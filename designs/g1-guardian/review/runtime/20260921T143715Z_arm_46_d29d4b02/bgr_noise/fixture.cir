* BGR standalone C-PEX AC noise/PSRR pilot
.lib /foss/pdks/ihp-sg13g2/libs.tech/ngspice/models/cornerHBT.lib hbt_typ
.lib /foss/pdks/ihp-sg13g2/libs.tech/ngspice/models/cornerMOShv.lib mos_tt
.lib /foss/pdks/ihp-sg13g2/libs.tech/ngspice/models/cornerRES.lib res_typ
.include /work/designs/g1-guardian/blocks/g1_bgr/sim/qualification/runs/bgr_noise_20260921_01/pex.spice
.option gmin=1e-15 abstol=1e-14 reltol=1e-5 vntol=1e-7
.temp 27
.global sub!
Vsub sub! 0 0
Vdd vdd 0 dc 3.3 ac 1
Vr4 r4 0 0
Xbgr vdd 0 r4 vref iptat pbias pcasc vbe dvbe g1_bgr
Vload iptat 0 1
Cload vref 0 1p
.control
set num_threads=1
set numdgt=15
set wr_singlescale
set wr_vecnames
ac dec 50 .1 100Meg
let rejection = -db(v(vref))
wrdata /work/designs/g1-guardian/review/runtime/20260921T143715Z_arm_46_d29d4b02/bgr_noise/psrr.dat rejection
noise v(vref) Vdd dec 50 1 10Meg
setplot noise1
wrdata /work/designs/g1-guardian/review/runtime/20260921T143715Z_arm_46_d29d4b02/bgr_noise/noise.dat onoise_spectrum
setplot noise2
print onoise_total
quit
.endc
.end
