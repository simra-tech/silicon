* no_fill floating drive P; diagnostic capacitor-network AC only
C6 0 N 1.3032200000000001e-17
C7 0 P 1.8661900000000002e-19
C17 0 N 8.5681900000000009e-17
C18 0 P 6.3260600000000007e-17
C27 0 N 1.7918500000000002e-17
C28 0 P 2.1505600000000004e-17
C36 0 N 2.6524600000000001e-17
C37 0 P 8.8934599999999992e-18
C44 0 N 3.4632700000000002e-17
C45 0 P 1.5622000000000002e-17
C51 0 N 2.4507700000000003e-16
C52 0 P 1.0517e-16
C61 0 P 3.4877500000000003e-15
C63 0 N 9.7328200000000006e-18
C64 0 P 5.1580900000000003e-17
C66 N P 3.4877500000000003e-15
C67 N 0 4.7941100000000005e-16
C68 P 0 5.8666800000000009e-17
VP P 0 DC 0 AC 1
VN N 0 DC 0 AC 0
.control
set numdgt=17
ac lin 1 1Meg 1Meg
let cp = -imag(i(VP))/(2*pi*1e6)
let cn = -imag(i(VN))/(2*pi*1e6)
print cp cn
quit
.endc
.end
