* actual_fill floating drive P; diagnostic capacitor-network AC only
C6 0 FILL_L10_0 1.6003300000000002e-17
C7 0 FILL_L10_1 4.1808200000000004e-18
C8 0 FILL_L10_2 1.50602e-18
C9 0 FILL_L10_3 4.8077900000000005e-17
C10 0 FILL_L10_6 1.62764e-18
C11 0 FILL_L30_1 9.6104300000000013e-19
C12 0 FILL_L50_2 1.8283200000000001e-17
C13 0 FILL_L50_5 1.3386500000000001e-19
C14 0 FILL_L8_1 1.41394e-17
C15 0 FILL_L8_14 7.3171200000000004e-18
C16 0 FILL_L8_7 2.39126e-18
C17 0 FILL_L8_8 1.3284800000000002e-17
C18 0 N 1.1482100000000001e-17
C28 0 FILL_L10_1 6.9259800000000005e-18
C29 0 FILL_L10_10 8.7633899999999994e-18
C30 0 FILL_L10_2 7.2077900000000013e-18
C31 0 FILL_L10_3 1.1993300000000001e-17
C32 0 FILL_L10_4 2.7254500000000002e-17
C33 0 FILL_L10_5 1.2171400000000001e-17
C34 0 FILL_L10_6 4.3057200000000002e-17
C35 0 FILL_L10_7 1.2171400000000001e-17
C36 0 FILL_L10_8 1.2171400000000001e-17
C37 0 FILL_L10_9 1.04775e-17
C38 0 FILL_L30_1 7.2251200000000012e-18
C39 0 FILL_L30_2 3.6203200000000002e-18
C40 0 FILL_L30_3 5.6661200000000011e-17
C41 0 FILL_L30_4 3.6203200000000002e-18
C42 0 FILL_L30_5 4.2144700000000003e-17
C43 0 FILL_L30_6 4.1447000000000008e-18
C44 0 FILL_L30_7 4.1447000000000008e-18
C45 0 FILL_L50_0 4.5539299999999999e-17
C46 0 FILL_L50_1 2.4925100000000002e-18
C47 0 FILL_L50_2 3.3652600000000002e-17
C48 0 FILL_L50_3 2.2072600000000005e-18
C49 0 FILL_L50_4 2.29717e-18
C50 0 FILL_L50_5 1.1266e-18
C51 0 FILL_L8_11 2.6021200000000004e-18
C52 0 FILL_L8_12 1.2662800000000002e-17
C53 0 FILL_L8_14 6.0846999999999999e-19
C54 0 FILL_L8_15 1.2662800000000002e-17
C55 0 FILL_L8_17 2.6021200000000004e-18
C56 0 FILL_L8_18 1.2662800000000002e-17
C57 0 FILL_L8_21 4.5986900000000007e-19
C58 0 FILL_L8_22 9.1172400000000016e-18
C59 0 FILL_L8_5 2.09868e-18
C60 0 FILL_L8_6 1.3329800000000001e-17
C61 0 FILL_L8_7 3.3517600000000001e-17
C62 0 FILL_L8_8 3.0903400000000005e-17
C63 0 FILL_L8_9 1.2662800000000002e-17
C64 0 N 7.977460000000001e-17
C65 0 P 6.320020000000001e-17
C74 0 FILL_L10_2 2.4371200000000005e-17
C75 0 FILL_L10_3 1.2913300000000002e-18
C76 0 FILL_L10_4 1.9248800000000002e-18
C77 0 FILL_L10_5 2.9801500000000003e-18
C78 0 FILL_L10_7 4.0354099999999999e-18
C79 0 FILL_L10_8 3.0265499999999999e-18
C80 0 FILL_L30_0 2.9005100000000003e-17
C81 0 FILL_L30_2 3.9748500000000004e-17
C82 0 FILL_L30_3 9.0497100000000002e-18
C83 0 FILL_L30_4 2.9252099999999999e-17
C84 0 FILL_L30_5 9.0497100000000002e-18
C85 0 FILL_L30_6 2.9252099999999999e-17
C86 0 FILL_L30_7 2.4652700000000001e-17
C87 0 FILL_L50_0 3.5191800000000003e-18
C88 0 FILL_L50_1 3.57277e-18
C89 0 FILL_L50_2 3.8137700000000005e-18
C90 0 FILL_L50_3 3.57277e-18
C91 0 FILL_L50_4 3.57277e-18
C92 0 FILL_L50_5 4.10082e-18
C93 0 FILL_L50_6 3.57277e-18
C94 0 FILL_L50_7 1.7633499999999999e-18
C95 0 FILL_L8_11 1.2804000000000001e-17
C96 0 FILL_L8_12 8.0615000000000014e-18
C97 0 FILL_L8_15 8.718710000000001e-18
C98 0 FILL_L8_17 1.1998100000000002e-17
C99 0 FILL_L8_18 8.718710000000001e-18
C100 0 FILL_L8_2 6.1610500000000008e-18
C101 0 FILL_L8_21 2.56139e-18
C102 0 FILL_L8_22 5.8894900000000004e-18
C103 0 FILL_L8_3 1.2211200000000001e-18
C104 0 FILL_L8_4 9.2023499999999994e-18
C105 0 FILL_L8_5 1.8460100000000002e-17
C106 0 FILL_L8_6 9.128890000000001e-18
C107 0 FILL_L8_7 3.0688600000000002e-18
C108 0 FILL_L8_9 7.6616700000000006e-18
C109 0 N 1.78462e-17
C110 0 P 2.1419300000000001e-17
C118 0 FILL_L10_0 2.77025e-18
C119 0 FILL_L10_1 3.0418100000000002e-19
C120 0 FILL_L10_2 4.0332800000000002e-17
C121 0 FILL_L10_3 7.7633999999999998e-18
C122 0 FILL_L30_0 9.86765e-18
C123 0 FILL_L30_1 1.29949e-17
C124 0 FILL_L30_2 1.0667400000000002e-18
C125 0 FILL_L50_0 3.7980999999999998e-18
C126 0 FILL_L50_2 1.5093900000000001e-18
C127 0 FILL_L8_1 1.0651300000000001e-19
C128 0 FILL_L8_2 5.0061500000000001e-18
C129 0 FILL_L8_3 5.9339600000000008e-19
C130 0 FILL_L8_4 1.4771399999999999e-18
C131 0 FILL_L8_5 3.1352400000000002e-18
C132 0 FILL_L8_7 6.25768e-19
C133 0 N 2.6504500000000003e-17
C134 0 P 8.8532500000000002e-18
C141 0 FILL_L10_2 7.4778400000000009e-18
C142 0 FILL_L10_3 1.4536500000000002e-18
C143 0 FILL_L10_4 4.0147200000000002e-18
C144 0 FILL_L10_5 3.2467400000000003e-18
C145 0 FILL_L10_6 1.13006e-17
C146 0 FILL_L10_7 3.73597e-18
C147 0 FILL_L10_9 1.5101000000000002e-18
C148 0 FILL_L30_3 6.4239100000000007e-18
C149 0 FILL_L30_5 3.7378500000000005e-18
C150 0 FILL_L50_0 1.13277e-17
C151 0 FILL_L50_1 7.713040000000001e-18
C152 0 FILL_L50_2 5.7658499999999996e-17
C153 0 FILL_L50_3 4.4985300000000004e-18
C154 0 FILL_L50_4 3.3782000000000003e-18
C155 0 FILL_L50_5 3.4008500000000002e-17
C156 0 FILL_L8_10 4.2162899999999998e-19
C157 0 FILL_L8_11 5.3156900000000004e-18
C158 0 FILL_L8_12 1.41815e-18
C159 0 FILL_L8_15 1.2598800000000003e-18
C160 0 FILL_L8_17 2.85968e-18
C161 0 FILL_L8_2 4.7880800000000005e-19
C162 0 FILL_L8_4 1.49895e-18
C163 0 FILL_L8_5 5.4996200000000006e-18
C164 0 FILL_L8_6 2.6189800000000002e-18
C165 0 FILL_L8_7 4.444600000000001e-18
C166 0 FILL_L8_8 6.4670000000000009e-19
C167 0 FILL_L8_9 1.6857100000000001e-18
C168 0 N 2.3292500000000001e-17
C169 0 P 1.5571700000000002e-17
C175 0 FILL_L10_0 2.7139900000000002e-18
C176 0 FILL_L10_1 5.3959300000000002e-17
C177 0 FILL_L10_10 1.1913500000000001e-16
C178 0 FILL_L10_11 1.1408400000000002e-16
C179 0 FILL_L10_2 6.7106400000000001e-18
C180 0 FILL_L10_3 2.1112100000000003e-17
C181 0 FILL_L10_4 1.03501e-17
C182 0 FILL_L10_5 1.0924400000000002e-17
C183 0 FILL_L10_6 4.2393200000000005e-16
C184 0 FILL_L10_7 1.3189700000000002e-17
C185 0 FILL_L10_8 9.3450700000000005e-17
C186 0 FILL_L10_9 5.2963700000000001e-16
C187 0 FILL_L30_1 8.0943100000000014e-18
C188 0 FILL_L30_3 8.0943100000000014e-18
C189 0 FILL_L30_5 8.0943100000000014e-18
C190 0 FILL_L30_6 4.9221399999999999e-18
C191 0 FILL_L30_7 1.27509e-17
C192 0 FILL_L50_0 5.7197199999999999e-18
C193 0 FILL_L50_1 6.0366000000000007e-18
C194 0 FILL_L50_2 5.1638699999999994e-16
C195 0 FILL_L50_3 6.6584200000000002e-18
C196 0 FILL_L50_4 1.77229e-17
C197 0 FILL_L50_5 5.00193e-16
C198 0 FILL_L50_6 1.8001200000000002e-16
C199 0 FILL_L50_7 3.9329899999999998e-16
C200 0 FILL_L8_1 1.3525200000000001e-17
C201 0 FILL_L8_10 1.3254600000000003e-18
C202 0 FILL_L8_12 5.4394100000000006e-19
C203 0 FILL_L8_13 1.3254600000000003e-18
C204 0 FILL_L8_14 2.0897800000000003e-17
C205 0 FILL_L8_15 1.0878799999999999e-18
C206 0 FILL_L8_16 1.3254600000000003e-18
C207 0 FILL_L8_17 1.9670900000000002e-19
C208 0 FILL_L8_18 2.7376700000000001e-18
C209 0 FILL_L8_19 1.3091700000000001e-17
C210 0 FILL_L8_20 3.5555600000000002e-17
C211 0 FILL_L8_21 5.6652100000000008e-19
C212 0 FILL_L8_22 5.5346700000000003e-18
C213 0 FILL_L8_23 1.9704599999999999e-17
C214 0 FILL_L8_24 1.8554600000000001e-17
C215 0 FILL_L8_4 1.0661200000000001e-18
C216 0 FILL_L8_6 9.7909400000000009e-19
C217 0 FILL_L8_7 9.4237000000000002e-18
C218 0 FILL_L8_8 3.9126200000000001e-17
C219 0 N 2.0079e-16
C220 0 P 1.0501600000000001e-16
C224 0 FILL_L10_2 8.8244600000000015e-17
C225 0 FILL_L30_0 2.2944299999999999e-17
C226 0 FILL_L30_1 7.5934400000000005e-18
C227 0 FILL_L30_2 2.2944299999999999e-17
C228 0 FILL_L30_3 7.5934400000000005e-18
C229 0 FILL_L30_4 2.2944299999999999e-17
C230 0 FILL_L30_5 7.5934400000000005e-18
C231 0 FILL_L30_6 2.2944299999999999e-17
C232 0 FILL_L30_7 2.2944299999999999e-17
C233 0 FILL_L8_11 7.544170000000001e-18
C234 0 FILL_L8_12 1.0723699999999999e-17
C235 0 FILL_L8_15 1.0723699999999999e-17
C236 0 FILL_L8_17 7.544170000000001e-18
C237 0 FILL_L8_18 1.0723699999999999e-17
C238 0 FILL_L8_2 5.3354900000000001e-18
C239 0 FILL_L8_21 1.4123400000000001e-18
C240 0 FILL_L8_22 7.3447100000000004e-18
C241 0 FILL_L8_3 8.5533600000000003e-19
C242 0 FILL_L8_4 1.0670700000000001e-17
C243 0 FILL_L8_5 7.2727100000000011e-18
C244 0 FILL_L8_6 1.07105e-17
C245 0 FILL_L8_9 1.0723699999999999e-17
C249 0 FILL_L10_10 3.3018800000000002e-19
C250 0 FILL_L10_2 7.4570500000000005e-17
C251 0 FILL_L10_4 2.05699e-19
C252 0 FILL_L10_5 4.3499600000000002e-19
C253 0 FILL_L10_6 3.6860100000000005e-19
C254 0 FILL_L10_7 6.6429300000000005e-19
C255 0 FILL_L10_8 6.1286800000000005e-19
C256 0 FILL_L10_9 3.6860100000000005e-19
C257 0 FILL_L30_1 4.7123800000000008e-17
C258 0 FILL_L30_3 4.9816300000000002e-17
C259 0 FILL_L30_5 5.0478200000000006e-17
C260 0 FILL_L30_6 4.3280300000000005e-19
C261 0 FILL_L30_7 3.0866700000000007e-19
C262 0 FILL_L8_11 3.5410700000000001e-19
C263 0 FILL_L8_12 2.24132e-18
C264 0 FILL_L8_15 2.4729900000000001e-18
C265 0 FILL_L8_17 3.5410700000000001e-19
C266 0 FILL_L8_18 2.3571599999999999e-18
C267 0 FILL_L8_22 1.6821200000000001e-18
C268 0 FILL_L8_4 2.4637200000000001e-18
C269 0 FILL_L8_5 1.4164300000000001e-19
C270 0 FILL_L8_6 2.41661e-18
C271 0 FILL_L8_9 2.1463600000000003e-18
C274 0 FILL_L10_2 2.4102000000000003e-17
C275 0 FILL_L10_3 1.13462e-19
C276 0 FILL_L10_4 8.2868400000000008e-19
C277 0 FILL_L10_5 8.2868400000000008e-19
C278 0 FILL_L10_6 4.3530200000000009e-19
C279 0 FILL_L10_7 8.2868400000000008e-19
C280 0 FILL_L10_8 6.2151300000000003e-19
C281 0 FILL_L10_9 4.3530200000000009e-19
C282 0 FILL_L30_1 5.3937200000000003e-18
C283 0 FILL_L30_3 5.3937200000000003e-18
C284 0 FILL_L30_5 5.3937200000000003e-18
C285 0 FILL_L30_6 3.2539100000000003e-19
C286 0 FILL_L8_11 3.11189e-19
C287 0 FILL_L8_12 4.1125300000000001e-19
C288 0 FILL_L8_15 4.1125300000000001e-19
C289 0 FILL_L8_17 3.11189e-19
C290 0 FILL_L8_18 3.0843900000000006e-19
C291 0 FILL_L8_4 4.0302700000000005e-19
C292 0 FILL_L8_5 1.2447600000000001e-19
C293 0 FILL_L8_6 3.7012700000000002e-19
C294 0 FILL_L8_9 4.1125300000000001e-19
C295 0 P 3.4877500000000003e-15
C297 0 FILL_L10_0 1.3439500000000001e-18
C298 0 FILL_L10_10 1.43041e-18
C299 0 FILL_L10_2 8.8192900000000005e-17
C300 0 FILL_L10_3 5.0439100000000011e-18
C301 0 FILL_L10_4 1.9866800000000001e-18
C302 0 FILL_L10_5 1.9866800000000001e-18
C303 0 FILL_L10_6 5.4746200000000004e-19
C304 0 FILL_L10_7 1.9866800000000001e-18
C305 0 FILL_L10_8 1.9866800000000001e-18
C306 0 FILL_L10_9 5.4746200000000004e-19
C307 0 FILL_L30_0 1.2871200000000001e-18
C308 0 FILL_L30_1 2.9479500000000002e-18
C309 0 FILL_L30_3 7.2167900000000003e-18
C310 0 FILL_L30_4 6.4355799999999998e-19
C311 0 FILL_L30_5 7.2167900000000003e-18
C312 0 FILL_L30_6 2.1042000000000003e-18
C313 0 FILL_L30_7 1.2871200000000001e-18
C314 0 FILL_L50_0 1.3044500000000002e-18
C315 0 FILL_L50_1 1.3361100000000001e-18
C316 0 FILL_L50_2 1.9062300000000003e-18
C317 0 FILL_L50_3 1.94085e-18
C318 0 FILL_L50_4 2.5455800000000003e-18
C319 0 FILL_L50_5 1.68197e-18
C320 0 FILL_L8_0 3.0213300000000002e-18
C321 0 FILL_L8_10 1.9641100000000003e-17
C322 0 FILL_L8_11 8.348340000000001e-18
C323 0 FILL_L8_12 1.0790500000000001e-17
C324 0 FILL_L8_13 1.9641100000000003e-17
C325 0 FILL_L8_14 1.0876200000000002e-17
C326 0 FILL_L8_15 1.0790500000000001e-17
C327 0 FILL_L8_16 1.9641100000000003e-17
C328 0 FILL_L8_17 8.348340000000001e-18
C329 0 FILL_L8_18 1.0790500000000001e-17
C330 0 FILL_L8_19 1.9641100000000003e-17
C331 0 FILL_L8_2 8.348340000000001e-18
C332 0 FILL_L8_20 1.0876200000000002e-17
C333 0 FILL_L8_22 7.7691300000000005e-18
C334 0 FILL_L8_23 1.4141600000000002e-17
C335 0 FILL_L8_3 1.0790500000000001e-17
C336 0 FILL_L8_4 1.0790500000000001e-17
C337 0 FILL_L8_5 8.348340000000001e-18
C338 0 FILL_L8_6 1.0790500000000001e-17
C339 0 FILL_L8_7 1.9641100000000003e-17
C340 0 FILL_L8_9 1.0790500000000001e-17
C341 0 N 9.7090599999999997e-18
C342 0 P 5.0994500000000007e-17
C344 FILL_L10_0 FILL_L10_1 7.8218700000000007e-18
C345 FILL_L10_0 FILL_L10_2 5.8335900000000006e-18
C346 FILL_L10_0 FILL_L10_3 2.7935199999999999e-17
C347 FILL_L10_0 FILL_L50_0 1.9872000000000001e-19
C348 FILL_L10_0 N 2.7399200000000002e-18
C349 FILL_L10_0 P 2.4729300000000002e-19
C350 FILL_L10_0 0 5.8495200000000003e-17
C351 FILL_L10_1 FILL_L8_1 1.8823000000000002e-17
C352 FILL_L10_1 0 7.9416900000000008e-17
C353 FILL_L10_10 FILL_L10_11 2.01134e-17
C354 FILL_L10_10 FILL_L10_8 2.7935199999999999e-17
C355 FILL_L10_10 FILL_L8_23 4.8402000000000005e-17
C356 FILL_L10_10 0 7.5500600000000009e-17
C357 FILL_L10_11 FILL_L10_9 2.7935199999999999e-17
C358 FILL_L10_11 FILL_L8_24 4.8402000000000005e-17
C359 FILL_L10_11 0 8.3961100000000012e-17
C360 FILL_L10_2 FILL_L10_3 2.08343e-17
C361 FILL_L10_2 FILL_L30_0 6.3965400000000009e-17
C362 FILL_L10_2 FILL_L30_1 1.7705600000000002e-16
C363 FILL_L10_2 FILL_L30_3 2.8437100000000001e-19
C364 FILL_L10_2 FILL_L8_0 4.9711900000000001e-17
C365 FILL_L10_2 FILL_L8_2 1.69062e-17
C366 FILL_L10_2 FILL_L8_3 1.1751300000000001e-16
C367 FILL_L10_2 FILL_L8_4 5.7366599999999999e-18
C368 FILL_L10_2 FILL_L8_6 1.1639200000000001e-18
C369 FILL_L10_2 FILL_L8_9 3.4886800000000005e-19
C370 FILL_L10_2 N 3.6895200000000005e-18
C371 FILL_L10_2 P 4.1698500000000002e-18
C372 FILL_L10_2 0 5.3966800000000002e-16
C373 FILL_L10_3 FILL_L50_0 1.4663200000000001e-18
C374 FILL_L10_3 FILL_L8_7 6.23543e-19
C375 FILL_L10_3 N 9.9396600000000006e-18
C376 FILL_L10_3 P 1.00978e-18
C377 FILL_L10_3 0 9.8350300000000006e-17
C378 FILL_L10_4 FILL_L10_5 2.7935199999999999e-17
C379 FILL_L10_4 FILL_L10_6 2.7935199999999999e-17
C380 FILL_L10_4 FILL_L30_3 4.5165800000000008e-18
C381 FILL_L10_4 FILL_L50_0 1.3501300000000002e-18
C382 FILL_L10_4 FILL_L50_1 2.1761200000000001e-17
C383 FILL_L10_4 FILL_L50_2 3.8908000000000001e-18
C384 FILL_L10_4 FILL_L8_10 6.7224999999999998e-17
C385 FILL_L10_4 FILL_L8_7 5.7366599999999999e-18
C386 FILL_L10_4 N 1.2552200000000001e-18
C387 FILL_L10_4 P 1.03039e-18
C388 FILL_L10_4 0 6.64322e-17
C389 FILL_L10_5 FILL_L10_6 2.7935199999999999e-17
C390 FILL_L10_5 FILL_L10_7 2.7935199999999999e-17
C391 FILL_L10_5 FILL_L30_5 2.2582900000000004e-18
C392 FILL_L10_5 FILL_L50_1 1.9454000000000001e-18
C393 FILL_L10_5 FILL_L50_3 1.5980700000000003e-17
C394 FILL_L10_5 FILL_L50_5 1.9454000000000001e-18
C395 FILL_L10_5 FILL_L8_13 6.7224999999999998e-17
C396 FILL_L10_5 N 5.6099900000000005e-18
C397 FILL_L10_5 P 1.03039e-18
C398 FILL_L10_5 0 6.5096500000000014e-17
C399 FILL_L10_6 FILL_L10_9 6.0340100000000005e-17
C400 FILL_L10_6 FILL_L50_2 7.4752900000000002e-17
C401 FILL_L10_6 FILL_L50_5 5.3771200000000002e-17
C402 FILL_L10_6 FILL_L8_14 5.0822100000000002e-16
C403 FILL_L10_6 FILL_L8_8 5.7366599999999999e-18
C404 FILL_L10_6 N 5.7365300000000002e-18
C405 FILL_L10_6 P 5.1998600000000002e-19
C406 FILL_L10_6 0 2.6757900000000003e-16
C407 FILL_L10_7 FILL_L10_8 2.7935199999999999e-17
C408 FILL_L10_7 FILL_L10_9 2.7935199999999999e-17
C409 FILL_L10_7 FILL_L50_3 5.8352700000000008e-18
C410 FILL_L10_7 FILL_L50_4 9.7220300000000003e-18
C411 FILL_L10_7 FILL_L50_5 6.9848699999999997e-18
C412 FILL_L10_7 FILL_L8_16 6.7224999999999998e-17
C413 FILL_L10_7 N 9.9647600000000006e-18
C414 FILL_L10_7 P 1.03039e-18
C415 FILL_L10_7 0 6.5096500000000014e-17
C416 FILL_L10_8 FILL_L10_9 2.7935199999999999e-17
C417 FILL_L10_8 FILL_L50_4 7.3671699999999996e-18
C418 FILL_L10_8 FILL_L50_6 3.7899000000000001e-18
C419 FILL_L10_8 FILL_L8_19 6.7224999999999998e-17
C420 FILL_L10_8 N 7.4735700000000008e-18
C421 FILL_L10_8 P 7.727910000000001e-19
C422 FILL_L10_8 0 6.5096500000000014e-17
C423 FILL_L10_9 FILL_L50_4 3.4144000000000005e-18
C424 FILL_L10_9 FILL_L50_5 8.9684900000000003e-17
C425 FILL_L10_9 FILL_L50_7 1.4453000000000002e-17
C426 FILL_L10_9 FILL_L8_20 5.0822100000000002e-16
C427 FILL_L10_9 N 3.8211000000000004e-18
C428 FILL_L10_9 P 5.1998600000000002e-19
C429 FILL_L10_9 0 2.8104000000000003e-16
C430 FILL_L30_0 FILL_L30_1 1.92731e-17
C431 FILL_L30_0 FILL_L30_2 4.7365199999999997e-18
C432 FILL_L30_0 FILL_L8_2 9.0924700000000007e-18
C433 FILL_L30_0 0 1.0377100000000001e-16
C434 FILL_L30_1 N 1.6070500000000002e-18
C435 FILL_L30_1 P 2.8873199999999999e-18
C436 FILL_L30_1 0 6.3383300000000004e-17
C437 FILL_L30_2 FILL_L30_3 1.92731e-17
C438 FILL_L30_2 FILL_L30_4 1.92731e-17
C439 FILL_L30_2 FILL_L8_11 9.0924700000000007e-18
C440 FILL_L30_2 FILL_L8_9 1.8017499999999998e-17
C441 FILL_L30_2 0 9.0804300000000006e-17
C442 FILL_L30_3 FILL_L30_5 1.92731e-17
C443 FILL_L30_3 FILL_L50_1 3.0598200000000003e-18
C444 FILL_L30_3 FILL_L8_9 1.2532900000000001e-17
C445 FILL_L30_3 N 1.6070500000000002e-18
C446 FILL_L30_3 P 2.8873199999999999e-18
C447 FILL_L30_3 0 6.056360000000001e-17
C448 FILL_L30_4 FILL_L30_5 1.92731e-17
C449 FILL_L30_4 FILL_L30_6 1.92731e-17
C450 FILL_L30_4 FILL_L8_11 4.5462400000000002e-18
C451 FILL_L30_4 FILL_L8_12 9.0087300000000012e-18
C452 FILL_L30_4 0 7.6840900000000005e-17
C453 FILL_L30_5 FILL_L50_3 3.0598200000000003e-18
C454 FILL_L30_5 FILL_L8_12 6.2664400000000005e-18
C455 FILL_L30_5 N 1.6070500000000002e-18
C456 FILL_L30_5 P 2.8873199999999999e-18
C457 FILL_L30_5 0 8.0173100000000013e-17
C458 FILL_L30_6 FILL_L30_7 1.92731e-17
C459 FILL_L30_6 FILL_L50_4 6.5896400000000007e-19
C460 FILL_L30_6 FILL_L8_17 9.0924700000000007e-18
C461 FILL_L30_6 N 2.0235000000000002e-19
C462 FILL_L30_6 P 2.5314100000000004e-19
C463 FILL_L30_6 0 9.5594899999999997e-17
C464 FILL_L30_7 0 1.0438000000000001e-16
C465 FILL_L50_0 FILL_L50_1 2.4713600000000001e-17
C466 FILL_L50_0 FILL_L50_2 2.4713600000000001e-17
C467 FILL_L50_0 FILL_L8_7 8.4865800000000013e-18
C468 FILL_L50_0 N 9.8265900000000003e-17
C469 FILL_L50_0 0 4.6638200000000002e-17
C470 FILL_L50_1 FILL_L50_2 2.4713600000000001e-17
C471 FILL_L50_1 FILL_L50_3 2.4713600000000001e-17
C472 FILL_L50_1 FILL_L8_10 1.49568e-18
C473 FILL_L50_1 FILL_L8_7 1.5756800000000002e-18
C474 FILL_L50_1 N 9.8265900000000003e-17
C475 FILL_L50_1 0 3.1747900000000007e-17
C476 FILL_L50_2 FILL_L50_5 5.3381300000000004e-17
C477 FILL_L50_2 FILL_L8_14 8.6179700000000007e-18
C478 FILL_L50_2 FILL_L8_7 4.5357300000000004e-18
C479 FILL_L50_2 FILL_L8_8 5.2012900000000005e-18
C480 FILL_L50_2 N 2.8268299999999999e-17
C481 FILL_L50_2 0 1.9950100000000003e-16
C482 FILL_L50_3 FILL_L50_4 2.4713600000000001e-17
C483 FILL_L50_3 FILL_L50_5 2.4713600000000001e-17
C484 FILL_L50_3 FILL_L8_13 1.49568e-18
C485 FILL_L50_3 FILL_L8_16 6.7038200000000004e-19
C486 FILL_L50_3 N 9.8265900000000003e-17
C487 FILL_L50_3 0 3.3928600000000003e-17
C488 FILL_L50_4 FILL_L50_5 2.4713600000000001e-17
C489 FILL_L50_4 FILL_L50_6 2.4713600000000001e-17
C490 FILL_L50_4 FILL_L8_16 1.4679600000000001e-18
C491 FILL_L50_4 FILL_L8_19 1.3905000000000002e-18
C492 FILL_L50_4 FILL_L8_20 2.0268800000000001e-18
C493 FILL_L50_4 N 9.8265900000000003e-17
C494 FILL_L50_4 0 3.2987099999999999e-17
C495 FILL_L50_5 FILL_L50_7 5.3381300000000004e-17
C496 FILL_L50_5 FILL_L8_14 5.388620000000001e-18
C497 FILL_L50_5 FILL_L8_20 5.388620000000001e-18
C498 FILL_L50_5 N 2.8268299999999999e-17
C499 FILL_L50_5 0 1.75393e-16
C500 FILL_L50_6 FILL_L50_7 2.4713600000000001e-17
C501 FILL_L50_6 N 9.8265900000000003e-17
C502 FILL_L50_6 0 2.9623000000000003e-17
C503 FILL_L50_7 N 1.0176600000000002e-17
C504 FILL_L50_7 0 1.1284200000000001e-16
C505 FILL_L8_0 FILL_L8_2 5.5757500000000005e-18
C506 FILL_L8_0 FILL_L8_3 1.9913400000000001e-17
C507 FILL_L8_0 0 8.7472099999999998e-17
C508 FILL_L8_1 0 1.0160400000000001e-16
C509 FILL_L8_10 FILL_L8_13 1.9913400000000001e-17
C510 FILL_L8_10 FILL_L8_14 1.9913400000000001e-17
C511 FILL_L8_10 FILL_L8_7 1.9913400000000001e-17
C512 FILL_L8_10 N 5.5014100000000008e-19
C513 FILL_L8_10 P 1.0245300000000001e-19
C514 FILL_L8_10 0 1.2719700000000002e-16
C515 FILL_L8_11 FILL_L8_12 1.9913400000000001e-17
C516 FILL_L8_11 FILL_L8_17 6.7705500000000005e-18
C517 FILL_L8_11 FILL_L8_5 6.7705500000000005e-18
C518 FILL_L8_11 FILL_L8_9 1.9913400000000001e-17
C519 FILL_L8_11 0 2.9737900000000004e-16
C520 FILL_L8_12 FILL_L8_15 1.9913400000000001e-17
C521 FILL_L8_12 FILL_L8_9 1.9913400000000001e-17
C522 FILL_L8_12 0 1.34885e-16
C523 FILL_L8_13 FILL_L8_14 1.9913400000000001e-17
C524 FILL_L8_13 FILL_L8_16 1.9913400000000001e-17
C525 FILL_L8_13 N 5.5014100000000008e-19
C526 FILL_L8_13 0 1.2719700000000002e-16
C527 FILL_L8_14 FILL_L8_20 4.3012900000000003e-17
C528 FILL_L8_14 FILL_L8_8 1.9913400000000001e-17
C529 FILL_L8_14 N 4.4929300000000004e-19
C530 FILL_L8_14 0 6.1632700000000005e-16
C531 FILL_L8_15 FILL_L8_17 1.9913400000000001e-17
C532 FILL_L8_15 FILL_L8_18 1.9913400000000001e-17
C533 FILL_L8_15 0 1.34885e-16
C534 FILL_L8_16 FILL_L8_19 1.9913400000000001e-17
C535 FILL_L8_16 FILL_L8_20 1.9913400000000001e-17
C536 FILL_L8_16 N 5.5014100000000008e-19
C537 FILL_L8_16 P 1.0245300000000001e-19
C538 FILL_L8_16 0 1.2719700000000002e-16
C539 FILL_L8_17 FILL_L8_18 1.9913400000000001e-17
C540 FILL_L8_17 FILL_L8_21 6.7705500000000005e-18
C541 FILL_L8_17 0 2.9737900000000004e-16
C542 FILL_L8_18 FILL_L8_22 1.9913400000000001e-17
C543 FILL_L8_18 0 1.34885e-16
C544 FILL_L8_19 FILL_L8_20 1.9913400000000001e-17
C545 FILL_L8_19 FILL_L8_23 1.9913400000000001e-17
C546 FILL_L8_19 N 4.1260599999999998e-19
C547 FILL_L8_19 0 1.2719700000000002e-16
C548 FILL_L8_2 FILL_L8_3 1.9913400000000001e-17
C549 FILL_L8_2 FILL_L8_5 6.7705500000000005e-18
C550 FILL_L8_2 0 2.4938700000000004e-16
C551 FILL_L8_20 FILL_L8_24 1.9913400000000001e-17
C552 FILL_L8_20 N 4.4929300000000004e-19
C553 FILL_L8_20 0 6.2021800000000001e-16
C554 FILL_L8_21 FILL_L8_22 1.43376e-17
C555 FILL_L8_21 0 7.4910300000000013e-17
C556 FILL_L8_22 0 1.2658300000000001e-16
C557 FILL_L8_23 FILL_L8_24 1.43376e-17
C558 FILL_L8_23 0 1.21048e-16
C559 FILL_L8_24 0 1.3285499999999999e-16
C560 FILL_L8_3 FILL_L8_4 1.9913400000000001e-17
C561 FILL_L8_3 0 1.34885e-16
C562 FILL_L8_4 FILL_L8_5 1.9913400000000001e-17
C563 FILL_L8_4 FILL_L8_6 1.9913400000000001e-17
C564 FILL_L8_4 0 1.34885e-16
C565 FILL_L8_5 FILL_L8_6 1.9913400000000001e-17
C566 FILL_L8_5 0 2.9737900000000004e-16
C567 FILL_L8_6 FILL_L8_9 1.9913400000000001e-17
C568 FILL_L8_6 0 1.34885e-16
C569 FILL_L8_7 FILL_L8_8 1.9913400000000001e-17
C570 FILL_L8_7 N 3.8098600000000003e-18
C571 FILL_L8_7 0 1.4176599999999999e-16
C572 FILL_L8_8 0 1.4896900000000002e-16
C573 FILL_L8_9 0 1.34885e-16
C574 N P 3.4877500000000003e-15
C575 N 0 3.1974000000000004e-16
C576 P 0 5.8567300000000001e-17
VP P 0 DC 0 AC 1
VN N 0 DC 0 AC 0
.control
set numdgt=17
ac lin 1 1Meg 1Meg
let cp = -imag(i(VP))/(2*pi*1e6)
let cn = -imag(i(VN))/(2*pi*1e6)
print cp cn
quit
.endc
.end
