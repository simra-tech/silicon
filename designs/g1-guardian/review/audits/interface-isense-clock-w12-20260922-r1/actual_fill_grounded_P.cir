* actual_fill grounded drive P; diagnostic capacitor-network AC only
C18 0 N 1.1482100000000001e-17
C64 0 N 7.977460000000001e-17
C65 0 P 6.320020000000001e-17
C109 0 N 1.78462e-17
C110 0 P 2.1419300000000001e-17
C133 0 N 2.6504500000000003e-17
C134 0 P 8.8532500000000002e-18
C168 0 N 2.3292500000000001e-17
C169 0 P 1.5571700000000002e-17
C219 0 N 2.0079e-16
C220 0 P 1.0501600000000001e-16
C295 0 P 3.4877500000000003e-15
C341 0 N 9.7090599999999997e-18
C342 0 P 5.0994500000000007e-17
C348 0 N 2.7399200000000002e-18
C349 0 P 2.4729300000000002e-19
C370 0 N 3.6895200000000005e-18
C371 0 P 4.1698500000000002e-18
C375 0 N 9.9396600000000006e-18
C376 0 P 1.00978e-18
C386 0 N 1.2552200000000001e-18
C387 0 P 1.03039e-18
C396 0 N 5.6099900000000005e-18
C397 0 P 1.03039e-18
C404 0 N 5.7365300000000002e-18
C405 0 P 5.1998600000000002e-19
C413 0 N 9.9647600000000006e-18
C414 0 P 1.03039e-18
C420 0 N 7.4735700000000008e-18
C421 0 P 7.727910000000001e-19
C427 0 N 3.8211000000000004e-18
C428 0 P 5.1998600000000002e-19
C434 0 N 1.6070500000000002e-18
C435 0 P 2.8873199999999999e-18
C445 0 N 1.6070500000000002e-18
C446 0 P 2.8873199999999999e-18
C455 0 N 1.6070500000000002e-18
C456 0 P 2.8873199999999999e-18
C461 0 N 2.0235000000000002e-19
C462 0 P 2.5314100000000004e-19
C468 0 N 9.8265900000000003e-17
C474 0 N 9.8265900000000003e-17
C480 0 N 2.8268299999999999e-17
C486 0 N 9.8265900000000003e-17
C493 0 N 9.8265900000000003e-17
C498 0 N 2.8268299999999999e-17
C501 0 N 9.8265900000000003e-17
C503 0 N 1.0176600000000002e-17
C512 0 N 5.5014100000000008e-19
C513 0 P 1.0245300000000001e-19
C525 0 N 5.5014100000000008e-19
C529 0 N 4.4929300000000004e-19
C536 0 N 5.5014100000000008e-19
C537 0 P 1.0245300000000001e-19
C546 0 N 4.1260599999999998e-19
C552 0 N 4.4929300000000004e-19
C570 0 N 3.8098600000000003e-18
C574 N P 3.4877500000000003e-15
C575 N 0 3.1974000000000004e-16
C576 P 0 5.8567300000000001e-17
VP P 0 DC 0 AC 1
VN N 0 DC 0 AC 0
.control
set numdgt=17
ac lin 1 1Meg 1Meg
let cp = -imag(i(VP))/(2*pi*1e6)
let cn = -imag(i(VN))/(2*pi*1e6)
print cp cn
quit
.endc
.end
