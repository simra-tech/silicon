* Extracted by KLayout with SG13G2 LVS runset on : 21/09/2026 16:16

* cell sg13g2_IOPadAnalog
* pin iovdd
* pin iovdd
* pin iovss
* pin pad
* pin padres
* pin vss
.SUBCKT sg13g2_IOPadAnalog iovdd iovdd$1 iovss pad padres vss
* cell instance $1 r0 *1 52.15,140.17
X$1 \$1 iovss padres pad iovdd$1 sg13g2_SecondaryProtection
* cell instance $2 r0 *1 0,65
X$2 \$1 iovss iovdd pad pad pad pad pad pad pad pad pad pad sg13g2_Clamp_P20N0D
* cell instance $3 r0 *1 23.47,53.08
X$3 \$1 iovss iovdd pad pad sg13g2_DCPDiode
* cell instance $4 r0 *1 0,6
X$4 \$1 iovss pad pad pad pad pad pad pad pad pad pad sg13g2_Clamp_N20N0D
* cell instance $5 r0 *1 23.47,17.56
X$5 \$1 iovss pad pad sg13g2_DCNDiode
* device instance $1 r0 *1 40,112.215 ptap1
R$1 iovss \$1 ptap1 A=4273.4p P=593.62u
* device instance $2 r0 *1 40,157 ptap1
R$2 vss \$1 ptap1 A=23.85p P=159.6u
.ENDS sg13g2_IOPadAnalog

* cell sg13g2_SecondaryProtection
* pin
* pin minus
* pin core
* pin pad
* pin plus
.SUBCKT sg13g2_SecondaryProtection \$1 minus core pad plus
* device instance $1 r0 *1 5.48,2.37 dantenna
D$1 \$1 core dantenna A=1.984p P=7.48u m=1
* device instance $2 r0 *1 3.31,7.34 dpantenna
D$2 core plus dpantenna A=3.1872p P=11.24u m=1
* device instance $3 r0 *1 0.935,1.365 rppd
R$3 pad core \$1 rppd w=1u l=2u ps=0u b=0 m=1
* device instance $4 r0 *1 5.48,2.37 ptap1
R$4 minus \$1 ptap1 A=9.0304p P=53.12u
.ENDS sg13g2_SecondaryProtection

* cell sg13g2_DCPDiode
* pin
* pin guard
* pin cathode
* pin anode
* pin anode
.SUBCKT sg13g2_DCPDiode \$1 guard cathode anode anode$1
* device instance $1 r0 *1 16.53,7.38 dpantenna
D$1 anode$1 cathode dpantenna A=35.0028p P=58.08u m=1
* device instance $2 r0 *1 16.53,2.88 dpantenna
D$2 anode cathode dpantenna A=35.0028p P=58.08u m=1
* device instance $3 r0 *1 16.53,5.13 ptap1
R$3 guard \$1 ptap1 A=33.5104p P=197.12u
.ENDS sg13g2_DCPDiode

* cell sg13g2_DCNDiode
* pin
* pin anode
* pin cathode
* pin cathode
.SUBCKT sg13g2_DCNDiode \$2 anode cathode cathode$1
* device instance $1 r0 *1 16.53,7.38 dantenna
D$1 \$2 cathode$1 dantenna A=35.0028p P=58.08u m=1
* device instance $2 r0 *1 16.53,2.88 dantenna
D$2 \$2 cathode dantenna A=35.0028p P=58.08u m=1
* device instance $3 r0 *1 16.53,5.13 ptap1
R$3 anode \$2 ptap1 A=141.2964p P=221.76u
.ENDS sg13g2_DCNDiode

* cell sg13g2_Clamp_P20N0D
* pin
* pin iovss
* pin iovdd
* pin pad
* pin pad
* pin pad
* pin pad
* pin pad
* pin pad
* pin pad
* pin pad
* pin pad
* pin pad
.SUBCKT sg13g2_Clamp_P20N0D \$1 iovss iovdd pad pad$1 pad$2 pad$3 pad$4 pad$5
+ pad$6 pad$7 pad$8 pad$9
* device instance $1 r0 *1 25.52,13.18 sg13_hv_pmos
M$1 iovdd \$5 pad iovdd sg13_hv_pmos L=0.6u W=26.64u AS=14.1192p AD=12.1212p
+ PS=44.2u PD=30.28u rfmode=0
* device instance $3 r0 *1 28.54,13.18 sg13_hv_pmos
M$3 iovdd \$5 pad$1 iovdd sg13_hv_pmos L=0.6u W=26.64u AS=12.1212p AD=12.1212p
+ PS=30.28u PD=30.28u rfmode=0
* device instance $5 r0 *1 31.56,13.18 sg13_hv_pmos
M$5 iovdd \$5 pad$2 iovdd sg13_hv_pmos L=0.6u W=26.64u AS=12.1212p AD=12.1212p
+ PS=30.28u PD=30.28u rfmode=0
* device instance $7 r0 *1 34.58,13.18 sg13_hv_pmos
M$7 iovdd \$5 pad$3 iovdd sg13_hv_pmos L=0.6u W=26.64u AS=12.1212p AD=12.1212p
+ PS=30.28u PD=30.28u rfmode=0
* device instance $9 r0 *1 37.6,13.18 sg13_hv_pmos
M$9 iovdd \$5 pad$4 iovdd sg13_hv_pmos L=0.6u W=26.64u AS=12.1212p AD=12.1212p
+ PS=30.28u PD=30.28u rfmode=0
* device instance $11 r0 *1 40.62,13.18 sg13_hv_pmos
M$11 iovdd \$5 pad$5 iovdd sg13_hv_pmos L=0.6u W=26.64u AS=12.1212p AD=12.1212p
+ PS=30.28u PD=30.28u rfmode=0
* device instance $13 r0 *1 43.64,13.18 sg13_hv_pmos
M$13 iovdd \$5 pad$6 iovdd sg13_hv_pmos L=0.6u W=26.64u AS=12.1212p AD=12.1212p
+ PS=30.28u PD=30.28u rfmode=0
* device instance $15 r0 *1 46.66,13.18 sg13_hv_pmos
M$15 iovdd \$5 pad$7 iovdd sg13_hv_pmos L=0.6u W=26.64u AS=12.1212p AD=12.1212p
+ PS=30.28u PD=30.28u rfmode=0
* device instance $17 r0 *1 49.68,13.18 sg13_hv_pmos
M$17 iovdd \$5 pad$8 iovdd sg13_hv_pmos L=0.6u W=26.64u AS=12.1212p AD=12.1212p
+ PS=30.28u PD=30.28u rfmode=0
* device instance $19 r0 *1 52.7,13.18 sg13_hv_pmos
M$19 iovdd \$5 pad$9 iovdd sg13_hv_pmos L=0.6u W=26.64u AS=12.1212p AD=14.1192p
+ PS=30.28u PD=44.2u rfmode=0
* device instance $41 r0 *1 66.3,3.175 rppd
R$41 iovdd \$5 iovdd rppd w=0.5u l=12.9u ps=0u b=0 m=1
* device instance $42 r0 *1 40,9.63 ptap1
R$42 iovss \$1 ptap1 A=67.0344p P=394.32u
.ENDS sg13g2_Clamp_P20N0D

* cell sg13g2_Clamp_N20N0D
* pin
* pin iovss
* pin pad
* pin pad
* pin pad
* pin pad
* pin pad
* pin pad
* pin pad
* pin pad
* pin pad
* pin pad
.SUBCKT sg13g2_Clamp_N20N0D \$2 iovss pad pad$1 pad$2 pad$3 pad$4 pad$5 pad$6
+ pad$7 pad$8 pad$9
* device instance $1 r0 *1 25.52,4.95 sg13_hv_nmos
M$1 iovss \$4 pad \$2 sg13_hv_nmos L=0.6u W=8.8u AS=4.664p AD=4.004p PS=15.32u
+ PD=10.62u rfmode=0
* device instance $3 r0 *1 28.54,4.95 sg13_hv_nmos
M$3 iovss \$4 pad$1 \$2 sg13_hv_nmos L=0.6u W=8.8u AS=4.004p AD=4.004p
+ PS=10.62u PD=10.62u rfmode=0
* device instance $5 r0 *1 31.56,4.95 sg13_hv_nmos
M$5 iovss \$4 pad$2 \$2 sg13_hv_nmos L=0.6u W=8.8u AS=4.004p AD=4.004p
+ PS=10.62u PD=10.62u rfmode=0
* device instance $7 r0 *1 34.58,4.95 sg13_hv_nmos
M$7 iovss \$4 pad$3 \$2 sg13_hv_nmos L=0.6u W=8.8u AS=4.004p AD=4.004p
+ PS=10.62u PD=10.62u rfmode=0
* device instance $9 r0 *1 37.6,4.95 sg13_hv_nmos
M$9 iovss \$4 pad$4 \$2 sg13_hv_nmos L=0.6u W=8.8u AS=4.004p AD=4.004p
+ PS=10.62u PD=10.62u rfmode=0
* device instance $11 r0 *1 40.62,4.95 sg13_hv_nmos
M$11 iovss \$4 pad$5 \$2 sg13_hv_nmos L=0.6u W=8.8u AS=4.004p AD=4.004p
+ PS=10.62u PD=10.62u rfmode=0
* device instance $13 r0 *1 43.64,4.95 sg13_hv_nmos
M$13 iovss \$4 pad$6 \$2 sg13_hv_nmos L=0.6u W=8.8u AS=4.004p AD=4.004p
+ PS=10.62u PD=10.62u rfmode=0
* device instance $15 r0 *1 46.66,4.95 sg13_hv_nmos
M$15 iovss \$4 pad$7 \$2 sg13_hv_nmos L=0.6u W=8.8u AS=4.004p AD=4.004p
+ PS=10.62u PD=10.62u rfmode=0
* device instance $17 r0 *1 49.68,4.95 sg13_hv_nmos
M$17 iovss \$4 pad$8 \$2 sg13_hv_nmos L=0.6u W=8.8u AS=4.004p AD=4.004p
+ PS=10.62u PD=10.62u rfmode=0
* device instance $19 r0 *1 52.7,4.95 sg13_hv_nmos
M$19 iovss \$4 pad$9 \$2 sg13_hv_nmos L=0.6u W=8.8u AS=4.004p AD=4.664p
+ PS=10.62u PD=15.32u rfmode=0
* device instance $21 r0 *1 66.3,3.175 rppd
R$21 iovss \$4 \$2 rppd w=0.5u l=3.54u ps=0u b=0 m=1
* device instance $22 r0 *1 40,5 ptap1
R$22 iovss \$2 ptap1 A=55.7736p P=328.08u
.ENDS sg13g2_Clamp_N20N0D
