* actual_fill grounded drive P; diagnostic capacitor-network AC only
C57 0 N 5.3824699999999997e-16
C58 0 P 4.1395900000000006e-16
C76 0 P 2.2401400000000002e-17
C84 0 N 7.1460300000000001e-19
C97 0 N 3.3681500000000001e-18
C98 0 P 3.3681500000000001e-18
C108 0 P 3.1209100000000001e-17
C118 0 N 8.0500100000000008e-18
C124 0 N 3.2379300000000005e-17
C125 0 P 1.6246300000000003e-17
C133 0 P 2.8456000000000003e-17
C140 0 P 2.7530899999999999e-18
C150 0 N 1.0645800000000001e-17
C157 0 N 4.7125200000000003e-17
C158 0 P 2.2925800000000002e-17
C169 0 P 3.4193399999999999e-17
C179 0 N 6.8834100000000004e-18
C185 0 N 1.8114100000000001e-17
C186 0 P 1.00476e-17
C196 0 P 3.4193399999999999e-17
C202 0 N 5.0022200000000005e-18
C227 0 N 2.8385000000000007e-16
C228 0 P 2.4131700000000004e-16
C247 0 N 1.4192500000000003e-16
C248 0 P 1.2065800000000001e-16
C259 0 N 2.77272e-16
C260 0 P 2.3473900000000003e-16
C284 0 N 2.8385000000000007e-16
C285 0 P 2.4131700000000004e-16
C297 0 P 1.6377600000000001e-17
C300 0 N 4.6027900000000008e-17
C303 0 N 2.30139e-17
C306 0 P 1.6377600000000001e-17
C309 0 P 1.6377600000000001e-17
C312 0 N 4.6027900000000008e-17
C315 0 P 1.6377600000000001e-17
C318 0 P 1.6377600000000001e-17
C320 0 N 4.6027900000000008e-17
C323 0 P 1.6377600000000001e-17
C325 0 P 1.6377600000000001e-17
C337 0 N 1.4115400000000001e-18
C338 0 P 1.4115400000000001e-18
C347 0 N 5.8718400000000005e-19
C348 0 P 5.8718400000000005e-19
C358 0 N 2.9913600000000006e-19
C359 0 P 2.9913600000000006e-19
C367 0 N 1.1234900000000001e-18
C368 0 P 1.1234900000000001e-18
C372 N P 3.4877500000000003e-15
C373 N 0 2.3101200000000002e-16
C374 P 0 2.9236800000000002e-16
VP P 0 DC 0 AC 1
VN N 0 DC 0 AC 0
.control
set numdgt=17
ac lin 1 1Meg 1Meg
let cp = -imag(i(VP))/(2*pi*1e6)
let cn = -imag(i(VN))/(2*pi*1e6)
print cp cn
quit
.endc
.end
