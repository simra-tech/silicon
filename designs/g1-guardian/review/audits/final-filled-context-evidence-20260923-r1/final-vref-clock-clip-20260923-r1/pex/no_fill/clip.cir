* cell sense_fill_clip
.SUBCKT sense_fill_clip
* net 1 CTX_L8_0
* net 2 CTX_L8_1
* net 3 CTX_L10_0,CTX_L30_7
* net 4 CTX_L30_0,CTX_L50_0
* net 5 CTX_L30_1
* net 6 CTX_L30_2
* net 7 CTX_L30_3
* net 8 CTX_L30_4
* net 9 P
* net 10 N
* net 11 CTX_L134_0
.ENDS sense_fill_clip
