* no_fill grounded drive P; diagnostic capacitor-network AC only
C1 0 N 1.53322e-16
C9 0 N 1.6587900000000001e-17
C10 0 P 1.7075400000000001e-17
C17 0 N 4.1208400000000002e-19
C18 0 P 4.6496800000000005e-19
C32 0 P 4.3061700000000003e-15
C34 0 N 3.1286900000000004e-18
C35 0 P 3.5745200000000008e-18
C37 0 N 3.0158999999999999e-18
C38 0 P 2.66389e-18
C40 N P 4.3061700000000003e-15
C41 N 0 5.9219500000000005e-16
C42 P 0 1.2115500000000002e-16
VP P 0 DC 0 AC 1
VN N 0 DC 0 AC 0
.control
set numdgt=17
ac lin 1 1Meg 1Meg
let cp = -imag(i(VP))/(2*pi*1e6)
let cn = -imag(i(VN))/(2*pi*1e6)
print cp cn
quit
.endc
.end
