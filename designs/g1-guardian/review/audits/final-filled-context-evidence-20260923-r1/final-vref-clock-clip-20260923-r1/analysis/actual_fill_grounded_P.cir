* actual_fill grounded drive P; diagnostic capacitor-network AC only
C49 0 N 1.53322e-16
C78 0 N 1.45823e-17
C79 0 P 1.7075400000000001e-17
C96 0 N 1.4717300000000001e-19
C97 0 P 1.6606000000000003e-19
C175 0 P 4.3061700000000003e-15
C194 0 N 8.6039100000000012e-19
C195 0 P 9.8299200000000014e-19
C241 0 N 8.2937200000000008e-19
C242 0 P 7.3256900000000007e-19
C261 0 N 3.9047600000000005e-18
C269 0 N 3.9047600000000005e-18
C276 0 N 2.4367100000000004e-18
C288 0 N 2.5083700000000002e-17
C300 0 N 2.5083700000000002e-17
C312 0 N 2.2647e-17
C366 0 N 1.9705400000000003e-17
C367 0 P 1.66709e-17
C374 0 N 1.5685400000000002e-16
C375 0 P 1.2561700000000001e-16
C383 0 N 1.5685400000000002e-16
C384 0 P 1.2561700000000001e-16
C392 0 N 1.5685400000000002e-16
C393 0 P 1.2561700000000001e-16
C400 0 N 1.3714800000000001e-16
C401 0 P 1.0894600000000001e-16
C407 0 N 3.7675999999999999e-18
C408 0 P 6.9818800000000003e-18
C414 0 N 3.7675999999999999e-18
C415 0 P 6.9818800000000003e-18
C431 0 N 3.7675999999999999e-18
C432 0 P 6.9818800000000003e-18
C436 0 N 1.5070400000000002e-19
C437 0 P 2.79275e-19
C446 0 N 1.9239000000000001e-16
C447 0 P 2.5466800000000001e-17
C455 0 N 1.9242800000000002e-16
C456 0 P 2.5466800000000001e-17
C463 0 N 1.9242800000000002e-16
C464 0 P 2.5466800000000001e-17
C468 0 N 9.1952900000000009e-18
C469 0 P 1.01867e-18
C482 0 N 1.6102600000000001e-18
C483 0 P 1.6102600000000001e-18
C488 0 N 3.2205200000000002e-18
C489 0 P 3.2205200000000002e-18
C518 0 N 3.2205200000000002e-18
C519 0 P 3.2205200000000002e-18
C527 0 N 3.2205200000000002e-18
C528 0 P 3.2205200000000002e-18
C530 0 N 1.6102600000000001e-18
C531 0 P 1.6102600000000001e-18
C542 N P 4.3061700000000003e-15
C543 N 0 3.5238800000000001e-16
C544 P 0 4.5125100000000007e-17
VP P 0 DC 0 AC 1
VN N 0 DC 0 AC 0
.control
set numdgt=17
ac lin 1 1Meg 1Meg
let cp = -imag(i(VP))/(2*pi*1e6)
let cn = -imag(i(VN))/(2*pi*1e6)
print cp cn
quit
.endc
.end
