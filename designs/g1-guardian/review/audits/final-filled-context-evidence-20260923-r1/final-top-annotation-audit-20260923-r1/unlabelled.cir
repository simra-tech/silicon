* Pin-creation API control, not a circuit qualification
.SUBCKT T
R1 A INTERNAL 1
R2 INTERNAL B 1
.ENDS T
