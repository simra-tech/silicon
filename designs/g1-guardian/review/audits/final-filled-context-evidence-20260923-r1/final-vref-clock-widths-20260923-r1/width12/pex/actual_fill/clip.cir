* cell sense_fill_clip
.SUBCKT sense_fill_clip
* net 2 FILL_L10_0
* net 3 FILL_L10_1
* net 4 FILL_L67_0
* net 5 FILL_L50_0
* net 6 FILL_L10_2
* net 7 FILL_L50_1
* net 8 FILL_L67_1
* net 9 CTX_L30_1
* net 10 CTX_L8_0
* net 11 CTX_L134_0
* net 12 CTX_L30_0
* net 13 FILL_L10_3
* net 14 FILL_L50_2
* net 15 FILL_L67_2
* net 16 FILL_L10_4
* net 17 FILL_L50_3
* net 18 FILL_L67_3
* net 19 FILL_L8_0
* net 20 FILL_L10_5
* net 21 FILL_L8_1
* net 22 FILL_L10_6
* net 23 FILL_L8_2
* net 24 FILL_L10_7
* net 25 CTX_L30_2
* net 26 FILL_L10_8
* net 27 FILL_L8_3
* net 28 FILL_L10_9
* net 29 FILL_L8_4
* net 30 FILL_L50_4
* net 31 FILL_L67_4
* net 32 FILL_L50_5
* net 33 FILL_L67_5
* net 34 P
* net 35 CTX_L30_3
* net 36 N
* net 37 FILL_L50_6
* net 38 FILL_L67_6
* net 39 FILL_L67_7
* net 40 FILL_L50_7
* net 41 FILL_L10_12
* net 42 FILL_L8_5
* net 43 FILL_L10_10
* net 44 FILL_L8_6
* net 45 FILL_L8_7
* net 46 FILL_L10_11
* net 47 FILL_L8_8
* net 48 FILL_L10_13
* net 49 FILL_L8_9
* net 50 CTX_L8_1
* net 51 CTX_L30_6
* net 52 FILL_L8_10
* net 53 FILL_L10_14
* net 54 FILL_L8_11
* net 55 FILL_L8_12
* net 56 FILL_L10_15
* net 57 FILL_L8_13
.ENDS sense_fill_clip
