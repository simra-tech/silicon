* actual_fill grounded drive N; diagnostic capacitor-network AC only
C26 0 N 1.45823e-17
C27 0 P 1.7075400000000001e-17
C105 0 P 4.3061700000000003e-15
C136 0 N 1.53322e-16
C155 0 N 8.6039100000000012e-19
C156 0 P 9.8299200000000014e-19
C180 0 N 8.2937200000000008e-19
C181 0 P 7.3256900000000007e-19
C198 0 N 3.9047600000000005e-18
C204 0 N 3.9047600000000005e-18
C210 0 N 2.4367100000000004e-18
C219 0 N 2.5083700000000002e-17
C228 0 N 2.5083700000000002e-17
C236 0 N 2.2647e-17
C259 0 N 1.9705400000000003e-17
C260 0 P 1.66709e-17
C266 0 N 1.5685400000000002e-16
C267 0 P 1.2561700000000001e-16
C275 0 N 1.5685400000000002e-16
C276 0 P 1.2561700000000001e-16
C284 0 N 1.5685400000000002e-16
C285 0 P 1.2561700000000001e-16
C292 0 N 1.3714800000000001e-16
C293 0 P 1.0894600000000001e-16
C299 0 N 3.7675999999999999e-18
C300 0 P 6.9818800000000003e-18
C306 0 N 3.7675999999999999e-18
C307 0 P 6.9818800000000003e-18
C313 0 N 3.7675999999999999e-18
C314 0 P 6.9818800000000003e-18
C318 0 N 1.5070400000000002e-19
C319 0 P 2.79275e-19
C327 0 N 1.9239000000000001e-16
C328 0 P 2.5466800000000001e-17
C335 0 N 1.9242800000000002e-16
C336 0 P 2.5466800000000001e-17
C343 0 N 1.9242800000000002e-16
C344 0 P 2.5466800000000001e-17
C348 0 N 9.1952900000000009e-18
C349 0 P 1.01867e-18
C353 0 N 1.6102600000000001e-18
C354 0 P 1.6102600000000001e-18
C359 0 N 3.2205200000000002e-18
C360 0 P 3.2205200000000002e-18
C377 0 N 3.2205200000000002e-18
C378 0 P 3.2205200000000002e-18
C381 0 N 3.2205200000000002e-18
C382 0 P 3.2205200000000002e-18
C384 0 N 1.6102600000000001e-18
C385 0 P 1.6102600000000001e-18
C396 N P 4.3061700000000003e-15
C397 N 0 3.5238800000000001e-16
C398 P 0 4.5125100000000007e-17
VP P 0 DC 0 AC 0
VN N 0 DC 0 AC 1
.control
set numdgt=17
ac lin 1 1Meg 1Meg
let cp = -imag(i(VP))/(2*pi*1e6)
let cn = -imag(i(VN))/(2*pi*1e6)
print cp cn
quit
.endc
.end
