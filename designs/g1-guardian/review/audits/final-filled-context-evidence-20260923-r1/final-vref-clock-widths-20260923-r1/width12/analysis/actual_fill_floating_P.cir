* actual_fill floating drive P; diagnostic capacitor-network AC only
C4 0 FILL_L10_0 9.2877600000000018e-19
C5 0 FILL_L10_1 1.4742100000000001e-19
C6 0 FILL_L10_12 1.2755000000000003e-18
C7 0 FILL_L10_13 3.7514800000000002e-18
C8 0 FILL_L10_14 7.5029700000000016e-18
C9 0 FILL_L10_15 7.5029700000000016e-18
C10 0 FILL_L10_2 2.2981000000000001e-18
C11 0 FILL_L10_3 4.5962100000000008e-18
C12 0 FILL_L10_4 4.5962100000000008e-18
C13 0 FILL_L10_5 3.9691200000000002e-18
C14 0 FILL_L10_6 1.8616700000000004e-17
C15 0 FILL_L10_7 2.49715e-17
C16 0 FILL_L10_8 3.1326400000000003e-17
C17 0 FILL_L10_9 2.9517900000000005e-17
C18 0 FILL_L50_0 9.3991000000000005e-17
C19 0 FILL_L50_1 9.4288400000000004e-17
C20 0 FILL_L50_2 9.4288400000000004e-17
C21 0 FILL_L50_3 7.2077600000000005e-18
C22 0 FILL_L50_4 4.5098100000000005e-17
C23 0 FILL_L50_5 4.5098100000000005e-17
C24 0 FILL_L50_6 4.5098100000000005e-17
C25 0 FILL_L50_7 1.8039300000000001e-18
C26 0 N 1.45823e-17
C27 0 P 1.7075400000000001e-17
C31 0 FILL_L10_0 7.0986300000000009e-17
C32 0 FILL_L10_1 4.3866900000000002e-16
C33 0 FILL_L10_2 4.3866900000000002e-16
C34 0 FILL_L10_3 4.3866900000000002e-16
C35 0 FILL_L10_4 3.6768200000000003e-16
C36 0 FILL_L50_0 4.7301400000000004e-16
C37 0 FILL_L50_1 4.7395600000000004e-16
C38 0 FILL_L50_2 4.7395600000000004e-16
C39 0 FILL_L50_3 5.6413000000000003e-17
C43 0 FILL_L10_0 8.0370500000000015e-18
C44 0 FILL_L10_1 8.2734399999999999e-17
C45 0 FILL_L10_2 8.2734399999999999e-17
C46 0 FILL_L10_3 8.2734399999999999e-17
C47 0 FILL_L10_4 7.4697300000000004e-17
C48 0 FILL_L10_5 4.0681399999999997e-18
C49 0 FILL_L10_6 4.1878000000000005e-17
C50 0 FILL_L10_7 4.1878000000000005e-17
C51 0 FILL_L10_8 4.1878000000000005e-17
C52 0 FILL_L10_9 3.7809800000000004e-17
C53 0 FILL_L50_0 2.8102900000000004e-16
C54 0 FILL_L50_1 2.8121800000000003e-16
C55 0 FILL_L50_2 2.8121800000000003e-16
C56 0 FILL_L50_3 1.8739600000000002e-17
C57 0 FILL_L8_0 3.11664e-19
C58 0 FILL_L8_1 3.2083100000000002e-18
C59 0 FILL_L8_2 3.2083100000000002e-18
C60 0 FILL_L8_3 3.2083100000000002e-18
C61 0 FILL_L8_4 2.8966400000000002e-18
C66 0 FILL_L10_5 2.6279499999999999e-17
C67 0 FILL_L10_6 2.24529e-16
C68 0 FILL_L10_7 2.24529e-16
C69 0 FILL_L10_8 2.24529e-16
C70 0 FILL_L10_9 1.98249e-16
C71 0 FILL_L50_0 8.9370199999999999e-17
C72 0 FILL_L50_1 8.9370199999999999e-17
C73 0 FILL_L50_2 8.9370199999999999e-17
C74 0 FILL_L50_3 3.5748100000000002e-18
C75 0 FILL_L50_4 8.7125700000000002e-18
C76 0 FILL_L50_5 8.7125700000000002e-18
C77 0 FILL_L50_6 8.7125700000000002e-18
C78 0 FILL_L50_7 3.4850300000000004e-19
C79 0 FILL_L8_0 1.6102600000000001e-18
C80 0 FILL_L8_1 3.2205200000000002e-18
C81 0 FILL_L8_2 3.2205200000000002e-18
C82 0 FILL_L8_3 3.2205200000000002e-18
C83 0 FILL_L8_4 1.6102600000000001e-18
C87 0 FILL_L10_5 1.66709e-17
C88 0 FILL_L10_6 1.2561700000000001e-16
C89 0 FILL_L10_7 1.2561700000000001e-16
C90 0 FILL_L10_8 1.2561700000000001e-16
C91 0 FILL_L10_9 1.0894600000000001e-16
C92 0 FILL_L50_0 1.1347200000000002e-17
C93 0 FILL_L50_1 1.1347200000000002e-17
C94 0 FILL_L50_2 1.1347200000000002e-17
C95 0 FILL_L50_3 4.5388800000000003e-19
C96 0 FILL_L50_4 1.46777e-17
C97 0 FILL_L50_5 1.46777e-17
C98 0 FILL_L50_6 1.46777e-17
C99 0 FILL_L50_7 5.8710600000000009e-19
C100 0 FILL_L8_0 1.6102600000000001e-18
C101 0 FILL_L8_1 3.2205200000000002e-18
C102 0 FILL_L8_2 3.2205200000000002e-18
C103 0 FILL_L8_3 3.2205200000000002e-18
C104 0 FILL_L8_4 1.6102600000000001e-18
C105 0 P 4.3061700000000003e-15
C108 0 FILL_L10_10 6.0360400000000006e-18
C109 0 FILL_L10_11 6.0360400000000006e-18
C110 0 FILL_L10_12 4.7292600000000001e-17
C111 0 FILL_L10_13 3.3165300000000003e-16
C112 0 FILL_L10_14 3.2732900000000002e-16
C113 0 FILL_L10_15 2.8436100000000002e-16
C114 0 FILL_L10_5 1.7043000000000001e-19
C115 0 FILL_L10_6 2.5985000000000001e-18
C116 0 FILL_L10_7 1.7544200000000003e-18
C117 0 FILL_L10_8 1.7544200000000003e-18
C118 0 FILL_L10_9 1.5037900000000001e-18
C119 0 FILL_L50_4 8.4435700000000007e-17
C120 0 FILL_L50_5 8.4435700000000007e-17
C121 0 FILL_L50_6 8.4435700000000007e-17
C122 0 FILL_L50_7 3.3774300000000002e-18
C123 0 FILL_L8_1 1.0996800000000001e-18
C124 0 FILL_L8_10 5.5003100000000004e-19
C125 0 FILL_L8_11 5.5003100000000004e-19
C126 0 FILL_L8_12 5.5003100000000004e-19
C127 0 FILL_L8_13 2.7501600000000002e-19
C128 0 FILL_L8_2 3.0780400000000003e-19
C129 0 FILL_L8_3 3.0780400000000003e-19
C130 0 FILL_L8_4 3.0780400000000003e-19
C131 0 FILL_L8_5 1.8701100000000002e-19
C132 0 FILL_L8_6 2.0273700000000001e-18
C133 0 FILL_L8_7 2.0273700000000001e-18
C134 0 FILL_L8_8 5.5003100000000004e-19
C135 0 FILL_L8_9 5.5003100000000004e-19
C136 0 N 1.53322e-16
C138 0 FILL_L10_0 2.5591700000000002e-17
C139 0 FILL_L10_1 1.8317800000000002e-16
C140 0 FILL_L10_2 1.8317800000000002e-16
C141 0 FILL_L10_3 1.8317800000000002e-16
C142 0 FILL_L10_4 1.5758600000000002e-16
C143 0 FILL_L50_0 1.33239e-17
C144 0 FILL_L50_1 1.6394300000000002e-17
C145 0 FILL_L50_2 1.6394300000000002e-17
C146 0 FILL_L50_3 4.1185899999999999e-19
C147 0 FILL_L50_4 7.3015800000000006e-19
C148 0 FILL_L50_5 2.19047e-18
C149 0 FILL_L50_6 2.19047e-18
C150 0 FILL_L8_0 3.6687600000000003e-18
C151 0 FILL_L8_1 3.7766599999999997e-17
C152 0 FILL_L8_2 3.7766599999999997e-17
C153 0 FILL_L8_3 3.7766599999999997e-17
C154 0 FILL_L8_4 3.4097900000000004e-17
C155 0 N 8.6039100000000012e-19
C156 0 P 9.8299200000000014e-19
C158 0 FILL_L10_12 7.4043900000000007e-18
C159 0 FILL_L10_13 7.8415899999999999e-17
C160 0 FILL_L10_14 7.8415899999999999e-17
C161 0 FILL_L10_15 7.1011500000000008e-17
C162 0 FILL_L50_1 2.18921e-19
C163 0 FILL_L50_2 2.18921e-19
C164 0 FILL_L50_4 1.5811400000000002e-17
C165 0 FILL_L50_5 1.1734700000000001e-17
C166 0 FILL_L50_6 9.9548100000000001e-18
C167 0 FILL_L8_1 8.348340000000001e-18
C168 0 FILL_L8_10 1.0790500000000001e-17
C169 0 FILL_L8_11 1.0790500000000001e-17
C170 0 FILL_L8_12 1.0790500000000001e-17
C171 0 FILL_L8_13 7.1216999999999996e-18
C172 0 FILL_L8_2 8.348340000000001e-18
C173 0 FILL_L8_3 8.348340000000001e-18
C174 0 FILL_L8_4 8.348340000000001e-18
C175 0 FILL_L8_5 3.6687600000000003e-18
C176 0 FILL_L8_6 1.0790500000000001e-17
C177 0 FILL_L8_7 1.0790500000000001e-17
C178 0 FILL_L8_8 1.0790500000000001e-17
C179 0 FILL_L8_9 1.0790500000000001e-17
C180 0 N 8.2937200000000008e-19
C181 0 P 7.3256900000000007e-19
C183 FILL_L10_0 FILL_L10_1 4.9445400000000003e-17
C184 FILL_L10_0 FILL_L10_5 9.4979800000000004e-18
C185 FILL_L10_0 FILL_L50_0 1.3701000000000001e-18
C186 FILL_L10_0 FILL_L8_0 1.38235e-18
C187 FILL_L10_0 0 1.0868600000000001e-16
C188 FILL_L10_1 FILL_L10_2 4.9445400000000003e-17
C189 FILL_L10_1 FILL_L10_6 9.7773300000000019e-17
C190 FILL_L10_1 FILL_L50_0 7.3210100000000005e-17
C191 FILL_L10_1 FILL_L8_1 1.4230000000000002e-17
C192 FILL_L10_1 0 3.0925700000000002e-16
C193 FILL_L10_10 FILL_L10_11 2.7935199999999999e-17
C194 FILL_L10_10 FILL_L10_12 2.7935199999999999e-17
C195 FILL_L10_10 FILL_L10_6 2.7935199999999999e-17
C196 FILL_L10_10 FILL_L50_4 5.1245500000000004e-17
C197 FILL_L10_10 FILL_L8_6 6.7224999999999998e-17
C198 FILL_L10_10 N 3.9047600000000005e-18
C199 FILL_L10_10 0 7.6795700000000008e-17
C200 FILL_L10_11 FILL_L10_13 2.7935199999999999e-17
C201 FILL_L10_11 FILL_L10_6 2.7935199999999999e-17
C202 FILL_L10_11 FILL_L50_4 5.5127700000000003e-17
C203 FILL_L10_11 FILL_L8_7 6.7224999999999998e-17
C204 FILL_L10_11 N 3.9047600000000005e-18
C205 FILL_L10_11 0 7.6795700000000008e-17
C206 FILL_L10_12 FILL_L10_13 1.5842400000000001e-17
C207 FILL_L10_12 FILL_L10_5 9.4979800000000004e-18
C208 FILL_L10_12 FILL_L50_4 1.5556100000000003e-17
C209 FILL_L10_12 FILL_L8_5 3.2017099999999999e-17
C210 FILL_L10_12 N 2.4367100000000004e-18
C211 FILL_L10_12 0 2.4996700000000004e-16
C212 FILL_L10_13 FILL_L10_14 9.7773300000000019e-17
C213 FILL_L10_13 FILL_L10_7 9.7773300000000019e-17
C214 FILL_L10_13 FILL_L50_4 3.2842900000000003e-17
C215 FILL_L10_13 FILL_L50_5 2.16433e-16
C216 FILL_L10_13 FILL_L8_2 9.8589300000000015e-18
C217 FILL_L10_13 FILL_L8_8 1.1751300000000001e-16
C218 FILL_L10_13 FILL_L8_9 1.1751300000000001e-16
C219 FILL_L10_13 N 2.5083700000000002e-17
C220 FILL_L10_13 0 5.0205799999999998e-16
C221 FILL_L10_14 FILL_L10_15 9.7773300000000019e-17
C222 FILL_L10_14 FILL_L10_8 9.7773300000000019e-17
C223 FILL_L10_14 FILL_L50_5 6.2229199999999999e-17
C224 FILL_L10_14 FILL_L50_6 1.65203e-16
C225 FILL_L10_14 FILL_L8_10 1.1751300000000001e-16
C226 FILL_L10_14 FILL_L8_11 1.1751300000000001e-16
C227 FILL_L10_14 FILL_L8_3 9.8589300000000015e-18
C228 FILL_L10_14 N 2.5083700000000002e-17
C229 FILL_L10_14 0 4.5495500000000001e-16
C230 FILL_L10_15 FILL_L10_9 8.8275400000000016e-17
C231 FILL_L10_15 FILL_L50_6 1.3087799999999998e-16
C232 FILL_L10_15 FILL_L50_7 5.2490100000000004e-17
C233 FILL_L10_15 FILL_L8_12 1.1751300000000001e-16
C234 FILL_L10_15 FILL_L8_13 8.54956e-17
C235 FILL_L10_15 FILL_L8_4 9.8589300000000015e-18
C236 FILL_L10_15 N 2.2647e-17
C237 FILL_L10_15 0 4.9567800000000006e-16
C238 FILL_L10_2 FILL_L10_3 4.9445400000000003e-17
C239 FILL_L10_2 FILL_L10_7 9.7773300000000019e-17
C240 FILL_L10_2 FILL_L50_0 5.8352700000000008e-18
C241 FILL_L10_2 FILL_L50_1 6.2109000000000007e-17
C242 FILL_L10_2 FILL_L8_2 1.4230000000000002e-17
C243 FILL_L10_2 0 3.0925700000000002e-16
C244 FILL_L10_3 FILL_L10_4 4.9445400000000003e-17
C245 FILL_L10_3 FILL_L10_8 9.7773300000000019e-17
C246 FILL_L10_3 FILL_L50_1 1.55573e-17
C247 FILL_L10_3 FILL_L50_2 4.6101199999999999e-17
C248 FILL_L10_3 FILL_L8_3 1.4230000000000002e-17
C249 FILL_L10_3 0 3.0925700000000002e-16
C250 FILL_L10_4 FILL_L10_9 8.8275400000000016e-17
C251 FILL_L10_4 FILL_L50_2 3.5919899999999999e-17
C252 FILL_L10_4 FILL_L50_3 1.3634600000000001e-17
C253 FILL_L10_4 FILL_L8_4 1.2847700000000001e-17
C254 FILL_L10_4 0 3.2375500000000002e-16
C255 FILL_L10_5 FILL_L10_6 9.7773300000000019e-17
C256 FILL_L10_5 FILL_L50_0 2.7402000000000003e-18
C257 FILL_L10_5 FILL_L50_4 1.2604900000000002e-18
C258 FILL_L10_5 FILL_L8_0 7.9997700000000001e-17
C259 FILL_L10_5 N 1.9705400000000003e-17
C260 FILL_L10_5 P 1.66709e-17
C261 FILL_L10_5 0 1.8037899999999999e-16
C262 FILL_L10_6 FILL_L10_7 9.7773300000000019e-17
C263 FILL_L10_6 FILL_L50_0 1.6419200000000002e-16
C264 FILL_L10_6 FILL_L50_4 1.28456e-16
C265 FILL_L10_6 FILL_L8_1 8.2350600000000007e-16
C266 FILL_L10_6 N 1.5685400000000002e-16
C267 FILL_L10_6 P 1.2561700000000001e-16
C268 FILL_L10_6 0 2.2736300000000001e-16
C269 FILL_L10_7 FILL_L10_8 9.7773300000000019e-17
C270 FILL_L10_7 FILL_L50_0 1.1670500000000001e-17
C271 FILL_L10_7 FILL_L50_1 1.3691200000000002e-16
C272 FILL_L10_7 FILL_L50_4 5.3684500000000009e-18
C273 FILL_L10_7 FILL_L50_5 9.3263200000000002e-17
C274 FILL_L10_7 FILL_L8_2 8.2350600000000007e-16
C275 FILL_L10_7 N 1.5685400000000002e-16
C276 FILL_L10_7 P 1.2561700000000001e-16
C277 FILL_L10_7 0 1.9621900000000002e-16
C278 FILL_L10_8 FILL_L10_9 9.7773300000000019e-17
C279 FILL_L10_8 FILL_L50_1 3.1114599999999999e-17
C280 FILL_L10_8 FILL_L50_2 9.9819000000000008e-17
C281 FILL_L10_8 FILL_L50_5 1.4312699999999999e-17
C282 FILL_L10_8 FILL_L50_6 6.4086900000000001e-17
C283 FILL_L10_8 FILL_L8_3 8.2350600000000007e-16
C284 FILL_L10_8 N 1.5685400000000002e-16
C285 FILL_L10_8 P 1.2561700000000001e-16
C286 FILL_L10_8 0 1.9621900000000002e-16
C287 FILL_L10_9 FILL_L50_2 7.6917500000000007e-17
C288 FILL_L10_9 FILL_L50_3 2.8081600000000006e-17
C289 FILL_L10_9 FILL_L50_6 4.7495500000000004e-17
C290 FILL_L10_9 FILL_L50_7 1.48557e-17
C291 FILL_L10_9 FILL_L8_4 7.4350800000000009e-16
C292 FILL_L10_9 N 1.3714800000000001e-16
C293 FILL_L10_9 P 1.0894600000000001e-16
C294 FILL_L10_9 0 2.5942700000000005e-16
C295 FILL_L50_0 FILL_L50_1 9.8854299999999996e-17
C296 FILL_L50_0 FILL_L50_4 9.8854299999999996e-17
C297 FILL_L50_0 FILL_L8_1 1.4589000000000001e-17
C298 FILL_L50_0 FILL_L8_2 1.3407600000000001e-18
C299 FILL_L50_0 N 3.7675999999999999e-18
C300 FILL_L50_0 P 6.9818800000000003e-18
C301 FILL_L50_0 0 2.9081599999999999e-16
C302 FILL_L50_1 FILL_L50_2 9.8854299999999996e-17
C303 FILL_L50_1 FILL_L50_5 9.8854299999999996e-17
C304 FILL_L50_1 FILL_L8_2 1.3629e-17
C305 FILL_L50_1 FILL_L8_3 4.2766800000000003e-18
C306 FILL_L50_1 N 3.7675999999999999e-18
C307 FILL_L50_1 P 6.9818800000000003e-18
C308 FILL_L50_1 0 2.2153200000000003e-16
C309 FILL_L50_2 FILL_L50_3 9.8854299999999996e-17
C310 FILL_L50_2 FILL_L50_6 9.8854299999999996e-17
C311 FILL_L50_2 FILL_L8_3 9.8880900000000008e-18
C312 FILL_L50_2 FILL_L8_4 8.0176200000000022e-18
C313 FILL_L50_2 N 3.7675999999999999e-18
C314 FILL_L50_2 P 6.9818800000000003e-18
C315 FILL_L50_2 0 2.1396900000000001e-16
C316 FILL_L50_3 FILL_L50_7 3.9541700000000001e-18
C317 FILL_L50_3 FILL_L8_4 5.4038800000000001e-19
C318 FILL_L50_3 N 1.5070400000000002e-19
C319 FILL_L50_3 P 2.79275e-19
C320 FILL_L50_3 0 1.36134e-16
C321 FILL_L50_4 FILL_L50_5 9.8854299999999996e-17
C322 FILL_L50_4 FILL_L8_1 2.1758000000000001e-17
C323 FILL_L50_4 FILL_L8_2 6.16752e-19
C324 FILL_L50_4 FILL_L8_6 1.1489300000000001e-17
C325 FILL_L50_4 FILL_L8_7 1.2985e-17
C326 FILL_L50_4 FILL_L8_8 1.3407600000000001e-18
C327 FILL_L50_4 N 1.9239000000000001e-16
C328 FILL_L50_4 P 2.5466800000000001e-17
C329 FILL_L50_4 0 3.5465e-16
C330 FILL_L50_5 FILL_L50_6 9.8854299999999996e-17
C331 FILL_L50_5 FILL_L8_10 4.2766800000000003e-18
C332 FILL_L50_5 FILL_L8_2 1.2659000000000002e-17
C333 FILL_L50_5 FILL_L8_3 1.9672700000000003e-18
C334 FILL_L50_5 FILL_L8_9 8.5533600000000005e-18
C335 FILL_L50_5 N 1.9242800000000002e-16
C336 FILL_L50_5 P 2.5466800000000001e-17
C337 FILL_L50_5 0 2.2792300000000002e-16
C338 FILL_L50_6 FILL_L50_7 9.8854299999999996e-17
C339 FILL_L50_6 FILL_L8_11 8.5533600000000005e-18
C340 FILL_L50_6 FILL_L8_12 8.5533600000000005e-18
C341 FILL_L50_6 FILL_L8_3 8.382300000000002e-18
C342 FILL_L50_6 FILL_L8_4 6.2439600000000011e-18
C343 FILL_L50_6 N 1.9242800000000002e-16
C344 FILL_L50_6 P 2.5466800000000001e-17
C345 FILL_L50_6 0 2.1551900000000003e-16
C346 FILL_L50_7 FILL_L8_13 6.842690000000001e-19
C347 FILL_L50_7 FILL_L8_4 6.842690000000001e-19
C348 FILL_L50_7 N 9.1952900000000009e-18
C349 FILL_L50_7 P 1.01867e-18
C350 FILL_L50_7 0 1.3728100000000003e-16
C351 FILL_L8_0 FILL_L8_1 6.96968e-17
C352 FILL_L8_0 FILL_L8_5 6.7705500000000005e-18
C353 FILL_L8_0 N 1.6102600000000001e-18
C354 FILL_L8_0 P 1.6102600000000001e-18
C355 FILL_L8_0 0 2.7902700000000002e-16
C356 FILL_L8_1 FILL_L8_2 6.96968e-17
C357 FILL_L8_1 FILL_L8_6 1.9913400000000001e-17
C358 FILL_L8_1 FILL_L8_7 1.9913400000000001e-17
C359 FILL_L8_1 N 3.2205200000000002e-18
C360 FILL_L8_1 P 3.2205200000000002e-18
C361 FILL_L8_1 0 7.9950800000000011e-16
C362 FILL_L8_10 FILL_L8_11 1.9913400000000001e-17
C363 FILL_L8_10 FILL_L8_3 1.9913400000000001e-17
C364 FILL_L8_10 FILL_L8_9 1.9913400000000001e-17
C365 FILL_L8_10 0 1.34885e-16
C366 FILL_L8_11 FILL_L8_12 1.9913400000000001e-17
C367 FILL_L8_11 FILL_L8_3 1.9913400000000001e-17
C368 FILL_L8_11 0 1.34885e-16
C369 FILL_L8_12 FILL_L8_13 1.9913400000000001e-17
C370 FILL_L8_12 FILL_L8_4 1.9913400000000001e-17
C371 FILL_L8_12 0 1.34885e-16
C372 FILL_L8_13 FILL_L8_4 1.3142800000000001e-17
C373 FILL_L8_13 0 1.2124900000000001e-16
C374 FILL_L8_2 FILL_L8_3 6.96968e-17
C375 FILL_L8_2 FILL_L8_8 1.9913400000000001e-17
C376 FILL_L8_2 FILL_L8_9 1.9913400000000001e-17
C377 FILL_L8_2 N 3.2205200000000002e-18
C378 FILL_L8_2 P 3.2205200000000002e-18
C379 FILL_L8_2 0 7.9950800000000011e-16
C380 FILL_L8_3 FILL_L8_4 6.96968e-17
C381 FILL_L8_3 N 3.2205200000000002e-18
C382 FILL_L8_3 P 3.2205200000000002e-18
C383 FILL_L8_3 0 7.9950800000000011e-16
C384 FILL_L8_4 N 1.6102600000000001e-18
C385 FILL_L8_4 P 1.6102600000000001e-18
C386 FILL_L8_4 0 7.9757500000000015e-16
C387 FILL_L8_5 FILL_L8_6 1.9913400000000001e-17
C388 FILL_L8_5 0 9.2805300000000006e-17
C389 FILL_L8_6 FILL_L8_7 1.9913400000000001e-17
C390 FILL_L8_6 0 1.34885e-16
C391 FILL_L8_7 FILL_L8_8 1.9913400000000001e-17
C392 FILL_L8_7 0 1.34885e-16
C393 FILL_L8_8 FILL_L8_9 1.9913400000000001e-17
C394 FILL_L8_8 0 1.34885e-16
C395 FILL_L8_9 0 1.34885e-16
C396 N P 4.3061700000000003e-15
C397 N 0 3.5238800000000001e-16
C398 P 0 4.5125100000000007e-17
VP P 0 DC 0 AC 1
VN N 0 DC 0 AC 0
.control
set numdgt=17
ac lin 1 1Meg 1Meg
let cp = -imag(i(VP))/(2*pi*1e6)
let cn = -imag(i(VN))/(2*pi*1e6)
print cp cn
quit
.endc
.end
