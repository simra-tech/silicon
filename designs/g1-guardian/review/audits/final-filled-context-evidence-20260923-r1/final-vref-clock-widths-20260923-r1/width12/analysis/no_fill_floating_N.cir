* no_fill floating drive N; diagnostic capacitor-network AC only
C5 0 N 1.6587900000000001e-17
C6 0 P 1.7075400000000001e-17
C20 0 P 4.3061700000000003e-15
C23 0 N 1.53322e-16
C25 0 N 3.1286900000000004e-18
C26 0 P 3.5745200000000008e-18
C28 0 N 3.0158999999999999e-18
C29 0 P 2.66389e-18
C31 N P 4.3061700000000003e-15
C32 N 0 5.9219500000000005e-16
C33 P 0 1.2115500000000002e-16
VP P 0 DC 0 AC 0
VN N 0 DC 0 AC 1
.control
set numdgt=17
ac lin 1 1Meg 1Meg
let cp = -imag(i(VP))/(2*pi*1e6)
let cn = -imag(i(VN))/(2*pi*1e6)
print cp cn
quit
.endc
.end
