* cell sense_fill_clip
.SUBCKT sense_fill_clip
* net 1 CTX_L67_0
* net 3 CTX_L126_0
* net 4 CTX_L134_0
* net 5 CTX_L30_0,CTX_L50_0
* net 6 CTX_L8_0
* net 7 CTX_L30_1
* net 8 CTX_L134_1
* net 9 CTX_L8_1
* net 10 CTX_L30_2
* net 11 CTX_L30_3
* net 12 CTX_L30_4
* net 13 P
* net 14 N
* net 15 CTX_L8_2
* net 16 CTX_L10_0,CTX_L30_7,CTX_L8_3
* net 17 CTX_L8_15
* net 18 CTX_L10_2,CTX_L30_8,CTX_L8_4
* net 19 CTX_L8_16
* net 20 CTX_L10_3,CTX_L30_9,CTX_L8_5,CTX_L8_6
* net 21 CTX_L8_17
* net 22 CTX_L8_18
* net 23 CTX_L10_4,CTX_L30_10,CTX_L8_7,CTX_L8_8
* net 24 CTX_L8_19
* net 25 CTX_L8_20
* net 26 CTX_L10_5,CTX_L30_11,CTX_L8_10,CTX_L8_9
* net 27 CTX_L8_21
* net 28 CTX_L10_1
* net 29 CTX_L10_6,CTX_L8_11
* net 30 CTX_L8_22
* net 31 CTX_L10_9,CTX_L8_13
* net 32 CTX_L8_23
* net 33 CTX_L8_24
* net 34 CTX_L8_25
* net 35 CTX_L8_26
* net 36 CTX_L8_27
* net 37 CTX_L8_28
* net 38 CTX_L8_29
* net 39 CTX_L8_30
* net 40 CTX_L10_8,CTX_L30_12,CTX_L8_12
* net 41 CTX_L10_14
* net 42 CTX_L10_13
* net 43 CTX_L10_12,CTX_L8_14
* net 44 CTX_L10_11
* net 45 CTX_L10_7
* net 46 CTX_L10_10
.ENDS sense_fill_clip
