* cell sense_fill_clip
.SUBCKT sense_fill_clip
* net 2 CTX_L67_0
* net 3 CTX_L126_0
* net 4 CTX_L134_0
* net 5 CTX_L30_0,CTX_L50_0
* net 6 CTX_L8_0
* net 7 FILL_L10_0
* net 8 FILL_L10_1
* net 9 FILL_L10_2
* net 10 CTX_L134_1
* net 11 CTX_L30_1
* net 12 FILL_L10_3
* net 13 FILL_L10_4
* net 14 FILL_L67_0
* net 15 FILL_L50_0
* net 16 FILL_L50_1
* net 17 FILL_L67_1
* net 18 CTX_L30_2
* net 19 CTX_L8_1
* net 20 FILL_L67_2
* net 21 FILL_L50_2
* net 22 FILL_L50_3
* net 23 FILL_L67_3
* net 24 FILL_L8_0
* net 25 FILL_L10_5
* net 26 FILL_L10_6
* net 27 FILL_L8_1
* net 28 FILL_L8_2
* net 29 FILL_L10_7
* net 30 CTX_L30_3
* net 31 N
* net 32 P
* net 33 CTX_L30_4
* net 34 FILL_L8_3
* net 35 FILL_L10_8
* net 36 FILL_L8_4
* net 37 FILL_L10_9
* net 38 FILL_L67_4
* net 39 FILL_L50_4
* net 40 FILL_L50_5
* net 41 FILL_L67_5
* net 42 FILL_L67_6
* net 43 FILL_L50_6
* net 44 FILL_L67_7
* net 45 FILL_L50_7
* net 46 FILL_L10_12
* net 47 FILL_L8_5
* net 48 FILL_L8_6
* net 49 FILL_L10_10
* net 50 FILL_L8_7
* net 51 FILL_L10_11
* net 52 FILL_L8_8
* net 53 FILL_L10_13
* net 54 FILL_L8_9
* net 55 CTX_L8_2
* net 56 FILL_L8_10
* net 57 FILL_L10_14
* net 58 FILL_L8_11
* net 59 FILL_L8_12
* net 60 FILL_L10_15
* net 61 FILL_L8_13
* net 62 FILL_L10_16
* net 63 FILL_L8_14
* net 64 FILL_L8_15
* net 65 FILL_L50_8
* net 66 FILL_L67_8
* net 67 FILL_L8_16
* net 68 FILL_L10_17
* net 69 FILL_L8_17
* net 70 FILL_L50_9
* net 71 FILL_L67_9
* net 72 FILL_L10_18
* net 73 FILL_L8_18
* net 74 FILL_L10_19
* net 75 FILL_L8_19
* net 76 FILL_L8_20
* net 77 FILL_L10_20
* net 78 FILL_L50_10
* net 79 FILL_L67_10
* net 80 FILL_L8_21
* net 81 FILL_L10_21
* net 82 FILL_L10_22
* net 83 FILL_L8_22
* net 84 FILL_L50_11
* net 85 FILL_L67_11
* net 86 CTX_L10_0,CTX_L30_7,CTX_L8_3
* net 87 FILL_L50_12
* net 88 FILL_L67_12
* net 89 FILL_L67_13
* net 90 FILL_L50_13
* net 91 FILL_L67_14
* net 92 FILL_L50_14
* net 93 FILL_L67_15
* net 94 FILL_L50_15
* net 95 CTX_L8_15
* net 96 CTX_L8_16
* net 97 CTX_L8_17
* net 98 FILL_L67_16
* net 99 FILL_L50_16
* net 100 CTX_L8_18
* net 101 CTX_L8_19
* net 102 CTX_L8_20
* net 103 CTX_L8_21
* net 104 FILL_L50_17
* net 105 FILL_L67_17
* net 106 CTX_L10_1
* net 107 CTX_L10_6,CTX_L8_11
* net 108 CTX_L8_22
* net 109 CTX_L10_9,CTX_L8_13
* net 110 CTX_L8_23
* net 111 CTX_L8_24
* net 112 CTX_L8_25
* net 113 FILL_L50_18
* net 114 FILL_L67_18
* net 115 CTX_L8_26
* net 116 CTX_L8_27
* net 117 CTX_L8_28
* net 118 CTX_L8_29
* net 119 FILL_L67_19
* net 120 FILL_L50_19
* net 121 CTX_L8_30
* net 122 CTX_L10_2,CTX_L30_8,CTX_L8_4
* net 123 CTX_L10_3,CTX_L30_9,CTX_L8_5,CTX_L8_6
* net 124 CTX_L10_4,CTX_L30_10,CTX_L8_7,CTX_L8_8
* net 125 CTX_L10_8,CTX_L30_12,CTX_L8_12
* net 126 CTX_L10_5,CTX_L30_11,CTX_L8_10,CTX_L8_9
* net 127 CTX_L10_11
* net 128 CTX_L10_12,CTX_L8_14
* net 129 CTX_L10_13
* net 130 CTX_L10_14
* net 131 CTX_L10_10
* net 132 CTX_L10_7
.ENDS sense_fill_clip
