*********************************************************
*** NGSPICE file created by KLayout-PEX 0.3.12
*** -----------------------------------------------------
***     Extraction Engine: KPEX/2.5D
***     Technology: ihp_sg13g2
***     Date: 2026-09-23 06:06:40
*********************************************************

.SUBCKT sense_fill_clip
Cext_1 CTX_L10_0|CTX_L30_7|CTX_L8_3 CTX_L10_1 37.598a
Cext_2 CTX_L10_0|CTX_L30_7|CTX_L8_3 CTX_L10_12|CTX_L8_14 120.197a
Cext_3 CTX_L10_0|CTX_L30_7|CTX_L8_3 CTX_L10_2|CTX_L30_8|CTX_L8_4 385.16a
Cext_4 CTX_L10_0|CTX_L30_7|CTX_L8_3 CTX_L10_3|CTX_L30_9|CTX_L8_5|CTX_L8_6
+ 811.876a
Cext_5 CTX_L10_0|CTX_L30_7|CTX_L8_3 CTX_L10_4|CTX_L30_10|CTX_L8_7|CTX_L8_8
+ 811.777a
Cext_6 CTX_L10_0|CTX_L30_7|CTX_L8_3 CTX_L10_5|CTX_L30_11|CTX_L8_10|CTX_L8_9
+ 811.777a
Cext_7 CTX_L10_0|CTX_L30_7|CTX_L8_3 CTX_L10_6|CTX_L8_11 405.686a
Cext_8 CTX_L10_0|CTX_L30_7|CTX_L8_3 CTX_L10_7 1.1908a
Cext_9 CTX_L10_0|CTX_L30_7|CTX_L8_3 CTX_L10_8|CTX_L30_12|CTX_L8_12 396.692a
Cext_10 CTX_L10_0|CTX_L30_7|CTX_L8_3 CTX_L10_9|CTX_L8_13 120.467a
Cext_11 CTX_L10_0|CTX_L30_7|CTX_L8_3 CTX_L8_15 3.55576a
Cext_12 CTX_L10_0|CTX_L30_7|CTX_L8_3 CTX_L8_16 395.842a
Cext_13 CTX_L10_0|CTX_L30_7|CTX_L8_3 CTX_L8_17 395.842a
Cext_14 CTX_L10_0|CTX_L30_7|CTX_L8_3 CTX_L8_18 395.842a
Cext_15 CTX_L10_0|CTX_L30_7|CTX_L8_3 CTX_L8_19 395.842a
Cext_16 CTX_L10_0|CTX_L30_7|CTX_L8_3 CTX_L8_2 422.493a
Cext_17 CTX_L10_0|CTX_L30_7|CTX_L8_3 CTX_L8_20 395.842a
Cext_18 CTX_L10_0|CTX_L30_7|CTX_L8_3 CTX_L8_21 395.842a
Cext_19 CTX_L10_0|CTX_L30_7|CTX_L8_3 CTX_L8_22 395.842a
Cext_20 CTX_L10_0|CTX_L30_7|CTX_L8_3 CTX_L8_23 52.5916a
Cext_21 CTX_L10_0|CTX_L30_7|CTX_L8_3 CTX_L8_24 120.197a
Cext_22 CTX_L10_0|CTX_L30_7|CTX_L8_3 CTX_L8_25 52.5916a
Cext_23 CTX_L10_0|CTX_L30_7|CTX_L8_3 CTX_L8_26 52.5916a
Cext_24 CTX_L10_0|CTX_L30_7|CTX_L8_3 CTX_L8_27 120.197a
Cext_25 CTX_L10_0|CTX_L30_7|CTX_L8_3 CTX_L8_28 52.5916a
Cext_26 CTX_L10_0|CTX_L30_7|CTX_L8_3 CTX_L8_29 120.197a
Cext_27 CTX_L10_0|CTX_L30_7|CTX_L8_3 CTX_L8_30 49.9248a
Cext_28 CTX_L10_0|CTX_L30_7|CTX_L8_3 N 153.322a
Cext_29 CTX_L10_0|CTX_L30_7|CTX_L8_3 VSUBS 5.33517f
Cext_30 CTX_L10_1 CTX_L10_12|CTX_L8_14 18.4164a
Cext_31 CTX_L10_1 CTX_L10_2|CTX_L30_8|CTX_L8_4 292.331a
Cext_32 CTX_L10_1 CTX_L10_3|CTX_L30_9|CTX_L8_5|CTX_L8_6 506.499a
Cext_33 CTX_L10_1 CTX_L10_4|CTX_L30_10|CTX_L8_7|CTX_L8_8 506.499a
Cext_34 CTX_L10_1 CTX_L10_5|CTX_L30_11|CTX_L8_10|CTX_L8_9 506.499a
Cext_35 CTX_L10_1 CTX_L10_6|CTX_L8_11 1.6151f
Cext_36 CTX_L10_1 CTX_L10_7 108.23a
Cext_37 CTX_L10_1 CTX_L10_8|CTX_L30_12|CTX_L8_12 21.6299a
Cext_38 CTX_L10_1 CTX_L10_9|CTX_L8_13 18.6385a
Cext_39 CTX_L10_1 CTX_L8_15 14.3129a
Cext_40 CTX_L10_1 CTX_L8_16 20.8009a
Cext_41 CTX_L10_1 CTX_L8_17 18.3345a
Cext_42 CTX_L10_1 CTX_L8_18 20.8009a
Cext_43 CTX_L10_1 CTX_L8_19 18.3345a
Cext_44 CTX_L10_1 CTX_L8_20 20.8009a
Cext_45 CTX_L10_1 CTX_L8_21 18.3345a
Cext_46 CTX_L10_1 CTX_L8_22 18.3345a
Cext_47 CTX_L10_1 CTX_L8_23 18.3345a
Cext_48 CTX_L10_1 CTX_L8_24 18.4164a
Cext_49 CTX_L10_1 CTX_L8_25 18.3345a
Cext_50 CTX_L10_1 CTX_L8_26 18.3345a
Cext_51 CTX_L10_1 CTX_L8_27 18.4164a
Cext_52 CTX_L10_1 CTX_L8_28 18.3345a
Cext_53 CTX_L10_1 CTX_L8_29 18.4164a
Cext_54 CTX_L10_1 CTX_L8_30 7.48599a
Cext_55 CTX_L10_1 VSUBS 656.05a
Cext_56 CTX_L10_10 CTX_L10_11 3.61066f
Cext_57 CTX_L10_10 CTX_L10_12|CTX_L8_14 12.973a
Cext_58 CTX_L10_10 CTX_L10_2|CTX_L30_8|CTX_L8_4 27.199a
Cext_59 CTX_L10_10 CTX_L10_3|CTX_L30_9|CTX_L8_5|CTX_L8_6 29.9751a
Cext_60 CTX_L10_10 CTX_L10_4|CTX_L30_10|CTX_L8_7|CTX_L8_8 29.9751a
Cext_61 CTX_L10_10 CTX_L10_5|CTX_L30_11|CTX_L8_10|CTX_L8_9 25.4305a
Cext_62 CTX_L10_10 CTX_L10_6|CTX_L8_11 0.475859a
Cext_63 CTX_L10_10 CTX_L10_7 60.8796a
Cext_64 CTX_L10_10 CTX_L10_8|CTX_L30_12|CTX_L8_12 2.12365f
Cext_65 CTX_L10_10 CTX_L10_9|CTX_L8_13 1.32155f
Cext_66 CTX_L10_10 CTX_L8_15 12.0777a
Cext_67 CTX_L10_10 CTX_L8_16 17.0201a
Cext_68 CTX_L10_10 CTX_L8_17 17.0201a
Cext_69 CTX_L10_10 CTX_L8_18 17.0201a
Cext_70 CTX_L10_10 CTX_L8_19 17.0201a
Cext_71 CTX_L10_10 CTX_L8_20 17.0201a
Cext_72 CTX_L10_10 CTX_L8_21 18.2628a
Cext_73 CTX_L10_10 CTX_L8_22 20.7292a
Cext_74 CTX_L10_10 CTX_L8_23 13.48a
Cext_75 CTX_L10_10 CTX_L8_24 12.5592a
Cext_76 CTX_L10_10 CTX_L8_25 12.5592a
Cext_77 CTX_L10_10 CTX_L8_26 12.5592a
Cext_78 CTX_L10_10 CTX_L8_27 12.5592a
Cext_79 CTX_L10_10 CTX_L8_28 12.5592a
Cext_80 CTX_L10_10 CTX_L8_29 12.5592a
Cext_81 CTX_L10_10 CTX_L8_30 6.04217a
Cext_82 CTX_L10_10 VSUBS 188.355a
Cext_83 CTX_L10_11 CTX_L10_12|CTX_L8_14 3.624f
Cext_84 CTX_L10_11 CTX_L10_2|CTX_L30_8|CTX_L8_4 27.0071a
Cext_85 CTX_L10_11 CTX_L10_3|CTX_L30_9|CTX_L8_5|CTX_L8_6 29.5914a
Cext_86 CTX_L10_11 CTX_L10_4|CTX_L30_10|CTX_L8_7|CTX_L8_8 29.5914a
Cext_87 CTX_L10_11 CTX_L10_5|CTX_L30_11|CTX_L8_10|CTX_L8_9 25.0468a
Cext_88 CTX_L10_11 CTX_L10_6|CTX_L8_11 0.284003a
Cext_89 CTX_L10_11 CTX_L10_8|CTX_L30_12|CTX_L8_12 26.6942a
Cext_90 CTX_L10_11 CTX_L10_9|CTX_L8_13 0.88667a
Cext_91 CTX_L10_11 CTX_L8_15 12.0777a
Cext_92 CTX_L10_11 CTX_L8_16 17.0201a
Cext_93 CTX_L10_11 CTX_L8_17 17.0201a
Cext_94 CTX_L10_11 CTX_L8_18 17.0201a
Cext_95 CTX_L10_11 CTX_L8_19 17.0201a
Cext_96 CTX_L10_11 CTX_L8_20 17.0201a
Cext_97 CTX_L10_11 CTX_L8_21 18.2628a
Cext_98 CTX_L10_11 CTX_L8_22 18.2628a
Cext_99 CTX_L10_11 CTX_L8_23 13.48a
Cext_100 CTX_L10_11 CTX_L8_24 12.5592a
Cext_101 CTX_L10_11 CTX_L8_25 12.5592a
Cext_102 CTX_L10_11 CTX_L8_26 12.5592a
Cext_103 CTX_L10_11 CTX_L8_27 12.5592a
Cext_104 CTX_L10_11 CTX_L8_28 12.5592a
Cext_105 CTX_L10_11 CTX_L8_29 12.5592a
Cext_106 CTX_L10_11 CTX_L8_30 6.04217a
Cext_107 CTX_L10_11 VSUBS 183.966a
Cext_108 CTX_L10_12|CTX_L8_14 CTX_L10_13 3.61252f
Cext_109 CTX_L10_12|CTX_L8_14 CTX_L10_14 0.208848a
Cext_110 CTX_L10_12|CTX_L8_14 CTX_L10_2|CTX_L30_8|CTX_L8_4 26.9088a
Cext_111 CTX_L10_12|CTX_L8_14 CTX_L10_3|CTX_L30_9|CTX_L8_5|CTX_L8_6 29.3948a
Cext_112 CTX_L10_12|CTX_L8_14 CTX_L10_4|CTX_L30_10|CTX_L8_7|CTX_L8_8 29.3948a
Cext_113 CTX_L10_12|CTX_L8_14 CTX_L10_5|CTX_L30_11|CTX_L8_10|CTX_L8_9 24.8502a
Cext_114 CTX_L10_12|CTX_L8_14 CTX_L10_6|CTX_L8_11 12.6706a
Cext_115 CTX_L10_12|CTX_L8_14 CTX_L10_7 12.5592a
Cext_116 CTX_L10_12|CTX_L8_14 CTX_L10_8|CTX_L30_12|CTX_L8_12 26.3926a
Cext_117 CTX_L10_12|CTX_L8_14 CTX_L10_9|CTX_L8_13 13.2572a
Cext_118 CTX_L10_12|CTX_L8_14 CTX_L8_15 12.0777a
Cext_119 CTX_L10_12|CTX_L8_14 CTX_L8_16 17.0201a
Cext_120 CTX_L10_12|CTX_L8_14 CTX_L8_17 17.0201a
Cext_121 CTX_L10_12|CTX_L8_14 CTX_L8_18 17.0201a
Cext_122 CTX_L10_12|CTX_L8_14 CTX_L8_19 17.0201a
Cext_123 CTX_L10_12|CTX_L8_14 CTX_L8_20 17.0201a
Cext_124 CTX_L10_12|CTX_L8_14 CTX_L8_21 18.2628a
Cext_125 CTX_L10_12|CTX_L8_14 CTX_L8_22 18.2628a
Cext_126 CTX_L10_12|CTX_L8_14 CTX_L8_23 13.48a
Cext_127 CTX_L10_12|CTX_L8_14 CTX_L8_24 12.5592a
Cext_128 CTX_L10_12|CTX_L8_14 CTX_L8_25 1.00847f
Cext_129 CTX_L10_12|CTX_L8_14 CTX_L8_26 261.304a
Cext_130 CTX_L10_12|CTX_L8_14 CTX_L8_27 12.5592a
Cext_131 CTX_L10_12|CTX_L8_14 CTX_L8_28 12.5592a
Cext_132 CTX_L10_12|CTX_L8_14 CTX_L8_29 12.5592a
Cext_133 CTX_L10_12|CTX_L8_14 CTX_L8_30 6.04217a
Cext_134 CTX_L10_12|CTX_L8_14 VSUBS 441.775a
Cext_135 CTX_L10_13 CTX_L10_14 3.61066f
Cext_136 CTX_L10_13 CTX_L10_2|CTX_L30_8|CTX_L8_4 26.8531a
Cext_137 CTX_L10_13 CTX_L10_3|CTX_L30_9|CTX_L8_5|CTX_L8_6 29.2833a
Cext_138 CTX_L10_13 CTX_L10_4|CTX_L30_10|CTX_L8_7|CTX_L8_8 29.2833a
Cext_139 CTX_L10_13 CTX_L10_5|CTX_L30_11|CTX_L8_10|CTX_L8_9 24.7387a
Cext_140 CTX_L10_13 CTX_L10_8|CTX_L30_12|CTX_L8_12 26.0915a
Cext_141 CTX_L10_13 CTX_L10_9|CTX_L8_13 0.284003a
Cext_142 CTX_L10_13 CTX_L8_15 12.0777a
Cext_143 CTX_L10_13 CTX_L8_16 17.0201a
Cext_144 CTX_L10_13 CTX_L8_17 17.0201a
Cext_145 CTX_L10_13 CTX_L8_18 17.0201a
Cext_146 CTX_L10_13 CTX_L8_19 17.0201a
Cext_147 CTX_L10_13 CTX_L8_20 17.0201a
Cext_148 CTX_L10_13 CTX_L8_21 18.2628a
Cext_149 CTX_L10_13 CTX_L8_22 18.2628a
Cext_150 CTX_L10_13 CTX_L8_23 13.48a
Cext_151 CTX_L10_13 CTX_L8_24 12.5592a
Cext_152 CTX_L10_13 CTX_L8_25 16.0993a
Cext_153 CTX_L10_13 CTX_L8_26 13.48a
Cext_154 CTX_L10_13 CTX_L8_27 12.5592a
Cext_155 CTX_L10_13 CTX_L8_28 12.5592a
Cext_156 CTX_L10_13 CTX_L8_29 12.5592a
Cext_157 CTX_L10_13 CTX_L8_30 6.04217a
Cext_158 CTX_L10_13 VSUBS 185.462a
Cext_159 CTX_L10_14 CTX_L10_2|CTX_L30_8|CTX_L8_4 6.74289a
Cext_160 CTX_L10_14 CTX_L10_3|CTX_L30_9|CTX_L8_5|CTX_L8_6 7.22212a
Cext_161 CTX_L10_14 CTX_L10_4|CTX_L30_10|CTX_L8_7|CTX_L8_8 7.22212a
Cext_162 CTX_L10_14 CTX_L10_5|CTX_L30_11|CTX_L8_10|CTX_L8_9 6.27533a
Cext_163 CTX_L10_14 CTX_L10_8|CTX_L30_12|CTX_L8_12 6.55215a
Cext_164 CTX_L10_14 CTX_L8_15 3.4696a
Cext_165 CTX_L10_14 CTX_L8_16 4.59789a
Cext_166 CTX_L10_14 CTX_L8_17 4.59789a
Cext_167 CTX_L10_14 CTX_L8_18 4.59789a
Cext_168 CTX_L10_14 CTX_L8_19 4.59789a
Cext_169 CTX_L10_14 CTX_L8_20 4.59789a
Cext_170 CTX_L10_14 CTX_L8_21 4.8568a
Cext_171 CTX_L10_14 CTX_L8_22 4.8568a
Cext_172 CTX_L10_14 CTX_L8_23 3.86038a
Cext_173 CTX_L10_14 CTX_L8_24 3.66855a
Cext_174 CTX_L10_14 CTX_L8_25 4.40607a
Cext_175 CTX_L10_14 CTX_L8_26 3.86038a
Cext_176 CTX_L10_14 CTX_L8_27 3.66855a
Cext_177 CTX_L10_14 CTX_L8_28 3.66855a
Cext_178 CTX_L10_14 CTX_L8_29 3.66855a
Cext_179 CTX_L10_14 CTX_L8_30 1.5218a
Cext_180 CTX_L10_14 VSUBS 761.174a
Cext_181 CTX_L10_2|CTX_L30_8|CTX_L8_4 CTX_L10_3|CTX_L30_9|CTX_L8_5|CTX_L8_6
+ 76.5537a
Cext_182 CTX_L10_2|CTX_L30_8|CTX_L8_4 CTX_L10_7 299.381a
Cext_183 CTX_L10_2|CTX_L30_8|CTX_L8_4 CTX_L10_8|CTX_L30_12|CTX_L8_12 27.6098a
Cext_184 CTX_L10_2|CTX_L30_8|CTX_L8_4 CTX_L8_15 701.21a
Cext_185 CTX_L10_2|CTX_L30_8|CTX_L8_4 CTX_L8_16 61.2285a
Cext_186 CTX_L10_2|CTX_L30_8|CTX_L8_4 CTX_L8_17 2.2771a
Cext_187 CTX_L10_2|CTX_L30_8|CTX_L8_4 VSUBS 335.328a
Cext_188 CTX_L10_3|CTX_L30_9|CTX_L8_5|CTX_L8_6
+ CTX_L10_4|CTX_L30_10|CTX_L8_7|CTX_L8_8 76.5537a
Cext_189 CTX_L10_3|CTX_L30_9|CTX_L8_5|CTX_L8_6 CTX_L10_7 498.514a
Cext_190 CTX_L10_3|CTX_L30_9|CTX_L8_5|CTX_L8_6 CTX_L10_8|CTX_L30_12|CTX_L8_12
+ 30.7967a
Cext_191 CTX_L10_3|CTX_L30_9|CTX_L8_5|CTX_L8_6 CTX_L8_16 691.234a
Cext_192 CTX_L10_3|CTX_L30_9|CTX_L8_5|CTX_L8_6 CTX_L8_17 754.128a
Cext_193 CTX_L10_3|CTX_L30_9|CTX_L8_5|CTX_L8_6 CTX_L8_18 61.104a
Cext_194 CTX_L10_3|CTX_L30_9|CTX_L8_5|CTX_L8_6 CTX_L8_19 2.20077a
Cext_195 CTX_L10_3|CTX_L30_9|CTX_L8_5|CTX_L8_6 VSUBS 414.717a
Cext_196 CTX_L10_4|CTX_L30_10|CTX_L8_7|CTX_L8_8
+ CTX_L10_5|CTX_L30_11|CTX_L8_10|CTX_L8_9 76.5537a
Cext_197 CTX_L10_4|CTX_L30_10|CTX_L8_7|CTX_L8_8 CTX_L10_7 498.514a
Cext_198 CTX_L10_4|CTX_L30_10|CTX_L8_7|CTX_L8_8 CTX_L10_8|CTX_L30_12|CTX_L8_12
+ 30.7967a
Cext_199 CTX_L10_4|CTX_L30_10|CTX_L8_7|CTX_L8_8 CTX_L8_18 691.234a
Cext_200 CTX_L10_4|CTX_L30_10|CTX_L8_7|CTX_L8_8 CTX_L8_19 754.128a
Cext_201 CTX_L10_4|CTX_L30_10|CTX_L8_7|CTX_L8_8 CTX_L8_20 61.104a
Cext_202 CTX_L10_4|CTX_L30_10|CTX_L8_7|CTX_L8_8 CTX_L8_21 2.20077a
Cext_203 CTX_L10_4|CTX_L30_10|CTX_L8_7|CTX_L8_8 VSUBS 415.017a
Cext_204 CTX_L10_5|CTX_L30_11|CTX_L8_10|CTX_L8_9 CTX_L10_6|CTX_L8_11 29.2732a
Cext_205 CTX_L10_5|CTX_L30_11|CTX_L8_10|CTX_L8_9 CTX_L10_7 499.843a
Cext_206 CTX_L10_5|CTX_L30_11|CTX_L8_10|CTX_L8_9 CTX_L10_8|CTX_L30_12|CTX_L8_12
+ 233.738a
Cext_207 CTX_L10_5|CTX_L30_11|CTX_L8_10|CTX_L8_9 CTX_L10_9|CTX_L8_13 0.475957a
Cext_208 CTX_L10_5|CTX_L30_11|CTX_L8_10|CTX_L8_9 CTX_L8_20 691.234a
Cext_209 CTX_L10_5|CTX_L30_11|CTX_L8_10|CTX_L8_9 CTX_L8_21 754.058a
Cext_210 CTX_L10_5|CTX_L30_11|CTX_L8_10|CTX_L8_9 CTX_L8_22 1.70106a
Cext_211 CTX_L10_5|CTX_L30_11|CTX_L8_10|CTX_L8_9 CTX_L8_23 0.293346a
Cext_212 CTX_L10_5|CTX_L30_11|CTX_L8_10|CTX_L8_9 CTX_L8_24 0.243504a
Cext_213 CTX_L10_5|CTX_L30_11|CTX_L8_10|CTX_L8_9 VSUBS 405.998a
Cext_214 CTX_L10_6|CTX_L8_11 CTX_L10_7 1.59777f
Cext_215 CTX_L10_6|CTX_L8_11 CTX_L10_8|CTX_L30_12|CTX_L8_12 692.866a
Cext_216 CTX_L10_6|CTX_L8_11 CTX_L10_9|CTX_L8_13 12.973a
Cext_217 CTX_L10_6|CTX_L8_11 CTX_L8_22 61.5245a
Cext_218 CTX_L10_6|CTX_L8_11 CTX_L8_23 12.5592a
Cext_219 CTX_L10_6|CTX_L8_11 CTX_L8_24 12.5592a
Cext_220 CTX_L10_6|CTX_L8_11 CTX_L8_25 12.5592a
Cext_221 CTX_L10_6|CTX_L8_11 CTX_L8_26 12.5592a
Cext_222 CTX_L10_6|CTX_L8_11 CTX_L8_27 12.5592a
Cext_223 CTX_L10_6|CTX_L8_11 CTX_L8_28 12.5592a
Cext_224 CTX_L10_6|CTX_L8_11 CTX_L8_29 12.5592a
Cext_225 CTX_L10_6|CTX_L8_11 CTX_L8_30 6.04217a
Cext_226 CTX_L10_6|CTX_L8_11 VSUBS 236.198a
Cext_227 CTX_L10_7 CTX_L10_8|CTX_L30_12|CTX_L8_12 2.11859f
Cext_228 CTX_L10_7 CTX_L10_9|CTX_L8_13 1.33303f
Cext_229 CTX_L10_7 CTX_L8_15 12.0777a
Cext_230 CTX_L10_7 CTX_L8_16 19.4865a
Cext_231 CTX_L10_7 CTX_L8_17 17.0201a
Cext_232 CTX_L10_7 CTX_L8_18 19.4865a
Cext_233 CTX_L10_7 CTX_L8_19 17.0201a
Cext_234 CTX_L10_7 CTX_L8_20 19.4865a
Cext_235 CTX_L10_7 CTX_L8_21 17.0201a
Cext_236 CTX_L10_7 CTX_L8_22 15.9464a
Cext_237 CTX_L10_7 CTX_L8_23 12.5592a
Cext_238 CTX_L10_7 CTX_L8_24 12.5592a
Cext_239 CTX_L10_7 CTX_L8_25 12.5592a
Cext_240 CTX_L10_7 CTX_L8_26 12.5592a
Cext_241 CTX_L10_7 CTX_L8_27 12.5592a
Cext_242 CTX_L10_7 CTX_L8_28 12.5592a
Cext_243 CTX_L10_7 CTX_L8_29 12.5592a
Cext_244 CTX_L10_7 CTX_L8_30 6.04217a
Cext_245 CTX_L10_7 VSUBS 191.013a
Cext_246 CTX_L10_8|CTX_L30_12|CTX_L8_12 CTX_L10_9|CTX_L8_13 13.3969a
Cext_247 CTX_L10_8|CTX_L30_12|CTX_L8_12 CTX_L8_15 12.0777a
Cext_248 CTX_L10_8|CTX_L30_12|CTX_L8_12 CTX_L8_16 17.0201a
Cext_249 CTX_L10_8|CTX_L30_12|CTX_L8_12 CTX_L8_17 17.0201a
Cext_250 CTX_L10_8|CTX_L30_12|CTX_L8_12 CTX_L8_18 17.0201a
Cext_251 CTX_L10_8|CTX_L30_12|CTX_L8_12 CTX_L8_19 17.0201a
Cext_252 CTX_L10_8|CTX_L30_12|CTX_L8_12 CTX_L8_20 17.0201a
Cext_253 CTX_L10_8|CTX_L30_12|CTX_L8_12 CTX_L8_21 40.1017a
Cext_254 CTX_L10_8|CTX_L30_12|CTX_L8_12 CTX_L8_22 28.8582a
Cext_255 CTX_L10_8|CTX_L30_12|CTX_L8_12 CTX_L8_23 1.16819a
Cext_256 CTX_L10_8|CTX_L30_12|CTX_L8_12 CTX_L8_24 0.951771a
Cext_257 CTX_L10_8|CTX_L30_12|CTX_L8_12 CTX_L8_25 0.603413a
Cext_258 CTX_L10_8|CTX_L30_12|CTX_L8_12 VSUBS 349.228a
Cext_259 CTX_L10_9|CTX_L8_13 CTX_L8_22 812.829a
Cext_260 CTX_L10_9|CTX_L8_13 CTX_L8_23 211.359a
Cext_261 CTX_L10_9|CTX_L8_13 CTX_L8_24 12.5592a
Cext_262 CTX_L10_9|CTX_L8_13 CTX_L8_25 12.5592a
Cext_263 CTX_L10_9|CTX_L8_13 CTX_L8_26 12.5592a
Cext_264 CTX_L10_9|CTX_L8_13 CTX_L8_27 12.5592a
Cext_265 CTX_L10_9|CTX_L8_13 CTX_L8_28 12.5592a
Cext_266 CTX_L10_9|CTX_L8_13 CTX_L8_29 12.5592a
Cext_267 CTX_L10_9|CTX_L8_13 CTX_L8_30 6.04217a
Cext_268 CTX_L10_9|CTX_L8_13 VSUBS 282.899a
Cext_269 CTX_L126_0 CTX_L30_0|CTX_L50_0 156.37a
Cext_270 CTX_L126_0 CTX_L67_0 1.25019f
Cext_271 CTX_L126_0 VSUBS 1.13544f
Cext_272 CTX_L134_0 CTX_L134_1 632.067a
Cext_273 CTX_L134_0 CTX_L30_0|CTX_L50_0 609.208a
Cext_274 CTX_L134_0 CTX_L67_0 15.2183a
Cext_275 CTX_L134_0 CTX_L8_0 34.1889a
Cext_276 CTX_L134_0 VSUBS 855.847a
Cext_277 CTX_L134_1 CTX_L30_0|CTX_L50_0 369.278a
Cext_278 CTX_L134_1 CTX_L30_1 193.753a
Cext_279 CTX_L134_1 CTX_L30_2 22.6487a
Cext_280 CTX_L134_1 CTX_L30_3 17.9889a
Cext_281 CTX_L134_1 CTX_L30_4 17.5443a
Cext_282 CTX_L134_1 CTX_L8_0 2.83089a
Cext_283 CTX_L134_1 CTX_L8_1 2.37861a
Cext_284 CTX_L134_1 N 16.5879a
Cext_285 CTX_L134_1 P 17.0754a
Cext_286 CTX_L134_1 VSUBS 824.993a
Cext_287 CTX_L30_0|CTX_L50_0 CTX_L30_1 1.45162f
Cext_288 CTX_L30_0|CTX_L50_0 CTX_L30_2 2.35367a
Cext_289 CTX_L30_0|CTX_L50_0 CTX_L30_3 0.606347a
Cext_290 CTX_L30_0|CTX_L50_0 CTX_L30_4 0.528673a
Cext_291 CTX_L30_0|CTX_L50_0 CTX_L67_0 830.987a
Cext_292 CTX_L30_0|CTX_L50_0 CTX_L8_0 279.843a
Cext_293 CTX_L30_0|CTX_L50_0 CTX_L8_1 142.555a
Cext_294 CTX_L30_0|CTX_L50_0 N 0.412084a
Cext_295 CTX_L30_0|CTX_L50_0 P 0.464968a
Cext_296 CTX_L30_0|CTX_L50_0 VSUBS 3.25102f
Cext_297 CTX_L30_1 CTX_L30_2 1.26652f
Cext_298 CTX_L30_1 CTX_L8_0 14.9294a
Cext_299 CTX_L30_1 CTX_L8_1 322.601a
Cext_300 CTX_L30_1 VSUBS 719.344a
Cext_301 CTX_L30_2 CTX_L30_3 279.622a
Cext_302 CTX_L30_2 CTX_L8_1 16.8702a
Cext_303 CTX_L30_2 VSUBS 482.488a
Cext_304 CTX_L30_3 CTX_L30_4 4.30617f
Cext_305 CTX_L30_3 CTX_L8_1 4.77902a
Cext_306 CTX_L30_3 CTX_L8_2 2.11758a
Cext_307 CTX_L30_3 VSUBS 425.208a
Cext_308 CTX_L30_4 CTX_L8_1 4.11579a
Cext_309 CTX_L30_4 CTX_L8_2 2.36811a
Cext_310 CTX_L30_4 P 4.30617f
Cext_311 CTX_L30_4 VSUBS 121.003a
Cext_312 CTX_L67_0 VSUBS 1.19673f
Cext_313 CTX_L8_0 CTX_L8_1 90.7469a
Cext_314 CTX_L8_0 VSUBS 1.76154f
Cext_315 CTX_L8_1 N 3.12869a
Cext_316 CTX_L8_1 P 3.57452a
Cext_317 CTX_L8_1 VSUBS 1.76154f
Cext_318 CTX_L8_15 CTX_L8_16 71.7828a
Cext_319 CTX_L8_15 VSUBS 506.087a
Cext_320 CTX_L8_16 CTX_L8_17 71.7828a
Cext_321 CTX_L8_16 VSUBS 282.276a
Cext_322 CTX_L8_17 CTX_L8_18 71.7828a
Cext_323 CTX_L8_17 VSUBS 282.276a
Cext_324 CTX_L8_18 CTX_L8_19 71.7828a
Cext_325 CTX_L8_18 VSUBS 282.276a
Cext_326 CTX_L8_19 CTX_L8_20 71.7828a
Cext_327 CTX_L8_19 VSUBS 282.276a
Cext_328 CTX_L8_2 N 3.0159a
Cext_329 CTX_L8_2 P 2.66389a
Cext_330 CTX_L8_2 VSUBS 1.77771f
Cext_331 CTX_L8_20 CTX_L8_21 71.7828a
Cext_332 CTX_L8_20 VSUBS 282.276a
Cext_333 CTX_L8_21 CTX_L8_22 23.0446a
Cext_334 CTX_L8_21 VSUBS 304.617a
Cext_335 CTX_L8_22 CTX_L8_23 49.8978a
Cext_336 CTX_L8_22 VSUBS 288.594a
Cext_337 CTX_L8_23 CTX_L8_24 1.07664f
Cext_338 CTX_L8_23 VSUBS 257.654a
Cext_339 CTX_L8_24 CTX_L8_25 274.031a
Cext_340 CTX_L8_24 VSUBS 267.748a
Cext_341 CTX_L8_25 CTX_L8_26 17.0703a
Cext_342 CTX_L8_25 VSUBS 257.597a
Cext_343 CTX_L8_26 CTX_L8_27 1.07664f
Cext_344 CTX_L8_26 VSUBS 249.462a
Cext_345 CTX_L8_27 CTX_L8_28 274.031a
Cext_346 CTX_L8_27 VSUBS 267.748a
Cext_347 CTX_L8_28 CTX_L8_29 1.07664f
Cext_348 CTX_L8_28 VSUBS 245.503a
Cext_349 CTX_L8_29 CTX_L8_30 274.031a
Cext_350 CTX_L8_29 VSUBS 267.748a
Cext_351 CTX_L8_30 VSUBS 497.404a
Cext_352 N P 4.30617f
Cext_353 N VSUBS 592.195a
Cext_354 P VSUBS 121.155a
.ENDS sense_fill_clip
