* actual_fill grounded drive N; diagnostic capacitor-network AC only
C83 0 N 1.53322e-16
C426 0 N 1.45823e-17
C427 0 P 1.7075400000000001e-17
C446 0 N 1.4717300000000001e-19
C447 0 P 1.6606000000000003e-19
C526 0 P 4.3061700000000003e-15
C556 0 N 8.6039100000000012e-19
C557 0 P 9.8299200000000014e-19
C628 0 N 8.2937200000000008e-19
C629 0 P 7.3256900000000007e-19
C700 0 N 3.9047600000000005e-18
C708 0 N 3.9047600000000005e-18
C715 0 N 2.4367100000000004e-18
C728 0 N 2.5083700000000002e-17
C741 0 N 2.5083700000000002e-17
C753 0 N 2.2647e-17
C811 0 N 1.9705400000000003e-17
C812 0 P 1.66709e-17
C819 0 N 1.5685400000000002e-16
C820 0 P 1.2561700000000001e-16
C828 0 N 1.5685400000000002e-16
C829 0 P 1.2561700000000001e-16
C837 0 N 1.5685400000000002e-16
C838 0 P 1.2561700000000001e-16
C845 0 N 1.3714800000000001e-16
C846 0 P 1.0894600000000001e-16
C852 0 N 3.7675999999999999e-18
C853 0 P 6.9818800000000003e-18
C859 0 N 3.7675999999999999e-18
C860 0 P 6.9818800000000003e-18
C904 0 N 3.7675999999999999e-18
C905 0 P 6.9818800000000003e-18
C909 0 N 1.5070400000000002e-19
C910 0 P 2.79275e-19
C919 0 N 1.9239000000000001e-16
C920 0 P 2.5466800000000001e-17
C928 0 N 1.9242800000000002e-16
C929 0 P 2.5466800000000001e-17
C936 0 N 1.9242800000000002e-16
C937 0 P 2.5466800000000001e-17
C941 0 N 9.1952900000000009e-18
C942 0 P 1.01867e-18
C955 0 N 1.6102600000000001e-18
C956 0 P 1.6102600000000001e-18
C961 0 N 3.2205200000000002e-18
C962 0 P 3.2205200000000002e-18
C991 0 N 3.2205200000000002e-18
C992 0 P 3.2205200000000002e-18
C1000 0 N 3.2205200000000002e-18
C1001 0 P 3.2205200000000002e-18
C1003 0 N 1.6102600000000001e-18
C1004 0 P 1.6102600000000001e-18
C1015 N P 4.3061700000000003e-15
C1016 N 0 3.5238800000000001e-16
C1017 P 0 4.5125100000000007e-17
VP P 0 DC 0 AC 0
VN N 0 DC 0 AC 1
.control
set numdgt=17
ac lin 1 1Meg 1Meg
let cp = -imag(i(VP))/(2*pi*1e6)
let cn = -imag(i(VN))/(2*pi*1e6)
print cp cn
quit
.endc
.end
