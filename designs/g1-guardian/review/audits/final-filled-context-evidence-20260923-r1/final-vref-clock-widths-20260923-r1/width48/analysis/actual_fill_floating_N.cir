* actual_fill floating drive N; diagnostic capacitor-network AC only
C27 0 FILL_L10_10 8.0871399999999996e-18
C28 0 FILL_L10_11 9.6188300000000023e-18
C29 0 FILL_L10_12 5.4174000000000002e-17
C30 0 FILL_L10_13 4.0249100000000003e-16
C31 0 FILL_L10_14 3.9816600000000005e-16
C32 0 FILL_L10_15 3.4831700000000005e-16
C33 0 FILL_L10_16 3.0692100000000003e-17
C34 0 FILL_L10_17 7.6644200000000007e-17
C35 0 FILL_L10_18 5.9046100000000005e-17
C36 0 FILL_L10_19 5.9122199999999998e-17
C37 0 FILL_L10_20 5.9150100000000004e-17
C38 0 FILL_L10_21 5.8939399999999999e-17
C39 0 FILL_L10_22 3.9110700000000006e-17
C40 0 FILL_L10_5 1.7043000000000001e-19
C41 0 FILL_L10_6 4.3977600000000001e-18
C42 0 FILL_L10_7 1.7544200000000003e-18
C43 0 FILL_L10_8 1.7544200000000003e-18
C44 0 FILL_L10_9 1.5037900000000001e-18
C45 0 FILL_L50_10 6.3048299999999999e-16
C46 0 FILL_L50_11 6.2608100000000005e-17
C47 0 FILL_L50_12 1.7534000000000001e-16
C48 0 FILL_L50_13 1.24982e-16
C49 0 FILL_L50_14 1.0706999999999999e-16
C50 0 FILL_L50_15 1.1599200000000001e-17
C51 0 FILL_L50_16 2.73754e-17
C52 0 FILL_L50_17 2.2916000000000003e-17
C53 0 FILL_L50_18 5.3875900000000008e-18
C54 0 FILL_L50_19 1.9775400000000004e-19
C55 0 FILL_L50_4 9.2559100000000008e-17
C56 0 FILL_L50_5 9.1138200000000004e-17
C57 0 FILL_L50_6 9.1138200000000004e-17
C58 0 FILL_L50_7 3.6455300000000004e-18
C59 0 FILL_L50_8 7.278510000000001e-16
C60 0 FILL_L50_9 6.4101500000000002e-16
C61 0 FILL_L8_1 1.0117000000000002e-18
C62 0 FILL_L8_10 5.5003100000000004e-19
C63 0 FILL_L8_11 5.5003100000000004e-19
C64 0 FILL_L8_12 5.5003100000000004e-19
C65 0 FILL_L8_13 2.7501600000000002e-19
C66 0 FILL_L8_14 3.8352500000000005e-18
C67 0 FILL_L8_15 3.06788e-17
C68 0 FILL_L8_16 6.7920699999999999e-17
C69 0 FILL_L8_17 1.1280200000000001e-17
C70 0 FILL_L8_18 1.1280200000000001e-17
C71 0 FILL_L8_19 1.1280200000000001e-17
C72 0 FILL_L8_2 3.0780400000000003e-19
C73 0 FILL_L8_20 1.1280200000000001e-17
C74 0 FILL_L8_21 1.1280200000000001e-17
C75 0 FILL_L8_22 7.4448999999999996e-18
C76 0 FILL_L8_3 3.0780400000000003e-19
C77 0 FILL_L8_4 3.0780400000000003e-19
C78 0 FILL_L8_5 1.8701100000000002e-19
C79 0 FILL_L8_6 2.0273700000000001e-18
C80 0 FILL_L8_7 2.0273700000000001e-18
C81 0 FILL_L8_8 5.5003100000000004e-19
C82 0 FILL_L8_9 5.5003100000000004e-19
C83 0 N 1.53322e-16
C110 0 FILL_L50_12 1.7263800000000002e-17
C111 0 FILL_L50_13 1.7550300000000001e-17
C112 0 FILL_L50_14 1.7550300000000001e-17
C113 0 FILL_L50_15 7.0201200000000002e-19
C114 0 FILL_L50_16 8.7394100000000002e-17
C115 0 FILL_L50_17 8.8056500000000009e-17
C116 0 FILL_L50_18 8.5475200000000012e-17
C117 0 FILL_L50_19 7.9195200000000011e-18
C145 0 FILL_L50_16 3.9293400000000004e-17
C146 0 FILL_L50_17 3.8763100000000003e-17
C147 0 FILL_L50_18 4.2775000000000002e-17
C148 0 FILL_L50_19 6.1139600000000002e-18
C174 0 FILL_L50_16 1.3206100000000001e-17
C175 0 FILL_L50_17 1.2186200000000001e-17
C176 0 FILL_L50_18 1.4338699999999999e-17
C177 0 FILL_L50_19 4.8397099999999999e-19
C205 0 FILL_L50_14 1.2029600000000001e-17
C206 0 FILL_L50_16 1.02014e-17
C207 0 FILL_L50_17 9.5502199999999997e-18
C208 0 FILL_L50_18 3.0434499999999999e-17
C209 0 FILL_L50_19 4.3410100000000006e-19
C234 0 FILL_L50_16 8.5231899999999997e-18
C235 0 FILL_L50_17 7.8884800000000013e-18
C236 0 FILL_L50_18 9.0672200000000016e-18
C237 0 FILL_L50_19 2.7201700000000001e-19
C260 0 FILL_L50_16 1.3122400000000002e-18
C261 0 FILL_L50_17 1.3162100000000001e-18
C262 0 FILL_L50_18 1.0624800000000003e-18
C270 0 FILL_L50_12 1.9775300000000001e-18
C271 0 FILL_L50_16 6.1865500000000004e-17
C280 0 FILL_L50_12 2.1952600000000001e-17
C281 0 FILL_L50_16 2.1844500000000002e-16
C290 0 FILL_L50_12 1.33769e-17
C291 0 FILL_L50_13 2.0172599999999999e-18
C292 0 FILL_L50_16 4.2154000000000005e-17
C293 0 FILL_L50_17 7.1681500000000002e-17
C304 0 FILL_L10_18 1.1489000000000001e-19
C305 0 FILL_L50_13 2.2375800000000004e-17
C306 0 FILL_L50_17 2.1164200000000001e-16
C307 0 FILL_L50_18 3.41105e-18
C321 0 FILL_L50_13 1.1288600000000002e-17
C322 0 FILL_L50_17 2.5691300000000001e-17
C323 0 FILL_L50_18 4.8514000000000005e-17
C324 0 FILL_L50_19 6.35929e-18
C344 0 FILL_L50_16 4.6999600000000004e-17
C345 0 FILL_L50_17 4.8757500000000003e-17
C346 0 FILL_L50_18 4.8514000000000005e-17
C347 0 FILL_L50_19 6.35929e-18
C361 0 FILL_L50_13 7.4663400000000006e-18
C362 0 FILL_L50_16 4.4687000000000003e-17
C363 0 FILL_L50_17 1.1294000000000002e-16
C364 0 FILL_L50_18 4.5953200000000008e-18
C375 0 FILL_L50_13 2.0543300000000003e-18
C376 0 FILL_L50_14 2.0543300000000003e-18
C377 0 FILL_L50_17 5.6617600000000004e-18
C378 0 FILL_L50_18 4.9541900000000003e-17
C379 0 FILL_L50_19 6.35929e-18
C388 0 FILL_L10_0 8.7060300000000009e-19
C389 0 FILL_L10_1 4.025280000000001e-18
C390 0 FILL_L10_2 1.4006299999999999e-17
C391 0 FILL_L10_3 1.4006299999999999e-17
C392 0 FILL_L10_4 1.26457e-17
C393 0 FILL_L50_0 2.4104199999999998e-18
C394 0 FILL_L50_1 7.1419700000000002e-18
C395 0 FILL_L50_2 7.1419700000000002e-18
C396 0 FILL_L50_3 2.8567900000000004e-19
C404 0 FILL_L10_0 1.8385200000000001e-18
C405 0 FILL_L10_1 4.8373499999999999e-18
C406 0 FILL_L10_12 1.2755000000000003e-18
C407 0 FILL_L10_13 3.7514800000000002e-18
C408 0 FILL_L10_14 7.5029700000000016e-18
C409 0 FILL_L10_15 7.5029700000000016e-18
C410 0 FILL_L10_2 1.3104400000000001e-17
C411 0 FILL_L10_3 1.5402500000000001e-17
C412 0 FILL_L10_4 1.4234e-17
C413 0 FILL_L10_5 3.9691200000000002e-18
C414 0 FILL_L10_6 1.8616700000000004e-17
C415 0 FILL_L10_7 2.49715e-17
C416 0 FILL_L10_8 3.1326400000000003e-17
C417 0 FILL_L10_9 2.9517900000000005e-17
C418 0 FILL_L50_0 9.9817700000000008e-17
C419 0 FILL_L50_1 1.00213e-16
C420 0 FILL_L50_2 1.00213e-16
C421 0 FILL_L50_3 7.5223199999999999e-18
C422 0 FILL_L50_4 4.5098100000000005e-17
C423 0 FILL_L50_5 4.5098100000000005e-17
C424 0 FILL_L50_6 4.5098100000000005e-17
C425 0 FILL_L50_7 1.8039300000000001e-18
C426 0 N 1.45823e-17
C427 0 P 1.7075400000000001e-17
C436 0 FILL_L10_0 4.6379700000000006e-17
C437 0 FILL_L10_1 3.6412200000000002e-16
C438 0 FILL_L10_2 3.0628500000000006e-16
C439 0 FILL_L10_3 3.0125700000000004e-16
C440 0 FILL_L10_4 2.63917e-16
C441 0 FILL_L10_5 4.3788100000000003e-19
C442 0 FILL_L50_0 1.2505300000000001e-16
C443 0 FILL_L50_1 3.6372900000000002e-17
C444 0 FILL_L50_2 3.6372900000000002e-17
C445 0 FILL_L50_3 1.4549200000000001e-18
C446 0 N 1.4717300000000001e-19
C447 0 P 1.6606000000000003e-19
C452 0 FILL_L10_0 1.16097e-16
C453 0 FILL_L10_1 7.3515800000000006e-16
C454 0 FILL_L10_2 7.3515800000000006e-16
C455 0 FILL_L10_3 7.3515800000000006e-16
C456 0 FILL_L10_4 6.1906100000000006e-16
C457 0 FILL_L50_0 5.51179e-16
C458 0 FILL_L50_1 5.52121e-16
C459 0 FILL_L50_2 5.52121e-16
C460 0 FILL_L50_3 5.9539500000000006e-17
C464 0 FILL_L10_0 8.0370500000000015e-18
C465 0 FILL_L10_1 8.2734399999999999e-17
C466 0 FILL_L10_2 8.2734399999999999e-17
C467 0 FILL_L10_3 8.2734399999999999e-17
C468 0 FILL_L10_4 7.4697300000000004e-17
C469 0 FILL_L10_5 3.9811300000000003e-18
C470 0 FILL_L10_6 4.1790900000000002e-17
C471 0 FILL_L10_7 4.1878000000000005e-17
C472 0 FILL_L10_8 4.1878000000000005e-17
C473 0 FILL_L10_9 3.7809800000000004e-17
C474 0 FILL_L50_0 2.8102900000000004e-16
C475 0 FILL_L50_1 2.8121800000000003e-16
C476 0 FILL_L50_2 2.8121800000000003e-16
C477 0 FILL_L50_3 1.8739600000000002e-17
C478 0 FILL_L8_0 1.74165e-19
C479 0 FILL_L8_1 3.1624699999999999e-18
C480 0 FILL_L8_2 3.2083100000000002e-18
C481 0 FILL_L8_3 3.2083100000000002e-18
C482 0 FILL_L8_4 2.8966400000000002e-18
C487 0 FILL_L10_5 2.6279499999999999e-17
C488 0 FILL_L10_6 2.24529e-16
C489 0 FILL_L10_7 2.24529e-16
C490 0 FILL_L10_8 2.24529e-16
C491 0 FILL_L10_9 1.98249e-16
C492 0 FILL_L50_0 8.9370199999999999e-17
C493 0 FILL_L50_1 8.9370199999999999e-17
C494 0 FILL_L50_2 8.9370199999999999e-17
C495 0 FILL_L50_3 3.5748100000000002e-18
C496 0 FILL_L50_4 8.7125700000000002e-18
C497 0 FILL_L50_5 8.7125700000000002e-18
C498 0 FILL_L50_6 8.7125700000000002e-18
C499 0 FILL_L50_7 3.4850300000000004e-19
C500 0 FILL_L8_0 1.6102600000000001e-18
C501 0 FILL_L8_1 3.2205200000000002e-18
C502 0 FILL_L8_2 3.2205200000000002e-18
C503 0 FILL_L8_3 3.2205200000000002e-18
C504 0 FILL_L8_4 1.6102600000000001e-18
C508 0 FILL_L10_5 1.66709e-17
C509 0 FILL_L10_6 1.2561700000000001e-16
C510 0 FILL_L10_7 1.2561700000000001e-16
C511 0 FILL_L10_8 1.2561700000000001e-16
C512 0 FILL_L10_9 1.0894600000000001e-16
C513 0 FILL_L50_0 1.1347200000000002e-17
C514 0 FILL_L50_1 1.1347200000000002e-17
C515 0 FILL_L50_2 1.1347200000000002e-17
C516 0 FILL_L50_3 4.5388800000000003e-19
C517 0 FILL_L50_4 1.46777e-17
C518 0 FILL_L50_5 1.46777e-17
C519 0 FILL_L50_6 1.46777e-17
C520 0 FILL_L50_7 5.8710600000000009e-19
C521 0 FILL_L8_0 1.6102600000000001e-18
C522 0 FILL_L8_1 3.2205200000000002e-18
C523 0 FILL_L8_2 3.2205200000000002e-18
C524 0 FILL_L8_3 3.2205200000000002e-18
C525 0 FILL_L8_4 1.6102600000000001e-18
C526 0 P 4.3061700000000003e-15
C530 0 FILL_L10_0 3.2134099999999999e-19
C531 0 FILL_L10_1 4.8986300000000003e-18
C532 0 FILL_L10_2 4.9696200000000004e-18
C533 0 FILL_L10_3 4.9696200000000004e-18
C534 0 FILL_L10_4 4.4868600000000006e-18
C535 0 FILL_L50_0 6.3848600000000001e-19
C536 0 FILL_L50_1 1.89181e-18
C537 0 FILL_L50_2 1.89181e-18
C539 0 FILL_L10_0 3.1640200000000002e-17
C540 0 FILL_L10_1 2.4544200000000003e-16
C541 0 FILL_L10_2 2.4544200000000003e-16
C542 0 FILL_L10_3 2.4544200000000003e-16
C543 0 FILL_L10_4 2.1380100000000001e-16
C544 0 FILL_L50_0 1.33239e-17
C545 0 FILL_L50_1 1.6394300000000002e-17
C546 0 FILL_L50_2 1.6394300000000002e-17
C547 0 FILL_L50_3 4.1185899999999999e-19
C548 0 FILL_L50_4 7.3015800000000006e-19
C549 0 FILL_L50_5 2.19047e-18
C550 0 FILL_L50_6 2.19047e-18
C551 0 FILL_L8_0 3.6687600000000003e-18
C552 0 FILL_L8_1 3.7766599999999997e-17
C553 0 FILL_L8_2 3.7766599999999997e-17
C554 0 FILL_L8_3 3.7766599999999997e-17
C555 0 FILL_L8_4 3.4097900000000004e-17
C556 0 N 8.6039100000000012e-19
C557 0 P 9.8299200000000014e-19
C560 0 FILL_L50_12 1.0219800000000002e-18
C561 0 FILL_L50_16 2.7184600000000001e-18
C564 0 FILL_L50_12 1.8773200000000003e-18
C565 0 FILL_L50_16 7.9909700000000009e-18
C568 0 FILL_L50_12 7.0567200000000014e-18
C569 0 FILL_L50_16 2.0185400000000004e-17
C572 0 FILL_L50_12 7.0567200000000014e-18
C573 0 FILL_L50_16 2.0381000000000003e-17
C576 0 FILL_L50_12 1.2316700000000002e-18
C577 0 FILL_L50_13 1.0481100000000002e-18
C578 0 FILL_L50_16 7.1115900000000002e-18
C579 0 FILL_L50_17 2.7879800000000002e-18
C581 0 FILL_L10_10 7.4845200000000004e-19
C582 0 FILL_L10_11 6.5863800000000004e-19
C583 0 FILL_L10_12 1.05178e-17
C584 0 FILL_L10_13 1.10466e-16
C585 0 FILL_L10_14 1.10466e-16
C586 0 FILL_L10_15 9.9948099999999999e-17
C587 0 FILL_L10_16 1.18136e-18
C588 0 FILL_L10_17 3.4745800000000005e-18
C589 0 FILL_L10_18 3.4745800000000005e-18
C590 0 FILL_L10_19 3.4745800000000005e-18
C591 0 FILL_L10_20 3.4745800000000005e-18
C592 0 FILL_L10_21 3.4745800000000005e-18
C593 0 FILL_L10_22 2.2932200000000001e-18
C594 0 FILL_L10_6 3.0675900000000001e-19
C595 0 FILL_L50_1 2.18921e-19
C596 0 FILL_L50_10 1.21962e-17
C597 0 FILL_L50_12 1.64573e-18
C598 0 FILL_L50_13 2.6095200000000001e-18
C599 0 FILL_L50_14 1.8184800000000001e-18
C600 0 FILL_L50_2 2.18921e-19
C601 0 FILL_L50_4 1.5811400000000002e-17
C602 0 FILL_L50_5 1.1734700000000001e-17
C603 0 FILL_L50_6 9.9548100000000001e-18
C604 0 FILL_L50_8 1.14644e-17
C605 0 FILL_L50_9 1.8294200000000002e-17
C606 0 FILL_L8_1 8.348340000000001e-18
C607 0 FILL_L8_10 1.0790500000000001e-17
C608 0 FILL_L8_11 1.0790500000000001e-17
C609 0 FILL_L8_12 1.0790500000000001e-17
C610 0 FILL_L8_13 7.1216999999999996e-18
C611 0 FILL_L8_14 1.0145300000000001e-17
C612 0 FILL_L8_15 2.9839000000000003e-17
C613 0 FILL_L8_16 2.9839000000000003e-17
C614 0 FILL_L8_17 2.9839000000000003e-17
C615 0 FILL_L8_18 2.9839000000000003e-17
C616 0 FILL_L8_19 2.9839000000000003e-17
C617 0 FILL_L8_2 8.348340000000001e-18
C618 0 FILL_L8_20 2.9839000000000003e-17
C619 0 FILL_L8_21 2.9839000000000003e-17
C620 0 FILL_L8_22 1.9693800000000002e-17
C621 0 FILL_L8_3 8.348340000000001e-18
C622 0 FILL_L8_4 8.348340000000001e-18
C623 0 FILL_L8_5 3.6687600000000003e-18
C624 0 FILL_L8_6 1.0790500000000001e-17
C625 0 FILL_L8_7 1.0790500000000001e-17
C626 0 FILL_L8_8 1.0790500000000001e-17
C627 0 FILL_L8_9 1.0790500000000001e-17
C628 0 N 8.2937200000000008e-19
C629 0 P 7.3256900000000007e-19
C632 0 FILL_L50_12 7.2457300000000007e-19
C633 0 FILL_L50_13 3.0918500000000002e-18
C634 0 FILL_L50_16 2.0577899999999998e-18
C635 0 FILL_L50_17 1.0077000000000001e-17
C638 0 FILL_L50_13 7.0567200000000014e-18
C639 0 FILL_L50_17 2.1026500000000001e-17
C642 0 FILL_L50_13 1.2206500000000001e-18
C643 0 FILL_L50_14 1.0735500000000002e-18
C644 0 FILL_L50_17 7.4399100000000013e-18
C645 0 FILL_L50_18 3.04887e-18
C648 0 FILL_L50_14 6.0063100000000007e-18
C649 0 FILL_L50_18 1.2018700000000002e-17
C652 0 FILL_L50_14 1.1506500000000001e-17
C653 0 FILL_L50_18 1.9819300000000001e-17
C656 0 FILL_L50_14 7.887130000000001e-18
C657 0 FILL_L50_18 1.9284700000000003e-17
C660 0 FILL_L50_14 7.887130000000001e-18
C661 0 FILL_L50_18 1.9284700000000003e-17
C664 0 FILL_L10_21 1.1489000000000001e-19
C665 0 FILL_L50_14 1.09285e-17
C666 0 FILL_L50_18 1.4922700000000001e-17
C669 0 FILL_L50_14 1.6825500000000001e-18
C670 0 FILL_L50_15 1.0980700000000002e-18
C671 0 FILL_L50_18 5.7554300000000002e-18
C672 0 FILL_L50_19 2.92087e-18
C675 0 FILL_L50_14 2.0172599999999999e-18
C676 0 FILL_L50_15 2.25915e-18
C677 0 FILL_L50_18 3.0958400000000002e-18
C678 0 FILL_L50_19 3.7081600000000003e-18
C680 0 FILL_L50_15 1.6449300000000002e-18
C681 0 FILL_L50_19 2.7403e-18
C683 FILL_L10_0 FILL_L10_1 9.7773300000000019e-17
C684 FILL_L10_0 FILL_L10_5 9.4979800000000004e-18
C685 FILL_L10_0 FILL_L50_0 1.3701000000000001e-18
C686 FILL_L10_0 FILL_L8_0 1.38235e-18
C687 FILL_L10_0 0 2.0358300000000002e-16
C688 FILL_L10_1 FILL_L10_2 9.7773300000000019e-17
C689 FILL_L10_1 FILL_L10_6 9.7773300000000019e-17
C690 FILL_L10_1 FILL_L50_0 8.2701899999999996e-17
C691 FILL_L10_1 FILL_L8_1 1.4230000000000002e-17
C692 FILL_L10_1 0 4.6531099999999998e-16
C693 FILL_L10_10 FILL_L10_11 2.7935199999999999e-17
C694 FILL_L10_10 FILL_L10_12 2.7935199999999999e-17
C695 FILL_L10_10 FILL_L10_6 2.7935199999999999e-17
C696 FILL_L10_10 FILL_L50_4 5.1245500000000004e-17
C697 FILL_L10_10 FILL_L50_8 3.3484600000000006e-18
C698 FILL_L10_10 FILL_L8_15 1.2124200000000001e-18
C699 FILL_L10_10 FILL_L8_6 6.7224999999999998e-17
C700 FILL_L10_10 N 3.9047600000000005e-18
C701 FILL_L10_10 0 7.2775499999999993e-17
C702 FILL_L10_11 FILL_L10_13 2.7935199999999999e-17
C703 FILL_L10_11 FILL_L10_6 2.7935199999999999e-17
C704 FILL_L10_11 FILL_L50_4 5.5127700000000003e-17
C705 FILL_L10_11 FILL_L50_8 2.94665e-18
C706 FILL_L10_11 FILL_L8_16 1.0669300000000001e-18
C707 FILL_L10_11 FILL_L8_7 6.7224999999999998e-17
C708 FILL_L10_11 N 3.9047600000000005e-18
C709 FILL_L10_11 0 7.171500000000001e-17
C710 FILL_L10_12 FILL_L10_13 1.5842400000000001e-17
C711 FILL_L10_12 FILL_L10_16 9.4979800000000004e-18
C712 FILL_L10_12 FILL_L10_5 9.4979800000000004e-18
C713 FILL_L10_12 FILL_L50_4 1.5556100000000003e-17
C714 FILL_L10_12 FILL_L8_5 3.2017099999999999e-17
C715 FILL_L10_12 N 2.4367100000000004e-18
C716 FILL_L10_12 0 2.4204700000000001e-16
C717 FILL_L10_13 FILL_L10_14 9.7773300000000019e-17
C718 FILL_L10_13 FILL_L10_17 2.7935199999999999e-17
C719 FILL_L10_13 FILL_L10_18 2.7935199999999999e-17
C720 FILL_L10_13 FILL_L10_7 9.7773300000000019e-17
C721 FILL_L10_13 FILL_L50_13 1.46674e-18
C722 FILL_L10_13 FILL_L50_4 3.2842900000000003e-17
C723 FILL_L10_13 FILL_L50_5 2.16433e-16
C724 FILL_L10_13 FILL_L50_9 3.5007500000000001e-17
C725 FILL_L10_13 FILL_L8_2 9.8589300000000015e-18
C726 FILL_L10_13 FILL_L8_8 1.1751300000000001e-16
C727 FILL_L10_13 FILL_L8_9 1.1751300000000001e-16
C728 FILL_L10_13 N 2.5083700000000002e-17
C729 FILL_L10_13 0 4.5146100000000006e-16
C730 FILL_L10_14 FILL_L10_15 9.7773300000000019e-17
C731 FILL_L10_14 FILL_L10_19 2.7935199999999999e-17
C732 FILL_L10_14 FILL_L10_20 2.7935199999999999e-17
C733 FILL_L10_14 FILL_L10_8 9.7773300000000019e-17
C734 FILL_L10_14 FILL_L50_10 1.7475500000000002e-17
C735 FILL_L10_14 FILL_L50_14 4.8891300000000006e-19
C736 FILL_L10_14 FILL_L50_5 6.2229199999999999e-17
C737 FILL_L10_14 FILL_L50_6 1.65203e-16
C738 FILL_L10_14 FILL_L8_10 1.1751300000000001e-16
C739 FILL_L10_14 FILL_L8_11 1.1751300000000001e-16
C740 FILL_L10_14 FILL_L8_3 9.8589300000000015e-18
C741 FILL_L10_14 N 2.5083700000000002e-17
C742 FILL_L10_14 0 4.0435800000000004e-16
C743 FILL_L10_15 FILL_L10_21 2.7935199999999999e-17
C744 FILL_L10_15 FILL_L10_22 1.8437300000000003e-17
C745 FILL_L10_15 FILL_L10_9 8.8275400000000016e-17
C746 FILL_L10_15 FILL_L50_10 8.7095400000000018e-18
C747 FILL_L10_15 FILL_L50_11 1.3935300000000001e-18
C748 FILL_L10_15 FILL_L50_6 1.3087799999999998e-16
C749 FILL_L10_15 FILL_L50_7 5.2490100000000004e-17
C750 FILL_L10_15 FILL_L8_12 1.1751300000000001e-16
C751 FILL_L10_15 FILL_L8_13 8.54956e-17
C752 FILL_L10_15 FILL_L8_4 9.8589300000000015e-18
C753 FILL_L10_15 N 2.2647e-17
C754 FILL_L10_15 0 4.5299900000000005e-16
C755 FILL_L10_16 FILL_L50_8 1.05291e-17
C756 FILL_L10_16 FILL_L8_14 2.2856500000000002e-17
C757 FILL_L10_16 FILL_L8_15 5.7366599999999999e-18
C758 FILL_L10_16 0 7.0314899999999996e-17
C759 FILL_L10_17 FILL_L10_18 2.7935199999999999e-17
C760 FILL_L10_17 FILL_L50_8 1.55454e-17
C761 FILL_L10_17 FILL_L50_9 2.2405100000000001e-17
C762 FILL_L10_17 FILL_L8_16 5.2766700000000006e-18
C763 FILL_L10_17 FILL_L8_17 6.7224999999999998e-17
C764 FILL_L10_17 0 7.3179900000000006e-17
C765 FILL_L10_18 FILL_L10_19 2.7935199999999999e-17
C766 FILL_L10_18 FILL_L50_13 3.95711e-18
C767 FILL_L10_18 FILL_L50_9 5.6597300000000003e-17
C768 FILL_L10_18 FILL_L8_18 6.7224999999999998e-17
C769 FILL_L10_18 0 7.3275300000000013e-17
C770 FILL_L10_19 FILL_L10_20 2.7935199999999999e-17
C771 FILL_L10_19 FILL_L50_10 1.1670500000000001e-17
C772 FILL_L10_19 FILL_L50_9 2.2405100000000001e-17
C773 FILL_L10_19 FILL_L8_19 6.7224999999999998e-17
C774 FILL_L10_19 0 7.3182800000000002e-17
C775 FILL_L10_2 FILL_L10_3 9.7773300000000019e-17
C776 FILL_L10_2 FILL_L10_7 9.7773300000000019e-17
C777 FILL_L10_2 FILL_L50_0 5.8352700000000008e-18
C778 FILL_L10_2 FILL_L50_1 7.7306600000000014e-17
C779 FILL_L10_2 FILL_L8_2 1.4230000000000002e-17
C780 FILL_L10_2 0 4.6531099999999998e-16
C781 FILL_L10_20 FILL_L10_21 2.7935199999999999e-17
C782 FILL_L10_20 FILL_L50_10 5.0118000000000004e-17
C783 FILL_L10_20 FILL_L50_14 3.95711e-18
C784 FILL_L10_20 FILL_L8_20 6.7224999999999998e-17
C785 FILL_L10_20 0 7.3181700000000015e-17
C786 FILL_L10_21 FILL_L10_22 2.7935199999999999e-17
C787 FILL_L10_21 FILL_L50_10 4.6235799999999999e-17
C788 FILL_L10_21 FILL_L50_14 3.95711e-18
C789 FILL_L10_21 FILL_L8_21 6.7224999999999998e-17
C790 FILL_L10_21 0 7.3405500000000003e-17
C791 FILL_L10_22 FILL_L50_10 3.8908000000000001e-18
C792 FILL_L10_22 FILL_L50_11 1.2057800000000001e-17
C793 FILL_L10_22 FILL_L50_15 6.3313699999999997e-19
C794 FILL_L10_22 FILL_L8_22 4.4368499999999999e-17
C795 FILL_L10_22 0 7.845260000000001e-17
C796 FILL_L10_3 FILL_L10_4 9.7773300000000019e-17
C797 FILL_L10_3 FILL_L10_8 9.7773300000000019e-17
C798 FILL_L10_3 FILL_L50_1 1.55573e-17
C799 FILL_L10_3 FILL_L50_2 5.5219700000000005e-17
C800 FILL_L10_3 FILL_L8_3 1.4230000000000002e-17
C801 FILL_L10_3 0 4.6531099999999998e-16
C802 FILL_L10_4 FILL_L10_9 8.8275400000000016e-17
C803 FILL_L10_4 FILL_L50_2 4.1998899999999999e-17
C804 FILL_L10_4 FILL_L50_3 1.46072e-17
C805 FILL_L10_4 FILL_L8_4 1.2847700000000001e-17
C806 FILL_L10_4 0 5.0531500000000001e-16
C807 FILL_L10_5 FILL_L10_6 9.7773300000000019e-17
C808 FILL_L10_5 FILL_L50_0 2.7402000000000003e-18
C809 FILL_L10_5 FILL_L50_4 1.2604900000000002e-18
C810 FILL_L10_5 FILL_L8_0 7.9997700000000001e-17
C811 FILL_L10_5 N 1.9705400000000003e-17
C812 FILL_L10_5 P 1.66709e-17
C813 FILL_L10_5 0 1.8037899999999999e-16
C814 FILL_L10_6 FILL_L10_7 9.7773300000000019e-17
C815 FILL_L10_6 FILL_L50_0 1.6415400000000001e-16
C816 FILL_L10_6 FILL_L50_4 1.28456e-16
C817 FILL_L10_6 FILL_L50_8 1.3494000000000001e-18
C818 FILL_L10_6 FILL_L8_1 8.2350600000000007e-16
C819 FILL_L10_6 N 1.5685400000000002e-16
C820 FILL_L10_6 P 1.2561700000000001e-16
C821 FILL_L10_6 0 2.2611200000000002e-16
C822 FILL_L10_7 FILL_L10_8 9.7773300000000019e-17
C823 FILL_L10_7 FILL_L50_0 1.1670500000000001e-17
C824 FILL_L10_7 FILL_L50_1 1.3691200000000002e-16
C825 FILL_L10_7 FILL_L50_4 5.3684500000000009e-18
C826 FILL_L10_7 FILL_L50_5 9.3263200000000002e-17
C827 FILL_L10_7 FILL_L8_2 8.2350600000000007e-16
C828 FILL_L10_7 N 1.5685400000000002e-16
C829 FILL_L10_7 P 1.2561700000000001e-16
C830 FILL_L10_7 0 1.9621900000000002e-16
C831 FILL_L10_8 FILL_L10_9 9.7773300000000019e-17
C832 FILL_L10_8 FILL_L50_1 3.1114599999999999e-17
C833 FILL_L10_8 FILL_L50_2 9.9819000000000008e-17
C834 FILL_L10_8 FILL_L50_5 1.4312699999999999e-17
C835 FILL_L10_8 FILL_L50_6 6.4086900000000001e-17
C836 FILL_L10_8 FILL_L8_3 8.2350600000000007e-16
C837 FILL_L10_8 N 1.5685400000000002e-16
C838 FILL_L10_8 P 1.2561700000000001e-16
C839 FILL_L10_8 0 1.9621900000000002e-16
C840 FILL_L10_9 FILL_L50_2 7.6917500000000007e-17
C841 FILL_L10_9 FILL_L50_3 2.8081600000000006e-17
C842 FILL_L10_9 FILL_L50_6 4.7495500000000004e-17
C843 FILL_L10_9 FILL_L50_7 1.48557e-17
C844 FILL_L10_9 FILL_L8_4 7.4350800000000009e-16
C845 FILL_L10_9 N 1.3714800000000001e-16
C846 FILL_L10_9 P 1.0894600000000001e-16
C847 FILL_L10_9 0 2.5942700000000005e-16
C848 FILL_L50_0 FILL_L50_1 9.8854299999999996e-17
C849 FILL_L50_0 FILL_L50_4 9.8854299999999996e-17
C850 FILL_L50_0 FILL_L8_1 1.4570800000000003e-17
C851 FILL_L50_0 FILL_L8_2 1.3407600000000001e-18
C852 FILL_L50_0 N 3.7675999999999999e-18
C853 FILL_L50_0 P 6.9818800000000003e-18
C854 FILL_L50_0 0 1.9123600000000001e-16
C855 FILL_L50_1 FILL_L50_2 9.8854299999999996e-17
C856 FILL_L50_1 FILL_L50_5 9.8854299999999996e-17
C857 FILL_L50_1 FILL_L8_2 1.3629e-17
C858 FILL_L50_1 FILL_L8_3 4.2766800000000003e-18
C859 FILL_L50_1 N 3.7675999999999999e-18
C860 FILL_L50_1 P 6.9818800000000003e-18
C861 FILL_L50_1 0 1.4345400000000001e-16
C862 FILL_L50_10 FILL_L50_11 9.8854299999999996e-17
C863 FILL_L50_10 FILL_L50_14 9.8854299999999996e-17
C864 FILL_L50_10 FILL_L50_6 9.8854299999999996e-17
C865 FILL_L50_10 FILL_L50_9 9.8854299999999996e-17
C866 FILL_L50_10 FILL_L8_19 1.3407600000000001e-18
C867 FILL_L50_10 FILL_L8_20 1.12638e-17
C868 FILL_L50_10 FILL_L8_21 9.7681700000000009e-18
C869 FILL_L50_10 0 1.93545e-16
C870 FILL_L50_11 FILL_L50_15 3.9541700000000001e-18
C871 FILL_L50_11 FILL_L50_7 3.9541700000000001e-18
C872 FILL_L50_11 FILL_L8_22 8.7863800000000002e-19
C873 FILL_L50_11 0 1.4936200000000001e-16
C874 FILL_L50_12 FILL_L50_13 9.8854299999999996e-17
C875 FILL_L50_12 FILL_L50_16 9.8854299999999996e-17
C876 FILL_L50_12 FILL_L50_8 9.8854299999999996e-17
C877 FILL_L50_12 FILL_L8_15 1.4222400000000001e-18
C878 FILL_L50_12 FILL_L8_16 1.3314500000000001e-18
C879 FILL_L50_12 0 3.1832300000000002e-16
C880 FILL_L50_13 FILL_L50_14 9.8854299999999996e-17
C881 FILL_L50_13 FILL_L50_17 9.8854299999999996e-17
C882 FILL_L50_13 FILL_L50_9 9.8854299999999996e-17
C883 FILL_L50_13 FILL_L8_18 1.5130200000000002e-18
C884 FILL_L50_13 0 2.5141500000000001e-16
C885 FILL_L50_14 FILL_L50_15 9.8854299999999996e-17
C886 FILL_L50_14 FILL_L50_18 9.8854299999999996e-17
C887 FILL_L50_14 FILL_L8_20 1.5130200000000002e-18
C888 FILL_L50_14 FILL_L8_21 1.4222400000000001e-18
C889 FILL_L50_14 0 2.54667e-16
C890 FILL_L50_15 FILL_L50_19 3.9541700000000001e-18
C891 FILL_L50_15 FILL_L8_22 1.8156200000000002e-19
C892 FILL_L50_15 0 1.5722300000000002e-16
C893 FILL_L50_16 FILL_L50_17 9.8854299999999996e-17
C894 FILL_L50_16 0 3.2108900000000004e-16
C895 FILL_L50_17 FILL_L50_18 9.8854299999999996e-17
C896 FILL_L50_17 0 2.5012400000000003e-16
C897 FILL_L50_18 FILL_L50_19 9.8854299999999996e-17
C898 FILL_L50_18 0 2.5171900000000001e-16
C899 FILL_L50_19 0 1.4858500000000003e-16
C900 FILL_L50_2 FILL_L50_3 9.8854299999999996e-17
C901 FILL_L50_2 FILL_L50_6 9.8854299999999996e-17
C902 FILL_L50_2 FILL_L8_3 9.8880900000000008e-18
C903 FILL_L50_2 FILL_L8_4 8.0176200000000022e-18
C904 FILL_L50_2 N 3.7675999999999999e-18
C905 FILL_L50_2 P 6.9818800000000003e-18
C906 FILL_L50_2 0 1.3589e-16
C907 FILL_L50_3 FILL_L50_7 3.9541700000000001e-18
C908 FILL_L50_3 FILL_L8_4 5.4038800000000001e-19
C909 FILL_L50_3 N 1.5070400000000002e-19
C910 FILL_L50_3 P 2.79275e-19
C911 FILL_L50_3 0 1.3281100000000002e-16
C912 FILL_L50_4 FILL_L50_5 9.8854299999999996e-17
C913 FILL_L50_4 FILL_L50_8 9.8854299999999996e-17
C914 FILL_L50_4 FILL_L8_1 2.1758000000000001e-17
C915 FILL_L50_4 FILL_L8_2 6.16752e-19
C916 FILL_L50_4 FILL_L8_6 1.1489300000000001e-17
C917 FILL_L50_4 FILL_L8_7 1.2985e-17
C918 FILL_L50_4 FILL_L8_8 1.3407600000000001e-18
C919 FILL_L50_4 N 1.9239000000000001e-16
C920 FILL_L50_4 P 2.5466800000000001e-17
C921 FILL_L50_4 0 2.74645e-16
C922 FILL_L50_5 FILL_L50_6 9.8854299999999996e-17
C923 FILL_L50_5 FILL_L50_9 9.8854299999999996e-17
C924 FILL_L50_5 FILL_L8_10 4.2766800000000003e-18
C925 FILL_L50_5 FILL_L8_2 1.2659000000000002e-17
C926 FILL_L50_5 FILL_L8_3 1.9672700000000003e-18
C927 FILL_L50_5 FILL_L8_9 8.5533600000000005e-18
C928 FILL_L50_5 N 1.9242800000000002e-16
C929 FILL_L50_5 P 2.5466800000000001e-17
C930 FILL_L50_5 0 1.4791800000000001e-16
C931 FILL_L50_6 FILL_L50_7 9.8854299999999996e-17
C932 FILL_L50_6 FILL_L8_11 8.5533600000000005e-18
C933 FILL_L50_6 FILL_L8_12 8.5533600000000005e-18
C934 FILL_L50_6 FILL_L8_3 8.382300000000002e-18
C935 FILL_L50_6 FILL_L8_4 6.2439600000000011e-18
C936 FILL_L50_6 N 1.9242800000000002e-16
C937 FILL_L50_6 P 2.5466800000000001e-17
C938 FILL_L50_6 0 1.3551400000000003e-16
C939 FILL_L50_7 FILL_L8_13 6.842690000000001e-19
C940 FILL_L50_7 FILL_L8_4 6.842690000000001e-19
C941 FILL_L50_7 N 9.1952900000000009e-18
C942 FILL_L50_7 P 1.01867e-18
C943 FILL_L50_7 0 1.3408099999999999e-16
C944 FILL_L50_8 FILL_L50_9 9.8854299999999996e-17
C945 FILL_L50_8 FILL_L8_15 2.3419200000000002e-17
C946 FILL_L50_8 FILL_L8_16 2.2530300000000001e-17
C947 FILL_L50_8 FILL_L8_17 1.3407600000000001e-18
C948 FILL_L50_8 0 2.7457799999999998e-16
C949 FILL_L50_9 FILL_L8_17 4.2766800000000003e-18
C950 FILL_L50_9 FILL_L8_18 1.4044800000000001e-17
C951 FILL_L50_9 FILL_L8_19 4.2766800000000003e-18
C952 FILL_L50_9 0 1.9928300000000001e-16
C953 FILL_L8_0 FILL_L8_1 6.96968e-17
C954 FILL_L8_0 FILL_L8_5 6.7705500000000005e-18
C955 FILL_L8_0 N 1.6102600000000001e-18
C956 FILL_L8_0 P 1.6102600000000001e-18
C957 FILL_L8_0 0 2.7902700000000002e-16
C958 FILL_L8_1 FILL_L8_2 6.96968e-17
C959 FILL_L8_1 FILL_L8_6 1.9913400000000001e-17
C960 FILL_L8_1 FILL_L8_7 1.9913400000000001e-17
C961 FILL_L8_1 N 3.2205200000000002e-18
C962 FILL_L8_1 P 3.2205200000000002e-18
C963 FILL_L8_1 0 7.9950800000000011e-16
C964 FILL_L8_10 FILL_L8_11 1.9913400000000001e-17
C965 FILL_L8_10 FILL_L8_3 1.9913400000000001e-17
C966 FILL_L8_10 FILL_L8_9 1.9913400000000001e-17
C967 FILL_L8_10 0 1.34885e-16
C968 FILL_L8_11 FILL_L8_12 1.9913400000000001e-17
C969 FILL_L8_11 FILL_L8_3 1.9913400000000001e-17
C970 FILL_L8_11 0 1.34885e-16
C971 FILL_L8_12 FILL_L8_13 1.9913400000000001e-17
C972 FILL_L8_12 FILL_L8_4 1.9913400000000001e-17
C973 FILL_L8_12 0 1.34885e-16
C974 FILL_L8_13 FILL_L8_4 1.3142800000000001e-17
C975 FILL_L8_13 0 1.2124900000000001e-16
C976 FILL_L8_14 FILL_L8_15 1.9913400000000001e-17
C977 FILL_L8_14 0 9.3122700000000004e-17
C978 FILL_L8_15 FILL_L8_16 1.9913400000000001e-17
C979 FILL_L8_15 0 1.3581800000000002e-16
C980 FILL_L8_16 FILL_L8_17 1.9913400000000001e-17
C981 FILL_L8_16 0 1.3581800000000002e-16
C982 FILL_L8_17 FILL_L8_18 1.9913400000000001e-17
C983 FILL_L8_17 0 1.3581800000000002e-16
C984 FILL_L8_18 FILL_L8_19 1.9913400000000001e-17
C985 FILL_L8_18 0 1.3581800000000002e-16
C986 FILL_L8_19 FILL_L8_20 1.9913400000000001e-17
C987 FILL_L8_19 0 1.3581800000000002e-16
C988 FILL_L8_2 FILL_L8_3 6.96968e-17
C989 FILL_L8_2 FILL_L8_8 1.9913400000000001e-17
C990 FILL_L8_2 FILL_L8_9 1.9913400000000001e-17
C991 FILL_L8_2 N 3.2205200000000002e-18
C992 FILL_L8_2 P 3.2205200000000002e-18
C993 FILL_L8_2 0 7.9950800000000011e-16
C994 FILL_L8_20 FILL_L8_21 1.9913400000000001e-17
C995 FILL_L8_20 0 1.3581800000000002e-16
C996 FILL_L8_21 FILL_L8_22 1.9913400000000001e-17
C997 FILL_L8_21 0 1.3581800000000002e-16
C998 FILL_L8_22 0 1.2186500000000001e-16
C999 FILL_L8_3 FILL_L8_4 6.96968e-17
C1000 FILL_L8_3 N 3.2205200000000002e-18
C1001 FILL_L8_3 P 3.2205200000000002e-18
C1002 FILL_L8_3 0 7.9950800000000011e-16
C1003 FILL_L8_4 N 1.6102600000000001e-18
C1004 FILL_L8_4 P 1.6102600000000001e-18
C1005 FILL_L8_4 0 7.9757500000000015e-16
C1006 FILL_L8_5 FILL_L8_6 1.9913400000000001e-17
C1007 FILL_L8_5 0 9.2805300000000006e-17
C1008 FILL_L8_6 FILL_L8_7 1.9913400000000001e-17
C1009 FILL_L8_6 0 1.34885e-16
C1010 FILL_L8_7 FILL_L8_8 1.9913400000000001e-17
C1011 FILL_L8_7 0 1.34885e-16
C1012 FILL_L8_8 FILL_L8_9 1.9913400000000001e-17
C1013 FILL_L8_8 0 1.34885e-16
C1014 FILL_L8_9 0 1.34885e-16
C1015 N P 4.3061700000000003e-15
C1016 N 0 3.5238800000000001e-16
C1017 P 0 4.5125100000000007e-17
VP P 0 DC 0 AC 0
VN N 0 DC 0 AC 1
.control
set numdgt=17
ac lin 1 1Meg 1Meg
let cp = -imag(i(VP))/(2*pi*1e6)
let cn = -imag(i(VN))/(2*pi*1e6)
print cp cn
quit
.endc
.end
