* no_fill grounded drive N; diagnostic capacitor-network AC only
C7 0 N 1.5193400000000001e-17
C8 0 P 1.8661900000000002e-19
C22 0 N 8.6524400000000008e-17
C23 0 P 6.3260600000000007e-17
C40 0 N 6.0237900000000001e-19
C41 0 P 6.8418500000000009e-19
C57 0 N 1.7918500000000002e-17
C58 0 P 2.1505600000000004e-17
C71 0 N 3.1245100000000003e-17
C72 0 P 8.6723000000000012e-18
C86 0 N 4.0606000000000007e-17
C87 0 P 1.5622000000000002e-17
C128 0 N 2.4822100000000004e-16
C129 0 P 1.0517e-16
C144 0 P 3.4877500000000003e-15
C147 0 N 9.7328200000000006e-18
C148 0 P 5.0729799999999999e-17
C150 N P 3.4877500000000003e-15
C151 N 0 4.5861099999999999e-16
C152 P 0 5.7605600000000004e-17
VP P 0 DC 0 AC 0
VN N 0 DC 0 AC 1
.control
set numdgt=17
ac lin 1 1Meg 1Meg
let cp = -imag(i(VP))/(2*pi*1e6)
let cn = -imag(i(VN))/(2*pi*1e6)
print cp cn
quit
.endc
.end
