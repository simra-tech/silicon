* actual_fill floating drive N; diagnostic capacitor-network AC only
C1 0 FILL_L10_0 5.5222000000000006e-18
C2 0 FILL_L10_1 2.0268600000000002e-18
C3 0 FILL_L10_10 2.1446500000000001e-17
C4 0 FILL_L10_11 7.6466700000000003e-17
C5 0 FILL_L10_12 4.7541900000000001e-17
C6 0 FILL_L10_13 2.7826899999999998e-17
C7 0 FILL_L10_14 6.7818800000000005e-17
C8 0 FILL_L10_2 9.7826500000000009e-18
C9 0 FILL_L10_3 5.9933100000000004e-17
C10 0 FILL_L10_4 3.4743000000000007e-17
C11 0 FILL_L10_5 8.2003200000000017e-17
C12 0 FILL_L10_6 4.8389200000000004e-17
C13 0 FILL_L10_7 2.6335800000000001e-17
C14 0 FILL_L10_8 8.08684e-17
C15 0 FILL_L10_9 4.1520200000000008e-17
C16 0 FILL_L30_0 3.3841600000000003e-18
C17 0 FILL_L30_1 4.1498900000000003e-17
C18 0 FILL_L30_10 1.5336100000000001e-16
C19 0 FILL_L30_11 3.3841600000000003e-18
C20 0 FILL_L30_12 3.3841600000000003e-18
C21 0 FILL_L30_13 2.8216200000000006e-17
C22 0 FILL_L30_14 7.668040000000001e-17
C23 0 FILL_L30_2 1.4029400000000003e-16
C24 0 FILL_L30_3 3.3841600000000003e-18
C25 0 FILL_L30_4 3.3841600000000003e-18
C26 0 FILL_L30_5 5.6432500000000005e-17
C27 0 FILL_L30_6 1.5336100000000001e-16
C28 0 FILL_L30_7 3.3841600000000003e-18
C29 0 FILL_L30_8 3.3841600000000003e-18
C30 0 FILL_L30_9 5.6432500000000005e-17
C31 0 FILL_L50_0 1.8184500000000001e-17
C32 0 FILL_L50_1 2.2647600000000001e-16
C33 0 FILL_L50_10 1.2606200000000001e-16
C34 0 FILL_L50_2 1.8184500000000001e-17
C35 0 FILL_L50_3 1.8184500000000001e-17
C36 0 FILL_L50_4 2.5212500000000003e-16
C37 0 FILL_L50_5 1.8184500000000001e-17
C38 0 FILL_L50_6 1.8184500000000001e-17
C39 0 FILL_L50_7 2.5212500000000003e-16
C40 0 FILL_L50_8 1.8184500000000001e-17
C41 0 FILL_L50_9 1.8184500000000001e-17
C42 0 FILL_L8_0 1.7609300000000004e-18
C43 0 FILL_L8_1 1.1131200000000001e-18
C44 0 FILL_L8_10 1.1774200000000002e-17
C45 0 FILL_L8_11 3.8630300000000002e-18
C46 0 FILL_L8_12 8.3513800000000006e-18
C47 0 FILL_L8_13 8.9378700000000016e-18
C48 0 FILL_L8_14 3.3639800000000005e-18
C49 0 FILL_L8_2 1.1269300000000001e-18
C50 0 FILL_L8_3 8.8301200000000015e-18
C51 0 FILL_L8_4 9.5735800000000002e-18
C52 0 FILL_L8_5 4.8048500000000003e-18
C53 0 FILL_L8_6 1.2623800000000001e-17
C54 0 FILL_L8_7 1.1296700000000001e-17
C55 0 FILL_L8_8 4.1769700000000002e-18
C56 0 FILL_L8_9 1.3906000000000003e-17
C57 0 N 1.49725e-15
C58 0 P 5.4831700000000005e-16
C60 0 FILL_L10_11 3.4877900000000001e-17
C61 0 FILL_L10_14 3.1312799999999999e-17
C62 0 FILL_L10_5 1.03205e-17
C63 0 FILL_L10_8 3.4432000000000003e-17
C64 0 FILL_L30_10 7.8968300000000002e-18
C65 0 FILL_L30_11 7.5664699999999998e-18
C66 0 FILL_L30_12 6.2259100000000006e-18
C67 0 FILL_L30_14 4.07602e-18
C68 0 FILL_L30_8 4.14992e-18
C69 0 FILL_L50_3 3.8611500000000004e-18
C70 0 FILL_L50_5 4.9401700000000009e-18
C71 0 FILL_L50_6 1.0857300000000002e-17
C72 0 FILL_L50_8 1.5335700000000001e-17
C73 0 FILL_L50_9 1.35879e-17
C74 0 FILL_L8_11 2.0188400000000001e-18
C75 0 FILL_L8_14 2.0213100000000003e-18
C76 0 P 2.4795300000000002e-17
C78 FILL_L10_0 FILL_L10_1 1.39676e-17
C79 FILL_L10_0 FILL_L10_3 6.9838100000000001e-17
C80 FILL_L10_0 FILL_L30_1 1.3259900000000001e-16
C81 FILL_L10_0 FILL_L30_2 1.7474700000000001e-18
C82 FILL_L10_0 FILL_L50_1 3.1589700000000003e-18
C83 FILL_L10_0 FILL_L8_0 8.40312e-17
C84 FILL_L10_0 N 2.87551e-18
C85 FILL_L10_0 0 1.4644100000000001e-16
C86 FILL_L10_1 FILL_L10_2 1.39676e-17
C87 FILL_L10_1 FILL_L10_4 9.7773300000000019e-17
C88 FILL_L10_1 FILL_L30_2 2.2208100000000002e-16
C89 FILL_L10_1 FILL_L8_1 1.1764400000000002e-16
C90 FILL_L10_1 N 9.8324800000000015e-19
C91 FILL_L10_1 P 1.6254500000000001e-18
C92 FILL_L10_1 0 1.8486400000000003e-16
C93 FILL_L10_10 FILL_L10_11 9.7773300000000019e-17
C94 FILL_L10_10 FILL_L10_13 9.7773300000000019e-17
C95 FILL_L10_10 FILL_L10_7 9.7773300000000019e-17
C96 FILL_L10_10 FILL_L10_9 9.7773300000000019e-17
C97 FILL_L10_10 FILL_L30_10 9.2695400000000007e-16
C98 FILL_L10_10 FILL_L8_10 8.2350600000000007e-16
C99 FILL_L10_10 N 4.4774400000000001e-17
C100 FILL_L10_10 P 1.13782e-17
C101 FILL_L10_10 0 1.9621900000000002e-16
C102 FILL_L10_11 FILL_L10_14 8.380570000000001e-17
C103 FILL_L10_11 FILL_L10_8 8.380570000000001e-17
C104 FILL_L10_11 FILL_L30_10 6.0451500000000002e-17
C105 FILL_L10_11 FILL_L30_11 1.20314e-16
C106 FILL_L10_11 FILL_L30_8 1.7036000000000002e-16
C107 FILL_L10_11 FILL_L50_6 4.4840200000000006e-17
C108 FILL_L10_11 FILL_L50_8 3.2796700000000007e-17
C109 FILL_L10_11 FILL_L8_11 7.0586200000000003e-16
C110 FILL_L10_11 P 7.8441800000000007e-17
C111 FILL_L10_11 0 2.5494200000000004e-16
C112 FILL_L10_12 FILL_L10_13 8.380570000000001e-17
C113 FILL_L10_12 FILL_L10_9 6.9838100000000001e-17
C114 FILL_L10_12 FILL_L30_13 3.7099400000000006e-16
C115 FILL_L10_12 FILL_L30_14 6.9898900000000003e-18
C116 FILL_L10_12 FILL_L30_9 2.7948400000000001e-17
C117 FILL_L10_12 FILL_L50_10 3.6723000000000004e-17
C118 FILL_L10_12 FILL_L50_7 1.74191e-17
C119 FILL_L10_12 FILL_L8_12 5.0418700000000006e-16
C120 FILL_L10_12 N 2.7467200000000001e-17
C121 FILL_L10_12 0 2.6847500000000004e-16
C122 FILL_L10_13 FILL_L10_14 8.380570000000001e-17
C123 FILL_L10_13 FILL_L30_10 4.8909600000000001e-17
C124 FILL_L10_13 FILL_L30_14 6.0937200000000001e-16
C125 FILL_L10_13 FILL_L8_13 7.0586200000000003e-16
C126 FILL_L10_13 N 8.9148100000000001e-17
C127 FILL_L10_13 P 2.12233e-17
C128 FILL_L10_13 0 2.5494200000000004e-16
C129 FILL_L10_14 FILL_L30_11 1.3974200000000001e-17
C130 FILL_L10_14 FILL_L30_12 1.92071e-16
C131 FILL_L10_14 FILL_L30_14 3.3719299999999999e-17
C132 FILL_L10_14 FILL_L50_8 8.7095400000000018e-18
C133 FILL_L10_14 FILL_L50_9 4.8174300000000004e-17
C134 FILL_L10_14 FILL_L8_14 6.0502500000000001e-16
C135 FILL_L10_14 P 7.0886700000000007e-17
C136 FILL_L10_14 0 2.9288200000000002e-16
C137 FILL_L10_2 FILL_L10_5 8.380570000000001e-17
C138 FILL_L10_2 FILL_L30_0 7.9602300000000007e-17
C139 FILL_L10_2 FILL_L30_2 6.9870900000000006e-18
C140 FILL_L10_2 FILL_L50_0 1.2043600000000001e-17
C141 FILL_L10_2 FILL_L8_2 1.0083700000000001e-16
C142 FILL_L10_2 P 7.5550600000000002e-18
C143 FILL_L10_2 0 1.7084800000000002e-16
C144 FILL_L10_3 FILL_L10_4 9.7773300000000019e-17
C145 FILL_L10_3 FILL_L10_6 6.9838100000000001e-17
C146 FILL_L10_3 FILL_L30_1 4.3846000000000003e-16
C147 FILL_L10_3 FILL_L30_2 6.9898900000000003e-18
C148 FILL_L10_3 FILL_L30_5 6.7651200000000006e-17
C149 FILL_L10_3 FILL_L50_1 4.6360500000000005e-17
C150 FILL_L10_3 FILL_L50_4 2.8870300000000003e-17
C151 FILL_L10_3 FILL_L8_3 5.882190000000001e-16
C152 FILL_L10_3 N 3.54497e-17
C153 FILL_L10_3 0 2.4092599999999998e-16
C154 FILL_L10_4 FILL_L10_5 9.7773300000000019e-17
C155 FILL_L10_4 FILL_L10_7 9.7773300000000019e-17
C156 FILL_L10_4 FILL_L30_2 7.2743800000000001e-16
C157 FILL_L10_4 FILL_L30_6 1.1839000000000001e-16
C158 FILL_L10_4 FILL_L8_4 8.2350600000000007e-16
C159 FILL_L10_4 N 1.15514e-16
C160 FILL_L10_4 P 2.8584100000000002e-17
C161 FILL_L10_4 0 1.9621900000000002e-16
C162 FILL_L10_5 FILL_L10_8 8.380570000000001e-17
C163 FILL_L10_5 FILL_L30_0 1.3974200000000001e-17
C164 FILL_L10_5 FILL_L30_2 3.3719299999999999e-17
C165 FILL_L10_5 FILL_L30_3 1.9807600000000001e-16
C166 FILL_L10_5 FILL_L30_4 3.3825600000000003e-17
C167 FILL_L10_5 FILL_L50_0 8.7095400000000018e-18
C168 FILL_L10_5 FILL_L50_2 5.2993000000000008e-17
C169 FILL_L10_5 FILL_L50_3 1.4435200000000002e-17
C170 FILL_L10_5 FILL_L8_5 7.0586200000000003e-16
C171 FILL_L10_5 P 8.4830800000000006e-17
C172 FILL_L10_5 0 2.5494200000000004e-16
C173 FILL_L10_6 FILL_L10_7 9.7773300000000019e-17
C174 FILL_L10_6 FILL_L10_9 6.9838100000000001e-17
C175 FILL_L10_6 FILL_L30_5 5.4903599999999997e-16
C176 FILL_L10_6 FILL_L30_6 1.0484800000000001e-17
C177 FILL_L10_6 FILL_L30_9 6.9898900000000003e-18
C178 FILL_L10_6 FILL_L50_4 3.1589700000000004e-17
C179 FILL_L10_6 FILL_L50_7 7.7816000000000003e-18
C180 FILL_L10_6 FILL_L8_6 5.882190000000001e-16
C181 FILL_L10_6 N 2.5235600000000005e-17
C182 FILL_L10_6 0 2.4092599999999998e-16
C183 FILL_L10_7 FILL_L10_8 9.7773300000000019e-17
C184 FILL_L10_7 FILL_L30_10 1.2232300000000001e-17
C185 FILL_L10_7 FILL_L30_6 9.0101000000000002e-16
C186 FILL_L10_7 FILL_L8_7 8.2350600000000007e-16
C187 FILL_L10_7 N 7.0157100000000007e-17
C188 FILL_L10_7 P 1.7113500000000001e-17
C189 FILL_L10_7 0 1.9621900000000002e-16
C190 FILL_L10_8 FILL_L30_4 6.3965400000000009e-17
C191 FILL_L10_8 FILL_L30_6 5.34644e-17
C192 FILL_L10_8 FILL_L30_7 1.90195e-16
C193 FILL_L10_8 FILL_L30_8 3.4949400000000003e-18
C194 FILL_L10_8 FILL_L50_3 2.0753100000000001e-17
C195 FILL_L10_8 FILL_L50_5 5.1158200000000006e-17
C196 FILL_L10_8 FILL_L50_6 3.8908000000000001e-18
C197 FILL_L10_8 FILL_L8_8 7.0586200000000003e-16
C198 FILL_L10_8 P 8.4830800000000006e-17
C199 FILL_L10_8 0 2.5494200000000004e-16
C200 FILL_L10_9 FILL_L30_10 1.2232300000000001e-17
C201 FILL_L10_9 FILL_L30_9 5.6955600000000006e-16
C202 FILL_L10_9 FILL_L50_7 2.2112800000000001e-17
C203 FILL_L10_9 FILL_L8_9 5.882190000000001e-16
C204 FILL_L10_9 N 2.0128599999999999e-17
C205 FILL_L10_9 0 2.4092599999999998e-16
C206 FILL_L30_0 FILL_L30_2 1.92731e-17
C207 FILL_L30_0 FILL_L30_3 1.92731e-17
C208 FILL_L30_0 FILL_L50_0 6.7224999999999998e-17
C209 FILL_L30_0 FILL_L8_2 3.01665e-18
C210 FILL_L30_0 FILL_L8_5 2.30082e-18
C211 FILL_L30_0 P 3.6514799999999999e-18
C212 FILL_L30_0 0 8.1565600000000015e-17
C213 FILL_L30_1 FILL_L30_2 7.7092600000000011e-17
C214 FILL_L30_1 FILL_L30_5 3.8546300000000006e-17
C215 FILL_L30_1 FILL_L50_1 5.3779999999999998e-16
C216 FILL_L30_1 FILL_L8_0 1.6102599999999999e-17
C217 FILL_L30_1 FILL_L8_3 1.6102599999999999e-17
C218 FILL_L30_1 N 4.9648100000000005e-18
C219 FILL_L30_1 0 2.7282100000000003e-16
C220 FILL_L30_10 FILL_L30_11 1.92731e-17
C221 FILL_L30_10 FILL_L30_14 7.7092600000000011e-17
C222 FILL_L30_10 FILL_L30_6 7.7092600000000011e-17
C223 FILL_L30_10 FILL_L30_8 1.92731e-17
C224 FILL_L30_10 FILL_L30_9 7.7092600000000011e-17
C225 FILL_L30_10 FILL_L8_10 2.11165e-17
C226 FILL_L30_10 FILL_L8_11 8.0528700000000005e-18
C227 FILL_L30_10 FILL_L8_13 8.0528700000000005e-18
C228 FILL_L30_10 N 9.4484500000000007e-16
C229 FILL_L30_10 P 1.6977000000000002e-16
C230 FILL_L30_10 0 2.0633500000000003e-16
C231 FILL_L30_11 FILL_L30_12 1.92731e-17
C232 FILL_L30_11 FILL_L30_8 1.92731e-17
C233 FILL_L30_11 FILL_L50_8 6.7224999999999998e-17
C234 FILL_L30_11 FILL_L8_11 3.01665e-18
C235 FILL_L30_11 FILL_L8_14 2.30082e-18
C236 FILL_L30_11 P 3.6514799999999999e-18
C237 FILL_L30_11 0 5.0213600000000005e-17
C238 FILL_L30_12 FILL_L30_14 1.92731e-17
C239 FILL_L30_12 FILL_L50_9 6.7224999999999998e-17
C240 FILL_L30_12 P 3.6514799999999999e-18
C241 FILL_L30_12 0 6.1356300000000001e-17
C242 FILL_L30_13 FILL_L30_14 3.8546300000000006e-17
C243 FILL_L30_13 FILL_L30_9 3.8546300000000006e-17
C244 FILL_L30_13 FILL_L50_10 2.6889999999999999e-16
C245 FILL_L30_13 N 2.4824000000000004e-18
C246 FILL_L30_13 0 1.5645200000000002e-16
C247 FILL_L30_14 FILL_L8_13 6.0333000000000001e-18
C248 FILL_L30_14 FILL_L8_14 4.60164e-18
C249 FILL_L30_14 N 4.7242300000000004e-16
C250 FILL_L30_14 P 8.4884800000000009e-17
C251 FILL_L30_14 0 2.0792300000000001e-16
C252 FILL_L30_2 FILL_L30_3 1.92731e-17
C253 FILL_L30_2 FILL_L30_6 7.7092600000000011e-17
C254 FILL_L30_2 FILL_L8_1 2.9687900000000004e-17
C255 FILL_L30_2 FILL_L8_2 1.15041e-18
C256 FILL_L30_2 FILL_L8_4 3.4212900000000001e-17
C257 FILL_L30_2 FILL_L8_5 4.60164e-18
C258 FILL_L30_2 N 8.7084400000000013e-16
C259 FILL_L30_2 P 1.6977000000000002e-16
C260 FILL_L30_2 0 3.3724800000000002e-16
C261 FILL_L30_3 FILL_L30_4 1.92731e-17
C262 FILL_L30_3 FILL_L50_2 6.7224999999999998e-17
C263 FILL_L30_3 P 3.6514799999999999e-18
C264 FILL_L30_3 0 3.9701300000000009e-17
C265 FILL_L30_4 FILL_L30_6 1.92731e-17
C266 FILL_L30_4 FILL_L30_7 1.92731e-17
C267 FILL_L30_4 FILL_L50_3 6.7224999999999998e-17
C268 FILL_L30_4 FILL_L8_5 5.0346600000000001e-18
C269 FILL_L30_4 FILL_L8_8 5.7504800000000001e-18
C270 FILL_L30_4 P 3.6514799999999999e-18
C271 FILL_L30_4 0 5.9642700000000001e-17
C272 FILL_L30_5 FILL_L30_6 7.7092600000000011e-17
C273 FILL_L30_5 FILL_L30_9 3.8546300000000006e-17
C274 FILL_L30_5 FILL_L50_4 5.3779999999999998e-16
C275 FILL_L30_5 FILL_L8_3 1.0069300000000001e-17
C276 FILL_L30_5 FILL_L8_6 1.1501000000000001e-17
C277 FILL_L30_5 N 4.9648100000000005e-18
C278 FILL_L30_5 0 2.1626900000000002e-16
C279 FILL_L30_6 FILL_L30_7 1.92731e-17
C280 FILL_L30_6 FILL_L8_4 1.7621300000000003e-17
C281 FILL_L30_6 FILL_L8_7 2.9176600000000002e-17
C282 FILL_L30_6 FILL_L8_8 6.9024600000000003e-18
C283 FILL_L30_6 N 9.4484500000000007e-16
C284 FILL_L30_6 P 1.6977000000000002e-16
C285 FILL_L30_6 0 2.1840199999999999e-16
C286 FILL_L30_7 FILL_L30_8 1.92731e-17
C287 FILL_L30_7 FILL_L50_5 6.7224999999999998e-17
C288 FILL_L30_7 P 3.6514799999999999e-18
C289 FILL_L30_7 0 4.0107600000000001e-17
C290 FILL_L30_8 FILL_L50_6 6.7224999999999998e-17
C291 FILL_L30_8 P 3.6514799999999999e-18
C292 FILL_L30_8 0 4.0609100000000004e-17
C293 FILL_L30_9 FILL_L50_7 5.3779999999999998e-16
C294 FILL_L30_9 FILL_L8_12 4.60164e-18
C295 FILL_L30_9 FILL_L8_9 6.0333000000000001e-18
C296 FILL_L30_9 N 4.9648100000000005e-18
C297 FILL_L30_9 0 2.10236e-16
C298 FILL_L50_0 FILL_L50_2 2.4713600000000001e-17
C299 FILL_L50_0 P 3.9494400000000005e-17
C300 FILL_L50_0 0 6.4829200000000006e-17
C301 FILL_L50_1 FILL_L50_4 4.9427100000000007e-17
C302 FILL_L50_1 N 1.1294400000000001e-16
C303 FILL_L50_1 0 2.0941300000000004e-16
C304 FILL_L50_10 FILL_L50_7 4.9427100000000007e-17
C305 FILL_L50_10 N 5.64721e-17
C306 FILL_L50_10 0 1.39384e-16
C307 FILL_L50_2 FILL_L50_3 2.4713600000000001e-17
C308 FILL_L50_2 P 3.9494400000000005e-17
C309 FILL_L50_2 0 3.25359e-17
C310 FILL_L50_3 FILL_L50_5 2.4713600000000001e-17
C311 FILL_L50_3 P 3.9494400000000005e-17
C312 FILL_L50_3 0 3.8446700000000004e-17
C313 FILL_L50_4 FILL_L50_7 4.9427100000000007e-17
C314 FILL_L50_4 N 1.1294400000000001e-16
C315 FILL_L50_4 0 1.6576900000000001e-16
C316 FILL_L50_5 FILL_L50_6 2.4713600000000001e-17
C317 FILL_L50_5 P 3.9494400000000005e-17
C318 FILL_L50_5 0 3.27292e-17
C319 FILL_L50_6 FILL_L50_8 2.4713600000000001e-17
C320 FILL_L50_6 P 3.9494400000000005e-17
C321 FILL_L50_6 0 3.2964800000000002e-17
C322 FILL_L50_7 N 1.1294400000000001e-16
C323 FILL_L50_7 0 1.7020599999999999e-16
C324 FILL_L50_8 FILL_L50_9 2.4713600000000001e-17
C325 FILL_L50_8 P 3.9494400000000005e-17
C326 FILL_L50_8 0 3.5746200000000002e-17
C327 FILL_L50_9 P 3.9494400000000005e-17
C328 FILL_L50_9 0 5.3798900000000007e-17
C329 FILL_L8_0 FILL_L8_1 9.9566900000000006e-18
C330 FILL_L8_0 FILL_L8_3 4.9783400000000003e-17
C331 FILL_L8_0 N 3.2792900000000005e-19
C332 FILL_L8_0 0 2.3152000000000001e-16
C333 FILL_L8_1 FILL_L8_2 9.9566900000000006e-18
C334 FILL_L8_1 FILL_L8_4 6.96968e-17
C335 FILL_L8_1 N 3.7572800000000005e-19
C336 FILL_L8_1 P 6.9748400000000006e-19
C337 FILL_L8_1 0 3.0331700000000001e-16
C338 FILL_L8_10 FILL_L8_11 6.96968e-17
C339 FILL_L8_10 FILL_L8_13 6.96968e-17
C340 FILL_L8_10 FILL_L8_7 6.96968e-17
C341 FILL_L8_10 FILL_L8_9 6.96968e-17
C342 FILL_L8_10 N 1.85099e-17
C343 FILL_L8_10 P 4.8823900000000006e-18
C344 FILL_L8_10 0 7.5091400000000008e-16
C345 FILL_L8_11 FILL_L8_14 5.9740100000000005e-17
C346 FILL_L8_11 FILL_L8_8 5.9740100000000005e-17
C347 FILL_L8_11 P 5.1604000000000007e-18
C348 FILL_L8_11 0 7.2469200000000008e-16
C349 FILL_L8_12 FILL_L8_13 5.9740100000000005e-17
C350 FILL_L8_12 FILL_L8_9 4.9783400000000003e-17
C351 FILL_L8_12 N 1.9675800000000004e-18
C352 FILL_L8_12 0 6.06822e-16
C353 FILL_L8_13 FILL_L8_14 5.9740100000000005e-17
C354 FILL_L8_13 N 8.8601800000000006e-18
C355 FILL_L8_13 P 4.1849e-18
C356 FILL_L8_13 0 7.2469200000000008e-16
C357 FILL_L8_14 P 4.4231999999999997e-18
C358 FILL_L8_14 0 6.9063699999999997e-16
C359 FILL_L8_2 FILL_L8_5 5.9740100000000005e-17
C360 FILL_L8_2 P 7.3720000000000001e-19
C361 FILL_L8_2 0 2.7156500000000001e-16
C362 FILL_L8_3 FILL_L8_4 6.96968e-17
C363 FILL_L8_3 FILL_L8_6 4.9783400000000003e-17
C364 FILL_L8_3 N 2.2955000000000002e-18
C365 FILL_L8_3 0 6.4041700000000011e-16
C366 FILL_L8_4 FILL_L8_5 6.96968e-17
C367 FILL_L8_4 FILL_L8_7 6.96968e-17
C368 FILL_L8_4 N 5.9953800000000002e-18
C369 FILL_L8_4 P 4.8823900000000006e-18
C370 FILL_L8_4 0 7.5091400000000008e-16
C371 FILL_L8_5 FILL_L8_8 5.9740100000000005e-17
C372 FILL_L8_5 P 5.1604000000000007e-18
C373 FILL_L8_5 0 7.2469200000000008e-16
C374 FILL_L8_6 FILL_L8_7 6.96968e-17
C375 FILL_L8_6 FILL_L8_9 4.9783400000000003e-17
C376 FILL_L8_6 N 2.2955000000000002e-18
C377 FILL_L8_6 0 6.4041700000000011e-16
C378 FILL_L8_7 FILL_L8_8 6.96968e-17
C379 FILL_L8_7 N 1.52694e-17
C380 FILL_L8_7 P 4.8823900000000006e-18
C381 FILL_L8_7 0 7.5091400000000008e-16
C382 FILL_L8_8 P 5.1604000000000007e-18
C383 FILL_L8_8 0 7.2469200000000008e-16
C384 FILL_L8_9 N 2.2955000000000002e-18
C385 FILL_L8_9 0 6.4041700000000011e-16
C386 N P 4.9427100000000006e-16
C387 N 0 5.5166300000000003e-16
C388 P 0 4.4773599999999998e-16
VP P 0 DC 0 AC 0
VN N 0 DC 0 AC 1
.control
set numdgt=17
ac lin 1 1Meg 1Meg
let cp = -imag(i(VP))/(2*pi*1e6)
let cn = -imag(i(VN))/(2*pi*1e6)
print cp cn
quit
.endc
.end
