* actual_fill grounded drive P; diagnostic capacitor-network AC only
C57 0 N 1.49725e-15
C58 0 P 5.4831700000000005e-16
C76 0 P 2.4795300000000002e-17
C84 0 N 2.87551e-18
C90 0 N 9.8324800000000015e-19
C91 0 P 1.6254500000000001e-18
C99 0 N 4.4774400000000001e-17
C100 0 P 1.13782e-17
C110 0 P 7.8441800000000007e-17
C120 0 N 2.7467200000000001e-17
C126 0 N 8.9148100000000001e-17
C127 0 P 2.12233e-17
C135 0 P 7.0886700000000007e-17
C142 0 P 7.5550600000000002e-18
C152 0 N 3.54497e-17
C159 0 N 1.15514e-16
C160 0 P 2.8584100000000002e-17
C171 0 P 8.4830800000000006e-17
C181 0 N 2.5235600000000005e-17
C187 0 N 7.0157100000000007e-17
C188 0 P 1.7113500000000001e-17
C198 0 P 8.4830800000000006e-17
C204 0 N 2.0128599999999999e-17
C211 0 P 3.6514799999999999e-18
C218 0 N 4.9648100000000005e-18
C228 0 N 9.4484500000000007e-16
C229 0 P 1.6977000000000002e-16
C236 0 P 3.6514799999999999e-18
C240 0 P 3.6514799999999999e-18
C245 0 N 2.4824000000000004e-18
C249 0 N 4.7242300000000004e-16
C250 0 P 8.4884800000000009e-17
C258 0 N 8.7084400000000013e-16
C259 0 P 1.6977000000000002e-16
C263 0 P 3.6514799999999999e-18
C270 0 P 3.6514799999999999e-18
C277 0 N 4.9648100000000005e-18
C283 0 N 9.4484500000000007e-16
C284 0 P 1.6977000000000002e-16
C288 0 P 3.6514799999999999e-18
C291 0 P 3.6514799999999999e-18
C296 0 N 4.9648100000000005e-18
C299 0 P 3.9494400000000005e-17
C302 0 N 1.1294400000000001e-16
C305 0 N 5.64721e-17
C308 0 P 3.9494400000000005e-17
C311 0 P 3.9494400000000005e-17
C314 0 N 1.1294400000000001e-16
C317 0 P 3.9494400000000005e-17
C320 0 P 3.9494400000000005e-17
C322 0 N 1.1294400000000001e-16
C325 0 P 3.9494400000000005e-17
C327 0 P 3.9494400000000005e-17
C331 0 N 3.2792900000000005e-19
C335 0 N 3.7572800000000005e-19
C336 0 P 6.9748400000000006e-19
C342 0 N 1.85099e-17
C343 0 P 4.8823900000000006e-18
C347 0 P 5.1604000000000007e-18
C351 0 N 1.9675800000000004e-18
C354 0 N 8.8601800000000006e-18
C355 0 P 4.1849e-18
C357 0 P 4.4231999999999997e-18
C360 0 P 7.3720000000000001e-19
C364 0 N 2.2955000000000002e-18
C368 0 N 5.9953800000000002e-18
C369 0 P 4.8823900000000006e-18
C372 0 P 5.1604000000000007e-18
C376 0 N 2.2955000000000002e-18
C379 0 N 1.52694e-17
C380 0 P 4.8823900000000006e-18
C382 0 P 5.1604000000000007e-18
C384 0 N 2.2955000000000002e-18
C386 N P 4.9427100000000006e-16
C387 N 0 5.5166300000000003e-16
C388 P 0 4.4773599999999998e-16
VP P 0 DC 0 AC 1
VN N 0 DC 0 AC 0
.control
set numdgt=17
ac lin 1 1Meg 1Meg
let cp = -imag(i(VP))/(2*pi*1e6)
let cn = -imag(i(VN))/(2*pi*1e6)
print cp cn
quit
.endc
.end
