* LVS reference netlist derived from g1_trip.spice by lvs_netlist.py (see docstring)
.subckt g1_trip ISENSE VREF clk dac_soft[0] dac_soft[1] dac_soft[2] dac_soft[3] dac_soft[4] dac_soft[5] dac_soft[6] dac_soft[7] dac_hard[0] dac_hard[1] dac_hard[2] dac_hard[3] dac_hard[4] dac_hard[5] dac_hard[6] dac_hard[7] cmp_soft cmp_hard VDD IOVDD VSS
XCOND ISENSE icmp VSS g1_cond
XDACS VREF dac_soft[0] dac_soft[1] dac_soft[2] dac_soft[3] dac_soft[4] dac_soft[5] dac_soft[6] dac_soft[7] vth_soft VDD IOVDD VSS g1_dac8
XDACH VREF dac_hard[0] dac_hard[1] dac_hard[2] dac_hard[3] dac_hard[4] dac_hard[5] dac_hard[6] dac_hard[7] vth_hard VDD IOVDD VSS g1_dac8
CCHS vth_soft VSS cap_cmim w=26u l=26u m=1
CCHH vth_hard VSS cap_cmim w=26u l=26u m=1
XCLKI clk cmp_clk_n VDD VSS g1_inv
XCS icmp vth_soft clk cmp_soft cmp_soft_n VDD VSS g1_cmp
XCH icmp vth_hard cmp_clk_n cmp_hard cmp_hard_n VDD VSS g1_cmp
.ends
.subckt g1_cond isense icmp vss
RRC0 isense c0 vss rppd w=2u l=76.7u b=0 m=1
RRC1 c0 c1 vss rppd w=2u l=76.7u b=0 m=1
RRC2 c1 c2 vss rppd w=2u l=76.7u b=0 m=1
RRC3 c2 c3 vss rppd w=2u l=76.7u b=0 m=1
RRC4 c3 icmp vss rppd w=2u l=76.7u b=0 m=1
RRC5 icmp c5 vss rppd w=2u l=76.7u b=0 m=1
RRC6 c5 c6 vss rppd w=2u l=76.7u b=0 m=1
RRC7 c6 c7 vss rppd w=2u l=76.7u b=0 m=1
RRC8 c7 c8 vss rppd w=2u l=76.7u b=0 m=1
RRC9 c8 vss vss rppd w=2u l=76.7u b=0 m=1
CCH icmp vss cap_cmim w=26u l=26u m=1
.ends
.subckt g1_dac8 vref d0 d1 d2 d3 d4 d5 d6 d7 out vdd vdda vss
RRU0 s0 vss vss rppd w=4u l=1.2u b=0 m=1
RRU1 s1 s0 vss rppd w=4u l=1.2u b=0 m=1
RRU2 s2 s1 vss rppd w=4u l=1.2u b=0 m=1
RRU3 s3 s2 vss rppd w=4u l=1.2u b=0 m=1
RRU4 s4 s3 vss rppd w=4u l=1.2u b=0 m=1
RRU5 s5 s4 vss rppd w=4u l=1.2u b=0 m=1
RRU6 s6 s5 vss rppd w=4u l=1.2u b=0 m=1
RRU7 s7 s6 vss rppd w=4u l=1.2u b=0 m=1
RRU8 s8 s7 vss rppd w=4u l=1.2u b=0 m=1
RRU9 s9 s8 vss rppd w=4u l=1.2u b=0 m=1
RRU10 s10 s9 vss rppd w=4u l=1.2u b=0 m=1
RRU11 s11 s10 vss rppd w=4u l=1.2u b=0 m=1
RRU12 s12 s11 vss rppd w=4u l=1.2u b=0 m=1
RRU13 s13 s12 vss rppd w=4u l=1.2u b=0 m=1
RRU14 s14 s13 vss rppd w=4u l=1.2u b=0 m=1
RRU15 s15 s14 vss rppd w=4u l=1.2u b=0 m=1
RRU16 s16 s15 vss rppd w=4u l=1.2u b=0 m=1
RRU17 s17 s16 vss rppd w=4u l=1.2u b=0 m=1
RRU18 s18 s17 vss rppd w=4u l=1.2u b=0 m=1
RRU19 s19 s18 vss rppd w=4u l=1.2u b=0 m=1
RRU20 s20 s19 vss rppd w=4u l=1.2u b=0 m=1
RRU21 s21 s20 vss rppd w=4u l=1.2u b=0 m=1
RRU22 s22 s21 vss rppd w=4u l=1.2u b=0 m=1
RRU23 s23 s22 vss rppd w=4u l=1.2u b=0 m=1
RRU24 s24 s23 vss rppd w=4u l=1.2u b=0 m=1
RRU25 s25 s24 vss rppd w=4u l=1.2u b=0 m=1
RRU26 s26 s25 vss rppd w=4u l=1.2u b=0 m=1
RRU27 s27 s26 vss rppd w=4u l=1.2u b=0 m=1
RRU28 s28 s27 vss rppd w=4u l=1.2u b=0 m=1
RRU29 s29 s28 vss rppd w=4u l=1.2u b=0 m=1
RRU30 s30 s29 vss rppd w=4u l=1.2u b=0 m=1
RRU31 s31 s30 vss rppd w=4u l=1.2u b=0 m=1
RRU32 s32 s31 vss rppd w=4u l=1.2u b=0 m=1
RRU33 s33 s32 vss rppd w=4u l=1.2u b=0 m=1
RRU34 s34 s33 vss rppd w=4u l=1.2u b=0 m=1
RRU35 s35 s34 vss rppd w=4u l=1.2u b=0 m=1
RRU36 s36 s35 vss rppd w=4u l=1.2u b=0 m=1
RRU37 s37 s36 vss rppd w=4u l=1.2u b=0 m=1
RRU38 s38 s37 vss rppd w=4u l=1.2u b=0 m=1
RRU39 s39 s38 vss rppd w=4u l=1.2u b=0 m=1
RRU40 s40 s39 vss rppd w=4u l=1.2u b=0 m=1
RRU41 s41 s40 vss rppd w=4u l=1.2u b=0 m=1
RRU42 s42 s41 vss rppd w=4u l=1.2u b=0 m=1
RRU43 s43 s42 vss rppd w=4u l=1.2u b=0 m=1
RRU44 s44 s43 vss rppd w=4u l=1.2u b=0 m=1
RRU45 s45 s44 vss rppd w=4u l=1.2u b=0 m=1
RRU46 s46 s45 vss rppd w=4u l=1.2u b=0 m=1
RRU47 s47 s46 vss rppd w=4u l=1.2u b=0 m=1
RRU48 s48 s47 vss rppd w=4u l=1.2u b=0 m=1
RRU49 s49 s48 vss rppd w=4u l=1.2u b=0 m=1
RRU50 s50 s49 vss rppd w=4u l=1.2u b=0 m=1
RRU51 s51 s50 vss rppd w=4u l=1.2u b=0 m=1
RRU52 s52 s51 vss rppd w=4u l=1.2u b=0 m=1
RRU53 s53 s52 vss rppd w=4u l=1.2u b=0 m=1
RRU54 s54 s53 vss rppd w=4u l=1.2u b=0 m=1
RRU55 s55 s54 vss rppd w=4u l=1.2u b=0 m=1
RRU56 s56 s55 vss rppd w=4u l=1.2u b=0 m=1
RRU57 s57 s56 vss rppd w=4u l=1.2u b=0 m=1
RRU58 s58 s57 vss rppd w=4u l=1.2u b=0 m=1
RRU59 s59 s58 vss rppd w=4u l=1.2u b=0 m=1
RRU60 s60 s59 vss rppd w=4u l=1.2u b=0 m=1
RRU61 s61 s60 vss rppd w=4u l=1.2u b=0 m=1
RRU62 s62 s61 vss rppd w=4u l=1.2u b=0 m=1
RRU63 s63 s62 vss rppd w=4u l=1.2u b=0 m=1
RRU64 s64 s63 vss rppd w=4u l=1.2u b=0 m=1
RRU65 s65 s64 vss rppd w=4u l=1.2u b=0 m=1
RRU66 s66 s65 vss rppd w=4u l=1.2u b=0 m=1
RRU67 s67 s66 vss rppd w=4u l=1.2u b=0 m=1
RRU68 s68 s67 vss rppd w=4u l=1.2u b=0 m=1
RRU69 s69 s68 vss rppd w=4u l=1.2u b=0 m=1
RRU70 s70 s69 vss rppd w=4u l=1.2u b=0 m=1
RRU71 s71 s70 vss rppd w=4u l=1.2u b=0 m=1
RRU72 s72 s71 vss rppd w=4u l=1.2u b=0 m=1
RRU73 s73 s72 vss rppd w=4u l=1.2u b=0 m=1
RRU74 s74 s73 vss rppd w=4u l=1.2u b=0 m=1
RRU75 s75 s74 vss rppd w=4u l=1.2u b=0 m=1
RRU76 s76 s75 vss rppd w=4u l=1.2u b=0 m=1
RRU77 s77 s76 vss rppd w=4u l=1.2u b=0 m=1
RRU78 s78 s77 vss rppd w=4u l=1.2u b=0 m=1
RRU79 s79 s78 vss rppd w=4u l=1.2u b=0 m=1
RRU80 s80 s79 vss rppd w=4u l=1.2u b=0 m=1
RRU81 s81 s80 vss rppd w=4u l=1.2u b=0 m=1
RRU82 s82 s81 vss rppd w=4u l=1.2u b=0 m=1
RRU83 s83 s82 vss rppd w=4u l=1.2u b=0 m=1
RRU84 s84 s83 vss rppd w=4u l=1.2u b=0 m=1
RRU85 s85 s84 vss rppd w=4u l=1.2u b=0 m=1
RRU86 s86 s85 vss rppd w=4u l=1.2u b=0 m=1
RRU87 s87 s86 vss rppd w=4u l=1.2u b=0 m=1
RRU88 s88 s87 vss rppd w=4u l=1.2u b=0 m=1
RRU89 s89 s88 vss rppd w=4u l=1.2u b=0 m=1
RRU90 s90 s89 vss rppd w=4u l=1.2u b=0 m=1
RRU91 s91 s90 vss rppd w=4u l=1.2u b=0 m=1
RRU92 s92 s91 vss rppd w=4u l=1.2u b=0 m=1
RRU93 s93 s92 vss rppd w=4u l=1.2u b=0 m=1
RRU94 s94 s93 vss rppd w=4u l=1.2u b=0 m=1
RRU95 s95 s94 vss rppd w=4u l=1.2u b=0 m=1
RRU96 s96 s95 vss rppd w=4u l=1.2u b=0 m=1
RRU97 s97 s96 vss rppd w=4u l=1.2u b=0 m=1
RRU98 s98 s97 vss rppd w=4u l=1.2u b=0 m=1
RRU99 s99 s98 vss rppd w=4u l=1.2u b=0 m=1
RRU100 s100 s99 vss rppd w=4u l=1.2u b=0 m=1
RRU101 s101 s100 vss rppd w=4u l=1.2u b=0 m=1
RRU102 s102 s101 vss rppd w=4u l=1.2u b=0 m=1
RRU103 s103 s102 vss rppd w=4u l=1.2u b=0 m=1
RRU104 s104 s103 vss rppd w=4u l=1.2u b=0 m=1
RRU105 s105 s104 vss rppd w=4u l=1.2u b=0 m=1
RRU106 s106 s105 vss rppd w=4u l=1.2u b=0 m=1
RRU107 s107 s106 vss rppd w=4u l=1.2u b=0 m=1
RRU108 s108 s107 vss rppd w=4u l=1.2u b=0 m=1
RRU109 s109 s108 vss rppd w=4u l=1.2u b=0 m=1
RRU110 s110 s109 vss rppd w=4u l=1.2u b=0 m=1
RRU111 s111 s110 vss rppd w=4u l=1.2u b=0 m=1
RRU112 s112 s111 vss rppd w=4u l=1.2u b=0 m=1
RRU113 s113 s112 vss rppd w=4u l=1.2u b=0 m=1
RRU114 s114 s113 vss rppd w=4u l=1.2u b=0 m=1
RRU115 s115 s114 vss rppd w=4u l=1.2u b=0 m=1
RRU116 s116 s115 vss rppd w=4u l=1.2u b=0 m=1
RRU117 s117 s116 vss rppd w=4u l=1.2u b=0 m=1
RRU118 s118 s117 vss rppd w=4u l=1.2u b=0 m=1
RRU119 s119 s118 vss rppd w=4u l=1.2u b=0 m=1
RRU120 s120 s119 vss rppd w=4u l=1.2u b=0 m=1
RRU121 s121 s120 vss rppd w=4u l=1.2u b=0 m=1
RRU122 s122 s121 vss rppd w=4u l=1.2u b=0 m=1
RRU123 s123 s122 vss rppd w=4u l=1.2u b=0 m=1
RRU124 s124 s123 vss rppd w=4u l=1.2u b=0 m=1
RRU125 s125 s124 vss rppd w=4u l=1.2u b=0 m=1
RRU126 s126 s125 vss rppd w=4u l=1.2u b=0 m=1
RRU127 s127 s126 vss rppd w=4u l=1.2u b=0 m=1
RRU128 s128 s127 vss rppd w=4u l=1.2u b=0 m=1
RRU129 s129 s128 vss rppd w=4u l=1.2u b=0 m=1
RRU130 s130 s129 vss rppd w=4u l=1.2u b=0 m=1
RRU131 s131 s130 vss rppd w=4u l=1.2u b=0 m=1
RRU132 s132 s131 vss rppd w=4u l=1.2u b=0 m=1
RRU133 s133 s132 vss rppd w=4u l=1.2u b=0 m=1
RRU134 s134 s133 vss rppd w=4u l=1.2u b=0 m=1
RRU135 s135 s134 vss rppd w=4u l=1.2u b=0 m=1
RRU136 s136 s135 vss rppd w=4u l=1.2u b=0 m=1
RRU137 s137 s136 vss rppd w=4u l=1.2u b=0 m=1
RRU138 s138 s137 vss rppd w=4u l=1.2u b=0 m=1
RRU139 s139 s138 vss rppd w=4u l=1.2u b=0 m=1
RRU140 s140 s139 vss rppd w=4u l=1.2u b=0 m=1
RRU141 s141 s140 vss rppd w=4u l=1.2u b=0 m=1
RRU142 s142 s141 vss rppd w=4u l=1.2u b=0 m=1
RRU143 s143 s142 vss rppd w=4u l=1.2u b=0 m=1
RRU144 s144 s143 vss rppd w=4u l=1.2u b=0 m=1
RRU145 s145 s144 vss rppd w=4u l=1.2u b=0 m=1
RRU146 s146 s145 vss rppd w=4u l=1.2u b=0 m=1
RRU147 s147 s146 vss rppd w=4u l=1.2u b=0 m=1
RRU148 s148 s147 vss rppd w=4u l=1.2u b=0 m=1
RRU149 s149 s148 vss rppd w=4u l=1.2u b=0 m=1
RRU150 s150 s149 vss rppd w=4u l=1.2u b=0 m=1
RRU151 s151 s150 vss rppd w=4u l=1.2u b=0 m=1
RRU152 s152 s151 vss rppd w=4u l=1.2u b=0 m=1
RRU153 s153 s152 vss rppd w=4u l=1.2u b=0 m=1
RRU154 s154 s153 vss rppd w=4u l=1.2u b=0 m=1
RRU155 s155 s154 vss rppd w=4u l=1.2u b=0 m=1
RRU156 s156 s155 vss rppd w=4u l=1.2u b=0 m=1
RRU157 s157 s156 vss rppd w=4u l=1.2u b=0 m=1
RRU158 s158 s157 vss rppd w=4u l=1.2u b=0 m=1
RRU159 s159 s158 vss rppd w=4u l=1.2u b=0 m=1
RRU160 s160 s159 vss rppd w=4u l=1.2u b=0 m=1
RRU161 s161 s160 vss rppd w=4u l=1.2u b=0 m=1
RRU162 s162 s161 vss rppd w=4u l=1.2u b=0 m=1
RRU163 s163 s162 vss rppd w=4u l=1.2u b=0 m=1
RRU164 s164 s163 vss rppd w=4u l=1.2u b=0 m=1
RRU165 s165 s164 vss rppd w=4u l=1.2u b=0 m=1
RRU166 s166 s165 vss rppd w=4u l=1.2u b=0 m=1
RRU167 s167 s166 vss rppd w=4u l=1.2u b=0 m=1
RRU168 s168 s167 vss rppd w=4u l=1.2u b=0 m=1
RRU169 s169 s168 vss rppd w=4u l=1.2u b=0 m=1
RRU170 s170 s169 vss rppd w=4u l=1.2u b=0 m=1
RRU171 s171 s170 vss rppd w=4u l=1.2u b=0 m=1
RRU172 s172 s171 vss rppd w=4u l=1.2u b=0 m=1
RRU173 s173 s172 vss rppd w=4u l=1.2u b=0 m=1
RRU174 s174 s173 vss rppd w=4u l=1.2u b=0 m=1
RRU175 s175 s174 vss rppd w=4u l=1.2u b=0 m=1
RRU176 s176 s175 vss rppd w=4u l=1.2u b=0 m=1
RRU177 s177 s176 vss rppd w=4u l=1.2u b=0 m=1
RRU178 s178 s177 vss rppd w=4u l=1.2u b=0 m=1
RRU179 s179 s178 vss rppd w=4u l=1.2u b=0 m=1
RRU180 s180 s179 vss rppd w=4u l=1.2u b=0 m=1
RRU181 s181 s180 vss rppd w=4u l=1.2u b=0 m=1
RRU182 s182 s181 vss rppd w=4u l=1.2u b=0 m=1
RRU183 s183 s182 vss rppd w=4u l=1.2u b=0 m=1
RRU184 s184 s183 vss rppd w=4u l=1.2u b=0 m=1
RRU185 s185 s184 vss rppd w=4u l=1.2u b=0 m=1
RRU186 s186 s185 vss rppd w=4u l=1.2u b=0 m=1
RRU187 s187 s186 vss rppd w=4u l=1.2u b=0 m=1
RRU188 s188 s187 vss rppd w=4u l=1.2u b=0 m=1
RRU189 s189 s188 vss rppd w=4u l=1.2u b=0 m=1
RRU190 s190 s189 vss rppd w=4u l=1.2u b=0 m=1
RRU191 s191 s190 vss rppd w=4u l=1.2u b=0 m=1
RRU192 s192 s191 vss rppd w=4u l=1.2u b=0 m=1
RRU193 s193 s192 vss rppd w=4u l=1.2u b=0 m=1
RRU194 s194 s193 vss rppd w=4u l=1.2u b=0 m=1
RRU195 s195 s194 vss rppd w=4u l=1.2u b=0 m=1
RRU196 s196 s195 vss rppd w=4u l=1.2u b=0 m=1
RRU197 s197 s196 vss rppd w=4u l=1.2u b=0 m=1
RRU198 s198 s197 vss rppd w=4u l=1.2u b=0 m=1
RRU199 s199 s198 vss rppd w=4u l=1.2u b=0 m=1
RRU200 s200 s199 vss rppd w=4u l=1.2u b=0 m=1
RRU201 s201 s200 vss rppd w=4u l=1.2u b=0 m=1
RRU202 s202 s201 vss rppd w=4u l=1.2u b=0 m=1
RRU203 s203 s202 vss rppd w=4u l=1.2u b=0 m=1
RRU204 s204 s203 vss rppd w=4u l=1.2u b=0 m=1
RRU205 s205 s204 vss rppd w=4u l=1.2u b=0 m=1
RRU206 s206 s205 vss rppd w=4u l=1.2u b=0 m=1
RRU207 s207 s206 vss rppd w=4u l=1.2u b=0 m=1
RRU208 s208 s207 vss rppd w=4u l=1.2u b=0 m=1
RRU209 s209 s208 vss rppd w=4u l=1.2u b=0 m=1
RRU210 s210 s209 vss rppd w=4u l=1.2u b=0 m=1
RRU211 s211 s210 vss rppd w=4u l=1.2u b=0 m=1
RRU212 s212 s211 vss rppd w=4u l=1.2u b=0 m=1
RRU213 s213 s212 vss rppd w=4u l=1.2u b=0 m=1
RRU214 s214 s213 vss rppd w=4u l=1.2u b=0 m=1
RRU215 s215 s214 vss rppd w=4u l=1.2u b=0 m=1
RRU216 s216 s215 vss rppd w=4u l=1.2u b=0 m=1
RRU217 s217 s216 vss rppd w=4u l=1.2u b=0 m=1
RRU218 s218 s217 vss rppd w=4u l=1.2u b=0 m=1
RRU219 s219 s218 vss rppd w=4u l=1.2u b=0 m=1
RRU220 s220 s219 vss rppd w=4u l=1.2u b=0 m=1
RRU221 s221 s220 vss rppd w=4u l=1.2u b=0 m=1
RRU222 s222 s221 vss rppd w=4u l=1.2u b=0 m=1
RRU223 s223 s222 vss rppd w=4u l=1.2u b=0 m=1
RRU224 s224 s223 vss rppd w=4u l=1.2u b=0 m=1
RRU225 s225 s224 vss rppd w=4u l=1.2u b=0 m=1
RRU226 s226 s225 vss rppd w=4u l=1.2u b=0 m=1
RRU227 s227 s226 vss rppd w=4u l=1.2u b=0 m=1
RRU228 s228 s227 vss rppd w=4u l=1.2u b=0 m=1
RRU229 s229 s228 vss rppd w=4u l=1.2u b=0 m=1
RRU230 s230 s229 vss rppd w=4u l=1.2u b=0 m=1
RRU231 s231 s230 vss rppd w=4u l=1.2u b=0 m=1
RRU232 s232 s231 vss rppd w=4u l=1.2u b=0 m=1
RRU233 s233 s232 vss rppd w=4u l=1.2u b=0 m=1
RRU234 s234 s233 vss rppd w=4u l=1.2u b=0 m=1
RRU235 s235 s234 vss rppd w=4u l=1.2u b=0 m=1
RRU236 s236 s235 vss rppd w=4u l=1.2u b=0 m=1
RRU237 s237 s236 vss rppd w=4u l=1.2u b=0 m=1
RRU238 s238 s237 vss rppd w=4u l=1.2u b=0 m=1
RRU239 s239 s238 vss rppd w=4u l=1.2u b=0 m=1
RRU240 s240 s239 vss rppd w=4u l=1.2u b=0 m=1
RRU241 s241 s240 vss rppd w=4u l=1.2u b=0 m=1
RRU242 s242 s241 vss rppd w=4u l=1.2u b=0 m=1
RRU243 s243 s242 vss rppd w=4u l=1.2u b=0 m=1
RRU244 s244 s243 vss rppd w=4u l=1.2u b=0 m=1
RRU245 s245 s244 vss rppd w=4u l=1.2u b=0 m=1
RRU246 s246 s245 vss rppd w=4u l=1.2u b=0 m=1
RRU247 s247 s246 vss rppd w=4u l=1.2u b=0 m=1
RRU248 s248 s247 vss rppd w=4u l=1.2u b=0 m=1
RRU249 s249 s248 vss rppd w=4u l=1.2u b=0 m=1
RRU250 s250 s249 vss rppd w=4u l=1.2u b=0 m=1
RRU251 s251 s250 vss rppd w=4u l=1.2u b=0 m=1
RRU252 s252 s251 vss rppd w=4u l=1.2u b=0 m=1
RRU253 s253 s252 vss rppd w=4u l=1.2u b=0 m=1
RRU254 t0 s253 vss rppd w=4u l=1.2u b=0 m=1
RRU255 t1 t0 vss rppd w=4u l=1.2u b=0 m=1
RRU256 t2 t1 vss rppd w=4u l=1.2u b=0 m=1
RRU257 t3 t2 vss rppd w=4u l=1.2u b=0 m=1
RRU258 t4 t3 vss rppd w=4u l=1.2u b=0 m=1
RRU259 t5 t4 vss rppd w=4u l=1.2u b=0 m=1
RRU260 t6 t5 vss rppd w=4u l=1.2u b=0 m=1
RRU261 t7 t6 vss rppd w=4u l=1.2u b=0 m=1
RRU262 t8 t7 vss rppd w=4u l=1.2u b=0 m=1
RRU263 t9 t8 vss rppd w=4u l=1.2u b=0 m=1
RRU264 t10 t9 vss rppd w=4u l=1.2u b=0 m=1
RRU265 t11 t10 vss rppd w=4u l=1.2u b=0 m=1
RRU266 t12 t11 vss rppd w=4u l=1.2u b=0 m=1
RRU267 t13 t12 vss rppd w=4u l=1.2u b=0 m=1
RRU268 t14 t13 vss rppd w=4u l=1.2u b=0 m=1
RRU269 t15 t14 vss rppd w=4u l=1.2u b=0 m=1
RRU270 t16 t15 vss rppd w=4u l=1.2u b=0 m=1
RRU271 t17 t16 vss rppd w=4u l=1.2u b=0 m=1
RRU272 t18 t17 vss rppd w=4u l=1.2u b=0 m=1
RRU273 t19 t18 vss rppd w=4u l=1.2u b=0 m=1
RRU274 t20 t19 vss rppd w=4u l=1.2u b=0 m=1
RRU275 t21 t20 vss rppd w=4u l=1.2u b=0 m=1
RRU276 t22 t21 vss rppd w=4u l=1.2u b=0 m=1
RRU277 t23 t22 vss rppd w=4u l=1.2u b=0 m=1
RRU278 t24 t23 vss rppd w=4u l=1.2u b=0 m=1
RRU279 t25 t24 vss rppd w=4u l=1.2u b=0 m=1
RRU280 t26 t25 vss rppd w=4u l=1.2u b=0 m=1
RRU281 t27 t26 vss rppd w=4u l=1.2u b=0 m=1
RRU282 t28 t27 vss rppd w=4u l=1.2u b=0 m=1
RRU283 t29 t28 vss rppd w=4u l=1.2u b=0 m=1
RRU284 t30 t29 vss rppd w=4u l=1.2u b=0 m=1
RRU285 t31 t30 vss rppd w=4u l=1.2u b=0 m=1
RRU286 t32 t31 vss rppd w=4u l=1.2u b=0 m=1
RRU287 t33 t32 vss rppd w=4u l=1.2u b=0 m=1
RRU288 t34 t33 vss rppd w=4u l=1.2u b=0 m=1
RRU289 t35 t34 vss rppd w=4u l=1.2u b=0 m=1
RRU290 t36 t35 vss rppd w=4u l=1.2u b=0 m=1
RRU291 t37 t36 vss rppd w=4u l=1.2u b=0 m=1
RRU292 t38 t37 vss rppd w=4u l=1.2u b=0 m=1
RRU293 t39 t38 vss rppd w=4u l=1.2u b=0 m=1
RRU294 t40 t39 vss rppd w=4u l=1.2u b=0 m=1
RRU295 t41 t40 vss rppd w=4u l=1.2u b=0 m=1
RRU296 t42 t41 vss rppd w=4u l=1.2u b=0 m=1
RRU297 t43 t42 vss rppd w=4u l=1.2u b=0 m=1
RRU298 t44 t43 vss rppd w=4u l=1.2u b=0 m=1
RRU299 t45 t44 vss rppd w=4u l=1.2u b=0 m=1
RRU300 t46 t45 vss rppd w=4u l=1.2u b=0 m=1
RRU301 t47 t46 vss rppd w=4u l=1.2u b=0 m=1
RRU302 t48 t47 vss rppd w=4u l=1.2u b=0 m=1
RRU303 t49 t48 vss rppd w=4u l=1.2u b=0 m=1
RRU304 t50 t49 vss rppd w=4u l=1.2u b=0 m=1
RRU305 t51 t50 vss rppd w=4u l=1.2u b=0 m=1
RRU306 t52 t51 vss rppd w=4u l=1.2u b=0 m=1
RRU307 t53 t52 vss rppd w=4u l=1.2u b=0 m=1
RRU308 t54 t53 vss rppd w=4u l=1.2u b=0 m=1
RRU309 t55 t54 vss rppd w=4u l=1.2u b=0 m=1
RRU310 t56 t55 vss rppd w=4u l=1.2u b=0 m=1
RRU311 t57 t56 vss rppd w=4u l=1.2u b=0 m=1
RRU312 t58 t57 vss rppd w=4u l=1.2u b=0 m=1
RRU313 t59 t58 vss rppd w=4u l=1.2u b=0 m=1
RRU314 t60 t59 vss rppd w=4u l=1.2u b=0 m=1
RRU315 t61 t60 vss rppd w=4u l=1.2u b=0 m=1
RRU316 t62 t61 vss rppd w=4u l=1.2u b=0 m=1
RRU317 t63 t62 vss rppd w=4u l=1.2u b=0 m=1
RRU318 t64 t63 vss rppd w=4u l=1.2u b=0 m=1
RRU319 t65 t64 vss rppd w=4u l=1.2u b=0 m=1
RRU320 t66 t65 vss rppd w=4u l=1.2u b=0 m=1
RRU321 t67 t66 vss rppd w=4u l=1.2u b=0 m=1
RRU322 t68 t67 vss rppd w=4u l=1.2u b=0 m=1
RRU323 t69 t68 vss rppd w=4u l=1.2u b=0 m=1
RRU324 t70 t69 vss rppd w=4u l=1.2u b=0 m=1
RRU325 t71 t70 vss rppd w=4u l=1.2u b=0 m=1
RRU326 t72 t71 vss rppd w=4u l=1.2u b=0 m=1
RRU327 t73 t72 vss rppd w=4u l=1.2u b=0 m=1
RRU328 t74 t73 vss rppd w=4u l=1.2u b=0 m=1
RRU329 t75 t74 vss rppd w=4u l=1.2u b=0 m=1
RRU330 t76 t75 vss rppd w=4u l=1.2u b=0 m=1
RRU331 t77 t76 vss rppd w=4u l=1.2u b=0 m=1
RRU332 t78 t77 vss rppd w=4u l=1.2u b=0 m=1
RRU333 t79 t78 vss rppd w=4u l=1.2u b=0 m=1
RRU334 t80 t79 vss rppd w=4u l=1.2u b=0 m=1
RRU335 t81 t80 vss rppd w=4u l=1.2u b=0 m=1
RRU336 t82 t81 vss rppd w=4u l=1.2u b=0 m=1
RRU337 t83 t82 vss rppd w=4u l=1.2u b=0 m=1
RRU338 t84 t83 vss rppd w=4u l=1.2u b=0 m=1
RRU339 t85 t84 vss rppd w=4u l=1.2u b=0 m=1
RRU340 t86 t85 vss rppd w=4u l=1.2u b=0 m=1
RRU341 t87 t86 vss rppd w=4u l=1.2u b=0 m=1
RRU342 t88 t87 vss rppd w=4u l=1.2u b=0 m=1
RRU343 t89 t88 vss rppd w=4u l=1.2u b=0 m=1
RRU344 t90 t89 vss rppd w=4u l=1.2u b=0 m=1
RRU345 t91 t90 vss rppd w=4u l=1.2u b=0 m=1
RRU346 t92 t91 vss rppd w=4u l=1.2u b=0 m=1
RRU347 t93 t92 vss rppd w=4u l=1.2u b=0 m=1
RRU348 t94 t93 vss rppd w=4u l=1.2u b=0 m=1
RRU349 t95 t94 vss rppd w=4u l=1.2u b=0 m=1
RRU350 t96 t95 vss rppd w=4u l=1.2u b=0 m=1
RRU351 t97 t96 vss rppd w=4u l=1.2u b=0 m=1
RRU352 t98 t97 vss rppd w=4u l=1.2u b=0 m=1
RRU353 t99 t98 vss rppd w=4u l=1.2u b=0 m=1
RRU354 t100 t99 vss rppd w=4u l=1.2u b=0 m=1
RRU355 t101 t100 vss rppd w=4u l=1.2u b=0 m=1
RRU356 t102 t101 vss rppd w=4u l=1.2u b=0 m=1
RRU357 t103 t102 vss rppd w=4u l=1.2u b=0 m=1
RRU358 t104 t103 vss rppd w=4u l=1.2u b=0 m=1
RRU359 t105 t104 vss rppd w=4u l=1.2u b=0 m=1
RRU360 t106 t105 vss rppd w=4u l=1.2u b=0 m=1
RRU361 t107 t106 vss rppd w=4u l=1.2u b=0 m=1
RRU362 t108 t107 vss rppd w=4u l=1.2u b=0 m=1
RRU363 t109 t108 vss rppd w=4u l=1.2u b=0 m=1
RRU364 t110 t109 vss rppd w=4u l=1.2u b=0 m=1
RRU365 t111 t110 vss rppd w=4u l=1.2u b=0 m=1
RRU366 t112 t111 vss rppd w=4u l=1.2u b=0 m=1
RRU367 t113 t112 vss rppd w=4u l=1.2u b=0 m=1
RRU368 t114 t113 vss rppd w=4u l=1.2u b=0 m=1
RRU369 t115 t114 vss rppd w=4u l=1.2u b=0 m=1
RRU370 t116 t115 vss rppd w=4u l=1.2u b=0 m=1
RRU371 t117 t116 vss rppd w=4u l=1.2u b=0 m=1
RRU372 t118 t117 vss rppd w=4u l=1.2u b=0 m=1
RRU373 t119 t118 vss rppd w=4u l=1.2u b=0 m=1
RRU374 t120 t119 vss rppd w=4u l=1.2u b=0 m=1
RRU375 t121 t120 vss rppd w=4u l=1.2u b=0 m=1
RRU376 t122 t121 vss rppd w=4u l=1.2u b=0 m=1
RRU377 t123 t122 vss rppd w=4u l=1.2u b=0 m=1
RRU378 t124 t123 vss rppd w=4u l=1.2u b=0 m=1
RRU379 t125 t124 vss rppd w=4u l=1.2u b=0 m=1
RRU380 t126 t125 vss rppd w=4u l=1.2u b=0 m=1
RRU381 t127 t126 vss rppd w=4u l=1.2u b=0 m=1
RRU382 t128 t127 vss rppd w=4u l=1.2u b=0 m=1
RRU383 t129 t128 vss rppd w=4u l=1.2u b=0 m=1
RRU384 t130 t129 vss rppd w=4u l=1.2u b=0 m=1
RRU385 t131 t130 vss rppd w=4u l=1.2u b=0 m=1
RRU386 t132 t131 vss rppd w=4u l=1.2u b=0 m=1
RRU387 t133 t132 vss rppd w=4u l=1.2u b=0 m=1
RRU388 t134 t133 vss rppd w=4u l=1.2u b=0 m=1
RRU389 t135 t134 vss rppd w=4u l=1.2u b=0 m=1
RRU390 t136 t135 vss rppd w=4u l=1.2u b=0 m=1
RRU391 t137 t136 vss rppd w=4u l=1.2u b=0 m=1
RRU392 t138 t137 vss rppd w=4u l=1.2u b=0 m=1
RRU393 t139 t138 vss rppd w=4u l=1.2u b=0 m=1
RRU394 t140 t139 vss rppd w=4u l=1.2u b=0 m=1
RRU395 t141 t140 vss rppd w=4u l=1.2u b=0 m=1
RRU396 t142 t141 vss rppd w=4u l=1.2u b=0 m=1
RRU397 t143 t142 vss rppd w=4u l=1.2u b=0 m=1
RRU398 t144 t143 vss rppd w=4u l=1.2u b=0 m=1
RRU399 t145 t144 vss rppd w=4u l=1.2u b=0 m=1
RRU400 t146 t145 vss rppd w=4u l=1.2u b=0 m=1
RRU401 t147 t146 vss rppd w=4u l=1.2u b=0 m=1
RRU402 t148 t147 vss rppd w=4u l=1.2u b=0 m=1
RRU403 t149 t148 vss rppd w=4u l=1.2u b=0 m=1
RRU404 t150 t149 vss rppd w=4u l=1.2u b=0 m=1
RRU405 t151 t150 vss rppd w=4u l=1.2u b=0 m=1
RRU406 t152 t151 vss rppd w=4u l=1.2u b=0 m=1
RRU407 t153 t152 vss rppd w=4u l=1.2u b=0 m=1
RRU408 t154 t153 vss rppd w=4u l=1.2u b=0 m=1
RRU409 t155 t154 vss rppd w=4u l=1.2u b=0 m=1
RRU410 t156 t155 vss rppd w=4u l=1.2u b=0 m=1
RRU411 t157 t156 vss rppd w=4u l=1.2u b=0 m=1
RRU412 t158 t157 vss rppd w=4u l=1.2u b=0 m=1
RRU413 t159 t158 vss rppd w=4u l=1.2u b=0 m=1
RRU414 t160 t159 vss rppd w=4u l=1.2u b=0 m=1
RRU415 t161 t160 vss rppd w=4u l=1.2u b=0 m=1
RRU416 t162 t161 vss rppd w=4u l=1.2u b=0 m=1
RRU417 t163 t162 vss rppd w=4u l=1.2u b=0 m=1
RRU418 t164 t163 vss rppd w=4u l=1.2u b=0 m=1
RRU419 t165 t164 vss rppd w=4u l=1.2u b=0 m=1
RRU420 t166 t165 vss rppd w=4u l=1.2u b=0 m=1
RRU421 t167 t166 vss rppd w=4u l=1.2u b=0 m=1
RRU422 t168 t167 vss rppd w=4u l=1.2u b=0 m=1
RRU423 t169 t168 vss rppd w=4u l=1.2u b=0 m=1
RRU424 t170 t169 vss rppd w=4u l=1.2u b=0 m=1
RRU425 t171 t170 vss rppd w=4u l=1.2u b=0 m=1
RRU426 t172 t171 vss rppd w=4u l=1.2u b=0 m=1
RRU427 t173 t172 vss rppd w=4u l=1.2u b=0 m=1
RRU428 t174 t173 vss rppd w=4u l=1.2u b=0 m=1
RRU429 t175 t174 vss rppd w=4u l=1.2u b=0 m=1
RRU430 t176 t175 vss rppd w=4u l=1.2u b=0 m=1
RRU431 t177 t176 vss rppd w=4u l=1.2u b=0 m=1
RRU432 t178 t177 vss rppd w=4u l=1.2u b=0 m=1
RRU433 t179 t178 vss rppd w=4u l=1.2u b=0 m=1
RRU434 t180 t179 vss rppd w=4u l=1.2u b=0 m=1
RRU435 t181 t180 vss rppd w=4u l=1.2u b=0 m=1
RRU436 t182 t181 vss rppd w=4u l=1.2u b=0 m=1
RRU437 t183 t182 vss rppd w=4u l=1.2u b=0 m=1
RRU438 t184 t183 vss rppd w=4u l=1.2u b=0 m=1
RRU439 t185 t184 vss rppd w=4u l=1.2u b=0 m=1
RRU440 t186 t185 vss rppd w=4u l=1.2u b=0 m=1
RRU441 t187 t186 vss rppd w=4u l=1.2u b=0 m=1
RRU442 t188 t187 vss rppd w=4u l=1.2u b=0 m=1
RRU443 t189 t188 vss rppd w=4u l=1.2u b=0 m=1
RRU444 t190 t189 vss rppd w=4u l=1.2u b=0 m=1
RRU445 t191 t190 vss rppd w=4u l=1.2u b=0 m=1
RRU446 t192 t191 vss rppd w=4u l=1.2u b=0 m=1
RRU447 t193 t192 vss rppd w=4u l=1.2u b=0 m=1
RRU448 t194 t193 vss rppd w=4u l=1.2u b=0 m=1
RRU449 t195 t194 vss rppd w=4u l=1.2u b=0 m=1
RRU450 t196 t195 vss rppd w=4u l=1.2u b=0 m=1
RRU451 t197 t196 vss rppd w=4u l=1.2u b=0 m=1
RRU452 t198 t197 vss rppd w=4u l=1.2u b=0 m=1
RRU453 t199 t198 vss rppd w=4u l=1.2u b=0 m=1
RRU454 t200 t199 vss rppd w=4u l=1.2u b=0 m=1
RRU455 t201 t200 vss rppd w=4u l=1.2u b=0 m=1
RRU456 t202 t201 vss rppd w=4u l=1.2u b=0 m=1
RRU457 t203 t202 vss rppd w=4u l=1.2u b=0 m=1
RRU458 t204 t203 vss rppd w=4u l=1.2u b=0 m=1
RRU459 t205 t204 vss rppd w=4u l=1.2u b=0 m=1
RRU460 t206 t205 vss rppd w=4u l=1.2u b=0 m=1
RRU461 t207 t206 vss rppd w=4u l=1.2u b=0 m=1
RRU462 t208 t207 vss rppd w=4u l=1.2u b=0 m=1
RRU463 t209 t208 vss rppd w=4u l=1.2u b=0 m=1
RRU464 t210 t209 vss rppd w=4u l=1.2u b=0 m=1
RRU465 t211 t210 vss rppd w=4u l=1.2u b=0 m=1
RRU466 t212 t211 vss rppd w=4u l=1.2u b=0 m=1
RRU467 t213 t212 vss rppd w=4u l=1.2u b=0 m=1
RRU468 t214 t213 vss rppd w=4u l=1.2u b=0 m=1
RRU469 t215 t214 vss rppd w=4u l=1.2u b=0 m=1
RRU470 t216 t215 vss rppd w=4u l=1.2u b=0 m=1
RRU471 t217 t216 vss rppd w=4u l=1.2u b=0 m=1
RRU472 t218 t217 vss rppd w=4u l=1.2u b=0 m=1
RRU473 t219 t218 vss rppd w=4u l=1.2u b=0 m=1
RRU474 t220 t219 vss rppd w=4u l=1.2u b=0 m=1
RRU475 t221 t220 vss rppd w=4u l=1.2u b=0 m=1
RRU476 t222 t221 vss rppd w=4u l=1.2u b=0 m=1
RRU477 t223 t222 vss rppd w=4u l=1.2u b=0 m=1
RRU478 t224 t223 vss rppd w=4u l=1.2u b=0 m=1
RRU479 t225 t224 vss rppd w=4u l=1.2u b=0 m=1
RRU480 t226 t225 vss rppd w=4u l=1.2u b=0 m=1
RRU481 t227 t226 vss rppd w=4u l=1.2u b=0 m=1
RRU482 t228 t227 vss rppd w=4u l=1.2u b=0 m=1
RRU483 t229 t228 vss rppd w=4u l=1.2u b=0 m=1
RRU484 t230 t229 vss rppd w=4u l=1.2u b=0 m=1
RRU485 t231 t230 vss rppd w=4u l=1.2u b=0 m=1
RRU486 t232 t231 vss rppd w=4u l=1.2u b=0 m=1
RRU487 t233 t232 vss rppd w=4u l=1.2u b=0 m=1
RRU488 t234 t233 vss rppd w=4u l=1.2u b=0 m=1
RRU489 t235 t234 vss rppd w=4u l=1.2u b=0 m=1
RRU490 t236 t235 vss rppd w=4u l=1.2u b=0 m=1
RRU491 t237 t236 vss rppd w=4u l=1.2u b=0 m=1
RRU492 t238 t237 vss rppd w=4u l=1.2u b=0 m=1
RRU493 t239 t238 vss rppd w=4u l=1.2u b=0 m=1
RRU494 t240 t239 vss rppd w=4u l=1.2u b=0 m=1
RRU495 t241 t240 vss rppd w=4u l=1.2u b=0 m=1
RRU496 t242 t241 vss rppd w=4u l=1.2u b=0 m=1
RRU497 t243 t242 vss rppd w=4u l=1.2u b=0 m=1
RRU498 t244 t243 vss rppd w=4u l=1.2u b=0 m=1
RRU499 t245 t244 vss rppd w=4u l=1.2u b=0 m=1
RRU500 t246 t245 vss rppd w=4u l=1.2u b=0 m=1
RRU501 t247 t246 vss rppd w=4u l=1.2u b=0 m=1
RRU502 t248 t247 vss rppd w=4u l=1.2u b=0 m=1
RRU503 t249 t248 vss rppd w=4u l=1.2u b=0 m=1
RRU504 t250 t249 vss rppd w=4u l=1.2u b=0 m=1
RRU505 t251 t250 vss rppd w=4u l=1.2u b=0 m=1
RRU506 t252 t251 vss rppd w=4u l=1.2u b=0 m=1
RRU507 t253 t252 vss rppd w=4u l=1.2u b=0 m=1
RRU508 t254 t253 vss rppd w=4u l=1.2u b=0 m=1
RRU509 t255 t254 vss rppd w=4u l=1.2u b=0 m=1
RRU510 s510 t255 vss rppd w=4u l=1.2u b=0 m=1
RRU511 s511 s510 vss rppd w=4u l=1.2u b=0 m=1
RRU512 s512 s511 vss rppd w=4u l=1.2u b=0 m=1
RRU513 s513 s512 vss rppd w=4u l=1.2u b=0 m=1
RRU514 s514 s513 vss rppd w=4u l=1.2u b=0 m=1
RRU515 s515 s514 vss rppd w=4u l=1.2u b=0 m=1
RRU516 s516 s515 vss rppd w=4u l=1.2u b=0 m=1
RRU517 s517 s516 vss rppd w=4u l=1.2u b=0 m=1
RRU518 s518 s517 vss rppd w=4u l=1.2u b=0 m=1
RRU519 s519 s518 vss rppd w=4u l=1.2u b=0 m=1
RRU520 s520 s519 vss rppd w=4u l=1.2u b=0 m=1
RRU521 s521 s520 vss rppd w=4u l=1.2u b=0 m=1
RRU522 s522 s521 vss rppd w=4u l=1.2u b=0 m=1
RRU523 s523 s522 vss rppd w=4u l=1.2u b=0 m=1
RRU524 s524 s523 vss rppd w=4u l=1.2u b=0 m=1
RRU525 s525 s524 vss rppd w=4u l=1.2u b=0 m=1
RRU526 s526 s525 vss rppd w=4u l=1.2u b=0 m=1
RRU527 s527 s526 vss rppd w=4u l=1.2u b=0 m=1
RRU528 s528 s527 vss rppd w=4u l=1.2u b=0 m=1
RRU529 vref s528 vss rppd w=4u l=1.2u b=0 m=1
XLU0 d0 dh0 dhn0 vdd vdda vss g1_tlvlup
XLU1 d1 dh1 dhn1 vdd vdda vss g1_tlvlup
XLU2 d2 dh2 dhn2 vdd vdda vss g1_tlvlup
XLU3 d3 dh3 dhn3 vdd vdda vss g1_tlvlup
XLU4 d4 dh4 dhn4 vdd vdda vss g1_tlvlup
XLU5 d5 dh5 dhn5 vdd vdda vss g1_tlvlup
XLU6 d6 dh6 dhn6 vdd vdda vss g1_tlvlup
XLU7 d7 dh7 dhn7 vdd vdda vss g1_tlvlup
MMS0_0a t0 dhn0 m0_0 vss sg13_hv_nmos w=2u l=0.45u m=1
MMS0_0b t1 dh0 m0_0 vss sg13_hv_nmos w=2u l=0.45u m=1
MMS0_1a t2 dhn0 m0_1 vss sg13_hv_nmos w=2u l=0.45u m=1
MMS0_1b t3 dh0 m0_1 vss sg13_hv_nmos w=2u l=0.45u m=1
MMS0_2a t4 dhn0 m0_2 vss sg13_hv_nmos w=2u l=0.45u m=1
MMS0_2b t5 dh0 m0_2 vss sg13_hv_nmos w=2u l=0.45u m=1
MMS0_3a t6 dhn0 m0_3 vss sg13_hv_nmos w=2u l=0.45u m=1
MMS0_3b t7 dh0 m0_3 vss sg13_hv_nmos w=2u l=0.45u m=1
MMS0_4a t8 dhn0 m0_4 vss sg13_hv_nmos w=2u l=0.45u m=1
MMS0_4b t9 dh0 m0_4 vss sg13_hv_nmos w=2u l=0.45u m=1
MMS0_5a t10 dhn0 m0_5 vss sg13_hv_nmos w=2u l=0.45u m=1
MMS0_5b t11 dh0 m0_5 vss sg13_hv_nmos w=2u l=0.45u m=1
MMS0_6a t12 dhn0 m0_6 vss sg13_hv_nmos w=2u l=0.45u m=1
MMS0_6b t13 dh0 m0_6 vss sg13_hv_nmos w=2u l=0.45u m=1
MMS0_7a t14 dhn0 m0_7 vss sg13_hv_nmos w=2u l=0.45u m=1
MMS0_7b t15 dh0 m0_7 vss sg13_hv_nmos w=2u l=0.45u m=1
MMS0_8a t16 dhn0 m0_8 vss sg13_hv_nmos w=2u l=0.45u m=1
MMS0_8b t17 dh0 m0_8 vss sg13_hv_nmos w=2u l=0.45u m=1
MMS0_9a t18 dhn0 m0_9 vss sg13_hv_nmos w=2u l=0.45u m=1
MMS0_9b t19 dh0 m0_9 vss sg13_hv_nmos w=2u l=0.45u m=1
MMS0_10a t20 dhn0 m0_10 vss sg13_hv_nmos w=2u l=0.45u m=1
MMS0_10b t21 dh0 m0_10 vss sg13_hv_nmos w=2u l=0.45u m=1
MMS0_11a t22 dhn0 m0_11 vss sg13_hv_nmos w=2u l=0.45u m=1
MMS0_11b t23 dh0 m0_11 vss sg13_hv_nmos w=2u l=0.45u m=1
MMS0_12a t24 dhn0 m0_12 vss sg13_hv_nmos w=2u l=0.45u m=1
MMS0_12b t25 dh0 m0_12 vss sg13_hv_nmos w=2u l=0.45u m=1
MMS0_13a t26 dhn0 m0_13 vss sg13_hv_nmos w=2u l=0.45u m=1
MMS0_13b t27 dh0 m0_13 vss sg13_hv_nmos w=2u l=0.45u m=1
MMS0_14a t28 dhn0 m0_14 vss sg13_hv_nmos w=2u l=0.45u m=1
MMS0_14b t29 dh0 m0_14 vss sg13_hv_nmos w=2u l=0.45u m=1
MMS0_15a t30 dhn0 m0_15 vss sg13_hv_nmos w=2u l=0.45u m=1
MMS0_15b t31 dh0 m0_15 vss sg13_hv_nmos w=2u l=0.45u m=1
MMS0_16a t32 dhn0 m0_16 vss sg13_hv_nmos w=2u l=0.45u m=1
MMS0_16b t33 dh0 m0_16 vss sg13_hv_nmos w=2u l=0.45u m=1
MMS0_17a t34 dhn0 m0_17 vss sg13_hv_nmos w=2u l=0.45u m=1
MMS0_17b t35 dh0 m0_17 vss sg13_hv_nmos w=2u l=0.45u m=1
MMS0_18a t36 dhn0 m0_18 vss sg13_hv_nmos w=2u l=0.45u m=1
MMS0_18b t37 dh0 m0_18 vss sg13_hv_nmos w=2u l=0.45u m=1
MMS0_19a t38 dhn0 m0_19 vss sg13_hv_nmos w=2u l=0.45u m=1
MMS0_19b t39 dh0 m0_19 vss sg13_hv_nmos w=2u l=0.45u m=1
MMS0_20a t40 dhn0 m0_20 vss sg13_hv_nmos w=2u l=0.45u m=1
MMS0_20b t41 dh0 m0_20 vss sg13_hv_nmos w=2u l=0.45u m=1
MMS0_21a t42 dhn0 m0_21 vss sg13_hv_nmos w=2u l=0.45u m=1
MMS0_21b t43 dh0 m0_21 vss sg13_hv_nmos w=2u l=0.45u m=1
MMS0_22a t44 dhn0 m0_22 vss sg13_hv_nmos w=2u l=0.45u m=1
MMS0_22b t45 dh0 m0_22 vss sg13_hv_nmos w=2u l=0.45u m=1
MMS0_23a t46 dhn0 m0_23 vss sg13_hv_nmos w=2u l=0.45u m=1
MMS0_23b t47 dh0 m0_23 vss sg13_hv_nmos w=2u l=0.45u m=1
MMS0_24a t48 dhn0 m0_24 vss sg13_hv_nmos w=2u l=0.45u m=1
MMS0_24b t49 dh0 m0_24 vss sg13_hv_nmos w=2u l=0.45u m=1
MMS0_25a t50 dhn0 m0_25 vss sg13_hv_nmos w=2u l=0.45u m=1
MMS0_25b t51 dh0 m0_25 vss sg13_hv_nmos w=2u l=0.45u m=1
MMS0_26a t52 dhn0 m0_26 vss sg13_hv_nmos w=2u l=0.45u m=1
MMS0_26b t53 dh0 m0_26 vss sg13_hv_nmos w=2u l=0.45u m=1
MMS0_27a t54 dhn0 m0_27 vss sg13_hv_nmos w=2u l=0.45u m=1
MMS0_27b t55 dh0 m0_27 vss sg13_hv_nmos w=2u l=0.45u m=1
MMS0_28a t56 dhn0 m0_28 vss sg13_hv_nmos w=2u l=0.45u m=1
MMS0_28b t57 dh0 m0_28 vss sg13_hv_nmos w=2u l=0.45u m=1
MMS0_29a t58 dhn0 m0_29 vss sg13_hv_nmos w=2u l=0.45u m=1
MMS0_29b t59 dh0 m0_29 vss sg13_hv_nmos w=2u l=0.45u m=1
MMS0_30a t60 dhn0 m0_30 vss sg13_hv_nmos w=2u l=0.45u m=1
MMS0_30b t61 dh0 m0_30 vss sg13_hv_nmos w=2u l=0.45u m=1
MMS0_31a t62 dhn0 m0_31 vss sg13_hv_nmos w=2u l=0.45u m=1
MMS0_31b t63 dh0 m0_31 vss sg13_hv_nmos w=2u l=0.45u m=1
MMS0_32a t64 dhn0 m0_32 vss sg13_hv_nmos w=2u l=0.45u m=1
MMS0_32b t65 dh0 m0_32 vss sg13_hv_nmos w=2u l=0.45u m=1
MMS0_33a t66 dhn0 m0_33 vss sg13_hv_nmos w=2u l=0.45u m=1
MMS0_33b t67 dh0 m0_33 vss sg13_hv_nmos w=2u l=0.45u m=1
MMS0_34a t68 dhn0 m0_34 vss sg13_hv_nmos w=2u l=0.45u m=1
MMS0_34b t69 dh0 m0_34 vss sg13_hv_nmos w=2u l=0.45u m=1
MMS0_35a t70 dhn0 m0_35 vss sg13_hv_nmos w=2u l=0.45u m=1
MMS0_35b t71 dh0 m0_35 vss sg13_hv_nmos w=2u l=0.45u m=1
MMS0_36a t72 dhn0 m0_36 vss sg13_hv_nmos w=2u l=0.45u m=1
MMS0_36b t73 dh0 m0_36 vss sg13_hv_nmos w=2u l=0.45u m=1
MMS0_37a t74 dhn0 m0_37 vss sg13_hv_nmos w=2u l=0.45u m=1
MMS0_37b t75 dh0 m0_37 vss sg13_hv_nmos w=2u l=0.45u m=1
MMS0_38a t76 dhn0 m0_38 vss sg13_hv_nmos w=2u l=0.45u m=1
MMS0_38b t77 dh0 m0_38 vss sg13_hv_nmos w=2u l=0.45u m=1
MMS0_39a t78 dhn0 m0_39 vss sg13_hv_nmos w=2u l=0.45u m=1
MMS0_39b t79 dh0 m0_39 vss sg13_hv_nmos w=2u l=0.45u m=1
MMS0_40a t80 dhn0 m0_40 vss sg13_hv_nmos w=2u l=0.45u m=1
MMS0_40b t81 dh0 m0_40 vss sg13_hv_nmos w=2u l=0.45u m=1
MMS0_41a t82 dhn0 m0_41 vss sg13_hv_nmos w=2u l=0.45u m=1
MMS0_41b t83 dh0 m0_41 vss sg13_hv_nmos w=2u l=0.45u m=1
MMS0_42a t84 dhn0 m0_42 vss sg13_hv_nmos w=2u l=0.45u m=1
MMS0_42b t85 dh0 m0_42 vss sg13_hv_nmos w=2u l=0.45u m=1
MMS0_43a t86 dhn0 m0_43 vss sg13_hv_nmos w=2u l=0.45u m=1
MMS0_43b t87 dh0 m0_43 vss sg13_hv_nmos w=2u l=0.45u m=1
MMS0_44a t88 dhn0 m0_44 vss sg13_hv_nmos w=2u l=0.45u m=1
MMS0_44b t89 dh0 m0_44 vss sg13_hv_nmos w=2u l=0.45u m=1
MMS0_45a t90 dhn0 m0_45 vss sg13_hv_nmos w=2u l=0.45u m=1
MMS0_45b t91 dh0 m0_45 vss sg13_hv_nmos w=2u l=0.45u m=1
MMS0_46a t92 dhn0 m0_46 vss sg13_hv_nmos w=2u l=0.45u m=1
MMS0_46b t93 dh0 m0_46 vss sg13_hv_nmos w=2u l=0.45u m=1
MMS0_47a t94 dhn0 m0_47 vss sg13_hv_nmos w=2u l=0.45u m=1
MMS0_47b t95 dh0 m0_47 vss sg13_hv_nmos w=2u l=0.45u m=1
MMS0_48a t96 dhn0 m0_48 vss sg13_hv_nmos w=2u l=0.45u m=1
MMS0_48b t97 dh0 m0_48 vss sg13_hv_nmos w=2u l=0.45u m=1
MMS0_49a t98 dhn0 m0_49 vss sg13_hv_nmos w=2u l=0.45u m=1
MMS0_49b t99 dh0 m0_49 vss sg13_hv_nmos w=2u l=0.45u m=1
MMS0_50a t100 dhn0 m0_50 vss sg13_hv_nmos w=2u l=0.45u m=1
MMS0_50b t101 dh0 m0_50 vss sg13_hv_nmos w=2u l=0.45u m=1
MMS0_51a t102 dhn0 m0_51 vss sg13_hv_nmos w=2u l=0.45u m=1
MMS0_51b t103 dh0 m0_51 vss sg13_hv_nmos w=2u l=0.45u m=1
MMS0_52a t104 dhn0 m0_52 vss sg13_hv_nmos w=2u l=0.45u m=1
MMS0_52b t105 dh0 m0_52 vss sg13_hv_nmos w=2u l=0.45u m=1
MMS0_53a t106 dhn0 m0_53 vss sg13_hv_nmos w=2u l=0.45u m=1
MMS0_53b t107 dh0 m0_53 vss sg13_hv_nmos w=2u l=0.45u m=1
MMS0_54a t108 dhn0 m0_54 vss sg13_hv_nmos w=2u l=0.45u m=1
MMS0_54b t109 dh0 m0_54 vss sg13_hv_nmos w=2u l=0.45u m=1
MMS0_55a t110 dhn0 m0_55 vss sg13_hv_nmos w=2u l=0.45u m=1
MMS0_55b t111 dh0 m0_55 vss sg13_hv_nmos w=2u l=0.45u m=1
MMS0_56a t112 dhn0 m0_56 vss sg13_hv_nmos w=2u l=0.45u m=1
MMS0_56b t113 dh0 m0_56 vss sg13_hv_nmos w=2u l=0.45u m=1
MMS0_57a t114 dhn0 m0_57 vss sg13_hv_nmos w=2u l=0.45u m=1
MMS0_57b t115 dh0 m0_57 vss sg13_hv_nmos w=2u l=0.45u m=1
MMS0_58a t116 dhn0 m0_58 vss sg13_hv_nmos w=2u l=0.45u m=1
MMS0_58b t117 dh0 m0_58 vss sg13_hv_nmos w=2u l=0.45u m=1
MMS0_59a t118 dhn0 m0_59 vss sg13_hv_nmos w=2u l=0.45u m=1
MMS0_59b t119 dh0 m0_59 vss sg13_hv_nmos w=2u l=0.45u m=1
MMS0_60a t120 dhn0 m0_60 vss sg13_hv_nmos w=2u l=0.45u m=1
MMS0_60b t121 dh0 m0_60 vss sg13_hv_nmos w=2u l=0.45u m=1
MMS0_61a t122 dhn0 m0_61 vss sg13_hv_nmos w=2u l=0.45u m=1
MMS0_61b t123 dh0 m0_61 vss sg13_hv_nmos w=2u l=0.45u m=1
MMS0_62a t124 dhn0 m0_62 vss sg13_hv_nmos w=2u l=0.45u m=1
MMS0_62b t125 dh0 m0_62 vss sg13_hv_nmos w=2u l=0.45u m=1
MMS0_63a t126 dhn0 m0_63 vss sg13_hv_nmos w=2u l=0.45u m=1
MMS0_63b t127 dh0 m0_63 vss sg13_hv_nmos w=2u l=0.45u m=1
MMS0_64a t128 dhn0 m0_64 vss sg13_hv_nmos w=2u l=0.45u m=1
MMS0_64b t129 dh0 m0_64 vss sg13_hv_nmos w=2u l=0.45u m=1
MMS0_65a t130 dhn0 m0_65 vss sg13_hv_nmos w=2u l=0.45u m=1
MMS0_65b t131 dh0 m0_65 vss sg13_hv_nmos w=2u l=0.45u m=1
MMS0_66a t132 dhn0 m0_66 vss sg13_hv_nmos w=2u l=0.45u m=1
MMS0_66b t133 dh0 m0_66 vss sg13_hv_nmos w=2u l=0.45u m=1
MMS0_67a t134 dhn0 m0_67 vss sg13_hv_nmos w=2u l=0.45u m=1
MMS0_67b t135 dh0 m0_67 vss sg13_hv_nmos w=2u l=0.45u m=1
MMS0_68a t136 dhn0 m0_68 vss sg13_hv_nmos w=2u l=0.45u m=1
MMS0_68b t137 dh0 m0_68 vss sg13_hv_nmos w=2u l=0.45u m=1
MMS0_69a t138 dhn0 m0_69 vss sg13_hv_nmos w=2u l=0.45u m=1
MMS0_69b t139 dh0 m0_69 vss sg13_hv_nmos w=2u l=0.45u m=1
MMS0_70a t140 dhn0 m0_70 vss sg13_hv_nmos w=2u l=0.45u m=1
MMS0_70b t141 dh0 m0_70 vss sg13_hv_nmos w=2u l=0.45u m=1
MMS0_71a t142 dhn0 m0_71 vss sg13_hv_nmos w=2u l=0.45u m=1
MMS0_71b t143 dh0 m0_71 vss sg13_hv_nmos w=2u l=0.45u m=1
MMS0_72a t144 dhn0 m0_72 vss sg13_hv_nmos w=2u l=0.45u m=1
MMS0_72b t145 dh0 m0_72 vss sg13_hv_nmos w=2u l=0.45u m=1
MMS0_73a t146 dhn0 m0_73 vss sg13_hv_nmos w=2u l=0.45u m=1
MMS0_73b t147 dh0 m0_73 vss sg13_hv_nmos w=2u l=0.45u m=1
MMS0_74a t148 dhn0 m0_74 vss sg13_hv_nmos w=2u l=0.45u m=1
MMS0_74b t149 dh0 m0_74 vss sg13_hv_nmos w=2u l=0.45u m=1
MMS0_75a t150 dhn0 m0_75 vss sg13_hv_nmos w=2u l=0.45u m=1
MMS0_75b t151 dh0 m0_75 vss sg13_hv_nmos w=2u l=0.45u m=1
MMS0_76a t152 dhn0 m0_76 vss sg13_hv_nmos w=2u l=0.45u m=1
MMS0_76b t153 dh0 m0_76 vss sg13_hv_nmos w=2u l=0.45u m=1
MMS0_77a t154 dhn0 m0_77 vss sg13_hv_nmos w=2u l=0.45u m=1
MMS0_77b t155 dh0 m0_77 vss sg13_hv_nmos w=2u l=0.45u m=1
MMS0_78a t156 dhn0 m0_78 vss sg13_hv_nmos w=2u l=0.45u m=1
MMS0_78b t157 dh0 m0_78 vss sg13_hv_nmos w=2u l=0.45u m=1
MMS0_79a t158 dhn0 m0_79 vss sg13_hv_nmos w=2u l=0.45u m=1
MMS0_79b t159 dh0 m0_79 vss sg13_hv_nmos w=2u l=0.45u m=1
MMS0_80a t160 dhn0 m0_80 vss sg13_hv_nmos w=2u l=0.45u m=1
MMS0_80b t161 dh0 m0_80 vss sg13_hv_nmos w=2u l=0.45u m=1
MMS0_81a t162 dhn0 m0_81 vss sg13_hv_nmos w=2u l=0.45u m=1
MMS0_81b t163 dh0 m0_81 vss sg13_hv_nmos w=2u l=0.45u m=1
MMS0_82a t164 dhn0 m0_82 vss sg13_hv_nmos w=2u l=0.45u m=1
MMS0_82b t165 dh0 m0_82 vss sg13_hv_nmos w=2u l=0.45u m=1
MMS0_83a t166 dhn0 m0_83 vss sg13_hv_nmos w=2u l=0.45u m=1
MMS0_83b t167 dh0 m0_83 vss sg13_hv_nmos w=2u l=0.45u m=1
MMS0_84a t168 dhn0 m0_84 vss sg13_hv_nmos w=2u l=0.45u m=1
MMS0_84b t169 dh0 m0_84 vss sg13_hv_nmos w=2u l=0.45u m=1
MMS0_85a t170 dhn0 m0_85 vss sg13_hv_nmos w=2u l=0.45u m=1
MMS0_85b t171 dh0 m0_85 vss sg13_hv_nmos w=2u l=0.45u m=1
MMS0_86a t172 dhn0 m0_86 vss sg13_hv_nmos w=2u l=0.45u m=1
MMS0_86b t173 dh0 m0_86 vss sg13_hv_nmos w=2u l=0.45u m=1
MMS0_87a t174 dhn0 m0_87 vss sg13_hv_nmos w=2u l=0.45u m=1
MMS0_87b t175 dh0 m0_87 vss sg13_hv_nmos w=2u l=0.45u m=1
MMS0_88a t176 dhn0 m0_88 vss sg13_hv_nmos w=2u l=0.45u m=1
MMS0_88b t177 dh0 m0_88 vss sg13_hv_nmos w=2u l=0.45u m=1
MMS0_89a t178 dhn0 m0_89 vss sg13_hv_nmos w=2u l=0.45u m=1
MMS0_89b t179 dh0 m0_89 vss sg13_hv_nmos w=2u l=0.45u m=1
MMS0_90a t180 dhn0 m0_90 vss sg13_hv_nmos w=2u l=0.45u m=1
MMS0_90b t181 dh0 m0_90 vss sg13_hv_nmos w=2u l=0.45u m=1
MMS0_91a t182 dhn0 m0_91 vss sg13_hv_nmos w=2u l=0.45u m=1
MMS0_91b t183 dh0 m0_91 vss sg13_hv_nmos w=2u l=0.45u m=1
MMS0_92a t184 dhn0 m0_92 vss sg13_hv_nmos w=2u l=0.45u m=1
MMS0_92b t185 dh0 m0_92 vss sg13_hv_nmos w=2u l=0.45u m=1
MMS0_93a t186 dhn0 m0_93 vss sg13_hv_nmos w=2u l=0.45u m=1
MMS0_93b t187 dh0 m0_93 vss sg13_hv_nmos w=2u l=0.45u m=1
MMS0_94a t188 dhn0 m0_94 vss sg13_hv_nmos w=2u l=0.45u m=1
MMS0_94b t189 dh0 m0_94 vss sg13_hv_nmos w=2u l=0.45u m=1
MMS0_95a t190 dhn0 m0_95 vss sg13_hv_nmos w=2u l=0.45u m=1
MMS0_95b t191 dh0 m0_95 vss sg13_hv_nmos w=2u l=0.45u m=1
MMS0_96a t192 dhn0 m0_96 vss sg13_hv_nmos w=2u l=0.45u m=1
MMS0_96b t193 dh0 m0_96 vss sg13_hv_nmos w=2u l=0.45u m=1
MMS0_97a t194 dhn0 m0_97 vss sg13_hv_nmos w=2u l=0.45u m=1
MMS0_97b t195 dh0 m0_97 vss sg13_hv_nmos w=2u l=0.45u m=1
MMS0_98a t196 dhn0 m0_98 vss sg13_hv_nmos w=2u l=0.45u m=1
MMS0_98b t197 dh0 m0_98 vss sg13_hv_nmos w=2u l=0.45u m=1
MMS0_99a t198 dhn0 m0_99 vss sg13_hv_nmos w=2u l=0.45u m=1
MMS0_99b t199 dh0 m0_99 vss sg13_hv_nmos w=2u l=0.45u m=1
MMS0_100a t200 dhn0 m0_100 vss sg13_hv_nmos w=2u l=0.45u m=1
MMS0_100b t201 dh0 m0_100 vss sg13_hv_nmos w=2u l=0.45u m=1
MMS0_101a t202 dhn0 m0_101 vss sg13_hv_nmos w=2u l=0.45u m=1
MMS0_101b t203 dh0 m0_101 vss sg13_hv_nmos w=2u l=0.45u m=1
MMS0_102a t204 dhn0 m0_102 vss sg13_hv_nmos w=2u l=0.45u m=1
MMS0_102b t205 dh0 m0_102 vss sg13_hv_nmos w=2u l=0.45u m=1
MMS0_103a t206 dhn0 m0_103 vss sg13_hv_nmos w=2u l=0.45u m=1
MMS0_103b t207 dh0 m0_103 vss sg13_hv_nmos w=2u l=0.45u m=1
MMS0_104a t208 dhn0 m0_104 vss sg13_hv_nmos w=2u l=0.45u m=1
MMS0_104b t209 dh0 m0_104 vss sg13_hv_nmos w=2u l=0.45u m=1
MMS0_105a t210 dhn0 m0_105 vss sg13_hv_nmos w=2u l=0.45u m=1
MMS0_105b t211 dh0 m0_105 vss sg13_hv_nmos w=2u l=0.45u m=1
MMS0_106a t212 dhn0 m0_106 vss sg13_hv_nmos w=2u l=0.45u m=1
MMS0_106b t213 dh0 m0_106 vss sg13_hv_nmos w=2u l=0.45u m=1
MMS0_107a t214 dhn0 m0_107 vss sg13_hv_nmos w=2u l=0.45u m=1
MMS0_107b t215 dh0 m0_107 vss sg13_hv_nmos w=2u l=0.45u m=1
MMS0_108a t216 dhn0 m0_108 vss sg13_hv_nmos w=2u l=0.45u m=1
MMS0_108b t217 dh0 m0_108 vss sg13_hv_nmos w=2u l=0.45u m=1
MMS0_109a t218 dhn0 m0_109 vss sg13_hv_nmos w=2u l=0.45u m=1
MMS0_109b t219 dh0 m0_109 vss sg13_hv_nmos w=2u l=0.45u m=1
MMS0_110a t220 dhn0 m0_110 vss sg13_hv_nmos w=2u l=0.45u m=1
MMS0_110b t221 dh0 m0_110 vss sg13_hv_nmos w=2u l=0.45u m=1
MMS0_111a t222 dhn0 m0_111 vss sg13_hv_nmos w=2u l=0.45u m=1
MMS0_111b t223 dh0 m0_111 vss sg13_hv_nmos w=2u l=0.45u m=1
MMS0_112a t224 dhn0 m0_112 vss sg13_hv_nmos w=2u l=0.45u m=1
MMS0_112b t225 dh0 m0_112 vss sg13_hv_nmos w=2u l=0.45u m=1
MMS0_113a t226 dhn0 m0_113 vss sg13_hv_nmos w=2u l=0.45u m=1
MMS0_113b t227 dh0 m0_113 vss sg13_hv_nmos w=2u l=0.45u m=1
MMS0_114a t228 dhn0 m0_114 vss sg13_hv_nmos w=2u l=0.45u m=1
MMS0_114b t229 dh0 m0_114 vss sg13_hv_nmos w=2u l=0.45u m=1
MMS0_115a t230 dhn0 m0_115 vss sg13_hv_nmos w=2u l=0.45u m=1
MMS0_115b t231 dh0 m0_115 vss sg13_hv_nmos w=2u l=0.45u m=1
MMS0_116a t232 dhn0 m0_116 vss sg13_hv_nmos w=2u l=0.45u m=1
MMS0_116b t233 dh0 m0_116 vss sg13_hv_nmos w=2u l=0.45u m=1
MMS0_117a t234 dhn0 m0_117 vss sg13_hv_nmos w=2u l=0.45u m=1
MMS0_117b t235 dh0 m0_117 vss sg13_hv_nmos w=2u l=0.45u m=1
MMS0_118a t236 dhn0 m0_118 vss sg13_hv_nmos w=2u l=0.45u m=1
MMS0_118b t237 dh0 m0_118 vss sg13_hv_nmos w=2u l=0.45u m=1
MMS0_119a t238 dhn0 m0_119 vss sg13_hv_nmos w=2u l=0.45u m=1
MMS0_119b t239 dh0 m0_119 vss sg13_hv_nmos w=2u l=0.45u m=1
MMS0_120a t240 dhn0 m0_120 vss sg13_hv_nmos w=2u l=0.45u m=1
MMS0_120b t241 dh0 m0_120 vss sg13_hv_nmos w=2u l=0.45u m=1
MMS0_121a t242 dhn0 m0_121 vss sg13_hv_nmos w=2u l=0.45u m=1
MMS0_121b t243 dh0 m0_121 vss sg13_hv_nmos w=2u l=0.45u m=1
MMS0_122a t244 dhn0 m0_122 vss sg13_hv_nmos w=2u l=0.45u m=1
MMS0_122b t245 dh0 m0_122 vss sg13_hv_nmos w=2u l=0.45u m=1
MMS0_123a t246 dhn0 m0_123 vss sg13_hv_nmos w=2u l=0.45u m=1
MMS0_123b t247 dh0 m0_123 vss sg13_hv_nmos w=2u l=0.45u m=1
MMS0_124a t248 dhn0 m0_124 vss sg13_hv_nmos w=2u l=0.45u m=1
MMS0_124b t249 dh0 m0_124 vss sg13_hv_nmos w=2u l=0.45u m=1
MMS0_125a t250 dhn0 m0_125 vss sg13_hv_nmos w=2u l=0.45u m=1
MMS0_125b t251 dh0 m0_125 vss sg13_hv_nmos w=2u l=0.45u m=1
MMS0_126a t252 dhn0 m0_126 vss sg13_hv_nmos w=2u l=0.45u m=1
MMS0_126b t253 dh0 m0_126 vss sg13_hv_nmos w=2u l=0.45u m=1
MMS0_127a t254 dhn0 m0_127 vss sg13_hv_nmos w=2u l=0.45u m=1
MMS0_127b t255 dh0 m0_127 vss sg13_hv_nmos w=2u l=0.45u m=1
MMS1_0a m0_0 dhn1 m1_0 vss sg13_hv_nmos w=2u l=0.45u m=1
MMS1_0b m0_1 dh1 m1_0 vss sg13_hv_nmos w=2u l=0.45u m=1
MMS1_1a m0_2 dhn1 m1_1 vss sg13_hv_nmos w=2u l=0.45u m=1
MMS1_1b m0_3 dh1 m1_1 vss sg13_hv_nmos w=2u l=0.45u m=1
MMS1_2a m0_4 dhn1 m1_2 vss sg13_hv_nmos w=2u l=0.45u m=1
MMS1_2b m0_5 dh1 m1_2 vss sg13_hv_nmos w=2u l=0.45u m=1
MMS1_3a m0_6 dhn1 m1_3 vss sg13_hv_nmos w=2u l=0.45u m=1
MMS1_3b m0_7 dh1 m1_3 vss sg13_hv_nmos w=2u l=0.45u m=1
MMS1_4a m0_8 dhn1 m1_4 vss sg13_hv_nmos w=2u l=0.45u m=1
MMS1_4b m0_9 dh1 m1_4 vss sg13_hv_nmos w=2u l=0.45u m=1
MMS1_5a m0_10 dhn1 m1_5 vss sg13_hv_nmos w=2u l=0.45u m=1
MMS1_5b m0_11 dh1 m1_5 vss sg13_hv_nmos w=2u l=0.45u m=1
MMS1_6a m0_12 dhn1 m1_6 vss sg13_hv_nmos w=2u l=0.45u m=1
MMS1_6b m0_13 dh1 m1_6 vss sg13_hv_nmos w=2u l=0.45u m=1
MMS1_7a m0_14 dhn1 m1_7 vss sg13_hv_nmos w=2u l=0.45u m=1
MMS1_7b m0_15 dh1 m1_7 vss sg13_hv_nmos w=2u l=0.45u m=1
MMS1_8a m0_16 dhn1 m1_8 vss sg13_hv_nmos w=2u l=0.45u m=1
MMS1_8b m0_17 dh1 m1_8 vss sg13_hv_nmos w=2u l=0.45u m=1
MMS1_9a m0_18 dhn1 m1_9 vss sg13_hv_nmos w=2u l=0.45u m=1
MMS1_9b m0_19 dh1 m1_9 vss sg13_hv_nmos w=2u l=0.45u m=1
MMS1_10a m0_20 dhn1 m1_10 vss sg13_hv_nmos w=2u l=0.45u m=1
MMS1_10b m0_21 dh1 m1_10 vss sg13_hv_nmos w=2u l=0.45u m=1
MMS1_11a m0_22 dhn1 m1_11 vss sg13_hv_nmos w=2u l=0.45u m=1
MMS1_11b m0_23 dh1 m1_11 vss sg13_hv_nmos w=2u l=0.45u m=1
MMS1_12a m0_24 dhn1 m1_12 vss sg13_hv_nmos w=2u l=0.45u m=1
MMS1_12b m0_25 dh1 m1_12 vss sg13_hv_nmos w=2u l=0.45u m=1
MMS1_13a m0_26 dhn1 m1_13 vss sg13_hv_nmos w=2u l=0.45u m=1
MMS1_13b m0_27 dh1 m1_13 vss sg13_hv_nmos w=2u l=0.45u m=1
MMS1_14a m0_28 dhn1 m1_14 vss sg13_hv_nmos w=2u l=0.45u m=1
MMS1_14b m0_29 dh1 m1_14 vss sg13_hv_nmos w=2u l=0.45u m=1
MMS1_15a m0_30 dhn1 m1_15 vss sg13_hv_nmos w=2u l=0.45u m=1
MMS1_15b m0_31 dh1 m1_15 vss sg13_hv_nmos w=2u l=0.45u m=1
MMS1_16a m0_32 dhn1 m1_16 vss sg13_hv_nmos w=2u l=0.45u m=1
MMS1_16b m0_33 dh1 m1_16 vss sg13_hv_nmos w=2u l=0.45u m=1
MMS1_17a m0_34 dhn1 m1_17 vss sg13_hv_nmos w=2u l=0.45u m=1
MMS1_17b m0_35 dh1 m1_17 vss sg13_hv_nmos w=2u l=0.45u m=1
MMS1_18a m0_36 dhn1 m1_18 vss sg13_hv_nmos w=2u l=0.45u m=1
MMS1_18b m0_37 dh1 m1_18 vss sg13_hv_nmos w=2u l=0.45u m=1
MMS1_19a m0_38 dhn1 m1_19 vss sg13_hv_nmos w=2u l=0.45u m=1
MMS1_19b m0_39 dh1 m1_19 vss sg13_hv_nmos w=2u l=0.45u m=1
MMS1_20a m0_40 dhn1 m1_20 vss sg13_hv_nmos w=2u l=0.45u m=1
MMS1_20b m0_41 dh1 m1_20 vss sg13_hv_nmos w=2u l=0.45u m=1
MMS1_21a m0_42 dhn1 m1_21 vss sg13_hv_nmos w=2u l=0.45u m=1
MMS1_21b m0_43 dh1 m1_21 vss sg13_hv_nmos w=2u l=0.45u m=1
MMS1_22a m0_44 dhn1 m1_22 vss sg13_hv_nmos w=2u l=0.45u m=1
MMS1_22b m0_45 dh1 m1_22 vss sg13_hv_nmos w=2u l=0.45u m=1
MMS1_23a m0_46 dhn1 m1_23 vss sg13_hv_nmos w=2u l=0.45u m=1
MMS1_23b m0_47 dh1 m1_23 vss sg13_hv_nmos w=2u l=0.45u m=1
MMS1_24a m0_48 dhn1 m1_24 vss sg13_hv_nmos w=2u l=0.45u m=1
MMS1_24b m0_49 dh1 m1_24 vss sg13_hv_nmos w=2u l=0.45u m=1
MMS1_25a m0_50 dhn1 m1_25 vss sg13_hv_nmos w=2u l=0.45u m=1
MMS1_25b m0_51 dh1 m1_25 vss sg13_hv_nmos w=2u l=0.45u m=1
MMS1_26a m0_52 dhn1 m1_26 vss sg13_hv_nmos w=2u l=0.45u m=1
MMS1_26b m0_53 dh1 m1_26 vss sg13_hv_nmos w=2u l=0.45u m=1
MMS1_27a m0_54 dhn1 m1_27 vss sg13_hv_nmos w=2u l=0.45u m=1
MMS1_27b m0_55 dh1 m1_27 vss sg13_hv_nmos w=2u l=0.45u m=1
MMS1_28a m0_56 dhn1 m1_28 vss sg13_hv_nmos w=2u l=0.45u m=1
MMS1_28b m0_57 dh1 m1_28 vss sg13_hv_nmos w=2u l=0.45u m=1
MMS1_29a m0_58 dhn1 m1_29 vss sg13_hv_nmos w=2u l=0.45u m=1
MMS1_29b m0_59 dh1 m1_29 vss sg13_hv_nmos w=2u l=0.45u m=1
MMS1_30a m0_60 dhn1 m1_30 vss sg13_hv_nmos w=2u l=0.45u m=1
MMS1_30b m0_61 dh1 m1_30 vss sg13_hv_nmos w=2u l=0.45u m=1
MMS1_31a m0_62 dhn1 m1_31 vss sg13_hv_nmos w=2u l=0.45u m=1
MMS1_31b m0_63 dh1 m1_31 vss sg13_hv_nmos w=2u l=0.45u m=1
MMS1_32a m0_64 dhn1 m1_32 vss sg13_hv_nmos w=2u l=0.45u m=1
MMS1_32b m0_65 dh1 m1_32 vss sg13_hv_nmos w=2u l=0.45u m=1
MMS1_33a m0_66 dhn1 m1_33 vss sg13_hv_nmos w=2u l=0.45u m=1
MMS1_33b m0_67 dh1 m1_33 vss sg13_hv_nmos w=2u l=0.45u m=1
MMS1_34a m0_68 dhn1 m1_34 vss sg13_hv_nmos w=2u l=0.45u m=1
MMS1_34b m0_69 dh1 m1_34 vss sg13_hv_nmos w=2u l=0.45u m=1
MMS1_35a m0_70 dhn1 m1_35 vss sg13_hv_nmos w=2u l=0.45u m=1
MMS1_35b m0_71 dh1 m1_35 vss sg13_hv_nmos w=2u l=0.45u m=1
MMS1_36a m0_72 dhn1 m1_36 vss sg13_hv_nmos w=2u l=0.45u m=1
MMS1_36b m0_73 dh1 m1_36 vss sg13_hv_nmos w=2u l=0.45u m=1
MMS1_37a m0_74 dhn1 m1_37 vss sg13_hv_nmos w=2u l=0.45u m=1
MMS1_37b m0_75 dh1 m1_37 vss sg13_hv_nmos w=2u l=0.45u m=1
MMS1_38a m0_76 dhn1 m1_38 vss sg13_hv_nmos w=2u l=0.45u m=1
MMS1_38b m0_77 dh1 m1_38 vss sg13_hv_nmos w=2u l=0.45u m=1
MMS1_39a m0_78 dhn1 m1_39 vss sg13_hv_nmos w=2u l=0.45u m=1
MMS1_39b m0_79 dh1 m1_39 vss sg13_hv_nmos w=2u l=0.45u m=1
MMS1_40a m0_80 dhn1 m1_40 vss sg13_hv_nmos w=2u l=0.45u m=1
MMS1_40b m0_81 dh1 m1_40 vss sg13_hv_nmos w=2u l=0.45u m=1
MMS1_41a m0_82 dhn1 m1_41 vss sg13_hv_nmos w=2u l=0.45u m=1
MMS1_41b m0_83 dh1 m1_41 vss sg13_hv_nmos w=2u l=0.45u m=1
MMS1_42a m0_84 dhn1 m1_42 vss sg13_hv_nmos w=2u l=0.45u m=1
MMS1_42b m0_85 dh1 m1_42 vss sg13_hv_nmos w=2u l=0.45u m=1
MMS1_43a m0_86 dhn1 m1_43 vss sg13_hv_nmos w=2u l=0.45u m=1
MMS1_43b m0_87 dh1 m1_43 vss sg13_hv_nmos w=2u l=0.45u m=1
MMS1_44a m0_88 dhn1 m1_44 vss sg13_hv_nmos w=2u l=0.45u m=1
MMS1_44b m0_89 dh1 m1_44 vss sg13_hv_nmos w=2u l=0.45u m=1
MMS1_45a m0_90 dhn1 m1_45 vss sg13_hv_nmos w=2u l=0.45u m=1
MMS1_45b m0_91 dh1 m1_45 vss sg13_hv_nmos w=2u l=0.45u m=1
MMS1_46a m0_92 dhn1 m1_46 vss sg13_hv_nmos w=2u l=0.45u m=1
MMS1_46b m0_93 dh1 m1_46 vss sg13_hv_nmos w=2u l=0.45u m=1
MMS1_47a m0_94 dhn1 m1_47 vss sg13_hv_nmos w=2u l=0.45u m=1
MMS1_47b m0_95 dh1 m1_47 vss sg13_hv_nmos w=2u l=0.45u m=1
MMS1_48a m0_96 dhn1 m1_48 vss sg13_hv_nmos w=2u l=0.45u m=1
MMS1_48b m0_97 dh1 m1_48 vss sg13_hv_nmos w=2u l=0.45u m=1
MMS1_49a m0_98 dhn1 m1_49 vss sg13_hv_nmos w=2u l=0.45u m=1
MMS1_49b m0_99 dh1 m1_49 vss sg13_hv_nmos w=2u l=0.45u m=1
MMS1_50a m0_100 dhn1 m1_50 vss sg13_hv_nmos w=2u l=0.45u m=1
MMS1_50b m0_101 dh1 m1_50 vss sg13_hv_nmos w=2u l=0.45u m=1
MMS1_51a m0_102 dhn1 m1_51 vss sg13_hv_nmos w=2u l=0.45u m=1
MMS1_51b m0_103 dh1 m1_51 vss sg13_hv_nmos w=2u l=0.45u m=1
MMS1_52a m0_104 dhn1 m1_52 vss sg13_hv_nmos w=2u l=0.45u m=1
MMS1_52b m0_105 dh1 m1_52 vss sg13_hv_nmos w=2u l=0.45u m=1
MMS1_53a m0_106 dhn1 m1_53 vss sg13_hv_nmos w=2u l=0.45u m=1
MMS1_53b m0_107 dh1 m1_53 vss sg13_hv_nmos w=2u l=0.45u m=1
MMS1_54a m0_108 dhn1 m1_54 vss sg13_hv_nmos w=2u l=0.45u m=1
MMS1_54b m0_109 dh1 m1_54 vss sg13_hv_nmos w=2u l=0.45u m=1
MMS1_55a m0_110 dhn1 m1_55 vss sg13_hv_nmos w=2u l=0.45u m=1
MMS1_55b m0_111 dh1 m1_55 vss sg13_hv_nmos w=2u l=0.45u m=1
MMS1_56a m0_112 dhn1 m1_56 vss sg13_hv_nmos w=2u l=0.45u m=1
MMS1_56b m0_113 dh1 m1_56 vss sg13_hv_nmos w=2u l=0.45u m=1
MMS1_57a m0_114 dhn1 m1_57 vss sg13_hv_nmos w=2u l=0.45u m=1
MMS1_57b m0_115 dh1 m1_57 vss sg13_hv_nmos w=2u l=0.45u m=1
MMS1_58a m0_116 dhn1 m1_58 vss sg13_hv_nmos w=2u l=0.45u m=1
MMS1_58b m0_117 dh1 m1_58 vss sg13_hv_nmos w=2u l=0.45u m=1
MMS1_59a m0_118 dhn1 m1_59 vss sg13_hv_nmos w=2u l=0.45u m=1
MMS1_59b m0_119 dh1 m1_59 vss sg13_hv_nmos w=2u l=0.45u m=1
MMS1_60a m0_120 dhn1 m1_60 vss sg13_hv_nmos w=2u l=0.45u m=1
MMS1_60b m0_121 dh1 m1_60 vss sg13_hv_nmos w=2u l=0.45u m=1
MMS1_61a m0_122 dhn1 m1_61 vss sg13_hv_nmos w=2u l=0.45u m=1
MMS1_61b m0_123 dh1 m1_61 vss sg13_hv_nmos w=2u l=0.45u m=1
MMS1_62a m0_124 dhn1 m1_62 vss sg13_hv_nmos w=2u l=0.45u m=1
MMS1_62b m0_125 dh1 m1_62 vss sg13_hv_nmos w=2u l=0.45u m=1
MMS1_63a m0_126 dhn1 m1_63 vss sg13_hv_nmos w=2u l=0.45u m=1
MMS1_63b m0_127 dh1 m1_63 vss sg13_hv_nmos w=2u l=0.45u m=1
MMS2_0a m1_0 dhn2 m2_0 vss sg13_hv_nmos w=2u l=0.45u m=1
MMS2_0b m1_1 dh2 m2_0 vss sg13_hv_nmos w=2u l=0.45u m=1
MMS2_1a m1_2 dhn2 m2_1 vss sg13_hv_nmos w=2u l=0.45u m=1
MMS2_1b m1_3 dh2 m2_1 vss sg13_hv_nmos w=2u l=0.45u m=1
MMS2_2a m1_4 dhn2 m2_2 vss sg13_hv_nmos w=2u l=0.45u m=1
MMS2_2b m1_5 dh2 m2_2 vss sg13_hv_nmos w=2u l=0.45u m=1
MMS2_3a m1_6 dhn2 m2_3 vss sg13_hv_nmos w=2u l=0.45u m=1
MMS2_3b m1_7 dh2 m2_3 vss sg13_hv_nmos w=2u l=0.45u m=1
MMS2_4a m1_8 dhn2 m2_4 vss sg13_hv_nmos w=2u l=0.45u m=1
MMS2_4b m1_9 dh2 m2_4 vss sg13_hv_nmos w=2u l=0.45u m=1
MMS2_5a m1_10 dhn2 m2_5 vss sg13_hv_nmos w=2u l=0.45u m=1
MMS2_5b m1_11 dh2 m2_5 vss sg13_hv_nmos w=2u l=0.45u m=1
MMS2_6a m1_12 dhn2 m2_6 vss sg13_hv_nmos w=2u l=0.45u m=1
MMS2_6b m1_13 dh2 m2_6 vss sg13_hv_nmos w=2u l=0.45u m=1
MMS2_7a m1_14 dhn2 m2_7 vss sg13_hv_nmos w=2u l=0.45u m=1
MMS2_7b m1_15 dh2 m2_7 vss sg13_hv_nmos w=2u l=0.45u m=1
MMS2_8a m1_16 dhn2 m2_8 vss sg13_hv_nmos w=2u l=0.45u m=1
MMS2_8b m1_17 dh2 m2_8 vss sg13_hv_nmos w=2u l=0.45u m=1
MMS2_9a m1_18 dhn2 m2_9 vss sg13_hv_nmos w=2u l=0.45u m=1
MMS2_9b m1_19 dh2 m2_9 vss sg13_hv_nmos w=2u l=0.45u m=1
MMS2_10a m1_20 dhn2 m2_10 vss sg13_hv_nmos w=2u l=0.45u m=1
MMS2_10b m1_21 dh2 m2_10 vss sg13_hv_nmos w=2u l=0.45u m=1
MMS2_11a m1_22 dhn2 m2_11 vss sg13_hv_nmos w=2u l=0.45u m=1
MMS2_11b m1_23 dh2 m2_11 vss sg13_hv_nmos w=2u l=0.45u m=1
MMS2_12a m1_24 dhn2 m2_12 vss sg13_hv_nmos w=2u l=0.45u m=1
MMS2_12b m1_25 dh2 m2_12 vss sg13_hv_nmos w=2u l=0.45u m=1
MMS2_13a m1_26 dhn2 m2_13 vss sg13_hv_nmos w=2u l=0.45u m=1
MMS2_13b m1_27 dh2 m2_13 vss sg13_hv_nmos w=2u l=0.45u m=1
MMS2_14a m1_28 dhn2 m2_14 vss sg13_hv_nmos w=2u l=0.45u m=1
MMS2_14b m1_29 dh2 m2_14 vss sg13_hv_nmos w=2u l=0.45u m=1
MMS2_15a m1_30 dhn2 m2_15 vss sg13_hv_nmos w=2u l=0.45u m=1
MMS2_15b m1_31 dh2 m2_15 vss sg13_hv_nmos w=2u l=0.45u m=1
MMS2_16a m1_32 dhn2 m2_16 vss sg13_hv_nmos w=2u l=0.45u m=1
MMS2_16b m1_33 dh2 m2_16 vss sg13_hv_nmos w=2u l=0.45u m=1
MMS2_17a m1_34 dhn2 m2_17 vss sg13_hv_nmos w=2u l=0.45u m=1
MMS2_17b m1_35 dh2 m2_17 vss sg13_hv_nmos w=2u l=0.45u m=1
MMS2_18a m1_36 dhn2 m2_18 vss sg13_hv_nmos w=2u l=0.45u m=1
MMS2_18b m1_37 dh2 m2_18 vss sg13_hv_nmos w=2u l=0.45u m=1
MMS2_19a m1_38 dhn2 m2_19 vss sg13_hv_nmos w=2u l=0.45u m=1
MMS2_19b m1_39 dh2 m2_19 vss sg13_hv_nmos w=2u l=0.45u m=1
MMS2_20a m1_40 dhn2 m2_20 vss sg13_hv_nmos w=2u l=0.45u m=1
MMS2_20b m1_41 dh2 m2_20 vss sg13_hv_nmos w=2u l=0.45u m=1
MMS2_21a m1_42 dhn2 m2_21 vss sg13_hv_nmos w=2u l=0.45u m=1
MMS2_21b m1_43 dh2 m2_21 vss sg13_hv_nmos w=2u l=0.45u m=1
MMS2_22a m1_44 dhn2 m2_22 vss sg13_hv_nmos w=2u l=0.45u m=1
MMS2_22b m1_45 dh2 m2_22 vss sg13_hv_nmos w=2u l=0.45u m=1
MMS2_23a m1_46 dhn2 m2_23 vss sg13_hv_nmos w=2u l=0.45u m=1
MMS2_23b m1_47 dh2 m2_23 vss sg13_hv_nmos w=2u l=0.45u m=1
MMS2_24a m1_48 dhn2 m2_24 vss sg13_hv_nmos w=2u l=0.45u m=1
MMS2_24b m1_49 dh2 m2_24 vss sg13_hv_nmos w=2u l=0.45u m=1
MMS2_25a m1_50 dhn2 m2_25 vss sg13_hv_nmos w=2u l=0.45u m=1
MMS2_25b m1_51 dh2 m2_25 vss sg13_hv_nmos w=2u l=0.45u m=1
MMS2_26a m1_52 dhn2 m2_26 vss sg13_hv_nmos w=2u l=0.45u m=1
MMS2_26b m1_53 dh2 m2_26 vss sg13_hv_nmos w=2u l=0.45u m=1
MMS2_27a m1_54 dhn2 m2_27 vss sg13_hv_nmos w=2u l=0.45u m=1
MMS2_27b m1_55 dh2 m2_27 vss sg13_hv_nmos w=2u l=0.45u m=1
MMS2_28a m1_56 dhn2 m2_28 vss sg13_hv_nmos w=2u l=0.45u m=1
MMS2_28b m1_57 dh2 m2_28 vss sg13_hv_nmos w=2u l=0.45u m=1
MMS2_29a m1_58 dhn2 m2_29 vss sg13_hv_nmos w=2u l=0.45u m=1
MMS2_29b m1_59 dh2 m2_29 vss sg13_hv_nmos w=2u l=0.45u m=1
MMS2_30a m1_60 dhn2 m2_30 vss sg13_hv_nmos w=2u l=0.45u m=1
MMS2_30b m1_61 dh2 m2_30 vss sg13_hv_nmos w=2u l=0.45u m=1
MMS2_31a m1_62 dhn2 m2_31 vss sg13_hv_nmos w=2u l=0.45u m=1
MMS2_31b m1_63 dh2 m2_31 vss sg13_hv_nmos w=2u l=0.45u m=1
MMS3_0a m2_0 dhn3 m3_0 vss sg13_hv_nmos w=2u l=0.45u m=1
MMS3_0b m2_1 dh3 m3_0 vss sg13_hv_nmos w=2u l=0.45u m=1
MMS3_1a m2_2 dhn3 m3_1 vss sg13_hv_nmos w=2u l=0.45u m=1
MMS3_1b m2_3 dh3 m3_1 vss sg13_hv_nmos w=2u l=0.45u m=1
MMS3_2a m2_4 dhn3 m3_2 vss sg13_hv_nmos w=2u l=0.45u m=1
MMS3_2b m2_5 dh3 m3_2 vss sg13_hv_nmos w=2u l=0.45u m=1
MMS3_3a m2_6 dhn3 m3_3 vss sg13_hv_nmos w=2u l=0.45u m=1
MMS3_3b m2_7 dh3 m3_3 vss sg13_hv_nmos w=2u l=0.45u m=1
MMS3_4a m2_8 dhn3 m3_4 vss sg13_hv_nmos w=2u l=0.45u m=1
MMS3_4b m2_9 dh3 m3_4 vss sg13_hv_nmos w=2u l=0.45u m=1
MMS3_5a m2_10 dhn3 m3_5 vss sg13_hv_nmos w=2u l=0.45u m=1
MMS3_5b m2_11 dh3 m3_5 vss sg13_hv_nmos w=2u l=0.45u m=1
MMS3_6a m2_12 dhn3 m3_6 vss sg13_hv_nmos w=2u l=0.45u m=1
MMS3_6b m2_13 dh3 m3_6 vss sg13_hv_nmos w=2u l=0.45u m=1
MMS3_7a m2_14 dhn3 m3_7 vss sg13_hv_nmos w=2u l=0.45u m=1
MMS3_7b m2_15 dh3 m3_7 vss sg13_hv_nmos w=2u l=0.45u m=1
MMS3_8a m2_16 dhn3 m3_8 vss sg13_hv_nmos w=2u l=0.45u m=1
MMS3_8b m2_17 dh3 m3_8 vss sg13_hv_nmos w=2u l=0.45u m=1
MMS3_9a m2_18 dhn3 m3_9 vss sg13_hv_nmos w=2u l=0.45u m=1
MMS3_9b m2_19 dh3 m3_9 vss sg13_hv_nmos w=2u l=0.45u m=1
MMS3_10a m2_20 dhn3 m3_10 vss sg13_hv_nmos w=2u l=0.45u m=1
MMS3_10b m2_21 dh3 m3_10 vss sg13_hv_nmos w=2u l=0.45u m=1
MMS3_11a m2_22 dhn3 m3_11 vss sg13_hv_nmos w=2u l=0.45u m=1
MMS3_11b m2_23 dh3 m3_11 vss sg13_hv_nmos w=2u l=0.45u m=1
MMS3_12a m2_24 dhn3 m3_12 vss sg13_hv_nmos w=2u l=0.45u m=1
MMS3_12b m2_25 dh3 m3_12 vss sg13_hv_nmos w=2u l=0.45u m=1
MMS3_13a m2_26 dhn3 m3_13 vss sg13_hv_nmos w=2u l=0.45u m=1
MMS3_13b m2_27 dh3 m3_13 vss sg13_hv_nmos w=2u l=0.45u m=1
MMS3_14a m2_28 dhn3 m3_14 vss sg13_hv_nmos w=2u l=0.45u m=1
MMS3_14b m2_29 dh3 m3_14 vss sg13_hv_nmos w=2u l=0.45u m=1
MMS3_15a m2_30 dhn3 m3_15 vss sg13_hv_nmos w=2u l=0.45u m=1
MMS3_15b m2_31 dh3 m3_15 vss sg13_hv_nmos w=2u l=0.45u m=1
MMS4_0a m3_0 dhn4 m4_0 vss sg13_hv_nmos w=2u l=0.45u m=1
MMS4_0b m3_1 dh4 m4_0 vss sg13_hv_nmos w=2u l=0.45u m=1
MMS4_1a m3_2 dhn4 m4_1 vss sg13_hv_nmos w=2u l=0.45u m=1
MMS4_1b m3_3 dh4 m4_1 vss sg13_hv_nmos w=2u l=0.45u m=1
MMS4_2a m3_4 dhn4 m4_2 vss sg13_hv_nmos w=2u l=0.45u m=1
MMS4_2b m3_5 dh4 m4_2 vss sg13_hv_nmos w=2u l=0.45u m=1
MMS4_3a m3_6 dhn4 m4_3 vss sg13_hv_nmos w=2u l=0.45u m=1
MMS4_3b m3_7 dh4 m4_3 vss sg13_hv_nmos w=2u l=0.45u m=1
MMS4_4a m3_8 dhn4 m4_4 vss sg13_hv_nmos w=2u l=0.45u m=1
MMS4_4b m3_9 dh4 m4_4 vss sg13_hv_nmos w=2u l=0.45u m=1
MMS4_5a m3_10 dhn4 m4_5 vss sg13_hv_nmos w=2u l=0.45u m=1
MMS4_5b m3_11 dh4 m4_5 vss sg13_hv_nmos w=2u l=0.45u m=1
MMS4_6a m3_12 dhn4 m4_6 vss sg13_hv_nmos w=2u l=0.45u m=1
MMS4_6b m3_13 dh4 m4_6 vss sg13_hv_nmos w=2u l=0.45u m=1
MMS4_7a m3_14 dhn4 m4_7 vss sg13_hv_nmos w=2u l=0.45u m=1
MMS4_7b m3_15 dh4 m4_7 vss sg13_hv_nmos w=2u l=0.45u m=1
MMS5_0a m4_0 dhn5 m5_0 vss sg13_hv_nmos w=2u l=0.45u m=1
MMS5_0b m4_1 dh5 m5_0 vss sg13_hv_nmos w=2u l=0.45u m=1
MMS5_1a m4_2 dhn5 m5_1 vss sg13_hv_nmos w=2u l=0.45u m=1
MMS5_1b m4_3 dh5 m5_1 vss sg13_hv_nmos w=2u l=0.45u m=1
MMS5_2a m4_4 dhn5 m5_2 vss sg13_hv_nmos w=2u l=0.45u m=1
MMS5_2b m4_5 dh5 m5_2 vss sg13_hv_nmos w=2u l=0.45u m=1
MMS5_3a m4_6 dhn5 m5_3 vss sg13_hv_nmos w=2u l=0.45u m=1
MMS5_3b m4_7 dh5 m5_3 vss sg13_hv_nmos w=2u l=0.45u m=1
MMS6_0a m5_0 dhn6 m6_0 vss sg13_hv_nmos w=2u l=0.45u m=1
MMS6_0b m5_1 dh6 m6_0 vss sg13_hv_nmos w=2u l=0.45u m=1
MMS6_1a m5_2 dhn6 m6_1 vss sg13_hv_nmos w=2u l=0.45u m=1
MMS6_1b m5_3 dh6 m6_1 vss sg13_hv_nmos w=2u l=0.45u m=1
MMS7_0a m6_0 dhn7 out vss sg13_hv_nmos w=2u l=0.45u m=1
MMS7_0b m6_1 dh7 out vss sg13_hv_nmos w=2u l=0.45u m=1
.ends
.subckt g1_inv a y vdd vss
MMP y a vdd vdd sg13_lv_pmos w=1u l=0.13u m=1
MMN y a vss vss sg13_lv_nmos w=0.5u l=0.13u m=1
.ends
.subckt g1_cmp inp inn clk q qb vdd vss
MMTAIL tail clk vss vss sg13_lv_nmos w=16u l=0.13u m=1
MM1 xp inp tail vss sg13_lv_nmos w=12u l=0.34u m=1
MM2 xq inn tail vss sg13_lv_nmos w=12u l=0.34u m=1
MMD1 xq inp xq vss sg13_lv_nmos w=6u l=0.13u m=1
MMD2 xp inn xp vss sg13_lv_nmos w=6u l=0.13u m=1
MM3 xn yn xp vss sg13_lv_nmos w=3u l=0.13u m=1
MM4 yn xn xq vss sg13_lv_nmos w=3u l=0.13u m=1
MM5 xn yn vdd vdd sg13_lv_pmos w=3u l=0.13u m=1
MM6 yn xn vdd vdd sg13_lv_pmos w=3u l=0.13u m=1
MM7 xn clk vdd vdd sg13_lv_pmos w=6u l=0.13u m=1
MM8 yn clk vdd vdd sg13_lv_pmos w=6u l=0.13u m=1
MM9 xp clk vdd vdd sg13_lv_pmos w=3u l=0.13u m=1
MM10 xq clk vdd vdd sg13_lv_pmos w=3u l=0.13u m=1
MMIAP xnb xn vdd vdd sg13_lv_pmos w=1u l=0.13u m=1
MMIAN xnb xn vss vss sg13_lv_nmos w=4u l=0.13u m=1
MMIBP ynb yn vdd vdd sg13_lv_pmos w=1u l=0.13u m=1
MMIBN ynb yn vss vss sg13_lv_nmos w=4u l=0.13u m=1
MMNAP1 na xnb vdd vdd sg13_lv_pmos w=4u l=0.13u m=1
MMNAP2 qb q na vdd sg13_lv_pmos w=4u l=0.13u m=1
MMNAN1 qb xnb vss vss sg13_lv_nmos w=1.5u l=0.13u m=1
MMNAN2 qb q vss vss sg13_lv_nmos w=1.5u l=0.13u m=1
MMNBP1 nb ynb vdd vdd sg13_lv_pmos w=4u l=0.13u m=1
MMNBP2 q qb nb vdd sg13_lv_pmos w=4u l=0.13u m=1
MMNBN1 q ynb vss vss sg13_lv_nmos w=1.5u l=0.13u m=1
MMNBN2 q qb vss vss sg13_lv_nmos w=1.5u l=0.13u m=1
.ends
.subckt g1_tlvlup a y yb vdd vdda vss
XI a ab vdd vss g1_inv
MMN1 nb a vss vss sg13_hv_nmos w=1.9u l=0.45u m=1
MMN2 n ab vss vss sg13_hv_nmos w=1.9u l=0.45u m=1
MMP1 nb n vdda vdda sg13_hv_pmos w=0.3u l=0.45u m=1
MMP2 n nb vdda vdda sg13_hv_pmos w=0.3u l=0.45u m=1
XO nb y vdda vss g1_thv_inv
XOB y yb vdda vss g1_thv_inv
.ends
.subckt g1_thv_inv a y vdda vss
MMP y a vdda vdda sg13_hv_pmos w=3.9u l=0.45u m=1
MMN y a vss vss sg13_hv_nmos w=1.9u l=0.45u m=1
.ends
