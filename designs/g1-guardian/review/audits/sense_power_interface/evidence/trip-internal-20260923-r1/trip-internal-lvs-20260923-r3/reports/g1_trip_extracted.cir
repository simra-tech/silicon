* Extracted by KLayout with SG13G2 LVS runset on : 23/09/2026 04:23

.SUBCKT g1_trip IOVDD ISENSE VDD VREF VSS clk cmp_clk_n cmp_hard cmp_soft
+ dac_hard[0] dac_hard[1] dac_hard[2] dac_hard[3] dac_hard[4] dac_hard[5]
+ dac_hard[6] dac_hard[7] dac_soft[0] dac_soft[1] dac_soft[2] dac_soft[3]
+ dac_soft[4] dac_soft[5] dac_soft[6] dac_soft[7] icmp vth_hard vth_soft
X$1 VSS ISENSE icmp g1_cond
X$2 VSS icmp clk vth_soft cmp_soft VDD g1_cmp
X$3 VSS icmp cmp_clk_n vth_hard cmp_hard VDD g1_cmp
X$1420 VSS VDD dac_soft[0] dac_soft[1] dac_soft[2] dac_soft[3] dac_soft[4]
+ dac_soft[5] dac_soft[6] dac_soft[7] IOVDD VREF vth_soft g1_dac8
X$1425 VSS VDD dac_hard[0] dac_hard[1] dac_hard[2] dac_hard[3] dac_hard[4]
+ dac_hard[5] dac_hard[6] dac_hard[7] IOVDD VREF vth_hard g1_dac8
M$1 VSS clk cmp_clk_n VSS sg13_lv_nmos L=0.13u W=0.5u AS=0.17p AD=0.17p
+ PS=1.68u PD=1.68u rfmode=0
M$2 VDD clk cmp_clk_n VDD sg13_lv_pmos L=0.13u W=1u AS=0.34p AD=0.34p PS=2.68u
+ PD=2.68u rfmode=0
C$3 vth_soft VSS cap_cmim w=26u l=26u A=676p P=104u m=1
C$4 vth_hard VSS cap_cmim w=26u l=26u A=676p P=104u m=1
.ENDS g1_trip

.SUBCKT g1_cond vss isense icmp
R$10 icmp isense vss rppd w=2u l=383.5u ps=0u b=0 m=1
R$20 vss icmp vss rppd w=2u l=383.5u ps=0u b=0 m=1
C$21 icmp vss cap_cmim w=26u l=26u A=676p P=104u m=1
.ENDS g1_cond

.SUBCKT g1_cmp vss inp clk inn q vdd
M$1 \$8 inn \$8 vss sg13_lv_nmos L=0.13u W=6u AS=2.04p AD=2.04p PS=12.68u
+ PD=12.68u rfmode=0
M$2 \$3 \$12 vss vss sg13_lv_nmos L=0.13u W=4u AS=1.36p AD=1.36p PS=8.68u
+ PD=8.68u rfmode=0
M$3 \$12 \$4 \$8 vss sg13_lv_nmos L=0.13u W=3u AS=1.02p AD=1.02p PS=6.68u
+ PD=6.68u rfmode=0
M$4 \$7 \$12 \$4 vss sg13_lv_nmos L=0.13u W=3u AS=1.02p AD=1.02p PS=6.68u
+ PD=6.68u rfmode=0
M$5 vss qb q vss sg13_lv_nmos L=0.13u W=1.5u AS=0.51p AD=0.51p PS=3.68u
+ PD=3.68u rfmode=0
M$6 \$7 inn \$9 vss sg13_lv_nmos L=0.34u W=12u AS=3.18p AD=3.18p PS=19.06u
+ PD=19.06u rfmode=0
M$8 vss \$10 q vss sg13_lv_nmos L=0.13u W=1.5u AS=0.51p AD=0.51p PS=3.68u
+ PD=3.68u rfmode=0
M$9 qb \$3 vss vss sg13_lv_nmos L=0.13u W=1.5u AS=0.51p AD=0.51p PS=3.68u
+ PD=3.68u rfmode=0
M$10 qb q vss vss sg13_lv_nmos L=0.13u W=1.5u AS=0.51p AD=0.51p PS=3.68u
+ PD=3.68u rfmode=0
M$11 vss \$4 \$10 vss sg13_lv_nmos L=0.13u W=4u AS=1.36p AD=1.36p PS=8.68u
+ PD=8.68u rfmode=0
M$12 \$7 inp \$7 vss sg13_lv_nmos L=0.13u W=6u AS=2.04p AD=2.04p PS=12.68u
+ PD=12.68u rfmode=0
M$13 vss clk \$9 vss sg13_lv_nmos L=0.13u W=16u AS=3.64p AD=3.64p PS=21.82u
+ PD=21.82u rfmode=0
M$17 \$8 inp \$9 vss sg13_lv_nmos L=0.34u W=12u AS=3.18p AD=3.18p PS=19.06u
+ PD=19.06u rfmode=0
M$19 vdd clk \$4 vdd sg13_lv_pmos L=0.13u W=6u AS=2.04p AD=2.04p PS=12.68u
+ PD=12.68u rfmode=0
M$20 \$12 clk vdd vdd sg13_lv_pmos L=0.13u W=6u AS=2.04p AD=2.04p PS=12.68u
+ PD=12.68u rfmode=0
M$21 \$16 qb q vdd sg13_lv_pmos L=0.13u W=4u AS=1.36p AD=1.36p PS=8.68u
+ PD=8.68u rfmode=0
M$22 vdd \$10 \$16 vdd sg13_lv_pmos L=0.13u W=4u AS=1.36p AD=1.36p PS=8.68u
+ PD=8.68u rfmode=0
M$23 \$3 \$12 vdd vdd sg13_lv_pmos L=0.13u W=1u AS=0.34p AD=0.34p PS=2.68u
+ PD=2.68u rfmode=0
M$24 vdd \$12 \$4 vdd sg13_lv_pmos L=0.13u W=3u AS=1.02p AD=1.02p PS=6.68u
+ PD=6.68u rfmode=0
M$25 qb q \$15 vdd sg13_lv_pmos L=0.13u W=4u AS=1.36p AD=1.36p PS=8.68u
+ PD=8.68u rfmode=0
M$26 \$15 \$3 vdd vdd sg13_lv_pmos L=0.13u W=4u AS=1.36p AD=1.36p PS=8.68u
+ PD=8.68u rfmode=0
M$27 \$12 \$4 vdd vdd sg13_lv_pmos L=0.13u W=3u AS=1.02p AD=1.02p PS=6.68u
+ PD=6.68u rfmode=0
M$28 vdd \$4 \$10 vdd sg13_lv_pmos L=0.13u W=1u AS=0.34p AD=0.34p PS=2.68u
+ PD=2.68u rfmode=0
M$29 \$8 clk vdd vdd sg13_lv_pmos L=0.13u W=3u AS=1.02p AD=1.02p PS=6.68u
+ PD=6.68u rfmode=0
M$30 vdd clk \$7 vdd sg13_lv_pmos L=0.13u W=3u AS=1.02p AD=1.02p PS=6.68u
+ PD=6.68u rfmode=0
.ENDS g1_cmp

.SUBCKT g1_dac8 vss vdd d0 d1 d2 d3 d4 d5 d6 d7 vdda vref out
M$1 vss d0 \$11 vss sg13_lv_nmos L=0.13u W=0.5u AS=0.17p AD=0.17p PS=1.68u
+ PD=1.68u rfmode=0
M$2 vss d1 \$12 vss sg13_lv_nmos L=0.13u W=0.5u AS=0.17p AD=0.17p PS=1.68u
+ PD=1.68u rfmode=0
M$3 vss d2 \$13 vss sg13_lv_nmos L=0.13u W=0.5u AS=0.17p AD=0.17p PS=1.68u
+ PD=1.68u rfmode=0
M$4 vss d3 \$14 vss sg13_lv_nmos L=0.13u W=0.5u AS=0.17p AD=0.17p PS=1.68u
+ PD=1.68u rfmode=0
M$5 vss d4 \$15 vss sg13_lv_nmos L=0.13u W=0.5u AS=0.17p AD=0.17p PS=1.68u
+ PD=1.68u rfmode=0
M$6 vss d5 \$16 vss sg13_lv_nmos L=0.13u W=0.5u AS=0.17p AD=0.17p PS=1.68u
+ PD=1.68u rfmode=0
M$7 vss d6 \$17 vss sg13_lv_nmos L=0.13u W=0.5u AS=0.17p AD=0.17p PS=1.68u
+ PD=1.68u rfmode=0
M$8 vss d7 \$18 vss sg13_lv_nmos L=0.13u W=0.5u AS=0.17p AD=0.17p PS=1.68u
+ PD=1.68u rfmode=0
M$9 vss d0 \$19 vss sg13_hv_nmos L=0.45u W=1.9u AS=0.646p AD=0.646p PS=4.48u
+ PD=4.48u rfmode=0
M$10 vss \$11 \$35 vss sg13_hv_nmos L=0.45u W=1.9u AS=0.646p AD=0.646p PS=4.48u
+ PD=4.48u rfmode=0
M$11 vss \$19 \$20 vss sg13_hv_nmos L=0.45u W=1.9u AS=0.646p AD=0.646p PS=4.48u
+ PD=4.48u rfmode=0
M$12 vss \$20 \$36 vss sg13_hv_nmos L=0.45u W=1.9u AS=0.646p AD=0.646p PS=4.48u
+ PD=4.48u rfmode=0
M$13 vss d1 \$21 vss sg13_hv_nmos L=0.45u W=1.9u AS=0.646p AD=0.646p PS=4.48u
+ PD=4.48u rfmode=0
M$14 vss \$12 \$37 vss sg13_hv_nmos L=0.45u W=1.9u AS=0.646p AD=0.646p PS=4.48u
+ PD=4.48u rfmode=0
M$15 vss \$21 \$22 vss sg13_hv_nmos L=0.45u W=1.9u AS=0.646p AD=0.646p PS=4.48u
+ PD=4.48u rfmode=0
M$16 vss \$22 \$38 vss sg13_hv_nmos L=0.45u W=1.9u AS=0.646p AD=0.646p PS=4.48u
+ PD=4.48u rfmode=0
M$17 vss d2 \$23 vss sg13_hv_nmos L=0.45u W=1.9u AS=0.646p AD=0.646p PS=4.48u
+ PD=4.48u rfmode=0
M$18 vss \$13 \$39 vss sg13_hv_nmos L=0.45u W=1.9u AS=0.646p AD=0.646p PS=4.48u
+ PD=4.48u rfmode=0
M$19 vss \$23 \$24 vss sg13_hv_nmos L=0.45u W=1.9u AS=0.646p AD=0.646p PS=4.48u
+ PD=4.48u rfmode=0
M$20 vss \$24 \$40 vss sg13_hv_nmos L=0.45u W=1.9u AS=0.646p AD=0.646p PS=4.48u
+ PD=4.48u rfmode=0
M$21 vss d3 \$25 vss sg13_hv_nmos L=0.45u W=1.9u AS=0.646p AD=0.646p PS=4.48u
+ PD=4.48u rfmode=0
M$22 vss \$14 \$41 vss sg13_hv_nmos L=0.45u W=1.9u AS=0.646p AD=0.646p PS=4.48u
+ PD=4.48u rfmode=0
M$23 vss \$25 \$26 vss sg13_hv_nmos L=0.45u W=1.9u AS=0.646p AD=0.646p PS=4.48u
+ PD=4.48u rfmode=0
M$24 vss \$26 \$42 vss sg13_hv_nmos L=0.45u W=1.9u AS=0.646p AD=0.646p PS=4.48u
+ PD=4.48u rfmode=0
M$25 vss d4 \$27 vss sg13_hv_nmos L=0.45u W=1.9u AS=0.646p AD=0.646p PS=4.48u
+ PD=4.48u rfmode=0
M$26 vss \$15 \$43 vss sg13_hv_nmos L=0.45u W=1.9u AS=0.646p AD=0.646p PS=4.48u
+ PD=4.48u rfmode=0
M$27 vss \$27 \$28 vss sg13_hv_nmos L=0.45u W=1.9u AS=0.646p AD=0.646p PS=4.48u
+ PD=4.48u rfmode=0
M$28 vss \$28 \$44 vss sg13_hv_nmos L=0.45u W=1.9u AS=0.646p AD=0.646p PS=4.48u
+ PD=4.48u rfmode=0
M$29 vss d5 \$29 vss sg13_hv_nmos L=0.45u W=1.9u AS=0.646p AD=0.646p PS=4.48u
+ PD=4.48u rfmode=0
M$30 vss \$16 \$45 vss sg13_hv_nmos L=0.45u W=1.9u AS=0.646p AD=0.646p PS=4.48u
+ PD=4.48u rfmode=0
M$31 vss \$29 \$30 vss sg13_hv_nmos L=0.45u W=1.9u AS=0.646p AD=0.646p PS=4.48u
+ PD=4.48u rfmode=0
M$32 vss \$30 \$46 vss sg13_hv_nmos L=0.45u W=1.9u AS=0.646p AD=0.646p PS=4.48u
+ PD=4.48u rfmode=0
M$33 vss d6 \$31 vss sg13_hv_nmos L=0.45u W=1.9u AS=0.646p AD=0.646p PS=4.48u
+ PD=4.48u rfmode=0
M$34 vss \$17 \$47 vss sg13_hv_nmos L=0.45u W=1.9u AS=0.646p AD=0.646p PS=4.48u
+ PD=4.48u rfmode=0
M$35 vss \$31 \$32 vss sg13_hv_nmos L=0.45u W=1.9u AS=0.646p AD=0.646p PS=4.48u
+ PD=4.48u rfmode=0
M$36 vss \$32 \$48 vss sg13_hv_nmos L=0.45u W=1.9u AS=0.646p AD=0.646p PS=4.48u
+ PD=4.48u rfmode=0
M$37 vss d7 \$33 vss sg13_hv_nmos L=0.45u W=1.9u AS=0.646p AD=0.646p PS=4.48u
+ PD=4.48u rfmode=0
M$38 vss \$18 \$49 vss sg13_hv_nmos L=0.45u W=1.9u AS=0.646p AD=0.646p PS=4.48u
+ PD=4.48u rfmode=0
M$39 vss \$33 \$34 vss sg13_hv_nmos L=0.45u W=1.9u AS=0.646p AD=0.646p PS=4.48u
+ PD=4.48u rfmode=0
M$40 vss \$34 \$50 vss sg13_hv_nmos L=0.45u W=1.9u AS=0.646p AD=0.646p PS=4.48u
+ PD=4.48u rfmode=0
M$41 \$54 \$36 \$58 vss sg13_hv_nmos L=0.45u W=2u AS=0.68p AD=0.38p PS=4.68u
+ PD=2.38u rfmode=0
M$42 \$58 \$20 \$63 vss sg13_hv_nmos L=0.45u W=2u AS=0.38p AD=0.68p PS=2.38u
+ PD=4.68u rfmode=0
M$43 \$76 \$36 \$85 vss sg13_hv_nmos L=0.45u W=2u AS=0.68p AD=0.38p PS=4.68u
+ PD=2.38u rfmode=0
M$44 \$85 \$20 \$86 vss sg13_hv_nmos L=0.45u W=2u AS=0.38p AD=0.68p PS=2.38u
+ PD=4.68u rfmode=0
M$45 \$102 \$36 \$113 vss sg13_hv_nmos L=0.45u W=2u AS=0.68p AD=0.38p PS=4.68u
+ PD=2.38u rfmode=0
M$46 \$113 \$20 \$114 vss sg13_hv_nmos L=0.45u W=2u AS=0.38p AD=0.68p PS=2.38u
+ PD=4.68u rfmode=0
M$47 \$113 \$38 \$103 vss sg13_hv_nmos L=0.45u W=2u AS=0.68p AD=0.38p PS=4.68u
+ PD=2.38u rfmode=0
M$48 \$103 \$22 \$140 vss sg13_hv_nmos L=0.45u W=2u AS=0.38p AD=0.68p PS=2.38u
+ PD=4.68u rfmode=0
M$49 \$58 \$38 \$68 vss sg13_hv_nmos L=0.45u W=2u AS=0.68p AD=0.38p PS=4.68u
+ PD=2.38u rfmode=0
M$50 \$68 \$22 \$85 vss sg13_hv_nmos L=0.45u W=2u AS=0.38p AD=0.68p PS=2.38u
+ PD=4.68u rfmode=0
M$51 \$68 \$40 \$94 vss sg13_hv_nmos L=0.45u W=2u AS=0.68p AD=0.38p PS=4.68u
+ PD=2.38u rfmode=0
M$52 \$94 \$24 \$103 vss sg13_hv_nmos L=0.45u W=2u AS=0.38p AD=0.68p PS=2.38u
+ PD=4.68u rfmode=0
M$53 \$64 \$20 \$69 vss sg13_hv_nmos L=0.45u W=2u AS=0.68p AD=0.38p PS=4.68u
+ PD=2.38u rfmode=0
M$54 \$69 \$36 \$77 vss sg13_hv_nmos L=0.45u W=2u AS=0.38p AD=0.68p PS=2.38u
+ PD=4.68u rfmode=0
M$55 \$115 \$20 \$124 vss sg13_hv_nmos L=0.45u W=2u AS=0.68p AD=0.38p PS=4.68u
+ PD=2.38u rfmode=0
M$56 \$124 \$36 \$131 vss sg13_hv_nmos L=0.45u W=2u AS=0.38p AD=0.68p PS=2.38u
+ PD=4.68u rfmode=0
M$57 \$87 \$20 \$95 vss sg13_hv_nmos L=0.45u W=2u AS=0.68p AD=0.38p PS=4.68u
+ PD=2.38u rfmode=0
M$58 \$95 \$36 \$104 vss sg13_hv_nmos L=0.45u W=2u AS=0.38p AD=0.68p PS=2.38u
+ PD=4.68u rfmode=0
M$59 \$69 \$22 \$88 vss sg13_hv_nmos L=0.45u W=2u AS=0.68p AD=0.38p PS=4.68u
+ PD=2.38u rfmode=0
M$60 \$88 \$38 \$95 vss sg13_hv_nmos L=0.45u W=2u AS=0.38p AD=0.68p PS=2.38u
+ PD=4.68u rfmode=0
M$61 \$88 \$24 \$117 vss sg13_hv_nmos L=0.45u W=2u AS=0.68p AD=0.38p PS=4.68u
+ PD=2.38u rfmode=0
M$62 \$117 \$40 \$116 vss sg13_hv_nmos L=0.45u W=2u AS=0.38p AD=0.68p PS=2.38u
+ PD=4.68u rfmode=0
M$63 \$55 \$36 \$59 vss sg13_hv_nmos L=0.45u W=2u AS=0.68p AD=0.38p PS=4.68u
+ PD=2.38u rfmode=0
M$64 \$59 \$20 \$65 vss sg13_hv_nmos L=0.45u W=2u AS=0.38p AD=0.68p PS=2.38u
+ PD=4.68u rfmode=0
M$65 \$105 \$36 \$118 vss sg13_hv_nmos L=0.45u W=2u AS=0.68p AD=0.38p PS=4.68u
+ PD=2.38u rfmode=0
M$66 \$118 \$20 \$119 vss sg13_hv_nmos L=0.45u W=2u AS=0.38p AD=0.68p PS=2.38u
+ PD=4.68u rfmode=0
M$67 \$78 \$36 \$89 vss sg13_hv_nmos L=0.45u W=2u AS=0.68p AD=0.38p PS=4.68u
+ PD=2.38u rfmode=0
M$68 \$89 \$20 \$90 vss sg13_hv_nmos L=0.45u W=2u AS=0.38p AD=0.68p PS=2.38u
+ PD=4.68u rfmode=0
M$69 \$59 \$38 \$70 vss sg13_hv_nmos L=0.45u W=2u AS=0.68p AD=0.38p PS=4.68u
+ PD=2.38u rfmode=0
M$70 \$70 \$22 \$89 vss sg13_hv_nmos L=0.45u W=2u AS=0.38p AD=0.68p PS=2.38u
+ PD=4.68u rfmode=0
M$71 \$70 \$40 \$96 vss sg13_hv_nmos L=0.45u W=2u AS=0.68p AD=0.38p PS=4.68u
+ PD=2.38u rfmode=0
M$72 \$96 \$24 \$106 vss sg13_hv_nmos L=0.45u W=2u AS=0.38p AD=0.68p PS=2.38u
+ PD=4.68u rfmode=0
M$73 \$118 \$38 \$106 vss sg13_hv_nmos L=0.45u W=2u AS=0.68p AD=0.38p PS=4.68u
+ PD=2.38u rfmode=0
M$74 \$106 \$22 \$142 vss sg13_hv_nmos L=0.45u W=2u AS=0.38p AD=0.68p PS=2.38u
+ PD=4.68u rfmode=0
M$75 \$120 \$20 \$125 vss sg13_hv_nmos L=0.45u W=2u AS=0.68p AD=0.38p PS=4.68u
+ PD=2.38u rfmode=0
M$76 \$125 \$36 \$133 vss sg13_hv_nmos L=0.45u W=2u AS=0.38p AD=0.68p PS=2.38u
+ PD=4.68u rfmode=0
M$77 \$66 \$20 \$71 vss sg13_hv_nmos L=0.45u W=2u AS=0.68p AD=0.38p PS=4.68u
+ PD=2.38u rfmode=0
M$78 \$71 \$36 \$79 vss sg13_hv_nmos L=0.45u W=2u AS=0.38p AD=0.68p PS=2.38u
+ PD=4.68u rfmode=0
M$79 \$91 \$20 \$97 vss sg13_hv_nmos L=0.45u W=2u AS=0.68p AD=0.38p PS=4.68u
+ PD=2.38u rfmode=0
M$80 \$97 \$36 \$107 vss sg13_hv_nmos L=0.45u W=2u AS=0.38p AD=0.68p PS=2.38u
+ PD=4.68u rfmode=0
M$81 \$71 \$22 \$92 vss sg13_hv_nmos L=0.45u W=2u AS=0.68p AD=0.38p PS=4.68u
+ PD=2.38u rfmode=0
M$82 \$92 \$38 \$97 vss sg13_hv_nmos L=0.45u W=2u AS=0.38p AD=0.68p PS=2.38u
+ PD=4.68u rfmode=0
M$83 \$92 \$24 \$121 vss sg13_hv_nmos L=0.45u W=2u AS=0.68p AD=0.38p PS=4.68u
+ PD=2.38u rfmode=0
M$84 \$121 \$40 \$122 vss sg13_hv_nmos L=0.45u W=2u AS=0.38p AD=0.68p PS=2.38u
+ PD=4.68u rfmode=0
M$85 \$130 \$36 \$140 vss sg13_hv_nmos L=0.45u W=2u AS=0.68p AD=0.38p PS=4.68u
+ PD=2.38u rfmode=0
M$86 \$140 \$20 \$139 vss sg13_hv_nmos L=0.45u W=2u AS=0.38p AD=0.68p PS=2.38u
+ PD=4.68u rfmode=0
M$87 \$124 \$22 \$116 vss sg13_hv_nmos L=0.45u W=2u AS=0.68p AD=0.38p PS=4.68u
+ PD=2.38u rfmode=0
M$88 \$116 \$38 \$146 vss sg13_hv_nmos L=0.45u W=2u AS=0.38p AD=0.68p PS=2.38u
+ PD=4.68u rfmode=0
M$89 \$132 \$36 \$142 vss sg13_hv_nmos L=0.45u W=2u AS=0.68p AD=0.38p PS=4.68u
+ PD=2.38u rfmode=0
M$90 \$142 \$20 \$143 vss sg13_hv_nmos L=0.45u W=2u AS=0.38p AD=0.68p PS=2.38u
+ PD=4.68u rfmode=0
M$91 \$125 \$22 \$122 vss sg13_hv_nmos L=0.45u W=2u AS=0.68p AD=0.38p PS=4.68u
+ PD=2.38u rfmode=0
M$92 \$122 \$38 \$148 vss sg13_hv_nmos L=0.45u W=2u AS=0.38p AD=0.68p PS=2.38u
+ PD=4.68u rfmode=0
M$93 \$94 \$42 \$145 vss sg13_hv_nmos L=0.45u W=2u AS=0.68p AD=0.38p PS=4.68u
+ PD=2.38u rfmode=0
M$94 \$145 \$26 \$155 vss sg13_hv_nmos L=0.45u W=2u AS=0.38p AD=0.68p PS=2.38u
+ PD=4.68u rfmode=0
M$95 \$141 \$20 \$146 vss sg13_hv_nmos L=0.45u W=2u AS=0.68p AD=0.38p PS=4.68u
+ PD=2.38u rfmode=0
M$96 \$146 \$36 \$156 vss sg13_hv_nmos L=0.45u W=2u AS=0.38p AD=0.68p PS=2.38u
+ PD=4.68u rfmode=0
M$97 \$96 \$42 \$147 vss sg13_hv_nmos L=0.45u W=2u AS=0.68p AD=0.38p PS=4.68u
+ PD=2.38u rfmode=0
M$98 \$147 \$26 \$158 vss sg13_hv_nmos L=0.45u W=2u AS=0.38p AD=0.68p PS=2.38u
+ PD=4.68u rfmode=0
M$99 \$144 \$20 \$148 vss sg13_hv_nmos L=0.45u W=2u AS=0.68p AD=0.38p PS=4.68u
+ PD=2.38u rfmode=0
M$100 \$148 \$36 \$159 vss sg13_hv_nmos L=0.45u W=2u AS=0.38p AD=0.68p PS=2.38u
+ PD=4.68u rfmode=0
M$101 \$154 \$36 \$165 vss sg13_hv_nmos L=0.45u W=2u AS=0.68p AD=0.38p PS=4.68u
+ PD=2.38u rfmode=0
M$102 \$165 \$20 \$166 vss sg13_hv_nmos L=0.45u W=2u AS=0.38p AD=0.68p PS=2.38u
+ PD=4.68u rfmode=0
M$103 \$117 \$26 \$168 vss sg13_hv_nmos L=0.45u W=2u AS=0.68p AD=0.38p PS=4.68u
+ PD=2.38u rfmode=0
M$104 \$168 \$42 \$169 vss sg13_hv_nmos L=0.45u W=2u AS=0.38p AD=0.68p PS=2.38u
+ PD=4.68u rfmode=0
M$105 \$157 \$36 \$170 vss sg13_hv_nmos L=0.45u W=2u AS=0.68p AD=0.38p PS=4.68u
+ PD=2.38u rfmode=0
M$106 \$170 \$20 \$171 vss sg13_hv_nmos L=0.45u W=2u AS=0.38p AD=0.68p PS=2.38u
+ PD=4.68u rfmode=0
M$107 \$121 \$26 \$173 vss sg13_hv_nmos L=0.45u W=2u AS=0.68p AD=0.38p PS=4.68u
+ PD=2.38u rfmode=0
M$108 \$173 \$42 \$174 vss sg13_hv_nmos L=0.45u W=2u AS=0.38p AD=0.68p PS=2.38u
+ PD=4.68u rfmode=0
M$109 \$165 \$38 \$176 vss sg13_hv_nmos L=0.45u W=2u AS=0.68p AD=0.38p PS=4.68u
+ PD=2.38u rfmode=0
M$110 \$176 \$22 \$193 vss sg13_hv_nmos L=0.45u W=2u AS=0.38p AD=0.68p PS=2.38u
+ PD=4.68u rfmode=0
M$111 \$167 \$20 \$177 vss sg13_hv_nmos L=0.45u W=2u AS=0.68p AD=0.38p PS=4.68u
+ PD=2.38u rfmode=0
M$112 \$177 \$36 \$185 vss sg13_hv_nmos L=0.45u W=2u AS=0.38p AD=0.68p PS=2.38u
+ PD=4.68u rfmode=0
M$113 \$170 \$38 \$178 vss sg13_hv_nmos L=0.45u W=2u AS=0.68p AD=0.38p PS=4.68u
+ PD=2.38u rfmode=0
M$114 \$178 \$22 \$197 vss sg13_hv_nmos L=0.45u W=2u AS=0.38p AD=0.68p PS=2.38u
+ PD=4.68u rfmode=0
M$115 \$172 \$20 \$179 vss sg13_hv_nmos L=0.45u W=2u AS=0.68p AD=0.38p PS=4.68u
+ PD=2.38u rfmode=0
M$116 \$179 \$36 \$187 vss sg13_hv_nmos L=0.45u W=2u AS=0.38p AD=0.68p PS=2.38u
+ PD=4.68u rfmode=0
M$117 \$184 \$36 \$193 vss sg13_hv_nmos L=0.45u W=2u AS=0.68p AD=0.38p PS=4.68u
+ PD=2.38u rfmode=0
M$118 \$193 \$20 \$194 vss sg13_hv_nmos L=0.45u W=2u AS=0.38p AD=0.68p PS=2.38u
+ PD=4.68u rfmode=0
M$119 \$177 \$22 \$196 vss sg13_hv_nmos L=0.45u W=2u AS=0.68p AD=0.38p PS=4.68u
+ PD=2.38u rfmode=0
M$120 \$196 \$38 \$202 vss sg13_hv_nmos L=0.45u W=2u AS=0.38p AD=0.68p PS=2.38u
+ PD=4.68u rfmode=0
M$121 \$186 \$36 \$197 vss sg13_hv_nmos L=0.45u W=2u AS=0.68p AD=0.38p PS=4.68u
+ PD=2.38u rfmode=0
M$122 \$197 \$20 \$198 vss sg13_hv_nmos L=0.45u W=2u AS=0.38p AD=0.68p PS=2.38u
+ PD=4.68u rfmode=0
M$123 \$179 \$22 \$200 vss sg13_hv_nmos L=0.45u W=2u AS=0.68p AD=0.38p PS=4.68u
+ PD=2.38u rfmode=0
M$124 \$200 \$38 \$203 vss sg13_hv_nmos L=0.45u W=2u AS=0.38p AD=0.68p PS=2.38u
+ PD=4.68u rfmode=0
M$125 \$176 \$40 \$155 vss sg13_hv_nmos L=0.45u W=2u AS=0.68p AD=0.38p PS=4.68u
+ PD=2.38u rfmode=0
M$126 \$155 \$24 \$209 vss sg13_hv_nmos L=0.45u W=2u AS=0.38p AD=0.68p PS=2.38u
+ PD=4.68u rfmode=0
M$127 \$195 \$20 \$202 vss sg13_hv_nmos L=0.45u W=2u AS=0.68p AD=0.38p PS=4.68u
+ PD=2.38u rfmode=0
M$128 \$202 \$36 \$210 vss sg13_hv_nmos L=0.45u W=2u AS=0.38p AD=0.68p PS=2.38u
+ PD=4.68u rfmode=0
M$129 \$178 \$40 \$158 vss sg13_hv_nmos L=0.45u W=2u AS=0.68p AD=0.38p PS=4.68u
+ PD=2.38u rfmode=0
M$130 \$158 \$24 \$212 vss sg13_hv_nmos L=0.45u W=2u AS=0.38p AD=0.68p PS=2.38u
+ PD=4.68u rfmode=0
M$131 \$199 \$20 \$203 vss sg13_hv_nmos L=0.45u W=2u AS=0.68p AD=0.38p PS=4.68u
+ PD=2.38u rfmode=0
M$132 \$203 \$36 \$213 vss sg13_hv_nmos L=0.45u W=2u AS=0.38p AD=0.68p PS=2.38u
+ PD=4.68u rfmode=0
M$133 \$208 \$36 \$219 vss sg13_hv_nmos L=0.45u W=2u AS=0.68p AD=0.38p PS=4.68u
+ PD=2.38u rfmode=0
M$134 \$219 \$20 \$220 vss sg13_hv_nmos L=0.45u W=2u AS=0.38p AD=0.68p PS=2.38u
+ PD=4.68u rfmode=0
M$135 \$196 \$24 \$169 vss sg13_hv_nmos L=0.45u W=2u AS=0.68p AD=0.38p PS=4.68u
+ PD=2.38u rfmode=0
M$136 \$169 \$40 \$222 vss sg13_hv_nmos L=0.45u W=2u AS=0.38p AD=0.68p PS=2.38u
+ PD=4.68u rfmode=0
M$137 \$211 \$36 \$224 vss sg13_hv_nmos L=0.45u W=2u AS=0.68p AD=0.38p PS=4.68u
+ PD=2.38u rfmode=0
M$138 \$224 \$20 \$223 vss sg13_hv_nmos L=0.45u W=2u AS=0.38p AD=0.68p PS=2.38u
+ PD=4.68u rfmode=0
M$139 \$200 \$24 \$174 vss sg13_hv_nmos L=0.45u W=2u AS=0.68p AD=0.38p PS=4.68u
+ PD=2.38u rfmode=0
M$140 \$174 \$40 \$226 vss sg13_hv_nmos L=0.45u W=2u AS=0.38p AD=0.68p PS=2.38u
+ PD=4.68u rfmode=0
M$141 \$219 \$38 \$209 vss sg13_hv_nmos L=0.45u W=2u AS=0.68p AD=0.38p PS=4.68u
+ PD=2.38u rfmode=0
M$142 \$209 \$22 \$243 vss sg13_hv_nmos L=0.45u W=2u AS=0.38p AD=0.68p PS=2.38u
+ PD=4.68u rfmode=0
M$143 \$221 \$20 \$228 vss sg13_hv_nmos L=0.45u W=2u AS=0.68p AD=0.38p PS=4.68u
+ PD=2.38u rfmode=0
M$144 \$228 \$36 \$235 vss sg13_hv_nmos L=0.45u W=2u AS=0.38p AD=0.68p PS=2.38u
+ PD=4.68u rfmode=0
M$145 \$224 \$38 \$212 vss sg13_hv_nmos L=0.45u W=2u AS=0.68p AD=0.38p PS=4.68u
+ PD=2.38u rfmode=0
M$146 \$212 \$22 \$246 vss sg13_hv_nmos L=0.45u W=2u AS=0.38p AD=0.68p PS=2.38u
+ PD=4.68u rfmode=0
M$147 \$225 \$20 \$229 vss sg13_hv_nmos L=0.45u W=2u AS=0.68p AD=0.38p PS=4.68u
+ PD=2.38u rfmode=0
M$148 \$229 \$36 \$237 vss sg13_hv_nmos L=0.45u W=2u AS=0.38p AD=0.68p PS=2.38u
+ PD=4.68u rfmode=0
M$149 \$234 \$36 \$243 vss sg13_hv_nmos L=0.45u W=2u AS=0.68p AD=0.38p PS=4.68u
+ PD=2.38u rfmode=0
M$150 \$243 \$20 \$244 vss sg13_hv_nmos L=0.45u W=2u AS=0.38p AD=0.68p PS=2.38u
+ PD=4.68u rfmode=0
M$151 \$228 \$22 \$222 vss sg13_hv_nmos L=0.45u W=2u AS=0.68p AD=0.38p PS=4.68u
+ PD=2.38u rfmode=0
M$152 \$222 \$38 \$251 vss sg13_hv_nmos L=0.45u W=2u AS=0.38p AD=0.68p PS=2.38u
+ PD=4.68u rfmode=0
M$153 \$236 \$36 \$246 vss sg13_hv_nmos L=0.45u W=2u AS=0.68p AD=0.38p PS=4.68u
+ PD=2.38u rfmode=0
M$154 \$246 \$20 \$247 vss sg13_hv_nmos L=0.45u W=2u AS=0.38p AD=0.68p PS=2.38u
+ PD=4.68u rfmode=0
M$155 \$229 \$22 \$226 vss sg13_hv_nmos L=0.45u W=2u AS=0.68p AD=0.38p PS=4.68u
+ PD=2.38u rfmode=0
M$156 \$226 \$38 \$253 vss sg13_hv_nmos L=0.45u W=2u AS=0.38p AD=0.68p PS=2.38u
+ PD=4.68u rfmode=0
M$157 \$145 \$44 \$250 vss sg13_hv_nmos L=0.45u W=2u AS=0.68p AD=0.38p PS=4.68u
+ PD=2.38u rfmode=0
M$158 \$250 \$28 \$350 vss sg13_hv_nmos L=0.45u W=2u AS=0.38p AD=0.68p PS=2.38u
+ PD=4.68u rfmode=0
M$159 \$245 \$20 \$251 vss sg13_hv_nmos L=0.45u W=2u AS=0.68p AD=0.38p PS=4.68u
+ PD=2.38u rfmode=0
M$160 \$251 \$36 \$259 vss sg13_hv_nmos L=0.45u W=2u AS=0.38p AD=0.68p PS=2.38u
+ PD=4.68u rfmode=0
M$161 \$147 \$44 \$252 vss sg13_hv_nmos L=0.45u W=2u AS=0.68p AD=0.38p PS=4.68u
+ PD=2.38u rfmode=0
M$162 \$252 \$28 \$352 vss sg13_hv_nmos L=0.45u W=2u AS=0.38p AD=0.68p PS=2.38u
+ PD=4.68u rfmode=0
M$163 \$248 \$20 \$253 vss sg13_hv_nmos L=0.45u W=2u AS=0.68p AD=0.38p PS=4.68u
+ PD=2.38u rfmode=0
M$164 \$253 \$36 \$261 vss sg13_hv_nmos L=0.45u W=2u AS=0.38p AD=0.68p PS=2.38u
+ PD=4.68u rfmode=0
M$165 \$258 \$36 \$267 vss sg13_hv_nmos L=0.45u W=2u AS=0.68p AD=0.38p PS=4.68u
+ PD=2.38u rfmode=0
M$166 \$267 \$20 \$268 vss sg13_hv_nmos L=0.45u W=2u AS=0.38p AD=0.68p PS=2.38u
+ PD=4.68u rfmode=0
M$167 \$168 \$28 \$270 vss sg13_hv_nmos L=0.45u W=2u AS=0.68p AD=0.38p PS=4.68u
+ PD=2.38u rfmode=0
M$168 \$270 \$44 \$370 vss sg13_hv_nmos L=0.45u W=2u AS=0.38p AD=0.68p PS=2.38u
+ PD=4.68u rfmode=0
M$169 \$260 \$36 \$271 vss sg13_hv_nmos L=0.45u W=2u AS=0.68p AD=0.38p PS=4.68u
+ PD=2.38u rfmode=0
M$170 \$271 \$20 \$272 vss sg13_hv_nmos L=0.45u W=2u AS=0.38p AD=0.68p PS=2.38u
+ PD=4.68u rfmode=0
M$171 \$173 \$28 \$274 vss sg13_hv_nmos L=0.45u W=2u AS=0.68p AD=0.38p PS=4.68u
+ PD=2.38u rfmode=0
M$172 \$274 \$44 \$375 vss sg13_hv_nmos L=0.45u W=2u AS=0.38p AD=0.68p PS=2.38u
+ PD=4.68u rfmode=0
M$173 \$267 \$38 \$276 vss sg13_hv_nmos L=0.45u W=2u AS=0.68p AD=0.38p PS=4.68u
+ PD=2.38u rfmode=0
M$174 \$276 \$22 \$293 vss sg13_hv_nmos L=0.45u W=2u AS=0.38p AD=0.68p PS=2.38u
+ PD=4.68u rfmode=0
M$175 \$269 \$20 \$277 vss sg13_hv_nmos L=0.45u W=2u AS=0.68p AD=0.38p PS=4.68u
+ PD=2.38u rfmode=0
M$176 \$277 \$36 \$285 vss sg13_hv_nmos L=0.45u W=2u AS=0.38p AD=0.68p PS=2.38u
+ PD=4.68u rfmode=0
M$177 \$271 \$38 \$278 vss sg13_hv_nmos L=0.45u W=2u AS=0.68p AD=0.38p PS=4.68u
+ PD=2.38u rfmode=0
M$178 \$278 \$22 \$297 vss sg13_hv_nmos L=0.45u W=2u AS=0.38p AD=0.68p PS=2.38u
+ PD=4.68u rfmode=0
M$179 \$273 \$20 \$279 vss sg13_hv_nmos L=0.45u W=2u AS=0.68p AD=0.38p PS=4.68u
+ PD=2.38u rfmode=0
M$180 \$279 \$36 \$287 vss sg13_hv_nmos L=0.45u W=2u AS=0.38p AD=0.68p PS=2.38u
+ PD=4.68u rfmode=0
M$181 \$284 \$36 \$293 vss sg13_hv_nmos L=0.45u W=2u AS=0.68p AD=0.38p PS=4.68u
+ PD=2.38u rfmode=0
M$182 \$293 \$20 \$294 vss sg13_hv_nmos L=0.45u W=2u AS=0.38p AD=0.68p PS=2.38u
+ PD=4.68u rfmode=0
M$183 \$277 \$22 \$296 vss sg13_hv_nmos L=0.45u W=2u AS=0.68p AD=0.38p PS=4.68u
+ PD=2.38u rfmode=0
M$184 \$296 \$38 \$303 vss sg13_hv_nmos L=0.45u W=2u AS=0.38p AD=0.68p PS=2.38u
+ PD=4.68u rfmode=0
M$185 \$286 \$36 \$297 vss sg13_hv_nmos L=0.45u W=2u AS=0.68p AD=0.38p PS=4.68u
+ PD=2.38u rfmode=0
M$186 \$297 \$20 \$298 vss sg13_hv_nmos L=0.45u W=2u AS=0.38p AD=0.68p PS=2.38u
+ PD=4.68u rfmode=0
M$187 \$279 \$22 \$300 vss sg13_hv_nmos L=0.45u W=2u AS=0.68p AD=0.38p PS=4.68u
+ PD=2.38u rfmode=0
M$188 \$300 \$38 \$305 vss sg13_hv_nmos L=0.45u W=2u AS=0.38p AD=0.68p PS=2.38u
+ PD=4.68u rfmode=0
M$189 \$276 \$40 \$302 vss sg13_hv_nmos L=0.45u W=2u AS=0.68p AD=0.38p PS=4.68u
+ PD=2.38u rfmode=0
M$190 \$302 \$24 \$311 vss sg13_hv_nmos L=0.45u W=2u AS=0.38p AD=0.68p PS=2.38u
+ PD=4.68u rfmode=0
M$191 \$295 \$20 \$303 vss sg13_hv_nmos L=0.45u W=2u AS=0.68p AD=0.38p PS=4.68u
+ PD=2.38u rfmode=0
M$192 \$303 \$36 \$312 vss sg13_hv_nmos L=0.45u W=2u AS=0.38p AD=0.68p PS=2.38u
+ PD=4.68u rfmode=0
M$193 \$278 \$40 \$304 vss sg13_hv_nmos L=0.45u W=2u AS=0.68p AD=0.38p PS=4.68u
+ PD=2.38u rfmode=0
M$194 \$304 \$24 \$314 vss sg13_hv_nmos L=0.45u W=2u AS=0.38p AD=0.68p PS=2.38u
+ PD=4.68u rfmode=0
M$195 \$299 \$20 \$305 vss sg13_hv_nmos L=0.45u W=2u AS=0.68p AD=0.38p PS=4.68u
+ PD=2.38u rfmode=0
M$196 \$305 \$36 \$315 vss sg13_hv_nmos L=0.45u W=2u AS=0.38p AD=0.68p PS=2.38u
+ PD=4.68u rfmode=0
M$197 \$310 \$36 \$320 vss sg13_hv_nmos L=0.45u W=2u AS=0.68p AD=0.38p PS=4.68u
+ PD=2.38u rfmode=0
M$198 \$320 \$20 \$321 vss sg13_hv_nmos L=0.45u W=2u AS=0.38p AD=0.68p PS=2.38u
+ PD=4.68u rfmode=0
M$199 \$296 \$24 \$323 vss sg13_hv_nmos L=0.45u W=2u AS=0.68p AD=0.38p PS=4.68u
+ PD=2.38u rfmode=0
M$200 \$323 \$40 \$324 vss sg13_hv_nmos L=0.45u W=2u AS=0.38p AD=0.68p PS=2.38u
+ PD=4.68u rfmode=0
M$201 \$313 \$36 \$325 vss sg13_hv_nmos L=0.45u W=2u AS=0.68p AD=0.38p PS=4.68u
+ PD=2.38u rfmode=0
M$202 \$325 \$20 \$326 vss sg13_hv_nmos L=0.45u W=2u AS=0.38p AD=0.68p PS=2.38u
+ PD=4.68u rfmode=0
M$203 \$300 \$24 \$328 vss sg13_hv_nmos L=0.45u W=2u AS=0.68p AD=0.38p PS=4.68u
+ PD=2.38u rfmode=0
M$204 \$328 \$40 \$329 vss sg13_hv_nmos L=0.45u W=2u AS=0.38p AD=0.68p PS=2.38u
+ PD=4.68u rfmode=0
M$205 \$320 \$38 \$311 vss sg13_hv_nmos L=0.45u W=2u AS=0.68p AD=0.38p PS=4.68u
+ PD=2.38u rfmode=0
M$206 \$311 \$22 \$344 vss sg13_hv_nmos L=0.45u W=2u AS=0.38p AD=0.68p PS=2.38u
+ PD=4.68u rfmode=0
M$207 \$322 \$20 \$330 vss sg13_hv_nmos L=0.45u W=2u AS=0.68p AD=0.38p PS=4.68u
+ PD=2.38u rfmode=0
M$208 \$330 \$36 \$337 vss sg13_hv_nmos L=0.45u W=2u AS=0.38p AD=0.68p PS=2.38u
+ PD=4.68u rfmode=0
M$209 \$325 \$38 \$314 vss sg13_hv_nmos L=0.45u W=2u AS=0.68p AD=0.38p PS=4.68u
+ PD=2.38u rfmode=0
M$210 \$314 \$22 \$347 vss sg13_hv_nmos L=0.45u W=2u AS=0.38p AD=0.68p PS=2.38u
+ PD=4.68u rfmode=0
M$211 \$327 \$20 \$331 vss sg13_hv_nmos L=0.45u W=2u AS=0.68p AD=0.38p PS=4.68u
+ PD=2.38u rfmode=0
M$212 \$331 \$36 \$339 vss sg13_hv_nmos L=0.45u W=2u AS=0.38p AD=0.68p PS=2.38u
+ PD=4.68u rfmode=0
M$213 \$336 \$36 \$344 vss sg13_hv_nmos L=0.45u W=2u AS=0.68p AD=0.38p PS=4.68u
+ PD=2.38u rfmode=0
M$214 \$344 \$20 \$345 vss sg13_hv_nmos L=0.45u W=2u AS=0.38p AD=0.68p PS=2.38u
+ PD=4.68u rfmode=0
M$215 \$330 \$22 \$324 vss sg13_hv_nmos L=0.45u W=2u AS=0.68p AD=0.38p PS=4.68u
+ PD=2.38u rfmode=0
M$216 \$324 \$38 \$351 vss sg13_hv_nmos L=0.45u W=2u AS=0.38p AD=0.68p PS=2.38u
+ PD=4.68u rfmode=0
M$217 \$338 \$36 \$347 vss sg13_hv_nmos L=0.45u W=2u AS=0.68p AD=0.38p PS=4.68u
+ PD=2.38u rfmode=0
M$218 \$347 \$20 \$348 vss sg13_hv_nmos L=0.45u W=2u AS=0.38p AD=0.68p PS=2.38u
+ PD=4.68u rfmode=0
M$219 \$331 \$22 \$329 vss sg13_hv_nmos L=0.45u W=2u AS=0.68p AD=0.38p PS=4.68u
+ PD=2.38u rfmode=0
M$220 \$329 \$38 \$353 vss sg13_hv_nmos L=0.45u W=2u AS=0.38p AD=0.68p PS=2.38u
+ PD=4.68u rfmode=0
M$221 \$302 \$42 \$350 vss sg13_hv_nmos L=0.45u W=2u AS=0.68p AD=0.38p PS=4.68u
+ PD=2.38u rfmode=0
M$222 \$350 \$26 \$359 vss sg13_hv_nmos L=0.45u W=2u AS=0.38p AD=0.68p PS=2.38u
+ PD=4.68u rfmode=0
M$223 \$346 \$20 \$351 vss sg13_hv_nmos L=0.45u W=2u AS=0.68p AD=0.38p PS=4.68u
+ PD=2.38u rfmode=0
M$224 \$351 \$36 \$360 vss sg13_hv_nmos L=0.45u W=2u AS=0.38p AD=0.68p PS=2.38u
+ PD=4.68u rfmode=0
M$225 \$304 \$42 \$352 vss sg13_hv_nmos L=0.45u W=2u AS=0.68p AD=0.38p PS=4.68u
+ PD=2.38u rfmode=0
M$226 \$352 \$26 \$362 vss sg13_hv_nmos L=0.45u W=2u AS=0.38p AD=0.68p PS=2.38u
+ PD=4.68u rfmode=0
M$227 \$349 \$20 \$353 vss sg13_hv_nmos L=0.45u W=2u AS=0.68p AD=0.38p PS=4.68u
+ PD=2.38u rfmode=0
M$228 \$353 \$36 \$363 vss sg13_hv_nmos L=0.45u W=2u AS=0.38p AD=0.68p PS=2.38u
+ PD=4.68u rfmode=0
M$229 \$358 \$36 \$367 vss sg13_hv_nmos L=0.45u W=2u AS=0.68p AD=0.38p PS=4.68u
+ PD=2.38u rfmode=0
M$230 \$367 \$20 \$368 vss sg13_hv_nmos L=0.45u W=2u AS=0.38p AD=0.68p PS=2.38u
+ PD=4.68u rfmode=0
M$231 \$323 \$26 \$370 vss sg13_hv_nmos L=0.45u W=2u AS=0.68p AD=0.38p PS=4.68u
+ PD=2.38u rfmode=0
M$232 \$370 \$42 \$371 vss sg13_hv_nmos L=0.45u W=2u AS=0.38p AD=0.68p PS=2.38u
+ PD=4.68u rfmode=0
M$233 \$361 \$36 \$372 vss sg13_hv_nmos L=0.45u W=2u AS=0.68p AD=0.38p PS=4.68u
+ PD=2.38u rfmode=0
M$234 \$372 \$20 \$373 vss sg13_hv_nmos L=0.45u W=2u AS=0.38p AD=0.68p PS=2.38u
+ PD=4.68u rfmode=0
M$235 \$328 \$26 \$375 vss sg13_hv_nmos L=0.45u W=2u AS=0.68p AD=0.38p PS=4.68u
+ PD=2.38u rfmode=0
M$236 \$375 \$42 \$376 vss sg13_hv_nmos L=0.45u W=2u AS=0.38p AD=0.68p PS=2.38u
+ PD=4.68u rfmode=0
M$237 \$367 \$38 \$378 vss sg13_hv_nmos L=0.45u W=2u AS=0.68p AD=0.38p PS=4.68u
+ PD=2.38u rfmode=0
M$238 \$378 \$22 \$395 vss sg13_hv_nmos L=0.45u W=2u AS=0.38p AD=0.68p PS=2.38u
+ PD=4.68u rfmode=0
M$239 \$369 \$20 \$379 vss sg13_hv_nmos L=0.45u W=2u AS=0.68p AD=0.38p PS=4.68u
+ PD=2.38u rfmode=0
M$240 \$379 \$36 \$387 vss sg13_hv_nmos L=0.45u W=2u AS=0.38p AD=0.68p PS=2.38u
+ PD=4.68u rfmode=0
M$241 \$372 \$38 \$380 vss sg13_hv_nmos L=0.45u W=2u AS=0.68p AD=0.38p PS=4.68u
+ PD=2.38u rfmode=0
M$242 \$380 \$22 \$398 vss sg13_hv_nmos L=0.45u W=2u AS=0.38p AD=0.68p PS=2.38u
+ PD=4.68u rfmode=0
M$243 \$374 \$20 \$381 vss sg13_hv_nmos L=0.45u W=2u AS=0.68p AD=0.38p PS=4.68u
+ PD=2.38u rfmode=0
M$244 \$381 \$36 \$389 vss sg13_hv_nmos L=0.45u W=2u AS=0.38p AD=0.68p PS=2.38u
+ PD=4.68u rfmode=0
M$245 \$386 \$36 \$395 vss sg13_hv_nmos L=0.45u W=2u AS=0.68p AD=0.38p PS=4.68u
+ PD=2.38u rfmode=0
M$246 \$395 \$20 \$394 vss sg13_hv_nmos L=0.45u W=2u AS=0.38p AD=0.68p PS=2.38u
+ PD=4.68u rfmode=0
M$247 \$379 \$22 \$397 vss sg13_hv_nmos L=0.45u W=2u AS=0.68p AD=0.38p PS=4.68u
+ PD=2.38u rfmode=0
M$248 \$397 \$38 \$402 vss sg13_hv_nmos L=0.45u W=2u AS=0.38p AD=0.68p PS=2.38u
+ PD=4.68u rfmode=0
M$249 \$388 \$36 \$398 vss sg13_hv_nmos L=0.45u W=2u AS=0.68p AD=0.38p PS=4.68u
+ PD=2.38u rfmode=0
M$250 \$398 \$20 \$399 vss sg13_hv_nmos L=0.45u W=2u AS=0.38p AD=0.68p PS=2.38u
+ PD=4.68u rfmode=0
M$251 \$381 \$22 \$401 vss sg13_hv_nmos L=0.45u W=2u AS=0.68p AD=0.38p PS=4.68u
+ PD=2.38u rfmode=0
M$252 \$401 \$38 \$403 vss sg13_hv_nmos L=0.45u W=2u AS=0.38p AD=0.68p PS=2.38u
+ PD=4.68u rfmode=0
M$253 \$378 \$40 \$359 vss sg13_hv_nmos L=0.45u W=2u AS=0.68p AD=0.38p PS=4.68u
+ PD=2.38u rfmode=0
M$254 \$359 \$24 \$409 vss sg13_hv_nmos L=0.45u W=2u AS=0.38p AD=0.68p PS=2.38u
+ PD=4.68u rfmode=0
M$255 \$396 \$20 \$402 vss sg13_hv_nmos L=0.45u W=2u AS=0.68p AD=0.38p PS=4.68u
+ PD=2.38u rfmode=0
M$256 \$402 \$36 \$410 vss sg13_hv_nmos L=0.45u W=2u AS=0.38p AD=0.68p PS=2.38u
+ PD=4.68u rfmode=0
M$257 \$380 \$40 \$362 vss sg13_hv_nmos L=0.45u W=2u AS=0.68p AD=0.38p PS=4.68u
+ PD=2.38u rfmode=0
M$258 \$362 \$24 \$412 vss sg13_hv_nmos L=0.45u W=2u AS=0.38p AD=0.68p PS=2.38u
+ PD=4.68u rfmode=0
M$259 \$400 \$20 \$403 vss sg13_hv_nmos L=0.45u W=2u AS=0.68p AD=0.38p PS=4.68u
+ PD=2.38u rfmode=0
M$260 \$403 \$36 \$413 vss sg13_hv_nmos L=0.45u W=2u AS=0.38p AD=0.68p PS=2.38u
+ PD=4.68u rfmode=0
M$261 \$408 \$36 \$418 vss sg13_hv_nmos L=0.45u W=2u AS=0.68p AD=0.38p PS=4.68u
+ PD=2.38u rfmode=0
M$262 \$418 \$20 \$419 vss sg13_hv_nmos L=0.45u W=2u AS=0.38p AD=0.68p PS=2.38u
+ PD=4.68u rfmode=0
M$263 \$397 \$24 \$371 vss sg13_hv_nmos L=0.45u W=2u AS=0.68p AD=0.38p PS=4.68u
+ PD=2.38u rfmode=0
M$264 \$371 \$40 \$421 vss sg13_hv_nmos L=0.45u W=2u AS=0.38p AD=0.68p PS=2.38u
+ PD=4.68u rfmode=0
M$265 \$411 \$36 \$422 vss sg13_hv_nmos L=0.45u W=2u AS=0.68p AD=0.38p PS=4.68u
+ PD=2.38u rfmode=0
M$266 \$422 \$20 \$423 vss sg13_hv_nmos L=0.45u W=2u AS=0.38p AD=0.68p PS=2.38u
+ PD=4.68u rfmode=0
M$267 \$401 \$24 \$376 vss sg13_hv_nmos L=0.45u W=2u AS=0.68p AD=0.38p PS=4.68u
+ PD=2.38u rfmode=0
M$268 \$376 \$40 \$425 vss sg13_hv_nmos L=0.45u W=2u AS=0.38p AD=0.68p PS=2.38u
+ PD=4.68u rfmode=0
M$269 \$418 \$38 \$409 vss sg13_hv_nmos L=0.45u W=2u AS=0.68p AD=0.38p PS=4.68u
+ PD=2.38u rfmode=0
M$270 \$409 \$22 \$440 vss sg13_hv_nmos L=0.45u W=2u AS=0.38p AD=0.68p PS=2.38u
+ PD=4.68u rfmode=0
M$271 \$420 \$20 \$426 vss sg13_hv_nmos L=0.45u W=2u AS=0.68p AD=0.38p PS=4.68u
+ PD=2.38u rfmode=0
M$272 \$426 \$36 \$433 vss sg13_hv_nmos L=0.45u W=2u AS=0.38p AD=0.68p PS=2.38u
+ PD=4.68u rfmode=0
M$273 \$422 \$38 \$412 vss sg13_hv_nmos L=0.45u W=2u AS=0.68p AD=0.38p PS=4.68u
+ PD=2.38u rfmode=0
M$274 \$412 \$22 \$443 vss sg13_hv_nmos L=0.45u W=2u AS=0.38p AD=0.68p PS=2.38u
+ PD=4.68u rfmode=0
M$275 \$424 \$20 \$427 vss sg13_hv_nmos L=0.45u W=2u AS=0.68p AD=0.38p PS=4.68u
+ PD=2.38u rfmode=0
M$276 \$427 \$36 \$435 vss sg13_hv_nmos L=0.45u W=2u AS=0.38p AD=0.68p PS=2.38u
+ PD=4.68u rfmode=0
M$277 \$432 \$36 \$440 vss sg13_hv_nmos L=0.45u W=2u AS=0.68p AD=0.38p PS=4.68u
+ PD=2.38u rfmode=0
M$278 \$440 \$20 \$441 vss sg13_hv_nmos L=0.45u W=2u AS=0.38p AD=0.68p PS=2.38u
+ PD=4.68u rfmode=0
M$279 \$426 \$22 \$421 vss sg13_hv_nmos L=0.45u W=2u AS=0.68p AD=0.38p PS=4.68u
+ PD=2.38u rfmode=0
M$280 \$421 \$38 \$447 vss sg13_hv_nmos L=0.45u W=2u AS=0.38p AD=0.68p PS=2.38u
+ PD=4.68u rfmode=0
M$281 \$434 \$36 \$443 vss sg13_hv_nmos L=0.45u W=2u AS=0.68p AD=0.38p PS=4.68u
+ PD=2.38u rfmode=0
M$282 \$443 \$20 \$444 vss sg13_hv_nmos L=0.45u W=2u AS=0.38p AD=0.68p PS=2.38u
+ PD=4.68u rfmode=0
M$283 \$427 \$22 \$425 vss sg13_hv_nmos L=0.45u W=2u AS=0.68p AD=0.38p PS=4.68u
+ PD=2.38u rfmode=0
M$284 \$425 \$38 \$449 vss sg13_hv_nmos L=0.45u W=2u AS=0.38p AD=0.68p PS=2.38u
+ PD=4.68u rfmode=0
M$285 \$250 \$46 \$446 vss sg13_hv_nmos L=0.45u W=2u AS=0.68p AD=0.38p PS=4.68u
+ PD=2.38u rfmode=0
M$286 \$446 \$30 \$646 vss sg13_hv_nmos L=0.45u W=2u AS=0.38p AD=0.68p PS=2.38u
+ PD=4.68u rfmode=0
M$287 \$442 \$20 \$447 vss sg13_hv_nmos L=0.45u W=2u AS=0.68p AD=0.38p PS=4.68u
+ PD=2.38u rfmode=0
M$288 \$447 \$36 \$455 vss sg13_hv_nmos L=0.45u W=2u AS=0.38p AD=0.68p PS=2.38u
+ PD=4.68u rfmode=0
M$289 \$252 \$46 \$448 vss sg13_hv_nmos L=0.45u W=2u AS=0.68p AD=0.38p PS=4.68u
+ PD=2.38u rfmode=0
M$290 \$448 \$30 \$650 vss sg13_hv_nmos L=0.45u W=2u AS=0.38p AD=0.68p PS=2.38u
+ PD=4.68u rfmode=0
M$291 \$445 \$20 \$449 vss sg13_hv_nmos L=0.45u W=2u AS=0.68p AD=0.38p PS=4.68u
+ PD=2.38u rfmode=0
M$292 \$449 \$36 \$457 vss sg13_hv_nmos L=0.45u W=2u AS=0.38p AD=0.68p PS=2.38u
+ PD=4.68u rfmode=0
M$293 \$454 \$36 \$462 vss sg13_hv_nmos L=0.45u W=2u AS=0.68p AD=0.38p PS=4.68u
+ PD=2.38u rfmode=0
M$294 \$462 \$20 \$463 vss sg13_hv_nmos L=0.45u W=2u AS=0.38p AD=0.68p PS=2.38u
+ PD=4.68u rfmode=0
M$295 \$270 \$30 \$465 vss sg13_hv_nmos L=0.45u W=2u AS=0.68p AD=0.38p PS=4.68u
+ PD=2.38u rfmode=0
M$296 \$465 \$46 \$654 vss sg13_hv_nmos L=0.45u W=2u AS=0.38p AD=0.68p PS=2.38u
+ PD=4.68u rfmode=0
M$297 \$456 \$36 \$466 vss sg13_hv_nmos L=0.45u W=2u AS=0.68p AD=0.38p PS=4.68u
+ PD=2.38u rfmode=0
M$298 \$466 \$20 \$467 vss sg13_hv_nmos L=0.45u W=2u AS=0.38p AD=0.68p PS=2.38u
+ PD=4.68u rfmode=0
M$299 \$274 \$30 \$469 vss sg13_hv_nmos L=0.45u W=2u AS=0.68p AD=0.38p PS=4.68u
+ PD=2.38u rfmode=0
M$300 \$469 \$46 \$656 vss sg13_hv_nmos L=0.45u W=2u AS=0.38p AD=0.68p PS=2.38u
+ PD=4.68u rfmode=0
M$301 \$462 \$38 \$470 vss sg13_hv_nmos L=0.45u W=2u AS=0.68p AD=0.38p PS=4.68u
+ PD=2.38u rfmode=0
M$302 \$470 \$22 \$486 vss sg13_hv_nmos L=0.45u W=2u AS=0.38p AD=0.68p PS=2.38u
+ PD=4.68u rfmode=0
M$303 \$464 \$20 \$471 vss sg13_hv_nmos L=0.45u W=2u AS=0.68p AD=0.38p PS=4.68u
+ PD=2.38u rfmode=0
M$304 \$471 \$36 \$479 vss sg13_hv_nmos L=0.45u W=2u AS=0.38p AD=0.68p PS=2.38u
+ PD=4.68u rfmode=0
M$305 \$466 \$38 \$472 vss sg13_hv_nmos L=0.45u W=2u AS=0.68p AD=0.38p PS=4.68u
+ PD=2.38u rfmode=0
M$306 \$472 \$22 \$490 vss sg13_hv_nmos L=0.45u W=2u AS=0.38p AD=0.68p PS=2.38u
+ PD=4.68u rfmode=0
M$307 \$468 \$20 \$473 vss sg13_hv_nmos L=0.45u W=2u AS=0.68p AD=0.38p PS=4.68u
+ PD=2.38u rfmode=0
M$308 \$473 \$36 \$481 vss sg13_hv_nmos L=0.45u W=2u AS=0.38p AD=0.68p PS=2.38u
+ PD=4.68u rfmode=0
M$309 \$478 \$36 \$486 vss sg13_hv_nmos L=0.45u W=2u AS=0.68p AD=0.38p PS=4.68u
+ PD=2.38u rfmode=0
M$310 \$486 \$20 \$487 vss sg13_hv_nmos L=0.45u W=2u AS=0.38p AD=0.68p PS=2.38u
+ PD=4.68u rfmode=0
M$311 \$471 \$22 \$489 vss sg13_hv_nmos L=0.45u W=2u AS=0.68p AD=0.38p PS=4.68u
+ PD=2.38u rfmode=0
M$312 \$489 \$38 \$496 vss sg13_hv_nmos L=0.45u W=2u AS=0.38p AD=0.68p PS=2.38u
+ PD=4.68u rfmode=0
M$313 \$480 \$36 \$490 vss sg13_hv_nmos L=0.45u W=2u AS=0.68p AD=0.38p PS=4.68u
+ PD=2.38u rfmode=0
M$314 \$490 \$20 \$491 vss sg13_hv_nmos L=0.45u W=2u AS=0.38p AD=0.68p PS=2.38u
+ PD=4.68u rfmode=0
M$315 \$473 \$22 \$493 vss sg13_hv_nmos L=0.45u W=2u AS=0.68p AD=0.38p PS=4.68u
+ PD=2.38u rfmode=0
M$316 \$493 \$38 \$498 vss sg13_hv_nmos L=0.45u W=2u AS=0.38p AD=0.68p PS=2.38u
+ PD=4.68u rfmode=0
M$317 \$469 \$32 \$494 vss sg13_hv_nmos L=0.45u W=2u AS=0.68p AD=0.38p PS=4.68u
+ PD=2.38u rfmode=0
M$318 \$494 \$48 \$448 vss sg13_hv_nmos L=0.45u W=2u AS=0.38p AD=0.68p PS=2.38u
+ PD=4.68u rfmode=0
M$319 \$472 \$40 \$497 vss sg13_hv_nmos L=0.45u W=2u AS=0.68p AD=0.38p PS=4.68u
+ PD=2.38u rfmode=0
M$320 \$497 \$24 \$507 vss sg13_hv_nmos L=0.45u W=2u AS=0.38p AD=0.68p PS=2.38u
+ PD=4.68u rfmode=0
M$321 \$492 \$20 \$498 vss sg13_hv_nmos L=0.45u W=2u AS=0.68p AD=0.38p PS=4.68u
+ PD=2.38u rfmode=0
M$322 \$498 \$36 \$508 vss sg13_hv_nmos L=0.45u W=2u AS=0.38p AD=0.68p PS=2.38u
+ PD=4.68u rfmode=0
M$323 \$470 \$40 \$495 vss sg13_hv_nmos L=0.45u W=2u AS=0.68p AD=0.38p PS=4.68u
+ PD=2.38u rfmode=0
M$324 \$495 \$24 \$504 vss sg13_hv_nmos L=0.45u W=2u AS=0.38p AD=0.68p PS=2.38u
+ PD=4.68u rfmode=0
M$325 \$488 \$20 \$496 vss sg13_hv_nmos L=0.45u W=2u AS=0.68p AD=0.38p PS=4.68u
+ PD=2.38u rfmode=0
M$326 \$496 \$36 \$505 vss sg13_hv_nmos L=0.45u W=2u AS=0.38p AD=0.68p PS=2.38u
+ PD=4.68u rfmode=0
M$327 \$503 \$36 \$513 vss sg13_hv_nmos L=0.45u W=2u AS=0.68p AD=0.38p PS=4.68u
+ PD=2.38u rfmode=0
M$328 \$513 \$20 \$514 vss sg13_hv_nmos L=0.45u W=2u AS=0.38p AD=0.68p PS=2.38u
+ PD=4.68u rfmode=0
M$329 \$489 \$24 \$515 vss sg13_hv_nmos L=0.45u W=2u AS=0.68p AD=0.38p PS=4.68u
+ PD=2.38u rfmode=0
M$330 \$515 \$40 \$516 vss sg13_hv_nmos L=0.45u W=2u AS=0.38p AD=0.68p PS=2.38u
+ PD=4.68u rfmode=0
M$331 \$506 \$36 \$517 vss sg13_hv_nmos L=0.45u W=2u AS=0.68p AD=0.38p PS=4.68u
+ PD=2.38u rfmode=0
M$332 \$517 \$20 \$518 vss sg13_hv_nmos L=0.45u W=2u AS=0.38p AD=0.68p PS=2.38u
+ PD=4.68u rfmode=0
M$333 \$493 \$24 \$520 vss sg13_hv_nmos L=0.45u W=2u AS=0.68p AD=0.38p PS=4.68u
+ PD=2.38u rfmode=0
M$334 \$520 \$40 \$521 vss sg13_hv_nmos L=0.45u W=2u AS=0.38p AD=0.68p PS=2.38u
+ PD=4.68u rfmode=0
M$335 \$494 \$34 out vss sg13_hv_nmos L=0.45u W=2u AS=0.68p AD=0.38p PS=4.68u
+ PD=2.38u rfmode=0
M$336 out \$50 \$526 vss sg13_hv_nmos L=0.45u W=2u AS=0.38p AD=0.68p PS=2.38u
+ PD=4.68u rfmode=0
M$337 \$517 \$38 \$507 vss sg13_hv_nmos L=0.45u W=2u AS=0.68p AD=0.38p PS=4.68u
+ PD=2.38u rfmode=0
M$338 \$507 \$22 \$536 vss sg13_hv_nmos L=0.45u W=2u AS=0.38p AD=0.68p PS=2.38u
+ PD=4.68u rfmode=0
M$339 \$519 \$20 \$525 vss sg13_hv_nmos L=0.45u W=2u AS=0.68p AD=0.38p PS=4.68u
+ PD=2.38u rfmode=0
M$340 \$525 \$36 \$533 vss sg13_hv_nmos L=0.45u W=2u AS=0.38p AD=0.68p PS=2.38u
+ PD=4.68u rfmode=0
M$341 \$513 \$38 \$504 vss sg13_hv_nmos L=0.45u W=2u AS=0.68p AD=0.38p PS=4.68u
+ PD=2.38u rfmode=0
M$342 \$504 \$22 \$535 vss sg13_hv_nmos L=0.45u W=2u AS=0.38p AD=0.68p PS=2.38u
+ PD=4.68u rfmode=0
M$343 \$523 \$20 \$524 vss sg13_hv_nmos L=0.45u W=2u AS=0.68p AD=0.38p PS=4.68u
+ PD=2.38u rfmode=0
M$344 \$524 \$36 \$531 vss sg13_hv_nmos L=0.45u W=2u AS=0.38p AD=0.68p PS=2.38u
+ PD=4.68u rfmode=0
M$345 \$530 \$36 \$535 vss sg13_hv_nmos L=0.45u W=2u AS=0.68p AD=0.38p PS=4.68u
+ PD=2.38u rfmode=0
M$346 \$535 \$20 \$541 vss sg13_hv_nmos L=0.45u W=2u AS=0.38p AD=0.68p PS=2.38u
+ PD=4.68u rfmode=0
M$347 \$524 \$22 \$516 vss sg13_hv_nmos L=0.45u W=2u AS=0.68p AD=0.38p PS=4.68u
+ PD=2.38u rfmode=0
M$348 \$516 \$38 \$546 vss sg13_hv_nmos L=0.45u W=2u AS=0.38p AD=0.68p PS=2.38u
+ PD=4.68u rfmode=0
M$349 \$532 \$36 \$536 vss sg13_hv_nmos L=0.45u W=2u AS=0.68p AD=0.38p PS=4.68u
+ PD=2.38u rfmode=0
M$350 \$536 \$20 \$543 vss sg13_hv_nmos L=0.45u W=2u AS=0.38p AD=0.68p PS=2.38u
+ PD=4.68u rfmode=0
M$351 \$525 \$22 \$521 vss sg13_hv_nmos L=0.45u W=2u AS=0.68p AD=0.38p PS=4.68u
+ PD=2.38u rfmode=0
M$352 \$521 \$38 \$548 vss sg13_hv_nmos L=0.45u W=2u AS=0.38p AD=0.68p PS=2.38u
+ PD=4.68u rfmode=0
M$353 \$465 \$32 \$526 vss sg13_hv_nmos L=0.45u W=2u AS=0.68p AD=0.38p PS=4.68u
+ PD=2.38u rfmode=0
M$354 \$526 \$48 \$446 vss sg13_hv_nmos L=0.45u W=2u AS=0.38p AD=0.68p PS=2.38u
+ PD=4.68u rfmode=0
M$355 \$497 \$42 \$547 vss sg13_hv_nmos L=0.45u W=2u AS=0.68p AD=0.38p PS=4.68u
+ PD=2.38u rfmode=0
M$356 \$547 \$26 \$557 vss sg13_hv_nmos L=0.45u W=2u AS=0.38p AD=0.68p PS=2.38u
+ PD=4.68u rfmode=0
M$357 \$544 \$20 \$548 vss sg13_hv_nmos L=0.45u W=2u AS=0.68p AD=0.38p PS=4.68u
+ PD=2.38u rfmode=0
M$358 \$548 \$36 \$558 vss sg13_hv_nmos L=0.45u W=2u AS=0.38p AD=0.68p PS=2.38u
+ PD=4.68u rfmode=0
M$359 \$495 \$42 \$545 vss sg13_hv_nmos L=0.45u W=2u AS=0.68p AD=0.38p PS=4.68u
+ PD=2.38u rfmode=0
M$360 \$545 \$26 \$554 vss sg13_hv_nmos L=0.45u W=2u AS=0.38p AD=0.68p PS=2.38u
+ PD=4.68u rfmode=0
M$361 \$542 \$20 \$546 vss sg13_hv_nmos L=0.45u W=2u AS=0.68p AD=0.38p PS=4.68u
+ PD=2.38u rfmode=0
M$362 \$546 \$36 \$555 vss sg13_hv_nmos L=0.45u W=2u AS=0.38p AD=0.68p PS=2.38u
+ PD=4.68u rfmode=0
M$363 \$553 \$36 \$559 vss sg13_hv_nmos L=0.45u W=2u AS=0.68p AD=0.38p PS=4.68u
+ PD=2.38u rfmode=0
M$364 \$559 \$20 \$567 vss sg13_hv_nmos L=0.45u W=2u AS=0.38p AD=0.68p PS=2.38u
+ PD=4.68u rfmode=0
M$365 \$515 \$26 \$560 vss sg13_hv_nmos L=0.45u W=2u AS=0.68p AD=0.38p PS=4.68u
+ PD=2.38u rfmode=0
M$366 \$560 \$42 \$569 vss sg13_hv_nmos L=0.45u W=2u AS=0.38p AD=0.68p PS=2.38u
+ PD=4.68u rfmode=0
M$367 \$556 \$36 \$561 vss sg13_hv_nmos L=0.45u W=2u AS=0.68p AD=0.38p PS=4.68u
+ PD=2.38u rfmode=0
M$368 \$561 \$20 \$570 vss sg13_hv_nmos L=0.45u W=2u AS=0.38p AD=0.68p PS=2.38u
+ PD=4.68u rfmode=0
M$369 \$520 \$26 \$562 vss sg13_hv_nmos L=0.45u W=2u AS=0.68p AD=0.38p PS=4.68u
+ PD=2.38u rfmode=0
M$370 \$562 \$42 \$572 vss sg13_hv_nmos L=0.45u W=2u AS=0.38p AD=0.68p PS=2.38u
+ PD=4.68u rfmode=0
M$371 \$559 \$38 \$578 vss sg13_hv_nmos L=0.45u W=2u AS=0.68p AD=0.38p PS=4.68u
+ PD=2.38u rfmode=0
M$372 \$578 \$22 \$585 vss sg13_hv_nmos L=0.45u W=2u AS=0.38p AD=0.68p PS=2.38u
+ PD=4.68u rfmode=0
M$373 \$568 \$20 \$580 vss sg13_hv_nmos L=0.45u W=2u AS=0.68p AD=0.38p PS=4.68u
+ PD=2.38u rfmode=0
M$374 \$580 \$36 \$579 vss sg13_hv_nmos L=0.45u W=2u AS=0.38p AD=0.68p PS=2.38u
+ PD=4.68u rfmode=0
M$375 \$561 \$38 \$582 vss sg13_hv_nmos L=0.45u W=2u AS=0.68p AD=0.38p PS=4.68u
+ PD=2.38u rfmode=0
M$376 \$582 \$22 \$587 vss sg13_hv_nmos L=0.45u W=2u AS=0.38p AD=0.68p PS=2.38u
+ PD=4.68u rfmode=0
M$377 \$571 \$20 \$583 vss sg13_hv_nmos L=0.45u W=2u AS=0.68p AD=0.38p PS=4.68u
+ PD=2.38u rfmode=0
M$378 \$583 \$36 \$584 vss sg13_hv_nmos L=0.45u W=2u AS=0.38p AD=0.68p PS=2.38u
+ PD=4.68u rfmode=0
M$379 \$577 \$36 \$585 vss sg13_hv_nmos L=0.45u W=2u AS=0.68p AD=0.38p PS=4.68u
+ PD=2.38u rfmode=0
M$380 \$585 \$20 \$593 vss sg13_hv_nmos L=0.45u W=2u AS=0.38p AD=0.68p PS=2.38u
+ PD=4.68u rfmode=0
M$381 \$580 \$22 \$586 vss sg13_hv_nmos L=0.45u W=2u AS=0.68p AD=0.38p PS=4.68u
+ PD=2.38u rfmode=0
M$382 \$586 \$38 \$603 vss sg13_hv_nmos L=0.45u W=2u AS=0.38p AD=0.68p PS=2.38u
+ PD=4.68u rfmode=0
M$383 \$581 \$36 \$587 vss sg13_hv_nmos L=0.45u W=2u AS=0.68p AD=0.38p PS=4.68u
+ PD=2.38u rfmode=0
M$384 \$587 \$20 \$595 vss sg13_hv_nmos L=0.45u W=2u AS=0.38p AD=0.68p PS=2.38u
+ PD=4.68u rfmode=0
M$385 \$583 \$22 \$588 vss sg13_hv_nmos L=0.45u W=2u AS=0.68p AD=0.38p PS=4.68u
+ PD=2.38u rfmode=0
M$386 \$588 \$38 \$607 vss sg13_hv_nmos L=0.45u W=2u AS=0.38p AD=0.68p PS=2.38u
+ PD=4.68u rfmode=0
M$387 \$578 \$40 \$554 vss sg13_hv_nmos L=0.45u W=2u AS=0.68p AD=0.38p PS=4.68u
+ PD=2.38u rfmode=0
M$388 \$554 \$24 \$602 vss sg13_hv_nmos L=0.45u W=2u AS=0.38p AD=0.68p PS=2.38u
+ PD=4.68u rfmode=0
M$389 \$594 \$20 \$603 vss sg13_hv_nmos L=0.45u W=2u AS=0.68p AD=0.38p PS=4.68u
+ PD=2.38u rfmode=0
M$390 \$603 \$36 \$604 vss sg13_hv_nmos L=0.45u W=2u AS=0.38p AD=0.68p PS=2.38u
+ PD=4.68u rfmode=0
M$391 \$582 \$40 \$557 vss sg13_hv_nmos L=0.45u W=2u AS=0.68p AD=0.38p PS=4.68u
+ PD=2.38u rfmode=0
M$392 \$557 \$24 \$606 vss sg13_hv_nmos L=0.45u W=2u AS=0.38p AD=0.68p PS=2.38u
+ PD=4.68u rfmode=0
M$393 \$596 \$20 \$607 vss sg13_hv_nmos L=0.45u W=2u AS=0.68p AD=0.38p PS=4.68u
+ PD=2.38u rfmode=0
M$394 \$607 \$36 \$608 vss sg13_hv_nmos L=0.45u W=2u AS=0.38p AD=0.68p PS=2.38u
+ PD=4.68u rfmode=0
M$395 \$601 \$36 \$609 vss sg13_hv_nmos L=0.45u W=2u AS=0.68p AD=0.38p PS=4.68u
+ PD=2.38u rfmode=0
M$396 \$609 \$20 \$615 vss sg13_hv_nmos L=0.45u W=2u AS=0.38p AD=0.68p PS=2.38u
+ PD=4.68u rfmode=0
M$397 \$586 \$24 \$569 vss sg13_hv_nmos L=0.45u W=2u AS=0.68p AD=0.38p PS=4.68u
+ PD=2.38u rfmode=0
M$398 \$569 \$40 \$617 vss sg13_hv_nmos L=0.45u W=2u AS=0.38p AD=0.68p PS=2.38u
+ PD=4.68u rfmode=0
M$399 \$605 \$36 \$610 vss sg13_hv_nmos L=0.45u W=2u AS=0.68p AD=0.38p PS=4.68u
+ PD=2.38u rfmode=0
M$400 \$610 \$20 \$618 vss sg13_hv_nmos L=0.45u W=2u AS=0.38p AD=0.68p PS=2.38u
+ PD=4.68u rfmode=0
M$401 \$588 \$24 \$572 vss sg13_hv_nmos L=0.45u W=2u AS=0.68p AD=0.38p PS=4.68u
+ PD=2.38u rfmode=0
M$402 \$572 \$40 \$620 vss sg13_hv_nmos L=0.45u W=2u AS=0.38p AD=0.68p PS=2.38u
+ PD=4.68u rfmode=0
M$403 \$609 \$38 \$602 vss sg13_hv_nmos L=0.45u W=2u AS=0.68p AD=0.38p PS=4.68u
+ PD=2.38u rfmode=0
M$404 \$602 \$22 \$631 vss sg13_hv_nmos L=0.45u W=2u AS=0.38p AD=0.68p PS=2.38u
+ PD=4.68u rfmode=0
M$405 \$616 \$20 \$626 vss sg13_hv_nmos L=0.45u W=2u AS=0.68p AD=0.38p PS=4.68u
+ PD=2.38u rfmode=0
M$406 \$626 \$36 \$627 vss sg13_hv_nmos L=0.45u W=2u AS=0.38p AD=0.68p PS=2.38u
+ PD=4.68u rfmode=0
M$407 \$610 \$38 \$606 vss sg13_hv_nmos L=0.45u W=2u AS=0.68p AD=0.38p PS=4.68u
+ PD=2.38u rfmode=0
M$408 \$606 \$22 \$632 vss sg13_hv_nmos L=0.45u W=2u AS=0.38p AD=0.68p PS=2.38u
+ PD=4.68u rfmode=0
M$409 \$619 \$20 \$630 vss sg13_hv_nmos L=0.45u W=2u AS=0.68p AD=0.38p PS=4.68u
+ PD=2.38u rfmode=0
M$410 \$630 \$36 \$629 vss sg13_hv_nmos L=0.45u W=2u AS=0.38p AD=0.68p PS=2.38u
+ PD=4.68u rfmode=0
M$411 \$625 \$36 \$631 vss sg13_hv_nmos L=0.45u W=2u AS=0.68p AD=0.38p PS=4.68u
+ PD=2.38u rfmode=0
M$412 \$631 \$20 \$637 vss sg13_hv_nmos L=0.45u W=2u AS=0.38p AD=0.68p PS=2.38u
+ PD=4.68u rfmode=0
M$413 \$626 \$22 \$617 vss sg13_hv_nmos L=0.45u W=2u AS=0.68p AD=0.38p PS=4.68u
+ PD=2.38u rfmode=0
M$414 \$617 \$38 \$647 vss sg13_hv_nmos L=0.45u W=2u AS=0.38p AD=0.68p PS=2.38u
+ PD=4.68u rfmode=0
M$415 \$628 \$36 \$632 vss sg13_hv_nmos L=0.45u W=2u AS=0.68p AD=0.38p PS=4.68u
+ PD=2.38u rfmode=0
M$416 \$632 \$20 \$639 vss sg13_hv_nmos L=0.45u W=2u AS=0.38p AD=0.68p PS=2.38u
+ PD=4.68u rfmode=0
M$417 \$630 \$22 \$620 vss sg13_hv_nmos L=0.45u W=2u AS=0.68p AD=0.38p PS=4.68u
+ PD=2.38u rfmode=0
M$418 \$620 \$38 \$652 vss sg13_hv_nmos L=0.45u W=2u AS=0.38p AD=0.68p PS=2.38u
+ PD=4.68u rfmode=0
M$419 \$545 \$44 \$646 vss sg13_hv_nmos L=0.45u W=2u AS=0.68p AD=0.38p PS=4.68u
+ PD=2.38u rfmode=0
M$420 \$646 \$28 \$742 vss sg13_hv_nmos L=0.45u W=2u AS=0.38p AD=0.68p PS=2.38u
+ PD=4.68u rfmode=0
M$421 \$638 \$20 \$647 vss sg13_hv_nmos L=0.45u W=2u AS=0.68p AD=0.38p PS=4.68u
+ PD=2.38u rfmode=0
M$422 \$647 \$36 \$648 vss sg13_hv_nmos L=0.45u W=2u AS=0.38p AD=0.68p PS=2.38u
+ PD=4.68u rfmode=0
M$423 \$547 \$44 \$650 vss sg13_hv_nmos L=0.45u W=2u AS=0.68p AD=0.38p PS=4.68u
+ PD=2.38u rfmode=0
M$424 \$650 \$28 \$747 vss sg13_hv_nmos L=0.45u W=2u AS=0.38p AD=0.68p PS=2.38u
+ PD=4.68u rfmode=0
M$425 \$640 \$20 \$652 vss sg13_hv_nmos L=0.45u W=2u AS=0.68p AD=0.38p PS=4.68u
+ PD=2.38u rfmode=0
M$426 \$652 \$36 \$651 vss sg13_hv_nmos L=0.45u W=2u AS=0.38p AD=0.68p PS=2.38u
+ PD=4.68u rfmode=0
M$427 \$645 \$36 \$653 vss sg13_hv_nmos L=0.45u W=2u AS=0.68p AD=0.38p PS=4.68u
+ PD=2.38u rfmode=0
M$428 \$653 \$20 \$661 vss sg13_hv_nmos L=0.45u W=2u AS=0.38p AD=0.68p PS=2.38u
+ PD=4.68u rfmode=0
M$429 \$560 \$28 \$654 vss sg13_hv_nmos L=0.45u W=2u AS=0.68p AD=0.38p PS=4.68u
+ PD=2.38u rfmode=0
M$430 \$654 \$44 \$752 vss sg13_hv_nmos L=0.45u W=2u AS=0.38p AD=0.68p PS=2.38u
+ PD=4.68u rfmode=0
M$431 \$649 \$36 \$655 vss sg13_hv_nmos L=0.45u W=2u AS=0.68p AD=0.38p PS=4.68u
+ PD=2.38u rfmode=0
M$432 \$655 \$20 \$663 vss sg13_hv_nmos L=0.45u W=2u AS=0.38p AD=0.68p PS=2.38u
+ PD=4.68u rfmode=0
M$433 \$562 \$28 \$656 vss sg13_hv_nmos L=0.45u W=2u AS=0.68p AD=0.38p PS=4.68u
+ PD=2.38u rfmode=0
M$434 \$656 \$44 \$754 vss sg13_hv_nmos L=0.45u W=2u AS=0.38p AD=0.68p PS=2.38u
+ PD=4.68u rfmode=0
M$435 \$653 \$38 \$670 vss sg13_hv_nmos L=0.45u W=2u AS=0.68p AD=0.38p PS=4.68u
+ PD=2.38u rfmode=0
M$436 \$670 \$22 \$677 vss sg13_hv_nmos L=0.45u W=2u AS=0.38p AD=0.68p PS=2.38u
+ PD=4.68u rfmode=0
M$437 \$662 \$20 \$671 vss sg13_hv_nmos L=0.45u W=2u AS=0.68p AD=0.38p PS=4.68u
+ PD=2.38u rfmode=0
M$438 \$671 \$36 \$672 vss sg13_hv_nmos L=0.45u W=2u AS=0.38p AD=0.68p PS=2.38u
+ PD=4.68u rfmode=0
M$439 \$655 \$38 \$674 vss sg13_hv_nmos L=0.45u W=2u AS=0.68p AD=0.38p PS=4.68u
+ PD=2.38u rfmode=0
M$440 \$674 \$22 \$679 vss sg13_hv_nmos L=0.45u W=2u AS=0.38p AD=0.68p PS=2.38u
+ PD=4.68u rfmode=0
M$441 \$664 \$20 \$675 vss sg13_hv_nmos L=0.45u W=2u AS=0.68p AD=0.38p PS=4.68u
+ PD=2.38u rfmode=0
M$442 \$675 \$36 \$676 vss sg13_hv_nmos L=0.45u W=2u AS=0.38p AD=0.68p PS=2.38u
+ PD=4.68u rfmode=0
M$443 \$669 \$36 \$677 vss sg13_hv_nmos L=0.45u W=2u AS=0.68p AD=0.38p PS=4.68u
+ PD=2.38u rfmode=0
M$444 \$677 \$20 \$685 vss sg13_hv_nmos L=0.45u W=2u AS=0.38p AD=0.68p PS=2.38u
+ PD=4.68u rfmode=0
M$445 \$671 \$22 \$678 vss sg13_hv_nmos L=0.45u W=2u AS=0.68p AD=0.38p PS=4.68u
+ PD=2.38u rfmode=0
M$446 \$678 \$38 \$696 vss sg13_hv_nmos L=0.45u W=2u AS=0.38p AD=0.68p PS=2.38u
+ PD=4.68u rfmode=0
M$447 \$673 \$36 \$679 vss sg13_hv_nmos L=0.45u W=2u AS=0.68p AD=0.38p PS=4.68u
+ PD=2.38u rfmode=0
M$448 \$679 \$20 \$687 vss sg13_hv_nmos L=0.45u W=2u AS=0.38p AD=0.68p PS=2.38u
+ PD=4.68u rfmode=0
M$449 \$675 \$22 \$680 vss sg13_hv_nmos L=0.45u W=2u AS=0.68p AD=0.38p PS=4.68u
+ PD=2.38u rfmode=0
M$450 \$680 \$38 \$701 vss sg13_hv_nmos L=0.45u W=2u AS=0.38p AD=0.68p PS=2.38u
+ PD=4.68u rfmode=0
M$451 \$670 \$40 \$694 vss sg13_hv_nmos L=0.45u W=2u AS=0.68p AD=0.38p PS=4.68u
+ PD=2.38u rfmode=0
M$452 \$694 \$24 \$695 vss sg13_hv_nmos L=0.45u W=2u AS=0.38p AD=0.68p PS=2.38u
+ PD=4.68u rfmode=0
M$453 \$686 \$20 \$696 vss sg13_hv_nmos L=0.45u W=2u AS=0.68p AD=0.38p PS=4.68u
+ PD=2.38u rfmode=0
M$454 \$696 \$36 \$697 vss sg13_hv_nmos L=0.45u W=2u AS=0.38p AD=0.68p PS=2.38u
+ PD=4.68u rfmode=0
M$455 \$674 \$40 \$699 vss sg13_hv_nmos L=0.45u W=2u AS=0.68p AD=0.38p PS=4.68u
+ PD=2.38u rfmode=0
M$456 \$699 \$24 \$700 vss sg13_hv_nmos L=0.45u W=2u AS=0.38p AD=0.68p PS=2.38u
+ PD=4.68u rfmode=0
M$457 \$688 \$20 \$701 vss sg13_hv_nmos L=0.45u W=2u AS=0.68p AD=0.38p PS=4.68u
+ PD=2.38u rfmode=0
M$458 \$701 \$36 \$702 vss sg13_hv_nmos L=0.45u W=2u AS=0.38p AD=0.68p PS=2.38u
+ PD=4.68u rfmode=0
M$459 \$693 \$36 \$703 vss sg13_hv_nmos L=0.45u W=2u AS=0.68p AD=0.38p PS=4.68u
+ PD=2.38u rfmode=0
M$460 \$703 \$20 \$711 vss sg13_hv_nmos L=0.45u W=2u AS=0.38p AD=0.68p PS=2.38u
+ PD=4.68u rfmode=0
M$461 \$678 \$24 \$704 vss sg13_hv_nmos L=0.45u W=2u AS=0.68p AD=0.38p PS=4.68u
+ PD=2.38u rfmode=0
M$462 \$704 \$40 \$713 vss sg13_hv_nmos L=0.45u W=2u AS=0.38p AD=0.68p PS=2.38u
+ PD=4.68u rfmode=0
M$463 \$698 \$36 \$705 vss sg13_hv_nmos L=0.45u W=2u AS=0.68p AD=0.38p PS=4.68u
+ PD=2.38u rfmode=0
M$464 \$705 \$20 \$714 vss sg13_hv_nmos L=0.45u W=2u AS=0.38p AD=0.68p PS=2.38u
+ PD=4.68u rfmode=0
M$465 \$680 \$24 \$706 vss sg13_hv_nmos L=0.45u W=2u AS=0.68p AD=0.38p PS=4.68u
+ PD=2.38u rfmode=0
M$466 \$706 \$40 \$716 vss sg13_hv_nmos L=0.45u W=2u AS=0.38p AD=0.68p PS=2.38u
+ PD=4.68u rfmode=0
M$467 \$703 \$38 \$695 vss sg13_hv_nmos L=0.45u W=2u AS=0.68p AD=0.38p PS=4.68u
+ PD=2.38u rfmode=0
M$468 \$695 \$22 \$727 vss sg13_hv_nmos L=0.45u W=2u AS=0.38p AD=0.68p PS=2.38u
+ PD=4.68u rfmode=0
M$469 \$712 \$20 \$722 vss sg13_hv_nmos L=0.45u W=2u AS=0.68p AD=0.38p PS=4.68u
+ PD=2.38u rfmode=0
M$470 \$722 \$36 \$723 vss sg13_hv_nmos L=0.45u W=2u AS=0.38p AD=0.68p PS=2.38u
+ PD=4.68u rfmode=0
M$471 \$705 \$38 \$700 vss sg13_hv_nmos L=0.45u W=2u AS=0.68p AD=0.38p PS=4.68u
+ PD=2.38u rfmode=0
M$472 \$700 \$22 \$728 vss sg13_hv_nmos L=0.45u W=2u AS=0.38p AD=0.68p PS=2.38u
+ PD=4.68u rfmode=0
M$473 \$715 \$20 \$725 vss sg13_hv_nmos L=0.45u W=2u AS=0.68p AD=0.38p PS=4.68u
+ PD=2.38u rfmode=0
M$474 \$725 \$36 \$726 vss sg13_hv_nmos L=0.45u W=2u AS=0.38p AD=0.68p PS=2.38u
+ PD=4.68u rfmode=0
M$475 \$721 \$36 \$727 vss sg13_hv_nmos L=0.45u W=2u AS=0.68p AD=0.38p PS=4.68u
+ PD=2.38u rfmode=0
M$476 \$727 \$20 \$733 vss sg13_hv_nmos L=0.45u W=2u AS=0.38p AD=0.68p PS=2.38u
+ PD=4.68u rfmode=0
M$477 \$722 \$22 \$713 vss sg13_hv_nmos L=0.45u W=2u AS=0.68p AD=0.38p PS=4.68u
+ PD=2.38u rfmode=0
M$478 \$713 \$38 \$744 vss sg13_hv_nmos L=0.45u W=2u AS=0.38p AD=0.68p PS=2.38u
+ PD=4.68u rfmode=0
M$479 \$724 \$36 \$728 vss sg13_hv_nmos L=0.45u W=2u AS=0.68p AD=0.38p PS=4.68u
+ PD=2.38u rfmode=0
M$480 \$728 \$20 \$735 vss sg13_hv_nmos L=0.45u W=2u AS=0.38p AD=0.68p PS=2.38u
+ PD=4.68u rfmode=0
M$481 \$725 \$22 \$716 vss sg13_hv_nmos L=0.45u W=2u AS=0.68p AD=0.38p PS=4.68u
+ PD=2.38u rfmode=0
M$482 \$716 \$38 \$749 vss sg13_hv_nmos L=0.45u W=2u AS=0.38p AD=0.68p PS=2.38u
+ PD=4.68u rfmode=0
M$483 \$694 \$42 \$742 vss sg13_hv_nmos L=0.45u W=2u AS=0.68p AD=0.38p PS=4.68u
+ PD=2.38u rfmode=0
M$484 \$742 \$26 \$743 vss sg13_hv_nmos L=0.45u W=2u AS=0.38p AD=0.68p PS=2.38u
+ PD=4.68u rfmode=0
M$485 \$734 \$20 \$744 vss sg13_hv_nmos L=0.45u W=2u AS=0.68p AD=0.38p PS=4.68u
+ PD=2.38u rfmode=0
M$486 \$744 \$36 \$745 vss sg13_hv_nmos L=0.45u W=2u AS=0.38p AD=0.68p PS=2.38u
+ PD=4.68u rfmode=0
M$487 \$699 \$42 \$747 vss sg13_hv_nmos L=0.45u W=2u AS=0.68p AD=0.38p PS=4.68u
+ PD=2.38u rfmode=0
M$488 \$747 \$26 \$748 vss sg13_hv_nmos L=0.45u W=2u AS=0.38p AD=0.68p PS=2.38u
+ PD=4.68u rfmode=0
M$489 \$736 \$20 \$749 vss sg13_hv_nmos L=0.45u W=2u AS=0.68p AD=0.38p PS=4.68u
+ PD=2.38u rfmode=0
M$490 \$749 \$36 \$750 vss sg13_hv_nmos L=0.45u W=2u AS=0.38p AD=0.68p PS=2.38u
+ PD=4.68u rfmode=0
M$491 \$741 \$36 \$751 vss sg13_hv_nmos L=0.45u W=2u AS=0.68p AD=0.38p PS=4.68u
+ PD=2.38u rfmode=0
M$492 \$751 \$20 \$759 vss sg13_hv_nmos L=0.45u W=2u AS=0.38p AD=0.68p PS=2.38u
+ PD=4.68u rfmode=0
M$493 \$704 \$26 \$752 vss sg13_hv_nmos L=0.45u W=2u AS=0.68p AD=0.38p PS=4.68u
+ PD=2.38u rfmode=0
M$494 \$752 \$42 \$761 vss sg13_hv_nmos L=0.45u W=2u AS=0.38p AD=0.68p PS=2.38u
+ PD=4.68u rfmode=0
M$495 \$746 \$36 \$753 vss sg13_hv_nmos L=0.45u W=2u AS=0.68p AD=0.38p PS=4.68u
+ PD=2.38u rfmode=0
M$496 \$753 \$20 \$762 vss sg13_hv_nmos L=0.45u W=2u AS=0.38p AD=0.68p PS=2.38u
+ PD=4.68u rfmode=0
M$497 \$706 \$26 \$754 vss sg13_hv_nmos L=0.45u W=2u AS=0.68p AD=0.38p PS=4.68u
+ PD=2.38u rfmode=0
M$498 \$754 \$42 \$764 vss sg13_hv_nmos L=0.45u W=2u AS=0.38p AD=0.68p PS=2.38u
+ PD=4.68u rfmode=0
M$499 \$751 \$38 \$770 vss sg13_hv_nmos L=0.45u W=2u AS=0.68p AD=0.38p PS=4.68u
+ PD=2.38u rfmode=0
M$500 \$770 \$22 \$777 vss sg13_hv_nmos L=0.45u W=2u AS=0.38p AD=0.68p PS=2.38u
+ PD=4.68u rfmode=0
M$501 \$760 \$20 \$772 vss sg13_hv_nmos L=0.45u W=2u AS=0.68p AD=0.38p PS=4.68u
+ PD=2.38u rfmode=0
M$502 \$772 \$36 \$771 vss sg13_hv_nmos L=0.45u W=2u AS=0.38p AD=0.68p PS=2.38u
+ PD=4.68u rfmode=0
M$503 \$753 \$38 \$774 vss sg13_hv_nmos L=0.45u W=2u AS=0.68p AD=0.38p PS=4.68u
+ PD=2.38u rfmode=0
M$504 \$774 \$22 \$779 vss sg13_hv_nmos L=0.45u W=2u AS=0.38p AD=0.68p PS=2.38u
+ PD=4.68u rfmode=0
M$505 \$763 \$20 \$776 vss sg13_hv_nmos L=0.45u W=2u AS=0.68p AD=0.38p PS=4.68u
+ PD=2.38u rfmode=0
M$506 \$776 \$36 \$775 vss sg13_hv_nmos L=0.45u W=2u AS=0.38p AD=0.68p PS=2.38u
+ PD=4.68u rfmode=0
M$507 \$769 \$36 \$777 vss sg13_hv_nmos L=0.45u W=2u AS=0.68p AD=0.38p PS=4.68u
+ PD=2.38u rfmode=0
M$508 \$777 \$20 \$785 vss sg13_hv_nmos L=0.45u W=2u AS=0.38p AD=0.68p PS=2.38u
+ PD=4.68u rfmode=0
M$509 \$772 \$22 \$778 vss sg13_hv_nmos L=0.45u W=2u AS=0.68p AD=0.38p PS=4.68u
+ PD=2.38u rfmode=0
M$510 \$778 \$38 \$795 vss sg13_hv_nmos L=0.45u W=2u AS=0.38p AD=0.68p PS=2.38u
+ PD=4.68u rfmode=0
M$511 \$773 \$36 \$779 vss sg13_hv_nmos L=0.45u W=2u AS=0.68p AD=0.38p PS=4.68u
+ PD=2.38u rfmode=0
M$512 \$779 \$20 \$787 vss sg13_hv_nmos L=0.45u W=2u AS=0.38p AD=0.68p PS=2.38u
+ PD=4.68u rfmode=0
M$513 \$776 \$22 \$780 vss sg13_hv_nmos L=0.45u W=2u AS=0.68p AD=0.38p PS=4.68u
+ PD=2.38u rfmode=0
M$514 \$780 \$38 \$799 vss sg13_hv_nmos L=0.45u W=2u AS=0.38p AD=0.68p PS=2.38u
+ PD=4.68u rfmode=0
M$515 \$770 \$40 \$743 vss sg13_hv_nmos L=0.45u W=2u AS=0.68p AD=0.38p PS=4.68u
+ PD=2.38u rfmode=0
M$516 \$743 \$24 \$794 vss sg13_hv_nmos L=0.45u W=2u AS=0.38p AD=0.68p PS=2.38u
+ PD=4.68u rfmode=0
M$517 \$786 \$20 \$795 vss sg13_hv_nmos L=0.45u W=2u AS=0.68p AD=0.38p PS=4.68u
+ PD=2.38u rfmode=0
M$518 \$795 \$36 \$796 vss sg13_hv_nmos L=0.45u W=2u AS=0.38p AD=0.68p PS=2.38u
+ PD=4.68u rfmode=0
M$519 \$774 \$40 \$748 vss sg13_hv_nmos L=0.45u W=2u AS=0.68p AD=0.38p PS=4.68u
+ PD=2.38u rfmode=0
M$520 \$748 \$24 \$798 vss sg13_hv_nmos L=0.45u W=2u AS=0.38p AD=0.68p PS=2.38u
+ PD=4.68u rfmode=0
M$521 \$788 \$20 \$799 vss sg13_hv_nmos L=0.45u W=2u AS=0.68p AD=0.38p PS=4.68u
+ PD=2.38u rfmode=0
M$522 \$799 \$36 \$800 vss sg13_hv_nmos L=0.45u W=2u AS=0.38p AD=0.68p PS=2.38u
+ PD=4.68u rfmode=0
M$523 \$793 \$36 \$801 vss sg13_hv_nmos L=0.45u W=2u AS=0.68p AD=0.38p PS=4.68u
+ PD=2.38u rfmode=0
M$524 \$801 \$20 \$807 vss sg13_hv_nmos L=0.45u W=2u AS=0.38p AD=0.68p PS=2.38u
+ PD=4.68u rfmode=0
M$525 \$778 \$24 \$761 vss sg13_hv_nmos L=0.45u W=2u AS=0.68p AD=0.38p PS=4.68u
+ PD=2.38u rfmode=0
M$526 \$761 \$40 \$809 vss sg13_hv_nmos L=0.45u W=2u AS=0.38p AD=0.68p PS=2.38u
+ PD=4.68u rfmode=0
M$527 \$797 \$36 \$802 vss sg13_hv_nmos L=0.45u W=2u AS=0.68p AD=0.38p PS=4.68u
+ PD=2.38u rfmode=0
M$528 \$802 \$20 \$810 vss sg13_hv_nmos L=0.45u W=2u AS=0.38p AD=0.68p PS=2.38u
+ PD=4.68u rfmode=0
M$529 \$780 \$24 \$764 vss sg13_hv_nmos L=0.45u W=2u AS=0.68p AD=0.38p PS=4.68u
+ PD=2.38u rfmode=0
M$530 \$764 \$40 \$812 vss sg13_hv_nmos L=0.45u W=2u AS=0.38p AD=0.68p PS=2.38u
+ PD=4.68u rfmode=0
M$531 \$801 \$38 \$794 vss sg13_hv_nmos L=0.45u W=2u AS=0.68p AD=0.38p PS=4.68u
+ PD=2.38u rfmode=0
M$532 \$794 \$22 \$823 vss sg13_hv_nmos L=0.45u W=2u AS=0.38p AD=0.68p PS=2.38u
+ PD=4.68u rfmode=0
M$533 \$808 \$20 \$819 vss sg13_hv_nmos L=0.45u W=2u AS=0.68p AD=0.38p PS=4.68u
+ PD=2.38u rfmode=0
M$534 \$819 \$36 \$818 vss sg13_hv_nmos L=0.45u W=2u AS=0.38p AD=0.68p PS=2.38u
+ PD=4.68u rfmode=0
M$535 \$802 \$38 \$798 vss sg13_hv_nmos L=0.45u W=2u AS=0.68p AD=0.38p PS=4.68u
+ PD=2.38u rfmode=0
M$536 \$798 \$22 \$824 vss sg13_hv_nmos L=0.45u W=2u AS=0.38p AD=0.68p PS=2.38u
+ PD=4.68u rfmode=0
M$537 \$811 \$20 \$821 vss sg13_hv_nmos L=0.45u W=2u AS=0.68p AD=0.38p PS=4.68u
+ PD=2.38u rfmode=0
M$538 \$821 \$36 \$822 vss sg13_hv_nmos L=0.45u W=2u AS=0.38p AD=0.68p PS=2.38u
+ PD=4.68u rfmode=0
M$539 \$817 \$36 \$823 vss sg13_hv_nmos L=0.45u W=2u AS=0.68p AD=0.38p PS=4.68u
+ PD=2.38u rfmode=0
M$540 \$823 \$20 \$829 vss sg13_hv_nmos L=0.45u W=2u AS=0.38p AD=0.68p PS=2.38u
+ PD=4.68u rfmode=0
M$541 \$819 \$22 \$809 vss sg13_hv_nmos L=0.45u W=2u AS=0.68p AD=0.38p PS=4.68u
+ PD=2.38u rfmode=0
M$542 \$809 \$38 \$836 vss sg13_hv_nmos L=0.45u W=2u AS=0.38p AD=0.68p PS=2.38u
+ PD=4.68u rfmode=0
M$543 \$820 \$36 \$824 vss sg13_hv_nmos L=0.45u W=2u AS=0.68p AD=0.38p PS=4.68u
+ PD=2.38u rfmode=0
M$544 \$824 \$20 \$831 vss sg13_hv_nmos L=0.45u W=2u AS=0.38p AD=0.68p PS=2.38u
+ PD=4.68u rfmode=0
M$545 \$821 \$22 \$812 vss sg13_hv_nmos L=0.45u W=2u AS=0.68p AD=0.38p PS=4.68u
+ PD=2.38u rfmode=0
M$546 \$812 \$38 \$838 vss sg13_hv_nmos L=0.45u W=2u AS=0.38p AD=0.68p PS=2.38u
+ PD=4.68u rfmode=0
M$547 \$830 \$20 \$836 vss sg13_hv_nmos L=0.45u W=2u AS=0.68p AD=0.38p PS=4.68u
+ PD=2.38u rfmode=0
M$548 \$836 \$36 \$835 vss sg13_hv_nmos L=0.45u W=2u AS=0.38p AD=0.68p PS=2.38u
+ PD=4.68u rfmode=0
M$549 \$832 \$20 \$838 vss sg13_hv_nmos L=0.45u W=2u AS=0.68p AD=0.38p PS=4.68u
+ PD=2.38u rfmode=0
M$550 \$838 \$36 \$837 vss sg13_hv_nmos L=0.45u W=2u AS=0.38p AD=0.68p PS=2.38u
+ PD=4.68u rfmode=0
M$551 \$14 d3 vdd vdd sg13_lv_pmos L=0.13u W=1u AS=0.34p AD=0.34p PS=2.68u
+ PD=2.68u rfmode=0
M$552 \$17 d6 vdd vdd sg13_lv_pmos L=0.13u W=1u AS=0.34p AD=0.34p PS=2.68u
+ PD=2.68u rfmode=0
M$553 \$15 d4 vdd vdd sg13_lv_pmos L=0.13u W=1u AS=0.34p AD=0.34p PS=2.68u
+ PD=2.68u rfmode=0
M$554 \$12 d1 vdd vdd sg13_lv_pmos L=0.13u W=1u AS=0.34p AD=0.34p PS=2.68u
+ PD=2.68u rfmode=0
M$555 \$18 d7 vdd vdd sg13_lv_pmos L=0.13u W=1u AS=0.34p AD=0.34p PS=2.68u
+ PD=2.68u rfmode=0
M$556 \$13 d2 vdd vdd sg13_lv_pmos L=0.13u W=1u AS=0.34p AD=0.34p PS=2.68u
+ PD=2.68u rfmode=0
M$557 \$16 d5 vdd vdd sg13_lv_pmos L=0.13u W=1u AS=0.34p AD=0.34p PS=2.68u
+ PD=2.68u rfmode=0
M$558 \$11 d0 vdd vdd sg13_lv_pmos L=0.13u W=1u AS=0.34p AD=0.34p PS=2.68u
+ PD=2.68u rfmode=0
M$559 vdda \$35 \$19 vdda sg13_hv_pmos L=0.45u W=0.3u AS=0.102p AD=0.102p
+ PS=1.28u PD=1.28u rfmode=0
M$560 vdda \$19 \$35 vdda sg13_hv_pmos L=0.45u W=0.3u AS=0.102p AD=0.102p
+ PS=1.28u PD=1.28u rfmode=0
M$561 vdda \$19 \$20 vdda sg13_hv_pmos L=0.45u W=3.9u AS=1.326p AD=1.326p
+ PS=8.48u PD=8.48u rfmode=0
M$562 vdda \$20 \$36 vdda sg13_hv_pmos L=0.45u W=3.9u AS=1.326p AD=1.326p
+ PS=8.48u PD=8.48u rfmode=0
M$563 vdda \$37 \$21 vdda sg13_hv_pmos L=0.45u W=0.3u AS=0.102p AD=0.102p
+ PS=1.28u PD=1.28u rfmode=0
M$564 vdda \$21 \$37 vdda sg13_hv_pmos L=0.45u W=0.3u AS=0.102p AD=0.102p
+ PS=1.28u PD=1.28u rfmode=0
M$565 vdda \$21 \$22 vdda sg13_hv_pmos L=0.45u W=3.9u AS=1.326p AD=1.326p
+ PS=8.48u PD=8.48u rfmode=0
M$566 vdda \$22 \$38 vdda sg13_hv_pmos L=0.45u W=3.9u AS=1.326p AD=1.326p
+ PS=8.48u PD=8.48u rfmode=0
M$567 vdda \$39 \$23 vdda sg13_hv_pmos L=0.45u W=0.3u AS=0.102p AD=0.102p
+ PS=1.28u PD=1.28u rfmode=0
M$568 vdda \$23 \$39 vdda sg13_hv_pmos L=0.45u W=0.3u AS=0.102p AD=0.102p
+ PS=1.28u PD=1.28u rfmode=0
M$569 vdda \$23 \$24 vdda sg13_hv_pmos L=0.45u W=3.9u AS=1.326p AD=1.326p
+ PS=8.48u PD=8.48u rfmode=0
M$570 vdda \$24 \$40 vdda sg13_hv_pmos L=0.45u W=3.9u AS=1.326p AD=1.326p
+ PS=8.48u PD=8.48u rfmode=0
M$571 vdda \$41 \$25 vdda sg13_hv_pmos L=0.45u W=0.3u AS=0.102p AD=0.102p
+ PS=1.28u PD=1.28u rfmode=0
M$572 vdda \$25 \$41 vdda sg13_hv_pmos L=0.45u W=0.3u AS=0.102p AD=0.102p
+ PS=1.28u PD=1.28u rfmode=0
M$573 vdda \$25 \$26 vdda sg13_hv_pmos L=0.45u W=3.9u AS=1.326p AD=1.326p
+ PS=8.48u PD=8.48u rfmode=0
M$574 vdda \$26 \$42 vdda sg13_hv_pmos L=0.45u W=3.9u AS=1.326p AD=1.326p
+ PS=8.48u PD=8.48u rfmode=0
M$575 vdda \$43 \$27 vdda sg13_hv_pmos L=0.45u W=0.3u AS=0.102p AD=0.102p
+ PS=1.28u PD=1.28u rfmode=0
M$576 vdda \$27 \$43 vdda sg13_hv_pmos L=0.45u W=0.3u AS=0.102p AD=0.102p
+ PS=1.28u PD=1.28u rfmode=0
M$577 vdda \$27 \$28 vdda sg13_hv_pmos L=0.45u W=3.9u AS=1.326p AD=1.326p
+ PS=8.48u PD=8.48u rfmode=0
M$578 vdda \$28 \$44 vdda sg13_hv_pmos L=0.45u W=3.9u AS=1.326p AD=1.326p
+ PS=8.48u PD=8.48u rfmode=0
M$579 vdda \$45 \$29 vdda sg13_hv_pmos L=0.45u W=0.3u AS=0.102p AD=0.102p
+ PS=1.28u PD=1.28u rfmode=0
M$580 vdda \$29 \$45 vdda sg13_hv_pmos L=0.45u W=0.3u AS=0.102p AD=0.102p
+ PS=1.28u PD=1.28u rfmode=0
M$581 vdda \$29 \$30 vdda sg13_hv_pmos L=0.45u W=3.9u AS=1.326p AD=1.326p
+ PS=8.48u PD=8.48u rfmode=0
M$582 vdda \$30 \$46 vdda sg13_hv_pmos L=0.45u W=3.9u AS=1.326p AD=1.326p
+ PS=8.48u PD=8.48u rfmode=0
M$583 vdda \$47 \$31 vdda sg13_hv_pmos L=0.45u W=0.3u AS=0.102p AD=0.102p
+ PS=1.28u PD=1.28u rfmode=0
M$584 vdda \$31 \$47 vdda sg13_hv_pmos L=0.45u W=0.3u AS=0.102p AD=0.102p
+ PS=1.28u PD=1.28u rfmode=0
M$585 vdda \$31 \$32 vdda sg13_hv_pmos L=0.45u W=3.9u AS=1.326p AD=1.326p
+ PS=8.48u PD=8.48u rfmode=0
M$586 vdda \$32 \$48 vdda sg13_hv_pmos L=0.45u W=3.9u AS=1.326p AD=1.326p
+ PS=8.48u PD=8.48u rfmode=0
M$587 vdda \$49 \$33 vdda sg13_hv_pmos L=0.45u W=0.3u AS=0.102p AD=0.102p
+ PS=1.28u PD=1.28u rfmode=0
M$588 vdda \$33 \$49 vdda sg13_hv_pmos L=0.45u W=0.3u AS=0.102p AD=0.102p
+ PS=1.28u PD=1.28u rfmode=0
M$589 vdda \$33 \$34 vdda sg13_hv_pmos L=0.45u W=3.9u AS=1.326p AD=1.326p
+ PS=8.48u PD=8.48u rfmode=0
M$590 vdda \$34 \$50 vdda sg13_hv_pmos L=0.45u W=3.9u AS=1.326p AD=1.326p
+ PS=8.48u PD=8.48u rfmode=0
R$594 \$54 \$63 vss rppd w=4u l=1.2u ps=0u b=0 m=1
R$595 \$55 \$64 vss rppd w=4u l=1.2u ps=0u b=0 m=1
R$596 \$55 \$65 vss rppd w=4u l=1.2u ps=0u b=0 m=1
R$603 \$63 \$76 vss rppd w=4u l=1.2u ps=0u b=0 m=1
R$604 \$64 \$77 vss rppd w=4u l=1.2u ps=0u b=0 m=1
R$605 \$65 \$78 vss rppd w=4u l=1.2u ps=0u b=0 m=1
R$606 \$66 \$79 vss rppd w=4u l=1.2u ps=0u b=0 m=1
R$612 \$76 \$86 vss rppd w=4u l=1.2u ps=0u b=0 m=1
R$613 \$77 \$87 vss rppd w=4u l=1.2u ps=0u b=0 m=1
R$614 \$78 \$90 vss rppd w=4u l=1.2u ps=0u b=0 m=1
R$615 \$79 \$91 vss rppd w=4u l=1.2u ps=0u b=0 m=1
R$621 \$86 \$102 vss rppd w=4u l=1.2u ps=0u b=0 m=1
R$622 \$87 \$104 vss rppd w=4u l=1.2u ps=0u b=0 m=1
R$623 \$90 \$105 vss rppd w=4u l=1.2u ps=0u b=0 m=1
R$624 \$91 \$107 vss rppd w=4u l=1.2u ps=0u b=0 m=1
R$630 \$102 \$114 vss rppd w=4u l=1.2u ps=0u b=0 m=1
R$631 \$104 \$115 vss rppd w=4u l=1.2u ps=0u b=0 m=1
R$632 \$105 \$119 vss rppd w=4u l=1.2u ps=0u b=0 m=1
R$633 \$107 \$120 vss rppd w=4u l=1.2u ps=0u b=0 m=1
R$639 \$114 \$130 vss rppd w=4u l=1.2u ps=0u b=0 m=1
R$640 \$115 \$131 vss rppd w=4u l=1.2u ps=0u b=0 m=1
R$641 \$119 \$132 vss rppd w=4u l=1.2u ps=0u b=0 m=1
R$642 \$120 \$133 vss rppd w=4u l=1.2u ps=0u b=0 m=1
R$648 \$130 \$139 vss rppd w=4u l=1.2u ps=0u b=0 m=1
R$649 \$131 \$141 vss rppd w=4u l=1.2u ps=0u b=0 m=1
R$650 \$132 \$143 vss rppd w=4u l=1.2u ps=0u b=0 m=1
R$651 \$133 \$144 vss rppd w=4u l=1.2u ps=0u b=0 m=1
R$657 \$139 \$154 vss rppd w=4u l=1.2u ps=0u b=0 m=1
R$658 \$141 \$156 vss rppd w=4u l=1.2u ps=0u b=0 m=1
R$659 \$143 \$157 vss rppd w=4u l=1.2u ps=0u b=0 m=1
R$660 \$144 \$159 vss rppd w=4u l=1.2u ps=0u b=0 m=1
R$666 \$154 \$166 vss rppd w=4u l=1.2u ps=0u b=0 m=1
R$667 \$156 \$167 vss rppd w=4u l=1.2u ps=0u b=0 m=1
R$668 \$157 \$171 vss rppd w=4u l=1.2u ps=0u b=0 m=1
R$669 \$159 \$172 vss rppd w=4u l=1.2u ps=0u b=0 m=1
R$675 \$166 \$184 vss rppd w=4u l=1.2u ps=0u b=0 m=1
R$676 \$167 \$185 vss rppd w=4u l=1.2u ps=0u b=0 m=1
R$677 \$171 \$186 vss rppd w=4u l=1.2u ps=0u b=0 m=1
R$678 \$172 \$187 vss rppd w=4u l=1.2u ps=0u b=0 m=1
R$684 \$184 \$194 vss rppd w=4u l=1.2u ps=0u b=0 m=1
R$685 \$185 \$195 vss rppd w=4u l=1.2u ps=0u b=0 m=1
R$686 \$186 \$198 vss rppd w=4u l=1.2u ps=0u b=0 m=1
R$687 \$187 \$199 vss rppd w=4u l=1.2u ps=0u b=0 m=1
R$693 \$194 \$208 vss rppd w=4u l=1.2u ps=0u b=0 m=1
R$694 \$195 \$210 vss rppd w=4u l=1.2u ps=0u b=0 m=1
R$695 \$198 \$211 vss rppd w=4u l=1.2u ps=0u b=0 m=1
R$696 \$199 \$213 vss rppd w=4u l=1.2u ps=0u b=0 m=1
R$702 \$208 \$220 vss rppd w=4u l=1.2u ps=0u b=0 m=1
R$703 \$210 \$221 vss rppd w=4u l=1.2u ps=0u b=0 m=1
R$704 \$211 \$223 vss rppd w=4u l=1.2u ps=0u b=0 m=1
R$705 \$213 \$225 vss rppd w=4u l=1.2u ps=0u b=0 m=1
R$711 \$220 \$234 vss rppd w=4u l=1.2u ps=0u b=0 m=1
R$712 \$221 \$235 vss rppd w=4u l=1.2u ps=0u b=0 m=1
R$713 \$223 \$236 vss rppd w=4u l=1.2u ps=0u b=0 m=1
R$714 \$225 \$237 vss rppd w=4u l=1.2u ps=0u b=0 m=1
R$720 \$234 \$244 vss rppd w=4u l=1.2u ps=0u b=0 m=1
R$721 \$235 \$245 vss rppd w=4u l=1.2u ps=0u b=0 m=1
R$722 \$236 \$247 vss rppd w=4u l=1.2u ps=0u b=0 m=1
R$723 \$237 \$248 vss rppd w=4u l=1.2u ps=0u b=0 m=1
R$729 \$244 \$258 vss rppd w=4u l=1.2u ps=0u b=0 m=1
R$730 \$245 \$259 vss rppd w=4u l=1.2u ps=0u b=0 m=1
R$731 \$247 \$260 vss rppd w=4u l=1.2u ps=0u b=0 m=1
R$732 \$248 \$261 vss rppd w=4u l=1.2u ps=0u b=0 m=1
R$738 \$258 \$268 vss rppd w=4u l=1.2u ps=0u b=0 m=1
R$739 \$259 \$269 vss rppd w=4u l=1.2u ps=0u b=0 m=1
R$740 \$260 \$272 vss rppd w=4u l=1.2u ps=0u b=0 m=1
R$741 \$261 \$273 vss rppd w=4u l=1.2u ps=0u b=0 m=1
R$747 \$268 \$284 vss rppd w=4u l=1.2u ps=0u b=0 m=1
R$748 \$269 \$285 vss rppd w=4u l=1.2u ps=0u b=0 m=1
R$749 \$272 \$286 vss rppd w=4u l=1.2u ps=0u b=0 m=1
R$750 \$273 \$287 vss rppd w=4u l=1.2u ps=0u b=0 m=1
R$751 \$66 vref vss rppd w=4u l=24u ps=0u b=0 m=1
R$756 \$284 \$294 vss rppd w=4u l=1.2u ps=0u b=0 m=1
R$757 \$285 \$295 vss rppd w=4u l=1.2u ps=0u b=0 m=1
R$758 \$286 \$298 vss rppd w=4u l=1.2u ps=0u b=0 m=1
R$759 \$287 \$299 vss rppd w=4u l=1.2u ps=0u b=0 m=1
R$765 \$294 \$310 vss rppd w=4u l=1.2u ps=0u b=0 m=1
R$766 \$295 \$312 vss rppd w=4u l=1.2u ps=0u b=0 m=1
R$767 \$298 \$313 vss rppd w=4u l=1.2u ps=0u b=0 m=1
R$768 \$299 \$315 vss rppd w=4u l=1.2u ps=0u b=0 m=1
R$773 \$310 \$321 vss rppd w=4u l=1.2u ps=0u b=0 m=1
R$774 \$312 \$322 vss rppd w=4u l=1.2u ps=0u b=0 m=1
R$775 \$313 \$326 vss rppd w=4u l=1.2u ps=0u b=0 m=1
R$776 \$315 \$327 vss rppd w=4u l=1.2u ps=0u b=0 m=1
R$781 \$321 \$336 vss rppd w=4u l=1.2u ps=0u b=0 m=1
R$782 \$322 \$337 vss rppd w=4u l=1.2u ps=0u b=0 m=1
R$783 \$326 \$338 vss rppd w=4u l=1.2u ps=0u b=0 m=1
R$784 \$327 \$339 vss rppd w=4u l=1.2u ps=0u b=0 m=1
R$789 \$336 \$345 vss rppd w=4u l=1.2u ps=0u b=0 m=1
R$790 \$337 \$346 vss rppd w=4u l=1.2u ps=0u b=0 m=1
R$791 \$338 \$348 vss rppd w=4u l=1.2u ps=0u b=0 m=1
R$792 \$339 \$349 vss rppd w=4u l=1.2u ps=0u b=0 m=1
R$797 \$345 \$358 vss rppd w=4u l=1.2u ps=0u b=0 m=1
R$798 \$346 \$360 vss rppd w=4u l=1.2u ps=0u b=0 m=1
R$799 \$348 \$361 vss rppd w=4u l=1.2u ps=0u b=0 m=1
R$800 \$349 \$363 vss rppd w=4u l=1.2u ps=0u b=0 m=1
R$805 \$358 \$368 vss rppd w=4u l=1.2u ps=0u b=0 m=1
R$806 \$360 \$369 vss rppd w=4u l=1.2u ps=0u b=0 m=1
R$807 \$361 \$373 vss rppd w=4u l=1.2u ps=0u b=0 m=1
R$808 \$363 \$374 vss rppd w=4u l=1.2u ps=0u b=0 m=1
R$813 \$368 \$386 vss rppd w=4u l=1.2u ps=0u b=0 m=1
R$814 \$369 \$387 vss rppd w=4u l=1.2u ps=0u b=0 m=1
R$815 \$373 \$388 vss rppd w=4u l=1.2u ps=0u b=0 m=1
R$816 \$374 \$389 vss rppd w=4u l=1.2u ps=0u b=0 m=1
R$821 \$386 \$394 vss rppd w=4u l=1.2u ps=0u b=0 m=1
R$822 \$387 \$396 vss rppd w=4u l=1.2u ps=0u b=0 m=1
R$823 \$388 \$399 vss rppd w=4u l=1.2u ps=0u b=0 m=1
R$824 \$389 \$400 vss rppd w=4u l=1.2u ps=0u b=0 m=1
R$829 \$394 \$408 vss rppd w=4u l=1.2u ps=0u b=0 m=1
R$830 \$396 \$410 vss rppd w=4u l=1.2u ps=0u b=0 m=1
R$831 \$399 \$411 vss rppd w=4u l=1.2u ps=0u b=0 m=1
R$832 \$400 \$413 vss rppd w=4u l=1.2u ps=0u b=0 m=1
R$837 \$408 \$419 vss rppd w=4u l=1.2u ps=0u b=0 m=1
R$838 \$410 \$420 vss rppd w=4u l=1.2u ps=0u b=0 m=1
R$839 \$411 \$423 vss rppd w=4u l=1.2u ps=0u b=0 m=1
R$840 \$413 \$424 vss rppd w=4u l=1.2u ps=0u b=0 m=1
R$845 \$419 \$432 vss rppd w=4u l=1.2u ps=0u b=0 m=1
R$846 \$420 \$433 vss rppd w=4u l=1.2u ps=0u b=0 m=1
R$847 \$423 \$434 vss rppd w=4u l=1.2u ps=0u b=0 m=1
R$848 \$424 \$435 vss rppd w=4u l=1.2u ps=0u b=0 m=1
R$853 \$432 \$441 vss rppd w=4u l=1.2u ps=0u b=0 m=1
R$854 \$433 \$442 vss rppd w=4u l=1.2u ps=0u b=0 m=1
R$855 \$434 \$444 vss rppd w=4u l=1.2u ps=0u b=0 m=1
R$856 \$435 \$445 vss rppd w=4u l=1.2u ps=0u b=0 m=1
R$861 \$441 \$454 vss rppd w=4u l=1.2u ps=0u b=0 m=1
R$862 \$442 \$455 vss rppd w=4u l=1.2u ps=0u b=0 m=1
R$863 \$444 \$456 vss rppd w=4u l=1.2u ps=0u b=0 m=1
R$864 \$445 \$457 vss rppd w=4u l=1.2u ps=0u b=0 m=1
R$869 \$454 \$463 vss rppd w=4u l=1.2u ps=0u b=0 m=1
R$870 \$455 \$464 vss rppd w=4u l=1.2u ps=0u b=0 m=1
R$871 \$456 \$467 vss rppd w=4u l=1.2u ps=0u b=0 m=1
R$872 \$457 \$468 vss rppd w=4u l=1.2u ps=0u b=0 m=1
R$877 \$463 \$478 vss rppd w=4u l=1.2u ps=0u b=0 m=1
R$878 \$464 \$479 vss rppd w=4u l=1.2u ps=0u b=0 m=1
R$879 \$467 \$480 vss rppd w=4u l=1.2u ps=0u b=0 m=1
R$880 \$468 \$481 vss rppd w=4u l=1.2u ps=0u b=0 m=1
R$885 \$478 \$487 vss rppd w=4u l=1.2u ps=0u b=0 m=1
R$886 \$479 \$488 vss rppd w=4u l=1.2u ps=0u b=0 m=1
R$887 \$480 \$491 vss rppd w=4u l=1.2u ps=0u b=0 m=1
R$888 \$481 \$492 vss rppd w=4u l=1.2u ps=0u b=0 m=1
R$893 \$487 \$503 vss rppd w=4u l=1.2u ps=0u b=0 m=1
R$894 \$488 \$505 vss rppd w=4u l=1.2u ps=0u b=0 m=1
R$895 \$491 \$506 vss rppd w=4u l=1.2u ps=0u b=0 m=1
R$896 \$492 \$508 vss rppd w=4u l=1.2u ps=0u b=0 m=1
R$901 \$503 \$514 vss rppd w=4u l=1.2u ps=0u b=0 m=1
R$902 \$505 \$523 vss rppd w=4u l=1.2u ps=0u b=0 m=1
R$903 \$506 \$518 vss rppd w=4u l=1.2u ps=0u b=0 m=1
R$904 \$508 \$519 vss rppd w=4u l=1.2u ps=0u b=0 m=1
R$909 \$514 \$530 vss rppd w=4u l=1.2u ps=0u b=0 m=1
R$910 \$523 \$531 vss rppd w=4u l=1.2u ps=0u b=0 m=1
R$911 \$518 \$532 vss rppd w=4u l=1.2u ps=0u b=0 m=1
R$912 \$519 \$533 vss rppd w=4u l=1.2u ps=0u b=0 m=1
R$917 \$530 \$541 vss rppd w=4u l=1.2u ps=0u b=0 m=1
R$918 \$531 \$542 vss rppd w=4u l=1.2u ps=0u b=0 m=1
R$919 \$532 \$543 vss rppd w=4u l=1.2u ps=0u b=0 m=1
R$920 \$533 \$544 vss rppd w=4u l=1.2u ps=0u b=0 m=1
R$925 \$541 \$553 vss rppd w=4u l=1.2u ps=0u b=0 m=1
R$926 \$542 \$555 vss rppd w=4u l=1.2u ps=0u b=0 m=1
R$927 \$543 \$556 vss rppd w=4u l=1.2u ps=0u b=0 m=1
R$928 \$544 \$558 vss rppd w=4u l=1.2u ps=0u b=0 m=1
R$933 \$553 \$567 vss rppd w=4u l=1.2u ps=0u b=0 m=1
R$934 \$555 \$568 vss rppd w=4u l=1.2u ps=0u b=0 m=1
R$935 \$556 \$570 vss rppd w=4u l=1.2u ps=0u b=0 m=1
R$936 \$558 \$571 vss rppd w=4u l=1.2u ps=0u b=0 m=1
R$941 \$567 \$577 vss rppd w=4u l=1.2u ps=0u b=0 m=1
R$942 \$568 \$579 vss rppd w=4u l=1.2u ps=0u b=0 m=1
R$943 \$570 \$581 vss rppd w=4u l=1.2u ps=0u b=0 m=1
R$944 \$571 \$584 vss rppd w=4u l=1.2u ps=0u b=0 m=1
R$949 \$577 \$593 vss rppd w=4u l=1.2u ps=0u b=0 m=1
R$950 \$579 \$594 vss rppd w=4u l=1.2u ps=0u b=0 m=1
R$951 \$581 \$595 vss rppd w=4u l=1.2u ps=0u b=0 m=1
R$952 \$584 \$596 vss rppd w=4u l=1.2u ps=0u b=0 m=1
R$957 \$593 \$601 vss rppd w=4u l=1.2u ps=0u b=0 m=1
R$958 \$594 \$604 vss rppd w=4u l=1.2u ps=0u b=0 m=1
R$959 \$595 \$605 vss rppd w=4u l=1.2u ps=0u b=0 m=1
R$960 \$596 \$608 vss rppd w=4u l=1.2u ps=0u b=0 m=1
R$965 \$601 \$615 vss rppd w=4u l=1.2u ps=0u b=0 m=1
R$966 \$604 \$616 vss rppd w=4u l=1.2u ps=0u b=0 m=1
R$967 \$605 \$618 vss rppd w=4u l=1.2u ps=0u b=0 m=1
R$968 \$608 \$619 vss rppd w=4u l=1.2u ps=0u b=0 m=1
R$973 \$615 \$625 vss rppd w=4u l=1.2u ps=0u b=0 m=1
R$974 \$616 \$627 vss rppd w=4u l=1.2u ps=0u b=0 m=1
R$975 \$618 \$628 vss rppd w=4u l=1.2u ps=0u b=0 m=1
R$976 \$619 \$629 vss rppd w=4u l=1.2u ps=0u b=0 m=1
R$981 \$625 \$637 vss rppd w=4u l=1.2u ps=0u b=0 m=1
R$982 \$627 \$638 vss rppd w=4u l=1.2u ps=0u b=0 m=1
R$983 \$628 \$639 vss rppd w=4u l=1.2u ps=0u b=0 m=1
R$984 \$629 \$640 vss rppd w=4u l=1.2u ps=0u b=0 m=1
R$989 \$637 \$645 vss rppd w=4u l=1.2u ps=0u b=0 m=1
R$990 \$638 \$648 vss rppd w=4u l=1.2u ps=0u b=0 m=1
R$991 \$639 \$649 vss rppd w=4u l=1.2u ps=0u b=0 m=1
R$992 \$640 \$651 vss rppd w=4u l=1.2u ps=0u b=0 m=1
R$997 \$645 \$661 vss rppd w=4u l=1.2u ps=0u b=0 m=1
R$998 \$648 \$662 vss rppd w=4u l=1.2u ps=0u b=0 m=1
R$999 \$649 \$663 vss rppd w=4u l=1.2u ps=0u b=0 m=1
R$1000 \$651 \$664 vss rppd w=4u l=1.2u ps=0u b=0 m=1
R$1005 \$661 \$669 vss rppd w=4u l=1.2u ps=0u b=0 m=1
R$1006 \$662 \$672 vss rppd w=4u l=1.2u ps=0u b=0 m=1
R$1007 \$663 \$673 vss rppd w=4u l=1.2u ps=0u b=0 m=1
R$1008 \$664 \$676 vss rppd w=4u l=1.2u ps=0u b=0 m=1
R$1013 \$669 \$685 vss rppd w=4u l=1.2u ps=0u b=0 m=1
R$1014 \$672 \$686 vss rppd w=4u l=1.2u ps=0u b=0 m=1
R$1015 \$673 \$687 vss rppd w=4u l=1.2u ps=0u b=0 m=1
R$1016 \$676 \$688 vss rppd w=4u l=1.2u ps=0u b=0 m=1
R$1021 \$685 \$693 vss rppd w=4u l=1.2u ps=0u b=0 m=1
R$1022 \$686 \$697 vss rppd w=4u l=1.2u ps=0u b=0 m=1
R$1023 \$687 \$698 vss rppd w=4u l=1.2u ps=0u b=0 m=1
R$1024 \$688 \$702 vss rppd w=4u l=1.2u ps=0u b=0 m=1
R$1029 \$693 \$711 vss rppd w=4u l=1.2u ps=0u b=0 m=1
R$1030 \$697 \$712 vss rppd w=4u l=1.2u ps=0u b=0 m=1
R$1031 \$698 \$714 vss rppd w=4u l=1.2u ps=0u b=0 m=1
R$1032 \$702 \$715 vss rppd w=4u l=1.2u ps=0u b=0 m=1
R$1037 \$711 \$721 vss rppd w=4u l=1.2u ps=0u b=0 m=1
R$1038 \$712 \$723 vss rppd w=4u l=1.2u ps=0u b=0 m=1
R$1039 \$714 \$724 vss rppd w=4u l=1.2u ps=0u b=0 m=1
R$1040 \$715 \$726 vss rppd w=4u l=1.2u ps=0u b=0 m=1
R$1045 \$721 \$733 vss rppd w=4u l=1.2u ps=0u b=0 m=1
R$1046 \$723 \$734 vss rppd w=4u l=1.2u ps=0u b=0 m=1
R$1047 \$724 \$735 vss rppd w=4u l=1.2u ps=0u b=0 m=1
R$1048 \$726 \$736 vss rppd w=4u l=1.2u ps=0u b=0 m=1
R$1053 \$733 \$741 vss rppd w=4u l=1.2u ps=0u b=0 m=1
R$1054 \$734 \$745 vss rppd w=4u l=1.2u ps=0u b=0 m=1
R$1055 \$735 \$746 vss rppd w=4u l=1.2u ps=0u b=0 m=1
R$1056 \$736 \$750 vss rppd w=4u l=1.2u ps=0u b=0 m=1
R$1061 \$741 \$759 vss rppd w=4u l=1.2u ps=0u b=0 m=1
R$1062 \$745 \$760 vss rppd w=4u l=1.2u ps=0u b=0 m=1
R$1063 \$746 \$762 vss rppd w=4u l=1.2u ps=0u b=0 m=1
R$1064 \$750 \$763 vss rppd w=4u l=1.2u ps=0u b=0 m=1
R$1069 \$759 \$769 vss rppd w=4u l=1.2u ps=0u b=0 m=1
R$1070 \$760 \$771 vss rppd w=4u l=1.2u ps=0u b=0 m=1
R$1071 \$762 \$773 vss rppd w=4u l=1.2u ps=0u b=0 m=1
R$1072 \$763 \$775 vss rppd w=4u l=1.2u ps=0u b=0 m=1
R$1077 \$769 \$785 vss rppd w=4u l=1.2u ps=0u b=0 m=1
R$1078 \$771 \$786 vss rppd w=4u l=1.2u ps=0u b=0 m=1
R$1079 \$773 \$787 vss rppd w=4u l=1.2u ps=0u b=0 m=1
R$1080 \$775 \$788 vss rppd w=4u l=1.2u ps=0u b=0 m=1
R$1085 \$785 \$793 vss rppd w=4u l=1.2u ps=0u b=0 m=1
R$1086 \$786 \$796 vss rppd w=4u l=1.2u ps=0u b=0 m=1
R$1087 \$787 \$797 vss rppd w=4u l=1.2u ps=0u b=0 m=1
R$1088 \$788 \$800 vss rppd w=4u l=1.2u ps=0u b=0 m=1
R$1093 \$793 \$807 vss rppd w=4u l=1.2u ps=0u b=0 m=1
R$1094 \$796 \$808 vss rppd w=4u l=1.2u ps=0u b=0 m=1
R$1095 \$797 \$810 vss rppd w=4u l=1.2u ps=0u b=0 m=1
R$1096 \$800 \$811 vss rppd w=4u l=1.2u ps=0u b=0 m=1
R$1101 \$807 \$817 vss rppd w=4u l=1.2u ps=0u b=0 m=1
R$1102 \$808 \$818 vss rppd w=4u l=1.2u ps=0u b=0 m=1
R$1103 \$810 \$820 vss rppd w=4u l=1.2u ps=0u b=0 m=1
R$1104 \$811 \$822 vss rppd w=4u l=1.2u ps=0u b=0 m=1
R$1108 \$54 vss vss rppd w=4u l=306u ps=0u b=0 m=1
R$1109 \$817 \$829 vss rppd w=4u l=1.2u ps=0u b=0 m=1
R$1110 \$818 \$830 vss rppd w=4u l=1.2u ps=0u b=0 m=1
R$1111 \$820 \$831 vss rppd w=4u l=1.2u ps=0u b=0 m=1
R$1112 \$822 \$832 vss rppd w=4u l=1.2u ps=0u b=0 m=1
R$1117 \$829 \$835 vss rppd w=4u l=1.2u ps=0u b=0 m=1
R$1118 \$830 \$835 vss rppd w=4u l=1.2u ps=0u b=0 m=1
R$1119 \$831 \$837 vss rppd w=4u l=1.2u ps=0u b=0 m=1
R$1120 \$832 \$837 vss rppd w=4u l=1.2u ps=0u b=0 m=1
.ENDS g1_dac8
