* Frozen ordinary-metal capacitor graph; ideal outside P/N grouping, other context grounded.
C8 0 N 9.7084600000000002e-17
C11 0 N 7.1596900000000006e-16
C12 0 P 1.14841e-16
C13 0 P 1.6596800000000004e-17
C16 0 N 1.6711400000000002e-17
C17 0 P 4.2755300000000002e-16
C22 0 P 4.1042600000000003e-16
C24 0 N 1.9109600000000002e-16
C25 0 P 1.1890500000000001e-16
C26 0 P 2.0499200000000004e-18
C27 0 P 4.4793500000000005e-16
C32 0 P 9.8378000000000011e-17
C33 0 P 4.4793500000000005e-16
C40 0 N 5.56341e-16
C42 N P 1.5411600000000003e-16
C43 N P 1.9109600000000002e-16
C44 N 0 2.8560900000000002e-15
C45 N P 1.0115100000000001e-16
C46 N P 4.4793500000000005e-16
C47 N 0 2.9798100000000002e-15
C50 P 0 2.3607900000000002e-15
C52 P 0 9.6437600000000003e-16
C54 P 0 2.9798100000000002e-15
C55 P 0 1.0585899999999999e-15
C56 P 0 1.0585899999999999e-15
VP P 0 DC 0 AC 0
VN N 0 DC 0 AC 1
.control
set numdgt=17
ac lin 1 1Meg 1Meg
let cp = -imag(i(VP))/(2*pi*1e6)
let cn = -imag(i(VN))/(2*pi*1e6)
print cp cn
echo SENSE_FEED_AC_END
quit
.endc
.end
