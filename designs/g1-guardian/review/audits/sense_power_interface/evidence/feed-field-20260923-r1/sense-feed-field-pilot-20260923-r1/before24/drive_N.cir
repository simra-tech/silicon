* Frozen ordinary-metal capacitor graph; ideal outside P/N grouping, other context grounded.
C1 0 N 7.1608399999999996e-16
C2 0 P 1.6711400000000002e-17
C5 0 N 8.3343100000000017e-18
C6 0 N 8.3343100000000017e-18
C7 0 P 4.1042600000000003e-16
C9 0 N 5.56341e-16
C11 0 N 1.1031000000000001e-16
C12 0 N 5.8334700000000007e-17
C13 0 P 9.8378000000000011e-17
C14 0 P 4.4793500000000005e-16
C16 N P 6.8428600000000003e-18
C17 N P 1.9109600000000002e-16
C18 N 0 2.8560900000000002e-15
C19 N 0 5.8295000000000013e-16
C20 N 0 6.1495500000000005e-16
C23 P 0 9.3517400000000004e-16
C26 P 0 5.9983000000000012e-16
C28 P 0 2.9798100000000002e-15
C29 P 0 1.0585899999999999e-15
VP P 0 DC 0 AC 0
VN N 0 DC 0 AC 1
.control
set numdgt=17
ac lin 1 1Meg 1Meg
let cp = -imag(i(VP))/(2*pi*1e6)
let cn = -imag(i(VN))/(2*pi*1e6)
print cp cn
echo SENSE_FEED_AC_END
quit
.endc
.end
