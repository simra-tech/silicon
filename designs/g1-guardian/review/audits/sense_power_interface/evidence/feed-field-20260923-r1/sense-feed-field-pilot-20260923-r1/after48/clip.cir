* cell sense_fill_clip
.SUBCKT sense_fill_clip
* net 2 CTX_L8_5
* net 3 CTX_L10_0,CTX_L8_0,CTX_L8_1,CTX_L8_2,CTX_L8_3,CTX_L8_4
* net 4 N
* net 5 CTX_L10_2,CTX_L8_10,CTX_L8_11,CTX_L8_12,CTX_L8_8,CTX_L8_9
* net 6 CTX_L8_6
* net 7 CTX_L8_7
* net 8 CTX_L10_1
* net 9 PSEG_L8_14
* net 10 P
* net 11 PSEG_L8_15
* net 12 CTX_L8_21
* net 13 CTX_L10_4,CTX_L8_16,CTX_L8_17,CTX_L8_18,CTX_L8_19,CTX_L8_20
* net 14 CTX_L8_30
* net 15 CTX_L10_6,CTX_L8_24,CTX_L8_25,CTX_L8_26,CTX_L8_27,CTX_L8_28
* net 16 NSEG_L8_22
* net 17 PSEG_L10_5
* net 18 PSEG_L8_23
* net 19 CTX_L8_29
* net 20 CTX_L8_31
.ENDS sense_fill_clip
