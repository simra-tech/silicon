* Frozen ordinary-metal capacitor graph; ideal outside P/N grouping, other context grounded.
C2 0 N 9.7084600000000002e-17
C5 0 N 7.1596900000000006e-16
C6 0 P 1.14841e-16
C7 0 P 1.6596800000000004e-17
C10 0 N 8.3343100000000017e-18
C11 0 N 8.3343100000000017e-18
C12 0 P 4.2755300000000002e-16
C14 0 N 5.56341e-16
C16 0 N 1.1031000000000001e-16
C17 0 N 5.8334700000000007e-17
C18 0 P 1.1890500000000001e-16
C19 0 P 4.4793500000000005e-16
C21 N P 1.5411600000000003e-16
C22 N P 1.9109600000000002e-16
C23 N 0 2.8560900000000002e-15
C24 N 0 5.8295000000000013e-16
C25 N 0 6.1495500000000005e-16
C28 P 0 2.3607900000000002e-15
C30 P 0 2.9798100000000002e-15
C31 P 0 1.0585899999999999e-15
VP P 0 DC 0 AC 1
VN N 0 DC 0 AC 0
.control
set numdgt=17
ac lin 1 1Meg 1Meg
let cp = -imag(i(VP))/(2*pi*1e6)
let cn = -imag(i(VN))/(2*pi*1e6)
print cp cn
echo SENSE_FEED_AC_END
quit
.endc
.end
