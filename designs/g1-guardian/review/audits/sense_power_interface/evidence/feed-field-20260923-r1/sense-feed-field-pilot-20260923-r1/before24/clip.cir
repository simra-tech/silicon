* cell sense_fill_clip
.SUBCKT sense_fill_clip
* net 1 CTX_L8_0
* net 2 CTX_L10_0,CTX_L8_1,CTX_L8_2,CTX_L8_3,CTX_L8_4,CTX_L8_5
* net 3 N
* net 4 PSEG_L8_7
* net 5 PSEG_L8_8
* net 6 CTX_L10_3,CTX_L8_10,CTX_L8_11,CTX_L8_12,CTX_L8_13,CTX_L8_9
* net 7 NSEG_L8_14
* net 8 CTX_L8_15
* net 9 NSEG_L8_16
* net 10 P
* net 11 PSEG_L10_2
.ENDS sense_fill_clip
