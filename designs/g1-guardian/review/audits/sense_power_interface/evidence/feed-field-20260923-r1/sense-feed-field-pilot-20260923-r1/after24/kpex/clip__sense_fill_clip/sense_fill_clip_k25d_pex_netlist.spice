*********************************************************
*** NGSPICE file created by KLayout-PEX 0.3.12
*** -----------------------------------------------------
***     Extraction Engine: KPEX/2.5D
***     Technology: ihp_sg13g2
***     Date: 2026-09-23 08:26:03
*********************************************************

.SUBCKT sense_fill_clip
Cext_1 CTX_L10_0 CTX_L10_1|CTX_L8_1|CTX_L8_2|CTX_L8_3|CTX_L8_4|CTX_L8_5 427.553a
Cext_2 CTX_L10_0 CTX_L8_0 484.987a
Cext_3 CTX_L10_0 N 97.0846a
Cext_4 CTX_L10_0 VSUBS 1.09956f
Cext_5 CTX_L10_1|CTX_L8_1|CTX_L8_2|CTX_L8_3|CTX_L8_4|CTX_L8_5 CTX_L8_0 11.7905a
Cext_6 CTX_L10_1|CTX_L8_1|CTX_L8_2|CTX_L8_3|CTX_L8_4|CTX_L8_5 N 715.969a
Cext_7 CTX_L10_1|CTX_L8_1|CTX_L8_2|CTX_L8_3|CTX_L8_4|CTX_L8_5 P 114.841a
Cext_8 CTX_L10_1|CTX_L8_1|CTX_L8_2|CTX_L8_3|CTX_L8_4|CTX_L8_5 PSEG_L8_7 16.5968a
Cext_9 CTX_L10_1|CTX_L8_1|CTX_L8_2|CTX_L8_3|CTX_L8_4|CTX_L8_5 VSUBS 1.22424f
Cext_10 CTX_L10_3|CTX_L8_10|CTX_L8_11|CTX_L8_12|CTX_L8_13|CTX_L8_9 CTX_L8_15
+ 716.041a
Cext_11 CTX_L10_3|CTX_L8_10|CTX_L8_11|CTX_L8_12|CTX_L8_13|CTX_L8_9 NSEG_L8_14
+ 8.33431a
Cext_12 CTX_L10_3|CTX_L8_10|CTX_L8_11|CTX_L8_12|CTX_L8_13|CTX_L8_9 NSEG_L8_16
+ 8.33431a
Cext_13 CTX_L10_3|CTX_L8_10|CTX_L8_11|CTX_L8_12|CTX_L8_13|CTX_L8_9 P 427.553a
Cext_14 CTX_L10_3|CTX_L8_10|CTX_L8_11|CTX_L8_12|CTX_L8_13|CTX_L8_9 VSUBS
+ 1.25719f
Cext_15 CTX_L8_0 N 556.341a
Cext_16 CTX_L8_0 VSUBS 1.36462f
Cext_17 CTX_L8_15 NSEG_L8_14 110.31a
Cext_18 CTX_L8_15 NSEG_L8_16 58.3347a
Cext_19 CTX_L8_15 P 118.905a
Cext_20 CTX_L8_15 PSEG_L8_8 447.935a
Cext_21 CTX_L8_15 VSUBS 2.84824f
Cext_22 N P 154.116a
Cext_23 N PSEG_L8_7 191.096a
Cext_24 N VSUBS 2.85609f
Cext_25 NSEG_L8_14 VSUBS 582.95a
Cext_26 NSEG_L8_16 VSUBS 614.955a
Cext_27 P PSEG_L8_7 1.86308f
Cext_28 P PSEG_L8_8 880.632a
Cext_29 P VSUBS 2.36079f
Cext_30 PSEG_L8_7 PSEG_L8_8 447.935a
Cext_31 PSEG_L8_7 VSUBS 2.97981f
Cext_32 PSEG_L8_8 VSUBS 1.05859f
.ENDS sense_fill_clip
