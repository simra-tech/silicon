* Frozen ordinary-metal capacitor graph; ideal outside P/N grouping, other context grounded.
C7 0 N 2.2831100000000002e-17
C11 0 N 7.1608399999999996e-16
C12 0 P 1.6711400000000002e-17
C15 0 N 1.6711400000000002e-17
C16 0 P 4.1042600000000003e-16
C21 0 P 4.1042600000000003e-16
C23 0 N 1.9109600000000002e-16
C24 0 P 9.8378000000000011e-17
C25 0 P 2.0499200000000004e-18
C26 0 P 4.4793500000000005e-16
C31 0 P 9.8378000000000011e-17
C32 0 P 4.4793500000000005e-16
C39 0 N 5.56341e-16
C41 N P 6.8428600000000003e-18
C42 N P 1.9109600000000002e-16
C43 N 0 2.8560900000000002e-15
C44 N P 1.0115100000000001e-16
C45 N P 4.4793500000000005e-16
C46 N 0 2.9798100000000002e-15
C49 P 0 9.3517400000000004e-16
C52 P 0 5.9983000000000012e-16
C54 P 0 9.6437600000000003e-16
C56 P 0 2.9798100000000002e-15
C57 P 0 1.0585899999999999e-15
C58 P 0 1.0585899999999999e-15
VP P 0 DC 0 AC 0
VN N 0 DC 0 AC 1
.control
set numdgt=17
ac lin 1 1Meg 1Meg
let cp = -imag(i(VP))/(2*pi*1e6)
let cn = -imag(i(VN))/(2*pi*1e6)
print cp cn
echo SENSE_FEED_AC_END
quit
.endc
.end
