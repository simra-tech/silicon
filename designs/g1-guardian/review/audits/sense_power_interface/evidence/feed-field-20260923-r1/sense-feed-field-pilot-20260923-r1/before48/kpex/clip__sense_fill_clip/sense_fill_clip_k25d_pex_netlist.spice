*********************************************************
*** NGSPICE file created by KLayout-PEX 0.3.12
*** -----------------------------------------------------
***     Extraction Engine: KPEX/2.5D
***     Technology: ihp_sg13g2
***     Date: 2026-09-23 08:25:59
*********************************************************

.SUBCKT sense_fill_clip
Cext_1 CTX_L10_0|CTX_L8_0|CTX_L8_1|CTX_L8_2|CTX_L8_3|CTX_L8_4 CTX_L8_5 716.084a
Cext_2 CTX_L10_0|CTX_L8_0|CTX_L8_1|CTX_L8_2|CTX_L8_3|CTX_L8_4 CTX_L8_6 16.7114a
Cext_3 CTX_L10_0|CTX_L8_0|CTX_L8_1|CTX_L8_2|CTX_L8_3|CTX_L8_4 VSUBS 1.60695f
Cext_4 CTX_L10_1 CTX_L10_2|CTX_L8_10|CTX_L8_11|CTX_L8_12|CTX_L8_8|CTX_L8_9
+ 220.506a
Cext_5 CTX_L10_1 CTX_L8_5 6.84286a
Cext_6 CTX_L10_1 CTX_L8_6 642.929a
Cext_7 CTX_L10_1 CTX_L8_7 35.2981a
Cext_8 CTX_L10_1 N 22.8311a
Cext_9 CTX_L10_1 VSUBS 1.1299f
Cext_10 CTX_L10_2|CTX_L8_10|CTX_L8_11|CTX_L8_12|CTX_L8_8|CTX_L8_9 CTX_L8_6
+ 1.67256a
Cext_11 CTX_L10_2|CTX_L8_10|CTX_L8_11|CTX_L8_12|CTX_L8_8|CTX_L8_9 CTX_L8_7
+ 29.0695a
Cext_12 CTX_L10_2|CTX_L8_10|CTX_L8_11|CTX_L8_12|CTX_L8_8|CTX_L8_9 N 716.084a
Cext_13 CTX_L10_2|CTX_L8_10|CTX_L8_11|CTX_L8_12|CTX_L8_8|CTX_L8_9 PSEG_L8_14
+ 16.7114a
Cext_14 CTX_L10_2|CTX_L8_10|CTX_L8_11|CTX_L8_12|CTX_L8_8|CTX_L8_9 VSUBS 1.39898f
Cext_15 CTX_L10_5|CTX_L8_16|CTX_L8_17|CTX_L8_18|CTX_L8_19|CTX_L8_20 CTX_L8_21
+ 716.084a
Cext_16 CTX_L10_5|CTX_L8_16|CTX_L8_17|CTX_L8_18|CTX_L8_19|CTX_L8_20 NSEG_L8_22
+ 16.7114a
Cext_17 CTX_L10_5|CTX_L8_16|CTX_L8_17|CTX_L8_18|CTX_L8_19|CTX_L8_20 PSEG_L10_4
+ 410.426a
Cext_18 CTX_L10_5|CTX_L8_16|CTX_L8_17|CTX_L8_18|CTX_L8_19|CTX_L8_20 VSUBS
+ 1.26791f
Cext_19 CTX_L10_7|CTX_L8_24|CTX_L8_25|CTX_L8_26|CTX_L8_27|CTX_L8_28 CTX_L8_29
+ 8.20937a
Cext_20 CTX_L10_7|CTX_L8_24|CTX_L8_25|CTX_L8_26|CTX_L8_27|CTX_L8_28 CTX_L8_30
+ 715.791a
Cext_21 CTX_L10_7|CTX_L8_24|CTX_L8_25|CTX_L8_26|CTX_L8_27|CTX_L8_28 CTX_L8_31
+ 8.20937a
Cext_22 CTX_L10_7|CTX_L8_24|CTX_L8_25|CTX_L8_26|CTX_L8_27|CTX_L8_28 PSEG_L10_6
+ 410.426a
Cext_23 CTX_L10_7|CTX_L8_24|CTX_L8_25|CTX_L8_26|CTX_L8_27|CTX_L8_28 VSUBS
+ 1.2695f
Cext_24 CTX_L8_21 NSEG_L8_22 191.096a
Cext_25 CTX_L8_21 PSEG_L10_4 98.378a
Cext_26 CTX_L8_21 PSEG_L10_6 2.04992a
Cext_27 CTX_L8_21 PSEG_L8_15 447.935a
Cext_28 CTX_L8_21 VSUBS 2.91382f
Cext_29 CTX_L8_29 CTX_L8_30 89.6029a
Cext_30 CTX_L8_29 VSUBS 468.539a
Cext_31 CTX_L8_30 CTX_L8_31 47.981a
Cext_32 CTX_L8_30 PSEG_L10_6 98.378a
Cext_33 CTX_L8_30 PSEG_L8_23 447.935a
Cext_34 CTX_L8_30 VSUBS 2.61305f
Cext_35 CTX_L8_31 VSUBS 494.168a
Cext_36 CTX_L8_5 CTX_L8_6 191.096a
Cext_37 CTX_L8_5 VSUBS 3.27755f
Cext_38 CTX_L8_6 CTX_L8_7 374.886a
Cext_39 CTX_L8_6 VSUBS 3.02831f
Cext_40 CTX_L8_7 N 556.341a
Cext_41 CTX_L8_7 VSUBS 1.04936f
Cext_42 N P 6.84286a
Cext_43 N PSEG_L8_14 191.096a
Cext_44 N VSUBS 2.85609f
Cext_45 NSEG_L8_22 PSEG_L10_6 101.151a
Cext_46 NSEG_L8_22 PSEG_L8_23 447.935a
Cext_47 NSEG_L8_22 VSUBS 2.97981f
Cext_48 P PSEG_L10_4 636.845a
Cext_49 P PSEG_L8_14 642.929a
Cext_50 P VSUBS 935.174a
Cext_51 PSEG_L10_4 PSEG_L8_14 20.2176a
Cext_52 PSEG_L10_4 PSEG_L8_15 428.478a
Cext_53 PSEG_L10_4 VSUBS 599.83a
Cext_54 PSEG_L10_6 PSEG_L8_23 428.478a
Cext_55 PSEG_L10_6 VSUBS 964.376a
Cext_56 PSEG_L8_14 PSEG_L8_15 447.935a
Cext_57 PSEG_L8_14 VSUBS 2.97981f
Cext_58 PSEG_L8_15 VSUBS 1.05859f
Cext_59 PSEG_L8_23 VSUBS 1.05859f
.ENDS sense_fill_clip
