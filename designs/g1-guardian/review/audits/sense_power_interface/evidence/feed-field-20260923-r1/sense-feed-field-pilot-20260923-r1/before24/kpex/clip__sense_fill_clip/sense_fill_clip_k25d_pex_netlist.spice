*********************************************************
*** NGSPICE file created by KLayout-PEX 0.3.12
*** -----------------------------------------------------
***     Extraction Engine: KPEX/2.5D
***     Technology: ihp_sg13g2
***     Date: 2026-09-23 08:25:55
*********************************************************

.SUBCKT sense_fill_clip
Cext_1 CTX_L10_0|CTX_L8_1|CTX_L8_2|CTX_L8_3|CTX_L8_4|CTX_L8_5 CTX_L8_0 29.0695a
Cext_2 CTX_L10_0|CTX_L8_1|CTX_L8_2|CTX_L8_3|CTX_L8_4|CTX_L8_5 N 716.084a
Cext_3 CTX_L10_0|CTX_L8_1|CTX_L8_2|CTX_L8_3|CTX_L8_4|CTX_L8_5 PSEG_L8_7 16.7114a
Cext_4 CTX_L10_0|CTX_L8_1|CTX_L8_2|CTX_L8_3|CTX_L8_4|CTX_L8_5 VSUBS 1.57199f
Cext_5 CTX_L10_3|CTX_L8_10|CTX_L8_11|CTX_L8_12|CTX_L8_13|CTX_L8_9 CTX_L8_15
+ 716.041a
Cext_6 CTX_L10_3|CTX_L8_10|CTX_L8_11|CTX_L8_12|CTX_L8_13|CTX_L8_9 NSEG_L8_14
+ 8.33431a
Cext_7 CTX_L10_3|CTX_L8_10|CTX_L8_11|CTX_L8_12|CTX_L8_13|CTX_L8_9 NSEG_L8_16
+ 8.33431a
Cext_8 CTX_L10_3|CTX_L8_10|CTX_L8_11|CTX_L8_12|CTX_L8_13|CTX_L8_9 PSEG_L10_2
+ 410.426a
Cext_9 CTX_L10_3|CTX_L8_10|CTX_L8_11|CTX_L8_12|CTX_L8_13|CTX_L8_9 VSUBS 1.26791f
Cext_10 CTX_L8_0 N 556.341a
Cext_11 CTX_L8_0 VSUBS 1.3646f
Cext_12 CTX_L8_15 NSEG_L8_14 110.31a
Cext_13 CTX_L8_15 NSEG_L8_16 58.3347a
Cext_14 CTX_L8_15 PSEG_L10_2 98.378a
Cext_15 CTX_L8_15 PSEG_L8_8 447.935a
Cext_16 CTX_L8_15 VSUBS 2.84824f
Cext_17 N P 6.84286a
Cext_18 N PSEG_L8_7 191.096a
Cext_19 N VSUBS 2.85609f
Cext_20 NSEG_L8_14 VSUBS 582.95a
Cext_21 NSEG_L8_16 VSUBS 614.955a
Cext_22 P PSEG_L10_2 636.845a
Cext_23 P PSEG_L8_7 642.929a
Cext_24 P VSUBS 935.174a
Cext_25 PSEG_L10_2 PSEG_L8_7 20.2176a
Cext_26 PSEG_L10_2 PSEG_L8_8 428.478a
Cext_27 PSEG_L10_2 VSUBS 599.83a
Cext_28 PSEG_L8_7 PSEG_L8_8 447.935a
Cext_29 PSEG_L8_7 VSUBS 2.97981f
Cext_30 PSEG_L8_8 VSUBS 1.05859f
.ENDS sense_fill_clip
