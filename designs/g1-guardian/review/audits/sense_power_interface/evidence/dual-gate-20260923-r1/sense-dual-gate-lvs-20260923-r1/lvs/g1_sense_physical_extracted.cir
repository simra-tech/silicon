* Extracted by KLayout with SG13G2 LVS runset on : 23/09/2026 06:21

.SUBCKT g1_sense_physical iptat isense sense_n sense_p vdd vped vref vref_buf
+ vss
X$1 vss \$63 vdd \$3 iptat \$140 \$191 \$574 \$513 \$506 isense
+ g1_ota_main_candidate
X$2 \$684 \$908 \$638 iptat vped vss \$794 \$943 vdd vped \$370 g1_ota
X$4 \$744 \$917 \$651 iptat vref_buf vss \$818 \$984 vdd vref_buf vref g1_ota
R$1 \$38 \$370 vss rppd w=2u l=76.7u ps=0u b=0 m=1
R$2 \$38 \$291 vss rppd w=2u l=76.7u ps=0u b=0 m=1
R$3 \$39 \$291 vss rppd w=2u l=76.7u ps=0u b=0 m=1
R$4 \$39 \$292 vss rppd w=2u l=76.7u ps=0u b=0 m=1
R$5 \$40 \$292 vss rppd w=2u l=76.7u ps=0u b=0 m=1
R$6 \$40 \$293 vss rppd w=2u l=76.7u ps=0u b=0 m=1
R$7 \$41 \$293 vss rppd w=2u l=76.7u ps=0u b=0 m=1
R$8 \$41 \$294 vss rppd w=2u l=76.7u ps=0u b=0 m=1
R$9 \$42 \$294 vss rppd w=2u l=76.7u ps=0u b=0 m=1
R$10 \$42 \$295 vss rppd w=2u l=76.7u ps=0u b=0 m=1
R$11 \$43 \$295 vss rppd w=2u l=76.7u ps=0u b=0 m=1
R$12 \$43 \$296 vss rppd w=2u l=76.7u ps=0u b=0 m=1
R$13 \$44 \$296 vss rppd w=2u l=76.7u ps=0u b=0 m=1
R$14 \$45 \$63 vss rppd w=2u l=76.7u ps=0u b=0 m=1
R$15 \$45 \$297 vss rppd w=2u l=76.7u ps=0u b=0 m=1
R$16 \$46 \$297 vss rppd w=2u l=76.7u ps=0u b=0 m=1
R$17 \$46 \$298 vss rppd w=2u l=76.7u ps=0u b=0 m=1
R$18 \$47 \$298 vss rppd w=2u l=76.7u ps=0u b=0 m=1
R$19 \$47 \$299 vss rppd w=2u l=76.7u ps=0u b=0 m=1
R$20 \$48 \$299 vss rppd w=2u l=76.7u ps=0u b=0 m=1
R$21 \$48 \$300 vss rppd w=2u l=76.7u ps=0u b=0 m=1
R$22 \$49 \$300 vss rppd w=2u l=76.7u ps=0u b=0 m=1
R$23 \$49 \$301 vss rppd w=2u l=76.7u ps=0u b=0 m=1
R$24 sense_n \$63 vss rppd w=2u l=76.7u ps=0u b=0 m=1
R$25 sense_p \$3 vss rppd w=2u l=76.7u ps=0u b=0 m=1
R$26 \$52 \$3 vss rppd w=2u l=76.7u ps=0u b=0 m=1
R$27 \$52 \$302 vss rppd w=2u l=76.7u ps=0u b=0 m=1
R$28 \$53 \$302 vss rppd w=2u l=76.7u ps=0u b=0 m=1
R$29 \$53 \$303 vss rppd w=2u l=76.7u ps=0u b=0 m=1
R$30 \$54 \$303 vss rppd w=2u l=76.7u ps=0u b=0 m=1
R$31 \$54 \$304 vss rppd w=2u l=76.7u ps=0u b=0 m=1
R$32 \$55 \$304 vss rppd w=2u l=76.7u ps=0u b=0 m=1
R$33 \$55 \$305 vss rppd w=2u l=76.7u ps=0u b=0 m=1
R$34 \$56 \$305 vss rppd w=2u l=76.7u ps=0u b=0 m=1
R$35 \$56 \$306 vss rppd w=2u l=76.7u ps=0u b=0 m=1
R$36 \$57 \$307 vss rppd w=2u l=76.7u ps=0u b=0 m=1
R$37 \$57 \$308 vss rppd w=2u l=76.7u ps=0u b=0 m=1
R$38 \$58 \$308 vss rppd w=2u l=76.7u ps=0u b=0 m=1
R$39 \$58 \$309 vss rppd w=2u l=76.7u ps=0u b=0 m=1
R$40 \$59 \$309 vss rppd w=2u l=76.7u ps=0u b=0 m=1
R$41 \$59 \$310 vss rppd w=2u l=76.7u ps=0u b=0 m=1
R$42 \$60 \$310 vss rppd w=2u l=76.7u ps=0u b=0 m=1
R$43 \$60 \$311 vss rppd w=2u l=76.7u ps=0u b=0 m=1
R$44 \$61 \$311 vss rppd w=2u l=76.7u ps=0u b=0 m=1
R$45 \$61 \$312 vss rppd w=2u l=76.7u ps=0u b=0 m=1
R$46 \$62 \$312 vss rppd w=2u l=76.7u ps=0u b=0 m=1
R$47 \$62 \$313 vss rppd w=2u l=76.7u ps=0u b=0 m=1
R$48 \$44 \$313 vss rppd w=2u l=76.7u ps=0u b=0 m=1
R$49 \$371 \$611 vss rppd w=2u l=76.7u ps=0u b=0 m=1
R$50 \$371 \$612 vss rppd w=2u l=76.7u ps=0u b=0 m=1
R$51 \$372 \$612 vss rppd w=2u l=76.7u ps=0u b=0 m=1
R$52 \$372 \$613 vss rppd w=2u l=76.7u ps=0u b=0 m=1
R$53 \$373 \$613 vss rppd w=2u l=76.7u ps=0u b=0 m=1
R$54 \$373 \$614 vss rppd w=2u l=76.7u ps=0u b=0 m=1
R$55 \$374 \$614 vss rppd w=2u l=76.7u ps=0u b=0 m=1
R$56 \$374 \$615 vss rppd w=2u l=76.7u ps=0u b=0 m=1
R$57 \$375 \$615 vss rppd w=2u l=76.7u ps=0u b=0 m=1
R$58 \$375 \$616 vss rppd w=2u l=76.7u ps=0u b=0 m=1
R$59 \$376 \$616 vss rppd w=2u l=76.7u ps=0u b=0 m=1
R$60 \$376 \$617 vss rppd w=2u l=76.7u ps=0u b=0 m=1
R$61 \$307 \$617 vss rppd w=2u l=76.7u ps=0u b=0 m=1
R$62 \$377 \$306 vss rppd w=2u l=76.7u ps=0u b=0 m=1
R$63 \$377 \$618 vss rppd w=2u l=76.7u ps=0u b=0 m=1
R$64 \$378 \$618 vss rppd w=2u l=76.7u ps=0u b=0 m=1
R$65 \$378 \$619 vss rppd w=2u l=76.7u ps=0u b=0 m=1
R$66 \$379 \$619 vss rppd w=2u l=76.7u ps=0u b=0 m=1
R$67 \$379 \$620 vss rppd w=2u l=76.7u ps=0u b=0 m=1
R$68 \$380 \$620 vss rppd w=2u l=76.7u ps=0u b=0 m=1
R$69 \$380 \$621 vss rppd w=2u l=76.7u ps=0u b=0 m=1
R$70 \$381 \$621 vss rppd w=2u l=76.7u ps=0u b=0 m=1
R$71 \$381 vped vss rppd w=2u l=76.7u ps=0u b=0 m=1
R$72 \$382 vref_buf vss rppd w=2u l=76.7u ps=0u b=0 m=1
R$73 \$382 \$370 vss rppd w=2u l=76.7u ps=0u b=0 m=1
R$74 \$383 \$301 vss rppd w=2u l=76.7u ps=0u b=0 m=1
R$75 \$383 \$622 vss rppd w=2u l=76.7u ps=0u b=0 m=1
R$76 \$384 \$622 vss rppd w=2u l=76.7u ps=0u b=0 m=1
R$77 \$384 \$623 vss rppd w=2u l=76.7u ps=0u b=0 m=1
R$78 \$385 \$623 vss rppd w=2u l=76.7u ps=0u b=0 m=1
R$79 \$385 \$624 vss rppd w=2u l=76.7u ps=0u b=0 m=1
R$80 \$386 \$624 vss rppd w=2u l=76.7u ps=0u b=0 m=1
R$81 \$386 \$625 vss rppd w=2u l=76.7u ps=0u b=0 m=1
R$82 \$387 \$625 vss rppd w=2u l=76.7u ps=0u b=0 m=1
R$83 \$387 isense vss rppd w=2u l=76.7u ps=0u b=0 m=1
R$84 \$388 \$611 vss rppd w=2u l=76.7u ps=0u b=0 m=1
R$85 \$388 \$626 vss rppd w=2u l=76.7u ps=0u b=0 m=1
R$86 \$389 \$626 vss rppd w=2u l=76.7u ps=0u b=0 m=1
R$87 \$389 \$627 vss rppd w=2u l=76.7u ps=0u b=0 m=1
R$88 \$390 \$627 vss rppd w=2u l=76.7u ps=0u b=0 m=1
R$89 \$390 \$628 vss rppd w=2u l=76.7u ps=0u b=0 m=1
R$90 \$391 \$628 vss rppd w=2u l=76.7u ps=0u b=0 m=1
R$91 \$391 \$629 vss rppd w=2u l=76.7u ps=0u b=0 m=1
R$92 \$392 \$629 vss rppd w=2u l=76.7u ps=0u b=0 m=1
R$93 \$392 \$630 vss rppd w=2u l=76.7u ps=0u b=0 m=1
R$94 \$393 \$630 vss rppd w=2u l=76.7u ps=0u b=0 m=1
R$95 \$393 vss vss rppd w=2u l=76.7u ps=0u b=0 m=1
M$96 vss iptat iptat vss sg13_hv_nmos L=1u W=3.3u AS=1.122p AD=1.122p PS=7.28u
+ PD=7.28u rfmode=0
.ENDS g1_sense_physical

.SUBCKT g1_ota \$1 \$2 \$4 vbn out vss \$9 \$10 vdd inn inp
M$1 vss \$4 \$4 vss sg13_hv_nmos L=1u W=1.6u AS=0.544p AD=0.544p PS=3.88u
+ PD=3.88u rfmode=0
M$2 vss vbn \$2 vss sg13_hv_nmos L=1u W=8u AS=2.12p AD=2.12p PS=13.06u
+ PD=13.06u rfmode=0
M$4 vss vbn \$1 vss sg13_hv_nmos L=1u W=8u AS=2.12p AD=2.12p PS=13.06u
+ PD=13.06u rfmode=0
M$6 vss vbn \$3 vss sg13_hv_nmos L=1u W=80u AS=16.4p AD=16.4p PS=92.1u PD=92.1u
+ rfmode=0
M$16 \$3 \$4 \$9 vss sg13_hv_nmos L=1u W=48u AS=10.32p AD=10.32p PS=58.58u
+ PD=58.58u rfmode=0
M$22 \$6 \$4 \$10 vss sg13_hv_nmos L=1u W=48u AS=10.32p AD=10.32p PS=58.58u
+ PD=58.58u rfmode=0
M$28 vss vbn \$6 vss sg13_hv_nmos L=1u W=80u AS=16.4p AD=16.4p PS=92.1u
+ PD=92.1u rfmode=0
M$38 vss vbn out vss sg13_hv_nmos L=1u W=96u AS=19.44p AD=19.44p PS=108.86u
+ PD=108.86u rfmode=0
M$50 vdd \$9 \$30 vdd sg13_hv_pmos L=1u W=96u AS=19.44p AD=19.44p PS=108.86u
+ PD=108.86u rfmode=0
M$62 \$30 \$1 \$9 vdd sg13_hv_pmos L=1u W=96u AS=19.44p AD=19.44p PS=108.86u
+ PD=108.86u rfmode=0
M$74 \$31 \$1 \$10 vdd sg13_hv_pmos L=1u W=96u AS=19.44p AD=19.44p PS=108.86u
+ PD=108.86u rfmode=0
M$86 vdd \$9 \$31 vdd sg13_hv_pmos L=1u W=96u AS=19.44p AD=19.44p PS=108.86u
+ PD=108.86u rfmode=0
M$98 \$41 inn \$3 vdd sg13_hv_pmos L=2u W=96u AS=19.14p AD=19.14p PS=108.38u
+ PD=108.38u rfmode=0
M$100 \$41 inp \$6 vdd sg13_hv_pmos L=2u W=96u AS=19.14p AD=19.14p PS=108.38u
+ PD=108.38u rfmode=0
M$114 vdd \$1 \$1 vdd sg13_hv_pmos L=1u W=3.2u AS=1.088p AD=1.088p PS=7.08u
+ PD=7.08u rfmode=0
M$115 vdd \$2 \$4 vdd sg13_hv_pmos L=1u W=16u AS=3.64p AD=3.64p PS=21.82u
+ PD=21.82u rfmode=0
M$119 vdd \$2 \$2 vdd sg13_hv_pmos L=1u W=16u AS=3.64p AD=3.64p PS=21.82u
+ PD=21.82u rfmode=0
M$123 vdd \$2 \$41 vdd sg13_hv_pmos L=1u W=128u AS=25.52p AD=25.52p PS=142.38u
+ PD=142.38u rfmode=0
M$155 vdd \$10 out vdd sg13_hv_pmos L=1u W=192u AS=37.68p AD=37.68p PS=209.42u
+ PD=209.42u rfmode=0
R$179 \$10 \$29 vss rppd w=1u l=6.2u ps=0u b=0 m=1
C$180 \$29 out cap_cmim w=23u l=23u A=529p P=92u m=1
.ENDS g1_ota

.SUBCKT g1_ota_main_candidate vss inn vdd inp vbn \$13 \$17 \$21 \$30 \$31 out
M$1 vss vbn \$3 vss sg13_hv_nmos L=4u W=320u AS=62p AD=62p PS=343.5u PD=343.5u
+ rfmode=0
M$41 vss vbn \$6 vss sg13_hv_nmos L=4u W=320u AS=62p AD=62p PS=343.5u PD=343.5u
+ rfmode=0
M$81 vss vbn \$30 vss sg13_hv_nmos L=1u W=8u AS=2.12p AD=2.12p PS=13.06u
+ PD=13.06u rfmode=0
M$83 \$3 \$31 \$13 vss sg13_hv_nmos L=1u W=48u AS=10.32p AD=10.32p PS=58.58u
+ PD=58.58u rfmode=0
M$89 vss \$31 \$31 vss sg13_hv_nmos L=1u W=1.6u AS=0.544p AD=0.544p PS=3.88u
+ PD=3.88u rfmode=0
M$90 vss vbn \$17 vss sg13_hv_nmos L=1u W=8u AS=2.12p AD=2.12p PS=13.06u
+ PD=13.06u rfmode=0
M$92 \$6 \$31 \$21 vss sg13_hv_nmos L=1u W=48u AS=10.32p AD=10.32p PS=58.58u
+ PD=58.58u rfmode=0
M$98 vss vbn out vss sg13_hv_nmos L=1u W=96u AS=19.44p AD=19.44p PS=108.86u
+ PD=108.86u rfmode=0
M$110 \$5 inn \$3 vdd sg13_hv_pmos L=2u W=384u AS=73.86p AD=73.86p PS=414.62u
+ PD=414.62u rfmode=0
M$112 \$5 inp \$6 vdd sg13_hv_pmos L=2u W=384u AS=73.86p AD=73.86p PS=414.62u
+ PD=414.62u rfmode=0
M$174 \$14 \$17 \$13 vdd sg13_hv_pmos L=4u W=384u AS=74.16p AD=74.16p
+ PS=410.54u PD=410.54u rfmode=0
M$222 vdd \$13 \$14 vdd sg13_hv_pmos L=4u W=384u AS=74.16p AD=74.16p PS=410.54u
+ PD=410.54u rfmode=0
M$270 \$20 \$17 \$21 vdd sg13_hv_pmos L=4u W=384u AS=74.16p AD=74.16p
+ PS=410.54u PD=410.54u rfmode=0
M$318 vdd \$13 \$20 vdd sg13_hv_pmos L=4u W=384u AS=74.16p AD=74.16p PS=410.54u
+ PD=410.54u rfmode=0
M$430 vdd \$30 \$5 vdd sg13_hv_pmos L=1u W=128u AS=25.52p AD=25.52p PS=142.38u
+ PD=142.38u rfmode=0
M$446 vdd \$30 \$30 vdd sg13_hv_pmos L=1u W=16u AS=3.64p AD=3.64p PS=21.82u
+ PD=21.82u rfmode=0
M$450 vdd \$30 \$31 vdd sg13_hv_pmos L=1u W=16u AS=3.64p AD=3.64p PS=21.82u
+ PD=21.82u rfmode=0
M$454 vdd \$17 \$17 vdd sg13_hv_pmos L=1u W=3.2u AS=1.088p AD=1.088p PS=7.08u
+ PD=7.08u rfmode=0
M$455 vdd \$21 out vdd sg13_hv_pmos L=1u W=192u AS=37.68p AD=37.68p PS=209.42u
+ PD=209.42u rfmode=0
R$479 \$21 \$32 vss rppd w=1u l=6.2u ps=0u b=0 m=1
C$480 \$32 out cap_cmim w=69u l=23u A=1587p P=184u m=1
.ENDS g1_ota_main_candidate
