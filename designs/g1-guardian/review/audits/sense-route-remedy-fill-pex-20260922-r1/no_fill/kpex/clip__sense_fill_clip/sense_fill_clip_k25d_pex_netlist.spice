*********************************************************
*** NGSPICE file created by KLayout-PEX 0.3.12
*** -----------------------------------------------------
***     Extraction Engine: KPEX/2.5D
***     Technology: ihp_sg13g2
***     Date: 2026-09-22 15:26:37
*********************************************************

.SUBCKT sense_fill_clip
Cext_1 CTX_L126_0 CTX_L134_0 1.49152f
Cext_2 CTX_L126_0 N 1.59885f
Cext_3 CTX_L126_0 P 548.317a
Cext_4 CTX_L126_0 VSUBS 2.92507f
Cext_5 CTX_L134_0 P 33.8174a
Cext_6 CTX_L134_0 VSUBS 996.75a
Cext_7 N P 494.271a
Cext_8 N VSUBS 1.38256f
Cext_9 P VSUBS 908.312a
.ENDS sense_fill_clip
