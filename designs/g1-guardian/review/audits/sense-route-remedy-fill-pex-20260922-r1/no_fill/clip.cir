* cell sense_fill_clip
.SUBCKT sense_fill_clip
* net 1 N
* net 2 P
* net 3 CTX_L126_0
* net 4 CTX_L134_0
.ENDS sense_fill_clip
