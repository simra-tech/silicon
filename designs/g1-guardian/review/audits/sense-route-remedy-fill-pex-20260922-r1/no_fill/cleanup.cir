* Extracted by KLayout with SG13G2 LVS runset on : 22/09/2026 15:26

.SUBCKT sense_fill_clip
.ENDS sense_fill_clip
