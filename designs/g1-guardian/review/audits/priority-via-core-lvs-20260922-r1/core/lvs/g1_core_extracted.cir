* Extracted by KLayout with SG13G2 LVS runset on : 22/09/2026 17:33

* cell g1_core
* pin D_ELT
* pin D_STD
* pin G_SHARED
* pin HBT_B
* pin HBT_C
* pin HBT_E
* pin SENSE_N
* pin SENSE_P
* pin VDD
* pin VDDA
* pin VSS
* pin en_i
* pin fault_n_o
* pin gate_o
* pin i_core_sclk_i
* pin i_core_sdi_i
* pin i_core_sdo_o
* pin i_core_temp_out_o
* pin i_core_vref
.SUBCKT g1_core D_ELT D_STD G_SHARED HBT_B HBT_C HBT_E SENSE_N SENSE_P VDD VDDA
+ VSS en_i fault_n_o gate_o i_core_sclk_i i_core_sdi_i i_core_sdo_o
+ i_core_temp_out_o i_core_vref
* cell instance $57 r0 *1 586,860
X$57 VSS \$38791 \$54260 VDDA VDD g1_ls_up
* cell instance $58 r0 *1 566,860
X$58 VSS \$38358 \$54243 VDDA VDD g1_ls_up
* cell instance $3725 r0 *1 737,648
X$3725 VSS \$39210 \$39406 \$39407 \$39405 \$39318 \$39165 \$39493 \$39596 VDD
+ VDDA \$38993 \$38994 \$38792 \$38602 \$38995 \$39019 \$38999 \$38793 \$33619
+ \$46221 \$35795 \$38357 \$37734 g1_trip
* cell instance $12400 r0 *1 850,862
X$12400 VSS \$37734 \$35930 VDD en_i \$37596 \$37595 gate_o \$38359 VDDA
+ fault_n_o g1_gate
* cell instance $24630 r0 *1 366.5,848
X$24630 VSS \$37721 \$36370 \$39738 \$31485 \$35895 \$25985 VDD g1_osc
* cell instance $28263 r0 *1 546,860
X$28263 VSS \$37923 \$54241 VDDA VDD g1_ls_up
* cell instance $33260 r0 *1 733,440
X$33260 VSS \$27428 SENSE_P SENSE_N \$46221 \$33619 i_core_vref VDDA g1_sense
* cell instance $89396 r0 *1 367,408
X$89396 VSS VDD \$25985 \$35795 \$38359 \$35895 \$35930 \$31485 \$36370 \$37734
+ \$37596 \$37595 \$37923 \$38357 en_i \$38791 \$38358 \$38906 \$38602 \$39738
+ \$37721 i_core_sdi_i i_core_sclk_i \$39406 \$39210 \$39165 \$38999 \$39493
+ \$38995 \$39405 \$38792 \$39318 \$38994 \$38993 \$38793 \$39019 \$39596
+ \$39407 i_core_sdo_o g1_digital
* cell instance $123848 r0 *1 367,370
X$123848 VSS G_SHARED D_ELT D_STD g1_dose_macro
* cell instance $126136 r0 *1 367,800
X$126136 VSS HBT_B HBT_E HBT_C g1_dut_macro
* cell instance $127936 r0 *1 645,862
X$127936 VSS i_core_vref \$60299 \$27428 \$61186 \$54241 VDDA g1_bgr
* cell instance $181219 r0 *1 546,883
X$181219 VSS \$54243 i_core_vref VDDA \$60299 \$61186 \$54260 i_core_temp_out_o
+ VDD g1_t2f
* cell instance $197049 m0 *1 724.8,782.46
X$197049 \$38906 VDD VSS sg13g2_tiehi
* cell instance $197050 m0 *1 367.2,782.46
X$197050 \$38357 VDD VSS sg13g2_antennanp
* cell instance $197051 m0 *1 368.64,782.46
X$197051 i_core_sdi_i VDD VSS sg13g2_antennanp
* cell instance $197052 m0 *1 723.36,782.46
X$197052 en_i VDD VSS sg13g2_antennanp
* cell instance $197053 m0 *1 365.76,782.46
X$197053 \$38357 VDD VSS sg13g2_antennanp
* cell instance $197055 m0 *1 721.92,782.46
X$197055 \$38359 VDD VSS sg13g2_antennanp
* cell instance $197056 r0 *1 725.28,782.46
X$197056 \$38359 VDD VSS sg13g2_antennanp
* cell instance $197057 m0 *1 723.84,797.58
X$197057 VDD VSS sg13g2_decap_4
* cell instance $197058 m0 *1 723.84,820.26
X$197058 VDD VSS sg13g2_decap_4
* cell instance $197059 m0 *1 719.52,782.46
X$197059 VDD VSS sg13g2_decap_4
* cell instance $197060 m0 *1 723.84,835.38
X$197060 VDD VSS sg13g2_decap_4
* cell instance $197061 m0 *1 723.84,812.7
X$197061 VDD VSS sg13g2_decap_4
* cell instance $197062 m0 *1 723.84,790.02
X$197062 VDD VSS sg13g2_decap_4
* cell instance $197063 m0 *1 723.84,827.82
X$197063 VDD VSS sg13g2_decap_4
* cell instance $197064 m0 *1 724.32,842.94
X$197064 VDD VSS sg13g2_decap_4
* cell instance $197065 m0 *1 723.84,805.14
X$197065 VDD VSS sg13g2_decap_4
* cell instance $197066 r0 *1 723.84,812.7
X$197066 VDD VSS sg13g2_decap_4
* cell instance $197067 r0 *1 723.84,820.26
X$197067 VDD VSS sg13g2_decap_4
* cell instance $197068 r0 *1 724.32,842.94
X$197068 VDD VSS sg13g2_decap_4
* cell instance $197069 r0 *1 723.84,805.14
X$197069 VDD VSS sg13g2_decap_4
* cell instance $197070 r0 *1 723.84,797.58
X$197070 VDD VSS sg13g2_decap_4
* cell instance $197071 r0 *1 723.84,827.82
X$197071 VDD VSS sg13g2_decap_4
* cell instance $197072 r0 *1 724.32,835.38
X$197072 VDD VSS sg13g2_decap_4
* cell instance $197073 r0 *1 723.84,790.02
X$197073 VDD VSS sg13g2_decap_4
* cell instance $197095 m0 *1 866.88,956.34
X$197095 VDD VSS sg13g2_decap_8
* cell instance $197096 m0 *1 907.2,956.34
X$197096 VDD VSS sg13g2_decap_8
* cell instance $197097 m0 *1 880.32,956.34
X$197097 VDD VSS sg13g2_decap_8
* cell instance $197098 m0 *1 893.76,979.02
X$197098 VDD VSS sg13g2_decap_8
* cell instance $197099 m0 *1 897.12,979.02
X$197099 VDD VSS sg13g2_decap_8
* cell instance $197100 m0 *1 870.24,956.34
X$197100 VDD VSS sg13g2_decap_8
* cell instance $197101 m0 *1 890.4,956.34
X$197101 VDD VSS sg13g2_decap_8
* cell instance $197102 m0 *1 870.24,963.9
X$197102 VDD VSS sg13g2_decap_8
* cell instance $197103 m0 *1 954.24,948.78
X$197103 VDD VSS sg13g2_decap_8
* cell instance $197104 m0 *1 960.96,948.78
X$197104 VDD VSS sg13g2_decap_8
* cell instance $197105 m0 *1 967.68,941.22
X$197105 VDD VSS sg13g2_decap_8
* cell instance $197106 m0 *1 836.64,956.34
X$197106 VDD VSS sg13g2_decap_8
* cell instance $197107 m0 *1 954.24,941.22
X$197107 VDD VSS sg13g2_decap_8
* cell instance $197108 m0 *1 903.84,956.34
X$197108 VDD VSS sg13g2_decap_8
* cell instance $197109 m0 *1 873.6,956.34
X$197109 VDD VSS sg13g2_decap_8
* cell instance $197110 m0 *1 960.96,941.22
X$197110 VDD VSS sg13g2_decap_8
* cell instance $197111 m0 *1 900.48,956.34
X$197111 VDD VSS sg13g2_decap_8
* cell instance $197112 m0 *1 870.24,933.66
X$197112 VDD VSS sg13g2_decap_8
* cell instance $197113 m0 *1 846.72,956.34
X$197113 VDD VSS sg13g2_decap_8
* cell instance $197114 m0 *1 870.24,979.02
X$197114 VDD VSS sg13g2_decap_8
* cell instance $197115 m0 *1 843.36,956.34
X$197115 VDD VSS sg13g2_decap_8
* cell instance $197116 m0 *1 893.76,956.34
X$197116 VDD VSS sg13g2_decap_8
* cell instance $197117 m0 *1 853.44,956.34
X$197117 VDD VSS sg13g2_decap_8
* cell instance $197118 m0 *1 876.96,956.34
X$197118 VDD VSS sg13g2_decap_8
* cell instance $197119 m0 *1 870.24,941.22
X$197119 VDD VSS sg13g2_decap_8
* cell instance $197120 m0 *1 883.68,956.34
X$197120 VDD VSS sg13g2_decap_8
* cell instance $197121 m0 *1 860.16,956.34
X$197121 VDD VSS sg13g2_decap_8
* cell instance $197122 m0 *1 897.12,956.34
X$197122 VDD VSS sg13g2_decap_8
* cell instance $197123 m0 *1 967.68,948.78
X$197123 VDD VSS sg13g2_decap_8
* cell instance $197124 m0 *1 673.92,842.94
X$197124 VDD VSS sg13g2_decap_8
* cell instance $197125 m0 *1 957.6,948.78
X$197125 VDD VSS sg13g2_decap_8
* cell instance $197126 m0 *1 850.08,956.34
X$197126 VDD VSS sg13g2_decap_8
* cell instance $197127 m0 *1 957.6,941.22
X$197127 VDD VSS sg13g2_decap_8
* cell instance $197128 m0 *1 863.52,956.34
X$197128 VDD VSS sg13g2_decap_8
* cell instance $197129 m0 *1 964.32,948.78
X$197129 VDD VSS sg13g2_decap_8
* cell instance $197130 m0 *1 840,956.34
X$197130 VDD VSS sg13g2_decap_8
* cell instance $197131 m0 *1 887.04,956.34
X$197131 VDD VSS sg13g2_decap_8
* cell instance $197132 m0 *1 870.24,948.78
X$197132 VDD VSS sg13g2_decap_8
* cell instance $197133 m0 *1 856.8,956.34
X$197133 VDD VSS sg13g2_decap_8
* cell instance $197134 m0 *1 964.32,941.22
X$197134 VDD VSS sg13g2_decap_8
* cell instance $197135 m0 *1 742.56,979.02
X$197135 VDD VSS sg13g2_decap_8
* cell instance $197136 m0 *1 739.2,971.46
X$197136 VDD VSS sg13g2_decap_8
* cell instance $197137 m0 *1 673.44,812.7
X$197137 VDD VSS sg13g2_decap_8
* cell instance $197138 m0 *1 673.44,835.38
X$197138 VDD VSS sg13g2_decap_8
* cell instance $197139 m0 *1 673.44,805.14
X$197139 VDD VSS sg13g2_decap_8
* cell instance $197140 m0 *1 742.56,956.34
X$197140 VDD VSS sg13g2_decap_8
* cell instance $197141 m0 *1 672.48,396.9
X$197141 VDD VSS sg13g2_decap_8
* cell instance $197142 m0 *1 745.92,956.34
X$197142 VDD VSS sg13g2_decap_8
* cell instance $197143 m0 *1 679.2,782.46
X$197143 VDD VSS sg13g2_decap_8
* cell instance $197144 m0 *1 749.28,956.34
X$197144 VDD VSS sg13g2_decap_8
* cell instance $197145 m0 *1 910.56,963.9
X$197145 VDD VSS sg13g2_decap_8
* cell instance $197146 m0 *1 910.56,956.34
X$197146 VDD VSS sg13g2_decap_8
* cell instance $197147 m0 *1 819.84,933.66
X$197147 VDD VSS sg13g2_decap_8
* cell instance $197148 m0 *1 813.12,948.78
X$197148 VDD VSS sg13g2_decap_8
* cell instance $197149 m0 *1 819.84,948.78
X$197149 VDD VSS sg13g2_decap_8
* cell instance $197150 m0 *1 823.2,941.22
X$197150 VDD VSS sg13g2_decap_8
* cell instance $197151 m0 *1 672.48,389.34
X$197151 VDD VSS sg13g2_decap_8
* cell instance $197152 m0 *1 739.2,956.34
X$197152 VDD VSS sg13g2_decap_8
* cell instance $197153 m0 *1 745.92,941.22
X$197153 VDD VSS sg13g2_decap_8
* cell instance $197154 m0 *1 739.2,933.66
X$197154 VDD VSS sg13g2_decap_8
* cell instance $197155 m0 *1 742.56,948.78
X$197155 VDD VSS sg13g2_decap_8
* cell instance $197156 m0 *1 749.28,933.66
X$197156 VDD VSS sg13g2_decap_8
* cell instance $197157 m0 *1 950.88,948.78
X$197157 VDD VSS sg13g2_decap_8
* cell instance $197158 m0 *1 950.88,933.66
X$197158 VDD VSS sg13g2_decap_8
* cell instance $197159 m0 *1 739.2,979.02
X$197159 VDD VSS sg13g2_decap_8
* cell instance $197160 m0 *1 749.28,971.46
X$197160 VDD VSS sg13g2_decap_8
* cell instance $197161 m0 *1 749.28,979.02
X$197161 VDD VSS sg13g2_decap_8
* cell instance $197162 m0 *1 910.56,948.78
X$197162 VDD VSS sg13g2_decap_8
* cell instance $197163 m0 *1 745.92,979.02
X$197163 VDD VSS sg13g2_decap_8
* cell instance $197164 m0 *1 910.56,941.22
X$197164 VDD VSS sg13g2_decap_8
* cell instance $197165 m0 *1 910.56,933.66
X$197165 VDD VSS sg13g2_decap_8
* cell instance $197166 m0 *1 742.56,971.46
X$197166 VDD VSS sg13g2_decap_8
* cell instance $197167 m0 *1 745.92,971.46
X$197167 VDD VSS sg13g2_decap_8
* cell instance $197168 m0 *1 742.56,963.9
X$197168 VDD VSS sg13g2_decap_8
* cell instance $197169 m0 *1 745.92,963.9
X$197169 VDD VSS sg13g2_decap_8
* cell instance $197170 m0 *1 739.2,963.9
X$197170 VDD VSS sg13g2_decap_8
* cell instance $197171 m0 *1 749.28,963.9
X$197171 VDD VSS sg13g2_decap_8
* cell instance $197172 m0 *1 813.12,941.22
X$197172 VDD VSS sg13g2_decap_8
* cell instance $197173 m0 *1 826.56,948.78
X$197173 VDD VSS sg13g2_decap_8
* cell instance $197174 m0 *1 819.84,941.22
X$197174 VDD VSS sg13g2_decap_8
* cell instance $197175 m0 *1 816.48,941.22
X$197175 VDD VSS sg13g2_decap_8
* cell instance $197176 m0 *1 816.48,948.78
X$197176 VDD VSS sg13g2_decap_8
* cell instance $197177 m0 *1 826.56,941.22
X$197177 VDD VSS sg13g2_decap_8
* cell instance $197178 m0 *1 803.04,933.66
X$197178 VDD VSS sg13g2_decap_8
* cell instance $197179 m0 *1 806.4,933.66
X$197179 VDD VSS sg13g2_decap_8
* cell instance $197180 m0 *1 673.44,790.02
X$197180 VDD VSS sg13g2_decap_8
* cell instance $197181 m0 *1 910.56,979.02
X$197181 VDD VSS sg13g2_decap_8
* cell instance $197182 m0 *1 910.56,971.46
X$197182 VDD VSS sg13g2_decap_8
* cell instance $197183 m0 *1 762.72,941.22
X$197183 VDD VSS sg13g2_decap_8
* cell instance $197184 m0 *1 769.44,948.78
X$197184 VDD VSS sg13g2_decap_8
* cell instance $197185 m0 *1 766.08,948.78
X$197185 VDD VSS sg13g2_decap_8
* cell instance $197186 m0 *1 752.64,948.78
X$197186 VDD VSS sg13g2_decap_8
* cell instance $197187 m0 *1 762.72,948.78
X$197187 VDD VSS sg13g2_decap_8
* cell instance $197188 m0 *1 752.64,933.66
X$197188 VDD VSS sg13g2_decap_8
* cell instance $197189 m0 *1 759.36,941.22
X$197189 VDD VSS sg13g2_decap_8
* cell instance $197190 m0 *1 826.56,933.66
X$197190 VDD VSS sg13g2_decap_8
* cell instance $197191 m0 *1 672.48,782.46
X$197191 VDD VSS sg13g2_decap_8
* cell instance $197192 m0 *1 672.48,381.78
X$197192 VDD VSS sg13g2_decap_8
* cell instance $197193 m0 *1 796.32,933.66
X$197193 VDD VSS sg13g2_decap_8
* cell instance $197194 m0 *1 799.68,948.78
X$197194 VDD VSS sg13g2_decap_8
* cell instance $197195 m0 *1 796.32,941.22
X$197195 VDD VSS sg13g2_decap_8
* cell instance $197196 m0 *1 799.68,933.66
X$197196 VDD VSS sg13g2_decap_8
* cell instance $197197 m0 *1 809.76,948.78
X$197197 VDD VSS sg13g2_decap_8
* cell instance $197198 m0 *1 813.12,933.66
X$197198 VDD VSS sg13g2_decap_8
* cell instance $197199 m0 *1 823.2,948.78
X$197199 VDD VSS sg13g2_decap_8
* cell instance $197200 m0 *1 809.76,941.22
X$197200 VDD VSS sg13g2_decap_8
* cell instance $197201 m0 *1 806.4,948.78
X$197201 VDD VSS sg13g2_decap_8
* cell instance $197202 m0 *1 803.04,941.22
X$197202 VDD VSS sg13g2_decap_8
* cell instance $197203 m0 *1 799.68,941.22
X$197203 VDD VSS sg13g2_decap_8
* cell instance $197204 m0 *1 816.48,933.66
X$197204 VDD VSS sg13g2_decap_8
* cell instance $197205 m0 *1 806.4,941.22
X$197205 VDD VSS sg13g2_decap_8
* cell instance $197206 m0 *1 803.04,948.78
X$197206 VDD VSS sg13g2_decap_8
* cell instance $197207 m0 *1 796.32,948.78
X$197207 VDD VSS sg13g2_decap_8
* cell instance $197208 m0 *1 823.2,933.66
X$197208 VDD VSS sg13g2_decap_8
* cell instance $197209 m0 *1 809.76,933.66
X$197209 VDD VSS sg13g2_decap_8
* cell instance $197210 m0 *1 712.8,782.46
X$197210 VDD VSS sg13g2_decap_8
* cell instance $197211 m0 *1 924,956.34
X$197211 VDD VSS sg13g2_decap_8
* cell instance $197212 m0 *1 930.72,956.34
X$197212 VDD VSS sg13g2_decap_8
* cell instance $197213 m0 *1 713.76,790.02
X$197213 VDD VSS sg13g2_decap_8
* cell instance $197214 m0 *1 713.76,812.7
X$197214 VDD VSS sg13g2_decap_8
* cell instance $197215 m0 *1 713.76,820.26
X$197215 VDD VSS sg13g2_decap_8
* cell instance $197216 m0 *1 713.76,827.82
X$197216 VDD VSS sg13g2_decap_8
* cell instance $197217 m0 *1 713.76,805.14
X$197217 VDD VSS sg13g2_decap_8
* cell instance $197218 m0 *1 749.28,948.78
X$197218 VDD VSS sg13g2_decap_8
* cell instance $197219 m0 *1 703.68,797.58
X$197219 VDD VSS sg13g2_decap_8
* cell instance $197220 m0 *1 707.04,797.58
X$197220 VDD VSS sg13g2_decap_8
* cell instance $197221 m0 *1 696.96,797.58
X$197221 VDD VSS sg13g2_decap_8
* cell instance $197222 m0 *1 680.16,797.58
X$197222 VDD VSS sg13g2_decap_8
* cell instance $197223 m0 *1 683.52,797.58
X$197223 VDD VSS sg13g2_decap_8
* cell instance $197224 m0 *1 686.88,797.58
X$197224 VDD VSS sg13g2_decap_8
* cell instance $197225 m0 *1 690.24,797.58
X$197225 VDD VSS sg13g2_decap_8
* cell instance $197226 m0 *1 676.8,797.58
X$197226 VDD VSS sg13g2_decap_8
* cell instance $197227 m0 *1 693.6,797.58
X$197227 VDD VSS sg13g2_decap_8
* cell instance $197228 m0 *1 700.32,797.58
X$197228 VDD VSS sg13g2_decap_8
* cell instance $197229 m0 *1 887.04,948.78
X$197229 VDD VSS sg13g2_decap_8
* cell instance $197230 m0 *1 883.68,941.22
X$197230 VDD VSS sg13g2_decap_8
* cell instance $197231 m0 *1 883.68,948.78
X$197231 VDD VSS sg13g2_decap_8
* cell instance $197232 m0 *1 880.32,941.22
X$197232 VDD VSS sg13g2_decap_8
* cell instance $197233 m0 *1 887.04,941.22
X$197233 VDD VSS sg13g2_decap_8
* cell instance $197234 m0 *1 693.6,827.82
X$197234 VDD VSS sg13g2_decap_8
* cell instance $197235 m0 *1 673.44,797.58
X$197235 VDD VSS sg13g2_decap_8
* cell instance $197236 m0 *1 693.6,812.7
X$197236 VDD VSS sg13g2_decap_8
* cell instance $197237 m0 *1 710.4,797.58
X$197237 VDD VSS sg13g2_decap_8
* cell instance $197238 m0 *1 693.6,820.26
X$197238 VDD VSS sg13g2_decap_8
* cell instance $197239 m0 *1 717.12,805.14
X$197239 VDD VSS sg13g2_decap_8
* cell instance $197240 m0 *1 717.12,812.7
X$197240 VDD VSS sg13g2_decap_8
* cell instance $197241 m0 *1 717.12,820.26
X$197241 VDD VSS sg13g2_decap_8
* cell instance $197242 m0 *1 720.48,812.7
X$197242 VDD VSS sg13g2_decap_8
* cell instance $197243 m0 *1 720.48,827.82
X$197243 VDD VSS sg13g2_decap_8
* cell instance $197244 m0 *1 720.48,820.26
X$197244 VDD VSS sg13g2_decap_8
* cell instance $197245 m0 *1 720.48,805.14
X$197245 VDD VSS sg13g2_decap_8
* cell instance $197246 m0 *1 717.12,827.82
X$197246 VDD VSS sg13g2_decap_8
* cell instance $197247 m0 *1 693.6,805.14
X$197247 VDD VSS sg13g2_decap_8
* cell instance $197248 m0 *1 704.16,842.94
X$197248 VDD VSS sg13g2_decap_8
* cell instance $197249 m0 *1 700.8,842.94
X$197249 VDD VSS sg13g2_decap_8
* cell instance $197250 m0 *1 971.04,956.34
X$197250 VDD VSS sg13g2_decap_8
* cell instance $197251 m0 *1 697.44,842.94
X$197251 VDD VSS sg13g2_decap_8
* cell instance $197252 m0 *1 707.52,842.94
X$197252 VDD VSS sg13g2_decap_8
* cell instance $197253 m0 *1 673.44,827.82
X$197253 VDD VSS sg13g2_decap_8
* cell instance $197254 m0 *1 950.88,979.02
X$197254 VDD VSS sg13g2_decap_8
* cell instance $197255 m0 *1 710.88,842.94
X$197255 VDD VSS sg13g2_decap_8
* cell instance $197256 m0 *1 713.76,797.58
X$197256 VDD VSS sg13g2_decap_8
* cell instance $197257 m0 *1 714.24,842.94
X$197257 VDD VSS sg13g2_decap_8
* cell instance $197258 m0 *1 742.56,941.22
X$197258 VDD VSS sg13g2_decap_8
* cell instance $197259 m0 *1 745.92,948.78
X$197259 VDD VSS sg13g2_decap_8
* cell instance $197260 m0 *1 739.2,948.78
X$197260 VDD VSS sg13g2_decap_8
* cell instance $197261 m0 *1 749.28,941.22
X$197261 VDD VSS sg13g2_decap_8
* cell instance $197262 m0 *1 950.88,971.46
X$197262 VDD VSS sg13g2_decap_8
* cell instance $197263 m0 *1 745.92,933.66
X$197263 VDD VSS sg13g2_decap_8
* cell instance $197264 m0 *1 742.56,933.66
X$197264 VDD VSS sg13g2_decap_8
* cell instance $197265 m0 *1 739.2,941.22
X$197265 VDD VSS sg13g2_decap_8
* cell instance $197266 m0 *1 673.44,820.26
X$197266 VDD VSS sg13g2_decap_8
* cell instance $197267 m0 *1 717.12,797.58
X$197267 VDD VSS sg13g2_decap_8
* cell instance $197268 m0 *1 720.48,797.58
X$197268 VDD VSS sg13g2_decap_8
* cell instance $197269 m0 *1 974.4,956.34
X$197269 VDD VSS sg13g2_decap_8
* cell instance $197270 m0 *1 981.12,956.34
X$197270 VDD VSS sg13g2_decap_8
* cell instance $197271 m0 *1 977.76,956.34
X$197271 VDD VSS sg13g2_decap_8
* cell instance $197272 m0 *1 672.48,374.22
X$197272 VDD VSS sg13g2_decap_8
* cell instance $197273 m0 *1 954.24,956.34
X$197273 VDD VSS sg13g2_decap_8
* cell instance $197274 m0 *1 967.68,956.34
X$197274 VDD VSS sg13g2_decap_8
* cell instance $197275 m0 *1 964.32,956.34
X$197275 VDD VSS sg13g2_decap_8
* cell instance $197276 m0 *1 717.6,842.94
X$197276 VDD VSS sg13g2_decap_8
* cell instance $197277 m0 *1 687.36,842.94
X$197277 VDD VSS sg13g2_decap_8
* cell instance $197278 m0 *1 684,842.94
X$197278 VDD VSS sg13g2_decap_8
* cell instance $197279 m0 *1 680.64,842.94
X$197279 VDD VSS sg13g2_decap_8
* cell instance $197280 m0 *1 677.28,842.94
X$197280 VDD VSS sg13g2_decap_8
* cell instance $197281 m0 *1 960.96,956.34
X$197281 VDD VSS sg13g2_decap_8
* cell instance $197282 m0 *1 690.72,842.94
X$197282 VDD VSS sg13g2_decap_8
* cell instance $197283 m0 *1 957.6,956.34
X$197283 VDD VSS sg13g2_decap_8
* cell instance $197284 m0 *1 694.08,842.94
X$197284 VDD VSS sg13g2_decap_8
* cell instance $197285 m0 *1 720.96,842.94
X$197285 VDD VSS sg13g2_decap_8
* cell instance $197286 m0 *1 792.96,971.46
X$197286 VDD VSS sg13g2_decap_8
* cell instance $197287 m0 *1 762.72,979.02
X$197287 VDD VSS sg13g2_decap_8
* cell instance $197288 m0 *1 756,979.02
X$197288 VDD VSS sg13g2_decap_8
* cell instance $197289 m0 *1 759.36,979.02
X$197289 VDD VSS sg13g2_decap_8
* cell instance $197290 m0 *1 769.44,979.02
X$197290 VDD VSS sg13g2_decap_8
* cell instance $197291 m0 *1 782.88,979.02
X$197291 VDD VSS sg13g2_decap_8
* cell instance $197292 m0 *1 789.6,979.02
X$197292 VDD VSS sg13g2_decap_8
* cell instance $197293 m0 *1 776.16,979.02
X$197293 VDD VSS sg13g2_decap_8
* cell instance $197294 m0 *1 766.08,941.22
X$197294 VDD VSS sg13g2_decap_8
* cell instance $197295 m0 *1 779.52,979.02
X$197295 VDD VSS sg13g2_decap_8
* cell instance $197296 m0 *1 772.8,971.46
X$197296 VDD VSS sg13g2_decap_8
* cell instance $197297 m0 *1 772.8,979.02
X$197297 VDD VSS sg13g2_decap_8
* cell instance $197298 m0 *1 772.8,963.9
X$197298 VDD VSS sg13g2_decap_8
* cell instance $197299 m0 *1 826.56,971.46
X$197299 VDD VSS sg13g2_decap_8
* cell instance $197300 m0 *1 826.56,963.9
X$197300 VDD VSS sg13g2_decap_8
* cell instance $197301 m0 *1 680.16,835.38
X$197301 VDD VSS sg13g2_decap_8
* cell instance $197302 m0 *1 683.52,835.38
X$197302 VDD VSS sg13g2_decap_8
* cell instance $197303 m0 *1 823.2,963.9
X$197303 VDD VSS sg13g2_decap_8
* cell instance $197304 m0 *1 786.24,979.02
X$197304 VDD VSS sg13g2_decap_8
* cell instance $197305 m0 *1 759.36,971.46
X$197305 VDD VSS sg13g2_decap_8
* cell instance $197306 m0 *1 766.08,963.9
X$197306 VDD VSS sg13g2_decap_8
* cell instance $197307 m0 *1 782.88,956.34
X$197307 VDD VSS sg13g2_decap_8
* cell instance $197308 m0 *1 833.28,933.66
X$197308 VDD VSS sg13g2_decap_8
* cell instance $197309 m0 *1 833.28,971.46
X$197309 VDD VSS sg13g2_decap_8
* cell instance $197310 m0 *1 792.96,941.22
X$197310 VDD VSS sg13g2_decap_8
* cell instance $197311 m0 *1 833.28,963.9
X$197311 VDD VSS sg13g2_decap_8
* cell instance $197312 m0 *1 769.44,963.9
X$197312 VDD VSS sg13g2_decap_8
* cell instance $197313 m0 *1 792.96,979.02
X$197313 VDD VSS sg13g2_decap_8
* cell instance $197314 m0 *1 792.96,963.9
X$197314 VDD VSS sg13g2_decap_8
* cell instance $197315 m0 *1 792.96,956.34
X$197315 VDD VSS sg13g2_decap_8
* cell instance $197316 m0 *1 766.08,971.46
X$197316 VDD VSS sg13g2_decap_8
* cell instance $197317 m0 *1 769.44,971.46
X$197317 VDD VSS sg13g2_decap_8
* cell instance $197318 m0 *1 792.96,948.78
X$197318 VDD VSS sg13g2_decap_8
* cell instance $197319 m0 *1 833.28,956.34
X$197319 VDD VSS sg13g2_decap_8
* cell instance $197320 m0 *1 792.96,933.66
X$197320 VDD VSS sg13g2_decap_8
* cell instance $197321 m0 *1 676.8,835.38
X$197321 VDD VSS sg13g2_decap_8
* cell instance $197322 m0 *1 766.08,979.02
X$197322 VDD VSS sg13g2_decap_8
* cell instance $197323 m0 *1 833.28,979.02
X$197323 VDD VSS sg13g2_decap_8
* cell instance $197324 m0 *1 796.32,979.02
X$197324 VDD VSS sg13g2_decap_8
* cell instance $197325 m0 *1 809.76,979.02
X$197325 VDD VSS sg13g2_decap_8
* cell instance $197326 m0 *1 799.68,979.02
X$197326 VDD VSS sg13g2_decap_8
* cell instance $197327 m0 *1 686.88,835.38
X$197327 VDD VSS sg13g2_decap_8
* cell instance $197328 m0 *1 816.48,979.02
X$197328 VDD VSS sg13g2_decap_8
* cell instance $197329 m0 *1 806.4,956.34
X$197329 VDD VSS sg13g2_decap_8
* cell instance $197330 m0 *1 819.84,979.02
X$197330 VDD VSS sg13g2_decap_8
* cell instance $197331 m0 *1 826.56,979.02
X$197331 VDD VSS sg13g2_decap_8
* cell instance $197332 m0 *1 809.76,956.34
X$197332 VDD VSS sg13g2_decap_8
* cell instance $197333 m0 *1 813.12,971.46
X$197333 VDD VSS sg13g2_decap_8
* cell instance $197334 m0 *1 813.12,963.9
X$197334 VDD VSS sg13g2_decap_8
* cell instance $197335 m0 *1 813.12,979.02
X$197335 VDD VSS sg13g2_decap_8
* cell instance $197336 m0 *1 826.56,956.34
X$197336 VDD VSS sg13g2_decap_8
* cell instance $197337 m0 *1 819.84,956.34
X$197337 VDD VSS sg13g2_decap_8
* cell instance $197338 m0 *1 813.12,956.34
X$197338 VDD VSS sg13g2_decap_8
* cell instance $197339 m0 *1 816.48,956.34
X$197339 VDD VSS sg13g2_decap_8
* cell instance $197340 m0 *1 796.32,956.34
X$197340 VDD VSS sg13g2_decap_8
* cell instance $197341 m0 *1 803.04,956.34
X$197341 VDD VSS sg13g2_decap_8
* cell instance $197342 m0 *1 823.2,979.02
X$197342 VDD VSS sg13g2_decap_8
* cell instance $197343 m0 *1 799.68,956.34
X$197343 VDD VSS sg13g2_decap_8
* cell instance $197344 m0 *1 816.48,963.9
X$197344 VDD VSS sg13g2_decap_8
* cell instance $197345 m0 *1 816.48,971.46
X$197345 VDD VSS sg13g2_decap_8
* cell instance $197346 m0 *1 819.84,971.46
X$197346 VDD VSS sg13g2_decap_8
* cell instance $197347 m0 *1 823.2,971.46
X$197347 VDD VSS sg13g2_decap_8
* cell instance $197348 m0 *1 819.84,963.9
X$197348 VDD VSS sg13g2_decap_8
* cell instance $197349 m0 *1 690.24,835.38
X$197349 VDD VSS sg13g2_decap_8
* cell instance $197350 m0 *1 799.68,963.9
X$197350 VDD VSS sg13g2_decap_8
* cell instance $197351 m0 *1 803.04,979.02
X$197351 VDD VSS sg13g2_decap_8
* cell instance $197352 m0 *1 799.68,971.46
X$197352 VDD VSS sg13g2_decap_8
* cell instance $197353 m0 *1 809.76,971.46
X$197353 VDD VSS sg13g2_decap_8
* cell instance $197354 m0 *1 809.76,963.9
X$197354 VDD VSS sg13g2_decap_8
* cell instance $197355 m0 *1 803.04,971.46
X$197355 VDD VSS sg13g2_decap_8
* cell instance $197356 m0 *1 806.4,971.46
X$197356 VDD VSS sg13g2_decap_8
* cell instance $197357 m0 *1 806.4,963.9
X$197357 VDD VSS sg13g2_decap_8
* cell instance $197358 m0 *1 796.32,963.9
X$197358 VDD VSS sg13g2_decap_8
* cell instance $197359 m0 *1 803.04,963.9
X$197359 VDD VSS sg13g2_decap_8
* cell instance $197360 m0 *1 806.4,979.02
X$197360 VDD VSS sg13g2_decap_8
* cell instance $197361 m0 *1 796.32,971.46
X$197361 VDD VSS sg13g2_decap_8
* cell instance $197362 m0 *1 759.36,933.66
X$197362 VDD VSS sg13g2_decap_8
* cell instance $197363 m0 *1 772.8,933.66
X$197363 VDD VSS sg13g2_decap_8
* cell instance $197364 m0 *1 776.16,933.66
X$197364 VDD VSS sg13g2_decap_8
* cell instance $197365 m0 *1 782.88,933.66
X$197365 VDD VSS sg13g2_decap_8
* cell instance $197366 m0 *1 786.24,933.66
X$197366 VDD VSS sg13g2_decap_8
* cell instance $197367 m0 *1 779.52,933.66
X$197367 VDD VSS sg13g2_decap_8
* cell instance $197368 m0 *1 752.64,956.34
X$197368 VDD VSS sg13g2_decap_8
* cell instance $197369 m0 *1 829.92,948.78
X$197369 VDD VSS sg13g2_decap_8
* cell instance $197370 m0 *1 762.72,971.46
X$197370 VDD VSS sg13g2_decap_8
* cell instance $197371 m0 *1 829.92,933.66
X$197371 VDD VSS sg13g2_decap_8
* cell instance $197372 m0 *1 829.92,971.46
X$197372 VDD VSS sg13g2_decap_8
* cell instance $197373 m0 *1 829.92,963.9
X$197373 VDD VSS sg13g2_decap_8
* cell instance $197374 m0 *1 829.92,979.02
X$197374 VDD VSS sg13g2_decap_8
* cell instance $197375 m0 *1 829.92,956.34
X$197375 VDD VSS sg13g2_decap_8
* cell instance $197376 m0 *1 752.64,963.9
X$197376 VDD VSS sg13g2_decap_8
* cell instance $197377 m0 *1 720.48,835.38
X$197377 VDD VSS sg13g2_decap_8
* cell instance $197378 m0 *1 693.6,835.38
X$197378 VDD VSS sg13g2_decap_8
* cell instance $197379 m0 *1 703.68,835.38
X$197379 VDD VSS sg13g2_decap_8
* cell instance $197380 m0 *1 829.92,941.22
X$197380 VDD VSS sg13g2_decap_8
* cell instance $197381 m0 *1 769.44,941.22
X$197381 VDD VSS sg13g2_decap_8
* cell instance $197382 m0 *1 713.76,835.38
X$197382 VDD VSS sg13g2_decap_8
* cell instance $197383 m0 *1 752.64,971.46
X$197383 VDD VSS sg13g2_decap_8
* cell instance $197384 m0 *1 717.12,835.38
X$197384 VDD VSS sg13g2_decap_8
* cell instance $197385 m0 *1 752.64,979.02
X$197385 VDD VSS sg13g2_decap_8
* cell instance $197386 m0 *1 756,941.22
X$197386 VDD VSS sg13g2_decap_8
* cell instance $197387 m0 *1 756,948.78
X$197387 VDD VSS sg13g2_decap_8
* cell instance $197388 m0 *1 759.36,948.78
X$197388 VDD VSS sg13g2_decap_8
* cell instance $197389 m0 *1 756,933.66
X$197389 VDD VSS sg13g2_decap_8
* cell instance $197390 m0 *1 786.24,941.22
X$197390 VDD VSS sg13g2_decap_8
* cell instance $197391 m0 *1 789.6,948.78
X$197391 VDD VSS sg13g2_decap_8
* cell instance $197392 m0 *1 779.52,948.78
X$197392 VDD VSS sg13g2_decap_8
* cell instance $197393 m0 *1 776.16,948.78
X$197393 VDD VSS sg13g2_decap_8
* cell instance $197394 m0 *1 779.52,941.22
X$197394 VDD VSS sg13g2_decap_8
* cell instance $197395 m0 *1 782.88,948.78
X$197395 VDD VSS sg13g2_decap_8
* cell instance $197396 m0 *1 786.24,948.78
X$197396 VDD VSS sg13g2_decap_8
* cell instance $197397 m0 *1 776.16,941.22
X$197397 VDD VSS sg13g2_decap_8
* cell instance $197398 m0 *1 782.88,941.22
X$197398 VDD VSS sg13g2_decap_8
* cell instance $197399 m0 *1 789.6,941.22
X$197399 VDD VSS sg13g2_decap_8
* cell instance $197400 m0 *1 782.88,971.46
X$197400 VDD VSS sg13g2_decap_8
* cell instance $197401 m0 *1 779.52,963.9
X$197401 VDD VSS sg13g2_decap_8
* cell instance $197402 m0 *1 776.16,971.46
X$197402 VDD VSS sg13g2_decap_8
* cell instance $197403 m0 *1 786.24,956.34
X$197403 VDD VSS sg13g2_decap_8
* cell instance $197404 m0 *1 782.88,963.9
X$197404 VDD VSS sg13g2_decap_8
* cell instance $197405 m0 *1 776.16,963.9
X$197405 VDD VSS sg13g2_decap_8
* cell instance $197406 m0 *1 786.24,963.9
X$197406 VDD VSS sg13g2_decap_8
* cell instance $197407 m0 *1 789.6,963.9
X$197407 VDD VSS sg13g2_decap_8
* cell instance $197408 m0 *1 700.32,835.38
X$197408 VDD VSS sg13g2_decap_8
* cell instance $197409 m0 *1 786.24,971.46
X$197409 VDD VSS sg13g2_decap_8
* cell instance $197410 m0 *1 707.04,835.38
X$197410 VDD VSS sg13g2_decap_8
* cell instance $197411 m0 *1 756,963.9
X$197411 VDD VSS sg13g2_decap_8
* cell instance $197412 m0 *1 759.36,963.9
X$197412 VDD VSS sg13g2_decap_8
* cell instance $197413 m0 *1 762.72,963.9
X$197413 VDD VSS sg13g2_decap_8
* cell instance $197414 m0 *1 756,971.46
X$197414 VDD VSS sg13g2_decap_8
* cell instance $197415 m0 *1 789.6,956.34
X$197415 VDD VSS sg13g2_decap_8
* cell instance $197416 m0 *1 779.52,956.34
X$197416 VDD VSS sg13g2_decap_8
* cell instance $197417 m0 *1 833.28,948.78
X$197417 VDD VSS sg13g2_decap_8
* cell instance $197418 m0 *1 789.6,971.46
X$197418 VDD VSS sg13g2_decap_8
* cell instance $197419 m0 *1 752.64,941.22
X$197419 VDD VSS sg13g2_decap_8
* cell instance $197420 m0 *1 823.2,956.34
X$197420 VDD VSS sg13g2_decap_8
* cell instance $197421 m0 *1 772.8,956.34
X$197421 VDD VSS sg13g2_decap_8
* cell instance $197422 m0 *1 756,956.34
X$197422 VDD VSS sg13g2_decap_8
* cell instance $197423 m0 *1 769.44,956.34
X$197423 VDD VSS sg13g2_decap_8
* cell instance $197424 m0 *1 696.96,835.38
X$197424 VDD VSS sg13g2_decap_8
* cell instance $197425 m0 *1 759.36,956.34
X$197425 VDD VSS sg13g2_decap_8
* cell instance $197426 m0 *1 710.4,835.38
X$197426 VDD VSS sg13g2_decap_8
* cell instance $197427 m0 *1 779.52,971.46
X$197427 VDD VSS sg13g2_decap_8
* cell instance $197428 m0 *1 766.08,956.34
X$197428 VDD VSS sg13g2_decap_8
* cell instance $197429 m0 *1 762.72,956.34
X$197429 VDD VSS sg13g2_decap_8
* cell instance $197430 m0 *1 789.6,933.66
X$197430 VDD VSS sg13g2_decap_8
* cell instance $197431 m0 *1 762.72,933.66
X$197431 VDD VSS sg13g2_decap_8
* cell instance $197432 m0 *1 769.44,933.66
X$197432 VDD VSS sg13g2_decap_8
* cell instance $197433 m0 *1 772.8,941.22
X$197433 VDD VSS sg13g2_decap_8
* cell instance $197434 m0 *1 772.8,948.78
X$197434 VDD VSS sg13g2_decap_8
* cell instance $197435 m0 *1 766.08,933.66
X$197435 VDD VSS sg13g2_decap_8
* cell instance $197436 m0 *1 776.16,956.34
X$197436 VDD VSS sg13g2_decap_8
* cell instance $197437 m0 *1 833.28,941.22
X$197437 VDD VSS sg13g2_decap_8
* cell instance $197438 m0 *1 873.6,963.9
X$197438 VDD VSS sg13g2_decap_8
* cell instance $197439 m0 *1 883.68,971.46
X$197439 VDD VSS sg13g2_decap_8
* cell instance $197440 m0 *1 883.68,963.9
X$197440 VDD VSS sg13g2_decap_8
* cell instance $197441 m0 *1 934.08,979.02
X$197441 VDD VSS sg13g2_decap_8
* cell instance $197442 m0 *1 944.16,979.02
X$197442 VDD VSS sg13g2_decap_8
* cell instance $197443 m0 *1 880.32,963.9
X$197443 VDD VSS sg13g2_decap_8
* cell instance $197444 m0 *1 880.32,971.46
X$197444 VDD VSS sg13g2_decap_8
* cell instance $197445 m0 *1 876.96,963.9
X$197445 VDD VSS sg13g2_decap_8
* cell instance $197446 m0 *1 920.64,956.34
X$197446 VDD VSS sg13g2_decap_8
* cell instance $197447 m0 *1 930.72,979.02
X$197447 VDD VSS sg13g2_decap_8
* cell instance $197448 m0 *1 930.72,963.9
X$197448 VDD VSS sg13g2_decap_8
* cell instance $197449 m0 *1 897.12,971.46
X$197449 VDD VSS sg13g2_decap_8
* cell instance $197450 m0 *1 903.84,963.9
X$197450 VDD VSS sg13g2_decap_8
* cell instance $197451 m0 *1 907.2,971.46
X$197451 VDD VSS sg13g2_decap_8
* cell instance $197452 m0 *1 903.84,971.46
X$197452 VDD VSS sg13g2_decap_8
* cell instance $197453 m0 *1 900.48,971.46
X$197453 VDD VSS sg13g2_decap_8
* cell instance $197454 m0 *1 893.76,971.46
X$197454 VDD VSS sg13g2_decap_8
* cell instance $197455 m0 *1 900.48,963.9
X$197455 VDD VSS sg13g2_decap_8
* cell instance $197456 m0 *1 927.36,971.46
X$197456 VDD VSS sg13g2_decap_8
* cell instance $197457 m0 *1 940.8,979.02
X$197457 VDD VSS sg13g2_decap_8
* cell instance $197458 m0 *1 883.68,979.02
X$197458 VDD VSS sg13g2_decap_8
* cell instance $197459 m0 *1 913.92,963.9
X$197459 VDD VSS sg13g2_decap_8
* cell instance $197460 m0 *1 873.6,971.46
X$197460 VDD VSS sg13g2_decap_8
* cell instance $197461 m0 *1 913.92,971.46
X$197461 VDD VSS sg13g2_decap_8
* cell instance $197462 m0 *1 920.64,971.46
X$197462 VDD VSS sg13g2_decap_8
* cell instance $197463 m0 *1 887.04,971.46
X$197463 VDD VSS sg13g2_decap_8
* cell instance $197464 m0 *1 924,979.02
X$197464 VDD VSS sg13g2_decap_8
* cell instance $197465 m0 *1 920.64,963.9
X$197465 VDD VSS sg13g2_decap_8
* cell instance $197466 m0 *1 927.36,979.02
X$197466 VDD VSS sg13g2_decap_8
* cell instance $197467 m0 *1 937.44,979.02
X$197467 VDD VSS sg13g2_decap_8
* cell instance $197468 m0 *1 947.52,979.02
X$197468 VDD VSS sg13g2_decap_8
* cell instance $197469 m0 *1 913.92,979.02
X$197469 VDD VSS sg13g2_decap_8
* cell instance $197470 m0 *1 887.04,963.9
X$197470 VDD VSS sg13g2_decap_8
* cell instance $197471 m0 *1 876.96,971.46
X$197471 VDD VSS sg13g2_decap_8
* cell instance $197472 m0 *1 917.28,979.02
X$197472 VDD VSS sg13g2_decap_8
* cell instance $197473 m0 *1 920.64,979.02
X$197473 VDD VSS sg13g2_decap_8
* cell instance $197474 m0 *1 924,971.46
X$197474 VDD VSS sg13g2_decap_8
* cell instance $197475 m0 *1 675.84,782.46
X$197475 VDD VSS sg13g2_decap_8
* cell instance $197476 m0 *1 676.8,790.02
X$197476 VDD VSS sg13g2_decap_8
* cell instance $197477 m0 *1 710.4,790.02
X$197477 VDD VSS sg13g2_decap_8
* cell instance $197478 m0 *1 706.08,782.46
X$197478 VDD VSS sg13g2_decap_8
* cell instance $197479 m0 *1 863.52,979.02
X$197479 VDD VSS sg13g2_decap_8
* cell instance $197480 m0 *1 856.8,979.02
X$197480 VDD VSS sg13g2_decap_8
* cell instance $197481 m0 *1 860.16,979.02
X$197481 VDD VSS sg13g2_decap_8
* cell instance $197482 m0 *1 866.88,979.02
X$197482 VDD VSS sg13g2_decap_8
* cell instance $197483 m0 *1 897.12,963.9
X$197483 VDD VSS sg13g2_decap_8
* cell instance $197484 m0 *1 843.36,979.02
X$197484 VDD VSS sg13g2_decap_8
* cell instance $197485 m0 *1 702.72,782.46
X$197485 VDD VSS sg13g2_decap_8
* cell instance $197486 m0 *1 686.88,790.02
X$197486 VDD VSS sg13g2_decap_8
* cell instance $197487 m0 *1 699.36,782.46
X$197487 VDD VSS sg13g2_decap_8
* cell instance $197488 m0 *1 840,979.02
X$197488 VDD VSS sg13g2_decap_8
* cell instance $197489 m0 *1 836.64,979.02
X$197489 VDD VSS sg13g2_decap_8
* cell instance $197490 m0 *1 692.64,782.46
X$197490 VDD VSS sg13g2_decap_8
* cell instance $197491 m0 *1 689.28,782.46
X$197491 VDD VSS sg13g2_decap_8
* cell instance $197492 m0 *1 693.6,790.02
X$197492 VDD VSS sg13g2_decap_8
* cell instance $197493 m0 *1 974.4,971.46
X$197493 VDD VSS sg13g2_decap_8
* cell instance $197494 m0 *1 981.12,963.9
X$197494 VDD VSS sg13g2_decap_8
* cell instance $197495 m0 *1 907.2,963.9
X$197495 VDD VSS sg13g2_decap_8
* cell instance $197496 m0 *1 977.76,971.46
X$197496 VDD VSS sg13g2_decap_8
* cell instance $197497 m0 *1 981.12,971.46
X$197497 VDD VSS sg13g2_decap_8
* cell instance $197498 m0 *1 893.76,963.9
X$197498 VDD VSS sg13g2_decap_8
* cell instance $197499 m0 *1 850.08,963.9
X$197499 VDD VSS sg13g2_decap_8
* cell instance $197500 m0 *1 850.08,971.46
X$197500 VDD VSS sg13g2_decap_8
* cell instance $197501 m0 *1 850.08,979.02
X$197501 VDD VSS sg13g2_decap_8
* cell instance $197502 m0 *1 685.92,782.46
X$197502 VDD VSS sg13g2_decap_8
* cell instance $197503 m0 *1 974.4,963.9
X$197503 VDD VSS sg13g2_decap_8
* cell instance $197504 m0 *1 853.44,979.02
X$197504 VDD VSS sg13g2_decap_8
* cell instance $197505 m0 *1 853.44,971.46
X$197505 VDD VSS sg13g2_decap_8
* cell instance $197506 m0 *1 853.44,963.9
X$197506 VDD VSS sg13g2_decap_8
* cell instance $197507 m0 *1 709.44,782.46
X$197507 VDD VSS sg13g2_decap_8
* cell instance $197508 m0 *1 700.32,790.02
X$197508 VDD VSS sg13g2_decap_8
* cell instance $197509 m0 *1 683.52,790.02
X$197509 VDD VSS sg13g2_decap_8
* cell instance $197510 m0 *1 680.16,790.02
X$197510 VDD VSS sg13g2_decap_8
* cell instance $197511 m0 *1 696.96,790.02
X$197511 VDD VSS sg13g2_decap_8
* cell instance $197512 m0 *1 977.76,963.9
X$197512 VDD VSS sg13g2_decap_8
* cell instance $197513 m0 *1 927.36,948.78
X$197513 VDD VSS sg13g2_decap_8
* cell instance $197514 m0 *1 930.72,941.22
X$197514 VDD VSS sg13g2_decap_8
* cell instance $197515 m0 *1 913.92,948.78
X$197515 VDD VSS sg13g2_decap_8
* cell instance $197516 m0 *1 913.92,933.66
X$197516 VDD VSS sg13g2_decap_8
* cell instance $197517 m0 *1 930.72,948.78
X$197517 VDD VSS sg13g2_decap_8
* cell instance $197518 m0 *1 930.72,933.66
X$197518 VDD VSS sg13g2_decap_8
* cell instance $197519 m0 *1 947.52,933.66
X$197519 VDD VSS sg13g2_decap_8
* cell instance $197520 m0 *1 913.92,941.22
X$197520 VDD VSS sg13g2_decap_8
* cell instance $197521 m0 *1 890.4,963.9
X$197521 VDD VSS sg13g2_decap_8
* cell instance $197522 m0 *1 934.08,941.22
X$197522 VDD VSS sg13g2_decap_8
* cell instance $197523 m0 *1 947.52,948.78
X$197523 VDD VSS sg13g2_decap_8
* cell instance $197524 m0 *1 934.08,948.78
X$197524 VDD VSS sg13g2_decap_8
* cell instance $197525 m0 *1 937.44,948.78
X$197525 VDD VSS sg13g2_decap_8
* cell instance $197526 m0 *1 940.8,948.78
X$197526 VDD VSS sg13g2_decap_8
* cell instance $197527 m0 *1 944.16,948.78
X$197527 VDD VSS sg13g2_decap_8
* cell instance $197528 m0 *1 947.52,941.22
X$197528 VDD VSS sg13g2_decap_8
* cell instance $197529 m0 *1 927.36,933.66
X$197529 VDD VSS sg13g2_decap_8
* cell instance $197530 m0 *1 917.28,933.66
X$197530 VDD VSS sg13g2_decap_8
* cell instance $197531 m0 *1 934.08,933.66
X$197531 VDD VSS sg13g2_decap_8
* cell instance $197532 m0 *1 974.4,948.78
X$197532 VDD VSS sg13g2_decap_8
* cell instance $197533 m0 *1 974.4,941.22
X$197533 VDD VSS sg13g2_decap_8
* cell instance $197534 m0 *1 981.12,941.22
X$197534 VDD VSS sg13g2_decap_8
* cell instance $197535 m0 *1 977.76,941.22
X$197535 VDD VSS sg13g2_decap_8
* cell instance $197536 m0 *1 977.76,948.78
X$197536 VDD VSS sg13g2_decap_8
* cell instance $197537 m0 *1 981.12,948.78
X$197537 VDD VSS sg13g2_decap_8
* cell instance $197538 m0 *1 974.4,933.66
X$197538 VDD VSS sg13g2_decap_8
* cell instance $197539 m0 *1 981.12,933.66
X$197539 VDD VSS sg13g2_decap_8
* cell instance $197540 m0 *1 924,933.66
X$197540 VDD VSS sg13g2_decap_8
* cell instance $197541 m0 *1 971.04,948.78
X$197541 VDD VSS sg13g2_decap_8
* cell instance $197542 m0 *1 971.04,941.22
X$197542 VDD VSS sg13g2_decap_8
* cell instance $197543 m0 *1 977.76,933.66
X$197543 VDD VSS sg13g2_decap_8
* cell instance $197544 m0 *1 960.96,933.66
X$197544 VDD VSS sg13g2_decap_8
* cell instance $197545 m0 *1 957.6,933.66
X$197545 VDD VSS sg13g2_decap_8
* cell instance $197546 m0 *1 967.68,933.66
X$197546 VDD VSS sg13g2_decap_8
* cell instance $197547 m0 *1 954.24,933.66
X$197547 VDD VSS sg13g2_decap_8
* cell instance $197548 m0 *1 964.32,933.66
X$197548 VDD VSS sg13g2_decap_8
* cell instance $197549 m0 *1 920.64,933.66
X$197549 VDD VSS sg13g2_decap_8
* cell instance $197550 m0 *1 971.04,933.66
X$197550 VDD VSS sg13g2_decap_8
* cell instance $197551 m0 *1 947.52,963.9
X$197551 VDD VSS sg13g2_decap_8
* cell instance $197552 m0 *1 934.08,971.46
X$197552 VDD VSS sg13g2_decap_8
* cell instance $197553 m0 *1 940.8,971.46
X$197553 VDD VSS sg13g2_decap_8
* cell instance $197554 m0 *1 940.8,963.9
X$197554 VDD VSS sg13g2_decap_8
* cell instance $197555 m0 *1 917.28,971.46
X$197555 VDD VSS sg13g2_decap_8
* cell instance $197556 m0 *1 903.84,979.02
X$197556 VDD VSS sg13g2_decap_8
* cell instance $197557 m0 *1 900.48,979.02
X$197557 VDD VSS sg13g2_decap_8
* cell instance $197558 m0 *1 907.2,979.02
X$197558 VDD VSS sg13g2_decap_8
* cell instance $197559 m0 *1 937.44,941.22
X$197559 VDD VSS sg13g2_decap_8
* cell instance $197560 m0 *1 917.28,963.9
X$197560 VDD VSS sg13g2_decap_8
* cell instance $197561 m0 *1 927.36,963.9
X$197561 VDD VSS sg13g2_decap_8
* cell instance $197562 m0 *1 870.24,971.46
X$197562 VDD VSS sg13g2_decap_8
* cell instance $197563 m0 *1 880.32,979.02
X$197563 VDD VSS sg13g2_decap_8
* cell instance $197564 m0 *1 890.4,971.46
X$197564 VDD VSS sg13g2_decap_8
* cell instance $197565 m0 *1 876.96,979.02
X$197565 VDD VSS sg13g2_decap_8
* cell instance $197566 m0 *1 890.4,979.02
X$197566 VDD VSS sg13g2_decap_8
* cell instance $197567 m0 *1 887.04,979.02
X$197567 VDD VSS sg13g2_decap_8
* cell instance $197568 m0 *1 873.6,979.02
X$197568 VDD VSS sg13g2_decap_8
* cell instance $197569 m0 *1 924,963.9
X$197569 VDD VSS sg13g2_decap_8
* cell instance $197570 m0 *1 944.16,941.22
X$197570 VDD VSS sg13g2_decap_8
* cell instance $197571 m0 *1 940.8,933.66
X$197571 VDD VSS sg13g2_decap_8
* cell instance $197572 m0 *1 937.44,933.66
X$197572 VDD VSS sg13g2_decap_8
* cell instance $197573 m0 *1 927.36,941.22
X$197573 VDD VSS sg13g2_decap_8
* cell instance $197574 m0 *1 917.28,941.22
X$197574 VDD VSS sg13g2_decap_8
* cell instance $197575 m0 *1 944.16,933.66
X$197575 VDD VSS sg13g2_decap_8
* cell instance $197576 m0 *1 920.64,941.22
X$197576 VDD VSS sg13g2_decap_8
* cell instance $197577 m0 *1 924,941.22
X$197577 VDD VSS sg13g2_decap_8
* cell instance $197578 m0 *1 937.44,963.9
X$197578 VDD VSS sg13g2_decap_8
* cell instance $197579 m0 *1 917.28,948.78
X$197579 VDD VSS sg13g2_decap_8
* cell instance $197580 m0 *1 924,948.78
X$197580 VDD VSS sg13g2_decap_8
* cell instance $197581 m0 *1 940.8,941.22
X$197581 VDD VSS sg13g2_decap_8
* cell instance $197582 m0 *1 930.72,971.46
X$197582 VDD VSS sg13g2_decap_8
* cell instance $197583 m0 *1 934.08,963.9
X$197583 VDD VSS sg13g2_decap_8
* cell instance $197584 m0 *1 944.16,971.46
X$197584 VDD VSS sg13g2_decap_8
* cell instance $197585 m0 *1 937.44,971.46
X$197585 VDD VSS sg13g2_decap_8
* cell instance $197586 m0 *1 947.52,971.46
X$197586 VDD VSS sg13g2_decap_8
* cell instance $197587 m0 *1 944.16,963.9
X$197587 VDD VSS sg13g2_decap_8
* cell instance $197588 m0 *1 920.64,948.78
X$197588 VDD VSS sg13g2_decap_8
* cell instance $197589 m0 *1 680.16,827.82
X$197589 VDD VSS sg13g2_decap_8
* cell instance $197590 m0 *1 897.12,933.66
X$197590 VDD VSS sg13g2_decap_8
* cell instance $197591 m0 *1 873.6,933.66
X$197591 VDD VSS sg13g2_decap_8
* cell instance $197592 m0 *1 907.2,933.66
X$197592 VDD VSS sg13g2_decap_8
* cell instance $197593 m0 *1 903.84,933.66
X$197593 VDD VSS sg13g2_decap_8
* cell instance $197594 m0 *1 883.68,933.66
X$197594 VDD VSS sg13g2_decap_8
* cell instance $197595 m0 *1 876.96,933.66
X$197595 VDD VSS sg13g2_decap_8
* cell instance $197596 m0 *1 683.52,827.82
X$197596 VDD VSS sg13g2_decap_8
* cell instance $197597 m0 *1 846.72,979.02
X$197597 VDD VSS sg13g2_decap_8
* cell instance $197598 m0 *1 686.88,827.82
X$197598 VDD VSS sg13g2_decap_8
* cell instance $197599 m0 *1 690.24,827.82
X$197599 VDD VSS sg13g2_decap_8
* cell instance $197600 m0 *1 971.04,963.9
X$197600 VDD VSS sg13g2_decap_8
* cell instance $197601 m0 *1 880.32,933.66
X$197601 VDD VSS sg13g2_decap_8
* cell instance $197602 m0 *1 893.76,933.66
X$197602 VDD VSS sg13g2_decap_8
* cell instance $197603 m0 *1 680.16,820.26
X$197603 VDD VSS sg13g2_decap_8
* cell instance $197604 m0 *1 683.52,820.26
X$197604 VDD VSS sg13g2_decap_8
* cell instance $197605 m0 *1 686.88,820.26
X$197605 VDD VSS sg13g2_decap_8
* cell instance $197606 m0 *1 900.48,933.66
X$197606 VDD VSS sg13g2_decap_8
* cell instance $197607 m0 *1 971.04,971.46
X$197607 VDD VSS sg13g2_decap_8
* cell instance $197608 m0 *1 853.44,941.22
X$197608 VDD VSS sg13g2_decap_8
* cell instance $197609 m0 *1 863.52,941.22
X$197609 VDD VSS sg13g2_decap_8
* cell instance $197610 m0 *1 863.52,948.78
X$197610 VDD VSS sg13g2_decap_8
* cell instance $197611 m0 *1 860.16,941.22
X$197611 VDD VSS sg13g2_decap_8
* cell instance $197612 m0 *1 856.8,948.78
X$197612 VDD VSS sg13g2_decap_8
* cell instance $197613 m0 *1 853.44,948.78
X$197613 VDD VSS sg13g2_decap_8
* cell instance $197614 m0 *1 860.16,948.78
X$197614 VDD VSS sg13g2_decap_8
* cell instance $197615 m0 *1 840,948.78
X$197615 VDD VSS sg13g2_decap_8
* cell instance $197616 m0 *1 971.04,979.02
X$197616 VDD VSS sg13g2_decap_8
* cell instance $197617 m0 *1 843.36,941.22
X$197617 VDD VSS sg13g2_decap_8
* cell instance $197618 m0 *1 690.24,820.26
X$197618 VDD VSS sg13g2_decap_8
* cell instance $197619 m0 *1 974.4,979.02
X$197619 VDD VSS sg13g2_decap_8
* cell instance $197620 m0 *1 836.64,941.22
X$197620 VDD VSS sg13g2_decap_8
* cell instance $197621 m0 *1 890.4,933.66
X$197621 VDD VSS sg13g2_decap_8
* cell instance $197622 m0 *1 887.04,933.66
X$197622 VDD VSS sg13g2_decap_8
* cell instance $197623 m0 *1 676.8,827.82
X$197623 VDD VSS sg13g2_decap_8
* cell instance $197624 m0 *1 890.4,941.22
X$197624 VDD VSS sg13g2_decap_8
* cell instance $197625 m0 *1 981.12,979.02
X$197625 VDD VSS sg13g2_decap_8
* cell instance $197626 m0 *1 840,941.22
X$197626 VDD VSS sg13g2_decap_8
* cell instance $197627 m0 *1 900.48,941.22
X$197627 VDD VSS sg13g2_decap_8
* cell instance $197628 m0 *1 934.08,956.34
X$197628 VDD VSS sg13g2_decap_8
* cell instance $197629 m0 *1 907.2,948.78
X$197629 VDD VSS sg13g2_decap_8
* cell instance $197630 m0 *1 903.84,948.78
X$197630 VDD VSS sg13g2_decap_8
* cell instance $197631 m0 *1 897.12,941.22
X$197631 VDD VSS sg13g2_decap_8
* cell instance $197632 m0 *1 937.44,956.34
X$197632 VDD VSS sg13g2_decap_8
* cell instance $197633 m0 *1 897.12,948.78
X$197633 VDD VSS sg13g2_decap_8
* cell instance $197634 m0 *1 900.48,948.78
X$197634 VDD VSS sg13g2_decap_8
* cell instance $197635 m0 *1 890.4,948.78
X$197635 VDD VSS sg13g2_decap_8
* cell instance $197636 m0 *1 893.76,948.78
X$197636 VDD VSS sg13g2_decap_8
* cell instance $197637 m0 *1 927.36,956.34
X$197637 VDD VSS sg13g2_decap_8
* cell instance $197638 m0 *1 913.92,956.34
X$197638 VDD VSS sg13g2_decap_8
* cell instance $197639 m0 *1 876.96,948.78
X$197639 VDD VSS sg13g2_decap_8
* cell instance $197640 m0 *1 876.96,941.22
X$197640 VDD VSS sg13g2_decap_8
* cell instance $197641 m0 *1 880.32,948.78
X$197641 VDD VSS sg13g2_decap_8
* cell instance $197642 m0 *1 873.6,941.22
X$197642 VDD VSS sg13g2_decap_8
* cell instance $197643 m0 *1 873.6,948.78
X$197643 VDD VSS sg13g2_decap_8
* cell instance $197644 m0 *1 917.28,956.34
X$197644 VDD VSS sg13g2_decap_8
* cell instance $197645 m0 *1 947.52,956.34
X$197645 VDD VSS sg13g2_decap_8
* cell instance $197646 m0 *1 950.88,941.22
X$197646 VDD VSS sg13g2_decap_8
* cell instance $197647 m0 *1 907.2,941.22
X$197647 VDD VSS sg13g2_decap_8
* cell instance $197648 m0 *1 903.84,941.22
X$197648 VDD VSS sg13g2_decap_8
* cell instance $197649 m0 *1 950.88,956.34
X$197649 VDD VSS sg13g2_decap_8
* cell instance $197650 m0 *1 676.8,820.26
X$197650 VDD VSS sg13g2_decap_8
* cell instance $197651 m0 *1 950.88,963.9
X$197651 VDD VSS sg13g2_decap_8
* cell instance $197652 m0 *1 940.8,956.34
X$197652 VDD VSS sg13g2_decap_8
* cell instance $197653 m0 *1 710.4,827.82
X$197653 VDD VSS sg13g2_decap_8
* cell instance $197654 m0 *1 944.16,956.34
X$197654 VDD VSS sg13g2_decap_8
* cell instance $197655 m0 *1 700.32,820.26
X$197655 VDD VSS sg13g2_decap_8
* cell instance $197656 m0 *1 703.68,820.26
X$197656 VDD VSS sg13g2_decap_8
* cell instance $197657 m0 *1 707.04,820.26
X$197657 VDD VSS sg13g2_decap_8
* cell instance $197658 m0 *1 700.32,827.82
X$197658 VDD VSS sg13g2_decap_8
* cell instance $197659 m0 *1 707.04,827.82
X$197659 VDD VSS sg13g2_decap_8
* cell instance $197660 m0 *1 703.68,827.82
X$197660 VDD VSS sg13g2_decap_8
* cell instance $197661 m0 *1 696.96,827.82
X$197661 VDD VSS sg13g2_decap_8
* cell instance $197662 m0 *1 710.4,820.26
X$197662 VDD VSS sg13g2_decap_8
* cell instance $197663 m0 *1 893.76,941.22
X$197663 VDD VSS sg13g2_decap_8
* cell instance $197664 m0 *1 696.96,820.26
X$197664 VDD VSS sg13g2_decap_8
* cell instance $197665 m0 *1 700.32,812.7
X$197665 VDD VSS sg13g2_decap_8
* cell instance $197666 m0 *1 696.96,805.14
X$197666 VDD VSS sg13g2_decap_8
* cell instance $197667 m0 *1 703.68,805.14
X$197667 VDD VSS sg13g2_decap_8
* cell instance $197668 m0 *1 710.4,805.14
X$197668 VDD VSS sg13g2_decap_8
* cell instance $197669 m0 *1 967.68,971.46
X$197669 VDD VSS sg13g2_decap_8
* cell instance $197670 m0 *1 690.24,812.7
X$197670 VDD VSS sg13g2_decap_8
* cell instance $197671 m0 *1 960.96,963.9
X$197671 VDD VSS sg13g2_decap_8
* cell instance $197672 m0 *1 957.6,979.02
X$197672 VDD VSS sg13g2_decap_8
* cell instance $197673 m0 *1 853.44,933.66
X$197673 VDD VSS sg13g2_decap_8
* cell instance $197674 m0 *1 960.96,979.02
X$197674 VDD VSS sg13g2_decap_8
* cell instance $197675 m0 *1 964.32,979.02
X$197675 VDD VSS sg13g2_decap_8
* cell instance $197676 m0 *1 954.24,979.02
X$197676 VDD VSS sg13g2_decap_8
* cell instance $197677 m0 *1 686.88,812.7
X$197677 VDD VSS sg13g2_decap_8
* cell instance $197678 m0 *1 840,971.46
X$197678 VDD VSS sg13g2_decap_8
* cell instance $197679 m0 *1 836.64,971.46
X$197679 VDD VSS sg13g2_decap_8
* cell instance $197680 m0 *1 840,963.9
X$197680 VDD VSS sg13g2_decap_8
* cell instance $197681 m0 *1 846.72,963.9
X$197681 VDD VSS sg13g2_decap_8
* cell instance $197682 m0 *1 843.36,971.46
X$197682 VDD VSS sg13g2_decap_8
* cell instance $197683 m0 *1 967.68,979.02
X$197683 VDD VSS sg13g2_decap_8
* cell instance $197684 m0 *1 967.68,963.9
X$197684 VDD VSS sg13g2_decap_8
* cell instance $197685 m0 *1 954.24,963.9
X$197685 VDD VSS sg13g2_decap_8
* cell instance $197686 m0 *1 707.04,790.02
X$197686 VDD VSS sg13g2_decap_8
* cell instance $197687 m0 *1 957.6,963.9
X$197687 VDD VSS sg13g2_decap_8
* cell instance $197688 m0 *1 964.32,963.9
X$197688 VDD VSS sg13g2_decap_8
* cell instance $197689 m0 *1 696,782.46
X$197689 VDD VSS sg13g2_decap_8
* cell instance $197690 m0 *1 682.56,782.46
X$197690 VDD VSS sg13g2_decap_8
* cell instance $197691 m0 *1 690.24,790.02
X$197691 VDD VSS sg13g2_decap_8
* cell instance $197692 m0 *1 707.04,805.14
X$197692 VDD VSS sg13g2_decap_8
* cell instance $197693 m0 *1 954.24,971.46
X$197693 VDD VSS sg13g2_decap_8
* cell instance $197694 m0 *1 957.6,971.46
X$197694 VDD VSS sg13g2_decap_8
* cell instance $197695 m0 *1 960.96,971.46
X$197695 VDD VSS sg13g2_decap_8
* cell instance $197696 m0 *1 964.32,971.46
X$197696 VDD VSS sg13g2_decap_8
* cell instance $197697 m0 *1 710.4,812.7
X$197697 VDD VSS sg13g2_decap_8
* cell instance $197698 m0 *1 696.96,812.7
X$197698 VDD VSS sg13g2_decap_8
* cell instance $197699 m0 *1 707.04,812.7
X$197699 VDD VSS sg13g2_decap_8
* cell instance $197700 m0 *1 700.32,805.14
X$197700 VDD VSS sg13g2_decap_8
* cell instance $197701 m0 *1 703.68,812.7
X$197701 VDD VSS sg13g2_decap_8
* cell instance $197702 m0 *1 703.68,790.02
X$197702 VDD VSS sg13g2_decap_8
* cell instance $197703 m0 *1 680.16,812.7
X$197703 VDD VSS sg13g2_decap_8
* cell instance $197704 m0 *1 676.8,812.7
X$197704 VDD VSS sg13g2_decap_8
* cell instance $197705 m0 *1 683.52,812.7
X$197705 VDD VSS sg13g2_decap_8
* cell instance $197706 m0 *1 683.52,805.14
X$197706 VDD VSS sg13g2_decap_8
* cell instance $197707 m0 *1 686.88,805.14
X$197707 VDD VSS sg13g2_decap_8
* cell instance $197708 m0 *1 860.16,933.66
X$197708 VDD VSS sg13g2_decap_8
* cell instance $197709 m0 *1 843.36,933.66
X$197709 VDD VSS sg13g2_decap_8
* cell instance $197710 m0 *1 977.76,979.02
X$197710 VDD VSS sg13g2_decap_8
* cell instance $197711 m0 *1 836.64,963.9
X$197711 VDD VSS sg13g2_decap_8
* cell instance $197712 m0 *1 850.08,941.22
X$197712 VDD VSS sg13g2_decap_8
* cell instance $197713 m0 *1 690.24,805.14
X$197713 VDD VSS sg13g2_decap_8
* cell instance $197714 m0 *1 836.64,933.66
X$197714 VDD VSS sg13g2_decap_8
* cell instance $197715 m0 *1 863.52,933.66
X$197715 VDD VSS sg13g2_decap_8
* cell instance $197716 m0 *1 866.88,941.22
X$197716 VDD VSS sg13g2_decap_8
* cell instance $197717 m0 *1 866.88,948.78
X$197717 VDD VSS sg13g2_decap_8
* cell instance $197718 m0 *1 856.8,941.22
X$197718 VDD VSS sg13g2_decap_8
* cell instance $197719 m0 *1 840,933.66
X$197719 VDD VSS sg13g2_decap_8
* cell instance $197720 m0 *1 850.08,933.66
X$197720 VDD VSS sg13g2_decap_8
* cell instance $197721 m0 *1 866.88,933.66
X$197721 VDD VSS sg13g2_decap_8
* cell instance $197722 m0 *1 846.72,971.46
X$197722 VDD VSS sg13g2_decap_8
* cell instance $197723 m0 *1 843.36,963.9
X$197723 VDD VSS sg13g2_decap_8
* cell instance $197724 m0 *1 866.88,963.9
X$197724 VDD VSS sg13g2_decap_8
* cell instance $197725 m0 *1 866.88,971.46
X$197725 VDD VSS sg13g2_decap_8
* cell instance $197726 m0 *1 863.52,971.46
X$197726 VDD VSS sg13g2_decap_8
* cell instance $197727 m0 *1 856.8,971.46
X$197727 VDD VSS sg13g2_decap_8
* cell instance $197728 m0 *1 856.8,963.9
X$197728 VDD VSS sg13g2_decap_8
* cell instance $197729 m0 *1 860.16,963.9
X$197729 VDD VSS sg13g2_decap_8
* cell instance $197730 m0 *1 836.64,948.78
X$197730 VDD VSS sg13g2_decap_8
* cell instance $197731 m0 *1 863.52,963.9
X$197731 VDD VSS sg13g2_decap_8
* cell instance $197732 m0 *1 850.08,948.78
X$197732 VDD VSS sg13g2_decap_8
* cell instance $197733 m0 *1 856.8,933.66
X$197733 VDD VSS sg13g2_decap_8
* cell instance $197734 m0 *1 846.72,933.66
X$197734 VDD VSS sg13g2_decap_8
* cell instance $197735 m0 *1 676.8,805.14
X$197735 VDD VSS sg13g2_decap_8
* cell instance $197736 m0 *1 680.16,805.14
X$197736 VDD VSS sg13g2_decap_8
* cell instance $197737 m0 *1 843.36,948.78
X$197737 VDD VSS sg13g2_decap_8
* cell instance $197738 m0 *1 846.72,941.22
X$197738 VDD VSS sg13g2_decap_8
* cell instance $197739 m0 *1 846.72,948.78
X$197739 VDD VSS sg13g2_decap_8
* cell instance $197740 m0 *1 860.16,971.46
X$197740 VDD VSS sg13g2_decap_8
* cell instance $197741 m0 *1 736.32,396.9
X$197741 VDD VSS sg13g2_decap_8
* cell instance $197742 m0 *1 820.32,381.78
X$197742 VDD VSS sg13g2_decap_8
* cell instance $197743 m0 *1 820.32,389.34
X$197743 VDD VSS sg13g2_decap_8
* cell instance $197744 m0 *1 749.76,396.9
X$197744 VDD VSS sg13g2_decap_8
* cell instance $197745 m0 *1 823.68,389.34
X$197745 VDD VSS sg13g2_decap_8
* cell instance $197746 m0 *1 712.8,381.78
X$197746 VDD VSS sg13g2_decap_8
* cell instance $197747 m0 *1 464.16,374.22
X$197747 VDD VSS sg13g2_decap_8
* cell instance $197748 m0 *1 806.88,381.78
X$197748 VDD VSS sg13g2_decap_8
* cell instance $197749 m0 *1 606.24,827.82
X$197749 VDD VSS sg13g2_decap_8
* cell instance $197750 m0 *1 609.6,820.26
X$197750 VDD VSS sg13g2_decap_8
* cell instance $197751 m0 *1 596.16,827.82
X$197751 VDD VSS sg13g2_decap_8
* cell instance $197752 m0 *1 716.16,396.9
X$197752 VDD VSS sg13g2_decap_8
* cell instance $197753 m0 *1 841.44,412.02
X$197753 VDD VSS sg13g2_decap_8
* cell instance $197754 m0 *1 803.52,381.78
X$197754 VDD VSS sg13g2_decap_8
* cell instance $197755 m0 *1 599.52,827.82
X$197755 VDD VSS sg13g2_decap_8
* cell instance $197756 m0 *1 457.44,374.22
X$197756 VDD VSS sg13g2_decap_8
* cell instance $197757 m0 *1 712.8,374.22
X$197757 VDD VSS sg13g2_decap_8
* cell instance $197758 m0 *1 800.16,389.34
X$197758 VDD VSS sg13g2_decap_8
* cell instance $197759 m0 *1 806.88,389.34
X$197759 VDD VSS sg13g2_decap_8
* cell instance $197760 m0 *1 796.8,389.34
X$197760 VDD VSS sg13g2_decap_8
* cell instance $197761 m0 *1 803.52,389.34
X$197761 VDD VSS sg13g2_decap_8
* cell instance $197762 m0 *1 800.16,381.78
X$197762 VDD VSS sg13g2_decap_8
* cell instance $197763 m0 *1 796.8,381.78
X$197763 VDD VSS sg13g2_decap_8
* cell instance $197764 m0 *1 616.32,827.82
X$197764 VDD VSS sg13g2_decap_8
* cell instance $197765 m0 *1 623.04,827.82
X$197765 VDD VSS sg13g2_decap_8
* cell instance $197766 m0 *1 803.52,374.22
X$197766 VDD VSS sg13g2_decap_8
* cell instance $197767 m0 *1 609.6,827.82
X$197767 VDD VSS sg13g2_decap_8
* cell instance $197768 m0 *1 810.24,381.78
X$197768 VDD VSS sg13g2_decap_8
* cell instance $197769 m0 *1 606.24,812.7
X$197769 VDD VSS sg13g2_decap_8
* cell instance $197770 m0 *1 602.88,812.7
X$197770 VDD VSS sg13g2_decap_8
* cell instance $197771 m0 *1 743.04,396.9
X$197771 VDD VSS sg13g2_decap_8
* cell instance $197772 m0 *1 746.4,396.9
X$197772 VDD VSS sg13g2_decap_8
* cell instance $197773 m0 *1 609.6,805.14
X$197773 VDD VSS sg13g2_decap_8
* cell instance $197774 m0 *1 729.6,396.9
X$197774 VDD VSS sg13g2_decap_8
* cell instance $197775 m0 *1 719.52,396.9
X$197775 VDD VSS sg13g2_decap_8
* cell instance $197776 m0 *1 596.16,812.7
X$197776 VDD VSS sg13g2_decap_8
* cell instance $197777 m0 *1 596.16,805.14
X$197777 VDD VSS sg13g2_decap_8
* cell instance $197778 m0 *1 816.96,381.78
X$197778 VDD VSS sg13g2_decap_8
* cell instance $197779 m0 *1 599.52,805.14
X$197779 VDD VSS sg13g2_decap_8
* cell instance $197780 m0 *1 732.96,396.9
X$197780 VDD VSS sg13g2_decap_8
* cell instance $197781 m0 *1 606.24,820.26
X$197781 VDD VSS sg13g2_decap_8
* cell instance $197782 m0 *1 722.88,396.9
X$197782 VDD VSS sg13g2_decap_8
* cell instance $197783 m0 *1 827.04,389.34
X$197783 VDD VSS sg13g2_decap_8
* cell instance $197784 m0 *1 827.04,381.78
X$197784 VDD VSS sg13g2_decap_8
* cell instance $197785 m0 *1 816.96,389.34
X$197785 VDD VSS sg13g2_decap_8
* cell instance $197786 m0 *1 609.6,812.7
X$197786 VDD VSS sg13g2_decap_8
* cell instance $197787 m0 *1 726.24,396.9
X$197787 VDD VSS sg13g2_decap_8
* cell instance $197788 m0 *1 602.88,820.26
X$197788 VDD VSS sg13g2_decap_8
* cell instance $197789 m0 *1 470.88,374.22
X$197789 VDD VSS sg13g2_decap_8
* cell instance $197790 m0 *1 599.52,820.26
X$197790 VDD VSS sg13g2_decap_8
* cell instance $197791 m0 *1 602.88,827.82
X$197791 VDD VSS sg13g2_decap_8
* cell instance $197792 m0 *1 596.16,820.26
X$197792 VDD VSS sg13g2_decap_8
* cell instance $197793 m0 *1 467.52,374.22
X$197793 VDD VSS sg13g2_decap_8
* cell instance $197794 m0 *1 823.68,381.78
X$197794 VDD VSS sg13g2_decap_8
* cell instance $197795 m0 *1 599.52,812.7
X$197795 VDD VSS sg13g2_decap_8
* cell instance $197796 m0 *1 504.48,374.22
X$197796 VDD VSS sg13g2_decap_8
* cell instance $197797 m0 *1 911.04,389.34
X$197797 VDD VSS sg13g2_decap_8
* cell instance $197798 m0 *1 911.04,396.9
X$197798 VDD VSS sg13g2_decap_8
* cell instance $197799 m0 *1 626.4,827.82
X$197799 VDD VSS sg13g2_decap_8
* cell instance $197800 m0 *1 750.72,404.46
X$197800 VDD VSS sg13g2_decap_8
* cell instance $197801 m0 *1 612.96,812.7
X$197801 VDD VSS sg13g2_decap_8
* cell instance $197802 m0 *1 911.04,374.22
X$197802 VDD VSS sg13g2_decap_8
* cell instance $197803 m0 *1 754.08,412.02
X$197803 VDD VSS sg13g2_decap_8
* cell instance $197804 m0 *1 843.84,396.9
X$197804 VDD VSS sg13g2_decap_8
* cell instance $197805 m0 *1 871.68,427.14
X$197805 VDD VSS sg13g2_decap_8
* cell instance $197806 m0 *1 884.16,396.9
X$197806 VDD VSS sg13g2_decap_8
* cell instance $197807 m0 *1 870.72,381.78
X$197807 VDD VSS sg13g2_decap_8
* cell instance $197808 m0 *1 706.08,396.9
X$197808 VDD VSS sg13g2_decap_8
* cell instance $197809 m0 *1 840.48,396.9
X$197809 VDD VSS sg13g2_decap_8
* cell instance $197810 m0 *1 612.96,805.14
X$197810 VDD VSS sg13g2_decap_8
* cell instance $197811 m0 *1 837.12,396.9
X$197811 VDD VSS sg13g2_decap_8
* cell instance $197812 m0 *1 833.76,396.9
X$197812 VDD VSS sg13g2_decap_8
* cell instance $197813 m0 *1 612.96,827.82
X$197813 VDD VSS sg13g2_decap_8
* cell instance $197814 m0 *1 612.96,820.26
X$197814 VDD VSS sg13g2_decap_8
* cell instance $197815 m0 *1 894.24,396.9
X$197815 VDD VSS sg13g2_decap_8
* cell instance $197816 m0 *1 887.52,396.9
X$197816 VDD VSS sg13g2_decap_8
* cell instance $197817 m0 *1 900.96,396.9
X$197817 VDD VSS sg13g2_decap_8
* cell instance $197818 m0 *1 660,827.82
X$197818 VDD VSS sg13g2_decap_8
* cell instance $197819 m0 *1 890.88,396.9
X$197819 VDD VSS sg13g2_decap_8
* cell instance $197820 m0 *1 897.6,396.9
X$197820 VDD VSS sg13g2_decap_8
* cell instance $197821 m0 *1 907.68,396.9
X$197821 VDD VSS sg13g2_decap_8
* cell instance $197822 m0 *1 904.32,396.9
X$197822 VDD VSS sg13g2_decap_8
* cell instance $197823 m0 *1 800.16,374.22
X$197823 VDD VSS sg13g2_decap_8
* cell instance $197824 m0 *1 460.8,374.22
X$197824 VDD VSS sg13g2_decap_8
* cell instance $197825 m0 *1 619.68,820.26
X$197825 VDD VSS sg13g2_decap_8
* cell instance $197826 m0 *1 616.32,820.26
X$197826 VDD VSS sg13g2_decap_8
* cell instance $197827 m0 *1 796.8,374.22
X$197827 VDD VSS sg13g2_decap_8
* cell instance $197828 m0 *1 623.04,820.26
X$197828 VDD VSS sg13g2_decap_8
* cell instance $197829 m0 *1 806.88,374.22
X$197829 VDD VSS sg13g2_decap_8
* cell instance $197830 m0 *1 709.44,396.9
X$197830 VDD VSS sg13g2_decap_8
* cell instance $197831 m0 *1 712.8,396.9
X$197831 VDD VSS sg13g2_decap_8
* cell instance $197832 m0 *1 487.68,374.22
X$197832 VDD VSS sg13g2_decap_8
* cell instance $197833 m0 *1 823.68,374.22
X$197833 VDD VSS sg13g2_decap_8
* cell instance $197834 m0 *1 712.8,389.34
X$197834 VDD VSS sg13g2_decap_8
* cell instance $197835 m0 *1 827.04,374.22
X$197835 VDD VSS sg13g2_decap_8
* cell instance $197836 m0 *1 912,419.58
X$197836 VDD VSS sg13g2_decap_8
* cell instance $197837 m0 *1 816.96,374.22
X$197837 VDD VSS sg13g2_decap_8
* cell instance $197838 m0 *1 820.32,374.22
X$197838 VDD VSS sg13g2_decap_8
* cell instance $197839 m0 *1 912,427.14
X$197839 VDD VSS sg13g2_decap_8
* cell instance $197840 m0 *1 629.76,820.26
X$197840 VDD VSS sg13g2_decap_8
* cell instance $197841 m0 *1 626.4,820.26
X$197841 VDD VSS sg13g2_decap_8
* cell instance $197842 m0 *1 619.68,827.82
X$197842 VDD VSS sg13g2_decap_8
* cell instance $197843 m0 *1 911.04,381.78
X$197843 VDD VSS sg13g2_decap_8
* cell instance $197844 m0 *1 750.72,419.58
X$197844 VDD VSS sg13g2_decap_8
* cell instance $197845 m0 *1 912,404.46
X$197845 VDD VSS sg13g2_decap_8
* cell instance $197846 m0 *1 629.76,827.82
X$197846 VDD VSS sg13g2_decap_8
* cell instance $197847 m0 *1 484.32,374.22
X$197847 VDD VSS sg13g2_decap_8
* cell instance $197848 m0 *1 912,412.02
X$197848 VDD VSS sg13g2_decap_8
* cell instance $197849 m0 *1 750.72,412.02
X$197849 VDD VSS sg13g2_decap_8
* cell instance $197850 m0 *1 699.36,396.9
X$197850 VDD VSS sg13g2_decap_8
* cell instance $197851 m0 *1 645.6,782.46
X$197851 VDD VSS sg13g2_decap_8
* cell instance $197852 m0 *1 669.12,782.46
X$197852 VDD VSS sg13g2_decap_8
* cell instance $197853 m0 *1 665.76,782.46
X$197853 VDD VSS sg13g2_decap_8
* cell instance $197854 m0 *1 763.2,374.22
X$197854 VDD VSS sg13g2_decap_8
* cell instance $197855 m0 *1 655.68,782.46
X$197855 VDD VSS sg13g2_decap_8
* cell instance $197856 m0 *1 437.28,389.34
X$197856 VDD VSS sg13g2_decap_8
* cell instance $197857 m0 *1 639.84,790.02
X$197857 VDD VSS sg13g2_decap_8
* cell instance $197858 m0 *1 636.48,790.02
X$197858 VDD VSS sg13g2_decap_8
* cell instance $197859 m0 *1 766.56,374.22
X$197859 VDD VSS sg13g2_decap_8
* cell instance $197860 m0 *1 759.84,374.22
X$197860 VDD VSS sg13g2_decap_8
* cell instance $197861 m0 *1 635.52,782.46
X$197861 VDD VSS sg13g2_decap_8
* cell instance $197862 m0 *1 638.88,782.46
X$197862 VDD VSS sg13g2_decap_8
* cell instance $197863 m0 *1 739.68,396.9
X$197863 VDD VSS sg13g2_decap_8
* cell instance $197864 m0 *1 670.08,790.02
X$197864 VDD VSS sg13g2_decap_8
* cell instance $197865 m0 *1 666.72,790.02
X$197865 VDD VSS sg13g2_decap_8
* cell instance $197866 m0 *1 663.36,790.02
X$197866 VDD VSS sg13g2_decap_8
* cell instance $197867 m0 *1 780,374.22
X$197867 VDD VSS sg13g2_decap_8
* cell instance $197868 m0 *1 660,790.02
X$197868 VDD VSS sg13g2_decap_8
* cell instance $197869 m0 *1 656.64,790.02
X$197869 VDD VSS sg13g2_decap_8
* cell instance $197870 m0 *1 652.32,782.46
X$197870 VDD VSS sg13g2_decap_8
* cell instance $197871 m0 *1 642.24,782.46
X$197871 VDD VSS sg13g2_decap_8
* cell instance $197872 m0 *1 653.28,790.02
X$197872 VDD VSS sg13g2_decap_8
* cell instance $197873 m0 *1 646.56,790.02
X$197873 VDD VSS sg13g2_decap_8
* cell instance $197874 m0 *1 649.92,790.02
X$197874 VDD VSS sg13g2_decap_8
* cell instance $197875 m0 *1 648.96,782.46
X$197875 VDD VSS sg13g2_decap_8
* cell instance $197876 m0 *1 598.56,782.46
X$197876 VDD VSS sg13g2_decap_8
* cell instance $197877 m0 *1 776.64,374.22
X$197877 VDD VSS sg13g2_decap_8
* cell instance $197878 m0 *1 737.28,412.02
X$197878 VDD VSS sg13g2_decap_8
* cell instance $197879 m0 *1 440.64,381.78
X$197879 VDD VSS sg13g2_decap_8
* cell instance $197880 m0 *1 444,389.34
X$197880 VDD VSS sg13g2_decap_8
* cell instance $197881 m0 *1 552.48,790.02
X$197881 VDD VSS sg13g2_decap_8
* cell instance $197882 m0 *1 766.56,389.34
X$197882 VDD VSS sg13g2_decap_8
* cell instance $197883 m0 *1 552.48,797.58
X$197883 VDD VSS sg13g2_decap_8
* cell instance $197884 m0 *1 756.48,389.34
X$197884 VDD VSS sg13g2_decap_8
* cell instance $197885 m0 *1 437.28,381.78
X$197885 VDD VSS sg13g2_decap_8
* cell instance $197886 m0 *1 769.92,389.34
X$197886 VDD VSS sg13g2_decap_8
* cell instance $197887 m0 *1 551.52,782.46
X$197887 VDD VSS sg13g2_decap_8
* cell instance $197888 m0 *1 769.92,381.78
X$197888 VDD VSS sg13g2_decap_8
* cell instance $197889 m0 *1 450.72,389.34
X$197889 VDD VSS sg13g2_decap_8
* cell instance $197890 m0 *1 759.84,381.78
X$197890 VDD VSS sg13g2_decap_8
* cell instance $197891 m0 *1 662.4,782.46
X$197891 VDD VSS sg13g2_decap_8
* cell instance $197892 m0 *1 766.56,381.78
X$197892 VDD VSS sg13g2_decap_8
* cell instance $197893 m0 *1 763.2,381.78
X$197893 VDD VSS sg13g2_decap_8
* cell instance $197894 m0 *1 763.2,389.34
X$197894 VDD VSS sg13g2_decap_8
* cell instance $197895 m0 *1 756.48,381.78
X$197895 VDD VSS sg13g2_decap_8
* cell instance $197896 m0 *1 744,419.58
X$197896 VDD VSS sg13g2_decap_8
* cell instance $197897 m0 *1 747.36,412.02
X$197897 VDD VSS sg13g2_decap_8
* cell instance $197898 m0 *1 737.28,427.14
X$197898 VDD VSS sg13g2_decap_8
* cell instance $197899 m0 *1 659.04,782.46
X$197899 VDD VSS sg13g2_decap_8
* cell instance $197900 m0 *1 756.48,374.22
X$197900 VDD VSS sg13g2_decap_8
* cell instance $197901 m0 *1 747.36,419.58
X$197901 VDD VSS sg13g2_decap_8
* cell instance $197902 m0 *1 769.92,374.22
X$197902 VDD VSS sg13g2_decap_8
* cell instance $197903 m0 *1 643.2,790.02
X$197903 VDD VSS sg13g2_decap_8
* cell instance $197904 m0 *1 450.72,381.78
X$197904 VDD VSS sg13g2_decap_8
* cell instance $197905 m0 *1 759.84,389.34
X$197905 VDD VSS sg13g2_decap_8
* cell instance $197906 m0 *1 444,374.22
X$197906 VDD VSS sg13g2_decap_8
* cell instance $197907 m0 *1 612.96,790.02
X$197907 VDD VSS sg13g2_decap_8
* cell instance $197908 m0 *1 612,782.46
X$197908 VDD VSS sg13g2_decap_8
* cell instance $197909 m0 *1 679.2,396.9
X$197909 VDD VSS sg13g2_decap_8
* cell instance $197910 m0 *1 682.56,396.9
X$197910 VDD VSS sg13g2_decap_8
* cell instance $197911 m0 *1 685.92,396.9
X$197911 VDD VSS sg13g2_decap_8
* cell instance $197912 m0 *1 810.24,389.34
X$197912 VDD VSS sg13g2_decap_8
* cell instance $197913 m0 *1 619.68,805.14
X$197913 VDD VSS sg13g2_decap_8
* cell instance $197914 m0 *1 619.68,812.7
X$197914 VDD VSS sg13g2_decap_8
* cell instance $197915 m0 *1 629.76,812.7
X$197915 VDD VSS sg13g2_decap_8
* cell instance $197916 m0 *1 813.6,381.78
X$197916 VDD VSS sg13g2_decap_8
* cell instance $197917 m0 *1 689.28,396.9
X$197917 VDD VSS sg13g2_decap_8
* cell instance $197918 m0 *1 599.52,790.02
X$197918 VDD VSS sg13g2_decap_8
* cell instance $197919 m0 *1 813.6,389.34
X$197919 VDD VSS sg13g2_decap_8
* cell instance $197920 m0 *1 616.32,812.7
X$197920 VDD VSS sg13g2_decap_8
* cell instance $197921 m0 *1 629.76,805.14
X$197921 VDD VSS sg13g2_decap_8
* cell instance $197922 m0 *1 696,396.9
X$197922 VDD VSS sg13g2_decap_8
* cell instance $197923 m0 *1 626.4,805.14
X$197923 VDD VSS sg13g2_decap_8
* cell instance $197924 m0 *1 626.4,812.7
X$197924 VDD VSS sg13g2_decap_8
* cell instance $197925 m0 *1 623.04,812.7
X$197925 VDD VSS sg13g2_decap_8
* cell instance $197926 m0 *1 616.32,805.14
X$197926 VDD VSS sg13g2_decap_8
* cell instance $197927 m0 *1 813.6,374.22
X$197927 VDD VSS sg13g2_decap_8
* cell instance $197928 m0 *1 692.64,396.9
X$197928 VDD VSS sg13g2_decap_8
* cell instance $197929 m0 *1 450.72,374.22
X$197929 VDD VSS sg13g2_decap_8
* cell instance $197931 m0 *1 602.88,805.14
X$197931 VDD VSS sg13g2_decap_8
* cell instance $197932 m0 *1 606.24,805.14
X$197932 VDD VSS sg13g2_decap_8
* cell instance $197933 m0 *1 623.04,805.14
X$197933 VDD VSS sg13g2_decap_8
* cell instance $197934 m0 *1 609.6,790.02
X$197934 VDD VSS sg13g2_decap_8
* cell instance $197935 m0 *1 606.24,790.02
X$197935 VDD VSS sg13g2_decap_8
* cell instance $197936 m0 *1 444,381.78
X$197936 VDD VSS sg13g2_decap_8
* cell instance $197937 m0 *1 595.2,782.46
X$197937 VDD VSS sg13g2_decap_8
* cell instance $197938 m0 *1 608.64,782.46
X$197938 VDD VSS sg13g2_decap_8
* cell instance $197939 m0 *1 737.28,404.46
X$197939 VDD VSS sg13g2_decap_8
* cell instance $197940 m0 *1 605.28,782.46
X$197940 VDD VSS sg13g2_decap_8
* cell instance $197941 m0 *1 601.92,782.46
X$197941 VDD VSS sg13g2_decap_8
* cell instance $197942 m0 *1 596.16,790.02
X$197942 VDD VSS sg13g2_decap_8
* cell instance $197943 m0 *1 783.36,374.22
X$197943 VDD VSS sg13g2_decap_8
* cell instance $197944 m0 *1 602.88,790.02
X$197944 VDD VSS sg13g2_decap_8
* cell instance $197945 m0 *1 786.72,374.22
X$197945 VDD VSS sg13g2_decap_8
* cell instance $197946 m0 *1 622.08,782.46
X$197946 VDD VSS sg13g2_decap_8
* cell instance $197947 m0 *1 810.24,374.22
X$197947 VDD VSS sg13g2_decap_8
* cell instance $197948 m0 *1 437.28,374.22
X$197948 VDD VSS sg13g2_decap_8
* cell instance $197949 m0 *1 618.72,782.46
X$197949 VDD VSS sg13g2_decap_8
* cell instance $197950 m0 *1 625.44,782.46
X$197950 VDD VSS sg13g2_decap_8
* cell instance $197951 m0 *1 615.36,782.46
X$197951 VDD VSS sg13g2_decap_8
* cell instance $197952 m0 *1 626.4,790.02
X$197952 VDD VSS sg13g2_decap_8
* cell instance $197953 m0 *1 440.64,374.22
X$197953 VDD VSS sg13g2_decap_8
* cell instance $197954 m0 *1 702.72,396.9
X$197954 VDD VSS sg13g2_decap_8
* cell instance $197955 m0 *1 629.76,790.02
X$197955 VDD VSS sg13g2_decap_8
* cell instance $197956 m0 *1 628.8,782.46
X$197956 VDD VSS sg13g2_decap_8
* cell instance $197957 m0 *1 623.04,790.02
X$197957 VDD VSS sg13g2_decap_8
* cell instance $197958 m0 *1 619.68,790.02
X$197958 VDD VSS sg13g2_decap_8
* cell instance $197959 m0 *1 616.32,790.02
X$197959 VDD VSS sg13g2_decap_8
* cell instance $197960 m0 *1 675.84,396.9
X$197960 VDD VSS sg13g2_decap_8
* cell instance $197961 m0 *1 447.36,374.22
X$197961 VDD VSS sg13g2_decap_8
* cell instance $197962 m0 *1 851.52,404.46
X$197962 VDD VSS sg13g2_decap_8
* cell instance $197963 m0 *1 655.68,381.78
X$197963 VDD VSS sg13g2_decap_8
* cell instance $197964 m0 *1 635.52,389.34
X$197964 VDD VSS sg13g2_decap_8
* cell instance $197965 m0 *1 619.68,797.58
X$197965 VDD VSS sg13g2_decap_8
* cell instance $197966 m0 *1 616.32,797.58
X$197966 VDD VSS sg13g2_decap_8
* cell instance $197967 m0 *1 511.2,374.22
X$197967 VDD VSS sg13g2_decap_8
* cell instance $197968 m0 *1 629.76,797.58
X$197968 VDD VSS sg13g2_decap_8
* cell instance $197969 m0 *1 626.4,797.58
X$197969 VDD VSS sg13g2_decap_8
* cell instance $197970 m0 *1 623.04,797.58
X$197970 VDD VSS sg13g2_decap_8
* cell instance $197971 m0 *1 609.6,797.58
X$197971 VDD VSS sg13g2_decap_8
* cell instance $197972 m0 *1 599.52,797.58
X$197972 VDD VSS sg13g2_decap_8
* cell instance $197973 m0 *1 606.24,797.58
X$197973 VDD VSS sg13g2_decap_8
* cell instance $197974 m0 *1 871.68,404.46
X$197974 VDD VSS sg13g2_decap_8
* cell instance $197975 m0 *1 602.88,797.58
X$197975 VDD VSS sg13g2_decap_8
* cell instance $197976 m0 *1 612.96,797.58
X$197976 VDD VSS sg13g2_decap_8
* cell instance $197977 m0 *1 663.36,797.58
X$197977 VDD VSS sg13g2_decap_8
* cell instance $197978 m0 *1 484.32,389.34
X$197978 VDD VSS sg13g2_decap_8
* cell instance $197979 m0 *1 660,797.58
X$197979 VDD VSS sg13g2_decap_8
* cell instance $197980 m0 *1 670.08,797.58
X$197980 VDD VSS sg13g2_decap_8
* cell instance $197981 m0 *1 656.64,797.58
X$197981 VDD VSS sg13g2_decap_8
* cell instance $197982 m0 *1 666.72,797.58
X$197982 VDD VSS sg13g2_decap_8
* cell instance $197983 m0 *1 649.92,797.58
X$197983 VDD VSS sg13g2_decap_8
* cell instance $197984 m0 *1 851.52,419.58
X$197984 VDD VSS sg13g2_decap_8
* cell instance $197985 m0 *1 639.84,797.58
X$197985 VDD VSS sg13g2_decap_8
* cell instance $197986 m0 *1 643.2,797.58
X$197986 VDD VSS sg13g2_decap_8
* cell instance $197987 m0 *1 636.48,797.58
X$197987 VDD VSS sg13g2_decap_8
* cell instance $197988 m0 *1 596.16,797.58
X$197988 VDD VSS sg13g2_decap_8
* cell instance $197989 m0 *1 649.92,827.82
X$197989 VDD VSS sg13g2_decap_8
* cell instance $197990 m0 *1 905.28,412.02
X$197990 VDD VSS sg13g2_decap_8
* cell instance $197991 m0 *1 646.56,827.82
X$197991 VDD VSS sg13g2_decap_8
* cell instance $197992 m0 *1 908.64,404.46
X$197992 VDD VSS sg13g2_decap_8
* cell instance $197993 m0 *1 908.64,412.02
X$197993 VDD VSS sg13g2_decap_8
* cell instance $197994 m0 *1 494.4,381.78
X$197994 VDD VSS sg13g2_decap_8
* cell instance $197995 m0 *1 636.48,827.82
X$197995 VDD VSS sg13g2_decap_8
* cell instance $197996 m0 *1 480.96,389.34
X$197996 VDD VSS sg13g2_decap_8
* cell instance $197997 m0 *1 639.84,827.82
X$197997 VDD VSS sg13g2_decap_8
* cell instance $197998 m0 *1 905.28,404.46
X$197998 VDD VSS sg13g2_decap_8
* cell instance $197999 m0 *1 898.56,404.46
X$197999 VDD VSS sg13g2_decap_8
* cell instance $198000 m0 *1 649.92,820.26
X$198000 VDD VSS sg13g2_decap_8
* cell instance $198001 m0 *1 646.56,820.26
X$198001 VDD VSS sg13g2_decap_8
* cell instance $198002 m0 *1 851.52,427.14
X$198002 VDD VSS sg13g2_decap_8
* cell instance $198003 m0 *1 639.84,820.26
X$198003 VDD VSS sg13g2_decap_8
* cell instance $198004 m0 *1 901.92,412.02
X$198004 VDD VSS sg13g2_decap_8
* cell instance $198005 m0 *1 901.92,404.46
X$198005 VDD VSS sg13g2_decap_8
* cell instance $198006 m0 *1 898.56,412.02
X$198006 VDD VSS sg13g2_decap_8
* cell instance $198007 m0 *1 895.2,404.46
X$198007 VDD VSS sg13g2_decap_8
* cell instance $198008 m0 *1 636.48,820.26
X$198008 VDD VSS sg13g2_decap_8
* cell instance $198009 m0 *1 895.2,412.02
X$198009 VDD VSS sg13g2_decap_8
* cell instance $198010 m0 *1 834.72,419.58
X$198010 VDD VSS sg13g2_decap_8
* cell instance $198011 m0 *1 848.16,419.58
X$198011 VDD VSS sg13g2_decap_8
* cell instance $198012 m0 *1 660,820.26
X$198012 VDD VSS sg13g2_decap_8
* cell instance $198013 m0 *1 838.08,419.58
X$198013 VDD VSS sg13g2_decap_8
* cell instance $198014 m0 *1 663.36,820.26
X$198014 VDD VSS sg13g2_decap_8
* cell instance $198015 m0 *1 844.8,419.58
X$198015 VDD VSS sg13g2_decap_8
* cell instance $198016 m0 *1 643.2,820.26
X$198016 VDD VSS sg13g2_decap_8
* cell instance $198017 m0 *1 844.8,427.14
X$198017 VDD VSS sg13g2_decap_8
* cell instance $198018 m0 *1 848.16,427.14
X$198018 VDD VSS sg13g2_decap_8
* cell instance $198019 m0 *1 838.08,427.14
X$198019 VDD VSS sg13g2_decap_8
* cell instance $198020 m0 *1 652.32,389.34
X$198020 VDD VSS sg13g2_decap_8
* cell instance $198021 m0 *1 665.76,381.78
X$198021 VDD VSS sg13g2_decap_8
* cell instance $198022 m0 *1 504.48,381.78
X$198022 VDD VSS sg13g2_decap_8
* cell instance $198023 m0 *1 834.72,427.14
X$198023 VDD VSS sg13g2_decap_8
* cell instance $198024 m0 *1 592.8,812.7
X$198024 VDD VSS sg13g2_decap_8
* cell instance $198025 m0 *1 841.44,427.14
X$198025 VDD VSS sg13g2_decap_8
* cell instance $198026 m0 *1 662.4,389.34
X$198026 VDD VSS sg13g2_decap_8
* cell instance $198027 m0 *1 592.8,820.26
X$198027 VDD VSS sg13g2_decap_8
* cell instance $198028 m0 *1 838.08,404.46
X$198028 VDD VSS sg13g2_decap_8
* cell instance $198029 m0 *1 646.56,797.58
X$198029 VDD VSS sg13g2_decap_8
* cell instance $198030 m0 *1 834.72,412.02
X$198030 VDD VSS sg13g2_decap_8
* cell instance $198031 m0 *1 838.08,412.02
X$198031 VDD VSS sg13g2_decap_8
* cell instance $198032 m0 *1 834.72,404.46
X$198032 VDD VSS sg13g2_decap_8
* cell instance $198033 m0 *1 477.6,389.34
X$198033 VDD VSS sg13g2_decap_8
* cell instance $198034 m0 *1 484.32,381.78
X$198034 VDD VSS sg13g2_decap_8
* cell instance $198035 m0 *1 480.96,381.78
X$198035 VDD VSS sg13g2_decap_8
* cell instance $198036 m0 *1 477.6,381.78
X$198036 VDD VSS sg13g2_decap_8
* cell instance $198037 m0 *1 841.44,404.46
X$198037 VDD VSS sg13g2_decap_8
* cell instance $198038 m0 *1 665.76,389.34
X$198038 VDD VSS sg13g2_decap_8
* cell instance $198039 m0 *1 592.8,805.14
X$198039 VDD VSS sg13g2_decap_8
* cell instance $198040 m0 *1 592.8,790.02
X$198040 VDD VSS sg13g2_decap_8
* cell instance $198041 m0 *1 592.8,797.58
X$198041 VDD VSS sg13g2_decap_8
* cell instance $198042 m0 *1 844.8,404.46
X$198042 VDD VSS sg13g2_decap_8
* cell instance $198043 m0 *1 592.8,827.82
X$198043 VDD VSS sg13g2_decap_8
* cell instance $198044 m0 *1 653.28,797.58
X$198044 VDD VSS sg13g2_decap_8
* cell instance $198045 m0 *1 669.12,389.34
X$198045 VDD VSS sg13g2_decap_8
* cell instance $198046 m0 *1 633.12,812.7
X$198046 VDD VSS sg13g2_decap_8
* cell instance $198047 m0 *1 638.88,381.78
X$198047 VDD VSS sg13g2_decap_8
* cell instance $198048 m0 *1 507.84,374.22
X$198048 VDD VSS sg13g2_decap_8
* cell instance $198049 m0 *1 851.52,412.02
X$198049 VDD VSS sg13g2_decap_8
* cell instance $198050 m0 *1 633.12,820.26
X$198050 VDD VSS sg13g2_decap_8
* cell instance $198051 m0 *1 722.88,374.22
X$198051 VDD VSS sg13g2_decap_8
* cell instance $198052 m0 *1 633.12,805.14
X$198052 VDD VSS sg13g2_decap_8
* cell instance $198053 m0 *1 868.32,419.58
X$198053 VDD VSS sg13g2_decap_8
* cell instance $198054 m0 *1 633.12,827.82
X$198054 VDD VSS sg13g2_decap_8
* cell instance $198055 m0 *1 861.6,419.58
X$198055 VDD VSS sg13g2_decap_8
* cell instance $198056 m0 *1 864.96,419.58
X$198056 VDD VSS sg13g2_decap_8
* cell instance $198057 m0 *1 662.4,381.78
X$198057 VDD VSS sg13g2_decap_8
* cell instance $198058 m0 *1 854.88,419.58
X$198058 VDD VSS sg13g2_decap_8
* cell instance $198059 m0 *1 633.12,790.02
X$198059 VDD VSS sg13g2_decap_8
* cell instance $198060 m0 *1 841.44,419.58
X$198060 VDD VSS sg13g2_decap_8
* cell instance $198061 m0 *1 659.04,381.78
X$198061 VDD VSS sg13g2_decap_8
* cell instance $198062 m0 *1 854.88,427.14
X$198062 VDD VSS sg13g2_decap_8
* cell instance $198063 m0 *1 861.6,427.14
X$198063 VDD VSS sg13g2_decap_8
* cell instance $198064 m0 *1 864.96,427.14
X$198064 VDD VSS sg13g2_decap_8
* cell instance $198065 m0 *1 648.96,381.78
X$198065 VDD VSS sg13g2_decap_8
* cell instance $198066 m0 *1 652.32,381.78
X$198066 VDD VSS sg13g2_decap_8
* cell instance $198067 m0 *1 868.32,427.14
X$198067 VDD VSS sg13g2_decap_8
* cell instance $198068 m0 *1 633.12,797.58
X$198068 VDD VSS sg13g2_decap_8
* cell instance $198069 m0 *1 858.24,427.14
X$198069 VDD VSS sg13g2_decap_8
* cell instance $198070 m0 *1 655.68,389.34
X$198070 VDD VSS sg13g2_decap_8
* cell instance $198071 m0 *1 858.24,419.58
X$198071 VDD VSS sg13g2_decap_8
* cell instance $198072 m0 *1 878.4,419.58
X$198072 VDD VSS sg13g2_decap_8
* cell instance $198073 m0 *1 875.04,419.58
X$198073 VDD VSS sg13g2_decap_8
* cell instance $198074 m0 *1 885.12,419.58
X$198074 VDD VSS sg13g2_decap_8
* cell instance $198075 m0 *1 753.12,381.78
X$198075 VDD VSS sg13g2_decap_8
* cell instance $198076 m0 *1 891.84,404.46
X$198076 VDD VSS sg13g2_decap_8
* cell instance $198077 m0 *1 750.72,427.14
X$198077 VDD VSS sg13g2_decap_8
* cell instance $198078 m0 *1 753.12,374.22
X$198078 VDD VSS sg13g2_decap_8
* cell instance $198079 m0 *1 660,812.7
X$198079 VDD VSS sg13g2_decap_8
* cell instance $198080 m0 *1 753.12,396.9
X$198080 VDD VSS sg13g2_decap_8
* cell instance $198081 m0 *1 891.84,412.02
X$198081 VDD VSS sg13g2_decap_8
* cell instance $198082 m0 *1 891.84,419.58
X$198082 VDD VSS sg13g2_decap_8
* cell instance $198083 m0 *1 491.04,389.34
X$198083 VDD VSS sg13g2_decap_8
* cell instance $198084 m0 *1 643.2,827.82
X$198084 VDD VSS sg13g2_decap_8
* cell instance $198085 m0 *1 891.84,427.14
X$198085 VDD VSS sg13g2_decap_8
* cell instance $198086 m0 *1 753.12,389.34
X$198086 VDD VSS sg13g2_decap_8
* cell instance $198087 m0 *1 666.72,805.14
X$198087 VDD VSS sg13g2_decap_8
* cell instance $198088 m0 *1 670.08,805.14
X$198088 VDD VSS sg13g2_decap_8
* cell instance $198089 m0 *1 666.72,812.7
X$198089 VDD VSS sg13g2_decap_8
* cell instance $198090 m0 *1 898.56,419.58
X$198090 VDD VSS sg13g2_decap_8
* cell instance $198091 m0 *1 905.28,419.58
X$198091 VDD VSS sg13g2_decap_8
* cell instance $198092 m0 *1 895.2,419.58
X$198092 VDD VSS sg13g2_decap_8
* cell instance $198093 m0 *1 901.92,419.58
X$198093 VDD VSS sg13g2_decap_8
* cell instance $198094 m0 *1 656.64,812.7
X$198094 VDD VSS sg13g2_decap_8
* cell instance $198095 m0 *1 908.64,419.58
X$198095 VDD VSS sg13g2_decap_8
* cell instance $198096 m0 *1 663.36,812.7
X$198096 VDD VSS sg13g2_decap_8
* cell instance $198097 m0 *1 653.28,812.7
X$198097 VDD VSS sg13g2_decap_8
* cell instance $198098 m0 *1 656.64,805.14
X$198098 VDD VSS sg13g2_decap_8
* cell instance $198099 m0 *1 754.08,404.46
X$198099 VDD VSS sg13g2_decap_8
* cell instance $198100 m0 *1 864,396.9
X$198100 VDD VSS sg13g2_decap_8
* cell instance $198101 m0 *1 491.04,374.22
X$198101 VDD VSS sg13g2_decap_8
* cell instance $198102 m0 *1 494.4,374.22
X$198102 VDD VSS sg13g2_decap_8
* cell instance $198103 m0 *1 871.68,412.02
X$198103 VDD VSS sg13g2_decap_8
* cell instance $198104 m0 *1 871.68,419.58
X$198104 VDD VSS sg13g2_decap_8
* cell instance $198105 m0 *1 857.28,396.9
X$198105 VDD VSS sg13g2_decap_8
* cell instance $198106 m0 *1 663.36,827.82
X$198106 VDD VSS sg13g2_decap_8
* cell instance $198107 m0 *1 666.72,820.26
X$198107 VDD VSS sg13g2_decap_8
* cell instance $198108 m0 *1 670.08,820.26
X$198108 VDD VSS sg13g2_decap_8
* cell instance $198109 m0 *1 847.2,396.9
X$198109 VDD VSS sg13g2_decap_8
* cell instance $198110 m0 *1 853.92,396.9
X$198110 VDD VSS sg13g2_decap_8
* cell instance $198111 m0 *1 656.64,820.26
X$198111 VDD VSS sg13g2_decap_8
* cell instance $198112 m0 *1 754.08,419.58
X$198112 VDD VSS sg13g2_decap_8
* cell instance $198113 m0 *1 850.56,396.9
X$198113 VDD VSS sg13g2_decap_8
* cell instance $198114 m0 *1 670.08,827.82
X$198114 VDD VSS sg13g2_decap_8
* cell instance $198115 m0 *1 656.64,827.82
X$198115 VDD VSS sg13g2_decap_8
* cell instance $198116 m0 *1 860.64,396.9
X$198116 VDD VSS sg13g2_decap_8
* cell instance $198117 m0 *1 874.08,396.9
X$198117 VDD VSS sg13g2_decap_8
* cell instance $198118 m0 *1 867.36,396.9
X$198118 VDD VSS sg13g2_decap_8
* cell instance $198119 m0 *1 870.72,396.9
X$198119 VDD VSS sg13g2_decap_8
* cell instance $198120 m0 *1 880.8,396.9
X$198120 VDD VSS sg13g2_decap_8
* cell instance $198121 m0 *1 877.44,396.9
X$198121 VDD VSS sg13g2_decap_8
* cell instance $198122 m0 *1 870.72,389.34
X$198122 VDD VSS sg13g2_decap_8
* cell instance $198123 m0 *1 754.08,427.14
X$198123 VDD VSS sg13g2_decap_8
* cell instance $198124 m0 *1 870.72,374.22
X$198124 VDD VSS sg13g2_decap_8
* cell instance $198125 m0 *1 487.68,389.34
X$198125 VDD VSS sg13g2_decap_8
* cell instance $198126 m0 *1 666.72,827.82
X$198126 VDD VSS sg13g2_decap_8
* cell instance $198127 m0 *1 830.4,389.34
X$198127 VDD VSS sg13g2_decap_8
* cell instance $198128 m0 *1 507.84,381.78
X$198128 VDD VSS sg13g2_decap_8
* cell instance $198129 m0 *1 646.56,812.7
X$198129 VDD VSS sg13g2_decap_8
* cell instance $198130 m0 *1 888.48,404.46
X$198130 VDD VSS sg13g2_decap_8
* cell instance $198131 m0 *1 501.12,381.78
X$198131 VDD VSS sg13g2_decap_8
* cell instance $198132 m0 *1 875.04,412.02
X$198132 VDD VSS sg13g2_decap_8
* cell instance $198133 m0 *1 831.36,412.02
X$198133 VDD VSS sg13g2_decap_8
* cell instance $198134 m0 *1 653.28,805.14
X$198134 VDD VSS sg13g2_decap_8
* cell instance $198135 m0 *1 497.76,381.78
X$198135 VDD VSS sg13g2_decap_8
* cell instance $198136 m0 *1 831.36,419.58
X$198136 VDD VSS sg13g2_decap_8
* cell instance $198137 m0 *1 511.2,389.34
X$198137 VDD VSS sg13g2_decap_8
* cell instance $198138 m0 *1 888.48,412.02
X$198138 VDD VSS sg13g2_decap_8
* cell instance $198139 m0 *1 881.76,419.58
X$198139 VDD VSS sg13g2_decap_8
* cell instance $198140 m0 *1 878.4,412.02
X$198140 VDD VSS sg13g2_decap_8
* cell instance $198141 m0 *1 881.76,412.02
X$198141 VDD VSS sg13g2_decap_8
* cell instance $198142 m0 *1 649.92,812.7
X$198142 VDD VSS sg13g2_decap_8
* cell instance $198143 m0 *1 881.76,404.46
X$198143 VDD VSS sg13g2_decap_8
* cell instance $198144 m0 *1 885.12,404.46
X$198144 VDD VSS sg13g2_decap_8
* cell instance $198145 m0 *1 878.4,404.46
X$198145 VDD VSS sg13g2_decap_8
* cell instance $198146 m0 *1 507.84,389.34
X$198146 VDD VSS sg13g2_decap_8
* cell instance $198147 m0 *1 885.12,412.02
X$198147 VDD VSS sg13g2_decap_8
* cell instance $198148 m0 *1 875.04,404.46
X$198148 VDD VSS sg13g2_decap_8
* cell instance $198149 m0 *1 830.4,381.78
X$198149 VDD VSS sg13g2_decap_8
* cell instance $198150 m0 *1 831.36,427.14
X$198150 VDD VSS sg13g2_decap_8
* cell instance $198151 m0 *1 642.24,381.78
X$198151 VDD VSS sg13g2_decap_8
* cell instance $198152 m0 *1 645.6,381.78
X$198152 VDD VSS sg13g2_decap_8
* cell instance $198153 m0 *1 831.36,404.46
X$198153 VDD VSS sg13g2_decap_8
* cell instance $198154 m0 *1 888.48,419.58
X$198154 VDD VSS sg13g2_decap_8
* cell instance $198155 m0 *1 653.28,820.26
X$198155 VDD VSS sg13g2_decap_8
* cell instance $198156 m0 *1 901.92,427.14
X$198156 VDD VSS sg13g2_decap_8
* cell instance $198157 m0 *1 830.4,374.22
X$198157 VDD VSS sg13g2_decap_8
* cell instance $198158 m0 *1 908.64,427.14
X$198158 VDD VSS sg13g2_decap_8
* cell instance $198159 m0 *1 504.48,389.34
X$198159 VDD VSS sg13g2_decap_8
* cell instance $198160 m0 *1 670.08,812.7
X$198160 VDD VSS sg13g2_decap_8
* cell instance $198161 m0 *1 898.56,427.14
X$198161 VDD VSS sg13g2_decap_8
* cell instance $198162 m0 *1 895.2,427.14
X$198162 VDD VSS sg13g2_decap_8
* cell instance $198163 m0 *1 663.36,805.14
X$198163 VDD VSS sg13g2_decap_8
* cell instance $198164 m0 *1 653.28,827.82
X$198164 VDD VSS sg13g2_decap_8
* cell instance $198165 m0 *1 905.28,427.14
X$198165 VDD VSS sg13g2_decap_8
* cell instance $198166 m0 *1 830.4,396.9
X$198166 VDD VSS sg13g2_decap_8
* cell instance $198167 m0 *1 888.48,427.14
X$198167 VDD VSS sg13g2_decap_8
* cell instance $198168 m0 *1 881.76,427.14
X$198168 VDD VSS sg13g2_decap_8
* cell instance $198169 m0 *1 660,805.14
X$198169 VDD VSS sg13g2_decap_8
* cell instance $198170 m0 *1 636.48,812.7
X$198170 VDD VSS sg13g2_decap_8
* cell instance $198171 m0 *1 636.48,805.14
X$198171 VDD VSS sg13g2_decap_8
* cell instance $198172 m0 *1 639.84,805.14
X$198172 VDD VSS sg13g2_decap_8
* cell instance $198173 m0 *1 643.2,805.14
X$198173 VDD VSS sg13g2_decap_8
* cell instance $198174 m0 *1 646.56,805.14
X$198174 VDD VSS sg13g2_decap_8
* cell instance $198175 m0 *1 649.92,805.14
X$198175 VDD VSS sg13g2_decap_8
* cell instance $198176 m0 *1 885.12,427.14
X$198176 VDD VSS sg13g2_decap_8
* cell instance $198177 m0 *1 511.2,381.78
X$198177 VDD VSS sg13g2_decap_8
* cell instance $198178 m0 *1 875.04,427.14
X$198178 VDD VSS sg13g2_decap_8
* cell instance $198179 m0 *1 643.2,812.7
X$198179 VDD VSS sg13g2_decap_8
* cell instance $198180 m0 *1 639.84,812.7
X$198180 VDD VSS sg13g2_decap_8
* cell instance $198181 m0 *1 878.4,427.14
X$198181 VDD VSS sg13g2_decap_8
* cell instance $198182 m0 *1 791.04,427.14
X$198182 VDD VSS sg13g2_decap_8
* cell instance $198183 m0 *1 800.16,396.9
X$198183 VDD VSS sg13g2_decap_8
* cell instance $198184 m0 *1 820.32,396.9
X$198184 VDD VSS sg13g2_decap_8
* cell instance $198185 m0 *1 803.52,396.9
X$198185 VDD VSS sg13g2_decap_8
* cell instance $198186 m0 *1 806.88,396.9
X$198186 VDD VSS sg13g2_decap_8
* cell instance $198187 m0 *1 813.6,396.9
X$198187 VDD VSS sg13g2_decap_8
* cell instance $198188 m0 *1 810.24,396.9
X$198188 VDD VSS sg13g2_decap_8
* cell instance $198189 m0 *1 816.96,396.9
X$198189 VDD VSS sg13g2_decap_8
* cell instance $198190 m0 *1 542.4,790.02
X$198190 VDD VSS sg13g2_decap_8
* cell instance $198191 m0 *1 827.04,396.9
X$198191 VDD VSS sg13g2_decap_8
* cell instance $198192 m0 *1 823.68,396.9
X$198192 VDD VSS sg13g2_decap_8
* cell instance $198193 m0 *1 417.12,389.34
X$198193 VDD VSS sg13g2_decap_8
* cell instance $198194 m0 *1 572.64,797.58
X$198194 VDD VSS sg13g2_decap_8
* cell instance $198195 m0 *1 790.08,381.78
X$198195 VDD VSS sg13g2_decap_8
* cell instance $198196 m0 *1 679.2,381.78
X$198196 VDD VSS sg13g2_decap_8
* cell instance $198197 m0 *1 682.56,389.34
X$198197 VDD VSS sg13g2_decap_8
* cell instance $198198 m0 *1 532.32,790.02
X$198198 VDD VSS sg13g2_decap_8
* cell instance $198199 m0 *1 790.08,374.22
X$198199 VDD VSS sg13g2_decap_8
* cell instance $198200 m0 *1 528.96,790.02
X$198200 VDD VSS sg13g2_decap_8
* cell instance $198201 m0 *1 549.12,790.02
X$198201 VDD VSS sg13g2_decap_8
* cell instance $198202 m0 *1 682.56,381.78
X$198202 VDD VSS sg13g2_decap_8
* cell instance $198203 m0 *1 791.04,404.46
X$198203 VDD VSS sg13g2_decap_8
* cell instance $198204 m0 *1 780,396.9
X$198204 VDD VSS sg13g2_decap_8
* cell instance $198205 m0 *1 689.28,381.78
X$198205 VDD VSS sg13g2_decap_8
* cell instance $198206 m0 *1 542.4,812.7
X$198206 VDD VSS sg13g2_decap_8
* cell instance $198207 m0 *1 423.84,389.34
X$198207 VDD VSS sg13g2_decap_8
* cell instance $198208 m0 *1 790.08,389.34
X$198208 VDD VSS sg13g2_decap_8
* cell instance $198209 m0 *1 769.92,396.9
X$198209 VDD VSS sg13g2_decap_8
* cell instance $198210 m0 *1 535.68,790.02
X$198210 VDD VSS sg13g2_decap_8
* cell instance $198211 m0 *1 522.24,790.02
X$198211 VDD VSS sg13g2_decap_8
* cell instance $198212 m0 *1 517.92,782.46
X$198212 VDD VSS sg13g2_decap_8
* cell instance $198213 m0 *1 521.28,782.46
X$198213 VDD VSS sg13g2_decap_8
* cell instance $198214 m0 *1 790.08,396.9
X$198214 VDD VSS sg13g2_decap_8
* cell instance $198215 m0 *1 545.76,790.02
X$198215 VDD VSS sg13g2_decap_8
* cell instance $198216 m0 *1 796.8,396.9
X$198216 VDD VSS sg13g2_decap_8
* cell instance $198217 m0 *1 793.44,396.9
X$198217 VDD VSS sg13g2_decap_8
* cell instance $198218 m0 *1 783.36,396.9
X$198218 VDD VSS sg13g2_decap_8
* cell instance $198219 m0 *1 786.72,396.9
X$198219 VDD VSS sg13g2_decap_8
* cell instance $198220 m0 *1 548.16,782.46
X$198220 VDD VSS sg13g2_decap_8
* cell instance $198221 m0 *1 420.48,374.22
X$198221 VDD VSS sg13g2_decap_8
* cell instance $198222 m0 *1 756.48,396.9
X$198222 VDD VSS sg13g2_decap_8
* cell instance $198223 m0 *1 675.84,381.78
X$198223 VDD VSS sg13g2_decap_8
* cell instance $198224 m0 *1 541.44,782.46
X$198224 VDD VSS sg13g2_decap_8
* cell instance $198225 m0 *1 430.56,389.34
X$198225 VDD VSS sg13g2_decap_8
* cell instance $198226 m0 *1 538.08,782.46
X$198226 VDD VSS sg13g2_decap_8
* cell instance $198227 m0 *1 534.72,782.46
X$198227 VDD VSS sg13g2_decap_8
* cell instance $198228 m0 *1 793.44,381.78
X$198228 VDD VSS sg13g2_decap_8
* cell instance $198229 m0 *1 531.36,782.46
X$198229 VDD VSS sg13g2_decap_8
* cell instance $198230 m0 *1 528,782.46
X$198230 VDD VSS sg13g2_decap_8
* cell instance $198231 m0 *1 524.64,782.46
X$198231 VDD VSS sg13g2_decap_8
* cell instance $198232 m0 *1 539.04,790.02
X$198232 VDD VSS sg13g2_decap_8
* cell instance $198233 m0 *1 793.44,374.22
X$198233 VDD VSS sg13g2_decap_8
* cell instance $198234 m0 *1 544.8,782.46
X$198234 VDD VSS sg13g2_decap_8
* cell instance $198235 m0 *1 525.6,790.02
X$198235 VDD VSS sg13g2_decap_8
* cell instance $198236 m0 *1 793.44,389.34
X$198236 VDD VSS sg13g2_decap_8
* cell instance $198237 m0 *1 696,389.34
X$198237 VDD VSS sg13g2_decap_8
* cell instance $198238 m0 *1 696,381.78
X$198238 VDD VSS sg13g2_decap_8
* cell instance $198239 m0 *1 811.2,427.14
X$198239 VDD VSS sg13g2_decap_8
* cell instance $198240 m0 *1 811.2,404.46
X$198240 VDD VSS sg13g2_decap_8
* cell instance $198241 m0 *1 515.52,805.14
X$198241 VDD VSS sg13g2_decap_8
* cell instance $198242 m0 *1 444,396.9
X$198242 VDD VSS sg13g2_decap_8
* cell instance $198243 m0 *1 702.72,381.78
X$198243 VDD VSS sg13g2_decap_8
* cell instance $198244 m0 *1 518.88,805.14
X$198244 VDD VSS sg13g2_decap_8
* cell instance $198245 m0 *1 522.24,805.14
X$198245 VDD VSS sg13g2_decap_8
* cell instance $198246 m0 *1 525.6,812.7
X$198246 VDD VSS sg13g2_decap_8
* cell instance $198247 m0 *1 450.72,396.9
X$198247 VDD VSS sg13g2_decap_8
* cell instance $198248 m0 *1 817.92,419.58
X$198248 VDD VSS sg13g2_decap_8
* cell instance $198249 m0 *1 542.4,805.14
X$198249 VDD VSS sg13g2_decap_8
* cell instance $198250 m0 *1 828,419.58
X$198250 VDD VSS sg13g2_decap_8
* cell instance $198251 m0 *1 515.52,820.26
X$198251 VDD VSS sg13g2_decap_8
* cell instance $198252 m0 *1 525.6,827.82
X$198252 VDD VSS sg13g2_decap_8
* cell instance $198253 m0 *1 824.64,419.58
X$198253 VDD VSS sg13g2_decap_8
* cell instance $198254 m0 *1 814.56,427.14
X$198254 VDD VSS sg13g2_decap_8
* cell instance $198255 m0 *1 821.28,427.14
X$198255 VDD VSS sg13g2_decap_8
* cell instance $198256 m0 *1 474.24,374.22
X$198256 VDD VSS sg13g2_decap_8
* cell instance $198257 m0 *1 817.92,427.14
X$198257 VDD VSS sg13g2_decap_8
* cell instance $198258 m0 *1 522.24,820.26
X$198258 VDD VSS sg13g2_decap_8
* cell instance $198259 m0 *1 525.6,820.26
X$198259 VDD VSS sg13g2_decap_8
* cell instance $198260 m0 *1 528.96,820.26
X$198260 VDD VSS sg13g2_decap_8
* cell instance $198261 m0 *1 518.88,820.26
X$198261 VDD VSS sg13g2_decap_8
* cell instance $198262 m0 *1 515.52,827.82
X$198262 VDD VSS sg13g2_decap_8
* cell instance $198263 m0 *1 518.88,827.82
X$198263 VDD VSS sg13g2_decap_8
* cell instance $198264 m0 *1 791.04,419.58
X$198264 VDD VSS sg13g2_decap_8
* cell instance $198265 m0 *1 814.56,419.58
X$198265 VDD VSS sg13g2_decap_8
* cell instance $198266 m0 *1 545.76,812.7
X$198266 VDD VSS sg13g2_decap_8
* cell instance $198267 m0 *1 821.28,419.58
X$198267 VDD VSS sg13g2_decap_8
* cell instance $198268 m0 *1 797.76,419.58
X$198268 VDD VSS sg13g2_decap_8
* cell instance $198269 m0 *1 804.48,419.58
X$198269 VDD VSS sg13g2_decap_8
* cell instance $198270 m0 *1 794.4,419.58
X$198270 VDD VSS sg13g2_decap_8
* cell instance $198271 m0 *1 549.12,812.7
X$198271 VDD VSS sg13g2_decap_8
* cell instance $198272 m0 *1 539.04,812.7
X$198272 VDD VSS sg13g2_decap_8
* cell instance $198273 m0 *1 801.12,419.58
X$198273 VDD VSS sg13g2_decap_8
* cell instance $198274 m0 *1 807.84,419.58
X$198274 VDD VSS sg13g2_decap_8
* cell instance $198275 m0 *1 545.76,805.14
X$198275 VDD VSS sg13g2_decap_8
* cell instance $198276 m0 *1 549.12,805.14
X$198276 VDD VSS sg13g2_decap_8
* cell instance $198277 m0 *1 528.96,812.7
X$198277 VDD VSS sg13g2_decap_8
* cell instance $198278 m0 *1 410.4,374.22
X$198278 VDD VSS sg13g2_decap_8
* cell instance $198279 m0 *1 535.68,805.14
X$198279 VDD VSS sg13g2_decap_8
* cell instance $198280 m0 *1 539.04,805.14
X$198280 VDD VSS sg13g2_decap_8
* cell instance $198281 m0 *1 515.52,812.7
X$198281 VDD VSS sg13g2_decap_8
* cell instance $198282 m0 *1 811.2,419.58
X$198282 VDD VSS sg13g2_decap_8
* cell instance $198283 m0 *1 811.2,412.02
X$198283 VDD VSS sg13g2_decap_8
* cell instance $198284 m0 *1 518.88,812.7
X$198284 VDD VSS sg13g2_decap_8
* cell instance $198285 m0 *1 675.84,389.34
X$198285 VDD VSS sg13g2_decap_8
* cell instance $198286 m0 *1 522.24,812.7
X$198286 VDD VSS sg13g2_decap_8
* cell instance $198287 m0 *1 709.44,389.34
X$198287 VDD VSS sg13g2_decap_8
* cell instance $198288 m0 *1 706.08,381.78
X$198288 VDD VSS sg13g2_decap_8
* cell instance $198289 m0 *1 528.96,805.14
X$198289 VDD VSS sg13g2_decap_8
* cell instance $198290 m0 *1 525.6,805.14
X$198290 VDD VSS sg13g2_decap_8
* cell instance $198291 m0 *1 535.68,812.7
X$198291 VDD VSS sg13g2_decap_8
* cell instance $198292 m0 *1 420.48,396.9
X$198292 VDD VSS sg13g2_decap_8
* cell instance $198293 m0 *1 739.68,381.78
X$198293 VDD VSS sg13g2_decap_8
* cell instance $198294 m0 *1 696,374.22
X$198294 VDD VSS sg13g2_decap_8
* cell instance $198295 m0 *1 433.92,374.22
X$198295 VDD VSS sg13g2_decap_8
* cell instance $198296 m0 *1 702.72,374.22
X$198296 VDD VSS sg13g2_decap_8
* cell instance $198297 m0 *1 709.44,374.22
X$198297 VDD VSS sg13g2_decap_8
* cell instance $198298 m0 *1 675.84,374.22
X$198298 VDD VSS sg13g2_decap_8
* cell instance $198299 m0 *1 736.32,381.78
X$198299 VDD VSS sg13g2_decap_8
* cell instance $198300 m0 *1 433.92,389.34
X$198300 VDD VSS sg13g2_decap_8
* cell instance $198301 m0 *1 679.2,374.22
X$198301 VDD VSS sg13g2_decap_8
* cell instance $198302 m0 *1 732.96,381.78
X$198302 VDD VSS sg13g2_decap_8
* cell instance $198303 m0 *1 719.52,374.22
X$198303 VDD VSS sg13g2_decap_8
* cell instance $198304 m0 *1 518.88,790.02
X$198304 VDD VSS sg13g2_decap_8
* cell instance $198305 m0 *1 729.6,381.78
X$198305 VDD VSS sg13g2_decap_8
* cell instance $198306 m0 *1 726.24,381.78
X$198306 VDD VSS sg13g2_decap_8
* cell instance $198307 m0 *1 722.88,381.78
X$198307 VDD VSS sg13g2_decap_8
* cell instance $198308 m0 *1 682.56,374.22
X$198308 VDD VSS sg13g2_decap_8
* cell instance $198309 m0 *1 749.76,389.34
X$198309 VDD VSS sg13g2_decap_8
* cell instance $198310 m0 *1 685.92,374.22
X$198310 VDD VSS sg13g2_decap_8
* cell instance $198311 m0 *1 729.6,389.34
X$198311 VDD VSS sg13g2_decap_8
* cell instance $198312 m0 *1 716.16,374.22
X$198312 VDD VSS sg13g2_decap_8
* cell instance $198313 m0 *1 433.92,396.9
X$198313 VDD VSS sg13g2_decap_8
* cell instance $198314 m0 *1 433.92,381.78
X$198314 VDD VSS sg13g2_decap_8
* cell instance $198315 m0 *1 749.76,381.78
X$198315 VDD VSS sg13g2_decap_8
* cell instance $198316 m0 *1 514.56,374.22
X$198316 VDD VSS sg13g2_decap_8
* cell instance $198317 m0 *1 726.24,389.34
X$198317 VDD VSS sg13g2_decap_8
* cell instance $198318 m0 *1 729.6,374.22
X$198318 VDD VSS sg13g2_decap_8
* cell instance $198319 m0 *1 407.04,389.34
X$198319 VDD VSS sg13g2_decap_8
* cell instance $198320 m0 *1 743.04,381.78
X$198320 VDD VSS sg13g2_decap_8
* cell instance $198321 m0 *1 407.04,374.22
X$198321 VDD VSS sg13g2_decap_8
* cell instance $198322 m0 *1 716.16,389.34
X$198322 VDD VSS sg13g2_decap_8
* cell instance $198323 m0 *1 420.48,389.34
X$198323 VDD VSS sg13g2_decap_8
* cell instance $198324 m0 *1 699.36,374.22
X$198324 VDD VSS sg13g2_decap_8
* cell instance $198325 m0 *1 407.04,381.78
X$198325 VDD VSS sg13g2_decap_8
* cell instance $198326 m0 *1 417.12,381.78
X$198326 VDD VSS sg13g2_decap_8
* cell instance $198327 m0 *1 719.52,381.78
X$198327 VDD VSS sg13g2_decap_8
* cell instance $198328 m0 *1 430.56,374.22
X$198328 VDD VSS sg13g2_decap_8
* cell instance $198329 m0 *1 427.2,374.22
X$198329 VDD VSS sg13g2_decap_8
* cell instance $198330 m0 *1 413.76,381.78
X$198330 VDD VSS sg13g2_decap_8
* cell instance $198331 m0 *1 746.4,374.22
X$198331 VDD VSS sg13g2_decap_8
* cell instance $198332 m0 *1 410.4,396.9
X$198332 VDD VSS sg13g2_decap_8
* cell instance $198333 m0 *1 743.04,374.22
X$198333 VDD VSS sg13g2_decap_8
* cell instance $198334 m0 *1 739.68,374.22
X$198334 VDD VSS sg13g2_decap_8
* cell instance $198335 m0 *1 736.32,374.22
X$198335 VDD VSS sg13g2_decap_8
* cell instance $198336 m0 *1 423.84,374.22
X$198336 VDD VSS sg13g2_decap_8
* cell instance $198337 m0 *1 716.16,381.78
X$198337 VDD VSS sg13g2_decap_8
* cell instance $198338 m0 *1 427.2,389.34
X$198338 VDD VSS sg13g2_decap_8
* cell instance $198339 m0 *1 423.84,396.9
X$198339 VDD VSS sg13g2_decap_8
* cell instance $198340 m0 *1 430.56,396.9
X$198340 VDD VSS sg13g2_decap_8
* cell instance $198341 m0 *1 427.2,396.9
X$198341 VDD VSS sg13g2_decap_8
* cell instance $198342 m0 *1 413.76,396.9
X$198342 VDD VSS sg13g2_decap_8
* cell instance $198343 m0 *1 417.12,396.9
X$198343 VDD VSS sg13g2_decap_8
* cell instance $198344 m0 *1 732.96,374.22
X$198344 VDD VSS sg13g2_decap_8
* cell instance $198345 m0 *1 407.04,396.9
X$198345 VDD VSS sg13g2_decap_8
* cell instance $198346 m0 *1 706.08,374.22
X$198346 VDD VSS sg13g2_decap_8
* cell instance $198347 m0 *1 423.84,381.78
X$198347 VDD VSS sg13g2_decap_8
* cell instance $198348 m0 *1 410.4,389.34
X$198348 VDD VSS sg13g2_decap_8
* cell instance $198349 m0 *1 685.92,381.78
X$198349 VDD VSS sg13g2_decap_8
* cell instance $198350 m0 *1 581.76,782.46
X$198350 VDD VSS sg13g2_decap_8
* cell instance $198351 m0 *1 726.24,374.22
X$198351 VDD VSS sg13g2_decap_8
* cell instance $198352 m0 *1 413.76,389.34
X$198352 VDD VSS sg13g2_decap_8
* cell instance $198353 m0 *1 568.32,782.46
X$198353 VDD VSS sg13g2_decap_8
* cell instance $198354 m0 *1 572.64,790.02
X$198354 VDD VSS sg13g2_decap_8
* cell instance $198355 m0 *1 565.92,790.02
X$198355 VDD VSS sg13g2_decap_8
* cell instance $198356 m0 *1 749.76,374.22
X$198356 VDD VSS sg13g2_decap_8
* cell instance $198357 m0 *1 685.92,389.34
X$198357 VDD VSS sg13g2_decap_8
* cell instance $198358 m0 *1 564.96,782.46
X$198358 VDD VSS sg13g2_decap_8
* cell instance $198359 m0 *1 410.4,381.78
X$198359 VDD VSS sg13g2_decap_8
* cell instance $198360 m0 *1 562.56,790.02
X$198360 VDD VSS sg13g2_decap_8
* cell instance $198361 m0 *1 746.4,381.78
X$198361 VDD VSS sg13g2_decap_8
* cell instance $198362 m0 *1 559.2,790.02
X$198362 VDD VSS sg13g2_decap_8
* cell instance $198363 m0 *1 555.84,790.02
X$198363 VDD VSS sg13g2_decap_8
* cell instance $198364 m0 *1 791.04,412.02
X$198364 VDD VSS sg13g2_decap_8
* cell instance $198365 m0 *1 773.28,396.9
X$198365 VDD VSS sg13g2_decap_8
* cell instance $198366 m0 *1 586.08,790.02
X$198366 VDD VSS sg13g2_decap_8
* cell instance $198367 m0 *1 759.84,396.9
X$198367 VDD VSS sg13g2_decap_8
* cell instance $198368 m0 *1 569.28,790.02
X$198368 VDD VSS sg13g2_decap_8
* cell instance $198369 m0 *1 515.52,790.02
X$198369 VDD VSS sg13g2_decap_8
* cell instance $198370 m0 *1 766.56,396.9
X$198370 VDD VSS sg13g2_decap_8
* cell instance $198371 m0 *1 776.64,396.9
X$198371 VDD VSS sg13g2_decap_8
* cell instance $198372 m0 *1 763.2,396.9
X$198372 VDD VSS sg13g2_decap_8
* cell instance $198373 m0 *1 679.2,389.34
X$198373 VDD VSS sg13g2_decap_8
* cell instance $198374 m0 *1 514.56,396.9
X$198374 VDD VSS sg13g2_decap_8
* cell instance $198375 m0 *1 689.28,374.22
X$198375 VDD VSS sg13g2_decap_8
* cell instance $198376 m0 *1 514.56,389.34
X$198376 VDD VSS sg13g2_decap_8
* cell instance $198377 m0 *1 746.4,389.34
X$198377 VDD VSS sg13g2_decap_8
* cell instance $198378 m0 *1 514.56,381.78
X$198378 VDD VSS sg13g2_decap_8
* cell instance $198379 m0 *1 743.04,389.34
X$198379 VDD VSS sg13g2_decap_8
* cell instance $198380 m0 *1 732.96,389.34
X$198380 VDD VSS sg13g2_decap_8
* cell instance $198381 m0 *1 722.88,389.34
X$198381 VDD VSS sg13g2_decap_8
* cell instance $198382 m0 *1 578.4,782.46
X$198382 VDD VSS sg13g2_decap_8
* cell instance $198383 m0 *1 719.52,389.34
X$198383 VDD VSS sg13g2_decap_8
* cell instance $198384 m0 *1 582.72,790.02
X$198384 VDD VSS sg13g2_decap_8
* cell instance $198385 m0 *1 736.32,389.34
X$198385 VDD VSS sg13g2_decap_8
* cell instance $198386 m0 *1 561.6,782.46
X$198386 VDD VSS sg13g2_decap_8
* cell instance $198387 m0 *1 427.2,381.78
X$198387 VDD VSS sg13g2_decap_8
* cell instance $198388 m0 *1 579.36,790.02
X$198388 VDD VSS sg13g2_decap_8
* cell instance $198389 m0 *1 575.04,782.46
X$198389 VDD VSS sg13g2_decap_8
* cell instance $198390 m0 *1 585.12,782.46
X$198390 VDD VSS sg13g2_decap_8
* cell instance $198391 m0 *1 689.28,389.34
X$198391 VDD VSS sg13g2_decap_8
* cell instance $198392 m0 *1 588.48,782.46
X$198392 VDD VSS sg13g2_decap_8
* cell instance $198393 m0 *1 576,790.02
X$198393 VDD VSS sg13g2_decap_8
* cell instance $198394 m0 *1 420.48,381.78
X$198394 VDD VSS sg13g2_decap_8
* cell instance $198395 m0 *1 430.56,381.78
X$198395 VDD VSS sg13g2_decap_8
* cell instance $198396 m0 *1 558.24,782.46
X$198396 VDD VSS sg13g2_decap_8
* cell instance $198397 m0 *1 571.68,782.46
X$198397 VDD VSS sg13g2_decap_8
* cell instance $198398 m0 *1 739.68,389.34
X$198398 VDD VSS sg13g2_decap_8
* cell instance $198399 m0 *1 413.76,374.22
X$198399 VDD VSS sg13g2_decap_8
* cell instance $198400 m0 *1 417.12,374.22
X$198400 VDD VSS sg13g2_decap_8
* cell instance $198401 m0 *1 589.44,790.02
X$198401 VDD VSS sg13g2_decap_8
* cell instance $198402 m0 *1 569.28,805.14
X$198402 VDD VSS sg13g2_decap_8
* cell instance $198403 m0 *1 787.68,412.02
X$198403 VDD VSS sg13g2_decap_8
* cell instance $198404 m0 *1 780.96,404.46
X$198404 VDD VSS sg13g2_decap_8
* cell instance $198405 m0 *1 559.2,805.14
X$198405 VDD VSS sg13g2_decap_8
* cell instance $198406 m0 *1 777.6,412.02
X$198406 VDD VSS sg13g2_decap_8
* cell instance $198407 m0 *1 565.92,812.7
X$198407 VDD VSS sg13g2_decap_8
* cell instance $198408 m0 *1 740.64,412.02
X$198408 VDD VSS sg13g2_decap_8
* cell instance $198409 m0 *1 555.84,827.82
X$198409 VDD VSS sg13g2_decap_8
* cell instance $198410 m0 *1 562.56,827.82
X$198410 VDD VSS sg13g2_decap_8
* cell instance $198411 m0 *1 565.92,827.82
X$198411 VDD VSS sg13g2_decap_8
* cell instance $198412 m0 *1 784.32,412.02
X$198412 VDD VSS sg13g2_decap_8
* cell instance $198413 m0 *1 784.32,404.46
X$198413 VDD VSS sg13g2_decap_8
* cell instance $198414 m0 *1 824.64,427.14
X$198414 VDD VSS sg13g2_decap_8
* cell instance $198415 m0 *1 460.8,381.78
X$198415 VDD VSS sg13g2_decap_8
* cell instance $198416 m0 *1 774.24,412.02
X$198416 VDD VSS sg13g2_decap_8
* cell instance $198417 m0 *1 464.16,389.34
X$198417 VDD VSS sg13g2_decap_8
* cell instance $198418 m0 *1 780.96,412.02
X$198418 VDD VSS sg13g2_decap_8
* cell instance $198419 m0 *1 559.2,820.26
X$198419 VDD VSS sg13g2_decap_8
* cell instance $198420 m0 *1 744,427.14
X$198420 VDD VSS sg13g2_decap_8
* cell instance $198421 m0 *1 470.88,381.78
X$198421 VDD VSS sg13g2_decap_8
* cell instance $198422 m0 *1 467.52,381.78
X$198422 VDD VSS sg13g2_decap_8
* cell instance $198423 m0 *1 774.24,404.46
X$198423 VDD VSS sg13g2_decap_8
* cell instance $198424 m0 *1 464.16,381.78
X$198424 VDD VSS sg13g2_decap_8
* cell instance $198425 m0 *1 457.44,389.34
X$198425 VDD VSS sg13g2_decap_8
* cell instance $198426 m0 *1 569.28,827.82
X$198426 VDD VSS sg13g2_decap_8
* cell instance $198427 m0 *1 562.56,820.26
X$198427 VDD VSS sg13g2_decap_8
* cell instance $198428 m0 *1 777.6,404.46
X$198428 VDD VSS sg13g2_decap_8
* cell instance $198429 m0 *1 582.72,812.7
X$198429 VDD VSS sg13g2_decap_8
* cell instance $198430 m0 *1 586.08,812.7
X$198430 VDD VSS sg13g2_decap_8
* cell instance $198431 m0 *1 582.72,805.14
X$198431 VDD VSS sg13g2_decap_8
* cell instance $198432 m0 *1 760.8,427.14
X$198432 VDD VSS sg13g2_decap_8
* cell instance $198433 m0 *1 589.44,812.7
X$198433 VDD VSS sg13g2_decap_8
* cell instance $198434 m0 *1 764.16,427.14
X$198434 VDD VSS sg13g2_decap_8
* cell instance $198435 m0 *1 767.52,427.14
X$198435 VDD VSS sg13g2_decap_8
* cell instance $198436 m0 *1 576,812.7
X$198436 VDD VSS sg13g2_decap_8
* cell instance $198437 m0 *1 692.64,374.22
X$198437 VDD VSS sg13g2_decap_8
* cell instance $198438 m0 *1 586.08,805.14
X$198438 VDD VSS sg13g2_decap_8
* cell instance $198439 m0 *1 569.28,812.7
X$198439 VDD VSS sg13g2_decap_8
* cell instance $198440 m0 *1 767.52,404.46
X$198440 VDD VSS sg13g2_decap_8
* cell instance $198441 m0 *1 760.8,404.46
X$198441 VDD VSS sg13g2_decap_8
* cell instance $198442 m0 *1 787.68,404.46
X$198442 VDD VSS sg13g2_decap_8
* cell instance $198443 m0 *1 565.92,805.14
X$198443 VDD VSS sg13g2_decap_8
* cell instance $198444 m0 *1 562.56,812.7
X$198444 VDD VSS sg13g2_decap_8
* cell instance $198445 m0 *1 764.16,404.46
X$198445 VDD VSS sg13g2_decap_8
* cell instance $198446 m0 *1 760.8,412.02
X$198446 VDD VSS sg13g2_decap_8
* cell instance $198447 m0 *1 764.16,412.02
X$198447 VDD VSS sg13g2_decap_8
* cell instance $198448 m0 *1 555.84,805.14
X$198448 VDD VSS sg13g2_decap_8
* cell instance $198449 m0 *1 757.44,412.02
X$198449 VDD VSS sg13g2_decap_8
* cell instance $198450 m0 *1 740.64,419.58
X$198450 VDD VSS sg13g2_decap_8
* cell instance $198451 m0 *1 555.84,812.7
X$198451 VDD VSS sg13g2_decap_8
* cell instance $198452 m0 *1 757.44,404.46
X$198452 VDD VSS sg13g2_decap_8
* cell instance $198453 m0 *1 744,412.02
X$198453 VDD VSS sg13g2_decap_8
* cell instance $198454 m0 *1 559.2,812.7
X$198454 VDD VSS sg13g2_decap_8
* cell instance $198455 m0 *1 767.52,412.02
X$198455 VDD VSS sg13g2_decap_8
* cell instance $198456 m0 *1 562.56,805.14
X$198456 VDD VSS sg13g2_decap_8
* cell instance $198457 m0 *1 554.88,782.46
X$198457 VDD VSS sg13g2_decap_8
* cell instance $198458 m0 *1 447.36,381.78
X$198458 VDD VSS sg13g2_decap_8
* cell instance $198459 m0 *1 552.48,812.7
X$198459 VDD VSS sg13g2_decap_8
* cell instance $198460 m0 *1 552.48,820.26
X$198460 VDD VSS sg13g2_decap_8
* cell instance $198461 m0 *1 552.48,827.82
X$198461 VDD VSS sg13g2_decap_8
* cell instance $198462 m0 *1 545.76,797.58
X$198462 VDD VSS sg13g2_decap_8
* cell instance $198463 m0 *1 549.12,797.58
X$198463 VDD VSS sg13g2_decap_8
* cell instance $198464 m0 *1 535.68,797.58
X$198464 VDD VSS sg13g2_decap_8
* cell instance $198465 m0 *1 542.4,797.58
X$198465 VDD VSS sg13g2_decap_8
* cell instance $198466 m0 *1 539.04,797.58
X$198466 VDD VSS sg13g2_decap_8
* cell instance $198467 m0 *1 515.52,797.58
X$198467 VDD VSS sg13g2_decap_8
* cell instance $198468 m0 *1 522.24,797.58
X$198468 VDD VSS sg13g2_decap_8
* cell instance $198469 m0 *1 747.36,427.14
X$198469 VDD VSS sg13g2_decap_8
* cell instance $198470 m0 *1 528.96,797.58
X$198470 VDD VSS sg13g2_decap_8
* cell instance $198471 m0 *1 525.6,797.58
X$198471 VDD VSS sg13g2_decap_8
* cell instance $198472 m0 *1 532.32,797.58
X$198472 VDD VSS sg13g2_decap_8
* cell instance $198473 m0 *1 576,797.58
X$198473 VDD VSS sg13g2_decap_8
* cell instance $198474 m0 *1 586.08,797.58
X$198474 VDD VSS sg13g2_decap_8
* cell instance $198475 m0 *1 582.72,797.58
X$198475 VDD VSS sg13g2_decap_8
* cell instance $198476 m0 *1 579.36,797.58
X$198476 VDD VSS sg13g2_decap_8
* cell instance $198477 m0 *1 589.44,797.58
X$198477 VDD VSS sg13g2_decap_8
* cell instance $198478 m0 *1 565.92,797.58
X$198478 VDD VSS sg13g2_decap_8
* cell instance $198479 m0 *1 569.28,797.58
X$198479 VDD VSS sg13g2_decap_8
* cell instance $198480 m0 *1 562.56,797.58
X$198480 VDD VSS sg13g2_decap_8
* cell instance $198481 m0 *1 559.2,797.58
X$198481 VDD VSS sg13g2_decap_8
* cell instance $198482 m0 *1 555.84,797.58
X$198482 VDD VSS sg13g2_decap_8
* cell instance $198483 m0 *1 518.88,797.58
X$198483 VDD VSS sg13g2_decap_8
* cell instance $198484 m0 *1 569.28,820.26
X$198484 VDD VSS sg13g2_decap_8
* cell instance $198485 m0 *1 565.92,820.26
X$198485 VDD VSS sg13g2_decap_8
* cell instance $198486 m0 *1 744,404.46
X$198486 VDD VSS sg13g2_decap_8
* cell instance $198487 m0 *1 457.44,381.78
X$198487 VDD VSS sg13g2_decap_8
* cell instance $198488 m0 *1 555.84,820.26
X$198488 VDD VSS sg13g2_decap_8
* cell instance $198489 m0 *1 460.8,389.34
X$198489 VDD VSS sg13g2_decap_8
* cell instance $198490 m0 *1 467.52,389.34
X$198490 VDD VSS sg13g2_decap_8
* cell instance $198491 m0 *1 740.64,404.46
X$198491 VDD VSS sg13g2_decap_8
* cell instance $198492 m0 *1 470.88,389.34
X$198492 VDD VSS sg13g2_decap_8
* cell instance $198493 m0 *1 773.28,389.34
X$198493 VDD VSS sg13g2_decap_8
* cell instance $198494 m0 *1 447.36,389.34
X$198494 VDD VSS sg13g2_decap_8
* cell instance $198495 m0 *1 773.28,381.78
X$198495 VDD VSS sg13g2_decap_8
* cell instance $198496 m0 *1 773.28,374.22
X$198496 VDD VSS sg13g2_decap_8
* cell instance $198497 m0 *1 783.36,381.78
X$198497 VDD VSS sg13g2_decap_8
* cell instance $198498 m0 *1 740.64,427.14
X$198498 VDD VSS sg13g2_decap_8
* cell instance $198499 m0 *1 747.36,404.46
X$198499 VDD VSS sg13g2_decap_8
* cell instance $198500 m0 *1 780,381.78
X$198500 VDD VSS sg13g2_decap_8
* cell instance $198501 m0 *1 786.72,389.34
X$198501 VDD VSS sg13g2_decap_8
* cell instance $198502 m0 *1 576,820.26
X$198502 VDD VSS sg13g2_decap_8
* cell instance $198503 m0 *1 780,389.34
X$198503 VDD VSS sg13g2_decap_8
* cell instance $198504 m0 *1 786.72,381.78
X$198504 VDD VSS sg13g2_decap_8
* cell instance $198505 m0 *1 440.64,389.34
X$198505 VDD VSS sg13g2_decap_8
* cell instance $198506 m0 *1 776.64,381.78
X$198506 VDD VSS sg13g2_decap_8
* cell instance $198507 m0 *1 776.64,389.34
X$198507 VDD VSS sg13g2_decap_8
* cell instance $198508 m0 *1 783.36,389.34
X$198508 VDD VSS sg13g2_decap_8
* cell instance $198509 m0 *1 737.28,419.58
X$198509 VDD VSS sg13g2_decap_8
* cell instance $198510 m0 *1 552.48,805.14
X$198510 VDD VSS sg13g2_decap_8
* cell instance $198511 m0 *1 559.2,827.82
X$198511 VDD VSS sg13g2_decap_8
* cell instance $198512 m0 *1 797.76,412.02
X$198512 VDD VSS sg13g2_decap_8
* cell instance $198513 m0 *1 794.4,412.02
X$198513 VDD VSS sg13g2_decap_8
* cell instance $198514 m0 *1 504.48,396.9
X$198514 VDD VSS sg13g2_decap_8
* cell instance $198515 m0 *1 549.12,820.26
X$198515 VDD VSS sg13g2_decap_8
* cell instance $198516 m0 *1 474.24,381.78
X$198516 VDD VSS sg13g2_decap_8
* cell instance $198517 m0 *1 539.04,820.26
X$198517 VDD VSS sg13g2_decap_8
* cell instance $198518 m0 *1 706.08,389.34
X$198518 VDD VSS sg13g2_decap_8
* cell instance $198519 m0 *1 807.84,404.46
X$198519 VDD VSS sg13g2_decap_8
* cell instance $198520 m0 *1 474.24,396.9
X$198520 VDD VSS sg13g2_decap_8
* cell instance $198521 m0 *1 702.72,389.34
X$198521 VDD VSS sg13g2_decap_8
* cell instance $198522 m0 *1 801.12,412.02
X$198522 VDD VSS sg13g2_decap_8
* cell instance $198523 m0 *1 804.48,404.46
X$198523 VDD VSS sg13g2_decap_8
* cell instance $198524 m0 *1 454.08,389.34
X$198524 VDD VSS sg13g2_decap_8
* cell instance $198525 m0 *1 532.32,820.26
X$198525 VDD VSS sg13g2_decap_8
* cell instance $198526 m0 *1 532.32,812.7
X$198526 VDD VSS sg13g2_decap_8
* cell instance $198527 m0 *1 824.64,412.02
X$198527 VDD VSS sg13g2_decap_8
* cell instance $198528 m0 *1 497.76,396.9
X$198528 VDD VSS sg13g2_decap_8
* cell instance $198529 m0 *1 494.4,396.9
X$198529 VDD VSS sg13g2_decap_8
* cell instance $198530 m0 *1 821.28,412.02
X$198530 VDD VSS sg13g2_decap_8
* cell instance $198531 m0 *1 828,412.02
X$198531 VDD VSS sg13g2_decap_8
* cell instance $198532 m0 *1 487.68,396.9
X$198532 VDD VSS sg13g2_decap_8
* cell instance $198533 m0 *1 474.24,389.34
X$198533 VDD VSS sg13g2_decap_8
* cell instance $198534 m0 *1 470.88,396.9
X$198534 VDD VSS sg13g2_decap_8
* cell instance $198535 m0 *1 824.64,404.46
X$198535 VDD VSS sg13g2_decap_8
* cell instance $198536 m0 *1 480.96,396.9
X$198536 VDD VSS sg13g2_decap_8
* cell instance $198537 m0 *1 814.56,404.46
X$198537 VDD VSS sg13g2_decap_8
* cell instance $198538 m0 *1 501.12,396.9
X$198538 VDD VSS sg13g2_decap_8
* cell instance $198539 m0 *1 528.96,827.82
X$198539 VDD VSS sg13g2_decap_8
* cell instance $198540 m0 *1 828,427.14
X$198540 VDD VSS sg13g2_decap_8
* cell instance $198541 m0 *1 709.44,381.78
X$198541 VDD VSS sg13g2_decap_8
* cell instance $198542 m0 *1 522.24,827.82
X$198542 VDD VSS sg13g2_decap_8
* cell instance $198543 m0 *1 464.16,396.9
X$198543 VDD VSS sg13g2_decap_8
* cell instance $198544 m0 *1 797.76,427.14
X$198544 VDD VSS sg13g2_decap_8
* cell instance $198545 m0 *1 807.84,427.14
X$198545 VDD VSS sg13g2_decap_8
* cell instance $198546 m0 *1 794.4,427.14
X$198546 VDD VSS sg13g2_decap_8
* cell instance $198547 m0 *1 460.8,396.9
X$198547 VDD VSS sg13g2_decap_8
* cell instance $198548 m0 *1 511.2,396.9
X$198548 VDD VSS sg13g2_decap_8
* cell instance $198549 m0 *1 801.12,427.14
X$198549 VDD VSS sg13g2_decap_8
* cell instance $198550 m0 *1 542.4,820.26
X$198550 VDD VSS sg13g2_decap_8
* cell instance $198551 m0 *1 545.76,820.26
X$198551 VDD VSS sg13g2_decap_8
* cell instance $198552 m0 *1 545.76,827.82
X$198552 VDD VSS sg13g2_decap_8
* cell instance $198553 m0 *1 699.36,389.34
X$198553 VDD VSS sg13g2_decap_8
* cell instance $198554 m0 *1 699.36,381.78
X$198554 VDD VSS sg13g2_decap_8
* cell instance $198555 m0 *1 539.04,827.82
X$198555 VDD VSS sg13g2_decap_8
* cell instance $198556 m0 *1 797.76,404.46
X$198556 VDD VSS sg13g2_decap_8
* cell instance $198557 m0 *1 794.4,404.46
X$198557 VDD VSS sg13g2_decap_8
* cell instance $198558 m0 *1 535.68,820.26
X$198558 VDD VSS sg13g2_decap_8
* cell instance $198559 m0 *1 542.4,827.82
X$198559 VDD VSS sg13g2_decap_8
* cell instance $198560 m0 *1 535.68,827.82
X$198560 VDD VSS sg13g2_decap_8
* cell instance $198561 m0 *1 507.84,396.9
X$198561 VDD VSS sg13g2_decap_8
* cell instance $198562 m0 *1 549.12,827.82
X$198562 VDD VSS sg13g2_decap_8
* cell instance $198563 m0 *1 807.84,412.02
X$198563 VDD VSS sg13g2_decap_8
* cell instance $198564 m0 *1 801.12,404.46
X$198564 VDD VSS sg13g2_decap_8
* cell instance $198565 m0 *1 804.48,412.02
X$198565 VDD VSS sg13g2_decap_8
* cell instance $198566 m0 *1 804.48,427.14
X$198566 VDD VSS sg13g2_decap_8
* cell instance $198567 m0 *1 447.36,396.9
X$198567 VDD VSS sg13g2_decap_8
* cell instance $198568 m0 *1 770.88,412.02
X$198568 VDD VSS sg13g2_decap_8
* cell instance $198569 m0 *1 589.44,827.82
X$198569 VDD VSS sg13g2_decap_8
* cell instance $198570 m0 *1 770.88,419.58
X$198570 VDD VSS sg13g2_decap_8
* cell instance $198571 m0 *1 692.64,381.78
X$198571 VDD VSS sg13g2_decap_8
* cell instance $198572 m0 *1 579.36,820.26
X$198572 VDD VSS sg13g2_decap_8
* cell instance $198573 m0 *1 572.64,805.14
X$198573 VDD VSS sg13g2_decap_8
* cell instance $198574 m0 *1 572.64,827.82
X$198574 VDD VSS sg13g2_decap_8
* cell instance $198575 m0 *1 692.64,389.34
X$198575 VDD VSS sg13g2_decap_8
* cell instance $198576 m0 *1 770.88,427.14
X$198576 VDD VSS sg13g2_decap_8
* cell instance $198577 m0 *1 780.96,419.58
X$198577 VDD VSS sg13g2_decap_8
* cell instance $198578 m0 *1 777.6,419.58
X$198578 VDD VSS sg13g2_decap_8
* cell instance $198579 m0 *1 467.52,396.9
X$198579 VDD VSS sg13g2_decap_8
* cell instance $198580 m0 *1 774.24,427.14
X$198580 VDD VSS sg13g2_decap_8
* cell instance $198581 m0 *1 780.96,427.14
X$198581 VDD VSS sg13g2_decap_8
* cell instance $198582 m0 *1 589.44,805.14
X$198582 VDD VSS sg13g2_decap_8
* cell instance $198583 m0 *1 454.08,374.22
X$198583 VDD VSS sg13g2_decap_8
* cell instance $198584 m0 *1 454.08,381.78
X$198584 VDD VSS sg13g2_decap_8
* cell instance $198585 m0 *1 579.36,812.7
X$198585 VDD VSS sg13g2_decap_8
* cell instance $198586 m0 *1 784.32,427.14
X$198586 VDD VSS sg13g2_decap_8
* cell instance $198587 m0 *1 777.6,427.14
X$198587 VDD VSS sg13g2_decap_8
* cell instance $198588 m0 *1 787.68,427.14
X$198588 VDD VSS sg13g2_decap_8
* cell instance $198589 m0 *1 757.44,427.14
X$198589 VDD VSS sg13g2_decap_8
* cell instance $198590 m0 *1 576,805.14
X$198590 VDD VSS sg13g2_decap_8
* cell instance $198591 m0 *1 572.64,812.7
X$198591 VDD VSS sg13g2_decap_8
* cell instance $198592 m0 *1 579.36,805.14
X$198592 VDD VSS sg13g2_decap_8
* cell instance $198593 m0 *1 572.64,820.26
X$198593 VDD VSS sg13g2_decap_8
* cell instance $198594 m0 *1 828,404.46
X$198594 VDD VSS sg13g2_decap_8
* cell instance $198595 m0 *1 491.04,396.9
X$198595 VDD VSS sg13g2_decap_8
* cell instance $198596 m0 *1 532.32,805.14
X$198596 VDD VSS sg13g2_decap_8
* cell instance $198597 m0 *1 821.28,404.46
X$198597 VDD VSS sg13g2_decap_8
* cell instance $198598 m0 *1 817.92,412.02
X$198598 VDD VSS sg13g2_decap_8
* cell instance $198599 m0 *1 477.6,396.9
X$198599 VDD VSS sg13g2_decap_8
* cell instance $198600 m0 *1 532.32,827.82
X$198600 VDD VSS sg13g2_decap_8
* cell instance $198601 m0 *1 814.56,412.02
X$198601 VDD VSS sg13g2_decap_8
* cell instance $198602 m0 *1 817.92,404.46
X$198602 VDD VSS sg13g2_decap_8
* cell instance $198603 m0 *1 784.32,419.58
X$198603 VDD VSS sg13g2_decap_8
* cell instance $198604 m0 *1 774.24,419.58
X$198604 VDD VSS sg13g2_decap_8
* cell instance $198605 m0 *1 586.08,820.26
X$198605 VDD VSS sg13g2_decap_8
* cell instance $198606 m0 *1 787.68,419.58
X$198606 VDD VSS sg13g2_decap_8
* cell instance $198607 m0 *1 454.08,396.9
X$198607 VDD VSS sg13g2_decap_8
* cell instance $198608 m0 *1 579.36,827.82
X$198608 VDD VSS sg13g2_decap_8
* cell instance $198609 m0 *1 582.72,827.82
X$198609 VDD VSS sg13g2_decap_8
* cell instance $198610 m0 *1 484.32,396.9
X$198610 VDD VSS sg13g2_decap_8
* cell instance $198611 m0 *1 767.52,419.58
X$198611 VDD VSS sg13g2_decap_8
* cell instance $198612 m0 *1 586.08,827.82
X$198612 VDD VSS sg13g2_decap_8
* cell instance $198613 m0 *1 770.88,404.46
X$198613 VDD VSS sg13g2_decap_8
* cell instance $198614 m0 *1 757.44,419.58
X$198614 VDD VSS sg13g2_decap_8
* cell instance $198615 m0 *1 760.8,419.58
X$198615 VDD VSS sg13g2_decap_8
* cell instance $198616 m0 *1 764.16,419.58
X$198616 VDD VSS sg13g2_decap_8
* cell instance $198617 m0 *1 440.64,396.9
X$198617 VDD VSS sg13g2_decap_8
* cell instance $198618 m0 *1 582.72,820.26
X$198618 VDD VSS sg13g2_decap_8
* cell instance $198619 m0 *1 437.28,396.9
X$198619 VDD VSS sg13g2_decap_8
* cell instance $198620 m0 *1 457.44,396.9
X$198620 VDD VSS sg13g2_decap_8
* cell instance $198621 m0 *1 576,827.82
X$198621 VDD VSS sg13g2_decap_8
* cell instance $198622 m0 *1 502.08,827.82
X$198622 VDD VSS sg13g2_decap_8
* cell instance $198623 m0 *1 535.68,835.38
X$198623 VDD VSS sg13g2_decap_8
* cell instance $198624 m0 *1 492,805.14
X$198624 VDD VSS sg13g2_decap_8
* cell instance $198625 m0 *1 512.16,827.82
X$198625 VDD VSS sg13g2_decap_8
* cell instance $198626 m0 *1 628.8,389.34
X$198626 VDD VSS sg13g2_decap_8
* cell instance $198627 m0 *1 502.08,820.26
X$198627 VDD VSS sg13g2_decap_8
* cell instance $198628 m0 *1 528,381.78
X$198628 VDD VSS sg13g2_decap_8
* cell instance $198629 m0 *1 522.24,835.38
X$198629 VDD VSS sg13g2_decap_8
* cell instance $198630 m0 *1 528,389.34
X$198630 VDD VSS sg13g2_decap_8
* cell instance $198631 m0 *1 508.8,835.38
X$198631 VDD VSS sg13g2_decap_8
* cell instance $198632 m0 *1 521.28,381.78
X$198632 VDD VSS sg13g2_decap_8
* cell instance $198633 m0 *1 455.04,805.14
X$198633 VDD VSS sg13g2_decap_8
* cell instance $198634 m0 *1 932.16,404.46
X$198634 VDD VSS sg13g2_decap_8
* cell instance $198635 m0 *1 524.64,381.78
X$198635 VDD VSS sg13g2_decap_8
* cell instance $198636 m0 *1 932.16,427.14
X$198636 VDD VSS sg13g2_decap_8
* cell instance $198637 m0 *1 635.52,396.9
X$198637 VDD VSS sg13g2_decap_8
* cell instance $198638 m0 *1 531.36,381.78
X$198638 VDD VSS sg13g2_decap_8
* cell instance $198639 m0 *1 474.24,782.46
X$198639 VDD VSS sg13g2_decap_8
* cell instance $198640 m0 *1 531.36,389.34
X$198640 VDD VSS sg13g2_decap_8
* cell instance $198641 m0 *1 932.16,419.58
X$198641 VDD VSS sg13g2_decap_8
* cell instance $198642 m0 *1 948.96,419.58
X$198642 VDD VSS sg13g2_decap_8
* cell instance $198643 m0 *1 942.24,419.58
X$198643 VDD VSS sg13g2_decap_8
* cell instance $198644 m0 *1 568.32,381.78
X$198644 VDD VSS sg13g2_decap_8
* cell instance $198645 m0 *1 481.92,805.14
X$198645 VDD VSS sg13g2_decap_8
* cell instance $198646 m0 *1 498.72,805.14
X$198646 VDD VSS sg13g2_decap_8
* cell instance $198647 m0 *1 975.84,404.46
X$198647 VDD VSS sg13g2_decap_8
* cell instance $198648 m0 *1 502.08,805.14
X$198648 VDD VSS sg13g2_decap_8
* cell instance $198649 m0 *1 538.08,381.78
X$198649 VDD VSS sg13g2_decap_8
* cell instance $198650 m0 *1 925.44,419.58
X$198650 VDD VSS sg13g2_decap_8
* cell instance $198651 m0 *1 505.44,805.14
X$198651 VDD VSS sg13g2_decap_8
* cell instance $198652 m0 *1 928.8,419.58
X$198652 VDD VSS sg13g2_decap_8
* cell instance $198653 m0 *1 502.08,812.7
X$198653 VDD VSS sg13g2_decap_8
* cell instance $198654 m0 *1 915.36,419.58
X$198654 VDD VSS sg13g2_decap_8
* cell instance $198655 m0 *1 488.64,805.14
X$198655 VDD VSS sg13g2_decap_8
* cell instance $198656 m0 *1 608.64,381.78
X$198656 VDD VSS sg13g2_decap_8
* cell instance $198657 m0 *1 485.28,812.7
X$198657 VDD VSS sg13g2_decap_8
* cell instance $198658 m0 *1 485.28,805.14
X$198658 VDD VSS sg13g2_decap_8
* cell instance $198659 m0 *1 615.36,389.34
X$198659 VDD VSS sg13g2_decap_8
* cell instance $198660 m0 *1 488.64,812.7
X$198660 VDD VSS sg13g2_decap_8
* cell instance $198661 m0 *1 532.32,835.38
X$198661 VDD VSS sg13g2_decap_8
* cell instance $198662 m0 *1 492,827.82
X$198662 VDD VSS sg13g2_decap_8
* cell instance $198663 m0 *1 932.16,412.02
X$198663 VDD VSS sg13g2_decap_8
* cell instance $198664 m0 *1 481.92,812.7
X$198664 VDD VSS sg13g2_decap_8
* cell instance $198665 m0 *1 478.56,805.14
X$198665 VDD VSS sg13g2_decap_8
* cell instance $198666 m0 *1 539.04,835.38
X$198666 VDD VSS sg13g2_decap_8
* cell instance $198667 m0 *1 478.56,812.7
X$198667 VDD VSS sg13g2_decap_8
* cell instance $198668 m0 *1 498.72,827.82
X$198668 VDD VSS sg13g2_decap_8
* cell instance $198669 m0 *1 492,812.7
X$198669 VDD VSS sg13g2_decap_8
* cell instance $198670 m0 *1 548.16,381.78
X$198670 VDD VSS sg13g2_decap_8
* cell instance $198671 m0 *1 475.2,812.7
X$198671 VDD VSS sg13g2_decap_8
* cell instance $198672 m0 *1 524.64,389.34
X$198672 VDD VSS sg13g2_decap_8
* cell instance $198673 m0 *1 928.8,427.14
X$198673 VDD VSS sg13g2_decap_8
* cell instance $198674 m0 *1 475.2,827.82
X$198674 VDD VSS sg13g2_decap_8
* cell instance $198675 m0 *1 475.2,820.26
X$198675 VDD VSS sg13g2_decap_8
* cell instance $198676 m0 *1 915.36,427.14
X$198676 VDD VSS sg13g2_decap_8
* cell instance $198677 m0 *1 968.16,374.22
X$198677 VDD VSS sg13g2_decap_8
* cell instance $198678 m0 *1 925.44,427.14
X$198678 VDD VSS sg13g2_decap_8
* cell instance $198679 m0 *1 922.08,427.14
X$198679 VDD VSS sg13g2_decap_8
* cell instance $198680 m0 *1 512.16,812.7
X$198680 VDD VSS sg13g2_decap_8
* cell instance $198681 m0 *1 655.68,396.9
X$198681 VDD VSS sg13g2_decap_8
* cell instance $198682 m0 *1 471.84,790.02
X$198682 VDD VSS sg13g2_decap_8
* cell instance $198683 m0 *1 922.08,412.02
X$198683 VDD VSS sg13g2_decap_8
* cell instance $198684 m0 *1 455.04,797.58
X$198684 VDD VSS sg13g2_decap_8
* cell instance $198685 m0 *1 588.48,374.22
X$198685 VDD VSS sg13g2_decap_8
* cell instance $198686 m0 *1 468.48,797.58
X$198686 VDD VSS sg13g2_decap_8
* cell instance $198687 m0 *1 465.12,797.58
X$198687 VDD VSS sg13g2_decap_8
* cell instance $198688 m0 *1 458.4,797.58
X$198688 VDD VSS sg13g2_decap_8
* cell instance $198689 m0 *1 648.96,396.9
X$198689 VDD VSS sg13g2_decap_8
* cell instance $198690 m0 *1 461.76,797.58
X$198690 VDD VSS sg13g2_decap_8
* cell instance $198691 m0 *1 448.32,797.58
X$198691 VDD VSS sg13g2_decap_8
* cell instance $198692 m0 *1 642.24,396.9
X$198692 VDD VSS sg13g2_decap_8
* cell instance $198693 m0 *1 441.6,797.58
X$198693 VDD VSS sg13g2_decap_8
* cell instance $198694 m0 *1 964.8,374.22
X$198694 VDD VSS sg13g2_decap_8
* cell instance $198695 m0 *1 945.6,419.58
X$198695 VDD VSS sg13g2_decap_8
* cell instance $198696 m0 *1 471.84,805.14
X$198696 VDD VSS sg13g2_decap_8
* cell instance $198697 m0 *1 471.84,812.7
X$198697 VDD VSS sg13g2_decap_8
* cell instance $198698 m0 *1 938.88,419.58
X$198698 VDD VSS sg13g2_decap_8
* cell instance $198699 m0 *1 512.16,835.38
X$198699 VDD VSS sg13g2_decap_8
* cell instance $198700 m0 *1 471.84,827.82
X$198700 VDD VSS sg13g2_decap_8
* cell instance $198701 m0 *1 935.52,419.58
X$198701 VDD VSS sg13g2_decap_8
* cell instance $198702 m0 *1 918.72,419.58
X$198702 VDD VSS sg13g2_decap_8
* cell instance $198703 m0 *1 471.84,820.26
X$198703 VDD VSS sg13g2_decap_8
* cell instance $198704 m0 *1 922.08,419.58
X$198704 VDD VSS sg13g2_decap_8
* cell instance $198705 m0 *1 942.24,427.14
X$198705 VDD VSS sg13g2_decap_8
* cell instance $198706 m0 *1 954.72,374.22
X$198706 VDD VSS sg13g2_decap_8
* cell instance $198707 m0 *1 961.44,374.22
X$198707 VDD VSS sg13g2_decap_8
* cell instance $198708 m0 *1 948.96,427.14
X$198708 VDD VSS sg13g2_decap_8
* cell instance $198709 m0 *1 958.08,374.22
X$198709 VDD VSS sg13g2_decap_8
* cell instance $198710 m0 *1 517.92,381.78
X$198710 VDD VSS sg13g2_decap_8
* cell instance $198711 m0 *1 938.88,427.14
X$198711 VDD VSS sg13g2_decap_8
* cell instance $198712 m0 *1 515.52,835.38
X$198712 VDD VSS sg13g2_decap_8
* cell instance $198713 m0 *1 935.52,427.14
X$198713 VDD VSS sg13g2_decap_8
* cell instance $198714 m0 *1 518.88,835.38
X$198714 VDD VSS sg13g2_decap_8
* cell instance $198715 m0 *1 475.2,790.02
X$198715 VDD VSS sg13g2_decap_8
* cell instance $198716 m0 *1 918.72,427.14
X$198716 VDD VSS sg13g2_decap_8
* cell instance $198717 m0 *1 517.92,389.34
X$198717 VDD VSS sg13g2_decap_8
* cell instance $198718 m0 *1 475.2,805.14
X$198718 VDD VSS sg13g2_decap_8
* cell instance $198719 m0 *1 945.6,427.14
X$198719 VDD VSS sg13g2_decap_8
* cell instance $198720 m0 *1 481.92,820.26
X$198720 VDD VSS sg13g2_decap_8
* cell instance $198721 m0 *1 959.04,419.58
X$198721 VDD VSS sg13g2_decap_8
* cell instance $198722 m0 *1 965.76,419.58
X$198722 VDD VSS sg13g2_decap_8
* cell instance $198723 m0 *1 544.8,381.78
X$198723 VDD VSS sg13g2_decap_8
* cell instance $198724 m0 *1 979.2,427.14
X$198724 VDD VSS sg13g2_decap_8
* cell instance $198725 m0 *1 488.64,827.82
X$198725 VDD VSS sg13g2_decap_8
* cell instance $198726 m0 *1 478.56,820.26
X$198726 VDD VSS sg13g2_decap_8
* cell instance $198727 m0 *1 975.84,427.14
X$198727 VDD VSS sg13g2_decap_8
* cell instance $198728 m0 *1 982.56,427.14
X$198728 VDD VSS sg13g2_decap_8
* cell instance $198729 m0 *1 978.24,374.22
X$198729 VDD VSS sg13g2_decap_8
* cell instance $198730 m0 *1 585.12,381.78
X$198730 VDD VSS sg13g2_decap_8
* cell instance $198731 m0 *1 601.92,381.78
X$198731 VDD VSS sg13g2_decap_8
* cell instance $198732 m0 *1 965.76,427.14
X$198732 VDD VSS sg13g2_decap_8
* cell instance $198733 m0 *1 959.04,427.14
X$198733 VDD VSS sg13g2_decap_8
* cell instance $198734 m0 *1 962.4,427.14
X$198734 VDD VSS sg13g2_decap_8
* cell instance $198735 m0 *1 608.64,389.34
X$198735 VDD VSS sg13g2_decap_8
* cell instance $198736 m0 *1 969.12,427.14
X$198736 VDD VSS sg13g2_decap_8
* cell instance $198737 m0 *1 485.28,820.26
X$198737 VDD VSS sg13g2_decap_8
* cell instance $198738 m0 *1 485.28,827.82
X$198738 VDD VSS sg13g2_decap_8
* cell instance $198739 m0 *1 481.92,827.82
X$198739 VDD VSS sg13g2_decap_8
* cell instance $198740 m0 *1 478.56,827.82
X$198740 VDD VSS sg13g2_decap_8
* cell instance $198741 m0 *1 495.36,827.82
X$198741 VDD VSS sg13g2_decap_8
* cell instance $198742 m0 *1 579.36,835.38
X$198742 VDD VSS sg13g2_decap_8
* cell instance $198743 m0 *1 955.68,427.14
X$198743 VDD VSS sg13g2_decap_8
* cell instance $198744 m0 *1 955.68,419.58
X$198744 VDD VSS sg13g2_decap_8
* cell instance $198745 m0 *1 601.92,374.22
X$198745 VDD VSS sg13g2_decap_8
* cell instance $198746 m0 *1 455.04,812.7
X$198746 VDD VSS sg13g2_decap_8
* cell instance $198747 m0 *1 455.04,827.82
X$198747 VDD VSS sg13g2_decap_8
* cell instance $198748 m0 *1 558.24,389.34
X$198748 VDD VSS sg13g2_decap_8
* cell instance $198749 m0 *1 545.76,835.38
X$198749 VDD VSS sg13g2_decap_8
* cell instance $198750 m0 *1 512.16,805.14
X$198750 VDD VSS sg13g2_decap_8
* cell instance $198751 m0 *1 455.04,820.26
X$198751 VDD VSS sg13g2_decap_8
* cell instance $198752 m0 *1 972.48,412.02
X$198752 VDD VSS sg13g2_decap_8
* cell instance $198753 m0 *1 972.48,404.46
X$198753 VDD VSS sg13g2_decap_8
* cell instance $198754 m0 *1 601.92,389.34
X$198754 VDD VSS sg13g2_decap_8
* cell instance $198755 m0 *1 962.4,419.58
X$198755 VDD VSS sg13g2_decap_8
* cell instance $198756 m0 *1 576,835.38
X$198756 VDD VSS sg13g2_decap_8
* cell instance $198757 m0 *1 972.48,419.58
X$198757 VDD VSS sg13g2_decap_8
* cell instance $198758 m0 *1 972.48,427.14
X$198758 VDD VSS sg13g2_decap_8
* cell instance $198759 m0 *1 605.28,389.34
X$198759 VDD VSS sg13g2_decap_8
* cell instance $198760 m0 *1 595.2,389.34
X$198760 VDD VSS sg13g2_decap_8
* cell instance $198761 m0 *1 979.2,419.58
X$198761 VDD VSS sg13g2_decap_8
* cell instance $198762 m0 *1 975.84,419.58
X$198762 VDD VSS sg13g2_decap_8
* cell instance $198763 m0 *1 498.72,820.26
X$198763 VDD VSS sg13g2_decap_8
* cell instance $198764 m0 *1 488.64,820.26
X$198764 VDD VSS sg13g2_decap_8
* cell instance $198765 m0 *1 982.56,419.58
X$198765 VDD VSS sg13g2_decap_8
* cell instance $198766 m0 *1 969.12,419.58
X$198766 VDD VSS sg13g2_decap_8
* cell instance $198767 m0 *1 582.72,835.38
X$198767 VDD VSS sg13g2_decap_8
* cell instance $198768 m0 *1 569.28,835.38
X$198768 VDD VSS sg13g2_decap_8
* cell instance $198769 m0 *1 605.28,381.78
X$198769 VDD VSS sg13g2_decap_8
* cell instance $198770 m0 *1 541.44,389.34
X$198770 VDD VSS sg13g2_decap_8
* cell instance $198771 m0 *1 955.68,404.46
X$198771 VDD VSS sg13g2_decap_8
* cell instance $198772 m0 *1 962.4,404.46
X$198772 VDD VSS sg13g2_decap_8
* cell instance $198773 m0 *1 965.76,404.46
X$198773 VDD VSS sg13g2_decap_8
* cell instance $198774 m0 *1 965.76,412.02
X$198774 VDD VSS sg13g2_decap_8
* cell instance $198775 m0 *1 525.6,835.38
X$198775 VDD VSS sg13g2_decap_8
* cell instance $198776 m0 *1 542.4,835.38
X$198776 VDD VSS sg13g2_decap_8
* cell instance $198777 m0 *1 508.8,805.14
X$198777 VDD VSS sg13g2_decap_8
* cell instance $198778 m0 *1 528.96,835.38
X$198778 VDD VSS sg13g2_decap_8
* cell instance $198779 m0 *1 492,820.26
X$198779 VDD VSS sg13g2_decap_8
* cell instance $198780 m0 *1 541.44,381.78
X$198780 VDD VSS sg13g2_decap_8
* cell instance $198781 m0 *1 979.2,412.02
X$198781 VDD VSS sg13g2_decap_8
* cell instance $198782 m0 *1 508.8,812.7
X$198782 VDD VSS sg13g2_decap_8
* cell instance $198783 m0 *1 632.16,782.46
X$198783 VDD VSS sg13g2_decap_8
* cell instance $198784 m0 *1 975.84,412.02
X$198784 VDD VSS sg13g2_decap_8
* cell instance $198785 m0 *1 505.44,812.7
X$198785 VDD VSS sg13g2_decap_8
* cell instance $198786 m0 *1 982.56,412.02
X$198786 VDD VSS sg13g2_decap_8
* cell instance $198787 m0 *1 982.56,404.46
X$198787 VDD VSS sg13g2_decap_8
* cell instance $198788 m0 *1 495.36,812.7
X$198788 VDD VSS sg13g2_decap_8
* cell instance $198789 m0 *1 979.2,404.46
X$198789 VDD VSS sg13g2_decap_8
* cell instance $198790 m0 *1 538.08,389.34
X$198790 VDD VSS sg13g2_decap_8
* cell instance $198791 m0 *1 544.8,389.34
X$198791 VDD VSS sg13g2_decap_8
* cell instance $198792 m0 *1 495.36,805.14
X$198792 VDD VSS sg13g2_decap_8
* cell instance $198793 m0 *1 498.72,812.7
X$198793 VDD VSS sg13g2_decap_8
* cell instance $198794 m0 *1 586.08,835.38
X$198794 VDD VSS sg13g2_decap_8
* cell instance $198795 m0 *1 505.44,820.26
X$198795 VDD VSS sg13g2_decap_8
* cell instance $198796 m0 *1 508.8,820.26
X$198796 VDD VSS sg13g2_decap_8
* cell instance $198797 m0 *1 595.2,381.78
X$198797 VDD VSS sg13g2_decap_8
* cell instance $198798 m0 *1 959.04,412.02
X$198798 VDD VSS sg13g2_decap_8
* cell instance $198799 m0 *1 572.64,835.38
X$198799 VDD VSS sg13g2_decap_8
* cell instance $198800 m0 *1 508.8,827.82
X$198800 VDD VSS sg13g2_decap_8
* cell instance $198801 m0 *1 598.56,381.78
X$198801 VDD VSS sg13g2_decap_8
* cell instance $198802 m0 *1 505.44,827.82
X$198802 VDD VSS sg13g2_decap_8
* cell instance $198803 m0 *1 549.12,835.38
X$198803 VDD VSS sg13g2_decap_8
* cell instance $198804 m0 *1 564.96,381.78
X$198804 VDD VSS sg13g2_decap_8
* cell instance $198805 m0 *1 981.6,374.22
X$198805 VDD VSS sg13g2_decap_8
* cell instance $198806 m0 *1 959.04,404.46
X$198806 VDD VSS sg13g2_decap_8
* cell instance $198807 m0 *1 555.84,835.38
X$198807 VDD VSS sg13g2_decap_8
* cell instance $198808 m0 *1 495.36,820.26
X$198808 VDD VSS sg13g2_decap_8
* cell instance $198809 m0 *1 955.68,412.02
X$198809 VDD VSS sg13g2_decap_8
* cell instance $198810 m0 *1 969.12,404.46
X$198810 VDD VSS sg13g2_decap_8
* cell instance $198811 m0 *1 562.56,835.38
X$198811 VDD VSS sg13g2_decap_8
* cell instance $198812 m0 *1 565.92,835.38
X$198812 VDD VSS sg13g2_decap_8
* cell instance $198813 m0 *1 969.12,412.02
X$198813 VDD VSS sg13g2_decap_8
* cell instance $198814 m0 *1 552.48,835.38
X$198814 VDD VSS sg13g2_decap_8
* cell instance $198815 m0 *1 548.16,389.34
X$198815 VDD VSS sg13g2_decap_8
* cell instance $198816 m0 *1 559.2,835.38
X$198816 VDD VSS sg13g2_decap_8
* cell instance $198817 m0 *1 598.56,389.34
X$198817 VDD VSS sg13g2_decap_8
* cell instance $198818 m0 *1 962.4,412.02
X$198818 VDD VSS sg13g2_decap_8
* cell instance $198819 m0 *1 608.64,396.9
X$198819 VDD VSS sg13g2_decap_8
* cell instance $198820 m0 *1 667.2,842.94
X$198820 VDD VSS sg13g2_decap_8
* cell instance $198821 m0 *1 927.84,389.34
X$198821 VDD VSS sg13g2_decap_8
* cell instance $198822 m0 *1 981.6,381.78
X$198822 VDD VSS sg13g2_decap_8
* cell instance $198823 m0 *1 921.12,389.34
X$198823 VDD VSS sg13g2_decap_8
* cell instance $198824 m0 *1 924.48,389.34
X$198824 VDD VSS sg13g2_decap_8
* cell instance $198825 m0 *1 571.68,374.22
X$198825 VDD VSS sg13g2_decap_8
* cell instance $198826 m0 *1 647.04,842.94
X$198826 VDD VSS sg13g2_decap_8
* cell instance $198827 m0 *1 575.04,374.22
X$198827 VDD VSS sg13g2_decap_8
* cell instance $198828 m0 *1 578.4,374.22
X$198828 VDD VSS sg13g2_decap_8
* cell instance $198829 m0 *1 974.88,381.78
X$198829 VDD VSS sg13g2_decap_8
* cell instance $198830 m0 *1 512.16,820.26
X$198830 VDD VSS sg13g2_decap_8
* cell instance $198831 m0 *1 924.48,374.22
X$198831 VDD VSS sg13g2_decap_8
* cell instance $198832 m0 *1 974.88,389.34
X$198832 VDD VSS sg13g2_decap_8
* cell instance $198833 m0 *1 561.6,389.34
X$198833 VDD VSS sg13g2_decap_8
* cell instance $198834 m0 *1 581.76,374.22
X$198834 VDD VSS sg13g2_decap_8
* cell instance $198835 m0 *1 626.88,842.94
X$198835 VDD VSS sg13g2_decap_8
* cell instance $198836 m0 *1 616.8,842.94
X$198836 VDD VSS sg13g2_decap_8
* cell instance $198837 m0 *1 917.76,374.22
X$198837 VDD VSS sg13g2_decap_8
* cell instance $198838 m0 *1 566.4,842.94
X$198838 VDD VSS sg13g2_decap_8
* cell instance $198839 m0 *1 630.24,842.94
X$198839 VDD VSS sg13g2_decap_8
* cell instance $198840 m0 *1 914.4,374.22
X$198840 VDD VSS sg13g2_decap_8
* cell instance $198841 m0 *1 921.12,374.22
X$198841 VDD VSS sg13g2_decap_8
* cell instance $198842 m0 *1 620.16,842.94
X$198842 VDD VSS sg13g2_decap_8
* cell instance $198843 m0 *1 924.48,381.78
X$198843 VDD VSS sg13g2_decap_8
* cell instance $198844 m0 *1 968.16,381.78
X$198844 VDD VSS sg13g2_decap_8
* cell instance $198845 m0 *1 921.12,381.78
X$198845 VDD VSS sg13g2_decap_8
* cell instance $198846 m0 *1 961.44,381.78
X$198846 VDD VSS sg13g2_decap_8
* cell instance $198847 m0 *1 558.24,381.78
X$198847 VDD VSS sg13g2_decap_8
* cell instance $198848 m0 *1 917.76,381.78
X$198848 VDD VSS sg13g2_decap_8
* cell instance $198849 m0 *1 917.76,389.34
X$198849 VDD VSS sg13g2_decap_8
* cell instance $198850 m0 *1 636.96,842.94
X$198850 VDD VSS sg13g2_decap_8
* cell instance $198851 m0 *1 670.56,842.94
X$198851 VDD VSS sg13g2_decap_8
* cell instance $198852 m0 *1 914.4,381.78
X$198852 VDD VSS sg13g2_decap_8
* cell instance $198853 m0 *1 914.4,389.34
X$198853 VDD VSS sg13g2_decap_8
* cell instance $198854 m0 *1 657.12,842.94
X$198854 VDD VSS sg13g2_decap_8
* cell instance $198855 m0 *1 981.6,389.34
X$198855 VDD VSS sg13g2_decap_8
* cell instance $198856 m0 *1 643.68,842.94
X$198856 VDD VSS sg13g2_decap_8
* cell instance $198857 m0 *1 927.84,381.78
X$198857 VDD VSS sg13g2_decap_8
* cell instance $198858 m0 *1 978.24,389.34
X$198858 VDD VSS sg13g2_decap_8
* cell instance $198859 m0 *1 645.6,396.9
X$198859 VDD VSS sg13g2_decap_8
* cell instance $198860 m0 *1 640.32,842.94
X$198860 VDD VSS sg13g2_decap_8
* cell instance $198861 m0 *1 571.68,381.78
X$198861 VDD VSS sg13g2_decap_8
* cell instance $198862 m0 *1 568.32,389.34
X$198862 VDD VSS sg13g2_decap_8
* cell instance $198863 m0 *1 931.2,389.34
X$198863 VDD VSS sg13g2_decap_8
* cell instance $198864 m0 *1 663.84,842.94
X$198864 VDD VSS sg13g2_decap_8
* cell instance $198865 m0 *1 665.76,396.9
X$198865 VDD VSS sg13g2_decap_8
* cell instance $198866 m0 *1 660.48,842.94
X$198866 VDD VSS sg13g2_decap_8
* cell instance $198867 m0 *1 561.6,381.78
X$198867 VDD VSS sg13g2_decap_8
* cell instance $198868 m0 *1 622.08,396.9
X$198868 VDD VSS sg13g2_decap_8
* cell instance $198869 m0 *1 625.44,396.9
X$198869 VDD VSS sg13g2_decap_8
* cell instance $198870 m0 *1 628.8,396.9
X$198870 VDD VSS sg13g2_decap_8
* cell instance $198871 m0 *1 598.56,396.9
X$198871 VDD VSS sg13g2_decap_8
* cell instance $198872 m0 *1 612,396.9
X$198872 VDD VSS sg13g2_decap_8
* cell instance $198873 m0 *1 568.32,374.22
X$198873 VDD VSS sg13g2_decap_8
* cell instance $198874 m0 *1 579.84,842.94
X$198874 VDD VSS sg13g2_decap_8
* cell instance $198875 m0 *1 971.52,389.34
X$198875 VDD VSS sg13g2_decap_8
* cell instance $198876 m0 *1 633.6,842.94
X$198876 VDD VSS sg13g2_decap_8
* cell instance $198877 m0 *1 558.24,374.22
X$198877 VDD VSS sg13g2_decap_8
* cell instance $198878 m0 *1 563.04,842.94
X$198878 VDD VSS sg13g2_decap_8
* cell instance $198879 m0 *1 632.16,389.34
X$198879 VDD VSS sg13g2_decap_8
* cell instance $198880 m0 *1 971.52,374.22
X$198880 VDD VSS sg13g2_decap_8
* cell instance $198881 m0 *1 971.52,381.78
X$198881 VDD VSS sg13g2_decap_8
* cell instance $198882 m0 *1 571.68,389.34
X$198882 VDD VSS sg13g2_decap_8
* cell instance $198883 m0 *1 589.92,842.94
X$198883 VDD VSS sg13g2_decap_8
* cell instance $198884 m0 *1 573.12,842.94
X$198884 VDD VSS sg13g2_decap_8
* cell instance $198885 m0 *1 615.36,396.9
X$198885 VDD VSS sg13g2_decap_8
* cell instance $198886 m0 *1 601.92,396.9
X$198886 VDD VSS sg13g2_decap_8
* cell instance $198887 m0 *1 585.12,374.22
X$198887 VDD VSS sg13g2_decap_8
* cell instance $198888 m0 *1 559.68,842.94
X$198888 VDD VSS sg13g2_decap_8
* cell instance $198889 m0 *1 576.48,842.94
X$198889 VDD VSS sg13g2_decap_8
* cell instance $198890 m0 *1 586.56,842.94
X$198890 VDD VSS sg13g2_decap_8
* cell instance $198891 m0 *1 583.2,842.94
X$198891 VDD VSS sg13g2_decap_8
* cell instance $198892 m0 *1 556.32,842.94
X$198892 VDD VSS sg13g2_decap_8
* cell instance $198893 m0 *1 569.76,842.94
X$198893 VDD VSS sg13g2_decap_8
* cell instance $198894 m0 *1 561.6,374.22
X$198894 VDD VSS sg13g2_decap_8
* cell instance $198895 m0 *1 927.84,374.22
X$198895 VDD VSS sg13g2_decap_8
* cell instance $198896 m0 *1 578.4,381.78
X$198896 VDD VSS sg13g2_decap_8
* cell instance $198897 m0 *1 623.52,842.94
X$198897 VDD VSS sg13g2_decap_8
* cell instance $198898 m0 *1 937.92,374.22
X$198898 VDD VSS sg13g2_decap_8
* cell instance $198899 m0 *1 941.28,374.22
X$198899 VDD VSS sg13g2_decap_8
* cell instance $198900 m0 *1 632.16,396.9
X$198900 VDD VSS sg13g2_decap_8
* cell instance $198901 m0 *1 944.64,374.22
X$198901 VDD VSS sg13g2_decap_8
* cell instance $198902 m0 *1 948,374.22
X$198902 VDD VSS sg13g2_decap_8
* cell instance $198903 m0 *1 606.72,842.94
X$198903 VDD VSS sg13g2_decap_8
* cell instance $198904 m0 *1 618.72,396.9
X$198904 VDD VSS sg13g2_decap_8
* cell instance $198905 m0 *1 603.36,842.94
X$198905 VDD VSS sg13g2_decap_8
* cell instance $198906 m0 *1 978.24,381.78
X$198906 VDD VSS sg13g2_decap_8
* cell instance $198907 m0 *1 595.2,396.9
X$198907 VDD VSS sg13g2_decap_8
* cell instance $198908 m0 *1 632.16,374.22
X$198908 VDD VSS sg13g2_decap_8
* cell instance $198909 m0 *1 600,842.94
X$198909 VDD VSS sg13g2_decap_8
* cell instance $198910 m0 *1 596.64,842.94
X$198910 VDD VSS sg13g2_decap_8
* cell instance $198911 m0 *1 575.04,381.78
X$198911 VDD VSS sg13g2_decap_8
* cell instance $198912 m0 *1 610.08,842.94
X$198912 VDD VSS sg13g2_decap_8
* cell instance $198913 m0 *1 934.56,374.22
X$198913 VDD VSS sg13g2_decap_8
* cell instance $198914 m0 *1 931.2,381.78
X$198914 VDD VSS sg13g2_decap_8
* cell instance $198915 m0 *1 632.16,381.78
X$198915 VDD VSS sg13g2_decap_8
* cell instance $198916 m0 *1 613.44,842.94
X$198916 VDD VSS sg13g2_decap_8
* cell instance $198917 m0 *1 605.28,396.9
X$198917 VDD VSS sg13g2_decap_8
* cell instance $198918 m0 *1 528,374.22
X$198918 VDD VSS sg13g2_decap_8
* cell instance $198919 m0 *1 475.2,797.58
X$198919 VDD VSS sg13g2_decap_8
* cell instance $198920 m0 *1 531.36,374.22
X$198920 VDD VSS sg13g2_decap_8
* cell instance $198921 m0 *1 918.72,404.46
X$198921 VDD VSS sg13g2_decap_8
* cell instance $198922 m0 *1 485.28,797.58
X$198922 VDD VSS sg13g2_decap_8
* cell instance $198923 m0 *1 488.64,797.58
X$198923 VDD VSS sg13g2_decap_8
* cell instance $198924 m0 *1 593.28,842.94
X$198924 VDD VSS sg13g2_decap_8
* cell instance $198925 m0 *1 481.92,797.58
X$198925 VDD VSS sg13g2_decap_8
* cell instance $198926 m0 *1 478.56,797.58
X$198926 VDD VSS sg13g2_decap_8
* cell instance $198927 m0 *1 492,797.58
X$198927 VDD VSS sg13g2_decap_8
* cell instance $198928 m0 *1 575.04,389.34
X$198928 VDD VSS sg13g2_decap_8
* cell instance $198929 m0 *1 564.96,389.34
X$198929 VDD VSS sg13g2_decap_8
* cell instance $198930 m0 *1 928.8,404.46
X$198930 VDD VSS sg13g2_decap_8
* cell instance $198931 m0 *1 618.72,381.78
X$198931 VDD VSS sg13g2_decap_8
* cell instance $198932 m0 *1 945.6,404.46
X$198932 VDD VSS sg13g2_decap_8
* cell instance $198933 m0 *1 954.72,381.78
X$198933 VDD VSS sg13g2_decap_8
* cell instance $198934 m0 *1 618.72,389.34
X$198934 VDD VSS sg13g2_decap_8
* cell instance $198935 m0 *1 945.6,412.02
X$198935 VDD VSS sg13g2_decap_8
* cell instance $198936 m0 *1 935.52,412.02
X$198936 VDD VSS sg13g2_decap_8
* cell instance $198937 m0 *1 521.28,374.22
X$198937 VDD VSS sg13g2_decap_8
* cell instance $198938 m0 *1 938.88,412.02
X$198938 VDD VSS sg13g2_decap_8
* cell instance $198939 m0 *1 471.84,797.58
X$198939 VDD VSS sg13g2_decap_8
* cell instance $198940 m0 *1 578.4,389.34
X$198940 VDD VSS sg13g2_decap_8
* cell instance $198941 m0 *1 925.44,412.02
X$198941 VDD VSS sg13g2_decap_8
* cell instance $198942 m0 *1 444.96,797.58
X$198942 VDD VSS sg13g2_decap_8
* cell instance $198943 m0 *1 438.24,797.58
X$198943 VDD VSS sg13g2_decap_8
* cell instance $198944 m0 *1 925.44,404.46
X$198944 VDD VSS sg13g2_decap_8
* cell instance $198945 m0 *1 451.68,797.58
X$198945 VDD VSS sg13g2_decap_8
* cell instance $198946 m0 *1 521.28,389.34
X$198946 VDD VSS sg13g2_decap_8
* cell instance $198947 m0 *1 928.8,412.02
X$198947 VDD VSS sg13g2_decap_8
* cell instance $198948 m0 *1 615.36,381.78
X$198948 VDD VSS sg13g2_decap_8
* cell instance $198949 m0 *1 915.36,404.46
X$198949 VDD VSS sg13g2_decap_8
* cell instance $198950 m0 *1 915.36,412.02
X$198950 VDD VSS sg13g2_decap_8
* cell instance $198951 m0 *1 638.88,396.9
X$198951 VDD VSS sg13g2_decap_8
* cell instance $198952 m0 *1 918.72,412.02
X$198952 VDD VSS sg13g2_decap_8
* cell instance $198953 m0 *1 968.16,389.34
X$198953 VDD VSS sg13g2_decap_8
* cell instance $198954 m0 *1 652.32,396.9
X$198954 VDD VSS sg13g2_decap_8
* cell instance $198955 m0 *1 512.16,790.02
X$198955 VDD VSS sg13g2_decap_8
* cell instance $198956 m0 *1 922.08,404.46
X$198956 VDD VSS sg13g2_decap_8
* cell instance $198957 m0 *1 508.8,797.58
X$198957 VDD VSS sg13g2_decap_8
* cell instance $198958 m0 *1 498.72,797.58
X$198958 VDD VSS sg13g2_decap_8
* cell instance $198959 m0 *1 495.36,797.58
X$198959 VDD VSS sg13g2_decap_8
* cell instance $198960 m0 *1 512.16,797.58
X$198960 VDD VSS sg13g2_decap_8
* cell instance $198961 m0 *1 958.08,389.34
X$198961 VDD VSS sg13g2_decap_8
* cell instance $198962 m0 *1 524.64,374.22
X$198962 VDD VSS sg13g2_decap_8
* cell instance $198963 m0 *1 954.72,389.34
X$198963 VDD VSS sg13g2_decap_8
* cell instance $198964 m0 *1 502.08,797.58
X$198964 VDD VSS sg13g2_decap_8
* cell instance $198965 m0 *1 505.44,797.58
X$198965 VDD VSS sg13g2_decap_8
* cell instance $198966 m0 *1 514.56,782.46
X$198966 VDD VSS sg13g2_decap_8
* cell instance $198967 m0 *1 937.92,381.78
X$198967 VDD VSS sg13g2_decap_8
* cell instance $198968 m0 *1 622.08,389.34
X$198968 VDD VSS sg13g2_decap_8
* cell instance $198969 m0 *1 941.28,381.78
X$198969 VDD VSS sg13g2_decap_8
* cell instance $198970 m0 *1 588.48,381.78
X$198970 VDD VSS sg13g2_decap_8
* cell instance $198971 m0 *1 434.88,805.14
X$198971 VDD VSS sg13g2_decap_8
* cell instance $198972 m0 *1 669.12,396.9
X$198972 VDD VSS sg13g2_decap_8
* cell instance $198973 m0 *1 964.8,381.78
X$198973 VDD VSS sg13g2_decap_8
* cell instance $198974 m0 *1 546.24,842.94
X$198974 VDD VSS sg13g2_decap_8
* cell instance $198975 m0 *1 612,374.22
X$198975 VDD VSS sg13g2_decap_8
* cell instance $198976 m0 *1 958.08,381.78
X$198976 VDD VSS sg13g2_decap_8
* cell instance $198977 m0 *1 538.08,374.22
X$198977 VDD VSS sg13g2_decap_8
* cell instance $198978 m0 *1 938.88,404.46
X$198978 VDD VSS sg13g2_decap_8
* cell instance $198979 m0 *1 937.92,389.34
X$198979 VDD VSS sg13g2_decap_8
* cell instance $198980 m0 *1 934.56,381.78
X$198980 VDD VSS sg13g2_decap_8
* cell instance $198981 m0 *1 948,381.78
X$198981 VDD VSS sg13g2_decap_8
* cell instance $198982 m0 *1 549.6,842.94
X$198982 VDD VSS sg13g2_decap_8
* cell instance $198983 m0 *1 944.64,381.78
X$198983 VDD VSS sg13g2_decap_8
* cell instance $198984 m0 *1 944.64,389.34
X$198984 VDD VSS sg13g2_decap_8
* cell instance $198985 m0 *1 941.28,389.34
X$198985 VDD VSS sg13g2_decap_8
* cell instance $198986 m0 *1 612,389.34
X$198986 VDD VSS sg13g2_decap_8
* cell instance $198987 m0 *1 653.76,842.94
X$198987 VDD VSS sg13g2_decap_8
* cell instance $198988 m0 *1 650.4,842.94
X$198988 VDD VSS sg13g2_decap_8
* cell instance $198989 m0 *1 964.8,389.34
X$198989 VDD VSS sg13g2_decap_8
* cell instance $198990 m0 *1 542.88,842.94
X$198990 VDD VSS sg13g2_decap_8
* cell instance $198991 m0 *1 612,381.78
X$198991 VDD VSS sg13g2_decap_8
* cell instance $198992 m0 *1 948.96,404.46
X$198992 VDD VSS sg13g2_decap_8
* cell instance $198993 m0 *1 517.92,374.22
X$198993 VDD VSS sg13g2_decap_8
* cell instance $198994 m0 *1 622.08,381.78
X$198994 VDD VSS sg13g2_decap_8
* cell instance $198995 m0 *1 434.88,790.02
X$198995 VDD VSS sg13g2_decap_8
* cell instance $198996 m0 *1 434.88,797.58
X$198996 VDD VSS sg13g2_decap_8
* cell instance $198997 m0 *1 433.92,782.46
X$198997 VDD VSS sg13g2_decap_8
* cell instance $198998 m0 *1 961.44,389.34
X$198998 VDD VSS sg13g2_decap_8
* cell instance $198999 m0 *1 948.96,412.02
X$198999 VDD VSS sg13g2_decap_8
* cell instance $199000 m0 *1 541.44,374.22
X$199000 VDD VSS sg13g2_decap_8
* cell instance $199001 m0 *1 434.88,820.26
X$199001 VDD VSS sg13g2_decap_8
* cell instance $199002 m0 *1 434.88,812.7
X$199002 VDD VSS sg13g2_decap_8
* cell instance $199003 m0 *1 948,389.34
X$199003 VDD VSS sg13g2_decap_8
* cell instance $199004 m0 *1 935.52,404.46
X$199004 VDD VSS sg13g2_decap_8
* cell instance $199005 m0 *1 434.88,827.82
X$199005 VDD VSS sg13g2_decap_8
* cell instance $199006 m0 *1 942.24,412.02
X$199006 VDD VSS sg13g2_decap_8
* cell instance $199007 m0 *1 552.96,842.94
X$199007 VDD VSS sg13g2_decap_8
* cell instance $199008 m0 *1 625.44,389.34
X$199008 VDD VSS sg13g2_decap_8
* cell instance $199009 m0 *1 625.44,381.78
X$199009 VDD VSS sg13g2_decap_8
* cell instance $199010 m0 *1 628.8,381.78
X$199010 VDD VSS sg13g2_decap_8
* cell instance $199011 m0 *1 544.8,374.22
X$199011 VDD VSS sg13g2_decap_8
* cell instance $199012 m0 *1 548.16,374.22
X$199012 VDD VSS sg13g2_decap_8
* cell instance $199013 m0 *1 931.2,374.22
X$199013 VDD VSS sg13g2_decap_8
* cell instance $199014 m0 *1 585.12,389.34
X$199014 VDD VSS sg13g2_decap_8
* cell instance $199015 m0 *1 934.56,389.34
X$199015 VDD VSS sg13g2_decap_8
* cell instance $199016 m0 *1 942.24,404.46
X$199016 VDD VSS sg13g2_decap_8
* cell instance $199017 m0 *1 847.2,389.34
X$199017 VDD VSS sg13g2_decap_8
* cell instance $199018 m0 *1 431.52,835.38
X$199018 VDD VSS sg13g2_decap_8
* cell instance $199019 m0 *1 837.12,389.34
X$199019 VDD VSS sg13g2_decap_8
* cell instance $199020 m0 *1 648.96,374.22
X$199020 VDD VSS sg13g2_decap_8
* cell instance $199021 m0 *1 434.88,835.38
X$199021 VDD VSS sg13g2_decap_8
* cell instance $199022 m0 *1 591.84,389.34
X$199022 VDD VSS sg13g2_decap_8
* cell instance $199023 m0 *1 591.84,396.9
X$199023 VDD VSS sg13g2_decap_8
* cell instance $199024 m0 *1 528,396.9
X$199024 VDD VSS sg13g2_decap_8
* cell instance $199025 m0 *1 544.8,396.9
X$199025 VDD VSS sg13g2_decap_8
* cell instance $199026 m0 *1 411.36,812.7
X$199026 VDD VSS sg13g2_decap_8
* cell instance $199027 m0 *1 840.48,389.34
X$199027 VDD VSS sg13g2_decap_8
* cell instance $199028 m0 *1 564.96,374.22
X$199028 VDD VSS sg13g2_decap_8
* cell instance $199029 m0 *1 541.44,396.9
X$199029 VDD VSS sg13g2_decap_8
* cell instance $199030 m0 *1 588.48,396.9
X$199030 VDD VSS sg13g2_decap_8
* cell instance $199031 m0 *1 424.8,835.38
X$199031 VDD VSS sg13g2_decap_8
* cell instance $199032 m0 *1 833.76,389.34
X$199032 VDD VSS sg13g2_decap_8
* cell instance $199033 m0 *1 843.84,381.78
X$199033 VDD VSS sg13g2_decap_8
* cell instance $199034 m0 *1 418.08,820.26
X$199034 VDD VSS sg13g2_decap_8
* cell instance $199035 m0 *1 438.24,835.38
X$199035 VDD VSS sg13g2_decap_8
* cell instance $199036 m0 *1 414.72,820.26
X$199036 VDD VSS sg13g2_decap_8
* cell instance $199037 m0 *1 833.76,381.78
X$199037 VDD VSS sg13g2_decap_8
* cell instance $199038 m0 *1 411.36,835.38
X$199038 VDD VSS sg13g2_decap_8
* cell instance $199039 m0 *1 847.2,374.22
X$199039 VDD VSS sg13g2_decap_8
* cell instance $199040 m0 *1 840.48,381.78
X$199040 VDD VSS sg13g2_decap_8
* cell instance $199041 m0 *1 487.68,381.78
X$199041 VDD VSS sg13g2_decap_8
* cell instance $199042 m0 *1 431.52,827.82
X$199042 VDD VSS sg13g2_decap_8
* cell instance $199043 m0 *1 448.32,835.38
X$199043 VDD VSS sg13g2_decap_8
* cell instance $199044 m0 *1 451.68,835.38
X$199044 VDD VSS sg13g2_decap_8
* cell instance $199045 m0 *1 455.04,835.38
X$199045 VDD VSS sg13g2_decap_8
* cell instance $199046 m0 *1 444.96,835.38
X$199046 VDD VSS sg13g2_decap_8
* cell instance $199047 m0 *1 424.8,805.14
X$199047 VDD VSS sg13g2_decap_8
* cell instance $199048 m0 *1 458.4,835.38
X$199048 VDD VSS sg13g2_decap_8
* cell instance $199049 m0 *1 428.16,805.14
X$199049 VDD VSS sg13g2_decap_8
* cell instance $199050 m0 *1 421.44,805.14
X$199050 VDD VSS sg13g2_decap_8
* cell instance $199051 m0 *1 421.44,820.26
X$199051 VDD VSS sg13g2_decap_8
* cell instance $199052 m0 *1 847.2,381.78
X$199052 VDD VSS sg13g2_decap_8
* cell instance $199053 m0 *1 857.28,381.78
X$199053 VDD VSS sg13g2_decap_8
* cell instance $199054 m0 *1 645.6,374.22
X$199054 VDD VSS sg13g2_decap_8
* cell instance $199055 m0 *1 665.76,374.22
X$199055 VDD VSS sg13g2_decap_8
* cell instance $199056 m0 *1 659.04,374.22
X$199056 VDD VSS sg13g2_decap_8
* cell instance $199057 m0 *1 860.64,389.34
X$199057 VDD VSS sg13g2_decap_8
* cell instance $199058 m0 *1 591.84,374.22
X$199058 VDD VSS sg13g2_decap_8
* cell instance $199059 m0 *1 428.16,835.38
X$199059 VDD VSS sg13g2_decap_8
* cell instance $199060 m0 *1 581.76,381.78
X$199060 VDD VSS sg13g2_decap_8
* cell instance $199061 m0 *1 669.12,374.22
X$199061 VDD VSS sg13g2_decap_8
* cell instance $199062 m0 *1 843.84,389.34
X$199062 VDD VSS sg13g2_decap_8
* cell instance $199063 m0 *1 591.84,381.78
X$199063 VDD VSS sg13g2_decap_8
* cell instance $199064 m0 *1 837.12,381.78
X$199064 VDD VSS sg13g2_decap_8
* cell instance $199065 m0 *1 431.52,805.14
X$199065 VDD VSS sg13g2_decap_8
* cell instance $199066 m0 *1 857.28,374.22
X$199066 VDD VSS sg13g2_decap_8
* cell instance $199067 m0 *1 507.84,782.46
X$199067 VDD VSS sg13g2_decap_8
* cell instance $199068 m0 *1 629.76,835.38
X$199068 VDD VSS sg13g2_decap_8
* cell instance $199069 m0 *1 853.92,374.22
X$199069 VDD VSS sg13g2_decap_8
* cell instance $199070 m0 *1 653.28,835.38
X$199070 VDD VSS sg13g2_decap_8
* cell instance $199071 m0 *1 548.16,396.9
X$199071 VDD VSS sg13g2_decap_8
* cell instance $199072 m0 *1 498.72,790.02
X$199072 VDD VSS sg13g2_decap_8
* cell instance $199073 m0 *1 666.72,835.38
X$199073 VDD VSS sg13g2_decap_8
* cell instance $199074 m0 *1 554.88,396.9
X$199074 VDD VSS sg13g2_decap_8
* cell instance $199075 m0 *1 561.6,396.9
X$199075 VDD VSS sg13g2_decap_8
* cell instance $199076 m0 *1 890.88,389.34
X$199076 VDD VSS sg13g2_decap_8
* cell instance $199077 m0 *1 428.16,827.82
X$199077 VDD VSS sg13g2_decap_8
* cell instance $199078 m0 *1 660,835.38
X$199078 VDD VSS sg13g2_decap_8
* cell instance $199079 m0 *1 492,790.02
X$199079 VDD VSS sg13g2_decap_8
* cell instance $199080 m0 *1 488.64,790.02
X$199080 VDD VSS sg13g2_decap_8
* cell instance $199081 m0 *1 481.92,790.02
X$199081 VDD VSS sg13g2_decap_8
* cell instance $199082 m0 *1 502.08,790.02
X$199082 VDD VSS sg13g2_decap_8
* cell instance $199083 m0 *1 598.56,374.22
X$199083 VDD VSS sg13g2_decap_8
* cell instance $199084 m0 *1 635.52,381.78
X$199084 VDD VSS sg13g2_decap_8
* cell instance $199085 m0 *1 663.36,835.38
X$199085 VDD VSS sg13g2_decap_8
* cell instance $199086 m0 *1 645.6,389.34
X$199086 VDD VSS sg13g2_decap_8
* cell instance $199087 m0 *1 656.64,835.38
X$199087 VDD VSS sg13g2_decap_8
* cell instance $199088 m0 *1 478.56,790.02
X$199088 VDD VSS sg13g2_decap_8
* cell instance $199089 m0 *1 495.36,790.02
X$199089 VDD VSS sg13g2_decap_8
* cell instance $199090 m0 *1 551.52,374.22
X$199090 VDD VSS sg13g2_decap_8
* cell instance $199091 m0 *1 424.8,812.7
X$199091 VDD VSS sg13g2_decap_8
* cell instance $199092 m0 *1 414.72,812.7
X$199092 VDD VSS sg13g2_decap_8
* cell instance $199093 m0 *1 418.08,812.7
X$199093 VDD VSS sg13g2_decap_8
* cell instance $199094 m0 *1 833.76,374.22
X$199094 VDD VSS sg13g2_decap_8
* cell instance $199095 m0 *1 843.84,374.22
X$199095 VDD VSS sg13g2_decap_8
* cell instance $199096 m0 *1 393.6,782.46
X$199096 VDD VSS sg13g2_decap_8
* cell instance $199097 m0 *1 840.48,374.22
X$199097 VDD VSS sg13g2_decap_8
* cell instance $199098 m0 *1 551.52,381.78
X$199098 VDD VSS sg13g2_decap_8
* cell instance $199099 m0 *1 837.12,374.22
X$199099 VDD VSS sg13g2_decap_8
* cell instance $199100 m0 *1 424.8,797.58
X$199100 VDD VSS sg13g2_decap_8
* cell instance $199101 m0 *1 867.36,374.22
X$199101 VDD VSS sg13g2_decap_8
* cell instance $199102 m0 *1 414.72,835.38
X$199102 VDD VSS sg13g2_decap_8
* cell instance $199103 m0 *1 411.36,797.58
X$199103 VDD VSS sg13g2_decap_8
* cell instance $199104 m0 *1 414.72,797.58
X$199104 VDD VSS sg13g2_decap_8
* cell instance $199105 m0 *1 418.08,797.58
X$199105 VDD VSS sg13g2_decap_8
* cell instance $199106 m0 *1 669.12,381.78
X$199106 VDD VSS sg13g2_decap_8
* cell instance $199107 m0 *1 431.52,797.58
X$199107 VDD VSS sg13g2_decap_8
* cell instance $199108 m0 *1 428.16,797.58
X$199108 VDD VSS sg13g2_decap_8
* cell instance $199109 m0 *1 418.08,835.38
X$199109 VDD VSS sg13g2_decap_8
* cell instance $199110 m0 *1 864,374.22
X$199110 VDD VSS sg13g2_decap_8
* cell instance $199111 m0 *1 860.64,374.22
X$199111 VDD VSS sg13g2_decap_8
* cell instance $199112 m0 *1 589.44,835.38
X$199112 VDD VSS sg13g2_decap_8
* cell instance $199113 m0 *1 571.68,396.9
X$199113 VDD VSS sg13g2_decap_8
* cell instance $199114 m0 *1 421.44,797.58
X$199114 VDD VSS sg13g2_decap_8
* cell instance $199115 m0 *1 417.12,782.46
X$199115 VDD VSS sg13g2_decap_8
* cell instance $199116 m0 *1 497.76,374.22
X$199116 VDD VSS sg13g2_decap_8
* cell instance $199117 m0 *1 431.52,790.02
X$199117 VDD VSS sg13g2_decap_8
* cell instance $199118 m0 *1 413.76,782.46
X$199118 VDD VSS sg13g2_decap_8
* cell instance $199119 m0 *1 854.88,412.02
X$199119 VDD VSS sg13g2_decap_8
* cell instance $199120 m0 *1 505.44,835.38
X$199120 VDD VSS sg13g2_decap_8
* cell instance $199121 m0 *1 430.56,782.46
X$199121 VDD VSS sg13g2_decap_8
* cell instance $199122 m0 *1 421.44,835.38
X$199122 VDD VSS sg13g2_decap_8
* cell instance $199123 m0 *1 407.04,782.46
X$199123 VDD VSS sg13g2_decap_8
* cell instance $199124 m0 *1 854.88,404.46
X$199124 VDD VSS sg13g2_decap_8
* cell instance $199125 m0 *1 491.04,381.78
X$199125 VDD VSS sg13g2_decap_8
* cell instance $199126 m0 *1 431.52,812.7
X$199126 VDD VSS sg13g2_decap_8
* cell instance $199127 m0 *1 638.88,374.22
X$199127 VDD VSS sg13g2_decap_8
* cell instance $199128 m0 *1 410.4,782.46
X$199128 VDD VSS sg13g2_decap_8
* cell instance $199129 m0 *1 642.24,374.22
X$199129 VDD VSS sg13g2_decap_8
* cell instance $199130 m0 *1 868.32,404.46
X$199130 VDD VSS sg13g2_decap_8
* cell instance $199131 m0 *1 861.6,412.02
X$199131 VDD VSS sg13g2_decap_8
* cell instance $199132 m0 *1 414.72,790.02
X$199132 VDD VSS sg13g2_decap_8
* cell instance $199133 m0 *1 461.76,835.38
X$199133 VDD VSS sg13g2_decap_8
* cell instance $199134 m0 *1 376.8,782.46
X$199134 VDD VSS sg13g2_decap_8
* cell instance $199135 m0 *1 864.96,404.46
X$199135 VDD VSS sg13g2_decap_8
* cell instance $199136 m0 *1 850.56,381.78
X$199136 VDD VSS sg13g2_decap_8
* cell instance $199137 m0 *1 494.4,389.34
X$199137 VDD VSS sg13g2_decap_8
* cell instance $199138 m0 *1 421.44,790.02
X$199138 VDD VSS sg13g2_decap_8
* cell instance $199139 m0 *1 720.48,790.02
X$199139 VDD VSS sg13g2_decap_8
* cell instance $199140 m0 *1 591.84,782.46
X$199140 VDD VSS sg13g2_decap_8
* cell instance $199141 m0 *1 844.8,412.02
X$199141 VDD VSS sg13g2_decap_8
* cell instance $199142 m0 *1 411.36,790.02
X$199142 VDD VSS sg13g2_decap_8
* cell instance $199143 m0 *1 848.16,404.46
X$199143 VDD VSS sg13g2_decap_8
* cell instance $199144 m0 *1 420.48,782.46
X$199144 VDD VSS sg13g2_decap_8
* cell instance $199145 m0 *1 652.32,374.22
X$199145 VDD VSS sg13g2_decap_8
* cell instance $199146 m0 *1 403.68,782.46
X$199146 VDD VSS sg13g2_decap_8
* cell instance $199147 m0 *1 400.32,782.46
X$199147 VDD VSS sg13g2_decap_8
* cell instance $199148 m0 *1 428.16,790.02
X$199148 VDD VSS sg13g2_decap_8
* cell instance $199149 m0 *1 848.16,412.02
X$199149 VDD VSS sg13g2_decap_8
* cell instance $199150 m0 *1 497.76,389.34
X$199150 VDD VSS sg13g2_decap_8
* cell instance $199151 m0 *1 589.44,820.26
X$199151 VDD VSS sg13g2_decap_8
* cell instance $199152 m0 *1 864.96,412.02
X$199152 VDD VSS sg13g2_decap_8
* cell instance $199153 m0 *1 717.12,790.02
X$199153 VDD VSS sg13g2_decap_8
* cell instance $199154 m0 *1 423.84,782.46
X$199154 VDD VSS sg13g2_decap_8
* cell instance $199155 m0 *1 424.8,790.02
X$199155 VDD VSS sg13g2_decap_8
* cell instance $199156 m0 *1 396.96,782.46
X$199156 VDD VSS sg13g2_decap_8
* cell instance $199157 m0 *1 427.2,782.46
X$199157 VDD VSS sg13g2_decap_8
* cell instance $199158 m0 *1 858.24,404.46
X$199158 VDD VSS sg13g2_decap_8
* cell instance $199159 m0 *1 868.32,412.02
X$199159 VDD VSS sg13g2_decap_8
* cell instance $199160 m0 *1 861.6,404.46
X$199160 VDD VSS sg13g2_decap_8
* cell instance $199161 m0 *1 858.24,412.02
X$199161 VDD VSS sg13g2_decap_8
* cell instance $199162 m0 *1 716.16,782.46
X$199162 VDD VSS sg13g2_decap_8
* cell instance $199163 m0 *1 418.08,790.02
X$199163 VDD VSS sg13g2_decap_8
* cell instance $199164 m0 *1 424.8,827.82
X$199164 VDD VSS sg13g2_decap_8
* cell instance $199165 m0 *1 468.48,835.38
X$199165 VDD VSS sg13g2_decap_8
* cell instance $199166 m0 *1 478.56,835.38
X$199166 VDD VSS sg13g2_decap_8
* cell instance $199167 m0 *1 481.92,835.38
X$199167 VDD VSS sg13g2_decap_8
* cell instance $199168 m0 *1 485.28,835.38
X$199168 VDD VSS sg13g2_decap_8
* cell instance $199169 m0 *1 867.36,389.34
X$199169 VDD VSS sg13g2_decap_8
* cell instance $199170 m0 *1 488.64,835.38
X$199170 VDD VSS sg13g2_decap_8
* cell instance $199171 m0 *1 471.84,835.38
X$199171 VDD VSS sg13g2_decap_8
* cell instance $199172 m0 *1 411.36,827.82
X$199172 VDD VSS sg13g2_decap_8
* cell instance $199173 m0 *1 501.12,389.34
X$199173 VDD VSS sg13g2_decap_8
* cell instance $199174 m0 *1 853.92,381.78
X$199174 VDD VSS sg13g2_decap_8
* cell instance $199175 m0 *1 501.12,374.22
X$199175 VDD VSS sg13g2_decap_8
* cell instance $199176 m0 *1 441.6,835.38
X$199176 VDD VSS sg13g2_decap_8
* cell instance $199177 m0 *1 864,389.34
X$199177 VDD VSS sg13g2_decap_8
* cell instance $199178 m0 *1 414.72,805.14
X$199178 VDD VSS sg13g2_decap_8
* cell instance $199179 m0 *1 418.08,805.14
X$199179 VDD VSS sg13g2_decap_8
* cell instance $199180 m0 *1 421.44,812.7
X$199180 VDD VSS sg13g2_decap_8
* cell instance $199181 m0 *1 867.36,381.78
X$199181 VDD VSS sg13g2_decap_8
* cell instance $199182 m0 *1 421.44,827.82
X$199182 VDD VSS sg13g2_decap_8
* cell instance $199183 m0 *1 428.16,820.26
X$199183 VDD VSS sg13g2_decap_8
* cell instance $199184 m0 *1 853.92,389.34
X$199184 VDD VSS sg13g2_decap_8
* cell instance $199185 m0 *1 424.8,820.26
X$199185 VDD VSS sg13g2_decap_8
* cell instance $199186 m0 *1 414.72,827.82
X$199186 VDD VSS sg13g2_decap_8
* cell instance $199187 m0 *1 418.08,827.82
X$199187 VDD VSS sg13g2_decap_8
* cell instance $199188 m0 *1 475.2,835.38
X$199188 VDD VSS sg13g2_decap_8
* cell instance $199189 m0 *1 495.36,835.38
X$199189 VDD VSS sg13g2_decap_8
* cell instance $199190 m0 *1 850.56,389.34
X$199190 VDD VSS sg13g2_decap_8
* cell instance $199191 m0 *1 373.44,782.46
X$199191 VDD VSS sg13g2_decap_8
* cell instance $199192 m0 *1 655.68,374.22
X$199192 VDD VSS sg13g2_decap_8
* cell instance $199193 m0 *1 498.72,835.38
X$199193 VDD VSS sg13g2_decap_8
* cell instance $199194 m0 *1 850.56,374.22
X$199194 VDD VSS sg13g2_decap_8
* cell instance $199195 m0 *1 386.88,782.46
X$199195 VDD VSS sg13g2_decap_8
* cell instance $199196 m0 *1 383.52,782.46
X$199196 VDD VSS sg13g2_decap_8
* cell instance $199197 m0 *1 502.08,835.38
X$199197 VDD VSS sg13g2_decap_8
* cell instance $199198 m0 *1 370.08,782.46
X$199198 VDD VSS sg13g2_decap_8
* cell instance $199199 m0 *1 492,835.38
X$199199 VDD VSS sg13g2_decap_8
* cell instance $199200 m0 *1 411.36,805.14
X$199200 VDD VSS sg13g2_decap_8
* cell instance $199201 m0 *1 390.24,782.46
X$199201 VDD VSS sg13g2_decap_8
* cell instance $199202 m0 *1 635.52,374.22
X$199202 VDD VSS sg13g2_decap_8
* cell instance $199203 m0 *1 380.16,782.46
X$199203 VDD VSS sg13g2_decap_8
* cell instance $199204 m0 *1 428.16,812.7
X$199204 VDD VSS sg13g2_decap_8
* cell instance $199205 m0 *1 431.52,820.26
X$199205 VDD VSS sg13g2_decap_8
* cell instance $199206 m0 *1 477.6,374.22
X$199206 VDD VSS sg13g2_decap_8
* cell instance $199207 m0 *1 411.36,820.26
X$199207 VDD VSS sg13g2_decap_8
* cell instance $199208 m0 *1 662.4,374.22
X$199208 VDD VSS sg13g2_decap_8
* cell instance $199209 m0 *1 465.12,835.38
X$199209 VDD VSS sg13g2_decap_8
* cell instance $199210 m0 *1 860.64,381.78
X$199210 VDD VSS sg13g2_decap_8
* cell instance $199211 m0 *1 864,381.78
X$199211 VDD VSS sg13g2_decap_8
* cell instance $199212 m0 *1 857.28,389.34
X$199212 VDD VSS sg13g2_decap_8
* cell instance $199213 m0 *1 480.96,374.22
X$199213 VDD VSS sg13g2_decap_8
* cell instance $199214 m0 *1 438.24,805.14
X$199214 VDD VSS sg13g2_decap_8
* cell instance $199215 m0 *1 538.08,396.9
X$199215 VDD VSS sg13g2_decap_8
* cell instance $199216 m0 *1 441.6,812.7
X$199216 VDD VSS sg13g2_decap_8
* cell instance $199217 m0 *1 441.6,805.14
X$199217 VDD VSS sg13g2_decap_8
* cell instance $199218 m0 *1 534.72,396.9
X$199218 VDD VSS sg13g2_decap_8
* cell instance $199219 m0 *1 451.68,805.14
X$199219 VDD VSS sg13g2_decap_8
* cell instance $199220 m0 *1 900.96,374.22
X$199220 VDD VSS sg13g2_decap_8
* cell instance $199221 m0 *1 451.68,812.7
X$199221 VDD VSS sg13g2_decap_8
* cell instance $199222 m0 *1 904.32,374.22
X$199222 VDD VSS sg13g2_decap_8
* cell instance $199223 m0 *1 907.68,374.22
X$199223 VDD VSS sg13g2_decap_8
* cell instance $199224 m0 *1 897.6,374.22
X$199224 VDD VSS sg13g2_decap_8
* cell instance $199225 m0 *1 884.16,381.78
X$199225 VDD VSS sg13g2_decap_8
* cell instance $199226 m0 *1 444.96,812.7
X$199226 VDD VSS sg13g2_decap_8
* cell instance $199227 m0 *1 894.24,374.22
X$199227 VDD VSS sg13g2_decap_8
* cell instance $199228 m0 *1 438.24,812.7
X$199228 VDD VSS sg13g2_decap_8
* cell instance $199229 m0 *1 596.16,835.38
X$199229 VDD VSS sg13g2_decap_8
* cell instance $199230 m0 *1 927.84,396.9
X$199230 VDD VSS sg13g2_decap_8
* cell instance $199231 m0 *1 951.36,381.78
X$199231 VDD VSS sg13g2_decap_8
* cell instance $199232 m0 *1 968.16,396.9
X$199232 VDD VSS sg13g2_decap_8
* cell instance $199233 m0 *1 978.24,396.9
X$199233 VDD VSS sg13g2_decap_8
* cell instance $199234 m0 *1 981.6,396.9
X$199234 VDD VSS sg13g2_decap_8
* cell instance $199235 m0 *1 971.52,396.9
X$199235 VDD VSS sg13g2_decap_8
* cell instance $199236 m0 *1 444.96,805.14
X$199236 VDD VSS sg13g2_decap_8
* cell instance $199237 m0 *1 599.52,835.38
X$199237 VDD VSS sg13g2_decap_8
* cell instance $199238 m0 *1 551.52,389.34
X$199238 VDD VSS sg13g2_decap_8
* cell instance $199239 m0 *1 558.24,396.9
X$199239 VDD VSS sg13g2_decap_8
* cell instance $199240 m0 *1 564.96,396.9
X$199240 VDD VSS sg13g2_decap_8
* cell instance $199241 m0 *1 551.52,396.9
X$199241 VDD VSS sg13g2_decap_8
* cell instance $199242 m0 *1 890.88,374.22
X$199242 VDD VSS sg13g2_decap_8
* cell instance $199243 m0 *1 524.64,396.9
X$199243 VDD VSS sg13g2_decap_8
* cell instance $199244 m0 *1 887.52,374.22
X$199244 VDD VSS sg13g2_decap_8
* cell instance $199245 m0 *1 884.16,374.22
X$199245 VDD VSS sg13g2_decap_8
* cell instance $199246 m0 *1 461.76,805.14
X$199246 VDD VSS sg13g2_decap_8
* cell instance $199247 m0 *1 517.92,396.9
X$199247 VDD VSS sg13g2_decap_8
* cell instance $199248 m0 *1 521.28,396.9
X$199248 VDD VSS sg13g2_decap_8
* cell instance $199249 m0 *1 448.32,812.7
X$199249 VDD VSS sg13g2_decap_8
* cell instance $199250 m0 *1 874.08,374.22
X$199250 VDD VSS sg13g2_decap_8
* cell instance $199251 m0 *1 468.48,805.14
X$199251 VDD VSS sg13g2_decap_8
* cell instance $199252 m0 *1 626.4,835.38
X$199252 VDD VSS sg13g2_decap_8
* cell instance $199253 m0 *1 592.8,835.38
X$199253 VDD VSS sg13g2_decap_8
* cell instance $199254 m0 *1 458.4,812.7
X$199254 VDD VSS sg13g2_decap_8
* cell instance $199255 m0 *1 877.44,374.22
X$199255 VDD VSS sg13g2_decap_8
* cell instance $199256 m0 *1 662.4,396.9
X$199256 VDD VSS sg13g2_decap_8
* cell instance $199257 m0 *1 465.12,812.7
X$199257 VDD VSS sg13g2_decap_8
* cell instance $199258 m0 *1 605.28,374.22
X$199258 VDD VSS sg13g2_decap_8
* cell instance $199259 m0 *1 659.04,396.9
X$199259 VDD VSS sg13g2_decap_8
* cell instance $199260 m0 *1 531.36,396.9
X$199260 VDD VSS sg13g2_decap_8
* cell instance $199261 m0 *1 465.12,805.14
X$199261 VDD VSS sg13g2_decap_8
* cell instance $199262 m0 *1 438.24,827.82
X$199262 VDD VSS sg13g2_decap_8
* cell instance $199263 m0 *1 951.36,374.22
X$199263 VDD VSS sg13g2_decap_8
* cell instance $199264 m0 *1 534.72,374.22
X$199264 VDD VSS sg13g2_decap_8
* cell instance $199265 m0 *1 921.12,396.9
X$199265 VDD VSS sg13g2_decap_8
* cell instance $199266 m0 *1 458.4,827.82
X$199266 VDD VSS sg13g2_decap_8
* cell instance $199267 m0 *1 468.48,827.82
X$199267 VDD VSS sg13g2_decap_8
* cell instance $199268 m0 *1 595.2,374.22
X$199268 VDD VSS sg13g2_decap_8
* cell instance $199269 m0 *1 952.32,427.14
X$199269 VDD VSS sg13g2_decap_8
* cell instance $199270 m0 *1 952.32,419.58
X$199270 VDD VSS sg13g2_decap_8
* cell instance $199271 m0 *1 461.76,827.82
X$199271 VDD VSS sg13g2_decap_8
* cell instance $199272 m0 *1 606.24,835.38
X$199272 VDD VSS sg13g2_decap_8
* cell instance $199273 m0 *1 974.88,396.9
X$199273 VDD VSS sg13g2_decap_8
* cell instance $199274 m0 *1 468.48,820.26
X$199274 VDD VSS sg13g2_decap_8
* cell instance $199275 m0 *1 608.64,374.22
X$199275 VDD VSS sg13g2_decap_8
* cell instance $199276 m0 *1 952.32,412.02
X$199276 VDD VSS sg13g2_decap_8
* cell instance $199277 m0 *1 465.12,827.82
X$199277 VDD VSS sg13g2_decap_8
* cell instance $199278 m0 *1 465.12,820.26
X$199278 VDD VSS sg13g2_decap_8
* cell instance $199279 m0 *1 458.4,820.26
X$199279 VDD VSS sg13g2_decap_8
* cell instance $199280 m0 *1 461.76,820.26
X$199280 VDD VSS sg13g2_decap_8
* cell instance $199281 m0 *1 974.88,374.22
X$199281 VDD VSS sg13g2_decap_8
* cell instance $199282 m0 *1 924.48,396.9
X$199282 VDD VSS sg13g2_decap_8
* cell instance $199283 m0 *1 914.4,396.9
X$199283 VDD VSS sg13g2_decap_8
* cell instance $199284 m0 *1 917.76,396.9
X$199284 VDD VSS sg13g2_decap_8
* cell instance $199285 m0 *1 952.32,404.46
X$199285 VDD VSS sg13g2_decap_8
* cell instance $199286 m0 *1 448.32,805.14
X$199286 VDD VSS sg13g2_decap_8
* cell instance $199287 m0 *1 441.6,820.26
X$199287 VDD VSS sg13g2_decap_8
* cell instance $199288 m0 *1 448.32,820.26
X$199288 VDD VSS sg13g2_decap_8
* cell instance $199289 m0 *1 444.96,820.26
X$199289 VDD VSS sg13g2_decap_8
* cell instance $199290 m0 *1 948,396.9
X$199290 VDD VSS sg13g2_decap_8
* cell instance $199291 m0 *1 944.64,396.9
X$199291 VDD VSS sg13g2_decap_8
* cell instance $199292 m0 *1 941.28,396.9
X$199292 VDD VSS sg13g2_decap_8
* cell instance $199293 m0 *1 934.56,396.9
X$199293 VDD VSS sg13g2_decap_8
* cell instance $199294 m0 *1 937.92,396.9
X$199294 VDD VSS sg13g2_decap_8
* cell instance $199295 m0 *1 441.6,827.82
X$199295 VDD VSS sg13g2_decap_8
* cell instance $199296 m0 *1 931.2,396.9
X$199296 VDD VSS sg13g2_decap_8
* cell instance $199297 m0 *1 602.88,835.38
X$199297 VDD VSS sg13g2_decap_8
* cell instance $199298 m0 *1 958.08,396.9
X$199298 VDD VSS sg13g2_decap_8
* cell instance $199299 m0 *1 951.36,396.9
X$199299 VDD VSS sg13g2_decap_8
* cell instance $199300 m0 *1 954.72,396.9
X$199300 VDD VSS sg13g2_decap_8
* cell instance $199301 m0 *1 451.68,820.26
X$199301 VDD VSS sg13g2_decap_8
* cell instance $199302 m0 *1 534.72,389.34
X$199302 VDD VSS sg13g2_decap_8
* cell instance $199303 m0 *1 451.68,827.82
X$199303 VDD VSS sg13g2_decap_8
* cell instance $199304 m0 *1 961.44,396.9
X$199304 VDD VSS sg13g2_decap_8
* cell instance $199305 m0 *1 448.32,827.82
X$199305 VDD VSS sg13g2_decap_8
* cell instance $199306 m0 *1 444.96,827.82
X$199306 VDD VSS sg13g2_decap_8
* cell instance $199307 m0 *1 438.24,820.26
X$199307 VDD VSS sg13g2_decap_8
* cell instance $199308 m0 *1 964.8,396.9
X$199308 VDD VSS sg13g2_decap_8
* cell instance $199309 m0 *1 951.36,389.34
X$199309 VDD VSS sg13g2_decap_8
* cell instance $199310 m0 *1 534.72,381.78
X$199310 VDD VSS sg13g2_decap_8
* cell instance $199311 m0 *1 581.76,389.34
X$199311 VDD VSS sg13g2_decap_8
* cell instance $199312 m0 *1 907.68,381.78
X$199312 VDD VSS sg13g2_decap_8
* cell instance $199313 m0 *1 900.96,389.34
X$199313 VDD VSS sg13g2_decap_8
* cell instance $199314 m0 *1 480.96,782.46
X$199314 VDD VSS sg13g2_decap_8
* cell instance $199315 m0 *1 585.12,396.9
X$199315 VDD VSS sg13g2_decap_8
* cell instance $199316 m0 *1 477.6,782.46
X$199316 VDD VSS sg13g2_decap_8
* cell instance $199317 m0 *1 484.32,782.46
X$199317 VDD VSS sg13g2_decap_8
* cell instance $199318 m0 *1 904.32,381.78
X$199318 VDD VSS sg13g2_decap_8
* cell instance $199319 m0 *1 894.24,381.78
X$199319 VDD VSS sg13g2_decap_8
* cell instance $199320 m0 *1 900.96,381.78
X$199320 VDD VSS sg13g2_decap_8
* cell instance $199321 m0 *1 438.24,790.02
X$199321 VDD VSS sg13g2_decap_8
* cell instance $199322 m0 *1 609.6,835.38
X$199322 VDD VSS sg13g2_decap_8
* cell instance $199323 m0 *1 508.8,790.02
X$199323 VDD VSS sg13g2_decap_8
* cell instance $199324 m0 *1 612.96,835.38
X$199324 VDD VSS sg13g2_decap_8
* cell instance $199325 m0 *1 511.2,782.46
X$199325 VDD VSS sg13g2_decap_8
* cell instance $199326 m0 *1 455.04,790.02
X$199326 VDD VSS sg13g2_decap_8
* cell instance $199327 m0 *1 622.08,374.22
X$199327 VDD VSS sg13g2_decap_8
* cell instance $199328 m0 *1 457.44,782.46
X$199328 VDD VSS sg13g2_decap_8
* cell instance $199329 m0 *1 615.36,374.22
X$199329 VDD VSS sg13g2_decap_8
* cell instance $199330 m0 *1 907.68,389.34
X$199330 VDD VSS sg13g2_decap_8
* cell instance $199331 m0 *1 894.24,389.34
X$199331 VDD VSS sg13g2_decap_8
* cell instance $199332 m0 *1 618.72,374.22
X$199332 VDD VSS sg13g2_decap_8
* cell instance $199333 m0 *1 505.44,790.02
X$199333 VDD VSS sg13g2_decap_8
* cell instance $199334 m0 *1 670.08,835.38
X$199334 VDD VSS sg13g2_decap_8
* cell instance $199335 m0 *1 646.56,835.38
X$199335 VDD VSS sg13g2_decap_8
* cell instance $199336 m0 *1 636.48,835.38
X$199336 VDD VSS sg13g2_decap_8
* cell instance $199337 m0 *1 659.04,389.34
X$199337 VDD VSS sg13g2_decap_8
* cell instance $199338 m0 *1 649.92,835.38
X$199338 VDD VSS sg13g2_decap_8
* cell instance $199339 m0 *1 633.12,835.38
X$199339 VDD VSS sg13g2_decap_8
* cell instance $199340 m0 *1 648.96,389.34
X$199340 VDD VSS sg13g2_decap_8
* cell instance $199341 m0 *1 554.88,389.34
X$199341 VDD VSS sg13g2_decap_8
* cell instance $199342 m0 *1 639.84,835.38
X$199342 VDD VSS sg13g2_decap_8
* cell instance $199343 m0 *1 890.88,381.78
X$199343 VDD VSS sg13g2_decap_8
* cell instance $199344 m0 *1 554.88,374.22
X$199344 VDD VSS sg13g2_decap_8
* cell instance $199345 m0 *1 485.28,790.02
X$199345 VDD VSS sg13g2_decap_8
* cell instance $199346 m0 *1 497.76,782.46
X$199346 VDD VSS sg13g2_decap_8
* cell instance $199347 m0 *1 494.4,782.46
X$199347 VDD VSS sg13g2_decap_8
* cell instance $199348 m0 *1 638.88,389.34
X$199348 VDD VSS sg13g2_decap_8
* cell instance $199349 m0 *1 642.24,389.34
X$199349 VDD VSS sg13g2_decap_8
* cell instance $199350 m0 *1 643.2,835.38
X$199350 VDD VSS sg13g2_decap_8
* cell instance $199351 m0 *1 554.88,381.78
X$199351 VDD VSS sg13g2_decap_8
* cell instance $199352 m0 *1 491.04,782.46
X$199352 VDD VSS sg13g2_decap_8
* cell instance $199353 m0 *1 588.48,389.34
X$199353 VDD VSS sg13g2_decap_8
* cell instance $199354 m0 *1 487.68,782.46
X$199354 VDD VSS sg13g2_decap_8
* cell instance $199355 m0 *1 504.48,782.46
X$199355 VDD VSS sg13g2_decap_8
* cell instance $199356 m0 *1 897.6,381.78
X$199356 VDD VSS sg13g2_decap_8
* cell instance $199357 m0 *1 501.12,782.46
X$199357 VDD VSS sg13g2_decap_8
* cell instance $199358 m0 *1 447.36,782.46
X$199358 VDD VSS sg13g2_decap_8
* cell instance $199359 m0 *1 448.32,790.02
X$199359 VDD VSS sg13g2_decap_8
* cell instance $199360 m0 *1 444,782.46
X$199360 VDD VSS sg13g2_decap_8
* cell instance $199361 m0 *1 874.08,389.34
X$199361 VDD VSS sg13g2_decap_8
* cell instance $199362 m0 *1 616.32,835.38
X$199362 VDD VSS sg13g2_decap_8
* cell instance $199363 m0 *1 468.48,790.02
X$199363 VDD VSS sg13g2_decap_8
* cell instance $199364 m0 *1 887.52,381.78
X$199364 VDD VSS sg13g2_decap_8
* cell instance $199365 m0 *1 575.04,396.9
X$199365 VDD VSS sg13g2_decap_8
* cell instance $199366 m0 *1 440.64,782.46
X$199366 VDD VSS sg13g2_decap_8
* cell instance $199367 m0 *1 877.44,381.78
X$199367 VDD VSS sg13g2_decap_8
* cell instance $199368 m0 *1 880.8,381.78
X$199368 VDD VSS sg13g2_decap_8
* cell instance $199369 m0 *1 623.04,835.38
X$199369 VDD VSS sg13g2_decap_8
* cell instance $199370 m0 *1 880.8,389.34
X$199370 VDD VSS sg13g2_decap_8
* cell instance $199371 m0 *1 450.72,782.46
X$199371 VDD VSS sg13g2_decap_8
* cell instance $199372 m0 *1 874.08,381.78
X$199372 VDD VSS sg13g2_decap_8
* cell instance $199373 m0 *1 444.96,790.02
X$199373 VDD VSS sg13g2_decap_8
* cell instance $199374 m0 *1 619.68,835.38
X$199374 VDD VSS sg13g2_decap_8
* cell instance $199375 m0 *1 884.16,389.34
X$199375 VDD VSS sg13g2_decap_8
* cell instance $199376 m0 *1 568.32,396.9
X$199376 VDD VSS sg13g2_decap_8
* cell instance $199377 m0 *1 625.44,374.22
X$199377 VDD VSS sg13g2_decap_8
* cell instance $199378 m0 *1 468.48,812.7
X$199378 VDD VSS sg13g2_decap_8
* cell instance $199379 m0 *1 461.76,812.7
X$199379 VDD VSS sg13g2_decap_8
* cell instance $199380 m0 *1 458.4,805.14
X$199380 VDD VSS sg13g2_decap_8
* cell instance $199381 m0 *1 880.8,374.22
X$199381 VDD VSS sg13g2_decap_8
* cell instance $199382 m0 *1 437.28,782.46
X$199382 VDD VSS sg13g2_decap_8
* cell instance $199383 m0 *1 877.44,389.34
X$199383 VDD VSS sg13g2_decap_8
* cell instance $199384 m0 *1 461.76,790.02
X$199384 VDD VSS sg13g2_decap_8
* cell instance $199385 m0 *1 581.76,396.9
X$199385 VDD VSS sg13g2_decap_8
* cell instance $199386 m0 *1 465.12,790.02
X$199386 VDD VSS sg13g2_decap_8
* cell instance $199387 m0 *1 451.68,790.02
X$199387 VDD VSS sg13g2_decap_8
* cell instance $199388 m0 *1 887.52,389.34
X$199388 VDD VSS sg13g2_decap_8
* cell instance $199389 m0 *1 464.16,782.46
X$199389 VDD VSS sg13g2_decap_8
* cell instance $199390 m0 *1 904.32,389.34
X$199390 VDD VSS sg13g2_decap_8
* cell instance $199391 m0 *1 460.8,782.46
X$199391 VDD VSS sg13g2_decap_8
* cell instance $199392 m0 *1 897.6,389.34
X$199392 VDD VSS sg13g2_decap_8
* cell instance $199393 m0 *1 578.4,396.9
X$199393 VDD VSS sg13g2_decap_8
* cell instance $199394 m0 *1 470.88,782.46
X$199394 VDD VSS sg13g2_decap_8
* cell instance $199395 m0 *1 467.52,782.46
X$199395 VDD VSS sg13g2_decap_8
* cell instance $199396 m0 *1 454.08,782.46
X$199396 VDD VSS sg13g2_decap_8
* cell instance $199397 m0 *1 628.8,374.22
X$199397 VDD VSS sg13g2_decap_8
* cell instance $199398 m0 *1 458.4,790.02
X$199398 VDD VSS sg13g2_decap_8
* cell instance $199399 m0 *1 441.6,790.02
X$199399 VDD VSS sg13g2_decap_8
* cell instance $199400 r0 *1 679.2,366.66
X$199400 VDD VSS sg13g2_decap_8
* cell instance $199401 r0 *1 689.28,389.34
X$199401 VDD VSS sg13g2_decap_8
* cell instance $199402 r0 *1 910.56,963.9
X$199402 VDD VSS sg13g2_decap_8
* cell instance $199403 r0 *1 682.56,389.34
X$199403 VDD VSS sg13g2_decap_8
* cell instance $199404 r0 *1 729.6,389.34
X$199404 VDD VSS sg13g2_decap_8
* cell instance $199405 r0 *1 578.4,374.22
X$199405 VDD VSS sg13g2_decap_8
* cell instance $199406 r0 *1 689.28,366.66
X$199406 VDD VSS sg13g2_decap_8
* cell instance $199407 r0 *1 716.16,374.22
X$199407 VDD VSS sg13g2_decap_8
* cell instance $199408 r0 *1 685.92,389.34
X$199408 VDD VSS sg13g2_decap_8
* cell instance $199409 r0 *1 682.56,366.66
X$199409 VDD VSS sg13g2_decap_8
* cell instance $199410 r0 *1 675.84,366.66
X$199410 VDD VSS sg13g2_decap_8
* cell instance $199411 r0 *1 675.84,389.34
X$199411 VDD VSS sg13g2_decap_8
* cell instance $199412 r0 *1 702.72,366.66
X$199412 VDD VSS sg13g2_decap_8
* cell instance $199413 r0 *1 679.2,381.78
X$199413 VDD VSS sg13g2_decap_8
* cell instance $199414 r0 *1 706.08,366.66
X$199414 VDD VSS sg13g2_decap_8
* cell instance $199415 r0 *1 571.68,389.34
X$199415 VDD VSS sg13g2_decap_8
* cell instance $199416 r0 *1 685.92,381.78
X$199416 VDD VSS sg13g2_decap_8
* cell instance $199417 r0 *1 709.44,366.66
X$199417 VDD VSS sg13g2_decap_8
* cell instance $199418 r0 *1 699.36,366.66
X$199418 VDD VSS sg13g2_decap_8
* cell instance $199419 r0 *1 696,366.66
X$199419 VDD VSS sg13g2_decap_8
* cell instance $199420 r0 *1 910.56,956.34
X$199420 VDD VSS sg13g2_decap_8
* cell instance $199421 r0 *1 685.92,366.66
X$199421 VDD VSS sg13g2_decap_8
* cell instance $199422 r0 *1 675.84,381.78
X$199422 VDD VSS sg13g2_decap_8
* cell instance $199423 r0 *1 754.08,396.9
X$199423 VDD VSS sg13g2_decap_8
* cell instance $199424 r0 *1 618.72,366.66
X$199424 VDD VSS sg13g2_decap_8
* cell instance $199425 r0 *1 628.8,366.66
X$199425 VDD VSS sg13g2_decap_8
* cell instance $199426 r0 *1 622.08,366.66
X$199426 VDD VSS sg13g2_decap_8
* cell instance $199427 r0 *1 655.68,381.78
X$199427 VDD VSS sg13g2_decap_8
* cell instance $199428 r0 *1 754.08,404.46
X$199428 VDD VSS sg13g2_decap_8
* cell instance $199429 r0 *1 754.08,419.58
X$199429 VDD VSS sg13g2_decap_8
* cell instance $199430 r0 *1 754.08,412.02
X$199430 VDD VSS sg13g2_decap_8
* cell instance $199431 r0 *1 750.72,396.9
X$199431 VDD VSS sg13g2_decap_8
* cell instance $199432 r0 *1 638.88,381.78
X$199432 VDD VSS sg13g2_decap_8
* cell instance $199433 r0 *1 608.64,389.34
X$199433 VDD VSS sg13g2_decap_8
* cell instance $199434 r0 *1 753.12,374.22
X$199434 VDD VSS sg13g2_decap_8
* cell instance $199435 r0 *1 753.12,366.66
X$199435 VDD VSS sg13g2_decap_8
* cell instance $199436 r0 *1 655.68,389.34
X$199436 VDD VSS sg13g2_decap_8
* cell instance $199437 r0 *1 642.24,381.78
X$199437 VDD VSS sg13g2_decap_8
* cell instance $199438 r0 *1 665.76,381.78
X$199438 VDD VSS sg13g2_decap_8
* cell instance $199439 r0 *1 753.12,389.34
X$199439 VDD VSS sg13g2_decap_8
* cell instance $199440 r0 *1 753.12,381.78
X$199440 VDD VSS sg13g2_decap_8
* cell instance $199441 r0 *1 750.72,412.02
X$199441 VDD VSS sg13g2_decap_8
* cell instance $199442 r0 *1 652.32,389.34
X$199442 VDD VSS sg13g2_decap_8
* cell instance $199443 r0 *1 638.88,389.34
X$199443 VDD VSS sg13g2_decap_8
* cell instance $199444 r0 *1 750.72,419.58
X$199444 VDD VSS sg13g2_decap_8
* cell instance $199445 r0 *1 833.28,933.66
X$199445 VDD VSS sg13g2_decap_8
* cell instance $199446 r0 *1 833.28,941.22
X$199446 VDD VSS sg13g2_decap_8
* cell instance $199447 r0 *1 740.64,412.02
X$199447 VDD VSS sg13g2_decap_8
* cell instance $199448 r0 *1 605.28,389.34
X$199448 VDD VSS sg13g2_decap_8
* cell instance $199449 r0 *1 833.28,956.34
X$199449 VDD VSS sg13g2_decap_8
* cell instance $199450 r0 *1 601.92,389.34
X$199450 VDD VSS sg13g2_decap_8
* cell instance $199451 r0 *1 833.28,963.9
X$199451 VDD VSS sg13g2_decap_8
* cell instance $199452 r0 *1 833.28,979.02
X$199452 VDD VSS sg13g2_decap_8
* cell instance $199453 r0 *1 833.28,971.46
X$199453 VDD VSS sg13g2_decap_8
* cell instance $199454 r0 *1 833.28,948.78
X$199454 VDD VSS sg13g2_decap_8
* cell instance $199455 r0 *1 750.72,404.46
X$199455 VDD VSS sg13g2_decap_8
* cell instance $199456 r0 *1 595.2,366.66
X$199456 VDD VSS sg13g2_decap_8
* cell instance $199457 r0 *1 598.56,366.66
X$199457 VDD VSS sg13g2_decap_8
* cell instance $199458 r0 *1 601.92,366.66
X$199458 VDD VSS sg13g2_decap_8
* cell instance $199459 r0 *1 608.64,366.66
X$199459 VDD VSS sg13g2_decap_8
* cell instance $199460 r0 *1 712.8,374.22
X$199460 VDD VSS sg13g2_decap_8
* cell instance $199461 r0 *1 625.44,366.66
X$199461 VDD VSS sg13g2_decap_8
* cell instance $199462 r0 *1 712.8,366.66
X$199462 VDD VSS sg13g2_decap_8
* cell instance $199463 r0 *1 712.8,389.34
X$199463 VDD VSS sg13g2_decap_8
* cell instance $199464 r0 *1 712.8,381.78
X$199464 VDD VSS sg13g2_decap_8
* cell instance $199465 r0 *1 615.36,366.66
X$199465 VDD VSS sg13g2_decap_8
* cell instance $199466 r0 *1 605.28,366.66
X$199466 VDD VSS sg13g2_decap_8
* cell instance $199467 r0 *1 662.4,389.34
X$199467 VDD VSS sg13g2_decap_8
* cell instance $199468 r0 *1 635.52,381.78
X$199468 VDD VSS sg13g2_decap_8
* cell instance $199469 r0 *1 652.32,381.78
X$199469 VDD VSS sg13g2_decap_8
* cell instance $199470 r0 *1 645.6,366.66
X$199470 VDD VSS sg13g2_decap_8
* cell instance $199471 r0 *1 648.96,366.66
X$199471 VDD VSS sg13g2_decap_8
* cell instance $199472 r0 *1 659.04,366.66
X$199472 VDD VSS sg13g2_decap_8
* cell instance $199473 r0 *1 662.4,374.22
X$199473 VDD VSS sg13g2_decap_8
* cell instance $199474 r0 *1 662.4,366.66
X$199474 VDD VSS sg13g2_decap_8
* cell instance $199475 r0 *1 652.32,374.22
X$199475 VDD VSS sg13g2_decap_8
* cell instance $199476 r0 *1 642.24,366.66
X$199476 VDD VSS sg13g2_decap_8
* cell instance $199477 r0 *1 642.24,389.34
X$199477 VDD VSS sg13g2_decap_8
* cell instance $199478 r0 *1 669.12,374.22
X$199478 VDD VSS sg13g2_decap_8
* cell instance $199479 r0 *1 635.52,374.22
X$199479 VDD VSS sg13g2_decap_8
* cell instance $199480 r0 *1 648.96,381.78
X$199480 VDD VSS sg13g2_decap_8
* cell instance $199481 r0 *1 652.32,366.66
X$199481 VDD VSS sg13g2_decap_8
* cell instance $199482 r0 *1 655.68,366.66
X$199482 VDD VSS sg13g2_decap_8
* cell instance $199483 r0 *1 665.76,374.22
X$199483 VDD VSS sg13g2_decap_8
* cell instance $199484 r0 *1 669.12,366.66
X$199484 VDD VSS sg13g2_decap_8
* cell instance $199485 r0 *1 648.96,389.34
X$199485 VDD VSS sg13g2_decap_8
* cell instance $199486 r0 *1 669.12,381.78
X$199486 VDD VSS sg13g2_decap_8
* cell instance $199487 r0 *1 645.6,389.34
X$199487 VDD VSS sg13g2_decap_8
* cell instance $199488 r0 *1 648.96,374.22
X$199488 VDD VSS sg13g2_decap_8
* cell instance $199489 r0 *1 830.4,374.22
X$199489 VDD VSS sg13g2_decap_8
* cell instance $199490 r0 *1 830.4,366.66
X$199490 VDD VSS sg13g2_decap_8
* cell instance $199491 r0 *1 830.4,381.78
X$199491 VDD VSS sg13g2_decap_8
* cell instance $199492 r0 *1 830.4,389.34
X$199492 VDD VSS sg13g2_decap_8
* cell instance $199493 r0 *1 645.6,374.22
X$199493 VDD VSS sg13g2_decap_8
* cell instance $199494 r0 *1 659.04,374.22
X$199494 VDD VSS sg13g2_decap_8
* cell instance $199495 r0 *1 831.36,412.02
X$199495 VDD VSS sg13g2_decap_8
* cell instance $199496 r0 *1 831.36,404.46
X$199496 VDD VSS sg13g2_decap_8
* cell instance $199497 r0 *1 642.24,374.22
X$199497 VDD VSS sg13g2_decap_8
* cell instance $199498 r0 *1 831.36,396.9
X$199498 VDD VSS sg13g2_decap_8
* cell instance $199499 r0 *1 635.52,389.34
X$199499 VDD VSS sg13g2_decap_8
* cell instance $199500 r0 *1 662.4,381.78
X$199500 VDD VSS sg13g2_decap_8
* cell instance $199501 r0 *1 655.68,374.22
X$199501 VDD VSS sg13g2_decap_8
* cell instance $199502 r0 *1 665.76,366.66
X$199502 VDD VSS sg13g2_decap_8
* cell instance $199503 r0 *1 638.88,374.22
X$199503 VDD VSS sg13g2_decap_8
* cell instance $199504 r0 *1 665.76,389.34
X$199504 VDD VSS sg13g2_decap_8
* cell instance $199505 r0 *1 669.12,389.34
X$199505 VDD VSS sg13g2_decap_8
* cell instance $199506 r0 *1 635.52,366.66
X$199506 VDD VSS sg13g2_decap_8
* cell instance $199507 r0 *1 638.88,366.66
X$199507 VDD VSS sg13g2_decap_8
* cell instance $199508 r0 *1 645.6,381.78
X$199508 VDD VSS sg13g2_decap_8
* cell instance $199509 r0 *1 659.04,381.78
X$199509 VDD VSS sg13g2_decap_8
* cell instance $199510 r0 *1 659.04,389.34
X$199510 VDD VSS sg13g2_decap_8
* cell instance $199511 r0 *1 831.36,419.58
X$199511 VDD VSS sg13g2_decap_8
* cell instance $199512 r0 *1 615.36,374.22
X$199512 VDD VSS sg13g2_decap_8
* cell instance $199513 r0 *1 618.72,374.22
X$199513 VDD VSS sg13g2_decap_8
* cell instance $199514 r0 *1 702.72,389.34
X$199514 VDD VSS sg13g2_decap_8
* cell instance $199515 r0 *1 628.8,374.22
X$199515 VDD VSS sg13g2_decap_8
* cell instance $199516 r0 *1 612,381.78
X$199516 VDD VSS sg13g2_decap_8
* cell instance $199517 r0 *1 612,389.34
X$199517 VDD VSS sg13g2_decap_8
* cell instance $199518 r0 *1 709.44,381.78
X$199518 VDD VSS sg13g2_decap_8
* cell instance $199519 r0 *1 601.92,374.22
X$199519 VDD VSS sg13g2_decap_8
* cell instance $199520 r0 *1 605.28,374.22
X$199520 VDD VSS sg13g2_decap_8
* cell instance $199521 r0 *1 625.44,374.22
X$199521 VDD VSS sg13g2_decap_8
* cell instance $199522 r0 *1 744,412.02
X$199522 VDD VSS sg13g2_decap_8
* cell instance $199523 r0 *1 625.44,389.34
X$199523 VDD VSS sg13g2_decap_8
* cell instance $199524 r0 *1 622.08,389.34
X$199524 VDD VSS sg13g2_decap_8
* cell instance $199525 r0 *1 625.44,381.78
X$199525 VDD VSS sg13g2_decap_8
* cell instance $199526 r0 *1 706.08,381.78
X$199526 VDD VSS sg13g2_decap_8
* cell instance $199527 r0 *1 692.64,374.22
X$199527 VDD VSS sg13g2_decap_8
* cell instance $199528 r0 *1 692.64,366.66
X$199528 VDD VSS sg13g2_decap_8
* cell instance $199529 r0 *1 692.64,381.78
X$199529 VDD VSS sg13g2_decap_8
* cell instance $199530 r0 *1 692.64,389.34
X$199530 VDD VSS sg13g2_decap_8
* cell instance $199531 r0 *1 696,374.22
X$199531 VDD VSS sg13g2_decap_8
* cell instance $199532 r0 *1 699.36,374.22
X$199532 VDD VSS sg13g2_decap_8
* cell instance $199533 r0 *1 598.56,374.22
X$199533 VDD VSS sg13g2_decap_8
* cell instance $199534 r0 *1 910.56,948.78
X$199534 VDD VSS sg13g2_decap_8
* cell instance $199535 r0 *1 679.2,389.34
X$199535 VDD VSS sg13g2_decap_8
* cell instance $199536 r0 *1 689.28,381.78
X$199536 VDD VSS sg13g2_decap_8
* cell instance $199537 r0 *1 682.56,381.78
X$199537 VDD VSS sg13g2_decap_8
* cell instance $199538 r0 *1 632.16,389.34
X$199538 VDD VSS sg13g2_decap_8
* cell instance $199539 r0 *1 910.56,979.02
X$199539 VDD VSS sg13g2_decap_8
* cell instance $199540 r0 *1 709.44,389.34
X$199540 VDD VSS sg13g2_decap_8
* cell instance $199541 r0 *1 910.56,971.46
X$199541 VDD VSS sg13g2_decap_8
* cell instance $199542 r0 *1 696,389.34
X$199542 VDD VSS sg13g2_decap_8
* cell instance $199543 r0 *1 632.16,366.66
X$199543 VDD VSS sg13g2_decap_8
* cell instance $199544 r0 *1 608.64,374.22
X$199544 VDD VSS sg13g2_decap_8
* cell instance $199545 r0 *1 699.36,381.78
X$199545 VDD VSS sg13g2_decap_8
* cell instance $199546 r0 *1 702.72,381.78
X$199546 VDD VSS sg13g2_decap_8
* cell instance $199547 r0 *1 632.16,381.78
X$199547 VDD VSS sg13g2_decap_8
* cell instance $199548 r0 *1 699.36,389.34
X$199548 VDD VSS sg13g2_decap_8
* cell instance $199549 r0 *1 632.16,374.22
X$199549 VDD VSS sg13g2_decap_8
* cell instance $199550 r0 *1 706.08,389.34
X$199550 VDD VSS sg13g2_decap_8
* cell instance $199551 r0 *1 595.2,374.22
X$199551 VDD VSS sg13g2_decap_8
* cell instance $199552 r0 *1 612,374.22
X$199552 VDD VSS sg13g2_decap_8
* cell instance $199553 r0 *1 622.08,374.22
X$199553 VDD VSS sg13g2_decap_8
* cell instance $199554 r0 *1 612,366.66
X$199554 VDD VSS sg13g2_decap_8
* cell instance $199555 r0 *1 696,381.78
X$199555 VDD VSS sg13g2_decap_8
* cell instance $199556 r0 *1 829.92,979.02
X$199556 VDD VSS sg13g2_decap_8
* cell instance $199557 r0 *1 744,419.58
X$199557 VDD VSS sg13g2_decap_8
* cell instance $199558 r0 *1 740.64,396.9
X$199558 VDD VSS sg13g2_decap_8
* cell instance $199559 r0 *1 744,396.9
X$199559 VDD VSS sg13g2_decap_8
* cell instance $199560 r0 *1 829.92,971.46
X$199560 VDD VSS sg13g2_decap_8
* cell instance $199561 r0 *1 618.72,389.34
X$199561 VDD VSS sg13g2_decap_8
* cell instance $199562 r0 *1 737.28,412.02
X$199562 VDD VSS sg13g2_decap_8
* cell instance $199563 r0 *1 598.56,389.34
X$199563 VDD VSS sg13g2_decap_8
* cell instance $199564 r0 *1 747.36,396.9
X$199564 VDD VSS sg13g2_decap_8
* cell instance $199565 r0 *1 740.64,404.46
X$199565 VDD VSS sg13g2_decap_8
* cell instance $199566 r0 *1 706.08,374.22
X$199566 VDD VSS sg13g2_decap_8
* cell instance $199567 r0 *1 740.64,419.58
X$199567 VDD VSS sg13g2_decap_8
* cell instance $199568 r0 *1 605.28,381.78
X$199568 VDD VSS sg13g2_decap_8
* cell instance $199569 r0 *1 747.36,419.58
X$199569 VDD VSS sg13g2_decap_8
* cell instance $199570 r0 *1 747.36,412.02
X$199570 VDD VSS sg13g2_decap_8
* cell instance $199571 r0 *1 744,404.46
X$199571 VDD VSS sg13g2_decap_8
* cell instance $199572 r0 *1 595.2,381.78
X$199572 VDD VSS sg13g2_decap_8
* cell instance $199573 r0 *1 598.56,381.78
X$199573 VDD VSS sg13g2_decap_8
* cell instance $199574 r0 *1 608.64,381.78
X$199574 VDD VSS sg13g2_decap_8
* cell instance $199575 r0 *1 595.2,389.34
X$199575 VDD VSS sg13g2_decap_8
* cell instance $199576 r0 *1 833.28,926.1
X$199576 VDD VSS sg13g2_decap_8
* cell instance $199577 r0 *1 601.92,381.78
X$199577 VDD VSS sg13g2_decap_8
* cell instance $199578 r0 *1 615.36,389.34
X$199578 VDD VSS sg13g2_decap_8
* cell instance $199579 r0 *1 622.08,381.78
X$199579 VDD VSS sg13g2_decap_8
* cell instance $199580 r0 *1 702.72,374.22
X$199580 VDD VSS sg13g2_decap_8
* cell instance $199581 r0 *1 675.84,374.22
X$199581 VDD VSS sg13g2_decap_8
* cell instance $199582 r0 *1 829.92,926.1
X$199582 VDD VSS sg13g2_decap_8
* cell instance $199583 r0 *1 679.2,374.22
X$199583 VDD VSS sg13g2_decap_8
* cell instance $199584 r0 *1 685.92,374.22
X$199584 VDD VSS sg13g2_decap_8
* cell instance $199585 r0 *1 709.44,374.22
X$199585 VDD VSS sg13g2_decap_8
* cell instance $199586 r0 *1 682.56,374.22
X$199586 VDD VSS sg13g2_decap_8
* cell instance $199587 r0 *1 829.92,948.78
X$199587 VDD VSS sg13g2_decap_8
* cell instance $199588 r0 *1 737.28,396.9
X$199588 VDD VSS sg13g2_decap_8
* cell instance $199589 r0 *1 829.92,941.22
X$199589 VDD VSS sg13g2_decap_8
* cell instance $199590 r0 *1 737.28,404.46
X$199590 VDD VSS sg13g2_decap_8
* cell instance $199591 r0 *1 829.92,933.66
X$199591 VDD VSS sg13g2_decap_8
* cell instance $199592 r0 *1 618.72,381.78
X$199592 VDD VSS sg13g2_decap_8
* cell instance $199593 r0 *1 615.36,381.78
X$199593 VDD VSS sg13g2_decap_8
* cell instance $199594 r0 *1 628.8,381.78
X$199594 VDD VSS sg13g2_decap_8
* cell instance $199595 r0 *1 628.8,389.34
X$199595 VDD VSS sg13g2_decap_8
* cell instance $199596 r0 *1 829.92,956.34
X$199596 VDD VSS sg13g2_decap_8
* cell instance $199597 r0 *1 747.36,404.46
X$199597 VDD VSS sg13g2_decap_8
* cell instance $199598 r0 *1 737.28,419.58
X$199598 VDD VSS sg13g2_decap_8
* cell instance $199599 r0 *1 829.92,963.9
X$199599 VDD VSS sg13g2_decap_8
* cell instance $199600 r0 *1 689.28,374.22
X$199600 VDD VSS sg13g2_decap_8
* cell instance $199601 r0 *1 907.68,381.78
X$199601 VDD VSS sg13g2_decap_8
* cell instance $199602 r0 *1 907.68,389.34
X$199602 VDD VSS sg13g2_decap_8
* cell instance $199603 r0 *1 904.32,389.34
X$199603 VDD VSS sg13g2_decap_8
* cell instance $199604 r0 *1 904.32,381.78
X$199604 VDD VSS sg13g2_decap_8
* cell instance $199605 r0 *1 894.24,381.78
X$199605 VDD VSS sg13g2_decap_8
* cell instance $199606 r0 *1 874.08,381.78
X$199606 VDD VSS sg13g2_decap_8
* cell instance $199607 r0 *1 887.52,381.78
X$199607 VDD VSS sg13g2_decap_8
* cell instance $199608 r0 *1 887.52,389.34
X$199608 VDD VSS sg13g2_decap_8
* cell instance $199609 r0 *1 568.32,374.22
X$199609 VDD VSS sg13g2_decap_8
* cell instance $199610 r0 *1 877.44,381.78
X$199610 VDD VSS sg13g2_decap_8
* cell instance $199611 r0 *1 874.08,389.34
X$199611 VDD VSS sg13g2_decap_8
* cell instance $199612 r0 *1 880.8,389.34
X$199612 VDD VSS sg13g2_decap_8
* cell instance $199613 r0 *1 884.16,389.34
X$199613 VDD VSS sg13g2_decap_8
* cell instance $199614 r0 *1 877.44,389.34
X$199614 VDD VSS sg13g2_decap_8
* cell instance $199615 r0 *1 880.8,381.78
X$199615 VDD VSS sg13g2_decap_8
* cell instance $199616 r0 *1 884.16,366.66
X$199616 VDD VSS sg13g2_decap_8
* cell instance $199617 r0 *1 877.44,366.66
X$199617 VDD VSS sg13g2_decap_8
* cell instance $199618 r0 *1 884.16,381.78
X$199618 VDD VSS sg13g2_decap_8
* cell instance $199619 r0 *1 897.6,374.22
X$199619 VDD VSS sg13g2_decap_8
* cell instance $199620 r0 *1 894.24,374.22
X$199620 VDD VSS sg13g2_decap_8
* cell instance $199621 r0 *1 890.88,374.22
X$199621 VDD VSS sg13g2_decap_8
* cell instance $199622 r0 *1 890.88,366.66
X$199622 VDD VSS sg13g2_decap_8
* cell instance $199623 r0 *1 904.32,374.22
X$199623 VDD VSS sg13g2_decap_8
* cell instance $199624 r0 *1 907.68,374.22
X$199624 VDD VSS sg13g2_decap_8
* cell instance $199625 r0 *1 884.16,374.22
X$199625 VDD VSS sg13g2_decap_8
* cell instance $199626 r0 *1 880.8,374.22
X$199626 VDD VSS sg13g2_decap_8
* cell instance $199627 r0 *1 897.6,381.78
X$199627 VDD VSS sg13g2_decap_8
* cell instance $199628 r0 *1 874.08,374.22
X$199628 VDD VSS sg13g2_decap_8
* cell instance $199629 r0 *1 890.88,389.34
X$199629 VDD VSS sg13g2_decap_8
* cell instance $199630 r0 *1 877.44,374.22
X$199630 VDD VSS sg13g2_decap_8
* cell instance $199631 r0 *1 887.52,374.22
X$199631 VDD VSS sg13g2_decap_8
* cell instance $199632 r0 *1 897.6,389.34
X$199632 VDD VSS sg13g2_decap_8
* cell instance $199633 r0 *1 900.96,381.78
X$199633 VDD VSS sg13g2_decap_8
* cell instance $199634 r0 *1 900.96,389.34
X$199634 VDD VSS sg13g2_decap_8
* cell instance $199635 r0 *1 894.24,389.34
X$199635 VDD VSS sg13g2_decap_8
* cell instance $199636 r0 *1 890.88,381.78
X$199636 VDD VSS sg13g2_decap_8
* cell instance $199637 r0 *1 965.76,412.02
X$199637 VDD VSS sg13g2_decap_8
* cell instance $199638 r0 *1 972.48,404.46
X$199638 VDD VSS sg13g2_decap_8
* cell instance $199639 r0 *1 972.48,396.9
X$199639 VDD VSS sg13g2_decap_8
* cell instance $199640 r0 *1 955.68,412.02
X$199640 VDD VSS sg13g2_decap_8
* cell instance $199641 r0 *1 969.12,412.02
X$199641 VDD VSS sg13g2_decap_8
* cell instance $199642 r0 *1 979.2,412.02
X$199642 VDD VSS sg13g2_decap_8
* cell instance $199643 r0 *1 972.48,419.58
X$199643 VDD VSS sg13g2_decap_8
* cell instance $199644 r0 *1 975.84,412.02
X$199644 VDD VSS sg13g2_decap_8
* cell instance $199645 r0 *1 874.08,366.66
X$199645 VDD VSS sg13g2_decap_8
* cell instance $199646 r0 *1 982.56,419.58
X$199646 VDD VSS sg13g2_decap_8
* cell instance $199647 r0 *1 975.84,419.58
X$199647 VDD VSS sg13g2_decap_8
* cell instance $199648 r0 *1 959.04,419.58
X$199648 VDD VSS sg13g2_decap_8
* cell instance $199649 r0 *1 969.12,419.58
X$199649 VDD VSS sg13g2_decap_8
* cell instance $199650 r0 *1 965.76,419.58
X$199650 VDD VSS sg13g2_decap_8
* cell instance $199651 r0 *1 962.4,419.58
X$199651 VDD VSS sg13g2_decap_8
* cell instance $199652 r0 *1 955.68,419.58
X$199652 VDD VSS sg13g2_decap_8
* cell instance $199653 r0 *1 965.76,396.9
X$199653 VDD VSS sg13g2_decap_8
* cell instance $199654 r0 *1 979.2,419.58
X$199654 VDD VSS sg13g2_decap_8
* cell instance $199655 r0 *1 880.8,366.66
X$199655 VDD VSS sg13g2_decap_8
* cell instance $199656 r0 *1 887.52,366.66
X$199656 VDD VSS sg13g2_decap_8
* cell instance $199657 r0 *1 897.6,366.66
X$199657 VDD VSS sg13g2_decap_8
* cell instance $199658 r0 *1 900.96,366.66
X$199658 VDD VSS sg13g2_decap_8
* cell instance $199659 r0 *1 904.32,366.66
X$199659 VDD VSS sg13g2_decap_8
* cell instance $199660 r0 *1 907.68,366.66
X$199660 VDD VSS sg13g2_decap_8
* cell instance $199661 r0 *1 894.24,366.66
X$199661 VDD VSS sg13g2_decap_8
* cell instance $199662 r0 *1 951.36,381.78
X$199662 VDD VSS sg13g2_decap_8
* cell instance $199663 r0 *1 962.4,412.02
X$199663 VDD VSS sg13g2_decap_8
* cell instance $199664 r0 *1 951.36,374.22
X$199664 VDD VSS sg13g2_decap_8
* cell instance $199665 r0 *1 951.36,366.66
X$199665 VDD VSS sg13g2_decap_8
* cell instance $199666 r0 *1 952.32,412.02
X$199666 VDD VSS sg13g2_decap_8
* cell instance $199667 r0 *1 952.32,419.58
X$199667 VDD VSS sg13g2_decap_8
* cell instance $199668 r0 *1 952.32,396.9
X$199668 VDD VSS sg13g2_decap_8
* cell instance $199669 r0 *1 952.32,404.46
X$199669 VDD VSS sg13g2_decap_8
* cell instance $199670 r0 *1 982.56,412.02
X$199670 VDD VSS sg13g2_decap_8
* cell instance $199671 r0 *1 972.48,412.02
X$199671 VDD VSS sg13g2_decap_8
* cell instance $199672 r0 *1 959.04,412.02
X$199672 VDD VSS sg13g2_decap_8
* cell instance $199673 r0 *1 951.36,389.34
X$199673 VDD VSS sg13g2_decap_8
* cell instance $199674 r0 *1 861.6,396.9
X$199674 VDD VSS sg13g2_decap_8
* cell instance $199675 r0 *1 861.6,404.46
X$199675 VDD VSS sg13g2_decap_8
* cell instance $199676 r0 *1 854.88,404.46
X$199676 VDD VSS sg13g2_decap_8
* cell instance $199677 r0 *1 864.96,396.9
X$199677 VDD VSS sg13g2_decap_8
* cell instance $199678 r0 *1 868.32,396.9
X$199678 VDD VSS sg13g2_decap_8
* cell instance $199679 r0 *1 858.24,404.46
X$199679 VDD VSS sg13g2_decap_8
* cell instance $199680 r0 *1 864.96,404.46
X$199680 VDD VSS sg13g2_decap_8
* cell instance $199681 r0 *1 868.32,404.46
X$199681 VDD VSS sg13g2_decap_8
* cell instance $199682 r0 *1 900.96,374.22
X$199682 VDD VSS sg13g2_decap_8
* cell instance $199683 r0 *1 850.56,389.34
X$199683 VDD VSS sg13g2_decap_8
* cell instance $199684 r0 *1 843.84,374.22
X$199684 VDD VSS sg13g2_decap_8
* cell instance $199685 r0 *1 850.56,381.78
X$199685 VDD VSS sg13g2_decap_8
* cell instance $199686 r0 *1 857.28,374.22
X$199686 VDD VSS sg13g2_decap_8
* cell instance $199687 r0 *1 847.2,374.22
X$199687 VDD VSS sg13g2_decap_8
* cell instance $199688 r0 *1 860.64,374.22
X$199688 VDD VSS sg13g2_decap_8
* cell instance $199689 r0 *1 867.36,374.22
X$199689 VDD VSS sg13g2_decap_8
* cell instance $199690 r0 *1 850.56,366.66
X$199690 VDD VSS sg13g2_decap_8
* cell instance $199691 r0 *1 840.48,374.22
X$199691 VDD VSS sg13g2_decap_8
* cell instance $199692 r0 *1 858.24,419.58
X$199692 VDD VSS sg13g2_decap_8
* cell instance $199693 r0 *1 861.6,419.58
X$199693 VDD VSS sg13g2_decap_8
* cell instance $199694 r0 *1 838.08,419.58
X$199694 VDD VSS sg13g2_decap_8
* cell instance $199695 r0 *1 841.44,419.58
X$199695 VDD VSS sg13g2_decap_8
* cell instance $199696 r0 *1 844.8,419.58
X$199696 VDD VSS sg13g2_decap_8
* cell instance $199697 r0 *1 848.16,419.58
X$199697 VDD VSS sg13g2_decap_8
* cell instance $199698 r0 *1 834.72,419.58
X$199698 VDD VSS sg13g2_decap_8
* cell instance $199699 r0 *1 834.72,404.46
X$199699 VDD VSS sg13g2_decap_8
* cell instance $199700 r0 *1 858.24,396.9
X$199700 VDD VSS sg13g2_decap_8
* cell instance $199701 r0 *1 834.72,396.9
X$199701 VDD VSS sg13g2_decap_8
* cell instance $199702 r0 *1 838.08,404.46
X$199702 VDD VSS sg13g2_decap_8
* cell instance $199703 r0 *1 838.08,396.9
X$199703 VDD VSS sg13g2_decap_8
* cell instance $199704 r0 *1 841.44,404.46
X$199704 VDD VSS sg13g2_decap_8
* cell instance $199705 r0 *1 844.8,396.9
X$199705 VDD VSS sg13g2_decap_8
* cell instance $199706 r0 *1 848.16,396.9
X$199706 VDD VSS sg13g2_decap_8
* cell instance $199707 r0 *1 848.16,404.46
X$199707 VDD VSS sg13g2_decap_8
* cell instance $199708 r0 *1 844.8,404.46
X$199708 VDD VSS sg13g2_decap_8
* cell instance $199709 r0 *1 854.88,396.9
X$199709 VDD VSS sg13g2_decap_8
* cell instance $199710 r0 *1 841.44,396.9
X$199710 VDD VSS sg13g2_decap_8
* cell instance $199711 r0 *1 847.2,381.78
X$199711 VDD VSS sg13g2_decap_8
* cell instance $199712 r0 *1 843.84,389.34
X$199712 VDD VSS sg13g2_decap_8
* cell instance $199713 r0 *1 837.12,389.34
X$199713 VDD VSS sg13g2_decap_8
* cell instance $199714 r0 *1 840.48,389.34
X$199714 VDD VSS sg13g2_decap_8
* cell instance $199715 r0 *1 840.48,381.78
X$199715 VDD VSS sg13g2_decap_8
* cell instance $199716 r0 *1 833.76,381.78
X$199716 VDD VSS sg13g2_decap_8
* cell instance $199717 r0 *1 847.2,389.34
X$199717 VDD VSS sg13g2_decap_8
* cell instance $199718 r0 *1 833.76,366.66
X$199718 VDD VSS sg13g2_decap_8
* cell instance $199719 r0 *1 853.92,374.22
X$199719 VDD VSS sg13g2_decap_8
* cell instance $199720 r0 *1 840.48,366.66
X$199720 VDD VSS sg13g2_decap_8
* cell instance $199721 r0 *1 847.2,366.66
X$199721 VDD VSS sg13g2_decap_8
* cell instance $199722 r0 *1 837.12,366.66
X$199722 VDD VSS sg13g2_decap_8
* cell instance $199723 r0 *1 867.36,366.66
X$199723 VDD VSS sg13g2_decap_8
* cell instance $199724 r0 *1 853.92,366.66
X$199724 VDD VSS sg13g2_decap_8
* cell instance $199725 r0 *1 860.64,366.66
X$199725 VDD VSS sg13g2_decap_8
* cell instance $199726 r0 *1 857.28,366.66
X$199726 VDD VSS sg13g2_decap_8
* cell instance $199727 r0 *1 864,366.66
X$199727 VDD VSS sg13g2_decap_8
* cell instance $199728 r0 *1 843.84,366.66
X$199728 VDD VSS sg13g2_decap_8
* cell instance $199729 r0 *1 850.56,374.22
X$199729 VDD VSS sg13g2_decap_8
* cell instance $199730 r0 *1 864,374.22
X$199730 VDD VSS sg13g2_decap_8
* cell instance $199731 r0 *1 837.12,374.22
X$199731 VDD VSS sg13g2_decap_8
* cell instance $199732 r0 *1 833.76,374.22
X$199732 VDD VSS sg13g2_decap_8
* cell instance $199733 r0 *1 867.36,389.34
X$199733 VDD VSS sg13g2_decap_8
* cell instance $199734 r0 *1 867.36,381.78
X$199734 VDD VSS sg13g2_decap_8
* cell instance $199735 r0 *1 857.28,381.78
X$199735 VDD VSS sg13g2_decap_8
* cell instance $199736 r0 *1 864,381.78
X$199736 VDD VSS sg13g2_decap_8
* cell instance $199737 r0 *1 843.84,381.78
X$199737 VDD VSS sg13g2_decap_8
* cell instance $199738 r0 *1 853.92,389.34
X$199738 VDD VSS sg13g2_decap_8
* cell instance $199739 r0 *1 864,389.34
X$199739 VDD VSS sg13g2_decap_8
* cell instance $199740 r0 *1 673.92,835.38
X$199740 VDD VSS sg13g2_decap_8
* cell instance $199741 r0 *1 673.92,842.94
X$199741 VDD VSS sg13g2_decap_8
* cell instance $199742 r0 *1 860.64,381.78
X$199742 VDD VSS sg13g2_decap_8
* cell instance $199743 r0 *1 853.92,381.78
X$199743 VDD VSS sg13g2_decap_8
* cell instance $199744 r0 *1 860.64,389.34
X$199744 VDD VSS sg13g2_decap_8
* cell instance $199745 r0 *1 837.12,381.78
X$199745 VDD VSS sg13g2_decap_8
* cell instance $199746 r0 *1 833.76,389.34
X$199746 VDD VSS sg13g2_decap_8
* cell instance $199747 r0 *1 857.28,389.34
X$199747 VDD VSS sg13g2_decap_8
* cell instance $199748 r0 *1 948,366.66
X$199748 VDD VSS sg13g2_decap_8
* cell instance $199749 r0 *1 934.56,366.66
X$199749 VDD VSS sg13g2_decap_8
* cell instance $199750 r0 *1 944.64,366.66
X$199750 VDD VSS sg13g2_decap_8
* cell instance $199751 r0 *1 937.92,366.66
X$199751 VDD VSS sg13g2_decap_8
* cell instance $199752 r0 *1 948,374.22
X$199752 VDD VSS sg13g2_decap_8
* cell instance $199753 r0 *1 931.2,374.22
X$199753 VDD VSS sg13g2_decap_8
* cell instance $199754 r0 *1 931.2,366.66
X$199754 VDD VSS sg13g2_decap_8
* cell instance $199755 r0 *1 944.64,374.22
X$199755 VDD VSS sg13g2_decap_8
* cell instance $199756 r0 *1 962.4,396.9
X$199756 VDD VSS sg13g2_decap_8
* cell instance $199757 r0 *1 981.6,374.22
X$199757 VDD VSS sg13g2_decap_8
* cell instance $199758 r0 *1 971.52,366.66
X$199758 VDD VSS sg13g2_decap_8
* cell instance $199759 r0 *1 974.88,374.22
X$199759 VDD VSS sg13g2_decap_8
* cell instance $199760 r0 *1 971.52,381.78
X$199760 VDD VSS sg13g2_decap_8
* cell instance $199761 r0 *1 971.52,389.34
X$199761 VDD VSS sg13g2_decap_8
* cell instance $199762 r0 *1 958.08,374.22
X$199762 VDD VSS sg13g2_decap_8
* cell instance $199763 r0 *1 961.44,374.22
X$199763 VDD VSS sg13g2_decap_8
* cell instance $199764 r0 *1 954.72,374.22
X$199764 VDD VSS sg13g2_decap_8
* cell instance $199765 r0 *1 941.28,374.22
X$199765 VDD VSS sg13g2_decap_8
* cell instance $199766 r0 *1 917.76,389.34
X$199766 VDD VSS sg13g2_decap_8
* cell instance $199767 r0 *1 921.12,389.34
X$199767 VDD VSS sg13g2_decap_8
* cell instance $199768 r0 *1 924.48,381.78
X$199768 VDD VSS sg13g2_decap_8
* cell instance $199769 r0 *1 924.48,389.34
X$199769 VDD VSS sg13g2_decap_8
* cell instance $199770 r0 *1 927.84,389.34
X$199770 VDD VSS sg13g2_decap_8
* cell instance $199771 r0 *1 921.12,374.22
X$199771 VDD VSS sg13g2_decap_8
* cell instance $199772 r0 *1 924.48,374.22
X$199772 VDD VSS sg13g2_decap_8
* cell instance $199773 r0 *1 921.12,381.78
X$199773 VDD VSS sg13g2_decap_8
* cell instance $199774 r0 *1 941.28,366.66
X$199774 VDD VSS sg13g2_decap_8
* cell instance $199775 r0 *1 914.4,366.66
X$199775 VDD VSS sg13g2_decap_8
* cell instance $199776 r0 *1 931.2,381.78
X$199776 VDD VSS sg13g2_decap_8
* cell instance $199777 r0 *1 917.76,366.66
X$199777 VDD VSS sg13g2_decap_8
* cell instance $199778 r0 *1 921.12,366.66
X$199778 VDD VSS sg13g2_decap_8
* cell instance $199779 r0 *1 917.76,374.22
X$199779 VDD VSS sg13g2_decap_8
* cell instance $199780 r0 *1 914.4,374.22
X$199780 VDD VSS sg13g2_decap_8
* cell instance $199781 r0 *1 924.48,366.66
X$199781 VDD VSS sg13g2_decap_8
* cell instance $199782 r0 *1 927.84,366.66
X$199782 VDD VSS sg13g2_decap_8
* cell instance $199783 r0 *1 931.2,389.34
X$199783 VDD VSS sg13g2_decap_8
* cell instance $199784 r0 *1 927.84,381.78
X$199784 VDD VSS sg13g2_decap_8
* cell instance $199785 r0 *1 961.44,366.66
X$199785 VDD VSS sg13g2_decap_8
* cell instance $199786 r0 *1 964.8,366.66
X$199786 VDD VSS sg13g2_decap_8
* cell instance $199787 r0 *1 968.16,366.66
X$199787 VDD VSS sg13g2_decap_8
* cell instance $199788 r0 *1 958.08,366.66
X$199788 VDD VSS sg13g2_decap_8
* cell instance $199789 r0 *1 954.72,366.66
X$199789 VDD VSS sg13g2_decap_8
* cell instance $199790 r0 *1 978.24,366.66
X$199790 VDD VSS sg13g2_decap_8
* cell instance $199791 r0 *1 974.88,366.66
X$199791 VDD VSS sg13g2_decap_8
* cell instance $199792 r0 *1 981.6,366.66
X$199792 VDD VSS sg13g2_decap_8
* cell instance $199793 r0 *1 964.8,374.22
X$199793 VDD VSS sg13g2_decap_8
* cell instance $199794 r0 *1 672.48,374.22
X$199794 VDD VSS sg13g2_decap_8
* cell instance $199795 r0 *1 672.48,389.34
X$199795 VDD VSS sg13g2_decap_8
* cell instance $199796 r0 *1 673.44,827.82
X$199796 VDD VSS sg13g2_decap_8
* cell instance $199797 r0 *1 673.44,797.58
X$199797 VDD VSS sg13g2_decap_8
* cell instance $199798 r0 *1 672.48,366.66
X$199798 VDD VSS sg13g2_decap_8
* cell instance $199799 r0 *1 673.44,782.46
X$199799 VDD VSS sg13g2_decap_8
* cell instance $199800 r0 *1 673.44,790.02
X$199800 VDD VSS sg13g2_decap_8
* cell instance $199801 r0 *1 673.44,820.26
X$199801 VDD VSS sg13g2_decap_8
* cell instance $199802 r0 *1 672.48,381.78
X$199802 VDD VSS sg13g2_decap_8
* cell instance $199803 r0 *1 968.16,374.22
X$199803 VDD VSS sg13g2_decap_8
* cell instance $199804 r0 *1 971.52,374.22
X$199804 VDD VSS sg13g2_decap_8
* cell instance $199805 r0 *1 978.24,374.22
X$199805 VDD VSS sg13g2_decap_8
* cell instance $199806 r0 *1 981.6,389.34
X$199806 VDD VSS sg13g2_decap_8
* cell instance $199807 r0 *1 978.24,389.34
X$199807 VDD VSS sg13g2_decap_8
* cell instance $199808 r0 *1 974.88,389.34
X$199808 VDD VSS sg13g2_decap_8
* cell instance $199809 r0 *1 974.88,381.78
X$199809 VDD VSS sg13g2_decap_8
* cell instance $199810 r0 *1 981.6,381.78
X$199810 VDD VSS sg13g2_decap_8
* cell instance $199811 r0 *1 968.16,381.78
X$199811 VDD VSS sg13g2_decap_8
* cell instance $199812 r0 *1 961.44,381.78
X$199812 VDD VSS sg13g2_decap_8
* cell instance $199813 r0 *1 954.72,381.78
X$199813 VDD VSS sg13g2_decap_8
* cell instance $199814 r0 *1 958.08,381.78
X$199814 VDD VSS sg13g2_decap_8
* cell instance $199815 r0 *1 964.8,389.34
X$199815 VDD VSS sg13g2_decap_8
* cell instance $199816 r0 *1 961.44,389.34
X$199816 VDD VSS sg13g2_decap_8
* cell instance $199817 r0 *1 954.72,389.34
X$199817 VDD VSS sg13g2_decap_8
* cell instance $199818 r0 *1 964.8,381.78
X$199818 VDD VSS sg13g2_decap_8
* cell instance $199819 r0 *1 968.16,389.34
X$199819 VDD VSS sg13g2_decap_8
* cell instance $199820 r0 *1 958.08,389.34
X$199820 VDD VSS sg13g2_decap_8
* cell instance $199821 r0 *1 978.24,381.78
X$199821 VDD VSS sg13g2_decap_8
* cell instance $199822 r0 *1 925.44,412.02
X$199822 VDD VSS sg13g2_decap_8
* cell instance $199823 r0 *1 932.16,419.58
X$199823 VDD VSS sg13g2_decap_8
* cell instance $199824 r0 *1 918.72,412.02
X$199824 VDD VSS sg13g2_decap_8
* cell instance $199825 r0 *1 922.08,412.02
X$199825 VDD VSS sg13g2_decap_8
* cell instance $199826 r0 *1 948.96,412.02
X$199826 VDD VSS sg13g2_decap_8
* cell instance $199827 r0 *1 932.16,396.9
X$199827 VDD VSS sg13g2_decap_8
* cell instance $199828 r0 *1 915.36,412.02
X$199828 VDD VSS sg13g2_decap_8
* cell instance $199829 r0 *1 928.8,412.02
X$199829 VDD VSS sg13g2_decap_8
* cell instance $199830 r0 *1 914.4,381.78
X$199830 VDD VSS sg13g2_decap_8
* cell instance $199831 r0 *1 945.6,419.58
X$199831 VDD VSS sg13g2_decap_8
* cell instance $199832 r0 *1 948.96,419.58
X$199832 VDD VSS sg13g2_decap_8
* cell instance $199833 r0 *1 938.88,419.58
X$199833 VDD VSS sg13g2_decap_8
* cell instance $199834 r0 *1 935.52,419.58
X$199834 VDD VSS sg13g2_decap_8
* cell instance $199835 r0 *1 942.24,419.58
X$199835 VDD VSS sg13g2_decap_8
* cell instance $199836 r0 *1 918.72,419.58
X$199836 VDD VSS sg13g2_decap_8
* cell instance $199837 r0 *1 922.08,419.58
X$199837 VDD VSS sg13g2_decap_8
* cell instance $199838 r0 *1 928.8,419.58
X$199838 VDD VSS sg13g2_decap_8
* cell instance $199839 r0 *1 932.16,412.02
X$199839 VDD VSS sg13g2_decap_8
* cell instance $199840 r0 *1 959.04,396.9
X$199840 VDD VSS sg13g2_decap_8
* cell instance $199841 r0 *1 955.68,396.9
X$199841 VDD VSS sg13g2_decap_8
* cell instance $199842 r0 *1 969.12,404.46
X$199842 VDD VSS sg13g2_decap_8
* cell instance $199843 r0 *1 969.12,396.9
X$199843 VDD VSS sg13g2_decap_8
* cell instance $199844 r0 *1 962.4,404.46
X$199844 VDD VSS sg13g2_decap_8
* cell instance $199845 r0 *1 955.68,404.46
X$199845 VDD VSS sg13g2_decap_8
* cell instance $199846 r0 *1 965.76,404.46
X$199846 VDD VSS sg13g2_decap_8
* cell instance $199847 r0 *1 959.04,404.46
X$199847 VDD VSS sg13g2_decap_8
* cell instance $199848 r0 *1 938.88,412.02
X$199848 VDD VSS sg13g2_decap_8
* cell instance $199849 r0 *1 982.56,396.9
X$199849 VDD VSS sg13g2_decap_8
* cell instance $199850 r0 *1 979.2,404.46
X$199850 VDD VSS sg13g2_decap_8
* cell instance $199851 r0 *1 975.84,396.9
X$199851 VDD VSS sg13g2_decap_8
* cell instance $199852 r0 *1 975.84,404.46
X$199852 VDD VSS sg13g2_decap_8
* cell instance $199853 r0 *1 982.56,404.46
X$199853 VDD VSS sg13g2_decap_8
* cell instance $199854 r0 *1 942.24,412.02
X$199854 VDD VSS sg13g2_decap_8
* cell instance $199855 r0 *1 945.6,412.02
X$199855 VDD VSS sg13g2_decap_8
* cell instance $199856 r0 *1 935.52,412.02
X$199856 VDD VSS sg13g2_decap_8
* cell instance $199857 r0 *1 932.16,404.46
X$199857 VDD VSS sg13g2_decap_8
* cell instance $199858 r0 *1 979.2,396.9
X$199858 VDD VSS sg13g2_decap_8
* cell instance $199859 r0 *1 945.6,404.46
X$199859 VDD VSS sg13g2_decap_8
* cell instance $199860 r0 *1 942.24,404.46
X$199860 VDD VSS sg13g2_decap_8
* cell instance $199861 r0 *1 934.56,374.22
X$199861 VDD VSS sg13g2_decap_8
* cell instance $199862 r0 *1 937.92,374.22
X$199862 VDD VSS sg13g2_decap_8
* cell instance $199863 r0 *1 937.92,389.34
X$199863 VDD VSS sg13g2_decap_8
* cell instance $199864 r0 *1 934.56,381.78
X$199864 VDD VSS sg13g2_decap_8
* cell instance $199865 r0 *1 948,389.34
X$199865 VDD VSS sg13g2_decap_8
* cell instance $199866 r0 *1 944.64,389.34
X$199866 VDD VSS sg13g2_decap_8
* cell instance $199867 r0 *1 915.36,419.58
X$199867 VDD VSS sg13g2_decap_8
* cell instance $199868 r0 *1 948,381.78
X$199868 VDD VSS sg13g2_decap_8
* cell instance $199869 r0 *1 941.28,381.78
X$199869 VDD VSS sg13g2_decap_8
* cell instance $199870 r0 *1 937.92,381.78
X$199870 VDD VSS sg13g2_decap_8
* cell instance $199871 r0 *1 941.28,389.34
X$199871 VDD VSS sg13g2_decap_8
* cell instance $199872 r0 *1 934.56,389.34
X$199872 VDD VSS sg13g2_decap_8
* cell instance $199873 r0 *1 914.4,389.34
X$199873 VDD VSS sg13g2_decap_8
* cell instance $199874 r0 *1 927.84,374.22
X$199874 VDD VSS sg13g2_decap_8
* cell instance $199875 r0 *1 917.76,381.78
X$199875 VDD VSS sg13g2_decap_8
* cell instance $199876 r0 *1 944.64,381.78
X$199876 VDD VSS sg13g2_decap_8
* cell instance $199877 r0 *1 925.44,419.58
X$199877 VDD VSS sg13g2_decap_8
* cell instance $199878 r0 *1 922.08,404.46
X$199878 VDD VSS sg13g2_decap_8
* cell instance $199879 r0 *1 922.08,396.9
X$199879 VDD VSS sg13g2_decap_8
* cell instance $199880 r0 *1 928.8,396.9
X$199880 VDD VSS sg13g2_decap_8
* cell instance $199881 r0 *1 918.72,404.46
X$199881 VDD VSS sg13g2_decap_8
* cell instance $199882 r0 *1 915.36,396.9
X$199882 VDD VSS sg13g2_decap_8
* cell instance $199883 r0 *1 925.44,396.9
X$199883 VDD VSS sg13g2_decap_8
* cell instance $199884 r0 *1 915.36,404.46
X$199884 VDD VSS sg13g2_decap_8
* cell instance $199885 r0 *1 938.88,396.9
X$199885 VDD VSS sg13g2_decap_8
* cell instance $199886 r0 *1 918.72,396.9
X$199886 VDD VSS sg13g2_decap_8
* cell instance $199887 r0 *1 928.8,404.46
X$199887 VDD VSS sg13g2_decap_8
* cell instance $199888 r0 *1 938.88,404.46
X$199888 VDD VSS sg13g2_decap_8
* cell instance $199889 r0 *1 945.6,396.9
X$199889 VDD VSS sg13g2_decap_8
* cell instance $199890 r0 *1 948.96,404.46
X$199890 VDD VSS sg13g2_decap_8
* cell instance $199891 r0 *1 948.96,396.9
X$199891 VDD VSS sg13g2_decap_8
* cell instance $199892 r0 *1 935.52,404.46
X$199892 VDD VSS sg13g2_decap_8
* cell instance $199893 r0 *1 942.24,396.9
X$199893 VDD VSS sg13g2_decap_8
* cell instance $199894 r0 *1 935.52,396.9
X$199894 VDD VSS sg13g2_decap_8
* cell instance $199895 r0 *1 925.44,404.46
X$199895 VDD VSS sg13g2_decap_8
* cell instance $199896 r0 *1 817.92,396.9
X$199896 VDD VSS sg13g2_decap_8
* cell instance $199897 r0 *1 821.28,396.9
X$199897 VDD VSS sg13g2_decap_8
* cell instance $199898 r0 *1 814.56,404.46
X$199898 VDD VSS sg13g2_decap_8
* cell instance $199899 r0 *1 821.28,404.46
X$199899 VDD VSS sg13g2_decap_8
* cell instance $199900 r0 *1 828,396.9
X$199900 VDD VSS sg13g2_decap_8
* cell instance $199901 r0 *1 824.64,396.9
X$199901 VDD VSS sg13g2_decap_8
* cell instance $199902 r0 *1 757.44,412.02
X$199902 VDD VSS sg13g2_decap_8
* cell instance $199903 r0 *1 777.6,412.02
X$199903 VDD VSS sg13g2_decap_8
* cell instance $199904 r0 *1 854.88,419.58
X$199904 VDD VSS sg13g2_decap_8
* cell instance $199905 r0 *1 770.88,419.58
X$199905 VDD VSS sg13g2_decap_8
* cell instance $199906 r0 *1 784.32,412.02
X$199906 VDD VSS sg13g2_decap_8
* cell instance $199907 r0 *1 780.96,412.02
X$199907 VDD VSS sg13g2_decap_8
* cell instance $199908 r0 *1 787.68,412.02
X$199908 VDD VSS sg13g2_decap_8
* cell instance $199909 r0 *1 770.88,412.02
X$199909 VDD VSS sg13g2_decap_8
* cell instance $199910 r0 *1 760.8,412.02
X$199910 VDD VSS sg13g2_decap_8
* cell instance $199911 r0 *1 774.24,412.02
X$199911 VDD VSS sg13g2_decap_8
* cell instance $199912 r0 *1 764.16,412.02
X$199912 VDD VSS sg13g2_decap_8
* cell instance $199913 r0 *1 770.88,396.9
X$199913 VDD VSS sg13g2_decap_8
* cell instance $199914 r0 *1 797.76,419.58
X$199914 VDD VSS sg13g2_decap_8
* cell instance $199915 r0 *1 804.48,419.58
X$199915 VDD VSS sg13g2_decap_8
* cell instance $199916 r0 *1 807.84,419.58
X$199916 VDD VSS sg13g2_decap_8
* cell instance $199917 r0 *1 801.12,419.58
X$199917 VDD VSS sg13g2_decap_8
* cell instance $199918 r0 *1 797.76,396.9
X$199918 VDD VSS sg13g2_decap_8
* cell instance $199919 r0 *1 804.48,396.9
X$199919 VDD VSS sg13g2_decap_8
* cell instance $199920 r0 *1 807.84,396.9
X$199920 VDD VSS sg13g2_decap_8
* cell instance $199921 r0 *1 801.12,404.46
X$199921 VDD VSS sg13g2_decap_8
* cell instance $199922 r0 *1 828,404.46
X$199922 VDD VSS sg13g2_decap_8
* cell instance $199923 r0 *1 794.4,404.46
X$199923 VDD VSS sg13g2_decap_8
* cell instance $199924 r0 *1 797.76,404.46
X$199924 VDD VSS sg13g2_decap_8
* cell instance $199925 r0 *1 801.12,396.9
X$199925 VDD VSS sg13g2_decap_8
* cell instance $199926 r0 *1 794.4,396.9
X$199926 VDD VSS sg13g2_decap_8
* cell instance $199927 r0 *1 807.84,404.46
X$199927 VDD VSS sg13g2_decap_8
* cell instance $199928 r0 *1 824.64,404.46
X$199928 VDD VSS sg13g2_decap_8
* cell instance $199929 r0 *1 817.92,404.46
X$199929 VDD VSS sg13g2_decap_8
* cell instance $199930 r0 *1 814.56,396.9
X$199930 VDD VSS sg13g2_decap_8
* cell instance $199931 r0 *1 804.48,404.46
X$199931 VDD VSS sg13g2_decap_8
* cell instance $199932 r0 *1 774.24,404.46
X$199932 VDD VSS sg13g2_decap_8
* cell instance $199933 r0 *1 777.6,396.9
X$199933 VDD VSS sg13g2_decap_8
* cell instance $199934 r0 *1 780.96,396.9
X$199934 VDD VSS sg13g2_decap_8
* cell instance $199935 r0 *1 784.32,404.46
X$199935 VDD VSS sg13g2_decap_8
* cell instance $199936 r0 *1 777.6,404.46
X$199936 VDD VSS sg13g2_decap_8
* cell instance $199937 r0 *1 787.68,396.9
X$199937 VDD VSS sg13g2_decap_8
* cell instance $199938 r0 *1 774.24,396.9
X$199938 VDD VSS sg13g2_decap_8
* cell instance $199939 r0 *1 780.96,404.46
X$199939 VDD VSS sg13g2_decap_8
* cell instance $199940 r0 *1 767.52,412.02
X$199940 VDD VSS sg13g2_decap_8
* cell instance $199941 r0 *1 783.36,374.22
X$199941 VDD VSS sg13g2_decap_8
* cell instance $199942 r0 *1 780,374.22
X$199942 VDD VSS sg13g2_decap_8
* cell instance $199943 r0 *1 776.64,374.22
X$199943 VDD VSS sg13g2_decap_8
* cell instance $199944 r0 *1 759.84,374.22
X$199944 VDD VSS sg13g2_decap_8
* cell instance $199945 r0 *1 773.28,374.22
X$199945 VDD VSS sg13g2_decap_8
* cell instance $199946 r0 *1 769.92,374.22
X$199946 VDD VSS sg13g2_decap_8
* cell instance $199947 r0 *1 786.72,374.22
X$199947 VDD VSS sg13g2_decap_8
* cell instance $199948 r0 *1 763.2,374.22
X$199948 VDD VSS sg13g2_decap_8
* cell instance $199949 r0 *1 784.32,396.9
X$199949 VDD VSS sg13g2_decap_8
* cell instance $199950 r0 *1 770.88,404.46
X$199950 VDD VSS sg13g2_decap_8
* cell instance $199951 r0 *1 787.68,419.58
X$199951 VDD VSS sg13g2_decap_8
* cell instance $199952 r0 *1 777.6,419.58
X$199952 VDD VSS sg13g2_decap_8
* cell instance $199953 r0 *1 780.96,419.58
X$199953 VDD VSS sg13g2_decap_8
* cell instance $199954 r0 *1 784.32,419.58
X$199954 VDD VSS sg13g2_decap_8
* cell instance $199955 r0 *1 774.24,419.58
X$199955 VDD VSS sg13g2_decap_8
* cell instance $199956 r0 *1 757.44,419.58
X$199956 VDD VSS sg13g2_decap_8
* cell instance $199957 r0 *1 767.52,419.58
X$199957 VDD VSS sg13g2_decap_8
* cell instance $199958 r0 *1 787.68,404.46
X$199958 VDD VSS sg13g2_decap_8
* cell instance $199959 r0 *1 760.8,419.58
X$199959 VDD VSS sg13g2_decap_8
* cell instance $199960 r0 *1 760.8,404.46
X$199960 VDD VSS sg13g2_decap_8
* cell instance $199961 r0 *1 757.44,396.9
X$199961 VDD VSS sg13g2_decap_8
* cell instance $199962 r0 *1 767.52,396.9
X$199962 VDD VSS sg13g2_decap_8
* cell instance $199963 r0 *1 764.16,396.9
X$199963 VDD VSS sg13g2_decap_8
* cell instance $199964 r0 *1 760.8,396.9
X$199964 VDD VSS sg13g2_decap_8
* cell instance $199965 r0 *1 764.16,404.46
X$199965 VDD VSS sg13g2_decap_8
* cell instance $199966 r0 *1 757.44,404.46
X$199966 VDD VSS sg13g2_decap_8
* cell instance $199967 r0 *1 767.52,404.46
X$199967 VDD VSS sg13g2_decap_8
* cell instance $199968 r0 *1 764.16,419.58
X$199968 VDD VSS sg13g2_decap_8
* cell instance $199969 r0 *1 719.52,381.78
X$199969 VDD VSS sg13g2_decap_8
* cell instance $199970 r0 *1 726.24,381.78
X$199970 VDD VSS sg13g2_decap_8
* cell instance $199971 r0 *1 726.24,389.34
X$199971 VDD VSS sg13g2_decap_8
* cell instance $199972 r0 *1 722.88,389.34
X$199972 VDD VSS sg13g2_decap_8
* cell instance $199973 r0 *1 746.4,374.22
X$199973 VDD VSS sg13g2_decap_8
* cell instance $199974 r0 *1 736.32,389.34
X$199974 VDD VSS sg13g2_decap_8
* cell instance $199975 r0 *1 746.4,389.34
X$199975 VDD VSS sg13g2_decap_8
* cell instance $199976 r0 *1 746.4,381.78
X$199976 VDD VSS sg13g2_decap_8
* cell instance $199977 r0 *1 794.4,419.58
X$199977 VDD VSS sg13g2_decap_8
* cell instance $199978 r0 *1 732.96,381.78
X$199978 VDD VSS sg13g2_decap_8
* cell instance $199979 r0 *1 729.6,381.78
X$199979 VDD VSS sg13g2_decap_8
* cell instance $199980 r0 *1 719.52,389.34
X$199980 VDD VSS sg13g2_decap_8
* cell instance $199981 r0 *1 743.04,389.34
X$199981 VDD VSS sg13g2_decap_8
* cell instance $199982 r0 *1 736.32,381.78
X$199982 VDD VSS sg13g2_decap_8
* cell instance $199983 r0 *1 716.16,366.66
X$199983 VDD VSS sg13g2_decap_8
* cell instance $199984 r0 *1 749.76,381.78
X$199984 VDD VSS sg13g2_decap_8
* cell instance $199985 r0 *1 749.76,389.34
X$199985 VDD VSS sg13g2_decap_8
* cell instance $199986 r0 *1 743.04,381.78
X$199986 VDD VSS sg13g2_decap_8
* cell instance $199987 r0 *1 719.52,366.66
X$199987 VDD VSS sg13g2_decap_8
* cell instance $199988 r0 *1 749.76,374.22
X$199988 VDD VSS sg13g2_decap_8
* cell instance $199989 r0 *1 729.6,366.66
X$199989 VDD VSS sg13g2_decap_8
* cell instance $199990 r0 *1 726.24,374.22
X$199990 VDD VSS sg13g2_decap_8
* cell instance $199991 r0 *1 749.76,366.66
X$199991 VDD VSS sg13g2_decap_8
* cell instance $199992 r0 *1 736.32,374.22
X$199992 VDD VSS sg13g2_decap_8
* cell instance $199993 r0 *1 722.88,366.66
X$199993 VDD VSS sg13g2_decap_8
* cell instance $199994 r0 *1 736.32,366.66
X$199994 VDD VSS sg13g2_decap_8
* cell instance $199995 r0 *1 739.68,381.78
X$199995 VDD VSS sg13g2_decap_8
* cell instance $199996 r0 *1 739.68,366.66
X$199996 VDD VSS sg13g2_decap_8
* cell instance $199997 r0 *1 719.52,374.22
X$199997 VDD VSS sg13g2_decap_8
* cell instance $199998 r0 *1 722.88,374.22
X$199998 VDD VSS sg13g2_decap_8
* cell instance $199999 r0 *1 743.04,366.66
X$199999 VDD VSS sg13g2_decap_8
* cell instance $200000 r0 *1 726.24,366.66
X$200000 VDD VSS sg13g2_decap_8
* cell instance $200001 r0 *1 729.6,374.22
X$200001 VDD VSS sg13g2_decap_8
* cell instance $200002 r0 *1 746.4,366.66
X$200002 VDD VSS sg13g2_decap_8
* cell instance $200003 r0 *1 743.04,374.22
X$200003 VDD VSS sg13g2_decap_8
* cell instance $200004 r0 *1 722.88,381.78
X$200004 VDD VSS sg13g2_decap_8
* cell instance $200005 r0 *1 732.96,366.66
X$200005 VDD VSS sg13g2_decap_8
* cell instance $200006 r0 *1 811.2,404.46
X$200006 VDD VSS sg13g2_decap_8
* cell instance $200007 r0 *1 817.92,412.02
X$200007 VDD VSS sg13g2_decap_8
* cell instance $200008 r0 *1 811.2,412.02
X$200008 VDD VSS sg13g2_decap_8
* cell instance $200009 r0 *1 804.48,412.02
X$200009 VDD VSS sg13g2_decap_8
* cell instance $200010 r0 *1 811.2,419.58
X$200010 VDD VSS sg13g2_decap_8
* cell instance $200011 r0 *1 794.4,412.02
X$200011 VDD VSS sg13g2_decap_8
* cell instance $200012 r0 *1 797.76,412.02
X$200012 VDD VSS sg13g2_decap_8
* cell instance $200013 r0 *1 801.12,412.02
X$200013 VDD VSS sg13g2_decap_8
* cell instance $200014 r0 *1 739.68,389.34
X$200014 VDD VSS sg13g2_decap_8
* cell instance $200015 r0 *1 821.28,412.02
X$200015 VDD VSS sg13g2_decap_8
* cell instance $200016 r0 *1 824.64,412.02
X$200016 VDD VSS sg13g2_decap_8
* cell instance $200017 r0 *1 828,412.02
X$200017 VDD VSS sg13g2_decap_8
* cell instance $200018 r0 *1 817.92,419.58
X$200018 VDD VSS sg13g2_decap_8
* cell instance $200019 r0 *1 821.28,419.58
X$200019 VDD VSS sg13g2_decap_8
* cell instance $200020 r0 *1 814.56,419.58
X$200020 VDD VSS sg13g2_decap_8
* cell instance $200021 r0 *1 828,419.58
X$200021 VDD VSS sg13g2_decap_8
* cell instance $200022 r0 *1 824.64,419.58
X$200022 VDD VSS sg13g2_decap_8
* cell instance $200023 r0 *1 811.2,396.9
X$200023 VDD VSS sg13g2_decap_8
* cell instance $200024 r0 *1 732.96,389.34
X$200024 VDD VSS sg13g2_decap_8
* cell instance $200025 r0 *1 739.68,374.22
X$200025 VDD VSS sg13g2_decap_8
* cell instance $200026 r0 *1 716.16,389.34
X$200026 VDD VSS sg13g2_decap_8
* cell instance $200027 r0 *1 732.96,374.22
X$200027 VDD VSS sg13g2_decap_8
* cell instance $200028 r0 *1 716.16,381.78
X$200028 VDD VSS sg13g2_decap_8
* cell instance $200029 r0 *1 793.44,374.22
X$200029 VDD VSS sg13g2_decap_8
* cell instance $200030 r0 *1 793.44,389.34
X$200030 VDD VSS sg13g2_decap_8
* cell instance $200031 r0 *1 793.44,381.78
X$200031 VDD VSS sg13g2_decap_8
* cell instance $200032 r0 *1 814.56,412.02
X$200032 VDD VSS sg13g2_decap_8
* cell instance $200033 r0 *1 791.04,419.58
X$200033 VDD VSS sg13g2_decap_8
* cell instance $200034 r0 *1 790.08,374.22
X$200034 VDD VSS sg13g2_decap_8
* cell instance $200035 r0 *1 790.08,381.78
X$200035 VDD VSS sg13g2_decap_8
* cell instance $200036 r0 *1 790.08,389.34
X$200036 VDD VSS sg13g2_decap_8
* cell instance $200037 r0 *1 790.08,366.66
X$200037 VDD VSS sg13g2_decap_8
* cell instance $200038 r0 *1 791.04,396.9
X$200038 VDD VSS sg13g2_decap_8
* cell instance $200039 r0 *1 791.04,404.46
X$200039 VDD VSS sg13g2_decap_8
* cell instance $200040 r0 *1 791.04,412.02
X$200040 VDD VSS sg13g2_decap_8
* cell instance $200041 r0 *1 807.84,412.02
X$200041 VDD VSS sg13g2_decap_8
* cell instance $200042 r0 *1 793.44,366.66
X$200042 VDD VSS sg13g2_decap_8
* cell instance $200043 r0 *1 891.84,404.46
X$200043 VDD VSS sg13g2_decap_8
* cell instance $200044 r0 *1 901.92,412.02
X$200044 VDD VSS sg13g2_decap_8
* cell instance $200045 r0 *1 898.56,412.02
X$200045 VDD VSS sg13g2_decap_8
* cell instance $200046 r0 *1 888.48,412.02
X$200046 VDD VSS sg13g2_decap_8
* cell instance $200047 r0 *1 891.84,412.02
X$200047 VDD VSS sg13g2_decap_8
* cell instance $200048 r0 *1 895.2,412.02
X$200048 VDD VSS sg13g2_decap_8
* cell instance $200049 r0 *1 881.76,412.02
X$200049 VDD VSS sg13g2_decap_8
* cell instance $200050 r0 *1 875.04,412.02
X$200050 VDD VSS sg13g2_decap_8
* cell instance $200051 r0 *1 773.28,381.78
X$200051 VDD VSS sg13g2_decap_8
* cell instance $200052 r0 *1 901.92,419.58
X$200052 VDD VSS sg13g2_decap_8
* cell instance $200053 r0 *1 895.2,419.58
X$200053 VDD VSS sg13g2_decap_8
* cell instance $200054 r0 *1 905.28,419.58
X$200054 VDD VSS sg13g2_decap_8
* cell instance $200055 r0 *1 898.56,419.58
X$200055 VDD VSS sg13g2_decap_8
* cell instance $200056 r0 *1 885.12,419.58
X$200056 VDD VSS sg13g2_decap_8
* cell instance $200057 r0 *1 888.48,419.58
X$200057 VDD VSS sg13g2_decap_8
* cell instance $200058 r0 *1 881.76,419.58
X$200058 VDD VSS sg13g2_decap_8
* cell instance $200059 r0 *1 875.04,419.58
X$200059 VDD VSS sg13g2_decap_8
* cell instance $200060 r0 *1 908.64,419.58
X$200060 VDD VSS sg13g2_decap_8
* cell instance $200061 r0 *1 911.04,389.34
X$200061 VDD VSS sg13g2_decap_8
* cell instance $200062 r0 *1 911.04,381.78
X$200062 VDD VSS sg13g2_decap_8
* cell instance $200063 r0 *1 911.04,366.66
X$200063 VDD VSS sg13g2_decap_8
* cell instance $200064 r0 *1 911.04,374.22
X$200064 VDD VSS sg13g2_decap_8
* cell instance $200065 r0 *1 912,419.58
X$200065 VDD VSS sg13g2_decap_8
* cell instance $200066 r0 *1 871.68,396.9
X$200066 VDD VSS sg13g2_decap_8
* cell instance $200067 r0 *1 871.68,404.46
X$200067 VDD VSS sg13g2_decap_8
* cell instance $200068 r0 *1 871.68,412.02
X$200068 VDD VSS sg13g2_decap_8
* cell instance $200069 r0 *1 908.64,412.02
X$200069 VDD VSS sg13g2_decap_8
* cell instance $200070 r0 *1 870.72,389.34
X$200070 VDD VSS sg13g2_decap_8
* cell instance $200071 r0 *1 870.72,366.66
X$200071 VDD VSS sg13g2_decap_8
* cell instance $200072 r0 *1 870.72,374.22
X$200072 VDD VSS sg13g2_decap_8
* cell instance $200073 r0 *1 871.68,419.58
X$200073 VDD VSS sg13g2_decap_8
* cell instance $200074 r0 *1 878.4,412.02
X$200074 VDD VSS sg13g2_decap_8
* cell instance $200075 r0 *1 885.12,412.02
X$200075 VDD VSS sg13g2_decap_8
* cell instance $200076 r0 *1 905.28,412.02
X$200076 VDD VSS sg13g2_decap_8
* cell instance $200077 r0 *1 891.84,396.9
X$200077 VDD VSS sg13g2_decap_8
* cell instance $200078 r0 *1 891.84,419.58
X$200078 VDD VSS sg13g2_decap_8
* cell instance $200079 r0 *1 870.72,381.78
X$200079 VDD VSS sg13g2_decap_8
* cell instance $200080 r0 *1 898.56,404.46
X$200080 VDD VSS sg13g2_decap_8
* cell instance $200081 r0 *1 851.52,419.58
X$200081 VDD VSS sg13g2_decap_8
* cell instance $200082 r0 *1 841.44,412.02
X$200082 VDD VSS sg13g2_decap_8
* cell instance $200083 r0 *1 851.52,396.9
X$200083 VDD VSS sg13g2_decap_8
* cell instance $200084 r0 *1 861.6,412.02
X$200084 VDD VSS sg13g2_decap_8
* cell instance $200085 r0 *1 864.96,412.02
X$200085 VDD VSS sg13g2_decap_8
* cell instance $200086 r0 *1 868.32,412.02
X$200086 VDD VSS sg13g2_decap_8
* cell instance $200087 r0 *1 834.72,412.02
X$200087 VDD VSS sg13g2_decap_8
* cell instance $200088 r0 *1 878.4,419.58
X$200088 VDD VSS sg13g2_decap_8
* cell instance $200089 r0 *1 844.8,412.02
X$200089 VDD VSS sg13g2_decap_8
* cell instance $200090 r0 *1 851.52,404.46
X$200090 VDD VSS sg13g2_decap_8
* cell instance $200091 r0 *1 858.24,412.02
X$200091 VDD VSS sg13g2_decap_8
* cell instance $200092 r0 *1 848.16,412.02
X$200092 VDD VSS sg13g2_decap_8
* cell instance $200093 r0 *1 851.52,412.02
X$200093 VDD VSS sg13g2_decap_8
* cell instance $200094 r0 *1 854.88,412.02
X$200094 VDD VSS sg13g2_decap_8
* cell instance $200095 r0 *1 868.32,419.58
X$200095 VDD VSS sg13g2_decap_8
* cell instance $200096 r0 *1 864.96,419.58
X$200096 VDD VSS sg13g2_decap_8
* cell instance $200097 r0 *1 838.08,412.02
X$200097 VDD VSS sg13g2_decap_8
* cell instance $200098 r0 *1 881.76,404.46
X$200098 VDD VSS sg13g2_decap_8
* cell instance $200099 r0 *1 888.48,396.9
X$200099 VDD VSS sg13g2_decap_8
* cell instance $200100 r0 *1 881.76,396.9
X$200100 VDD VSS sg13g2_decap_8
* cell instance $200101 r0 *1 878.4,396.9
X$200101 VDD VSS sg13g2_decap_8
* cell instance $200102 r0 *1 875.04,396.9
X$200102 VDD VSS sg13g2_decap_8
* cell instance $200103 r0 *1 888.48,404.46
X$200103 VDD VSS sg13g2_decap_8
* cell instance $200104 r0 *1 878.4,404.46
X$200104 VDD VSS sg13g2_decap_8
* cell instance $200105 r0 *1 875.04,404.46
X$200105 VDD VSS sg13g2_decap_8
* cell instance $200106 r0 *1 895.2,404.46
X$200106 VDD VSS sg13g2_decap_8
* cell instance $200107 r0 *1 885.12,404.46
X$200107 VDD VSS sg13g2_decap_8
* cell instance $200108 r0 *1 895.2,396.9
X$200108 VDD VSS sg13g2_decap_8
* cell instance $200109 r0 *1 908.64,396.9
X$200109 VDD VSS sg13g2_decap_8
* cell instance $200110 r0 *1 905.28,396.9
X$200110 VDD VSS sg13g2_decap_8
* cell instance $200111 r0 *1 901.92,404.46
X$200111 VDD VSS sg13g2_decap_8
* cell instance $200112 r0 *1 901.92,396.9
X$200112 VDD VSS sg13g2_decap_8
* cell instance $200113 r0 *1 898.56,396.9
X$200113 VDD VSS sg13g2_decap_8
* cell instance $200114 r0 *1 905.28,404.46
X$200114 VDD VSS sg13g2_decap_8
* cell instance $200115 r0 *1 908.64,404.46
X$200115 VDD VSS sg13g2_decap_8
* cell instance $200116 r0 *1 885.12,396.9
X$200116 VDD VSS sg13g2_decap_8
* cell instance $200117 r0 *1 763.2,389.34
X$200117 VDD VSS sg13g2_decap_8
* cell instance $200118 r0 *1 759.84,381.78
X$200118 VDD VSS sg13g2_decap_8
* cell instance $200119 r0 *1 763.2,381.78
X$200119 VDD VSS sg13g2_decap_8
* cell instance $200120 r0 *1 766.56,366.66
X$200120 VDD VSS sg13g2_decap_8
* cell instance $200121 r0 *1 769.92,366.66
X$200121 VDD VSS sg13g2_decap_8
* cell instance $200122 r0 *1 763.2,366.66
X$200122 VDD VSS sg13g2_decap_8
* cell instance $200123 r0 *1 756.48,366.66
X$200123 VDD VSS sg13g2_decap_8
* cell instance $200124 r0 *1 759.84,366.66
X$200124 VDD VSS sg13g2_decap_8
* cell instance $200125 r0 *1 912,404.46
X$200125 VDD VSS sg13g2_decap_8
* cell instance $200126 r0 *1 776.64,366.66
X$200126 VDD VSS sg13g2_decap_8
* cell instance $200127 r0 *1 783.36,366.66
X$200127 VDD VSS sg13g2_decap_8
* cell instance $200128 r0 *1 786.72,366.66
X$200128 VDD VSS sg13g2_decap_8
* cell instance $200129 r0 *1 827.04,374.22
X$200129 VDD VSS sg13g2_decap_8
* cell instance $200130 r0 *1 810.24,366.66
X$200130 VDD VSS sg13g2_decap_8
* cell instance $200131 r0 *1 820.32,374.22
X$200131 VDD VSS sg13g2_decap_8
* cell instance $200132 r0 *1 816.96,374.22
X$200132 VDD VSS sg13g2_decap_8
* cell instance $200133 r0 *1 803.52,374.22
X$200133 VDD VSS sg13g2_decap_8
* cell instance $200134 r0 *1 780,366.66
X$200134 VDD VSS sg13g2_decap_8
* cell instance $200135 r0 *1 773.28,389.34
X$200135 VDD VSS sg13g2_decap_8
* cell instance $200136 r0 *1 773.28,366.66
X$200136 VDD VSS sg13g2_decap_8
* cell instance $200137 r0 *1 766.56,374.22
X$200137 VDD VSS sg13g2_decap_8
* cell instance $200138 r0 *1 756.48,374.22
X$200138 VDD VSS sg13g2_decap_8
* cell instance $200139 r0 *1 786.72,381.78
X$200139 VDD VSS sg13g2_decap_8
* cell instance $200140 r0 *1 776.64,389.34
X$200140 VDD VSS sg13g2_decap_8
* cell instance $200141 r0 *1 780,389.34
X$200141 VDD VSS sg13g2_decap_8
* cell instance $200142 r0 *1 776.64,381.78
X$200142 VDD VSS sg13g2_decap_8
* cell instance $200143 r0 *1 766.56,389.34
X$200143 VDD VSS sg13g2_decap_8
* cell instance $200144 r0 *1 786.72,389.34
X$200144 VDD VSS sg13g2_decap_8
* cell instance $200145 r0 *1 783.36,381.78
X$200145 VDD VSS sg13g2_decap_8
* cell instance $200146 r0 *1 780,381.78
X$200146 VDD VSS sg13g2_decap_8
* cell instance $200147 r0 *1 756.48,389.34
X$200147 VDD VSS sg13g2_decap_8
* cell instance $200148 r0 *1 756.48,381.78
X$200148 VDD VSS sg13g2_decap_8
* cell instance $200149 r0 *1 759.84,389.34
X$200149 VDD VSS sg13g2_decap_8
* cell instance $200150 r0 *1 769.92,381.78
X$200150 VDD VSS sg13g2_decap_8
* cell instance $200151 r0 *1 769.92,389.34
X$200151 VDD VSS sg13g2_decap_8
* cell instance $200152 r0 *1 766.56,381.78
X$200152 VDD VSS sg13g2_decap_8
* cell instance $200153 r0 *1 783.36,389.34
X$200153 VDD VSS sg13g2_decap_8
* cell instance $200154 r0 *1 800.16,389.34
X$200154 VDD VSS sg13g2_decap_8
* cell instance $200155 r0 *1 803.52,389.34
X$200155 VDD VSS sg13g2_decap_8
* cell instance $200156 r0 *1 803.52,381.78
X$200156 VDD VSS sg13g2_decap_8
* cell instance $200157 r0 *1 806.88,381.78
X$200157 VDD VSS sg13g2_decap_8
* cell instance $200158 r0 *1 806.88,389.34
X$200158 VDD VSS sg13g2_decap_8
* cell instance $200159 r0 *1 800.16,381.78
X$200159 VDD VSS sg13g2_decap_8
* cell instance $200160 r0 *1 796.8,381.78
X$200160 VDD VSS sg13g2_decap_8
* cell instance $200161 r0 *1 800.16,366.66
X$200161 VDD VSS sg13g2_decap_8
* cell instance $200162 r0 *1 813.6,374.22
X$200162 VDD VSS sg13g2_decap_8
* cell instance $200163 r0 *1 803.52,366.66
X$200163 VDD VSS sg13g2_decap_8
* cell instance $200164 r0 *1 806.88,366.66
X$200164 VDD VSS sg13g2_decap_8
* cell instance $200165 r0 *1 823.68,366.66
X$200165 VDD VSS sg13g2_decap_8
* cell instance $200166 r0 *1 827.04,366.66
X$200166 VDD VSS sg13g2_decap_8
* cell instance $200167 r0 *1 820.32,366.66
X$200167 VDD VSS sg13g2_decap_8
* cell instance $200168 r0 *1 816.96,366.66
X$200168 VDD VSS sg13g2_decap_8
* cell instance $200169 r0 *1 912,396.9
X$200169 VDD VSS sg13g2_decap_8
* cell instance $200170 r0 *1 912,412.02
X$200170 VDD VSS sg13g2_decap_8
* cell instance $200171 r0 *1 796.8,366.66
X$200171 VDD VSS sg13g2_decap_8
* cell instance $200172 r0 *1 823.68,374.22
X$200172 VDD VSS sg13g2_decap_8
* cell instance $200173 r0 *1 810.24,374.22
X$200173 VDD VSS sg13g2_decap_8
* cell instance $200174 r0 *1 813.6,381.78
X$200174 VDD VSS sg13g2_decap_8
* cell instance $200175 r0 *1 813.6,389.34
X$200175 VDD VSS sg13g2_decap_8
* cell instance $200176 r0 *1 813.6,366.66
X$200176 VDD VSS sg13g2_decap_8
* cell instance $200177 r0 *1 810.24,389.34
X$200177 VDD VSS sg13g2_decap_8
* cell instance $200178 r0 *1 810.24,381.78
X$200178 VDD VSS sg13g2_decap_8
* cell instance $200179 r0 *1 796.8,374.22
X$200179 VDD VSS sg13g2_decap_8
* cell instance $200180 r0 *1 796.8,389.34
X$200180 VDD VSS sg13g2_decap_8
* cell instance $200181 r0 *1 806.88,374.22
X$200181 VDD VSS sg13g2_decap_8
* cell instance $200182 r0 *1 823.68,389.34
X$200182 VDD VSS sg13g2_decap_8
* cell instance $200183 r0 *1 816.96,381.78
X$200183 VDD VSS sg13g2_decap_8
* cell instance $200184 r0 *1 820.32,389.34
X$200184 VDD VSS sg13g2_decap_8
* cell instance $200185 r0 *1 823.68,381.78
X$200185 VDD VSS sg13g2_decap_8
* cell instance $200186 r0 *1 827.04,381.78
X$200186 VDD VSS sg13g2_decap_8
* cell instance $200187 r0 *1 820.32,381.78
X$200187 VDD VSS sg13g2_decap_8
* cell instance $200188 r0 *1 827.04,389.34
X$200188 VDD VSS sg13g2_decap_8
* cell instance $200189 r0 *1 816.96,389.34
X$200189 VDD VSS sg13g2_decap_8
* cell instance $200190 r0 *1 800.16,374.22
X$200190 VDD VSS sg13g2_decap_8
* cell instance $200191 r0 *1 408,782.46
X$200191 VDD VSS sg13g2_decap_8
* cell instance $200192 r0 *1 431.52,782.46
X$200192 VDD VSS sg13g2_decap_8
* cell instance $200193 r0 *1 759.36,941.22
X$200193 VDD VSS sg13g2_decap_8
* cell instance $200194 r0 *1 786.24,941.22
X$200194 VDD VSS sg13g2_decap_8
* cell instance $200195 r0 *1 421.44,782.46
X$200195 VDD VSS sg13g2_decap_8
* cell instance $200196 r0 *1 789.6,933.66
X$200196 VDD VSS sg13g2_decap_8
* cell instance $200197 r0 *1 428.16,782.46
X$200197 VDD VSS sg13g2_decap_8
* cell instance $200198 r0 *1 789.6,941.22
X$200198 VDD VSS sg13g2_decap_8
* cell instance $200199 r0 *1 779.52,941.22
X$200199 VDD VSS sg13g2_decap_8
* cell instance $200200 r0 *1 779.52,933.66
X$200200 VDD VSS sg13g2_decap_8
* cell instance $200201 r0 *1 786.24,933.66
X$200201 VDD VSS sg13g2_decap_8
* cell instance $200202 r0 *1 673.44,812.7
X$200202 VDD VSS sg13g2_decap_8
* cell instance $200203 r0 *1 776.16,933.66
X$200203 VDD VSS sg13g2_decap_8
* cell instance $200204 r0 *1 782.88,941.22
X$200204 VDD VSS sg13g2_decap_8
* cell instance $200205 r0 *1 782.88,933.66
X$200205 VDD VSS sg13g2_decap_8
* cell instance $200206 r0 *1 772.8,941.22
X$200206 VDD VSS sg13g2_decap_8
* cell instance $200207 r0 *1 397.92,782.46
X$200207 VDD VSS sg13g2_decap_8
* cell instance $200208 r0 *1 424.8,782.46
X$200208 VDD VSS sg13g2_decap_8
* cell instance $200209 r0 *1 414.72,782.46
X$200209 VDD VSS sg13g2_decap_8
* cell instance $200210 r0 *1 772.8,933.66
X$200210 VDD VSS sg13g2_decap_8
* cell instance $200211 r0 *1 592.8,782.46
X$200211 VDD VSS sg13g2_decap_8
* cell instance $200212 r0 *1 592.8,790.02
X$200212 VDD VSS sg13g2_decap_8
* cell instance $200213 r0 *1 592.8,797.58
X$200213 VDD VSS sg13g2_decap_8
* cell instance $200214 r0 *1 776.16,941.22
X$200214 VDD VSS sg13g2_decap_8
* cell instance $200215 r0 *1 414.72,797.58
X$200215 VDD VSS sg13g2_decap_8
* cell instance $200216 r0 *1 411.36,812.7
X$200216 VDD VSS sg13g2_decap_8
* cell instance $200217 r0 *1 418.08,805.14
X$200217 VDD VSS sg13g2_decap_8
* cell instance $200218 r0 *1 431.52,812.7
X$200218 VDD VSS sg13g2_decap_8
* cell instance $200219 r0 *1 769.44,933.66
X$200219 VDD VSS sg13g2_decap_8
* cell instance $200220 r0 *1 391.2,782.46
X$200220 VDD VSS sg13g2_decap_8
* cell instance $200221 r0 *1 762.72,933.66
X$200221 VDD VSS sg13g2_decap_8
* cell instance $200222 r0 *1 762.72,941.22
X$200222 VDD VSS sg13g2_decap_8
* cell instance $200223 r0 *1 381.12,782.46
X$200223 VDD VSS sg13g2_decap_8
* cell instance $200224 r0 *1 387.84,782.46
X$200224 VDD VSS sg13g2_decap_8
* cell instance $200225 r0 *1 384.48,782.46
X$200225 VDD VSS sg13g2_decap_8
* cell instance $200226 r0 *1 756,941.22
X$200226 VDD VSS sg13g2_decap_8
* cell instance $200227 r0 *1 364.32,782.46
X$200227 VDD VSS sg13g2_decap_8
* cell instance $200228 r0 *1 371.04,782.46
X$200228 VDD VSS sg13g2_decap_8
* cell instance $200229 r0 *1 374.4,782.46
X$200229 VDD VSS sg13g2_decap_8
* cell instance $200230 r0 *1 377.76,782.46
X$200230 VDD VSS sg13g2_decap_8
* cell instance $200231 r0 *1 756,933.66
X$200231 VDD VSS sg13g2_decap_8
* cell instance $200232 r0 *1 759.36,933.66
X$200232 VDD VSS sg13g2_decap_8
* cell instance $200233 r0 *1 367.68,782.46
X$200233 VDD VSS sg13g2_decap_8
* cell instance $200234 r0 *1 411.36,782.46
X$200234 VDD VSS sg13g2_decap_8
* cell instance $200235 r0 *1 401.28,782.46
X$200235 VDD VSS sg13g2_decap_8
* cell instance $200236 r0 *1 418.08,782.46
X$200236 VDD VSS sg13g2_decap_8
* cell instance $200237 r0 *1 404.64,782.46
X$200237 VDD VSS sg13g2_decap_8
* cell instance $200238 r0 *1 766.08,933.66
X$200238 VDD VSS sg13g2_decap_8
* cell instance $200239 r0 *1 666.72,790.02
X$200239 VDD VSS sg13g2_decap_8
* cell instance $200240 r0 *1 756,963.9
X$200240 VDD VSS sg13g2_decap_8
* cell instance $200241 r0 *1 762.72,963.9
X$200241 VDD VSS sg13g2_decap_8
* cell instance $200242 r0 *1 759.36,963.9
X$200242 VDD VSS sg13g2_decap_8
* cell instance $200243 r0 *1 660,790.02
X$200243 VDD VSS sg13g2_decap_8
* cell instance $200244 r0 *1 636.48,790.02
X$200244 VDD VSS sg13g2_decap_8
* cell instance $200245 r0 *1 643.2,790.02
X$200245 VDD VSS sg13g2_decap_8
* cell instance $200246 r0 *1 633.12,782.46
X$200246 VDD VSS sg13g2_decap_8
* cell instance $200247 r0 *1 633.12,820.26
X$200247 VDD VSS sg13g2_decap_8
* cell instance $200248 r0 *1 633.12,827.82
X$200248 VDD VSS sg13g2_decap_8
* cell instance $200249 r0 *1 629.76,790.02
X$200249 VDD VSS sg13g2_decap_8
* cell instance $200250 r0 *1 772.8,926.1
X$200250 VDD VSS sg13g2_decap_8
* cell instance $200251 r0 *1 769.44,956.34
X$200251 VDD VSS sg13g2_decap_8
* cell instance $200252 r0 *1 633.12,812.7
X$200252 VDD VSS sg13g2_decap_8
* cell instance $200253 r0 *1 762.72,956.34
X$200253 VDD VSS sg13g2_decap_8
* cell instance $200254 r0 *1 766.08,956.34
X$200254 VDD VSS sg13g2_decap_8
* cell instance $200255 r0 *1 759.36,956.34
X$200255 VDD VSS sg13g2_decap_8
* cell instance $200256 r0 *1 756,956.34
X$200256 VDD VSS sg13g2_decap_8
* cell instance $200257 r0 *1 633.12,797.58
X$200257 VDD VSS sg13g2_decap_8
* cell instance $200258 r0 *1 609.6,790.02
X$200258 VDD VSS sg13g2_decap_8
* cell instance $200259 r0 *1 612.96,790.02
X$200259 VDD VSS sg13g2_decap_8
* cell instance $200260 r0 *1 766.08,963.9
X$200260 VDD VSS sg13g2_decap_8
* cell instance $200261 r0 *1 769.44,963.9
X$200261 VDD VSS sg13g2_decap_8
* cell instance $200262 r0 *1 633.12,805.14
X$200262 VDD VSS sg13g2_decap_8
* cell instance $200263 r0 *1 592.8,820.26
X$200263 VDD VSS sg13g2_decap_8
* cell instance $200264 r0 *1 789.6,956.34
X$200264 VDD VSS sg13g2_decap_8
* cell instance $200265 r0 *1 789.6,963.9
X$200265 VDD VSS sg13g2_decap_8
* cell instance $200266 r0 *1 782.88,963.9
X$200266 VDD VSS sg13g2_decap_8
* cell instance $200267 r0 *1 786.24,963.9
X$200267 VDD VSS sg13g2_decap_8
* cell instance $200268 r0 *1 592.8,827.82
X$200268 VDD VSS sg13g2_decap_8
* cell instance $200269 r0 *1 779.52,963.9
X$200269 VDD VSS sg13g2_decap_8
* cell instance $200270 r0 *1 782.88,956.34
X$200270 VDD VSS sg13g2_decap_8
* cell instance $200271 r0 *1 779.52,956.34
X$200271 VDD VSS sg13g2_decap_8
* cell instance $200272 r0 *1 592.8,812.7
X$200272 VDD VSS sg13g2_decap_8
* cell instance $200273 r0 *1 592.8,805.14
X$200273 VDD VSS sg13g2_decap_8
* cell instance $200274 r0 *1 646.56,790.02
X$200274 VDD VSS sg13g2_decap_8
* cell instance $200275 r0 *1 596.16,790.02
X$200275 VDD VSS sg13g2_decap_8
* cell instance $200276 r0 *1 656.64,790.02
X$200276 VDD VSS sg13g2_decap_8
* cell instance $200277 r0 *1 776.16,963.9
X$200277 VDD VSS sg13g2_decap_8
* cell instance $200278 r0 *1 786.24,956.34
X$200278 VDD VSS sg13g2_decap_8
* cell instance $200279 r0 *1 776.16,956.34
X$200279 VDD VSS sg13g2_decap_8
* cell instance $200280 r0 *1 639.84,790.02
X$200280 VDD VSS sg13g2_decap_8
* cell instance $200281 r0 *1 663.36,790.02
X$200281 VDD VSS sg13g2_decap_8
* cell instance $200282 r0 *1 653.28,790.02
X$200282 VDD VSS sg13g2_decap_8
* cell instance $200283 r0 *1 633.12,790.02
X$200283 VDD VSS sg13g2_decap_8
* cell instance $200284 r0 *1 649.92,790.02
X$200284 VDD VSS sg13g2_decap_8
* cell instance $200285 r0 *1 670.08,790.02
X$200285 VDD VSS sg13g2_decap_8
* cell instance $200286 r0 *1 599.52,790.02
X$200286 VDD VSS sg13g2_decap_8
* cell instance $200287 r0 *1 806.4,926.1
X$200287 VDD VSS sg13g2_decap_8
* cell instance $200288 r0 *1 799.68,926.1
X$200288 VDD VSS sg13g2_decap_8
* cell instance $200289 r0 *1 803.04,926.1
X$200289 VDD VSS sg13g2_decap_8
* cell instance $200290 r0 *1 809.76,926.1
X$200290 VDD VSS sg13g2_decap_8
* cell instance $200291 r0 *1 796.32,926.1
X$200291 VDD VSS sg13g2_decap_8
* cell instance $200292 r0 *1 799.68,933.66
X$200292 VDD VSS sg13g2_decap_8
* cell instance $200293 r0 *1 806.4,933.66
X$200293 VDD VSS sg13g2_decap_8
* cell instance $200294 r0 *1 495.36,782.46
X$200294 VDD VSS sg13g2_decap_8
* cell instance $200295 r0 *1 796.32,941.22
X$200295 VDD VSS sg13g2_decap_8
* cell instance $200296 r0 *1 806.4,941.22
X$200296 VDD VSS sg13g2_decap_8
* cell instance $200297 r0 *1 803.04,941.22
X$200297 VDD VSS sg13g2_decap_8
* cell instance $200298 r0 *1 424.8,827.82
X$200298 VDD VSS sg13g2_decap_8
* cell instance $200299 r0 *1 809.76,933.66
X$200299 VDD VSS sg13g2_decap_8
* cell instance $200300 r0 *1 809.76,941.22
X$200300 VDD VSS sg13g2_decap_8
* cell instance $200301 r0 *1 796.32,933.66
X$200301 VDD VSS sg13g2_decap_8
* cell instance $200302 r0 *1 803.04,933.66
X$200302 VDD VSS sg13g2_decap_8
* cell instance $200303 r0 *1 799.68,941.22
X$200303 VDD VSS sg13g2_decap_8
* cell instance $200304 r0 *1 411.36,790.02
X$200304 VDD VSS sg13g2_decap_8
* cell instance $200305 r0 *1 431.52,790.02
X$200305 VDD VSS sg13g2_decap_8
* cell instance $200306 r0 *1 428.16,790.02
X$200306 VDD VSS sg13g2_decap_8
* cell instance $200307 r0 *1 421.44,790.02
X$200307 VDD VSS sg13g2_decap_8
* cell instance $200308 r0 *1 819.84,941.22
X$200308 VDD VSS sg13g2_decap_8
* cell instance $200309 r0 *1 424.8,790.02
X$200309 VDD VSS sg13g2_decap_8
* cell instance $200310 r0 *1 478.56,782.46
X$200310 VDD VSS sg13g2_decap_8
* cell instance $200311 r0 *1 455.04,782.46
X$200311 VDD VSS sg13g2_decap_8
* cell instance $200312 r0 *1 739.2,948.78
X$200312 VDD VSS sg13g2_decap_8
* cell instance $200313 r0 *1 749.28,948.78
X$200313 VDD VSS sg13g2_decap_8
* cell instance $200314 r0 *1 742.56,948.78
X$200314 VDD VSS sg13g2_decap_8
* cell instance $200315 r0 *1 745.92,948.78
X$200315 VDD VSS sg13g2_decap_8
* cell instance $200316 r0 *1 438.24,782.46
X$200316 VDD VSS sg13g2_decap_8
* cell instance $200317 r0 *1 508.8,782.46
X$200317 VDD VSS sg13g2_decap_8
* cell instance $200318 r0 *1 498.72,782.46
X$200318 VDD VSS sg13g2_decap_8
* cell instance $200319 r0 *1 823.2,933.66
X$200319 VDD VSS sg13g2_decap_8
* cell instance $200320 r0 *1 502.08,782.46
X$200320 VDD VSS sg13g2_decap_8
* cell instance $200321 r0 *1 813.12,933.66
X$200321 VDD VSS sg13g2_decap_8
* cell instance $200322 r0 *1 492,782.46
X$200322 VDD VSS sg13g2_decap_8
* cell instance $200323 r0 *1 826.56,933.66
X$200323 VDD VSS sg13g2_decap_8
* cell instance $200324 r0 *1 819.84,933.66
X$200324 VDD VSS sg13g2_decap_8
* cell instance $200325 r0 *1 485.28,782.46
X$200325 VDD VSS sg13g2_decap_8
* cell instance $200326 r0 *1 823.2,941.22
X$200326 VDD VSS sg13g2_decap_8
* cell instance $200327 r0 *1 505.44,782.46
X$200327 VDD VSS sg13g2_decap_8
* cell instance $200328 r0 *1 481.92,782.46
X$200328 VDD VSS sg13g2_decap_8
* cell instance $200329 r0 *1 816.48,926.1
X$200329 VDD VSS sg13g2_decap_8
* cell instance $200330 r0 *1 819.84,926.1
X$200330 VDD VSS sg13g2_decap_8
* cell instance $200331 r0 *1 488.64,782.46
X$200331 VDD VSS sg13g2_decap_8
* cell instance $200332 r0 *1 823.2,926.1
X$200332 VDD VSS sg13g2_decap_8
* cell instance $200333 r0 *1 826.56,926.1
X$200333 VDD VSS sg13g2_decap_8
* cell instance $200334 r0 *1 816.48,941.22
X$200334 VDD VSS sg13g2_decap_8
* cell instance $200335 r0 *1 762.72,926.1
X$200335 VDD VSS sg13g2_decap_8
* cell instance $200336 r0 *1 766.08,926.1
X$200336 VDD VSS sg13g2_decap_8
* cell instance $200337 r0 *1 418.08,812.7
X$200337 VDD VSS sg13g2_decap_8
* cell instance $200338 r0 *1 769.44,926.1
X$200338 VDD VSS sg13g2_decap_8
* cell instance $200339 r0 *1 414.72,812.7
X$200339 VDD VSS sg13g2_decap_8
* cell instance $200340 r0 *1 411.36,805.14
X$200340 VDD VSS sg13g2_decap_8
* cell instance $200341 r0 *1 431.52,820.26
X$200341 VDD VSS sg13g2_decap_8
* cell instance $200342 r0 *1 424.8,820.26
X$200342 VDD VSS sg13g2_decap_8
* cell instance $200343 r0 *1 428.16,820.26
X$200343 VDD VSS sg13g2_decap_8
* cell instance $200344 r0 *1 421.44,820.26
X$200344 VDD VSS sg13g2_decap_8
* cell instance $200345 r0 *1 424.8,805.14
X$200345 VDD VSS sg13g2_decap_8
* cell instance $200346 r0 *1 394.56,782.46
X$200346 VDD VSS sg13g2_decap_8
* cell instance $200347 r0 *1 431.52,827.82
X$200347 VDD VSS sg13g2_decap_8
* cell instance $200348 r0 *1 428.16,827.82
X$200348 VDD VSS sg13g2_decap_8
* cell instance $200349 r0 *1 411.36,827.82
X$200349 VDD VSS sg13g2_decap_8
* cell instance $200350 r0 *1 414.72,827.82
X$200350 VDD VSS sg13g2_decap_8
* cell instance $200351 r0 *1 411.36,797.58
X$200351 VDD VSS sg13g2_decap_8
* cell instance $200352 r0 *1 418.08,797.58
X$200352 VDD VSS sg13g2_decap_8
* cell instance $200353 r0 *1 414.72,820.26
X$200353 VDD VSS sg13g2_decap_8
* cell instance $200354 r0 *1 414.72,805.14
X$200354 VDD VSS sg13g2_decap_8
* cell instance $200355 r0 *1 424.8,812.7
X$200355 VDD VSS sg13g2_decap_8
* cell instance $200356 r0 *1 766.08,941.22
X$200356 VDD VSS sg13g2_decap_8
* cell instance $200357 r0 *1 769.44,941.22
X$200357 VDD VSS sg13g2_decap_8
* cell instance $200358 r0 *1 428.16,812.7
X$200358 VDD VSS sg13g2_decap_8
* cell instance $200359 r0 *1 418.08,790.02
X$200359 VDD VSS sg13g2_decap_8
* cell instance $200360 r0 *1 414.72,790.02
X$200360 VDD VSS sg13g2_decap_8
* cell instance $200361 r0 *1 816.48,933.66
X$200361 VDD VSS sg13g2_decap_8
* cell instance $200362 r0 *1 418.08,827.82
X$200362 VDD VSS sg13g2_decap_8
* cell instance $200363 r0 *1 813.12,926.1
X$200363 VDD VSS sg13g2_decap_8
* cell instance $200364 r0 *1 421.44,827.82
X$200364 VDD VSS sg13g2_decap_8
* cell instance $200365 r0 *1 826.56,941.22
X$200365 VDD VSS sg13g2_decap_8
* cell instance $200366 r0 *1 431.52,805.14
X$200366 VDD VSS sg13g2_decap_8
* cell instance $200367 r0 *1 424.8,797.58
X$200367 VDD VSS sg13g2_decap_8
* cell instance $200368 r0 *1 418.08,820.26
X$200368 VDD VSS sg13g2_decap_8
* cell instance $200369 r0 *1 421.44,797.58
X$200369 VDD VSS sg13g2_decap_8
* cell instance $200370 r0 *1 759.36,926.1
X$200370 VDD VSS sg13g2_decap_8
* cell instance $200371 r0 *1 428.16,805.14
X$200371 VDD VSS sg13g2_decap_8
* cell instance $200372 r0 *1 421.44,805.14
X$200372 VDD VSS sg13g2_decap_8
* cell instance $200373 r0 *1 789.6,926.1
X$200373 VDD VSS sg13g2_decap_8
* cell instance $200374 r0 *1 779.52,926.1
X$200374 VDD VSS sg13g2_decap_8
* cell instance $200375 r0 *1 782.88,926.1
X$200375 VDD VSS sg13g2_decap_8
* cell instance $200376 r0 *1 776.16,926.1
X$200376 VDD VSS sg13g2_decap_8
* cell instance $200377 r0 *1 786.24,926.1
X$200377 VDD VSS sg13g2_decap_8
* cell instance $200378 r0 *1 411.36,820.26
X$200378 VDD VSS sg13g2_decap_8
* cell instance $200379 r0 *1 421.44,812.7
X$200379 VDD VSS sg13g2_decap_8
* cell instance $200380 r0 *1 431.52,797.58
X$200380 VDD VSS sg13g2_decap_8
* cell instance $200381 r0 *1 756,926.1
X$200381 VDD VSS sg13g2_decap_8
* cell instance $200382 r0 *1 428.16,797.58
X$200382 VDD VSS sg13g2_decap_8
* cell instance $200383 r0 *1 813.12,941.22
X$200383 VDD VSS sg13g2_decap_8
* cell instance $200384 r0 *1 799.68,971.46
X$200384 VDD VSS sg13g2_decap_8
* cell instance $200385 r0 *1 796.32,971.46
X$200385 VDD VSS sg13g2_decap_8
* cell instance $200386 r0 *1 813.12,979.02
X$200386 VDD VSS sg13g2_decap_8
* cell instance $200387 r0 *1 623.04,812.7
X$200387 VDD VSS sg13g2_decap_8
* cell instance $200388 r0 *1 612.96,812.7
X$200388 VDD VSS sg13g2_decap_8
* cell instance $200389 r0 *1 619.68,812.7
X$200389 VDD VSS sg13g2_decap_8
* cell instance $200390 r0 *1 612.96,827.82
X$200390 VDD VSS sg13g2_decap_8
* cell instance $200391 r0 *1 629.76,812.7
X$200391 VDD VSS sg13g2_decap_8
* cell instance $200392 r0 *1 612.96,797.58
X$200392 VDD VSS sg13g2_decap_8
* cell instance $200393 r0 *1 612.96,820.26
X$200393 VDD VSS sg13g2_decap_8
* cell instance $200394 r0 *1 609.6,812.7
X$200394 VDD VSS sg13g2_decap_8
* cell instance $200395 r0 *1 616.32,790.02
X$200395 VDD VSS sg13g2_decap_8
* cell instance $200396 r0 *1 596.16,812.7
X$200396 VDD VSS sg13g2_decap_8
* cell instance $200397 r0 *1 599.52,812.7
X$200397 VDD VSS sg13g2_decap_8
* cell instance $200398 r0 *1 602.88,812.7
X$200398 VDD VSS sg13g2_decap_8
* cell instance $200399 r0 *1 616.32,812.7
X$200399 VDD VSS sg13g2_decap_8
* cell instance $200400 r0 *1 626.4,812.7
X$200400 VDD VSS sg13g2_decap_8
* cell instance $200401 r0 *1 612.96,805.14
X$200401 VDD VSS sg13g2_decap_8
* cell instance $200402 r0 *1 803.04,948.78
X$200402 VDD VSS sg13g2_decap_8
* cell instance $200403 r0 *1 796.32,948.78
X$200403 VDD VSS sg13g2_decap_8
* cell instance $200404 r0 *1 809.76,948.78
X$200404 VDD VSS sg13g2_decap_8
* cell instance $200405 r0 *1 806.4,948.78
X$200405 VDD VSS sg13g2_decap_8
* cell instance $200406 r0 *1 799.68,948.78
X$200406 VDD VSS sg13g2_decap_8
* cell instance $200407 r0 *1 606.24,812.7
X$200407 VDD VSS sg13g2_decap_8
* cell instance $200408 r0 *1 666.72,812.7
X$200408 VDD VSS sg13g2_decap_8
* cell instance $200409 r0 *1 663.36,812.7
X$200409 VDD VSS sg13g2_decap_8
* cell instance $200410 r0 *1 660,812.7
X$200410 VDD VSS sg13g2_decap_8
* cell instance $200411 r0 *1 656.64,812.7
X$200411 VDD VSS sg13g2_decap_8
* cell instance $200412 r0 *1 656.64,827.82
X$200412 VDD VSS sg13g2_decap_8
* cell instance $200413 r0 *1 826.56,979.02
X$200413 VDD VSS sg13g2_decap_8
* cell instance $200414 r0 *1 670.08,827.82
X$200414 VDD VSS sg13g2_decap_8
* cell instance $200415 r0 *1 656.64,820.26
X$200415 VDD VSS sg13g2_decap_8
* cell instance $200416 r0 *1 663.36,820.26
X$200416 VDD VSS sg13g2_decap_8
* cell instance $200417 r0 *1 670.08,820.26
X$200417 VDD VSS sg13g2_decap_8
* cell instance $200418 r0 *1 666.72,820.26
X$200418 VDD VSS sg13g2_decap_8
* cell instance $200419 r0 *1 809.76,971.46
X$200419 VDD VSS sg13g2_decap_8
* cell instance $200420 r0 *1 660,820.26
X$200420 VDD VSS sg13g2_decap_8
* cell instance $200421 r0 *1 823.2,979.02
X$200421 VDD VSS sg13g2_decap_8
* cell instance $200422 r0 *1 813.12,963.9
X$200422 VDD VSS sg13g2_decap_8
* cell instance $200423 r0 *1 813.12,956.34
X$200423 VDD VSS sg13g2_decap_8
* cell instance $200424 r0 *1 813.12,971.46
X$200424 VDD VSS sg13g2_decap_8
* cell instance $200425 r0 *1 819.84,971.46
X$200425 VDD VSS sg13g2_decap_8
* cell instance $200426 r0 *1 803.04,971.46
X$200426 VDD VSS sg13g2_decap_8
* cell instance $200427 r0 *1 826.56,971.46
X$200427 VDD VSS sg13g2_decap_8
* cell instance $200428 r0 *1 823.2,971.46
X$200428 VDD VSS sg13g2_decap_8
* cell instance $200429 r0 *1 816.48,971.46
X$200429 VDD VSS sg13g2_decap_8
* cell instance $200430 r0 *1 806.4,971.46
X$200430 VDD VSS sg13g2_decap_8
* cell instance $200431 r0 *1 816.48,979.02
X$200431 VDD VSS sg13g2_decap_8
* cell instance $200432 r0 *1 616.32,827.82
X$200432 VDD VSS sg13g2_decap_8
* cell instance $200433 r0 *1 616.32,820.26
X$200433 VDD VSS sg13g2_decap_8
* cell instance $200434 r0 *1 792.96,948.78
X$200434 VDD VSS sg13g2_decap_8
* cell instance $200435 r0 *1 792.96,971.46
X$200435 VDD VSS sg13g2_decap_8
* cell instance $200436 r0 *1 792.96,979.02
X$200436 VDD VSS sg13g2_decap_8
* cell instance $200437 r0 *1 619.68,820.26
X$200437 VDD VSS sg13g2_decap_8
* cell instance $200438 r0 *1 626.4,820.26
X$200438 VDD VSS sg13g2_decap_8
* cell instance $200439 r0 *1 623.04,820.26
X$200439 VDD VSS sg13g2_decap_8
* cell instance $200440 r0 *1 606.24,827.82
X$200440 VDD VSS sg13g2_decap_8
* cell instance $200441 r0 *1 602.88,827.82
X$200441 VDD VSS sg13g2_decap_8
* cell instance $200442 r0 *1 596.16,820.26
X$200442 VDD VSS sg13g2_decap_8
* cell instance $200443 r0 *1 823.2,948.78
X$200443 VDD VSS sg13g2_decap_8
* cell instance $200444 r0 *1 606.24,820.26
X$200444 VDD VSS sg13g2_decap_8
* cell instance $200445 r0 *1 609.6,820.26
X$200445 VDD VSS sg13g2_decap_8
* cell instance $200446 r0 *1 599.52,827.82
X$200446 VDD VSS sg13g2_decap_8
* cell instance $200447 r0 *1 752.64,933.66
X$200447 VDD VSS sg13g2_decap_8
* cell instance $200448 r0 *1 602.88,820.26
X$200448 VDD VSS sg13g2_decap_8
* cell instance $200449 r0 *1 609.6,827.82
X$200449 VDD VSS sg13g2_decap_8
* cell instance $200450 r0 *1 596.16,827.82
X$200450 VDD VSS sg13g2_decap_8
* cell instance $200451 r0 *1 752.64,963.9
X$200451 VDD VSS sg13g2_decap_8
* cell instance $200452 r0 *1 752.64,956.34
X$200452 VDD VSS sg13g2_decap_8
* cell instance $200453 r0 *1 609.6,797.58
X$200453 VDD VSS sg13g2_decap_8
* cell instance $200454 r0 *1 606.24,805.14
X$200454 VDD VSS sg13g2_decap_8
* cell instance $200455 r0 *1 599.52,820.26
X$200455 VDD VSS sg13g2_decap_8
* cell instance $200456 r0 *1 826.56,948.78
X$200456 VDD VSS sg13g2_decap_8
* cell instance $200457 r0 *1 819.84,948.78
X$200457 VDD VSS sg13g2_decap_8
* cell instance $200458 r0 *1 816.48,948.78
X$200458 VDD VSS sg13g2_decap_8
* cell instance $200459 r0 *1 629.76,820.26
X$200459 VDD VSS sg13g2_decap_8
* cell instance $200460 r0 *1 629.76,827.82
X$200460 VDD VSS sg13g2_decap_8
* cell instance $200461 r0 *1 813.12,948.78
X$200461 VDD VSS sg13g2_decap_8
* cell instance $200462 r0 *1 762.72,948.78
X$200462 VDD VSS sg13g2_decap_8
* cell instance $200463 r0 *1 759.36,948.78
X$200463 VDD VSS sg13g2_decap_8
* cell instance $200464 r0 *1 756,948.78
X$200464 VDD VSS sg13g2_decap_8
* cell instance $200465 r0 *1 766.08,948.78
X$200465 VDD VSS sg13g2_decap_8
* cell instance $200466 r0 *1 769.44,948.78
X$200466 VDD VSS sg13g2_decap_8
* cell instance $200467 r0 *1 792.96,963.9
X$200467 VDD VSS sg13g2_decap_8
* cell instance $200468 r0 *1 779.52,948.78
X$200468 VDD VSS sg13g2_decap_8
* cell instance $200469 r0 *1 789.6,948.78
X$200469 VDD VSS sg13g2_decap_8
* cell instance $200470 r0 *1 786.24,948.78
X$200470 VDD VSS sg13g2_decap_8
* cell instance $200471 r0 *1 782.88,948.78
X$200471 VDD VSS sg13g2_decap_8
* cell instance $200472 r0 *1 772.8,948.78
X$200472 VDD VSS sg13g2_decap_8
* cell instance $200473 r0 *1 792.96,926.1
X$200473 VDD VSS sg13g2_decap_8
* cell instance $200474 r0 *1 623.04,827.82
X$200474 VDD VSS sg13g2_decap_8
* cell instance $200475 r0 *1 619.68,827.82
X$200475 VDD VSS sg13g2_decap_8
* cell instance $200476 r0 *1 792.96,941.22
X$200476 VDD VSS sg13g2_decap_8
* cell instance $200477 r0 *1 792.96,933.66
X$200477 VDD VSS sg13g2_decap_8
* cell instance $200478 r0 *1 792.96,956.34
X$200478 VDD VSS sg13g2_decap_8
* cell instance $200479 r0 *1 626.4,827.82
X$200479 VDD VSS sg13g2_decap_8
* cell instance $200480 r0 *1 776.16,948.78
X$200480 VDD VSS sg13g2_decap_8
* cell instance $200481 r0 *1 636.48,805.14
X$200481 VDD VSS sg13g2_decap_8
* cell instance $200482 r0 *1 646.56,797.58
X$200482 VDD VSS sg13g2_decap_8
* cell instance $200483 r0 *1 786.24,979.02
X$200483 VDD VSS sg13g2_decap_8
* cell instance $200484 r0 *1 789.6,979.02
X$200484 VDD VSS sg13g2_decap_8
* cell instance $200485 r0 *1 643.2,797.58
X$200485 VDD VSS sg13g2_decap_8
* cell instance $200486 r0 *1 782.88,979.02
X$200486 VDD VSS sg13g2_decap_8
* cell instance $200487 r0 *1 776.16,979.02
X$200487 VDD VSS sg13g2_decap_8
* cell instance $200488 r0 *1 779.52,979.02
X$200488 VDD VSS sg13g2_decap_8
* cell instance $200489 r0 *1 646.56,805.14
X$200489 VDD VSS sg13g2_decap_8
* cell instance $200490 r0 *1 772.8,963.9
X$200490 VDD VSS sg13g2_decap_8
* cell instance $200491 r0 *1 643.2,805.14
X$200491 VDD VSS sg13g2_decap_8
* cell instance $200492 r0 *1 670.08,812.7
X$200492 VDD VSS sg13g2_decap_8
* cell instance $200493 r0 *1 772.8,956.34
X$200493 VDD VSS sg13g2_decap_8
* cell instance $200494 r0 *1 636.48,797.58
X$200494 VDD VSS sg13g2_decap_8
* cell instance $200495 r0 *1 766.08,971.46
X$200495 VDD VSS sg13g2_decap_8
* cell instance $200496 r0 *1 772.8,971.46
X$200496 VDD VSS sg13g2_decap_8
* cell instance $200497 r0 *1 776.16,971.46
X$200497 VDD VSS sg13g2_decap_8
* cell instance $200498 r0 *1 756,971.46
X$200498 VDD VSS sg13g2_decap_8
* cell instance $200499 r0 *1 759.36,971.46
X$200499 VDD VSS sg13g2_decap_8
* cell instance $200500 r0 *1 762.72,971.46
X$200500 VDD VSS sg13g2_decap_8
* cell instance $200501 r0 *1 789.6,971.46
X$200501 VDD VSS sg13g2_decap_8
* cell instance $200502 r0 *1 786.24,971.46
X$200502 VDD VSS sg13g2_decap_8
* cell instance $200503 r0 *1 769.44,971.46
X$200503 VDD VSS sg13g2_decap_8
* cell instance $200504 r0 *1 639.84,797.58
X$200504 VDD VSS sg13g2_decap_8
* cell instance $200505 r0 *1 626.4,790.02
X$200505 VDD VSS sg13g2_decap_8
* cell instance $200506 r0 *1 619.68,790.02
X$200506 VDD VSS sg13g2_decap_8
* cell instance $200507 r0 *1 623.04,790.02
X$200507 VDD VSS sg13g2_decap_8
* cell instance $200508 r0 *1 606.24,790.02
X$200508 VDD VSS sg13g2_decap_8
* cell instance $200509 r0 *1 602.88,790.02
X$200509 VDD VSS sg13g2_decap_8
* cell instance $200510 r0 *1 666.72,827.82
X$200510 VDD VSS sg13g2_decap_8
* cell instance $200511 r0 *1 759.36,979.02
X$200511 VDD VSS sg13g2_decap_8
* cell instance $200512 r0 *1 663.36,827.82
X$200512 VDD VSS sg13g2_decap_8
* cell instance $200513 r0 *1 756,979.02
X$200513 VDD VSS sg13g2_decap_8
* cell instance $200514 r0 *1 660,827.82
X$200514 VDD VSS sg13g2_decap_8
* cell instance $200515 r0 *1 639.84,820.26
X$200515 VDD VSS sg13g2_decap_8
* cell instance $200516 r0 *1 649.92,797.58
X$200516 VDD VSS sg13g2_decap_8
* cell instance $200517 r0 *1 649.92,820.26
X$200517 VDD VSS sg13g2_decap_8
* cell instance $200518 r0 *1 646.56,820.26
X$200518 VDD VSS sg13g2_decap_8
* cell instance $200519 r0 *1 762.72,979.02
X$200519 VDD VSS sg13g2_decap_8
* cell instance $200520 r0 *1 766.08,979.02
X$200520 VDD VSS sg13g2_decap_8
* cell instance $200521 r0 *1 769.44,979.02
X$200521 VDD VSS sg13g2_decap_8
* cell instance $200522 r0 *1 649.92,827.82
X$200522 VDD VSS sg13g2_decap_8
* cell instance $200523 r0 *1 643.2,820.26
X$200523 VDD VSS sg13g2_decap_8
* cell instance $200524 r0 *1 643.2,827.82
X$200524 VDD VSS sg13g2_decap_8
* cell instance $200525 r0 *1 639.84,827.82
X$200525 VDD VSS sg13g2_decap_8
* cell instance $200526 r0 *1 636.48,827.82
X$200526 VDD VSS sg13g2_decap_8
* cell instance $200527 r0 *1 646.56,827.82
X$200527 VDD VSS sg13g2_decap_8
* cell instance $200528 r0 *1 636.48,820.26
X$200528 VDD VSS sg13g2_decap_8
* cell instance $200529 r0 *1 809.76,956.34
X$200529 VDD VSS sg13g2_decap_8
* cell instance $200530 r0 *1 660,797.58
X$200530 VDD VSS sg13g2_decap_8
* cell instance $200531 r0 *1 809.76,963.9
X$200531 VDD VSS sg13g2_decap_8
* cell instance $200532 r0 *1 663.36,797.58
X$200532 VDD VSS sg13g2_decap_8
* cell instance $200533 r0 *1 803.04,963.9
X$200533 VDD VSS sg13g2_decap_8
* cell instance $200534 r0 *1 796.32,963.9
X$200534 VDD VSS sg13g2_decap_8
* cell instance $200535 r0 *1 806.4,963.9
X$200535 VDD VSS sg13g2_decap_8
* cell instance $200536 r0 *1 803.04,956.34
X$200536 VDD VSS sg13g2_decap_8
* cell instance $200537 r0 *1 796.32,956.34
X$200537 VDD VSS sg13g2_decap_8
* cell instance $200538 r0 *1 806.4,956.34
X$200538 VDD VSS sg13g2_decap_8
* cell instance $200539 r0 *1 799.68,963.9
X$200539 VDD VSS sg13g2_decap_8
* cell instance $200540 r0 *1 772.8,979.02
X$200540 VDD VSS sg13g2_decap_8
* cell instance $200541 r0 *1 670.08,797.58
X$200541 VDD VSS sg13g2_decap_8
* cell instance $200542 r0 *1 636.48,812.7
X$200542 VDD VSS sg13g2_decap_8
* cell instance $200543 r0 *1 796.32,979.02
X$200543 VDD VSS sg13g2_decap_8
* cell instance $200544 r0 *1 803.04,979.02
X$200544 VDD VSS sg13g2_decap_8
* cell instance $200545 r0 *1 809.76,979.02
X$200545 VDD VSS sg13g2_decap_8
* cell instance $200546 r0 *1 643.2,812.7
X$200546 VDD VSS sg13g2_decap_8
* cell instance $200547 r0 *1 806.4,979.02
X$200547 VDD VSS sg13g2_decap_8
* cell instance $200548 r0 *1 799.68,979.02
X$200548 VDD VSS sg13g2_decap_8
* cell instance $200549 r0 *1 639.84,812.7
X$200549 VDD VSS sg13g2_decap_8
* cell instance $200550 r0 *1 819.84,979.02
X$200550 VDD VSS sg13g2_decap_8
* cell instance $200551 r0 *1 649.92,812.7
X$200551 VDD VSS sg13g2_decap_8
* cell instance $200552 r0 *1 799.68,956.34
X$200552 VDD VSS sg13g2_decap_8
* cell instance $200553 r0 *1 782.88,971.46
X$200553 VDD VSS sg13g2_decap_8
* cell instance $200554 r0 *1 779.52,971.46
X$200554 VDD VSS sg13g2_decap_8
* cell instance $200555 r0 *1 649.92,805.14
X$200555 VDD VSS sg13g2_decap_8
* cell instance $200556 r0 *1 639.84,805.14
X$200556 VDD VSS sg13g2_decap_8
* cell instance $200557 r0 *1 653.28,797.58
X$200557 VDD VSS sg13g2_decap_8
* cell instance $200558 r0 *1 653.28,805.14
X$200558 VDD VSS sg13g2_decap_8
* cell instance $200559 r0 *1 653.28,812.7
X$200559 VDD VSS sg13g2_decap_8
* cell instance $200560 r0 *1 653.28,820.26
X$200560 VDD VSS sg13g2_decap_8
* cell instance $200561 r0 *1 819.84,956.34
X$200561 VDD VSS sg13g2_decap_8
* cell instance $200562 r0 *1 819.84,963.9
X$200562 VDD VSS sg13g2_decap_8
* cell instance $200563 r0 *1 666.72,797.58
X$200563 VDD VSS sg13g2_decap_8
* cell instance $200564 r0 *1 646.56,812.7
X$200564 VDD VSS sg13g2_decap_8
* cell instance $200565 r0 *1 826.56,963.9
X$200565 VDD VSS sg13g2_decap_8
* cell instance $200566 r0 *1 823.2,963.9
X$200566 VDD VSS sg13g2_decap_8
* cell instance $200567 r0 *1 816.48,956.34
X$200567 VDD VSS sg13g2_decap_8
* cell instance $200568 r0 *1 816.48,963.9
X$200568 VDD VSS sg13g2_decap_8
* cell instance $200569 r0 *1 656.64,805.14
X$200569 VDD VSS sg13g2_decap_8
* cell instance $200570 r0 *1 663.36,805.14
X$200570 VDD VSS sg13g2_decap_8
* cell instance $200571 r0 *1 826.56,956.34
X$200571 VDD VSS sg13g2_decap_8
* cell instance $200572 r0 *1 670.08,805.14
X$200572 VDD VSS sg13g2_decap_8
* cell instance $200573 r0 *1 653.28,827.82
X$200573 VDD VSS sg13g2_decap_8
* cell instance $200574 r0 *1 666.72,805.14
X$200574 VDD VSS sg13g2_decap_8
* cell instance $200575 r0 *1 823.2,956.34
X$200575 VDD VSS sg13g2_decap_8
* cell instance $200576 r0 *1 660,805.14
X$200576 VDD VSS sg13g2_decap_8
* cell instance $200577 r0 *1 656.64,797.58
X$200577 VDD VSS sg13g2_decap_8
* cell instance $200578 r0 *1 700.32,820.26
X$200578 VDD VSS sg13g2_decap_8
* cell instance $200579 r0 *1 660.48,842.94
X$200579 VDD VSS sg13g2_decap_8
* cell instance $200580 r0 *1 696.96,820.26
X$200580 VDD VSS sg13g2_decap_8
* cell instance $200581 r0 *1 643.68,842.94
X$200581 VDD VSS sg13g2_decap_8
* cell instance $200582 r0 *1 653.76,835.38
X$200582 VDD VSS sg13g2_decap_8
* cell instance $200583 r0 *1 700.32,827.82
X$200583 VDD VSS sg13g2_decap_8
* cell instance $200584 r0 *1 650.4,835.38
X$200584 VDD VSS sg13g2_decap_8
* cell instance $200585 r0 *1 696.96,827.82
X$200585 VDD VSS sg13g2_decap_8
* cell instance $200586 r0 *1 663.84,835.38
X$200586 VDD VSS sg13g2_decap_8
* cell instance $200587 r0 *1 667.2,835.38
X$200587 VDD VSS sg13g2_decap_8
* cell instance $200588 r0 *1 703.68,827.82
X$200588 VDD VSS sg13g2_decap_8
* cell instance $200589 r0 *1 448.32,782.46
X$200589 VDD VSS sg13g2_decap_8
* cell instance $200590 r0 *1 703.68,820.26
X$200590 VDD VSS sg13g2_decap_8
* cell instance $200591 r0 *1 707.04,820.26
X$200591 VDD VSS sg13g2_decap_8
* cell instance $200592 r0 *1 710.4,827.82
X$200592 VDD VSS sg13g2_decap_8
* cell instance $200593 r0 *1 660.48,835.38
X$200593 VDD VSS sg13g2_decap_8
* cell instance $200594 r0 *1 710.4,820.26
X$200594 VDD VSS sg13g2_decap_8
* cell instance $200595 r0 *1 710.4,812.7
X$200595 VDD VSS sg13g2_decap_8
* cell instance $200596 r0 *1 434.88,790.02
X$200596 VDD VSS sg13g2_decap_8
* cell instance $200597 r0 *1 434.88,797.58
X$200597 VDD VSS sg13g2_decap_8
* cell instance $200598 r0 *1 693.6,797.58
X$200598 VDD VSS sg13g2_decap_8
* cell instance $200599 r0 *1 693.6,827.82
X$200599 VDD VSS sg13g2_decap_8
* cell instance $200600 r0 *1 696.96,812.7
X$200600 VDD VSS sg13g2_decap_8
* cell instance $200601 r0 *1 707.04,827.82
X$200601 VDD VSS sg13g2_decap_8
* cell instance $200602 r0 *1 676.8,820.26
X$200602 VDD VSS sg13g2_decap_8
* cell instance $200603 r0 *1 626.88,835.38
X$200603 VDD VSS sg13g2_decap_8
* cell instance $200604 r0 *1 620.16,835.38
X$200604 VDD VSS sg13g2_decap_8
* cell instance $200605 r0 *1 657.12,835.38
X$200605 VDD VSS sg13g2_decap_8
* cell instance $200606 r0 *1 643.68,835.38
X$200606 VDD VSS sg13g2_decap_8
* cell instance $200607 r0 *1 680.16,820.26
X$200607 VDD VSS sg13g2_decap_8
* cell instance $200608 r0 *1 683.52,820.26
X$200608 VDD VSS sg13g2_decap_8
* cell instance $200609 r0 *1 686.88,820.26
X$200609 VDD VSS sg13g2_decap_8
* cell instance $200610 r0 *1 690.24,820.26
X$200610 VDD VSS sg13g2_decap_8
* cell instance $200611 r0 *1 647.04,842.94
X$200611 VDD VSS sg13g2_decap_8
* cell instance $200612 r0 *1 640.32,835.38
X$200612 VDD VSS sg13g2_decap_8
* cell instance $200613 r0 *1 650.4,842.94
X$200613 VDD VSS sg13g2_decap_8
* cell instance $200614 r0 *1 667.2,842.94
X$200614 VDD VSS sg13g2_decap_8
* cell instance $200615 r0 *1 663.84,842.94
X$200615 VDD VSS sg13g2_decap_8
* cell instance $200616 r0 *1 647.04,835.38
X$200616 VDD VSS sg13g2_decap_8
* cell instance $200617 r0 *1 676.8,827.82
X$200617 VDD VSS sg13g2_decap_8
* cell instance $200618 r0 *1 636.96,842.94
X$200618 VDD VSS sg13g2_decap_8
* cell instance $200619 r0 *1 670.56,842.94
X$200619 VDD VSS sg13g2_decap_8
* cell instance $200620 r0 *1 670.56,835.38
X$200620 VDD VSS sg13g2_decap_8
* cell instance $200621 r0 *1 680.16,827.82
X$200621 VDD VSS sg13g2_decap_8
* cell instance $200622 r0 *1 657.12,842.94
X$200622 VDD VSS sg13g2_decap_8
* cell instance $200623 r0 *1 640.32,842.94
X$200623 VDD VSS sg13g2_decap_8
* cell instance $200624 r0 *1 653.76,842.94
X$200624 VDD VSS sg13g2_decap_8
* cell instance $200625 r0 *1 636.96,835.38
X$200625 VDD VSS sg13g2_decap_8
* cell instance $200626 r0 *1 720.48,797.58
X$200626 VDD VSS sg13g2_decap_8
* cell instance $200627 r0 *1 508.8,790.02
X$200627 VDD VSS sg13g2_decap_8
* cell instance $200628 r0 *1 441.6,790.02
X$200628 VDD VSS sg13g2_decap_8
* cell instance $200629 r0 *1 720.48,812.7
X$200629 VDD VSS sg13g2_decap_8
* cell instance $200630 r0 *1 720.48,820.26
X$200630 VDD VSS sg13g2_decap_8
* cell instance $200631 r0 *1 720.48,805.14
X$200631 VDD VSS sg13g2_decap_8
* cell instance $200632 r0 *1 717.12,827.82
X$200632 VDD VSS sg13g2_decap_8
* cell instance $200633 r0 *1 717.12,805.14
X$200633 VDD VSS sg13g2_decap_8
* cell instance $200634 r0 *1 717.12,812.7
X$200634 VDD VSS sg13g2_decap_8
* cell instance $200635 r0 *1 683.52,790.02
X$200635 VDD VSS sg13g2_decap_8
* cell instance $200636 r0 *1 686.88,790.02
X$200636 VDD VSS sg13g2_decap_8
* cell instance $200637 r0 *1 700.32,812.7
X$200637 VDD VSS sg13g2_decap_8
* cell instance $200638 r0 *1 700.32,790.02
X$200638 VDD VSS sg13g2_decap_8
* cell instance $200639 r0 *1 703.68,790.02
X$200639 VDD VSS sg13g2_decap_8
* cell instance $200640 r0 *1 707.04,790.02
X$200640 VDD VSS sg13g2_decap_8
* cell instance $200641 r0 *1 696.96,790.02
X$200641 VDD VSS sg13g2_decap_8
* cell instance $200642 r0 *1 710.4,790.02
X$200642 VDD VSS sg13g2_decap_8
* cell instance $200643 r0 *1 693.6,790.02
X$200643 VDD VSS sg13g2_decap_8
* cell instance $200644 r0 *1 475.2,827.82
X$200644 VDD VSS sg13g2_decap_8
* cell instance $200645 r0 *1 713.76,782.46
X$200645 VDD VSS sg13g2_decap_8
* cell instance $200646 r0 *1 475.2,820.26
X$200646 VDD VSS sg13g2_decap_8
* cell instance $200647 r0 *1 713.76,797.58
X$200647 VDD VSS sg13g2_decap_8
* cell instance $200648 r0 *1 713.76,820.26
X$200648 VDD VSS sg13g2_decap_8
* cell instance $200649 r0 *1 690.24,790.02
X$200649 VDD VSS sg13g2_decap_8
* cell instance $200650 r0 *1 703.68,812.7
X$200650 VDD VSS sg13g2_decap_8
* cell instance $200651 r0 *1 707.04,812.7
X$200651 VDD VSS sg13g2_decap_8
* cell instance $200652 r0 *1 686.88,812.7
X$200652 VDD VSS sg13g2_decap_8
* cell instance $200653 r0 *1 680.16,812.7
X$200653 VDD VSS sg13g2_decap_8
* cell instance $200654 r0 *1 676.8,812.7
X$200654 VDD VSS sg13g2_decap_8
* cell instance $200655 r0 *1 683.52,812.7
X$200655 VDD VSS sg13g2_decap_8
* cell instance $200656 r0 *1 690.24,812.7
X$200656 VDD VSS sg13g2_decap_8
* cell instance $200657 r0 *1 434.88,820.26
X$200657 VDD VSS sg13g2_decap_8
* cell instance $200658 r0 *1 693.6,812.7
X$200658 VDD VSS sg13g2_decap_8
* cell instance $200659 r0 *1 693.6,820.26
X$200659 VDD VSS sg13g2_decap_8
* cell instance $200660 r0 *1 693.6,805.14
X$200660 VDD VSS sg13g2_decap_8
* cell instance $200661 r0 *1 461.76,790.02
X$200661 VDD VSS sg13g2_decap_8
* cell instance $200662 r0 *1 434.88,805.14
X$200662 VDD VSS sg13g2_decap_8
* cell instance $200663 r0 *1 434.88,812.7
X$200663 VDD VSS sg13g2_decap_8
* cell instance $200664 r0 *1 717.12,820.26
X$200664 VDD VSS sg13g2_decap_8
* cell instance $200665 r0 *1 434.88,782.46
X$200665 VDD VSS sg13g2_decap_8
* cell instance $200666 r0 *1 495.36,790.02
X$200666 VDD VSS sg13g2_decap_8
* cell instance $200667 r0 *1 492,790.02
X$200667 VDD VSS sg13g2_decap_8
* cell instance $200668 r0 *1 488.64,790.02
X$200668 VDD VSS sg13g2_decap_8
* cell instance $200669 r0 *1 717.12,797.58
X$200669 VDD VSS sg13g2_decap_8
* cell instance $200670 r0 *1 720.48,827.82
X$200670 VDD VSS sg13g2_decap_8
* cell instance $200671 r0 *1 465.12,790.02
X$200671 VDD VSS sg13g2_decap_8
* cell instance $200672 r0 *1 485.28,790.02
X$200672 VDD VSS sg13g2_decap_8
* cell instance $200673 r0 *1 505.44,790.02
X$200673 VDD VSS sg13g2_decap_8
* cell instance $200674 r0 *1 434.88,827.82
X$200674 VDD VSS sg13g2_decap_8
* cell instance $200675 r0 *1 696.96,797.58
X$200675 VDD VSS sg13g2_decap_8
* cell instance $200676 r0 *1 696.96,805.14
X$200676 VDD VSS sg13g2_decap_8
* cell instance $200677 r0 *1 710.4,805.14
X$200677 VDD VSS sg13g2_decap_8
* cell instance $200678 r0 *1 710.4,797.58
X$200678 VDD VSS sg13g2_decap_8
* cell instance $200679 r0 *1 512.16,782.46
X$200679 VDD VSS sg13g2_decap_8
* cell instance $200680 r0 *1 512.16,790.02
X$200680 VDD VSS sg13g2_decap_8
* cell instance $200681 r0 *1 680.16,797.58
X$200681 VDD VSS sg13g2_decap_8
* cell instance $200682 r0 *1 593.28,835.38
X$200682 VDD VSS sg13g2_decap_8
* cell instance $200683 r0 *1 676.8,805.14
X$200683 VDD VSS sg13g2_decap_8
* cell instance $200684 r0 *1 683.52,797.58
X$200684 VDD VSS sg13g2_decap_8
* cell instance $200685 r0 *1 593.28,842.94
X$200685 VDD VSS sg13g2_decap_8
* cell instance $200686 r0 *1 616.8,835.38
X$200686 VDD VSS sg13g2_decap_8
* cell instance $200687 r0 *1 552.96,835.38
X$200687 VDD VSS sg13g2_decap_8
* cell instance $200688 r0 *1 552.96,842.94
X$200688 VDD VSS sg13g2_decap_8
* cell instance $200689 r0 *1 680.16,805.14
X$200689 VDD VSS sg13g2_decap_8
* cell instance $200690 r0 *1 546.24,835.38
X$200690 VDD VSS sg13g2_decap_8
* cell instance $200691 r0 *1 542.88,842.94
X$200691 VDD VSS sg13g2_decap_8
* cell instance $200692 r0 *1 549.6,835.38
X$200692 VDD VSS sg13g2_decap_8
* cell instance $200693 r0 *1 542.88,835.38
X$200693 VDD VSS sg13g2_decap_8
* cell instance $200694 r0 *1 549.6,842.94
X$200694 VDD VSS sg13g2_decap_8
* cell instance $200695 r0 *1 546.24,842.94
X$200695 VDD VSS sg13g2_decap_8
* cell instance $200696 r0 *1 563.04,842.94
X$200696 VDD VSS sg13g2_decap_8
* cell instance $200697 r0 *1 583.2,842.94
X$200697 VDD VSS sg13g2_decap_8
* cell instance $200698 r0 *1 686.88,797.58
X$200698 VDD VSS sg13g2_decap_8
* cell instance $200699 r0 *1 720.48,782.46
X$200699 VDD VSS sg13g2_decap_8
* cell instance $200700 r0 *1 717.12,782.46
X$200700 VDD VSS sg13g2_decap_8
* cell instance $200701 r0 *1 710.4,782.46
X$200701 VDD VSS sg13g2_decap_8
* cell instance $200702 r0 *1 693.6,782.46
X$200702 VDD VSS sg13g2_decap_8
* cell instance $200703 r0 *1 700.32,782.46
X$200703 VDD VSS sg13g2_decap_8
* cell instance $200704 r0 *1 680.16,782.46
X$200704 VDD VSS sg13g2_decap_8
* cell instance $200705 r0 *1 707.04,782.46
X$200705 VDD VSS sg13g2_decap_8
* cell instance $200706 r0 *1 690.24,782.46
X$200706 VDD VSS sg13g2_decap_8
* cell instance $200707 r0 *1 676.8,782.46
X$200707 VDD VSS sg13g2_decap_8
* cell instance $200708 r0 *1 683.52,782.46
X$200708 VDD VSS sg13g2_decap_8
* cell instance $200709 r0 *1 512.16,797.58
X$200709 VDD VSS sg13g2_decap_8
* cell instance $200710 r0 *1 707.04,805.14
X$200710 VDD VSS sg13g2_decap_8
* cell instance $200711 r0 *1 703.68,782.46
X$200711 VDD VSS sg13g2_decap_8
* cell instance $200712 r0 *1 696.96,782.46
X$200712 VDD VSS sg13g2_decap_8
* cell instance $200713 r0 *1 512.16,820.26
X$200713 VDD VSS sg13g2_decap_8
* cell instance $200714 r0 *1 703.68,797.58
X$200714 VDD VSS sg13g2_decap_8
* cell instance $200715 r0 *1 703.68,805.14
X$200715 VDD VSS sg13g2_decap_8
* cell instance $200716 r0 *1 512.16,827.82
X$200716 VDD VSS sg13g2_decap_8
* cell instance $200717 r0 *1 700.32,805.14
X$200717 VDD VSS sg13g2_decap_8
* cell instance $200718 r0 *1 707.04,797.58
X$200718 VDD VSS sg13g2_decap_8
* cell instance $200719 r0 *1 512.16,812.7
X$200719 VDD VSS sg13g2_decap_8
* cell instance $200720 r0 *1 700.32,797.58
X$200720 VDD VSS sg13g2_decap_8
* cell instance $200721 r0 *1 512.16,805.14
X$200721 VDD VSS sg13g2_decap_8
* cell instance $200722 r0 *1 686.88,782.46
X$200722 VDD VSS sg13g2_decap_8
* cell instance $200723 r0 *1 676.8,797.58
X$200723 VDD VSS sg13g2_decap_8
* cell instance $200724 r0 *1 613.44,842.94
X$200724 VDD VSS sg13g2_decap_8
* cell instance $200725 r0 *1 690.24,827.82
X$200725 VDD VSS sg13g2_decap_8
* cell instance $200726 r0 *1 613.44,835.38
X$200726 VDD VSS sg13g2_decap_8
* cell instance $200727 r0 *1 600,835.38
X$200727 VDD VSS sg13g2_decap_8
* cell instance $200728 r0 *1 683.52,827.82
X$200728 VDD VSS sg13g2_decap_8
* cell instance $200729 r0 *1 686.88,827.82
X$200729 VDD VSS sg13g2_decap_8
* cell instance $200730 r0 *1 596.64,835.38
X$200730 VDD VSS sg13g2_decap_8
* cell instance $200731 r0 *1 610.08,835.38
X$200731 VDD VSS sg13g2_decap_8
* cell instance $200732 r0 *1 606.72,835.38
X$200732 VDD VSS sg13g2_decap_8
* cell instance $200733 r0 *1 603.36,842.94
X$200733 VDD VSS sg13g2_decap_8
* cell instance $200734 r0 *1 683.52,805.14
X$200734 VDD VSS sg13g2_decap_8
* cell instance $200735 r0 *1 600,842.94
X$200735 VDD VSS sg13g2_decap_8
* cell instance $200736 r0 *1 606.72,842.94
X$200736 VDD VSS sg13g2_decap_8
* cell instance $200737 r0 *1 596.64,842.94
X$200737 VDD VSS sg13g2_decap_8
* cell instance $200738 r0 *1 610.08,842.94
X$200738 VDD VSS sg13g2_decap_8
* cell instance $200739 r0 *1 626.88,842.94
X$200739 VDD VSS sg13g2_decap_8
* cell instance $200740 r0 *1 623.52,835.38
X$200740 VDD VSS sg13g2_decap_8
* cell instance $200741 r0 *1 630.24,842.94
X$200741 VDD VSS sg13g2_decap_8
* cell instance $200742 r0 *1 623.52,842.94
X$200742 VDD VSS sg13g2_decap_8
* cell instance $200743 r0 *1 630.24,835.38
X$200743 VDD VSS sg13g2_decap_8
* cell instance $200744 r0 *1 620.16,842.94
X$200744 VDD VSS sg13g2_decap_8
* cell instance $200745 r0 *1 616.8,842.94
X$200745 VDD VSS sg13g2_decap_8
* cell instance $200746 r0 *1 603.36,835.38
X$200746 VDD VSS sg13g2_decap_8
* cell instance $200747 r0 *1 579.84,842.94
X$200747 VDD VSS sg13g2_decap_8
* cell instance $200748 r0 *1 576.48,842.94
X$200748 VDD VSS sg13g2_decap_8
* cell instance $200749 r0 *1 573.12,842.94
X$200749 VDD VSS sg13g2_decap_8
* cell instance $200750 r0 *1 569.76,842.94
X$200750 VDD VSS sg13g2_decap_8
* cell instance $200751 r0 *1 566.4,842.94
X$200751 VDD VSS sg13g2_decap_8
* cell instance $200752 r0 *1 589.92,842.94
X$200752 VDD VSS sg13g2_decap_8
* cell instance $200753 r0 *1 586.56,842.94
X$200753 VDD VSS sg13g2_decap_8
* cell instance $200754 r0 *1 559.68,842.94
X$200754 VDD VSS sg13g2_decap_8
* cell instance $200755 r0 *1 566.4,835.38
X$200755 VDD VSS sg13g2_decap_8
* cell instance $200756 r0 *1 569.76,835.38
X$200756 VDD VSS sg13g2_decap_8
* cell instance $200757 r0 *1 690.24,805.14
X$200757 VDD VSS sg13g2_decap_8
* cell instance $200758 r0 *1 690.24,797.58
X$200758 VDD VSS sg13g2_decap_8
* cell instance $200759 r0 *1 573.12,835.38
X$200759 VDD VSS sg13g2_decap_8
* cell instance $200760 r0 *1 686.88,805.14
X$200760 VDD VSS sg13g2_decap_8
* cell instance $200761 r0 *1 556.32,835.38
X$200761 VDD VSS sg13g2_decap_8
* cell instance $200762 r0 *1 586.56,835.38
X$200762 VDD VSS sg13g2_decap_8
* cell instance $200763 r0 *1 583.2,835.38
X$200763 VDD VSS sg13g2_decap_8
* cell instance $200764 r0 *1 579.84,835.38
X$200764 VDD VSS sg13g2_decap_8
* cell instance $200765 r0 *1 563.04,835.38
X$200765 VDD VSS sg13g2_decap_8
* cell instance $200766 r0 *1 559.68,835.38
X$200766 VDD VSS sg13g2_decap_8
* cell instance $200767 r0 *1 589.92,835.38
X$200767 VDD VSS sg13g2_decap_8
* cell instance $200768 r0 *1 556.32,842.94
X$200768 VDD VSS sg13g2_decap_8
* cell instance $200769 r0 *1 633.6,842.94
X$200769 VDD VSS sg13g2_decap_8
* cell instance $200770 r0 *1 633.6,835.38
X$200770 VDD VSS sg13g2_decap_8
* cell instance $200771 r0 *1 576.48,835.38
X$200771 VDD VSS sg13g2_decap_8
* cell instance $200772 r0 *1 458.4,820.26
X$200772 VDD VSS sg13g2_decap_8
* cell instance $200773 r0 *1 714.24,835.38
X$200773 VDD VSS sg13g2_decap_8
* cell instance $200774 r0 *1 714.24,842.94
X$200774 VDD VSS sg13g2_decap_8
* cell instance $200775 r0 *1 710.88,835.38
X$200775 VDD VSS sg13g2_decap_8
* cell instance $200776 r0 *1 465.12,827.82
X$200776 VDD VSS sg13g2_decap_8
* cell instance $200777 r0 *1 461.76,827.82
X$200777 VDD VSS sg13g2_decap_8
* cell instance $200778 r0 *1 458.4,827.82
X$200778 VDD VSS sg13g2_decap_8
* cell instance $200779 r0 *1 461.76,820.26
X$200779 VDD VSS sg13g2_decap_8
* cell instance $200780 r0 *1 710.88,842.94
X$200780 VDD VSS sg13g2_decap_8
* cell instance $200781 r0 *1 441.6,820.26
X$200781 VDD VSS sg13g2_decap_8
* cell instance $200782 r0 *1 438.24,820.26
X$200782 VDD VSS sg13g2_decap_8
* cell instance $200783 r0 *1 713.76,812.7
X$200783 VDD VSS sg13g2_decap_8
* cell instance $200784 r0 *1 451.68,820.26
X$200784 VDD VSS sg13g2_decap_8
* cell instance $200785 r0 *1 451.68,827.82
X$200785 VDD VSS sg13g2_decap_8
* cell instance $200786 r0 *1 441.6,827.82
X$200786 VDD VSS sg13g2_decap_8
* cell instance $200787 r0 *1 745.92,926.1
X$200787 VDD VSS sg13g2_decap_8
* cell instance $200788 r0 *1 749.28,926.1
X$200788 VDD VSS sg13g2_decap_8
* cell instance $200789 r0 *1 448.32,827.82
X$200789 VDD VSS sg13g2_decap_8
* cell instance $200790 r0 *1 438.24,827.82
X$200790 VDD VSS sg13g2_decap_8
* cell instance $200791 r0 *1 745.92,933.66
X$200791 VDD VSS sg13g2_decap_8
* cell instance $200792 r0 *1 739.2,941.22
X$200792 VDD VSS sg13g2_decap_8
* cell instance $200793 r0 *1 739.2,933.66
X$200793 VDD VSS sg13g2_decap_8
* cell instance $200794 r0 *1 448.32,820.26
X$200794 VDD VSS sg13g2_decap_8
* cell instance $200795 r0 *1 444.96,827.82
X$200795 VDD VSS sg13g2_decap_8
* cell instance $200796 r0 *1 444.96,812.7
X$200796 VDD VSS sg13g2_decap_8
* cell instance $200797 r0 *1 438.24,812.7
X$200797 VDD VSS sg13g2_decap_8
* cell instance $200798 r0 *1 684,842.94
X$200798 VDD VSS sg13g2_decap_8
* cell instance $200799 r0 *1 458.4,812.7
X$200799 VDD VSS sg13g2_decap_8
* cell instance $200800 r0 *1 704.16,842.94
X$200800 VDD VSS sg13g2_decap_8
* cell instance $200801 r0 *1 455.04,812.7
X$200801 VDD VSS sg13g2_decap_8
* cell instance $200802 r0 *1 465.12,812.7
X$200802 VDD VSS sg13g2_decap_8
* cell instance $200803 r0 *1 451.68,812.7
X$200803 VDD VSS sg13g2_decap_8
* cell instance $200804 r0 *1 468.48,812.7
X$200804 VDD VSS sg13g2_decap_8
* cell instance $200805 r0 *1 441.6,812.7
X$200805 VDD VSS sg13g2_decap_8
* cell instance $200806 r0 *1 707.52,835.38
X$200806 VDD VSS sg13g2_decap_8
* cell instance $200807 r0 *1 468.48,820.26
X$200807 VDD VSS sg13g2_decap_8
* cell instance $200808 r0 *1 697.44,835.38
X$200808 VDD VSS sg13g2_decap_8
* cell instance $200809 r0 *1 707.52,842.94
X$200809 VDD VSS sg13g2_decap_8
* cell instance $200810 r0 *1 700.8,835.38
X$200810 VDD VSS sg13g2_decap_8
* cell instance $200811 r0 *1 704.16,835.38
X$200811 VDD VSS sg13g2_decap_8
* cell instance $200812 r0 *1 455.04,827.82
X$200812 VDD VSS sg13g2_decap_8
* cell instance $200813 r0 *1 455.04,797.58
X$200813 VDD VSS sg13g2_decap_8
* cell instance $200814 r0 *1 455.04,805.14
X$200814 VDD VSS sg13g2_decap_8
* cell instance $200815 r0 *1 461.76,812.7
X$200815 VDD VSS sg13g2_decap_8
* cell instance $200816 r0 *1 448.32,812.7
X$200816 VDD VSS sg13g2_decap_8
* cell instance $200817 r0 *1 465.12,820.26
X$200817 VDD VSS sg13g2_decap_8
* cell instance $200818 r0 *1 468.48,827.82
X$200818 VDD VSS sg13g2_decap_8
* cell instance $200819 r0 *1 455.04,820.26
X$200819 VDD VSS sg13g2_decap_8
* cell instance $200820 r0 *1 745.92,956.34
X$200820 VDD VSS sg13g2_decap_8
* cell instance $200821 r0 *1 465.12,797.58
X$200821 VDD VSS sg13g2_decap_8
* cell instance $200822 r0 *1 749.28,963.9
X$200822 VDD VSS sg13g2_decap_8
* cell instance $200823 r0 *1 742.56,979.02
X$200823 VDD VSS sg13g2_decap_8
* cell instance $200824 r0 *1 745.92,971.46
X$200824 VDD VSS sg13g2_decap_8
* cell instance $200825 r0 *1 739.2,979.02
X$200825 VDD VSS sg13g2_decap_8
* cell instance $200826 r0 *1 461.76,805.14
X$200826 VDD VSS sg13g2_decap_8
* cell instance $200827 r0 *1 739.2,963.9
X$200827 VDD VSS sg13g2_decap_8
* cell instance $200828 r0 *1 461.76,797.58
X$200828 VDD VSS sg13g2_decap_8
* cell instance $200829 r0 *1 458.4,797.58
X$200829 VDD VSS sg13g2_decap_8
* cell instance $200830 r0 *1 749.28,956.34
X$200830 VDD VSS sg13g2_decap_8
* cell instance $200831 r0 *1 444.96,820.26
X$200831 VDD VSS sg13g2_decap_8
* cell instance $200832 r0 *1 441.6,782.46
X$200832 VDD VSS sg13g2_decap_8
* cell instance $200833 r0 *1 745.92,963.9
X$200833 VDD VSS sg13g2_decap_8
* cell instance $200834 r0 *1 739.2,956.34
X$200834 VDD VSS sg13g2_decap_8
* cell instance $200835 r0 *1 742.56,963.9
X$200835 VDD VSS sg13g2_decap_8
* cell instance $200836 r0 *1 465.12,782.46
X$200836 VDD VSS sg13g2_decap_8
* cell instance $200837 r0 *1 739.2,971.46
X$200837 VDD VSS sg13g2_decap_8
* cell instance $200838 r0 *1 461.76,782.46
X$200838 VDD VSS sg13g2_decap_8
* cell instance $200839 r0 *1 468.48,782.46
X$200839 VDD VSS sg13g2_decap_8
* cell instance $200840 r0 *1 458.4,782.46
X$200840 VDD VSS sg13g2_decap_8
* cell instance $200841 r0 *1 451.68,782.46
X$200841 VDD VSS sg13g2_decap_8
* cell instance $200842 r0 *1 444.96,782.46
X$200842 VDD VSS sg13g2_decap_8
* cell instance $200843 r0 *1 745.92,979.02
X$200843 VDD VSS sg13g2_decap_8
* cell instance $200844 r0 *1 749.28,941.22
X$200844 VDD VSS sg13g2_decap_8
* cell instance $200845 r0 *1 742.56,941.22
X$200845 VDD VSS sg13g2_decap_8
* cell instance $200846 r0 *1 441.6,805.14
X$200846 VDD VSS sg13g2_decap_8
* cell instance $200847 r0 *1 448.32,797.58
X$200847 VDD VSS sg13g2_decap_8
* cell instance $200848 r0 *1 742.56,933.66
X$200848 VDD VSS sg13g2_decap_8
* cell instance $200849 r0 *1 745.92,941.22
X$200849 VDD VSS sg13g2_decap_8
* cell instance $200850 r0 *1 444.96,797.58
X$200850 VDD VSS sg13g2_decap_8
* cell instance $200851 r0 *1 749.28,933.66
X$200851 VDD VSS sg13g2_decap_8
* cell instance $200852 r0 *1 444.96,805.14
X$200852 VDD VSS sg13g2_decap_8
* cell instance $200853 r0 *1 448.32,805.14
X$200853 VDD VSS sg13g2_decap_8
* cell instance $200854 r0 *1 739.2,926.1
X$200854 VDD VSS sg13g2_decap_8
* cell instance $200855 r0 *1 465.12,805.14
X$200855 VDD VSS sg13g2_decap_8
* cell instance $200856 r0 *1 742.56,926.1
X$200856 VDD VSS sg13g2_decap_8
* cell instance $200857 r0 *1 451.68,805.14
X$200857 VDD VSS sg13g2_decap_8
* cell instance $200858 r0 *1 438.24,805.14
X$200858 VDD VSS sg13g2_decap_8
* cell instance $200859 r0 *1 742.56,956.34
X$200859 VDD VSS sg13g2_decap_8
* cell instance $200860 r0 *1 441.6,797.58
X$200860 VDD VSS sg13g2_decap_8
* cell instance $200861 r0 *1 438.24,797.58
X$200861 VDD VSS sg13g2_decap_8
* cell instance $200862 r0 *1 742.56,971.46
X$200862 VDD VSS sg13g2_decap_8
* cell instance $200863 r0 *1 749.28,979.02
X$200863 VDD VSS sg13g2_decap_8
* cell instance $200864 r0 *1 749.28,971.46
X$200864 VDD VSS sg13g2_decap_8
* cell instance $200865 r0 *1 458.4,805.14
X$200865 VDD VSS sg13g2_decap_8
* cell instance $200866 r0 *1 468.48,797.58
X$200866 VDD VSS sg13g2_decap_8
* cell instance $200867 r0 *1 468.48,805.14
X$200867 VDD VSS sg13g2_decap_8
* cell instance $200868 r0 *1 451.68,797.58
X$200868 VDD VSS sg13g2_decap_8
* cell instance $200869 r0 *1 680.16,790.02
X$200869 VDD VSS sg13g2_decap_8
* cell instance $200870 r0 *1 478.56,790.02
X$200870 VDD VSS sg13g2_decap_8
* cell instance $200871 r0 *1 475.2,790.02
X$200871 VDD VSS sg13g2_decap_8
* cell instance $200872 r0 *1 471.84,790.02
X$200872 VDD VSS sg13g2_decap_8
* cell instance $200873 r0 *1 468.48,790.02
X$200873 VDD VSS sg13g2_decap_8
* cell instance $200874 r0 *1 481.92,790.02
X$200874 VDD VSS sg13g2_decap_8
* cell instance $200875 r0 *1 481.92,797.58
X$200875 VDD VSS sg13g2_decap_8
* cell instance $200876 r0 *1 481.92,805.14
X$200876 VDD VSS sg13g2_decap_8
* cell instance $200877 r0 *1 478.56,805.14
X$200877 VDD VSS sg13g2_decap_8
* cell instance $200878 r0 *1 478.56,797.58
X$200878 VDD VSS sg13g2_decap_8
* cell instance $200879 r0 *1 485.28,805.14
X$200879 VDD VSS sg13g2_decap_8
* cell instance $200880 r0 *1 697.44,842.94
X$200880 VDD VSS sg13g2_decap_8
* cell instance $200881 r0 *1 488.64,805.14
X$200881 VDD VSS sg13g2_decap_8
* cell instance $200882 r0 *1 505.44,812.7
X$200882 VDD VSS sg13g2_decap_8
* cell instance $200883 r0 *1 495.36,827.82
X$200883 VDD VSS sg13g2_decap_8
* cell instance $200884 r0 *1 485.28,797.58
X$200884 VDD VSS sg13g2_decap_8
* cell instance $200885 r0 *1 492,820.26
X$200885 VDD VSS sg13g2_decap_8
* cell instance $200886 r0 *1 498.72,805.14
X$200886 VDD VSS sg13g2_decap_8
* cell instance $200887 r0 *1 492,805.14
X$200887 VDD VSS sg13g2_decap_8
* cell instance $200888 r0 *1 717.6,842.94
X$200888 VDD VSS sg13g2_decap_8
* cell instance $200889 r0 *1 720.96,842.94
X$200889 VDD VSS sg13g2_decap_8
* cell instance $200890 r0 *1 495.36,805.14
X$200890 VDD VSS sg13g2_decap_8
* cell instance $200891 r0 *1 505.44,805.14
X$200891 VDD VSS sg13g2_decap_8
* cell instance $200892 r0 *1 488.64,797.58
X$200892 VDD VSS sg13g2_decap_8
* cell instance $200893 r0 *1 475.2,805.14
X$200893 VDD VSS sg13g2_decap_8
* cell instance $200894 r0 *1 713.76,805.14
X$200894 VDD VSS sg13g2_decap_8
* cell instance $200895 r0 *1 713.76,827.82
X$200895 VDD VSS sg13g2_decap_8
* cell instance $200896 r0 *1 475.2,797.58
X$200896 VDD VSS sg13g2_decap_8
* cell instance $200897 r0 *1 475.2,812.7
X$200897 VDD VSS sg13g2_decap_8
* cell instance $200898 r0 *1 475.2,782.46
X$200898 VDD VSS sg13g2_decap_8
* cell instance $200899 r0 *1 451.68,790.02
X$200899 VDD VSS sg13g2_decap_8
* cell instance $200900 r0 *1 444.96,790.02
X$200900 VDD VSS sg13g2_decap_8
* cell instance $200901 r0 *1 448.32,790.02
X$200901 VDD VSS sg13g2_decap_8
* cell instance $200902 r0 *1 458.4,790.02
X$200902 VDD VSS sg13g2_decap_8
* cell instance $200903 r0 *1 455.04,790.02
X$200903 VDD VSS sg13g2_decap_8
* cell instance $200904 r0 *1 676.8,790.02
X$200904 VDD VSS sg13g2_decap_8
* cell instance $200905 r0 *1 502.08,790.02
X$200905 VDD VSS sg13g2_decap_8
* cell instance $200906 r0 *1 498.72,790.02
X$200906 VDD VSS sg13g2_decap_8
* cell instance $200907 r0 *1 471.84,812.7
X$200907 VDD VSS sg13g2_decap_8
* cell instance $200908 r0 *1 471.84,827.82
X$200908 VDD VSS sg13g2_decap_8
* cell instance $200909 r0 *1 471.84,820.26
X$200909 VDD VSS sg13g2_decap_8
* cell instance $200910 r0 *1 713.76,790.02
X$200910 VDD VSS sg13g2_decap_8
* cell instance $200911 r0 *1 717.12,790.02
X$200911 VDD VSS sg13g2_decap_8
* cell instance $200912 r0 *1 471.84,805.14
X$200912 VDD VSS sg13g2_decap_8
* cell instance $200913 r0 *1 471.84,797.58
X$200913 VDD VSS sg13g2_decap_8
* cell instance $200914 r0 *1 720.48,790.02
X$200914 VDD VSS sg13g2_decap_8
* cell instance $200915 r0 *1 471.84,782.46
X$200915 VDD VSS sg13g2_decap_8
* cell instance $200916 r0 *1 438.24,790.02
X$200916 VDD VSS sg13g2_decap_8
* cell instance $200917 r0 *1 508.8,827.82
X$200917 VDD VSS sg13g2_decap_8
* cell instance $200918 r0 *1 502.08,827.82
X$200918 VDD VSS sg13g2_decap_8
* cell instance $200919 r0 *1 687.36,835.38
X$200919 VDD VSS sg13g2_decap_8
* cell instance $200920 r0 *1 498.72,827.82
X$200920 VDD VSS sg13g2_decap_8
* cell instance $200921 r0 *1 488.64,820.26
X$200921 VDD VSS sg13g2_decap_8
* cell instance $200922 r0 *1 481.92,827.82
X$200922 VDD VSS sg13g2_decap_8
* cell instance $200923 r0 *1 478.56,827.82
X$200923 VDD VSS sg13g2_decap_8
* cell instance $200924 r0 *1 677.28,835.38
X$200924 VDD VSS sg13g2_decap_8
* cell instance $200925 r0 *1 680.64,835.38
X$200925 VDD VSS sg13g2_decap_8
* cell instance $200926 r0 *1 684,835.38
X$200926 VDD VSS sg13g2_decap_8
* cell instance $200927 r0 *1 680.64,842.94
X$200927 VDD VSS sg13g2_decap_8
* cell instance $200928 r0 *1 720.96,835.38
X$200928 VDD VSS sg13g2_decap_8
* cell instance $200929 r0 *1 687.36,842.94
X$200929 VDD VSS sg13g2_decap_8
* cell instance $200930 r0 *1 481.92,820.26
X$200930 VDD VSS sg13g2_decap_8
* cell instance $200931 r0 *1 478.56,820.26
X$200931 VDD VSS sg13g2_decap_8
* cell instance $200932 r0 *1 495.36,820.26
X$200932 VDD VSS sg13g2_decap_8
* cell instance $200933 r0 *1 677.28,842.94
X$200933 VDD VSS sg13g2_decap_8
* cell instance $200934 r0 *1 485.28,820.26
X$200934 VDD VSS sg13g2_decap_8
* cell instance $200935 r0 *1 502.08,820.26
X$200935 VDD VSS sg13g2_decap_8
* cell instance $200936 r0 *1 488.64,827.82
X$200936 VDD VSS sg13g2_decap_8
* cell instance $200937 r0 *1 690.72,842.94
X$200937 VDD VSS sg13g2_decap_8
* cell instance $200938 r0 *1 485.28,827.82
X$200938 VDD VSS sg13g2_decap_8
* cell instance $200939 r0 *1 694.08,835.38
X$200939 VDD VSS sg13g2_decap_8
* cell instance $200940 r0 *1 700.8,842.94
X$200940 VDD VSS sg13g2_decap_8
* cell instance $200941 r0 *1 502.08,797.58
X$200941 VDD VSS sg13g2_decap_8
* cell instance $200942 r0 *1 485.28,812.7
X$200942 VDD VSS sg13g2_decap_8
* cell instance $200943 r0 *1 717.6,835.38
X$200943 VDD VSS sg13g2_decap_8
* cell instance $200944 r0 *1 495.36,797.58
X$200944 VDD VSS sg13g2_decap_8
* cell instance $200945 r0 *1 505.44,797.58
X$200945 VDD VSS sg13g2_decap_8
* cell instance $200946 r0 *1 508.8,797.58
X$200946 VDD VSS sg13g2_decap_8
* cell instance $200947 r0 *1 508.8,805.14
X$200947 VDD VSS sg13g2_decap_8
* cell instance $200948 r0 *1 492,812.7
X$200948 VDD VSS sg13g2_decap_8
* cell instance $200949 r0 *1 502.08,805.14
X$200949 VDD VSS sg13g2_decap_8
* cell instance $200950 r0 *1 488.64,812.7
X$200950 VDD VSS sg13g2_decap_8
* cell instance $200951 r0 *1 498.72,797.58
X$200951 VDD VSS sg13g2_decap_8
* cell instance $200952 r0 *1 508.8,820.26
X$200952 VDD VSS sg13g2_decap_8
* cell instance $200953 r0 *1 495.36,812.7
X$200953 VDD VSS sg13g2_decap_8
* cell instance $200954 r0 *1 694.08,842.94
X$200954 VDD VSS sg13g2_decap_8
* cell instance $200955 r0 *1 481.92,812.7
X$200955 VDD VSS sg13g2_decap_8
* cell instance $200956 r0 *1 478.56,812.7
X$200956 VDD VSS sg13g2_decap_8
* cell instance $200957 r0 *1 492,797.58
X$200957 VDD VSS sg13g2_decap_8
* cell instance $200958 r0 *1 502.08,812.7
X$200958 VDD VSS sg13g2_decap_8
* cell instance $200959 r0 *1 498.72,812.7
X$200959 VDD VSS sg13g2_decap_8
* cell instance $200960 r0 *1 492,827.82
X$200960 VDD VSS sg13g2_decap_8
* cell instance $200961 r0 *1 508.8,812.7
X$200961 VDD VSS sg13g2_decap_8
* cell instance $200962 r0 *1 498.72,820.26
X$200962 VDD VSS sg13g2_decap_8
* cell instance $200963 r0 *1 505.44,827.82
X$200963 VDD VSS sg13g2_decap_8
* cell instance $200964 r0 *1 505.44,820.26
X$200964 VDD VSS sg13g2_decap_8
* cell instance $200965 r0 *1 690.72,835.38
X$200965 VDD VSS sg13g2_decap_8
* cell instance $200966 r0 *1 470.88,366.66
X$200966 VDD VSS sg13g2_decap_8
* cell instance $200967 r0 *1 937.44,941.22
X$200967 VDD VSS sg13g2_decap_8
* cell instance $200968 r0 *1 940.8,941.22
X$200968 VDD VSS sg13g2_decap_8
* cell instance $200969 r0 *1 467.52,366.66
X$200969 VDD VSS sg13g2_decap_8
* cell instance $200970 r0 *1 934.08,941.22
X$200970 VDD VSS sg13g2_decap_8
* cell instance $200971 r0 *1 930.72,933.66
X$200971 VDD VSS sg13g2_decap_8
* cell instance $200972 r0 *1 947.52,926.1
X$200972 VDD VSS sg13g2_decap_8
* cell instance $200973 r0 *1 944.16,926.1
X$200973 VDD VSS sg13g2_decap_8
* cell instance $200974 r0 *1 940.8,926.1
X$200974 VDD VSS sg13g2_decap_8
* cell instance $200975 r0 *1 934.08,926.1
X$200975 VDD VSS sg13g2_decap_8
* cell instance $200976 r0 *1 937.44,926.1
X$200976 VDD VSS sg13g2_decap_8
* cell instance $200977 r0 *1 606.24,797.58
X$200977 VDD VSS sg13g2_decap_8
* cell instance $200978 r0 *1 924,926.1
X$200978 VDD VSS sg13g2_decap_8
* cell instance $200979 r0 *1 927.36,926.1
X$200979 VDD VSS sg13g2_decap_8
* cell instance $200980 r0 *1 913.92,926.1
X$200980 VDD VSS sg13g2_decap_8
* cell instance $200981 r0 *1 917.28,926.1
X$200981 VDD VSS sg13g2_decap_8
* cell instance $200982 r0 *1 920.64,926.1
X$200982 VDD VSS sg13g2_decap_8
* cell instance $200983 r0 *1 927.36,933.66
X$200983 VDD VSS sg13g2_decap_8
* cell instance $200984 r0 *1 497.76,374.22
X$200984 VDD VSS sg13g2_decap_8
* cell instance $200985 r0 *1 924,933.66
X$200985 VDD VSS sg13g2_decap_8
* cell instance $200986 r0 *1 477.6,366.66
X$200986 VDD VSS sg13g2_decap_8
* cell instance $200987 r0 *1 491.04,374.22
X$200987 VDD VSS sg13g2_decap_8
* cell instance $200988 r0 *1 480.96,389.34
X$200988 VDD VSS sg13g2_decap_8
* cell instance $200989 r0 *1 460.8,366.66
X$200989 VDD VSS sg13g2_decap_8
* cell instance $200990 r0 *1 924,941.22
X$200990 VDD VSS sg13g2_decap_8
* cell instance $200991 r0 *1 947.52,933.66
X$200991 VDD VSS sg13g2_decap_8
* cell instance $200992 r0 *1 447.36,389.34
X$200992 VDD VSS sg13g2_decap_8
* cell instance $200993 r0 *1 927.36,941.22
X$200993 VDD VSS sg13g2_decap_8
* cell instance $200994 r0 *1 913.92,941.22
X$200994 VDD VSS sg13g2_decap_8
* cell instance $200995 r0 *1 440.64,381.78
X$200995 VDD VSS sg13g2_decap_8
* cell instance $200996 r0 *1 920.64,941.22
X$200996 VDD VSS sg13g2_decap_8
* cell instance $200997 r0 *1 920.64,933.66
X$200997 VDD VSS sg13g2_decap_8
* cell instance $200998 r0 *1 930.72,941.22
X$200998 VDD VSS sg13g2_decap_8
* cell instance $200999 r0 *1 437.28,381.78
X$200999 VDD VSS sg13g2_decap_8
* cell instance $201000 r0 *1 947.52,941.22
X$201000 VDD VSS sg13g2_decap_8
* cell instance $201001 r0 *1 937.44,933.66
X$201001 VDD VSS sg13g2_decap_8
* cell instance $201002 r0 *1 930.72,926.1
X$201002 VDD VSS sg13g2_decap_8
* cell instance $201003 r0 *1 437.28,366.66
X$201003 VDD VSS sg13g2_decap_8
* cell instance $201004 r0 *1 450.72,366.66
X$201004 VDD VSS sg13g2_decap_8
* cell instance $201005 r0 *1 447.36,366.66
X$201005 VDD VSS sg13g2_decap_8
* cell instance $201006 r0 *1 444,366.66
X$201006 VDD VSS sg13g2_decap_8
* cell instance $201007 r0 *1 934.08,933.66
X$201007 VDD VSS sg13g2_decap_8
* cell instance $201008 r0 *1 440.64,366.66
X$201008 VDD VSS sg13g2_decap_8
* cell instance $201009 r0 *1 940.8,933.66
X$201009 VDD VSS sg13g2_decap_8
* cell instance $201010 r0 *1 457.44,366.66
X$201010 VDD VSS sg13g2_decap_8
* cell instance $201012 r0 *1 464.16,366.66
X$201012 VDD VSS sg13g2_decap_8
* cell instance $201013 r0 *1 944.16,933.66
X$201013 VDD VSS sg13g2_decap_8
* cell instance $201014 r0 *1 944.16,941.22
X$201014 VDD VSS sg13g2_decap_8
* cell instance $201015 r0 *1 934.08,963.9
X$201015 VDD VSS sg13g2_decap_8
* cell instance $201016 r0 *1 511.2,389.34
X$201016 VDD VSS sg13g2_decap_8
* cell instance $201017 r0 *1 484.32,381.78
X$201017 VDD VSS sg13g2_decap_8
* cell instance $201018 r0 *1 497.76,381.78
X$201018 VDD VSS sg13g2_decap_8
* cell instance $201019 r0 *1 917.28,956.34
X$201019 VDD VSS sg13g2_decap_8
* cell instance $201020 r0 *1 924,963.9
X$201020 VDD VSS sg13g2_decap_8
* cell instance $201021 r0 *1 507.84,381.78
X$201021 VDD VSS sg13g2_decap_8
* cell instance $201022 r0 *1 511.2,381.78
X$201022 VDD VSS sg13g2_decap_8
* cell instance $201023 r0 *1 947.52,971.46
X$201023 VDD VSS sg13g2_decap_8
* cell instance $201024 r0 *1 924,956.34
X$201024 VDD VSS sg13g2_decap_8
* cell instance $201025 r0 *1 930.72,979.02
X$201025 VDD VSS sg13g2_decap_8
* cell instance $201026 r0 *1 913.92,933.66
X$201026 VDD VSS sg13g2_decap_8
* cell instance $201027 r0 *1 927.36,963.9
X$201027 VDD VSS sg13g2_decap_8
* cell instance $201028 r0 *1 507.84,389.34
X$201028 VDD VSS sg13g2_decap_8
* cell instance $201029 r0 *1 927.36,956.34
X$201029 VDD VSS sg13g2_decap_8
* cell instance $201030 r0 *1 507.84,374.22
X$201030 VDD VSS sg13g2_decap_8
* cell instance $201031 r0 *1 913.92,956.34
X$201031 VDD VSS sg13g2_decap_8
* cell instance $201032 r0 *1 511.2,366.66
X$201032 VDD VSS sg13g2_decap_8
* cell instance $201033 r0 *1 920.64,956.34
X$201033 VDD VSS sg13g2_decap_8
* cell instance $201034 r0 *1 504.48,366.66
X$201034 VDD VSS sg13g2_decap_8
* cell instance $201035 r0 *1 913.92,963.9
X$201035 VDD VSS sg13g2_decap_8
* cell instance $201036 r0 *1 477.6,389.34
X$201036 VDD VSS sg13g2_decap_8
* cell instance $201037 r0 *1 920.64,963.9
X$201037 VDD VSS sg13g2_decap_8
* cell instance $201038 r0 *1 917.28,971.46
X$201038 VDD VSS sg13g2_decap_8
* cell instance $201039 r0 *1 917.28,933.66
X$201039 VDD VSS sg13g2_decap_8
* cell instance $201040 r0 *1 494.4,389.34
X$201040 VDD VSS sg13g2_decap_8
* cell instance $201041 r0 *1 913.92,971.46
X$201041 VDD VSS sg13g2_decap_8
* cell instance $201042 r0 *1 930.72,963.9
X$201042 VDD VSS sg13g2_decap_8
* cell instance $201043 r0 *1 477.6,381.78
X$201043 VDD VSS sg13g2_decap_8
* cell instance $201044 r0 *1 920.64,971.46
X$201044 VDD VSS sg13g2_decap_8
* cell instance $201045 r0 *1 924,971.46
X$201045 VDD VSS sg13g2_decap_8
* cell instance $201046 r0 *1 930.72,971.46
X$201046 VDD VSS sg13g2_decap_8
* cell instance $201047 r0 *1 934.08,971.46
X$201047 VDD VSS sg13g2_decap_8
* cell instance $201048 r0 *1 944.16,971.46
X$201048 VDD VSS sg13g2_decap_8
* cell instance $201049 r0 *1 487.68,389.34
X$201049 VDD VSS sg13g2_decap_8
* cell instance $201050 r0 *1 504.48,381.78
X$201050 VDD VSS sg13g2_decap_8
* cell instance $201051 r0 *1 940.8,963.9
X$201051 VDD VSS sg13g2_decap_8
* cell instance $201052 r0 *1 947.52,963.9
X$201052 VDD VSS sg13g2_decap_8
* cell instance $201053 r0 *1 491.04,381.78
X$201053 VDD VSS sg13g2_decap_8
* cell instance $201054 r0 *1 494.4,381.78
X$201054 VDD VSS sg13g2_decap_8
* cell instance $201055 r0 *1 934.08,956.34
X$201055 VDD VSS sg13g2_decap_8
* cell instance $201056 r0 *1 937.44,956.34
X$201056 VDD VSS sg13g2_decap_8
* cell instance $201057 r0 *1 944.16,956.34
X$201057 VDD VSS sg13g2_decap_8
* cell instance $201058 r0 *1 947.52,956.34
X$201058 VDD VSS sg13g2_decap_8
* cell instance $201059 r0 *1 491.04,389.34
X$201059 VDD VSS sg13g2_decap_8
* cell instance $201060 r0 *1 944.16,963.9
X$201060 VDD VSS sg13g2_decap_8
* cell instance $201061 r0 *1 937.44,963.9
X$201061 VDD VSS sg13g2_decap_8
* cell instance $201062 r0 *1 940.8,956.34
X$201062 VDD VSS sg13g2_decap_8
* cell instance $201063 r0 *1 981.12,926.1
X$201063 VDD VSS sg13g2_decap_8
* cell instance $201064 r0 *1 427.2,389.34
X$201064 VDD VSS sg13g2_decap_8
* cell instance $201065 r0 *1 420.48,366.66
X$201065 VDD VSS sg13g2_decap_8
* cell instance $201066 r0 *1 423.84,389.34
X$201066 VDD VSS sg13g2_decap_8
* cell instance $201067 r0 *1 410.4,381.78
X$201067 VDD VSS sg13g2_decap_8
* cell instance $201068 r0 *1 430.56,381.78
X$201068 VDD VSS sg13g2_decap_8
* cell instance $201069 r0 *1 427.2,381.78
X$201069 VDD VSS sg13g2_decap_8
* cell instance $201070 r0 *1 430.56,389.34
X$201070 VDD VSS sg13g2_decap_8
* cell instance $201071 r0 *1 977.76,926.1
X$201071 VDD VSS sg13g2_decap_8
* cell instance $201072 r0 *1 407.04,366.66
X$201072 VDD VSS sg13g2_decap_8
* cell instance $201073 r0 *1 974.4,926.1
X$201073 VDD VSS sg13g2_decap_8
* cell instance $201074 r0 *1 917.28,941.22
X$201074 VDD VSS sg13g2_decap_8
* cell instance $201075 r0 *1 957.6,926.1
X$201075 VDD VSS sg13g2_decap_8
* cell instance $201076 r0 *1 960.96,926.1
X$201076 VDD VSS sg13g2_decap_8
* cell instance $201077 r0 *1 964.32,926.1
X$201077 VDD VSS sg13g2_decap_8
* cell instance $201078 r0 *1 954.24,926.1
X$201078 VDD VSS sg13g2_decap_8
* cell instance $201079 r0 *1 967.68,926.1
X$201079 VDD VSS sg13g2_decap_8
* cell instance $201080 r0 *1 967.68,933.66
X$201080 VDD VSS sg13g2_decap_8
* cell instance $201081 r0 *1 417.12,381.78
X$201081 VDD VSS sg13g2_decap_8
* cell instance $201082 r0 *1 954.24,941.22
X$201082 VDD VSS sg13g2_decap_8
* cell instance $201083 r0 *1 964.32,933.66
X$201083 VDD VSS sg13g2_decap_8
* cell instance $201084 r0 *1 474.24,374.22
X$201084 VDD VSS sg13g2_decap_8
* cell instance $201085 r0 *1 960.96,933.66
X$201085 VDD VSS sg13g2_decap_8
* cell instance $201086 r0 *1 423.84,381.78
X$201086 VDD VSS sg13g2_decap_8
* cell instance $201087 r0 *1 907.2,948.78
X$201087 VDD VSS sg13g2_decap_8
* cell instance $201088 r0 *1 893.76,948.78
X$201088 VDD VSS sg13g2_decap_8
* cell instance $201089 r0 *1 890.4,948.78
X$201089 VDD VSS sg13g2_decap_8
* cell instance $201090 r0 *1 843.36,948.78
X$201090 VDD VSS sg13g2_decap_8
* cell instance $201091 r0 *1 836.64,948.78
X$201091 VDD VSS sg13g2_decap_8
* cell instance $201092 r0 *1 840,948.78
X$201092 VDD VSS sg13g2_decap_8
* cell instance $201093 r0 *1 846.72,948.78
X$201093 VDD VSS sg13g2_decap_8
* cell instance $201094 r0 *1 860.16,948.78
X$201094 VDD VSS sg13g2_decap_8
* cell instance $201095 r0 *1 853.44,948.78
X$201095 VDD VSS sg13g2_decap_8
* cell instance $201096 r0 *1 856.8,948.78
X$201096 VDD VSS sg13g2_decap_8
* cell instance $201097 r0 *1 866.88,948.78
X$201097 VDD VSS sg13g2_decap_8
* cell instance $201098 r0 *1 413.76,374.22
X$201098 VDD VSS sg13g2_decap_8
* cell instance $201099 r0 *1 850.08,948.78
X$201099 VDD VSS sg13g2_decap_8
* cell instance $201100 r0 *1 407.04,381.78
X$201100 VDD VSS sg13g2_decap_8
* cell instance $201101 r0 *1 420.48,374.22
X$201101 VDD VSS sg13g2_decap_8
* cell instance $201102 r0 *1 420.48,381.78
X$201102 VDD VSS sg13g2_decap_8
* cell instance $201103 r0 *1 410.4,389.34
X$201103 VDD VSS sg13g2_decap_8
* cell instance $201104 r0 *1 870.24,956.34
X$201104 VDD VSS sg13g2_decap_8
* cell instance $201105 r0 *1 417.12,374.22
X$201105 VDD VSS sg13g2_decap_8
* cell instance $201106 r0 *1 870.24,963.9
X$201106 VDD VSS sg13g2_decap_8
* cell instance $201107 r0 *1 417.12,366.66
X$201107 VDD VSS sg13g2_decap_8
* cell instance $201108 r0 *1 870.24,948.78
X$201108 VDD VSS sg13g2_decap_8
* cell instance $201109 r0 *1 413.76,366.66
X$201109 VDD VSS sg13g2_decap_8
* cell instance $201110 r0 *1 863.52,948.78
X$201110 VDD VSS sg13g2_decap_8
* cell instance $201111 r0 *1 981.12,933.66
X$201111 VDD VSS sg13g2_decap_8
* cell instance $201112 r0 *1 454.08,381.78
X$201112 VDD VSS sg13g2_decap_8
* cell instance $201113 r0 *1 454.08,389.34
X$201113 VDD VSS sg13g2_decap_8
* cell instance $201114 r0 *1 457.44,389.34
X$201114 VDD VSS sg13g2_decap_8
* cell instance $201115 r0 *1 460.8,381.78
X$201115 VDD VSS sg13g2_decap_8
* cell instance $201116 r0 *1 464.16,381.78
X$201116 VDD VSS sg13g2_decap_8
* cell instance $201117 r0 *1 464.16,389.34
X$201117 VDD VSS sg13g2_decap_8
* cell instance $201118 r0 *1 460.8,389.34
X$201118 VDD VSS sg13g2_decap_8
* cell instance $201119 r0 *1 467.52,389.34
X$201119 VDD VSS sg13g2_decap_8
* cell instance $201120 r0 *1 971.04,941.22
X$201120 VDD VSS sg13g2_decap_8
* cell instance $201121 r0 *1 470.88,381.78
X$201121 VDD VSS sg13g2_decap_8
* cell instance $201122 r0 *1 964.32,941.22
X$201122 VDD VSS sg13g2_decap_8
* cell instance $201123 r0 *1 467.52,381.78
X$201123 VDD VSS sg13g2_decap_8
* cell instance $201124 r0 *1 457.44,381.78
X$201124 VDD VSS sg13g2_decap_8
* cell instance $201125 r0 *1 450.72,389.34
X$201125 VDD VSS sg13g2_decap_8
* cell instance $201126 r0 *1 437.28,389.34
X$201126 VDD VSS sg13g2_decap_8
* cell instance $201127 r0 *1 971.04,926.1
X$201127 VDD VSS sg13g2_decap_8
* cell instance $201128 r0 *1 444,381.78
X$201128 VDD VSS sg13g2_decap_8
* cell instance $201129 r0 *1 971.04,933.66
X$201129 VDD VSS sg13g2_decap_8
* cell instance $201130 r0 *1 450.72,381.78
X$201130 VDD VSS sg13g2_decap_8
* cell instance $201131 r0 *1 440.64,389.34
X$201131 VDD VSS sg13g2_decap_8
* cell instance $201132 r0 *1 444,389.34
X$201132 VDD VSS sg13g2_decap_8
* cell instance $201133 r0 *1 447.36,381.78
X$201133 VDD VSS sg13g2_decap_8
* cell instance $201134 r0 *1 470.88,389.34
X$201134 VDD VSS sg13g2_decap_8
* cell instance $201135 r0 *1 474.24,366.66
X$201135 VDD VSS sg13g2_decap_8
* cell instance $201136 r0 *1 954.24,933.66
X$201136 VDD VSS sg13g2_decap_8
* cell instance $201137 r0 *1 957.6,933.66
X$201137 VDD VSS sg13g2_decap_8
* cell instance $201138 r0 *1 960.96,941.22
X$201138 VDD VSS sg13g2_decap_8
* cell instance $201139 r0 *1 957.6,941.22
X$201139 VDD VSS sg13g2_decap_8
* cell instance $201140 r0 *1 967.68,941.22
X$201140 VDD VSS sg13g2_decap_8
* cell instance $201141 r0 *1 977.76,941.22
X$201141 VDD VSS sg13g2_decap_8
* cell instance $201142 r0 *1 474.24,381.78
X$201142 VDD VSS sg13g2_decap_8
* cell instance $201143 r0 *1 974.4,941.22
X$201143 VDD VSS sg13g2_decap_8
* cell instance $201144 r0 *1 974.4,933.66
X$201144 VDD VSS sg13g2_decap_8
* cell instance $201145 r0 *1 474.24,389.34
X$201145 VDD VSS sg13g2_decap_8
* cell instance $201146 r0 *1 460.8,374.22
X$201146 VDD VSS sg13g2_decap_8
* cell instance $201147 r0 *1 440.64,374.22
X$201147 VDD VSS sg13g2_decap_8
* cell instance $201148 r0 *1 437.28,374.22
X$201148 VDD VSS sg13g2_decap_8
* cell instance $201149 r0 *1 454.08,366.66
X$201149 VDD VSS sg13g2_decap_8
* cell instance $201150 r0 *1 981.12,941.22
X$201150 VDD VSS sg13g2_decap_8
* cell instance $201151 r0 *1 457.44,374.22
X$201151 VDD VSS sg13g2_decap_8
* cell instance $201152 r0 *1 450.72,374.22
X$201152 VDD VSS sg13g2_decap_8
* cell instance $201153 r0 *1 444,374.22
X$201153 VDD VSS sg13g2_decap_8
* cell instance $201154 r0 *1 447.36,374.22
X$201154 VDD VSS sg13g2_decap_8
* cell instance $201155 r0 *1 470.88,374.22
X$201155 VDD VSS sg13g2_decap_8
* cell instance $201156 r0 *1 467.52,374.22
X$201156 VDD VSS sg13g2_decap_8
* cell instance $201157 r0 *1 464.16,374.22
X$201157 VDD VSS sg13g2_decap_8
* cell instance $201158 r0 *1 977.76,933.66
X$201158 VDD VSS sg13g2_decap_8
* cell instance $201159 r0 *1 454.08,374.22
X$201159 VDD VSS sg13g2_decap_8
* cell instance $201160 r0 *1 950.88,971.46
X$201160 VDD VSS sg13g2_decap_8
* cell instance $201161 r0 *1 528,389.34
X$201161 VDD VSS sg13g2_decap_8
* cell instance $201162 r0 *1 528,366.66
X$201162 VDD VSS sg13g2_decap_8
* cell instance $201163 r0 *1 524.64,366.66
X$201163 VDD VSS sg13g2_decap_8
* cell instance $201164 r0 *1 521.28,366.66
X$201164 VDD VSS sg13g2_decap_8
* cell instance $201165 r0 *1 950.88,979.02
X$201165 VDD VSS sg13g2_decap_8
* cell instance $201166 r0 *1 531.36,366.66
X$201166 VDD VSS sg13g2_decap_8
* cell instance $201167 r0 *1 517.92,366.66
X$201167 VDD VSS sg13g2_decap_8
* cell instance $201168 r0 *1 544.8,366.66
X$201168 VDD VSS sg13g2_decap_8
* cell instance $201169 r0 *1 541.44,366.66
X$201169 VDD VSS sg13g2_decap_8
* cell instance $201170 r0 *1 950.88,926.1
X$201170 VDD VSS sg13g2_decap_8
* cell instance $201171 r0 *1 507.84,366.66
X$201171 VDD VSS sg13g2_decap_8
* cell instance $201172 r0 *1 538.08,366.66
X$201172 VDD VSS sg13g2_decap_8
* cell instance $201173 r0 *1 950.88,941.22
X$201173 VDD VSS sg13g2_decap_8
* cell instance $201174 r0 *1 950.88,933.66
X$201174 VDD VSS sg13g2_decap_8
* cell instance $201175 r0 *1 960.96,948.78
X$201175 VDD VSS sg13g2_decap_8
* cell instance $201176 r0 *1 967.68,948.78
X$201176 VDD VSS sg13g2_decap_8
* cell instance $201177 r0 *1 957.6,948.78
X$201177 VDD VSS sg13g2_decap_8
* cell instance $201178 r0 *1 964.32,948.78
X$201178 VDD VSS sg13g2_decap_8
* cell instance $201179 r0 *1 954.24,948.78
X$201179 VDD VSS sg13g2_decap_8
* cell instance $201180 r0 *1 981.12,948.78
X$201180 VDD VSS sg13g2_decap_8
* cell instance $201181 r0 *1 581.76,374.22
X$201181 VDD VSS sg13g2_decap_8
* cell instance $201182 r0 *1 974.4,948.78
X$201182 VDD VSS sg13g2_decap_8
* cell instance $201183 r0 *1 548.16,366.66
X$201183 VDD VSS sg13g2_decap_8
* cell instance $201184 r0 *1 964.32,971.46
X$201184 VDD VSS sg13g2_decap_8
* cell instance $201185 r0 *1 954.24,971.46
X$201185 VDD VSS sg13g2_decap_8
* cell instance $201186 r0 *1 960.96,971.46
X$201186 VDD VSS sg13g2_decap_8
* cell instance $201187 r0 *1 957.6,971.46
X$201187 VDD VSS sg13g2_decap_8
* cell instance $201188 r0 *1 971.04,956.34
X$201188 VDD VSS sg13g2_decap_8
* cell instance $201189 r0 *1 944.16,948.78
X$201189 VDD VSS sg13g2_decap_8
* cell instance $201190 r0 *1 947.52,948.78
X$201190 VDD VSS sg13g2_decap_8
* cell instance $201191 r0 *1 930.72,948.78
X$201191 VDD VSS sg13g2_decap_8
* cell instance $201192 r0 *1 950.88,956.34
X$201192 VDD VSS sg13g2_decap_8
* cell instance $201193 r0 *1 950.88,963.9
X$201193 VDD VSS sg13g2_decap_8
* cell instance $201194 r0 *1 950.88,948.78
X$201194 VDD VSS sg13g2_decap_8
* cell instance $201195 r0 *1 528,381.78
X$201195 VDD VSS sg13g2_decap_8
* cell instance $201196 r0 *1 548.16,381.78
X$201196 VDD VSS sg13g2_decap_8
* cell instance $201197 r0 *1 541.44,381.78
X$201197 VDD VSS sg13g2_decap_8
* cell instance $201198 r0 *1 544.8,389.34
X$201198 VDD VSS sg13g2_decap_8
* cell instance $201199 r0 *1 517.92,389.34
X$201199 VDD VSS sg13g2_decap_8
* cell instance $201200 r0 *1 521.28,389.34
X$201200 VDD VSS sg13g2_decap_8
* cell instance $201201 r0 *1 531.36,389.34
X$201201 VDD VSS sg13g2_decap_8
* cell instance $201202 r0 *1 531.36,381.78
X$201202 VDD VSS sg13g2_decap_8
* cell instance $201203 r0 *1 521.28,381.78
X$201203 VDD VSS sg13g2_decap_8
* cell instance $201204 r0 *1 517.92,381.78
X$201204 VDD VSS sg13g2_decap_8
* cell instance $201205 r0 *1 524.64,389.34
X$201205 VDD VSS sg13g2_decap_8
* cell instance $201206 r0 *1 524.64,381.78
X$201206 VDD VSS sg13g2_decap_8
* cell instance $201207 r0 *1 548.16,389.34
X$201207 VDD VSS sg13g2_decap_8
* cell instance $201208 r0 *1 575.04,366.66
X$201208 VDD VSS sg13g2_decap_8
* cell instance $201209 r0 *1 571.68,366.66
X$201209 VDD VSS sg13g2_decap_8
* cell instance $201210 r0 *1 561.6,389.34
X$201210 VDD VSS sg13g2_decap_8
* cell instance $201211 r0 *1 588.48,374.22
X$201211 VDD VSS sg13g2_decap_8
* cell instance $201212 r0 *1 575.04,389.34
X$201212 VDD VSS sg13g2_decap_8
* cell instance $201213 r0 *1 585.12,381.78
X$201213 VDD VSS sg13g2_decap_8
* cell instance $201214 r0 *1 558.24,381.78
X$201214 VDD VSS sg13g2_decap_8
* cell instance $201215 r0 *1 564.96,389.34
X$201215 VDD VSS sg13g2_decap_8
* cell instance $201216 r0 *1 585.12,389.34
X$201216 VDD VSS sg13g2_decap_8
* cell instance $201217 r0 *1 581.76,389.34
X$201217 VDD VSS sg13g2_decap_8
* cell instance $201218 r0 *1 910.56,941.22
X$201218 VDD VSS sg13g2_decap_8
* cell instance $201219 r0 *1 977.76,948.78
X$201219 VDD VSS sg13g2_decap_8
* cell instance $201220 r0 *1 568.32,381.78
X$201220 VDD VSS sg13g2_decap_8
* cell instance $201221 r0 *1 571.68,381.78
X$201221 VDD VSS sg13g2_decap_8
* cell instance $201222 r0 *1 561.6,381.78
X$201222 VDD VSS sg13g2_decap_8
* cell instance $201223 r0 *1 910.56,933.66
X$201223 VDD VSS sg13g2_decap_8
* cell instance $201224 r0 *1 564.96,381.78
X$201224 VDD VSS sg13g2_decap_8
* cell instance $201225 r0 *1 588.48,381.78
X$201225 VDD VSS sg13g2_decap_8
* cell instance $201226 r0 *1 588.48,389.34
X$201226 VDD VSS sg13g2_decap_8
* cell instance $201227 r0 *1 575.04,381.78
X$201227 VDD VSS sg13g2_decap_8
* cell instance $201228 r0 *1 588.48,366.66
X$201228 VDD VSS sg13g2_decap_8
* cell instance $201229 r0 *1 568.32,389.34
X$201229 VDD VSS sg13g2_decap_8
* cell instance $201230 r0 *1 578.4,381.78
X$201230 VDD VSS sg13g2_decap_8
* cell instance $201231 r0 *1 578.4,389.34
X$201231 VDD VSS sg13g2_decap_8
* cell instance $201232 r0 *1 971.04,948.78
X$201232 VDD VSS sg13g2_decap_8
* cell instance $201233 r0 *1 927.36,948.78
X$201233 VDD VSS sg13g2_decap_8
* cell instance $201234 r0 *1 913.92,948.78
X$201234 VDD VSS sg13g2_decap_8
* cell instance $201235 r0 *1 917.28,948.78
X$201235 VDD VSS sg13g2_decap_8
* cell instance $201236 r0 *1 920.64,948.78
X$201236 VDD VSS sg13g2_decap_8
* cell instance $201237 r0 *1 924,948.78
X$201237 VDD VSS sg13g2_decap_8
* cell instance $201238 r0 *1 937.44,948.78
X$201238 VDD VSS sg13g2_decap_8
* cell instance $201239 r0 *1 940.8,948.78
X$201239 VDD VSS sg13g2_decap_8
* cell instance $201240 r0 *1 934.08,948.78
X$201240 VDD VSS sg13g2_decap_8
* cell instance $201241 r0 *1 581.76,366.66
X$201241 VDD VSS sg13g2_decap_8
* cell instance $201242 r0 *1 558.24,389.34
X$201242 VDD VSS sg13g2_decap_8
* cell instance $201243 r0 *1 561.6,374.22
X$201243 VDD VSS sg13g2_decap_8
* cell instance $201244 r0 *1 564.96,374.22
X$201244 VDD VSS sg13g2_decap_8
* cell instance $201245 r0 *1 910.56,926.1
X$201245 VDD VSS sg13g2_decap_8
* cell instance $201246 r0 *1 581.76,381.78
X$201246 VDD VSS sg13g2_decap_8
* cell instance $201247 r0 *1 558.24,366.66
X$201247 VDD VSS sg13g2_decap_8
* cell instance $201248 r0 *1 561.6,366.66
X$201248 VDD VSS sg13g2_decap_8
* cell instance $201249 r0 *1 585.12,374.22
X$201249 VDD VSS sg13g2_decap_8
* cell instance $201250 r0 *1 578.4,366.66
X$201250 VDD VSS sg13g2_decap_8
* cell instance $201251 r0 *1 571.68,374.22
X$201251 VDD VSS sg13g2_decap_8
* cell instance $201252 r0 *1 564.96,366.66
X$201252 VDD VSS sg13g2_decap_8
* cell instance $201253 r0 *1 568.32,366.66
X$201253 VDD VSS sg13g2_decap_8
* cell instance $201254 r0 *1 558.24,374.22
X$201254 VDD VSS sg13g2_decap_8
* cell instance $201255 r0 *1 575.04,374.22
X$201255 VDD VSS sg13g2_decap_8
* cell instance $201256 r0 *1 585.12,366.66
X$201256 VDD VSS sg13g2_decap_8
* cell instance $201257 r0 *1 501.12,389.34
X$201257 VDD VSS sg13g2_decap_8
* cell instance $201258 r0 *1 477.6,374.22
X$201258 VDD VSS sg13g2_decap_8
* cell instance $201259 r0 *1 484.32,366.66
X$201259 VDD VSS sg13g2_decap_8
* cell instance $201260 r0 *1 480.96,381.78
X$201260 VDD VSS sg13g2_decap_8
* cell instance $201261 r0 *1 981.12,963.9
X$201261 VDD VSS sg13g2_decap_8
* cell instance $201262 r0 *1 501.12,374.22
X$201262 VDD VSS sg13g2_decap_8
* cell instance $201263 r0 *1 497.76,389.34
X$201263 VDD VSS sg13g2_decap_8
* cell instance $201264 r0 *1 480.96,366.66
X$201264 VDD VSS sg13g2_decap_8
* cell instance $201265 r0 *1 494.4,366.66
X$201265 VDD VSS sg13g2_decap_8
* cell instance $201266 r0 *1 487.68,374.22
X$201266 VDD VSS sg13g2_decap_8
* cell instance $201267 r0 *1 480.96,374.22
X$201267 VDD VSS sg13g2_decap_8
* cell instance $201268 r0 *1 544.8,381.78
X$201268 VDD VSS sg13g2_decap_8
* cell instance $201269 r0 *1 977.76,963.9
X$201269 VDD VSS sg13g2_decap_8
* cell instance $201270 r0 *1 487.68,366.66
X$201270 VDD VSS sg13g2_decap_8
* cell instance $201271 r0 *1 491.04,366.66
X$201271 VDD VSS sg13g2_decap_8
* cell instance $201272 r0 *1 497.76,366.66
X$201272 VDD VSS sg13g2_decap_8
* cell instance $201273 r0 *1 591.84,366.66
X$201273 VDD VSS sg13g2_decap_8
* cell instance $201274 r0 *1 591.84,374.22
X$201274 VDD VSS sg13g2_decap_8
* cell instance $201275 r0 *1 591.84,381.78
X$201275 VDD VSS sg13g2_decap_8
* cell instance $201276 r0 *1 591.84,389.34
X$201276 VDD VSS sg13g2_decap_8
* cell instance $201277 r0 *1 551.52,366.66
X$201277 VDD VSS sg13g2_decap_8
* cell instance $201278 r0 *1 551.52,374.22
X$201278 VDD VSS sg13g2_decap_8
* cell instance $201279 r0 *1 974.4,963.9
X$201279 VDD VSS sg13g2_decap_8
* cell instance $201280 r0 *1 494.4,374.22
X$201280 VDD VSS sg13g2_decap_8
* cell instance $201281 r0 *1 917.28,963.9
X$201281 VDD VSS sg13g2_decap_8
* cell instance $201282 r0 *1 924,979.02
X$201282 VDD VSS sg13g2_decap_8
* cell instance $201283 r0 *1 920.64,979.02
X$201283 VDD VSS sg13g2_decap_8
* cell instance $201284 r0 *1 917.28,979.02
X$201284 VDD VSS sg13g2_decap_8
* cell instance $201285 r0 *1 511.2,374.22
X$201285 VDD VSS sg13g2_decap_8
* cell instance $201286 r0 *1 504.48,389.34
X$201286 VDD VSS sg13g2_decap_8
* cell instance $201287 r0 *1 504.48,374.22
X$201287 VDD VSS sg13g2_decap_8
* cell instance $201288 r0 *1 913.92,979.02
X$201288 VDD VSS sg13g2_decap_8
* cell instance $201289 r0 *1 927.36,971.46
X$201289 VDD VSS sg13g2_decap_8
* cell instance $201290 r0 *1 501.12,381.78
X$201290 VDD VSS sg13g2_decap_8
* cell instance $201291 r0 *1 484.32,389.34
X$201291 VDD VSS sg13g2_decap_8
* cell instance $201292 r0 *1 501.12,366.66
X$201292 VDD VSS sg13g2_decap_8
* cell instance $201293 r0 *1 944.16,979.02
X$201293 VDD VSS sg13g2_decap_8
* cell instance $201294 r0 *1 484.32,374.22
X$201294 VDD VSS sg13g2_decap_8
* cell instance $201295 r0 *1 940.8,979.02
X$201295 VDD VSS sg13g2_decap_8
* cell instance $201296 r0 *1 934.08,979.02
X$201296 VDD VSS sg13g2_decap_8
* cell instance $201297 r0 *1 937.44,979.02
X$201297 VDD VSS sg13g2_decap_8
* cell instance $201298 r0 *1 947.52,979.02
X$201298 VDD VSS sg13g2_decap_8
* cell instance $201299 r0 *1 930.72,956.34
X$201299 VDD VSS sg13g2_decap_8
* cell instance $201300 r0 *1 937.44,971.46
X$201300 VDD VSS sg13g2_decap_8
* cell instance $201301 r0 *1 940.8,971.46
X$201301 VDD VSS sg13g2_decap_8
* cell instance $201302 r0 *1 974.4,956.34
X$201302 VDD VSS sg13g2_decap_8
* cell instance $201303 r0 *1 487.68,381.78
X$201303 VDD VSS sg13g2_decap_8
* cell instance $201304 r0 *1 927.36,979.02
X$201304 VDD VSS sg13g2_decap_8
* cell instance $201305 r0 *1 534.72,381.78
X$201305 VDD VSS sg13g2_decap_8
* cell instance $201306 r0 *1 534.72,366.66
X$201306 VDD VSS sg13g2_decap_8
* cell instance $201307 r0 *1 548.16,374.22
X$201307 VDD VSS sg13g2_decap_8
* cell instance $201308 r0 *1 538.08,374.22
X$201308 VDD VSS sg13g2_decap_8
* cell instance $201309 r0 *1 534.72,374.22
X$201309 VDD VSS sg13g2_decap_8
* cell instance $201310 r0 *1 517.92,374.22
X$201310 VDD VSS sg13g2_decap_8
* cell instance $201311 r0 *1 977.76,979.02
X$201311 VDD VSS sg13g2_decap_8
* cell instance $201312 r0 *1 544.8,374.22
X$201312 VDD VSS sg13g2_decap_8
* cell instance $201313 r0 *1 541.44,374.22
X$201313 VDD VSS sg13g2_decap_8
* cell instance $201314 r0 *1 531.36,374.22
X$201314 VDD VSS sg13g2_decap_8
* cell instance $201315 r0 *1 528,374.22
X$201315 VDD VSS sg13g2_decap_8
* cell instance $201316 r0 *1 981.12,956.34
X$201316 VDD VSS sg13g2_decap_8
* cell instance $201317 r0 *1 521.28,374.22
X$201317 VDD VSS sg13g2_decap_8
* cell instance $201318 r0 *1 971.04,971.46
X$201318 VDD VSS sg13g2_decap_8
* cell instance $201319 r0 *1 974.4,971.46
X$201319 VDD VSS sg13g2_decap_8
* cell instance $201320 r0 *1 981.12,971.46
X$201320 VDD VSS sg13g2_decap_8
* cell instance $201321 r0 *1 971.04,979.02
X$201321 VDD VSS sg13g2_decap_8
* cell instance $201322 r0 *1 524.64,374.22
X$201322 VDD VSS sg13g2_decap_8
* cell instance $201323 r0 *1 541.44,389.34
X$201323 VDD VSS sg13g2_decap_8
* cell instance $201324 r0 *1 967.68,971.46
X$201324 VDD VSS sg13g2_decap_8
* cell instance $201325 r0 *1 538.08,389.34
X$201325 VDD VSS sg13g2_decap_8
* cell instance $201326 r0 *1 971.04,963.9
X$201326 VDD VSS sg13g2_decap_8
* cell instance $201327 r0 *1 538.08,381.78
X$201327 VDD VSS sg13g2_decap_8
* cell instance $201328 r0 *1 977.76,971.46
X$201328 VDD VSS sg13g2_decap_8
* cell instance $201329 r0 *1 977.76,956.34
X$201329 VDD VSS sg13g2_decap_8
* cell instance $201330 r0 *1 551.52,381.78
X$201330 VDD VSS sg13g2_decap_8
* cell instance $201331 r0 *1 960.96,956.34
X$201331 VDD VSS sg13g2_decap_8
* cell instance $201332 r0 *1 964.32,963.9
X$201332 VDD VSS sg13g2_decap_8
* cell instance $201333 r0 *1 554.88,381.78
X$201333 VDD VSS sg13g2_decap_8
* cell instance $201334 r0 *1 554.88,374.22
X$201334 VDD VSS sg13g2_decap_8
* cell instance $201335 r0 *1 954.24,963.9
X$201335 VDD VSS sg13g2_decap_8
* cell instance $201336 r0 *1 957.6,956.34
X$201336 VDD VSS sg13g2_decap_8
* cell instance $201337 r0 *1 967.68,963.9
X$201337 VDD VSS sg13g2_decap_8
* cell instance $201338 r0 *1 954.24,956.34
X$201338 VDD VSS sg13g2_decap_8
* cell instance $201339 r0 *1 554.88,366.66
X$201339 VDD VSS sg13g2_decap_8
* cell instance $201340 r0 *1 534.72,389.34
X$201340 VDD VSS sg13g2_decap_8
* cell instance $201341 r0 *1 554.88,389.34
X$201341 VDD VSS sg13g2_decap_8
* cell instance $201342 r0 *1 960.96,963.9
X$201342 VDD VSS sg13g2_decap_8
* cell instance $201343 r0 *1 964.32,956.34
X$201343 VDD VSS sg13g2_decap_8
* cell instance $201344 r0 *1 967.68,956.34
X$201344 VDD VSS sg13g2_decap_8
* cell instance $201345 r0 *1 957.6,979.02
X$201345 VDD VSS sg13g2_decap_8
* cell instance $201346 r0 *1 954.24,979.02
X$201346 VDD VSS sg13g2_decap_8
* cell instance $201347 r0 *1 960.96,979.02
X$201347 VDD VSS sg13g2_decap_8
* cell instance $201348 r0 *1 967.68,979.02
X$201348 VDD VSS sg13g2_decap_8
* cell instance $201349 r0 *1 964.32,979.02
X$201349 VDD VSS sg13g2_decap_8
* cell instance $201350 r0 *1 551.52,389.34
X$201350 VDD VSS sg13g2_decap_8
* cell instance $201351 r0 *1 974.4,979.02
X$201351 VDD VSS sg13g2_decap_8
* cell instance $201352 r0 *1 981.12,979.02
X$201352 VDD VSS sg13g2_decap_8
* cell instance $201353 r0 *1 957.6,963.9
X$201353 VDD VSS sg13g2_decap_8
* cell instance $201354 r0 *1 903.84,933.66
X$201354 VDD VSS sg13g2_decap_8
* cell instance $201355 r0 *1 907.2,933.66
X$201355 VDD VSS sg13g2_decap_8
* cell instance $201356 r0 *1 559.2,797.58
X$201356 VDD VSS sg13g2_decap_8
* cell instance $201357 r0 *1 555.84,797.58
X$201357 VDD VSS sg13g2_decap_8
* cell instance $201358 r0 *1 559.2,812.7
X$201358 VDD VSS sg13g2_decap_8
* cell instance $201359 r0 *1 562.56,805.14
X$201359 VDD VSS sg13g2_decap_8
* cell instance $201360 r0 *1 562.56,797.58
X$201360 VDD VSS sg13g2_decap_8
* cell instance $201361 r0 *1 565.92,805.14
X$201361 VDD VSS sg13g2_decap_8
* cell instance $201362 r0 *1 565.92,812.7
X$201362 VDD VSS sg13g2_decap_8
* cell instance $201363 r0 *1 582.72,797.58
X$201363 VDD VSS sg13g2_decap_8
* cell instance $201364 r0 *1 579.36,797.58
X$201364 VDD VSS sg13g2_decap_8
* cell instance $201365 r0 *1 897.12,948.78
X$201365 VDD VSS sg13g2_decap_8
* cell instance $201366 r0 *1 582.72,812.7
X$201366 VDD VSS sg13g2_decap_8
* cell instance $201367 r0 *1 572.64,812.7
X$201367 VDD VSS sg13g2_decap_8
* cell instance $201368 r0 *1 897.12,933.66
X$201368 VDD VSS sg13g2_decap_8
* cell instance $201369 r0 *1 572.64,805.14
X$201369 VDD VSS sg13g2_decap_8
* cell instance $201370 r0 *1 582.72,805.14
X$201370 VDD VSS sg13g2_decap_8
* cell instance $201371 r0 *1 589.44,797.58
X$201371 VDD VSS sg13g2_decap_8
* cell instance $201372 r0 *1 579.36,805.14
X$201372 VDD VSS sg13g2_decap_8
* cell instance $201373 r0 *1 890.4,926.1
X$201373 VDD VSS sg13g2_decap_8
* cell instance $201374 r0 *1 890.4,941.22
X$201374 VDD VSS sg13g2_decap_8
* cell instance $201375 r0 *1 576,805.14
X$201375 VDD VSS sg13g2_decap_8
* cell instance $201376 r0 *1 890.4,933.66
X$201376 VDD VSS sg13g2_decap_8
* cell instance $201377 r0 *1 576,797.58
X$201377 VDD VSS sg13g2_decap_8
* cell instance $201378 r0 *1 876.96,941.22
X$201378 VDD VSS sg13g2_decap_8
* cell instance $201379 r0 *1 883.68,933.66
X$201379 VDD VSS sg13g2_decap_8
* cell instance $201380 r0 *1 562.56,827.82
X$201380 VDD VSS sg13g2_decap_8
* cell instance $201381 r0 *1 559.2,820.26
X$201381 VDD VSS sg13g2_decap_8
* cell instance $201382 r0 *1 562.56,820.26
X$201382 VDD VSS sg13g2_decap_8
* cell instance $201383 r0 *1 887.04,941.22
X$201383 VDD VSS sg13g2_decap_8
* cell instance $201384 r0 *1 880.32,941.22
X$201384 VDD VSS sg13g2_decap_8
* cell instance $201385 r0 *1 900.48,933.66
X$201385 VDD VSS sg13g2_decap_8
* cell instance $201386 r0 *1 893.76,933.66
X$201386 VDD VSS sg13g2_decap_8
* cell instance $201387 r0 *1 893.76,941.22
X$201387 VDD VSS sg13g2_decap_8
* cell instance $201388 r0 *1 565.92,827.82
X$201388 VDD VSS sg13g2_decap_8
* cell instance $201389 r0 *1 562.56,812.7
X$201389 VDD VSS sg13g2_decap_8
* cell instance $201390 r0 *1 907.2,941.22
X$201390 VDD VSS sg13g2_decap_8
* cell instance $201391 r0 *1 897.12,941.22
X$201391 VDD VSS sg13g2_decap_8
* cell instance $201392 r0 *1 569.28,820.26
X$201392 VDD VSS sg13g2_decap_8
* cell instance $201393 r0 *1 569.28,812.7
X$201393 VDD VSS sg13g2_decap_8
* cell instance $201394 r0 *1 559.2,805.14
X$201394 VDD VSS sg13g2_decap_8
* cell instance $201395 r0 *1 569.28,805.14
X$201395 VDD VSS sg13g2_decap_8
* cell instance $201396 r0 *1 565.92,797.58
X$201396 VDD VSS sg13g2_decap_8
* cell instance $201397 r0 *1 569.28,797.58
X$201397 VDD VSS sg13g2_decap_8
* cell instance $201398 r0 *1 555.84,805.14
X$201398 VDD VSS sg13g2_decap_8
* cell instance $201399 r0 *1 555.84,812.7
X$201399 VDD VSS sg13g2_decap_8
* cell instance $201400 r0 *1 900.48,941.22
X$201400 VDD VSS sg13g2_decap_8
* cell instance $201401 r0 *1 903.84,941.22
X$201401 VDD VSS sg13g2_decap_8
* cell instance $201402 r0 *1 856.8,941.22
X$201402 VDD VSS sg13g2_decap_8
* cell instance $201403 r0 *1 853.44,933.66
X$201403 VDD VSS sg13g2_decap_8
* cell instance $201404 r0 *1 582.72,827.82
X$201404 VDD VSS sg13g2_decap_8
* cell instance $201405 r0 *1 850.08,933.66
X$201405 VDD VSS sg13g2_decap_8
* cell instance $201406 r0 *1 866.88,933.66
X$201406 VDD VSS sg13g2_decap_8
* cell instance $201407 r0 *1 856.8,933.66
X$201407 VDD VSS sg13g2_decap_8
* cell instance $201408 r0 *1 525.6,812.7
X$201408 VDD VSS sg13g2_decap_8
* cell instance $201409 r0 *1 549.12,812.7
X$201409 VDD VSS sg13g2_decap_8
* cell instance $201410 r0 *1 532.32,827.82
X$201410 VDD VSS sg13g2_decap_8
* cell instance $201411 r0 *1 545.76,812.7
X$201411 VDD VSS sg13g2_decap_8
* cell instance $201412 r0 *1 532.32,797.58
X$201412 VDD VSS sg13g2_decap_8
* cell instance $201413 r0 *1 589.44,805.14
X$201413 VDD VSS sg13g2_decap_8
* cell instance $201414 r0 *1 522.24,812.7
X$201414 VDD VSS sg13g2_decap_8
* cell instance $201415 r0 *1 866.88,926.1
X$201415 VDD VSS sg13g2_decap_8
* cell instance $201416 r0 *1 860.16,926.1
X$201416 VDD VSS sg13g2_decap_8
* cell instance $201417 r0 *1 853.44,926.1
X$201417 VDD VSS sg13g2_decap_8
* cell instance $201418 r0 *1 863.52,926.1
X$201418 VDD VSS sg13g2_decap_8
* cell instance $201419 r0 *1 856.8,926.1
X$201419 VDD VSS sg13g2_decap_8
* cell instance $201420 r0 *1 515.52,812.7
X$201420 VDD VSS sg13g2_decap_8
* cell instance $201421 r0 *1 518.88,812.7
X$201421 VDD VSS sg13g2_decap_8
* cell instance $201422 r0 *1 840,926.1
X$201422 VDD VSS sg13g2_decap_8
* cell instance $201423 r0 *1 836.64,926.1
X$201423 VDD VSS sg13g2_decap_8
* cell instance $201424 r0 *1 539.04,812.7
X$201424 VDD VSS sg13g2_decap_8
* cell instance $201425 r0 *1 850.08,941.22
X$201425 VDD VSS sg13g2_decap_8
* cell instance $201426 r0 *1 586.08,812.7
X$201426 VDD VSS sg13g2_decap_8
* cell instance $201427 r0 *1 586.08,805.14
X$201427 VDD VSS sg13g2_decap_8
* cell instance $201428 r0 *1 586.08,797.58
X$201428 VDD VSS sg13g2_decap_8
* cell instance $201429 r0 *1 576,812.7
X$201429 VDD VSS sg13g2_decap_8
* cell instance $201430 r0 *1 579.36,812.7
X$201430 VDD VSS sg13g2_decap_8
* cell instance $201431 r0 *1 843.36,933.66
X$201431 VDD VSS sg13g2_decap_8
* cell instance $201432 r0 *1 589.44,812.7
X$201432 VDD VSS sg13g2_decap_8
* cell instance $201433 r0 *1 572.64,797.58
X$201433 VDD VSS sg13g2_decap_8
* cell instance $201434 r0 *1 846.72,933.66
X$201434 VDD VSS sg13g2_decap_8
* cell instance $201435 r0 *1 572.64,820.26
X$201435 VDD VSS sg13g2_decap_8
* cell instance $201436 r0 *1 572.64,827.82
X$201436 VDD VSS sg13g2_decap_8
* cell instance $201437 r0 *1 866.88,941.22
X$201437 VDD VSS sg13g2_decap_8
* cell instance $201438 r0 *1 673.44,805.14
X$201438 VDD VSS sg13g2_decap_8
* cell instance $201439 r0 *1 576,820.26
X$201439 VDD VSS sg13g2_decap_8
* cell instance $201440 r0 *1 586.08,820.26
X$201440 VDD VSS sg13g2_decap_8
* cell instance $201441 r0 *1 582.72,820.26
X$201441 VDD VSS sg13g2_decap_8
* cell instance $201442 r0 *1 579.36,820.26
X$201442 VDD VSS sg13g2_decap_8
* cell instance $201443 r0 *1 853.44,941.22
X$201443 VDD VSS sg13g2_decap_8
* cell instance $201444 r0 *1 863.52,941.22
X$201444 VDD VSS sg13g2_decap_8
* cell instance $201445 r0 *1 860.16,941.22
X$201445 VDD VSS sg13g2_decap_8
* cell instance $201446 r0 *1 863.52,933.66
X$201446 VDD VSS sg13g2_decap_8
* cell instance $201447 r0 *1 589.44,820.26
X$201447 VDD VSS sg13g2_decap_8
* cell instance $201448 r0 *1 860.16,933.66
X$201448 VDD VSS sg13g2_decap_8
* cell instance $201449 r0 *1 586.08,827.82
X$201449 VDD VSS sg13g2_decap_8
* cell instance $201450 r0 *1 840,933.66
X$201450 VDD VSS sg13g2_decap_8
* cell instance $201451 r0 *1 619.68,782.46
X$201451 VDD VSS sg13g2_decap_8
* cell instance $201452 r0 *1 629.76,782.46
X$201452 VDD VSS sg13g2_decap_8
* cell instance $201453 r0 *1 623.04,782.46
X$201453 VDD VSS sg13g2_decap_8
* cell instance $201454 r0 *1 616.32,782.46
X$201454 VDD VSS sg13g2_decap_8
* cell instance $201455 r0 *1 609.6,782.46
X$201455 VDD VSS sg13g2_decap_8
* cell instance $201456 r0 *1 596.16,782.46
X$201456 VDD VSS sg13g2_decap_8
* cell instance $201457 r0 *1 602.88,782.46
X$201457 VDD VSS sg13g2_decap_8
* cell instance $201458 r0 *1 599.52,782.46
X$201458 VDD VSS sg13g2_decap_8
* cell instance $201459 r0 *1 606.24,782.46
X$201459 VDD VSS sg13g2_decap_8
* cell instance $201460 r0 *1 666.72,782.46
X$201460 VDD VSS sg13g2_decap_8
* cell instance $201461 r0 *1 646.56,782.46
X$201461 VDD VSS sg13g2_decap_8
* cell instance $201462 r0 *1 873.6,941.22
X$201462 VDD VSS sg13g2_decap_8
* cell instance $201463 r0 *1 663.36,782.46
X$201463 VDD VSS sg13g2_decap_8
* cell instance $201464 r0 *1 636.48,782.46
X$201464 VDD VSS sg13g2_decap_8
* cell instance $201465 r0 *1 670.08,782.46
X$201465 VDD VSS sg13g2_decap_8
* cell instance $201466 r0 *1 656.64,782.46
X$201466 VDD VSS sg13g2_decap_8
* cell instance $201467 r0 *1 639.84,782.46
X$201467 VDD VSS sg13g2_decap_8
* cell instance $201468 r0 *1 649.92,782.46
X$201468 VDD VSS sg13g2_decap_8
* cell instance $201469 r0 *1 643.2,782.46
X$201469 VDD VSS sg13g2_decap_8
* cell instance $201470 r0 *1 653.28,782.46
X$201470 VDD VSS sg13g2_decap_8
* cell instance $201471 r0 *1 525.6,790.02
X$201471 VDD VSS sg13g2_decap_8
* cell instance $201472 r0 *1 542.4,790.02
X$201472 VDD VSS sg13g2_decap_8
* cell instance $201473 r0 *1 532.32,790.02
X$201473 VDD VSS sg13g2_decap_8
* cell instance $201474 r0 *1 660,782.46
X$201474 VDD VSS sg13g2_decap_8
* cell instance $201475 r0 *1 596.16,805.14
X$201475 VDD VSS sg13g2_decap_8
* cell instance $201476 r0 *1 602.88,797.58
X$201476 VDD VSS sg13g2_decap_8
* cell instance $201477 r0 *1 596.16,797.58
X$201477 VDD VSS sg13g2_decap_8
* cell instance $201478 r0 *1 752.64,948.78
X$201478 VDD VSS sg13g2_decap_8
* cell instance $201479 r0 *1 602.88,805.14
X$201479 VDD VSS sg13g2_decap_8
* cell instance $201480 r0 *1 609.6,805.14
X$201480 VDD VSS sg13g2_decap_8
* cell instance $201481 r0 *1 752.64,979.02
X$201481 VDD VSS sg13g2_decap_8
* cell instance $201482 r0 *1 752.64,971.46
X$201482 VDD VSS sg13g2_decap_8
* cell instance $201483 r0 *1 752.64,926.1
X$201483 VDD VSS sg13g2_decap_8
* cell instance $201484 r0 *1 599.52,797.58
X$201484 VDD VSS sg13g2_decap_8
* cell instance $201485 r0 *1 599.52,805.14
X$201485 VDD VSS sg13g2_decap_8
* cell instance $201486 r0 *1 752.64,941.22
X$201486 VDD VSS sg13g2_decap_8
* cell instance $201487 r0 *1 626.4,797.58
X$201487 VDD VSS sg13g2_decap_8
* cell instance $201488 r0 *1 623.04,805.14
X$201488 VDD VSS sg13g2_decap_8
* cell instance $201489 r0 *1 619.68,805.14
X$201489 VDD VSS sg13g2_decap_8
* cell instance $201490 r0 *1 629.76,797.58
X$201490 VDD VSS sg13g2_decap_8
* cell instance $201491 r0 *1 616.32,805.14
X$201491 VDD VSS sg13g2_decap_8
* cell instance $201492 r0 *1 623.04,797.58
X$201492 VDD VSS sg13g2_decap_8
* cell instance $201493 r0 *1 626.4,805.14
X$201493 VDD VSS sg13g2_decap_8
* cell instance $201494 r0 *1 616.32,797.58
X$201494 VDD VSS sg13g2_decap_8
* cell instance $201495 r0 *1 629.76,805.14
X$201495 VDD VSS sg13g2_decap_8
* cell instance $201496 r0 *1 612.96,782.46
X$201496 VDD VSS sg13g2_decap_8
* cell instance $201497 r0 *1 626.4,782.46
X$201497 VDD VSS sg13g2_decap_8
* cell instance $201498 r0 *1 619.68,797.58
X$201498 VDD VSS sg13g2_decap_8
* cell instance $201499 r0 *1 552.48,797.58
X$201499 VDD VSS sg13g2_decap_8
* cell instance $201500 r0 *1 579.36,827.82
X$201500 VDD VSS sg13g2_decap_8
* cell instance $201501 r0 *1 907.2,926.1
X$201501 VDD VSS sg13g2_decap_8
* cell instance $201502 r0 *1 900.48,926.1
X$201502 VDD VSS sg13g2_decap_8
* cell instance $201503 r0 *1 576,827.82
X$201503 VDD VSS sg13g2_decap_8
* cell instance $201504 r0 *1 903.84,926.1
X$201504 VDD VSS sg13g2_decap_8
* cell instance $201505 r0 *1 589.44,827.82
X$201505 VDD VSS sg13g2_decap_8
* cell instance $201506 r0 *1 565.92,820.26
X$201506 VDD VSS sg13g2_decap_8
* cell instance $201507 r0 *1 555.84,827.82
X$201507 VDD VSS sg13g2_decap_8
* cell instance $201508 r0 *1 559.2,827.82
X$201508 VDD VSS sg13g2_decap_8
* cell instance $201509 r0 *1 897.12,926.1
X$201509 VDD VSS sg13g2_decap_8
* cell instance $201510 r0 *1 535.68,790.02
X$201510 VDD VSS sg13g2_decap_8
* cell instance $201511 r0 *1 887.04,926.1
X$201511 VDD VSS sg13g2_decap_8
* cell instance $201512 r0 *1 883.68,926.1
X$201512 VDD VSS sg13g2_decap_8
* cell instance $201513 r0 *1 876.96,926.1
X$201513 VDD VSS sg13g2_decap_8
* cell instance $201514 r0 *1 880.32,926.1
X$201514 VDD VSS sg13g2_decap_8
* cell instance $201515 r0 *1 569.28,827.82
X$201515 VDD VSS sg13g2_decap_8
* cell instance $201516 r0 *1 883.68,941.22
X$201516 VDD VSS sg13g2_decap_8
* cell instance $201517 r0 *1 887.04,933.66
X$201517 VDD VSS sg13g2_decap_8
* cell instance $201518 r0 *1 876.96,933.66
X$201518 VDD VSS sg13g2_decap_8
* cell instance $201519 r0 *1 555.84,820.26
X$201519 VDD VSS sg13g2_decap_8
* cell instance $201520 r0 *1 873.6,933.66
X$201520 VDD VSS sg13g2_decap_8
* cell instance $201521 r0 *1 880.32,933.66
X$201521 VDD VSS sg13g2_decap_8
* cell instance $201522 r0 *1 873.6,926.1
X$201522 VDD VSS sg13g2_decap_8
* cell instance $201523 r0 *1 528.96,790.02
X$201523 VDD VSS sg13g2_decap_8
* cell instance $201524 r0 *1 539.04,790.02
X$201524 VDD VSS sg13g2_decap_8
* cell instance $201525 r0 *1 522.24,790.02
X$201525 VDD VSS sg13g2_decap_8
* cell instance $201526 r0 *1 552.48,820.26
X$201526 VDD VSS sg13g2_decap_8
* cell instance $201527 r0 *1 515.52,790.02
X$201527 VDD VSS sg13g2_decap_8
* cell instance $201528 r0 *1 518.88,790.02
X$201528 VDD VSS sg13g2_decap_8
* cell instance $201529 r0 *1 552.48,782.46
X$201529 VDD VSS sg13g2_decap_8
* cell instance $201530 r0 *1 552.48,790.02
X$201530 VDD VSS sg13g2_decap_8
* cell instance $201531 r0 *1 559.2,790.02
X$201531 VDD VSS sg13g2_decap_8
* cell instance $201532 r0 *1 582.72,790.02
X$201532 VDD VSS sg13g2_decap_8
* cell instance $201533 r0 *1 572.64,790.02
X$201533 VDD VSS sg13g2_decap_8
* cell instance $201534 r0 *1 893.76,926.1
X$201534 VDD VSS sg13g2_decap_8
* cell instance $201535 r0 *1 579.36,790.02
X$201535 VDD VSS sg13g2_decap_8
* cell instance $201536 r0 *1 562.56,790.02
X$201536 VDD VSS sg13g2_decap_8
* cell instance $201537 r0 *1 555.84,790.02
X$201537 VDD VSS sg13g2_decap_8
* cell instance $201538 r0 *1 549.12,790.02
X$201538 VDD VSS sg13g2_decap_8
* cell instance $201539 r0 *1 576,790.02
X$201539 VDD VSS sg13g2_decap_8
* cell instance $201540 r0 *1 569.28,790.02
X$201540 VDD VSS sg13g2_decap_8
* cell instance $201541 r0 *1 565.92,790.02
X$201541 VDD VSS sg13g2_decap_8
* cell instance $201542 r0 *1 589.44,790.02
X$201542 VDD VSS sg13g2_decap_8
* cell instance $201543 r0 *1 552.48,827.82
X$201543 VDD VSS sg13g2_decap_8
* cell instance $201544 r0 *1 552.48,812.7
X$201544 VDD VSS sg13g2_decap_8
* cell instance $201545 r0 *1 552.48,805.14
X$201545 VDD VSS sg13g2_decap_8
* cell instance $201546 r0 *1 545.76,790.02
X$201546 VDD VSS sg13g2_decap_8
* cell instance $201547 r0 *1 586.08,790.02
X$201547 VDD VSS sg13g2_decap_8
* cell instance $201548 r0 *1 873.6,963.9
X$201548 VDD VSS sg13g2_decap_8
* cell instance $201549 r0 *1 883.68,963.9
X$201549 VDD VSS sg13g2_decap_8
* cell instance $201550 r0 *1 883.68,956.34
X$201550 VDD VSS sg13g2_decap_8
* cell instance $201551 r0 *1 887.04,956.34
X$201551 VDD VSS sg13g2_decap_8
* cell instance $201552 r0 *1 887.04,963.9
X$201552 VDD VSS sg13g2_decap_8
* cell instance $201553 r0 *1 876.96,963.9
X$201553 VDD VSS sg13g2_decap_8
* cell instance $201554 r0 *1 880.32,963.9
X$201554 VDD VSS sg13g2_decap_8
* cell instance $201555 r0 *1 579.36,782.46
X$201555 VDD VSS sg13g2_decap_8
* cell instance $201556 r0 *1 880.32,979.02
X$201556 VDD VSS sg13g2_decap_8
* cell instance $201557 r0 *1 876.96,979.02
X$201557 VDD VSS sg13g2_decap_8
* cell instance $201558 r0 *1 873.6,979.02
X$201558 VDD VSS sg13g2_decap_8
* cell instance $201559 r0 *1 528.96,812.7
X$201559 VDD VSS sg13g2_decap_8
* cell instance $201560 r0 *1 887.04,979.02
X$201560 VDD VSS sg13g2_decap_8
* cell instance $201561 r0 *1 883.68,979.02
X$201561 VDD VSS sg13g2_decap_8
* cell instance $201562 r0 *1 900.48,979.02
X$201562 VDD VSS sg13g2_decap_8
* cell instance $201563 r0 *1 582.72,782.46
X$201563 VDD VSS sg13g2_decap_8
* cell instance $201564 r0 *1 589.44,782.46
X$201564 VDD VSS sg13g2_decap_8
* cell instance $201565 r0 *1 569.28,782.46
X$201565 VDD VSS sg13g2_decap_8
* cell instance $201566 r0 *1 572.64,782.46
X$201566 VDD VSS sg13g2_decap_8
* cell instance $201567 r0 *1 903.84,979.02
X$201567 VDD VSS sg13g2_decap_8
* cell instance $201568 r0 *1 562.56,782.46
X$201568 VDD VSS sg13g2_decap_8
* cell instance $201569 r0 *1 907.2,979.02
X$201569 VDD VSS sg13g2_decap_8
* cell instance $201570 r0 *1 514.56,389.34
X$201570 VDD VSS sg13g2_decap_8
* cell instance $201571 r0 *1 555.84,782.46
X$201571 VDD VSS sg13g2_decap_8
* cell instance $201572 r0 *1 549.12,782.46
X$201572 VDD VSS sg13g2_decap_8
* cell instance $201573 r0 *1 525.6,782.46
X$201573 VDD VSS sg13g2_decap_8
* cell instance $201574 r0 *1 907.2,963.9
X$201574 VDD VSS sg13g2_decap_8
* cell instance $201575 r0 *1 545.76,782.46
X$201575 VDD VSS sg13g2_decap_8
* cell instance $201576 r0 *1 893.76,956.34
X$201576 VDD VSS sg13g2_decap_8
* cell instance $201577 r0 *1 897.12,956.34
X$201577 VDD VSS sg13g2_decap_8
* cell instance $201578 r0 *1 900.48,956.34
X$201578 VDD VSS sg13g2_decap_8
* cell instance $201579 r0 *1 900.48,963.9
X$201579 VDD VSS sg13g2_decap_8
* cell instance $201580 r0 *1 897.12,963.9
X$201580 VDD VSS sg13g2_decap_8
* cell instance $201581 r0 *1 522.24,782.46
X$201581 VDD VSS sg13g2_decap_8
* cell instance $201582 r0 *1 893.76,963.9
X$201582 VDD VSS sg13g2_decap_8
* cell instance $201583 r0 *1 565.92,782.46
X$201583 VDD VSS sg13g2_decap_8
* cell instance $201584 r0 *1 515.52,782.46
X$201584 VDD VSS sg13g2_decap_8
* cell instance $201585 r0 *1 528.96,782.46
X$201585 VDD VSS sg13g2_decap_8
* cell instance $201586 r0 *1 903.84,956.34
X$201586 VDD VSS sg13g2_decap_8
* cell instance $201587 r0 *1 903.84,963.9
X$201587 VDD VSS sg13g2_decap_8
* cell instance $201588 r0 *1 576,782.46
X$201588 VDD VSS sg13g2_decap_8
* cell instance $201589 r0 *1 586.08,782.46
X$201589 VDD VSS sg13g2_decap_8
* cell instance $201590 r0 *1 907.2,956.34
X$201590 VDD VSS sg13g2_decap_8
* cell instance $201591 r0 *1 559.2,782.46
X$201591 VDD VSS sg13g2_decap_8
* cell instance $201592 r0 *1 873.6,956.34
X$201592 VDD VSS sg13g2_decap_8
* cell instance $201593 r0 *1 880.32,956.34
X$201593 VDD VSS sg13g2_decap_8
* cell instance $201594 r0 *1 876.96,956.34
X$201594 VDD VSS sg13g2_decap_8
* cell instance $201595 r0 *1 518.88,782.46
X$201595 VDD VSS sg13g2_decap_8
* cell instance $201596 r0 *1 870.24,941.22
X$201596 VDD VSS sg13g2_decap_8
* cell instance $201597 r0 *1 870.24,933.66
X$201597 VDD VSS sg13g2_decap_8
* cell instance $201598 r0 *1 423.84,374.22
X$201598 VDD VSS sg13g2_decap_8
* cell instance $201599 r0 *1 427.2,366.66
X$201599 VDD VSS sg13g2_decap_8
* cell instance $201600 r0 *1 410.4,374.22
X$201600 VDD VSS sg13g2_decap_8
* cell instance $201601 r0 *1 430.56,366.66
X$201601 VDD VSS sg13g2_decap_8
* cell instance $201602 r0 *1 430.56,374.22
X$201602 VDD VSS sg13g2_decap_8
* cell instance $201603 r0 *1 427.2,374.22
X$201603 VDD VSS sg13g2_decap_8
* cell instance $201604 r0 *1 423.84,366.66
X$201604 VDD VSS sg13g2_decap_8
* cell instance $201605 r0 *1 413.76,381.78
X$201605 VDD VSS sg13g2_decap_8
* cell instance $201606 r0 *1 407.04,374.22
X$201606 VDD VSS sg13g2_decap_8
* cell instance $201607 r0 *1 514.56,381.78
X$201607 VDD VSS sg13g2_decap_8
* cell instance $201608 r0 *1 417.12,389.34
X$201608 VDD VSS sg13g2_decap_8
* cell instance $201609 r0 *1 420.48,389.34
X$201609 VDD VSS sg13g2_decap_8
* cell instance $201610 r0 *1 413.76,389.34
X$201610 VDD VSS sg13g2_decap_8
* cell instance $201611 r0 *1 410.4,366.66
X$201611 VDD VSS sg13g2_decap_8
* cell instance $201612 r0 *1 876.96,948.78
X$201612 VDD VSS sg13g2_decap_8
* cell instance $201613 r0 *1 873.6,948.78
X$201613 VDD VSS sg13g2_decap_8
* cell instance $201614 r0 *1 883.68,948.78
X$201614 VDD VSS sg13g2_decap_8
* cell instance $201615 r0 *1 880.32,948.78
X$201615 VDD VSS sg13g2_decap_8
* cell instance $201616 r0 *1 887.04,948.78
X$201616 VDD VSS sg13g2_decap_8
* cell instance $201617 r0 *1 900.48,948.78
X$201617 VDD VSS sg13g2_decap_8
* cell instance $201618 r0 *1 903.84,948.78
X$201618 VDD VSS sg13g2_decap_8
* cell instance $201619 r0 *1 407.04,389.34
X$201619 VDD VSS sg13g2_decap_8
* cell instance $201620 r0 *1 897.12,979.02
X$201620 VDD VSS sg13g2_decap_8
* cell instance $201621 r0 *1 514.56,374.22
X$201621 VDD VSS sg13g2_decap_8
* cell instance $201622 r0 *1 893.76,979.02
X$201622 VDD VSS sg13g2_decap_8
* cell instance $201623 r0 *1 514.56,366.66
X$201623 VDD VSS sg13g2_decap_8
* cell instance $201624 r0 *1 890.4,956.34
X$201624 VDD VSS sg13g2_decap_8
* cell instance $201625 r0 *1 903.84,971.46
X$201625 VDD VSS sg13g2_decap_8
* cell instance $201626 r0 *1 907.2,971.46
X$201626 VDD VSS sg13g2_decap_8
* cell instance $201627 r0 *1 897.12,971.46
X$201627 VDD VSS sg13g2_decap_8
* cell instance $201628 r0 *1 433.92,389.34
X$201628 VDD VSS sg13g2_decap_8
* cell instance $201629 r0 *1 883.68,971.46
X$201629 VDD VSS sg13g2_decap_8
* cell instance $201630 r0 *1 890.4,971.46
X$201630 VDD VSS sg13g2_decap_8
* cell instance $201631 r0 *1 433.92,366.66
X$201631 VDD VSS sg13g2_decap_8
* cell instance $201632 r0 *1 433.92,381.78
X$201632 VDD VSS sg13g2_decap_8
* cell instance $201633 r0 *1 876.96,971.46
X$201633 VDD VSS sg13g2_decap_8
* cell instance $201634 r0 *1 880.32,971.46
X$201634 VDD VSS sg13g2_decap_8
* cell instance $201635 r0 *1 873.6,971.46
X$201635 VDD VSS sg13g2_decap_8
* cell instance $201636 r0 *1 900.48,971.46
X$201636 VDD VSS sg13g2_decap_8
* cell instance $201637 r0 *1 890.4,979.02
X$201637 VDD VSS sg13g2_decap_8
* cell instance $201638 r0 *1 887.04,971.46
X$201638 VDD VSS sg13g2_decap_8
* cell instance $201639 r0 *1 890.4,963.9
X$201639 VDD VSS sg13g2_decap_8
* cell instance $201640 r0 *1 870.24,971.46
X$201640 VDD VSS sg13g2_decap_8
* cell instance $201641 r0 *1 870.24,979.02
X$201641 VDD VSS sg13g2_decap_8
* cell instance $201642 r0 *1 433.92,374.22
X$201642 VDD VSS sg13g2_decap_8
* cell instance $201643 r0 *1 870.24,926.1
X$201643 VDD VSS sg13g2_decap_8
* cell instance $201644 r0 *1 893.76,971.46
X$201644 VDD VSS sg13g2_decap_8
* cell instance $201645 r0 *1 860.16,956.34
X$201645 VDD VSS sg13g2_decap_8
* cell instance $201646 r0 *1 856.8,956.34
X$201646 VDD VSS sg13g2_decap_8
* cell instance $201647 r0 *1 860.16,963.9
X$201647 VDD VSS sg13g2_decap_8
* cell instance $201648 r0 *1 866.88,963.9
X$201648 VDD VSS sg13g2_decap_8
* cell instance $201649 r0 *1 863.52,963.9
X$201649 VDD VSS sg13g2_decap_8
* cell instance $201650 r0 *1 866.88,956.34
X$201650 VDD VSS sg13g2_decap_8
* cell instance $201651 r0 *1 518.88,827.82
X$201651 VDD VSS sg13g2_decap_8
* cell instance $201652 r0 *1 515.52,827.82
X$201652 VDD VSS sg13g2_decap_8
* cell instance $201653 r0 *1 522.24,820.26
X$201653 VDD VSS sg13g2_decap_8
* cell instance $201654 r0 *1 528.96,820.26
X$201654 VDD VSS sg13g2_decap_8
* cell instance $201655 r0 *1 525.6,820.26
X$201655 VDD VSS sg13g2_decap_8
* cell instance $201656 r0 *1 535.68,782.46
X$201656 VDD VSS sg13g2_decap_8
* cell instance $201657 r0 *1 843.36,963.9
X$201657 VDD VSS sg13g2_decap_8
* cell instance $201658 r0 *1 840,956.34
X$201658 VDD VSS sg13g2_decap_8
* cell instance $201659 r0 *1 518.88,820.26
X$201659 VDD VSS sg13g2_decap_8
* cell instance $201660 r0 *1 528.96,827.82
X$201660 VDD VSS sg13g2_decap_8
* cell instance $201661 r0 *1 846.72,956.34
X$201661 VDD VSS sg13g2_decap_8
* cell instance $201662 r0 *1 515.52,820.26
X$201662 VDD VSS sg13g2_decap_8
* cell instance $201663 r0 *1 525.6,827.82
X$201663 VDD VSS sg13g2_decap_8
* cell instance $201664 r0 *1 843.36,956.34
X$201664 VDD VSS sg13g2_decap_8
* cell instance $201665 r0 *1 522.24,827.82
X$201665 VDD VSS sg13g2_decap_8
* cell instance $201666 r0 *1 518.88,805.14
X$201666 VDD VSS sg13g2_decap_8
* cell instance $201667 r0 *1 518.88,797.58
X$201667 VDD VSS sg13g2_decap_8
* cell instance $201668 r0 *1 863.52,956.34
X$201668 VDD VSS sg13g2_decap_8
* cell instance $201669 r0 *1 532.32,805.14
X$201669 VDD VSS sg13g2_decap_8
* cell instance $201670 r0 *1 542.4,812.7
X$201670 VDD VSS sg13g2_decap_8
* cell instance $201671 r0 *1 846.72,926.1
X$201671 VDD VSS sg13g2_decap_8
* cell instance $201672 r0 *1 843.36,926.1
X$201672 VDD VSS sg13g2_decap_8
* cell instance $201673 r0 *1 535.68,812.7
X$201673 VDD VSS sg13g2_decap_8
* cell instance $201674 r0 *1 532.32,812.7
X$201674 VDD VSS sg13g2_decap_8
* cell instance $201675 r0 *1 532.32,820.26
X$201675 VDD VSS sg13g2_decap_8
* cell instance $201676 r0 *1 542.4,827.82
X$201676 VDD VSS sg13g2_decap_8
* cell instance $201677 r0 *1 539.04,820.26
X$201677 VDD VSS sg13g2_decap_8
* cell instance $201678 r0 *1 542.4,820.26
X$201678 VDD VSS sg13g2_decap_8
* cell instance $201679 r0 *1 535.68,820.26
X$201679 VDD VSS sg13g2_decap_8
* cell instance $201680 r0 *1 856.8,963.9
X$201680 VDD VSS sg13g2_decap_8
* cell instance $201681 r0 *1 549.12,820.26
X$201681 VDD VSS sg13g2_decap_8
* cell instance $201682 r0 *1 535.68,827.82
X$201682 VDD VSS sg13g2_decap_8
* cell instance $201683 r0 *1 549.12,827.82
X$201683 VDD VSS sg13g2_decap_8
* cell instance $201684 r0 *1 836.64,941.22
X$201684 VDD VSS sg13g2_decap_8
* cell instance $201685 r0 *1 545.76,820.26
X$201685 VDD VSS sg13g2_decap_8
* cell instance $201686 r0 *1 846.72,941.22
X$201686 VDD VSS sg13g2_decap_8
* cell instance $201687 r0 *1 850.08,926.1
X$201687 VDD VSS sg13g2_decap_8
* cell instance $201688 r0 *1 843.36,941.22
X$201688 VDD VSS sg13g2_decap_8
* cell instance $201689 r0 *1 539.04,827.82
X$201689 VDD VSS sg13g2_decap_8
* cell instance $201690 r0 *1 545.76,827.82
X$201690 VDD VSS sg13g2_decap_8
* cell instance $201691 r0 *1 836.64,933.66
X$201691 VDD VSS sg13g2_decap_8
* cell instance $201692 r0 *1 840,941.22
X$201692 VDD VSS sg13g2_decap_8
* cell instance $201693 r0 *1 542.4,797.58
X$201693 VDD VSS sg13g2_decap_8
* cell instance $201694 r0 *1 856.8,979.02
X$201694 VDD VSS sg13g2_decap_8
* cell instance $201695 r0 *1 866.88,979.02
X$201695 VDD VSS sg13g2_decap_8
* cell instance $201696 r0 *1 860.16,979.02
X$201696 VDD VSS sg13g2_decap_8
* cell instance $201697 r0 *1 539.04,782.46
X$201697 VDD VSS sg13g2_decap_8
* cell instance $201698 r0 *1 853.44,979.02
X$201698 VDD VSS sg13g2_decap_8
* cell instance $201699 r0 *1 850.08,979.02
X$201699 VDD VSS sg13g2_decap_8
* cell instance $201700 r0 *1 846.72,971.46
X$201700 VDD VSS sg13g2_decap_8
* cell instance $201701 r0 *1 853.44,971.46
X$201701 VDD VSS sg13g2_decap_8
* cell instance $201702 r0 *1 856.8,971.46
X$201702 VDD VSS sg13g2_decap_8
* cell instance $201703 r0 *1 836.64,971.46
X$201703 VDD VSS sg13g2_decap_8
* cell instance $201704 r0 *1 515.52,797.58
X$201704 VDD VSS sg13g2_decap_8
* cell instance $201705 r0 *1 542.4,782.46
X$201705 VDD VSS sg13g2_decap_8
* cell instance $201706 r0 *1 532.32,782.46
X$201706 VDD VSS sg13g2_decap_8
* cell instance $201707 r0 *1 843.36,971.46
X$201707 VDD VSS sg13g2_decap_8
* cell instance $201708 r0 *1 863.52,971.46
X$201708 VDD VSS sg13g2_decap_8
* cell instance $201709 r0 *1 860.16,971.46
X$201709 VDD VSS sg13g2_decap_8
* cell instance $201710 r0 *1 866.88,971.46
X$201710 VDD VSS sg13g2_decap_8
* cell instance $201711 r0 *1 850.08,956.34
X$201711 VDD VSS sg13g2_decap_8
* cell instance $201712 r0 *1 850.08,971.46
X$201712 VDD VSS sg13g2_decap_8
* cell instance $201713 r0 *1 850.08,963.9
X$201713 VDD VSS sg13g2_decap_8
* cell instance $201714 r0 *1 853.44,963.9
X$201714 VDD VSS sg13g2_decap_8
* cell instance $201715 r0 *1 853.44,956.34
X$201715 VDD VSS sg13g2_decap_8
* cell instance $201716 r0 *1 840,971.46
X$201716 VDD VSS sg13g2_decap_8
* cell instance $201717 r0 *1 840,963.9
X$201717 VDD VSS sg13g2_decap_8
* cell instance $201718 r0 *1 846.72,963.9
X$201718 VDD VSS sg13g2_decap_8
* cell instance $201719 r0 *1 836.64,956.34
X$201719 VDD VSS sg13g2_decap_8
* cell instance $201720 r0 *1 525.6,797.58
X$201720 VDD VSS sg13g2_decap_8
* cell instance $201721 r0 *1 522.24,797.58
X$201721 VDD VSS sg13g2_decap_8
* cell instance $201722 r0 *1 515.52,805.14
X$201722 VDD VSS sg13g2_decap_8
* cell instance $201723 r0 *1 528.96,805.14
X$201723 VDD VSS sg13g2_decap_8
* cell instance $201724 r0 *1 528.96,797.58
X$201724 VDD VSS sg13g2_decap_8
* cell instance $201725 r0 *1 525.6,805.14
X$201725 VDD VSS sg13g2_decap_8
* cell instance $201726 r0 *1 522.24,805.14
X$201726 VDD VSS sg13g2_decap_8
* cell instance $201727 r0 *1 836.64,963.9
X$201727 VDD VSS sg13g2_decap_8
* cell instance $201728 r0 *1 545.76,805.14
X$201728 VDD VSS sg13g2_decap_8
* cell instance $201729 r0 *1 843.36,979.02
X$201729 VDD VSS sg13g2_decap_8
* cell instance $201730 r0 *1 846.72,979.02
X$201730 VDD VSS sg13g2_decap_8
* cell instance $201731 r0 *1 535.68,797.58
X$201731 VDD VSS sg13g2_decap_8
* cell instance $201732 r0 *1 539.04,805.14
X$201732 VDD VSS sg13g2_decap_8
* cell instance $201733 r0 *1 545.76,797.58
X$201733 VDD VSS sg13g2_decap_8
* cell instance $201734 r0 *1 539.04,797.58
X$201734 VDD VSS sg13g2_decap_8
* cell instance $201735 r0 *1 840,979.02
X$201735 VDD VSS sg13g2_decap_8
* cell instance $201736 r0 *1 549.12,797.58
X$201736 VDD VSS sg13g2_decap_8
* cell instance $201737 r0 *1 549.12,805.14
X$201737 VDD VSS sg13g2_decap_8
* cell instance $201738 r0 *1 542.4,805.14
X$201738 VDD VSS sg13g2_decap_8
* cell instance $201739 r0 *1 535.68,805.14
X$201739 VDD VSS sg13g2_decap_8
* cell instance $201740 r0 *1 863.52,979.02
X$201740 VDD VSS sg13g2_decap_8
* cell instance $201741 r0 *1 836.64,979.02
X$201741 VDD VSS sg13g2_decap_8
.ENDS g1_core

* cell g1_sense
* pin vss
* pin iptat
* pin sense_p
* pin sense_n
* pin isense
* pin vref_buf
* pin vref
* pin vdd
.SUBCKT g1_sense vss iptat sense_p sense_n isense vref_buf vref vdd
* cell instance $98 r0 *1 13.5,69
X$98 vss iptat vped vdd vped \$34 g1_ota
* cell instance $99 r0 *1 13.5,124.2
X$99 vss iptat vref_buf vdd vref_buf vref g1_ota
* cell instance $1314 r0 *1 13.5,13.8
X$1314 vss iptat isense vdd \$30 \$31 g1_ota
* device instance $1 r0 *1 105,19.65 sg13_hv_nmos
M$1 vss iptat iptat vss sg13_hv_nmos L=1u W=3.3u AS=1.122p AD=1.122p PS=7.28u
+ PD=7.28u rfmode=0
* device instance $11 r0 *1 126.155,96.915 rppd
R$11 vss vref_buf vss rppd w=2u l=4065.1u ps=0u b=0 m=1
* device instance $15 r0 *1 153.655,96.915 rppd
R$15 sense_p vped vss rppd w=2u l=1610.7u ps=0u b=0 m=1
* device instance $30 r0 *1 183.655,96.915 rppd
R$30 sense_n isense vss rppd w=2u l=1610.7u ps=0u b=0 m=1
.ENDS g1_sense

* cell g1_dose_macro
* pin vss
* pin G_SHARED
* pin D_ELT
* pin D_STD
.SUBCKT g1_dose_macro vss G_SHARED D_ELT D_STD
* device instance $1 r0 *1 16.765,15 sg13_lv_nmos
M$1 vss G_SHARED D_STD vss sg13_lv_nmos L=0.13u W=3.98u AS=1.3532p AD=1.3532p
+ PS=8.64u PD=8.64u rfmode=0
* device instance $2 r0 *1 13.545,15 sg13_hv_nmos
M$2 vss G_SHARED D_ELT vss sg13_hv_nmos L=0.45u W=3.98u AS=1.3532p AD=1.3532p
+ PS=8.64u PD=8.64u rfmode=0
.ENDS g1_dose_macro

* cell g1_ls_up
* pin vss
* pin in
* pin out
* pin vdda
* pin vdd
.SUBCKT g1_ls_up vss in out vdda vdd
* device instance $1 r0 *1 7.665,8.95 sg13_hv_pmos
M$1 vdda \$4 out vdda sg13_hv_pmos L=0.45u W=3.9u AS=1.326p AD=1.326p PS=8.48u
+ PD=8.48u rfmode=0
* device instance $2 r0 *1 6.265,7.15 sg13_hv_pmos
M$2 vdda \$4 \$6 vdda sg13_hv_pmos L=0.45u W=0.3u AS=0.102p AD=0.102p PS=1.28u
+ PD=1.28u rfmode=0
* device instance $3 r0 *1 4.865,7.15 sg13_hv_pmos
M$3 vdda \$6 \$4 vdda sg13_hv_pmos L=0.45u W=0.3u AS=0.102p AD=0.102p PS=1.28u
+ PD=1.28u rfmode=0
* device instance $4 r0 *1 7.665,2.85 sg13_hv_nmos
M$4 vss \$4 out vss sg13_hv_nmos L=0.45u W=1.9u AS=0.646p AD=0.646p PS=4.48u
+ PD=4.48u rfmode=0
* device instance $5 r0 *1 4.865,3.8 sg13_hv_nmos
M$5 vss in \$4 vss sg13_hv_nmos L=0.45u W=3.8u AS=1.292p AD=1.292p PS=8.28u
+ PD=8.28u rfmode=0
* device instance $6 r0 *1 6.265,3.8 sg13_hv_nmos
M$6 vss \$3 \$6 vss sg13_hv_nmos L=0.45u W=3.8u AS=1.292p AD=1.292p PS=8.28u
+ PD=8.28u rfmode=0
* device instance $7 r0 *1 1.005,8 sg13_lv_pmos
M$7 vdd in \$3 vdd sg13_lv_pmos L=0.13u W=2u AS=0.68p AD=0.68p PS=4.68u
+ PD=4.68u rfmode=0
* device instance $8 r0 *1 1.005,2.4 sg13_lv_nmos
M$8 vss in \$3 vss sg13_lv_nmos L=0.13u W=1u AS=0.34p AD=0.34p PS=2.68u
+ PD=2.68u rfmode=0
.ENDS g1_ls_up

* cell g1_t2f
* pin vss
* pin mode
* pin vref
* pin vdd
* pin pcasc
* pin pbias
* pin en
* pin fout
* pin vdd12
.SUBCKT g1_t2f vss mode vref vdd pcasc pbias en fout vdd12
* device instance $2 r0 *1 82.595,3.995 rppd
R$2 vss vr vss rppd w=0.5u l=245u ps=0u b=0 m=1
* device instance $11 r0 *1 56.59,40 sg13_hv_nmos
M$11 vref moden vth vss sg13_hv_nmos L=0.5u W=4u AS=1.36p AD=0.76p PS=8.68u
+ PD=4.38u rfmode=0
* device instance $12 r0 *1 57.47,40 sg13_hv_nmos
M$12 vth mode vr vss sg13_hv_nmos L=0.5u W=4u AS=0.76p AD=1.36p PS=4.38u
+ PD=8.68u rfmode=0
* device instance $13 r0 *1 18.56,40 sg13_hv_nmos
M$13 vss d1g cap1 vss sg13_hv_nmos L=0.5u W=4u AS=1.36p AD=1.36p PS=8.68u
+ PD=8.68u rfmode=0
* device instance $14 r0 *1 48.56,40 sg13_hv_nmos
M$14 vss d2g cap2 vss sg13_hv_nmos L=0.5u W=4u AS=1.36p AD=1.36p PS=8.68u
+ PD=8.68u rfmode=0
* device instance $15 r0 *1 18.56,46 sg13_hv_pmos
M$15 isrc d1g cap1 vdd sg13_hv_pmos L=0.5u W=4u AS=1.36p AD=1.36p PS=8.68u
+ PD=8.68u rfmode=0
* device instance $16 r0 *1 48.56,46 sg13_hv_pmos
M$16 isrc d2g cap2 vdd sg13_hv_pmos L=0.5u W=4u AS=1.36p AD=1.36p PS=8.68u
+ PD=8.68u rfmode=0
* device instance $17 r0 *1 34.91,95.2 sg13_hv_pmos
M$17 vdd c2 rn vdd sg13_hv_pmos L=0.5u W=4u AS=1.36p AD=1.36p PS=8.68u PD=8.68u
+ rfmode=0
* device instance $18 r0 *1 15.39,95.2 sg13_hv_pmos
M$18 vdd c1 sn vdd sg13_hv_pmos L=0.5u W=4u AS=1.36p AD=1.36p PS=8.68u PD=8.68u
+ rfmode=0
* device instance $19 r0 *1 60.59,38.5 sg13_hv_nmos
M$19 vss mode moden vss sg13_hv_nmos L=0.5u W=1u AS=0.34p AD=0.34p PS=2.68u
+ PD=2.68u rfmode=0
* device instance $20 r0 *1 33.13,88.7 sg13_hv_nmos
M$20 vss ob2 c2 vss sg13_hv_nmos L=0.5u W=1u AS=0.34p AD=0.34p PS=2.68u
+ PD=2.68u rfmode=0
* device instance $21 r0 *1 28.69,88.7 sg13_hv_nmos
M$21 vss d2g a vss sg13_hv_nmos L=0.5u W=1u AS=0.34p AD=0.34p PS=2.68u PD=2.68u
+ rfmode=0
* device instance $22 r0 *1 13.61,88.7 sg13_hv_nmos
M$22 vss ob1 c1 vss sg13_hv_nmos L=0.5u W=1u AS=0.34p AD=0.34p PS=2.68u
+ PD=2.68u rfmode=0
* device instance $23 r0 *1 28.69,94.2 sg13_hv_pmos
M$23 vdd d2g a vdd sg13_hv_pmos L=0.5u W=2u AS=0.68p AD=0.68p PS=4.68u PD=4.68u
+ rfmode=0
* device instance $24 r0 *1 33.13,94.2 sg13_hv_pmos
M$24 vdd ob2 c2 vdd sg13_hv_pmos L=0.5u W=2u AS=0.68p AD=0.68p PS=4.68u
+ PD=4.68u rfmode=0
* device instance $25 r0 *1 13.61,94.2 sg13_hv_pmos
M$25 vdd ob1 c1 vdd sg13_hv_pmos L=0.5u W=2u AS=0.68p AD=0.68p PS=4.68u
+ PD=4.68u rfmode=0
* device instance $26 r0 *1 60.59,45 sg13_hv_pmos
M$26 vdd mode moden vdd sg13_hv_pmos L=0.5u W=2u AS=0.68p AD=0.68p PS=4.68u
+ PD=4.68u rfmode=0
* device instance $27 r0 *1 6.55,67.57 npn13G2
Q$27 vss vss vss vss npn13G2 we=70n le=900n Nx=1 m=2
* device instance $29 r0 *1 19.15,67.57 npn13G2
Q$29 cb1 cap1 tail1 vss npn13G2 we=70n le=900n Nx=1 m=1
* device instance $30 r0 *1 31.75,67.57 npn13G2
Q$30 ca2 vth tail2 vss npn13G2 we=70n le=900n Nx=1 m=1
* device instance $31 r0 *1 25.45,67.57 npn13G2
Q$31 cb2 cap2 tail2 vss npn13G2 we=70n le=900n Nx=1 m=1
* device instance $32 r0 *1 12.85,67.57 npn13G2
Q$32 ca1 vth tail1 vss npn13G2 we=70n le=900n Nx=1 m=1
* device instance $33 r0 *1 17.26,60.5 sg13_hv_nmos
M$33 vss nbias tail1 vss sg13_hv_nmos L=2u W=20u AS=5.3p AD=5.3p PS=31.06u
+ PD=31.06u rfmode=0
* device instance $35 r0 *1 29.86,60.5 sg13_hv_nmos
M$35 vss nbias tail2 vss sg13_hv_nmos L=2u W=20u AS=5.3p AD=5.3p PS=31.06u
+ PD=31.06u rfmode=0
* device instance $37 r0 *1 24.75,60.5 sg13_hv_nmos
M$37 vss nbias nbias vss sg13_hv_nmos L=2u W=10u AS=3.4p AD=3.4p PS=20.68u
+ PD=20.68u rfmode=0
* device instance $38 r0 *1 14.61,75.4 sg13_hv_nmos
M$38 ca1 vcg oa1 vss sg13_hv_nmos L=1u W=4u AS=1.06p AD=1.06p PS=7.06u PD=7.06u
+ rfmode=0
* device instance $40 r0 *1 33.51,75.4 sg13_hv_nmos
M$40 ca2 vcg oa2 vss sg13_hv_nmos L=1u W=4u AS=1.06p AD=1.06p PS=7.06u PD=7.06u
+ rfmode=0
* device instance $42 r0 *1 27.21,75.4 sg13_hv_nmos
M$42 cb2 vcg ob2 vss sg13_hv_nmos L=1u W=4u AS=1.06p AD=1.06p PS=7.06u PD=7.06u
+ rfmode=0
* device instance $44 r0 *1 20.91,75.4 sg13_hv_nmos
M$44 cb1 vcg ob1 vss sg13_hv_nmos L=1u W=4u AS=1.06p AD=1.06p PS=7.06u PD=7.06u
+ rfmode=0
* device instance $46 r0 *1 18.47,75.65 sg13_hv_nmos
M$46 ca1 nbias vss vss sg13_hv_nmos L=2u W=0.5u AS=0.17p AD=0.17p PS=1.68u
+ PD=1.68u rfmode=0
* device instance $47 r0 *1 31.07,75.65 sg13_hv_nmos
M$47 cb2 nbias vss vss sg13_hv_nmos L=2u W=0.5u AS=0.17p AD=0.17p PS=1.68u
+ PD=1.68u rfmode=0
* device instance $48 r0 *1 24.77,75.65 sg13_hv_nmos
M$48 cb1 nbias vss vss sg13_hv_nmos L=2u W=0.5u AS=0.17p AD=0.17p PS=1.68u
+ PD=1.68u rfmode=0
* device instance $49 r0 *1 37.37,75.65 sg13_hv_nmos
M$49 ca2 nbias vss vss sg13_hv_nmos L=2u W=0.5u AS=0.17p AD=0.17p PS=1.68u
+ PD=1.68u rfmode=0
* device instance $50 r0 *1 20.91,80 sg13_hv_pmos
M$50 vdd oa1 ob1 vdd sg13_hv_pmos L=1u W=4u AS=1.36p AD=1.36p PS=8.68u PD=8.68u
+ rfmode=0
* device instance $51 r0 *1 14.61,80 sg13_hv_pmos
M$51 vdd oa1 oa1 vdd sg13_hv_pmos L=1u W=4u AS=1.36p AD=1.36p PS=8.68u PD=8.68u
+ rfmode=0
* device instance $52 r0 *1 27.21,80 sg13_hv_pmos
M$52 vdd oa2 ob2 vdd sg13_hv_pmos L=1u W=4u AS=1.36p AD=1.36p PS=8.68u PD=8.68u
+ rfmode=0
* device instance $53 r0 *1 33.51,80 sg13_hv_pmos
M$53 vdd oa2 oa2 vdd sg13_hv_pmos L=1u W=4u AS=1.36p AD=1.36p PS=8.68u PD=8.68u
+ rfmode=0
* device instance $54 r0 *1 15.39,89.2 sg13_hv_nmos
M$54 vss c1 sn vss sg13_hv_nmos L=0.5u W=2u AS=0.68p AD=0.68p PS=4.68u PD=4.68u
+ rfmode=0
* device instance $55 r0 *1 34.91,89.2 sg13_hv_nmos
M$55 vss c2 rn vss sg13_hv_nmos L=0.5u W=2u AS=0.68p AD=0.68p PS=4.68u PD=4.68u
+ rfmode=0
* device instance $56 r0 *1 17.17,89.2 sg13_hv_nmos
M$56 vss en \$I775 vss sg13_hv_nmos L=0.5u W=2u AS=0.68p AD=0.38p PS=4.68u
+ PD=2.38u rfmode=0
* device instance $57 r0 *1 18.05,89.2 sg13_hv_nmos
M$57 \$I775 qn d1g vss sg13_hv_nmos L=0.5u W=2u AS=0.38p AD=0.68p PS=2.38u
+ PD=4.68u rfmode=0
* device instance $58 r0 *1 30.47,89.2 sg13_hv_nmos
M$58 lsa a vss vss sg13_hv_nmos L=0.5u W=2u AS=0.68p AD=0.38p PS=4.68u PD=2.38u
+ rfmode=0
* device instance $59 r0 *1 31.35,89.2 sg13_hv_nmos
M$59 vss d2g lsb vss sg13_hv_nmos L=0.5u W=2u AS=0.38p AD=0.68p PS=2.38u
+ PD=4.68u rfmode=0
* device instance $60 r0 *1 22.49,89.2 sg13_hv_nmos
M$60 vss qn \$I776 vss sg13_hv_nmos L=0.5u W=2u AS=0.68p AD=0.38p PS=4.68u
+ PD=2.38u rfmode=0
* device instance $61 r0 *1 23.37,89.2 sg13_hv_nmos
M$61 \$I776 sn q vss sg13_hv_nmos L=0.5u W=2u AS=0.38p AD=0.68p PS=2.38u
+ PD=4.68u rfmode=0
* device instance $62 r0 *1 19.83,89.2 sg13_hv_nmos
M$62 vss en \$I774 vss sg13_hv_nmos L=0.5u W=2u AS=0.68p AD=0.38p PS=4.68u
+ PD=2.38u rfmode=0
* device instance $63 r0 *1 20.71,89.2 sg13_hv_nmos
M$63 \$I774 q d2g vss sg13_hv_nmos L=0.5u W=2u AS=0.38p AD=0.68p PS=2.38u
+ PD=4.68u rfmode=0
* device instance $64 r0 *1 22.49,94.2 sg13_hv_pmos
M$64 vdd qn q vdd sg13_hv_pmos L=0.5u W=2u AS=0.68p AD=0.38p PS=4.68u PD=2.38u
+ rfmode=0
* device instance $65 r0 *1 23.37,94.2 sg13_hv_pmos
M$65 q sn vdd vdd sg13_hv_pmos L=0.5u W=2u AS=0.38p AD=0.68p PS=2.38u PD=4.68u
+ rfmode=0
* device instance $66 r0 *1 19.83,94.2 sg13_hv_pmos
M$66 vdd en d2g vdd sg13_hv_pmos L=0.5u W=2u AS=0.68p AD=0.38p PS=4.68u
+ PD=2.38u rfmode=0
* device instance $67 r0 *1 20.71,94.2 sg13_hv_pmos
M$67 d2g q vdd vdd sg13_hv_pmos L=0.5u W=2u AS=0.38p AD=0.68p PS=2.38u PD=4.68u
+ rfmode=0
* device instance $68 r0 *1 17.17,94.2 sg13_hv_pmos
M$68 vdd en d1g vdd sg13_hv_pmos L=0.5u W=2u AS=0.68p AD=0.38p PS=4.68u
+ PD=2.38u rfmode=0
* device instance $69 r0 *1 18.05,94.2 sg13_hv_pmos
M$69 d1g qn vdd vdd sg13_hv_pmos L=0.5u W=2u AS=0.38p AD=0.68p PS=2.38u
+ PD=4.68u rfmode=0
* device instance $70 r0 *1 25.15,89.7 sg13_hv_nmos
M$70 vss en \$I787 vss sg13_hv_nmos L=0.5u W=3u AS=1.02p AD=0.57p PS=6.68u
+ PD=3.38u rfmode=0
* device instance $71 r0 *1 26.03,89.7 sg13_hv_nmos
M$71 \$I787 q \$I788 vss sg13_hv_nmos L=0.5u W=3u AS=0.57p AD=0.57p PS=3.38u
+ PD=3.38u rfmode=0
* device instance $72 r0 *1 26.91,89.7 sg13_hv_nmos
M$72 \$I788 rn qn vss sg13_hv_nmos L=0.5u W=3u AS=0.57p AD=1.02p PS=3.38u
+ PD=6.68u rfmode=0
* device instance $73 r0 *1 25.15,94.2 sg13_hv_pmos
M$73 vdd en qn vdd sg13_hv_pmos L=0.5u W=2u AS=0.68p AD=0.38p PS=4.68u PD=2.38u
+ rfmode=0
* device instance $74 r0 *1 26.03,94.2 sg13_hv_pmos
M$74 qn q vdd vdd sg13_hv_pmos L=0.5u W=2u AS=0.38p AD=0.38p PS=2.38u PD=2.38u
+ rfmode=0
* device instance $75 r0 *1 26.91,94.2 sg13_hv_pmos
M$75 vdd rn qn vdd sg13_hv_pmos L=0.5u W=2u AS=0.38p AD=0.68p PS=2.38u PD=4.68u
+ rfmode=0
* device instance $76 r0 *1 40.49,91.45 sg13_lv_pmos
M$76 lsa lsb vdd12 vdd12 sg13_lv_pmos L=0.3u W=0.5u AS=0.17p AD=0.095p PS=1.68u
+ PD=0.88u rfmode=0
* device instance $77 r0 *1 41.17,91.45 sg13_lv_pmos
M$77 vdd12 lsa lsb vdd12 sg13_lv_pmos L=0.3u W=0.5u AS=0.095p AD=0.17p PS=0.88u
+ PD=1.68u rfmode=0
* device instance $78 r0 *1 43.405,88.45 sg13_lv_nmos
M$78 vss lsb fon vss sg13_lv_nmos L=0.13u W=0.5u AS=0.17p AD=0.17p PS=1.68u
+ PD=1.68u rfmode=0
* device instance $79 r0 *1 43.405,91.7 sg13_lv_pmos
M$79 vdd12 lsb fon vdd12 sg13_lv_pmos L=0.13u W=1u AS=0.34p AD=0.34p PS=2.68u
+ PD=2.68u rfmode=0
* device instance $80 r0 *1 44.815,88.7 sg13_lv_nmos
M$80 vss fon fout vss sg13_lv_nmos L=0.13u W=1u AS=0.34p AD=0.34p PS=2.68u
+ PD=2.68u rfmode=0
* device instance $81 r0 *1 54.34,73.5 sg13_hv_pmos
M$81 vdd pbias do vdd sg13_hv_pmos L=4u W=10u AS=3.4p AD=3.4p PS=20.68u
+ PD=20.68u rfmode=0
* device instance $82 r0 *1 74.56,73.5 sg13_hv_pmos
M$82 vdd pbias vcg vdd sg13_hv_pmos L=4u W=10u AS=3.4p AD=3.4p PS=20.68u
+ PD=20.68u rfmode=0
* device instance $83 r0 *1 69.28,73.5 sg13_hv_pmos
M$83 vdd pbias db vdd sg13_hv_pmos L=4u W=10u AS=3.4p AD=3.4p PS=20.68u
+ PD=20.68u rfmode=0
* device instance $84 r0 *1 71.74,60.5 sg13_hv_pmos
M$84 db pcasc nbias db sg13_hv_pmos L=4u W=10u AS=3.4p AD=3.4p PS=20.68u
+ PD=20.68u rfmode=0
* device instance $85 r0 *1 51.84,60.5 sg13_hv_pmos
M$85 do pcasc isrc do sg13_hv_pmos L=4u W=10u AS=3.4p AD=3.4p PS=20.68u
+ PD=20.68u rfmode=0
* device instance $86 r0 *1 59.62,73.5 sg13_hv_pmos
M$86 vdd pbias dr vdd sg13_hv_pmos L=4u W=20u AS=5.3p AD=5.3p PS=31.06u
+ PD=31.06u rfmode=0
* device instance $88 r0 *1 59.62,60.5 sg13_hv_pmos
M$88 vr pcasc dr dr sg13_hv_pmos L=4u W=20u AS=5.3p AD=5.3p PS=31.06u PD=31.06u
+ rfmode=0
* device instance $90 r0 *1 78.56,56.5 sg13_hv_pmos
M$90 vcg vth vss vcg sg13_hv_pmos L=2u W=2u AS=0.68p AD=0.68p PS=4.68u PD=4.68u
+ rfmode=0
* device instance $91 r0 *1 5,4.2 cap_cmim
C$91 cap1 vss cap_cmim w=28u l=28u A=784p P=112u m=1
* device instance $92 r0 *1 35,4.2 cap_cmim
C$92 cap2 vss cap_cmim w=28u l=28u A=784p P=112u m=1
* device instance $93 r0 *1 44.815,92.2 sg13_lv_pmos
M$93 vdd12 fon fout vdd12 sg13_lv_pmos L=0.13u W=2u AS=0.68p AD=0.68p PS=4.68u
+ PD=4.68u rfmode=0
.ENDS g1_t2f

* cell g1_dut_macro
* pin vss
* pin HBT_B
* pin HBT_E
* pin HBT_C
.SUBCKT g1_dut_macro vss HBT_B HBT_E HBT_C
* device instance $1 r0 *1 13.475,14.57 npn13G2
Q$1 HBT_C HBT_B HBT_E vss npn13G2 we=70n le=900n Nx=1 m=1
.ENDS g1_dut_macro

* cell g1_osc
* pin VSS
* pin trim[0]
* pin trim[1]
* pin trim[2]
* pin trim[3]
* pin en
* pin osc_clk
* pin VDD
.SUBCKT g1_osc VSS trim[0] trim[1] trim[2] trim[3] en osc_clk VDD
* device instance $1 r0 *1 79.295,12 sg13_lv_nmos
M$1 VSS \$20 vb VSS sg13_lv_nmos L=0.13u W=4u AS=1.36p AD=1.36p PS=8.68u
+ PD=8.68u rfmode=0
* device instance $2 r0 *1 77.765,12 sg13_lv_nmos
M$2 VSS \$19 va VSS sg13_lv_nmos L=0.13u W=4u AS=1.36p AD=1.36p PS=8.68u
+ PD=8.68u rfmode=0
* device instance $3 r0 *1 76.235,12 sg13_lv_nmos
M$3 VSS trim[3] \$40 VSS sg13_lv_nmos L=0.13u W=4u AS=1.36p AD=1.36p PS=8.68u
+ PD=8.68u rfmode=0
* device instance $4 r0 *1 90.005,10.5 sg13_lv_nmos
M$4 \$45 \$22 \$20 VSS sg13_lv_nmos L=0.13u W=1u AS=0.34p AD=0.34p PS=2.68u
+ PD=2.68u rfmode=0
* device instance $5 r0 *1 96.125,10.25 sg13_lv_nmos
M$5 VSS \$46 osc_clk VSS sg13_lv_nmos L=0.13u W=0.5u AS=0.17p AD=0.17p PS=1.68u
+ PD=1.68u rfmode=0
* device instance $6 r0 *1 52.205,10.25 sg13_lv_nmos
M$6 VSS \$25 \$26 VSS sg13_lv_nmos L=0.13u W=0.5u AS=0.17p AD=0.17p PS=1.68u
+ PD=1.68u rfmode=0
* device instance $7 r0 *1 55.45,11 sg13_lv_nmos
M$7 VSS vbn \$28 VSS sg13_lv_nmos L=0.5u W=2u AS=0.68p AD=0.68p PS=4.68u
+ PD=4.68u rfmode=0
* device instance $8 r0 *1 94.595,10.25 sg13_lv_nmos
M$8 VSS \$44 \$46 VSS sg13_lv_nmos L=0.13u W=0.5u AS=0.17p AD=0.17p PS=1.68u
+ PD=1.68u rfmode=0
* device instance $9 r0 *1 91.535,10.5 sg13_lv_nmos
M$9 VSS en \$45 VSS sg13_lv_nmos L=0.13u W=1u AS=0.34p AD=0.34p PS=2.68u
+ PD=2.68u rfmode=0
* device instance $10 r0 *1 93.065,10.25 sg13_lv_nmos
M$10 VSS \$44 \$19 VSS sg13_lv_nmos L=0.13u W=0.5u AS=0.17p AD=0.17p PS=1.68u
+ PD=1.68u rfmode=0
* device instance $11 r0 *1 85.415,10.25 sg13_lv_nmos
M$11 VSS \$22 \$44 VSS sg13_lv_nmos L=0.13u W=0.5u AS=0.17p AD=0.17p PS=1.68u
+ PD=1.68u rfmode=0
* device instance $12 r0 *1 63.81,11 sg13_lv_nmos
M$12 VSS vbn vbn VSS sg13_lv_nmos L=0.5u W=2u AS=0.68p AD=0.68p PS=4.68u
+ PD=4.68u rfmode=0
* device instance $13 r0 *1 86.945,10.25 sg13_lv_nmos
M$13 VSS \$32 \$22 VSS sg13_lv_nmos L=0.13u W=0.5u AS=0.17p AD=0.17p PS=1.68u
+ PD=1.68u rfmode=0
* device instance $14 r0 *1 50.59,12 sg13_lv_nmos
M$14 \$23 vth \$25 VSS sg13_lv_nmos L=0.3u W=4u AS=1.36p AD=1.36p PS=8.68u
+ PD=8.68u rfmode=0
* device instance $15 r0 *1 62.095,10.25 sg13_lv_nmos
M$15 VSS \$31 \$32 VSS sg13_lv_nmos L=0.13u W=0.5u AS=0.17p AD=0.17p PS=1.68u
+ PD=1.68u rfmode=0
* device instance $16 r0 *1 58.95,12 sg13_lv_nmos
M$16 \$28 vth \$30 VSS sg13_lv_nmos L=0.3u W=4u AS=1.36p AD=1.36p PS=8.68u
+ PD=8.68u rfmode=0
* device instance $17 r0 *1 47.09,11 sg13_lv_nmos
M$17 VSS vbn \$23 VSS sg13_lv_nmos L=0.5u W=2u AS=0.68p AD=0.68p PS=4.68u
+ PD=4.68u rfmode=0
* device instance $18 r0 *1 53.735,10.25 sg13_lv_nmos
M$18 VSS \$26 \$27 VSS sg13_lv_nmos L=0.13u W=0.5u AS=0.17p AD=0.17p PS=1.68u
+ PD=1.68u rfmode=0
* device instance $19 r0 *1 68.585,12 sg13_lv_nmos
M$19 VSS trim[1] \$35 VSS sg13_lv_nmos L=0.13u W=4u AS=1.36p AD=1.36p PS=8.68u
+ PD=8.68u rfmode=0
* device instance $20 r0 *1 88.475,10.25 sg13_lv_nmos
M$20 VSS \$44 \$22 VSS sg13_lv_nmos L=0.13u W=0.5u AS=0.17p AD=0.17p PS=1.68u
+ PD=1.68u rfmode=0
* device instance $21 r0 *1 82.355,10.25 sg13_lv_nmos
M$21 VSS \$27 \$44 VSS sg13_lv_nmos L=0.13u W=0.5u AS=0.17p AD=0.17p PS=1.68u
+ PD=1.68u rfmode=0
* device instance $22 r0 *1 60.565,10.25 sg13_lv_nmos
M$22 VSS \$30 \$31 VSS sg13_lv_nmos L=0.13u W=0.5u AS=0.17p AD=0.17p PS=1.68u
+ PD=1.68u rfmode=0
* device instance $23 r0 *1 48.89,12 sg13_lv_nmos
M$23 \$23 va \$24 VSS sg13_lv_nmos L=0.3u W=4u AS=1.36p AD=1.36p PS=8.68u
+ PD=8.68u rfmode=0
* device instance $24 r0 *1 80.825,10.25 sg13_lv_nmos
M$24 VSS en \$43 VSS sg13_lv_nmos L=0.13u W=0.5u AS=0.17p AD=0.17p PS=1.68u
+ PD=1.68u rfmode=0
* device instance $25 r0 *1 67.055,12 sg13_lv_nmos
M$25 VSS trim[0] \$34 VSS sg13_lv_nmos L=0.13u W=4u AS=1.36p AD=1.36p PS=8.68u
+ PD=8.68u rfmode=0
* device instance $26 r0 *1 83.885,10.25 sg13_lv_nmos
M$26 VSS \$43 \$44 VSS sg13_lv_nmos L=0.13u W=0.5u AS=0.17p AD=0.17p PS=1.68u
+ PD=1.68u rfmode=0
* device instance $27 r0 *1 65.525,12 sg13_lv_nmos
M$27 VSS trim[0] \$33 VSS sg13_lv_nmos L=0.13u W=4u AS=1.36p AD=1.36p PS=8.68u
+ PD=8.68u rfmode=0
* device instance $28 r0 *1 70.115,12 sg13_lv_nmos
M$28 VSS trim[1] \$36 VSS sg13_lv_nmos L=0.13u W=4u AS=1.36p AD=1.36p PS=8.68u
+ PD=8.68u rfmode=0
* device instance $29 r0 *1 74.705,12 sg13_lv_nmos
M$29 VSS trim[3] \$39 VSS sg13_lv_nmos L=0.13u W=4u AS=1.36p AD=1.36p PS=8.68u
+ PD=8.68u rfmode=0
* device instance $30 r0 *1 57.25,12 sg13_lv_nmos
M$30 \$28 vb \$29 VSS sg13_lv_nmos L=0.3u W=4u AS=1.36p AD=1.36p PS=8.68u
+ PD=8.68u rfmode=0
* device instance $31 r0 *1 71.645,12 sg13_lv_nmos
M$31 VSS trim[2] \$37 VSS sg13_lv_nmos L=0.13u W=4u AS=1.36p AD=1.36p PS=8.68u
+ PD=8.68u rfmode=0
* device instance $32 r0 *1 73.175,12 sg13_lv_nmos
M$32 VSS trim[2] \$38 VSS sg13_lv_nmos L=0.13u W=4u AS=1.36p AD=1.36p PS=8.68u
+ PD=8.68u rfmode=0
* device instance $33 r0 *1 114.515,24.7 sg13_lv_pmos
M$33 \$50 \$22 \$44 VDD sg13_lv_pmos L=0.13u W=3u AS=1.02p AD=1.02p PS=6.68u
+ PD=6.68u rfmode=0
* device instance $34 r0 *1 112.985,24.7 sg13_lv_pmos
M$34 \$48 \$43 \$50 VDD sg13_lv_pmos L=0.13u W=3u AS=1.02p AD=1.02p PS=6.68u
+ PD=6.68u rfmode=0
* device instance $35 r0 *1 111.455,24.7 sg13_lv_pmos
M$35 VDD \$27 \$48 VDD sg13_lv_pmos L=0.13u W=3u AS=1.02p AD=1.02p PS=6.68u
+ PD=6.68u rfmode=0
* device instance $36 r0 *1 117.575,24.2 sg13_lv_pmos
M$36 \$49 \$44 \$22 VDD sg13_lv_pmos L=0.13u W=2u AS=0.68p AD=0.68p PS=4.68u
+ PD=4.68u rfmode=0
* device instance $37 r0 *1 116.045,24.2 sg13_lv_pmos
M$37 VDD \$32 \$49 VDD sg13_lv_pmos L=0.13u W=2u AS=0.68p AD=0.68p PS=4.68u
+ PD=4.68u rfmode=0
* device instance $38 r0 *1 109.925,23.7 sg13_lv_pmos
M$38 VDD en \$43 VDD sg13_lv_pmos L=0.13u W=1u AS=0.34p AD=0.34p PS=2.68u
+ PD=2.68u rfmode=0
* device instance $39 r0 *1 108.395,23.7 sg13_lv_pmos
M$39 VDD \$31 \$32 VDD sg13_lv_pmos L=0.13u W=1u AS=0.34p AD=0.34p PS=2.68u
+ PD=2.68u rfmode=0
* device instance $40 r0 *1 123.695,23.7 sg13_lv_pmos
M$40 VDD \$44 \$46 VDD sg13_lv_pmos L=0.13u W=1u AS=0.34p AD=0.34p PS=2.68u
+ PD=2.68u rfmode=0
* device instance $41 r0 *1 119.105,23.7 sg13_lv_pmos
M$41 VDD \$22 \$20 VDD sg13_lv_pmos L=0.13u W=1u AS=0.34p AD=0.34p PS=2.68u
+ PD=2.68u rfmode=0
* device instance $42 r0 *1 103.55,24.2 sg13_lv_pmos
M$42 VDD \$29 \$29 VDD sg13_lv_pmos L=0.3u W=2u AS=0.68p AD=0.68p PS=4.68u
+ PD=4.68u rfmode=0
* device instance $43 r0 *1 105.25,24.2 sg13_lv_pmos
M$43 VDD \$29 \$30 VDD sg13_lv_pmos L=0.3u W=2u AS=0.68p AD=0.68p PS=4.68u
+ PD=4.68u rfmode=0
* device instance $44 r0 *1 106.865,23.7 sg13_lv_pmos
M$44 VDD \$30 \$31 VDD sg13_lv_pmos L=0.13u W=1u AS=0.34p AD=0.34p PS=2.68u
+ PD=2.68u rfmode=0
* device instance $45 r0 *1 120.635,23.7 sg13_lv_pmos
M$45 VDD en \$20 VDD sg13_lv_pmos L=0.13u W=1u AS=0.34p AD=0.34p PS=2.68u
+ PD=2.68u rfmode=0
* device instance $46 r0 *1 101.935,23.7 sg13_lv_pmos
M$46 VDD \$26 \$27 VDD sg13_lv_pmos L=0.13u W=1u AS=0.34p AD=0.34p PS=2.68u
+ PD=2.68u rfmode=0
* device instance $47 r0 *1 98.79,24.2 sg13_lv_pmos
M$47 VDD \$24 \$25 VDD sg13_lv_pmos L=0.3u W=2u AS=0.68p AD=0.68p PS=4.68u
+ PD=4.68u rfmode=0
* device instance $48 r0 *1 125.225,23.7 sg13_lv_pmos
M$48 VDD \$46 osc_clk VDD sg13_lv_pmos L=0.13u W=1u AS=0.34p AD=0.34p PS=2.68u
+ PD=2.68u rfmode=0
* device instance $49 r0 *1 122.165,23.7 sg13_lv_pmos
M$49 VDD \$44 \$19 VDD sg13_lv_pmos L=0.13u W=1u AS=0.34p AD=0.34p PS=2.68u
+ PD=2.68u rfmode=0
* device instance $50 r0 *1 100.405,23.7 sg13_lv_pmos
M$50 VDD \$25 \$26 VDD sg13_lv_pmos L=0.13u W=1u AS=0.34p AD=0.34p PS=2.68u
+ PD=2.68u rfmode=0
* device instance $51 r0 *1 97.09,24.2 sg13_lv_pmos
M$51 VDD \$24 \$24 VDD sg13_lv_pmos L=0.3u W=2u AS=0.68p AD=0.68p PS=4.68u
+ PD=4.68u rfmode=0
* device instance $52 r0 *1 60.34,28.69 dpantenna
D$52 vth VDD dpantenna A=0.6084p P=3.12u m=1
* device instance $53 r0 *1 6.345,9.995 rppd
R$53 va VDD VSS rppd w=1u l=117u ps=0u b=0 m=1
* device instance $55 r0 *1 10.045,9.995 rppd
R$55 VDD vb VSS rppd w=1u l=117u ps=0u b=0 m=1
* device instance $59 r0 *1 17.445,9.995 rppd
R$59 vth VDD VSS rppd w=1u l=384.3u ps=0u b=0 m=1
* device instance $67 r0 *1 32.245,9.995 rppd
R$67 VSS vth VSS rppd w=1u l=384.3u ps=0u b=0 m=1
* device instance $69 r0 *1 35.945,9.995 rppd
R$69 vbn VDD VSS rppd w=1u l=134.3u ps=0u b=0 m=1
* device instance $71 r0 *1 48.5,71.48 cap_cmim
C$71 va \$39 cap_cmim w=23.09u l=23.09u A=533.1481p P=92.36u m=1
* device instance $72 r0 *1 48.5,52.15 cap_cmim
C$72 va \$37 cap_cmim w=16.33u l=16.33u A=266.6689p P=65.32u m=1
* device instance $73 r0 *1 48.5,97.57 cap_cmim
C$73 va VSS cap_cmim w=31.65u l=31.65u A=1001.7225p P=126.6u m=1
* device instance $74 r0 *1 88,71.48 cap_cmim
C$74 vb \$40 cap_cmim w=23.09u l=23.09u A=533.1481p P=92.36u m=1
* device instance $75 r0 *1 129,52.15 cap_cmim
C$75 va \$33 cap_cmim w=8.16u l=8.16u A=66.5856p P=32.64u m=1
* device instance $76 r0 *1 129,63.31 cap_cmim
C$76 va \$35 cap_cmim w=11.55u l=11.55u A=133.4025p P=46.2u m=1
* device instance $77 r0 *1 88,52.15 cap_cmim
C$77 vb \$38 cap_cmim w=16.33u l=16.33u A=266.6689p P=65.32u m=1
* device instance $78 r0 *1 129,77.86 cap_cmim
C$78 vb \$34 cap_cmim w=8.16u l=8.16u A=66.5856p P=32.64u m=1
* device instance $79 r0 *1 129,89.02 cap_cmim
C$79 vb \$36 cap_cmim w=11.55u l=11.55u A=133.4025p P=46.2u m=1
* device instance $80 r0 *1 88,97.57 cap_cmim
C$80 vb VSS cap_cmim w=31.65u l=31.65u A=1001.7225p P=126.6u m=1
* device instance $81 r0 *1 129,103.57 cap_cmim
C$81 vth VSS cap_cmim w=26u l=26u A=676p P=104u m=1
.ENDS g1_osc

* cell g1_gate
* pin vss
* pin hard_cmp
* pin fast_en
* pin vdd
* pin en_core
* pin clr_d
* pin trip_d
* pin gate_core
* pin tripped
* pin vdda
* pin fault_core
.SUBCKT g1_gate vss hard_cmp fast_en vdd en_core clr_d trip_d gate_core tripped
+ vdda fault_core
* device instance $1 r0 *1 99.755,12.3 sg13_lv_pmos
M$1 \$3 hard_cmp vdd vdd sg13_lv_pmos L=0.13u W=2u AS=0.68p AD=0.38p PS=4.68u
+ PD=2.38u rfmode=0
* device instance $2 r0 *1 100.265,12.3 sg13_lv_pmos
M$2 vdd fast_en \$3 vdd sg13_lv_pmos L=0.13u W=2u AS=0.38p AD=0.68p PS=2.38u
+ PD=4.68u rfmode=0
* device instance $3 r0 *1 99.755,9.5 sg13_lv_nmos
M$3 \$3 hard_cmp \$I873 vss sg13_lv_nmos L=0.13u W=2u AS=0.68p AD=0.38p
+ PS=4.68u PD=2.38u rfmode=0
* device instance $4 r0 *1 100.265,9.5 sg13_lv_nmos
M$4 \$I873 fast_en vss vss sg13_lv_nmos L=0.13u W=2u AS=0.38p AD=0.68p PS=2.38u
+ PD=4.68u rfmode=0
* device instance $5 r0 *1 103.075,12.3 sg13_lv_pmos
M$5 vdd \$3 \$5 vdd sg13_lv_pmos L=0.13u W=2u AS=0.68p AD=0.68p PS=4.68u
+ PD=4.68u rfmode=0
* device instance $6 r0 *1 114.315,12.3 sg13_lv_pmos
M$6 vdd en_core \$9 vdd sg13_lv_pmos L=0.13u W=2u AS=0.68p AD=0.68p PS=4.68u
+ PD=4.68u rfmode=0
* device instance $7 r0 *1 111.505,12.3 sg13_lv_pmos
M$7 vdd clr_d \$8 vdd sg13_lv_pmos L=0.13u W=2u AS=0.68p AD=0.68p PS=4.68u
+ PD=4.68u rfmode=0
* device instance $8 r0 *1 108.695,12.3 sg13_lv_pmos
M$8 vdd trip_d \$7 vdd sg13_lv_pmos L=0.13u W=2u AS=0.68p AD=0.68p PS=4.68u
+ PD=4.68u rfmode=0
* device instance $9 r0 *1 105.885,12.3 sg13_lv_pmos
M$9 vdd \$5 \$6 vdd sg13_lv_pmos L=0.13u W=2u AS=0.68p AD=0.68p PS=4.68u
+ PD=4.68u rfmode=0
* device instance $10 r0 *1 103.075,9 sg13_lv_nmos
M$10 vss \$3 \$5 vss sg13_lv_nmos L=0.13u W=1u AS=0.34p AD=0.34p PS=2.68u
+ PD=2.68u rfmode=0
* device instance $11 r0 *1 114.315,9 sg13_lv_nmos
M$11 vss en_core \$9 vss sg13_lv_nmos L=0.13u W=1u AS=0.34p AD=0.34p PS=2.68u
+ PD=2.68u rfmode=0
* device instance $12 r0 *1 111.505,9 sg13_lv_nmos
M$12 vss clr_d \$8 vss sg13_lv_nmos L=0.13u W=1u AS=0.34p AD=0.34p PS=2.68u
+ PD=2.68u rfmode=0
* device instance $13 r0 *1 108.695,9 sg13_lv_nmos
M$13 vss trip_d \$7 vss sg13_lv_nmos L=0.13u W=1u AS=0.34p AD=0.34p PS=2.68u
+ PD=2.68u rfmode=0
* device instance $14 r0 *1 105.885,9 sg13_lv_nmos
M$14 vss \$5 \$6 vss sg13_lv_nmos L=0.13u W=1u AS=0.34p AD=0.34p PS=2.68u
+ PD=2.68u rfmode=0
* device instance $15 r0 *1 120.445,11.8 sg13_lv_pmos
M$15 fault_core \$11 vdd vdd sg13_lv_pmos L=0.13u W=1u AS=0.34p AD=0.19p
+ PS=2.68u PD=1.38u rfmode=0
* device instance $16 r0 *1 120.955,11.8 sg13_lv_pmos
M$16 vdd fault_core \$11 vdd sg13_lv_pmos L=0.13u W=1u AS=0.19p AD=0.34p
+ PS=1.38u PD=2.68u rfmode=0
* device instance $17 r0 *1 123.765,11.8 sg13_lv_pmos
M$17 tripped \$12 vdd vdd sg13_lv_pmos L=0.13u W=1u AS=0.34p AD=0.19p PS=2.68u
+ PD=1.38u rfmode=0
* device instance $18 r0 *1 124.275,11.8 sg13_lv_pmos
M$18 vdd tripped \$12 vdd sg13_lv_pmos L=0.13u W=1u AS=0.19p AD=0.34p PS=1.38u
+ PD=2.68u rfmode=0
* device instance $19 r0 *1 117.125,11.8 sg13_lv_pmos
M$19 gate_core \$10 vdd vdd sg13_lv_pmos L=0.13u W=1u AS=0.34p AD=0.19p
+ PS=2.68u PD=1.38u rfmode=0
* device instance $20 r0 *1 117.635,11.8 sg13_lv_pmos
M$20 vdd gate_core \$10 vdd sg13_lv_pmos L=0.13u W=1u AS=0.19p AD=0.34p
+ PS=1.38u PD=2.68u rfmode=0
* device instance $21 r0 *1 32.065,31.85 sg13_hv_pmos
M$21 vdda \$28 \$32 vdda sg13_hv_pmos L=0.45u W=0.3u AS=0.102p AD=0.102p
+ PS=1.28u PD=1.28u rfmode=0
* device instance $22 r0 *1 44.405,31.85 sg13_hv_pmos
M$22 vdda \$33 \$38 vdda sg13_hv_pmos L=0.45u W=0.3u AS=0.102p AD=0.102p
+ PS=1.28u PD=1.28u rfmode=0
* device instance $23 r0 *1 11.845,31.85 sg13_hv_pmos
M$23 vdda \$18 \$17 vdda sg13_hv_pmos L=0.45u W=0.3u AS=0.102p AD=0.102p
+ PS=1.28u PD=1.28u rfmode=0
* device instance $24 r0 *1 7.385,31.85 sg13_hv_pmos
M$24 vdda \$17 \$18 vdda sg13_hv_pmos L=0.45u W=0.3u AS=0.102p AD=0.102p
+ PS=1.28u PD=1.28u rfmode=0
* device instance $25 r0 *1 36.525,31.85 sg13_hv_pmos
M$25 vdda \$32 \$28 vdda sg13_hv_pmos L=0.45u W=0.3u AS=0.102p AD=0.102p
+ PS=1.28u PD=1.28u rfmode=0
* device instance $26 r0 *1 19.725,31.85 sg13_hv_pmos
M$26 vdda \$20 \$27 vdda sg13_hv_pmos L=0.45u W=0.3u AS=0.102p AD=0.102p
+ PS=1.28u PD=1.28u rfmode=0
* device instance $27 r0 *1 24.185,31.85 sg13_hv_pmos
M$27 vdda \$27 \$20 vdda sg13_hv_pmos L=0.45u W=0.3u AS=0.102p AD=0.102p
+ PS=1.28u PD=1.28u rfmode=0
* device instance $28 r0 *1 48.865,31.85 sg13_hv_pmos
M$28 vdda \$38 \$33 vdda sg13_hv_pmos L=0.45u W=0.3u AS=0.102p AD=0.102p
+ PS=1.28u PD=1.28u rfmode=0
* device instance $29 r0 *1 9.615,41.75 sg13_hv_nmos
M$29 \$18 \$5 vss vss sg13_hv_nmos L=0.45u W=1.9u AS=0.646p AD=0.361p PS=4.48u
+ PD=2.28u rfmode=0
* device instance $30 r0 *1 10.445,41.75 sg13_hv_nmos
M$30 vss \$6 \$17 vss sg13_hv_nmos L=0.45u W=1.9u AS=0.361p AD=0.646p PS=2.28u
+ PD=4.48u rfmode=0
* device instance $31 r0 *1 55.925,41.75 sg13_hv_nmos
M$31 \$39 \$19 vss vss sg13_hv_nmos L=0.45u W=1.9u AS=0.646p AD=0.361p PS=4.48u
+ PD=2.28u rfmode=0
* device instance $32 r0 *1 56.755,41.75 sg13_hv_nmos
M$32 vss \$21 \$39 vss sg13_hv_nmos L=0.45u W=1.9u AS=0.361p AD=0.646p PS=2.28u
+ PD=4.48u rfmode=0
* device instance $33 r0 *1 46.635,41.75 sg13_hv_nmos
M$33 \$38 en_core vss vss sg13_hv_nmos L=0.45u W=1.9u AS=0.646p AD=0.361p
+ PS=4.48u PD=2.28u rfmode=0
* device instance $34 r0 *1 47.465,41.75 sg13_hv_nmos
M$34 vss \$9 \$33 vss sg13_hv_nmos L=0.45u W=1.9u AS=0.361p AD=0.646p PS=2.28u
+ PD=4.48u rfmode=0
* device instance $35 r0 *1 81.155,41.75 sg13_hv_nmos
M$35 \$24 \$23 vss vss sg13_hv_nmos L=0.45u W=1.9u AS=0.646p AD=0.361p PS=4.48u
+ PD=2.28u rfmode=0
* device instance $36 r0 *1 81.985,41.75 sg13_hv_nmos
M$36 vss \$36 \$24 vss sg13_hv_nmos L=0.45u W=1.9u AS=0.361p AD=0.646p PS=2.28u
+ PD=4.48u rfmode=0
* device instance $37 r0 *1 34.295,41.75 sg13_hv_nmos
M$37 \$32 clr_d vss vss sg13_hv_nmos L=0.45u W=1.9u AS=0.646p AD=0.361p
+ PS=4.48u PD=2.28u rfmode=0
* device instance $38 r0 *1 35.125,41.75 sg13_hv_nmos
M$38 vss \$8 \$28 vss sg13_hv_nmos L=0.45u W=1.9u AS=0.361p AD=0.646p PS=2.28u
+ PD=4.48u rfmode=0
* device instance $39 r0 *1 21.955,41.75 sg13_hv_nmos
M$39 \$27 trip_d vss vss sg13_hv_nmos L=0.45u W=1.9u AS=0.646p AD=0.361p
+ PS=4.48u PD=2.28u rfmode=0
* device instance $40 r0 *1 22.785,41.75 sg13_hv_nmos
M$40 vss \$7 \$20 vss sg13_hv_nmos L=0.45u W=1.9u AS=0.361p AD=0.646p PS=2.28u
+ PD=4.48u rfmode=0
* device instance $41 r0 *1 66.145,41.75 sg13_hv_nmos
M$41 \$35 \$23 vss vss sg13_hv_nmos L=0.45u W=1.9u AS=0.646p AD=0.361p PS=4.48u
+ PD=2.28u rfmode=0
* device instance $42 r0 *1 66.975,41.75 sg13_hv_nmos
M$42 vss \$29 \$35 vss sg13_hv_nmos L=0.45u W=1.9u AS=0.361p AD=0.646p PS=2.28u
+ PD=4.48u rfmode=0
* device instance $43 r0 *1 77.195,41.75 sg13_hv_nmos
M$43 \$31 \$22 vss vss sg13_hv_nmos L=0.45u W=1.9u AS=0.646p AD=0.361p PS=4.48u
+ PD=2.28u rfmode=0
* device instance $44 r0 *1 78.025,41.75 sg13_hv_nmos
M$44 vss \$36 \$31 vss sg13_hv_nmos L=0.45u W=1.9u AS=0.361p AD=0.646p PS=2.28u
+ PD=4.48u rfmode=0
* device instance $45 r0 *1 73.235,41.75 sg13_hv_nmos
M$45 \$36 \$30 vss vss sg13_hv_nmos L=0.45u W=1.9u AS=0.646p AD=0.361p PS=4.48u
+ PD=2.28u rfmode=0
* device instance $46 r0 *1 74.065,41.75 sg13_hv_nmos
M$46 vss \$31 \$36 vss sg13_hv_nmos L=0.45u W=1.9u AS=0.361p AD=0.646p PS=2.28u
+ PD=4.48u rfmode=0
* device instance $47 r0 *1 70.105,33.65 sg13_hv_pmos
M$47 vdda \$35 \$30 vdda sg13_hv_pmos L=0.45u W=3.9u AS=1.326p AD=1.326p
+ PS=8.48u PD=8.48u rfmode=0
* device instance $48 r0 *1 85.115,33.65 sg13_hv_pmos
M$48 vdda \$24 \$25 vdda sg13_hv_pmos L=0.45u W=3.9u AS=1.326p AD=1.326p
+ PS=8.48u PD=8.48u rfmode=0
* device instance $49 r0 *1 15.775,33.65 sg13_hv_pmos
M$49 vdda \$18 \$19 vdda sg13_hv_pmos L=0.45u W=3.9u AS=1.326p AD=1.326p
+ PS=8.48u PD=8.48u rfmode=0
* device instance $50 r0 *1 28.115,33.65 sg13_hv_pmos
M$50 vdda \$27 \$21 vdda sg13_hv_pmos L=0.45u W=3.9u AS=1.326p AD=1.326p
+ PS=8.48u PD=8.48u rfmode=0
* device instance $51 r0 *1 40.455,33.65 sg13_hv_pmos
M$51 vdda \$32 \$29 vdda sg13_hv_pmos L=0.45u W=3.9u AS=1.326p AD=1.326p
+ PS=8.48u PD=8.48u rfmode=0
* device instance $52 r0 *1 59.885,33.65 sg13_hv_pmos
M$52 vdda \$39 \$22 vdda sg13_hv_pmos L=0.45u W=3.9u AS=1.326p AD=1.326p
+ PS=8.48u PD=8.48u rfmode=0
* device instance $53 r0 *1 63.015,33.65 sg13_hv_pmos
M$53 vdda \$34 \$23 vdda sg13_hv_pmos L=0.45u W=3.9u AS=1.326p AD=1.326p
+ PS=8.48u PD=8.48u rfmode=0
* device instance $54 r0 *1 52.795,33.65 sg13_hv_pmos
M$54 vdda \$38 \$34 vdda sg13_hv_pmos L=0.45u W=3.9u AS=1.326p AD=1.326p
+ PS=8.48u PD=8.48u rfmode=0
* device instance $55 r0 *1 15.775,41.75 sg13_hv_nmos
M$55 vss \$18 \$19 vss sg13_hv_nmos L=0.45u W=1.9u AS=0.646p AD=0.646p PS=4.48u
+ PD=4.48u rfmode=0
* device instance $56 r0 *1 85.115,41.75 sg13_hv_nmos
M$56 vss \$24 \$25 vss sg13_hv_nmos L=0.45u W=1.9u AS=0.646p AD=0.646p PS=4.48u
+ PD=4.48u rfmode=0
* device instance $57 r0 *1 70.105,41.75 sg13_hv_nmos
M$57 vss \$35 \$30 vss sg13_hv_nmos L=0.45u W=1.9u AS=0.646p AD=0.646p PS=4.48u
+ PD=4.48u rfmode=0
* device instance $58 r0 *1 28.115,41.75 sg13_hv_nmos
M$58 vss \$27 \$21 vss sg13_hv_nmos L=0.45u W=1.9u AS=0.646p AD=0.646p PS=4.48u
+ PD=4.48u rfmode=0
* device instance $59 r0 *1 40.455,41.75 sg13_hv_nmos
M$59 vss \$32 \$29 vss sg13_hv_nmos L=0.45u W=1.9u AS=0.646p AD=0.646p PS=4.48u
+ PD=4.48u rfmode=0
* device instance $60 r0 *1 52.795,41.75 sg13_hv_nmos
M$60 vss \$38 \$34 vss sg13_hv_nmos L=0.45u W=1.9u AS=0.646p AD=0.646p PS=4.48u
+ PD=4.48u rfmode=0
* device instance $61 r0 *1 59.885,41.75 sg13_hv_nmos
M$61 vss \$39 \$22 vss sg13_hv_nmos L=0.45u W=1.9u AS=0.646p AD=0.646p PS=4.48u
+ PD=4.48u rfmode=0
* device instance $62 r0 *1 63.015,41.75 sg13_hv_nmos
M$62 vss \$34 \$23 vss sg13_hv_nmos L=0.45u W=1.9u AS=0.646p AD=0.646p PS=4.48u
+ PD=4.48u rfmode=0
* device instance $63 r0 *1 66.145,35.6 sg13_hv_pmos
M$63 vdda \$23 \$I874 vdda sg13_hv_pmos L=0.45u W=7.8u AS=2.652p AD=1.482p
+ PS=16.28u PD=8.18u rfmode=0
* device instance $64 r0 *1 66.975,35.6 sg13_hv_pmos
M$64 \$I874 \$29 \$35 vdda sg13_hv_pmos L=0.45u W=7.8u AS=1.482p AD=2.652p
+ PS=8.18u PD=16.28u rfmode=0
* device instance $65 r0 *1 77.195,35.6 sg13_hv_pmos
M$65 vdda \$22 \$I875 vdda sg13_hv_pmos L=0.45u W=7.8u AS=2.652p AD=1.482p
+ PS=16.28u PD=8.18u rfmode=0
* device instance $66 r0 *1 78.025,35.6 sg13_hv_pmos
M$66 \$I875 \$36 \$31 vdda sg13_hv_pmos L=0.45u W=7.8u AS=1.482p AD=2.652p
+ PS=8.18u PD=16.28u rfmode=0
* device instance $67 r0 *1 81.155,35.6 sg13_hv_pmos
M$67 vdda \$23 \$I876 vdda sg13_hv_pmos L=0.45u W=7.8u AS=2.652p AD=1.482p
+ PS=16.28u PD=8.18u rfmode=0
* device instance $68 r0 *1 81.985,35.6 sg13_hv_pmos
M$68 \$I876 \$36 \$24 vdda sg13_hv_pmos L=0.45u W=7.8u AS=1.482p AD=2.652p
+ PS=8.18u PD=16.28u rfmode=0
* device instance $69 r0 *1 55.925,35.6 sg13_hv_pmos
M$69 vdda \$19 \$I877 vdda sg13_hv_pmos L=0.45u W=7.8u AS=2.652p AD=1.482p
+ PS=16.28u PD=8.18u rfmode=0
* device instance $70 r0 *1 56.755,35.6 sg13_hv_pmos
M$70 \$I877 \$21 \$39 vdda sg13_hv_pmos L=0.45u W=7.8u AS=1.482p AD=2.652p
+ PS=8.18u PD=16.28u rfmode=0
* device instance $71 r0 *1 73.235,35.6 sg13_hv_pmos
M$71 vdda \$30 \$I878 vdda sg13_hv_pmos L=0.45u W=7.8u AS=2.652p AD=1.482p
+ PS=16.28u PD=8.18u rfmode=0
* device instance $72 r0 *1 74.065,35.6 sg13_hv_pmos
M$72 \$I878 \$31 \$36 vdda sg13_hv_pmos L=0.45u W=7.8u AS=1.482p AD=2.652p
+ PS=8.18u PD=16.28u rfmode=0
* device instance $73 r0 *1 88.245,41.8 sg13_hv_nmos
M$73 \$10 \$24 vss vss sg13_hv_nmos L=0.45u W=2u AS=0.68p AD=0.38p PS=4.68u
+ PD=2.38u rfmode=0
* device instance $74 r0 *1 89.075,41.8 sg13_hv_nmos
M$74 vss \$25 gate_core vss sg13_hv_nmos L=0.45u W=2u AS=0.38p AD=0.68p
+ PS=2.38u PD=4.68u rfmode=0
* device instance $75 r0 *1 96.165,41.8 sg13_hv_nmos
M$75 \$12 \$36 vss vss sg13_hv_nmos L=0.45u W=2u AS=0.68p AD=0.38p PS=4.68u
+ PD=2.38u rfmode=0
* device instance $76 r0 *1 96.995,41.8 sg13_hv_nmos
M$76 vss \$31 tripped vss sg13_hv_nmos L=0.45u W=2u AS=0.38p AD=0.68p PS=2.38u
+ PD=4.68u rfmode=0
* device instance $77 r0 *1 92.205,41.8 sg13_hv_nmos
M$77 \$11 \$31 vss vss sg13_hv_nmos L=0.45u W=2u AS=0.68p AD=0.38p PS=4.68u
+ PD=2.38u rfmode=0
* device instance $78 r0 *1 93.035,41.8 sg13_hv_nmos
M$78 vss \$36 fault_core vss sg13_hv_nmos L=0.45u W=2u AS=0.38p AD=0.68p
+ PS=2.38u PD=4.68u rfmode=0
.ENDS g1_gate

* cell g1_trip
* pin VSS
* pin dac_soft[1]
* pin dac_soft[4]
* pin dac_soft[5]
* pin dac_soft[3]
* pin dac_soft[2]
* pin dac_soft[0]
* pin dac_soft[6]
* pin dac_soft[7]
* pin VDD
* pin IOVDD
* pin dac_hard[0]
* pin dac_hard[1]
* pin dac_hard[2]
* pin dac_hard[3]
* pin dac_hard[4]
* pin dac_hard[5]
* pin dac_hard[6]
* pin dac_hard[7]
* pin VREF
* pin ISENSE
* pin clk
* pin cmp_soft
* pin cmp_hard
.SUBCKT g1_trip VSS dac_soft[1] dac_soft[4] dac_soft[5] dac_soft[3] dac_soft[2]
+ dac_soft[0] dac_soft[6] dac_soft[7] VDD IOVDD dac_hard[0] dac_hard[1]
+ dac_hard[2] dac_hard[3] dac_hard[4] dac_hard[5] dac_hard[6] dac_hard[7] VREF
+ ISENSE clk cmp_soft cmp_hard
* cell instance $1 r0 *1 2,154
X$1 VSS ISENSE icmp g1_cond
* cell instance $2 m90 *1 141.7,162
X$2 VSS icmp clk vth_soft cmp_soft VDD g1_cmp
* cell instance $3 m90 *1 208,162
X$3 VSS icmp cmp_clk_n vth_hard cmp_hard VDD g1_cmp
* cell instance $582 r0 *1 118,8
X$582 VSS VDD dac_hard[0] dac_hard[1] dac_hard[2] dac_hard[3] dac_hard[4]
+ dac_hard[5] dac_hard[6] dac_hard[7] IOVDD VREF vth_hard g1_dac8
* cell instance $796 r0 *1 3,8
X$796 VSS VDD dac_soft[0] dac_soft[1] dac_soft[2] dac_soft[3] dac_soft[4]
+ dac_soft[5] dac_soft[6] dac_soft[7] IOVDD VREF vth_soft g1_dac8
* device instance $1 r0 *1 175.405,185.25 sg13_lv_nmos
M$1 VSS clk cmp_clk_n VSS sg13_lv_nmos L=0.13u W=0.5u AS=0.17p AD=0.17p
+ PS=1.68u PD=1.68u rfmode=0
* device instance $2 r0 *1 175.405,187.5 sg13_lv_pmos
M$2 VDD clk cmp_clk_n VDD sg13_lv_pmos L=0.13u W=1u AS=0.34p AD=0.34p PS=2.68u
+ PD=2.68u rfmode=0
* device instance $3 r0 *1 97.5,158.5 cap_cmim
C$3 vth_soft VSS cap_cmim w=26u l=26u A=676p P=104u m=1
* device instance $4 r0 *1 162.5,158.5 cap_cmim
C$4 vth_hard VSS cap_cmim w=26u l=26u A=676p P=104u m=1
.ENDS g1_trip

* cell g1_digital
* pin VSS
* pin VDD
* pin osc_clk
* pin cmp_clk
* pin tripped
* pin osc_en
* pin fast_en
* pin osc_trim[3]
* pin osc_trim[1]
* pin cmp_hard
* pin clr_d
* pin trip_d
* pin bgr_r4
* pin cmp_soft
* pin en
* pin t2f_en
* pin t2f_mode
* pin por_n
* pin dac_hard[3]
* pin osc_trim[2]
* pin osc_trim[0]
* pin sdi
* pin sclk
* pin dac_soft[4]
* pin dac_soft[1]
* pin dac_soft[0]
* pin dac_hard[6]
* pin dac_soft[6]
* pin dac_hard[4]
* pin dac_soft[3]
* pin dac_hard[2]
* pin dac_soft[2]
* pin dac_hard[1]
* pin dac_hard[0]
* pin dac_hard[7]
* pin dac_hard[5]
* pin dac_soft[7]
* pin dac_soft[5]
* pin sdo
.SUBCKT g1_digital VSS VDD osc_clk cmp_clk tripped osc_en fast_en osc_trim[3]
+ osc_trim[1] cmp_hard clr_d trip_d bgr_r4 cmp_soft en t2f_en t2f_mode por_n
+ dac_hard[3] osc_trim[2] osc_trim[0] sdi sclk dac_soft[4] dac_soft[1]
+ dac_soft[0] dac_hard[6] dac_soft[6] dac_hard[4] dac_soft[3] dac_hard[2]
+ dac_soft[2] dac_hard[1] dac_hard[0] dac_hard[7] dac_hard[5] dac_soft[7]
+ dac_soft[5] sdo
* cell instance $26 m0 *1 162.24,351.54
X$26 VSS \$23676 sclk VDD sg13g2_buf_16
* cell instance $27 m0 *1 184.8,291.06
X$27 VSS \$20924 \$21439 VDD sg13g2_buf_16
* cell instance $28 m0 *1 203.04,328.86
X$28 VSS \$22401 sclk VDD sg13g2_buf_16
* cell instance $29 m0 *1 142.56,328.86
X$29 VSS \$23825 \$23676 VDD sg13g2_buf_16
* cell instance $30 m0 *1 161.28,313.74
X$30 VSS \$22121 \$21439 VDD sg13g2_buf_16
* cell instance $31 m0 *1 181.92,321.3
X$31 VSS \$22575 \$21439 VDD sg13g2_buf_16
* cell instance $32 m0 *1 222.72,351.54
X$32 VSS \$23700 \$21439 VDD sg13g2_buf_16
* cell instance $33 m0 *1 195.84,306.18
X$33 VSS \$21439 \$22401 VDD sg13g2_buf_16
* cell instance $34 m0 *1 192.48,343.98
X$34 VSS \$23545 \$21439 VDD sg13g2_buf_16
* cell instance $35 r0 *1 163.2,291.06
X$35 VSS \$20447 \$21439 VDD sg13g2_buf_16
* cell instance $36 r0 *1 166.08,328.86
X$36 VSS \$23108 \$21439 VDD sg13g2_buf_16
* cell instance $37 r0 *1 207.84,306.18
X$37 VSS \$20454 \$21439 VDD sg13g2_buf_16
* cell instance $38 m0 *1 299.04,336.42
X$38 VDD VSS \$23947 \$24270 \$23557 \$21082 sg13g2_nand3b_1
* cell instance $39 m0 *1 103.68,268.38
X$39 VDD VSS \$19415 \$16959 \$18738 \$19720 sg13g2_nand3b_1
* cell instance $40 m0 *1 68.16,291.06
X$40 VDD VSS \$11133 \$21365 \$21483 \$21006 sg13g2_nand3b_1
* cell instance $41 r0 *1 282.24,223.02
X$41 VDD VSS \$15585 \$15690 \$14462 \$15695 sg13g2_nand3b_1
* cell instance $42 r0 *1 277.92,313.74
X$42 VDD VSS \$23159 \$22151 \$22714 \$21079 sg13g2_nand3b_1
* cell instance $43 m0 *1 32.16,238.14
X$43 VDD VSS \$16229 \$15993 \$16228 \$16389 sg13g2_or3_1
* cell instance $44 m0 *1 272.16,336.42
X$44 VDD VSS \$24092 \$16764 \$24263 \$24266 sg13g2_or3_1
* cell instance $45 m0 *1 309.12,336.42
X$45 VDD VSS \$24784 \$24275 \$24442 \$23714 sg13g2_or3_1
* cell instance $46 m0 *1 107.04,245.7
X$46 VDD VSS \$17017 \$16268 \$16622 \$17250 sg13g2_or3_1
* cell instance $47 m0 *1 105.12,275.94
X$47 VDD VSS \$19981 \$18735 \$19651 \$20286 sg13g2_or3_1
* cell instance $48 r0 *1 242.88,306.18
X$48 VDD VSS \$22545 \$20456 \$16806 \$22336 sg13g2_or3_1
* cell instance $49 r0 *1 223.68,268.38
X$49 VDD VSS \$19674 \$19915 \$19669 \$18419 sg13g2_or3_1
* cell instance $50 r0 *1 258.24,245.7
X$50 VDD VSS \$18218 \$15261 \$18058 \$17892 sg13g2_or3_1
* cell instance $51 m0 *1 110.4,268.38
X$51 VDD VSS \$19720 \$19653 \$11897 \$19985 \$8015 sg13g2_or4_1
* cell instance $52 m0 *1 33.12,245.7
X$52 VDD VSS \$16987 \$17770 \$16992 \$17403 \$16229 sg13g2_or4_1
* cell instance $53 m0 *1 63.36,298.62
X$53 VDD VSS \$21605 \$21681 \$21867 \$21682 \$21870 sg13g2_or4_1
* cell instance $54 r0 *1 36,238.14
X$54 VDD VSS \$16993 \$16870 \$16992 \$15628 \$14871 sg13g2_or4_1
* cell instance $55 r0 *1 164.64,207.9
X$55 VDD VSS \$13812 \$14566 \$14210 \$14358 \$14362 sg13g2_or4_1
* cell instance $56 m0 *1 145.44,351.54
X$56 VSS \$25254 VDD \$23542 \$25003 sg13g2_xor2_1
* cell instance $57 m0 *1 108.96,215.46
X$57 VSS \$14650 VDD \$13966 \$13144 sg13g2_xor2_1
* cell instance $58 m0 *1 335.04,162.54
X$58 VSS \$10325 VDD \$4409 \$8915 sg13g2_xor2_1
* cell instance $59 m0 *1 267.36,336.42
X$59 VSS \$24407 VDD \$24262 \$24261 sg13g2_xor2_1
* cell instance $60 m0 *1 229.92,298.62
X$60 VSS \$21843 VDD \$19327 \$21519 sg13g2_xor2_1
* cell instance $61 m0 *1 188.64,343.98
X$61 VSS \$24920 VDD \$24754 \$25164 sg13g2_xor2_1
* cell instance $62 m0 *1 114.72,351.54
X$62 VSS \$24877 VDD \$24998 \$24821 sg13g2_xor2_1
* cell instance $63 m0 *1 85.92,238.14
X$63 VSS \$16255 VDD \$16248 \$15927 sg13g2_xor2_1
* cell instance $64 m0 *1 253.44,291.06
X$64 VSS \$21323 VDD \$21071 \$18473 sg13g2_xor2_1
* cell instance $65 m0 *1 240,298.62
X$65 VSS \$21942 VDD \$16311 \$21444 sg13g2_xor2_1
* cell instance $66 m0 *1 134.4,207.9
X$66 VSS \$14033 VDD \$12638 \$13664 sg13g2_xor2_1
* cell instance $67 m0 *1 118.08,328.86
X$67 VSS \$23664 VDD \$23665 \$23819 sg13g2_xor2_1
* cell instance $68 m0 *1 120.48,275.94
X$68 VSS \$19653 VDD \$7997 \$20516 sg13g2_xor2_1
* cell instance $69 m0 *1 119.52,207.9
X$69 VSS \$13327 VDD \$12901 \$13664 sg13g2_xor2_1
* cell instance $70 m0 *1 117.12,223.02
X$70 VSS \$15346 VDD \$14338 \$13144 sg13g2_xor2_1
* cell instance $71 m0 *1 141.12,321.3
X$71 VSS \$23409 VDD \$24753 \$22945 sg13g2_xor2_1
* cell instance $72 m0 *1 37.92,253.26
X$72 VSS \$17740 VDD \$17770 \$16992 sg13g2_xor2_1
* cell instance $73 m0 *1 114.72,245.7
X$73 VSS \$17017 VDD \$15847 \$15937 sg13g2_xor2_1
* cell instance $74 r0 *1 87.84,230.58
X$74 VSS \$15334 VDD \$15004 \$15927 sg13g2_xor2_1
* cell instance $75 r0 *1 137.28,192.78
X$75 VSS \$13638 VDD \$12660 \$12818 sg13g2_xor2_1
* cell instance $76 r0 *1 42.72,253.26
X$76 VSS \$17408 VDD \$16876 \$18494 sg13g2_xor2_1
* cell instance $77 r0 *1 134.88,238.14
X$77 VSS \$16792 VDD \$17031 \$16630 sg13g2_xor2_1
* cell instance $78 r0 *1 123.36,306.18
X$78 VSS \$23102 VDD \$21623 \$21507 sg13g2_xor2_1
* cell instance $79 r0 *1 153.12,328.86
X$79 VSS \$24464 VDD \$23540 \$23510 sg13g2_xor2_1
* cell instance $80 r0 *1 156.96,328.86
X$80 VSS \$21830 VDD sg13g2_inv_8
* cell instance $81 r0 *1 259.68,313.74
X$81 VSS \$23145 VDD \$22709 \$22884 sg13g2_xor2_1
* cell instance $82 r0 *1 113.28,238.14
X$82 VSS \$16268 VDD \$15846 \$15937 sg13g2_xor2_1
* cell instance $83 r0 *1 128.64,230.58
X$83 VSS \$16046 VDD \$16136 \$15937 sg13g2_xor2_1
* cell instance $84 r0 *1 304.32,328.86
X$84 VSS \$23840 VDD \$23947 \$18205 sg13g2_xor2_1
* cell instance $85 r0 *1 156.48,306.18
X$85 VSS \$22394 VDD \$22571 \$22948 sg13g2_xor2_1
* cell instance $86 r0 *1 141.12,192.78
X$86 VSS \$12644 VDD \$11868 \$12818 sg13g2_xor2_1
* cell instance $87 r0 *1 103.68,298.62
X$87 VSS \$22063 VDD \$21385 \$21548 sg13g2_xor2_1
* cell instance $88 r0 *1 80.64,207.9
X$88 VSS \$13954 VDD \$13300 \$13144 sg13g2_xor2_1
* cell instance $89 r0 *1 313.92,313.74
X$89 VSS \$23028 VDD \$22728 \$17471 sg13g2_xor2_1
* cell instance $90 r0 *1 114.24,343.98
X$90 VSS \$24869 VDD \$23340 \$23795 sg13g2_xor2_1
* cell instance $91 r0 *1 103.2,321.3
X$91 VSS \$23662 VDD \$23441 \$23791 sg13g2_xor2_1
* cell instance $92 m0 *1 129.6,238.14
X$92 VSS VDD \$16280 \$15938 \$16279 \$16630 \$16789 sg13g2_and4_1
* cell instance $93 m0 *1 338.4,298.62
X$93 VSS VDD \$21581 \$22743 \$21947 \$21852 \$21854 sg13g2_and4_1
* cell instance $94 m0 *1 258.72,200.34
X$94 VSS VDD \$12700 \$12691 \$13211 \$13066 \$12920 sg13g2_and4_1
* cell instance $95 m0 *1 228.48,268.38
X$95 VSS VDD \$19437 \$17877 \$19090 \$18814 \$18469 sg13g2_and4_1
* cell instance $96 m0 *1 246.72,230.58
X$96 VSS VDD \$15680 \$14604 \$15679 \$15956 \$16096 sg13g2_and4_1
* cell instance $97 m0 *1 274.56,192.78
X$97 VSS VDD \$12314 \$12705 \$12310 \$12924 \$13221 sg13g2_and4_1
* cell instance $98 r0 *1 326.4,154.98
X$98 VSS VDD \$2449 \$4643 \$8915 \$4641 \$5917 sg13g2_and4_1
* cell instance $99 r0 *1 345.12,336.42
X$99 VSS VDD \$24107 \$23354 \$24780 \$24778 \$23957 sg13g2_and4_1
* cell instance $100 r0 *1 309.12,336.42
X$100 VSS VDD \$24098 \$23717 \$23716 \$24273 \$23977 sg13g2_and4_1
* cell instance $101 r0 *1 135.36,215.46
X$101 VSS VDD \$15231 \$14798 \$14350 \$15223 \$14890 sg13g2_and4_1
* cell instance $102 r0 *1 275.52,298.62
X$102 VSS VDD \$22151 \$20607 \$21452 \$22222 \$20938 sg13g2_and4_1
* cell instance $103 r0 *1 88.32,215.46
X$103 VSS VDD \$16256 \$15638 \$14318 \$15596 \$14882 sg13g2_and4_1
* cell instance $104 r0 *1 206.88,170.1
X$104 VSS VDD \$11263 \$11489 \$11487 \$10730 \$10733 sg13g2_and4_1
* cell instance $105 r0 *1 146.88,245.7
X$105 VSS VDD \$18060 \$16629 \$16895 \$17018 \$17659 sg13g2_and4_1
* cell instance $106 r0 *1 204.96,275.94
X$106 VSS VDD \$11498 \$20015 \$20451 \$20195 \$20046 sg13g2_and4_1
* cell instance $107 r0 *1 293.76,275.94
X$107 VDD VSS \$16160 sg13g2_inv_4
* cell instance $108 r0 *1 230.4,328.86
X$108 VDD VSS \$23122 sg13g2_inv_4
* cell instance $109 r0 *1 229.44,200.34
X$109 VDD VSS \$12538 sg13g2_inv_4
* cell instance $110 m0 *1 328.32,170.1
X$110 VDD VSS \$2442 \$2449 \$2645 sg13g2_xnor2_1
* cell instance $111 m0 *1 89.76,238.14
X$111 VDD VSS \$16449 \$16618 \$16260 sg13g2_xnor2_1
* cell instance $112 m0 *1 84.96,230.58
X$112 VDD VSS \$15638 \$14884 \$15927 sg13g2_xnor2_1
* cell instance $113 m0 *1 83.52,207.9
X$113 VDD VSS \$13884 \$13141 \$13954 sg13g2_xnor2_1
* cell instance $114 m0 *1 253.44,298.62
X$114 VDD VSS \$21944 \$21565 \$21323 sg13g2_xnor2_1
* cell instance $115 m0 *1 79.68,207.9
X$115 VDD VSS \$14017 \$13460 \$14484 sg13g2_xnor2_1
* cell instance $116 m0 *1 316.8,170.1
X$116 VDD VSS \$11370 \$11038 \$11290 sg13g2_xnor2_1
* cell instance $117 m0 *1 286.08,162.54
X$117 VDD VSS \$11634 \$10314 \$10312 sg13g2_xnor2_1
* cell instance $118 m0 *1 327.84,238.14
X$118 VDD VSS \$15755 \$16645 \$15088 sg13g2_xnor2_1
* cell instance $119 m0 *1 134.88,238.14
X$119 VDD VSS \$16630 \$16286 \$15648 sg13g2_xnor2_1
* cell instance $120 m0 *1 113.28,275.94
X$120 VDD VSS \$20293 \$20512 \$19986 sg13g2_xnor2_1
* cell instance $121 m0 *1 312,313.74
X$121 VDD VSS \$22780 \$22728 \$17471 sg13g2_xnor2_1
* cell instance $122 m0 *1 332.16,170.1
X$122 VDD VSS \$10667 \$2392 \$2403 sg13g2_xnor2_1
* cell instance $123 m0 *1 260.16,328.86
X$123 VDD VSS \$24194 \$23491 \$23151 sg13g2_xnor2_1
* cell instance $124 m0 *1 309.6,154.98
X$124 VDD VSS \$7069 \$2431 \$8697 sg13g2_xnor2_1
* cell instance $125 m0 *1 103.2,200.34
X$125 VDD VSS \$13311 \$13147 \$13144 sg13g2_xnor2_1
* cell instance $126 m0 *1 280.8,185.22
X$126 VDD VSS \$12238 \$12314 \$12278 sg13g2_xnor2_1
* cell instance $127 m0 *1 332.64,306.18
X$127 VDD VSS \$22174 \$22353 \$21852 sg13g2_xnor2_1
* cell instance $128 m0 *1 128.16,200.34
X$128 VDD VSS \$13337 \$14121 \$13634 sg13g2_xnor2_1
* cell instance $129 m0 *1 324,245.7
X$129 VDD VSS \$17162 \$17129 \$16812 sg13g2_xnor2_1
* cell instance $130 m0 *1 257.28,298.62
X$130 VDD VSS \$22024 \$18477 \$20241 sg13g2_xnor2_1
* cell instance $131 m0 *1 138.72,215.46
X$131 VDD VSS \$14352 \$14346 \$12818 sg13g2_xnor2_1
* cell instance $132 m0 *1 325.44,230.58
X$132 VDD VSS \$15988 \$15710 \$15983 sg13g2_xnor2_1
* cell instance $133 m0 *1 249.6,298.62
X$133 VDD VSS \$22022 \$21321 \$21716 sg13g2_xnor2_1
* cell instance $134 m0 *1 246.72,306.18
X$134 VDD VSS \$22407 \$21943 \$22137 sg13g2_xnor2_1
* cell instance $135 m0 *1 252,207.9
X$135 VDD VSS \$14058 \$12691 \$12920 sg13g2_xnor2_1
* cell instance $136 m0 *1 264,328.86
X$136 VDD VSS \$23148 \$23456 \$16311 sg13g2_xnor2_1
* cell instance $137 m0 *1 274.08,306.18
X$137 VDD VSS \$22145 \$22149 \$19282 sg13g2_xnor2_1
* cell instance $138 m0 *1 330.24,343.98
X$138 VDD VSS \$24856 \$24109 \$24778 sg13g2_xnor2_1
* cell instance $139 m0 *1 256.8,313.74
X$139 VDD VSS \$22883 \$22706 \$22141 sg13g2_xnor2_1
* cell instance $140 m0 *1 127.2,230.58
X$140 VDD VSS \$15938 \$15644 \$15937 sg13g2_xnor2_1
* cell instance $141 m0 *1 136.8,200.34
X$141 VDD VSS \$13341 \$12897 \$13638 sg13g2_xnor2_1
* cell instance $142 m0 *1 301.44,147.42
X$142 VDD VSS \$6244 \$2402 \$7423 sg13g2_xnor2_1
* cell instance $143 m0 *1 110.4,245.7
X$143 VDD VSS \$18930 \$16622 \$16268 sg13g2_xnor2_1
* cell instance $144 m0 *1 339.36,260.82
X$144 VDD VSS \$19492 \$18820 \$19487 sg13g2_xnor2_1
* cell instance $145 m0 *1 41.76,298.62
X$145 VDD VSS \$20737 \$21677 \$21682 sg13g2_xnor2_1
* cell instance $146 m0 *1 35.52,238.14
X$146 VDD VSS \$16243 \$16229 \$16777 sg13g2_xnor2_1
* cell instance $147 m0 *1 104.16,185.22
X$147 VDD VSS \$11752 \$12294 \$12334 sg13g2_xnor2_1
* cell instance $148 m0 *1 121.44,343.98
X$148 VDD VSS \$25126 \$24594 \$23910 sg13g2_xnor2_1
* cell instance $149 m0 *1 103.2,245.7
X$149 VDD VSS \$17540 \$17009 \$15927 sg13g2_xnor2_1
* cell instance $150 r0 *1 246.24,298.62
X$150 VDD VSS \$22136 \$21846 \$21942 sg13g2_xnor2_1
* cell instance $151 r0 *1 250.08,298.62
X$151 VDD VSS \$22137 \$16764 \$17458 sg13g2_xnor2_1
* cell instance $152 r0 *1 288.96,132.3
X$152 VDD VSS \$8759 \$6962 \$6600 sg13g2_xnor2_1
* cell instance $153 r0 *1 249.12,291.06
X$153 VDD VSS \$21716 \$15062 \$20040 sg13g2_xnor2_1
* cell instance $154 r0 *1 343.2,321.3
X$154 VDD VSS \$23724 \$20066 \$22898 sg13g2_xnor2_1
* cell instance $155 r0 *1 142.08,207.9
X$155 VDD VSS \$15235 \$14549 \$14352 sg13g2_xnor2_1
* cell instance $156 r0 *1 264.48,268.38
X$156 VDD VSS \$20159 \$19572 \$19922 sg13g2_xnor2_1
* cell instance $157 r0 *1 99.36,215.46
X$157 VDD VSS \$13787 \$13311 \$13306 sg13g2_xnor2_1
* cell instance $158 r0 *1 124.8,230.58
X$158 VDD VSS \$16279 \$16136 \$15937 sg13g2_xnor2_1
* cell instance $159 r0 *1 326.88,245.7
X$159 VDD VSS \$17709 \$17697 \$16912 sg13g2_xnor2_1
* cell instance $160 r0 *1 92.16,215.46
X$160 VDD VSS \$15171 \$14998 \$15334 sg13g2_xnor2_1
* cell instance $161 r0 *1 129.12,238.14
X$161 VDD VSS \$16789 \$16888 \$13794 sg13g2_xnor2_1
* cell instance $162 r0 *1 333.6,275.94
X$162 VDD VSS \$20572 \$20466 \$20062 sg13g2_xnor2_1
* cell instance $163 r0 *1 321.12,154.98
X$163 VDD VSS \$9906 \$8922 \$10328 sg13g2_xnor2_1
* cell instance $164 r0 *1 113.76,336.42
X$164 VDD VSS \$24957 \$23255 \$24994 sg13g2_xnor2_1
* cell instance $165 r0 *1 136.32,260.82
X$165 VDD VSS \$19556 \$19417 \$19177 sg13g2_xnor2_1
* cell instance $166 r0 *1 133.92,336.42
X$166 VDD VSS \$24664 \$24367 \$24827 sg13g2_xnor2_1
* cell instance $167 r0 *1 237.12,298.62
X$167 VDD VSS \$22311 \$16772 \$19086 sg13g2_xnor2_1
* cell instance $168 r0 *1 132.48,230.58
X$168 VDD VSS \$16220 \$16050 \$15938 sg13g2_xnor2_1
* cell instance $169 r0 *1 84,230.58
X$169 VDD VSS \$16439 \$16255 \$16254 sg13g2_xnor2_1
* cell instance $170 r0 *1 107.52,298.62
X$170 VDD VSS \$21977 \$21827 \$21312 sg13g2_xnor2_1
* cell instance $171 r0 *1 83.52,223.02
X$171 VDD VSS \$15596 \$15004 \$15927 sg13g2_xnor2_1
* cell instance $172 r0 *1 119.52,306.18
X$172 VDD VSS \$22809 \$23101 \$22326 sg13g2_xnor2_1
* cell instance $173 r0 *1 84.48,215.46
X$173 VDD VSS \$14484 \$13720 \$13144 sg13g2_xnor2_1
* cell instance $174 r0 *1 320.16,230.58
X$174 VDD VSS \$16400 \$16165 \$15982 sg13g2_xnor2_1
* cell instance $175 r0 *1 310.08,313.74
X$175 VDD VSS \$23170 \$23027 \$16528 sg13g2_xnor2_1
* cell instance $176 r0 *1 79.68,223.02
X$176 VDD VSS \$15776 \$15638 \$15637 sg13g2_xnor2_1
* cell instance $177 r0 *1 119.52,200.34
X$177 VDD VSS \$13634 \$12655 \$13664 sg13g2_xnor2_1
* cell instance $178 r0 *1 211.68,215.46
X$178 VDD VSS \$15364 \$14811 \$14812 sg13g2_xnor2_1
* cell instance $179 r0 *1 134.88,328.86
X$179 VDD VSS \$23914 \$24055 \$23674 sg13g2_xnor2_1
* cell instance $180 r0 *1 337.44,328.86
X$180 VDD VSS \$24106 \$24107 \$23956 sg13g2_xnor2_1
* cell instance $181 r0 *1 262.56,328.86
X$181 VDD VSS \$24088 \$23148 \$23765 sg13g2_xnor2_1
* cell instance $182 r0 *1 257.28,306.18
X$182 VDD VSS \$22706 \$22342 \$19327 sg13g2_xnor2_1
* cell instance $183 r0 *1 128.64,185.22
X$183 VDD VSS \$11853 \$12803 \$12334 sg13g2_xnor2_1
* cell instance $184 r0 *1 105.12,245.7
X$184 VDD VSS \$18275 \$16793 \$15937 sg13g2_xnor2_1
* cell instance $185 r0 *1 121.92,245.7
X$185 VDD VSS \$17807 \$18026 \$17017 sg13g2_xnor2_1
* cell instance $186 r0 *1 264,321.3
X$186 VDD VSS \$23491 \$23455 \$15062 sg13g2_xnor2_1
* cell instance $187 r0 *1 343.68,170.1
X$187 VDD VSS \$3749 \$2653 \$588 sg13g2_xnor2_1
* cell instance $188 r0 *1 300.48,328.86
X$188 VDD VSS \$24096 \$24270 \$19020 sg13g2_xnor2_1
* cell instance $189 r0 *1 282.24,192.78
X$189 VDD VSS \$13070 \$12705 \$13221 sg13g2_xnor2_1
* cell instance $190 r0 *1 242.4,298.62
X$190 VDD VSS \$22315 \$22021 \$22024 sg13g2_xnor2_1
* cell instance $191 r0 *1 263.52,313.74
X$191 VDD VSS \$23149 \$22966 \$23295 sg13g2_xnor2_1
* cell instance $192 r0 *1 97.92,230.58
X$192 VDD VSS \$16260 \$16132 \$15927 sg13g2_xnor2_1
* cell instance $193 r0 *1 143.52,260.82
X$193 VDD VSS \$19178 \$19422 \$19731 sg13g2_xnor2_1
* cell instance $194 r0 *1 233.28,298.62
X$194 VDD VSS \$22132 \$21843 \$21842 sg13g2_xnor2_1
* cell instance $195 r0 *1 316.32,162.54
X$195 VDD VSS \$10795 \$10545 \$8057 sg13g2_xnor2_1
* cell instance $196 m0 *1 67.2,260.82
X$196 VSS VDD \$18880 \$17513 \$17740 sg13g2_nor2b_1
* cell instance $197 m0 *1 105.6,215.46
X$197 VSS VDD \$13504 \$13144 \$13147 sg13g2_nor2b_1
* cell instance $198 m0 *1 212.16,268.38
X$198 VSS VDD \$17896 \$19669 \$19747 sg13g2_nor2b_1
* cell instance $199 m0 *1 197.28,275.94
X$199 VSS VDD \$10488 \$20234 \$20233 sg13g2_nor2b_1
* cell instance $200 m0 *1 48,238.14
X$200 VSS VDD \$16669 \$14878 \$15631 sg13g2_nor2b_1
* cell instance $201 m0 *1 322.56,328.86
X$201 VSS VDD \$23564 \$23844 \$23721 sg13g2_nor2b_1
* cell instance $202 m0 *1 309.6,313.74
X$202 VSS VDD \$22474 \$17471 \$22728 sg13g2_nor2b_1
* cell instance $203 m0 *1 192.48,283.5
X$203 VSS VDD \$20528 \$20764 \$20665 sg13g2_nor2b_1
* cell instance $204 m0 *1 307.2,321.3
X$204 VSS VDD \$22728 \$16528 \$23027 sg13g2_nor2b_1
* cell instance $205 m0 *1 246.24,102.06
X$205 VSS VDD \$4359 \$5677 \$5661 sg13g2_nor2b_1
* cell instance $206 m0 *1 261.12,177.66
X$206 VSS VDD \$11728 \$12041 \$11713 sg13g2_nor2b_1
* cell instance $207 m0 *1 250.56,306.18
X$207 VSS VDD \$22623 \$17458 \$16764 sg13g2_nor2b_1
* cell instance $208 m0 *1 40.8,215.46
X$208 VSS VDD \$14646 \$14304 \$14305 sg13g2_nor2b_1
* cell instance $209 m0 *1 34.08,230.58
X$209 VSS VDD \$15629 \$15628 \$14299 sg13g2_nor2b_1
* cell instance $210 m0 *1 36,260.82
X$210 VSS VDD \$18728 \$16992 \$14299 sg13g2_nor2b_1
* cell instance $211 m0 *1 251.52,139.86
X$211 VSS VDD \$7653 \$8028 \$8909 sg13g2_nor2b_1
* cell instance $212 m0 *1 325.92,298.62
X$212 VSS VDD \$21459 \$21947 \$20361 sg13g2_nor2b_1
* cell instance $213 m0 *1 348.96,147.42
X$213 VSS VDD \$8674 \$9492 \$9306 sg13g2_nor2b_1
* cell instance $214 m0 *1 180.48,343.98
X$214 VSS VDD \$24753 \$24063 \$24387 sg13g2_nor2b_1
* cell instance $215 m0 *1 120.96,321.3
X$215 VSS VDD \$22935 \$23529 \$23101 sg13g2_nor2b_1
* cell instance $216 m0 *1 73.92,245.7
X$216 VSS VDD \$17004 \$17794 \$17413 sg13g2_nor2b_1
* cell instance $217 m0 *1 179.52,245.7
X$217 VSS VDD \$17436 \$15846 \$16800 sg13g2_nor2b_1
* cell instance $218 m0 *1 239.04,162.54
X$218 VSS VDD \$10651 \$9834 \$9833 sg13g2_nor2b_1
* cell instance $219 m0 *1 348,238.14
X$219 VSS VDD \$16368 \$14462 \$16816 sg13g2_nor2b_1
* cell instance $220 m0 *1 229.44,117.18
X$220 VSS VDD \$5642 \$7377 \$7186 sg13g2_nor2b_1
* cell instance $221 m0 *1 274.08,223.02
X$221 VSS VDD \$15378 \$6947 \$14405 sg13g2_nor2b_1
* cell instance $222 m0 *1 269.76,117.18
X$222 VSS VDD \$6356 \$6593 \$5731 sg13g2_nor2b_1
* cell instance $223 m0 *1 328.32,298.62
X$223 VSS VDD \$21578 \$21852 \$17693 sg13g2_nor2b_1
* cell instance $224 m0 *1 106.56,298.62
X$224 VSS VDD \$21779 \$21826 \$21827 sg13g2_nor2b_1
* cell instance $225 m0 *1 154.56,328.86
X$225 VSS VDD \$23677 \$24375 \$24057 sg13g2_nor2b_1
* cell instance $226 m0 *1 305.76,343.98
X$226 VSS VDD \$24787 \$23716 \$22026 sg13g2_nor2b_1
* cell instance $227 m0 *1 234.72,268.38
X$227 VSS VDD \$19440 \$18466 \$17876 sg13g2_nor2b_1
* cell instance $228 m0 *1 259.2,162.54
X$228 VSS VDD \$10476 \$10493 \$10833 sg13g2_nor2b_1
* cell instance $229 m0 *1 57.6,260.82
X$229 VSS VDD \$18878 \$17003 \$17513 sg13g2_nor2b_1
* cell instance $230 m0 *1 268.32,192.78
X$230 VSS VDD \$12311 \$12689 \$12700 sg13g2_nor2b_1
* cell instance $231 r0 *1 156,230.58
X$231 VSS VDD \$15942 \$16136 \$16289 sg13g2_nor2b_1
* cell instance $232 r0 *1 162.24,207.9
X$232 VSS VDD \$14358 \$12901 \$14043 sg13g2_nor2b_1
* cell instance $233 r0 *1 224.64,253.26
X$233 VSS VDD \$18786 \$17677 \$18296 sg13g2_nor2b_1
* cell instance $234 r0 *1 170.88,207.9
X$234 VSS VDD \$14210 \$14211 \$12655 sg13g2_nor2b_1
* cell instance $235 r0 *1 48,291.06
X$235 VSS VDD \$21294 \$20744 \$21358 sg13g2_nor2b_1
* cell instance $236 r0 *1 266.4,328.86
X$236 VSS VDD \$23937 \$23456 \$16311 sg13g2_nor2b_1
* cell instance $237 r0 *1 229.44,268.38
X$237 VSS VDD \$19090 \$17876 \$18466 sg13g2_nor2b_1
* cell instance $238 r0 *1 274.56,306.18
X$238 VSS VDD \$22585 \$22518 \$22151 sg13g2_nor2b_1
* cell instance $239 r0 *1 59.52,298.62
X$239 VSS VDD \$21867 \$22090 \$22089 sg13g2_nor2b_1
* cell instance $240 r0 *1 228.96,117.18
X$240 VSS VDD \$7627 \$7388 \$5320 sg13g2_nor2b_1
* cell instance $241 r0 *1 105.6,238.14
X$241 VSS VDD \$16620 \$16255 \$16260 sg13g2_nor2b_1
* cell instance $242 r0 *1 63.36,260.82
X$242 VSS VDD \$19170 \$19166 \$19171 sg13g2_nor2b_1
* cell instance $243 r0 *1 246.72,291.06
X$243 VSS VDD \$21663 \$20040 \$15062 sg13g2_nor2b_1
* cell instance $244 r0 *1 47.04,238.14
X$244 VSS VDD \$17179 \$16244 \$16243 sg13g2_nor2b_1
* cell instance $245 r0 *1 267.84,321.3
X$245 VSS VDD \$23703 \$23455 \$15062 sg13g2_nor2b_1
* cell instance $246 r0 *1 141.6,245.7
X$246 VSS VDD \$17823 \$17822 \$17821 sg13g2_nor2b_1
* cell instance $247 r0 *1 189.6,139.86
X$247 VSS VDD \$7779 \$9420 \$9424 sg13g2_nor2b_1
* cell instance $248 r0 *1 323.04,215.46
X$248 VSS VDD \$14431 \$14075 \$11949 sg13g2_nor2b_1
* cell instance $249 r0 *1 254.4,283.5
X$249 VSS VDD \$21070 \$20241 \$18477 sg13g2_nor2b_1
* cell instance $250 m0 *1 51.84,238.14
X$250 VDD VSS \$16236 \$15625 \$16238 \$16779 sg13g2_a21o_1
* cell instance $251 m0 *1 129.6,139.86
X$251 VDD VSS \$8594 \$8197 \$7337 \$8432 sg13g2_a21o_1
* cell instance $252 m0 *1 310.08,124.74
X$252 VDD VSS \$5451 \$6122 \$5891 \$5443 sg13g2_a21o_1
* cell instance $253 m0 *1 77.76,245.7
X$253 VDD VSS \$17413 \$15920 \$17796 \$17797 sg13g2_a21o_1
* cell instance $254 m0 *1 306.24,154.98
X$254 VDD VSS \$9947 \$9139 \$8697 \$2431 sg13g2_a21o_1
* cell instance $255 m0 *1 38.4,268.38
X$255 VDD VSS \$19395 \$17767 \$19396 \$19711 sg13g2_a21o_1
* cell instance $256 m0 *1 240,154.98
X$256 VDD VSS \$9833 \$9395 \$10173 \$10309 sg13g2_a21o_1
* cell instance $257 m0 *1 180,162.54
X$257 VDD VSS \$10622 \$10290 \$10467 \$10617 sg13g2_a21o_1
* cell instance $258 m0 *1 133.44,200.34
X$258 VDD VSS \$13153 \$12973 \$14033 \$13668 sg13g2_a21o_1
* cell instance $259 m0 *1 324.96,170.1
X$259 VDD VSS \$3074 \$7422 \$7423 \$2402 sg13g2_a21o_1
* cell instance $260 m0 *1 99.84,298.62
X$260 VDD VSS \$21880 \$20224 \$21691 \$21924 sg13g2_a21o_1
* cell instance $261 m0 *1 111.36,283.5
X$261 VDD VSS \$21184 \$20097 \$20653 \$20920 sg13g2_a21o_1
* cell instance $262 m0 *1 70.08,313.74
X$262 VDD VSS \$23239 \$22172 \$22862 \$22863 sg13g2_a21o_1
* cell instance $263 m0 *1 88.8,343.98
X$263 VDD VSS \$24815 \$23440 \$23795 \$23340 sg13g2_a21o_1
* cell instance $264 m0 *1 170.88,328.86
X$264 VDD VSS \$24239 \$20922 \$24242 \$23827 sg13g2_a21o_1
* cell instance $265 m0 *1 282.24,102.06
X$265 VDD VSS \$5731 \$5505 \$5672 \$5875 sg13g2_a21o_1
* cell instance $266 m0 *1 128.16,351.54
X$266 VDD VSS \$25118 \$24385 \$23910 \$24594 sg13g2_a21o_1
* cell instance $267 m0 *1 257.28,139.86
X$267 VDD VSS \$8372 \$6794 \$8030 \$9290 sg13g2_a21o_1
* cell instance $268 m0 *1 269.76,154.98
X$268 VDD VSS \$9997 \$9054 \$9840 \$10063 sg13g2_a21o_1
* cell instance $269 m0 *1 80.64,306.18
X$269 VDD VSS \$22382 \$21538 \$22320 \$22383 sg13g2_a21o_1
* cell instance $270 m0 *1 348.48,154.98
X$270 VDD VSS \$9847 \$7841 \$588 \$2653 sg13g2_a21o_1
* cell instance $271 r0 *1 56.16,298.62
X$271 VDD VSS \$22089 \$20814 \$21957 \$22003 sg13g2_a21o_1
* cell instance $272 r0 *1 81.6,260.82
X$272 VDD VSS \$19174 \$17781 \$19173 \$19175 sg13g2_a21o_1
* cell instance $273 r0 *1 129.6,245.7
X$273 VDD VSS \$17654 \$17425 \$16888 \$16781 sg13g2_a21o_1
* cell instance $274 r0 *1 266.4,306.18
X$274 VDD VSS \$22711 \$18477 \$22344 \$22145 sg13g2_a21o_1
* cell instance $275 r0 *1 324.48,283.5
X$275 VDD VSS \$20281 \$20800 \$21125 \$20947 sg13g2_a21o_1
* cell instance $276 r0 *1 261.12,306.18
X$276 VDD VSS \$22707 \$19086 \$22344 \$20159 sg13g2_a21o_1
* cell instance $277 r0 *1 348.48,147.42
X$277 VDD VSS \$9682 \$4643 \$5917 \$4641 sg13g2_a21o_1
* cell instance $278 r0 *1 260.64,230.58
X$278 VDD VSS \$16545 \$17099 \$7136 \$13442 sg13g2_a21o_1
* cell instance $279 r0 *1 23.04,223.02
X$279 VDD VSS \$15725 \$14974 \$15540 \$15627 sg13g2_a21o_1
* cell instance $280 r0 *1 162.72,321.3
X$280 VDD VSS \$23538 \$23630 \$23510 \$23540 sg13g2_a21o_1
* cell instance $281 r0 *1 261.12,147.42
X$281 VDD VSS \$10489 \$9650 \$9474 \$9653 sg13g2_a21o_1
* cell instance $282 r0 *1 69.12,207.9
X$282 VDD VSS \$14312 \$13456 \$14012 \$14014 sg13g2_a21o_1
* cell instance $283 r0 *1 320.16,162.54
X$283 VDD VSS \$10663 \$10668 \$8057 \$10545 sg13g2_a21o_1
* cell instance $284 r0 *1 42.24,207.9
X$284 VDD VSS \$14305 \$12880 \$14089 \$14198 sg13g2_a21o_1
* cell instance $285 r0 *1 271.2,185.22
X$285 VDD VSS \$11891 \$12054 \$12278 \$12314 sg13g2_a21o_1
* cell instance $286 r0 *1 124.32,298.62
X$286 VDD VSS \$22106 \$21435 \$21548 \$21547 sg13g2_a21o_1
* cell instance $287 r0 *1 31.2,207.9
X$287 VDD VSS \$14448 \$13485 \$14193 \$14009 sg13g2_a21o_1
* cell instance $288 r0 *1 328.32,207.9
X$288 VDD VSS \$14463 \$14255 \$14462 \$13706 sg13g2_a21o_1
* cell instance $289 r0 *1 86.88,275.94
X$289 VDD VSS \$20584 \$19070 \$19979 \$20228 sg13g2_a21o_1
* cell instance $290 r0 *1 68.16,275.94
X$290 VDD VSS \$20578 \$19491 \$20345 \$20746 sg13g2_a21o_1
* cell instance $291 r0 *1 304.8,170.1
X$291 VDD VSS \$11612 \$11215 \$11034 \$10710 sg13g2_a21o_1
* cell instance $292 r0 *1 274.08,162.54
X$292 VDD VSS \$11027 \$9589 \$11026 \$11276 sg13g2_a21o_1
* cell instance $293 r0 *1 285.6,132.3
X$293 VDD VSS \$6945 \$6818 \$7898 \$6958 sg13g2_a21o_1
* cell instance $294 r0 *1 323.52,245.7
X$294 VDD VSS \$17511 \$17120 \$16912 \$17697 sg13g2_a21o_1
* cell instance $295 r0 *1 164.16,245.7
X$295 VDD VSS \$16294 \$18079 \$17664 \$17435 sg13g2_a21o_1
* cell instance $296 r0 *1 97.44,253.26
X$296 VDD VSS \$18526 \$18917 \$17009 \$16781 sg13g2_a21o_1
* cell instance $297 r0 *1 239.52,306.18
X$297 VDD VSS \$22699 \$22545 \$20456 \$16806 sg13g2_a21o_1
* cell instance $298 m0 *1 252.48,192.78
X$298 VDD VSS \$12695 \$12690 \$12591 \$12691 sg13g2_and3_1
* cell instance $299 m0 *1 230.4,132.3
X$299 VDD VSS \$8905 \$7184 \$8018 \$7186 sg13g2_and3_1
* cell instance $300 m0 *1 255.36,162.54
X$300 VDD VSS \$5675 \$10481 \$10489 \$8617 sg13g2_and3_1
* cell instance $301 m0 *1 313.92,336.42
X$301 VDD VSS \$23716 \$23563 \$23717 \$24552 sg13g2_and3_1
* cell instance $302 m0 *1 242.4,306.18
X$302 VDD VSS \$20456 \$22545 \$16806 \$22340 sg13g2_and3_1
* cell instance $303 m0 *1 128.64,306.18
X$303 VDD VSS \$21507 \$22326 \$22325 \$21694 sg13g2_and3_1
* cell instance $304 m0 *1 265.92,177.66
X$304 VDD VSS \$11892 \$11713 \$11891 \$11939 sg13g2_and3_1
* cell instance $305 m0 *1 213.6,162.54
X$305 VDD VSS \$8899 \$9272 \$8272 \$10480 sg13g2_and3_1
* cell instance $306 m0 *1 202.56,177.66
X$306 VDD VSS \$10963 \$11007 \$10876 \$10873 sg13g2_and3_1
* cell instance $307 m0 *1 253.92,139.86
X$307 VDD VSS \$6356 \$7705 \$7653 \$8018 sg13g2_and3_1
* cell instance $308 m0 *1 221.76,124.74
X$308 VDD VSS \$7368 \$7182 \$7181 \$7695 sg13g2_and3_1
* cell instance $309 m0 *1 282.72,162.54
X$309 VDD VSS \$9964 \$11031 \$10312 \$10175 sg13g2_and3_1
* cell instance $310 m0 *1 110.4,328.86
X$310 VDD VSS \$23791 \$23441 \$23818 \$23665 sg13g2_and3_1
* cell instance $311 r0 *1 347.04,321.3
X$311 VDD VSS \$22898 \$20066 \$22899 \$23354 sg13g2_and3_1
* cell instance $312 r0 *1 273.6,200.34
X$312 VDD VSS \$13224 \$12700 \$13598 \$12705 sg13g2_and3_1
* cell instance $313 r0 *1 143.52,275.94
X$313 VDD VSS \$19177 \$19417 \$19419 \$19909 sg13g2_and3_1
* cell instance $314 r0 *1 208.32,215.46
X$314 VDD VSS \$14812 \$14811 \$14223 \$14382 sg13g2_and3_1
* cell instance $315 r0 *1 341.28,328.86
X$315 VDD VSS \$23956 \$24107 \$24282 \$22743 sg13g2_and3_1
* cell instance $316 r0 *1 124.32,313.74
X$316 VDD VSS \$21549 \$21694 \$21623 \$21385 sg13g2_and3_1
* cell instance $317 r0 *1 224.64,117.18
X$317 VDD VSS \$7181 \$7627 \$7182 \$7180 sg13g2_and3_1
* cell instance $318 r0 *1 209.76,139.86
X$318 VDD VSS \$8899 \$9124 \$8272 \$8612 sg13g2_and3_1
* cell instance $319 r0 *1 203.52,170.1
X$319 VDD VSS \$10733 \$10474 \$10730 \$11007 sg13g2_and3_1
* cell instance $320 r0 *1 250.56,200.34
X$320 VDD VSS \$12921 \$12691 \$12920 \$13199 sg13g2_and3_1
* cell instance $321 m0 *1 166.08,328.86
X$321 VSS \$23342 \$20922 \$23119 \$23421 VDD sg13g2_mux2_1
* cell instance $322 m0 *1 143.04,306.18
X$322 VSS \$22260 \$20658 \$20758 \$20046 VDD sg13g2_mux2_1
* cell instance $323 m0 *1 172.32,283.5
X$323 VSS \$20523 \$20006 \$21042 \$19623 VDD sg13g2_mux2_1
* cell instance $324 m0 *1 175.2,192.78
X$324 VSS \$12347 \$12298 \$12351 \$12909 VDD sg13g2_mux2_1
* cell instance $325 m0 *1 180,192.78
X$325 VSS \$2703 osc_clk VDD sg13g2_buf_16
* cell instance $326 m0 *1 209.76,298.62
X$326 VSS \$21712 \$21051 \$19086 \$10831 VDD sg13g2_mux2_1
* cell instance $327 m0 *1 278.88,215.46
X$327 VSS \$14409 \$14232 \$12452 \$14068 VDD sg13g2_mux2_1
* cell instance $328 m0 *1 291.36,313.74
X$328 VSS \$22722 \$20942 \$13512 \$16528 VDD sg13g2_mux2_1
* cell instance $329 m0 *1 304.32,291.06
X$329 VSS \$21091 \$20363 \$12711 \$17693 VDD sg13g2_mux2_1
* cell instance $330 m0 *1 151.68,313.74
X$330 VSS \$22674 \$22679 \$22118 \$13948 VDD sg13g2_mux2_1
* cell instance $331 m0 *1 156.48,313.74
X$331 VSS \$22119 \$20922 \$20758 \$21559 VDD sg13g2_mux2_1
* cell instance $332 m0 *1 184.32,245.7
X$332 VSS \$17059 \$15946 \$13228 \$16796 VDD sg13g2_mux2_1
* cell instance $333 m0 *1 151.68,185.22
X$333 VSS \$12015 \$12298 \$12342 \$12819 VDD sg13g2_mux2_1
* cell instance $334 m0 *1 190.08,306.18
X$334 VSS \$22334 \$20658 \$21936 \$22418 VDD sg13g2_mux2_1
* cell instance $335 m0 *1 182.88,215.46
X$335 VSS \$14376 \$13969 \$13948 \$14043 VDD sg13g2_mux2_1
* cell instance $336 m0 *1 155.04,253.26
X$336 VSS \$17832 \$14893 \$17830 \$17828 VDD sg13g2_mux2_1
* cell instance $337 m0 *1 185.76,230.58
X$337 VSS \$15665 \$15946 \$14666 \$15353 VDD sg13g2_mux2_1
* cell instance $338 m0 *1 258.72,336.42
X$338 VSS \$24546 \$21051 \$16764 \$16473 VDD sg13g2_mux2_1
* cell instance $339 m0 *1 60,260.82
X$339 VSS \$18270 \$14878 \$18445 \$17408 VDD sg13g2_mux2_1
* cell instance $340 m0 *1 190.08,313.74
X$340 VSS \$22682 \$22679 \$22400 \$21724 VDD sg13g2_mux2_1
* cell instance $341 m0 *1 160.32,230.58
X$341 VSS \$15884 \$14893 \$15655 \$15861 VDD sg13g2_mux2_1
* cell instance $342 m0 *1 188.64,238.14
X$342 VSS \$16303 \$15946 \$16082 \$16289 VDD sg13g2_mux2_1
* cell instance $343 m0 *1 192,298.62
X$343 VSS \$21707 \$20664 \$21935 \$21710 VDD sg13g2_mux2_1
* cell instance $344 m0 *1 297.6,192.78
X$344 VSS \$12801 \$12377 \$12711 \$12061 VDD sg13g2_mux2_1
* cell instance $345 m0 *1 125.28,298.62
X$345 VSS \$18723 \$19732 \$21314 \$21796 VDD sg13g2_mux2_1
* cell instance $346 m0 *1 283.68,268.38
X$346 VSS \$20051 \$19682 \$19205 \$17465 VDD sg13g2_mux2_1
* cell instance $347 m0 *1 279.36,336.42
X$347 VSS \$24463 \$22715 \$16082 \$20127 VDD sg13g2_mux2_1
* cell instance $348 m0 *1 303.36,260.82
X$348 VSS \$19251 \$13229 \$19205 \$19113 VDD sg13g2_mux2_1
* cell instance $349 m0 *1 59.04,238.14
X$349 VSS \$16246 \$14878 \$16244 \$16243 VDD sg13g2_mux2_1
* cell instance $350 m0 *1 185.28,328.86
X$350 VSS \$23689 \$22679 \$23119 \$16082 VDD sg13g2_mux2_1
* cell instance $351 m0 *1 187.2,207.9
X$351 VSS \$14175 \$13969 \$13512 \$13967 VDD sg13g2_mux2_1
* cell instance $352 m0 *1 274.08,321.3
X$352 VSS \$23489 \$22715 \$13512 \$21079 VDD sg13g2_mux2_1
* cell instance $353 m0 *1 305.28,298.62
X$353 VSS \$21725 \$20363 \$12057 \$20361 VDD sg13g2_mux2_1
* cell instance $354 m0 *1 147.36,283.5
X$354 VSS \$20518 \$20658 \$20223 \$18907 VDD sg13g2_mux2_1
* cell instance $355 m0 *1 179.04,291.06
X$355 VSS \$21249 \$20664 \$21042 \$13585 VDD sg13g2_mux2_1
* cell instance $356 m0 *1 223.68,291.06
X$356 VSS \$21280 \$20342 \$12057 \$16772 VDD sg13g2_mux2_1
* cell instance $357 m0 *1 287.52,306.18
X$357 VSS \$22153 \$20942 \$12711 \$22026 VDD sg13g2_mux2_1
* cell instance $358 m0 *1 180.48,328.86
X$358 VSS \$23687 \$22679 \$23828 \$21060 VDD sg13g2_mux2_1
* cell instance $359 m0 *1 187.2,260.82
X$359 VSS \$19306 \$16633 \$10831 \$15359 VDD sg13g2_mux2_1
* cell instance $360 m0 *1 159.36,275.94
X$360 VSS \$20007 \$20006 \$20223 \$19098 VDD sg13g2_mux2_1
* cell instance $361 m0 *1 182.88,306.18
X$361 VSS \$22280 \$20922 \$21936 \$22126 VDD sg13g2_mux2_1
* cell instance $362 m0 *1 250.56,321.3
X$362 VSS \$23309 \$21051 \$15062 \$22418 VDD sg13g2_mux2_1
* cell instance $363 m0 *1 257.28,291.06
X$363 VSS \$21407 \$21051 \$21071 \$21441 VDD sg13g2_mux2_1
* cell instance $364 m0 *1 297.6,215.46
X$364 VSS \$14416 \$12059 \$14666 \$11519 VDD sg13g2_mux2_1
* cell instance $365 m0 *1 283.2,328.86
X$365 VSS \$23942 \$20942 \$22418 \$18205 VDD sg13g2_mux2_1
* cell instance $366 m0 *1 160.32,283.5
X$366 VSS \$20521 \$20006 \$20758 \$19608 VDD sg13g2_mux2_1
* cell instance $367 r0 *1 135.36,298.62
X$367 VSS \$21799 \$21554 \$13948 \$20519 VDD sg13g2_mux2_1
* cell instance $368 r0 *1 184.32,321.3
X$368 VSS \$23291 \$20922 \$22400 \$23114 VDD sg13g2_mux2_1
* cell instance $369 r0 *1 302.88,207.9
X$369 VSS \$14071 \$13229 \$12711 \$13851 VDD sg13g2_mux2_1
* cell instance $370 r0 *1 264.48,223.02
X$370 VSS \$15691 \$14232 \$12710 \$15690 VDD sg13g2_mux2_1
* cell instance $371 r0 *1 172.32,185.22
X$371 VSS \$12187 \$12298 \$11704 \$12183 VDD sg13g2_mux2_1
* cell instance $372 r0 *1 301.92,260.82
X$372 VSS \$19535 \$15168 \$16082 \$12062 VDD sg13g2_mux2_1
* cell instance $373 r0 *1 157.44,192.78
X$373 VSS \$12832 \$12298 \$12019 \$13168 VDD sg13g2_mux2_1
* cell instance $374 r0 *1 175.2,238.14
X$374 VSS \$17056 \$14893 \$16800 \$16799 VDD sg13g2_mux2_1
* cell instance $375 r0 *1 292.32,313.74
X$375 VSS \$23166 \$20942 \$16082 \$17471 VDD sg13g2_mux2_1
* cell instance $376 r0 *1 182.88,207.9
X$376 VSS \$14377 \$13969 \$13585 \$14211 VDD sg13g2_mux2_1
* cell instance $377 r0 *1 156.96,245.7
X$377 VSS \$17833 \$14893 \$17831 \$17583 VDD sg13g2_mux2_1
* cell instance $378 r0 *1 180.96,268.38
X$378 VSS \$19740 \$18769 \$10831 \$19735 VDD sg13g2_mux2_1
* cell instance $379 r0 *1 180,245.7
X$379 VSS \$17849 \$17669 \$13585 \$17665 VDD sg13g2_mux2_1
* cell instance $380 r0 *1 160.8,283.5
X$380 VSS \$21040 \$20006 \$22118 \$18638 VDD sg13g2_mux2_1
* cell instance $381 r0 *1 173.28,177.66
X$381 VSS \$11767 \$12298 \$11480 \$11484 VDD sg13g2_mux2_1
* cell instance $382 r0 *1 304.8,253.26
X$382 VSS \$18838 \$13229 \$18907 \$18487 VDD sg13g2_mux2_1
* cell instance $383 r0 *1 286.08,260.82
X$383 VSS \$19555 \$19682 \$20046 \$17905 VDD sg13g2_mux2_1
* cell instance $384 r0 *1 257.76,336.42
X$384 VSS \$24769 \$21051 \$16806 \$21060 VDD sg13g2_mux2_1
* cell instance $385 r0 *1 159.36,238.14
X$385 VSS \$17049 \$14893 \$16798 \$17046 VDD sg13g2_mux2_1
* cell instance $386 r0 *1 166.08,321.3
X$386 VSS \$22869 \$22679 \$23421 \$20772 VDD sg13g2_mux2_1
* cell instance $387 r0 *1 210.72,298.62
X$387 VSS \$22129 \$21051 \$19327 \$12893 VDD sg13g2_mux2_1
* cell instance $388 r0 *1 182.88,215.46
X$388 VSS \$14898 \$13969 \$14666 \$14896 VDD sg13g2_mux2_1
* cell instance $389 r0 *1 292.32,283.5
X$389 VSS \$21616 \$20942 \$12057 \$21085 VDD sg13g2_mux2_1
* cell instance $390 r0 *1 175.2,245.7
X$390 VSS \$18107 \$14893 \$17668 \$17054 VDD sg13g2_mux2_1
* cell instance $391 r0 *1 155.04,200.34
X$391 VSS \$13811 \$12298 \$13810 \$13809 VDD sg13g2_mux2_1
* cell instance $392 r0 *1 232.32,313.74
X$392 VSS \$23131 \$21051 \$16311 \$21724 VDD sg13g2_mux2_1
* cell instance $393 r0 *1 255.36,291.06
X$393 VSS \$21568 \$21051 \$18477 \$12710 VDD sg13g2_mux2_1
* cell instance $394 r0 *1 142.08,298.62
X$394 VSS \$21990 \$21554 \$18907 \$19732 VDD sg13g2_mux2_1
* cell instance $395 r0 *1 154.08,215.46
X$395 VSS \$15030 \$14893 \$14802 \$14801 VDD sg13g2_mux2_1
* cell instance $396 r0 *1 206.88,313.74
X$396 VSS \$22873 \$20006 \$23119 \$19674 VDD sg13g2_mux2_1
* cell instance $397 r0 *1 156,283.5
X$397 VSS \$21231 \$20922 \$20223 \$21039 VDD sg13g2_mux2_1
* cell instance $398 r0 *1 154.08,177.66
X$398 VSS \$12018 \$12298 \$11762 \$12016 VDD sg13g2_mux2_1
* cell instance $399 r0 *1 177.12,185.22
X$399 VSS \$12667 \$12298 \$12222 \$12854 VDD sg13g2_mux2_1
* cell instance $400 r0 *1 163.68,298.62
X$400 VSS \$21702 \$20658 \$21039 \$20764 VDD sg13g2_mux2_1
* cell instance $401 r0 *1 189.12,321.3
X$401 VSS \$23011 \$22679 \$23114 \$20532 VDD sg13g2_mux2_1
* cell instance $402 r0 *1 163.2,230.58
X$402 VSS \$16297 \$14893 \$15944 \$16534 VDD sg13g2_mux2_1
* cell instance $403 r0 *1 287.52,283.5
X$403 VSS \$21083 \$20942 \$12452 \$21082 VDD sg13g2_mux2_1
* cell instance $404 r0 *1 168.48,298.62
X$404 VSS \$22273 \$20922 \$22118 \$21935 VDD sg13g2_mux2_1
* cell instance $405 r0 *1 203.04,306.18
X$405 VSS \$22687 \$20006 \$22400 \$19669 VDD sg13g2_mux2_1
* cell instance $406 r0 *1 288.48,185.22
X$406 VSS \$12373 \$12377 \$12057 \$12374 VDD sg13g2_mux2_1
* cell instance $407 r0 *1 278.88,215.46
X$407 VSS \$15071 \$14232 \$13228 \$14422 VDD sg13g2_mux2_1
* cell instance $408 r0 *1 278.4,207.9
X$408 VSS \$14408 \$14232 \$13512 \$13244 VDD sg13g2_mux2_1
* cell instance $409 r0 *1 173.28,298.62
X$409 VSS \$21998 \$20922 \$21042 \$21934 VDD sg13g2_mux2_1
* cell instance $410 r0 *1 304.8,275.94
X$410 VSS \$20055 \$20363 \$14666 \$17714 VDD sg13g2_mux2_1
* cell instance $411 m0 *1 308.16,343.98
X$411 VDD VSS \$24872 \$24774 \$25041 \$22734 sg13g2_nor3_1
* cell instance $412 m0 *1 80.16,291.06
X$412 VDD VSS \$20747 \$21016 \$21019 \$20916 sg13g2_nor3_1
* cell instance $413 m0 *1 40.32,291.06
X$413 VDD VSS \$20997 \$20995 \$21473 \$21006 sg13g2_nor3_1
* cell instance $414 m0 *1 168,192.78
X$414 VDD VSS \$12658 \$12657 \$12905 \$12903 sg13g2_nor3_1
* cell instance $415 m0 *1 258.72,192.78
X$415 VDD VSS \$13010 \$12697 \$13094 \$12364 sg13g2_nor3_1
* cell instance $416 m0 *1 253.92,177.66
X$416 VDD VSS \$11709 \$11502 \$11728 \$11498 sg13g2_nor3_1
* cell instance $417 m0 *1 275.04,343.98
X$417 VDD VSS \$24092 \$24791 \$24263 \$16764 sg13g2_nor3_1
* cell instance $418 m0 *1 113.28,132.3
X$418 VDD VSS \$8157 \$6166 \$8427 \$8577 sg13g2_nor3_1
* cell instance $419 m0 *1 211.68,275.94
X$419 VDD VSS \$20016 \$13060 \$20017 \$20236 sg13g2_nor3_1
* cell instance $420 m0 *1 178.56,351.54
X$420 VDD VSS \$23827 \$23684 \$24389 \$24242 sg13g2_nor3_1
* cell instance $421 m0 *1 243.36,200.34
X$421 VDD VSS \$13199 \$13200 \$13591 \$12046 sg13g2_nor3_1
* cell instance $422 m0 *1 39.36,223.02
X$422 VDD VSS \$14298 \$14872 \$14646 \$14871 sg13g2_nor3_1
* cell instance $423 m0 *1 332.64,268.38
X$423 VDD VSS \$19778 \$19482 \$20066 \$14075 sg13g2_nor3_1
* cell instance $424 m0 *1 312.48,351.54
X$424 VDD VSS \$24552 \$24841 \$22734 \$23715 sg13g2_nor3_1
* cell instance $425 m0 *1 207.84,230.58
X$425 VDD VSS \$15553 \$16560 \$16561 \$13820 sg13g2_nor3_1
* cell instance $426 m0 *1 73.92,109.62
X$426 VDD VSS \$5817 \$6402 \$1846 \$5953 sg13g2_nor3_1
* cell instance $427 m0 *1 59.04,283.5
X$427 VDD VSS \$20650 \$20649 \$21007 \$20914 sg13g2_nor3_1
* cell instance $428 m0 *1 312,230.58
X$428 VDD VSS \$16178 \$15802 \$16182 \$15086 sg13g2_nor3_1
* cell instance $429 m0 *1 336.96,291.06
X$429 VDD VSS \$21107 \$21337 \$21114 \$20558 sg13g2_nor3_1
* cell instance $430 m0 *1 216,102.06
X$430 VDD VSS \$5027 \$4565 \$5849 \$5338 sg13g2_nor3_1
* cell instance $431 m0 *1 322.56,306.18
X$431 VDD VSS \$17701 \$22158 \$22349 \$20021 sg13g2_nor3_1
* cell instance $432 m0 *1 264.96,200.34
X$432 VDD VSS \$12700 \$13560 \$13597 \$12514 sg13g2_nor3_1
* cell instance $433 m0 *1 218.4,336.42
X$433 VDD VSS \$24540 \$24391 \$24246 \$24249 sg13g2_nor3_1
* cell instance $434 m0 *1 67.68,306.18
X$434 VDD VSS \$22318 \$22376 \$22377 \$21006 sg13g2_nor3_1
* cell instance $435 m0 *1 231.36,260.82
X$435 VDD VSS \$19091 \$15675 \$19190 \$17331 sg13g2_nor3_1
* cell instance $436 m0 *1 161.76,192.78
X$436 VDD VSS \$11483 \$13116 \$13115 \$12657 sg13g2_nor3_1
* cell instance $437 m0 *1 204.48,139.86
X$437 VDD VSS \$8612 \$7039 \$8898 \$5338 sg13g2_nor3_1
* cell instance $438 m0 *1 315.84,102.06
X$438 VDD VSS \$5188 \$4366 \$5975 \$5678 sg13g2_nor3_1
* cell instance $439 m0 *1 264,139.86
X$439 VDD VSS \$8367 \$7407 \$8636 \$11195 sg13g2_nor3_1
* cell instance $440 m0 *1 54.24,306.18
X$440 VDD VSS \$22449 \$22651 \$22365 \$21006 sg13g2_nor3_1
* cell instance $441 m0 *1 272.16,253.26
X$441 VDD VSS \$18131 \$18481 \$18132 \$17900 sg13g2_nor3_1
* cell instance $442 m0 *1 172.32,177.66
X$442 VDD VSS \$11613 \$11764 \$11475 \$11478 sg13g2_nor3_1
* cell instance $443 m0 *1 55.2,283.5
X$443 VDD VSS \$20649 \$19489 \$20648 \$21006 sg13g2_nor3_1
* cell instance $444 m0 *1 286.08,139.86
X$444 VDD VSS \$5717 \$5180 \$6597 \$5678 sg13g2_nor3_1
* cell instance $445 m0 *1 323.04,230.58
X$445 VDD VSS \$15710 \$15771 \$15585 \$15983 sg13g2_nor3_1
* cell instance $446 m0 *1 301.44,132.3
X$446 VDD VSS \$6209 \$7820 \$8465 \$5678 sg13g2_nor3_1
* cell instance $447 m0 *1 291.36,139.86
X$447 VDD VSS \$8178 \$7778 \$8754 \$5175 sg13g2_nor3_1
* cell instance $448 m0 *1 214.56,336.42
X$448 VDD VSS \$24496 \$24494 \$24360 \$23694 sg13g2_nor3_1
* cell instance $449 m0 *1 238.56,177.66
X$449 VDD VSS \$11680 \$11499 \$11909 \$11498 sg13g2_nor3_1
* cell instance $450 m0 *1 84.96,291.06
X$450 VDD VSS \$16959 \$20225 \$21166 \$19720 sg13g2_nor3_1
* cell instance $451 m0 *1 206.4,275.94
X$451 VDD VSS \$20016 \$13681 \$20017 \$20236 sg13g2_nor3_1
* cell instance $452 m0 *1 175.2,215.46
X$452 VDD VSS \$14372 \$14367 \$14585 \$14214 sg13g2_nor3_1
* cell instance $453 m0 *1 212.16,336.42
X$453 VDD VSS \$24031 \$24486 \$24361 \$24068 sg13g2_nor3_1
* cell instance $454 m0 *1 75.84,306.18
X$454 VDD VSS \$22212 \$21300 \$22008 \$19720 sg13g2_nor3_1
* cell instance $455 m0 *1 72,291.06
X$455 VDD VSS \$21016 \$20745 \$21539 \$21006 sg13g2_nor3_1
* cell instance $456 m0 *1 202.56,215.46
X$456 VDD VSS \$14382 \$14612 \$14630 \$13013 sg13g2_nor3_1
* cell instance $457 m0 *1 203.04,200.34
X$457 VDD VSS \$10474 \$13412 \$13771 \$10872 sg13g2_nor3_1
* cell instance $458 m0 *1 132.96,245.7
X$458 VDD VSS \$16276 \$17289 \$17030 \$17428 sg13g2_nor3_1
* cell instance $459 m0 *1 335.52,321.3
X$459 VDD VSS \$23354 \$23189 \$23359 \$23183 sg13g2_nor3_1
* cell instance $460 m0 *1 278.4,170.1
X$460 VDD VSS \$10314 \$10062 \$11028 \$8637 sg13g2_nor3_1
* cell instance $461 m0 *1 321.6,207.9
X$461 VDD VSS \$13481 \$14095 \$14075 \$14242 sg13g2_nor3_1
* cell instance $462 m0 *1 177.6,336.42
X$462 VDD VSS \$23827 \$24387 \$24389 \$24477 sg13g2_nor3_1
* cell instance $463 m0 *1 221.28,102.06
X$463 VDD VSS \$5642 \$3506 \$5572 \$5338 sg13g2_nor3_1
* cell instance $464 m0 *1 129.6,245.7
X$464 VDD VSS \$16794 \$17425 \$17026 \$15647 sg13g2_nor3_1
* cell instance $465 m0 *1 249.6,260.82
X$465 VDD VSS \$18301 \$17474 \$18814 \$19098 sg13g2_nor3_1
* cell instance $466 m0 *1 281.76,154.98
X$466 VDD VSS \$9653 \$8793 \$9991 \$8637 sg13g2_nor3_1
* cell instance $467 m0 *1 228.48,253.26
X$467 VDD VSS \$13977 \$18185 \$16638 \$13442 sg13g2_nor3_1
* cell instance $468 m0 *1 209.76,223.02
X$468 VDD VSS \$14811 \$15315 \$15607 \$13820 sg13g2_nor3_1
* cell instance $469 m0 *1 223.2,268.38
X$469 VDD VSS \$19674 \$18793 \$19669 \$19605 sg13g2_nor3_1
* cell instance $470 m0 *1 241.92,253.26
X$470 VDD VSS \$17880 \$13433 \$17331 \$18419 sg13g2_nor3_1
* cell instance $471 m0 *1 261.12,253.26
X$471 VDD VSS \$17321 \$18823 \$17895 \$18224 sg13g2_nor3_1
* cell instance $472 m0 *1 208.32,185.22
X$472 VDD VSS \$12305 \$12470 \$12865 \$13013 sg13g2_nor3_1
* cell instance $473 m0 *1 247.68,253.26
X$473 VDD VSS \$17880 \$11671 \$17331 \$18419 sg13g2_nor3_1
* cell instance $474 m0 *1 48,298.62
X$474 VDD VSS \$21677 \$21679 \$20993 \$19720 sg13g2_nor3_1
* cell instance $475 m0 *1 251.52,117.18
X$475 VDD VSS \$6804 \$5402 \$7192 \$5175 sg13g2_nor3_1
* cell instance $476 m0 *1 332.16,336.42
X$476 VDD VSS \$22743 \$24278 \$24284 \$23183 sg13g2_nor3_1
* cell instance $477 m0 *1 138.72,268.38
X$477 VDD VSS \$19959 \$19819 \$19422 \$19078 sg13g2_nor3_1
* cell instance $478 m0 *1 137.28,328.86
X$478 VDD VSS \$23808 \$23915 \$23507 \$23445 sg13g2_nor3_1
* cell instance $479 m0 *1 334.56,291.06
X$479 VDD VSS \$20691 \$21108 \$21105 \$20558 sg13g2_nor3_1
* cell instance $480 m0 *1 87.84,154.98
X$480 VDD VSS \$9800 \$9962 \$7330 \$9951 sg13g2_nor3_1
* cell instance $481 m0 *1 316.32,185.22
X$481 VDD VSS \$8057 \$12433 \$12062 \$11519 sg13g2_nor3_1
* cell instance $482 r0 *1 216.48,147.42
X$482 VDD VSS \$9124 \$9281 \$9405 \$5338 sg13g2_nor3_1
* cell instance $483 r0 *1 243.36,253.26
X$483 VDD VSS \$17880 \$15857 \$18419 \$17455 sg13g2_nor3_1
* cell instance $484 r0 *1 269.76,306.18
X$484 VDD VSS \$22585 \$22712 \$22146 \$21071 sg13g2_nor3_1
* cell instance $485 r0 *1 286.08,192.78
X$485 VDD VSS \$12705 \$13088 \$13349 \$12046 sg13g2_nor3_1
* cell instance $486 r0 *1 242.88,245.7
X$486 VDD VSS \$18240 \$17629 \$16768 \$17897 sg13g2_nor3_1
* cell instance $487 r0 *1 228.96,245.7
X$487 VDD VSS \$17678 \$17082 \$17677 \$11897 sg13g2_nor3_1
* cell instance $488 r0 *1 334.08,306.18
X$488 VDD VSS \$22353 \$22741 \$22748 \$20558 sg13g2_nor3_1
* cell instance $489 r0 *1 192.96,275.94
X$489 VDD VSS \$20012 \$16633 \$20527 \$20449 sg13g2_nor3_1
* cell instance $490 r0 *1 141.12,275.94
X$490 VDD VSS \$19418 \$20300 \$19909 \$19078 sg13g2_nor3_1
* cell instance $491 r0 *1 103.2,154.98
X$491 VDD VSS \$11092 \$10047 \$10365 \$10157 sg13g2_nor3_1
* cell instance $492 r0 *1 251.04,102.06
X$492 VDD VSS \$5860 \$5558 \$5867 \$6809 sg13g2_nor3_1
* cell instance $493 r0 *1 333.6,298.62
X$493 VDD VSS \$21581 \$22160 \$22159 \$20558 sg13g2_nor3_1
* cell instance $494 r0 *1 227.04,253.26
X$494 VDD VSS \$18796 \$16150 \$18638 \$17876 sg13g2_nor3_1
* cell instance $495 r0 *1 270.72,328.86
X$495 VDD VSS \$24091 \$24181 \$16806 \$23939 sg13g2_nor3_1
* cell instance $496 r0 *1 283.68,313.74
X$496 VDD VSS \$21079 \$23021 \$20127 \$21328 sg13g2_nor3_1
* cell instance $497 r0 *1 272.64,245.7
X$497 VDD VSS \$17446 \$17454 \$18124 \$17723 sg13g2_nor3_1
* cell instance $498 r0 *1 228.48,94.5
X$498 VDD VSS \$5410 \$4045 \$5409 \$5175 sg13g2_nor3_1
* cell instance $499 r0 *1 221.28,268.38
X$499 VDD VSS \$19674 \$19439 \$19669 \$19915 sg13g2_nor3_1
* cell instance $500 r0 *1 203.04,230.58
X$500 VDD VSS \$10872 \$16306 \$16557 \$15669 sg13g2_nor3_1
* cell instance $501 r0 *1 209.76,154.98
X$501 VDD VSS \$10301 \$8894 \$10056 \$9824 sg13g2_nor3_1
* cell instance $502 r0 *1 348.96,336.42
X$502 VDD VSS \$23959 \$24844 \$24109 \$23183 sg13g2_nor3_1
* cell instance $503 r0 *1 235.68,253.26
X$503 VDD VSS \$18227 \$18701 \$16843 \$16315 sg13g2_nor3_1
* cell instance $504 r0 *1 140.16,102.06
X$504 VDD VSS \$6001 \$6318 \$6169 \$5802 sg13g2_nor3_1
* cell instance $505 r0 *1 329.28,223.02
X$505 VDD VSS \$15771 \$15568 \$12561 \$11789 sg13g2_nor3_1
* cell instance $506 r0 *1 331.68,207.9
X$506 VDD VSS \$12955 \$13491 \$13072 \$13241 sg13g2_nor3_1
* cell instance $507 r0 *1 318.24,328.86
X$507 VDD VSS \$23955 \$24102 \$24103 \$22734 sg13g2_nor3_1
* cell instance $508 r0 *1 259.68,238.14
X$508 VDD VSS \$15585 \$17099 \$16838 \$17331 sg13g2_nor3_1
* cell instance $509 r0 *1 200.64,283.5
X$509 VDD VSS \$20772 \$20670 \$20532 \$20531 sg13g2_nor3_1
* cell instance $510 r0 *1 210.72,117.18
X$510 VDD VSS \$5850 \$5840 \$7798 \$5338 sg13g2_nor3_1
* cell instance $511 r0 *1 220.32,109.62
X$511 VDD VSS \$7180 \$6706 \$7373 \$5338 sg13g2_nor3_1
* cell instance $512 r0 *1 211.68,328.86
X$512 VDD VSS \$23926 \$24186 \$23925 \$24539 sg13g2_nor3_1
* cell instance $513 r0 *1 244.32,124.74
X$513 VDD VSS \$7186 \$7009 \$8629 \$5175 sg13g2_nor3_1
* cell instance $514 r0 *1 124.8,268.38
X$514 VDD VSS \$19809 \$19727 \$19417 \$19078 sg13g2_nor3_1
* cell instance $515 r0 *1 229.44,154.98
X$515 VDD VSS \$9128 \$10171 \$10599 \$8637 sg13g2_nor3_1
* cell instance $516 r0 *1 238.56,260.82
X$516 VDD VSS \$19091 \$18237 \$19190 \$17455 sg13g2_nor3_1
* cell instance $517 r0 *1 109.44,253.26
X$517 VDD VSS \$18275 \$18922 \$18624 \$17802 sg13g2_nor3_1
* cell instance $518 r0 *1 200.16,162.54
X$518 VDD VSS \$10873 \$11147 \$10773 \$10872 sg13g2_nor3_1
* cell instance $519 r0 *1 283.2,132.3
X$519 VDD VSS \$6962 \$5717 \$6600 \$5194 sg13g2_nor3_1
* cell instance $520 r0 *1 226.08,162.54
X$520 VDD VSS \$10729 \$11021 \$10649 \$10484 sg13g2_nor3_1
* cell instance $521 r0 *1 197.76,162.54
X$521 VDD VSS \$11007 \$11408 \$10732 \$10872 sg13g2_nor3_1
* cell instance $522 r0 *1 329.28,192.78
X$522 VDD VSS \$12933 \$13483 \$13072 \$13241 sg13g2_nor3_1
* cell instance $523 r0 *1 244.8,177.66
X$523 VDD VSS \$12266 \$11910 \$11936 \$12514 sg13g2_nor3_1
* cell instance $524 r0 *1 193.44,283.5
X$524 VDD VSS \$20772 \$20233 \$20532 \$21705 sg13g2_nor3_1
* cell instance $525 r0 *1 48,253.26
X$525 VDD VSS \$18880 \$19166 \$18878 \$8015 sg13g2_nor3_1
* cell instance $526 r0 *1 264.96,94.5
X$526 VDD VSS \$5558 \$5088 \$5417 \$5175 sg13g2_nor3_1
* cell instance $527 r0 *1 255.84,238.14
X$527 VDD VSS \$16949 \$16327 \$17341 \$16805 sg13g2_nor3_1
* cell instance $528 r0 *1 201.6,207.9
X$528 VDD VSS \$13683 \$14760 \$14220 \$13013 sg13g2_nor3_1
* cell instance $529 r0 *1 240.96,124.74
X$529 VDD VSS \$8228 \$8020 \$7388 \$7377 sg13g2_nor3_1
* cell instance $530 r0 *1 276,328.86
X$530 VDD VSS \$23159 \$24092 \$20127 \$23939 sg13g2_nor3_1
* cell instance $531 r0 *1 266.88,192.78
X$531 VDD VSS \$12311 \$13219 \$13092 \$12514 sg13g2_nor3_1
* cell instance $532 r0 *1 102.72,253.26
X$532 VDD VSS \$18624 \$18917 \$18750 \$15650 sg13g2_nor3_1
* cell instance $533 r0 *1 114.72,192.78
X$533 VDD VSS \$13332 \$13743 \$13327 \$13152 sg13g2_nor3_1
* cell instance $534 r0 *1 290.4,154.98
X$534 VDD VSS \$10175 \$8820 \$10245 \$8637 sg13g2_nor3_1
* cell instance $535 r0 *1 187.2,162.54
X$535 VDD VSS \$10644 \$10645 \$10724 \$10871 sg13g2_nor3_1
* cell instance $536 r0 *1 261.6,260.82
X$536 VDD VSS \$17364 \$19572 \$18826 \$19103 sg13g2_nor3_1
* cell instance $537 r0 *1 329.76,336.42
X$537 VDD VSS \$24107 \$24626 \$24634 \$23183 sg13g2_nor3_1
* cell instance $538 r0 *1 247.2,94.5
X$538 VDD VSS \$5178 \$3663 \$5414 \$5175 sg13g2_nor3_1
* cell instance $539 r0 *1 331.2,275.94
X$539 VDD VSS \$20466 \$20570 \$20465 \$20558 sg13g2_nor3_1
* cell instance $540 r0 *1 249.6,94.5
X$540 VDD VSS \$5183 \$2906 \$5318 \$5175 sg13g2_nor3_1
* cell instance $541 m0 *1 231.36,102.06
X$541 VDD VSS \$5410 \$5648 \$5642 sg13g2_and2_1
* cell instance $542 m0 *1 218.88,102.06
X$542 VDD VSS \$5027 \$5644 \$5850 sg13g2_and2_1
* cell instance $543 m0 *1 150.72,275.94
X$543 VDD VSS \$19422 \$20005 \$19909 sg13g2_and2_1
* cell instance $544 m0 *1 332.16,177.66
X$544 VDD VSS \$11526 \$11788 \$11209 sg13g2_and2_1
* cell instance $545 m0 *1 332.16,283.5
X$545 VDD VSS \$20466 \$20464 \$20691 sg13g2_and2_1
* cell instance $546 m0 *1 327.36,177.66
X$546 VDD VSS \$11201 \$11789 \$11949 sg13g2_and2_1
* cell instance $547 m0 *1 226.56,275.94
X$547 VDD VSS \$17877 \$19669 \$19601 sg13g2_and2_1
* cell instance $548 m0 *1 49.44,79.38
X$548 VDD VSS \$3206 \$4019 \$3148 sg13g2_and2_1
* cell instance $549 m0 *1 271.68,223.02
X$549 VDD VSS \$15065 \$14821 \$15692 sg13g2_and2_1
* cell instance $550 m0 *1 130.08,328.86
X$550 VDD VSS \$23531 \$23674 \$24055 sg13g2_and2_1
* cell instance $551 m0 *1 303.36,343.98
X$551 VDD VSS \$24872 \$24273 \$24552 sg13g2_and2_1
* cell instance $552 m0 *1 254.4,117.18
X$552 VDD VSS \$6804 \$7136 \$5558 sg13g2_and2_1
* cell instance $553 m0 *1 151.68,170.1
X$553 VDD VSS \$11258 \$10831 \$10488 sg13g2_and2_1
* cell instance $554 m0 *1 43.2,291.06
X$554 VDD VSS \$20997 \$20741 \$20649 sg13g2_and2_1
* cell instance $555 m0 *1 45.6,298.62
X$555 VDD VSS \$21677 \$21012 \$20997 sg13g2_and2_1
* cell instance $556 m0 *1 70.08,306.18
X$556 VDD VSS \$22377 \$22050 \$22008 sg13g2_and2_1
* cell instance $557 m0 *1 75.84,351.54
X$557 VDD VSS \$25230 \$23255 \$24815 sg13g2_and2_1
* cell instance $558 m0 *1 280.32,162.54
X$558 VDD VSS \$10314 \$10780 \$10493 sg13g2_and2_1
* cell instance $559 m0 *1 339.36,313.74
X$559 VDD VSS \$22353 \$21947 \$22743 sg13g2_and2_1
* cell instance $560 m0 *1 178.08,328.86
X$560 VDD VSS \$23542 \$23828 \$23684 sg13g2_and2_1
* cell instance $561 m0 *1 206.88,207.9
X$561 VDD VSS \$12305 \$14052 \$14183 sg13g2_and2_1
* cell instance $562 m0 *1 339.36,291.06
X$562 VDD VSS \$20691 \$20690 \$21107 sg13g2_and2_1
* cell instance $563 m0 *1 269.76,132.3
X$563 VDD VSS \$8636 \$7575 \$8033 sg13g2_and2_1
* cell instance $564 m0 *1 177.12,245.7
X$564 VDD VSS \$17054 \$17434 \$13057 sg13g2_and2_1
* cell instance $565 m0 *1 217.92,215.46
X$565 VDD VSS \$13683 \$14186 \$14382 sg13g2_and2_1
* cell instance $566 m0 *1 268.32,313.74
X$566 VDD VSS \$23020 \$22713 \$22584 sg13g2_and2_1
* cell instance $567 m0 *1 220.8,336.42
X$567 VDD VSS \$24393 \$23695 \$23928 sg13g2_and2_1
* cell instance $568 m0 *1 198.24,283.5
X$568 VDD VSS \$20451 \$20525 \$20528 sg13g2_and2_1
* cell instance $569 m0 *1 271.2,215.46
X$569 VDD VSS \$14242 \$12057 \$13681 sg13g2_and2_1
* cell instance $570 m0 *1 312.96,321.3
X$570 VDD VSS \$23394 \$23350 \$23170 sg13g2_and2_1
* cell instance $571 m0 *1 118.56,343.98
X$571 VDD VSS \$21623 \$23819 \$23665 sg13g2_and2_1
* cell instance $572 m0 *1 246.24,192.78
X$572 VDD VSS \$11680 \$11501 \$11709 sg13g2_and2_1
* cell instance $573 m0 *1 120.96,351.54
X$573 VDD VSS \$23441 \$24821 \$24998 sg13g2_and2_1
* cell instance $574 m0 *1 300.96,94.5
X$574 VDD VSS \$5188 \$5255 \$5717 sg13g2_and2_1
* cell instance $575 m0 *1 208.32,268.38
X$575 VDD VSS \$19425 \$19669 \$19747 sg13g2_and2_1
* cell instance $576 m0 *1 286.08,132.3
X$576 VDD VSS \$8178 \$8648 \$7407 sg13g2_and2_1
* cell instance $577 m0 *1 267.36,200.34
X$577 VDD VSS \$12514 \$12711 \$13681 sg13g2_and2_1
* cell instance $578 m0 *1 262.56,200.34
X$578 VDD VSS \$13211 \$12921 \$12918 sg13g2_and2_1
* cell instance $579 m0 *1 264.96,321.3
X$579 VDD VSS \$23424 \$23491 \$23148 sg13g2_and2_1
* cell instance $580 m0 *1 305.76,328.86
X$580 VDD VSS \$24142 \$23947 \$23713 sg13g2_and2_1
* cell instance $581 m0 *1 275.52,336.42
X$581 VDD VSS \$24261 \$24265 \$24266 sg13g2_and2_1
* cell instance $582 m0 *1 284.16,154.98
X$582 VDD VSS \$9653 \$9844 \$10175 sg13g2_and2_1
* cell instance $583 m0 *1 163.68,328.86
X$583 VDD VSS \$23826 \$23827 \$23538 sg13g2_and2_1
* cell instance $584 m0 *1 232.32,162.54
X$584 VDD VSS \$10599 \$10061 \$10481 sg13g2_and2_1
* cell instance $585 r0 *1 314.4,321.3
X$585 VDD VSS \$23175 \$23350 \$23951 sg13g2_and2_1
* cell instance $586 r0 *1 177.12,192.78
X$586 VDD VSS \$12909 \$12890 \$13057 sg13g2_and2_1
* cell instance $587 r0 *1 276.48,343.98
X$587 VDD VSS \$24263 \$20127 \$23159 sg13g2_and2_1
* cell instance $588 r0 *1 321.12,321.3
X$588 VDD VSS \$23563 \$22738 \$23176 sg13g2_and2_1
* cell instance $589 r0 *1 107.04,253.26
X$589 VDD VSS \$18624 \$17540 \$16881 sg13g2_and2_1
* cell instance $590 r0 *1 344.64,328.86
X$590 VDD VSS \$24109 \$23957 \$23354 sg13g2_and2_1
* cell instance $591 r0 *1 335.52,238.14
X$591 VDD VSS \$17138 \$16816 \$16918 sg13g2_and2_1
* cell instance $592 r0 *1 195.36,336.42
X$592 VDD VSS \$23695 \$24063 \$24389 sg13g2_and2_1
* cell instance $593 r0 *1 152.64,253.26
X$593 VDD VSS \$17364 \$18060 \$15231 sg13g2_and2_1
* cell instance $594 r0 *1 218.88,147.42
X$594 VDD VSS \$9124 \$9127 \$9128 sg13g2_and2_1
* cell instance $595 r0 *1 321.6,306.18
X$595 VDD VSS \$22735 \$22423 \$22601 sg13g2_and2_1
* cell instance $596 r0 *1 213.12,139.86
X$596 VDD VSS \$9120 \$8272 \$9124 sg13g2_and2_1
* cell instance $597 r0 *1 245.76,253.26
X$597 VDD VSS \$17684 \$17879 \$18793 sg13g2_and2_1
* cell instance $598 r0 *1 204,238.14
X$598 VDD VSS \$15669 \$16309 \$14052 sg13g2_and2_1
* cell instance $599 r0 *1 215.52,192.78
X$599 VDD VSS \$12046 \$12893 \$13060 sg13g2_and2_1
* cell instance $600 r0 *1 320.16,207.9
X$600 VDD VSS \$14074 \$12695 \$13483 sg13g2_and2_1
* cell instance $601 r0 *1 127.2,268.38
X$601 VDD VSS \$19417 \$19728 \$19729 sg13g2_and2_1
* cell instance $602 r0 *1 315.84,328.86
X$602 VDD VSS \$23951 \$23842 \$24098 sg13g2_and2_1
* cell instance $603 r0 *1 233.76,117.18
X$603 VDD VSS \$7380 \$7182 \$7186 sg13g2_and2_1
* cell instance $604 r0 *1 275.52,313.74
X$604 VDD VSS \$22518 \$22714 \$23021 sg13g2_and2_1
* cell instance $605 r0 *1 209.28,200.34
X$605 VDD VSS \$13013 \$13585 \$13060 sg13g2_and2_1
* cell instance $606 r0 *1 212.16,223.02
X$606 VDD VSS \$14811 \$15049 \$15553 sg13g2_and2_1
* cell instance $607 r0 *1 335.52,291.06
X$607 VDD VSS \$21107 \$21096 \$21581 sg13g2_and2_1
* cell instance $608 r0 *1 324,238.14
X$608 VDD VSS \$11789 \$15585 \$17176 sg13g2_and2_1
* cell instance $609 r0 *1 199.68,200.34
X$609 VDD VSS \$13820 \$13585 \$13681 sg13g2_and2_1
* cell instance $610 r0 *1 320.64,328.86
X$610 VDD VSS \$23955 \$23951 \$23563 sg13g2_and2_1
* cell instance $611 r0 *1 75.84,298.62
X$611 VDD VSS \$22008 \$21681 \$21016 sg13g2_and2_1
* cell instance $612 r0 *1 172.8,238.14
X$612 VDD VSS \$16799 \$17051 \$13057 sg13g2_and2_1
* cell instance $613 r0 *1 126.72,238.14
X$613 VDD VSS \$16794 \$16789 \$16628 sg13g2_and2_1
* cell instance $614 r0 *1 258.24,185.22
X$614 VDD VSS \$11709 \$12697 \$12691 sg13g2_and2_1
* cell instance $615 r0 *1 208.32,117.18
X$615 VDD VSS \$5850 \$7368 \$7180 sg13g2_and2_1
* cell instance $617 m0 *1 180.48,41.58
X$617 \$304 VSS VDD sg13g2_inv_2
* cell instance $618 m0 *1 176.16,223.02
X$618 \$13170 VSS VDD sg13g2_inv_2
* cell instance $619 m0 *1 125.76,117.18
X$619 \$5380 VSS VDD sg13g2_inv_2
* cell instance $620 m0 *1 75.84,200.34
X$620 \$12289 VSS VDD sg13g2_inv_2
* cell instance $621 m0 *1 176.64,41.58
X$621 \$98 VSS VDD sg13g2_inv_2
* cell instance $622 m0 *1 272.16,298.62
X$622 \$20682 VSS VDD sg13g2_inv_2
* cell instance $623 r0 *1 24.48,245.7
X$623 \$15624 VSS VDD sg13g2_inv_2
* cell instance $624 r0 *1 187.68,49.14
X$624 \$918 VSS VDD sg13g2_inv_2
* cell instance $625 r0 *1 87.36,79.38
X$625 \$3156 VSS VDD sg13g2_inv_2
* cell instance $626 r0 *1 297.12,336.42
X$626 \$22724 VSS VDD sg13g2_inv_2
* cell instance $627 r0 *1 165.12,124.74
X$627 \$5630 VSS VDD sg13g2_inv_2
* cell instance $628 r0 *1 193.44,177.66
X$628 \$9827 VSS VDD sg13g2_inv_2
* cell instance $629 r0 *1 241.44,102.06
X$629 \$2916 VSS VDD sg13g2_inv_2
* cell instance $630 r0 *1 279.36,41.58
X$630 \$2389 VSS VDD sg13g2_inv_2
* cell instance $631 m0 *1 284.16,245.7
X$631 VDD \$17258 VSS \$16508 \$14065 \$17115 \$17576 sg13g2_nand4_1
* cell instance $632 m0 *1 288.48,139.86
X$632 VDD \$8648 VSS \$7900 \$5255 \$8920 \$1923 sg13g2_nand4_1
* cell instance $633 m0 *1 254.4,185.22
X$633 VDD \$12310 VSS \$12364 \$12278 \$12041 \$12054 sg13g2_nand4_1
* cell instance $634 m0 *1 263.52,253.26
X$634 VDD \$18180 VSS \$17895 \$18644 \$18130 \$18307 sg13g2_nand4_1
* cell instance $635 m0 *1 313.44,185.22
X$635 VDD \$11784 VSS \$12421 \$11714 \$12433 \$12791 sg13g2_nand4_1
* cell instance $636 m0 *1 253.92,238.14
X$636 VDD \$16109 VSS \$16562 \$16329 \$16326 \$16327 sg13g2_nand4_1
* cell instance $637 m0 *1 264.96,185.22
X$637 VDD \$12310 VSS \$11713 \$12278 \$12054 \$12311 sg13g2_nand4_1
* cell instance $638 m0 *1 268.8,223.02
X$638 VDD \$15381 VSS \$17321 \$15220 \$13991 \$15065 sg13g2_nand4_1
* cell instance $639 m0 *1 63.36,139.86
X$639 VDD \$8956 VSS \$8532 \$8957 \$7324 \$8946 sg13g2_nand4_1
* cell instance $640 m0 *1 42.72,177.66
X$640 VDD \$11446 VSS \$5820 \$11747 \$6730 \$11811 sg13g2_nand4_1
* cell instance $641 m0 *1 270.24,200.34
X$641 VDD \$13224 VSS \$12689 \$13598 \$13221 \$12924 sg13g2_nand4_1
* cell instance $642 m0 *1 269.28,253.26
X$642 VDD \$18149 VSS \$18131 \$18157 \$17898 \$18680 sg13g2_nand4_1
* cell instance $643 m0 *1 109.92,275.94
X$643 VDD \$20293 VSS \$20592 \$20285 \$19988 \$20286 sg13g2_nand4_1
* cell instance $644 m0 *1 258.24,245.7
X$644 VDD \$17097 VSS \$18218 \$17461 \$16201 \$17093 sg13g2_nand4_1
* cell instance $645 m0 *1 222.24,162.54
X$645 VDD \$10480 VSS \$10649 \$10651 \$9127 \$9637 sg13g2_nand4_1
* cell instance $646 m0 *1 134.88,102.06
X$646 VDD \$5624 VSS \$5802 \$5827 \$4306 \$5524 sg13g2_nand4_1
* cell instance $647 m0 *1 61.92,291.06
X$647 VDD \$20741 VSS \$19985 \$22091 \$20914 \$21599 sg13g2_nand4_1
* cell instance $648 m0 *1 195.36,283.5
X$648 VDD \$20764 VSS \$20234 \$20525 \$20665 \$20508 sg13g2_nand4_1
* cell instance $649 m0 *1 255.84,192.78
X$649 VDD \$12921 VSS \$12693 \$12920 \$13066 \$12918 sg13g2_nand4_1
* cell instance $650 m0 *1 207.84,260.82
X$650 VDD \$17859 VSS \$18240 \$19324 \$19319 \$19573 sg13g2_nand4_1
* cell instance $651 m0 *1 225.12,124.74
X$651 VDD \$5644 VSS \$7377 \$3514 \$5406 \$7695 sg13g2_nand4_1
* cell instance $652 m0 *1 312.96,238.14
X$652 VDD \$16644 VSS \$16430 \$16358 \$15982 \$15983 sg13g2_nand4_1
* cell instance $653 m0 *1 144.96,86.94
X$653 VDD \$1438 VSS \$4324 \$4518 \$4320 \$4613 sg13g2_nand4_1
* cell instance $654 m0 *1 103.2,154.98
X$654 VDD \$10049 VSS \$7336 \$10047 \$9803 \$9962 sg13g2_nand4_1
* cell instance $655 m0 *1 233.76,132.3
X$655 VDD \$8275 VSS \$7379 \$4624 \$5648 \$8018 sg13g2_nand4_1
* cell instance $656 m0 *1 103.2,117.18
X$656 VDD \$7262 VSS \$5826 \$6765 \$6768 \$6251 sg13g2_nand4_1
* cell instance $657 m0 *1 67.68,298.62
X$657 VDD \$20741 VSS \$21541 \$20914 \$21539 \$22092 sg13g2_nand4_1
* cell instance $658 m0 *1 87.84,94.5
X$658 VDD \$4954 VSS \$4785 \$5149 \$2665 \$4992 sg13g2_nand4_1
* cell instance $659 m0 *1 112.32,109.62
X$659 VDD \$6156 VSS \$6320 \$6771 \$8777 \$6521 sg13g2_nand4_1
* cell instance $660 m0 *1 300.96,238.14
X$660 VDD \$16808 VSS \$16435 \$15385 \$15973 \$16348 sg13g2_nand4_1
* cell instance $661 m0 *1 212.16,207.9
X$661 VDD \$14223 VSS \$13824 \$14186 \$13684 \$13430 sg13g2_nand4_1
* cell instance $662 r0 *1 138.72,238.14
X$662 VDD \$16136 VSS \$17030 \$16286 \$16888 \$16793 sg13g2_nand4_1
* cell instance $663 r0 *1 203.04,283.5
X$663 VDD \$20014 VSS \$21047 \$20195 \$20532 \$20452 sg13g2_nand4_1
* cell instance $664 r0 *1 169.44,185.22
X$664 VDD \$11764 VSS \$12658 \$12530 \$12659 \$12529 sg13g2_nand4_1
* cell instance $665 r0 *1 280.8,162.54
X$665 VDD \$9964 VSS \$10484 \$9844 \$10780 \$11029 sg13g2_nand4_1
* cell instance $666 r0 *1 322.08,313.74
X$666 VDD \$22422 VSS \$23176 \$22736 \$22158 \$23175 sg13g2_nand4_1
* cell instance $667 r0 *1 121.92,230.58
X$667 VDD \$15004 VSS \$16276 \$16132 \$16248 \$15644 sg13g2_nand4_1
* cell instance $668 r0 *1 229.92,253.26
X$668 VDD \$18639 VSS \$18797 \$18599 \$13830 \$18481 sg13g2_nand4_1
* cell instance $669 r0 *1 137.28,102.06
X$669 VDD \$5828 VSS \$6169 \$6166 \$3248 \$4322 sg13g2_nand4_1
* cell instance $670 r0 *1 252.96,238.14
X$670 VDD \$16636 VSS \$16805 \$16804 \$17090 \$17088 sg13g2_nand4_1
* cell instance $671 r0 *1 125.28,207.9
X$671 VDD \$12901 VSS \$14340 \$13966 \$14338 \$13147 sg13g2_nand4_1
* cell instance $672 r0 *1 134.88,207.9
X$672 VDD \$11868 VSS \$14345 \$12660 \$12638 \$12655 sg13g2_nand4_1
* cell instance $673 r0 *1 96,215.46
X$673 VDD \$13306 VSS \$14965 \$13720 \$13300 \$14884 sg13g2_nand4_1
* cell instance $674 r0 *1 238.08,253.26
X$674 VDD \$18701 VSS \$19045 \$18695 \$15524 \$18600 sg13g2_nand4_1
* cell instance $675 r0 *1 207.84,253.26
X$675 VDD \$18987 VSS \$17446 \$18633 \$18781 \$18778 sg13g2_nand4_1
* cell instance $676 r0 *1 246.24,223.02
X$676 VDD \$15372 VSS \$15681 \$15366 \$15060 \$15680 sg13g2_nand4_1
* cell instance $677 r0 *1 200.64,49.14
X$677 VDD \$3139 VSS \$2369 \$2561 \$2235 \$2004 sg13g2_nand4_1
* cell instance $678 r0 *1 285.12,253.26
X$678 VDD \$18106 VSS \$17900 \$15185 \$18506 \$18961 sg13g2_nand4_1
* cell instance $679 r0 *1 230.88,260.82
X$679 VDD \$19623 VSS \$12539 \$18466 \$19439 \$19449 sg13g2_nand4_1
* cell instance $680 r0 *1 255.36,215.46
X$680 VDD \$14757 VSS \$15261 \$14062 \$15252 \$15061 sg13g2_nand4_1
* cell instance $681 r0 *1 134.4,102.06
X$681 VDD \$6159 VSS \$5623 \$6968 \$6314 \$3716 sg13g2_nand4_1
* cell instance $682 r0 *1 131.52,102.06
X$682 VDD \$6002 VSS \$6001 \$4918 \$6165 \$6164 sg13g2_nand4_1
* cell instance $683 r0 *1 127.68,298.62
X$683 VDD \$21549 VSS \$22246 \$21694 \$20732 \$22106 sg13g2_nand4_1
* cell instance $684 r0 *1 252.48,117.18
X$684 VDD \$2959 VSS \$7388 \$6811 \$7653 \$4579 sg13g2_nand4_1
* cell instance $685 r0 *1 287.04,245.7
X$685 VDD \$15964 VSS \$17723 \$18022 \$18087 \$17903 sg13g2_nand4_1
* cell instance $686 r0 *1 28.32,124.74
X$686 VDD \$9507 VSS \$5736 \$2415 \$7845 \$8250 sg13g2_nand4_1
* cell instance $687 m0 *1 209.28,207.9
X$687 VDD VSS \$13972 \$14053 \$13824 \$11152 \$14183 sg13g2_nor4_1
* cell instance $688 m0 *1 298.08,238.14
X$688 VDD VSS \$16809 \$16831 \$15705 \$16347 \$16348 sg13g2_nor4_1
* cell instance $689 m0 *1 209.76,283.5
X$689 VDD VSS \$20195 \$20538 \$20017 \$20013 \$20903 sg13g2_nor4_1
* cell instance $690 m0 *1 212.64,283.5
X$690 VDD VSS \$20195 \$20538 \$20017 \$20774 \$21056 sg13g2_nor4_1
* cell instance $691 m0 *1 208.8,275.94
X$691 VDD VSS \$20195 \$20014 \$20016 \$19746 \$19109 sg13g2_nor4_1
* cell instance $692 m0 *1 139.68,102.06
X$692 VDD VSS \$6017 \$2497 \$5629 \$5387 \$6002 sg13g2_nor4_1
* cell instance $693 m0 *1 335.04,268.38
X$693 VDD VSS \$20076 \$20379 \$19763 \$19689 \$20066 sg13g2_nor4_1
* cell instance $694 m0 *1 173.28,336.42
X$694 VDD VSS \$23540 \$23510 \$23630 \$24242 \$23928 sg13g2_nor4_1
* cell instance $695 m0 *1 139.68,328.86
X$695 VDD VSS \$23674 \$23673 \$23675 \$24055 \$23804 sg13g2_nor4_1
* cell instance $696 m0 *1 319.68,306.18
X$696 VDD VSS \$11531 \$20021 \$22349 \$17701 \$14423 sg13g2_nor4_1
* cell instance $697 m0 *1 63.36,102.06
X$697 VDD VSS \$5820 \$5736 \$2369 \$1406 \$5827 sg13g2_nor4_1
* cell instance $698 m0 *1 225.6,268.38
X$698 VDD VSS \$19674 \$19605 \$19190 \$17678 \$19747 sg13g2_nor4_1
* cell instance $699 m0 *1 126.72,238.14
X$699 VDD VSS \$16248 \$16132 \$15644 \$16136 \$16629 sg13g2_nor4_1
* cell instance $700 m0 *1 139.2,109.62
X$700 VDD VSS \$6531 \$6328 \$4324 \$6320 \$5524 sg13g2_nor4_1
* cell instance $701 m0 *1 253.92,170.1
X$701 VDD VSS \$10884 \$11195 \$6318 \$11021 \$10493 sg13g2_nor4_1
* cell instance $702 m0 *1 130.56,132.3
X$702 VDD VSS \$8355 \$8532 \$8594 \$7975 \$6165 sg13g2_nor4_1
* cell instance $703 m0 *1 70.56,298.62
X$703 VDD VSS \$21303 \$21870 \$22050 \$21012 \$21599 sg13g2_nor4_1
* cell instance $704 m0 *1 36.96,245.7
X$704 VDD VSS \$16993 \$16992 \$15628 \$16870 \$16995 sg13g2_nor4_1
* cell instance $705 m0 *1 87.36,117.18
X$705 VDD VSS \$6753 \$7336 \$6487 \$4470 \$6164 sg13g2_nor4_1
* cell instance $706 m0 *1 132.48,215.46
X$706 VDD VSS \$14345 \$14724 \$14340 \$14965 \$14728 sg13g2_nor4_1
* cell instance $707 m0 *1 125.76,215.46
X$707 VDD VSS \$14338 \$13966 \$13147 \$13306 \$15223 sg13g2_nor4_1
* cell instance $708 m0 *1 244.8,253.26
X$708 VDD VSS \$14841 \$17684 \$15375 \$14405 \$18695 sg13g2_nor4_1
* cell instance $709 m0 *1 118.56,245.7
X$709 VDD VSS \$16622 \$16268 \$17017 \$17548 \$16273 sg13g2_nor4_1
* cell instance $710 m0 *1 103.2,102.06
X$710 VDD VSS \$5482 \$5826 \$4996 \$5623 \$5828 sg13g2_nor4_1
* cell instance $711 m0 *1 280.8,170.1
X$711 VDD VSS \$11506 \$10884 \$11509 \$10485 \$11031 sg13g2_nor4_1
* cell instance $712 m0 *1 64.8,291.06
X$712 VDD VSS \$21009 \$21481 \$21681 \$21012 \$21365 sg13g2_nor4_1
* cell instance $713 m0 *1 273.12,124.74
X$713 VDD VSS \$6947 \$5194 \$7582 \$7900 \$7575 sg13g2_nor4_1
* cell instance $714 r0 *1 315.36,245.7
X$714 VDD VSS \$17697 \$16912 \$17120 \$17475 \$17520 sg13g2_nor4_1
* cell instance $715 r0 *1 158.88,56.7
X$715 VDD VSS \$2740 \$3037 \$2524 \$2849 \$3248 sg13g2_nor4_1
* cell instance $716 r0 *1 124.8,86.94
X$716 VDD VSS \$4609 \$4785 \$1157 \$1675 \$4918 sg13g2_nor4_1
* cell instance $717 r0 *1 116.16,79.38
X$717 VDD VSS \$3595 \$3386 \$4032 \$4305 \$4306 sg13g2_nor4_1
* cell instance $718 r0 *1 300,321.3
X$718 VDD VSS \$18205 \$19020 \$21082 \$23709 \$23027 sg13g2_nor4_1
* cell instance $719 r0 *1 227.52,260.82
X$719 VDD VSS \$19608 \$18469 \$19190 \$19091 \$16315 sg13g2_nor4_1
* cell instance $720 r0 *1 232.8,253.26
X$720 VDD VSS \$18466 \$17876 \$18419 \$17331 \$18703 sg13g2_nor4_1
* cell instance $721 r0 *1 137.76,207.9
X$721 VDD VSS \$12638 \$12660 \$12655 \$12901 \$14350 sg13g2_nor4_1
* cell instance $722 r0 *1 103.68,71.82
X$722 VDD VSS \$3496 \$2671 \$3807 \$4286 \$3497 sg13g2_nor4_1
* cell instance $723 r0 *1 230.4,177.66
X$723 VDD VSS \$11772 \$11663 \$11266 \$11490 \$11969 sg13g2_nor4_1
* cell instance $724 r0 *1 103.2,215.46
X$724 VDD VSS \$13300 \$13720 \$14884 \$15004 \$14890 sg13g2_nor4_1
* cell instance $725 r0 *1 64.32,298.62
X$725 VDD VSS \$21682 \$21605 \$21681 \$21012 \$22092 sg13g2_nor4_1
* cell instance $726 r0 *1 252.96,185.22
X$726 VDD VSS \$12689 \$12053 \$12364 \$12693 \$12363 sg13g2_nor4_1
* cell instance $727 r0 *1 134.88,154.98
X$727 VDD VSS \$10641 \$1312 \$10386 \$10291 \$4613 sg13g2_nor4_1
* cell instance $728 r0 *1 204,207.9
X$728 VDD VSS \$14611 \$14053 \$13972 \$13824 \$10474 sg13g2_nor4_1
* cell instance $729 r0 *1 263.04,109.62
X$729 VDD VSS \$7047 \$6809 \$6810 \$5663 \$6811 sg13g2_nor4_1
* cell instance $730 r0 *1 71.52,291.06
X$730 VDD VSS \$21682 \$21605 \$21303 \$21540 \$21483 sg13g2_nor4_1
* cell instance $731 r0 *1 178.08,207.9
X$731 VDD VSS \$14215 \$14214 \$14585 \$14581 \$14582 sg13g2_nor4_1
* cell instance $732 r0 *1 138.24,56.7
X$732 VDD VSS \$2897 \$2828 \$2736 \$2735 \$4322 sg13g2_nor4_1
* cell instance $733 r0 *1 139.2,215.46
X$733 VDD VSS \$11868 \$14346 \$15847 \$15846 \$14798 sg13g2_nor4_1
* cell instance $734 r0 *1 277.44,162.54
X$734 VDD VSS \$10496 \$10884 \$10744 \$10311 \$11029 sg13g2_nor4_1
* cell instance $759 m0 *1 80.16,154.98
X$759 \$8940 \$9794 \$9528 VDD VSS sg13g2_or2_1
* cell instance $760 m0 *1 329.28,230.58
X$760 \$15986 \$15987 \$15712 VDD VSS sg13g2_or2_1
* cell instance $761 m0 *1 300.96,328.86
X$761 \$21085 \$23709 \$22026 VDD VSS sg13g2_or2_1
* cell instance $762 m0 *1 239.52,253.26
X$762 \$18296 \$18600 \$16838 VDD VSS sg13g2_or2_1
* cell instance $763 m0 *1 234.72,162.54
X$763 \$10484 \$10481 \$10485 VDD VSS sg13g2_or2_1
* cell instance $764 m0 *1 188.16,162.54
X$764 \$10725 \$10623 \$10301 VDD VSS sg13g2_or2_1
* cell instance $765 m0 *1 120.96,223.02
X$765 \$15346 \$13332 \$14650 VDD VSS sg13g2_or2_1
* cell instance $766 m0 *1 125.76,207.9
X$766 \$12655 \$13671 \$12901 VDD VSS sg13g2_or2_1
* cell instance $767 m0 *1 142.56,192.78
X$767 \$12642 \$12898 \$12644 VDD VSS sg13g2_or2_1
* cell instance $768 m0 *1 66.24,139.86
X$768 \$7323 \$8956 \$8420 VDD VSS sg13g2_or2_1
* cell instance $769 m0 *1 67.2,109.62
X$769 \$5708 \$6159 \$6401 VDD VSS sg13g2_or2_1
* cell instance $770 m0 *1 143.04,253.26
X$770 \$17822 \$18045 \$17821 VDD VSS sg13g2_or2_1
* cell instance $771 m0 *1 81.6,124.74
X$771 \$6621 \$7262 \$7332 VDD VSS sg13g2_or2_1
* cell instance $772 r0 *1 320.64,245.7
X$772 \$17701 \$17176 \$17520 VDD VSS sg13g2_or2_1
* cell instance $773 r0 *1 144.48,321.3
X$773 \$23507 \$23535 \$23804 VDD VSS sg13g2_or2_1
* cell instance $774 r0 *1 118.56,223.02
X$774 \$15346 \$15012 \$13152 VDD VSS sg13g2_or2_1
* cell instance $775 r0 *1 104.64,41.58
X$775 \$771 \$1857 \$1418 VDD VSS sg13g2_or2_1
* cell instance $776 r0 *1 145.92,86.94
X$776 \$4786 \$3904 \$4790 VDD VSS sg13g2_or2_1
* cell instance $777 r0 *1 63.36,306.18
X$777 \$22091 \$20650 \$22655 VDD VSS sg13g2_or2_1
* cell instance $778 r0 *1 114.24,200.34
X$778 \$13327 \$13796 \$13801 VDD VSS sg13g2_or2_1
* cell instance $779 r0 *1 346.56,215.46
X$779 \$14828 \$15091 \$14246 VDD VSS sg13g2_or2_1
* cell instance $780 r0 *1 61.92,238.14
X$780 \$16876 \$17001 \$14878 VDD VSS sg13g2_or2_1
* cell instance $781 r0 *1 231.36,117.18
X$781 \$7377 \$7184 \$7379 VDD VSS sg13g2_or2_1
* cell instance $782 r0 *1 180.96,86.94
X$782 \$3711 \$4954 \$4795 VDD VSS sg13g2_or2_1
* cell instance $783 r0 *1 208.32,283.5
X$783 \$20774 \$21051 \$21047 VDD VSS sg13g2_or2_1
* cell instance $784 r0 *1 107.04,94.5
X$784 \$4604 \$4999 \$4997 VDD VSS sg13g2_or2_1
* cell instance $785 r0 *1 118.56,86.94
X$785 \$4296 \$4779 \$3816 VDD VSS sg13g2_or2_1
* cell instance $786 r0 *1 299.52,253.26
X$786 \$16831 \$18664 \$16912 VDD VSS sg13g2_or2_1
* cell instance $787 m0 *1 24.96,41.58
X$787 VSS \$1389 VDD \$1490 \$1806 \$1752 \$1291 \$1391 sg13g2_a221oi_1
* cell instance $788 m0 *1 141.6,34.02
X$788 VSS \$385 VDD \$1438 \$81 \$1192 \$455 \$985 sg13g2_a221oi_1
* cell instance $789 m0 *1 325.92,275.94
X$789 VSS \$20281 VDD \$19689 \$20061 \$20251 \$17714 \$20063 sg13g2_a221oi_1
* cell instance $790 m0 *1 252.48,336.42
X$790 VSS \$19202 VDD \$24403 \$22703 \$16562 \$24508 \$20039 sg13g2_a221oi_1
* cell instance $791 m0 *1 161.76,223.02
X$791 VSS \$15480 VDD \$14744 \$15354 \$15034 \$14655 \$13966 sg13g2_a221oi_1
* cell instance $792 m0 *1 249.6,162.54
X$792 VSS \$8909 VDD \$8861 \$6804 \$10586 \$12057 \$10488 sg13g2_a221oi_1
* cell instance $793 m0 *1 232.32,313.74
X$793 VSS \$19202 VDD \$22856 \$22542 \$18797 \$22879 \$20039 sg13g2_a221oi_1
* cell instance $794 m0 *1 248.64,336.42
X$794 VSS \$19202 VDD \$25201 \$22995 \$15681 \$24731 \$20039 sg13g2_a221oi_1
* cell instance $795 m0 *1 236.16,313.74
X$795 VSS \$19202 VDD \$22989 \$22304 \$17748 \$22696 \$20039 sg13g2_a221oi_1
* cell instance $796 m0 *1 177.6,215.46
X$796 VSS \$14746 VDD \$14368 \$14582 \$14367 \$14214 \$14371 sg13g2_a221oi_1
* cell instance $797 m0 *1 277.92,245.7
X$797 VSS \$15697 VDD \$17466 \$16808 \$17106 \$15232 \$15078 sg13g2_a221oi_1
* cell instance $798 m0 *1 267.84,328.86
X$798 VSS \$23151 VDD \$24262 \$23424 \$23937 \$23835 \$23703 sg13g2_a221oi_1
* cell instance $799 m0 *1 131.04,102.06
X$799 VSS \$5617 VDD \$5371 \$5148 \$5619 \$4786 \$4789 sg13g2_a221oi_1
* cell instance $800 m0 *1 140.64,200.34
X$800 VSS \$12966 VDD \$12642 \$13583 \$12820 \$12968 \$12638 sg13g2_a221oi_1
* cell instance $801 m0 *1 159.84,238.14
X$801 VSS \$16294 VDD \$16515 \$16734 \$16287 \$15951 \$16286 sg13g2_a221oi_1
* cell instance $802 m0 *1 305.28,336.42
X$802 VSS \$24096 VDD \$24442 \$24273 \$24550 \$23716 \$23717 sg13g2_a221oi_1
* cell instance $803 m0 *1 86.4,139.86
X$803 VSS \$3701 VDD \$8969 \$2600 \$9394 \$8876 \$8567 sg13g2_a221oi_1
* cell instance $804 m0 *1 184.8,94.5
X$804 VSS \$4343 VDD \$5552 \$3312 \$6049 \$3711 \$4799 sg13g2_a221oi_1
* cell instance $805 m0 *1 309.12,238.14
X$805 VSS \$15970 VDD \$16455 \$15982 \$16642 \$16358 \$15978 sg13g2_a221oi_1
* cell instance $806 m0 *1 164.16,192.78
X$806 VSS \$12654 VDD \$12903 \$12901 \$12653 \$12655 \$12656 sg13g2_a221oi_1
* cell instance $807 m0 *1 308.16,230.58
X$807 VSS \$15704 VDD \$16642 \$15088 \$15975 \$15714 \$15705 sg13g2_a221oi_1
* cell instance $808 m0 *1 56.16,223.02
X$808 VSS \$15128 VDD \$13715 \$14985 \$14984 \$8015 \$14986 sg13g2_a221oi_1
* cell instance $809 m0 *1 115.68,139.86
X$809 VSS \$8589 VDD \$6765 \$8510 \$8429 \$7957 \$8884 sg13g2_a221oi_1
* cell instance $810 m0 *1 156.48,139.86
X$810 VSS \$8265 VDD \$8599 \$7550 \$6772 \$7982 \$8601 sg13g2_a221oi_1
* cell instance $811 m0 *1 252.48,230.58
X$811 VSS \$14405 VDD \$15682 \$8648 \$16153 \$2959 \$13442 sg13g2_a221oi_1
* cell instance $812 m0 *1 184.32,162.54
X$812 VSS \$10165 VDD \$9106 \$10644 \$9824 \$10645 \$10301 sg13g2_a221oi_1
* cell instance $813 m0 *1 305.28,238.14
X$813 VSS \$15973 VDD \$15975 \$16644 \$16810 \$16812 \$15385 sg13g2_a221oi_1
* cell instance $814 m0 *1 46.56,192.78
X$814 VSS \$12624 VDD \$11747 \$12943 \$13260 \$11742 \$12625 sg13g2_a221oi_1
* cell instance $815 m0 *1 33.12,102.06
X$815 VSS \$6237 VDD \$6730 \$5914 \$5602 \$3681 \$4980 sg13g2_a221oi_1
* cell instance $816 m0 *1 276,124.74
X$816 VSS \$5661 VDD \$6976 \$6947 \$5678 \$7575 \$7407 sg13g2_a221oi_1
* cell instance $817 m0 *1 214.08,49.14
X$817 VSS \$2237 VDD \$2235 \$2706 \$1903 \$1003 \$1904 sg13g2_a221oi_1
* cell instance $818 m0 *1 266.4,260.82
X$818 VSS \$18060 VDD \$20607 \$15231 \$19103 \$18827 \$19104 sg13g2_a221oi_1
* cell instance $819 m0 *1 158.4,200.34
X$819 VSS \$12342 VDD \$12653 \$12984 \$13936 \$13165 \$12019 sg13g2_a221oi_1
* cell instance $820 m0 *1 23.04,147.42
X$820 VSS \$9681 VDD \$8250 \$8870 \$9676 \$8676 \$9245 sg13g2_a221oi_1
* cell instance $821 r0 *1 79.68,86.94
X$821 VSS \$3892 VDD \$4292 \$3480 \$4867 \$3388 \$3894 sg13g2_a221oi_1
* cell instance $822 r0 *1 248.16,328.86
X$822 VSS \$19202 VDD \$24209 \$22408 \$17892 \$23934 \$20039 sg13g2_a221oi_1
* cell instance $823 r0 *1 242.4,328.86
X$823 VSS \$19202 VDD \$24544 \$23933 \$16594 \$24081 \$20039 sg13g2_a221oi_1
* cell instance $824 r0 *1 309.12,230.58
X$824 VSS \$16161 VDD \$16182 \$15707 \$16455 \$15979 \$16347 sg13g2_a221oi_1
* cell instance $825 r0 *1 282.24,230.58
X$825 VSS \$15697 VDD \$16151 \$15978 \$16508 \$15695 \$14911 sg13g2_a221oi_1
* cell instance $826 r0 *1 101.28,26.46
X$826 VSS \$1075 VDD \$1673 \$1365 \$1077 \$771 \$975 sg13g2_a221oi_1
* cell instance $827 r0 *1 315.84,207.9
X$827 VSS \$14074 VDD \$14239 \$13853 \$14422 \$14423 \$14240 sg13g2_a221oi_1
* cell instance $828 r0 *1 147.36,260.82
X$828 VSS \$19422 VDD \$18558 \$19731 \$19286 \$19423 \$19417 sg13g2_a221oi_1
* cell instance $829 r0 *1 41.28,49.14
X$829 VSS \$1757 VDD \$2415 \$2039 \$2773 \$1477 \$2305 sg13g2_a221oi_1
* cell instance $830 r0 *1 23.04,124.74
X$830 VSS \$7315 VDD \$7845 \$7661 \$8064 \$6853 \$7662 sg13g2_a221oi_1
* cell instance $831 r0 *1 195.84,49.14
X$831 VSS \$2178 VDD \$2561 \$2560 \$2277 \$1196 \$1897 sg13g2_a221oi_1
* cell instance $832 r0 *1 234.24,177.66
X$832 VSS \$11901 VDD \$11964 \$11776 \$12255 \$4624 \$11663 sg13g2_a221oi_1
* cell instance $833 r0 *1 123.36,200.34
X$833 VSS \$13634 VDD \$13668 \$13743 \$13907 \$12968 \$13671 sg13g2_a221oi_1
* cell instance $834 r0 *1 316.8,177.66
X$834 VSS \$11871 VDD \$11787 \$11783 \$11782 \$11872 \$11290 sg13g2_a221oi_1
* cell instance $835 r0 *1 23.52,71.82
X$835 VSS \$3477 VDD \$3201 \$3538 \$3680 \$3146 \$3684 sg13g2_a221oi_1
* cell instance $836 r0 *1 320.64,177.66
X$836 VSS \$10330 VDD \$11858 \$12177 \$11787 \$11716 \$11788 sg13g2_a221oi_1
* cell instance $837 r0 *1 252.96,230.58
X$837 VSS \$15375 VDD \$16326 \$16764 \$15378 \$15608 \$14841 sg13g2_a221oi_1
* cell instance $838 r0 *1 23.04,162.54
X$838 VSS \$11050 VDD \$9507 \$10853 \$10904 \$10081 \$10970 sg13g2_a221oi_1
* cell instance $839 r0 *1 55.68,238.14
X$839 VSS \$16874 VDD \$15760 \$17184 \$17179 \$17000 \$17196 sg13g2_a221oi_1
* cell instance $840 r0 *1 237.12,313.74
X$840 VSS \$19202 VDD \$23047 \$22537 \$17085 \$23018 \$20039 sg13g2_a221oi_1
* cell instance $841 r0 *1 65.76,245.7
X$841 VSS \$17001 VDD \$16122 \$17980 \$14195 \$8015 \$17650 sg13g2_a221oi_1
* cell instance $842 r0 *1 325.92,177.66
X$842 VSS \$10182 VDD \$12383 \$12070 \$11858 \$12062 \$10902 sg13g2_a221oi_1
* cell instance $843 r0 *1 52.8,132.3
X$843 VSS \$8416 VDD \$8946 \$7431 \$8310 \$8476 \$8417 sg13g2_a221oi_1
* cell instance $844 r0 *1 327.84,291.06
X$844 VSS \$21590 VDD \$21333 \$21459 \$21578 \$21457 \$21577 sg13g2_a221oi_1
* cell instance $845 r0 *1 63.36,41.58
X$845 VSS \$2438 VDD \$1761 \$2040 \$1511 \$265 \$1518 sg13g2_a221oi_1
* cell instance $846 r0 *1 230.88,230.58
X$846 VSS \$16150 VDD \$16205 \$16239 \$16206 \$16311 \$15375 sg13g2_a221oi_1
* cell instance $847 r0 *1 265.44,230.58
X$847 VSS \$14905 VDD \$16201 \$12559 \$16545 \$15973 \$15697 sg13g2_a221oi_1
* cell instance $848 r0 *1 84.96,109.62
X$848 VSS \$6756 VDD \$6915 \$6747 \$6580 \$4771 \$5373 sg13g2_a221oi_1
* cell instance $849 r0 *1 236.64,223.02
X$849 VSS \$15250 VDD \$15594 \$13244 \$15597 \$15056 \$13977 sg13g2_a221oi_1
* cell instance $850 r0 *1 231.36,238.14
X$850 VSS \$13977 VDD \$16802 \$15674 \$17078 \$16800 \$16638 sg13g2_a221oi_1
* cell instance $851 r0 *1 75.84,94.5
X$851 VSS \$5366 VDD \$5149 \$4424 \$5364 \$5142 \$5367 sg13g2_a221oi_1
* cell instance $852 r0 *1 112.32,56.7
X$852 VSS \$3084 VDD \$3301 \$2812 \$2485 \$1226 \$2132 sg13g2_a221oi_1
* cell instance $853 r0 *1 158.88,230.58
X$853 VSS \$15944 VDD \$16217 \$16141 \$16518 \$15552 \$15655 sg13g2_a221oi_1
* cell instance $854 m0 *1 302.88,245.7
X$854 \$17124 VSS VDD \$16915 \$17125 \$17911 \$18030 sg13g2_a22oi_1
* cell instance $855 m0 *1 266.4,253.26
X$855 \$17898 VSS VDD \$15375 \$15690 \$15250 \$18477 sg13g2_a22oi_1
* cell instance $856 m0 *1 248.16,238.14
X$856 \$16804 VSS VDD \$13442 \$16289 \$16315 \$8375 sg13g2_a22oi_1
* cell instance $857 m0 *1 212.16,223.02
X$857 \$15502 VSS VDD \$15506 \$13967 \$14841 \$14223 sg13g2_a22oi_1
* cell instance $858 m0 *1 109.44,253.26
X$858 \$18689 VSS VDD \$16781 \$18273 \$17803 \$16793 sg13g2_a22oi_1
* cell instance $859 m0 *1 289.92,245.7
X$859 \$17088 VSS VDD \$16843 \$12062 \$14905 \$17471 sg13g2_a22oi_1
* cell instance $860 m0 *1 216.48,185.22
X$860 \$12475 VSS VDD \$11663 \$12019 \$11772 \$5644 sg13g2_a22oi_1
* cell instance $861 m0 *1 177.6,26.46
X$861 \$758 VSS VDD \$389 \$30 \$786 \$560 sg13g2_a22oi_1
* cell instance $862 m0 *1 315.84,177.66
X$862 \$11783 VSS VDD \$10668 \$11784 \$11515 \$11714 sg13g2_a22oi_1
* cell instance $863 m0 *1 210.72,185.22
X$863 \$12207 VSS VDD \$11772 \$11489 \$11266 \$11762 sg13g2_a22oi_1
* cell instance $864 m0 *1 266.88,207.9
X$864 \$13991 VSS VDD \$11503 \$13307 \$14063 \$6356 sg13g2_a22oi_1
* cell instance $865 m0 *1 248.16,207.9
X$865 \$14604 VSS VDD \$13181 \$12924 \$13832 \$13684 sg13g2_a22oi_1
* cell instance $866 m0 *1 237.6,207.9
X$866 \$13830 VSS VDD \$13832 \$13470 \$13977 \$12918 sg13g2_a22oi_1
* cell instance $867 m0 *1 267.36,283.5
X$867 \$15692 VSS VDD \$16843 \$21071 \$19437 \$21082 sg13g2_a22oi_1
* cell instance $868 m0 *1 266.88,245.7
X$868 \$17464 VSS VDD \$14841 \$16915 \$15697 \$14043 sg13g2_a22oi_1
* cell instance $869 m0 *1 278.4,207.9
X$869 \$14062 VSS VDD \$13832 \$13849 \$14063 \$13224 sg13g2_a22oi_1
* cell instance $870 m0 *1 233.28,343.98
X$870 \$24803 VSS VDD \$24250 \$24611 \$24393 \$24761 sg13g2_a22oi_1
* cell instance $871 m0 *1 256.32,230.58
X$871 \$16640 VSS VDD \$16638 \$9650 \$16152 \$15655 sg13g2_a22oi_1
* cell instance $872 m0 *1 155.04,268.38
X$872 \$19573 VSS VDD \$18786 \$19732 \$19425 \$18738 sg13g2_a22oi_1
* cell instance $873 m0 *1 157.92,268.38
X$873 \$18599 VSS VDD \$18786 \$20519 \$19425 \$18735 sg13g2_a22oi_1
* cell instance $874 m0 *1 251.04,238.14
X$874 \$16769 VSS VDD \$16323 \$12374 \$14905 \$16772 sg13g2_a22oi_1
* cell instance $875 m0 *1 232.8,238.14
X$875 \$16586 VSS VDD \$16638 \$16528 \$16843 \$15944 sg13g2_a22oi_1
* cell instance $876 m0 *1 259.68,223.02
X$876 \$15220 VSS VDD \$13181 \$13853 \$15078 \$15049 sg13g2_a22oi_1
* cell instance $877 m0 *1 220.32,177.66
X$877 \$11731 VSS VDD \$11663 \$12222 \$11772 \$5406 sg13g2_a22oi_1
* cell instance $878 m0 *1 205.92,94.5
X$878 \$3139 VSS VDD \$5024 \$5096 \$5097 \$6195 sg13g2_a22oi_1
* cell instance $879 m0 *1 210.72,260.82
X$879 \$18633 VSS VDD \$14841 \$19327 \$15375 \$18289 sg13g2_a22oi_1
* cell instance $880 m0 *1 255.36,245.7
X$880 \$17093 VSS VDD \$14405 \$17684 \$17360 \$5255 sg13g2_a22oi_1
* cell instance $881 m0 *1 122.4,298.62
X$881 \$21796 VSS VDD \$22110 \$21695 \$20751 \$21434 sg13g2_a22oi_1
* cell instance $882 m0 *1 226.08,336.42
X$882 \$24248 VSS VDD \$24250 \$24542 \$24393 \$24075 sg13g2_a22oi_1
* cell instance $883 m0 *1 252.96,223.02
X$883 \$15061 VSS VDD \$15506 \$15062 \$15375 \$14812 sg13g2_a22oi_1
* cell instance $884 m0 *1 110.88,102.06
X$884 \$5500 VSS VDD \$6157 \$4284 \$5382 \$6287 sg13g2_a22oi_1
* cell instance $885 m0 *1 63.36,245.7
X$885 \$17005 VSS VDD \$16955 \$17740 \$17003 \$17408 sg13g2_a22oi_1
* cell instance $886 m0 *1 315.84,215.46
X$886 \$14826 VSS VDD \$14240 \$13853 \$14074 \$14423 sg13g2_a22oi_1
* cell instance $887 m0 *1 159.36,245.7
X$887 \$17329 VSS VDD \$18763 \$17431 \$17333 \$16793 sg13g2_a22oi_1
* cell instance $888 m0 *1 182.4,109.62
X$888 \$6521 VSS VDD \$6188 \$6184 \$6190 \$4922 sg13g2_a22oi_1
* cell instance $889 m0 *1 213.6,230.58
X$889 \$16636 VSS VDD \$15506 \$14988 \$16150 \$14186 sg13g2_a22oi_1
* cell instance $890 m0 *1 308.16,245.7
X$890 \$15214 VSS VDD \$17474 \$15078 \$17475 \$17714 sg13g2_a22oi_1
* cell instance $891 m0 *1 204.96,260.82
X$891 \$19319 VSS VDD \$16315 \$19735 \$17896 \$19309 sg13g2_a22oi_1
* cell instance $892 m0 *1 256.8,260.82
X$892 \$19360 VSS VDD \$14911 \$18646 \$19202 \$18820 sg13g2_a22oi_1
* cell instance $893 m0 *1 219.36,185.22
X$893 \$12227 VSS VDD \$11663 \$12351 \$11772 \$3514 sg13g2_a22oi_1
* cell instance $894 m0 *1 114.24,223.02
X$894 \$15341 VSS VDD \$13042 \$15014 \$15453 \$13966 sg13g2_a22oi_1
* cell instance $895 m0 *1 280.8,283.5
X$895 \$18644 VSS VDD \$18484 \$20693 \$17474 \$20860 sg13g2_a22oi_1
* cell instance $896 m0 *1 200.16,253.26
X$896 \$18130 VSS VDD \$16315 \$17202 \$16150 \$17665 sg13g2_a22oi_1
* cell instance $897 m0 *1 265.92,215.46
X$897 \$14821 VSS VDD \$14841 \$6819 \$14405 \$14211 sg13g2_a22oi_1
* cell instance $898 m0 *1 205.44,253.26
X$898 \$18778 VSS VDD \$13181 \$18445 \$16150 \$16963 sg13g2_a22oi_1
* cell instance $899 m0 *1 163.68,238.14
X$899 \$16734 VSS VDD \$16141 \$16797 \$16796 \$15658 sg13g2_a22oi_1
* cell instance $900 m0 *1 271.2,306.18
X$900 \$22342 VSS VDD \$22518 \$22149 \$22511 \$22151 sg13g2_a22oi_1
* cell instance $901 m0 *1 261.12,245.7
X$901 \$17461 VSS VDD \$16638 \$18205 \$16843 \$16798 sg13g2_a22oi_1
* cell instance $902 m0 *1 51.84,94.5
X$902 \$6251 VSS VDD \$4984 \$3277 \$4985 \$4014 sg13g2_a22oi_1
* cell instance $903 m0 *1 275.04,245.7
X$903 \$17315 VSS VDD \$16152 \$17465 \$17104 \$10312 sg13g2_a22oi_1
* cell instance $904 m0 *1 323.04,275.94
X$904 \$20061 VSS VDD \$20062 \$20464 \$20059 \$20054 sg13g2_a22oi_1
* cell instance $905 m0 *1 309.6,253.26
X$905 \$18506 VSS VDD \$15078 \$21457 \$17474 \$16368 sg13g2_a22oi_1
* cell instance $906 m0 *1 210.72,26.46
X$906 \$2004 VSS VDD \$4 \$1289 \$1616 \$893 sg13g2_a22oi_1
* cell instance $907 m0 *1 77.28,154.98
X$907 \$5372 VSS VDD \$9790 \$10446 \$10044 \$8940 sg13g2_a22oi_1
* cell instance $908 m0 *1 213.6,260.82
X$908 \$19324 VSS VDD \$14841 \$19086 \$15375 \$15359 sg13g2_a22oi_1
* cell instance $909 m0 *1 158.88,223.02
X$909 \$15354 VSS VDD \$13962 \$14354 \$15353 \$15359 sg13g2_a22oi_1
* cell instance $910 m0 *1 172.8,253.26
X$910 \$18456 VSS VDD \$17009 \$17846 \$15847 \$18282 sg13g2_a22oi_1
* cell instance $911 m0 *1 279.84,253.26
X$911 \$18106 VSS VDD \$14911 \$18311 \$16323 \$14437 sg13g2_a22oi_1
* cell instance $912 m0 *1 300,245.7
X$912 \$17125 VSS VDD \$16912 \$16809 \$17120 \$16831 sg13g2_a22oi_1
* cell instance $913 m0 *1 225.12,177.66
X$913 \$11730 VSS VDD \$11663 \$11704 \$12234 \$5648 sg13g2_a22oi_1
* cell instance $914 m0 *1 213.6,185.22
X$914 \$12214 VSS VDD \$11772 \$8272 \$11490 \$12342 sg13g2_a22oi_1
* cell instance $915 m0 *1 289.92,223.02
X$915 \$15185 VSS VDD \$14405 \$13334 \$14905 \$1923 sg13g2_a22oi_1
* cell instance $916 m0 *1 282.72,253.26
X$916 \$18087 VSS VDD \$11671 \$18529 \$18484 \$10780 sg13g2_a22oi_1
* cell instance $917 m0 *1 230.4,343.98
X$917 \$25264 VSS VDD \$24073 \$24545 \$24393 \$24761 sg13g2_a22oi_1
* cell instance $918 m0 *1 158.4,215.46
X$918 \$14557 VSS VDD \$13810 \$14354 \$14802 \$13962 sg13g2_a22oi_1
* cell instance $919 m0 *1 287.04,223.02
X$919 \$15964 VSS VDD \$14405 \$14670 \$14911 \$8920 sg13g2_a22oi_1
* cell instance $920 m0 *1 223.68,253.26
X$920 \$18172 VSS VDD \$13442 \$18790 \$18786 \$4949 sg13g2_a22oi_1
* cell instance $921 m0 *1 53.28,223.02
X$921 \$14989 VSS VDD \$14013 \$15124 \$15762 \$14874 sg13g2_a22oi_1
* cell instance $922 r0 *1 111.84,215.46
X$922 \$14853 VSS VDD \$13042 \$15200 \$15012 \$14338 sg13g2_a22oi_1
* cell instance $923 r0 *1 278.4,283.5
X$923 \$17576 VSS VDD \$18484 \$21446 \$16323 \$21079 sg13g2_a22oi_1
* cell instance $924 r0 *1 172.32,245.7
X$924 \$17845 VSS VDD \$18093 \$17434 \$17842 \$17009 sg13g2_a22oi_1
* cell instance $925 r0 *1 249.6,215.46
X$925 \$15060 VSS VDD \$12234 \$11519 \$14905 \$14802 sg13g2_a22oi_1
* cell instance $926 r0 *1 212.16,245.7
X$926 \$18149 VSS VDD \$13181 \$17862 \$16315 \$16637 sg13g2_a22oi_1
* cell instance $927 r0 *1 266.88,253.26
X$927 \$18307 VSS VDD \$17896 \$11872 \$14905 \$18826 sg13g2_a22oi_1
* cell instance $928 r0 *1 310.08,245.7
X$928 \$17115 VSS VDD \$17474 \$12070 \$14905 \$18008 sg13g2_a22oi_1
* cell instance $929 r0 *1 219.36,170.1
X$929 \$11429 VSS VDD \$11266 \$9637 \$11490 \$10876 sg13g2_a22oi_1
* cell instance $930 r0 *1 132.48,79.38
X$930 \$4518 VSS VDD \$4299 \$3500 \$4035 \$2723 sg13g2_a22oi_1
* cell instance $931 r0 *1 192.48,268.38
X$931 \$18987 VSS VDD \$17896 \$20414 \$19425 \$19427 sg13g2_a22oi_1
* cell instance $932 r0 *1 284.16,245.7
X$932 \$17903 VSS VDD \$17104 \$17470 \$15697 \$17905 sg13g2_a22oi_1
* cell instance $933 r0 *1 239.52,238.14
X$933 \$17083 VSS VDD \$13832 \$17373 \$17082 \$12921 sg13g2_a22oi_1
* cell instance $934 r0 *1 41.76,170.1
X$934 \$11446 VSS VDD \$11448 \$11447 \$11745 \$11325 sg13g2_a22oi_1
* cell instance $935 r0 *1 200.64,238.14
X$935 \$17097 VSS VDD \$16315 \$16244 \$16150 \$16796 sg13g2_a22oi_1
* cell instance $936 r0 *1 281.28,283.5
X$936 \$16096 VSS VDD \$18237 \$21328 \$18484 \$20940 sg13g2_a22oi_1
* cell instance $937 r0 *1 322.56,207.9
X$937 \$14479 VSS VDD \$14255 \$14437 \$14431 \$14241 sg13g2_a22oi_1
* cell instance $938 r0 *1 144.96,192.78
X$938 \$12647 VSS VDD \$12637 \$12640 \$12898 \$11868 sg13g2_a22oi_1
* cell instance $939 r0 *1 261.6,245.7
X$939 \$18180 VSS VDD \$16638 \$14068 \$15250 \$17830 sg13g2_a22oi_1
* cell instance $940 r0 *1 265.92,245.7
X$940 \$18157 VSS VDD \$13442 \$17899 \$17896 \$4579 sg13g2_a22oi_1
* cell instance $941 r0 *1 236.64,238.14
X$941 \$17081 VSS VDD \$13832 \$16959 \$17082 \$12920 sg13g2_a22oi_1
* cell instance $942 r0 *1 248.16,230.58
X$942 \$15956 VSS VDD \$16315 \$15963 \$15697 \$15353 sg13g2_a22oi_1
* cell instance $943 r0 *1 275.52,253.26
X$943 \$18483 VSS VDD \$14911 \$18827 \$18484 \$14462 sg13g2_a22oi_1
* cell instance $944 r0 *1 255.84,253.26
X$944 \$17090 VSS VDD \$17684 \$18819 \$17474 \$18296 sg13g2_a22oi_1
* cell instance $945 r0 *1 285.6,223.02
X$945 \$15381 VSS VDD \$11671 \$15385 \$15697 \$9964 sg13g2_a22oi_1
* cell instance $946 r0 *1 259.68,223.02
X$946 \$14907 VSS VDD \$15675 \$16806 \$15375 \$14896 sg13g2_a22oi_1
* cell instance $947 r0 *1 27.84,185.22
X$947 \$11811 VSS VDD \$12572 \$12744 \$12619 \$12325 sg13g2_a22oi_1
* cell instance $948 r0 *1 116.64,200.34
X$948 \$13044 VSS VDD \$12637 \$13905 \$13796 \$12901 sg13g2_a22oi_1
* cell instance $949 r0 *1 245.28,230.58
X$949 \$15679 VSS VDD \$16152 \$16317 \$16323 \$10651 sg13g2_a22oi_1
* cell instance $950 r0 *1 219.36,192.78
X$950 \$13554 VSS VDD \$11772 \$9127 \$11490 \$13810 sg13g2_a22oi_1
* cell instance $951 r0 *1 282.24,253.26
X$951 \$18949 VSS VDD \$11671 \$20134 \$18484 \$9844 sg13g2_a22oi_1
* cell instance $952 r0 *1 218.4,336.42
X$952 \$24758 VSS VDD \$24073 \$23548 \$24393 \$24755 sg13g2_a22oi_1
* cell instance $953 r0 *1 301.92,253.26
X$953 \$18310 VSS VDD \$14063 \$20361 \$17474 \$18487 sg13g2_a22oi_1
* cell instance $954 r0 *1 258.24,215.46
X$954 \$15252 VSS VDD \$14841 \$14422 \$15250 \$13817 sg13g2_a22oi_1
* cell instance $955 r0 *1 288,253.26
X$955 \$18961 VSS VDD \$18484 \$19113 \$14063 \$19282 sg13g2_a22oi_1
* cell instance $956 m0 *1 290.88,260.82
X$956 VSS \$13229 \$19109 VDD sg13g2_buf_4
* cell instance $957 r0 *1 47.52,223.02
X$957 \$15753 VSS VDD \$15632 \$14981 \$14986 \$15631 sg13g2_a22oi_1
* cell instance $958 r0 *1 136.32,230.58
X$958 \$16492 VSS VDD \$15350 \$16043 \$16283 \$16136 sg13g2_a22oi_1
* cell instance $959 r0 *1 271.68,283.5
X$959 \$18546 VSS VDD \$16843 \$21064 \$16323 \$22026 sg13g2_a22oi_1
* cell instance $960 r0 *1 222.24,192.78
X$960 \$13182 VSS VDD \$11503 \$13430 \$13181 \$7181 sg13g2_a22oi_1
* cell instance $961 r0 *1 210.72,177.66
X$961 \$11973 VSS VDD \$11772 \$10300 \$11490 \$11480 sg13g2_a22oi_1
* cell instance $962 r0 *1 308.16,328.86
X$962 \$23948 VSS VDD \$24142 \$23842 \$23840 \$23977 sg13g2_a22oi_1
* cell instance $963 r0 *1 167.52,245.7
X$963 \$17435 VSS VDD \$17659 \$17862 \$17018 \$17665 sg13g2_a22oi_1
* cell instance $964 r0 *1 304.8,215.46
X$964 \$15079 VSS VDD \$14063 \$14080 \$15078 \$13851 sg13g2_a22oi_1
* cell instance $965 r0 *1 255.36,170.1
X$965 \$11667 VSS VDD \$11503 \$9474 \$11671 \$8909 sg13g2_a22oi_1
* cell instance $966 r0 *1 210.72,170.1
X$966 \$11493 VSS VDD \$11266 \$10725 \$11490 \$11487 sg13g2_a22oi_1
* cell instance $967 r0 *1 153.6,56.7
X$967 \$2841 VSS VDD \$2343 \$1869 \$2230 \$1186 sg13g2_a22oi_1
* cell instance $968 r0 *1 315.84,306.18
X$968 \$22601 VSS VDD \$22474 \$22736 \$22780 \$22420 sg13g2_a22oi_1
* cell instance $969 r0 *1 222.24,170.1
X$969 \$11703 VSS VDD \$11663 \$10733 \$11266 \$7368 sg13g2_a22oi_1
* cell instance $970 r0 *1 213.6,170.1
X$970 \$11701 VSS VDD \$11266 \$9272 \$11490 \$10963 sg13g2_a22oi_1
* cell instance $971 r0 *1 227.52,177.66
X$971 \$12036 VSS VDD \$11663 \$12241 \$11266 \$8275 sg13g2_a22oi_1
* cell instance $972 r0 *1 216.48,170.1
X$972 \$11644 VSS VDD \$11266 \$8899 \$11490 \$10730 sg13g2_a22oi_1
* cell instance $973 r0 *1 108.48,132.3
X$973 \$8156 VSS VDD \$7944 \$6914 \$7341 \$7844 sg13g2_a22oi_1
* cell instance $974 r0 *1 154.08,245.7
X$974 \$17431 VSS VDD \$17830 \$17018 \$17831 \$17659 sg13g2_a22oi_1
* cell instance $975 r0 *1 307.2,245.7
X$975 \$18022 VSS VDD \$17474 \$12061 \$14905 \$17693 sg13g2_a22oi_1
* cell instance $976 r0 *1 313.92,177.66
X$976 \$11781 VSS VDD \$11780 \$10328 \$12186 \$12061 sg13g2_a22oi_1
* cell instance $977 r0 *1 169.92,71.82
X$977 \$3719 VSS VDD \$3718 \$1866 \$3170 \$3117 sg13g2_a22oi_1
* cell instance $978 r0 *1 321.6,283.5
X$978 \$20947 VSS VDD \$20690 \$21096 \$20798 \$20687 sg13g2_a22oi_1
* cell instance $979 r0 *1 252,207.9
X$979 \$14401 VSS VDD \$13832 \$13191 \$13977 \$13066 sg13g2_a22oi_1
* cell instance $980 r0 *1 317.76,313.74
X$980 \$14240 VSS VDD \$22731 \$22735 \$23172 \$23173 sg13g2_a22oi_1
* cell instance $981 r0 *1 210.72,253.26
X$981 \$18781 VSS VDD \$16638 \$18782 \$15250 \$17668 sg13g2_a22oi_1
* cell instance $982 r0 *1 209.28,245.7
X$982 \$17859 VSS VDD \$13181 \$17433 \$15250 \$16309 sg13g2_a22oi_1
* cell instance $983 r0 *1 73.92,177.66
X$983 \$7030 VSS VDD \$12001 \$11759 \$12009 \$11921 sg13g2_a22oi_1
* cell instance $984 r0 *1 286.08,230.58
X$984 \$16835 VSS VDD \$16342 \$15970 \$15697 \$13221 sg13g2_a22oi_1
* cell instance $985 m0 *1 236.64,230.58
X$985 VSS VDD \$16206 \$16586 \$11667 \$15502 sg13g2_nand3_1
* cell instance $986 m0 *1 236.16,245.7
X$986 VSS VDD \$17748 \$16802 \$17081 \$17629 sg13g2_nand3_1
* cell instance $987 m0 *1 200.64,283.5
X$987 VSS VDD \$20012 \$20195 \$20670 \$20014 sg13g2_nand3_1
* cell instance $988 m0 *1 83.52,64.26
X$988 VSS VDD \$3084 \$1756 \$2879 \$2323 sg13g2_nand3_1
* cell instance $989 m0 *1 201.12,94.5
X$989 VSS VDD \$5097 \$4331 \$5019 \$5021 sg13g2_nand3_1
* cell instance $990 m0 *1 294.72,260.82
X$990 VSS VDD \$18058 \$18510 \$18949 \$20052 sg13g2_nand3_1
* cell instance $991 m0 *1 261.6,306.18
X$991 VSS VDD \$22141 \$22344 \$20159 \$19086 sg13g2_nand3_1
* cell instance $992 m0 *1 267.84,306.18
X$992 VSS VDD \$22584 \$22344 \$22145 \$18477 sg13g2_nand3_1
* cell instance $993 m0 *1 226.56,260.82
X$993 VSS VDD \$16105 \$18296 \$18793 \$19090 sg13g2_nand3_1
* cell instance $994 m0 *1 237.12,253.26
X$994 VSS VDD \$15524 \$17877 \$18296 \$17879 sg13g2_nand3_1
* cell instance $995 m0 *1 73.44,298.62
X$995 VSS VDD \$21540 \$21007 \$22096 \$22091 sg13g2_nand3_1
* cell instance $996 m0 *1 180.96,351.54
X$996 VSS VDD \$23827 \$23540 \$23630 \$23510 sg13g2_nand3_1
* cell instance $997 m0 *1 63.36,56.7
X$997 VSS VDD \$2438 \$1390 \$2311 \$2313 sg13g2_nand3_1
* cell instance $998 m0 *1 76.32,109.62
X$998 VSS VDD \$6487 \$7030 \$6402 \$6400 sg13g2_nand3_1
* cell instance $999 m0 *1 134.88,328.86
X$999 VSS VDD \$23669 \$23618 \$23531 \$23673 sg13g2_nand3_1
* cell instance $1000 m0 *1 219.36,238.14
X$1000 VSS VDD \$14053 \$16963 \$16637 \$16309 sg13g2_nand3_1
* cell instance $1001 m0 *1 104.64,321.3
X$1001 VSS VDD \$23255 \$23340 \$23440 \$23795 sg13g2_nand3_1
* cell instance $1002 m0 *1 56.64,200.34
X$1002 VSS VDD \$12624 \$11990 \$13129 \$13132 sg13g2_nand3_1
* cell instance $1003 m0 *1 322.08,238.14
X$1003 VSS VDD \$16165 \$15714 \$16645 \$15088 sg13g2_nand3_1
* cell instance $1004 m0 *1 105.6,86.94
X$1004 VSS VDD \$4470 \$3602 \$1673 \$3497 sg13g2_nand3_1
* cell instance $1005 m0 *1 320.64,170.1
X$1005 VSS VDD \$11038 \$8057 \$10545 \$10668 sg13g2_nand3_1
* cell instance $1006 m0 *1 203.04,109.62
X$1006 VSS VDD \$6195 \$5391 \$6788 \$6590 sg13g2_nand3_1
* cell instance $1007 m0 *1 27.84,124.74
X$1007 VSS VDD \$7315 \$6396 \$7314 \$7054 sg13g2_nand3_1
* cell instance $1008 m0 *1 41.76,41.58
X$1008 VSS VDD \$1757 \$763 \$1393 \$1392 sg13g2_nand3_1
* cell instance $1009 m0 *1 190.08,49.14
X$1009 VSS VDD \$2178 \$781 \$1889 \$1731 sg13g2_nand3_1
* cell instance $1010 m0 *1 23.04,71.82
X$1010 VSS VDD \$3477 \$2037 \$3280 \$3024 sg13g2_nand3_1
* cell instance $1011 m0 *1 238.56,245.7
X$1011 VSS VDD \$17085 \$17084 \$17083 \$17454 sg13g2_nand3_1
* cell instance $1012 m0 *1 348.96,86.94
X$1012 VSS VDD \$4409 \$4641 \$4643 \$5917 sg13g2_nand3_1
* cell instance $1013 m0 *1 228.96,260.82
X$1013 VSS VDD \$19019 \$19339 \$18185 \$18592 sg13g2_nand3_1
* cell instance $1014 m0 *1 347.52,177.66
X$1014 VSS VDD \$9306 \$10330 \$11526 \$11721 sg13g2_nand3_1
* cell instance $1015 m0 *1 186.72,34.02
X$1015 VSS VDD \$893 \$84 \$86 \$85 sg13g2_nand3_1
* cell instance $1016 m0 *1 277.44,253.26
X$1016 VSS VDD \$17897 \$18483 \$17466 \$18310 sg13g2_nand3_1
* cell instance $1017 m0 *1 169.92,177.66
X$1017 VSS VDD \$11479 \$12459 \$12614 \$11764 sg13g2_nand3_1
* cell instance $1018 m0 *1 321.6,321.3
X$1018 VSS VDD \$23174 \$22738 \$23175 \$22736 sg13g2_nand3_1
* cell instance $1019 r0 *1 281.76,238.14
X$1019 VSS VDD \$16949 \$17246 \$17111 \$16835 sg13g2_nand3_1
* cell instance $1020 r0 *1 295.2,139.86
X$1020 VSS VDD \$2635 \$7423 \$2402 \$7422 sg13g2_nand3_1
* cell instance $1021 r0 *1 43.2,177.66
X$1021 VSS VDD \$11745 \$10528 \$11744 \$11743 sg13g2_nand3_1
* cell instance $1022 r0 *1 292.8,139.86
X$1022 VSS VDD \$8922 \$9139 \$2431 \$8697 sg13g2_nand3_1
* cell instance $1023 r0 *1 184.8,154.98
X$1023 VSS VDD \$10629 \$10623 \$10165 \$5653 sg13g2_nand3_1
* cell instance $1024 r0 *1 18.72,41.58
X$1024 VSS VDD \$1389 \$510 \$1387 \$1182 sg13g2_nand3_1
* cell instance $1025 r0 *1 84,94.5
X$1025 VSS VDD \$5482 \$5139 \$5371 \$5372 sg13g2_nand3_1
* cell instance $1026 r0 *1 23.04,147.42
X$1026 VSS VDD \$9681 \$8065 \$9092 \$8869 sg13g2_nand3_1
* cell instance $1027 r0 *1 209.28,162.54
X$1027 VSS VDD \$11152 \$10876 \$11263 \$10963 sg13g2_nand3_1
* cell instance $1028 r0 *1 83.04,18.9
X$1028 VSS VDD \$643 \$150 \$451 \$452 sg13g2_nand3_1
* cell instance $1029 r0 *1 252,177.66
X$1029 VSS VDD \$12053 \$11501 \$11776 \$11274 sg13g2_nand3_1
* cell instance $1030 r0 *1 154.56,18.9
X$1030 VSS VDD \$331 \$76 \$277 \$462 sg13g2_nand3_1
* cell instance $1031 r0 *1 115.68,291.06
X$1031 VSS VDD \$21509 \$20519 \$21435 \$21547 sg13g2_nand3_1
* cell instance $1032 r0 *1 233.76,260.82
X$1032 VSS VDD \$19441 \$19189 \$19190 \$19439 sg13g2_nand3_1
* cell instance $1033 r0 *1 20.16,185.22
X$1033 VSS VDD \$12325 \$10968 \$12323 \$12282 sg13g2_nand3_1
* cell instance $1034 r0 *1 255.84,185.22
X$1034 VSS VDD \$12358 \$12591 \$12363 \$12695 sg13g2_nand3_1
* cell instance $1035 r0 *1 110.88,291.06
X$1035 VSS VDD \$21827 \$21547 \$21385 \$21548 sg13g2_nand3_1
* cell instance $1036 r0 *1 195.84,283.5
X$1036 VSS VDD \$20774 \$20449 \$20665 \$20764 sg13g2_nand3_1
* cell instance $1037 r0 *1 116.16,223.02
X$1037 VSS VDD \$15453 \$15012 \$14650 \$15011 sg13g2_nand3_1
* cell instance $1038 r0 *1 275.04,245.7
X$1038 VSS VDD \$18124 \$15079 \$18546 \$17686 sg13g2_nand3_1
* cell instance $1039 r0 *1 236.16,260.82
X$1039 VSS VDD \$19865 \$19090 \$17877 \$19449 sg13g2_nand3_1
* cell instance $1040 r0 *1 40.8,64.26
X$1040 VSS VDD \$3386 \$3201 \$513 \$3545 sg13g2_nand3_1
* cell instance $1041 r0 *1 122.4,94.5
X$1041 VSS VDD \$5387 \$3301 \$5500 \$5381 sg13g2_nand3_1
* cell instance $1042 r0 *1 183.84,34.02
X$1042 VSS VDD \$1616 \$337 \$921 \$1001 sg13g2_nand3_1
* cell instance $1043 r0 *1 195.36,275.94
X$1043 VSS VDD \$20351 \$20233 \$20451 \$20508 sg13g2_nand3_1
* cell instance $1044 r0 *1 203.52,49.14
X$1044 VSS VDD \$2237 \$1270 \$1323 \$1782 sg13g2_nand3_1
* cell instance $1045 r0 *1 30.72,185.22
X$1045 VSS VDD \$12619 \$11304 \$12621 \$12410 sg13g2_nand3_1
* cell instance $1046 r0 *1 326.88,223.02
X$1046 VSS VDD \$15713 \$14075 \$15568 \$11949 sg13g2_nand3_1
* cell instance $1047 r0 *1 239.52,230.58
X$1047 VSS VDD \$16594 \$16205 \$15594 \$16151 sg13g2_nand3_1
* cell instance $1048 r0 *1 347.52,170.1
X$1048 VSS VDD \$11206 \$11296 \$11526 \$10330 sg13g2_nand3_1
* cell instance $1049 r0 *1 270.24,245.7
X$1049 VSS VDD \$18132 \$17315 \$17464 \$17686 sg13g2_nand3_1
* cell instance $1050 r0 *1 145.44,253.26
X$1050 VSS VDD \$19078 \$14018 \$17826 \$17433 sg13g2_nand3_1
* cell instance $1051 r0 *1 133.92,343.98
X$1051 VSS VDD \$24367 \$24594 \$24385 \$23910 sg13g2_nand3_1
* cell instance $1052 r0 *1 132.96,245.7
X$1052 VSS VDD \$17428 \$15847 \$15846 \$17009 sg13g2_nand3_1
* cell instance $1053 r0 *1 88.32,34.02
X$1053 VSS VDD \$1075 \$146 \$538 \$905 sg13g2_nand3_1
* cell instance $1054 r0 *1 45.12,170.1
X$1054 VSS VDD \$11448 \$9609 \$10973 \$11168 sg13g2_nand3_1
* cell instance $1055 r0 *1 59.52,238.14
X$1055 VSS VDD \$16955 \$17004 \$18445 \$16876 sg13g2_nand3_1
* cell instance $1056 r0 *1 29.28,162.54
X$1056 VSS VDD \$11050 \$9493 \$10272 \$9780 sg13g2_nand3_1
* cell instance $1057 r0 *1 318.24,245.7
X$1057 VSS VDD \$17129 \$17697 \$17120 \$16912 sg13g2_nand3_1
* cell instance $1058 r0 *1 268.8,215.46
X$1058 VSS VDD \$15059 \$14907 \$15214 \$14910 sg13g2_nand3_1
* cell instance $1059 r0 *1 30.24,102.06
X$1059 VSS VDD \$6237 \$4832 \$6135 \$5812 sg13g2_nand3_1
* cell instance $1060 r0 *1 221.76,245.7
X$1060 VSS VDD \$14776 \$15232 \$17826 \$17433 sg13g2_nand3_1
* cell instance $1061 r0 *1 290.4,139.86
X$1061 VSS VDD \$2392 \$7841 \$2653 \$588 sg13g2_nand3_1
* cell instance $1062 r0 *1 124.32,328.86
X$1062 VSS VDD \$23101 \$22325 \$21623 \$21507 sg13g2_nand3_1
* cell instance $1063 m0 *1 336,298.62
X$1063 VDD \$22159 VSS \$22353 \$21852 \$21854 sg13g2_a21oi_1
* cell instance $1064 m0 *1 54.24,321.3
X$1064 VDD \$23375 VSS \$23522 \$23086 \$23039 sg13g2_a21oi_1
* cell instance $1065 m0 *1 116.16,291.06
X$1065 VDD \$21695 VSS \$20414 \$21312 \$21384 sg13g2_a21oi_1
* cell instance $1066 m0 *1 106.08,117.18
X$1066 VDD \$6768 VSS \$6513 \$5363 \$4025 sg13g2_a21oi_1
* cell instance $1067 m0 *1 33.6,215.46
X$1067 VDD \$13779 VSS \$14928 \$14680 \$14195 sg13g2_a21oi_1
* cell instance $1068 m0 *1 309.12,328.86
X$1068 VDD \$23736 VSS \$23948 \$23714 \$23743 sg13g2_a21oi_1
* cell instance $1069 m0 *1 294.24,192.78
X$1069 VDD \$12552 VSS \$12377 \$12710 \$12709 sg13g2_a21oi_1
* cell instance $1070 m0 *1 324,200.34
X$1070 VDD \$13481 VSS \$13072 \$13241 \$13491 sg13g2_a21oi_1
* cell instance $1071 m0 *1 84.48,26.46
X$1071 VDD \$773 VSS \$451 \$452 \$150 sg13g2_a21oi_1
* cell instance $1072 m0 *1 262.56,185.22
X$1072 VDD \$12056 VSS \$12311 \$12310 \$12545 sg13g2_a21oi_1
* cell instance $1073 m0 *1 282.72,275.94
X$1073 VDD \$20141 VSS \$19682 \$18907 \$20049 sg13g2_a21oi_1
* cell instance $1074 m0 *1 38.4,260.82
X$1074 VDD \$19065 VSS \$17740 \$16231 \$18728 sg13g2_a21oi_1
* cell instance $1075 m0 *1 59.04,200.34
X$1075 VDD \$13276 VSS \$13129 \$13132 \$11990 sg13g2_a21oi_1
* cell instance $1076 m0 *1 69.6,26.46
X$1076 VDD \$818 VSS \$450 \$522 \$36 sg13g2_a21oi_1
* cell instance $1077 m0 *1 121.44,283.5
X$1077 VDD \$20843 VSS \$20351 \$20515 \$20611 sg13g2_a21oi_1
* cell instance $1078 m0 *1 217.44,154.98
X$1078 VDD \$10058 VSS \$9830 \$10057 \$8896 sg13g2_a21oi_1
* cell instance $1079 m0 *1 219.36,291.06
X$1079 VDD \$21424 VSS \$20342 \$12711 \$21054 sg13g2_a21oi_1
* cell instance $1080 m0 *1 302.88,298.62
X$1080 VDD \$21741 VSS \$20795 \$12710 \$21739 sg13g2_a21oi_1
* cell instance $1081 m0 *1 17.76,102.06
X$1081 VDD \$5139 VSS \$5600 \$4268 \$5897 sg13g2_a21oi_1
* cell instance $1082 m0 *1 269.76,124.74
X$1082 VDD \$6813 VSS \$7407 \$7575 \$8033 sg13g2_a21oi_1
* cell instance $1083 m0 *1 322.56,177.66
X$1083 VDD \$10336 VSS \$11789 \$7426 \$8672 sg13g2_a21oi_1
* cell instance $1084 m0 *1 119.52,41.58
X$1084 VDD \$1422 VSS \$1426 \$973 \$1733 sg13g2_a21oi_1
* cell instance $1085 m0 *1 29.76,238.14
X$1085 VDD \$15922 VSS \$16657 \$16226 \$14984 sg13g2_a21oi_1
* cell instance $1086 m0 *1 128.16,207.9
X$1086 VDD \$13905 VSS \$13801 \$13327 \$12973 sg13g2_a21oi_1
* cell instance $1087 m0 *1 227.04,109.62
X$1087 VDD \$6441 VSS \$6198 \$6592 \$5771 sg13g2_a21oi_1
* cell instance $1088 m0 *1 240.48,139.86
X$1088 VDD \$8626 VSS \$8021 \$8454 \$7364 sg13g2_a21oi_1
* cell instance $1089 m0 *1 326.4,321.3
X$1089 VDD \$23578 VSS \$22158 \$23171 \$23721 sg13g2_a21oi_1
* cell instance $1090 m0 *1 229.92,94.5
X$1090 VDD \$3922 VSS \$5410 \$4624 \$5346 sg13g2_a21oi_1
* cell instance $1091 m0 *1 40.32,177.66
X$1091 VDD \$11685 VSS \$11744 \$11743 \$10528 sg13g2_a21oi_1
* cell instance $1092 m0 *1 251.04,102.06
X$1092 VDD \$5414 VSS \$5183 \$4949 \$4579 sg13g2_a21oi_1
* cell instance $1093 m0 *1 140.16,192.78
X$1093 VDD \$12640 VSS \$12644 \$12642 \$12973 sg13g2_a21oi_1
* cell instance $1094 m0 *1 103.2,56.7
X$1094 VDD \$2671 VSS \$2329 \$2206 \$2464 sg13g2_a21oi_1
* cell instance $1095 m0 *1 59.52,291.06
X$1095 VDD \$21358 VSS \$20650 \$21007 \$21006 sg13g2_a21oi_1
* cell instance $1096 m0 *1 31.2,192.78
X$1096 VDD \$12283 VSS \$12621 \$12410 \$11304 sg13g2_a21oi_1
* cell instance $1097 m0 *1 342.72,313.74
X$1097 VDD \$23359 VSS \$20066 \$22898 \$22899 sg13g2_a21oi_1
* cell instance $1098 m0 *1 81.12,64.26
X$1098 VDD \$2795 VSS \$2879 \$2323 \$1756 sg13g2_a21oi_1
* cell instance $1099 m0 *1 35.52,253.26
X$1099 VDD \$16653 VSS \$17957 \$17494 \$14984 sg13g2_a21oi_1
* cell instance $1100 m0 *1 236.64,132.3
X$1100 VDD \$8013 VSS \$5320 \$8020 \$8275 sg13g2_a21oi_1
* cell instance $1101 m0 *1 220.32,215.46
X$1101 VDD \$14630 VSS \$14811 \$14812 \$14223 sg13g2_a21oi_1
* cell instance $1102 m0 *1 55.2,238.14
X$1102 VDD \$16402 VSS \$14878 \$16239 \$16669 sg13g2_a21oi_1
* cell instance $1103 m0 *1 30.24,124.74
X$1103 VDD \$7056 VSS \$7314 \$7054 \$6396 sg13g2_a21oi_1
* cell instance $1104 m0 *1 74.88,154.98
X$1104 VDD \$9088 VSS \$10044 \$10043 \$10155 sg13g2_a21oi_1
* cell instance $1105 m0 *1 228,132.3
X$1105 VDD \$5320 VSS \$8020 \$8275 \$8015 sg13g2_a21oi_1
* cell instance $1106 m0 *1 123.36,223.02
X$1106 VDD \$15200 VSS \$13152 \$15346 \$12973 sg13g2_a21oi_1
* cell instance $1107 m0 *1 233.28,185.22
X$1107 VDD \$12357 VSS \$11901 \$12041 \$11668 sg13g2_a21oi_1
* cell instance $1108 m0 *1 233.76,223.02
X$1108 VDD \$15366 VSS \$13442 \$7182 \$15316 sg13g2_a21oi_1
* cell instance $1109 m0 *1 224.64,94.5
X$1109 VDD \$4756 VSS \$5027 \$3514 \$5338 sg13g2_a21oi_1
* cell instance $1110 m0 *1 235.68,185.22
X$1110 VDD \$12679 VSS \$11901 \$12360 \$12509 sg13g2_a21oi_1
* cell instance $1111 m0 *1 137.76,192.78
X$1111 VDD \$12897 VSS \$12638 \$12968 \$12966 sg13g2_a21oi_1
* cell instance $1112 m0 *1 243.84,283.5
X$1112 VDD \$20619 VSS \$20458 \$13228 \$20621 sg13g2_a21oi_1
* cell instance $1113 m0 *1 246.24,283.5
X$1113 VDD \$20544 VSS \$20458 \$16082 \$20681 sg13g2_a21oi_1
* cell instance $1114 m0 *1 228.48,283.5
X$1114 VDD \$20777 VSS \$20342 \$14666 \$20713 sg13g2_a21oi_1
* cell instance $1115 m0 *1 76.8,124.74
X$1115 VDD \$4992 VSS \$7031 \$6621 \$9793 sg13g2_a21oi_1
* cell instance $1116 m0 *1 255.84,207.9
X$1116 VDD \$13597 VSS \$13199 \$12918 \$13066 sg13g2_a21oi_1
* cell instance $1117 m0 *1 114.24,268.38
X$1117 VDD \$19414 VSS \$19723 \$18742 \$11897 sg13g2_a21oi_1
* cell instance $1118 m0 *1 249.12,223.02
X$1118 VDD \$15372 VSS \$13977 \$14157 \$15059 sg13g2_a21oi_1
* cell instance $1119 m0 *1 335.52,79.38
X$1119 VDD \$3766 VSS \$2919 \$3100 \$3744 sg13g2_a21oi_1
* cell instance $1120 m0 *1 195.84,147.42
X$1120 VDD \$9424 VSS \$8612 \$9272 \$5338 sg13g2_a21oi_1
* cell instance $1121 m0 *1 231.84,245.7
X$1121 VDD \$17084 VSS \$13977 \$13691 \$17077 sg13g2_a21oi_1
* cell instance $1122 m0 *1 118.08,170.1
X$1122 VDD \$9622 VSS \$11182 \$10989 \$11181 sg13g2_a21oi_1
* cell instance $1123 m0 *1 85.92,192.78
X$1123 VDD \$10049 VSS \$12628 \$12627 \$13098 sg13g2_a21oi_1
* cell instance $1124 m0 *1 96,260.82
X$1124 VDD \$18749 VSS \$18945 \$19073 \$17515 sg13g2_a21oi_1
* cell instance $1125 m0 *1 245.76,117.18
X$1125 VDD \$7143 VSS \$7389 \$7044 \$5784 sg13g2_a21oi_1
* cell instance $1126 m0 *1 158.88,102.06
X$1126 VDD \$5624 VSS \$5392 \$4157 \$5627 sg13g2_a21oi_1
* cell instance $1127 m0 *1 25.44,71.82
X$1127 VDD \$3281 VSS \$3280 \$3024 \$2037 sg13g2_a21oi_1
* cell instance $1128 m0 *1 248.64,102.06
X$1128 VDD \$5032 VSS \$5419 \$5663 \$5862 sg13g2_a21oi_1
* cell instance $1129 m0 *1 213.12,192.78
X$1129 VDD \$12865 VSS \$10873 \$11487 \$11489 sg13g2_a21oi_1
* cell instance $1130 m0 *1 192.48,49.14
X$1130 VDD \$1894 VSS \$1889 \$1731 \$781 sg13g2_a21oi_1
* cell instance $1131 m0 *1 257.76,71.82
X$1131 VDD \$2748 VSS \$3640 \$3734 \$3126 sg13g2_a21oi_1
* cell instance $1132 m0 *1 252.96,306.18
X$1132 VDD \$22408 VSS \$22022 \$22336 \$22340 sg13g2_a21oi_1
* cell instance $1133 m0 *1 39.84,245.7
X$1133 VDD \$16876 VSS \$14980 \$16995 \$18663 sg13g2_a21oi_1
* cell instance $1134 m0 *1 234.72,147.42
X$1134 VDD \$9398 VSS \$9236 \$9285 \$8270 sg13g2_a21oi_1
* cell instance $1135 m0 *1 205.92,162.54
X$1135 VDD \$10732 VSS \$10474 \$10733 \$10730 sg13g2_a21oi_1
* cell instance $1136 m0 *1 277.92,147.42
X$1136 VDD \$9294 VSS \$9475 \$9295 \$7821 sg13g2_a21oi_1
* cell instance $1137 m0 *1 85.44,177.66
X$1137 VDD \$3037 VSS \$11756 \$11686 \$12002 sg13g2_a21oi_1
* cell instance $1138 m0 *1 132,306.18
X$1138 VDD \$22110 VSS \$20414 \$22326 \$20519 sg13g2_a21oi_1
* cell instance $1139 m0 *1 36.48,230.58
X$1139 VDD \$15737 VSS \$15631 \$16231 \$15629 sg13g2_a21oi_1
* cell instance $1140 m0 *1 50.4,268.38
X$1140 VDD \$19713 VSS \$17780 \$16127 \$19167 sg13g2_a21oi_1
* cell instance $1141 m0 *1 168.96,268.38
X$1141 VDD \$19835 VSS \$17669 \$13948 \$19736 sg13g2_a21oi_1
* cell instance $1142 m0 *1 63.36,162.54
X$1142 VDD \$8873 VSS \$10444 \$10273 \$12114 sg13g2_a21oi_1
* cell instance $1143 m0 *1 98.4,306.18
X$1143 VDD \$21822 VSS \$22563 \$22387 \$21598 sg13g2_a21oi_1
* cell instance $1144 m0 *1 79.68,230.58
X$1144 VDD \$16250 VSS \$15925 \$15924 \$14932 sg13g2_a21oi_1
* cell instance $1145 m0 *1 38.88,230.58
X$1145 VDD \$15631 VSS \$16389 \$15628 \$16179 sg13g2_a21oi_1
* cell instance $1146 m0 *1 42.24,117.18
X$1146 VDD \$6400 VSS \$6737 \$4976 \$6735 sg13g2_a21oi_1
* cell instance $1147 m0 *1 190.08,79.38
X$1147 VDD \$3716 VSS \$3324 \$2617 \$4739 sg13g2_a21oi_1
* cell instance $1148 m0 *1 303.84,154.98
X$1148 VDD \$10072 VSS \$9662 \$9661 \$8457 sg13g2_a21oi_1
* cell instance $1149 m0 *1 196.32,154.98
X$1149 VDD \$10055 VSS \$9825 \$9822 \$8382 sg13g2_a21oi_1
* cell instance $1150 m0 *1 115.68,238.14
X$1150 VDD \$18026 VSS \$15846 \$14018 \$16270 sg13g2_a21oi_1
* cell instance $1151 m0 *1 71.52,253.26
X$1151 VDD \$17986 VSS \$17004 \$16876 \$18445 sg13g2_a21oi_1
* cell instance $1152 m0 *1 288.48,260.82
X$1152 VDD \$19818 VSS \$16336 \$12711 \$19271 sg13g2_a21oi_1
* cell instance $1153 m0 *1 64.8,260.82
X$1153 VDD \$19171 VSS \$17003 \$8015 \$14984 sg13g2_a21oi_1
* cell instance $1154 m0 *1 227.04,94.5
X$1154 VDD \$5172 VSS \$4807 \$4623 \$3430 sg13g2_a21oi_1
* cell instance $1155 m0 *1 307.2,185.22
X$1155 VDD \$12376 VSS \$12377 \$12452 \$12315 sg13g2_a21oi_1
* cell instance $1156 m0 *1 18.72,139.86
X$1156 VDD \$8927 VSS \$9092 \$8869 \$8065 sg13g2_a21oi_1
* cell instance $1157 m0 *1 347.04,343.98
X$1157 VDD \$24634 VSS \$24109 \$24778 \$24780 sg13g2_a21oi_1
* cell instance $1158 m0 *1 84.96,185.22
X$1158 VDD \$12416 VSS \$11756 \$11686 \$10976 sg13g2_a21oi_1
* cell instance $1159 m0 *1 227.52,298.62
X$1159 VDD \$21715 VSS \$20342 \$13512 \$21269 sg13g2_a21oi_1
* cell instance $1160 m0 *1 108.96,238.14
X$1160 VDD \$16622 VSS \$16620 \$16256 \$16266 sg13g2_a21oi_1
* cell instance $1161 m0 *1 45.6,253.26
X$1161 VDD \$16874 VSS \$17202 \$16996 \$18267 sg13g2_a21oi_1
* cell instance $1162 m0 *1 25.92,253.26
X$1162 VDD \$18437 VSS \$18263 \$17486 \$16984 sg13g2_a21oi_1
* cell instance $1163 m0 *1 174.72,260.82
X$1163 VDD \$19839 VSS \$15946 \$10831 \$19291 sg13g2_a21oi_1
* cell instance $1164 m0 *1 118.56,351.54
X$1164 VDD \$24593 VSS \$25126 \$23669 \$23445 sg13g2_a21oi_1
* cell instance $1165 m0 *1 319.2,321.3
X$1165 VDD \$22893 VSS \$23174 \$23173 \$22734 sg13g2_a21oi_1
* cell instance $1166 m0 *1 102.72,275.94
X$1166 VDD \$19651 VSS \$19983 \$18737 \$19982 sg13g2_a21oi_1
* cell instance $1167 m0 *1 104.16,162.54
X$1167 VDD \$9501 VSS \$10457 \$10699 \$10456 sg13g2_a21oi_1
* cell instance $1168 m0 *1 257.76,328.86
X$1168 VDD \$23765 VSS \$23491 \$23151 \$23703 sg13g2_a21oi_1
* cell instance $1169 m0 *1 347.52,336.42
X$1169 VDD \$24284 VSS \$24107 \$23956 \$24282 sg13g2_a21oi_1
* cell instance $1170 m0 *1 141.12,238.14
X$1170 VDD \$16282 VSS \$16630 \$16794 \$16284 sg13g2_a21oi_1
* cell instance $1171 m0 *1 206.4,132.3
X$1171 VDD \$8614 VSS \$8006 \$8007 \$7685 sg13g2_a21oi_1
* cell instance $1172 m0 *1 178.08,343.98
X$1172 VDD \$24061 VSS \$23827 \$24389 \$24387 sg13g2_a21oi_1
* cell instance $1173 m0 *1 233.28,306.18
X$1173 VDD \$22304 VSS \$22311 \$22336 \$22340 sg13g2_a21oi_1
* cell instance $1174 m0 *1 235.68,306.18
X$1174 VDD \$22537 VSS \$22132 \$22336 \$22340 sg13g2_a21oi_1
* cell instance $1175 m0 *1 314.4,328.86
X$1175 VDD \$23715 VSS \$23563 \$23717 \$23716 sg13g2_a21oi_1
* cell instance $1176 m0 *1 211.2,245.7
X$1176 VDD \$16561 VSS \$15669 \$16963 \$16637 sg13g2_a21oi_1
* cell instance $1177 m0 *1 231.84,177.66
X$1177 VDD \$12247 VSS \$11901 \$11274 \$11675 sg13g2_a21oi_1
* cell instance $1178 m0 *1 135.36,245.7
X$1178 VDD \$17031 VSS \$16888 \$12968 \$16794 sg13g2_a21oi_1
* cell instance $1179 m0 *1 276,207.9
X$1179 VDD \$13349 VSS \$12700 \$13224 \$13598 sg13g2_a21oi_1
* cell instance $1180 m0 *1 292.8,207.9
X$1180 VDD \$13732 VSS \$13229 \$13228 \$13308 sg13g2_a21oi_1
* cell instance $1181 m0 *1 324,321.3
X$1181 VDD \$23471 VSS \$23175 \$22738 \$22736 sg13g2_a21oi_1
* cell instance $1182 m0 *1 228.48,185.22
X$1182 VDD \$12354 VSS \$11901 \$12278 \$12034 sg13g2_a21oi_1
* cell instance $1183 m0 *1 148.8,154.98
X$1183 VDD \$9803 VSS \$10052 \$8570 \$9569 sg13g2_a21oi_1
* cell instance $1184 m0 *1 230.88,185.22
X$1184 VDD \$12603 VSS \$11901 \$12054 \$12308 sg13g2_a21oi_1
* cell instance $1185 m0 *1 278.88,275.94
X$1185 VDD \$20045 VSS \$14232 \$20046 \$20358 sg13g2_a21oi_1
* cell instance $1186 m0 *1 230.4,192.78
X$1186 VDD \$12674 VSS \$11969 \$12310 \$12915 sg13g2_a21oi_1
* cell instance $1187 m0 *1 121.44,245.7
X$1187 VDD \$16627 VSS \$16793 \$12968 \$17023 sg13g2_a21oi_1
* cell instance $1188 m0 *1 198.72,94.5
X$1188 VDD \$5017 VSS \$5019 \$5021 \$4331 sg13g2_a21oi_1
* cell instance $1189 m0 *1 127.68,328.86
X$1189 VDD \$23529 VSS \$21623 \$21507 \$22325 sg13g2_a21oi_1
* cell instance $1190 m0 *1 264.96,283.5
X$1190 VDD \$20548 VSS \$20461 \$12057 \$20866 sg13g2_a21oi_1
* cell instance $1191 m0 *1 132.48,328.86
X$1191 VDD \$23822 VSS \$23914 \$23669 \$23445 sg13g2_a21oi_1
* cell instance $1192 m0 *1 44.16,41.58
X$1192 VDD \$1398 VSS \$1393 \$1392 \$763 sg13g2_a21oi_1
* cell instance $1193 m0 *1 123.84,328.86
X$1193 VDD \$23994 VSS \$23667 \$23669 \$23445 sg13g2_a21oi_1
* cell instance $1194 m0 *1 155.52,154.98
X$1194 VDD \$6314 VSS \$9815 \$9814 \$10767 sg13g2_a21oi_1
* cell instance $1195 m0 *1 293.28,154.98
X$1195 VDD \$9852 VSS \$10070 \$9853 \$8456 sg13g2_a21oi_1
* cell instance $1196 m0 *1 237.12,71.82
X$1196 VDD \$3851 VSS \$2969 \$2908 \$2978 sg13g2_a21oi_1
* cell instance $1197 m0 *1 145.44,230.58
X$1197 VDD \$15651 VSS \$15552 \$14354 \$15648 sg13g2_a21oi_1
* cell instance $1198 m0 *1 132,207.9
X$1198 VDD \$13907 VSS \$13962 \$12984 \$12818 sg13g2_a21oi_1
* cell instance $1199 m0 *1 249.12,139.86
X$1199 VDD \$8629 VSS \$6804 \$8909 \$8375 sg13g2_a21oi_1
* cell instance $1200 m0 *1 288.48,230.58
X$1200 VDD \$15070 VSS \$15802 \$15690 \$15695 sg13g2_a21oi_1
* cell instance $1201 m0 *1 315.36,321.3
X$1201 VDD \$23351 VSS \$23028 \$23171 \$23234 sg13g2_a21oi_1
* cell instance $1202 m0 *1 208.8,245.7
X$1202 VDD \$17388 VSS \$15669 \$16963 \$17065 sg13g2_a21oi_1
* cell instance $1203 m0 *1 194.4,253.26
X$1203 VDD \$18720 VSS \$17669 \$12893 \$18574 sg13g2_a21oi_1
* cell instance $1204 m0 *1 105.6,56.7
X$1204 VDD \$2469 VSS \$2329 \$2206 \$1668 sg13g2_a21oi_1
* cell instance $1205 m0 *1 45.6,238.14
X$1205 VDD \$15623 VSS \$16402 \$16231 \$16942 sg13g2_a21oi_1
* cell instance $1206 m0 *1 238.56,306.18
X$1206 VDD \$22542 VSS \$22315 \$22336 \$22340 sg13g2_a21oi_1
* cell instance $1207 m0 *1 255.84,147.42
X$1207 VDD \$9385 VSS \$9470 \$9469 \$8616 sg13g2_a21oi_1
* cell instance $1208 m0 *1 138.72,230.58
X$1208 VDD \$16043 VSS \$16282 \$16046 \$15647 sg13g2_a21oi_1
* cell instance $1209 r0 *1 129.6,109.62
X$1209 VDD \$6968 VSS \$6776 \$6417 \$6967 sg13g2_a21oi_1
* cell instance $1210 r0 *1 207.36,192.78
X$1210 VDD \$12911 VSS \$12305 \$12241 \$13416 sg13g2_a21oi_1
* cell instance $1211 r0 *1 63.36,245.7
X$1211 VDD \$17980 VSS \$14878 \$17004 \$8015 sg13g2_a21oi_1
* cell instance $1212 r0 *1 39.84,207.9
X$1212 VDD \$12879 VSS \$14306 \$14301 \$14195 sg13g2_a21oi_1
* cell instance $1213 r0 *1 284.64,102.06
X$1213 VDD \$6597 VSS \$6209 \$1923 \$6819 sg13g2_a21oi_1
* cell instance $1214 r0 *1 264.48,192.78
X$1214 VDD \$13092 VSS \$12705 \$13221 \$12924 sg13g2_a21oi_1
* cell instance $1215 r0 *1 74.88,41.58
X$1215 VDD \$1848 VSS \$1530 \$808 \$1847 sg13g2_a21oi_1
* cell instance $1216 r0 *1 44.16,215.46
X$1216 VDD \$14981 VSS \$14298 \$14871 \$14872 sg13g2_a21oi_1
* cell instance $1217 r0 *1 66.72,230.58
X$1217 VDD \$15917 VSS \$16413 \$16127 \$16247 sg13g2_a21oi_1
* cell instance $1218 r0 *1 345.6,268.38
X$1218 VDD \$19778 VSS \$18820 \$19487 \$19484 sg13g2_a21oi_1
* cell instance $1219 r0 *1 248.16,200.34
X$1219 VDD \$13471 VSS \$13199 \$12918 \$13451 sg13g2_a21oi_1
* cell instance $1220 r0 *1 216.48,200.34
X$1220 VDD \$13827 VSS \$13683 \$13684 \$13778 sg13g2_a21oi_1
* cell instance $1221 r0 *1 159.84,207.9
X$1221 VDD \$13936 VSS \$14557 \$14803 \$14040 sg13g2_a21oi_1
* cell instance $1222 r0 *1 160.32,223.02
X$1222 VDD \$15355 VSS \$15862 \$15644 \$16217 sg13g2_a21oi_1
* cell instance $1223 r0 *1 118.56,343.98
X$1223 VDD \$23656 VSS \$23441 \$23791 \$23818 sg13g2_a21oi_1
* cell instance $1224 r0 *1 130.56,298.62
X$1224 VDD \$14052 VSS \$22246 \$20519 \$22812 sg13g2_a21oi_1
* cell instance $1225 r0 *1 108.48,56.7
X$1225 VDD \$2888 VSS \$2886 \$2730 \$2041 sg13g2_a21oi_1
* cell instance $1226 r0 *1 318.24,215.46
X$1226 VDD \$11949 VSS \$12591 \$12695 \$14242 sg13g2_a21oi_1
* cell instance $1227 r0 *1 311.04,328.86
X$1227 VDD \$24275 VSS \$23713 \$23947 \$23977 sg13g2_a21oi_1
* cell instance $1228 r0 *1 145.92,64.26
X$1228 VDD \$3307 VSS \$3164 \$1723 \$3163 sg13g2_a21oi_1
* cell instance $1229 r0 *1 265.92,117.18
X$1229 VDD \$6810 VSS \$7398 \$7193 \$5407 sg13g2_a21oi_1
* cell instance $1230 r0 *1 246.24,306.18
X$1230 VDD \$23933 VSS \$22136 \$22336 \$22340 sg13g2_a21oi_1
* cell instance $1231 r0 *1 211.68,162.54
X$1231 VDD \$10736 VSS \$10474 \$10733 \$10872 sg13g2_a21oi_1
* cell instance $1232 r0 *1 316.8,64.26
X$1232 VDD \$1935 VSS \$2915 \$2927 \$3932 sg13g2_a21oi_1
* cell instance $1233 r0 *1 185.28,230.58
X$1233 VDD \$16212 VSS \$15946 \$13512 \$16542 sg13g2_a21oi_1
* cell instance $1234 r0 *1 178.08,117.18
X$1234 VDD \$5381 VSS \$7356 \$7128 \$7354 sg13g2_a21oi_1
* cell instance $1235 r0 *1 251.04,306.18
X$1235 VDD \$22703 VSS \$22407 \$22336 \$22340 sg13g2_a21oi_1
* cell instance $1236 r0 *1 249.6,268.38
X$1236 VDD \$17360 VSS \$19608 \$20040 \$19756 sg13g2_a21oi_1
* cell instance $1237 r0 *1 97.44,18.9
X$1237 VDD \$536 VSS \$538 \$905 \$146 sg13g2_a21oi_1
* cell instance $1238 r0 *1 119.04,283.5
X$1238 VDD \$21191 VSS \$20351 \$19986 \$20854 sg13g2_a21oi_1
* cell instance $1239 r0 *1 209.28,147.42
X$1239 VDD \$10056 VSS \$8612 \$9272 \$9637 sg13g2_a21oi_1
* cell instance $1240 r0 *1 104.64,328.86
X$1240 VDD \$24874 VSS \$23669 \$23910 \$23445 sg13g2_a21oi_1
* cell instance $1241 r0 *1 257.76,328.86
X$1241 VDD \$23934 VSS \$24194 \$23142 \$23139 sg13g2_a21oi_1
* cell instance $1242 r0 *1 65.76,260.82
X$1242 VDD \$19407 VSS \$19409 \$19408 \$18620 sg13g2_a21oi_1
* cell instance $1243 r0 *1 332.16,185.22
X$1243 VDD \$12560 VSS \$11209 \$11296 \$11788 sg13g2_a21oi_1
* cell instance $1244 r0 *1 151.68,124.74
X$1244 VDD \$7905 VSS \$7991 \$6673 \$7987 sg13g2_a21oi_1
* cell instance $1245 r0 *1 59.04,56.7
X$1245 VDD \$2606 VSS \$2311 \$2313 \$1390 sg13g2_a21oi_1
* cell instance $1246 r0 *1 211.68,200.34
X$1246 VDD \$13771 VSS \$13683 \$13684 \$13430 sg13g2_a21oi_1
* cell instance $1247 r0 *1 74.4,215.46
X$1247 VDD \$14991 VSS \$14691 \$14784 \$13866 sg13g2_a21oi_1
* cell instance $1248 r0 *1 232.8,71.82
X$1248 VDD \$3860 VSS \$3731 \$3730 \$2904 sg13g2_a21oi_1
* cell instance $1249 r0 *1 291.84,170.1
X$1249 VDD \$11509 VSS \$11281 \$11280 \$10405 sg13g2_a21oi_1
* cell instance $1250 r0 *1 349.44,162.54
X$1250 VDD \$11044 VSS \$11206 \$10902 \$9150 sg13g2_a21oi_1
* cell instance $1251 r0 *1 47.52,94.5
X$1251 VDD \$5356 VSS \$4984 \$5446 \$4988 sg13g2_a21oi_1
* cell instance $1252 r0 *1 260.16,64.26
X$1252 VDD \$3337 VSS \$3182 \$3180 \$3179 sg13g2_a21oi_1
* cell instance $1253 r0 *1 159.36,18.9
X$1253 VDD \$553 VSS \$277 \$462 \$76 sg13g2_a21oi_1
* cell instance $1254 r0 *1 215.04,245.7
X$1254 VDD \$18426 VSS \$14232 \$10831 \$17754 sg13g2_a21oi_1
* cell instance $1255 r0 *1 65.76,117.18
X$1255 VDD \$7324 VSS \$6891 \$5708 \$2789 sg13g2_a21oi_1
* cell instance $1256 r0 *1 167.52,49.14
X$1256 VDD \$2353 VSS \$2053 \$1089 \$2163 sg13g2_a21oi_1
* cell instance $1257 r0 *1 326.4,238.14
X$1257 VDD \$15712 VSS \$16645 \$15088 \$15714 sg13g2_a21oi_1
* cell instance $1258 r0 *1 36.96,253.26
X$1258 VDD \$18866 VSS \$14299 \$18619 \$18727 sg13g2_a21oi_1
* cell instance $1259 r0 *1 204.96,162.54
X$1259 VDD \$10773 VSS \$11007 \$10963 \$10876 sg13g2_a21oi_1
* cell instance $1260 r0 *1 297.6,139.86
X$1260 VDD \$9012 VSS \$8642 \$7832 \$6942 sg13g2_a21oi_1
* cell instance $1261 r0 *1 191.04,154.98
X$1261 VDD \$10167 VSS \$10301 \$10645 \$10300 sg13g2_a21oi_1
* cell instance $1262 r0 *1 271.2,215.46
X$1262 VDD \$14910 VSS \$15857 \$8033 \$14911 sg13g2_a21oi_1
* cell instance $1263 r0 *1 306.24,132.3
X$1263 VDD \$8658 VSS \$7230 \$8467 \$8143 sg13g2_a21oi_1
* cell instance $1264 r0 *1 251.52,283.5
X$1264 VDD \$20891 VSS \$20458 \$12452 \$21237 sg13g2_a21oi_1
* cell instance $1265 r0 *1 323.04,328.86
X$1265 VDD \$24103 VSS \$23563 \$24098 \$23842 sg13g2_a21oi_1
* cell instance $1266 r0 *1 248.64,306.18
X$1266 VDD \$22545 VSS \$21943 \$22137 \$22623 sg13g2_a21oi_1
* cell instance $1267 r0 *1 118.56,336.42
X$1267 VDD \$24384 VSS \$24664 \$23669 \$23445 sg13g2_a21oi_1
* cell instance $1268 r0 *1 275.52,321.3
X$1268 VDD \$23456 VSS \$22887 \$21079 \$23554 sg13g2_a21oi_1
* cell instance $1269 r0 *1 242.4,177.66
X$1269 VDD \$12262 VSS \$12358 \$12047 \$12046 sg13g2_a21oi_1
* cell instance $1270 r0 *1 78.72,253.26
X$1270 VDD \$17508 VSS \$18519 \$16127 \$18900 sg13g2_a21oi_1
* cell instance $1271 r0 *1 289.92,245.7
X$1271 VDD \$17906 VSS \$16336 \$12057 \$18085 sg13g2_a21oi_1
* cell instance $1272 r0 *1 103.2,192.78
X$1272 VDD \$13141 VSS \$13311 \$13306 \$13504 sg13g2_a21oi_1
* cell instance $1273 r0 *1 222.72,260.82
X$1273 VDD \$19339 VSS \$19601 \$19440 \$19747 sg13g2_a21oi_1
* cell instance $1274 r0 *1 239.04,321.3
X$1274 VDD \$23133 VSS \$20039 \$23454 \$19203 sg13g2_a21oi_1
* cell instance $1275 r0 *1 267.36,313.74
X$1275 VDD \$23151 VSS \$23020 \$22885 \$22712 sg13g2_a21oi_1
* cell instance $1276 r0 *1 238.08,177.66
X$1276 VDD \$13186 VSS \$11901 \$11501 \$11895 sg13g2_a21oi_1
* cell instance $1277 r0 *1 252.96,291.06
X$1277 VDD \$21846 VSS \$21321 \$21716 \$21663 sg13g2_a21oi_1
* cell instance $1278 r0 *1 240,170.1
X$1278 VDD \$11273 VSS \$11680 \$11274 \$11678 sg13g2_a21oi_1
* cell instance $1279 r0 *1 48,245.7
X$1279 VDD \$17780 VSS \$17513 \$17202 \$17406 sg13g2_a21oi_1
* cell instance $1280 r0 *1 140.16,306.18
X$1280 VDD \$22392 VSS \$22325 \$21507 \$21435 sg13g2_a21oi_1
* cell instance $1281 r0 *1 312.96,230.58
X$1281 VDD \$16178 VSS \$16435 \$15707 \$16161 sg13g2_a21oi_1
* cell instance $1282 r0 *1 202.56,26.46
X$1282 VDD \$956 VSS \$921 \$1001 \$337 sg13g2_a21oi_1
* cell instance $1283 r0 *1 273.6,291.06
X$1283 VDD \$21326 VSS \$20461 \$12452 \$21077 sg13g2_a21oi_1
* cell instance $1284 r0 *1 38.88,260.82
X$1284 VDD \$18725 VSS \$19164 \$19398 \$14984 sg13g2_a21oi_1
* cell instance $1285 r0 *1 280.32,328.86
X$1285 VDD \$24408 VSS \$22715 \$14666 \$24773 sg13g2_a21oi_1
* cell instance $1286 r0 *1 288,154.98
X$1286 VDD \$10245 VSS \$10314 \$10312 \$9964 sg13g2_a21oi_1
* cell instance $1287 r0 *1 176.16,18.9
X$1287 VDD \$279 VSS \$86 \$85 \$84 sg13g2_a21oi_1
* cell instance $1288 r0 *1 109.44,215.46
X$1288 VDD \$15010 VSS \$15012 \$15011 \$14650 sg13g2_a21oi_1
* cell instance $1289 r0 *1 189.6,162.54
X$1289 VDD \$10724 VSS \$11005 \$11004 \$10007 sg13g2_a21oi_1
* cell instance $1290 r0 *1 39.36,283.5
X$1290 VDD \$20992 VSS \$20912 \$20994 \$20911 sg13g2_a21oi_1
* cell instance $1291 r0 *1 264.48,253.26
X$1291 VDD \$18680 VSS \$16843 \$19020 \$18805 sg13g2_a21oi_1
* cell instance $1292 r0 *1 201.6,109.62
X$1292 VDD \$6713 VSS \$6788 \$6590 \$5391 sg13g2_a21oi_1
* cell instance $1293 r0 *1 258.72,162.54
X$1293 VDD \$10833 VSS \$10485 \$10884 \$8637 sg13g2_a21oi_1
* cell instance $1294 r0 *1 213.12,117.18
X$1294 VDD \$7606 VSS \$7366 \$7149 \$6705 sg13g2_a21oi_1
* cell instance $1295 r0 *1 37.92,71.82
X$1295 VDD \$3545 VSS \$3885 \$2408 \$3689 sg13g2_a21oi_1
* cell instance $1296 r0 *1 290.88,321.3
X$1296 VDD \$23838 VSS \$20942 \$12710 \$23556 sg13g2_a21oi_1
* cell instance $1297 r0 *1 25.44,102.06
X$1297 VDD \$6140 VSS \$6135 \$5812 \$4832 sg13g2_a21oi_1
* cell instance $1298 r0 *1 256.32,298.62
X$1298 VDD \$18646 VSS \$21944 \$22336 \$22340 sg13g2_a21oi_1
* cell instance $1299 r0 *1 141.12,260.82
X$1299 VDD \$19418 VSS \$19417 \$19177 \$19419 sg13g2_a21oi_1
* cell instance $1300 r0 *1 348.96,132.3
X$1300 VDD \$8671 VSS \$8672 \$4641 \$7424 sg13g2_a21oi_1
* cell instance $1301 r0 *1 119.04,79.38
X$1301 VDD \$4320 VSS \$3814 \$4296 \$4028 sg13g2_a21oi_1
* cell instance $1302 r0 *1 154.56,238.14
X$1302 VDD \$16288 VSS \$16798 \$16797 \$17329 sg13g2_a21oi_1
* cell instance $1303 r0 *1 51.84,207.9
X$1303 VDD \$12881 VSS \$14013 \$14306 \$14195 sg13g2_a21oi_1
* cell instance $1304 r0 *1 84.48,283.5
X$1304 VDD \$21019 VSS \$21021 \$20651 \$21020 sg13g2_a21oi_1
* cell instance $1305 r0 *1 222.72,94.5
X$1305 VDD \$5403 VSS \$5404 \$5171 \$4735 sg13g2_a21oi_1
* cell instance $1306 r0 *1 337.44,275.94
X$1306 VDD \$20269 VSS \$20466 \$20062 \$20252 sg13g2_a21oi_1
* cell instance $1307 r0 *1 140.64,321.3
X$1307 VDD \$23621 VSS \$23533 \$23675 \$23445 sg13g2_a21oi_1
* cell instance $1308 r0 *1 225.12,94.5
X$1308 VDD \$5572 VSS \$5027 \$3514 \$5406 sg13g2_a21oi_1
* cell instance $1309 r0 *1 243.84,94.5
X$1309 VDD \$6088 VSS \$5655 \$5176 \$3967 sg13g2_a21oi_1
* cell instance $1310 r0 *1 45.12,283.5
X$1310 VDD \$21000 VSS \$20913 \$20740 \$21117 sg13g2_a21oi_1
* cell instance $1311 r0 *1 298.56,207.9
X$1311 VDD \$14552 VSS \$13229 \$12452 \$13478 sg13g2_a21oi_1
* cell instance $1312 r0 *1 16.32,41.58
X$1312 VDD \$1835 VSS \$1387 \$1182 \$510 sg13g2_a21oi_1
* cell instance $1313 r0 *1 245.76,200.34
X$1313 VDD \$13591 VSS \$12691 \$12920 \$12921 sg13g2_a21oi_1
* cell instance $1314 r0 *1 17.76,185.22
X$1314 VDD \$12566 VSS \$12323 \$12282 \$10968 sg13g2_a21oi_1
* cell instance $1315 r0 *1 26.4,245.7
X$1315 VDD \$17403 VSS \$17153 \$16869 \$16983 sg13g2_a21oi_1
* cell instance $1316 r0 *1 27.36,230.58
X$1316 VDD \$16228 VSS \$15918 \$15761 \$16376 sg13g2_a21oi_1
* cell instance $1317 r0 *1 108.48,291.06
X$1317 VDD \$21826 VSS \$21385 \$21548 \$21547 sg13g2_a21oi_1
* cell instance $1318 r0 *1 113.28,291.06
X$1318 VDD \$21433 VSS \$21694 \$21623 \$21549 sg13g2_a21oi_1
* cell instance $1319 r0 *1 89.28,56.7
X$1319 VDD \$2665 VSS \$2043 \$2721 \$2724 sg13g2_a21oi_1
* cell instance $1320 r0 *1 325.92,336.42
X$1320 VDD \$24650 VSS \$23563 \$23717 \$23970 sg13g2_a21oi_1
* cell instance $1321 r0 *1 54.72,215.46
X$1321 VDD \$15124 VSS \$14988 \$14983 \$14877 sg13g2_a21oi_1
* cell instance $1322 r0 *1 247.2,177.66
X$1322 VDD \$11936 VSS \$11680 \$11274 \$11776 sg13g2_a21oi_1
* cell instance $1323 r0 *1 127.68,64.26
X$1323 VDD \$3602 VSS \$2984 \$2204 \$3160 sg13g2_a21oi_1
* cell instance $1324 r0 *1 298.56,283.5
X$1324 VDD \$20793 VSS \$20795 \$22418 \$20792 sg13g2_a21oi_1
* cell instance $1325 r0 *1 257.28,275.94
X$1325 VDD \$20433 VSS \$20458 \$12710 \$20242 sg13g2_a21oi_1
* cell instance $1326 r0 *1 44.64,268.38
X$1326 VDD \$19971 VSS \$19972 \$19892 \$18861 sg13g2_a21oi_1
* cell instance $1327 r0 *1 264.96,147.42
X$1327 VDD \$8237 VSS \$9653 \$9474 \$9752 sg13g2_a21oi_1
* cell instance $1328 r0 *1 192,132.3
X$1328 VDD \$8446 VSS \$8609 \$8444 \$7683 sg13g2_a21oi_1
* cell instance $1329 r0 *1 271.68,117.18
X$1329 VDD \$7402 VSS \$7579 \$7578 \$6981 sg13g2_a21oi_1
* cell instance $1330 r0 *1 26.88,162.54
X$1330 VDD \$10971 VSS \$10272 \$9780 \$9493 sg13g2_a21oi_1
* cell instance $1331 r0 *1 117.12,238.14
X$1331 VDD \$17023 VSS \$16883 \$17018 \$13794 sg13g2_a21oi_1
* cell instance $1332 r0 *1 305.28,336.42
X$1332 VDD \$24550 VSS \$24787 \$24621 \$24270 sg13g2_a21oi_1
* cell instance $1333 r0 *1 281.28,313.74
X$1333 VDD \$23266 VSS \$22715 \$13228 \$22889 sg13g2_a21oi_1
* cell instance $1334 r0 *1 200.16,185.22
X$1334 VDD \$12197 VSS \$10873 \$11487 \$10872 sg13g2_a21oi_1
* cell instance $1335 r0 *1 288.48,64.26
X$1335 VDD \$3342 VSS \$4180 \$3955 \$3392 sg13g2_a21oi_1
* cell instance $1336 r0 *1 323.04,223.02
X$1336 VDD \$15391 VSS \$15568 \$15086 \$14242 sg13g2_a21oi_1
* cell instance $1337 r0 *1 305.76,238.14
X$1337 VDD \$16810 VSS \$15701 \$17128 \$17124 sg13g2_a21oi_1
* cell instance $1338 r0 *1 119.52,230.58
X$1338 VDD \$13152 VSS \$16280 \$16273 \$16133 sg13g2_a21oi_1
* cell instance $1339 r0 *1 227.52,34.02
X$1339 VDD \$2077 VSS \$1323 \$1782 \$1270 sg13g2_a21oi_1
* cell instance $1340 r0 *1 271.2,200.34
X$1340 VDD \$13619 VSS \$12700 \$13224 \$12923 sg13g2_a21oi_1
* cell instance $1341 r0 *1 217.92,139.86
X$1341 VDD \$8901 VSS \$8450 \$8618 \$7925 sg13g2_a21oi_1
* cell instance $1342 r0 *1 48,306.18
X$1342 VDD \$22083 VSS \$22858 \$22556 \$21917 sg13g2_a21oi_1
* cell instance $1343 r0 *1 202.56,162.54
X$1343 VDD \$11009 VSS \$11007 \$10963 \$10872 sg13g2_a21oi_1
* cell instance $1344 r0 *1 65.76,306.18
X$1344 VDD \$22367 VSS \$22655 \$22091 \$22618 sg13g2_a21oi_1
* cell instance $1345 r0 *1 253.92,298.62
X$1345 VDD \$21565 VSS \$22021 \$22024 \$21070 sg13g2_a21oi_1
* cell instance $1346 m0 *1 326.4,124.74
X$1346 \$1203 VDD VSS sg13g2_antennanp
* cell instance $1347 m0 *1 127.2,102.06
X$1347 VSS \$4977 VDD \$5617 \$6162 \$5992 sg13g2_o21ai_1
* cell instance $1348 m0 *1 333.12,147.42
X$1348 VSS \$9513 VDD \$10195 \$9906 \$7205 sg13g2_o21ai_1
* cell instance $1349 m0 *1 264,260.82
X$1349 VSS \$19336 VDD \$19570 \$18769 \$19103 sg13g2_o21ai_1
* cell instance $1350 m0 *1 325.92,283.5
X$1350 VSS \$20800 VDD \$20367 \$20690 \$20687 sg13g2_o21ai_1
* cell instance $1351 m0 *1 83.52,192.78
X$1351 VSS \$11552 VDD \$12628 \$12887 \$12952 sg13g2_o21ai_1
* cell instance $1352 m0 *1 264.96,336.42
X$1352 VSS \$24615 VDD \$24260 \$24181 \$24258 sg13g2_o21ai_1
* cell instance $1353 m0 *1 182.88,34.02
X$1353 VSS \$970 VDD \$786 \$281 \$1168 sg13g2_o21ai_1
* cell instance $1354 m0 *1 103.2,215.46
X$1354 VSS \$14505 VDD \$13792 \$13660 \$13306 sg13g2_o21ai_1
* cell instance $1355 m0 *1 85.44,200.34
X$1355 VSS \$13724 VDD \$13297 \$13884 \$13660 sg13g2_o21ai_1
* cell instance $1356 m0 *1 45.6,56.7
X$1356 VSS \$2601 VDD \$2305 \$2306 \$2420 sg13g2_o21ai_1
* cell instance $1357 m0 *1 165.12,215.46
X$1357 VSS \$14566 VDD \$14360 \$13966 \$14655 sg13g2_o21ai_1
* cell instance $1358 m0 *1 127.2,64.26
X$1358 VSS \$1667 VDD \$2984 \$2891 \$2988 sg13g2_o21ai_1
* cell instance $1359 m0 *1 107.04,253.26
X$1359 VSS \$17803 VDD \$18275 \$18624 \$17802 sg13g2_o21ai_1
* cell instance $1360 m0 *1 229.92,215.46
X$1360 VSS \$12591 VDD \$14239 \$14776 \$14368 sg13g2_o21ai_1
* cell instance $1361 m0 *1 39.36,79.38
X$1361 VSS \$3476 VDD \$3885 \$3690 \$4088 sg13g2_o21ai_1
* cell instance $1362 m0 *1 168,215.46
X$1362 VSS \$14746 VDD \$14361 \$14362 \$14744 sg13g2_o21ai_1
* cell instance $1363 m0 *1 87.84,177.66
X$1363 VSS \$9800 VDD \$11757 \$11687 \$10976 sg13g2_o21ai_1
* cell instance $1364 m0 *1 131.52,154.98
X$1364 VSS \$7344 VDD \$10051 \$9806 \$10229 sg13g2_o21ai_1
* cell instance $1365 m0 *1 175.68,253.26
X$1365 VSS \$17333 VDD \$17845 \$17436 \$18090 sg13g2_o21ai_1
* cell instance $1366 m0 *1 49.44,94.5
X$1366 VSS \$3679 VDD \$4985 \$5357 \$5215 sg13g2_o21ai_1
* cell instance $1367 m0 *1 63.36,147.42
X$1367 VSS \$4286 VDD \$9449 \$9447 \$8476 sg13g2_o21ai_1
* cell instance $1368 m0 *1 251.04,291.06
X$1368 VSS \$21321 VDD \$21411 \$21565 \$21323 sg13g2_o21ai_1
* cell instance $1369 m0 *1 128.64,154.98
X$1369 VSS \$5619 VDD \$9794 \$9806 \$9262 sg13g2_o21ai_1
* cell instance $1370 m0 *1 255.36,321.3
X$1370 VSS \$22696 VDD \$23142 \$22882 \$23139 sg13g2_o21ai_1
* cell instance $1371 m0 *1 136.8,306.18
X$1371 VSS \$22496 VDD \$21434 \$22392 \$19732 sg13g2_o21ai_1
* cell instance $1372 m0 *1 223.68,313.74
X$1372 VSS \$22977 VDD \$23123 \$22856 \$21061 sg13g2_o21ai_1
* cell instance $1373 m0 *1 262.56,321.3
X$1373 VSS \$23454 VDD \$23142 \$23149 \$23139 sg13g2_o21ai_1
* cell instance $1374 m0 *1 134.4,306.18
X$1374 VSS \$21201 VDD \$22495 \$20414 \$22325 sg13g2_o21ai_1
* cell instance $1375 m0 *1 63.36,109.62
X$1375 VSS \$6576 VDD \$6891 \$6401 \$6743 sg13g2_o21ai_1
* cell instance $1376 m0 *1 226.08,185.22
X$1376 VSS \$12255 VDD \$12207 \$12539 \$10644 sg13g2_o21ai_1
* cell instance $1377 m0 *1 234.24,260.82
X$1377 VSS \$21061 VDD \$14170 \$19045 \$19019 sg13g2_o21ai_1
* cell instance $1378 m0 *1 146.4,253.26
X$1378 VSS \$18394 VDD \$14018 \$18558 \$17364 sg13g2_o21ai_1
* cell instance $1379 m0 *1 57.6,154.98
X$1379 VSS \$8957 VDD \$10040 \$9786 \$9322 sg13g2_o21ai_1
* cell instance $1380 m0 *1 259.68,343.98
X$1380 VSS \$24508 VDD \$23142 \$24407 \$23139 sg13g2_o21ai_1
* cell instance $1381 m0 *1 235.68,298.62
X$1381 VSS \$22021 VDD \$21770 \$21843 \$21842 sg13g2_o21ai_1
* cell instance $1382 m0 *1 77.28,207.9
X$1382 VSS \$14269 VDD \$13783 \$14017 \$13660 sg13g2_o21ai_1
* cell instance $1383 m0 *1 160.32,139.86
X$1383 VSS \$8121 VDD \$8601 \$9268 \$9267 sg13g2_o21ai_1
* cell instance $1384 m0 *1 46.08,132.3
X$1384 VSS \$8310 VDD \$7741 \$8253 \$7844 sg13g2_o21ai_1
* cell instance $1385 m0 *1 132,177.66
X$1385 VSS \$11584 VDD \$11692 \$11467 \$11466 sg13g2_o21ai_1
* cell instance $1386 m0 *1 54.24,200.34
X$1386 VSS \$11442 VDD \$12625 \$13125 \$13259 sg13g2_o21ai_1
* cell instance $1387 m0 *1 145.44,34.02
X$1387 VSS \$1122 VDD \$1439 \$912 \$81 sg13g2_o21ai_1
* cell instance $1388 m0 *1 124.32,41.58
X$1388 VSS \$1675 VDD \$1562 \$1428 \$973 sg13g2_o21ai_1
* cell instance $1389 m0 *1 348.96,124.74
X$1389 VSS \$7437 VDD \$7723 \$2767 \$2444 sg13g2_o21ai_1
* cell instance $1390 m0 *1 121.92,41.58
X$1390 VSS \$446 VDD \$1426 \$1428 \$1427 sg13g2_o21ai_1
* cell instance $1391 m0 *1 314.88,275.94
X$1391 VSS \$20364 VDD \$20583 \$20363 \$20059 sg13g2_o21ai_1
* cell instance $1392 m0 *1 317.28,306.18
X$1392 VSS \$22423 VDD \$22422 \$22474 \$22420 sg13g2_o21ai_1
* cell instance $1393 m0 *1 111.84,71.82
X$1393 VSS \$3595 VDD \$3404 \$3299 \$3498 sg13g2_o21ai_1
* cell instance $1394 m0 *1 126.24,139.86
X$1394 VSS \$7771 VDD \$8589 \$8887 \$8591 sg13g2_o21ai_1
* cell instance $1395 m0 *1 232.32,268.38
X$1395 VSS \$16119 VDD \$19865 \$19441 \$18469 sg13g2_o21ai_1
* cell instance $1396 m0 *1 118.56,18.9
X$1396 VSS \$154 VDD \$237 \$235 \$215 sg13g2_o21ai_1
* cell instance $1397 m0 *1 119.04,283.5
X$1397 VSS \$7997 VDD \$20232 \$18735 \$19986 sg13g2_o21ai_1
* cell instance $1398 m0 *1 316.8,117.18
X$1398 VSS \$8470 VDD \$7419 \$7069 \$7205 sg13g2_o21ai_1
* cell instance $1399 m0 *1 335.52,102.06
X$1399 VSS \$5683 VDD \$5886 \$6244 \$2444 sg13g2_o21ai_1
* cell instance $1400 m0 *1 79.2,109.62
X$1400 VSS \$6250 VDD \$5373 \$5370 \$6578 sg13g2_o21ai_1
* cell instance $1401 m0 *1 103.2,147.42
X$1401 VSS \$8950 VDD \$8567 \$9456 \$9539 sg13g2_o21ai_1
* cell instance $1402 m0 *1 273.12,154.98
X$1402 VSS \$10496 VDD \$9997 \$10063 \$9840 sg13g2_o21ai_1
* cell instance $1403 m0 *1 151.2,56.7
X$1403 VSS \$2613 VDD \$2343 \$2345 \$2510 sg13g2_o21ai_1
* cell instance $1404 m0 *1 272.16,170.1
X$1404 VSS \$10884 VDD \$11027 \$11276 \$11026 sg13g2_o21ai_1
* cell instance $1405 m0 *1 121.92,170.1
X$1405 VSS \$10386 VDD \$11360 \$11181 \$11183 sg13g2_o21ai_1
* cell instance $1406 m0 *1 65.76,238.14
X$1406 VSS \$16247 VDD \$5675 \$16244 \$16127 sg13g2_o21ai_1
* cell instance $1407 m0 *1 232.32,215.46
X$1407 VSS \$14814 VDD \$15051 \$12247 \$14224 sg13g2_o21ai_1
* cell instance $1408 m0 *1 108.48,109.62
X$1408 VSS \$5464 VDD \$6513 \$6581 \$6512 sg13g2_o21ai_1
* cell instance $1409 m0 *1 43.68,132.3
X$1409 VSS \$4759 VDD \$7944 \$8253 \$8083 sg13g2_o21ai_1
* cell instance $1410 m0 *1 106.08,102.06
X$1410 VSS \$5969 VDD \$5495 \$4997 \$5973 sg13g2_o21ai_1
* cell instance $1411 m0 *1 48,162.54
X$1411 VSS \$10439 VDD \$10273 \$9786 \$9322 sg13g2_o21ai_1
* cell instance $1412 m0 *1 115.68,132.3
X$1412 VSS \$5504 VDD \$7341 \$7682 \$8349 sg13g2_o21ai_1
* cell instance $1413 m0 *1 175.2,26.46
X$1413 VSS \$709 VDD \$389 \$784 \$863 sg13g2_o21ai_1
* cell instance $1414 m0 *1 97.92,170.1
X$1414 VSS \$11092 VDD \$11340 \$11458 \$10977 sg13g2_o21ai_1
* cell instance $1415 m0 *1 196.32,170.1
X$1415 VSS \$11229 VDD \$11009 \$11007 \$10963 sg13g2_o21ai_1
* cell instance $1416 m0 *1 123.36,207.9
X$1416 VSS \$14121 VDD \$13796 \$13165 \$13664 sg13g2_o21ai_1
* cell instance $1417 m0 *1 25.44,124.74
X$1417 VSS \$7308 VDD \$7662 \$7311 \$7848 sg13g2_o21ai_1
* cell instance $1418 m0 *1 245.76,298.62
X$1418 VSS \$21943 VDD \$21672 \$21846 \$21942 sg13g2_o21ai_1
* cell instance $1419 m0 *1 210.24,230.58
X$1419 VSS \$17065 VDD \$13179 \$15669 \$16963 sg13g2_o21ai_1
* cell instance $1420 m0 *1 189.6,102.06
X$1420 VSS \$5629 VDD \$5552 \$5633 \$4922 sg13g2_o21ai_1
* cell instance $1421 m0 *1 103.2,177.66
X$1421 VSS \$9792 VDD \$11843 \$11458 \$11737 sg13g2_o21ai_1
* cell instance $1422 m0 *1 44.64,117.18
X$1422 VSS \$7025 VDD \$6737 \$7024 \$7158 sg13g2_o21ai_1
* cell instance $1423 m0 *1 143.52,71.82
X$1423 VSS \$3501 VDD \$3164 \$2737 \$3465 sg13g2_o21ai_1
* cell instance $1424 m0 *1 319.68,253.26
X$1424 VSS \$18340 VDD \$17477 \$17521 \$15713 sg13g2_o21ai_1
* cell instance $1425 m0 *1 77.76,291.06
X$1425 VSS \$21303 VDD \$20916 \$20747 \$21019 sg13g2_o21ai_1
* cell instance $1426 m0 *1 108.96,223.02
X$1426 VSS \$15447 VDD \$15190 \$15171 \$13660 sg13g2_o21ai_1
* cell instance $1427 m0 *1 207.36,283.5
X$1427 VSS \$20634 VDD \$21275 \$20006 \$19915 sg13g2_o21ai_1
* cell instance $1428 m0 *1 324.96,260.82
X$1428 VSS \$18653 VDD \$19124 \$15713 \$17697 sg13g2_o21ai_1
* cell instance $1429 m0 *1 300.48,102.06
X$1429 VSS \$5677 VDD \$5675 \$5188 \$5721 sg13g2_o21ai_1
* cell instance $1430 m0 *1 328.32,268.38
X$1430 VSS \$17701 VDD \$12695 \$19689 \$19763 sg13g2_o21ai_1
* cell instance $1431 m0 *1 220.32,351.54
X$1431 VSS \$25020 VDD \$25264 \$23692 \$24541 sg13g2_o21ai_1
* cell instance $1432 m0 *1 48,139.86
X$1432 VSS \$8427 VDD \$8873 \$8087 \$7431 sg13g2_o21ai_1
* cell instance $1433 m0 *1 119.52,139.86
X$1433 VSS \$8129 VDD \$8884 \$8580 \$8586 sg13g2_o21ai_1
* cell instance $1434 m0 *1 325.92,162.54
X$1434 VSS \$10349 VDD \$8666 \$10795 \$7205 sg13g2_o21ai_1
* cell instance $1435 m0 *1 106.08,41.58
X$1435 VSS \$909 VDD \$975 \$1418 \$1417 sg13g2_o21ai_1
* cell instance $1436 m0 *1 79.68,260.82
X$1436 VSS \$17003 VDD \$19174 \$19175 \$19173 sg13g2_o21ai_1
* cell instance $1437 m0 *1 178.56,207.9
X$1437 VSS \$14215 VDD \$14047 \$13175 \$13817 sg13g2_o21ai_1
* cell instance $1438 m0 *1 81.12,238.14
X$1438 VSS \$16253 VDD \$16424 \$16439 \$13660 sg13g2_o21ai_1
* cell instance $1439 m0 *1 107.04,139.86
X$1439 VSS \$7938 VDD \$6157 \$8571 \$8756 sg13g2_o21ai_1
* cell instance $1440 m0 *1 166.56,207.9
X$1440 VSS \$14361 VDD \$14360 \$13812 \$14210 sg13g2_o21ai_1
* cell instance $1441 m0 *1 65.28,283.5
X$1441 VSS \$20914 VDD \$20578 \$20746 \$20345 sg13g2_o21ai_1
* cell instance $1442 m0 *1 23.04,79.38
X$1442 VSS \$2036 VDD \$3684 \$3195 \$3687 sg13g2_o21ai_1
* cell instance $1443 m0 *1 223.2,336.42
X$1443 VSS \$24397 VDD \$24248 \$23695 \$24541 sg13g2_o21ai_1
* cell instance $1444 m0 *1 232.8,192.78
X$1444 VSS \$13102 VDD \$13029 \$12603 \$12677 sg13g2_o21ai_1
* cell instance $1445 m0 *1 320.16,328.86
X$1445 VSS \$23721 VDD \$23563 \$23175 \$22758 sg13g2_o21ai_1
* cell instance $1446 m0 *1 260.16,321.3
X$1446 VSS \$22879 VDD \$23142 \$23145 \$23139 sg13g2_o21ai_1
* cell instance $1447 m0 *1 157.92,230.58
X$1447 VSS \$15480 VDD \$16067 \$16515 \$15942 sg13g2_o21ai_1
* cell instance $1448 m0 *1 78.24,306.18
X$1448 VSS \$22096 VDD \$22382 \$22383 \$22320 sg13g2_o21ai_1
* cell instance $1449 m0 *1 156.48,102.06
X$1449 VSS \$6017 VDD \$5838 \$5165 \$4157 sg13g2_o21ai_1
* cell instance $1450 m0 *1 235.2,192.78
X$1450 VSS \$13103 VDD \$13032 \$12357 \$12677 sg13g2_o21ai_1
* cell instance $1451 m0 *1 35.04,94.5
X$1451 VSS \$2304 VDD \$4980 \$4761 \$5134 sg13g2_o21ai_1
* cell instance $1452 m0 *1 72.48,94.5
X$1452 VSS \$2318 VDD \$5366 \$4768 \$4766 sg13g2_o21ai_1
* cell instance $1453 m0 *1 329.76,291.06
X$1453 VSS \$21125 VDD \$21357 \$21333 \$21101 sg13g2_o21ai_1
* cell instance $1454 m0 *1 96.48,275.94
X$1454 VSS \$19222 VDD \$20584 \$20228 \$19979 sg13g2_o21ai_1
* cell instance $1455 m0 *1 156.96,207.9
X$1455 VSS \$14040 VDD \$14149 \$13810 \$13962 sg13g2_o21ai_1
* cell instance $1456 m0 *1 295.68,238.14
X$1456 VSS \$16044 VDD \$15700 \$15077 \$15705 sg13g2_o21ai_1
* cell instance $1457 m0 *1 329.28,245.7
X$1457 VSS \$17487 VDD \$17137 \$17162 \$15713 sg13g2_o21ai_1
* cell instance $1458 m0 *1 183.84,207.9
X$1458 VSS \$14173 VDD \$13818 \$13969 \$14217 sg13g2_o21ai_1
* cell instance $1459 m0 *1 257.76,321.3
X$1459 VSS \$23018 VDD \$23142 \$22883 \$23139 sg13g2_o21ai_1
* cell instance $1460 m0 *1 324.96,177.66
X$1460 VSS \$9309 VDD \$11297 \$8674 \$8925 sg13g2_o21ai_1
* cell instance $1461 m0 *1 198.72,71.82
X$1461 VSS \$3321 VDD \$3324 \$3322 \$3646 sg13g2_o21ai_1
* cell instance $1462 m0 *1 48,102.06
X$1462 VSS \$5817 VDD \$5814 \$5357 \$3277 sg13g2_o21ai_1
* cell instance $1463 m0 *1 314.4,170.1
X$1463 VSS \$11285 VDD \$11288 \$11370 \$9157 sg13g2_o21ai_1
* cell instance $1464 m0 *1 313.44,177.66
X$1464 VSS \$11871 VDD \$11781 \$10668 \$11714 sg13g2_o21ai_1
* cell instance $1465 m0 *1 185.28,124.74
X$1465 VSS \$1263 VDD \$7356 \$7353 \$7689 sg13g2_o21ai_1
* cell instance $1466 m0 *1 104.64,139.86
X$1466 VSS \$7975 VDD \$8969 \$8571 \$6287 sg13g2_o21ai_1
* cell instance $1467 m0 *1 256.32,336.42
X$1467 VSS \$24081 VDD \$23142 \$24319 \$23139 sg13g2_o21ai_1
* cell instance $1468 m0 *1 302.88,253.26
X$1468 VSS \$17911 VDD \$18664 \$17697 \$17718 sg13g2_o21ai_1
* cell instance $1469 m0 *1 86.88,86.94
X$1469 VSS \$4277 VDD \$3894 \$4281 \$4665 sg13g2_o21ai_1
* cell instance $1470 m0 *1 79.2,124.74
X$1470 VSS \$5390 VDD \$6756 \$7673 \$6761 sg13g2_o21ai_1
* cell instance $1471 m0 *1 107.04,268.38
X$1471 VSS \$20285 VDD \$18735 \$19981 \$19651 sg13g2_o21ai_1
* cell instance $1472 m0 *1 271.68,192.78
X$1472 VSS \$12923 VDD \$11892 \$12700 \$13224 sg13g2_o21ai_1
* cell instance $1473 m0 *1 233.76,102.06
X$1473 VSS \$5346 VDD \$5653 \$5410 \$4624 sg13g2_o21ai_1
* cell instance $1474 m0 *1 134.88,185.22
X$1474 VSS \$10641 VDD \$11463 \$11467 \$11088 sg13g2_o21ai_1
* cell instance $1475 m0 *1 240.48,207.9
X$1475 VSS \$13194 VDD \$14170 \$13832 \$13192 sg13g2_o21ai_1
* cell instance $1476 m0 *1 248.64,192.78
X$1476 VSS \$13451 VDD \$11892 \$13199 \$12918 sg13g2_o21ai_1
* cell instance $1477 m0 *1 103.2,86.94
X$1477 VSS \$4996 VDD \$4292 \$3895 \$2723 sg13g2_o21ai_1
* cell instance $1478 m0 *1 189.6,298.62
X$1478 VSS \$21706 VDD \$22127 \$20664 \$21705 sg13g2_o21ai_1
* cell instance $1479 m0 *1 242.88,313.74
X$1479 VSS \$22995 VDD \$22699 \$16806 \$20456 sg13g2_o21ai_1
* cell instance $1480 m0 *1 48,109.62
X$1480 VSS \$1181 VDD \$6573 \$6145 \$6242 sg13g2_o21ai_1
* cell instance $1481 m0 *1 109.44,185.22
X$1481 VSS \$12149 VDD \$11759 \$12335 \$11562 sg13g2_o21ai_1
* cell instance $1482 m0 *1 272.16,230.58
X$1482 VSS \$16198 VDD \$16540 \$16334 \$16161 sg13g2_o21ai_1
* cell instance $1483 m0 *1 292.8,230.58
X$1483 VSS \$16059 VDD \$15816 \$15077 \$15704 sg13g2_o21ai_1
* cell instance $1484 m0 *1 45.6,230.58
X$1484 VSS \$15762 VDD \$15753 \$15630 \$15760 sg13g2_o21ai_1
* cell instance $1485 m0 *1 310.56,162.54
X$1485 VSS \$6843 VDD \$11035 \$10667 \$2444 sg13g2_o21ai_1
* cell instance $1486 m0 *1 48,230.58
X$1486 VSS \$15630 VDD \$16006 \$15632 \$15631 sg13g2_o21ai_1
* cell instance $1487 m0 *1 82.56,230.58
X$1487 VSS \$15928 VDD \$16023 \$15772 \$15927 sg13g2_o21ai_1
* cell instance $1488 m0 *1 112.8,200.34
X$1488 VSS \$13515 VDD \$13151 \$13337 \$12973 sg13g2_o21ai_1
* cell instance $1489 m0 *1 303.84,162.54
X$1489 VSS \$10311 VDD \$11612 \$10710 \$11034 sg13g2_o21ai_1
* cell instance $1490 m0 *1 66.72,207.9
X$1490 VSS \$14013 VDD \$14312 \$14014 \$14012 sg13g2_o21ai_1
* cell instance $1491 m0 *1 330.72,71.82
X$1491 VSS \$3529 VDD \$3346 \$3362 \$2444 sg13g2_o21ai_1
* cell instance $1492 m0 *1 122.4,313.74
X$1492 VSS \$22812 VDD \$21623 \$22496 \$21694 sg13g2_o21ai_1
* cell instance $1493 m0 *1 41.28,170.1
X$1493 VSS \$10974 VDD \$11168 \$10973 \$9609 sg13g2_o21ai_1
* cell instance $1494 m0 *1 208.32,162.54
X$1494 VSS \$10738 VDD \$10736 \$10474 \$10733 sg13g2_o21ai_1
* cell instance $1495 m0 *1 118.08,275.94
X$1495 VSS \$20232 VDD \$19222 \$20515 \$18790 sg13g2_o21ai_1
* cell instance $1496 m0 *1 172.8,215.46
X$1496 VSS \$14214 VDD \$15036 \$11395 \$14896 sg13g2_o21ai_1
* cell instance $1497 m0 *1 106.56,238.14
X$1497 VSS \$16700 VDD \$16624 \$16449 \$13660 sg13g2_o21ai_1
* cell instance $1498 m0 *1 322.56,49.14
X$1498 VSS \$2096 VDD \$2118 \$2442 \$2444 sg13g2_o21ai_1
* cell instance $1499 m0 *1 164.64,79.38
X$1499 VSS \$3807 VDD \$3987 \$4041 \$3117 sg13g2_o21ai_1
* cell instance $1500 m0 *1 280.32,306.18
X$1500 VSS \$22508 VDD \$22356 \$20461 \$22222 sg13g2_o21ai_1
* cell instance $1501 m0 *1 180.48,34.02
X$1501 VSS \$1157 VDD \$758 \$281 \$30 sg13g2_o21ai_1
* cell instance $1502 m0 *1 162.24,79.38
X$1502 VSS \$3496 VDD \$3719 \$4040 \$3607 sg13g2_o21ai_1
* cell instance $1503 m0 *1 142.08,109.62
X$1503 VSS \$5805 VDD \$6776 \$6418 \$6689 sg13g2_o21ai_1
* cell instance $1504 m0 *1 178.56,223.02
X$1504 VSS \$14585 VDD \$14371 \$11868 \$15040 sg13g2_o21ai_1
* cell instance $1505 m0 *1 226.08,313.74
X$1505 VSS \$22875 VDD \$23126 \$23133 \$21061 sg13g2_o21ai_1
* cell instance $1506 m0 *1 77.76,79.38
X$1506 VSS \$4022 VDD \$3892 \$4021 \$4117 sg13g2_o21ai_1
* cell instance $1507 m0 *1 303.36,328.86
X$1507 VSS \$23713 VDD \$21082 \$23709 \$19020 sg13g2_o21ai_1
* cell instance $1508 m0 *1 15.36,102.06
X$1508 VSS \$4598 VDD \$5600 \$5350 \$5900 sg13g2_o21ai_1
* cell instance $1509 m0 *1 260.64,313.74
X$1509 VSS \$22884 VDD \$22824 \$22706 \$22141 sg13g2_o21ai_1
* cell instance $1510 m0 *1 141.12,230.58
X$1510 VSS \$16050 VDD \$16283 \$15552 \$15648 sg13g2_o21ai_1
* cell instance $1511 m0 *1 226.56,86.94
X$1511 VSS \$4588 VDD \$4756 \$5027 \$3514 sg13g2_o21ai_1
* cell instance $1512 m0 *1 169.92,200.34
X$1512 VSS \$12905 VDD \$12614 \$12656 \$12890 sg13g2_o21ai_1
* cell instance $1513 m0 *1 276,298.62
X$1513 VSS \$21877 VDD \$21875 \$20461 \$21452 sg13g2_o21ai_1
* cell instance $1514 m0 *1 331.68,238.14
X$1514 VSS \$16392 VDD \$16820 \$15988 \$15713 sg13g2_o21ai_1
* cell instance $1515 m0 *1 91.2,298.62
X$1515 VSS \$20916 VDD \$21880 \$21924 \$21691 sg13g2_o21ai_1
* cell instance $1516 m0 *1 311.04,185.22
X$1516 VSS \$12380 VDD \$12374 \$11780 \$12061 sg13g2_o21ai_1
* cell instance $1517 m0 *1 309.12,351.54
X$1517 VSS \$24873 VDD \$23952 \$24872 \$23977 sg13g2_o21ai_1
* cell instance $1518 m0 *1 87.84,200.34
X$1518 VSS \$13460 VDD \$13497 \$13141 \$13954 sg13g2_o21ai_1
* cell instance $1519 m0 *1 25.44,170.1
X$1519 VSS \$8412 VDD \$10970 \$11163 \$11159 sg13g2_o21ai_1
* cell instance $1520 m0 *1 228,192.78
X$1520 VSS \$13559 VDD \$12914 \$12354 \$12677 sg13g2_o21ai_1
* cell instance $1521 m0 *1 153.6,56.7
X$1521 VSS \$2740 VDD \$2353 \$2345 \$1186 sg13g2_o21ai_1
* cell instance $1522 m0 *1 312,200.34
X$1522 VSS \$13502 VDD \$13235 \$12059 \$12177 sg13g2_o21ai_1
* cell instance $1523 m0 *1 324.48,238.14
X$1523 VSS \$16166 VDD \$16688 \$16400 \$15713 sg13g2_o21ai_1
* cell instance $1524 m0 *1 147.84,79.38
X$1524 VSS \$2678 VDD \$4035 \$3713 \$4184 sg13g2_o21ai_1
* cell instance $1525 m0 *1 73.44,49.14
X$1525 VSS \$764 VDD \$2043 \$2042 \$2607 sg13g2_o21ai_1
* cell instance $1526 m0 *1 198.24,49.14
X$1526 VSS \$2563 VDD \$1897 \$2069 \$1898 sg13g2_o21ai_1
* cell instance $1527 m0 *1 300.48,253.26
X$1527 VSS \$18510 VDD \$15078 \$16430 \$17697 sg13g2_o21ai_1
* cell instance $1528 m0 *1 72.96,117.18
X$1528 VSS \$6740 VDD \$5367 \$6750 \$7076 sg13g2_o21ai_1
* cell instance $1529 r0 *1 30.24,147.42
X$1529 VSS \$9442 VDD \$9245 \$9440 \$9615 sg13g2_o21ai_1
* cell instance $1530 r0 *1 137.28,18.9
X$1530 VSS \$74 VDD \$459 \$384 \$275 sg13g2_o21ai_1
* cell instance $1531 m0 *1 138.72,26.46
X$1531 \$40 \$984 \$384 VDD VSS sg13g2_or2_1
* cell instance $1532 r0 *1 118.08,291.06
X$1532 VSS \$20751 VDD \$21548 \$21435 \$21312 sg13g2_o21ai_1
* cell instance $1533 r0 *1 171.36,49.14
X$1533 VSS \$2356 VDD \$2058 \$1877 \$2355 sg13g2_o21ai_1
* cell instance $1534 r0 *1 118.08,49.14
X$1534 VSS \$1292 VDD \$2132 \$2208 \$2477 sg13g2_o21ai_1
* cell instance $1535 r0 *1 165.12,49.14
X$1535 VSS \$2223 VDD \$2053 \$2160 \$2052 sg13g2_o21ai_1
* cell instance $1536 r0 *1 27.84,41.58
X$1536 VSS \$762 VDD \$1391 \$1754 \$1840 sg13g2_o21ai_1
* cell instance $1537 r0 *1 116.16,86.94
X$1537 VSS \$4305 VDD \$4999 \$5002 \$4284 sg13g2_o21ai_1
* cell instance $1538 r0 *1 141.6,238.14
X$1538 VSS \$17036 VDD \$17034 \$16792 \$15647 sg13g2_o21ai_1
* cell instance $1539 r0 *1 112.8,71.82
X$1539 VSS \$3286 VDD \$3814 \$3816 \$4149 sg13g2_o21ai_1
* cell instance $1540 r0 *1 77.28,223.02
X$1540 VSS \$15591 VDD \$15333 \$15776 \$13660 sg13g2_o21ai_1
* cell instance $1541 r0 *1 132.96,223.02
X$1541 VSS \$15620 VDD \$15351 \$16220 \$15647 sg13g2_o21ai_1
* cell instance $1542 r0 *1 234.24,207.9
X$1542 VSS \$14225 VDD \$14165 \$12679 \$14224 sg13g2_o21ai_1
* cell instance $1543 r0 *1 227.52,223.02
X$1543 VSS \$15555 VDD \$15365 \$12674 \$14224 sg13g2_o21ai_1
* cell instance $1544 r0 *1 155.52,162.54
X$1544 VSS \$10102 VDD \$9815 \$10716 \$10998 sg13g2_o21ai_1
* cell instance $1545 r0 *1 302.4,275.94
X$1545 VSS \$20360 VDD \$20481 \$20363 \$20054 sg13g2_o21ai_1
* cell instance $1546 r0 *1 273.12,328.86
X$1546 VSS \$24265 VDD \$16764 \$24092 \$24263 sg13g2_o21ai_1
* cell instance $1547 r0 *1 162.72,49.14
X$1547 VSS \$2524 VDD \$2291 \$2160 \$1089 sg13g2_o21ai_1
* cell instance $1548 r0 *1 267.84,185.22
X$1548 VSS \$12545 VDD \$11892 \$12311 \$12310 sg13g2_o21ai_1
* cell instance $1549 r0 *1 80.64,109.62
X$1549 VSS \$6753 VDD \$6915 \$6750 \$5142 sg13g2_o21ai_1
* cell instance $1550 r0 *1 78.24,207.9
X$1550 VSS \$14317 VDD \$14018 \$13300 \$13720 sg13g2_o21ai_1
* cell instance $1551 r0 *1 161.76,245.7
X$1551 VSS \$18079 VDD \$17586 \$17659 \$17665 sg13g2_o21ai_1
* cell instance $1552 r0 *1 116.16,268.38
X$1552 VSS \$19726 VDD \$19953 \$19723 \$18742 sg13g2_o21ai_1
* cell instance $1553 r0 *1 226.08,245.7
X$1553 VSS \$17077 VDD \$18172 \$16105 \$17846 sg13g2_o21ai_1
* cell instance $1554 r0 *1 219.36,41.58
X$1554 VSS \$959 VDD \$1904 \$2074 \$1204 sg13g2_o21ai_1
* cell instance $1555 r0 *1 175.2,154.98
X$1555 VSS \$10644 VDD \$10622 \$10617 \$10467 sg13g2_o21ai_1
* cell instance $1556 r0 *1 178.56,268.38
X$1556 VSS \$19665 VDD \$19913 \$18769 \$19423 sg13g2_o21ai_1
* cell instance $1557 r0 *1 36.48,260.82
X$1557 VSS \$16992 VDD \$19395 \$19711 \$19396 sg13g2_o21ai_1
* cell instance $1558 r0 *1 173.76,18.9
X$1558 VSS \$328 VDD \$90 \$211 \$732 sg13g2_o21ai_1
* cell instance $1559 r0 *1 229.92,313.74
X$1559 VSS \$23324 VDD \$23128 \$22989 \$21061 sg13g2_o21ai_1
* cell instance $1560 r0 *1 87.84,238.14
X$1560 VSS \$15637 VDD \$16023 \$14998 \$15334 sg13g2_o21ai_1
* cell instance $1561 r0 *1 147.84,192.78
X$1561 VSS \$14549 VDD \$12898 \$11697 \$12818 sg13g2_o21ai_1
* cell instance $1562 r0 *1 48,124.74
X$1562 VSS \$1662 VDD \$8416 \$8087 \$7947 sg13g2_o21ai_1
* cell instance $1563 r0 *1 227.52,313.74
X$1563 VSS \$23053 VDD \$23312 \$23047 \$21061 sg13g2_o21ai_1
* cell instance $1564 r0 *1 75.84,207.9
X$1564 VSS \$14318 VDD \$14317 \$13141 \$13954 sg13g2_o21ai_1
* cell instance $1565 r0 *1 161.76,56.7
X$1565 VSS \$2849 VDD \$1857 \$3168 \$1866 sg13g2_o21ai_1
* cell instance $1566 r0 *1 166.56,79.38
X$1566 VSS \$4549 VDD \$4194 \$4040 \$4332 sg13g2_o21ai_1
* cell instance $1567 r0 *1 169.44,79.38
X$1567 VSS \$2953 VDD \$3718 \$4041 \$4553 sg13g2_o21ai_1
* cell instance $1568 r0 *1 293.76,230.58
X$1568 VSS \$16188 VDD \$16189 \$15077 \$16347 sg13g2_o21ai_1
* cell instance $1569 r0 *1 249.6,177.66
X$1569 VSS \$11678 VDD \$11892 \$11680 \$11274 sg13g2_o21ai_1
* cell instance $1570 r0 *1 146.88,18.9
X$1570 VSS \$204 VDD \$385 \$912 \$699 sg13g2_o21ai_1
* cell instance $1571 r0 *1 198.24,283.5
X$1571 VSS \$20767 VDD \$21263 \$20664 \$20014 sg13g2_o21ai_1
* cell instance $1572 r0 *1 331.68,192.78
X$1572 VSS \$13273 VDD \$12933 \$13072 \$13241 sg13g2_o21ai_1
* cell instance $1573 r0 *1 26.4,223.02
X$1573 VSS \$15628 VDD \$15725 \$15627 \$15540 sg13g2_o21ai_1
* cell instance $1574 r0 *1 239.52,328.86
X$1574 VSS \$24507 VDD \$23930 \$24209 \$21061 sg13g2_o21ai_1
* cell instance $1575 r0 *1 140.16,49.14
X$1575 VSS \$2497 VDD \$1254 \$2048 \$1078 sg13g2_o21ai_1
* cell instance $1576 r0 *1 183.36,102.06
X$1576 VSS \$5841 VDD \$6188 \$5633 \$6187 sg13g2_o21ai_1
* cell instance $1577 r0 *1 231.36,245.7
X$1577 VSS \$17078 VDD \$18207 \$15524 \$17650 sg13g2_o21ai_1
* cell instance $1578 r0 *1 149.28,56.7
X$1578 VSS \$1192 VDD \$3904 \$2361 \$1869 sg13g2_o21ai_1
* cell instance $1579 r0 *1 110.4,71.82
X$1579 VSS \$3152 VDD \$4299 \$3895 \$4295 sg13g2_o21ai_1
* cell instance $1580 r0 *1 111.36,177.66
X$1580 VSS \$8777 VDD \$12152 \$12335 \$11562 sg13g2_o21ai_1
* cell instance $1581 r0 *1 135.84,49.14
X$1581 VSS \$2731 VDD \$1743 \$2048 \$2494 sg13g2_o21ai_1
* cell instance $1582 r0 *1 348.96,102.06
X$1582 VSS \$6222 VDD \$6224 \$6221 \$2444 sg13g2_o21ai_1
* cell instance $1583 r0 *1 295.2,223.02
X$1583 VSS \$15583 VDD \$15384 \$15077 \$15701 sg13g2_o21ai_1
* cell instance $1584 r0 *1 156.96,238.14
X$1584 VSS \$16795 VDD \$16901 \$16798 \$16797 sg13g2_o21ai_1
* cell instance $1585 r0 *1 122.88,79.38
X$1585 VSS \$4161 VDD \$4033 \$4003 \$4030 sg13g2_o21ai_1
* cell instance $1586 r0 *1 125.28,79.38
X$1586 VSS \$4032 VDD \$4313 \$4003 \$2945 sg13g2_o21ai_1
* cell instance $1587 r0 *1 276.48,336.42
X$1587 VSS \$24258 VDD \$24265 \$24262 \$24791 sg13g2_o21ai_1
* cell instance $1588 r0 *1 322.08,94.5
X$1588 VSS \$5194 VDD \$5451 \$5443 \$5891 sg13g2_o21ai_1
* cell instance $1589 r0 *1 255.36,245.7
X$1589 VSS \$18224 VDD \$14401 \$17087 \$18473 sg13g2_o21ai_1
* cell instance $1590 r0 *1 121.92,18.9
X$1590 VSS \$429 VDD \$677 \$235 \$77 sg13g2_o21ai_1
* cell instance $1591 r0 *1 143.52,86.94
X$1591 VSS \$222 VDD \$4789 \$4790 \$4926 sg13g2_o21ai_1
* cell instance $1592 r0 *1 315.84,215.46
X$1592 VSS \$14427 VDD \$14255 \$14826 \$14422 sg13g2_o21ai_1
* cell instance $1593 r0 *1 148.32,64.26
X$1593 VSS \$2051 VDD \$3614 \$3310 \$3308 sg13g2_o21ai_1
* cell instance $1594 r0 *1 144.96,154.98
X$1594 VSS \$9457 VDD \$10052 \$10161 \$10393 sg13g2_o21ai_1
* cell instance $1595 r0 *1 185.76,102.06
X$1595 VSS \$1994 VDD \$6190 \$6191 \$6189 sg13g2_o21ai_1
* cell instance $1596 r0 *1 328.8,147.42
X$1596 VSS \$9147 VDD \$9666 \$9716 \$7205 sg13g2_o21ai_1
* cell instance $1597 r0 *1 153.6,71.82
X$1597 VSS \$4614 VDD \$3311 \$3310 \$3847 sg13g2_o21ai_1
* cell instance $1598 r0 *1 140.64,34.02
X$1598 VSS \$1184 VDD \$985 \$1311 \$1580 sg13g2_o21ai_1
* cell instance $1599 r0 *1 85.44,238.14
X$1599 VSS \$16618 VDD \$17220 \$16255 \$16254 sg13g2_o21ai_1
* cell instance $1600 r0 *1 87.36,71.82
X$1600 VSS \$3023 VDD \$3701 \$3700 \$3422 sg13g2_o21ai_1
* cell instance $1601 r0 *1 180.96,328.86
X$1601 VSS \$23920 VDD \$24063 \$23827 \$24242 sg13g2_o21ai_1
* cell instance $1602 r0 *1 267.36,147.42
X$1602 VSS \$9752 VDD \$5675 \$9653 \$9474 sg13g2_o21ai_1
* cell instance $1603 r0 *1 64.8,313.74
X$1603 VSS \$22091 VDD \$23239 \$22863 \$22862 sg13g2_o21ai_1
* cell instance $1604 r0 *1 316.8,321.3
X$1604 VSS \$23172 VDD \$23351 \$23736 \$23394 sg13g2_o21ai_1
* cell instance $1605 r0 *1 313.92,283.5
X$1605 VSS \$21092 VDD \$20830 \$20795 \$20798 sg13g2_o21ai_1
* cell instance $1606 r0 *1 189.6,49.14
X$1606 VSS \$1875 VDD \$2230 \$2361 \$2229 sg13g2_o21ai_1
* cell instance $1607 r0 *1 66.24,34.02
X$1607 VSS \$1294 VDD \$1518 \$1404 \$1669 sg13g2_o21ai_1
* cell instance $1608 r0 *1 175.68,207.9
X$1608 VSS \$14581 VDD \$14213 \$12638 \$14217 sg13g2_o21ai_1
* cell instance $1609 r0 *1 305.76,154.98
X$1609 VSS \$9169 VDD \$9300 \$10325 \$2444 sg13g2_o21ai_1
* cell instance $1610 r0 *1 48,260.82
X$1610 VSS \$19167 VDD \$5675 \$17202 \$16231 sg13g2_o21ai_1
* cell instance $1611 r0 *1 334.56,177.66
X$1611 VSS \$11944 VDD \$11523 \$9485 \$10182 sg13g2_o21ai_1
* cell instance $1612 r0 *1 76.32,253.26
X$1612 VSS \$18900 VDD \$5675 \$18445 \$16127 sg13g2_o21ai_1
* cell instance $1613 r0 *1 349.44,139.86
X$1613 VSS \$8930 VDD \$9309 \$9306 \$9157 sg13g2_o21ai_1
* cell instance $1614 r0 *1 329.76,177.66
X$1614 VSS \$12763 VDD \$11943 \$10902 \$12062 sg13g2_o21ai_1
* cell instance $1615 r0 *1 171.36,18.9
X$1615 VSS \$733 VDD \$208 \$211 \$31 sg13g2_o21ai_1
* cell instance $1616 r0 *1 66.72,177.66
X$1616 VSS \$11749 VDD \$12001 \$12000 \$11750 sg13g2_o21ai_1
* cell instance $1617 r0 *1 132.96,298.62
X$1617 VSS \$21985 VDD \$21216 \$21554 \$21435 sg13g2_o21ai_1
* cell instance $1618 r0 *1 64.32,177.66
X$1618 VSS \$11241 VDD \$11171 \$10978 \$10914 sg13g2_o21ai_1
* cell instance $1619 r0 *1 142.08,215.46
X$1619 VSS \$14653 VDD \$14652 \$15235 \$12973 sg13g2_o21ai_1
* cell instance $1620 r0 *1 313.92,162.54
X$1620 VSS \$10665 VDD \$11076 \$10919 \$7205 sg13g2_o21ai_1
* cell instance $1621 r0 *1 121.44,283.5
X$1621 VSS \$21314 VDD \$21509 \$21201 \$20519 sg13g2_o21ai_1
* cell instance $1622 r0 *1 168.96,64.26
X$1622 VSS \$78 VDD \$3170 \$3168 \$3252 sg13g2_o21ai_1
* cell instance $1623 r0 *1 53.28,238.14
X$1623 VSS \$16942 VDD \$5675 \$16239 \$16231 sg13g2_o21ai_1
* cell instance $1624 r0 *1 313.44,328.86
X$1624 VSS \$23952 VDD \$23563 \$24098 \$22758 sg13g2_o21ai_1
* cell instance $1625 r0 *1 132,34.02
X$1625 VSS \$1312 VDD \$1107 \$1311 \$455 sg13g2_o21ai_1
* cell instance $1626 r0 *1 178.56,275.94
X$1626 VSS \$20448 VDD \$20522 \$20664 \$20525 sg13g2_o21ai_1
* cell instance $1627 r0 *1 183.36,86.94
X$1627 VSS \$2359 VDD \$4799 \$4795 \$4796 sg13g2_o21ai_1
* cell instance $1628 r0 *1 297.6,238.14
X$1628 VSS \$17258 VDD \$15078 \$16430 \$16912 sg13g2_o21ai_1
* cell instance $1629 r0 *1 78.72,34.02
X$1629 VSS \$972 VDD \$1530 \$1408 \$1349 sg13g2_o21ai_1
* cell instance $1630 r0 *1 168.96,170.1
X$1630 VSS \$11613 VDD \$11477 \$11985 \$11868 sg13g2_o21ai_1
* cell instance $1631 r0 *1 49.44,238.14
X$1631 VSS \$15632 VDD \$16236 \$16779 \$16238 sg13g2_o21ai_1
* cell instance $1632 r0 *1 166.56,170.1
X$1632 VSS \$12344 VDD \$11477 \$11475 \$11478 sg13g2_o21ai_1
* cell instance $1633 r0 *1 141.12,56.7
X$1633 VSS \$2736 VDD \$984 \$2737 \$1723 sg13g2_o21ai_1
* cell instance $1634 r0 *1 322.56,200.34
X$1634 VSS \$13717 VDD \$13706 \$13483 \$13241 sg13g2_o21ai_1
* cell instance $1635 r0 *1 209.76,192.78
X$1635 VSS \$13416 VDD \$13179 \$12305 \$12241 sg13g2_o21ai_1
* cell instance $1636 r0 *1 159.36,132.3
X$1636 VSS \$3898 VDD \$8265 \$8437 \$8439 sg13g2_o21ai_1
* cell instance $1637 r0 *1 182.4,223.02
X$1637 VSS \$15614 VDD \$15663 \$13969 \$15040 sg13g2_o21ai_1
* cell instance $1638 r0 *1 272.16,306.18
X$1638 VSS \$22713 VDD \$21071 \$22585 \$22146 sg13g2_o21ai_1
* cell instance $1639 r0 *1 110.88,238.14
X$1639 VSS \$16881 VDD \$17250 \$16883 \$15937 sg13g2_o21ai_1
* cell instance $1640 r0 *1 300,238.14
X$1640 VSS \$17246 VDD \$15078 \$16430 \$17120 sg13g2_o21ai_1
* cell instance $1641 r0 *1 69.6,132.3
X$1641 VSS \$7321 VDD \$7669 \$8420 \$8723 sg13g2_o21ai_1
* cell instance $1642 r0 *1 72.96,147.42
X$1642 VSS \$67 VDD \$9790 \$9528 \$9935 sg13g2_o21ai_1
* cell instance $1643 r0 *1 128.16,102.06
X$1643 VSS \$6967 VDD \$4779 \$6162 \$5148 sg13g2_o21ai_1
* cell instance $1644 r0 *1 103.2,238.14
X$1644 VSS \$16965 VDD \$14018 \$16248 \$16132 sg13g2_o21ai_1
* cell instance $1645 r0 *1 112.32,253.26
X$1645 VSS \$18542 VDD \$18933 \$18930 \$15650 sg13g2_o21ai_1
* cell instance $1646 r0 *1 99.84,18.9
X$1646 VSS \$1077 VDD \$383 \$381 \$230 sg13g2_o21ai_1
* cell instance $1647 r0 *1 215.52,139.86
X$1647 VSS \$9224 VDD \$5675 \$9124 \$8272 sg13g2_o21ai_1
* cell instance $1648 r0 *1 161.76,94.5
X$1648 VSS \$3598 VDD \$5392 \$5165 \$5302 sg13g2_o21ai_1
* cell instance $1649 r0 *1 289.44,109.62
X$1649 VSS \$6947 VDD \$6945 \$6958 \$7898 sg13g2_o21ai_1
* cell instance $1650 r0 *1 214.08,200.34
X$1650 VSS \$13778 VDD \$13179 \$13683 \$13684 sg13g2_o21ai_1
* cell instance $1651 r0 *1 188.16,79.38
X$1651 VSS \$2061 VDD \$4343 \$4346 \$4226 sg13g2_o21ai_1
* cell instance $1652 r0 *1 41.76,215.46
X$1652 VSS \$14874 VDD \$14979 \$14298 \$14871 sg13g2_o21ai_1
* cell instance $1653 r0 *1 259.2,260.82
X$1653 VSS \$19467 VDD \$19466 \$18769 \$19104 sg13g2_o21ai_1
* cell instance $1654 r0 *1 63.36,86.94
X$1654 VSS \$4609 VDD \$1422 \$4988 \$4014 sg13g2_o21ai_1
* cell instance $1655 r0 *1 295.2,238.14
X$1655 VSS \$17692 VDD \$17550 \$16334 \$16809 sg13g2_o21ai_1
* cell instance $1656 r0 *1 331.68,223.02
X$1656 VSS \$15749 VDD \$15766 \$15755 \$15713 sg13g2_o21ai_1
* cell instance $1657 r0 *1 39.84,238.14
X$1657 VSS \$16996 VDD \$16229 \$16988 \$17172 sg13g2_o21ai_1
* cell instance $1658 r0 *1 87.84,154.98
X$1658 VSS \$6731 VDD \$10449 \$10278 \$10357 sg13g2_o21ai_1
* cell instance $1659 r0 *1 138.24,162.54
X$1659 VSS \$10765 VDD \$10996 \$10994 \$10993 sg13g2_o21ai_1
* cell instance $1660 r0 *1 291.36,306.18
X$1660 VSS \$22605 VDD \$22717 \$21081 \$22420 sg13g2_o21ai_1
* cell instance $1661 r0 *1 333.12,238.14
X$1661 VSS \$18318 VDD \$17704 \$17709 \$15713 sg13g2_o21ai_1
* cell instance $1662 r0 *1 44.16,18.9
X$1662 VSS \$267 VDD \$449 \$516 \$608 sg13g2_o21ai_1
* cell instance $1663 r0 *1 156.48,132.3
X$1663 VSS \$8355 VDD \$8599 \$8437 \$7550 sg13g2_o21ai_1
* cell instance $1664 r0 *1 240,343.98
X$1664 VSS \$24924 VDD \$25027 \$25201 \$21061 sg13g2_o21ai_1
* cell instance $1665 r0 *1 134.88,124.74
X$1665 VSS \$1719 VDD \$8432 \$7983 \$7896 sg13g2_o21ai_1
* cell instance $1666 r0 *1 118.08,253.26
X$1666 VSS \$18627 VDD \$17269 \$17807 \$15647 sg13g2_o21ai_1
* cell instance $1667 r0 *1 147.36,275.94
X$1667 VSS \$20408 VDD \$20728 \$20351 \$10831 sg13g2_o21ai_1
* cell instance $1668 r0 *1 86.88,124.74
X$1668 VSS \$8565 VDD \$7031 \$7332 \$8116 sg13g2_o21ai_1
* cell instance $1669 r0 *1 96.96,200.34
X$1669 VSS \$13731 VDD \$13508 \$13787 \$13660 sg13g2_o21ai_1
* cell instance $1670 r0 *1 252.48,336.42
X$1670 VSS \$24614 VDD \$24019 \$24403 \$21061 sg13g2_o21ai_1
* cell instance $1671 r0 *1 34.56,207.9
X$1671 VSS \$14298 VDD \$14448 \$14009 \$14193 sg13g2_o21ai_1
* cell instance $1672 r0 *1 276.96,238.14
X$1672 VSS \$17106 VDD \$17290 \$12539 \$10884 sg13g2_o21ai_1
* cell instance $1673 r0 *1 329.28,185.22
X$1673 VSS \$12561 VDD \$12385 \$12763 \$12383 sg13g2_o21ai_1
* cell instance $1674 r0 *1 139.68,170.1
X$1674 VSS \$2897 VDD \$11470 \$10994 \$10046 sg13g2_o21ai_1
* cell instance $1675 r0 *1 134.88,192.78
X$1675 VSS \$13526 VDD \$12639 \$13341 \$12973 sg13g2_o21ai_1
* cell instance $1676 r0 *1 250.56,238.14
X$1676 VSS \$17341 VDD \$16640 \$17087 \$17458 sg13g2_o21ai_1
* cell instance $1677 r0 *1 173.76,253.26
X$1677 VSS \$17664 VDD \$18456 \$18767 \$18565 sg13g2_o21ai_1
* cell instance $1678 r0 *1 139.2,154.98
X$1678 VSS \$10291 VDD \$10117 \$10161 \$8570 sg13g2_o21ai_1
* cell instance $1679 r0 *1 236.16,117.18
X$1679 VSS \$7646 VDD \$5653 \$7186 \$7182 sg13g2_o21ai_1
* cell instance $1680 r0 *1 116.16,283.5
X$1680 VSS \$20512 VDD \$21184 \$20920 \$20653 sg13g2_o21ai_1
* cell instance $1681 r0 *1 95.04,18.9
X$1681 VSS \$264 VDD \$456 \$381 \$272 sg13g2_o21ai_1
* cell instance $1682 r0 *1 348.96,71.82
X$1682 VSS \$4071 VDD \$585 \$3749 \$2444 sg13g2_o21ai_1
* cell instance $1683 r0 *1 189.6,253.26
X$1683 VSS \$18774 VDD \$19182 \$16633 \$14655 sg13g2_o21ai_1
* cell instance $1684 r0 *1 236.64,207.9
X$1684 VSS \$14267 VDD \$14226 \$13186 \$14224 sg13g2_o21ai_1
* cell instance $1685 r0 *1 157.44,102.06
X$1685 VSS \$7811 VDD \$6177 \$6172 \$6174 sg13g2_o21ai_1
* cell instance $1686 r0 *1 348.96,124.74
X$1686 VSS \$8061 VDD \$5205 \$8044 \$7205 sg13g2_o21ai_1
* cell instance $1687 r0 *1 271.2,343.98
X$1687 VSS \$24260 VDD \$16806 \$24091 \$23939 sg13g2_o21ai_1
* cell instance $1688 r0 *1 319.2,306.18
X$1688 VSS \$22734 VDD \$22424 \$14080 \$11531 sg13g2_o21ai_1
* cell instance $1689 r0 *1 231.36,223.02
X$1689 VSS \$15597 VDD \$15557 \$16105 \$15951 sg13g2_o21ai_1
* cell instance $1690 r0 *1 132.48,192.78
X$1690 VSS \$13524 VDD \$12894 \$13153 \$12966 sg13g2_o21ai_1
* cell instance $1691 r0 *1 237.12,336.42
X$1691 VSS \$24763 VDD \$24543 \$24544 \$21061 sg13g2_o21ai_1
* cell instance $1692 r0 *1 155.04,124.74
X$1692 VSS \$7992 VDD \$7991 \$7993 \$7989 sg13g2_o21ai_1
* cell instance $1693 r0 *1 157.92,223.02
X$1693 VSS \$14803 VDD \$15355 \$15655 \$15552 sg13g2_o21ai_1
* cell instance $1694 r0 *1 330.24,238.14
X$1694 VSS \$16815 VDD \$16651 \$15987 \$15713 sg13g2_o21ai_1
* cell instance $1695 r0 *1 146.4,124.74
X$1695 VSS \$6745 VDD \$7037 \$7986 \$7283 sg13g2_o21ai_1
* cell instance $1696 r0 *1 124.8,94.5
X$1696 VSS \$3703 VDD \$5382 \$5002 \$4783 sg13g2_o21ai_1
* cell instance $1697 r0 *1 137.28,124.74
X$1697 VSS \$8197 VDD \$7905 \$7983 \$7337 sg13g2_o21ai_1
* cell instance $1698 r0 *1 260.64,124.74
X$1698 VSS \$8028 VDD \$8372 \$9290 \$8030 sg13g2_o21ai_1
* cell instance $1699 r0 *1 303.36,192.78
X$1699 VSS \$13080 VDD \$13320 \$12377 \$11716 sg13g2_o21ai_1
* cell instance $1700 r0 *1 195.36,177.66
X$1700 VSS \$12534 VDD \$12197 \$10873 \$11487 sg13g2_o21ai_1
* cell instance $1701 r0 *1 241.44,215.46
X$1701 VSS \$15055 VDD \$15057 \$11964 \$12677 sg13g2_o21ai_1
* cell instance $1702 r0 *1 54.72,147.42
X$1702 VSS \$9785 VDD \$8417 \$9447 \$9356 sg13g2_o21ai_1
* cell instance $39605 m0 *1 230.88,253.26
X$39605 VSS \$2703 \$14903 VDD sg13g2_buf_8
* cell instance $39606 m0 *1 229.44,336.42
X$39606 VSS \$14903 \$23122 VDD sg13g2_buf_8
* cell instance $39607 m0 *1 299.04,200.34
X$39607 VSS \$8635 \$12554 VDD sg13g2_buf_8
* cell instance $39608 m0 *1 159.36,34.02
X$39608 VSS \$83 \$I100130 VDD sg13g2_buf_8
* cell instance $39609 m0 *1 113.28,207.9
X$39609 VSS \$13053 \$12633 VDD sg13g2_buf_8
* cell instance $39610 m0 *1 177.12,154.98
X$39610 VSS \$9114 \$I100128 VDD sg13g2_buf_8
* cell instance $39611 m0 *1 326.4,18.9
X$39611 VSS \$167 \$304 VDD sg13g2_buf_8
* cell instance $39612 m0 *1 77.76,200.34
X$39612 VSS \$13138 \$12289 VDD sg13g2_buf_8
* cell instance $39613 m0 *1 24.96,207.9
X$39613 VSS \$13138 \$12626 VDD sg13g2_buf_8
* cell instance $39614 m0 *1 156.96,328.86
X$39614 VSS \$20856 \$21830 VDD sg13g2_buf_8
* cell instance $39615 m0 *1 72.96,26.46
X$39615 VSS \$525 \$149 VDD sg13g2_buf_8
* cell instance $39616 m0 *1 86.88,351.54
X$39616 VSS \$21537 \$22565 VDD sg13g2_buf_8
* cell instance $39617 m0 *1 113.28,41.58
X$39617 VSS \$1433 \$75 VDD sg13g2_buf_8
* cell instance $39618 m0 *1 103.2,79.38
X$39618 VSS \$1433 \$3156 VDD sg13g2_buf_8
* cell instance $39619 m0 *1 243.36,162.54
X$39619 VSS \$8635 \$9284 VDD sg13g2_buf_8
* cell instance $39620 m0 *1 280.8,34.02
X$39620 VSS \$1000 \$246 VDD sg13g2_buf_8
* cell instance $39621 m0 *1 138.72,86.94
X$39621 VSS \$1433 \$3162 VDD sg13g2_buf_8
* cell instance $39622 m0 *1 136.8,260.82
X$39622 VSS \$13053 \$16506 VDD sg13g2_buf_8
* cell instance $39623 m0 *1 238.56,86.94
X$39623 VSS \$4210 \$3177 VDD sg13g2_buf_8
* cell instance $39624 m0 *1 132.96,139.86
X$39624 VSS \$2703 \$7998 VDD sg13g2_buf_8
* cell instance $39625 m0 *1 55.68,245.7
X$39625 VSS \$2703 \$13138 VDD sg13g2_buf_8
* cell instance $39626 m0 *1 123.84,79.38
X$39626 VSS \$2703 \$1433 VDD sg13g2_buf_8
* cell instance $39627 m0 *1 167.04,79.38
X$39627 VSS \$4210 \$2900 VDD sg13g2_buf_8
* cell instance $39628 m0 *1 214.56,26.46
X$39628 VSS \$95 \$I100110 VDD sg13g2_buf_8
* cell instance $39629 m0 *1 336.96,328.86
X$39629 VSS \$17546 \$22192 VDD sg13g2_buf_8
* cell instance $39630 m0 *1 93.6,298.62
X$39630 VSS \$21537 \$19978 VDD sg13g2_buf_8
* cell instance $39631 m0 *1 84,162.54
X$39631 VSS \$7667 \$9541 VDD sg13g2_buf_8
* cell instance $39632 m0 *1 205.92,102.06
X$39632 VSS \$2703 \$4210 VDD sg13g2_buf_8
* cell instance $39633 m0 *1 131.04,230.58
X$39633 VSS \$2703 \$13053 VDD sg13g2_buf_8
* cell instance $39634 m0 *1 330.72,139.86
X$39634 VSS \$9487 \$7721 VDD sg13g2_buf_8
* cell instance $39635 m0 *1 262.56,223.02
X$39635 VSS \$13206 \$I100103 VDD sg13g2_buf_8
* cell instance $39636 m0 *1 202.08,245.7
X$39636 VSS \$14903 \$14809 VDD sg13g2_buf_8
* cell instance $39637 m0 *1 118.56,291.06
X$39637 VSS \$20856 \$I100101 VDD sg13g2_buf_8
* cell instance $39638 m0 *1 132.96,109.62
X$39638 VSS \$1433 \$5380 VDD sg13g2_buf_8
* cell instance $39639 m0 *1 116.16,313.74
X$39639 VSS \$20856 \$21825 VDD sg13g2_buf_8
* cell instance $39640 m0 *1 303.84,94.5
X$39640 VSS \$2703 \$2397 VDD sg13g2_buf_8
* cell instance $39641 m0 *1 83.52,56.7
X$39641 VSS \$525 \$1412 VDD sg13g2_buf_8
* cell instance $39642 m0 *1 228.48,291.06
X$39642 VSS \$14903 \$20459 VDD sg13g2_buf_8
* cell instance $39643 m0 *1 341.76,86.94
X$39643 VSS \$2397 \$2916 VDD sg13g2_buf_8
* cell instance $39644 m0 *1 220.32,56.7
X$39644 VSS \$2703 \$1000 VDD sg13g2_buf_8
* cell instance $39645 m0 *1 231.36,207.9
X$39645 VSS \$14903 \$12538 VDD sg13g2_buf_8
* cell instance $39646 m0 *1 195.84,132.3
X$39646 VSS \$4210 \$5631 VDD sg13g2_buf_8
* cell instance $39647 m0 *1 327.84,124.74
X$39647 VSS \$2397 \$5681 VDD sg13g2_buf_8
* cell instance $39648 m0 *1 34.56,124.74
X$39648 VSS \$7667 \$5916 VDD sg13g2_buf_8
* cell instance $39649 m0 *1 329.76,56.7
X$39649 VSS \$2397 \$1684 VDD sg13g2_buf_8
* cell instance $39650 m0 *1 43.68,86.94
X$39650 VSS \$525 \$3151 VDD sg13g2_buf_8
* cell instance $39651 m0 *1 289.92,102.06
X$39651 VSS \$2397 \$4385 VDD sg13g2_buf_8
* cell instance $39652 m0 *1 24.48,245.7
X$39652 VSS \$13138 \$15624 VDD sg13g2_buf_8
* cell instance $39653 m0 *1 65.28,253.26
X$39653 VSS \$13138 \$15634 VDD sg13g2_buf_8
* cell instance $39654 m0 *1 260.16,71.82
X$39654 VSS \$2703 \$167 VDD sg13g2_buf_8
* cell instance $39655 m0 *1 339.36,200.34
X$39655 VSS \$9487 \$12321 VDD sg13g2_buf_8
* cell instance $39656 m0 *1 206.4,86.94
X$39656 VSS \$4210 \$3725 VDD sg13g2_buf_8
* cell instance $39657 m0 *1 24.96,64.26
X$39657 VSS \$525 \$1384 VDD sg13g2_buf_8
* cell instance $39658 m0 *1 198.24,56.7
X$39658 VSS \$1000 \$918 VDD sg13g2_buf_8
* cell instance $39659 m0 *1 70.08,102.06
X$39659 VSS \$7667 \$4275 VDD sg13g2_buf_8
* cell instance $39660 m0 *1 328.8,162.54
X$39660 VSS \$9487 \$9327 VDD sg13g2_buf_8
* cell instance $39661 m0 *1 64.8,79.38
X$39661 VSS \$2703 \$525 VDD sg13g2_buf_8
* cell instance $39662 m0 *1 292.8,71.82
X$39662 VSS \$167 \$2389 VDD sg13g2_buf_8
* cell instance $39663 m0 *1 292.8,245.7
X$39663 VSS \$17546 \$I100075 VDD sg13g2_buf_8
* cell instance $39664 m0 *1 84,124.74
X$39664 VSS \$7998 \$5612 VDD sg13g2_buf_8
* cell instance $39665 m0 *1 141.12,283.5
X$39665 VSS \$20856 \$19658 VDD sg13g2_buf_8
* cell instance $39666 m0 *1 36,283.5
X$39666 VSS \$13138 \$19646 VDD sg13g2_buf_8
* cell instance $39667 r0 *1 63.36,124.74
X$39667 VSS \$2703 \$7667 VDD sg13g2_buf_8
* cell instance $39668 r0 *1 309.6,207.9
X$39668 VSS \$2703 \$9487 VDD sg13g2_buf_8
* cell instance $39669 r0 *1 176.16,215.46
X$39669 VSS \$13053 \$13170 VDD sg13g2_buf_8
* cell instance $39670 r0 *1 131.04,170.1
X$39670 VSS \$7998 \$9809 VDD sg13g2_buf_8
* cell instance $39671 r0 *1 281.76,154.98
X$39671 VSS \$8635 \$8183 VDD sg13g2_buf_8
* cell instance $39672 r0 *1 24.96,207.9
X$39672 VSS \$12626 \$I100066 VDD sg13g2_buf_8
* cell instance $39673 r0 *1 63.36,162.54
X$39673 VSS \$7667 \$9250 VDD sg13g2_buf_8
* cell instance $39674 r0 *1 299.04,336.42
X$39674 VSS \$17546 \$22724 VDD sg13g2_buf_8
* cell instance $39675 r0 *1 88.8,291.06
X$39675 VSS \$19978 \$I100063 VDD sg13g2_buf_8
* cell instance $39676 r0 *1 292.8,253.26
X$39676 VSS \$2703 \$17546 VDD sg13g2_buf_8
* cell instance $39677 r0 *1 151.2,192.78
X$39677 VSS \$13053 \$11472 VDD sg13g2_buf_8
* cell instance $39678 r0 *1 291.84,260.82
X$39678 VSS \$9487 \$16160 VDD sg13g2_buf_8
* cell instance $39679 r0 *1 177.6,154.98
X$39679 VSS \$7998 \$9114 VDD sg13g2_buf_8
* cell instance $39680 r0 *1 134.4,34.02
X$39680 VSS \$1433 \$79 VDD sg13g2_buf_8
* cell instance $39681 r0 *1 213.6,26.46
X$39681 VSS \$1000 \$95 VDD sg13g2_buf_8
* cell instance $39682 r0 *1 158.4,34.02
X$39682 VSS \$1000 \$83 VDD sg13g2_buf_8
* cell instance $39683 r0 *1 65.28,291.06
X$39683 VSS \$2703 \$21537 VDD sg13g2_buf_8
* cell instance $39684 r0 *1 23.04,154.98
X$39684 VSS \$7667 \$8551 VDD sg13g2_buf_8
* cell instance $39685 r0 *1 37.44,306.18
X$39685 VSS \$21537 \$21534 VDD sg13g2_buf_8
* cell instance $39686 r0 *1 262.56,215.46
X$39686 VSS \$14903 \$13206 VDD sg13g2_buf_8
* cell instance $39687 r0 *1 216.96,117.18
X$39687 VSS \$4210 \$6432 VDD sg13g2_buf_8
* cell instance $39688 r0 *1 276,291.06
X$39688 VSS \$17546 \$20682 VDD sg13g2_buf_8
* cell instance $39689 r0 *1 255.36,117.18
X$39689 VSS \$8635 \$6443 VDD sg13g2_buf_8
* cell instance $39690 r0 *1 136.8,253.26
X$39690 VSS \$16506 \$I100048 VDD sg13g2_buf_8
* cell instance $39691 r0 *1 123.84,283.5
X$39691 VSS \$2703 \$20856 VDD sg13g2_buf_8
* cell instance $39692 r0 *1 33.6,343.98
X$39692 VSS \$21537 \$24039 VDD sg13g2_buf_8
* cell instance $39693 r0 *1 330.72,245.7
X$39693 VSS \$9487 \$15972 VDD sg13g2_buf_8
* cell instance $39694 r0 *1 202.56,185.22
X$39694 VSS \$8635 \$9827 VDD sg13g2_buf_8
* cell instance $39695 r0 *1 91.68,230.58
X$39695 VSS \$13053 \$14322 VDD sg13g2_buf_8
* cell instance $39696 r0 *1 113.76,132.3
X$39696 VSS \$7998 \$6281 VDD sg13g2_buf_8
* cell instance $39697 r0 *1 165.6,117.18
X$39697 VSS \$7998 \$5630 VDD sg13g2_buf_8
* cell instance $39698 r0 *1 58.56,328.86
X$39698 VSS \$21537 \$23087 VDD sg13g2_buf_8
* cell instance $39699 r0 *1 345.6,26.46
X$39699 VSS \$167 \$98 VDD sg13g2_buf_8
* cell instance $39700 r0 *1 270.72,79.38
X$39700 VSS \$167 \$247 VDD sg13g2_buf_8
* cell instance $39701 r0 *1 126.72,328.86
X$39701 VSS \$20856 \$23104 VDD sg13g2_buf_8
* cell instance $39702 r0 *1 244.8,185.22
X$39702 VSS \$2703 \$8635 VDD sg13g2_buf_8
* cell instance $39703 r0 *1 302.88,94.5
X$39703 VSS \$2397 \$2914 VDD sg13g2_buf_8
* cell instance $39704 r0 *1 35.04,26.46
X$39704 VSS \$525 \$226 VDD sg13g2_buf_8
* cell instance $39705 r0 *1 329.28,283.5
X$39705 VSS \$17546 \$19691 VDD sg13g2_buf_8
* cell instance $39706 r0 *1 239.52,64.26
X$39706 VSS \$1000 \$1459 VDD sg13g2_buf_8
* cell instance $39707 r0 *1 336.96,321.3
X$39707 VSS \$22192 \$I100031 VDD sg13g2_buf_8
* cell instance $39708 m0 *1 262.08,351.54
X$39708 VSS dac_soft[5] VDD \$24081 sg13g2_buf_1
* cell instance $39709 m0 *1 210.24,132.3
X$39709 VSS \$6790 VDD \$6196 sg13g2_buf_1
* cell instance $39710 m0 *1 51.36,49.14
X$39710 VSS \$897 VDD \$804 sg13g2_buf_1
* cell instance $39711 m0 *1 293.76,238.14
X$39711 VSS \$15077 VDD \$16334 sg13g2_buf_1
* cell instance $39712 m0 *1 48.48,268.38
X$39712 VSS \$19401 VDD \$19717 sg13g2_buf_1
* cell instance $39713 m0 *1 264,351.54
X$39713 VSS sdo VDD \$25035 sg13g2_buf_1
* cell instance $39714 m0 *1 260.16,351.54
X$39714 VSS dac_soft[7] VDD \$24731 sg13g2_buf_1
* cell instance $39715 m0 *1 123.84,117.18
X$39715 VSS \$6154 VDD \$6774 sg13g2_buf_1
* cell instance $39716 m0 *1 106.56,94.5
X$39716 VSS \$4287 VDD \$3791 sg13g2_buf_1
* cell instance $39717 m0 *1 233.76,298.62
X$39717 VSS \$13512 VDD \$21724 sg13g2_buf_1
* cell instance $39718 m0 *1 241.44,200.34
X$39718 VSS \$12677 VDD \$13194 sg13g2_buf_1
* cell instance $39719 m0 *1 84,313.74
X$39719 VSS \$22562 VDD \$22658 sg13g2_buf_1
* cell instance $39720 m0 *1 8.16,230.58
X$39720 VSS \$15915 VDD cmp_soft sg13g2_buf_1
* cell instance $39721 m0 *1 249.12,291.06
X$39721 VSS \$20038 VDD \$20382 sg13g2_buf_1
* cell instance $39722 m0 *1 229.92,245.7
X$39722 VSS \$13181 VDD \$15506 sg13g2_buf_1
* cell instance $39723 m0 *1 343.2,275.94
X$39723 VSS \$19514 VDD \$20253 sg13g2_buf_1
* cell instance $39724 m0 *1 51.84,328.86
X$39724 VSS \$23517 VDD \$23002 sg13g2_buf_1
* cell instance $39725 m0 *1 258.24,351.54
X$39725 VSS dac_hard[5] VDD \$23933 sg13g2_buf_1
* cell instance $39726 m0 *1 61.92,223.02
X$39726 VSS \$14878 VDD \$14989 sg13g2_buf_1
* cell instance $39727 m0 *1 260.64,86.94
X$39727 VSS \$1012 VDD \$1103 sg13g2_buf_1
* cell instance $39728 m0 *1 162.24,245.7
X$39728 VSS \$14999 VDD \$5546 sg13g2_buf_1
* cell instance $39729 m0 *1 334.08,192.78
X$39729 VSS \$8660 VDD \$7052 sg13g2_buf_1
* cell instance $39730 m0 *1 256.32,351.54
X$39730 VSS dac_hard[7] VDD \$22995 sg13g2_buf_1
* cell instance $39731 m0 *1 254.88,328.86
X$39731 VSS \$23120 VDD \$20382 sg13g2_buf_1
* cell instance $39732 m0 *1 254.4,351.54
X$39732 VSS dac_soft[3] VDD \$23454 sg13g2_buf_1
* cell instance $39733 m0 *1 198.24,147.42
X$39733 VSS \$5338 VDD \$9824 sg13g2_buf_1
* cell instance $39734 m0 *1 174.24,328.86
X$39734 VSS \$20922 VDD \$23684 sg13g2_buf_1
* cell instance $39735 m0 *1 48.48,215.46
X$39735 VSS \$14195 VDD \$11258 sg13g2_buf_1
* cell instance $39736 m0 *1 293.76,283.5
X$39736 VSS \$19471 VDD \$20686 sg13g2_buf_1
* cell instance $39737 m0 *1 110.88,200.34
X$39737 VSS \$12013 VDD \$13579 sg13g2_buf_1
* cell instance $39738 m0 *1 94.08,223.02
X$39738 VSS \$14018 VDD \$13309 sg13g2_buf_1
* cell instance $39739 m0 *1 52.8,154.98
X$39739 VSS \$9097 VDD \$7950 sg13g2_buf_1
* cell instance $39740 m0 *1 336,18.9
X$39740 VSS \$288 VDD \$254 sg13g2_buf_1
* cell instance $39741 m0 *1 297.12,260.82
X$39741 VSS \$16336 VDD \$20110 sg13g2_buf_1
* cell instance $39742 m0 *1 327.84,223.02
X$39742 VSS \$14075 VDD \$15111 sg13g2_buf_1
* cell instance $39743 m0 *1 336,41.58
X$39743 VSS \$1480 VDD \$2429 sg13g2_buf_1
* cell instance $39744 m0 *1 52.32,200.34
X$39744 VSS \$11991 VDD \$13126 sg13g2_buf_1
* cell instance $39745 m0 *1 153.6,177.66
X$39745 VSS \$9108 VDD \$10865 sg13g2_buf_1
* cell instance $39746 m0 *1 8.16,275.94
X$39746 VSS \$20223 VDD sdi sg13g2_buf_1
* cell instance $39747 m0 *1 93.6,192.78
X$39747 VSS \$10452 VDD \$9034 sg13g2_buf_1
* cell instance $39748 m0 *1 312.48,170.1
X$39748 VSS \$8475 VDD \$11201 sg13g2_buf_1
* cell instance $39749 m0 *1 26.88,268.38
X$39749 VSS \$19394 VDD \$19647 sg13g2_buf_1
* cell instance $39750 m0 *1 88.32,245.7
X$39750 VSS \$15232 VDD \$15775 sg13g2_buf_1
* cell instance $39751 m0 *1 188.64,170.1
X$39751 VSS \$5653 VDD \$9639 sg13g2_buf_1
* cell instance $39752 m0 *1 53.28,177.66
X$39752 VSS \$7950 VDD \$10452 sg13g2_buf_1
* cell instance $39753 m0 *1 86.4,245.7
X$39753 VSS \$15547 VDD \$17405 sg13g2_buf_1
* cell instance $39754 m0 *1 31.68,223.02
X$39754 VSS \$13576 VDD \$14011 sg13g2_buf_1
* cell instance $39755 m0 *1 166.56,200.34
X$39755 VSS \$12020 VDD \$13579 sg13g2_buf_1
* cell instance $39756 m0 *1 156.96,223.02
X$39756 VSS \$13963 VDD \$13579 sg13g2_buf_1
* cell instance $39757 m0 *1 155.04,223.02
X$39757 VSS \$15248 VDD \$13816 sg13g2_buf_1
* cell instance $39758 m0 *1 334.56,260.82
X$39758 VSS \$15263 VDD \$5546 sg13g2_buf_1
* cell instance $39759 m0 *1 224.64,260.82
X$39759 VSS \$16638 VDD \$12234 sg13g2_buf_1
* cell instance $39760 m0 *1 45.6,268.38
X$39760 VSS \$19647 VDD \$19401 sg13g2_buf_1
* cell instance $39761 m0 *1 349.92,117.18
X$39761 VSS \$7052 VDD \$6847 sg13g2_buf_1
* cell instance $39762 m0 *1 151.68,177.66
X$39762 VSS \$10465 VDD \$9108 sg13g2_buf_1
* cell instance $39763 m0 *1 304.32,283.5
X$39763 VSS \$20795 VDD \$20554 sg13g2_buf_1
* cell instance $39764 m0 *1 302.4,283.5
X$39764 VSS \$20363 VDD \$20554 sg13g2_buf_1
* cell instance $39765 m0 *1 349.92,275.94
X$39765 VSS \$16816 VDD en sg13g2_buf_1
* cell instance $39766 m0 *1 186.24,313.74
X$39766 VSS \$22418 VDD \$21066 sg13g2_buf_1
* cell instance $39767 m0 *1 237.12,268.38
X$39767 VSS \$18469 VDD \$19098 sg13g2_buf_1
* cell instance $39768 m0 *1 252.96,328.86
X$39768 VSS \$23451 VDD \$23120 sg13g2_buf_1
* cell instance $39769 m0 *1 188.16,313.74
X$39769 VSS \$20658 VDD \$22679 sg13g2_buf_1
* cell instance $39770 m0 *1 220.8,306.18
X$39770 VSS \$12711 VDD \$20046 sg13g2_buf_1
* cell instance $39771 m0 *1 158.4,298.62
X$39771 VSS \$21696 VDD \$19911 sg13g2_buf_1
* cell instance $39772 m0 *1 218.4,351.54
X$39772 VSS dac_hard[0] VDD \$22304 sg13g2_buf_1
* cell instance $39773 m0 *1 52.8,283.5
X$39773 VSS \$20742 VDD \$19401 sg13g2_buf_1
* cell instance $39774 m0 *1 156.48,298.62
X$39774 VSS \$20046 VDD \$21812 sg13g2_buf_1
* cell instance $39775 m0 *1 251.04,34.02
X$39775 VSS \$160 VDD \$162 sg13g2_buf_1
* cell instance $39776 m0 *1 223.2,192.78
X$39776 VSS \$11503 VDD \$13442 sg13g2_buf_1
* cell instance $39777 m0 *1 348,275.94
X$39777 VSS gate_en VDD \$16368 sg13g2_buf_1
* cell instance $39778 m0 *1 142.08,223.02
X$39778 VSS \$12637 VDD \$15350 sg13g2_buf_1
* cell instance $39779 m0 *1 220.8,71.82
X$39779 VSS \$2743 VDD \$2907 sg13g2_buf_1
* cell instance $39780 m0 *1 262.56,283.5
X$39780 VSS \$12452 VDD \$13585 sg13g2_buf_1
* cell instance $39781 m0 *1 258.24,177.66
X$39781 VSS \$9392 VDD \$11018 sg13g2_buf_1
* cell instance $39782 m0 *1 22.56,328.86
X$39782 VSS \$24040 VDD \$23002 sg13g2_buf_1
* cell instance $39783 m0 *1 252.96,34.02
X$39783 VSS \$1009 VDD \$1103 sg13g2_buf_1
* cell instance $39784 m0 *1 236.16,343.98
X$39784 VSS \$14170 VDD \$24027 sg13g2_buf_1
* cell instance $39785 m0 *1 295.68,283.5
X$39785 VSS \$20686 VDD \$20253 sg13g2_buf_1
* cell instance $39786 m0 *1 126.24,49.14
X$39786 VSS \$976 VDD \$1431 sg13g2_buf_1
* cell instance $39787 m0 *1 185.76,351.54
X$39787 VSS \$22679 VDD \$24753 sg13g2_buf_1
* cell instance $39788 m0 *1 196.8,253.26
X$39788 VSS \$17669 VDD \$18631 sg13g2_buf_1
* cell instance $39789 m0 *1 53.28,49.14
X$39789 VSS \$804 VDD \$2097 sg13g2_buf_1
* cell instance $39790 m0 *1 126.72,306.18
X$39790 VSS \$12893 VDD \$20046 sg13g2_buf_1
* cell instance $39791 m0 *1 220.32,192.78
X$39791 VSS \$11490 VDD \$13433 sg13g2_buf_1
* cell instance $39792 m0 *1 346.08,260.82
X$39792 VSS dac_hard[3] VDD \$18646 sg13g2_buf_1
* cell instance $39793 m0 *1 284.16,139.86
X$39793 VSS \$7826 VDD \$6847 sg13g2_buf_1
* cell instance $39794 m0 *1 349.92,260.82
X$39794 VSS clr_d VDD \$15091 sg13g2_buf_1
* cell instance $39795 m0 *1 250.08,147.42
X$39795 VSS \$9283 VDD \$9392 sg13g2_buf_1
* cell instance $39796 m0 *1 345.6,200.34
X$39796 VSS \$12060 VDD \$12564 sg13g2_buf_1
* cell instance $39797 m0 *1 41.76,132.3
X$39797 VSS \$7307 VDD \$6148 sg13g2_buf_1
* cell instance $39798 m0 *1 344.16,260.82
X$39798 VSS osc_trim[2] VDD \$19113 sg13g2_buf_1
* cell instance $39799 m0 *1 124.32,139.86
X$39799 VSS \$7340 VDD \$6774 sg13g2_buf_1
* cell instance $39800 m0 *1 122.4,139.86
X$39800 VSS \$6774 VDD \$9034 sg13g2_buf_1
* cell instance $39801 m0 *1 234.72,291.06
X$39801 VSS \$14666 VDD \$21060 sg13g2_buf_1
* cell instance $39802 m0 *1 240.96,245.7
X$39802 VSS \$13832 VDD \$16342 sg13g2_buf_1
* cell instance $39803 m0 *1 245.28,94.5
X$39803 VSS \$3920 VDD \$1012 sg13g2_buf_1
* cell instance $39804 m0 *1 82.08,313.74
X$39804 VSS \$23096 VDD \$22658 sg13g2_buf_1
* cell instance $39805 m0 *1 288.48,291.06
X$39805 VSS \$20942 VDD \$21081 sg13g2_buf_1
* cell instance $39806 m0 *1 301.92,162.54
X$39806 VSS \$10506 VDD \$7052 sg13g2_buf_1
* cell instance $39807 m0 *1 274.56,238.14
X$39807 VSS \$16334 VDD \$16336 sg13g2_buf_1
* cell instance $39808 m0 *1 284.64,56.7
X$39808 VSS \$2386 VDD \$1020 sg13g2_buf_1
* cell instance $39809 m0 *1 348.96,230.58
X$39809 VSS \$12564 VDD \$14109 sg13g2_buf_1
* cell instance $39810 m0 *1 346.56,230.58
X$39810 VSS trip VDD \$14462 sg13g2_buf_1
* cell instance $39811 m0 *1 238.56,351.54
X$39811 VSS dac_hard[1] VDD \$22537 sg13g2_buf_1
* cell instance $39812 m0 *1 236.64,351.54
X$39812 VSS dac_soft[2] VDD \$22879 sg13g2_buf_1
* cell instance $39813 m0 *1 234.72,351.54
X$39813 VSS dac_hard[2] VDD \$22542 sg13g2_buf_1
* cell instance $39814 m0 *1 300,162.54
X$39814 VSS \$1469 VDD \$8475 sg13g2_buf_1
* cell instance $39815 m0 *1 306.24,49.14
X$39815 VSS \$1020 VDD \$288 sg13g2_buf_1
* cell instance $39816 m0 *1 177.12,321.3
X$39816 VSS \$23009 VDD \$22120 sg13g2_buf_1
* cell instance $39817 m0 *1 270.24,283.5
X$39817 VSS \$20461 VDD \$20903 sg13g2_buf_1
* cell instance $39818 m0 *1 290.4,185.22
X$39818 VSS \$12377 VDD \$12059 sg13g2_buf_1
* cell instance $39819 m0 *1 136.8,321.3
X$39819 VSS \$21692 VDD \$19987 sg13g2_buf_1
* cell instance $39820 m0 *1 137.28,223.02
X$39820 VSS \$12818 VDD \$15232 sg13g2_buf_1
* cell instance $39821 m0 *1 228.96,275.94
X$39821 VSS \$17876 VDD \$19623 sg13g2_buf_1
* cell instance $39822 m0 *1 161.28,306.18
X$39822 VSS \$22264 VDD \$22120 sg13g2_buf_1
* cell instance $39823 m0 *1 239.04,230.58
X$39823 VSS \$15312 VDD \$15263 sg13g2_buf_1
* cell instance $39824 m0 *1 257.28,185.22
X$39824 VSS \$11018 VDD \$254 sg13g2_buf_1
* cell instance $39825 m0 *1 159.84,41.58
X$39825 VSS \$1314 VDD \$1775 sg13g2_buf_1
* cell instance $39826 m0 *1 120,268.38
X$39826 VSS \$11195 VDD \$19415 sg13g2_buf_1
* cell instance $39827 m0 *1 94.56,170.1
X$39827 VSS \$9801 VDD \$9252 sg13g2_buf_1
* cell instance $39828 m0 *1 214.08,102.06
X$39828 VSS \$2907 VDD \$1103 sg13g2_buf_1
* cell instance $39829 m0 *1 349.92,185.22
X$39829 VSS \$6847 VDD \$254 sg13g2_buf_1
* cell instance $39830 m0 *1 75.36,336.42
X$39830 VSS \$23657 VDD \$23096 sg13g2_buf_1
* cell instance $39831 m0 *1 237.6,102.06
X$39831 VSS \$3191 VDD \$2429 sg13g2_buf_1
* cell instance $39832 m0 *1 77.76,260.82
X$39832 VSS \$8905 VDD \$19156 sg13g2_buf_1
* cell instance $39833 m0 *1 144.96,321.3
X$39833 VSS \$13948 VDD \$19205 sg13g2_buf_1
* cell instance $39834 m0 *1 344.16,26.46
X$39834 VSS \$1032 VDD \$295 sg13g2_buf_1
* cell instance $39835 m0 *1 165.6,64.26
X$39835 VSS \$2614 VDD \$3318 sg13g2_buf_1
* cell instance $39836 m0 *1 348,260.82
X$39836 VSS t2f_en VDD \$17112 sg13g2_buf_1
* cell instance $39837 m0 *1 174.72,41.58
X$39837 VSS \$481 VDD \$1597 sg13g2_buf_1
* cell instance $39838 m0 *1 252.96,343.98
X$39838 VSS dac_soft[4] VDD \$23934 sg13g2_buf_1
* cell instance $39839 m0 *1 251.04,343.98
X$39839 VSS \$24764 VDD \$23120 sg13g2_buf_1
* cell instance $39840 m0 *1 165.12,283.5
X$39840 VSS \$19608 VDD \$20663 sg13g2_buf_1
* cell instance $39841 m0 *1 104.64,298.62
X$39841 VSS \$23499 VDD \$21692 sg13g2_buf_1
* cell instance $39842 m0 *1 348,253.26
X$39842 VSS trip_d VDD \$15717 sg13g2_buf_1
* cell instance $39843 m0 *1 125.28,253.26
X$39843 VSS \$15003 VDD \$17050 sg13g2_buf_1
* cell instance $39844 m0 *1 234.72,215.46
X$39844 VSS \$14224 VDD \$12677 sg13g2_buf_1
* cell instance $39845 m0 *1 178.56,41.58
X$39845 VSS \$164 VDD \$165 sg13g2_buf_1
* cell instance $39846 m0 *1 272.64,139.86
X$39846 VSS \$5046 VDD \$794 sg13g2_buf_1
* cell instance $39847 m0 *1 245.28,109.62
X$39847 VSS \$2429 VDD \$288 sg13g2_buf_1
* cell instance $39848 m0 *1 115.68,71.82
X$39848 VSS \$2611 VDD \$2337 sg13g2_buf_1
* cell instance $39849 m0 *1 335.04,328.86
X$39849 VSS \$23183 VDD \$14075 sg13g2_buf_1
* cell instance $39850 m0 *1 336.48,260.82
X$39850 VSS \$14109 VDD \$15263 sg13g2_buf_1
* cell instance $39851 m0 *1 349.92,253.26
X$39851 VSS trip_cause[1] VDD \$14437 sg13g2_buf_1
* cell instance $39852 m0 *1 90.24,253.26
X$39852 VSS \$17415 VDD \$17405 sg13g2_buf_1
* cell instance $39853 m0 *1 8.16,283.5
X$39853 VSS \$20804 VDD \$19401 sg13g2_buf_1
* cell instance $39854 m0 *1 247.2,139.86
X$39854 VSS \$7919 VDD \$254 sg13g2_buf_1
* cell instance $39855 m0 *1 147.84,230.58
X$39855 VSS \$15648 VDD \$15232 sg13g2_buf_1
* cell instance $39856 m0 *1 230.88,275.94
X$39856 VSS \$18814 VDD \$19608 sg13g2_buf_1
* cell instance $39857 m0 *1 176.16,117.18
X$39857 VSS \$5389 VDD \$6180 sg13g2_buf_1
* cell instance $39858 m0 *1 324,18.9
X$39858 VSS \$794 VDD \$295 sg13g2_buf_1
* cell instance $39859 m0 *1 46.08,139.86
X$39859 VSS \$6148 VDD \$6266 sg13g2_buf_1
* cell instance $39860 m0 *1 84.48,139.86
X$39860 VSS \$7163 VDD \$6266 sg13g2_buf_1
* cell instance $39861 m0 *1 63.36,253.26
X$39861 VSS \$17513 VDD \$14989 sg13g2_buf_1
* cell instance $39862 m0 *1 261.12,298.62
X$39862 VSS \$12710 VDD \$13948 sg13g2_buf_1
* cell instance $39863 m0 *1 289.92,336.42
X$39863 VSS \$24547 VDD \$22721 sg13g2_buf_1
* cell instance $39864 m0 *1 336,192.78
X$39864 VSS \$254 VDD \$5546 sg13g2_buf_1
* cell instance $39865 m0 *1 335.52,313.74
X$39865 VSS \$22721 VDD \$20382 sg13g2_buf_1
* cell instance $39866 m0 *1 336,223.02
X$39866 VSS \$13239 VDD \$13985 sg13g2_buf_1
* cell instance $39867 m0 *1 249.6,117.18
X$39867 VSS \$5413 VDD \$5751 sg13g2_buf_1
* cell instance $39868 m0 *1 209.76,321.3
X$39868 VSS \$23117 VDD \$23120 sg13g2_buf_1
* cell instance $39869 m0 *1 149.76,185.22
X$39869 VSS \$9034 VDD \$5546 sg13g2_buf_1
* cell instance $39870 m0 *1 349.92,177.66
X$39870 VSS \$12075 VDD tripped sg13g2_buf_1
* cell instance $39871 m0 *1 206.88,321.3
X$39871 VSS \$20006 VDD \$23542 sg13g2_buf_1
* cell instance $39872 m0 *1 47.52,79.38
X$39872 VSS \$2310 VDD \$3147 sg13g2_buf_1
* cell instance $39873 m0 *1 334.08,18.9
X$39873 VSS \$395 VDD \$165 sg13g2_buf_1
* cell instance $39874 m0 *1 346.08,275.94
X$39874 VSS \$20253 VDD \$20382 sg13g2_buf_1
* cell instance $39875 m0 *1 289.92,162.54
X$39875 VSS \$9838 VDD \$6847 sg13g2_buf_1
* cell instance $39876 m0 *1 51.36,177.66
X$39876 VSS \$10443 VDD \$7950 sg13g2_buf_1
* cell instance $39877 m0 *1 230.88,86.94
X$39877 VSS \$162 VDD \$1009 sg13g2_buf_1
* cell instance $39878 m0 *1 75.36,207.9
X$39878 VSS \$11567 VDD \$13126 sg13g2_buf_1
* cell instance $39879 m0 *1 283.68,147.42
X$39879 VSS \$295 VDD \$6847 sg13g2_buf_1
* cell instance $39880 m0 *1 154.08,283.5
X$39880 VSS \$10831 VDD \$18907 sg13g2_buf_1
* cell instance $39881 m0 *1 82.56,139.86
X$39881 VSS \$6763 VDD \$7163 sg13g2_buf_1
* cell instance $39882 r0 *1 205.92,56.7
X$39882 VSS \$470 VDD \$1103 sg13g2_buf_1
* cell instance $39883 r0 *1 183.36,230.58
X$39883 VSS \$13969 VDD \$16633 sg13g2_buf_1
* cell instance $39884 r0 *1 187.68,253.26
X$39884 VSS \$15946 VDD \$18631 sg13g2_buf_1
* cell instance $39885 r0 *1 83.52,238.14
X$39885 VSS \$13794 VDD \$15232 sg13g2_buf_1
* cell instance $39886 r0 *1 345.12,275.94
X$39886 VSS \$20382 VDD \$15263 sg13g2_buf_1
* cell instance $39887 r0 *1 159.84,298.62
X$39887 VSS \$22120 VDD \$19987 sg13g2_buf_1
* cell instance $39888 r0 *1 120.96,223.02
X$39888 VSS \$13042 VDD \$15350 sg13g2_buf_1
* cell instance $39889 r0 *1 54.24,343.98
X$39889 VSS \$23002 VDD \$22658 sg13g2_buf_1
* cell instance $39890 r0 *1 130.08,192.78
X$39890 VSS \$12655 VDD \$12890 sg13g2_buf_1
* cell instance $39891 r0 *1 323.52,185.22
X$39891 VSS \$2444 VDD \$7205 sg13g2_buf_1
* cell instance $39892 r0 *1 40.8,253.26
X$39892 VSS \$16231 VDD \$16127 sg13g2_buf_1
* cell instance $39893 r0 *1 159.36,291.06
X$39893 VSS \$21041 VDD \$19663 sg13g2_buf_1
* cell instance $39894 r0 *1 73.92,207.9
X$39894 VSS \$14202 VDD \$13126 sg13g2_buf_1
* cell instance $39895 r0 *1 218.88,253.26
X$39895 VSS \$12234 VDD \$18703 sg13g2_buf_1
* cell instance $39896 r0 *1 230.88,275.94
X$39896 VSS \$12057 VDD \$18907 sg13g2_buf_1
* cell instance $39897 r0 *1 334.08,207.9
X$39897 VSS trip_set_sel VDD \$14068 sg13g2_buf_1
* cell instance $39898 r0 *1 66.24,328.86
X$39898 VSS \$23652 VDD \$23096 sg13g2_buf_1
* cell instance $39899 r0 *1 200.16,64.26
X$39899 VSS \$252 VDD \$1026 sg13g2_buf_1
* cell instance $39900 r0 *1 120.96,268.38
X$39900 VSS \$19413 VDD \$19906 sg13g2_buf_1
* cell instance $39901 r0 *1 269.76,132.3
X$39901 VSS \$5678 VDD \$8637 sg13g2_buf_1
* cell instance $39902 r0 *1 334.08,260.82
X$39902 VSS \$19477 VDD \$19514 sg13g2_buf_1
* cell instance $39903 r0 *1 219.84,306.18
X$39903 VSS \$20762 VDD \$19666 sg13g2_buf_1
* cell instance $39904 r0 *1 220.8,253.26
X$39904 VSS \$13977 VDD \$16119 sg13g2_buf_1
* cell instance $39905 r0 *1 334.08,18.9
X$39905 VSS \$599 VDD \$1009 sg13g2_buf_1
* cell instance $39906 r0 *1 81.12,253.26
X$39906 VSS \$16127 VDD \$8905 sg13g2_buf_1
* cell instance $39907 r0 *1 209.76,86.94
X$39907 VSS \$3326 VDD \$2907 sg13g2_buf_1
* cell instance $39908 r0 *1 140.16,298.62
X$39908 VSS \$18907 VDD \$21643 sg13g2_buf_1
* cell instance $39909 r0 *1 86.4,306.18
X$39909 VSS \$22658 VDD \$19717 sg13g2_buf_1
* cell instance $39910 r0 *1 131.52,94.5
X$39910 VSS \$2337 VDD \$1135 sg13g2_buf_1
* cell instance $39911 r0 *1 45.6,94.5
X$39911 VSS \$3147 VDD \$3791 sg13g2_buf_1
* cell instance $39912 r0 *1 108.96,238.14
X$39912 VSS \$15937 VDD \$15927 sg13g2_buf_1
* cell instance $39913 r0 *1 207.36,200.34
X$39913 VSS \$11875 VDD \$12221 sg13g2_buf_1
* cell instance $39914 r0 *1 80.16,94.5
X$39914 VSS \$3791 VDD \$2097 sg13g2_buf_1
* cell instance $39915 r0 *1 144.48,215.46
X$39915 VSS \$12973 VDD \$15650 sg13g2_buf_1
* cell instance $39916 r0 *1 291.84,56.7
X$39916 VSS \$1783 VDD \$1346 sg13g2_buf_1
* cell instance $39917 r0 *1 129.6,94.5
X$39917 VSS \$4174 VDD \$2337 sg13g2_buf_1
* cell instance $39918 r0 *1 256.8,207.9
X$39918 VSS \$13700 VDD \$14404 sg13g2_buf_1
* cell instance $39919 r0 *1 167.04,94.5
X$39919 VSS \$3721 VDD \$3318 sg13g2_buf_1
* cell instance $39920 r0 *1 168.96,94.5
X$39920 VSS \$3318 VDD \$1135 sg13g2_buf_1
* cell instance $39921 r0 *1 170.88,94.5
X$39921 VSS \$1135 VDD \$2097 sg13g2_buf_1
* cell instance $39922 r0 *1 172.8,94.5
X$39922 VSS \$2097 VDD \$5546 sg13g2_buf_1
* cell instance $39923 r0 *1 17.28,170.1
X$39923 VSS \$10271 VDD \$7950 sg13g2_buf_1
* cell instance $39924 r0 *1 43.68,94.5
X$39924 VSS \$3291 VDD \$3147 sg13g2_buf_1
* cell instance $39925 r0 *1 135.84,275.94
X$39925 VSS \$19906 VDD \$19911 sg13g2_buf_1
* cell instance $39926 r0 *1 222.72,253.26
X$39926 VSS \$13442 VDD \$17875 sg13g2_buf_1
* cell instance $39927 r0 *1 332.16,306.18
X$39927 VSS \$22595 VDD \$22721 sg13g2_buf_1
* cell instance $39928 r0 *1 193.44,298.62
X$39928 VSS \$20664 VDD \$20658 sg13g2_buf_1
* cell instance $39929 r0 *1 183.36,328.86
X$39929 VSS \$16082 VDD \$16473 sg13g2_buf_1
* cell instance $39930 r0 *1 85.44,71.82
X$39930 VSS \$2319 VDD \$3791 sg13g2_buf_1
* cell instance $39931 r0 *1 218.88,79.38
X$39931 VSS \$1213 VDD \$1026 sg13g2_buf_1
* cell instance $39932 r0 *1 77.28,86.94
X$39932 VSS \$3490 VDD \$3791 sg13g2_buf_1
* cell instance $39933 r0 *1 103.2,245.7
X$39933 VSS \$13660 VDD \$15650 sg13g2_buf_1
* cell instance $39934 r0 *1 59.04,215.46
X$39934 VSS \$14984 VDD \$14195 sg13g2_buf_1
* cell instance $39935 r0 *1 239.52,102.06
X$39935 VSS \$1792 VDD \$2393 sg13g2_buf_1
* cell instance $39936 r0 *1 216.96,79.38
X$39936 VSS \$2393 VDD \$2429 sg13g2_buf_1
* cell instance $39937 r0 *1 52.8,215.46
X$39937 VSS \$14011 VDD \$13126 sg13g2_buf_1
* cell instance $39938 r0 *1 8.16,291.06
X$39938 VSS \$21530 VDD \$22165 sg13g2_buf_1
* cell instance $39939 r0 *1 83.04,109.62
X$39939 VSS \$4987 VDD \$6266 sg13g2_buf_1
* cell instance $39940 r0 *1 135.84,245.7
X$39940 VSS \$15650 VDD \$18045 sg13g2_buf_1
* cell instance $39941 r0 *1 338.4,223.02
X$39941 VSS trip_cause[0] VDD \$14670 sg13g2_buf_1
* cell instance $39942 r0 *1 128.16,207.9
X$39942 VSS \$12968 VDD \$13309 sg13g2_buf_1
* cell instance $39943 r0 *1 168.96,223.02
X$39943 VSS \$15649 VDD \$14999 sg13g2_buf_1
* cell instance $39944 r0 *1 162.72,223.02
X$39944 VSS \$13579 VDD \$14999 sg13g2_buf_1
* cell instance $39945 r0 *1 202.08,64.26
X$39945 VSS \$1678 VDD \$470 sg13g2_buf_1
* cell instance $39946 r0 *1 213.6,253.26
X$39946 VSS \$17437 VDD \$15312 sg13g2_buf_1
* cell instance $39947 r0 *1 202.56,215.46
X$39947 VSS \$12221 VDD \$14404 sg13g2_buf_1
* cell instance $39948 r0 *1 80.16,215.46
X$39948 VSS \$13126 VDD \$14999 sg13g2_buf_1
* cell instance $39949 r0 *1 247.2,102.06
X$39949 VSS \$1103 VDD \$288 sg13g2_buf_1
* cell instance $39950 r0 *1 78.24,215.46
X$39950 VSS \$13144 VDD \$13794 sg13g2_buf_1
* cell instance $39951 r0 *1 339.84,275.94
X$39951 VSS \$20558 VDD \$15111 sg13g2_buf_1
* cell instance $39952 r0 *1 169.44,18.9
X$39952 VSS \$419 VDD \$481 sg13g2_buf_1
* cell instance $39953 r0 *1 349.92,275.94
X$39953 VSS \$16918 VDD por_n sg13g2_buf_1
* cell instance $39954 r0 *1 349.92,170.1
X$39954 VSS cmp_clk VDD \$11531 sg13g2_buf_1
* cell instance $39955 r0 *1 86.4,268.38
X$39955 VSS \$19717 VDD \$19987 sg13g2_buf_1
* cell instance $39956 r0 *1 178.08,298.62
X$39956 VSS \$13585 VDD \$21441 sg13g2_buf_1
* cell instance $39957 r0 *1 343.2,223.02
X$39957 VSS \$15717 VDD \$14462 sg13g2_buf_1
* cell instance $39958 r0 *1 206.4,64.26
X$39958 VSS \$1462 VDD \$165 sg13g2_buf_1
* cell instance $39959 r0 *1 259.2,26.46
X$39959 VSS \$1346 VDD \$1012 sg13g2_buf_1
* cell instance $39960 r0 *1 228.96,132.3
X$39960 VSS \$5175 VDD \$8637 sg13g2_buf_1
* cell instance $39961 r0 *1 250.08,139.86
X$39961 VSS \$5751 VDD \$7919 sg13g2_buf_1
* cell instance $39962 r0 *1 276.48,132.3
X$39962 VSS \$5514 VDD \$6847 sg13g2_buf_1
* cell instance $39963 r0 *1 245.28,283.5
X$39963 VSS \$13228 VDD \$21066 sg13g2_buf_1
* cell instance $39964 r0 *1 125.76,245.7
X$39964 VSS \$15846 VDD \$17051 sg13g2_buf_1
* cell instance $39965 r0 *1 166.56,238.14
X$39965 VSS \$17050 VDD \$14999 sg13g2_buf_1
* cell instance $39966 r0 *1 216,162.54
X$39966 VSS \$10302 VDD \$9117 sg13g2_buf_1
* cell instance $39967 r0 *1 152.16,336.42
X$39967 VSS \$24057 VDD \$22120 sg13g2_buf_1
* cell instance $39968 r0 *1 127.68,245.7
X$39968 VSS \$15847 VDD \$17434 sg13g2_buf_1
* cell instance $39969 r0 *1 213.12,260.82
X$39969 VSS \$14841 VDD \$15675 sg13g2_buf_1
* cell instance $39970 r0 *1 247.2,283.5
X$39970 VSS \$20458 VDD \$21056 sg13g2_buf_1
* cell instance $39971 r0 *1 211.2,260.82
X$39971 VSS \$15375 VDD \$19437 sg13g2_buf_1
* cell instance $39972 r0 *1 299.04,215.46
X$39972 VSS \$12059 VDD \$15168 sg13g2_buf_1
* cell instance $39973 r0 *1 204.48,291.06
X$39973 VSS \$20195 VDD \$21710 sg13g2_buf_1
* cell instance $39974 r0 *1 253.44,215.46
X$39974 VSS \$14404 VDD \$15263 sg13g2_buf_1
* cell instance $39975 r0 *1 159.36,170.1
X$39975 VSS \$10865 VDD \$9034 sg13g2_buf_1
* cell instance $39976 r0 *1 173.76,49.14
X$39976 VSS \$1775 VDD \$1135 sg13g2_buf_1
* cell instance $39977 r0 *1 340.32,223.02
X$39977 VSS \$13985 VDD \$12564 sg13g2_buf_1
* cell instance $39978 r0 *1 44.16,313.74
X$39978 VSS \$22165 VDD \$22658 sg13g2_buf_1
* cell instance $39979 r0 *1 93.6,132.3
X$39979 VSS \$6266 VDD \$9034 sg13g2_buf_1
* cell instance $39980 r0 *1 77.28,291.06
X$39980 VSS \$21006 VDD \$19720 sg13g2_buf_1
* cell instance $39981 r0 *1 181.44,192.78
X$39981 VSS \$11483 VDD \$13816 sg13g2_buf_1
* cell instance $39982 r0 *1 126.24,34.02
X$39982 VSS \$29 VDD \$1431 sg13g2_buf_1
* cell instance $39983 r0 *1 86.88,291.06
X$39983 VSS \$20917 VDD \$19717 sg13g2_buf_1
* cell instance $39984 r0 *1 145.92,207.9
X$39984 VSS \$12638 VDD \$13000 sg13g2_buf_1
* cell instance $39985 r0 *1 294.72,298.62
X$39985 VSS \$22589 VDD \$22721 sg13g2_buf_1
* cell instance $39986 r0 *1 215.04,79.38
X$39986 VSS \$1597 VDD \$288 sg13g2_buf_1
* cell instance $39987 r0 *1 93.12,56.7
X$39987 VSS \$534 VDD \$2097 sg13g2_buf_1
* cell instance $39988 r0 *1 171.84,139.86
X$39988 VSS \$6180 VDD \$9034 sg13g2_buf_1
* cell instance $39989 r0 *1 343.2,253.26
X$39989 VSS \$5546 VDD \$17143 sg13g2_buf_1
* cell instance $39990 r0 *1 348,223.02
X$39990 VSS osc_en VDD \$13849 sg13g2_buf_1
* cell instance $39991 r0 *1 86.4,34.02
X$39991 VSS \$69 VDD \$534 sg13g2_buf_1
* cell instance $39992 r0 *1 112.32,200.34
X$39992 VSS \$13664 VDD \$13794 sg13g2_buf_1
* cell instance $39993 r0 *1 92.64,64.26
X$39993 VSS \$1411 VDD \$534 sg13g2_buf_1
* cell instance $39994 r0 *1 185.76,49.14
X$39994 VSS \$1026 VDD \$1597 sg13g2_buf_1
* cell instance $39995 r0 *1 349.44,215.46
X$39995 VSS osc_trim[3] VDD \$13307 sg13g2_buf_1
* cell instance $39996 r0 *1 88.32,321.3
X$39996 VSS \$23530 VDD \$21692 sg13g2_buf_1
* cell instance $39997 r0 *1 82.08,230.58
X$39997 VSS \$15927 VDD \$13794 sg13g2_buf_1
* cell instance $39998 r0 *1 245.76,215.46
X$39998 VSS \$12681 VDD \$14404 sg13g2_buf_1
* cell instance $39999 r0 *1 225.12,283.5
X$39999 VSS \$20342 VDD \$21056 sg13g2_buf_1
* cell instance $40000 r0 *1 88.32,170.1
X$40000 VSS \$9252 VDD \$10452 sg13g2_buf_1
* cell instance $40001 r0 *1 211.68,124.74
X$40001 VSS \$7362 VDD \$6196 sg13g2_buf_1
* cell instance $40002 r0 *1 300.96,207.9
X$40002 VSS \$13617 VDD \$14109 sg13g2_buf_1
* cell instance $40003 r0 *1 134.4,162.54
X$40003 VSS \$9107 VDD \$10865 sg13g2_buf_1
* cell instance $40004 r0 *1 346.56,253.26
X$40004 VSS bgr_r4 VDD \$17465 sg13g2_buf_1
* cell instance $40005 r0 *1 348.48,253.26
X$40005 VSS \$15567 VDD \$14109 sg13g2_buf_1
* cell instance $40006 r0 *1 114.24,223.02
X$40006 VSS \$13735 VDD \$13579 sg13g2_buf_1
* cell instance $40007 r0 *1 139.68,245.7
X$40007 VSS \$16781 VDD \$15350 sg13g2_buf_1
* cell instance $40008 r0 *1 225.12,192.78
X$40008 VSS \$11772 VDD \$12234 sg13g2_buf_1
* cell instance $40009 r0 *1 327.36,192.78
X$40009 VSS \$8925 VDD \$11201 sg13g2_buf_1
* cell instance $40010 r0 *1 298.08,170.1
X$40010 VSS \$10887 VDD \$6847 sg13g2_buf_1
* cell instance $40011 r0 *1 220.32,139.86
X$40011 VSS \$6196 VDD \$7919 sg13g2_buf_1
* cell instance $40012 r0 *1 132.96,328.86
X$40012 VSS \$22667 VDD \$21692 sg13g2_buf_1
* cell instance $40013 r0 *1 104.16,306.18
X$40013 VSS \$22481 VDD \$21692 sg13g2_buf_1
* cell instance $40014 r0 *1 309.6,170.1
X$40014 VSS \$7205 VDD \$9157 sg13g2_buf_1
* cell instance $40015 r0 *1 169.92,139.86
X$40015 VSS \$7346 VDD \$6180 sg13g2_buf_1
* cell instance $40016 r0 *1 285.12,34.02
X$40016 VSS \$165 VDD \$1597 sg13g2_buf_1
* cell instance $40017 r0 *1 349.92,268.38
X$40017 VSS t2f_mode VDD \$17905 sg13g2_buf_1
* cell instance $40018 r0 *1 235.68,343.98
X$40018 VSS dac_soft[0] VDD \$22696 sg13g2_buf_1
* cell instance $40019 r0 *1 348,268.38
X$40019 VSS osc_trim[0] VDD \$18487 sg13g2_buf_1
* cell instance $40020 r0 *1 46.08,245.7
X$40020 VSS \$17640 VDD \$17405 sg13g2_buf_1
* cell instance $40021 r0 *1 260.16,343.98
X$40021 VSS dac_soft[6] VDD \$24508 sg13g2_buf_1
* cell instance $40022 r0 *1 336.48,223.02
X$40022 VSS \$13711 VDD cmp_hard sg13g2_buf_1
* cell instance $40023 r0 *1 93.12,253.26
X$40023 VSS \$17405 VDD \$14999 sg13g2_buf_1
* cell instance $40024 r0 *1 336,192.78
X$40024 VSS osc_trim[1] VDD \$13851 sg13g2_buf_1
* cell instance $40025 r0 *1 214.08,102.06
X$40025 VSS \$5634 VDD \$6196 sg13g2_buf_1
* cell instance $40026 r0 *1 214.08,162.54
X$40026 VSS \$9117 VDD \$11018 sg13g2_buf_1
* cell instance $40027 r0 *1 107.04,275.94
X$40027 VSS \$19720 VDD \$20592 sg13g2_buf_1
* cell instance $40028 r0 *1 45.12,238.14
X$40028 VSS \$15633 VDD \$17405 sg13g2_buf_1
* cell instance $40029 r0 *1 325.44,185.22
X$40029 VSS fault_n VDD \$12695 sg13g2_buf_1
* cell instance $40030 r0 *1 233.76,268.38
X$40030 VSS \$18466 VDD \$18638 sg13g2_buf_1
* cell instance $40031 r0 *1 213.12,268.38
X$40031 VSS \$19666 VDD \$20038 sg13g2_buf_1
* cell instance $40032 r0 *1 132.96,154.98
X$40032 VSS \$9259 VDD \$9107 sg13g2_buf_1
* cell instance $40033 r0 *1 227.52,154.98
X$40033 VSS \$8637 VDD \$9824 sg13g2_buf_1
* cell instance $40034 r0 *1 233.76,343.98
X$40034 VSS dac_soft[1] VDD \$23018 sg13g2_buf_1
* cell instance $40035 r0 *1 333.6,343.98
X$40035 VSS \$24627 VDD \$22595 sg13g2_buf_1
* cell instance $40036 r0 *1 205.44,200.34
X$40036 VSS \$10872 VDD \$13820 sg13g2_buf_1
* cell instance $40037 r0 *1 179.52,192.78
X$40037 VSS \$12298 VDD \$13116 sg13g2_buf_1
* cell instance $40038 r0 *1 334.08,192.78
X$40038 VSS fast_en VDD \$13244 sg13g2_buf_1
* cell instance $40039 r0 *1 204.96,245.7
X$40039 VSS \$15947 VDD \$17437 sg13g2_buf_1
* cell instance $40040 r0 *1 274.08,26.46
X$40040 VSS \$1008 VDD \$599 sg13g2_buf_1
* cell instance $40041 r0 *1 36.48,64.26
X$40041 VSS \$2197 VDD \$3147 sg13g2_buf_1
* cell instance $40042 r0 *1 237.6,245.7
X$40042 VSS \$16152 VDD \$13433 sg13g2_buf_1
* cell instance $40043 r0 *1 131.04,56.7
X$40043 VSS \$1431 VDD \$1135 sg13g2_buf_1
* cell instance $40044 r0 *1 273.6,321.3
X$40044 VSS \$22715 VDD \$20903 sg13g2_buf_1
* cell instance $40045 r0 *1 144,245.7
X$40045 VSS \$15350 VDD \$17823 sg13g2_buf_1
* cell instance $40046 r0 *1 245.28,245.7
X$40046 VSS \$16843 VDD \$18237 sg13g2_buf_1
* cell instance $40047 r0 *1 339.36,253.26
X$40047 VSS \$15693 VDD \$14109 sg13g2_buf_1
* cell instance $40048 r0 *1 27.84,18.9
X$40048 VSS \$223 VDD \$804 sg13g2_buf_1
* cell instance $40049 r0 *1 48.48,26.46
X$40049 VSS \$68 VDD \$804 sg13g2_buf_1
* cell instance $40050 r0 *1 184.32,170.1
X$40050 VSS \$9824 VDD \$11258 sg13g2_buf_1
* cell instance $40051 r0 *1 161.76,26.46
X$40051 VSS \$52 VDD \$1135 sg13g2_buf_1
* cell instance $40052 r0 *1 212.16,313.74
X$40052 VSS \$22678 VDD \$23117 sg13g2_buf_1
* cell instance $40053 r0 *1 43.2,260.82
X$40053 VSS \$14299 VDD \$11195 sg13g2_buf_1
* cell instance $40054 r0 *1 233.76,185.22
X$40054 VSS \$11901 VDD \$11969 sg13g2_buf_1
* cell instance $40055 r0 *1 295.68,192.78
X$40055 VSS \$12313 VDD \$14109 sg13g2_buf_1
* cell instance $40056 r0 *1 164.16,268.38
X$40056 VSS \$19987 VDD \$5546 sg13g2_buf_1
* cell instance $40057 r0 *1 168,268.38
X$40057 VSS \$19911 VDD \$19987 sg13g2_buf_1
* cell instance $40058 r0 *1 88.32,268.38
X$40058 VSS \$19899 VDD \$19717 sg13g2_buf_1
* cell instance $40059 r0 *1 93.12,18.9
X$40059 VSS \$73 VDD \$534 sg13g2_buf_1
* cell instance $40060 r0 *1 166.08,268.38
X$40060 VSS \$19663 VDD \$19911 sg13g2_buf_1
* cell instance $40061 r0 *1 255.36,343.98
X$40061 VSS dac_hard[4] VDD \$22408 sg13g2_buf_1
* cell instance $40062 r0 *1 257.28,343.98
X$40062 VSS dac_hard[6] VDD \$22703 sg13g2_buf_1
* cell instance $40063 r0 *1 306.72,56.7
X$40063 VSS \$2758 VDD \$1020 sg13g2_buf_1
* cell instance $40064 r0 *1 226.56,185.22
X$40064 VSS \$11266 VDD \$13181 sg13g2_buf_1
* cell instance $40065 r0 *1 152.16,215.46
X$40065 VSS \$14893 VDD \$13116 sg13g2_buf_1
* cell instance $40066 r0 *1 240.48,177.66
X$40066 VSS \$11663 VDD \$11503 sg13g2_buf_1
* cell instance $40067 r0 *1 248.16,253.26
X$40067 VSS \$14405 VDD \$15857 sg13g2_buf_1
* cell instance $40068 r0 *1 137.76,245.7
X$40068 VSS \$15647 VDD \$15650 sg13g2_buf_1
* cell instance $40069 r0 *1 337.44,253.26
X$40069 VSS \$17917 VDD \$15693 sg13g2_buf_1
* cell instance $40070 r0 *1 213.12,147.42
X$40070 VSS \$5675 VDD \$9639 sg13g2_buf_1
* cell instance $40071 r0 *1 316.32,26.46
X$40071 VSS \$1468 VDD \$1020 sg13g2_buf_1
* cell instance $40072 r0 *1 8.16,253.26
X$40072 VSS clk_div_out VDD \$18723 sg13g2_buf_1
* cell instance $40073 r0 *1 41.76,117.18
X$40073 VSS \$4974 VDD \$6148 sg13g2_buf_1
* cell instance $40074 m0 *1 233.28,64.26
X$40074 VDD VSS \$2979 \$2869 sg13g2_dlygate4sd3_1
* cell instance $40075 m0 *1 202.08,26.46
X$40075 VDD VSS \$875 \$282 sg13g2_dlygate4sd3_1
* cell instance $40076 m0 *1 331.68,132.3
X$40076 VDD VSS \$5438 \$4075 sg13g2_dlygate4sd3_1
* cell instance $40077 m0 *1 44.64,306.18
X$40077 VDD VSS \$22370 \$22761 sg13g2_dlygate4sd3_1
* cell instance $40078 m0 *1 346.08,26.46
X$40078 VDD VSS \$587 \$795 sg13g2_dlygate4sd3_1
* cell instance $40079 m0 *1 37.44,298.62
X$40079 VDD VSS \$21951 \$20991 sg13g2_dlygate4sd3_1
* cell instance $40080 m0 *1 12.96,336.42
X$40080 VDD VSS \$24418 \$24630 sg13g2_dlygate4sd3_1
* cell instance $40081 m0 *1 339.36,26.46
X$40081 VDD VSS \$595 \$801 sg13g2_dlygate4sd3_1
* cell instance $40082 m0 *1 106.08,351.54
X$40082 VDD VSS \$24949 \$24989 sg13g2_dlygate4sd3_1
* cell instance $40083 m0 *1 308.16,132.3
X$40083 VDD VSS \$1682 \$5249 sg13g2_dlygate4sd3_1
* cell instance $40084 m0 *1 182.88,343.98
X$40084 VDD VSS \$24918 \$24754 sg13g2_dlygate4sd3_1
* cell instance $40085 m0 *1 40.32,306.18
X$40085 VDD VSS \$22369 \$22443 sg13g2_dlygate4sd3_1
* cell instance $40086 m0 *1 270.24,109.62
X$40086 VDD VSS \$793 \$633 sg13g2_dlygate4sd3_1
* cell instance $40087 m0 *1 233.76,34.02
X$40087 VDD VSS \$1206 \$1979 sg13g2_dlygate4sd3_1
* cell instance $40088 m0 *1 146.88,321.3
X$40088 VDD VSS \$23341 \$23411 sg13g2_dlygate4sd3_1
* cell instance $40089 m0 *1 74.4,321.3
X$40089 VDD VSS \$23386 \$23779 sg13g2_dlygate4sd3_1
* cell instance $40090 m0 *1 267.84,102.06
X$40090 VDD VSS \$3050 \$2853 sg13g2_dlygate4sd3_1
* cell instance $40091 m0 *1 50.88,313.74
X$40091 VDD VSS \$23084 \$23082 sg13g2_dlygate4sd3_1
* cell instance $40092 m0 *1 23.04,215.46
X$40092 VDD VSS \$14441 \$14007 sg13g2_dlygate4sd3_1
* cell instance $40093 m0 *1 347.52,200.34
X$40093 VDD VSS \$13248 \$12935 sg13g2_dlygate4sd3_1
* cell instance $40094 m0 *1 331.2,102.06
X$40094 VDD VSS \$5940 \$5685 sg13g2_dlygate4sd3_1
* cell instance $40095 m0 *1 181.44,18.9
X$40095 VDD VSS \$177 \$34 sg13g2_dlygate4sd3_1
* cell instance $40096 m0 *1 193.44,34.02
X$40096 VDD VSS \$250 \$937 sg13g2_dlygate4sd3_1
* cell instance $40097 m0 *1 10.08,245.7
X$40097 VDD VSS \$17765 \$15396 sg13g2_dlygate4sd3_1
* cell instance $40098 m0 *1 202.08,41.58
X$40098 VDD VSS \$1575 \$175 sg13g2_dlygate4sd3_1
* cell instance $40099 m0 *1 173.76,343.98
X$40099 VDD VSS \$24907 \$25137 sg13g2_dlygate4sd3_1
* cell instance $40100 m0 *1 169.92,147.42
X$40100 VDD VSS \$8842 \$10835 sg13g2_dlygate4sd3_1
* cell instance $40101 m0 *1 113.76,328.86
X$40101 VDD VSS \$23257 \$22866 sg13g2_dlygate4sd3_1
* cell instance $40102 m0 *1 8.64,336.42
X$40102 VDD VSS \$24843 \$24301 sg13g2_dlygate4sd3_1
* cell instance $40103 m0 *1 85.92,313.74
X$40103 VDD VSS \$22922 \$23058 sg13g2_dlygate4sd3_1
* cell instance $40104 m0 *1 197.76,41.58
X$40104 VDD VSS \$1339 \$1679 sg13g2_dlygate4sd3_1
* cell instance $40105 m0 *1 279.84,124.74
X$40105 VDD VSS \$1501 \$290 sg13g2_dlygate4sd3_1
* cell instance $40106 m0 *1 313.44,124.74
X$40106 VDD VSS \$3203 \$4635 sg13g2_dlygate4sd3_1
* cell instance $40107 m0 *1 222.24,49.14
X$40107 VDD VSS \$1905 \$1978 sg13g2_dlygate4sd3_1
* cell instance $40108 m0 *1 347.52,245.7
X$40108 VDD VSS \$17145 \$17484 sg13g2_dlygate4sd3_1
* cell instance $40109 m0 *1 34.08,291.06
X$40109 VDD VSS \$20990 \$22603 sg13g2_dlygate4sd3_1
* cell instance $40110 m0 *1 78.24,351.54
X$40110 VDD VSS \$25086 \$24644 sg13g2_dlygate4sd3_1
* cell instance $40111 m0 *1 324.48,147.42
X$40111 VDD VSS \$6903 \$102 sg13g2_dlygate4sd3_1
* cell instance $40112 m0 *1 328.8,147.42
X$40112 VDD VSS \$3079 \$3360 sg13g2_dlygate4sd3_1
* cell instance $40113 m0 *1 215.04,34.02
X$40113 VDD VSS \$924 \$1004 sg13g2_dlygate4sd3_1
* cell instance $40114 m0 *1 203.04,18.9
X$40114 VDD VSS \$189 \$181 sg13g2_dlygate4sd3_1
* cell instance $40115 m0 *1 313.92,147.42
X$40115 VDD VSS \$1795 \$2085 sg13g2_dlygate4sd3_1
* cell instance $40116 m0 *1 312.48,132.3
X$40116 VDD VSS \$2083 \$2453 sg13g2_dlygate4sd3_1
* cell instance $40117 m0 *1 326.88,154.98
X$40117 VDD VSS \$2765 \$2637 sg13g2_dlygate4sd3_1
* cell instance $40118 m0 *1 347.52,162.54
X$40118 VDD VSS \$3752 \$3535 sg13g2_dlygate4sd3_1
* cell instance $40119 m0 *1 305.28,34.02
X$40119 VDD VSS \$1070 \$1234 sg13g2_dlygate4sd3_1
* cell instance $40120 m0 *1 318.24,147.42
X$40120 VDD VSS \$4631 \$802 sg13g2_dlygate4sd3_1
* cell instance $40121 m0 *1 239.52,71.82
X$40121 VDD VSS \$3137 \$2957 sg13g2_dlygate4sd3_1
* cell instance $40122 m0 *1 263.52,79.38
X$40122 VDD VSS \$3524 \$3819 sg13g2_dlygate4sd3_1
* cell instance $40123 m0 *1 210.72,41.58
X$40123 VDD VSS \$1322 \$1715 sg13g2_dlygate4sd3_1
* cell instance $40124 m0 *1 308.64,139.86
X$40124 VDD VSS \$2391 \$2113 sg13g2_dlygate4sd3_1
* cell instance $40125 m0 *1 312.48,117.18
X$40125 VDD VSS \$4824 \$5988 sg13g2_dlygate4sd3_1
* cell instance $40126 m0 *1 247.68,86.94
X$40126 VDD VSS \$926 \$1328 sg13g2_dlygate4sd3_1
* cell instance $40127 m0 *1 287.04,34.02
X$40127 VDD VSS \$1550 \$1085 sg13g2_dlygate4sd3_1
* cell instance $40128 m0 *1 240.96,56.7
X$40128 VDD VSS \$2076 \$2378 sg13g2_dlygate4sd3_1
* cell instance $40129 m0 *1 297.12,132.3
X$40129 VDD VSS \$1801 \$1708 sg13g2_dlygate4sd3_1
* cell instance $40130 m0 *1 215.04,41.58
X$40130 VDD VSS \$1650 \$1269 sg13g2_dlygate4sd3_1
* cell instance $40131 m0 *1 322.08,124.74
X$40131 VDD VSS \$5193 \$4857 sg13g2_dlygate4sd3_1
* cell instance $40132 m0 *1 206.4,41.58
X$40132 VDD VSS \$1603 \$1460 sg13g2_dlygate4sd3_1
* cell instance $40133 m0 *1 256.32,86.94
X$40133 VDD VSS \$2383 \$3048 sg13g2_dlygate4sd3_1
* cell instance $40134 m0 *1 303.84,132.3
X$40134 VDD VSS \$2470 \$1947 sg13g2_dlygate4sd3_1
* cell instance $40135 m0 *1 206.4,26.46
X$40135 VDD VSS \$706 \$887 sg13g2_dlygate4sd3_1
* cell instance $40136 m0 *1 10.56,321.3
X$40136 VDD VSS \$23515 \$23729 sg13g2_dlygate4sd3_1
* cell instance $40137 m0 *1 82.56,351.54
X$40137 VDD VSS \$23814 \$25228 sg13g2_dlygate4sd3_1
* cell instance $40138 m0 *1 317.76,124.74
X$40138 VDD VSS \$4388 \$3355 sg13g2_dlygate4sd3_1
* cell instance $40139 m0 *1 110.4,351.54
X$40139 VDD VSS \$24995 \$25084 sg13g2_dlygate4sd3_1
* cell instance $40140 m0 *1 217.92,49.14
X$40140 VDD VSS \$1983 \$1968 sg13g2_dlygate4sd3_1
* cell instance $40141 m0 *1 252,86.94
X$40141 VDD VSS \$2079 \$2384 sg13g2_dlygate4sd3_1
* cell instance $40142 m0 *1 343.2,162.54
X$40142 VDD VSS \$3069 \$3063 sg13g2_dlygate4sd3_1
* cell instance $40143 m0 *1 312.96,139.86
X$40143 VDD VSS \$2762 \$2398 sg13g2_dlygate4sd3_1
* cell instance $40144 m0 *1 288.48,132.3
X$40144 VDD VSS \$1491 \$1470 sg13g2_dlygate4sd3_1
* cell instance $40145 m0 *1 338.88,162.54
X$40145 VDD VSS \$2498 \$2247 sg13g2_dlygate4sd3_1
* cell instance $40146 m0 *1 331.2,154.98
X$40146 VDD VSS \$2433 \$3070 sg13g2_dlygate4sd3_1
* cell instance $40147 m0 *1 60.96,313.74
X$40147 VDD VSS \$23439 \$23089 sg13g2_dlygate4sd3_1
* cell instance $40148 m0 *1 301.92,109.62
X$40148 VDD VSS \$5427 \$4632 sg13g2_dlygate4sd3_1
* cell instance $40149 m0 *1 22.56,268.38
X$40149 VDD VSS \$19768 \$19063 sg13g2_dlygate4sd3_1
* cell instance $40150 m0 *1 59.04,306.18
X$40150 VDD VSS \$22373 \$23907 sg13g2_dlygate4sd3_1
* cell instance $40151 m0 *1 147.36,177.66
X$40151 VDD VSS \$11594 \$11695 sg13g2_dlygate4sd3_1
* cell instance $40152 m0 *1 194.4,18.9
X$40152 VDD VSS \$157 \$242 sg13g2_dlygate4sd3_1
* cell instance $40153 m0 *1 25.44,275.94
X$40153 VDD VSS \$20264 \$19970 sg13g2_dlygate4sd3_1
* cell instance $40154 m0 *1 198.72,18.9
X$40154 VDD VSS \$494 \$2 sg13g2_dlygate4sd3_1
* cell instance $40155 m0 *1 36.96,313.74
X$40155 VDD VSS \$22906 \$23075 sg13g2_dlygate4sd3_1
* cell instance $40156 m0 *1 189.12,26.46
X$40156 VDD VSS \$474 \$666 sg13g2_dlygate4sd3_1
* cell instance $40157 m0 *1 325.92,71.82
X$40157 VDD VSS \$3371 \$3557 sg13g2_dlygate4sd3_1
* cell instance $40158 m0 *1 288.48,124.74
X$40158 VDD VSS \$1237 \$1333 sg13g2_dlygate4sd3_1
* cell instance $40159 m0 *1 153.6,343.98
X$40159 VDD VSS \$24902 \$24750 sg13g2_dlygate4sd3_1
* cell instance $40160 m0 *1 254.88,102.06
X$40160 VDD VSS \$287 \$797 sg13g2_dlygate4sd3_1
* cell instance $40161 m0 *1 197.76,34.02
X$40161 VDD VSS \$1091 \$846 sg13g2_dlygate4sd3_1
* cell instance $40162 m0 *1 296.16,102.06
X$40162 VDD VSS \$4629 \$4472 sg13g2_dlygate4sd3_1
* cell instance $40163 m0 *1 37.92,321.3
X$40163 VDD VSS \$23369 \$23747 sg13g2_dlygate4sd3_1
* cell instance $40164 m0 *1 305.28,147.42
X$40164 VDD VSS \$1688 \$2256 sg13g2_dlygate4sd3_1
* cell instance $40165 m0 *1 33.6,321.3
X$40165 VDD VSS \$23360 \$23074 sg13g2_dlygate4sd3_1
* cell instance $40166 m0 *1 309.6,147.42
X$40166 VDD VSS \$2103 \$2764 sg13g2_dlygate4sd3_1
* cell instance $40167 m0 *1 49.92,321.3
X$40167 VDD VSS \$23478 \$23081 sg13g2_dlygate4sd3_1
* cell instance $40168 m0 *1 14.88,321.3
X$40168 VDD VSS \$22750 \$23070 sg13g2_dlygate4sd3_1
* cell instance $40169 m0 *1 189.12,34.02
X$40169 VDD VSS \$373 \$999 sg13g2_dlygate4sd3_1
* cell instance $40170 m0 *1 216.48,71.82
X$40170 VDD VSS \$3432 \$3327 sg13g2_dlygate4sd3_1
* cell instance $40171 m0 *1 292.32,64.26
X$40171 VDD VSS \$2826 \$2934 sg13g2_dlygate4sd3_1
* cell instance $40172 m0 *1 185.76,18.9
X$40172 VDD VSS \$24 \$156 sg13g2_dlygate4sd3_1
* cell instance $40173 m0 *1 193.44,26.46
X$40173 VDD VSS \$789 \$341 sg13g2_dlygate4sd3_1
* cell instance $40174 m0 *1 65.76,313.74
X$40174 VDD VSS \$22917 \$22915 sg13g2_dlygate4sd3_1
* cell instance $40175 m0 *1 25.44,291.06
X$40175 VDD VSS \$21339 \$21342 sg13g2_dlygate4sd3_1
* cell instance $40176 m0 *1 41.28,313.74
X$40176 VDD VSS \$23212 \$23077 sg13g2_dlygate4sd3_1
* cell instance $40177 m0 *1 56.64,321.3
X$40177 VDD VSS \$23088 \$23378 sg13g2_dlygate4sd3_1
* cell instance $40178 m0 *1 332.16,117.18
X$40178 VDD VSS \$5895 \$6466 sg13g2_dlygate4sd3_1
* cell instance $40179 m0 *1 8.16,291.06
X$40179 VDD VSS \$21858 \$21120 sg13g2_dlygate4sd3_1
* cell instance $40180 m0 *1 22.56,223.02
X$40180 VDD VSS \$15395 \$14975 sg13g2_dlygate4sd3_1
* cell instance $40181 m0 *1 197.76,26.46
X$40181 VDD VSS \$569 \$285 sg13g2_dlygate4sd3_1
* cell instance $40182 m0 *1 190.08,18.9
X$40182 VDD VSS \$125 \$155 sg13g2_dlygate4sd3_1
* cell instance $40183 m0 *1 36,306.18
X$40183 VDD VSS \$22368 \$22079 sg13g2_dlygate4sd3_1
* cell instance $40184 m0 *1 263.52,102.06
X$40184 VDD VSS \$1914 \$1964 sg13g2_dlygate4sd3_1
* cell instance $40185 m0 *1 284.16,124.74
X$40185 VDD VSS \$1706 \$1517 sg13g2_dlygate4sd3_1
* cell instance $40186 m0 *1 259.2,102.06
X$40186 VDD VSS \$1695 \$1017 sg13g2_dlygate4sd3_1
* cell instance $40187 m0 *1 103.2,336.42
X$40187 VDD VSS \$24335 \$23097 sg13g2_dlygate4sd3_1
* cell instance $40188 m0 *1 265.92,109.62
X$40188 VDD VSS \$1343 \$6596 sg13g2_dlygate4sd3_1
* cell instance $40189 m0 *1 158.88,170.1
X$40189 VDD VSS \$11126 \$11188 sg13g2_dlygate4sd3_1
* cell instance $40190 m0 *1 274.56,109.62
X$40190 VDD VSS \$1818 \$2136 sg13g2_dlygate4sd3_1
* cell instance $40191 m0 *1 277.92,117.18
X$40191 VDD VSS \$1080 \$836 sg13g2_dlygate4sd3_1
* cell instance $40192 m0 *1 55.2,313.74
X$40192 VDD VSS \$24433 \$22652 sg13g2_dlygate4sd3_1
* cell instance $40193 m0 *1 293.28,117.18
X$40193 VDD VSS \$6083 \$3604 sg13g2_dlygate4sd3_1
* cell instance $40194 m0 *1 283.2,109.62
X$40194 VDD VSS \$3052 \$4819 sg13g2_dlygate4sd3_1
* cell instance $40195 m0 *1 346.56,71.82
X$40195 VDD VSS \$3530 \$4087 sg13g2_dlygate4sd3_1
* cell instance $40196 m0 *1 285.6,102.06
X$40196 VDD VSS \$4187 \$4387 sg13g2_dlygate4sd3_1
* cell instance $40197 m0 *1 292.8,124.74
X$40197 VDD VSS \$1803 \$2130 sg13g2_dlygate4sd3_1
* cell instance $40198 m0 *1 196.8,298.62
X$40198 VDD VSS \$22629 \$21936 sg13g2_dlygate4sd3_1
* cell instance $40199 m0 *1 46.56,313.74
X$40199 VDD VSS \$22768 \$22650 sg13g2_dlygate4sd3_1
* cell instance $40200 m0 *1 273.6,117.18
X$40200 VDD VSS \$1212 \$928 sg13g2_dlygate4sd3_1
* cell instance $40201 m0 *1 29.76,291.06
X$40201 VDD VSS \$21346 \$20987 sg13g2_dlygate4sd3_1
* cell instance $40202 m0 *1 297.6,117.18
X$40202 VDD VSS \$3735 \$3937 sg13g2_dlygate4sd3_1
* cell instance $40203 m0 *1 278.88,109.62
X$40203 VDD VSS \$3049 \$4497 sg13g2_dlygate4sd3_1
* cell instance $40204 m0 *1 306.24,117.18
X$40204 VDD VSS \$5429 \$4155 sg13g2_dlygate4sd3_1
* cell instance $40205 m0 *1 347.04,215.46
X$40205 VDD VSS \$14083 \$13858 sg13g2_dlygate4sd3_1
* cell instance $40206 m0 *1 292.8,132.3
X$40206 VDD VSS \$1225 \$1341 sg13g2_dlygate4sd3_1
* cell instance $40207 m0 *1 180.48,26.46
X$40207 VDD VSS \$166 \$877 sg13g2_dlygate4sd3_1
* cell instance $40208 m0 *1 42.24,321.3
X$40208 VDD VSS \$23475 \$23371 sg13g2_dlygate4sd3_1
* cell instance $40209 m0 *1 184.8,26.46
X$40209 VDD VSS \$627 \$163 sg13g2_dlygate4sd3_1
* cell instance $40210 m0 *1 48.96,306.18
X$40210 VDD VSS \$22371 \$22447 sg13g2_dlygate4sd3_1
* cell instance $40211 m0 *1 277.92,102.06
X$40211 VDD VSS \$3526 \$3393 sg13g2_dlygate4sd3_1
* cell instance $40212 m0 *1 301.92,117.18
X$40212 VDD VSS \$3186 \$3098 sg13g2_dlygate4sd3_1
* cell instance $40213 m0 *1 282.24,117.18
X$40213 VDD VSS \$1916 \$1211 sg13g2_dlygate4sd3_1
* cell instance $40214 m0 *1 180.96,124.74
X$40214 VDD VSS \$8225 \$7688 sg13g2_dlygate4sd3_1
* cell instance $40215 m0 *1 272.16,102.06
X$40215 VDD VSS \$2246 \$3398 sg13g2_dlygate4sd3_1
* cell instance $40216 m0 *1 287.52,117.18
X$40216 VDD VSS \$2753 \$1710 sg13g2_dlygate4sd3_1
* cell instance $40217 r0 *1 86.4,328.86
X$40217 VDD VSS \$24144 \$23983 sg13g2_dlygate4sd3_1
* cell instance $40218 r0 *1 305.76,109.62
X$40218 VDD VSS \$4889 \$5191 sg13g2_dlygate4sd3_1
* cell instance $40219 r0 *1 206.88,11.34
X$40219 VDD VSS \$130 \$93 sg13g2_dlygate4sd3_1
* cell instance $40220 r0 *1 328.32,49.14
X$40220 VDD VSS \$2399 \$2396 sg13g2_dlygate4sd3_1
* cell instance $40221 r0 *1 211.2,11.34
X$40221 VDD VSS \$192 \$423 sg13g2_dlygate4sd3_1
* cell instance $40222 r0 *1 188.64,34.02
X$40222 VDD VSS \$1203 \$581 sg13g2_dlygate4sd3_1
* cell instance $40223 r0 *1 12,343.98
X$40223 VDD VSS \$24934 \$25046 sg13g2_dlygate4sd3_1
* cell instance $40224 r0 *1 205.92,34.02
X$40224 VDD VSS \$1353 \$1266 sg13g2_dlygate4sd3_1
* cell instance $40225 r0 *1 9.12,283.5
X$40225 VDD VSS \$21113 \$20985 sg13g2_dlygate4sd3_1
* cell instance $40226 r0 *1 191.52,18.9
X$40226 VDD VSS \$393 \$333 sg13g2_dlygate4sd3_1
* cell instance $40227 r0 *1 8.16,268.38
X$40227 VDD VSS \$20258 \$19889 sg13g2_dlygate4sd3_1
* cell instance $40228 r0 *1 210.24,34.02
X$40228 VDD VSS \$1112 \$1348 sg13g2_dlygate4sd3_1
* cell instance $40229 r0 *1 331.68,139.86
X$40229 VDD VSS \$4395 \$3066 sg13g2_dlygate4sd3_1
* cell instance $40230 r0 *1 287.04,102.06
X$40230 VDD VSS \$3241 \$3794 sg13g2_dlygate4sd3_1
* cell instance $40231 r0 *1 45.12,298.62
X$40231 VDD VSS \$22178 \$22173 sg13g2_dlygate4sd3_1
* cell instance $40232 r0 *1 193.92,11.34
X$40232 VDD VSS \$33 \$12 sg13g2_dlygate4sd3_1
* cell instance $40233 r0 *1 40.8,298.62
X$40233 VDD VSS \$22649 \$22648 sg13g2_dlygate4sd3_1
* cell instance $40234 r0 *1 312.96,132.3
X$40234 VDD VSS \$3060 \$2803 sg13g2_dlygate4sd3_1
* cell instance $40235 r0 *1 285.12,109.62
X$40235 VDD VSS \$2149 \$2150 sg13g2_dlygate4sd3_1
* cell instance $40236 r0 *1 71.52,313.74
X$40236 VDD VSS \$23244 \$23092 sg13g2_dlygate4sd3_1
* cell instance $40237 r0 *1 287.04,117.18
X$40237 VDD VSS \$1810 \$1015 sg13g2_dlygate4sd3_1
* cell instance $40238 r0 *1 311.52,109.62
X$40238 VDD VSS \$4633 \$5230 sg13g2_dlygate4sd3_1
* cell instance $40239 r0 *1 38.4,313.74
X$40239 VDD VSS \$23438 \$23205 sg13g2_dlygate4sd3_1
* cell instance $40240 r0 *1 311.52,147.42
X$40240 VDD VSS \$2634 \$2086 sg13g2_dlygate4sd3_1
* cell instance $40241 r0 *1 313.44,124.74
X$40241 VDD VSS \$2759 \$3571 sg13g2_dlygate4sd3_1
* cell instance $40242 r0 *1 66.24,321.3
X$40242 VDD VSS \$23523 \$23595 sg13g2_dlygate4sd3_1
* cell instance $40243 r0 *1 280.32,102.06
X$40243 VDD VSS \$4524 \$2831 sg13g2_dlygate4sd3_1
* cell instance $40244 r0 *1 330.24,154.98
X$40244 VDD VSS \$1324 \$1497 sg13g2_dlygate4sd3_1
* cell instance $40245 r0 *1 22.56,215.46
X$40245 VDD VSS \$14919 \$14293 sg13g2_dlygate4sd3_1
* cell instance $40246 r0 *1 67.2,313.74
X$40246 VDD VSS \$23091 \$23090 sg13g2_dlygate4sd3_1
* cell instance $40247 r0 *1 9.12,275.94
X$40247 VDD VSS \$20256 \$19773 sg13g2_dlygate4sd3_1
* cell instance $40248 r0 *1 54.24,328.86
X$40248 VDD VSS \$24129 \$24310 sg13g2_dlygate4sd3_1
* cell instance $40249 r0 *1 120,328.86
X$40249 VDD VSS \$23815 \$23991 sg13g2_dlygate4sd3_1
* cell instance $40250 r0 *1 25.44,268.38
X$40250 VDD VSS \$19935 \$19890 sg13g2_dlygate4sd3_1
* cell instance $40251 r0 *1 222.24,41.58
X$40251 VDD VSS \$1455 \$1458 sg13g2_dlygate4sd3_1
* cell instance $40252 r0 *1 46.08,313.74
X$40252 VDD VSS \$23220 \$23045 sg13g2_dlygate4sd3_1
* cell instance $40253 r0 *1 75.84,313.74
X$40253 VDD VSS \$23095 \$24588 sg13g2_dlygate4sd3_1
* cell instance $40254 r0 *1 342.24,109.62
X$40254 VDD VSS \$4399 \$4638 sg13g2_dlygate4sd3_1
* cell instance $40255 r0 *1 80.16,313.74
X$40255 VDD VSS \$23057 \$23247 sg13g2_dlygate4sd3_1
* cell instance $40256 r0 *1 49.92,328.86
X$40256 VDD VSS \$23906 \$23988 sg13g2_dlygate4sd3_1
* cell instance $40257 r0 *1 178.56,18.9
X$40257 VDD VSS \$54 \$572 sg13g2_dlygate4sd3_1
* cell instance $40258 r0 *1 310.08,102.06
X$40258 VDD VSS \$6273 \$5196 sg13g2_dlygate4sd3_1
* cell instance $40259 r0 *1 197.28,34.02
X$40259 VDD VSS \$832 \$326 sg13g2_dlygate4sd3_1
* cell instance $40260 r0 *1 346.56,79.38
X$40260 VDD VSS \$4639 \$5049 sg13g2_dlygate4sd3_1
* cell instance $40261 r0 *1 16.32,343.98
X$40261 VDD VSS \$24981 \$24980 sg13g2_dlygate4sd3_1
* cell instance $40262 r0 *1 344.64,71.82
X$40262 VDD VSS \$3941 \$3754 sg13g2_dlygate4sd3_1
* cell instance $40263 r0 *1 215.52,11.34
X$40263 VDD VSS \$159 \$158 sg13g2_dlygate4sd3_1
* cell instance $40264 r0 *1 282.72,117.18
X$40264 VDD VSS \$1787 \$1019 sg13g2_dlygate4sd3_1
* cell instance $40265 r0 *1 344.64,124.74
X$40265 VDD VSS \$5204 \$5906 sg13g2_dlygate4sd3_1
* cell instance $40266 r0 *1 220.8,56.7
X$40266 VDD VSS \$2873 \$2872 sg13g2_dlygate4sd3_1
* cell instance $40267 r0 *1 9.6,192.78
X$40267 VDD VSS \$13575 \$13856 sg13g2_dlygate4sd3_1
* cell instance $40268 r0 *1 23.52,321.3
X$40268 VDD VSS \$23464 \$22903 sg13g2_dlygate4sd3_1
* cell instance $40269 r0 *1 340.32,71.82
X$40269 VDD VSS \$4404 \$5924 sg13g2_dlygate4sd3_1
* cell instance $40270 r0 *1 187.2,18.9
X$40270 VDD VSS \$325 \$108 sg13g2_dlygate4sd3_1
* cell instance $40271 r0 *1 249.6,71.82
X$40271 VDD VSS \$2379 \$3519 sg13g2_dlygate4sd3_1
* cell instance $40272 r0 *1 240.96,71.82
X$40272 VDD VSS \$2911 \$1911 sg13g2_dlygate4sd3_1
* cell instance $40273 r0 *1 273.6,86.94
X$40273 VDD VSS \$4947 \$4191 sg13g2_dlygate4sd3_1
* cell instance $40274 r0 *1 327.36,124.74
X$40274 VDD VSS \$4852 \$5053 sg13g2_dlygate4sd3_1
* cell instance $40275 r0 *1 318.72,124.74
X$40275 VDD VSS \$3582 \$3087 sg13g2_dlygate4sd3_1
* cell instance $40276 r0 *1 323.04,124.74
X$40276 VDD VSS \$3745 \$6246 sg13g2_dlygate4sd3_1
* cell instance $40277 r0 *1 236.64,71.82
X$40277 VDD VSS \$2381 \$1207 sg13g2_dlygate4sd3_1
* cell instance $40278 r0 *1 291.36,102.06
X$40278 VDD VSS \$3825 \$3775 sg13g2_dlygate4sd3_1
* cell instance $40279 r0 *1 255.84,71.82
X$40279 VDD VSS \$3125 \$2690 sg13g2_dlygate4sd3_1
* cell instance $40280 r0 *1 266.4,79.38
X$40280 VDD VSS \$4711 \$3810 sg13g2_dlygate4sd3_1
* cell instance $40281 r0 *1 300.96,117.18
X$40281 VDD VSS \$2390 \$2757 sg13g2_dlygate4sd3_1
* cell instance $40282 r0 *1 278.4,117.18
X$40282 VDD VSS \$2084 \$1938 sg13g2_dlygate4sd3_1
* cell instance $40283 r0 *1 26.4,275.94
X$40283 VDD VSS \$20952 \$20511 sg13g2_dlygate4sd3_1
* cell instance $40284 r0 *1 182.88,18.9
X$40284 VDD VSS \$392 \$286 sg13g2_dlygate4sd3_1
* cell instance $40285 r0 *1 292.32,117.18
X$40285 VDD VSS \$2243 \$2254 sg13g2_dlygate4sd3_1
* cell instance $40286 r0 *1 278.88,86.94
X$40286 VDD VSS \$4927 \$4628 sg13g2_dlygate4sd3_1
* cell instance $40287 r0 *1 267.84,109.62
X$40287 VDD VSS \$823 \$480 sg13g2_dlygate4sd3_1
* cell instance $40288 r0 *1 268.8,94.5
X$40288 VDD VSS \$2751 \$2626 sg13g2_dlygate4sd3_1
* cell instance $40289 r0 *1 292.8,132.3
X$40289 VDD VSS \$1683 \$1685 sg13g2_dlygate4sd3_1
* cell instance $40290 r0 *1 192.96,124.74
X$40290 VDD VSS \$7796 \$8004 sg13g2_dlygate4sd3_1
* cell instance $40291 r0 *1 202.56,11.34
X$40291 VDD VSS \$63 \$182 sg13g2_dlygate4sd3_1
* cell instance $40293 r0 *1 204.96,26.46
X$40293 VDD VSS \$244 \$922 sg13g2_dlygate4sd3_1
* cell instance $40294 r0 *1 219.84,49.14
X$40294 VDD VSS \$2170 \$2239 sg13g2_dlygate4sd3_1
* cell instance $40295 r0 *1 204.48,94.5
X$40295 VDD VSS \$4047 \$5401 sg13g2_dlygate4sd3_1
* cell instance $40296 r0 *1 161.76,328.86
X$40296 VDD VSS \$23917 \$22571 sg13g2_dlygate4sd3_1
* cell instance $40297 r0 *1 189.6,11.34
X$40297 VDD VSS \$11 \$115 sg13g2_dlygate4sd3_1
* cell instance $40298 r0 *1 198.24,11.34
X$40298 VDD VSS \$94 \$16 sg13g2_dlygate4sd3_1
* cell instance $40299 r0 *1 27.84,321.3
X$40299 VDD VSS \$23037 \$23516 sg13g2_dlygate4sd3_1
* cell instance $40300 r0 *1 309.12,124.74
X$40300 VDD VSS \$4460 \$2633 sg13g2_dlygate4sd3_1
* cell instance $40301 r0 *1 274.08,117.18
X$40301 VDD VSS \$1216 \$1337 sg13g2_dlygate4sd3_1
* cell instance $40302 r0 *1 43.68,306.18
X$40302 VDD VSS \$22766 \$22606 sg13g2_dlygate4sd3_1
* cell instance $40303 r0 *1 296.64,117.18
X$40303 VDD VSS \$3220 \$2631 sg13g2_dlygate4sd3_1
* cell instance $40304 r0 *1 8.16,313.74
X$40304 VDD VSS \$23034 \$22434 sg13g2_dlygate4sd3_1
* cell instance $40305 r0 *1 252.48,86.94
X$40305 VDD VSS \$1208 \$1913 sg13g2_dlygate4sd3_1
* cell instance $40306 r0 *1 44.64,230.58
X$40306 VDD VSS \$16012 \$16125 sg13g2_dlygate4sd3_1
* cell instance $40307 r0 *1 36.48,298.62
X$40307 VDD VSS \$22031 \$22080 sg13g2_dlygate4sd3_1
* cell instance $40308 r0 *1 332.64,64.26
X$40308 VDD VSS \$790 \$3359 sg13g2_dlygate4sd3_1
* cell instance $40309 r0 *1 331.68,117.18
X$40309 VDD VSS \$4636 \$4843 sg13g2_dlygate4sd3_1
* cell instance $40310 r0 *1 344.64,102.06
X$40310 VDD VSS \$5200 \$5430 sg13g2_dlygate4sd3_1
* cell instance $40311 r0 *1 70.56,321.3
X$40311 VDD VSS \$23388 \$23524 sg13g2_dlygate4sd3_1
* cell instance $40312 r0 *1 195.84,18.9
X$40312 VDD VSS \$374 \$363 sg13g2_dlygate4sd3_1
* cell instance $40313 r0 *1 300,139.86
X$40313 VDD VSS \$2259 \$1924 sg13g2_dlygate4sd3_1
* cell instance $40314 r0 *1 308.64,132.3
X$40314 VDD VSS \$1797 \$1697 sg13g2_dlygate4sd3_1
* cell instance $40315 r0 *1 340.32,102.06
X$40315 VDD VSS \$6619 \$6218 sg13g2_dlygate4sd3_1
* cell instance $40316 r0 *1 192.96,34.02
X$40316 VDD VSS \$936 \$1482 sg13g2_dlygate4sd3_1
* cell instance $40317 r0 *1 347.52,109.62
X$40317 VDD VSS \$5694 \$5202 sg13g2_dlygate4sd3_1
* cell instance $40318 r0 *1 315.84,79.38
X$40318 VDD VSS \$4143 \$4394 sg13g2_dlygate4sd3_1
* cell instance $40319 r0 *1 297.12,132.3
X$40319 VDD VSS \$1954 \$1232 sg13g2_dlygate4sd3_1
* cell instance $40320 r0 *1 331.2,147.42
X$40320 VDD VSS \$3543 \$3758 sg13g2_dlygate4sd3_1
* cell instance $40321 r0 *1 262.08,79.38
X$40321 VDD VSS \$3738 \$3620 sg13g2_dlygate4sd3_1
* cell instance $40322 r0 *1 330.24,132.3
X$40322 VDD VSS \$4129 \$4654 sg13g2_dlygate4sd3_1
* cell instance $40323 r0 *1 228.48,71.82
X$40323 VDD VSS \$3141 \$3662 sg13g2_dlygate4sd3_1
* cell instance $40324 r0 *1 347.52,154.98
X$40324 VDD VSS \$4084 \$4416 sg13g2_dlygate4sd3_1
* cell instance $40325 r0 *1 245.76,11.34
X$40325 VDD VSS \$96 \$689 sg13g2_dlygate4sd3_1
* cell instance $40326 r0 *1 245.28,71.82
X$40326 VDD VSS \$2909 \$1912 sg13g2_dlygate4sd3_1
* cell instance $40327 r0 *1 107.04,321.3
X$40327 VDD VSS \$22865 \$23609 sg13g2_dlygate4sd3_1
* cell instance $40328 r0 *1 61.92,321.3
X$40328 VDD VSS \$23197 \$23767 sg13g2_dlygate4sd3_1
* cell instance $40329 r0 *1 345.6,49.14
X$40329 VDD VSS \$2404 \$2406 sg13g2_dlygate4sd3_1
* cell instance $40330 r0 *1 200.16,18.9
X$40330 VDD VSS \$497 \$348 sg13g2_dlygate4sd3_1
* cell instance $40331 r0 *1 24.96,291.06
X$40331 VDD VSS \$20910 \$21531 sg13g2_dlygate4sd3_1
* cell instance $40332 r0 *1 209.28,26.46
X$40332 VDD VSS \$952 \$923 sg13g2_dlygate4sd3_1
* cell instance $40333 r0 *1 202.08,41.58
X$40333 VDD VSS \$1066 \$1022 sg13g2_dlygate4sd3_1
* cell instance $40334 r0 *1 201.6,34.02
X$40334 VDD VSS \$1106 \$1095 sg13g2_dlygate4sd3_1
* cell instance $40335 r0 *1 68.16,328.86
X$40335 VDD VSS \$24320 \$23979 sg13g2_dlygate4sd3_1
* cell instance $40336 r0 *1 301.44,132.3
X$40336 VDD VSS \$114 \$3575 sg13g2_dlygate4sd3_1
* cell instance $40337 r0 *1 303.36,124.74
X$40337 VDD VSS \$2134 \$2478 sg13g2_dlygate4sd3_1
* cell instance $40338 m0 *1 220.8,268.38
X$40338 VDD VSS \$19601 \$19669 \$19091 sg13g2_nand2b_1
* cell instance $40339 m0 *1 56.64,306.18
X$40339 VDD VSS \$20650 \$21006 \$22618 sg13g2_nand2b_1
* cell instance $40340 m0 *1 139.2,306.18
X$40340 VDD VSS \$20414 \$21549 \$22495 sg13g2_nand2b_1
* cell instance $40341 m0 *1 271.68,328.86
X$40341 VDD VSS \$23456 \$16311 \$23835 sg13g2_nand2b_1
* cell instance $40342 m0 *1 237.6,154.98
X$40342 VDD VSS \$9833 \$9834 \$10061 sg13g2_nand2b_1
* cell instance $40343 m0 *1 85.92,64.26
X$40343 VDD VSS \$2877 \$1756 \$2812 sg13g2_nand2b_1
* cell instance $40344 m0 *1 48,253.26
X$40344 VDD VSS \$17005 \$17986 \$17184 sg13g2_nand2b_1
* cell instance $40345 m0 *1 36,215.46
X$40345 VDD VSS \$14299 \$14298 \$14680 sg13g2_nand2b_1
* cell instance $40346 m0 *1 23.04,170.1
X$40346 VDD VSS \$10038 \$9493 \$10853 sg13g2_nand2b_1
* cell instance $40347 m0 *1 122.88,238.14
X$40347 VDD VSS \$16627 \$16273 \$16628 sg13g2_nand2b_1
* cell instance $40348 m0 *1 63.36,192.78
X$40348 VDD VSS \$12885 \$11990 \$12943 sg13g2_nand2b_1
* cell instance $40349 m0 *1 27.84,71.82
X$40349 VDD VSS \$3194 \$2037 \$3538 sg13g2_nand2b_1
* cell instance $40350 m0 *1 312,245.7
X$40350 VDD VSS \$16812 \$16430 \$17475 sg13g2_nand2b_1
* cell instance $40351 m0 *1 302.88,336.42
X$40351 VDD VSS \$23717 \$21085 \$24621 sg13g2_nand2b_1
* cell instance $40352 m0 *1 83.52,238.14
X$40352 VDD VSS \$16965 \$15928 \$16266 sg13g2_nand2b_1
* cell instance $40353 m0 *1 45.6,177.66
X$40353 VDD VSS \$11449 \$10528 \$11447 sg13g2_nand2b_1
* cell instance $40354 m0 *1 159.36,207.9
X$40354 VDD VSS \$13966 \$12342 \$14149 sg13g2_nand2b_1
* cell instance $40355 m0 *1 240.96,328.86
X$40355 VDD VSS \$24545 \$24027 \$24019 sg13g2_nand2b_1
* cell instance $40356 m0 *1 203.52,94.5
X$40356 VDD VSS \$5023 \$4331 \$5096 sg13g2_nand2b_1
* cell instance $40357 m0 *1 76.32,253.26
X$40357 VDD VSS \$17413 \$17794 \$17650 sg13g2_nand2b_1
* cell instance $40358 m0 *1 221.28,328.86
X$40358 VDD VSS \$23697 \$14170 \$23123 sg13g2_nand2b_1
* cell instance $40359 m0 *1 326.4,291.06
X$40359 VDD VSS \$20693 \$21096 \$21357 sg13g2_nand2b_1
* cell instance $40360 m0 *1 223.68,328.86
X$40360 VDD VSS \$23125 \$14170 \$23312 sg13g2_nand2b_1
* cell instance $40361 m0 *1 23.04,124.74
X$40361 VDD VSS \$7022 \$6396 \$7661 sg13g2_nand2b_1
* cell instance $40362 m0 *1 263.04,313.74
X$40362 VDD VSS \$22884 \$22709 \$22885 sg13g2_nand2b_1
* cell instance $40363 m0 *1 329.76,177.66
X$40363 VDD VSS \$11297 \$11519 \$11943 sg13g2_nand2b_1
* cell instance $40364 m0 *1 138.72,238.14
X$40364 VDD VSS \$16279 \$16282 \$16283 sg13g2_nand2b_1
* cell instance $40365 m0 *1 155.52,230.58
X$40365 VDD VSS \$15644 \$15353 \$16067 sg13g2_nand2b_1
* cell instance $40366 m0 *1 217.44,56.7
X$40366 VDD VSS \$3328 \$1270 \$2706 sg13g2_nand2b_1
* cell instance $40367 m0 *1 330.72,298.62
X$40367 VDD VSS \$21852 \$17693 \$21590 sg13g2_nand2b_1
* cell instance $40368 m0 *1 176.16,207.9
X$40368 VDD VSS \$12660 \$13967 \$14047 sg13g2_nand2b_1
* cell instance $40369 m0 *1 156.96,245.7
X$40369 VDD VSS \$16888 \$16796 \$17586 sg13g2_nand2b_1
* cell instance $40370 m0 *1 252.96,245.7
X$40370 VDD VSS \$14911 \$17364 \$16329 sg13g2_nand2b_1
* cell instance $40371 m0 *1 205.44,109.62
X$40371 VDD VSS \$6436 \$5391 \$5024 sg13g2_nand2b_1
* cell instance $40372 m0 *1 43.2,215.46
X$40372 VDD VSS \$14305 \$14304 \$14979 sg13g2_nand2b_1
* cell instance $40373 m0 *1 172.8,192.78
X$40373 VDD VSS \$13000 \$12222 \$12530 sg13g2_nand2b_1
* cell instance $40374 m0 *1 194.88,49.14
X$40374 VDD VSS \$1888 \$781 \$2560 sg13g2_nand2b_1
* cell instance $40375 m0 *1 246.72,260.82
X$40375 VDD VSS \$18469 \$18814 \$17331 sg13g2_nand2b_1
* cell instance $40376 m0 *1 277.92,306.18
X$40376 VDD VSS \$18529 \$20607 \$22511 sg13g2_nand2b_1
* cell instance $40377 m0 *1 157.44,238.14
X$40377 VDD VSS \$16286 \$15944 \$16901 sg13g2_nand2b_1
* cell instance $40378 m0 *1 176.16,351.54
X$40378 VDD VSS \$23920 \$23542 \$24480 sg13g2_nand2b_1
* cell instance $40379 m0 *1 170.4,192.78
X$40379 VDD VSS \$12660 \$11704 \$12659 sg13g2_nand2b_1
* cell instance $40380 r0 *1 324.96,275.94
X$40380 VDD VSS \$18008 \$20464 \$20367 sg13g2_nand2b_1
* cell instance $40381 r0 *1 63.36,230.58
X$40381 VDD VSS \$16244 \$16243 \$16006 sg13g2_nand2b_1
* cell instance $40382 r0 *1 225.12,260.82
X$40382 VDD VSS \$17876 \$18466 \$19189 sg13g2_nand2b_1
* cell instance $40383 r0 *1 33.12,185.22
X$40383 VDD VSS \$12327 \$11304 \$12744 sg13g2_nand2b_1
* cell instance $40384 r0 *1 240.96,253.26
X$40384 VDD VSS \$18793 \$17880 \$16838 sg13g2_nand2b_1
* cell instance $40385 r0 *1 186.24,34.02
X$40385 VDD VSS \$1317 \$337 \$1289 sg13g2_nand2b_1
* cell instance $40386 r0 *1 27.84,102.06
X$40386 VDD VSS \$6138 \$4832 \$5914 sg13g2_nand2b_1
* cell instance $40387 r0 *1 211.68,343.98
X$40387 VDD VSS \$23695 \$23928 \$23692 sg13g2_nand2b_1
* cell instance $40388 r0 *1 250.08,245.7
X$40388 VDD VSS \$17684 \$17455 \$17087 sg13g2_nand2b_1
* cell instance $40389 r0 *1 66.24,26.46
X$40389 VDD VSS \$899 \$36 \$900 sg13g2_nand2b_1
* cell instance $40390 r0 *1 61.44,56.7
X$40390 VDD VSS \$2317 \$1390 \$2040 sg13g2_nand2b_1
* cell instance $40391 r0 *1 256.8,283.5
X$40391 VDD VSS \$21071 \$18473 \$21411 sg13g2_nand2b_1
* cell instance $40392 r0 *1 324.96,170.1
X$40392 VDD VSS \$11296 \$9492 \$9157 sg13g2_nand2b_1
* cell instance $40393 r0 *1 327.36,170.1
X$40393 VDD VSS \$11523 \$11526 \$10182 \$9157 sg13g2_nand3b_1
* cell instance $40394 r0 *1 332.16,177.66
X$40394 VDD VSS \$11519 \$11297 \$12385 sg13g2_nand2b_1
* cell instance $40395 r0 *1 22.56,185.22
X$40395 VDD VSS \$12324 \$10968 \$12572 sg13g2_nand2b_1
* cell instance $40396 r0 *1 21.12,41.58
X$40396 VDD VSS \$1479 \$510 \$1806 sg13g2_nand2b_1
* cell instance $40397 r0 *1 268.8,117.18
X$40397 VDD VSS \$5731 \$6593 \$6809 sg13g2_nand2b_1
* cell instance $40398 r0 *1 237.6,343.98
X$40398 VDD VSS \$24611 \$24027 \$25027 sg13g2_nand2b_1
* cell instance $40399 r0 *1 82.08,215.46
X$40399 VDD VSS \$13144 \$13720 \$14882 sg13g2_nand2b_1
* cell instance $40400 r0 *1 259.68,192.78
X$40400 VDD VSS \$13211 \$12689 \$13094 sg13g2_nand2b_1
* cell instance $40401 r0 *1 23.04,139.86
X$40401 VDD VSS \$8682 \$8065 \$8870 sg13g2_nand2b_1
* cell instance $40402 r0 *1 237.12,328.86
X$40402 VDD VSS \$24077 \$14170 \$23930 sg13g2_nand2b_1
* cell instance $40403 r0 *1 228,321.3
X$40403 VDD VSS \$23546 \$14170 \$23126 sg13g2_nand2b_1
* cell instance $40404 r0 *1 234.72,336.42
X$40404 VDD VSS \$24542 \$14170 \$24543 sg13g2_nand2b_1
* cell instance $40405 r0 *1 227.04,268.38
X$40405 VDD VSS \$18466 \$17876 \$19190 sg13g2_nand2b_1
* cell instance $40406 r0 *1 85.44,18.9
X$40406 VDD VSS \$453 \$150 \$417 sg13g2_nand2b_1
* cell instance $40407 r0 *1 273.12,94.5
X$40407 VDD VSS \$3960 \$3521 \$5663 sg13g2_nand2b_1
* cell instance $40408 r0 *1 297.6,275.94
X$40408 VDD VSS \$17474 \$20687 \$20052 sg13g2_nand2b_1
* cell instance $40409 r0 *1 156.96,18.9
X$40409 VDD VSS \$461 \$76 \$543 sg13g2_nand2b_1
* cell instance $40410 r0 *1 43.68,41.58
X$40410 VDD VSS \$1293 \$763 \$2039 sg13g2_nand2b_1
* cell instance $40411 r0 *1 205.92,283.5
X$40411 VDD VSS \$20452 \$20532 \$20017 sg13g2_nand2b_1
* cell instance $40412 r0 *1 90.72,34.02
X$40412 VDD VSS \$907 \$146 \$1365 sg13g2_nand2b_1
* cell instance $40413 r0 *1 168.48,207.9
X$40413 VDD VSS \$14211 \$12655 \$14360 sg13g2_nand2b_1
* cell instance $40414 r0 *1 320.64,215.46
X$40414 VDD VSS \$14826 \$14422 \$14241 sg13g2_nand2b_1
* cell instance $40415 r0 *1 230.4,321.3
X$40415 VDD VSS \$23548 \$14170 \$23128 sg13g2_nand2b_1
* cell instance $40416 r0 *1 61.92,298.62
X$40416 VDD VSS \$22089 \$22090 \$21007 sg13g2_nand2b_1
* cell instance $40417 m0 *1 318.24,245.7
X$40417 VDD VSS \$17521 \$17129 \$17511 sg13g2_nand2_1
* cell instance $40418 m0 *1 107.04,200.34
X$40418 VDD VSS \$13508 \$13147 \$13042 sg13g2_nand2_1
* cell instance $40419 m0 *1 320.64,223.02
X$40419 VDD VSS \$14503 \$14670 \$14431 sg13g2_nand2_1
* cell instance $40420 m0 *1 77.28,223.02
X$40420 VDD VSS \$15333 \$14884 \$13042 sg13g2_nand2_1
* cell instance $40421 m0 *1 156,49.14
X$40421 VDD VSS \$2343 \$2218 \$2221 sg13g2_nand2_1
* cell instance $40422 m0 *1 124.32,170.1
X$40422 VDD VSS \$11360 \$11183 \$11182 sg13g2_nand2_1
* cell instance $40423 m0 *1 322.08,245.7
X$40423 VDD VSS \$17137 \$17128 \$15391 sg13g2_nand2_1
* cell instance $40424 m0 *1 163.68,109.62
X$40424 VDD VSS \$6177 \$6179 \$6331 sg13g2_nand2_1
* cell instance $40425 m0 *1 320.16,245.7
X$40425 VDD VSS \$17477 \$17120 \$15391 sg13g2_nand2_1
* cell instance $40426 m0 *1 55.68,154.98
X$40426 VDD VSS \$10444 \$9322 \$9786 sg13g2_nand2_1
* cell instance $40427 m0 *1 185.28,109.62
X$40427 VDD VSS \$6190 \$6428 \$6427 sg13g2_nand2_1
* cell instance $40428 m0 *1 141.12,26.46
X$40428 VDD VSS \$1107 \$40 \$459 sg13g2_nand2_1
* cell instance $40429 m0 *1 65.76,170.1
X$40429 VDD VSS \$11171 \$11173 \$11172 sg13g2_nand2_1
* cell instance $40430 m0 *1 38.88,215.46
X$40430 VDD VSS \$14301 \$14299 \$14646 sg13g2_nand2_1
* cell instance $40431 m0 *1 249.12,109.62
X$40431 VDD VSS \$5419 \$2959 \$5320 sg13g2_nand2_1
* cell instance $40432 m0 *1 120.96,49.14
X$40432 VDD VSS \$2132 \$1861 \$1862 sg13g2_nand2_1
* cell instance $40433 m0 *1 161.76,71.82
X$40433 VDD VSS \$3311 \$3313 \$3504 sg13g2_nand2_1
* cell instance $40434 m0 *1 160.32,79.38
X$40434 VDD VSS \$3987 \$3607 \$4194 sg13g2_nand2_1
* cell instance $40435 m0 *1 63.84,170.1
X$40435 VDD VSS \$9449 \$10632 \$11171 sg13g2_nand2_1
* cell instance $40436 m0 *1 142.56,94.5
X$40436 VDD VSS \$4789 \$5007 \$5009 sg13g2_nand2_1
* cell instance $40437 m0 *1 222.72,200.34
X$40437 VDD VSS \$12915 \$13182 \$13554 sg13g2_nand2_1
* cell instance $40438 m0 *1 170.88,86.94
X$40438 VDD VSS \$4194 \$4335 \$4616 sg13g2_nand2_1
* cell instance $40439 m0 *1 152.64,34.02
X$40439 VDD VSS \$385 \$987 \$988 sg13g2_nand2_1
* cell instance $40440 m0 *1 233.76,139.86
X$40440 VDD VSS \$8228 \$4624 \$5648 sg13g2_nand2_1
* cell instance $40441 m0 *1 136.8,215.46
X$40441 VDD VSS \$14652 \$14346 \$12637 sg13g2_nand2_1
* cell instance $40442 m0 *1 68.64,139.86
X$40442 VDD VSS \$7669 \$8560 \$8562 sg13g2_nand2_1
* cell instance $40443 m0 *1 147.84,86.94
X$40443 VDD VSS \$4035 \$3902 \$3712 sg13g2_nand2_1
* cell instance $40444 m0 *1 231.84,223.02
X$40444 VDD VSS \$15051 \$15056 \$14224 sg13g2_nand2_1
* cell instance $40445 m0 *1 114.72,18.9
X$40445 VDD VSS \$237 \$234 \$153 sg13g2_nand2_1
* cell instance $40446 m0 *1 133.92,154.98
X$40446 VDD VSS \$10117 \$9262 \$10051 sg13g2_nand2_1
* cell instance $40447 m0 *1 187.68,306.18
X$40447 VDD VSS \$22127 \$22126 \$20664 sg13g2_nand2_1
* cell instance $40448 m0 *1 60,223.02
X$40448 VDD VSS \$15128 \$14988 \$14878 sg13g2_nand2_1
* cell instance $40449 m0 *1 183.84,230.58
X$40449 VDD VSS \$15663 \$16082 \$13969 sg13g2_nand2_1
* cell instance $40450 m0 *1 136.32,26.46
X$40450 VDD VSS \$985 \$779 \$983 sg13g2_nand2_1
* cell instance $40451 m0 *1 297.12,223.02
X$40451 VDD VSS \$15384 \$12452 \$15077 sg13g2_nand2_1
* cell instance $40452 m0 *1 332.16,215.46
X$40452 VDD VSS \$14434 \$14828 \$14246 sg13g2_nand2_1
* cell instance $40453 m0 *1 46.56,215.46
X$40453 VDD VSS \$14306 \$8905 \$14874 sg13g2_nand2_1
* cell instance $40454 m0 *1 174.24,207.9
X$40454 VDD VSS \$14213 \$13967 \$12014 sg13g2_nand2_1
* cell instance $40455 m0 *1 251.04,215.46
X$40455 VDD VSS \$14757 \$14400 \$13977 sg13g2_nand2_1
* cell instance $40456 m0 *1 147.84,117.18
X$40456 VDD VSS \$7037 \$7175 \$7133 sg13g2_nand2_1
* cell instance $40457 m0 *1 223.2,177.66
X$40457 VDD VSS \$11668 \$11701 \$12227 sg13g2_nand2_1
* cell instance $40458 m0 *1 228,177.66
X$40458 VDD VSS \$11895 \$11429 \$11731 sg13g2_nand2_1
* cell instance $40459 m0 *1 190.56,283.5
X$40459 VDD VSS \$20527 \$20764 \$20665 sg13g2_nand2_1
* cell instance $40460 m0 *1 187.2,298.62
X$40460 VDD VSS \$21263 \$21934 \$20664 sg13g2_nand2_1
* cell instance $40461 m0 *1 175.68,18.9
X$40461 VDD VSS \$389 \$343 \$339 sg13g2_nand2_1
* cell instance $40462 m0 *1 308.64,283.5
X$40462 VDD VSS \$20830 \$12452 \$20795 sg13g2_nand2_1
* cell instance $40463 m0 *1 244.8,260.82
X$40463 VDD VSS \$18815 \$17879 \$18793 sg13g2_nand2_1
* cell instance $40464 m0 *1 142.56,117.18
X$40464 VDD VSS \$6776 \$7036 \$6775 sg13g2_nand2_1
* cell instance $40465 m0 *1 201.12,298.62
X$40465 VDD VSS \$21275 \$21936 \$20006 sg13g2_nand2_1
* cell instance $40466 m0 *1 145.92,117.18
X$40466 VDD VSS \$1439 \$6167 \$7037 sg13g2_nand2_1
* cell instance $40467 m0 *1 130.08,79.38
X$40467 VDD VSS \$4033 \$3709 \$3897 sg13g2_nand2_1
* cell instance $40468 m0 *1 238.56,260.82
X$40468 VDD VSS \$18796 \$17877 \$18296 sg13g2_nand2_1
* cell instance $40469 m0 *1 282.72,306.18
X$40469 VDD VSS \$22356 \$12710 \$20461 sg13g2_nand2_1
* cell instance $40470 m0 *1 259.2,253.26
X$40470 VDD VSS \$17686 \$18296 \$17684 sg13g2_nand2_1
* cell instance $40471 m0 *1 283.2,207.9
X$40471 VDD VSS \$14065 \$13598 \$13832 sg13g2_nand2_1
* cell instance $40472 m0 *1 180.96,223.02
X$40472 VDD VSS \$15036 \$15040 \$11868 sg13g2_nand2_1
* cell instance $40473 m0 *1 244.8,268.38
X$40473 VDD VSS \$17678 \$19756 \$18814 sg13g2_nand2_1
* cell instance $40474 m0 *1 108,86.94
X$40474 VDD VSS \$4299 \$3493 \$4126 sg13g2_nand2_1
* cell instance $40475 m0 *1 108.48,102.06
X$40475 VDD VSS \$6156 \$4604 \$5495 sg13g2_nand2_1
* cell instance $40476 m0 *1 79.2,223.02
X$40476 VDD VSS \$14998 \$14882 \$14318 sg13g2_nand2_1
* cell instance $40477 m0 *1 195.84,162.54
X$40477 VDD VSS \$10729 \$10645 \$10300 sg13g2_nand2_1
* cell instance $40478 m0 *1 156.48,79.38
X$40478 VDD VSS \$3614 \$3308 \$3311 sg13g2_nand2_1
* cell instance $40479 m0 *1 145.92,64.26
X$40479 VDD VSS \$3164 \$2898 \$2738 sg13g2_nand2_1
* cell instance $40480 m0 *1 117.12,283.5
X$40480 VDD VSS \$20732 \$19732 \$20751 sg13g2_nand2_1
* cell instance $40481 m0 *1 145.92,71.82
X$40481 VDD VSS \$2735 \$3307 \$2841 sg13g2_nand2_1
* cell instance $40482 m0 *1 108.96,200.34
X$40482 VDD VSS \$13792 \$13306 \$13042 sg13g2_nand2_1
* cell instance $40483 m0 *1 261.12,268.38
X$40483 VDD VSS \$19466 \$13585 \$18769 sg13g2_nand2_1
* cell instance $40484 m0 *1 263.04,268.38
X$40484 VDD VSS \$19570 \$19205 \$18769 sg13g2_nand2_1
* cell instance $40485 m0 *1 178.56,34.02
X$40485 VDD VSS \$786 \$280 \$241 sg13g2_nand2_1
* cell instance $40486 m0 *1 37.44,223.02
X$40486 VDD VSS \$14928 \$8905 \$14981 sg13g2_nand2_1
* cell instance $40487 m0 *1 244.32,102.06
X$40487 VDD VSS \$5862 \$5653 \$5860 sg13g2_nand2_1
* cell instance $40488 m0 *1 250.56,230.58
X$40488 VDD VSS \$16109 \$15276 \$16119 sg13g2_nand2_1
* cell instance $40489 m0 *1 166.08,49.14
X$40489 VDD VSS \$2291 \$1109 \$2058 sg13g2_nand2_1
* cell instance $40490 m0 *1 162.24,49.14
X$40490 VDD VSS \$2053 \$1871 \$1873 sg13g2_nand2_1
* cell instance $40491 m0 *1 276.48,223.02
X$40491 VDD VSS \$15557 \$5721 \$14405 sg13g2_nand2_1
* cell instance $40492 m0 *1 332.16,260.82
X$40492 VDD VSS \$17704 \$16912 \$15391 sg13g2_nand2_1
* cell instance $40493 m0 *1 327.36,260.82
X$40493 VDD VSS \$19124 \$17697 \$15391 sg13g2_nand2_1
* cell instance $40494 m0 *1 123.36,64.26
X$40494 VDD VSS \$2984 \$2733 \$2890 sg13g2_nand2_1
* cell instance $40495 m0 *1 31.2,245.7
X$40495 VDD VSS \$17494 \$14299 \$16988 sg13g2_nand2_1
* cell instance $40496 m0 *1 135.84,192.78
X$40496 VDD VSS \$12894 \$12638 \$12637 sg13g2_nand2_1
* cell instance $40497 m0 *1 242.88,207.9
X$40497 VDD VSS \$14165 \$14157 \$14224 sg13g2_nand2_1
* cell instance $40498 m0 *1 138.72,283.5
X$40498 VDD VSS \$21216 \$12893 \$21554 sg13g2_nand2_1
* cell instance $40499 m0 *1 156.48,132.3
X$40499 VDD VSS \$8265 \$7990 \$8548 sg13g2_nand2_1
* cell instance $40500 m0 *1 336,94.5
X$40500 VDD VSS \$5205 \$4643 \$1469 sg13g2_nand2_1
* cell instance $40501 m0 *1 39.36,238.14
X$40501 VDD VSS \$16657 \$16231 \$16243 sg13g2_nand2_1
* cell instance $40502 m0 *1 259.68,260.82
X$40502 VDD VSS \$19203 \$18823 \$19360 sg13g2_nand2_1
* cell instance $40503 m0 *1 107.04,162.54
X$40503 VDD VSS \$10457 \$10453 \$10640 sg13g2_nand2_1
* cell instance $40504 m0 *1 24.48,132.3
X$40504 VDD VSS \$7662 \$7866 \$8249 sg13g2_nand2_1
* cell instance $40505 m0 *1 111.36,238.14
X$40505 VDD VSS \$16624 \$16132 \$16781 sg13g2_nand2_1
* cell instance $40506 m0 *1 308.64,162.54
X$40506 VDD VSS \$10919 \$11038 \$10663 sg13g2_nand2_1
* cell instance $40507 m0 *1 180.48,260.82
X$40507 VDD VSS \$19913 \$12893 \$18769 sg13g2_nand2_1
* cell instance $40508 m0 *1 298.08,162.54
X$40508 VDD VSS \$5886 \$7423 \$1469 sg13g2_nand2_1
* cell instance $40509 m0 *1 306.72,162.54
X$40509 VDD VSS \$10195 \$9523 \$8475 sg13g2_nand2_1
* cell instance $40510 m0 *1 298.08,154.98
X$40510 VDD VSS \$7419 \$8697 \$8475 sg13g2_nand2_1
* cell instance $40511 m0 *1 100.32,185.22
X$40511 VDD VSS \$11843 \$12006 \$12290 sg13g2_nand2_1
* cell instance $40512 m0 *1 181.92,207.9
X$40512 VDD VSS \$13818 \$13228 \$13969 sg13g2_nand2_1
* cell instance $40513 m0 *1 121.92,328.86
X$40513 VDD VSS \$23667 \$24367 \$25118 sg13g2_nand2_1
* cell instance $40514 m0 *1 120.96,238.14
X$40514 VDD VSS \$16133 \$16627 \$16053 sg13g2_nand2_1
* cell instance $40515 m0 *1 148.8,253.26
X$40515 VDD VSS \$17822 \$17433 \$17826 sg13g2_nand2_1
* cell instance $40516 m0 *1 224.16,185.22
X$40516 VDD VSS \$12034 \$11703 \$12214 sg13g2_nand2_1
* cell instance $40517 m0 *1 254.88,313.74
X$40517 VDD VSS \$22882 \$22141 \$22707 sg13g2_nand2_1
* cell instance $40518 m0 *1 331.68,230.58
X$40518 VDD VSS \$15710 \$15979 \$15986 sg13g2_nand2_1
* cell instance $40519 m0 *1 290.88,230.58
X$40519 VDD VSS \$15816 \$13228 \$15077 sg13g2_nand2_1
* cell instance $40520 m0 *1 48.48,41.58
X$40520 VDD VSS \$1518 \$1047 \$1400 sg13g2_nand2_1
* cell instance $40521 m0 *1 46.56,147.42
X$40521 VDD VSS \$8417 \$9248 \$9249 sg13g2_nand2_1
* cell instance $40522 m0 *1 158.88,154.98
X$40522 VDD VSS \$9815 \$10164 \$10293 sg13g2_nand2_1
* cell instance $40523 m0 *1 184.32,49.14
X$40523 VDD VSS \$1897 \$2067 \$2233 sg13g2_nand2_1
* cell instance $40524 m0 *1 274.56,139.86
X$40524 VDD VSS \$9300 \$8915 \$1469 sg13g2_nand2_1
* cell instance $40525 m0 *1 123.84,245.7
X$40525 VDD VSS \$17269 \$15847 \$16781 sg13g2_nand2_1
* cell instance $40526 m0 *1 238.56,291.06
X$40526 VDD VSS \$21770 \$21064 \$19327 sg13g2_nand2_1
* cell instance $40527 m0 *1 47.52,94.5
X$40527 VDD VSS \$4984 \$4853 \$4764 sg13g2_nand2_1
* cell instance $40528 m0 *1 259.2,306.18
X$40528 VDD VSS \$22824 \$19327 \$22342 sg13g2_nand2_1
* cell instance $40529 m0 *1 83.52,117.18
X$40529 VDD VSS \$7031 \$6754 \$7167 sg13g2_nand2_1
* cell instance $40530 m0 *1 43.68,94.5
X$40530 VDD VSS \$4985 \$4430 \$4983 sg13g2_nand2_1
* cell instance $40531 m0 *1 137.28,185.22
X$40531 VDD VSS \$11692 \$11926 \$11468 sg13g2_nand2_1
* cell instance $40532 m0 *1 85.44,117.18
X$40532 VDD VSS \$6756 \$6757 \$7333 sg13g2_nand2_1
* cell instance $40533 m0 *1 77.28,238.14
X$40533 VDD VSS \$16424 \$16248 \$16781 sg13g2_nand2_1
* cell instance $40534 m0 *1 31.68,253.26
X$40534 VDD VSS \$17770 \$18494 \$16876 sg13g2_nand2_1
* cell instance $40535 m0 *1 265.44,313.74
X$40535 VDD VSS \$22709 \$22584 \$22711 sg13g2_nand2_1
* cell instance $40536 m0 *1 33.12,94.5
X$40536 VDD VSS \$4980 \$4979 \$4978 sg13g2_nand2_1
* cell instance $40537 m0 *1 173.76,200.34
X$40537 VDD VSS \$12459 \$12530 \$12659 sg13g2_nand2_1
* cell instance $40538 m0 *1 41.28,260.82
X$40538 VDD VSS \$19164 \$16231 \$17408 sg13g2_nand2_1
* cell instance $40539 m0 *1 41.76,79.38
X$40539 VDD VSS \$3885 \$3484 \$3886 sg13g2_nand2_1
* cell instance $40540 m0 *1 296.16,162.54
X$40540 VDD VSS \$3346 \$7841 \$1469 sg13g2_nand2_1
* cell instance $40541 m0 *1 323.04,170.1
X$40541 VDD VSS \$11288 \$11515 \$8925 sg13g2_nand2_1
* cell instance $40542 m0 *1 152.16,283.5
X$40542 VDD VSS \$20728 \$11897 \$20351 sg13g2_nand2_1
* cell instance $40543 m0 *1 201.6,71.82
X$40543 VDD VSS \$3324 \$3325 \$3175 sg13g2_nand2_1
* cell instance $40544 m0 *1 175.68,200.34
X$40544 VDD VSS \$12529 \$13175 \$12222 sg13g2_nand2_1
* cell instance $40545 m0 *1 109.92,260.82
X$40545 VDD VSS \$17548 \$17540 \$18275 sg13g2_nand2_1
* cell instance $40546 m0 *1 281.76,245.7
X$40546 VDD VSS \$17290 \$17112 \$17104 sg13g2_nand2_1
* cell instance $40547 m0 *1 318.72,185.22
X$40547 VDD VSS \$12186 \$12380 \$12421 sg13g2_nand2_1
* cell instance $40548 m0 *1 239.52,200.34
X$40548 VDD VSS \$13032 \$13191 \$12677 sg13g2_nand2_1
* cell instance $40549 m0 *1 177.6,200.34
X$40549 VDD VSS \$13115 \$11479 \$12344 sg13g2_nand2_1
* cell instance $40550 m0 *1 187.68,71.82
X$40550 VDD VSS \$2230 \$3135 \$3507 sg13g2_nand2_1
* cell instance $40551 m0 *1 329.76,192.78
X$40551 VDD VSS \$11296 \$11789 \$11949 sg13g2_nand2_1
* cell instance $40552 m0 *1 222.24,185.22
X$40552 VDD VSS \$12308 \$11644 \$12475 sg13g2_nand2_1
* cell instance $40553 m0 *1 289.44,154.98
X$40553 VDD VSS \$3362 \$2392 \$9847 sg13g2_nand2_1
* cell instance $40554 m0 *1 39.36,170.1
X$40554 VDD VSS \$11064 \$9609 \$10973 sg13g2_nand2_1
* cell instance $40555 m0 *1 71.52,49.14
X$40555 VDD VSS \$2043 \$1844 \$1843 sg13g2_nand2_1
* cell instance $40556 m0 *1 27.84,170.1
X$40556 VDD VSS \$10970 \$11161 \$11160 sg13g2_nand2_1
* cell instance $40557 m0 *1 277.92,313.74
X$40557 VDD VSS \$22887 \$22714 \$22151 sg13g2_nand2_1
* cell instance $40558 m0 *1 188.64,94.5
X$40558 VDD VSS \$4799 \$5014 \$4794 sg13g2_nand2_1
* cell instance $40559 m0 *1 68.16,102.06
X$40559 VDD VSS \$5366 \$5362 \$5240 sg13g2_nand2_1
* cell instance $40560 m0 *1 78.24,41.58
X$40560 VDD VSS \$1530 \$1297 \$1298 sg13g2_nand2_1
* cell instance $40561 m0 *1 109.44,139.86
X$40561 VDD VSS \$6157 \$8425 \$8426 sg13g2_nand2_1
* cell instance $40562 m0 *1 46.08,162.54
X$40562 VDD VSS \$9779 \$10444 \$10439 sg13g2_nand2_1
* cell instance $40563 m0 *1 114.24,291.06
X$40563 VDD VSS \$21434 \$21507 \$21435 sg13g2_nand2_1
* cell instance $40564 m0 *1 222.72,215.46
X$40564 VDD VSS \$13972 \$15049 \$14812 sg13g2_nand2_1
* cell instance $40565 m0 *1 187.68,124.74
X$40565 VDD VSS \$7356 \$7357 \$7359 sg13g2_nand2_1
* cell instance $40566 m0 *1 130.08,177.66
X$40566 VDD VSS \$11463 \$11088 \$11692 sg13g2_nand2_1
* cell instance $40567 m0 *1 238.08,298.62
X$40567 VDD VSS \$21842 \$19086 \$16772 sg13g2_nand2_1
* cell instance $40568 m0 *1 72.96,79.38
X$40568 VDD VSS \$3892 \$3783 \$3696 sg13g2_nand2_1
* cell instance $40569 m0 *1 63.84,18.9
X$40569 VDD VSS \$148 \$70 \$28 sg13g2_nand2_1
* cell instance $40570 r0 *1 65.28,18.9
X$40570 VSS VDD \$378 \$36 \$450 \$522 sg13g2_nand3_1
* cell instance $40571 m0 *1 332.16,223.02
X$40571 VDD VSS \$15766 \$15088 \$15391 sg13g2_nand2_1
* cell instance $40572 m0 *1 83.52,79.38
X$40572 VDD VSS \$3894 \$4122 \$4023 sg13g2_nand2_1
* cell instance $40573 m0 *1 44.16,162.54
X$40573 VDD VSS \$3884 \$11064 \$10974 sg13g2_nand2_1
* cell instance $40574 m0 *1 310.56,170.1
X$40574 VDD VSS \$11076 \$10668 \$8475 sg13g2_nand2_1
* cell instance $40575 m0 *1 63.36,124.74
X$40575 VDD VSS \$7741 \$7323 \$7669 sg13g2_nand2_1
* cell instance $40576 m0 *1 162.72,139.86
X$40576 VDD VSS \$8601 \$8893 \$8603 sg13g2_nand2_1
* cell instance $40577 m0 *1 237.6,200.34
X$40577 VDD VSS \$13029 \$13470 \$12677 sg13g2_nand2_1
* cell instance $40578 m0 *1 246.24,238.14
X$40578 VDD VSS \$16768 \$16769 \$15682 sg13g2_nand2_1
* cell instance $40579 m0 *1 111.84,185.22
X$40579 VDD VSS \$12009 \$11562 \$12335 sg13g2_nand2_1
* cell instance $40580 m0 *1 138.24,245.7
X$40580 VDD VSS \$17034 \$16286 \$16781 sg13g2_nand2_1
* cell instance $40581 m0 *1 272.64,238.14
X$40581 VDD VSS \$16540 \$14666 \$16334 sg13g2_nand2_1
* cell instance $40582 m0 *1 311.52,177.66
X$40582 VDD VSS \$2118 \$2645 \$8475 sg13g2_nand2_1
* cell instance $40583 m0 *1 336,132.3
X$40583 VDD VSS \$8666 \$8057 \$8475 sg13g2_nand2_1
* cell instance $40584 m0 *1 185.28,260.82
X$40584 VDD VSS \$19182 \$12893 \$16633 sg13g2_nand2_1
* cell instance $40585 m0 *1 70.08,185.22
X$40585 VDD VSS \$12001 \$12286 \$12285 sg13g2_nand2_1
* cell instance $40586 m0 *1 130.56,215.46
X$40586 VDD VSS \$14724 \$12818 \$14346 sg13g2_nand2_1
* cell instance $40587 m0 *1 309.12,200.34
X$40587 VDD VSS \$13235 \$13512 \$12059 sg13g2_nand2_1
* cell instance $40588 r0 *1 130.08,34.02
X$40588 VDD VSS \$1562 \$1078 \$1743 sg13g2_nand2_1
* cell instance $40589 r0 *1 115.2,117.18
X$40589 VDD VSS \$7341 \$7681 \$7172 sg13g2_nand2_1
* cell instance $40590 r0 *1 140.16,200.34
X$40590 VDD VSS \$13583 \$12818 \$12014 sg13g2_nand2_1
* cell instance $40591 r0 *1 262.08,192.78
X$40591 VDD VSS \$13010 \$12920 \$13066 sg13g2_nand2_1
* cell instance $40592 r0 *1 325.92,306.18
X$40592 VDD VSS \$22738 \$11531 \$22424 sg13g2_nand2_1
* cell instance $40593 r0 *1 224.16,71.82
X$40593 VDD VSS \$1904 \$2620 \$3515 sg13g2_nand2_1
* cell instance $40594 r0 *1 126.24,102.06
X$40594 VDD VSS \$5617 \$6161 \$6160 sg13g2_nand2_1
* cell instance $40595 r0 *1 27.36,71.82
X$40595 VDD VSS \$3684 \$3559 \$3882 sg13g2_nand2_1
* cell instance $40596 r0 *1 108.48,154.98
X$40596 VDD VSS \$6771 \$10284 \$10457 sg13g2_nand2_1
* cell instance $40597 r0 *1 203.52,79.38
X$40597 VDD VSS \$4343 \$4347 \$4349 sg13g2_nand2_1
* cell instance $40598 r0 *1 122.88,34.02
X$40598 VDD VSS \$1426 \$1308 \$1261 sg13g2_nand2_1
* cell instance $40599 r0 *1 233.76,223.02
X$40599 VDD VSS \$15365 \$15674 \$14224 sg13g2_nand2_1
* cell instance $40600 r0 *1 161.28,291.06
X$40600 VDD VSS \$20522 \$21559 \$20664 sg13g2_nand2_1
* cell instance $40601 r0 *1 103.2,177.66
X$40601 VDD VSS \$11757 \$10977 \$11843 sg13g2_nand2_1
* cell instance $40602 r0 *1 108.48,177.66
X$40602 VDD VSS \$10459 \$12009 \$12149 sg13g2_nand2_1
* cell instance $40603 r0 *1 180.96,207.9
X$40603 VDD VSS \$14372 \$14215 \$14213 sg13g2_nand2_1
* cell instance $40604 r0 *1 143.04,253.26
X$40604 VDD VSS \$17821 \$18394 \$16791 sg13g2_nand2_1
* cell instance $40605 r0 *1 243.84,215.46
X$40605 VDD VSS \$14226 \$14400 \$14224 sg13g2_nand2_1
* cell instance $40606 r0 *1 122.88,132.3
X$40606 VDD VSS \$8589 \$9458 \$8430 sg13g2_nand2_1
* cell instance $40607 r0 *1 113.76,86.94
X$40607 VDD VSS \$3814 \$4302 \$4775 sg13g2_nand2_1
* cell instance $40608 r0 *1 215.52,253.26
X$40608 VDD VSS \$18639 \$17831 \$16638 sg13g2_nand2_1
* cell instance $40609 r0 *1 280.32,253.26
X$40609 VDD VSS \$17111 \$20127 \$18484 sg13g2_nand2_1
* cell instance $40610 r0 *1 240.96,223.02
X$40610 VDD VSS \$15057 \$15276 \$13194 sg13g2_nand2_1
* cell instance $40611 r0 *1 45.12,49.14
X$40611 VDD VSS \$2305 \$2201 \$2309 sg13g2_nand2_1
* cell instance $40612 r0 *1 83.52,71.82
X$40612 VDD VSS \$3701 \$3489 \$3699 sg13g2_nand2_1
* cell instance $40613 r0 *1 309.6,275.94
X$40613 VDD VSS \$20583 \$21724 \$20363 sg13g2_nand2_1
* cell instance $40614 r0 *1 106.56,117.18
X$40614 VDD VSS \$8157 \$8156 \$1848 sg13g2_nand2_1
* cell instance $40615 r0 *1 104.64,117.18
X$40615 VDD VSS \$6513 \$6412 \$7171 sg13g2_nand2_1
* cell instance $40616 r0 *1 111.84,139.86
X$40616 VDD VSS \$8884 \$8578 \$8883 sg13g2_nand2_1
* cell instance $40617 r0 *1 128.64,154.98
X$40617 VDD VSS \$10051 \$10286 \$10287 sg13g2_nand2_1
* cell instance $40618 r0 *1 127.68,215.46
X$40618 VDD VSS \$15011 \$12968 \$14338 sg13g2_nand2_1
* cell instance $40619 r0 *1 212.16,192.78
X$40619 VDD VSS \$13179 \$13585 \$13060 sg13g2_nand2_1
* cell instance $40620 r0 *1 48.48,18.9
X$40620 VDD VSS \$449 \$269 \$196 sg13g2_nand2_1
* cell instance $40621 r0 *1 300.48,275.94
X$40621 VDD VSS \$20481 \$16082 \$20363 sg13g2_nand2_1
* cell instance $40622 r0 *1 112.8,192.78
X$40622 VDD VSS \$13151 \$12655 \$12637 sg13g2_nand2_1
* cell instance $40623 r0 *1 276.96,306.18
X$40623 VDD VSS \$22344 \$22151 \$22518 sg13g2_nand2_1
* cell instance $40624 r0 *1 147.36,147.42
X$40624 VDD VSS \$10052 \$9812 \$9632 sg13g2_nand2_1
* cell instance $40625 r0 *1 307.68,207.9
X$40625 VDD VSS \$14514 \$14427 \$14503 sg13g2_nand2_1
* cell instance $40626 r0 *1 25.92,41.58
X$40626 VDD VSS \$1391 \$1753 \$2038 sg13g2_nand2_1
* cell instance $40627 r0 *1 26.4,147.42
X$40627 VDD VSS \$9245 \$9614 \$9612 sg13g2_nand2_1
* cell instance $40628 r0 *1 265.44,343.98
X$40628 VDD VSS \$23142 \$24258 \$24181 sg13g2_nand2_1
* cell instance $40629 r0 *1 126.72,185.22
X$40629 VDD VSS \$12294 \$13948 \$10488 sg13g2_nand2_1
* cell instance $40630 r0 *1 148.8,162.54
X$40630 VDD VSS \$9639 \$10831 \$10488 sg13g2_nand2_1
* cell instance $40631 r0 *1 47.04,139.86
X$40631 VDD VSS \$8416 \$8418 \$8878 sg13g2_nand2_1
* cell instance $40632 r0 *1 155.52,102.06
X$40632 VDD VSS \$5838 \$5006 \$6177 sg13g2_nand2_1
* cell instance $40633 r0 *1 132.96,238.14
X$40633 VDD VSS \$16791 \$17289 \$14728 sg13g2_nand2_1
* cell instance $40634 r0 *1 181.44,102.06
X$40634 VDD VSS \$6188 \$5844 \$6185 sg13g2_nand2_1
* cell instance $40635 r0 *1 85.92,154.98
X$40635 VDD VSS \$10449 \$10281 \$10280 sg13g2_nand2_1
* cell instance $40636 r0 *1 82.08,154.98
X$40636 VDD VSS \$10044 \$9717 \$10275 sg13g2_nand2_1
* cell instance $40637 r0 *1 141.12,162.54
X$40637 VDD VSS \$10996 \$10935 \$10995 sg13g2_nand2_1
* cell instance $40638 r0 *1 81.6,139.86
X$40638 VDD VSS \$8567 \$9453 \$9452 sg13g2_nand2_1
* cell instance $40639 r0 *1 83.52,192.78
X$40639 VDD VSS \$12628 \$13139 \$13659 sg13g2_nand2_1
* cell instance $40640 r0 *1 88.32,192.78
X$40640 VDD VSS \$13297 \$13300 \$13042 sg13g2_nand2_1
* cell instance $40641 r0 *1 71.04,147.42
X$40641 VDD VSS \$9790 \$9450 \$9251 sg13g2_nand2_1
* cell instance $40642 r0 *1 86.4,170.1
X$40642 VDD VSS \$11340 \$9617 \$10449 sg13g2_nand2_1
* cell instance $40643 r0 *1 138.24,49.14
X$40643 VDD VSS \$1743 \$1867 \$2151 sg13g2_nand2_1
* cell instance $40644 r0 *1 175.68,49.14
X$40644 VDD VSS \$2058 \$2060 \$2227 sg13g2_nand2_1
* cell instance $40645 r0 *1 77.28,200.34
X$40645 VDD VSS \$13783 \$13720 \$13042 sg13g2_nand2_1
* cell instance $40646 r0 *1 79.2,200.34
X$40646 VDD VSS \$13497 \$14018 \$13300 sg13g2_nand2_1
* cell instance $40647 r0 *1 106.08,215.46
X$40647 VDD VSS \$15190 \$15004 \$13042 sg13g2_nand2_1
* cell instance $40648 r0 *1 289.44,306.18
X$40648 VDD VSS \$22717 \$14666 \$21081 sg13g2_nand2_1
* cell instance $40649 r0 *1 313.92,215.46
X$40649 VDD VSS \$15086 \$12695 \$12591 sg13g2_nand2_1
* cell instance $40650 r0 *1 318.24,230.58
X$40650 VDD VSS \$16688 \$15979 \$15391 sg13g2_nand2_1
* cell instance $40651 r0 *1 131.04,223.02
X$40651 VDD VSS \$15351 \$15644 \$15350 sg13g2_nand2_1
* cell instance $40652 r0 *1 127.68,79.38
X$40652 VDD VSS \$4313 \$2945 \$4033 sg13g2_nand2_1
* cell instance $40653 r0 *1 114.72,253.26
X$40653 VDD VSS \$18933 \$15846 \$16781 sg13g2_nand2_1
* cell instance $40654 r0 *1 173.28,200.34
X$40654 VDD VSS \$12614 \$12014 \$11704 sg13g2_nand2_1
* cell instance $40655 r0 *1 46.56,102.06
X$40655 VDD VSS \$5814 \$4833 \$6573 sg13g2_nand2_1
* cell instance $40656 r0 *1 183.36,200.34
X$40656 VDD VSS \$13057 \$13948 \$13681 sg13g2_nand2_1
* cell instance $40657 r0 *1 146.88,321.3
X$40657 VDD VSS \$23533 \$23673 \$23531 sg13g2_nand2_1
* cell instance $40658 r0 *1 118.56,268.38
X$40658 VDD VSS \$19988 \$19726 \$19414 sg13g2_nand2_1
* cell instance $40659 r0 *1 320.16,238.14
X$40659 VDD VSS \$16820 \$15707 \$15391 sg13g2_nand2_1
* cell instance $40660 r0 *1 68.16,117.18
X$40660 VDD VSS \$6891 \$6890 \$7671 sg13g2_nand2_1
* cell instance $40661 r0 *1 244.8,260.82
X$40661 VDD VSS \$17455 \$18469 \$18814 sg13g2_nand2_1
* cell instance $40662 r0 *1 242.88,260.82
X$40662 VDD VSS \$18301 \$19440 \$18793 sg13g2_nand2_1
* cell instance $40663 r0 *1 260.64,185.22
X$40663 VDD VSS \$12690 \$12360 \$12363 sg13g2_nand2_1
* cell instance $40664 r0 *1 293.28,223.02
X$40664 VDD VSS \$15700 \$13512 \$15077 sg13g2_nand2_1
* cell instance $40665 r0 *1 185.76,71.82
X$40665 VDD VSS \$3718 \$3724 \$3723 sg13g2_nand2_1
* cell instance $40666 r0 *1 174.24,215.46
X$40666 VDD VSS \$14371 \$14896 \$11395 sg13g2_nand2_1
* cell instance $40667 r0 *1 240.96,260.82
X$40667 VDD VSS \$18816 \$19440 \$17877 sg13g2_nand2_1
* cell instance $40668 r0 *1 72.48,117.18
X$40668 VDD VSS \$5367 \$7028 \$6749 sg13g2_nand2_1
* cell instance $40669 r0 *1 121.44,170.1
X$40669 VDD VSS \$11182 \$10156 \$11461 sg13g2_nand2_1
* cell instance $40670 r0 *1 285.6,283.5
X$40670 VDD VSS \$18207 \$21085 \$16843 sg13g2_nand2_1
* cell instance $40671 r0 *1 43.68,117.18
X$40671 VDD VSS \$6737 \$7157 \$7318 sg13g2_nand2_1
* cell instance $40672 r0 *1 224.64,185.22
X$40672 VDD VSS \$12509 \$12036 \$11973 sg13g2_nand2_1
* cell instance $40673 r0 *1 324,306.18
X$40673 VDD VSS \$22758 \$14080 \$22424 sg13g2_nand2_1
* cell instance $40674 r0 *1 47.52,117.18
X$40674 VDD VSS \$6573 \$5816 \$6147 sg13g2_nand2_1
* cell instance $40675 r0 *1 142.08,170.1
X$40675 VDD VSS \$11470 \$10046 \$10996 sg13g2_nand2_1
* cell instance $40676 r0 *1 132.48,185.22
X$40676 VDD VSS \$12803 \$12893 \$10488 sg13g2_nand2_1
* cell instance $40677 r0 *1 159.36,124.74
X$40677 VDD VSS \$7991 \$7350 \$7994 sg13g2_nand2_1
* cell instance $40678 r0 *1 46.08,124.74
X$40678 VDD VSS \$7944 \$7802 \$8084 sg13g2_nand2_1
* cell instance $40679 r0 *1 115.2,230.58
X$40679 VDD VSS \$16023 \$14018 \$15004 sg13g2_nand2_1
* cell instance $40680 r0 *1 336,18.9
X$40680 VDD VSS \$585 \$588 \$1469 sg13g2_nand2_1
* cell instance $40681 r0 *1 336,56.7
X$40681 VDD VSS \$2767 \$2635 \$3074 sg13g2_nand2_1
* cell instance $40682 r0 *1 291.84,230.58
X$40682 VDD VSS \$16189 \$16473 \$15077 sg13g2_nand2_1
* cell instance $40683 r0 *1 48.48,192.78
X$40683 VDD VSS \$12625 \$12883 \$13124 sg13g2_nand2_1
* cell instance $40684 r0 *1 292.32,245.7
X$40684 VDD VSS \$17550 \$12710 \$16334 sg13g2_nand2_1
* cell instance $40685 r0 *1 172.8,64.26
X$40685 VDD VSS \$3170 \$2901 \$3171 sg13g2_nand2_1
* cell instance $40686 r0 *1 201.12,275.94
X$40686 VDD VSS \$19746 \$20532 \$20452 sg13g2_nand2_1
* cell instance $40687 r0 *1 273.6,298.62
X$40687 VDD VSS \$22149 \$21452 \$20607 sg13g2_nand2_1
* cell instance $40688 r0 *1 244.8,291.06
X$40688 VDD VSS \$21672 \$21446 \$16311 sg13g2_nand2_1
* cell instance $40689 r0 *1 197.76,275.94
X$40689 VDD VSS \$20016 \$20525 \$20528 sg13g2_nand2_1
* cell instance $40690 r0 *1 249.12,102.06
X$40690 VDD VSS \$5860 \$4949 \$5183 sg13g2_nand2_1
* cell instance $40691 r0 *1 349.92,223.02
X$40691 VDD VSS \$15736 \$14246 \$13706 sg13g2_nand2_1
* cell instance $40692 r0 *1 104.16,18.9
X$40692 VDD VSS \$456 \$316 \$273 sg13g2_nand2_1
* cell instance $40693 r0 *1 294.24,154.98
X$40693 VDD VSS \$8044 \$4409 \$9682 sg13g2_nand2_1
* cell instance $40694 r0 *1 203.04,275.94
X$40694 VDD VSS \$20236 \$20538 \$20195 sg13g2_nand2_1
* cell instance $40695 r0 *1 264.48,306.18
X$40695 VDD VSS \$23295 \$22584 \$22885 sg13g2_nand2_1
* cell instance $40696 r0 *1 227.52,200.34
X$40696 VDD VSS \$12914 \$13691 \$12677 sg13g2_nand2_1
* cell instance $40697 r0 *1 321.6,185.22
X$40697 VDD VSS \$11035 \$4838 \$1469 sg13g2_nand2_1
* cell instance $40698 r0 *1 300,154.98
X$40698 VDD VSS \$9716 \$8922 \$9947 sg13g2_nand2_1
* cell instance $40699 r0 *1 296.16,154.98
X$40699 VDD VSS \$6224 \$8045 \$1469 sg13g2_nand2_1
* cell instance $40700 r0 *1 298.08,154.98
X$40700 VDD VSS \$9666 \$9139 \$8475 sg13g2_nand2_1
* cell instance $40701 r0 *1 41.28,260.82
X$40701 VDD VSS \$19398 \$14299 \$18494 sg13g2_nand2_1
* cell instance $40702 r0 *1 102.24,18.9
X$40702 VDD VSS \$383 \$230 \$456 sg13g2_nand2_1
* cell instance $40703 r0 *1 35.04,253.26
X$40703 VDD VSS \$16993 \$18619 \$18494 sg13g2_nand2_1
* cell instance $40704 r0 *1 26.4,94.5
X$40704 VDD VSS \$5600 \$4432 \$5353 sg13g2_nand2_1
* cell instance $40705 r0 *1 120,18.9
X$40705 VDD VSS \$677 \$77 \$237 sg13g2_nand2_1
* cell instance $40706 r0 *1 193.44,336.42
X$40706 VDD VSS \$24073 \$24063 \$24389 sg13g2_nand2_1
* cell instance $40707 r0 *1 278.4,132.3
X$40707 VDD VSS \$5661 \$5721 \$5188 sg13g2_nand2_1
* cell instance $40708 r0 *1 334.08,223.02
X$40708 VDD VSS \$16651 \$15714 \$15391 sg13g2_nand2_1
* cell instance $40709 r0 *1 235.68,245.7
X$40709 VDD VSS \$17880 \$17876 \$18466 sg13g2_nand2_1
* cell instance $40710 r0 *1 221.76,328.86
X$40710 VDD VSS \$23696 \$23695 \$23928 sg13g2_nand2_1
* cell instance $40711 r0 *1 334.56,185.22
X$40711 VDD VSS \$9492 \$11949 \$12561 sg13g2_nand2_1
* cell instance $40712 r0 *1 320.64,200.34
X$40712 VDD VSS \$13499 \$13706 \$13273 sg13g2_nand2_1
* cell instance $40713 r0 *1 135.36,18.9
X$40713 VDD VSS \$459 \$458 \$434 sg13g2_nand2_1
* cell instance $40714 r0 *1 180.96,11.34
X$40714 VDD VSS \$90 \$87 \$3 sg13g2_nand2_1
* cell instance $40715 r0 *1 182.88,11.34
X$40715 VDD VSS \$89 \$84 \$4 sg13g2_nand2b_1
* cell instance $40716 r0 *1 185.28,11.34
X$40716 VDD VSS \$10 \$106 sg13g2_dlygate4sd3_1
* cell instance $40719 r0 *1 208.8,275.94
X$40719 VDD VSS \$20022 \$20508 \$20670 sg13g2_nand2_1
* cell instance $40720 r0 *1 282.24,291.06
X$40720 VDD VSS \$21875 \$12711 \$20461 sg13g2_nand2_1
* cell instance $40721 r0 *1 88.32,94.5
X$40721 VDD VSS \$5373 \$5610 \$5374 sg13g2_nand2_1
* cell instance $40722 r0 *1 68.16,306.18
X$40722 VDD VSS \$22655 \$21605 \$22377 sg13g2_nand2_1
* cell instance $40723 r0 *1 103.68,94.5
X$40723 VDD VSS \$5495 \$5154 \$5263 sg13g2_nand2_1
* cell instance $40724 r0 *1 34.08,238.14
X$40724 VDD VSS \$16226 \$14299 \$16777 sg13g2_nand2_1
* cell instance $40725 r0 *1 30.24,238.14
X$40725 VDD VSS \$16870 \$16777 \$16988 sg13g2_nand2_1
* cell instance $40726 r0 *1 106.08,34.02
X$40726 VDD VSS \$975 \$1305 \$1304 sg13g2_nand2_1
* cell instance $40727 r0 *1 81.6,238.14
X$40727 VDD VSS \$17220 \$14018 \$16248 sg13g2_nand2_1
* cell instance $40728 r0 *1 300.96,192.78
X$40728 VDD VSS \$13320 \$13228 \$12377 sg13g2_nand2_1
* cell instance $40729 r0 *1 231.84,268.38
X$40729 VDD VSS \$17677 \$19439 \$19440 sg13g2_nand2_1
* cell instance $40730 r0 *1 43.2,245.7
X$40730 VDD VSS \$17957 \$16231 \$17000 sg13g2_nand2_1
* cell instance $40731 r0 *1 280.8,139.86
X$40731 VDD VSS \$7723 \$7422 \$1469 sg13g2_nand2_1
* cell instance $40732 r0 *1 226.08,170.1
X$40732 VDD VSS \$11675 \$11493 \$11730 sg13g2_nand2_1
* cell instance $40733 r0 *1 140.16,185.22
X$40733 VDD VSS \$12639 \$12660 \$12637 sg13g2_nand2_1
* cell instance $40734 r0 *1 191.04,275.94
X$40734 VDD VSS \$20013 \$20449 \$20528 sg13g2_nand2_1
* cell instance $40735 r0 *1 127.2,94.5
X$40735 VDD VSS \$5382 \$5157 \$5274 sg13g2_nand2_1
* cell instance $40736 r0 *1 193.92,162.54
X$40736 VDD VSS \$10165 \$10725 \$10301 sg13g2_nand2_1
* cell instance $40737 r0 *1 137.76,132.3
X$40737 VDD VSS \$8432 \$8433 \$8434 sg13g2_nand2_1
* cell instance $40738 r0 *1 164.16,94.5
X$40738 VDD VSS \$5392 \$5164 \$5010 sg13g2_nand2_1
* cell instance $40739 r0 *1 336,207.9
X$40739 VDD VSS \$14249 \$13706 \$14434 sg13g2_nand2_1
* cell instance $40740 r0 *1 171.84,170.1
X$40740 VDD VSS \$11477 \$11395 \$11480 sg13g2_nand2_1
* cell instance $40741 r0 *1 286.56,139.86
X$40741 VDD VSS \$6962 \$8920 \$8178 sg13g2_nand2_1
* cell instance $40742 m0 *1 323.04,260.82
X$40742 VDD VSS sg13g2_decap_4
* cell instance $40743 m0 *1 186.72,86.94
X$40743 VDD VSS sg13g2_decap_4
* cell instance $40744 m0 *1 137.76,102.06
X$40744 VDD VSS sg13g2_decap_4
* cell instance $40745 m0 *1 8.16,154.98
X$40745 VDD VSS sg13g2_decap_4
* cell instance $40746 m0 *1 182.4,56.7
X$40746 VDD VSS sg13g2_decap_4
* cell instance $40747 m0 *1 128.16,109.62
X$40747 VDD VSS sg13g2_decap_4
* cell instance $40748 m0 *1 287.04,275.94
X$40748 VDD VSS sg13g2_decap_4
* cell instance $40749 m0 *1 8.16,71.82
X$40749 VDD VSS sg13g2_decap_4
* cell instance $40750 m0 *1 229.92,177.66
X$40750 VDD VSS sg13g2_decap_4
* cell instance $40751 m0 *1 150.72,223.02
X$40751 VDD VSS sg13g2_decap_4
* cell instance $40752 m0 *1 193.92,94.5
X$40752 VDD VSS sg13g2_decap_4
* cell instance $40753 m0 *1 66.24,102.06
X$40753 VDD VSS sg13g2_decap_4
* cell instance $40754 m0 *1 328.32,283.5
X$40754 VDD VSS sg13g2_decap_4
* cell instance $40755 m0 *1 204.48,275.94
X$40755 VDD VSS sg13g2_decap_4
* cell instance $40756 m0 *1 204.96,207.9
X$40756 VDD VSS sg13g2_decap_4
* cell instance $40757 m0 *1 8.16,56.7
X$40757 VDD VSS sg13g2_decap_4
* cell instance $40758 m0 *1 199.68,275.94
X$40758 VDD VSS sg13g2_decap_4
* cell instance $40759 m0 *1 276.96,215.46
X$40759 VDD VSS sg13g2_decap_4
* cell instance $40760 m0 *1 268.8,215.46
X$40760 VDD VSS sg13g2_decap_4
* cell instance $40761 m0 *1 238.08,185.22
X$40761 VDD VSS sg13g2_decap_4
* cell instance $40762 m0 *1 30.72,215.46
X$40762 VDD VSS sg13g2_decap_4
* cell instance $40763 m0 *1 256.32,343.98
X$40763 VDD VSS sg13g2_decap_4
* cell instance $40764 m0 *1 305.28,321.3
X$40764 VDD VSS sg13g2_decap_4
* cell instance $40765 m0 *1 314.4,245.7
X$40765 VDD VSS sg13g2_decap_4
* cell instance $40766 m0 *1 181.92,245.7
X$40766 VDD VSS sg13g2_decap_4
* cell instance $40767 m0 *1 8.16,79.38
X$40767 VDD VSS sg13g2_decap_4
* cell instance $40768 m0 *1 8.16,64.26
X$40768 VDD VSS sg13g2_decap_4
* cell instance $40769 m0 *1 311.04,291.06
X$40769 VDD VSS sg13g2_decap_4
* cell instance $40770 m0 *1 243.84,298.62
X$40770 VDD VSS sg13g2_decap_4
* cell instance $40771 m0 *1 348.96,351.54
X$40771 VDD VSS sg13g2_decap_4
* cell instance $40772 m0 *1 278.88,283.5
X$40772 VDD VSS sg13g2_decap_4
* cell instance $40773 m0 *1 8.16,94.5
X$40773 VDD VSS sg13g2_decap_4
* cell instance $40774 m0 *1 186.24,223.02
X$40774 VDD VSS sg13g2_decap_4
* cell instance $40775 m0 *1 273.12,245.7
X$40775 VDD VSS sg13g2_decap_4
* cell instance $40776 m0 *1 95.52,192.78
X$40776 VDD VSS sg13g2_decap_4
* cell instance $40777 m0 *1 8.16,86.94
X$40777 VDD VSS sg13g2_decap_4
* cell instance $40778 m0 *1 8.16,147.42
X$40778 VDD VSS sg13g2_decap_4
* cell instance $40779 m0 *1 325.44,268.38
X$40779 VDD VSS sg13g2_decap_4
* cell instance $40780 m0 *1 324,283.5
X$40780 VDD VSS sg13g2_decap_4
* cell instance $40781 m0 *1 261.6,260.82
X$40781 VDD VSS sg13g2_decap_4
* cell instance $40782 m0 *1 252,260.82
X$40782 VDD VSS sg13g2_decap_4
* cell instance $40783 m0 *1 183.36,351.54
X$40783 VDD VSS sg13g2_decap_4
* cell instance $40784 m0 *1 8.16,177.66
X$40784 VDD VSS sg13g2_decap_4
* cell instance $40785 m0 *1 126.24,154.98
X$40785 VDD VSS sg13g2_decap_4
* cell instance $40786 m0 *1 193.92,162.54
X$40786 VDD VSS sg13g2_decap_4
* cell instance $40787 m0 *1 226.08,328.86
X$40787 VDD VSS sg13g2_decap_4
* cell instance $40788 m0 *1 67.68,56.7
X$40788 VDD VSS sg13g2_decap_4
* cell instance $40789 m0 *1 70.08,215.46
X$40789 VDD VSS sg13g2_decap_4
* cell instance $40790 m0 *1 228,223.02
X$40790 VDD VSS sg13g2_decap_4
* cell instance $40791 m0 *1 306.72,177.66
X$40791 VDD VSS sg13g2_decap_4
* cell instance $40792 m0 *1 219.84,260.82
X$40792 VDD VSS sg13g2_decap_4
* cell instance $40793 m0 *1 247.2,147.42
X$40793 VDD VSS sg13g2_decap_4
* cell instance $40794 m0 *1 277.44,162.54
X$40794 VDD VSS sg13g2_decap_4
* cell instance $40795 m0 *1 87.36,298.62
X$40795 VDD VSS sg13g2_decap_4
* cell instance $40796 m0 *1 14.88,185.22
X$40796 VDD VSS sg13g2_decap_4
* cell instance $40797 m0 *1 203.04,253.26
X$40797 VDD VSS sg13g2_decap_4
* cell instance $40798 m0 *1 170.4,215.46
X$40798 VDD VSS sg13g2_decap_4
* cell instance $40799 m0 *1 76.8,64.26
X$40799 VDD VSS sg13g2_decap_4
* cell instance $40800 m0 *1 182.4,260.82
X$40800 VDD VSS sg13g2_decap_4
* cell instance $40801 m0 *1 35.52,177.66
X$40801 VDD VSS sg13g2_decap_4
* cell instance $40802 m0 *1 334.08,223.02
X$40802 VDD VSS sg13g2_decap_4
* cell instance $40803 m0 *1 80.16,313.74
X$40803 VDD VSS sg13g2_decap_4
* cell instance $40804 m0 *1 329.76,223.02
X$40804 VDD VSS sg13g2_decap_4
* cell instance $40805 m0 *1 240,313.74
X$40805 VDD VSS sg13g2_decap_4
* cell instance $40806 m0 *1 221.28,253.26
X$40806 VDD VSS sg13g2_decap_4
* cell instance $40807 m0 *1 110.4,41.58
X$40807 VDD VSS sg13g2_decap_4
* cell instance $40808 m0 *1 159.36,18.9
X$40808 VDD VSS sg13g2_decap_4
* cell instance $40809 m0 *1 36.96,170.1
X$40809 VDD VSS sg13g2_decap_4
* cell instance $40810 m0 *1 22.56,207.9
X$40810 VDD VSS sg13g2_decap_4
* cell instance $40811 m0 *1 63.36,185.22
X$40811 VDD VSS sg13g2_decap_4
* cell instance $40812 m0 *1 252,147.42
X$40812 VDD VSS sg13g2_decap_4
* cell instance $40813 m0 *1 48,207.9
X$40813 VDD VSS sg13g2_decap_4
* cell instance $40814 m0 *1 79.2,26.46
X$40814 VDD VSS sg13g2_decap_4
* cell instance $40815 m0 *1 228,215.46
X$40815 VDD VSS sg13g2_decap_4
* cell instance $40816 m0 *1 349.44,343.98
X$40816 VDD VSS sg13g2_decap_4
* cell instance $40817 m0 *1 128.16,132.3
X$40817 VDD VSS sg13g2_decap_4
* cell instance $40818 m0 *1 128.16,41.58
X$40818 VDD VSS sg13g2_decap_4
* cell instance $40819 m0 *1 196.32,336.42
X$40819 VDD VSS sg13g2_decap_4
* cell instance $40820 m0 *1 90.72,283.5
X$40820 VDD VSS sg13g2_decap_4
* cell instance $40821 m0 *1 218.4,132.3
X$40821 VDD VSS sg13g2_decap_4
* cell instance $40822 m0 *1 82.56,291.06
X$40822 VDD VSS sg13g2_decap_4
* cell instance $40823 m0 *1 210.72,162.54
X$40823 VDD VSS sg13g2_decap_4
* cell instance $40824 m0 *1 349.44,306.18
X$40824 VDD VSS sg13g2_decap_4
* cell instance $40825 m0 *1 348.96,298.62
X$40825 VDD VSS sg13g2_decap_4
* cell instance $40826 m0 *1 248.64,124.74
X$40826 VDD VSS sg13g2_decap_4
* cell instance $40827 m0 *1 103.68,26.46
X$40827 VDD VSS sg13g2_decap_4
* cell instance $40828 m0 *1 37.44,79.38
X$40828 VDD VSS sg13g2_decap_4
* cell instance $40829 m0 *1 142.56,185.22
X$40829 VDD VSS sg13g2_decap_4
* cell instance $40830 m0 *1 98.88,275.94
X$40830 VDD VSS sg13g2_decap_4
* cell instance $40831 m0 *1 84.48,245.7
X$40831 VDD VSS sg13g2_decap_4
* cell instance $40832 m0 *1 81.6,79.38
X$40832 VDD VSS sg13g2_decap_4
* cell instance $40833 m0 *1 23.04,275.94
X$40833 VDD VSS sg13g2_decap_4
* cell instance $40834 m0 *1 80.64,275.94
X$40834 VDD VSS sg13g2_decap_4
* cell instance $40835 m0 *1 14.88,162.54
X$40835 VDD VSS sg13g2_decap_4
* cell instance $40836 m0 *1 153.12,245.7
X$40836 VDD VSS sg13g2_decap_4
* cell instance $40837 m0 *1 8.16,170.1
X$40837 VDD VSS sg13g2_decap_4
* cell instance $40838 m0 *1 220.32,162.54
X$40838 VDD VSS sg13g2_decap_4
* cell instance $40839 m0 *1 217.92,268.38
X$40839 VDD VSS sg13g2_decap_4
* cell instance $40840 m0 *1 272.64,177.66
X$40840 VDD VSS sg13g2_decap_4
* cell instance $40841 m0 *1 47.04,223.02
X$40841 VDD VSS sg13g2_decap_4
* cell instance $40842 m0 *1 235.2,154.98
X$40842 VDD VSS sg13g2_decap_4
* cell instance $40843 m0 *1 111.84,18.9
X$40843 VDD VSS sg13g2_decap_4
* cell instance $40844 m0 *1 321.12,200.34
X$40844 VDD VSS sg13g2_decap_4
* cell instance $40845 m0 *1 187.68,117.18
X$40845 VDD VSS sg13g2_decap_4
* cell instance $40846 m0 *1 29.28,185.22
X$40846 VDD VSS sg13g2_decap_4
* cell instance $40847 m0 *1 203.52,86.94
X$40847 VDD VSS sg13g2_decap_4
* cell instance $40848 m0 *1 172.8,86.94
X$40848 VDD VSS sg13g2_decap_4
* cell instance $40849 m0 *1 118.08,238.14
X$40849 VDD VSS sg13g2_decap_4
* cell instance $40850 m0 *1 147.84,109.62
X$40850 VDD VSS sg13g2_decap_4
* cell instance $40851 m0 *1 8.16,34.02
X$40851 VDD VSS sg13g2_decap_4
* cell instance $40852 m0 *1 285.6,253.26
X$40852 VDD VSS sg13g2_decap_4
* cell instance $40853 m0 *1 297.6,283.5
X$40853 VDD VSS sg13g2_decap_4
* cell instance $40854 m0 *1 274.56,253.26
X$40854 VDD VSS sg13g2_decap_4
* cell instance $40855 m0 *1 269.28,230.58
X$40855 VDD VSS sg13g2_decap_4
* cell instance $40856 m0 *1 244.32,230.58
X$40856 VDD VSS sg13g2_decap_4
* cell instance $40857 m0 *1 8.16,49.14
X$40857 VDD VSS sg13g2_decap_4
* cell instance $40858 m0 *1 235.68,139.86
X$40858 VDD VSS sg13g2_decap_4
* cell instance $40859 m0 *1 8.16,192.78
X$40859 VDD VSS sg13g2_decap_4
* cell instance $40860 m0 *1 8.16,200.34
X$40860 VDD VSS sg13g2_decap_4
* cell instance $40861 m0 *1 227.04,245.7
X$40861 VDD VSS sg13g2_decap_4
* cell instance $40862 m0 *1 139.2,223.02
X$40862 VDD VSS sg13g2_decap_4
* cell instance $40863 m0 *1 281.28,207.9
X$40863 VDD VSS sg13g2_decap_4
* cell instance $40864 m0 *1 162.24,147.42
X$40864 VDD VSS sg13g2_decap_4
* cell instance $40865 m0 *1 35.52,268.38
X$40865 VDD VSS sg13g2_decap_4
* cell instance $40866 m0 *1 273.12,207.9
X$40866 VDD VSS sg13g2_decap_4
* cell instance $40867 m0 *1 202.08,132.3
X$40867 VDD VSS sg13g2_decap_4
* cell instance $40868 m0 *1 225.12,192.78
X$40868 VDD VSS sg13g2_decap_4
* cell instance $40869 m0 *1 124.32,230.58
X$40869 VDD VSS sg13g2_decap_4
* cell instance $40870 m0 *1 8.16,238.14
X$40870 VDD VSS sg13g2_decap_4
* cell instance $40871 m0 *1 8.16,245.7
X$40871 VDD VSS sg13g2_decap_4
* cell instance $40872 m0 *1 264.96,207.9
X$40872 VDD VSS sg13g2_decap_4
* cell instance $40873 m0 *1 8.16,41.58
X$40873 VDD VSS sg13g2_decap_4
* cell instance $40874 m0 *1 211.2,351.54
X$40874 VDD VSS sg13g2_decap_4
* cell instance $40875 m0 *1 132,79.38
X$40875 VDD VSS sg13g2_decap_4
* cell instance $40876 m0 *1 263.52,177.66
X$40876 VDD VSS sg13g2_decap_4
* cell instance $40877 m0 *1 191.04,147.42
X$40877 VDD VSS sg13g2_decap_4
* cell instance $40878 m0 *1 137.76,124.74
X$40878 VDD VSS sg13g2_decap_4
* cell instance $40879 m0 *1 8.16,306.18
X$40879 VDD VSS sg13g2_decap_4
* cell instance $40880 m0 *1 147.84,56.7
X$40880 VDD VSS sg13g2_decap_4
* cell instance $40881 m0 *1 37.92,26.46
X$40881 VDD VSS sg13g2_decap_4
* cell instance $40882 m0 *1 8.16,132.3
X$40882 VDD VSS sg13g2_decap_4
* cell instance $40883 m0 *1 8.16,124.74
X$40883 VDD VSS sg13g2_decap_4
* cell instance $40884 m0 *1 227.52,102.06
X$40884 VDD VSS sg13g2_decap_4
* cell instance $40885 m0 *1 91.68,192.78
X$40885 VDD VSS sg13g2_decap_4
* cell instance $40886 m0 *1 87.36,253.26
X$40886 VDD VSS sg13g2_decap_4
* cell instance $40887 m0 *1 323.04,298.62
X$40887 VDD VSS sg13g2_decap_4
* cell instance $40888 m0 *1 308.16,260.82
X$40888 VDD VSS sg13g2_decap_4
* cell instance $40889 m0 *1 318.72,275.94
X$40889 VDD VSS sg13g2_decap_4
* cell instance $40890 m0 *1 201.12,200.34
X$40890 VDD VSS sg13g2_decap_4
* cell instance $40891 m0 *1 80.64,139.86
X$40891 VDD VSS sg13g2_decap_4
* cell instance $40892 m0 *1 295.2,336.42
X$40892 VDD VSS sg13g2_decap_4
* cell instance $40893 m0 *1 154.08,170.1
X$40893 VDD VSS sg13g2_decap_4
* cell instance $40894 m0 *1 138.72,321.3
X$40894 VDD VSS sg13g2_decap_4
* cell instance $40895 m0 *1 47.52,124.74
X$40895 VDD VSS sg13g2_decap_4
* cell instance $40896 m0 *1 269.76,139.86
X$40896 VDD VSS sg13g2_decap_4
* cell instance $40897 m0 *1 8.16,109.62
X$40897 VDD VSS sg13g2_decap_4
* cell instance $40898 m0 *1 244.32,192.78
X$40898 VDD VSS sg13g2_decap_4
* cell instance $40899 m0 *1 237.12,162.54
X$40899 VDD VSS sg13g2_decap_4
* cell instance $40900 m0 *1 26.4,192.78
X$40900 VDD VSS sg13g2_decap_4
* cell instance $40901 m0 *1 291.36,238.14
X$40901 VDD VSS sg13g2_decap_4
* cell instance $40902 m0 *1 8.16,18.9
X$40902 VDD VSS sg13g2_decap_4
* cell instance $40903 m0 *1 23.04,26.46
X$40903 VDD VSS sg13g2_decap_4
* cell instance $40904 m0 *1 8.16,313.74
X$40904 VDD VSS sg13g2_decap_4
* cell instance $40905 m0 *1 306.72,253.26
X$40905 VDD VSS sg13g2_decap_4
* cell instance $40906 m0 *1 270.24,170.1
X$40906 VDD VSS sg13g2_decap_4
* cell instance $40907 m0 *1 8.16,26.46
X$40907 VDD VSS sg13g2_decap_4
* cell instance $40908 m0 *1 138.72,162.54
X$40908 VDD VSS sg13g2_decap_4
* cell instance $40909 m0 *1 32.16,109.62
X$40909 VDD VSS sg13g2_decap_4
* cell instance $40910 m0 *1 80.64,177.66
X$40910 VDD VSS sg13g2_decap_4
* cell instance $40911 m0 *1 287.52,336.42
X$40911 VDD VSS sg13g2_decap_4
* cell instance $40912 m0 *1 170.4,71.82
X$40912 VDD VSS sg13g2_decap_4
* cell instance $40913 m0 *1 349.92,336.42
X$40913 VDD VSS sg13g2_decap_4
* cell instance $40914 m0 *1 32.16,230.58
X$40914 VDD VSS sg13g2_decap_4
* cell instance $40915 m0 *1 156.48,275.94
X$40915 VDD VSS sg13g2_decap_4
* cell instance $40916 m0 *1 306.24,283.5
X$40916 VDD VSS sg13g2_decap_4
* cell instance $40917 m0 *1 305.76,245.7
X$40917 VDD VSS sg13g2_decap_4
* cell instance $40918 m0 *1 252,313.74
X$40918 VDD VSS sg13g2_decap_4
* cell instance $40919 m0 *1 264,245.7
X$40919 VDD VSS sg13g2_decap_4
* cell instance $40920 m0 *1 133.92,260.82
X$40920 VDD VSS sg13g2_decap_4
* cell instance $40921 m0 *1 273.6,147.42
X$40921 VDD VSS sg13g2_decap_4
* cell instance $40922 m0 *1 127.2,253.26
X$40922 VDD VSS sg13g2_decap_4
* cell instance $40923 m0 *1 188.16,79.38
X$40923 VDD VSS sg13g2_decap_4
* cell instance $40924 m0 *1 286.56,260.82
X$40924 VDD VSS sg13g2_decap_4
* cell instance $40925 m0 *1 267.36,321.3
X$40925 VDD VSS sg13g2_decap_4
* cell instance $40926 m0 *1 270.24,238.14
X$40926 VDD VSS sg13g2_decap_4
* cell instance $40927 m0 *1 161.76,132.3
X$40927 VDD VSS sg13g2_decap_4
* cell instance $40928 m0 *1 325.92,223.02
X$40928 VDD VSS sg13g2_decap_4
* cell instance $40929 m0 *1 178.08,117.18
X$40929 VDD VSS sg13g2_decap_4
* cell instance $40930 m0 *1 30.24,336.42
X$40930 VDD VSS sg13g2_decap_4
* cell instance $40931 m0 *1 314.4,230.58
X$40931 VDD VSS sg13g2_decap_4
* cell instance $40932 m0 *1 288,185.22
X$40932 VDD VSS sg13g2_decap_4
* cell instance $40933 m0 *1 32.16,71.82
X$40933 VDD VSS sg13g2_decap_4
* cell instance $40934 m0 *1 250.08,328.86
X$40934 VDD VSS sg13g2_decap_4
* cell instance $40935 m0 *1 70.56,124.74
X$40935 VDD VSS sg13g2_decap_4
* cell instance $40936 m0 *1 174.24,154.98
X$40936 VDD VSS sg13g2_decap_4
* cell instance $40937 m0 *1 284.64,306.18
X$40937 VDD VSS sg13g2_decap_4
* cell instance $40938 m0 *1 74.4,215.46
X$40938 VDD VSS sg13g2_decap_4
* cell instance $40939 m0 *1 278.88,154.98
X$40939 VDD VSS sg13g2_decap_4
* cell instance $40940 m0 *1 174.24,351.54
X$40940 VDD VSS sg13g2_decap_4
* cell instance $40941 m0 *1 48,64.26
X$40941 VDD VSS sg13g2_decap_4
* cell instance $40942 m0 *1 174.24,223.02
X$40942 VDD VSS sg13g2_decap_4
* cell instance $40943 m0 *1 269.76,298.62
X$40943 VDD VSS sg13g2_decap_4
* cell instance $40944 m0 *1 8.16,321.3
X$40944 VDD VSS sg13g2_decap_4
* cell instance $40945 m0 *1 143.52,41.58
X$40945 VDD VSS sg13g2_decap_4
* cell instance $40946 m0 *1 133.92,192.78
X$40946 VDD VSS sg13g2_decap_4
* cell instance $40947 m0 *1 288.48,313.74
X$40947 VDD VSS sg13g2_decap_4
* cell instance $40948 m0 *1 72.48,207.9
X$40948 VDD VSS sg13g2_decap_4
* cell instance $40949 m0 *1 79.2,192.78
X$40949 VDD VSS sg13g2_decap_4
* cell instance $40950 m0 *1 119.52,26.46
X$40950 VDD VSS sg13g2_decap_4
* cell instance $40951 m0 *1 107.52,260.82
X$40951 VDD VSS sg13g2_decap_4
* cell instance $40952 m0 *1 153.12,207.9
X$40952 VDD VSS sg13g2_decap_4
* cell instance $40953 m0 *1 249.6,245.7
X$40953 VDD VSS sg13g2_decap_4
* cell instance $40954 m0 *1 172.32,207.9
X$40954 VDD VSS sg13g2_decap_4
* cell instance $40955 m0 *1 161.76,207.9
X$40955 VDD VSS sg13g2_decap_4
* cell instance $40956 m0 *1 103.68,260.82
X$40956 VDD VSS sg13g2_decap_4
* cell instance $40957 m0 *1 200.64,215.46
X$40957 VDD VSS sg13g2_decap_4
* cell instance $40958 m0 *1 73.44,200.34
X$40958 VDD VSS sg13g2_decap_4
* cell instance $40959 m0 *1 8.16,117.18
X$40959 VDD VSS sg13g2_decap_4
* cell instance $40960 m0 *1 63.36,283.5
X$40960 VDD VSS sg13g2_decap_4
* cell instance $40961 m0 *1 63.36,230.58
X$40961 VDD VSS sg13g2_decap_4
* cell instance $40962 m0 *1 212.16,102.06
X$40962 VDD VSS sg13g2_decap_4
* cell instance $40963 m0 *1 247.2,291.06
X$40963 VDD VSS sg13g2_decap_4
* cell instance $40964 m0 *1 121.92,268.38
X$40964 VDD VSS sg13g2_decap_4
* cell instance $40965 m0 *1 55.2,177.66
X$40965 VDD VSS sg13g2_decap_4
* cell instance $40966 m0 *1 8.16,215.46
X$40966 VDD VSS sg13g2_decap_4
* cell instance $40967 m0 *1 318.72,223.02
X$40967 VDD VSS sg13g2_decap_4
* cell instance $40968 r0 *1 265.92,185.22
X$40968 VDD VSS sg13g2_decap_4
* cell instance $40969 r0 *1 146.4,162.54
X$40969 VDD VSS sg13g2_decap_4
* cell instance $40970 r0 *1 251.04,185.22
X$40970 VDD VSS sg13g2_decap_4
* cell instance $40971 r0 *1 170.88,162.54
X$40971 VDD VSS sg13g2_decap_4
* cell instance $40972 r0 *1 162.72,147.42
X$40972 VDD VSS sg13g2_decap_4
* cell instance $40973 r0 *1 244.8,192.78
X$40973 VDD VSS sg13g2_decap_4
* cell instance $40974 r0 *1 239.04,185.22
X$40974 VDD VSS sg13g2_decap_4
* cell instance $40975 r0 *1 150.72,162.54
X$40975 VDD VSS sg13g2_decap_4
* cell instance $40976 r0 *1 268.32,200.34
X$40976 VDD VSS sg13g2_decap_4
* cell instance $40977 r0 *1 106.56,170.1
X$40977 VDD VSS sg13g2_decap_4
* cell instance $40978 r0 *1 117.6,162.54
X$40978 VDD VSS sg13g2_decap_4
* cell instance $40979 r0 *1 163.68,170.1
X$40979 VDD VSS sg13g2_decap_4
* cell instance $40980 r0 *1 136.32,162.54
X$40980 VDD VSS sg13g2_decap_4
* cell instance $40981 r0 *1 231.84,185.22
X$40981 VDD VSS sg13g2_decap_4
* cell instance $40982 r0 *1 181.44,200.34
X$40982 VDD VSS sg13g2_decap_4
* cell instance $40983 r0 *1 182.4,170.1
X$40983 VDD VSS sg13g2_decap_4
* cell instance $40984 r0 *1 146.4,94.5
X$40984 VDD VSS sg13g2_decap_4
* cell instance $40985 r0 *1 180.96,147.42
X$40985 VDD VSS sg13g2_decap_4
* cell instance $40986 r0 *1 151.68,56.7
X$40986 VDD VSS sg13g2_decap_4
* cell instance $40987 r0 *1 139.68,343.98
X$40987 VDD VSS sg13g2_decap_4
* cell instance $40988 r0 *1 180,64.26
X$40988 VDD VSS sg13g2_decap_4
* cell instance $40989 r0 *1 167.04,64.26
X$40989 VDD VSS sg13g2_decap_4
* cell instance $40990 r0 *1 177.12,56.7
X$40990 VDD VSS sg13g2_decap_4
* cell instance $40991 r0 *1 236.16,321.3
X$40991 VDD VSS sg13g2_decap_4
* cell instance $40992 r0 *1 24.96,185.22
X$40992 VDD VSS sg13g2_decap_4
* cell instance $40993 r0 *1 14.88,185.22
X$40993 VDD VSS sg13g2_decap_4
* cell instance $40994 r0 *1 13.92,192.78
X$40994 VDD VSS sg13g2_decap_4
* cell instance $40995 r0 *1 293.28,200.34
X$40995 VDD VSS sg13g2_decap_4
* cell instance $40996 r0 *1 176.64,268.38
X$40996 VDD VSS sg13g2_decap_4
* cell instance $40997 r0 *1 8.16,79.38
X$40997 VDD VSS sg13g2_decap_4
* cell instance $40998 r0 *1 69.12,343.98
X$40998 VDD VSS sg13g2_decap_4
* cell instance $40999 r0 *1 129.6,79.38
X$40999 VDD VSS sg13g2_decap_4
* cell instance $41000 r0 *1 8.16,223.02
X$41000 VDD VSS sg13g2_decap_4
* cell instance $41001 r0 *1 311.04,215.46
X$41001 VDD VSS sg13g2_decap_4
* cell instance $41002 r0 *1 296.64,215.46
X$41002 VDD VSS sg13g2_decap_4
* cell instance $41003 r0 *1 26.88,215.46
X$41003 VDD VSS sg13g2_decap_4
* cell instance $41004 r0 *1 268.8,328.86
X$41004 VDD VSS sg13g2_decap_4
* cell instance $41005 r0 *1 36.96,207.9
X$41005 VDD VSS sg13g2_decap_4
* cell instance $41006 r0 *1 136.32,56.7
X$41006 VDD VSS sg13g2_decap_4
* cell instance $41007 r0 *1 129.12,56.7
X$41007 VDD VSS sg13g2_decap_4
* cell instance $41008 r0 *1 262.08,253.26
X$41008 VDD VSS sg13g2_decap_4
* cell instance $41009 r0 *1 289.44,313.74
X$41009 VDD VSS sg13g2_decap_4
* cell instance $41010 r0 *1 22.56,207.9
X$41010 VDD VSS sg13g2_decap_4
* cell instance $41011 r0 *1 23.52,64.26
X$41011 VDD VSS sg13g2_decap_4
* cell instance $41012 r0 *1 14.88,56.7
X$41012 VDD VSS sg13g2_decap_4
* cell instance $41013 r0 *1 38.4,64.26
X$41013 VDD VSS sg13g2_decap_4
* cell instance $41014 r0 *1 43.2,64.26
X$41014 VDD VSS sg13g2_decap_4
* cell instance $41015 r0 *1 34.56,64.26
X$41015 VDD VSS sg13g2_decap_4
* cell instance $41016 r0 *1 161.76,260.82
X$41016 VDD VSS sg13g2_decap_4
* cell instance $41017 r0 *1 40.8,56.7
X$41017 VDD VSS sg13g2_decap_4
* cell instance $41018 r0 *1 11.52,41.58
X$41018 VDD VSS sg13g2_decap_4
* cell instance $41019 r0 *1 137.76,185.22
X$41019 VDD VSS sg13g2_decap_4
* cell instance $41020 r0 *1 8.16,34.02
X$41020 VDD VSS sg13g2_decap_4
* cell instance $41021 r0 *1 8.16,18.9
X$41021 VDD VSS sg13g2_decap_4
* cell instance $41022 r0 *1 156.48,56.7
X$41022 VDD VSS sg13g2_decap_4
* cell instance $41023 r0 *1 175.68,275.94
X$41023 VDD VSS sg13g2_decap_4
* cell instance $41024 r0 *1 36.48,18.9
X$41024 VDD VSS sg13g2_decap_4
* cell instance $41025 r0 *1 84.48,34.02
X$41025 VDD VSS sg13g2_decap_4
* cell instance $41026 r0 *1 288.96,230.58
X$41026 VDD VSS sg13g2_decap_4
* cell instance $41027 r0 *1 74.88,200.34
X$41027 VDD VSS sg13g2_decap_4
* cell instance $41028 r0 *1 229.44,238.14
X$41028 VDD VSS sg13g2_decap_4
* cell instance $41029 r0 *1 90.72,18.9
X$41029 VDD VSS sg13g2_decap_4
* cell instance $41030 r0 *1 54.24,207.9
X$41030 VDD VSS sg13g2_decap_4
* cell instance $41031 r0 *1 176.16,86.94
X$41031 VDD VSS sg13g2_decap_4
* cell instance $41032 r0 *1 246.24,328.86
X$41032 VDD VSS sg13g2_decap_4
* cell instance $41033 r0 *1 148.32,79.38
X$41033 VDD VSS sg13g2_decap_4
* cell instance $41034 r0 *1 278.4,328.86
X$41034 VDD VSS sg13g2_decap_4
* cell instance $41035 r0 *1 228.48,230.58
X$41035 VDD VSS sg13g2_decap_4
* cell instance $41036 r0 *1 206.4,147.42
X$41036 VDD VSS sg13g2_decap_4
* cell instance $41037 r0 *1 187.2,139.86
X$41037 VDD VSS sg13g2_decap_4
* cell instance $41038 r0 *1 88.32,260.82
X$41038 VDD VSS sg13g2_decap_4
* cell instance $41039 r0 *1 8.16,298.62
X$41039 VDD VSS sg13g2_decap_4
* cell instance $41040 r0 *1 189.12,154.98
X$41040 VDD VSS sg13g2_decap_4
* cell instance $41041 r0 *1 84.96,275.94
X$41041 VDD VSS sg13g2_decap_4
* cell instance $41042 r0 *1 195.84,162.54
X$41042 VDD VSS sg13g2_decap_4
* cell instance $41043 r0 *1 188.16,170.1
X$41043 VDD VSS sg13g2_decap_4
* cell instance $41044 r0 *1 320.64,223.02
X$41044 VDD VSS sg13g2_decap_4
* cell instance $41045 r0 *1 226.56,132.3
X$41045 VDD VSS sg13g2_decap_4
* cell instance $41046 r0 *1 207.36,321.3
X$41046 VDD VSS sg13g2_decap_4
* cell instance $41047 r0 *1 28.8,223.02
X$41047 VDD VSS sg13g2_decap_4
* cell instance $41048 r0 *1 84.48,306.18
X$41048 VDD VSS sg13g2_decap_4
* cell instance $41049 r0 *1 195.36,298.62
X$41049 VDD VSS sg13g2_decap_4
* cell instance $41050 r0 *1 238.08,170.1
X$41050 VDD VSS sg13g2_decap_4
* cell instance $41051 r0 *1 242.4,268.38
X$41051 VDD VSS sg13g2_decap_4
* cell instance $41052 r0 *1 190.56,268.38
X$41052 VDD VSS sg13g2_decap_4
* cell instance $41053 r0 *1 218.4,268.38
X$41053 VDD VSS sg13g2_decap_4
* cell instance $41054 r0 *1 262.08,268.38
X$41054 VDD VSS sg13g2_decap_4
* cell instance $41055 r0 *1 306.24,268.38
X$41055 VDD VSS sg13g2_decap_4
* cell instance $41056 r0 *1 242.4,162.54
X$41056 VDD VSS sg13g2_decap_4
* cell instance $41057 r0 *1 187.2,306.18
X$41057 VDD VSS sg13g2_decap_4
* cell instance $41058 r0 *1 87.36,298.62
X$41058 VDD VSS sg13g2_decap_4
* cell instance $41059 r0 *1 265.44,139.86
X$41059 VDD VSS sg13g2_decap_4
* cell instance $41060 r0 *1 323.52,192.78
X$41060 VDD VSS sg13g2_decap_4
* cell instance $41061 r0 *1 257.28,260.82
X$41061 VDD VSS sg13g2_decap_4
* cell instance $41062 r0 *1 276.96,215.46
X$41062 VDD VSS sg13g2_decap_4
* cell instance $41063 r0 *1 255.36,328.86
X$41063 VDD VSS sg13g2_decap_4
* cell instance $41064 r0 *1 247.68,117.18
X$41064 VDD VSS sg13g2_decap_4
* cell instance $41065 r0 *1 247.2,245.7
X$41065 VDD VSS sg13g2_decap_4
* cell instance $41066 r0 *1 225.6,200.34
X$41066 VDD VSS sg13g2_decap_4
* cell instance $41067 r0 *1 42.24,238.14
X$41067 VDD VSS sg13g2_decap_4
* cell instance $41068 r0 *1 8.16,238.14
X$41068 VDD VSS sg13g2_decap_4
* cell instance $41069 r0 *1 26.4,238.14
X$41069 VDD VSS sg13g2_decap_4
* cell instance $41070 r0 *1 23.04,253.26
X$41070 VDD VSS sg13g2_decap_4
* cell instance $41071 r0 *1 186.72,109.62
X$41071 VDD VSS sg13g2_decap_4
* cell instance $41072 r0 *1 224.64,154.98
X$41072 VDD VSS sg13g2_decap_4
* cell instance $41073 r0 *1 152.64,18.9
X$41073 VDD VSS sg13g2_decap_4
* cell instance $41074 r0 *1 290.4,192.78
X$41074 VDD VSS sg13g2_decap_4
* cell instance $41075 r0 *1 144.96,18.9
X$41075 VDD VSS sg13g2_decap_4
* cell instance $41076 r0 *1 269.28,283.5
X$41076 VDD VSS sg13g2_decap_4
* cell instance $41077 r0 *1 34.56,260.82
X$41077 VDD VSS sg13g2_decap_4
* cell instance $41078 r0 *1 243.36,283.5
X$41078 VDD VSS sg13g2_decap_4
* cell instance $41079 r0 *1 8.16,245.7
X$41079 VDD VSS sg13g2_decap_4
* cell instance $41080 r0 *1 292.32,298.62
X$41080 VDD VSS sg13g2_decap_4
* cell instance $41081 r0 *1 222.24,139.86
X$41081 VDD VSS sg13g2_decap_4
* cell instance $41082 r0 *1 268.8,298.62
X$41082 VDD VSS sg13g2_decap_4
* cell instance $41083 r0 *1 212.16,154.98
X$41083 VDD VSS sg13g2_decap_4
* cell instance $41084 r0 *1 275.52,207.9
X$41084 VDD VSS sg13g2_decap_4
* cell instance $41085 r0 *1 47.52,170.1
X$41085 VDD VSS sg13g2_decap_4
* cell instance $41086 r0 *1 38.88,170.1
X$41086 VDD VSS sg13g2_decap_4
* cell instance $41087 r0 *1 132.96,215.46
X$41087 VDD VSS sg13g2_decap_4
* cell instance $41088 r0 *1 35.04,162.54
X$41088 VDD VSS sg13g2_decap_4
* cell instance $41089 r0 *1 284.16,306.18
X$41089 VDD VSS sg13g2_decap_4
* cell instance $41090 r0 *1 207.84,223.02
X$41090 VDD VSS sg13g2_decap_4
* cell instance $41091 r0 *1 8.16,177.66
X$41091 VDD VSS sg13g2_decap_4
* cell instance $41092 r0 *1 8.16,162.54
X$41092 VDD VSS sg13g2_decap_4
* cell instance $41093 r0 *1 8.16,154.98
X$41093 VDD VSS sg13g2_decap_4
* cell instance $41094 r0 *1 8.16,139.86
X$41094 VDD VSS sg13g2_decap_4
* cell instance $41095 r0 *1 205.44,192.78
X$41095 VDD VSS sg13g2_decap_4
* cell instance $41096 r0 *1 44.16,139.86
X$41096 VDD VSS sg13g2_decap_4
* cell instance $41097 r0 *1 39.84,117.18
X$41097 VDD VSS sg13g2_decap_4
* cell instance $41098 r0 *1 100.8,253.26
X$41098 VDD VSS sg13g2_decap_4
* cell instance $41099 r0 *1 14.88,117.18
X$41099 VDD VSS sg13g2_decap_4
* cell instance $41100 r0 *1 122.88,238.14
X$41100 VDD VSS sg13g2_decap_4
* cell instance $41101 r0 *1 8.16,124.74
X$41101 VDD VSS sg13g2_decap_4
* cell instance $41102 r0 *1 8.16,132.3
X$41102 VDD VSS sg13g2_decap_4
* cell instance $41103 r0 *1 312.96,245.7
X$41103 VDD VSS sg13g2_decap_4
* cell instance $41104 r0 *1 200.64,230.58
X$41104 VDD VSS sg13g2_decap_4
* cell instance $41105 r0 *1 14.88,102.06
X$41105 VDD VSS sg13g2_decap_4
* cell instance $41106 r0 *1 21.12,102.06
X$41106 VDD VSS sg13g2_decap_4
* cell instance $41107 r0 *1 8.16,109.62
X$41107 VDD VSS sg13g2_decap_4
* cell instance $41108 r0 *1 114.24,147.42
X$41108 VDD VSS sg13g2_decap_4
* cell instance $41109 r0 *1 42.72,102.06
X$41109 VDD VSS sg13g2_decap_4
* cell instance $41110 r0 *1 300,260.82
X$41110 VDD VSS sg13g2_decap_4
* cell instance $41111 r0 *1 36.48,109.62
X$41111 VDD VSS sg13g2_decap_4
* cell instance $41112 r0 *1 316.32,283.5
X$41112 VDD VSS sg13g2_decap_4
* cell instance $41113 r0 *1 278.88,275.94
X$41113 VDD VSS sg13g2_decap_4
* cell instance $41114 r0 *1 109.44,139.86
X$41114 VDD VSS sg13g2_decap_4
* cell instance $41115 r0 *1 132,147.42
X$41115 VDD VSS sg13g2_decap_4
* cell instance $41116 r0 *1 323.52,291.06
X$41116 VDD VSS sg13g2_decap_4
* cell instance $41117 r0 *1 123.84,154.98
X$41117 VDD VSS sg13g2_decap_4
* cell instance $41118 r0 *1 157.92,207.9
X$41118 VDD VSS sg13g2_decap_4
* cell instance $41119 r0 *1 120.48,117.18
X$41119 VDD VSS sg13g2_decap_4
* cell instance $41120 r0 *1 132.96,124.74
X$41120 VDD VSS sg13g2_decap_4
* cell instance $41121 r0 *1 349.44,306.18
X$41121 VDD VSS sg13g2_decap_4
* cell instance $41122 r0 *1 348.96,298.62
X$41122 VDD VSS sg13g2_decap_4
* cell instance $41123 r0 *1 149.76,215.46
X$41123 VDD VSS sg13g2_decap_4
* cell instance $41124 r0 *1 173.28,207.9
X$41124 VDD VSS sg13g2_decap_4
* cell instance $41125 r0 *1 331.68,260.82
X$41125 VDD VSS sg13g2_decap_4
* cell instance $41126 r0 *1 200.64,215.46
X$41126 VDD VSS sg13g2_decap_4
* cell instance $41127 r0 *1 171.84,215.46
X$41127 VDD VSS sg13g2_decap_4
* cell instance $41128 r0 *1 262.56,223.02
X$41128 VDD VSS sg13g2_decap_4
* cell instance $41129 r0 *1 163.2,124.74
X$41129 VDD VSS sg13g2_decap_4
* cell instance $41130 m0 *1 164.64,132.3
X$41130 VSS \$8367 VDD \$2223 \$7997 sg13g2_xor2_1
* cell instance $41131 r0 *1 247.68,215.46
X$41131 VDD VSS sg13g2_decap_4
* cell instance $41132 r0 *1 221.76,185.22
X$41132 VDD VSS sg13g2_decap_4
* cell instance $41133 r0 *1 141.6,132.3
X$41133 VDD VSS sg13g2_decap_4
* cell instance $41134 r0 *1 166.56,102.06
X$41134 VDD VSS sg13g2_decap_4
* cell instance $41135 r0 *1 287.52,306.18
X$41135 VDD VSS sg13g2_decap_4
* cell instance $41136 r0 *1 197.28,185.22
X$41136 VDD VSS sg13g2_decap_4
* cell instance $41137 r0 *1 74.4,162.54
X$41137 VDD VSS sg13g2_decap_4
* cell instance $41138 r0 *1 78.72,162.54
X$41138 VDD VSS sg13g2_decap_4
* cell instance $41139 r0 *1 330.72,298.62
X$41139 VDD VSS sg13g2_decap_4
* cell instance $41140 r0 *1 298.08,321.3
X$41140 VDD VSS sg13g2_decap_4
* cell instance $41141 r0 *1 166.08,223.02
X$41141 VDD VSS sg13g2_decap_4
* cell instance $41142 r0 *1 193.92,86.94
X$41142 VDD VSS sg13g2_decap_4
* cell instance $41143 r0 *1 332.16,328.86
X$41143 VDD VSS sg13g2_decap_4
* cell instance $41144 r0 *1 278.4,253.26
X$41144 VDD VSS sg13g2_decap_4
* cell instance $41145 r0 *1 34.08,71.82
X$41145 VDD VSS sg13g2_decap_4
* cell instance $41146 r0 *1 155.04,343.98
X$41146 VDD VSS sg13g2_decap_4
* cell instance $41147 r0 *1 152.16,230.58
X$41147 VDD VSS sg13g2_decap_4
* cell instance $41148 r0 *1 274.56,283.5
X$41148 VDD VSS sg13g2_decap_4
* cell instance $41149 r0 *1 70.56,86.94
X$41149 VDD VSS sg13g2_decap_4
* cell instance $41150 r0 *1 8.16,71.82
X$41150 VDD VSS sg13g2_decap_4
* cell instance $41151 r0 *1 8.16,49.14
X$41151 VDD VSS sg13g2_decap_4
* cell instance $41152 r0 *1 66.72,79.38
X$41152 VDD VSS sg13g2_decap_4
* cell instance $41153 r0 *1 220.8,260.82
X$41153 VDD VSS sg13g2_decap_4
* cell instance $41154 r0 *1 219.36,245.7
X$41154 VDD VSS sg13g2_decap_4
* cell instance $41155 r0 *1 224.16,245.7
X$41155 VDD VSS sg13g2_decap_4
* cell instance $41156 r0 *1 207.84,86.94
X$41156 VDD VSS sg13g2_decap_4
* cell instance $41157 r0 *1 290.88,238.14
X$41157 VDD VSS sg13g2_decap_4
* cell instance $41158 r0 *1 248.16,321.3
X$41158 VDD VSS sg13g2_decap_4
* cell instance $41159 r0 *1 254.88,336.42
X$41159 VDD VSS sg13g2_decap_4
* cell instance $41160 r0 *1 279.36,238.14
X$41160 VDD VSS sg13g2_decap_4
* cell instance $41161 r0 *1 257.76,313.74
X$41161 VDD VSS sg13g2_decap_4
* cell instance $41162 r0 *1 133.92,253.26
X$41162 VDD VSS sg13g2_decap_4
* cell instance $41163 r0 *1 69.6,124.74
X$41163 VDD VSS sg13g2_decap_4
* cell instance $41164 r0 *1 129.12,260.82
X$41164 VDD VSS sg13g2_decap_4
* cell instance $41165 r0 *1 8.16,86.94
X$41165 VDD VSS sg13g2_decap_4
* cell instance $41166 r0 *1 349.92,283.5
X$41166 VDD VSS sg13g2_decap_4
* cell instance $41167 r0 *1 66.72,102.06
X$41167 VDD VSS sg13g2_decap_4
* cell instance $41168 r0 *1 106.56,260.82
X$41168 VDD VSS sg13g2_decap_4
* cell instance $41169 r0 *1 184.8,79.38
X$41169 VDD VSS sg13g2_decap_4
* cell instance $41170 r0 *1 273.6,343.98
X$41170 VDD VSS sg13g2_decap_4
* cell instance $41171 r0 *1 283.68,260.82
X$41171 VDD VSS sg13g2_decap_4
* cell instance $41172 r0 *1 306.72,260.82
X$41172 VDD VSS sg13g2_decap_4
* cell instance $41173 r0 *1 251.04,230.58
X$41173 VDD VSS sg13g2_decap_4
* cell instance $41174 r0 *1 191.04,71.82
X$41174 VDD VSS sg13g2_decap_4
* cell instance $41175 r0 *1 70.08,117.18
X$41175 VDD VSS sg13g2_decap_4
* cell instance $41176 r0 *1 343.2,275.94
X$41176 VDD VSS sg13g2_decap_4
* cell instance $41177 r0 *1 117.12,230.58
X$41177 VDD VSS sg13g2_decap_4
* cell instance $41178 m0 *1 148.32,185.22
X$41178 VDD VSS \$11472 \$I98976 sg13g2_inv_1
* cell instance $41179 m0 *1 176.16,328.86
X$41179 VDD VSS \$23108 \$I98975 sg13g2_inv_1
* cell instance $41180 m0 *1 185.28,34.02
X$41180 VDD VSS \$30 \$1168 sg13g2_inv_1
* cell instance $41181 m0 *1 164.16,64.26
X$41181 VDD VSS \$1866 \$3252 sg13g2_inv_1
* cell instance $41182 m0 *1 158.88,79.38
X$41182 VDD VSS \$3607 \$4332 sg13g2_inv_1
* cell instance $41183 m0 *1 253.44,102.06
X$41183 VDD VSS \$4579 \$5867 sg13g2_inv_1
* cell instance $41184 m0 *1 316.32,230.58
X$41184 VDD VSS \$15979 \$15982 sg13g2_inv_1
* cell instance $41185 m0 *1 133.44,238.14
X$41185 VDD VSS \$16492 \$16491 sg13g2_inv_1
* cell instance $41186 m0 *1 209.76,291.06
X$41186 VDD VSS \$20538 \$20014 sg13g2_inv_1
* cell instance $41187 m0 *1 271.68,260.82
X$41187 VDD VSS \$18826 \$19104 sg13g2_inv_1
* cell instance $41188 m0 *1 83.52,185.22
X$41188 VDD VSS \$10976 \$12002 sg13g2_inv_1
* cell instance $41189 m0 *1 120.48,170.1
X$41189 VDD VSS \$11183 \$10989 sg13g2_inv_1
* cell instance $41190 m0 *1 24.96,154.98
X$41190 VDD VSS \$8551 \$I98964 sg13g2_inv_1
* cell instance $41191 m0 *1 160.8,147.42
X$41191 VDD VSS \$7982 \$9267 sg13g2_inv_1
* cell instance $41192 m0 *1 146.88,185.22
X$41192 VDD VSS \$12647 \$12447 sg13g2_inv_1
* cell instance $41193 m0 *1 70.08,18.9
X$41193 VDD VSS \$271 \$185 sg13g2_inv_1
* cell instance $41194 m0 *1 173.76,26.46
X$41194 VDD VSS \$560 \$863 sg13g2_inv_1
* cell instance $41195 m0 *1 316.32,245.7
X$41195 VDD VSS \$17128 \$16812 sg13g2_inv_1
* cell instance $41196 m0 *1 168.96,71.82
X$41196 VDD VSS \$2900 \$I98958 sg13g2_inv_1
* cell instance $41197 m0 *1 270.24,260.82
X$41197 VDD VSS \$17899 \$19103 sg13g2_inv_1
* cell instance $41198 m0 *1 309.6,185.22
X$41198 VDD VSS \$12559 \$11716 sg13g2_inv_1
* cell instance $41199 m0 *1 194.4,170.1
X$41199 VDD VSS \$11229 \$11402 sg13g2_inv_1
* cell instance $41200 m0 *1 150.24,79.38
X$41200 VDD VSS \$3500 \$4184 sg13g2_inv_1
* cell instance $41201 m0 *1 129.12,215.46
X$41201 VDD VSS \$14338 \$13962 sg13g2_inv_1
* cell instance $41202 m0 *1 109.92,283.5
X$41202 VDD VSS \$18790 \$19986 sg13g2_inv_1
* cell instance $41203 m0 *1 176.16,336.42
X$41203 VDD VSS \$24242 \$24477 sg13g2_inv_1
* cell instance $41204 m0 *1 115.68,283.5
X$41204 VDD VSS \$18735 \$20515 sg13g2_inv_1
* cell instance $41205 m0 *1 158.88,49.14
X$41205 VDD VSS \$1089 \$2052 sg13g2_inv_1
* cell instance $41206 m0 *1 315.84,238.14
X$41206 VDD VSS \$15088 \$16644 sg13g2_inv_1
* cell instance $41207 m0 *1 188.64,223.02
X$41207 VDD VSS \$15608 \$15040 sg13g2_inv_1
* cell instance $41208 m0 *1 232.32,34.02
X$41208 VDD VSS \$1003 \$1204 sg13g2_inv_1
* cell instance $41209 m0 *1 175.2,86.94
X$41209 VDD VSS \$3117 \$4553 sg13g2_inv_1
* cell instance $41210 m0 *1 334.56,298.62
X$41210 VDD VSS \$21854 \$21577 sg13g2_inv_1
* cell instance $41211 m0 *1 88.8,147.42
X$41211 VDD VSS \$8876 \$9539 sg13g2_inv_1
* cell instance $41212 m0 *1 110.88,291.06
X$41212 VDD VSS \$20519 \$21384 sg13g2_inv_1
* cell instance $41213 m0 *1 330.24,132.3
X$41213 VDD VSS \$7721 \$I98941 sg13g2_inv_1
* cell instance $41214 m0 *1 149.76,56.7
X$41214 VDD VSS \$1186 \$2510 sg13g2_inv_1
* cell instance $41215 m0 *1 319.2,230.58
X$41215 VDD VSS \$15707 \$15983 sg13g2_inv_1
* cell instance $41216 m0 *1 228,328.86
X$41216 VDD VSS \$23700 \$23832 sg13g2_inv_1
* cell instance $41217 m0 *1 182.88,117.18
X$41217 VDD VSS \$6184 \$6189 sg13g2_inv_1
* cell instance $41218 m0 *1 103.2,298.62
X$41218 VDD VSS \$21825 \$I98936 sg13g2_inv_1
* cell instance $41219 m0 *1 143.04,26.46
X$41219 VDD VSS \$81 \$699 sg13g2_inv_1
* cell instance $41220 m0 *1 82.56,154.98
X$41220 VDD VSS \$8940 \$9935 sg13g2_inv_1
* cell instance $41221 m0 *1 162.72,200.34
X$41221 VDD VSS \$12019 \$12654 sg13g2_inv_1
* cell instance $41222 m0 *1 186.24,71.82
X$41222 VDD VSS \$1869 \$2229 sg13g2_inv_1
* cell instance $41223 m0 *1 112.32,260.82
X$41223 VDD VSS \$18689 \$19268 sg13g2_inv_1
* cell instance $41224 m0 *1 167.04,283.5
X$41224 VDD VSS \$20447 \$I98930 sg13g2_inv_1
* cell instance $41225 m0 *1 180,253.26
X$41225 VDD VSS \$17668 \$17842 sg13g2_inv_1
* cell instance $41226 m0 *1 69.6,260.82
X$41226 VDD VSS \$15634 \$I98928 sg13g2_inv_1
* cell instance $41227 m0 *1 44.16,56.7
X$41227 VDD VSS \$1477 \$2420 sg13g2_inv_1
* cell instance $41228 m0 *1 251.52,245.7
X$41228 VDD VSS \$17087 \$16323 sg13g2_inv_1
* cell instance $41229 m0 *1 282.24,268.38
X$41229 VDD VSS \$19826 \$17112 sg13g2_inv_1
* cell instance $41230 m0 *1 123.36,351.54
X$41230 VDD VSS \$24994 \$25097 sg13g2_inv_1
* cell instance $41231 m0 *1 172.8,260.82
X$41231 VDD VSS \$18282 \$17862 sg13g2_inv_1
* cell instance $41232 m0 *1 116.64,268.38
X$41232 VDD VSS \$11897 \$18738 sg13g2_inv_1
* cell instance $41233 m0 *1 168.48,200.34
X$41233 VDD VSS \$12351 \$12656 sg13g2_inv_1
* cell instance $41234 m0 *1 23.52,64.26
X$41234 VDD VSS \$1384 \$I98920 sg13g2_inv_1
* cell instance $41235 m0 *1 137.76,291.06
X$41235 VDD VSS \$20414 \$21435 sg13g2_inv_1
* cell instance $41236 m0 *1 254.88,343.98
X$41236 VDD VSS \$23700 \$24837 sg13g2_inv_1
* cell instance $41237 m0 *1 258.24,343.98
X$41237 VDD VSS \$24615 \$24731 sg13g2_inv_1
* cell instance $41238 m0 *1 57.6,238.14
X$41238 VDD VSS \$15632 \$16239 sg13g2_inv_1
* cell instance $41239 m0 *1 64.32,238.14
X$41239 VDD VSS \$16246 \$16413 sg13g2_inv_1
* cell instance $41240 m0 *1 154.08,238.14
X$41240 VDD VSS \$16286 \$16141 sg13g2_inv_1
* cell instance $41241 m0 *1 80.16,79.38
X$41241 VDD VSS \$3480 \$4117 sg13g2_inv_1
* cell instance $41242 m0 *1 144.48,238.14
X$41242 VDD VSS \$16136 \$15552 sg13g2_inv_1
* cell instance $41243 m0 *1 42.24,94.5
X$41243 VDD VSS \$3277 \$5215 sg13g2_inv_1
* cell instance $41244 m0 *1 172.32,200.34
X$41244 VDD VSS \$12660 \$12014 sg13g2_inv_1
* cell instance $41245 m0 *1 179.52,200.34
X$41245 VDD VSS \$12638 \$13175 sg13g2_inv_1
* cell instance $41246 m0 *1 274.56,162.54
X$41246 VDD VSS \$10496 \$9650 sg13g2_inv_1
* cell instance $41247 m0 *1 276,162.54
X$41247 VDD VSS \$9474 \$10744 sg13g2_inv_1
* cell instance $41248 m0 *1 308.64,177.66
X$41248 VDD VSS \$11721 \$10902 sg13g2_inv_1
* cell instance $41249 m0 *1 310.08,177.66
X$41249 VDD VSS \$8057 \$11780 sg13g2_inv_1
* cell instance $41250 m0 *1 198.72,253.26
X$41250 VDD VSS \$18289 \$14655 sg13g2_inv_1
* cell instance $41251 m0 *1 288.48,245.7
X$41251 VDD VSS \$16831 \$17470 sg13g2_inv_1
* cell instance $41252 m0 *1 303.84,238.14
X$41252 VDD VSS \$15385 \$15701 sg13g2_inv_1
* cell instance $41253 m0 *1 287.52,109.62
X$41253 VDD VSS \$6962 \$6209 sg13g2_inv_1
* cell instance $41254 m0 *1 320.64,185.22
X$41254 VDD VSS \$12070 \$12177 sg13g2_inv_1
* cell instance $41255 m0 *1 82.08,192.78
X$41255 VDD VSS \$12627 \$12952 sg13g2_inv_1
* cell instance $41256 m0 *1 49.92,223.02
X$41256 VDD VSS \$14981 \$14983 sg13g2_inv_1
* cell instance $41257 m0 *1 214.08,351.54
X$41257 VDD VSS \$25021 \$24541 sg13g2_inv_1
* cell instance $41258 m0 *1 215.52,351.54
X$41258 VDD VSS \$23700 \$25177 sg13g2_inv_1
* cell instance $41259 m0 *1 234.72,245.7
X$41259 VDD VSS \$16959 \$17373 sg13g2_inv_1
* cell instance $41260 m0 *1 216.96,351.54
X$41260 VDD VSS \$23700 \$25181 sg13g2_inv_1
* cell instance $41261 m0 *1 317.76,321.3
X$41261 VDD VSS \$22736 \$23171 sg13g2_inv_1
* cell instance $41262 m0 *1 241.92,162.54
X$41262 VDD VSS \$9284 \$I98892 sg13g2_inv_1
* cell instance $41263 m0 *1 33.12,124.74
X$41263 VDD VSS \$5916 \$I98891 sg13g2_inv_1
* cell instance $41264 m0 *1 182.88,49.14
X$41264 VDD VSS \$1196 \$1898 sg13g2_inv_1
* cell instance $41265 m0 *1 272.64,313.74
X$41265 VDD VSS \$22713 \$22954 sg13g2_inv_1
* cell instance $41266 m0 *1 77.28,117.18
X$41266 VDD VSS \$5142 \$7076 sg13g2_inv_1
* cell instance $41267 m0 *1 164.16,200.34
X$41267 VDD VSS \$12901 \$13165 sg13g2_inv_1
* cell instance $41268 m0 *1 305.28,253.26
X$41268 VDD VSS \$17120 \$18030 sg13g2_inv_1
* cell instance $41269 m0 *1 73.92,253.26
X$41269 VDD VSS \$18270 \$18519 sg13g2_inv_1
* cell instance $41270 m0 *1 103.2,139.86
X$41270 VDD VSS \$6287 \$8756 sg13g2_inv_1
* cell instance $41271 m0 *1 113.76,185.22
X$41271 VDD VSS \$11759 \$12152 sg13g2_inv_1
* cell instance $41272 m0 *1 222.24,275.94
X$41272 VDD VSS \$19605 \$19915 sg13g2_inv_1
* cell instance $41273 m0 *1 328.32,192.78
X$41273 VDD VSS \$12933 \$12955 sg13g2_inv_1
* cell instance $41274 m0 *1 317.28,275.94
X$41274 VDD VSS \$18008 \$20059 sg13g2_inv_1
* cell instance $41275 m0 *1 242.88,275.94
X$41275 VDD VSS \$20456 \$16317 sg13g2_inv_1
* cell instance $41276 m0 *1 156.96,170.1
X$41276 VDD VSS \$9814 \$10998 sg13g2_inv_1
* cell instance $41277 m0 *1 114.72,230.58
X$41277 VDD VSS \$14853 \$15015 sg13g2_inv_1
* cell instance $41278 m0 *1 116.16,230.58
X$41278 VDD VSS \$15341 \$14718 sg13g2_inv_1
* cell instance $41279 m0 *1 276.48,238.14
X$41279 VDD VSS \$15963 \$16161 sg13g2_inv_1
* cell instance $41280 m0 *1 291.84,117.18
X$41280 VDD VSS \$5194 \$6819 sg13g2_inv_1
* cell instance $41281 m0 *1 26.88,49.14
X$41281 VDD VSS \$1291 \$1840 sg13g2_inv_1
* cell instance $41282 m0 *1 110.88,162.54
X$41282 VDD VSS \$10284 \$10699 sg13g2_inv_1
* cell instance $41283 m0 *1 97.92,18.9
X$41283 VDD VSS \$230 \$272 sg13g2_inv_1
* cell instance $41284 m0 *1 108.48,94.5
X$41284 VDD VSS \$2723 \$4295 sg13g2_inv_1
* cell instance $41285 m0 *1 133.44,132.3
X$41285 VDD VSS \$7337 \$7896 sg13g2_inv_1
* cell instance $41286 m0 *1 105.6,177.66
X$41286 VDD VSS \$10977 \$11737 sg13g2_inv_1
* cell instance $41287 m0 *1 126.72,41.58
X$41287 VDD VSS \$973 \$1427 sg13g2_inv_1
* cell instance $41288 m0 *1 162.72,215.46
X$41288 VDD VSS \$14346 \$11395 sg13g2_inv_1
* cell instance $41289 m0 *1 300,343.98
X$41289 VDD VSS \$24873 \$24886 sg13g2_inv_1
* cell instance $41290 m0 *1 181.44,215.46
X$41290 VDD VSS \$13817 \$14217 sg13g2_inv_1
* cell instance $41291 m0 *1 251.04,192.78
X$41291 VDD VSS \$11498 \$11892 sg13g2_inv_1
* cell instance $41292 m0 *1 75.84,298.62
X$41292 VDD VSS \$21303 \$21539 sg13g2_inv_1
* cell instance $41293 m0 *1 138.24,343.98
X$41293 VDD VSS \$23618 \$23675 sg13g2_inv_1
* cell instance $41294 m0 *1 110.88,109.62
X$41294 VDD VSS \$5363 \$6512 sg13g2_inv_1
* cell instance $41295 m0 *1 137.76,18.9
X$41295 VDD VSS \$40 \$275 sg13g2_inv_1
* cell instance $41296 m0 *1 180.48,321.3
X$41296 VDD VSS \$22575 \$I98858 sg13g2_inv_1
* cell instance $41297 m0 *1 126.72,34.02
X$41297 VDD VSS \$79 \$I98857 sg13g2_inv_1
* cell instance $41298 m0 *1 120,132.3
X$41298 VDD VSS \$6914 \$8349 sg13g2_inv_1
* cell instance $41299 m0 *1 255.36,132.3
X$41299 VDD VSS \$8028 \$8375 sg13g2_inv_1
* cell instance $41300 m0 *1 129.6,64.26
X$41300 VDD VSS \$2204 \$2988 sg13g2_inv_1
* cell instance $41301 m0 *1 144.96,192.78
X$41301 VDD VSS \$11868 \$11697 sg13g2_inv_1
* cell instance $41302 m0 *1 149.76,117.18
X$41302 VDD VSS \$6167 \$7283 sg13g2_inv_1
* cell instance $41303 m0 *1 109.92,86.94
X$41303 VDD VSS \$4296 \$4149 sg13g2_inv_1
* cell instance $41304 m0 *1 96.48,170.1
X$41304 VDD VSS \$9617 \$10357 sg13g2_inv_1
* cell instance $41305 m0 *1 207.84,298.62
X$41305 VDD VSS \$20454 \$I98849 sg13g2_inv_1
* cell instance $41306 m0 *1 324.96,306.18
X$41306 VDD VSS \$14080 \$22349 sg13g2_inv_1
* cell instance $41307 m0 *1 129.6,102.06
X$41307 VDD VSS \$5148 \$5992 sg13g2_inv_1
* cell instance $41308 m0 *1 130.56,170.1
X$41308 VDD VSS \$9809 \$I98846 sg13g2_inv_1
* cell instance $41309 m0 *1 151.68,207.9
X$41309 VDD VSS \$13966 \$12984 sg13g2_inv_1
* cell instance $41310 m0 *1 153.6,223.02
X$41310 VDD VSS \$14802 \$15862 sg13g2_inv_1
* cell instance $41311 m0 *1 330.72,260.82
X$41311 VDD VSS \$14462 \$12695 sg13g2_inv_1
* cell instance $41312 m0 *1 268.32,124.74
X$41312 VDD VSS \$5721 \$7582 sg13g2_inv_1
* cell instance $41313 m0 *1 65.28,306.18
X$41313 VDD VSS \$22655 \$22449 sg13g2_inv_1
* cell instance $41314 m0 *1 121.92,56.7
X$41314 VDD VSS \$1226 \$2477 sg13g2_inv_1
* cell instance $41315 m0 *1 155.04,132.3
X$41315 VDD VSS \$6673 \$7989 sg13g2_inv_1
* cell instance $41316 r0 *1 42.72,313.74
X$41316 VDD VSS \$21534 \$I98838 sg13g2_inv_1
* cell instance $41317 r0 *1 88.8,109.62
X$41317 VDD VSS \$6747 \$6761 sg13g2_inv_1
* cell instance $41318 r0 *1 318.72,283.5
X$41318 VDD VSS \$20693 \$20798 sg13g2_inv_1
* cell instance $41319 r0 *1 217.44,253.26
X$41319 VDD VSS \$17864 \$17433 sg13g2_inv_1
* cell instance $41320 r0 *1 48.96,139.86
X$41320 VDD VSS \$8476 \$9356 sg13g2_inv_1
* cell instance $41321 r0 *1 302.4,238.14
X$41321 VDD VSS \$16915 \$16809 sg13g2_inv_1
* cell instance $41322 r0 *1 328.32,215.46
X$41322 VDD VSS \$14479 \$14924 sg13g2_inv_1
* cell instance $41323 r0 *1 306.72,306.18
X$41323 VDD VSS \$20940 \$22420 sg13g2_inv_1
* cell instance $41324 r0 *1 284.16,291.06
X$41324 VDD VSS \$18529 \$21452 sg13g2_inv_1
* cell instance $41325 r0 *1 168,18.9
X$41325 VDD VSS \$31 \$732 sg13g2_inv_1
* cell instance $41326 r0 *1 185.76,86.94
X$41326 VDD VSS \$3711 \$4796 sg13g2_inv_1
* cell instance $41327 r0 *1 32.64,147.42
X$41327 VDD VSS \$8676 \$9615 sg13g2_inv_1
* cell instance $41328 r0 *1 131.04,154.98
X$41328 VDD VSS \$9262 \$10229 sg13g2_inv_1
* cell instance $41329 r0 *1 161.76,102.06
X$41329 VDD VSS \$5006 \$6174 sg13g2_inv_1
* cell instance $41330 r0 *1 324,230.58
X$41330 VDD VSS \$16165 \$15986 sg13g2_inv_1
* cell instance $41331 r0 *1 169.92,49.14
X$41331 VDD VSS \$1109 \$2355 sg13g2_inv_1
* cell instance $41332 r0 *1 240,192.78
X$41332 VDD VSS \$11901 \$13192 sg13g2_inv_1
* cell instance $41333 r0 *1 161.76,132.3
X$41333 VDD VSS \$7550 \$8439 sg13g2_inv_1
* cell instance $41334 r0 *1 178.08,253.26
X$41334 VDD VSS \$17831 \$18093 sg13g2_inv_1
* cell instance $41335 r0 *1 190.08,102.06
X$41335 VDD VSS \$4922 \$6187 sg13g2_inv_1
* cell instance $41336 r0 *1 216.96,336.42
X$41336 VDD VSS \$23700 \$24698 sg13g2_inv_1
* cell instance $41337 r0 *1 71.04,298.62
X$41337 VDD VSS \$22096 \$22050 sg13g2_inv_1
* cell instance $41338 r0 *1 67.2,41.58
X$41338 VDD VSS \$265 \$1669 sg13g2_inv_1
* cell instance $41339 r0 *1 201.12,336.42
X$41339 VDD VSS \$23545 \$24487 sg13g2_inv_1
* cell instance $41340 r0 *1 15.84,170.1
X$41340 VDD VSS \$10081 \$11159 sg13g2_inv_1
* cell instance $41341 r0 *1 202.56,336.42
X$41341 VDD VSS \$23545 \$24067 sg13g2_inv_1
* cell instance $41342 r0 *1 341.76,275.94
X$41342 VDD VSS \$19487 \$20379 sg13g2_inv_1
* cell instance $41343 r0 *1 284.16,283.5
X$41343 VDD VSS \$20938 \$20860 sg13g2_inv_1
* cell instance $41344 r0 *1 296.64,321.3
X$41344 VDD VSS \$23557 \$19020 sg13g2_inv_1
* cell instance $41345 r0 *1 103.2,41.58
X$41345 VDD VSS \$771 \$1417 sg13g2_inv_1
* cell instance $41346 r0 *1 129.6,170.1
X$41346 VDD VSS \$11088 \$11466 sg13g2_inv_1
* cell instance $41347 r0 *1 295.68,102.06
X$41347 VDD VSS \$1923 \$6600 sg13g2_inv_1
* cell instance $41348 r0 *1 39.36,253.26
X$41348 VDD VSS \$18619 \$18663 sg13g2_inv_1
* cell instance $41349 r0 *1 79.2,109.62
X$41349 VDD VSS \$4771 \$6578 sg13g2_inv_1
* cell instance $41350 r0 *1 17.76,102.06
X$41350 VDD VSS \$4268 \$5900 sg13g2_inv_1
* cell instance $41351 r0 *1 131.52,64.26
X$41351 VDD VSS \$1723 \$3465 sg13g2_inv_1
* cell instance $41352 r0 *1 150.72,245.7
X$41352 VDD VSS \$16793 \$17659 sg13g2_inv_1
* cell instance $41353 r0 *1 261.12,328.86
X$41353 VDD VSS \$24088 \$24319 sg13g2_inv_1
* cell instance $41354 r0 *1 35.04,94.5
X$41354 VDD VSS \$3681 \$5134 sg13g2_inv_1
* cell instance $41355 r0 *1 307.68,124.74
X$41355 VDD VSS \$8045 \$2642 sg13g2_inv_1
* cell instance $41356 r0 *1 243.36,291.06
X$41356 VDD VSS \$21444 \$21446 sg13g2_inv_1
* cell instance $41357 r0 *1 315.36,230.58
X$41357 VDD VSS \$15978 \$15705 sg13g2_inv_1
* cell instance $41358 r0 *1 45.12,102.06
X$41358 VDD VSS \$4833 \$6242 sg13g2_inv_1
* cell instance $41359 r0 *1 267.36,94.5
X$41359 VDD VSS \$5419 \$5183 sg13g2_inv_1
* cell instance $41360 r0 *1 282.72,328.86
X$41360 VDD VSS \$23939 \$21328 sg13g2_inv_1
* cell instance $41361 r0 *1 164.64,223.02
X$41361 VDD VSS \$15951 \$15658 sg13g2_inv_1
* cell instance $41362 r0 *1 64.32,117.18
X$41362 VDD VSS \$5708 \$6743 sg13g2_inv_1
* cell instance $41363 r0 *1 210.24,343.98
X$41363 VDD VSS \$23700 \$24960 sg13g2_inv_1
* cell instance $41364 r0 *1 279.36,306.18
X$41364 VDD VSS \$19282 \$22222 sg13g2_inv_1
* cell instance $41365 r0 *1 72.48,124.74
X$41365 VDD VSS \$6621 \$8116 sg13g2_inv_1
* cell instance $41366 r0 *1 152.16,223.02
X$41366 VDD VSS \$15644 \$14354 sg13g2_inv_1
* cell instance $41367 r0 *1 327.84,275.94
X$41367 VDD VSS \$20252 \$20063 sg13g2_inv_1
* cell instance $41368 r0 *1 208.8,343.98
X$41368 VDD VSS \$24758 \$25168 sg13g2_inv_1
* cell instance $41369 r0 *1 121.44,132.3
X$41369 VDD VSS \$8510 \$8591 sg13g2_inv_1
* cell instance $41370 r0 *1 171.84,177.66
X$41370 VDD VSS \$11762 \$11985 sg13g2_inv_1
* cell instance $41371 r0 *1 120,132.3
X$41371 VDD VSS \$7957 \$8586 sg13g2_inv_1
* cell instance $41372 r0 *1 179.04,283.5
X$41372 VDD VSS \$20924 \$I98782 sg13g2_inv_1
* cell instance $41373 r0 *1 73.92,132.3
X$41373 VDD VSS \$7323 \$8723 sg13g2_inv_1
* cell instance $41374 r0 *1 162.24,298.62
X$41374 VDD VSS \$22121 \$I98780 sg13g2_inv_1
* cell instance $41375 r0 *1 303.84,238.14
X$41375 VDD VSS \$15973 \$15704 sg13g2_inv_1
* cell instance $41376 r0 *1 308.16,238.14
X$41376 VDD VSS \$15970 \$16347 sg13g2_inv_1
* cell instance $41377 r0 *1 75.36,34.02
X$41377 VDD VSS \$808 \$1349 sg13g2_inv_1
* cell instance $41378 r0 *1 121.44,238.14
X$41378 VDD VSS \$17009 \$17018 sg13g2_inv_1
* cell instance $41379 r0 *1 348.48,275.94
X$41379 VDD VSS \$19484 \$20076 sg13g2_inv_1
* cell instance $41380 r0 *1 151.68,328.86
X$41380 VDD VSS \$23510 \$24235 sg13g2_inv_1
* cell instance $41381 r0 *1 45.6,117.18
X$41381 VDD VSS \$4976 \$7158 sg13g2_inv_1
* cell instance $41382 r0 *1 142.56,49.14
X$41382 VDD VSS \$1078 \$2494 sg13g2_inv_1
* cell instance $41383 r0 *1 331.2,26.46
X$41383 VDD VSS \$99 \$I98771 sg13g2_inv_1
* cell instance $41384 r0 *1 44.64,124.74
X$41384 VDD VSS \$7844 \$8083 sg13g2_inv_1
* cell instance $41385 r0 *1 192,260.82
X$41385 VDD VSS \$18768 \$19309 sg13g2_inv_1
* cell instance $41386 r0 *1 324.48,177.66
X$41386 VDD VSS \$11784 \$11872 sg13g2_inv_1
* cell instance $41387 r0 *1 110.88,56.7
X$41387 VDD VSS \$1668 \$2464 sg13g2_inv_1
* cell instance $41388 r0 *1 69.6,102.06
X$41388 VDD VSS \$4275 \$I98766 sg13g2_inv_1
* cell instance $41389 r0 *1 64.32,238.14
X$41389 VDD VSS \$17202 \$17196 sg13g2_inv_1
* cell instance $41390 r0 *1 38.4,132.3
X$41390 VDD VSS \$7431 \$7947 sg13g2_inv_1
* cell instance $41391 r0 *1 280.32,154.98
X$41391 VDD VSS \$10311 \$10312 sg13g2_inv_1
* cell instance $41392 r0 *1 186.72,79.38
X$41392 VDD VSS \$3312 \$4226 sg13g2_inv_1
* cell instance $41393 r0 *1 26.88,124.74
X$41393 VDD VSS \$6853 \$7848 sg13g2_inv_1
* cell instance $41394 r0 *1 293.76,238.14
X$41394 VDD VSS \$17718 \$16808 sg13g2_inv_1
* cell instance $41395 r0 *1 320.64,313.74
X$41395 VDD VSS \$22422 \$23173 sg13g2_inv_1
* cell instance $41396 r0 *1 42.72,18.9
X$41396 VDD VSS \$266 \$608 sg13g2_inv_1
* cell instance $41397 r0 *1 105.6,94.5
X$41397 VDD VSS \$4604 \$5973 sg13g2_inv_1
* cell instance $41398 r0 *1 75.84,223.02
X$41398 VDD VSS \$14884 \$15772 sg13g2_inv_1
* cell instance $41399 r0 *1 123.36,86.94
X$41399 VDD VSS \$4284 \$4783 sg13g2_inv_1
* cell instance $41400 r0 *1 286.08,306.18
X$41400 VDD VSS \$22714 \$20134 sg13g2_inv_1
* cell instance $41401 r0 *1 324.96,154.98
X$41401 VDD VSS \$10330 \$10182 sg13g2_inv_1
* cell instance $41402 r0 *1 309.12,268.38
X$41402 VDD VSS \$18819 \$20054 sg13g2_inv_1
* cell instance $41403 r0 *1 47.04,192.78
X$41403 VDD VSS \$11742 \$13259 sg13g2_inv_1
* cell instance $41404 r0 *1 84.96,343.98
X$41404 VDD VSS \$23795 \$24589 sg13g2_inv_1
* cell instance $41405 r0 *1 142.08,86.94
X$41405 VDD VSS \$4786 \$4926 sg13g2_inv_1
* cell instance $41406 r0 *1 36.48,71.82
X$41406 VDD VSS \$2408 \$4088 sg13g2_inv_1
* cell instance $41407 r0 *1 111.36,192.78
X$41407 VDD VSS \$13044 \$13150 sg13g2_inv_1
* cell instance $41408 r0 *1 309.12,200.34
X$41408 VDD VSS \$13603 \$13849 sg13g2_inv_1
* cell instance $41409 r0 *1 105.6,192.78
X$41409 VDD VSS \$13144 \$13309 sg13g2_inv_1
* cell instance $41410 r0 *1 155.04,86.94
X$41410 VDD VSS \$4157 \$5302 sg13g2_inv_1
* cell instance $41411 r0 *1 234.24,328.86
X$41411 VDD VSS \$24803 \$24345 sg13g2_inv_1
* cell instance $41412 r0 *1 292.8,192.78
X$41412 VDD VSS \$11714 \$13334 sg13g2_inv_1
* cell instance $41413 r0 *1 185.76,268.38
X$41413 VDD VSS \$19427 \$19423 sg13g2_inv_1
* cell instance $41414 r0 *1 91.68,56.7
X$41414 VDD VSS \$2721 \$2607 sg13g2_inv_1
* cell instance $41415 r0 *1 143.04,34.02
X$41415 VDD VSS \$455 \$1580 sg13g2_inv_1
* cell instance $41416 r0 *1 65.76,86.94
X$41416 VDD VSS \$4014 \$5446 sg13g2_inv_1
* cell instance $41417 r0 *1 69.12,177.66
X$41417 VDD VSS \$11921 \$11750 sg13g2_inv_1
* cell instance $41418 r0 *1 244.8,268.38
X$41418 VDD VSS \$18469 \$19756 sg13g2_inv_1
* cell instance $41419 r0 *1 188.16,275.94
X$41419 VDD VSS \$20531 \$21705 sg13g2_inv_1
* cell instance $41420 r0 *1 108,215.46
X$41420 VDD VSS \$12633 \$I98734 sg13g2_inv_1
* cell instance $41421 r0 *1 92.16,132.3
X$41421 VDD VSS \$5612 \$I98733 sg13g2_inv_1
* cell instance $41422 r0 *1 189.6,275.94
X$41422 VDD VSS \$20449 \$20525 sg13g2_inv_1
* cell instance $41423 r0 *1 312.48,162.54
X$41423 VDD VSS \$9523 \$10328 sg13g2_inv_1
* cell instance $41424 r0 *1 153.12,238.14
X$41424 VDD VSS \$16888 \$16797 sg13g2_inv_1
* cell instance $41425 r0 *1 172.8,162.54
X$41425 VDD VSS \$10629 \$9630 sg13g2_inv_1
* cell instance $41426 r0 *1 69.6,162.54
X$41426 VDD VSS \$10632 \$10914 sg13g2_inv_1
* cell instance $41427 r0 *1 195.84,185.22
X$41427 VDD VSS \$12534 \$12349 sg13g2_inv_1
* cell instance $41428 r0 *1 336,86.94
X$41428 VDD VSS \$4838 \$2403 sg13g2_inv_1
* cell instance $41429 r0 *1 63.36,283.5
X$41429 VDD VSS \$20914 \$21009 sg13g2_inv_1
* cell instance $41430 r0 *1 77.28,162.54
X$41430 VDD VSS \$10446 \$10043 sg13g2_inv_1
* cell instance $41431 r0 *1 141.6,154.98
X$41431 VDD VSS \$8570 \$10393 sg13g2_inv_1
* cell instance $41432 r0 *1 63.36,154.98
X$41432 VDD VSS \$10273 \$10040 sg13g2_inv_1
* cell instance $41433 r0 *1 138.24,343.98
X$41433 VDD VSS \$24828 \$24827 sg13g2_inv_1
* cell instance $41434 r0 *1 207.84,162.54
X$41434 VDD VSS \$10738 \$11014 sg13g2_inv_1
* cell instance $41435 r0 *1 91.2,64.26
X$41435 VDD VSS \$2600 \$3422 sg13g2_inv_1
* cell instance $41436 r0 *1 121.44,79.38
X$41436 VDD VSS \$2945 \$4030 sg13g2_inv_1
* cell instance $41437 r0 *1 83.52,86.94
X$41437 VDD VSS \$3388 \$4665 sg13g2_inv_1
* cell instance $41438 r0 *1 144.96,109.62
X$41438 VDD VSS \$6417 \$6689 sg13g2_inv_1
* cell instance $41439 r0 *1 73.44,86.94
X$41439 VDD VSS \$4424 \$4766 sg13g2_inv_1
* cell instance $41440 r0 *1 125.28,185.22
X$41440 VDD VSS \$7997 \$12334 sg13g2_inv_1
* cell instance $41441 r0 *1 308.16,170.1
X$41441 VDD VSS \$11515 \$11290 sg13g2_inv_1
* cell instance $41442 r0 *1 277.44,268.38
X$41442 VDD VSS \$20241 \$18311 sg13g2_inv_1
* cell instance $41443 r0 *1 159.36,253.26
X$41443 VDD VSS \$17830 \$18763 sg13g2_inv_1
* cell instance $41444 r0 *1 318.72,291.06
X$41444 VDD VSS \$21456 \$21457 sg13g2_inv_1
* cell instance $41445 r0 *1 271.68,268.38
X$41445 VDD VSS \$19922 \$18827 sg13g2_inv_1
* cell instance $41446 r0 *1 64.8,328.86
X$41446 VDD VSS \$23087 \$I98708 sg13g2_inv_1
* cell instance $41447 r0 *1 152.16,71.82
X$41447 VDD VSS \$3308 \$3847 sg13g2_inv_1
* cell instance $41448 r0 *1 305.76,192.78
X$41448 VDD VSS \$13231 \$13307 sg13g2_inv_1
* cell instance $41449 r0 *1 334.56,132.3
X$41449 VDD VSS \$5917 \$7426 sg13g2_inv_1
* cell instance $41450 r0 *1 182.4,117.18
X$41450 VDD VSS \$7128 \$7689 sg13g2_inv_1
* cell instance $41451 r0 *1 87.84,283.5
X$41451 VDD VSS \$20916 \$21166 sg13g2_inv_1
* cell instance $41452 r0 *1 205.44,79.38
X$41452 VDD VSS \$2617 \$3646 sg13g2_inv_1
* cell instance $41453 r0 *1 330.24,139.86
X$41453 VDD VSS \$9327 \$I98701 sg13g2_inv_1
* cell instance $41454 r0 *1 213.6,79.38
X$41454 VDD VSS \$4588 \$2742 sg13g2_inv_1
* cell instance $41455 r0 *1 176.64,200.34
X$41455 VDD VSS \$13057 \$13816 sg13g2_inv_1
* cell instance $41456 r0 *1 216,260.82
X$41456 VDD VSS \$20021 \$18782 sg13g2_inv_1
* cell instance $41457 r0 *1 63.36,291.06
X$41457 VDD VSS \$20741 \$21481 sg13g2_inv_1
* cell instance $41458 r0 *1 63.36,223.02
X$41458 VDD VSS \$14988 \$14986 sg13g2_inv_1
* cell instance $41459 r0 *1 218.4,343.98
X$41459 VDD VSS \$23700 \$I98695 sg13g2_inv_1
* cell instance $41460 r0 *1 144,170.1
X$41460 VDD VSS \$10046 \$10993 sg13g2_inv_1
* cell instance $41461 r0 *1 29.28,71.82
X$41461 VDD VSS \$3146 \$3687 sg13g2_inv_1
* cell instance $41462 r0 *1 231.84,298.62
X$41462 VDD VSS \$21519 \$21064 sg13g2_inv_1
* cell instance $41463 r0 *1 80.64,162.54
X$41463 VDD VSS \$9541 \$I98691 sg13g2_inv_1
* cell instance $41464 r0 *1 41.76,245.7
X$41464 VDD VSS \$16996 \$17000 sg13g2_inv_1
* cell instance $41465 r0 *1 316.8,230.58
X$41465 VDD VSS \$15714 \$16358 sg13g2_inv_1
* cell instance $41466 r0 *1 325.92,192.78
X$41466 VDD VSS \$11531 \$12384 sg13g2_inv_1
* cell instance $41467 r0 *1 241.44,185.22
X$41467 VDD VSS \$12360 \$12047 sg13g2_inv_1
* cell instance $41468 m0 *1 136.8,283.5
X$41468 VDD VSS \$20351 \$12893 \$20854 sg13g2_nor2_1
* cell instance $41469 m0 *1 297.12,336.42
X$41469 VDD VSS \$22026 \$21085 \$24270 sg13g2_nor2_1
* cell instance $41470 m0 *1 332.64,291.06
X$41470 VDD VSS \$21107 \$20690 \$21105 sg13g2_nor2_1
* cell instance $41471 m0 *1 205.92,147.42
X$41471 VDD VSS \$8614 \$8005 \$8899 sg13g2_nor2_1
* cell instance $41472 m0 *1 48,321.3
X$41472 VDD VSS \$23375 \$23079 \$21605 sg13g2_nor2_1
* cell instance $41473 m0 *1 204.48,132.3
X$41473 VDD VSS \$8006 \$8007 \$8005 sg13g2_nor2_1
* cell instance $41474 m0 *1 229.44,102.06
X$41474 VDD VSS \$5642 \$5648 \$5409 sg13g2_nor2_1
* cell instance $41475 m0 *1 222.72,132.3
X$41475 VDD VSS \$7380 \$7181 \$7373 sg13g2_nor2_1
* cell instance $41476 m0 *1 100.8,275.94
X$41476 VDD VSS \$19983 \$18737 \$19981 sg13g2_nor2_1
* cell instance $41477 m0 *1 247.2,94.5
X$41477 VDD VSS \$5320 \$2959 \$5318 sg13g2_nor2_1
* cell instance $41478 m0 *1 229.44,109.62
X$41478 VDD VSS \$6198 \$6592 \$6440 sg13g2_nor2_1
* cell instance $41479 m0 *1 188.16,49.14
X$41479 VDD VSS \$1889 \$1731 \$1888 sg13g2_nor2_1
* cell instance $41480 m0 *1 82.56,328.86
X$41480 VDD VSS \$23656 \$23665 \$24141 sg13g2_nor2_1
* cell instance $41481 m0 *1 238.56,64.26
X$41481 VDD VSS \$2969 \$2908 \$2968 sg13g2_nor2_1
* cell instance $41482 m0 *1 247.2,109.62
X$41482 VDD VSS \$5875 \$5672 \$6593 sg13g2_nor2_1
* cell instance $41483 m0 *1 223.68,102.06
X$41483 VDD VSS \$5403 \$5855 \$5644 sg13g2_nor2_1
* cell instance $41484 m0 *1 144.96,185.22
X$41484 VDD VSS \$12014 \$12818 \$12820 sg13g2_nor2_1
* cell instance $41485 m0 *1 330.24,283.5
X$41485 VDD VSS \$20691 \$20464 \$20465 sg13g2_nor2_1
* cell instance $41486 m0 *1 220.32,132.3
X$41486 VDD VSS \$7180 \$7368 \$7798 sg13g2_nor2_1
* cell instance $41487 m0 *1 112.32,291.06
X$41487 VDD VSS \$21385 \$21433 \$21310 sg13g2_nor2_1
* cell instance $41488 m0 *1 186.24,49.14
X$41488 VDD VSS \$1894 \$1888 \$981 sg13g2_nor2_1
* cell instance $41489 m0 *1 68.16,185.22
X$41489 VDD VSS \$12285 \$12286 \$12000 sg13g2_nor2_1
* cell instance $41490 m0 *1 322.08,185.22
X$41490 VDD VSS \$9492 \$5917 \$10323 sg13g2_nor2_1
* cell instance $41491 m0 *1 20.64,185.22
X$41491 VDD VSS \$12323 \$12282 \$12324 sg13g2_nor2_1
* cell instance $41492 m0 *1 240.48,132.3
X$41492 VDD VSS \$8021 \$8454 \$8389 sg13g2_nor2_1
* cell instance $41493 m0 *1 337.44,313.74
X$41493 VDD VSS \$22743 \$21947 \$22748 sg13g2_nor2_1
* cell instance $41494 m0 *1 102.24,185.22
X$41494 VDD VSS \$12290 \$12006 \$11458 sg13g2_nor2_1
* cell instance $41495 m0 *1 311.04,321.3
X$41495 VDD VSS \$23170 \$23350 \$23234 sg13g2_nor2_1
* cell instance $41496 m0 *1 332.16,192.78
X$41496 VDD VSS \$11526 \$9492 \$9303 sg13g2_nor2_1
* cell instance $41497 m0 *1 304.32,49.14
X$41497 VDD VSS \$2919 \$3100 \$2080 sg13g2_nor2_1
* cell instance $41498 m0 *1 157.92,343.98
X$41498 VDD VSS \$23531 \$23673 \$23808 sg13g2_nor2_1
* cell instance $41499 m0 *1 72.48,306.18
X$41499 VDD VSS \$22008 \$22050 \$22318 sg13g2_nor2_1
* cell instance $41500 m0 *1 216.48,132.3
X$41500 VDD VSS \$8901 \$8390 \$8272 sg13g2_nor2_1
* cell instance $41501 m0 *1 196.8,94.5
X$41501 VDD VSS \$5017 \$5023 \$3033 sg13g2_nor2_1
* cell instance $41502 m0 *1 201.6,86.94
X$41502 VDD VSS \$4349 \$4347 \$4346 sg13g2_nor2_1
* cell instance $41503 m0 *1 241.44,102.06
X$41503 VDD VSS \$5655 \$5176 \$5763 sg13g2_nor2_1
* cell instance $41504 m0 *1 204.96,283.5
X$41504 VDD VSS \$20772 \$20531 \$20452 sg13g2_nor2_1
* cell instance $41505 m0 *1 53.76,328.86
X$41505 VDD VSS \$23522 \$23086 \$23079 sg13g2_nor2_1
* cell instance $41506 m0 *1 309.12,291.06
X$41506 VDD VSS \$20363 \$21456 \$21739 sg13g2_nor2_1
* cell instance $41507 m0 *1 17.28,185.22
X$41507 VDD VSS \$12566 \$12324 \$10037 sg13g2_nor2_1
* cell instance $41508 m0 *1 208.8,94.5
X$41508 VDD VSS \$5019 \$5021 \$5023 sg13g2_nor2_1
* cell instance $41509 m0 *1 300,283.5
X$41509 VDD VSS \$20795 \$20687 \$20792 sg13g2_nor2_1
* cell instance $41510 m0 *1 218.88,79.38
X$41510 VDD VSS \$1323 \$1782 \$3328 sg13g2_nor2_1
* cell instance $41511 m0 *1 276.96,275.94
X$41511 VDD VSS \$14232 \$20021 \$20358 sg13g2_nor2_1
* cell instance $41512 m0 *1 182.4,41.58
X$41512 VDD VSS \$921 \$1001 \$1317 sg13g2_nor2_1
* cell instance $41513 m0 *1 234.72,86.94
X$41513 VDD VSS \$3182 \$3180 \$4358 sg13g2_nor2_1
* cell instance $41514 m0 *1 244.8,86.94
X$41514 VDD VSS \$3851 \$2968 \$4624 sg13g2_nor2_1
* cell instance $41515 m0 *1 228.96,86.94
X$41515 VDD VSS \$4807 \$4623 \$5174 sg13g2_nor2_1
* cell instance $41516 m0 *1 236.64,86.94
X$41516 VDD VSS \$3337 \$4358 \$4579 sg13g2_nor2_1
* cell instance $41517 m0 *1 232.8,86.94
X$41517 VDD VSS \$3640 \$3734 \$2860 sg13g2_nor2_1
* cell instance $41518 m0 *1 321.12,275.94
X$41518 VDD VSS \$20062 \$20054 \$20251 sg13g2_nor2_1
* cell instance $41519 m0 *1 200.16,147.42
X$41519 VDD VSS \$8612 \$9272 \$9420 sg13g2_nor2_1
* cell instance $41520 m0 *1 189.6,71.82
X$41520 VDD VSS \$3507 \$3135 \$2361 sg13g2_nor2_1
* cell instance $41521 m0 *1 336,56.7
X$41521 VDD VSS \$2635 \$2642 \$2431 sg13g2_nor2_1
* cell instance $41522 m0 *1 215.04,328.86
X$41522 VDD VSS \$23692 \$23642 \$23694 sg13g2_nor2_1
* cell instance $41523 m0 *1 239.52,102.06
X$41523 VDD VSS \$6088 \$5763 \$5648 sg13g2_nor2_1
* cell instance $41524 m0 *1 38.4,291.06
X$41524 VDD VSS \$20997 \$21012 \$20993 sg13g2_nor2_1
* cell instance $41525 m0 *1 218.88,328.86
X$41525 VDD VSS \$23696 \$23697 \$24361 sg13g2_nor2_1
* cell instance $41526 m0 *1 216.96,328.86
X$41526 VDD VSS \$23695 \$23893 \$24496 sg13g2_nor2_1
* cell instance $41527 m0 *1 65.28,185.22
X$41527 VDD VSS \$12000 \$11921 \$12114 sg13g2_nor2_1
* cell instance $41528 m0 *1 31.2,185.22
X$41528 VDD VSS \$12283 \$12327 \$7800 sg13g2_nor2_1
* cell instance $41529 m0 *1 322.56,64.26
X$41529 VDD VSS \$2915 \$2927 \$1791 sg13g2_nor2_1
* cell instance $41530 m0 *1 285.12,275.94
X$41530 VDD VSS \$19682 \$19826 \$20049 sg13g2_nor2_1
* cell instance $41531 m0 *1 198.72,154.98
X$41531 VDD VSS \$9825 \$9822 \$10134 sg13g2_nor2_1
* cell instance $41532 m0 *1 186.24,79.38
X$41532 VDD VSS \$3723 \$3724 \$4041 sg13g2_nor2_1
* cell instance $41533 m0 *1 193.44,147.42
X$41533 VDD VSS \$8446 \$8268 \$9272 sg13g2_nor2_1
* cell instance $41534 m0 *1 330.72,306.18
X$41534 VDD VSS \$22174 \$20558 \$22169 sg13g2_nor2_1
* cell instance $41535 m0 *1 341.76,291.06
X$41535 VDD VSS \$21581 \$21096 \$21114 sg13g2_nor2_1
* cell instance $41536 m0 *1 187.2,109.62
X$41536 VDD VSS \$6427 \$6428 \$6191 sg13g2_nor2_1
* cell instance $41537 m0 *1 225.12,109.62
X$41537 VDD VSS \$6441 \$6440 \$7181 sg13g2_nor2_1
* cell instance $41538 m0 *1 105.6,260.82
X$41538 VDD VSS \$16881 \$17540 \$18750 sg13g2_nor2_1
* cell instance $41539 m0 *1 144.96,170.1
X$41539 VDD VSS \$10995 \$10935 \$10994 sg13g2_nor2_1
* cell instance $41540 m0 *1 61.44,200.34
X$41540 VDD VSS \$13129 \$13132 \$12885 sg13g2_nor2_1
* cell instance $41541 m0 *1 84,154.98
X$41541 VDD VSS \$9456 \$8876 \$9951 sg13g2_nor2_1
* cell instance $41542 m0 *1 301.92,154.98
X$41542 VDD VSS \$10072 \$9663 \$9964 sg13g2_nor2_1
* cell instance $41543 m0 *1 177.6,18.9
X$41543 VDD VSS \$279 \$89 \$105 sg13g2_nor2_1
* cell instance $41544 m0 *1 179.52,18.9
X$41544 VDD VSS \$241 \$280 \$281 sg13g2_nor2_1
* cell instance $41545 m0 *1 328.32,343.98
X$41545 VDD VSS \$24856 \$23183 \$24858 sg13g2_nor2_1
* cell instance $41546 m0 *1 322.56,147.42
X$41546 VDD VSS \$9303 \$8925 \$9485 sg13g2_nor2_1
* cell instance $41547 m0 *1 85.92,154.98
X$41547 VDD VSS \$9452 \$9453 \$9456 sg13g2_nor2_1
* cell instance $41548 m0 *1 244.32,245.7
X$41548 VDD VSS \$16838 \$17455 \$16342 sg13g2_nor2_1
* cell instance $41549 m0 *1 65.76,18.9
X$41549 VDD VSS \$180 \$271 \$520 sg13g2_nor2_1
* cell instance $41550 m0 *1 67.68,18.9
X$41550 VSS \$71 VDD \$148 \$180 \$185 sg13g2_o21ai_1
* cell instance $41551 m0 *1 82.08,283.5
X$41551 VDD VSS \$21021 \$20651 \$20747 sg13g2_nor2_1
* cell instance $41552 m0 *1 88.32,64.26
X$41552 VDD VSS \$2469 \$2463 \$1382 sg13g2_nor2_1
* cell instance $41553 m0 *1 79.2,238.14
X$41553 VDD VSS \$15928 \$16256 \$16254 sg13g2_nor2_1
* cell instance $41554 m0 *1 75.36,238.14
X$41554 VDD VSS \$15925 \$15924 \$17217 sg13g2_nor2_1
* cell instance $41555 m0 *1 45.6,94.5
X$41555 VDD VSS \$4983 \$4430 \$5357 sg13g2_nor2_1
* cell instance $41556 m0 *1 334.08,124.74
X$41556 VDD VSS \$7726 \$4641 \$7424 sg13g2_nor2_1
* cell instance $41557 m0 *1 69.6,49.14
X$41557 VDD VSS \$1843 \$1844 \$2042 sg13g2_nor2_1
* cell instance $41558 m0 *1 73.92,147.42
X$41558 VDD VSS \$9251 \$9450 \$9528 sg13g2_nor2_1
* cell instance $41559 m0 *1 310.56,117.18
X$41559 VDD VSS \$7230 \$8467 \$6832 sg13g2_nor2_1
* cell instance $41560 m0 *1 202.56,275.94
X$41560 VDD VSS \$20012 \$20013 \$18769 sg13g2_nor2_1
* cell instance $41561 m0 *1 75.36,117.18
X$41561 VDD VSS \$6749 \$7028 \$6750 sg13g2_nor2_1
* cell instance $41562 m0 *1 63.36,41.58
X$41562 VDD VSS \$1404 \$265 \$1511 sg13g2_nor2_1
* cell instance $41563 m0 *1 72.96,124.74
X$41563 VDD VSS \$7333 \$6757 \$7673 sg13g2_nor2_1
* cell instance $41564 m0 *1 31.2,94.5
X$41564 VDD VSS \$4978 \$4979 \$4761 sg13g2_nor2_1
* cell instance $41565 m0 *1 29.76,170.1
X$41565 VDD VSS \$11160 \$11161 \$11163 sg13g2_nor2_1
* cell instance $41566 m0 *1 195.36,275.94
X$41566 VDD VSS \$20012 \$20016 \$18631 sg13g2_nor2_1
* cell instance $41567 m0 *1 238.56,139.86
X$41567 VDD VSS \$8626 \$8389 \$8275 sg13g2_nor2_1
* cell instance $41568 m0 *1 144.48,94.5
X$41568 VDD VSS \$5009 \$5007 \$4790 sg13g2_nor2_1
* cell instance $41569 m0 *1 225.6,102.06
X$41569 VDD VSS \$5404 \$5171 \$5855 sg13g2_nor2_1
* cell instance $41570 m0 *1 44.16,139.86
X$41570 VDD VSS \$8084 \$7802 \$8253 sg13g2_nor2_1
* cell instance $41571 m0 *1 42.24,139.86
X$41571 VDD VSS \$8878 \$8418 \$8087 sg13g2_nor2_1
* cell instance $41572 m0 *1 279.84,313.74
X$41572 VDD VSS \$22715 \$22714 \$22889 sg13g2_nor2_1
* cell instance $41573 m0 *1 162.72,94.5
X$41573 VDD VSS \$5010 \$5164 \$5165 sg13g2_nor2_1
* cell instance $41574 m0 *1 80.16,162.54
X$41574 VDD VSS \$10155 \$10446 \$9793 sg13g2_nor2_1
* cell instance $41575 m0 *1 324.96,328.86
X$41575 VDD VSS \$23955 \$23350 \$23844 sg13g2_nor2_1
* cell instance $41576 m0 *1 83.52,177.66
X$41576 VDD VSS \$11756 \$11686 \$11687 sg13g2_nor2_1
* cell instance $41577 m0 *1 305.28,200.34
X$41577 VDD VSS \$13229 \$13603 \$13308 sg13g2_nor2_1
* cell instance $41578 m0 *1 74.88,124.74
X$41578 VDD VSS \$7673 \$6747 \$7330 sg13g2_nor2_1
* cell instance $41579 m0 *1 146.4,192.78
X$41579 VDD VSS \$11483 \$12984 \$12819 sg13g2_nor2_1
* cell instance $41580 m0 *1 300,154.98
X$41580 VDD VSS \$8658 \$6832 \$8648 sg13g2_nor2_1
* cell instance $41581 m0 *1 158.88,147.42
X$41581 VDD VSS \$9268 \$7982 \$9569 sg13g2_nor2_1
* cell instance $41582 m0 *1 112.32,223.02
X$41582 VDD VSS \$15010 \$12973 \$15014 sg13g2_nor2_1
* cell instance $41583 m0 *1 98.4,260.82
X$41583 VDD VSS \$18945 \$19073 \$18912 sg13g2_nor2_1
* cell instance $41584 m0 *1 67.68,170.1
X$41584 VDD VSS \$11172 \$11173 \$10978 sg13g2_nor2_1
* cell instance $41585 m0 *1 158.88,26.46
X$41585 VDD VSS \$553 \$461 \$782 sg13g2_nor2_1
* cell instance $41586 m0 *1 307.2,200.34
X$41586 VDD VSS \$12377 \$11784 \$12315 sg13g2_nor2_1
* cell instance $41587 m0 *1 226.08,162.54
X$41587 VDD VSS \$10481 \$10649 \$10301 sg13g2_nor2_1
* cell instance $41588 r0 *1 228.48,162.54
X$41588 VDD VSS \$11133 \$11021 \$11897 \$6318 \$10485 sg13g2_or4_1
* cell instance $41589 m0 *1 164.64,147.42
X$41589 VDD VSS \$8603 \$8893 \$9268 sg13g2_nor2_1
* cell instance $41590 m0 *1 226.08,132.3
X$41590 VDD VSS \$8013 \$5175 \$8269 sg13g2_nor2_1
* cell instance $41591 m0 *1 69.6,170.1
X$41591 VDD VSS \$10978 \$10632 \$5364 sg13g2_nor2_1
* cell instance $41592 m0 *1 295.68,154.98
X$41592 VDD VSS \$10070 \$9853 \$9851 sg13g2_nor2_1
* cell instance $41593 m0 *1 270.24,321.3
X$41593 VDD VSS \$23349 \$23154 \$23455 sg13g2_nor2_1
* cell instance $41594 m0 *1 270.72,313.74
X$41594 VDD VSS \$22712 \$22954 \$22966 sg13g2_nor2_1
* cell instance $41595 m0 *1 82.08,26.46
X$41595 VDD VSS \$773 \$453 \$227 sg13g2_nor2_1
* cell instance $41596 m0 *1 343.2,328.86
X$41596 VDD VSS \$23724 \$20558 \$23355 sg13g2_nor2_1
* cell instance $41597 m0 *1 26.88,109.62
X$41597 VDD VSS \$6140 \$6138 \$6142 sg13g2_nor2_1
* cell instance $41598 m0 *1 336,170.1
X$41598 VDD VSS \$11038 \$11290 \$11209 sg13g2_nor2_1
* cell instance $41599 m0 *1 46.56,41.58
X$41599 VDD VSS \$1400 \$1047 \$1404 sg13g2_nor2_1
* cell instance $41600 m0 *1 111.84,139.86
X$41600 VDD VSS \$8580 \$7957 \$8577 sg13g2_nor2_1
* cell instance $41601 m0 *1 48.48,147.42
X$41601 VDD VSS \$9249 \$9248 \$9447 sg13g2_nor2_1
* cell instance $41602 m0 *1 39.84,41.58
X$41602 VDD VSS \$1393 \$1392 \$1293 sg13g2_nor2_1
* cell instance $41603 m0 *1 43.2,268.38
X$41603 VDD VSS \$19971 \$19782 \$18494 sg13g2_nor2_1
* cell instance $41604 m0 *1 38.4,117.18
X$41604 VDD VSS \$7318 \$7157 \$7024 sg13g2_nor2_1
* cell instance $41605 m0 *1 28.32,49.14
X$41605 VDD VSS \$2038 \$1753 \$1754 sg13g2_nor2_1
* cell instance $41606 m0 *1 40.32,117.18
X$41606 VDD VSS \$7024 \$4976 \$6735 sg13g2_nor2_1
* cell instance $41607 m0 *1 178.08,253.26
X$41607 VDD VSS \$15847 \$17846 \$18565 sg13g2_nor2_1
* cell instance $41608 m0 *1 236.64,291.06
X$41608 VDD VSS \$20342 \$21444 \$21269 sg13g2_nor2_1
* cell instance $41609 m0 *1 48,56.7
X$41609 VDD VSS \$2309 \$2201 \$2306 sg13g2_nor2_1
* cell instance $41610 m0 *1 33.6,253.26
X$41610 VDD VSS \$16993 \$16992 \$17172 sg13g2_nor2_1
* cell instance $41611 m0 *1 30.24,230.58
X$41611 VDD VSS \$15918 \$15761 \$15993 sg13g2_nor2_1
* cell instance $41612 m0 *1 25.44,117.18
X$41612 VDD VSS \$7056 \$7022 \$5810 sg13g2_nor2_1
* cell instance $41613 m0 *1 23.04,117.18
X$41613 VDD VSS \$7314 \$7054 \$7022 sg13g2_nor2_1
* cell instance $41614 m0 *1 319.68,177.66
X$41614 VDD VSS \$11788 \$11716 \$11782 sg13g2_nor2_1
* cell instance $41615 m0 *1 214.08,275.94
X$41615 VDD VSS \$20017 \$20234 \$15168 sg13g2_nor2_1
* cell instance $41616 m0 *1 50.4,200.34
X$41616 VDD VSS \$13125 \$11742 \$13260 sg13g2_nor2_1
* cell instance $41617 m0 *1 51.36,223.02
X$41617 VDD VSS \$15130 \$8015 \$14985 sg13g2_nor2_1
* cell instance $41618 m0 *1 316.8,328.86
X$41618 VDD VSS \$14423 \$23717 \$23970 sg13g2_nor2_1
* cell instance $41619 m0 *1 108.96,162.54
X$41619 VDD VSS \$10640 \$10453 \$10456 sg13g2_nor2_1
* cell instance $41620 m0 *1 113.28,238.14
X$41620 VDD VSS \$16622 \$16268 \$16270 sg13g2_nor2_1
* cell instance $41621 m0 *1 30.24,71.82
X$41621 VDD VSS \$3280 \$3024 \$3194 sg13g2_nor2_1
* cell instance $41622 m0 *1 48.48,71.82
X$41622 VDD VSS \$3288 \$3287 \$3289 sg13g2_nor2_1
* cell instance $41623 m0 *1 78.72,253.26
X$41623 VDD VSS \$17797 \$17796 \$17794 sg13g2_nor2_1
* cell instance $41624 m0 *1 26.4,132.3
X$41624 VDD VSS \$7311 \$6853 \$8064 sg13g2_nor2_1
* cell instance $41625 m0 *1 38.4,177.66
X$41625 VDD VSS \$11744 \$11743 \$11449 sg13g2_nor2_1
* cell instance $41626 m0 *1 143.04,260.82
X$41626 VDD VSS \$19178 \$19078 \$19154 sg13g2_nor2_1
* cell instance $41627 m0 *1 29.76,253.26
X$41627 VDD VSS \$17403 \$16987 \$16988 sg13g2_nor2_1
* cell instance $41628 m0 *1 48,177.66
X$41628 VDD VSS \$11685 \$11449 \$11450 sg13g2_nor2_1
* cell instance $41629 m0 *1 216,275.94
X$41629 VDD VSS \$20022 \$20013 \$20110 sg13g2_nor2_1
* cell instance $41630 m0 *1 41.76,253.26
X$41630 VDD VSS \$17003 \$17740 \$18267 sg13g2_nor2_1
* cell instance $41631 m0 *1 215.52,283.5
X$41631 VDD VSS \$20022 \$20016 \$20554 sg13g2_nor2_1
* cell instance $41632 m0 *1 43.68,253.26
X$41632 VDD VSS \$17513 \$16996 \$17406 sg13g2_nor2_1
* cell instance $41633 m0 *1 224.16,275.94
X$41633 VDD VSS \$19674 \$19605 \$19601 sg13g2_nor2_1
* cell instance $41634 m0 *1 221.76,291.06
X$41634 VDD VSS \$20342 \$21519 \$21054 sg13g2_nor2_1
* cell instance $41635 m0 *1 31.68,170.1
X$41635 VDD VSS \$11163 \$10081 \$10904 sg13g2_nor2_1
* cell instance $41636 m0 *1 207.84,223.02
X$41636 VDD VSS \$14611 \$14053 \$15553 sg13g2_nor2_1
* cell instance $41637 m0 *1 186.72,238.14
X$41637 VDD VSS \$15946 \$15951 \$16542 sg13g2_nor2_1
* cell instance $41638 m0 *1 277.44,328.86
X$41638 VDD VSS \$23021 \$23159 \$23554 sg13g2_nor2_1
* cell instance $41639 m0 *1 153.6,230.58
X$41639 VDD VSS \$15248 \$15552 \$15861 sg13g2_nor2_1
* cell instance $41640 m0 *1 23.52,177.66
X$41640 VDD VSS \$10971 \$10038 \$10758 sg13g2_nor2_1
* cell instance $41641 m0 *1 321.12,230.58
X$41641 VDD VSS \$12561 \$15585 \$15111 sg13g2_nor2_1
* cell instance $41642 m0 *1 33.6,260.82
X$41642 VDD VSS \$19065 \$14984 \$17639 sg13g2_nor2_1
* cell instance $41643 m0 *1 25.44,79.38
X$41643 VDD VSS \$3882 \$3559 \$3195 sg13g2_nor2_1
* cell instance $41644 m0 *1 282.24,139.86
X$41644 VDD VSS \$5717 \$5255 \$5975 sg13g2_nor2_1
* cell instance $41645 m0 *1 23.04,154.98
X$41645 VDD VSS \$10272 \$9780 \$10038 sg13g2_nor2_1
* cell instance $41646 m0 *1 349.92,139.86
X$41646 VDD VSS \$8674 \$8925 \$9150 sg13g2_nor2_1
* cell instance $41647 m0 *1 27.36,154.98
X$41647 VDD VSS \$9440 \$8676 \$9676 sg13g2_nor2_1
* cell instance $41648 m0 *1 278.4,139.86
X$41648 VDD VSS \$8642 \$7832 \$9055 sg13g2_nor2_1
* cell instance $41649 m0 *1 276.48,139.86
X$41649 VDD VSS \$3766 \$2080 \$5255 sg13g2_nor2_1
* cell instance $41650 m0 *1 280.32,139.86
X$41650 VDD VSS \$8759 \$5678 \$5873 sg13g2_nor2_1
* cell instance $41651 m0 *1 23.04,41.58
X$41651 VDD VSS \$1387 \$1182 \$1479 sg13g2_nor2_1
* cell instance $41652 m0 *1 113.76,139.86
X$41652 VDD VSS \$8883 \$8578 \$8580 sg13g2_nor2_1
* cell instance $41653 m0 *1 143.52,230.58
X$41653 VDD VSS \$15651 \$16284 \$16053 sg13g2_nor2_1
* cell instance $41654 m0 *1 116.64,18.9
X$41654 VDD VSS \$153 \$234 \$235 sg13g2_nor2_1
* cell instance $41655 m0 *1 254.88,260.82
X$41655 VDD VSS \$18815 \$17678 \$18484 sg13g2_nor2_1
* cell instance $41656 m0 *1 286.56,154.98
X$41656 VDD VSS \$10175 \$9844 \$9991 sg13g2_nor2_1
* cell instance $41657 m0 *1 301.44,343.98
X$41657 VDD VSS \$24096 \$24273 \$24784 sg13g2_nor2_1
* cell instance $41658 m0 *1 315.36,306.18
X$41658 VDD VSS \$17701 \$20021 \$22424 sg13g2_nor2_1
* cell instance $41659 m0 *1 131.04,64.26
X$41659 VDD VSS \$2891 \$2204 \$2828 sg13g2_nor2_1
* cell instance $41660 m0 *1 125.28,64.26
X$41660 VDD VSS \$2890 \$2733 \$2891 sg13g2_nor2_1
* cell instance $41661 m0 *1 70.56,94.5
X$41661 VDD VSS \$5240 \$5362 \$4768 sg13g2_nor2_1
* cell instance $41662 m0 *1 67.68,94.5
X$41662 VDD VSS \$4764 \$4853 \$4988 sg13g2_nor2_1
* cell instance $41663 m0 *1 257.28,253.26
X$41663 VDD VSS \$17678 \$16838 \$15078 sg13g2_nor2_1
* cell instance $41664 m0 *1 250.08,253.26
X$41664 VDD VSS \$18301 \$17455 \$15250 sg13g2_nor2_1
* cell instance $41665 m0 *1 253.92,253.26
X$41665 VDD VSS \$18301 \$17331 \$14905 sg13g2_nor2_1
* cell instance $41666 m0 *1 239.52,268.38
X$41666 VDD VSS \$18814 \$19756 \$19449 sg13g2_nor2_1
* cell instance $41667 m0 *1 330.72,268.38
X$41667 VDD VSS \$19689 \$19763 \$18820 sg13g2_nor2_1
* cell instance $41668 m0 *1 65.28,124.74
X$41668 VDD VSS \$7671 \$6890 \$6401 sg13g2_nor2_1
* cell instance $41669 m0 *1 131.04,109.62
X$41669 VDD VSS \$6418 \$6417 \$6531 sg13g2_nor2_1
* cell instance $41670 m0 *1 247.68,268.38
X$41670 VDD VSS \$17678 \$18816 \$20039 sg13g2_nor2_1
* cell instance $41671 m0 *1 242.4,260.82
X$41671 VDD VSS \$18466 \$17876 \$17879 sg13g2_nor2_1
* cell instance $41672 m0 *1 240.48,260.82
X$41672 VDD VSS \$18796 \$19189 \$14063 sg13g2_nor2_1
* cell instance $41673 m0 *1 165.6,223.02
X$41673 VDD VSS \$13962 \$15359 \$15034 sg13g2_nor2_1
* cell instance $41674 m0 *1 276,147.42
X$41674 VDD VSS \$9294 \$9293 \$9474 sg13g2_nor2_1
* cell instance $41675 m0 *1 236.64,260.82
X$41675 VDD VSS \$15524 \$17003 \$18805 sg13g2_nor2_1
* cell instance $41676 m0 *1 105.12,253.26
X$41676 VDD VSS \$17018 \$15937 \$17802 sg13g2_nor2_1
* cell instance $41677 m0 *1 277.44,343.98
X$41677 VDD VSS \$22715 \$23939 \$24773 sg13g2_nor2_1
* cell instance $41678 m0 *1 104.64,94.5
X$41678 VDD VSS \$5263 \$5154 \$4997 sg13g2_nor2_1
* cell instance $41679 m0 *1 292.32,192.78
X$41679 VDD VSS \$12377 \$11714 \$12709 sg13g2_nor2_1
* cell instance $41680 m0 *1 252,253.26
X$41680 VDD VSS \$17678 \$18301 \$15697 sg13g2_nor2_1
* cell instance $41681 m0 *1 164.16,49.14
X$41681 VDD VSS \$1877 \$1109 \$2163 sg13g2_nor2_1
* cell instance $41682 m0 *1 108.48,41.58
X$41682 VDD VSS \$1304 \$1305 \$1418 sg13g2_nor2_1
* cell instance $41683 m0 *1 258.24,147.42
X$41683 VDD VSS \$9470 \$9469 \$9288 sg13g2_nor2_1
* cell instance $41684 m0 *1 297.12,200.34
X$41684 VDD VSS \$13229 \$13231 \$13478 sg13g2_nor2_1
* cell instance $41685 m0 *1 155.52,238.14
X$41685 VDD VSS \$16795 \$16288 \$16518 sg13g2_nor2_1
* cell instance $41686 m0 *1 253.92,147.42
X$41686 VDD VSS \$9385 \$9288 \$8909 sg13g2_nor2_1
* cell instance $41687 m0 *1 75.84,79.38
X$41687 VDD VSS \$4021 \$3480 \$1847 sg13g2_nor2_1
* cell instance $41688 m0 *1 88.32,79.38
X$41688 VDD VSS \$4126 \$3493 \$3895 sg13g2_nor2_1
* cell instance $41689 m0 *1 41.76,223.02
X$41689 VDD VSS \$14298 \$14979 \$14980 sg13g2_nor2_1
* cell instance $41690 m0 *1 99.84,18.9
X$41690 VDD VSS \$273 \$316 \$381 sg13g2_nor2_1
* cell instance $41691 m0 *1 122.88,49.14
X$41691 VDD VSS \$1862 \$1861 \$2208 sg13g2_nor2_1
* cell instance $41692 m0 *1 229.92,223.02
X$41692 VDD VSS \$15524 \$14013 \$15316 sg13g2_nor2_1
* cell instance $41693 m0 *1 89.28,298.62
X$41693 VDD VSS \$21822 \$22386 \$21681 sg13g2_nor2_1
* cell instance $41694 m0 *1 233.28,154.98
X$41694 VDD VSS \$10481 \$10061 \$9128 sg13g2_nor2_1
* cell instance $41695 m0 *1 274.56,177.66
X$41695 VDD VSS \$12238 \$12046 \$12547 sg13g2_nor2_1
* cell instance $41696 m0 *1 120.96,154.98
X$41696 VDD VSS \$8887 \$8510 \$10365 sg13g2_nor2_1
* cell instance $41697 m0 *1 116.16,124.74
X$41697 VDD VSS \$7172 \$7681 \$7682 sg13g2_nor2_1
* cell instance $41698 m0 *1 109.44,117.18
X$41698 VDD VSS \$6581 \$5363 \$6772 sg13g2_nor2_1
* cell instance $41699 m0 *1 315.84,313.74
X$41699 VDD VSS \$22474 \$22420 \$22731 sg13g2_nor2_1
* cell instance $41700 m0 *1 166.56,238.14
X$41700 VDD VSS \$15248 \$16141 \$16534 sg13g2_nor2_1
* cell instance $41701 m0 *1 311.52,328.86
X$41701 VDD VSS \$23840 \$23842 \$23743 sg13g2_nor2_1
* cell instance $41702 m0 *1 63.36,306.18
X$41702 VDD VSS \$22377 \$21605 \$22365 sg13g2_nor2_1
* cell instance $41703 m0 *1 111.36,117.18
X$41703 VDD VSS \$7171 \$6412 \$6581 sg13g2_nor2_1
* cell instance $41704 m0 *1 86.4,79.38
X$41704 VDD VSS \$3700 \$2600 \$4028 sg13g2_nor2_1
* cell instance $41705 m0 *1 118.08,132.3
X$41705 VDD VSS \$7682 \$6914 \$8429 sg13g2_nor2_1
* cell instance $41706 m0 *1 291.36,154.98
X$41706 VDD VSS \$9852 \$9851 \$9844 sg13g2_nor2_1
* cell instance $41707 m0 *1 156.48,215.46
X$41707 VDD VSS \$15248 \$14354 \$14801 sg13g2_nor2_1
* cell instance $41708 m0 *1 29.28,192.78
X$41708 VDD VSS \$12621 \$12410 \$12327 sg13g2_nor2_1
* cell instance $41709 m0 *1 256.32,177.66
X$41709 VDD VSS \$11709 \$11501 \$11909 sg13g2_nor2_1
* cell instance $41710 m0 *1 163.68,207.9
X$41710 VDD VSS \$13165 \$14043 \$13812 sg13g2_nor2_1
* cell instance $41711 m0 *1 226.56,253.26
X$41711 VDD VSS \$16152 \$13181 \$18592 sg13g2_nor2_1
* cell instance $41712 m0 *1 116.64,64.26
X$41712 VDD VSS \$2888 \$3104 \$2115 sg13g2_nor2_1
* cell instance $41713 m0 *1 71.04,79.38
X$41713 VDD VSS \$3696 \$3783 \$4021 sg13g2_nor2_1
* cell instance $41714 m0 *1 65.76,268.38
X$41714 VDD VSS \$19407 \$19715 \$17202 sg13g2_nor2_1
* cell instance $41715 m0 *1 163.68,71.82
X$41715 VDD VSS \$3504 \$3313 \$3310 sg13g2_nor2_1
* cell instance $41716 m0 *1 222.72,260.82
X$41716 VDD VSS \$18796 \$19190 \$15506 sg13g2_nor2_1
* cell instance $41717 m0 *1 65.76,56.7
X$41717 VDD VSS \$2311 \$2313 \$2317 sg13g2_nor2_1
* cell instance $41718 m0 *1 278.4,223.02
X$41718 VDD VSS \$15070 \$14242 \$16094 sg13g2_nor2_1
* cell instance $41719 m0 *1 44.64,192.78
X$41719 VDD VSS \$13124 \$12883 \$13125 sg13g2_nor2_1
* cell instance $41720 m0 *1 180.96,49.14
X$41720 VDD VSS \$2227 \$2060 \$1877 sg13g2_nor2_1
* cell instance $41721 m0 *1 22.56,245.7
X$41721 VDD VSS \$18263 \$17486 \$16985 sg13g2_nor2_1
* cell instance $41722 m0 *1 150.72,34.02
X$41722 VDD VSS \$988 \$987 \$912 sg13g2_nor2_1
* cell instance $41723 m0 *1 72,223.02
X$41723 VDD VSS \$14991 \$14313 \$14988 sg13g2_nor2_1
* cell instance $41724 m0 *1 72.48,215.46
X$41724 VDD VSS \$14691 \$14784 \$14313 sg13g2_nor2_1
* cell instance $41725 m0 *1 272.16,321.3
X$41725 VDD VSS \$22151 \$22714 \$23349 sg13g2_nor2_1
* cell instance $41726 m0 *1 118.08,268.38
X$41726 VDD VSS \$19653 \$11195 \$19156 sg13g2_nor2_1
* cell instance $41727 m0 *1 141.12,49.14
X$41727 VDD VSS \$2151 \$1867 \$2048 sg13g2_nor2_1
* cell instance $41728 m0 *1 253.44,162.54
X$41728 VDD VSS \$6804 \$8909 \$10586 sg13g2_nor2_1
* cell instance $41729 m0 *1 257.28,275.94
X$41729 VDD VSS \$20342 \$20241 \$20242 sg13g2_nor2_1
* cell instance $41730 m0 *1 79.2,64.26
X$41730 VDD VSS \$2879 \$2323 \$2877 sg13g2_nor2_1
* cell instance $41731 m0 *1 82.08,162.54
X$41731 VDD VSS \$10275 \$9717 \$10155 sg13g2_nor2_1
* cell instance $41732 m0 *1 67.68,268.38
X$41732 VDD VSS \$19409 \$19408 \$19715 sg13g2_nor2_1
* cell instance $41733 m0 *1 156,147.42
X$41733 VDD VSS \$8548 \$7990 \$8437 sg13g2_nor2_1
* cell instance $41734 m0 *1 307.2,351.54
X$41734 VDD VSS \$24552 \$24273 \$25041 sg13g2_nor2_1
* cell instance $41735 m0 *1 170.4,170.1
X$41735 VDD VSS \$11480 \$11395 \$11478 sg13g2_nor2_1
* cell instance $41736 m0 *1 140.64,117.18
X$41736 VDD VSS \$6775 \$7036 \$6418 sg13g2_nor2_1
* cell instance $41737 m0 *1 123.84,94.5
X$41737 VDD VSS \$5274 \$5157 \$5002 sg13g2_nor2_1
* cell instance $41738 m0 *1 345.12,328.86
X$41738 VDD VSS \$23354 \$23957 \$23959 sg13g2_nor2_1
* cell instance $41739 m0 *1 155.04,207.9
X$41739 VDD VSS \$11483 \$13962 \$13809 sg13g2_nor2_1
* cell instance $41740 m0 *1 155.04,245.7
X$41740 VDD VSS \$15248 \$17018 \$17583 sg13g2_nor2_1
* cell instance $41741 m0 *1 203.04,283.5
X$41741 VDD VSS \$20195 \$20014 \$20508 sg13g2_nor2_1
* cell instance $41742 m0 *1 180.96,117.18
X$41742 VDD VSS \$6185 \$5844 \$5633 sg13g2_nor2_1
* cell instance $41743 m0 *1 280.32,147.42
X$41743 VDD VSS \$9475 \$9295 \$9293 sg13g2_nor2_1
* cell instance $41744 m0 *1 160.32,49.14
X$41744 VDD VSS \$1873 \$1871 \$2160 sg13g2_nor2_1
* cell instance $41745 m0 *1 285.6,147.42
X$41745 VDD VSS \$4180 \$3955 \$9371 sg13g2_nor2_1
* cell instance $41746 m0 *1 274.08,298.62
X$41746 VDD VSS \$22149 \$19282 \$21959 sg13g2_nor2_1
* cell instance $41747 m0 *1 61.44,283.5
X$41747 VDD VSS \$20744 \$21009 \$20648 sg13g2_nor2_1
* cell instance $41748 r0 *1 225.6,328.86
X$41748 VDD VSS \$23928 \$24073 \$24250 sg13g2_nor2_1
* cell instance $41749 r0 *1 153.12,260.82
X$41749 VDD VSS \$19909 \$19423 \$19179 sg13g2_nor2_1
* cell instance $41750 r0 *1 206.4,117.18
X$41750 VDD VSS \$7606 \$7367 \$7368 sg13g2_nor2_1
* cell instance $41751 r0 *1 74.4,56.7
X$41751 VDD VSS \$2795 \$2877 \$4658 sg13g2_nor2_1
* cell instance $41752 r0 *1 23.04,291.06
X$41752 VDD VSS \$20992 \$21532 \$21012 sg13g2_nor2_1
* cell instance $41753 r0 *1 176.64,260.82
X$41753 VDD VSS \$15946 \$18768 \$19291 sg13g2_nor2_1
* cell instance $41754 r0 *1 45.6,64.26
X$41754 VDD VSS \$3148 \$4019 \$3287 sg13g2_nor2_1
* cell instance $41755 r0 *1 79.68,238.14
X$41755 VDD VSS \$16250 \$17217 \$16244 sg13g2_nor2_1
* cell instance $41756 r0 *1 47.52,64.26
X$41756 VDD VSS \$3206 \$2599 \$3288 sg13g2_nor2_1
* cell instance $41757 r0 *1 204,109.62
X$41757 VDD VSS \$6788 \$6590 \$6436 sg13g2_nor2_1
* cell instance $41758 r0 *1 290.88,253.26
X$41758 VDD VSS \$16336 \$17718 \$18085 sg13g2_nor2_1
* cell instance $41759 r0 *1 334.56,328.86
X$41759 VDD VSS \$24106 \$23183 \$24105 sg13g2_nor2_1
* cell instance $41760 r0 *1 75.36,86.94
X$41760 VDD VSS \$4768 \$4424 \$4867 sg13g2_nor2_1
* cell instance $41761 r0 *1 206.88,139.86
X$41761 VDD VSS \$9120 \$8899 \$8898 sg13g2_nor2_1
* cell instance $41762 r0 *1 204.48,117.18
X$41762 VDD VSS \$7366 \$7149 \$7367 sg13g2_nor2_1
* cell instance $41763 r0 *1 224.16,139.86
X$41763 VDD VSS \$9128 \$9127 \$9405 sg13g2_nor2_1
* cell instance $41764 r0 *1 273.6,253.26
X$41764 VDD VSS \$18820 \$14462 \$17826 sg13g2_nor2_1
* cell instance $41765 r0 *1 89.28,64.26
X$41765 VDD VSS \$2463 \$1668 \$2724 sg13g2_nor2_1
* cell instance $41766 r0 *1 162.24,192.78
X$41766 VDD VSS \$11483 \$13165 \$13168 sg13g2_nor2_1
* cell instance $41767 r0 *1 217.44,245.7
X$41767 VDD VSS \$14232 \$17864 \$17754 sg13g2_nor2_1
* cell instance $41768 r0 *1 143.04,154.98
X$41768 VDD VSS \$9632 \$9812 \$10161 sg13g2_nor2_1
* cell instance $41769 r0 *1 276.48,283.5
X$41769 VDD VSS \$20461 \$20938 \$21077 sg13g2_nor2_1
* cell instance $41770 r0 *1 285.6,170.1
X$41770 VDD VSS \$11509 \$11506 \$10780 sg13g2_nor2_1
* cell instance $41771 r0 *1 289.92,170.1
X$41771 VDD VSS \$11281 \$11280 \$11506 sg13g2_nor2_1
* cell instance $41772 r0 *1 63.84,56.7
X$41772 VDD VSS \$2606 \$2317 \$2641 sg13g2_nor2_1
* cell instance $41773 r0 *1 45.6,321.3
X$41773 VDD VSS \$22858 \$22556 \$22082 sg13g2_nor2_1
* cell instance $41774 r0 *1 146.88,238.14
X$41774 VDD VSS \$16895 \$15648 \$16284 sg13g2_nor2_1
* cell instance $41775 r0 *1 144.96,238.14
X$41775 VDD VSS \$16888 \$16286 \$16895 sg13g2_nor2_1
* cell instance $41776 r0 *1 42.24,71.82
X$41776 VDD VSS \$3690 \$2408 \$3689 sg13g2_nor2_1
* cell instance $41777 r0 *1 288,170.1
X$41777 VDD VSS \$11634 \$8637 \$10420 sg13g2_nor2_1
* cell instance $41778 r0 *1 319.2,185.22
X$41778 VDD VSS \$12559 \$12070 \$12791 sg13g2_nor2_1
* cell instance $41779 r0 *1 85.44,79.38
X$41779 VDD VSS \$4281 \$3388 \$4025 sg13g2_nor2_1
* cell instance $41780 r0 *1 40.32,71.82
X$41780 VDD VSS \$3886 \$3484 \$3690 sg13g2_nor2_1
* cell instance $41781 r0 *1 222.24,71.82
X$41781 VDD VSS \$3515 \$2620 \$2074 sg13g2_nor2_1
* cell instance $41782 r0 *1 21.6,64.26
X$41782 VDD VSS \$3195 \$3146 \$3680 sg13g2_nor2_1
* cell instance $41783 r0 *1 251.04,56.7
X$41783 VDD VSS \$2748 \$2860 \$2959 sg13g2_nor2_1
* cell instance $41784 r0 *1 204,64.26
X$41784 VDD VSS \$3175 \$3325 \$3322 sg13g2_nor2_1
* cell instance $41785 r0 *1 25.92,64.26
X$41785 VDD VSS \$3281 \$3194 \$2196 sg13g2_nor2_1
* cell instance $41786 r0 *1 193.92,71.82
X$41786 VDD VSS \$3322 \$2617 \$3160 sg13g2_nor2_1
* cell instance $41787 r0 *1 151.2,260.82
X$41787 VDD VSS \$19179 \$19735 \$19286 sg13g2_nor2_1
* cell instance $41788 r0 *1 221.28,132.3
X$41788 VDD VSS \$8450 \$8618 \$8390 sg13g2_nor2_1
* cell instance $41789 r0 *1 176.16,253.26
X$41789 VDD VSS \$15846 \$18768 \$18767 sg13g2_nor2_1
* cell instance $41790 r0 *1 206.88,245.7
X$41790 VDD VSS \$14052 \$16309 \$16557 sg13g2_nor2_1
* cell instance $41791 r0 *1 28.32,238.14
X$41791 VDD VSS \$17153 \$16869 \$16987 sg13g2_nor2_1
* cell instance $41792 r0 *1 29.76,291.06
X$41792 VDD VSS \$20912 \$20994 \$21532 sg13g2_nor2_1
* cell instance $41793 r0 *1 253.44,245.7
X$41793 VDD VSS \$16838 \$17331 \$14911 sg13g2_nor2_1
* cell instance $41794 r0 *1 110.88,86.94
X$41794 VDD VSS \$2886 \$2730 \$3104 sg13g2_nor2_1
* cell instance $41795 r0 *1 246.72,260.82
X$41795 VDD VSS \$18814 \$18469 \$18296 sg13g2_nor2_1
* cell instance $41796 r0 *1 121.44,86.94
X$41796 VDD VSS \$4775 \$4302 \$3816 sg13g2_nor2_1
* cell instance $41797 r0 *1 243.36,102.06
X$41797 VDD VSS \$5860 \$5867 \$5178 sg13g2_nor2_1
* cell instance $41798 r0 *1 161.76,18.9
X$41798 VDD VSS \$277 \$462 \$461 sg13g2_nor2_1
* cell instance $41799 r0 *1 245.28,102.06
X$41799 VDD VSS \$5178 \$6356 \$5417 sg13g2_nor2_1
* cell instance $41800 r0 *1 129.12,71.82
X$41800 VDD VSS \$3897 \$3709 \$4003 sg13g2_nor2_1
* cell instance $41801 r0 *1 32.16,238.14
X$41801 VDD VSS \$16228 \$15993 \$16777 sg13g2_nor2_1
* cell instance $41802 r0 *1 217.44,102.06
X$41802 VDD VSS \$5850 \$5644 \$5849 sg13g2_nor2_1
* cell instance $41803 r0 *1 138.72,321.3
X$41803 VDD VSS \$23533 \$23618 \$23507 sg13g2_nor2_1
* cell instance $41804 r0 *1 223.68,102.06
X$41804 VDD VSS \$5172 \$5174 \$5406 sg13g2_nor2_1
* cell instance $41805 r0 *1 83.52,79.38
X$41805 VDD VSS \$4023 \$4122 \$4281 sg13g2_nor2_1
* cell instance $41806 r0 *1 242.88,185.22
X$41806 VDD VSS \$12358 \$12360 \$12266 sg13g2_nor2_1
* cell instance $41807 r0 *1 174.72,64.26
X$41807 VDD VSS \$3171 \$2901 \$3168 sg13g2_nor2_1
* cell instance $41808 r0 *1 179.52,34.02
X$41808 VDD VSS \$784 \$560 \$1733 sg13g2_nor2_1
* cell instance $41809 r0 *1 177.6,34.02
X$41809 VDD VSS \$339 \$343 \$784 sg13g2_nor2_1
* cell instance $41810 r0 *1 228.48,328.86
X$41810 VDD VSS \$23695 \$24075 \$24246 sg13g2_nor2_1
* cell instance $41811 r0 *1 143.52,56.7
X$41811 VDD VSS \$2738 \$2898 \$2737 sg13g2_nor2_1
* cell instance $41812 r0 *1 99.36,343.98
X$41812 VDD VSS \$23255 \$25097 \$24998 sg13g2_nor2_1
* cell instance $41813 r0 *1 161.76,154.98
X$41813 VDD VSS \$10293 \$10164 \$10716 sg13g2_nor2_1
* cell instance $41814 r0 *1 254.4,275.94
X$41814 VDD VSS \$20458 \$17458 \$20681 sg13g2_nor2_1
* cell instance $41815 r0 *1 25.44,253.26
X$41815 VDD VSS \$18437 \$16985 \$18619 sg13g2_nor2_1
* cell instance $41816 r0 *1 161.76,170.1
X$41816 VDD VSS \$11762 \$11697 \$11475 sg13g2_nor2_1
* cell instance $41817 r0 *1 164.64,79.38
X$41817 VDD VSS \$4616 \$4335 \$4040 sg13g2_nor2_1
* cell instance $41818 r0 *1 137.76,275.94
X$41818 VDD VSS \$20351 \$13948 \$20611 sg13g2_nor2_1
* cell instance $41819 r0 *1 253.92,253.26
X$41819 VDD VSS \$18816 \$17331 \$17104 sg13g2_nor2_1
* cell instance $41820 r0 *1 42.72,230.58
X$41820 VDD VSS \$14980 \$14871 \$16179 sg13g2_nor2_1
* cell instance $41821 r0 *1 251.04,253.26
X$41821 VDD VSS \$18815 \$18814 \$16153 sg13g2_nor2_1
* cell instance $41822 r0 *1 322.56,41.58
X$41822 VDD VSS \$1935 \$1791 \$1923 sg13g2_nor2_1
* cell instance $41823 r0 *1 120.96,34.02
X$41823 VDD VSS \$1261 \$1308 \$1428 sg13g2_nor2_1
* cell instance $41824 r0 *1 261.6,117.18
X$41824 VDD VSS \$6810 \$7047 \$7136 sg13g2_nor2_1
* cell instance $41825 r0 *1 263.52,117.18
X$41825 VDD VSS \$7398 \$7193 \$7047 sg13g2_nor2_1
* cell instance $41826 r0 *1 240.48,117.18
X$41826 VDD VSS \$7143 \$7386 \$7182 sg13g2_nor2_1
* cell instance $41827 r0 *1 242.4,117.18
X$41827 VDD VSS \$7389 \$7044 \$7386 sg13g2_nor2_1
* cell instance $41828 r0 *1 128.16,34.02
X$41828 VDD VSS \$983 \$779 \$1311 sg13g2_nor2_1
* cell instance $41829 r0 *1 107.04,26.46
X$41829 VDD VSS \$538 \$905 \$907 sg13g2_nor2_1
* cell instance $41830 r0 *1 105.12,26.46
X$41830 VDD VSS \$536 \$907 \$382 sg13g2_nor2_1
* cell instance $41831 r0 *1 239.52,245.7
X$41831 VDD VSS \$17677 \$18469 \$18227 sg13g2_nor2_1
* cell instance $41832 r0 *1 173.76,170.1
X$41832 VDD VSS \$11483 \$11395 \$11484 sg13g2_nor2_1
* cell instance $41833 r0 *1 47.04,268.38
X$41833 VDD VSS \$19972 \$19892 \$19782 sg13g2_nor2_1
* cell instance $41834 r0 *1 122.88,268.38
X$41834 VDD VSS \$19078 \$19729 \$19992 sg13g2_nor2_1
* cell instance $41835 r0 *1 238.56,117.18
X$41835 VDD VSS \$7380 \$7646 \$5845 sg13g2_nor2_1
* cell instance $41836 r0 *1 155.52,268.38
X$41836 VDD VSS \$19909 \$20005 \$19959 sg13g2_nor2_1
* cell instance $41837 r0 *1 250.56,117.18
X$41837 VDD VSS \$5558 \$7136 \$7192 sg13g2_nor2_1
* cell instance $41838 m0 *1 251.52,124.74
X$41838 VSS VDD \$7705 \$4579 \$4949 \$7136 \$2959 sg13g2_and4_1
* cell instance $41839 r0 *1 171.36,268.38
X$41839 VDD VSS \$17669 \$18282 \$19736 sg13g2_nor2_1
* cell instance $41840 r0 *1 95.04,253.26
X$41840 VDD VSS \$18749 \$18912 \$18445 sg13g2_nor2_1
* cell instance $41841 r0 *1 273.6,313.74
X$41841 VDD VSS \$23021 \$22887 \$23154 sg13g2_nor2_1
* cell instance $41842 r0 *1 178.08,177.66
X$41842 VDD VSS \$11483 \$12014 \$12183 sg13g2_nor2_1
* cell instance $41843 r0 *1 45.6,207.9
X$41843 VDD VSS \$14198 \$14089 \$14304 sg13g2_nor2_1
* cell instance $41844 r0 *1 233.76,245.7
X$41844 VDD VSS \$17677 \$17455 \$17875 sg13g2_nor2_1
* cell instance $41845 r0 *1 248.64,260.82
X$41845 VDD VSS \$18816 \$17455 \$19202 sg13g2_nor2_1
* cell instance $41846 r0 *1 31.68,223.02
X$41846 VDD VSS \$15737 \$14984 \$15326 sg13g2_nor2_1
* cell instance $41847 r0 *1 253.92,71.82
X$41847 VDD VSS \$4059 \$3928 \$3521 sg13g2_nor2_1
* cell instance $41848 r0 *1 72,26.46
X$41848 VDD VSS \$818 \$899 \$527 sg13g2_nor2_1
* cell instance $41849 r0 *1 174.72,11.34
X$41849 VDD VSS \$86 \$85 \$89 sg13g2_nor2_1
* cell instance $41850 r0 *1 64.32,26.46
X$41850 VDD VSS \$450 \$522 \$899 sg13g2_nor2_1
* cell instance $41851 r0 *1 190.08,132.3
X$41851 VDD VSS \$8609 \$8444 \$8268 sg13g2_nor2_1
* cell instance $41852 r0 *1 176.64,11.34
X$41852 VDD VSS \$3 \$87 \$211 sg13g2_nor2_1
* cell instance $41853 r0 *1 179.04,11.34
X$41853 VDD VSS \$208 \$31 \$90 sg13g2_nand2_1
* cell instance $41854 r0 *1 72.96,41.58
X$41854 VDD VSS \$1408 \$808 \$1846 sg13g2_nor2_1
* cell instance $41855 r0 *1 38.4,18.9
X$41855 VDD VSS \$196 \$269 \$516 sg13g2_nor2_1
* cell instance $41856 r0 *1 46.56,18.9
X$41856 VDD VSS \$516 \$266 \$448 sg13g2_nor2_1
* cell instance $41857 r0 *1 278.88,336.42
X$41857 VDD VSS \$23159 \$20127 \$24091 sg13g2_nor2_1
* cell instance $41858 r0 *1 239.52,275.94
X$41858 VDD VSS \$20458 \$20040 \$20621 sg13g2_nor2_1
* cell instance $41859 r0 *1 86.88,185.22
X$41859 VDD VSS \$12416 \$11687 \$10851 sg13g2_nor2_1
* cell instance $41860 r0 *1 57.12,215.46
X$41860 VDD VSS \$14878 \$14983 \$15130 sg13g2_nor2_1
* cell instance $41861 r0 *1 14.4,41.58
X$41861 VDD VSS \$1835 \$1479 \$3019 sg13g2_nor2_1
* cell instance $41862 r0 *1 233.28,275.94
X$41862 VDD VSS \$20342 \$20456 \$20713 sg13g2_nor2_1
* cell instance $41863 r0 *1 293.28,321.3
X$41863 VDD VSS \$20942 \$23557 \$23556 sg13g2_nor2_1
* cell instance $41864 r0 *1 24,41.58
X$41864 VDD VSS \$1754 \$1291 \$1752 sg13g2_nor2_1
* cell instance $41865 r0 *1 44.64,34.02
X$41865 VDD VSS \$1398 \$1293 \$766 sg13g2_nor2_1
* cell instance $41866 r0 *1 170.4,245.7
X$41866 VDD VSS \$17842 \$15847 \$18090 sg13g2_nor2_1
* cell instance $41867 r0 *1 152.16,245.7
X$41867 VDD VSS \$15248 \$17659 \$17828 sg13g2_nor2_1
* cell instance $41868 r0 *1 214.08,343.98
X$41868 VDD VSS \$23692 \$24755 \$24539 sg13g2_nor2_1
* cell instance $41869 r0 *1 263.52,343.98
X$41869 VDD VSS \$24260 \$24258 \$23139 sg13g2_nor2_1
* cell instance $41870 r0 *1 43.2,56.7
X$41870 VDD VSS \$2306 \$1477 \$2773 sg13g2_nor2_1
* cell instance $41871 r0 *1 233.76,79.38
X$41871 VDD VSS \$3731 \$3730 \$4257 sg13g2_nor2_1
* cell instance $41872 r0 *1 46.08,260.82
X$41872 VDD VSS \$8015 \$16876 \$18727 sg13g2_nor2_1
* cell instance $41873 r0 *1 153.6,162.54
X$41873 VDD VSS \$10716 \$9814 \$10767 sg13g2_nor2_1
* cell instance $41874 r0 *1 179.04,86.94
X$41874 VDD VSS \$4794 \$5014 \$4795 sg13g2_nor2_1
* cell instance $41875 r0 *1 152.16,177.66
X$41875 VDD VSS \$11483 \$11697 \$12016 sg13g2_nor2_1
* cell instance $41876 r0 *1 265.92,109.62
X$41876 VDD VSS \$6813 \$5678 \$6986 sg13g2_nor2_1
* cell instance $41877 r0 *1 49.44,298.62
X$41877 VDD VSS \$22083 \$22082 \$21682 sg13g2_nor2_1
* cell instance $41878 r0 *1 144.96,71.82
X$41878 VDD VSS \$3712 \$3902 \$3713 sg13g2_nor2_1
* cell instance $41879 r0 *1 146.88,71.82
X$41879 VDD VSS \$3713 \$3500 \$3163 sg13g2_nor2_1
* cell instance $41880 r0 *1 139.68,18.9
X$41880 VDD VSS \$434 \$458 \$384 sg13g2_nor2_1
* cell instance $41881 r0 *1 160.8,49.14
X$41881 VDD VSS \$2221 \$2218 \$2345 sg13g2_nor2_1
* cell instance $41882 r0 *1 195.84,102.06
X$41882 VDD VSS \$6713 \$6436 \$5516 sg13g2_nor2_1
* cell instance $41883 r0 *1 103.2,49.14
X$41883 VDD VSS \$2329 \$2206 \$2463 sg13g2_nor2_1
* cell instance $41884 r0 *1 188.16,102.06
X$41884 VDD VSS \$6191 \$6184 \$6049 sg13g2_nor2_1
* cell instance $41885 r0 *1 120.48,49.14
X$41885 VDD VSS \$2208 \$1226 \$2485 sg13g2_nor2_1
* cell instance $41886 r0 *1 81.12,200.34
X$41886 VDD VSS \$13659 \$13139 \$12887 sg13g2_nor2_1
* cell instance $41887 r0 *1 139.68,132.3
X$41887 VDD VSS \$8434 \$8433 \$7983 sg13g2_nor2_1
* cell instance $41888 r0 *1 81.12,18.9
X$41888 VDD VSS \$451 \$452 \$453 sg13g2_nor2_1
* cell instance $41889 r0 *1 63.36,192.78
X$41889 VDD VSS \$13276 \$12885 \$12092 sg13g2_nor2_1
* cell instance $41890 r0 *1 288.48,192.78
X$41890 VDD VSS \$13070 \$12046 \$13086 sg13g2_nor2_1
* cell instance $41891 r0 *1 226.56,71.82
X$41891 VDD VSS \$3860 \$4257 \$3514 sg13g2_nor2_1
* cell instance $41892 r0 *1 192,49.14
X$41892 VDD VSS \$2069 \$1196 \$2277 sg13g2_nor2_1
* cell instance $41893 r0 *1 85.44,192.78
X$41893 VDD VSS \$12887 \$12627 \$13098 sg13g2_nor2_1
* cell instance $41894 r0 *1 327.36,185.22
X$41894 VDD VSS \$12560 \$9485 \$11525 sg13g2_nor2_1
* cell instance $41895 r0 *1 32.16,253.26
X$41895 VDD VSS \$18866 \$14984 \$16868 sg13g2_nor2_1
* cell instance $41896 r0 *1 193.92,49.14
X$41896 VDD VSS \$2233 \$2067 \$2069 sg13g2_nor2_1
* cell instance $41897 r0 *1 76.8,34.02
X$41897 VDD VSS \$1298 \$1297 \$1408 sg13g2_nor2_1
* cell instance $41898 r0 *1 216.48,343.98
X$41898 VDD VSS \$23692 \$23893 \$24540 sg13g2_nor2_1
* cell instance $41899 r0 *1 271.68,298.62
X$41899 VDD VSS \$21959 \$20938 \$22146 sg13g2_nor2_1
* cell instance $41900 r0 *1 157.44,124.74
X$41900 VDD VSS \$7993 \$6673 \$5627 sg13g2_nor2_1
* cell instance $41901 r0 *1 75.36,291.06
X$41901 VDD VSS \$21541 \$21540 \$16959 sg13g2_nor2_1
* cell instance $41902 r0 *1 148.8,124.74
X$41902 VDD VSS \$7986 \$6167 \$7987 sg13g2_nor2_1
* cell instance $41903 r0 *1 137.28,170.1
X$41903 VDD VSS \$11468 \$11926 \$11467 sg13g2_nor2_1
* cell instance $41904 r0 *1 272.16,132.3
X$41904 VDD VSS \$7402 \$8509 \$8033 sg13g2_nor2_1
* cell instance $41905 r0 *1 194.88,154.98
X$41905 VDD VSS \$10055 \$10134 \$10300 sg13g2_nor2_1
* cell instance $41906 r0 *1 123.36,170.1
X$41906 VDD VSS \$11461 \$10156 \$11181 sg13g2_nor2_1
* cell instance $41907 r0 *1 75.36,117.18
X$41907 VDD VSS \$7167 \$6754 \$7332 sg13g2_nor2_1
* cell instance $41908 r0 *1 50.88,215.46
X$41908 VDD VSS \$14013 \$14874 \$14877 sg13g2_nor2_1
* cell instance $41909 r0 *1 322.08,238.14
X$41909 VDD VSS \$17129 \$16812 \$16645 sg13g2_nor2_1
* cell instance $41910 r0 *1 153.6,102.06
X$41910 VDD VSS \$6172 \$5006 \$6328 sg13g2_nor2_1
* cell instance $41911 r0 *1 124.8,238.14
X$41911 VDD VSS \$16628 \$16789 \$17026 sg13g2_nor2_1
* cell instance $41912 r0 *1 119.52,238.14
X$41912 VDD VSS \$15846 \$15847 \$16883 sg13g2_nor2_1
* cell instance $41913 r0 *1 325.44,215.46
X$41913 VDD VSS \$14242 \$15086 \$14255 sg13g2_nor2_1
* cell instance $41914 r0 *1 209.76,321.3
X$41914 VDD VSS \$23695 \$23642 \$24031 sg13g2_nor2_1
* cell instance $41915 r0 *1 349.92,49.14
X$41915 VDD VSS \$2392 \$2403 \$2402 sg13g2_nor2_1
* cell instance $41916 r0 *1 274.08,132.3
X$41916 VDD VSS \$7579 \$7578 \$8509 sg13g2_nor2_1
* cell instance $41917 r0 *1 72,132.3
X$41917 VDD VSS \$8562 \$8560 \$8420 sg13g2_nor2_1
* cell instance $41918 r0 *1 180.48,117.18
X$41918 VDD VSS \$7359 \$7357 \$7353 sg13g2_nor2_1
* cell instance $41919 r0 *1 161.28,124.74
X$41919 VDD VSS \$7994 \$7350 \$7993 sg13g2_nor2_1
* cell instance $41920 r0 *1 149.76,117.18
X$41920 VDD VSS \$7133 \$7175 \$7986 sg13g2_nor2_1
* cell instance $41921 r0 *1 159.84,102.06
X$41921 VDD VSS \$6331 \$6179 \$6172 sg13g2_nor2_1
* cell instance $41922 r0 *1 176.16,117.18
X$41922 VDD VSS \$7353 \$7128 \$7354 sg13g2_nor2_1
* cell instance $41923 r0 *1 216,328.86
X$41923 VDD VSS \$23695 \$23922 \$23926 sg13g2_nor2_1
* cell instance $41924 r0 *1 249.6,283.5
X$41924 VDD VSS \$20458 \$18473 \$21237 sg13g2_nor2_1
* cell instance $41925 r0 *1 23.04,132.3
X$41925 VDD VSS \$8249 \$7866 \$7311 sg13g2_nor2_1
* cell instance $41926 r0 *1 346.08,223.02
X$41926 VDD VSS \$15736 \$14828 \$15405 sg13g2_nor2_1
* cell instance $41927 r0 *1 210.24,64.26
X$41927 VDD VSS \$2077 \$3328 \$442 sg13g2_nor2_1
* cell instance $41928 r0 *1 208.32,64.26
X$41928 VDD VSS \$2074 \$1003 \$1903 sg13g2_nor2_1
* cell instance $41929 r0 *1 298.08,260.82
X$41929 VDD VSS \$16336 \$16831 \$19271 sg13g2_nor2_1
* cell instance $41930 r0 *1 281.28,132.3
X$41930 VDD VSS \$7407 \$8648 \$8754 sg13g2_nor2_1
* cell instance $41931 r0 *1 187.2,154.98
X$41931 VDD VSS \$10167 \$9824 \$8435 sg13g2_nor2_1
* cell instance $41932 r0 *1 23.52,102.06
X$41932 VDD VSS \$6135 \$5812 \$6138 sg13g2_nor2_1
* cell instance $41933 r0 *1 19.2,102.06
X$41933 VDD VSS \$5353 \$4432 \$5350 sg13g2_nor2_1
* cell instance $41934 r0 *1 48.48,102.06
X$41934 VDD VSS \$6147 \$5816 \$6145 sg13g2_nor2_1
* cell instance $41935 r0 *1 179.04,328.86
X$41935 VDD VSS \$24061 \$22679 \$24388 sg13g2_nor2_1
* cell instance $41936 r0 *1 219.84,328.86
X$41936 VDD VSS \$23696 \$23546 \$24360 sg13g2_nor2_1
* cell instance $41937 r0 *1 208.8,268.38
X$41937 VDD VSS \$20017 \$20014 \$20015 sg13g2_nor2_1
* cell instance $41938 r0 *1 210.72,268.38
X$41938 VDD VSS \$19746 \$20234 \$19682 sg13g2_nor2_1
* cell instance $41939 r0 *1 192,162.54
X$41939 VDD VSS \$10724 \$10871 \$10725 sg13g2_nor2_1
* cell instance $41940 r0 *1 328.32,268.38
X$41940 VDD VSS \$20063 \$17714 \$19763 sg13g2_nor2_1
* cell instance $41941 r0 *1 330.72,268.38
X$41941 VDD VSS \$20269 \$14075 \$20064 sg13g2_nor2_1
* cell instance $41942 r0 *1 326.4,207.9
X$41942 VDD VSS \$14075 \$14242 \$13706 sg13g2_nor2_1
* cell instance $41943 r0 *1 130.08,207.9
X$41943 VDD VSS \$13668 \$14033 \$12966 sg13g2_nor2_1
* cell instance $41944 r0 *1 214.08,328.86
X$41944 VDD VSS \$23692 \$23922 \$24068 sg13g2_nor2_1
* cell instance $41945 r0 *1 47.52,283.5
X$41945 VDD VSS \$21000 \$20739 \$20741 sg13g2_nor2_1
* cell instance $41946 r0 *1 33.12,94.5
X$41946 VDD VSS \$4761 \$3681 \$5602 sg13g2_nor2_1
* cell instance $41947 r0 *1 123.36,207.9
X$41947 VDD VSS \$13907 \$14206 \$13801 sg13g2_nor2_1
* cell instance $41948 r0 *1 132,207.9
X$41948 VDD VSS \$13332 \$13152 \$14206 sg13g2_nor2_1
* cell instance $41949 r0 *1 11.52,94.5
X$41949 VDD VSS \$5350 \$4268 \$5897 sg13g2_nor2_1
* cell instance $41950 r0 *1 186.24,170.1
X$41950 VDD VSS \$11005 \$11004 \$10871 sg13g2_nor2_1
* cell instance $41951 r0 *1 43.2,283.5
X$41951 VDD VSS \$20913 \$20740 \$20739 sg13g2_nor2_1
* cell instance $41952 r0 *1 204.48,215.46
X$41952 VDD VSS \$14382 \$14186 \$14220 sg13g2_nor2_1
* cell instance $41953 r0 *1 206.4,215.46
X$41953 VDD VSS \$10872 \$14052 \$14611 sg13g2_nor2_1
* cell instance $41954 r0 *1 214.56,223.02
X$41954 VDD VSS \$15364 \$13013 \$15048 sg13g2_nor2_1
* cell instance $41955 r0 *1 86.4,94.5
X$41955 VDD VSS \$5374 \$5610 \$5370 sg13g2_nor2_1
* cell instance $41956 r0 *1 25.44,139.86
X$41956 VDD VSS \$9092 \$8869 \$8682 sg13g2_nor2_1
* cell instance $41957 r0 *1 82.08,94.5
X$41957 VDD VSS \$5370 \$4771 \$5953 sg13g2_nor2_1
* cell instance $41958 r0 *1 213.12,283.5
X$41958 VDD VSS \$20012 \$20774 \$21081 sg13g2_nor2_1
* cell instance $41959 r0 *1 8.16,147.42
X$41959 VDD VSS \$8927 \$8682 \$9439 sg13g2_nor2_1
* cell instance $41960 r0 *1 217.92,328.86
X$41960 VDD VSS \$23696 \$23125 \$23925 sg13g2_nor2_1
* cell instance $41961 r0 *1 211.2,283.5
X$41961 VDD VSS \$20022 \$20774 \$14232 sg13g2_nor2_1
* cell instance $41962 r0 *1 38.4,275.94
X$41962 VDD VSS \$20737 \$19720 \$20569 sg13g2_nor2_1
* cell instance $41963 r0 *1 349.92,117.18
X$41963 VDD VSS \$7205 \$7426 \$7726 sg13g2_nor2_1
* cell instance $41964 r0 *1 319.2,321.3
X$41964 VDD VSS \$23578 \$23471 \$23179 sg13g2_nor2_1
* cell instance $41965 r0 *1 49.44,117.18
X$41965 VDD VSS \$6145 \$4833 \$6580 sg13g2_nor2_1
* cell instance $41966 r0 *1 82.08,162.54
X$41966 VDD VSS \$10280 \$10281 \$10278 sg13g2_nor2_1
* cell instance $41967 r0 *1 223.68,328.86
X$41967 VDD VSS \$23696 \$24077 \$24249 sg13g2_nor2_1
* cell instance $41968 r0 *1 28.32,147.42
X$41968 VDD VSS \$9612 \$9614 \$9440 sg13g2_nor2_1
* cell instance $41969 r0 *1 210.24,223.02
X$41969 VDD VSS \$15553 \$15049 \$15607 sg13g2_nor2_1
* cell instance $41970 r0 *1 164.16,238.14
X$41970 VDD VSS \$15248 \$16797 \$17046 sg13g2_nor2_1
* cell instance $41971 r0 *1 136.32,343.98
X$41971 VDD VSS \$24367 \$24827 \$24055 sg13g2_nor2_1
* cell instance $41972 r0 *1 181.92,34.02
X$41972 VDD VSS \$956 \$1317 \$1376 sg13g2_nor2_1
* cell instance $41973 r0 *1 214.08,154.98
X$41973 VDD VSS \$9830 \$10057 \$10305 sg13g2_nor2_1
* cell instance $41974 r0 *1 78.72,298.62
X$41974 VDD VSS \$21016 \$21681 \$22212 sg13g2_nor2_1
* cell instance $41975 r0 *1 126.72,154.98
X$41975 VDD VSS \$10287 \$10286 \$9806 sg13g2_nor2_1
* cell instance $41976 r0 *1 204.96,139.86
X$41976 VDD VSS \$9224 \$9120 \$7686 sg13g2_nor2_1
* cell instance $41977 r0 *1 301.92,154.98
X$41977 VDD VSS \$10323 \$8475 \$8672 sg13g2_nor2_1
* cell instance $41978 r0 *1 130.08,147.42
X$41978 VDD VSS \$8430 \$9458 \$8887 sg13g2_nor2_1
* cell instance $41979 r0 *1 192,253.26
X$41979 VDD VSS \$15946 \$17846 \$18574 sg13g2_nor2_1
* cell instance $41980 r0 *1 111.36,132.3
X$41980 VDD VSS \$8426 \$8425 \$8571 sg13g2_nor2_1
* cell instance $41981 r0 *1 254.88,207.9
X$41981 VDD VSS \$14058 \$11498 \$14402 sg13g2_nor2_1
* cell instance $41982 r0 *1 216,154.98
X$41982 VDD VSS \$10058 \$10305 \$9637 sg13g2_nor2_1
* cell instance $41983 r0 *1 284.64,139.86
X$41983 VDD VSS \$9012 \$9055 \$8920 sg13g2_nor2_1
* cell instance $41984 r0 *1 273.6,275.94
X$41984 VDD VSS \$20461 \$19922 \$20866 sg13g2_nor2_1
* cell instance $41985 r0 *1 244.8,154.98
X$41985 VDD VSS \$10309 \$10173 \$9834 sg13g2_nor2_1
* cell instance $41986 r0 *1 309.6,147.42
X$41986 VDD VSS \$9662 \$9661 \$9663 sg13g2_nor2_1
* cell instance $41987 r0 *1 336,260.82
X$41987 VDD VSS \$19492 \$14075 \$19481 sg13g2_nor2_1
* cell instance $41988 r0 *1 229.44,139.86
X$41988 VDD VSS \$9398 \$9129 \$9127 sg13g2_nor2_1
* cell instance $41989 r0 *1 231.36,139.86
X$41989 VDD VSS \$9236 \$9285 \$9129 sg13g2_nor2_1
* cell instance $41990 r0 *1 288.48,139.86
X$41990 VDD VSS \$8178 \$8920 \$8465 sg13g2_nor2_1
* cell instance $41991 r0 *1 303.84,154.98
X$41991 VDD VSS \$8922 \$10328 \$10545 sg13g2_nor2_1
* cell instance $41992 r0 *1 325.92,291.06
X$41992 VDD VSS \$21577 \$21457 \$21101 sg13g2_nor2_1
* cell instance $41993 r0 *1 133.92,260.82
X$41993 VDD VSS \$19556 \$19078 \$19551 sg13g2_nor2_1
* cell instance $41994 r0 *1 132,260.82
X$41994 VDD VSS \$19729 \$19728 \$19809 sg13g2_nor2_1
* cell instance $41995 r0 *1 195.84,86.94
X$41995 VDD VSS \$4346 \$3312 \$4739 sg13g2_nor2_1
* cell instance $41996 r0 *1 183.36,192.78
X$41996 VDD VSS \$11483 \$13175 \$12854 sg13g2_nor2_1
* cell instance $41997 r0 *1 81.6,71.82
X$41997 VDD VSS \$3699 \$3489 \$3700 sg13g2_nor2_1
* cell instance $41998 r0 *1 54.24,298.62
X$41998 VDD VSS \$20650 \$21007 \$20744 sg13g2_nor2_1
* cell instance $41999 r0 *1 124.32,102.06
X$41999 VDD VSS \$6160 \$6161 \$6162 sg13g2_nor2_1
* cell instance $42000 r0 *1 105.12,253.26
X$42000 VDD VSS \$18922 \$15650 \$18273 sg13g2_nor2_1
* cell instance $42001 r0 *1 52.32,298.62
X$42001 VDD VSS \$22003 \$21957 \$22090 sg13g2_nor2_1
* cell instance $42002 r0 *1 329.28,275.94
X$42002 VDD VSS \$20572 \$20558 \$20386 sg13g2_nor2_1
* cell instance $42003 r0 *1 283.68,162.54
X$42003 VDD VSS \$10493 \$10780 \$11028 sg13g2_nor2_1
* cell instance $42004 r0 *1 72.48,56.7
X$42004 VDD VSS \$2042 \$2721 \$2789 sg13g2_nor2_1
* cell instance $42005 r0 *1 154.08,230.58
X$42005 VDD VSS \$15552 \$16289 \$16287 sg13g2_nor2_1
* cell instance $42006 r0 *1 282.72,139.86
X$42006 VDD VSS \$3342 \$9371 \$5721 sg13g2_nor2_1
* cell instance $42007 r0 *1 105.6,154.98
X$42007 VDD VSS \$10456 \$10284 \$9394 sg13g2_nor2_1
* cell instance $42008 r0 *1 84,154.98
X$42008 VDD VSS \$10278 \$9617 \$10157 sg13g2_nor2_1
* cell instance $42009 r0 *1 45.12,291.06
X$42009 VDD VSS \$20649 \$20741 \$21473 sg13g2_nor2_1
* cell instance $42010 r0 *1 202.08,291.06
X$42010 VDD VSS \$21047 \$20013 \$21554 sg13g2_nor2_1
* cell instance $42011 r0 *1 88.32,306.18
X$42011 VDD VSS \$22563 \$22387 \$22386 sg13g2_nor2_1
* cell instance $42691 m0 *1 161.76,41.58
X$42691 VSS \$1775 \$983 \$527 \$83 VDD sg13g2_dfrbpq_1
* cell instance $42692 m0 *1 195.36,185.22
X$42692 VSS \$11875 \$11487 \$12349 \$9827 VDD sg13g2_dfrbpq_1
* cell instance $42693 m0 *1 161.76,18.9
X$42693 VSS \$52 \$337 \$442 \$83 VDD sg13g2_dfrbpq_1
* cell instance $42694 m0 *1 215.04,207.9
X$42694 VSS \$13700 \$13684 \$13827 \$12538 VDD sg13g2_dfrbpq_1
* cell instance $42695 m0 *1 203.52,117.18
X$42695 VSS \$6790 \$7149 \$5840 \$6432 VDD sg13g2_dfrbpq_1
* cell instance $42696 m0 *1 256.8,154.98
X$42696 VSS \$9392 \$11215 \$10420 \$8183 VDD sg13g2_dfrbpq_1
* cell instance $42697 m0 *1 190.56,230.58
X$42697 VSS \$15947 \$15353 \$15665 \$14809 VDD sg13g2_dfrbpq_1
* cell instance $42698 m0 *1 267.84,185.22
X$42698 VSS \$12313 \$12310 \$12056 \$13206 VDD sg13g2_dfrbpq_1
* cell instance $42699 m0 *1 10.08,275.94
X$42699 VSS \$19394 \$19890 \$20256 \$19646 VDD sg13g2_dfrbpq_1
* cell instance $42700 m0 *1 156.48,185.22
X$42700 VSS \$12020 \$12019 \$12832 \$11472 VDD sg13g2_dfrbpq_1
* cell instance $42701 m0 *1 109.92,79.38
X$42701 VSS \$4174 \$4157 \$2613 \$3156 VDD sg13g2_dfrbpq_1
* cell instance $42702 m0 *1 211.2,109.62
X$42702 VSS \$5634 \$4794 \$3898 \$6432 VDD sg13g2_dfrbpq_1
* cell instance $42703 m0 *1 337.92,102.06
X$42703 VSS \$5046 \$5133 \$5895 \$5681 VDD sg13g2_dfrbpq_1
* cell instance $42704 m0 *1 10.08,306.18
X$42704 VSS \$20804 \$22434 \$21951 \$21534 VDD sg13g2_dfrbpq_1
* cell instance $42705 m0 *1 173.28,313.74
X$42705 VSS \$22264 \$20772 \$22869 \$22575 VDD sg13g2_dfrbpq_1
* cell instance $42706 m0 *1 204.48,154.98
X$42706 VSS \$9117 \$10057 \$8894 \$9827 VDD sg13g2_dfrbpq_1
* cell instance $42707 m0 *1 256.8,117.18
X$42707 VSS \$5514 \$6942 \$7820 \$6443 VDD sg13g2_dfrbpq_1
* cell instance $42708 m0 *1 337.92,192.78
X$42708 VSS \$12060 \$12935 \$12075 \$12321 VDD sg13g2_dfrbpq_1
* cell instance $42709 m0 *1 223.68,230.58
X$42709 VSS \$15312 \$15674 \$15555 \$13206 VDD sg13g2_dfrbpq_1
* cell instance $42710 m0 *1 12.48,291.06
X$42710 VSS \$19647 \$21120 \$21339 \$19646 VDD sg13g2_dfrbpq_1
* cell instance $42711 m0 *1 231.36,109.62
X$42711 VSS \$5413 \$5019 \$5841 \$6432 VDD sg13g2_dfrbpq_1
* cell instance $42712 m0 *1 87.36,185.22
X$42712 VSS \$11567 \$12006 \$11552 \$12289 VDD sg13g2_dfrbpq_1
* cell instance $42713 m0 *1 78.72,321.3
X$42713 VSS \$22562 \$23247 \$23388 \$22565 VDD sg13g2_dfrbpq_1
* cell instance $42714 m0 *1 243.84,154.98
X$42714 VSS \$9392 \$10405 \$10062 \$9284 VDD sg13g2_dfrbpq_1
* cell instance $42715 m0 *1 117.6,71.82
X$42715 VSS \$2611 \$3607 \$3598 \$3162 VDD sg13g2_dfrbpq_1
* cell instance $42716 m0 *1 125.76,86.94
X$42716 VSS \$2337 \$4126 \$2601 \$3162 VDD sg13g2_dfrbpq_1
* cell instance $42717 m0 *1 273.12,132.3
X$42717 VSS \$7826 \$7389 \$5845 \$6443 VDD sg13g2_dfrbpq_1
* cell instance $42718 m0 *1 192.96,102.06
X$42718 VSS \$5634 \$5784 \$5845 \$6432 VDD sg13g2_dfrbpq_1
* cell instance $42719 m0 *1 290.88,291.06
X$42719 VSS \$20686 \$21082 \$21083 \$16160 VDD sg13g2_dfrbpq_1
* cell instance $42720 m0 *1 262.08,343.98
X$42720 VSS \$24547 \$16806 \$24769 \$22724 VDD sg13g2_dfrbpq_1
* cell instance $42721 m0 *1 10.08,283.5
X$42721 VSS \$19394 \$21117 \$20995 \$19646 VDD sg13g2_dfrbpq_1
* cell instance $42722 m0 *1 295.2,207.9
X$42722 VSS \$13617 \$13231 \$14552 \$12554 VDD sg13g2_dfrbpq_1
* cell instance $42723 m0 *1 160.8,26.46
X$42723 VSS \$52 \$343 \$222 \$83 VDD sg13g2_dfrbpq_1
* cell instance $42724 m0 *1 55.68,328.86
X$42724 VSS \$23652 \$23595 \$23088 \$23087 VDD sg13g2_dfrbpq_1
* cell instance $42725 m0 *1 176.16,177.66
X$42725 VSS \$11875 \$11480 \$11767 \$9114 VDD sg13g2_dfrbpq_1
* cell instance $42726 m0 *1 335.52,154.98
X$42726 VSS \$8660 \$4641 \$8671 \$9327 VDD sg13g2_dfrbpq_1
* cell instance $42727 m0 *1 11.52,298.62
X$42727 VSS \$20804 \$20985 \$21858 \$21534 VDD sg13g2_dfrbpq_1
* cell instance $42728 m0 *1 190.56,117.18
X$42728 VSS \$7362 \$7364 \$8269 \$5631 VDD sg13g2_dfrbpq_1
* cell instance $42729 m0 *1 336,147.42
X$42729 VSS \$8660 \$4643 \$8061 \$7721 VDD sg13g2_dfrbpq_1
* cell instance $42730 m0 *1 198.72,170.1
X$42730 VSS \$10302 \$10730 \$11408 \$9827 VDD sg13g2_dfrbpq_1
* cell instance $42731 m0 *1 224.64,200.34
X$42731 VSS \$12681 \$13691 \$13559 \$12538 VDD sg13g2_dfrbpq_1
* cell instance $42732 m0 *1 324,185.22
X$42732 VSS \$12060 \$11281 \$10062 \$12321 VDD sg13g2_dfrbpq_1
* cell instance $42733 m0 *1 240.96,170.1
X$42733 VSS \$9392 \$11274 \$11273 \$9284 VDD sg13g2_dfrbpq_1
* cell instance $42734 m0 *1 121.92,26.46
X$42734 VSS \$29 \$779 \$527 \$79 VDD sg13g2_dfrbpq_1
* cell instance $42735 m0 *1 211.68,321.3
X$42735 VSS \$22678 \$23697 \$22977 \$23122 VDD sg13g2_dfrbpq_1
* cell instance $42736 m0 *1 249.6,283.5
X$42736 VSS \$20038 \$18473 \$20891 \$20682 VDD sg13g2_dfrbpq_1
* cell instance $42737 m0 *1 120.96,18.9
X$42737 VSS \$29 \$560 \$222 \$79 VDD sg13g2_dfrbpq_1
* cell instance $42738 m0 *1 215.04,223.02
X$42738 VSS \$17437 \$15049 \$15315 \$12538 VDD sg13g2_dfrbpq_1
* cell instance $42739 m0 *1 312.96,162.54
X$42739 VSS \$10506 \$10668 \$10665 \$9327 VDD sg13g2_dfrbpq_1
* cell instance $42740 m0 *1 165.6,34.02
X$42740 VSS \$1314 \$1270 \$1263 \$83 VDD sg13g2_dfrbpq_1
* cell instance $42741 m0 *1 121.92,185.22
X$42741 VSS \$12013 \$10280 \$8565 \$11472 VDD sg13g2_dfrbpq_1
* cell instance $42742 m0 *1 271.68,56.7
X$42742 VSS \$2386 \$4819 \$3050 \$247 VDD sg13g2_dfrbpq_1
* cell instance $42743 m0 *1 297.12,124.74
X$42743 VSS \$7826 \$7832 \$7820 \$4385 VDD sg13g2_dfrbpq_1
* cell instance $42744 m0 *1 302.88,102.06
X$42744 VSS \$794 \$3182 \$3663 \$5681 VDD sg13g2_dfrbpq_1
* cell instance $42745 m0 *1 287.52,147.42
X$42745 VSS \$9838 \$9290 \$7009 \$8183 VDD sg13g2_dfrbpq_1
* cell instance $42746 m0 *1 295.2,139.86
X$42746 VSS \$7826 \$8467 \$7778 \$8183 VDD sg13g2_dfrbpq_1
* cell instance $42747 m0 *1 52.8,268.38
X$42747 VSS \$19899 \$19408 \$19713 \$15634 VDD sg13g2_dfrbpq_1
* cell instance $42748 m0 *1 310.08,109.62
X$42748 VSS \$1597 \$3359 \$6903 \$5681 VDD sg13g2_dfrbpq_1
* cell instance $42749 m0 *1 110.88,94.5
X$42749 VSS \$4174 \$5006 \$4614 \$5380 VDD sg13g2_dfrbpq_1
* cell instance $42750 m0 *1 317.28,139.86
X$42750 VSS \$8660 \$6958 \$6976 \$7721 VDD sg13g2_dfrbpq_1
* cell instance $42751 m0 *1 240.96,177.66
X$42751 VSS \$9392 \$11776 \$11910 \$9284 VDD sg13g2_dfrbpq_1
* cell instance $42752 m0 *1 168,49.14
X$42752 VSS \$1775 \$2060 \$981 \$83 VDD sg13g2_dfrbpq_1
* cell instance $42753 m0 *1 221.76,147.42
X$42753 VSS \$9283 \$9285 \$9281 \$9284 VDD sg13g2_dfrbpq_1
* cell instance $42754 m0 *1 336.96,139.86
X$42754 VSS \$7052 \$8642 \$7820 \$7721 VDD sg13g2_dfrbpq_1
* cell instance $42755 m0 *1 207.36,139.86
X$42755 VSS \$6790 \$8618 \$7686 \$5631 VDD sg13g2_dfrbpq_1
* cell instance $42756 m0 *1 283.68,170.1
X$42756 VSS \$10887 \$11280 \$10062 \$8183 VDD sg13g2_dfrbpq_1
* cell instance $42757 m0 *1 283.68,215.46
X$42757 VSS \$13617 \$13244 \$14408 \$13206 VDD sg13g2_dfrbpq_1
* cell instance $42758 m0 *1 189.12,177.66
X$42758 VSS \$10302 \$10293 \$9457 \$9827 VDD sg13g2_dfrbpq_1
* cell instance $42759 m0 *1 244.32,275.94
X$42759 VSS \$20038 \$17458 \$20544 \$20459 VDD sg13g2_dfrbpq_1
* cell instance $42760 m0 *1 10.08,200.34
X$42760 VSS \$11991 \$13485 \$13779 \$12626 VDD sg13g2_dfrbpq_1
* cell instance $42761 m0 *1 318.24,102.06
X$42761 VSS \$5046 \$5685 \$4404 \$5681 VDD sg13g2_dfrbpq_1
* cell instance $42762 m0 *1 10.08,313.74
X$42762 VSS \$20804 \$23039 \$22651 \$21534 VDD sg13g2_dfrbpq_1
* cell instance $42763 m0 *1 10.08,192.78
X$42763 VSS \$11991 \$12880 \$12879 \$12626 VDD sg13g2_dfrbpq_1
* cell instance $42764 m0 *1 302.4,192.78
X$42764 VSS \$12060 \$12559 \$13080 \$12554 VDD sg13g2_dfrbpq_1
* cell instance $42765 m0 *1 171.36,268.38
X$42765 VSS \$19666 \$18768 \$19839 \$19658 VDD sg13g2_dfrbpq_1
* cell instance $42766 m0 *1 323.04,109.62
X$42766 VSS \$5046 \$6466 \$6619 \$5681 VDD sg13g2_dfrbpq_1
* cell instance $42767 m0 *1 334.56,177.66
X$42767 VSS \$10506 \$10330 \$11944 \$9327 VDD sg13g2_dfrbpq_1
* cell instance $42768 m0 *1 111.36,86.94
X$42768 VSS \$4174 \$3699 \$2641 \$3162 VDD sg13g2_dfrbpq_1
* cell instance $42769 m0 *1 292.8,185.22
X$42769 VSS \$12313 \$12374 \$12373 \$12554 VDD sg13g2_dfrbpq_1
* cell instance $42770 m0 *1 77.28,336.42
X$42770 VSS \$23096 \$25228 \$23095 \$22565 VDD sg13g2_dfrbpq_1
* cell instance $42771 m0 *1 207.84,147.42
X$42771 VSS \$9117 \$7359 \$7344 \$5631 VDD sg13g2_dfrbpq_1
* cell instance $42772 m0 *1 337.92,207.9
X$42772 VSS \$13239 \$14080 \$14083 \$12321 VDD sg13g2_dfrbpq_1
* cell instance $42773 m0 *1 108.96,56.7
X$42773 VSS \$2611 \$3308 \$2678 \$75 VDD sg13g2_dfrbpq_1
* cell instance $42774 m0 *1 224.64,170.1
X$42774 VSS \$11018 \$9825 \$8435 \$9284 VDD sg13g2_dfrbpq_1
* cell instance $42775 m0 *1 220.32,154.98
X$42775 VSS \$9283 \$8609 \$7779 \$9284 VDD sg13g2_dfrbpq_1
* cell instance $42776 m0 *1 216.48,117.18
X$42776 VSS \$5413 \$6592 \$6706 \$6432 VDD sg13g2_dfrbpq_1
* cell instance $42777 m0 *1 191.52,139.86
X$42777 VSS \$9117 \$7994 \$2356 \$5631 VDD sg13g2_dfrbpq_1
* cell instance $42778 m0 *1 220.32,139.86
X$42778 VSS \$9283 \$9054 \$8617 \$6443 VDD sg13g2_dfrbpq_1
* cell instance $42779 m0 *1 313.44,154.98
X$42779 VSS \$10506 \$8057 \$10349 \$7721 VDD sg13g2_dfrbpq_1
* cell instance $42780 m0 *1 232.8,117.18
X$42780 VSS \$5413 \$7044 \$5845 \$6432 VDD sg13g2_dfrbpq_1
* cell instance $42781 m0 *1 263.52,275.94
X$42781 VSS \$19471 \$19922 \$20548 \$20682 VDD sg13g2_dfrbpq_1
* cell instance $42782 m0 *1 264.96,268.38
X$42782 VSS \$19471 \$18826 \$19467 \$16160 VDD sg13g2_dfrbpq_1
* cell instance $42783 m0 *1 262.08,291.06
X$42783 VSS \$20253 \$21071 \$21407 \$20682 VDD sg13g2_dfrbpq_1
* cell instance $42784 m0 *1 206.88,177.66
X$42784 VSS \$11018 \$10617 \$9106 \$9827 VDD sg13g2_dfrbpq_1
* cell instance $42785 m0 *1 90.24,200.34
X$42785 VSS \$14202 \$12323 \$10851 \$12289 VDD sg13g2_dfrbpq_1
* cell instance $42786 m0 *1 23.04,313.74
X$42786 VSS \$21530 \$23074 \$23037 \$21534 VDD sg13g2_dfrbpq_1
* cell instance $42787 m0 *1 23.04,306.18
X$42787 VSS \$21530 \$22172 \$22367 \$21534 VDD sg13g2_dfrbpq_1
* cell instance $42788 m0 *1 176.64,102.06
X$42788 VSS \$5634 \$5771 \$6706 \$5631 VDD sg13g2_dfrbpq_1
* cell instance $42789 m0 *1 91.68,321.3
X$42789 VSS \$22481 \$23058 \$24335 \$21825 VDD sg13g2_dfrbpq_1
* cell instance $42790 m0 *1 85.44,306.18
X$42790 VSS \$22562 \$22387 \$21300 \$19978 VDD sg13g2_dfrbpq_1
* cell instance $42791 m0 *1 318.72,215.46
X$42791 VSS \$13239 \$14670 \$14514 \$12321 VDD sg13g2_dfrbpq_1
* cell instance $42792 m0 *1 88.8,230.58
X$42792 VSS \$15547 \$14009 \$13779 \$14322 VDD sg13g2_dfrbpq_1
* cell instance $42793 m0 *1 106.56,26.46
X$42793 VSS \$29 \$234 \$71 \$79 VDD sg13g2_dfrbpq_1
* cell instance $42794 m0 *1 108,49.14
X$42794 VSS \$976 \$1861 \$970 \$75 VDD sg13g2_dfrbpq_1
* cell instance $42795 m0 *1 273.12,200.34
X$42795 VSS \$13617 \$13224 \$13619 \$13206 VDD sg13g2_dfrbpq_1
* cell instance $42796 m0 *1 278.4,192.78
X$42796 VSS \$12313 \$13221 \$13086 \$12554 VDD sg13g2_dfrbpq_1
* cell instance $42797 m0 *1 84.48,328.86
X$42797 VSS \$23657 \$23983 \$23814 \$22565 VDD sg13g2_dfrbpq_1
* cell instance $42798 m0 *1 337.92,223.02
X$42798 VSS \$13985 \$14828 \$15405 \$12321 VDD sg13g2_dfrbpq_1
* cell instance $42799 m0 *1 9.6,223.02
X$42799 VSS \$13576 \$15396 \$15395 \$12626 VDD sg13g2_dfrbpq_1
* cell instance $42800 m0 *1 275.52,291.06
X$42800 VSS \$20686 \$20938 \$21326 \$20682 VDD sg13g2_dfrbpq_1
* cell instance $42801 m0 *1 171.36,94.5
X$42801 VSS \$3721 \$5014 \$3898 \$2900 VDD sg13g2_dfrbpq_1
* cell instance $42802 m0 *1 98.88,71.82
X$42802 VSS \$2319 \$2309 \$1382 \$3156 VDD sg13g2_dfrbpq_1
* cell instance $42803 r0 *1 107.04,71.82
X$42803 VDD VSS \$2730 \$2886 \$2041 \$3498 sg13g2_and3_1
* cell instance $42804 m0 *1 90.24,245.7
X$42804 VSS \$17415 \$15918 \$15922 \$14322 VDD sg13g2_dfrbpq_1
* cell instance $42805 m0 *1 337.92,170.1
X$42805 VSS \$7052 \$11297 \$8930 \$9327 VDD sg13g2_dfrbpq_1
* cell instance $42806 m0 *1 92.16,343.98
X$42806 VSS \$23499 \$23340 \$24869 \$23104 VDD sg13g2_dfrbpq_1
* cell instance $42807 m0 *1 90.24,268.38
X$42807 VSS \$19899 \$18263 \$16868 \$19978 VDD sg13g2_dfrbpq_1
* cell instance $42808 m0 *1 211.68,170.1
X$42808 VSS \$10302 \$10733 \$11014 \$9827 VDD sg13g2_dfrbpq_1
* cell instance $42809 m0 *1 175.68,170.1
X$42809 VSS \$10302 \$9632 \$7992 \$9114 VDD sg13g2_dfrbpq_1
* cell instance $42810 m0 *1 337.92,132.3
X$42810 VSS \$252 \$6596 \$1203 \$99 VDD sg13g2_dfrbpq_1
* cell instance $42811 m0 *1 288.96,109.62
X$42811 VSS \$5514 \$4059 \$5032 \$4385 VDD sg13g2_dfrbpq_1
* cell instance $42812 m0 *1 190.08,328.86
X$42812 VSS \$23117 \$16473 \$23689 \$23545 VDD sg13g2_dfrbpq_1
* cell instance $42813 m0 *1 83.04,260.82
X$42813 VSS \$17415 \$19073 \$17508 \$15634 VDD sg13g2_dfrbpq_1
* cell instance $42814 m0 *1 180,336.42
X$42814 VSS \$23677 \$24063 \$24480 \$23545 VDD sg13g2_dfrbpq_1
* cell instance $42815 m0 *1 103.68,64.26
X$42815 VSS \$2611 \$1843 \$1292 \$75 VDD sg13g2_dfrbpq_1
* cell instance $42816 r0 *1 108.48,64.26
X$42816 VDD VSS \$2886 \$3299 \$2041 \$2730 sg13g2_nor3_1
* cell instance $42817 m0 *1 204.48,343.98
X$42817 VSS \$23117 \$24755 \$25168 \$24960 VDD sg13g2_dfrbpq_1
* cell instance $42818 m0 *1 230.88,283.5
X$42818 VSS \$20038 \$16772 \$21280 \$20459 VDD sg13g2_dfrbpq_1
* cell instance $42819 m0 *1 199.2,336.42
X$42819 VSS \$23117 \$23642 \$24486 \$24487 VDD sg13g2_dfrbpq_1
* cell instance $42820 m0 *1 33.12,336.42
X$42820 VSS \$23517 \$22650 \$22766 \$24039 VDD sg13g2_dfrbpq_1
* cell instance $42821 m0 *1 35.04,351.54
X$42821 VSS \$23517 \$25046 \$22178 \$24039 VDD sg13g2_dfrbpq_1
* cell instance $42822 m0 *1 144.48,26.46
X$42822 VSS \$52 \$781 \$782 \$83 VDD sg13g2_dfrbpq_1
* cell instance $42823 m0 *1 9.6,268.38
X$42823 VSS \$19394 \$19773 \$19768 \$19646 VDD sg13g2_dfrbpq_1
* cell instance $42824 m0 *1 93.6,238.14
X$42824 VSS \$15003 \$16248 \$16253 \$14322 VDD sg13g2_dfrbpq_1
* cell instance $42825 m0 *1 87.36,207.9
X$42825 VSS \$14202 \$12621 \$11241 \$12289 VDD sg13g2_dfrbpq_1
* cell instance $42826 m0 *1 9.6,343.98
X$42826 VSS \$24040 \$23077 \$20258 \$24039 VDD sg13g2_dfrbpq_1
* cell instance $42827 m0 *1 334.56,336.42
X$42827 VSS \$24627 \$24282 \$24278 \$22192 VDD sg13g2_dfrbpq_1
* cell instance $42828 m0 *1 9.12,351.54
X$42828 VSS \$24040 \$22603 \$24843 \$24039 VDD sg13g2_dfrbpq_1
* cell instance $42829 m0 *1 319.2,117.18
X$42829 VSS \$1032 \$7423 \$5683 \$5681 VDD sg13g2_dfrbpq_1
* cell instance $42830 m0 *1 336,351.54
X$42830 VSS \$24627 \$23957 \$24844 \$22192 VDD sg13g2_dfrbpq_1
* cell instance $42831 m0 *1 336,109.62
X$42831 VSS \$1032 \$4838 \$6843 \$5681 VDD sg13g2_dfrbpq_1
* cell instance $42832 m0 *1 348.96,109.62
X$42832 VDD VSS \$5681 sg13g2_inv_4
* cell instance $42833 m0 *1 336.96,117.18
X$42833 VSS \$295 \$2915 \$5873 \$5681 VDD sg13g2_dfrbpq_1
* cell instance $42834 m0 *1 9.6,260.82
X$42834 VSS \$19394 \$19063 \$17765 \$15624 VDD sg13g2_dfrbpq_1
* cell instance $42835 m0 *1 92.16,253.26
X$42835 VSS \$15003 \$17009 \$18526 \$14322 VDD sg13g2_dfrbpq_1
* cell instance $42836 m0 *1 83.52,275.94
X$42836 VSS \$19899 \$19979 \$19222 \$19978 VDD sg13g2_dfrbpq_1
* cell instance $42837 m0 *1 23.04,283.5
X$42837 VSS \$19394 \$20814 \$21294 \$19646 VDD sg13g2_dfrbpq_1
* cell instance $42838 m0 *1 90.24,336.42
X$42838 VSS \$23657 \$23522 \$22651 \$22565 VDD sg13g2_dfrbpq_1
* cell instance $42839 m0 *1 336,124.74
X$42839 VSS \$1032 \$7841 \$3529 \$7721 VDD sg13g2_dfrbpq_1
* cell instance $42840 m0 *1 169.44,185.22
X$42840 VSS \$12020 \$10995 \$10102 \$11472 VDD sg13g2_dfrbpq_1
* cell instance $42841 m0 *1 90.24,313.74
X$42841 VSS \$22562 \$22003 \$21294 \$22565 VDD sg13g2_dfrbpq_1
* cell instance $42842 m0 *1 173.28,71.82
X$42842 VSS \$3318 \$3430 \$3506 \$2900 VDD sg13g2_dfrbpq_1
* cell instance $42843 m0 *1 228.96,124.74
X$42843 VSS \$5751 \$6788 \$5390 \$6432 VDD sg13g2_dfrbpq_1
* cell instance $42844 m0 *1 93.12,351.54
X$42844 VSS \$23499 \$23440 \$25230 \$23104 VDD sg13g2_dfrbpq_1
* cell instance $42845 m0 *1 36.96,343.98
X$42845 VSS \$23517 \$23075 \$22768 \$24039 VDD sg13g2_dfrbpq_1
* cell instance $42846 m0 *1 24.48,298.62
X$42846 VSS \$20804 \$21917 \$20569 \$21534 VDD sg13g2_dfrbpq_1
* cell instance $42847 m0 *1 190.08,109.62
X$42847 VSS \$5634 \$5010 \$2613 \$6432 VDD sg13g2_dfrbpq_1
* cell instance $42848 m0 *1 195.36,313.74
X$42848 VSS \$23117 \$21066 \$22334 \$22575 VDD sg13g2_dfrbpq_1
* cell instance $42849 m0 *1 196.8,291.06
X$42849 VSS \$20762 \$20538 \$20767 \$20454 VDD sg13g2_dfrbpq_1
* cell instance $42850 m0 *1 193.92,321.3
X$42850 VSS \$22678 \$23119 \$22400 \$22575 VDD sg13g2_dfrbpq_1
* cell instance $42851 m0 *1 87.36,291.06
X$42851 VSS \$20917 \$21691 \$20225 \$19978 VDD sg13g2_dfrbpq_1
* cell instance $42852 m0 *1 259.2,18.9
X$42852 VSS \$162 \$341 \$393 \$247 VDD sg13g2_dfrbpq_1
* cell instance $42853 m0 *1 43.2,260.82
X$42853 VSS \$19647 \$19070 \$19222 \$15624 VDD sg13g2_dfrbpq_1
* cell instance $42854 m0 *1 178.56,139.86
X$42854 VSS \$9117 \$8444 \$7779 \$5631 VDD sg13g2_dfrbpq_1
* cell instance $42855 m0 *1 50.4,185.22
X$42855 VSS \$11991 \$12410 \$11241 \$12289 VDD sg13g2_dfrbpq_1
* cell instance $42856 m0 *1 259.68,26.46
X$42856 VSS \$395 \$1328 \$789 \$247 VDD sg13g2_dfrbpq_1
* cell instance $42857 m0 *1 317.28,132.3
X$42857 VSS \$1032 \$8045 \$6222 \$7721 VDD sg13g2_dfrbpq_1
* cell instance $42858 m0 *1 265.44,49.14
X$42858 VSS \$97 \$2150 \$1070 \$247 VDD sg13g2_dfrbpq_1
* cell instance $42859 m0 *1 10.08,215.46
X$42859 VSS \$14011 \$14974 \$15326 \$12626 VDD sg13g2_dfrbpq_1
* cell instance $42860 m0 *1 191.04,124.74
X$42860 VSS \$7362 \$5401 \$7796 \$5631 VDD sg13g2_dfrbpq_1
* cell instance $42861 m0 *1 269.28,79.38
X$42861 VSS \$2386 \$4191 \$4524 \$2389 VDD sg13g2_dfrbpq_1
* cell instance $42862 m0 *1 267.84,34.02
X$42862 VSS \$395 \$1211 \$1091 \$247 VDD sg13g2_dfrbpq_1
* cell instance $42863 r0 *1 269.76,34.02
X$42863 \$246 VSS VDD sg13g2_inv_2
* cell instance $42864 m0 *1 240.48,185.22
X$42864 VSS \$12681 \$12360 \$12262 \$12538 VDD sg13g2_dfrbpq_1
* cell instance $42865 m0 *1 173.28,79.38
X$42865 VSS \$3721 \$2738 \$1719 \$2900 VDD sg13g2_dfrbpq_1
* cell instance $42866 m0 *1 266.4,71.82
X$42866 VSS \$2386 \$3620 \$3524 \$2389 VDD sg13g2_dfrbpq_1
* cell instance $42867 m0 *1 311.52,343.98
X$42867 VSS \$24627 \$23716 \$24841 \$22724 VDD sg13g2_dfrbpq_1
* cell instance $42868 m0 *1 299.04,223.02
X$42868 VSS \$15567 \$15978 \$16044 \$12554 VDD sg13g2_dfrbpq_1
* cell instance $42869 m0 *1 271.2,41.58
X$42869 VSS \$97 \$1710 \$1818 \$247 VDD sg13g2_dfrbpq_1
* cell instance $42870 m0 *1 19.2,321.3
X$42870 VSS \$21530 \$22648 \$23360 \$24039 VDD sg13g2_dfrbpq_1
* cell instance $42871 m0 *1 296.64,170.1
X$42871 VSS \$10887 \$11034 \$10420 \$8183 VDD sg13g2_dfrbpq_1
* cell instance $42872 m0 *1 336.96,185.22
X$42872 VSS \$12060 \$10710 \$10420 \$12321 VDD sg13g2_dfrbpq_1
* cell instance $42873 m0 *1 183.36,154.98
X$42873 VSS \$9117 \$8548 \$7771 \$9114 VDD sg13g2_dfrbpq_1
* cell instance $42874 m0 *1 334.08,215.46
X$42874 VSS \$13239 \$14437 \$14924 \$12321 VDD sg13g2_dfrbpq_1
* cell instance $42875 m0 *1 25.92,328.86
X$42875 VSS \$22165 \$23205 \$23369 \$24039 VDD sg13g2_dfrbpq_1
* cell instance $42876 m0 *1 12.96,253.26
X$42876 VSS \$17640 \$18620 \$19713 \$15624 VDD sg13g2_dfrbpq_1
* cell instance $42877 m0 *1 17.28,336.42
X$42877 VSS \$24040 \$22761 \$23906 \$24039 VDD sg13g2_dfrbpq_1
* cell instance $42878 m0 *1 50.4,230.58
X$42878 VSS \$15633 \$15761 \$15922 \$15634 VDD sg13g2_dfrbpq_1
* cell instance $42879 m0 *1 50.4,215.46
X$42879 VSS \$14011 \$14193 \$13779 \$12626 VDD sg13g2_dfrbpq_1
* cell instance $42880 m0 *1 288.96,275.94
X$42880 VSS \$20686 \$17465 \$20051 \$16160 VDD sg13g2_dfrbpq_1
* cell instance $42881 m0 *1 50.4,207.9
X$42881 VSS \$14011 \$14089 \$12879 \$12289 VDD sg13g2_dfrbpq_1
* cell instance $42882 m0 *1 181.44,253.26
X$42882 VSS \$15312 \$17668 \$18107 \$14809 VDD sg13g2_dfrbpq_1
* cell instance $42883 m0 *1 10.08,230.58
X$42883 VSS \$13576 \$16376 \$15922 \$15624 VDD sg13g2_dfrbpq_1
* cell instance $42884 m0 *1 242.4,132.3
X$42884 VSS \$5751 \$7366 \$5840 \$6443 VDD sg13g2_dfrbpq_1
* cell instance $42885 m0 *1 50.4,253.26
X$42885 VSS \$17640 \$17486 \$16868 \$15634 VDD sg13g2_dfrbpq_1
* cell instance $42886 m0 *1 50.4,192.78
X$42886 VSS \$11991 \$12883 \$9785 \$12289 VDD sg13g2_dfrbpq_1
* cell instance $42887 m0 *1 146.4,41.58
X$42887 VSS \$1314 \$153 \$71 \$79 VDD sg13g2_dfrbpq_1
* cell instance $42888 m0 *1 42.72,245.7
X$42888 VSS \$15633 \$17515 \$17508 \$15624 VDD sg13g2_dfrbpq_1
* cell instance $42889 m0 *1 10.08,238.14
X$42889 VSS \$15633 \$16983 \$16653 \$15624 VDD sg13g2_dfrbpq_1
* cell instance $42890 m0 *1 9.6,328.86
X$42890 VSS \$21530 \$23729 \$22649 \$24039 VDD sg13g2_dfrbpq_1
* cell instance $42891 m0 *1 296.16,313.74
X$42891 VSS \$22589 \$16528 \$22722 \$22724 VDD sg13g2_dfrbpq_1
* cell instance $42892 m0 *1 173.76,298.62
X$42892 VSS \$21041 \$21934 \$21998 \$20924 VDD sg13g2_dfrbpq_1
* cell instance $42893 m0 *1 66.24,230.58
X$42893 VSS \$15547 \$15775 \$16012 \$14322 VDD sg13g2_dfrbpq_1
* cell instance $42894 m0 *1 22.08,351.54
X$42894 VSS \$23002 \$22173 \$22369 \$24039 VDD sg13g2_dfrbpq_1
* cell instance $42895 m0 *1 207.84,306.18
X$42895 VSS \$19666 \$19669 \$22687 \$20454 VDD sg13g2_dfrbpq_1
* cell instance $42896 m0 *1 292.32,306.18
X$42896 VSS \$22589 \$22026 \$22153 \$20682 VDD sg13g2_dfrbpq_1
* cell instance $42897 m0 *1 92.64,283.5
X$42897 VSS \$19413 \$19409 \$19713 \$19978 VDD sg13g2_dfrbpq_1
* cell instance $42898 m0 *1 90.24,215.46
X$42898 VSS \$14202 \$13124 \$9785 \$14322 VDD sg13g2_dfrbpq_1
* cell instance $42899 m0 *1 23.52,343.98
X$42899 VSS \$24040 \$24630 \$21346 \$24039 VDD sg13g2_dfrbpq_1
* cell instance $42900 m0 *1 177.12,283.5
X$42900 VSS \$20762 \$19623 \$20523 \$20924 VDD sg13g2_dfrbpq_1
* cell instance $42901 m0 *1 180.48,64.26
X$42901 VSS \$2743 \$3135 \$2061 \$918 VDD sg13g2_dfrbpq_1
* cell instance $42902 m0 *1 209.76,313.74
X$42902 VSS \$22678 \$19674 \$22873 \$20454 VDD sg13g2_dfrbpq_1
* cell instance $42903 m0 *1 182.4,185.22
X$42903 VSS \$11875 \$12351 \$12347 \$9827 VDD sg13g2_dfrbpq_1
* cell instance $42904 m0 *1 103.2,34.02
X$42904 VSS \$976 \$1186 \$1184 \$75 VDD sg13g2_dfrbpq_1
* cell instance $42905 m0 *1 262.08,94.5
X$42905 VSS \$2758 \$3731 \$2742 \$4385 VDD sg13g2_dfrbpq_1
* cell instance $42906 m0 *1 181.44,132.3
X$42906 VSS \$7362 \$8270 \$9281 \$5631 VDD sg13g2_dfrbpq_1
* cell instance $42907 m0 *1 310.08,298.62
X$42907 VSS \$19514 \$17693 \$21091 \$19691 VDD sg13g2_dfrbpq_1
* cell instance $42908 m0 *1 324,207.9
X$42908 VSS \$13239 \$13072 \$14095 \$12321 VDD sg13g2_dfrbpq_1
* cell instance $42909 m0 *1 302.4,215.46
X$42909 VSS \$13985 \$11519 \$14416 \$12554 VDD sg13g2_dfrbpq_1
* cell instance $42910 m0 *1 256.8,132.3
X$42910 VSS \$7826 \$6198 \$6706 \$6443 VDD sg13g2_dfrbpq_1
* cell instance $42911 m0 *1 208.32,124.74
X$42911 VSS \$7362 \$6185 \$5805 \$6432 VDD sg13g2_dfrbpq_1
* cell instance $42912 m0 *1 266.4,64.26
X$42912 VSS \$2386 \$3398 \$3049 \$2389 VDD sg13g2_dfrbpq_1
* cell instance $42913 m0 *1 255.36,124.74
X$42913 VSS \$7919 \$8143 \$7778 \$6443 VDD sg13g2_dfrbpq_1
* cell instance $42914 m0 *1 261.6,162.54
X$42914 VSS \$10887 \$9236 \$9281 \$8183 VDD sg13g2_dfrbpq_1
* cell instance $42915 m0 *1 262.56,86.94
X$42915 VSS \$2758 \$3180 \$3663 \$2389 VDD sg13g2_dfrbpq_1
* cell instance $42916 m0 *1 326.4,200.34
X$42916 VSS \$13239 \$12933 \$13499 \$12321 VDD sg13g2_dfrbpq_1
* cell instance $42917 m0 *1 9.6,207.9
X$42917 VSS \$13576 \$14007 \$13575 \$12626 VDD sg13g2_dfrbpq_1
* cell instance $42918 m0 *1 313.44,291.06
X$42918 VSS \$19514 \$20693 \$21092 \$19691 VDD sg13g2_dfrbpq_1
* cell instance $42919 m0 *1 143.04,49.14
X$42919 VSS \$1314 \$2218 \$1184 \$83 VDD sg13g2_dfrbpq_1
* cell instance $42920 m0 *1 258.72,56.7
X$42920 VSS \$1783 \$2626 \$2383 \$247 VDD sg13g2_dfrbpq_1
* cell instance $42921 m0 *1 37.44,18.9
X$42921 VSS \$68 \$146 \$972 \$226 VDD sg13g2_dfrbpq_1
* cell instance $42922 r0 *1 40.32,18.9
X$42922 VDD \$513 VSS \$449 \$266 \$448 sg13g2_a21oi_1
* cell instance $42923 m0 *1 169.44,109.62
X$42923 VSS \$5389 \$5009 \$3703 \$5630 VDD sg13g2_dfrbpq_1
* cell instance $42924 m0 *1 310.08,41.58
X$42924 VSS \$1213 \$1697 \$1706 \$98 VDD sg13g2_dfrbpq_1
* cell instance $42925 m0 *1 308.16,49.14
X$42925 VSS \$1213 \$2113 \$2083 \$1684 VDD sg13g2_dfrbpq_1
* cell instance $42926 m0 *1 310.08,94.5
X$42926 VSS \$1480 \$5230 \$5193 \$2914 VDD sg13g2_dfrbpq_1
* cell instance $42927 m0 *1 313.44,26.46
X$42927 VSS \$481 \$572 \$627 \$98 VDD sg13g2_dfrbpq_1
* cell instance $42928 m0 *1 249.12,94.5
X$42928 VSS \$3920 \$3928 \$5032 \$3177 VDD sg13g2_dfrbpq_1
* cell instance $42929 m0 *1 309.12,79.38
X$42929 VSS \$1480 \$2396 \$3530 \$2914 VDD sg13g2_dfrbpq_1
* cell instance $42930 m0 *1 309.6,64.26
X$42930 VSS \$2393 \$3087 \$4460 \$1684 VDD sg13g2_dfrbpq_1
* cell instance $42931 m0 *1 142.56,102.06
X$42931 VSS \$5389 \$4775 \$3152 \$5380 VDD sg13g2_dfrbpq_1
* cell instance $42932 m0 *1 64.32,34.02
X$42932 VSS \$69 \$1226 \$970 \$149 VDD sg13g2_dfrbpq_1
* cell instance $42933 m0 *1 65.28,41.58
X$42933 VSS \$1411 \$1297 \$1294 \$1412 VDD sg13g2_dfrbpq_1
* cell instance $42934 m0 *1 311.04,18.9
X$42934 VSS \$481 \$163 \$250 \$98 VDD sg13g2_dfrbpq_1
* cell instance $42935 m0 *1 336.48,306.18
X$42935 VSS \$22595 \$21852 \$22169 \$19691 VDD sg13g2_dfrbpq_1
* cell instance $42936 m0 *1 310.56,34.02
X$42936 VSS \$1213 \$1017 \$1225 \$98 VDD sg13g2_dfrbpq_1
* cell instance $42937 m0 *1 312.96,71.82
X$42937 VSS \$2393 \$4635 \$3582 \$1684 VDD sg13g2_dfrbpq_1
* cell instance $42938 m0 *1 244.8,71.82
X$42938 VSS \$1783 \$3515 \$1875 \$1459 VDD sg13g2_dfrbpq_1
* cell instance $42939 m0 *1 80.16,41.58
X$42939 VSS \$1411 \$1305 \$764 \$1412 VDD sg13g2_dfrbpq_1
* cell instance $42940 m0 *1 77.28,34.02
X$42940 VSS \$73 \$905 \$972 \$1412 VDD sg13g2_dfrbpq_1
* cell instance $42941 m0 *1 140.64,124.74
X$42941 VSS \$7346 \$7683 \$7779 \$5380 VDD sg13g2_dfrbpq_1
* cell instance $42942 m0 *1 337.44,64.26
X$42942 VSS \$3191 \$3066 \$3069 \$2916 VDD sg13g2_dfrbpq_1
* cell instance $42943 m0 *1 333.12,71.82
X$42943 VSS \$3191 \$3535 \$3543 \$2916 VDD sg13g2_dfrbpq_1
* cell instance $42944 m0 *1 324.48,64.26
X$42944 VSS \$1792 \$3070 \$3079 \$1684 VDD sg13g2_dfrbpq_1
* cell instance $42945 m0 *1 328.8,86.94
X$42945 VSS \$3191 \$4638 \$4636 \$2916 VDD sg13g2_dfrbpq_1
* cell instance $42946 m0 *1 240.48,64.26
X$42946 VSS \$1783 \$3519 \$3137 \$1459 VDD sg13g2_dfrbpq_1
* cell instance $42947 m0 *1 75.84,49.14
X$42947 VSS \$1411 \$2204 \$2115 \$1412 VDD sg13g2_dfrbpq_1
* cell instance $42948 m0 *1 245.76,56.7
X$42948 VSS \$1783 \$2690 \$2379 \$246 VDD sg13g2_dfrbpq_1
* cell instance $42949 m0 *1 315.36,86.94
X$42949 VSS \$1480 \$3754 \$4633 \$2914 VDD sg13g2_dfrbpq_1
* cell instance $42950 m0 *1 96,223.02
X$42950 VSS \$15003 \$14014 \$12881 \$12633 VDD sg13g2_dfrbpq_1
* cell instance $42951 m0 *1 166.08,230.58
X$42951 VSS \$15649 \$15655 \$15884 \$13170 VDD sg13g2_dfrbpq_1
* cell instance $42952 m0 *1 57.6,177.66
X$42952 VSS \$9801 \$11173 \$11749 \$9250 VDD sg13g2_dfrbpq_1
* cell instance $42953 m0 *1 130.08,253.26
X$42953 VSS \$17050 \$16888 \$17654 \$16506 VDD sg13g2_dfrbpq_1
* cell instance $42954 m0 *1 101.76,230.58
X$42954 VSS \$15003 \$14691 \$13715 \$12633 VDD sg13g2_dfrbpq_1
* cell instance $42955 m0 *1 232.32,41.58
X$42955 VSS \$599 \$86 \$709 \$1459 VDD sg13g2_dfrbpq_1
* cell instance $42956 m0 *1 233.76,79.38
X$42956 VSS \$3920 \$2908 \$3922 \$3177 VDD sg13g2_dfrbpq_1
* cell instance $42957 m0 *1 81.6,170.1
X$42957 VSS \$9801 \$10281 \$8565 \$9541 VDD sg13g2_dfrbpq_1
* cell instance $42958 m0 *1 60.96,154.98
X$42958 VSS \$9252 \$9450 \$7025 \$9250 VDD sg13g2_dfrbpq_1
* cell instance $42959 m0 *1 67.2,162.54
X$42959 VSS \$9801 \$10446 \$9501 \$9250 VDD sg13g2_dfrbpq_1
* cell instance $42960 m0 *1 103.2,313.74
X$42960 VSS \$22481 \$22866 \$22865 \$21825 VDD sg13g2_dfrbpq_1
* cell instance $42961 m0 *1 50.4,124.74
X$42961 VSS \$6148 \$7866 \$6740 \$5916 VDD sg13g2_dfrbpq_1
* cell instance $42962 m0 *1 47.04,117.18
X$42962 VSS \$6148 \$7054 \$3019 \$5916 VDD sg13g2_dfrbpq_1
* cell instance $42963 m0 *1 162.24,102.06
X$42963 VSS \$6180 \$6705 \$5840 \$5630 VDD sg13g2_dfrbpq_1
* cell instance $42964 m0 *1 50.4,162.54
X$42964 VSS \$10443 \$9780 \$9439 \$9250 VDD sg13g2_dfrbpq_1
* cell instance $42965 m0 *1 21.12,139.86
X$42965 VSS \$7307 \$8940 \$7025 \$8551 VDD sg13g2_dfrbpq_1
* cell instance $42966 m0 *1 47.04,170.1
X$42966 VSS \$10443 \$10977 \$11552 \$9250 VDD sg13g2_dfrbpq_1
* cell instance $42967 m0 *1 232.32,94.5
X$42967 VSS \$3920 \$5176 \$4045 \$3177 VDD sg13g2_dfrbpq_1
* cell instance $42968 m0 *1 233.76,26.46
X$42968 VSS \$162 \$1266 \$875 \$246 VDD sg13g2_dfrbpq_1
* cell instance $42969 m0 *1 233.28,18.9
X$42969 VSS \$160 \$181 \$244 \$95 VDD sg13g2_dfrbpq_1
* cell instance $42970 m0 *1 100.8,306.18
X$42970 VSS \$22481 \$21548 \$22063 \$19978 VDD sg13g2_dfrbpq_1
* cell instance $42971 m0 *1 10.08,18.9
X$42971 VSS \$223 \$265 \$264 \$226 VDD sg13g2_dfrbpq_1
* cell instance $42972 m0 *1 10.08,26.46
X$42972 VSS \$223 \$763 \$762 \$226 VDD sg13g2_dfrbpq_1
* cell instance $42974 m0 *1 48.48,132.3
X$42974 VSS \$7950 \$7802 \$7800 \$5916 VDD sg13g2_dfrbpq_1
* cell instance $42975 m0 *1 50.4,139.86
X$42975 VSS \$9097 \$8869 \$7938 \$5916 VDD sg13g2_dfrbpq_1
* cell instance $42976 m0 *1 50.4,102.06
X$42976 VSS \$6148 \$5812 \$4598 \$4275 VDD sg13g2_dfrbpq_1
* cell instance $42977 m0 *1 50.4,109.62
X$42977 VSS \$6148 \$7157 \$6142 \$4275 VDD sg13g2_dfrbpq_1
* cell instance $42978 m0 *1 97.44,192.78
X$42978 VSS \$12013 \$11172 \$11749 \$12633 VDD sg13g2_dfrbpq_1
* cell instance $42979 m0 *1 50.4,147.42
X$42979 VSS \$9097 \$9614 \$8412 \$9250 VDD sg13g2_dfrbpq_1
* cell instance $42980 m0 *1 296.16,79.38
X$42980 VSS \$2758 \$4155 \$4143 \$2914 VDD sg13g2_dfrbpq_1
* cell instance $42981 m0 *1 52.8,26.46
X$42981 VSS \$69 \$522 \$766 \$149 VDD sg13g2_dfrbpq_1
* cell instance $42982 m0 *1 65.76,26.46
X$42982 VSS \$378 VDD \$1221 \$900 \$520 \$271 \$148 sg13g2_a221oi_1
* cell instance $42983 m0 *1 100.32,132.3
X$42983 VSS \$7340 \$6749 \$5810 \$6281 VDD sg13g2_dfrbpq_1
* cell instance $42984 m0 *1 236.16,223.02
X$42984 VSS \$15312 \$15276 \$15055 \$13206 VDD sg13g2_dfrbpq_1
* cell instance $42985 m0 *1 222.72,71.82
X$42985 VSS \$1346 \$3179 \$3663 \$3177 VDD sg13g2_dfrbpq_1
* cell instance $42986 m0 *1 103.2,124.74
X$42986 VSS \$7340 \$7550 \$7771 \$6281 VDD sg13g2_dfrbpq_1
* cell instance $42987 m0 *1 220.32,18.9
X$42987 VSS \$160 \$282 \$192 \$95 VDD sg13g2_dfrbpq_1
* cell instance $42988 m0 *1 219.36,41.58
X$42988 VSS \$599 \$241 \$328 \$95 VDD sg13g2_dfrbpq_1
* cell instance $42989 m0 *1 219.84,64.26
X$42989 VSS \$1346 \$2872 \$3141 \$3177 VDD sg13g2_dfrbpq_1
* cell instance $42990 m0 *1 276.48,86.94
X$42990 VSS \$419 \$4628 \$4711 \$4385 VDD sg13g2_dfrbpq_1
* cell instance $42991 m0 *1 81.6,18.9
X$42991 VSS \$69 \$455 \$527 \$149 VDD sg13g2_dfrbpq_1
* cell instance $42992 r0 *1 87.84,18.9
X$42992 \$971 VSS VDD \$417 \$543 \$331 \$643 sg13g2_a22oi_1
* cell instance $42993 m0 *1 275.04,94.5
X$42993 VSS \$2758 \$2969 \$3922 \$4385 VDD sg13g2_dfrbpq_1
* cell instance $42994 m0 *1 118.08,124.74
X$42994 VSS \$6774 \$5374 \$1376 \$5380 VDD sg13g2_dfrbpq_1
* cell instance $42995 m0 *1 337.92,79.38
X$42995 VSS \$2429 \$4075 \$4084 \$2916 VDD sg13g2_dfrbpq_1
* cell instance $42996 m0 *1 108.96,298.62
X$42996 VSS \$19911 \$21312 \$21977 \$21825 VDD sg13g2_dfrbpq_1
* cell instance $42997 m0 *1 113.76,102.06
X$42997 VSS \$6154 \$4023 \$4161 \$5380 VDD sg13g2_dfrbpq_1
* cell instance $42998 m0 *1 113.76,306.18
X$42998 VSS \$22667 \$21549 \$21310 \$21825 VDD sg13g2_dfrbpq_1
* cell instance $42999 m0 *1 279.84,71.82
X$42999 VSS \$1468 \$3604 \$3526 \$2389 VDD sg13g2_dfrbpq_1
* cell instance $43000 m0 *1 279.36,64.26
X$43000 VSS \$1468 \$801 \$3052 \$2389 VDD sg13g2_dfrbpq_1
* cell instance $43001 m0 *1 334.56,283.5
X$43001 VSS \$19477 \$20464 \$20570 \$19691 VDD sg13g2_dfrbpq_1
* cell instance $43002 m0 *1 50.4,298.62
X$43002 VSS \$20742 \$21957 \$21294 \$19646 VDD sg13g2_dfrbpq_1
* cell instance $43003 m0 *1 148.32,192.78
X$43003 VSS \$12020 \$11461 \$10459 \$11472 VDD sg13g2_dfrbpq_1
* cell instance $43004 m0 *1 47.04,336.42
X$43004 VSS \$23517 \$23089 \$23220 \$23087 VDD sg13g2_dfrbpq_1
* cell instance $43005 m0 *1 47.52,275.94
X$43005 VSS \$19647 \$20224 \$20225 \$19646 VDD sg13g2_dfrbpq_1
* cell instance $43006 m0 *1 38.88,328.86
X$43006 VSS \$23517 \$23081 \$23475 \$23087 VDD sg13g2_dfrbpq_1
* cell instance $43007 m0 *1 144.48,200.34
X$43007 VSS \$12020 \$12660 \$13526 \$11472 VDD sg13g2_dfrbpq_1
* cell instance $43008 m0 *1 330.24,275.94
X$43008 VSS \$19514 \$20252 \$20064 \$19691 VDD sg13g2_dfrbpq_1
* cell instance $43009 m0 *1 115.2,109.62
X$43009 VSS \$6154 \$6161 \$5464 \$5380 VDD sg13g2_dfrbpq_1
* cell instance $43010 m0 *1 337.92,94.5
X$43010 VSS \$5046 \$5049 \$5204 \$2916 VDD sg13g2_dfrbpq_1
* cell instance $43011 m0 *1 236.64,215.46
X$43011 VSS \$13700 \$14157 \$14225 \$13206 VDD sg13g2_dfrbpq_1
* cell instance $43012 m0 *1 245.76,200.34
X$43012 VSS \$12681 \$12921 \$13200 \$13206 VDD sg13g2_dfrbpq_1
* cell instance $43013 m0 *1 246.72,79.38
X$43013 VSS \$3920 \$3734 \$2906 \$1459 VDD sg13g2_dfrbpq_1
* cell instance $43014 m0 *1 259.68,79.38
X$43014 VDD VSS \$3960 \$3510 \$3928 \$4059 sg13g2_a21o_1
* cell instance $43015 m0 *1 167.52,124.74
X$43015 VSS \$6180 \$7925 \$7686 \$5630 VDD sg13g2_dfrbpq_1
* cell instance $43016 m0 *1 322.08,79.38
X$43016 VSS \$3191 \$3937 \$4129 \$2916 VDD sg13g2_dfrbpq_1
* cell instance $43017 m0 *1 252.96,215.46
X$43017 VSS \$13700 \$12920 \$14402 \$13206 VDD sg13g2_dfrbpq_1
* cell instance $43018 m0 *1 278.4,298.62
X$43018 VSS \$20686 \$18529 \$21877 \$20682 VDD sg13g2_dfrbpq_1
* cell instance $43019 m0 *1 168.48,132.3
X$43019 VSS \$7346 \$7688 \$8842 \$5630 VDD sg13g2_dfrbpq_1
* cell instance $43020 m0 *1 323.04,94.5
X$43020 VSS \$1480 \$5053 \$3941 \$2916 VDD sg13g2_dfrbpq_1
* cell instance $43021 m0 *1 226.56,49.14
X$43021 VSS \$1346 \$1978 \$2076 \$1459 VDD sg13g2_dfrbpq_1
* cell instance $43022 m0 *1 154.56,124.74
X$43022 VSS \$6180 \$6160 \$5464 \$5630 VDD sg13g2_dfrbpq_1
* cell instance $43023 m0 *1 155.04,117.18
X$43023 VSS \$6180 \$7685 \$7039 \$5630 VDD sg13g2_dfrbpq_1
* cell instance $43024 m0 *1 219.36,34.02
X$43024 VSS \$599 \$1004 \$1455 \$95 VDD sg13g2_dfrbpq_1
* cell instance $43025 m0 *1 150.72,109.62
X$43025 VSS \$5389 \$6179 \$4614 \$5630 VDD sg13g2_dfrbpq_1
* cell instance $43026 m0 *1 316.8,56.7
X$43026 VSS \$2393 \$2398 \$3060 \$1684 VDD sg13g2_dfrbpq_1
* cell instance $43027 m0 *1 124.8,313.74
X$43027 VSS \$22667 \$22325 \$22935 \$21825 VDD sg13g2_dfrbpq_1
* cell instance $43028 m0 *1 55.68,49.14
X$43028 VSS \$1411 \$2041 \$3023 \$226 VDD sg13g2_dfrbpq_1
* cell instance $43029 m0 *1 337.92,56.7
X$43029 VSS \$1792 \$2637 \$2634 \$1684 VDD sg13g2_dfrbpq_1
* cell instance $43030 m0 *1 317.76,313.74
X$43030 VSS \$22595 \$22422 \$22893 \$22192 VDD sg13g2_dfrbpq_1
* cell instance $43031 m0 *1 220.8,26.46
X$43031 VSS \$160 \$689 \$952 \$95 VDD sg13g2_dfrbpq_1
* cell instance $43032 m0 *1 283.2,79.38
X$43032 VSS \$2758 \$4472 \$4187 \$2914 VDD sg13g2_dfrbpq_1
* cell instance $43033 m0 *1 288,94.5
X$43033 VSS \$1020 \$3640 \$2906 \$4385 VDD sg13g2_dfrbpq_1
* cell instance $43034 m0 *1 220.8,79.38
X$43034 VSS \$3920 \$3507 \$2061 \$3177 VDD sg13g2_dfrbpq_1
* cell instance $43035 m0 *1 286.56,56.7
X$43035 VSS \$1468 \$2631 \$595 \$2389 VDD sg13g2_dfrbpq_1
* cell instance $43036 m0 *1 289.44,86.94
X$43036 VSS \$1020 \$4632 \$4629 \$4385 VDD sg13g2_dfrbpq_1
* cell instance $43037 m0 *1 142.56,215.46
X$43037 VSS \$13963 \$14346 \$14653 \$13170 VDD sg13g2_dfrbpq_1
* cell instance $43038 m0 *1 302.4,86.94
X$43038 VSS \$1480 \$5988 \$4889 \$2914 VDD sg13g2_dfrbpq_1
* cell instance $43039 m0 *1 337.92,321.3
X$43039 VSS \$22595 \$22898 \$23355 \$22192 VDD sg13g2_dfrbpq_1
* cell instance $43040 m0 *1 77.28,102.06
X$43040 VSS \$4987 \$6417 \$5504 \$4275 VDD sg13g2_dfrbpq_1
* cell instance $43041 m0 *1 81.6,109.62
X$43041 VSS \$4987 \$4978 \$3679 \$5612 VDD sg13g2_dfrbpq_1
* cell instance $43042 m0 *1 146.88,336.42
X$43042 VSS \$24057 \$24375 \$23535 \$23104 VDD sg13g2_dfrbpq_1
* cell instance $43043 m0 *1 192,260.82
X$43043 VSS \$17437 \$18289 \$18774 \$14809 VDD sg13g2_dfrbpq_1
* cell instance $43044 m0 *1 204.48,56.7
X$43044 VSS \$1678 \$2620 \$1875 \$918 VDD sg13g2_dfrbpq_1
* cell instance $43045 m0 *1 184.32,268.38
X$43045 VSS \$19666 \$19735 \$19740 \$20459 VDD sg13g2_dfrbpq_1
* cell instance $43046 m0 *1 114.24,260.82
X$43046 VSS \$17050 \$16793 \$19268 \$16506 VDD sg13g2_dfrbpq_1
* cell instance $43047 m0 *1 112.32,253.26
X$43047 VSS \$15003 \$17051 \$18542 \$16506 VDD sg13g2_dfrbpq_1
* cell instance $43048 m0 *1 192.48,79.38
X$43048 VSS \$3326 \$3967 \$4045 \$3725 VDD sg13g2_dfrbpq_1
* cell instance $43049 m0 *1 163.2,306.18
X$43049 VSS \$22264 \$21935 \$22273 \$22121 VDD sg13g2_dfrbpq_1
* cell instance $43050 m0 *1 205.44,79.38
X$43050 VSS \$3326 \$3171 \$1994 \$3725 VDD sg13g2_dfrbpq_1
* cell instance $43051 m0 *1 124.8,268.38
X$43051 VSS \$19413 \$19728 \$19727 \$19658 VDD sg13g2_dfrbpq_1
* cell instance $43052 m0 *1 193.44,64.26
X$43052 VSS \$2743 \$2978 \$3922 \$918 VDD sg13g2_dfrbpq_1
* cell instance $43053 m0 *1 138.72,207.9
X$43053 VSS \$13963 \$13000 \$13524 \$11472 VDD sg13g2_dfrbpq_1
* cell instance $43054 m0 *1 160.32,298.62
X$43054 VSS \$21041 \$21559 \$22119 \$22121 VDD sg13g2_dfrbpq_1
* cell instance $43055 m0 *1 185.28,56.7
X$43055 VSS \$1678 \$2067 \$2359 \$918 VDD sg13g2_dfrbpq_1
* cell instance $43056 m0 *1 203.52,71.82
X$43056 VSS \$3326 \$3327 \$4047 \$3725 VDD sg13g2_dfrbpq_1
* cell instance $43057 m0 *1 141.12,268.38
X$43057 VSS \$19663 \$19731 \$19154 \$19658 VDD sg13g2_dfrbpq_1
* cell instance $43058 m0 *1 10.08,79.38
X$43058 VSS \$3291 \$4014 \$3884 \$1384 VDD sg13g2_dfrbpq_1
* cell instance $43059 m0 *1 10.08,86.94
X$43059 VSS \$3291 \$4832 \$4598 \$3151 VDD sg13g2_dfrbpq_1
* cell instance $43060 m0 *1 10.08,94.5
X$43060 VSS \$4974 \$4976 \$6142 \$3151 VDD sg13g2_dfrbpq_1
* cell instance $43061 m0 *1 74.4,132.3
X$43061 VSS \$6763 \$8510 \$8121 \$5612 VDD sg13g2_dfrbpq_1
* cell instance $43062 m0 *1 61.44,132.3
X$43062 VSS \$7163 \$7957 \$8950 \$5612 VDD sg13g2_dfrbpq_1
* cell instance $43063 m0 *1 189.12,245.7
X$43063 VSS \$17437 \$16796 \$17059 \$14809 VDD sg13g2_dfrbpq_1
* cell instance $43064 m0 *1 60,117.18
X$43064 VSS \$7163 \$7028 \$5810 \$4275 VDD sg13g2_dfrbpq_1
* cell instance $43065 m0 *1 10.08,64.26
X$43065 VSS \$2197 \$3146 \$3286 \$1384 VDD sg13g2_dfrbpq_1
* cell instance $43066 m0 *1 10.08,71.82
X$43066 VSS \$2197 \$3277 \$3476 \$1384 VDD sg13g2_dfrbpq_1
* cell instance $43067 m0 *1 153.12,291.06
X$43067 VSS \$21696 \$21039 \$21231 \$20447 VDD sg13g2_dfrbpq_1
* cell instance $43068 m0 *1 54.72,94.5
X$43068 VSS \$4987 \$5363 \$6250 \$4275 VDD sg13g2_dfrbpq_1
* cell instance $43069 m0 *1 51.84,79.38
X$43069 VSS \$3490 \$4604 \$4277 \$3151 VDD sg13g2_dfrbpq_1
* cell instance $43070 m0 *1 74.88,94.5
X$43070 VSS \$3490 \$5148 \$5464 \$4275 VDD sg13g2_dfrbpq_1
* cell instance $43071 m0 *1 73.92,86.94
X$43071 VSS \$3490 \$4122 \$4161 \$4275 VDD sg13g2_dfrbpq_1
* cell instance $43072 m0 *1 188.64,86.94
X$43072 VSS \$3326 \$3504 \$2678 \$3725 VDD sg13g2_dfrbpq_1
* cell instance $43073 m0 *1 71.52,71.82
X$43073 VSS \$2319 \$3489 \$2641 \$1412 VDD sg13g2_dfrbpq_1
* cell instance $43074 m0 *1 70.56,56.7
X$43074 VSS \$2319 \$2323 \$2318 \$1412 VDD sg13g2_dfrbpq_1
* cell instance $43075 m0 *1 50.4,56.7
X$43075 VSS \$2310 \$2313 \$1662 \$1412 VDD sg13g2_dfrbpq_1
* cell instance $43076 m0 *1 143.52,298.62
X$43076 VSS \$21696 \$19732 \$21990 \$21830 VDD sg13g2_dfrbpq_1
* cell instance $43077 m0 *1 147.84,306.18
X$43077 VSS \$22264 \$22118 \$20758 \$22121 VDD sg13g2_dfrbpq_1
* cell instance $43078 m0 *1 164.16,245.7
X$43078 VSS \$17050 \$16798 \$17049 \$13170 VDD sg13g2_dfrbpq_1
* cell instance $43079 m0 *1 140.16,245.7
X$43079 VSS \$15649 \$16286 \$17036 \$16506 VDD sg13g2_dfrbpq_1
* cell instance $43080 m0 *1 214.56,298.62
X$43080 VSS \$20762 \$19086 \$21712 \$20459 VDD sg13g2_dfrbpq_1
* cell instance $43081 m0 *1 211.68,94.5
X$43081 VSS \$5634 \$5171 \$4565 \$3725 VDD sg13g2_dfrbpq_1
* cell instance $43082 m0 *1 208.32,253.26
X$43082 VSS \$17437 \$17864 \$18426 \$14809 VDD sg13g2_dfrbpq_1
* cell instance $43083 m0 *1 217.44,343.98
X$43083 VSS \$23451 \$24075 \$24391 \$25181 VDD sg13g2_dfrbpq_1
* cell instance $43084 m0 *1 224.64,321.3
X$43084 VSS \$23451 \$23548 \$23324 \$23122 VDD sg13g2_dfrbpq_1
* cell instance $43085 m0 *1 50.4,86.94
X$43085 VSS \$3147 \$4432 \$2731 \$3151 VDD sg13g2_dfrbpq_1
* cell instance $43086 m0 *1 39.84,26.46
X$43086 VSS \$68 \$771 \$764 \$226 VDD sg13g2_dfrbpq_1
* cell instance $43087 m0 *1 50.4,41.58
X$43087 VSS \$897 \$1668 \$1667 \$226 VDD sg13g2_dfrbpq_1
* cell instance $43088 m0 *1 50.4,34.02
X$43088 VSS \$804 \$1182 \$446 \$149 VDD sg13g2_dfrbpq_1
* cell instance $43089 r0 *1 63.36,34.02
X$43089 VDD \$1490 VSS \$1406 \$971 \$1761 \$1221 sg13g2_nand4_1
* cell instance $43090 m0 *1 50.4,18.9
X$43090 VSS \$68 \$269 \$227 \$149 VDD sg13g2_dfrbpq_1
* cell instance $43091 m0 *1 50.4,64.26
X$43091 VSS \$2310 \$3024 \$2036 \$3151 VDD sg13g2_dfrbpq_1
* cell instance $43092 m0 *1 50.4,71.82
X$43092 VSS \$3291 \$3559 \$3286 \$3151 VDD sg13g2_dfrbpq_1
* cell instance $43093 m0 *1 63.36,71.82
X$43093 VSS \$3404 \$2599 \$3206 \$3287 VDD sg13g2_mux2_1
* cell instance $43094 m0 *1 237.6,321.3
X$43094 VSS \$23451 \$16311 \$23131 \$23122 VDD sg13g2_dfrbpq_1
* cell instance $43095 m0 *1 241.44,351.54
X$43095 VSS \$24764 \$25035 \$24345 \$24837 VDD sg13g2_dfrbpq_1
* cell instance $43096 m0 *1 238.08,343.98
X$43096 VSS \$24764 \$24542 \$24763 \$23122 VDD sg13g2_dfrbpq_1
* cell instance $43097 m0 *1 213.6,86.94
X$43097 VSS \$3326 \$4623 \$3506 \$3725 VDD sg13g2_dfrbpq_1
* cell instance $43098 m0 *1 193.44,238.14
X$43098 VSS \$15947 \$16289 \$16303 \$14809 VDD sg13g2_dfrbpq_1
* cell instance $43099 m0 *1 192,207.9
X$43099 VSS \$12221 \$13967 \$14175 \$13170 VDD sg13g2_dfrbpq_1
* cell instance $43100 m0 *1 164.16,321.3
X$43100 VSS \$22264 \$23421 \$23342 \$23108 VDD sg13g2_dfrbpq_1
* cell instance $43101 m0 *1 10.08,154.98
X$43101 VSS \$10271 \$10081 \$10037 \$8551 VDD sg13g2_dfrbpq_1
* cell instance $43102 m0 *1 10.08,147.42
X$43102 VSS \$9097 \$9493 \$9439 \$8551 VDD sg13g2_dfrbpq_1
* cell instance $43103 m0 *1 278.88,321.3
X$43103 VSS \$22589 \$22714 \$23266 \$20682 VDD sg13g2_dfrbpq_1
* cell instance $43104 m0 *1 10.08,170.1
X$43104 VSS \$10271 \$11304 \$11241 \$8551 VDD sg13g2_dfrbpq_1
* cell instance $43105 m0 *1 10.08,177.66
X$43105 VSS \$10271 \$11742 \$9785 \$8551 VDD sg13g2_dfrbpq_1
* cell instance $43106 m0 *1 159.84,253.26
X$43106 VSS \$17050 \$17831 \$17833 \$16506 VDD sg13g2_dfrbpq_1
* cell instance $43107 m0 *1 115.2,200.34
X$43107 VSS \$12013 \$12901 \$13150 \$12633 VDD sg13g2_dfrbpq_1
* cell instance $43108 m0 *1 100.32,207.9
X$43108 VSS \$13735 \$13147 \$13731 \$12633 VDD sg13g2_dfrbpq_1
* cell instance $43109 m0 *1 117.6,192.78
X$43109 VSS \$12013 \$12890 \$13515 \$11472 VDD sg13g2_dfrbpq_1
* cell instance $43110 m0 *1 112.8,215.46
X$43110 VSS \$13735 \$13966 \$14718 \$12633 VDD sg13g2_dfrbpq_1
* cell instance $43111 m0 *1 26.88,147.42
X$43111 VSS \$9097 \$9717 \$9501 \$8551 VDD sg13g2_dfrbpq_1
* cell instance $43112 m0 *1 10.08,56.7
X$43112 VSS \$2197 \$2599 \$2304 \$1384 VDD sg13g2_dfrbpq_1
* cell instance $43113 m0 *1 207.36,18.9
X$43113 VSS \$470 \$158 \$706 \$95 VDD sg13g2_dfrbpq_1
* cell instance $43114 m0 *1 187.68,215.46
X$43114 VSS \$12221 \$14043 \$14376 \$13170 VDD sg13g2_dfrbpq_1
* cell instance $43115 m0 *1 238.08,34.02
X$43115 VSS \$1008 \$1085 \$1650 \$246 VDD sg13g2_dfrbpq_1
* cell instance $43116 m0 *1 75.84,147.42
X$43116 VSS \$9252 \$9262 \$9792 \$9541 VDD sg13g2_dfrbpq_1
* cell instance $43117 m0 *1 10.08,34.02
X$43117 VSS \$223 \$1291 \$1181 \$226 VDD sg13g2_dfrbpq_1
* cell instance $43118 m0 *1 10.08,41.58
X$43118 VSS \$897 \$1390 \$1662 \$1384 VDD sg13g2_dfrbpq_1
* cell instance $43119 m0 *1 10.08,49.14
X$43119 VSS \$2197 \$2037 \$2036 \$1384 VDD sg13g2_dfrbpq_1
* cell instance $43120 m0 *1 245.28,41.58
X$43120 VSS \$1009 \$921 \$442 \$246 VDD sg13g2_dfrbpq_1
* cell instance $43121 m0 *1 246.72,26.46
X$43121 VSS \$162 \$666 \$569 \$246 VDD sg13g2_dfrbpq_1
* cell instance $43122 m0 *1 239.52,49.14
X$43122 VSS \$599 \$1911 \$2170 \$1459 VDD sg13g2_dfrbpq_1
* cell instance $43123 m0 *1 246.24,18.9
X$43123 VSS \$162 \$285 \$374 \$246 VDD sg13g2_dfrbpq_1
* cell instance $43124 m0 *1 252.48,49.14
X$43124 VSS \$1009 \$1968 \$2079 \$246 VDD sg13g2_dfrbpq_1
* cell instance $43125 m0 *1 258.24,41.58
X$43125 VSS \$1008 \$1964 \$1603 \$247 VDD sg13g2_dfrbpq_1
* cell instance $43126 m0 *1 254.88,34.02
X$43126 VSS \$1008 \$1460 \$1208 \$246 VDD sg13g2_dfrbpq_1
* cell instance $43127 m0 *1 17.76,162.54
X$43127 VSS \$10271 \$10632 \$11749 \$8551 VDD sg13g2_dfrbpq_1
* cell instance $43128 m0 *1 253.44,64.26
X$43128 VSS \$1783 \$2934 \$3125 \$1459 VDD sg13g2_dfrbpq_1
* cell instance $43129 m0 *1 206.88,64.26
X$43129 VSS \$2907 \$3126 \$2906 \$918 VDD sg13g2_dfrbpq_1
* cell instance $43130 m0 *1 34.08,109.62
X$43130 VSS \$4974 \$6621 \$4658 \$5916 VDD sg13g2_dfrbpq_1
* cell instance $43131 m0 *1 34.08,71.82
X$43131 VSS \$2197 \$3388 \$4161 \$1384 VDD sg13g2_dfrbpq_1
* cell instance $43132 m0 *1 10.08,109.62
X$43132 VSS \$4974 \$6396 \$3019 \$5916 VDD sg13g2_dfrbpq_1
* cell instance $43133 m0 *1 206.4,238.14
X$43133 VSS \$15947 \$16637 \$16560 \$14809 VDD sg13g2_dfrbpq_1
* cell instance $43134 m0 *1 31.2,56.7
X$43134 VSS \$2197 \$2600 \$2641 \$1384 VDD sg13g2_dfrbpq_1
* cell instance $43135 m0 *1 318.24,336.42
X$43135 VSS \$22721 \$23842 \$24102 \$22724 VDD sg13g2_dfrbpq_1
* cell instance $43136 m0 *1 279.36,343.98
X$43136 VSS \$22589 \$23939 \$24408 \$22724 VDD sg13g2_dfrbpq_1
* cell instance $43137 m0 *1 228,56.7
X$43137 VSS \$1346 \$2378 \$2979 \$1459 VDD sg13g2_dfrbpq_1
* cell instance $43138 m0 *1 202.08,34.02
X$43138 VSS \$470 \$1001 \$442 \$95 VDD sg13g2_dfrbpq_1
* cell instance $43139 m0 *1 201.12,49.14
X$43139 VSS \$1678 \$339 \$222 \$918 VDD sg13g2_dfrbpq_1
* cell instance $43140 m0 *1 10.08,132.3
X$43140 VSS \$7307 \$8476 \$5969 \$5916 VDD sg13g2_dfrbpq_1
* cell instance $43141 m0 *1 166.08,291.06
X$43141 VSS \$21041 \$20764 \$21702 \$20447 VDD sg13g2_dfrbpq_1
* cell instance $43142 m0 *1 287.52,253.26
X$43142 VSS \$15693 \$17718 \$17906 \$16160 VDD sg13g2_dfrbpq_1
* cell instance $43143 m0 *1 288.96,268.38
X$43143 VSS \$19471 \$16831 \$19818 \$16160 VDD sg13g2_dfrbpq_1
* cell instance $43144 m0 *1 20.16,102.06
X$43144 VSS \$4974 \$5142 \$5810 \$5916 VDD sg13g2_dfrbpq_1
* cell instance $43145 m0 *1 123.84,283.5
X$43145 VSS \$19413 \$18735 \$20843 \$19658 VDD sg13g2_dfrbpq_1
* cell instance $43146 m0 *1 124.32,275.94
X$43146 VSS \$19413 \$19729 \$19992 \$19658 VDD sg13g2_dfrbpq_1
* cell instance $43147 m0 *1 124.8,291.06
X$43147 VSS \$19906 \$18790 \$21191 \$19658 VDD sg13g2_dfrbpq_1
* cell instance $43148 m0 *1 184.32,41.58
X$43148 VSS \$1678 \$1731 \$782 \$918 VDD sg13g2_dfrbpq_1
* cell instance $43149 m0 *1 10.08,117.18
X$43149 VSS \$7307 \$7431 \$7308 \$5916 VDD sg13g2_dfrbpq_1
* cell instance $43150 m0 *1 164.16,275.94
X$43150 VSS \$19663 \$19098 \$20007 \$20447 VDD sg13g2_dfrbpq_1
* cell instance $43151 m0 *1 24.96,26.46
X$43151 VSS \$223 \$808 \$1294 \$226 VDD sg13g2_dfrbpq_1
* cell instance $43152 m0 *1 23.04,18.9
X$43152 VSS \$223 \$266 \$227 \$226 VDD sg13g2_dfrbpq_1
* cell instance $43153 m0 *1 200.16,192.78
X$43153 VSS \$11875 \$11489 \$12470 \$9827 VDD sg13g2_dfrbpq_1
* cell instance $43154 m0 *1 204.96,215.46
X$43154 VSS \$12221 \$14186 \$14760 \$14809 VDD sg13g2_dfrbpq_1
* cell instance $43155 m0 *1 205.44,200.34
X$43155 VSS \$11875 \$13430 \$13412 \$12538 VDD sg13g2_dfrbpq_1
* cell instance $43156 m0 *1 10.08,124.74
X$43156 VSS \$7307 \$7844 \$7800 \$5916 VDD sg13g2_dfrbpq_1
* cell instance $43157 m0 *1 164.64,139.86
X$43157 VSS \$9108 \$8896 \$8894 \$5630 VDD sg13g2_dfrbpq_1
* cell instance $43158 m0 *1 90.24,117.18
X$43158 VSS \$6763 \$6147 \$4759 \$5612 VDD sg13g2_dfrbpq_1
* cell instance $43159 m0 *1 107.52,336.42
X$43159 VSS \$23499 \$23791 \$23662 \$23104 VDD sg13g2_dfrbpq_1
* cell instance $43160 m0 *1 105.6,343.98
X$43160 VSS \$23499 \$24821 \$24877 \$23104 VDD sg13g2_dfrbpq_1
* cell instance $43161 m0 *1 295.2,230.58
X$43161 VSS \$15693 \$15973 \$16059 \$15972 VDD sg13g2_dfrbpq_1
* cell instance $43162 m0 *1 315.36,192.78
X$43162 VSS \$12060 \$12070 \$13502 \$12321 VDD sg13g2_dfrbpq_1
* cell instance $43163 m0 *1 308.16,207.9
X$43163 VSS \$13985 \$13851 \$14071 \$12554 VDD sg13g2_dfrbpq_1
* cell instance $43164 m0 *1 310.08,260.82
X$43164 VSS \$15567 \$19113 \$19251 \$15972 VDD sg13g2_dfrbpq_1
* cell instance $43165 m0 *1 167.52,64.26
X$43165 VSS \$2614 \$2151 \$959 \$2900 VDD sg13g2_dfrbpq_1
* cell instance $43166 m0 *1 131.52,147.42
X$43166 VSS \$9259 \$8426 \$7321 \$9809 VDD sg13g2_dfrbpq_1
* cell instance $43167 m0 *1 333.6,230.58
X$43167 VSS \$15567 \$15714 \$16815 \$15972 VDD sg13g2_dfrbpq_1
* cell instance $43168 m0 *1 132,170.1
X$43168 VSS \$9107 \$10935 \$10102 \$9809 VDD sg13g2_dfrbpq_1
* cell instance $43169 m0 *1 135.84,154.98
X$43169 VSS \$9108 \$9812 \$7992 \$9809 VDD sg13g2_dfrbpq_1
* cell instance $43170 m0 *1 298.08,18.9
X$43170 VSS \$164 \$286 \$325 \$98 VDD sg13g2_dfrbpq_1
* cell instance $43171 m0 *1 300.48,26.46
X$43171 VSS \$164 \$1022 \$793 \$98 VDD sg13g2_dfrbpq_1
* cell instance $43172 m0 *1 120.96,336.42
X$43172 VSS \$23530 \$24385 \$23994 \$23104 VDD sg13g2_dfrbpq_1
* cell instance $43173 m0 *1 143.52,139.86
X$43173 VSS \$9108 \$7990 \$7771 \$5630 VDD sg13g2_dfrbpq_1
* cell instance $43174 m0 *1 275.52,230.58
X$43174 VSS \$15693 \$15695 \$16094 \$13206 VDD sg13g2_dfrbpq_1
* cell instance $43175 m0 *1 128.16,34.02
X$43175 VSS \$29 \$1109 \$981 \$79 VDD sg13g2_dfrbpq_1
* cell instance $43176 m0 *1 337.92,49.14
X$43176 VSS \$1792 \$2086 \$2259 \$99 VDD sg13g2_dfrbpq_1
* cell instance $43177 m0 *1 324.48,34.02
X$43177 VSS \$252 \$877 \$1212 \$99 VDD sg13g2_dfrbpq_1
* cell instance $43178 m0 *1 324.96,49.14
X$43178 VSS \$252 \$2085 \$2103 \$1684 VDD sg13g2_dfrbpq_1
* cell instance $43179 m0 *1 130.56,41.58
X$43179 VSS \$1431 \$273 \$105 \$79 VDD sg13g2_dfrbpq_1
* cell instance $43180 m0 *1 160.32,336.42
X$43180 VSS \$23677 \$23540 \$24464 \$23108 VDD sg13g2_dfrbpq_1
* cell instance $43181 m0 *1 132.96,64.26
X$43181 VSS \$2614 \$3117 \$3033 \$3162 VDD sg13g2_dfrbpq_1
* cell instance $43182 m0 *1 149.28,351.54
X$43182 VSS \$24057 \$25003 \$25254 \$23108 VDD sg13g2_dfrbpq_1
* cell instance $43183 m0 *1 326.4,26.46
X$43183 VSS \$419 \$802 \$823 \$99 VDD sg13g2_dfrbpq_1
* cell instance $43184 m0 *1 288,328.86
X$43184 VSS \$22589 \$23557 \$23838 \$22724 VDD sg13g2_dfrbpq_1
* cell instance $43185 m0 *1 297.12,41.58
X$43185 VSS \$1462 \$1497 \$1801 \$98 VDD sg13g2_dfrbpq_1
* cell instance $43186 m0 *1 301.92,275.94
X$43186 VSS \$19477 \$18819 \$20360 \$19691 VDD sg13g2_dfrbpq_1
* cell instance $43187 m0 *1 160.8,343.98
X$43187 VSS \$23677 \$23630 \$23826 \$23108 VDD sg13g2_dfrbpq_1
* cell instance $43188 m0 *1 157.92,86.94
X$43188 VSS \$3721 \$4335 \$3598 \$2900 VDD sg13g2_dfrbpq_1
* cell instance $43189 m0 *1 149.76,94.5
X$43189 VSS \$3721 \$5164 \$2613 \$3162 VDD sg13g2_dfrbpq_1
* cell instance $43190 m0 *1 148.8,71.82
X$43190 VSS \$2614 \$3313 \$2678 \$2900 VDD sg13g2_dfrbpq_1
* cell instance $43191 m0 *1 108,321.3
X$43191 VSS \$22481 \$23819 \$23664 \$21825 VDD sg13g2_dfrbpq_1
* cell instance $43192 m0 *1 156,56.7
X$43192 VSS \$2614 \$2617 \$2563 \$83 VDD sg13g2_dfrbpq_1
* cell instance $43193 m0 *1 287.52,26.46
X$43193 VSS \$164 \$633 \$1787 \$304 VDD sg13g2_dfrbpq_1
* cell instance $43194 m0 *1 60.96,336.42
X$43194 VSS \$23652 \$23092 \$24433 \$23087 VDD sg13g2_dfrbpq_1
* cell instance $43195 m0 *1 60.96,321.3
X$43195 VSS \$22562 \$22862 \$22367 \$23087 VDD sg13g2_dfrbpq_1
* cell instance $43196 m0 *1 87.36,132.3
X$43196 VSS \$6763 \$8425 \$7321 \$5612 VDD sg13g2_dfrbpq_1
* cell instance $43197 m0 *1 90.24,49.14
X$43197 VSS \$1411 \$1393 \$762 \$1412 VDD sg13g2_dfrbpq_1
* cell instance $43198 m0 *1 75.84,343.98
X$43198 VSS \$23096 \$24588 \$24949 \$22565 VDD sg13g2_dfrbpq_1
* cell instance $43199 m0 *1 90.24,34.02
X$43199 VSS \$534 \$28 \$267 \$149 VDD sg13g2_dfrbpq_1
* cell instance $43200 m0 *1 91.68,94.5
X$43200 VSS \$6154 \$5154 \$4277 \$3156 VDD sg13g2_dfrbpq_1
* cell instance $43201 m0 *1 97.44,328.86
X$43201 VSS \$23499 \$23988 \$23815 \$21825 VDD sg13g2_dfrbpq_1
* cell instance $43202 m0 *1 127.68,117.18
X$43202 VSS \$6154 \$7128 \$7344 \$5380 VDD sg13g2_dfrbpq_1
* cell instance $43203 m0 *1 90.72,26.46
X$43203 VSS \$73 \$316 \$105 \$149 VDD sg13g2_dfrbpq_1
* cell instance $43204 m0 *1 125.28,343.98
X$43204 VSS \$23530 \$24828 \$24384 \$23104 VDD sg13g2_dfrbpq_1
* cell instance $43205 m0 *1 151.2,321.3
X$43205 VSS \$23009 \$22948 \$23917 \$21830 VDD sg13g2_dfrbpq_1
* cell instance $43206 m0 *1 252,109.62
X$43206 VSS \$5413 \$5404 \$4565 \$6443 VDD sg13g2_dfrbpq_1
* cell instance $43207 m0 *1 115.68,162.54
X$43207 VSS \$9107 \$10286 \$9792 \$9809 VDD sg13g2_dfrbpq_1
* cell instance $43208 m0 *1 154.08,162.54
X$43208 VSS \$10465 \$8430 \$8121 \$9114 VDD sg13g2_dfrbpq_1
* cell instance $43209 m0 *1 90.24,102.06
X$43209 VSS \$4987 \$4853 \$3884 \$5612 VDD sg13g2_dfrbpq_1
* cell instance $43210 m0 *1 141.12,162.54
X$43210 VSS \$10465 \$8883 \$8950 \$9809 VDD sg13g2_dfrbpq_1
* cell instance $43211 m0 *1 107.04,177.66
X$43211 VSS \$9107 \$10275 \$9501 \$9809 VDD sg13g2_dfrbpq_1
* cell instance $43212 m0 *1 134.4,177.66
X$43212 VSS \$10465 \$11695 \$11853 \$9809 VDD sg13g2_dfrbpq_1
* cell instance $43213 m0 *1 90.24,56.7
X$43213 VSS \$2319 \$2038 \$1181 \$1412 VDD sg13g2_dfrbpq_1
* cell instance $43214 m0 *1 134.88,132.3
X$43214 VSS \$7346 \$7171 \$6250 \$5380 VDD sg13g2_dfrbpq_1
* cell instance $43215 m0 *1 85.92,71.82
X$43215 VSS \$3490 \$3493 \$2601 \$3156 VDD sg13g2_dfrbpq_1
* cell instance $43216 m0 *1 155.52,177.66
X$43216 VSS \$10465 \$10287 \$9792 \$11472 VDD sg13g2_dfrbpq_1
* cell instance $43217 m0 *1 167.04,162.54
X$43217 VSS \$10865 \$10467 \$9106 \$9114 VDD sg13g2_dfrbpq_1
* cell instance $43218 m0 *1 123.84,321.3
X$43218 VSS \$22667 \$21507 \$23102 \$23104 VDD sg13g2_dfrbpq_1
* cell instance $43219 m0 *1 90.24,86.94
X$43219 VSS \$4287 \$3882 \$3286 \$3156 VDD sg13g2_dfrbpq_1
* cell instance $43220 m0 *1 105.6,147.42
X$43220 VSS \$9259 \$9814 \$9457 \$6281 VDD sg13g2_dfrbpq_1
* cell instance $43221 m0 *1 139.68,343.98
X$43221 VSS \$24057 \$24750 \$23825 \$21830 VDD sg13g2_dfrbpq_1
* cell instance $43222 m0 *1 68.64,328.86
X$43222 VSS \$23652 \$23779 \$23523 \$19978 VDD sg13g2_dfrbpq_1
* cell instance $43223 m0 *1 90.24,162.54
X$43223 VSS \$10452 \$9612 \$8412 \$9541 VDD sg13g2_dfrbpq_1
* cell instance $43224 m0 *1 90.24,79.38
X$43224 VSS \$4287 \$3280 \$2036 \$3156 VDD sg13g2_dfrbpq_1
* cell instance $43225 m0 *1 272.16,18.9
X$43225 VSS \$395 \$333 \$33 \$304 VDD sg13g2_dfrbpq_1
* cell instance $43226 m0 *1 62.4,351.54
X$43226 VSS \$23652 \$25084 \$22917 \$23087 VDD sg13g2_dfrbpq_1
* cell instance $43227 m0 *1 62.88,343.98
X$43227 VSS \$23096 \$23090 \$24995 \$23087 VDD sg13g2_dfrbpq_1
* cell instance $43228 m0 *1 278.4,49.14
X$43228 VSS \$97 \$2136 \$2149 \$247 VDD sg13g2_dfrbpq_1
* cell instance $43229 m0 *1 90.24,147.42
X$43229 VSS \$9252 \$8084 \$7800 \$9541 VDD sg13g2_dfrbpq_1
* cell instance $43230 m0 *1 274.08,26.46
X$43230 VSS \$395 \$836 \$790 \$304 VDD sg13g2_dfrbpq_1
* cell instance $43231 m0 *1 284.16,41.58
X$43231 VSS \$1462 \$1708 \$1810 \$304 VDD sg13g2_dfrbpq_1
* cell instance $43232 m0 *1 323.04,41.58
X$43232 VSS \$1213 \$1482 \$1695 \$1684 VDD sg13g2_dfrbpq_1
* cell instance $43233 m0 *1 130.56,71.82
X$43233 VSS \$2337 \$2329 \$1667 \$3162 VDD sg13g2_dfrbpq_1
* cell instance $43234 m0 *1 285.12,18.9
X$43234 VSS \$164 \$326 \$11 \$304 VDD sg13g2_dfrbpq_1
* cell instance $43235 m0 *1 129.6,94.5
X$43235 VSS \$2337 \$5007 \$3703 \$3162 VDD sg13g2_dfrbpq_1
* cell instance $43236 m0 *1 90.24,124.74
X$43236 VSS \$7340 \$7671 \$5356 \$5612 VDD sg13g2_dfrbpq_1
* cell instance $43237 m0 *1 128.16,56.7
X$43237 VSS \$2337 \$1304 \$764 \$75 VDD sg13g2_dfrbpq_1
* cell instance $43238 m0 *1 292.32,34.02
X$43238 VSS \$1462 \$1232 \$1237 \$304 VDD sg13g2_dfrbpq_1
* cell instance $43239 m0 *1 48.96,351.54
X$43239 VSS \$23002 \$23907 \$24981 \$23087 VDD sg13g2_dfrbpq_1
* cell instance $43240 m0 *1 81.12,223.02
X$43240 VSS \$15547 \$14884 \$15591 \$14322 VDD sg13g2_dfrbpq_1
* cell instance $43241 m0 *1 49.92,343.98
X$43241 VSS \$23652 \$23082 \$23439 \$23087 VDD sg13g2_dfrbpq_1
* cell instance $43242 m0 *1 291.36,49.14
X$43242 VSS \$97 \$2130 \$2134 \$98 VDD sg13g2_dfrbpq_1
* cell instance $43243 m0 *1 137.76,275.94
X$43243 VSS \$19663 \$19419 \$20300 \$19658 VDD sg13g2_dfrbpq_1
* cell instance $43244 m0 *1 139.2,291.06
X$43244 VSS \$21696 \$20758 \$20223 \$20447 VDD sg13g2_dfrbpq_1
* cell instance $43245 m0 *1 90.24,177.66
X$43245 VSS \$10452 \$10272 \$9439 \$9541 VDD sg13g2_dfrbpq_1
* cell instance $43246 m0 *1 337.92,41.58
X$43246 VSS \$1792 \$1685 \$1688 \$99 VDD sg13g2_dfrbpq_1
* cell instance $43247 m0 *1 235.68,336.42
X$43247 VSS \$23451 \$24077 \$24507 \$23122 VDD sg13g2_dfrbpq_1
* cell instance $43248 m0 *1 90.24,154.98
X$43248 VSS \$9801 \$9092 \$7938 \$9541 VDD sg13g2_dfrbpq_1
* cell instance $43249 m0 *1 118.56,147.42
X$43249 VSS \$9259 \$7333 \$6731 \$6281 VDD sg13g2_dfrbpq_1
* cell instance $43250 m0 *1 300,56.7
X$43250 VSS \$2393 \$2633 \$2390 \$1684 VDD sg13g2_dfrbpq_1
* cell instance $43251 m0 *1 296.64,64.26
X$43251 VSS \$1468 \$3098 \$2404 \$2914 VDD sg13g2_dfrbpq_1
* cell instance $43252 m0 *1 300,71.82
X$43252 VSS \$419 \$3575 \$4631 \$2914 VDD sg13g2_dfrbpq_1
* cell instance $43253 m0 *1 337.92,268.38
X$43253 VSS \$19477 \$19487 \$19481 \$19691 VDD sg13g2_dfrbpq_1
* cell instance $43254 m0 *1 130.56,298.62
X$43254 VSS \$21696 \$20414 \$21985 \$19658 VDD sg13g2_dfrbpq_1
* cell instance $43255 m0 *1 93.12,41.58
X$43255 VSS \$976 \$1723 \$1719 \$75 VDD sg13g2_dfrbpq_1
* cell instance $43256 m0 *1 94.56,109.62
X$43256 VSS \$6154 \$6412 \$6250 \$6281 VDD sg13g2_dfrbpq_1
* cell instance $43257 m0 *1 134.88,79.38
X$43257 VSS \$3721 \$3902 \$2953 \$3162 VDD sg13g2_dfrbpq_1
* cell instance $43258 m0 *1 335.04,238.14
X$43258 VSS \$15567 \$15088 \$15749 \$15972 VDD sg13g2_dfrbpq_1
* cell instance $43259 m0 *1 337.92,18.9
X$43259 VSS \$252 \$290 \$287 \$99 VDD sg13g2_dfrbpq_1
* cell instance $43260 m0 *1 335.04,253.26
X$43260 VSS \$17917 \$16912 \$18318 \$15972 VDD sg13g2_dfrbpq_1
* cell instance $43261 r0 *1 341.28,253.26
X$43261 \$17705 VDD VSS sg13g2_tiehi
* cell instance $43262 m0 *1 322.08,253.26
X$43262 VSS \$17917 \$17120 \$18340 \$15972 VDD sg13g2_dfrbpq_1
* cell instance $43263 m0 *1 333.12,245.7
X$43263 VSS \$17917 \$17128 \$17487 \$15972 VDD sg13g2_dfrbpq_1
* cell instance $43264 m0 *1 147.84,64.26
X$43264 VSS \$2614 \$1862 \$970 \$2900 VDD sg13g2_dfrbpq_1
* cell instance $43265 m0 *1 334.08,343.98
X$43265 VSS \$24627 \$24778 \$24858 \$22192 VDD sg13g2_dfrbpq_1
* cell instance $43266 m0 *1 77.28,215.46
X$43266 VSS \$14202 \$13720 \$14269 \$14322 VDD sg13g2_dfrbpq_1
* cell instance $43267 m0 *1 100.8,170.1
X$43267 VSS \$10865 \$9251 \$7025 \$9809 VDD sg13g2_dfrbpq_1
* cell instance $43268 m0 *1 138.24,313.74
X$43268 VSS \$22264 \$22945 \$23409 \$22121 VDD sg13g2_dfrbpq_1
* cell instance $43269 m0 *1 337.92,34.02
X$43269 VSS \$1026 \$999 \$1216 \$99 VDD sg13g2_dfrbpq_1
* cell instance $43270 m0 *1 90.24,64.26
X$43270 VSS \$2319 \$2311 \$1662 \$3156 VDD sg13g2_dfrbpq_1
* cell instance $43271 m0 *1 128.16,49.14
X$43271 VSS \$976 \$1867 \$959 \$79 VDD sg13g2_dfrbpq_1
* cell instance $43272 m0 *1 133.92,336.42
X$43272 VSS \$24057 \$23674 \$23822 \$23104 VDD sg13g2_dfrbpq_1
* cell instance $43273 m0 *1 90.24,139.86
X$43273 VSS \$9252 \$8878 \$7308 \$5612 VDD sg13g2_dfrbpq_1
* cell instance $43274 m0 *1 45.6,291.06
X$43274 VSS \$20742 \$21598 \$21300 \$19646 VDD sg13g2_dfrbpq_1
* cell instance $43275 r0 *1 89.28,79.38
X$43275 VSS \$4287 \$3886 \$2196 \$3156 VDD sg13g2_dfrbpq_1
* cell instance $43276 r0 *1 90.24,154.98
X$43276 VSS \$10452 \$9249 \$5969 \$9541 VDD sg13g2_dfrbpq_1
* cell instance $43277 r0 *1 189.6,26.46
X$43277 VSS \$470 \$85 \$709 \$918 VDD sg13g2_dfrbpq_1
* cell instance $43278 r0 *1 299.52,162.54
X$43278 VSS \$10506 \$10063 \$8617 \$9327 VDD sg13g2_dfrbpq_1
* cell instance $43279 r0 *1 231.84,154.98
X$43279 VSS \$9283 \$10173 \$10171 \$9284 VDD sg13g2_dfrbpq_1
* cell instance $43280 r0 *1 84,162.54
X$43280 VSS \$9801 \$11088 \$10765 \$9541 VDD sg13g2_dfrbpq_1
* cell instance $43281 r0 *1 294.24,245.7
X$43281 VSS \$15693 \$16915 \$17692 \$16160 VDD sg13g2_dfrbpq_1
* cell instance $43282 r0 *1 16.8,117.18
X$43282 VSS \$7307 \$7323 \$6576 \$5916 VDD sg13g2_dfrbpq_1
* cell instance $43283 r0 *1 206.88,207.9
X$43283 VSS \$12221 \$14223 \$14612 \$12538 VDD sg13g2_dfrbpq_1
* cell instance $43284 r0 *1 204.48,18.9
X$43284 VSS \$470 \$887 \$497 \$95 VDD sg13g2_dfrbpq_1
* cell instance $43285 r0 *1 300.96,177.66
X$43285 VSS \$12060 \$11276 \$10476 \$9327 VDD sg13g2_dfrbpq_1
* cell instance $43286 r0 *1 26.4,283.5
X$43286 VSS \$20804 \$20991 \$20910 \$19646 VDD sg13g2_dfrbpq_1
* cell instance $43287 r0 *1 13.44,94.5
X$43287 VSS \$4974 \$5708 \$5356 \$3151 VDD sg13g2_dfrbpq_1
* cell instance $43288 r0 *1 235.2,147.42
X$43288 VSS \$9283 \$8006 \$7039 \$9284 VDD sg13g2_dfrbpq_1
* cell instance $43289 r0 *1 195.36,132.3
X$43289 VSS \$6790 \$8007 \$7039 \$5631 VDD sg13g2_dfrbpq_1
* cell instance $43290 r0 *1 189.12,41.58
X$43290 VSS \$1678 \$277 \$204 \$918 VDD sg13g2_dfrbpq_1
* cell instance $43291 r0 *1 93.12,34.02
X$43291 VSS \$976 \$450 \$766 \$75 VDD sg13g2_dfrbpq_1
* cell instance $43292 r0 *1 49.92,94.5
X$43292 VSS \$3147 \$4979 \$3679 \$3151 VDD sg13g2_dfrbpq_1
* cell instance $43293 r0 *1 207.84,56.7
X$43293 VSS \$2743 \$2227 \$981 \$918 VDD sg13g2_dfrbpq_1
* cell instance $43294 r0 *1 84.96,86.94
X$43294 VSS \$4287 \$3148 \$2304 \$3156 VDD sg13g2_dfrbpq_1
* cell instance $43295 r0 *1 337.92,177.66
X$43295 VSS \$10506 \$11721 \$11044 \$9327 VDD sg13g2_dfrbpq_1
* cell instance $43296 r0 *1 323.52,162.54
X$43296 VSS \$7052 \$10070 \$8793 \$9327 VDD sg13g2_dfrbpq_1
* cell instance $43297 r0 *1 296.16,200.34
X$43297 VSS \$13617 \$13603 \$13732 \$12554 VDD sg13g2_dfrbpq_1
* cell instance $43298 r0 *1 32.64,321.3
X$43298 VSS \$23517 \$23371 \$23438 \$21534 VDD sg13g2_dfrbpq_1
* cell instance $43299 r0 *1 173.76,109.62
X$43299 VSS \$5389 \$6428 \$5516 \$5631 VDD sg13g2_dfrbpq_1
* cell instance $43300 r0 *1 206.4,238.14
X$43300 VSS \$15947 \$16963 \$17388 \$14809 VDD sg13g2_dfrbpq_1
* cell instance $43301 r0 *1 102.24,230.58
X$43301 VSS \$15003 \$16132 \$16700 \$12633 VDD sg13g2_dfrbpq_1
* cell instance $43302 r0 *1 10.08,109.62
X$43302 VSS \$4974 \$6853 \$6740 \$5916 VDD sg13g2_dfrbpq_1
* cell instance $43303 r0 *1 10.08,154.98
X$43303 VSS \$10271 \$10528 \$10758 \$8551 VDD sg13g2_dfrbpq_1
* cell instance $43304 r0 *1 10.08,147.42
X$43304 VSS \$9097 \$9609 \$9779 \$8551 VDD sg13g2_dfrbpq_1
* cell instance $43305 r0 *1 29.76,230.58
X$43305 VSS \$15633 \$15920 \$16122 \$15624 VDD sg13g2_dfrbpq_1
* cell instance $43306 r0 *1 90.24,49.14
X$43306 VSS \$2319 \$2206 \$1667 \$1412 VDD sg13g2_dfrbpq_1
* cell instance $43307 r0 *1 88.32,26.46
X$43307 VSS \$69 \$1078 \$959 \$149 VDD sg13g2_dfrbpq_1
* cell instance $43308 r0 *1 24.48,306.18
X$43308 VSS \$21530 \$22903 \$22750 \$21534 VDD sg13g2_dfrbpq_1
* cell instance $43309 r0 *1 35.52,328.86
X$43309 VSS \$24040 \$24301 \$23212 \$23087 VDD sg13g2_dfrbpq_1
* cell instance $43310 r0 *1 300.96,283.5
X$43310 VSS \$19514 \$20687 \$20793 \$19691 VDD sg13g2_dfrbpq_1
* cell instance $43311 r0 *1 172.8,71.82
X$43311 VSS \$3721 \$3724 \$3033 \$2900 VDD sg13g2_dfrbpq_1
* cell instance $43312 r0 *1 197.76,102.06
X$43312 VSS \$5634 \$4616 \$3598 \$6432 VDD sg13g2_dfrbpq_1
* cell instance $43313 r0 *1 83.04,11.34
X$43313 VSS \$73 \$40 \$154 \$149 VDD sg13g2_dfrbpq_1
* cell instance $43314 r0 *1 191.04,117.18
X$43314 VSS \$7362 \$6331 \$4614 \$5631 VDD sg13g2_dfrbpq_1
* cell instance $43315 r0 *1 317.28,139.86
X$43315 VSS \$8660 \$9139 \$9147 \$7721 VDD sg13g2_dfrbpq_1
* cell instance $43316 r0 *1 174.24,162.54
X$43316 VSS \$10302 \$11004 \$9630 \$9114 VDD sg13g2_dfrbpq_1
* cell instance $43317 r0 *1 180,124.74
X$43317 VSS \$7362 \$8004 \$8225 \$5631 VDD sg13g2_dfrbpq_1
* cell instance $43318 r0 *1 28.8,245.7
X$43318 VSS \$17640 \$17781 \$19170 \$15624 VDD sg13g2_dfrbpq_1
* cell instance $43319 r0 *1 90.24,94.5
X$43319 VSS \$4987 \$4983 \$3476 \$3156 VDD sg13g2_dfrbpq_1
* cell instance $43320 r0 *1 182.88,343.98
X$43320 VSS \$23120 \$25164 \$24918 \$23122 VDD sg13g2_dfrbpq_1
* cell instance $43321 r0 *1 174.24,306.18
X$43321 VSS \$22678 \$21936 \$21042 \$22121 VDD sg13g2_dfrbpq_1
* cell instance $43322 r0 *1 10.08,245.7
X$43322 VSS \$17640 \$17767 \$17639 \$15624 VDD sg13g2_dfrbpq_1
* cell instance $43323 r0 *1 176.16,41.58
X$43323 VSS \$1678 \$988 \$74 \$918 VDD sg13g2_dfrbpq_1
* cell instance $43324 r0 *1 10.08,124.74
X$43324 VSS \$7307 \$8065 \$7938 \$5916 VDD sg13g2_dfrbpq_1
* cell instance $43325 r0 *1 206.4,41.58
X$43325 VSS \$470 \$3 \$78 \$95 VDD sg13g2_dfrbpq_1
* cell instance $43326 r0 *1 90.24,109.62
X$43326 VSS \$6763 \$6135 \$4598 \$5612 VDD sg13g2_dfrbpq_1
* cell instance $43327 r0 *1 10.08,132.3
X$43327 VSS \$7307 \$8676 \$8412 \$8551 VDD sg13g2_dfrbpq_1
* cell instance $43328 r0 *1 90.24,117.18
X$43328 VSS \$7163 \$7318 \$6142 \$5612 VDD sg13g2_dfrbpq_1
* cell instance $43329 r0 *1 176.64,26.46
X$43329 VSS \$470 \$280 \$328 \$918 VDD sg13g2_dfrbpq_1
* cell instance $43330 r0 *1 180,336.42
X$43330 VSS \$23677 \$24389 \$24388 \$23545 VDD sg13g2_dfrbpq_1
* cell instance $43331 r0 *1 88.32,147.42
X$43331 VSS \$9259 \$10046 \$10102 \$9541 VDD sg13g2_dfrbpq_1
* cell instance $43332 r0 *1 283.68,147.42
X$43332 VSS \$9838 \$9853 \$8793 \$8183 VDD sg13g2_dfrbpq_1
* cell instance $43333 r0 *1 255.36,200.34
X$43333 VSS \$13700 \$13066 \$13560 \$12538 VDD sg13g2_dfrbpq_1
* cell instance $43334 r0 *1 174.72,94.5
X$43334 VSS \$3326 \$3712 \$2953 \$3725 VDD sg13g2_dfrbpq_1
* cell instance $43335 r0 *1 182.88,185.22
X$43335 VSS \$11875 \$12222 \$12667 \$9827 VDD sg13g2_dfrbpq_1
* cell instance $43336 r0 *1 208.32,132.3
X$43336 VSS \$6790 \$8616 \$8861 \$5631 VDD sg13g2_dfrbpq_1
* cell instance $43337 r0 *1 338.4,230.58
X$43337 VSS \$15567 \$15707 \$16392 \$15972 VDD sg13g2_dfrbpq_1
* cell instance $43338 r0 *1 213.6,124.74
X$43338 VSS \$7362 \$6427 \$5516 \$6432 VDD sg13g2_dfrbpq_1
* cell instance $43339 r0 *1 176.64,132.3
X$43339 VSS \$7362 \$7133 \$4022 \$5631 VDD sg13g2_dfrbpq_1
* cell instance $43340 r0 *1 170.88,321.3
X$43340 VSS \$22120 \$23828 \$23119 \$22575 VDD sg13g2_dfrbpq_1
* cell instance $43341 r0 *1 187.68,230.58
X$43341 VSS \$15947 \$15951 \$16212 \$14809 VDD sg13g2_dfrbpq_1
* cell instance $43342 r0 *1 285.6,162.54
X$43342 VSS \$9838 \$9470 \$8861 \$8183 VDD sg13g2_dfrbpq_1
* cell instance $43343 r0 *1 84,102.06
X$43343 VSS \$6266 \$5353 \$2731 \$4275 VDD sg13g2_dfrbpq_1
* cell instance $43344 r0 *1 337.92,238.14
X$43344 VSS \$17138 \$17143 \$17145 \$15972 VDD sg13g2_dfrbpq_1
* cell instance $43345 r0 *1 90.24,177.66
X$43345 VSS \$11567 \$10973 \$9779 \$9541 VDD sg13g2_dfrbpq_1
* cell instance $43346 r0 *1 180,238.14
X$43346 VSS \$15947 \$16800 \$17056 \$14809 VDD sg13g2_dfrbpq_1
* cell instance $43347 r0 *1 183.36,147.42
X$43347 VSS \$9117 \$9822 \$8435 \$9114 VDD sg13g2_dfrbpq_1
* cell instance $43348 r0 *1 95.52,132.3
X$43348 VSS \$7340 \$8570 \$7992 \$6281 VDD sg13g2_dfrbpq_1
* cell instance $43349 r0 *1 122.88,275.94
X$43349 VSS \$19413 \$18945 \$17508 \$19658 VDD sg13g2_dfrbpq_1
* cell instance $43350 r0 *1 89.76,71.82
X$43350 VSS \$3490 \$4786 \$3703 \$3156 VDD sg13g2_dfrbpq_1
* cell instance $43351 r0 *1 45.6,56.7
X$43351 VSS \$2310 \$2723 \$2601 \$1384 VDD sg13g2_dfrbpq_1
* cell instance $43352 r0 *1 10.08,49.14
X$43352 VSS \$2197 \$2408 \$2196 \$1384 VDD sg13g2_dfrbpq_1
* cell instance $43353 r0 *1 77.28,49.14
X$43353 VSS \$1411 \$1400 \$264 \$1412 VDD sg13g2_dfrbpq_1
* cell instance $43354 r0 *1 90.24,170.1
X$43354 VSS \$9801 \$9786 \$9088 \$9541 VDD sg13g2_dfrbpq_1
* cell instance $43355 r0 *1 62.88,94.5
X$43355 VSS \$3490 \$5362 \$4977 \$4275 VDD sg13g2_dfrbpq_1
* cell instance $43356 r0 *1 133.44,94.5
X$43356 VSS \$5389 \$6184 \$5516 \$3162 VDD sg13g2_dfrbpq_1
* cell instance $43357 r0 *1 44.64,71.82
X$43357 VSS \$2310 \$4019 \$2304 \$3151 VDD sg13g2_dfrbpq_1
* cell instance $43358 r0 *1 90.24,41.58
X$43358 VSS \$1411 \$1387 \$446 \$1412 VDD sg13g2_dfrbpq_1
* cell instance $43359 r0 *1 136.8,117.18
X$43359 VSS \$7346 \$7175 \$4022 \$5380 VDD sg13g2_dfrbpq_1
* cell instance $43360 r0 *1 168.96,230.58
X$43360 VSS \$17050 \$15944 \$16297 \$13170 VDD sg13g2_dfrbpq_1
* cell instance $43361 r0 *1 176.16,291.06
X$43361 VSS \$20762 \$21441 \$21249 \$20924 VDD sg13g2_dfrbpq_1
* cell instance $43362 r0 *1 264.48,11.34
X$43362 VSS \$395 \$12 \$125 \$304 VDD sg13g2_dfrbpq_1
* cell instance $43363 r0 *1 95.04,56.7
X$43363 VSS \$2611 \$3500 \$2953 \$75 VDD sg13g2_dfrbpq_1
* cell instance $43364 r0 *1 270.72,147.42
X$43364 VSS \$9838 \$8021 \$8269 \$8183 VDD sg13g2_dfrbpq_1
* cell instance $43365 r0 *1 261.12,26.46
X$43365 VSS \$395 \$846 \$926 \$247 VDD sg13g2_dfrbpq_1
* cell instance $43366 r0 *1 267.36,177.66
X$43366 VSS \$12313 \$12054 \$11939 \$8183 VDD sg13g2_dfrbpq_1
* cell instance $43367 r0 *1 252,94.5
X$43367 VSS \$5751 \$6122 \$5180 \$3177 VDD sg13g2_dfrbpq_1
* cell instance $43368 r0 *1 262.56,64.26
X$43368 VSS \$419 \$3810 \$3825 \$2389 VDD sg13g2_dfrbpq_1
* cell instance $43369 r0 *1 324.48,94.5
X$43369 VSS \$5046 \$5430 \$5438 \$2916 VDD sg13g2_dfrbpq_1
* cell instance $43370 r0 *1 269.28,18.9
X$43370 VSS \$395 \$155 \$94 \$304 VDD sg13g2_dfrbpq_1
* cell instance $43371 r0 *1 137.76,177.66
X$43371 VSS \$10465 \$10640 \$9622 \$9809 VDD sg13g2_dfrbpq_1
* cell instance $43372 r0 *1 132,109.62
X$43372 VSS \$6774 \$5263 \$4277 \$5380 VDD sg13g2_dfrbpq_1
* cell instance $43373 r0 *1 260.16,71.82
X$43373 VSS \$2386 \$3819 \$3735 \$2389 VDD sg13g2_dfrbpq_1
* cell instance $43374 r0 *1 126.72,139.86
X$43374 VSS \$9107 \$10290 \$9106 \$6281 VDD sg13g2_dfrbpq_1
* cell instance $43375 r0 *1 209.76,94.5
X$43375 VSS \$6196 \$5407 \$5402 \$3725 VDD sg13g2_dfrbpq_1
* cell instance $43376 r0 *1 178.56,260.82
X$43376 VSS \$19666 \$19427 \$19665 \$14809 VDD sg13g2_dfrbpq_1
* cell instance $43377 r0 *1 264,124.74
X$43377 VSS \$7826 \$7578 \$6986 \$6443 VDD sg13g2_dfrbpq_1
* cell instance $43378 r0 *1 195.84,343.98
X$43378 VSS \$23120 \$24027 \$24920 \$23122 VDD sg13g2_dfrbpq_1
* cell instance $43379 r0 *1 274.56,185.22
X$43379 VSS \$12313 \$12278 \$12547 \$12554 VDD sg13g2_dfrbpq_1
* cell instance $43380 r0 *1 204,336.42
X$43380 VSS \$23117 \$23893 \$24494 \$24698 VDD sg13g2_dfrbpq_1
* cell instance $43381 r0 *1 276.96,200.34
X$43381 VSS \$12313 \$13598 \$13088 \$12554 VDD sg13g2_dfrbpq_1
* cell instance $43382 r0 *1 142.08,343.98
X$43382 VSS \$24057 \$23445 \$24902 \$21830 VDD sg13g2_dfrbpq_1
* cell instance $43383 r0 *1 337.92,18.9
X$43383 VSS \$1026 \$797 \$373 \$99 VDD sg13g2_dfrbpq_1
* cell instance $43384 r0 *1 194.4,321.3
X$43384 VSS \$23117 \$21724 \$22682 \$23545 VDD sg13g2_dfrbpq_1
* cell instance $43385 r0 *1 146.88,298.62
X$43385 VSS \$22264 \$21812 \$22260 \$20447 VDD sg13g2_dfrbpq_1
* cell instance $43386 r0 *1 143.04,306.18
X$43386 VSS \$21696 \$20920 \$18790 \$21830 VDD sg13g2_dfrbpq_1
* cell instance $43387 r0 *1 9.6,321.3
X$43387 VSS \$21530 \$23516 \$23464 \$21534 VDD sg13g2_dfrbpq_1
* cell instance $43388 r0 *1 190.56,79.38
X$43388 VSS \$3326 \$4347 \$3321 \$3725 VDD sg13g2_dfrbpq_1
* cell instance $43389 r0 *1 109.44,94.5
X$43389 VSS \$4174 \$5157 \$4549 \$5380 VDD sg13g2_dfrbpq_1
* cell instance $43390 r0 *1 148.8,94.5
X$43390 VSS \$5389 \$5391 \$5390 \$3162 VDD sg13g2_dfrbpq_1
* cell instance $43391 r0 *1 50.88,11.34
X$43391 VSS \$69 \$230 \$105 \$149 VDD sg13g2_dfrbpq_1
* cell instance $43392 r0 *1 64.32,11.34
X$43392 VDD VSS \$28 \$70 \$180 sg13g2_nor2_1
* cell instance $43393 r0 *1 62.4,64.26
X$43393 VSS \$2319 \$4296 \$3152 \$1412 VDD sg13g2_dfrbpq_1
* cell instance $43394 r0 *1 57.6,71.82
X$43394 VSS \$3490 \$3783 \$3289 \$3151 VDD sg13g2_dfrbpq_1
* cell instance $43395 r0 *1 50.4,41.58
X$43395 VSS \$897 \$1753 \$1181 \$226 VDD sg13g2_dfrbpq_1
* cell instance $43396 r0 *1 50.4,34.02
X$43396 VSS \$897 \$1392 \$762 \$149 VDD sg13g2_dfrbpq_1
* cell instance $43397 r0 *1 50.4,26.46
X$43397 VSS \$897 \$1047 \$264 \$149 VDD sg13g2_dfrbpq_1
* cell instance $43398 r0 *1 180.48,298.62
X$43398 VSS \$20762 \$22126 \$22280 \$20924 VDD sg13g2_dfrbpq_1
* cell instance $43399 r0 *1 50.4,86.94
X$43399 VSS \$3291 \$4764 \$3884 \$3151 VDD sg13g2_dfrbpq_1
* cell instance $43400 r0 *1 9.6,328.86
X$43400 VSS \$21530 \$22447 \$23515 \$24039 VDD sg13g2_dfrbpq_1
* cell instance $43401 r0 *1 51.36,18.9
X$43401 VSS \$69 \$70 \$267 \$149 VDD sg13g2_dfrbpq_1
* cell instance $43402 r0 *1 63.84,49.14
X$43402 VSS \$1411 \$1844 \$1292 \$1412 VDD sg13g2_dfrbpq_1
* cell instance $43403 r0 *1 50.4,49.14
X$43403 VSS \$2310 \$2201 \$1382 \$226 VDD sg13g2_dfrbpq_1
* cell instance $43404 r0 *1 49.44,64.26
X$43404 VSS \$2310 \$3484 \$2196 \$3151 VDD sg13g2_dfrbpq_1
* cell instance $43405 r0 *1 50.4,79.38
X$43405 VSS \$3147 \$4430 \$3476 \$3151 VDD sg13g2_dfrbpq_1
* cell instance $43406 r0 *1 69.6,79.38
X$43406 VSS \$3490 \$4284 \$4549 \$4275 VDD sg13g2_dfrbpq_1
* cell instance $43407 r0 *1 305.28,117.18
X$43407 VSS \$1032 \$5875 \$5088 \$5681 VDD sg13g2_dfrbpq_1
* cell instance $43408 r0 *1 192,56.7
X$43408 VSS \$2743 \$1873 \$909 \$918 VDD sg13g2_dfrbpq_1
* cell instance $43409 r0 *1 321.12,18.9
X$43409 VSS \$481 \$480 \$177 \$99 VDD sg13g2_dfrbpq_1
* cell instance $43410 r0 *1 311.52,170.1
X$43410 VSS \$10506 \$11515 \$11285 \$9327 VDD sg13g2_dfrbpq_1
* cell instance $43411 r0 *1 315.84,147.42
X$43411 VSS \$8660 \$9523 \$9513 \$7721 VDD sg13g2_dfrbpq_1
* cell instance $43412 r0 *1 315.84,109.62
X$43412 VSS \$794 \$4180 \$4359 \$5681 VDD sg13g2_dfrbpq_1
* cell instance $43413 r0 *1 189.12,306.18
X$43413 VSS \$22678 \$22400 \$22629 \$22575 VDD sg13g2_dfrbpq_1
* cell instance $43414 r0 *1 160.32,306.18
X$43414 VSS \$23009 \$21042 \$22118 \$22121 VDD sg13g2_dfrbpq_1
* cell instance $43415 r0 *1 56.64,132.3
X$43415 VSS \$7163 \$8560 \$6576 \$5612 VDD sg13g2_dfrbpq_1
* cell instance $43416 r0 *1 146.4,291.06
X$43416 VSS \$21696 \$21643 \$20518 \$20447 VDD sg13g2_dfrbpq_1
* cell instance $43417 r0 *1 157.92,162.54
X$43417 VSS \$10465 \$10835 \$11126 \$9114 VDD sg13g2_dfrbpq_1
* cell instance $43418 r0 *1 148.8,154.98
X$43418 VSS \$10465 \$10164 \$9457 \$9809 VDD sg13g2_dfrbpq_1
* cell instance $43419 r0 *1 196.8,154.98
X$43419 VSS \$10302 \$8603 \$7811 \$9114 VDD sg13g2_dfrbpq_1
* cell instance $43420 r0 *1 191.52,94.5
X$43420 VSS \$5634 \$5021 \$5841 \$3725 VDD sg13g2_dfrbpq_1
* cell instance $43421 r0 *1 334.56,154.98
X$43421 VSS \$8660 \$5917 \$10336 \$9327 VDD sg13g2_dfrbpq_1
* cell instance $43422 r0 *1 336.48,162.54
X$43422 VSS \$7052 \$9662 \$8820 \$9327 VDD sg13g2_dfrbpq_1
* cell instance $43423 r0 *1 330.72,170.1
X$43423 VSS \$10506 \$11788 \$11525 \$9327 VDD sg13g2_dfrbpq_1
* cell instance $43424 r0 *1 336,139.86
X$43424 VSS \$7052 \$8915 \$9169 \$7721 VDD sg13g2_dfrbpq_1
* cell instance $43425 r0 *1 73.92,124.74
X$43425 VSS \$6763 \$6754 \$4658 \$5612 VDD sg13g2_dfrbpq_1
* cell instance $43426 r0 *1 156.48,139.86
X$43426 VSS \$9108 \$8893 \$7811 \$9114 VDD sg13g2_dfrbpq_1
* cell instance $43427 r0 *1 79.2,132.3
X$43427 VSS \$6763 \$6757 \$6731 \$5612 VDD sg13g2_dfrbpq_1
* cell instance $43428 r0 *1 77.28,117.18
X$43428 VSS \$6763 \$7337 \$8129 \$5612 VDD sg13g2_dfrbpq_1
* cell instance $43429 r0 *1 65.76,109.62
X$43429 VSS \$4987 \$6914 \$6745 \$4275 VDD sg13g2_dfrbpq_1
* cell instance $43430 r0 *1 71.04,102.06
X$43430 VSS \$4987 \$5610 \$1376 \$4275 VDD sg13g2_dfrbpq_1
* cell instance $43431 r0 *1 158.88,177.66
X$43431 VSS \$12020 \$11762 \$12018 \$11472 VDD sg13g2_dfrbpq_1
* cell instance $43432 r0 *1 197.76,177.66
X$43432 VSS \$10302 \$10876 \$11147 \$9827 VDD sg13g2_dfrbpq_1
* cell instance $43433 r0 *1 212.16,64.26
X$43433 VSS \$2743 \$3662 \$3432 \$3725 VDD sg13g2_dfrbpq_1
* cell instance $43434 r0 *1 335.52,147.42
X$43434 VSS \$7052 \$7230 \$7778 \$9327 VDD sg13g2_dfrbpq_1
* cell instance $43435 r0 *1 309.12,94.5
X$43435 VSS \$794 \$5196 \$4639 \$2914 VDD sg13g2_dfrbpq_1
* cell instance $43436 r0 *1 230.88,94.5
X$43436 VSS \$5413 \$4349 \$3321 \$3177 VDD sg13g2_dfrbpq_1
* cell instance $43437 r0 *1 265.92,41.58
X$43437 VSS \$1008 \$1715 \$1914 \$247 VDD sg13g2_dfrbpq_1
* cell instance $43438 r0 *1 266.4,102.06
X$43438 VSS \$5514 \$5672 \$5088 \$4385 VDD sg13g2_dfrbpq_1
* cell instance $43439 r0 *1 134.4,147.42
X$43439 VSS \$9108 \$10007 \$9630 \$9809 VDD sg13g2_dfrbpq_1
* cell instance $43440 r0 *1 263.04,49.14
X$43440 VSS \$97 \$2853 \$2243 \$247 VDD sg13g2_dfrbpq_1
* cell instance $43441 r0 *1 337.44,94.5
X$43441 VSS \$5046 \$5906 \$5694 \$2916 VDD sg13g2_dfrbpq_1
* cell instance $43442 r0 *1 288.96,94.5
X$43442 VSS \$5514 \$3100 \$4366 \$4385 VDD sg13g2_dfrbpq_1
* cell instance $43443 r0 *1 276,94.5
X$43443 VSS \$5514 \$3955 \$4359 \$4385 VDD sg13g2_dfrbpq_1
* cell instance $43444 r0 *1 319.68,11.34
X$43444 VSS \$481 \$175 \$54 \$99 VDD sg13g2_dfrbpq_1
* cell instance $43445 m0 *1 332.64,18.9
X$43445 \$166 VDD VSS sg13g2_antennanp
* cell instance $43446 r0 *1 267.84,139.86
X$43446 VSS \$9838 \$9295 \$8237 \$8183 VDD sg13g2_dfrbpq_1
* cell instance $43447 r0 *1 261.12,162.54
X$43447 VSS \$10887 \$11026 \$10476 \$8183 VDD sg13g2_dfrbpq_1
* cell instance $43448 r0 *1 260.64,154.98
X$43448 VSS \$9838 \$9840 \$8617 \$8183 VDD sg13g2_dfrbpq_1
* cell instance $43449 r0 *1 314.4,102.06
X$43449 VSS \$794 \$5924 \$6273 \$5681 VDD sg13g2_dfrbpq_1
* cell instance $43450 r0 *1 101.28,343.98
X$43450 VSS \$23499 \$24994 \$24957 \$23104 VDD sg13g2_dfrbpq_1
* cell instance $43451 r0 *1 180.96,313.74
X$43451 VSS \$22678 \$23114 \$23291 \$22575 VDD sg13g2_dfrbpq_1
* cell instance $43452 r0 *1 271.68,170.1
X$43452 VSS \$9838 \$10309 \$10171 \$8183 VDD sg13g2_dfrbpq_1
* cell instance $43453 r0 *1 271.68,34.02
X$43453 VSS \$97 \$1207 \$1916 \$247 VDD sg13g2_dfrbpq_1
* cell instance $43454 r0 *1 182.88,64.26
X$43454 VSS \$2743 \$2221 \$1184 \$3725 VDD sg13g2_dfrbpq_1
* cell instance $43455 r0 *1 52.8,109.62
X$43455 VSS \$4987 \$6890 \$5356 \$4275 VDD sg13g2_dfrbpq_1
* cell instance $43456 r0 *1 109.44,260.82
X$43456 VSS \$19413 \$17797 \$16122 \$16506 VDD sg13g2_dfrbpq_1
* cell instance $43457 r0 *1 108.96,245.7
X$43457 VSS \$17050 \$15925 \$15917 \$14322 VDD sg13g2_dfrbpq_1
* cell instance $43458 r0 *1 180.48,283.5
X$43458 VSS \$20762 \$20449 \$20448 \$20924 VDD sg13g2_dfrbpq_1
* cell instance $43459 r0 *1 308.16,154.98
X$43459 VSS \$10506 \$9475 \$8237 \$9327 VDD sg13g2_dfrbpq_1
* cell instance $43460 r0 *1 120.96,253.26
X$43460 VSS \$15003 \$17434 \$18627 \$16506 VDD sg13g2_dfrbpq_1
* cell instance $43461 r0 *1 149.76,275.94
X$43461 VSS \$19663 \$11897 \$20408 \$19658 VDD sg13g2_dfrbpq_1
* cell instance $43462 r0 *1 304.32,139.86
X$43462 VSS \$8660 \$7579 \$6986 \$7721 VDD sg13g2_dfrbpq_1
* cell instance $43463 r0 *1 265.92,56.7
X$43463 VSS \$2386 \$4497 \$2751 \$2389 VDD sg13g2_dfrbpq_1
* cell instance $43464 r0 *1 277.44,124.74
X$43464 VSS \$7826 \$7898 \$6976 \$8183 VDD sg13g2_dfrbpq_1
* cell instance $43465 r0 *1 158.88,215.46
X$43465 VSS \$13963 \$14802 \$15030 \$13170 VDD sg13g2_dfrbpq_1
* cell instance $43466 r0 *1 156,185.22
X$43466 VSS \$12020 \$12342 \$12015 \$11472 VDD sg13g2_dfrbpq_1
* cell instance $43467 r0 *1 159.84,200.34
X$43467 VSS \$13963 \$13810 \$13811 \$13170 VDD sg13g2_dfrbpq_1
* cell instance $43468 r0 *1 163.2,132.3
X$43468 VSS \$7346 \$6775 \$5504 \$5630 VDD sg13g2_dfrbpq_1
* cell instance $43469 r0 *1 323.04,86.94
X$43469 VSS \$3191 \$4843 \$4852 \$2916 VDD sg13g2_dfrbpq_1
* cell instance $43470 r0 *1 69.12,230.58
X$43470 VSS \$15547 \$15924 \$15917 \$14322 VDD sg13g2_dfrbpq_1
* cell instance $43471 r0 *1 63.36,253.26
X$43471 VSS \$15547 \$18742 \$18738 \$15634 VDD sg13g2_dfrbpq_1
* cell instance $43472 r0 *1 69.6,245.7
X$43472 VSS \$17415 \$17796 \$16122 \$15634 VDD sg13g2_dfrbpq_1
* cell instance $43473 r0 *1 224.16,109.62
X$43473 VSS \$5413 \$6981 \$6986 \$6432 VDD sg13g2_dfrbpq_1
* cell instance $43474 r0 *1 294.24,41.58
X$43474 VSS \$1462 \$1947 \$1803 \$98 VDD sg13g2_dfrbpq_1
* cell instance $43475 r0 *1 167.04,124.74
X$43475 VSS \$7346 \$7357 \$7344 \$5630 VDD sg13g2_dfrbpq_1
* cell instance $43476 r0 *1 68.64,260.82
X$43476 VSS \$19899 \$19173 \$19170 \$15634 VDD sg13g2_dfrbpq_1
* cell instance $43477 r0 *1 198.72,328.86
X$43477 VSS \$23117 \$23922 \$24186 \$24067 VDD sg13g2_dfrbpq_1
* cell instance $43478 r0 *1 13.44,275.94
X$43478 VSS \$19647 \$20511 \$20264 \$19646 VDD sg13g2_dfrbpq_1
* cell instance $43479 r0 *1 151.68,117.18
X$43479 VSS \$7346 \$7350 \$2356 \$5380 VDD sg13g2_dfrbpq_1
* cell instance $43480 r0 *1 320.64,79.38
X$43480 VSS \$3191 \$6246 \$4395 \$2916 VDD sg13g2_dfrbpq_1
* cell instance $43481 r0 *1 46.08,185.22
X$43481 VSS \$11991 \$12282 \$10851 \$12626 VDD sg13g2_dfrbpq_1
* cell instance $43482 r0 *1 300,34.02
X$43482 VSS \$1213 \$1517 \$1954 \$98 VDD sg13g2_dfrbpq_1
* cell instance $43483 r0 *1 149.76,109.62
X$43483 VSS \$5389 \$5274 \$4549 \$5630 VDD sg13g2_dfrbpq_1
* cell instance $43484 r0 *1 323.04,56.7
X$43484 VSS \$1792 \$2764 \$2762 \$1684 VDD sg13g2_dfrbpq_1
* cell instance $43485 r0 *1 319.68,64.26
X$43485 VSS \$1792 \$3360 \$3203 \$1684 VDD sg13g2_dfrbpq_1
* cell instance $43486 r0 *1 192,139.86
X$43486 VSS \$9117 \$9395 \$10171 \$9114 VDD sg13g2_dfrbpq_1
* cell instance $43487 r0 *1 279.36,298.62
X$43487 VSS \$20686 \$19282 \$22508 \$20682 VDD sg13g2_dfrbpq_1
* cell instance $43488 r0 *1 50.4,192.78
X$43488 VSS \$13126 \$13132 \$11584 \$12289 VDD sg13g2_dfrbpq_1
* cell instance $43489 r0 *1 272.16,109.62
X$43489 VSS \$5514 \$5655 \$4045 \$4385 VDD sg13g2_dfrbpq_1
* cell instance $43490 r0 *1 281.28,41.58
X$43490 VSS \$419 \$795 \$1575 \$247 VDD sg13g2_dfrbpq_1
* cell instance $43491 r0 *1 50.4,230.58
X$43491 VSS \$15633 \$16238 \$15623 \$15634 VDD sg13g2_dfrbpq_1
* cell instance $43492 r0 *1 13.44,283.5
X$43492 VSS \$19647 \$21342 \$20952 \$19646 VDD sg13g2_dfrbpq_1
* cell instance $43493 r0 *1 290.4,124.74
X$43493 VSS \$7826 \$7398 \$5402 \$4385 VDD sg13g2_dfrbpq_1
* cell instance $43494 r0 *1 291.84,109.62
X$43494 VSS \$5514 \$5891 \$5180 \$4385 VDD sg13g2_dfrbpq_1
* cell instance $43495 r0 *1 124.32,177.66
X$43495 VSS \$12013 \$11926 \$10765 \$9809 VDD sg13g2_dfrbpq_1
* cell instance $43496 r0 *1 310.08,56.7
X$43496 VSS \$2393 \$2803 \$2759 \$1684 VDD sg13g2_dfrbpq_1
* cell instance $43497 r0 *1 306.72,11.34
X$43497 VSS \$481 \$34 \$10 \$98 VDD sg13g2_dfrbpq_1
* cell instance $43498 r0 *1 276,49.14
X$43498 VSS \$97 \$2247 \$2246 \$247 VDD sg13g2_dfrbpq_1
* cell instance $43499 r0 *1 302.88,79.38
X$43499 VSS \$1480 \$4087 \$5429 \$2914 VDD sg13g2_dfrbpq_1
* cell instance $43500 r0 *1 309.12,86.94
X$43500 VSS \$1480 \$4857 \$4824 \$2914 VDD sg13g2_dfrbpq_1
* cell instance $43501 r0 *1 332.64,49.14
X$43501 VSS \$1792 \$2256 \$2433 \$1684 VDD sg13g2_dfrbpq_1
* cell instance $43502 r0 *1 302.88,26.46
X$43502 VSS \$481 \$937 \$1066 \$98 VDD sg13g2_dfrbpq_1
* cell instance $43503 r0 *1 314.88,49.14
X$43503 VSS \$1026 \$2254 \$2391 \$1684 VDD sg13g2_dfrbpq_1
* cell instance $43504 r0 *1 308.64,260.82
X$43504 VSS \$19477 \$12062 \$19535 \$15972 VDD sg13g2_dfrbpq_1
* cell instance $43505 r0 *1 288.96,49.14
X$43505 VSS \$97 \$2478 \$2498 \$2389 VDD sg13g2_dfrbpq_1
* cell instance $43506 r0 *1 239.04,207.9
X$43506 VSS \$12681 \$14400 \$14267 \$13206 VDD sg13g2_dfrbpq_1
* cell instance $43507 r0 *1 100.8,336.42
X$43507 VSS \$23499 \$22863 \$22367 \$21825 VDD sg13g2_dfrbpq_1
* cell instance $43508 r0 *1 232.32,200.34
X$43508 VSS \$12681 \$13191 \$13103 \$12538 VDD sg13g2_dfrbpq_1
* cell instance $43509 r0 *1 327.36,71.82
X$43509 VSS \$3191 \$3758 \$3745 \$2916 VDD sg13g2_dfrbpq_1
* cell instance $43510 r0 *1 221.28,147.42
X$43510 VSS \$9283 \$9589 \$10476 \$9284 VDD sg13g2_dfrbpq_1
* cell instance $43511 r0 *1 337.44,86.94
X$43511 VSS \$5046 \$5202 \$5200 \$2916 VDD sg13g2_dfrbpq_1
* cell instance $43512 r0 *1 107.04,328.86
X$43512 VSS \$23499 \$23818 \$24141 \$21825 VDD sg13g2_dfrbpq_1
* cell instance $43513 r0 *1 246.72,192.78
X$43513 VSS \$12681 \$12918 \$13471 \$12538 VDD sg13g2_dfrbpq_1
* cell instance $43514 r0 *1 143.52,132.3
X$43514 VSS \$7346 \$8382 \$8435 \$5630 VDD sg13g2_dfrbpq_1
* cell instance $43515 r0 *1 310.56,253.26
X$43515 VSS \$15567 \$18487 \$18838 \$15972 VDD sg13g2_dfrbpq_1
* cell instance $43516 r0 *1 333.6,79.38
X$43516 VSS \$2429 \$4416 \$4399 \$2916 VDD sg13g2_dfrbpq_1
* cell instance $43517 r0 *1 111.36,321.3
X$43517 VSS \$22481 \$22383 \$22376 \$21825 VDD sg13g2_dfrbpq_1
* cell instance $43518 r0 *1 120.96,336.42
X$43518 VSS \$23530 \$24594 \$24593 \$23104 VDD sg13g2_dfrbpq_1
* cell instance $43519 r0 *1 241.44,275.94
X$43519 VSS \$20038 \$20040 \$20619 \$20459 VDD sg13g2_dfrbpq_1
* cell instance $43520 r0 *1 230.4,291.06
X$43520 VSS \$20038 \$21444 \$21715 \$20682 VDD sg13g2_dfrbpq_1
* cell instance $43521 r0 *1 301.92,49.14
X$43521 VSS \$1213 \$2453 \$2470 \$1684 VDD sg13g2_dfrbpq_1
* cell instance $43522 m0 *1 314.4,56.7
X$43522 VDD VSS \$2653 \$2645 \$2449 sg13g2_and2_1
* cell instance $43523 r0 *1 337.92,245.7
X$43523 VSS \$17138 \$17484 \$17705 \$15972 VDD sg13g2_dfrbpq_1
* cell instance $43524 r0 *1 296.16,86.94
X$43524 VSS \$1020 \$5191 \$5427 \$4385 VDD sg13g2_dfrbpq_1
* cell instance $43525 r0 *1 228.48,215.46
X$43525 VSS \$12681 \$15056 \$14814 \$13206 VDD sg13g2_dfrbpq_1
* cell instance $43526 r0 *1 111.36,298.62
X$43526 VSS \$19906 \$21021 \$20745 \$21825 VDD sg13g2_dfrbpq_1
* cell instance $43527 r0 *1 106.08,306.18
X$43527 VSS \$19911 \$21547 \$21779 \$21825 VDD sg13g2_dfrbpq_1
* cell instance $43528 r0 *1 210.72,275.94
X$43528 VSS \$19666 \$19605 \$20634 \$20454 VDD sg13g2_dfrbpq_1
* cell instance $43529 r0 *1 287.04,34.02
X$43529 VSS \$1462 \$1333 \$1343 \$304 VDD sg13g2_dfrbpq_1
* cell instance $43530 r0 *1 120.48,291.06
X$43530 VSS \$19906 \$20228 \$19222 \$19658 VDD sg13g2_dfrbpq_1
* cell instance $43531 r0 *1 276.96,79.38
X$43531 VSS \$2758 \$4387 \$4947 \$4385 VDD sg13g2_dfrbpq_1
* cell instance $43532 r0 *1 324.48,253.26
X$43532 VSS \$17917 \$17697 \$18653 \$15972 VDD sg13g2_dfrbpq_1
* cell instance $43533 r0 *1 108.96,275.94
X$43533 VSS \$19413 \$19175 \$19170 \$16506 VDD sg13g2_dfrbpq_1
* cell instance $43534 r0 *1 124.8,132.3
X$43534 VSS \$7340 \$8433 \$8129 \$6281 VDD sg13g2_dfrbpq_1
* cell instance $43535 r0 *1 317.28,132.3
X$43535 VSS \$8660 \$8697 \$8470 \$7721 VDD sg13g2_dfrbpq_1
* cell instance $43536 r0 *1 50.4,260.82
X$43536 VSS \$19401 \$19396 \$17639 \$15634 VDD sg13g2_dfrbpq_1
* cell instance $43537 r0 *1 123.36,117.18
X$43537 VSS \$7340 \$7036 \$5504 \$5380 VDD sg13g2_dfrbpq_1
* cell instance $43538 r0 *1 96.48,139.86
X$43538 VSS \$9259 \$8562 \$6576 \$6281 VDD sg13g2_dfrbpq_1
* cell instance $43539 r0 *1 101.28,147.42
X$43539 VSS \$9259 \$8578 \$8950 \$6281 VDD sg13g2_dfrbpq_1
* cell instance $43540 r0 *1 190.56,170.1
X$43540 VSS \$10302 \$10963 \$11402 \$9827 VDD sg13g2_dfrbpq_1
* cell instance $43541 r0 *1 337.92,291.06
X$43541 VSS \$20253 \$21096 \$21337 \$19691 VDD sg13g2_dfrbpq_1
* cell instance $43542 r0 *1 336,298.62
X$43542 VSS \$19514 \$21854 \$22160 \$19691 VDD sg13g2_dfrbpq_1
* cell instance $43543 r0 *1 336.48,306.18
X$43543 VSS \$22595 \$21947 \$22741 \$22192 VDD sg13g2_dfrbpq_1
* cell instance $43544 r0 *1 116.64,124.74
X$43544 VSS \$7340 \$7982 \$7811 \$6281 VDD sg13g2_dfrbpq_1
* cell instance $43545 r0 *1 275.52,64.26
X$43545 VSS \$2386 \$3393 \$3241 \$2389 VDD sg13g2_dfrbpq_1
* cell instance $43546 r0 *1 278.88,56.7
X$43546 VSS \$1468 \$2831 \$2753 \$2389 VDD sg13g2_dfrbpq_1
* cell instance $43547 r0 *1 337.92,260.82
X$43547 VSS \$19477 \$19484 \$19482 \$15972 VDD sg13g2_dfrbpq_1
* cell instance $43548 r0 *1 336.96,283.5
X$43548 VSS \$20253 \$20690 \$21108 \$19691 VDD sg13g2_dfrbpq_1
* cell instance $43549 r0 *1 142.08,185.22
X$43549 VSS \$12020 \$11868 \$12447 \$11472 VDD sg13g2_dfrbpq_1
* cell instance $43550 r0 *1 142.08,200.34
X$43550 VSS \$13963 \$12335 \$12334 \$11472 VDD sg13g2_dfrbpq_1
* cell instance $43551 r0 *1 111.36,102.06
X$43551 VSS \$6154 \$6673 \$2356 \$5380 VDD sg13g2_dfrbpq_1
* cell instance $43552 r0 *1 50.4,245.7
X$43552 VSS \$17640 \$16869 \$16653 \$15634 VDD sg13g2_dfrbpq_1
* cell instance $43553 r0 *1 50.4,253.26
X$43553 VSS \$15547 \$18737 \$18735 \$15634 VDD sg13g2_dfrbpq_1
* cell instance $43554 r0 *1 293.76,306.18
X$43554 VSS \$22589 \$20940 \$22605 \$20682 VDD sg13g2_dfrbpq_1
* cell instance $43555 r0 *1 50.4,223.02
X$43555 VSS \$15633 \$15540 \$15326 \$15634 VDD sg13g2_dfrbpq_1
* cell instance $43556 r0 *1 289.92,26.46
X$43556 VSS \$164 \$1019 \$1080 \$304 VDD sg13g2_dfrbpq_1
* cell instance $43557 r0 *1 337.92,56.7
X$43557 VSS \$2393 \$3063 \$2765 \$1684 VDD sg13g2_dfrbpq_1
* cell instance $43558 r0 *1 337.92,64.26
X$43558 VSS \$3191 \$3355 \$3752 \$2916 VDD sg13g2_dfrbpq_1
* cell instance $43559 r0 *1 96.96,102.06
X$43559 VSS \$6154 \$6167 \$4022 \$6281 VDD sg13g2_dfrbpq_1
* cell instance $43560 r0 *1 297.12,102.06
X$43560 VSS \$5514 \$2927 \$5873 \$4385 VDD sg13g2_dfrbpq_1
* cell instance $43561 m0 *1 306.24,109.62
X$43561 VDD VSS \$6221 \$2635 \$2642 sg13g2_xnor2_1
* cell instance $43562 r0 *1 103.2,109.62
X$43562 VSS \$6154 \$5240 \$4977 \$6281 VDD sg13g2_dfrbpq_1
* cell instance $43563 r0 *1 289.92,79.38
X$43563 VSS \$2758 \$4394 \$4388 \$2914 VDD sg13g2_dfrbpq_1
* cell instance $43564 r0 *1 97.92,162.54
X$43564 VSS \$9107 \$10284 \$9622 \$9809 VDD sg13g2_dfrbpq_1
* cell instance $43565 r0 *1 286.08,71.82
X$43565 VSS \$1468 \$3557 \$6083 \$2914 VDD sg13g2_dfrbpq_1
* cell instance $43566 r0 *1 325.44,230.58
X$43566 VSS \$15567 \$15979 \$16166 \$15972 VDD sg13g2_dfrbpq_1
* cell instance $43567 r0 *1 300.48,71.82
X$43567 VSS \$419 \$3775 \$587 \$2914 VDD sg13g2_dfrbpq_1
* cell instance $43568 r0 *1 290.88,64.26
X$43568 VSS \$1468 \$2406 \$3371 \$2914 VDD sg13g2_dfrbpq_1
* cell instance $43569 r0 *1 293.76,56.7
X$43569 VSS \$1468 \$2757 \$3220 \$2389 VDD sg13g2_dfrbpq_1
* cell instance $43570 r0 *1 283.2,86.94
X$43570 VSS \$419 \$5249 \$4927 \$4385 VDD sg13g2_dfrbpq_1
* cell instance $43571 r0 *1 328.8,109.62
X$43571 VSS \$794 \$2919 \$4366 \$5681 VDD sg13g2_dfrbpq_1
* cell instance $43572 r0 *1 318.72,117.18
X$43572 VSS \$1032 \$7422 \$7437 \$7721 VDD sg13g2_dfrbpq_1
* cell instance $43573 r0 *1 336.96,117.18
X$43573 VSS \$1032 \$588 \$4071 \$7721 VDD sg13g2_dfrbpq_1
* cell instance $43574 r0 *1 336,132.3
X$43574 VSS \$1032 \$2645 \$2096 \$7721 VDD sg13g2_dfrbpq_1
* cell instance $43575 r0 *1 331.68,124.74
X$43575 VSS \$295 \$5443 \$5180 \$7721 VDD sg13g2_dfrbpq_1
* cell instance $43576 r0 *1 276.96,26.46
X$43576 VSS \$1462 \$1015 \$2381 \$304 VDD sg13g2_dfrbpq_1
* cell instance $43577 r0 *1 290.4,11.34
X$43577 VSS \$164 \$108 \$114 \$304 VDD sg13g2_dfrbpq_1
* cell instance $43578 r0 *1 303.36,11.34
X$43578 VSS \$97 VDD \$165 sg13g2_buf_1
* cell instance $43579 r0 *1 327.36,102.06
X$43579 VSS \$5046 \$6218 \$5940 \$5681 VDD sg13g2_dfrbpq_1
* cell instance $43580 r0 *1 282.24,18.9
X$43580 VSS \$395 \$156 \$392 \$304 VDD sg13g2_dfrbpq_1
* cell instance $43581 r0 *1 103.68,124.74
X$43581 VSS \$7340 \$7681 \$6745 \$6281 VDD sg13g2_dfrbpq_1
* cell instance $43582 r0 *1 273.12,71.82
X$43582 VSS \$2386 \$3794 \$3738 \$2389 VDD sg13g2_dfrbpq_1
* cell instance $43583 r0 *1 296.64,343.98
X$43583 VSS \$24547 \$23977 \$24886 \$22724 VDD sg13g2_dfrbpq_1
* cell instance $43584 r0 *1 187.68,207.9
X$43584 VSS \$12221 \$14211 \$14377 \$13170 VDD sg13g2_dfrbpq_1
* cell instance $43585 r0 *1 187.68,215.46
X$43585 VSS \$14404 \$14896 \$14898 \$13170 VDD sg13g2_dfrbpq_1
* cell instance $43586 r0 *1 103.2,283.5
X$43586 VSS \$19906 \$20653 \$18790 \$19978 VDD sg13g2_dfrbpq_1
* cell instance $43587 r0 *1 337.92,41.58
X$43587 VSS \$1792 \$1924 \$1683 \$99 VDD sg13g2_dfrbpq_1
* cell instance $43588 r0 *1 246.24,26.46
X$43588 VSS \$1008 \$1095 \$1112 \$246 VDD sg13g2_dfrbpq_1
* cell instance $43589 r0 *1 332.64,11.34
X$43589 VSS \$419 \$102 \$166 \$99 VDD sg13g2_dfrbpq_1
* cell instance $43590 r0 *1 345.6,11.34
X$43590 VSS \$167 \$99 VDD sg13g2_buf_8
* cell instance $43591 r0 *1 75.36,147.42
X$43591 VSS \$9252 \$9453 \$9442 \$9541 VDD sg13g2_dfrbpq_1
* cell instance $43592 r0 *1 243.36,18.9
X$43592 VSS \$162 \$363 \$494 \$246 VDD sg13g2_dfrbpq_1
* cell instance $43593 r0 *1 318.24,26.46
X$43593 VSS \$252 \$928 \$936 \$99 VDD sg13g2_dfrbpq_1
* cell instance $43594 r0 *1 240,41.58
X$43594 VSS \$1783 \$1912 \$1983 \$1459 VDD sg13g2_dfrbpq_1
* cell instance $43595 r0 *1 243.84,34.02
X$43595 VSS \$1009 \$1348 \$1353 \$246 VDD sg13g2_dfrbpq_1
* cell instance $43596 r0 *1 143.52,139.86
X$43596 VSS \$9108 \$7172 \$6745 \$9114 VDD sg13g2_dfrbpq_1
* cell instance $43597 r0 *1 120,162.54
X$43597 VSS \$9107 \$9452 \$9442 \$9809 VDD sg13g2_dfrbpq_1
* cell instance $43598 r0 *1 325.92,34.02
X$43598 VSS \$252 \$1470 \$1501 \$99 VDD sg13g2_dfrbpq_1
* cell instance $43599 r0 *1 58.08,147.42
X$43599 VSS \$9252 \$10453 \$9622 \$9250 VDD sg13g2_dfrbpq_1
* cell instance $43600 r0 *1 256.8,34.02
X$43600 VSS \$1008 \$1234 \$1106 \$247 VDD sg13g2_dfrbpq_1
* cell instance $43601 r0 *1 252.96,41.58
X$43601 VSS \$1008 \$1913 \$1550 \$246 VDD sg13g2_dfrbpq_1
* cell instance $43602 r0 *1 189.12,291.06
X$43602 VSS \$20762 \$20531 \$21706 \$20454 VDD sg13g2_dfrbpq_1
* cell instance $43603 r0 *1 197.28,298.62
X$43603 VSS \$20762 \$21710 \$21707 \$20454 VDD sg13g2_dfrbpq_1
* cell instance $43604 r0 *1 97.44,207.9
X$43604 VSS \$12013 \$13306 \$14505 \$12633 VDD sg13g2_dfrbpq_1
* cell instance $43605 r0 *1 280.8,336.42
X$43605 VSS \$22589 \$20127 \$24463 \$22724 VDD sg13g2_dfrbpq_1
* cell instance $43606 r0 *1 171.84,79.38
X$43606 VSS \$3318 \$4735 \$4565 \$2900 VDD sg13g2_dfrbpq_1
* cell instance $43607 r0 *1 100.32,223.02
X$43607 VSS \$15003 \$15004 \$15447 \$12633 VDD sg13g2_dfrbpq_1
* cell instance $43608 r0 *1 287.52,328.86
X$43608 VSS \$24547 \$18205 \$23942 \$22724 VDD sg13g2_dfrbpq_1
* cell instance $43609 r0 *1 332.64,26.46
X$43609 VSS \$252 \$581 \$1491 \$99 VDD sg13g2_dfrbpq_1
* cell instance $43610 r0 *1 179.04,56.7
X$43610 VSS \$2743 \$2904 \$2742 \$918 VDD sg13g2_dfrbpq_1
* cell instance $43611 r0 *1 230.88,34.02
X$43611 VSS \$599 \$1269 \$1324 \$95 VDD sg13g2_dfrbpq_1
* cell instance $43612 r0 *1 232.8,26.46
X$43612 VSS \$160 \$922 \$96 \$246 VDD sg13g2_dfrbpq_1
* cell instance $43613 r0 *1 10.08,139.86
X$43613 VSS \$9097 \$9322 \$9088 \$8551 VDD sg13g2_dfrbpq_1
* cell instance $43614 r0 *1 332.64,268.38
X$43614 VSS \$19477 \$20062 \$20386 \$19691 VDD sg13g2_dfrbpq_1
* cell instance $43615 r0 *1 31.68,291.06
X$43615 VSS \$20742 \$21538 \$22376 \$21534 VDD sg13g2_dfrbpq_1
* cell instance $43616 r0 *1 83.52,139.86
X$43616 VSS \$9252 \$8249 \$6740 \$9541 VDD sg13g2_dfrbpq_1
* cell instance $43617 r0 *1 10.08,177.66
X$43617 VSS \$10271 \$11990 \$11584 \$8551 VDD sg13g2_dfrbpq_1
* cell instance $43618 r0 *1 90.24,124.74
X$43618 VSS \$6763 \$7314 \$3019 \$5612 VDD sg13g2_dfrbpq_1
* cell instance $43619 r0 *1 10.08,162.54
X$43619 VSS \$10271 \$10968 \$10851 \$8551 VDD sg13g2_dfrbpq_1
* cell instance $43620 r0 *1 10.08,291.06
X$43620 VSS \$19394 \$20911 \$21679 \$21534 VDD sg13g2_dfrbpq_1
* cell instance $43621 r0 *1 23.52,298.62
X$43621 VSS \$20804 \$22079 \$22031 \$21534 VDD sg13g2_dfrbpq_1
* cell instance $43622 r0 *1 260.64,275.94
X$43622 VSS \$19471 \$20241 \$20433 \$20682 VDD sg13g2_dfrbpq_1
* cell instance $43623 r0 *1 264,260.82
X$43623 VSS \$19471 \$17899 \$19336 \$16160 VDD sg13g2_dfrbpq_1
* cell instance $43624 r0 *1 310.56,268.38
X$43624 VSS \$19477 \$17714 \$20055 \$19691 VDD sg13g2_dfrbpq_1
* cell instance $43625 r0 *1 269.28,192.78
X$43625 VSS \$12313 \$12924 \$13219 \$12554 VDD sg13g2_dfrbpq_1
* cell instance $43626 r0 *1 184.8,223.02
X$43626 VSS \$15947 \$15608 \$15614 \$14809 VDD sg13g2_dfrbpq_1
* cell instance $43627 r0 *1 269.28,230.58
X$43627 VSS \$15693 \$15963 \$16198 \$13206 VDD sg13g2_dfrbpq_1
* cell instance $43628 r0 *1 263.52,336.42
X$43628 VSS \$24547 \$16764 \$24546 \$22724 VDD sg13g2_dfrbpq_1
* cell instance $43629 r0 *1 260.16,291.06
X$43629 VSS \$20686 \$18477 \$21568 \$20682 VDD sg13g2_dfrbpq_1
* cell instance $43630 r0 *1 117.12,192.78
X$43630 VSS \$12013 \$11756 \$11450 \$12633 VDD sg13g2_dfrbpq_1
* cell instance $43631 r0 *1 280.32,268.38
X$43631 VSS \$19471 \$19826 \$20141 \$16160 VDD sg13g2_dfrbpq_1
* cell instance $43632 r0 *1 114.72,215.46
X$43632 VSS \$13735 \$14338 \$15015 \$12633 VDD sg13g2_dfrbpq_1
* cell instance $43633 r0 *1 95.52,64.26
X$43633 VSS \$2611 \$2730 \$3023 \$3156 VDD sg13g2_dfrbpq_1
* cell instance $43634 r0 *1 146.4,170.1
X$43634 VSS \$10465 \$11188 \$11594 \$11472 VDD sg13g2_dfrbpq_1
* cell instance $43635 r0 *1 293.28,268.38
X$43635 VSS \$19471 \$17905 \$19555 \$16160 VDD sg13g2_dfrbpq_1
* cell instance $43636 r0 *1 110.4,207.9
X$43636 VSS \$13735 \$13659 \$12092 \$12633 VDD sg13g2_dfrbpq_1
* cell instance $43637 r0 *1 36.96,162.54
X$43637 VSS \$10443 \$10976 \$11450 \$9250 VDD sg13g2_dfrbpq_1
* cell instance $43638 m0 *1 43.68,170.1
X$43638 VDD VSS \$10973 \$11168 \$9609 \$11325 sg13g2_or3_1
* cell instance $43639 r0 *1 30.24,177.66
X$43639 VSS \$11991 \$12627 \$12092 \$9250 VDD sg13g2_dfrbpq_1
* cell instance $43640 r0 *1 19.2,170.1
X$43640 VSS \$10271 \$11921 \$11442 \$8551 VDD sg13g2_dfrbpq_1
* cell instance $43641 r0 *1 338.88,34.02
X$43641 VSS \$1026 \$1337 \$1339 \$99 VDD sg13g2_dfrbpq_1
* cell instance $43642 r0 *1 269.28,223.02
X$43642 VSS \$15693 \$15690 \$15691 \$13206 VDD sg13g2_dfrbpq_1
* cell instance $43643 r0 *1 11.52,306.18
X$43643 VSS \$20804 \$22080 \$23034 \$21534 VDD sg13g2_dfrbpq_1
* cell instance $43644 r0 *1 250.56,11.34
X$43644 VSS \$162 \$16 \$157 \$246 VDD sg13g2_dfrbpq_1
* cell instance $43645 r0 *1 292.8,291.06
X$43645 VSS \$20686 \$21085 \$21616 \$16160 VDD sg13g2_dfrbpq_1
* cell instance $43646 r0 *1 71.52,283.5
X$43646 VSS \$20917 \$21020 \$20745 \$15634 VDD sg13g2_dfrbpq_1
* cell instance $43647 r0 *1 117.12,147.42
X$43647 VSS \$9259 \$9458 \$8121 \$6281 VDD sg13g2_dfrbpq_1
* cell instance $43648 r0 *1 113.76,139.86
X$43648 VSS \$9259 \$7167 \$4658 \$6281 VDD sg13g2_dfrbpq_1
* cell instance $43649 r0 *1 102.24,185.22
X$43649 VSS \$12013 \$11759 \$12334 \$12633 VDD sg13g2_dfrbpq_1
* cell instance $43650 r0 *1 99.36,200.34
X$43650 VSS \$13735 \$12285 \$11442 \$12633 VDD sg13g2_dfrbpq_1
* cell instance $43651 r0 *1 185.28,328.86
X$43651 VSS \$23120 \$21060 \$23687 \$23545 VDD sg13g2_dfrbpq_1
* cell instance $43652 r0 *1 324.96,200.34
X$43652 VSS \$13239 \$13241 \$13717 \$12321 VDD sg13g2_dfrbpq_1
* cell instance $43653 r0 *1 333.6,215.46
X$43653 VSS \$13239 \$14462 \$14463 \$12321 VDD sg13g2_dfrbpq_1
* cell instance $43654 r0 *1 256.32,18.9
X$43654 VSS \$162 \$348 \$474 \$247 VDD sg13g2_dfrbpq_1
* cell instance $43655 r0 *1 337.92,207.9
X$43655 VSS \$13985 \$14246 \$14249 \$12321 VDD sg13g2_dfrbpq_1
* cell instance $43656 r0 *1 324.96,41.58
X$43656 VSS \$252 \$1679 \$1795 \$1684 VDD sg13g2_dfrbpq_1
* cell instance $43657 r0 *1 313.44,71.82
X$43657 VSS \$1480 \$4654 \$2399 \$2914 VDD sg13g2_dfrbpq_1
* cell instance $43658 r0 *1 303.84,64.26
X$43658 VSS \$2393 \$3571 \$3186 \$2914 VDD sg13g2_dfrbpq_1
* cell instance $43659 r0 *1 308.16,18.9
X$43659 VSS \$481 \$106 \$1682 \$98 VDD sg13g2_dfrbpq_1
* cell instance $43660 r0 *1 244.8,162.54
X$43660 VSS \$9392 \$9830 \$8894 \$9284 VDD sg13g2_dfrbpq_1
* cell instance $43661 r0 *1 247.68,154.98
X$43661 VSS \$9283 \$8450 \$7686 \$9284 VDD sg13g2_dfrbpq_1
* cell instance $43662 r0 *1 312.96,34.02
X$43662 VSS \$1213 \$1341 \$2084 \$98 VDD sg13g2_dfrbpq_1
* cell instance $43663 r0 *1 10.56,298.62
X$43663 VSS \$20804 \$21531 \$21113 \$21534 VDD sg13g2_dfrbpq_1
* cell instance $43664 r0 *1 168.48,102.06
X$43664 VSS \$5389 \$5844 \$5805 \$5630 VDD sg13g2_dfrbpq_1
* cell instance $43665 r0 *1 308.16,41.58
X$43665 VSS \$1213 \$1938 \$1797 \$98 VDD sg13g2_dfrbpq_1
* cell instance $43666 r0 *1 242.4,170.1
X$43666 VSS \$9392 \$11501 \$11499 \$9284 VDD sg13g2_dfrbpq_1
* cell instance $43667 r0 *1 306.24,185.22
X$43667 VSS \$12060 \$12061 \$12801 \$12554 VDD sg13g2_dfrbpq_1
* cell instance $43668 r0 *1 307.2,192.78
X$43668 VSS \$12060 \$11784 \$12376 \$12554 VDD sg13g2_dfrbpq_1
* cell instance $43669 r0 *1 108.48,170.1
X$43669 VSS \$9107 \$11183 \$10459 \$9809 VDD sg13g2_dfrbpq_1
* cell instance $43670 r0 *1 214.56,177.66
X$43670 VSS \$12221 \$11005 \$9630 \$9827 VDD sg13g2_dfrbpq_1
* cell instance $43671 r0 *1 248.16,147.42
X$43671 VSS \$9283 \$9469 \$8861 \$9284 VDD sg13g2_dfrbpq_1
* cell instance $43672 r0 *1 185.28,200.34
X$43672 VSS \$12221 \$13817 \$14173 \$13170 VDD sg13g2_dfrbpq_1
* cell instance $43673 r0 *1 76.8,177.66
X$43673 VSS \$11567 \$11686 \$11450 \$9541 VDD sg13g2_dfrbpq_1
* cell instance $43674 r0 *1 295.2,18.9
X$43674 VSS \$164 \$242 \$832 \$304 VDD sg13g2_dfrbpq_1
* cell instance $43675 r0 *1 62.4,170.1
X$43675 VSS \$9801 \$11562 \$11752 \$9250 VDD sg13g2_dfrbpq_1
* cell instance $43676 r0 *1 55.2,275.94
X$43676 VSS \$19899 \$20345 \$19489 \$15634 VDD sg13g2_dfrbpq_1
* cell instance $43677 r0 *1 68.64,154.98
X$43677 VSS \$9801 \$10156 \$10459 \$9541 VDD sg13g2_dfrbpq_1
* cell instance $43678 r0 *1 125.28,321.3
X$43678 VSS \$23530 \$22563 \$21300 \$23104 VDD sg13g2_dfrbpq_1
* cell instance $43679 r0 *1 164.16,192.78
X$43679 VSS \$12020 \$11468 \$10765 \$13170 VDD sg13g2_dfrbpq_1
* cell instance $43680 r0 *1 120.96,343.98
X$43680 VSS \$23530 \$23910 \$24874 \$23104 VDD sg13g2_dfrbpq_1
* cell instance $43681 r0 *1 164.64,147.42
X$43681 VSS \$9108 \$8434 \$8129 \$9114 VDD sg13g2_dfrbpq_1
* cell instance $43682 r0 *1 50.4,154.98
X$43682 VSS \$10443 \$10273 \$9088 \$9250 VDD sg13g2_dfrbpq_1
* cell instance $43683 r0 *1 296.64,147.42
X$43683 VSS \$9838 \$9661 \$8820 \$9327 VDD sg13g2_dfrbpq_1
* cell instance $43684 r0 *1 180.48,177.66
X$43684 VSS \$11875 \$11704 \$12187 \$9827 VDD sg13g2_dfrbpq_1
* cell instance $43685 r0 *1 51.36,117.18
X$43685 VSS \$7163 \$6287 \$7321 \$4275 VDD sg13g2_dfrbpq_1
* cell instance $43686 r0 *1 280.8,275.94
X$43686 VSS \$19471 \$20021 \$20045 \$16160 VDD sg13g2_dfrbpq_1
* cell instance $43687 r0 *1 50.4,162.54
X$43687 VSS \$10443 \$11168 \$9779 \$9250 VDD sg13g2_dfrbpq_1
* cell instance $43688 r0 *1 50.4,124.74
X$43688 VSS \$6148 \$8418 \$7308 \$5916 VDD sg13g2_dfrbpq_1
* cell instance $43689 r0 *1 39.84,132.3
X$43689 VSS \$7307 \$8876 \$9442 \$8551 VDD sg13g2_dfrbpq_1
* cell instance $43690 r0 *1 41.76,147.42
X$43690 VSS \$9097 \$9617 \$8565 \$9250 VDD sg13g2_dfrbpq_1
* cell instance $43691 r0 *1 50.4,177.66
X$43691 VSS \$10443 \$11743 \$10758 \$9250 VDD sg13g2_dfrbpq_1
* cell instance $43692 r0 *1 50.4,139.86
X$43692 VSS \$9097 \$9248 \$5969 \$9250 VDD sg13g2_dfrbpq_1
* cell instance $43693 r0 *1 230.4,18.9
X$43693 VSS \$160 \$182 \$130 \$246 VDD sg13g2_dfrbpq_1
* cell instance $43694 r0 *1 49.44,170.1
X$43694 VSS \$10443 \$11161 \$10037 \$9250 VDD sg13g2_dfrbpq_1
* cell instance $43695 r0 *1 39.36,109.62
X$43695 VSS \$4974 \$6747 \$6731 \$5916 VDD sg13g2_dfrbpq_1
* cell instance $43696 r0 *1 50.4,102.06
X$43696 VSS \$6148 \$5816 \$4759 \$4275 VDD sg13g2_dfrbpq_1
* cell instance $43697 r0 *1 71.52,306.18
X$43697 VSS \$22562 \$22320 \$22376 \$22565 VDD sg13g2_dfrbpq_1
* cell instance $43698 r0 *1 277.44,11.34
X$43698 VSS \$164 \$115 \$24 \$304 VDD sg13g2_dfrbpq_1
* cell instance $43699 r0 *1 254.4,177.66
X$43699 VSS \$9392 \$12041 \$11502 \$9284 VDD sg13g2_dfrbpq_1
* cell instance $43700 r0 *1 208.8,185.22
X$43700 VSS \$11875 \$12241 \$12911 \$12538 VDD sg13g2_dfrbpq_1
* cell instance $43701 r0 *1 232.8,11.34
X$43701 VSS \$160 \$2 \$63 \$95 VDD sg13g2_dfrbpq_1
* cell instance $43702 r0 *1 217.44,18.9
X$43702 VSS \$470 \$423 \$159 \$95 VDD sg13g2_dfrbpq_1
* cell instance $43703 r0 *1 220.8,79.38
X$43703 VSS \$3920 \$3730 \$2742 \$3177 VDD sg13g2_dfrbpq_1
* cell instance $43704 r0 *1 20.64,343.98
X$43704 VSS \$24040 \$20987 \$20990 \$24039 VDD sg13g2_dfrbpq_1
* cell instance $43705 r0 *1 296.16,230.58
X$43705 VSS \$15693 \$15970 \$16188 \$16160 VDD sg13g2_dfrbpq_1
* cell instance $43706 r0 *1 226.08,86.94
X$43706 VSS \$3920 \$5505 \$5088 \$3177 VDD sg13g2_dfrbpq_1
* cell instance $43707 r0 *1 224.16,49.14
X$43707 VSS \$1346 \$1889 \$782 \$1459 VDD sg13g2_dfrbpq_1
* cell instance $43708 r0 *1 22.56,328.86
X$43708 VSS \$22165 \$23747 \$22370 \$24039 VDD sg13g2_dfrbpq_1
* cell instance $43709 r0 *1 87.36,223.02
X$43709 VSS \$15547 \$14198 \$12879 \$14322 VDD sg13g2_dfrbpq_1
* cell instance $43710 r0 *1 49.92,268.38
X$43710 VSS \$19647 \$19892 \$18725 \$19646 VDD sg13g2_dfrbpq_1
* cell instance $43711 r0 *1 225.12,64.26
X$43711 VSS \$1346 \$2233 \$2359 \$3177 VDD sg13g2_dfrbpq_1
* cell instance $43712 r0 *1 90.24,238.14
X$43712 VSS \$15547 \$15627 \$15326 \$14322 VDD sg13g2_dfrbpq_1
* cell instance $43713 r0 *1 90.24,283.5
X$43713 VSS \$20917 \$19972 \$18725 \$19978 VDD sg13g2_dfrbpq_1
* cell instance $43714 r0 *1 90.24,275.94
X$43714 VSS \$19899 \$19711 \$17639 \$19978 VDD sg13g2_dfrbpq_1
* cell instance $43715 r0 *1 90.24,260.82
X$43715 VSS \$17415 \$17153 \$16653 \$14322 VDD sg13g2_dfrbpq_1
* cell instance $43716 r0 *1 143.04,283.5
X$43716 VSS \$21696 \$19723 \$18738 \$19658 VDD sg13g2_dfrbpq_1
* cell instance $43717 r0 *1 50.4,313.74
X$43717 VSS \$22165 \$23086 \$22651 \$23087 VDD sg13g2_dfrbpq_1
* cell instance $43718 r0 *1 129.6,268.38
X$43718 VSS \$19906 \$19177 \$19551 \$19658 VDD sg13g2_dfrbpq_1
* cell instance $43719 r0 *1 214.56,34.02
X$43719 VSS \$1678 \$1458 \$1322 \$95 VDD sg13g2_dfrbpq_1
* cell instance $43720 r0 *1 209.28,71.82
X$43720 VSS \$2907 \$3510 \$5032 \$3725 VDD sg13g2_dfrbpq_1
* cell instance $43721 r0 *1 195.84,71.82
X$43721 VSS \$2743 \$3325 \$2563 \$918 VDD sg13g2_dfrbpq_1
* cell instance $43722 r0 *1 90.72,328.86
X$43722 VSS \$23657 \$23991 \$24144 \$22565 VDD sg13g2_dfrbpq_1
* cell instance $43723 r0 *1 28.8,215.46
X$43723 VSS \$13576 \$14932 \$15917 \$12626 VDD sg13g2_dfrbpq_1
* cell instance $43724 r0 *1 12.48,268.38
X$43724 VSS \$19394 \$19970 \$19935 \$19646 VDD sg13g2_dfrbpq_1
* cell instance $43725 r0 *1 87.84,336.42
X$43725 VSS \$23096 \$23795 \$24589 \$22565 VDD sg13g2_dfrbpq_1
* cell instance $43726 r0 *1 89.28,185.22
X$43726 VSS \$11567 \$11160 \$10037 \$12289 VDD sg13g2_dfrbpq_1
* cell instance $43727 r0 *1 90.24,192.78
X$43727 VSS \$11567 \$11744 \$10758 \$12289 VDD sg13g2_dfrbpq_1
* cell instance $43728 r0 *1 103.2,268.38
X$43728 VSS \$19413 \$19953 \$18738 \$16506 VDD sg13g2_dfrbpq_1
* cell instance $43729 r0 *1 21.6,200.34
X$43729 VSS \$13576 \$13866 \$13715 \$12626 VDD sg13g2_dfrbpq_1
* cell instance $43730 r0 *1 36,336.42
X$43730 VSS \$23517 \$23045 \$22906 \$24039 VDD sg13g2_dfrbpq_1
* cell instance $43731 r0 *1 83.04,200.34
X$43731 VSS \$11567 \$13300 \$13724 \$12289 VDD sg13g2_dfrbpq_1
* cell instance $43732 r0 *1 207.36,109.62
X$43732 VSS \$6790 \$6794 \$7009 \$6432 VDD sg13g2_dfrbpq_1
* cell instance $43733 r0 *1 337.92,192.78
X$43733 VSS \$12564 \$13853 \$13248 \$12321 VDD sg13g2_dfrbpq_1
* cell instance $43734 r0 *1 205.44,230.58
X$43734 VSS \$15947 \$16309 \$16306 \$14809 VDD sg13g2_dfrbpq_1
* cell instance $43735 r0 *1 242.4,343.98
X$43735 VSS \$24764 \$24545 \$24614 \$23122 VDD sg13g2_dfrbpq_1
* cell instance $43736 r0 *1 50.4,306.18
X$43736 VSS \$22165 \$22556 \$20569 \$19978 VDD sg13g2_dfrbpq_1
* cell instance $43737 r0 *1 239.52,336.42
X$43737 VSS \$24764 \$24611 \$24924 \$23122 VDD sg13g2_dfrbpq_1
* cell instance $43738 r0 *1 25.44,313.74
X$43738 VSS \$23002 \$22443 \$23197 \$21534 VDD sg13g2_dfrbpq_1
* cell instance $43739 r0 *1 48.96,336.42
X$43739 VSS \$23652 \$22652 \$23084 \$23087 VDD sg13g2_dfrbpq_1
* cell instance $43740 r0 *1 9.6,230.58
X$43740 VSS \$15633 \$16125 \$15915 \$15624 VDD sg13g2_dfrbpq_1
* cell instance $43741 r0 *1 59.04,185.22
X$43741 VSS \$11567 \$12286 \$11442 \$12289 VDD sg13g2_dfrbpq_1
* cell instance $43742 r0 *1 12.48,313.74
X$43742 VSS \$21530 \$23070 \$22368 \$21534 VDD sg13g2_dfrbpq_1
* cell instance $43743 r0 *1 213.12,86.94
X$43743 VSS \$3326 \$3723 \$3033 \$3725 VDD sg13g2_dfrbpq_1
* cell instance $43744 r0 *1 23.04,79.38
X$43744 VSS \$3291 \$4424 \$4977 \$1384 VDD sg13g2_dfrbpq_1
* cell instance $43745 r0 *1 17.76,56.7
X$43745 VSS \$2197 \$3480 \$3289 \$1384 VDD sg13g2_dfrbpq_1
* cell instance $43746 r0 *1 41.28,343.98
X$43746 VSS \$23002 \$24980 \$24934 \$23087 VDD sg13g2_dfrbpq_1
* cell instance $43747 r0 *1 237.12,49.14
X$43747 VSS \$599 \$2239 \$1206 \$1459 VDD sg13g2_dfrbpq_1
* cell instance $43748 r0 *1 10.08,71.82
X$43748 VSS \$3291 \$3681 \$3679 \$1384 VDD sg13g2_dfrbpq_1
* cell instance $43749 r0 *1 23.04,336.42
X$43749 VSS \$24040 \$22606 \$24418 \$24039 VDD sg13g2_dfrbpq_1
* cell instance $43750 r0 *1 122.88,26.46
X$43750 VSS \$1431 \$458 \$154 \$79 VDD sg13g2_dfrbpq_1
* cell instance $43751 r0 *1 109.92,26.46
X$43751 VSS \$29 \$1089 \$909 \$79 VDD sg13g2_dfrbpq_1
* cell instance $43752 r0 *1 145.44,34.02
X$43752 VSS \$1314 \$1196 \$2359 \$79 VDD sg13g2_dfrbpq_1
* cell instance $43753 r0 *1 219.84,26.46
X$43753 VSS \$160 \$923 \$924 \$95 VDD sg13g2_dfrbpq_1
* cell instance $43754 r0 *1 110.88,41.58
X$43754 VSS \$1431 \$451 \$67 \$75 VDD sg13g2_dfrbpq_1
* cell instance $43755 r0 *1 9.6,336.42
X$43755 VSS \$24040 \$19889 \$22371 \$24039 VDD sg13g2_dfrbpq_1
* cell instance $43756 r0 *1 10.08,238.14
X$43756 VSS \$15633 \$16984 \$16868 \$15624 VDD sg13g2_dfrbpq_1
* cell instance $43757 r0 *1 108,34.02
X$43757 VSS \$976 \$1308 \$382 \$75 VDD sg13g2_dfrbpq_1
* cell instance $43758 r0 *1 108.96,11.34
X$43758 VSS \$29 \$76 \$204 \$75 VDD sg13g2_dfrbpq_1
* cell instance $43759 r0 *1 121.92,11.34
X$43759 VDD VSS \$77 \$215 sg13g2_inv_1
* cell instance $43760 r0 *1 205.92,49.14
X$43760 VSS \$1678 \$1782 \$1263 \$918 VDD sg13g2_dfrbpq_1
* cell instance $43761 r0 *1 225.12,56.7
X$43761 VSS \$1346 \$2869 \$2873 \$1459 VDD sg13g2_dfrbpq_1
* cell instance $43762 r0 *1 123.84,41.58
X$43762 VSS \$976 \$1866 \$1994 \$79 VDD sg13g2_dfrbpq_1
* cell instance $43763 r0 *1 226.56,41.58
X$43763 VSS \$599 \$1979 \$1905 \$1459 VDD sg13g2_dfrbpq_1
* cell instance $43764 r0 *1 219.84,11.34
X$43764 VSS \$160 \$93 \$189 \$95 VDD sg13g2_dfrbpq_1
* cell instance $43765 r0 *1 37.44,86.94
X$43765 VSS \$3291 \$4771 \$1376 \$3151 VDD sg13g2_dfrbpq_1
* cell instance $43766 r0 *1 250.08,49.14
X$43766 VSS \$1008 \$2384 \$2911 \$246 VDD sg13g2_dfrbpq_1
* cell instance $43767 r0 *1 10.08,18.9
X$43767 VSS \$223 \$510 \$446 \$226 VDD sg13g2_dfrbpq_1
* cell instance $43768 r0 *1 236.16,79.38
X$43768 VSS \$1012 \$3392 \$4359 \$3177 VDD sg13g2_dfrbpq_1
* cell instance $43769 r0 *1 139.2,230.58
X$43769 VSS \$15649 \$16136 \$16491 \$16506 VDD sg13g2_dfrbpq_1
* cell instance $43770 r0 *1 135.36,223.02
X$43770 VSS \$15649 \$15644 \$15620 \$13170 VDD sg13g2_dfrbpq_1
* cell instance $43771 r0 *1 127.2,200.34
X$43771 VSS \$13735 \$12290 \$11552 \$11472 VDD sg13g2_dfrbpq_1
* cell instance $43772 r0 *1 123.84,11.34
X$43772 VSS \$29 \$31 \$78 \$79 VDD sg13g2_dfrbpq_1
* cell instance $43773 r0 *1 243.84,132.3
X$43773 VSS \$5751 \$8456 \$8793 \$6443 VDD sg13g2_dfrbpq_1
* cell instance $43774 r0 *1 227.04,192.78
X$43774 VSS \$12681 \$13470 \$13102 \$12538 VDD sg13g2_dfrbpq_1
* cell instance $43775 r0 *1 90.24,298.62
X$43775 VSS \$20917 \$20913 \$20995 \$19978 VDD sg13g2_dfrbpq_1
* cell instance $43776 r0 *1 95.04,291.06
X$43776 VSS \$19906 \$20746 \$19489 \$19978 VDD sg13g2_dfrbpq_1
* cell instance $43777 r0 *1 31.2,268.38
X$43777 VSS \$19647 \$20651 \$20745 \$19646 VDD sg13g2_dfrbpq_1
* cell instance $43778 r0 *1 215.52,215.46
X$43778 VSS \$13700 \$14812 \$15048 \$12538 VDD sg13g2_dfrbpq_1
* cell instance $43779 r0 *1 90.24,321.3
X$43779 VSS \$23657 \$22858 \$20569 \$22565 VDD sg13g2_dfrbpq_1
* cell instance $43780 r0 *1 142.56,268.38
X$43780 VSS \$19663 \$20005 \$19819 \$19658 VDD sg13g2_dfrbpq_1
* cell instance $43781 r0 *1 10.08,34.02
X$43781 VSS \$897 \$1477 \$1382 \$1384 VDD sg13g2_dfrbpq_1
* cell instance $43782 r0 *1 86.4,343.98
X$43782 VSS \$23657 \$23767 \$25086 \$22565 VDD sg13g2_dfrbpq_1
* cell instance $43783 r0 *1 160.8,253.26
X$43783 VSS \$17050 \$17830 \$17832 \$16506 VDD sg13g2_dfrbpq_1
* cell instance $43784 r0 *1 163.68,260.82
X$43784 VSS \$19663 \$18282 \$19835 \$16506 VDD sg13g2_dfrbpq_1
* cell instance $43785 r0 *1 277.92,321.3
X$43785 VSS \$22589 \$21079 \$23489 \$20682 VDD sg13g2_dfrbpq_1
* cell instance $43786 r0 *1 165.6,283.5
X$43786 VSS \$21041 \$18638 \$21040 \$20924 VDD sg13g2_dfrbpq_1
* cell instance $43787 r0 *1 30.72,41.58
X$43787 VSS \$897 \$1756 \$2318 \$1384 VDD sg13g2_dfrbpq_1
* cell instance $43788 r0 *1 11.52,26.46
X$43788 VSS \$223 \$271 \$267 \$226 VDD sg13g2_dfrbpq_1
* cell instance $43789 r0 *1 162.72,275.94
X$43789 VSS \$19663 \$20663 \$20521 \$20447 VDD sg13g2_dfrbpq_1
* cell instance $43790 r0 *1 24,34.02
X$43790 VSS \$897 \$2721 \$1292 \$226 VDD sg13g2_dfrbpq_1
* cell instance $43791 r0 *1 164.64,34.02
X$43791 VSS \$1314 \$1003 \$1875 \$83 VDD sg13g2_dfrbpq_1
* cell instance $43792 r0 *1 163.2,41.58
X$43792 VSS \$1775 \$434 \$154 \$83 VDD sg13g2_dfrbpq_1
* cell instance $43793 r0 *1 148.8,26.46
X$43793 VSS \$52 \$462 \$204 \$83 VDD sg13g2_dfrbpq_1
* cell instance $43794 r0 *1 163.68,26.46
X$43794 VSS \$52 \$87 \$78 \$83 VDD sg13g2_dfrbpq_1
* cell instance $43795 r0 *1 337.92,185.22
X$43795 VSS \$12564 \$11531 \$12384 \$12321 VDD sg13g2_dfrbpq_1
* cell instance $43796 r0 *1 150.24,41.58
X$43796 VSS \$1314 \$1871 \$909 \$83 VDD sg13g2_dfrbpq_1
* cell instance $43797 r0 *1 323.52,321.3
X$43797 VSS \$22721 \$23350 \$23564 \$22192 VDD sg13g2_dfrbpq_1
* cell instance $43798 r0 *1 74.88,321.3
X$43798 VSS \$22562 \$23524 \$23386 \$22565 VDD sg13g2_dfrbpq_1
* cell instance $43799 r0 *1 84.48,207.9
X$43799 VSS \$14202 \$13129 \$11584 \$12289 VDD sg13g2_dfrbpq_1
* cell instance $43800 r0 *1 10.08,86.94
X$43800 VSS \$4974 \$4833 \$4759 \$3151 VDD sg13g2_dfrbpq_1
* cell instance $43801 r0 *1 90.24,245.7
X$43801 VSS \$17415 \$16779 \$15623 \$14322 VDD sg13g2_dfrbpq_1
* cell instance $43802 r0 *1 245.76,64.26
X$43802 VSS \$1012 \$1323 \$1263 \$1459 VDD sg13g2_dfrbpq_1
* cell instance $43803 r0 *1 10.08,79.38
X$43803 VSS \$3291 \$4268 \$2731 \$3151 VDD sg13g2_dfrbpq_1
* cell instance $43804 r0 *1 77.28,41.58
X$43804 VSS \$534 \$196 \$227 \$1412 VDD sg13g2_dfrbpq_1
* cell instance $43805 r0 *1 256.8,132.3
X$43805 VSS \$7826 \$8457 \$8820 \$6443 VDD sg13g2_dfrbpq_1
* cell instance $43806 r0 *1 238.08,56.7
X$43806 VSS \$1783 \$2957 \$2909 \$1459 VDD sg13g2_dfrbpq_1
* cell instance $43807 r0 *1 66.72,11.34
X$43807 VSS \$69 \$77 \$71 \$149 VDD sg13g2_dfrbpq_1
* cell instance $43808 r0 *1 324.96,313.74
X$43808 VSS \$22595 \$22736 \$23179 \$22192 VDD sg13g2_dfrbpq_1
* cell instance $43809 r0 *1 297.12,313.74
X$43809 VSS \$22595 \$17471 \$23166 \$22724 VDD sg13g2_dfrbpq_1
* cell instance $43810 r0 *1 73.92,26.46
X$43810 VSS \$73 \$452 \$67 \$149 VDD sg13g2_dfrbpq_1
* cell instance $43811 r0 *1 67.68,18.9
X$43811 VSS \$69 \$973 \$382 \$149 VDD sg13g2_dfrbpq_1
* cell instance $43812 r0 *1 337.92,200.34
X$43812 VSS \$13239 \$13858 \$13711 \$12321 VDD sg13g2_dfrbpq_1
* cell instance $43813 r0 *1 247.68,124.74
X$43813 VSS \$5751 \$8030 \$7009 \$6443 VDD sg13g2_dfrbpq_1
* cell instance $43814 r0 *1 90.24,268.38
X$43814 VSS \$19899 \$19982 \$18735 \$19978 VDD sg13g2_dfrbpq_1
* cell instance $43815 r0 *1 90.24,306.18
X$43815 VSS \$22562 \$20912 \$21679 \$22565 VDD sg13g2_dfrbpq_1
* cell instance $43816 r0 *1 309.6,343.98
X$43816 VSS \$24627 \$24273 \$24774 \$22724 VDD sg13g2_dfrbpq_1
* cell instance $43817 r0 *1 312,275.94
X$43817 VSS \$19477 \$18008 \$20364 \$19691 VDD sg13g2_dfrbpq_1
* cell instance $43818 r0 *1 96,11.34
X$43818 VSS \$29 \$81 \$74 \$75 VDD sg13g2_dfrbpq_1
* cell instance $43819 r0 *1 62.88,268.38
X$43819 VSS \$19899 \$20097 \$18790 \$15634 VDD sg13g2_dfrbpq_1
* cell instance $43820 r0 *1 84.48,313.74
X$43820 VSS \$22562 \$23097 \$23057 \$22565 VDD sg13g2_dfrbpq_1
* cell instance $43821 r0 *1 239.04,86.94
X$43821 VSS \$3920 \$3175 \$2563 \$3177 VDD sg13g2_dfrbpq_1
* cell instance $43822 r0 *1 311.04,298.62
X$43822 VSS \$19514 \$20361 \$21725 \$22192 VDD sg13g2_dfrbpq_1
* cell instance $43823 r0 *1 237.12,109.62
X$43823 VSS \$5751 \$6818 \$6976 \$3177 VDD sg13g2_dfrbpq_1
* cell instance $43824 r0 *1 337.92,313.74
X$43824 VSS \$22595 \$22899 \$23189 \$22192 VDD sg13g2_dfrbpq_1
* cell instance $43825 r0 *1 312.96,336.42
X$43825 VSS \$24627 \$23717 \$24650 \$22724 VDD sg13g2_dfrbpq_1
* cell instance $43826 r0 *1 34.08,11.34
X$43826 VSS \$68 \$150 \$67 \$226 VDD sg13g2_dfrbpq_1
* cell instance $43827 r0 *1 252.96,56.7
X$43827 VSS \$1783 \$3048 \$2826 \$1459 VDD sg13g2_dfrbpq_1
* cell instance $43828 r0 *1 256.8,86.94
X$43828 VSS \$2758 \$3932 \$5873 \$1459 VDD sg13g2_dfrbpq_1
* cell instance $43829 r0 *1 269.76,86.94
X$43829 VSS VDD \$4949 \$3521 \$3960 sg13g2_nor2b_1
* cell instance $43830 r0 *1 249.12,79.38
X$43830 VSS \$1012 \$3744 \$4366 \$1459 VDD sg13g2_dfrbpq_1
* cell instance $43831 r0 *1 305.76,291.06
X$43831 VSS \$19514 \$21456 \$21741 \$19691 VDD sg13g2_dfrbpq_1
* cell instance $43832 r0 *1 71.52,343.98
X$43832 VSS \$23657 \$24989 \$23091 \$22565 VDD sg13g2_dfrbpq_1
* cell instance $43833 r0 *1 149.76,321.3
X$43833 VSS \$22264 \$22571 \$23341 \$21830 VDD sg13g2_dfrbpq_1
* cell instance $43834 r0 *1 167.04,336.42
X$43834 VSS \$23677 \$24242 \$24239 \$23108 VDD sg13g2_dfrbpq_1
* cell instance $43835 r0 *1 154.08,336.42
X$43835 VSS \$23677 \$23510 \$24235 \$23108 VDD sg13g2_dfrbpq_1
* cell instance $43836 r0 *1 156.96,343.98
X$43836 VSS \$22120 \$25137 \$25003 \$21830 VDD sg13g2_dfrbpq_1
* cell instance $43837 r0 *1 97.92,86.94
X$43837 VSS \$4174 \$3696 \$3289 \$3156 VDD sg13g2_dfrbpq_1
* cell instance $43838 r0 *1 102.24,79.38
X$43838 VSS \$4174 \$4302 \$3152 \$3156 VDD sg13g2_dfrbpq_1
* cell instance $43839 r0 *1 169.92,343.98
X$43839 VSS \$22120 \$24754 \$24907 \$21830 VDD sg13g2_dfrbpq_1
* cell instance $43840 r0 *1 215.52,298.62
X$43840 VSS \$20382 \$19327 \$22129 \$20459 VDD sg13g2_dfrbpq_1
* cell instance $43841 r0 *1 193.92,313.74
X$43841 VSS \$22678 \$20532 \$23011 \$22575 VDD sg13g2_dfrbpq_1
* cell instance $43842 r0 *1 72.48,328.86
X$43842 VSS \$23657 \$23979 \$24129 \$22565 VDD sg13g2_dfrbpq_1
* cell instance $43843 r0 *1 10.08,253.26
X$43843 VSS \$17640 \$18861 \$18725 \$15624 VDD sg13g2_dfrbpq_1
* cell instance $43844 r0 *1 284.16,207.9
X$43844 VSS \$13617 \$14068 \$14409 \$12554 VDD sg13g2_dfrbpq_1
* cell instance $43845 r0 *1 297.6,223.02
X$43845 VSS \$15567 \$15385 \$15583 \$15972 VDD sg13g2_dfrbpq_1
* cell instance $43846 r0 *1 250.08,109.62
X$43846 VSS \$5413 \$7193 \$5402 \$6443 VDD sg13g2_dfrbpq_1
* cell instance $43847 r0 *1 250.56,321.3
X$43847 VSS \$23451 \$15062 \$23309 \$23122 VDD sg13g2_dfrbpq_1
* cell instance $43848 r0 *1 227.04,283.5
X$43848 VSS \$20038 \$20456 \$20777 \$20459 VDD sg13g2_dfrbpq_1
* cell instance $43849 r0 *1 214.56,313.74
X$43849 VSS \$22678 \$23125 \$23053 \$23122 VDD sg13g2_dfrbpq_1
* cell instance $43850 r0 *1 56.16,207.9
X$43850 VSS \$14202 \$14012 \$12881 \$12289 VDD sg13g2_dfrbpq_1
* cell instance $43851 r0 *1 14.88,260.82
X$43851 VSS \$19394 \$19491 \$19489 \$15624 VDD sg13g2_dfrbpq_1
* cell instance $43852 r0 *1 219.84,343.98
X$43852 VSS \$23451 \$25021 \$24397 \$25177 VDD sg13g2_dfrbpq_1
* cell instance $43853 r0 *1 74.88,336.42
X$43853 VSS \$23657 \$24644 \$24320 \$22565 VDD sg13g2_dfrbpq_1
* cell instance $43854 r0 *1 156,71.82
X$43854 VSS \$3318 \$2890 \$2115 \$2900 VDD sg13g2_dfrbpq_1
* cell instance $43855 r0 *1 221.28,336.42
X$43855 VSS \$23451 \$24761 \$25020 \$23832 VDD sg13g2_dfrbpq_1
* cell instance $43856 r0 *1 253.44,102.06
X$43856 VSS \$5413 \$4807 \$3506 \$6443 VDD sg13g2_dfrbpq_1
* cell instance $43857 r0 *1 149.76,11.34
X$43857 VSS \$52 \$84 \$709 \$83 VDD sg13g2_dfrbpq_1
* cell instance $43858 r0 *1 138.72,328.86
X$43858 VSS \$24057 \$23673 \$23915 \$23104 VDD sg13g2_dfrbpq_1
* cell instance $43859 r0 *1 97.44,313.74
X$43859 VSS \$22481 \$23609 \$22922 \$21825 VDD sg13g2_dfrbpq_1
* cell instance $43860 r0 *1 335.52,343.98
X$43860 VSS \$24627 \$24780 \$24626 \$22192 VDD sg13g2_dfrbpq_1
* cell instance $43861 r0 *1 111.36,313.74
X$43861 VSS \$22481 \$20516 \$23257 \$21825 VDD sg13g2_dfrbpq_1
* cell instance $43862 r0 *1 56.16,343.98
X$43862 VSS \$23652 \$22915 \$22373 \$23087 VDD sg13g2_dfrbpq_1
* cell instance $43863 r0 *1 133.44,291.06
X$43863 VSS \$21696 \$20519 \$21799 \$19658 VDD sg13g2_dfrbpq_1
* cell instance $43864 r0 *1 164.16,56.7
X$43864 VSS \$2614 \$2901 \$1994 \$2900 VDD sg13g2_dfrbpq_1
* cell instance $43865 r0 *1 116.16,56.7
X$43865 VSS \$2611 \$2733 \$2115 \$75 VDD sg13g2_dfrbpq_1
* cell instance $43866 r0 *1 116.16,71.82
X$43866 VSS \$2611 \$3709 \$3501 \$3162 VDD sg13g2_dfrbpq_1
* cell instance $43867 r0 *1 110.88,64.26
X$43867 VSS \$2611 \$2879 \$2318 \$75 VDD sg13g2_dfrbpq_1
* cell instance $43868 r0 *1 61.44,215.46
X$43868 VSS \$14202 \$14784 \$13715 \$14322 VDD sg13g2_dfrbpq_1
* cell instance $43869 r0 *1 8.64,200.34
X$43869 VSS \$11991 \$13856 \$5133 \$12626 VDD sg13g2_dfrbpq_1
* cell instance $43870 r0 *1 137.76,336.42
X$43870 VSS \$24057 \$23618 \$23621 \$23104 VDD sg13g2_dfrbpq_1
* cell instance $43871 r0 *1 70.08,192.78
X$43871 VSS \$11567 \$13139 \$12092 \$12289 VDD sg13g2_dfrbpq_1
* cell instance $43872 r0 *1 188.64,109.62
X$43872 VSS \$5634 \$6590 \$5390 \$6432 VDD sg13g2_dfrbpq_1
* cell instance $43873 r0 *1 140.64,313.74
X$43873 VSS \$22264 \$23411 \$22945 \$21830 VDD sg13g2_dfrbpq_1
* cell instance $43874 r0 *1 127.2,306.18
X$43874 VSS \$22481 \$21924 \$20225 \$21825 VDD sg13g2_dfrbpq_1
* cell instance $43875 r0 *1 283.68,215.46
X$43875 VSS \$13617 \$14422 \$15071 \$13206 VDD sg13g2_dfrbpq_1
* cell instance $43876 r0 *1 130.08,283.5
X$43876 VSS \$19906 \$19983 \$18735 \$19658 VDD sg13g2_dfrbpq_1
* cell instance $43877 r0 *1 293.28,185.22
X$43877 VSS \$12313 \$11714 \$12552 \$12554 VDD sg13g2_dfrbpq_1
* cell instance $43878 r0 *1 15.84,192.78
X$43878 VSS \$11991 \$13456 \$12881 \$12626 VDD sg13g2_dfrbpq_1
* cell instance $43879 r0 *1 127.68,313.74
X$43879 VSS \$22667 \$22326 \$22809 \$23104 VDD sg13g2_dfrbpq_1
* cell instance $43880 r0 *1 61.92,336.42
X$43880 VSS \$23652 \$24310 \$23244 \$23087 VDD sg13g2_dfrbpq_1
* cell instance $43881 r0 *1 153.6,313.74
X$43881 VSS \$23009 \$19205 \$22674 \$23108 VDD sg13g2_dfrbpq_1
* cell instance $43882 r0 *1 168,313.74
X$43882 VSS \$23009 \$20665 \$22394 \$21830 VDD sg13g2_dfrbpq_1
* cell instance $43883 r0 *1 217.44,291.06
X$43883 VSS \$20038 \$21519 \$21424 \$20459 VDD sg13g2_dfrbpq_1
* cell instance $43884 r0 *1 150.72,64.26
X$43884 VSS \$2614 \$3312 \$3321 \$2900 VDD sg13g2_dfrbpq_1
* cell instance $43885 r0 *1 135.36,79.38
X$43885 VSS \$3721 \$2886 \$3023 \$3162 VDD sg13g2_dfrbpq_1
* cell instance $43886 r0 *1 147.84,49.14
X$43886 VSS \$1314 \$1261 \$382 \$83 VDD sg13g2_dfrbpq_1
* cell instance $43887 r0 *1 122.88,49.14
X$43887 VSS \$1431 \$538 \$972 \$75 VDD sg13g2_dfrbpq_1
* cell instance $43888 r0 *1 137.28,41.58
X$43888 VSS \$1314 \$1869 \$2061 \$79 VDD sg13g2_dfrbpq_1
* cell instance $43889 r0 *1 184.8,245.7
X$43889 VSS \$17437 \$17665 \$17849 \$14809 VDD sg13g2_dfrbpq_1
* cell instance $43890 r0 *1 48,321.3
X$43890 VSS \$23517 \$23378 \$23478 \$23087 VDD sg13g2_dfrbpq_1
* cell instance $43891 r0 *1 193.44,260.82
X$43891 VSS \$17437 \$15359 \$19306 \$14809 VDD sg13g2_dfrbpq_1
* cell instance $43892 r0 *1 194.88,253.26
X$43892 VSS \$17437 \$17846 \$18720 \$14809 VDD sg13g2_dfrbpq_1
* cell instance $43893 r0 *1 9.6,207.9
X$43893 VSS \$13576 \$14293 \$14441 \$12626 VDD sg13g2_dfrbpq_1
* cell instance $43894 r0 *1 128.64,86.94
X$43894 VSS \$4174 \$4922 \$5805 \$3162 VDD sg13g2_dfrbpq_1
* cell instance $43895 r0 *1 132.96,64.26
X$43895 VSS \$2614 \$2898 \$1719 \$3162 VDD sg13g2_dfrbpq_1
* cell instance $43896 r0 *1 228,124.74
X$43896 VSS \$7919 \$7821 \$8237 \$6443 VDD sg13g2_dfrbpq_1
* cell instance $43897 r0 *1 136.8,11.34
X$43897 VSS \$52 \$30 \$328 \$79 VDD sg13g2_dfrbpq_1
* cell instance $43898 r0 *1 135.84,26.46
X$43898 VSS \$52 \$987 \$74 \$79 VDD sg13g2_dfrbpq_1
* cell instance $43899 m0 *1 147.84,34.02
X$43899 VDD VSS \$733 \$2051 \$429 \$1122 \$1254 sg13g2_nor4_1
* cell instance $43900 r0 *1 76.32,56.7
X$43900 VSS \$2319 \$2945 \$3501 \$1412 VDD sg13g2_dfrbpq_1
* cell instance $43901 r0 *1 230.88,132.3
X$43901 VSS \$5751 \$8454 \$8269 \$6443 VDD sg13g2_dfrbpq_1
* cell instance $43902 r0 *1 50.4,291.06
X$43902 VSS \$20742 \$20994 \$21679 \$19646 VDD sg13g2_dfrbpq_1
* cell instance $43903 r0 *1 50.4,283.5
X$43903 VSS \$20742 \$20740 \$20995 \$19646 VDD sg13g2_dfrbpq_1
* cell instance $43904 r0 *1 332.16,336.42
X$43904 VSS \$24627 \$23956 \$24105 \$22192 VDD sg13g2_dfrbpq_1
* cell instance $43905 r0 *1 105.12,49.14
X$43905 VSS \$976 \$1298 \$1294 \$75 VDD sg13g2_dfrbpq_1
* cell instance $43906 r0 *1 156.48,86.94
X$43906 VSS \$3318 \$3897 \$3501 \$2900 VDD sg13g2_dfrbpq_1
* cell instance $43907 r0 *1 10.08,223.02
X$43907 VSS \$13576 \$15625 \$15623 \$15624 VDD sg13g2_dfrbpq_1
* cell instance $43908 r0 *1 131.52,71.82
X$43908 VSS \$4174 \$3711 \$3898 \$3162 VDD sg13g2_dfrbpq_1
* cell instance $43909 r0 *1 9.6,215.46
X$43909 VSS \$13576 \$14975 \$14919 \$12626 VDD sg13g2_dfrbpq_1
* cell instance $43910 r0 *1 151.2,79.38
X$43910 VSS \$3721 \$4331 \$5841 \$3162 VDD sg13g2_dfrbpq_1
* cell instance $43911 r0 *1 215.04,321.3
X$43911 VSS \$23451 \$23546 \$22875 \$23122 VDD sg13g2_dfrbpq_1
* cell instance $44720 r0 *1 8.16,11.34
X$44720 VDD VSS sg13g2_decap_8
* cell instance $44722 r0 *1 12.96,11.34
X$44722 VSS \$223 \$36 \$766 \$226 VDD sg13g2_dfrbpq_1
* cell instance $44725 m0 *1 315.84,253.26
X$44725 VDD VSS sg13g2_decap_8
* cell instance $44726 m0 *1 101.76,18.9
X$44726 VDD VSS sg13g2_decap_8
* cell instance $44727 m0 *1 264,306.18
X$44727 VDD VSS sg13g2_decap_8
* cell instance $44728 m0 *1 65.76,147.42
X$44728 VDD VSS sg13g2_decap_8
* cell instance $44729 m0 *1 69.12,147.42
X$44729 VDD VSS sg13g2_decap_8
* cell instance $44730 m0 *1 264.48,192.78
X$44730 VDD VSS sg13g2_decap_8
* cell instance $44731 m0 *1 221.76,238.14
X$44731 VDD VSS sg13g2_decap_8
* cell instance $44732 m0 *1 261.12,192.78
X$44732 VDD VSS sg13g2_decap_8
* cell instance $44733 m0 *1 228,162.54
X$44733 VDD VSS sg13g2_decap_8
* cell instance $44734 m0 *1 274.08,313.74
X$44734 VDD VSS sg13g2_decap_8
* cell instance $44735 m0 *1 315.36,223.02
X$44735 VDD VSS sg13g2_decap_8
* cell instance $44736 m0 *1 71.52,170.1
X$44736 VDD VSS sg13g2_decap_8
* cell instance $44737 m0 *1 70.56,177.66
X$44737 VDD VSS sg13g2_decap_8
* cell instance $44738 m0 *1 237.6,170.1
X$44738 VDD VSS sg13g2_decap_8
* cell instance $44739 m0 *1 314.4,200.34
X$44739 VDD VSS sg13g2_decap_8
* cell instance $44740 m0 *1 266.88,170.1
X$44740 VDD VSS sg13g2_decap_8
* cell instance $44741 m0 *1 263.52,170.1
X$44741 VDD VSS sg13g2_decap_8
* cell instance $44742 m0 *1 256.8,170.1
X$44742 VDD VSS sg13g2_decap_8
* cell instance $44743 m0 *1 255.36,306.18
X$44743 VDD VSS sg13g2_decap_8
* cell instance $44744 m0 *1 60,170.1
X$44744 VDD VSS sg13g2_decap_8
* cell instance $44745 m0 *1 105.12,18.9
X$44745 VDD VSS sg13g2_decap_8
* cell instance $44746 m0 *1 315.36,268.38
X$44746 VDD VSS sg13g2_decap_8
* cell instance $44747 m0 *1 73.92,177.66
X$44747 VDD VSS sg13g2_decap_8
* cell instance $44748 m0 *1 77.28,177.66
X$44748 VDD VSS sg13g2_decap_8
* cell instance $44749 m0 *1 78.24,170.1
X$44749 VDD VSS sg13g2_decap_8
* cell instance $44750 m0 *1 74.88,170.1
X$44750 VDD VSS sg13g2_decap_8
* cell instance $44751 m0 *1 8.16,162.54
X$44751 VDD VSS sg13g2_decap_8
* cell instance $44752 m0 *1 312.48,253.26
X$44752 VDD VSS sg13g2_decap_8
* cell instance $44753 m0 *1 260.16,170.1
X$44753 VDD VSS sg13g2_decap_8
* cell instance $44754 m0 *1 235.68,238.14
X$44754 VDD VSS sg13g2_decap_8
* cell instance $44755 m0 *1 39.84,147.42
X$44755 VDD VSS sg13g2_decap_8
* cell instance $44756 m0 *1 266.4,298.62
X$44756 VDD VSS sg13g2_decap_8
* cell instance $44757 m0 *1 229.44,306.18
X$44757 VDD VSS sg13g2_decap_8
* cell instance $44758 m0 *1 39.36,154.98
X$44758 VDD VSS sg13g2_decap_8
* cell instance $44759 m0 *1 263.04,298.62
X$44759 VDD VSS sg13g2_decap_8
* cell instance $44760 m0 *1 25.44,177.66
X$44760 VDD VSS sg13g2_decap_8
* cell instance $44761 m0 *1 203.52,223.02
X$44761 VDD VSS sg13g2_decap_8
* cell instance $44762 m0 *1 245.28,313.74
X$44762 VDD VSS sg13g2_decap_8
* cell instance $44763 m0 *1 46.08,154.98
X$44763 VDD VSS sg13g2_decap_8
* cell instance $44764 m0 *1 42.72,154.98
X$44764 VDD VSS sg13g2_decap_8
* cell instance $44765 m0 *1 228.48,313.74
X$44765 VDD VSS sg13g2_decap_8
* cell instance $44766 m0 *1 133.92,18.9
X$44766 VDD VSS sg13g2_decap_8
* cell instance $44767 m0 *1 260.64,139.86
X$44767 VDD VSS sg13g2_decap_8
* cell instance $44768 m0 *1 281.76,313.74
X$44768 VDD VSS sg13g2_decap_8
* cell instance $44769 m0 *1 11.52,162.54
X$44769 VDD VSS sg13g2_decap_8
* cell instance $44770 m0 *1 30.72,162.54
X$44770 VDD VSS sg13g2_decap_8
* cell instance $44771 m0 *1 28.8,177.66
X$44771 VDD VSS sg13g2_decap_8
* cell instance $44772 m0 *1 29.28,154.98
X$44772 VDD VSS sg13g2_decap_8
* cell instance $44773 m0 *1 34.08,162.54
X$44773 VDD VSS sg13g2_decap_8
* cell instance $44774 m0 *1 36,154.98
X$44774 VDD VSS sg13g2_decap_8
* cell instance $44775 m0 *1 46.56,185.22
X$44775 VDD VSS sg13g2_decap_8
* cell instance $44776 m0 *1 37.44,162.54
X$44776 VDD VSS sg13g2_decap_8
* cell instance $44777 m0 *1 33.6,170.1
X$44777 VDD VSS sg13g2_decap_8
* cell instance $44778 m0 *1 71.52,18.9
X$44778 VDD VSS sg13g2_decap_8
* cell instance $44779 m0 *1 43.2,185.22
X$44779 VDD VSS sg13g2_decap_8
* cell instance $44780 m0 *1 77.28,275.94
X$44780 VDD VSS sg13g2_decap_8
* cell instance $44781 m0 *1 240.96,192.78
X$44781 VDD VSS sg13g2_decap_8
* cell instance $44782 m0 *1 266.4,139.86
X$44782 VDD VSS sg13g2_decap_8
* cell instance $44783 m0 *1 32.16,177.66
X$44783 VDD VSS sg13g2_decap_8
* cell instance $44784 m0 *1 180.48,275.94
X$44784 VDD VSS sg13g2_decap_8
* cell instance $44785 m0 *1 242.88,139.86
X$44785 VDD VSS sg13g2_decap_8
* cell instance $44786 m0 *1 40.8,162.54
X$44786 VDD VSS sg13g2_decap_8
* cell instance $44787 m0 *1 78.24,18.9
X$44787 VDD VSS sg13g2_decap_8
* cell instance $44788 m0 *1 74.88,18.9
X$44788 VDD VSS sg13g2_decap_8
* cell instance $44789 m0 *1 113.28,117.18
X$44789 VDD VSS sg13g2_decap_8
* cell instance $44790 m0 *1 116.64,117.18
X$44790 VDD VSS sg13g2_decap_8
* cell instance $44791 m0 *1 120,117.18
X$44791 VDD VSS sg13g2_decap_8
* cell instance $44792 m0 *1 317.28,238.14
X$44792 VDD VSS sg13g2_decap_8
* cell instance $44793 m0 *1 328.32,351.54
X$44793 VDD VSS sg13g2_decap_8
* cell instance $44794 m0 *1 124.8,132.3
X$44794 VDD VSS sg13g2_decap_8
* cell instance $44795 m0 *1 121.44,132.3
X$44795 VDD VSS sg13g2_decap_8
* cell instance $44796 m0 *1 11.52,139.86
X$44796 VDD VSS sg13g2_decap_8
* cell instance $44797 m0 *1 72,185.22
X$44797 VDD VSS sg13g2_decap_8
* cell instance $44798 m0 *1 134.4,124.74
X$44798 VDD VSS sg13g2_decap_8
* cell instance $44799 m0 *1 131.04,124.74
X$44799 VDD VSS sg13g2_decap_8
* cell instance $44800 m0 *1 80.64,253.26
X$44800 VDD VSS sg13g2_decap_8
* cell instance $44801 m0 *1 26.4,230.58
X$44801 VDD VSS sg13g2_decap_8
* cell instance $44802 m0 *1 11.52,185.22
X$44802 VDD VSS sg13g2_decap_8
* cell instance $44803 m0 *1 260.16,147.42
X$44803 VDD VSS sg13g2_decap_8
* cell instance $44804 m0 *1 331.68,351.54
X$44804 VDD VSS sg13g2_decap_8
* cell instance $44805 m0 *1 324.96,351.54
X$44805 VDD VSS sg13g2_decap_8
* cell instance $44806 m0 *1 71.04,260.82
X$44806 VDD VSS sg13g2_decap_8
* cell instance $44807 m0 *1 202.08,147.42
X$44807 VDD VSS sg13g2_decap_8
* cell instance $44808 m0 *1 216.96,162.54
X$44808 VDD VSS sg13g2_decap_8
* cell instance $44809 m0 *1 308.64,268.38
X$44809 VDD VSS sg13g2_decap_8
* cell instance $44810 m0 *1 197.76,162.54
X$44810 VDD VSS sg13g2_decap_8
* cell instance $44811 m0 *1 113.76,170.1
X$44811 VDD VSS sg13g2_decap_8
* cell instance $44812 m0 *1 106.08,154.98
X$44812 VDD VSS sg13g2_decap_8
* cell instance $44813 m0 *1 201.12,162.54
X$44813 VDD VSS sg13g2_decap_8
* cell instance $44814 m0 *1 283.68,283.5
X$44814 VDD VSS sg13g2_decap_8
* cell instance $44815 m0 *1 109.44,154.98
X$44815 VDD VSS sg13g2_decap_8
* cell instance $44816 m0 *1 71.52,238.14
X$44816 VDD VSS sg13g2_decap_8
* cell instance $44817 m0 *1 305.28,268.38
X$44817 VDD VSS sg13g2_decap_8
* cell instance $44818 m0 *1 299.04,260.82
X$44818 VDD VSS sg13g2_decap_8
* cell instance $44819 m0 *1 301.92,268.38
X$44819 VDD VSS sg13g2_decap_8
* cell instance $44820 m0 *1 75.36,185.22
X$44820 VDD VSS sg13g2_decap_8
* cell instance $44821 m0 *1 213.6,245.7
X$44821 VDD VSS sg13g2_decap_8
* cell instance $44822 m0 *1 294.72,298.62
X$44822 VDD VSS sg13g2_decap_8
* cell instance $44823 m0 *1 190.56,162.54
X$44823 VDD VSS sg13g2_decap_8
* cell instance $44824 m0 *1 266.88,147.42
X$44824 VDD VSS sg13g2_decap_8
* cell instance $44825 m0 *1 122.88,154.98
X$44825 VDD VSS sg13g2_decap_8
* cell instance $44826 m0 *1 263.52,147.42
X$44826 VDD VSS sg13g2_decap_8
* cell instance $44827 m0 *1 112.8,154.98
X$44827 VDD VSS sg13g2_decap_8
* cell instance $44828 m0 *1 165.6,109.62
X$44828 VDD VSS sg13g2_decap_8
* cell instance $44829 m0 *1 248.64,313.74
X$44829 VDD VSS sg13g2_decap_8
* cell instance $44830 m0 *1 8.16,298.62
X$44830 VDD VSS sg13g2_decap_8
* cell instance $44831 m0 *1 216.96,245.7
X$44831 VDD VSS sg13g2_decap_8
* cell instance $44832 m0 *1 234.24,177.66
X$44832 VDD VSS sg13g2_decap_8
* cell instance $44833 m0 *1 42.24,283.5
X$44833 VDD VSS sg13g2_decap_8
* cell instance $44834 m0 *1 228.48,238.14
X$44834 VDD VSS sg13g2_decap_8
* cell instance $44835 m0 *1 328.8,321.3
X$44835 VDD VSS sg13g2_decap_8
* cell instance $44836 m0 *1 73.92,139.86
X$44836 VDD VSS sg13g2_decap_8
* cell instance $44837 m0 *1 223.68,245.7
X$44837 VDD VSS sg13g2_decap_8
* cell instance $44838 m0 *1 332.16,321.3
X$44838 VDD VSS sg13g2_decap_8
* cell instance $44839 m0 *1 70.56,139.86
X$44839 VDD VSS sg13g2_decap_8
* cell instance $44840 m0 *1 14.88,139.86
X$44840 VDD VSS sg13g2_decap_8
* cell instance $44841 m0 *1 77.28,139.86
X$44841 VDD VSS sg13g2_decap_8
* cell instance $44842 m0 *1 37.44,139.86
X$44842 VDD VSS sg13g2_decap_8
* cell instance $44843 m0 *1 34.08,139.86
X$44843 VDD VSS sg13g2_decap_8
* cell instance $44844 m0 *1 32.64,154.98
X$44844 VDD VSS sg13g2_decap_8
* cell instance $44845 m0 *1 108.48,18.9
X$44845 VDD VSS sg13g2_decap_8
* cell instance $44846 m0 *1 318.24,351.54
X$44846 VDD VSS sg13g2_decap_8
* cell instance $44847 m0 *1 8.16,139.86
X$44847 VDD VSS sg13g2_decap_8
* cell instance $44848 m0 *1 49.44,154.98
X$44848 VDD VSS sg13g2_decap_8
* cell instance $44849 m0 *1 240.48,147.42
X$44849 VDD VSS sg13g2_decap_8
* cell instance $44850 m0 *1 243.84,147.42
X$44850 VDD VSS sg13g2_decap_8
* cell instance $44851 m0 *1 318.72,268.38
X$44851 VDD VSS sg13g2_decap_8
* cell instance $44852 m0 *1 158.4,132.3
X$44852 VDD VSS sg13g2_decap_8
* cell instance $44853 m0 *1 168,117.18
X$44853 VDD VSS sg13g2_decap_8
* cell instance $44854 m0 *1 151.2,117.18
X$44854 VDD VSS sg13g2_decap_8
* cell instance $44855 m0 *1 298.08,298.62
X$44855 VDD VSS sg13g2_decap_8
* cell instance $44856 m0 *1 322.08,268.38
X$44856 VDD VSS sg13g2_decap_8
* cell instance $44857 m0 *1 171.36,117.18
X$44857 VDD VSS sg13g2_decap_8
* cell instance $44858 m0 *1 23.04,230.58
X$44858 VDD VSS sg13g2_decap_8
* cell instance $44859 m0 *1 211.2,291.06
X$44859 VDD VSS sg13g2_decap_8
* cell instance $44860 m0 *1 151.2,132.3
X$44860 VDD VSS sg13g2_decap_8
* cell instance $44861 m0 *1 217.92,275.94
X$44861 VDD VSS sg13g2_decap_8
* cell instance $44862 m0 *1 147.84,132.3
X$44862 VDD VSS sg13g2_decap_8
* cell instance $44863 m0 *1 41.28,230.58
X$44863 VDD VSS sg13g2_decap_8
* cell instance $44864 m0 *1 237.12,147.42
X$44864 VDD VSS sg13g2_decap_8
* cell instance $44865 m0 *1 220.32,245.7
X$44865 VDD VSS sg13g2_decap_8
* cell instance $44866 m0 *1 43.2,275.94
X$44866 VDD VSS sg13g2_decap_8
* cell instance $44867 m0 *1 144.48,109.62
X$44867 VDD VSS sg13g2_decap_8
* cell instance $44868 m0 *1 324.48,343.98
X$44868 VDD VSS sg13g2_decap_8
* cell instance $44869 m0 *1 321.6,351.54
X$44869 VDD VSS sg13g2_decap_8
* cell instance $44870 m0 *1 67.2,275.94
X$44870 VDD VSS sg13g2_decap_8
* cell instance $44871 m0 *1 215.52,192.78
X$44871 VDD VSS sg13g2_decap_8
* cell instance $44872 m0 *1 184.32,200.34
X$44872 VDD VSS sg13g2_decap_8
* cell instance $44873 m0 *1 45.6,283.5
X$44873 VDD VSS sg13g2_decap_8
* cell instance $44874 m0 *1 26.4,86.94
X$44874 VDD VSS sg13g2_decap_8
* cell instance $44875 m0 *1 27.36,79.38
X$44875 VDD VSS sg13g2_decap_8
* cell instance $44876 m0 *1 225.12,238.14
X$44876 VDD VSS sg13g2_decap_8
* cell instance $44877 m0 *1 187.68,200.34
X$44877 VDD VSS sg13g2_decap_8
* cell instance $44878 m0 *1 30.72,117.18
X$44878 VDD VSS sg13g2_decap_8
* cell instance $44879 m0 *1 216.48,230.58
X$44879 VDD VSS sg13g2_decap_8
* cell instance $44880 m0 *1 29.76,86.94
X$44880 VDD VSS sg13g2_decap_8
* cell instance $44881 m0 *1 203.52,230.58
X$44881 VDD VSS sg13g2_decap_8
* cell instance $44882 m0 *1 33.12,86.94
X$44882 VDD VSS sg13g2_decap_8
* cell instance $44883 m0 *1 36.48,86.94
X$44883 VDD VSS sg13g2_decap_8
* cell instance $44884 m0 *1 37.44,94.5
X$44884 VDD VSS sg13g2_decap_8
* cell instance $44885 m0 *1 269.76,207.9
X$44885 VDD VSS sg13g2_decap_8
* cell instance $44886 m0 *1 269.76,245.7
X$44886 VDD VSS sg13g2_decap_8
* cell instance $44887 m0 *1 39.84,86.94
X$44887 VDD VSS sg13g2_decap_8
* cell instance $44888 m0 *1 26.4,56.7
X$44888 VDD VSS sg13g2_decap_8
* cell instance $44889 m0 *1 66.72,86.94
X$44889 VDD VSS sg13g2_decap_8
* cell instance $44890 m0 *1 63.36,86.94
X$44890 VDD VSS sg13g2_decap_8
* cell instance $44891 m0 *1 303.36,177.66
X$44891 VDD VSS sg13g2_decap_8
* cell instance $44892 m0 *1 259.2,275.94
X$44892 VDD VSS sg13g2_decap_8
* cell instance $44893 m0 *1 63.36,64.26
X$44893 VDD VSS sg13g2_decap_8
* cell instance $44894 m0 *1 66.72,64.26
X$44894 VDD VSS sg13g2_decap_8
* cell instance $44895 m0 *1 68.16,71.82
X$44895 VDD VSS sg13g2_decap_8
* cell instance $44896 m0 *1 218.4,200.34
X$44896 VDD VSS sg13g2_decap_8
* cell instance $44897 m0 *1 26.4,94.5
X$44897 VDD VSS sg13g2_decap_8
* cell instance $44898 m0 *1 67.68,283.5
X$44898 VDD VSS sg13g2_decap_8
* cell instance $44899 m0 *1 285.12,313.74
X$44899 VDD VSS sg13g2_decap_8
* cell instance $44900 m0 *1 154.56,34.02
X$44900 VDD VSS sg13g2_decap_8
* cell instance $44901 m0 *1 29.76,34.02
X$44901 VDD VSS sg13g2_decap_8
* cell instance $44902 m0 *1 193.44,223.02
X$44902 VDD VSS sg13g2_decap_8
* cell instance $44903 m0 *1 293.28,177.66
X$44903 VDD VSS sg13g2_decap_8
* cell instance $44904 m0 *1 26.4,34.02
X$44904 VDD VSS sg13g2_decap_8
* cell instance $44905 m0 *1 291.84,162.54
X$44905 VDD VSS sg13g2_decap_8
* cell instance $44906 m0 *1 63.84,275.94
X$44906 VDD VSS sg13g2_decap_8
* cell instance $44907 m0 *1 269.28,351.54
X$44907 VDD VSS sg13g2_decap_8
* cell instance $44908 m0 *1 23.04,56.7
X$44908 VDD VSS sg13g2_decap_8
* cell instance $44909 m0 *1 115.2,185.22
X$44909 VDD VSS sg13g2_decap_8
* cell instance $44910 m0 *1 33.12,185.22
X$44910 VDD VSS sg13g2_decap_8
* cell instance $44911 m0 *1 330.24,328.86
X$44911 VDD VSS sg13g2_decap_8
* cell instance $44912 m0 *1 197.76,200.34
X$44912 VDD VSS sg13g2_decap_8
* cell instance $44913 m0 *1 326.88,328.86
X$44913 VDD VSS sg13g2_decap_8
* cell instance $44914 m0 *1 34.56,64.26
X$44914 VDD VSS sg13g2_decap_8
* cell instance $44915 m0 *1 259.2,185.22
X$44915 VDD VSS sg13g2_decap_8
* cell instance $44916 m0 *1 195.36,192.78
X$44916 VDD VSS sg13g2_decap_8
* cell instance $44917 m0 *1 37.92,64.26
X$44917 VDD VSS sg13g2_decap_8
* cell instance $44918 m0 *1 31.2,64.26
X$44918 VDD VSS sg13g2_decap_8
* cell instance $44919 m0 *1 41.28,64.26
X$44919 VDD VSS sg13g2_decap_8
* cell instance $44920 m0 *1 142.56,18.9
X$44920 VDD VSS sg13g2_decap_8
* cell instance $44921 m0 *1 191.04,200.34
X$44921 VDD VSS sg13g2_decap_8
* cell instance $44922 m0 *1 200.16,223.02
X$44922 VDD VSS sg13g2_decap_8
* cell instance $44923 m0 *1 196.8,223.02
X$44923 VDD VSS sg13g2_decap_8
* cell instance $44924 m0 *1 145.92,18.9
X$44924 VDD VSS sg13g2_decap_8
* cell instance $44925 m0 *1 190.08,223.02
X$44925 VDD VSS sg13g2_decap_8
* cell instance $44926 m0 *1 44.64,64.26
X$44926 VDD VSS sg13g2_decap_8
* cell instance $44927 m0 *1 183.36,86.94
X$44927 VDD VSS sg13g2_decap_8
* cell instance $44928 m0 *1 194.4,200.34
X$44928 VDD VSS sg13g2_decap_8
* cell instance $44929 m0 *1 28.8,41.58
X$44929 VDD VSS sg13g2_decap_8
* cell instance $44930 m0 *1 34.08,79.38
X$44930 VDD VSS sg13g2_decap_8
* cell instance $44931 m0 *1 30.72,79.38
X$44931 VDD VSS sg13g2_decap_8
* cell instance $44932 m0 *1 43.68,79.38
X$44932 VDD VSS sg13g2_decap_8
* cell instance $44933 m0 *1 149.28,18.9
X$44933 VDD VSS sg13g2_decap_8
* cell instance $44934 m0 *1 240.96,230.58
X$44934 VDD VSS sg13g2_decap_8
* cell instance $44935 m0 *1 219.84,230.58
X$44935 VDD VSS sg13g2_decap_8
* cell instance $44936 m0 *1 23.04,86.94
X$44936 VDD VSS sg13g2_decap_8
* cell instance $44937 m0 *1 262.56,230.58
X$44937 VDD VSS sg13g2_decap_8
* cell instance $44938 m0 *1 23.04,94.5
X$44938 VDD VSS sg13g2_decap_8
* cell instance $44939 m0 *1 156,18.9
X$44939 VDD VSS sg13g2_decap_8
* cell instance $44940 m0 *1 192,192.78
X$44940 VDD VSS sg13g2_decap_8
* cell instance $44941 m0 *1 265.92,230.58
X$44941 VDD VSS sg13g2_decap_8
* cell instance $44942 m0 *1 269.28,177.66
X$44942 VDD VSS sg13g2_decap_8
* cell instance $44943 m0 *1 270.24,147.42
X$44943 VDD VSS sg13g2_decap_8
* cell instance $44944 m0 *1 259.2,230.58
X$44944 VDD VSS sg13g2_decap_8
* cell instance $44945 m0 *1 224.64,215.46
X$44945 VDD VSS sg13g2_decap_8
* cell instance $44946 m0 *1 276.48,177.66
X$44946 VDD VSS sg13g2_decap_8
* cell instance $44947 m0 *1 35.04,132.3
X$44947 VDD VSS sg13g2_decap_8
* cell instance $44948 m0 *1 31.68,132.3
X$44948 VDD VSS sg13g2_decap_8
* cell instance $44949 m0 *1 23.04,34.02
X$44949 VDD VSS sg13g2_decap_8
* cell instance $44950 m0 *1 38.4,132.3
X$44950 VDD VSS sg13g2_decap_8
* cell instance $44951 m0 *1 283.2,177.66
X$44951 VDD VSS sg13g2_decap_8
* cell instance $44952 m0 *1 286.56,177.66
X$44952 VDD VSS sg13g2_decap_8
* cell instance $44953 m0 *1 289.92,177.66
X$44953 VDD VSS sg13g2_decap_8
* cell instance $44954 m0 *1 261.6,207.9
X$44954 VDD VSS sg13g2_decap_8
* cell instance $44955 m0 *1 44.16,124.74
X$44955 VDD VSS sg13g2_decap_8
* cell instance $44956 m0 *1 40.8,124.74
X$44956 VDD VSS sg13g2_decap_8
* cell instance $44957 m0 *1 77.76,283.5
X$44957 VDD VSS sg13g2_decap_8
* cell instance $44958 m0 *1 241.44,268.38
X$44958 VDD VSS sg13g2_decap_8
* cell instance $44959 m0 *1 23.04,49.14
X$44959 VDD VSS sg13g2_decap_8
* cell instance $44960 m0 *1 239.52,275.94
X$44960 VDD VSS sg13g2_decap_8
* cell instance $44961 m0 *1 279.84,177.66
X$44961 VDD VSS sg13g2_decap_8
* cell instance $44962 m0 *1 23.04,109.62
X$44962 VDD VSS sg13g2_decap_8
* cell instance $44963 m0 *1 74.4,283.5
X$44963 VDD VSS sg13g2_decap_8
* cell instance $44964 m0 *1 237.6,192.78
X$44964 VDD VSS sg13g2_decap_8
* cell instance $44965 m0 *1 181.92,238.14
X$44965 VDD VSS sg13g2_decap_8
* cell instance $44966 m0 *1 236.16,275.94
X$44966 VDD VSS sg13g2_decap_8
* cell instance $44967 m0 *1 43.2,147.42
X$44967 VDD VSS sg13g2_decap_8
* cell instance $44968 m0 *1 28.8,109.62
X$44968 VDD VSS sg13g2_decap_8
* cell instance $44969 m0 *1 34.08,117.18
X$44969 VDD VSS sg13g2_decap_8
* cell instance $44970 m0 *1 27.36,117.18
X$44970 VDD VSS sg13g2_decap_8
* cell instance $44971 m0 *1 287.04,283.5
X$44971 VDD VSS sg13g2_decap_8
* cell instance $44972 m0 *1 73.92,275.94
X$44972 VDD VSS sg13g2_decap_8
* cell instance $44973 m0 *1 87.36,283.5
X$44973 VDD VSS sg13g2_decap_8
* cell instance $44974 m0 *1 240.48,291.06
X$44974 VDD VSS sg13g2_decap_8
* cell instance $44975 m0 *1 243.84,291.06
X$44975 VDD VSS sg13g2_decap_8
* cell instance $44976 m0 *1 22.56,185.22
X$44976 VDD VSS sg13g2_decap_8
* cell instance $44977 m0 *1 232.8,275.94
X$44977 VDD VSS sg13g2_decap_8
* cell instance $44978 m0 *1 275.52,154.98
X$44978 VDD VSS sg13g2_decap_8
* cell instance $44979 m0 *1 182.88,223.02
X$44979 VDD VSS sg13g2_decap_8
* cell instance $44980 m0 *1 60.48,275.94
X$44980 VDD VSS sg13g2_decap_8
* cell instance $44981 m0 *1 274.56,170.1
X$44981 VDD VSS sg13g2_decap_8
* cell instance $44982 m0 *1 74.4,291.06
X$44982 VDD VSS sg13g2_decap_8
* cell instance $44983 m0 *1 28.32,132.3
X$44983 VDD VSS sg13g2_decap_8
* cell instance $44984 m0 *1 43.68,49.14
X$44984 VDD VSS sg13g2_decap_8
* cell instance $44985 m0 *1 47.04,49.14
X$44985 VDD VSS sg13g2_decap_8
* cell instance $44986 m0 *1 39.84,275.94
X$44986 VDD VSS sg13g2_decap_8
* cell instance $44987 m0 *1 244.8,207.9
X$44987 VDD VSS sg13g2_decap_8
* cell instance $44988 m0 *1 258.24,207.9
X$44988 VDD VSS sg13g2_decap_8
* cell instance $44989 m0 *1 32.16,41.58
X$44989 VDD VSS sg13g2_decap_8
* cell instance $44990 m0 *1 35.52,41.58
X$44990 VDD VSS sg13g2_decap_8
* cell instance $44991 m0 *1 246.24,245.7
X$44991 VDD VSS sg13g2_decap_8
* cell instance $44992 m0 *1 33.12,275.94
X$44992 VDD VSS sg13g2_decap_8
* cell instance $44993 m0 *1 36.96,49.14
X$44993 VDD VSS sg13g2_decap_8
* cell instance $44994 m0 *1 228,207.9
X$44994 VDD VSS sg13g2_decap_8
* cell instance $44995 m0 *1 40.32,49.14
X$44995 VDD VSS sg13g2_decap_8
* cell instance $44996 m0 *1 296.64,177.66
X$44996 VDD VSS sg13g2_decap_8
* cell instance $44997 m0 *1 39.84,34.02
X$44997 VDD VSS sg13g2_decap_8
* cell instance $44998 m0 *1 70.08,86.94
X$44998 VDD VSS sg13g2_decap_8
* cell instance $44999 m0 *1 70.08,64.26
X$44999 VDD VSS sg13g2_decap_8
* cell instance $45000 m0 *1 73.44,64.26
X$45000 VDD VSS sg13g2_decap_8
* cell instance $45001 m0 *1 300,177.66
X$45001 VDD VSS sg13g2_decap_8
* cell instance $45002 m0 *1 249.6,268.38
X$45002 VDD VSS sg13g2_decap_8
* cell instance $45003 m0 *1 11.52,102.06
X$45003 VDD VSS sg13g2_decap_8
* cell instance $45004 m0 *1 8.16,102.06
X$45004 VDD VSS sg13g2_decap_8
* cell instance $45005 m0 *1 252.96,268.38
X$45005 VDD VSS sg13g2_decap_8
* cell instance $45006 m0 *1 40.32,102.06
X$45006 VDD VSS sg13g2_decap_8
* cell instance $45007 m0 *1 36.48,275.94
X$45007 VDD VSS sg13g2_decap_8
* cell instance $45008 m0 *1 43.2,34.02
X$45008 VDD VSS sg13g2_decap_8
* cell instance $45009 m0 *1 36.96,102.06
X$45009 VDD VSS sg13g2_decap_8
* cell instance $45010 m0 *1 84,283.5
X$45010 VDD VSS sg13g2_decap_8
* cell instance $45011 m0 *1 43.68,102.06
X$45011 VDD VSS sg13g2_decap_8
* cell instance $45012 m0 *1 180.96,200.34
X$45012 VDD VSS sg13g2_decap_8
* cell instance $45013 m0 *1 46.56,34.02
X$45013 VDD VSS sg13g2_decap_8
* cell instance $45014 m0 *1 36.48,34.02
X$45014 VDD VSS sg13g2_decap_8
* cell instance $45015 m0 *1 33.12,34.02
X$45015 VDD VSS sg13g2_decap_8
* cell instance $45016 m0 *1 255.84,223.02
X$45016 VDD VSS sg13g2_decap_8
* cell instance $45017 m0 *1 67.2,124.74
X$45017 VDD VSS sg13g2_decap_8
* cell instance $45018 m0 *1 33.6,49.14
X$45018 VDD VSS sg13g2_decap_8
* cell instance $45019 m0 *1 30.24,49.14
X$45019 VDD VSS sg13g2_decap_8
* cell instance $45020 m0 *1 256.32,268.38
X$45020 VDD VSS sg13g2_decap_8
* cell instance $45021 m0 *1 69.6,109.62
X$45021 VDD VSS sg13g2_decap_8
* cell instance $45022 m0 *1 78.72,117.18
X$45022 VDD VSS sg13g2_decap_8
* cell instance $45023 m0 *1 279.36,328.86
X$45023 VDD VSS sg13g2_decap_8
* cell instance $45024 m0 *1 313.92,283.5
X$45024 VDD VSS sg13g2_decap_8
* cell instance $45025 m0 *1 150.72,253.26
X$45025 VDD VSS sg13g2_decap_8
* cell instance $45026 m0 *1 161.76,260.82
X$45026 VDD VSS sg13g2_decap_8
* cell instance $45027 m0 *1 168.48,260.82
X$45027 VDD VSS sg13g2_decap_8
* cell instance $45028 m0 *1 279.36,351.54
X$45028 VDD VSS sg13g2_decap_8
* cell instance $45029 m0 *1 276,351.54
X$45029 VDD VSS sg13g2_decap_8
* cell instance $45030 m0 *1 286.08,351.54
X$45030 VDD VSS sg13g2_decap_8
* cell instance $45031 m0 *1 68.16,238.14
X$45031 VDD VSS sg13g2_decap_8
* cell instance $45032 m0 *1 165.12,260.82
X$45032 VDD VSS sg13g2_decap_8
* cell instance $45033 m0 *1 282.72,351.54
X$45033 VDD VSS sg13g2_decap_8
* cell instance $45034 m0 *1 164.16,268.38
X$45034 VDD VSS sg13g2_decap_8
* cell instance $45035 m0 *1 165.6,71.82
X$45035 VDD VSS sg13g2_decap_8
* cell instance $45036 m0 *1 246.72,328.86
X$45036 VDD VSS sg13g2_decap_8
* cell instance $45037 m0 *1 148.32,260.82
X$45037 VDD VSS sg13g2_decap_8
* cell instance $45038 m0 *1 314.88,351.54
X$45038 VDD VSS sg13g2_decap_8
* cell instance $45039 m0 *1 144.96,260.82
X$45039 VDD VSS sg13g2_decap_8
* cell instance $45040 m0 *1 177.12,260.82
X$45040 VDD VSS sg13g2_decap_8
* cell instance $45041 m0 *1 175.68,56.7
X$45041 VDD VSS sg13g2_decap_8
* cell instance $45042 m0 *1 84,298.62
X$45042 VDD VSS sg13g2_decap_8
* cell instance $45043 m0 *1 131.52,351.54
X$45043 VDD VSS sg13g2_decap_8
* cell instance $45044 m0 *1 284.16,336.42
X$45044 VDD VSS sg13g2_decap_8
* cell instance $45045 m0 *1 168.96,56.7
X$45045 VDD VSS sg13g2_decap_8
* cell instance $45046 m0 *1 75.84,192.78
X$45046 VDD VSS sg13g2_decap_8
* cell instance $45047 m0 *1 48.96,283.5
X$45047 VDD VSS sg13g2_decap_8
* cell instance $45048 m0 *1 88.32,192.78
X$45048 VDD VSS sg13g2_decap_8
* cell instance $45049 m0 *1 274.08,328.86
X$45049 VDD VSS sg13g2_decap_8
* cell instance $45050 m0 *1 149.76,230.58
X$45050 VDD VSS sg13g2_decap_8
* cell instance $45051 m0 *1 22.56,260.82
X$45051 VDD VSS sg13g2_decap_8
* cell instance $45052 m0 *1 25.92,260.82
X$45052 VDD VSS sg13g2_decap_8
* cell instance $45053 m0 *1 179.04,230.58
X$45053 VDD VSS sg13g2_decap_8
* cell instance $45054 m0 *1 120.96,230.58
X$45054 VDD VSS sg13g2_decap_8
* cell instance $45055 m0 *1 117.6,230.58
X$45055 VDD VSS sg13g2_decap_8
* cell instance $45056 m0 *1 138.24,351.54
X$45056 VDD VSS sg13g2_decap_8
* cell instance $45057 m0 *1 160.8,268.38
X$45057 VDD VSS sg13g2_decap_8
* cell instance $45058 m0 *1 158.4,260.82
X$45058 VDD VSS sg13g2_decap_8
* cell instance $45059 m0 *1 141.6,351.54
X$45059 VDD VSS sg13g2_decap_8
* cell instance $45060 m0 *1 130.56,260.82
X$45060 VDD VSS sg13g2_decap_8
* cell instance $45061 m0 *1 123.36,56.7
X$45061 VDD VSS sg13g2_decap_8
* cell instance $45062 m0 *1 144.48,56.7
X$45062 VDD VSS sg13g2_decap_8
* cell instance $45063 m0 *1 26.4,238.14
X$45063 VDD VSS sg13g2_decap_8
* cell instance $45064 m0 *1 317.76,200.34
X$45064 VDD VSS sg13g2_decap_8
* cell instance $45065 m0 *1 76.8,313.74
X$45065 VDD VSS sg13g2_decap_8
* cell instance $45066 m0 *1 141.12,56.7
X$45066 VDD VSS sg13g2_decap_8
* cell instance $45067 m0 *1 8.16,253.26
X$45067 VDD VSS sg13g2_decap_8
* cell instance $45068 m0 *1 151.68,260.82
X$45068 VDD VSS sg13g2_decap_8
* cell instance $45069 m0 *1 214.56,268.38
X$45069 VDD VSS sg13g2_decap_8
* cell instance $45070 m0 *1 28.8,268.38
X$45070 VDD VSS sg13g2_decap_8
* cell instance $45071 m0 *1 29.28,260.82
X$45071 VDD VSS sg13g2_decap_8
* cell instance $45072 m0 *1 290.4,283.5
X$45072 VDD VSS sg13g2_decap_8
* cell instance $45073 m0 *1 125.76,245.7
X$45073 VDD VSS sg13g2_decap_8
* cell instance $45074 m0 *1 322.56,223.02
X$45074 VDD VSS sg13g2_decap_8
* cell instance $45075 m0 *1 291.36,298.62
X$45075 VDD VSS sg13g2_decap_8
* cell instance $45076 m0 *1 81.12,245.7
X$45076 VDD VSS sg13g2_decap_8
* cell instance $45077 m0 *1 241.92,124.74
X$45077 VDD VSS sg13g2_decap_8
* cell instance $45078 m0 *1 100.32,260.82
X$45078 VDD VSS sg13g2_decap_8
* cell instance $45079 m0 *1 155.04,260.82
X$45079 VDD VSS sg13g2_decap_8
* cell instance $45080 m0 *1 265.92,351.54
X$45080 VDD VSS sg13g2_decap_8
* cell instance $45081 m0 *1 204,268.38
X$45081 VDD VSS sg13g2_decap_8
* cell instance $45082 m0 *1 172.32,56.7
X$45082 VDD VSS sg13g2_decap_8
* cell instance $45083 m0 *1 216.48,260.82
X$45083 VDD VSS sg13g2_decap_8
* cell instance $45084 m0 *1 149.28,238.14
X$45084 VDD VSS sg13g2_decap_8
* cell instance $45085 m0 *1 145.92,238.14
X$45085 VDD VSS sg13g2_decap_8
* cell instance $45086 m0 *1 229.44,328.86
X$45086 VDD VSS sg13g2_decap_8
* cell instance $45087 m0 *1 127.2,260.82
X$45087 VDD VSS sg13g2_decap_8
* cell instance $45088 m0 *1 289.44,351.54
X$45088 VDD VSS sg13g2_decap_8
* cell instance $45089 m0 *1 232.8,328.86
X$45089 VDD VSS sg13g2_decap_8
* cell instance $45090 m0 *1 171.84,238.14
X$45090 VDD VSS sg13g2_decap_8
* cell instance $45091 m0 *1 243.36,328.86
X$45091 VDD VSS sg13g2_decap_8
* cell instance $45092 m0 *1 32.16,268.38
X$45092 VDD VSS sg13g2_decap_8
* cell instance $45093 m0 *1 168.48,238.14
X$45093 VDD VSS sg13g2_decap_8
* cell instance $45094 m0 *1 178.56,238.14
X$45094 VDD VSS sg13g2_decap_8
* cell instance $45095 m0 *1 175.2,238.14
X$45095 VDD VSS sg13g2_decap_8
* cell instance $45096 m0 *1 272.64,351.54
X$45096 VDD VSS sg13g2_decap_8
* cell instance $45097 m0 *1 236.16,328.86
X$45097 VDD VSS sg13g2_decap_8
* cell instance $45098 m0 *1 103.68,291.06
X$45098 VDD VSS sg13g2_decap_8
* cell instance $45099 m0 *1 23.04,200.34
X$45099 VDD VSS sg13g2_decap_8
* cell instance $45100 m0 *1 41.28,238.14
X$45100 VDD VSS sg13g2_decap_8
* cell instance $45101 m0 *1 317.28,283.5
X$45101 VDD VSS sg13g2_decap_8
* cell instance $45102 m0 *1 320.64,283.5
X$45102 VDD VSS sg13g2_decap_8
* cell instance $45103 m0 *1 23.04,192.78
X$45103 VDD VSS sg13g2_decap_8
* cell instance $45104 m0 *1 156,283.5
X$45104 VDD VSS sg13g2_decap_8
* cell instance $45105 m0 *1 23.04,238.14
X$45105 VDD VSS sg13g2_decap_8
* cell instance $45106 m0 *1 179.04,56.7
X$45106 VDD VSS sg13g2_decap_8
* cell instance $45107 m0 *1 40.32,192.78
X$45107 VDD VSS sg13g2_decap_8
* cell instance $45108 m0 *1 39.84,200.34
X$45108 VDD VSS sg13g2_decap_8
* cell instance $45109 m0 *1 348.48,313.74
X$45109 VDD VSS sg13g2_decap_8
* cell instance $45110 m0 *1 347.04,291.06
X$45110 VDD VSS sg13g2_decap_8
* cell instance $45111 m0 *1 347.52,283.5
X$45111 VDD VSS sg13g2_decap_8
* cell instance $45112 m0 *1 153.12,275.94
X$45112 VDD VSS sg13g2_decap_8
* cell instance $45113 m0 *1 46.56,200.34
X$45113 VDD VSS sg13g2_decap_8
* cell instance $45114 m0 *1 43.2,200.34
X$45114 VDD VSS sg13g2_decap_8
* cell instance $45115 m0 *1 343.68,291.06
X$45115 VDD VSS sg13g2_decap_8
* cell instance $45116 m0 *1 36.96,192.78
X$45116 VDD VSS sg13g2_decap_8
* cell instance $45117 m0 *1 26.88,223.02
X$45117 VDD VSS sg13g2_decap_8
* cell instance $45118 m0 *1 29.76,200.34
X$45118 VDD VSS sg13g2_decap_8
* cell instance $45119 m0 *1 31.2,207.9
X$45119 VDD VSS sg13g2_decap_8
* cell instance $45120 m0 *1 27.36,215.46
X$45120 VDD VSS sg13g2_decap_8
* cell instance $45121 m0 *1 34.56,207.9
X$45121 VDD VSS sg13g2_decap_8
* cell instance $45122 m0 *1 326.4,306.18
X$45122 VDD VSS sg13g2_decap_8
* cell instance $45123 m0 *1 330.72,313.74
X$45123 VDD VSS sg13g2_decap_8
* cell instance $45124 m0 *1 70.56,275.94
X$45124 VDD VSS sg13g2_decap_8
* cell instance $45125 m0 *1 107.04,291.06
X$45125 VDD VSS sg13g2_decap_8
* cell instance $45126 m0 *1 43.68,223.02
X$45126 VDD VSS sg13g2_decap_8
* cell instance $45127 m0 *1 179.52,306.18
X$45127 VDD VSS sg13g2_decap_8
* cell instance $45128 m0 *1 176.16,306.18
X$45128 VDD VSS sg13g2_decap_8
* cell instance $45129 m0 *1 26.4,200.34
X$45129 VDD VSS sg13g2_decap_8
* cell instance $45130 m0 *1 33.6,223.02
X$45130 VDD VSS sg13g2_decap_8
* cell instance $45131 m0 *1 37.92,207.9
X$45131 VDD VSS sg13g2_decap_8
* cell instance $45132 m0 *1 41.28,207.9
X$45132 VDD VSS sg13g2_decap_8
* cell instance $45133 m0 *1 100.32,291.06
X$45133 VDD VSS sg13g2_decap_8
* cell instance $45134 m0 *1 295.2,321.3
X$45134 VDD VSS sg13g2_decap_8
* cell instance $45135 m0 *1 44.64,207.9
X$45135 VDD VSS sg13g2_decap_8
* cell instance $45136 m0 *1 125.76,94.5
X$45136 VDD VSS sg13g2_decap_8
* cell instance $45137 m0 *1 63.84,223.02
X$45137 VDD VSS sg13g2_decap_8
* cell instance $45138 m0 *1 67.2,223.02
X$45138 VDD VSS sg13g2_decap_8
* cell instance $45139 m0 *1 66.72,215.46
X$45139 VDD VSS sg13g2_decap_8
* cell instance $45140 m0 *1 63.36,215.46
X$45140 VDD VSS sg13g2_decap_8
* cell instance $45141 m0 *1 124.8,351.54
X$45141 VDD VSS sg13g2_decap_8
* cell instance $45142 m0 *1 134.88,351.54
X$45142 VDD VSS sg13g2_decap_8
* cell instance $45143 m0 *1 177.12,275.94
X$45143 VDD VSS sg13g2_decap_8
* cell instance $45144 m0 *1 105.6,283.5
X$45144 VDD VSS sg13g2_decap_8
* cell instance $45145 m0 *1 345.12,313.74
X$45145 VDD VSS sg13g2_decap_8
* cell instance $45146 m0 *1 66.72,200.34
X$45146 VDD VSS sg13g2_decap_8
* cell instance $45147 m0 *1 63.36,200.34
X$45147 VDD VSS sg13g2_decap_8
* cell instance $45148 m0 *1 191.52,71.82
X$45148 VDD VSS sg13g2_decap_8
* cell instance $45149 m0 *1 190.56,94.5
X$45149 VDD VSS sg13g2_decap_8
* cell instance $45150 m0 *1 69.12,192.78
X$45150 VDD VSS sg13g2_decap_8
* cell instance $45151 m0 *1 65.76,192.78
X$45151 VDD VSS sg13g2_decap_8
* cell instance $45152 m0 *1 342.24,298.62
X$45152 VDD VSS sg13g2_decap_8
* cell instance $45153 m0 *1 224.16,283.5
X$45153 VDD VSS sg13g2_decap_8
* cell instance $45154 m0 *1 194.88,71.82
X$45154 VDD VSS sg13g2_decap_8
* cell instance $45155 m0 *1 256.8,238.14
X$45155 VDD VSS sg13g2_decap_8
* cell instance $45156 m0 *1 33.12,200.34
X$45156 VDD VSS sg13g2_decap_8
* cell instance $45157 m0 *1 36.48,200.34
X$45157 VDD VSS sg13g2_decap_8
* cell instance $45158 m0 *1 73.44,313.74
X$45158 VDD VSS sg13g2_decap_8
* cell instance $45159 m0 *1 33.6,192.78
X$45159 VDD VSS sg13g2_decap_8
* cell instance $45160 m0 *1 263.52,238.14
X$45160 VDD VSS sg13g2_decap_8
* cell instance $45161 m0 *1 168.48,283.5
X$45161 VDD VSS sg13g2_decap_8
* cell instance $45162 m0 *1 14.4,245.7
X$45162 VDD VSS sg13g2_decap_8
* cell instance $45163 m0 *1 345.6,298.62
X$45163 VDD VSS sg13g2_decap_8
* cell instance $45164 m0 *1 63.36,207.9
X$45164 VDD VSS sg13g2_decap_8
* cell instance $45165 m0 *1 69.12,207.9
X$45165 VDD VSS sg13g2_decap_8
* cell instance $45166 m0 *1 72.48,192.78
X$45166 VDD VSS sg13g2_decap_8
* cell instance $45167 m0 *1 226.08,306.18
X$45167 VDD VSS sg13g2_decap_8
* cell instance $45168 m0 *1 260.16,238.14
X$45168 VDD VSS sg13g2_decap_8
* cell instance $45169 m0 *1 70.08,200.34
X$45169 VDD VSS sg13g2_decap_8
* cell instance $45170 m0 *1 17.76,245.7
X$45170 VDD VSS sg13g2_decap_8
* cell instance $45171 m0 *1 73.92,223.02
X$45171 VDD VSS sg13g2_decap_8
* cell instance $45172 m0 *1 298.56,321.3
X$45172 VDD VSS sg13g2_decap_8
* cell instance $45173 m0 *1 266.88,238.14
X$45173 VDD VSS sg13g2_decap_8
* cell instance $45174 m0 *1 284.64,185.22
X$45174 VDD VSS sg13g2_decap_8
* cell instance $45175 m0 *1 190.56,275.94
X$45175 VDD VSS sg13g2_decap_8
* cell instance $45176 m0 *1 147.84,147.42
X$45176 VDD VSS sg13g2_decap_8
* cell instance $45177 m0 *1 183.84,275.94
X$45177 VDD VSS sg13g2_decap_8
* cell instance $45178 m0 *1 187.68,147.42
X$45178 VDD VSS sg13g2_decap_8
* cell instance $45179 m0 *1 122.88,34.02
X$45179 VDD VSS sg13g2_decap_8
* cell instance $45180 m0 *1 71.04,283.5
X$45180 VDD VSS sg13g2_decap_8
* cell instance $45181 m0 *1 184.32,147.42
X$45181 VDD VSS sg13g2_decap_8
* cell instance $45182 m0 *1 242.4,238.14
X$45182 VDD VSS sg13g2_decap_8
* cell instance $45183 m0 *1 151.2,154.98
X$45183 VDD VSS sg13g2_decap_8
* cell instance $45184 m0 *1 83.04,268.38
X$45184 VDD VSS sg13g2_decap_8
* cell instance $45185 m0 *1 74.4,260.82
X$45185 VDD VSS sg13g2_decap_8
* cell instance $45186 m0 *1 144.48,147.42
X$45186 VDD VSS sg13g2_decap_8
* cell instance $45187 m0 *1 151.2,147.42
X$45187 VDD VSS sg13g2_decap_8
* cell instance $45188 m0 *1 281.28,238.14
X$45188 VDD VSS sg13g2_decap_8
* cell instance $45189 m0 *1 200.64,154.98
X$45189 VDD VSS sg13g2_decap_8
* cell instance $45190 m0 *1 8.16,185.22
X$45190 VDD VSS sg13g2_decap_8
* cell instance $45191 m0 *1 170.88,154.98
X$45191 VDD VSS sg13g2_decap_8
* cell instance $45192 m0 *1 187.2,275.94
X$45192 VDD VSS sg13g2_decap_8
* cell instance $45193 m0 *1 292.8,200.34
X$45193 VDD VSS sg13g2_decap_8
* cell instance $45194 m0 *1 285.12,207.9
X$45194 VDD VSS sg13g2_decap_8
* cell instance $45195 m0 *1 288.48,207.9
X$45195 VDD VSS sg13g2_decap_8
* cell instance $45196 m0 *1 312,268.38
X$45196 VDD VSS sg13g2_decap_8
* cell instance $45197 m0 *1 184.32,117.18
X$45197 VDD VSS sg13g2_decap_8
* cell instance $45198 m0 *1 222.72,306.18
X$45198 VDD VSS sg13g2_decap_8
* cell instance $45199 m0 *1 160.8,64.26
X$45199 VDD VSS sg13g2_decap_8
* cell instance $45200 m0 *1 39.84,185.22
X$45200 VDD VSS sg13g2_decap_8
* cell instance $45201 m0 *1 277.92,238.14
X$45201 VDD VSS sg13g2_decap_8
* cell instance $45202 m0 *1 299.52,351.54
X$45202 VDD VSS sg13g2_decap_8
* cell instance $45203 m0 *1 302.88,351.54
X$45203 VDD VSS sg13g2_decap_8
* cell instance $45204 m0 *1 296.16,351.54
X$45204 VDD VSS sg13g2_decap_8
* cell instance $45205 m0 *1 166.56,170.1
X$45205 VDD VSS sg13g2_decap_8
* cell instance $45206 m0 *1 239.04,238.14
X$45206 VDD VSS sg13g2_decap_8
* cell instance $45207 m0 *1 284.64,238.14
X$45207 VDD VSS sg13g2_decap_8
* cell instance $45208 m0 *1 146.88,170.1
X$45208 VDD VSS sg13g2_decap_8
* cell instance $45209 m0 *1 119.52,34.02
X$45209 VDD VSS sg13g2_decap_8
* cell instance $45210 m0 *1 288,238.14
X$45210 VDD VSS sg13g2_decap_8
* cell instance $45211 m0 *1 163.2,170.1
X$45211 VDD VSS sg13g2_decap_8
* cell instance $45212 m0 *1 272.16,283.5
X$45212 VDD VSS sg13g2_decap_8
* cell instance $45213 m0 *1 103.2,49.14
X$45213 VDD VSS sg13g2_decap_8
* cell instance $45214 m0 *1 128.64,162.54
X$45214 VDD VSS sg13g2_decap_8
* cell instance $45215 m0 *1 132,162.54
X$45215 VDD VSS sg13g2_decap_8
* cell instance $45216 m0 *1 135.36,162.54
X$45216 VDD VSS sg13g2_decap_8
* cell instance $45217 m0 *1 276.48,260.82
X$45217 VDD VSS sg13g2_decap_8
* cell instance $45218 m0 *1 112.32,162.54
X$45218 VDD VSS sg13g2_decap_8
* cell instance $45219 m0 *1 116.16,154.98
X$45219 VDD VSS sg13g2_decap_8
* cell instance $45220 m0 *1 72.96,268.38
X$45220 VDD VSS sg13g2_decap_8
* cell instance $45221 m0 *1 126.24,170.1
X$45221 VDD VSS sg13g2_decap_8
* cell instance $45222 m0 *1 220.8,283.5
X$45222 VDD VSS sg13g2_decap_8
* cell instance $45223 m0 *1 273.12,260.82
X$45223 VDD VSS sg13g2_decap_8
* cell instance $45224 m0 *1 123.36,177.66
X$45224 VDD VSS sg13g2_decap_8
* cell instance $45225 m0 *1 152.64,18.9
X$45225 VDD VSS sg13g2_decap_8
* cell instance $45226 m0 *1 86.88,26.46
X$45226 VDD VSS sg13g2_decap_8
* cell instance $45227 m0 *1 120,177.66
X$45227 VDD VSS sg13g2_decap_8
* cell instance $45228 m0 *1 118.56,64.26
X$45228 VDD VSS sg13g2_decap_8
* cell instance $45229 m0 *1 139.2,185.22
X$45229 VDD VSS sg13g2_decap_8
* cell instance $45230 m0 *1 126.72,177.66
X$45230 VDD VSS sg13g2_decap_8
* cell instance $45231 m0 *1 139.2,18.9
X$45231 VDD VSS sg13g2_decap_8
* cell instance $45232 m0 *1 292.32,343.98
X$45232 VDD VSS sg13g2_decap_8
* cell instance $45233 m0 *1 291.84,336.42
X$45233 VDD VSS sg13g2_decap_8
* cell instance $45234 m0 *1 292.8,351.54
X$45234 VDD VSS sg13g2_decap_8
* cell instance $45235 m0 *1 291.84,321.3
X$45235 VDD VSS sg13g2_decap_8
* cell instance $45236 m0 *1 277.92,268.38
X$45236 VDD VSS sg13g2_decap_8
* cell instance $45237 m0 *1 167.52,154.98
X$45237 VDD VSS sg13g2_decap_8
* cell instance $45238 m0 *1 84,253.26
X$45238 VDD VSS sg13g2_decap_8
* cell instance $45239 m0 *1 164.16,154.98
X$45239 VDD VSS sg13g2_decap_8
* cell instance $45240 m0 *1 347.04,328.86
X$45240 VDD VSS sg13g2_decap_8
* cell instance $45241 m0 *1 283.2,260.82
X$45241 VDD VSS sg13g2_decap_8
* cell instance $45242 m0 *1 166.56,147.42
X$45242 VDD VSS sg13g2_decap_8
* cell instance $45243 m0 *1 279.84,260.82
X$45243 VDD VSS sg13g2_decap_8
* cell instance $45244 m0 *1 275.52,283.5
X$45244 VDD VSS sg13g2_decap_8
* cell instance $45245 m0 *1 177.6,147.42
X$45245 VDD VSS sg13g2_decap_8
* cell instance $45246 m0 *1 174.24,147.42
X$45246 VDD VSS sg13g2_decap_8
* cell instance $45247 m0 *1 190.56,170.1
X$45247 VDD VSS sg13g2_decap_8
* cell instance $45248 m0 *1 217.44,283.5
X$45248 VDD VSS sg13g2_decap_8
* cell instance $45249 m0 *1 214.56,291.06
X$45249 VDD VSS sg13g2_decap_8
* cell instance $45250 m0 *1 25.92,185.22
X$45250 VDD VSS sg13g2_decap_8
* cell instance $45251 m0 *1 194.4,351.54
X$45251 VDD VSS sg13g2_decap_8
* cell instance $45252 m0 *1 312,306.18
X$45252 VDD VSS sg13g2_decap_8
* cell instance $45253 m0 *1 66.24,245.7
X$45253 VDD VSS sg13g2_decap_8
* cell instance $45254 m0 *1 207.84,109.62
X$45254 VDD VSS sg13g2_decap_8
* cell instance $45255 m0 *1 310.56,283.5
X$45255 VDD VSS sg13g2_decap_8
* cell instance $45256 m0 *1 191.04,351.54
X$45256 VDD VSS sg13g2_decap_8
* cell instance $45257 m0 *1 80.64,298.62
X$45257 VDD VSS sg13g2_decap_8
* cell instance $45258 m0 *1 116.16,34.02
X$45258 VDD VSS sg13g2_decap_8
* cell instance $45259 m0 *1 153.12,86.94
X$45259 VDD VSS sg13g2_decap_8
* cell instance $45260 m0 *1 305.28,306.18
X$45260 VDD VSS sg13g2_decap_8
* cell instance $45261 m0 *1 286.08,200.34
X$45261 VDD VSS sg13g2_decap_8
* cell instance $45262 m0 *1 289.44,200.34
X$45262 VDD VSS sg13g2_decap_8
* cell instance $45263 m0 *1 149.76,86.94
X$45263 VDD VSS sg13g2_decap_8
* cell instance $45264 m0 *1 147.36,223.02
X$45264 VDD VSS sg13g2_decap_8
* cell instance $45265 m0 *1 192.96,336.42
X$45265 VDD VSS sg13g2_decap_8
* cell instance $45266 m0 *1 77.28,298.62
X$45266 VDD VSS sg13g2_decap_8
* cell instance $45267 m0 *1 273.6,215.46
X$45267 VDD VSS sg13g2_decap_8
* cell instance $45268 m0 *1 167.52,223.02
X$45268 VDD VSS sg13g2_decap_8
* cell instance $45269 m0 *1 245.28,124.74
X$45269 VDD VSS sg13g2_decap_8
* cell instance $45270 m0 *1 125.76,223.02
X$45270 VDD VSS sg13g2_decap_8
* cell instance $45271 m0 *1 301.92,321.3
X$45271 VDD VSS sg13g2_decap_8
* cell instance $45272 m0 *1 132.48,223.02
X$45272 VDD VSS sg13g2_decap_8
* cell instance $45273 m0 *1 129.12,223.02
X$45273 VDD VSS sg13g2_decap_8
* cell instance $45274 m0 *1 204.48,351.54
X$45274 VDD VSS sg13g2_decap_8
* cell instance $45275 m0 *1 151.68,79.38
X$45275 VDD VSS sg13g2_decap_8
* cell instance $45276 m0 *1 69.6,245.7
X$45276 VDD VSS sg13g2_decap_8
* cell instance $45277 m0 *1 170.88,223.02
X$45277 VDD VSS sg13g2_decap_8
* cell instance $45278 m0 *1 110.4,192.78
X$45278 VDD VSS sg13g2_decap_8
* cell instance $45279 m0 *1 207.84,351.54
X$45279 VDD VSS sg13g2_decap_8
* cell instance $45280 m0 *1 201.12,351.54
X$45280 VDD VSS sg13g2_decap_8
* cell instance $45281 m0 *1 146.4,94.5
X$45281 VDD VSS sg13g2_decap_8
* cell instance $45282 m0 *1 187.68,351.54
X$45282 VDD VSS sg13g2_decap_8
* cell instance $45283 m0 *1 130.56,192.78
X$45283 VDD VSS sg13g2_decap_8
* cell instance $45284 m0 *1 197.76,351.54
X$45284 VDD VSS sg13g2_decap_8
* cell instance $45285 m0 *1 168.96,207.9
X$45285 VDD VSS sg13g2_decap_8
* cell instance $45286 m0 *1 308.64,306.18
X$45286 VDD VSS sg13g2_decap_8
* cell instance $45287 m0 *1 113.76,192.78
X$45287 VDD VSS sg13g2_decap_8
* cell instance $45288 m0 *1 118.56,185.22
X$45288 VDD VSS sg13g2_decap_8
* cell instance $45289 m0 *1 292.8,223.02
X$45289 VDD VSS sg13g2_decap_8
* cell instance $45290 m0 *1 86.4,268.38
X$45290 VDD VSS sg13g2_decap_8
* cell instance $45291 m0 *1 180,86.94
X$45291 VDD VSS sg13g2_decap_8
* cell instance $45292 m0 *1 94.56,18.9
X$45292 VDD VSS sg13g2_decap_8
* cell instance $45293 m0 *1 78.72,185.22
X$45293 VDD VSS sg13g2_decap_8
* cell instance $45294 m0 *1 79.68,268.38
X$45294 VDD VSS sg13g2_decap_8
* cell instance $45295 m0 *1 176.64,86.94
X$45295 VDD VSS sg13g2_decap_8
* cell instance $45296 m0 *1 312,223.02
X$45296 VDD VSS sg13g2_decap_8
* cell instance $45297 m0 *1 204,124.74
X$45297 VDD VSS sg13g2_decap_8
* cell instance $45298 m0 *1 203.04,298.62
X$45298 VDD VSS sg13g2_decap_8
* cell instance $45299 m0 *1 76.32,268.38
X$45299 VDD VSS sg13g2_decap_8
* cell instance $45300 m0 *1 139.2,139.86
X$45300 VDD VSS sg13g2_decap_8
* cell instance $45301 m0 *1 212.16,132.3
X$45301 VDD VSS sg13g2_decap_8
* cell instance $45302 m0 *1 172.32,170.1
X$45302 VDD VSS sg13g2_decap_8
* cell instance $45303 m0 *1 164.64,94.5
X$45303 VDD VSS sg13g2_decap_8
* cell instance $45304 m0 *1 144,223.02
X$45304 VDD VSS sg13g2_decap_8
* cell instance $45305 m0 *1 160.8,154.98
X$45305 VDD VSS sg13g2_decap_8
* cell instance $45306 m0 *1 197.28,268.38
X$45306 VDD VSS sg13g2_decap_8
* cell instance $45307 m0 *1 69.6,268.38
X$45307 VDD VSS sg13g2_decap_8
* cell instance $45308 m0 *1 29.76,275.94
X$45308 VDD VSS sg13g2_decap_8
* cell instance $45309 m0 *1 295.68,343.98
X$45309 VDD VSS sg13g2_decap_8
* cell instance $45310 m0 *1 200.64,268.38
X$45310 VDD VSS sg13g2_decap_8
* cell instance $45311 m0 *1 180.96,147.42
X$45311 VDD VSS sg13g2_decap_8
* cell instance $45312 m0 *1 283.68,223.02
X$45312 VDD VSS sg13g2_decap_8
* cell instance $45313 m0 *1 168,94.5
X$45313 VDD VSS sg13g2_decap_8
* cell instance $45314 m0 *1 36.48,185.22
X$45314 VDD VSS sg13g2_decap_8
* cell instance $45315 m0 *1 280.32,223.02
X$45315 VDD VSS sg13g2_decap_8
* cell instance $45316 r0 *1 182.88,253.26
X$45316 VDD VSS sg13g2_decap_8
* cell instance $45317 r0 *1 116.16,18.9
X$45317 VDD VSS sg13g2_decap_8
* cell instance $45318 r0 *1 124.32,18.9
X$45318 VDD VSS sg13g2_decap_8
* cell instance $45319 r0 *1 132.96,56.7
X$45319 VDD VSS sg13g2_decap_8
* cell instance $45320 r0 *1 149.28,18.9
X$45320 VDD VSS sg13g2_decap_8
* cell instance $45321 r0 *1 131.04,18.9
X$45321 VDD VSS sg13g2_decap_8
* cell instance $45322 r0 *1 242.4,238.14
X$45322 VDD VSS sg13g2_decap_8
* cell instance $45323 r0 *1 241.92,230.58
X$45323 VDD VSS sg13g2_decap_8
* cell instance $45324 r0 *1 258.72,253.26
X$45324 VDD VSS sg13g2_decap_8
* cell instance $45325 r0 *1 262.08,238.14
X$45325 VDD VSS sg13g2_decap_8
* cell instance $45326 r0 *1 107.04,41.58
X$45326 VDD VSS sg13g2_decap_8
* cell instance $45327 r0 *1 106.08,18.9
X$45327 VDD VSS sg13g2_decap_8
* cell instance $45328 r0 *1 180.96,49.14
X$45328 VDD VSS sg13g2_decap_8
* cell instance $45329 r0 *1 141.6,18.9
X$45329 VDD VSS sg13g2_decap_8
* cell instance $45330 r0 *1 234.72,230.58
X$45330 VDD VSS sg13g2_decap_8
* cell instance $45331 r0 *1 127.68,18.9
X$45331 VDD VSS sg13g2_decap_8
* cell instance $45332 r0 *1 286.08,313.74
X$45332 VDD VSS sg13g2_decap_8
* cell instance $45333 r0 *1 123.84,64.26
X$45333 VDD VSS sg13g2_decap_8
* cell instance $45334 r0 *1 250.56,260.82
X$45334 VDD VSS sg13g2_decap_8
* cell instance $45335 r0 *1 112.8,18.9
X$45335 VDD VSS sg13g2_decap_8
* cell instance $45336 r0 *1 253.92,260.82
X$45336 VDD VSS sg13g2_decap_8
* cell instance $45337 r0 *1 109.44,18.9
X$45337 VDD VSS sg13g2_decap_8
* cell instance $45338 r0 *1 245.76,238.14
X$45338 VDD VSS sg13g2_decap_8
* cell instance $45339 r0 *1 275.52,275.94
X$45339 VDD VSS sg13g2_decap_8
* cell instance $45340 r0 *1 200.64,124.74
X$45340 VDD VSS sg13g2_decap_8
* cell instance $45341 r0 *1 197.28,124.74
X$45341 VDD VSS sg13g2_decap_8
* cell instance $45342 r0 *1 211.68,321.3
X$45342 VDD VSS sg13g2_decap_8
* cell instance $45343 r0 *1 223.2,132.3
X$45343 VDD VSS sg13g2_decap_8
* cell instance $45344 r0 *1 207.36,124.74
X$45344 VDD VSS sg13g2_decap_8
* cell instance $45345 r0 *1 180.96,275.94
X$45345 VDD VSS sg13g2_decap_8
* cell instance $45346 r0 *1 206.4,291.06
X$45346 VDD VSS sg13g2_decap_8
* cell instance $45347 r0 *1 209.76,291.06
X$45347 VDD VSS sg13g2_decap_8
* cell instance $45348 r0 *1 204,124.74
X$45348 VDD VSS sg13g2_decap_8
* cell instance $45349 r0 *1 187.2,117.18
X$45349 VDD VSS sg13g2_decap_8
* cell instance $45350 r0 *1 213.12,291.06
X$45350 VDD VSS sg13g2_decap_8
* cell instance $45351 r0 *1 183.84,117.18
X$45351 VDD VSS sg13g2_decap_8
* cell instance $45352 r0 *1 221.28,154.98
X$45352 VDD VSS sg13g2_decap_8
* cell instance $45353 r0 *1 217.92,154.98
X$45353 VDD VSS sg13g2_decap_8
* cell instance $45354 r0 *1 180.48,139.86
X$45354 VDD VSS sg13g2_decap_8
* cell instance $45355 r0 *1 243.36,139.86
X$45355 VDD VSS sg13g2_decap_8
* cell instance $45356 r0 *1 240,139.86
X$45356 VDD VSS sg13g2_decap_8
* cell instance $45357 r0 *1 258.72,139.86
X$45357 VDD VSS sg13g2_decap_8
* cell instance $45358 r0 *1 255.36,139.86
X$45358 VDD VSS sg13g2_decap_8
* cell instance $45359 r0 *1 252,139.86
X$45359 VDD VSS sg13g2_decap_8
* cell instance $45360 r0 *1 262.08,139.86
X$45360 VDD VSS sg13g2_decap_8
* cell instance $45361 r0 *1 221.76,283.5
X$45361 VDD VSS sg13g2_decap_8
* cell instance $45362 r0 *1 221.76,306.18
X$45362 VDD VSS sg13g2_decap_8
* cell instance $45363 r0 *1 218.4,283.5
X$45363 VDD VSS sg13g2_decap_8
* cell instance $45364 r0 *1 215.04,283.5
X$45364 VDD VSS sg13g2_decap_8
* cell instance $45365 r0 *1 217.92,162.54
X$45365 VDD VSS sg13g2_decap_8
* cell instance $45366 r0 *1 221.28,162.54
X$45366 VDD VSS sg13g2_decap_8
* cell instance $45367 r0 *1 199.68,147.42
X$45367 VDD VSS sg13g2_decap_8
* cell instance $45368 r0 *1 196.32,147.42
X$45368 VDD VSS sg13g2_decap_8
* cell instance $45369 r0 *1 183.84,139.86
X$45369 VDD VSS sg13g2_decap_8
* cell instance $45370 r0 *1 184.32,275.94
X$45370 VDD VSS sg13g2_decap_8
* cell instance $45371 r0 *1 203.04,147.42
X$45371 VDD VSS sg13g2_decap_8
* cell instance $45372 r0 *1 331.68,291.06
X$45372 VDD VSS sg13g2_decap_8
* cell instance $45373 r0 *1 201.12,86.94
X$45373 VDD VSS sg13g2_decap_8
* cell instance $45374 r0 *1 197.76,86.94
X$45374 VDD VSS sg13g2_decap_8
* cell instance $45375 r0 *1 187.2,86.94
X$45375 VDD VSS sg13g2_decap_8
* cell instance $45376 r0 *1 190.56,86.94
X$45376 VDD VSS sg13g2_decap_8
* cell instance $45377 r0 *1 195.84,64.26
X$45377 VDD VSS sg13g2_decap_8
* cell instance $45378 r0 *1 227.04,275.94
X$45378 VDD VSS sg13g2_decap_8
* cell instance $45379 r0 *1 191.52,102.06
X$45379 VDD VSS sg13g2_decap_8
* cell instance $45380 r0 *1 240.96,313.74
X$45380 VDD VSS sg13g2_decap_8
* cell instance $45381 r0 *1 244.32,313.74
X$45381 VDD VSS sg13g2_decap_8
* cell instance $45382 r0 *1 247.68,313.74
X$45382 VDD VSS sg13g2_decap_8
* cell instance $45383 r0 *1 251.04,313.74
X$45383 VDD VSS sg13g2_decap_8
* cell instance $45384 r0 *1 254.4,313.74
X$45384 VDD VSS sg13g2_decap_8
* cell instance $45385 r0 *1 327.36,298.62
X$45385 VDD VSS sg13g2_decap_8
* cell instance $45386 r0 *1 327.84,306.18
X$45386 VDD VSS sg13g2_decap_8
* cell instance $45387 r0 *1 324,298.62
X$45387 VDD VSS sg13g2_decap_8
* cell instance $45388 r0 *1 225.12,306.18
X$45388 VDD VSS sg13g2_decap_8
* cell instance $45389 r0 *1 210.72,102.06
X$45389 VDD VSS sg13g2_decap_8
* cell instance $45390 r0 *1 219.36,102.06
X$45390 VDD VSS sg13g2_decap_8
* cell instance $45391 r0 *1 244.32,117.18
X$45391 VDD VSS sg13g2_decap_8
* cell instance $45392 r0 *1 197.76,336.42
X$45392 VDD VSS sg13g2_decap_8
* cell instance $45393 r0 *1 228.96,102.06
X$45393 VDD VSS sg13g2_decap_8
* cell instance $45394 r0 *1 235.68,102.06
X$45394 VDD VSS sg13g2_decap_8
* cell instance $45395 r0 *1 232.32,102.06
X$45395 VDD VSS sg13g2_decap_8
* cell instance $45396 r0 *1 206.88,79.38
X$45396 VDD VSS sg13g2_decap_8
* cell instance $45397 r0 *1 244.8,321.3
X$45397 VDD VSS sg13g2_decap_8
* cell instance $45398 r0 *1 241.44,321.3
X$45398 VDD VSS sg13g2_decap_8
* cell instance $45399 r0 *1 232.8,321.3
X$45399 VDD VSS sg13g2_decap_8
* cell instance $45400 r0 *1 267.36,343.98
X$45400 VDD VSS sg13g2_decap_8
* cell instance $45401 r0 *1 320.16,291.06
X$45401 VDD VSS sg13g2_decap_8
* cell instance $45402 r0 *1 187.68,71.82
X$45402 VDD VSS sg13g2_decap_8
* cell instance $45403 r0 *1 204.48,86.94
X$45403 VDD VSS sg13g2_decap_8
* cell instance $45404 r0 *1 210.24,79.38
X$45404 VDD VSS sg13g2_decap_8
* cell instance $45405 r0 *1 252,328.86
X$45405 VDD VSS sg13g2_decap_8
* cell instance $45406 r0 *1 235.68,268.38
X$45406 VDD VSS sg13g2_decap_8
* cell instance $45407 r0 *1 205.44,268.38
X$45407 VDD VSS sg13g2_decap_8
* cell instance $45408 r0 *1 269.76,313.74
X$45408 VDD VSS sg13g2_decap_8
* cell instance $45409 r0 *1 255.36,268.38
X$45409 VDD VSS sg13g2_decap_8
* cell instance $45410 r0 *1 270.24,321.3
X$45410 VDD VSS sg13g2_decap_8
* cell instance $45411 r0 *1 258.72,268.38
X$45411 VDD VSS sg13g2_decap_8
* cell instance $45412 r0 *1 268.32,268.38
X$45412 VDD VSS sg13g2_decap_8
* cell instance $45413 r0 *1 273.12,268.38
X$45413 VDD VSS sg13g2_decap_8
* cell instance $45414 r0 *1 323.52,268.38
X$45414 VDD VSS sg13g2_decap_8
* cell instance $45415 r0 *1 187.2,268.38
X$45415 VDD VSS sg13g2_decap_8
* cell instance $45416 r0 *1 195.36,268.38
X$45416 VDD VSS sg13g2_decap_8
* cell instance $45417 r0 *1 198.72,268.38
X$45417 VDD VSS sg13g2_decap_8
* cell instance $45418 r0 *1 202.08,268.38
X$45418 VDD VSS sg13g2_decap_8
* cell instance $45419 r0 *1 215.04,268.38
X$45419 VDD VSS sg13g2_decap_8
* cell instance $45420 r0 *1 268.8,238.14
X$45420 VDD VSS sg13g2_decap_8
* cell instance $45421 r0 *1 233.28,139.86
X$45421 VDD VSS sg13g2_decap_8
* cell instance $45422 r0 *1 169.44,11.34
X$45422 VDD VSS sg13g2_decap_8
* cell instance $45423 r0 *1 172.8,11.34
X$45423 VDD VSS sg13g2_decap_4
* cell instance $45424 r0 *1 163.68,18.9
X$45424 VDD VSS sg13g2_decap_8
* cell instance $45425 r0 *1 166.08,11.34
X$45425 VDD VSS sg13g2_decap_8
* cell instance $45426 r0 *1 162.72,11.34
X$45426 VDD VSS sg13g2_decap_8
* cell instance $45427 r0 *1 187.68,94.5
X$45427 VDD VSS sg13g2_decap_8
* cell instance $45428 r0 *1 268.32,170.1
X$45428 VDD VSS sg13g2_decap_8
* cell instance $45429 r0 *1 226.56,207.9
X$45429 VDD VSS sg13g2_decap_8
* cell instance $45430 r0 *1 268.8,207.9
X$45430 VDD VSS sg13g2_decap_8
* cell instance $45431 r0 *1 225.12,230.58
X$45431 VDD VSS sg13g2_decap_8
* cell instance $45432 r0 *1 290.4,177.66
X$45432 VDD VSS sg13g2_decap_8
* cell instance $45433 r0 *1 293.76,177.66
X$45433 VDD VSS sg13g2_decap_8
* cell instance $45434 r0 *1 262.56,283.5
X$45434 VDD VSS sg13g2_decap_8
* cell instance $45435 r0 *1 265.92,283.5
X$45435 VDD VSS sg13g2_decap_8
* cell instance $45436 r0 *1 300,170.1
X$45436 VDD VSS sg13g2_decap_8
* cell instance $45437 r0 *1 294.24,170.1
X$45437 VDD VSS sg13g2_decap_8
* cell instance $45438 r0 *1 297.12,177.66
X$45438 VDD VSS sg13g2_decap_8
* cell instance $45439 r0 *1 226.08,238.14
X$45439 VDD VSS sg13g2_decap_8
* cell instance $45440 r0 *1 262.08,298.62
X$45440 VDD VSS sg13g2_decap_8
* cell instance $45441 r0 *1 225.6,102.06
X$45441 VDD VSS sg13g2_decap_8
* cell instance $45442 r0 *1 253.44,306.18
X$45442 VDD VSS sg13g2_decap_8
* cell instance $45443 r0 *1 246.72,139.86
X$45443 VDD VSS sg13g2_decap_8
* cell instance $45444 r0 *1 258.72,298.62
X$45444 VDD VSS sg13g2_decap_8
* cell instance $45445 r0 *1 261.6,170.1
X$45445 VDD VSS sg13g2_decap_8
* cell instance $45446 r0 *1 258.24,170.1
X$45446 VDD VSS sg13g2_decap_8
* cell instance $45447 r0 *1 239.04,268.38
X$45447 VDD VSS sg13g2_decap_8
* cell instance $45448 r0 *1 228,170.1
X$45448 VDD VSS sg13g2_decap_8
* cell instance $45449 r0 *1 234.72,170.1
X$45449 VDD VSS sg13g2_decap_8
* cell instance $45450 r0 *1 235.68,162.54
X$45450 VDD VSS sg13g2_decap_8
* cell instance $45451 r0 *1 231.36,170.1
X$45451 VDD VSS sg13g2_decap_8
* cell instance $45452 r0 *1 232.32,162.54
X$45452 VDD VSS sg13g2_decap_8
* cell instance $45453 r0 *1 223.68,275.94
X$45453 VDD VSS sg13g2_decap_8
* cell instance $45454 r0 *1 239.04,162.54
X$45454 VDD VSS sg13g2_decap_8
* cell instance $45455 r0 *1 236.64,139.86
X$45455 VDD VSS sg13g2_decap_8
* cell instance $45456 r0 *1 264.96,170.1
X$45456 VDD VSS sg13g2_decap_8
* cell instance $45457 r0 *1 252,268.38
X$45457 VDD VSS sg13g2_decap_8
* cell instance $45458 r0 *1 269.76,253.26
X$45458 VDD VSS sg13g2_decap_8
* cell instance $45459 r0 *1 246.24,268.38
X$45459 VDD VSS sg13g2_decap_8
* cell instance $45460 r0 *1 259.2,283.5
X$45460 VDD VSS sg13g2_decap_8
* cell instance $45461 r0 *1 280.32,177.66
X$45461 VDD VSS sg13g2_decap_8
* cell instance $45462 r0 *1 283.68,177.66
X$45462 VDD VSS sg13g2_decap_8
* cell instance $45463 r0 *1 287.04,177.66
X$45463 VDD VSS sg13g2_decap_8
* cell instance $45464 r0 *1 226.08,139.86
X$45464 VDD VSS sg13g2_decap_8
* cell instance $45465 r0 *1 273.6,154.98
X$45465 VDD VSS sg13g2_decap_8
* cell instance $45466 r0 *1 240,283.5
X$45466 VDD VSS sg13g2_decap_8
* cell instance $45467 r0 *1 235.2,275.94
X$45467 VDD VSS sg13g2_decap_8
* cell instance $45468 r0 *1 228.48,298.62
X$45468 VDD VSS sg13g2_decap_8
* cell instance $45469 r0 *1 228.48,306.18
X$45469 VDD VSS sg13g2_decap_8
* cell instance $45470 r0 *1 231.84,306.18
X$45470 VDD VSS sg13g2_decap_8
* cell instance $45471 r0 *1 235.2,306.18
X$45471 VDD VSS sg13g2_decap_8
* cell instance $45472 r0 *1 265.44,298.62
X$45472 VDD VSS sg13g2_decap_8
* cell instance $45473 r0 *1 276.96,154.98
X$45473 VDD VSS sg13g2_decap_8
* cell instance $45474 r0 *1 148.32,223.02
X$45474 VDD VSS sg13g2_decap_8
* cell instance $45475 r0 *1 146.4,215.46
X$45475 VDD VSS sg13g2_decap_8
* cell instance $45476 r0 *1 147.84,207.9
X$45476 VDD VSS sg13g2_decap_8
* cell instance $45477 r0 *1 153.6,223.02
X$45477 VDD VSS sg13g2_decap_8
* cell instance $45478 r0 *1 272.16,207.9
X$45478 VDD VSS sg13g2_decap_8
* cell instance $45479 r0 *1 154.56,207.9
X$45479 VDD VSS sg13g2_decap_8
* cell instance $45480 r0 *1 151.2,207.9
X$45480 VDD VSS sg13g2_decap_8
* cell instance $45481 r0 *1 288.48,223.02
X$45481 VDD VSS sg13g2_decap_8
* cell instance $45482 r0 *1 178.08,200.34
X$45482 VDD VSS sg13g2_decap_8
* cell instance $45483 r0 *1 273.6,215.46
X$45483 VDD VSS sg13g2_decap_8
* cell instance $45484 r0 *1 241.44,192.78
X$45484 VDD VSS sg13g2_decap_8
* cell instance $45485 r0 *1 36.48,94.5
X$45485 VDD VSS sg13g2_decap_8
* cell instance $45486 r0 *1 39.84,94.5
X$45486 VDD VSS sg13g2_decap_8
* cell instance $45487 r0 *1 28.32,94.5
X$45487 VDD VSS sg13g2_decap_8
* cell instance $45488 r0 *1 8.16,94.5
X$45488 VDD VSS sg13g2_decap_8
* cell instance $45489 r0 *1 300.96,215.46
X$45489 VDD VSS sg13g2_decap_8
* cell instance $45490 r0 *1 307.68,215.46
X$45490 VDD VSS sg13g2_decap_8
* cell instance $45491 r0 *1 139.68,139.86
X$45491 VDD VSS sg13g2_decap_8
* cell instance $45492 r0 *1 139.68,124.74
X$45492 VDD VSS sg13g2_decap_8
* cell instance $45493 r0 *1 159.36,147.42
X$45493 VDD VSS sg13g2_decap_8
* cell instance $45494 r0 *1 175.68,170.1
X$45494 VDD VSS sg13g2_decap_8
* cell instance $45495 r0 *1 179.04,170.1
X$45495 VDD VSS sg13g2_decap_8
* cell instance $45496 r0 *1 310.56,223.02
X$45496 VDD VSS sg13g2_decap_8
* cell instance $45497 r0 *1 317.28,200.34
X$45497 VDD VSS sg13g2_decap_8
* cell instance $45498 r0 *1 278.88,343.98
X$45498 VDD VSS sg13g2_decap_8
* cell instance $45499 r0 *1 288.96,343.98
X$45499 VDD VSS sg13g2_decap_8
* cell instance $45500 r0 *1 103.2,260.82
X$45500 VDD VSS sg13g2_decap_8
* cell instance $45501 r0 *1 320.16,192.78
X$45501 VDD VSS sg13g2_decap_8
* cell instance $45502 r0 *1 317.28,223.02
X$45502 VDD VSS sg13g2_decap_8
* cell instance $45503 r0 *1 115.2,185.22
X$45503 VDD VSS sg13g2_decap_8
* cell instance $45504 r0 *1 129.6,215.46
X$45504 VDD VSS sg13g2_decap_8
* cell instance $45505 r0 *1 329.76,215.46
X$45505 VDD VSS sg13g2_decap_8
* cell instance $45506 r0 *1 126.24,223.02
X$45506 VDD VSS sg13g2_decap_8
* cell instance $45507 r0 *1 288.96,291.06
X$45507 VDD VSS sg13g2_decap_8
* cell instance $45508 r0 *1 177.6,223.02
X$45508 VDD VSS sg13g2_decap_8
* cell instance $45509 r0 *1 285.6,291.06
X$45509 VDD VSS sg13g2_decap_8
* cell instance $45510 r0 *1 107.04,192.78
X$45510 VDD VSS sg13g2_decap_8
* cell instance $45511 r0 *1 310.56,200.34
X$45511 VDD VSS sg13g2_decap_8
* cell instance $45512 r0 *1 297.6,192.78
X$45512 VDD VSS sg13g2_decap_8
* cell instance $45513 r0 *1 118.56,185.22
X$45513 VDD VSS sg13g2_decap_8
* cell instance $45514 r0 *1 121.92,185.22
X$45514 VDD VSS sg13g2_decap_8
* cell instance $45515 r0 *1 134.4,185.22
X$45515 VDD VSS sg13g2_decap_8
* cell instance $45516 r0 *1 303.36,298.62
X$45516 VDD VSS sg13g2_decap_8
* cell instance $45517 r0 *1 170.88,223.02
X$45517 VDD VSS sg13g2_decap_8
* cell instance $45518 r0 *1 174.24,223.02
X$45518 VDD VSS sg13g2_decap_8
* cell instance $45519 r0 *1 289.92,200.34
X$45519 VDD VSS sg13g2_decap_8
* cell instance $45520 r0 *1 122.88,223.02
X$45520 VDD VSS sg13g2_decap_8
* cell instance $45521 r0 *1 280.32,260.82
X$45521 VDD VSS sg13g2_decap_8
* cell instance $45522 r0 *1 103.2,170.1
X$45522 VDD VSS sg13g2_decap_8
* cell instance $45523 r0 *1 105.12,177.66
X$45523 VDD VSS sg13g2_decap_8
* cell instance $45524 r0 *1 113.76,177.66
X$45524 VDD VSS sg13g2_decap_8
* cell instance $45525 r0 *1 110.88,162.54
X$45525 VDD VSS sg13g2_decap_8
* cell instance $45526 r0 *1 113.76,154.98
X$45526 VDD VSS sg13g2_decap_8
* cell instance $45527 r0 *1 110.4,154.98
X$45527 VDD VSS sg13g2_decap_8
* cell instance $45528 r0 *1 280.8,245.7
X$45528 VDD VSS sg13g2_decap_8
* cell instance $45529 r0 *1 277.44,245.7
X$45529 VDD VSS sg13g2_decap_8
* cell instance $45530 r0 *1 300,298.62
X$45530 VDD VSS sg13g2_decap_8
* cell instance $45531 r0 *1 311.52,306.18
X$45531 VDD VSS sg13g2_decap_8
* cell instance $45532 r0 *1 108.48,117.18
X$45532 VDD VSS sg13g2_decap_8
* cell instance $45533 r0 *1 111.84,117.18
X$45533 VDD VSS sg13g2_decap_8
* cell instance $45534 r0 *1 117.12,117.18
X$45534 VDD VSS sg13g2_decap_8
* cell instance $45535 r0 *1 116.16,109.62
X$45535 VDD VSS sg13g2_decap_8
* cell instance $45536 r0 *1 296.64,298.62
X$45536 VDD VSS sg13g2_decap_8
* cell instance $45537 r0 *1 129.6,124.74
X$45537 VDD VSS sg13g2_decap_8
* cell instance $45538 r0 *1 316.32,238.14
X$45538 VDD VSS sg13g2_decap_8
* cell instance $45539 r0 *1 126.24,109.62
X$45539 VDD VSS sg13g2_decap_8
* cell instance $45540 r0 *1 122.88,109.62
X$45540 VDD VSS sg13g2_decap_8
* cell instance $45541 r0 *1 119.52,109.62
X$45541 VDD VSS sg13g2_decap_8
* cell instance $45542 r0 *1 321.6,260.82
X$45542 VDD VSS sg13g2_decap_8
* cell instance $45543 r0 *1 120.48,154.98
X$45543 VDD VSS sg13g2_decap_8
* cell instance $45544 r0 *1 308.16,306.18
X$45544 VDD VSS sg13g2_decap_8
* cell instance $45545 r0 *1 309.6,238.14
X$45545 VDD VSS sg13g2_decap_8
* cell instance $45546 r0 *1 143.04,162.54
X$45546 VDD VSS sg13g2_decap_8
* cell instance $45547 r0 *1 284.16,238.14
X$45547 VDD VSS sg13g2_decap_8
* cell instance $45548 r0 *1 272.16,238.14
X$45548 VDD VSS sg13g2_decap_8
* cell instance $45549 r0 *1 152.64,147.42
X$45549 VDD VSS sg13g2_decap_8
* cell instance $45550 r0 *1 292.32,343.98
X$45550 VDD VSS sg13g2_decap_8
* cell instance $45551 r0 *1 287.52,238.14
X$45551 VDD VSS sg13g2_decap_8
* cell instance $45552 r0 *1 293.76,336.42
X$45552 VDD VSS sg13g2_decap_8
* cell instance $45553 r0 *1 156,147.42
X$45553 VDD VSS sg13g2_decap_8
* cell instance $45554 r0 *1 149.28,147.42
X$45554 VDD VSS sg13g2_decap_8
* cell instance $45555 r0 *1 120.48,177.66
X$45555 VDD VSS sg13g2_decap_8
* cell instance $45556 r0 *1 177.6,147.42
X$45556 VDD VSS sg13g2_decap_8
* cell instance $45557 r0 *1 276.96,260.82
X$45557 VDD VSS sg13g2_decap_8
* cell instance $45558 r0 *1 163.68,154.98
X$45558 VDD VSS sg13g2_decap_8
* cell instance $45559 r0 *1 167.04,154.98
X$45559 VDD VSS sg13g2_decap_8
* cell instance $45560 r0 *1 347.04,328.86
X$45560 VDD VSS sg13g2_decap_8
* cell instance $45561 r0 *1 173.76,139.86
X$45561 VDD VSS sg13g2_decap_8
* cell instance $45562 r0 *1 177.12,139.86
X$45562 VDD VSS sg13g2_decap_8
* cell instance $45563 r0 *1 117.12,177.66
X$45563 VDD VSS sg13g2_decap_8
* cell instance $45564 r0 *1 117.12,154.98
X$45564 VDD VSS sg13g2_decap_8
* cell instance $45565 r0 *1 114.24,162.54
X$45565 VDD VSS sg13g2_decap_8
* cell instance $45566 r0 *1 125.28,170.1
X$45566 VDD VSS sg13g2_decap_8
* cell instance $45567 r0 *1 170.4,154.98
X$45567 VDD VSS sg13g2_decap_8
* cell instance $45568 r0 *1 84.96,260.82
X$45568 VDD VSS sg13g2_decap_8
* cell instance $45569 r0 *1 86.4,253.26
X$45569 VDD VSS sg13g2_decap_8
* cell instance $45570 r0 *1 89.76,253.26
X$45570 VDD VSS sg13g2_decap_8
* cell instance $45571 r0 *1 69.12,238.14
X$45571 VDD VSS sg13g2_decap_8
* cell instance $45572 r0 *1 65.76,238.14
X$45572 VDD VSS sg13g2_decap_8
* cell instance $45573 r0 *1 75.84,238.14
X$45573 VDD VSS sg13g2_decap_8
* cell instance $45574 r0 *1 302.88,321.3
X$45574 VDD VSS sg13g2_decap_8
* cell instance $45575 r0 *1 27.36,253.26
X$45575 VDD VSS sg13g2_decap_8
* cell instance $45576 r0 *1 27.84,260.82
X$45576 VDD VSS sg13g2_decap_8
* cell instance $45577 r0 *1 8.16,343.98
X$45577 VDD VSS sg13g2_decap_8
* cell instance $45578 r0 *1 122.4,260.82
X$45578 VDD VSS sg13g2_decap_8
* cell instance $45579 r0 *1 11.52,260.82
X$45579 VDD VSS sg13g2_decap_8
* cell instance $45580 r0 *1 50.4,275.94
X$45580 VDD VSS sg13g2_decap_8
* cell instance $45581 r0 *1 8.16,260.82
X$45581 VDD VSS sg13g2_decap_8
* cell instance $45582 r0 *1 23.04,238.14
X$45582 VDD VSS sg13g2_decap_8
* cell instance $45583 r0 *1 22.56,230.58
X$45583 VDD VSS sg13g2_decap_8
* cell instance $45584 r0 *1 28.8,192.78
X$45584 VDD VSS sg13g2_decap_8
* cell instance $45585 r0 *1 46.56,215.46
X$45585 VDD VSS sg13g2_decap_8
* cell instance $45586 r0 *1 40.32,223.02
X$45586 VDD VSS sg13g2_decap_8
* cell instance $45587 r0 *1 36.96,223.02
X$45587 VDD VSS sg13g2_decap_8
* cell instance $45588 r0 *1 43.68,223.02
X$45588 VDD VSS sg13g2_decap_8
* cell instance $45589 r0 *1 33.6,223.02
X$45589 VDD VSS sg13g2_decap_8
* cell instance $45590 r0 *1 31.2,260.82
X$45590 VDD VSS sg13g2_decap_8
* cell instance $45591 r0 *1 79.2,291.06
X$45591 VDD VSS sg13g2_decap_8
* cell instance $45592 r0 *1 71.52,275.94
X$45592 VDD VSS sg13g2_decap_8
* cell instance $45593 r0 *1 84,298.62
X$45593 VDD VSS sg13g2_decap_8
* cell instance $45594 r0 *1 72.48,298.62
X$45594 VDD VSS sg13g2_decap_8
* cell instance $45595 r0 *1 80.64,298.62
X$45595 VDD VSS sg13g2_decap_8
* cell instance $45596 r0 *1 82.56,291.06
X$45596 VDD VSS sg13g2_decap_8
* cell instance $45597 r0 *1 43.68,275.94
X$45597 VDD VSS sg13g2_decap_8
* cell instance $45598 r0 *1 67.2,298.62
X$45598 VDD VSS sg13g2_decap_8
* cell instance $45599 r0 *1 47.04,275.94
X$45599 VDD VSS sg13g2_decap_8
* cell instance $45600 r0 *1 34.08,275.94
X$45600 VDD VSS sg13g2_decap_8
* cell instance $45601 r0 *1 30.72,275.94
X$45601 VDD VSS sg13g2_decap_8
* cell instance $45602 r0 *1 8.16,306.18
X$45602 VDD VSS sg13g2_decap_8
* cell instance $45603 r0 *1 64.8,283.5
X$45603 VDD VSS sg13g2_decap_8
* cell instance $45604 r0 *1 81.6,275.94
X$45604 VDD VSS sg13g2_decap_8
* cell instance $45605 r0 *1 78.24,275.94
X$45605 VDD VSS sg13g2_decap_8
* cell instance $45606 r0 *1 74.88,275.94
X$45606 VDD VSS sg13g2_decap_8
* cell instance $45607 r0 *1 51.36,200.34
X$45607 VDD VSS sg13g2_decap_8
* cell instance $45608 r0 *1 40.32,275.94
X$45608 VDD VSS sg13g2_decap_8
* cell instance $45609 r0 *1 48,200.34
X$45609 VDD VSS sg13g2_decap_8
* cell instance $45610 r0 *1 82.56,245.7
X$45610 VDD VSS sg13g2_decap_8
* cell instance $45611 r0 *1 85.92,245.7
X$45611 VDD VSS sg13g2_decap_8
* cell instance $45612 r0 *1 72.48,238.14
X$45612 VDD VSS sg13g2_decap_8
* cell instance $45613 r0 *1 83.04,253.26
X$45613 VDD VSS sg13g2_decap_8
* cell instance $45614 r0 *1 68.16,283.5
X$45614 VDD VSS sg13g2_decap_8
* cell instance $45615 r0 *1 54.72,200.34
X$45615 VDD VSS sg13g2_decap_8
* cell instance $45616 r0 *1 82.08,185.22
X$45616 VDD VSS sg13g2_decap_8
* cell instance $45617 r0 *1 306.24,321.3
X$45617 VDD VSS sg13g2_decap_8
* cell instance $45618 r0 *1 309.6,321.3
X$45618 VDD VSS sg13g2_decap_8
* cell instance $45619 r0 *1 284.16,328.86
X$45619 VDD VSS sg13g2_decap_8
* cell instance $45620 r0 *1 75.36,185.22
X$45620 VDD VSS sg13g2_decap_8
* cell instance $45621 r0 *1 78.72,185.22
X$45621 VDD VSS sg13g2_decap_8
* cell instance $45622 r0 *1 158.4,260.82
X$45622 VDD VSS sg13g2_decap_8
* cell instance $45623 r0 *1 82.56,268.38
X$45623 VDD VSS sg13g2_decap_8
* cell instance $45624 r0 *1 179.52,253.26
X$45624 VDD VSS sg13g2_decap_8
* cell instance $45625 r0 *1 147.84,253.26
X$45625 VDD VSS sg13g2_decap_8
* cell instance $45626 r0 *1 47.52,207.9
X$45626 VDD VSS sg13g2_decap_8
* cell instance $45627 r0 *1 79.2,268.38
X$45627 VDD VSS sg13g2_decap_8
* cell instance $45628 r0 *1 75.84,268.38
X$45628 VDD VSS sg13g2_decap_8
* cell instance $45629 r0 *1 155.04,253.26
X$45629 VDD VSS sg13g2_decap_8
* cell instance $45630 r0 *1 148.8,238.14
X$45630 VDD VSS sg13g2_decap_8
* cell instance $45631 r0 *1 173.28,268.38
X$45631 VDD VSS sg13g2_decap_8
* cell instance $45632 r0 *1 157.44,268.38
X$45632 VDD VSS sg13g2_decap_8
* cell instance $45633 r0 *1 168.48,238.14
X$45633 VDD VSS sg13g2_decap_8
* cell instance $45634 r0 *1 160.8,268.38
X$45634 VDD VSS sg13g2_decap_8
* cell instance $45635 r0 *1 285.6,343.98
X$45635 VDD VSS sg13g2_decap_8
* cell instance $45636 r0 *1 282.24,343.98
X$45636 VDD VSS sg13g2_decap_8
* cell instance $45637 r0 *1 125.76,260.82
X$45637 VDD VSS sg13g2_decap_8
* cell instance $45638 r0 *1 155.04,260.82
X$45638 VDD VSS sg13g2_decap_8
* cell instance $45639 r0 *1 8.16,185.22
X$45639 VDD VSS sg13g2_decap_8
* cell instance $45640 r0 *1 11.52,185.22
X$45640 VDD VSS sg13g2_decap_8
* cell instance $45641 r0 *1 42.24,192.78
X$45641 VDD VSS sg13g2_decap_8
* cell instance $45642 r0 *1 32.16,192.78
X$45642 VDD VSS sg13g2_decap_8
* cell instance $45643 r0 *1 38.88,192.78
X$45643 VDD VSS sg13g2_decap_8
* cell instance $45644 r0 *1 35.52,192.78
X$45644 VDD VSS sg13g2_decap_8
* cell instance $45645 r0 *1 103.2,275.94
X$45645 VDD VSS sg13g2_decap_8
* cell instance $45646 r0 *1 38.88,185.22
X$45646 VDD VSS sg13g2_decap_8
* cell instance $45647 r0 *1 37.92,200.34
X$45647 VDD VSS sg13g2_decap_8
* cell instance $45648 r0 *1 41.28,200.34
X$45648 VDD VSS sg13g2_decap_8
* cell instance $45649 r0 *1 44.64,200.34
X$45649 VDD VSS sg13g2_decap_8
* cell instance $45650 r0 *1 58.08,200.34
X$45650 VDD VSS sg13g2_decap_8
* cell instance $45651 r0 *1 35.52,185.22
X$45651 VDD VSS sg13g2_decap_8
* cell instance $45652 r0 *1 42.24,185.22
X$45652 VDD VSS sg13g2_decap_8
* cell instance $45653 r0 *1 72,185.22
X$45653 VDD VSS sg13g2_decap_8
* cell instance $45654 r0 *1 71.52,200.34
X$45654 VDD VSS sg13g2_decap_8
* cell instance $45655 r0 *1 71.52,223.02
X$45655 VDD VSS sg13g2_decap_8
* cell instance $45656 r0 *1 64.8,223.02
X$45656 VDD VSS sg13g2_decap_8
* cell instance $45657 r0 *1 68.16,223.02
X$45657 VDD VSS sg13g2_decap_8
* cell instance $45658 r0 *1 61.44,200.34
X$45658 VDD VSS sg13g2_decap_8
* cell instance $45659 r0 *1 65.28,192.78
X$45659 VDD VSS sg13g2_decap_8
* cell instance $45660 r0 *1 68.16,200.34
X$45660 VDD VSS sg13g2_decap_8
* cell instance $45661 r0 *1 64.8,200.34
X$45661 VDD VSS sg13g2_decap_8
* cell instance $45662 r0 *1 34.56,200.34
X$45662 VDD VSS sg13g2_decap_8
* cell instance $45663 r0 *1 8.16,56.7
X$45663 VDD VSS sg13g2_decap_8
* cell instance $45664 r0 *1 11.52,56.7
X$45664 VDD VSS sg13g2_decap_8
* cell instance $45665 r0 *1 185.28,192.78
X$45665 VDD VSS sg13g2_decap_8
* cell instance $45666 r0 *1 328.8,328.86
X$45666 VDD VSS sg13g2_decap_8
* cell instance $45667 r0 *1 37.44,56.7
X$45667 VDD VSS sg13g2_decap_8
* cell instance $45668 r0 *1 192,192.78
X$45668 VDD VSS sg13g2_decap_8
* cell instance $45669 r0 *1 31.2,64.26
X$45669 VDD VSS sg13g2_decap_8
* cell instance $45670 r0 *1 34.08,56.7
X$45670 VDD VSS sg13g2_decap_8
* cell instance $45671 r0 *1 325.44,328.86
X$45671 VDD VSS sg13g2_decap_8
* cell instance $45672 r0 *1 30.72,56.7
X$45672 VDD VSS sg13g2_decap_8
* cell instance $45673 r0 *1 171.84,117.18
X$45673 VDD VSS sg13g2_decap_8
* cell instance $45674 r0 *1 8.16,26.46
X$45674 VDD VSS sg13g2_decap_8
* cell instance $45675 r0 *1 31.2,26.46
X$45675 VDD VSS sg13g2_decap_8
* cell instance $45676 r0 *1 29.28,11.34
X$45676 VDD VSS sg13g2_decap_8
* cell instance $45677 r0 *1 41.28,26.46
X$45677 VDD VSS sg13g2_decap_8
* cell instance $45678 r0 *1 44.64,26.46
X$45678 VDD VSS sg13g2_decap_8
* cell instance $45679 r0 *1 197.76,223.02
X$45679 VDD VSS sg13g2_decap_8
* cell instance $45680 r0 *1 24.48,26.46
X$45680 VDD VSS sg13g2_decap_8
* cell instance $45681 r0 *1 29.76,18.9
X$45681 VDD VSS sg13g2_decap_8
* cell instance $45682 r0 *1 27.84,26.46
X$45682 VDD VSS sg13g2_decap_8
* cell instance $45683 r0 *1 36.96,34.02
X$45683 VDD VSS sg13g2_decap_8
* cell instance $45684 r0 *1 40.32,34.02
X$45684 VDD VSS sg13g2_decap_8
* cell instance $45685 r0 *1 201.12,223.02
X$45685 VDD VSS sg13g2_decap_8
* cell instance $45686 r0 *1 69.12,56.7
X$45686 VDD VSS sg13g2_decap_8
* cell instance $45687 r0 *1 82.08,64.26
X$45687 VDD VSS sg13g2_decap_8
* cell instance $45688 r0 *1 218.88,200.34
X$45688 VDD VSS sg13g2_decap_8
* cell instance $45689 r0 *1 222.24,200.34
X$45689 VDD VSS sg13g2_decap_8
* cell instance $45690 r0 *1 85.44,64.26
X$45690 VDD VSS sg13g2_decap_8
* cell instance $45691 r0 *1 75.36,64.26
X$45691 VDD VSS sg13g2_decap_8
* cell instance $45692 r0 *1 78.72,64.26
X$45692 VDD VSS sg13g2_decap_8
* cell instance $45693 r0 *1 27.84,64.26
X$45693 VDD VSS sg13g2_decap_8
* cell instance $45694 r0 *1 30.72,71.82
X$45694 VDD VSS sg13g2_decap_8
* cell instance $45695 r0 *1 26.4,86.94
X$45695 VDD VSS sg13g2_decap_8
* cell instance $45696 r0 *1 29.76,86.94
X$45696 VDD VSS sg13g2_decap_8
* cell instance $45697 r0 *1 8.16,64.26
X$45697 VDD VSS sg13g2_decap_8
* cell instance $45698 r0 *1 39.36,79.38
X$45698 VDD VSS sg13g2_decap_8
* cell instance $45699 r0 *1 33.12,86.94
X$45699 VDD VSS sg13g2_decap_8
* cell instance $45700 r0 *1 36,79.38
X$45700 VDD VSS sg13g2_decap_8
* cell instance $45701 r0 *1 195.36,192.78
X$45701 VDD VSS sg13g2_decap_8
* cell instance $45702 r0 *1 46.08,79.38
X$45702 VDD VSS sg13g2_decap_8
* cell instance $45703 r0 *1 42.72,79.38
X$45703 VDD VSS sg13g2_decap_8
* cell instance $45704 r0 *1 23.04,86.94
X$45704 VDD VSS sg13g2_decap_8
* cell instance $45705 r0 *1 18.24,64.26
X$45705 VDD VSS sg13g2_decap_8
* cell instance $45706 r0 *1 198.72,192.78
X$45706 VDD VSS sg13g2_decap_8
* cell instance $45707 r0 *1 11.52,64.26
X$45707 VDD VSS sg13g2_decap_8
* cell instance $45708 r0 *1 14.88,64.26
X$45708 VDD VSS sg13g2_decap_8
* cell instance $45709 r0 *1 188.64,192.78
X$45709 VDD VSS sg13g2_decap_8
* cell instance $45710 r0 *1 329.28,343.98
X$45710 VDD VSS sg13g2_decap_8
* cell instance $45711 r0 *1 222.72,238.14
X$45711 VDD VSS sg13g2_decap_8
* cell instance $45712 r0 *1 219.36,238.14
X$45712 VDD VSS sg13g2_decap_8
* cell instance $45713 r0 *1 79.68,11.34
X$45713 VDD VSS sg13g2_decap_8
* cell instance $45714 r0 *1 144,49.14
X$45714 VDD VSS sg13g2_decap_8
* cell instance $45715 r0 *1 192.96,238.14
X$45715 VDD VSS sg13g2_decap_8
* cell instance $45716 r0 *1 177.6,49.14
X$45716 VDD VSS sg13g2_decap_8
* cell instance $45717 r0 *1 148.8,71.82
X$45717 VDD VSS sg13g2_decap_8
* cell instance $45718 r0 *1 196.32,238.14
X$45718 VDD VSS sg13g2_decap_8
* cell instance $45719 r0 *1 172.8,86.94
X$45719 VDD VSS sg13g2_decap_8
* cell instance $45720 r0 *1 169.44,86.94
X$45720 VDD VSS sg13g2_decap_8
* cell instance $45721 r0 *1 46.08,41.58
X$45721 VDD VSS sg13g2_decap_8
* cell instance $45722 r0 *1 151.68,86.94
X$45722 VDD VSS sg13g2_decap_8
* cell instance $45723 r0 *1 206.4,260.82
X$45723 VDD VSS sg13g2_decap_8
* cell instance $45724 r0 *1 217.44,260.82
X$45724 VDD VSS sg13g2_decap_8
* cell instance $45725 r0 *1 348.48,343.98
X$45725 VDD VSS sg13g2_decap_8
* cell instance $45726 r0 *1 145.44,56.7
X$45726 VDD VSS sg13g2_decap_8
* cell instance $45727 r0 *1 176.64,64.26
X$45727 VDD VSS sg13g2_decap_8
* cell instance $45728 r0 *1 163.68,64.26
X$45728 VDD VSS sg13g2_decap_8
* cell instance $45729 r0 *1 201.12,245.7
X$45729 VDD VSS sg13g2_decap_8
* cell instance $45730 r0 *1 197.76,245.7
X$45730 VDD VSS sg13g2_decap_8
* cell instance $45731 r0 *1 256.8,230.58
X$45731 VDD VSS sg13g2_decap_8
* cell instance $45732 r0 *1 265.44,238.14
X$45732 VDD VSS sg13g2_decap_8
* cell instance $45733 r0 *1 148.32,86.94
X$45733 VDD VSS sg13g2_decap_8
* cell instance $45734 r0 *1 223.2,207.9
X$45734 VDD VSS sg13g2_decap_8
* cell instance $45735 r0 *1 219.84,207.9
X$45735 VDD VSS sg13g2_decap_8
* cell instance $45736 r0 *1 46.56,34.02
X$45736 VDD VSS sg13g2_decap_8
* cell instance $45737 r0 *1 219.84,223.02
X$45737 VDD VSS sg13g2_decap_8
* cell instance $45738 r0 *1 223.2,223.02
X$45738 VDD VSS sg13g2_decap_8
* cell instance $45739 r0 *1 8.16,41.58
X$45739 VDD VSS sg13g2_decap_8
* cell instance $45740 r0 *1 23.04,18.9
X$45740 VDD VSS sg13g2_decap_8
* cell instance $45741 r0 *1 216.48,223.02
X$45741 VDD VSS sg13g2_decap_8
* cell instance $45742 r0 *1 25.92,11.34
X$45742 VDD VSS sg13g2_decap_8
* cell instance $45744 r0 *1 202.08,200.34
X$45744 VDD VSS sg13g2_decap_8
* cell instance $45745 r0 *1 68.64,34.02
X$45745 VDD VSS sg13g2_decap_8
* cell instance $45746 r0 *1 202.08,192.78
X$45746 VDD VSS sg13g2_decap_8
* cell instance $45747 r0 *1 47.04,11.34
X$45747 VDD VSS sg13g2_decap_8
* cell instance $45748 r0 *1 204.48,223.02
X$45748 VDD VSS sg13g2_decap_8
* cell instance $45749 r0 *1 68.64,26.46
X$45749 VDD VSS sg13g2_decap_8
* cell instance $45750 r0 *1 72,34.02
X$45750 VDD VSS sg13g2_decap_8
* cell instance $45751 r0 *1 322.56,343.98
X$45751 VDD VSS sg13g2_decap_8
* cell instance $45752 r0 *1 81.12,34.02
X$45752 VDD VSS sg13g2_decap_8
* cell instance $45753 r0 *1 218.4,230.58
X$45753 VDD VSS sg13g2_decap_8
* cell instance $45754 r0 *1 325.92,343.98
X$45754 VDD VSS sg13g2_decap_8
* cell instance $45755 r0 *1 68.64,41.58
X$45755 VDD VSS sg13g2_decap_8
* cell instance $45756 r0 *1 221.76,230.58
X$45756 VDD VSS sg13g2_decap_8
* cell instance $45757 r0 *1 33.12,18.9
X$45757 VDD VSS sg13g2_decap_8
* cell instance $45758 r0 *1 66.72,139.86
X$45758 VDD VSS sg13g2_decap_8
* cell instance $45759 r0 *1 63.36,139.86
X$45759 VDD VSS sg13g2_decap_8
* cell instance $45760 r0 *1 76.8,139.86
X$45760 VDD VSS sg13g2_decap_8
* cell instance $45761 r0 *1 27.36,139.86
X$45761 VDD VSS sg13g2_decap_8
* cell instance $45762 r0 *1 29.28,154.98
X$45762 VDD VSS sg13g2_decap_8
* cell instance $45763 r0 *1 26.4,177.66
X$45763 VDD VSS sg13g2_decap_8
* cell instance $45764 r0 *1 32.16,170.1
X$45764 VDD VSS sg13g2_decap_8
* cell instance $45765 r0 *1 35.52,170.1
X$45765 VDD VSS sg13g2_decap_8
* cell instance $45766 r0 *1 45.6,177.66
X$45766 VDD VSS sg13g2_decap_8
* cell instance $45767 r0 *1 31.68,162.54
X$45767 VDD VSS sg13g2_decap_8
* cell instance $45768 r0 *1 65.76,56.7
X$45768 VDD VSS sg13g2_decap_8
* cell instance $45769 r0 *1 8.16,170.1
X$45769 VDD VSS sg13g2_decap_8
* cell instance $45770 r0 *1 228.48,185.22
X$45770 VDD VSS sg13g2_decap_8
* cell instance $45771 r0 *1 23.04,177.66
X$45771 VDD VSS sg13g2_decap_8
* cell instance $45772 r0 *1 37.44,147.42
X$45772 VDD VSS sg13g2_decap_8
* cell instance $45773 r0 *1 37.44,139.86
X$45773 VDD VSS sg13g2_decap_8
* cell instance $45774 r0 *1 34.08,147.42
X$45774 VDD VSS sg13g2_decap_8
* cell instance $45775 r0 *1 39.36,154.98
X$45775 VDD VSS sg13g2_decap_8
* cell instance $45776 r0 *1 42.72,154.98
X$45776 VDD VSS sg13g2_decap_8
* cell instance $45777 r0 *1 46.08,154.98
X$45777 VDD VSS sg13g2_decap_8
* cell instance $45778 r0 *1 32.64,154.98
X$45778 VDD VSS sg13g2_decap_8
* cell instance $45779 r0 *1 36,154.98
X$45779 VDD VSS sg13g2_decap_8
* cell instance $45780 r0 *1 11.52,170.1
X$45780 VDD VSS sg13g2_decap_8
* cell instance $45781 r0 *1 328.32,260.82
X$45781 VDD VSS sg13g2_decap_8
* cell instance $45782 r0 *1 143.04,124.74
X$45782 VDD VSS sg13g2_decap_8
* cell instance $45783 r0 *1 324.96,260.82
X$45783 VDD VSS sg13g2_decap_8
* cell instance $45784 r0 *1 149.28,102.06
X$45784 VDD VSS sg13g2_decap_8
* cell instance $45785 r0 *1 145.92,102.06
X$45785 VDD VSS sg13g2_decap_8
* cell instance $45786 r0 *1 142.56,102.06
X$45786 VDD VSS sg13g2_decap_8
* cell instance $45787 r0 *1 146.4,109.62
X$45787 VDD VSS sg13g2_decap_8
* cell instance $45788 r0 *1 169.44,109.62
X$45788 VDD VSS sg13g2_decap_8
* cell instance $45789 r0 *1 163.2,102.06
X$45789 VDD VSS sg13g2_decap_8
* cell instance $45790 r0 *1 162.72,109.62
X$45790 VDD VSS sg13g2_decap_8
* cell instance $45791 r0 *1 166.08,109.62
X$45791 VDD VSS sg13g2_decap_8
* cell instance $45792 r0 *1 64.8,154.98
X$45792 VDD VSS sg13g2_decap_8
* cell instance $45793 r0 *1 313.92,223.02
X$45793 VDD VSS sg13g2_decap_8
* cell instance $45794 r0 *1 312.96,238.14
X$45794 VDD VSS sg13g2_decap_8
* cell instance $45795 r0 *1 306.72,298.62
X$45795 VDD VSS sg13g2_decap_8
* cell instance $45796 r0 *1 71.04,162.54
X$45796 VDD VSS sg13g2_decap_8
* cell instance $45797 r0 *1 70.08,139.86
X$45797 VDD VSS sg13g2_decap_8
* cell instance $45798 r0 *1 70.56,177.66
X$45798 VDD VSS sg13g2_decap_8
* cell instance $45799 r0 *1 73.44,139.86
X$45799 VDD VSS sg13g2_decap_8
* cell instance $45800 r0 *1 75.36,170.1
X$45800 VDD VSS sg13g2_decap_8
* cell instance $45801 r0 *1 78.72,170.1
X$45801 VDD VSS sg13g2_decap_8
* cell instance $45802 r0 *1 82.08,170.1
X$45802 VDD VSS sg13g2_decap_8
* cell instance $45803 r0 *1 262.56,185.22
X$45803 VDD VSS sg13g2_decap_8
* cell instance $45804 r0 *1 313.92,200.34
X$45804 VDD VSS sg13g2_decap_8
* cell instance $45805 r0 *1 32.64,102.06
X$45805 VDD VSS sg13g2_decap_8
* cell instance $45806 r0 *1 36,102.06
X$45806 VDD VSS sg13g2_decap_8
* cell instance $45807 r0 *1 33.12,109.62
X$45807 VDD VSS sg13g2_decap_8
* cell instance $45808 r0 *1 262.08,207.9
X$45808 VDD VSS sg13g2_decap_8
* cell instance $45809 r0 *1 265.44,207.9
X$45809 VDD VSS sg13g2_decap_8
* cell instance $45810 r0 *1 75.36,132.3
X$45810 VDD VSS sg13g2_decap_8
* cell instance $45811 r0 *1 255.84,223.02
X$45811 VDD VSS sg13g2_decap_8
* cell instance $45812 r0 *1 280.8,306.18
X$45812 VDD VSS sg13g2_decap_8
* cell instance $45813 r0 *1 63.36,102.06
X$45813 VDD VSS sg13g2_decap_8
* cell instance $45814 r0 *1 252.48,223.02
X$45814 VDD VSS sg13g2_decap_8
* cell instance $45815 r0 *1 258.72,207.9
X$45815 VDD VSS sg13g2_decap_8
* cell instance $45816 r0 *1 30.72,139.86
X$45816 VDD VSS sg13g2_decap_8
* cell instance $45817 r0 *1 47.04,49.14
X$45817 VDD VSS sg13g2_decap_8
* cell instance $45818 r0 *1 36.48,49.14
X$45818 VDD VSS sg13g2_decap_8
* cell instance $45819 r0 *1 29.76,49.14
X$45819 VDD VSS sg13g2_decap_8
* cell instance $45820 r0 *1 33.12,49.14
X$45820 VDD VSS sg13g2_decap_8
* cell instance $45821 r0 *1 26.4,49.14
X$45821 VDD VSS sg13g2_decap_8
* cell instance $45822 r0 *1 70.56,71.82
X$45822 VDD VSS sg13g2_decap_8
* cell instance $45823 r0 *1 77.28,71.82
X$45823 VDD VSS sg13g2_decap_8
* cell instance $45824 r0 *1 73.92,71.82
X$45824 VDD VSS sg13g2_decap_8
* cell instance $45825 r0 *1 249.12,223.02
X$45825 VDD VSS sg13g2_decap_8
* cell instance $45826 r0 *1 67.2,86.94
X$45826 VDD VSS sg13g2_decap_8
* cell instance $45827 r0 *1 63.36,79.38
X$45827 VDD VSS sg13g2_decap_8
* cell instance $45828 r0 *1 23.04,49.14
X$45828 VDD VSS sg13g2_decap_8
* cell instance $45829 r0 *1 34.08,139.86
X$45829 VDD VSS sg13g2_decap_8
* cell instance $45830 r0 *1 40.8,139.86
X$45830 VDD VSS sg13g2_decap_8
* cell instance $45831 r0 *1 235.68,185.22
X$45831 VDD VSS sg13g2_decap_8
* cell instance $45832 r0 *1 29.76,117.18
X$45832 VDD VSS sg13g2_decap_8
* cell instance $45833 r0 *1 33.12,117.18
X$45833 VDD VSS sg13g2_decap_8
* cell instance $45834 r0 *1 36.48,117.18
X$45834 VDD VSS sg13g2_decap_8
* cell instance $45835 r0 *1 8.16,117.18
X$45835 VDD VSS sg13g2_decap_8
* cell instance $45836 r0 *1 11.52,117.18
X$45836 VDD VSS sg13g2_decap_8
* cell instance $45837 r0 *1 28.32,132.3
X$45837 VDD VSS sg13g2_decap_8
* cell instance $45838 r0 *1 26.4,109.62
X$45838 VDD VSS sg13g2_decap_8
* cell instance $45839 r0 *1 29.76,109.62
X$45839 VDD VSS sg13g2_decap_8
* cell instance $45840 r0 *1 39.36,102.06
X$45840 VDD VSS sg13g2_decap_8
* cell instance $45841 r0 *1 34.56,124.74
X$45841 VDD VSS sg13g2_decap_8
* cell instance $45842 r0 *1 37.92,124.74
X$45842 VDD VSS sg13g2_decap_8
* cell instance $45843 r0 *1 41.28,124.74
X$45843 VDD VSS sg13g2_decap_8
* cell instance $45844 r0 *1 31.68,132.3
X$45844 VDD VSS sg13g2_decap_8
* cell instance $45845 r0 *1 35.04,132.3
X$45845 VDD VSS sg13g2_decap_8
* cell instance $45846 r0 *1 24.96,132.3
X$45846 VDD VSS sg13g2_decap_8
* cell instance $45847 r0 *1 11.52,102.06
X$45847 VDD VSS sg13g2_decap_8
* cell instance $45848 r0 *1 8.16,102.06
X$45848 VDD VSS sg13g2_decap_8
* cell instance $45849 r0 *1 229.92,207.9
X$45849 VDD VSS sg13g2_decap_8
* cell instance $45850 r0 *1 23.04,109.62
X$45850 VDD VSS sg13g2_decap_8
* cell instance $45851 r0 *1 242.88,223.02
X$45851 VDD VSS sg13g2_decap_8
* cell instance $45852 r0 *1 31.2,124.74
X$45852 VDD VSS sg13g2_decap_8
.ENDS g1_digital

* cell g1_bgr
* pin vss
* pin vref
* pin pcasc
* pin iptat
* pin pbias
* pin r4
* pin vdd
.SUBCKT g1_bgr vss vref pcasc iptat pbias r4 vdd
* device instance $7 r0 *1 64.195,4.995 rhigh
R$7 det vss vss rhigh w=0.5u l=735u ps=0u b=0 m=1
* device instance $16 r0 *1 28.395,4.995 rppd
R$16 vss dvbe vss rppd w=1u l=51.5u ps=0u b=0 m=1
* device instance $17 r0 *1 18.895,4.995 rppd
R$17 vd1 vb2 vss rppd w=1u l=192u ps=0u b=0 m=1
* device instance $23 r0 *1 32.195,4.995 rppd
R$23 vbe3 vref vss rppd w=1u l=315u ps=0u b=0 m=1
* device instance $27 r0 *1 8.09,113 sg13_hv_pmos
M$27 vdd det kick vdd sg13_hv_pmos L=0.5u W=2u AS=0.68p AD=0.68p PS=4.68u
+ PD=4.68u rfmode=0
* device instance $28 r0 *1 10.39,113 sg13_hv_pmos
M$28 vdd r4 r4n vdd sg13_hv_pmos L=0.5u W=2u AS=0.68p AD=0.68p PS=4.68u
+ PD=4.68u rfmode=0
* device instance $29 r0 *1 48.84,96 sg13_hv_nmos
M$29 vbe vb2 n1 vss sg13_hv_nmos L=1u W=20u AS=6.8p AD=6.8p PS=41.36u PD=41.36u
+ rfmode=0
* device instance $30 r0 *1 51.64,96 sg13_hv_nmos
M$30 c2 vb2 pcasc vss sg13_hv_nmos L=1u W=20u AS=6.8p AD=6.8p PS=41.36u
+ PD=41.36u rfmode=0
* device instance $33 r0 *1 60.9,91.5 sg13_hv_nmos
M$33 vss det kick vss sg13_hv_nmos L=0.5u W=1u AS=0.34p AD=0.34p PS=2.68u
+ PD=2.68u rfmode=0
* device instance $34 r0 *1 74.5,91.5 sg13_hv_nmos
M$34 vss r4 r4n vss sg13_hv_nmos L=0.5u W=1u AS=0.34p AD=0.34p PS=2.68u
+ PD=2.68u rfmode=0
* device instance $35 r0 *1 72,91.5 sg13_hv_nmos
M$35 vss r4n b1b vss sg13_hv_nmos L=0.5u W=1u AS=0.34p AD=0.34p PS=2.68u
+ PD=2.68u rfmode=0
* device instance $36 r0 *1 64.5,91.5 sg13_hv_nmos
M$36 vss kick pbias vss sg13_hv_nmos L=4u W=1u AS=0.34p AD=0.34p PS=2.68u
+ PD=2.68u rfmode=0
* device instance $37 r0 *1 69.5,92 sg13_hv_nmos
M$37 b1b r4 vbe vss sg13_hv_nmos L=0.5u W=2u AS=0.68p AD=0.68p PS=4.68u
+ PD=4.68u rfmode=0
* device instance $46 r0 *1 45.495,4.995 rppd
R$46 pcasc pbias vss rppd w=1u l=500u ps=0u b=0 m=1
* device instance $48 r0 *1 8.1,74.88 npn13G2
Q$48 vss vss vss vss npn13G2 we=70n le=900n Nx=1 m=9
* device instance $52 r0 *1 39.6,68.17 npn13G2
Q$52 vbe b1b vss vss npn13G2 we=70n le=900n Nx=1 m=1
* device instance $53 r0 *1 39.6,74.88 npn13G2
Q$53 vbe vbe vss vss npn13G2 we=70n le=900n Nx=1 m=1
* device instance $57 r0 *1 27,68.17 npn13G2
Q$57 vd2 vd2 vss vss npn13G2 we=70n le=900n Nx=1 m=1
* device instance $60 r0 *1 45.9,68.17 npn13G2
Q$60 vbe3 vbe3 vss vss npn13G2 we=70n le=900n Nx=1 m=1
* device instance $61 r0 *1 52.2,74.88 npn13G2
Q$61 c2 vbe dvbe vss npn13G2 we=70n le=900n Nx=1 m=8
* device instance $65 r0 *1 33.3,68.17 npn13G2
Q$65 vd1 vd1 vd2 vss npn13G2 we=70n le=900n Nx=1 m=1
* device instance $70 r0 *1 10.34,96 sg13_hv_pmos
M$70 d5 pcasc vb2 d5 sg13_hv_pmos L=4u W=10u AS=3.4p AD=3.4p PS=20.68u
+ PD=20.68u rfmode=0
* device instance $71 r0 *1 42.34,96 sg13_hv_pmos
M$71 d4 pcasc iptat d4 sg13_hv_pmos L=4u W=10u AS=3.4p AD=3.4p PS=20.68u
+ PD=20.68u rfmode=0
* device instance $72 r0 *1 18.34,96 sg13_hv_pmos
M$72 d3 pcasc vref d3 sg13_hv_pmos L=4u W=10u AS=3.4p AD=3.4p PS=20.68u
+ PD=20.68u rfmode=0
* device instance $73 r0 *1 26.34,96 sg13_hv_pmos
M$73 d1 pcasc n1 d1 sg13_hv_pmos L=4u W=10u AS=3.4p AD=3.4p PS=20.68u PD=20.68u
+ rfmode=0
* device instance $74 r0 *1 34.34,96 sg13_hv_pmos
M$74 d2 pcasc pbias d2 sg13_hv_pmos L=4u W=10u AS=3.4p AD=3.4p PS=20.68u
+ PD=20.68u rfmode=0
* device instance $75 r0 *1 52.14,114.5 sg13_hv_pmos
M$75 vdd pbias d1 vdd sg13_hv_pmos L=4u W=10u AS=3.4p AD=3.4p PS=21.36u
+ PD=21.36u rfmode=0
* device instance $76 r0 *1 46.74,114.5 sg13_hv_pmos
M$76 vdd pbias d3 vdd sg13_hv_pmos L=4u W=10u AS=3.4p AD=3.4p PS=21.36u
+ PD=21.36u rfmode=0
* device instance $78 r0 *1 30.54,114.5 sg13_hv_pmos
M$78 vdd pbias d2 vdd sg13_hv_pmos L=4u W=10u AS=3.4p AD=3.4p PS=21.36u
+ PD=21.36u rfmode=0
* device instance $79 r0 *1 25.14,114.5 sg13_hv_pmos
M$79 vdd pbias d4 vdd sg13_hv_pmos L=4u W=10u AS=3.4p AD=3.4p PS=21.36u
+ PD=21.36u rfmode=0
* device instance $80 r0 *1 19.74,114.5 sg13_hv_pmos
M$80 vdd pbias d5 vdd sg13_hv_pmos L=4u W=10u AS=3.4p AD=3.4p PS=21.36u
+ PD=21.36u rfmode=0
* device instance $81 r0 *1 73.74,114.5 sg13_hv_pmos
M$81 vdd pbias det vdd sg13_hv_pmos L=4u W=10u AS=3.4p AD=3.4p PS=21.36u
+ PD=21.36u rfmode=0
.ENDS g1_bgr

* cell g1_ota
* pin vss
* pin vbn
* pin out
* pin vdd
* pin inn
* pin inp
.SUBCKT g1_ota vss vbn out vdd inn inp
* device instance $1 r0 *1 0.84,0.8 sg13_hv_nmos
M$1 vss \$5 \$5 vss sg13_hv_nmos L=1u W=1.6u AS=0.544p AD=0.544p PS=3.88u
+ PD=3.88u rfmode=0
* device instance $2 r0 *1 3.92,4 sg13_hv_nmos
M$2 vss vbn \$3 vss sg13_hv_nmos L=1u W=8u AS=2.72p AD=2.72p PS=16.68u
+ PD=16.68u rfmode=0
* device instance $3 r0 *1 7,4 sg13_hv_nmos
M$3 vss vbn \$2 vss sg13_hv_nmos L=1u W=8u AS=2.72p AD=2.72p PS=16.68u
+ PD=16.68u rfmode=0
* device instance $4 r0 *1 10.08,4 sg13_hv_nmos
M$4 vss vbn \$4 vss sg13_hv_nmos L=1u W=80u AS=16.4p AD=16.4p PS=92.1u PD=92.1u
+ rfmode=0
* device instance $14 r0 *1 45.54,4 sg13_hv_nmos
M$14 vss vbn \$7 vss sg13_hv_nmos L=1u W=80u AS=16.4p AD=16.4p PS=92.1u
+ PD=92.1u rfmode=0
* device instance $24 r0 *1 25.58,4 sg13_hv_nmos
M$24 \$4 \$5 \$19 vss sg13_hv_nmos L=1u W=48u AS=10.32p AD=10.32p PS=58.58u
+ PD=58.58u rfmode=0
* device instance $30 r0 *1 35.56,4 sg13_hv_nmos
M$30 \$7 \$5 \$33 vss sg13_hv_nmos L=1u W=48u AS=10.32p AD=10.32p PS=58.58u
+ PD=58.58u rfmode=0
* device instance $36 r0 *1 61.04,4 sg13_hv_nmos
M$36 vss vbn out vss sg13_hv_nmos L=1u W=96u AS=19.44p AD=19.44p PS=108.86u
+ PD=108.86u rfmode=0
* device instance $48 r0 *1 58.33,17.6 sg13_hv_pmos
M$48 vdd \$19 \$26 vdd sg13_hv_pmos L=1u W=96u AS=19.44p AD=19.44p PS=108.86u
+ PD=108.86u rfmode=0
* device instance $60 r0 *1 21.81,17.6 sg13_hv_pmos
M$60 \$25 \$2 \$19 vdd sg13_hv_pmos L=1u W=96u AS=19.44p AD=19.44p PS=108.86u
+ PD=108.86u rfmode=0
* device instance $72 r0 *1 3.55,17.6 sg13_hv_pmos
M$72 vdd \$19 \$25 vdd sg13_hv_pmos L=1u W=96u AS=19.44p AD=19.44p PS=108.86u
+ PD=108.86u rfmode=0
* device instance $84 r0 *1 40.07,17.6 sg13_hv_pmos
M$84 \$26 \$2 \$33 vdd sg13_hv_pmos L=1u W=96u AS=19.44p AD=19.44p PS=108.86u
+ PD=108.86u rfmode=0
* device instance $96 r0 *1 1.64,28 sg13_hv_pmos
M$96 \$28 inn \$4 vdd sg13_hv_pmos L=2u W=96u AS=19.14p AD=19.14p PS=108.38u
+ PD=108.38u rfmode=0
* device instance $98 r0 *1 6.4,28 sg13_hv_pmos
M$98 \$28 inp \$7 vdd sg13_hv_pmos L=2u W=96u AS=18.24p AD=18.24p PS=102.08u
+ PD=102.08u rfmode=0
* device instance $128 r0 *1 4.77,36.4 sg13_hv_pmos
M$128 vdd \$2 \$2 vdd sg13_hv_pmos L=1u W=3.2u AS=1.088p AD=1.088p PS=7.08u
+ PD=7.08u rfmode=0
* device instance $129 r0 *1 7.85,38.8 sg13_hv_pmos
M$129 vdd \$3 \$5 vdd sg13_hv_pmos L=1u W=16u AS=4.24p AD=4.24p PS=25.06u
+ PD=25.06u rfmode=0
* device instance $131 r0 *1 12.31,38.8 sg13_hv_pmos
M$131 vdd \$3 \$3 vdd sg13_hv_pmos L=1u W=16u AS=4.24p AD=4.24p PS=25.06u
+ PD=25.06u rfmode=0
* device instance $133 r0 *1 16.77,38.8 sg13_hv_pmos
M$133 vdd \$3 \$28 vdd sg13_hv_pmos L=1u W=128u AS=25.52p AD=25.52p PS=142.38u
+ PD=142.38u rfmode=0
* device instance $149 r0 *1 40.55,38.8 sg13_hv_pmos
M$149 vdd \$33 out vdd sg13_hv_pmos L=1u W=192u AS=37.68p AD=37.68p PS=209.42u
+ PD=209.42u rfmode=0
* device instance $173 r0 *1 84.555,25.995 rppd
R$173 \$33 \$32 vss rppd w=1u l=6.2u ps=0u b=0 m=1
* device instance $174 r0 *1 27.03,12.4 cap_cmim
C$174 \$32 out cap_cmim w=23u l=23u A=529p P=92u m=1
.ENDS g1_ota

* cell g1_cond
* pin vss
* pin isense
* pin icmp
.SUBCKT g1_cond vss isense icmp
* device instance $10 r0 *1 25.235,3.995 rppd
R$10 icmp isense vss rppd w=2u l=383.5u ps=0u b=0 m=1
* device instance $20 r0 *1 48.835,3.995 rppd
R$20 vss icmp vss rppd w=2u l=383.5u ps=0u b=0 m=1
* device instance $21 r0 *1 57.06,9 cap_cmim
C$21 icmp vss cap_cmim w=26u l=26u A=676p P=104u m=1
.ENDS g1_cond

* cell g1_cmp
* pin vss
* pin inp
* pin clk
* pin inn
* pin q
* pin vdd
.SUBCKT g1_cmp vss inp clk inn q vdd
* device instance $1 r0 *1 4.905,3 sg13_lv_nmos
M$1 \$9 inn \$9 vss sg13_lv_nmos L=0.13u W=6u AS=2.04p AD=2.04p PS=12.68u
+ PD=12.68u rfmode=0
* device instance $2 r0 *1 -7.905,2 sg13_lv_nmos
M$2 \$3 \$4 vss vss sg13_lv_nmos L=0.13u W=4u AS=1.36p AD=1.36p PS=8.68u
+ PD=8.68u rfmode=0
* device instance $3 r0 *1 -6.405,1.5 sg13_lv_nmos
M$3 \$4 \$5 \$9 vss sg13_lv_nmos L=0.13u W=3u AS=1.02p AD=1.02p PS=6.68u
+ PD=6.68u rfmode=0
* device instance $4 r0 *1 6.405,1.5 sg13_lv_nmos
M$4 \$8 \$4 \$5 vss sg13_lv_nmos L=0.13u W=3u AS=1.02p AD=1.02p PS=6.68u
+ PD=6.68u rfmode=0
* device instance $5 r0 *1 11.405,0.75 sg13_lv_nmos
M$5 vss qb q vss sg13_lv_nmos L=0.13u W=1.5u AS=0.51p AD=0.51p PS=3.68u
+ PD=3.68u rfmode=0
* device instance $6 r0 *1 2.58,3 sg13_lv_nmos
M$6 \$8 inn \$10 vss sg13_lv_nmos L=0.34u W=12u AS=3.18p AD=3.18p PS=19.06u
+ PD=19.06u rfmode=0
* device instance $8 r0 *1 9.905,0.75 sg13_lv_nmos
M$8 vss \$11 q vss sg13_lv_nmos L=0.13u W=1.5u AS=0.51p AD=0.51p PS=3.68u
+ PD=3.68u rfmode=0
* device instance $9 r0 *1 -9.905,0.75 sg13_lv_nmos
M$9 qb \$3 vss vss sg13_lv_nmos L=0.13u W=1.5u AS=0.51p AD=0.51p PS=3.68u
+ PD=3.68u rfmode=0
* device instance $10 r0 *1 -11.405,0.75 sg13_lv_nmos
M$10 qb q vss vss sg13_lv_nmos L=0.13u W=1.5u AS=0.51p AD=0.51p PS=3.68u
+ PD=3.68u rfmode=0
* device instance $11 r0 *1 7.905,2 sg13_lv_nmos
M$11 vss \$5 \$11 vss sg13_lv_nmos L=0.13u W=4u AS=1.36p AD=1.36p PS=8.68u
+ PD=8.68u rfmode=0
* device instance $12 r0 *1 -4.905,3 sg13_lv_nmos
M$12 \$8 inp \$8 vss sg13_lv_nmos L=0.13u W=6u AS=2.04p AD=2.04p PS=12.68u
+ PD=12.68u rfmode=0
* device instance $13 r0 *1 -0.765,2 sg13_lv_nmos
M$13 vss clk \$10 vss sg13_lv_nmos L=0.13u W=16u AS=3.64p AD=3.64p PS=21.82u
+ PD=21.82u rfmode=0
* device instance $17 r0 *1 -3.3,3 sg13_lv_nmos
M$17 \$9 inp \$10 vss sg13_lv_nmos L=0.34u W=12u AS=3.18p AD=3.18p PS=19.06u
+ PD=19.06u rfmode=0
* device instance $19 r0 *1 2.405,14 sg13_lv_pmos
M$19 vdd clk \$5 vdd sg13_lv_pmos L=0.13u W=6u AS=2.04p AD=2.04p PS=12.68u
+ PD=12.68u rfmode=0
* device instance $20 r0 *1 -2.405,14 sg13_lv_pmos
M$20 \$4 clk vdd vdd sg13_lv_pmos L=0.13u W=6u AS=2.04p AD=2.04p PS=12.68u
+ PD=12.68u rfmode=0
* device instance $21 r0 *1 11.405,13 sg13_lv_pmos
M$21 \$16 qb q vdd sg13_lv_pmos L=0.13u W=4u AS=1.36p AD=1.36p PS=8.68u
+ PD=8.68u rfmode=0
* device instance $22 r0 *1 9.905,13 sg13_lv_pmos
M$22 vdd \$11 \$16 vdd sg13_lv_pmos L=0.13u W=4u AS=1.36p AD=1.36p PS=8.68u
+ PD=8.68u rfmode=0
* device instance $23 r0 *1 -7.905,11.5 sg13_lv_pmos
M$23 \$3 \$4 vdd vdd sg13_lv_pmos L=0.13u W=1u AS=0.34p AD=0.34p PS=2.68u
+ PD=2.68u rfmode=0
* device instance $24 r0 *1 6.405,12.5 sg13_lv_pmos
M$24 vdd \$4 \$5 vdd sg13_lv_pmos L=0.13u W=3u AS=1.02p AD=1.02p PS=6.68u
+ PD=6.68u rfmode=0
* device instance $25 r0 *1 -11.405,13 sg13_lv_pmos
M$25 qb q \$15 vdd sg13_lv_pmos L=0.13u W=4u AS=1.36p AD=1.36p PS=8.68u
+ PD=8.68u rfmode=0
* device instance $26 r0 *1 -9.905,13 sg13_lv_pmos
M$26 \$15 \$3 vdd vdd sg13_lv_pmos L=0.13u W=4u AS=1.36p AD=1.36p PS=8.68u
+ PD=8.68u rfmode=0
* device instance $27 r0 *1 -6.405,12.5 sg13_lv_pmos
M$27 \$4 \$5 vdd vdd sg13_lv_pmos L=0.13u W=3u AS=1.02p AD=1.02p PS=6.68u
+ PD=6.68u rfmode=0
* device instance $28 r0 *1 7.905,11.5 sg13_lv_pmos
M$28 vdd \$5 \$11 vdd sg13_lv_pmos L=0.13u W=1u AS=0.34p AD=0.34p PS=2.68u
+ PD=2.68u rfmode=0
* device instance $29 r0 *1 -0.905,12.5 sg13_lv_pmos
M$29 \$9 clk vdd vdd sg13_lv_pmos L=0.13u W=3u AS=1.02p AD=1.02p PS=6.68u
+ PD=6.68u rfmode=0
* device instance $30 r0 *1 0.905,12.5 sg13_lv_pmos
M$30 vdd clk \$8 vdd sg13_lv_pmos L=0.13u W=3u AS=1.02p AD=1.02p PS=6.68u
+ PD=6.68u rfmode=0
.ENDS g1_cmp

* cell g1_dac8
* pin vss
* pin vdd
* pin d0
* pin d1
* pin d2
* pin d3
* pin d4
* pin d5
* pin d6
* pin d7
* pin vdda
* pin vref
* pin out
.SUBCKT g1_dac8 vss vdd d0 d1 d2 d3 d4 d5 d6 d7 vdda vref out
* device instance $1 r0 *1 10.405,3.25 sg13_lv_nmos
M$1 vss d0 \$11 vss sg13_lv_nmos L=0.13u W=0.5u AS=0.17p AD=0.17p PS=1.68u
+ PD=1.68u rfmode=0
* device instance $2 r0 *1 17.405,3.25 sg13_lv_nmos
M$2 vss d1 \$12 vss sg13_lv_nmos L=0.13u W=0.5u AS=0.17p AD=0.17p PS=1.68u
+ PD=1.68u rfmode=0
* device instance $3 r0 *1 24.405,3.25 sg13_lv_nmos
M$3 vss d2 \$13 vss sg13_lv_nmos L=0.13u W=0.5u AS=0.17p AD=0.17p PS=1.68u
+ PD=1.68u rfmode=0
* device instance $4 r0 *1 31.405,3.25 sg13_lv_nmos
M$4 vss d3 \$14 vss sg13_lv_nmos L=0.13u W=0.5u AS=0.17p AD=0.17p PS=1.68u
+ PD=1.68u rfmode=0
* device instance $5 r0 *1 38.405,3.25 sg13_lv_nmos
M$5 vss d4 \$15 vss sg13_lv_nmos L=0.13u W=0.5u AS=0.17p AD=0.17p PS=1.68u
+ PD=1.68u rfmode=0
* device instance $6 r0 *1 45.405,3.25 sg13_lv_nmos
M$6 vss d5 \$16 vss sg13_lv_nmos L=0.13u W=0.5u AS=0.17p AD=0.17p PS=1.68u
+ PD=1.68u rfmode=0
* device instance $7 r0 *1 52.405,3.25 sg13_lv_nmos
M$7 vss d6 \$17 vss sg13_lv_nmos L=0.13u W=0.5u AS=0.17p AD=0.17p PS=1.68u
+ PD=1.68u rfmode=0
* device instance $8 r0 *1 59.405,3.25 sg13_lv_nmos
M$8 vss d7 \$18 vss sg13_lv_nmos L=0.13u W=0.5u AS=0.17p AD=0.17p PS=1.68u
+ PD=1.68u rfmode=0
* device instance $9 r0 *1 10.565,7.55 sg13_hv_nmos
M$9 vss d0 \$19 vss sg13_hv_nmos L=0.45u W=1.9u AS=0.646p AD=0.646p PS=4.48u
+ PD=4.48u rfmode=0
* device instance $10 r0 *1 12.065,7.55 sg13_hv_nmos
M$10 vss \$11 \$35 vss sg13_hv_nmos L=0.45u W=1.9u AS=0.646p AD=0.646p PS=4.48u
+ PD=4.48u rfmode=0
* device instance $11 r0 *1 13.565,7.55 sg13_hv_nmos
M$11 vss \$19 \$20 vss sg13_hv_nmos L=0.45u W=1.9u AS=0.646p AD=0.646p PS=4.48u
+ PD=4.48u rfmode=0
* device instance $12 r0 *1 15.065,7.55 sg13_hv_nmos
M$12 vss \$20 \$36 vss sg13_hv_nmos L=0.45u W=1.9u AS=0.646p AD=0.646p PS=4.48u
+ PD=4.48u rfmode=0
* device instance $13 r0 *1 17.565,7.55 sg13_hv_nmos
M$13 vss d1 \$21 vss sg13_hv_nmos L=0.45u W=1.9u AS=0.646p AD=0.646p PS=4.48u
+ PD=4.48u rfmode=0
* device instance $14 r0 *1 19.065,7.55 sg13_hv_nmos
M$14 vss \$12 \$37 vss sg13_hv_nmos L=0.45u W=1.9u AS=0.646p AD=0.646p PS=4.48u
+ PD=4.48u rfmode=0
* device instance $15 r0 *1 20.565,7.55 sg13_hv_nmos
M$15 vss \$21 \$22 vss sg13_hv_nmos L=0.45u W=1.9u AS=0.646p AD=0.646p PS=4.48u
+ PD=4.48u rfmode=0
* device instance $16 r0 *1 22.065,7.55 sg13_hv_nmos
M$16 vss \$22 \$38 vss sg13_hv_nmos L=0.45u W=1.9u AS=0.646p AD=0.646p PS=4.48u
+ PD=4.48u rfmode=0
* device instance $17 r0 *1 24.565,7.55 sg13_hv_nmos
M$17 vss d2 \$23 vss sg13_hv_nmos L=0.45u W=1.9u AS=0.646p AD=0.646p PS=4.48u
+ PD=4.48u rfmode=0
* device instance $18 r0 *1 26.065,7.55 sg13_hv_nmos
M$18 vss \$13 \$39 vss sg13_hv_nmos L=0.45u W=1.9u AS=0.646p AD=0.646p PS=4.48u
+ PD=4.48u rfmode=0
* device instance $19 r0 *1 27.565,7.55 sg13_hv_nmos
M$19 vss \$23 \$24 vss sg13_hv_nmos L=0.45u W=1.9u AS=0.646p AD=0.646p PS=4.48u
+ PD=4.48u rfmode=0
* device instance $20 r0 *1 29.065,7.55 sg13_hv_nmos
M$20 vss \$24 \$40 vss sg13_hv_nmos L=0.45u W=1.9u AS=0.646p AD=0.646p PS=4.48u
+ PD=4.48u rfmode=0
* device instance $21 r0 *1 31.565,7.55 sg13_hv_nmos
M$21 vss d3 \$25 vss sg13_hv_nmos L=0.45u W=1.9u AS=0.646p AD=0.646p PS=4.48u
+ PD=4.48u rfmode=0
* device instance $22 r0 *1 33.065,7.55 sg13_hv_nmos
M$22 vss \$14 \$41 vss sg13_hv_nmos L=0.45u W=1.9u AS=0.646p AD=0.646p PS=4.48u
+ PD=4.48u rfmode=0
* device instance $23 r0 *1 34.565,7.55 sg13_hv_nmos
M$23 vss \$25 \$26 vss sg13_hv_nmos L=0.45u W=1.9u AS=0.646p AD=0.646p PS=4.48u
+ PD=4.48u rfmode=0
* device instance $24 r0 *1 36.065,7.55 sg13_hv_nmos
M$24 vss \$26 \$42 vss sg13_hv_nmos L=0.45u W=1.9u AS=0.646p AD=0.646p PS=4.48u
+ PD=4.48u rfmode=0
* device instance $25 r0 *1 38.565,7.55 sg13_hv_nmos
M$25 vss d4 \$27 vss sg13_hv_nmos L=0.45u W=1.9u AS=0.646p AD=0.646p PS=4.48u
+ PD=4.48u rfmode=0
* device instance $26 r0 *1 40.065,7.55 sg13_hv_nmos
M$26 vss \$15 \$43 vss sg13_hv_nmos L=0.45u W=1.9u AS=0.646p AD=0.646p PS=4.48u
+ PD=4.48u rfmode=0
* device instance $27 r0 *1 41.565,7.55 sg13_hv_nmos
M$27 vss \$27 \$28 vss sg13_hv_nmos L=0.45u W=1.9u AS=0.646p AD=0.646p PS=4.48u
+ PD=4.48u rfmode=0
* device instance $28 r0 *1 43.065,7.55 sg13_hv_nmos
M$28 vss \$28 \$44 vss sg13_hv_nmos L=0.45u W=1.9u AS=0.646p AD=0.646p PS=4.48u
+ PD=4.48u rfmode=0
* device instance $29 r0 *1 45.565,7.55 sg13_hv_nmos
M$29 vss d5 \$29 vss sg13_hv_nmos L=0.45u W=1.9u AS=0.646p AD=0.646p PS=4.48u
+ PD=4.48u rfmode=0
* device instance $30 r0 *1 47.065,7.55 sg13_hv_nmos
M$30 vss \$16 \$45 vss sg13_hv_nmos L=0.45u W=1.9u AS=0.646p AD=0.646p PS=4.48u
+ PD=4.48u rfmode=0
* device instance $31 r0 *1 48.565,7.55 sg13_hv_nmos
M$31 vss \$29 \$30 vss sg13_hv_nmos L=0.45u W=1.9u AS=0.646p AD=0.646p PS=4.48u
+ PD=4.48u rfmode=0
* device instance $32 r0 *1 50.065,7.55 sg13_hv_nmos
M$32 vss \$30 \$46 vss sg13_hv_nmos L=0.45u W=1.9u AS=0.646p AD=0.646p PS=4.48u
+ PD=4.48u rfmode=0
* device instance $33 r0 *1 52.565,7.55 sg13_hv_nmos
M$33 vss d6 \$31 vss sg13_hv_nmos L=0.45u W=1.9u AS=0.646p AD=0.646p PS=4.48u
+ PD=4.48u rfmode=0
* device instance $34 r0 *1 54.065,7.55 sg13_hv_nmos
M$34 vss \$17 \$47 vss sg13_hv_nmos L=0.45u W=1.9u AS=0.646p AD=0.646p PS=4.48u
+ PD=4.48u rfmode=0
* device instance $35 r0 *1 55.565,7.55 sg13_hv_nmos
M$35 vss \$31 \$32 vss sg13_hv_nmos L=0.45u W=1.9u AS=0.646p AD=0.646p PS=4.48u
+ PD=4.48u rfmode=0
* device instance $36 r0 *1 57.065,7.55 sg13_hv_nmos
M$36 vss \$32 \$48 vss sg13_hv_nmos L=0.45u W=1.9u AS=0.646p AD=0.646p PS=4.48u
+ PD=4.48u rfmode=0
* device instance $37 r0 *1 59.565,7.55 sg13_hv_nmos
M$37 vss d7 \$33 vss sg13_hv_nmos L=0.45u W=1.9u AS=0.646p AD=0.646p PS=4.48u
+ PD=4.48u rfmode=0
* device instance $38 r0 *1 61.065,7.55 sg13_hv_nmos
M$38 vss \$18 \$49 vss sg13_hv_nmos L=0.45u W=1.9u AS=0.646p AD=0.646p PS=4.48u
+ PD=4.48u rfmode=0
* device instance $39 r0 *1 62.565,7.55 sg13_hv_nmos
M$39 vss \$33 \$34 vss sg13_hv_nmos L=0.45u W=1.9u AS=0.646p AD=0.646p PS=4.48u
+ PD=4.48u rfmode=0
* device instance $40 r0 *1 64.065,7.55 sg13_hv_nmos
M$40 vss \$34 \$50 vss sg13_hv_nmos L=0.45u W=1.9u AS=0.646p AD=0.646p PS=4.48u
+ PD=4.48u rfmode=0
* device instance $41 r0 *1 31.75,26.635 sg13_hv_nmos
M$41 \$54 \$36 \$58 vss sg13_hv_nmos L=0.45u W=2u AS=0.68p AD=0.38p PS=4.68u
+ PD=2.38u rfmode=0
* device instance $42 r0 *1 31.75,27.465 sg13_hv_nmos
M$42 \$58 \$20 \$63 vss sg13_hv_nmos L=0.45u W=2u AS=0.38p AD=0.68p PS=2.38u
+ PD=4.68u rfmode=0
* device instance $43 r0 *1 31.75,30.155 sg13_hv_nmos
M$43 \$76 \$36 \$85 vss sg13_hv_nmos L=0.45u W=2u AS=0.68p AD=0.38p PS=4.68u
+ PD=2.38u rfmode=0
* device instance $44 r0 *1 31.75,30.985 sg13_hv_nmos
M$44 \$85 \$20 \$86 vss sg13_hv_nmos L=0.45u W=2u AS=0.38p AD=0.68p PS=2.38u
+ PD=4.68u rfmode=0
* device instance $45 r0 *1 31.75,33.675 sg13_hv_nmos
M$45 \$102 \$36 \$113 vss sg13_hv_nmos L=0.45u W=2u AS=0.68p AD=0.38p PS=4.68u
+ PD=2.38u rfmode=0
* device instance $46 r0 *1 31.75,34.505 sg13_hv_nmos
M$46 \$113 \$20 \$114 vss sg13_hv_nmos L=0.45u W=2u AS=0.38p AD=0.68p PS=2.38u
+ PD=4.68u rfmode=0
* device instance $47 r0 *1 37.23,35.435 sg13_hv_nmos
M$47 \$113 \$38 \$103 vss sg13_hv_nmos L=0.45u W=2u AS=0.68p AD=0.38p PS=4.68u
+ PD=2.38u rfmode=0
* device instance $48 r0 *1 37.23,36.265 sg13_hv_nmos
M$48 \$103 \$22 \$139 vss sg13_hv_nmos L=0.45u W=2u AS=0.38p AD=0.68p PS=2.38u
+ PD=4.68u rfmode=0
* device instance $49 r0 *1 37.23,28.395 sg13_hv_nmos
M$49 \$58 \$38 \$68 vss sg13_hv_nmos L=0.45u W=2u AS=0.68p AD=0.38p PS=4.68u
+ PD=2.38u rfmode=0
* device instance $50 r0 *1 37.23,29.225 sg13_hv_nmos
M$50 \$68 \$22 \$85 vss sg13_hv_nmos L=0.45u W=2u AS=0.38p AD=0.68p PS=2.38u
+ PD=4.68u rfmode=0
* device instance $51 r0 *1 37.23,31.915 sg13_hv_nmos
M$51 \$68 \$40 \$94 vss sg13_hv_nmos L=0.45u W=2u AS=0.68p AD=0.38p PS=4.68u
+ PD=2.38u rfmode=0
* device instance $52 r0 *1 37.23,32.745 sg13_hv_nmos
M$52 \$94 \$24 \$103 vss sg13_hv_nmos L=0.45u W=2u AS=0.38p AD=0.68p PS=2.38u
+ PD=4.68u rfmode=0
* device instance $53 r0 *1 48.45,28.395 sg13_hv_nmos
M$53 \$64 \$20 \$69 vss sg13_hv_nmos L=0.45u W=2u AS=0.68p AD=0.38p PS=4.68u
+ PD=2.38u rfmode=0
* device instance $54 r0 *1 48.45,29.225 sg13_hv_nmos
M$54 \$69 \$36 \$77 vss sg13_hv_nmos L=0.45u W=2u AS=0.38p AD=0.68p PS=2.38u
+ PD=4.68u rfmode=0
* device instance $55 r0 *1 48.45,35.435 sg13_hv_nmos
M$55 \$115 \$20 \$124 vss sg13_hv_nmos L=0.45u W=2u AS=0.68p AD=0.38p PS=4.68u
+ PD=2.38u rfmode=0
* device instance $56 r0 *1 48.45,36.265 sg13_hv_nmos
M$56 \$124 \$36 \$131 vss sg13_hv_nmos L=0.45u W=2u AS=0.38p AD=0.68p PS=2.38u
+ PD=4.68u rfmode=0
* device instance $57 r0 *1 48.45,31.915 sg13_hv_nmos
M$57 \$87 \$20 \$95 vss sg13_hv_nmos L=0.45u W=2u AS=0.68p AD=0.38p PS=4.68u
+ PD=2.38u rfmode=0
* device instance $58 r0 *1 48.45,32.745 sg13_hv_nmos
M$58 \$95 \$36 \$104 vss sg13_hv_nmos L=0.45u W=2u AS=0.38p AD=0.68p PS=2.38u
+ PD=4.68u rfmode=0
* device instance $59 r0 *1 53.93,30.155 sg13_hv_nmos
M$59 \$69 \$22 \$88 vss sg13_hv_nmos L=0.45u W=2u AS=0.68p AD=0.38p PS=4.68u
+ PD=2.38u rfmode=0
* device instance $60 r0 *1 53.93,30.985 sg13_hv_nmos
M$60 \$88 \$38 \$95 vss sg13_hv_nmos L=0.45u W=2u AS=0.38p AD=0.68p PS=2.38u
+ PD=4.68u rfmode=0
* device instance $61 r0 *1 53.93,33.675 sg13_hv_nmos
M$61 \$88 \$24 \$116 vss sg13_hv_nmos L=0.45u W=2u AS=0.68p AD=0.38p PS=4.68u
+ PD=2.38u rfmode=0
* device instance $62 r0 *1 53.93,34.505 sg13_hv_nmos
M$62 \$116 \$40 \$117 vss sg13_hv_nmos L=0.45u W=2u AS=0.38p AD=0.68p PS=2.38u
+ PD=4.68u rfmode=0
* device instance $63 r0 *1 65.15,26.635 sg13_hv_nmos
M$63 \$55 \$36 \$59 vss sg13_hv_nmos L=0.45u W=2u AS=0.68p AD=0.38p PS=4.68u
+ PD=2.38u rfmode=0
* device instance $64 r0 *1 65.15,27.465 sg13_hv_nmos
M$64 \$59 \$20 \$65 vss sg13_hv_nmos L=0.45u W=2u AS=0.38p AD=0.68p PS=2.38u
+ PD=4.68u rfmode=0
* device instance $65 r0 *1 65.15,33.675 sg13_hv_nmos
M$65 \$105 \$36 \$118 vss sg13_hv_nmos L=0.45u W=2u AS=0.68p AD=0.38p PS=4.68u
+ PD=2.38u rfmode=0
* device instance $66 r0 *1 65.15,34.505 sg13_hv_nmos
M$66 \$118 \$20 \$119 vss sg13_hv_nmos L=0.45u W=2u AS=0.38p AD=0.68p PS=2.38u
+ PD=4.68u rfmode=0
* device instance $67 r0 *1 65.15,30.155 sg13_hv_nmos
M$67 \$78 \$36 \$89 vss sg13_hv_nmos L=0.45u W=2u AS=0.68p AD=0.38p PS=4.68u
+ PD=2.38u rfmode=0
* device instance $68 r0 *1 65.15,30.985 sg13_hv_nmos
M$68 \$89 \$20 \$90 vss sg13_hv_nmos L=0.45u W=2u AS=0.38p AD=0.68p PS=2.38u
+ PD=4.68u rfmode=0
* device instance $69 r0 *1 70.63,28.395 sg13_hv_nmos
M$69 \$59 \$38 \$70 vss sg13_hv_nmos L=0.45u W=2u AS=0.68p AD=0.38p PS=4.68u
+ PD=2.38u rfmode=0
* device instance $70 r0 *1 70.63,29.225 sg13_hv_nmos
M$70 \$70 \$22 \$89 vss sg13_hv_nmos L=0.45u W=2u AS=0.38p AD=0.68p PS=2.38u
+ PD=4.68u rfmode=0
* device instance $71 r0 *1 70.63,31.915 sg13_hv_nmos
M$71 \$70 \$40 \$96 vss sg13_hv_nmos L=0.45u W=2u AS=0.68p AD=0.38p PS=4.68u
+ PD=2.38u rfmode=0
* device instance $72 r0 *1 70.63,32.745 sg13_hv_nmos
M$72 \$96 \$24 \$106 vss sg13_hv_nmos L=0.45u W=2u AS=0.38p AD=0.68p PS=2.38u
+ PD=4.68u rfmode=0
* device instance $73 r0 *1 70.63,35.435 sg13_hv_nmos
M$73 \$118 \$38 \$106 vss sg13_hv_nmos L=0.45u W=2u AS=0.68p AD=0.38p PS=4.68u
+ PD=2.38u rfmode=0
* device instance $74 r0 *1 70.63,36.265 sg13_hv_nmos
M$74 \$106 \$22 \$142 vss sg13_hv_nmos L=0.45u W=2u AS=0.38p AD=0.68p PS=2.38u
+ PD=4.68u rfmode=0
* device instance $75 r0 *1 81.85,35.435 sg13_hv_nmos
M$75 \$120 \$20 \$125 vss sg13_hv_nmos L=0.45u W=2u AS=0.68p AD=0.38p PS=4.68u
+ PD=2.38u rfmode=0
* device instance $76 r0 *1 81.85,36.265 sg13_hv_nmos
M$76 \$125 \$36 \$133 vss sg13_hv_nmos L=0.45u W=2u AS=0.38p AD=0.68p PS=2.38u
+ PD=4.68u rfmode=0
* device instance $77 r0 *1 81.85,28.395 sg13_hv_nmos
M$77 \$66 \$20 \$71 vss sg13_hv_nmos L=0.45u W=2u AS=0.68p AD=0.38p PS=4.68u
+ PD=2.38u rfmode=0
* device instance $78 r0 *1 81.85,29.225 sg13_hv_nmos
M$78 \$71 \$36 \$79 vss sg13_hv_nmos L=0.45u W=2u AS=0.38p AD=0.68p PS=2.38u
+ PD=4.68u rfmode=0
* device instance $79 r0 *1 81.85,31.915 sg13_hv_nmos
M$79 \$91 \$20 \$97 vss sg13_hv_nmos L=0.45u W=2u AS=0.68p AD=0.38p PS=4.68u
+ PD=2.38u rfmode=0
* device instance $80 r0 *1 81.85,32.745 sg13_hv_nmos
M$80 \$97 \$36 \$107 vss sg13_hv_nmos L=0.45u W=2u AS=0.38p AD=0.68p PS=2.38u
+ PD=4.68u rfmode=0
* device instance $81 r0 *1 87.33,30.155 sg13_hv_nmos
M$81 \$71 \$22 \$92 vss sg13_hv_nmos L=0.45u W=2u AS=0.68p AD=0.38p PS=4.68u
+ PD=2.38u rfmode=0
* device instance $82 r0 *1 87.33,30.985 sg13_hv_nmos
M$82 \$92 \$38 \$97 vss sg13_hv_nmos L=0.45u W=2u AS=0.38p AD=0.68p PS=2.38u
+ PD=4.68u rfmode=0
* device instance $83 r0 *1 87.33,33.675 sg13_hv_nmos
M$83 \$92 \$24 \$122 vss sg13_hv_nmos L=0.45u W=2u AS=0.68p AD=0.38p PS=4.68u
+ PD=2.38u rfmode=0
* device instance $84 r0 *1 87.33,34.505 sg13_hv_nmos
M$84 \$122 \$40 \$121 vss sg13_hv_nmos L=0.45u W=2u AS=0.38p AD=0.68p PS=2.38u
+ PD=4.68u rfmode=0
* device instance $85 r0 *1 31.75,37.195 sg13_hv_nmos
M$85 \$130 \$36 \$139 vss sg13_hv_nmos L=0.45u W=2u AS=0.68p AD=0.38p PS=4.68u
+ PD=2.38u rfmode=0
* device instance $86 r0 *1 31.75,38.025 sg13_hv_nmos
M$86 \$139 \$20 \$140 vss sg13_hv_nmos L=0.45u W=2u AS=0.38p AD=0.68p PS=2.38u
+ PD=4.68u rfmode=0
* device instance $87 r0 *1 53.93,37.195 sg13_hv_nmos
M$87 \$124 \$22 \$117 vss sg13_hv_nmos L=0.45u W=2u AS=0.68p AD=0.38p PS=4.68u
+ PD=2.38u rfmode=0
* device instance $88 r0 *1 53.93,38.025 sg13_hv_nmos
M$88 \$117 \$38 \$147 vss sg13_hv_nmos L=0.45u W=2u AS=0.38p AD=0.68p PS=2.38u
+ PD=4.68u rfmode=0
* device instance $89 r0 *1 65.15,37.195 sg13_hv_nmos
M$89 \$132 \$36 \$142 vss sg13_hv_nmos L=0.45u W=2u AS=0.68p AD=0.38p PS=4.68u
+ PD=2.38u rfmode=0
* device instance $90 r0 *1 65.15,38.025 sg13_hv_nmos
M$90 \$142 \$20 \$143 vss sg13_hv_nmos L=0.45u W=2u AS=0.38p AD=0.68p PS=2.38u
+ PD=4.68u rfmode=0
* device instance $91 r0 *1 87.33,37.195 sg13_hv_nmos
M$91 \$125 \$22 \$121 vss sg13_hv_nmos L=0.45u W=2u AS=0.68p AD=0.38p PS=4.68u
+ PD=2.38u rfmode=0
* device instance $92 r0 *1 87.33,38.025 sg13_hv_nmos
M$92 \$121 \$38 \$149 vss sg13_hv_nmos L=0.45u W=2u AS=0.38p AD=0.68p PS=2.38u
+ PD=4.68u rfmode=0
* device instance $93 r0 *1 37.23,38.955 sg13_hv_nmos
M$93 \$94 \$42 \$146 vss sg13_hv_nmos L=0.45u W=2u AS=0.68p AD=0.38p PS=4.68u
+ PD=2.38u rfmode=0
* device instance $94 r0 *1 37.23,39.785 sg13_hv_nmos
M$94 \$146 \$26 \$155 vss sg13_hv_nmos L=0.45u W=2u AS=0.38p AD=0.68p PS=2.38u
+ PD=4.68u rfmode=0
* device instance $95 r0 *1 48.45,38.955 sg13_hv_nmos
M$95 \$141 \$20 \$147 vss sg13_hv_nmos L=0.45u W=2u AS=0.68p AD=0.38p PS=4.68u
+ PD=2.38u rfmode=0
* device instance $96 r0 *1 48.45,39.785 sg13_hv_nmos
M$96 \$147 \$36 \$156 vss sg13_hv_nmos L=0.45u W=2u AS=0.38p AD=0.68p PS=2.38u
+ PD=4.68u rfmode=0
* device instance $97 r0 *1 70.63,38.955 sg13_hv_nmos
M$97 \$96 \$42 \$148 vss sg13_hv_nmos L=0.45u W=2u AS=0.68p AD=0.38p PS=4.68u
+ PD=2.38u rfmode=0
* device instance $98 r0 *1 70.63,39.785 sg13_hv_nmos
M$98 \$148 \$26 \$158 vss sg13_hv_nmos L=0.45u W=2u AS=0.38p AD=0.68p PS=2.38u
+ PD=4.68u rfmode=0
* device instance $99 r0 *1 81.85,38.955 sg13_hv_nmos
M$99 \$144 \$20 \$149 vss sg13_hv_nmos L=0.45u W=2u AS=0.68p AD=0.38p PS=4.68u
+ PD=2.38u rfmode=0
* device instance $100 r0 *1 81.85,39.785 sg13_hv_nmos
M$100 \$149 \$36 \$159 vss sg13_hv_nmos L=0.45u W=2u AS=0.38p AD=0.68p PS=2.38u
+ PD=4.68u rfmode=0
* device instance $101 r0 *1 31.75,40.715 sg13_hv_nmos
M$101 \$154 \$36 \$165 vss sg13_hv_nmos L=0.45u W=2u AS=0.68p AD=0.38p PS=4.68u
+ PD=2.38u rfmode=0
* device instance $102 r0 *1 31.75,41.545 sg13_hv_nmos
M$102 \$165 \$20 \$166 vss sg13_hv_nmos L=0.45u W=2u AS=0.38p AD=0.68p PS=2.38u
+ PD=4.68u rfmode=0
* device instance $103 r0 *1 53.93,40.715 sg13_hv_nmos
M$103 \$116 \$26 \$168 vss sg13_hv_nmos L=0.45u W=2u AS=0.68p AD=0.38p PS=4.68u
+ PD=2.38u rfmode=0
* device instance $104 r0 *1 53.93,41.545 sg13_hv_nmos
M$104 \$168 \$42 \$169 vss sg13_hv_nmos L=0.45u W=2u AS=0.38p AD=0.68p PS=2.38u
+ PD=4.68u rfmode=0
* device instance $105 r0 *1 65.15,40.715 sg13_hv_nmos
M$105 \$157 \$36 \$170 vss sg13_hv_nmos L=0.45u W=2u AS=0.68p AD=0.38p PS=4.68u
+ PD=2.38u rfmode=0
* device instance $106 r0 *1 65.15,41.545 sg13_hv_nmos
M$106 \$170 \$20 \$171 vss sg13_hv_nmos L=0.45u W=2u AS=0.38p AD=0.68p PS=2.38u
+ PD=4.68u rfmode=0
* device instance $107 r0 *1 87.33,40.715 sg13_hv_nmos
M$107 \$122 \$26 \$173 vss sg13_hv_nmos L=0.45u W=2u AS=0.68p AD=0.38p PS=4.68u
+ PD=2.38u rfmode=0
* device instance $108 r0 *1 87.33,41.545 sg13_hv_nmos
M$108 \$173 \$42 \$174 vss sg13_hv_nmos L=0.45u W=2u AS=0.38p AD=0.68p PS=2.38u
+ PD=4.68u rfmode=0
* device instance $109 r0 *1 37.23,42.475 sg13_hv_nmos
M$109 \$165 \$38 \$176 vss sg13_hv_nmos L=0.45u W=2u AS=0.68p AD=0.38p PS=4.68u
+ PD=2.38u rfmode=0
* device instance $110 r0 *1 37.23,43.305 sg13_hv_nmos
M$110 \$176 \$22 \$193 vss sg13_hv_nmos L=0.45u W=2u AS=0.38p AD=0.68p PS=2.38u
+ PD=4.68u rfmode=0
* device instance $111 r0 *1 48.45,42.475 sg13_hv_nmos
M$111 \$167 \$20 \$177 vss sg13_hv_nmos L=0.45u W=2u AS=0.68p AD=0.38p PS=4.68u
+ PD=2.38u rfmode=0
* device instance $112 r0 *1 48.45,43.305 sg13_hv_nmos
M$112 \$177 \$36 \$185 vss sg13_hv_nmos L=0.45u W=2u AS=0.38p AD=0.68p PS=2.38u
+ PD=4.68u rfmode=0
* device instance $113 r0 *1 70.63,42.475 sg13_hv_nmos
M$113 \$170 \$38 \$178 vss sg13_hv_nmos L=0.45u W=2u AS=0.68p AD=0.38p PS=4.68u
+ PD=2.38u rfmode=0
* device instance $114 r0 *1 70.63,43.305 sg13_hv_nmos
M$114 \$178 \$22 \$197 vss sg13_hv_nmos L=0.45u W=2u AS=0.38p AD=0.68p PS=2.38u
+ PD=4.68u rfmode=0
* device instance $115 r0 *1 81.85,42.475 sg13_hv_nmos
M$115 \$172 \$20 \$179 vss sg13_hv_nmos L=0.45u W=2u AS=0.68p AD=0.38p PS=4.68u
+ PD=2.38u rfmode=0
* device instance $116 r0 *1 81.85,43.305 sg13_hv_nmos
M$116 \$179 \$36 \$187 vss sg13_hv_nmos L=0.45u W=2u AS=0.38p AD=0.68p PS=2.38u
+ PD=4.68u rfmode=0
* device instance $117 r0 *1 31.75,44.235 sg13_hv_nmos
M$117 \$184 \$36 \$193 vss sg13_hv_nmos L=0.45u W=2u AS=0.68p AD=0.38p PS=4.68u
+ PD=2.38u rfmode=0
* device instance $118 r0 *1 31.75,45.065 sg13_hv_nmos
M$118 \$193 \$20 \$194 vss sg13_hv_nmos L=0.45u W=2u AS=0.38p AD=0.68p PS=2.38u
+ PD=4.68u rfmode=0
* device instance $119 r0 *1 53.93,44.235 sg13_hv_nmos
M$119 \$177 \$22 \$196 vss sg13_hv_nmos L=0.45u W=2u AS=0.68p AD=0.38p PS=4.68u
+ PD=2.38u rfmode=0
* device instance $120 r0 *1 53.93,45.065 sg13_hv_nmos
M$120 \$196 \$38 \$202 vss sg13_hv_nmos L=0.45u W=2u AS=0.38p AD=0.68p PS=2.38u
+ PD=4.68u rfmode=0
* device instance $121 r0 *1 65.15,44.235 sg13_hv_nmos
M$121 \$186 \$36 \$197 vss sg13_hv_nmos L=0.45u W=2u AS=0.68p AD=0.38p PS=4.68u
+ PD=2.38u rfmode=0
* device instance $122 r0 *1 65.15,45.065 sg13_hv_nmos
M$122 \$197 \$20 \$198 vss sg13_hv_nmos L=0.45u W=2u AS=0.38p AD=0.68p PS=2.38u
+ PD=4.68u rfmode=0
* device instance $123 r0 *1 87.33,44.235 sg13_hv_nmos
M$123 \$179 \$22 \$200 vss sg13_hv_nmos L=0.45u W=2u AS=0.68p AD=0.38p PS=4.68u
+ PD=2.38u rfmode=0
* device instance $124 r0 *1 87.33,45.065 sg13_hv_nmos
M$124 \$200 \$38 \$203 vss sg13_hv_nmos L=0.45u W=2u AS=0.38p AD=0.68p PS=2.38u
+ PD=4.68u rfmode=0
* device instance $125 r0 *1 37.23,45.995 sg13_hv_nmos
M$125 \$176 \$40 \$155 vss sg13_hv_nmos L=0.45u W=2u AS=0.68p AD=0.38p PS=4.68u
+ PD=2.38u rfmode=0
* device instance $126 r0 *1 37.23,46.825 sg13_hv_nmos
M$126 \$155 \$24 \$209 vss sg13_hv_nmos L=0.45u W=2u AS=0.38p AD=0.68p PS=2.38u
+ PD=4.68u rfmode=0
* device instance $127 r0 *1 48.45,45.995 sg13_hv_nmos
M$127 \$195 \$20 \$202 vss sg13_hv_nmos L=0.45u W=2u AS=0.68p AD=0.38p PS=4.68u
+ PD=2.38u rfmode=0
* device instance $128 r0 *1 48.45,46.825 sg13_hv_nmos
M$128 \$202 \$36 \$210 vss sg13_hv_nmos L=0.45u W=2u AS=0.38p AD=0.68p PS=2.38u
+ PD=4.68u rfmode=0
* device instance $129 r0 *1 70.63,45.995 sg13_hv_nmos
M$129 \$178 \$40 \$158 vss sg13_hv_nmos L=0.45u W=2u AS=0.68p AD=0.38p PS=4.68u
+ PD=2.38u rfmode=0
* device instance $130 r0 *1 70.63,46.825 sg13_hv_nmos
M$130 \$158 \$24 \$212 vss sg13_hv_nmos L=0.45u W=2u AS=0.38p AD=0.68p PS=2.38u
+ PD=4.68u rfmode=0
* device instance $131 r0 *1 81.85,45.995 sg13_hv_nmos
M$131 \$199 \$20 \$203 vss sg13_hv_nmos L=0.45u W=2u AS=0.68p AD=0.38p PS=4.68u
+ PD=2.38u rfmode=0
* device instance $132 r0 *1 81.85,46.825 sg13_hv_nmos
M$132 \$203 \$36 \$213 vss sg13_hv_nmos L=0.45u W=2u AS=0.38p AD=0.68p PS=2.38u
+ PD=4.68u rfmode=0
* device instance $133 r0 *1 31.75,47.755 sg13_hv_nmos
M$133 \$208 \$36 \$219 vss sg13_hv_nmos L=0.45u W=2u AS=0.68p AD=0.38p PS=4.68u
+ PD=2.38u rfmode=0
* device instance $134 r0 *1 31.75,48.585 sg13_hv_nmos
M$134 \$219 \$20 \$220 vss sg13_hv_nmos L=0.45u W=2u AS=0.38p AD=0.68p PS=2.38u
+ PD=4.68u rfmode=0
* device instance $135 r0 *1 53.93,47.755 sg13_hv_nmos
M$135 \$196 \$24 \$169 vss sg13_hv_nmos L=0.45u W=2u AS=0.68p AD=0.38p PS=4.68u
+ PD=2.38u rfmode=0
* device instance $136 r0 *1 53.93,48.585 sg13_hv_nmos
M$136 \$169 \$40 \$222 vss sg13_hv_nmos L=0.45u W=2u AS=0.38p AD=0.68p PS=2.38u
+ PD=4.68u rfmode=0
* device instance $137 r0 *1 65.15,47.755 sg13_hv_nmos
M$137 \$211 \$36 \$223 vss sg13_hv_nmos L=0.45u W=2u AS=0.68p AD=0.38p PS=4.68u
+ PD=2.38u rfmode=0
* device instance $138 r0 *1 65.15,48.585 sg13_hv_nmos
M$138 \$223 \$20 \$224 vss sg13_hv_nmos L=0.45u W=2u AS=0.38p AD=0.68p PS=2.38u
+ PD=4.68u rfmode=0
* device instance $139 r0 *1 87.33,47.755 sg13_hv_nmos
M$139 \$200 \$24 \$174 vss sg13_hv_nmos L=0.45u W=2u AS=0.68p AD=0.38p PS=4.68u
+ PD=2.38u rfmode=0
* device instance $140 r0 *1 87.33,48.585 sg13_hv_nmos
M$140 \$174 \$40 \$226 vss sg13_hv_nmos L=0.45u W=2u AS=0.38p AD=0.68p PS=2.38u
+ PD=4.68u rfmode=0
* device instance $141 r0 *1 37.23,49.515 sg13_hv_nmos
M$141 \$219 \$38 \$209 vss sg13_hv_nmos L=0.45u W=2u AS=0.68p AD=0.38p PS=4.68u
+ PD=2.38u rfmode=0
* device instance $142 r0 *1 37.23,50.345 sg13_hv_nmos
M$142 \$209 \$22 \$243 vss sg13_hv_nmos L=0.45u W=2u AS=0.38p AD=0.68p PS=2.38u
+ PD=4.68u rfmode=0
* device instance $143 r0 *1 48.45,49.515 sg13_hv_nmos
M$143 \$221 \$20 \$228 vss sg13_hv_nmos L=0.45u W=2u AS=0.68p AD=0.38p PS=4.68u
+ PD=2.38u rfmode=0
* device instance $144 r0 *1 48.45,50.345 sg13_hv_nmos
M$144 \$228 \$36 \$235 vss sg13_hv_nmos L=0.45u W=2u AS=0.38p AD=0.68p PS=2.38u
+ PD=4.68u rfmode=0
* device instance $145 r0 *1 70.63,49.515 sg13_hv_nmos
M$145 \$223 \$38 \$212 vss sg13_hv_nmos L=0.45u W=2u AS=0.68p AD=0.38p PS=4.68u
+ PD=2.38u rfmode=0
* device instance $146 r0 *1 70.63,50.345 sg13_hv_nmos
M$146 \$212 \$22 \$246 vss sg13_hv_nmos L=0.45u W=2u AS=0.38p AD=0.68p PS=2.38u
+ PD=4.68u rfmode=0
* device instance $147 r0 *1 81.85,49.515 sg13_hv_nmos
M$147 \$225 \$20 \$229 vss sg13_hv_nmos L=0.45u W=2u AS=0.68p AD=0.38p PS=4.68u
+ PD=2.38u rfmode=0
* device instance $148 r0 *1 81.85,50.345 sg13_hv_nmos
M$148 \$229 \$36 \$237 vss sg13_hv_nmos L=0.45u W=2u AS=0.38p AD=0.68p PS=2.38u
+ PD=4.68u rfmode=0
* device instance $149 r0 *1 31.75,51.275 sg13_hv_nmos
M$149 \$234 \$36 \$243 vss sg13_hv_nmos L=0.45u W=2u AS=0.68p AD=0.38p PS=4.68u
+ PD=2.38u rfmode=0
* device instance $150 r0 *1 31.75,52.105 sg13_hv_nmos
M$150 \$243 \$20 \$244 vss sg13_hv_nmos L=0.45u W=2u AS=0.38p AD=0.68p PS=2.38u
+ PD=4.68u rfmode=0
* device instance $151 r0 *1 53.93,51.275 sg13_hv_nmos
M$151 \$228 \$22 \$222 vss sg13_hv_nmos L=0.45u W=2u AS=0.68p AD=0.38p PS=4.68u
+ PD=2.38u rfmode=0
* device instance $152 r0 *1 53.93,52.105 sg13_hv_nmos
M$152 \$222 \$38 \$251 vss sg13_hv_nmos L=0.45u W=2u AS=0.38p AD=0.68p PS=2.38u
+ PD=4.68u rfmode=0
* device instance $153 r0 *1 65.15,51.275 sg13_hv_nmos
M$153 \$236 \$36 \$246 vss sg13_hv_nmos L=0.45u W=2u AS=0.68p AD=0.38p PS=4.68u
+ PD=2.38u rfmode=0
* device instance $154 r0 *1 65.15,52.105 sg13_hv_nmos
M$154 \$246 \$20 \$247 vss sg13_hv_nmos L=0.45u W=2u AS=0.38p AD=0.68p PS=2.38u
+ PD=4.68u rfmode=0
* device instance $155 r0 *1 87.33,51.275 sg13_hv_nmos
M$155 \$229 \$22 \$226 vss sg13_hv_nmos L=0.45u W=2u AS=0.68p AD=0.38p PS=4.68u
+ PD=2.38u rfmode=0
* device instance $156 r0 *1 87.33,52.105 sg13_hv_nmos
M$156 \$226 \$38 \$253 vss sg13_hv_nmos L=0.45u W=2u AS=0.38p AD=0.68p PS=2.38u
+ PD=4.68u rfmode=0
* device instance $157 r0 *1 37.23,53.035 sg13_hv_nmos
M$157 \$146 \$44 \$250 vss sg13_hv_nmos L=0.45u W=2u AS=0.68p AD=0.38p PS=4.68u
+ PD=2.38u rfmode=0
* device instance $158 r0 *1 37.23,53.865 sg13_hv_nmos
M$158 \$250 \$28 \$350 vss sg13_hv_nmos L=0.45u W=2u AS=0.38p AD=0.68p PS=2.38u
+ PD=4.68u rfmode=0
* device instance $159 r0 *1 48.45,53.035 sg13_hv_nmos
M$159 \$245 \$20 \$251 vss sg13_hv_nmos L=0.45u W=2u AS=0.68p AD=0.38p PS=4.68u
+ PD=2.38u rfmode=0
* device instance $160 r0 *1 48.45,53.865 sg13_hv_nmos
M$160 \$251 \$36 \$259 vss sg13_hv_nmos L=0.45u W=2u AS=0.38p AD=0.68p PS=2.38u
+ PD=4.68u rfmode=0
* device instance $161 r0 *1 70.63,53.035 sg13_hv_nmos
M$161 \$148 \$44 \$252 vss sg13_hv_nmos L=0.45u W=2u AS=0.68p AD=0.38p PS=4.68u
+ PD=2.38u rfmode=0
* device instance $162 r0 *1 70.63,53.865 sg13_hv_nmos
M$162 \$252 \$28 \$352 vss sg13_hv_nmos L=0.45u W=2u AS=0.38p AD=0.68p PS=2.38u
+ PD=4.68u rfmode=0
* device instance $163 r0 *1 81.85,53.035 sg13_hv_nmos
M$163 \$248 \$20 \$253 vss sg13_hv_nmos L=0.45u W=2u AS=0.68p AD=0.38p PS=4.68u
+ PD=2.38u rfmode=0
* device instance $164 r0 *1 81.85,53.865 sg13_hv_nmos
M$164 \$253 \$36 \$261 vss sg13_hv_nmos L=0.45u W=2u AS=0.38p AD=0.68p PS=2.38u
+ PD=4.68u rfmode=0
* device instance $165 r0 *1 31.75,54.795 sg13_hv_nmos
M$165 \$258 \$36 \$267 vss sg13_hv_nmos L=0.45u W=2u AS=0.68p AD=0.38p PS=4.68u
+ PD=2.38u rfmode=0
* device instance $166 r0 *1 31.75,55.625 sg13_hv_nmos
M$166 \$267 \$20 \$268 vss sg13_hv_nmos L=0.45u W=2u AS=0.38p AD=0.68p PS=2.38u
+ PD=4.68u rfmode=0
* device instance $167 r0 *1 53.93,54.795 sg13_hv_nmos
M$167 \$168 \$28 \$270 vss sg13_hv_nmos L=0.45u W=2u AS=0.68p AD=0.38p PS=4.68u
+ PD=2.38u rfmode=0
* device instance $168 r0 *1 53.93,55.625 sg13_hv_nmos
M$168 \$270 \$44 \$371 vss sg13_hv_nmos L=0.45u W=2u AS=0.38p AD=0.68p PS=2.38u
+ PD=4.68u rfmode=0
* device instance $169 r0 *1 65.15,54.795 sg13_hv_nmos
M$169 \$260 \$36 \$271 vss sg13_hv_nmos L=0.45u W=2u AS=0.68p AD=0.38p PS=4.68u
+ PD=2.38u rfmode=0
* device instance $170 r0 *1 65.15,55.625 sg13_hv_nmos
M$170 \$271 \$20 \$272 vss sg13_hv_nmos L=0.45u W=2u AS=0.38p AD=0.68p PS=2.38u
+ PD=4.68u rfmode=0
* device instance $171 r0 *1 87.33,54.795 sg13_hv_nmos
M$171 \$173 \$28 \$274 vss sg13_hv_nmos L=0.45u W=2u AS=0.68p AD=0.38p PS=4.68u
+ PD=2.38u rfmode=0
* device instance $172 r0 *1 87.33,55.625 sg13_hv_nmos
M$172 \$274 \$44 \$376 vss sg13_hv_nmos L=0.45u W=2u AS=0.38p AD=0.68p PS=2.38u
+ PD=4.68u rfmode=0
* device instance $173 r0 *1 37.23,56.555 sg13_hv_nmos
M$173 \$267 \$38 \$276 vss sg13_hv_nmos L=0.45u W=2u AS=0.68p AD=0.38p PS=4.68u
+ PD=2.38u rfmode=0
* device instance $174 r0 *1 37.23,57.385 sg13_hv_nmos
M$174 \$276 \$22 \$292 vss sg13_hv_nmos L=0.45u W=2u AS=0.38p AD=0.68p PS=2.38u
+ PD=4.68u rfmode=0
* device instance $175 r0 *1 48.45,56.555 sg13_hv_nmos
M$175 \$269 \$20 \$277 vss sg13_hv_nmos L=0.45u W=2u AS=0.68p AD=0.38p PS=4.68u
+ PD=2.38u rfmode=0
* device instance $176 r0 *1 48.45,57.385 sg13_hv_nmos
M$176 \$277 \$36 \$285 vss sg13_hv_nmos L=0.45u W=2u AS=0.38p AD=0.68p PS=2.38u
+ PD=4.68u rfmode=0
* device instance $177 r0 *1 70.63,56.555 sg13_hv_nmos
M$177 \$271 \$38 \$278 vss sg13_hv_nmos L=0.45u W=2u AS=0.68p AD=0.38p PS=4.68u
+ PD=2.38u rfmode=0
* device instance $178 r0 *1 70.63,57.385 sg13_hv_nmos
M$178 \$278 \$22 \$296 vss sg13_hv_nmos L=0.45u W=2u AS=0.38p AD=0.68p PS=2.38u
+ PD=4.68u rfmode=0
* device instance $179 r0 *1 81.85,56.555 sg13_hv_nmos
M$179 \$273 \$20 \$279 vss sg13_hv_nmos L=0.45u W=2u AS=0.68p AD=0.38p PS=4.68u
+ PD=2.38u rfmode=0
* device instance $180 r0 *1 81.85,57.385 sg13_hv_nmos
M$180 \$279 \$36 \$287 vss sg13_hv_nmos L=0.45u W=2u AS=0.38p AD=0.68p PS=2.38u
+ PD=4.68u rfmode=0
* device instance $181 r0 *1 31.75,58.315 sg13_hv_nmos
M$181 \$284 \$36 \$292 vss sg13_hv_nmos L=0.45u W=2u AS=0.68p AD=0.38p PS=4.68u
+ PD=2.38u rfmode=0
* device instance $182 r0 *1 31.75,59.145 sg13_hv_nmos
M$182 \$292 \$20 \$293 vss sg13_hv_nmos L=0.45u W=2u AS=0.38p AD=0.68p PS=2.38u
+ PD=4.68u rfmode=0
* device instance $183 r0 *1 53.93,58.315 sg13_hv_nmos
M$183 \$277 \$22 \$295 vss sg13_hv_nmos L=0.45u W=2u AS=0.68p AD=0.38p PS=4.68u
+ PD=2.38u rfmode=0
* device instance $184 r0 *1 53.93,59.145 sg13_hv_nmos
M$184 \$295 \$38 \$303 vss sg13_hv_nmos L=0.45u W=2u AS=0.38p AD=0.68p PS=2.38u
+ PD=4.68u rfmode=0
* device instance $185 r0 *1 65.15,58.315 sg13_hv_nmos
M$185 \$286 \$36 \$296 vss sg13_hv_nmos L=0.45u W=2u AS=0.68p AD=0.38p PS=4.68u
+ PD=2.38u rfmode=0
* device instance $186 r0 *1 65.15,59.145 sg13_hv_nmos
M$186 \$296 \$20 \$297 vss sg13_hv_nmos L=0.45u W=2u AS=0.38p AD=0.68p PS=2.38u
+ PD=4.68u rfmode=0
* device instance $187 r0 *1 87.33,58.315 sg13_hv_nmos
M$187 \$279 \$22 \$299 vss sg13_hv_nmos L=0.45u W=2u AS=0.68p AD=0.38p PS=4.68u
+ PD=2.38u rfmode=0
* device instance $188 r0 *1 87.33,59.145 sg13_hv_nmos
M$188 \$299 \$38 \$305 vss sg13_hv_nmos L=0.45u W=2u AS=0.38p AD=0.68p PS=2.38u
+ PD=4.68u rfmode=0
* device instance $189 r0 *1 37.23,60.075 sg13_hv_nmos
M$189 \$276 \$40 \$302 vss sg13_hv_nmos L=0.45u W=2u AS=0.68p AD=0.38p PS=4.68u
+ PD=2.38u rfmode=0
* device instance $190 r0 *1 37.23,60.905 sg13_hv_nmos
M$190 \$302 \$24 \$311 vss sg13_hv_nmos L=0.45u W=2u AS=0.38p AD=0.68p PS=2.38u
+ PD=4.68u rfmode=0
* device instance $191 r0 *1 48.45,60.075 sg13_hv_nmos
M$191 \$294 \$20 \$303 vss sg13_hv_nmos L=0.45u W=2u AS=0.68p AD=0.38p PS=4.68u
+ PD=2.38u rfmode=0
* device instance $192 r0 *1 48.45,60.905 sg13_hv_nmos
M$192 \$303 \$36 \$312 vss sg13_hv_nmos L=0.45u W=2u AS=0.38p AD=0.68p PS=2.38u
+ PD=4.68u rfmode=0
* device instance $193 r0 *1 70.63,60.075 sg13_hv_nmos
M$193 \$278 \$40 \$304 vss sg13_hv_nmos L=0.45u W=2u AS=0.68p AD=0.38p PS=4.68u
+ PD=2.38u rfmode=0
* device instance $194 r0 *1 70.63,60.905 sg13_hv_nmos
M$194 \$304 \$24 \$314 vss sg13_hv_nmos L=0.45u W=2u AS=0.38p AD=0.68p PS=2.38u
+ PD=4.68u rfmode=0
* device instance $195 r0 *1 81.85,60.075 sg13_hv_nmos
M$195 \$298 \$20 \$305 vss sg13_hv_nmos L=0.45u W=2u AS=0.68p AD=0.38p PS=4.68u
+ PD=2.38u rfmode=0
* device instance $196 r0 *1 81.85,60.905 sg13_hv_nmos
M$196 \$305 \$36 \$315 vss sg13_hv_nmos L=0.45u W=2u AS=0.38p AD=0.68p PS=2.38u
+ PD=4.68u rfmode=0
* device instance $197 r0 *1 31.75,61.835 sg13_hv_nmos
M$197 \$310 \$36 \$320 vss sg13_hv_nmos L=0.45u W=2u AS=0.68p AD=0.38p PS=4.68u
+ PD=2.38u rfmode=0
* device instance $198 r0 *1 31.75,62.665 sg13_hv_nmos
M$198 \$320 \$20 \$321 vss sg13_hv_nmos L=0.45u W=2u AS=0.38p AD=0.68p PS=2.38u
+ PD=4.68u rfmode=0
* device instance $199 r0 *1 53.93,61.835 sg13_hv_nmos
M$199 \$295 \$24 \$323 vss sg13_hv_nmos L=0.45u W=2u AS=0.68p AD=0.38p PS=4.68u
+ PD=2.38u rfmode=0
* device instance $200 r0 *1 53.93,62.665 sg13_hv_nmos
M$200 \$323 \$40 \$324 vss sg13_hv_nmos L=0.45u W=2u AS=0.38p AD=0.68p PS=2.38u
+ PD=4.68u rfmode=0
* device instance $201 r0 *1 65.15,61.835 sg13_hv_nmos
M$201 \$313 \$36 \$325 vss sg13_hv_nmos L=0.45u W=2u AS=0.68p AD=0.38p PS=4.68u
+ PD=2.38u rfmode=0
* device instance $202 r0 *1 65.15,62.665 sg13_hv_nmos
M$202 \$325 \$20 \$326 vss sg13_hv_nmos L=0.45u W=2u AS=0.38p AD=0.68p PS=2.38u
+ PD=4.68u rfmode=0
* device instance $203 r0 *1 87.33,61.835 sg13_hv_nmos
M$203 \$299 \$24 \$329 vss sg13_hv_nmos L=0.45u W=2u AS=0.68p AD=0.38p PS=4.68u
+ PD=2.38u rfmode=0
* device instance $204 r0 *1 87.33,62.665 sg13_hv_nmos
M$204 \$329 \$40 \$328 vss sg13_hv_nmos L=0.45u W=2u AS=0.38p AD=0.68p PS=2.38u
+ PD=4.68u rfmode=0
* device instance $205 r0 *1 37.23,63.595 sg13_hv_nmos
M$205 \$320 \$38 \$311 vss sg13_hv_nmos L=0.45u W=2u AS=0.68p AD=0.38p PS=4.68u
+ PD=2.38u rfmode=0
* device instance $206 r0 *1 37.23,64.425 sg13_hv_nmos
M$206 \$311 \$22 \$345 vss sg13_hv_nmos L=0.45u W=2u AS=0.38p AD=0.68p PS=2.38u
+ PD=4.68u rfmode=0
* device instance $207 r0 *1 48.45,63.595 sg13_hv_nmos
M$207 \$322 \$20 \$330 vss sg13_hv_nmos L=0.45u W=2u AS=0.68p AD=0.38p PS=4.68u
+ PD=2.38u rfmode=0
* device instance $208 r0 *1 48.45,64.425 sg13_hv_nmos
M$208 \$330 \$36 \$337 vss sg13_hv_nmos L=0.45u W=2u AS=0.38p AD=0.68p PS=2.38u
+ PD=4.68u rfmode=0
* device instance $209 r0 *1 70.63,63.595 sg13_hv_nmos
M$209 \$325 \$38 \$314 vss sg13_hv_nmos L=0.45u W=2u AS=0.68p AD=0.38p PS=4.68u
+ PD=2.38u rfmode=0
* device instance $210 r0 *1 70.63,64.425 sg13_hv_nmos
M$210 \$314 \$22 \$347 vss sg13_hv_nmos L=0.45u W=2u AS=0.38p AD=0.68p PS=2.38u
+ PD=4.68u rfmode=0
* device instance $211 r0 *1 81.85,63.595 sg13_hv_nmos
M$211 \$327 \$20 \$331 vss sg13_hv_nmos L=0.45u W=2u AS=0.68p AD=0.38p PS=4.68u
+ PD=2.38u rfmode=0
* device instance $212 r0 *1 81.85,64.425 sg13_hv_nmos
M$212 \$331 \$36 \$339 vss sg13_hv_nmos L=0.45u W=2u AS=0.38p AD=0.68p PS=2.38u
+ PD=4.68u rfmode=0
* device instance $213 r0 *1 31.75,65.355 sg13_hv_nmos
M$213 \$336 \$36 \$345 vss sg13_hv_nmos L=0.45u W=2u AS=0.68p AD=0.38p PS=4.68u
+ PD=2.38u rfmode=0
* device instance $214 r0 *1 31.75,66.185 sg13_hv_nmos
M$214 \$345 \$20 \$344 vss sg13_hv_nmos L=0.45u W=2u AS=0.38p AD=0.68p PS=2.38u
+ PD=4.68u rfmode=0
* device instance $215 r0 *1 53.93,65.355 sg13_hv_nmos
M$215 \$330 \$22 \$324 vss sg13_hv_nmos L=0.45u W=2u AS=0.68p AD=0.38p PS=4.68u
+ PD=2.38u rfmode=0
* device instance $216 r0 *1 53.93,66.185 sg13_hv_nmos
M$216 \$324 \$38 \$351 vss sg13_hv_nmos L=0.45u W=2u AS=0.38p AD=0.68p PS=2.38u
+ PD=4.68u rfmode=0
* device instance $217 r0 *1 65.15,65.355 sg13_hv_nmos
M$217 \$338 \$36 \$347 vss sg13_hv_nmos L=0.45u W=2u AS=0.68p AD=0.38p PS=4.68u
+ PD=2.38u rfmode=0
* device instance $218 r0 *1 65.15,66.185 sg13_hv_nmos
M$218 \$347 \$20 \$348 vss sg13_hv_nmos L=0.45u W=2u AS=0.38p AD=0.68p PS=2.38u
+ PD=4.68u rfmode=0
* device instance $219 r0 *1 87.33,65.355 sg13_hv_nmos
M$219 \$331 \$22 \$328 vss sg13_hv_nmos L=0.45u W=2u AS=0.68p AD=0.38p PS=4.68u
+ PD=2.38u rfmode=0
* device instance $220 r0 *1 87.33,66.185 sg13_hv_nmos
M$220 \$328 \$38 \$353 vss sg13_hv_nmos L=0.45u W=2u AS=0.38p AD=0.68p PS=2.38u
+ PD=4.68u rfmode=0
* device instance $221 r0 *1 37.23,67.115 sg13_hv_nmos
M$221 \$302 \$42 \$350 vss sg13_hv_nmos L=0.45u W=2u AS=0.68p AD=0.38p PS=4.68u
+ PD=2.38u rfmode=0
* device instance $222 r0 *1 37.23,67.945 sg13_hv_nmos
M$222 \$350 \$26 \$359 vss sg13_hv_nmos L=0.45u W=2u AS=0.38p AD=0.68p PS=2.38u
+ PD=4.68u rfmode=0
* device instance $223 r0 *1 48.45,67.115 sg13_hv_nmos
M$223 \$346 \$20 \$351 vss sg13_hv_nmos L=0.45u W=2u AS=0.68p AD=0.38p PS=4.68u
+ PD=2.38u rfmode=0
* device instance $224 r0 *1 48.45,67.945 sg13_hv_nmos
M$224 \$351 \$36 \$360 vss sg13_hv_nmos L=0.45u W=2u AS=0.38p AD=0.68p PS=2.38u
+ PD=4.68u rfmode=0
* device instance $225 r0 *1 70.63,67.115 sg13_hv_nmos
M$225 \$304 \$42 \$352 vss sg13_hv_nmos L=0.45u W=2u AS=0.68p AD=0.38p PS=4.68u
+ PD=2.38u rfmode=0
* device instance $226 r0 *1 70.63,67.945 sg13_hv_nmos
M$226 \$352 \$26 \$362 vss sg13_hv_nmos L=0.45u W=2u AS=0.38p AD=0.68p PS=2.38u
+ PD=4.68u rfmode=0
* device instance $227 r0 *1 81.85,67.115 sg13_hv_nmos
M$227 \$349 \$20 \$353 vss sg13_hv_nmos L=0.45u W=2u AS=0.68p AD=0.38p PS=4.68u
+ PD=2.38u rfmode=0
* device instance $228 r0 *1 81.85,67.945 sg13_hv_nmos
M$228 \$353 \$36 \$363 vss sg13_hv_nmos L=0.45u W=2u AS=0.38p AD=0.68p PS=2.38u
+ PD=4.68u rfmode=0
* device instance $229 r0 *1 31.75,68.875 sg13_hv_nmos
M$229 \$358 \$36 \$368 vss sg13_hv_nmos L=0.45u W=2u AS=0.68p AD=0.38p PS=4.68u
+ PD=2.38u rfmode=0
* device instance $230 r0 *1 31.75,69.705 sg13_hv_nmos
M$230 \$368 \$20 \$369 vss sg13_hv_nmos L=0.45u W=2u AS=0.38p AD=0.68p PS=2.38u
+ PD=4.68u rfmode=0
* device instance $231 r0 *1 53.93,68.875 sg13_hv_nmos
M$231 \$323 \$26 \$371 vss sg13_hv_nmos L=0.45u W=2u AS=0.68p AD=0.38p PS=4.68u
+ PD=2.38u rfmode=0
* device instance $232 r0 *1 53.93,69.705 sg13_hv_nmos
M$232 \$371 \$42 \$372 vss sg13_hv_nmos L=0.45u W=2u AS=0.38p AD=0.68p PS=2.38u
+ PD=4.68u rfmode=0
* device instance $233 r0 *1 65.15,68.875 sg13_hv_nmos
M$233 \$361 \$36 \$373 vss sg13_hv_nmos L=0.45u W=2u AS=0.68p AD=0.38p PS=4.68u
+ PD=2.38u rfmode=0
* device instance $234 r0 *1 65.15,69.705 sg13_hv_nmos
M$234 \$373 \$20 \$374 vss sg13_hv_nmos L=0.45u W=2u AS=0.38p AD=0.68p PS=2.38u
+ PD=4.68u rfmode=0
* device instance $235 r0 *1 87.33,68.875 sg13_hv_nmos
M$235 \$329 \$26 \$376 vss sg13_hv_nmos L=0.45u W=2u AS=0.68p AD=0.38p PS=4.68u
+ PD=2.38u rfmode=0
* device instance $236 r0 *1 87.33,69.705 sg13_hv_nmos
M$236 \$376 \$42 \$377 vss sg13_hv_nmos L=0.45u W=2u AS=0.38p AD=0.68p PS=2.38u
+ PD=4.68u rfmode=0
* device instance $237 r0 *1 37.23,70.635 sg13_hv_nmos
M$237 \$368 \$38 \$378 vss sg13_hv_nmos L=0.45u W=2u AS=0.68p AD=0.38p PS=4.68u
+ PD=2.38u rfmode=0
* device instance $238 r0 *1 37.23,71.465 sg13_hv_nmos
M$238 \$378 \$22 \$394 vss sg13_hv_nmos L=0.45u W=2u AS=0.38p AD=0.68p PS=2.38u
+ PD=4.68u rfmode=0
* device instance $239 r0 *1 48.45,70.635 sg13_hv_nmos
M$239 \$370 \$20 \$379 vss sg13_hv_nmos L=0.45u W=2u AS=0.68p AD=0.38p PS=4.68u
+ PD=2.38u rfmode=0
* device instance $240 r0 *1 48.45,71.465 sg13_hv_nmos
M$240 \$379 \$36 \$387 vss sg13_hv_nmos L=0.45u W=2u AS=0.38p AD=0.68p PS=2.38u
+ PD=4.68u rfmode=0
* device instance $241 r0 *1 70.63,70.635 sg13_hv_nmos
M$241 \$373 \$38 \$380 vss sg13_hv_nmos L=0.45u W=2u AS=0.68p AD=0.38p PS=4.68u
+ PD=2.38u rfmode=0
* device instance $242 r0 *1 70.63,71.465 sg13_hv_nmos
M$242 \$380 \$22 \$398 vss sg13_hv_nmos L=0.45u W=2u AS=0.38p AD=0.68p PS=2.38u
+ PD=4.68u rfmode=0
* device instance $243 r0 *1 81.85,70.635 sg13_hv_nmos
M$243 \$375 \$20 \$381 vss sg13_hv_nmos L=0.45u W=2u AS=0.68p AD=0.38p PS=4.68u
+ PD=2.38u rfmode=0
* device instance $244 r0 *1 81.85,71.465 sg13_hv_nmos
M$244 \$381 \$36 \$389 vss sg13_hv_nmos L=0.45u W=2u AS=0.38p AD=0.68p PS=2.38u
+ PD=4.68u rfmode=0
* device instance $245 r0 *1 31.75,72.395 sg13_hv_nmos
M$245 \$386 \$36 \$394 vss sg13_hv_nmos L=0.45u W=2u AS=0.68p AD=0.38p PS=4.68u
+ PD=2.38u rfmode=0
* device instance $246 r0 *1 31.75,73.225 sg13_hv_nmos
M$246 \$394 \$20 \$395 vss sg13_hv_nmos L=0.45u W=2u AS=0.38p AD=0.68p PS=2.38u
+ PD=4.68u rfmode=0
* device instance $247 r0 *1 53.93,72.395 sg13_hv_nmos
M$247 \$379 \$22 \$397 vss sg13_hv_nmos L=0.45u W=2u AS=0.68p AD=0.38p PS=4.68u
+ PD=2.38u rfmode=0
* device instance $248 r0 *1 53.93,73.225 sg13_hv_nmos
M$248 \$397 \$38 \$402 vss sg13_hv_nmos L=0.45u W=2u AS=0.38p AD=0.68p PS=2.38u
+ PD=4.68u rfmode=0
* device instance $249 r0 *1 65.15,72.395 sg13_hv_nmos
M$249 \$388 \$36 \$398 vss sg13_hv_nmos L=0.45u W=2u AS=0.68p AD=0.38p PS=4.68u
+ PD=2.38u rfmode=0
* device instance $250 r0 *1 65.15,73.225 sg13_hv_nmos
M$250 \$398 \$20 \$399 vss sg13_hv_nmos L=0.45u W=2u AS=0.38p AD=0.68p PS=2.38u
+ PD=4.68u rfmode=0
* device instance $251 r0 *1 87.33,72.395 sg13_hv_nmos
M$251 \$381 \$22 \$401 vss sg13_hv_nmos L=0.45u W=2u AS=0.68p AD=0.38p PS=4.68u
+ PD=2.38u rfmode=0
* device instance $252 r0 *1 87.33,73.225 sg13_hv_nmos
M$252 \$401 \$38 \$403 vss sg13_hv_nmos L=0.45u W=2u AS=0.38p AD=0.68p PS=2.38u
+ PD=4.68u rfmode=0
* device instance $253 r0 *1 37.23,74.155 sg13_hv_nmos
M$253 \$378 \$40 \$359 vss sg13_hv_nmos L=0.45u W=2u AS=0.68p AD=0.38p PS=4.68u
+ PD=2.38u rfmode=0
* device instance $254 r0 *1 37.23,74.985 sg13_hv_nmos
M$254 \$359 \$24 \$409 vss sg13_hv_nmos L=0.45u W=2u AS=0.38p AD=0.68p PS=2.38u
+ PD=4.68u rfmode=0
* device instance $255 r0 *1 48.45,74.155 sg13_hv_nmos
M$255 \$396 \$20 \$402 vss sg13_hv_nmos L=0.45u W=2u AS=0.68p AD=0.38p PS=4.68u
+ PD=2.38u rfmode=0
* device instance $256 r0 *1 48.45,74.985 sg13_hv_nmos
M$256 \$402 \$36 \$410 vss sg13_hv_nmos L=0.45u W=2u AS=0.38p AD=0.68p PS=2.38u
+ PD=4.68u rfmode=0
* device instance $257 r0 *1 70.63,74.155 sg13_hv_nmos
M$257 \$380 \$40 \$362 vss sg13_hv_nmos L=0.45u W=2u AS=0.68p AD=0.38p PS=4.68u
+ PD=2.38u rfmode=0
* device instance $258 r0 *1 70.63,74.985 sg13_hv_nmos
M$258 \$362 \$24 \$412 vss sg13_hv_nmos L=0.45u W=2u AS=0.38p AD=0.68p PS=2.38u
+ PD=4.68u rfmode=0
* device instance $259 r0 *1 81.85,74.155 sg13_hv_nmos
M$259 \$400 \$20 \$403 vss sg13_hv_nmos L=0.45u W=2u AS=0.68p AD=0.38p PS=4.68u
+ PD=2.38u rfmode=0
* device instance $260 r0 *1 81.85,74.985 sg13_hv_nmos
M$260 \$403 \$36 \$413 vss sg13_hv_nmos L=0.45u W=2u AS=0.38p AD=0.68p PS=2.38u
+ PD=4.68u rfmode=0
* device instance $261 r0 *1 31.75,75.915 sg13_hv_nmos
M$261 \$408 \$36 \$419 vss sg13_hv_nmos L=0.45u W=2u AS=0.68p AD=0.38p PS=4.68u
+ PD=2.38u rfmode=0
* device instance $262 r0 *1 31.75,76.745 sg13_hv_nmos
M$262 \$419 \$20 \$418 vss sg13_hv_nmos L=0.45u W=2u AS=0.38p AD=0.68p PS=2.38u
+ PD=4.68u rfmode=0
* device instance $263 r0 *1 53.93,75.915 sg13_hv_nmos
M$263 \$397 \$24 \$372 vss sg13_hv_nmos L=0.45u W=2u AS=0.68p AD=0.38p PS=4.68u
+ PD=2.38u rfmode=0
* device instance $264 r0 *1 53.93,76.745 sg13_hv_nmos
M$264 \$372 \$40 \$421 vss sg13_hv_nmos L=0.45u W=2u AS=0.38p AD=0.68p PS=2.38u
+ PD=4.68u rfmode=0
* device instance $265 r0 *1 65.15,75.915 sg13_hv_nmos
M$265 \$411 \$36 \$422 vss sg13_hv_nmos L=0.45u W=2u AS=0.68p AD=0.38p PS=4.68u
+ PD=2.38u rfmode=0
* device instance $266 r0 *1 65.15,76.745 sg13_hv_nmos
M$266 \$422 \$20 \$423 vss sg13_hv_nmos L=0.45u W=2u AS=0.38p AD=0.68p PS=2.38u
+ PD=4.68u rfmode=0
* device instance $267 r0 *1 87.33,75.915 sg13_hv_nmos
M$267 \$401 \$24 \$377 vss sg13_hv_nmos L=0.45u W=2u AS=0.68p AD=0.38p PS=4.68u
+ PD=2.38u rfmode=0
* device instance $268 r0 *1 87.33,76.745 sg13_hv_nmos
M$268 \$377 \$40 \$425 vss sg13_hv_nmos L=0.45u W=2u AS=0.38p AD=0.68p PS=2.38u
+ PD=4.68u rfmode=0
* device instance $269 r0 *1 37.23,77.675 sg13_hv_nmos
M$269 \$419 \$38 \$409 vss sg13_hv_nmos L=0.45u W=2u AS=0.68p AD=0.38p PS=4.68u
+ PD=2.38u rfmode=0
* device instance $270 r0 *1 37.23,78.505 sg13_hv_nmos
M$270 \$409 \$22 \$439 vss sg13_hv_nmos L=0.45u W=2u AS=0.38p AD=0.68p PS=2.38u
+ PD=4.68u rfmode=0
* device instance $271 r0 *1 48.45,77.675 sg13_hv_nmos
M$271 \$420 \$20 \$426 vss sg13_hv_nmos L=0.45u W=2u AS=0.68p AD=0.38p PS=4.68u
+ PD=2.38u rfmode=0
* device instance $272 r0 *1 48.45,78.505 sg13_hv_nmos
M$272 \$426 \$36 \$433 vss sg13_hv_nmos L=0.45u W=2u AS=0.38p AD=0.68p PS=2.38u
+ PD=4.68u rfmode=0
* device instance $273 r0 *1 70.63,77.675 sg13_hv_nmos
M$273 \$422 \$38 \$412 vss sg13_hv_nmos L=0.45u W=2u AS=0.68p AD=0.38p PS=4.68u
+ PD=2.38u rfmode=0
* device instance $274 r0 *1 70.63,78.505 sg13_hv_nmos
M$274 \$412 \$22 \$442 vss sg13_hv_nmos L=0.45u W=2u AS=0.38p AD=0.68p PS=2.38u
+ PD=4.68u rfmode=0
* device instance $275 r0 *1 81.85,77.675 sg13_hv_nmos
M$275 \$424 \$20 \$427 vss sg13_hv_nmos L=0.45u W=2u AS=0.68p AD=0.38p PS=4.68u
+ PD=2.38u rfmode=0
* device instance $276 r0 *1 81.85,78.505 sg13_hv_nmos
M$276 \$427 \$36 \$435 vss sg13_hv_nmos L=0.45u W=2u AS=0.38p AD=0.68p PS=2.38u
+ PD=4.68u rfmode=0
* device instance $277 r0 *1 31.75,79.435 sg13_hv_nmos
M$277 \$432 \$36 \$439 vss sg13_hv_nmos L=0.45u W=2u AS=0.68p AD=0.38p PS=4.68u
+ PD=2.38u rfmode=0
* device instance $278 r0 *1 31.75,80.265 sg13_hv_nmos
M$278 \$439 \$20 \$440 vss sg13_hv_nmos L=0.45u W=2u AS=0.38p AD=0.68p PS=2.38u
+ PD=4.68u rfmode=0
* device instance $279 r0 *1 53.93,79.435 sg13_hv_nmos
M$279 \$426 \$22 \$421 vss sg13_hv_nmos L=0.45u W=2u AS=0.68p AD=0.38p PS=4.68u
+ PD=2.38u rfmode=0
* device instance $280 r0 *1 53.93,80.265 sg13_hv_nmos
M$280 \$421 \$38 \$447 vss sg13_hv_nmos L=0.45u W=2u AS=0.38p AD=0.68p PS=2.38u
+ PD=4.68u rfmode=0
* device instance $281 r0 *1 65.15,79.435 sg13_hv_nmos
M$281 \$434 \$36 \$442 vss sg13_hv_nmos L=0.45u W=2u AS=0.68p AD=0.38p PS=4.68u
+ PD=2.38u rfmode=0
* device instance $282 r0 *1 65.15,80.265 sg13_hv_nmos
M$282 \$442 \$20 \$443 vss sg13_hv_nmos L=0.45u W=2u AS=0.38p AD=0.68p PS=2.38u
+ PD=4.68u rfmode=0
* device instance $283 r0 *1 87.33,79.435 sg13_hv_nmos
M$283 \$427 \$22 \$425 vss sg13_hv_nmos L=0.45u W=2u AS=0.68p AD=0.38p PS=4.68u
+ PD=2.38u rfmode=0
* device instance $284 r0 *1 87.33,80.265 sg13_hv_nmos
M$284 \$425 \$38 \$449 vss sg13_hv_nmos L=0.45u W=2u AS=0.38p AD=0.68p PS=2.38u
+ PD=4.68u rfmode=0
* device instance $285 r0 *1 37.23,81.195 sg13_hv_nmos
M$285 \$250 \$46 \$446 vss sg13_hv_nmos L=0.45u W=2u AS=0.68p AD=0.38p PS=4.68u
+ PD=2.38u rfmode=0
* device instance $286 r0 *1 37.23,82.025 sg13_hv_nmos
M$286 \$446 \$30 \$646 vss sg13_hv_nmos L=0.45u W=2u AS=0.38p AD=0.68p PS=2.38u
+ PD=4.68u rfmode=0
* device instance $287 r0 *1 48.45,81.195 sg13_hv_nmos
M$287 \$441 \$20 \$447 vss sg13_hv_nmos L=0.45u W=2u AS=0.68p AD=0.38p PS=4.68u
+ PD=2.38u rfmode=0
* device instance $288 r0 *1 48.45,82.025 sg13_hv_nmos
M$288 \$447 \$36 \$455 vss sg13_hv_nmos L=0.45u W=2u AS=0.38p AD=0.68p PS=2.38u
+ PD=4.68u rfmode=0
* device instance $289 r0 *1 70.63,81.195 sg13_hv_nmos
M$289 \$252 \$46 \$448 vss sg13_hv_nmos L=0.45u W=2u AS=0.68p AD=0.38p PS=4.68u
+ PD=2.38u rfmode=0
* device instance $290 r0 *1 70.63,82.025 sg13_hv_nmos
M$290 \$448 \$30 \$650 vss sg13_hv_nmos L=0.45u W=2u AS=0.38p AD=0.68p PS=2.38u
+ PD=4.68u rfmode=0
* device instance $291 r0 *1 81.85,81.195 sg13_hv_nmos
M$291 \$444 \$20 \$449 vss sg13_hv_nmos L=0.45u W=2u AS=0.68p AD=0.38p PS=4.68u
+ PD=2.38u rfmode=0
* device instance $292 r0 *1 81.85,82.025 sg13_hv_nmos
M$292 \$449 \$36 \$457 vss sg13_hv_nmos L=0.45u W=2u AS=0.38p AD=0.68p PS=2.38u
+ PD=4.68u rfmode=0
* device instance $293 r0 *1 31.75,82.955 sg13_hv_nmos
M$293 \$454 \$36 \$462 vss sg13_hv_nmos L=0.45u W=2u AS=0.68p AD=0.38p PS=4.68u
+ PD=2.38u rfmode=0
* device instance $294 r0 *1 31.75,83.785 sg13_hv_nmos
M$294 \$462 \$20 \$463 vss sg13_hv_nmos L=0.45u W=2u AS=0.38p AD=0.68p PS=2.38u
+ PD=4.68u rfmode=0
* device instance $295 r0 *1 53.93,82.955 sg13_hv_nmos
M$295 \$270 \$30 \$465 vss sg13_hv_nmos L=0.45u W=2u AS=0.68p AD=0.38p PS=4.68u
+ PD=2.38u rfmode=0
* device instance $296 r0 *1 53.93,83.785 sg13_hv_nmos
M$296 \$465 \$46 \$654 vss sg13_hv_nmos L=0.45u W=2u AS=0.38p AD=0.68p PS=2.38u
+ PD=4.68u rfmode=0
* device instance $297 r0 *1 65.15,82.955 sg13_hv_nmos
M$297 \$456 \$36 \$466 vss sg13_hv_nmos L=0.45u W=2u AS=0.68p AD=0.38p PS=4.68u
+ PD=2.38u rfmode=0
* device instance $298 r0 *1 65.15,83.785 sg13_hv_nmos
M$298 \$466 \$20 \$467 vss sg13_hv_nmos L=0.45u W=2u AS=0.38p AD=0.68p PS=2.38u
+ PD=4.68u rfmode=0
* device instance $299 r0 *1 87.33,82.955 sg13_hv_nmos
M$299 \$274 \$30 \$469 vss sg13_hv_nmos L=0.45u W=2u AS=0.68p AD=0.38p PS=4.68u
+ PD=2.38u rfmode=0
* device instance $300 r0 *1 87.33,83.785 sg13_hv_nmos
M$300 \$469 \$46 \$656 vss sg13_hv_nmos L=0.45u W=2u AS=0.38p AD=0.68p PS=2.38u
+ PD=4.68u rfmode=0
* device instance $301 r0 *1 37.23,84.715 sg13_hv_nmos
M$301 \$462 \$38 \$470 vss sg13_hv_nmos L=0.45u W=2u AS=0.68p AD=0.38p PS=4.68u
+ PD=2.38u rfmode=0
* device instance $302 r0 *1 37.23,85.545 sg13_hv_nmos
M$302 \$470 \$22 \$486 vss sg13_hv_nmos L=0.45u W=2u AS=0.38p AD=0.68p PS=2.38u
+ PD=4.68u rfmode=0
* device instance $303 r0 *1 48.45,84.715 sg13_hv_nmos
M$303 \$464 \$20 \$471 vss sg13_hv_nmos L=0.45u W=2u AS=0.68p AD=0.38p PS=4.68u
+ PD=2.38u rfmode=0
* device instance $304 r0 *1 48.45,85.545 sg13_hv_nmos
M$304 \$471 \$36 \$479 vss sg13_hv_nmos L=0.45u W=2u AS=0.38p AD=0.68p PS=2.38u
+ PD=4.68u rfmode=0
* device instance $305 r0 *1 70.63,84.715 sg13_hv_nmos
M$305 \$466 \$38 \$472 vss sg13_hv_nmos L=0.45u W=2u AS=0.68p AD=0.38p PS=4.68u
+ PD=2.38u rfmode=0
* device instance $306 r0 *1 70.63,85.545 sg13_hv_nmos
M$306 \$472 \$22 \$490 vss sg13_hv_nmos L=0.45u W=2u AS=0.38p AD=0.68p PS=2.38u
+ PD=4.68u rfmode=0
* device instance $307 r0 *1 81.85,84.715 sg13_hv_nmos
M$307 \$468 \$20 \$473 vss sg13_hv_nmos L=0.45u W=2u AS=0.68p AD=0.38p PS=4.68u
+ PD=2.38u rfmode=0
* device instance $308 r0 *1 81.85,85.545 sg13_hv_nmos
M$308 \$473 \$36 \$481 vss sg13_hv_nmos L=0.45u W=2u AS=0.38p AD=0.68p PS=2.38u
+ PD=4.68u rfmode=0
* device instance $309 r0 *1 31.75,86.475 sg13_hv_nmos
M$309 \$478 \$36 \$486 vss sg13_hv_nmos L=0.45u W=2u AS=0.68p AD=0.38p PS=4.68u
+ PD=2.38u rfmode=0
* device instance $310 r0 *1 31.75,87.305 sg13_hv_nmos
M$310 \$486 \$20 \$487 vss sg13_hv_nmos L=0.45u W=2u AS=0.38p AD=0.68p PS=2.38u
+ PD=4.68u rfmode=0
* device instance $311 r0 *1 53.93,86.475 sg13_hv_nmos
M$311 \$471 \$22 \$489 vss sg13_hv_nmos L=0.45u W=2u AS=0.68p AD=0.38p PS=4.68u
+ PD=2.38u rfmode=0
* device instance $312 r0 *1 53.93,87.305 sg13_hv_nmos
M$312 \$489 \$38 \$496 vss sg13_hv_nmos L=0.45u W=2u AS=0.38p AD=0.68p PS=2.38u
+ PD=4.68u rfmode=0
* device instance $313 r0 *1 65.15,86.475 sg13_hv_nmos
M$313 \$480 \$36 \$490 vss sg13_hv_nmos L=0.45u W=2u AS=0.68p AD=0.38p PS=4.68u
+ PD=2.38u rfmode=0
* device instance $314 r0 *1 65.15,87.305 sg13_hv_nmos
M$314 \$490 \$20 \$491 vss sg13_hv_nmos L=0.45u W=2u AS=0.38p AD=0.68p PS=2.38u
+ PD=4.68u rfmode=0
* device instance $315 r0 *1 87.33,86.475 sg13_hv_nmos
M$315 \$473 \$22 \$493 vss sg13_hv_nmos L=0.45u W=2u AS=0.68p AD=0.38p PS=4.68u
+ PD=2.38u rfmode=0
* device instance $316 r0 *1 87.33,87.305 sg13_hv_nmos
M$316 \$493 \$38 \$498 vss sg13_hv_nmos L=0.45u W=2u AS=0.38p AD=0.68p PS=2.38u
+ PD=4.68u rfmode=0
* device instance $317 r0 *1 103.41,87.065 sg13_hv_nmos
M$317 \$469 \$32 \$494 vss sg13_hv_nmos L=0.45u W=2u AS=0.68p AD=0.38p PS=4.68u
+ PD=2.38u rfmode=0
* device instance $318 r0 *1 103.41,87.895 sg13_hv_nmos
M$318 \$494 \$48 \$448 vss sg13_hv_nmos L=0.45u W=2u AS=0.38p AD=0.68p PS=2.38u
+ PD=4.68u rfmode=0
* device instance $319 r0 *1 70.63,88.235 sg13_hv_nmos
M$319 \$472 \$40 \$497 vss sg13_hv_nmos L=0.45u W=2u AS=0.68p AD=0.38p PS=4.68u
+ PD=2.38u rfmode=0
* device instance $320 r0 *1 70.63,89.065 sg13_hv_nmos
M$320 \$497 \$24 \$507 vss sg13_hv_nmos L=0.45u W=2u AS=0.38p AD=0.68p PS=2.38u
+ PD=4.68u rfmode=0
* device instance $321 r0 *1 81.85,88.235 sg13_hv_nmos
M$321 \$492 \$20 \$498 vss sg13_hv_nmos L=0.45u W=2u AS=0.68p AD=0.38p PS=4.68u
+ PD=2.38u rfmode=0
* device instance $322 r0 *1 81.85,89.065 sg13_hv_nmos
M$322 \$498 \$36 \$508 vss sg13_hv_nmos L=0.45u W=2u AS=0.38p AD=0.68p PS=2.38u
+ PD=4.68u rfmode=0
* device instance $323 r0 *1 37.23,88.235 sg13_hv_nmos
M$323 \$470 \$40 \$495 vss sg13_hv_nmos L=0.45u W=2u AS=0.68p AD=0.38p PS=4.68u
+ PD=2.38u rfmode=0
* device instance $324 r0 *1 37.23,89.065 sg13_hv_nmos
M$324 \$495 \$24 \$504 vss sg13_hv_nmos L=0.45u W=2u AS=0.38p AD=0.68p PS=2.38u
+ PD=4.68u rfmode=0
* device instance $325 r0 *1 48.45,88.235 sg13_hv_nmos
M$325 \$488 \$20 \$496 vss sg13_hv_nmos L=0.45u W=2u AS=0.68p AD=0.38p PS=4.68u
+ PD=2.38u rfmode=0
* device instance $326 r0 *1 48.45,89.065 sg13_hv_nmos
M$326 \$496 \$36 \$505 vss sg13_hv_nmos L=0.45u W=2u AS=0.38p AD=0.68p PS=2.38u
+ PD=4.68u rfmode=0
* device instance $327 r0 *1 31.75,89.995 sg13_hv_nmos
M$327 \$503 \$36 \$511 vss sg13_hv_nmos L=0.45u W=2u AS=0.68p AD=0.38p PS=4.68u
+ PD=2.38u rfmode=0
* device instance $328 r0 *1 31.75,90.825 sg13_hv_nmos
M$328 \$511 \$20 \$512 vss sg13_hv_nmos L=0.45u W=2u AS=0.38p AD=0.68p PS=2.38u
+ PD=4.68u rfmode=0
* device instance $329 r0 *1 53.93,89.995 sg13_hv_nmos
M$329 \$489 \$24 \$513 vss sg13_hv_nmos L=0.45u W=2u AS=0.68p AD=0.38p PS=4.68u
+ PD=2.38u rfmode=0
* device instance $330 r0 *1 53.93,90.825 sg13_hv_nmos
M$330 \$513 \$40 \$514 vss sg13_hv_nmos L=0.45u W=2u AS=0.38p AD=0.68p PS=2.38u
+ PD=4.68u rfmode=0
* device instance $331 r0 *1 65.15,89.995 sg13_hv_nmos
M$331 \$506 \$36 \$515 vss sg13_hv_nmos L=0.45u W=2u AS=0.68p AD=0.38p PS=4.68u
+ PD=2.38u rfmode=0
* device instance $332 r0 *1 65.15,90.825 sg13_hv_nmos
M$332 \$515 \$20 \$516 vss sg13_hv_nmos L=0.45u W=2u AS=0.38p AD=0.68p PS=2.38u
+ PD=4.68u rfmode=0
* device instance $333 r0 *1 87.33,89.995 sg13_hv_nmos
M$333 \$493 \$24 \$519 vss sg13_hv_nmos L=0.45u W=2u AS=0.68p AD=0.38p PS=4.68u
+ PD=2.38u rfmode=0
* device instance $334 r0 *1 87.33,90.825 sg13_hv_nmos
M$334 \$519 \$40 \$518 vss sg13_hv_nmos L=0.45u W=2u AS=0.38p AD=0.68p PS=2.38u
+ PD=4.68u rfmode=0
* device instance $335 r0 *1 103.41,90.585 sg13_hv_nmos
M$335 \$494 \$34 out vss sg13_hv_nmos L=0.45u W=2u AS=0.68p AD=0.38p PS=4.68u
+ PD=2.38u rfmode=0
* device instance $336 r0 *1 103.41,91.415 sg13_hv_nmos
M$336 out \$50 \$526 vss sg13_hv_nmos L=0.45u W=2u AS=0.38p AD=0.68p PS=2.38u
+ PD=4.68u rfmode=0
* device instance $337 r0 *1 70.63,91.755 sg13_hv_nmos
M$337 \$515 \$38 \$507 vss sg13_hv_nmos L=0.45u W=2u AS=0.68p AD=0.38p PS=4.68u
+ PD=2.38u rfmode=0
* device instance $338 r0 *1 70.63,92.585 sg13_hv_nmos
M$338 \$507 \$22 \$536 vss sg13_hv_nmos L=0.45u W=2u AS=0.38p AD=0.68p PS=2.38u
+ PD=4.68u rfmode=0
* device instance $339 r0 *1 81.85,91.755 sg13_hv_nmos
M$339 \$517 \$20 \$525 vss sg13_hv_nmos L=0.45u W=2u AS=0.68p AD=0.38p PS=4.68u
+ PD=2.38u rfmode=0
* device instance $340 r0 *1 81.85,92.585 sg13_hv_nmos
M$340 \$525 \$36 \$533 vss sg13_hv_nmos L=0.45u W=2u AS=0.38p AD=0.68p PS=2.38u
+ PD=4.68u rfmode=0
* device instance $341 r0 *1 37.23,91.755 sg13_hv_nmos
M$341 \$511 \$38 \$504 vss sg13_hv_nmos L=0.45u W=2u AS=0.68p AD=0.38p PS=4.68u
+ PD=2.38u rfmode=0
* device instance $342 r0 *1 37.23,92.585 sg13_hv_nmos
M$342 \$504 \$22 \$534 vss sg13_hv_nmos L=0.45u W=2u AS=0.38p AD=0.68p PS=2.38u
+ PD=4.68u rfmode=0
* device instance $343 r0 *1 48.45,91.755 sg13_hv_nmos
M$343 \$523 \$20 \$524 vss sg13_hv_nmos L=0.45u W=2u AS=0.68p AD=0.38p PS=4.68u
+ PD=2.38u rfmode=0
* device instance $344 r0 *1 48.45,92.585 sg13_hv_nmos
M$344 \$524 \$36 \$532 vss sg13_hv_nmos L=0.45u W=2u AS=0.38p AD=0.68p PS=2.38u
+ PD=4.68u rfmode=0
* device instance $345 r0 *1 31.75,93.515 sg13_hv_nmos
M$345 \$531 \$36 \$534 vss sg13_hv_nmos L=0.45u W=2u AS=0.68p AD=0.38p PS=4.68u
+ PD=2.38u rfmode=0
* device instance $346 r0 *1 31.75,94.345 sg13_hv_nmos
M$346 \$534 \$20 \$541 vss sg13_hv_nmos L=0.45u W=2u AS=0.38p AD=0.68p PS=2.38u
+ PD=4.68u rfmode=0
* device instance $347 r0 *1 53.93,93.515 sg13_hv_nmos
M$347 \$524 \$22 \$514 vss sg13_hv_nmos L=0.45u W=2u AS=0.68p AD=0.38p PS=4.68u
+ PD=2.38u rfmode=0
* device instance $348 r0 *1 53.93,94.345 sg13_hv_nmos
M$348 \$514 \$38 \$546 vss sg13_hv_nmos L=0.45u W=2u AS=0.38p AD=0.68p PS=2.38u
+ PD=4.68u rfmode=0
* device instance $349 r0 *1 65.15,93.515 sg13_hv_nmos
M$349 \$535 \$36 \$536 vss sg13_hv_nmos L=0.45u W=2u AS=0.68p AD=0.38p PS=4.68u
+ PD=2.38u rfmode=0
* device instance $350 r0 *1 65.15,94.345 sg13_hv_nmos
M$350 \$536 \$20 \$543 vss sg13_hv_nmos L=0.45u W=2u AS=0.38p AD=0.68p PS=2.38u
+ PD=4.68u rfmode=0
* device instance $351 r0 *1 87.33,93.515 sg13_hv_nmos
M$351 \$525 \$22 \$518 vss sg13_hv_nmos L=0.45u W=2u AS=0.68p AD=0.38p PS=4.68u
+ PD=2.38u rfmode=0
* device instance $352 r0 *1 87.33,94.345 sg13_hv_nmos
M$352 \$518 \$38 \$548 vss sg13_hv_nmos L=0.45u W=2u AS=0.38p AD=0.68p PS=2.38u
+ PD=4.68u rfmode=0
* device instance $353 r0 *1 103.41,94.105 sg13_hv_nmos
M$353 \$465 \$32 \$526 vss sg13_hv_nmos L=0.45u W=2u AS=0.68p AD=0.38p PS=4.68u
+ PD=2.38u rfmode=0
* device instance $354 r0 *1 103.41,94.935 sg13_hv_nmos
M$354 \$526 \$48 \$446 vss sg13_hv_nmos L=0.45u W=2u AS=0.38p AD=0.68p PS=2.38u
+ PD=4.68u rfmode=0
* device instance $355 r0 *1 70.63,95.275 sg13_hv_nmos
M$355 \$497 \$42 \$547 vss sg13_hv_nmos L=0.45u W=2u AS=0.68p AD=0.38p PS=4.68u
+ PD=2.38u rfmode=0
* device instance $356 r0 *1 70.63,96.105 sg13_hv_nmos
M$356 \$547 \$26 \$556 vss sg13_hv_nmos L=0.45u W=2u AS=0.38p AD=0.68p PS=2.38u
+ PD=4.68u rfmode=0
* device instance $357 r0 *1 81.85,95.275 sg13_hv_nmos
M$357 \$544 \$20 \$548 vss sg13_hv_nmos L=0.45u W=2u AS=0.68p AD=0.38p PS=4.68u
+ PD=2.38u rfmode=0
* device instance $358 r0 *1 81.85,96.105 sg13_hv_nmos
M$358 \$548 \$36 \$557 vss sg13_hv_nmos L=0.45u W=2u AS=0.38p AD=0.68p PS=2.38u
+ PD=4.68u rfmode=0
* device instance $359 r0 *1 37.23,95.275 sg13_hv_nmos
M$359 \$495 \$42 \$545 vss sg13_hv_nmos L=0.45u W=2u AS=0.68p AD=0.38p PS=4.68u
+ PD=2.38u rfmode=0
* device instance $360 r0 *1 37.23,96.105 sg13_hv_nmos
M$360 \$545 \$26 \$553 vss sg13_hv_nmos L=0.45u W=2u AS=0.38p AD=0.68p PS=2.38u
+ PD=4.68u rfmode=0
* device instance $361 r0 *1 48.45,95.275 sg13_hv_nmos
M$361 \$542 \$20 \$546 vss sg13_hv_nmos L=0.45u W=2u AS=0.68p AD=0.38p PS=4.68u
+ PD=2.38u rfmode=0
* device instance $362 r0 *1 48.45,96.105 sg13_hv_nmos
M$362 \$546 \$36 \$554 vss sg13_hv_nmos L=0.45u W=2u AS=0.38p AD=0.68p PS=2.38u
+ PD=4.68u rfmode=0
* device instance $363 r0 *1 31.75,97.035 sg13_hv_nmos
M$363 \$552 \$36 \$559 vss sg13_hv_nmos L=0.45u W=2u AS=0.68p AD=0.38p PS=4.68u
+ PD=2.38u rfmode=0
* device instance $364 r0 *1 31.75,97.865 sg13_hv_nmos
M$364 \$559 \$20 \$567 vss sg13_hv_nmos L=0.45u W=2u AS=0.38p AD=0.68p PS=2.38u
+ PD=4.68u rfmode=0
* device instance $365 r0 *1 53.93,97.035 sg13_hv_nmos
M$365 \$513 \$26 \$560 vss sg13_hv_nmos L=0.45u W=2u AS=0.68p AD=0.38p PS=4.68u
+ PD=2.38u rfmode=0
* device instance $366 r0 *1 53.93,97.865 sg13_hv_nmos
M$366 \$560 \$42 \$569 vss sg13_hv_nmos L=0.45u W=2u AS=0.38p AD=0.68p PS=2.38u
+ PD=4.68u rfmode=0
* device instance $367 r0 *1 65.15,97.035 sg13_hv_nmos
M$367 \$555 \$36 \$561 vss sg13_hv_nmos L=0.45u W=2u AS=0.68p AD=0.38p PS=4.68u
+ PD=2.38u rfmode=0
* device instance $368 r0 *1 65.15,97.865 sg13_hv_nmos
M$368 \$561 \$20 \$570 vss sg13_hv_nmos L=0.45u W=2u AS=0.38p AD=0.68p PS=2.38u
+ PD=4.68u rfmode=0
* device instance $369 r0 *1 87.33,97.035 sg13_hv_nmos
M$369 \$519 \$26 \$562 vss sg13_hv_nmos L=0.45u W=2u AS=0.68p AD=0.38p PS=4.68u
+ PD=2.38u rfmode=0
* device instance $370 r0 *1 87.33,97.865 sg13_hv_nmos
M$370 \$562 \$42 \$572 vss sg13_hv_nmos L=0.45u W=2u AS=0.38p AD=0.68p PS=2.38u
+ PD=4.68u rfmode=0
* device instance $371 r0 *1 37.23,98.795 sg13_hv_nmos
M$371 \$559 \$38 \$578 vss sg13_hv_nmos L=0.45u W=2u AS=0.68p AD=0.38p PS=4.68u
+ PD=2.38u rfmode=0
* device instance $372 r0 *1 37.23,99.625 sg13_hv_nmos
M$372 \$578 \$22 \$585 vss sg13_hv_nmos L=0.45u W=2u AS=0.38p AD=0.68p PS=2.38u
+ PD=4.68u rfmode=0
* device instance $373 r0 *1 48.45,98.795 sg13_hv_nmos
M$373 \$568 \$20 \$579 vss sg13_hv_nmos L=0.45u W=2u AS=0.68p AD=0.38p PS=4.68u
+ PD=2.38u rfmode=0
* device instance $374 r0 *1 48.45,99.625 sg13_hv_nmos
M$374 \$579 \$36 \$580 vss sg13_hv_nmos L=0.45u W=2u AS=0.38p AD=0.68p PS=2.38u
+ PD=4.68u rfmode=0
* device instance $375 r0 *1 70.63,98.795 sg13_hv_nmos
M$375 \$561 \$38 \$582 vss sg13_hv_nmos L=0.45u W=2u AS=0.68p AD=0.38p PS=4.68u
+ PD=2.38u rfmode=0
* device instance $376 r0 *1 70.63,99.625 sg13_hv_nmos
M$376 \$582 \$22 \$587 vss sg13_hv_nmos L=0.45u W=2u AS=0.38p AD=0.68p PS=2.38u
+ PD=4.68u rfmode=0
* device instance $377 r0 *1 81.85,98.795 sg13_hv_nmos
M$377 \$571 \$20 \$583 vss sg13_hv_nmos L=0.45u W=2u AS=0.68p AD=0.38p PS=4.68u
+ PD=2.38u rfmode=0
* device instance $378 r0 *1 81.85,99.625 sg13_hv_nmos
M$378 \$583 \$36 \$584 vss sg13_hv_nmos L=0.45u W=2u AS=0.38p AD=0.68p PS=2.38u
+ PD=4.68u rfmode=0
* device instance $379 r0 *1 31.75,100.555 sg13_hv_nmos
M$379 \$577 \$36 \$585 vss sg13_hv_nmos L=0.45u W=2u AS=0.68p AD=0.38p PS=4.68u
+ PD=2.38u rfmode=0
* device instance $380 r0 *1 31.75,101.385 sg13_hv_nmos
M$380 \$585 \$20 \$593 vss sg13_hv_nmos L=0.45u W=2u AS=0.38p AD=0.68p PS=2.38u
+ PD=4.68u rfmode=0
* device instance $381 r0 *1 53.93,100.555 sg13_hv_nmos
M$381 \$579 \$22 \$586 vss sg13_hv_nmos L=0.45u W=2u AS=0.68p AD=0.38p PS=4.68u
+ PD=2.38u rfmode=0
* device instance $382 r0 *1 53.93,101.385 sg13_hv_nmos
M$382 \$586 \$38 \$604 vss sg13_hv_nmos L=0.45u W=2u AS=0.38p AD=0.68p PS=2.38u
+ PD=4.68u rfmode=0
* device instance $383 r0 *1 65.15,100.555 sg13_hv_nmos
M$383 \$581 \$36 \$587 vss sg13_hv_nmos L=0.45u W=2u AS=0.68p AD=0.38p PS=4.68u
+ PD=2.38u rfmode=0
* device instance $384 r0 *1 65.15,101.385 sg13_hv_nmos
M$384 \$587 \$20 \$595 vss sg13_hv_nmos L=0.45u W=2u AS=0.38p AD=0.68p PS=2.38u
+ PD=4.68u rfmode=0
* device instance $385 r0 *1 87.33,100.555 sg13_hv_nmos
M$385 \$583 \$22 \$588 vss sg13_hv_nmos L=0.45u W=2u AS=0.68p AD=0.38p PS=4.68u
+ PD=2.38u rfmode=0
* device instance $386 r0 *1 87.33,101.385 sg13_hv_nmos
M$386 \$588 \$38 \$607 vss sg13_hv_nmos L=0.45u W=2u AS=0.38p AD=0.68p PS=2.38u
+ PD=4.68u rfmode=0
* device instance $387 r0 *1 37.23,102.315 sg13_hv_nmos
M$387 \$578 \$40 \$553 vss sg13_hv_nmos L=0.45u W=2u AS=0.68p AD=0.38p PS=4.68u
+ PD=2.38u rfmode=0
* device instance $388 r0 *1 37.23,103.145 sg13_hv_nmos
M$388 \$553 \$24 \$602 vss sg13_hv_nmos L=0.45u W=2u AS=0.38p AD=0.68p PS=2.38u
+ PD=4.68u rfmode=0
* device instance $389 r0 *1 48.45,102.315 sg13_hv_nmos
M$389 \$594 \$20 \$604 vss sg13_hv_nmos L=0.45u W=2u AS=0.68p AD=0.38p PS=4.68u
+ PD=2.38u rfmode=0
* device instance $390 r0 *1 48.45,103.145 sg13_hv_nmos
M$390 \$604 \$36 \$603 vss sg13_hv_nmos L=0.45u W=2u AS=0.38p AD=0.68p PS=2.38u
+ PD=4.68u rfmode=0
* device instance $391 r0 *1 70.63,102.315 sg13_hv_nmos
M$391 \$582 \$40 \$556 vss sg13_hv_nmos L=0.45u W=2u AS=0.68p AD=0.38p PS=4.68u
+ PD=2.38u rfmode=0
* device instance $392 r0 *1 70.63,103.145 sg13_hv_nmos
M$392 \$556 \$24 \$606 vss sg13_hv_nmos L=0.45u W=2u AS=0.38p AD=0.68p PS=2.38u
+ PD=4.68u rfmode=0
* device instance $393 r0 *1 81.85,102.315 sg13_hv_nmos
M$393 \$596 \$20 \$607 vss sg13_hv_nmos L=0.45u W=2u AS=0.68p AD=0.38p PS=4.68u
+ PD=2.38u rfmode=0
* device instance $394 r0 *1 81.85,103.145 sg13_hv_nmos
M$394 \$607 \$36 \$608 vss sg13_hv_nmos L=0.45u W=2u AS=0.38p AD=0.68p PS=2.38u
+ PD=4.68u rfmode=0
* device instance $395 r0 *1 31.75,104.075 sg13_hv_nmos
M$395 \$601 \$36 \$609 vss sg13_hv_nmos L=0.45u W=2u AS=0.68p AD=0.38p PS=4.68u
+ PD=2.38u rfmode=0
* device instance $396 r0 *1 31.75,104.905 sg13_hv_nmos
M$396 \$609 \$20 \$615 vss sg13_hv_nmos L=0.45u W=2u AS=0.38p AD=0.68p PS=2.38u
+ PD=4.68u rfmode=0
* device instance $397 r0 *1 53.93,104.075 sg13_hv_nmos
M$397 \$586 \$24 \$569 vss sg13_hv_nmos L=0.45u W=2u AS=0.68p AD=0.38p PS=4.68u
+ PD=2.38u rfmode=0
* device instance $398 r0 *1 53.93,104.905 sg13_hv_nmos
M$398 \$569 \$40 \$617 vss sg13_hv_nmos L=0.45u W=2u AS=0.38p AD=0.68p PS=2.38u
+ PD=4.68u rfmode=0
* device instance $399 r0 *1 65.15,104.075 sg13_hv_nmos
M$399 \$605 \$36 \$610 vss sg13_hv_nmos L=0.45u W=2u AS=0.68p AD=0.38p PS=4.68u
+ PD=2.38u rfmode=0
* device instance $400 r0 *1 65.15,104.905 sg13_hv_nmos
M$400 \$610 \$20 \$618 vss sg13_hv_nmos L=0.45u W=2u AS=0.38p AD=0.68p PS=2.38u
+ PD=4.68u rfmode=0
* device instance $401 r0 *1 87.33,104.075 sg13_hv_nmos
M$401 \$588 \$24 \$572 vss sg13_hv_nmos L=0.45u W=2u AS=0.68p AD=0.38p PS=4.68u
+ PD=2.38u rfmode=0
* device instance $402 r0 *1 87.33,104.905 sg13_hv_nmos
M$402 \$572 \$40 \$620 vss sg13_hv_nmos L=0.45u W=2u AS=0.38p AD=0.68p PS=2.38u
+ PD=4.68u rfmode=0
* device instance $403 r0 *1 37.23,105.835 sg13_hv_nmos
M$403 \$609 \$38 \$602 vss sg13_hv_nmos L=0.45u W=2u AS=0.68p AD=0.38p PS=4.68u
+ PD=2.38u rfmode=0
* device instance $404 r0 *1 37.23,106.665 sg13_hv_nmos
M$404 \$602 \$22 \$631 vss sg13_hv_nmos L=0.45u W=2u AS=0.38p AD=0.68p PS=2.38u
+ PD=4.68u rfmode=0
* device instance $405 r0 *1 48.45,105.835 sg13_hv_nmos
M$405 \$616 \$20 \$626 vss sg13_hv_nmos L=0.45u W=2u AS=0.68p AD=0.38p PS=4.68u
+ PD=2.38u rfmode=0
* device instance $406 r0 *1 48.45,106.665 sg13_hv_nmos
M$406 \$626 \$36 \$627 vss sg13_hv_nmos L=0.45u W=2u AS=0.38p AD=0.68p PS=2.38u
+ PD=4.68u rfmode=0
* device instance $407 r0 *1 70.63,105.835 sg13_hv_nmos
M$407 \$610 \$38 \$606 vss sg13_hv_nmos L=0.45u W=2u AS=0.68p AD=0.38p PS=4.68u
+ PD=2.38u rfmode=0
* device instance $408 r0 *1 70.63,106.665 sg13_hv_nmos
M$408 \$606 \$22 \$632 vss sg13_hv_nmos L=0.45u W=2u AS=0.38p AD=0.68p PS=2.38u
+ PD=4.68u rfmode=0
* device instance $409 r0 *1 81.85,105.835 sg13_hv_nmos
M$409 \$619 \$20 \$629 vss sg13_hv_nmos L=0.45u W=2u AS=0.68p AD=0.38p PS=4.68u
+ PD=2.38u rfmode=0
* device instance $410 r0 *1 81.85,106.665 sg13_hv_nmos
M$410 \$629 \$36 \$630 vss sg13_hv_nmos L=0.45u W=2u AS=0.38p AD=0.68p PS=2.38u
+ PD=4.68u rfmode=0
* device instance $411 r0 *1 31.75,107.595 sg13_hv_nmos
M$411 \$625 \$36 \$631 vss sg13_hv_nmos L=0.45u W=2u AS=0.68p AD=0.38p PS=4.68u
+ PD=2.38u rfmode=0
* device instance $412 r0 *1 31.75,108.425 sg13_hv_nmos
M$412 \$631 \$20 \$637 vss sg13_hv_nmos L=0.45u W=2u AS=0.38p AD=0.68p PS=2.38u
+ PD=4.68u rfmode=0
* device instance $413 r0 *1 53.93,107.595 sg13_hv_nmos
M$413 \$626 \$22 \$617 vss sg13_hv_nmos L=0.45u W=2u AS=0.68p AD=0.38p PS=4.68u
+ PD=2.38u rfmode=0
* device instance $414 r0 *1 53.93,108.425 sg13_hv_nmos
M$414 \$617 \$38 \$647 vss sg13_hv_nmos L=0.45u W=2u AS=0.38p AD=0.68p PS=2.38u
+ PD=4.68u rfmode=0
* device instance $415 r0 *1 65.15,107.595 sg13_hv_nmos
M$415 \$628 \$36 \$632 vss sg13_hv_nmos L=0.45u W=2u AS=0.68p AD=0.38p PS=4.68u
+ PD=2.38u rfmode=0
* device instance $416 r0 *1 65.15,108.425 sg13_hv_nmos
M$416 \$632 \$20 \$639 vss sg13_hv_nmos L=0.45u W=2u AS=0.38p AD=0.68p PS=2.38u
+ PD=4.68u rfmode=0
* device instance $417 r0 *1 87.33,107.595 sg13_hv_nmos
M$417 \$629 \$22 \$620 vss sg13_hv_nmos L=0.45u W=2u AS=0.68p AD=0.38p PS=4.68u
+ PD=2.38u rfmode=0
* device instance $418 r0 *1 87.33,108.425 sg13_hv_nmos
M$418 \$620 \$38 \$651 vss sg13_hv_nmos L=0.45u W=2u AS=0.38p AD=0.68p PS=2.38u
+ PD=4.68u rfmode=0
* device instance $419 r0 *1 37.23,109.355 sg13_hv_nmos
M$419 \$545 \$44 \$646 vss sg13_hv_nmos L=0.45u W=2u AS=0.68p AD=0.38p PS=4.68u
+ PD=2.38u rfmode=0
* device instance $420 r0 *1 37.23,110.185 sg13_hv_nmos
M$420 \$646 \$28 \$743 vss sg13_hv_nmos L=0.45u W=2u AS=0.38p AD=0.68p PS=2.38u
+ PD=4.68u rfmode=0
* device instance $421 r0 *1 48.45,109.355 sg13_hv_nmos
M$421 \$638 \$20 \$647 vss sg13_hv_nmos L=0.45u W=2u AS=0.68p AD=0.38p PS=4.68u
+ PD=2.38u rfmode=0
* device instance $422 r0 *1 48.45,110.185 sg13_hv_nmos
M$422 \$647 \$36 \$648 vss sg13_hv_nmos L=0.45u W=2u AS=0.38p AD=0.68p PS=2.38u
+ PD=4.68u rfmode=0
* device instance $423 r0 *1 70.63,109.355 sg13_hv_nmos
M$423 \$547 \$44 \$650 vss sg13_hv_nmos L=0.45u W=2u AS=0.68p AD=0.38p PS=4.68u
+ PD=2.38u rfmode=0
* device instance $424 r0 *1 70.63,110.185 sg13_hv_nmos
M$424 \$650 \$28 \$747 vss sg13_hv_nmos L=0.45u W=2u AS=0.38p AD=0.68p PS=2.38u
+ PD=4.68u rfmode=0
* device instance $425 r0 *1 81.85,109.355 sg13_hv_nmos
M$425 \$640 \$20 \$651 vss sg13_hv_nmos L=0.45u W=2u AS=0.68p AD=0.38p PS=4.68u
+ PD=2.38u rfmode=0
* device instance $426 r0 *1 81.85,110.185 sg13_hv_nmos
M$426 \$651 \$36 \$652 vss sg13_hv_nmos L=0.45u W=2u AS=0.38p AD=0.68p PS=2.38u
+ PD=4.68u rfmode=0
* device instance $427 r0 *1 31.75,111.115 sg13_hv_nmos
M$427 \$645 \$36 \$653 vss sg13_hv_nmos L=0.45u W=2u AS=0.68p AD=0.38p PS=4.68u
+ PD=2.38u rfmode=0
* device instance $428 r0 *1 31.75,111.945 sg13_hv_nmos
M$428 \$653 \$20 \$661 vss sg13_hv_nmos L=0.45u W=2u AS=0.38p AD=0.68p PS=2.38u
+ PD=4.68u rfmode=0
* device instance $429 r0 *1 53.93,111.115 sg13_hv_nmos
M$429 \$560 \$28 \$654 vss sg13_hv_nmos L=0.45u W=2u AS=0.68p AD=0.38p PS=4.68u
+ PD=2.38u rfmode=0
* device instance $430 r0 *1 53.93,111.945 sg13_hv_nmos
M$430 \$654 \$44 \$752 vss sg13_hv_nmos L=0.45u W=2u AS=0.38p AD=0.68p PS=2.38u
+ PD=4.68u rfmode=0
* device instance $431 r0 *1 65.15,111.115 sg13_hv_nmos
M$431 \$649 \$36 \$655 vss sg13_hv_nmos L=0.45u W=2u AS=0.68p AD=0.38p PS=4.68u
+ PD=2.38u rfmode=0
* device instance $432 r0 *1 65.15,111.945 sg13_hv_nmos
M$432 \$655 \$20 \$663 vss sg13_hv_nmos L=0.45u W=2u AS=0.38p AD=0.68p PS=2.38u
+ PD=4.68u rfmode=0
* device instance $433 r0 *1 87.33,111.115 sg13_hv_nmos
M$433 \$562 \$28 \$656 vss sg13_hv_nmos L=0.45u W=2u AS=0.68p AD=0.38p PS=4.68u
+ PD=2.38u rfmode=0
* device instance $434 r0 *1 87.33,111.945 sg13_hv_nmos
M$434 \$656 \$44 \$754 vss sg13_hv_nmos L=0.45u W=2u AS=0.38p AD=0.68p PS=2.38u
+ PD=4.68u rfmode=0
* device instance $435 r0 *1 37.23,112.875 sg13_hv_nmos
M$435 \$653 \$38 \$670 vss sg13_hv_nmos L=0.45u W=2u AS=0.68p AD=0.38p PS=4.68u
+ PD=2.38u rfmode=0
* device instance $436 r0 *1 37.23,113.705 sg13_hv_nmos
M$436 \$670 \$22 \$677 vss sg13_hv_nmos L=0.45u W=2u AS=0.38p AD=0.68p PS=2.38u
+ PD=4.68u rfmode=0
* device instance $437 r0 *1 48.45,112.875 sg13_hv_nmos
M$437 \$662 \$20 \$672 vss sg13_hv_nmos L=0.45u W=2u AS=0.68p AD=0.38p PS=4.68u
+ PD=2.38u rfmode=0
* device instance $438 r0 *1 48.45,113.705 sg13_hv_nmos
M$438 \$672 \$36 \$671 vss sg13_hv_nmos L=0.45u W=2u AS=0.38p AD=0.68p PS=2.38u
+ PD=4.68u rfmode=0
* device instance $439 r0 *1 70.63,112.875 sg13_hv_nmos
M$439 \$655 \$38 \$674 vss sg13_hv_nmos L=0.45u W=2u AS=0.68p AD=0.38p PS=4.68u
+ PD=2.38u rfmode=0
* device instance $440 r0 *1 70.63,113.705 sg13_hv_nmos
M$440 \$674 \$22 \$679 vss sg13_hv_nmos L=0.45u W=2u AS=0.38p AD=0.68p PS=2.38u
+ PD=4.68u rfmode=0
* device instance $441 r0 *1 81.85,112.875 sg13_hv_nmos
M$441 \$664 \$20 \$675 vss sg13_hv_nmos L=0.45u W=2u AS=0.68p AD=0.38p PS=4.68u
+ PD=2.38u rfmode=0
* device instance $442 r0 *1 81.85,113.705 sg13_hv_nmos
M$442 \$675 \$36 \$676 vss sg13_hv_nmos L=0.45u W=2u AS=0.38p AD=0.68p PS=2.38u
+ PD=4.68u rfmode=0
* device instance $443 r0 *1 31.75,114.635 sg13_hv_nmos
M$443 \$669 \$36 \$677 vss sg13_hv_nmos L=0.45u W=2u AS=0.68p AD=0.38p PS=4.68u
+ PD=2.38u rfmode=0
* device instance $444 r0 *1 31.75,115.465 sg13_hv_nmos
M$444 \$677 \$20 \$685 vss sg13_hv_nmos L=0.45u W=2u AS=0.38p AD=0.68p PS=2.38u
+ PD=4.68u rfmode=0
* device instance $445 r0 *1 53.93,114.635 sg13_hv_nmos
M$445 \$672 \$22 \$678 vss sg13_hv_nmos L=0.45u W=2u AS=0.68p AD=0.38p PS=4.68u
+ PD=2.38u rfmode=0
* device instance $446 r0 *1 53.93,115.465 sg13_hv_nmos
M$446 \$678 \$38 \$696 vss sg13_hv_nmos L=0.45u W=2u AS=0.38p AD=0.68p PS=2.38u
+ PD=4.68u rfmode=0
* device instance $447 r0 *1 65.15,114.635 sg13_hv_nmos
M$447 \$673 \$36 \$679 vss sg13_hv_nmos L=0.45u W=2u AS=0.68p AD=0.38p PS=4.68u
+ PD=2.38u rfmode=0
* device instance $448 r0 *1 65.15,115.465 sg13_hv_nmos
M$448 \$679 \$20 \$687 vss sg13_hv_nmos L=0.45u W=2u AS=0.38p AD=0.68p PS=2.38u
+ PD=4.68u rfmode=0
* device instance $449 r0 *1 87.33,114.635 sg13_hv_nmos
M$449 \$675 \$22 \$680 vss sg13_hv_nmos L=0.45u W=2u AS=0.68p AD=0.38p PS=4.68u
+ PD=2.38u rfmode=0
* device instance $450 r0 *1 87.33,115.465 sg13_hv_nmos
M$450 \$680 \$38 \$701 vss sg13_hv_nmos L=0.45u W=2u AS=0.38p AD=0.68p PS=2.38u
+ PD=4.68u rfmode=0
* device instance $451 r0 *1 37.23,116.395 sg13_hv_nmos
M$451 \$670 \$40 \$695 vss sg13_hv_nmos L=0.45u W=2u AS=0.68p AD=0.38p PS=4.68u
+ PD=2.38u rfmode=0
* device instance $452 r0 *1 37.23,117.225 sg13_hv_nmos
M$452 \$695 \$24 \$694 vss sg13_hv_nmos L=0.45u W=2u AS=0.38p AD=0.68p PS=2.38u
+ PD=4.68u rfmode=0
* device instance $453 r0 *1 48.45,116.395 sg13_hv_nmos
M$453 \$686 \$20 \$696 vss sg13_hv_nmos L=0.45u W=2u AS=0.68p AD=0.38p PS=4.68u
+ PD=2.38u rfmode=0
* device instance $454 r0 *1 48.45,117.225 sg13_hv_nmos
M$454 \$696 \$36 \$697 vss sg13_hv_nmos L=0.45u W=2u AS=0.38p AD=0.68p PS=2.38u
+ PD=4.68u rfmode=0
* device instance $455 r0 *1 70.63,116.395 sg13_hv_nmos
M$455 \$674 \$40 \$699 vss sg13_hv_nmos L=0.45u W=2u AS=0.68p AD=0.38p PS=4.68u
+ PD=2.38u rfmode=0
* device instance $456 r0 *1 70.63,117.225 sg13_hv_nmos
M$456 \$699 \$24 \$700 vss sg13_hv_nmos L=0.45u W=2u AS=0.38p AD=0.68p PS=2.38u
+ PD=4.68u rfmode=0
* device instance $457 r0 *1 81.85,116.395 sg13_hv_nmos
M$457 \$688 \$20 \$701 vss sg13_hv_nmos L=0.45u W=2u AS=0.68p AD=0.38p PS=4.68u
+ PD=2.38u rfmode=0
* device instance $458 r0 *1 81.85,117.225 sg13_hv_nmos
M$458 \$701 \$36 \$702 vss sg13_hv_nmos L=0.45u W=2u AS=0.38p AD=0.68p PS=2.38u
+ PD=4.68u rfmode=0
* device instance $459 r0 *1 31.75,118.155 sg13_hv_nmos
M$459 \$693 \$36 \$703 vss sg13_hv_nmos L=0.45u W=2u AS=0.68p AD=0.38p PS=4.68u
+ PD=2.38u rfmode=0
* device instance $460 r0 *1 31.75,118.985 sg13_hv_nmos
M$460 \$703 \$20 \$711 vss sg13_hv_nmos L=0.45u W=2u AS=0.38p AD=0.68p PS=2.38u
+ PD=4.68u rfmode=0
* device instance $461 r0 *1 53.93,118.155 sg13_hv_nmos
M$461 \$678 \$24 \$704 vss sg13_hv_nmos L=0.45u W=2u AS=0.68p AD=0.38p PS=4.68u
+ PD=2.38u rfmode=0
* device instance $462 r0 *1 53.93,118.985 sg13_hv_nmos
M$462 \$704 \$40 \$713 vss sg13_hv_nmos L=0.45u W=2u AS=0.38p AD=0.68p PS=2.38u
+ PD=4.68u rfmode=0
* device instance $463 r0 *1 65.15,118.155 sg13_hv_nmos
M$463 \$698 \$36 \$705 vss sg13_hv_nmos L=0.45u W=2u AS=0.68p AD=0.38p PS=4.68u
+ PD=2.38u rfmode=0
* device instance $464 r0 *1 65.15,118.985 sg13_hv_nmos
M$464 \$705 \$20 \$714 vss sg13_hv_nmos L=0.45u W=2u AS=0.38p AD=0.68p PS=2.38u
+ PD=4.68u rfmode=0
* device instance $465 r0 *1 87.33,118.155 sg13_hv_nmos
M$465 \$680 \$24 \$706 vss sg13_hv_nmos L=0.45u W=2u AS=0.68p AD=0.38p PS=4.68u
+ PD=2.38u rfmode=0
* device instance $466 r0 *1 87.33,118.985 sg13_hv_nmos
M$466 \$706 \$40 \$716 vss sg13_hv_nmos L=0.45u W=2u AS=0.38p AD=0.68p PS=2.38u
+ PD=4.68u rfmode=0
* device instance $467 r0 *1 37.23,119.915 sg13_hv_nmos
M$467 \$703 \$38 \$694 vss sg13_hv_nmos L=0.45u W=2u AS=0.68p AD=0.38p PS=4.68u
+ PD=2.38u rfmode=0
* device instance $468 r0 *1 37.23,120.745 sg13_hv_nmos
M$468 \$694 \$22 \$727 vss sg13_hv_nmos L=0.45u W=2u AS=0.38p AD=0.68p PS=2.38u
+ PD=4.68u rfmode=0
* device instance $469 r0 *1 48.45,119.915 sg13_hv_nmos
M$469 \$712 \$20 \$723 vss sg13_hv_nmos L=0.45u W=2u AS=0.68p AD=0.38p PS=4.68u
+ PD=2.38u rfmode=0
* device instance $470 r0 *1 48.45,120.745 sg13_hv_nmos
M$470 \$723 \$36 \$722 vss sg13_hv_nmos L=0.45u W=2u AS=0.38p AD=0.68p PS=2.38u
+ PD=4.68u rfmode=0
* device instance $471 r0 *1 70.63,119.915 sg13_hv_nmos
M$471 \$705 \$38 \$700 vss sg13_hv_nmos L=0.45u W=2u AS=0.68p AD=0.38p PS=4.68u
+ PD=2.38u rfmode=0
* device instance $472 r0 *1 70.63,120.745 sg13_hv_nmos
M$472 \$700 \$22 \$728 vss sg13_hv_nmos L=0.45u W=2u AS=0.38p AD=0.68p PS=2.38u
+ PD=4.68u rfmode=0
* device instance $473 r0 *1 81.85,119.915 sg13_hv_nmos
M$473 \$715 \$20 \$725 vss sg13_hv_nmos L=0.45u W=2u AS=0.68p AD=0.38p PS=4.68u
+ PD=2.38u rfmode=0
* device instance $474 r0 *1 81.85,120.745 sg13_hv_nmos
M$474 \$725 \$36 \$726 vss sg13_hv_nmos L=0.45u W=2u AS=0.38p AD=0.68p PS=2.38u
+ PD=4.68u rfmode=0
* device instance $475 r0 *1 31.75,121.675 sg13_hv_nmos
M$475 \$721 \$36 \$727 vss sg13_hv_nmos L=0.45u W=2u AS=0.68p AD=0.38p PS=4.68u
+ PD=2.38u rfmode=0
* device instance $476 r0 *1 31.75,122.505 sg13_hv_nmos
M$476 \$727 \$20 \$733 vss sg13_hv_nmos L=0.45u W=2u AS=0.38p AD=0.68p PS=2.38u
+ PD=4.68u rfmode=0
* device instance $477 r0 *1 53.93,121.675 sg13_hv_nmos
M$477 \$723 \$22 \$713 vss sg13_hv_nmos L=0.45u W=2u AS=0.68p AD=0.38p PS=4.68u
+ PD=2.38u rfmode=0
* device instance $478 r0 *1 53.93,122.505 sg13_hv_nmos
M$478 \$713 \$38 \$744 vss sg13_hv_nmos L=0.45u W=2u AS=0.38p AD=0.68p PS=2.38u
+ PD=4.68u rfmode=0
* device instance $479 r0 *1 65.15,121.675 sg13_hv_nmos
M$479 \$724 \$36 \$728 vss sg13_hv_nmos L=0.45u W=2u AS=0.68p AD=0.38p PS=4.68u
+ PD=2.38u rfmode=0
* device instance $480 r0 *1 65.15,122.505 sg13_hv_nmos
M$480 \$728 \$20 \$735 vss sg13_hv_nmos L=0.45u W=2u AS=0.38p AD=0.68p PS=2.38u
+ PD=4.68u rfmode=0
* device instance $481 r0 *1 87.33,121.675 sg13_hv_nmos
M$481 \$725 \$22 \$716 vss sg13_hv_nmos L=0.45u W=2u AS=0.68p AD=0.38p PS=4.68u
+ PD=2.38u rfmode=0
* device instance $482 r0 *1 87.33,122.505 sg13_hv_nmos
M$482 \$716 \$38 \$749 vss sg13_hv_nmos L=0.45u W=2u AS=0.38p AD=0.68p PS=2.38u
+ PD=4.68u rfmode=0
* device instance $483 r0 *1 37.23,123.435 sg13_hv_nmos
M$483 \$695 \$42 \$743 vss sg13_hv_nmos L=0.45u W=2u AS=0.68p AD=0.38p PS=4.68u
+ PD=2.38u rfmode=0
* device instance $484 r0 *1 37.23,124.265 sg13_hv_nmos
M$484 \$743 \$26 \$742 vss sg13_hv_nmos L=0.45u W=2u AS=0.38p AD=0.68p PS=2.38u
+ PD=4.68u rfmode=0
* device instance $485 r0 *1 48.45,123.435 sg13_hv_nmos
M$485 \$734 \$20 \$744 vss sg13_hv_nmos L=0.45u W=2u AS=0.68p AD=0.38p PS=4.68u
+ PD=2.38u rfmode=0
* device instance $486 r0 *1 48.45,124.265 sg13_hv_nmos
M$486 \$744 \$36 \$745 vss sg13_hv_nmos L=0.45u W=2u AS=0.38p AD=0.68p PS=2.38u
+ PD=4.68u rfmode=0
* device instance $487 r0 *1 70.63,123.435 sg13_hv_nmos
M$487 \$699 \$42 \$747 vss sg13_hv_nmos L=0.45u W=2u AS=0.68p AD=0.38p PS=4.68u
+ PD=2.38u rfmode=0
* device instance $488 r0 *1 70.63,124.265 sg13_hv_nmos
M$488 \$747 \$26 \$748 vss sg13_hv_nmos L=0.45u W=2u AS=0.38p AD=0.68p PS=2.38u
+ PD=4.68u rfmode=0
* device instance $489 r0 *1 81.85,123.435 sg13_hv_nmos
M$489 \$736 \$20 \$749 vss sg13_hv_nmos L=0.45u W=2u AS=0.68p AD=0.38p PS=4.68u
+ PD=2.38u rfmode=0
* device instance $490 r0 *1 81.85,124.265 sg13_hv_nmos
M$490 \$749 \$36 \$750 vss sg13_hv_nmos L=0.45u W=2u AS=0.38p AD=0.68p PS=2.38u
+ PD=4.68u rfmode=0
* device instance $491 r0 *1 31.75,125.195 sg13_hv_nmos
M$491 \$741 \$36 \$751 vss sg13_hv_nmos L=0.45u W=2u AS=0.68p AD=0.38p PS=4.68u
+ PD=2.38u rfmode=0
* device instance $492 r0 *1 31.75,126.025 sg13_hv_nmos
M$492 \$751 \$20 \$759 vss sg13_hv_nmos L=0.45u W=2u AS=0.38p AD=0.68p PS=2.38u
+ PD=4.68u rfmode=0
* device instance $493 r0 *1 53.93,125.195 sg13_hv_nmos
M$493 \$704 \$26 \$752 vss sg13_hv_nmos L=0.45u W=2u AS=0.68p AD=0.38p PS=4.68u
+ PD=2.38u rfmode=0
* device instance $494 r0 *1 53.93,126.025 sg13_hv_nmos
M$494 \$752 \$42 \$761 vss sg13_hv_nmos L=0.45u W=2u AS=0.38p AD=0.68p PS=2.38u
+ PD=4.68u rfmode=0
* device instance $495 r0 *1 65.15,125.195 sg13_hv_nmos
M$495 \$746 \$36 \$753 vss sg13_hv_nmos L=0.45u W=2u AS=0.68p AD=0.38p PS=4.68u
+ PD=2.38u rfmode=0
* device instance $496 r0 *1 65.15,126.025 sg13_hv_nmos
M$496 \$753 \$20 \$762 vss sg13_hv_nmos L=0.45u W=2u AS=0.38p AD=0.68p PS=2.38u
+ PD=4.68u rfmode=0
* device instance $497 r0 *1 87.33,125.195 sg13_hv_nmos
M$497 \$706 \$26 \$754 vss sg13_hv_nmos L=0.45u W=2u AS=0.68p AD=0.38p PS=4.68u
+ PD=2.38u rfmode=0
* device instance $498 r0 *1 87.33,126.025 sg13_hv_nmos
M$498 \$754 \$42 \$764 vss sg13_hv_nmos L=0.45u W=2u AS=0.38p AD=0.68p PS=2.38u
+ PD=4.68u rfmode=0
* device instance $499 r0 *1 37.23,126.955 sg13_hv_nmos
M$499 \$751 \$38 \$770 vss sg13_hv_nmos L=0.45u W=2u AS=0.68p AD=0.38p PS=4.68u
+ PD=2.38u rfmode=0
* device instance $500 r0 *1 37.23,127.785 sg13_hv_nmos
M$500 \$770 \$22 \$777 vss sg13_hv_nmos L=0.45u W=2u AS=0.38p AD=0.68p PS=2.38u
+ PD=4.68u rfmode=0
* device instance $501 r0 *1 48.45,126.955 sg13_hv_nmos
M$501 \$760 \$20 \$772 vss sg13_hv_nmos L=0.45u W=2u AS=0.68p AD=0.38p PS=4.68u
+ PD=2.38u rfmode=0
* device instance $502 r0 *1 48.45,127.785 sg13_hv_nmos
M$502 \$772 \$36 \$771 vss sg13_hv_nmos L=0.45u W=2u AS=0.38p AD=0.68p PS=2.38u
+ PD=4.68u rfmode=0
* device instance $503 r0 *1 70.63,126.955 sg13_hv_nmos
M$503 \$753 \$38 \$774 vss sg13_hv_nmos L=0.45u W=2u AS=0.68p AD=0.38p PS=4.68u
+ PD=2.38u rfmode=0
* device instance $504 r0 *1 70.63,127.785 sg13_hv_nmos
M$504 \$774 \$22 \$779 vss sg13_hv_nmos L=0.45u W=2u AS=0.38p AD=0.68p PS=2.38u
+ PD=4.68u rfmode=0
* device instance $505 r0 *1 81.85,126.955 sg13_hv_nmos
M$505 \$763 \$20 \$775 vss sg13_hv_nmos L=0.45u W=2u AS=0.68p AD=0.38p PS=4.68u
+ PD=2.38u rfmode=0
* device instance $506 r0 *1 81.85,127.785 sg13_hv_nmos
M$506 \$775 \$36 \$776 vss sg13_hv_nmos L=0.45u W=2u AS=0.38p AD=0.68p PS=2.38u
+ PD=4.68u rfmode=0
* device instance $507 r0 *1 31.75,128.715 sg13_hv_nmos
M$507 \$769 \$36 \$777 vss sg13_hv_nmos L=0.45u W=2u AS=0.68p AD=0.38p PS=4.68u
+ PD=2.38u rfmode=0
* device instance $508 r0 *1 31.75,129.545 sg13_hv_nmos
M$508 \$777 \$20 \$785 vss sg13_hv_nmos L=0.45u W=2u AS=0.38p AD=0.68p PS=2.38u
+ PD=4.68u rfmode=0
* device instance $509 r0 *1 53.93,128.715 sg13_hv_nmos
M$509 \$772 \$22 \$778 vss sg13_hv_nmos L=0.45u W=2u AS=0.68p AD=0.38p PS=4.68u
+ PD=2.38u rfmode=0
* device instance $510 r0 *1 53.93,129.545 sg13_hv_nmos
M$510 \$778 \$38 \$795 vss sg13_hv_nmos L=0.45u W=2u AS=0.38p AD=0.68p PS=2.38u
+ PD=4.68u rfmode=0
* device instance $511 r0 *1 65.15,128.715 sg13_hv_nmos
M$511 \$773 \$36 \$779 vss sg13_hv_nmos L=0.45u W=2u AS=0.68p AD=0.38p PS=4.68u
+ PD=2.38u rfmode=0
* device instance $512 r0 *1 65.15,129.545 sg13_hv_nmos
M$512 \$779 \$20 \$787 vss sg13_hv_nmos L=0.45u W=2u AS=0.38p AD=0.68p PS=2.38u
+ PD=4.68u rfmode=0
* device instance $513 r0 *1 87.33,128.715 sg13_hv_nmos
M$513 \$775 \$22 \$780 vss sg13_hv_nmos L=0.45u W=2u AS=0.68p AD=0.38p PS=4.68u
+ PD=2.38u rfmode=0
* device instance $514 r0 *1 87.33,129.545 sg13_hv_nmos
M$514 \$780 \$38 \$799 vss sg13_hv_nmos L=0.45u W=2u AS=0.38p AD=0.68p PS=2.38u
+ PD=4.68u rfmode=0
* device instance $515 r0 *1 37.23,130.475 sg13_hv_nmos
M$515 \$770 \$40 \$742 vss sg13_hv_nmos L=0.45u W=2u AS=0.68p AD=0.38p PS=4.68u
+ PD=2.38u rfmode=0
* device instance $516 r0 *1 37.23,131.305 sg13_hv_nmos
M$516 \$742 \$24 \$794 vss sg13_hv_nmos L=0.45u W=2u AS=0.38p AD=0.68p PS=2.38u
+ PD=4.68u rfmode=0
* device instance $517 r0 *1 48.45,130.475 sg13_hv_nmos
M$517 \$786 \$20 \$795 vss sg13_hv_nmos L=0.45u W=2u AS=0.68p AD=0.38p PS=4.68u
+ PD=2.38u rfmode=0
* device instance $518 r0 *1 48.45,131.305 sg13_hv_nmos
M$518 \$795 \$36 \$796 vss sg13_hv_nmos L=0.45u W=2u AS=0.38p AD=0.68p PS=2.38u
+ PD=4.68u rfmode=0
* device instance $519 r0 *1 70.63,130.475 sg13_hv_nmos
M$519 \$774 \$40 \$748 vss sg13_hv_nmos L=0.45u W=2u AS=0.68p AD=0.38p PS=4.68u
+ PD=2.38u rfmode=0
* device instance $520 r0 *1 70.63,131.305 sg13_hv_nmos
M$520 \$748 \$24 \$798 vss sg13_hv_nmos L=0.45u W=2u AS=0.38p AD=0.68p PS=2.38u
+ PD=4.68u rfmode=0
* device instance $521 r0 *1 81.85,130.475 sg13_hv_nmos
M$521 \$788 \$20 \$799 vss sg13_hv_nmos L=0.45u W=2u AS=0.68p AD=0.38p PS=4.68u
+ PD=2.38u rfmode=0
* device instance $522 r0 *1 81.85,131.305 sg13_hv_nmos
M$522 \$799 \$36 \$800 vss sg13_hv_nmos L=0.45u W=2u AS=0.38p AD=0.68p PS=2.38u
+ PD=4.68u rfmode=0
* device instance $523 r0 *1 31.75,132.235 sg13_hv_nmos
M$523 \$793 \$36 \$801 vss sg13_hv_nmos L=0.45u W=2u AS=0.68p AD=0.38p PS=4.68u
+ PD=2.38u rfmode=0
* device instance $524 r0 *1 31.75,133.065 sg13_hv_nmos
M$524 \$801 \$20 \$807 vss sg13_hv_nmos L=0.45u W=2u AS=0.38p AD=0.68p PS=2.38u
+ PD=4.68u rfmode=0
* device instance $525 r0 *1 53.93,132.235 sg13_hv_nmos
M$525 \$778 \$24 \$761 vss sg13_hv_nmos L=0.45u W=2u AS=0.68p AD=0.38p PS=4.68u
+ PD=2.38u rfmode=0
* device instance $526 r0 *1 53.93,133.065 sg13_hv_nmos
M$526 \$761 \$40 \$809 vss sg13_hv_nmos L=0.45u W=2u AS=0.38p AD=0.68p PS=2.38u
+ PD=4.68u rfmode=0
* device instance $527 r0 *1 65.15,132.235 sg13_hv_nmos
M$527 \$797 \$36 \$802 vss sg13_hv_nmos L=0.45u W=2u AS=0.68p AD=0.38p PS=4.68u
+ PD=2.38u rfmode=0
* device instance $528 r0 *1 65.15,133.065 sg13_hv_nmos
M$528 \$802 \$20 \$810 vss sg13_hv_nmos L=0.45u W=2u AS=0.38p AD=0.68p PS=2.38u
+ PD=4.68u rfmode=0
* device instance $529 r0 *1 87.33,132.235 sg13_hv_nmos
M$529 \$780 \$24 \$764 vss sg13_hv_nmos L=0.45u W=2u AS=0.68p AD=0.38p PS=4.68u
+ PD=2.38u rfmode=0
* device instance $530 r0 *1 87.33,133.065 sg13_hv_nmos
M$530 \$764 \$40 \$812 vss sg13_hv_nmos L=0.45u W=2u AS=0.38p AD=0.68p PS=2.38u
+ PD=4.68u rfmode=0
* device instance $531 r0 *1 37.23,133.995 sg13_hv_nmos
M$531 \$801 \$38 \$794 vss sg13_hv_nmos L=0.45u W=2u AS=0.68p AD=0.38p PS=4.68u
+ PD=2.38u rfmode=0
* device instance $532 r0 *1 37.23,134.825 sg13_hv_nmos
M$532 \$794 \$22 \$823 vss sg13_hv_nmos L=0.45u W=2u AS=0.38p AD=0.68p PS=2.38u
+ PD=4.68u rfmode=0
* device instance $533 r0 *1 48.45,133.995 sg13_hv_nmos
M$533 \$808 \$20 \$818 vss sg13_hv_nmos L=0.45u W=2u AS=0.68p AD=0.38p PS=4.68u
+ PD=2.38u rfmode=0
* device instance $534 r0 *1 48.45,134.825 sg13_hv_nmos
M$534 \$818 \$36 \$819 vss sg13_hv_nmos L=0.45u W=2u AS=0.38p AD=0.68p PS=2.38u
+ PD=4.68u rfmode=0
* device instance $535 r0 *1 70.63,133.995 sg13_hv_nmos
M$535 \$802 \$38 \$798 vss sg13_hv_nmos L=0.45u W=2u AS=0.68p AD=0.38p PS=4.68u
+ PD=2.38u rfmode=0
* device instance $536 r0 *1 70.63,134.825 sg13_hv_nmos
M$536 \$798 \$22 \$824 vss sg13_hv_nmos L=0.45u W=2u AS=0.38p AD=0.68p PS=2.38u
+ PD=4.68u rfmode=0
* device instance $537 r0 *1 81.85,133.995 sg13_hv_nmos
M$537 \$811 \$20 \$821 vss sg13_hv_nmos L=0.45u W=2u AS=0.68p AD=0.38p PS=4.68u
+ PD=2.38u rfmode=0
* device instance $538 r0 *1 81.85,134.825 sg13_hv_nmos
M$538 \$821 \$36 \$822 vss sg13_hv_nmos L=0.45u W=2u AS=0.38p AD=0.68p PS=2.38u
+ PD=4.68u rfmode=0
* device instance $539 r0 *1 31.75,135.755 sg13_hv_nmos
M$539 \$817 \$36 \$823 vss sg13_hv_nmos L=0.45u W=2u AS=0.68p AD=0.38p PS=4.68u
+ PD=2.38u rfmode=0
* device instance $540 r0 *1 31.75,136.585 sg13_hv_nmos
M$540 \$823 \$20 \$829 vss sg13_hv_nmos L=0.45u W=2u AS=0.38p AD=0.68p PS=2.38u
+ PD=4.68u rfmode=0
* device instance $541 r0 *1 53.93,135.755 sg13_hv_nmos
M$541 \$818 \$22 \$809 vss sg13_hv_nmos L=0.45u W=2u AS=0.68p AD=0.38p PS=4.68u
+ PD=2.38u rfmode=0
* device instance $542 r0 *1 53.93,136.585 sg13_hv_nmos
M$542 \$809 \$38 \$836 vss sg13_hv_nmos L=0.45u W=2u AS=0.38p AD=0.68p PS=2.38u
+ PD=4.68u rfmode=0
* device instance $543 r0 *1 65.15,135.755 sg13_hv_nmos
M$543 \$820 \$36 \$824 vss sg13_hv_nmos L=0.45u W=2u AS=0.68p AD=0.38p PS=4.68u
+ PD=2.38u rfmode=0
* device instance $544 r0 *1 65.15,136.585 sg13_hv_nmos
M$544 \$824 \$20 \$831 vss sg13_hv_nmos L=0.45u W=2u AS=0.38p AD=0.68p PS=2.38u
+ PD=4.68u rfmode=0
* device instance $545 r0 *1 87.33,135.755 sg13_hv_nmos
M$545 \$821 \$22 \$812 vss sg13_hv_nmos L=0.45u W=2u AS=0.68p AD=0.38p PS=4.68u
+ PD=2.38u rfmode=0
* device instance $546 r0 *1 87.33,136.585 sg13_hv_nmos
M$546 \$812 \$38 \$838 vss sg13_hv_nmos L=0.45u W=2u AS=0.38p AD=0.68p PS=2.38u
+ PD=4.68u rfmode=0
* device instance $547 r0 *1 48.45,137.515 sg13_hv_nmos
M$547 \$830 \$20 \$836 vss sg13_hv_nmos L=0.45u W=2u AS=0.68p AD=0.38p PS=4.68u
+ PD=2.38u rfmode=0
* device instance $548 r0 *1 48.45,138.345 sg13_hv_nmos
M$548 \$836 \$36 \$835 vss sg13_hv_nmos L=0.45u W=2u AS=0.38p AD=0.68p PS=2.38u
+ PD=4.68u rfmode=0
* device instance $549 r0 *1 81.85,137.515 sg13_hv_nmos
M$549 \$832 \$20 \$838 vss sg13_hv_nmos L=0.45u W=2u AS=0.68p AD=0.38p PS=4.68u
+ PD=2.38u rfmode=0
* device instance $550 r0 *1 81.85,138.345 sg13_hv_nmos
M$550 \$838 \$36 \$837 vss sg13_hv_nmos L=0.45u W=2u AS=0.38p AD=0.68p PS=2.38u
+ PD=4.68u rfmode=0
* device instance $551 r0 *1 33.705,3.5 sg13_lv_pmos
M$551 \$14 d3 vdd vdd sg13_lv_pmos L=0.13u W=1u AS=0.34p AD=0.34p PS=2.68u
+ PD=2.68u rfmode=0
* device instance $552 r0 *1 54.705,3.5 sg13_lv_pmos
M$552 \$17 d6 vdd vdd sg13_lv_pmos L=0.13u W=1u AS=0.34p AD=0.34p PS=2.68u
+ PD=2.68u rfmode=0
* device instance $553 r0 *1 40.705,3.5 sg13_lv_pmos
M$553 \$15 d4 vdd vdd sg13_lv_pmos L=0.13u W=1u AS=0.34p AD=0.34p PS=2.68u
+ PD=2.68u rfmode=0
* device instance $554 r0 *1 19.705,3.5 sg13_lv_pmos
M$554 \$12 d1 vdd vdd sg13_lv_pmos L=0.13u W=1u AS=0.34p AD=0.34p PS=2.68u
+ PD=2.68u rfmode=0
* device instance $555 r0 *1 61.705,3.5 sg13_lv_pmos
M$555 \$18 d7 vdd vdd sg13_lv_pmos L=0.13u W=1u AS=0.34p AD=0.34p PS=2.68u
+ PD=2.68u rfmode=0
* device instance $556 r0 *1 26.705,3.5 sg13_lv_pmos
M$556 \$13 d2 vdd vdd sg13_lv_pmos L=0.13u W=1u AS=0.34p AD=0.34p PS=2.68u
+ PD=2.68u rfmode=0
* device instance $557 r0 *1 47.705,3.5 sg13_lv_pmos
M$557 \$16 d5 vdd vdd sg13_lv_pmos L=0.13u W=1u AS=0.34p AD=0.34p PS=2.68u
+ PD=2.68u rfmode=0
* device instance $558 r0 *1 12.705,3.5 sg13_lv_pmos
M$558 \$11 d0 vdd vdd sg13_lv_pmos L=0.13u W=1u AS=0.34p AD=0.34p PS=2.68u
+ PD=2.68u rfmode=0
* device instance $559 r0 *1 10.565,10.75 sg13_hv_pmos
M$559 vdda \$35 \$19 vdda sg13_hv_pmos L=0.45u W=0.3u AS=0.102p AD=0.102p
+ PS=1.28u PD=1.28u rfmode=0
* device instance $560 r0 *1 12.065,10.75 sg13_hv_pmos
M$560 vdda \$19 \$35 vdda sg13_hv_pmos L=0.45u W=0.3u AS=0.102p AD=0.102p
+ PS=1.28u PD=1.28u rfmode=0
* device instance $561 r0 *1 13.565,12.55 sg13_hv_pmos
M$561 vdda \$19 \$20 vdda sg13_hv_pmos L=0.45u W=3.9u AS=1.326p AD=1.326p
+ PS=8.48u PD=8.48u rfmode=0
* device instance $562 r0 *1 15.065,12.55 sg13_hv_pmos
M$562 vdda \$20 \$36 vdda sg13_hv_pmos L=0.45u W=3.9u AS=1.326p AD=1.326p
+ PS=8.48u PD=8.48u rfmode=0
* device instance $563 r0 *1 17.565,10.75 sg13_hv_pmos
M$563 vdda \$37 \$21 vdda sg13_hv_pmos L=0.45u W=0.3u AS=0.102p AD=0.102p
+ PS=1.28u PD=1.28u rfmode=0
* device instance $564 r0 *1 19.065,10.75 sg13_hv_pmos
M$564 vdda \$21 \$37 vdda sg13_hv_pmos L=0.45u W=0.3u AS=0.102p AD=0.102p
+ PS=1.28u PD=1.28u rfmode=0
* device instance $565 r0 *1 20.565,12.55 sg13_hv_pmos
M$565 vdda \$21 \$22 vdda sg13_hv_pmos L=0.45u W=3.9u AS=1.326p AD=1.326p
+ PS=8.48u PD=8.48u rfmode=0
* device instance $566 r0 *1 22.065,12.55 sg13_hv_pmos
M$566 vdda \$22 \$38 vdda sg13_hv_pmos L=0.45u W=3.9u AS=1.326p AD=1.326p
+ PS=8.48u PD=8.48u rfmode=0
* device instance $567 r0 *1 24.565,10.75 sg13_hv_pmos
M$567 vdda \$39 \$23 vdda sg13_hv_pmos L=0.45u W=0.3u AS=0.102p AD=0.102p
+ PS=1.28u PD=1.28u rfmode=0
* device instance $568 r0 *1 26.065,10.75 sg13_hv_pmos
M$568 vdda \$23 \$39 vdda sg13_hv_pmos L=0.45u W=0.3u AS=0.102p AD=0.102p
+ PS=1.28u PD=1.28u rfmode=0
* device instance $569 r0 *1 27.565,12.55 sg13_hv_pmos
M$569 vdda \$23 \$24 vdda sg13_hv_pmos L=0.45u W=3.9u AS=1.326p AD=1.326p
+ PS=8.48u PD=8.48u rfmode=0
* device instance $570 r0 *1 29.065,12.55 sg13_hv_pmos
M$570 vdda \$24 \$40 vdda sg13_hv_pmos L=0.45u W=3.9u AS=1.326p AD=1.326p
+ PS=8.48u PD=8.48u rfmode=0
* device instance $571 r0 *1 31.565,10.75 sg13_hv_pmos
M$571 vdda \$41 \$25 vdda sg13_hv_pmos L=0.45u W=0.3u AS=0.102p AD=0.102p
+ PS=1.28u PD=1.28u rfmode=0
* device instance $572 r0 *1 33.065,10.75 sg13_hv_pmos
M$572 vdda \$25 \$41 vdda sg13_hv_pmos L=0.45u W=0.3u AS=0.102p AD=0.102p
+ PS=1.28u PD=1.28u rfmode=0
* device instance $573 r0 *1 34.565,12.55 sg13_hv_pmos
M$573 vdda \$25 \$26 vdda sg13_hv_pmos L=0.45u W=3.9u AS=1.326p AD=1.326p
+ PS=8.48u PD=8.48u rfmode=0
* device instance $574 r0 *1 36.065,12.55 sg13_hv_pmos
M$574 vdda \$26 \$42 vdda sg13_hv_pmos L=0.45u W=3.9u AS=1.326p AD=1.326p
+ PS=8.48u PD=8.48u rfmode=0
* device instance $575 r0 *1 38.565,10.75 sg13_hv_pmos
M$575 vdda \$43 \$27 vdda sg13_hv_pmos L=0.45u W=0.3u AS=0.102p AD=0.102p
+ PS=1.28u PD=1.28u rfmode=0
* device instance $576 r0 *1 40.065,10.75 sg13_hv_pmos
M$576 vdda \$27 \$43 vdda sg13_hv_pmos L=0.45u W=0.3u AS=0.102p AD=0.102p
+ PS=1.28u PD=1.28u rfmode=0
* device instance $577 r0 *1 41.565,12.55 sg13_hv_pmos
M$577 vdda \$27 \$28 vdda sg13_hv_pmos L=0.45u W=3.9u AS=1.326p AD=1.326p
+ PS=8.48u PD=8.48u rfmode=0
* device instance $578 r0 *1 43.065,12.55 sg13_hv_pmos
M$578 vdda \$28 \$44 vdda sg13_hv_pmos L=0.45u W=3.9u AS=1.326p AD=1.326p
+ PS=8.48u PD=8.48u rfmode=0
* device instance $579 r0 *1 45.565,10.75 sg13_hv_pmos
M$579 vdda \$45 \$29 vdda sg13_hv_pmos L=0.45u W=0.3u AS=0.102p AD=0.102p
+ PS=1.28u PD=1.28u rfmode=0
* device instance $580 r0 *1 47.065,10.75 sg13_hv_pmos
M$580 vdda \$29 \$45 vdda sg13_hv_pmos L=0.45u W=0.3u AS=0.102p AD=0.102p
+ PS=1.28u PD=1.28u rfmode=0
* device instance $581 r0 *1 48.565,12.55 sg13_hv_pmos
M$581 vdda \$29 \$30 vdda sg13_hv_pmos L=0.45u W=3.9u AS=1.326p AD=1.326p
+ PS=8.48u PD=8.48u rfmode=0
* device instance $582 r0 *1 50.065,12.55 sg13_hv_pmos
M$582 vdda \$30 \$46 vdda sg13_hv_pmos L=0.45u W=3.9u AS=1.326p AD=1.326p
+ PS=8.48u PD=8.48u rfmode=0
* device instance $583 r0 *1 52.565,10.75 sg13_hv_pmos
M$583 vdda \$47 \$31 vdda sg13_hv_pmos L=0.45u W=0.3u AS=0.102p AD=0.102p
+ PS=1.28u PD=1.28u rfmode=0
* device instance $584 r0 *1 54.065,10.75 sg13_hv_pmos
M$584 vdda \$31 \$47 vdda sg13_hv_pmos L=0.45u W=0.3u AS=0.102p AD=0.102p
+ PS=1.28u PD=1.28u rfmode=0
* device instance $585 r0 *1 55.565,12.55 sg13_hv_pmos
M$585 vdda \$31 \$32 vdda sg13_hv_pmos L=0.45u W=3.9u AS=1.326p AD=1.326p
+ PS=8.48u PD=8.48u rfmode=0
* device instance $586 r0 *1 57.065,12.55 sg13_hv_pmos
M$586 vdda \$32 \$48 vdda sg13_hv_pmos L=0.45u W=3.9u AS=1.326p AD=1.326p
+ PS=8.48u PD=8.48u rfmode=0
* device instance $587 r0 *1 59.565,10.75 sg13_hv_pmos
M$587 vdda \$49 \$33 vdda sg13_hv_pmos L=0.45u W=0.3u AS=0.102p AD=0.102p
+ PS=1.28u PD=1.28u rfmode=0
* device instance $588 r0 *1 61.065,10.75 sg13_hv_pmos
M$588 vdda \$33 \$49 vdda sg13_hv_pmos L=0.45u W=0.3u AS=0.102p AD=0.102p
+ PS=1.28u PD=1.28u rfmode=0
* device instance $589 r0 *1 62.565,12.55 sg13_hv_pmos
M$589 vdda \$33 \$34 vdda sg13_hv_pmos L=0.45u W=3.9u AS=1.326p AD=1.326p
+ PS=8.48u PD=8.48u rfmode=0
* device instance $590 r0 *1 64.065,12.55 sg13_hv_pmos
M$590 vdda \$34 \$50 vdda sg13_hv_pmos L=0.45u W=3.9u AS=1.326p AD=1.326p
+ PS=8.48u PD=8.48u rfmode=0
* device instance $594 r0 *1 24.795,26.495 rppd
R$594 \$54 \$63 vss rppd w=4u l=1.2u ps=0u b=0 m=1
* device instance $595 r0 *1 41.495,26.495 rppd
R$595 \$55 \$64 vss rppd w=4u l=1.2u ps=0u b=0 m=1
* device instance $596 r0 *1 58.195,26.495 rppd
R$596 \$55 \$65 vss rppd w=4u l=1.2u ps=0u b=0 m=1
* device instance $603 r0 *1 24.795,28.255 rppd
R$603 \$63 \$76 vss rppd w=4u l=1.2u ps=0u b=0 m=1
* device instance $604 r0 *1 41.495,28.255 rppd
R$604 \$64 \$77 vss rppd w=4u l=1.2u ps=0u b=0 m=1
* device instance $605 r0 *1 58.195,28.255 rppd
R$605 \$65 \$78 vss rppd w=4u l=1.2u ps=0u b=0 m=1
* device instance $606 r0 *1 74.895,28.255 rppd
R$606 \$66 \$79 vss rppd w=4u l=1.2u ps=0u b=0 m=1
* device instance $612 r0 *1 24.795,30.015 rppd
R$612 \$76 \$86 vss rppd w=4u l=1.2u ps=0u b=0 m=1
* device instance $613 r0 *1 41.495,30.015 rppd
R$613 \$77 \$87 vss rppd w=4u l=1.2u ps=0u b=0 m=1
* device instance $614 r0 *1 58.195,30.015 rppd
R$614 \$78 \$90 vss rppd w=4u l=1.2u ps=0u b=0 m=1
* device instance $615 r0 *1 74.895,30.015 rppd
R$615 \$79 \$91 vss rppd w=4u l=1.2u ps=0u b=0 m=1
* device instance $621 r0 *1 24.795,31.775 rppd
R$621 \$86 \$102 vss rppd w=4u l=1.2u ps=0u b=0 m=1
* device instance $622 r0 *1 41.495,31.775 rppd
R$622 \$87 \$104 vss rppd w=4u l=1.2u ps=0u b=0 m=1
* device instance $623 r0 *1 58.195,31.775 rppd
R$623 \$90 \$105 vss rppd w=4u l=1.2u ps=0u b=0 m=1
* device instance $624 r0 *1 74.895,31.775 rppd
R$624 \$91 \$107 vss rppd w=4u l=1.2u ps=0u b=0 m=1
* device instance $630 r0 *1 24.795,33.535 rppd
R$630 \$102 \$114 vss rppd w=4u l=1.2u ps=0u b=0 m=1
* device instance $631 r0 *1 41.495,33.535 rppd
R$631 \$104 \$115 vss rppd w=4u l=1.2u ps=0u b=0 m=1
* device instance $632 r0 *1 58.195,33.535 rppd
R$632 \$105 \$119 vss rppd w=4u l=1.2u ps=0u b=0 m=1
* device instance $633 r0 *1 74.895,33.535 rppd
R$633 \$107 \$120 vss rppd w=4u l=1.2u ps=0u b=0 m=1
* device instance $639 r0 *1 24.795,35.295 rppd
R$639 \$114 \$130 vss rppd w=4u l=1.2u ps=0u b=0 m=1
* device instance $640 r0 *1 41.495,35.295 rppd
R$640 \$115 \$131 vss rppd w=4u l=1.2u ps=0u b=0 m=1
* device instance $641 r0 *1 58.195,35.295 rppd
R$641 \$119 \$132 vss rppd w=4u l=1.2u ps=0u b=0 m=1
* device instance $642 r0 *1 74.895,35.295 rppd
R$642 \$120 \$133 vss rppd w=4u l=1.2u ps=0u b=0 m=1
* device instance $648 r0 *1 24.795,37.055 rppd
R$648 \$130 \$140 vss rppd w=4u l=1.2u ps=0u b=0 m=1
* device instance $649 r0 *1 41.495,37.055 rppd
R$649 \$131 \$141 vss rppd w=4u l=1.2u ps=0u b=0 m=1
* device instance $650 r0 *1 58.195,37.055 rppd
R$650 \$132 \$143 vss rppd w=4u l=1.2u ps=0u b=0 m=1
* device instance $651 r0 *1 74.895,37.055 rppd
R$651 \$133 \$144 vss rppd w=4u l=1.2u ps=0u b=0 m=1
* device instance $657 r0 *1 24.795,38.815 rppd
R$657 \$140 \$154 vss rppd w=4u l=1.2u ps=0u b=0 m=1
* device instance $658 r0 *1 41.495,38.815 rppd
R$658 \$141 \$156 vss rppd w=4u l=1.2u ps=0u b=0 m=1
* device instance $659 r0 *1 58.195,38.815 rppd
R$659 \$143 \$157 vss rppd w=4u l=1.2u ps=0u b=0 m=1
* device instance $660 r0 *1 74.895,38.815 rppd
R$660 \$144 \$159 vss rppd w=4u l=1.2u ps=0u b=0 m=1
* device instance $666 r0 *1 24.795,40.575 rppd
R$666 \$154 \$166 vss rppd w=4u l=1.2u ps=0u b=0 m=1
* device instance $667 r0 *1 41.495,40.575 rppd
R$667 \$156 \$167 vss rppd w=4u l=1.2u ps=0u b=0 m=1
* device instance $668 r0 *1 58.195,40.575 rppd
R$668 \$157 \$171 vss rppd w=4u l=1.2u ps=0u b=0 m=1
* device instance $669 r0 *1 74.895,40.575 rppd
R$669 \$159 \$172 vss rppd w=4u l=1.2u ps=0u b=0 m=1
* device instance $675 r0 *1 24.795,42.335 rppd
R$675 \$166 \$184 vss rppd w=4u l=1.2u ps=0u b=0 m=1
* device instance $676 r0 *1 41.495,42.335 rppd
R$676 \$167 \$185 vss rppd w=4u l=1.2u ps=0u b=0 m=1
* device instance $677 r0 *1 58.195,42.335 rppd
R$677 \$171 \$186 vss rppd w=4u l=1.2u ps=0u b=0 m=1
* device instance $678 r0 *1 74.895,42.335 rppd
R$678 \$172 \$187 vss rppd w=4u l=1.2u ps=0u b=0 m=1
* device instance $684 r0 *1 24.795,44.095 rppd
R$684 \$184 \$194 vss rppd w=4u l=1.2u ps=0u b=0 m=1
* device instance $685 r0 *1 41.495,44.095 rppd
R$685 \$185 \$195 vss rppd w=4u l=1.2u ps=0u b=0 m=1
* device instance $686 r0 *1 58.195,44.095 rppd
R$686 \$186 \$198 vss rppd w=4u l=1.2u ps=0u b=0 m=1
* device instance $687 r0 *1 74.895,44.095 rppd
R$687 \$187 \$199 vss rppd w=4u l=1.2u ps=0u b=0 m=1
* device instance $693 r0 *1 24.795,45.855 rppd
R$693 \$194 \$208 vss rppd w=4u l=1.2u ps=0u b=0 m=1
* device instance $694 r0 *1 41.495,45.855 rppd
R$694 \$195 \$210 vss rppd w=4u l=1.2u ps=0u b=0 m=1
* device instance $695 r0 *1 58.195,45.855 rppd
R$695 \$198 \$211 vss rppd w=4u l=1.2u ps=0u b=0 m=1
* device instance $696 r0 *1 74.895,45.855 rppd
R$696 \$199 \$213 vss rppd w=4u l=1.2u ps=0u b=0 m=1
* device instance $702 r0 *1 24.795,47.615 rppd
R$702 \$208 \$220 vss rppd w=4u l=1.2u ps=0u b=0 m=1
* device instance $703 r0 *1 41.495,47.615 rppd
R$703 \$210 \$221 vss rppd w=4u l=1.2u ps=0u b=0 m=1
* device instance $704 r0 *1 58.195,47.615 rppd
R$704 \$211 \$224 vss rppd w=4u l=1.2u ps=0u b=0 m=1
* device instance $705 r0 *1 74.895,47.615 rppd
R$705 \$213 \$225 vss rppd w=4u l=1.2u ps=0u b=0 m=1
* device instance $711 r0 *1 24.795,49.375 rppd
R$711 \$220 \$234 vss rppd w=4u l=1.2u ps=0u b=0 m=1
* device instance $712 r0 *1 41.495,49.375 rppd
R$712 \$221 \$235 vss rppd w=4u l=1.2u ps=0u b=0 m=1
* device instance $713 r0 *1 58.195,49.375 rppd
R$713 \$224 \$236 vss rppd w=4u l=1.2u ps=0u b=0 m=1
* device instance $714 r0 *1 74.895,49.375 rppd
R$714 \$225 \$237 vss rppd w=4u l=1.2u ps=0u b=0 m=1
* device instance $720 r0 *1 24.795,51.135 rppd
R$720 \$234 \$244 vss rppd w=4u l=1.2u ps=0u b=0 m=1
* device instance $721 r0 *1 41.495,51.135 rppd
R$721 \$235 \$245 vss rppd w=4u l=1.2u ps=0u b=0 m=1
* device instance $722 r0 *1 58.195,51.135 rppd
R$722 \$236 \$247 vss rppd w=4u l=1.2u ps=0u b=0 m=1
* device instance $723 r0 *1 74.895,51.135 rppd
R$723 \$237 \$248 vss rppd w=4u l=1.2u ps=0u b=0 m=1
* device instance $729 r0 *1 24.795,52.895 rppd
R$729 \$244 \$258 vss rppd w=4u l=1.2u ps=0u b=0 m=1
* device instance $730 r0 *1 41.495,52.895 rppd
R$730 \$245 \$259 vss rppd w=4u l=1.2u ps=0u b=0 m=1
* device instance $731 r0 *1 58.195,52.895 rppd
R$731 \$247 \$260 vss rppd w=4u l=1.2u ps=0u b=0 m=1
* device instance $732 r0 *1 74.895,52.895 rppd
R$732 \$248 \$261 vss rppd w=4u l=1.2u ps=0u b=0 m=1
* device instance $738 r0 *1 24.795,54.655 rppd
R$738 \$258 \$268 vss rppd w=4u l=1.2u ps=0u b=0 m=1
* device instance $739 r0 *1 41.495,54.655 rppd
R$739 \$259 \$269 vss rppd w=4u l=1.2u ps=0u b=0 m=1
* device instance $740 r0 *1 58.195,54.655 rppd
R$740 \$260 \$272 vss rppd w=4u l=1.2u ps=0u b=0 m=1
* device instance $741 r0 *1 74.895,54.655 rppd
R$741 \$261 \$273 vss rppd w=4u l=1.2u ps=0u b=0 m=1
* device instance $747 r0 *1 24.795,56.415 rppd
R$747 \$268 \$284 vss rppd w=4u l=1.2u ps=0u b=0 m=1
* device instance $748 r0 *1 41.495,56.415 rppd
R$748 \$269 \$285 vss rppd w=4u l=1.2u ps=0u b=0 m=1
* device instance $749 r0 *1 58.195,56.415 rppd
R$749 \$272 \$286 vss rppd w=4u l=1.2u ps=0u b=0 m=1
* device instance $750 r0 *1 74.895,56.415 rppd
R$750 \$273 \$287 vss rppd w=4u l=1.2u ps=0u b=0 m=1
* device instance $751 r0 *1 91.595,56.415 rppd
R$751 \$66 vref vss rppd w=4u l=24u ps=0u b=0 m=1
* device instance $756 r0 *1 24.795,58.175 rppd
R$756 \$284 \$293 vss rppd w=4u l=1.2u ps=0u b=0 m=1
* device instance $757 r0 *1 41.495,58.175 rppd
R$757 \$285 \$294 vss rppd w=4u l=1.2u ps=0u b=0 m=1
* device instance $758 r0 *1 58.195,58.175 rppd
R$758 \$286 \$297 vss rppd w=4u l=1.2u ps=0u b=0 m=1
* device instance $759 r0 *1 74.895,58.175 rppd
R$759 \$287 \$298 vss rppd w=4u l=1.2u ps=0u b=0 m=1
* device instance $765 r0 *1 24.795,59.935 rppd
R$765 \$293 \$310 vss rppd w=4u l=1.2u ps=0u b=0 m=1
* device instance $766 r0 *1 41.495,59.935 rppd
R$766 \$294 \$312 vss rppd w=4u l=1.2u ps=0u b=0 m=1
* device instance $767 r0 *1 58.195,59.935 rppd
R$767 \$297 \$313 vss rppd w=4u l=1.2u ps=0u b=0 m=1
* device instance $768 r0 *1 74.895,59.935 rppd
R$768 \$298 \$315 vss rppd w=4u l=1.2u ps=0u b=0 m=1
* device instance $773 r0 *1 24.795,61.695 rppd
R$773 \$310 \$321 vss rppd w=4u l=1.2u ps=0u b=0 m=1
* device instance $774 r0 *1 41.495,61.695 rppd
R$774 \$312 \$322 vss rppd w=4u l=1.2u ps=0u b=0 m=1
* device instance $775 r0 *1 58.195,61.695 rppd
R$775 \$313 \$326 vss rppd w=4u l=1.2u ps=0u b=0 m=1
* device instance $776 r0 *1 74.895,61.695 rppd
R$776 \$315 \$327 vss rppd w=4u l=1.2u ps=0u b=0 m=1
* device instance $781 r0 *1 24.795,63.455 rppd
R$781 \$321 \$336 vss rppd w=4u l=1.2u ps=0u b=0 m=1
* device instance $782 r0 *1 41.495,63.455 rppd
R$782 \$322 \$337 vss rppd w=4u l=1.2u ps=0u b=0 m=1
* device instance $783 r0 *1 58.195,63.455 rppd
R$783 \$326 \$338 vss rppd w=4u l=1.2u ps=0u b=0 m=1
* device instance $784 r0 *1 74.895,63.455 rppd
R$784 \$327 \$339 vss rppd w=4u l=1.2u ps=0u b=0 m=1
* device instance $789 r0 *1 24.795,65.215 rppd
R$789 \$336 \$344 vss rppd w=4u l=1.2u ps=0u b=0 m=1
* device instance $790 r0 *1 41.495,65.215 rppd
R$790 \$337 \$346 vss rppd w=4u l=1.2u ps=0u b=0 m=1
* device instance $791 r0 *1 58.195,65.215 rppd
R$791 \$338 \$348 vss rppd w=4u l=1.2u ps=0u b=0 m=1
* device instance $792 r0 *1 74.895,65.215 rppd
R$792 \$339 \$349 vss rppd w=4u l=1.2u ps=0u b=0 m=1
* device instance $797 r0 *1 24.795,66.975 rppd
R$797 \$344 \$358 vss rppd w=4u l=1.2u ps=0u b=0 m=1
* device instance $798 r0 *1 41.495,66.975 rppd
R$798 \$346 \$360 vss rppd w=4u l=1.2u ps=0u b=0 m=1
* device instance $799 r0 *1 58.195,66.975 rppd
R$799 \$348 \$361 vss rppd w=4u l=1.2u ps=0u b=0 m=1
* device instance $800 r0 *1 74.895,66.975 rppd
R$800 \$349 \$363 vss rppd w=4u l=1.2u ps=0u b=0 m=1
* device instance $805 r0 *1 24.795,68.735 rppd
R$805 \$358 \$369 vss rppd w=4u l=1.2u ps=0u b=0 m=1
* device instance $806 r0 *1 41.495,68.735 rppd
R$806 \$360 \$370 vss rppd w=4u l=1.2u ps=0u b=0 m=1
* device instance $807 r0 *1 58.195,68.735 rppd
R$807 \$361 \$374 vss rppd w=4u l=1.2u ps=0u b=0 m=1
* device instance $808 r0 *1 74.895,68.735 rppd
R$808 \$363 \$375 vss rppd w=4u l=1.2u ps=0u b=0 m=1
* device instance $813 r0 *1 24.795,70.495 rppd
R$813 \$369 \$386 vss rppd w=4u l=1.2u ps=0u b=0 m=1
* device instance $814 r0 *1 41.495,70.495 rppd
R$814 \$370 \$387 vss rppd w=4u l=1.2u ps=0u b=0 m=1
* device instance $815 r0 *1 58.195,70.495 rppd
R$815 \$374 \$388 vss rppd w=4u l=1.2u ps=0u b=0 m=1
* device instance $816 r0 *1 74.895,70.495 rppd
R$816 \$375 \$389 vss rppd w=4u l=1.2u ps=0u b=0 m=1
* device instance $821 r0 *1 24.795,72.255 rppd
R$821 \$386 \$395 vss rppd w=4u l=1.2u ps=0u b=0 m=1
* device instance $822 r0 *1 41.495,72.255 rppd
R$822 \$387 \$396 vss rppd w=4u l=1.2u ps=0u b=0 m=1
* device instance $823 r0 *1 58.195,72.255 rppd
R$823 \$388 \$399 vss rppd w=4u l=1.2u ps=0u b=0 m=1
* device instance $824 r0 *1 74.895,72.255 rppd
R$824 \$389 \$400 vss rppd w=4u l=1.2u ps=0u b=0 m=1
* device instance $829 r0 *1 24.795,74.015 rppd
R$829 \$395 \$408 vss rppd w=4u l=1.2u ps=0u b=0 m=1
* device instance $830 r0 *1 41.495,74.015 rppd
R$830 \$396 \$410 vss rppd w=4u l=1.2u ps=0u b=0 m=1
* device instance $831 r0 *1 58.195,74.015 rppd
R$831 \$399 \$411 vss rppd w=4u l=1.2u ps=0u b=0 m=1
* device instance $832 r0 *1 74.895,74.015 rppd
R$832 \$400 \$413 vss rppd w=4u l=1.2u ps=0u b=0 m=1
* device instance $837 r0 *1 24.795,75.775 rppd
R$837 \$408 \$418 vss rppd w=4u l=1.2u ps=0u b=0 m=1
* device instance $838 r0 *1 41.495,75.775 rppd
R$838 \$410 \$420 vss rppd w=4u l=1.2u ps=0u b=0 m=1
* device instance $839 r0 *1 58.195,75.775 rppd
R$839 \$411 \$423 vss rppd w=4u l=1.2u ps=0u b=0 m=1
* device instance $840 r0 *1 74.895,75.775 rppd
R$840 \$413 \$424 vss rppd w=4u l=1.2u ps=0u b=0 m=1
* device instance $845 r0 *1 24.795,77.535 rppd
R$845 \$418 \$432 vss rppd w=4u l=1.2u ps=0u b=0 m=1
* device instance $846 r0 *1 41.495,77.535 rppd
R$846 \$420 \$433 vss rppd w=4u l=1.2u ps=0u b=0 m=1
* device instance $847 r0 *1 58.195,77.535 rppd
R$847 \$423 \$434 vss rppd w=4u l=1.2u ps=0u b=0 m=1
* device instance $848 r0 *1 74.895,77.535 rppd
R$848 \$424 \$435 vss rppd w=4u l=1.2u ps=0u b=0 m=1
* device instance $853 r0 *1 24.795,79.295 rppd
R$853 \$432 \$440 vss rppd w=4u l=1.2u ps=0u b=0 m=1
* device instance $854 r0 *1 41.495,79.295 rppd
R$854 \$433 \$441 vss rppd w=4u l=1.2u ps=0u b=0 m=1
* device instance $855 r0 *1 58.195,79.295 rppd
R$855 \$434 \$443 vss rppd w=4u l=1.2u ps=0u b=0 m=1
* device instance $856 r0 *1 74.895,79.295 rppd
R$856 \$435 \$444 vss rppd w=4u l=1.2u ps=0u b=0 m=1
* device instance $861 r0 *1 24.795,81.055 rppd
R$861 \$440 \$454 vss rppd w=4u l=1.2u ps=0u b=0 m=1
* device instance $862 r0 *1 41.495,81.055 rppd
R$862 \$441 \$455 vss rppd w=4u l=1.2u ps=0u b=0 m=1
* device instance $863 r0 *1 58.195,81.055 rppd
R$863 \$443 \$456 vss rppd w=4u l=1.2u ps=0u b=0 m=1
* device instance $864 r0 *1 74.895,81.055 rppd
R$864 \$444 \$457 vss rppd w=4u l=1.2u ps=0u b=0 m=1
* device instance $869 r0 *1 24.795,82.815 rppd
R$869 \$454 \$463 vss rppd w=4u l=1.2u ps=0u b=0 m=1
* device instance $870 r0 *1 41.495,82.815 rppd
R$870 \$455 \$464 vss rppd w=4u l=1.2u ps=0u b=0 m=1
* device instance $871 r0 *1 58.195,82.815 rppd
R$871 \$456 \$467 vss rppd w=4u l=1.2u ps=0u b=0 m=1
* device instance $872 r0 *1 74.895,82.815 rppd
R$872 \$457 \$468 vss rppd w=4u l=1.2u ps=0u b=0 m=1
* device instance $877 r0 *1 24.795,84.575 rppd
R$877 \$463 \$478 vss rppd w=4u l=1.2u ps=0u b=0 m=1
* device instance $878 r0 *1 41.495,84.575 rppd
R$878 \$464 \$479 vss rppd w=4u l=1.2u ps=0u b=0 m=1
* device instance $879 r0 *1 58.195,84.575 rppd
R$879 \$467 \$480 vss rppd w=4u l=1.2u ps=0u b=0 m=1
* device instance $880 r0 *1 74.895,84.575 rppd
R$880 \$468 \$481 vss rppd w=4u l=1.2u ps=0u b=0 m=1
* device instance $885 r0 *1 24.795,86.335 rppd
R$885 \$478 \$487 vss rppd w=4u l=1.2u ps=0u b=0 m=1
* device instance $886 r0 *1 41.495,86.335 rppd
R$886 \$479 \$488 vss rppd w=4u l=1.2u ps=0u b=0 m=1
* device instance $887 r0 *1 58.195,86.335 rppd
R$887 \$480 \$491 vss rppd w=4u l=1.2u ps=0u b=0 m=1
* device instance $888 r0 *1 74.895,86.335 rppd
R$888 \$481 \$492 vss rppd w=4u l=1.2u ps=0u b=0 m=1
* device instance $893 r0 *1 24.795,88.095 rppd
R$893 \$487 \$503 vss rppd w=4u l=1.2u ps=0u b=0 m=1
* device instance $894 r0 *1 41.495,88.095 rppd
R$894 \$488 \$505 vss rppd w=4u l=1.2u ps=0u b=0 m=1
* device instance $895 r0 *1 58.195,88.095 rppd
R$895 \$491 \$506 vss rppd w=4u l=1.2u ps=0u b=0 m=1
* device instance $896 r0 *1 74.895,88.095 rppd
R$896 \$492 \$508 vss rppd w=4u l=1.2u ps=0u b=0 m=1
* device instance $901 r0 *1 24.795,89.855 rppd
R$901 \$503 \$512 vss rppd w=4u l=1.2u ps=0u b=0 m=1
* device instance $902 r0 *1 41.495,89.855 rppd
R$902 \$505 \$523 vss rppd w=4u l=1.2u ps=0u b=0 m=1
* device instance $903 r0 *1 58.195,89.855 rppd
R$903 \$506 \$516 vss rppd w=4u l=1.2u ps=0u b=0 m=1
* device instance $904 r0 *1 74.895,89.855 rppd
R$904 \$508 \$517 vss rppd w=4u l=1.2u ps=0u b=0 m=1
* device instance $909 r0 *1 24.795,91.615 rppd
R$909 \$512 \$531 vss rppd w=4u l=1.2u ps=0u b=0 m=1
* device instance $910 r0 *1 41.495,91.615 rppd
R$910 \$523 \$532 vss rppd w=4u l=1.2u ps=0u b=0 m=1
* device instance $911 r0 *1 58.195,91.615 rppd
R$911 \$516 \$535 vss rppd w=4u l=1.2u ps=0u b=0 m=1
* device instance $912 r0 *1 74.895,91.615 rppd
R$912 \$517 \$533 vss rppd w=4u l=1.2u ps=0u b=0 m=1
* device instance $917 r0 *1 24.795,93.375 rppd
R$917 \$531 \$541 vss rppd w=4u l=1.2u ps=0u b=0 m=1
* device instance $918 r0 *1 41.495,93.375 rppd
R$918 \$532 \$542 vss rppd w=4u l=1.2u ps=0u b=0 m=1
* device instance $919 r0 *1 58.195,93.375 rppd
R$919 \$535 \$543 vss rppd w=4u l=1.2u ps=0u b=0 m=1
* device instance $920 r0 *1 74.895,93.375 rppd
R$920 \$533 \$544 vss rppd w=4u l=1.2u ps=0u b=0 m=1
* device instance $925 r0 *1 24.795,95.135 rppd
R$925 \$541 \$552 vss rppd w=4u l=1.2u ps=0u b=0 m=1
* device instance $926 r0 *1 41.495,95.135 rppd
R$926 \$542 \$554 vss rppd w=4u l=1.2u ps=0u b=0 m=1
* device instance $927 r0 *1 58.195,95.135 rppd
R$927 \$543 \$555 vss rppd w=4u l=1.2u ps=0u b=0 m=1
* device instance $928 r0 *1 74.895,95.135 rppd
R$928 \$544 \$557 vss rppd w=4u l=1.2u ps=0u b=0 m=1
* device instance $933 r0 *1 24.795,96.895 rppd
R$933 \$552 \$567 vss rppd w=4u l=1.2u ps=0u b=0 m=1
* device instance $934 r0 *1 41.495,96.895 rppd
R$934 \$554 \$568 vss rppd w=4u l=1.2u ps=0u b=0 m=1
* device instance $935 r0 *1 58.195,96.895 rppd
R$935 \$555 \$570 vss rppd w=4u l=1.2u ps=0u b=0 m=1
* device instance $936 r0 *1 74.895,96.895 rppd
R$936 \$557 \$571 vss rppd w=4u l=1.2u ps=0u b=0 m=1
* device instance $941 r0 *1 24.795,98.655 rppd
R$941 \$567 \$577 vss rppd w=4u l=1.2u ps=0u b=0 m=1
* device instance $942 r0 *1 41.495,98.655 rppd
R$942 \$568 \$580 vss rppd w=4u l=1.2u ps=0u b=0 m=1
* device instance $943 r0 *1 58.195,98.655 rppd
R$943 \$570 \$581 vss rppd w=4u l=1.2u ps=0u b=0 m=1
* device instance $944 r0 *1 74.895,98.655 rppd
R$944 \$571 \$584 vss rppd w=4u l=1.2u ps=0u b=0 m=1
* device instance $949 r0 *1 24.795,100.415 rppd
R$949 \$577 \$593 vss rppd w=4u l=1.2u ps=0u b=0 m=1
* device instance $950 r0 *1 41.495,100.415 rppd
R$950 \$580 \$594 vss rppd w=4u l=1.2u ps=0u b=0 m=1
* device instance $951 r0 *1 58.195,100.415 rppd
R$951 \$581 \$595 vss rppd w=4u l=1.2u ps=0u b=0 m=1
* device instance $952 r0 *1 74.895,100.415 rppd
R$952 \$584 \$596 vss rppd w=4u l=1.2u ps=0u b=0 m=1
* device instance $957 r0 *1 24.795,102.175 rppd
R$957 \$593 \$601 vss rppd w=4u l=1.2u ps=0u b=0 m=1
* device instance $958 r0 *1 41.495,102.175 rppd
R$958 \$594 \$603 vss rppd w=4u l=1.2u ps=0u b=0 m=1
* device instance $959 r0 *1 58.195,102.175 rppd
R$959 \$595 \$605 vss rppd w=4u l=1.2u ps=0u b=0 m=1
* device instance $960 r0 *1 74.895,102.175 rppd
R$960 \$596 \$608 vss rppd w=4u l=1.2u ps=0u b=0 m=1
* device instance $965 r0 *1 24.795,103.935 rppd
R$965 \$601 \$615 vss rppd w=4u l=1.2u ps=0u b=0 m=1
* device instance $966 r0 *1 41.495,103.935 rppd
R$966 \$603 \$616 vss rppd w=4u l=1.2u ps=0u b=0 m=1
* device instance $967 r0 *1 58.195,103.935 rppd
R$967 \$605 \$618 vss rppd w=4u l=1.2u ps=0u b=0 m=1
* device instance $968 r0 *1 74.895,103.935 rppd
R$968 \$608 \$619 vss rppd w=4u l=1.2u ps=0u b=0 m=1
* device instance $973 r0 *1 24.795,105.695 rppd
R$973 \$615 \$625 vss rppd w=4u l=1.2u ps=0u b=0 m=1
* device instance $974 r0 *1 41.495,105.695 rppd
R$974 \$616 \$627 vss rppd w=4u l=1.2u ps=0u b=0 m=1
* device instance $975 r0 *1 58.195,105.695 rppd
R$975 \$618 \$628 vss rppd w=4u l=1.2u ps=0u b=0 m=1
* device instance $976 r0 *1 74.895,105.695 rppd
R$976 \$619 \$630 vss rppd w=4u l=1.2u ps=0u b=0 m=1
* device instance $981 r0 *1 24.795,107.455 rppd
R$981 \$625 \$637 vss rppd w=4u l=1.2u ps=0u b=0 m=1
* device instance $982 r0 *1 41.495,107.455 rppd
R$982 \$627 \$638 vss rppd w=4u l=1.2u ps=0u b=0 m=1
* device instance $983 r0 *1 58.195,107.455 rppd
R$983 \$628 \$639 vss rppd w=4u l=1.2u ps=0u b=0 m=1
* device instance $984 r0 *1 74.895,107.455 rppd
R$984 \$630 \$640 vss rppd w=4u l=1.2u ps=0u b=0 m=1
* device instance $989 r0 *1 24.795,109.215 rppd
R$989 \$637 \$645 vss rppd w=4u l=1.2u ps=0u b=0 m=1
* device instance $990 r0 *1 41.495,109.215 rppd
R$990 \$638 \$648 vss rppd w=4u l=1.2u ps=0u b=0 m=1
* device instance $991 r0 *1 58.195,109.215 rppd
R$991 \$639 \$649 vss rppd w=4u l=1.2u ps=0u b=0 m=1
* device instance $992 r0 *1 74.895,109.215 rppd
R$992 \$640 \$652 vss rppd w=4u l=1.2u ps=0u b=0 m=1
* device instance $997 r0 *1 24.795,110.975 rppd
R$997 \$645 \$661 vss rppd w=4u l=1.2u ps=0u b=0 m=1
* device instance $998 r0 *1 41.495,110.975 rppd
R$998 \$648 \$662 vss rppd w=4u l=1.2u ps=0u b=0 m=1
* device instance $999 r0 *1 58.195,110.975 rppd
R$999 \$649 \$663 vss rppd w=4u l=1.2u ps=0u b=0 m=1
* device instance $1000 r0 *1 74.895,110.975 rppd
R$1000 \$652 \$664 vss rppd w=4u l=1.2u ps=0u b=0 m=1
* device instance $1005 r0 *1 24.795,112.735 rppd
R$1005 \$661 \$669 vss rppd w=4u l=1.2u ps=0u b=0 m=1
* device instance $1006 r0 *1 41.495,112.735 rppd
R$1006 \$662 \$671 vss rppd w=4u l=1.2u ps=0u b=0 m=1
* device instance $1007 r0 *1 58.195,112.735 rppd
R$1007 \$663 \$673 vss rppd w=4u l=1.2u ps=0u b=0 m=1
* device instance $1008 r0 *1 74.895,112.735 rppd
R$1008 \$664 \$676 vss rppd w=4u l=1.2u ps=0u b=0 m=1
* device instance $1013 r0 *1 24.795,114.495 rppd
R$1013 \$669 \$685 vss rppd w=4u l=1.2u ps=0u b=0 m=1
* device instance $1014 r0 *1 41.495,114.495 rppd
R$1014 \$671 \$686 vss rppd w=4u l=1.2u ps=0u b=0 m=1
* device instance $1015 r0 *1 58.195,114.495 rppd
R$1015 \$673 \$687 vss rppd w=4u l=1.2u ps=0u b=0 m=1
* device instance $1016 r0 *1 74.895,114.495 rppd
R$1016 \$676 \$688 vss rppd w=4u l=1.2u ps=0u b=0 m=1
* device instance $1021 r0 *1 24.795,116.255 rppd
R$1021 \$685 \$693 vss rppd w=4u l=1.2u ps=0u b=0 m=1
* device instance $1022 r0 *1 41.495,116.255 rppd
R$1022 \$686 \$697 vss rppd w=4u l=1.2u ps=0u b=0 m=1
* device instance $1023 r0 *1 58.195,116.255 rppd
R$1023 \$687 \$698 vss rppd w=4u l=1.2u ps=0u b=0 m=1
* device instance $1024 r0 *1 74.895,116.255 rppd
R$1024 \$688 \$702 vss rppd w=4u l=1.2u ps=0u b=0 m=1
* device instance $1029 r0 *1 24.795,118.015 rppd
R$1029 \$693 \$711 vss rppd w=4u l=1.2u ps=0u b=0 m=1
* device instance $1030 r0 *1 41.495,118.015 rppd
R$1030 \$697 \$712 vss rppd w=4u l=1.2u ps=0u b=0 m=1
* device instance $1031 r0 *1 58.195,118.015 rppd
R$1031 \$698 \$714 vss rppd w=4u l=1.2u ps=0u b=0 m=1
* device instance $1032 r0 *1 74.895,118.015 rppd
R$1032 \$702 \$715 vss rppd w=4u l=1.2u ps=0u b=0 m=1
* device instance $1037 r0 *1 24.795,119.775 rppd
R$1037 \$711 \$721 vss rppd w=4u l=1.2u ps=0u b=0 m=1
* device instance $1038 r0 *1 41.495,119.775 rppd
R$1038 \$712 \$722 vss rppd w=4u l=1.2u ps=0u b=0 m=1
* device instance $1039 r0 *1 58.195,119.775 rppd
R$1039 \$714 \$724 vss rppd w=4u l=1.2u ps=0u b=0 m=1
* device instance $1040 r0 *1 74.895,119.775 rppd
R$1040 \$715 \$726 vss rppd w=4u l=1.2u ps=0u b=0 m=1
* device instance $1045 r0 *1 24.795,121.535 rppd
R$1045 \$721 \$733 vss rppd w=4u l=1.2u ps=0u b=0 m=1
* device instance $1046 r0 *1 41.495,121.535 rppd
R$1046 \$722 \$734 vss rppd w=4u l=1.2u ps=0u b=0 m=1
* device instance $1047 r0 *1 58.195,121.535 rppd
R$1047 \$724 \$735 vss rppd w=4u l=1.2u ps=0u b=0 m=1
* device instance $1048 r0 *1 74.895,121.535 rppd
R$1048 \$726 \$736 vss rppd w=4u l=1.2u ps=0u b=0 m=1
* device instance $1053 r0 *1 24.795,123.295 rppd
R$1053 \$733 \$741 vss rppd w=4u l=1.2u ps=0u b=0 m=1
* device instance $1054 r0 *1 41.495,123.295 rppd
R$1054 \$734 \$745 vss rppd w=4u l=1.2u ps=0u b=0 m=1
* device instance $1055 r0 *1 58.195,123.295 rppd
R$1055 \$735 \$746 vss rppd w=4u l=1.2u ps=0u b=0 m=1
* device instance $1056 r0 *1 74.895,123.295 rppd
R$1056 \$736 \$750 vss rppd w=4u l=1.2u ps=0u b=0 m=1
* device instance $1061 r0 *1 24.795,125.055 rppd
R$1061 \$741 \$759 vss rppd w=4u l=1.2u ps=0u b=0 m=1
* device instance $1062 r0 *1 41.495,125.055 rppd
R$1062 \$745 \$760 vss rppd w=4u l=1.2u ps=0u b=0 m=1
* device instance $1063 r0 *1 58.195,125.055 rppd
R$1063 \$746 \$762 vss rppd w=4u l=1.2u ps=0u b=0 m=1
* device instance $1064 r0 *1 74.895,125.055 rppd
R$1064 \$750 \$763 vss rppd w=4u l=1.2u ps=0u b=0 m=1
* device instance $1069 r0 *1 24.795,126.815 rppd
R$1069 \$759 \$769 vss rppd w=4u l=1.2u ps=0u b=0 m=1
* device instance $1070 r0 *1 41.495,126.815 rppd
R$1070 \$760 \$771 vss rppd w=4u l=1.2u ps=0u b=0 m=1
* device instance $1071 r0 *1 58.195,126.815 rppd
R$1071 \$762 \$773 vss rppd w=4u l=1.2u ps=0u b=0 m=1
* device instance $1072 r0 *1 74.895,126.815 rppd
R$1072 \$763 \$776 vss rppd w=4u l=1.2u ps=0u b=0 m=1
* device instance $1077 r0 *1 24.795,128.575 rppd
R$1077 \$769 \$785 vss rppd w=4u l=1.2u ps=0u b=0 m=1
* device instance $1078 r0 *1 41.495,128.575 rppd
R$1078 \$771 \$786 vss rppd w=4u l=1.2u ps=0u b=0 m=1
* device instance $1079 r0 *1 58.195,128.575 rppd
R$1079 \$773 \$787 vss rppd w=4u l=1.2u ps=0u b=0 m=1
* device instance $1080 r0 *1 74.895,128.575 rppd
R$1080 \$776 \$788 vss rppd w=4u l=1.2u ps=0u b=0 m=1
* device instance $1085 r0 *1 24.795,130.335 rppd
R$1085 \$785 \$793 vss rppd w=4u l=1.2u ps=0u b=0 m=1
* device instance $1086 r0 *1 41.495,130.335 rppd
R$1086 \$786 \$796 vss rppd w=4u l=1.2u ps=0u b=0 m=1
* device instance $1087 r0 *1 58.195,130.335 rppd
R$1087 \$787 \$797 vss rppd w=4u l=1.2u ps=0u b=0 m=1
* device instance $1088 r0 *1 74.895,130.335 rppd
R$1088 \$788 \$800 vss rppd w=4u l=1.2u ps=0u b=0 m=1
* device instance $1093 r0 *1 24.795,132.095 rppd
R$1093 \$793 \$807 vss rppd w=4u l=1.2u ps=0u b=0 m=1
* device instance $1094 r0 *1 41.495,132.095 rppd
R$1094 \$796 \$808 vss rppd w=4u l=1.2u ps=0u b=0 m=1
* device instance $1095 r0 *1 58.195,132.095 rppd
R$1095 \$797 \$810 vss rppd w=4u l=1.2u ps=0u b=0 m=1
* device instance $1096 r0 *1 74.895,132.095 rppd
R$1096 \$800 \$811 vss rppd w=4u l=1.2u ps=0u b=0 m=1
* device instance $1101 r0 *1 24.795,133.855 rppd
R$1101 \$807 \$817 vss rppd w=4u l=1.2u ps=0u b=0 m=1
* device instance $1102 r0 *1 41.495,133.855 rppd
R$1102 \$808 \$819 vss rppd w=4u l=1.2u ps=0u b=0 m=1
* device instance $1103 r0 *1 58.195,133.855 rppd
R$1103 \$810 \$820 vss rppd w=4u l=1.2u ps=0u b=0 m=1
* device instance $1104 r0 *1 74.895,133.855 rppd
R$1104 \$811 \$822 vss rppd w=4u l=1.2u ps=0u b=0 m=1
* device instance $1108 r0 *1 20.435,135.615 rppd
R$1108 \$54 vss vss rppd w=4u l=306u ps=0u b=0 m=1
* device instance $1109 r0 *1 24.795,135.615 rppd
R$1109 \$817 \$829 vss rppd w=4u l=1.2u ps=0u b=0 m=1
* device instance $1110 r0 *1 41.495,135.615 rppd
R$1110 \$819 \$830 vss rppd w=4u l=1.2u ps=0u b=0 m=1
* device instance $1111 r0 *1 58.195,135.615 rppd
R$1111 \$820 \$831 vss rppd w=4u l=1.2u ps=0u b=0 m=1
* device instance $1112 r0 *1 74.895,135.615 rppd
R$1112 \$822 \$832 vss rppd w=4u l=1.2u ps=0u b=0 m=1
* device instance $1117 r0 *1 24.795,137.375 rppd
R$1117 \$829 \$835 vss rppd w=4u l=1.2u ps=0u b=0 m=1
* device instance $1118 r0 *1 41.495,137.375 rppd
R$1118 \$830 \$835 vss rppd w=4u l=1.2u ps=0u b=0 m=1
* device instance $1119 r0 *1 58.195,137.375 rppd
R$1119 \$831 \$837 vss rppd w=4u l=1.2u ps=0u b=0 m=1
* device instance $1120 r0 *1 74.895,137.375 rppd
R$1120 \$832 \$837 vss rppd w=4u l=1.2u ps=0u b=0 m=1
.ENDS g1_dac8

* cell sg13g2_antennanp
* pin A
* pin VDD
* pin VSS
.SUBCKT sg13g2_antennanp A VDD VSS
* device instance $1 r0 *1 0.74,0.88 dantenna
D$1 VSS A dantenna A=0.6084p P=3.12u m=1
* device instance $2 r0 *1 0.74,2.73 dpantenna
D$2 A VDD dpantenna A=1.407p P=4.78u m=1
.ENDS sg13g2_antennanp

* cell sg13g2_or4_1
* pin VDD
* pin VSS
* pin B
* pin D
* pin A
* pin C
* pin X
.SUBCKT sg13g2_or4_1 VDD VSS B D A C X
* device instance $1 r0 *1 0.765,1.055 sg13_lv_nmos
M$1 VSS D \$7 VSS sg13_lv_nmos L=0.13u W=0.55u AS=0.187p AD=0.1045p PS=1.78u
+ PD=0.93u rfmode=0
* device instance $2 r0 *1 1.275,1.055 sg13_lv_nmos
M$2 VSS C \$7 VSS sg13_lv_nmos L=0.13u W=0.55u AS=0.16755p AD=0.1045p PS=1.165u
+ PD=0.93u rfmode=0
* device instance $3 r0 *1 1.99,1.055 sg13_lv_nmos
M$3 VSS B \$7 VSS sg13_lv_nmos L=0.13u W=0.55u AS=0.16755p AD=0.1045p PS=1.165u
+ PD=0.93u rfmode=0
* device instance $4 r0 *1 2.5,1.055 sg13_lv_nmos
M$4 VSS A \$7 VSS sg13_lv_nmos L=0.13u W=0.55u AS=0.14135p AD=0.1045p PS=1.14u
+ PD=0.93u rfmode=0
* device instance $5 r0 *1 3.03,0.96 sg13_lv_nmos
M$5 VSS \$7 X VSS sg13_lv_nmos L=0.13u W=0.74u AS=0.14135p AD=0.2516p PS=1.14u
+ PD=2.16u rfmode=0
* device instance $6 r0 *1 0.765,2.68 sg13_lv_pmos
M$6 \$7 D \$11 VDD sg13_lv_pmos L=0.13u W=1u AS=0.34p AD=0.19p PS=2.68u
+ PD=1.38u rfmode=0
* device instance $7 r0 *1 1.275,2.68 sg13_lv_pmos
M$7 \$11 C \$10 VDD sg13_lv_pmos L=0.13u W=1u AS=0.19p AD=0.2925p PS=1.38u
+ PD=1.585u rfmode=0
* device instance $8 r0 *1 1.99,2.68 sg13_lv_pmos
M$8 \$10 B \$9 VDD sg13_lv_pmos L=0.13u W=1u AS=0.2925p AD=0.19p PS=1.585u
+ PD=1.38u rfmode=0
* device instance $9 r0 *1 2.5,2.68 sg13_lv_pmos
M$9 VDD A \$9 VDD sg13_lv_pmos L=0.13u W=1u AS=0.2144p AD=0.19p PS=1.52u
+ PD=1.38u rfmode=0
* device instance $10 r0 *1 3.03,2.62 sg13_lv_pmos
M$10 VDD \$7 X VDD sg13_lv_pmos L=0.13u W=1.12u AS=0.2144p AD=0.3808p PS=1.52u
+ PD=2.92u rfmode=0
.ENDS sg13g2_or4_1

* cell sg13g2_inv_8
* pin VSS
* pin A
* pin VDD
.SUBCKT sg13g2_inv_8 VSS A VDD
* device instance $1 r0 *1 0.59,0.96 sg13_lv_nmos
M$1 VSS A Y VSS sg13_lv_nmos L=0.13u W=5.92u AS=1.2395p AD=1.2395p PS=10.01u
+ PD=10.01u rfmode=0
* device instance $9 r0 *1 0.59,2.62 sg13_lv_pmos
M$9 VDD A Y VDD sg13_lv_pmos L=0.13u W=8.96u AS=1.876p AD=1.876p PS=13.43u
+ PD=13.43u rfmode=0
.ENDS sg13g2_inv_8

* cell sg13g2_buf_4
* pin VSS
* pin X
* pin A
* pin VDD
.SUBCKT sg13g2_buf_4 VSS X A VDD
* device instance $1 r0 *1 0.62,0.96 sg13_lv_nmos
M$1 VSS \$3 X VSS sg13_lv_nmos L=0.13u W=2.96u AS=0.6734p AD=0.7511p PS=5.52u
+ PD=4.99u rfmode=0
* device instance $5 r0 *1 3.17,0.96 sg13_lv_nmos
M$5 VSS A \$3 VSS sg13_lv_nmos L=0.13u W=0.74u AS=0.3293p AD=0.2516p PS=1.63u
+ PD=2.16u rfmode=0
* device instance $6 r0 *1 2.66,2.48 sg13_lv_pmos
M$6 VDD A \$3 VDD sg13_lv_pmos L=0.13u W=1.68u AS=0.3626p AD=0.4452p PS=2.72u
+ PD=3.58u rfmode=0
* device instance $8 r0 *1 0.62,2.62 sg13_lv_pmos
M$8 VDD \$3 X VDD sg13_lv_pmos L=0.13u W=4.48u AS=1.0192p AD=0.8414p PS=7.42u
+ PD=6u rfmode=0
.ENDS sg13g2_buf_4

* cell sg13g2_tiehi
* pin L_HI
* pin VDD
* pin VSS
.SUBCKT sg13g2_tiehi L_HI VDD VSS
* device instance $1 r0 *1 0.55,1.125 sg13_lv_nmos
M$1 VSS \$5 \$5 VSS sg13_lv_nmos L=0.13u W=0.3u AS=0.2043375p AD=0.111p
+ PS=1.585u PD=1.34u rfmode=0
* device instance $2 r0 *1 1.17,0.877 sg13_lv_nmos
M$2 VSS \$3 \$1 VSS sg13_lv_nmos L=0.13u W=0.795u AS=0.2043375p AD=0.274275p
+ PS=1.585u PD=2.28u rfmode=0
* device instance $3 r0 *1 0.55,2.475 sg13_lv_pmos
M$3 \$3 \$5 VDD VDD sg13_lv_pmos L=0.13u W=0.66u AS=0.2442p AD=0.4657125p
+ PS=2.06u PD=2.54u rfmode=0
* device instance $4 r0 *1 1.175,2.722 sg13_lv_pmos
M$4 VDD \$1 L_HI VDD sg13_lv_pmos L=0.13u W=1.155u AS=0.4657125p AD=0.3927p
+ PS=2.54u PD=2.99u rfmode=0
.ENDS sg13g2_tiehi

* cell sg13g2_inv_4
* pin VDD
* pin VSS
* pin A
.SUBCKT sg13g2_inv_4 VDD VSS A
* device instance $1 r0 *1 0.65,0.96 sg13_lv_nmos
M$1 VSS A Y VSS sg13_lv_nmos L=0.13u W=2.96u AS=0.6734p AD=0.6734p PS=5.52u
+ PD=5.52u rfmode=0
* device instance $5 r0 *1 0.65,2.62 sg13_lv_pmos
M$5 VDD A Y VDD sg13_lv_pmos L=0.13u W=4.48u AS=1.0192p AD=1.0192p PS=7.42u
+ PD=7.42u rfmode=0
.ENDS sg13g2_inv_4

* cell sg13g2_nor4_1
* pin VDD
* pin VSS
* pin B
* pin A
* pin C
* pin D
* pin Y
.SUBCKT sg13g2_nor4_1 VDD VSS B A C D Y
* device instance $1 r0 *1 0.685,0.96 sg13_lv_nmos
M$1 VSS A Y VSS sg13_lv_nmos L=0.13u W=0.74u AS=0.2516p AD=0.1406p PS=2.16u
+ PD=1.12u rfmode=0
* device instance $2 r0 *1 1.195,0.96 sg13_lv_nmos
M$2 Y B VSS VSS sg13_lv_nmos L=0.13u W=0.74u AS=0.1406p AD=0.1406p PS=1.12u
+ PD=1.12u rfmode=0
* device instance $3 r0 *1 1.705,0.96 sg13_lv_nmos
M$3 VSS C Y VSS sg13_lv_nmos L=0.13u W=0.74u AS=0.1406p AD=0.1406p PS=1.12u
+ PD=1.12u rfmode=0
* device instance $4 r0 *1 2.215,0.96 sg13_lv_nmos
M$4 Y D VSS VSS sg13_lv_nmos L=0.13u W=0.74u AS=0.1406p AD=0.237575p PS=1.12u
+ PD=2.16u rfmode=0
* device instance $5 r0 *1 0.685,2.62 sg13_lv_pmos
M$5 VDD A \$9 VDD sg13_lv_pmos L=0.13u W=1.12u AS=0.3808p AD=0.2128p PS=2.92u
+ PD=1.5u rfmode=0
* device instance $6 r0 *1 1.195,2.62 sg13_lv_pmos
M$6 \$9 B \$8 VDD sg13_lv_pmos L=0.13u W=1.12u AS=0.2128p AD=0.2128p PS=1.5u
+ PD=1.5u rfmode=0
* device instance $7 r0 *1 1.705,2.62 sg13_lv_pmos
M$7 \$8 C \$10 VDD sg13_lv_pmos L=0.13u W=1.12u AS=0.2128p AD=0.2128p PS=1.5u
+ PD=1.5u rfmode=0
* device instance $8 r0 *1 2.215,2.62 sg13_lv_pmos
M$8 \$10 D Y VDD sg13_lv_pmos L=0.13u W=1.12u AS=0.2128p AD=0.4368p PS=1.5u
+ PD=3.02u rfmode=0
.ENDS sg13g2_nor4_1

* cell sg13g2_or2_1
* pin A
* pin X
* pin B
* pin VDD
* pin VSS
.SUBCKT sg13g2_or2_1 A X B VDD VSS
* device instance $1 r0 *1 0.645,0.755 sg13_lv_nmos
M$1 VSS B \$6 VSS sg13_lv_nmos L=0.13u W=0.55u AS=0.187p AD=0.1045p PS=1.78u
+ PD=0.93u rfmode=0
* device instance $2 r0 *1 1.155,0.755 sg13_lv_nmos
M$2 \$6 A VSS VSS sg13_lv_nmos L=0.13u W=0.55u AS=0.1045p AD=0.1469p PS=0.93u
+ PD=1.155u rfmode=0
* device instance $3 r0 *1 1.7,0.85 sg13_lv_nmos
M$3 VSS \$6 X VSS sg13_lv_nmos L=0.13u W=0.74u AS=0.1469p AD=0.2516p PS=1.155u
+ PD=2.16u rfmode=0
* device instance $4 r0 *1 0.645,2.88 sg13_lv_pmos
M$4 \$6 B \$7 VDD sg13_lv_pmos L=0.13u W=0.84u AS=0.2856p AD=0.1596p PS=2.36u
+ PD=1.22u rfmode=0
* device instance $5 r0 *1 1.155,2.88 sg13_lv_pmos
M$5 VDD A \$7 VDD sg13_lv_pmos L=0.13u W=0.84u AS=0.2226p AD=0.1596p PS=1.535u
+ PD=1.22u rfmode=0
* device instance $6 r0 *1 1.7,2.74 sg13_lv_pmos
M$6 VDD \$6 X VDD sg13_lv_pmos L=0.13u W=1.12u AS=0.2226p AD=0.3976p PS=1.535u
+ PD=2.95u rfmode=0
.ENDS sg13g2_or2_1

* cell sg13g2_inv_2
* pin A
* pin VSS
* pin VDD
.SUBCKT sg13g2_inv_2 A VSS VDD
* device instance $1 r0 *1 0.67,0.96 sg13_lv_nmos
M$1 VSS A Y VSS sg13_lv_nmos L=0.13u W=1.48u AS=0.3922p AD=0.3922p PS=3.28u
+ PD=3.28u rfmode=0
* device instance $3 r0 *1 0.67,2.62 sg13_lv_pmos
M$3 VDD A Y VDD sg13_lv_pmos L=0.13u W=2.24u AS=0.5936p AD=0.5992p PS=4.42u
+ PD=4.43u rfmode=0
.ENDS sg13g2_inv_2

* cell sg13g2_and4_1
* pin VSS
* pin VDD
* pin X
* pin D
* pin C
* pin B
* pin A
.SUBCKT sg13g2_and4_1 VSS VDD X D C B A
* device instance $1 r0 *1 0.81,0.91 sg13_lv_nmos
M$1 \$4 A \$11 VSS sg13_lv_nmos L=0.13u W=0.64u AS=0.2176p AD=0.1216p PS=1.96u
+ PD=1.02u rfmode=0
* device instance $2 r0 *1 1.32,0.91 sg13_lv_nmos
M$2 \$11 B \$10 VSS sg13_lv_nmos L=0.13u W=0.64u AS=0.1216p AD=0.1216p PS=1.02u
+ PD=1.02u rfmode=0
* device instance $3 r0 *1 1.83,0.91 sg13_lv_nmos
M$3 \$10 C \$9 VSS sg13_lv_nmos L=0.13u W=0.64u AS=0.1216p AD=0.1408p PS=1.02u
+ PD=1.08u rfmode=0
* device instance $4 r0 *1 2.4,0.91 sg13_lv_nmos
M$4 \$9 D VSS VSS sg13_lv_nmos L=0.13u W=0.64u AS=0.1408p AD=0.1447p PS=1.08u
+ PD=1.15u rfmode=0
* device instance $5 r0 *1 2.94,0.96 sg13_lv_nmos
M$5 VSS \$4 X VSS sg13_lv_nmos L=0.13u W=0.74u AS=0.1447p AD=0.3552p PS=1.15u
+ PD=2.44u rfmode=0
* device instance $6 r0 *1 0.81,2.76 sg13_lv_pmos
M$6 VDD A \$4 VDD sg13_lv_pmos L=0.13u W=0.84u AS=0.2856p AD=0.1596p PS=2.36u
+ PD=1.22u rfmode=0
* device instance $7 r0 *1 1.32,2.76 sg13_lv_pmos
M$7 \$4 B VDD VDD sg13_lv_pmos L=0.13u W=0.84u AS=0.1596p AD=0.1596p PS=1.22u
+ PD=1.22u rfmode=0
* device instance $8 r0 *1 1.83,2.76 sg13_lv_pmos
M$8 VDD C \$4 VDD sg13_lv_pmos L=0.13u W=0.84u AS=0.1596p AD=0.1848p PS=1.22u
+ PD=1.28u rfmode=0
* device instance $9 r0 *1 2.4,2.76 sg13_lv_pmos
M$9 VDD D \$4 VDD sg13_lv_pmos L=0.13u W=0.84u AS=0.2044p AD=0.1848p PS=1.53u
+ PD=1.28u rfmode=0
* device instance $10 r0 *1 2.94,2.62 sg13_lv_pmos
M$10 VDD \$4 X VDD sg13_lv_pmos L=0.13u W=1.12u AS=0.2044p AD=0.5376p PS=1.53u
+ PD=3.2u rfmode=0
.ENDS sg13g2_and4_1

* cell sg13g2_nand3b_1
* pin VDD
* pin VSS
* pin Y
* pin B
* pin C
* pin A_N
.SUBCKT sg13g2_nand3b_1 VDD VSS Y B C A_N
* device instance $1 r0 *1 0.875,1.075 sg13_lv_nmos
M$1 VSS A_N \$6 VSS sg13_lv_nmos L=0.13u W=0.55u AS=0.18575p AD=0.187p PS=1.26u
+ PD=1.78u rfmode=0
* device instance $2 r0 *1 1.525,0.98 sg13_lv_nmos
M$2 VSS C \$9 VSS sg13_lv_nmos L=0.13u W=0.74u AS=0.18575p AD=0.1406p PS=1.26u
+ PD=1.12u rfmode=0
* device instance $3 r0 *1 2.035,0.98 sg13_lv_nmos
M$3 \$9 B \$8 VSS sg13_lv_nmos L=0.13u W=0.74u AS=0.1406p AD=0.1406p PS=1.12u
+ PD=1.12u rfmode=0
* device instance $4 r0 *1 2.545,0.98 sg13_lv_nmos
M$4 \$8 \$6 Y VSS sg13_lv_nmos L=0.13u W=0.74u AS=0.1406p AD=0.3404p PS=1.12u
+ PD=2.4u rfmode=0
* device instance $5 r0 *1 0.985,2.48 sg13_lv_pmos
M$5 \$6 A_N VDD VDD sg13_lv_pmos L=0.13u W=0.84u AS=0.2856p AD=0.2198p PS=2.36u
+ PD=1.53u rfmode=0
* device instance $6 r0 *1 1.525,2.62 sg13_lv_pmos
M$6 VDD C Y VDD sg13_lv_pmos L=0.13u W=1.12u AS=0.2198p AD=0.2128p PS=1.53u
+ PD=1.5u rfmode=0
* device instance $7 r0 *1 2.035,2.62 sg13_lv_pmos
M$7 Y B VDD VDD sg13_lv_pmos L=0.13u W=1.12u AS=0.2128p AD=0.2128p PS=1.5u
+ PD=1.5u rfmode=0
* device instance $8 r0 *1 2.545,2.62 sg13_lv_pmos
M$8 VDD \$6 Y VDD sg13_lv_pmos L=0.13u W=1.12u AS=0.2128p AD=0.3808p PS=1.5u
+ PD=2.92u rfmode=0
.ENDS sg13g2_nand3b_1

* cell sg13g2_and3_1
* pin VDD
* pin VSS
* pin A
* pin C
* pin B
* pin X
.SUBCKT sg13g2_and3_1 VDD VSS A C B X
* device instance $1 r0 *1 0.785,1.12 sg13_lv_nmos
M$1 \$7 A \$9 VSS sg13_lv_nmos L=0.13u W=0.64u AS=0.2176p AD=0.1216p PS=1.96u
+ PD=1.02u rfmode=0
* device instance $2 r0 *1 1.295,1.12 sg13_lv_nmos
M$2 \$9 B \$8 VSS sg13_lv_nmos L=0.13u W=0.64u AS=0.1216p AD=0.1216p PS=1.02u
+ PD=1.02u rfmode=0
* device instance $3 r0 *1 1.805,1.12 sg13_lv_nmos
M$3 VSS C \$8 VSS sg13_lv_nmos L=0.13u W=0.64u AS=0.1371p AD=0.1216p PS=1.12u
+ PD=1.02u rfmode=0
* device instance $4 r0 *1 2.315,1.07 sg13_lv_nmos
M$4 VSS \$7 X VSS sg13_lv_nmos L=0.13u W=0.74u AS=0.1371p AD=0.2516p PS=1.12u
+ PD=2.16u rfmode=0
* device instance $5 r0 *1 0.785,2.775 sg13_lv_pmos
M$5 \$7 A VDD VDD sg13_lv_pmos L=0.13u W=0.84u AS=0.2856p AD=0.1596p PS=2.36u
+ PD=1.22u rfmode=0
* device instance $6 r0 *1 1.295,2.775 sg13_lv_pmos
M$6 VDD B \$7 VDD sg13_lv_pmos L=0.13u W=0.84u AS=0.1596p AD=0.1596p PS=1.22u
+ PD=1.22u rfmode=0
* device instance $7 r0 *1 1.805,2.775 sg13_lv_pmos
M$7 VDD C \$7 VDD sg13_lv_pmos L=0.13u W=0.84u AS=0.36195p AD=0.1596p PS=1.84u
+ PD=1.22u rfmode=0
* device instance $8 r0 *1 2.655,2.73 sg13_lv_pmos
M$8 VDD \$7 X VDD sg13_lv_pmos L=0.13u W=1.12u AS=0.36195p AD=0.3808p PS=1.84u
+ PD=2.92u rfmode=0
.ENDS sg13g2_and3_1

* cell sg13g2_xor2_1
* pin VSS
* pin X
* pin VDD
* pin B
* pin A
.SUBCKT sg13g2_xor2_1 VSS X VDD B A
* device instance $1 r0 *1 0.98,1.115 sg13_lv_nmos
M$1 VSS A \$1 VSS sg13_lv_nmos L=0.13u W=0.55u AS=0.374p AD=0.174625p PS=2.46u
+ PD=1.185u rfmode=0
* device instance $2 r0 *1 1.745,1.115 sg13_lv_nmos
M$2 VSS B \$1 VSS sg13_lv_nmos L=0.13u W=0.55u AS=0.15245p AD=0.174625p
+ PS=1.17u PD=1.185u rfmode=0
* device instance $3 r0 *1 2.305,1.02 sg13_lv_nmos
M$3 VSS A \$9 VSS sg13_lv_nmos L=0.13u W=0.74u AS=0.15245p AD=0.0888p PS=1.17u
+ PD=0.98u rfmode=0
* device instance $4 r0 *1 2.675,1.02 sg13_lv_nmos
M$4 \$9 B X VSS sg13_lv_nmos L=0.13u W=0.74u AS=0.0888p AD=0.1628p PS=0.98u
+ PD=1.18u rfmode=0
* device instance $5 r0 *1 3.245,1.02 sg13_lv_nmos
M$5 X \$1 VSS VSS sg13_lv_nmos L=0.13u W=0.74u AS=0.1628p AD=0.3108p PS=1.18u
+ PD=2.32u rfmode=0
* device instance $6 r0 *1 2.305,2.62 sg13_lv_pmos
M$6 \$3 A VDD VDD sg13_lv_pmos L=0.13u W=1.12u AS=0.3808p AD=0.2128p PS=2.92u
+ PD=1.5u rfmode=0
* device instance $7 r0 *1 2.815,2.62 sg13_lv_pmos
M$7 VDD B \$3 VDD sg13_lv_pmos L=0.13u W=1.12u AS=0.2128p AD=0.2128p PS=1.5u
+ PD=1.5u rfmode=0
* device instance $8 r0 *1 3.325,2.62 sg13_lv_pmos
M$8 \$3 \$1 X VDD sg13_lv_pmos L=0.13u W=1.12u AS=0.2128p AD=0.3808p PS=1.5u
+ PD=2.92u rfmode=0
* device instance $9 r0 *1 0.82,2.68 sg13_lv_pmos
M$9 VDD A \$8 VDD sg13_lv_pmos L=0.13u W=1u AS=0.36p AD=0.1225p PS=2.72u
+ PD=1.245u rfmode=0
* device instance $10 r0 *1 1.195,2.68 sg13_lv_pmos
M$10 \$8 B \$1 VDD sg13_lv_pmos L=0.13u W=1u AS=0.1225p AD=0.34p PS=1.245u
+ PD=2.68u rfmode=0
.ENDS sg13g2_xor2_1

* cell sg13g2_a221oi_1
* pin VSS
* pin B1
* pin VDD
* pin Y
* pin B2
* pin C1
* pin A1
* pin A2
.SUBCKT sg13g2_a221oi_1 VSS B1 VDD Y B2 C1 A1 A2
* device instance $1 r0 *1 2.685,1.07 sg13_lv_nmos
M$1 Y A1 \$11 VSS sg13_lv_nmos L=0.13u W=0.74u AS=0.2516p AD=0.1406p PS=2.16u
+ PD=1.12u rfmode=0
* device instance $2 r0 *1 3.195,1.07 sg13_lv_nmos
M$2 \$11 A2 VSS VSS sg13_lv_nmos L=0.13u W=0.74u AS=0.1406p AD=0.2516p PS=1.12u
+ PD=2.16u rfmode=0
* device instance $3 r0 *1 0.645,1.07 sg13_lv_nmos
M$3 Y C1 VSS VSS sg13_lv_nmos L=0.13u W=0.74u AS=0.2516p AD=0.1406p PS=2.16u
+ PD=1.12u rfmode=0
* device instance $4 r0 *1 1.155,1.07 sg13_lv_nmos
M$4 VSS B2 \$12 VSS sg13_lv_nmos L=0.13u W=0.74u AS=0.1406p AD=0.1406p PS=1.12u
+ PD=1.12u rfmode=0
* device instance $5 r0 *1 1.665,1.07 sg13_lv_nmos
M$5 \$12 B1 Y VSS sg13_lv_nmos L=0.13u W=0.74u AS=0.1406p AD=0.2516p PS=1.12u
+ PD=2.16u rfmode=0
* device instance $6 r0 *1 2.685,2.62 sg13_lv_pmos
M$6 VDD A1 \$9 VDD sg13_lv_pmos L=0.13u W=1.12u AS=0.3808p AD=0.2128p PS=2.92u
+ PD=1.5u rfmode=0
* device instance $7 r0 *1 3.195,2.62 sg13_lv_pmos
M$7 \$9 A2 VDD VDD sg13_lv_pmos L=0.13u W=1.12u AS=0.2128p AD=0.3808p PS=1.5u
+ PD=2.92u rfmode=0
* device instance $8 r0 *1 0.645,2.62 sg13_lv_pmos
M$8 Y C1 \$6 VDD sg13_lv_pmos L=0.13u W=1.12u AS=0.3808p AD=0.2128p PS=2.92u
+ PD=1.5u rfmode=0
* device instance $9 r0 *1 1.155,2.62 sg13_lv_pmos
M$9 \$6 B2 \$9 VDD sg13_lv_pmos L=0.13u W=1.12u AS=0.2128p AD=0.2128p PS=1.5u
+ PD=1.5u rfmode=0
* device instance $10 r0 *1 1.665,2.62 sg13_lv_pmos
M$10 \$9 B1 \$6 VDD sg13_lv_pmos L=0.13u W=1.12u AS=0.2128p AD=0.3808p PS=1.5u
+ PD=2.92u rfmode=0
.ENDS sg13g2_a221oi_1

* cell sg13g2_or3_1
* pin VDD
* pin VSS
* pin C
* pin A
* pin B
* pin X
.SUBCKT sg13g2_or3_1 VDD VSS C A B X
* device instance $1 r0 *1 0.77,0.865 sg13_lv_nmos
M$1 \$6 C VSS VSS sg13_lv_nmos L=0.13u W=0.55u AS=0.187p AD=0.1045p PS=1.78u
+ PD=0.93u rfmode=0
* device instance $2 r0 *1 1.28,0.865 sg13_lv_nmos
M$2 VSS B \$6 VSS sg13_lv_nmos L=0.13u W=0.55u AS=0.1045p AD=0.198p PS=0.93u
+ PD=1.27u rfmode=0
* device instance $3 r0 *1 2.13,0.865 sg13_lv_nmos
M$3 \$6 A VSS VSS sg13_lv_nmos L=0.13u W=0.55u AS=0.198p AD=0.13395p PS=1.27u
+ PD=1.12u rfmode=0
* device instance $4 r0 *1 2.64,0.96 sg13_lv_nmos
M$4 VSS \$6 X VSS sg13_lv_nmos L=0.13u W=0.74u AS=0.13395p AD=0.2516p PS=1.12u
+ PD=2.16u rfmode=0
* device instance $5 r0 *1 0.77,2.56 sg13_lv_pmos
M$5 \$6 C \$9 VDD sg13_lv_pmos L=0.13u W=1u AS=0.34p AD=0.19p PS=2.68u PD=1.38u
+ rfmode=0
* device instance $6 r0 *1 1.28,2.56 sg13_lv_pmos
M$6 \$9 B \$8 VDD sg13_lv_pmos L=0.13u W=1u AS=0.19p AD=0.1575p PS=1.38u
+ PD=1.315u rfmode=0
* device instance $7 r0 *1 1.725,2.56 sg13_lv_pmos
M$7 \$8 A VDD VDD sg13_lv_pmos L=0.13u W=1u AS=0.1575p AD=0.3822p PS=1.315u
+ PD=1.84u rfmode=0
* device instance $8 r0 *1 2.575,2.62 sg13_lv_pmos
M$8 VDD \$6 X VDD sg13_lv_pmos L=0.13u W=1.12u AS=0.3822p AD=0.3808p PS=1.84u
+ PD=2.92u rfmode=0
.ENDS sg13g2_or3_1

* cell sg13g2_nand3_1
* pin VSS
* pin VDD
* pin Y
* pin B
* pin C
* pin A
.SUBCKT sg13g2_nand3_1 VSS VDD Y B C A
* device instance $1 r0 *1 0.665,0.98 sg13_lv_nmos
M$1 VSS C \$8 VSS sg13_lv_nmos L=0.13u W=0.74u AS=0.2886p AD=0.1406p PS=2.26u
+ PD=1.12u rfmode=0
* device instance $2 r0 *1 1.175,0.98 sg13_lv_nmos
M$2 \$8 B \$7 VSS sg13_lv_nmos L=0.13u W=0.74u AS=0.1406p AD=0.1406p PS=1.12u
+ PD=1.12u rfmode=0
* device instance $3 r0 *1 1.685,0.98 sg13_lv_nmos
M$3 \$7 A Y VSS sg13_lv_nmos L=0.13u W=0.74u AS=0.1406p AD=0.2516p PS=1.12u
+ PD=2.16u rfmode=0
* device instance $4 r0 *1 0.665,2.69 sg13_lv_pmos
M$4 VDD C Y VDD sg13_lv_pmos L=0.13u W=1.12u AS=0.3808p AD=0.2128p PS=2.92u
+ PD=1.5u rfmode=0
* device instance $5 r0 *1 1.175,2.69 sg13_lv_pmos
M$5 Y B VDD VDD sg13_lv_pmos L=0.13u W=1.12u AS=0.2128p AD=0.2128p PS=1.5u
+ PD=1.5u rfmode=0
* device instance $6 r0 *1 1.685,2.69 sg13_lv_pmos
M$6 VDD A Y VDD sg13_lv_pmos L=0.13u W=1.12u AS=0.2128p AD=0.3808p PS=1.5u
+ PD=2.92u rfmode=0
.ENDS sg13g2_nand3_1

* cell sg13g2_nor2b_1
* pin VSS
* pin VDD
* pin Y
* pin A
* pin B_N
.SUBCKT sg13g2_nor2b_1 VSS VDD Y A B_N
* device instance $1 r0 *1 0.635,1.055 sg13_lv_nmos
M$1 VSS B_N \$5 VSS sg13_lv_nmos L=0.13u W=0.55u AS=0.17255p AD=0.187p PS=1.25u
+ PD=1.78u rfmode=0
* device instance $2 r0 *1 1.275,0.96 sg13_lv_nmos
M$2 VSS \$5 Y VSS sg13_lv_nmos L=0.13u W=0.74u AS=0.17255p AD=0.1406p PS=1.25u
+ PD=1.12u rfmode=0
* device instance $3 r0 *1 1.785,0.96 sg13_lv_nmos
M$3 Y A VSS VSS sg13_lv_nmos L=0.13u W=0.74u AS=0.1406p AD=0.2516p PS=1.12u
+ PD=2.16u rfmode=0
* device instance $4 r0 *1 0.635,2.48 sg13_lv_pmos
M$4 \$5 B_N VDD VDD sg13_lv_pmos L=0.13u W=0.84u AS=0.2856p AD=0.2618p PS=2.36u
+ PD=1.63u rfmode=0
* device instance $5 r0 *1 1.275,2.62 sg13_lv_pmos
M$5 VDD \$5 \$7 VDD sg13_lv_pmos L=0.13u W=1.12u AS=0.2618p AD=0.1176p PS=1.63u
+ PD=1.33u rfmode=0
* device instance $6 r0 *1 1.615,2.62 sg13_lv_pmos
M$6 \$7 A Y VDD sg13_lv_pmos L=0.13u W=1.12u AS=0.1176p AD=0.3808p PS=1.33u
+ PD=2.92u rfmode=0
.ENDS sg13g2_nor2b_1

* cell sg13g2_a21o_1
* pin VDD
* pin VSS
* pin X
* pin B1
* pin A1
* pin A2
.SUBCKT sg13g2_a21o_1 VDD VSS X B1 A1 A2
* device instance $1 r0 *1 1.33,1.07 sg13_lv_nmos
M$1 X \$6 VSS VSS sg13_lv_nmos L=0.13u W=0.74u AS=0.2351p AD=0.15745p PS=2.16u
+ PD=1.175u rfmode=0
* device instance $2 r0 *1 1.895,1.12 sg13_lv_nmos
M$2 VSS B1 \$6 VSS sg13_lv_nmos L=0.13u W=0.64u AS=0.15745p AD=0.1216p
+ PS=1.175u PD=1.02u rfmode=0
* device instance $3 r0 *1 2.405,1.12 sg13_lv_nmos
M$3 \$6 A1 \$9 VSS sg13_lv_nmos L=0.13u W=0.64u AS=0.1216p AD=0.0816p PS=1.02u
+ PD=0.895u rfmode=0
* device instance $4 r0 *1 2.79,1.12 sg13_lv_nmos
M$4 \$9 A2 VSS VSS sg13_lv_nmos L=0.13u W=0.64u AS=0.0816p AD=0.2176p PS=0.895u
+ PD=1.96u rfmode=0
* device instance $5 r0 *1 1.725,2.68 sg13_lv_pmos
M$5 \$6 B1 \$5 VDD sg13_lv_pmos L=0.13u W=1u AS=0.35p AD=0.2125p PS=2.7u
+ PD=1.425u rfmode=0
* device instance $6 r0 *1 2.28,2.68 sg13_lv_pmos
M$6 \$5 A1 VDD VDD sg13_lv_pmos L=0.13u W=1u AS=0.2125p AD=0.19p PS=1.425u
+ PD=1.38u rfmode=0
* device instance $7 r0 *1 2.79,2.68 sg13_lv_pmos
M$7 VDD A2 \$5 VDD sg13_lv_pmos L=0.13u W=1u AS=0.19p AD=0.34p PS=1.38u
+ PD=2.68u rfmode=0
* device instance $8 r0 *1 0.685,2.62 sg13_lv_pmos
M$8 X \$6 VDD VDD sg13_lv_pmos L=0.13u W=1.12u AS=0.3808p AD=0.3808p PS=2.92u
+ PD=2.92u rfmode=0
.ENDS sg13g2_a21o_1

* cell sg13g2_and2_1
* pin VDD
* pin VSS
* pin X
* pin A
* pin B
.SUBCKT sg13g2_and2_1 VDD VSS X A B
* device instance $1 r0 *1 0.63,1.12 sg13_lv_nmos
M$1 \$4 A \$7 VSS sg13_lv_nmos L=0.13u W=0.64u AS=0.2176p AD=0.1216p PS=1.96u
+ PD=1.02u rfmode=0
* device instance $2 r0 *1 1.14,1.12 sg13_lv_nmos
M$2 VSS B \$7 VSS sg13_lv_nmos L=0.13u W=0.64u AS=0.1331p AD=0.1216p PS=1.12u
+ PD=1.02u rfmode=0
* device instance $3 r0 *1 1.65,1.07 sg13_lv_nmos
M$3 VSS \$4 X VSS sg13_lv_nmos L=0.13u W=0.74u AS=0.1331p AD=0.2516p PS=1.12u
+ PD=2.16u rfmode=0
* device instance $4 r0 *1 0.63,2.76 sg13_lv_pmos
M$4 VDD A \$4 VDD sg13_lv_pmos L=0.13u W=0.84u AS=0.2856p AD=0.1596p PS=2.36u
+ PD=1.22u rfmode=0
* device instance $5 r0 *1 1.14,2.76 sg13_lv_pmos
M$5 VDD B \$4 VDD sg13_lv_pmos L=0.13u W=0.84u AS=0.1918p AD=0.1596p PS=1.5u
+ PD=1.22u rfmode=0
* device instance $6 r0 *1 1.65,2.62 sg13_lv_pmos
M$6 VDD \$4 X VDD sg13_lv_pmos L=0.13u W=1.12u AS=0.1918p AD=0.3808p PS=1.5u
+ PD=2.92u rfmode=0
.ENDS sg13g2_and2_1

* cell sg13g2_dlygate4sd3_1
* pin VDD
* pin VSS
* pin X
* pin A
.SUBCKT sg13g2_dlygate4sd3_1 VDD VSS X A
* device instance $1 r0 *1 2.78,1.12 sg13_lv_nmos
M$1 VSS \$5 \$4 VSS sg13_lv_nmos L=0.5u W=0.42u AS=0.1426p AD=0.1428p PS=1.16u
+ PD=1.52u rfmode=0
* device instance $2 r0 *1 3.515,0.96 sg13_lv_nmos
M$2 VSS \$4 X VSS sg13_lv_nmos L=0.13u W=0.74u AS=0.1426p AD=0.2516p PS=1.16u
+ PD=2.16u rfmode=0
* device instance $3 r0 *1 0.685,0.8 sg13_lv_nmos
M$3 \$6 A VSS VSS sg13_lv_nmos L=0.13u W=0.42u AS=0.1428p AD=0.0798p PS=1.52u
+ PD=0.8u rfmode=0
* device instance $4 r0 *1 1.38,0.8 sg13_lv_nmos
M$4 VSS \$6 \$5 VSS sg13_lv_nmos L=0.5u W=0.42u AS=0.0798p AD=0.1428p PS=0.8u
+ PD=1.52u rfmode=0
* device instance $5 r0 *1 2.78,2.56 sg13_lv_pmos
M$5 \$4 \$5 VDD VDD sg13_lv_pmos L=0.5u W=1u AS=0.34p AD=0.2254p PS=2.68u
+ PD=1.53u rfmode=0
* device instance $6 r0 *1 3.505,2.62 sg13_lv_pmos
M$6 VDD \$4 X VDD sg13_lv_pmos L=0.13u W=1.12u AS=0.2254p AD=0.4256p PS=1.53u
+ PD=3u rfmode=0
* device instance $7 r0 *1 0.685,2.765 sg13_lv_pmos
M$7 VDD A \$6 VDD sg13_lv_pmos L=0.13u W=0.42u AS=0.1523p AD=0.1428p PS=1.38u
+ PD=1.52u rfmode=0
* device instance $8 r0 *1 1.38,2.68 sg13_lv_pmos
M$8 VDD \$6 \$5 VDD sg13_lv_pmos L=0.5u W=1u AS=0.1523p AD=0.34p PS=1.38u
+ PD=2.68u rfmode=0
.ENDS sg13g2_dlygate4sd3_1

* cell sg13g2_buf_8
* pin VSS
* pin A
* pin X
* pin VDD
.SUBCKT sg13g2_buf_8 VSS A X VDD
* device instance $1 r0 *1 0.545,0.96 sg13_lv_nmos
M$1 \$2 A VSS VSS sg13_lv_nmos L=0.13u W=2.22u AS=0.5365p AD=0.4218p PS=4.41u
+ PD=3.36u rfmode=0
* device instance $4 r0 *1 2.075,0.96 sg13_lv_nmos
M$4 VSS \$2 X VSS sg13_lv_nmos L=0.13u W=5.92u AS=1.1248p AD=1.2358p PS=8.96u
+ PD=10u rfmode=0
* device instance $12 r0 *1 0.545,2.62 sg13_lv_pmos
M$12 \$2 A VDD VDD sg13_lv_pmos L=0.13u W=3.36u AS=0.8064p AD=0.6384p PS=5.92u
+ PD=4.5u rfmode=0
* device instance $15 r0 *1 2.075,2.62 sg13_lv_pmos
M$15 VDD \$2 X VDD sg13_lv_pmos L=0.13u W=8.96u AS=1.7024p AD=1.876p PS=12u
+ PD=13.43u rfmode=0
.ENDS sg13g2_buf_8

* cell sg13g2_buf_16
* pin VSS
* pin X
* pin A
* pin VDD
.SUBCKT sg13g2_buf_16 VSS X A VDD
* device instance $1 r0 *1 0.645,0.96 sg13_lv_nmos
M$1 VSS \$3 X VSS sg13_lv_nmos L=0.13u W=11.84u AS=2.3606p AD=2.2496p PS=18.96u
+ PD=17.92u rfmode=0
* device instance $17 r0 *1 8.805,0.96 sg13_lv_nmos
M$17 VSS A \$3 VSS sg13_lv_nmos L=0.13u W=4.44u AS=0.8436p AD=0.9546p PS=6.72u
+ PD=7.76u rfmode=0
* device instance $23 r0 *1 0.645,2.62 sg13_lv_pmos
M$23 VDD \$3 X VDD sg13_lv_pmos L=0.13u W=17.92u AS=3.5896p AD=3.4048p
+ PS=25.45u PD=24u rfmode=0
* device instance $39 r0 *1 8.805,2.62 sg13_lv_pmos
M$39 VDD A \$3 VDD sg13_lv_pmos L=0.13u W=6.72u AS=1.2768p AD=1.4448p PS=9u
+ PD=10.42u rfmode=0
.ENDS sg13g2_buf_16

* cell sg13g2_buf_1
* pin VSS
* pin X
* pin VDD
* pin A
.SUBCKT sg13g2_buf_1 VSS X VDD A
* device instance $1 r0 *1 0.605,1.035 sg13_lv_nmos
M$1 VSS A \$1 VSS sg13_lv_nmos L=0.13u W=0.55u AS=0.14875p AD=0.187p PS=1.16u
+ PD=1.78u rfmode=0
* device instance $2 r0 *1 1.155,0.94 sg13_lv_nmos
M$2 VSS \$1 X VSS sg13_lv_nmos L=0.13u W=0.74u AS=0.14875p AD=0.2886p PS=1.16u
+ PD=2.26u rfmode=0
* device instance $3 r0 *1 0.605,2.76 sg13_lv_pmos
M$3 VDD A \$1 VDD sg13_lv_pmos L=0.13u W=0.84u AS=0.2114p AD=0.2856p PS=1.54u
+ PD=2.36u rfmode=0
* device instance $4 r0 *1 1.155,2.62 sg13_lv_pmos
M$4 VDD \$1 X VDD sg13_lv_pmos L=0.13u W=1.12u AS=0.2114p AD=0.42p PS=1.54u
+ PD=2.99u rfmode=0
.ENDS sg13g2_buf_1

* cell sg13g2_dfrbpq_1
* pin VSS
* pin RESET_B
* pin Q
* pin D
* pin CLK
* pin VDD
.SUBCKT sg13g2_dfrbpq_1 VSS RESET_B Q D CLK VDD
* device instance $1 r0 *1 5.94,1.045 sg13_lv_nmos
M$1 VSS \$4 \$18 VSS sg13_lv_nmos L=0.13u W=0.74u AS=0.317325p AD=0.2516p
+ PS=1.805u PD=2.16u rfmode=0
* device instance $2 r0 *1 6.64,1.045 sg13_lv_nmos
M$2 VSS CLK \$4 VSS sg13_lv_nmos L=0.13u W=0.74u AS=0.317325p AD=0.2516p
+ PS=1.805u PD=2.16u rfmode=0
* device instance $3 r0 *1 7.85,1.165 sg13_lv_nmos
M$3 \$14 \$4 \$7 VSS sg13_lv_nmos L=0.13u W=0.42u AS=0.12665p AD=0.1428p
+ PS=1.145u PD=1.52u rfmode=0
* device instance $4 r0 *1 8.385,1.005 sg13_lv_nmos
M$4 \$3 \$18 \$14 VSS sg13_lv_nmos L=0.13u W=0.74u AS=0.3473p AD=0.12665p
+ PS=2.71u PD=1.145u rfmode=0
* device instance $5 r0 *1 0.595,0.78 sg13_lv_nmos
M$5 \$5 D \$15 VSS sg13_lv_nmos L=0.13u W=0.42u AS=0.1428p AD=0.0609p PS=1.52u
+ PD=0.71u rfmode=0
* device instance $6 r0 *1 1.015,0.78 sg13_lv_nmos
M$6 \$15 RESET_B VSS VSS sg13_lv_nmos L=0.13u W=0.42u AS=0.0609p AD=0.1626p
+ PS=0.71u PD=1.415u rfmode=0
* device instance $7 r0 *1 1.595,1.165 sg13_lv_nmos
M$7 VSS \$12 \$3 VSS sg13_lv_nmos L=0.13u W=0.74u AS=0.1626p AD=0.2516p
+ PS=1.415u PD=2.16u rfmode=0
* device instance $8 r0 *1 11.66,0.94 sg13_lv_nmos
M$8 \$9 \$14 VSS VSS sg13_lv_nmos L=0.13u W=0.74u AS=0.2516p AD=0.1406p
+ PS=2.16u PD=1.12u rfmode=0
* device instance $9 r0 *1 12.17,0.94 sg13_lv_nmos
M$9 VSS \$9 Q VSS sg13_lv_nmos L=0.13u W=0.74u AS=0.1406p AD=0.2516p PS=1.12u
+ PD=2.16u rfmode=0
* device instance $10 r0 *1 3.77,1.57 sg13_lv_nmos
M$10 \$5 \$4 \$12 VSS sg13_lv_nmos L=0.13u W=0.42u AS=0.1296p AD=0.0798p
+ PS=1.52u PD=0.8u rfmode=0
* device instance $11 r0 *1 4.28,1.57 sg13_lv_nmos
M$11 \$12 \$18 \$6 VSS sg13_lv_nmos L=0.13u W=0.42u AS=0.0798p AD=0.2373p
+ PS=0.8u PD=1.97u rfmode=0
* device instance $12 r0 *1 9.435,0.78 sg13_lv_nmos
M$12 \$7 \$8 VSS VSS sg13_lv_nmos L=0.13u W=0.42u AS=0.1428p AD=0.0798p
+ PS=1.52u PD=0.8u rfmode=0
* device instance $13 r0 *1 9.945,0.78 sg13_lv_nmos
M$13 VSS RESET_B \$17 VSS sg13_lv_nmos L=0.13u W=0.42u AS=0.0798p AD=0.0378p
+ PS=0.8u PD=0.6u rfmode=0
* device instance $14 r0 *1 10.255,0.78 sg13_lv_nmos
M$14 \$17 \$14 \$8 VSS sg13_lv_nmos L=0.13u W=0.42u AS=0.0378p AD=0.1428p
+ PS=0.6u PD=1.52u rfmode=0
* device instance $15 r0 *1 2.685,0.845 sg13_lv_nmos
M$15 VSS RESET_B \$16 VSS sg13_lv_nmos L=0.13u W=0.42u AS=0.1701p AD=0.0378p
+ PS=1.65u PD=0.6u rfmode=0
* device instance $16 r0 *1 2.995,0.845 sg13_lv_nmos
M$16 \$16 \$3 \$6 VSS sg13_lv_nmos L=0.13u W=0.42u AS=0.0378p AD=0.1428p
+ PS=0.6u PD=1.52u rfmode=0
* device instance $17 r0 *1 8.86,2.355 sg13_lv_pmos
M$17 \$14 \$18 \$21 VDD sg13_lv_pmos L=0.13u W=0.42u AS=0.2048p AD=0.09345p
+ PS=1.63u PD=0.865u rfmode=0
* device instance $18 r0 *1 9.435,2.355 sg13_lv_pmos
M$18 \$21 \$8 VDD VDD sg13_lv_pmos L=0.13u W=0.42u AS=0.09345p AD=0.204p
+ PS=0.865u PD=1.835u rfmode=0
* device instance $19 r0 *1 9.945,2.355 sg13_lv_pmos
M$19 VDD RESET_B \$8 VDD sg13_lv_pmos L=0.13u W=0.42u AS=0.204p AD=0.0798p
+ PS=1.835u PD=0.8u rfmode=0
* device instance $20 r0 *1 10.455,2.355 sg13_lv_pmos
M$20 \$8 \$14 VDD VDD sg13_lv_pmos L=0.13u W=0.42u AS=0.0798p AD=0.4659p
+ PS=0.8u PD=3.65u rfmode=0
* device instance $21 r0 *1 8.1,2.645 sg13_lv_pmos
M$21 \$3 \$4 \$14 VDD sg13_lv_pmos L=0.13u W=1u AS=0.34p AD=0.2048p PS=2.68u
+ PD=1.63u rfmode=0
* device instance $22 r0 *1 11.66,2.62 sg13_lv_pmos
M$22 \$9 \$14 VDD VDD sg13_lv_pmos L=0.13u W=1.12u AS=0.3864p AD=0.2128p
+ PS=2.93u PD=1.5u rfmode=0
* device instance $23 r0 *1 12.17,2.62 sg13_lv_pmos
M$23 VDD \$9 Q VDD sg13_lv_pmos L=0.13u W=1.12u AS=0.2128p AD=0.3808p PS=1.5u
+ PD=2.92u rfmode=0
* device instance $24 r0 *1 0.595,2.37 sg13_lv_pmos
M$24 VDD D \$5 VDD sg13_lv_pmos L=0.13u W=0.42u AS=0.1428p AD=0.0798p PS=1.52u
+ PD=0.8u rfmode=0
* device instance $25 r0 *1 1.105,2.37 sg13_lv_pmos
M$25 VDD RESET_B \$5 VDD sg13_lv_pmos L=0.13u W=0.42u AS=0.3623875p AD=0.0798p
+ PS=2.605u PD=0.8u rfmode=0
* device instance $26 r0 *1 1.555,2.66 sg13_lv_pmos
M$26 VDD \$12 \$3 VDD sg13_lv_pmos L=0.13u W=1u AS=0.3623875p AD=0.34p
+ PS=2.605u PD=2.68u rfmode=0
* device instance $27 r0 *1 5.94,2.61 sg13_lv_pmos
M$27 \$18 \$4 VDD VDD sg13_lv_pmos L=0.13u W=1.12u AS=0.3864p AD=0.41165p
+ PS=2.93u PD=2.12u rfmode=0
* device instance $28 r0 *1 6.64,2.61 sg13_lv_pmos
M$28 VDD CLK \$4 VDD sg13_lv_pmos L=0.13u W=1.12u AS=0.41165p AD=0.4088p
+ PS=2.12u PD=2.97u rfmode=0
* device instance $29 r0 *1 2.605,2.735 sg13_lv_pmos
M$29 \$12 RESET_B VDD VDD sg13_lv_pmos L=0.13u W=0.42u AS=0.147p AD=0.1563p
+ PS=1.54u PD=1.22u rfmode=0
* device instance $30 r0 *1 3.34,2.735 sg13_lv_pmos
M$30 VDD \$3 \$20 VDD sg13_lv_pmos L=0.13u W=0.42u AS=0.1563p AD=0.063p
+ PS=1.22u PD=0.72u rfmode=0
* device instance $31 r0 *1 3.77,2.735 sg13_lv_pmos
M$31 \$20 \$4 \$12 VDD sg13_lv_pmos L=0.13u W=0.42u AS=0.063p AD=0.0798p
+ PS=0.72u PD=0.8u rfmode=0
* device instance $32 r0 *1 4.28,2.735 sg13_lv_pmos
M$32 \$12 \$18 \$5 VDD sg13_lv_pmos L=0.13u W=0.42u AS=0.0798p AD=0.1428p
+ PS=0.8u PD=1.52u rfmode=0
.ENDS sg13g2_dfrbpq_1

* cell sg13g2_mux2_1
* pin VSS
* pin X
* pin S
* pin A1
* pin A0
* pin VDD
.SUBCKT sg13g2_mux2_1 VSS X S A1 A0 VDD
* device instance $1 r0 *1 0.7,1.055 sg13_lv_nmos
M$1 VSS S \$2 VSS sg13_lv_nmos L=0.13u W=0.55u AS=0.18945p AD=0.187p PS=1.27u
+ PD=1.78u rfmode=0
* device instance $2 r0 *1 1.36,0.96 sg13_lv_nmos
M$2 VSS S \$8 VSS sg13_lv_nmos L=0.13u W=0.74u AS=0.18945p AD=0.13135p PS=1.27u
+ PD=1.095u rfmode=0
* device instance $3 r0 *1 1.845,0.96 sg13_lv_nmos
M$3 \$8 A1 \$3 VSS sg13_lv_nmos L=0.13u W=0.74u AS=0.13135p AD=0.1628p
+ PS=1.095u PD=1.18u rfmode=0
* device instance $4 r0 *1 2.415,0.96 sg13_lv_nmos
M$4 \$3 A0 \$9 VSS sg13_lv_nmos L=0.13u W=0.74u AS=0.1628p AD=0.3367p PS=1.18u
+ PD=1.65u rfmode=0
* device instance $5 r0 *1 3.455,0.96 sg13_lv_nmos
M$5 \$9 \$2 VSS VSS sg13_lv_nmos L=0.13u W=0.74u AS=0.3367p AD=0.148p PS=1.65u
+ PD=1.14u rfmode=0
* device instance $6 r0 *1 3.985,0.96 sg13_lv_nmos
M$6 VSS \$3 X VSS sg13_lv_nmos L=0.13u W=0.74u AS=0.148p AD=0.4033p PS=1.14u
+ PD=2.57u rfmode=0
* device instance $7 r0 *1 0.7,2.48 sg13_lv_pmos
M$7 \$2 S VDD VDD sg13_lv_pmos L=0.13u W=0.84u AS=0.2856p AD=0.253p PS=2.36u
+ PD=1.53u rfmode=0
* device instance $8 r0 *1 1.36,2.56 sg13_lv_pmos
M$8 VDD S \$10 VDD sg13_lv_pmos L=0.13u W=1u AS=0.253p AD=0.3325p PS=1.53u
+ PD=1.665u rfmode=0
* device instance $9 r0 *1 2.155,2.56 sg13_lv_pmos
M$9 \$10 A0 \$3 VDD sg13_lv_pmos L=0.13u W=1u AS=0.3325p AD=0.2225p PS=1.665u
+ PD=1.445u rfmode=0
* device instance $10 r0 *1 2.73,2.56 sg13_lv_pmos
M$10 \$3 A1 \$11 VDD sg13_lv_pmos L=0.13u W=1u AS=0.2225p AD=0.2975p PS=1.445u
+ PD=1.595u rfmode=0
* device instance $11 r0 *1 3.455,2.56 sg13_lv_pmos
M$11 \$11 \$2 VDD VDD sg13_lv_pmos L=0.13u W=1u AS=0.2975p AD=0.2198p PS=1.595u
+ PD=1.52u rfmode=0
* device instance $12 r0 *1 3.985,2.62 sg13_lv_pmos
M$12 VDD \$3 X VDD sg13_lv_pmos L=0.13u W=1.12u AS=0.2198p AD=0.6048p PS=1.52u
+ PD=3.32u rfmode=0
.ENDS sg13g2_mux2_1

* cell sg13g2_xnor2_1
* pin VDD
* pin VSS
* pin Y
* pin B
* pin A
.SUBCKT sg13g2_xnor2_1 VDD VSS Y B A
* device instance $1 r0 *1 0.71,1.12 sg13_lv_nmos
M$1 VSS A \$9 VSS sg13_lv_nmos L=0.13u W=0.64u AS=0.2272p AD=0.0784p PS=1.99u
+ PD=0.885u rfmode=0
* device instance $2 r0 *1 1.085,1.12 sg13_lv_nmos
M$2 \$9 B \$7 VSS sg13_lv_nmos L=0.13u W=0.64u AS=0.0784p AD=0.2176p PS=0.885u
+ PD=1.96u rfmode=0
* device instance $3 r0 *1 2.11,0.96 sg13_lv_nmos
M$3 VSS A \$3 VSS sg13_lv_nmos L=0.13u W=0.74u AS=0.1898p AD=0.2516p PS=1.36u
+ PD=2.16u rfmode=0
* device instance $4 r0 *1 2.68,0.96 sg13_lv_nmos
M$4 VSS B \$3 VSS sg13_lv_nmos L=0.13u W=0.74u AS=0.1898p AD=0.1406p PS=1.36u
+ PD=1.12u rfmode=0
* device instance $5 r0 *1 3.19,0.96 sg13_lv_nmos
M$5 \$3 \$7 Y VSS sg13_lv_nmos L=0.13u W=0.74u AS=0.1406p AD=0.2516p PS=1.12u
+ PD=2.16u rfmode=0
* device instance $6 r0 *1 0.895,2.565 sg13_lv_pmos
M$6 VDD A \$7 VDD sg13_lv_pmos L=0.13u W=0.84u AS=0.4536p AD=0.1596p PS=2.76u
+ PD=1.22u rfmode=0
* device instance $7 r0 *1 1.405,2.565 sg13_lv_pmos
M$7 VDD B \$7 VDD sg13_lv_pmos L=0.13u W=0.84u AS=0.2891p AD=0.1596p PS=1.695u
+ PD=1.22u rfmode=0
* device instance $8 r0 *1 2.11,2.62 sg13_lv_pmos
M$8 VDD A \$8 VDD sg13_lv_pmos L=0.13u W=1.12u AS=0.2891p AD=0.1428p PS=1.695u
+ PD=1.375u rfmode=0
* device instance $9 r0 *1 2.495,2.62 sg13_lv_pmos
M$9 \$8 B Y VDD sg13_lv_pmos L=0.13u W=1.12u AS=0.1428p AD=0.2408p PS=1.375u
+ PD=1.55u rfmode=0
* device instance $10 r0 *1 3.055,2.62 sg13_lv_pmos
M$10 Y \$7 VDD VDD sg13_lv_pmos L=0.13u W=1.12u AS=0.2408p AD=0.3808p PS=1.55u
+ PD=2.92u rfmode=0
.ENDS sg13g2_xnor2_1

* cell sg13g2_nand4_1
* pin VDD
* pin A
* pin VSS
* pin Y
* pin B
* pin C
* pin D
.SUBCKT sg13g2_nand4_1 VDD A VSS Y B C D
* device instance $1 r0 *1 0.665,0.98 sg13_lv_nmos
M$1 VSS D \$10 VSS sg13_lv_nmos L=0.13u W=0.74u AS=0.2516p AD=0.1406p PS=2.16u
+ PD=1.12u rfmode=0
* device instance $2 r0 *1 1.175,0.98 sg13_lv_nmos
M$2 \$10 C \$9 VSS sg13_lv_nmos L=0.13u W=0.74u AS=0.1406p AD=0.1406p PS=1.12u
+ PD=1.12u rfmode=0
* device instance $3 r0 *1 1.685,0.98 sg13_lv_nmos
M$3 \$9 B \$8 VSS sg13_lv_nmos L=0.13u W=0.74u AS=0.1406p AD=0.1406p PS=1.12u
+ PD=1.12u rfmode=0
* device instance $4 r0 *1 2.195,0.98 sg13_lv_nmos
M$4 \$8 A Y VSS sg13_lv_nmos L=0.13u W=0.74u AS=0.1406p AD=0.2516p PS=1.12u
+ PD=2.16u rfmode=0
* device instance $5 r0 *1 0.665,2.69 sg13_lv_pmos
M$5 VDD D Y VDD sg13_lv_pmos L=0.13u W=1.12u AS=0.3808p AD=0.2128p PS=2.92u
+ PD=1.5u rfmode=0
* device instance $6 r0 *1 1.175,2.69 sg13_lv_pmos
M$6 Y C VDD VDD sg13_lv_pmos L=0.13u W=1.12u AS=0.2128p AD=0.2128p PS=1.5u
+ PD=1.5u rfmode=0
* device instance $7 r0 *1 1.685,2.69 sg13_lv_pmos
M$7 VDD B Y VDD sg13_lv_pmos L=0.13u W=1.12u AS=0.2128p AD=0.2128p PS=1.5u
+ PD=1.5u rfmode=0
* device instance $8 r0 *1 2.195,2.69 sg13_lv_pmos
M$8 Y A VDD VDD sg13_lv_pmos L=0.13u W=1.12u AS=0.2128p AD=0.3808p PS=1.5u
+ PD=2.92u rfmode=0
.ENDS sg13g2_nand4_1

* cell sg13g2_a21oi_1
* pin VDD
* pin Y
* pin VSS
* pin A2
* pin A1
* pin B1
.SUBCKT sg13g2_a21oi_1 VDD Y VSS A2 A1 B1
* device instance $1 r0 *1 0.71,1.07 sg13_lv_nmos
M$1 VSS B1 Y VSS sg13_lv_nmos L=0.13u W=0.74u AS=0.2516p AD=0.1406p PS=2.16u
+ PD=1.12u rfmode=0
* device instance $2 r0 *1 1.22,1.07 sg13_lv_nmos
M$2 Y A1 \$8 VSS sg13_lv_nmos L=0.13u W=0.74u AS=0.1406p AD=0.1406p PS=1.12u
+ PD=1.12u rfmode=0
* device instance $3 r0 *1 1.73,1.07 sg13_lv_nmos
M$3 \$8 A2 VSS VSS sg13_lv_nmos L=0.13u W=0.74u AS=0.1406p AD=0.2516p PS=1.12u
+ PD=2.16u rfmode=0
* device instance $4 r0 *1 0.71,2.62 sg13_lv_pmos
M$4 Y B1 \$4 VDD sg13_lv_pmos L=0.13u W=1.12u AS=0.3808p AD=0.2128p PS=2.92u
+ PD=1.5u rfmode=0
* device instance $5 r0 *1 1.22,2.62 sg13_lv_pmos
M$5 \$4 A1 VDD VDD sg13_lv_pmos L=0.13u W=1.12u AS=0.2128p AD=0.2128p PS=1.5u
+ PD=1.5u rfmode=0
* device instance $6 r0 *1 1.73,2.62 sg13_lv_pmos
M$6 VDD A2 \$4 VDD sg13_lv_pmos L=0.13u W=1.12u AS=0.2128p AD=0.3808p PS=1.5u
+ PD=2.92u rfmode=0
.ENDS sg13g2_a21oi_1

* cell sg13g2_nor3_1
* pin VDD
* pin VSS
* pin C
* pin Y
* pin B
* pin A
.SUBCKT sg13g2_nor3_1 VDD VSS C Y B A
* device instance $1 r0 *1 0.76,0.985 sg13_lv_nmos
M$1 VSS A Y VSS sg13_lv_nmos L=0.13u W=0.77u AS=0.2618p AD=0.1694p PS=2.22u
+ PD=1.21u rfmode=0
* device instance $2 r0 *1 1.33,0.985 sg13_lv_nmos
M$2 Y B VSS VSS sg13_lv_nmos L=0.13u W=0.77u AS=0.1694p AD=0.1463p PS=1.21u
+ PD=1.15u rfmode=0
* device instance $3 r0 *1 1.84,0.985 sg13_lv_nmos
M$3 VSS C Y VSS sg13_lv_nmos L=0.13u W=0.77u AS=0.1463p AD=0.2618p PS=1.15u
+ PD=2.22u rfmode=0
* device instance $4 r0 *1 0.76,2.62 sg13_lv_pmos
M$4 VDD A \$8 VDD sg13_lv_pmos L=0.13u W=1.12u AS=0.3808p AD=0.2464p PS=2.92u
+ PD=1.56u rfmode=0
* device instance $5 r0 *1 1.33,2.62 sg13_lv_pmos
M$5 \$8 B \$7 VDD sg13_lv_pmos L=0.13u W=1.12u AS=0.2464p AD=0.2128p PS=1.56u
+ PD=1.5u rfmode=0
* device instance $6 r0 *1 1.84,2.62 sg13_lv_pmos
M$6 \$7 C Y VDD sg13_lv_pmos L=0.13u W=1.12u AS=0.2128p AD=0.3808p PS=1.5u
+ PD=2.92u rfmode=0
.ENDS sg13g2_nor3_1

* cell sg13g2_o21ai_1
* pin VSS
* pin Y
* pin VDD
* pin B1
* pin A2
* pin A1
.SUBCKT sg13g2_o21ai_1 VSS Y VDD B1 A2 A1
* device instance $1 r0 *1 0.525,0.92 sg13_lv_nmos
M$1 \$2 A1 VSS VSS sg13_lv_nmos L=0.15u W=0.74u AS=0.2516p AD=0.1406p PS=2.16u
+ PD=1.12u rfmode=0
* device instance $2 r0 *1 1.055,0.92 sg13_lv_nmos
M$2 VSS A2 \$2 VSS sg13_lv_nmos L=0.15u W=0.74u AS=0.1406p AD=0.1406p PS=1.12u
+ PD=1.12u rfmode=0
* device instance $3 r0 *1 1.585,0.92 sg13_lv_nmos
M$3 \$2 B1 Y VSS sg13_lv_nmos L=0.15u W=0.74u AS=0.1406p AD=0.2516p PS=1.12u
+ PD=2.16u rfmode=0
* device instance $4 r0 *1 0.525,2.72 sg13_lv_pmos
M$4 VDD A1 \$8 VDD sg13_lv_pmos L=0.15u W=1.12u AS=0.3808p AD=0.2128p PS=2.92u
+ PD=1.5u rfmode=0
* device instance $5 r0 *1 1.055,2.72 sg13_lv_pmos
M$5 \$8 A2 Y VDD sg13_lv_pmos L=0.15u W=1.12u AS=0.2128p AD=0.2128p PS=1.5u
+ PD=1.5u rfmode=0
* device instance $6 r0 *1 1.585,2.72 sg13_lv_pmos
M$6 Y B1 VDD VDD sg13_lv_pmos L=0.15u W=1.12u AS=0.2128p AD=0.3808p PS=1.5u
+ PD=2.92u rfmode=0
.ENDS sg13g2_o21ai_1

* cell sg13g2_a22oi_1
* pin Y
* pin VSS
* pin VDD
* pin A2
* pin B2
* pin B1
* pin A1
.SUBCKT sg13g2_a22oi_1 Y VSS VDD A2 B2 B1 A1
* device instance $1 r0 *1 0.57,0.85 sg13_lv_nmos
M$1 VSS B1 \$10 VSS sg13_lv_nmos L=0.13u W=0.74u AS=0.2553p AD=0.13875p
+ PS=2.17u PD=1.115u rfmode=0
* device instance $2 r0 *1 1.075,0.85 sg13_lv_nmos
M$2 \$10 B2 Y VSS sg13_lv_nmos L=0.13u W=0.74u AS=0.13875p AD=0.2664p PS=1.115u
+ PD=1.46u rfmode=0
* device instance $3 r0 *1 1.925,0.85 sg13_lv_nmos
M$3 Y A1 \$9 VSS sg13_lv_nmos L=0.13u W=0.74u AS=0.2664p AD=0.0962p PS=1.46u
+ PD=1u rfmode=0
* device instance $4 r0 *1 2.315,0.85 sg13_lv_nmos
M$4 \$9 A2 VSS VSS sg13_lv_nmos L=0.13u W=0.74u AS=0.0962p AD=0.2516p PS=1u
+ PD=2.16u rfmode=0
* device instance $5 r0 *1 0.57,2.74 sg13_lv_pmos
M$5 VDD A1 \$5 VDD sg13_lv_pmos L=0.13u W=1.12u AS=0.3808p AD=0.2716p PS=2.92u
+ PD=1.605u rfmode=0
* device instance $6 r0 *1 1.185,2.74 sg13_lv_pmos
M$6 \$5 B1 Y VDD sg13_lv_pmos L=0.13u W=1.12u AS=0.2716p AD=0.2128p PS=1.605u
+ PD=1.5u rfmode=0
* device instance $7 r0 *1 1.695,2.74 sg13_lv_pmos
M$7 Y B2 \$5 VDD sg13_lv_pmos L=0.13u W=1.12u AS=0.2128p AD=0.2744p PS=1.5u
+ PD=1.61u rfmode=0
* device instance $8 r0 *1 2.315,2.74 sg13_lv_pmos
M$8 \$5 A2 VDD VDD sg13_lv_pmos L=0.13u W=1.12u AS=0.2744p AD=0.3808p PS=1.61u
+ PD=2.92u rfmode=0
.ENDS sg13g2_a22oi_1

* cell sg13g2_nand2b_1
* pin VDD
* pin VSS
* pin B
* pin A_N
* pin Y
.SUBCKT sg13g2_nand2b_1 VDD VSS B A_N Y
* device instance $1 r0 *1 0.54,1.055 sg13_lv_nmos
M$1 VSS A_N \$6 VSS sg13_lv_nmos L=0.13u W=0.55u AS=0.14505p AD=0.187p PS=1.15u
+ PD=1.78u rfmode=0
* device instance $2 r0 *1 1.08,0.96 sg13_lv_nmos
M$2 VSS B \$7 VSS sg13_lv_nmos L=0.13u W=0.74u AS=0.14505p AD=0.1406p PS=1.15u
+ PD=1.12u rfmode=0
* device instance $3 r0 *1 1.59,0.96 sg13_lv_nmos
M$3 \$7 \$6 Y VSS sg13_lv_nmos L=0.13u W=0.74u AS=0.1406p AD=0.333p PS=1.12u
+ PD=2.38u rfmode=0
* device instance $4 r0 *1 0.54,2.48 sg13_lv_pmos
M$4 \$6 A_N VDD VDD sg13_lv_pmos L=0.13u W=0.84u AS=0.2856p AD=0.2198p PS=2.36u
+ PD=1.53u rfmode=0
* device instance $5 r0 *1 1.08,2.62 sg13_lv_pmos
M$5 VDD B Y VDD sg13_lv_pmos L=0.13u W=1.12u AS=0.2198p AD=0.2128p PS=1.53u
+ PD=1.5u rfmode=0
* device instance $6 r0 *1 1.59,2.62 sg13_lv_pmos
M$6 Y \$6 VDD VDD sg13_lv_pmos L=0.13u W=1.12u AS=0.2128p AD=0.3808p PS=1.5u
+ PD=2.92u rfmode=0
.ENDS sg13g2_nand2b_1

* cell sg13g2_nor2_1
* pin VDD
* pin VSS
* pin B
* pin A
* pin Y
.SUBCKT sg13g2_nor2_1 VDD VSS B A Y
* device instance $1 r0 *1 0.785,0.96 sg13_lv_nmos
M$1 VSS A Y VSS sg13_lv_nmos L=0.13u W=0.74u AS=0.2516p AD=0.1406p PS=2.16u
+ PD=1.12u rfmode=0
* device instance $2 r0 *1 1.295,0.96 sg13_lv_nmos
M$2 Y B VSS VSS sg13_lv_nmos L=0.13u W=0.74u AS=0.1406p AD=0.2516p PS=1.12u
+ PD=2.16u rfmode=0
* device instance $3 r0 *1 0.785,2.62 sg13_lv_pmos
M$3 VDD A \$6 VDD sg13_lv_pmos L=0.13u W=1.12u AS=0.4032p AD=0.1176p PS=2.96u
+ PD=1.33u rfmode=0
* device instance $4 r0 *1 1.125,2.62 sg13_lv_pmos
M$4 \$6 B Y VDD sg13_lv_pmos L=0.13u W=1.12u AS=0.1176p AD=0.3808p PS=1.33u
+ PD=2.92u rfmode=0
.ENDS sg13g2_nor2_1

* cell sg13g2_nand2_1
* pin VDD
* pin VSS
* pin Y
* pin A
* pin B
.SUBCKT sg13g2_nand2_1 VDD VSS Y A B
* device instance $1 r0 *1 0.705,0.96 sg13_lv_nmos
M$1 VSS B \$6 VSS sg13_lv_nmos L=0.13u W=0.74u AS=0.2516p AD=0.1406p PS=2.16u
+ PD=1.12u rfmode=0
* device instance $2 r0 *1 1.215,0.96 sg13_lv_nmos
M$2 \$6 A Y VSS sg13_lv_nmos L=0.13u W=0.74u AS=0.1406p AD=0.2516p PS=1.12u
+ PD=2.16u rfmode=0
* device instance $3 r0 *1 0.705,2.62 sg13_lv_pmos
M$3 VDD B Y VDD sg13_lv_pmos L=0.13u W=1.12u AS=0.3808p AD=0.2128p PS=2.92u
+ PD=1.5u rfmode=0
* device instance $4 r0 *1 1.215,2.62 sg13_lv_pmos
M$4 Y A VDD VDD sg13_lv_pmos L=0.13u W=1.12u AS=0.2128p AD=0.3808p PS=1.5u
+ PD=2.92u rfmode=0
.ENDS sg13g2_nand2_1

* cell sg13g2_inv_1
* pin VDD
* pin VSS
* pin A
* pin Y
.SUBCKT sg13g2_inv_1 VDD VSS A Y
* device instance $1 r0 *1 0.715,0.96 sg13_lv_nmos
M$1 VSS A Y VSS sg13_lv_nmos L=0.13u W=0.74u AS=0.2516p AD=0.2516p PS=2.16u
+ PD=2.16u rfmode=0
* device instance $2 r0 *1 0.715,2.635 sg13_lv_pmos
M$2 VDD A Y VDD sg13_lv_pmos L=0.13u W=1.12u AS=0.3808p AD=0.3808p PS=2.92u
+ PD=2.92u rfmode=0
.ENDS sg13g2_inv_1

* cell sg13g2_decap_4
* pin VDD
* pin VSS
.SUBCKT sg13g2_decap_4 VDD VSS
* device instance $1 r0 *1 0.96,0.855 sg13_lv_nmos
M$1 VSS VDD VSS VSS sg13_lv_nmos L=1u W=0.42u AS=0.1428p AD=0.1428p PS=1.52u
+ PD=1.52u rfmode=0
* device instance $2 r0 *1 0.96,2.68 sg13_lv_pmos
M$2 VDD VSS VDD VDD sg13_lv_pmos L=1u W=1u AS=0.34p AD=0.34p PS=2.68u PD=2.68u
+ rfmode=0
.ENDS sg13g2_decap_4

* cell sg13g2_decap_8
* pin VDD
* pin VSS
.SUBCKT sg13g2_decap_8 VDD VSS
* device instance $1 r0 *1 0.995,0.86 sg13_lv_nmos
M$1 VSS VDD VSS VSS sg13_lv_nmos L=1u W=0.84u AS=0.2226p AD=0.2226p PS=2.32u
+ PD=2.32u rfmode=0
* device instance $3 r0 *1 1.005,2.685 sg13_lv_pmos
M$3 VDD VSS VDD VDD sg13_lv_pmos L=1u W=2u AS=0.53p AD=0.53p PS=4.06u PD=4.06u
+ rfmode=0
.ENDS sg13g2_decap_8
