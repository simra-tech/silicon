* no_fill grounded drive P; diagnostic capacitor-network AC only
C14 0 N 4.2094100000000001e-16
C21 0 P 1.7186200000000001e-16
C36 0 N 7.5519000000000015e-16
C50 0 P 2.94672e-17
C66 0 N 3.4678400000000008e-17
C82 0 P 4.2430100000000002e-18
C94 0 N 9.1250900000000002e-17
C110 0 P 8.4215900000000014e-17
C118 0 P 2.5971700000000003e-18
C122 0 N 1.1109800000000002e-19
C134 0 N 3.0026200000000004e-17
C136 0 P 4.5392500000000002e-17
C153 0 P 1.2846200000000001e-18
C157 0 N 3.8936900000000001e-17
C164 0 P 9.0360700000000016e-18
C176 0 N 2.6562100000000001e-17
C193 0 P 5.1457900000000004e-17
C199 0 N 7.9999000000000001e-17
C215 0 P 1.2731600000000002e-16
C220 0 N 5.0724699999999999e-17
C227 0 P 1.55918e-17
C233 0 N 4.0606000000000007e-17
C240 0 P 1.5622000000000002e-17
C262 0 P 2.0065400000000001e-17
C276 0 P 2.98397e-17
C301 0 N 2.6446300000000002e-18
C314 0 P 1.0038200000000001e-19
C316 N 0 4.0641100000000005e-16
C317 N 0 2.27029e-16
C318 N 0 2.20457e-19
C319 N 0 3.0892600000000002e-17
C320 N 0 2.4110400000000001e-17
C321 N 0 8.0608000000000007e-17
C322 N P 5.2025600000000007e-15
C323 N 0 1.5126100000000001e-15
C376 0 P 4.0914500000000007e-18
C384 0 P 5.7082699999999999e-18
C396 0 P 7.7499700000000004e-18
C407 0 P 7.2886000000000005e-17
C412 0 P 1.3229e-16
C419 0 P 1.6010000000000003e-17
C425 0 P 1.6010000000000003e-17
C431 0 P 2.16834e-17
C449 0 P 1.21025e-14
C451 0 P 1.3623699999999999e-16
C453 P 0 1.01264e-15
VP P 0 DC 0 AC 1
VN N 0 DC 0 AC 0
.control
set numdgt=17
ac lin 1 1Meg 1Meg
let cp = -imag(i(VP))/(2*pi*1e6)
let cn = -imag(i(VN))/(2*pi*1e6)
print cp cn
quit
.endc
.end
