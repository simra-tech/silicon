* no_fill grounded drive P; diagnostic capacitor-network AC only
C14 0 N 4.2733300000000004e-16
C21 0 P 1.7174000000000003e-16
C36 0 N 7.5679800000000006e-16
C50 0 P 2.94672e-17
C66 0 N 3.4618000000000005e-17
C82 0 P 4.1744399999999996e-18
C94 0 N 9.1439700000000005e-17
C110 0 P 8.4220500000000012e-17
C118 0 P 2.5971700000000003e-18
C122 0 N 1.1109800000000002e-19
C134 0 N 3.1331700000000004e-17
C136 0 P 4.5279700000000004e-17
C153 0 P 1.2846200000000001e-18
C157 0 N 3.9412600000000002e-17
C164 0 P 9.0382400000000007e-18
C176 0 N 2.7980200000000002e-17
C193 0 P 5.1457900000000004e-17
C199 0 N 8.7087600000000002e-17
C215 0 P 1.27181e-16
C220 0 N 5.12639e-17
C227 0 P 1.55918e-17
C233 0 N 4.0606000000000007e-17
C240 0 P 1.5622000000000002e-17
C262 0 P 2.0065400000000001e-17
C269 0 N 1.3288100000000001e-19
C277 0 P 2.98397e-17
C302 0 N 4.5502500000000001e-18
C315 0 P 1.0038200000000001e-19
C317 N 0 4.0641100000000005e-16
C318 N 0 2.27029e-16
C319 N 0 2.20457e-19
C320 N 0 3.2414000000000006e-17
C321 N 0 2.7279900000000002e-17
C322 N 0 8.3363800000000006e-17
C323 N P 5.2537300000000003e-15
C324 N 0 1.5741500000000001e-15
C377 0 P 4.0914500000000007e-18
C385 0 P 5.7082699999999999e-18
C397 0 P 7.7499700000000004e-18
C408 0 P 7.2886000000000005e-17
C413 0 P 1.3229e-16
C420 0 P 1.6010000000000003e-17
C426 0 P 1.6010000000000003e-17
C432 0 P 2.16834e-17
C450 0 P 1.21025e-14
C452 0 P 1.36183e-16
C454 P 0 1.01243e-15
VP P 0 DC 0 AC 1
VN N 0 DC 0 AC 0
.control
set numdgt=17
ac lin 1 1Meg 1Meg
let cp = -imag(i(VP))/(2*pi*1e6)
let cn = -imag(i(VN))/(2*pi*1e6)
print cp cn
quit
.endc
.end
