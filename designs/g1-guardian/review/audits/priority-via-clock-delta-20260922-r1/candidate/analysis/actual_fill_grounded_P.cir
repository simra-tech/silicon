* actual_fill grounded drive P; diagnostic capacitor-network AC only
C13 0 N 3.7352300000000005e-16
C142 0 P 1.6849000000000003e-16
C171 0 N 7.5679800000000006e-16
C211 0 P 2.8850100000000003e-17
C227 0 N 3.2527200000000001e-17
C319 0 P 1.1550400000000001e-18
C331 0 N 8.3993800000000004e-17
C426 0 P 8.4114000000000007e-17
C453 0 P 2.3391700000000002e-18
C457 0 N 1.1109800000000002e-19
C508 0 N 2.32427e-17
C572 0 P 3.8907600000000007e-17
C614 0 P 1.2053100000000002e-18
C618 0 N 3.7657900000000001e-17
C672 0 P 9.0382400000000007e-18
C684 0 N 2.6576000000000001e-17
C788 0 P 5.1236000000000001e-17
C794 0 N 5.3647300000000006e-17
C883 0 P 1.0741600000000001e-16
C888 0 N 4.45263e-17
C941 0 P 1.5471200000000001e-17
C947 0 N 2.3292500000000001e-17
C1003 0 P 1.5571700000000002e-17
C1065 0 P 1.9836600000000001e-17
C1072 0 N 1.3288100000000001e-19
C1133 0 P 2.6109400000000004e-17
C1187 0 N 4.5502500000000001e-18
C1220 0 P 1.0038200000000001e-19
C1222 N 0 4.0591800000000001e-16
C1223 N 0 2.27029e-16
C1224 N 0 2.20457e-19
C1225 N 0 3.0707100000000002e-17
C1226 N 0 2.7213600000000001e-17
C1227 N 0 6.3273500000000002e-17
C1228 N 0 4.8415300000000002e-19
C1229 N 0 1.6145900000000003e-17
C1230 N 0 1.9980199999999999e-18
C1231 N 0 1.06939e-16
C1232 N 0 3.2404300000000004e-16
C1233 N 0 5.4091600000000007e-18
C1234 N 0 7.1383800000000004e-19
C1235 N 0 9.9145500000000009e-18
C1236 N 0 2.35818e-19
C1237 N 0 9.6007399999999998e-19
C1238 N 0 1.0010300000000001e-17
C1239 N 0 9.9396600000000006e-18
C1240 N 0 1.2552200000000001e-18
C1241 N 0 5.6099900000000005e-18
C1242 N 0 9.369080000000001e-18
C1243 N 0 9.9647600000000006e-18
C1244 N 0 7.4735700000000008e-18
C1245 N 0 6.0914400000000011e-18
C1246 N 0 1.1098200000000002e-17
C1247 N 0 6.1522000000000003e-18
C1248 N 0 5.1024000000000007e-18
C1249 N 0 4.3594600000000008e-18
C1250 N 0 4.3594600000000008e-18
C1251 N 0 1.99765e-16
C1252 N 0 1.8961400000000001e-16
C1253 N 0 6.4560799999999999e-17
C1254 N 0 1.3486700000000002e-17
C1255 N 0 8.38576e-18
C1256 N 0 1.3258900000000001e-17
C1257 N 0 1.3105700000000001e-17
C1258 N 0 2.2140600000000001e-17
C1259 N 0 1.9833200000000001e-19
C1260 N 0 1.6070500000000002e-18
C1261 N 0 1.23957e-19
C1262 N 0 1.6070500000000002e-18
C1263 N 0 2.0659600000000002e-19
C1264 N 0 1.6070500000000002e-18
C1265 N 0 2.0235000000000002e-19
C1266 N 0 5.06222e-19
C1267 N 0 5.8904000000000003e-19
C1268 N 0 5.2380000000000006e-17
C1269 N 0 1.53463e-17
C1270 N 0 9.8265900000000003e-17
C1271 N 0 2.8374e-17
C1272 N 0 9.8265900000000003e-17
C1273 N 0 9.8265900000000003e-17
C1274 N 0 2.8268299999999999e-17
C1275 N 0 9.8265900000000003e-17
C1276 N 0 9.8265900000000003e-17
C1277 N 0 2.8268299999999999e-17
C1278 N 0 9.8265900000000003e-17
C1279 N 0 1.0069900000000001e-16
C1280 N 0 4.2291800000000008e-17
C1281 N 0 7.57269e-18
C1282 N 0 1.1808400000000001e-16
C1283 N 0 1.9213100000000002e-16
C1284 N 0 1.0249800000000002e-16
C1285 N 0 4.7775400000000009e-19
C1286 N 0 7.6799600000000002e-18
C1287 N 0 1.0568400000000001e-18
C1288 N 0 1.6102600000000001e-18
C1289 N 0 1.1307500000000002e-16
C1290 N 0 3.8098600000000003e-18
C1291 N 0 5.5014100000000008e-19
C1292 N 0 5.5014100000000008e-19
C1293 N 0 4.4929300000000004e-19
C1294 N 0 5.5014100000000008e-19
C1295 N 0 4.1260599999999998e-19
C1296 N 0 4.4929300000000004e-19
C1297 N 0 2.87373e-19
C1298 N 0 1.153e-17
C1299 N 0 2.9233400000000002e-18
C1300 N 0 3.2205200000000002e-18
C1301 N 0 1.6102600000000001e-18
C1302 N P 5.2537300000000003e-15
C1303 N 0 9.2783299999999998e-16
C1430 0 P 4.0914500000000007e-18
C1454 0 P 5.7082699999999999e-18
C1489 0 P 7.7499700000000004e-18
C1531 0 P 7.2795599999999998e-17
C1556 0 P 1.3229e-16
C1584 0 P 1.6010000000000003e-17
C1609 0 P 1.6010000000000003e-17
C1635 0 P 2.16834e-17
C1914 0 P 1.21025e-14
C2030 0 P 1.3437600000000001e-16
C2052 0 P 3.6219899999999999e-18
C2065 0 P 5.3264600000000004e-18
C2088 0 P 5.3264600000000004e-18
C2096 0 P 8.9643700000000014e-19
C2115 0 P 4.9536000000000004e-18
C2124 0 P 8.6552600000000005e-19
C2134 0 P 4.7838700000000008e-19
C2154 0 P 9.8917200000000009e-19
C2161 0 P 4.5547300000000009e-18
C2195 0 P 5.2655800000000004e-18
C2203 0 P 1.00978e-18
C2235 0 P 1.03039e-18
C2240 0 P 1.0374000000000001e-19
C2254 0 P 1.03039e-18
C2266 0 P 5.1998600000000002e-19
C2290 0 P 1.03039e-18
C2301 0 P 7.727910000000001e-19
C2312 0 P 5.1998600000000002e-19
C2328 0 P 3.8978600000000003e-19
C2372 0 P 1.26457e-18
C2412 0 P 3.6374899999999999e-17
C2438 0 P 5.0775300000000004e-17
C2449 0 P 2.3091400000000004e-18
C2468 0 P 6.8224500000000005e-17
C2479 0 P 6.8083800000000004e-18
C2511 0 P 2.9049800000000004e-17
C2522 0 P 1.77481e-19
C2557 0 P 5.3264600000000004e-18
C2591 0 P 4.0664800000000004e-18
C2623 0 P 8.7924000000000011e-18
C2635 0 P 2.8873199999999999e-18
C2652 0 P 2.8873199999999999e-18
C2661 0 P 2.8873199999999999e-18
C2676 0 P 2.8873199999999999e-18
C2698 0 P 2.8873199999999999e-18
C2726 0 P 2.8873199999999999e-18
C2747 0 P 5.0628200000000008e-19
C2757 0 P 2.8873199999999999e-18
C2763 0 P 2.5314100000000004e-19
C2783 0 P 2.8873199999999999e-18
C2790 0 P 2.34989e-18
C2800 0 P 2.8873199999999999e-18
C2813 0 P 2.4807800000000001e-19
C2818 0 P 1.8226100000000003e-19
C2823 0 P 1.2657e-19
C2828 0 P 2.8873199999999999e-18
C2848 0 P 5.0628200000000008e-19
C2851 0 P 2.8873199999999999e-18
C2858 0 P 5.0331300000000003e-17
C2879 0 P 4.4039900000000009e-17
C2957 0 P 2.1894100000000004e-17
C2965 0 P 5.0331300000000003e-17
C2973 0 P 2.4862500000000002e-17
C2982 0 P 5.0331300000000003e-17
C2987 0 P 5.0331300000000003e-17
C2995 0 P 2.4862500000000002e-17
C3004 0 P 7.0913500000000004e-18
C3111 0 P 2.1581300000000001e-18
C3146 0 P 1.0245300000000001e-19
C3169 0 P 1.0245300000000001e-19
C3222 0 P 1.8082000000000001e-18
C3226 0 P 1.3216900000000001e-18
C3243 0 P 2.0783900000000003e-18
C3247 0 P 1.93149e-18
C3262 0 P 2.03089e-18
C3269 0 P 1.7548900000000001e-18
C3279 0 P 3.9457500000000003e-19
C3296 0 P 1.3984600000000002e-18
C3302 0 P 2.49407e-19
C3307 P 0 7.1703500000000002e-16
VP P 0 DC 0 AC 1
VN N 0 DC 0 AC 0
.control
set numdgt=17
ac lin 1 1Meg 1Meg
let cp = -imag(i(VP))/(2*pi*1e6)
let cn = -imag(i(VN))/(2*pi*1e6)
print cp cn
quit
.endc
.end
