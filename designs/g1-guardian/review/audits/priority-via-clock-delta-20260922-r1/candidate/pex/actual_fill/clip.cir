* cell sense_fill_clip
.SUBCKT sense_fill_clip
* net 2 CTX_L10_0,CTX_L30_18,CTX_L50_1,CTX_L8_0
* net 3 FILL_L8_0
* net 4 FILL_L10_0
* net 5 FILL_L50_4
* net 6 FILL_L67_5
* net 7 FILL_L30_0
* net 8 FILL_L8_1
* net 9 FILL_L67_6
* net 10 FILL_L50_5
* net 11 FILL_L30_3
* net 12 FILL_L8_2
* net 13 FILL_L10_1
* net 14 FILL_L67_0
* net 15 FILL_L30_1
* net 16 FILL_L50_0
* net 17 FILL_L67_1
* net 18 FILL_L10_2
* net 19 FILL_L67_2
* net 20 FILL_L50_1
* net 21 FILL_L10_3
* net 22 FILL_L8_3
* net 23 FILL_L10_4
* net 24 FILL_L50_2
* net 25 FILL_L67_3
* net 26 FILL_L10_5
* net 27 FILL_L50_3
* net 28 FILL_L67_4
* net 29 FILL_L8_4
* net 30 FILL_L10_6
* net 31 FILL_L10_7
* net 32 FILL_L8_6
* net 33 FILL_L30_2
* net 34 FILL_L8_7
* net 35 FILL_L8_5
* net 36 FILL_L8_8
* net 37 FILL_L10_8
* net 38 FILL_L30_4
* net 39 FILL_L67_7
* net 40 FILL_L67_8
* net 41 FILL_L30_5
* net 42 CTX_L10_3,CTX_L30_1
* net 43 CTX_L10_1,CTX_L10_4,CTX_L30_2
* net 44 CTX_L10_2,CTX_L30_0
* net 45 FILL_L10_9
* net 46 FILL_L8_10
* net 47 FILL_L30_6
* net 48 FILL_L67_9
* net 49 FILL_L50_6
* net 50 CTX_L126_0,CTX_L30_8,CTX_L50_0,CTX_L67_0
* net 51 FILL_L8_11
* net 52 FILL_L67_10
* net 53 FILL_L30_7
* net 54 FILL_L50_7
* net 55 FILL_L8_9
* net 56 FILL_L10_10
* net 57 FILL_L67_11
* net 58 FILL_L30_8
* net 59 CTX_L10_6,CTX_L30_4
* net 60 FILL_L50_10
* net 61 FILL_L67_13
* net 62 FILL_L30_9
* net 63 FILL_L30_10
* net 64 FILL_L50_8
* net 65 FILL_L134_0
* net 66 FILL_L67_14
* net 67 FILL_L30_11
* net 68 FILL_L50_9
* net 69 FILL_L8_13
* net 70 FILL_L8_12
* net 71 FILL_L67_12
* net 72 FILL_L30_12
* net 73 CTX_L10_7,CTX_L30_11,CTX_L8_1
* net 74 FILL_L10_11
* net 75 FILL_L8_14
* net 76 CTX_L10_5,CTX_L30_3
* net 77 FILL_L8_15
* net 78 FILL_L50_11
* net 79 FILL_L30_13
* net 80 FILL_L8_16
* net 81 FILL_L10_12
* net 82 FILL_L30_14
* net 83 FILL_L67_15
* net 84 CTX_L30_5,CTX_L50_14
* net 85 FILL_L30_15
* net 86 FILL_L8_19
* net 87 FILL_L10_14
* net 88 FILL_L50_12
* net 89 FILL_L8_20
* net 90 CTX_L30_20,CTX_L30_6,N
* net 91 FILL_L67_16
* net 92 FILL_L8_17
* net 93 FILL_L10_15
* net 94 FILL_L67_20
* net 95 FILL_L50_13
* net 96 FILL_L10_13
* net 97 FILL_L8_22
* net 98 FILL_L10_17
* net 99 FILL_L50_15
* net 100 FILL_L67_21
* net 101 FILL_L10_18
* net 102 FILL_L67_22
* net 103 FILL_L50_16
* net 104 FILL_L8_18
* net 105 FILL_L67_17
* net 106 CTX_L30_9,CTX_L50_11
* net 107 CTX_L30_7,CTX_L50_17
* net 108 FILL_L67_18
* net 109 FILL_L67_19
* net 110 FILL_L8_21
* net 111 FILL_L30_17
* net 112 CTX_L8_2
* net 113 FILL_L50_14
* net 114 FILL_L10_16
* net 115 FILL_L30_16
* net 116 FILL_L30_19
* net 117 FILL_L8_23
* net 118 FILL_L8_28
* net 119 FILL_L10_22
* net 120 CTX_L126_1,CTX_L30_10,CTX_L50_2,CTX_L67_1
* net 121 FILL_L8_29
* net 122 FILL_L30_20
* net 123 FILL_L8_24
* net 124 FILL_L10_23
* net 125 FILL_L30_21
* net 126 CTX_L134_0
* net 127 FILL_L10_19
* net 128 FILL_L8_25
* net 129 FILL_L10_20
* net 130 FILL_L8_26
* net 131 FILL_L10_21
* net 132 FILL_L30_18
* net 133 FILL_L126_0
* net 134 FILL_L10_25
* net 135 FILL_L8_27
* net 136 FILL_L67_23
* net 137 FILL_L8_30
* net 138 FILL_L67_24
* net 139 FILL_L10_24
* net 140 FILL_L67_25
* net 141 FILL_L30_22
* net 142 FILL_L67_26
* net 143 FILL_L30_24
* net 144 FILL_L8_32
* net 145 FILL_L10_26
* net 146 CTX_L30_13
* net 147 CTX_L30_12,CTX_L30_22,CTX_L50_4
* net 148 FILL_L8_33
* net 149 FILL_L8_31
* net 150 CTX_L10_12,CTX_L10_8,CTX_L30_14
* net 151 FILL_L30_23
* net 152 FILL_L10_27
* net 153 FILL_L67_27
* net 154 FILL_L67_28
* net 155 FILL_L8_34
* net 156 FILL_L67_29
* net 157 CTX_L134_1
* net 158 FILL_L50_17
* net 159 FILL_L8_35
* net 160 FILL_L8_36
* net 161 FILL_L50_19
* net 162 FILL_L67_30
* net 163 FILL_L8_37
* net 164 FILL_L8_38
* net 165 FILL_L67_31
* net 166 FILL_L50_20
* net 167 FILL_L8_39
* net 168 FILL_L8_42
* net 169 FILL_L10_28
* net 170 FILL_L8_43
* net 171 CTX_L10_11
* net 172 FILL_L30_26
* net 173 FILL_L8_40
* net 174 FILL_L30_27
* net 175 CTX_L50_21
* net 176 CTX_L50_22
* net 177 P
* net 178 FILL_L50_18
* net 179 FILL_L8_41
* net 180 FILL_L10_29
* net 181 FILL_L8_46
* net 182 FILL_L10_32
* net 183 FILL_L30_25
* net 184 FILL_L8_47
* net 185 FILL_L10_33
* net 186 FILL_L30_29
* net 187 FILL_L10_30
* net 188 FILL_L67_32
* net 189 CTX_L30_16
* net 190 CTX_L30_15
* net 191 FILL_L67_33
* net 192 FILL_L30_30
* net 193 FILL_L8_44
* net 194 FILL_L30_31
* net 195 FILL_L67_34
* net 196 FILL_L50_21
* net 197 FILL_L10_31
* net 198 FILL_L8_45
* net 199 FILL_L67_35
* net 200 FILL_L50_23
* net 201 FILL_L30_28
* net 202 FILL_L50_24
* net 203 FILL_L67_36
* net 204 FILL_L8_50
* net 205 FILL_L10_34
* net 206 FILL_L10_36
* net 207 CTX_L30_17
* net 208 FILL_L8_51
* net 209 FILL_L30_32
* net 210 FILL_L30_33
* net 211 FILL_L8_52
* net 212 FILL_L8_48
* net 213 FILL_L50_25
* net 214 FILL_L50_22
* net 215 FILL_L8_49
* net 216 FILL_L8_53
* net 217 FILL_L10_37
* net 218 FILL_L10_35
* net 219 FILL_L8_54
* net 220 FILL_L10_38
* net 221 FILL_L8_55
* net 222 FILL_L10_39
* net 223 FILL_L8_62
* net 224 FILL_L10_40
* net 225 FILL_L10_46
* net 226 FILL_L67_37
* net 227 FILL_L8_63
* net 228 FILL_L67_38
* net 229 FILL_L8_56
* net 230 FILL_L8_64
* net 231 FILL_L67_39
* net 232 FILL_L50_26
* net 233 FILL_L10_47
* net 234 FILL_L10_41
* net 235 FILL_L8_57
* net 236 FILL_L10_48
* net 237 FILL_L8_58
* net 238 FILL_L10_42
* net 239 FILL_L67_40
* net 240 FILL_L50_27
* net 241 FILL_L10_49
* net 242 FILL_L10_43
* net 243 FILL_L8_59
* net 244 FILL_L10_50
* net 245 FILL_L8_60
* net 246 FILL_L10_44
* net 247 FILL_L50_28
* net 248 FILL_L67_41
* net 249 FILL_L10_51
* net 250 FILL_L10_45
* net 251 FILL_L8_61
* net 252 CTX_L30_19,CTX_L50_18
* net 253 CTX_L10_10,CTX_L30_21
* net 254 CTX_L126_2,CTX_L134_2
* net 255 FILL_L50_29
* net 256 FILL_L8_65
* net 257 FILL_L67_42
* net 258 CTX_L30_23,CTX_L50_15
* net 259 FILL_L8_66
* net 260 FILL_L67_43
* net 261 FILL_L8_67
* net 262 FILL_L67_44
* net 263 FILL_L50_30
* net 264 FILL_L10_52
* net 265 FILL_L8_68
* net 266 FILL_L50_31
* net 267 FILL_L67_45
* net 268 FILL_L10_53
* net 269 FILL_L8_69
* net 270 FILL_L67_46
* net 271 FILL_L50_32
* net 272 FILL_L10_54
* net 273 FILL_L8_70
* net 274 FILL_L30_34
* net 275 FILL_L30_35
* net 276 FILL_L30_36
* net 277 FILL_L30_37
* net 278 FILL_L30_38
* net 279 FILL_L50_33
* net 280 FILL_L30_39
* net 281 FILL_L30_40
* net 282 FILL_L30_41
* net 283 FILL_L8_71
* net 284 FILL_L8_77
* net 285 FILL_L67_47
* net 286 CTX_L30_24,CTX_L50_10
* net 287 FILL_L8_78
* net 288 FILL_L8_72
* net 289 FILL_L67_48
* net 290 FILL_L30_42
* net 291 FILL_L8_79
* net 292 FILL_L8_73
* net 293 FILL_L67_49
* net 294 FILL_L50_34
* net 295 FILL_L10_58
* net 296 FILL_L8_80
* net 297 FILL_L8_74
* net 298 FILL_L10_55
* net 299 FILL_L50_35
* net 300 FILL_L67_50
* net 301 FILL_L8_81
* net 302 FILL_L10_59
* net 303 FILL_L8_75
* net 304 FILL_L10_56
* net 305 FILL_L67_51
* net 306 FILL_L50_36
* net 307 FILL_L10_57
* net 308 FILL_L10_60
* net 309 FILL_L8_76
* net 310 FILL_L8_82
* net 311 CTX_L30_27
* net 312 CTX_L30_26,CTX_L50_5,CTX_L50_9,CTX_L67_2
* net 313 FILL_L30_43
* net 314 FILL_L67_52
* net 315 FILL_L67_54
* net 316 CTX_L30_28,CTX_L50_27
* net 317 FILL_L67_55
* net 318 FILL_L50_37
* net 319 FILL_L50_39
* net 320 FILL_L67_56
* net 321 FILL_L67_53
* net 322 FILL_L8_83
* net 323 CTX_L30_31,CTX_L50_25
* net 324 CTX_L30_29,CTX_L50_26
* net 325 FILL_L8_84
* net 326 FILL_L10_61
* net 327 FILL_L8_85
* net 328 FILL_L50_38
* net 329 FILL_L8_86
* net 330 FILL_L10_62
* net 331 FILL_L8_87
* net 332 FILL_L8_88
* net 333 CTX_L30_30,CTX_L50_6,CTX_L50_8,CTX_L67_3
* net 334 CTX_L30_25,CTX_L50_12,CTX_L50_7,CTX_L67_4
* net 335 CTX_L30_32,CTX_L50_13
* net 336 FILL_L8_89
* net 337 CTX_L30_36,CTX_L50_16
* net 338 CTX_L30_35,CTX_L50_19
* net 339 FILL_L8_90
* net 340 CTX_L30_34,CTX_L50_20
* net 341 CTX_L134_3
* net 342 CTX_L30_33,CTX_L50_24
* net 343 FILL_L10_63
* net 344 FILL_L10_64
* net 345 FILL_L8_91
* net 346 FILL_L8_92
* net 347 FILL_L67_57
* net 348 FILL_L30_44
* net 349 FILL_L8_93
* net 350 FILL_L67_58
* net 351 CTX_L10_9,CTX_L30_37,CTX_L8_3
* net 352 FILL_L10_65
* net 353 FILL_L67_59
* net 354 FILL_L10_66
* net 355 FILL_L8_94
* net 356 FILL_L50_40
* net 357 FILL_L10_67
* net 358 FILL_L8_95
* net 359 FILL_L50_41
* net 360 FILL_L67_60
* net 361 FILL_L10_68
.ENDS sense_fill_clip
