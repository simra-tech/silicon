* cell sense_fill_clip
.SUBCKT sense_fill_clip
* net 2 CTX_L10_0,CTX_L30_18,CTX_L50_1,CTX_L8_0
* net 3 CTX_L10_3,CTX_L30_1
* net 4 CTX_L10_1,CTX_L10_4,CTX_L30_2
* net 5 CTX_L10_2,CTX_L30_0
* net 6 CTX_L10_5,CTX_L30_3
* net 7 CTX_L126_0,CTX_L30_8,CTX_L50_0,CTX_L67_0
* net 8 CTX_L10_7,CTX_L30_11,CTX_L8_1
* net 9 CTX_L10_6,CTX_L30_4
* net 10 CTX_L30_5,CTX_L50_14
* net 11 CTX_L30_20,CTX_L30_6,N
* net 12 CTX_L30_7,CTX_L50_17
* net 13 CTX_L126_1,CTX_L30_10,CTX_L50_2,CTX_L67_1
* net 14 CTX_L30_9,CTX_L50_11
* net 15 CTX_L8_2
* net 16 CTX_L134_0
* net 17 CTX_L30_13
* net 18 CTX_L30_12,CTX_L30_22,CTX_L50_4
* net 19 CTX_L10_12,CTX_L10_8,CTX_L30_14
* net 20 CTX_L30_16
* net 21 CTX_L30_15
* net 22 CTX_L10_11
* net 23 CTX_L50_21
* net 24 CTX_L50_22
* net 25 P
* net 26 CTX_L134_1
* net 27 CTX_L30_17
* net 28 CTX_L30_19,CTX_L50_18
* net 29 CTX_L126_2,CTX_L134_2
* net 30 CTX_L10_10,CTX_L30_21
* net 31 CTX_L30_23,CTX_L50_15
* net 32 CTX_L30_24,CTX_L50_10
* net 33 CTX_L30_25,CTX_L50_12,CTX_L50_7,CTX_L67_4
* net 34 CTX_L30_27
* net 35 CTX_L30_26,CTX_L50_5,CTX_L50_9,CTX_L67_2
* net 36 CTX_L30_29,CTX_L50_26
* net 37 CTX_L30_28,CTX_L50_27
* net 38 CTX_L30_30,CTX_L50_6,CTX_L50_8,CTX_L67_3
* net 39 CTX_L30_32,CTX_L50_13
* net 40 CTX_L134_3
* net 41 CTX_L30_33,CTX_L50_24
* net 42 CTX_L30_31,CTX_L50_25
* net 43 CTX_L30_36,CTX_L50_16
* net 44 CTX_L30_35,CTX_L50_19
* net 45 CTX_L30_34,CTX_L50_20
* net 46 CTX_L10_9,CTX_L30_37,CTX_L8_3
.ENDS sense_fill_clip
