* Extracted by KLayout with SG13G2 LVS runset on : 23/09/2026 02:30

.SUBCKT OTHER_TOP A Y VDD VSS
X1 A N VDD VSS RETAINED_INV
X2 N Y VDD VSS RETAINED_INV
.ENDS OTHER_TOP

.SUBCKT RETAINED_INV A Y VDD VSS
MN VSS A Y VSS sg13_lv_nmos L=0.13u W=0.8u AS=0p AD=0p PS=0u PD=0u rfmode=0
MP VDD A Y VDD sg13_lv_pmos L=0.13u W=1.6u AS=0p AD=0p PS=0u PD=0u rfmode=0
.ENDS RETAINED_INV
