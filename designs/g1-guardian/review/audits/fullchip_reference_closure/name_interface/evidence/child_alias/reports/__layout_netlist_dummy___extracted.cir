* Extracted by KLayout with SG13G2 LVS runset on : 23/09/2026 02:30

.SUBCKT NAME_CONTROL_TOP A Y VDD VSS
M1.N VSS A N VSS sg13_lv_nmos L=0.13u W=0.8u AS=0p AD=0p PS=0u PD=0u rfmode=0
M1.P VDD A N VDD sg13_lv_pmos L=0.13u W=1.6u AS=0p AD=0p PS=0u PD=0u rfmode=0
M2.N VSS N Y VSS sg13_lv_nmos L=0.13u W=0.8u AS=0p AD=0p PS=0u PD=0u rfmode=0
M2.P VDD N Y VDD sg13_lv_pmos L=0.13u W=1.6u AS=0p AD=0p PS=0u PD=0u rfmode=0
.ENDS NAME_CONTROL_TOP
