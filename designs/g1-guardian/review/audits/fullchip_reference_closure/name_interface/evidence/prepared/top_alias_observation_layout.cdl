.SUBCKT RETAINED_INV A Y VDD VSS
MN Y A VSS VSS sg13_lv_nmos W=0.8u L=0.13u
MP Y A VDD VDD sg13_lv_pmos W=1.6u L=0.13u
.ENDS
.SUBCKT OTHER_TOP A Y VDD VSS
X1 A N VDD VSS RETAINED_INV
X2 N Y VDD VSS RETAINED_INV
.ENDS
