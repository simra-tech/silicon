.SUBCKT sg13g2_RCClampResistor pin1 pin2
*.PININFO pin1:B pin2:B
RR15 net15 net16 5.239K $SUB=sub! $[rppd] l=20u w=1u b=0 m=1
RR20 net20 net21 5.239K $SUB=sub! $[rppd] l=20u w=1u b=0 m=1
RR23 net23 net24 5.239K $SUB=sub! $[rppd] l=20u w=1u b=0 m=1
RR17 net17 net18 5.239K $SUB=sub! $[rppd] l=20u w=1u b=0 m=1
RR16 net16 net17 5.239K $SUB=sub! $[rppd] l=20u w=1u b=0 m=1
RR25 net25 pin2 5.239K $SUB=sub! $[rppd] l=20u w=1u b=0 m=1
RR22 net22 net23 5.239K $SUB=sub! $[rppd] l=20u w=1u b=0 m=1
RR19 net19 net20 5.239K $SUB=sub! $[rppd] l=20u w=1u b=0 m=1
RR24 net24 net25 5.239K $SUB=sub! $[rppd] l=20u w=1u b=0 m=1
RR21 net21 net22 5.239K $SUB=sub! $[rppd] l=20u w=1u b=0 m=1
RR18 net18 net19 5.239K $SUB=sub! $[rppd] l=20u w=1u b=0 m=1
RR5 net5 net6 5.239K $SUB=sub! $[rppd] l=20u w=1u b=0 m=1
RR8 net8 net9 5.239K $SUB=sub! $[rppd] l=20u w=1u b=0 m=1
RR11 net11 net12 5.239K $SUB=sub! $[rppd] l=20u w=1u b=0 m=1
RR14 net14 net15 5.239K $SUB=sub! $[rppd] l=20u w=1u b=0 m=1
RR2 net2 net3 5.239K $SUB=sub! $[rppd] l=20u w=1u b=0 m=1
RR1 net1 net2 5.239K $SUB=sub! $[rppd] l=20u w=1u b=0 m=1
RR13 net13 net14 5.239K $SUB=sub! $[rppd] l=20u w=1u b=0 m=1
RR10 net10 net11 5.239K $SUB=sub! $[rppd] l=20u w=1u b=0 m=1
RR7 net7 net8 5.239K $SUB=sub! $[rppd] l=20u w=1u b=0 m=1
RR4 net4 net5 5.239K $SUB=sub! $[rppd] l=20u w=1u b=0 m=1
RR12 net12 net13 5.239K $SUB=sub! $[rppd] l=20u w=1u b=0 m=1
RR9 net9 net10 5.239K $SUB=sub! $[rppd] l=20u w=1u b=0 m=1
RR6 net6 net7 5.239K $SUB=sub! $[rppd] l=20u w=1u b=0 m=1
RR3 net3 net4 5.239K $SUB=sub! $[rppd] l=20u w=1u b=0 m=1
RR0 pin1 net1 5.239K $SUB=sub! $[rppd] l=20u w=1u b=0 m=1
.ENDS
