.SUBCKT sg13g2_SecondaryProtection core minus pad plus
*.PININFO core:B minus:B pad:B plus:B
RR0 pad core 586.899 $SUB=sub! $[rppd] m=1 l=2u w=1u b=0 m=1
DD1 sub! core dantenna m=1 w=640n l=3.1u a=1.984p p=7.48u
XR1 minus sub! ptap1 A=9.03p P=12.02u
DD0 core plus dpantenna m=1 w=640n l=4.98u a=3.187p p=11.24u
.ENDS
