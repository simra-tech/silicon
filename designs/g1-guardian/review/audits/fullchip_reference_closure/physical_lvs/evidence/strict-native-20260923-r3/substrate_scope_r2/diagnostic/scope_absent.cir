* Isolated reader scope control, not chip reference

.SUBCKT C A
RR1 A sub! A rppd w=1u l=2u
.ENDS C
.SUBCKT TOP A B
X1 A C
X2 B C
.ENDS TOP
