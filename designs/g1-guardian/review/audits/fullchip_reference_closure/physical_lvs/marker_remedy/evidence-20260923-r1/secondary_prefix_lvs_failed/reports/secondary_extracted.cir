* Extracted by KLayout with SG13G2 LVS runset on : 23/09/2026 06:58

* cell g1_io_secondary_polyres_r1
* pin core
* pin minus
* pin pad
* pin plus
.SUBCKT g1_io_secondary_polyres_r1 core minus pad plus
* device instance $1 r0 *1 5.48,2.37 dantenna
D$1 \$1 core dantenna A=1.984p P=7.48u m=1
* device instance $2 r0 *1 3.31,7.34 dpantenna
D$2 core plus dpantenna A=3.1872p P=11.24u m=1
* device instance $3 r0 *1 0.935,1.365 rppd
R$3 pad core \$1 rppd w=1u l=2u ps=0u b=0 m=1
* device instance $4 r0 *1 5.48,2.37 ptap1
R$4 minus \$1 ptap1 A=9.0304p P=53.12u
.ENDS g1_io_secondary_polyres_r1
