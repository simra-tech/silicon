* Extracted by KLayout with SG13G2 LVS runset on : 23/09/2026 06:56

* cell g1_io_rc_polyres_r1
* pin pin1
* pin pin2
.SUBCKT g1_io_rc_polyres_r1 pin1 pin2
* device instance $26 r0 *1 41.245,0.425 rppd
R$26 pin2 pin1 \$1 rppd w=1u l=520u ps=0u b=0 m=1
.ENDS g1_io_rc_polyres_r1
