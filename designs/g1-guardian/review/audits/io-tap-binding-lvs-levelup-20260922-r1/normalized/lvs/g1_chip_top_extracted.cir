* Extracted by KLayout with SG13G2 LVS runset on : 22/09/2026 15:13

* cell sg13g2_LevelUpInv
* pin i
* pin iovdd
* pin o
* pin vdd
* pin vss
.SUBCKT sg13g2_LevelUpInv i iovdd o vdd vss
* device instance $1 r0 *1 0.51,10.505 sg13_lv_nmos
M$1 \$6 i vss \$5 sg13_lv_nmos L=0.13u W=2.75u AS=0.935p AD=0.935p PS=6.18u
+ PD=6.18u rfmode=0
* device instance $2 r0 *1 2.84,6.82 sg13_hv_nmos
M$2 vss \$4 o \$5 sg13_hv_nmos L=0.45u W=1.9u AS=0.646p AD=0.646p PS=4.48u
+ PD=4.48u rfmode=0
* device instance $3 r0 *1 0.67,6.82 sg13_hv_nmos
M$3 \$3 i vss \$5 sg13_hv_nmos L=0.45u W=1.9u AS=0.646p AD=0.361p PS=4.48u
+ PD=2.28u rfmode=0
* device instance $4 r0 *1 1.5,6.82 sg13_hv_nmos
M$4 vss \$6 \$4 \$5 sg13_hv_nmos L=0.45u W=1.9u AS=0.361p AD=0.646p PS=2.28u
+ PD=4.48u rfmode=0
* device instance $5 r0 *1 0.51,15.495 sg13_lv_pmos
M$5 \$6 i vdd vdd sg13_lv_pmos L=0.13u W=4.75u AS=1.615p AD=1.615p PS=10.18u
+ PD=10.18u rfmode=0
* device instance $6 r0 *1 2.84,2.68 sg13_hv_pmos
M$6 iovdd \$4 o iovdd sg13_hv_pmos L=0.45u W=3.9u AS=1.326p AD=1.326p PS=8.48u
+ PD=8.48u rfmode=0
* device instance $7 r0 *1 0.67,2.68 sg13_hv_pmos
M$7 \$3 \$4 iovdd iovdd sg13_hv_pmos L=0.45u W=0.3u AS=0.102p AD=0.057p
+ PS=1.28u PD=0.68u rfmode=0
* device instance $8 r0 *1 1.5,2.68 sg13_hv_pmos
M$8 iovdd \$3 \$4 iovdd sg13_hv_pmos L=0.45u W=0.3u AS=0.057p AD=0.102p
+ PS=0.68u PD=1.28u rfmode=0
* device instance $9 r0 *1 1.755,8.5 ptap1
R$9 vss \$5 ptap1 A=1.053p P=7.62u
.ENDS sg13g2_LevelUpInv
