* cell sense_fill_clip
.SUBCKT sense_fill_clip
* net 2 FILL_L8_0
* net 3 FILL_L30_0
* net 4 FILL_L8_1
* net 5 FILL_L50_0
* net 6 FILL_L8_2
* net 7 FILL_L10_0
* net 8 CTX_L30_0
* net 9 FILL_L8_3
* net 10 FILL_L10_1
* net 11 FILL_L8_7
* net 12 FILL_L67_0
* net 13 FILL_L8_8
* net 14 FILL_L8_4
* net 15 CTX_L8_0
* net 16 FILL_L67_1
* net 17 FILL_L10_4
* net 18 FILL_L50_1
* net 19 FILL_L10_2
* net 20 FILL_L8_5
* net 21 FILL_L10_5
* net 22 FILL_L8_6
* net 23 FILL_L10_3
* net 24 FILL_L67_2
* net 25 FILL_L50_2
* net 26 CTX_L126_1,CTX_L134_0
* net 27 CTX_L50_1
* net 28 FILL_L8_9
* net 29 FILL_L67_3
* net 30 CTX_L30_1,CTX_L50_4
* net 31 CTX_L126_0
* net 32 CTX_L50_3
* net 33 FILL_L8_10
* net 34 CTX_L10_0
* net 35 CTX_L50_5
* net 36 P
* net 37 CTX_L30_3
* net 38 N
* net 39 FILL_L67_4
* net 40 CTX_L30_2,CTX_L50_0
* net 41 FILL_L50_3
* net 42 FILL_L8_11
* net 43 FILL_L10_6
* net 44 FILL_L50_5
* net 45 FILL_L67_5
* net 46 CTX_L30_5,CTX_L50_2
* net 47 CTX_L30_4
* net 48 FILL_L50_4
* net 49 FILL_L8_12
* net 50 FILL_L8_15
* net 51 FILL_L67_6
* net 52 FILL_L30_1
* net 53 FILL_L30_5
* net 54 FILL_L8_16
* net 55 FILL_L8_13
* net 56 FILL_L30_2
* net 57 FILL_L67_7
* net 58 FILL_L50_6
* net 59 FILL_L30_3
* net 60 FILL_L50_7
* net 61 FILL_L10_7
* net 62 FILL_L8_17
* net 63 FILL_L10_8
* net 64 FILL_L8_14
* net 65 FILL_L30_4
* net 66 FILL_L50_8
* net 67 FILL_L67_8
* net 68 FILL_L30_6
* net 69 FILL_L67_9
* net 70 FILL_L67_10
* net 71 CTX_L30_6
* net 72 FILL_L67_11
.ENDS sense_fill_clip
