* actual_fill grounded drive N; diagnostic capacitor-network AC only
C41 0 N 1.5173700000000001e-17
C42 0 P 1.87259e-17
C87 0 N 2.4479500000000003e-17
C88 0 P 2.9385200000000003e-17
C136 0 N 6.0853000000000007e-17
C137 0 P 2.8692000000000001e-17
C166 0 N 1.2387300000000001e-16
C167 0 P 1.2384300000000001e-16
C191 0 N 1.0038200000000001e-19
C192 0 P 1.4308399999999999e-19
C210 0 N 1.3679e-15
C211 0 P 6.6377800000000004e-19
C225 0 N 2.89104e-17
C226 0 P 2.2033300000000001e-17
C250 0 N 2.6109400000000004e-17
C251 0 P 2.2345500000000002e-17
C275 0 N 1.42023e-17
C276 0 P 2.0316800000000003e-18
C329 0 P 3.4877500000000003e-15
C352 0 N 1.16519e-17
C353 0 P 3.8117600000000003e-18
C359 0 N 5.3580200000000006e-19
C360 0 P 4.3091600000000004e-19
C383 0 N 1.26457e-18
C384 0 P 1.0394800000000001e-18
C398 0 N 3.6381300000000005e-17
C399 0 P 3.2639700000000001e-18
C412 0 N 5.0775300000000004e-17
C413 0 P 3.6381800000000002e-18
C422 0 N 5.2383900000000001e-17
C423 0 P 2.7546200000000002e-18
C434 0 N 2.8873199999999999e-18
C435 0 P 5.3937200000000003e-18
C442 0 N 2.34989e-18
C443 0 P 1.3518400000000001e-18
C451 0 N 2.4807800000000001e-19
C452 0 P 3.1888300000000006e-19
C456 0 N 1.1391300000000001e-19
C457 0 P 1.4642600000000002e-19
C472 0 N 2.1894100000000004e-17
C478 0 N 5.0331300000000003e-17
C483 0 N 2.4862500000000002e-17
C487 0 N 5.0331300000000003e-17
C492 0 N 5.0331300000000003e-17
C496 0 N 2.4862500000000002e-17
C502 0 P 2.1385100000000004e-19
C508 0 N 1.8052299999999998e-18
C509 0 P 1.6526e-17
C512 0 N 1.42102e-18
C513 0 P 2.2012000000000005e-19
C521 0 N 2.0783900000000003e-18
C522 0 P 1.7085799999999999e-17
C525 0 N 1.93149e-18
C526 0 P 3.6000900000000005e-19
C531 0 N 1.6211500000000002e-18
C532 0 P 1.2935900000000001e-17
C534 0 N 1.4624100000000001e-18
C535 0 P 2.0571900000000003e-19
C550 0 P 2.5932400000000002e-19
C552 0 P 3.1666400000000002e-19
C555 N P 3.4877500000000003e-15
C556 N 0 1.8997600000000001e-16
C557 P 0 6.16815e-17
VP P 0 DC 0 AC 0
VN N 0 DC 0 AC 1
.control
set numdgt=17
ac lin 1 1Meg 1Meg
let cp = -imag(i(VP))/(2*pi*1e6)
let cn = -imag(i(VN))/(2*pi*1e6)
print cp cn
quit
.endc
.end
