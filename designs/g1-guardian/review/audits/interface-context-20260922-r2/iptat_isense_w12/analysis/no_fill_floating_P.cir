* no_fill floating drive P; diagnostic capacitor-network AC only
C13 0 N 1.5219900000000003e-17
C14 0 P 1.8783000000000002e-17
C28 0 N 2.4541200000000003e-17
C29 0 P 2.9459100000000004e-17
C42 0 N 7.3535300000000016e-17
C43 0 P 2.8892000000000003e-17
C51 0 N 1.2387300000000001e-16
C52 0 P 1.2384300000000001e-16
C62 0 N 1.0038200000000001e-19
C63 0 P 1.4308399999999999e-19
C68 0 N 1.3679e-15
C69 0 P 6.6377800000000004e-19
C76 0 N 2.9272900000000001e-17
C77 0 P 2.2033300000000001e-17
C84 0 N 2.9585100000000004e-17
C85 0 P 2.2345500000000002e-17
C92 0 N 1.42023e-17
C93 0 P 2.0316800000000003e-18
C102 0 P 3.4877500000000003e-15
C104 0 N 1.1984e-17
C105 0 P 3.8530500000000005e-18
C107 N P 3.4877500000000003e-15
C108 N 0 4.0662500000000003e-16
C109 P 0 8.9641500000000002e-17
VP P 0 DC 0 AC 1
VN N 0 DC 0 AC 0
.control
set numdgt=17
ac lin 1 1Meg 1Meg
let cp = -imag(i(VP))/(2*pi*1e6)
let cn = -imag(i(VN))/(2*pi*1e6)
print cp cn
quit
.endc
.end
