* actual_fill floating drive P; diagnostic capacitor-network AC only
C13 0 FILL_L10_0 9.3719500000000004e-18
C14 0 FILL_L10_2 1.2171400000000001e-17
C15 0 FILL_L10_4 1.4294000000000001e-17
C16 0 FILL_L10_6 5.0029100000000004e-17
C17 0 FILL_L10_7 5.0029100000000004e-17
C18 0 FILL_L10_8 3.9022700000000004e-17
C19 0 FILL_L30_0 4.1447000000000008e-18
C20 0 FILL_L30_1 3.6203200000000002e-18
C21 0 FILL_L30_2 4.2143900000000006e-17
C22 0 FILL_L30_5 4.1227600000000004e-18
C23 0 FILL_L30_6 2.9378700000000004e-18
C24 0 FILL_L50_1 1.1485900000000001e-18
C25 0 FILL_L50_2 1.56781e-18
C26 0 FILL_L50_4 6.8915199999999999e-19
C27 0 FILL_L50_5 3.76274e-19
C28 0 FILL_L50_7 2.2512300000000004e-18
C29 0 FILL_L50_8 1.8562900000000002e-18
C30 0 FILL_L8_0 1.0557499999999999e-18
C31 0 FILL_L8_1 9.7503800000000007e-18
C32 0 FILL_L8_10 3.2539200000000003e-16
C33 0 FILL_L8_12 4.7988699999999999e-18
C34 0 FILL_L8_13 3.2388600000000005e-16
C35 0 FILL_L8_15 3.74312e-18
C36 0 FILL_L8_16 2.50016e-16
C37 0 FILL_L8_4 1.2662800000000002e-17
C38 0 FILL_L8_7 5.1044000000000004e-18
C39 0 FILL_L8_8 1.2662800000000002e-17
C40 0 FILL_L8_9 4.5589199999999999e-18
C41 0 N 1.5173700000000001e-17
C42 0 P 1.87259e-17
C56 0 FILL_L10_0 2.0984100000000001e-18
C57 0 FILL_L10_4 2.21167e-18
C58 0 FILL_L10_5 2.1373400000000003e-18
C59 0 FILL_L10_6 2.8820800000000003e-17
C60 0 FILL_L10_7 3.6027400000000003e-17
C61 0 FILL_L10_8 6.2968700000000008e-18
C62 0 FILL_L30_0 3.4193300000000004e-17
C63 0 FILL_L30_1 2.9634200000000002e-17
C64 0 FILL_L30_2 9.0497100000000002e-18
C65 0 FILL_L30_5 2.9215199999999998e-17
C66 0 FILL_L30_6 1.79193e-17
C67 0 FILL_L50_0 3.57277e-18
C68 0 FILL_L50_1 3.57277e-18
C69 0 FILL_L50_2 4.10082e-18
C70 0 FILL_L50_3 3.5370400000000002e-18
C71 0 FILL_L50_4 3.57277e-18
C72 0 FILL_L50_5 4.0085600000000006e-18
C73 0 FILL_L50_6 3.57277e-18
C74 0 FILL_L50_7 3.5013200000000003e-18
C75 0 FILL_L50_8 4.0803200000000008e-18
C76 0 FILL_L8_0 4.6621300000000008e-18
C77 0 FILL_L8_1 6.2372500000000012e-18
C78 0 FILL_L8_10 5.9439900000000004e-17
C79 0 FILL_L8_12 1.98967e-17
C80 0 FILL_L8_13 5.8453200000000009e-17
C81 0 FILL_L8_15 1.5584200000000001e-17
C82 0 FILL_L8_16 4.8960800000000002e-17
C83 0 FILL_L8_4 8.718710000000001e-18
C84 0 FILL_L8_7 2.2033200000000004e-17
C85 0 FILL_L8_8 8.718710000000001e-18
C86 0 FILL_L8_9 1.83254e-17
C87 0 N 2.4479500000000003e-17
C88 0 P 2.9385200000000003e-17
C101 0 FILL_L10_0 1.95976e-18
C102 0 FILL_L10_1 3.6643599999999998e-18
C103 0 FILL_L10_2 4.5526100000000007e-19
C104 0 FILL_L10_3 6.6841600000000003e-19
C105 0 FILL_L10_4 3.32537e-18
C106 0 FILL_L10_5 4.4897700000000006e-18
C107 0 FILL_L10_6 1.0582200000000001e-16
C108 0 FILL_L10_7 1.5941400000000001e-16
C109 0 FILL_L10_8 9.2193400000000004e-17
C110 0 FILL_L30_2 5.9535000000000007e-18
C111 0 FILL_L30_3 1.9314400000000001e-18
C112 0 FILL_L30_4 4.7910100000000007e-18
C113 0 FILL_L30_6 1.5122100000000002e-19
C114 0 FILL_L50_0 4.3655400000000009e-18
C115 0 FILL_L50_1 7.0138000000000004e-18
C116 0 FILL_L50_2 6.8543700000000012e-17
C117 0 FILL_L50_3 1.81952e-17
C118 0 FILL_L50_4 1.2221700000000002e-17
C119 0 FILL_L50_5 1.6542200000000002e-16
C120 0 FILL_L50_6 1.2813300000000001e-17
C121 0 FILL_L50_7 2.0890500000000001e-17
C122 0 FILL_L50_8 1.91339e-16
C123 0 FILL_L8_0 2.0836299999999998e-18
C124 0 FILL_L8_1 9.8393900000000005e-19
C125 0 FILL_L8_10 5.2317800000000001e-17
C126 0 FILL_L8_11 2.3587799999999999e-18
C127 0 FILL_L8_12 9.4576200000000007e-18
C128 0 FILL_L8_13 4.4988500000000004e-17
C129 0 FILL_L8_14 1.1017800000000001e-18
C130 0 FILL_L8_16 3.0039400000000001e-17
C131 0 FILL_L8_17 2.4573500000000003e-18
C132 0 FILL_L8_4 1.4254700000000001e-18
C133 0 FILL_L8_7 1.1351300000000001e-17
C134 0 FILL_L8_8 1.65397e-18
C135 0 FILL_L8_9 9.8161600000000012e-18
C136 0 N 6.0853000000000007e-17
C137 0 P 2.8692000000000001e-17
C144 0 FILL_L10_0 8.5130700000000012e-17
C145 0 FILL_L10_1 1.5157100000000001e-16
C146 0 FILL_L10_2 1.6277900000000001e-16
C147 0 FILL_L10_3 1.49271e-16
C148 0 FILL_L10_4 1.2781300000000001e-17
C149 0 FILL_L10_5 1.2920400000000001e-17
C150 0 FILL_L10_6 4.0629999999999999e-18
C151 0 FILL_L30_0 1.27509e-17
C152 0 FILL_L50_0 1.8888900000000003e-16
C153 0 FILL_L50_1 2.4520700000000002e-17
C154 0 FILL_L50_2 4.5706300000000003e-16
C155 0 FILL_L50_3 4.0741100000000007e-19
C156 0 FILL_L50_5 5.5407900000000005e-19
C157 0 FILL_L8_0 4.38158e-19
C158 0 FILL_L8_1 2.4874600000000003e-18
C159 0 FILL_L8_10 2.9465800000000003e-18
C160 0 FILL_L8_2 1.27868e-17
C161 0 FILL_L8_3 1.9180700000000001e-17
C162 0 FILL_L8_4 7.687050000000001e-18
C163 0 FILL_L8_5 2.5764500000000005e-17
C164 0 FILL_L8_6 2.1675400000000001e-17
C165 0 FILL_L8_7 2.3740700000000003e-18
C166 0 N 1.2387300000000001e-16
C167 0 P 1.2384300000000001e-16
C177 0 FILL_L30_0 7.1429400000000012e-18
C178 0 FILL_L30_1 2.4718700000000003e-18
C179 0 FILL_L30_2 1.2958900000000001e-17
C180 0 FILL_L30_5 2.42244e-18
C181 0 FILL_L30_6 1.8044700000000003e-18
C182 0 FILL_L8_0 6.1662900000000005e-19
C183 0 FILL_L8_1 7.14146e-19
C184 0 FILL_L8_10 7.6073499999999995e-17
C185 0 FILL_L8_13 5.2386900000000003e-17
C186 0 FILL_L8_16 4.4594600000000005e-17
C187 0 FILL_L8_4 2.1914000000000001e-18
C188 0 FILL_L8_7 1.1771800000000001e-17
C189 0 FILL_L8_8 6.4809000000000007e-18
C190 0 FILL_L8_9 1.5419200000000002e-17
C191 0 N 1.0038200000000001e-19
C192 0 P 1.4308399999999999e-19
C197 0 FILL_L10_0 5.1816800000000005e-18
C198 0 FILL_L10_1 8.8671500000000006e-19
C199 0 FILL_L10_4 1.1098200000000002e-17
C200 0 FILL_L10_5 6.1522000000000003e-18
C201 0 FILL_L10_6 1.87709e-16
C202 0 FILL_L50_0 9.8265900000000003e-17
C203 0 FILL_L50_1 1.0069900000000001e-16
C204 0 FILL_L50_2 3.41581e-17
C205 0 FILL_L50_3 1.0759200000000001e-16
C206 0 FILL_L50_5 8.1530400000000005e-17
C207 0 FILL_L8_10 4.1643499999999997e-18
C208 0 FILL_L8_11 2.3097400000000002e-18
C209 0 FILL_L8_2 2.8607300000000005e-19
C210 0 N 1.3679e-15
C211 0 P 6.6377800000000004e-19
C218 0 FILL_L10_6 2.8722000000000006e-16
C219 0 FILL_L50_3 2.1507200000000002e-17
C220 0 FILL_L50_4 4.5235000000000006e-18
C221 0 FILL_L50_5 1.2153500000000001e-16
C222 0 FILL_L8_10 1.33642e-16
C223 0 FILL_L8_11 2.9365800000000004e-18
C224 0 FILL_L8_9 3.1655300000000001e-17
C225 0 N 2.89104e-17
C226 0 P 2.2033300000000001e-17
C233 0 FILL_L10_6 1.4053899999999999e-16
C234 0 FILL_L10_7 4.7488300000000006e-17
C235 0 FILL_L10_8 1.8939700000000001e-18
C236 0 FILL_L30_1 1.8158600000000001e-17
C237 0 FILL_L30_2 1.8158600000000001e-17
C238 0 FILL_L30_3 1.8158600000000001e-17
C239 0 FILL_L30_4 1.8158600000000001e-17
C240 0 FILL_L50_4 5.2148100000000004e-17
C241 0 FILL_L50_5 9.5343100000000008e-17
C242 0 FILL_L50_8 3.9855900000000008e-18
C243 0 FILL_L8_10 7.2785100000000003e-17
C244 0 FILL_L8_11 4.2239000000000011e-18
C245 0 FILL_L8_12 6.6594100000000007e-19
C246 0 FILL_L8_13 5.5010500000000002e-17
C247 0 FILL_L8_14 3.2598500000000004e-18
C248 0 FILL_L8_16 5.0604199999999999e-18
C249 0 FILL_L8_9 1.8810199999999999e-17
C250 0 N 2.6109400000000004e-17
C251 0 P 2.2345500000000002e-17
C255 0 FILL_L30_1 2.9393299999999999e-17
C256 0 FILL_L30_5 2.9393299999999999e-17
C257 0 FILL_L30_6 2.1457100000000003e-17
C258 0 FILL_L8_12 4.2703700000000002e-17
C259 0 FILL_L8_13 1.2555300000000001e-17
C260 0 FILL_L8_15 1.93705e-17
C261 0 FILL_L8_16 9.7931100000000004e-18
C262 0 FILL_L8_9 8.3148400000000007e-19
C266 0 FILL_L10_7 9.7039000000000012e-18
C267 0 FILL_L10_8 2.7748399999999999e-16
C268 0 FILL_L30_3 7.4834200000000008e-18
C269 0 FILL_L30_4 7.4834200000000008e-18
C270 0 FILL_L30_6 5.7559000000000003e-18
C271 0 FILL_L50_7 3.8237100000000004e-18
C272 0 FILL_L50_8 1.1024400000000001e-17
C273 0 FILL_L8_16 1.41565e-17
C274 0 FILL_L8_17 2.6703600000000003e-18
C275 0 N 1.42023e-17
C276 0 P 2.0316800000000003e-18
C279 0 FILL_L30_0 8.444419999999999e-18
C280 0 FILL_L30_1 9.3037300000000016e-19
C281 0 FILL_L30_5 9.3037300000000016e-19
C282 0 FILL_L30_6 6.7917200000000001e-19
C283 0 FILL_L8_0 5.7757200000000003e-18
C284 0 FILL_L8_1 1.8848600000000002e-18
C285 0 FILL_L8_10 7.3313800000000014e-18
C286 0 FILL_L8_12 2.5004900000000002e-17
C287 0 FILL_L8_15 1.93889e-17
C288 0 FILL_L8_4 2.4478700000000003e-18
C289 0 FILL_L8_7 2.5164700000000003e-17
C290 0 FILL_L8_8 2.4478700000000003e-18
C291 0 FILL_L8_9 2.1799499999999999e-17
C295 0 FILL_L30_0 2.2944299999999999e-17
C296 0 FILL_L30_1 2.2944299999999999e-17
C297 0 FILL_L30_2 1.5374400000000001e-18
C298 0 FILL_L30_5 2.2851200000000001e-17
C299 0 FILL_L30_6 1.6749400000000001e-17
C300 0 FILL_L8_0 3.0512000000000004e-18
C301 0 FILL_L8_1 7.7953600000000004e-18
C302 0 FILL_L8_10 3.09915e-17
C303 0 FILL_L8_13 3.1426600000000002e-17
C304 0 FILL_L8_16 2.4191100000000001e-17
C305 0 FILL_L8_4 1.0723699999999999e-17
C306 0 FILL_L8_7 1.4547800000000002e-17
C307 0 FILL_L8_8 1.0723699999999999e-17
C308 0 FILL_L8_9 1.20643e-17
C311 0 FILL_L10_0 4.6008100000000009e-19
C312 0 FILL_L10_2 4.5859400000000005e-19
C313 0 FILL_L10_4 8.3637000000000004e-19
C314 0 FILL_L10_6 2.5425600000000001e-18
C315 0 FILL_L10_7 2.3499900000000001e-18
C316 0 FILL_L10_8 2.2163800000000001e-18
C317 0 FILL_L30_0 3.0866700000000007e-19
C318 0 FILL_L30_2 5.0477300000000002e-17
C319 0 FILL_L30_3 2.7253600000000004e-19
C320 0 FILL_L30_5 4.2414700000000004e-19
C321 0 FILL_L30_6 1.9476100000000001e-19
C322 0 FILL_L8_1 1.7883700000000001e-18
C323 0 FILL_L8_10 5.6052700000000001e-17
C324 0 FILL_L8_13 4.9781300000000005e-17
C325 0 FILL_L8_16 4.4594600000000005e-17
C326 0 FILL_L8_4 2.3362800000000002e-18
C327 0 FILL_L8_7 2.95089e-19
C328 0 FILL_L8_8 2.4729900000000001e-18
C329 0 P 3.4877500000000003e-15
C331 0 FILL_L10_0 1.5297400000000002e-18
C332 0 FILL_L10_1 1.79559e-19
C333 0 FILL_L10_2 2.5012500000000005e-18
C334 0 FILL_L10_3 5.1456700000000007e-19
C335 0 FILL_L10_4 5.7463900000000001e-17
C336 0 FILL_L10_5 5.0753600000000004e-17
C337 0 FILL_L10_6 3.5427400000000001e-18
C338 0 FILL_L30_0 1.2871200000000001e-18
C339 0 FILL_L50_1 2.89328e-18
C340 0 FILL_L50_2 1.2519600000000001e-17
C341 0 FILL_L50_5 8.2906300000000004e-18
C342 0 FILL_L50_8 1.9235300000000001e-19
C343 0 FILL_L8_1 8.3086600000000006e-18
C344 0 FILL_L8_11 7.1176600000000001e-17
C345 0 FILL_L8_2 1.5123699999999999e-17
C346 0 FILL_L8_3 4.1459400000000009e-18
C347 0 FILL_L8_4 1.0790500000000001e-17
C348 0 FILL_L8_5 3.2625799999999998e-17
C349 0 FILL_L8_6 1.2984600000000001e-17
C350 0 FILL_L8_7 8.348340000000001e-18
C351 0 FILL_L8_8 1.0790500000000001e-17
C352 0 N 1.16519e-17
C353 0 P 3.8117600000000003e-18
C355 FILL_L10_0 FILL_L10_1 2.1510100000000004e-17
C356 FILL_L10_0 FILL_L10_2 2.7935199999999999e-17
C357 FILL_L10_0 FILL_L50_0 2.7412500000000003e-18
C358 FILL_L10_0 FILL_L8_2 5.1763199999999999e-17
C359 FILL_L10_0 N 5.3580200000000006e-19
C360 FILL_L10_0 P 4.3091600000000004e-19
C361 FILL_L10_0 0 7.7353800000000008e-17
C362 FILL_L10_1 FILL_L10_3 2.7935199999999999e-17
C363 FILL_L10_1 FILL_L50_2 6.8136799999999999e-18
C364 FILL_L10_1 FILL_L50_5 4.39077e-19
C365 FILL_L10_1 FILL_L8_3 8.6962300000000004e-17
C366 FILL_L10_1 0 1.33295e-16
C367 FILL_L10_2 FILL_L10_3 2.7935199999999999e-17
C368 FILL_L10_2 FILL_L10_4 1.39676e-17
C369 FILL_L10_2 FILL_L10_6 5.1652400000000006e-18
C370 FILL_L10_2 FILL_L50_1 1.4804999999999999e-18
C371 FILL_L10_2 FILL_L8_5 6.7224999999999998e-17
C372 FILL_L10_2 0 7.0927800000000015e-17
C373 FILL_L10_3 FILL_L10_5 1.39676e-17
C374 FILL_L10_3 FILL_L50_2 9.590400000000001e-18
C375 FILL_L10_3 FILL_L50_5 1.4553799999999999e-18
C376 FILL_L10_3 FILL_L8_6 6.7224999999999998e-17
C377 FILL_L10_3 0 8.6486000000000006e-17
C378 FILL_L10_4 FILL_L10_5 2.7935199999999999e-17
C379 FILL_L10_4 FILL_L10_6 2.7935199999999999e-17
C380 FILL_L10_4 FILL_L50_1 2.1761200000000001e-17
C381 FILL_L10_4 FILL_L50_3 3.8908000000000001e-18
C382 FILL_L10_4 FILL_L8_5 1.51036e-18
C383 FILL_L10_4 N 1.26457e-18
C384 FILL_L10_4 P 1.0394800000000001e-18
C385 FILL_L10_4 0 8.1147100000000002e-17
C386 FILL_L10_5 FILL_L10_6 2.7935199999999999e-17
C387 FILL_L10_5 FILL_L50_1 1.9454000000000001e-18
C388 FILL_L10_5 FILL_L50_2 2.0843000000000002e-17
C389 FILL_L10_5 FILL_L50_5 1.9454000000000001e-18
C390 FILL_L10_5 FILL_L8_6 1.51036e-18
C391 FILL_L10_5 0 9.5091600000000003e-17
C392 FILL_L10_6 FILL_L10_7 9.7773300000000019e-17
C393 FILL_L10_6 FILL_L50_3 5.3319900000000002e-17
C394 FILL_L10_6 FILL_L50_4 4.34584e-17
C395 FILL_L10_6 FILL_L50_5 1.3779700000000001e-16
C396 FILL_L10_6 FILL_L8_10 2.4478800000000003e-17
C397 FILL_L10_6 FILL_L8_11 8.2350600000000007e-16
C398 FILL_L10_6 N 3.6381300000000005e-17
C399 FILL_L10_6 P 3.2639700000000001e-18
C400 FILL_L10_6 0 2.92746e-16
C401 FILL_L10_7 FILL_L10_8 9.7773300000000019e-17
C402 FILL_L10_7 FILL_L30_2 2.6211800000000001e-18
C403 FILL_L10_7 FILL_L30_3 1.7636500000000003e-16
C404 FILL_L10_7 FILL_L30_4 1.23317e-16
C405 FILL_L10_7 FILL_L50_4 1.04719e-17
C406 FILL_L10_7 FILL_L50_5 5.2359600000000008e-18
C407 FILL_L10_7 FILL_L50_6 4.9659000000000004e-17
C408 FILL_L10_7 FILL_L50_7 2.0914400000000003e-17
C409 FILL_L10_7 FILL_L50_8 1.06216e-16
C410 FILL_L10_7 FILL_L8_13 2.45489e-17
C411 FILL_L10_7 FILL_L8_14 8.2350600000000007e-16
C412 FILL_L10_7 N 5.0775300000000004e-17
C413 FILL_L10_7 P 3.6381800000000002e-18
C414 FILL_L10_7 0 2.6896499999999997e-16
C415 FILL_L10_8 FILL_L30_3 3.2724800000000002e-18
C416 FILL_L10_8 FILL_L30_4 1.6362400000000001e-18
C417 FILL_L10_8 FILL_L30_6 1.4743400000000002e-19
C418 FILL_L10_8 FILL_L50_7 3.1173500000000001e-17
C419 FILL_L10_8 FILL_L50_8 1.7067200000000001e-17
C420 FILL_L10_8 FILL_L8_16 1.9148200000000001e-17
C421 FILL_L10_8 FILL_L8_17 6.4233500000000011e-16
C422 FILL_L10_8 N 5.2383900000000001e-17
C423 FILL_L10_8 P 2.7546200000000002e-18
C424 FILL_L10_8 0 3.0411500000000001e-16
C425 FILL_L30_0 0 1.17571e-16
C426 FILL_L30_1 FILL_L30_2 1.92731e-17
C427 FILL_L30_1 FILL_L30_5 1.92731e-17
C428 FILL_L30_1 FILL_L8_12 1.4120400000000001e-17
C429 FILL_L30_1 FILL_L8_13 2.6166200000000002e-17
C430 FILL_L30_1 0 6.4352600000000001e-17
C431 FILL_L30_2 FILL_L30_3 1.92731e-17
C432 FILL_L30_2 FILL_L8_13 7.3572100000000009e-17
C433 FILL_L30_2 FILL_L8_16 6.7211400000000009e-18
C434 FILL_L30_2 N 2.8873199999999999e-18
C435 FILL_L30_2 P 5.3937200000000003e-18
C436 FILL_L30_2 0 2.6990400000000004e-17
C437 FILL_L30_3 FILL_L30_4 1.92731e-17
C438 FILL_L30_3 FILL_L50_4 5.0409200000000003e-19
C439 FILL_L30_3 FILL_L50_6 6.7224999999999998e-17
C440 FILL_L30_3 FILL_L50_7 3.0598200000000003e-18
C441 FILL_L30_3 FILL_L8_13 3.9629700000000004e-18
C442 FILL_L30_3 N 2.34989e-18
C443 FILL_L30_3 P 1.3518400000000001e-18
C444 FILL_L30_3 0 2.4692900000000002e-17
C445 FILL_L30_4 FILL_L50_5 2.5204600000000002e-19
C446 FILL_L30_4 FILL_L50_8 1.2322700000000001e-16
C447 FILL_L30_4 FILL_L8_14 3.01665e-18
C448 FILL_L30_4 0 6.4199200000000009e-17
C449 FILL_L30_5 FILL_L30_6 1.92731e-17
C450 FILL_L30_5 FILL_L50_7 6.4578500000000007e-19
C451 FILL_L30_5 N 2.4807800000000001e-19
C452 FILL_L30_5 P 3.1888300000000006e-19
C453 FILL_L30_5 0 9.9305900000000004e-17
C454 FILL_L30_6 FILL_L8_15 1.03079e-17
C455 FILL_L30_6 FILL_L8_16 2.4199700000000002e-17
C456 FILL_L30_6 N 1.1391300000000001e-19
C457 FILL_L30_6 P 1.4642600000000002e-19
C458 FILL_L30_6 0 7.4250699999999996e-17
C459 FILL_L50_0 FILL_L50_1 2.4713600000000001e-17
C460 FILL_L50_0 FILL_L50_2 2.4713600000000001e-17
C461 FILL_L50_0 0 2.7427800000000004e-17
C462 FILL_L50_1 FILL_L50_2 2.4713600000000001e-17
C463 FILL_L50_1 FILL_L50_3 2.4713600000000001e-17
C464 FILL_L50_1 FILL_L8_5 6.7038200000000004e-19
C465 FILL_L50_1 0 2.7919699999999998e-17
C466 FILL_L50_2 FILL_L50_5 4.1518800000000001e-17
C467 FILL_L50_2 FILL_L8_3 1.78708e-18
C468 FILL_L50_2 FILL_L8_6 4.1326299999999999e-18
C469 FILL_L50_2 0 2.1404700000000002e-16
C470 FILL_L50_3 FILL_L50_4 2.4713600000000001e-17
C471 FILL_L50_3 FILL_L50_5 2.4713600000000001e-17
C472 FILL_L50_3 N 2.1894100000000004e-17
C473 FILL_L50_3 0 1.10283e-17
C474 FILL_L50_4 FILL_L50_5 2.4713600000000001e-17
C475 FILL_L50_4 FILL_L50_6 2.4713600000000001e-17
C476 FILL_L50_4 FILL_L8_11 8.9735099999999998e-19
C477 FILL_L50_4 FILL_L8_14 8.0131300000000013e-19
C478 FILL_L50_4 N 5.0331300000000003e-17
C479 FILL_L50_4 0 1.5366300000000001e-17
C480 FILL_L50_5 FILL_L50_8 4.1518800000000001e-17
C481 FILL_L50_5 FILL_L8_11 1.1087400000000002e-17
C482 FILL_L50_5 FILL_L8_14 4.0065700000000001e-19
C483 FILL_L50_5 N 2.4862500000000002e-17
C484 FILL_L50_5 0 1.9315000000000002e-16
C485 FILL_L50_6 FILL_L50_7 2.4713600000000001e-17
C486 FILL_L50_6 FILL_L50_8 2.4713600000000001e-17
C487 FILL_L50_6 N 5.0331300000000003e-17
C488 FILL_L50_6 0 1.2760800000000001e-17
C489 FILL_L50_7 FILL_L50_8 2.4713600000000001e-17
C490 FILL_L50_7 FILL_L8_14 2.7810000000000005e-18
C491 FILL_L50_7 FILL_L8_17 2.9359200000000002e-18
C492 FILL_L50_7 N 5.0331300000000003e-17
C493 FILL_L50_7 0 4.2637600000000002e-17
C494 FILL_L50_8 FILL_L8_14 9.2222400000000006e-18
C495 FILL_L50_8 FILL_L8_17 2.1383400000000001e-18
C496 FILL_L50_8 N 2.4862500000000002e-17
C497 FILL_L50_8 0 2.4197100000000003e-16
C498 FILL_L8_0 FILL_L8_1 1.5333300000000001e-17
C499 FILL_L8_0 FILL_L8_7 1.6329000000000003e-17
C500 FILL_L8_0 0 1.21616e-16
C501 FILL_L8_1 FILL_L8_4 1.9913400000000001e-17
C502 FILL_L8_1 P 2.1385100000000004e-19
C503 FILL_L8_1 0 1.31027e-16
C504 FILL_L8_10 FILL_L8_11 6.96968e-17
C505 FILL_L8_10 FILL_L8_13 6.96968e-17
C506 FILL_L8_10 FILL_L8_8 1.9913400000000001e-17
C507 FILL_L8_10 FILL_L8_9 6.96968e-17
C508 FILL_L8_10 N 1.8052299999999998e-18
C509 FILL_L8_10 P 1.6526e-17
C510 FILL_L8_10 0 7.9238300000000012e-16
C511 FILL_L8_11 FILL_L8_14 6.96968e-17
C512 FILL_L8_11 N 1.42102e-18
C513 FILL_L8_11 P 2.2012000000000005e-19
C514 FILL_L8_11 0 8.0796800000000006e-16
C515 FILL_L8_12 FILL_L8_13 6.96968e-17
C516 FILL_L8_12 FILL_L8_15 1.6329000000000003e-17
C517 FILL_L8_12 FILL_L8_9 1.6329000000000003e-17
C518 FILL_L8_12 0 3.5725299999999999e-16
C519 FILL_L8_13 FILL_L8_14 6.96968e-17
C520 FILL_L8_13 FILL_L8_16 6.96968e-17
C521 FILL_L8_13 N 2.0783900000000003e-18
C522 FILL_L8_13 P 1.7085799999999999e-17
C523 FILL_L8_13 0 7.5091400000000008e-16
C524 FILL_L8_14 FILL_L8_17 6.96968e-17
C525 FILL_L8_14 N 1.93149e-18
C526 FILL_L8_14 P 3.6000900000000005e-19
C527 FILL_L8_14 0 8.0897100000000003e-16
C528 FILL_L8_15 FILL_L8_16 5.4363500000000008e-17
C529 FILL_L8_15 0 3.0055600000000003e-16
C530 FILL_L8_16 FILL_L8_17 5.4363500000000008e-17
C531 FILL_L8_16 N 1.6211500000000002e-18
C532 FILL_L8_16 P 1.2935900000000001e-17
C533 FILL_L8_16 0 6.7918300000000008e-16
C534 FILL_L8_17 N 1.4624100000000001e-18
C535 FILL_L8_17 P 2.0571900000000003e-19
C536 FILL_L8_17 0 7.2446700000000006e-16
C537 FILL_L8_2 FILL_L8_3 1.5333300000000001e-17
C538 FILL_L8_2 FILL_L8_5 1.9913400000000001e-17
C539 FILL_L8_2 0 1.2510800000000002e-16
C540 FILL_L8_3 FILL_L8_6 1.9913400000000001e-17
C541 FILL_L8_3 0 2.0769800000000002e-16
C542 FILL_L8_4 FILL_L8_7 1.9913400000000001e-17
C543 FILL_L8_4 FILL_L8_8 1.9913400000000001e-17
C544 FILL_L8_4 0 1.34885e-16
C545 FILL_L8_5 FILL_L8_6 1.9913400000000001e-17
C546 FILL_L8_5 0 1.3285600000000001e-16
C547 FILL_L8_6 0 1.49255e-16
C548 FILL_L8_7 FILL_L8_8 1.9913400000000001e-17
C549 FILL_L8_7 FILL_L8_9 1.6329000000000003e-17
C550 FILL_L8_7 P 2.5932400000000002e-19
C551 FILL_L8_7 0 3.7828300000000006e-16
C552 FILL_L8_8 P 3.1666400000000002e-19
C553 FILL_L8_8 0 1.34885e-16
C554 FILL_L8_9 0 3.5725299999999999e-16
C555 N P 3.4877500000000003e-15
C556 N 0 1.8997600000000001e-16
C557 P 0 6.16815e-17
VP P 0 DC 0 AC 1
VN N 0 DC 0 AC 0
.control
set numdgt=17
ac lin 1 1Meg 1Meg
let cp = -imag(i(VP))/(2*pi*1e6)
let cn = -imag(i(VN))/(2*pi*1e6)
print cp cn
quit
.endc
.end
