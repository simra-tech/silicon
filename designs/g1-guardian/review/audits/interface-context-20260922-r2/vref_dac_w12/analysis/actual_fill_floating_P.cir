* actual_fill floating drive P; diagnostic capacitor-network AC only
C8 0 FILL_L30_0 2.94669e-16
C9 0 FILL_L30_2 2.9761000000000002e-16
C10 0 FILL_L30_4 2.9761000000000002e-16
C11 0 FILL_L30_6 9.7463100000000006e-17
C12 0 FILL_L8_0 1.9012400000000002e-16
C13 0 FILL_L8_1 2.8134800000000002e-18
C14 0 FILL_L8_2 3.00411e-16
C15 0 FILL_L8_3 4.4157700000000008e-18
C16 0 FILL_L8_4 3.00411e-16
C17 0 FILL_L8_5 4.4157700000000008e-18
C18 0 FILL_L8_6 3.00411e-16
C19 0 FILL_L8_7 4.4157700000000008e-18
C20 0 FILL_L8_8 1.1028700000000001e-16
C21 0 FILL_L8_9 1.6022900000000002e-18
C30 0 FILL_L30_0 1.01523e-16
C31 0 FILL_L30_1 7.6123800000000002e-18
C32 0 FILL_L30_2 1.01523e-16
C33 0 FILL_L30_3 7.6123800000000002e-18
C34 0 FILL_L30_4 1.01523e-16
C35 0 FILL_L30_5 7.6123800000000002e-18
C36 0 FILL_L30_6 3.22335e-17
C37 0 FILL_L30_7 2.4169299999999998e-18
C38 0 FILL_L8_0 9.8309200000000016e-18
C39 0 FILL_L8_1 1.35564e-16
C40 0 FILL_L8_2 1.54297e-17
C41 0 FILL_L8_3 2.14778e-16
C42 0 FILL_L8_4 1.54297e-17
C43 0 FILL_L8_5 2.14778e-16
C44 0 FILL_L8_6 1.54297e-17
C45 0 FILL_L8_7 2.14778e-16
C46 0 FILL_L8_8 5.5987800000000003e-18
C47 0 FILL_L8_9 7.9214500000000012e-17
C48 0 N 1.1274000000000001e-15
C57 0 FILL_L30_1 2.3293399999999999e-16
C58 0 FILL_L30_3 2.3587399999999999e-16
C59 0 FILL_L30_5 2.3587399999999999e-16
C60 0 FILL_L30_7 7.7862100000000001e-17
C61 0 FILL_L8_1 1.2815600000000003e-16
C62 0 FILL_L8_3 2.0315199999999999e-16
C63 0 FILL_L8_5 2.0315199999999999e-16
C64 0 FILL_L8_7 2.0315199999999999e-16
C65 0 FILL_L8_9 7.4995900000000009e-17
C66 0 P 3.3182999999999999e-15
C78 0 FILL_L30_1 2.5969400000000005e-16
C79 0 FILL_L30_3 2.6263500000000003e-16
C80 0 FILL_L30_5 2.6263500000000003e-16
C81 0 FILL_L30_7 8.6358500000000011e-17
C82 0 FILL_L8_1 1.1392500000000002e-17
C83 0 FILL_L8_3 1.7880700000000001e-17
C84 0 FILL_L8_5 1.7880700000000001e-17
C85 0 FILL_L8_7 1.7880700000000001e-17
C86 0 FILL_L8_9 6.4881300000000002e-18
C95 0 FILL_L30_1 8.1156400000000016e-17
C96 0 FILL_L30_3 8.1156400000000016e-17
C97 0 FILL_L30_5 8.1156400000000016e-17
C98 0 FILL_L30_7 2.5767100000000002e-17
C99 0 FILL_L8_1 8.2076300000000005e-19
C100 0 FILL_L8_3 1.2881900000000001e-18
C101 0 FILL_L8_5 1.2881900000000001e-18
C102 0 FILL_L8_7 1.2881900000000001e-18
C103 0 FILL_L8_9 4.6743e-19
C121 0 FILL_L30_0 1.5080600000000003e-16
C122 0 FILL_L30_1 6.91856e-17
C123 0 FILL_L30_2 1.55367e-16
C124 0 FILL_L30_3 6.91856e-17
C125 0 FILL_L30_4 1.55367e-16
C126 0 FILL_L30_5 6.91856e-17
C127 0 FILL_L30_6 5.2054400000000006e-17
C128 0 FILL_L30_7 2.19664e-17
C129 0 FILL_L8_0 1.13973e-17
C130 0 FILL_L8_1 2.2219000000000002e-17
C131 0 FILL_L8_2 2.9178200000000004e-17
C132 0 FILL_L8_3 4.0600400000000005e-17
C133 0 FILL_L8_4 2.2570100000000003e-17
C134 0 FILL_L8_5 3.73833e-17
C135 0 FILL_L8_6 9.3539399999999997e-18
C136 0 FILL_L8_7 3.0949000000000004e-17
C137 0 FILL_L8_8 9.9635300000000017e-19
C138 0 FILL_L8_9 1.02099e-17
C139 0 P 2.0104e-17
C155 0 FILL_L30_1 1.1691000000000001e-16
C156 0 FILL_L30_3 1.1809600000000002e-16
C157 0 FILL_L30_5 1.1809600000000002e-16
C158 0 FILL_L30_7 3.8204000000000004e-17
C159 0 FILL_L8_1 1.4682000000000002e-17
C160 0 FILL_L8_3 2.7419600000000002e-17
C161 0 FILL_L8_5 2.4858200000000002e-17
C162 0 FILL_L8_7 1.9735600000000002e-17
C163 0 FILL_L8_9 6.2318000000000002e-18
C164 0 P 1.49205e-17
C183 0 FILL_L30_4 4.0365000000000004e-17
C184 0 FILL_L30_5 4.3078600000000007e-17
C185 0 FILL_L30_6 1.5642400000000002e-17
C186 0 FILL_L30_7 1.70931e-17
C187 0 FILL_L8_4 7.270460000000001e-18
C188 0 FILL_L8_5 5.9874300000000002e-18
C189 0 FILL_L8_6 6.1730500000000004e-18
C190 0 FILL_L8_7 1.4019500000000002e-17
C191 0 FILL_L8_8 7.0964500000000005e-19
C192 0 FILL_L8_9 4.4735500000000004e-18
C193 0 N 6.714630000000001e-19
C194 0 P 5.3452400000000011e-18
C197 0 FILL_L30_0 3.6979700000000004e-17
C198 0 FILL_L30_2 3.6979700000000004e-17
C199 0 FILL_L30_4 3.6979700000000004e-17
C200 0 FILL_L30_6 1.17411e-17
C201 0 FILL_L8_0 6.7736400000000012e-18
C202 0 FILL_L8_2 1.1746100000000001e-17
C203 0 FILL_L8_4 1.1201400000000001e-17
C204 0 FILL_L8_6 1.0111800000000002e-17
C205 0 FILL_L8_8 3.5887800000000003e-18
C208 0 FILL_L30_0 2.2764899999999999e-16
C209 0 FILL_L30_2 2.3002400000000001e-16
C210 0 FILL_L30_4 2.3002400000000001e-16
C211 0 FILL_L30_6 7.5433700000000012e-17
C212 0 FILL_L8_0 1.0993900000000001e-17
C213 0 FILL_L8_2 2.7277200000000002e-17
C214 0 FILL_L8_4 2.1710400000000001e-17
C215 0 FILL_L8_6 1.0802800000000001e-17
C216 0 FILL_L8_8 2.2390500000000004e-18
C221 0 FILL_L30_1 1.6109400000000002e-16
C222 0 FILL_L30_3 1.6347000000000002e-16
C223 0 FILL_L30_5 1.6347000000000002e-16
C224 0 FILL_L30_7 5.4302600000000003e-17
C225 0 FILL_L8_1 3.2239100000000004e-18
C226 0 FILL_L8_3 9.0734900000000006e-18
C227 0 FILL_L8_5 7.04443e-18
C228 0 FILL_L8_7 3.1069500000000003e-18
C229 0 FILL_L8_9 6.842690000000001e-19
C233 0 FILL_L30_1 1.6109400000000002e-16
C234 0 FILL_L30_3 1.6347000000000002e-16
C235 0 FILL_L30_5 1.6347000000000002e-16
C236 0 FILL_L30_7 5.4302600000000003e-17
C237 0 FILL_L8_1 4.3349300000000004e-19
C238 0 FILL_L8_3 1.1876500000000002e-18
C239 0 FILL_L8_5 8.9074000000000012e-19
C240 0 FILL_L8_7 2.96913e-19
C244 0 FILL_L30_1 2.5097399999999998e-16
C245 0 FILL_L30_3 2.5335000000000001e-16
C246 0 FILL_L30_5 2.5335000000000001e-16
C247 0 FILL_L30_7 8.283950000000001e-17
C248 0 FILL_L8_1 4.1337200000000004e-19
C249 0 FILL_L8_3 1.1325300000000001e-18
C250 0 FILL_L8_5 8.4939500000000011e-19
C251 0 FILL_L8_7 2.8313200000000004e-19
C255 0 FILL_L30_1 2.1349800000000001e-16
C256 0 FILL_L30_3 2.1587400000000001e-16
C257 0 FILL_L30_5 2.1587400000000001e-16
C258 0 FILL_L30_7 7.0940899999999998e-17
C259 0 FILL_L8_1 3.0805200000000001e-19
C260 0 FILL_L8_3 8.4397900000000014e-19
C261 0 FILL_L8_5 6.3298400000000003e-19
C262 0 FILL_L8_7 2.1099500000000001e-19
C265 0 FILL_L30_1 3.4239300000000005e-17
C266 0 FILL_L30_3 3.4239300000000005e-17
C267 0 FILL_L30_5 3.4239300000000005e-17
C268 0 FILL_L30_7 1.0871000000000002e-17
C272 0 FILL_L30_1 1.3544600000000001e-17
C273 0 FILL_L30_3 1.3544600000000001e-17
C274 0 FILL_L30_5 1.3544600000000001e-17
C275 0 FILL_L30_7 4.3003999999999999e-18
C276 0 FILL_L8_1 7.2624300000000003e-19
C277 0 FILL_L8_3 1.13984e-18
C278 0 FILL_L8_5 1.13984e-18
C279 0 FILL_L8_7 1.13984e-18
C280 0 FILL_L8_9 4.1360000000000006e-19
C283 0 FILL_L30_1 2.31776e-18
C284 0 FILL_L30_3 2.31776e-18
C285 0 FILL_L30_5 2.31776e-18
C286 0 FILL_L30_7 7.3588900000000004e-19
C287 0 FILL_L8_1 1.1438300000000001e-19
C288 0 FILL_L8_3 1.5251100000000003e-19
C289 0 FILL_L8_5 2.6689400000000004e-19
C290 0 FILL_L8_7 2.2876700000000002e-19
C293 0 FILL_L30_0 3.0944200000000004e-16
C294 0 FILL_L30_2 3.1181700000000005e-16
C295 0 FILL_L30_4 3.1181700000000005e-16
C296 0 FILL_L30_6 1.0140300000000001e-16
C297 0 FILL_L8_0 1.1768100000000001e-17
C298 0 FILL_L8_2 3.2241300000000007e-17
C299 0 FILL_L8_4 2.4480100000000003e-17
C300 0 FILL_L8_6 9.1838200000000014e-18
C301 0 FILL_L8_8 8.5533600000000003e-19
C304 0 FILL_L30_0 3.0944200000000004e-16
C305 0 FILL_L30_2 3.1181700000000005e-16
C306 0 FILL_L30_4 3.1181700000000005e-16
C307 0 FILL_L30_6 1.0140300000000001e-16
C308 0 FILL_L8_0 4.4804500000000007e-18
C309 0 FILL_L8_1 3.8411500000000004e-19
C310 0 FILL_L8_2 1.2275200000000001e-17
C311 0 FILL_L8_3 1.0523700000000001e-18
C312 0 FILL_L8_4 9.2064100000000003e-18
C313 0 FILL_L8_5 7.8927700000000007e-19
C314 0 FILL_L8_6 3.0688000000000002e-18
C315 0 FILL_L8_7 2.6309200000000002e-19
C319 0 FILL_L30_0 1.7031800000000001e-16
C320 0 FILL_L30_1 3.4565600000000004e-18
C321 0 FILL_L30_2 1.7055600000000003e-16
C322 0 FILL_L30_3 3.4565600000000004e-18
C323 0 FILL_L30_4 1.7055600000000003e-16
C324 0 FILL_L30_5 3.4565600000000004e-18
C325 0 FILL_L30_6 5.4391500000000002e-17
C326 0 FILL_L30_7 1.0974600000000002e-18
C327 0 FILL_L8_1 1.12409e-17
C328 0 FILL_L8_2 1.02657e-19
C329 0 FILL_L8_3 1.8094500000000002e-17
C330 0 FILL_L8_5 1.7974100000000001e-17
C331 0 FILL_L8_7 1.7974100000000001e-17
C332 0 FILL_L8_9 6.7331700000000005e-18
C335 0 FILL_L30_0 1.8617000000000002e-17
C336 0 FILL_L30_1 6.1497500000000007e-18
C337 0 FILL_L30_2 1.8617000000000002e-17
C338 0 FILL_L30_3 6.1497500000000007e-18
C339 0 FILL_L30_4 1.8617000000000002e-17
C340 0 FILL_L30_5 6.1497500000000007e-18
C341 0 FILL_L30_6 5.9108900000000009e-18
C342 0 FILL_L30_7 1.9525399999999999e-18
C343 0 FILL_L8_1 9.7335100000000011e-18
C344 0 FILL_L8_3 1.5276800000000002e-17
C345 0 FILL_L8_5 1.5276800000000002e-17
C346 0 FILL_L8_7 1.5276800000000002e-17
C347 0 FILL_L8_9 5.5433000000000004e-18
C351 0 FILL_L30_0 9.8875000000000007e-18
C352 0 FILL_L30_1 1.0960500000000001e-17
C353 0 FILL_L30_2 9.8875000000000007e-18
C354 0 FILL_L30_3 1.0960500000000001e-17
C355 0 FILL_L30_4 9.8875000000000007e-18
C356 0 FILL_L30_5 1.0960500000000001e-17
C357 0 FILL_L30_6 3.1392800000000001e-18
C358 0 FILL_L30_7 3.4799600000000002e-18
C359 0 FILL_L8_1 1.68159e-17
C360 0 FILL_L8_3 2.6760900000000001e-17
C361 0 FILL_L8_5 2.6760900000000001e-17
C362 0 FILL_L8_7 2.6760900000000001e-17
C363 0 FILL_L8_9 9.9449799999999996e-18
C364 0 N 3.0638300000000001e-17
C367 0 FILL_L30_0 5.6403900000000007e-18
C368 0 FILL_L30_1 6.3988200000000009e-17
C369 0 FILL_L30_2 5.6403900000000007e-18
C370 0 FILL_L30_3 6.3988200000000009e-17
C371 0 FILL_L30_4 5.6403900000000007e-18
C372 0 FILL_L30_5 6.3988200000000009e-17
C373 0 FILL_L30_6 1.7908200000000004e-18
C374 0 FILL_L30_7 2.03163e-17
C375 0 FILL_L8_1 1.1282800000000001e-17
C376 0 FILL_L8_3 1.9521400000000002e-17
C377 0 FILL_L8_5 1.8460200000000003e-17
C378 0 FILL_L8_7 1.6337900000000003e-17
C379 0 FILL_L8_9 5.5433000000000004e-18
C380 0 N 9.2488000000000003e-17
C381 0 P 3.3449700000000005e-17
C384 0 FILL_L30_1 1.7614700000000001e-16
C385 0 FILL_L30_3 1.7852300000000002e-16
C386 0 FILL_L30_5 1.7852300000000002e-16
C387 0 FILL_L30_7 5.9081900000000006e-17
C388 0 FILL_L8_1 7.9189800000000013e-18
C389 0 FILL_L8_3 1.6157600000000001e-17
C390 0 FILL_L8_5 1.3975199999999999e-17
C391 0 FILL_L8_7 9.6103600000000004e-18
C392 0 FILL_L8_9 2.6952900000000001e-18
C393 0 P 3.3189300000000006e-17
C396 0 FILL_L30_1 1.6109400000000002e-16
C397 0 FILL_L30_3 1.6347000000000002e-16
C398 0 FILL_L30_5 1.6347000000000002e-16
C399 0 FILL_L30_7 5.4302600000000003e-17
C400 0 FILL_L8_1 5.2247600000000004e-18
C401 0 FILL_L8_3 1.4314400000000001e-17
C402 0 FILL_L8_5 1.1034900000000001e-17
C403 0 FILL_L8_7 4.7020900000000001e-18
C404 0 FILL_L8_9 8.5533600000000003e-19
C406 0 FILL_L30_0 1.8274000000000002e-19
C407 0 FILL_L30_1 2.3463300000000001e-17
C408 0 FILL_L30_2 1.8274000000000002e-19
C409 0 FILL_L30_3 2.3463300000000001e-17
C410 0 FILL_L30_4 1.2182600000000002e-19
C411 0 FILL_L30_5 2.2847600000000002e-17
C412 0 FILL_L30_7 6.8630900000000004e-18
C413 0 FILL_L8_1 1.5392500000000002e-17
C414 0 FILL_L8_3 2.4158700000000001e-17
C415 0 FILL_L8_5 2.4158700000000001e-17
C416 0 FILL_L8_7 2.4158700000000001e-17
C417 0 FILL_L8_9 8.7661400000000004e-18
C418 0 N 3.6098100000000003e-19
C419 0 P 4.2307500000000001e-19
C421 FILL_L30_0 FILL_L30_1 7.7092600000000011e-17
C422 FILL_L30_0 FILL_L30_2 7.7092600000000011e-17
C423 FILL_L30_0 FILL_L8_0 1.3626800000000001e-16
C424 FILL_L30_0 FILL_L8_1 3.6390300000000006e-17
C425 FILL_L30_0 FILL_L8_2 1.3149800000000001e-16
C426 FILL_L30_0 FILL_L8_3 2.4260200000000003e-17
C427 FILL_L30_0 N 6.9818800000000003e-18
C428 FILL_L30_0 P 2.2902200000000002e-18
C429 FILL_L30_0 0 3.8146600000000004e-16
C430 FILL_L30_1 FILL_L30_3 7.7092600000000011e-17
C431 FILL_L30_1 FILL_L8_1 1.01646e-16
C432 FILL_L30_1 FILL_L8_3 8.8973700000000006e-17
C433 FILL_L30_1 N 2.5466800000000001e-17
C434 FILL_L30_1 P 8.7439400000000006e-17
C435 FILL_L30_1 0 4.1182600000000006e-16
C436 FILL_L30_2 FILL_L30_3 7.7092600000000011e-17
C437 FILL_L30_2 FILL_L30_4 7.7092600000000011e-17
C438 FILL_L30_2 FILL_L8_2 9.9316700000000007e-17
C439 FILL_L30_2 FILL_L8_3 1.2130100000000001e-17
C440 FILL_L30_2 FILL_L8_4 1.8674500000000002e-16
C441 FILL_L30_2 FILL_L8_5 4.8520400000000006e-17
C442 FILL_L30_2 N 6.9818800000000003e-18
C443 FILL_L30_2 P 2.2902200000000002e-18
C444 FILL_L30_2 0 2.9454000000000005e-16
C445 FILL_L30_3 FILL_L30_5 7.7092600000000011e-17
C446 FILL_L30_3 FILL_L8_3 6.2000500000000005e-17
C447 FILL_L30_3 FILL_L8_5 1.38165e-16
C448 FILL_L30_3 N 2.5466800000000001e-17
C449 FILL_L30_3 P 8.8909700000000004e-17
C450 FILL_L30_3 0 3.2797800000000002e-16
C451 FILL_L30_4 FILL_L30_5 7.7092600000000011e-17
C452 FILL_L30_4 FILL_L30_6 7.7092600000000011e-17
C453 FILL_L30_4 FILL_L8_4 4.5396500000000003e-17
C454 FILL_L30_4 FILL_L8_6 2.2111400000000003e-16
C455 FILL_L30_4 FILL_L8_7 7.2780600000000012e-17
C456 FILL_L30_4 N 6.9818800000000003e-18
C457 FILL_L30_4 P 2.2902200000000002e-18
C458 FILL_L30_4 0 2.9790000000000002e-16
C459 FILL_L30_5 FILL_L30_7 7.7092600000000011e-17
C460 FILL_L30_5 FILL_L8_5 2.36851e-17
C461 FILL_L30_5 FILL_L8_7 1.76462e-16
C462 FILL_L30_5 N 2.5466800000000001e-17
C463 FILL_L30_5 P 8.8909700000000004e-17
C464 FILL_L30_5 0 3.2790900000000002e-16
C465 FILL_L30_6 FILL_L30_7 2.4476900000000003e-17
C466 FILL_L30_6 FILL_L8_6 9.1148399999999992e-18
C467 FILL_L30_6 FILL_L8_8 8.1739999999999998e-17
C468 FILL_L30_6 FILL_L8_9 3.0810400000000004e-17
C469 FILL_L30_6 N 2.2167500000000005e-18
C470 FILL_L30_6 P 7.2714500000000005e-19
C471 FILL_L30_6 0 2.2811099999999999e-16
C472 FILL_L30_7 FILL_L8_7 4.7555700000000003e-18
C473 FILL_L30_7 FILL_L8_9 6.8512e-17
C474 FILL_L30_7 N 8.0857200000000011e-18
C475 FILL_L30_7 P 2.9714800000000005e-17
C476 FILL_L30_7 0 2.3972200000000001e-16
C477 FILL_L8_0 FILL_L8_1 4.44068e-17
C478 FILL_L8_0 FILL_L8_2 5.4562600000000006e-17
C479 FILL_L8_0 0 5.2498900000000006e-16
C480 FILL_L8_1 FILL_L8_3 6.96968e-17
C481 FILL_L8_1 N 1.21075e-16
C482 FILL_L8_1 P 8.8475700000000008e-17
C483 FILL_L8_1 0 6.2242100000000008e-16
C484 FILL_L8_2 FILL_L8_3 6.96968e-17
C485 FILL_L8_2 FILL_L8_4 5.4562600000000006e-17
C486 FILL_L8_2 0 6.8086900000000004e-16
C487 FILL_L8_3 FILL_L8_5 6.96968e-17
C488 FILL_L8_3 N 1.9203800000000003e-16
C489 FILL_L8_3 P 1.4087300000000001e-16
C490 FILL_L8_3 0 7.9409500000000004e-16
C491 FILL_L8_4 FILL_L8_5 6.96968e-17
C492 FILL_L8_4 FILL_L8_6 5.4562600000000006e-17
C493 FILL_L8_4 0 6.8086900000000004e-16
C494 FILL_L8_5 FILL_L8_7 6.96968e-17
C495 FILL_L8_5 N 1.9203800000000003e-16
C496 FILL_L8_5 P 1.4087300000000001e-16
C497 FILL_L8_5 0 7.9409500000000004e-16
C498 FILL_L8_6 FILL_L8_7 6.96968e-17
C499 FILL_L8_6 FILL_L8_8 5.4562600000000006e-17
C500 FILL_L8_6 0 6.8086900000000004e-16
C501 FILL_L8_7 FILL_L8_9 6.96968e-17
C502 FILL_L8_7 N 1.9203800000000003e-16
C503 FILL_L8_7 P 1.4087300000000001e-16
C504 FILL_L8_7 0 7.9409500000000004e-16
C505 FILL_L8_8 FILL_L8_9 2.529e-17
C506 FILL_L8_8 0 3.7280500000000005e-16
C507 FILL_L8_9 N 7.0963100000000007e-17
C508 FILL_L8_9 P 5.2397399999999998e-17
C509 FILL_L8_9 0 4.4876900000000007e-16
C510 N P 3.3182999999999999e-15
C511 N 0 9.8231000000000001e-17
C512 P 0 6.9910900000000009e-17
VP P 0 DC 0 AC 1
VN N 0 DC 0 AC 0
.control
set numdgt=17
ac lin 1 1Meg 1Meg
let cp = -imag(i(VP))/(2*pi*1e6)
let cn = -imag(i(VN))/(2*pi*1e6)
print cp cn
quit
.endc
.end
