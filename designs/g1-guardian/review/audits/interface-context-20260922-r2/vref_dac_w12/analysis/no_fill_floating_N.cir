* no_fill floating drive N; diagnostic capacitor-network AC only
C17 0 N 1.1274000000000001e-15
C27 0 P 3.3182999999999999e-15
C64 0 P 3.0019e-17
C80 0 P 2.2421600000000004e-17
C99 0 N 6.714630000000001e-19
C100 0 P 7.7712700000000004e-18
C137 0 N 3.0638300000000001e-17
C140 0 N 9.2488000000000003e-17
C141 0 P 4.9860800000000002e-17
C144 0 P 4.9860800000000002e-17
C148 0 N 1.53938e-18
C149 0 P 1.8041800000000001e-18
C151 N P 3.3182999999999999e-15
C152 N 0 2.9495900000000005e-16
C153 P 0 2.0055800000000001e-16
VP P 0 DC 0 AC 0
VN N 0 DC 0 AC 1
.control
set numdgt=17
ac lin 1 1Meg 1Meg
let cp = -imag(i(VP))/(2*pi*1e6)
let cn = -imag(i(VN))/(2*pi*1e6)
print cp cn
quit
.endc
.end
