* actual_fill grounded drive P; diagnostic capacitor-network AC only
C48 0 N 1.1274000000000001e-15
C66 0 P 3.3182999999999999e-15
C139 0 P 2.0104e-17
C164 0 P 1.49205e-17
C193 0 N 6.714630000000001e-19
C194 0 P 5.3452400000000011e-18
C364 0 N 3.0638300000000001e-17
C380 0 N 9.2488000000000003e-17
C381 0 P 3.3449700000000005e-17
C393 0 P 3.3189300000000006e-17
C418 0 N 3.6098100000000003e-19
C419 0 P 4.2307500000000001e-19
C427 0 N 6.9818800000000003e-18
C428 0 P 2.2902200000000002e-18
C433 0 N 2.5466800000000001e-17
C434 0 P 8.7439400000000006e-17
C442 0 N 6.9818800000000003e-18
C443 0 P 2.2902200000000002e-18
C448 0 N 2.5466800000000001e-17
C449 0 P 8.8909700000000004e-17
C456 0 N 6.9818800000000003e-18
C457 0 P 2.2902200000000002e-18
C462 0 N 2.5466800000000001e-17
C463 0 P 8.8909700000000004e-17
C469 0 N 2.2167500000000005e-18
C470 0 P 7.2714500000000005e-19
C474 0 N 8.0857200000000011e-18
C475 0 P 2.9714800000000005e-17
C481 0 N 1.21075e-16
C482 0 P 8.8475700000000008e-17
C488 0 N 1.9203800000000003e-16
C489 0 P 1.4087300000000001e-16
C495 0 N 1.9203800000000003e-16
C496 0 P 1.4087300000000001e-16
C502 0 N 1.9203800000000003e-16
C503 0 P 1.4087300000000001e-16
C507 0 N 7.0963100000000007e-17
C508 0 P 5.2397399999999998e-17
C510 N P 3.3182999999999999e-15
C511 N 0 9.8231000000000001e-17
C512 P 0 6.9910900000000009e-17
VP P 0 DC 0 AC 1
VN N 0 DC 0 AC 0
.control
set numdgt=17
ac lin 1 1Meg 1Meg
let cp = -imag(i(VP))/(2*pi*1e6)
let cn = -imag(i(VN))/(2*pi*1e6)
print cp cn
quit
.endc
.end
