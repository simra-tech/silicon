* cell sense_fill_clip
.SUBCKT sense_fill_clip
* net 1 CTX_L8_0
* net 2 CTX_L10_0
* net 3 CTX_L10_1
* net 4 N
* net 5 P
* net 6 CTX_L10_4
* net 7 CTX_L10_5
* net 8 CTX_L10_6
* net 9 CTX_L50_0
* net 10 CTX_L50_1
* net 11 CTX_L50_2
* net 12 CTX_L50_3
* net 13 CTX_L50_4
* net 14 CTX_L50_5
* net 15 CTX_L50_6
* net 16 CTX_L50_7
* net 17 CTX_L50_8
* net 18 CTX_L50_9
* net 19 CTX_L50_10
* net 20 CTX_L50_11
* net 21 CTX_L50_12
* net 22 CTX_L50_13
* net 23 CTX_L50_14
* net 24 CTX_L50_15
* net 25 CTX_L50_16
* net 26 CTX_L126_0
* net 27 CTX_L126_1
* net 28 CTX_L134_0
.ENDS sense_fill_clip
