* cell sense_fill_clip
.SUBCKT sense_fill_clip
* net 2 CTX_L50_0
* net 3 CTX_L50_1
* net 4 FILL_L8_2
* net 5 FILL_L8_0
* net 6 CTX_L10_0
* net 7 CTX_L50_2
* net 8 FILL_L30_2
* net 9 FILL_L67_2
* net 10 FILL_L30_0
* net 11 FILL_L67_0
* net 12 CTX_L50_3
* net 13 CTX_L126_0
* net 14 CTX_L50_4
* net 15 CTX_L50_5
* net 16 CTX_L10_1
* net 17 CTX_L50_6
* net 18 CTX_L50_7
* net 19 N
* net 20 FILL_L8_3
* net 21 FILL_L8_1
* net 22 P
* net 23 CTX_L10_4
* net 24 CTX_L50_8
* net 25 CTX_L50_9
* net 26 CTX_L50_10
* net 27 CTX_L50_11
* net 28 FILL_L30_1
* net 29 FILL_L30_3
* net 30 FILL_L67_3
* net 31 FILL_L67_1
* net 32 CTX_L50_12
* net 33 CTX_L10_5
* net 34 CTX_L50_13
* net 35 CTX_L50_14
* net 36 CTX_L10_6
* net 37 CTX_L126_1
* net 38 CTX_L50_15
* net 39 CTX_L50_16
* net 40 CTX_L8_0
* net 41 FILL_L8_6
* net 42 FILL_L8_4
* net 43 FILL_L8_8
* net 44 FILL_L30_6
* net 45 FILL_L30_4
* net 46 FILL_L67_6
* net 47 FILL_L67_4
* net 48 FILL_L8_7
* net 49 FILL_L8_9
* net 50 FILL_L8_5
* net 51 CTX_L134_0
* net 52 FILL_L30_7
* net 53 FILL_L67_7
* net 54 FILL_L67_5
* net 55 FILL_L30_5
.ENDS sense_fill_clip
