* actual_fill floating drive N; diagnostic capacitor-network AC only
C16 0 FILL_L10_16 2.8772900000000003e-16
C17 0 FILL_L10_17 2.86513e-16
C18 0 FILL_L10_18 5.9056100000000004e-17
C19 0 FILL_L30_1 1.8420200000000003e-17
C20 0 FILL_L30_10 1.45276e-19
C21 0 FILL_L30_2 7.1557000000000011e-18
C22 0 FILL_L30_9 2.50476e-19
C23 0 FILL_L50_4 2.1507200000000002e-17
C24 0 FILL_L50_5 4.5235000000000006e-18
C25 0 FILL_L50_6 2.8468200000000006e-16
C26 0 FILL_L50_7 1.2038700000000002e-16
C27 0 FILL_L8_15 4.2481300000000002e-17
C28 0 FILL_L8_16 2.2045700000000001e-16
C29 0 FILL_L8_17 1.35046e-16
C30 0 FILL_L8_18 3.1802700000000003e-18
C31 0 FILL_L8_19 3.2205200000000002e-18
C32 0 FILL_L8_20 1.6102600000000001e-18
C33 0 FILL_L8_21 5.0998100000000006e-17
C34 0 FILL_L8_22 1.1938300000000001e-16
C35 0 FILL_L8_27 3.9600600000000002e-17
C36 0 FILL_L8_28 9.3118500000000009e-17
C37 0 N 2.8850100000000003e-17
C38 0 P 2.1973000000000002e-17
C53 0 FILL_L10_0 8.8464700000000007e-18
C54 0 FILL_L10_10 1.1488900000000001e-17
C55 0 FILL_L10_4 1.1488900000000001e-17
C56 0 FILL_L30_0 4.9031100000000003e-18
C57 0 FILL_L30_10 3.5134200000000004e-18
C58 0 FILL_L30_2 2.9409200000000002e-17
C59 0 FILL_L30_3 4.9031100000000003e-18
C60 0 FILL_L30_9 4.9031100000000003e-18
C61 0 FILL_L8_1 7.2997600000000016e-17
C62 0 FILL_L8_12 3.3867400000000004e-18
C63 0 FILL_L8_13 3.1992300000000003e-16
C64 0 FILL_L8_14 2.3606400000000001e-18
C65 0 FILL_L8_15 1.9643100000000001e-18
C66 0 FILL_L8_16 3.1992300000000003e-16
C67 0 FILL_L8_17 1.2637800000000001e-17
C68 0 FILL_L8_2 1.8176900000000002e-18
C69 0 FILL_L8_22 3.1992300000000003e-16
C70 0 FILL_L8_23 1.2728800000000001e-17
C71 0 FILL_L8_28 2.4692500000000001e-16
C72 0 FILL_L8_29 9.928430000000001e-18
C73 0 FILL_L8_6 2.3606400000000001e-18
C87 0 FILL_L10_1 9.3719500000000004e-18
C88 0 FILL_L10_11 1.4294000000000001e-17
C89 0 FILL_L10_16 5.0029100000000004e-17
C90 0 FILL_L10_19 5.0029100000000004e-17
C91 0 FILL_L10_22 3.9022700000000004e-17
C92 0 FILL_L10_5 1.2171400000000001e-17
C93 0 FILL_L30_0 4.1447000000000008e-18
C94 0 FILL_L30_10 2.9074e-18
C95 0 FILL_L30_3 3.6203200000000002e-18
C96 0 FILL_L30_4 4.2143900000000006e-17
C97 0 FILL_L30_9 4.1227600000000004e-18
C98 0 FILL_L50_1 1.1485900000000001e-18
C99 0 FILL_L50_10 2.20946e-18
C100 0 FILL_L50_2 1.8661000000000004e-18
C101 0 FILL_L50_5 6.8915199999999999e-19
C102 0 FILL_L50_6 4.4786399999999999e-19
C103 0 FILL_L50_9 2.2512300000000004e-18
C104 0 FILL_L8_1 1.4210900000000002e-18
C105 0 FILL_L8_13 6.7650200000000001e-18
C106 0 FILL_L8_14 1.2662800000000002e-17
C107 0 FILL_L8_16 6.0626900000000004e-18
C108 0 FILL_L8_17 3.2539200000000003e-16
C109 0 FILL_L8_2 9.7503800000000007e-18
C110 0 FILL_L8_22 6.4594800000000007e-18
C111 0 FILL_L8_23 3.2388600000000005e-16
C112 0 FILL_L8_28 4.8538400000000001e-18
C113 0 FILL_L8_29 2.50016e-16
C114 0 FILL_L8_6 1.2662800000000002e-17
C115 0 N 1.5173700000000001e-17
C116 0 P 1.87259e-17
C133 0 FILL_L10_0 2.7828100000000001e-18
C134 0 FILL_L10_1 2.0984100000000001e-18
C135 0 FILL_L10_10 3.6140400000000007e-18
C136 0 FILL_L10_11 2.21167e-18
C137 0 FILL_L10_12 2.1373400000000003e-18
C138 0 FILL_L10_16 2.8820800000000003e-17
C139 0 FILL_L10_19 3.6027400000000003e-17
C140 0 FILL_L10_22 6.2968700000000008e-18
C141 0 FILL_L10_4 3.6140400000000007e-18
C142 0 FILL_L30_0 3.4193300000000004e-17
C143 0 FILL_L30_1 3.6739700000000006e-18
C144 0 FILL_L30_10 1.79193e-17
C145 0 FILL_L30_2 7.604160000000001e-18
C146 0 FILL_L30_3 2.9634200000000002e-17
C147 0 FILL_L30_4 9.0497100000000002e-18
C148 0 FILL_L30_9 2.9215199999999998e-17
C149 0 FILL_L50_0 3.57277e-18
C150 0 FILL_L50_1 3.57277e-18
C151 0 FILL_L50_10 4.0803200000000008e-18
C152 0 FILL_L50_2 4.10082e-18
C153 0 FILL_L50_4 3.5370400000000002e-18
C154 0 FILL_L50_5 3.57277e-18
C155 0 FILL_L50_6 4.0085600000000006e-18
C156 0 FILL_L50_8 3.57277e-18
C157 0 FILL_L50_9 3.5013200000000003e-18
C158 0 FILL_L8_0 2.1078700000000002e-18
C159 0 FILL_L8_1 1.3415900000000001e-17
C160 0 FILL_L8_12 1.52994e-17
C161 0 FILL_L8_13 6.1823200000000002e-17
C162 0 FILL_L8_14 8.718710000000001e-18
C163 0 FILL_L8_15 2.1450000000000002e-17
C164 0 FILL_L8_16 5.2467100000000003e-17
C165 0 FILL_L8_17 5.9215600000000007e-17
C166 0 FILL_L8_2 6.2372500000000012e-18
C167 0 FILL_L8_21 2.09487e-17
C168 0 FILL_L8_22 5.79938e-17
C169 0 FILL_L8_23 5.8453200000000009e-17
C170 0 FILL_L8_27 1.6243099999999999e-17
C171 0 FILL_L8_28 4.0973700000000003e-17
C172 0 FILL_L8_29 4.8816200000000004e-17
C173 0 FILL_L8_6 8.718710000000001e-18
C174 0 N 2.4479500000000003e-17
C175 0 P 2.9385200000000003e-17
C189 0 FILL_L10_0 2.9258800000000001e-18
C190 0 FILL_L10_1 1.95976e-18
C191 0 FILL_L10_10 6.4212300000000009e-18
C192 0 FILL_L10_11 3.32537e-18
C193 0 FILL_L10_12 4.4897700000000006e-18
C194 0 FILL_L10_13 5.09774e-18
C195 0 FILL_L10_16 1.05582e-16
C196 0 FILL_L10_17 3.9462300000000003e-17
C197 0 FILL_L10_19 1.6013500000000001e-16
C198 0 FILL_L10_2 7.5551800000000002e-18
C199 0 FILL_L10_20 5.6982100000000007e-17
C200 0 FILL_L10_21 3.0058900000000002e-18
C201 0 FILL_L10_22 9.3361500000000016e-17
C202 0 FILL_L10_23 6.4184900000000007e-17
C203 0 FILL_L10_24 5.0463699999999996e-18
C204 0 FILL_L10_4 4.3398300000000006e-18
C205 0 FILL_L10_5 4.5526100000000007e-19
C206 0 FILL_L10_6 6.6841600000000003e-19
C207 0 FILL_L30_1 3.9488099999999999e-18
C208 0 FILL_L30_10 1.5122100000000002e-19
C209 0 FILL_L30_2 3.86983e-18
C210 0 FILL_L30_4 5.9535000000000007e-18
C211 0 FILL_L30_5 1.9314400000000001e-18
C212 0 FILL_L30_6 4.7910100000000007e-18
C213 0 FILL_L50_0 4.3655400000000009e-18
C214 0 FILL_L50_1 7.0138000000000004e-18
C215 0 FILL_L50_10 3.6276700000000002e-16
C216 0 FILL_L50_11 2.8644900000000001e-17
C217 0 FILL_L50_12 5.3157800000000004e-18
C218 0 FILL_L50_13 1.5252400000000001e-18
C219 0 FILL_L50_2 1.1911e-16
C220 0 FILL_L50_4 1.81907e-17
C221 0 FILL_L50_5 1.2221700000000002e-17
C222 0 FILL_L50_6 3.4778900000000001e-16
C223 0 FILL_L50_7 3.6472700000000005e-17
C224 0 FILL_L50_8 1.2813300000000001e-17
C225 0 FILL_L50_9 2.0890500000000001e-17
C226 0 FILL_L8_0 2.37303e-18
C227 0 FILL_L8_1 7.7557499999999997e-18
C228 0 FILL_L8_12 2.0057600000000003e-17
C229 0 FILL_L8_13 4.2391200000000003e-17
C230 0 FILL_L8_14 1.65397e-18
C231 0 FILL_L8_15 2.7038700000000001e-17
C232 0 FILL_L8_16 3.7268400000000004e-17
C233 0 FILL_L8_17 5.21804e-17
C234 0 FILL_L8_18 2.3587799999999999e-18
C235 0 FILL_L8_19 1.3067100000000001e-18
C236 0 FILL_L8_2 9.8393900000000005e-19
C237 0 FILL_L8_21 2.2155900000000001e-17
C238 0 FILL_L8_22 3.4376900000000001e-17
C239 0 FILL_L8_23 4.4988500000000004e-17
C240 0 FILL_L8_24 1.50179e-18
C241 0 FILL_L8_25 2.10982e-18
C242 0 FILL_L8_29 3.0039400000000001e-17
C243 0 FILL_L8_30 3.1053600000000003e-18
C244 0 FILL_L8_31 3.1053600000000003e-18
C245 0 FILL_L8_6 1.4254700000000001e-18
C246 0 N 6.4053799999999994e-17
C247 0 P 2.8591500000000001e-17
C254 0 FILL_L10_0 1.47622e-17
C255 0 FILL_L10_10 1.8774300000000001e-18
C256 0 FILL_L10_4 1.8881200000000001e-17
C257 0 FILL_L30_0 7.7092600000000005e-18
C258 0 FILL_L8_0 8.5595400000000003e-18
C259 0 FILL_L8_1 1.8745800000000001e-17
C260 0 FILL_L8_12 3.0139299999999998e-17
C261 0 FILL_L8_13 4.9147100000000006e-17
C262 0 FILL_L8_15 2.44397e-19
C270 0 FILL_L10_1 8.5130700000000012e-17
C271 0 FILL_L10_11 1.2781300000000001e-17
C272 0 FILL_L10_12 1.2920400000000001e-17
C273 0 FILL_L10_13 1.2649100000000002e-17
C274 0 FILL_L10_14 1.2781300000000001e-17
C275 0 FILL_L10_15 9.7059200000000011e-18
C276 0 FILL_L10_16 4.0629999999999999e-18
C277 0 FILL_L10_17 3.9722300000000003e-18
C278 0 FILL_L10_18 3.4293000000000006e-19
C279 0 FILL_L10_2 2.8920600000000005e-16
C280 0 FILL_L10_3 1.8965700000000003e-16
C281 0 FILL_L10_5 1.6277900000000001e-16
C282 0 FILL_L10_6 1.58505e-16
C283 0 FILL_L10_7 1.58505e-16
C284 0 FILL_L10_8 1.58505e-16
C285 0 FILL_L10_9 4.6276800000000006e-17
C286 0 FILL_L30_0 1.27509e-17
C287 0 FILL_L50_0 1.8888900000000003e-16
C288 0 FILL_L50_1 2.4520700000000002e-17
C289 0 FILL_L50_2 1.03439e-15
C290 0 FILL_L50_3 4.4333600000000005e-16
C291 0 FILL_L50_4 4.0741100000000007e-19
C292 0 FILL_L50_6 1.4259400000000002e-18
C293 0 FILL_L50_7 6.8445100000000004e-19
C294 0 FILL_L8_1 1.2225500000000001e-18
C295 0 FILL_L8_10 2.5681999999999999e-17
C296 0 FILL_L8_11 9.7755899999999993e-18
C297 0 FILL_L8_13 6.29604e-18
C298 0 FILL_L8_17 2.9465800000000003e-18
C299 0 FILL_L8_2 2.4874600000000003e-18
C300 0 FILL_L8_3 1.27868e-17
C301 0 FILL_L8_4 3.9090800000000002e-17
C302 0 FILL_L8_5 2.9524299999999999e-17
C303 0 FILL_L8_6 7.687050000000001e-18
C304 0 FILL_L8_7 2.5764500000000005e-17
C305 0 FILL_L8_8 2.5681999999999999e-17
C306 0 FILL_L8_9 2.5605600000000002e-17
C307 0 N 1.2387300000000001e-16
C308 0 P 1.2384300000000001e-16
C318 0 FILL_L10_10 6.4415100000000005e-18
C319 0 FILL_L10_4 1.1709200000000001e-18
C320 0 FILL_L30_0 7.1429400000000012e-18
C321 0 FILL_L30_10 1.8044700000000003e-18
C322 0 FILL_L30_3 2.4718700000000003e-18
C323 0 FILL_L30_4 1.2958900000000001e-17
C324 0 FILL_L30_9 2.42244e-18
C325 0 FILL_L8_1 1.0328e-18
C326 0 FILL_L8_12 1.8431900000000001e-17
C327 0 FILL_L8_13 4.9488300000000008e-17
C328 0 FILL_L8_14 6.4809000000000007e-18
C329 0 FILL_L8_15 6.3828000000000009e-17
C330 0 FILL_L8_16 6.07168e-17
C331 0 FILL_L8_17 7.727910000000001e-17
C332 0 FILL_L8_2 7.14146e-19
C333 0 FILL_L8_23 5.2386900000000003e-17
C334 0 FILL_L8_29 4.4376300000000006e-17
C335 0 FILL_L8_6 2.1914000000000001e-18
C336 0 N 1.0038200000000001e-19
C337 0 P 1.4308399999999999e-19
C341 0 FILL_L10_1 5.1816800000000005e-18
C342 0 FILL_L10_11 1.1098200000000002e-17
C343 0 FILL_L10_12 6.1522000000000003e-18
C344 0 FILL_L10_13 5.1024000000000007e-18
C345 0 FILL_L10_14 4.3594600000000008e-18
C346 0 FILL_L10_15 2.9644300000000002e-18
C347 0 FILL_L10_16 1.8812000000000001e-16
C348 0 FILL_L10_17 1.8915400000000002e-16
C349 0 FILL_L10_18 4.0140700000000007e-17
C350 0 FILL_L10_2 2.2725e-18
C351 0 FILL_L50_0 9.8265900000000003e-17
C352 0 FILL_L50_1 1.0069900000000001e-16
C353 0 FILL_L50_2 4.2291800000000008e-17
C354 0 FILL_L50_3 5.8898700000000005e-18
C355 0 FILL_L50_4 1.07493e-16
C356 0 FILL_L50_6 1.9101800000000001e-16
C357 0 FILL_L50_7 8.1530400000000005e-17
C358 0 FILL_L8_17 4.0826600000000001e-18
C359 0 FILL_L8_18 2.5716600000000002e-18
C360 0 FILL_L8_19 3.2205200000000002e-18
C361 0 FILL_L8_20 1.6102600000000001e-18
C362 0 FILL_L8_3 2.8607300000000005e-19
C363 0 N 1.3678700000000001e-15
C364 0 P 6.4718300000000003e-19
C372 0 FILL_L10_0 3.78335e-19
C373 0 FILL_L10_10 4.9134400000000003e-19
C374 0 FILL_L10_16 1.4053899999999999e-16
C375 0 FILL_L10_17 1.4053899999999999e-16
C376 0 FILL_L10_18 2.7304600000000002e-17
C377 0 FILL_L10_19 4.7488300000000006e-17
C378 0 FILL_L10_20 5.03764e-17
C379 0 FILL_L10_21 1.09629e-17
C380 0 FILL_L10_22 1.8939700000000001e-18
C381 0 FILL_L10_23 2.3674600000000002e-18
C382 0 FILL_L10_24 6.4395000000000005e-19
C383 0 FILL_L10_4 4.9134400000000003e-19
C384 0 FILL_L30_0 3.5065000000000004e-19
C385 0 FILL_L30_2 1.3168200000000002e-18
C386 0 FILL_L30_3 1.8158600000000001e-17
C387 0 FILL_L30_4 1.8158600000000001e-17
C388 0 FILL_L30_5 1.8158600000000001e-17
C389 0 FILL_L30_6 1.8158600000000001e-17
C390 0 FILL_L30_7 1.8158600000000001e-17
C391 0 FILL_L30_8 1.8158600000000001e-17
C392 0 FILL_L50_10 1.1722300000000001e-17
C393 0 FILL_L50_11 3.9855900000000008e-18
C394 0 FILL_L50_5 5.2148100000000004e-17
C395 0 FILL_L50_6 2.23906e-16
C396 0 FILL_L50_7 9.5343100000000008e-17
C397 0 FILL_L8_1 1.05945e-17
C398 0 FILL_L8_13 4.8221300000000004e-17
C399 0 FILL_L8_16 7.2805300000000002e-17
C400 0 FILL_L8_17 7.2785100000000003e-17
C401 0 FILL_L8_18 4.2239000000000011e-18
C402 0 FILL_L8_19 4.2239000000000011e-18
C403 0 FILL_L8_20 8.2064300000000009e-19
C404 0 FILL_L8_22 7.5029400000000008e-18
C405 0 FILL_L8_23 5.5010500000000002e-17
C406 0 FILL_L8_24 3.2598500000000004e-18
C407 0 FILL_L8_25 3.2132800000000002e-18
C408 0 FILL_L8_26 6.3334300000000003e-19
C409 0 FILL_L8_28 2.8867399999999998e-19
C410 0 FILL_L8_29 5.0604199999999999e-18
C411 0 N 2.6109400000000004e-17
C412 0 P 2.2345500000000002e-17
C419 0 FILL_L30_1 2.5545100000000004e-17
C420 0 FILL_L30_10 2.1398200000000001e-17
C421 0 FILL_L30_2 2.7533200000000004e-17
C422 0 FILL_L30_3 2.9393299999999999e-17
C423 0 FILL_L30_9 2.9393299999999999e-17
C424 0 FILL_L8_15 3.94922e-17
C425 0 FILL_L8_16 4.0032400000000006e-17
C426 0 FILL_L8_21 3.88476e-17
C427 0 FILL_L8_22 9.2216900000000001e-17
C428 0 FILL_L8_23 1.2555300000000001e-17
C429 0 FILL_L8_27 1.9859599999999999e-18
C430 0 FILL_L8_28 2.2332600000000001e-17
C431 0 FILL_L8_29 9.3563800000000011e-18
C437 0 FILL_L30_1 9.5269300000000005e-18
C438 0 FILL_L30_10 1.6242000000000001e-19
C439 0 FILL_L30_2 9.6257800000000021e-18
C440 0 FILL_L8_16 1.6848200000000001e-19
C441 0 FILL_L8_21 1.6807400000000002e-17
C442 0 FILL_L8_22 2.1993900000000001e-17
C443 0 FILL_L8_27 7.7885700000000005e-17
C444 0 FILL_L8_28 1.06833e-16
C445 0 FILL_L8_29 3.2717500000000003e-18
C450 0 FILL_L30_10 2.8909699999999999e-18
C451 0 FILL_L8_27 3.3821700000000002e-17
C452 0 FILL_L8_28 4.0654500000000002e-17
C456 0 FILL_L10_19 9.7039000000000012e-18
C457 0 FILL_L10_20 1.0386100000000002e-17
C458 0 FILL_L10_21 2.2829400000000001e-18
C459 0 FILL_L10_22 2.7799400000000003e-16
C460 0 FILL_L10_23 2.6657300000000001e-16
C461 0 FILL_L10_24 5.5059800000000006e-17
C462 0 FILL_L30_10 5.7559000000000003e-18
C463 0 FILL_L30_5 7.4834200000000008e-18
C464 0 FILL_L30_6 7.4834200000000008e-18
C465 0 FILL_L30_7 7.4834200000000008e-18
C466 0 FILL_L30_8 7.4834200000000008e-18
C467 0 FILL_L50_10 2.5551300000000004e-17
C468 0 FILL_L50_11 9.4432100000000005e-18
C469 0 FILL_L50_12 4.9191400000000005e-17
C470 0 FILL_L50_13 6.035260000000001e-17
C471 0 FILL_L50_9 3.8237100000000004e-18
C472 0 FILL_L8_29 1.4080700000000002e-17
C473 0 FILL_L8_30 2.9543000000000001e-18
C474 0 FILL_L8_31 3.2205200000000002e-18
C475 0 FILL_L8_32 1.6102600000000001e-18
C476 0 N 1.4308899999999999e-17
C477 0 P 2.0004200000000004e-18
C481 0 FILL_L10_0 4.5605100000000002e-18
C482 0 FILL_L10_10 5.9227400000000006e-18
C483 0 FILL_L10_4 5.9227400000000006e-18
C484 0 FILL_L30_0 1.8238e-19
C485 0 FILL_L30_1 6.0853000000000003e-18
C486 0 FILL_L30_10 2.1156100000000002e-19
C487 0 FILL_L30_2 3.5368400000000007e-17
C488 0 FILL_L30_9 3.6476e-19
C489 0 FILL_L8_0 2.4787200000000004e-18
C490 0 FILL_L8_1 1.1319600000000001e-17
C491 0 FILL_L8_12 1.8829800000000001e-17
C492 0 FILL_L8_13 4.9680600000000004e-17
C493 0 FILL_L8_15 2.7261399999999999e-17
C494 0 FILL_L8_16 4.5215100000000005e-17
C495 0 FILL_L8_21 2.6225100000000004e-17
C496 0 FILL_L8_22 7.4330200000000005e-17
C497 0 FILL_L8_27 7.1817800000000003e-18
C498 0 FILL_L8_28 6.3133600000000007e-17
C501 0 FILL_L8_28 1.1022200000000001e-18
C504 0 FILL_L30_0 9.2736800000000007e-18
C505 0 FILL_L30_10 1.19655e-18
C506 0 FILL_L30_2 1.9678300000000001e-17
C507 0 FILL_L30_3 1.7596400000000004e-18
C508 0 FILL_L30_9 1.7596400000000004e-18
C509 0 FILL_L8_1 1.0593100000000001e-17
C510 0 FILL_L8_13 4.5973100000000007e-17
C511 0 FILL_L8_14 2.4478700000000003e-18
C512 0 FILL_L8_16 3.9306600000000006e-17
C513 0 FILL_L8_17 7.3313800000000014e-18
C514 0 FILL_L8_2 1.8848600000000002e-18
C515 0 FILL_L8_22 6.1883700000000006e-17
C516 0 FILL_L8_28 3.9725600000000004e-17
C517 0 FILL_L8_6 2.4478700000000003e-18
C521 0 FILL_L30_0 2.2944299999999999e-17
C522 0 FILL_L30_10 1.6749400000000001e-17
C523 0 FILL_L30_3 2.2944299999999999e-17
C524 0 FILL_L30_4 1.5374400000000001e-18
C525 0 FILL_L30_9 2.2851200000000001e-17
C526 0 FILL_L8_1 3.0512000000000004e-18
C527 0 FILL_L8_13 1.4547800000000002e-17
C528 0 FILL_L8_14 1.0723699999999999e-17
C529 0 FILL_L8_16 1.19811e-17
C530 0 FILL_L8_17 3.09915e-17
C531 0 FILL_L8_2 7.7953600000000004e-18
C532 0 FILL_L8_23 3.1426600000000002e-17
C533 0 FILL_L8_29 2.4119599999999999e-17
C534 0 FILL_L8_6 1.0723699999999999e-17
C537 0 FILL_L10_1 4.6008100000000009e-19
C538 0 FILL_L10_11 8.3637000000000004e-19
C539 0 FILL_L10_16 2.5383800000000004e-18
C540 0 FILL_L10_19 2.3499900000000001e-18
C541 0 FILL_L10_22 2.2163800000000001e-18
C542 0 FILL_L10_5 4.5859400000000005e-19
C543 0 FILL_L30_0 3.0866700000000007e-19
C544 0 FILL_L30_10 1.9476100000000001e-19
C545 0 FILL_L30_4 5.0477300000000002e-17
C546 0 FILL_L30_5 2.7253600000000004e-19
C547 0 FILL_L30_9 4.2414700000000004e-19
C548 0 FILL_L8_13 2.95089e-19
C549 0 FILL_L8_14 2.4729900000000001e-18
C550 0 FILL_L8_17 5.5943600000000008e-17
C551 0 FILL_L8_2 1.7883700000000001e-18
C552 0 FILL_L8_23 4.9781300000000005e-17
C553 0 FILL_L8_29 4.4373600000000006e-17
C554 0 FILL_L8_6 2.3362800000000002e-18
C555 0 P 3.4877500000000003e-15
C557 0 FILL_L10_1 1.5297400000000002e-18
C558 0 FILL_L10_11 5.7463900000000001e-17
C559 0 FILL_L10_12 5.1540700000000005e-17
C560 0 FILL_L10_13 5.0924900000000002e-17
C561 0 FILL_L10_14 5.08099e-17
C562 0 FILL_L10_15 3.1468800000000003e-17
C563 0 FILL_L10_16 3.5427400000000001e-18
C564 0 FILL_L10_17 3.5427400000000001e-18
C565 0 FILL_L10_18 1.3557400000000001e-19
C566 0 FILL_L10_2 2.6405800000000005e-19
C567 0 FILL_L10_3 2.6405800000000005e-19
C568 0 FILL_L10_5 2.5012500000000005e-18
C569 0 FILL_L10_6 5.1456700000000007e-19
C570 0 FILL_L10_7 5.1456700000000007e-19
C571 0 FILL_L10_8 5.1456700000000007e-19
C572 0 FILL_L30_0 1.2871200000000001e-18
C573 0 FILL_L30_8 2.3694400000000001e-19
C574 0 FILL_L50_1 2.89328e-18
C575 0 FILL_L50_10 2.8287200000000005e-19
C576 0 FILL_L50_2 2.7057900000000001e-17
C577 0 FILL_L50_3 9.0993899999999998e-18
C578 0 FILL_L50_6 1.2341600000000001e-17
C579 0 FILL_L50_7 7.1360400000000001e-18
C580 0 FILL_L8_10 1.2984600000000001e-17
C581 0 FILL_L8_11 2.3372300000000002e-18
C582 0 FILL_L8_13 8.348340000000001e-18
C583 0 FILL_L8_14 1.0790500000000001e-17
C584 0 FILL_L8_18 7.1176600000000001e-17
C585 0 FILL_L8_19 7.1176600000000001e-17
C586 0 FILL_L8_2 8.3086600000000006e-18
C587 0 FILL_L8_20 1.3828600000000001e-17
C588 0 FILL_L8_3 1.5123699999999999e-17
C589 0 FILL_L8_4 9.1454500000000009e-18
C590 0 FILL_L8_5 9.1454500000000009e-18
C591 0 FILL_L8_6 1.0790500000000001e-17
C592 0 FILL_L8_7 3.2625799999999998e-17
C593 0 FILL_L8_8 1.2984600000000001e-17
C594 0 FILL_L8_9 1.2984600000000001e-17
C595 0 N 1.16519e-17
C596 0 P 3.8117600000000003e-18
C598 FILL_L10_0 FILL_L10_4 2.7935199999999999e-17
C599 FILL_L10_0 FILL_L8_0 7.3290700000000001e-17
C600 FILL_L10_0 FILL_L8_1 6.6221700000000001e-18
C601 FILL_L10_0 0 8.0138900000000007e-17
C602 FILL_L10_1 FILL_L10_2 2.1510100000000004e-17
C603 FILL_L10_1 FILL_L10_5 2.7935199999999999e-17
C604 FILL_L10_1 FILL_L50_0 2.7412500000000003e-18
C605 FILL_L10_1 FILL_L8_3 5.1763199999999999e-17
C606 FILL_L10_1 N 5.3580200000000006e-19
C607 FILL_L10_1 P 4.3091600000000004e-19
C608 FILL_L10_1 0 7.7353800000000008e-17
C609 FILL_L10_10 FILL_L10_4 2.7935199999999999e-17
C610 FILL_L10_10 FILL_L8_12 1.3240400000000001e-16
C611 FILL_L10_10 FILL_L8_13 8.6002200000000009e-18
C612 FILL_L10_10 FILL_L8_15 1.0479400000000001e-17
C613 FILL_L10_10 FILL_L8_21 7.1222700000000006e-19
C614 FILL_L10_10 0 5.75781e-17
C615 FILL_L10_11 FILL_L10_12 2.7935199999999999e-17
C616 FILL_L10_11 FILL_L10_16 2.7935199999999999e-17
C617 FILL_L10_11 FILL_L10_5 1.39676e-17
C618 FILL_L10_11 FILL_L50_1 2.1761200000000001e-17
C619 FILL_L10_11 FILL_L50_4 3.8908000000000001e-18
C620 FILL_L10_11 FILL_L8_7 1.51036e-18
C621 FILL_L10_11 N 1.26457e-18
C622 FILL_L10_11 P 1.0394800000000001e-18
C623 FILL_L10_11 0 8.1147100000000002e-17
C624 FILL_L10_12 FILL_L10_13 2.7935199999999999e-17
C625 FILL_L10_12 FILL_L10_16 2.7935199999999999e-17
C626 FILL_L10_12 FILL_L10_6 1.39676e-17
C627 FILL_L10_12 FILL_L50_1 1.9454000000000001e-18
C628 FILL_L10_12 FILL_L50_2 2.17566e-17
C629 FILL_L10_12 FILL_L50_6 1.9454000000000001e-18
C630 FILL_L10_12 FILL_L8_8 1.51036e-18
C631 FILL_L10_12 0 7.3700199999999996e-17
C632 FILL_L10_13 FILL_L10_14 2.7935199999999999e-17
C633 FILL_L10_13 FILL_L10_17 2.7935199999999999e-17
C634 FILL_L10_13 FILL_L10_2 5.1652400000000006e-18
C635 FILL_L10_13 FILL_L10_7 1.39676e-17
C636 FILL_L10_13 FILL_L50_2 3.5714700000000003e-17
C637 FILL_L10_13 FILL_L50_6 3.8908000000000001e-18
C638 FILL_L10_13 FILL_L8_4 2.8200399999999999e-19
C639 FILL_L10_13 FILL_L8_9 1.51036e-18
C640 FILL_L10_13 0 6.98926e-17
C641 FILL_L10_14 FILL_L10_15 2.7935199999999999e-17
C642 FILL_L10_14 FILL_L10_17 2.7935199999999999e-17
C643 FILL_L10_14 FILL_L10_8 1.39676e-17
C644 FILL_L10_14 FILL_L50_2 8.5118100000000009e-18
C645 FILL_L10_14 FILL_L50_3 8.5118100000000009e-18
C646 FILL_L10_14 FILL_L8_10 1.51036e-18
C647 FILL_L10_14 0 7.3700199999999996e-17
C648 FILL_L10_15 FILL_L10_18 1.8996e-17
C649 FILL_L10_15 FILL_L10_3 5.1652400000000006e-18
C650 FILL_L10_15 FILL_L10_9 5.0283400000000002e-18
C651 FILL_L10_15 FILL_L50_3 2.19472e-17
C652 FILL_L10_15 FILL_L50_7 2.6457400000000002e-18
C653 FILL_L10_15 FILL_L8_11 5.4373000000000013e-19
C654 FILL_L10_15 FILL_L8_5 3.0652600000000003e-19
C655 FILL_L10_15 0 8.0547000000000008e-17
C656 FILL_L10_16 FILL_L10_17 9.7773300000000019e-17
C657 FILL_L10_16 FILL_L10_19 9.7773300000000019e-17
C658 FILL_L10_16 FILL_L10_5 5.1652400000000006e-18
C659 FILL_L10_16 FILL_L50_4 5.3319900000000002e-17
C660 FILL_L10_16 FILL_L50_5 4.34584e-17
C661 FILL_L10_16 FILL_L50_6 1.4346100000000003e-16
C662 FILL_L10_16 FILL_L8_17 2.4408600000000001e-17
C663 FILL_L10_16 FILL_L8_18 8.2350600000000007e-16
C664 FILL_L10_16 N 3.6374899999999999e-17
C665 FILL_L10_16 P 3.2587700000000003e-18
C666 FILL_L10_16 0 2.1986000000000004e-16
C667 FILL_L10_17 FILL_L10_18 9.7773300000000019e-17
C668 FILL_L10_17 FILL_L10_20 9.7773300000000019e-17
C669 FILL_L10_17 FILL_L10_7 5.1652400000000006e-18
C670 FILL_L10_17 FILL_L50_2 5.1482900000000008e-18
C671 FILL_L10_17 FILL_L50_6 2.3230500000000003e-16
C672 FILL_L10_17 FILL_L50_7 6.4834700000000002e-17
C673 FILL_L10_17 FILL_L8_19 8.2350600000000007e-16
C674 FILL_L10_17 0 2.2000000000000002e-16
C675 FILL_L10_18 FILL_L10_21 1.8996e-17
C676 FILL_L10_18 FILL_L50_7 7.3266499999999995e-17
C677 FILL_L10_18 FILL_L8_20 1.5999500000000002e-16
C678 FILL_L10_18 0 1.8974799999999999e-16
C679 FILL_L10_19 FILL_L10_20 9.7773300000000019e-17
C680 FILL_L10_19 FILL_L10_22 9.7773300000000019e-17
C681 FILL_L10_19 FILL_L30_4 2.6211800000000001e-18
C682 FILL_L10_19 FILL_L30_5 1.7636500000000003e-16
C683 FILL_L10_19 FILL_L30_6 1.23317e-16
C684 FILL_L10_19 FILL_L50_10 1.1078300000000001e-16
C685 FILL_L10_19 FILL_L50_5 1.04719e-17
C686 FILL_L10_19 FILL_L50_6 5.2359600000000008e-18
C687 FILL_L10_19 FILL_L50_8 4.9659000000000004e-17
C688 FILL_L10_19 FILL_L50_9 2.0914400000000003e-17
C689 FILL_L10_19 FILL_L8_23 2.45489e-17
C690 FILL_L10_19 FILL_L8_24 8.2350600000000007e-16
C691 FILL_L10_19 N 5.0775300000000004e-17
C692 FILL_L10_19 P 3.6381800000000002e-18
C693 FILL_L10_19 0 1.9621900000000002e-16
C694 FILL_L10_2 FILL_L10_3 2.1510100000000004e-17
C695 FILL_L10_2 FILL_L10_6 2.7935199999999999e-17
C696 FILL_L10_2 FILL_L10_7 2.7935199999999999e-17
C697 FILL_L10_2 FILL_L50_2 1.9444500000000002e-17
C698 FILL_L10_2 FILL_L50_6 6.4570200000000004e-19
C699 FILL_L10_2 FILL_L8_4 1.8117100000000001e-16
C700 FILL_L10_2 0 2.1916500000000001e-16
C701 FILL_L10_20 FILL_L10_21 9.7773300000000019e-17
C702 FILL_L10_20 FILL_L10_23 9.7773300000000019e-17
C703 FILL_L10_20 FILL_L30_6 1.3974200000000001e-17
C704 FILL_L10_20 FILL_L30_7 2.04081e-16
C705 FILL_L10_20 FILL_L30_8 3.3825600000000003e-17
C706 FILL_L10_20 FILL_L50_10 2.0239700000000002e-16
C707 FILL_L10_20 FILL_L50_11 4.5806800000000008e-17
C708 FILL_L10_20 FILL_L50_6 2.0756300000000001e-17
C709 FILL_L10_20 FILL_L8_25 8.2350600000000007e-16
C710 FILL_L10_20 N 2.3091400000000004e-18
C711 FILL_L10_20 0 1.9621900000000002e-16
C712 FILL_L10_21 FILL_L10_24 1.8996e-17
C713 FILL_L10_21 FILL_L30_8 4.8075700000000001e-17
C714 FILL_L10_21 FILL_L50_11 6.564360000000001e-17
C715 FILL_L10_21 FILL_L50_7 7.1209000000000004e-18
C716 FILL_L10_21 FILL_L8_26 1.5999500000000002e-16
C717 FILL_L10_21 0 1.89909e-16
C718 FILL_L10_22 FILL_L10_23 7.6263200000000009e-17
C719 FILL_L10_22 FILL_L30_10 1.4743400000000002e-19
C720 FILL_L10_22 FILL_L30_5 3.2724800000000002e-18
C721 FILL_L10_22 FILL_L30_6 1.6362400000000001e-18
C722 FILL_L10_22 FILL_L50_10 1.7067200000000001e-17
C723 FILL_L10_22 FILL_L50_12 5.4113500000000001e-18
C724 FILL_L10_22 FILL_L50_9 3.1173500000000001e-17
C725 FILL_L10_22 FILL_L8_29 1.9148200000000001e-17
C726 FILL_L10_22 FILL_L8_30 6.4233500000000011e-16
C727 FILL_L10_22 N 5.2383900000000001e-17
C728 FILL_L10_22 P 2.7546200000000002e-18
C729 FILL_L10_22 0 2.4737300000000002e-16
C730 FILL_L10_23 FILL_L10_24 7.6263200000000009e-17
C731 FILL_L10_23 FILL_L30_7 3.2724800000000002e-18
C732 FILL_L10_23 FILL_L50_10 6.5248999999999995e-17
C733 FILL_L10_23 FILL_L50_12 4.8327900000000003e-17
C734 FILL_L10_23 FILL_L50_13 1.10846e-17
C735 FILL_L10_23 FILL_L8_31 6.4233500000000011e-16
C736 FILL_L10_23 N 5.3043199999999998e-18
C737 FILL_L10_23 0 2.4737300000000002e-16
C738 FILL_L10_24 FILL_L50_11 2.1157900000000004e-17
C739 FILL_L10_24 FILL_L50_13 2.6367500000000001e-17
C740 FILL_L10_24 FILL_L8_32 1.2479600000000001e-16
C741 FILL_L10_24 0 1.6645500000000003e-16
C742 FILL_L10_3 FILL_L10_8 2.7935199999999999e-17
C743 FILL_L10_3 FILL_L10_9 5.0283400000000002e-18
C744 FILL_L10_3 FILL_L50_3 1.44006e-17
C745 FILL_L10_3 FILL_L50_7 6.4570200000000004e-19
C746 FILL_L10_3 FILL_L8_5 1.3872600000000002e-16
C747 FILL_L10_3 0 1.9514e-16
C748 FILL_L10_4 FILL_L8_12 1.3240400000000001e-16
C749 FILL_L10_4 FILL_L8_13 8.6002200000000009e-18
C750 FILL_L10_4 0 5.4697800000000002e-17
C751 FILL_L10_5 FILL_L10_6 2.7935199999999999e-17
C752 FILL_L10_5 FILL_L50_1 1.4804999999999999e-18
C753 FILL_L10_5 FILL_L8_7 6.7224999999999998e-17
C754 FILL_L10_5 0 7.0927800000000015e-17
C755 FILL_L10_6 FILL_L10_7 2.7935199999999999e-17
C756 FILL_L10_6 FILL_L50_2 9.590400000000001e-18
C757 FILL_L10_6 FILL_L50_6 1.4553799999999999e-18
C758 FILL_L10_6 FILL_L8_8 6.7224999999999998e-17
C759 FILL_L10_6 0 6.5701500000000001e-17
C760 FILL_L10_7 FILL_L10_8 2.7935199999999999e-17
C761 FILL_L10_7 FILL_L50_2 9.590400000000001e-18
C762 FILL_L10_7 FILL_L8_9 6.7224999999999998e-17
C763 FILL_L10_7 0 6.1893900000000006e-17
C764 FILL_L10_8 FILL_L10_9 2.7935199999999999e-17
C765 FILL_L10_8 FILL_L8_10 6.7224999999999998e-17
C766 FILL_L10_8 0 6.5701500000000001e-17
C767 FILL_L10_9 FILL_L50_3 1.5111000000000002e-18
C768 FILL_L10_9 FILL_L8_11 1.2100500000000001e-17
C769 FILL_L10_9 0 5.3859300000000004e-17
C770 FILL_L30_0 0 1.0889800000000001e-16
C771 FILL_L30_1 FILL_L30_2 1.92731e-17
C772 FILL_L30_1 FILL_L8_21 4.4819500000000004e-17
C773 FILL_L30_1 FILL_L8_22 1.1171900000000001e-17
C774 FILL_L30_1 FILL_L8_27 1.8260000000000001e-18
C775 FILL_L30_1 0 5.5617499999999999e-17
C776 FILL_L30_10 FILL_L30_9 1.92731e-17
C777 FILL_L30_10 FILL_L8_27 1.4349600000000001e-18
C778 FILL_L30_10 FILL_L8_28 1.8571100000000001e-17
C779 FILL_L30_10 FILL_L8_29 2.4142200000000001e-17
C780 FILL_L30_10 N 1.1391300000000001e-19
C781 FILL_L30_10 P 1.4642600000000002e-19
C782 FILL_L30_10 0 6.06354e-17
C783 FILL_L30_2 FILL_L30_3 1.92731e-17
C784 FILL_L30_2 FILL_L8_22 7.9324900000000005e-17
C785 FILL_L30_2 FILL_L8_28 3.5144400000000001e-18
C786 FILL_L30_2 0 1.8732900000000003e-17
C787 FILL_L30_3 FILL_L30_4 1.92731e-17
C788 FILL_L30_3 FILL_L30_9 1.92731e-17
C789 FILL_L30_3 FILL_L8_22 1.8189900000000002e-17
C790 FILL_L30_3 FILL_L8_23 2.6166200000000002e-17
C791 FILL_L30_3 0 4.1814599999999999e-17
C792 FILL_L30_4 FILL_L30_5 1.92731e-17
C793 FILL_L30_4 FILL_L8_23 7.3572100000000009e-17
C794 FILL_L30_4 FILL_L8_29 6.7211400000000009e-18
C795 FILL_L30_4 N 2.8873199999999999e-18
C796 FILL_L30_4 P 5.3937200000000003e-18
C797 FILL_L30_4 0 2.6990400000000004e-17
C798 FILL_L30_5 FILL_L30_6 1.92731e-17
C799 FILL_L30_5 FILL_L50_5 5.0409200000000003e-19
C800 FILL_L30_5 FILL_L50_8 6.7224999999999998e-17
C801 FILL_L30_5 FILL_L50_9 3.0598200000000003e-18
C802 FILL_L30_5 FILL_L8_23 3.9629700000000004e-18
C803 FILL_L30_5 N 2.34989e-18
C804 FILL_L30_5 P 1.3518400000000001e-18
C805 FILL_L30_5 0 2.4692900000000002e-17
C806 FILL_L30_6 FILL_L30_7 1.92731e-17
C807 FILL_L30_6 FILL_L50_10 1.3606299999999999e-16
C808 FILL_L30_6 FILL_L50_6 2.5204600000000002e-19
C809 FILL_L30_6 FILL_L8_24 3.01665e-18
C810 FILL_L30_6 FILL_L8_25 2.30082e-18
C811 FILL_L30_6 0 3.9613500000000003e-17
C812 FILL_L30_7 FILL_L30_8 1.92731e-17
C813 FILL_L30_7 FILL_L50_10 1.3606299999999999e-16
C814 FILL_L30_7 FILL_L50_6 5.0409200000000003e-19
C815 FILL_L30_7 0 2.3785100000000001e-17
C816 FILL_L30_8 FILL_L50_11 1.2322700000000001e-16
C817 FILL_L30_8 FILL_L50_7 5.0409200000000003e-19
C818 FILL_L30_8 FILL_L8_25 5.0346600000000001e-18
C819 FILL_L30_8 FILL_L8_26 5.7504800000000001e-18
C820 FILL_L30_8 0 8.1064600000000002e-17
C821 FILL_L30_9 FILL_L50_9 6.4578500000000007e-19
C822 FILL_L30_9 N 2.4807800000000001e-19
C823 FILL_L30_9 P 3.1888300000000006e-19
C824 FILL_L30_9 0 9.7490700000000017e-17
C825 FILL_L50_0 FILL_L50_1 2.4713600000000001e-17
C826 FILL_L50_0 FILL_L50_2 2.4713600000000001e-17
C827 FILL_L50_0 0 2.7427800000000004e-17
C828 FILL_L50_1 FILL_L50_2 2.4713600000000001e-17
C829 FILL_L50_1 FILL_L50_4 2.4713600000000001e-17
C830 FILL_L50_1 FILL_L8_7 6.7038200000000004e-19
C831 FILL_L50_1 0 2.7919699999999998e-17
C832 FILL_L50_10 FILL_L50_11 9.8854299999999996e-17
C833 FILL_L50_10 FILL_L50_12 2.4713600000000001e-17
C834 FILL_L50_10 FILL_L50_6 9.8854299999999996e-17
C835 FILL_L50_10 FILL_L50_8 2.4713600000000001e-17
C836 FILL_L50_10 FILL_L50_9 2.4713600000000001e-17
C837 FILL_L50_10 FILL_L8_24 1.1334400000000002e-17
C838 FILL_L50_10 FILL_L8_25 1.7904300000000001e-17
C839 FILL_L50_10 FILL_L8_30 2.1383400000000001e-18
C840 FILL_L50_10 FILL_L8_31 8.5533600000000005e-18
C841 FILL_L50_10 N 2.4862500000000002e-17
C842 FILL_L50_10 0 2.2345400000000003e-16
C843 FILL_L50_11 FILL_L50_13 4.1518800000000001e-17
C844 FILL_L50_11 FILL_L50_7 4.1518800000000001e-17
C845 FILL_L50_11 FILL_L8_25 4.1715000000000005e-18
C846 FILL_L50_11 FILL_L8_26 7.3120200000000003e-18
C847 FILL_L50_11 FILL_L8_32 2.9081400000000001e-18
C848 FILL_L50_11 0 1.9888600000000002e-16
C849 FILL_L50_12 FILL_L50_13 1.8040900000000001e-17
C850 FILL_L50_12 N 5.1766899999999998e-18
C851 FILL_L50_12 0 3.5413300000000002e-17
C852 FILL_L50_13 FILL_L8_31 1.4739300000000001e-18
C853 FILL_L50_13 FILL_L8_32 1.5560400000000002e-18
C854 FILL_L50_13 0 8.6664599999999997e-17
C855 FILL_L50_2 FILL_L50_3 9.8854299999999996e-17
C856 FILL_L50_2 FILL_L50_6 9.8854299999999996e-17
C857 FILL_L50_2 FILL_L8_4 3.5491800000000001e-18
C858 FILL_L50_2 FILL_L8_8 4.1326299999999999e-18
C859 FILL_L50_2 FILL_L8_9 4.1326299999999999e-18
C860 FILL_L50_2 0 2.1772700000000001e-16
C861 FILL_L50_3 FILL_L50_7 4.1518800000000001e-17
C862 FILL_L50_3 FILL_L8_11 6.3454100000000009e-19
C863 FILL_L50_3 FILL_L8_5 3.6292800000000002e-18
C864 FILL_L50_3 0 2.0681200000000004e-16
C865 FILL_L50_4 FILL_L50_5 2.4713600000000001e-17
C866 FILL_L50_4 FILL_L50_6 2.4713600000000001e-17
C867 FILL_L50_4 N 2.1894100000000004e-17
C868 FILL_L50_4 0 1.10283e-17
C869 FILL_L50_5 FILL_L50_6 2.4713600000000001e-17
C870 FILL_L50_5 FILL_L50_8 2.4713600000000001e-17
C871 FILL_L50_5 FILL_L8_18 8.9735099999999998e-19
C872 FILL_L50_5 FILL_L8_24 8.0131300000000013e-19
C873 FILL_L50_5 N 5.0331300000000003e-17
C874 FILL_L50_5 0 1.5313700000000002e-17
C875 FILL_L50_6 FILL_L50_7 9.8854299999999996e-17
C876 FILL_L50_6 FILL_L8_18 1.3706400000000001e-17
C877 FILL_L50_6 FILL_L8_19 1.5009600000000001e-17
C878 FILL_L50_6 FILL_L8_24 4.0065700000000001e-19
C879 FILL_L50_6 FILL_L8_25 1.4583900000000001e-18
C880 FILL_L50_6 N 2.4862500000000002e-17
C881 FILL_L50_6 0 1.3652500000000001e-16
C882 FILL_L50_7 FILL_L8_19 8.6211000000000011e-18
C883 FILL_L50_7 FILL_L8_20 9.71154e-18
C884 FILL_L50_7 FILL_L8_26 5.4489300000000003e-19
C885 FILL_L50_7 0 1.8851000000000001e-16
C886 FILL_L50_8 FILL_L50_9 2.4713600000000001e-17
C887 FILL_L50_8 N 5.0331300000000003e-17
C888 FILL_L50_8 0 1.2760800000000001e-17
C889 FILL_L50_9 FILL_L8_24 2.7810000000000005e-18
C890 FILL_L50_9 FILL_L8_30 2.9359200000000002e-18
C891 FILL_L50_9 N 5.0331300000000003e-17
C892 FILL_L50_9 0 4.2637600000000002e-17
C893 FILL_L8_0 FILL_L8_1 1.5333300000000001e-17
C894 FILL_L8_0 FILL_L8_12 3.6242300000000003e-17
C895 FILL_L8_0 0 2.1116200000000002e-16
C896 FILL_L8_1 FILL_L8_13 6.96968e-17
C897 FILL_L8_1 FILL_L8_2 1.5333300000000001e-17
C898 FILL_L8_1 0 3.4882600000000007e-16
C899 FILL_L8_10 FILL_L8_11 1.9913400000000001e-17
C900 FILL_L8_10 FILL_L8_5 1.9913400000000001e-17
C901 FILL_L8_10 FILL_L8_9 1.9913400000000001e-17
C902 FILL_L8_10 0 1.3266800000000001e-16
C903 FILL_L8_11 FILL_L8_5 3.5844100000000005e-18
C904 FILL_L8_11 0 7.8184299999999998e-17
C905 FILL_L8_12 FILL_L8_13 6.96968e-17
C906 FILL_L8_12 FILL_L8_15 3.6242300000000003e-17
C907 FILL_L8_12 0 5.2580300000000004e-16
C908 FILL_L8_13 FILL_L8_14 1.9913400000000001e-17
C909 FILL_L8_13 FILL_L8_16 6.96968e-17
C910 FILL_L8_13 FILL_L8_6 1.9913400000000001e-17
C911 FILL_L8_13 P 2.5932400000000002e-19
C912 FILL_L8_13 0 7.7194400000000005e-16
C913 FILL_L8_14 FILL_L8_17 1.9913400000000001e-17
C914 FILL_L8_14 FILL_L8_6 1.9913400000000001e-17
C915 FILL_L8_14 P 3.1666400000000002e-19
C916 FILL_L8_14 0 1.34885e-16
C917 FILL_L8_15 FILL_L8_16 6.96968e-17
C918 FILL_L8_15 FILL_L8_21 3.6242300000000003e-17
C919 FILL_L8_15 0 5.2580300000000004e-16
C920 FILL_L8_16 FILL_L8_17 6.96968e-17
C921 FILL_L8_16 FILL_L8_22 6.96968e-17
C922 FILL_L8_16 0 7.5091400000000008e-16
C923 FILL_L8_17 FILL_L8_18 6.96968e-17
C924 FILL_L8_17 FILL_L8_23 6.96968e-17
C925 FILL_L8_17 N 1.8052299999999998e-18
C926 FILL_L8_17 P 1.6427800000000001e-17
C927 FILL_L8_17 0 7.9238300000000012e-16
C928 FILL_L8_18 FILL_L8_19 6.96968e-17
C929 FILL_L8_18 FILL_L8_24 6.96968e-17
C930 FILL_L8_18 N 1.3216900000000001e-18
C931 FILL_L8_18 P 2.2012000000000005e-19
C932 FILL_L8_18 0 7.4991100000000001e-16
C933 FILL_L8_19 FILL_L8_20 6.96968e-17
C934 FILL_L8_19 FILL_L8_25 6.96968e-17
C935 FILL_L8_19 0 7.4991100000000001e-16
C936 FILL_L8_2 FILL_L8_6 1.9913400000000001e-17
C937 FILL_L8_2 P 2.1385100000000004e-19
C938 FILL_L8_2 0 1.31027e-16
C939 FILL_L8_20 FILL_L8_26 1.3541100000000001e-17
C940 FILL_L8_20 0 3.3346100000000002e-16
C941 FILL_L8_21 FILL_L8_22 6.96968e-17
C942 FILL_L8_21 FILL_L8_27 3.6242300000000003e-17
C943 FILL_L8_21 0 5.2580300000000004e-16
C944 FILL_L8_22 FILL_L8_23 6.96968e-17
C945 FILL_L8_22 FILL_L8_28 6.96968e-17
C946 FILL_L8_22 0 7.5091400000000008e-16
C947 FILL_L8_23 FILL_L8_24 6.96968e-17
C948 FILL_L8_23 FILL_L8_29 6.96968e-17
C949 FILL_L8_23 N 2.0783900000000003e-18
C950 FILL_L8_23 P 1.7085799999999999e-17
C951 FILL_L8_23 0 7.5091400000000008e-16
C952 FILL_L8_24 FILL_L8_25 6.96968e-17
C953 FILL_L8_24 FILL_L8_30 6.96968e-17
C954 FILL_L8_24 N 1.93149e-18
C955 FILL_L8_24 P 3.6000900000000005e-19
C956 FILL_L8_24 0 7.5091400000000008e-16
C957 FILL_L8_25 FILL_L8_26 6.96968e-17
C958 FILL_L8_25 FILL_L8_31 6.96968e-17
C959 FILL_L8_25 0 7.5091400000000008e-16
C960 FILL_L8_26 FILL_L8_32 1.3541100000000001e-17
C961 FILL_L8_26 0 3.3365600000000001e-16
C962 FILL_L8_27 FILL_L8_28 5.4363500000000008e-17
C963 FILL_L8_27 0 4.5873099999999998e-16
C964 FILL_L8_28 FILL_L8_29 5.4363500000000008e-17
C965 FILL_L8_28 0 6.7918300000000008e-16
C966 FILL_L8_29 FILL_L8_30 5.4363500000000008e-17
C967 FILL_L8_29 N 1.57364e-18
C968 FILL_L8_29 P 1.2717700000000001e-17
C969 FILL_L8_29 0 6.7918300000000008e-16
C970 FILL_L8_3 FILL_L8_4 1.5333300000000001e-17
C971 FILL_L8_3 FILL_L8_7 1.9913400000000001e-17
C972 FILL_L8_3 0 1.2510800000000002e-16
C973 FILL_L8_30 FILL_L8_31 5.4363500000000008e-17
C974 FILL_L8_30 N 1.3023700000000001e-18
C975 FILL_L8_30 0 6.7918300000000008e-16
C976 FILL_L8_31 FILL_L8_32 5.4363500000000008e-17
C977 FILL_L8_31 0 6.7918300000000008e-16
C978 FILL_L8_32 0 2.7841200000000001e-16
C979 FILL_L8_4 FILL_L8_5 1.5333300000000001e-17
C980 FILL_L8_4 FILL_L8_8 1.9913400000000001e-17
C981 FILL_L8_4 FILL_L8_9 1.9913400000000001e-17
C982 FILL_L8_4 0 3.6883999999999999e-16
C983 FILL_L8_5 0 3.0818500000000005e-16
C984 FILL_L8_6 0 1.34885e-16
C985 FILL_L8_7 FILL_L8_8 1.9913400000000001e-17
C986 FILL_L8_7 0 1.3285600000000001e-16
C987 FILL_L8_8 FILL_L8_9 1.9913400000000001e-17
C988 FILL_L8_8 0 1.3266800000000001e-16
C989 FILL_L8_9 0 1.3266800000000001e-16
C990 N P 3.4877500000000003e-15
C991 N 0 1.7323800000000002e-16
C992 P 0 6.1439100000000008e-17
VP P 0 DC 0 AC 0
VN N 0 DC 0 AC 1
.control
set numdgt=17
ac lin 1 1Meg 1Meg
let cp = -imag(i(VP))/(2*pi*1e6)
let cn = -imag(i(VN))/(2*pi*1e6)
print cp cn
quit
.endc
.end
