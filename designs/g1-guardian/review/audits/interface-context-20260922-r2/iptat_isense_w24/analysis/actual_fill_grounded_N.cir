* actual_fill grounded drive N; diagnostic capacitor-network AC only
C37 0 N 2.8850100000000003e-17
C38 0 P 2.1973000000000002e-17
C115 0 N 1.5173700000000001e-17
C116 0 P 1.87259e-17
C174 0 N 2.4479500000000003e-17
C175 0 P 2.9385200000000003e-17
C246 0 N 6.4053799999999994e-17
C247 0 P 2.8591500000000001e-17
C307 0 N 1.2387300000000001e-16
C308 0 P 1.2384300000000001e-16
C336 0 N 1.0038200000000001e-19
C337 0 P 1.4308399999999999e-19
C363 0 N 1.3678700000000001e-15
C364 0 P 6.4718300000000003e-19
C411 0 N 2.6109400000000004e-17
C412 0 P 2.2345500000000002e-17
C476 0 N 1.4308899999999999e-17
C477 0 P 2.0004200000000004e-18
C555 0 P 3.4877500000000003e-15
C595 0 N 1.16519e-17
C596 0 P 3.8117600000000003e-18
C606 0 N 5.3580200000000006e-19
C607 0 P 4.3091600000000004e-19
C621 0 N 1.26457e-18
C622 0 P 1.0394800000000001e-18
C664 0 N 3.6374899999999999e-17
C665 0 P 3.2587700000000003e-18
C691 0 N 5.0775300000000004e-17
C692 0 P 3.6381800000000002e-18
C710 0 N 2.3091400000000004e-18
C727 0 N 5.2383900000000001e-17
C728 0 P 2.7546200000000002e-18
C736 0 N 5.3043199999999998e-18
C780 0 N 1.1391300000000001e-19
C781 0 P 1.4642600000000002e-19
C795 0 N 2.8873199999999999e-18
C796 0 P 5.3937200000000003e-18
C803 0 N 2.34989e-18
C804 0 P 1.3518400000000001e-18
C822 0 N 2.4807800000000001e-19
C823 0 P 3.1888300000000006e-19
C841 0 N 2.4862500000000002e-17
C850 0 N 5.1766899999999998e-18
C867 0 N 2.1894100000000004e-17
C873 0 N 5.0331300000000003e-17
C880 0 N 2.4862500000000002e-17
C887 0 N 5.0331300000000003e-17
C891 0 N 5.0331300000000003e-17
C911 0 P 2.5932400000000002e-19
C915 0 P 3.1666400000000002e-19
C925 0 N 1.8052299999999998e-18
C926 0 P 1.6427800000000001e-17
C930 0 N 1.3216900000000001e-18
C931 0 P 2.2012000000000005e-19
C937 0 P 2.1385100000000004e-19
C949 0 N 2.0783900000000003e-18
C950 0 P 1.7085799999999999e-17
C954 0 N 1.93149e-18
C955 0 P 3.6000900000000005e-19
C967 0 N 1.57364e-18
C968 0 P 1.2717700000000001e-17
C974 0 N 1.3023700000000001e-18
C990 N P 3.4877500000000003e-15
C991 N 0 1.7323800000000002e-16
C992 P 0 6.1439100000000008e-17
VP P 0 DC 0 AC 0
VN N 0 DC 0 AC 1
.control
set numdgt=17
ac lin 1 1Meg 1Meg
let cp = -imag(i(VP))/(2*pi*1e6)
let cn = -imag(i(VN))/(2*pi*1e6)
print cp cn
quit
.endc
.end
