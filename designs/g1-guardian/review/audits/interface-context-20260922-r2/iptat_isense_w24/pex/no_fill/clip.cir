* cell sense_fill_clip
.SUBCKT sense_fill_clip
* net 1 CTX_L8_0
* net 2 CTX_L10_0,CTX_L30_4
* net 3 CTX_L10_1
* net 4 CTX_L10_2
* net 5 CTX_L30_0
* net 6 CTX_L30_1
* net 7 CTX_L30_3,CTX_L50_0
* net 8 CTX_L30_5,CTX_L50_1
* net 9 CTX_L30_6,CTX_L50_6
* net 10 CTX_L30_7,CTX_L50_2
* net 11 CTX_L30_8
* net 12 CTX_L30_9
* net 13 CTX_L30_2,CTX_L50_8
* net 14 CTX_L50_3
* net 15 CTX_L50_4
* net 16 CTX_L50_5
* net 17 CTX_L50_7
* net 18 CTX_L50_9
* net 19 P
* net 20 N
* net 21 CTX_L126_0
* net 22 CTX_L126_1,CTX_L134_0
.ENDS sense_fill_clip
