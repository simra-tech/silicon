*********************************************************
*** NGSPICE file created by KLayout-PEX 0.3.12
*** -----------------------------------------------------
***     Extraction Engine: KPEX/2.5D
***     Technology: ihp_sg13g2
***     Date: 2026-09-22 16:35:55
*********************************************************

.SUBCKT sense_fill_clip
Cext_1 CTX_L10_0|CTX_L30_4 CTX_L10_1 238.843a
Cext_2 CTX_L10_0|CTX_L30_4 CTX_L10_2 35.5363a
Cext_3 CTX_L10_0|CTX_L30_4 CTX_L126_0 45.9034a
Cext_4 CTX_L10_0|CTX_L30_4 CTX_L126_1|CTX_L134_0 72.5076a
Cext_5 CTX_L10_0|CTX_L30_4 CTX_L30_1 9.71987a
Cext_6 CTX_L10_0|CTX_L30_4 CTX_L30_2|CTX_L50_8 487.409a
Cext_7 CTX_L10_0|CTX_L30_4 CTX_L30_3|CTX_L50_0 724.794a
Cext_8 CTX_L10_0|CTX_L30_4 CTX_L30_5|CTX_L50_1 337.077a
Cext_9 CTX_L10_0|CTX_L30_4 CTX_L30_6|CTX_L50_6 66.6307a
Cext_10 CTX_L10_0|CTX_L30_4 CTX_L30_7|CTX_L50_2 40.0822a
Cext_11 CTX_L10_0|CTX_L30_4 CTX_L30_8 11.5498a
Cext_12 CTX_L10_0|CTX_L30_4 CTX_L50_3 61.4079a
Cext_13 CTX_L10_0|CTX_L30_4 CTX_L50_5 29.5793a
Cext_14 CTX_L10_0|CTX_L30_4 CTX_L50_7 25.0481a
Cext_15 CTX_L10_0|CTX_L30_4 CTX_L50_9 27.6316a
Cext_16 CTX_L10_0|CTX_L30_4 CTX_L8_0 7.5546a
Cext_17 CTX_L10_0|CTX_L30_4 N 29.4672a
Cext_18 CTX_L10_0|CTX_L30_4 P 21.973a
Cext_19 CTX_L10_0|CTX_L30_4 VSUBS 1.26044f
Cext_20 CTX_L10_1 CTX_L10_2 179.466a
Cext_21 CTX_L10_1 CTX_L126_0 82.0291a
Cext_22 CTX_L10_1 CTX_L126_1|CTX_L134_0 24.5899a
Cext_23 CTX_L10_1 CTX_L30_0 12.1321a
Cext_24 CTX_L10_1 CTX_L30_1 0.379189a
Cext_25 CTX_L10_1 CTX_L30_2|CTX_L50_8 40.6129a
Cext_26 CTX_L10_1 CTX_L30_5|CTX_L50_1 77.9814a
Cext_27 CTX_L10_1 CTX_L30_6|CTX_L50_6 41.4975a
Cext_28 CTX_L10_1 CTX_L30_7|CTX_L50_2 14.291a
Cext_29 CTX_L10_1 CTX_L30_8 3.81865a
Cext_30 CTX_L10_1 CTX_L50_3 52.7215a
Cext_31 CTX_L10_1 CTX_L50_5 73.0316a
Cext_32 CTX_L10_1 CTX_L50_7 8.97936a
Cext_33 CTX_L10_1 CTX_L8_0 0.292715a
Cext_34 CTX_L10_1 VSUBS 1.18818f
Cext_35 CTX_L10_2 CTX_L126_0 87.9815a
Cext_36 CTX_L10_2 CTX_L126_1|CTX_L134_0 58.0259a
Cext_37 CTX_L10_2 CTX_L30_1 54.7536a
Cext_38 CTX_L10_2 CTX_L30_2|CTX_L50_8 45.9288a
Cext_39 CTX_L10_2 CTX_L30_3|CTX_L50_0 4.68442a
Cext_40 CTX_L10_2 CTX_L30_5|CTX_L50_1 35.4712a
Cext_41 CTX_L10_2 CTX_L30_6|CTX_L50_6 3.78008a
Cext_42 CTX_L10_2 CTX_L30_9 1.87894a
Cext_43 CTX_L10_2 CTX_L50_5 5.14969a
Cext_44 CTX_L10_2 CTX_L50_7 35.4464a
Cext_45 CTX_L10_2 CTX_L50_9 68.0605a
Cext_46 CTX_L10_2 CTX_L8_0 17.9099a
Cext_47 CTX_L10_2 N 15.2199a
Cext_48 CTX_L10_2 P 18.783a
Cext_49 CTX_L10_2 VSUBS 1.34635f
Cext_50 CTX_L126_0 CTX_L126_1|CTX_L134_0 397.431a
Cext_51 CTX_L126_0 CTX_L30_0 6.49731a
Cext_52 CTX_L126_0 CTX_L30_1 71.6166a
Cext_53 CTX_L126_0 CTX_L30_2|CTX_L50_8 83.0563a
Cext_54 CTX_L126_0 CTX_L30_3|CTX_L50_0 10.843a
Cext_55 CTX_L126_0 CTX_L30_5|CTX_L50_1 74.6098a
Cext_56 CTX_L126_0 CTX_L30_6|CTX_L50_6 117.404a
Cext_57 CTX_L126_0 CTX_L30_7|CTX_L50_2 10.7553a
Cext_58 CTX_L126_0 CTX_L30_8 1.80349a
Cext_59 CTX_L126_0 CTX_L30_9 3.38148a
Cext_60 CTX_L126_0 CTX_L50_3 30.6382a
Cext_61 CTX_L126_0 CTX_L50_5 134.791a
Cext_62 CTX_L126_0 CTX_L50_7 276.809a
Cext_63 CTX_L126_0 CTX_L50_9 35.4475a
Cext_64 CTX_L126_0 CTX_L8_0 14.3987a
Cext_65 CTX_L126_0 N 24.5412a
Cext_66 CTX_L126_0 P 29.4591a
Cext_67 CTX_L126_0 VSUBS 1.41417f
Cext_68 CTX_L126_1|CTX_L134_0 CTX_L30_0 10.0429a
Cext_69 CTX_L126_1|CTX_L134_0 CTX_L30_1 135.84a
Cext_70 CTX_L126_1|CTX_L134_0 CTX_L30_2|CTX_L50_8 43.755a
Cext_71 CTX_L126_1|CTX_L134_0 CTX_L30_3|CTX_L50_0 78.0773a
Cext_72 CTX_L126_1|CTX_L134_0 CTX_L30_5|CTX_L50_1 98.1071a
Cext_73 CTX_L126_1|CTX_L134_0 CTX_L30_6|CTX_L50_6 12.6823a
Cext_74 CTX_L126_1|CTX_L134_0 CTX_L30_9 77.7386a
Cext_75 CTX_L126_1|CTX_L134_0 CTX_L50_3 31.321a
Cext_76 CTX_L126_1|CTX_L134_0 CTX_L50_5 21.9296a
Cext_77 CTX_L126_1|CTX_L134_0 CTX_L50_7 12.5226a
Cext_78 CTX_L126_1|CTX_L134_0 CTX_L50_9 33.3997a
Cext_79 CTX_L126_1|CTX_L134_0 CTX_L8_0 27.6346a
Cext_80 CTX_L126_1|CTX_L134_0 N 83.5442a
Cext_81 CTX_L126_1|CTX_L134_0 P 28.7035a
Cext_82 CTX_L126_1|CTX_L134_0 VSUBS 2.40323f
Cext_83 CTX_L30_0 CTX_L30_1 2.53092a
Cext_84 CTX_L30_0 CTX_L30_2|CTX_L50_8 35.6711a
Cext_85 CTX_L30_0 CTX_L30_5|CTX_L50_1 27.4857a
Cext_86 CTX_L30_0 CTX_L50_3 31.7283a
Cext_87 CTX_L30_0 CTX_L50_5 3.38527a
Cext_88 CTX_L30_0 CTX_L50_7 0.121885a
Cext_89 CTX_L30_0 CTX_L8_0 0.125841a
Cext_90 CTX_L30_0 VSUBS 346.605a
Cext_91 CTX_L30_1 CTX_L30_3|CTX_L50_0 344.179a
Cext_92 CTX_L30_1 CTX_L30_5|CTX_L50_1 0.176283a
Cext_93 CTX_L30_1 CTX_L50_3 0.133081a
Cext_94 CTX_L30_1 CTX_L50_5 0.363015a
Cext_95 CTX_L30_1 CTX_L50_7 1.73547a
Cext_96 CTX_L30_1 CTX_L50_9 66.7116a
Cext_97 CTX_L30_1 CTX_L8_0 176.196a
Cext_98 CTX_L30_1 N 123.873a
Cext_99 CTX_L30_1 P 123.843a
Cext_100 CTX_L30_1 VSUBS 1.32916f
Cext_101 CTX_L30_2|CTX_L50_8 CTX_L30_3|CTX_L50_0 2.64463a
Cext_102 CTX_L30_2|CTX_L50_8 CTX_L30_5|CTX_L50_1 56.3778a
Cext_103 CTX_L30_2|CTX_L50_8 CTX_L30_6|CTX_L50_6 26.5875a
Cext_104 CTX_L30_2|CTX_L50_8 CTX_L30_9 0.180258a
Cext_105 CTX_L30_2|CTX_L50_8 CTX_L50_3 29.6065a
Cext_106 CTX_L30_2|CTX_L50_8 CTX_L50_5 31.9514a
Cext_107 CTX_L30_2|CTX_L50_8 CTX_L50_7 2.19768f
Cext_108 CTX_L30_2|CTX_L50_8 CTX_L50_9 358.017a
Cext_109 CTX_L30_2|CTX_L50_8 N 0.100382a
Cext_110 CTX_L30_2|CTX_L50_8 P 0.143084a
Cext_111 CTX_L30_2|CTX_L50_8 VSUBS 556.026a
Cext_112 CTX_L30_3|CTX_L50_0 CTX_L50_9 0.253581a
Cext_113 CTX_L30_3|CTX_L50_0 CTX_L8_0 42.452a
Cext_114 CTX_L30_3|CTX_L50_0 N 1.36787f
Cext_115 CTX_L30_3|CTX_L50_0 P 0.647183a
Cext_116 CTX_L30_3|CTX_L50_0 VSUBS 475.241a
Cext_117 CTX_L30_5|CTX_L50_1 CTX_L30_6|CTX_L50_6 159.793a
Cext_118 CTX_L30_5|CTX_L50_1 CTX_L50_3 731.955a
Cext_119 CTX_L30_5|CTX_L50_1 CTX_L50_5 782.859a
Cext_120 CTX_L30_5|CTX_L50_1 CTX_L50_7 28.6464a
Cext_121 CTX_L30_5|CTX_L50_1 CTX_L50_9 27.7252a
Cext_122 CTX_L30_5|CTX_L50_1 CTX_L8_0 2.53802a
Cext_123 CTX_L30_5|CTX_L50_1 N 29.8397a
Cext_124 CTX_L30_5|CTX_L50_1 P 22.3455a
Cext_125 CTX_L30_5|CTX_L50_1 VSUBS 969.358a
Cext_126 CTX_L30_6|CTX_L50_6 CTX_L30_7|CTX_L50_2 31.53a
Cext_127 CTX_L30_6|CTX_L50_6 CTX_L30_8 0.186742a
Cext_128 CTX_L30_6|CTX_L50_6 CTX_L50_3 37.128a
Cext_129 CTX_L30_6|CTX_L50_6 CTX_L50_5 573.979a
Cext_130 CTX_L30_6|CTX_L50_6 CTX_L50_7 241.539a
Cext_131 CTX_L30_6|CTX_L50_6 VSUBS 483.844a
Cext_132 CTX_L30_7|CTX_L50_2 CTX_L30_8 153.586a
Cext_133 CTX_L30_7|CTX_L50_2 CTX_L50_3 651.978a
Cext_134 CTX_L30_7|CTX_L50_2 CTX_L50_5 1.5905a
Cext_135 CTX_L30_7|CTX_L50_2 CTX_L50_7 0.121885a
Cext_136 CTX_L30_7|CTX_L50_2 VSUBS 317.676a
Cext_137 CTX_L30_8 CTX_L30_9 0.779028a
Cext_138 CTX_L30_8 CTX_L50_3 14.0395a
Cext_139 CTX_L30_8 CTX_L50_4 2.9197a
Cext_140 CTX_L30_8 CTX_L50_5 1.82566a
Cext_141 CTX_L30_8 VSUBS 228.859a
Cext_142 CTX_L30_9 CTX_L50_7 0.13858a
Cext_143 CTX_L30_9 CTX_L50_9 1.03183a
Cext_144 CTX_L30_9 N 14.3992a
Cext_145 CTX_L30_9 P 2.00042a
Cext_146 CTX_L30_9 VSUBS 781.667a
Cext_147 CTX_L50_3 CTX_L50_4 14.5217a
Cext_148 CTX_L50_3 CTX_L50_5 464.459a
Cext_149 CTX_L50_3 CTX_L8_0 0.291801a
Cext_150 CTX_L50_3 VSUBS 737.634a
Cext_151 CTX_L50_4 CTX_L50_5 2.54306a
Cext_152 CTX_L50_4 VSUBS 6.58991a
Cext_153 CTX_L50_5 CTX_L50_7 214.047a
Cext_154 CTX_L50_5 CTX_L8_0 0.764395a
Cext_155 CTX_L50_5 VSUBS 315.977a
Cext_156 CTX_L50_7 CTX_L50_9 169.543a
Cext_157 CTX_L50_7 CTX_L8_0 1.82833a
Cext_158 CTX_L50_7 VSUBS 366.075a
Cext_159 CTX_L50_9 CTX_L8_0 2.65794a
Cext_160 CTX_L50_9 P 3.48775f
Cext_161 CTX_L50_9 VSUBS 243.208a
Cext_162 CTX_L8_0 N 11.984a
Cext_163 CTX_L8_0 P 3.85305a
Cext_164 CTX_L8_0 VSUBS 1.56542f
Cext_165 N P 3.48775f
Cext_166 N VSUBS 403.027a
Cext_167 P VSUBS 89.1188a
.ENDS sense_fill_clip
