* cell sense_fill_clip
.SUBCKT sense_fill_clip
* net 2 FILL_L8_0
* net 3 FILL_L10_0
* net 4 CTX_L30_0
* net 5 FILL_L8_1
* net 6 FILL_L30_0
* net 7 FILL_L8_2
* net 8 FILL_L50_0
* net 9 FILL_L8_3
* net 10 FILL_L10_1
* net 11 CTX_L30_1
* net 12 FILL_L10_2
* net 13 FILL_L8_4
* net 14 FILL_L10_3
* net 15 FILL_L8_5
* net 16 FILL_L8_12
* net 17 FILL_L67_0
* net 18 FILL_L10_4
* net 19 FILL_L10_10
* net 20 FILL_L8_13
* net 21 FILL_L67_1
* net 22 FILL_L8_6
* net 23 FILL_L8_14
* net 24 CTX_L8_0
* net 25 FILL_L67_2
* net 26 FILL_L10_11
* net 27 FILL_L50_1
* net 28 FILL_L8_7
* net 29 FILL_L10_5
* net 30 FILL_L10_12
* net 31 FILL_L10_6
* net 32 FILL_L8_8
* net 33 FILL_L50_2
* net 34 FILL_L67_3
* net 35 FILL_L10_13
* net 36 FILL_L8_9
* net 37 FILL_L10_7
* net 38 FILL_L10_14
* net 39 FILL_L8_10
* net 40 FILL_L10_8
* net 41 FILL_L50_3
* net 42 FILL_L67_4
* net 43 FILL_L10_15
* net 44 FILL_L10_9
* net 45 FILL_L8_11
* net 46 CTX_L10_0,CTX_L30_4
* net 47 CTX_L30_2,CTX_L50_8
* net 48 CTX_L30_5,CTX_L50_1
* net 49 CTX_L126_1,CTX_L134_0
* net 50 CTX_L30_3,CTX_L50_0
* net 51 FILL_L50_4
* net 52 FILL_L8_15
* net 53 FILL_L67_5
* net 54 FILL_L8_16
* net 55 CTX_L10_1
* net 56 CTX_L50_5
* net 57 FILL_L67_6
* net 58 CTX_L126_0
* net 59 CTX_L50_7
* net 60 FILL_L8_17
* net 61 CTX_L10_2
* net 62 CTX_L50_9
* net 63 P
* net 64 N
* net 65 FILL_L67_7
* net 66 FILL_L50_5
* net 67 FILL_L8_18
* net 68 FILL_L10_16
* net 69 FILL_L67_8
* net 70 FILL_L50_6
* net 71 FILL_L8_19
* net 72 FILL_L10_17
* net 73 FILL_L67_9
* net 74 FILL_L50_7
* net 75 FILL_L10_18
* net 76 FILL_L8_20
* net 77 CTX_L30_6,CTX_L50_6
* net 78 FILL_L8_21
* net 79 FILL_L67_10
* net 80 FILL_L30_1
* net 81 FILL_L30_2
* net 82 FILL_L8_22
* net 83 FILL_L67_11
* net 84 FILL_L30_3
* net 85 FILL_L30_9
* net 86 FILL_L8_23
* net 87 FILL_L30_4
* net 88 FILL_L67_12
* net 89 FILL_L50_9
* net 90 FILL_L50_8
* net 91 FILL_L30_5
* net 92 FILL_L8_24
* net 93 FILL_L10_19
* net 94 FILL_L30_6
* net 95 FILL_L50_10
* net 96 FILL_L67_13
* net 97 FILL_L30_7
* net 98 FILL_L10_20
* net 99 FILL_L8_25
* net 100 FILL_L30_8
* net 101 FILL_L67_14
* net 102 FILL_L50_11
* net 103 FILL_L8_26
* net 104 FILL_L10_21
* net 105 FILL_L8_27
* net 106 CTX_L30_7,CTX_L50_2
* net 107 CTX_L50_3
* net 108 FILL_L8_28
* net 109 FILL_L30_10
* net 110 FILL_L67_15
* net 111 FILL_L8_29
* net 112 FILL_L67_16
* net 113 CTX_L30_9
* net 114 FILL_L10_22
* net 115 FILL_L8_30
* net 116 FILL_L67_17
* net 117 FILL_L50_12
* net 118 FILL_L8_31
* net 119 FILL_L10_23
* net 120 FILL_L50_13
* net 121 FILL_L67_18
* net 122 FILL_L10_24
* net 123 FILL_L8_32
* net 124 CTX_L50_4
* net 125 CTX_L30_8
.ENDS sense_fill_clip
