* actual_fill floating drive P; diagnostic capacitor-network AC only
C16 0 FILL_L10_0 1.0468600000000001e-17
C17 0 FILL_L30_4 2.3851300000000005e-18
C18 0 FILL_L50_11 3.8709900000000005e-19
C19 0 FILL_L50_2 1.4885800000000001e-16
C20 0 FILL_L50_3 1.5609299999999999e-16
C32 0 FILL_L50_10 1.2002000000000002e-19
C33 0 FILL_L50_2 7.1293199999999999e-17
C34 0 FILL_L50_3 4.6182600000000004e-19
C44 0 FILL_L50_26 1.077e-17
C88 0 FILL_L30_1 3.1556000000000001e-17
C89 0 FILL_L30_16 3.1424900000000006e-17
C90 0 FILL_L30_17 1.0143300000000001e-18
C91 0 FILL_L30_2 1.1304300000000002e-18
C92 0 FILL_L30_7 1.6973100000000001e-17
C93 0 FILL_L30_8 1.0937600000000002e-18
C94 0 FILL_L50_10 1.6044100000000002e-17
C95 0 FILL_L50_11 5.3473400000000005e-18
C96 0 FILL_L50_18 4.7972400000000005e-17
C97 0 FILL_L50_19 4.3291500000000006e-18
C98 0 FILL_L50_2 3.2795900000000003e-17
C99 0 FILL_L50_26 2.9784100000000002e-17
C100 0 FILL_L50_27 1.9558100000000001e-18
C101 0 FILL_L50_3 4.5635500000000007e-18
C143 0 FILL_L10_0 3.5737400000000002e-18
C144 0 FILL_L10_1 3.1355e-17
C145 0 FILL_L10_10 6.9432000000000002e-18
C146 0 FILL_L10_3 1.5951900000000002e-17
C147 0 FILL_L10_4 1.07646e-17
C148 0 FILL_L10_5 9.6343599999999996e-18
C149 0 FILL_L10_6 5.7829499999999997e-18
C150 0 FILL_L10_7 2.7449800000000002e-18
C151 0 FILL_L10_8 1.07646e-17
C152 0 FILL_L10_9 7.2449399999999996e-18
C153 0 FILL_L30_1 1.3888799999999999e-18
C154 0 FILL_L30_10 9.306100000000002e-19
C155 0 FILL_L30_11 1.0003400000000001e-18
C156 0 FILL_L30_14 6.6785300000000005e-19
C157 0 FILL_L30_16 1.45582e-18
C158 0 FILL_L30_17 2.2360500000000001e-17
C159 0 FILL_L30_18 7.0285600000000013e-19
C160 0 FILL_L30_19 6.0172199999999999e-19
C161 0 FILL_L30_2 2.2539900000000001e-17
C162 0 FILL_L30_22 6.5434500000000004e-19
C163 0 FILL_L30_23 2.4068900000000002e-19
C164 0 FILL_L30_3 1.22718e-19
C165 0 FILL_L30_7 1.50602e-18
C166 0 FILL_L30_8 2.2473200000000001e-17
C167 0 FILL_L30_9 2.9593900000000003e-19
C168 0 FILL_L50_10 6.3944400000000009e-18
C169 0 FILL_L50_11 5.5530100000000006e-17
C170 0 FILL_L50_18 5.3625299999999998e-18
C171 0 FILL_L50_19 5.5515000000000001e-17
C172 0 FILL_L50_2 5.4217399999999999e-18
C173 0 FILL_L50_26 2.0722700000000001e-18
C174 0 FILL_L50_27 2.5341100000000001e-17
C175 0 FILL_L50_3 5.4273400000000009e-17
C189 0 FILL_L10_0 3.0905200000000001e-17
C190 0 FILL_L10_11 9.3060300000000004e-18
C191 0 FILL_L10_3 4.0211200000000004e-17
C192 0 FILL_L10_6 4.0211200000000004e-17
C193 0 FILL_L10_9 4.0211200000000004e-17
C194 0 FILL_L30_11 6.8914300000000002e-18
C195 0 FILL_L30_12 2.9761000000000002e-16
C196 0 FILL_L30_19 6.8914300000000002e-18
C197 0 FILL_L30_20 2.9761000000000002e-16
C198 0 FILL_L30_23 3.9153900000000002e-18
C199 0 FILL_L30_24 1.3544200000000002e-16
C200 0 FILL_L30_4 6.8914300000000002e-18
C201 0 FILL_L30_5 2.91144e-16
C202 0 FILL_L8_1 2.4337500000000004e-16
C203 0 FILL_L8_10 3.1992300000000003e-16
C204 0 FILL_L8_11 4.4157700000000008e-18
C205 0 FILL_L8_13 7.6547100000000011e-17
C206 0 FILL_L8_14 1.02194e-18
C207 0 FILL_L8_2 3.3938400000000001e-18
C208 0 FILL_L8_4 3.1992300000000003e-16
C209 0 FILL_L8_5 4.4157700000000008e-18
C210 0 FILL_L8_7 3.1992300000000003e-16
C211 0 FILL_L8_8 4.4157700000000008e-18
C220 0 FILL_L30_12 1.01523e-16
C221 0 FILL_L30_13 7.6123800000000002e-18
C222 0 FILL_L30_20 1.01523e-16
C223 0 FILL_L30_21 7.6123800000000002e-18
C224 0 FILL_L30_24 4.5939100000000008e-17
C225 0 FILL_L30_25 3.4446000000000001e-18
C226 0 FILL_L30_5 1.01523e-16
C227 0 FILL_L30_6 7.6123800000000002e-18
C228 0 FILL_L8_1 1.1858800000000002e-17
C229 0 FILL_L8_10 1.54297e-17
C230 0 FILL_L8_11 2.14778e-16
C231 0 FILL_L8_13 3.5708700000000008e-18
C232 0 FILL_L8_14 5.2213800000000002e-17
C233 0 FILL_L8_2 1.6256500000000001e-16
C234 0 FILL_L8_4 1.54297e-17
C235 0 FILL_L8_5 2.14778e-16
C236 0 FILL_L8_7 1.54297e-17
C237 0 FILL_L8_8 2.14778e-16
C243 0 FILL_L30_12 6.9818800000000003e-18
C244 0 FILL_L30_13 2.5466800000000001e-17
C245 0 FILL_L30_20 6.9818800000000003e-18
C246 0 FILL_L30_21 2.5466800000000001e-17
C247 0 FILL_L30_24 3.1593000000000002e-18
C248 0 FILL_L30_25 1.1523700000000001e-17
C249 0 FILL_L30_5 6.9818800000000003e-18
C250 0 FILL_L30_6 2.5466800000000001e-17
C251 0 FILL_L8_11 1.9203800000000003e-16
C252 0 FILL_L8_14 4.6951100000000003e-17
C253 0 FILL_L8_2 1.45087e-16
C254 0 FILL_L8_5 1.9203800000000003e-16
C255 0 FILL_L8_8 1.9203800000000003e-16
C262 0 FILL_L30_12 2.2902200000000002e-18
C263 0 FILL_L30_13 8.8909700000000004e-17
C264 0 FILL_L30_20 2.2902200000000002e-18
C265 0 FILL_L30_21 8.8909700000000004e-17
C266 0 FILL_L30_24 1.0363199999999999e-18
C267 0 FILL_L30_25 4.0618400000000006e-17
C268 0 FILL_L30_5 2.2902200000000002e-18
C269 0 FILL_L30_6 8.5676700000000009e-17
C270 0 FILL_L8_11 1.4087300000000001e-16
C271 0 FILL_L8_14 3.5110000000000005e-17
C272 0 FILL_L8_2 1.0576300000000002e-16
C273 0 FILL_L8_5 1.4087300000000001e-16
C274 0 FILL_L8_8 1.4087300000000001e-16
C275 0 N 3.2510800000000007e-17
C282 0 FILL_L30_13 2.3587399999999999e-16
C283 0 FILL_L30_21 2.3587399999999999e-16
C284 0 FILL_L30_25 1.0750700000000002e-16
C285 0 FILL_L30_6 2.29409e-16
C286 0 FILL_L8_11 2.0315199999999999e-16
C287 0 FILL_L8_14 4.9523100000000004e-17
C288 0 FILL_L8_2 1.53629e-16
C289 0 FILL_L8_5 2.0315199999999999e-16
C290 0 FILL_L8_8 2.0315199999999999e-16
C291 0 N 2.8625000000000003e-17
C292 0 P 9.4825500000000004e-18
C302 0 FILL_L30_13 2.6263500000000003e-16
C303 0 FILL_L30_21 2.6263500000000003e-16
C304 0 FILL_L30_25 1.1961600000000001e-16
C305 0 FILL_L30_6 2.5616900000000001e-16
C306 0 FILL_L8_11 1.7880700000000001e-17
C307 0 FILL_L8_14 4.1381000000000003e-18
C308 0 FILL_L8_2 1.3742600000000001e-17
C309 0 FILL_L8_5 1.7880700000000001e-17
C310 0 FILL_L8_8 1.7880700000000001e-17
C311 0 P 4.5911500000000004e-18
C334 0 FILL_L30_13 8.1156400000000016e-17
C335 0 FILL_L30_21 8.1080500000000012e-17
C336 0 FILL_L30_25 3.6723300000000005e-17
C337 0 FILL_L30_6 8.1156400000000016e-17
C338 0 FILL_L8_11 1.2881900000000001e-18
C339 0 FILL_L8_14 2.98125e-19
C340 0 FILL_L8_2 9.2013800000000015e-19
C341 0 FILL_L8_5 1.2881900000000001e-18
C342 0 FILL_L8_8 1.2881900000000001e-18
C367 0 FILL_L10_0 2.10236e-17
C368 0 FILL_L10_1 1.0123100000000001e-19
C369 0 FILL_L10_2 4.5418500000000002e-18
C370 0 FILL_L10_3 2.3975900000000001e-18
C371 0 FILL_L30_0 1.66144e-17
C372 0 FILL_L30_1 2.5545100000000004e-17
C373 0 FILL_L30_2 2.7489600000000002e-17
C374 0 FILL_L30_3 7.0736800000000013e-17
C375 0 FILL_L30_4 1.2544900000000002e-17
C376 0 FILL_L30_9 1.06116e-17
C377 0 FILL_L50_10 2.3630000000000001e-18
C378 0 FILL_L50_11 8.179710000000001e-18
C379 0 FILL_L50_2 2.7710400000000003e-16
C380 0 FILL_L50_3 3.1214800000000007e-16
C381 0 FILL_L8_0 5.5799800000000005e-19
C382 0 FILL_L8_3 2.7517500000000002e-17
C398 0 FILL_L30_0 7.7141100000000009e-18
C399 0 FILL_L30_1 4.1076600000000004e-18
C400 0 FILL_L30_7 1.10267e-17
C401 0 FILL_L50_10 2.0215600000000002e-16
C402 0 FILL_L50_11 5.6259000000000006e-19
C403 0 FILL_L50_18 3.58853e-19
C404 0 FILL_L50_2 4.6534200000000003e-17
C425 0 FILL_L10_1 3.01355e-18
C426 0 FILL_L10_5 3.03773e-18
C427 0 FILL_L10_6 6.1853600000000005e-18
C428 0 FILL_L30_14 1.5740500000000001e-18
C429 0 FILL_L30_19 6.5909900000000003e-19
C430 0 FILL_L30_7 8.7321000000000015e-18
C431 0 FILL_L30_8 8.7321000000000015e-18
C432 0 FILL_L50_10 3.2431900000000001e-17
C433 0 FILL_L50_11 2.0675799999999999e-17
C434 0 FILL_L50_18 8.6925299999999998e-17
C435 0 FILL_L50_19 6.2484900000000012e-17
C463 0 FILL_L10_1 8.8400000000000007e-19
C464 0 FILL_L10_7 2.2994300000000001e-17
C465 0 FILL_L10_8 2.32335e-18
C466 0 FILL_L10_9 4.3862300000000006e-18
C467 0 FILL_L30_15 2.3187100000000002e-17
C468 0 FILL_L30_16 8.2811000000000013e-17
C469 0 FILL_L30_17 9.0789699999999997e-17
C470 0 FILL_L30_18 7.28646e-18
C471 0 FILL_L30_19 1.9573500000000002e-18
C472 0 FILL_L50_11 1.5413800000000001e-18
C473 0 FILL_L50_18 2.4452500000000001e-16
C474 0 FILL_L50_19 2.02617e-16
C475 0 FILL_L50_26 2.0395000000000002e-18
C476 0 FILL_L50_27 4.2806600000000001e-18
C506 0 FILL_L30_0 1.19905e-18
C507 0 FILL_L30_1 4.0798400000000003e-17
C508 0 FILL_L30_15 9.1750900000000016e-18
C509 0 FILL_L30_16 9.1202000000000017e-18
C510 0 FILL_L30_7 5.9002000000000007e-17
C511 0 FILL_L50_10 9.6154700000000011e-17
C512 0 FILL_L50_18 1.4201900000000002e-16
C513 0 FILL_L50_2 6.9232900000000001e-17
C514 0 FILL_L50_26 6.7851100000000007e-18
C534 0 FILL_L10_10 6.7148000000000007e-18
C535 0 FILL_L30_15 3.6696100000000006e-18
C536 0 FILL_L30_16 1.3105700000000001e-17
C537 0 FILL_L30_17 1.3105700000000001e-17
C538 0 FILL_L30_22 9.1569500000000012e-18
C539 0 FILL_L30_23 2.60141e-18
C540 0 FILL_L50_18 3.8736299999999999e-18
C541 0 FILL_L50_19 2.2411e-18
C542 0 FILL_L50_26 1.9777900000000001e-16
C543 0 FILL_L50_27 1.60107e-16
C585 0 FILL_L10_0 1.64823e-17
C586 0 FILL_L10_10 7.2210300000000011e-18
C587 0 FILL_L10_11 2.7253200000000003e-18
C588 0 FILL_L10_2 1.3617000000000002e-17
C589 0 FILL_L10_3 6.5709300000000002e-17
C590 0 FILL_L10_4 1.0523400000000001e-17
C591 0 FILL_L10_5 1.1954300000000001e-17
C592 0 FILL_L10_6 6.4779800000000001e-17
C593 0 FILL_L10_7 1.0288500000000002e-17
C594 0 FILL_L10_8 1.4050800000000002e-17
C595 0 FILL_L10_9 5.2189200000000006e-17
C596 0 FILL_L30_10 6.9839600000000002e-18
C597 0 FILL_L30_11 1.4715000000000001e-16
C598 0 FILL_L30_12 2.0736700000000002e-17
C599 0 FILL_L30_14 6.9839600000000002e-18
C600 0 FILL_L30_18 6.9839600000000002e-18
C601 0 FILL_L30_19 1.4715000000000001e-16
C602 0 FILL_L30_20 2.0736700000000002e-17
C603 0 FILL_L30_22 6.9839600000000002e-18
C604 0 FILL_L30_23 6.5769900000000012e-17
C605 0 FILL_L30_24 9.3833400000000005e-18
C606 0 FILL_L30_3 6.9839600000000002e-18
C607 0 FILL_L30_4 1.45147e-16
C608 0 FILL_L30_5 2.0736700000000002e-17
C609 0 FILL_L30_9 6.9839600000000002e-18
C610 0 FILL_L50_0 3.3675200000000001e-17
C611 0 FILL_L50_10 1.4529200000000001e-17
C612 0 FILL_L50_11 2.11857e-16
C613 0 FILL_L50_12 3.7321900000000005e-17
C614 0 FILL_L50_16 3.7260599999999997e-17
C615 0 FILL_L50_18 1.3542300000000001e-17
C616 0 FILL_L50_19 2.11857e-16
C617 0 FILL_L50_2 1.41088e-17
C618 0 FILL_L50_20 3.7321900000000005e-17
C619 0 FILL_L50_24 3.5171100000000005e-17
C620 0 FILL_L50_26 5.7020200000000004e-18
C621 0 FILL_L50_27 9.5730200000000005e-17
C622 0 FILL_L50_3 2.11857e-16
C623 0 FILL_L50_4 3.7383099999999999e-17
C624 0 FILL_L50_8 3.7383099999999999e-17
C625 0 FILL_L8_0 6.1925600000000007e-18
C626 0 FILL_L8_1 8.0083800000000018e-18
C627 0 FILL_L8_10 1.7660900000000004e-17
C628 0 FILL_L8_12 1.0347700000000001e-18
C629 0 FILL_L8_13 2.0807600000000004e-18
C630 0 FILL_L8_3 6.8086900000000009e-18
C631 0 FILL_L8_4 2.05508e-17
C632 0 FILL_L8_6 6.1602900000000005e-18
C633 0 FILL_L8_7 2.05508e-17
C634 0 FILL_L8_9 5.9603200000000008e-18
C653 0 FILL_L10_0 1.52077e-18
C654 0 FILL_L10_3 1.60081e-17
C655 0 FILL_L10_6 1.60081e-17
C656 0 FILL_L10_9 1.2006100000000001e-17
C657 0 FILL_L30_11 3.2677e-17
C658 0 FILL_L30_12 1.55367e-16
C659 0 FILL_L30_13 6.91856e-17
C660 0 FILL_L30_19 3.2677e-17
C661 0 FILL_L30_20 1.55367e-16
C662 0 FILL_L30_21 6.91856e-17
C663 0 FILL_L30_23 1.47819e-17
C664 0 FILL_L30_24 7.1012800000000008e-17
C665 0 FILL_L30_25 3.1306499999999999e-17
C666 0 FILL_L30_4 3.2677e-17
C667 0 FILL_L30_5 1.48664e-16
C668 0 FILL_L30_6 6.91856e-17
C669 0 FILL_L8_1 1.1108900000000001e-17
C670 0 FILL_L8_10 3.1011000000000002e-17
C671 0 FILL_L8_11 3.73833e-17
C672 0 FILL_L8_13 2.5889400000000003e-18
C673 0 FILL_L8_14 6.7062400000000003e-18
C674 0 FILL_L8_2 2.2248100000000001e-17
C675 0 FILL_L8_4 3.7619100000000003e-17
C676 0 FILL_L8_5 4.0600400000000005e-17
C677 0 FILL_L8_7 3.7619100000000003e-17
C678 0 FILL_L8_8 4.0600400000000005e-17
C679 0 N 4.2665500000000008e-17
C680 0 P 3.5607700000000002e-17
C708 0 FILL_L30_13 1.1809600000000002e-16
C709 0 FILL_L30_21 1.18065e-16
C710 0 FILL_L30_25 5.3470500000000005e-17
C711 0 FILL_L30_6 1.16216e-16
C712 0 FILL_L8_11 2.4858200000000002e-17
C713 0 FILL_L8_14 3.9746199999999999e-18
C714 0 FILL_L8_2 1.3955500000000003e-17
C715 0 FILL_L8_5 2.7419600000000002e-17
C716 0 FILL_L8_8 2.7419600000000002e-17
C717 0 N 2.6993700000000001e-17
C718 0 P 3.2462000000000005e-17
C768 0 FILL_L50_1 1.8045800000000001e-18
C769 0 FILL_L50_13 1.8045800000000001e-18
C770 0 FILL_L50_14 1.5651200000000001e-16
C771 0 FILL_L50_15 1.07428e-16
C772 0 FILL_L50_17 1.8045800000000001e-18
C773 0 FILL_L50_21 1.7865400000000002e-18
C774 0 FILL_L50_22 1.56444e-16
C775 0 FILL_L50_23 1.07344e-16
C776 0 FILL_L50_25 1.7143500000000002e-18
C777 0 FILL_L50_28 7.0821800000000006e-17
C778 0 FILL_L50_29 4.9488100000000007e-17
C779 0 FILL_L50_5 1.7504400000000001e-18
C780 0 FILL_L50_6 1.5651200000000001e-16
C781 0 FILL_L50_7 9.92224e-17
C782 0 FILL_L50_9 1.8045800000000001e-18
C792 0 FILL_L10_0 5.23774e-18
C793 0 FILL_L10_10 5.3614300000000008e-19
C794 0 FILL_L10_2 3.80488e-19
C795 0 FILL_L10_3 5.5134100000000003e-17
C796 0 FILL_L10_5 7.1510500000000002e-19
C797 0 FILL_L10_6 5.5134100000000003e-17
C798 0 FILL_L10_7 6.5720700000000001e-19
C799 0 FILL_L10_8 1.5668e-18
C800 0 FILL_L10_9 4.1350600000000006e-17
C801 0 FILL_L30_11 2.5737800000000002e-16
C802 0 FILL_L30_19 2.5737800000000002e-16
C803 0 FILL_L30_23 1.16869e-16
C804 0 FILL_L30_4 2.5215400000000003e-16
C805 0 FILL_L50_0 1.8048800000000002e-17
C806 0 FILL_L50_11 1.72444e-17
C807 0 FILL_L50_12 1.8048800000000002e-17
C808 0 FILL_L50_16 1.8048800000000002e-17
C809 0 FILL_L50_19 1.72444e-17
C810 0 FILL_L50_20 1.8048800000000002e-17
C811 0 FILL_L50_24 1.8048800000000002e-17
C812 0 FILL_L50_27 6.983990000000001e-18
C813 0 FILL_L50_3 1.72444e-17
C814 0 FILL_L50_4 1.8048800000000002e-17
C815 0 FILL_L50_8 1.8048800000000002e-17
C816 0 FILL_L8_0 1.1335600000000002e-19
C817 0 FILL_L8_1 1.03528e-19
C818 0 FILL_L8_10 7.4921300000000004e-19
C819 0 FILL_L8_3 1.1932300000000001e-18
C820 0 FILL_L8_4 1.06524e-18
C821 0 FILL_L8_6 1.1932300000000001e-18
C822 0 FILL_L8_7 1.0598000000000001e-18
C823 0 FILL_L8_9 8.949200000000002e-19
C828 0 FILL_L10_0 3.7151499999999998e-18
C829 0 FILL_L10_11 1.1186900000000001e-18
C830 0 FILL_L10_3 4.8338400000000009e-18
C831 0 FILL_L10_6 4.8338400000000009e-18
C832 0 FILL_L10_9 4.8338400000000009e-18
C833 0 FILL_L30_11 3.4239300000000005e-17
C834 0 FILL_L30_12 4.7117900000000001e-18
C835 0 FILL_L30_19 3.4142200000000003e-17
C836 0 FILL_L30_20 4.7357100000000007e-18
C837 0 FILL_L30_23 1.5493300000000001e-17
C838 0 FILL_L30_24 2.1645500000000002e-18
C839 0 FILL_L30_4 3.41301e-17
C840 0 FILL_L30_5 4.7835400000000005e-18
C841 0 FILL_L8_0 1.5387599999999999e-18
C842 0 FILL_L8_1 1.4236000000000001e-18
C843 0 FILL_L8_10 1.9378300000000002e-18
C844 0 FILL_L8_12 4.6334399999999997e-19
C845 0 FILL_L8_13 3.1086700000000005e-19
C846 0 FILL_L8_3 2.0021000000000003e-18
C847 0 FILL_L8_4 1.9029700000000002e-18
C848 0 FILL_L8_6 2.0021000000000003e-18
C849 0 FILL_L8_7 1.8623000000000001e-18
C850 0 FILL_L8_9 2.0021000000000003e-18
C855 0 FILL_L30_12 9.8875000000000007e-18
C856 0 FILL_L30_13 1.0960500000000001e-17
C857 0 FILL_L30_20 9.8875000000000007e-18
C858 0 FILL_L30_21 1.0960500000000001e-17
C859 0 FILL_L30_24 4.474090000000001e-18
C860 0 FILL_L30_25 4.9596300000000002e-18
C861 0 FILL_L30_5 9.8875000000000007e-18
C862 0 FILL_L30_6 1.0960500000000001e-17
C863 0 FILL_L8_11 2.6760900000000001e-17
C864 0 FILL_L8_14 6.6526700000000001e-18
C865 0 FILL_L8_2 2.0108200000000002e-17
C866 0 FILL_L8_5 2.6760900000000001e-17
C867 0 FILL_L8_8 2.6760900000000001e-17
C869 0 FILL_L30_12 5.6403900000000007e-18
C870 0 FILL_L30_13 6.3988200000000009e-17
C871 0 FILL_L30_20 5.6403900000000007e-18
C872 0 FILL_L30_21 6.3988200000000009e-17
C873 0 FILL_L30_24 2.5522700000000003e-18
C874 0 FILL_L30_25 2.8954699999999999e-17
C875 0 FILL_L30_5 5.6403900000000007e-18
C876 0 FILL_L30_6 6.3988200000000009e-17
C877 0 FILL_L8_11 1.8460200000000003e-17
C878 0 FILL_L8_14 3.5354900000000004e-18
C879 0 FILL_L8_2 1.2144500000000002e-17
C880 0 FILL_L8_5 1.9521400000000002e-17
C881 0 FILL_L8_8 1.9521400000000002e-17
C882 0 N 1.2964900000000001e-15
C886 0 FILL_L30_13 1.6347000000000002e-16
C887 0 FILL_L30_21 1.6347000000000002e-16
C888 0 FILL_L30_25 7.4595000000000007e-17
C889 0 FILL_L30_6 1.5824600000000001e-16
C890 0 FILL_L8_11 7.04443e-18
C891 0 FILL_L8_14 2.1452200000000002e-19
C892 0 FILL_L8_2 8.3910100000000002e-19
C893 0 FILL_L8_5 9.0734900000000006e-18
C894 0 FILL_L8_8 9.0734900000000006e-18
C895 0 P 3.4877500000000003e-15
C899 0 FILL_L30_13 1.6347000000000002e-16
C900 0 FILL_L30_21 1.6347000000000002e-16
C901 0 FILL_L30_25 7.4595000000000007e-17
C902 0 FILL_L30_6 1.5824600000000001e-16
C903 0 FILL_L8_11 8.9074000000000012e-19
C904 0 FILL_L8_2 1.12827e-19
C905 0 FILL_L8_5 1.1876500000000002e-18
C906 0 FILL_L8_8 1.1876500000000002e-18
C910 0 FILL_L30_13 2.5335000000000001e-16
C911 0 FILL_L30_21 2.5335000000000001e-16
C912 0 FILL_L30_25 1.15266e-16
C913 0 FILL_L30_6 2.4812600000000003e-16
C914 0 FILL_L8_11 8.4939500000000011e-19
C915 0 FILL_L8_2 1.0759000000000002e-19
C916 0 FILL_L8_5 1.1325300000000001e-18
C917 0 FILL_L8_8 1.1325300000000001e-18
C921 0 FILL_L30_13 2.1587400000000001e-16
C922 0 FILL_L30_21 2.1584700000000002e-16
C923 0 FILL_L30_25 9.8307800000000003e-17
C924 0 FILL_L30_6 2.10569e-16
C925 0 FILL_L8_11 6.3298400000000003e-19
C926 0 FILL_L8_5 8.4397900000000014e-19
C927 0 FILL_L8_8 8.4397900000000014e-19
C930 0 FILL_L30_13 3.4239300000000005e-17
C931 0 FILL_L30_21 3.4177999999999998e-17
C932 0 FILL_L30_25 1.5493300000000001e-17
C933 0 FILL_L30_6 3.4239300000000005e-17
C937 0 FILL_L30_13 1.3544600000000001e-17
C938 0 FILL_L30_21 1.3510700000000002e-17
C939 0 FILL_L30_25 6.12892e-18
C940 0 FILL_L30_6 1.3544600000000001e-17
C941 0 FILL_L8_11 1.13984e-18
C942 0 FILL_L8_14 2.6379200000000005e-19
C943 0 FILL_L8_2 8.1417400000000005e-19
C944 0 FILL_L8_5 1.13984e-18
C945 0 FILL_L8_8 1.13984e-18
C950 0 FILL_L10_0 3.1223700000000004e-18
C951 0 FILL_L10_11 9.4019400000000005e-19
C952 0 FILL_L10_3 4.0625600000000005e-18
C953 0 FILL_L10_6 4.0625600000000005e-18
C954 0 FILL_L10_9 4.0625600000000005e-18
C955 0 FILL_L30_11 1.3544600000000001e-17
C956 0 FILL_L30_12 8.1080500000000005e-18
C957 0 FILL_L30_19 1.3544600000000001e-17
C958 0 FILL_L30_20 8.0269700000000013e-18
C959 0 FILL_L30_23 6.12892e-18
C960 0 FILL_L30_24 3.6688900000000008e-18
C961 0 FILL_L30_4 1.3544600000000001e-17
C962 0 FILL_L30_5 8.1080500000000005e-18
C963 0 FILL_L8_0 1.43099e-18
C964 0 FILL_L8_1 5.2405600000000007e-18
C965 0 FILL_L8_10 6.9069400000000003e-18
C966 0 FILL_L8_12 4.3089200000000001e-19
C967 0 FILL_L8_13 1.4563500000000002e-18
C968 0 FILL_L8_3 1.8618800000000002e-18
C969 0 FILL_L8_4 6.8709400000000007e-18
C970 0 FILL_L8_6 1.8618800000000002e-18
C971 0 FILL_L8_7 6.8289299999999999e-18
C972 0 FILL_L8_9 1.8618800000000002e-18
C976 0 FILL_L30_13 4.422380000000001e-18
C977 0 FILL_L30_21 4.4113300000000005e-18
C978 0 FILL_L30_25 1.9458500000000003e-18
C979 0 FILL_L30_6 4.38922e-18
C980 0 FILL_L8_11 2.6689400000000004e-19
C981 0 FILL_L8_2 1.9063900000000002e-19
C982 0 FILL_L8_5 2.6689400000000004e-19
C983 0 FILL_L8_8 1.5251100000000003e-19
C1000 0 FILL_L30_13 1.4938900000000001e-18
C1001 0 FILL_L30_21 1.4901600000000001e-18
C1002 0 FILL_L30_25 6.5731200000000007e-19
C1003 0 FILL_L30_6 1.4266700000000003e-18
C1031 0 FILL_L50_1 2.2471000000000003e-17
C1032 0 FILL_L50_13 2.2471000000000003e-17
C1033 0 FILL_L50_14 1.9033800000000001e-17
C1034 0 FILL_L50_17 2.2471000000000003e-17
C1035 0 FILL_L50_21 2.2471000000000003e-17
C1036 0 FILL_L50_22 1.9033800000000001e-17
C1037 0 FILL_L50_25 2.2471000000000003e-17
C1038 0 FILL_L50_28 7.7087000000000012e-18
C1039 0 FILL_L50_5 2.2471000000000003e-17
C1040 0 FILL_L50_6 1.9033800000000001e-17
C1041 0 FILL_L50_9 2.2471000000000003e-17
C1045 0 FILL_L10_0 2.5345000000000003e-18
C1046 0 FILL_L10_11 7.6317800000000006e-19
C1047 0 FILL_L10_3 3.2976800000000003e-18
C1048 0 FILL_L10_6 3.2976800000000003e-18
C1049 0 FILL_L10_9 3.2976800000000003e-18
C1050 0 FILL_L30_11 7.3730700000000005e-18
C1051 0 FILL_L30_12 1.5077100000000001e-17
C1052 0 FILL_L30_19 7.3730700000000005e-18
C1053 0 FILL_L30_20 1.5077100000000001e-17
C1054 0 FILL_L30_23 3.3363100000000002e-18
C1055 0 FILL_L30_24 6.8223700000000008e-18
C1056 0 FILL_L30_4 7.3730700000000005e-18
C1057 0 FILL_L30_5 1.5077100000000001e-17
C1058 0 FILL_L8_1 1.7889600000000004e-17
C1059 0 FILL_L8_10 2.3982500000000003e-17
C1060 0 FILL_L8_13 6.0226900000000006e-18
C1061 0 FILL_L8_4 2.3891200000000004e-17
C1062 0 FILL_L8_7 2.3961500000000003e-17
C1065 0 FILL_L10_0 2.0323700000000001e-18
C1066 0 FILL_L10_11 6.1197800000000005e-19
C1067 0 FILL_L10_3 2.6443500000000005e-18
C1068 0 FILL_L10_6 2.6443500000000005e-18
C1069 0 FILL_L10_9 2.6443500000000005e-18
C1070 0 FILL_L30_11 4.422380000000001e-18
C1071 0 FILL_L30_12 4.96112e-17
C1072 0 FILL_L30_19 4.422380000000001e-18
C1073 0 FILL_L30_20 4.96112e-17
C1074 0 FILL_L30_23 2.0011300000000001e-18
C1075 0 FILL_L30_24 2.2449100000000002e-17
C1076 0 FILL_L30_4 4.422380000000001e-18
C1077 0 FILL_L30_5 4.96112e-17
C1078 0 FILL_L8_1 1.7384400000000001e-17
C1079 0 FILL_L8_10 2.4494500000000002e-17
C1080 0 FILL_L8_13 5.7701500000000008e-18
C1081 0 FILL_L8_4 2.5126600000000003e-17
C1082 0 FILL_L8_7 2.5126600000000003e-17
C1085 0 FILL_L10_0 1.1527700000000001e-19
C1086 0 FILL_L10_3 1.2134400000000001e-18
C1087 0 FILL_L10_6 1.2134400000000001e-18
C1088 0 FILL_L10_9 9.100810000000001e-19
C1089 0 FILL_L30_12 2.3002400000000001e-16
C1090 0 FILL_L30_20 2.3002400000000001e-16
C1091 0 FILL_L30_24 1.0471100000000001e-16
C1092 0 FILL_L30_5 2.2480099999999999e-16
C1093 0 FILL_L8_1 5.1599100000000003e-18
C1094 0 FILL_L8_10 2.1666799999999999e-17
C1095 0 FILL_L8_13 1.1506799999999999e-18
C1096 0 FILL_L8_4 2.7211800000000002e-17
C1097 0 FILL_L8_7 2.7277200000000002e-17
C1100 0 FILL_L30_12 3.1181700000000005e-16
C1101 0 FILL_L30_20 3.1181700000000005e-16
C1102 0 FILL_L30_24 1.4172200000000002e-16
C1103 0 FILL_L30_5 3.0659400000000004e-16
C1104 0 FILL_L8_1 3.0629300000000005e-18
C1105 0 FILL_L8_10 2.4480100000000003e-17
C1106 0 FILL_L8_13 2.6815299999999997e-19
C1107 0 FILL_L8_4 3.2241300000000007e-17
C1108 0 FILL_L8_7 3.2241300000000007e-17
C1111 0 FILL_L30_12 3.1181700000000005e-16
C1112 0 FILL_L30_20 3.1181700000000005e-16
C1113 0 FILL_L30_24 1.4172200000000002e-16
C1114 0 FILL_L30_5 3.0659400000000004e-16
C1115 0 FILL_L8_1 1.1661500000000001e-18
C1116 0 FILL_L8_10 9.2064100000000003e-18
C1117 0 FILL_L8_11 7.8927700000000007e-19
C1118 0 FILL_L8_4 1.2275200000000001e-17
C1119 0 FILL_L8_5 1.0523700000000001e-18
C1120 0 FILL_L8_7 1.2275200000000001e-17
C1121 0 FILL_L8_8 1.0523700000000001e-18
C1125 0 FILL_L30_12 1.7055600000000003e-16
C1126 0 FILL_L30_13 3.4565600000000004e-18
C1127 0 FILL_L30_20 1.7055600000000003e-16
C1128 0 FILL_L30_21 3.4565600000000004e-18
C1129 0 FILL_L30_24 7.7238900000000012e-17
C1130 0 FILL_L30_25 1.5640900000000001e-18
C1131 0 FILL_L30_5 1.70033e-16
C1132 0 FILL_L30_6 3.4565600000000004e-18
C1133 0 FILL_L8_11 1.7974100000000001e-17
C1134 0 FILL_L8_14 4.573210000000001e-18
C1135 0 FILL_L8_2 1.3400900000000001e-17
C1136 0 FILL_L8_4 1.02657e-19
C1137 0 FILL_L8_5 1.8094500000000002e-17
C1138 0 FILL_L8_7 1.02657e-19
C1139 0 FILL_L8_8 1.8094500000000002e-17
C1141 0 FILL_L30_12 1.8617000000000002e-17
C1142 0 FILL_L30_13 6.1497500000000007e-18
C1143 0 FILL_L30_20 1.8617000000000002e-17
C1144 0 FILL_L30_21 6.1497500000000007e-18
C1145 0 FILL_L30_24 8.4241900000000005e-18
C1146 0 FILL_L30_25 2.7827600000000002e-18
C1147 0 FILL_L30_5 1.8617000000000002e-17
C1148 0 FILL_L30_6 6.1497500000000007e-18
C1149 0 FILL_L8_11 1.5276800000000002e-17
C1150 0 FILL_L8_14 3.5354900000000004e-18
C1151 0 FILL_L8_2 1.1741300000000001e-17
C1152 0 FILL_L8_5 1.5276800000000002e-17
C1153 0 FILL_L8_8 1.5276800000000002e-17
C1162 0 FILL_L10_1 4.2585100000000006e-18
C1163 0 FILL_L10_2 4.23156e-19
C1164 0 FILL_L10_4 5.7059600000000007e-17
C1165 0 FILL_L10_5 3.8885599999999999e-17
C1166 0 FILL_L10_6 8.7830700000000014e-18
C1167 0 FILL_L30_10 2.5803900000000002e-17
C1168 0 FILL_L30_11 3.3831800000000004e-19
C1169 0 FILL_L30_14 9.7586700000000011e-18
C1170 0 FILL_L30_7 2.7240300000000003e-18
C1171 0 FILL_L30_8 2.8472000000000001e-18
C1172 0 FILL_L50_10 4.6299700000000006e-17
C1173 0 FILL_L50_11 7.054040000000001e-17
C1174 0 FILL_L50_18 1.08996e-17
C1175 0 FILL_L50_19 3.3201700000000004e-17
C1176 0 FILL_L8_6 5.9838200000000006e-17
C1182 0 FILL_L30_21 2.9637200000000006e-19
C1183 0 FILL_L50_22 2.2412800000000003e-18
C1188 0 FILL_L50_7 7.7724700000000001e-18
C1193 0 FILL_L50_1 8.5110799999999999e-18
C1194 0 FILL_L50_6 1.6443899999999999e-17
C1204 0 FILL_L50_14 7.6011000000000003e-18
C1205 0 FILL_L50_5 1.2157800000000002e-18
C1206 0 FILL_L50_6 2.73174e-18
C1207 0 FILL_L50_9 3.2072900000000001e-18
C1212 0 FILL_L50_14 1.2819800000000002e-17
C1213 0 FILL_L50_6 4.6072600000000004e-18
C1217 0 FILL_L50_15 3.5169300000000001e-18
C1218 0 FILL_L50_7 1.2157800000000002e-18
C1223 0 FILL_L30_6 2.9637200000000006e-19
C1224 0 FILL_L50_5 4.9172600000000003e-18
C1228 0 FILL_L50_5 8.4489100000000011e-18
C1229 0 FILL_L50_6 1.5960200000000002e-17
C1233 0 FILL_L50_6 2.3181900000000001e-17
C1234 0 FILL_L50_7 3.5724100000000001e-18
C1236 0 FILL_L50_7 5.1847000000000006e-18
C1241 0 FILL_L50_17 1.6407500000000001e-18
C1242 0 FILL_L50_21 3.1251400000000002e-18
C1243 0 FILL_L50_22 2.2458200000000003e-17
C1247 0 FILL_L50_6 2.3997800000000003e-17
C1248 0 FILL_L50_7 3.5724100000000001e-18
C1253 0 FILL_L50_22 3.2410600000000002e-17
C1254 0 FILL_L50_23 3.5724100000000001e-18
C1258 0 FILL_L50_23 7.7724700000000001e-18
C1263 0 FILL_L50_21 1.5251800000000001e-19
C1267 0 FILL_L50_21 3.4331700000000004e-18
C1268 0 FILL_L50_22 8.9508799999999996e-18
C1269 0 FILL_L50_25 1.1071200000000001e-18
C1270 0 FILL_L50_28 2.3928000000000001e-18
C1274 0 FILL_L50_22 1.4980000000000002e-17
C1275 0 FILL_L50_23 1.1908000000000002e-19
C1276 0 FILL_L50_28 4.0356199999999998e-18
C1279 0 FILL_L50_23 4.0755400000000001e-18
C1280 0 FILL_L50_29 1.1071200000000001e-18
C1285 0 FILL_L50_25 7.6258800000000007e-19
C1289 0 FILL_L50_21 9.5007400000000003e-19
C1290 0 FILL_L50_22 2.0533900000000001e-18
C1291 0 FILL_L50_25 4.0870899999999999e-18
C1292 0 FILL_L50_28 9.8528199999999999e-18
C1295 0 FILL_L30_12 1.8274000000000002e-19
C1296 0 FILL_L30_13 3.0059499999999999e-17
C1297 0 FILL_L30_20 1.8274000000000002e-19
C1298 0 FILL_L30_21 3.0039800000000003e-17
C1299 0 FILL_L30_24 1.2182600000000002e-19
C1300 0 FILL_L30_25 1.3899200000000001e-17
C1301 0 FILL_L30_5 1.8274000000000002e-19
C1302 0 FILL_L30_6 3.0000500000000003e-17
C1303 0 FILL_L8_11 2.4158700000000001e-17
C1304 0 FILL_L8_14 5.5910000000000005e-18
C1305 0 FILL_L8_2 1.85677e-17
C1306 0 FILL_L8_5 2.4158700000000001e-17
C1307 0 FILL_L8_8 2.4158700000000001e-17
C1308 0 P 1.0883400000000001e-19
C1312 0 FILL_L50_22 3.4631700000000002e-18
C1313 0 FILL_L50_28 1.6035900000000003e-17
C1314 0 FILL_L50_29 5.9540100000000002e-19
C1317 0 FILL_L50_23 9.5007400000000003e-19
C1318 0 FILL_L50_29 4.2291999999999998e-18
C1324 0 FILL_L50_13 2.6523100000000003e-18
C1325 0 FILL_L50_14 5.7324100000000001e-18
C1326 0 FILL_L50_17 2.10341e-18
C1327 0 FILL_L50_22 4.5460800000000005e-18
C1332 0 FILL_L50_14 9.6681000000000017e-18
C1333 0 FILL_L50_22 7.66727e-18
C1337 0 FILL_L30_25 2.9637200000000006e-19
C1338 0 FILL_L50_28 2.2412800000000003e-18
C1341 0 FILL_L50_25 3.0464200000000001e-18
C1342 0 FILL_L50_28 1.6865300000000002e-17
C1345 0 FILL_L50_28 2.2977700000000001e-17
C1346 0 FILL_L50_29 3.5724100000000001e-18
C1348 0 FILL_L50_29 5.1847000000000006e-18
C1356 0 FILL_L30_14 7.7216800000000004e-19
C1357 0 FILL_L50_18 2.8081800000000003e-18
C1358 0 FILL_L50_19 2.8760599999999999e-18
C1367 0 FILL_L50_18 1.71585e-17
C1375 0 FILL_L30_13 1.9135000000000003e-18
C1376 0 FILL_L30_21 1.90872e-18
C1377 0 FILL_L30_25 8.4194000000000004e-19
C1378 0 FILL_L30_6 1.8273900000000003e-18
C1379 0 FILL_L50_1 5.5268800000000004e-19
C1380 0 FILL_L50_13 5.9216500000000006e-19
C1381 0 FILL_L50_17 5.5268800000000004e-19
C1382 0 FILL_L50_21 7.8165800000000004e-19
C1383 0 FILL_L50_25 7.5007600000000003e-19
C1384 0 FILL_L50_5 5.2900100000000013e-19
C1385 0 FILL_L50_9 7.8955400000000004e-19
C1394 0 FILL_L10_5 2.3464000000000001e-17
C1395 0 FILL_L10_7 1.2560600000000001e-16
C1396 0 FILL_L10_8 3.69509e-17
C1397 0 FILL_L10_9 5.8696299999999999e-18
C1398 0 FILL_L30_14 2.4806100000000002e-17
C1399 0 FILL_L30_15 2.4140500000000004e-19
C1400 0 FILL_L30_16 1.7541500000000004e-18
C1401 0 FILL_L30_17 1.8815700000000001e-17
C1402 0 FILL_L30_18 3.9917700000000004e-17
C1403 0 FILL_L30_19 2.1187900000000001e-17
C1404 0 FILL_L30_22 1.3474100000000002e-18
C1405 0 FILL_L50_18 2.3781500000000002e-17
C1406 0 FILL_L50_19 9.621030000000001e-17
C1407 0 FILL_L50_20 1.2237100000000002e-18
C1408 0 FILL_L50_27 1.0714600000000001e-18
C1409 0 FILL_L8_6 4.5699600000000006e-18
C1410 0 FILL_L8_9 5.6810400000000007e-17
C1418 0 FILL_L30_16 2.6232799999999999e-18
C1419 0 FILL_L30_17 4.3843300000000008e-19
C1420 0 FILL_L50_18 1.1173900000000002e-18
C1421 0 FILL_L50_19 2.6240000000000004e-19
C1422 0 FILL_L50_26 3.2395600000000003e-19
C1429 0 FILL_L30_15 1.0938100000000002e-17
C1430 0 FILL_L30_16 1.6225800000000002e-17
C1431 0 FILL_L50_18 1.3952600000000001e-17
C1432 0 FILL_L50_26 2.8995600000000002e-18
C1435 0 FILL_L30_15 1.7312600000000001e-18
C1436 0 FILL_L30_16 2.44398e-18
C1437 0 FILL_L50_18 7.6298000000000008e-18
C1438 0 FILL_L50_26 2.1296900000000002e-18
C1444 0 FILL_L30_16 3.10774e-19
C1445 0 FILL_L30_17 4.4194700000000003e-18
C1446 0 FILL_L50_18 2.4668500000000001e-19
C1447 0 FILL_L50_19 2.1116400000000001e-18
C1448 0 FILL_L50_27 1.69366e-18
C1452 0 FILL_L30_16 2.1981500000000001e-18
C1453 0 FILL_L50_18 1.54633e-18
C1454 0 FILL_L50_26 1.2304e-18
C1457 0 FILL_L10_8 8.3462100000000003e-19
C1458 0 FILL_L30_17 1.2457900000000001e-17
C1459 0 FILL_L50_19 7.28628e-18
C1460 0 FILL_L50_27 3.6750500000000003e-18
C1463 0 FILL_L30_15 3.8119000000000001e-19
C1464 0 FILL_L30_16 5.5513899999999999e-18
C1465 0 FILL_L50_18 6.2123700000000002e-18
C1466 0 FILL_L50_26 4.7743000000000009e-18
C1470 0 FILL_L50_15 2.6523100000000003e-18
C1471 0 FILL_L50_23 2.10341e-18
C1473 0 FILL_L10_5 3.7656000000000001e-19
C1474 0 FILL_L30_14 1.8602600000000003e-18
C1475 0 FILL_L30_19 2.3463700000000003e-19
C1476 0 FILL_L50_11 8.2010300000000005e-19
C1477 0 FILL_L50_19 1.6220700000000002e-17
C1480 0 FILL_L50_18 1.3622800000000001e-17
C1481 0 FILL_L50_19 1.0332399999999999e-18
C1485 0 FILL_L50_10 1.3057700000000001e-19
C1486 0 FILL_L50_18 1.7659700000000001e-19
C1492 0 FILL_L50_26 3.1317000000000001e-18
C1493 0 FILL_L50_27 2.0480300000000004e-19
C1497 0 FILL_L50_26 3.9601500000000005e-18
C1500 0 FILL_L50_26 6.6615700000000008e-18
C1505 0 FILL_L30_15 1.5187000000000002e-19
C1506 0 FILL_L30_16 8.0153800000000006e-19
C1507 0 FILL_L30_22 6.190480000000001e-19
C1508 0 FILL_L50_26 1.4625400000000002e-17
C1511 0 FILL_L50_26 6.947780000000001e-19
C1518 0 FILL_L30_23 1.2526300000000003e-19
C1519 0 FILL_L50_26 4.51495e-18
C1520 0 FILL_L50_27 1.9988400000000002e-18
C1524 0 FILL_L30_22 1.1154600000000002e-19
C1525 0 FILL_L50_26 2.6123000000000004e-19
C1526 0 FILL_L50_27 3.3316400000000006e-18
C1529 0 FILL_L10_10 4.5227299999999998e-19
C1530 0 FILL_L30_17 1.76279e-19
C1531 0 FILL_L30_22 1.21893e-19
C1532 0 FILL_L30_23 2.3907300000000003e-19
C1533 0 FILL_L50_27 8.0095500000000006e-18
C1536 0 FILL_L10_10 5.1235700000000005e-17
C1537 0 FILL_L10_7 1.53631e-19
C1538 0 FILL_L10_8 6.5215200000000004e-17
C1539 0 FILL_L30_15 8.016050000000001e-19
C1540 0 FILL_L30_16 2.7197300000000002e-18
C1541 0 FILL_L30_17 3.9436800000000006e-18
C1542 0 FILL_L30_18 7.01785e-18
C1543 0 FILL_L30_22 5.4420900000000009e-17
C1544 0 FILL_L30_23 1.2409700000000001e-17
C1545 0 FILL_L30_24 1.5598100000000001e-19
C1546 0 FILL_L50_19 9.5977300000000017e-18
C1547 0 FILL_L50_24 2.64376e-18
C1548 0 FILL_L50_26 2.6789500000000004e-17
C1549 0 FILL_L50_27 5.7371000000000001e-17
C1550 0 FILL_L8_12 8.3586500000000014e-18
C1551 0 FILL_L8_9 1.1466700000000001e-17
C1553 0 FILL_L10_10 1.1219200000000001e-17
C1554 0 FILL_L30_22 1.04779e-18
C1555 0 FILL_L8_12 2.19142e-18
C1559 0 FILL_L50_10 4.6697699999999996e-19
C1560 0 FILL_L50_18 6.17628e-19
C1563 0 FILL_L30_14 1.01227e-19
C1564 0 FILL_L50_10 7.8882100000000005e-19
C1565 0 FILL_L50_18 1.2571300000000002e-17
C1567 0 FILL_L30_15 3.7451000000000002e-18
C1568 0 FILL_L30_16 8.6843700000000006e-18
C1569 0 FILL_L30_17 1.3202400000000002e-18
C1570 0 FILL_L50_18 9.6144000000000002e-18
C1571 0 FILL_L50_19 1.3945300000000002e-18
C1574 0 FILL_L30_21 2.9637200000000006e-19
C1575 0 FILL_L50_17 4.9172600000000003e-18
C1578 0 FILL_L50_10 2.1050400000000001e-18
C1579 0 FILL_L50_18 7.73871e-18
C1581 0 FILL_L30_14 3.6731300000000002e-19
C1582 0 FILL_L50_10 3.2646700000000003e-19
C1583 0 FILL_L50_18 8.8010200000000006e-18
C1584 0 FILL_L50_19 1.1330499999999999e-18
C1590 0 FILL_L30_0 2.9120900000000003e-18
C1591 0 FILL_L30_1 1.5351100000000001e-18
C1592 0 FILL_L50_10 9.7504500000000019e-19
C1593 0 FILL_L50_2 2.8393600000000004e-18
C1597 0 FILL_L30_1 6.7061500000000003e-18
C1598 0 FILL_L30_7 4.0470900000000001e-18
C1599 0 FILL_L50_10 3.1123500000000002e-18
C1600 0 FILL_L50_2 3.07738e-18
C1606 0 FILL_L30_0 4.3750300000000002e-18
C1607 0 FILL_L30_1 1.3788300000000001e-17
C1608 0 FILL_L30_2 2.60675e-18
C1609 0 FILL_L50_2 6.6018700000000003e-18
C1610 0 FILL_L50_3 1.43811e-18
C1617 0 FILL_L10_1 4.0191000000000003e-19
C1618 0 FILL_L10_3 1.34566e-19
C1619 0 FILL_L30_2 3.6353699999999999e-18
C1620 0 FILL_L30_8 1.3664700000000002e-18
C1621 0 FILL_L50_11 1.25532e-18
C1622 0 FILL_L50_3 2.1050400000000001e-18
C1630 0 FILL_L10_1 3.3175800000000001e-18
C1631 0 FILL_L10_3 2.5314100000000004e-19
C1632 0 FILL_L30_2 3.5601600000000008e-18
C1633 0 FILL_L30_3 7.3505400000000006e-19
C1634 0 FILL_L30_8 2.1159700000000002e-18
C1635 0 FILL_L50_11 3.7296400000000003e-18
C1636 0 FILL_L50_3 6.2237000000000002e-18
C1642 0 FILL_L30_1 6.6521200000000005e-19
C1643 0 FILL_L30_7 1.91811e-18
C1644 0 FILL_L50_10 4.0161600000000005e-18
C1645 0 FILL_L50_2 3.6992800000000005e-18
C1648 0 FILL_L30_0 2.4921400000000001e-18
C1649 0 FILL_L50_10 2.2420000000000001e-18
C1650 0 FILL_L50_2 2.06609e-18
C1653 0 FILL_L50_17 8.5136299999999999e-18
C1654 0 FILL_L50_22 1.7724500000000001e-17
C1658 0 FILL_L10_3 3.1761300000000001e-19
C1659 0 FILL_L30_2 7.79883e-19
C1660 0 FILL_L30_3 2.2042300000000002e-18
C1661 0 FILL_L30_8 5.3230100000000004e-19
C1662 0 FILL_L30_9 1.6915000000000002e-18
C1663 0 FILL_L50_11 6.3472400000000009e-18
C1664 0 FILL_L50_3 7.2664099999999998e-18
C1668 0 FILL_L30_0 4.7265300000000002e-19
C1669 0 FILL_L30_7 1.09307e-18
C1670 0 FILL_L50_10 5.4321100000000003e-18
C1671 0 FILL_L50_2 2.6070500000000003e-18
C1674 0 FILL_L10_1 9.2318199999999995e-19
C1675 0 FILL_L30_7 9.5304200000000008e-18
C1676 0 FILL_L30_8 9.6469100000000004e-18
C1677 0 FILL_L50_10 5.5675400000000003e-18
C1678 0 FILL_L50_11 2.4021400000000002e-18
C1681 0 FILL_L10_1 1.3462899999999999e-16
C1682 0 FILL_L10_2 9.7906800000000007e-17
C1683 0 FILL_L10_3 1.7241900000000001e-18
C1684 0 FILL_L10_4 1.2066200000000001e-17
C1685 0 FILL_L30_0 4.8734399999999999e-19
C1686 0 FILL_L30_10 1.58428e-17
C1687 0 FILL_L30_11 2.0898600000000001e-17
C1688 0 FILL_L30_3 5.6706300000000001e-19
C1689 0 FILL_L30_7 3.1439600000000003e-17
C1690 0 FILL_L30_8 4.1935900000000002e-17
C1691 0 FILL_L30_9 3.0536700000000002e-17
C1692 0 FILL_L50_10 7.9632300000000004e-17
C1693 0 FILL_L50_11 1.1054200000000001e-16
C1694 0 FILL_L50_3 3.0221500000000001e-18
C1695 0 FILL_L50_8 8.8645799999999996e-19
C1696 0 FILL_L8_3 2.8808900000000001e-17
C1697 0 FILL_L8_6 1.6719400000000001e-18
C1700 0 FILL_L50_2 4.1239800000000011e-18
C1705 0 FILL_L30_4 1.25274e-19
C1706 0 FILL_L50_2 7.9039400000000009e-19
C1707 0 FILL_L50_3 1.35751e-18
C1711 0 FILL_L10_0 6.9492500000000008e-19
C1712 0 FILL_L30_4 9.3153799999999995e-19
C1713 0 FILL_L50_3 7.0749700000000005e-18
C1714 0 FILL_L8_0 1.10765e-17
C1718 0 FILL_L50_2 5.0911900000000006e-18
C1723 0 FILL_L30_4 1.7218100000000002e-19
C1724 0 FILL_L50_3 5.3699700000000007e-18
C1727 0 FILL_L50_22 2.61575e-17
C1728 0 FILL_L50_23 3.5724100000000001e-18
C1732 0 FILL_L30_4 5.8586300000000005e-19
C1733 0 FILL_L50_2 1.06937e-17
C1734 0 FILL_L50_3 5.6860700000000001e-18
C1737 0 FILL_L10_0 6.8308100000000008e-19
C1738 0 FILL_L10_1 6.6140500000000006e-19
C1739 0 FILL_L30_4 2.8540000000000004e-18
C1740 0 FILL_L50_3 2.5064699999999999e-17
C1741 0 FILL_L8_0 3.0667e-18
C1744 0 FILL_L10_1 7.5749200000000007e-19
C1745 0 FILL_L10_2 7.7327100000000006e-19
C1746 0 FILL_L30_0 7.5277300000000012e-18
C1747 0 FILL_L30_1 2.5609300000000004e-17
C1748 0 FILL_L30_2 3.7341600000000002e-17
C1749 0 FILL_L30_3 2.4908800000000001e-17
C1750 0 FILL_L30_4 1.7598700000000002e-17
C1751 0 FILL_L30_5 1.09187e-19
C1752 0 FILL_L30_9 3.94478e-19
C1753 0 FILL_L50_11 5.4886500000000006e-19
C1754 0 FILL_L50_2 5.5626800000000013e-17
C1755 0 FILL_L50_3 9.2880000000000005e-17
C1756 0 FILL_L50_4 1.5355600000000002e-18
C1757 0 FILL_L8_0 1.9495400000000002e-17
C1759 0 FILL_L30_1 1.7796900000000001e-18
C1760 0 FILL_L30_2 5.0708100000000005e-18
C1761 0 FILL_L50_2 1.1262800000000001e-18
C1762 0 FILL_L50_3 1.2994400000000001e-18
C1764 0 FILL_L50_7 5.4645300000000005e-18
C1768 0 FILL_L30_13 2.9637200000000006e-19
C1769 0 FILL_L50_14 2.2412800000000003e-18
C1773 0 FILL_L50_13 1.1955900000000001e-18
C1774 0 FILL_L50_14 2.15003e-17
C1775 0 FILL_L50_9 3.2291400000000005e-18
C1777 0 FILL_L50_23 6.0570300000000002e-18
C1781 0 FILL_L50_14 3.0795000000000003e-17
C1782 0 FILL_L50_15 3.5724100000000001e-18
C1785 0 FILL_L50_15 7.3292599999999995e-18
C1788 0 FILL_L30_6 2.9637200000000006e-19
C1789 0 FILL_L50_1 4.9172600000000003e-18
C1792 0 FILL_L30_13 2.9637200000000006e-19
C1793 0 FILL_L50_13 4.0977100000000007e-18
C1794 0 FILL_L50_14 3.7354700000000005e-19
C1797 0 FILL_L50_13 7.6325900000000008e-18
C1798 0 FILL_L50_14 1.89928e-17
C1799 0 FILL_L50_9 1.8564900000000003e-19
C1802 0 FILL_L50_14 2.79482e-17
C1803 0 FILL_L50_15 3.5724100000000001e-18
C1805 0 FILL_L50_15 6.5647300000000002e-18
C1808 0 FILL_L30_6 2.9637200000000006e-19
C1809 0 FILL_L50_6 2.2412800000000003e-18
C1812 0 FILL_L50_1 2.2595200000000004e-18
C1813 0 FILL_L50_5 2.4948700000000005e-18
C1814 0 FILL_L50_6 2.2458200000000003e-17
C1816 0 FILL_L50_6 3.2410600000000002e-17
C1817 0 FILL_L50_7 3.5724100000000001e-18
C1819 FILL_L10_0 FILL_L10_3 9.7773300000000019e-17
C1820 FILL_L10_0 FILL_L30_4 7.5154900000000004e-16
C1821 FILL_L10_0 FILL_L30_5 5.3330100000000006e-18
C1822 FILL_L10_0 FILL_L50_0 2.4367500000000001e-18
C1823 FILL_L10_0 FILL_L50_3 9.6723700000000018e-18
C1824 FILL_L10_0 FILL_L8_0 6.3292300000000009e-16
C1825 FILL_L10_0 FILL_L8_1 2.31346e-17
C1826 FILL_L10_0 0 2.7155900000000005e-16
C1827 FILL_L10_1 FILL_L10_2 2.7935199999999999e-17
C1828 FILL_L10_1 FILL_L30_11 5.333980000000001e-19
C1829 FILL_L10_1 FILL_L30_8 2.7232700000000005e-17
C1830 FILL_L10_1 FILL_L30_9 6.9870900000000006e-18
C1831 FILL_L10_1 FILL_L50_11 5.3790600000000004e-17
C1832 FILL_L10_1 FILL_L50_19 1.4671500000000001e-18
C1833 FILL_L10_1 FILL_L50_3 5.2666500000000004e-18
C1834 FILL_L10_1 0 5.6606400000000004e-17
C1835 FILL_L10_10 FILL_L10_11 2.2627500000000004e-17
C1836 FILL_L10_10 FILL_L10_8 2.7935199999999999e-17
C1837 FILL_L10_10 FILL_L30_22 2.55017e-17
C1838 FILL_L10_10 FILL_L30_23 4.4166999999999998e-18
C1839 FILL_L10_10 FILL_L50_27 2.6784800000000002e-17
C1840 FILL_L10_10 FILL_L8_12 1.92413e-18
C1841 FILL_L10_10 0 7.5028300000000006e-17
C1842 FILL_L10_11 FILL_L10_9 9.7773300000000019e-17
C1843 FILL_L10_11 FILL_L30_23 2.8394200000000002e-16
C1844 FILL_L10_11 FILL_L30_24 1.7278900000000001e-18
C1845 FILL_L10_11 FILL_L8_12 1.9058300000000001e-16
C1846 FILL_L10_11 FILL_L8_13 6.9661799999999997e-18
C1847 FILL_L10_11 0 1.9341300000000002e-16
C1848 FILL_L10_2 FILL_L10_3 2.7935199999999999e-17
C1849 FILL_L10_2 FILL_L10_4 2.7935199999999999e-17
C1850 FILL_L10_2 FILL_L30_10 1.73e-18
C1851 FILL_L10_2 FILL_L30_11 4.6154600000000001e-18
C1852 FILL_L10_2 FILL_L30_3 9.0636499999999999e-19
C1853 FILL_L10_2 FILL_L30_9 5.1247100000000005e-17
C1854 FILL_L10_2 FILL_L50_11 2.5647800000000003e-17
C1855 FILL_L10_2 FILL_L50_3 1.9058600000000003e-18
C1856 FILL_L10_2 FILL_L50_8 1.9454000000000001e-18
C1857 FILL_L10_2 FILL_L8_3 1.7365700000000001e-18
C1858 FILL_L10_2 0 6.7243600000000002e-17
C1859 FILL_L10_3 FILL_L10_6 9.7773300000000019e-17
C1860 FILL_L10_3 FILL_L30_11 6.1463700000000001e-16
C1861 FILL_L10_3 FILL_L30_12 3.1998100000000002e-18
C1862 FILL_L10_3 FILL_L30_4 2.3953800000000001e-16
C1863 FILL_L10_3 FILL_L30_9 1.4109400000000003e-18
C1864 FILL_L10_3 FILL_L50_11 1.8483100000000001e-18
C1865 FILL_L10_3 FILL_L50_4 2.0753100000000001e-17
C1866 FILL_L10_3 FILL_L50_8 2.0753100000000001e-17
C1867 FILL_L10_3 FILL_L8_3 8.2350600000000007e-16
C1868 FILL_L10_3 FILL_L8_4 3.0100800000000002e-17
C1869 FILL_L10_3 0 2.2469800000000005e-16
C1870 FILL_L10_4 FILL_L10_5 2.7935199999999999e-17
C1871 FILL_L10_4 FILL_L10_6 2.7935199999999999e-17
C1872 FILL_L10_4 FILL_L30_10 6.8152600000000008e-17
C1873 FILL_L10_4 FILL_L30_11 3.4774700000000002e-18
C1874 FILL_L10_4 FILL_L50_11 2.4879000000000005e-17
C1875 FILL_L10_4 FILL_L50_12 3.8713500000000006e-18
C1876 FILL_L10_4 FILL_L8_6 3.3807600000000004e-18
C1877 FILL_L10_4 0 6.803860000000001e-17
C1878 FILL_L10_5 FILL_L10_6 2.7935199999999999e-17
C1879 FILL_L10_5 FILL_L10_7 2.7935199999999999e-17
C1880 FILL_L10_5 FILL_L30_10 1.73e-18
C1881 FILL_L10_5 FILL_L30_14 5.1198500000000004e-17
C1882 FILL_L10_5 FILL_L30_19 1.3805000000000001e-18
C1883 FILL_L10_5 FILL_L50_11 1.9259500000000001e-18
C1884 FILL_L10_5 FILL_L50_16 1.5368700000000001e-18
C1885 FILL_L10_5 FILL_L50_19 1.6140000000000002e-17
C1886 FILL_L10_5 FILL_L8_6 2.9906900000000001e-18
C1887 FILL_L10_5 0 6.3361600000000003e-17
C1888 FILL_L10_6 FILL_L10_9 9.7773300000000019e-17
C1889 FILL_L10_6 FILL_L30_11 4.8960399999999998e-16
C1890 FILL_L10_6 FILL_L30_12 2.1332000000000003e-18
C1891 FILL_L10_6 FILL_L30_19 3.6457100000000004e-16
C1892 FILL_L10_6 FILL_L30_20 1.0666000000000002e-18
C1893 FILL_L10_6 FILL_L50_12 2.0753100000000001e-17
C1894 FILL_L10_6 FILL_L50_16 2.0753100000000001e-17
C1895 FILL_L10_6 FILL_L8_6 8.2350600000000007e-16
C1896 FILL_L10_6 FILL_L8_7 3.0100800000000002e-17
C1897 FILL_L10_6 0 2.0577600000000002e-16
C1898 FILL_L10_7 FILL_L10_8 2.7935199999999999e-17
C1899 FILL_L10_7 FILL_L10_9 2.7935199999999999e-17
C1900 FILL_L10_7 FILL_L30_14 6.9395899999999999e-18
C1901 FILL_L10_7 FILL_L30_18 2.7232700000000005e-17
C1902 FILL_L10_7 FILL_L30_19 5.7359700000000001e-18
C1903 FILL_L10_7 FILL_L50_19 3.3437100000000005e-17
C1904 FILL_L10_7 FILL_L8_9 8.9518900000000004e-19
C1905 FILL_L10_7 0 4.0926500000000002e-17
C1906 FILL_L10_8 FILL_L10_9 2.7935199999999999e-17
C1907 FILL_L10_8 FILL_L30_18 1.5013700000000002e-17
C1908 FILL_L10_8 FILL_L30_22 1.5013700000000002e-17
C1909 FILL_L10_8 FILL_L50_19 5.2194600000000001e-18
C1910 FILL_L10_8 FILL_L50_27 5.2194600000000001e-18
C1911 FILL_L10_8 FILL_L8_9 2.4162800000000001e-18
C1912 FILL_L10_8 0 5.3683000000000006e-17
C1913 FILL_L10_9 FILL_L30_17 3.4032400000000006e-19
C1914 FILL_L10_9 FILL_L30_18 2.7090100000000005e-18
C1915 FILL_L10_9 FILL_L30_19 7.2743800000000001e-16
C1916 FILL_L10_9 FILL_L30_20 4.2664099999999996e-18
C1917 FILL_L10_9 FILL_L30_23 1.1839000000000001e-16
C1918 FILL_L10_9 FILL_L50_19 2.9720700000000002e-18
C1919 FILL_L10_9 FILL_L50_20 1.6862300000000003e-17
C1920 FILL_L10_9 FILL_L50_24 1.4435200000000002e-17
C1921 FILL_L10_9 FILL_L8_10 3.0100800000000002e-17
C1922 FILL_L10_9 FILL_L8_9 8.2350600000000007e-16
C1923 FILL_L10_9 0 2.0907100000000001e-16
C1924 FILL_L30_0 FILL_L30_1 1.92731e-17
C1925 FILL_L30_0 FILL_L50_10 1.1257299999999999e-18
C1926 FILL_L30_0 FILL_L50_2 5.7327100000000004e-17
C1927 FILL_L30_0 0 3.9485000000000002e-17
C1928 FILL_L30_1 FILL_L30_2 1.92731e-17
C1929 FILL_L30_1 FILL_L30_7 1.92731e-17
C1930 FILL_L30_1 FILL_L50_2 1.30322e-16
C1931 FILL_L30_1 0 2.6030500000000003e-17
C1932 FILL_L30_10 FILL_L30_11 1.92731e-17
C1933 FILL_L30_10 FILL_L30_14 1.92731e-17
C1934 FILL_L30_10 FILL_L30_9 1.92731e-17
C1935 FILL_L30_10 FILL_L50_10 1.3473900000000001e-18
C1936 FILL_L30_10 FILL_L50_11 1.3606299999999999e-16
C1937 FILL_L30_10 FILL_L8_6 5.1734999999999999e-19
C1938 FILL_L30_10 0 4.3340900000000003e-17
C1939 FILL_L30_11 FILL_L30_12 7.7092600000000011e-17
C1940 FILL_L30_11 FILL_L30_19 7.7092600000000011e-17
C1941 FILL_L30_11 FILL_L30_4 7.7092600000000011e-17
C1942 FILL_L30_11 FILL_L30_9 1.92731e-17
C1943 FILL_L30_11 FILL_L50_11 2.7702200000000003e-17
C1944 FILL_L30_11 FILL_L50_12 1.51697e-16
C1945 FILL_L30_11 FILL_L50_8 1.51697e-16
C1946 FILL_L30_11 FILL_L8_3 3.2704500000000003e-17
C1947 FILL_L30_11 FILL_L8_4 1.6757899999999999e-17
C1948 FILL_L30_11 FILL_L8_6 3.11962e-17
C1949 FILL_L30_11 FILL_L8_7 1.1171900000000001e-17
C1950 FILL_L30_11 0 1.9873500000000004e-16
C1951 FILL_L30_12 FILL_L30_13 7.7092600000000011e-17
C1952 FILL_L30_12 FILL_L30_20 7.7092600000000011e-17
C1953 FILL_L30_12 FILL_L30_5 7.7092600000000011e-17
C1954 FILL_L30_12 FILL_L8_4 1.77384e-16
C1955 FILL_L30_12 FILL_L8_5 3.6390300000000006e-17
C1956 FILL_L30_12 FILL_L8_7 1.40634e-16
C1957 FILL_L30_12 FILL_L8_8 2.4260200000000003e-17
C1958 FILL_L30_12 0 2.0103700000000003e-16
C1959 FILL_L30_13 FILL_L30_21 7.7092600000000011e-17
C1960 FILL_L30_13 FILL_L30_6 7.7092600000000011e-17
C1961 FILL_L30_13 FILL_L8_5 1.1594700000000001e-16
C1962 FILL_L30_13 FILL_L8_8 8.8973700000000006e-17
C1963 FILL_L30_13 N 1.7852300000000002e-16
C1964 FILL_L30_13 P 1.6347000000000002e-16
C1965 FILL_L30_13 0 3.1573900000000001e-16
C1966 FILL_L30_14 FILL_L30_18 1.92731e-17
C1967 FILL_L30_14 FILL_L30_19 1.92731e-17
C1968 FILL_L30_14 FILL_L50_18 5.7319900000000007e-19
C1969 FILL_L30_14 FILL_L50_19 1.3606299999999999e-16
C1970 FILL_L30_14 0 3.8266300000000004e-17
C1971 FILL_L30_15 FILL_L30_16 1.92731e-17
C1972 FILL_L30_15 FILL_L50_18 5.5958799999999995e-17
C1973 FILL_L30_15 FILL_L50_26 8.0831700000000005e-19
C1974 FILL_L30_15 0 4.2105000000000002e-17
C1975 FILL_L30_16 FILL_L30_17 1.92731e-17
C1976 FILL_L30_16 FILL_L50_18 1.1613900000000001e-16
C1977 FILL_L30_16 FILL_L50_26 2.7425000000000002e-18
C1978 FILL_L30_16 0 3.2771700000000003e-17
C1979 FILL_L30_17 FILL_L30_18 1.92731e-17
C1980 FILL_L30_17 FILL_L50_19 1.1613900000000001e-16
C1981 FILL_L30_17 FILL_L50_27 2.8868500000000002e-18
C1982 FILL_L30_17 0 3.3176400000000005e-17
C1983 FILL_L30_18 FILL_L30_19 1.92731e-17
C1984 FILL_L30_18 FILL_L30_22 1.92731e-17
C1985 FILL_L30_18 FILL_L50_19 1.3300400000000001e-16
C1986 FILL_L30_18 0 3.1073300000000002e-17
C1987 FILL_L30_19 FILL_L30_20 7.7092600000000011e-17
C1988 FILL_L30_19 FILL_L30_23 7.7092600000000011e-17
C1989 FILL_L30_19 FILL_L50_16 1.51697e-16
C1990 FILL_L30_19 FILL_L50_19 2.7474400000000002e-17
C1991 FILL_L30_19 FILL_L50_20 1.51697e-16
C1992 FILL_L30_19 FILL_L8_10 2.22518e-17
C1993 FILL_L30_19 FILL_L8_6 2.9687900000000004e-17
C1994 FILL_L30_19 FILL_L8_7 5.5859600000000004e-18
C1995 FILL_L30_19 FILL_L8_9 3.4212900000000001e-17
C1996 FILL_L30_19 0 2.0615900000000001e-16
C1997 FILL_L30_2 FILL_L30_3 1.92731e-17
C1998 FILL_L30_2 FILL_L30_8 1.92731e-17
C1999 FILL_L30_2 FILL_L50_3 1.30322e-16
C2000 FILL_L30_2 0 3.1359800000000005e-17
C2001 FILL_L30_20 FILL_L30_21 7.7092600000000011e-17
C2002 FILL_L30_20 FILL_L30_24 7.7092600000000011e-17
C2003 FILL_L30_20 FILL_L8_10 2.0501800000000002e-16
C2004 FILL_L30_20 FILL_L8_11 4.8520400000000006e-17
C2005 FILL_L30_20 FILL_L8_7 1.0388500000000001e-16
C2006 FILL_L30_20 FILL_L8_8 1.2130100000000001e-17
C2007 FILL_L30_20 0 2.0777800000000001e-16
C2008 FILL_L30_21 FILL_L30_25 7.7092600000000011e-17
C2009 FILL_L30_21 FILL_L8_11 1.38165e-16
C2010 FILL_L30_21 FILL_L8_8 6.2000500000000005e-17
C2011 FILL_L30_21 N 1.7852300000000002e-16
C2012 FILL_L30_21 P 1.6347000000000002e-16
C2013 FILL_L30_21 0 3.1910800000000004e-16
C2014 FILL_L30_22 FILL_L30_23 1.92731e-17
C2015 FILL_L30_22 FILL_L50_26 1.17617e-18
C2016 FILL_L30_22 FILL_L50_27 1.2461700000000001e-16
C2017 FILL_L30_22 0 5.5641300000000003e-17
C2018 FILL_L30_23 FILL_L30_24 3.4884400000000002e-17
C2019 FILL_L30_23 FILL_L50_24 1.3873500000000002e-16
C2020 FILL_L30_23 FILL_L50_27 1.0814900000000001e-17
C2021 FILL_L30_23 FILL_L8_12 2.25702e-17
C2022 FILL_L30_23 FILL_L8_13 9.0492500000000014e-18
C2023 FILL_L30_23 FILL_L8_9 1.7621300000000003e-17
C2024 FILL_L30_23 0 2.3723900000000002e-16
C2025 FILL_L30_24 FILL_L30_25 3.4884400000000002e-17
C2026 FILL_L30_24 FILL_L8_10 4.5396500000000003e-17
C2027 FILL_L30_24 FILL_L8_13 7.2760199999999999e-17
C2028 FILL_L30_24 FILL_L8_14 1.96508e-17
C2029 FILL_L30_24 0 2.40264e-16
C2030 FILL_L30_25 FILL_L8_11 2.36851e-17
C2031 FILL_L30_25 FILL_L8_14 5.0597200000000004e-17
C2032 FILL_L30_25 N 8.1406500000000002e-17
C2033 FILL_L30_25 P 7.4595000000000007e-17
C2034 FILL_L30_25 0 2.8270800000000003e-16
C2035 FILL_L30_3 FILL_L30_4 1.92731e-17
C2036 FILL_L30_3 FILL_L30_9 1.92731e-17
C2037 FILL_L30_3 FILL_L50_3 1.3293500000000001e-16
C2038 FILL_L30_3 0 4.6538800000000007e-17
C2039 FILL_L30_4 FILL_L30_5 7.7092600000000011e-17
C2040 FILL_L30_4 FILL_L50_0 1.51697e-16
C2041 FILL_L30_4 FILL_L50_3 3.2584200000000006e-17
C2042 FILL_L30_4 FILL_L50_4 1.51697e-16
C2043 FILL_L30_4 FILL_L8_0 3.5721200000000004e-17
C2044 FILL_L30_4 FILL_L8_1 2.7929800000000004e-17
C2045 FILL_L30_4 FILL_L8_3 2.8179600000000001e-17
C2046 FILL_L30_4 0 3.2803600000000003e-16
C2047 FILL_L30_5 FILL_L30_6 7.7092600000000011e-17
C2048 FILL_L30_5 FILL_L8_1 2.07974e-16
C2049 FILL_L30_5 FILL_L8_2 6.0650500000000006e-17
C2050 FILL_L30_5 FILL_L8_4 6.7135599999999996e-17
C2051 FILL_L30_5 0 3.0389100000000006e-16
C2052 FILL_L30_6 FILL_L8_2 1.4750600000000001e-16
C2053 FILL_L30_6 FILL_L8_5 3.5027200000000004e-17
C2054 FILL_L30_6 N 1.7329900000000001e-16
C2055 FILL_L30_6 P 1.5824600000000001e-16
C2056 FILL_L30_6 0 4.0882600000000006e-16
C2057 FILL_L30_7 FILL_L30_8 1.92731e-17
C2058 FILL_L30_7 FILL_L50_10 1.37166e-16
C2059 FILL_L30_7 0 4.5787100000000005e-17
C2060 FILL_L30_8 FILL_L30_9 1.92731e-17
C2061 FILL_L30_8 FILL_L50_11 1.3606299999999999e-16
C2062 FILL_L30_8 0 3.4281700000000001e-17
C2063 FILL_L30_9 FILL_L50_11 1.3300400000000001e-16
C2064 FILL_L30_9 FILL_L8_3 8.9723800000000006e-19
C2065 FILL_L30_9 0 3.2465400000000003e-17
C2066 FILL_L50_0 FILL_L50_3 2.4713600000000001e-17
C2067 FILL_L50_0 FILL_L50_4 2.4713600000000001e-17
C2068 FILL_L50_0 0 3.8406900000000002e-17
C2069 FILL_L50_1 FILL_L50_5 2.4713600000000001e-17
C2070 FILL_L50_1 FILL_L50_6 2.4713600000000001e-17
C2071 FILL_L50_1 0 6.1024600000000001e-17
C2072 FILL_L50_10 FILL_L50_11 9.8854299999999996e-17
C2073 FILL_L50_10 FILL_L50_18 8.1060500000000013e-17
C2074 FILL_L50_10 FILL_L50_2 8.1060500000000013e-17
C2075 FILL_L50_10 0 2.0886800000000002e-16
C2076 FILL_L50_11 FILL_L50_12 2.4713600000000001e-17
C2077 FILL_L50_11 FILL_L50_19 9.8854299999999996e-17
C2078 FILL_L50_11 FILL_L50_3 9.8854299999999996e-17
C2079 FILL_L50_11 FILL_L50_8 2.4713600000000001e-17
C2080 FILL_L50_11 FILL_L8_6 1.4039700000000001e-19
C2081 FILL_L50_11 0 1.54463e-16
C2082 FILL_L50_12 FILL_L50_16 2.4713600000000001e-17
C2083 FILL_L50_12 FILL_L50_8 2.4713600000000001e-17
C2084 FILL_L50_12 0 7.8963300000000009e-18
C2085 FILL_L50_13 FILL_L50_14 2.4713600000000001e-17
C2086 FILL_L50_13 FILL_L50_17 2.4713600000000001e-17
C2087 FILL_L50_13 FILL_L50_9 2.4713600000000001e-17
C2088 FILL_L50_13 0 4.2598900000000005e-17
C2089 FILL_L50_14 FILL_L50_15 9.8854299999999996e-17
C2090 FILL_L50_14 FILL_L50_22 9.8854299999999996e-17
C2091 FILL_L50_14 FILL_L50_6 9.8854299999999996e-17
C2092 FILL_L50_14 FILL_L50_9 2.4713600000000001e-17
C2093 FILL_L50_14 0 2.8790199999999999e-16
C2094 FILL_L50_15 FILL_L50_23 1.7793800000000002e-17
C2095 FILL_L50_15 FILL_L50_7 1.7793800000000002e-17
C2096 FILL_L50_15 0 1.8802099999999999e-16
C2097 FILL_L50_16 FILL_L50_19 2.4713600000000001e-17
C2098 FILL_L50_16 FILL_L50_20 2.4713600000000001e-17
C2099 FILL_L50_16 0 9.0644399999999998e-18
C2100 FILL_L50_17 FILL_L50_21 2.4713600000000001e-17
C2101 FILL_L50_17 FILL_L50_22 2.4713600000000001e-17
C2102 FILL_L50_17 0 4.1395000000000005e-17
C2103 FILL_L50_18 FILL_L50_19 9.8854299999999996e-17
C2104 FILL_L50_18 FILL_L50_26 8.1060500000000013e-17
C2105 FILL_L50_18 0 2.1885700000000002e-16
C2106 FILL_L50_19 FILL_L50_20 2.4713600000000001e-17
C2107 FILL_L50_19 FILL_L50_27 9.8854299999999996e-17
C2108 FILL_L50_19 0 1.54588e-16
C2109 FILL_L50_2 FILL_L50_3 9.8854299999999996e-17
C2110 FILL_L50_2 0 2.89051e-16
C2111 FILL_L50_20 FILL_L50_24 2.4713600000000001e-17
C2112 FILL_L50_20 0 1.1653100000000002e-17
C2113 FILL_L50_21 FILL_L50_22 2.4713600000000001e-17
C2114 FILL_L50_21 FILL_L50_25 2.4713600000000001e-17
C2115 FILL_L50_21 0 4.8505600000000002e-17
C2116 FILL_L50_22 FILL_L50_23 9.8854299999999996e-17
C2117 FILL_L50_22 FILL_L50_28 9.8854299999999996e-17
C2118 FILL_L50_22 0 2.8387000000000002e-16
C2119 FILL_L50_23 FILL_L50_29 1.7793800000000002e-17
C2120 FILL_L50_23 0 1.8723400000000003e-16
C2121 FILL_L50_24 FILL_L50_27 2.4713600000000001e-17
C2122 FILL_L50_24 0 3.5478100000000002e-17
C2123 FILL_L50_25 FILL_L50_28 2.4713600000000001e-17
C2124 FILL_L50_25 0 6.6112400000000003e-17
C2125 FILL_L50_26 FILL_L50_27 4.4731600000000003e-17
C2126 FILL_L50_26 0 1.9044600000000002e-16
C2127 FILL_L50_27 0 1.8226400000000002e-16
C2128 FILL_L50_28 FILL_L50_29 4.4731600000000003e-17
C2129 FILL_L50_28 0 2.3907200000000004e-16
C2130 FILL_L50_29 0 1.0474400000000001e-16
C2131 FILL_L50_3 FILL_L50_4 2.4713600000000001e-17
C2132 FILL_L50_3 FILL_L8_0 3.9398800000000006e-18
C2133 FILL_L50_3 0 2.6364900000000004e-16
C2134 FILL_L50_4 FILL_L50_8 2.4713600000000001e-17
C2135 FILL_L50_4 0 9.2229300000000012e-18
C2136 FILL_L50_5 FILL_L50_6 2.4713600000000001e-17
C2137 FILL_L50_5 FILL_L50_9 2.4713600000000001e-17
C2138 FILL_L50_5 0 4.13991e-17
C2139 FILL_L50_6 FILL_L50_7 9.8854299999999996e-17
C2140 FILL_L50_6 0 3.5390499999999998e-16
C2141 FILL_L50_7 0 1.9831100000000003e-16
C2142 FILL_L50_8 0 8.5064499999999999e-18
C2143 FILL_L50_9 0 4.9346600000000005e-17
C2144 FILL_L8_0 FILL_L8_1 5.3567000000000005e-17
C2145 FILL_L8_0 FILL_L8_3 6.96968e-17
C2146 FILL_L8_0 0 6.9655200000000008e-16
C2147 FILL_L8_1 FILL_L8_2 5.3567000000000005e-17
C2148 FILL_L8_1 FILL_L8_4 6.96968e-17
C2149 FILL_L8_1 0 6.7244100000000005e-16
C2150 FILL_L8_10 FILL_L8_11 6.96968e-17
C2151 FILL_L8_10 FILL_L8_13 6.96968e-17
C2152 FILL_L8_10 FILL_L8_7 6.96968e-17
C2153 FILL_L8_10 FILL_L8_9 6.96968e-17
C2154 FILL_L8_10 0 7.5091400000000008e-16
C2155 FILL_L8_11 FILL_L8_14 6.96968e-17
C2156 FILL_L8_11 FILL_L8_8 6.96968e-17
C2157 FILL_L8_11 N 1.3975199999999999e-17
C2158 FILL_L8_11 P 1.1034900000000001e-17
C2159 FILL_L8_11 0 7.9409500000000004e-16
C2160 FILL_L8_12 FILL_L8_13 1.6129800000000002e-17
C2161 FILL_L8_12 FILL_L8_9 6.96968e-17
C2162 FILL_L8_12 0 3.6081200000000002e-16
C2163 FILL_L8_13 FILL_L8_14 1.6129800000000002e-17
C2164 FILL_L8_13 0 3.5556799999999999e-16
C2165 FILL_L8_14 N 1.71904e-18
C2166 FILL_L8_14 P 2.6815299999999997e-19
C2167 FILL_L8_14 0 3.6556099999999999e-16
C2168 FILL_L8_2 FILL_L8_5 6.96968e-17
C2169 FILL_L8_2 N 6.5382300000000011e-18
C2170 FILL_L8_2 P 1.35987e-18
C2171 FILL_L8_2 0 7.0562900000000007e-16
C2172 FILL_L8_3 FILL_L8_4 6.96968e-17
C2173 FILL_L8_3 FILL_L8_6 6.96968e-17
C2174 FILL_L8_3 0 7.6919300000000003e-16
C2175 FILL_L8_4 FILL_L8_5 6.96968e-17
C2176 FILL_L8_4 FILL_L8_7 6.96968e-17
C2177 FILL_L8_4 0 7.5091400000000008e-16
C2178 FILL_L8_5 FILL_L8_8 6.96968e-17
C2179 FILL_L8_5 N 1.6157600000000001e-17
C2180 FILL_L8_5 P 1.4314400000000001e-17
C2181 FILL_L8_5 0 7.9409500000000004e-16
C2182 FILL_L8_6 FILL_L8_7 6.96968e-17
C2183 FILL_L8_6 FILL_L8_9 6.96968e-17
C2184 FILL_L8_6 0 7.7175699999999999e-16
C2185 FILL_L8_7 FILL_L8_8 6.96968e-17
C2186 FILL_L8_7 0 7.5091400000000008e-16
C2187 FILL_L8_8 N 1.6157600000000001e-17
C2188 FILL_L8_8 P 1.4314400000000001e-17
C2189 FILL_L8_8 0 7.9409500000000004e-16
C2190 FILL_L8_9 0 7.619450000000001e-16
C2191 N P 3.4877500000000003e-15
C2192 N 0 2.2133700000000001e-17
C2193 P 0 1.4043000000000001e-17
VP P 0 DC 0 AC 1
VN N 0 DC 0 AC 0
.control
set numdgt=17
ac lin 1 1Meg 1Meg
let cp = -imag(i(VP))/(2*pi*1e6)
let cn = -imag(i(VN))/(2*pi*1e6)
print cp cn
quit
.endc
.end
