* cell sense_fill_clip
.SUBCKT sense_fill_clip
* net 2 CTX_L8_75
* net 3 CTX_L10_1,CTX_L30_1,CTX_L8_84
* net 4 CTX_L8_78
* net 5 CTX_L8_82
* net 6 CTX_L10_0,CTX_L30_0
* net 7 CTX_L8_76
* net 8 CTX_L8_79
* net 9 CTX_L8_83
* net 10 CTX_L8_77
* net 11 FILL_L50_0
* net 12 FILL_L10_0
* net 13 FILL_L8_0
* net 14 FILL_L8_1
* net 15 FILL_L8_2
* net 16 CTX_L8_92
* net 17 FILL_L50_1
* net 18 CTX_L8_101
* net 19 CTX_L8_110
* net 20 CTX_L8_87
* net 21 FILL_L30_0
* net 22 CTX_L10_2,CTX_L10_3,CTX_L30_2,CTX_L8_71,CTX_L8_80
* net 23 FILL_L67_0
* net 24 FILL_L50_2
* net 25 CTX_L10_8,CTX_L8_30,CTX_L8_56,CTX_L8_63
* net 26 CTX_L8_85
* net 27 CTX_L8_65
* net 28 FILL_L30_1
* net 29 FILL_L30_2
* net 30 FILL_L67_1
* net 31 FILL_L50_3
* net 32 FILL_L30_3
* net 33 FILL_L50_4
* net 34 FILL_L30_4
* net 35 FILL_L67_2
* net 36 FILL_L30_5
* net 37 FILL_L67_3
* net 38 FILL_L30_6
* net 39 FILL_L67_4
* net 40 FILL_L67_5
* net 41 CTX_L8_97
* net 42 FILL_L67_6
* net 43 FILL_L50_5
* net 44 CTX_L8_98
* net 45 FILL_L50_6
* net 46 FILL_L67_7
* net 47 CTX_L8_99
* net 48 FILL_L50_7
* net 49 FILL_L67_8
* net 50 CTX_L8_100
* net 51 CTX_L8_69
* net 52 CTX_L8_72
* net 53 CTX_L8_62
* net 54 CTX_L8_68
* net 55 CTX_L8_64
* net 56 CTX_L8_86
* net 57 CTX_L8_66
* net 58 CTX_L8_67
* net 59 CTX_L8_70
* net 60 FILL_L10_3
* net 61 FILL_L8_3
* net 62 FILL_L8_4
* net 63 FILL_L8_5
* net 64 CTX_L8_102
* net 65 CTX_L8_106
* net 66 CTX_L8_103
* net 67 CTX_L8_107
* net 68 CTX_L8_108
* net 69 CTX_L8_104
* net 70 CTX_L8_105
* net 71 CTX_L8_109
* net 72 CTX_L10_4,CTX_L10_5,CTX_L30_3,CTX_L8_0,CTX_L8_81
* net 73 CTX_L8_74
* net 74 FILL_L67_9
* net 75 FILL_L50_10
* net 76 FILL_L30_7
* net 77 CTX_L8_73
* net 78 FILL_L30_8
* net 79 FILL_L10_1
* net 80 FILL_L67_10
* net 81 FILL_L50_11
* net 82 FILL_L30_9
* net 83 FILL_L10_2
* net 84 FILL_L50_8
* net 85 FILL_L30_11
* net 86 FILL_L67_11
* net 87 FILL_L67_12
* net 88 FILL_L30_12
* net 89 FILL_L67_13
* net 90 FILL_L30_13
* net 91 FILL_L67_14
* net 92 CTX_L8_93
* net 93 CTX_L8_88
* net 94 FILL_L67_15
* net 95 FILL_L50_9
* net 96 CTX_L8_94
* net 97 CTX_L8_89
* net 98 FILL_L50_14
* net 99 FILL_L67_16
* net 100 CTX_L8_95
* net 101 CTX_L8_90
* net 102 FILL_L50_15
* net 103 FILL_L67_17
* net 104 CTX_L8_96
* net 105 CTX_L8_91
* net 106 CTX_L8_1
* net 107 CTX_L8_58
* net 108 CTX_L8_60
* net 109 CTX_L8_57
* net 110 CTX_L10_11
* net 111 CTX_L10_6,CTX_L30_4,CTX_L8_41
* net 112 CTX_L8_28
* net 113 CTX_L10_12
* net 114 FILL_L30_10
* net 115 FILL_L10_4
* net 116 CTX_L126_0
* net 117 FILL_L50_12
* net 118 FILL_L8_6
* net 119 FILL_L10_6
* net 120 CTX_L50_0
* net 121 CTX_L50_1
* net 122 CTX_L50_2
* net 123 CTX_L50_3
* net 124 CTX_L50_4
* net 125 CTX_L50_5
* net 126 FILL_L8_7
* net 127 CTX_L10_13
* net 128 CTX_L50_6
* net 129 CTX_L50_7
* net 130 CTX_L126_1
* net 131 CTX_L50_8
* net 132 CTX_L50_9
* net 133 CTX_L10_14
* net 134 CTX_L50_10
* net 135 CTX_L50_11
* net 136 CTX_L10_15
* net 137 FILL_L8_8
* net 138 CTX_L10_16
* net 139 N
* net 140 CTX_L10_17
* net 141 P
* net 142 CTX_L50_14
* net 143 CTX_L50_15
* net 144 CTX_L50_16
* net 145 CTX_L10_18
* net 146 CTX_L50_17
* net 147 CTX_L50_18
* net 148 CTX_L10_19
* net 149 CTX_L126_2
* net 150 CTX_L50_19
* net 151 CTX_L50_20
* net 152 CTX_L8_2
* net 153 CTX_L50_21
* net 154 CTX_L8_3
* net 155 CTX_L50_22
* net 156 CTX_L8_5
* net 157 FILL_L50_13
* net 158 CTX_L8_22
* net 159 CTX_L8_23
* net 160 CTX_L126_3
* net 161 CTX_L8_4
* net 162 CTX_L8_43
* net 163 CTX_L8_29
* net 164 CTX_L8_42
* net 165 CTX_L8_61
* net 166 CTX_L8_40
* net 167 FILL_L30_14
* net 168 FILL_L10_5
* net 169 FILL_L50_16
* net 170 CTX_L8_6
* net 171 FILL_L50_17
* net 172 CTX_L8_7
* net 173 CTX_L8_8
* net 174 CTX_L8_9
* net 175 FILL_L30_15
* net 176 CTX_L8_33
* net 177 FILL_L50_18
* net 178 FILL_L67_18
* net 179 CTX_L8_59
* net 180 FILL_L30_16
* net 181 CTX_L10_7,CTX_L30_5,CTX_L8_38
* net 182 CTX_L8_31
* net 183 FILL_L30_17
* net 184 CTX_L8_37
* net 185 FILL_L50_19
* net 186 FILL_L67_19
* net 187 FILL_L30_18
* net 188 FILL_L10_7
* net 189 FILL_L50_20
* net 190 FILL_L8_9
* net 191 FILL_L10_9
* net 192 FILL_L67_20
* net 193 FILL_L30_19
* net 194 FILL_L8_10
* net 195 FILL_L67_21
* net 196 FILL_L30_20
* net 197 FILL_L8_11
* net 198 FILL_L67_22
* net 199 FILL_L30_21
* net 200 FILL_L67_23
* net 201 CTX_L8_10
* net 202 FILL_L67_24
* net 203 FILL_L50_21
* net 204 CTX_L8_11
* net 205 FILL_L67_25
* net 206 FILL_L50_22
* net 207 CTX_L8_12
* net 208 FILL_L50_23
* net 209 FILL_L67_26
* net 210 CTX_L8_13
* net 211 CTX_L8_34
* net 212 CTX_L8_48
* net 213 CTX_L8_39
* net 214 CTX_L8_36
* net 215 CTX_L8_32
* net 216 CTX_L8_54
* net 217 CTX_L8_35
* net 218 FILL_L30_22
* net 219 FILL_L10_8
* net 220 FILL_L50_24
* net 221 CTX_L8_18
* net 222 CTX_L8_14
* net 223 FILL_L50_25
* net 224 CTX_L8_15
* net 225 CTX_L8_19
* net 226 CTX_L8_20
* net 227 CTX_L8_16
* net 228 CTX_L8_21
* net 229 CTX_L8_17
* net 230 CTX_L8_45
* net 231 CTX_L8_46
* net 232 CTX_L10_10,CTX_L8_47
* net 233 FILL_L50_26
* net 234 FILL_L67_27
* net 235 CTX_L8_44
* net 236 CTX_L8_49
* net 237 CTX_L10_9,CTX_L30_6,CTX_L8_53
* net 238 CTX_L8_50
* net 239 CTX_L8_51
* net 240 CTX_L8_52
* net 241 FILL_L67_28
* net 242 FILL_L50_27
* net 243 CTX_L8_55
* net 244 FILL_L10_10
* net 245 FILL_L10_11
* net 246 FILL_L8_12
* net 247 FILL_L67_29
* net 248 FILL_L30_23
* net 249 FILL_L8_13
* net 250 FILL_L30_24
* net 251 FILL_L67_30
* net 252 FILL_L8_14
* net 253 FILL_L67_31
* net 254 FILL_L30_25
* net 255 FILL_L67_32
* net 256 CTX_L8_24
* net 257 FILL_L67_33
* net 258 CTX_L8_25
* net 259 FILL_L50_28
* net 260 FILL_L67_34
* net 261 CTX_L8_26
* net 262 FILL_L50_29
* net 263 FILL_L67_35
* net 264 CTX_L8_27
.ENDS sense_fill_clip
