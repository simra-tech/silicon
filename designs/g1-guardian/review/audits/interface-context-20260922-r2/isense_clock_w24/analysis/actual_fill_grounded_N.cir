* actual_fill grounded drive N; diagnostic capacitor-network AC only
C35 0 N 1.35527e-17
C101 0 N 7.9891700000000005e-17
C102 0 P 6.320020000000001e-17
C148 0 N 1.3416e-19
C149 0 P 2.5752199999999997e-19
C213 0 N 1.78462e-17
C214 0 P 2.1419300000000001e-17
C252 0 N 2.7304400000000004e-17
C253 0 P 8.55166e-18
C315 0 N 2.3292500000000001e-17
C316 0 P 1.5571700000000002e-17
C472 0 N 2.0170400000000002e-16
C473 0 P 1.0501600000000001e-16
C595 0 P 3.4877500000000003e-15
C651 0 N 9.7090599999999997e-18
C652 0 P 4.9963800000000002e-17
C659 0 N 2.7399200000000002e-18
C660 0 P 2.4729300000000002e-19
C674 0 N 1.2552200000000001e-18
C675 0 P 1.03039e-18
C690 0 N 5.6099900000000005e-18
C691 0 P 1.03039e-18
C703 0 N 9.369080000000001e-18
C704 0 P 5.1998600000000002e-19
C728 0 N 9.9647600000000006e-18
C729 0 P 1.03039e-18
C740 0 N 7.4735700000000008e-18
C741 0 P 7.727910000000001e-19
C750 0 N 6.0914400000000011e-18
C751 0 P 5.1998600000000002e-19
C757 0 N 2.4001900000000004e-19
C802 0 N 3.6895200000000005e-18
C803 0 P 4.1698500000000002e-18
C810 0 N 9.9396600000000006e-18
C811 0 P 1.00978e-18
C848 0 N 8.210940000000002e-18
C849 0 P 1.88009e-18
C861 0 N 2.0659600000000002e-19
C881 0 N 1.6070500000000002e-18
C882 0 P 2.8873199999999999e-18
C888 0 N 2.0235000000000002e-19
C889 0 P 2.5314100000000004e-19
C896 0 N 1.6070500000000002e-18
C897 0 P 2.8873199999999999e-18
C904 0 N 1.23957e-19
C921 0 N 1.6070500000000002e-18
C922 0 P 2.8873199999999999e-18
C927 0 N 9.8265900000000003e-17
C933 0 N 9.8265900000000003e-17
C946 0 N 2.8268299999999999e-17
C957 0 N 9.8265900000000003e-17
C964 0 N 9.8265900000000003e-17
C972 0 N 2.8268299999999999e-17
C978 0 N 9.8265900000000003e-17
C980 0 N 1.0176600000000002e-17
C993 0 N 3.8098600000000003e-18
C1011 0 N 5.5014100000000008e-19
C1012 0 P 1.0245300000000001e-19
C1027 0 N 5.5014100000000008e-19
C1031 0 N 4.4929300000000004e-19
C1040 0 N 5.5014100000000008e-19
C1041 0 P 1.0245300000000001e-19
C1053 0 N 4.1260599999999998e-19
C1059 0 N 4.4929300000000004e-19
C1091 N P 3.4877500000000003e-15
C1092 N 0 2.9529900000000002e-16
C1093 P 0 5.7176099999999999e-17
VP P 0 DC 0 AC 0
VN N 0 DC 0 AC 1
.control
set numdgt=17
ac lin 1 1Meg 1Meg
let cp = -imag(i(VP))/(2*pi*1e6)
let cn = -imag(i(VN))/(2*pi*1e6)
print cp cn
quit
.endc
.end
