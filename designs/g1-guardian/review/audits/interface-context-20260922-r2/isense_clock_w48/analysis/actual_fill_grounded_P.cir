* actual_fill grounded drive P; diagnostic capacitor-network AC only
C145 0 N 2.0170400000000002e-16
C146 0 P 1.0501600000000001e-16
C636 0 N 1.35527e-17
C791 0 N 1.3416e-19
C792 0 P 2.5752199999999997e-19
C883 0 N 7.9891700000000005e-17
C884 0 P 6.320020000000001e-17
C1127 0 N 1.78462e-17
C1128 0 P 2.1419300000000001e-17
C1224 0 N 2.7304400000000004e-17
C1225 0 P 8.55166e-18
C1349 0 N 2.3292500000000001e-17
C1350 0 P 1.5571700000000002e-17
C1603 0 P 3.4877500000000003e-15
C1977 0 N 9.7090599999999997e-18
C1978 0 P 4.9963800000000002e-17
C1990 0 N 2.7399200000000002e-18
C1991 0 P 2.4729300000000002e-19
C2033 0 N 1.2552200000000001e-18
C2034 0 P 1.03039e-18
C2049 0 N 5.6099900000000005e-18
C2050 0 P 1.03039e-18
C2062 0 N 9.369080000000001e-18
C2063 0 P 5.1998600000000002e-19
C2082 0 N 2.4001900000000004e-19
C2125 0 N 9.9647600000000006e-18
C2126 0 P 1.03039e-18
C2137 0 N 7.4735700000000008e-18
C2138 0 P 7.727910000000001e-19
C2147 0 N 6.0914400000000011e-18
C2148 0 P 5.1998600000000002e-19
C2246 0 N 3.6895200000000005e-18
C2247 0 P 4.1698500000000002e-18
C2254 0 N 9.9396600000000006e-18
C2255 0 P 1.00978e-18
C2293 0 N 8.210940000000002e-18
C2294 0 P 1.88009e-18
C2335 0 N 1.6070500000000002e-18
C2336 0 P 2.8873199999999999e-18
C2341 0 N 2.0659600000000002e-19
C2379 0 N 1.6070500000000002e-18
C2380 0 P 2.8873199999999999e-18
C2386 0 N 2.0235000000000002e-19
C2387 0 P 2.5314100000000004e-19
C2393 0 N 1.6070500000000002e-18
C2394 0 P 2.8873199999999999e-18
C2406 0 N 1.23957e-19
C2432 0 N 2.8268299999999999e-17
C2471 0 N 9.8265900000000003e-17
C2485 0 N 9.8265900000000003e-17
C2497 0 N 2.8268299999999999e-17
C2523 0 N 9.8265900000000003e-17
C2527 0 N 1.0176600000000002e-17
C2545 0 N 9.8265900000000003e-17
C2560 0 N 9.8265900000000003e-17
C2578 0 N 3.8098600000000003e-18
C2612 0 N 5.5014100000000008e-19
C2613 0 P 1.0245300000000001e-19
C2626 0 N 5.5014100000000008e-19
C2630 0 N 4.4929300000000004e-19
C2650 0 N 5.5014100000000008e-19
C2651 0 P 1.0245300000000001e-19
C2663 0 N 4.1260599999999998e-19
C2668 0 N 4.4929300000000004e-19
C2718 N P 3.4877500000000003e-15
C2719 N 0 2.9529900000000002e-16
C2720 P 0 5.7176099999999999e-17
VP P 0 DC 0 AC 1
VN N 0 DC 0 AC 0
.control
set numdgt=17
ac lin 1 1Meg 1Meg
let cp = -imag(i(VP))/(2*pi*1e6)
let cn = -imag(i(VN))/(2*pi*1e6)
print cp cn
quit
.endc
.end
