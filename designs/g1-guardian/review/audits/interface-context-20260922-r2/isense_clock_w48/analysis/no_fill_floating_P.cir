* no_fill floating drive P; diagnostic capacitor-network AC only
C34 0 N 2.4822100000000004e-16
C35 0 P 1.0517e-16
C403 0 N 1.5193400000000001e-17
C404 0 P 1.8661900000000002e-19
C476 0 N 6.0237900000000001e-19
C477 0 P 6.8418500000000009e-19
C490 0 N 8.6524400000000008e-17
C491 0 P 6.3260600000000007e-17
C645 0 N 1.7918500000000002e-17
C646 0 P 2.1505600000000004e-17
C676 0 N 3.1245100000000003e-17
C677 0 P 8.6723000000000012e-18
C724 0 N 4.0606000000000007e-17
C725 0 P 1.5622000000000002e-17
C811 0 P 3.4877500000000003e-15
C1004 0 N 9.7328200000000006e-18
C1005 0 P 5.0729799999999999e-17
C1009 N P 3.4877500000000003e-15
C1010 N 0 4.5861099999999999e-16
C1011 P 0 5.7605600000000004e-17
VP P 0 DC 0 AC 1
VN N 0 DC 0 AC 0
.control
set numdgt=17
ac lin 1 1Meg 1Meg
let cp = -imag(i(VP))/(2*pi*1e6)
let cn = -imag(i(VN))/(2*pi*1e6)
print cp cn
quit
.endc
.end
