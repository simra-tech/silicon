* actual_fill floating drive N; diagnostic capacitor-network AC only
C5 0 FILL_L30_0 2.4081400000000003e-16
C6 0 FILL_L30_2 2.4728e-16
C7 0 FILL_L30_4 2.4728e-16
C8 0 FILL_L30_6 1.12668e-16
C9 0 FILL_L8_0 1.7502500000000002e-16
C10 0 FILL_L8_1 3.3938400000000001e-18
C11 0 FILL_L8_2 2.3099100000000005e-16
C12 0 FILL_L8_3 4.4157700000000008e-18
C13 0 FILL_L8_4 2.3099100000000005e-16
C14 0 FILL_L8_5 4.4157700000000008e-18
C15 0 FILL_L8_6 2.3099100000000005e-16
C16 0 FILL_L8_7 4.4157700000000008e-18
C17 0 FILL_L8_8 5.5965800000000005e-17
C18 0 FILL_L8_9 1.02194e-18
C27 0 FILL_L30_0 1.01523e-16
C28 0 FILL_L30_1 7.6123800000000002e-18
C29 0 FILL_L30_2 1.01523e-16
C30 0 FILL_L30_3 7.6123800000000002e-18
C31 0 FILL_L30_4 1.01523e-16
C32 0 FILL_L30_5 7.6123800000000002e-18
C33 0 FILL_L30_6 4.5939100000000008e-17
C34 0 FILL_L30_7 3.4446000000000001e-18
C35 0 FILL_L8_0 1.1858800000000002e-17
C36 0 FILL_L8_1 1.6256500000000001e-16
C37 0 FILL_L8_2 1.54297e-17
C38 0 FILL_L8_3 2.14778e-16
C39 0 FILL_L8_4 1.54297e-17
C40 0 FILL_L8_5 2.14778e-16
C41 0 FILL_L8_6 1.54297e-17
C42 0 FILL_L8_7 2.14778e-16
C43 0 FILL_L8_8 3.5708700000000008e-18
C44 0 FILL_L8_9 5.2213800000000002e-17
C50 0 FILL_L30_0 6.9818800000000003e-18
C51 0 FILL_L30_1 2.5466800000000001e-17
C52 0 FILL_L30_2 6.9818800000000003e-18
C53 0 FILL_L30_3 2.5466800000000001e-17
C54 0 FILL_L30_4 6.9818800000000003e-18
C55 0 FILL_L30_5 2.5466800000000001e-17
C56 0 FILL_L30_6 3.1593000000000002e-18
C57 0 FILL_L30_7 1.1523700000000001e-17
C58 0 FILL_L8_1 1.45087e-16
C59 0 FILL_L8_3 1.9203800000000003e-16
C60 0 FILL_L8_5 1.9203800000000003e-16
C61 0 FILL_L8_7 1.9203800000000003e-16
C62 0 FILL_L8_9 4.6951100000000003e-17
C69 0 FILL_L30_0 2.2902200000000002e-18
C70 0 FILL_L30_1 8.5676700000000009e-17
C71 0 FILL_L30_2 2.2902200000000002e-18
C72 0 FILL_L30_3 8.8909700000000004e-17
C73 0 FILL_L30_4 2.2902200000000002e-18
C74 0 FILL_L30_5 8.8909700000000004e-17
C75 0 FILL_L30_6 1.0363199999999999e-18
C76 0 FILL_L30_7 4.0618400000000006e-17
C77 0 FILL_L8_1 1.0576300000000002e-16
C78 0 FILL_L8_3 1.4087300000000001e-16
C79 0 FILL_L8_5 1.4087300000000001e-16
C80 0 FILL_L8_7 1.4087300000000001e-16
C81 0 FILL_L8_9 3.5110000000000005e-17
C82 0 N 3.2510800000000007e-17
C89 0 FILL_L30_1 2.29409e-16
C90 0 FILL_L30_3 2.3587399999999999e-16
C91 0 FILL_L30_5 2.3587399999999999e-16
C92 0 FILL_L30_7 1.0750700000000002e-16
C93 0 FILL_L8_1 1.53629e-16
C94 0 FILL_L8_3 2.0315199999999999e-16
C95 0 FILL_L8_5 2.0315199999999999e-16
C96 0 FILL_L8_7 2.0315199999999999e-16
C97 0 FILL_L8_9 4.9523100000000004e-17
C98 0 N 2.8625000000000003e-17
C99 0 P 9.4825500000000004e-18
C109 0 FILL_L30_1 2.5616900000000001e-16
C110 0 FILL_L30_3 2.6263500000000003e-16
C111 0 FILL_L30_5 2.6263500000000003e-16
C112 0 FILL_L30_7 1.1961600000000001e-16
C113 0 FILL_L8_1 1.3742600000000001e-17
C114 0 FILL_L8_3 1.7880700000000001e-17
C115 0 FILL_L8_5 1.7880700000000001e-17
C116 0 FILL_L8_7 1.7880700000000001e-17
C117 0 FILL_L8_9 4.1381000000000003e-18
C118 0 P 4.5911500000000004e-18
C126 0 FILL_L30_1 8.1156400000000016e-17
C127 0 FILL_L30_3 8.1156400000000016e-17
C128 0 FILL_L30_5 8.1156400000000016e-17
C129 0 FILL_L30_7 3.6723300000000005e-17
C130 0 FILL_L8_1 9.2013800000000015e-19
C131 0 FILL_L8_3 1.2881900000000001e-18
C132 0 FILL_L8_5 1.2881900000000001e-18
C133 0 FILL_L8_7 1.2881900000000001e-18
C134 0 FILL_L8_9 2.98125e-19
C147 0 FILL_L30_0 1.3317800000000002e-16
C148 0 FILL_L30_1 6.91856e-17
C149 0 FILL_L30_2 1.3988000000000002e-16
C150 0 FILL_L30_3 6.91856e-17
C151 0 FILL_L30_4 1.3988000000000002e-16
C152 0 FILL_L30_5 6.91856e-17
C153 0 FILL_L30_6 6.4005099999999998e-17
C154 0 FILL_L30_7 3.1306499999999999e-17
C155 0 FILL_L8_0 1.92996e-18
C156 0 FILL_L8_1 2.2248100000000001e-17
C157 0 FILL_L8_2 2.0315400000000002e-17
C158 0 FILL_L8_3 4.0600400000000005e-17
C159 0 FILL_L8_4 2.0315400000000002e-17
C160 0 FILL_L8_5 4.0600400000000005e-17
C161 0 FILL_L8_6 1.5236600000000001e-17
C162 0 FILL_L8_7 3.73833e-17
C163 0 FILL_L8_9 6.7062400000000003e-18
C164 0 N 4.2665500000000008e-17
C165 0 P 3.5607700000000002e-17
C178 0 FILL_L30_1 1.1630700000000001e-16
C179 0 FILL_L30_3 1.1809600000000002e-16
C180 0 FILL_L30_5 1.1809600000000002e-16
C181 0 FILL_L30_7 5.3622700000000004e-17
C182 0 FILL_L8_1 1.3955500000000003e-17
C183 0 FILL_L8_3 2.7419600000000002e-17
C184 0 FILL_L8_5 2.7419600000000002e-17
C185 0 FILL_L8_7 2.4858200000000002e-17
C186 0 FILL_L8_9 3.9746199999999999e-18
C187 0 N 2.6993700000000001e-17
C188 0 P 3.2462000000000005e-17
C191 0 FILL_L30_0 2.83433e-16
C192 0 FILL_L30_2 2.8865699999999999e-16
C193 0 FILL_L30_4 2.8865699999999999e-16
C194 0 FILL_L30_6 1.31242e-16
C195 0 FILL_L8_0 2.5439800000000002e-18
C196 0 FILL_L8_2 2.6778700000000004e-17
C197 0 FILL_L8_4 2.6778700000000004e-17
C198 0 FILL_L8_6 2.0383200000000001e-17
C199 0 FILL_L8_8 2.6815299999999997e-19
C202 0 FILL_L30_0 3.0659400000000004e-16
C203 0 FILL_L30_2 3.1181700000000005e-16
C204 0 FILL_L30_4 3.1181700000000005e-16
C205 0 FILL_L30_6 1.4172200000000002e-16
C206 0 FILL_L8_0 1.1661500000000001e-18
C207 0 FILL_L8_2 1.2275200000000001e-17
C208 0 FILL_L8_3 1.0523700000000001e-18
C209 0 FILL_L8_4 1.2275200000000001e-17
C210 0 FILL_L8_5 1.0523700000000001e-18
C211 0 FILL_L8_6 9.2064100000000003e-18
C212 0 FILL_L8_7 7.8927700000000007e-19
C217 0 FILL_L30_1 2.4812600000000003e-16
C218 0 FILL_L30_3 2.5335000000000001e-16
C219 0 FILL_L30_5 2.5335000000000001e-16
C220 0 FILL_L30_7 1.15266e-16
C221 0 FILL_L8_1 1.0759000000000002e-19
C222 0 FILL_L8_3 1.1325300000000001e-18
C223 0 FILL_L8_5 1.1325300000000001e-18
C224 0 FILL_L8_7 8.4939500000000011e-19
C228 0 FILL_L30_1 2.1065000000000003e-16
C229 0 FILL_L30_3 2.1587400000000001e-16
C230 0 FILL_L30_5 2.1587400000000001e-16
C231 0 FILL_L30_7 9.8307800000000003e-17
C232 0 FILL_L8_3 8.4397900000000014e-19
C233 0 FILL_L8_5 8.4397900000000014e-19
C234 0 FILL_L8_7 6.3298400000000003e-19
C237 0 FILL_L30_1 3.4239300000000005e-17
C238 0 FILL_L30_3 3.4239300000000005e-17
C239 0 FILL_L30_5 3.4239300000000005e-17
C240 0 FILL_L30_7 1.5493300000000001e-17
C244 0 FILL_L30_1 1.3544600000000001e-17
C245 0 FILL_L30_3 1.3544600000000001e-17
C246 0 FILL_L30_5 1.3544600000000001e-17
C247 0 FILL_L30_7 6.12892e-18
C248 0 FILL_L8_1 8.1417400000000005e-19
C249 0 FILL_L8_3 1.13984e-18
C250 0 FILL_L8_5 1.13984e-18
C251 0 FILL_L8_7 1.13984e-18
C252 0 FILL_L8_9 2.6379200000000005e-19
C255 0 FILL_L30_1 4.422380000000001e-18
C256 0 FILL_L30_3 4.422380000000001e-18
C257 0 FILL_L30_5 4.422380000000001e-18
C258 0 FILL_L30_7 2.0011300000000001e-18
C259 0 FILL_L8_1 1.9063900000000002e-19
C260 0 FILL_L8_3 2.6689400000000004e-19
C261 0 FILL_L8_5 1.5251100000000003e-19
C262 0 FILL_L8_7 2.6689400000000004e-19
C266 0 FILL_L30_0 1.70033e-16
C267 0 FILL_L30_1 3.4565600000000004e-18
C268 0 FILL_L30_2 1.7055600000000003e-16
C269 0 FILL_L30_3 3.4565600000000004e-18
C270 0 FILL_L30_4 1.7055600000000003e-16
C271 0 FILL_L30_5 3.4565600000000004e-18
C272 0 FILL_L30_6 7.7238900000000012e-17
C273 0 FILL_L30_7 1.5640900000000001e-18
C274 0 FILL_L8_1 1.3400900000000001e-17
C275 0 FILL_L8_2 1.02657e-19
C276 0 FILL_L8_3 1.8094500000000002e-17
C277 0 FILL_L8_4 1.02657e-19
C278 0 FILL_L8_5 1.8094500000000002e-17
C279 0 FILL_L8_7 1.7974100000000001e-17
C280 0 FILL_L8_9 4.573210000000001e-18
C283 0 FILL_L30_0 1.8617000000000002e-17
C284 0 FILL_L30_1 6.1497500000000007e-18
C285 0 FILL_L30_2 1.8617000000000002e-17
C286 0 FILL_L30_3 6.1497500000000007e-18
C287 0 FILL_L30_4 1.8617000000000002e-17
C288 0 FILL_L30_5 6.1497500000000007e-18
C289 0 FILL_L30_6 8.4241900000000005e-18
C290 0 FILL_L30_7 2.7827600000000002e-18
C291 0 FILL_L8_1 1.1741300000000001e-17
C292 0 FILL_L8_3 1.5276800000000002e-17
C293 0 FILL_L8_5 1.5276800000000002e-17
C294 0 FILL_L8_7 1.5276800000000002e-17
C295 0 FILL_L8_9 3.5354900000000004e-18
C299 0 FILL_L30_0 9.8875000000000007e-18
C300 0 FILL_L30_1 1.0960500000000001e-17
C301 0 FILL_L30_2 9.8875000000000007e-18
C302 0 FILL_L30_3 1.0960500000000001e-17
C303 0 FILL_L30_4 9.8875000000000007e-18
C304 0 FILL_L30_5 1.0960500000000001e-17
C305 0 FILL_L30_6 4.474090000000001e-18
C306 0 FILL_L30_7 4.9596300000000002e-18
C307 0 FILL_L8_1 2.0108200000000002e-17
C308 0 FILL_L8_3 2.6760900000000001e-17
C309 0 FILL_L8_5 2.6760900000000001e-17
C310 0 FILL_L8_7 2.6760900000000001e-17
C311 0 FILL_L8_9 6.6526700000000001e-18
C313 0 FILL_L30_0 5.6403900000000007e-18
C314 0 FILL_L30_1 6.3988200000000009e-17
C315 0 FILL_L30_2 5.6403900000000007e-18
C316 0 FILL_L30_3 6.3988200000000009e-17
C317 0 FILL_L30_4 5.6403900000000007e-18
C318 0 FILL_L30_5 6.3988200000000009e-17
C319 0 FILL_L30_6 2.5522700000000003e-18
C320 0 FILL_L30_7 2.8954699999999999e-17
C321 0 FILL_L8_1 1.2144500000000002e-17
C322 0 FILL_L8_3 1.9521400000000002e-17
C323 0 FILL_L8_5 1.9521400000000002e-17
C324 0 FILL_L8_7 1.8460200000000003e-17
C325 0 FILL_L8_9 3.5354900000000004e-18
C326 0 N 1.2964900000000001e-15
C330 0 FILL_L30_1 1.5824600000000001e-16
C331 0 FILL_L30_3 1.6347000000000002e-16
C332 0 FILL_L30_5 1.6347000000000002e-16
C333 0 FILL_L30_7 7.4595000000000007e-17
C334 0 FILL_L8_1 8.3910100000000002e-19
C335 0 FILL_L8_3 9.0734900000000006e-18
C336 0 FILL_L8_5 9.0734900000000006e-18
C337 0 FILL_L8_7 7.04443e-18
C338 0 FILL_L8_9 2.1452200000000002e-19
C339 0 P 3.4877500000000003e-15
C342 0 FILL_L30_1 1.5824600000000001e-16
C343 0 FILL_L30_3 1.6347000000000002e-16
C344 0 FILL_L30_5 1.6347000000000002e-16
C345 0 FILL_L30_7 7.4595000000000007e-17
C346 0 FILL_L8_1 1.12827e-19
C347 0 FILL_L8_3 1.1876500000000002e-18
C348 0 FILL_L8_5 1.1876500000000002e-18
C349 0 FILL_L8_7 8.9074000000000012e-19
C351 0 FILL_L30_0 1.8274000000000002e-19
C352 0 FILL_L30_1 3.0059499999999999e-17
C353 0 FILL_L30_2 1.8274000000000002e-19
C354 0 FILL_L30_3 3.0059499999999999e-17
C355 0 FILL_L30_4 1.8274000000000002e-19
C356 0 FILL_L30_5 3.0059499999999999e-17
C357 0 FILL_L30_6 1.2182600000000002e-19
C358 0 FILL_L30_7 1.39976e-17
C359 0 FILL_L8_1 1.85677e-17
C360 0 FILL_L8_3 2.4158700000000001e-17
C361 0 FILL_L8_5 2.4158700000000001e-17
C362 0 FILL_L8_7 2.4158700000000001e-17
C363 0 FILL_L8_9 5.5910000000000005e-18
C364 0 P 1.0883400000000001e-19
C366 FILL_L30_0 FILL_L30_1 7.7092600000000011e-17
C367 FILL_L30_0 FILL_L30_2 6.3215900000000006e-17
C368 FILL_L30_0 FILL_L8_0 1.2810300000000003e-16
C369 FILL_L30_0 FILL_L8_1 6.0650500000000006e-17
C370 FILL_L30_0 FILL_L8_2 4.61192e-17
C371 FILL_L30_0 0 3.6018900000000002e-16
C372 FILL_L30_1 FILL_L30_3 7.7092600000000011e-17
C373 FILL_L30_1 FILL_L8_1 1.4750600000000001e-16
C374 FILL_L30_1 FILL_L8_3 3.5027200000000004e-17
C375 FILL_L30_1 N 1.7329900000000001e-16
C376 FILL_L30_1 P 1.5824600000000001e-16
C377 FILL_L30_1 0 4.1302100000000002e-16
C378 FILL_L30_2 FILL_L30_3 7.7092600000000011e-17
C379 FILL_L30_2 FILL_L30_4 6.3215900000000006e-17
C380 FILL_L30_2 FILL_L8_2 1.1299500000000002e-16
C381 FILL_L30_2 FILL_L8_3 3.6390300000000006e-17
C382 FILL_L30_2 FILL_L8_4 9.0703300000000009e-17
C383 FILL_L30_2 FILL_L8_5 2.4260200000000003e-17
C384 FILL_L30_2 0 2.7896800000000004e-16
C385 FILL_L30_3 FILL_L30_5 7.7092600000000011e-17
C386 FILL_L30_3 FILL_L8_3 1.1594700000000001e-16
C387 FILL_L30_3 FILL_L8_5 8.8973700000000006e-17
C388 FILL_L30_3 N 1.7852300000000002e-16
C389 FILL_L30_3 P 1.6347000000000002e-16
C390 FILL_L30_3 0 3.1940900000000003e-16
C391 FILL_L30_4 FILL_L30_5 7.7092600000000011e-17
C392 FILL_L30_4 FILL_L30_6 6.3215900000000006e-17
C393 FILL_L30_4 FILL_L8_4 6.8411200000000005e-17
C394 FILL_L30_4 FILL_L8_5 1.2130100000000001e-17
C395 FILL_L30_4 FILL_L8_6 1.2902600000000003e-16
C396 FILL_L30_4 FILL_L8_7 4.8520400000000006e-17
C397 FILL_L30_4 0 2.83599e-16
C398 FILL_L30_5 FILL_L30_7 7.7092600000000011e-17
C399 FILL_L30_5 FILL_L8_5 6.2000500000000005e-17
C400 FILL_L30_5 FILL_L8_7 1.38165e-16
C401 FILL_L30_5 N 1.7852300000000002e-16
C402 FILL_L30_5 P 1.6347000000000002e-16
C403 FILL_L30_5 0 3.2292600000000003e-16
C404 FILL_L30_6 FILL_L30_7 3.4884400000000002e-17
C405 FILL_L30_6 FILL_L8_6 3.1185400000000004e-17
C406 FILL_L30_6 FILL_L8_8 4.5198900000000007e-17
C407 FILL_L30_6 FILL_L8_9 1.96508e-17
C408 FILL_L30_6 0 2.4553500000000001e-16
C409 FILL_L30_7 FILL_L8_7 2.36851e-17
C410 FILL_L30_7 FILL_L8_9 5.0597200000000004e-17
C411 FILL_L30_7 N 8.1406500000000002e-17
C412 FILL_L30_7 P 7.4595000000000007e-17
C413 FILL_L30_7 0 2.8457000000000001e-16
C414 FILL_L8_0 FILL_L8_1 5.3567000000000005e-17
C415 FILL_L8_0 FILL_L8_2 3.54458e-17
C416 FILL_L8_0 0 4.4740700000000005e-16
C417 FILL_L8_1 FILL_L8_3 6.96968e-17
C418 FILL_L8_1 N 6.5382300000000011e-18
C419 FILL_L8_1 P 1.35987e-18
C420 FILL_L8_1 0 7.0562900000000007e-16
C421 FILL_L8_2 FILL_L8_3 6.96968e-17
C422 FILL_L8_2 FILL_L8_4 3.54458e-17
C423 FILL_L8_2 0 5.1906100000000011e-16
C424 FILL_L8_3 FILL_L8_5 6.96968e-17
C425 FILL_L8_3 N 1.6157600000000001e-17
C426 FILL_L8_3 P 1.4314400000000001e-17
C427 FILL_L8_3 0 7.9409500000000004e-16
C428 FILL_L8_4 FILL_L8_5 6.96968e-17
C429 FILL_L8_4 FILL_L8_6 3.54458e-17
C430 FILL_L8_4 0 5.1906100000000011e-16
C431 FILL_L8_5 FILL_L8_7 6.96968e-17
C432 FILL_L8_5 N 1.6157600000000001e-17
C433 FILL_L8_5 P 1.4314400000000001e-17
C434 FILL_L8_5 0 7.9409500000000004e-16
C435 FILL_L8_6 FILL_L8_7 6.96968e-17
C436 FILL_L8_6 FILL_L8_8 3.54458e-17
C437 FILL_L8_6 0 5.1906100000000011e-16
C438 FILL_L8_7 FILL_L8_9 6.96968e-17
C439 FILL_L8_7 N 1.3975199999999999e-17
C440 FILL_L8_7 P 1.1034900000000001e-17
C441 FILL_L8_7 0 7.9409500000000004e-16
C442 FILL_L8_8 FILL_L8_9 1.6129800000000002e-17
C443 FILL_L8_8 0 2.12576e-16
C444 FILL_L8_9 N 1.71904e-18
C445 FILL_L8_9 P 2.6815299999999997e-19
C446 FILL_L8_9 0 3.6556099999999999e-16
C447 N P 3.4877500000000003e-15
C448 N 0 2.2133700000000001e-17
C449 P 0 1.4043000000000001e-17
VP P 0 DC 0 AC 0
VN N 0 DC 0 AC 1
.control
set numdgt=17
ac lin 1 1Meg 1Meg
let cp = -imag(i(VP))/(2*pi*1e6)
let cn = -imag(i(VN))/(2*pi*1e6)
print cp cn
quit
.endc
.end
