* actual_fill grounded drive P; diagnostic capacitor-network AC only
C82 0 N 3.2510800000000007e-17
C98 0 N 2.8625000000000003e-17
C99 0 P 9.4825500000000004e-18
C118 0 P 4.5911500000000004e-18
C164 0 N 4.2665500000000008e-17
C165 0 P 3.5607700000000002e-17
C187 0 N 2.6993700000000001e-17
C188 0 P 3.2462000000000005e-17
C326 0 N 1.2964900000000001e-15
C339 0 P 3.4877500000000003e-15
C364 0 P 1.0883400000000001e-19
C375 0 N 1.7329900000000001e-16
C376 0 P 1.5824600000000001e-16
C388 0 N 1.7852300000000002e-16
C389 0 P 1.6347000000000002e-16
C401 0 N 1.7852300000000002e-16
C402 0 P 1.6347000000000002e-16
C411 0 N 8.1406500000000002e-17
C412 0 P 7.4595000000000007e-17
C418 0 N 6.5382300000000011e-18
C419 0 P 1.35987e-18
C425 0 N 1.6157600000000001e-17
C426 0 P 1.4314400000000001e-17
C432 0 N 1.6157600000000001e-17
C433 0 P 1.4314400000000001e-17
C439 0 N 1.3975199999999999e-17
C440 0 P 1.1034900000000001e-17
C444 0 N 1.71904e-18
C445 0 P 2.6815299999999997e-19
C447 N P 3.4877500000000003e-15
C448 N 0 2.2133700000000001e-17
C449 P 0 1.4043000000000001e-17
VP P 0 DC 0 AC 1
VN N 0 DC 0 AC 0
.control
set numdgt=17
ac lin 1 1Meg 1Meg
let cp = -imag(i(VP))/(2*pi*1e6)
let cn = -imag(i(VN))/(2*pi*1e6)
print cp cn
quit
.endc
.end
