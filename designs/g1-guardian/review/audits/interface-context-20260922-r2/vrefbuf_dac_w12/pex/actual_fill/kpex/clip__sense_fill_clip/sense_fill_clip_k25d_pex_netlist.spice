*********************************************************
*** NGSPICE file created by KLayout-PEX 0.3.12
*** -----------------------------------------------------
***     Extraction Engine: KPEX/2.5D
***     Technology: ihp_sg13g2
***     Date: 2026-09-22 16:35:03
*********************************************************

.SUBCKT sense_fill_clip
Cext_1 CTX_L10_0 CTX_L10_1 262.111a
Cext_2 CTX_L10_0 CTX_L126_0 31.7895a
Cext_3 CTX_L10_0 CTX_L50_0 24.9145a
Cext_4 CTX_L10_0 CTX_L50_1 7.06787a
Cext_5 CTX_L10_0 CTX_L50_2 11.0618a
Cext_6 CTX_L10_0 FILL_L30_0 240.814a
Cext_7 CTX_L10_0 FILL_L30_2 247.28a
Cext_8 CTX_L10_0 FILL_L30_4 247.28a
Cext_9 CTX_L10_0 FILL_L30_6 112.668a
Cext_10 CTX_L10_0 FILL_L8_0 175.025a
Cext_11 CTX_L10_0 FILL_L8_1 3.39384a
Cext_12 CTX_L10_0 FILL_L8_2 230.991a
Cext_13 CTX_L10_0 FILL_L8_3 4.41577a
Cext_14 CTX_L10_0 FILL_L8_4 230.991a
Cext_15 CTX_L10_0 FILL_L8_5 4.41577a
Cext_16 CTX_L10_0 FILL_L8_6 230.991a
Cext_17 CTX_L10_0 FILL_L8_7 4.41577a
Cext_18 CTX_L10_0 FILL_L8_8 55.9658a
Cext_19 CTX_L10_0 FILL_L8_9 1.02194a
Cext_20 CTX_L10_0 VSUBS 965.061a
Cext_21 CTX_L10_1 CTX_L10_2 1.1274f
Cext_22 CTX_L10_1 CTX_L126_0 27.6797a
Cext_23 CTX_L10_1 CTX_L50_0 3.68875a
Cext_24 CTX_L10_1 CTX_L50_1 5.72713a
Cext_25 CTX_L10_1 CTX_L50_2 28.5545a
Cext_26 CTX_L10_1 CTX_L50_3 92.488a
Cext_27 CTX_L10_1 CTX_L50_4 30.6383a
Cext_28 CTX_L10_1 FILL_L30_0 101.523a
Cext_29 CTX_L10_1 FILL_L30_1 7.61238a
Cext_30 CTX_L10_1 FILL_L30_2 101.523a
Cext_31 CTX_L10_1 FILL_L30_3 7.61238a
Cext_32 CTX_L10_1 FILL_L30_4 101.523a
Cext_33 CTX_L10_1 FILL_L30_5 7.61238a
Cext_34 CTX_L10_1 FILL_L30_6 45.9391a
Cext_35 CTX_L10_1 FILL_L30_7 3.4446a
Cext_36 CTX_L10_1 FILL_L8_0 11.8588a
Cext_37 CTX_L10_1 FILL_L8_1 162.565a
Cext_38 CTX_L10_1 FILL_L8_2 15.4297a
Cext_39 CTX_L10_1 FILL_L8_3 214.778a
Cext_40 CTX_L10_1 FILL_L8_4 15.4297a
Cext_41 CTX_L10_1 FILL_L8_5 214.778a
Cext_42 CTX_L10_1 FILL_L8_6 15.4297a
Cext_43 CTX_L10_1 FILL_L8_7 214.778a
Cext_44 CTX_L10_1 FILL_L8_8 3.57087a
Cext_45 CTX_L10_1 FILL_L8_9 52.2138a
Cext_46 CTX_L10_1 VSUBS 403.277a
Cext_47 CTX_L10_2 CTX_L10_3 3.3183f
Cext_48 CTX_L10_2 CTX_L50_4 30.6383a
Cext_49 CTX_L10_2 CTX_L50_5 92.488a
Cext_50 CTX_L10_2 CTX_L8_0 0.360981a
Cext_51 CTX_L10_2 FILL_L30_0 6.98188a
Cext_52 CTX_L10_2 FILL_L30_1 25.4668a
Cext_53 CTX_L10_2 FILL_L30_2 6.98188a
Cext_54 CTX_L10_2 FILL_L30_3 25.4668a
Cext_55 CTX_L10_2 FILL_L30_4 6.98188a
Cext_56 CTX_L10_2 FILL_L30_5 25.4668a
Cext_57 CTX_L10_2 FILL_L30_6 3.1593a
Cext_58 CTX_L10_2 FILL_L30_7 11.5237a
Cext_59 CTX_L10_2 FILL_L8_1 145.087a
Cext_60 CTX_L10_2 FILL_L8_3 192.038a
Cext_61 CTX_L10_2 FILL_L8_5 192.038a
Cext_62 CTX_L10_2 FILL_L8_7 192.038a
Cext_63 CTX_L10_2 FILL_L8_9 46.9511a
Cext_64 CTX_L10_2 VSUBS 98.231a
Cext_65 CTX_L10_3 CTX_L10_4 3.3183f
Cext_66 CTX_L10_3 CTX_L126_0 19.7005a
Cext_67 CTX_L10_3 CTX_L126_1 14.6153a
Cext_68 CTX_L10_3 CTX_L50_5 32.7819a
Cext_69 CTX_L10_3 CTX_L8_0 0.423075a
Cext_70 CTX_L10_3 FILL_L30_0 2.29022a
Cext_71 CTX_L10_3 FILL_L30_1 85.6767a
Cext_72 CTX_L10_3 FILL_L30_2 2.29022a
Cext_73 CTX_L10_3 FILL_L30_3 88.9097a
Cext_74 CTX_L10_3 FILL_L30_4 2.29022a
Cext_75 CTX_L10_3 FILL_L30_5 88.9097a
Cext_76 CTX_L10_3 FILL_L30_6 1.03632a
Cext_77 CTX_L10_3 FILL_L30_7 40.6184a
Cext_78 CTX_L10_3 FILL_L8_1 105.763a
Cext_79 CTX_L10_3 FILL_L8_3 140.873a
Cext_80 CTX_L10_3 FILL_L8_5 140.873a
Cext_81 CTX_L10_3 FILL_L8_7 140.873a
Cext_82 CTX_L10_3 FILL_L8_9 35.11a
Cext_83 CTX_L10_3 N 32.5108a
Cext_84 CTX_L10_3 VSUBS 69.9109a
Cext_85 CTX_L10_4 CTX_L10_5 309.641a
Cext_86 CTX_L10_4 CTX_L50_10 5.72713a
Cext_87 CTX_L10_4 CTX_L50_8 8.44318a
Cext_88 CTX_L10_4 CTX_L50_9 7.06787a
Cext_89 CTX_L10_4 CTX_L8_0 0.614242a
Cext_90 CTX_L10_4 FILL_L30_1 229.409a
Cext_91 CTX_L10_4 FILL_L30_3 235.874a
Cext_92 CTX_L10_4 FILL_L30_5 235.874a
Cext_93 CTX_L10_4 FILL_L30_7 107.507a
Cext_94 CTX_L10_4 FILL_L8_1 153.629a
Cext_95 CTX_L10_4 FILL_L8_3 203.152a
Cext_96 CTX_L10_4 FILL_L8_5 203.152a
Cext_97 CTX_L10_4 FILL_L8_7 203.152a
Cext_98 CTX_L10_4 FILL_L8_9 49.5231a
Cext_99 CTX_L10_4 N 28.625a
Cext_100 CTX_L10_4 P 9.48255a
Cext_101 CTX_L10_4 VSUBS 359.627a
Cext_102 CTX_L10_5 CTX_L10_6 1.1274f
Cext_103 CTX_L10_5 CTX_L126_0 5.61152a
Cext_104 CTX_L10_5 CTX_L126_1 23.9985a
Cext_105 CTX_L10_5 CTX_L50_10 22.1836a
Cext_106 CTX_L10_5 CTX_L50_11 24.9145a
Cext_107 CTX_L10_5 CTX_L50_8 5.72713a
Cext_108 CTX_L10_5 CTX_L50_9 7.06787a
Cext_109 CTX_L10_5 CTX_L8_0 10.1323a
Cext_110 CTX_L10_5 FILL_L30_1 256.169a
Cext_111 CTX_L10_5 FILL_L30_3 262.635a
Cext_112 CTX_L10_5 FILL_L30_5 262.635a
Cext_113 CTX_L10_5 FILL_L30_7 119.616a
Cext_114 CTX_L10_5 FILL_L8_1 13.7426a
Cext_115 CTX_L10_5 FILL_L8_3 17.8807a
Cext_116 CTX_L10_5 FILL_L8_5 17.8807a
Cext_117 CTX_L10_5 FILL_L8_7 17.8807a
Cext_118 CTX_L10_5 FILL_L8_9 4.1381a
Cext_119 CTX_L10_5 P 4.59115a
Cext_120 CTX_L10_5 VSUBS 591.812a
Cext_121 CTX_L10_6 CTX_L126_1 40.8342a
Cext_122 CTX_L10_6 CTX_L50_11 9.48255a
Cext_123 CTX_L10_6 CTX_L50_12 92.488a
Cext_124 CTX_L10_6 CTX_L50_13 30.6383a
Cext_125 CTX_L10_6 CTX_L50_14 22.8364a
Cext_126 CTX_L10_6 CTX_L8_0 75.0854a
Cext_127 CTX_L10_6 FILL_L30_1 81.1564a
Cext_128 CTX_L10_6 FILL_L30_3 81.1564a
Cext_129 CTX_L10_6 FILL_L30_5 81.1564a
Cext_130 CTX_L10_6 FILL_L30_7 36.7233a
Cext_131 CTX_L10_6 FILL_L8_1 0.920138a
Cext_132 CTX_L10_6 FILL_L8_3 1.28819a
Cext_133 CTX_L10_6 FILL_L8_5 1.28819a
Cext_134 CTX_L10_6 FILL_L8_7 1.28819a
Cext_135 CTX_L10_6 FILL_L8_9 0.298125a
Cext_136 CTX_L10_6 VSUBS 892.227a
Cext_137 CTX_L126_0 CTX_L126_1 616.272a
Cext_138 CTX_L126_0 CTX_L50_0 51.6486a
Cext_139 CTX_L126_0 CTX_L50_1 201.673a
Cext_140 CTX_L126_0 CTX_L50_10 20.6614a
Cext_141 CTX_L126_0 CTX_L50_2 262.971a
Cext_142 CTX_L126_0 CTX_L50_3 116.729a
Cext_143 CTX_L126_0 CTX_L50_4 62.9859a
Cext_144 CTX_L126_0 CTX_L50_5 57.6862a
Cext_145 CTX_L126_0 CTX_L50_8 29.5923a
Cext_146 CTX_L126_0 CTX_L50_9 24.6521a
Cext_147 CTX_L126_0 CTX_L8_0 0.921936a
Cext_148 CTX_L126_0 FILL_L30_0 133.178a
Cext_149 CTX_L126_0 FILL_L30_1 69.1856a
Cext_150 CTX_L126_0 FILL_L30_2 139.88a
Cext_151 CTX_L126_0 FILL_L30_3 69.1856a
Cext_152 CTX_L126_0 FILL_L30_4 139.88a
Cext_153 CTX_L126_0 FILL_L30_5 69.1856a
Cext_154 CTX_L126_0 FILL_L30_6 64.0051a
Cext_155 CTX_L126_0 FILL_L30_7 31.3065a
Cext_156 CTX_L126_0 FILL_L8_0 1.92996a
Cext_157 CTX_L126_0 FILL_L8_1 22.2481a
Cext_158 CTX_L126_0 FILL_L8_2 20.3154a
Cext_159 CTX_L126_0 FILL_L8_3 40.6004a
Cext_160 CTX_L126_0 FILL_L8_4 20.3154a
Cext_161 CTX_L126_0 FILL_L8_5 40.6004a
Cext_162 CTX_L126_0 FILL_L8_6 15.2366a
Cext_163 CTX_L126_0 FILL_L8_7 37.3833a
Cext_164 CTX_L126_0 FILL_L8_9 6.70624a
Cext_165 CTX_L126_0 N 42.6655a
Cext_166 CTX_L126_0 P 35.6077a
Cext_167 CTX_L126_0 VSUBS 746.889a
Cext_168 CTX_L126_1 CTX_L50_10 79.3915a
Cext_169 CTX_L126_1 CTX_L50_11 149.305a
Cext_170 CTX_L126_1 CTX_L50_12 161.25a
Cext_171 CTX_L126_1 CTX_L50_13 161.25a
Cext_172 CTX_L126_1 CTX_L50_14 101.413a
Cext_173 CTX_L126_1 CTX_L50_3 2.65563a
Cext_174 CTX_L126_1 CTX_L50_4 16.0914a
Cext_175 CTX_L126_1 CTX_L50_5 18.9697a
Cext_176 CTX_L126_1 CTX_L50_8 39.0197a
Cext_177 CTX_L126_1 CTX_L50_9 46.4815a
Cext_178 CTX_L126_1 CTX_L8_0 37.2855a
Cext_179 CTX_L126_1 FILL_L30_1 116.307a
Cext_180 CTX_L126_1 FILL_L30_3 118.096a
Cext_181 CTX_L126_1 FILL_L30_5 118.096a
Cext_182 CTX_L126_1 FILL_L30_7 53.6227a
Cext_183 CTX_L126_1 FILL_L8_1 13.9555a
Cext_184 CTX_L126_1 FILL_L8_3 27.4196a
Cext_185 CTX_L126_1 FILL_L8_5 27.4196a
Cext_186 CTX_L126_1 FILL_L8_7 24.8582a
Cext_187 CTX_L126_1 FILL_L8_9 3.97462a
Cext_188 CTX_L126_1 N 26.9937a
Cext_189 CTX_L126_1 P 32.462a
Cext_190 CTX_L126_1 VSUBS 1.00562f
Cext_191 CTX_L50_0 CTX_L50_1 1.29649f
Cext_192 CTX_L50_0 FILL_L30_0 283.433a
Cext_193 CTX_L50_0 FILL_L30_2 288.657a
Cext_194 CTX_L50_0 FILL_L30_4 288.657a
Cext_195 CTX_L50_0 FILL_L30_6 131.242a
Cext_196 CTX_L50_0 FILL_L8_0 2.54398a
Cext_197 CTX_L50_0 FILL_L8_2 26.7787a
Cext_198 CTX_L50_0 FILL_L8_4 26.7787a
Cext_199 CTX_L50_0 FILL_L8_6 20.3832a
Cext_200 CTX_L50_0 FILL_L8_8 0.268153a
Cext_201 CTX_L50_0 VSUBS 506.827a
Cext_202 CTX_L50_1 CTX_L50_2 796.238a
Cext_203 CTX_L50_1 FILL_L30_0 306.594a
Cext_204 CTX_L50_1 FILL_L30_2 311.817a
Cext_205 CTX_L50_1 FILL_L30_4 311.817a
Cext_206 CTX_L50_1 FILL_L30_6 141.722a
Cext_207 CTX_L50_1 FILL_L8_0 1.16615a
Cext_208 CTX_L50_1 FILL_L8_2 12.2752a
Cext_209 CTX_L50_1 FILL_L8_3 1.05237a
Cext_210 CTX_L50_1 FILL_L8_4 12.2752a
Cext_211 CTX_L50_1 FILL_L8_5 1.05237a
Cext_212 CTX_L50_1 FILL_L8_6 9.20641a
Cext_213 CTX_L50_1 FILL_L8_7 0.789277a
Cext_214 CTX_L50_1 VSUBS 66.8511a
Cext_215 CTX_L50_10 CTX_L50_11 796.238a
Cext_216 CTX_L50_10 CTX_L50_9 3.48775f
Cext_217 CTX_L50_10 CTX_L8_0 1.94317a
Cext_218 CTX_L50_10 FILL_L30_1 248.126a
Cext_219 CTX_L50_10 FILL_L30_3 253.35a
Cext_220 CTX_L50_10 FILL_L30_5 253.35a
Cext_221 CTX_L50_10 FILL_L30_7 115.266a
Cext_222 CTX_L50_10 FILL_L8_1 0.10759a
Cext_223 CTX_L50_10 FILL_L8_3 1.13253a
Cext_224 CTX_L50_10 FILL_L8_5 1.13253a
Cext_225 CTX_L50_10 FILL_L8_7 0.849395a
Cext_226 CTX_L50_10 VSUBS 66.4441a
Cext_227 CTX_L50_11 CTX_L50_12 3.48775f
Cext_228 CTX_L50_11 CTX_L8_0 2.8322a
Cext_229 CTX_L50_11 FILL_L30_1 210.65a
Cext_230 CTX_L50_11 FILL_L30_3 215.874a
Cext_231 CTX_L50_11 FILL_L30_5 215.874a
Cext_232 CTX_L50_11 FILL_L30_7 98.3078a
Cext_233 CTX_L50_11 FILL_L8_3 0.843979a
Cext_234 CTX_L50_11 FILL_L8_5 0.843979a
Cext_235 CTX_L50_11 FILL_L8_7 0.632984a
Cext_236 CTX_L50_11 VSUBS 82.7556a
Cext_237 CTX_L50_12 CTX_L50_13 3.48775f
Cext_238 CTX_L50_12 FILL_L30_1 34.2393a
Cext_239 CTX_L50_12 FILL_L30_3 34.2393a
Cext_240 CTX_L50_12 FILL_L30_5 34.2393a
Cext_241 CTX_L50_12 FILL_L30_7 15.4933a
Cext_242 CTX_L50_12 VSUBS 67.7568a
Cext_243 CTX_L50_13 CTX_L50_14 1.29649f
Cext_244 CTX_L50_13 CTX_L8_0 11.2951a
Cext_245 CTX_L50_13 FILL_L30_1 13.5446a
Cext_246 CTX_L50_13 FILL_L30_3 13.5446a
Cext_247 CTX_L50_13 FILL_L30_5 13.5446a
Cext_248 CTX_L50_13 FILL_L30_7 6.12892a
Cext_249 CTX_L50_13 FILL_L8_1 0.814174a
Cext_250 CTX_L50_13 FILL_L8_3 1.13984a
Cext_251 CTX_L50_13 FILL_L8_5 1.13984a
Cext_252 CTX_L50_13 FILL_L8_7 1.13984a
Cext_253 CTX_L50_13 FILL_L8_9 0.263792a
Cext_254 CTX_L50_13 VSUBS 159.538a
Cext_255 CTX_L50_14 CTX_L8_0 61.2285a
Cext_256 CTX_L50_14 FILL_L30_1 4.42238a
Cext_257 CTX_L50_14 FILL_L30_3 4.42238a
Cext_258 CTX_L50_14 FILL_L30_5 4.42238a
Cext_259 CTX_L50_14 FILL_L30_7 2.00113a
Cext_260 CTX_L50_14 FILL_L8_1 0.190639a
Cext_261 CTX_L50_14 FILL_L8_3 0.266894a
Cext_262 CTX_L50_14 FILL_L8_5 0.152511a
Cext_263 CTX_L50_14 FILL_L8_7 0.266894a
Cext_264 CTX_L50_14 VSUBS 672.919a
Cext_265 CTX_L50_2 CTX_L50_3 3.48775f
Cext_266 CTX_L50_2 CTX_L8_0 0.440274a
Cext_267 CTX_L50_2 FILL_L30_0 170.033a
Cext_268 CTX_L50_2 FILL_L30_1 3.45656a
Cext_269 CTX_L50_2 FILL_L30_2 170.556a
Cext_270 CTX_L50_2 FILL_L30_3 3.45656a
Cext_271 CTX_L50_2 FILL_L30_4 170.556a
Cext_272 CTX_L50_2 FILL_L30_5 3.45656a
Cext_273 CTX_L50_2 FILL_L30_6 77.2389a
Cext_274 CTX_L50_2 FILL_L30_7 1.56409a
Cext_275 CTX_L50_2 FILL_L8_1 13.4009a
Cext_276 CTX_L50_2 FILL_L8_2 0.102657a
Cext_277 CTX_L50_2 FILL_L8_3 18.0945a
Cext_278 CTX_L50_2 FILL_L8_4 0.102657a
Cext_279 CTX_L50_2 FILL_L8_5 18.0945a
Cext_280 CTX_L50_2 FILL_L8_7 17.9741a
Cext_281 CTX_L50_2 FILL_L8_9 4.57321a
Cext_282 CTX_L50_2 VSUBS 72.3987a
Cext_283 CTX_L50_3 CTX_L50_4 3.48775f
Cext_284 CTX_L50_3 FILL_L30_0 18.617a
Cext_285 CTX_L50_3 FILL_L30_1 6.14975a
Cext_286 CTX_L50_3 FILL_L30_2 18.617a
Cext_287 CTX_L50_3 FILL_L30_3 6.14975a
Cext_288 CTX_L50_3 FILL_L30_4 18.617a
Cext_289 CTX_L50_3 FILL_L30_5 6.14975a
Cext_290 CTX_L50_3 FILL_L30_6 8.42419a
Cext_291 CTX_L50_3 FILL_L30_7 2.78276a
Cext_292 CTX_L50_3 FILL_L8_1 11.7413a
Cext_293 CTX_L50_3 FILL_L8_3 15.2768a
Cext_294 CTX_L50_3 FILL_L8_5 15.2768a
Cext_295 CTX_L50_3 FILL_L8_7 15.2768a
Cext_296 CTX_L50_3 FILL_L8_9 3.53549a
Cext_297 CTX_L50_3 VSUBS 29.8137a
Cext_298 CTX_L50_4 CTX_L50_5 3.48775f
Cext_299 CTX_L50_4 CTX_L8_0 0.739419a
Cext_300 CTX_L50_4 FILL_L30_0 9.8875a
Cext_301 CTX_L50_4 FILL_L30_1 10.9605a
Cext_302 CTX_L50_4 FILL_L30_2 9.8875a
Cext_303 CTX_L50_4 FILL_L30_3 10.9605a
Cext_304 CTX_L50_4 FILL_L30_4 9.8875a
Cext_305 CTX_L50_4 FILL_L30_5 10.9605a
Cext_306 CTX_L50_4 FILL_L30_6 4.47409a
Cext_307 CTX_L50_4 FILL_L30_7 4.95963a
Cext_308 CTX_L50_4 FILL_L8_1 20.1082a
Cext_309 CTX_L50_4 FILL_L8_3 26.7609a
Cext_310 CTX_L50_4 FILL_L8_5 26.7609a
Cext_311 CTX_L50_4 FILL_L8_7 26.7609a
Cext_312 CTX_L50_4 FILL_L8_9 6.65267a
Cext_313 CTX_L50_4 VSUBS 40.5513a
Cext_314 CTX_L50_5 FILL_L30_0 5.64039a
Cext_315 CTX_L50_5 FILL_L30_1 63.9882a
Cext_316 CTX_L50_5 FILL_L30_2 5.64039a
Cext_317 CTX_L50_5 FILL_L30_3 63.9882a
Cext_318 CTX_L50_5 FILL_L30_4 5.64039a
Cext_319 CTX_L50_5 FILL_L30_5 63.9882a
Cext_320 CTX_L50_5 FILL_L30_6 2.55227a
Cext_321 CTX_L50_5 FILL_L30_7 28.9547a
Cext_322 CTX_L50_5 FILL_L8_1 12.1445a
Cext_323 CTX_L50_5 FILL_L8_3 19.5214a
Cext_324 CTX_L50_5 FILL_L8_5 19.5214a
Cext_325 CTX_L50_5 FILL_L8_7 18.4602a
Cext_326 CTX_L50_5 FILL_L8_9 3.53549a
Cext_327 CTX_L50_5 N 1.29649f
Cext_328 CTX_L50_5 VSUBS 30.5625a
Cext_329 CTX_L50_8 CTX_L50_9 3.48775f
Cext_330 CTX_L50_8 CTX_L8_0 0.326785a
Cext_331 CTX_L50_8 FILL_L30_1 158.246a
Cext_332 CTX_L50_8 FILL_L30_3 163.47a
Cext_333 CTX_L50_8 FILL_L30_5 163.47a
Cext_334 CTX_L50_8 FILL_L30_7 74.595a
Cext_335 CTX_L50_8 FILL_L8_1 0.839101a
Cext_336 CTX_L50_8 FILL_L8_3 9.07349a
Cext_337 CTX_L50_8 FILL_L8_5 9.07349a
Cext_338 CTX_L50_8 FILL_L8_7 7.04443a
Cext_339 CTX_L50_8 FILL_L8_9 0.214522a
Cext_340 CTX_L50_8 P 3.48775f
Cext_341 CTX_L50_8 VSUBS 24.7002a
Cext_342 CTX_L50_9 CTX_L8_0 1.69963a
Cext_343 CTX_L50_9 FILL_L30_1 158.246a
Cext_344 CTX_L50_9 FILL_L30_3 163.47a
Cext_345 CTX_L50_9 FILL_L30_5 163.47a
Cext_346 CTX_L50_9 FILL_L30_7 74.595a
Cext_347 CTX_L50_9 FILL_L8_1 0.112827a
Cext_348 CTX_L50_9 FILL_L8_3 1.18765a
Cext_349 CTX_L50_9 FILL_L8_5 1.18765a
Cext_350 CTX_L50_9 FILL_L8_7 0.89074a
Cext_351 CTX_L50_9 VSUBS 41.4671a
Cext_352 CTX_L8_0 FILL_L30_0 0.18274a
Cext_353 CTX_L8_0 FILL_L30_1 30.0595a
Cext_354 CTX_L8_0 FILL_L30_2 0.18274a
Cext_355 CTX_L8_0 FILL_L30_3 30.0595a
Cext_356 CTX_L8_0 FILL_L30_4 0.18274a
Cext_357 CTX_L8_0 FILL_L30_5 30.0595a
Cext_358 CTX_L8_0 FILL_L30_6 0.121826a
Cext_359 CTX_L8_0 FILL_L30_7 13.9976a
Cext_360 CTX_L8_0 FILL_L8_1 18.5677a
Cext_361 CTX_L8_0 FILL_L8_3 24.1587a
Cext_362 CTX_L8_0 FILL_L8_5 24.1587a
Cext_363 CTX_L8_0 FILL_L8_7 24.1587a
Cext_364 CTX_L8_0 FILL_L8_9 5.591a
Cext_365 CTX_L8_0 P 0.108834a
Cext_366 CTX_L8_0 VSUBS 1.72661f
Cext_367 FILL_L30_0 FILL_L30_1 77.0926a
Cext_368 FILL_L30_0 FILL_L30_2 63.2159a
Cext_369 FILL_L30_0 FILL_L8_0 128.103a
Cext_370 FILL_L30_0 FILL_L8_1 60.6505a
Cext_371 FILL_L30_0 FILL_L8_2 46.1192a
Cext_372 FILL_L30_0 VSUBS 360.189a
Cext_373 FILL_L30_1 FILL_L30_3 77.0926a
Cext_374 FILL_L30_1 FILL_L8_1 147.506a
Cext_375 FILL_L30_1 FILL_L8_3 35.0272a
Cext_376 FILL_L30_1 N 173.299a
Cext_377 FILL_L30_1 P 158.246a
Cext_378 FILL_L30_1 VSUBS 413.021a
Cext_379 FILL_L30_2 FILL_L30_3 77.0926a
Cext_380 FILL_L30_2 FILL_L30_4 63.2159a
Cext_381 FILL_L30_2 FILL_L8_2 112.995a
Cext_382 FILL_L30_2 FILL_L8_3 36.3903a
Cext_383 FILL_L30_2 FILL_L8_4 90.7033a
Cext_384 FILL_L30_2 FILL_L8_5 24.2602a
Cext_385 FILL_L30_2 VSUBS 278.968a
Cext_386 FILL_L30_3 FILL_L30_5 77.0926a
Cext_387 FILL_L30_3 FILL_L8_3 115.947a
Cext_388 FILL_L30_3 FILL_L8_5 88.9737a
Cext_389 FILL_L30_3 N 178.523a
Cext_390 FILL_L30_3 P 163.47a
Cext_391 FILL_L30_3 VSUBS 319.409a
Cext_392 FILL_L30_4 FILL_L30_5 77.0926a
Cext_393 FILL_L30_4 FILL_L30_6 63.2159a
Cext_394 FILL_L30_4 FILL_L8_4 68.4112a
Cext_395 FILL_L30_4 FILL_L8_5 12.1301a
Cext_396 FILL_L30_4 FILL_L8_6 129.026a
Cext_397 FILL_L30_4 FILL_L8_7 48.5204a
Cext_398 FILL_L30_4 VSUBS 283.599a
Cext_399 FILL_L30_5 FILL_L30_7 77.0926a
Cext_400 FILL_L30_5 FILL_L8_5 62.0005a
Cext_401 FILL_L30_5 FILL_L8_7 138.165a
Cext_402 FILL_L30_5 N 178.523a
Cext_403 FILL_L30_5 P 163.47a
Cext_404 FILL_L30_5 VSUBS 322.926a
Cext_405 FILL_L30_6 FILL_L30_7 34.8844a
Cext_406 FILL_L30_6 FILL_L8_6 31.1854a
Cext_407 FILL_L30_6 FILL_L8_8 45.1989a
Cext_408 FILL_L30_6 FILL_L8_9 19.6508a
Cext_409 FILL_L30_6 VSUBS 245.535a
Cext_410 FILL_L30_7 FILL_L8_7 23.6851a
Cext_411 FILL_L30_7 FILL_L8_9 50.5972a
Cext_412 FILL_L30_7 N 81.4065a
Cext_413 FILL_L30_7 P 74.595a
Cext_414 FILL_L30_7 VSUBS 284.57a
Cext_415 FILL_L8_0 FILL_L8_1 53.567a
Cext_416 FILL_L8_0 FILL_L8_2 35.4458a
Cext_417 FILL_L8_0 VSUBS 447.407a
Cext_418 FILL_L8_1 FILL_L8_3 69.6968a
Cext_419 FILL_L8_1 N 6.53823a
Cext_420 FILL_L8_1 P 1.35987a
Cext_421 FILL_L8_1 VSUBS 705.629a
Cext_422 FILL_L8_2 FILL_L8_3 69.6968a
Cext_423 FILL_L8_2 FILL_L8_4 35.4458a
Cext_424 FILL_L8_2 VSUBS 519.061a
Cext_425 FILL_L8_3 FILL_L8_5 69.6968a
Cext_426 FILL_L8_3 N 16.1576a
Cext_427 FILL_L8_3 P 14.3144a
Cext_428 FILL_L8_3 VSUBS 794.095a
Cext_429 FILL_L8_4 FILL_L8_5 69.6968a
Cext_430 FILL_L8_4 FILL_L8_6 35.4458a
Cext_431 FILL_L8_4 VSUBS 519.061a
Cext_432 FILL_L8_5 FILL_L8_7 69.6968a
Cext_433 FILL_L8_5 N 16.1576a
Cext_434 FILL_L8_5 P 14.3144a
Cext_435 FILL_L8_5 VSUBS 794.095a
Cext_436 FILL_L8_6 FILL_L8_7 69.6968a
Cext_437 FILL_L8_6 FILL_L8_8 35.4458a
Cext_438 FILL_L8_6 VSUBS 519.061a
Cext_439 FILL_L8_7 FILL_L8_9 69.6968a
Cext_440 FILL_L8_7 N 13.9752a
Cext_441 FILL_L8_7 P 11.0349a
Cext_442 FILL_L8_7 VSUBS 794.095a
Cext_443 FILL_L8_8 FILL_L8_9 16.1298a
Cext_444 FILL_L8_8 VSUBS 212.576a
Cext_445 FILL_L8_9 N 1.71904a
Cext_446 FILL_L8_9 P 0.268153a
Cext_447 FILL_L8_9 VSUBS 365.561a
Cext_448 N P 3.48775f
Cext_449 N VSUBS 22.1337a
Cext_450 P VSUBS 14.043a
.ENDS sense_fill_clip
