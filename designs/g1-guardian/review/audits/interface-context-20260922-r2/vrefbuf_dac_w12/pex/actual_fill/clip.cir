* cell sense_fill_clip
.SUBCKT sense_fill_clip
* net 2 CTX_L10_0
* net 3 FILL_L8_2
* net 4 FILL_L8_0
* net 5 CTX_L50_0
* net 6 FILL_L67_3
* net 7 FILL_L30_2
* net 8 FILL_L67_0
* net 9 FILL_L30_0
* net 10 CTX_L50_1
* net 11 CTX_L126_0
* net 12 CTX_L50_2
* net 13 CTX_L50_3
* net 14 CTX_L10_1
* net 15 CTX_L50_4
* net 16 CTX_L50_5
* net 17 CTX_L10_2
* net 18 FILL_L8_1
* net 19 FILL_L8_3
* net 20 CTX_L10_3
* net 21 N
* net 22 CTX_L10_4
* net 23 P
* net 24 CTX_L50_8
* net 25 CTX_L50_9
* net 26 FILL_L30_1
* net 27 FILL_L67_4
* net 28 FILL_L67_1
* net 29 FILL_L30_3
* net 30 CTX_L50_10
* net 31 CTX_L10_5
* net 32 CTX_L50_11
* net 33 CTX_L50_12
* net 34 CTX_L10_6
* net 35 CTX_L126_1
* net 36 CTX_L50_13
* net 37 CTX_L50_14
* net 38 CTX_L8_0
* net 39 FILL_L67_5
* net 40 FILL_L67_2
* net 41 FILL_L8_8
* net 42 FILL_L8_4
* net 43 FILL_L8_6
* net 44 FILL_L67_9
* net 45 FILL_L30_6
* net 46 FILL_L67_6
* net 47 FILL_L30_4
* net 48 FILL_L8_5
* net 49 FILL_L8_9
* net 50 FILL_L8_7
* net 51 FILL_L67_7
* net 52 FILL_L30_7
* net 53 FILL_L30_5
* net 54 FILL_L67_10
* net 55 FILL_L67_8
* net 56 FILL_L67_11
.ENDS sense_fill_clip
