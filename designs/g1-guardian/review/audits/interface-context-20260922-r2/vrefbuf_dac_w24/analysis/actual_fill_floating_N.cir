* actual_fill floating drive N; diagnostic capacitor-network AC only
C11 0 FILL_L10_0 3.0905200000000001e-17
C12 0 FILL_L10_1 4.0211200000000004e-17
C13 0 FILL_L10_2 4.0211200000000004e-17
C14 0 FILL_L10_3 4.0211200000000004e-17
C15 0 FILL_L10_4 9.3060300000000004e-18
C16 0 FILL_L30_0 6.454010000000001e-18
C17 0 FILL_L30_1 2.91144e-16
C18 0 FILL_L30_10 1.3544200000000002e-16
C19 0 FILL_L30_3 6.454010000000001e-18
C20 0 FILL_L30_4 2.9761000000000002e-16
C21 0 FILL_L30_6 6.454010000000001e-18
C22 0 FILL_L30_7 2.9761000000000002e-16
C23 0 FILL_L30_9 3.6237699999999999e-18
C24 0 FILL_L8_1 2.4337500000000004e-16
C25 0 FILL_L8_10 3.1992300000000003e-16
C26 0 FILL_L8_11 4.4157700000000008e-18
C27 0 FILL_L8_13 7.6547100000000011e-17
C28 0 FILL_L8_14 1.02194e-18
C29 0 FILL_L8_2 3.3938400000000001e-18
C30 0 FILL_L8_4 3.1992300000000003e-16
C31 0 FILL_L8_5 4.4157700000000008e-18
C32 0 FILL_L8_7 3.1992300000000003e-16
C33 0 FILL_L8_8 4.4157700000000008e-18
C42 0 FILL_L30_1 1.01523e-16
C43 0 FILL_L30_10 4.5939100000000008e-17
C44 0 FILL_L30_11 3.4446000000000001e-18
C45 0 FILL_L30_2 7.6123800000000002e-18
C46 0 FILL_L30_4 1.01523e-16
C47 0 FILL_L30_5 7.6123800000000002e-18
C48 0 FILL_L30_7 1.01523e-16
C49 0 FILL_L30_8 7.6123800000000002e-18
C50 0 FILL_L8_1 1.1858800000000002e-17
C51 0 FILL_L8_10 1.54297e-17
C52 0 FILL_L8_11 2.14778e-16
C53 0 FILL_L8_13 3.5708700000000008e-18
C54 0 FILL_L8_14 5.2213800000000002e-17
C55 0 FILL_L8_2 1.6256500000000001e-16
C56 0 FILL_L8_4 1.54297e-17
C57 0 FILL_L8_5 2.14778e-16
C58 0 FILL_L8_7 1.54297e-17
C59 0 FILL_L8_8 2.14778e-16
C65 0 FILL_L30_1 6.9818800000000003e-18
C66 0 FILL_L30_10 3.1593000000000002e-18
C67 0 FILL_L30_11 1.1523700000000001e-17
C68 0 FILL_L30_2 2.5466800000000001e-17
C69 0 FILL_L30_4 6.9818800000000003e-18
C70 0 FILL_L30_5 2.5466800000000001e-17
C71 0 FILL_L30_7 6.9818800000000003e-18
C72 0 FILL_L30_8 2.5466800000000001e-17
C73 0 FILL_L8_11 1.9203800000000003e-16
C74 0 FILL_L8_14 4.6951100000000003e-17
C75 0 FILL_L8_2 1.45087e-16
C76 0 FILL_L8_5 1.9203800000000003e-16
C77 0 FILL_L8_8 1.9203800000000003e-16
C84 0 FILL_L30_1 2.2902200000000002e-18
C85 0 FILL_L30_10 1.0363199999999999e-18
C86 0 FILL_L30_11 4.0618400000000006e-17
C87 0 FILL_L30_2 8.5676700000000009e-17
C88 0 FILL_L30_4 2.2902200000000002e-18
C89 0 FILL_L30_5 8.8909700000000004e-17
C90 0 FILL_L30_7 2.2902200000000002e-18
C91 0 FILL_L30_8 8.8909700000000004e-17
C92 0 FILL_L8_11 1.4087300000000001e-16
C93 0 FILL_L8_14 3.5110000000000005e-17
C94 0 FILL_L8_2 1.0576300000000002e-16
C95 0 FILL_L8_5 1.4087300000000001e-16
C96 0 FILL_L8_8 1.4087300000000001e-16
C97 0 N 3.2510800000000007e-17
C104 0 FILL_L30_11 1.0750700000000002e-16
C105 0 FILL_L30_2 2.29409e-16
C106 0 FILL_L30_5 2.3587399999999999e-16
C107 0 FILL_L30_8 2.3587399999999999e-16
C108 0 FILL_L8_11 2.0315199999999999e-16
C109 0 FILL_L8_14 4.9523100000000004e-17
C110 0 FILL_L8_2 1.53629e-16
C111 0 FILL_L8_5 2.0315199999999999e-16
C112 0 FILL_L8_8 2.0315199999999999e-16
C113 0 N 2.8625000000000003e-17
C114 0 P 9.4825500000000004e-18
C124 0 FILL_L30_11 1.1961600000000001e-16
C125 0 FILL_L30_2 2.5616900000000001e-16
C126 0 FILL_L30_5 2.6263500000000003e-16
C127 0 FILL_L30_8 2.6263500000000003e-16
C128 0 FILL_L8_11 1.7880700000000001e-17
C129 0 FILL_L8_14 4.1381000000000003e-18
C130 0 FILL_L8_2 1.3742600000000001e-17
C131 0 FILL_L8_5 1.7880700000000001e-17
C132 0 FILL_L8_8 1.7880700000000001e-17
C133 0 P 4.5911500000000004e-18
C156 0 FILL_L30_11 3.6723300000000005e-17
C157 0 FILL_L30_2 8.1156400000000016e-17
C158 0 FILL_L30_5 8.1156400000000016e-17
C159 0 FILL_L30_8 8.1080500000000012e-17
C160 0 FILL_L8_11 1.2881900000000001e-18
C161 0 FILL_L8_14 2.98125e-19
C162 0 FILL_L8_2 9.2013800000000015e-19
C163 0 FILL_L8_5 1.2881900000000001e-18
C164 0 FILL_L8_8 1.2881900000000001e-18
C183 0 FILL_L10_0 1.52077e-18
C184 0 FILL_L10_1 1.60081e-17
C185 0 FILL_L10_2 1.60081e-17
C186 0 FILL_L10_3 1.2006100000000001e-17
C187 0 FILL_L30_0 3.2677e-17
C188 0 FILL_L30_1 1.48664e-16
C189 0 FILL_L30_10 7.1012800000000008e-17
C190 0 FILL_L30_11 3.1306499999999999e-17
C191 0 FILL_L30_2 6.91856e-17
C192 0 FILL_L30_3 3.2677e-17
C193 0 FILL_L30_4 1.55367e-16
C194 0 FILL_L30_5 6.91856e-17
C195 0 FILL_L30_6 3.2677e-17
C196 0 FILL_L30_7 1.55367e-16
C197 0 FILL_L30_8 6.91856e-17
C198 0 FILL_L30_9 1.47819e-17
C199 0 FILL_L8_1 1.1108900000000001e-17
C200 0 FILL_L8_10 3.1011000000000002e-17
C201 0 FILL_L8_11 3.73833e-17
C202 0 FILL_L8_13 2.5889400000000003e-18
C203 0 FILL_L8_14 6.7062400000000003e-18
C204 0 FILL_L8_2 2.2248100000000001e-17
C205 0 FILL_L8_4 3.7619100000000003e-17
C206 0 FILL_L8_5 4.0600400000000005e-17
C207 0 FILL_L8_7 3.7619100000000003e-17
C208 0 FILL_L8_8 4.0600400000000005e-17
C209 0 N 4.2665500000000008e-17
C210 0 P 3.5607700000000002e-17
C238 0 FILL_L30_11 5.3470500000000005e-17
C239 0 FILL_L30_2 1.16216e-16
C240 0 FILL_L30_5 1.1809600000000002e-16
C241 0 FILL_L30_8 1.18065e-16
C242 0 FILL_L8_11 2.4858200000000002e-17
C243 0 FILL_L8_14 3.9746199999999999e-18
C244 0 FILL_L8_2 1.3955500000000003e-17
C245 0 FILL_L8_5 2.7419600000000002e-17
C246 0 FILL_L8_8 2.7419600000000002e-17
C247 0 N 2.6993700000000001e-17
C248 0 P 3.2462000000000005e-17
C251 0 FILL_L10_0 4.7243500000000006e-18
C252 0 FILL_L10_1 4.9730000000000003e-17
C253 0 FILL_L10_2 4.9730000000000003e-17
C254 0 FILL_L10_3 3.7297500000000004e-17
C255 0 FILL_L30_0 2.4912600000000005e-16
C256 0 FILL_L30_3 2.5435000000000003e-16
C257 0 FILL_L30_6 2.5435000000000003e-16
C258 0 FILL_L30_9 1.1564300000000002e-16
C259 0 FILL_L50_0 1.8048800000000002e-17
C260 0 FILL_L50_1 1.8048800000000002e-17
C261 0 FILL_L50_2 1.8048800000000002e-17
C262 0 FILL_L50_3 1.8048800000000002e-17
C263 0 FILL_L50_4 1.8048800000000002e-17
C264 0 FILL_L50_5 1.8048800000000002e-17
C265 0 FILL_L50_6 1.8048800000000002e-17
C266 0 FILL_L8_0 1.1335600000000002e-19
C267 0 FILL_L8_1 1.03528e-19
C268 0 FILL_L8_10 8.1732300000000011e-19
C269 0 FILL_L8_3 1.1932300000000001e-18
C270 0 FILL_L8_4 1.08976e-18
C271 0 FILL_L8_6 1.1932300000000001e-18
C272 0 FILL_L8_7 1.08976e-18
C273 0 FILL_L8_9 8.949200000000002e-19
C276 0 FILL_L10_0 3.7151499999999998e-18
C277 0 FILL_L10_1 4.8338400000000009e-18
C278 0 FILL_L10_2 4.8338400000000009e-18
C279 0 FILL_L10_3 4.8338400000000009e-18
C280 0 FILL_L10_4 1.1186900000000001e-18
C281 0 FILL_L30_0 3.4239300000000005e-17
C282 0 FILL_L30_1 4.7835400000000005e-18
C283 0 FILL_L30_10 2.1645500000000002e-18
C284 0 FILL_L30_3 3.4239300000000005e-17
C285 0 FILL_L30_4 4.7835400000000005e-18
C286 0 FILL_L30_6 3.4239300000000005e-17
C287 0 FILL_L30_7 4.7835400000000005e-18
C288 0 FILL_L30_9 1.5493300000000001e-17
C289 0 FILL_L8_0 1.5387599999999999e-18
C290 0 FILL_L8_1 1.5630500000000001e-18
C291 0 FILL_L8_10 2.0337100000000003e-18
C292 0 FILL_L8_12 4.6334399999999997e-19
C293 0 FILL_L8_13 4.7065900000000001e-19
C294 0 FILL_L8_3 2.0021000000000003e-18
C295 0 FILL_L8_4 2.0337100000000003e-18
C296 0 FILL_L8_6 2.0021000000000003e-18
C297 0 FILL_L8_7 2.0337100000000003e-18
C298 0 FILL_L8_9 2.0021000000000003e-18
C303 0 FILL_L30_1 9.8875000000000007e-18
C304 0 FILL_L30_10 4.474090000000001e-18
C305 0 FILL_L30_11 4.9596300000000002e-18
C306 0 FILL_L30_2 1.0960500000000001e-17
C307 0 FILL_L30_4 9.8875000000000007e-18
C308 0 FILL_L30_5 1.0960500000000001e-17
C309 0 FILL_L30_7 9.8875000000000007e-18
C310 0 FILL_L30_8 1.0960500000000001e-17
C311 0 FILL_L8_11 2.6760900000000001e-17
C312 0 FILL_L8_14 6.6526700000000001e-18
C313 0 FILL_L8_2 2.0108200000000002e-17
C314 0 FILL_L8_5 2.6760900000000001e-17
C315 0 FILL_L8_8 2.6760900000000001e-17
C317 0 FILL_L30_1 5.6403900000000007e-18
C318 0 FILL_L30_10 2.5522700000000003e-18
C319 0 FILL_L30_11 2.8954699999999999e-17
C320 0 FILL_L30_2 6.3988200000000009e-17
C321 0 FILL_L30_4 5.6403900000000007e-18
C322 0 FILL_L30_5 6.3988200000000009e-17
C323 0 FILL_L30_7 5.6403900000000007e-18
C324 0 FILL_L30_8 6.3988200000000009e-17
C325 0 FILL_L8_11 1.8460200000000003e-17
C326 0 FILL_L8_14 3.5354900000000004e-18
C327 0 FILL_L8_2 1.2144500000000002e-17
C328 0 FILL_L8_5 1.9521400000000002e-17
C329 0 FILL_L8_8 1.9521400000000002e-17
C330 0 N 1.2964900000000001e-15
C334 0 FILL_L30_11 7.4595000000000007e-17
C335 0 FILL_L30_2 1.5824600000000001e-16
C336 0 FILL_L30_5 1.6347000000000002e-16
C337 0 FILL_L30_8 1.6347000000000002e-16
C338 0 FILL_L8_11 7.04443e-18
C339 0 FILL_L8_14 2.1452200000000002e-19
C340 0 FILL_L8_2 8.3910100000000002e-19
C341 0 FILL_L8_5 9.0734900000000006e-18
C342 0 FILL_L8_8 9.0734900000000006e-18
C343 0 P 3.4877500000000003e-15
C347 0 FILL_L30_11 7.4595000000000007e-17
C348 0 FILL_L30_2 1.5824600000000001e-16
C349 0 FILL_L30_5 1.6347000000000002e-16
C350 0 FILL_L30_8 1.6347000000000002e-16
C351 0 FILL_L8_11 8.9074000000000012e-19
C352 0 FILL_L8_2 1.12827e-19
C353 0 FILL_L8_5 1.1876500000000002e-18
C354 0 FILL_L8_8 1.1876500000000002e-18
C358 0 FILL_L30_11 1.15266e-16
C359 0 FILL_L30_2 2.4812600000000003e-16
C360 0 FILL_L30_5 2.5335000000000001e-16
C361 0 FILL_L30_8 2.5335000000000001e-16
C362 0 FILL_L8_11 8.4939500000000011e-19
C363 0 FILL_L8_2 1.0759000000000002e-19
C364 0 FILL_L8_5 1.1325300000000001e-18
C365 0 FILL_L8_8 1.1325300000000001e-18
C369 0 FILL_L30_11 9.8307800000000003e-17
C370 0 FILL_L30_2 2.10569e-16
C371 0 FILL_L30_5 2.1587400000000001e-16
C372 0 FILL_L30_8 2.1584700000000002e-16
C373 0 FILL_L8_11 6.3298400000000003e-19
C374 0 FILL_L8_5 8.4397900000000014e-19
C375 0 FILL_L8_8 8.4397900000000014e-19
C378 0 FILL_L30_11 1.5493300000000001e-17
C379 0 FILL_L30_2 3.4239300000000005e-17
C380 0 FILL_L30_5 3.4239300000000005e-17
C381 0 FILL_L30_8 3.4177999999999998e-17
C385 0 FILL_L30_11 6.12892e-18
C386 0 FILL_L30_2 1.3544600000000001e-17
C387 0 FILL_L30_5 1.3544600000000001e-17
C388 0 FILL_L30_8 1.3510700000000002e-17
C389 0 FILL_L8_11 1.13984e-18
C390 0 FILL_L8_14 2.6379200000000005e-19
C391 0 FILL_L8_2 8.1417400000000005e-19
C392 0 FILL_L8_5 1.13984e-18
C393 0 FILL_L8_8 1.13984e-18
C396 0 FILL_L10_0 3.1223700000000004e-18
C397 0 FILL_L10_1 4.0625600000000005e-18
C398 0 FILL_L10_2 4.0625600000000005e-18
C399 0 FILL_L10_3 4.0625600000000005e-18
C400 0 FILL_L10_4 9.4019400000000005e-19
C401 0 FILL_L30_0 1.3544600000000001e-17
C402 0 FILL_L30_1 8.1080500000000005e-18
C403 0 FILL_L30_10 3.6688900000000008e-18
C404 0 FILL_L30_3 1.3544600000000001e-17
C405 0 FILL_L30_4 8.1080500000000005e-18
C406 0 FILL_L30_6 1.3544600000000001e-17
C407 0 FILL_L30_7 8.1080500000000005e-18
C408 0 FILL_L30_9 6.12892e-18
C409 0 FILL_L8_0 1.43099e-18
C410 0 FILL_L8_1 5.3845800000000004e-18
C411 0 FILL_L8_10 7.0059600000000006e-18
C412 0 FILL_L8_12 4.3089200000000001e-19
C413 0 FILL_L8_13 1.6213800000000002e-18
C414 0 FILL_L8_3 1.8618800000000002e-18
C415 0 FILL_L8_4 7.0059600000000006e-18
C416 0 FILL_L8_6 1.8618800000000002e-18
C417 0 FILL_L8_7 7.0059600000000006e-18
C418 0 FILL_L8_9 1.8618800000000002e-18
C422 0 FILL_L30_11 1.9458500000000003e-18
C423 0 FILL_L30_2 4.38922e-18
C424 0 FILL_L30_5 4.422380000000001e-18
C425 0 FILL_L30_8 4.4113300000000005e-18
C426 0 FILL_L8_11 2.6689400000000004e-19
C427 0 FILL_L8_2 1.9063900000000002e-19
C428 0 FILL_L8_5 2.6689400000000004e-19
C429 0 FILL_L8_8 1.5251100000000003e-19
C446 0 FILL_L30_11 6.5731200000000007e-19
C447 0 FILL_L30_2 1.4266700000000003e-18
C448 0 FILL_L30_5 1.4938900000000001e-18
C449 0 FILL_L30_8 1.4901600000000001e-18
C466 0 FILL_L10_0 2.5345000000000003e-18
C467 0 FILL_L10_1 3.2976800000000003e-18
C468 0 FILL_L10_2 3.2976800000000003e-18
C469 0 FILL_L10_3 3.2976800000000003e-18
C470 0 FILL_L10_4 7.6317800000000006e-19
C471 0 FILL_L30_0 7.3730700000000005e-18
C472 0 FILL_L30_1 1.5077100000000001e-17
C473 0 FILL_L30_10 6.8223700000000008e-18
C474 0 FILL_L30_3 7.3730700000000005e-18
C475 0 FILL_L30_4 1.5077100000000001e-17
C476 0 FILL_L30_6 7.3730700000000005e-18
C477 0 FILL_L30_7 1.5077100000000001e-17
C478 0 FILL_L30_9 3.3363100000000002e-18
C479 0 FILL_L8_1 1.8016e-17
C480 0 FILL_L8_10 2.4038700000000001e-17
C481 0 FILL_L8_13 6.0226900000000006e-18
C482 0 FILL_L8_4 2.4038700000000001e-17
C483 0 FILL_L8_7 2.4038700000000001e-17
C486 0 FILL_L10_0 2.0323700000000001e-18
C487 0 FILL_L10_1 2.6443500000000005e-18
C488 0 FILL_L10_2 2.6443500000000005e-18
C489 0 FILL_L10_3 2.6443500000000005e-18
C490 0 FILL_L10_4 6.1197800000000005e-19
C491 0 FILL_L30_0 4.422380000000001e-18
C492 0 FILL_L30_1 4.96112e-17
C493 0 FILL_L30_10 2.2449100000000002e-17
C494 0 FILL_L30_3 4.422380000000001e-18
C495 0 FILL_L30_4 4.96112e-17
C496 0 FILL_L30_6 4.422380000000001e-18
C497 0 FILL_L30_7 4.96112e-17
C498 0 FILL_L30_9 2.0011300000000001e-18
C499 0 FILL_L8_1 1.7384400000000001e-17
C500 0 FILL_L8_10 2.4581800000000003e-17
C501 0 FILL_L8_13 5.7701500000000008e-18
C502 0 FILL_L8_4 2.5126600000000003e-17
C503 0 FILL_L8_7 2.5126600000000003e-17
C506 0 FILL_L10_0 1.1527700000000001e-19
C507 0 FILL_L10_1 1.2134400000000001e-18
C508 0 FILL_L10_2 1.2134400000000001e-18
C509 0 FILL_L10_3 9.100810000000001e-19
C510 0 FILL_L30_1 2.2480099999999999e-16
C511 0 FILL_L30_10 1.0471100000000001e-16
C512 0 FILL_L30_4 2.3002400000000001e-16
C513 0 FILL_L30_7 2.3002400000000001e-16
C514 0 FILL_L8_1 5.1599100000000003e-18
C515 0 FILL_L8_10 2.1710400000000001e-17
C516 0 FILL_L8_13 1.1506799999999999e-18
C517 0 FILL_L8_4 2.7277200000000002e-17
C518 0 FILL_L8_7 2.7277200000000002e-17
C521 0 FILL_L30_1 3.0659400000000004e-16
C522 0 FILL_L30_10 1.4172200000000002e-16
C523 0 FILL_L30_4 3.1181700000000005e-16
C524 0 FILL_L30_7 3.1181700000000005e-16
C525 0 FILL_L8_1 3.0629300000000005e-18
C526 0 FILL_L8_10 2.4480100000000003e-17
C527 0 FILL_L8_13 2.6815299999999997e-19
C528 0 FILL_L8_4 3.2241300000000007e-17
C529 0 FILL_L8_7 3.2241300000000007e-17
C532 0 FILL_L30_1 3.0659400000000004e-16
C533 0 FILL_L30_10 1.4172200000000002e-16
C534 0 FILL_L30_4 3.1181700000000005e-16
C535 0 FILL_L30_7 3.1181700000000005e-16
C536 0 FILL_L8_1 1.1661500000000001e-18
C537 0 FILL_L8_10 9.2064100000000003e-18
C538 0 FILL_L8_11 7.8927700000000007e-19
C539 0 FILL_L8_4 1.2275200000000001e-17
C540 0 FILL_L8_5 1.0523700000000001e-18
C541 0 FILL_L8_7 1.2275200000000001e-17
C542 0 FILL_L8_8 1.0523700000000001e-18
C546 0 FILL_L30_1 1.70033e-16
C547 0 FILL_L30_10 7.7238900000000012e-17
C548 0 FILL_L30_11 1.5640900000000001e-18
C549 0 FILL_L30_2 3.4565600000000004e-18
C550 0 FILL_L30_4 1.7055600000000003e-16
C551 0 FILL_L30_5 3.4565600000000004e-18
C552 0 FILL_L30_7 1.7055600000000003e-16
C553 0 FILL_L30_8 3.4565600000000004e-18
C554 0 FILL_L8_11 1.7974100000000001e-17
C555 0 FILL_L8_14 4.573210000000001e-18
C556 0 FILL_L8_2 1.3400900000000001e-17
C557 0 FILL_L8_4 1.02657e-19
C558 0 FILL_L8_5 1.8094500000000002e-17
C559 0 FILL_L8_7 1.02657e-19
C560 0 FILL_L8_8 1.8094500000000002e-17
C562 0 FILL_L30_1 1.8617000000000002e-17
C563 0 FILL_L30_10 8.4241900000000005e-18
C564 0 FILL_L30_11 2.7827600000000002e-18
C565 0 FILL_L30_2 6.1497500000000007e-18
C566 0 FILL_L30_4 1.8617000000000002e-17
C567 0 FILL_L30_5 6.1497500000000007e-18
C568 0 FILL_L30_7 1.8617000000000002e-17
C569 0 FILL_L30_8 6.1497500000000007e-18
C570 0 FILL_L8_11 1.5276800000000002e-17
C571 0 FILL_L8_14 3.5354900000000004e-18
C572 0 FILL_L8_2 1.1741300000000001e-17
C573 0 FILL_L8_5 1.5276800000000002e-17
C574 0 FILL_L8_8 1.5276800000000002e-17
C578 0 FILL_L30_2 2.9637200000000006e-19
C582 0 FILL_L30_2 2.9637200000000006e-19
C589 0 FILL_L30_1 1.8274000000000002e-19
C590 0 FILL_L30_10 1.2182600000000002e-19
C591 0 FILL_L30_11 1.3899200000000001e-17
C592 0 FILL_L30_2 3.0000500000000003e-17
C593 0 FILL_L30_4 1.8274000000000002e-19
C594 0 FILL_L30_5 3.0059499999999999e-17
C595 0 FILL_L30_7 1.8274000000000002e-19
C596 0 FILL_L30_8 3.0039800000000003e-17
C597 0 FILL_L8_11 2.4158700000000001e-17
C598 0 FILL_L8_14 5.5910000000000005e-18
C599 0 FILL_L8_2 1.85677e-17
C600 0 FILL_L8_5 2.4158700000000001e-17
C601 0 FILL_L8_8 2.4158700000000001e-17
C602 0 P 1.0883400000000001e-19
C613 0 FILL_L30_11 8.4194000000000004e-19
C614 0 FILL_L30_2 1.8273900000000003e-18
C615 0 FILL_L30_5 1.9135000000000003e-18
C616 0 FILL_L30_8 1.90872e-18
C618 0 FILL_L30_11 2.9637200000000006e-19
C621 0 FILL_L30_2 2.9637200000000006e-19
C626 0 FILL_L30_5 2.9637200000000006e-19
C629 0 FILL_L30_5 2.9637200000000006e-19
C634 0 FILL_L30_8 2.9637200000000006e-19
C637 0 FILL_L30_8 2.9637200000000006e-19
C640 FILL_L10_0 FILL_L10_1 7.7660000000000001e-17
C641 FILL_L10_0 FILL_L30_0 6.0454500000000004e-16
C642 FILL_L10_0 FILL_L30_1 5.3330100000000006e-18
C643 FILL_L10_0 FILL_L50_0 6.8228999999999999e-19
C644 FILL_L10_0 FILL_L8_0 5.0272200000000005e-16
C645 FILL_L10_0 FILL_L8_1 2.31346e-17
C646 FILL_L10_0 0 2.6701100000000004e-16
C647 FILL_L10_1 FILL_L10_2 7.7660000000000001e-17
C648 FILL_L10_1 FILL_L30_0 1.9026200000000002e-16
C649 FILL_L10_1 FILL_L30_3 4.9275800000000001e-16
C650 FILL_L10_1 FILL_L30_4 3.1998100000000002e-18
C651 FILL_L10_1 FILL_L50_1 5.8108700000000012e-18
C652 FILL_L10_1 FILL_L50_2 5.8108700000000012e-18
C653 FILL_L10_1 FILL_L8_3 6.540990000000001e-16
C654 FILL_L10_1 FILL_L8_4 3.0100800000000002e-17
C655 FILL_L10_1 0 2.4877500000000003e-16
C656 FILL_L10_2 FILL_L10_3 7.7660000000000001e-17
C657 FILL_L10_2 FILL_L30_3 3.9192600000000002e-16
C658 FILL_L10_2 FILL_L30_4 2.1332000000000003e-18
C659 FILL_L10_2 FILL_L30_6 2.9109400000000003e-16
C660 FILL_L10_2 FILL_L30_7 1.0666000000000002e-18
C661 FILL_L10_2 FILL_L50_3 5.8108700000000012e-18
C662 FILL_L10_2 FILL_L50_4 5.8108700000000012e-18
C663 FILL_L10_2 FILL_L8_6 6.540990000000001e-16
C664 FILL_L10_2 FILL_L8_7 3.0100800000000002e-17
C665 FILL_L10_2 0 2.4877500000000003e-16
C666 FILL_L10_3 FILL_L10_4 7.7660000000000001e-17
C667 FILL_L10_3 FILL_L30_6 5.8387400000000003e-16
C668 FILL_L10_3 FILL_L30_7 4.2664099999999996e-18
C669 FILL_L10_3 FILL_L30_9 9.4035100000000003e-17
C670 FILL_L10_3 FILL_L50_5 4.7214500000000004e-18
C671 FILL_L10_3 FILL_L50_6 4.0418500000000006e-18
C672 FILL_L10_3 FILL_L8_10 3.0100800000000002e-17
C673 FILL_L10_3 FILL_L8_9 6.540990000000001e-16
C674 FILL_L10_3 0 2.4877500000000003e-16
C675 FILL_L10_4 FILL_L30_10 1.7278900000000001e-18
C676 FILL_L10_4 FILL_L30_9 2.2799300000000003e-16
C677 FILL_L10_4 FILL_L8_12 1.5137700000000003e-16
C678 FILL_L10_4 FILL_L8_13 6.9661799999999997e-18
C679 FILL_L10_4 0 1.7524100000000003e-16
C680 FILL_L30_0 FILL_L30_1 7.7092600000000011e-17
C681 FILL_L30_0 FILL_L30_3 6.3215900000000006e-17
C682 FILL_L30_0 FILL_L50_0 7.3982799999999997e-17
C683 FILL_L30_0 FILL_L50_1 7.3982799999999997e-17
C684 FILL_L30_0 FILL_L8_0 2.9924300000000003e-17
C685 FILL_L30_0 FILL_L8_1 2.7929800000000004e-17
C686 FILL_L30_0 FILL_L8_3 2.2382600000000003e-17
C687 FILL_L30_0 0 3.4126100000000006e-16
C688 FILL_L30_1 FILL_L30_2 7.7092600000000011e-17
C689 FILL_L30_1 FILL_L30_4 7.7092600000000011e-17
C690 FILL_L30_1 FILL_L8_1 2.07974e-16
C691 FILL_L30_1 FILL_L8_2 6.0650500000000006e-17
C692 FILL_L30_1 FILL_L8_4 6.7135599999999996e-17
C693 FILL_L30_1 0 3.0389100000000006e-16
C694 FILL_L30_10 FILL_L30_11 3.4884400000000002e-17
C695 FILL_L30_10 FILL_L30_7 7.7092600000000011e-17
C696 FILL_L30_10 FILL_L30_9 3.4884400000000002e-17
C697 FILL_L30_10 FILL_L8_10 4.5396500000000003e-17
C698 FILL_L30_10 FILL_L8_13 7.2760199999999999e-17
C699 FILL_L30_10 FILL_L8_14 1.96508e-17
C700 FILL_L30_10 0 2.40264e-16
C701 FILL_L30_11 FILL_L30_8 7.7092600000000011e-17
C702 FILL_L30_11 FILL_L8_11 2.36851e-17
C703 FILL_L30_11 FILL_L8_14 5.0597200000000004e-17
C704 FILL_L30_11 N 8.1406500000000002e-17
C705 FILL_L30_11 P 7.4595000000000007e-17
C706 FILL_L30_11 0 2.8270800000000003e-16
C707 FILL_L30_2 FILL_L30_5 7.7092600000000011e-17
C708 FILL_L30_2 FILL_L8_2 1.4750600000000001e-16
C709 FILL_L30_2 FILL_L8_5 3.5027200000000004e-17
C710 FILL_L30_2 N 1.7329900000000001e-16
C711 FILL_L30_2 P 1.5824600000000001e-16
C712 FILL_L30_2 0 4.0882600000000006e-16
C713 FILL_L30_3 FILL_L30_4 7.7092600000000011e-17
C714 FILL_L30_3 FILL_L30_6 6.3215900000000006e-17
C715 FILL_L30_3 FILL_L50_2 7.3982799999999997e-17
C716 FILL_L30_3 FILL_L50_3 7.3982799999999997e-17
C717 FILL_L30_3 FILL_L8_3 2.69076e-17
C718 FILL_L30_3 FILL_L8_4 1.6757899999999999e-17
C719 FILL_L30_3 FILL_L8_6 2.5399300000000003e-17
C720 FILL_L30_3 FILL_L8_7 1.1171900000000001e-17
C721 FILL_L30_3 0 2.4848800000000004e-16
C722 FILL_L30_4 FILL_L30_5 7.7092600000000011e-17
C723 FILL_L30_4 FILL_L30_7 7.7092600000000011e-17
C724 FILL_L30_4 FILL_L8_4 1.77384e-16
C725 FILL_L30_4 FILL_L8_5 3.6390300000000006e-17
C726 FILL_L30_4 FILL_L8_7 1.40634e-16
C727 FILL_L30_4 FILL_L8_8 2.4260200000000003e-17
C728 FILL_L30_4 0 2.0103700000000003e-16
C729 FILL_L30_5 FILL_L30_8 7.7092600000000011e-17
C730 FILL_L30_5 FILL_L8_5 1.1594700000000001e-16
C731 FILL_L30_5 FILL_L8_8 8.8973700000000006e-17
C732 FILL_L30_5 N 1.7852300000000002e-16
C733 FILL_L30_5 P 1.6347000000000002e-16
C734 FILL_L30_5 0 3.1573900000000001e-16
C735 FILL_L30_6 FILL_L30_7 7.7092600000000011e-17
C736 FILL_L30_6 FILL_L30_9 6.3215900000000006e-17
C737 FILL_L30_6 FILL_L50_4 7.3982799999999997e-17
C738 FILL_L30_6 FILL_L50_5 7.3982799999999997e-17
C739 FILL_L30_6 FILL_L8_10 2.2343800000000003e-17
C740 FILL_L30_6 FILL_L8_6 2.3891e-17
C741 FILL_L30_6 FILL_L8_7 5.5859600000000004e-18
C742 FILL_L30_6 FILL_L8_9 2.84159e-17
C743 FILL_L30_6 0 2.5663500000000003e-16
C744 FILL_L30_7 FILL_L30_8 7.7092600000000011e-17
C745 FILL_L30_7 FILL_L8_10 2.0501800000000002e-16
C746 FILL_L30_7 FILL_L8_11 4.8520400000000006e-17
C747 FILL_L30_7 FILL_L8_7 1.0388500000000001e-16
C748 FILL_L30_7 FILL_L8_8 1.2130100000000001e-17
C749 FILL_L30_7 0 2.0777800000000001e-16
C750 FILL_L30_8 FILL_L8_11 1.38165e-16
C751 FILL_L30_8 FILL_L8_8 6.2000500000000005e-17
C752 FILL_L30_8 N 1.7852300000000002e-16
C753 FILL_L30_8 P 1.6347000000000002e-16
C754 FILL_L30_8 0 3.1910800000000004e-16
C755 FILL_L30_9 FILL_L50_6 7.0353499999999998e-17
C756 FILL_L30_9 FILL_L8_12 1.84298e-17
C757 FILL_L30_9 FILL_L8_13 9.0492500000000014e-18
C758 FILL_L30_9 FILL_L8_9 1.39963e-17
C759 FILL_L30_9 0 2.3809600000000004e-16
C760 FILL_L50_0 FILL_L50_1 6.9198000000000007e-18
C761 FILL_L50_0 0 3.6939200000000004e-17
C762 FILL_L50_1 FILL_L50_2 6.9198000000000007e-18
C763 FILL_L50_1 0 2.9082999999999998e-17
C764 FILL_L50_2 FILL_L50_3 6.9198000000000007e-18
C765 FILL_L50_2 0 2.9082999999999998e-17
C766 FILL_L50_3 FILL_L50_4 6.9198000000000007e-18
C767 FILL_L50_3 0 2.9082999999999998e-17
C768 FILL_L50_4 FILL_L50_5 6.9198000000000007e-18
C769 FILL_L50_4 0 2.9082999999999998e-17
C770 FILL_L50_5 FILL_L50_6 6.9198000000000007e-18
C771 FILL_L50_5 0 2.9773200000000004e-17
C772 FILL_L50_6 0 3.6763700000000004e-17
C773 FILL_L8_0 FILL_L8_1 5.3567000000000005e-17
C774 FILL_L8_0 FILL_L8_3 5.5359200000000004e-17
C775 FILL_L8_0 0 6.041810000000001e-16
C776 FILL_L8_1 FILL_L8_2 5.3567000000000005e-17
C777 FILL_L8_1 FILL_L8_4 6.96968e-17
C778 FILL_L8_1 0 6.7244100000000005e-16
C779 FILL_L8_10 FILL_L8_11 6.96968e-17
C780 FILL_L8_10 FILL_L8_13 6.96968e-17
C781 FILL_L8_10 FILL_L8_7 6.96968e-17
C782 FILL_L8_10 FILL_L8_9 6.96968e-17
C783 FILL_L8_10 0 7.5091400000000008e-16
C784 FILL_L8_11 FILL_L8_14 6.96968e-17
C785 FILL_L8_11 FILL_L8_8 6.96968e-17
C786 FILL_L8_11 N 1.3975199999999999e-17
C787 FILL_L8_11 P 1.1034900000000001e-17
C788 FILL_L8_11 0 7.9409500000000004e-16
C789 FILL_L8_12 FILL_L8_13 1.6129800000000002e-17
C790 FILL_L8_12 FILL_L8_9 5.5359200000000004e-17
C791 FILL_L8_12 0 3.0352200000000003e-16
C792 FILL_L8_13 FILL_L8_14 1.6129800000000002e-17
C793 FILL_L8_13 0 3.5556799999999999e-16
C794 FILL_L8_14 N 1.71904e-18
C795 FILL_L8_14 P 2.6815299999999997e-19
C796 FILL_L8_14 0 3.6556099999999999e-16
C797 FILL_L8_2 FILL_L8_5 6.96968e-17
C798 FILL_L8_2 N 6.5382300000000011e-18
C799 FILL_L8_2 P 1.35987e-18
C800 FILL_L8_2 0 7.0562900000000007e-16
C801 FILL_L8_3 FILL_L8_4 6.96968e-17
C802 FILL_L8_3 FILL_L8_6 5.5359200000000004e-17
C803 FILL_L8_3 0 6.8761100000000006e-16
C804 FILL_L8_4 FILL_L8_5 6.96968e-17
C805 FILL_L8_4 FILL_L8_7 6.96968e-17
C806 FILL_L8_4 0 7.5091400000000008e-16
C807 FILL_L8_5 FILL_L8_8 6.96968e-17
C808 FILL_L8_5 N 1.6157600000000001e-17
C809 FILL_L8_5 P 1.4314400000000001e-17
C810 FILL_L8_5 0 7.9409500000000004e-16
C811 FILL_L8_6 FILL_L8_7 6.96968e-17
C812 FILL_L8_6 FILL_L8_9 5.5359200000000004e-17
C813 FILL_L8_6 0 6.8761100000000006e-16
C814 FILL_L8_7 FILL_L8_8 6.96968e-17
C815 FILL_L8_7 0 7.5091400000000008e-16
C816 FILL_L8_8 N 1.6157600000000001e-17
C817 FILL_L8_8 P 1.4314400000000001e-17
C818 FILL_L8_8 0 7.9409500000000004e-16
C819 FILL_L8_9 0 6.8761100000000006e-16
C820 N P 3.4877500000000003e-15
C821 N 0 2.2133700000000001e-17
C822 P 0 1.4043000000000001e-17
VP P 0 DC 0 AC 0
VN N 0 DC 0 AC 1
.control
set numdgt=17
ac lin 1 1Meg 1Meg
let cp = -imag(i(VP))/(2*pi*1e6)
let cn = -imag(i(VN))/(2*pi*1e6)
print cp cn
quit
.endc
.end
