* actual_fill grounded drive N; diagnostic capacitor-network AC only
C97 0 N 3.2510800000000007e-17
C113 0 N 2.8625000000000003e-17
C114 0 P 9.4825500000000004e-18
C133 0 P 4.5911500000000004e-18
C209 0 N 4.2665500000000008e-17
C210 0 P 3.5607700000000002e-17
C247 0 N 2.6993700000000001e-17
C248 0 P 3.2462000000000005e-17
C330 0 N 1.2964900000000001e-15
C343 0 P 3.4877500000000003e-15
C602 0 P 1.0883400000000001e-19
C704 0 N 8.1406500000000002e-17
C705 0 P 7.4595000000000007e-17
C710 0 N 1.7329900000000001e-16
C711 0 P 1.5824600000000001e-16
C732 0 N 1.7852300000000002e-16
C733 0 P 1.6347000000000002e-16
C752 0 N 1.7852300000000002e-16
C753 0 P 1.6347000000000002e-16
C786 0 N 1.3975199999999999e-17
C787 0 P 1.1034900000000001e-17
C794 0 N 1.71904e-18
C795 0 P 2.6815299999999997e-19
C798 0 N 6.5382300000000011e-18
C799 0 P 1.35987e-18
C808 0 N 1.6157600000000001e-17
C809 0 P 1.4314400000000001e-17
C816 0 N 1.6157600000000001e-17
C817 0 P 1.4314400000000001e-17
C820 N P 3.4877500000000003e-15
C821 N 0 2.2133700000000001e-17
C822 P 0 1.4043000000000001e-17
VP P 0 DC 0 AC 0
VN N 0 DC 0 AC 1
.control
set numdgt=17
ac lin 1 1Meg 1Meg
let cp = -imag(i(VP))/(2*pi*1e6)
let cn = -imag(i(VN))/(2*pi*1e6)
print cp cn
quit
.endc
.end
