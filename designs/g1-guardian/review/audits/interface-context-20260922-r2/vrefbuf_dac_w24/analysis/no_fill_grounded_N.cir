* no_fill grounded drive N; diagnostic capacitor-network AC only
C31 0 N 4.9860800000000002e-17
C38 0 N 9.2488000000000003e-17
C39 0 P 3.0638300000000001e-17
C49 0 P 1.48341e-17
C90 0 N 4.2665500000000008e-17
C91 0 P 3.5607700000000002e-17
C119 0 N 2.6993700000000001e-17
C120 0 P 3.2462000000000005e-17
C130 0 N 1.2964900000000001e-15
C134 0 P 3.4877500000000003e-15
C210 0 P 4.3533600000000005e-18
C238 N P 3.4877500000000003e-15
C239 N 0 1.02187e-16
C240 P 0 1.0802700000000001e-16
VP P 0 DC 0 AC 0
VN N 0 DC 0 AC 1
.control
set numdgt=17
ac lin 1 1Meg 1Meg
let cp = -imag(i(VP))/(2*pi*1e6)
let cn = -imag(i(VN))/(2*pi*1e6)
print cp cn
quit
.endc
.end
