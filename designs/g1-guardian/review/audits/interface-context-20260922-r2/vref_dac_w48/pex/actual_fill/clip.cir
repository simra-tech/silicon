* cell sense_fill_clip
.SUBCKT sense_fill_clip
* net 2 CTX_L8_65
* net 3 CTX_L8_86
* net 4 CTX_L8_62
* net 5 CTX_L8_85
* net 6 FILL_L30_0
* net 7 CTX_L8_81
* net 8 CTX_L8_63
* net 9 CTX_L8_82
* net 10 CTX_L8_83
* net 11 FILL_L30_1
* net 12 CTX_L8_84
* net 13 FILL_L10_0
* net 14 CTX_L8_87
* net 15 CTX_L8_88
* net 16 FILL_L30_2
* net 17 FILL_L10_1
* net 18 FILL_L50_0
* net 19 FILL_L8_0
* net 20 FILL_L10_2
* net 21 FILL_L8_1
* net 22 FILL_L8_2
* net 23 CTX_L8_100
* net 24 FILL_L50_1
* net 25 CTX_L8_101
* net 26 CTX_L8_105
* net 27 CTX_L10_8,CTX_L8_66
* net 28 CTX_L8_70
* net 29 CTX_L8_64
* net 30 CTX_L10_0,CTX_L10_1,CTX_L30_0,CTX_L8_67
* net 31 FILL_L67_0
* net 32 FILL_L50_2
* net 33 FILL_L50_3
* net 34 FILL_L67_1
* net 35 FILL_L30_3
* net 36 FILL_L10_3
* net 37 FILL_L50_4
* net 38 FILL_L10_5
* net 39 FILL_L8_3
* net 40 FILL_L30_4
* net 41 FILL_L67_2
* net 42 FILL_L8_4
* net 43 FILL_L30_5
* net 44 FILL_L67_3
* net 45 FILL_L8_5
* net 46 FILL_L67_4
* net 47 FILL_L30_6
* net 48 FILL_L67_5
* net 49 CTX_L8_91
* net 50 CTX_L8_106
* net 51 FILL_L67_6
* net 52 FILL_L50_5
* net 53 CTX_L8_89
* net 54 CTX_L8_98
* net 55 FILL_L67_7
* net 56 FILL_L50_6
* net 57 CTX_L8_99
* net 58 CTX_L8_90
* net 59 CTX_L8_69
* net 60 CTX_L8_76
* net 61 CTX_L8_73
* net 62 CTX_L8_72
* net 63 CTX_L8_68
* net 64 CTX_L8_74
* net 65 CTX_L10_2,CTX_L30_1,CTX_L8_78
* net 66 CTX_L8_75
* net 67 CTX_L8_77
* net 68 FILL_L10_4
* net 69 CTX_L8_92
* net 70 CTX_L8_93
* net 71 CTX_L8_94
* net 72 CTX_L10_4,CTX_L8_50,CTX_L8_71
* net 73 FILL_L67_8
* net 74 FILL_L50_9
* net 75 CTX_L8_79
* net 76 CTX_L8_80
* net 77 CTX_L10_3,CTX_L30_2,CTX_L8_3
* net 78 CTX_L8_0
* net 79 FILL_L50_10
* net 80 FILL_L67_9
* net 81 FILL_L30_7
* net 82 FILL_L10_6
* net 83 FILL_L50_7
* net 84 FILL_L30_12
* net 85 FILL_L67_10
* net 86 CTX_L50_0
* net 87 CTX_L50_1
* net 88 CTX_L50_2
* net 89 CTX_L50_3
* net 90 CTX_L50_4
* net 91 CTX_L50_5
* net 92 CTX_L10_14
* net 93 CTX_L50_6
* net 94 FILL_L30_13
* net 95 FILL_L67_11
* net 96 CTX_L50_7
* net 97 CTX_L126_1
* net 98 CTX_L50_8
* net 99 CTX_L50_9
* net 100 CTX_L10_15
* net 101 CTX_L50_10
* net 102 CTX_L50_11
* net 103 N
* net 104 P
* net 105 CTX_L10_18
* net 106 CTX_L50_12
* net 107 CTX_L50_13
* net 108 CTX_L50_14
* net 109 CTX_L50_15
* net 110 FILL_L30_14
* net 111 FILL_L67_12
* net 112 CTX_L50_16
* net 113 CTX_L10_19
* net 114 CTX_L50_17
* net 115 CTX_L50_18
* net 116 CTX_L10_20
* net 117 CTX_L126_2
* net 118 CTX_L50_19
* net 119 CTX_L50_20
* net 120 CTX_L8_4
* net 121 CTX_L50_21
* net 122 FILL_L67_13
* net 123 CTX_L8_5
* net 124 CTX_L50_22
* net 125 CTX_L8_102
* net 126 CTX_L8_95
* net 127 FILL_L67_14
* net 128 FILL_L50_8
* net 129 CTX_L8_103
* net 130 CTX_L8_96
* net 131 FILL_L50_13
* net 132 FILL_L67_15
* net 133 CTX_L8_104
* net 134 CTX_L8_97
* net 135 CTX_L126_3
* net 136 CTX_L8_1
* net 137 CTX_L8_60
* net 138 CTX_L8_38
* net 139 FILL_L30_8
* net 140 CTX_L8_36
* net 141 CTX_L8_37
* net 142 CTX_L8_26
* net 143 CTX_L8_35
* net 144 CTX_L8_49
* net 145 FILL_L30_9
* net 146 CTX_L10_5,CTX_L30_3,CTX_L8_31
* net 147 CTX_L8_34
* net 148 CTX_L8_61
* net 149 CTX_L8_48
* net 150 CTX_L8_28
* net 151 FILL_L30_10
* net 152 CTX_L8_2
* net 153 FILL_L30_15
* net 154 FILL_L30_11
* net 155 FILL_L10_7
* net 156 FILL_L50_14
* net 157 FILL_L50_11
* net 158 FILL_L10_8
* net 159 FILL_L8_6
* net 160 FILL_L8_7
* net 161 FILL_L8_8
* net 162 CTX_L8_7
* net 163 CTX_L8_6
* net 164 FILL_L50_12
* net 165 FILL_L50_15
* net 166 CTX_L8_8
* net 167 CTX_L8_22
* net 168 CTX_L8_23
* net 169 CTX_L8_9
* net 170 CTX_L8_32
* net 171 CTX_L10_6,CTX_L30_4,CTX_L8_46
* net 172 CTX_L8_29
* net 173 CTX_L8_25
* net 174 CTX_L10_9,CTX_L30_6,CTX_L8_24
* net 175 FILL_L50_16
* net 176 FILL_L67_16
* net 177 CTX_L8_33
* net 178 CTX_L8_39
* net 179 CTX_L8_27
* net 180 CTX_L8_30
* net 181 FILL_L50_17
* net 182 FILL_L67_17
* net 183 FILL_L30_16
* net 184 FILL_L10_9
* net 185 FILL_L50_18
* net 186 FILL_L10_12
* net 187 FILL_L8_9
* net 188 FILL_L30_17
* net 189 FILL_L67_18
* net 190 FILL_L8_10
* net 191 FILL_L67_19
* net 192 FILL_L30_18
* net 193 FILL_L8_11
* net 194 FILL_L30_19
* net 195 FILL_L67_20
* net 196 FILL_L67_21
* net 197 CTX_L8_10
* net 198 CTX_L8_13
* net 199 FILL_L67_22
* net 200 FILL_L50_19
* net 201 CTX_L8_11
* net 202 CTX_L8_14
* net 203 FILL_L67_23
* net 204 FILL_L50_20
* net 205 CTX_L8_15
* net 206 CTX_L8_12
* net 207 CTX_L8_43
* net 208 CTX_L8_41
* net 209 CTX_L10_10,CTX_L8_44
* net 210 CTX_L10_11,CTX_L8_47
* net 211 CTX_L10_7,CTX_L30_5
* net 212 CTX_L10_12,CTX_L8_45
* net 213 CTX_L8_40
* net 214 CTX_L10_13,CTX_L8_42
* net 215 CTX_L8_54
* net 216 CTX_L8_56
* net 217 FILL_L10_10
* net 218 CTX_L8_57
* net 219 FILL_L10_11
* net 220 CTX_L8_59
* net 221 FILL_L50_21
* net 222 CTX_L8_16
* net 223 FILL_L50_22
* net 224 CTX_L8_17
* net 225 CTX_L8_18
* net 226 CTX_L8_51
* net 227 FILL_L50_23
* net 228 FILL_L67_24
* net 229 CTX_L8_52
* net 230 CTX_L8_53
* net 231 CTX_L8_55
* net 232 FILL_L67_25
* net 233 FILL_L50_24
* net 234 CTX_L8_58
* net 235 CTX_L126_0,CTX_L134_0
* net 236 FILL_L10_13
* net 237 FILL_L8_12
* net 238 FILL_L67_26
* net 239 FILL_L30_20
* net 240 FILL_L8_13
* net 241 FILL_L30_21
* net 242 FILL_L67_27
* net 243 FILL_L8_14
* net 244 FILL_L30_22
* net 245 FILL_L67_28
* net 246 FILL_L67_29
* net 247 CTX_L8_19
* net 248 FILL_L67_30
* net 249 CTX_L8_20
* net 250 FILL_L67_31
* net 251 FILL_L50_25
* net 252 CTX_L8_21
.ENDS sense_fill_clip
