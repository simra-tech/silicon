* actual_fill grounded drive P; diagnostic capacitor-network AC only
C176 0 N 1.1274000000000001e-15
C194 0 P 3.3182999999999999e-15
C693 0 N 6.714630000000001e-19
C694 0 P 5.3452400000000011e-18
C741 0 P 2.0104e-17
C780 0 P 1.49205e-17
C916 0 N 3.0638300000000001e-17
C932 0 N 9.2488000000000003e-17
C933 0 P 3.3449700000000005e-17
C945 0 P 3.3189300000000006e-17
C1511 0 N 3.6098100000000003e-19
C1512 0 P 4.2307500000000001e-19
C2009 0 N 6.9818800000000003e-18
C2010 0 P 2.2902200000000002e-18
C2016 0 N 2.5466800000000001e-17
C2017 0 P 8.8909700000000004e-17
C2043 0 N 6.9818800000000003e-18
C2044 0 P 2.2902200000000002e-18
C2049 0 N 2.5466800000000001e-17
C2050 0 P 8.8909700000000004e-17
C2067 0 N 2.2167500000000005e-18
C2068 0 P 7.2714500000000005e-19
C2072 0 N 8.0857200000000011e-18
C2073 0 P 2.9714800000000005e-17
C2095 0 N 6.9818800000000003e-18
C2096 0 P 2.2902200000000002e-18
C2100 0 N 2.5466800000000001e-17
C2101 0 P 8.7439400000000006e-17
C2192 0 N 1.9203800000000003e-16
C2193 0 P 1.4087300000000001e-16
C2200 0 N 7.0963100000000007e-17
C2201 0 P 5.2397399999999998e-17
C2204 0 N 1.21075e-16
C2205 0 P 8.8475700000000008e-17
C2214 0 N 1.9203800000000003e-16
C2215 0 P 1.4087300000000001e-16
C2222 0 N 1.9203800000000003e-16
C2223 0 P 1.4087300000000001e-16
C2226 N P 3.3182999999999999e-15
C2227 N 0 9.8231000000000001e-17
C2228 P 0 6.9910900000000009e-17
VP P 0 DC 0 AC 1
VN N 0 DC 0 AC 0
.control
set numdgt=17
ac lin 1 1Meg 1Meg
let cp = -imag(i(VP))/(2*pi*1e6)
let cn = -imag(i(VN))/(2*pi*1e6)
print cp cn
quit
.endc
.end
