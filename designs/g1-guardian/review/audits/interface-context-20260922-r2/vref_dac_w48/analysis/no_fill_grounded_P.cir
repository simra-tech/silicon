* no_fill grounded drive P; diagnostic capacitor-network AC only
C115 0 N 1.1274000000000001e-15
C125 0 P 3.3182999999999999e-15
C475 0 N 6.714630000000001e-19
C476 0 P 7.7712700000000004e-18
C497 0 P 3.0019e-17
C527 0 P 2.2421600000000004e-17
C588 0 N 3.0638300000000001e-17
C591 0 N 9.2488000000000003e-17
C592 0 P 4.9860800000000002e-17
C595 0 P 4.9860800000000002e-17
C853 0 N 1.53938e-18
C854 0 P 1.8041800000000001e-18
C1000 N P 3.3182999999999999e-15
C1001 N 0 2.9495900000000005e-16
C1002 P 0 2.0055800000000001e-16
VP P 0 DC 0 AC 1
VN N 0 DC 0 AC 0
.control
set numdgt=17
ac lin 1 1Meg 1Meg
let cp = -imag(i(VP))/(2*pi*1e6)
let cn = -imag(i(VN))/(2*pi*1e6)
print cp cn
quit
.endc
.end
