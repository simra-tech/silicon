* actual_fill floating drive P; diagnostic capacitor-network AC only
C13 0 FILL_L30_0 1.10267e-17
C14 0 FILL_L50_2 2.7258100000000005e-16
C15 0 FILL_L50_3 5.6259000000000006e-19
C16 0 FILL_L50_9 5.4492500000000001e-19
C25 0 FILL_L50_16 1.28476e-18
C26 0 FILL_L50_23 1.61084e-17
C40 0 FILL_L50_16 3.3551800000000002e-18
C41 0 FILL_L50_23 1.47145e-17
C52 0 FILL_L50_16 1.7859800000000001e-18
C53 0 FILL_L50_23 2.0488100000000001e-17
C101 0 FILL_L10_13 7.1619500000000006e-18
C102 0 FILL_L30_0 1.6973100000000001e-17
C103 0 FILL_L30_1 1.0937600000000002e-18
C104 0 FILL_L30_10 9.7766699999999994e-19
C105 0 FILL_L30_9 3.1424900000000006e-17
C106 0 FILL_L50_10 4.1826499999999998e-18
C107 0 FILL_L50_16 6.9248200000000007e-17
C108 0 FILL_L50_17 4.3584500000000009e-18
C109 0 FILL_L50_2 1.5839900000000002e-17
C110 0 FILL_L50_23 1.6716300000000001e-17
C111 0 FILL_L50_24 1.6282200000000001e-17
C112 0 FILL_L50_3 5.1129400000000005e-18
C113 0 FILL_L50_9 4.7757100000000003e-17
C127 0 FILL_L10_12 4.0211200000000004e-17
C128 0 FILL_L10_13 1.4590900000000001e-17
C129 0 FILL_L10_2 2.5620300000000002e-17
C130 0 FILL_L10_5 4.0211200000000004e-17
C131 0 FILL_L10_8 4.0211200000000004e-17
C132 0 FILL_L30_12 6.8914300000000002e-18
C133 0 FILL_L30_13 2.9761000000000002e-16
C134 0 FILL_L30_17 5.65095e-18
C135 0 FILL_L30_18 2.9761000000000002e-16
C136 0 FILL_L30_20 1.00647e-18
C137 0 FILL_L30_21 9.7463100000000006e-17
C138 0 FILL_L30_4 6.8914300000000002e-18
C139 0 FILL_L30_5 2.94669e-16
C140 0 FILL_L8_1 2.0255600000000004e-16
C141 0 FILL_L8_10 3.1992300000000003e-16
C142 0 FILL_L8_11 4.4157700000000008e-18
C143 0 FILL_L8_13 1.1736700000000002e-16
C144 0 FILL_L8_14 1.6022900000000002e-18
C145 0 FILL_L8_2 2.8134800000000002e-18
C146 0 FILL_L8_4 3.1992300000000003e-16
C147 0 FILL_L8_5 4.4157700000000008e-18
C148 0 FILL_L8_7 3.1992300000000003e-16
C149 0 FILL_L8_8 4.4157700000000008e-18
C158 0 FILL_L30_13 1.01523e-16
C159 0 FILL_L30_14 7.6123800000000002e-18
C160 0 FILL_L30_18 1.01523e-16
C161 0 FILL_L30_19 7.6123800000000002e-18
C162 0 FILL_L30_21 3.22335e-17
C163 0 FILL_L30_22 2.4169299999999998e-18
C164 0 FILL_L30_5 1.01523e-16
C165 0 FILL_L30_6 7.6123800000000002e-18
C166 0 FILL_L8_1 9.8309200000000016e-18
C167 0 FILL_L8_10 1.54297e-17
C168 0 FILL_L8_11 2.14778e-16
C169 0 FILL_L8_13 5.5987800000000003e-18
C170 0 FILL_L8_14 7.9214500000000012e-17
C171 0 FILL_L8_2 1.35564e-16
C172 0 FILL_L8_4 1.54297e-17
C173 0 FILL_L8_5 2.14778e-16
C174 0 FILL_L8_7 1.54297e-17
C175 0 FILL_L8_8 2.14778e-16
C176 0 N 1.1274000000000001e-15
C185 0 FILL_L30_14 2.3587399999999999e-16
C186 0 FILL_L30_19 2.3587399999999999e-16
C187 0 FILL_L30_22 7.7862100000000001e-17
C188 0 FILL_L30_6 2.3293399999999999e-16
C189 0 FILL_L8_11 2.0315199999999999e-16
C190 0 FILL_L8_14 7.4995900000000009e-17
C191 0 FILL_L8_2 1.2815600000000003e-16
C192 0 FILL_L8_5 2.0315199999999999e-16
C193 0 FILL_L8_8 2.0315199999999999e-16
C194 0 P 3.3182999999999999e-15
C206 0 FILL_L30_14 2.6263500000000003e-16
C207 0 FILL_L30_19 2.6263500000000003e-16
C208 0 FILL_L30_22 8.6358500000000011e-17
C209 0 FILL_L30_6 2.5969400000000005e-16
C210 0 FILL_L8_11 1.7880700000000001e-17
C211 0 FILL_L8_14 6.4881300000000002e-18
C212 0 FILL_L8_2 1.1392500000000002e-17
C213 0 FILL_L8_5 1.7880700000000001e-17
C214 0 FILL_L8_8 1.7880700000000001e-17
C236 0 FILL_L10_0 3.2715600000000003e-18
C237 0 FILL_L10_4 3.03773e-18
C238 0 FILL_L10_5 6.1853600000000005e-18
C239 0 FILL_L30_0 8.7321000000000015e-18
C240 0 FILL_L30_1 8.7321000000000015e-18
C241 0 FILL_L30_12 6.5909900000000003e-19
C242 0 FILL_L30_7 1.5740500000000001e-18
C243 0 FILL_L50_10 6.2992100000000005e-17
C244 0 FILL_L50_2 3.9439300000000009e-17
C245 0 FILL_L50_3 2.10109e-17
C246 0 FILL_L50_9 1.0625000000000001e-16
C270 0 FILL_L30_14 8.1080500000000012e-17
C271 0 FILL_L30_19 8.1156400000000016e-17
C272 0 FILL_L30_22 2.5767100000000002e-17
C273 0 FILL_L30_6 8.1156400000000016e-17
C274 0 FILL_L8_11 1.2881900000000001e-18
C275 0 FILL_L8_14 4.6743e-19
C276 0 FILL_L8_2 8.2076300000000005e-19
C277 0 FILL_L8_5 1.2881900000000001e-18
C278 0 FILL_L8_8 1.2881900000000001e-18
C308 0 FILL_L10_0 8.8400000000000007e-19
C309 0 FILL_L10_6 2.2994300000000001e-17
C310 0 FILL_L10_7 2.32335e-18
C311 0 FILL_L10_8 4.3862300000000006e-18
C312 0 FILL_L30_10 9.0789699999999997e-17
C313 0 FILL_L30_11 7.28646e-18
C314 0 FILL_L30_12 1.9573500000000002e-18
C315 0 FILL_L30_8 8.2811000000000013e-17
C316 0 FILL_L30_9 8.2811000000000013e-17
C317 0 FILL_L50_10 2.0227400000000003e-16
C318 0 FILL_L50_16 2.0395000000000002e-18
C319 0 FILL_L50_17 3.7533900000000006e-18
C320 0 FILL_L50_3 1.5413800000000001e-18
C321 0 FILL_L50_9 2.9211800000000002e-16
C350 0 FILL_L30_0 5.2122100000000007e-17
C351 0 FILL_L30_8 1.56172e-17
C352 0 FILL_L30_9 9.0517500000000012e-18
C353 0 FILL_L50_16 7.2470600000000016e-18
C354 0 FILL_L50_2 8.7844500000000004e-17
C355 0 FILL_L50_9 1.5327800000000001e-16
C388 0 FILL_L10_10 1.326e-17
C389 0 FILL_L10_12 4.90817e-19
C390 0 FILL_L10_9 6.8483800000000002e-18
C391 0 FILL_L30_10 1.3105700000000001e-17
C392 0 FILL_L30_15 9.1569500000000012e-18
C393 0 FILL_L30_16 1.48965e-18
C394 0 FILL_L30_17 3.5663e-18
C395 0 FILL_L30_8 1.3105700000000001e-17
C396 0 FILL_L30_9 1.3105700000000001e-17
C397 0 FILL_L50_10 2.2411e-18
C398 0 FILL_L50_16 2.9587099999999998e-16
C399 0 FILL_L50_17 2.06902e-16
C400 0 FILL_L50_24 8.8246e-19
C401 0 FILL_L50_9 3.8736299999999999e-18
C420 0 FILL_L30_8 1.3353699999999999e-19
C421 0 FILL_L50_16 7.7769400000000014e-17
C422 0 FILL_L50_23 1.4060300000000002e-17
C423 0 FILL_L50_9 2.3690400000000004e-19
C469 0 FILL_L10_0 3.1355e-17
C470 0 FILL_L10_10 3.1355e-17
C471 0 FILL_L10_12 9.74655e-18
C472 0 FILL_L10_2 7.9921700000000005e-18
C473 0 FILL_L10_3 1.07646e-17
C474 0 FILL_L10_4 9.6343599999999996e-18
C475 0 FILL_L10_5 5.7829499999999997e-18
C476 0 FILL_L10_6 2.7449800000000002e-18
C477 0 FILL_L10_7 1.07646e-17
C478 0 FILL_L10_8 7.2449399999999996e-18
C479 0 FILL_L10_9 8.9884800000000001e-18
C480 0 FILL_L30_0 1.50602e-18
C481 0 FILL_L30_1 2.2473200000000001e-17
C482 0 FILL_L30_10 2.2327100000000002e-17
C483 0 FILL_L30_11 7.0285600000000013e-19
C484 0 FILL_L30_12 6.0172199999999999e-19
C485 0 FILL_L30_15 6.5434500000000004e-19
C486 0 FILL_L30_16 7.2126400000000011e-19
C487 0 FILL_L30_17 2.4068900000000002e-19
C488 0 FILL_L30_2 2.9593900000000003e-19
C489 0 FILL_L30_3 9.306100000000002e-19
C490 0 FILL_L30_4 1.0003400000000001e-18
C491 0 FILL_L30_7 6.6785300000000005e-19
C492 0 FILL_L30_9 1.45582e-18
C493 0 FILL_L50_10 5.5416300000000003e-17
C494 0 FILL_L50_16 5.6827899999999999e-17
C495 0 FILL_L50_17 6.0053500000000008e-17
C496 0 FILL_L50_2 6.3944400000000009e-18
C497 0 FILL_L50_23 4.3306700000000004e-17
C498 0 FILL_L50_3 5.5406700000000006e-17
C499 0 FILL_L50_9 5.3625299999999998e-18
C532 0 FILL_L30_8 2.7021000000000001e-17
C533 0 FILL_L50_16 3.4913700000000002e-17
C534 0 FILL_L50_2 2.3941600000000002e-17
C535 0 FILL_L50_23 1.3743700000000002e-17
C536 0 FILL_L50_9 4.0484600000000004e-17
C551 0 FILL_L50_16 8.2933000000000013e-17
C552 0 FILL_L50_23 1.0340000000000001e-16
C553 0 FILL_L50_24 2.7709600000000003e-19
C631 0 FILL_L10_1 1.0331e-17
C632 0 FILL_L10_10 5.2649499999999999e-18
C633 0 FILL_L10_11 1.5273099999999999e-17
C634 0 FILL_L10_12 3.4447800000000006e-17
C635 0 FILL_L10_13 8.3174600000000017e-18
C636 0 FILL_L10_2 2.7645700000000004e-17
C637 0 FILL_L10_3 1.0523400000000001e-17
C638 0 FILL_L10_4 1.1954300000000001e-17
C639 0 FILL_L10_5 6.4779800000000001e-17
C640 0 FILL_L10_6 1.0288500000000002e-17
C641 0 FILL_L10_7 1.6143000000000001e-17
C642 0 FILL_L10_8 6.3444200000000009e-17
C643 0 FILL_L10_9 1.0363899999999999e-17
C644 0 FILL_L30_11 6.9839600000000002e-18
C645 0 FILL_L30_12 1.4715000000000001e-16
C646 0 FILL_L30_13 2.0736700000000002e-17
C647 0 FILL_L30_15 6.9839600000000002e-18
C648 0 FILL_L30_16 6.9839600000000002e-18
C649 0 FILL_L30_17 2.0042300000000001e-16
C650 0 FILL_L30_18 6.1101700000000011e-17
C651 0 FILL_L30_19 4.3078600000000007e-17
C652 0 FILL_L30_2 6.9839600000000002e-18
C653 0 FILL_L30_20 6.4287099999999997e-17
C654 0 FILL_L30_21 2.2708700000000003e-17
C655 0 FILL_L30_22 2.2449200000000002e-17
C656 0 FILL_L30_3 6.9839600000000002e-18
C657 0 FILL_L30_4 1.4569100000000002e-16
C658 0 FILL_L30_5 2.0736700000000002e-17
C659 0 FILL_L30_7 6.9839600000000002e-18
C660 0 FILL_L50_0 3.4994000000000003e-17
C661 0 FILL_L50_10 2.11857e-16
C662 0 FILL_L50_11 3.7321900000000005e-17
C663 0 FILL_L50_14 3.99753e-17
C664 0 FILL_L50_15 3.8120000000000002e-18
C665 0 FILL_L50_16 8.2099500000000009e-17
C666 0 FILL_L50_17 2.8146800000000003e-16
C667 0 FILL_L50_18 4.0715500000000002e-17
C668 0 FILL_L50_19 4.9005200000000005e-18
C669 0 FILL_L50_2 1.4529200000000001e-17
C670 0 FILL_L50_20 6.9873299999999999e-17
C671 0 FILL_L50_21 4.0526000000000008e-17
C672 0 FILL_L50_22 9.9095600000000011e-18
C673 0 FILL_L50_23 3.3539200000000001e-17
C674 0 FILL_L50_24 9.7690700000000013e-17
C675 0 FILL_L50_25 3.2947499999999998e-17
C676 0 FILL_L50_3 2.11857e-16
C677 0 FILL_L50_4 3.7321900000000005e-17
C678 0 FILL_L50_7 3.7260599999999997e-17
C679 0 FILL_L50_9 1.3542300000000001e-17
C680 0 FILL_L8_0 4.5103000000000006e-18
C681 0 FILL_L8_1 9.9478799999999998e-18
C682 0 FILL_L8_10 2.4728600000000003e-17
C683 0 FILL_L8_11 1.4019500000000002e-17
C684 0 FILL_L8_12 3.2623100000000001e-18
C685 0 FILL_L8_13 6.3037700000000003e-18
C686 0 FILL_L8_14 4.4735500000000004e-18
C687 0 FILL_L8_3 6.1602900000000005e-18
C688 0 FILL_L8_4 2.05508e-17
C689 0 FILL_L8_6 5.9603200000000008e-18
C690 0 FILL_L8_7 2.65707e-17
C691 0 FILL_L8_8 5.9874300000000002e-18
C692 0 FILL_L8_9 6.6352100000000005e-18
C693 0 N 6.714630000000001e-19
C694 0 P 5.3452400000000011e-18
C715 0 FILL_L10_12 4.0020300000000007e-18
C716 0 FILL_L10_2 5.8429599999999999e-18
C717 0 FILL_L10_5 1.60081e-17
C718 0 FILL_L10_8 1.2006100000000001e-17
C719 0 FILL_L30_12 3.2677e-17
C720 0 FILL_L30_13 1.55367e-16
C721 0 FILL_L30_14 6.91856e-17
C722 0 FILL_L30_17 3.2677e-17
C723 0 FILL_L30_18 1.55367e-16
C724 0 FILL_L30_19 6.91856e-17
C725 0 FILL_L30_20 1.02915e-17
C726 0 FILL_L30_21 5.2054400000000006e-17
C727 0 FILL_L30_22 2.19664e-17
C728 0 FILL_L30_4 3.2677e-17
C729 0 FILL_L30_5 1.5080600000000003e-16
C730 0 FILL_L30_6 6.91856e-17
C731 0 FILL_L8_1 1.6775400000000001e-17
C732 0 FILL_L8_10 1.7794900000000001e-17
C733 0 FILL_L8_11 3.0949000000000004e-17
C734 0 FILL_L8_13 4.0592100000000005e-18
C735 0 FILL_L8_14 1.02099e-17
C736 0 FILL_L8_2 2.2219000000000002e-17
C737 0 FILL_L8_4 3.7619100000000003e-17
C738 0 FILL_L8_5 4.0600400000000005e-17
C739 0 FILL_L8_7 3.1011000000000002e-17
C740 0 FILL_L8_8 3.73833e-17
C741 0 P 2.0104e-17
C771 0 FILL_L30_14 1.18065e-16
C772 0 FILL_L30_19 1.17943e-16
C773 0 FILL_L30_22 3.8204000000000004e-17
C774 0 FILL_L30_6 1.1691000000000001e-16
C775 0 FILL_L8_11 1.9735600000000002e-17
C776 0 FILL_L8_14 6.2318000000000002e-18
C777 0 FILL_L8_2 1.4682000000000002e-17
C778 0 FILL_L8_5 2.7419600000000002e-17
C779 0 FILL_L8_8 2.4858200000000002e-17
C780 0 P 1.49205e-17
C817 0 FILL_L50_1 1.8045800000000001e-18
C818 0 FILL_L50_12 1.7865400000000002e-18
C819 0 FILL_L50_13 1.5172100000000002e-16
C820 0 FILL_L50_15 1.7143500000000002e-18
C821 0 FILL_L50_19 1.8045800000000001e-18
C822 0 FILL_L50_20 1.5177800000000001e-16
C823 0 FILL_L50_22 1.8045800000000001e-18
C824 0 FILL_L50_25 4.8189400000000003e-17
C825 0 FILL_L50_5 1.8045800000000001e-18
C826 0 FILL_L50_6 1.5177800000000001e-16
C827 0 FILL_L50_8 1.8045800000000001e-18
C838 0 FILL_L10_1 3.80488e-19
C839 0 FILL_L10_11 8.0348900000000007e-19
C840 0 FILL_L10_12 1.3783500000000001e-17
C841 0 FILL_L10_2 2.0124000000000002e-17
C842 0 FILL_L10_4 7.1510500000000002e-19
C843 0 FILL_L10_5 5.5134100000000003e-17
C844 0 FILL_L10_6 6.5720700000000001e-19
C845 0 FILL_L10_7 1.5668e-18
C846 0 FILL_L10_8 4.1350600000000006e-17
C847 0 FILL_L10_9 6.3558899999999999e-19
C848 0 FILL_L30_12 2.5737800000000002e-16
C849 0 FILL_L30_17 2.5737800000000002e-16
C850 0 FILL_L30_20 8.3277200000000006e-17
C851 0 FILL_L30_4 2.5500200000000004e-16
C852 0 FILL_L50_0 1.8048800000000002e-17
C853 0 FILL_L50_10 1.72444e-17
C854 0 FILL_L50_11 1.8048800000000002e-17
C855 0 FILL_L50_14 1.8048800000000002e-17
C856 0 FILL_L50_17 1.72444e-17
C857 0 FILL_L50_18 1.8048800000000002e-17
C858 0 FILL_L50_21 1.8048800000000002e-17
C859 0 FILL_L50_24 2.3279999999999999e-18
C860 0 FILL_L50_3 1.72444e-17
C861 0 FILL_L50_4 1.8048800000000002e-17
C862 0 FILL_L50_7 1.8048800000000002e-17
C863 0 FILL_L8_0 4.3552800000000002e-19
C864 0 FILL_L8_1 3.9776400000000001e-19
C865 0 FILL_L8_10 1.74362e-19
C866 0 FILL_L8_3 1.1932300000000001e-18
C867 0 FILL_L8_4 1.0598000000000001e-18
C868 0 FILL_L8_6 8.949200000000002e-19
C869 0 FILL_L8_7 7.4921300000000004e-19
C870 0 FILL_L8_9 2.9830700000000003e-19
C876 0 FILL_L10_12 4.8338400000000009e-18
C877 0 FILL_L10_13 1.7539899999999999e-18
C878 0 FILL_L10_2 3.0798500000000002e-18
C879 0 FILL_L10_5 4.8338400000000009e-18
C880 0 FILL_L10_8 4.8338400000000009e-18
C881 0 FILL_L30_12 3.4142200000000003e-17
C882 0 FILL_L30_13 4.7357100000000007e-18
C883 0 FILL_L30_17 3.4202900000000002e-17
C884 0 FILL_L30_18 4.7835400000000005e-18
C885 0 FILL_L30_20 1.0773900000000001e-17
C886 0 FILL_L30_21 1.51877e-18
C887 0 FILL_L30_4 3.4239300000000005e-17
C888 0 FILL_L30_5 4.7117900000000001e-18
C889 0 FILL_L8_0 1.2756300000000002e-18
C890 0 FILL_L8_1 1.1911700000000001e-18
C891 0 FILL_L8_10 1.9581700000000001e-18
C892 0 FILL_L8_12 7.26478e-19
C893 0 FILL_L8_13 7.1470400000000001e-19
C894 0 FILL_L8_3 2.0021000000000003e-18
C895 0 FILL_L8_4 1.8623000000000001e-18
C896 0 FILL_L8_6 2.0021000000000003e-18
C897 0 FILL_L8_7 1.9378300000000002e-18
C898 0 FILL_L8_9 2.0021000000000003e-18
C903 0 FILL_L30_13 9.8875000000000007e-18
C904 0 FILL_L30_14 1.0960500000000001e-17
C905 0 FILL_L30_18 9.8875000000000007e-18
C906 0 FILL_L30_19 1.0960500000000001e-17
C907 0 FILL_L30_21 3.1392800000000001e-18
C908 0 FILL_L30_22 3.4799600000000002e-18
C909 0 FILL_L30_5 9.8875000000000007e-18
C910 0 FILL_L30_6 1.0960500000000001e-17
C911 0 FILL_L8_11 2.6760900000000001e-17
C912 0 FILL_L8_14 9.9449799999999996e-18
C913 0 FILL_L8_2 1.68159e-17
C914 0 FILL_L8_5 2.6760900000000001e-17
C915 0 FILL_L8_8 2.6760900000000001e-17
C916 0 N 3.0638300000000001e-17
C919 0 FILL_L30_13 5.6403900000000007e-18
C920 0 FILL_L30_14 6.3988200000000009e-17
C921 0 FILL_L30_18 5.6403900000000007e-18
C922 0 FILL_L30_19 6.3988200000000009e-17
C923 0 FILL_L30_21 1.7908200000000004e-18
C924 0 FILL_L30_22 2.03163e-17
C925 0 FILL_L30_5 5.6403900000000007e-18
C926 0 FILL_L30_6 6.3988200000000009e-17
C927 0 FILL_L8_11 1.6337900000000003e-17
C928 0 FILL_L8_14 5.5433000000000004e-18
C929 0 FILL_L8_2 1.1282800000000001e-17
C930 0 FILL_L8_5 1.9521400000000002e-17
C931 0 FILL_L8_8 1.8460200000000003e-17
C932 0 N 9.2488000000000003e-17
C933 0 P 3.3449700000000005e-17
C936 0 FILL_L30_14 1.7852300000000002e-16
C937 0 FILL_L30_19 1.7852300000000002e-16
C938 0 FILL_L30_22 5.9081900000000006e-17
C939 0 FILL_L30_6 1.7614700000000001e-16
C940 0 FILL_L8_11 9.6103600000000004e-18
C941 0 FILL_L8_14 2.6952900000000001e-18
C942 0 FILL_L8_2 7.9189800000000013e-18
C943 0 FILL_L8_5 1.6157600000000001e-17
C944 0 FILL_L8_8 1.3975199999999999e-17
C945 0 P 3.3189300000000006e-17
C949 0 FILL_L30_14 1.6347000000000002e-16
C950 0 FILL_L30_19 1.6347000000000002e-16
C951 0 FILL_L30_22 5.4302600000000003e-17
C952 0 FILL_L30_6 1.6109400000000002e-16
C953 0 FILL_L8_11 4.7020900000000001e-18
C954 0 FILL_L8_14 8.5533600000000003e-19
C955 0 FILL_L8_2 5.2247600000000004e-18
C956 0 FILL_L8_5 1.4314400000000001e-17
C957 0 FILL_L8_8 1.1034900000000001e-17
C961 0 FILL_L30_14 1.6347000000000002e-16
C962 0 FILL_L30_19 1.6347000000000002e-16
C963 0 FILL_L30_22 5.4302600000000003e-17
C964 0 FILL_L30_6 1.6109400000000002e-16
C965 0 FILL_L8_11 3.1069500000000003e-18
C966 0 FILL_L8_14 6.842690000000001e-19
C967 0 FILL_L8_2 3.2239100000000004e-18
C968 0 FILL_L8_5 9.0734900000000006e-18
C969 0 FILL_L8_8 7.04443e-18
C973 0 FILL_L30_14 1.6347000000000002e-16
C974 0 FILL_L30_19 1.6347000000000002e-16
C975 0 FILL_L30_22 5.4302600000000003e-17
C976 0 FILL_L30_6 1.6109400000000002e-16
C977 0 FILL_L8_11 2.96913e-19
C978 0 FILL_L8_2 4.3349300000000004e-19
C979 0 FILL_L8_5 1.1876500000000002e-18
C980 0 FILL_L8_8 8.9074000000000012e-19
C984 0 FILL_L30_14 2.5335000000000001e-16
C985 0 FILL_L30_19 2.5335000000000001e-16
C986 0 FILL_L30_22 8.283950000000001e-17
C987 0 FILL_L30_6 2.5097399999999998e-16
C988 0 FILL_L8_11 2.8313200000000004e-19
C989 0 FILL_L8_2 4.1337200000000004e-19
C990 0 FILL_L8_5 1.1325300000000001e-18
C991 0 FILL_L8_8 8.4939500000000011e-19
C995 0 FILL_L30_14 2.1584700000000002e-16
C996 0 FILL_L30_19 2.1587400000000001e-16
C997 0 FILL_L30_22 7.0940899999999998e-17
C998 0 FILL_L30_6 2.1349800000000001e-16
C999 0 FILL_L8_11 2.1099500000000001e-19
C1000 0 FILL_L8_2 3.0805200000000001e-19
C1001 0 FILL_L8_5 8.4397900000000014e-19
C1002 0 FILL_L8_8 6.3298400000000003e-19
C1005 0 FILL_L30_14 3.4177999999999998e-17
C1006 0 FILL_L30_19 3.4239300000000005e-17
C1007 0 FILL_L30_22 1.0871000000000002e-17
C1008 0 FILL_L30_6 3.4239300000000005e-17
C1012 0 FILL_L30_14 1.3510700000000002e-17
C1013 0 FILL_L30_19 1.3544600000000001e-17
C1014 0 FILL_L30_22 4.3003999999999999e-18
C1015 0 FILL_L30_6 1.3544600000000001e-17
C1016 0 FILL_L8_11 1.13984e-18
C1017 0 FILL_L8_14 4.1360000000000006e-19
C1018 0 FILL_L8_2 7.2624300000000003e-19
C1019 0 FILL_L8_5 1.13984e-18
C1020 0 FILL_L8_8 1.13984e-18
C1026 0 FILL_L10_12 4.0625600000000005e-18
C1027 0 FILL_L10_13 1.4741300000000001e-18
C1028 0 FILL_L10_2 2.58843e-18
C1029 0 FILL_L10_5 4.0625600000000005e-18
C1030 0 FILL_L10_8 4.0625600000000005e-18
C1031 0 FILL_L30_12 1.3544600000000001e-17
C1032 0 FILL_L30_13 8.0269700000000013e-18
C1033 0 FILL_L30_17 1.3544600000000001e-17
C1034 0 FILL_L30_18 8.1080500000000005e-18
C1035 0 FILL_L30_20 4.3003999999999999e-18
C1036 0 FILL_L30_21 2.5743000000000002e-18
C1037 0 FILL_L30_4 1.3544600000000001e-17
C1038 0 FILL_L30_5 8.1080500000000005e-18
C1039 0 FILL_L8_0 1.1862800000000001e-18
C1040 0 FILL_L8_1 4.3557800000000009e-18
C1041 0 FILL_L8_10 6.9279500000000002e-18
C1042 0 FILL_L8_12 6.7559600000000002e-19
C1043 0 FILL_L8_13 2.5181600000000001e-18
C1044 0 FILL_L8_3 1.8618800000000002e-18
C1045 0 FILL_L8_4 6.8289299999999999e-18
C1046 0 FILL_L8_6 1.8618800000000002e-18
C1047 0 FILL_L8_7 6.9069400000000003e-18
C1048 0 FILL_L8_9 1.8618800000000002e-18
C1052 0 FILL_L30_14 4.4113300000000005e-18
C1053 0 FILL_L30_19 4.3671000000000004e-18
C1054 0 FILL_L30_22 1.40411e-18
C1055 0 FILL_L30_6 4.422380000000001e-18
C1056 0 FILL_L8_11 2.2876700000000002e-19
C1057 0 FILL_L8_2 1.1438300000000001e-19
C1058 0 FILL_L8_5 1.5251100000000003e-19
C1059 0 FILL_L8_8 2.6689400000000004e-19
C1076 0 FILL_L30_14 1.4901600000000001e-18
C1077 0 FILL_L30_19 1.4752200000000001e-18
C1078 0 FILL_L30_22 4.0708499999999999e-19
C1079 0 FILL_L30_6 1.4938900000000001e-18
C1109 0 FILL_L50_1 2.2471000000000003e-17
C1110 0 FILL_L50_12 2.2471000000000003e-17
C1111 0 FILL_L50_13 1.9033800000000001e-17
C1112 0 FILL_L50_15 2.2471000000000003e-17
C1113 0 FILL_L50_19 2.2471000000000003e-17
C1114 0 FILL_L50_20 1.9033800000000001e-17
C1115 0 FILL_L50_22 2.2471000000000003e-17
C1116 0 FILL_L50_25 2.5695700000000002e-18
C1117 0 FILL_L50_5 2.2471000000000003e-17
C1118 0 FILL_L50_6 1.9033800000000001e-17
C1119 0 FILL_L50_8 2.2471000000000003e-17
C1124 0 FILL_L10_12 3.2976800000000003e-18
C1125 0 FILL_L10_13 1.1965900000000001e-18
C1126 0 FILL_L10_2 2.1010900000000002e-18
C1127 0 FILL_L10_5 3.2976800000000003e-18
C1128 0 FILL_L10_8 3.2976800000000003e-18
C1129 0 FILL_L30_12 7.3730700000000005e-18
C1130 0 FILL_L30_13 1.5077100000000001e-17
C1131 0 FILL_L30_17 7.3730700000000005e-18
C1132 0 FILL_L30_18 1.5077100000000001e-17
C1133 0 FILL_L30_20 2.3409499999999999e-18
C1134 0 FILL_L30_21 4.7869700000000008e-18
C1135 0 FILL_L30_4 7.3730700000000005e-18
C1136 0 FILL_L30_5 1.5077100000000001e-17
C1137 0 FILL_L8_1 1.4997199999999999e-17
C1138 0 FILL_L8_10 2.4017700000000004e-17
C1139 0 FILL_L8_13 8.9010500000000009e-18
C1140 0 FILL_L8_4 2.3961500000000003e-17
C1141 0 FILL_L8_7 2.3982500000000003e-17
C1145 0 FILL_L10_12 2.6443500000000005e-18
C1146 0 FILL_L10_13 9.5952200000000002e-19
C1147 0 FILL_L10_2 1.6848300000000003e-18
C1148 0 FILL_L10_5 2.6443500000000005e-18
C1149 0 FILL_L10_8 2.6443500000000005e-18
C1150 0 FILL_L30_12 4.422380000000001e-18
C1151 0 FILL_L30_13 4.96112e-17
C1152 0 FILL_L30_17 4.422380000000001e-18
C1153 0 FILL_L30_18 4.96112e-17
C1154 0 FILL_L30_20 1.40411e-18
C1155 0 FILL_L30_21 1.5751600000000002e-17
C1156 0 FILL_L30_4 4.422380000000001e-18
C1157 0 FILL_L30_5 4.96112e-17
C1158 0 FILL_L8_1 1.5181599999999999e-17
C1159 0 FILL_L8_10 2.3492300000000002e-17
C1160 0 FILL_L8_13 8.5612700000000016e-18
C1161 0 FILL_L8_4 2.5126600000000003e-17
C1162 0 FILL_L8_7 2.4494500000000002e-17
C1166 0 FILL_L10_12 3.0336000000000004e-19
C1167 0 FILL_L10_2 4.4290600000000003e-19
C1168 0 FILL_L10_5 1.2134400000000001e-18
C1169 0 FILL_L10_8 9.100810000000001e-19
C1170 0 FILL_L30_13 2.3002400000000001e-16
C1171 0 FILL_L30_18 2.3002400000000001e-16
C1172 0 FILL_L30_21 7.5433700000000012e-17
C1173 0 FILL_L30_5 2.2764899999999999e-16
C1174 0 FILL_L8_1 1.0928600000000001e-17
C1175 0 FILL_L8_10 1.0802800000000001e-17
C1176 0 FILL_L8_13 2.2390500000000004e-18
C1177 0 FILL_L8_4 2.7277200000000002e-17
C1178 0 FILL_L8_7 2.1666799999999999e-17
C1181 0 FILL_L30_13 3.1181700000000005e-16
C1182 0 FILL_L30_18 3.1181700000000005e-16
C1183 0 FILL_L30_21 1.0140300000000001e-16
C1184 0 FILL_L30_5 3.0944200000000004e-16
C1185 0 FILL_L8_1 1.1768100000000001e-17
C1186 0 FILL_L8_10 9.1838200000000014e-18
C1187 0 FILL_L8_13 8.5533600000000003e-19
C1188 0 FILL_L8_4 3.2241300000000007e-17
C1189 0 FILL_L8_7 2.4480100000000003e-17
C1192 0 FILL_L30_13 3.1181700000000005e-16
C1193 0 FILL_L30_18 3.1181700000000005e-16
C1194 0 FILL_L30_21 1.0140300000000001e-16
C1195 0 FILL_L30_5 3.0944200000000004e-16
C1196 0 FILL_L8_1 4.4804500000000007e-18
C1197 0 FILL_L8_10 3.0688000000000002e-18
C1198 0 FILL_L8_11 2.6309200000000002e-19
C1199 0 FILL_L8_2 3.8411500000000004e-19
C1200 0 FILL_L8_4 1.2275200000000001e-17
C1201 0 FILL_L8_5 1.0523700000000001e-18
C1202 0 FILL_L8_7 9.2064100000000003e-18
C1203 0 FILL_L8_8 7.8927700000000007e-19
C1207 0 FILL_L30_13 1.7055600000000003e-16
C1208 0 FILL_L30_14 3.4565600000000004e-18
C1209 0 FILL_L30_18 1.7055600000000003e-16
C1210 0 FILL_L30_19 3.4565600000000004e-18
C1211 0 FILL_L30_21 5.4391500000000002e-17
C1212 0 FILL_L30_22 1.0974600000000002e-18
C1213 0 FILL_L30_5 1.7031800000000001e-16
C1214 0 FILL_L30_6 3.4565600000000004e-18
C1215 0 FILL_L8_11 1.7974100000000001e-17
C1216 0 FILL_L8_14 6.7331700000000005e-18
C1217 0 FILL_L8_2 1.12409e-17
C1218 0 FILL_L8_4 1.02657e-19
C1219 0 FILL_L8_5 1.8094500000000002e-17
C1220 0 FILL_L8_8 1.7974100000000001e-17
C1222 0 FILL_L30_13 1.8617000000000002e-17
C1223 0 FILL_L30_14 6.1497500000000007e-18
C1224 0 FILL_L30_18 1.8617000000000002e-17
C1225 0 FILL_L30_19 6.1497500000000007e-18
C1226 0 FILL_L30_21 5.9108900000000009e-18
C1227 0 FILL_L30_22 1.9525399999999999e-18
C1228 0 FILL_L30_5 1.8617000000000002e-17
C1229 0 FILL_L30_6 6.1497500000000007e-18
C1230 0 FILL_L8_11 1.5276800000000002e-17
C1231 0 FILL_L8_14 5.5433000000000004e-18
C1232 0 FILL_L8_2 9.7335100000000011e-18
C1233 0 FILL_L8_5 1.5276800000000002e-17
C1234 0 FILL_L8_8 1.5276800000000002e-17
C1249 0 FILL_L10_10 2.4128199999999999e-19
C1250 0 FILL_L10_4 2.3464000000000001e-17
C1251 0 FILL_L10_6 1.2560600000000001e-16
C1252 0 FILL_L10_7 3.69509e-17
C1253 0 FILL_L10_8 5.8696299999999999e-18
C1254 0 FILL_L30_10 1.8691500000000003e-17
C1255 0 FILL_L30_11 3.9917700000000004e-17
C1256 0 FILL_L30_12 2.1187900000000001e-17
C1257 0 FILL_L30_15 1.3474100000000002e-18
C1258 0 FILL_L30_7 2.4911000000000002e-17
C1259 0 FILL_L30_8 1.8545400000000001e-18
C1260 0 FILL_L30_9 1.73577e-18
C1261 0 FILL_L50_10 9.5957500000000004e-17
C1262 0 FILL_L50_11 1.2237100000000002e-18
C1263 0 FILL_L50_17 1.0714600000000001e-18
C1264 0 FILL_L50_9 2.6715000000000003e-17
C1265 0 FILL_L8_3 4.5699600000000006e-18
C1266 0 FILL_L8_6 5.6810400000000007e-17
C1271 0 FILL_L30_8 6.1946000000000009e-18
C1272 0 FILL_L30_9 3.9635400000000003e-19
C1273 0 FILL_L50_9 1.5758500000000002e-18
C1279 0 FILL_L30_19 2.9637200000000006e-19
C1280 0 FILL_L50_20 2.2412800000000003e-18
C1288 0 FILL_L50_1 3.2072900000000001e-18
C1289 0 FILL_L50_6 7.6011000000000003e-18
C1295 0 FILL_L30_14 2.9637200000000006e-19
C1296 0 FILL_L50_8 4.9172600000000003e-18
C1301 0 FILL_L50_13 1.7724500000000001e-17
C1302 0 FILL_L50_8 8.5136299999999999e-18
C1306 0 FILL_L50_13 2.61575e-17
C1309 0 FILL_L50_6 1.2819800000000002e-17
C1315 0 FILL_L30_6 2.9637200000000006e-19
C1316 0 FILL_L50_5 4.0977100000000007e-18
C1317 0 FILL_L50_6 3.7354700000000005e-19
C1322 0 FILL_L50_15 3.0464200000000001e-18
C1323 0 FILL_L50_19 1.7171500000000001e-18
C1324 0 FILL_L50_20 2.2458200000000003e-17
C1328 0 FILL_L50_20 3.2410600000000002e-17
C1333 0 FILL_L30_19 2.9637200000000006e-19
C1334 0 FILL_L50_19 4.9172600000000003e-18
C1338 0 FILL_L50_19 8.5144300000000007e-18
C1339 0 FILL_L50_20 1.7565600000000002e-17
C1342 0 FILL_L50_20 2.5889600000000004e-17
C1350 0 FILL_L50_19 2.0256599999999998e-18
C1351 0 FILL_L50_20 4.3780400000000006e-18
C1352 0 FILL_L50_22 2.7311200000000003e-18
C1353 0 FILL_L50_25 5.9027399999999999e-18
C1356 0 FILL_L50_20 7.383850000000001e-18
C1357 0 FILL_L50_25 9.955370000000001e-18
C1361 0 FILL_L30_22 2.9637200000000006e-19
C1362 0 FILL_L50_22 3.4420800000000001e-18
C1363 0 FILL_L50_25 6.7238500000000008e-19
C1367 0 FILL_L10_7 8.3462100000000003e-19
C1368 0 FILL_L30_10 1.2385e-17
C1369 0 FILL_L50_10 7.2007100000000003e-18
C1370 0 FILL_L50_17 3.6750500000000003e-18
C1373 0 FILL_L50_22 6.935900000000001e-18
C1374 0 FILL_L50_25 1.44165e-17
C1376 0 FILL_L50_25 2.0059200000000002e-17
C1382 0 FILL_L50_12 3.4331700000000004e-18
C1383 0 FILL_L50_13 8.9508799999999996e-18
C1384 0 FILL_L50_15 1.1071200000000001e-18
C1385 0 FILL_L50_20 2.3928000000000001e-18
C1389 0 FILL_L50_13 1.4980000000000002e-17
C1390 0 FILL_L50_20 4.0356199999999998e-18
C1394 0 FILL_L50_16 1.64289e-17
C1401 0 FILL_L30_15 6.190480000000001e-19
C1402 0 FILL_L30_8 4.7670400000000001e-19
C1403 0 FILL_L30_9 3.4170800000000002e-19
C1404 0 FILL_L50_16 2.2202400000000001e-17
C1411 0 FILL_L30_17 1.2526300000000003e-19
C1412 0 FILL_L50_16 5.7082699999999999e-18
C1413 0 FILL_L50_17 2.4261600000000001e-18
C1421 0 FILL_L30_15 1.1154600000000002e-19
C1422 0 FILL_L30_17 2.9957600000000004e-19
C1423 0 FILL_L50_16 1.8271800000000003e-18
C1424 0 FILL_L50_17 7.891520000000001e-18
C1431 0 FILL_L50_16 3.37819e-17
C1435 0 FILL_L10_10 2.0955400000000003e-18
C1436 0 FILL_L10_9 7.7432500000000011e-19
C1437 0 FILL_L30_10 1.43901e-19
C1438 0 FILL_L30_15 1.21893e-19
C1439 0 FILL_L30_16 4.9627700000000007e-19
C1440 0 FILL_L30_17 6.966440000000001e-19
C1441 0 FILL_L50_17 2.0446999999999999e-17
C1446 0 FILL_L50_16 4.6045499999999999e-18
C1449 0 FILL_L30_16 1.0904300000000002e-18
C1450 0 FILL_L50_16 1.65915e-17
C1451 0 FILL_L50_17 1.3509500000000001e-18
C1459 0 FILL_L30_10 4.3843300000000008e-19
C1460 0 FILL_L30_9 2.2221000000000003e-18
C1461 0 FILL_L50_10 2.6240000000000004e-19
C1462 0 FILL_L50_16 3.2395600000000003e-19
C1463 0 FILL_L50_9 7.5150600000000006e-19
C1470 0 FILL_L30_8 1.04147e-18
C1471 0 FILL_L30_9 5.0303900000000001e-18
C1472 0 FILL_L50_16 5.368000000000001e-18
C1473 0 FILL_L50_9 5.6610399999999999e-18
C1480 0 FILL_L30_8 1.7774000000000001e-17
C1481 0 FILL_L30_9 1.61714e-17
C1482 0 FILL_L50_16 3.7542000000000004e-18
C1483 0 FILL_L50_9 1.4195100000000002e-17
C1485 0 FILL_L30_8 1.7312600000000001e-18
C1486 0 FILL_L30_9 2.44398e-18
C1487 0 FILL_L50_16 2.1296900000000002e-18
C1488 0 FILL_L50_9 6.6959800000000002e-18
C1490 0 FILL_L30_8 3.1184500000000005e-18
C1491 0 FILL_L50_16 1.3701700000000002e-18
C1492 0 FILL_L50_9 1.2865700000000002e-18
C1495 0 FILL_L50_16 2.7632200000000003e-18
C1496 0 FILL_L50_17 2.0480300000000004e-19
C1499 0 FILL_L30_13 1.8274000000000002e-19
C1500 0 FILL_L30_14 3.0039800000000003e-17
C1501 0 FILL_L30_18 1.2182600000000002e-19
C1502 0 FILL_L30_19 2.9345400000000001e-17
C1503 0 FILL_L30_22 8.9573800000000019e-18
C1504 0 FILL_L30_5 1.8274000000000002e-19
C1505 0 FILL_L30_6 3.0059499999999999e-17
C1506 0 FILL_L8_11 2.4158700000000001e-17
C1507 0 FILL_L8_14 8.7661400000000004e-18
C1508 0 FILL_L8_2 1.5392500000000002e-17
C1509 0 FILL_L8_5 2.4158700000000001e-17
C1510 0 FILL_L8_8 2.4158700000000001e-17
C1511 0 N 3.6098100000000003e-19
C1512 0 P 4.2307500000000001e-19
C1515 0 FILL_L50_16 2.8070200000000004e-18
C1516 0 FILL_L50_23 3.2690800000000003e-18
C1520 0 FILL_L50_23 3.2339000000000002e-19
C1530 0 FILL_L10_10 1.3567100000000001e-16
C1531 0 FILL_L10_11 1.3547600000000001e-16
C1532 0 FILL_L10_12 7.1083100000000007e-18
C1533 0 FILL_L10_13 7.3738100000000005e-19
C1534 0 FILL_L10_9 4.4405400000000006e-17
C1535 0 FILL_L30_15 5.3124200000000006e-18
C1536 0 FILL_L30_16 4.8284999999999998e-17
C1537 0 FILL_L30_17 6.2607400000000006e-18
C1538 0 FILL_L30_20 1.5595600000000002e-18
C1539 0 FILL_L50_16 2.7447700000000002e-17
C1540 0 FILL_L50_17 7.9508600000000002e-17
C1541 0 FILL_L50_18 1.1199200000000002e-18
C1542 0 FILL_L50_23 7.8243400000000013e-18
C1543 0 FILL_L50_24 3.6685000000000005e-17
C1544 0 FILL_L8_9 6.5651500000000005e-17
C1549 0 FILL_L30_10 4.3367100000000007e-18
C1550 0 FILL_L30_9 3.10774e-19
C1551 0 FILL_L50_10 1.9810400000000002e-18
C1552 0 FILL_L50_17 1.69366e-18
C1553 0 FILL_L50_9 2.4668500000000001e-19
C1556 0 FILL_L30_9 1.6862800000000002e-18
C1557 0 FILL_L50_16 1.2304e-18
C1558 0 FILL_L50_9 9.9245400000000003e-19
C1565 0 FILL_L30_14 1.90872e-18
C1566 0 FILL_L30_19 1.8895800000000001e-18
C1567 0 FILL_L30_22 5.2142900000000007e-19
C1568 0 FILL_L30_6 1.9135000000000003e-18
C1569 0 FILL_L50_1 7.8955400000000004e-19
C1570 0 FILL_L50_12 7.8165800000000004e-19
C1571 0 FILL_L50_15 7.5007600000000003e-19
C1572 0 FILL_L50_19 5.5268800000000004e-19
C1573 0 FILL_L50_22 6.2374700000000007e-19
C1574 0 FILL_L50_5 5.9216500000000006e-19
C1575 0 FILL_L50_8 5.5268800000000004e-19
C1578 0 FILL_L50_23 1.25717e-18
C1581 0 FILL_L50_23 3.3453100000000003e-18
C1584 0 FILL_L50_23 4.8395200000000006e-18
C1588 0 FILL_L30_20 2.3463500000000004e-19
C1589 0 FILL_L50_23 3.4511500000000003e-18
C1590 0 FILL_L50_24 2.9823500000000002e-18
C1593 0 FILL_L10_13 1.0153900000000001e-19
C1594 0 FILL_L30_20 2.2553800000000001e-19
C1595 0 FILL_L50_23 9.8821800000000014e-19
C1596 0 FILL_L50_24 2.1787899999999998e-18
C1599 0 FILL_L10_10 6.01132e-19
C1600 0 FILL_L10_13 3.1178400000000001e-19
C1601 0 FILL_L30_20 7.8035900000000009e-19
C1602 0 FILL_L50_17 1.0504900000000002e-19
C1603 0 FILL_L50_24 1.2665500000000001e-17
C1607 0 FILL_L10_10 6.3930000000000004e-19
C1608 0 FILL_L10_13 6.1099599999999999e-19
C1609 0 FILL_L30_20 1.5213400000000001e-18
C1610 0 FILL_L50_17 1.21857e-19
C1611 0 FILL_L50_24 1.4302200000000001e-17
C1614 0 FILL_L10_13 4.6064600000000006e-19
C1615 0 FILL_L30_16 7.705950000000001e-19
C1616 0 FILL_L30_20 7.6384500000000002e-19
C1617 0 FILL_L50_24 4.8082300000000003e-18
C1619 0 FILL_L10_11 2.4925100000000002e-18
C1620 0 FILL_L10_13 3.6786200000000001e-18
C1621 0 FILL_L30_20 4.0214999999999997e-18
C1622 0 FILL_L50_21 2.0901800000000004e-18
C1623 0 FILL_L50_24 7.09107e-18
C1624 0 FILL_L8_12 2.5021900000000001e-17
C1628 0 FILL_L50_12 1.5251800000000001e-19
C1630 0 FILL_L50_16 2.35057e-18
C1632 0 FILL_L10_10 1.8886400000000002e-18
C1633 0 FILL_L10_6 1.53631e-19
C1634 0 FILL_L10_7 6.5215200000000004e-17
C1635 0 FILL_L10_9 5.4394599999999999e-17
C1636 0 FILL_L30_10 3.9436800000000006e-18
C1637 0 FILL_L30_11 7.01785e-18
C1638 0 FILL_L30_15 5.4925700000000003e-17
C1639 0 FILL_L30_16 3.7812300000000003e-18
C1640 0 FILL_L30_17 1.2510100000000001e-17
C1641 0 FILL_L30_18 1.5598100000000001e-19
C1642 0 FILL_L30_8 2.4191300000000001e-18
C1643 0 FILL_L30_9 2.5336400000000003e-18
C1644 0 FILL_L50_10 9.4924600000000004e-18
C1645 0 FILL_L50_14 2.64376e-18
C1646 0 FILL_L50_16 3.00888e-17
C1647 0 FILL_L50_17 6.3724200000000011e-17
C1648 0 FILL_L8_6 1.1466700000000001e-17
C1649 0 FILL_L8_9 8.3586500000000014e-18
C1655 0 FILL_L30_0 1.47213e-18
C1656 0 FILL_L50_2 7.3971000000000005e-18
C1662 0 FILL_L10_0 9.2318199999999995e-19
C1663 0 FILL_L30_0 9.9194600000000013e-18
C1664 0 FILL_L30_1 9.9283400000000018e-18
C1665 0 FILL_L50_2 5.7536100000000005e-18
C1666 0 FILL_L50_3 2.4021400000000002e-18
C1670 0 FILL_L50_2 7.2299400000000008e-18
C1677 0 FILL_L10_0 1.3468000000000003e-16
C1678 0 FILL_L10_1 9.7923600000000002e-17
C1679 0 FILL_L10_2 1.7241900000000001e-18
C1680 0 FILL_L10_3 1.2138600000000001e-17
C1681 0 FILL_L30_0 3.4044600000000004e-17
C1682 0 FILL_L30_1 4.2009099999999999e-17
C1683 0 FILL_L30_2 3.0774300000000001e-17
C1684 0 FILL_L30_3 1.5890300000000002e-17
C1685 0 FILL_L30_4 2.0898600000000001e-17
C1686 0 FILL_L50_0 8.8645799999999996e-19
C1687 0 FILL_L50_2 9.5416300000000018e-17
C1688 0 FILL_L50_3 1.1028900000000001e-16
C1689 0 FILL_L8_0 2.8808900000000001e-17
C1690 0 FILL_L8_3 1.6719400000000001e-18
C1697 0 FILL_L50_2 4.6697699999999996e-19
C1698 0 FILL_L50_9 6.17628e-19
C1704 0 FILL_L50_15 7.6258800000000007e-19
C1710 0 FILL_L10_0 4.6181700000000006e-18
C1711 0 FILL_L10_1 4.23156e-19
C1712 0 FILL_L10_3 5.7059600000000007e-17
C1713 0 FILL_L10_4 3.8885599999999999e-17
C1714 0 FILL_L10_5 8.7830700000000014e-18
C1715 0 FILL_L30_0 2.7240300000000003e-18
C1716 0 FILL_L30_1 2.8472000000000001e-18
C1717 0 FILL_L30_3 2.6007800000000001e-17
C1718 0 FILL_L30_4 3.3831800000000004e-19
C1719 0 FILL_L30_7 9.8406000000000014e-18
C1720 0 FILL_L50_10 3.3645400000000004e-17
C1721 0 FILL_L50_2 5.4220200000000004e-17
C1722 0 FILL_L50_3 7.0932900000000009e-17
C1723 0 FILL_L50_9 1.3903000000000001e-17
C1724 0 FILL_L8_3 5.9838200000000006e-17
C1728 0 FILL_L30_7 1.01227e-19
C1729 0 FILL_L50_2 7.8882100000000005e-19
C1730 0 FILL_L50_9 1.33614e-17
C1734 0 FILL_L50_2 2.6488700000000002e-18
C1735 0 FILL_L50_9 9.0601299999999993e-18
C1740 0 FILL_L30_7 3.6731300000000002e-19
C1741 0 FILL_L50_10 1.1330499999999999e-18
C1742 0 FILL_L50_2 3.2646700000000003e-19
C1743 0 FILL_L50_9 8.8672699999999998e-18
C1748 0 FILL_L30_7 7.7216800000000004e-19
C1749 0 FILL_L50_10 2.8663900000000003e-18
C1750 0 FILL_L50_9 2.8081800000000003e-18
C1753 0 FILL_L50_2 1.1175699999999999e-18
C1754 0 FILL_L50_9 2.88761e-17
C1756 0 FILL_L10_4 3.7656000000000001e-19
C1757 0 FILL_L30_12 2.3463700000000003e-19
C1758 0 FILL_L30_7 1.8602600000000003e-18
C1759 0 FILL_L50_10 1.6132100000000004e-17
C1760 0 FILL_L50_3 8.2010300000000005e-19
C1762 0 FILL_L50_10 1.0332399999999999e-18
C1763 0 FILL_L50_9 1.7558000000000002e-17
C1766 0 FILL_L50_12 9.5007400000000003e-19
C1767 0 FILL_L50_13 2.0533900000000001e-18
C1768 0 FILL_L50_15 4.0870899999999999e-18
C1769 0 FILL_L50_20 9.8528199999999999e-18
C1771 0 FILL_L30_10 1.2573700000000002e-18
C1772 0 FILL_L30_8 7.0738000000000001e-18
C1773 0 FILL_L30_9 8.6653300000000019e-18
C1774 0 FILL_L50_10 1.3509500000000001e-18
C1775 0 FILL_L50_9 1.0373799999999999e-17
C1779 0 FILL_L30_0 1.14696e-18
C1780 0 FILL_L50_2 7.7868800000000012e-19
C1789 0 FILL_L10_0 1.15635e-18
C1790 0 FILL_L50_3 7.1542700000000007e-19
C1792 0 FILL_L30_0 1.9951700000000004e-18
C1793 0 FILL_L50_2 3.3806800000000002e-18
C1795 0 FILL_L50_2 1.62302e-18
C1797 0 FILL_L30_1 5.3230100000000004e-19
C1798 0 FILL_L30_2 6.5111800000000002e-19
C1799 0 FILL_L50_3 2.8220000000000001e-18
C1801 0 FILL_L10_1 3.2429300000000003e-18
C1802 0 FILL_L10_2 1.17073e-18
C1803 0 FILL_L30_2 7.3379099999999998e-18
C1804 0 FILL_L50_3 2.3341000000000002e-18
C1805 0 FILL_L8_0 1.1740000000000001e-17
C1810 0 FILL_L50_1 1.8564900000000003e-19
C1811 0 FILL_L50_5 7.6325900000000008e-18
C1812 0 FILL_L50_6 1.89928e-17
C1814 0 FILL_L50_13 3.4631700000000002e-18
C1815 0 FILL_L50_20 1.6035900000000003e-17
C1819 0 FILL_L50_6 2.79482e-17
C1822 0 FILL_L30_6 2.9637200000000006e-19
C1823 0 FILL_L50_6 2.2412800000000003e-18
C1828 0 FILL_L50_13 4.5460800000000005e-18
C1829 0 FILL_L50_5 2.6523100000000003e-18
C1830 0 FILL_L50_6 5.7324100000000001e-18
C1831 0 FILL_L50_8 2.10341e-18
C1833 0 FILL_L50_13 7.66727e-18
C1834 0 FILL_L50_6 9.6681000000000017e-18
C1837 0 FILL_L30_14 2.9637200000000006e-19
C1838 0 FILL_L50_13 2.2412800000000003e-18
C1841 0 FILL_L50_12 3.1251400000000002e-18
C1842 0 FILL_L50_13 2.2458200000000003e-17
C1843 0 FILL_L50_8 1.6407500000000001e-18
C1845 0 FILL_L50_13 3.2410600000000002e-17
C1848 0 FILL_L50_1 3.2291400000000005e-18
C1849 0 FILL_L50_5 1.1955900000000001e-18
C1850 0 FILL_L50_6 2.15003e-17
C1852 0 FILL_L50_6 3.0795000000000003e-17
C1854 FILL_L10_0 FILL_L10_1 2.7935199999999999e-17
C1855 FILL_L10_0 FILL_L30_1 2.7232700000000005e-17
C1856 FILL_L10_0 FILL_L30_2 6.9870900000000006e-18
C1857 FILL_L10_0 FILL_L30_4 5.333980000000001e-19
C1858 FILL_L10_0 FILL_L50_10 1.4671500000000001e-18
C1859 FILL_L10_0 FILL_L50_3 5.3945900000000005e-17
C1860 FILL_L10_0 0 6.6648300000000006e-17
C1861 FILL_L10_1 FILL_L10_2 2.7935199999999999e-17
C1862 FILL_L10_1 FILL_L10_3 2.7935199999999999e-17
C1863 FILL_L10_1 FILL_L30_2 5.1321e-17
C1864 FILL_L10_1 FILL_L30_3 1.7474700000000001e-18
C1865 FILL_L10_1 FILL_L30_4 4.6154600000000001e-18
C1866 FILL_L10_1 FILL_L50_0 1.9454000000000001e-18
C1867 FILL_L10_1 FILL_L50_3 2.5647800000000003e-17
C1868 FILL_L10_1 FILL_L8_0 1.7365700000000001e-18
C1869 FILL_L10_1 0 7.0528400000000014e-17
C1870 FILL_L10_10 FILL_L10_11 2.7935199999999999e-17
C1871 FILL_L10_10 FILL_L30_16 6.9870900000000006e-18
C1872 FILL_L10_10 FILL_L50_10 8.8612100000000019e-19
C1873 FILL_L10_10 FILL_L50_17 4.1044100000000005e-17
C1874 FILL_L10_10 FILL_L50_24 8.5109600000000014e-18
C1875 FILL_L10_10 0 6.0711900000000007e-17
C1876 FILL_L10_11 FILL_L10_12 2.7935199999999999e-17
C1877 FILL_L10_11 FILL_L10_9 2.7935199999999999e-17
C1878 FILL_L10_11 FILL_L30_16 5.1346300000000005e-17
C1879 FILL_L10_11 FILL_L30_17 1.7474700000000001e-18
C1880 FILL_L10_11 FILL_L50_17 1.27648e-17
C1881 FILL_L10_11 FILL_L50_18 1.9454000000000001e-18
C1882 FILL_L10_11 FILL_L50_24 4.5015300000000003e-18
C1883 FILL_L10_11 FILL_L8_9 3.1540500000000004e-19
C1884 FILL_L10_11 0 5.6628800000000002e-17
C1885 FILL_L10_12 FILL_L10_13 9.7773300000000019e-17
C1886 FILL_L10_12 FILL_L10_8 9.7773300000000019e-17
C1887 FILL_L10_12 FILL_L10_9 2.7935199999999999e-17
C1888 FILL_L10_12 FILL_L30_16 1.31218e-18
C1889 FILL_L10_12 FILL_L30_17 9.0101000000000002e-16
C1890 FILL_L10_12 FILL_L30_18 6.3996100000000007e-18
C1891 FILL_L10_12 FILL_L30_20 1.2232300000000001e-17
C1892 FILL_L10_12 FILL_L50_17 1.0391900000000001e-17
C1893 FILL_L10_12 FILL_L50_18 6.3179400000000006e-18
C1894 FILL_L10_12 FILL_L50_21 3.8908000000000001e-18
C1895 FILL_L10_12 FILL_L8_10 3.0100800000000002e-17
C1896 FILL_L10_12 FILL_L8_9 8.2350600000000007e-16
C1897 FILL_L10_12 0 2.0981900000000001e-16
C1898 FILL_L10_13 FILL_L30_20 3.1758400000000004e-16
C1899 FILL_L10_13 FILL_L30_21 2.7091700000000002e-18
C1900 FILL_L10_13 FILL_L50_24 1.0382400000000001e-17
C1901 FILL_L10_13 FILL_L8_12 2.9881500000000001e-16
C1902 FILL_L10_13 FILL_L8_13 1.0922300000000001e-17
C1903 FILL_L10_13 0 2.2155699999999999e-16
C1904 FILL_L10_2 FILL_L10_5 9.7773300000000019e-17
C1905 FILL_L10_2 FILL_L30_2 1.4109400000000003e-18
C1906 FILL_L10_2 FILL_L30_4 5.6317700000000006e-16
C1907 FILL_L10_2 FILL_L30_5 3.1998100000000002e-18
C1908 FILL_L10_2 FILL_L50_0 9.0523000000000007e-18
C1909 FILL_L10_2 FILL_L50_3 1.8483100000000001e-18
C1910 FILL_L10_2 FILL_L8_0 5.2469100000000007e-16
C1911 FILL_L10_2 FILL_L8_1 1.91785e-17
C1912 FILL_L10_2 0 2.47392e-16
C1913 FILL_L10_3 FILL_L10_4 2.7935199999999999e-17
C1914 FILL_L10_3 FILL_L10_5 2.7935199999999999e-17
C1915 FILL_L10_3 FILL_L30_3 6.8152600000000008e-17
C1916 FILL_L10_3 FILL_L30_4 3.4774700000000002e-18
C1917 FILL_L10_3 FILL_L50_3 2.4930800000000003e-17
C1918 FILL_L10_3 FILL_L50_4 3.8713500000000006e-18
C1919 FILL_L10_3 FILL_L8_3 3.3807600000000004e-18
C1920 FILL_L10_3 0 6.8068799999999996e-17
C1921 FILL_L10_4 FILL_L10_5 2.7935199999999999e-17
C1922 FILL_L10_4 FILL_L10_6 2.7935199999999999e-17
C1923 FILL_L10_4 FILL_L30_12 1.3805000000000001e-18
C1924 FILL_L10_4 FILL_L30_3 1.73e-18
C1925 FILL_L10_4 FILL_L30_7 5.1198500000000004e-17
C1926 FILL_L10_4 FILL_L50_10 1.6140000000000002e-17
C1927 FILL_L10_4 FILL_L50_3 1.9259500000000001e-18
C1928 FILL_L10_4 FILL_L50_7 1.5368700000000001e-18
C1929 FILL_L10_4 FILL_L8_3 2.9906900000000001e-18
C1930 FILL_L10_4 0 6.3361600000000003e-17
C1931 FILL_L10_5 FILL_L10_8 9.7773300000000019e-17
C1932 FILL_L10_5 FILL_L30_12 3.6457100000000004e-16
C1933 FILL_L10_5 FILL_L30_13 1.0666000000000002e-18
C1934 FILL_L10_5 FILL_L30_4 4.8960399999999998e-16
C1935 FILL_L10_5 FILL_L30_5 2.1332000000000003e-18
C1936 FILL_L10_5 FILL_L50_4 2.0753100000000001e-17
C1937 FILL_L10_5 FILL_L50_7 2.0753100000000001e-17
C1938 FILL_L10_5 FILL_L8_3 8.2350600000000007e-16
C1939 FILL_L10_5 FILL_L8_4 3.0100800000000002e-17
C1940 FILL_L10_5 0 2.0577600000000002e-16
C1941 FILL_L10_6 FILL_L10_7 2.7935199999999999e-17
C1942 FILL_L10_6 FILL_L10_8 2.7935199999999999e-17
C1943 FILL_L10_6 FILL_L30_11 2.7232700000000005e-17
C1944 FILL_L10_6 FILL_L30_12 5.7359700000000001e-18
C1945 FILL_L10_6 FILL_L30_7 6.9395899999999999e-18
C1946 FILL_L10_6 FILL_L50_10 3.3437100000000005e-17
C1947 FILL_L10_6 FILL_L8_6 8.9518900000000004e-19
C1948 FILL_L10_6 0 4.0926500000000002e-17
C1949 FILL_L10_7 FILL_L10_8 2.7935199999999999e-17
C1950 FILL_L10_7 FILL_L10_9 2.7935199999999999e-17
C1951 FILL_L10_7 FILL_L30_11 1.5013700000000002e-17
C1952 FILL_L10_7 FILL_L30_15 1.5013700000000002e-17
C1953 FILL_L10_7 FILL_L50_10 5.2194600000000001e-18
C1954 FILL_L10_7 FILL_L50_17 5.2194600000000001e-18
C1955 FILL_L10_7 FILL_L8_6 2.4162800000000001e-18
C1956 FILL_L10_7 0 5.3683000000000006e-17
C1957 FILL_L10_8 FILL_L30_10 3.4032400000000006e-19
C1958 FILL_L10_8 FILL_L30_11 2.7090100000000005e-18
C1959 FILL_L10_8 FILL_L30_12 7.2743800000000001e-16
C1960 FILL_L10_8 FILL_L30_13 4.2664099999999996e-18
C1961 FILL_L10_8 FILL_L30_17 1.1839000000000001e-16
C1962 FILL_L10_8 FILL_L50_10 2.9720700000000002e-18
C1963 FILL_L10_8 FILL_L50_11 1.6862300000000003e-17
C1964 FILL_L10_8 FILL_L50_14 1.4435200000000002e-17
C1965 FILL_L10_8 FILL_L8_6 8.2350600000000007e-16
C1966 FILL_L10_8 FILL_L8_7 3.0100800000000002e-17
C1967 FILL_L10_8 0 2.0907100000000001e-16
C1968 FILL_L10_9 FILL_L30_15 2.7232700000000005e-17
C1969 FILL_L10_9 FILL_L30_16 6.9172200000000007e-18
C1970 FILL_L10_9 FILL_L30_17 5.4491700000000003e-18
C1971 FILL_L10_9 FILL_L50_17 3.7147599999999998e-17
C1972 FILL_L10_9 FILL_L8_9 2.2066300000000003e-18
C1973 FILL_L10_9 0 5.2701099999999998e-17
C1974 FILL_L30_0 FILL_L30_1 1.92731e-17
C1975 FILL_L30_0 FILL_L50_2 1.3912300000000001e-16
C1976 FILL_L30_0 0 6.6522400000000006e-17
C1977 FILL_L30_1 FILL_L30_2 1.92731e-17
C1978 FILL_L30_1 FILL_L50_3 1.3606299999999999e-16
C1979 FILL_L30_1 0 5.5304300000000002e-17
C1980 FILL_L30_10 FILL_L30_11 1.92731e-17
C1981 FILL_L30_10 FILL_L30_9 1.92731e-17
C1982 FILL_L30_10 FILL_L50_10 1.1613900000000001e-16
C1983 FILL_L30_10 FILL_L50_17 2.8868500000000002e-18
C1984 FILL_L30_10 0 3.2519199999999999e-17
C1985 FILL_L30_11 FILL_L30_12 1.92731e-17
C1986 FILL_L30_11 FILL_L30_15 1.92731e-17
C1987 FILL_L30_11 FILL_L30_7 1.92731e-17
C1988 FILL_L30_11 FILL_L50_10 1.3300400000000001e-16
C1989 FILL_L30_11 0 3.1073300000000002e-17
C1990 FILL_L30_12 FILL_L30_13 7.7092600000000011e-17
C1991 FILL_L30_12 FILL_L30_17 7.7092600000000011e-17
C1992 FILL_L30_12 FILL_L30_4 7.7092600000000011e-17
C1993 FILL_L30_12 FILL_L30_7 1.92731e-17
C1994 FILL_L30_12 FILL_L50_10 2.7474400000000002e-17
C1995 FILL_L30_12 FILL_L50_11 1.51697e-16
C1996 FILL_L30_12 FILL_L50_7 1.51697e-16
C1997 FILL_L30_12 FILL_L8_3 2.9687900000000004e-17
C1998 FILL_L30_12 FILL_L8_4 5.5859600000000004e-18
C1999 FILL_L30_12 FILL_L8_6 3.4212900000000001e-17
C2000 FILL_L30_12 FILL_L8_7 2.22518e-17
C2001 FILL_L30_12 0 2.0615900000000001e-16
C2002 FILL_L30_13 FILL_L30_14 7.7092600000000011e-17
C2003 FILL_L30_13 FILL_L30_18 7.7092600000000011e-17
C2004 FILL_L30_13 FILL_L30_5 7.7092600000000011e-17
C2005 FILL_L30_13 FILL_L8_4 1.0388500000000001e-16
C2006 FILL_L30_13 FILL_L8_5 1.2130100000000001e-17
C2007 FILL_L30_13 FILL_L8_7 2.0501800000000002e-16
C2008 FILL_L30_13 FILL_L8_8 4.8520400000000006e-17
C2009 FILL_L30_13 N 6.9818800000000003e-18
C2010 FILL_L30_13 P 2.2902200000000002e-18
C2011 FILL_L30_13 0 2.0777800000000001e-16
C2012 FILL_L30_14 FILL_L30_19 7.7092600000000011e-17
C2013 FILL_L30_14 FILL_L30_6 7.7092600000000011e-17
C2014 FILL_L30_14 FILL_L8_5 6.2000500000000005e-17
C2015 FILL_L30_14 FILL_L8_8 1.38165e-16
C2016 FILL_L30_14 N 2.5466800000000001e-17
C2017 FILL_L30_14 P 8.8909700000000004e-17
C2018 FILL_L30_14 0 3.1910800000000004e-16
C2019 FILL_L30_15 FILL_L30_16 1.92731e-17
C2020 FILL_L30_15 FILL_L30_17 1.92731e-17
C2021 FILL_L30_15 FILL_L50_16 1.17617e-18
C2022 FILL_L30_15 FILL_L50_17 1.3508800000000001e-16
C2023 FILL_L30_15 0 3.3468600000000004e-17
C2024 FILL_L30_16 FILL_L30_17 1.92731e-17
C2025 FILL_L30_16 FILL_L50_16 1.2878400000000001e-18
C2026 FILL_L30_16 FILL_L50_17 1.3606299999999999e-16
C2027 FILL_L30_16 FILL_L50_24 3.5485699999999998e-18
C2028 FILL_L30_16 0 5.2997000000000002e-17
C2029 FILL_L30_17 FILL_L30_18 7.7092600000000011e-17
C2030 FILL_L30_17 FILL_L30_20 7.7092600000000011e-17
C2031 FILL_L30_17 FILL_L50_14 1.51697e-16
C2032 FILL_L30_17 FILL_L50_17 2.7183700000000004e-17
C2033 FILL_L30_17 FILL_L50_18 1.51697e-16
C2034 FILL_L30_17 FILL_L8_10 3.3481200000000003e-17
C2035 FILL_L30_17 FILL_L8_6 1.7621300000000003e-17
C2036 FILL_L30_17 FILL_L8_9 2.9176600000000002e-17
C2037 FILL_L30_17 0 2.1430900000000001e-16
C2038 FILL_L30_18 FILL_L30_19 7.7092600000000011e-17
C2039 FILL_L30_18 FILL_L30_21 7.7092600000000011e-17
C2040 FILL_L30_18 FILL_L8_10 2.4852400000000001e-16
C2041 FILL_L30_18 FILL_L8_11 7.2780600000000012e-17
C2042 FILL_L30_18 FILL_L8_7 4.5396500000000003e-17
C2043 FILL_L30_18 N 6.9818800000000003e-18
C2044 FILL_L30_18 P 2.2902200000000002e-18
C2045 FILL_L30_18 0 2.0857900000000001e-16
C2046 FILL_L30_19 FILL_L30_22 7.7092600000000011e-17
C2047 FILL_L30_19 FILL_L8_11 1.76462e-16
C2048 FILL_L30_19 FILL_L8_8 2.36851e-17
C2049 FILL_L30_19 N 2.5466800000000001e-17
C2050 FILL_L30_19 P 8.8909700000000004e-17
C2051 FILL_L30_19 0 3.1903200000000001e-16
C2052 FILL_L30_2 FILL_L30_3 1.92731e-17
C2053 FILL_L30_2 FILL_L30_4 1.92731e-17
C2054 FILL_L30_2 FILL_L50_3 1.3300400000000001e-16
C2055 FILL_L30_2 FILL_L8_0 8.9723800000000006e-19
C2056 FILL_L30_2 0 5.3724700000000005e-17
C2057 FILL_L30_20 FILL_L30_21 2.4476900000000003e-17
C2058 FILL_L30_20 FILL_L50_21 1.2265600000000001e-16
C2059 FILL_L30_20 FILL_L50_24 1.0057200000000001e-17
C2060 FILL_L30_20 FILL_L8_12 3.8311500000000006e-18
C2061 FILL_L30_20 FILL_L8_13 1.4096300000000001e-17
C2062 FILL_L30_20 0 2.1182800000000002e-16
C2063 FILL_L30_21 FILL_L30_22 2.4476900000000003e-17
C2064 FILL_L30_21 FILL_L8_10 9.1148399999999992e-18
C2065 FILL_L30_21 FILL_L8_13 9.3343599999999997e-17
C2066 FILL_L30_21 FILL_L8_14 3.0810400000000004e-17
C2067 FILL_L30_21 N 2.2167500000000005e-18
C2068 FILL_L30_21 P 7.2714500000000005e-19
C2069 FILL_L30_21 0 1.9812799999999999e-16
C2070 FILL_L30_22 FILL_L8_11 4.7555700000000003e-18
C2071 FILL_L30_22 FILL_L8_14 6.8512e-17
C2072 FILL_L30_22 N 8.0857200000000011e-18
C2073 FILL_L30_22 P 2.9714800000000005e-17
C2074 FILL_L30_22 0 2.3677799999999999e-16
C2075 FILL_L30_3 FILL_L30_4 1.92731e-17
C2076 FILL_L30_3 FILL_L30_7 1.92731e-17
C2077 FILL_L30_3 FILL_L50_2 1.3473900000000001e-18
C2078 FILL_L30_3 FILL_L50_3 1.3606299999999999e-16
C2079 FILL_L30_3 FILL_L8_3 5.1734999999999999e-19
C2080 FILL_L30_3 0 4.3361400000000004e-17
C2081 FILL_L30_4 FILL_L30_5 7.7092600000000011e-17
C2082 FILL_L30_4 FILL_L50_0 1.51697e-16
C2083 FILL_L30_4 FILL_L50_3 2.7702200000000003e-17
C2084 FILL_L30_4 FILL_L50_4 1.51697e-16
C2085 FILL_L30_4 FILL_L8_0 3.2704500000000003e-17
C2086 FILL_L30_4 FILL_L8_1 1.6757899999999999e-17
C2087 FILL_L30_4 FILL_L8_3 3.11962e-17
C2088 FILL_L30_4 FILL_L8_4 1.1171900000000001e-17
C2089 FILL_L30_4 0 3.00279e-16
C2090 FILL_L30_5 FILL_L30_6 7.7092600000000011e-17
C2091 FILL_L30_5 FILL_L8_1 1.4997300000000003e-16
C2092 FILL_L30_5 FILL_L8_2 3.6390300000000006e-17
C2093 FILL_L30_5 FILL_L8_4 1.40634e-16
C2094 FILL_L30_5 FILL_L8_5 2.4260200000000003e-17
C2095 FILL_L30_5 N 6.9818800000000003e-18
C2096 FILL_L30_5 P 2.2902200000000002e-18
C2097 FILL_L30_5 0 2.9470400000000001e-16
C2098 FILL_L30_6 FILL_L8_2 1.01646e-16
C2099 FILL_L30_6 FILL_L8_5 8.8973700000000006e-17
C2100 FILL_L30_6 N 2.5466800000000001e-17
C2101 FILL_L30_6 P 8.7439400000000006e-17
C2102 FILL_L30_6 0 4.03104e-16
C2103 FILL_L30_7 FILL_L50_10 1.3606299999999999e-16
C2104 FILL_L30_7 FILL_L50_9 5.7319900000000007e-19
C2105 FILL_L30_7 0 3.83709e-17
C2106 FILL_L30_8 FILL_L30_9 1.92731e-17
C2107 FILL_L30_8 FILL_L50_16 2.4393900000000002e-18
C2108 FILL_L30_8 FILL_L50_9 1.1589800000000001e-16
C2109 FILL_L30_8 0 5.4201600000000006e-17
C2110 FILL_L30_9 FILL_L50_16 2.5548600000000004e-18
C2111 FILL_L30_9 FILL_L50_9 1.1613900000000001e-16
C2112 FILL_L30_9 0 3.0091600000000001e-17
C2113 FILL_L50_0 FILL_L50_3 2.4713600000000001e-17
C2114 FILL_L50_0 FILL_L50_4 2.4713600000000001e-17
C2115 FILL_L50_0 0 3.3661999999999999e-17
C2116 FILL_L50_1 FILL_L50_5 2.4713600000000001e-17
C2117 FILL_L50_1 FILL_L50_6 2.4713600000000001e-17
C2118 FILL_L50_1 0 6.803230000000001e-17
C2119 FILL_L50_10 FILL_L50_11 2.4713600000000001e-17
C2120 FILL_L50_10 FILL_L50_17 9.8854299999999996e-17
C2121 FILL_L50_10 FILL_L50_3 9.8854299999999996e-17
C2122 FILL_L50_10 FILL_L50_7 2.4713600000000001e-17
C2123 FILL_L50_10 FILL_L50_9 9.8854299999999996e-17
C2124 FILL_L50_10 0 1.5444200000000001e-16
C2125 FILL_L50_11 FILL_L50_14 2.4713600000000001e-17
C2126 FILL_L50_11 FILL_L50_7 2.4713600000000001e-17
C2127 FILL_L50_11 0 1.1653100000000002e-17
C2128 FILL_L50_12 FILL_L50_13 2.4713600000000001e-17
C2129 FILL_L50_12 FILL_L50_15 2.4713600000000001e-17
C2130 FILL_L50_12 FILL_L50_8 2.4713600000000001e-17
C2131 FILL_L50_12 0 4.8505600000000002e-17
C2132 FILL_L50_13 FILL_L50_20 9.8854299999999996e-17
C2133 FILL_L50_13 FILL_L50_6 9.8854299999999996e-17
C2134 FILL_L50_13 FILL_L50_8 2.4713600000000001e-17
C2135 FILL_L50_13 0 3.5862700000000002e-16
C2136 FILL_L50_14 FILL_L50_17 2.4713600000000001e-17
C2137 FILL_L50_14 FILL_L50_18 2.4713600000000001e-17
C2138 FILL_L50_14 0 1.07477e-17
C2139 FILL_L50_15 FILL_L50_19 2.4713600000000001e-17
C2140 FILL_L50_15 FILL_L50_20 2.4713600000000001e-17
C2141 FILL_L50_15 0 4.7426699999999997e-17
C2142 FILL_L50_16 FILL_L50_17 9.8854299999999996e-17
C2143 FILL_L50_16 FILL_L50_23 9.8854299999999996e-17
C2144 FILL_L50_16 FILL_L50_9 9.8854299999999996e-17
C2145 FILL_L50_16 0 2.3506900000000002e-16
C2146 FILL_L50_17 FILL_L50_18 2.4713600000000001e-17
C2147 FILL_L50_17 FILL_L50_24 9.8854299999999996e-17
C2148 FILL_L50_17 0 1.52874e-16
C2149 FILL_L50_18 FILL_L50_21 2.4713600000000001e-17
C2150 FILL_L50_18 0 1.58568e-17
C2151 FILL_L50_19 FILL_L50_20 2.4713600000000001e-17
C2152 FILL_L50_19 FILL_L50_22 2.4713600000000001e-17
C2153 FILL_L50_19 0 4.1394599999999997e-17
C2154 FILL_L50_2 FILL_L50_3 9.8854299999999996e-17
C2155 FILL_L50_2 FILL_L50_9 9.8854299999999996e-17
C2156 FILL_L50_2 0 3.1589700000000001e-16
C2157 FILL_L50_20 FILL_L50_25 9.8854299999999996e-17
C2158 FILL_L50_20 0 3.5664700000000003e-16
C2159 FILL_L50_21 FILL_L50_24 2.4713600000000001e-17
C2160 FILL_L50_21 0 4.3969800000000002e-17
C2161 FILL_L50_22 FILL_L50_25 2.4713600000000001e-17
C2162 FILL_L50_22 0 6.3165600000000002e-17
C2163 FILL_L50_23 FILL_L50_24 3.1386200000000003e-17
C2164 FILL_L50_23 0 2.07057e-16
C2165 FILL_L50_24 0 1.8606500000000002e-16
C2166 FILL_L50_25 0 2.3471700000000004e-16
C2167 FILL_L50_3 FILL_L50_4 2.4713600000000001e-17
C2168 FILL_L50_3 FILL_L8_3 1.4039700000000001e-19
C2169 FILL_L50_3 0 2.3908900000000004e-16
C2170 FILL_L50_4 FILL_L50_7 2.4713600000000001e-17
C2171 FILL_L50_4 0 7.8963300000000009e-18
C2172 FILL_L50_5 FILL_L50_6 2.4713600000000001e-17
C2173 FILL_L50_5 FILL_L50_8 2.4713600000000001e-17
C2174 FILL_L50_5 0 4.2598900000000005e-17
C2175 FILL_L50_6 0 4.3738700000000004e-16
C2176 FILL_L50_7 0 9.0644399999999998e-18
C2177 FILL_L50_8 0 4.1395000000000005e-17
C2178 FILL_L50_9 0 2.2991399999999999e-16
C2179 FILL_L8_0 FILL_L8_1 4.44068e-17
C2180 FILL_L8_0 FILL_L8_3 6.96968e-17
C2181 FILL_L8_0 0 6.0530700000000002e-16
C2182 FILL_L8_1 FILL_L8_2 4.44068e-17
C2183 FILL_L8_1 FILL_L8_4 6.96968e-17
C2184 FILL_L8_1 0 5.949080000000001e-16
C2185 FILL_L8_10 FILL_L8_11 6.96968e-17
C2186 FILL_L8_10 FILL_L8_13 6.96968e-17
C2187 FILL_L8_10 FILL_L8_7 6.96968e-17
C2188 FILL_L8_10 FILL_L8_9 6.96968e-17
C2189 FILL_L8_10 0 7.5091400000000008e-16
C2190 FILL_L8_11 FILL_L8_14 6.96968e-17
C2191 FILL_L8_11 FILL_L8_8 6.96968e-17
C2192 FILL_L8_11 N 1.9203800000000003e-16
C2193 FILL_L8_11 P 1.4087300000000001e-16
C2194 FILL_L8_11 0 7.9409500000000004e-16
C2195 FILL_L8_12 FILL_L8_13 2.529e-17
C2196 FILL_L8_12 FILL_L8_9 6.96968e-17
C2197 FILL_L8_12 0 4.3341600000000003e-16
C2198 FILL_L8_13 FILL_L8_14 2.529e-17
C2199 FILL_L8_13 0 4.3310100000000004e-16
C2200 FILL_L8_14 N 7.0963100000000007e-17
C2201 FILL_L8_14 P 5.2397399999999998e-17
C2202 FILL_L8_14 0 4.4876900000000007e-16
C2203 FILL_L8_2 FILL_L8_5 6.96968e-17
C2204 FILL_L8_2 N 1.21075e-16
C2205 FILL_L8_2 P 8.8475700000000008e-17
C2206 FILL_L8_2 0 6.2242100000000008e-16
C2207 FILL_L8_3 FILL_L8_4 6.96968e-17
C2208 FILL_L8_3 FILL_L8_6 6.96968e-17
C2209 FILL_L8_3 0 7.7175699999999999e-16
C2210 FILL_L8_4 FILL_L8_5 6.96968e-17
C2211 FILL_L8_4 FILL_L8_7 6.96968e-17
C2212 FILL_L8_4 0 7.5091400000000008e-16
C2213 FILL_L8_5 FILL_L8_8 6.96968e-17
C2214 FILL_L8_5 N 1.9203800000000003e-16
C2215 FILL_L8_5 P 1.4087300000000001e-16
C2216 FILL_L8_5 0 7.9409500000000004e-16
C2217 FILL_L8_6 FILL_L8_7 6.96968e-17
C2218 FILL_L8_6 FILL_L8_9 6.96968e-17
C2219 FILL_L8_6 0 7.619450000000001e-16
C2220 FILL_L8_7 FILL_L8_8 6.96968e-17
C2221 FILL_L8_7 0 7.5091400000000008e-16
C2222 FILL_L8_8 N 1.9203800000000003e-16
C2223 FILL_L8_8 P 1.4087300000000001e-16
C2224 FILL_L8_8 0 7.9409500000000004e-16
C2225 FILL_L8_9 0 7.6002400000000004e-16
C2226 N P 3.3182999999999999e-15
C2227 N 0 9.8231000000000001e-17
C2228 P 0 6.9910900000000009e-17
VP P 0 DC 0 AC 1
VN N 0 DC 0 AC 0
.control
set numdgt=17
ac lin 1 1Meg 1Meg
let cp = -imag(i(VP))/(2*pi*1e6)
let cn = -imag(i(VN))/(2*pi*1e6)
print cp cn
quit
.endc
.end
