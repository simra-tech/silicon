* no_fill floating drive N; diagnostic capacitor-network AC only
C580 0 N 2.94672e-17
C581 0 P 2.1973000000000002e-17
C611 0 N 1.5219900000000003e-17
C612 0 P 1.8783000000000002e-17
C725 0 N 2.4541200000000003e-17
C726 0 P 2.9459100000000004e-17
C771 0 N 8.3544200000000006e-17
C772 0 P 2.8703500000000001e-17
C795 0 N 1.0038200000000001e-19
C796 0 P 1.4308399999999999e-19
C801 0 N 1.3678700000000001e-15
C802 0 P 6.4718300000000003e-19
C811 0 N 2.98397e-17
C812 0 P 2.2345500000000002e-17
C848 0 N 1.4399200000000003e-17
C849 0 P 2.0004200000000004e-18
C856 0 N 1.2387300000000001e-16
C857 0 P 1.2384300000000001e-16
C870 0 P 3.4877500000000003e-15
C930 0 N 1.1984e-17
C931 0 P 3.8530500000000005e-18
C1059 N P 3.4877500000000003e-15
C1060 N 0 4.0302700000000001e-16
C1061 P 0 8.9118800000000001e-17
VP P 0 DC 0 AC 0
VN N 0 DC 0 AC 1
.control
set numdgt=17
ac lin 1 1Meg 1Meg
let cp = -imag(i(VP))/(2*pi*1e6)
let cn = -imag(i(VN))/(2*pi*1e6)
print cp cn
quit
.endc
.end
