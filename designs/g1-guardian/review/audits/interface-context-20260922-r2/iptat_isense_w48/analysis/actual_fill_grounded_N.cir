* actual_fill grounded drive N; diagnostic capacitor-network AC only
C714 0 N 2.8850100000000003e-17
C715 0 P 2.1973000000000002e-17
C795 0 N 1.5173700000000001e-17
C796 0 P 1.87259e-17
C982 0 N 2.4479500000000003e-17
C983 0 P 2.9385200000000003e-17
C1087 0 N 6.4053799999999994e-17
C1088 0 P 2.8591500000000001e-17
C1181 0 N 1.0038200000000001e-19
C1182 0 P 1.4308399999999999e-19
C1224 0 N 1.3678700000000001e-15
C1225 0 P 6.4718300000000003e-19
C1293 0 N 2.6109400000000004e-17
C1294 0 P 2.2345500000000002e-17
C1404 0 N 1.4308899999999999e-17
C1405 0 P 2.0004200000000004e-18
C1473 0 N 1.2387300000000001e-16
C1474 0 P 1.2384300000000001e-16
C1533 0 P 3.4877500000000003e-15
C1702 0 N 1.16519e-17
C1703 0 P 3.8117600000000003e-18
C1904 0 N 5.3580200000000006e-19
C1905 0 P 4.3091600000000004e-19
C1960 0 N 1.26457e-18
C1961 0 P 1.0394800000000001e-18
C2063 0 N 3.6374899999999999e-17
C2064 0 P 3.2587700000000003e-18
C2122 0 N 5.0775300000000004e-17
C2123 0 P 3.6381800000000002e-18
C2135 0 N 2.3091400000000004e-18
C2187 0 N 5.2383900000000001e-17
C2188 0 P 2.7546200000000002e-18
C2196 0 N 5.3043199999999998e-18
C2297 0 N 2.4807800000000001e-19
C2298 0 P 3.1888300000000006e-19
C2303 0 N 1.1391300000000001e-19
C2304 0 P 1.4642600000000002e-19
C2322 0 N 2.8873199999999999e-18
C2323 0 P 5.3937200000000003e-18
C2330 0 N 2.34989e-18
C2331 0 P 1.3518400000000001e-18
C2360 0 N 5.0331300000000003e-17
C2370 0 N 2.4862500000000002e-17
C2393 0 N 5.0331300000000003e-17
C2403 0 N 5.0331300000000003e-17
C2411 0 N 2.4862500000000002e-17
C2433 0 N 5.1766899999999998e-18
C2464 0 N 2.1894100000000004e-17
C2503 0 P 2.5932400000000002e-19
C2506 0 P 2.1385100000000004e-19
C2510 0 P 3.1666400000000002e-19
C2520 0 N 1.8052299999999998e-18
C2521 0 P 1.6427800000000001e-17
C2525 0 N 1.3216900000000001e-18
C2526 0 P 2.2012000000000005e-19
C2550 0 N 2.0783900000000003e-18
C2551 0 P 1.7085799999999999e-17
C2555 0 N 1.93149e-18
C2556 0 P 3.6000900000000005e-19
C2574 0 N 1.57364e-18
C2575 0 P 1.2717700000000001e-17
C2580 0 N 1.3023700000000001e-18
C2596 N P 3.4877500000000003e-15
C2597 N 0 1.7323800000000002e-16
C2598 P 0 6.1439100000000008e-17
VP P 0 DC 0 AC 0
VN N 0 DC 0 AC 1
.control
set numdgt=17
ac lin 1 1Meg 1Meg
let cp = -imag(i(VP))/(2*pi*1e6)
let cn = -imag(i(VN))/(2*pi*1e6)
print cp cn
quit
.endc
.end
