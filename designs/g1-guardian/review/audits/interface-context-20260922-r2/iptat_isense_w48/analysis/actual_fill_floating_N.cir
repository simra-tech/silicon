* actual_fill floating drive N; diagnostic capacitor-network AC only
C37 0 FILL_L10_0 2.4298500000000003e-19
C38 0 FILL_L10_28 9.614490000000001e-18
C39 0 FILL_L10_6 1.4579100000000001e-19
C40 0 FILL_L50_2 9.4090600000000013e-18
C41 0 FILL_L8_0 3.24929e-18
C42 0 FILL_L8_1 3.2547300000000006e-19
C43 0 FILL_L8_18 4.4501600000000007e-18
C44 0 FILL_L8_19 3.2547300000000006e-19
C45 0 FILL_L8_21 1.4688700000000001e-17
C79 0 FILL_L10_28 4.5639700000000005e-18
C107 0 FILL_L50_17 2.2840200000000001e-19
C108 0 FILL_L50_2 1.7038400000000001e-18
C109 0 FILL_L50_9 9.4891300000000012e-17
C137 0 FILL_L10_27 7.4919600000000003e-17
C138 0 FILL_L50_9 3.2221200000000002e-19
C139 0 FILL_L8_0 2.20747e-18
C140 0 FILL_L8_18 1.0018499999999999e-17
C141 0 FILL_L8_21 3.6054400000000004e-17
C142 0 FILL_L8_22 5.4630800000000007e-19
C179 0 FILL_L10_0 1.1606900000000002e-19
C180 0 FILL_L50_2 4.4605500000000002e-17
C181 0 FILL_L50_9 3.93391e-18
C182 0 FILL_L8_0 1.2315700000000001e-18
C183 0 FILL_L8_18 8.006510000000001e-18
C184 0 FILL_L8_21 5.3419999999999998e-18
C208 0 FILL_L10_28 1.0746800000000001e-18
C209 0 FILL_L50_9 1.4441000000000001e-18
C210 0 FILL_L8_21 2.00708e-17
C211 0 FILL_L8_22 2.0785699999999999e-19
C244 0 FILL_L50_2 1.79207e-16
C245 0 FILL_L8_18 1.7603700000000003e-18
C288 0 FILL_L50_16 3.8870399999999999e-18
C289 0 FILL_L50_17 1.59737e-17
C290 0 FILL_L50_2 5.9953100000000005e-18
C291 0 FILL_L50_23 7.894440000000001e-19
C292 0 FILL_L50_9 1.6262400000000001e-16
C293 0 FILL_L8_21 1.4723400000000001e-19
C307 0 FILL_L50_0 1.61788e-18
C308 0 FILL_L8_0 1.2411700000000001e-19
C309 0 FILL_L8_18 2.4763700000000003e-17
C349 0 FILL_L10_28 1.91293e-18
C350 0 FILL_L10_34 1.3169300000000001e-17
C351 0 FILL_L10_35 4.1074500000000004e-19
C352 0 FILL_L30_1 1.0407e-18
C353 0 FILL_L50_16 4.1118700000000006e-19
C354 0 FILL_L50_2 1.3100700000000001e-17
C355 0 FILL_L50_9 1.2588800000000003e-16
C356 0 FILL_L8_21 3.5838799999999999e-19
C357 0 FILL_L8_29 3.18547e-17
C377 0 FILL_L50_16 8.0026500000000005e-17
C378 0 FILL_L50_9 1.8800700000000001e-18
C420 0 FILL_L10_0 1.47622e-17
C421 0 FILL_L10_16 1.8774300000000001e-18
C422 0 FILL_L10_27 6.6439500000000004e-19
C423 0 FILL_L10_34 1.33296e-19
C424 0 FILL_L10_6 1.8881200000000001e-17
C425 0 FILL_L30_0 7.7092600000000005e-18
C426 0 FILL_L30_1 1.1188e-19
C427 0 FILL_L50_0 5.2843100000000002e-17
C428 0 FILL_L50_16 1.5055500000000001e-18
C429 0 FILL_L50_17 2.5151100000000003e-18
C430 0 FILL_L50_2 6.6120500000000011e-17
C431 0 FILL_L50_9 6.8217600000000015e-17
C432 0 FILL_L8_0 2.3786900000000001e-17
C433 0 FILL_L8_1 1.8745800000000001e-17
C434 0 FILL_L8_18 7.0772100000000006e-17
C435 0 FILL_L8_19 4.9147100000000006e-17
C436 0 FILL_L8_21 2.0574800000000002e-18
C437 0 FILL_L8_29 5.34418e-19
C466 0 FILL_L10_34 1.0762400000000002e-18
C467 0 FILL_L30_1 2.8171500000000001e-18
C468 0 FILL_L50_16 8.2640800000000011e-18
C469 0 FILL_L50_17 2.8536000000000004e-18
C470 0 FILL_L50_23 9.8115800000000011e-19
C471 0 FILL_L50_9 5.0344000000000003e-17
C472 0 FILL_L8_29 2.0840100000000004e-18
C501 0 FILL_L10_41 1.18613e-19
C502 0 FILL_L50_16 1.0442600000000001e-16
C503 0 FILL_L50_17 5.4209400000000007e-17
C504 0 FILL_L50_23 5.0737600000000002e-18
C505 0 FILL_L8_37 2.71987e-17
C528 0 FILL_L50_16 8.2136900000000006e-17
C529 0 FILL_L50_2 2.4307000000000004e-19
C530 0 FILL_L50_23 1.6117799999999999e-17
C531 0 FILL_L50_9 2.25599e-17
C550 0 FILL_L50_16 1.9408300000000002e-16
C551 0 FILL_L50_17 8.7901500000000009e-19
C552 0 FILL_L50_23 1.1307700000000002e-17
C588 0 FILL_L50_16 1.89331e-17
C589 0 FILL_L50_17 1.4367900000000002e-18
C590 0 FILL_L50_2 1.41127e-17
C591 0 FILL_L50_23 2.59638e-18
C592 0 FILL_L50_9 8.7388300000000008e-18
C593 0 FILL_L8_18 6.7836700000000011e-19
C609 0 FILL_L50_0 1.0873100000000001e-19
C610 0 FILL_L50_2 1.5310300000000001e-16
C643 0 FILL_L10_28 1.09462e-18
C644 0 FILL_L10_34 1.31114e-18
C645 0 FILL_L10_35 1.0489100000000001e-17
C646 0 FILL_L10_41 1.9002900000000002e-17
C647 0 FILL_L10_42 4.7436500000000002e-18
C648 0 FILL_L30_1 2.31842e-19
C649 0 FILL_L50_16 6.4998200000000003e-19
C650 0 FILL_L50_17 5.0125600000000001e-18
C651 0 FILL_L50_23 1.1031600000000002e-19
C652 0 FILL_L8_29 2.4769800000000005e-18
C653 0 FILL_L8_37 1.0967200000000001e-17
C678 0 FILL_L10_27 1.6046400000000002e-18
C679 0 FILL_L10_28 1.18203e-17
C680 0 FILL_L10_29 2.8772900000000003e-16
C681 0 FILL_L10_30 2.86513e-16
C682 0 FILL_L10_31 2.86513e-16
C683 0 FILL_L10_32 2.86513e-16
C684 0 FILL_L10_33 2.1644000000000002e-16
C685 0 FILL_L10_34 1.18203e-17
C686 0 FILL_L10_35 1.18203e-17
C687 0 FILL_L10_41 1.18203e-17
C688 0 FILL_L10_42 2.71867e-18
C689 0 FILL_L134_0 9.6988700000000008e-18
C690 0 FILL_L134_1 7.8456700000000008e-19
C691 0 FILL_L30_1 9.6759100000000012e-19
C692 0 FILL_L30_14 2.50476e-19
C693 0 FILL_L30_15 1.25238e-19
C694 0 FILL_L30_2 1.8420200000000003e-17
C695 0 FILL_L30_3 7.1557000000000011e-18
C696 0 FILL_L50_10 4.5235000000000006e-18
C697 0 FILL_L50_11 2.8468200000000006e-16
C698 0 FILL_L50_12 2.8353400000000001e-16
C699 0 FILL_L50_13 2.8353400000000001e-16
C700 0 FILL_L50_14 1.2038700000000002e-16
C701 0 FILL_L50_8 2.1507200000000002e-17
C702 0 FILL_L8_21 5.0482800000000004e-17
C703 0 FILL_L8_22 2.2041300000000002e-16
C704 0 FILL_L8_23 1.35046e-16
C705 0 FILL_L8_24 3.1802700000000003e-18
C706 0 FILL_L8_25 3.2205200000000002e-18
C707 0 FILL_L8_26 3.2205200000000002e-18
C708 0 FILL_L8_27 3.2205200000000002e-18
C709 0 FILL_L8_28 1.6102600000000001e-18
C710 0 FILL_L8_29 5.8978099999999996e-17
C711 0 FILL_L8_30 1.19295e-16
C712 0 FILL_L8_37 4.6033300000000003e-17
C713 0 FILL_L8_38 9.3052800000000017e-17
C714 0 N 2.8850100000000003e-17
C715 0 P 2.1973000000000002e-17
C731 0 FILL_L10_0 8.8464700000000007e-18
C732 0 FILL_L10_16 1.1488900000000001e-17
C733 0 FILL_L10_27 5.9104000000000005e-18
C734 0 FILL_L10_6 1.1488900000000001e-17
C735 0 FILL_L30_0 4.9031100000000003e-18
C736 0 FILL_L30_14 4.9031100000000003e-18
C737 0 FILL_L30_15 3.5134200000000004e-18
C738 0 FILL_L30_3 2.9409200000000002e-17
C739 0 FILL_L30_4 4.9031100000000003e-18
C740 0 FILL_L50_0 3.8470400000000003e-19
C741 0 FILL_L8_1 7.2997600000000016e-17
C742 0 FILL_L8_18 4.9955900000000001e-18
C743 0 FILL_L8_19 3.1992300000000003e-16
C744 0 FILL_L8_2 1.8176900000000002e-18
C745 0 FILL_L8_20 2.3606400000000001e-18
C746 0 FILL_L8_21 2.27873e-18
C747 0 FILL_L8_22 3.1992300000000003e-16
C748 0 FILL_L8_23 1.2637800000000001e-17
C749 0 FILL_L8_30 3.1992300000000003e-16
C750 0 FILL_L8_31 1.2728800000000001e-17
C751 0 FILL_L8_38 2.4692500000000001e-16
C752 0 FILL_L8_39 9.928430000000001e-18
C753 0 FILL_L8_8 2.3606400000000001e-18
C767 0 FILL_L10_1 9.3719500000000004e-18
C768 0 FILL_L10_17 1.4294000000000001e-17
C769 0 FILL_L10_29 5.0029100000000004e-17
C770 0 FILL_L10_36 5.0029100000000004e-17
C771 0 FILL_L10_43 3.9022700000000004e-17
C772 0 FILL_L10_7 1.2171400000000001e-17
C773 0 FILL_L30_0 4.1447000000000008e-18
C774 0 FILL_L30_14 4.1227600000000004e-18
C775 0 FILL_L30_15 2.9074e-18
C776 0 FILL_L30_4 3.6203200000000002e-18
C777 0 FILL_L30_5 4.2143900000000006e-17
C778 0 FILL_L50_10 6.8915199999999999e-19
C779 0 FILL_L50_11 4.4786399999999999e-19
C780 0 FILL_L50_18 2.2512300000000004e-18
C781 0 FILL_L50_19 2.20946e-18
C782 0 FILL_L50_3 1.1485900000000001e-18
C783 0 FILL_L50_4 1.8661000000000004e-18
C784 0 FILL_L8_1 1.4210900000000002e-18
C785 0 FILL_L8_19 6.7650200000000001e-18
C786 0 FILL_L8_2 9.7503800000000007e-18
C787 0 FILL_L8_20 1.2662800000000002e-17
C788 0 FILL_L8_22 6.0626900000000004e-18
C789 0 FILL_L8_23 3.2539200000000003e-16
C790 0 FILL_L8_30 6.4594800000000007e-18
C791 0 FILL_L8_31 3.2388600000000005e-16
C792 0 FILL_L8_38 4.8538400000000001e-18
C793 0 FILL_L8_39 2.50016e-16
C794 0 FILL_L8_8 1.2662800000000002e-17
C795 0 N 1.5173700000000001e-17
C796 0 P 1.87259e-17
C828 0 FILL_L50_2 1.0439600000000001e-16
C829 0 FILL_L50_9 6.6060000000000001e-18
C851 0 FILL_L10_0 1.2292700000000001e-17
C852 0 FILL_L10_16 1.5964500000000002e-17
C853 0 FILL_L10_6 1.5964500000000002e-17
C854 0 FILL_L50_0 7.2398700000000003e-18
C855 0 FILL_L50_2 2.12151e-17
C856 0 FILL_L50_9 1.1423600000000001e-17
C857 0 FILL_L8_0 3.3916800000000007e-17
C858 0 FILL_L8_18 1.57658e-16
C859 0 FILL_L8_19 2.10562e-18
C898 0 FILL_L10_0 5.2298900000000004e-18
C899 0 FILL_L10_16 7.0430699999999999e-18
C900 0 FILL_L10_27 1.4021599999999999e-17
C901 0 FILL_L10_28 1.2618600000000002e-17
C902 0 FILL_L10_34 1.11274e-17
C903 0 FILL_L10_35 1.1695800000000001e-17
C904 0 FILL_L10_41 1.0864800000000001e-17
C905 0 FILL_L10_42 2.3553600000000005e-18
C906 0 FILL_L10_6 6.5805000000000005e-18
C907 0 FILL_L30_1 2.4478600000000002e-17
C908 0 FILL_L30_2 6.4618500000000008e-18
C909 0 FILL_L30_3 3.1209300000000001e-18
C910 0 FILL_L50_0 3.1298000000000001e-17
C911 0 FILL_L50_16 1.5504800000000001e-17
C912 0 FILL_L50_17 7.5128899999999998e-18
C913 0 FILL_L50_2 1.2884400000000001e-17
C914 0 FILL_L50_23 2.6499799999999999e-18
C915 0 FILL_L50_9 1.35971e-17
C916 0 FILL_L8_0 1.3102000000000002e-17
C917 0 FILL_L8_1 7.1466700000000014e-18
C918 0 FILL_L8_18 6.8858900000000012e-17
C919 0 FILL_L8_19 3.2484800000000005e-17
C920 0 FILL_L8_21 6.0373900000000008e-17
C921 0 FILL_L8_22 2.7284800000000001e-17
C922 0 FILL_L8_29 5.5335400000000005e-17
C923 0 FILL_L8_30 3.1290300000000001e-17
C924 0 FILL_L8_37 4.4773200000000008e-17
C925 0 FILL_L8_38 2.0470200000000001e-17
C941 0 FILL_L10_0 2.7828100000000001e-18
C942 0 FILL_L10_1 2.0984100000000001e-18
C943 0 FILL_L10_16 3.6140400000000007e-18
C944 0 FILL_L10_17 2.21167e-18
C945 0 FILL_L10_18 2.1373400000000003e-18
C946 0 FILL_L10_29 2.8820800000000003e-17
C947 0 FILL_L10_36 3.6027400000000003e-17
C948 0 FILL_L10_43 6.2968700000000008e-18
C949 0 FILL_L10_6 3.6140400000000007e-18
C950 0 FILL_L30_0 3.4193300000000004e-17
C951 0 FILL_L30_14 2.9215199999999998e-17
C952 0 FILL_L30_15 1.79193e-17
C953 0 FILL_L30_2 3.6739700000000006e-18
C954 0 FILL_L30_3 7.604160000000001e-18
C955 0 FILL_L30_4 2.9634200000000002e-17
C956 0 FILL_L30_5 9.0497100000000002e-18
C957 0 FILL_L50_1 3.57277e-18
C958 0 FILL_L50_10 3.57277e-18
C959 0 FILL_L50_11 4.0085600000000006e-18
C960 0 FILL_L50_15 3.57277e-18
C961 0 FILL_L50_18 3.5013200000000003e-18
C962 0 FILL_L50_19 4.0803200000000008e-18
C963 0 FILL_L50_3 3.57277e-18
C964 0 FILL_L50_4 4.10082e-18
C965 0 FILL_L50_8 3.5370400000000002e-18
C966 0 FILL_L8_0 3.7227500000000005e-18
C967 0 FILL_L8_1 1.3415900000000001e-17
C968 0 FILL_L8_18 2.2639800000000002e-17
C969 0 FILL_L8_19 6.1823200000000002e-17
C970 0 FILL_L8_2 6.2372500000000012e-18
C971 0 FILL_L8_20 8.718710000000001e-18
C972 0 FILL_L8_21 2.6055700000000002e-17
C973 0 FILL_L8_22 5.2222900000000009e-17
C974 0 FILL_L8_23 5.9215600000000007e-17
C975 0 FILL_L8_29 2.6038000000000003e-17
C976 0 FILL_L8_30 5.79938e-17
C977 0 FILL_L8_31 5.8453200000000009e-17
C978 0 FILL_L8_37 1.9510300000000003e-17
C979 0 FILL_L8_38 4.0900599999999999e-17
C980 0 FILL_L8_39 4.8816200000000004e-17
C981 0 FILL_L8_8 8.718710000000001e-18
C982 0 N 2.4479500000000003e-17
C983 0 P 2.9385200000000003e-17
C1020 0 FILL_L10_0 2.9258800000000001e-18
C1021 0 FILL_L10_1 1.95976e-18
C1022 0 FILL_L10_16 6.4212300000000009e-18
C1023 0 FILL_L10_17 3.32537e-18
C1024 0 FILL_L10_18 4.4897700000000006e-18
C1025 0 FILL_L10_19 5.09774e-18
C1026 0 FILL_L10_2 7.5551800000000002e-18
C1027 0 FILL_L10_27 6.748370000000001e-18
C1028 0 FILL_L10_28 3.1142e-18
C1029 0 FILL_L10_29 1.05582e-16
C1030 0 FILL_L10_30 3.9462300000000003e-17
C1031 0 FILL_L10_31 5.1314600000000003e-18
C1032 0 FILL_L10_34 1.9824100000000001e-18
C1033 0 FILL_L10_35 1.6888900000000002e-18
C1034 0 FILL_L10_36 1.6013500000000001e-16
C1035 0 FILL_L10_37 5.6982100000000007e-17
C1036 0 FILL_L10_38 1.5089900000000002e-17
C1037 0 FILL_L10_43 9.3361500000000016e-17
C1038 0 FILL_L10_44 6.4184900000000007e-17
C1039 0 FILL_L10_45 1.9719899999999999e-17
C1040 0 FILL_L10_6 4.3398300000000006e-18
C1041 0 FILL_L10_7 4.5526100000000007e-19
C1042 0 FILL_L10_8 6.6841600000000003e-19
C1043 0 FILL_L30_1 2.5073100000000003e-18
C1044 0 FILL_L30_15 1.5122100000000002e-19
C1045 0 FILL_L30_2 3.9488099999999999e-18
C1046 0 FILL_L30_3 3.86983e-18
C1047 0 FILL_L30_5 5.9535000000000007e-18
C1048 0 FILL_L30_6 1.9314400000000001e-18
C1049 0 FILL_L30_7 4.7910100000000007e-18
C1050 0 FILL_L50_0 4.8534700000000004e-18
C1051 0 FILL_L50_1 4.3655400000000009e-18
C1052 0 FILL_L50_10 1.2221700000000002e-17
C1053 0 FILL_L50_11 3.4778900000000001e-16
C1054 0 FILL_L50_12 6.7019300000000005e-17
C1055 0 FILL_L50_15 1.2813300000000001e-17
C1056 0 FILL_L50_16 2.4749200000000001e-17
C1057 0 FILL_L50_18 2.0890500000000001e-17
C1058 0 FILL_L50_19 3.6276700000000002e-16
C1059 0 FILL_L50_2 4.7967900000000002e-17
C1060 0 FILL_L50_20 5.03625e-17
C1061 0 FILL_L50_24 5.3157800000000004e-18
C1062 0 FILL_L50_25 1.5252400000000001e-18
C1063 0 FILL_L50_3 7.0138000000000004e-18
C1064 0 FILL_L50_4 1.1911e-16
C1065 0 FILL_L50_8 1.81907e-17
C1066 0 FILL_L50_9 5.6043300000000004e-17
C1067 0 FILL_L8_0 6.3087800000000004e-18
C1068 0 FILL_L8_1 7.7557499999999997e-18
C1069 0 FILL_L8_18 4.12833e-17
C1070 0 FILL_L8_19 4.2391200000000003e-17
C1071 0 FILL_L8_2 9.8393900000000005e-19
C1072 0 FILL_L8_20 1.65397e-18
C1073 0 FILL_L8_21 3.9378100000000008e-17
C1074 0 FILL_L8_22 3.71964e-17
C1075 0 FILL_L8_23 5.21804e-17
C1076 0 FILL_L8_24 2.3587799999999999e-18
C1077 0 FILL_L8_25 1.3067100000000001e-18
C1078 0 FILL_L8_29 2.9223300000000001e-17
C1079 0 FILL_L8_30 3.4376900000000001e-17
C1080 0 FILL_L8_31 4.4988500000000004e-17
C1081 0 FILL_L8_32 1.50179e-18
C1082 0 FILL_L8_33 2.10982e-18
C1083 0 FILL_L8_39 3.0039400000000001e-17
C1084 0 FILL_L8_40 3.1053600000000003e-18
C1085 0 FILL_L8_41 3.1053600000000003e-18
C1086 0 FILL_L8_8 1.4254700000000001e-18
C1087 0 N 6.4053799999999994e-17
C1088 0 P 2.8591500000000001e-17
C1095 0 FILL_L10_15 3.2813500000000003e-18
C1096 0 FILL_L10_22 2.3618000000000004e-18
C1097 0 FILL_L10_23 2.4478300000000002e-18
C1098 0 FILL_L10_24 3.8963899999999998e-18
C1099 0 FILL_L10_25 1.7188199999999999e-17
C1100 0 FILL_L10_26 1.8886099999999998e-18
C1101 0 FILL_L10_31 5.0248700000000001e-18
C1102 0 FILL_L10_32 1.2498700000000002e-18
C1103 0 FILL_L10_33 4.3549599999999998e-17
C1104 0 FILL_L10_38 8.9770800000000018e-18
C1105 0 FILL_L10_39 2.2557000000000001e-17
C1106 0 FILL_L10_4 7.8837200000000001e-18
C1107 0 FILL_L10_40 5.7357300000000002e-17
C1108 0 FILL_L10_45 1.0708600000000002e-17
C1109 0 FILL_L10_46 4.3279400000000007e-17
C1110 0 FILL_L10_47 6.0037100000000002e-17
C1111 0 FILL_L10_5 1.8072199999999998e-17
C1112 0 FILL_L134_0 3.6099700000000005e-16
C1113 0 FILL_L134_1 2.9514999999999997e-16
C1114 0 FILL_L30_12 4.2112299999999996e-18
C1115 0 FILL_L30_13 1.6159900000000003e-17
C1116 0 FILL_L50_12 8.3574800000000009e-18
C1117 0 FILL_L50_13 1.5651200000000001e-16
C1118 0 FILL_L50_14 1.8008600000000001e-16
C1119 0 FILL_L50_20 8.3574800000000009e-18
C1120 0 FILL_L50_21 1.5651200000000001e-16
C1121 0 FILL_L50_22 1.8014600000000001e-16
C1122 0 FILL_L50_25 1.5252400000000001e-18
C1123 0 FILL_L50_26 2.8563500000000001e-17
C1124 0 FILL_L50_27 3.3006300000000006e-17
C1125 0 FILL_L50_5 8.3574800000000009e-18
C1126 0 FILL_L50_6 1.5651200000000001e-16
C1127 0 FILL_L50_7 1.7607400000000001e-16
C1128 0 FILL_L8_17 9.55951e-19
C1129 0 FILL_L8_27 6.2311600000000007e-19
C1130 0 FILL_L8_28 7.3731200000000007e-18
C1131 0 FILL_L8_35 6.9484100000000006e-19
C1132 0 FILL_L8_36 5.6211399999999998e-18
C1133 0 FILL_L8_43 5.4914900000000009e-19
C1134 0 FILL_L8_44 2.4892300000000002e-18
C1135 0 FILL_L8_7 1.3651400000000001e-18
C1150 0 FILL_L10_16 6.4415100000000005e-18
C1151 0 FILL_L10_27 2.4655000000000003e-17
C1152 0 FILL_L10_28 1.3134900000000001e-17
C1153 0 FILL_L10_34 2.7632300000000004e-18
C1154 0 FILL_L10_35 3.2534700000000005e-18
C1155 0 FILL_L10_41 2.7186599999999999e-18
C1156 0 FILL_L10_42 4.2340000000000004e-19
C1157 0 FILL_L10_6 1.1709200000000001e-18
C1158 0 FILL_L30_0 7.1429400000000012e-18
C1159 0 FILL_L30_1 1.2315300000000001e-17
C1160 0 FILL_L30_14 2.42244e-18
C1161 0 FILL_L30_15 1.8044700000000003e-18
C1162 0 FILL_L30_2 5.9194600000000002e-18
C1163 0 FILL_L30_4 2.4718700000000003e-18
C1164 0 FILL_L30_5 1.2958900000000001e-17
C1165 0 FILL_L8_0 2.5451800000000005e-19
C1166 0 FILL_L8_1 1.0328e-18
C1167 0 FILL_L8_18 3.0407100000000002e-17
C1168 0 FILL_L8_19 4.9488300000000008e-17
C1169 0 FILL_L8_2 7.14146e-19
C1170 0 FILL_L8_20 6.4809000000000007e-18
C1171 0 FILL_L8_21 1.56774e-16
C1172 0 FILL_L8_22 6.7273600000000012e-17
C1173 0 FILL_L8_23 7.727910000000001e-17
C1174 0 FILL_L8_29 6.4969500000000002e-17
C1175 0 FILL_L8_30 8.0616299999999995e-18
C1176 0 FILL_L8_31 5.2386900000000003e-17
C1177 0 FILL_L8_37 4.87176e-17
C1178 0 FILL_L8_38 4.5762200000000006e-18
C1179 0 FILL_L8_39 4.4376300000000006e-17
C1180 0 FILL_L8_8 2.1914000000000001e-18
C1181 0 N 1.0038200000000001e-19
C1182 0 P 1.4308399999999999e-19
C1187 0 FILL_L10_1 5.1816800000000005e-18
C1188 0 FILL_L10_17 1.1098200000000002e-17
C1189 0 FILL_L10_18 6.1522000000000003e-18
C1190 0 FILL_L10_19 5.1024000000000007e-18
C1191 0 FILL_L10_2 2.2725e-18
C1192 0 FILL_L10_20 4.3594600000000008e-18
C1193 0 FILL_L10_21 4.3594600000000008e-18
C1194 0 FILL_L10_22 4.3594600000000008e-18
C1195 0 FILL_L10_23 4.3594600000000008e-18
C1196 0 FILL_L10_24 4.3594600000000008e-18
C1197 0 FILL_L10_25 4.3594600000000008e-18
C1198 0 FILL_L10_26 7.8470200000000004e-19
C1199 0 FILL_L10_29 1.8812000000000001e-16
C1200 0 FILL_L10_30 1.8915400000000002e-16
C1201 0 FILL_L10_31 1.8915400000000002e-16
C1202 0 FILL_L10_32 1.8915400000000002e-16
C1203 0 FILL_L10_33 1.4189099999999999e-16
C1204 0 FILL_L134_0 2.2225400000000002e-17
C1205 0 FILL_L134_1 2.55829e-18
C1206 0 FILL_L50_1 9.8265900000000003e-17
C1207 0 FILL_L50_11 1.9101800000000001e-16
C1208 0 FILL_L50_12 1.9101800000000001e-16
C1209 0 FILL_L50_13 1.9101800000000001e-16
C1210 0 FILL_L50_14 8.1530400000000005e-17
C1211 0 FILL_L50_3 1.0069900000000001e-16
C1212 0 FILL_L50_4 4.2291800000000008e-17
C1213 0 FILL_L50_5 1.4023500000000002e-17
C1214 0 FILL_L50_6 1.4023500000000002e-17
C1215 0 FILL_L50_7 5.8898700000000005e-18
C1216 0 FILL_L50_8 1.07493e-16
C1217 0 FILL_L8_23 4.0826600000000001e-18
C1218 0 FILL_L8_24 2.5716600000000002e-18
C1219 0 FILL_L8_25 3.2205200000000002e-18
C1220 0 FILL_L8_26 3.2205200000000002e-18
C1221 0 FILL_L8_27 3.2205200000000002e-18
C1222 0 FILL_L8_28 1.6102600000000001e-18
C1223 0 FILL_L8_3 2.8607300000000005e-19
C1224 0 N 1.3678700000000001e-15
C1225 0 P 6.4718300000000003e-19
C1234 0 FILL_L10_0 3.78335e-19
C1235 0 FILL_L10_16 4.9134400000000003e-19
C1236 0 FILL_L10_29 1.4053899999999999e-16
C1237 0 FILL_L10_30 1.4053899999999999e-16
C1238 0 FILL_L10_31 1.4053899999999999e-16
C1239 0 FILL_L10_32 1.4053899999999999e-16
C1240 0 FILL_L10_33 1.07612e-16
C1241 0 FILL_L10_36 4.7488300000000006e-17
C1242 0 FILL_L10_37 5.03764e-17
C1243 0 FILL_L10_38 5.0467700000000005e-17
C1244 0 FILL_L10_39 4.7488300000000006e-17
C1245 0 FILL_L10_40 3.7247700000000002e-17
C1246 0 FILL_L10_43 1.8939700000000001e-18
C1247 0 FILL_L10_44 2.3674600000000002e-18
C1248 0 FILL_L10_45 2.3674600000000002e-18
C1249 0 FILL_L10_46 1.8939700000000001e-18
C1250 0 FILL_L10_47 1.5720000000000002e-18
C1251 0 FILL_L10_6 4.9134400000000003e-19
C1252 0 FILL_L134_0 2.29389e-17
C1253 0 FILL_L134_1 2.5657800000000004e-18
C1254 0 FILL_L30_0 3.5065000000000004e-19
C1255 0 FILL_L30_10 1.8158600000000001e-17
C1256 0 FILL_L30_11 1.8158600000000001e-17
C1257 0 FILL_L30_12 1.8158600000000001e-17
C1258 0 FILL_L30_13 1.8158600000000001e-17
C1259 0 FILL_L30_3 1.3168200000000002e-18
C1260 0 FILL_L30_4 1.8158600000000001e-17
C1261 0 FILL_L30_5 1.8158600000000001e-17
C1262 0 FILL_L30_6 1.8158600000000001e-17
C1263 0 FILL_L30_7 1.8158600000000001e-17
C1264 0 FILL_L30_8 1.8158600000000001e-17
C1265 0 FILL_L30_9 1.8158600000000001e-17
C1266 0 FILL_L50_10 5.2148100000000004e-17
C1267 0 FILL_L50_11 2.23906e-16
C1268 0 FILL_L50_12 2.23906e-16
C1269 0 FILL_L50_13 2.23906e-16
C1270 0 FILL_L50_14 9.5256500000000008e-17
C1271 0 FILL_L50_19 1.1722300000000001e-17
C1272 0 FILL_L50_20 1.1722300000000001e-17
C1273 0 FILL_L50_21 1.1722300000000001e-17
C1274 0 FILL_L50_22 3.9855900000000008e-18
C1275 0 FILL_L8_1 1.05945e-17
C1276 0 FILL_L8_19 4.8221300000000004e-17
C1277 0 FILL_L8_22 7.2748400000000003e-17
C1278 0 FILL_L8_23 7.2785100000000003e-17
C1279 0 FILL_L8_24 4.2239000000000011e-18
C1280 0 FILL_L8_25 4.2239000000000011e-18
C1281 0 FILL_L8_26 4.2239000000000011e-18
C1282 0 FILL_L8_27 4.2239000000000011e-18
C1283 0 FILL_L8_28 3.2101600000000003e-18
C1284 0 FILL_L8_30 7.5029400000000008e-18
C1285 0 FILL_L8_31 5.5010500000000002e-17
C1286 0 FILL_L8_32 3.2598500000000004e-18
C1287 0 FILL_L8_33 3.2132800000000002e-18
C1288 0 FILL_L8_34 3.2598500000000004e-18
C1289 0 FILL_L8_35 3.2598500000000004e-18
C1290 0 FILL_L8_36 2.4961099999999999e-18
C1291 0 FILL_L8_38 2.8867399999999998e-19
C1292 0 FILL_L8_39 5.0604199999999999e-18
C1293 0 N 2.6109400000000004e-17
C1294 0 P 2.2345500000000002e-17
C1304 0 FILL_L10_27 1.1557800000000002e-18
C1305 0 FILL_L10_28 8.41335e-18
C1306 0 FILL_L10_34 2.4108600000000001e-17
C1307 0 FILL_L10_35 1.7424900000000003e-17
C1308 0 FILL_L10_41 1.8364500000000001e-17
C1309 0 FILL_L10_42 4.4469400000000003e-18
C1310 0 FILL_L30_1 6.74097e-17
C1311 0 FILL_L30_14 2.9393299999999999e-17
C1312 0 FILL_L30_15 2.1398200000000001e-17
C1313 0 FILL_L30_2 2.5545100000000004e-17
C1314 0 FILL_L30_3 2.7533200000000004e-17
C1315 0 FILL_L30_4 2.9393299999999999e-17
C1316 0 FILL_L8_18 2.04967e-18
C1317 0 FILL_L8_21 5.97697e-17
C1318 0 FILL_L8_22 4.0032400000000006e-17
C1319 0 FILL_L8_29 6.5531999999999999e-17
C1320 0 FILL_L8_30 9.2216900000000001e-17
C1321 0 FILL_L8_31 1.2555300000000001e-17
C1322 0 FILL_L8_37 1.8018600000000001e-17
C1323 0 FILL_L8_38 2.2332600000000001e-17
C1324 0 FILL_L8_39 9.3563800000000011e-18
C1337 0 FILL_L10_35 2.6737000000000003e-18
C1338 0 FILL_L10_41 3.7770600000000005e-17
C1339 0 FILL_L10_42 3.2915800000000004e-18
C1340 0 FILL_L30_1 9.5269300000000005e-18
C1341 0 FILL_L30_15 1.4001700000000001e-19
C1342 0 FILL_L30_2 9.5269300000000005e-18
C1343 0 FILL_L30_3 9.6257800000000021e-18
C1344 0 FILL_L50_23 5.0206000000000001e-18
C1345 0 FILL_L8_22 1.6848200000000001e-19
C1346 0 FILL_L8_29 2.53694e-17
C1347 0 FILL_L8_30 2.1993900000000001e-17
C1348 0 FILL_L8_37 1.2499700000000001e-16
C1349 0 FILL_L8_38 1.06833e-16
C1350 0 FILL_L8_39 3.2717500000000003e-18
C1360 0 FILL_L10_42 1.4539300000000001e-17
C1361 0 FILL_L30_15 2.8909699999999999e-18
C1362 0 FILL_L50_23 1.0831e-18
C1363 0 FILL_L8_37 6.1601500000000006e-17
C1364 0 FILL_L8_38 4.0654500000000002e-17
C1368 0 FILL_L10_36 9.7039000000000012e-18
C1369 0 FILL_L10_37 1.0386100000000002e-17
C1370 0 FILL_L10_38 1.0386100000000002e-17
C1371 0 FILL_L10_39 9.7039000000000012e-18
C1372 0 FILL_L10_40 7.5659800000000002e-18
C1373 0 FILL_L10_43 2.7799400000000003e-16
C1374 0 FILL_L10_44 2.6657300000000001e-16
C1375 0 FILL_L10_45 2.6594400000000006e-16
C1376 0 FILL_L10_46 2.6594400000000006e-16
C1377 0 FILL_L10_47 2.0069000000000001e-16
C1378 0 FILL_L134_0 7.7309100000000007e-18
C1379 0 FILL_L134_1 1.7161900000000002e-18
C1380 0 FILL_L30_10 7.4834200000000008e-18
C1381 0 FILL_L30_11 7.4834200000000008e-18
C1382 0 FILL_L30_12 7.4834200000000008e-18
C1383 0 FILL_L30_13 7.4834200000000008e-18
C1384 0 FILL_L30_15 5.7559000000000003e-18
C1385 0 FILL_L30_6 7.4834200000000008e-18
C1386 0 FILL_L30_7 7.4834200000000008e-18
C1387 0 FILL_L30_8 7.4834200000000008e-18
C1388 0 FILL_L30_9 7.4834200000000008e-18
C1389 0 FILL_L50_18 3.8237100000000004e-18
C1390 0 FILL_L50_19 2.5551300000000004e-17
C1391 0 FILL_L50_20 2.27278e-17
C1392 0 FILL_L50_21 2.27278e-17
C1393 0 FILL_L50_22 1.00644e-17
C1394 0 FILL_L50_24 4.9191400000000005e-17
C1395 0 FILL_L50_25 1.4059500000000002e-16
C1396 0 FILL_L50_26 1.4059500000000002e-16
C1397 0 FILL_L50_27 4.4184300000000006e-17
C1398 0 FILL_L8_39 1.4080700000000002e-17
C1399 0 FILL_L8_40 2.9543000000000001e-18
C1400 0 FILL_L8_41 3.2205200000000002e-18
C1401 0 FILL_L8_42 3.2205200000000002e-18
C1402 0 FILL_L8_43 3.2205200000000002e-18
C1403 0 FILL_L8_44 1.6102600000000001e-18
C1404 0 N 1.4308899999999999e-17
C1405 0 P 2.0004200000000004e-18
C1411 0 FILL_L10_1 8.5130700000000012e-17
C1412 0 FILL_L10_10 1.58505e-16
C1413 0 FILL_L10_11 1.58505e-16
C1414 0 FILL_L10_12 1.58505e-16
C1415 0 FILL_L10_13 1.58505e-16
C1416 0 FILL_L10_14 1.58505e-16
C1417 0 FILL_L10_15 1.55956e-16
C1418 0 FILL_L10_17 1.2781300000000001e-17
C1419 0 FILL_L10_18 1.2920400000000001e-17
C1420 0 FILL_L10_19 1.2649100000000002e-17
C1421 0 FILL_L10_2 2.8920600000000005e-16
C1422 0 FILL_L10_20 1.2781300000000001e-17
C1423 0 FILL_L10_21 1.2649100000000002e-17
C1424 0 FILL_L10_22 1.2781300000000001e-17
C1425 0 FILL_L10_23 1.2649100000000002e-17
C1426 0 FILL_L10_24 1.2781300000000001e-17
C1427 0 FILL_L10_25 1.2649100000000002e-17
C1428 0 FILL_L10_26 2.9457499999999999e-18
C1429 0 FILL_L10_29 4.0629999999999999e-18
C1430 0 FILL_L10_3 2.5007900000000004e-16
C1431 0 FILL_L10_30 3.9722300000000003e-18
C1432 0 FILL_L10_31 4.0629999999999999e-18
C1433 0 FILL_L10_32 4.0629999999999999e-18
C1434 0 FILL_L10_33 3.5586900000000004e-18
C1435 0 FILL_L10_4 2.4865100000000002e-16
C1436 0 FILL_L10_5 2.4801400000000003e-16
C1437 0 FILL_L10_7 1.6277900000000001e-16
C1438 0 FILL_L10_8 1.58505e-16
C1439 0 FILL_L10_9 1.58505e-16
C1440 0 FILL_L134_0 4.8763500000000001e-17
C1441 0 FILL_L134_1 4.00906e-18
C1442 0 FILL_L30_0 1.27509e-17
C1443 0 FILL_L50_1 1.8888900000000003e-16
C1444 0 FILL_L50_11 1.4259400000000002e-18
C1445 0 FILL_L50_12 1.6296500000000002e-18
C1446 0 FILL_L50_13 1.5685300000000002e-18
C1447 0 FILL_L50_14 6.1111700000000005e-19
C1448 0 FILL_L50_3 2.4520700000000002e-17
C1449 0 FILL_L50_4 1.03439e-15
C1450 0 FILL_L50_5 1.0206700000000001e-15
C1451 0 FILL_L50_6 1.0206700000000001e-15
C1452 0 FILL_L50_7 4.4333600000000005e-16
C1453 0 FILL_L50_8 4.0741100000000007e-19
C1454 0 FILL_L8_1 1.2225500000000001e-18
C1455 0 FILL_L8_10 2.5681999999999999e-17
C1456 0 FILL_L8_11 2.5605600000000002e-17
C1457 0 FILL_L8_12 2.5681999999999999e-17
C1458 0 FILL_L8_13 2.5681999999999999e-17
C1459 0 FILL_L8_14 2.5681999999999999e-17
C1460 0 FILL_L8_15 2.5681999999999999e-17
C1461 0 FILL_L8_16 2.5681999999999999e-17
C1462 0 FILL_L8_17 2.4262300000000001e-17
C1463 0 FILL_L8_19 6.29604e-18
C1464 0 FILL_L8_2 2.4874600000000003e-18
C1465 0 FILL_L8_23 2.9465800000000003e-18
C1466 0 FILL_L8_3 1.27868e-17
C1467 0 FILL_L8_4 3.9090800000000002e-17
C1468 0 FILL_L8_5 3.8139200000000004e-17
C1469 0 FILL_L8_6 3.8139200000000004e-17
C1470 0 FILL_L8_7 3.7784200000000003e-17
C1471 0 FILL_L8_8 7.687050000000001e-18
C1472 0 FILL_L8_9 2.5764500000000005e-17
C1473 0 N 1.2387300000000001e-16
C1474 0 P 1.2384300000000001e-16
C1478 0 FILL_L8_38 1.1022200000000001e-18
C1482 0 FILL_L30_0 9.2736800000000007e-18
C1483 0 FILL_L30_14 1.7596400000000004e-18
C1484 0 FILL_L30_15 1.19655e-18
C1485 0 FILL_L30_3 1.9678300000000001e-17
C1486 0 FILL_L30_4 1.7596400000000004e-18
C1487 0 FILL_L8_1 1.0593100000000001e-17
C1488 0 FILL_L8_19 4.5973100000000007e-17
C1489 0 FILL_L8_2 1.8848600000000002e-18
C1490 0 FILL_L8_20 2.4478700000000003e-18
C1491 0 FILL_L8_22 3.9131999999999998e-17
C1492 0 FILL_L8_23 7.3313800000000014e-18
C1493 0 FILL_L8_30 6.1883700000000006e-17
C1494 0 FILL_L8_38 3.9725600000000004e-17
C1495 0 FILL_L8_8 2.4478700000000003e-18
C1499 0 FILL_L30_0 2.2944299999999999e-17
C1500 0 FILL_L30_14 2.2851200000000001e-17
C1501 0 FILL_L30_15 1.6749400000000001e-17
C1502 0 FILL_L30_4 2.2944299999999999e-17
C1503 0 FILL_L30_5 1.5374400000000001e-18
C1504 0 FILL_L8_1 3.0512000000000004e-18
C1505 0 FILL_L8_19 1.4547800000000002e-17
C1506 0 FILL_L8_2 7.7953600000000004e-18
C1507 0 FILL_L8_20 1.0723699999999999e-17
C1508 0 FILL_L8_22 1.19811e-17
C1509 0 FILL_L8_23 3.09915e-17
C1510 0 FILL_L8_31 3.1426600000000002e-17
C1511 0 FILL_L8_39 2.4119599999999999e-17
C1512 0 FILL_L8_8 1.0723699999999999e-17
C1515 0 FILL_L10_1 4.6008100000000009e-19
C1516 0 FILL_L10_17 8.3637000000000004e-19
C1517 0 FILL_L10_29 2.5383800000000004e-18
C1518 0 FILL_L10_36 2.3499900000000001e-18
C1519 0 FILL_L10_43 2.2163800000000001e-18
C1520 0 FILL_L10_7 4.5859400000000005e-19
C1521 0 FILL_L30_0 3.0866700000000007e-19
C1522 0 FILL_L30_14 4.2414700000000004e-19
C1523 0 FILL_L30_15 1.9476100000000001e-19
C1524 0 FILL_L30_5 5.0477300000000002e-17
C1525 0 FILL_L30_6 2.7253600000000004e-19
C1526 0 FILL_L8_19 2.95089e-19
C1527 0 FILL_L8_2 1.7883700000000001e-18
C1528 0 FILL_L8_20 2.4729900000000001e-18
C1529 0 FILL_L8_23 5.5943600000000008e-17
C1530 0 FILL_L8_31 4.9781300000000005e-17
C1531 0 FILL_L8_39 4.4373600000000006e-17
C1532 0 FILL_L8_8 2.3362800000000002e-18
C1533 0 P 3.4877500000000003e-15
C1553 0 FILL_L10_0 2.6710900000000002e-18
C1554 0 FILL_L10_16 3.4689400000000002e-18
C1555 0 FILL_L10_27 1.01048e-17
C1556 0 FILL_L10_28 1.0884000000000002e-17
C1557 0 FILL_L10_34 8.1605700000000003e-18
C1558 0 FILL_L10_35 8.46242e-18
C1559 0 FILL_L10_41 7.7509200000000004e-18
C1560 0 FILL_L10_42 1.40925e-18
C1561 0 FILL_L10_6 3.4689400000000002e-18
C1562 0 FILL_L30_1 1.6057900000000001e-17
C1563 0 FILL_L50_0 8.4804800000000003e-17
C1564 0 FILL_L50_16 2.05673e-17
C1565 0 FILL_L50_17 1.1724900000000001e-17
C1566 0 FILL_L50_2 1.0626400000000001e-18
C1567 0 FILL_L8_0 1.18394e-17
C1568 0 FILL_L8_1 1.0675200000000002e-18
C1569 0 FILL_L8_18 5.9693900000000003e-17
C1570 0 FILL_L8_19 4.8523600000000007e-18
C1571 0 FILL_L8_21 1.3951100000000003e-17
C1572 0 FILL_L8_29 3.1424800000000002e-18
C1573 0 FILL_L8_37 6.6684100000000004e-18
C1575 0 FILL_L10_0 4.5605100000000002e-18
C1576 0 FILL_L10_16 5.9227400000000006e-18
C1577 0 FILL_L10_6 5.9227400000000006e-18
C1578 0 FILL_L30_0 1.8238e-19
C1579 0 FILL_L30_14 3.6476e-19
C1580 0 FILL_L30_15 1.8238e-19
C1581 0 FILL_L30_2 6.0853000000000003e-18
C1582 0 FILL_L30_3 3.5368400000000007e-17
C1583 0 FILL_L50_0 1.0618800000000001e-17
C1584 0 FILL_L8_0 6.1091300000000009e-18
C1585 0 FILL_L8_1 1.1319600000000001e-17
C1586 0 FILL_L8_18 3.5331600000000007e-17
C1587 0 FILL_L8_19 4.9680600000000004e-17
C1588 0 FILL_L8_21 3.0851400000000005e-17
C1589 0 FILL_L8_22 4.5113100000000004e-17
C1590 0 FILL_L8_29 3.0193600000000002e-17
C1591 0 FILL_L8_30 7.4330200000000005e-17
C1592 0 FILL_L8_37 8.1713000000000006e-18
C1593 0 FILL_L8_38 6.3133600000000007e-17
C1604 0 FILL_L50_2 6.2185499999999999e-18
C1611 0 FILL_L50_2 1.7820000000000002e-17
C1615 0 FILL_L50_2 5.9387400000000003e-18
C1622 0 FILL_L50_2 4.7008899999999998e-19
C1628 0 FILL_L50_2 5.7037100000000004e-18
C1634 0 FILL_L50_2 8.4166299999999996e-18
C1636 0 FILL_L10_1 1.5297400000000002e-18
C1637 0 FILL_L10_10 5.1456700000000007e-19
C1638 0 FILL_L10_11 5.1456700000000007e-19
C1639 0 FILL_L10_12 5.1456700000000007e-19
C1640 0 FILL_L10_13 5.1456700000000007e-19
C1641 0 FILL_L10_14 5.1456700000000007e-19
C1642 0 FILL_L10_15 5.1456700000000007e-19
C1643 0 FILL_L10_17 5.7463900000000001e-17
C1644 0 FILL_L10_18 5.1540700000000005e-17
C1645 0 FILL_L10_19 5.0924900000000002e-17
C1646 0 FILL_L10_2 2.6405800000000005e-19
C1647 0 FILL_L10_20 5.08099e-17
C1648 0 FILL_L10_21 5.08099e-17
C1649 0 FILL_L10_22 5.08099e-17
C1650 0 FILL_L10_23 5.08099e-17
C1651 0 FILL_L10_24 5.08099e-17
C1652 0 FILL_L10_25 5.08099e-17
C1653 0 FILL_L10_26 1.4624700000000002e-17
C1654 0 FILL_L10_29 3.5427400000000001e-18
C1655 0 FILL_L10_3 2.6405800000000005e-19
C1656 0 FILL_L10_30 3.5427400000000001e-18
C1657 0 FILL_L10_31 3.6783200000000002e-18
C1658 0 FILL_L10_32 3.6783200000000002e-18
C1659 0 FILL_L10_33 3.4071699999999999e-18
C1660 0 FILL_L10_4 2.6405800000000005e-19
C1661 0 FILL_L10_5 2.1652700000000002e-19
C1662 0 FILL_L10_7 2.5012500000000005e-18
C1663 0 FILL_L10_8 5.1456700000000007e-19
C1664 0 FILL_L10_9 5.1456700000000007e-19
C1665 0 FILL_L134_0 2.0100200000000003e-17
C1666 0 FILL_L134_1 2.3826299999999999e-18
C1667 0 FILL_L30_0 1.2871200000000001e-18
C1668 0 FILL_L30_9 2.3694400000000001e-19
C1669 0 FILL_L50_11 1.2341600000000001e-17
C1670 0 FILL_L50_12 9.6748400000000008e-18
C1671 0 FILL_L50_13 6.0517800000000002e-18
C1672 0 FILL_L50_14 2.5388000000000003e-18
C1673 0 FILL_L50_19 2.8287200000000005e-19
C1674 0 FILL_L50_3 2.89328e-18
C1675 0 FILL_L50_4 2.7057900000000001e-17
C1676 0 FILL_L50_5 2.2051800000000002e-17
C1677 0 FILL_L50_6 2.0428100000000003e-17
C1678 0 FILL_L50_7 1.0641700000000001e-17
C1679 0 FILL_L8_10 1.2984600000000001e-17
C1680 0 FILL_L8_11 1.2984600000000001e-17
C1681 0 FILL_L8_12 1.2984600000000001e-17
C1682 0 FILL_L8_13 1.2984600000000001e-17
C1683 0 FILL_L8_14 1.2984600000000001e-17
C1684 0 FILL_L8_15 1.2984600000000001e-17
C1685 0 FILL_L8_16 1.2984600000000001e-17
C1686 0 FILL_L8_17 1.2984600000000001e-17
C1687 0 FILL_L8_19 8.348340000000001e-18
C1688 0 FILL_L8_2 8.3086600000000006e-18
C1689 0 FILL_L8_20 1.0790500000000001e-17
C1690 0 FILL_L8_24 7.1176600000000001e-17
C1691 0 FILL_L8_25 7.1176600000000001e-17
C1692 0 FILL_L8_26 7.1176600000000001e-17
C1693 0 FILL_L8_27 7.1176600000000001e-17
C1694 0 FILL_L8_28 5.4500900000000002e-17
C1695 0 FILL_L8_3 1.5123699999999999e-17
C1696 0 FILL_L8_4 9.1454500000000009e-18
C1697 0 FILL_L8_5 9.1454500000000009e-18
C1698 0 FILL_L8_6 9.1454500000000009e-18
C1699 0 FILL_L8_7 9.1454500000000009e-18
C1700 0 FILL_L8_8 1.0790500000000001e-17
C1701 0 FILL_L8_9 3.2625799999999998e-17
C1702 0 N 1.16519e-17
C1703 0 P 3.8117600000000003e-18
C1711 0 FILL_L50_2 3.0796500000000004e-17
C1712 0 FILL_L8_18 2.2574200000000004e-17
C1725 0 FILL_L50_2 4.4386900000000004e-18
C1726 0 FILL_L50_9 5.2685200000000004e-18
C1729 0 FILL_L50_2 1.5952800000000002e-18
C1730 0 FILL_L50_9 3.1352700000000002e-18
C1733 0 FILL_L50_2 2.6641000000000001e-19
C1734 0 FILL_L50_9 1.5346600000000001e-18
C1737 0 FILL_L8_0 2.0601300000000003e-18
C1745 0 FILL_L50_9 4.5939800000000005e-19
C1750 0 FILL_L50_9 9.4167400000000022e-18
C1755 0 FILL_L50_17 3.0919700000000003e-19
C1756 0 FILL_L50_9 3.6686500000000006e-17
C1757 0 FILL_L8_21 2.3645700000000004e-17
C1761 0 FILL_L50_2 2.2608400000000001e-19
C1764 0 FILL_L50_9 1.3746000000000001e-17
C1771 0 FILL_L50_16 2.4466700000000002e-18
C1772 0 FILL_L50_9 7.0297400000000002e-19
C1779 0 FILL_L10_28 5.9061699999999994e-19
C1780 0 FILL_L10_34 1.8836000000000002e-19
C1781 0 FILL_L50_16 1.1789500000000002e-17
C1782 0 FILL_L50_17 1.1899300000000001e-18
C1783 0 FILL_L50_9 1.2097600000000001e-17
C1784 0 FILL_L8_21 8.0772999999999994e-18
C1785 0 FILL_L8_29 5.9867600000000006e-18
C1792 0 FILL_L50_16 7.8278999999999998e-18
C1795 0 FILL_L30_1 1.1619900000000001e-19
C1796 0 FILL_L50_16 1.7790200000000002e-18
C1797 0 FILL_L50_17 9.4739700000000018e-19
C1800 0 FILL_L30_1 6.0557900000000002e-19
C1801 0 FILL_L50_16 8.0001700000000006e-19
C1806 0 FILL_L50_16 1.6787600000000001e-17
C1809 0 FILL_L50_16 2.0901399999999999e-18
C1812 0 FILL_L50_16 8.9549500000000003e-18
C1813 0 FILL_L50_9 1.9943700000000002e-19
C1823 0 FILL_L10_35 2.2408000000000004e-18
C1824 0 FILL_L50_16 3.4138599999999998e-17
C1825 0 FILL_L50_17 6.4816600000000002e-18
C1826 0 FILL_L8_29 8.3750800000000015e-18
C1832 0 FILL_L50_17 3.1982200000000003e-18
C1838 0 FILL_L50_16 3.0623200000000005e-18
C1839 0 FILL_L50_23 1.6360300000000002e-19
C1843 0 FILL_L50_16 3.7127300000000003e-18
C1844 0 FILL_L50_17 1.7354800000000002e-19
C1845 0 FILL_L50_23 1.11326e-18
C1849 0 FILL_L50_16 9.8582400000000009e-18
C1850 0 FILL_L50_17 2.525e-18
C1855 0 FILL_L50_17 3.1785100000000006e-18
C1861 0 FILL_L50_17 1.32653e-18
C1866 0 FILL_L50_16 6.3181200000000006e-18
C1867 0 FILL_L50_23 3.20645e-18
C1870 0 FILL_L50_2 1.4957200000000003e-19
C1873 0 FILL_L50_17 5.0194100000000002e-19
C1877 0 FILL_L50_16 2.5129899999999999e-18
C1878 0 FILL_L50_23 2.4618000000000003e-18
C1881 0 FILL_L50_16 1.4130400000000002e-18
C1882 0 FILL_L50_17 8.1974900000000002e-19
C1883 0 FILL_L50_23 1.5977600000000002e-18
C1885 0 FILL_L10_42 5.8282100000000004e-19
C1886 0 FILL_L50_17 2.0608800000000001e-18
C1887 0 FILL_L50_23 2.4710400000000001e-17
C1888 0 FILL_L8_37 1.9518800000000001e-17
C1891 0 FILL_L50_2 1.35384e-18
C1893 0 FILL_L50_2 8.0146500000000007e-18
C1894 0 FILL_L8_0 1.2955900000000001e-17
C1896 FILL_L10_0 FILL_L10_6 2.7935199999999999e-17
C1897 FILL_L10_0 FILL_L8_0 8.4840800000000005e-17
C1898 FILL_L10_0 FILL_L8_1 6.6221700000000001e-18
C1899 FILL_L10_0 0 5.9715500000000009e-17
C1900 FILL_L10_1 FILL_L10_2 2.1510100000000004e-17
C1901 FILL_L10_1 FILL_L10_7 2.7935199999999999e-17
C1902 FILL_L10_1 FILL_L50_1 2.7412500000000003e-18
C1903 FILL_L10_1 FILL_L8_3 5.1763199999999999e-17
C1904 FILL_L10_1 N 5.3580200000000006e-19
C1905 FILL_L10_1 P 4.3091600000000004e-19
C1906 FILL_L10_1 0 7.7353800000000008e-17
C1907 FILL_L10_10 FILL_L10_11 2.7935199999999999e-17
C1908 FILL_L10_10 FILL_L10_20 1.39676e-17
C1909 FILL_L10_10 FILL_L10_3 2.7935199999999999e-17
C1910 FILL_L10_10 FILL_L10_9 2.7935199999999999e-17
C1911 FILL_L10_10 FILL_L8_12 6.7224999999999998e-17
C1912 FILL_L10_10 0 6.5701500000000001e-17
C1913 FILL_L10_11 FILL_L10_12 2.7935199999999999e-17
C1914 FILL_L10_11 FILL_L10_21 1.39676e-17
C1915 FILL_L10_11 FILL_L10_3 2.7935199999999999e-17
C1916 FILL_L10_11 FILL_L10_31 5.1652400000000006e-18
C1917 FILL_L10_11 FILL_L50_5 9.590400000000001e-18
C1918 FILL_L10_11 FILL_L8_13 6.7224999999999998e-17
C1919 FILL_L10_11 0 6.1893900000000006e-17
C1920 FILL_L10_12 FILL_L10_13 2.7935199999999999e-17
C1921 FILL_L10_12 FILL_L10_22 1.39676e-17
C1922 FILL_L10_12 FILL_L10_4 2.7935199999999999e-17
C1923 FILL_L10_12 FILL_L134_0 2.1063200000000004e-18
C1924 FILL_L10_12 FILL_L8_14 6.7224999999999998e-17
C1925 FILL_L10_12 0 6.5701500000000001e-17
C1926 FILL_L10_13 FILL_L10_14 2.7935199999999999e-17
C1927 FILL_L10_13 FILL_L10_23 1.39676e-17
C1928 FILL_L10_13 FILL_L10_32 5.1652400000000006e-18
C1929 FILL_L10_13 FILL_L10_4 2.7935199999999999e-17
C1930 FILL_L10_13 FILL_L134_0 9.2855200000000014e-19
C1931 FILL_L10_13 FILL_L50_6 9.590400000000001e-18
C1932 FILL_L10_13 FILL_L8_15 6.7224999999999998e-17
C1933 FILL_L10_13 0 6.1893900000000006e-17
C1934 FILL_L10_14 FILL_L10_15 2.7935199999999999e-17
C1935 FILL_L10_14 FILL_L10_24 1.39676e-17
C1936 FILL_L10_14 FILL_L10_5 2.7935199999999999e-17
C1937 FILL_L10_14 FILL_L134_0 2.7856599999999999e-19
C1938 FILL_L10_14 FILL_L50_13 1.54151e-18
C1939 FILL_L10_14 FILL_L50_6 9.590400000000001e-18
C1940 FILL_L10_14 FILL_L8_16 6.7224999999999998e-17
C1941 FILL_L10_14 0 6.5701500000000001e-17
C1942 FILL_L10_15 FILL_L10_25 1.39676e-17
C1943 FILL_L10_15 FILL_L10_33 5.1652400000000006e-18
C1944 FILL_L10_15 FILL_L10_5 2.7935199999999999e-17
C1945 FILL_L10_15 FILL_L50_7 5.3929000000000008e-18
C1946 FILL_L10_15 FILL_L8_17 6.7224999999999998e-17
C1947 FILL_L10_15 0 8.2678399999999999e-17
C1948 FILL_L10_16 FILL_L10_6 2.7935199999999999e-17
C1949 FILL_L10_16 FILL_L8_18 1.4740400000000001e-16
C1950 FILL_L10_16 FILL_L8_19 8.6002200000000009e-18
C1951 FILL_L10_16 FILL_L8_21 1.0479400000000001e-17
C1952 FILL_L10_16 FILL_L8_29 7.1222700000000006e-19
C1953 FILL_L10_16 0 3.1317799999999998e-17
C1954 FILL_L10_17 FILL_L10_18 2.7935199999999999e-17
C1955 FILL_L10_17 FILL_L10_29 2.7935199999999999e-17
C1956 FILL_L10_17 FILL_L10_7 1.39676e-17
C1957 FILL_L10_17 FILL_L50_3 2.1761200000000001e-17
C1958 FILL_L10_17 FILL_L50_8 3.8908000000000001e-18
C1959 FILL_L10_17 FILL_L8_9 1.51036e-18
C1960 FILL_L10_17 N 1.26457e-18
C1961 FILL_L10_17 P 1.0394800000000001e-18
C1962 FILL_L10_17 0 8.1147100000000002e-17
C1963 FILL_L10_18 FILL_L10_19 2.7935199999999999e-17
C1964 FILL_L10_18 FILL_L10_29 2.7935199999999999e-17
C1965 FILL_L10_18 FILL_L10_8 1.39676e-17
C1966 FILL_L10_18 FILL_L50_11 1.9454000000000001e-18
C1967 FILL_L10_18 FILL_L50_3 1.9454000000000001e-18
C1968 FILL_L10_18 FILL_L50_4 2.17566e-17
C1969 FILL_L10_18 FILL_L8_10 1.51036e-18
C1970 FILL_L10_18 0 7.3700199999999996e-17
C1971 FILL_L10_19 FILL_L10_2 5.1652400000000006e-18
C1972 FILL_L10_19 FILL_L10_20 2.7935199999999999e-17
C1973 FILL_L10_19 FILL_L10_30 2.7935199999999999e-17
C1974 FILL_L10_19 FILL_L10_9 1.39676e-17
C1975 FILL_L10_19 FILL_L134_0 5.8247000000000009e-19
C1976 FILL_L10_19 FILL_L50_11 3.8908000000000001e-18
C1977 FILL_L10_19 FILL_L50_4 3.5714700000000003e-17
C1978 FILL_L10_19 FILL_L8_11 1.51036e-18
C1979 FILL_L10_19 FILL_L8_4 2.8200399999999999e-19
C1980 FILL_L10_19 0 6.98926e-17
C1981 FILL_L10_2 FILL_L10_3 2.1510100000000004e-17
C1982 FILL_L10_2 FILL_L10_8 2.7935199999999999e-17
C1983 FILL_L10_2 FILL_L10_9 2.7935199999999999e-17
C1984 FILL_L10_2 FILL_L50_11 6.4570200000000004e-19
C1985 FILL_L10_2 FILL_L50_4 1.9444500000000002e-17
C1986 FILL_L10_2 FILL_L8_4 1.8117100000000001e-16
C1987 FILL_L10_2 0 2.1916500000000001e-16
C1988 FILL_L10_20 FILL_L10_21 2.7935199999999999e-17
C1989 FILL_L10_20 FILL_L10_30 2.7935199999999999e-17
C1990 FILL_L10_20 FILL_L134_0 3.8578500000000006e-18
C1991 FILL_L10_20 FILL_L50_4 8.5118100000000009e-18
C1992 FILL_L10_20 FILL_L50_5 8.5118100000000009e-18
C1993 FILL_L10_20 FILL_L8_12 1.51036e-18
C1994 FILL_L10_20 0 7.3700199999999996e-17
C1995 FILL_L10_21 FILL_L10_22 2.7935199999999999e-17
C1996 FILL_L10_21 FILL_L10_3 5.1652400000000006e-18
C1997 FILL_L10_21 FILL_L10_31 2.7935199999999999e-17
C1998 FILL_L10_21 FILL_L134_0 2.2024599999999999e-18
C1999 FILL_L10_21 FILL_L50_12 3.8908000000000001e-18
C2000 FILL_L10_21 FILL_L50_5 3.5714700000000003e-17
C2001 FILL_L10_21 FILL_L8_13 1.51036e-18
C2002 FILL_L10_21 FILL_L8_5 3.0652600000000003e-19
C2003 FILL_L10_21 0 6.98926e-17
C2004 FILL_L10_22 FILL_L10_23 2.7935199999999999e-17
C2005 FILL_L10_22 FILL_L10_31 2.7935199999999999e-17
C2006 FILL_L10_22 FILL_L134_0 4.8477600000000008e-18
C2007 FILL_L10_22 FILL_L50_12 1.9454000000000001e-18
C2008 FILL_L10_22 FILL_L50_5 2.17566e-17
C2009 FILL_L10_22 FILL_L50_6 1.9454000000000001e-18
C2010 FILL_L10_22 FILL_L8_14 1.51036e-18
C2011 FILL_L10_22 0 7.3700199999999996e-17
C2012 FILL_L10_23 FILL_L10_24 2.7935199999999999e-17
C2013 FILL_L10_23 FILL_L10_32 2.7935199999999999e-17
C2014 FILL_L10_23 FILL_L10_4 5.1652400000000006e-18
C2015 FILL_L10_23 FILL_L134_0 5.6163800000000009e-18
C2016 FILL_L10_23 FILL_L50_13 3.8908000000000001e-18
C2017 FILL_L10_23 FILL_L50_6 3.2014499999999999e-17
C2018 FILL_L10_23 FILL_L8_15 1.51036e-18
C2019 FILL_L10_23 FILL_L8_6 3.0652600000000003e-19
C2020 FILL_L10_23 0 6.98926e-17
C2021 FILL_L10_24 FILL_L10_25 2.7935199999999999e-17
C2022 FILL_L10_24 FILL_L10_32 2.7935199999999999e-17
C2023 FILL_L10_24 FILL_L134_0 4.2883100000000003e-18
C2024 FILL_L10_24 FILL_L50_13 3.8908000000000001e-18
C2025 FILL_L10_24 FILL_L50_6 3.3955599999999998e-17
C2026 FILL_L10_24 FILL_L8_16 1.51036e-18
C2027 FILL_L10_24 0 7.3700199999999996e-17
C2028 FILL_L10_25 FILL_L10_26 2.7935199999999999e-17
C2029 FILL_L10_25 FILL_L10_33 2.7935199999999999e-17
C2030 FILL_L10_25 FILL_L10_5 5.1652400000000006e-18
C2031 FILL_L10_25 FILL_L134_1 2.3449e-19
C2032 FILL_L10_25 FILL_L50_6 5.8352700000000008e-18
C2033 FILL_L10_25 FILL_L50_7 1.1202500000000002e-17
C2034 FILL_L10_25 FILL_L8_17 1.51036e-18
C2035 FILL_L10_25 FILL_L8_7 3.0652600000000003e-19
C2036 FILL_L10_25 0 6.98926e-17
C2037 FILL_L10_26 FILL_L10_33 5.0283400000000002e-18
C2038 FILL_L10_26 FILL_L134_1 8.7617999999999995e-19
C2039 FILL_L10_26 FILL_L50_14 7.0034400000000003e-19
C2040 FILL_L10_26 FILL_L50_7 1.0010800000000001e-17
C2041 FILL_L10_26 0 5.6841599999999998e-17
C2042 FILL_L10_27 FILL_L10_28 2.7935199999999999e-17
C2043 FILL_L10_27 FILL_L30_1 5.0164900000000005e-19
C2044 FILL_L10_27 FILL_L50_0 2.5370000000000001e-18
C2045 FILL_L10_27 FILL_L8_0 4.0150200000000007e-19
C2046 FILL_L10_27 FILL_L8_18 1.0479400000000001e-17
C2047 FILL_L10_27 FILL_L8_21 1.4740400000000001e-16
C2048 FILL_L10_27 FILL_L8_22 1.57148e-18
C2049 FILL_L10_27 0 2.9654700000000003e-17
C2050 FILL_L10_28 FILL_L10_34 2.7935199999999999e-17
C2051 FILL_L10_28 FILL_L30_1 1.6443300000000002e-18
C2052 FILL_L10_28 FILL_L50_0 4.6652900000000008e-19
C2053 FILL_L10_28 FILL_L8_21 1.4740400000000001e-16
C2054 FILL_L10_28 0 3.5970200000000003e-17
C2055 FILL_L10_29 FILL_L10_30 9.7773300000000019e-17
C2056 FILL_L10_29 FILL_L10_36 9.7773300000000019e-17
C2057 FILL_L10_29 FILL_L10_7 5.1652400000000006e-18
C2058 FILL_L10_29 FILL_L50_10 4.34584e-17
C2059 FILL_L10_29 FILL_L50_11 1.4346100000000003e-16
C2060 FILL_L10_29 FILL_L50_8 5.3319900000000002e-17
C2061 FILL_L10_29 FILL_L8_23 2.4408600000000001e-17
C2062 FILL_L10_29 FILL_L8_24 8.2350600000000007e-16
C2063 FILL_L10_29 N 3.6374899999999999e-17
C2064 FILL_L10_29 P 3.2587700000000003e-18
C2065 FILL_L10_29 0 2.1986000000000004e-16
C2066 FILL_L10_3 FILL_L10_4 2.1510100000000004e-17
C2067 FILL_L10_3 FILL_L50_12 6.4570200000000004e-19
C2068 FILL_L10_3 FILL_L50_5 1.88963e-17
C2069 FILL_L10_3 FILL_L8_5 1.8117100000000001e-16
C2070 FILL_L10_3 0 2.1916500000000001e-16
C2071 FILL_L10_30 FILL_L10_31 9.7773300000000019e-17
C2072 FILL_L10_30 FILL_L10_37 9.7773300000000019e-17
C2073 FILL_L10_30 FILL_L10_9 5.1652400000000006e-18
C2074 FILL_L10_30 FILL_L134_0 1.7648900000000002e-17
C2075 FILL_L10_30 FILL_L50_11 2.3230500000000003e-16
C2076 FILL_L10_30 FILL_L50_12 6.4834700000000002e-17
C2077 FILL_L10_30 FILL_L50_4 5.1482900000000008e-18
C2078 FILL_L10_30 FILL_L8_25 8.2350600000000007e-16
C2079 FILL_L10_30 0 2.2000000000000002e-16
C2080 FILL_L10_31 FILL_L10_32 9.7773300000000019e-17
C2081 FILL_L10_31 FILL_L10_38 9.7773300000000019e-17
C2082 FILL_L10_31 FILL_L134_0 1.1399800000000002e-17
C2083 FILL_L10_31 FILL_L50_12 2.6454900000000001e-16
C2084 FILL_L10_31 FILL_L50_13 1.2061500000000002e-17
C2085 FILL_L10_31 FILL_L50_5 7.7224400000000003e-18
C2086 FILL_L10_31 FILL_L8_26 8.2350600000000007e-16
C2087 FILL_L10_31 0 2.2014100000000001e-16
C2088 FILL_L10_32 FILL_L10_33 9.7773300000000019e-17
C2089 FILL_L10_32 FILL_L10_39 9.7773300000000019e-17
C2090 FILL_L10_32 FILL_L134_0 1.3434200000000002e-17
C2091 FILL_L10_32 FILL_L50_13 2.7106099999999998e-16
C2092 FILL_L10_32 FILL_L50_6 7.7224400000000003e-18
C2093 FILL_L10_32 FILL_L8_27 8.2350600000000007e-16
C2094 FILL_L10_32 0 2.2014100000000001e-16
C2095 FILL_L10_33 FILL_L10_40 7.4866400000000004e-17
C2096 FILL_L10_33 FILL_L134_1 1.85229e-18
C2097 FILL_L10_33 FILL_L50_13 3.6178700000000003e-17
C2098 FILL_L10_33 FILL_L50_14 1.6162100000000002e-16
C2099 FILL_L10_33 FILL_L50_7 7.7224400000000003e-18
C2100 FILL_L10_33 FILL_L8_28 6.3057000000000011e-16
C2101 FILL_L10_33 0 2.7008700000000001e-16
C2102 FILL_L10_34 FILL_L10_35 2.7935199999999999e-17
C2103 FILL_L10_34 FILL_L30_1 5.4465300000000002e-17
C2104 FILL_L10_34 FILL_L8_29 1.4740400000000001e-16
C2105 FILL_L10_34 0 3.9622000000000001e-17
C2106 FILL_L10_35 FILL_L10_41 2.7935199999999999e-17
C2107 FILL_L10_35 FILL_L30_1 3.0330600000000001e-17
C2108 FILL_L10_35 FILL_L8_29 1.4740400000000001e-16
C2109 FILL_L10_35 0 4.1425900000000001e-17
C2110 FILL_L10_36 FILL_L10_37 9.7773300000000019e-17
C2111 FILL_L10_36 FILL_L10_43 9.7773300000000019e-17
C2112 FILL_L10_36 FILL_L30_5 2.6211800000000001e-18
C2113 FILL_L10_36 FILL_L30_6 1.7636500000000003e-16
C2114 FILL_L10_36 FILL_L30_7 1.23317e-16
C2115 FILL_L10_36 FILL_L50_10 1.04719e-17
C2116 FILL_L10_36 FILL_L50_11 5.2359600000000008e-18
C2117 FILL_L10_36 FILL_L50_15 4.9659000000000004e-17
C2118 FILL_L10_36 FILL_L50_18 2.0914400000000003e-17
C2119 FILL_L10_36 FILL_L50_19 1.1078300000000001e-16
C2120 FILL_L10_36 FILL_L8_31 2.45489e-17
C2121 FILL_L10_36 FILL_L8_32 8.2350600000000007e-16
C2122 FILL_L10_36 N 5.0775300000000004e-17
C2123 FILL_L10_36 P 3.6381800000000002e-18
C2124 FILL_L10_36 0 1.9621900000000002e-16
C2125 FILL_L10_37 FILL_L10_38 9.7773300000000019e-17
C2126 FILL_L10_37 FILL_L10_44 9.7773300000000019e-17
C2127 FILL_L10_37 FILL_L134_0 1.2615900000000001e-17
C2128 FILL_L10_37 FILL_L30_7 1.3974200000000001e-17
C2129 FILL_L10_37 FILL_L30_8 2.04081e-16
C2130 FILL_L10_37 FILL_L30_9 3.3825600000000003e-17
C2131 FILL_L10_37 FILL_L50_11 2.0756300000000001e-17
C2132 FILL_L10_37 FILL_L50_19 2.0239700000000002e-16
C2133 FILL_L10_37 FILL_L50_20 4.5806800000000008e-17
C2134 FILL_L10_37 FILL_L8_33 8.2350600000000007e-16
C2135 FILL_L10_37 N 2.3091400000000004e-18
C2136 FILL_L10_37 0 1.9621900000000002e-16
C2137 FILL_L10_38 FILL_L10_39 9.7773300000000019e-17
C2138 FILL_L10_38 FILL_L10_45 9.7773300000000019e-17
C2139 FILL_L10_38 FILL_L134_0 1.8777200000000002e-17
C2140 FILL_L10_38 FILL_L30_10 1.9620000000000001e-16
C2141 FILL_L10_38 FILL_L30_11 3.4949400000000003e-18
C2142 FILL_L10_38 FILL_L30_9 6.3965400000000009e-17
C2143 FILL_L10_38 FILL_L50_12 3.1415700000000005e-17
C2144 FILL_L10_38 FILL_L50_20 2.4440400000000001e-16
C2145 FILL_L10_38 FILL_L50_21 9.7270000000000007e-18
C2146 FILL_L10_38 FILL_L8_34 8.2350600000000007e-16
C2147 FILL_L10_38 0 1.9621900000000002e-16
C2148 FILL_L10_39 FILL_L10_40 9.7773300000000019e-17
C2149 FILL_L10_39 FILL_L10_46 9.7773300000000019e-17
C2150 FILL_L10_39 FILL_L134_0 1.9996100000000001e-17
C2151 FILL_L10_39 FILL_L30_11 1.7636500000000003e-16
C2152 FILL_L10_39 FILL_L30_12 1.23317e-16
C2153 FILL_L10_39 FILL_L50_13 3.6651700000000004e-17
C2154 FILL_L10_39 FILL_L50_21 2.5187600000000004e-16
C2155 FILL_L10_39 FILL_L8_35 8.2350600000000007e-16
C2156 FILL_L10_39 0 1.9621900000000002e-16
C2157 FILL_L10_4 FILL_L10_5 2.1510100000000004e-17
C2158 FILL_L10_4 FILL_L134_0 1.0238099999999999e-17
C2159 FILL_L10_4 FILL_L50_6 9.6824300000000009e-18
C2160 FILL_L10_4 FILL_L8_6 1.8117100000000001e-16
C2161 FILL_L10_4 0 2.1916500000000001e-16
C2162 FILL_L10_40 FILL_L10_47 7.4866400000000004e-17
C2163 FILL_L10_40 FILL_L134_0 1.4613100000000002e-19
C2164 FILL_L10_40 FILL_L134_1 3.3921400000000003e-18
C2165 FILL_L10_40 FILL_L30_12 1.3974200000000001e-17
C2166 FILL_L10_40 FILL_L30_13 1.9168700000000004e-16
C2167 FILL_L10_40 FILL_L50_14 1.7592800000000001e-17
C2168 FILL_L10_40 FILL_L50_21 2.62154e-17
C2169 FILL_L10_40 FILL_L50_22 1.4174000000000001e-16
C2170 FILL_L10_40 FILL_L8_36 6.3057000000000011e-16
C2171 FILL_L10_40 0 2.4597200000000002e-16
C2172 FILL_L10_41 FILL_L10_42 2.7935199999999999e-17
C2173 FILL_L10_41 FILL_L30_1 1.9833799999999999e-18
C2174 FILL_L10_41 FILL_L8_37 1.4740400000000001e-16
C2175 FILL_L10_41 0 3.5398000000000008e-17
C2176 FILL_L10_42 FILL_L8_37 6.2563299999999997e-17
C2177 FILL_L10_42 0 3.93041e-17
C2178 FILL_L10_43 FILL_L10_44 7.6263200000000009e-17
C2179 FILL_L10_43 FILL_L30_15 1.4743400000000002e-19
C2180 FILL_L10_43 FILL_L30_6 3.2724800000000002e-18
C2181 FILL_L10_43 FILL_L30_7 1.6362400000000001e-18
C2182 FILL_L10_43 FILL_L50_18 3.1173500000000001e-17
C2183 FILL_L10_43 FILL_L50_19 1.7067200000000001e-17
C2184 FILL_L10_43 FILL_L50_24 5.4113500000000001e-18
C2185 FILL_L10_43 FILL_L8_39 1.9148200000000001e-17
C2186 FILL_L10_43 FILL_L8_40 6.4233500000000011e-16
C2187 FILL_L10_43 N 5.2383900000000001e-17
C2188 FILL_L10_43 P 2.7546200000000002e-18
C2189 FILL_L10_43 0 2.4737300000000002e-16
C2190 FILL_L10_44 FILL_L10_45 7.6263200000000009e-17
C2191 FILL_L10_44 FILL_L30_8 3.2724800000000002e-18
C2192 FILL_L10_44 FILL_L50_19 6.5248999999999995e-17
C2193 FILL_L10_44 FILL_L50_24 4.8327900000000003e-17
C2194 FILL_L10_44 FILL_L50_25 1.10846e-17
C2195 FILL_L10_44 FILL_L8_41 6.4233500000000011e-16
C2196 FILL_L10_44 N 5.3043199999999998e-18
C2197 FILL_L10_44 0 2.4737300000000002e-16
C2198 FILL_L10_45 FILL_L10_46 7.6263200000000009e-17
C2199 FILL_L10_45 FILL_L30_10 3.2724800000000002e-18
C2200 FILL_L10_45 FILL_L50_20 9.334380000000001e-17
C2201 FILL_L10_45 FILL_L50_25 1.06294e-16
C2202 FILL_L10_45 FILL_L50_26 2.0621200000000002e-18
C2203 FILL_L10_45 FILL_L8_42 6.4233500000000011e-16
C2204 FILL_L10_45 0 2.4737300000000002e-16
C2205 FILL_L10_46 FILL_L10_47 7.6263200000000009e-17
C2206 FILL_L10_46 FILL_L134_0 2.8730799999999998e-17
C2207 FILL_L10_46 FILL_L30_11 3.2724800000000002e-18
C2208 FILL_L10_46 FILL_L30_12 1.6362400000000001e-18
C2209 FILL_L10_46 FILL_L50_21 1.0890100000000001e-16
C2210 FILL_L10_46 FILL_L50_26 1.1758499999999999e-16
C2211 FILL_L10_46 FILL_L8_43 6.4233500000000011e-16
C2212 FILL_L10_46 0 2.4737300000000002e-16
C2213 FILL_L10_47 FILL_L134_1 6.7339200000000011e-18
C2214 FILL_L10_47 FILL_L30_13 3.2724800000000002e-18
C2215 FILL_L10_47 FILL_L50_22 5.4276500000000005e-17
C2216 FILL_L10_47 FILL_L50_26 6.1853900000000005e-18
C2217 FILL_L10_47 FILL_L50_27 4.3880600000000007e-17
C2218 FILL_L10_47 FILL_L8_44 4.9184500000000011e-16
C2219 FILL_L10_47 0 2.6408200000000003e-16
C2220 FILL_L10_5 FILL_L134_0 1.47308e-18
C2221 FILL_L10_5 FILL_L50_6 5.4825000000000007e-18
C2222 FILL_L10_5 FILL_L50_7 2.7412500000000003e-18
C2223 FILL_L10_5 FILL_L8_7 1.8117100000000001e-16
C2224 FILL_L10_5 0 2.3516900000000002e-16
C2225 FILL_L10_6 FILL_L8_18 1.4740400000000001e-16
C2226 FILL_L10_6 FILL_L8_19 8.6002200000000009e-18
C2227 FILL_L10_6 0 2.8135600000000003e-17
C2228 FILL_L10_7 FILL_L10_8 2.7935199999999999e-17
C2229 FILL_L10_7 FILL_L50_3 1.4804999999999999e-18
C2230 FILL_L10_7 FILL_L8_9 6.7224999999999998e-17
C2231 FILL_L10_7 0 7.0927800000000015e-17
C2232 FILL_L10_8 FILL_L10_9 2.7935199999999999e-17
C2233 FILL_L10_8 FILL_L50_11 1.4553799999999999e-18
C2234 FILL_L10_8 FILL_L50_4 9.590400000000001e-18
C2235 FILL_L10_8 FILL_L8_10 6.7224999999999998e-17
C2236 FILL_L10_8 0 6.5701500000000001e-17
C2237 FILL_L10_9 FILL_L50_4 9.590400000000001e-18
C2238 FILL_L10_9 FILL_L8_11 6.7224999999999998e-17
C2239 FILL_L10_9 0 6.1893900000000006e-17
C2240 FILL_L134_0 FILL_L134_1 4.5988900000000005e-16
C2241 FILL_L134_0 FILL_L30_10 7.2660800000000009e-19
C2242 FILL_L134_0 FILL_L30_11 3.43965e-18
C2243 FILL_L134_0 FILL_L30_12 1.7580900000000002e-18
C2244 FILL_L134_0 FILL_L50_11 1.79193e-17
C2245 FILL_L134_0 FILL_L50_12 8.8624000000000005e-17
C2246 FILL_L134_0 FILL_L50_13 1.2235200000000002e-16
C2247 FILL_L134_0 FILL_L50_19 1.7919300000000001e-18
C2248 FILL_L134_0 FILL_L50_20 8.8623999999999999e-18
C2249 FILL_L134_0 FILL_L50_21 9.0330700000000003e-17
C2250 FILL_L134_0 FILL_L50_26 1.0151400000000001e-17
C2251 FILL_L134_0 FILL_L50_4 7.1677100000000005e-18
C2252 FILL_L134_0 FILL_L50_5 3.54496e-17
C2253 FILL_L134_0 FILL_L50_6 9.7886700000000014e-17
C2254 FILL_L134_0 FILL_L8_14 3.8948400000000004e-19
C2255 FILL_L134_0 FILL_L8_26 2.5073100000000003e-18
C2256 FILL_L134_0 FILL_L8_27 7.6887800000000008e-18
C2257 FILL_L134_0 FILL_L8_34 1.1323300000000001e-18
C2258 FILL_L134_0 FILL_L8_35 3.2363900000000002e-18
C2259 FILL_L134_0 FILL_L8_6 1.0398400000000002e-18
C2260 FILL_L134_0 0 3.6909300000000005e-16
C2261 FILL_L134_1 FILL_L50_13 6.9006999999999998e-18
C2262 FILL_L134_1 FILL_L50_14 1.90138e-17
C2263 FILL_L134_1 FILL_L50_21 6.9007e-19
C2264 FILL_L134_1 FILL_L50_22 1.6022800000000001e-17
C2265 FILL_L134_1 FILL_L50_6 2.76028e-18
C2266 FILL_L134_1 FILL_L50_7 1.64561e-17
C2267 FILL_L134_1 FILL_L8_28 9.7649400000000001e-19
C2268 FILL_L134_1 FILL_L8_36 3.9650200000000005e-19
C2269 FILL_L134_1 0 3.7646800000000005e-16
C2270 FILL_L30_0 0 1.0889800000000001e-16
C2271 FILL_L30_1 FILL_L30_2 1.92731e-17
C2272 FILL_L30_1 FILL_L8_18 2.9223800000000001e-19
C2273 FILL_L30_1 FILL_L8_21 2.5296100000000001e-18
C2274 FILL_L30_1 FILL_L8_29 5.0695200000000004e-17
C2275 FILL_L30_1 0 3.5855300000000001e-17
C2276 FILL_L30_10 FILL_L30_11 1.92731e-17
C2277 FILL_L30_10 FILL_L30_9 1.92731e-17
C2278 FILL_L30_10 FILL_L50_12 5.0409200000000003e-19
C2279 FILL_L30_10 FILL_L50_20 1.3606299999999999e-16
C2280 FILL_L30_10 0 2.4191500000000003e-17
C2281 FILL_L30_11 FILL_L30_12 1.92731e-17
C2282 FILL_L30_11 FILL_L50_13 5.0409200000000003e-19
C2283 FILL_L30_11 FILL_L50_21 1.3606299999999999e-16
C2284 FILL_L30_11 0 2.4692900000000002e-17
C2285 FILL_L30_12 FILL_L30_13 1.92731e-17
C2286 FILL_L30_12 FILL_L50_13 4.2847800000000007e-19
C2287 FILL_L30_12 FILL_L50_21 1.3606299999999999e-16
C2288 FILL_L30_12 FILL_L8_35 3.01665e-18
C2289 FILL_L30_12 FILL_L8_36 2.30082e-18
C2290 FILL_L30_12 0 3.9613500000000003e-17
C2291 FILL_L30_13 FILL_L50_14 5.0409200000000003e-19
C2292 FILL_L30_13 FILL_L50_22 1.2322700000000001e-16
C2293 FILL_L30_13 0 4.7560300000000004e-17
C2294 FILL_L30_14 FILL_L30_15 1.92731e-17
C2295 FILL_L30_14 FILL_L30_4 1.92731e-17
C2296 FILL_L30_14 FILL_L50_18 6.4578500000000007e-19
C2297 FILL_L30_14 N 2.4807800000000001e-19
C2298 FILL_L30_14 P 3.1888300000000006e-19
C2299 FILL_L30_14 0 9.7490700000000017e-17
C2300 FILL_L30_15 FILL_L8_37 1.8177400000000001e-18
C2301 FILL_L30_15 FILL_L8_38 1.8571100000000001e-17
C2302 FILL_L30_15 FILL_L8_39 2.4142200000000001e-17
C2303 FILL_L30_15 N 1.1391300000000001e-19
C2304 FILL_L30_15 P 1.4642600000000002e-19
C2305 FILL_L30_15 0 5.9928300000000005e-17
C2306 FILL_L30_2 FILL_L30_3 1.92731e-17
C2307 FILL_L30_2 FILL_L8_29 5.0436800000000003e-17
C2308 FILL_L30_2 FILL_L8_30 1.1171900000000001e-17
C2309 FILL_L30_2 FILL_L8_37 1.8260000000000001e-18
C2310 FILL_L30_2 0 3.3079500000000003e-17
C2311 FILL_L30_3 FILL_L30_4 1.92731e-17
C2312 FILL_L30_3 FILL_L8_30 7.9324900000000005e-17
C2313 FILL_L30_3 FILL_L8_38 3.5144400000000001e-18
C2314 FILL_L30_3 0 1.8732900000000003e-17
C2315 FILL_L30_4 FILL_L30_5 1.92731e-17
C2316 FILL_L30_4 FILL_L8_30 1.8189900000000002e-17
C2317 FILL_L30_4 FILL_L8_31 2.6166200000000002e-17
C2318 FILL_L30_4 0 4.1814599999999999e-17
C2319 FILL_L30_5 FILL_L30_6 1.92731e-17
C2320 FILL_L30_5 FILL_L8_31 7.3572100000000009e-17
C2321 FILL_L30_5 FILL_L8_39 6.7211400000000009e-18
C2322 FILL_L30_5 N 2.8873199999999999e-18
C2323 FILL_L30_5 P 5.3937200000000003e-18
C2324 FILL_L30_5 0 2.6990400000000004e-17
C2325 FILL_L30_6 FILL_L30_7 1.92731e-17
C2326 FILL_L30_6 FILL_L50_10 5.0409200000000003e-19
C2327 FILL_L30_6 FILL_L50_15 6.7224999999999998e-17
C2328 FILL_L30_6 FILL_L50_18 3.0598200000000003e-18
C2329 FILL_L30_6 FILL_L8_31 3.9629700000000004e-18
C2330 FILL_L30_6 N 2.34989e-18
C2331 FILL_L30_6 P 1.3518400000000001e-18
C2332 FILL_L30_6 0 2.4692900000000002e-17
C2333 FILL_L30_7 FILL_L30_8 1.92731e-17
C2334 FILL_L30_7 FILL_L50_11 2.5204600000000002e-19
C2335 FILL_L30_7 FILL_L50_19 1.3606299999999999e-16
C2336 FILL_L30_7 FILL_L8_32 3.01665e-18
C2337 FILL_L30_7 FILL_L8_33 2.30082e-18
C2338 FILL_L30_7 0 3.9613500000000003e-17
C2339 FILL_L30_8 FILL_L30_9 1.92731e-17
C2340 FILL_L30_8 FILL_L50_11 5.0409200000000003e-19
C2341 FILL_L30_8 FILL_L50_19 1.3606299999999999e-16
C2342 FILL_L30_8 0 2.3785100000000001e-17
C2343 FILL_L30_9 FILL_L50_12 5.0409200000000003e-19
C2344 FILL_L30_9 FILL_L50_20 1.3606299999999999e-16
C2345 FILL_L30_9 FILL_L8_33 5.0346600000000001e-18
C2346 FILL_L30_9 FILL_L8_34 5.7504800000000001e-18
C2347 FILL_L30_9 0 5.4358800000000004e-17
C2348 FILL_L50_0 FILL_L8_0 7.8594799999999994e-18
C2349 FILL_L50_0 FILL_L8_18 2.4002600000000002e-17
C2350 FILL_L50_0 FILL_L8_21 2.59082e-18
C2351 FILL_L50_0 0 5.4421300000000005e-17
C2352 FILL_L50_1 FILL_L50_3 2.4713600000000001e-17
C2353 FILL_L50_1 FILL_L50_4 2.4713600000000001e-17
C2354 FILL_L50_1 0 2.7427800000000004e-17
C2355 FILL_L50_10 FILL_L50_11 2.4713600000000001e-17
C2356 FILL_L50_10 FILL_L50_15 2.4713600000000001e-17
C2357 FILL_L50_10 FILL_L50_8 2.4713600000000001e-17
C2358 FILL_L50_10 FILL_L8_24 8.9735099999999998e-19
C2359 FILL_L50_10 FILL_L8_32 8.0131300000000013e-19
C2360 FILL_L50_10 N 5.0331300000000003e-17
C2361 FILL_L50_10 0 1.5313700000000002e-17
C2362 FILL_L50_11 FILL_L50_12 9.8854299999999996e-17
C2363 FILL_L50_11 FILL_L50_19 9.8854299999999996e-17
C2364 FILL_L50_11 FILL_L50_4 9.8854299999999996e-17
C2365 FILL_L50_11 FILL_L50_8 2.4713600000000001e-17
C2366 FILL_L50_11 FILL_L8_24 1.3706400000000001e-17
C2367 FILL_L50_11 FILL_L8_25 1.5009600000000001e-17
C2368 FILL_L50_11 FILL_L8_32 4.0065700000000001e-19
C2369 FILL_L50_11 FILL_L8_33 1.4583900000000001e-18
C2370 FILL_L50_11 N 2.4862500000000002e-17
C2371 FILL_L50_11 0 1.3652500000000001e-16
C2372 FILL_L50_12 FILL_L50_13 9.8854299999999996e-17
C2373 FILL_L50_12 FILL_L50_20 9.8854299999999996e-17
C2374 FILL_L50_12 FILL_L50_5 9.8854299999999996e-17
C2375 FILL_L50_12 FILL_L8_25 8.6211000000000011e-18
C2376 FILL_L50_12 FILL_L8_26 1.1793400000000001e-17
C2377 FILL_L50_12 FILL_L8_34 2.4039400000000001e-18
C2378 FILL_L50_12 0 1.37862e-16
C2379 FILL_L50_13 FILL_L50_14 9.8854299999999996e-17
C2380 FILL_L50_13 FILL_L50_21 9.8854299999999996e-17
C2381 FILL_L50_13 FILL_L50_6 9.8854299999999996e-17
C2382 FILL_L50_13 FILL_L8_27 7.7773399999999999e-18
C2383 FILL_L50_13 FILL_L8_28 4.1563700000000005e-18
C2384 FILL_L50_13 FILL_L8_35 2.8046000000000005e-18
C2385 FILL_L50_13 0 1.29785e-16
C2386 FILL_L50_14 FILL_L50_22 4.1518800000000001e-17
C2387 FILL_L50_14 FILL_L50_7 4.1518800000000001e-17
C2388 FILL_L50_14 FILL_L8_28 1.4896000000000001e-18
C2389 FILL_L50_14 FILL_L8_36 1.20197e-18
C2390 FILL_L50_14 0 1.6364599999999999e-16
C2391 FILL_L50_15 FILL_L50_18 2.4713600000000001e-17
C2392 FILL_L50_15 FILL_L50_19 2.4713600000000001e-17
C2393 FILL_L50_15 N 5.0331300000000003e-17
C2394 FILL_L50_15 0 1.2760800000000001e-17
C2395 FILL_L50_16 FILL_L50_17 2.4713600000000001e-17
C2396 FILL_L50_16 FILL_L50_23 5.7335500000000007e-17
C2397 FILL_L50_16 FILL_L50_9 5.7335500000000007e-17
C2398 FILL_L50_16 0 2.1720600000000001e-16
C2399 FILL_L50_17 0 4.6894900000000002e-17
C2400 FILL_L50_18 FILL_L50_19 2.4713600000000001e-17
C2401 FILL_L50_18 FILL_L8_32 2.7810000000000005e-18
C2402 FILL_L50_18 FILL_L8_40 2.9359200000000002e-18
C2403 FILL_L50_18 N 5.0331300000000003e-17
C2404 FILL_L50_18 0 4.2637600000000002e-17
C2405 FILL_L50_19 FILL_L50_20 9.8854299999999996e-17
C2406 FILL_L50_19 FILL_L50_24 2.4713600000000001e-17
C2407 FILL_L50_19 FILL_L8_32 1.1334400000000002e-17
C2408 FILL_L50_19 FILL_L8_33 1.7904300000000001e-17
C2409 FILL_L50_19 FILL_L8_40 2.1383400000000001e-18
C2410 FILL_L50_19 FILL_L8_41 8.5533600000000005e-18
C2411 FILL_L50_19 N 2.4862500000000002e-17
C2412 FILL_L50_19 0 2.2345400000000003e-16
C2413 FILL_L50_2 FILL_L50_9 5.7335500000000007e-17
C2414 FILL_L50_2 0 2.3313300000000001e-16
C2415 FILL_L50_20 FILL_L50_21 9.8854299999999996e-17
C2416 FILL_L50_20 FILL_L50_25 9.8854299999999996e-17
C2417 FILL_L50_20 FILL_L8_33 4.1715000000000005e-18
C2418 FILL_L50_20 FILL_L8_34 1.7233899999999999e-17
C2419 FILL_L50_20 FILL_L8_42 1.283e-17
C2420 FILL_L50_20 0 1.6024300000000002e-16
C2421 FILL_L50_21 FILL_L50_22 9.8854299999999996e-17
C2422 FILL_L50_21 FILL_L50_26 9.8854299999999996e-17
C2423 FILL_L50_21 FILL_L8_35 1.72119e-17
C2424 FILL_L50_21 FILL_L8_36 2.0111500000000003e-18
C2425 FILL_L50_21 FILL_L8_43 1.4968400000000001e-17
C2426 FILL_L50_21 0 1.52887e-16
C2427 FILL_L50_22 FILL_L50_27 2.4713600000000001e-17
C2428 FILL_L50_22 FILL_L8_36 7.0992900000000007e-18
C2429 FILL_L50_22 FILL_L8_44 7.0992900000000007e-18
C2430 FILL_L50_22 0 1.85986e-16
C2431 FILL_L50_23 0 1.0741500000000002e-16
C2432 FILL_L50_24 FILL_L50_25 1.8040900000000001e-17
C2433 FILL_L50_24 N 5.1766899999999998e-18
C2434 FILL_L50_24 0 3.5413300000000002e-17
C2435 FILL_L50_25 FILL_L50_26 1.8040900000000001e-17
C2436 FILL_L50_25 FILL_L8_41 1.4739300000000001e-18
C2437 FILL_L50_25 FILL_L8_42 1.5560400000000002e-18
C2438 FILL_L50_25 0 1.36988e-16
C2439 FILL_L50_26 FILL_L50_27 1.8040900000000001e-17
C2440 FILL_L50_26 FILL_L8_43 7.9271200000000004e-19
C2441 FILL_L50_26 FILL_L8_44 7.1060500000000006e-19
C2442 FILL_L50_26 0 1.3094999999999999e-16
C2443 FILL_L50_27 0 5.0313500000000003e-17
C2444 FILL_L50_3 FILL_L50_4 2.4713600000000001e-17
C2445 FILL_L50_3 FILL_L50_8 2.4713600000000001e-17
C2446 FILL_L50_3 FILL_L8_9 6.7038200000000004e-19
C2447 FILL_L50_3 0 2.7919699999999998e-17
C2448 FILL_L50_4 FILL_L50_5 9.8854299999999996e-17
C2449 FILL_L50_4 FILL_L8_10 4.1326299999999999e-18
C2450 FILL_L50_4 FILL_L8_11 4.1326299999999999e-18
C2451 FILL_L50_4 FILL_L8_4 3.5491800000000001e-18
C2452 FILL_L50_4 0 2.1772700000000001e-16
C2453 FILL_L50_5 FILL_L50_6 9.8854299999999996e-17
C2454 FILL_L50_5 FILL_L8_13 4.1326299999999999e-18
C2455 FILL_L50_5 FILL_L8_5 3.6292800000000002e-18
C2456 FILL_L50_5 0 2.1555300000000002e-16
C2457 FILL_L50_6 FILL_L50_7 9.8854299999999996e-17
C2458 FILL_L50_6 FILL_L8_15 4.1326299999999999e-18
C2459 FILL_L50_6 FILL_L8_16 4.1326299999999999e-18
C2460 FILL_L50_6 FILL_L8_6 1.0012300000000001e-18
C2461 FILL_L50_6 0 2.1280000000000003e-16
C2462 FILL_L50_7 FILL_L8_17 2.3700100000000002e-18
C2463 FILL_L50_7 0 2.1290400000000001e-16
C2464 FILL_L50_8 N 2.1894100000000004e-17
C2465 FILL_L50_8 0 1.10283e-17
C2466 FILL_L50_9 0 1.9209000000000001e-16
C2467 FILL_L8_0 FILL_L8_1 1.5333300000000001e-17
C2468 FILL_L8_0 FILL_L8_18 6.96968e-17
C2469 FILL_L8_0 0 3.5106700000000005e-16
C2470 FILL_L8_1 FILL_L8_19 6.96968e-17
C2471 FILL_L8_1 FILL_L8_2 1.5333300000000001e-17
C2472 FILL_L8_1 0 3.4882600000000007e-16
C2473 FILL_L8_10 FILL_L8_11 1.9913400000000001e-17
C2474 FILL_L8_10 FILL_L8_4 1.9913400000000001e-17
C2475 FILL_L8_10 FILL_L8_9 1.9913400000000001e-17
C2476 FILL_L8_10 0 1.3266800000000001e-16
C2477 FILL_L8_11 FILL_L8_12 1.9913400000000001e-17
C2478 FILL_L8_11 FILL_L8_4 1.9913400000000001e-17
C2479 FILL_L8_11 0 1.3266800000000001e-16
C2480 FILL_L8_12 FILL_L8_13 1.9913400000000001e-17
C2481 FILL_L8_12 FILL_L8_5 1.9913400000000001e-17
C2482 FILL_L8_12 0 1.3266800000000001e-16
C2483 FILL_L8_13 FILL_L8_14 1.9913400000000001e-17
C2484 FILL_L8_13 FILL_L8_5 1.9913400000000001e-17
C2485 FILL_L8_13 0 1.3266800000000001e-16
C2486 FILL_L8_14 FILL_L8_15 1.9913400000000001e-17
C2487 FILL_L8_14 FILL_L8_6 1.9913400000000001e-17
C2488 FILL_L8_14 0 1.3266800000000001e-16
C2489 FILL_L8_15 FILL_L8_16 1.9913400000000001e-17
C2490 FILL_L8_15 FILL_L8_6 1.9913400000000001e-17
C2491 FILL_L8_15 0 1.3266800000000001e-16
C2492 FILL_L8_16 FILL_L8_17 1.9913400000000001e-17
C2493 FILL_L8_16 FILL_L8_7 1.9913400000000001e-17
C2494 FILL_L8_16 0 1.3266800000000001e-16
C2495 FILL_L8_17 FILL_L8_7 1.9913400000000001e-17
C2496 FILL_L8_17 0 1.49255e-16
C2497 FILL_L8_18 FILL_L8_19 6.96968e-17
C2498 FILL_L8_18 FILL_L8_21 6.96968e-17
C2499 FILL_L8_18 0 7.6572200000000008e-16
C2500 FILL_L8_19 FILL_L8_20 1.9913400000000001e-17
C2501 FILL_L8_19 FILL_L8_22 6.96968e-17
C2502 FILL_L8_19 FILL_L8_8 1.9913400000000001e-17
C2503 FILL_L8_19 P 2.5932400000000002e-19
C2504 FILL_L8_19 0 7.7194400000000005e-16
C2505 FILL_L8_2 FILL_L8_8 1.9913400000000001e-17
C2506 FILL_L8_2 P 2.1385100000000004e-19
C2507 FILL_L8_2 0 1.31027e-16
C2508 FILL_L8_20 FILL_L8_23 1.9913400000000001e-17
C2509 FILL_L8_20 FILL_L8_8 1.9913400000000001e-17
C2510 FILL_L8_20 P 3.1666400000000002e-19
C2511 FILL_L8_20 0 1.34885e-16
C2512 FILL_L8_21 FILL_L8_22 6.96968e-17
C2513 FILL_L8_21 FILL_L8_29 6.96968e-17
C2514 FILL_L8_21 0 7.59419e-16
C2515 FILL_L8_22 FILL_L8_23 6.96968e-17
C2516 FILL_L8_22 FILL_L8_30 6.96968e-17
C2517 FILL_L8_22 0 7.5091400000000008e-16
C2518 FILL_L8_23 FILL_L8_24 6.96968e-17
C2519 FILL_L8_23 FILL_L8_31 6.96968e-17
C2520 FILL_L8_23 N 1.8052299999999998e-18
C2521 FILL_L8_23 P 1.6427800000000001e-17
C2522 FILL_L8_23 0 7.9238300000000012e-16
C2523 FILL_L8_24 FILL_L8_25 6.96968e-17
C2524 FILL_L8_24 FILL_L8_32 6.96968e-17
C2525 FILL_L8_24 N 1.3216900000000001e-18
C2526 FILL_L8_24 P 2.2012000000000005e-19
C2527 FILL_L8_24 0 7.4991100000000001e-16
C2528 FILL_L8_25 FILL_L8_26 6.96968e-17
C2529 FILL_L8_25 FILL_L8_33 6.96968e-17
C2530 FILL_L8_25 0 7.4991100000000001e-16
C2531 FILL_L8_26 FILL_L8_27 6.96968e-17
C2532 FILL_L8_26 FILL_L8_34 6.96968e-17
C2533 FILL_L8_26 0 7.4991100000000001e-16
C2534 FILL_L8_27 FILL_L8_28 6.96968e-17
C2535 FILL_L8_27 FILL_L8_35 6.96968e-17
C2536 FILL_L8_27 0 7.4991100000000001e-16
C2537 FILL_L8_28 FILL_L8_36 5.3367800000000007e-17
C2538 FILL_L8_28 0 6.6998800000000013e-16
C2539 FILL_L8_29 FILL_L8_30 6.96968e-17
C2540 FILL_L8_29 FILL_L8_37 6.96968e-17
C2541 FILL_L8_29 0 7.7403200000000011e-16
C2542 FILL_L8_3 FILL_L8_4 1.5333300000000001e-17
C2543 FILL_L8_3 FILL_L8_9 1.9913400000000001e-17
C2544 FILL_L8_3 0 1.2510800000000002e-16
C2545 FILL_L8_30 FILL_L8_31 6.96968e-17
C2546 FILL_L8_30 FILL_L8_38 6.96968e-17
C2547 FILL_L8_30 0 7.5091400000000008e-16
C2548 FILL_L8_31 FILL_L8_32 6.96968e-17
C2549 FILL_L8_31 FILL_L8_39 6.96968e-17
C2550 FILL_L8_31 N 2.0783900000000003e-18
C2551 FILL_L8_31 P 1.7085799999999999e-17
C2552 FILL_L8_31 0 7.5091400000000008e-16
C2553 FILL_L8_32 FILL_L8_33 6.96968e-17
C2554 FILL_L8_32 FILL_L8_40 6.96968e-17
C2555 FILL_L8_32 N 1.93149e-18
C2556 FILL_L8_32 P 3.6000900000000005e-19
C2557 FILL_L8_32 0 7.5091400000000008e-16
C2558 FILL_L8_33 FILL_L8_34 6.96968e-17
C2559 FILL_L8_33 FILL_L8_41 6.96968e-17
C2560 FILL_L8_33 0 7.5091400000000008e-16
C2561 FILL_L8_34 FILL_L8_35 6.96968e-17
C2562 FILL_L8_34 FILL_L8_42 6.96968e-17
C2563 FILL_L8_34 0 7.5091400000000008e-16
C2564 FILL_L8_35 FILL_L8_36 6.96968e-17
C2565 FILL_L8_35 FILL_L8_43 6.96968e-17
C2566 FILL_L8_35 0 7.5091400000000008e-16
C2567 FILL_L8_36 FILL_L8_44 5.3367800000000007e-17
C2568 FILL_L8_36 0 6.7075600000000001e-16
C2569 FILL_L8_37 FILL_L8_38 5.4363500000000008e-17
C2570 FILL_L8_37 0 6.8780700000000007e-16
C2571 FILL_L8_38 FILL_L8_39 5.4363500000000008e-17
C2572 FILL_L8_38 0 6.7918300000000008e-16
C2573 FILL_L8_39 FILL_L8_40 5.4363500000000008e-17
C2574 FILL_L8_39 N 1.57364e-18
C2575 FILL_L8_39 P 1.2717700000000001e-17
C2576 FILL_L8_39 0 6.7918300000000008e-16
C2577 FILL_L8_4 FILL_L8_5 1.5333300000000001e-17
C2578 FILL_L8_4 0 3.6883999999999999e-16
C2579 FILL_L8_40 FILL_L8_41 5.4363500000000008e-17
C2580 FILL_L8_40 N 1.3023700000000001e-18
C2581 FILL_L8_40 0 6.7918300000000008e-16
C2582 FILL_L8_41 FILL_L8_42 5.4363500000000008e-17
C2583 FILL_L8_41 0 6.7918300000000008e-16
C2584 FILL_L8_42 FILL_L8_43 5.4363500000000008e-17
C2585 FILL_L8_42 0 6.7918300000000008e-16
C2586 FILL_L8_43 FILL_L8_44 5.4363500000000008e-17
C2587 FILL_L8_43 0 6.7918300000000008e-16
C2588 FILL_L8_44 0 5.9476100000000004e-16
C2589 FILL_L8_5 FILL_L8_6 1.5333300000000001e-17
C2590 FILL_L8_5 0 3.6883999999999999e-16
C2591 FILL_L8_6 FILL_L8_7 1.5333300000000001e-17
C2592 FILL_L8_6 0 3.6883999999999999e-16
C2593 FILL_L8_7 0 3.81613e-16
C2594 FILL_L8_8 0 1.34885e-16
C2595 FILL_L8_9 0 1.3285600000000001e-16
C2596 N P 3.4877500000000003e-15
C2597 N 0 1.7323800000000002e-16
C2598 P 0 6.1439100000000008e-17
VP P 0 DC 0 AC 0
VN N 0 DC 0 AC 1
.control
set numdgt=17
ac lin 1 1Meg 1Meg
let cp = -imag(i(VP))/(2*pi*1e6)
let cn = -imag(i(VN))/(2*pi*1e6)
print cp cn
quit
.endc
.end
