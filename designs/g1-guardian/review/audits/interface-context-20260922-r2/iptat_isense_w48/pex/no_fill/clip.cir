* cell sense_fill_clip
.SUBCKT sense_fill_clip
* net 2 CTX_L8_9
* net 3 CTX_L8_7
* net 4 CTX_L8_4
* net 5 CTX_L8_2
* net 6 CTX_L10_8,CTX_L8_25
* net 7 CTX_L8_5
* net 8 CTX_L10_1,CTX_L10_20,CTX_L30_2,CTX_L8_41
* net 9 CTX_L8_6
* net 10 CTX_L10_13,CTX_L10_7,CTX_L30_1,CTX_L8_11,CTX_L8_33,CTX_L8_36
* net 11 CTX_L10_21,CTX_L10_24,CTX_L30_17,CTX_L8_60
* net 12 CTX_L8_0
* net 13 CTX_L8_1
* net 14 CTX_L10_5,CTX_L8_12
* net 15 CTX_L8_3
* net 16 CTX_L8_8
* net 17 CTX_L8_10
* net 18 CTX_L8_13
* net 19 CTX_L8_15
* net 20 CTX_L10_3,CTX_L30_4
* net 21 CTX_L8_19
* net 22 CTX_L10_23,CTX_L30_22,CTX_L30_3,CTX_L50_2,CTX_L8_59
* net 23 CTX_L8_17
* net 24 CTX_L10_2,CTX_L8_18
* net 25 CTX_L30_7
* net 26 CTX_L10_29,CTX_L10_4,CTX_L30_5
* net 27 CTX_L10_15,CTX_L30_8,CTX_L8_38
* net 28 CTX_L10_0,CTX_L10_17,CTX_L10_6,CTX_L30_0,CTX_L30_6,CTX_L8_14,CTX_L8_39
* net 29 CTX_L10_32,CTX_L8_20
* net 30 CTX_L8_23
* net 31 CTX_L8_21
* net 32 CTX_L8_27
* net 33 CTX_L8_28
* net 34 CTX_L8_24
* net 35 CTX_L8_34
* net 36 CTX_L8_22
* net 37 CTX_L8_26
* net 38 CTX_L10_9,CTX_L30_9
* net 39 CTX_L8_30
* net 40 CTX_L8_32
* net 41 CTX_L30_18,CTX_L50_1
* net 42 CTX_L8_29
* net 43 CTX_L10_10,CTX_L30_10,CTX_L8_42
* net 44 CTX_L8_31
* net 45 CTX_L8_35
* net 46 CTX_L30_11,CTX_L50_14,CTX_L50_7
* net 47 CTX_L10_33,CTX_L30_13
* net 48 CTX_L126_2,CTX_L134_0
* net 49 CTX_L50_9
* net 50 CTX_L30_12,CTX_L50_0
* net 51 CTX_L8_44
* net 52 CTX_L10_14,CTX_L10_16,CTX_L30_15,CTX_L8_37,CTX_L8_43
* net 53 CTX_L8_46
* net 54 CTX_L10_11,CTX_L10_12,CTX_L30_14,CTX_L8_47
* net 55 CTX_L126_0
* net 56 CTX_L50_5
* net 57 CTX_L10_34
* net 58 CTX_L50_11
* net 59 CTX_L126_1
* net 60 CTX_L50_13
* net 61 CTX_L10_35
* net 62 CTX_L50_15
* net 63 P
* net 64 N
* net 65 CTX_L126_3
* net 66 CTX_L10_18,CTX_L10_19,CTX_L10_31,CTX_L30_16,CTX_L8_16,CTX_L8_40,CTX_L8_50
* net 67 CTX_L8_49
* net 68 CTX_L10_27,CTX_L8_45
* net 69 CTX_L10_25,CTX_L10_30,CTX_L30_19,CTX_L30_23,CTX_L8_51
* net 70 CTX_L30_20,CTX_L50_12,CTX_L50_6
* net 71 CTX_L8_48
* net 72 CTX_L8_55
* net 73 CTX_L10_22,CTX_L30_21,CTX_L8_58
* net 74 CTX_L8_57
* net 75 CTX_L8_53
* net 76 CTX_L8_54
* net 77 CTX_L8_56
* net 78 CTX_L8_52
* net 79 CTX_L10_28,CTX_L30_24,CTX_L8_64
* net 80 CTX_L8_66
* net 81 CTX_L8_61
* net 82 CTX_L10_26,CTX_L30_25,CTX_L8_71
* net 83 CTX_L8_72
* net 84 CTX_L8_63
* net 85 CTX_L8_69
* net 86 CTX_L8_65
* net 87 CTX_L8_62
* net 88 CTX_L8_67
* net 89 CTX_L8_68
* net 90 CTX_L8_70
* net 91 CTX_L30_26,CTX_L50_4,CTX_L50_8
* net 92 CTX_L8_73
* net 93 CTX_L8_74
* net 94 CTX_L30_27,CTX_L50_3
* net 95 CTX_L50_10
* net 96 CTX_L30_28
.ENDS sense_fill_clip
