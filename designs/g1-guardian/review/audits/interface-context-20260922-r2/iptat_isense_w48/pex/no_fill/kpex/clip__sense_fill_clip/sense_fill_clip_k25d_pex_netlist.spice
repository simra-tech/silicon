*********************************************************
*** NGSPICE file created by KLayout-PEX 0.3.12
*** -----------------------------------------------------
***     Extraction Engine: KPEX/2.5D
***     Technology: ihp_sg13g2
***     Date: 2026-09-22 16:36:17
*********************************************************

.SUBCKT sense_fill_clip
Cext_1 CTX_L10_0|CTX_L10_17|CTX_L10_6|CTX_L30_0|CTX_L30_6|CTX_L8_14|CTX_L8_39
+ CTX_L10_1|CTX_L10_20|CTX_L30_2|CTX_L8_41 127.333a
Cext_2 CTX_L10_0|CTX_L10_17|CTX_L10_6|CTX_L30_0|CTX_L30_6|CTX_L8_14|CTX_L8_39
+ CTX_L10_11|CTX_L10_12|CTX_L30_14|CTX_L8_47 542.68a
Cext_3 CTX_L10_0|CTX_L10_17|CTX_L10_6|CTX_L30_0|CTX_L30_6|CTX_L8_14|CTX_L8_39
+ CTX_L10_13|CTX_L10_7|CTX_L30_1|CTX_L8_11|CTX_L8_33|CTX_L8_36 2.18527f
Cext_4 CTX_L10_0|CTX_L10_17|CTX_L10_6|CTX_L30_0|CTX_L30_6|CTX_L8_14|CTX_L8_39
+ CTX_L10_14|CTX_L10_16|CTX_L30_15|CTX_L8_37|CTX_L8_43 298.632a
Cext_5 CTX_L10_0|CTX_L10_17|CTX_L10_6|CTX_L30_0|CTX_L30_6|CTX_L8_14|CTX_L8_39
+ CTX_L10_15|CTX_L30_8|CTX_L8_38 722.166a
Cext_6 CTX_L10_0|CTX_L10_17|CTX_L10_6|CTX_L30_0|CTX_L30_6|CTX_L8_14|CTX_L8_39
+ CTX_L10_18|CTX_L10_19|CTX_L10_31|CTX_L30_16|CTX_L8_16|CTX_L8_40|CTX_L8_50
+ 2.3627a
Cext_7 CTX_L10_0|CTX_L10_17|CTX_L10_6|CTX_L30_0|CTX_L30_6|CTX_L8_14|CTX_L8_39
+ CTX_L10_2|CTX_L8_18 317.718a
Cext_8 CTX_L10_0|CTX_L10_17|CTX_L10_6|CTX_L30_0|CTX_L30_6|CTX_L8_14|CTX_L8_39
+ CTX_L10_21|CTX_L10_24|CTX_L30_17|CTX_L8_60 47.8679a
Cext_9 CTX_L10_0|CTX_L10_17|CTX_L10_6|CTX_L30_0|CTX_L30_6|CTX_L8_14|CTX_L8_39
+ CTX_L10_23|CTX_L30_22|CTX_L30_3|CTX_L50_2|CTX_L8_59 158.261a
Cext_10 CTX_L10_0|CTX_L10_17|CTX_L10_6|CTX_L30_0|CTX_L30_6|CTX_L8_14|CTX_L8_39
+ CTX_L10_29|CTX_L10_4|CTX_L30_5 185.035a
Cext_11 CTX_L10_0|CTX_L10_17|CTX_L10_6|CTX_L30_0|CTX_L30_6|CTX_L8_14|CTX_L8_39
+ CTX_L10_3|CTX_L30_4 30.4219a
Cext_12 CTX_L10_0|CTX_L10_17|CTX_L10_6|CTX_L30_0|CTX_L30_6|CTX_L8_14|CTX_L8_39
+ CTX_L10_32|CTX_L8_20 65.158a
Cext_13 CTX_L10_0|CTX_L10_17|CTX_L10_6|CTX_L30_0|CTX_L30_6|CTX_L8_14|CTX_L8_39
+ CTX_L10_33|CTX_L30_13 5.73065a
Cext_14 CTX_L10_0|CTX_L10_17|CTX_L10_6|CTX_L30_0|CTX_L30_6|CTX_L8_14|CTX_L8_39
+ CTX_L10_5|CTX_L8_12 24.7839a
Cext_15 CTX_L10_0|CTX_L10_17|CTX_L10_6|CTX_L30_0|CTX_L30_6|CTX_L8_14|CTX_L8_39
+ CTX_L10_8|CTX_L8_25 21.5706a
Cext_16 CTX_L10_0|CTX_L10_17|CTX_L10_6|CTX_L30_0|CTX_L30_6|CTX_L8_14|CTX_L8_39
+ CTX_L10_9|CTX_L30_9 47.555a
Cext_17 CTX_L10_0|CTX_L10_17|CTX_L10_6|CTX_L30_0|CTX_L30_6|CTX_L8_14|CTX_L8_39
+ CTX_L126_0 67.4362a
Cext_18 CTX_L10_0|CTX_L10_17|CTX_L10_6|CTX_L30_0|CTX_L30_6|CTX_L8_14|CTX_L8_39
+ CTX_L126_2|CTX_L134_0 4.18164a
Cext_19 CTX_L10_0|CTX_L10_17|CTX_L10_6|CTX_L30_0|CTX_L30_6|CTX_L8_14|CTX_L8_39
+ CTX_L30_11|CTX_L50_14|CTX_L50_7 0.664783a
Cext_20 CTX_L10_0|CTX_L10_17|CTX_L10_6|CTX_L30_0|CTX_L30_6|CTX_L8_14|CTX_L8_39
+ CTX_L50_5 26.3947a
Cext_21 CTX_L10_0|CTX_L10_17|CTX_L10_6|CTX_L30_0|CTX_L30_6|CTX_L8_14|CTX_L8_39
+ CTX_L8_0 0.26806a
Cext_22 CTX_L10_0|CTX_L10_17|CTX_L10_6|CTX_L30_0|CTX_L30_6|CTX_L8_14|CTX_L8_39
+ CTX_L8_1 0.362247a
Cext_23 CTX_L10_0|CTX_L10_17|CTX_L10_6|CTX_L30_0|CTX_L30_6|CTX_L8_14|CTX_L8_39
+ CTX_L8_15 0.105046a
Cext_24 CTX_L10_0|CTX_L10_17|CTX_L10_6|CTX_L30_0|CTX_L30_6|CTX_L8_14|CTX_L8_39
+ CTX_L8_17 7.30843a
Cext_25 CTX_L10_0|CTX_L10_17|CTX_L10_6|CTX_L30_0|CTX_L30_6|CTX_L8_14|CTX_L8_39
+ CTX_L8_19 90.0176a
Cext_26 CTX_L10_0|CTX_L10_17|CTX_L10_6|CTX_L30_0|CTX_L30_6|CTX_L8_14|CTX_L8_39
+ CTX_L8_2 0.109409a
Cext_27 CTX_L10_0|CTX_L10_17|CTX_L10_6|CTX_L30_0|CTX_L30_6|CTX_L8_14|CTX_L8_39
+ CTX_L8_22 0.315167a
Cext_28 CTX_L10_0|CTX_L10_17|CTX_L10_6|CTX_L30_0|CTX_L30_6|CTX_L8_14|CTX_L8_39
+ CTX_L8_24 126.621a
Cext_29 CTX_L10_0|CTX_L10_17|CTX_L10_6|CTX_L30_0|CTX_L30_6|CTX_L8_14|CTX_L8_39
+ CTX_L8_3 0.369562a
Cext_30 CTX_L10_0|CTX_L10_17|CTX_L10_6|CTX_L30_0|CTX_L30_6|CTX_L8_14|CTX_L8_39
+ CTX_L8_32 0.451308a
Cext_31 CTX_L10_0|CTX_L10_17|CTX_L10_6|CTX_L30_0|CTX_L30_6|CTX_L8_14|CTX_L8_39
+ CTX_L8_35 41.746a
Cext_32 CTX_L10_0|CTX_L10_17|CTX_L10_6|CTX_L30_0|CTX_L30_6|CTX_L8_14|CTX_L8_39
+ CTX_L8_4 0.694065a
Cext_33 CTX_L10_0|CTX_L10_17|CTX_L10_6|CTX_L30_0|CTX_L30_6|CTX_L8_14|CTX_L8_39
+ CTX_L8_49 68.1025a
Cext_34 CTX_L10_0|CTX_L10_17|CTX_L10_6|CTX_L30_0|CTX_L30_6|CTX_L8_14|CTX_L8_39
+ CTX_L8_5 0.264658a
Cext_35 CTX_L10_0|CTX_L10_17|CTX_L10_6|CTX_L30_0|CTX_L30_6|CTX_L8_14|CTX_L8_39
+ CTX_L8_6 3.17918a
Cext_36 CTX_L10_0|CTX_L10_17|CTX_L10_6|CTX_L30_0|CTX_L30_6|CTX_L8_14|CTX_L8_39
+ CTX_L8_7 1.00371a
Cext_37 CTX_L10_0|CTX_L10_17|CTX_L10_6|CTX_L30_0|CTX_L30_6|CTX_L8_14|CTX_L8_39
+ CTX_L8_9 72.033a
Cext_38 CTX_L10_0|CTX_L10_17|CTX_L10_6|CTX_L30_0|CTX_L30_6|CTX_L8_14|CTX_L8_39
+ VSUBS 594.3a
Cext_39 CTX_L10_1|CTX_L10_20|CTX_L30_2|CTX_L8_41
+ CTX_L10_10|CTX_L30_10|CTX_L8_42 9.3686a
Cext_40 CTX_L10_1|CTX_L10_20|CTX_L30_2|CTX_L8_41
+ CTX_L10_11|CTX_L10_12|CTX_L30_14|CTX_L8_47 132.743a
Cext_41 CTX_L10_1|CTX_L10_20|CTX_L30_2|CTX_L8_41
+ CTX_L10_13|CTX_L10_7|CTX_L30_1|CTX_L8_11|CTX_L8_33|CTX_L8_36 838.82a
Cext_42 CTX_L10_1|CTX_L10_20|CTX_L30_2|CTX_L8_41
+ CTX_L10_14|CTX_L10_16|CTX_L30_15|CTX_L8_37|CTX_L8_43 30.9293a
Cext_43 CTX_L10_1|CTX_L10_20|CTX_L30_2|CTX_L8_41 CTX_L10_15|CTX_L30_8|CTX_L8_38
+ 350.387a
Cext_44 CTX_L10_1|CTX_L10_20|CTX_L30_2|CTX_L8_41
+ CTX_L10_18|CTX_L10_19|CTX_L10_31|CTX_L30_16|CTX_L8_16|CTX_L8_40|CTX_L8_50
+ 4.87816a
Cext_45 CTX_L10_1|CTX_L10_20|CTX_L30_2|CTX_L8_41 CTX_L10_2|CTX_L8_18 0.269785a
Cext_46 CTX_L10_1|CTX_L10_20|CTX_L30_2|CTX_L8_41
+ CTX_L10_21|CTX_L10_24|CTX_L30_17|CTX_L8_60 75.4609a
Cext_47 CTX_L10_1|CTX_L10_20|CTX_L30_2|CTX_L8_41
+ CTX_L10_23|CTX_L30_22|CTX_L30_3|CTX_L50_2|CTX_L8_59 306.879a
Cext_48 CTX_L10_1|CTX_L10_20|CTX_L30_2|CTX_L8_41 CTX_L10_29|CTX_L10_4|CTX_L30_5
+ 58.2553a
Cext_49 CTX_L10_1|CTX_L10_20|CTX_L30_2|CTX_L8_41 CTX_L10_3|CTX_L30_4 353.253a
Cext_50 CTX_L10_1|CTX_L10_20|CTX_L30_2|CTX_L8_41 CTX_L10_32|CTX_L8_20 528.916a
Cext_51 CTX_L10_1|CTX_L10_20|CTX_L30_2|CTX_L8_41 CTX_L10_5|CTX_L8_12 155.972a
Cext_52 CTX_L10_1|CTX_L10_20|CTX_L30_2|CTX_L8_41 CTX_L10_8|CTX_L8_25 75.0619a
Cext_53 CTX_L10_1|CTX_L10_20|CTX_L30_2|CTX_L8_41 CTX_L10_9|CTX_L30_9 28.3726a
Cext_54 CTX_L10_1|CTX_L10_20|CTX_L30_2|CTX_L8_41 CTX_L126_0 13.592a
Cext_55 CTX_L10_1|CTX_L10_20|CTX_L30_2|CTX_L8_41 CTX_L126_2|CTX_L134_0 10.2411a
Cext_56 CTX_L10_1|CTX_L10_20|CTX_L30_2|CTX_L8_41 CTX_L50_5 3.61503a
Cext_57 CTX_L10_1|CTX_L10_20|CTX_L30_2|CTX_L8_41 CTX_L8_1 0.151401a
Cext_58 CTX_L10_1|CTX_L10_20|CTX_L30_2|CTX_L8_41 CTX_L8_15 0.340798a
Cext_59 CTX_L10_1|CTX_L10_20|CTX_L30_2|CTX_L8_41 CTX_L8_17 9.25323a
Cext_60 CTX_L10_1|CTX_L10_20|CTX_L30_2|CTX_L8_41 CTX_L8_19 2.97734a
Cext_61 CTX_L10_1|CTX_L10_20|CTX_L30_2|CTX_L8_41 CTX_L8_2 0.169908a
Cext_62 CTX_L10_1|CTX_L10_20|CTX_L30_2|CTX_L8_41 CTX_L8_24 71.2797a
Cext_63 CTX_L10_1|CTX_L10_20|CTX_L30_2|CTX_L8_41 CTX_L8_26 1.8324a
Cext_64 CTX_L10_1|CTX_L10_20|CTX_L30_2|CTX_L8_41 CTX_L8_30 22.8514a
Cext_65 CTX_L10_1|CTX_L10_20|CTX_L30_2|CTX_L8_41 CTX_L8_32 41.1238a
Cext_66 CTX_L10_1|CTX_L10_20|CTX_L30_2|CTX_L8_41 CTX_L8_35 55.8825a
Cext_67 CTX_L10_1|CTX_L10_20|CTX_L30_2|CTX_L8_41 CTX_L8_46 215.732a
Cext_68 CTX_L10_1|CTX_L10_20|CTX_L30_2|CTX_L8_41 CTX_L8_49 2.17249a
Cext_69 CTX_L10_1|CTX_L10_20|CTX_L30_2|CTX_L8_41 CTX_L8_5 3.26926a
Cext_70 CTX_L10_1|CTX_L10_20|CTX_L30_2|CTX_L8_41 CTX_L8_9 71.1321a
Cext_71 CTX_L10_1|CTX_L10_20|CTX_L30_2|CTX_L8_41 VSUBS 188.379a
Cext_72 CTX_L10_10|CTX_L30_10|CTX_L8_42
+ CTX_L10_11|CTX_L10_12|CTX_L30_14|CTX_L8_47 0.325411a
Cext_73 CTX_L10_10|CTX_L30_10|CTX_L8_42
+ CTX_L10_13|CTX_L10_7|CTX_L30_1|CTX_L8_11|CTX_L8_33|CTX_L8_36 497.163a
Cext_74 CTX_L10_10|CTX_L30_10|CTX_L8_42
+ CTX_L10_14|CTX_L10_16|CTX_L30_15|CTX_L8_37|CTX_L8_43 103.24a
Cext_75 CTX_L10_10|CTX_L30_10|CTX_L8_42
+ CTX_L10_18|CTX_L10_19|CTX_L10_31|CTX_L30_16|CTX_L8_16|CTX_L8_40|CTX_L8_50
+ 119.497a
Cext_76 CTX_L10_10|CTX_L30_10|CTX_L8_42
+ CTX_L10_21|CTX_L10_24|CTX_L30_17|CTX_L8_60 27.3476a
Cext_77 CTX_L10_10|CTX_L30_10|CTX_L8_42
+ CTX_L10_23|CTX_L30_22|CTX_L30_3|CTX_L50_2|CTX_L8_59 13.5162a
Cext_78 CTX_L10_10|CTX_L30_10|CTX_L8_42
+ CTX_L10_25|CTX_L10_30|CTX_L30_19|CTX_L30_23|CTX_L8_51 0.878419a
Cext_79 CTX_L10_10|CTX_L30_10|CTX_L8_42 CTX_L10_27|CTX_L8_45 11.4643a
Cext_80 CTX_L10_10|CTX_L30_10|CTX_L8_42 CTX_L10_29|CTX_L10_4|CTX_L30_5 17.7339a
Cext_81 CTX_L10_10|CTX_L30_10|CTX_L8_42 CTX_L10_32|CTX_L8_20 153.815a
Cext_82 CTX_L10_10|CTX_L30_10|CTX_L8_42 CTX_L10_8|CTX_L8_25 1.55684a
Cext_83 CTX_L10_10|CTX_L30_10|CTX_L8_42 CTX_L10_9|CTX_L30_9 971.428a
Cext_84 CTX_L10_10|CTX_L30_10|CTX_L8_42 CTX_L126_0 6.31757a
Cext_85 CTX_L10_10|CTX_L30_10|CTX_L8_42 CTX_L126_2|CTX_L134_0 13.6761a
Cext_86 CTX_L10_10|CTX_L30_10|CTX_L8_42 CTX_L8_26 11.6486a
Cext_87 CTX_L10_10|CTX_L30_10|CTX_L8_42 CTX_L8_27 5.15961a
Cext_88 CTX_L10_10|CTX_L30_10|CTX_L8_42 CTX_L8_28 4.97509a
Cext_89 CTX_L10_10|CTX_L30_10|CTX_L8_42 CTX_L8_29 1.92941a
Cext_90 CTX_L10_10|CTX_L30_10|CTX_L8_42 CTX_L8_30 0.51974a
Cext_91 CTX_L10_10|CTX_L30_10|CTX_L8_42 CTX_L8_31 14.2809a
Cext_92 CTX_L10_10|CTX_L30_10|CTX_L8_42 CTX_L8_32 0.275412a
Cext_93 CTX_L10_10|CTX_L30_10|CTX_L8_42 CTX_L8_34 8.07636a
Cext_94 CTX_L10_10|CTX_L30_10|CTX_L8_42 CTX_L8_35 305.354a
Cext_95 CTX_L10_10|CTX_L30_10|CTX_L8_42 CTX_L8_44 1.29809a
Cext_96 CTX_L10_10|CTX_L30_10|CTX_L8_42 CTX_L8_46 52.4627a
Cext_97 CTX_L10_10|CTX_L30_10|CTX_L8_42 CTX_L8_49 117.483a
Cext_98 CTX_L10_10|CTX_L30_10|CTX_L8_42 VSUBS 179.831a
Cext_99 CTX_L10_11|CTX_L10_12|CTX_L30_14|CTX_L8_47
+ CTX_L10_13|CTX_L10_7|CTX_L30_1|CTX_L8_11|CTX_L8_33|CTX_L8_36 5.1769a
Cext_100 CTX_L10_11|CTX_L10_12|CTX_L30_14|CTX_L8_47
+ CTX_L10_14|CTX_L10_16|CTX_L30_15|CTX_L8_37|CTX_L8_43 134.646a
Cext_101 CTX_L10_11|CTX_L10_12|CTX_L30_14|CTX_L8_47
+ CTX_L10_15|CTX_L30_8|CTX_L8_38 179.412a
Cext_102 CTX_L10_11|CTX_L10_12|CTX_L30_14|CTX_L8_47
+ CTX_L10_18|CTX_L10_19|CTX_L10_31|CTX_L30_16|CTX_L8_16|CTX_L8_40|CTX_L8_50
+ 0.337513a
Cext_103 CTX_L10_11|CTX_L10_12|CTX_L30_14|CTX_L8_47 CTX_L10_2|CTX_L8_18 9.2375a
Cext_104 CTX_L10_11|CTX_L10_12|CTX_L30_14|CTX_L8_47
+ CTX_L10_21|CTX_L10_24|CTX_L30_17|CTX_L8_60 11.0964a
Cext_105 CTX_L10_11|CTX_L10_12|CTX_L30_14|CTX_L8_47
+ CTX_L10_23|CTX_L30_22|CTX_L30_3|CTX_L50_2|CTX_L8_59 31.277a
Cext_106 CTX_L10_11|CTX_L10_12|CTX_L30_14|CTX_L8_47
+ CTX_L10_25|CTX_L10_30|CTX_L30_19|CTX_L30_23|CTX_L8_51 4.49478a
Cext_107 CTX_L10_11|CTX_L10_12|CTX_L30_14|CTX_L8_47 CTX_L10_27|CTX_L8_45
+ 0.135625a
Cext_108 CTX_L10_11|CTX_L10_12|CTX_L30_14|CTX_L8_47 CTX_L10_32|CTX_L8_20
+ 3.23691a
Cext_109 CTX_L10_11|CTX_L10_12|CTX_L30_14|CTX_L8_47 CTX_L10_33|CTX_L30_13
+ 9.18013a
Cext_110 CTX_L10_11|CTX_L10_12|CTX_L30_14|CTX_L8_47 CTX_L10_34 7.44914a
Cext_111 CTX_L10_11|CTX_L10_12|CTX_L30_14|CTX_L8_47 CTX_L10_5|CTX_L8_12 1.17223a
Cext_112 CTX_L10_11|CTX_L10_12|CTX_L30_14|CTX_L8_47 CTX_L10_9|CTX_L30_9 1.20108f
Cext_113 CTX_L10_11|CTX_L10_12|CTX_L30_14|CTX_L8_47 CTX_L126_0 58.362a
Cext_114 CTX_L10_11|CTX_L10_12|CTX_L30_14|CTX_L8_47 CTX_L126_2|CTX_L134_0
+ 12.024a
Cext_115 CTX_L10_11|CTX_L10_12|CTX_L30_14|CTX_L8_47
+ CTX_L30_11|CTX_L50_14|CTX_L50_7 2.87025a
Cext_116 CTX_L10_11|CTX_L10_12|CTX_L30_14|CTX_L8_47 CTX_L50_5 73.7342a
Cext_117 CTX_L10_11|CTX_L10_12|CTX_L30_14|CTX_L8_47 CTX_L8_24 7.04084a
Cext_118 CTX_L10_11|CTX_L10_12|CTX_L30_14|CTX_L8_47 CTX_L8_3 0.197806a
Cext_119 CTX_L10_11|CTX_L10_12|CTX_L30_14|CTX_L8_47 CTX_L8_32 3.22392a
Cext_120 CTX_L10_11|CTX_L10_12|CTX_L30_14|CTX_L8_47 CTX_L8_35 166.885a
Cext_121 CTX_L10_11|CTX_L10_12|CTX_L30_14|CTX_L8_47 CTX_L8_46 233.507a
Cext_122 CTX_L10_11|CTX_L10_12|CTX_L30_14|CTX_L8_47 CTX_L8_49 125.628a
Cext_123 CTX_L10_11|CTX_L10_12|CTX_L30_14|CTX_L8_47 CTX_L8_61 0.289154a
Cext_124 CTX_L10_11|CTX_L10_12|CTX_L30_14|CTX_L8_47 CTX_L8_9 6.94179a
Cext_125 CTX_L10_11|CTX_L10_12|CTX_L30_14|CTX_L8_47 VSUBS 385.811a
Cext_126 CTX_L10_13|CTX_L10_7|CTX_L30_1|CTX_L8_11|CTX_L8_33|CTX_L8_36
+ CTX_L10_14|CTX_L10_16|CTX_L30_15|CTX_L8_37|CTX_L8_43 42.7281a
Cext_127 CTX_L10_13|CTX_L10_7|CTX_L30_1|CTX_L8_11|CTX_L8_33|CTX_L8_36
+ CTX_L10_15|CTX_L30_8|CTX_L8_38 388.342a
Cext_128 CTX_L10_13|CTX_L10_7|CTX_L30_1|CTX_L8_11|CTX_L8_33|CTX_L8_36
+ CTX_L10_18|CTX_L10_19|CTX_L10_31|CTX_L30_16|CTX_L8_16|CTX_L8_40|CTX_L8_50
+ 1.0134f
Cext_129 CTX_L10_13|CTX_L10_7|CTX_L30_1|CTX_L8_11|CTX_L8_33|CTX_L8_36
+ CTX_L10_2|CTX_L8_18 212.92a
Cext_130 CTX_L10_13|CTX_L10_7|CTX_L30_1|CTX_L8_11|CTX_L8_33|CTX_L8_36
+ CTX_L10_21|CTX_L10_24|CTX_L30_17|CTX_L8_60 334.772a
Cext_131 CTX_L10_13|CTX_L10_7|CTX_L30_1|CTX_L8_11|CTX_L8_33|CTX_L8_36
+ CTX_L10_23|CTX_L30_22|CTX_L30_3|CTX_L50_2|CTX_L8_59 134.674a
Cext_132 CTX_L10_13|CTX_L10_7|CTX_L30_1|CTX_L8_11|CTX_L8_33|CTX_L8_36
+ CTX_L10_25|CTX_L10_30|CTX_L30_19|CTX_L30_23|CTX_L8_51 8.88694a
Cext_133 CTX_L10_13|CTX_L10_7|CTX_L30_1|CTX_L8_11|CTX_L8_33|CTX_L8_36
+ CTX_L10_27|CTX_L8_45 6.17855a
Cext_134 CTX_L10_13|CTX_L10_7|CTX_L30_1|CTX_L8_11|CTX_L8_33|CTX_L8_36
+ CTX_L10_29|CTX_L10_4|CTX_L30_5 426.384a
Cext_135 CTX_L10_13|CTX_L10_7|CTX_L30_1|CTX_L8_11|CTX_L8_33|CTX_L8_36
+ CTX_L10_3|CTX_L30_4 137.093a
Cext_136 CTX_L10_13|CTX_L10_7|CTX_L30_1|CTX_L8_11|CTX_L8_33|CTX_L8_36
+ CTX_L10_32|CTX_L8_20 143.464a
Cext_137 CTX_L10_13|CTX_L10_7|CTX_L30_1|CTX_L8_11|CTX_L8_33|CTX_L8_36
+ CTX_L10_5|CTX_L8_12 356.778a
Cext_138 CTX_L10_13|CTX_L10_7|CTX_L30_1|CTX_L8_11|CTX_L8_33|CTX_L8_36
+ CTX_L10_8|CTX_L8_25 42.4354a
Cext_139 CTX_L10_13|CTX_L10_7|CTX_L30_1|CTX_L8_11|CTX_L8_33|CTX_L8_36
+ CTX_L10_9|CTX_L30_9 36.0593a
Cext_140 CTX_L10_13|CTX_L10_7|CTX_L30_1|CTX_L8_11|CTX_L8_33|CTX_L8_36
+ CTX_L126_0 27.3215a
Cext_141 CTX_L10_13|CTX_L10_7|CTX_L30_1|CTX_L8_11|CTX_L8_33|CTX_L8_36
+ CTX_L126_2|CTX_L134_0 19.3892a
Cext_142 CTX_L10_13|CTX_L10_7|CTX_L30_1|CTX_L8_11|CTX_L8_33|CTX_L8_36
+ CTX_L30_11|CTX_L50_14|CTX_L50_7 0.883067a
Cext_143 CTX_L10_13|CTX_L10_7|CTX_L30_1|CTX_L8_11|CTX_L8_33|CTX_L8_36 CTX_L50_5
+ 9.58936a
Cext_144 CTX_L10_13|CTX_L10_7|CTX_L30_1|CTX_L8_11|CTX_L8_33|CTX_L8_36 CTX_L8_0
+ 0.211474a
Cext_145 CTX_L10_13|CTX_L10_7|CTX_L30_1|CTX_L8_11|CTX_L8_33|CTX_L8_36 CTX_L8_13
+ 1.39548a
Cext_146 CTX_L10_13|CTX_L10_7|CTX_L30_1|CTX_L8_11|CTX_L8_33|CTX_L8_36 CTX_L8_15
+ 3.13436a
Cext_147 CTX_L10_13|CTX_L10_7|CTX_L30_1|CTX_L8_11|CTX_L8_33|CTX_L8_36 CTX_L8_17
+ 32.876a
Cext_148 CTX_L10_13|CTX_L10_7|CTX_L30_1|CTX_L8_11|CTX_L8_33|CTX_L8_36 CTX_L8_19
+ 134.652a
Cext_149 CTX_L10_13|CTX_L10_7|CTX_L30_1|CTX_L8_11|CTX_L8_33|CTX_L8_36 CTX_L8_22
+ 16.0147a
Cext_150 CTX_L10_13|CTX_L10_7|CTX_L30_1|CTX_L8_11|CTX_L8_33|CTX_L8_36 CTX_L8_24
+ 281.035a
Cext_151 CTX_L10_13|CTX_L10_7|CTX_L30_1|CTX_L8_11|CTX_L8_33|CTX_L8_36 CTX_L8_26
+ 37.2342a
Cext_152 CTX_L10_13|CTX_L10_7|CTX_L30_1|CTX_L8_11|CTX_L8_33|CTX_L8_36 CTX_L8_27
+ 9.52006a
Cext_153 CTX_L10_13|CTX_L10_7|CTX_L30_1|CTX_L8_11|CTX_L8_33|CTX_L8_36 CTX_L8_30
+ 3.64821a
Cext_154 CTX_L10_13|CTX_L10_7|CTX_L30_1|CTX_L8_11|CTX_L8_33|CTX_L8_36 CTX_L8_31
+ 8.88146a
Cext_155 CTX_L10_13|CTX_L10_7|CTX_L30_1|CTX_L8_11|CTX_L8_33|CTX_L8_36 CTX_L8_32
+ 99.6051a
Cext_156 CTX_L10_13|CTX_L10_7|CTX_L30_1|CTX_L8_11|CTX_L8_33|CTX_L8_36 CTX_L8_34
+ 7.33958a
Cext_157 CTX_L10_13|CTX_L10_7|CTX_L30_1|CTX_L8_11|CTX_L8_33|CTX_L8_36 CTX_L8_35
+ 209.281a
Cext_158 CTX_L10_13|CTX_L10_7|CTX_L30_1|CTX_L8_11|CTX_L8_33|CTX_L8_36 CTX_L8_49
+ 27.6711a
Cext_159 CTX_L10_13|CTX_L10_7|CTX_L30_1|CTX_L8_11|CTX_L8_33|CTX_L8_36 CTX_L8_8
+ 0.865344a
Cext_160 CTX_L10_13|CTX_L10_7|CTX_L30_1|CTX_L8_11|CTX_L8_33|CTX_L8_36 CTX_L8_9
+ 108.047a
Cext_161 CTX_L10_13|CTX_L10_7|CTX_L30_1|CTX_L8_11|CTX_L8_33|CTX_L8_36 VSUBS
+ 390.558a
Cext_162 CTX_L10_14|CTX_L10_16|CTX_L30_15|CTX_L8_37|CTX_L8_43
+ CTX_L10_15|CTX_L30_8|CTX_L8_38 179.363a
Cext_163 CTX_L10_14|CTX_L10_16|CTX_L30_15|CTX_L8_37|CTX_L8_43
+ CTX_L10_18|CTX_L10_19|CTX_L10_31|CTX_L30_16|CTX_L8_16|CTX_L8_40|CTX_L8_50
+ 0.552726a
Cext_164 CTX_L10_14|CTX_L10_16|CTX_L30_15|CTX_L8_37|CTX_L8_43
+ CTX_L10_2|CTX_L8_18 1.23747a
Cext_165 CTX_L10_14|CTX_L10_16|CTX_L30_15|CTX_L8_37|CTX_L8_43
+ CTX_L10_21|CTX_L10_24|CTX_L30_17|CTX_L8_60 209.869a
Cext_166 CTX_L10_14|CTX_L10_16|CTX_L30_15|CTX_L8_37|CTX_L8_43
+ CTX_L10_23|CTX_L30_22|CTX_L30_3|CTX_L50_2|CTX_L8_59 29.5173a
Cext_167 CTX_L10_14|CTX_L10_16|CTX_L30_15|CTX_L8_37|CTX_L8_43
+ CTX_L10_25|CTX_L10_30|CTX_L30_19|CTX_L30_23|CTX_L8_51 0.108099a
Cext_168 CTX_L10_14|CTX_L10_16|CTX_L30_15|CTX_L8_37|CTX_L8_43
+ CTX_L10_26|CTX_L30_25|CTX_L8_71 4.94792a
Cext_169 CTX_L10_14|CTX_L10_16|CTX_L30_15|CTX_L8_37|CTX_L8_43
+ CTX_L10_27|CTX_L8_45 0.197204a
Cext_170 CTX_L10_14|CTX_L10_16|CTX_L30_15|CTX_L8_37|CTX_L8_43
+ CTX_L10_29|CTX_L10_4|CTX_L30_5 0.269785a
Cext_171 CTX_L10_14|CTX_L10_16|CTX_L30_15|CTX_L8_37|CTX_L8_43
+ CTX_L10_32|CTX_L8_20 143.782a
Cext_172 CTX_L10_14|CTX_L10_16|CTX_L30_15|CTX_L8_37|CTX_L8_43
+ CTX_L10_9|CTX_L30_9 23.3407a
Cext_173 CTX_L10_14|CTX_L10_16|CTX_L30_15|CTX_L8_37|CTX_L8_43 CTX_L126_0
+ 11.9454a
Cext_174 CTX_L10_14|CTX_L10_16|CTX_L30_15|CTX_L8_37|CTX_L8_43
+ CTX_L126_2|CTX_L134_0 5.50507a
Cext_175 CTX_L10_14|CTX_L10_16|CTX_L30_15|CTX_L8_37|CTX_L8_43 CTX_L50_5 5.49701a
Cext_176 CTX_L10_14|CTX_L10_16|CTX_L30_15|CTX_L8_37|CTX_L8_43 CTX_L8_30
+ 0.863355a
Cext_177 CTX_L10_14|CTX_L10_16|CTX_L30_15|CTX_L8_37|CTX_L8_43 CTX_L8_32
+ 0.519765a
Cext_178 CTX_L10_14|CTX_L10_16|CTX_L30_15|CTX_L8_37|CTX_L8_43 CTX_L8_35 134.438a
Cext_179 CTX_L10_14|CTX_L10_16|CTX_L30_15|CTX_L8_37|CTX_L8_43 CTX_L8_44 0.27742a
Cext_180 CTX_L10_14|CTX_L10_16|CTX_L30_15|CTX_L8_37|CTX_L8_43 CTX_L8_46 13.9863a
Cext_181 CTX_L10_14|CTX_L10_16|CTX_L30_15|CTX_L8_37|CTX_L8_43 CTX_L8_49 348.755a
Cext_182 CTX_L10_14|CTX_L10_16|CTX_L30_15|CTX_L8_37|CTX_L8_43 CTX_L8_53 0.26439a
Cext_183 CTX_L10_14|CTX_L10_16|CTX_L30_15|CTX_L8_37|CTX_L8_43 CTX_L8_61 0.13048a
Cext_184 CTX_L10_14|CTX_L10_16|CTX_L30_15|CTX_L8_37|CTX_L8_43 VSUBS 198.621a
Cext_185 CTX_L10_15|CTX_L30_8|CTX_L8_38
+ CTX_L10_18|CTX_L10_19|CTX_L10_31|CTX_L30_16|CTX_L8_16|CTX_L8_40|CTX_L8_50
+ 23.9747a
Cext_186 CTX_L10_15|CTX_L30_8|CTX_L8_38 CTX_L10_2|CTX_L8_18 0.685473a
Cext_187 CTX_L10_15|CTX_L30_8|CTX_L8_38
+ CTX_L10_21|CTX_L10_24|CTX_L30_17|CTX_L8_60 41.0943a
Cext_188 CTX_L10_15|CTX_L30_8|CTX_L8_38
+ CTX_L10_23|CTX_L30_22|CTX_L30_3|CTX_L50_2|CTX_L8_59 36.3778a
Cext_189 CTX_L10_15|CTX_L30_8|CTX_L8_38 CTX_L10_29|CTX_L10_4|CTX_L30_5 141.386a
Cext_190 CTX_L10_15|CTX_L30_8|CTX_L8_38 CTX_L10_3|CTX_L30_4 72.8636a
Cext_191 CTX_L10_15|CTX_L30_8|CTX_L8_38 CTX_L10_32|CTX_L8_20 28.809a
Cext_192 CTX_L10_15|CTX_L30_8|CTX_L8_38 CTX_L10_5|CTX_L8_12 15.9499a
Cext_193 CTX_L10_15|CTX_L30_8|CTX_L8_38 CTX_L10_8|CTX_L8_25 26.8109a
Cext_194 CTX_L10_15|CTX_L30_8|CTX_L8_38 CTX_L10_9|CTX_L30_9 132.263a
Cext_195 CTX_L10_15|CTX_L30_8|CTX_L8_38 CTX_L126_0 14.6971a
Cext_196 CTX_L10_15|CTX_L30_8|CTX_L8_38 CTX_L126_2|CTX_L134_0 10.0935a
Cext_197 CTX_L10_15|CTX_L30_8|CTX_L8_38 CTX_L50_5 5.79094a
Cext_198 CTX_L10_15|CTX_L30_8|CTX_L8_38 CTX_L8_10 1.86864a
Cext_199 CTX_L10_15|CTX_L30_8|CTX_L8_38 CTX_L8_13 6.10515a
Cext_200 CTX_L10_15|CTX_L30_8|CTX_L8_38 CTX_L8_15 4.31773a
Cext_201 CTX_L10_15|CTX_L30_8|CTX_L8_38 CTX_L8_17 13.1545a
Cext_202 CTX_L10_15|CTX_L30_8|CTX_L8_38 CTX_L8_19 3.21814a
Cext_203 CTX_L10_15|CTX_L30_8|CTX_L8_38 CTX_L8_21 3.20146a
Cext_204 CTX_L10_15|CTX_L30_8|CTX_L8_38 CTX_L8_22 3.51769a
Cext_205 CTX_L10_15|CTX_L30_8|CTX_L8_38 CTX_L8_24 100.815a
Cext_206 CTX_L10_15|CTX_L30_8|CTX_L8_38 CTX_L8_26 0.459878a
Cext_207 CTX_L10_15|CTX_L30_8|CTX_L8_38 CTX_L8_27 3.77422a
Cext_208 CTX_L10_15|CTX_L30_8|CTX_L8_38 CTX_L8_28 1.24004a
Cext_209 CTX_L10_15|CTX_L30_8|CTX_L8_38 CTX_L8_30 0.468666a
Cext_210 CTX_L10_15|CTX_L30_8|CTX_L8_38 CTX_L8_32 40.0749a
Cext_211 CTX_L10_15|CTX_L30_8|CTX_L8_38 CTX_L8_34 0.584304a
Cext_212 CTX_L10_15|CTX_L30_8|CTX_L8_38 CTX_L8_35 132.088a
Cext_213 CTX_L10_15|CTX_L30_8|CTX_L8_38 CTX_L8_46 0.997448a
Cext_214 CTX_L10_15|CTX_L30_8|CTX_L8_38 CTX_L8_49 64.8111a
Cext_215 CTX_L10_15|CTX_L30_8|CTX_L8_38 CTX_L8_54 0.168437a
Cext_216 CTX_L10_15|CTX_L30_8|CTX_L8_38 VSUBS 189.163a
Cext_217
+ CTX_L10_18|CTX_L10_19|CTX_L10_31|CTX_L30_16|CTX_L8_16|CTX_L8_40|CTX_L8_50
+ CTX_L10_21|CTX_L10_24|CTX_L30_17|CTX_L8_60 1.08389f
Cext_218
+ CTX_L10_18|CTX_L10_19|CTX_L10_31|CTX_L30_16|CTX_L8_16|CTX_L8_40|CTX_L8_50
+ CTX_L10_22|CTX_L30_21|CTX_L8_58 28.5181a
Cext_219
+ CTX_L10_18|CTX_L10_19|CTX_L10_31|CTX_L30_16|CTX_L8_16|CTX_L8_40|CTX_L8_50
+ CTX_L10_23|CTX_L30_22|CTX_L30_3|CTX_L50_2|CTX_L8_59 75.7983a
Cext_220
+ CTX_L10_18|CTX_L10_19|CTX_L10_31|CTX_L30_16|CTX_L8_16|CTX_L8_40|CTX_L8_50
+ CTX_L10_25|CTX_L10_30|CTX_L30_19|CTX_L30_23|CTX_L8_51 1.51745f
Cext_221
+ CTX_L10_18|CTX_L10_19|CTX_L10_31|CTX_L30_16|CTX_L8_16|CTX_L8_40|CTX_L8_50
+ CTX_L10_26|CTX_L30_25|CTX_L8_71 27.9651a
Cext_222
+ CTX_L10_18|CTX_L10_19|CTX_L10_31|CTX_L30_16|CTX_L8_16|CTX_L8_40|CTX_L8_50
+ CTX_L10_27|CTX_L8_45 13.4436a
Cext_223
+ CTX_L10_18|CTX_L10_19|CTX_L10_31|CTX_L30_16|CTX_L8_16|CTX_L8_40|CTX_L8_50
+ CTX_L10_28|CTX_L30_24|CTX_L8_64 0.269785a
Cext_224
+ CTX_L10_18|CTX_L10_19|CTX_L10_31|CTX_L30_16|CTX_L8_16|CTX_L8_40|CTX_L8_50
+ CTX_L10_29|CTX_L10_4|CTX_L30_5 1.22186f
Cext_225
+ CTX_L10_18|CTX_L10_19|CTX_L10_31|CTX_L30_16|CTX_L8_16|CTX_L8_40|CTX_L8_50
+ CTX_L10_3|CTX_L30_4 4.81337a
Cext_226
+ CTX_L10_18|CTX_L10_19|CTX_L10_31|CTX_L30_16|CTX_L8_16|CTX_L8_40|CTX_L8_50
+ CTX_L10_32|CTX_L8_20 241.366a
Cext_227
+ CTX_L10_18|CTX_L10_19|CTX_L10_31|CTX_L30_16|CTX_L8_16|CTX_L8_40|CTX_L8_50
+ CTX_L10_8|CTX_L8_25 2.3304a
Cext_228
+ CTX_L10_18|CTX_L10_19|CTX_L10_31|CTX_L30_16|CTX_L8_16|CTX_L8_40|CTX_L8_50
+ CTX_L10_9|CTX_L30_9 16.9649a
Cext_229
+ CTX_L10_18|CTX_L10_19|CTX_L10_31|CTX_L30_16|CTX_L8_16|CTX_L8_40|CTX_L8_50
+ CTX_L126_0 12.54a
Cext_230
+ CTX_L10_18|CTX_L10_19|CTX_L10_31|CTX_L30_16|CTX_L8_16|CTX_L8_40|CTX_L8_50
+ CTX_L126_2|CTX_L134_0 17.2484a
Cext_231
+ CTX_L10_18|CTX_L10_19|CTX_L10_31|CTX_L30_16|CTX_L8_16|CTX_L8_40|CTX_L8_50
+ CTX_L30_26|CTX_L50_4|CTX_L50_8 0.502891a
Cext_232
+ CTX_L10_18|CTX_L10_19|CTX_L10_31|CTX_L30_16|CTX_L8_16|CTX_L8_40|CTX_L8_50
+ CTX_L30_27|CTX_L50_3 0.163272a
Cext_233
+ CTX_L10_18|CTX_L10_19|CTX_L10_31|CTX_L30_16|CTX_L8_16|CTX_L8_40|CTX_L8_50
+ CTX_L50_5 0.26913a
Cext_234
+ CTX_L10_18|CTX_L10_19|CTX_L10_31|CTX_L30_16|CTX_L8_16|CTX_L8_40|CTX_L8_50
+ CTX_L8_15 99.6051a
Cext_235
+ CTX_L10_18|CTX_L10_19|CTX_L10_31|CTX_L30_16|CTX_L8_16|CTX_L8_40|CTX_L8_50
+ CTX_L8_19 151.459a
Cext_236
+ CTX_L10_18|CTX_L10_19|CTX_L10_31|CTX_L30_16|CTX_L8_16|CTX_L8_40|CTX_L8_50
+ CTX_L8_22 9.23412a
Cext_237
+ CTX_L10_18|CTX_L10_19|CTX_L10_31|CTX_L30_16|CTX_L8_16|CTX_L8_40|CTX_L8_50
+ CTX_L8_24 216.895a
Cext_238
+ CTX_L10_18|CTX_L10_19|CTX_L10_31|CTX_L30_16|CTX_L8_16|CTX_L8_40|CTX_L8_50
+ CTX_L8_26 9.33955a
Cext_239
+ CTX_L10_18|CTX_L10_19|CTX_L10_31|CTX_L30_16|CTX_L8_16|CTX_L8_40|CTX_L8_50
+ CTX_L8_27 23.8227a
Cext_240
+ CTX_L10_18|CTX_L10_19|CTX_L10_31|CTX_L30_16|CTX_L8_16|CTX_L8_40|CTX_L8_50
+ CTX_L8_29 0.161692a
Cext_241
+ CTX_L10_18|CTX_L10_19|CTX_L10_31|CTX_L30_16|CTX_L8_16|CTX_L8_40|CTX_L8_50
+ CTX_L8_31 9.36031a
Cext_242
+ CTX_L10_18|CTX_L10_19|CTX_L10_31|CTX_L30_16|CTX_L8_16|CTX_L8_40|CTX_L8_50
+ CTX_L8_34 16.7709a
Cext_243
+ CTX_L10_18|CTX_L10_19|CTX_L10_31|CTX_L30_16|CTX_L8_16|CTX_L8_40|CTX_L8_50
+ CTX_L8_35 40.5801a
Cext_244
+ CTX_L10_18|CTX_L10_19|CTX_L10_31|CTX_L30_16|CTX_L8_16|CTX_L8_40|CTX_L8_50
+ CTX_L8_44 199.345a
Cext_245
+ CTX_L10_18|CTX_L10_19|CTX_L10_31|CTX_L30_16|CTX_L8_16|CTX_L8_40|CTX_L8_50
+ CTX_L8_48 0.118319a
Cext_246
+ CTX_L10_18|CTX_L10_19|CTX_L10_31|CTX_L30_16|CTX_L8_16|CTX_L8_40|CTX_L8_50
+ CTX_L8_49 61.9113a
Cext_247
+ CTX_L10_18|CTX_L10_19|CTX_L10_31|CTX_L30_16|CTX_L8_16|CTX_L8_40|CTX_L8_50
+ CTX_L8_53 225.777a
Cext_248
+ CTX_L10_18|CTX_L10_19|CTX_L10_31|CTX_L30_16|CTX_L8_16|CTX_L8_40|CTX_L8_50
+ CTX_L8_61 48.8049a
Cext_249
+ CTX_L10_18|CTX_L10_19|CTX_L10_31|CTX_L30_16|CTX_L8_16|CTX_L8_40|CTX_L8_50
+ CTX_L8_62 12.2714a
Cext_250
+ CTX_L10_18|CTX_L10_19|CTX_L10_31|CTX_L30_16|CTX_L8_16|CTX_L8_40|CTX_L8_50
+ CTX_L8_66 7.11758a
Cext_251
+ CTX_L10_18|CTX_L10_19|CTX_L10_31|CTX_L30_16|CTX_L8_16|CTX_L8_40|CTX_L8_50
+ CTX_L8_67 37.9102a
Cext_252
+ CTX_L10_18|CTX_L10_19|CTX_L10_31|CTX_L30_16|CTX_L8_16|CTX_L8_40|CTX_L8_50
+ CTX_L8_68 5.83987a
Cext_253
+ CTX_L10_18|CTX_L10_19|CTX_L10_31|CTX_L30_16|CTX_L8_16|CTX_L8_40|CTX_L8_50
+ CTX_L8_69 9.4298a
Cext_254
+ CTX_L10_18|CTX_L10_19|CTX_L10_31|CTX_L30_16|CTX_L8_16|CTX_L8_40|CTX_L8_50
+ CTX_L8_70 0.814447a
Cext_255
+ CTX_L10_18|CTX_L10_19|CTX_L10_31|CTX_L30_16|CTX_L8_16|CTX_L8_40|CTX_L8_50
+ CTX_L8_73 14.6202a
Cext_256
+ CTX_L10_18|CTX_L10_19|CTX_L10_31|CTX_L30_16|CTX_L8_16|CTX_L8_40|CTX_L8_50
+ CTX_L8_74 37.8927a
Cext_257
+ CTX_L10_18|CTX_L10_19|CTX_L10_31|CTX_L30_16|CTX_L8_16|CTX_L8_40|CTX_L8_50
+ CTX_L8_9 151.8a
Cext_258
+ CTX_L10_18|CTX_L10_19|CTX_L10_31|CTX_L30_16|CTX_L8_16|CTX_L8_40|CTX_L8_50
+ VSUBS 406.934a
Cext_259 CTX_L10_2|CTX_L8_18
+ CTX_L10_23|CTX_L30_22|CTX_L30_3|CTX_L50_2|CTX_L8_59 22.9361a
Cext_260 CTX_L10_2|CTX_L8_18 CTX_L10_29|CTX_L10_4|CTX_L30_5 0.271063a
Cext_261 CTX_L10_2|CTX_L8_18 CTX_L10_3|CTX_L30_4 0.235078a
Cext_262 CTX_L10_2|CTX_L8_18 CTX_L10_5|CTX_L8_12 19.8624a
Cext_263 CTX_L10_2|CTX_L8_18 CTX_L10_9|CTX_L30_9 2.87007a
Cext_264 CTX_L10_2|CTX_L8_18 CTX_L126_0 6.91073a
Cext_265 CTX_L10_2|CTX_L8_18 CTX_L126_2|CTX_L134_0 2.98407a
Cext_266 CTX_L10_2|CTX_L8_18 CTX_L50_5 2.84136a
Cext_267 CTX_L10_2|CTX_L8_18 CTX_L50_9 0.153025a
Cext_268 CTX_L10_2|CTX_L8_18 CTX_L8_17 233.507a
Cext_269 CTX_L10_2|CTX_L8_18 CTX_L8_24 66.6322a
Cext_270 CTX_L10_2|CTX_L8_18 CTX_L8_3 5.04636a
Cext_271 CTX_L10_2|CTX_L8_18 CTX_L8_9 123.32a
Cext_272 CTX_L10_2|CTX_L8_18 VSUBS 175.298a
Cext_273 CTX_L10_21|CTX_L10_24|CTX_L30_17|CTX_L8_60
+ CTX_L10_22|CTX_L30_21|CTX_L8_58 0.186574a
Cext_274 CTX_L10_21|CTX_L10_24|CTX_L30_17|CTX_L8_60
+ CTX_L10_23|CTX_L30_22|CTX_L30_3|CTX_L50_2|CTX_L8_59 54.5311a
Cext_275 CTX_L10_21|CTX_L10_24|CTX_L30_17|CTX_L8_60
+ CTX_L10_25|CTX_L10_30|CTX_L30_19|CTX_L30_23|CTX_L8_51 904.578a
Cext_276 CTX_L10_21|CTX_L10_24|CTX_L30_17|CTX_L8_60
+ CTX_L10_26|CTX_L30_25|CTX_L8_71 9.17891a
Cext_277 CTX_L10_21|CTX_L10_24|CTX_L30_17|CTX_L8_60 CTX_L10_27|CTX_L8_45
+ 37.4484a
Cext_278 CTX_L10_21|CTX_L10_24|CTX_L30_17|CTX_L8_60
+ CTX_L10_28|CTX_L30_24|CTX_L8_64 1.84037a
Cext_279 CTX_L10_21|CTX_L10_24|CTX_L30_17|CTX_L8_60
+ CTX_L10_29|CTX_L10_4|CTX_L30_5 1.44107f
Cext_280 CTX_L10_21|CTX_L10_24|CTX_L30_17|CTX_L8_60 CTX_L10_3|CTX_L30_4 44.1796a
Cext_281 CTX_L10_21|CTX_L10_24|CTX_L30_17|CTX_L8_60 CTX_L10_32|CTX_L8_20
+ 107.805a
Cext_282 CTX_L10_21|CTX_L10_24|CTX_L30_17|CTX_L8_60 CTX_L10_33|CTX_L30_13
+ 14.2237a
Cext_283 CTX_L10_21|CTX_L10_24|CTX_L30_17|CTX_L8_60 CTX_L10_8|CTX_L8_25 821.443a
Cext_284 CTX_L10_21|CTX_L10_24|CTX_L30_17|CTX_L8_60 CTX_L10_9|CTX_L30_9 18.775a
Cext_285 CTX_L10_21|CTX_L10_24|CTX_L30_17|CTX_L8_60 CTX_L126_0 32.8739a
Cext_286 CTX_L10_21|CTX_L10_24|CTX_L30_17|CTX_L8_60 CTX_L126_2|CTX_L134_0
+ 17.108a
Cext_287 CTX_L10_21|CTX_L10_24|CTX_L30_17|CTX_L8_60
+ CTX_L30_11|CTX_L50_14|CTX_L50_7 1.44365a
Cext_288 CTX_L10_21|CTX_L10_24|CTX_L30_17|CTX_L8_60
+ CTX_L30_20|CTX_L50_12|CTX_L50_6 2.10453a
Cext_289 CTX_L10_21|CTX_L10_24|CTX_L30_17|CTX_L8_60 CTX_L50_5 10.2452a
Cext_290 CTX_L10_21|CTX_L10_24|CTX_L30_17|CTX_L8_60 CTX_L8_0 0.584455a
Cext_291 CTX_L10_21|CTX_L10_24|CTX_L30_17|CTX_L8_60 CTX_L8_15 59.5663a
Cext_292 CTX_L10_21|CTX_L10_24|CTX_L30_17|CTX_L8_60 CTX_L8_19 23.5509a
Cext_293 CTX_L10_21|CTX_L10_24|CTX_L30_17|CTX_L8_60 CTX_L8_22 9.23412a
Cext_294 CTX_L10_21|CTX_L10_24|CTX_L30_17|CTX_L8_60 CTX_L8_24 36.7065a
Cext_295 CTX_L10_21|CTX_L10_24|CTX_L30_17|CTX_L8_60 CTX_L8_27 12.1936a
Cext_296 CTX_L10_21|CTX_L10_24|CTX_L30_17|CTX_L8_60 CTX_L8_28 20.4051a
Cext_297 CTX_L10_21|CTX_L10_24|CTX_L30_17|CTX_L8_60 CTX_L8_29 0.317638a
Cext_298 CTX_L10_21|CTX_L10_24|CTX_L30_17|CTX_L8_60 CTX_L8_31 1.12363a
Cext_299 CTX_L10_21|CTX_L10_24|CTX_L30_17|CTX_L8_60 CTX_L8_34 31.4058a
Cext_300 CTX_L10_21|CTX_L10_24|CTX_L30_17|CTX_L8_60 CTX_L8_35 42.7159a
Cext_301 CTX_L10_21|CTX_L10_24|CTX_L30_17|CTX_L8_60 CTX_L8_44 15.3507a
Cext_302 CTX_L10_21|CTX_L10_24|CTX_L30_17|CTX_L8_60 CTX_L8_46 8.38983a
Cext_303 CTX_L10_21|CTX_L10_24|CTX_L30_17|CTX_L8_60 CTX_L8_49 170.73a
Cext_304 CTX_L10_21|CTX_L10_24|CTX_L30_17|CTX_L8_60 CTX_L8_53 0.691927a
Cext_305 CTX_L10_21|CTX_L10_24|CTX_L30_17|CTX_L8_60 CTX_L8_54 237.473a
Cext_306 CTX_L10_21|CTX_L10_24|CTX_L30_17|CTX_L8_60 CTX_L8_57 0.89761a
Cext_307 CTX_L10_21|CTX_L10_24|CTX_L30_17|CTX_L8_60 CTX_L8_6 3.27025a
Cext_308 CTX_L10_21|CTX_L10_24|CTX_L30_17|CTX_L8_60 CTX_L8_61 96.0513a
Cext_309 CTX_L10_21|CTX_L10_24|CTX_L30_17|CTX_L8_60 CTX_L8_70 0.118107a
Cext_310 CTX_L10_21|CTX_L10_24|CTX_L30_17|CTX_L8_60 CTX_L8_9 65.5866a
Cext_311 CTX_L10_21|CTX_L10_24|CTX_L30_17|CTX_L8_60 VSUBS 553.689a
Cext_312 CTX_L10_22|CTX_L30_21|CTX_L8_58
+ CTX_L10_23|CTX_L30_22|CTX_L30_3|CTX_L50_2|CTX_L8_59 8.90952a
Cext_313 CTX_L10_22|CTX_L30_21|CTX_L8_58
+ CTX_L10_25|CTX_L10_30|CTX_L30_19|CTX_L30_23|CTX_L8_51 252.398a
Cext_314 CTX_L10_22|CTX_L30_21|CTX_L8_58 CTX_L10_26|CTX_L30_25|CTX_L8_71
+ 11.4888a
Cext_315 CTX_L10_22|CTX_L30_21|CTX_L8_58 CTX_L10_27|CTX_L8_45 29.9798a
Cext_316 CTX_L10_22|CTX_L30_21|CTX_L8_58 CTX_L10_28|CTX_L30_24|CTX_L8_64
+ 36.1411a
Cext_317 CTX_L10_22|CTX_L30_21|CTX_L8_58 CTX_L10_29|CTX_L10_4|CTX_L30_5 208.495a
Cext_318 CTX_L10_22|CTX_L30_21|CTX_L8_58 CTX_L126_0 3.25367a
Cext_319 CTX_L10_22|CTX_L30_21|CTX_L8_58 CTX_L126_2|CTX_L134_0 3.63151a
Cext_320 CTX_L10_22|CTX_L30_21|CTX_L8_58 CTX_L50_5 0.502068a
Cext_321 CTX_L10_22|CTX_L30_21|CTX_L8_58 CTX_L8_48 3.09802a
Cext_322 CTX_L10_22|CTX_L30_21|CTX_L8_58 CTX_L8_49 225.27a
Cext_323 CTX_L10_22|CTX_L30_21|CTX_L8_58 CTX_L8_52 1.89351a
Cext_324 CTX_L10_22|CTX_L30_21|CTX_L8_58 CTX_L8_53 97.4083a
Cext_325 CTX_L10_22|CTX_L30_21|CTX_L8_58 CTX_L8_55 6.09063a
Cext_326 CTX_L10_22|CTX_L30_21|CTX_L8_58 CTX_L8_56 0.514948a
Cext_327 CTX_L10_22|CTX_L30_21|CTX_L8_58 CTX_L8_57 108.789a
Cext_328 CTX_L10_22|CTX_L30_21|CTX_L8_58 CTX_L8_61 157.451a
Cext_329 CTX_L10_22|CTX_L30_21|CTX_L8_58 CTX_L8_66 0.247141a
Cext_330 CTX_L10_22|CTX_L30_21|CTX_L8_58 VSUBS 161.771a
Cext_331 CTX_L10_23|CTX_L30_22|CTX_L30_3|CTX_L50_2|CTX_L8_59
+ CTX_L10_25|CTX_L10_30|CTX_L30_19|CTX_L30_23|CTX_L8_51 71.5839a
Cext_332 CTX_L10_23|CTX_L30_22|CTX_L30_3|CTX_L50_2|CTX_L8_59
+ CTX_L10_26|CTX_L30_25|CTX_L8_71 2.00994a
Cext_333 CTX_L10_23|CTX_L30_22|CTX_L30_3|CTX_L50_2|CTX_L8_59
+ CTX_L10_27|CTX_L8_45 1.89542a
Cext_334 CTX_L10_23|CTX_L30_22|CTX_L30_3|CTX_L50_2|CTX_L8_59
+ CTX_L10_29|CTX_L10_4|CTX_L30_5 40.5607a
Cext_335 CTX_L10_23|CTX_L30_22|CTX_L30_3|CTX_L50_2|CTX_L8_59
+ CTX_L10_3|CTX_L30_4 199.694a
Cext_336 CTX_L10_23|CTX_L30_22|CTX_L30_3|CTX_L50_2|CTX_L8_59
+ CTX_L10_32|CTX_L8_20 124.403a
Cext_337 CTX_L10_23|CTX_L30_22|CTX_L30_3|CTX_L50_2|CTX_L8_59 CTX_L10_34 12.2991a
Cext_338 CTX_L10_23|CTX_L30_22|CTX_L30_3|CTX_L50_2|CTX_L8_59
+ CTX_L10_5|CTX_L8_12 29.2899a
Cext_339 CTX_L10_23|CTX_L30_22|CTX_L30_3|CTX_L50_2|CTX_L8_59
+ CTX_L10_8|CTX_L8_25 1.26557a
Cext_340 CTX_L10_23|CTX_L30_22|CTX_L30_3|CTX_L50_2|CTX_L8_59
+ CTX_L10_9|CTX_L30_9 75.9468a
Cext_341 CTX_L10_23|CTX_L30_22|CTX_L30_3|CTX_L50_2|CTX_L8_59 CTX_L126_0 100.004a
Cext_342 CTX_L10_23|CTX_L30_22|CTX_L30_3|CTX_L50_2|CTX_L8_59 CTX_L126_1 6.81548a
Cext_343 CTX_L10_23|CTX_L30_22|CTX_L30_3|CTX_L50_2|CTX_L8_59
+ CTX_L126_2|CTX_L134_0 54.1504a
Cext_344 CTX_L10_23|CTX_L30_22|CTX_L30_3|CTX_L50_2|CTX_L8_59
+ CTX_L30_11|CTX_L50_14|CTX_L50_7 39.5845a
Cext_345 CTX_L10_23|CTX_L30_22|CTX_L30_3|CTX_L50_2|CTX_L8_59
+ CTX_L30_18|CTX_L50_1 27.4857a
Cext_346 CTX_L10_23|CTX_L30_22|CTX_L30_3|CTX_L50_2|CTX_L8_59 CTX_L30_7 2.53092a
Cext_347 CTX_L10_23|CTX_L30_22|CTX_L30_3|CTX_L50_2|CTX_L8_59 CTX_L50_11 3.38527a
Cext_348 CTX_L10_23|CTX_L30_22|CTX_L30_3|CTX_L50_2|CTX_L8_59 CTX_L50_13
+ 0.121885a
Cext_349 CTX_L10_23|CTX_L30_22|CTX_L30_3|CTX_L50_2|CTX_L8_59 CTX_L50_5 176.02a
Cext_350 CTX_L10_23|CTX_L30_22|CTX_L30_3|CTX_L50_2|CTX_L8_59 CTX_L50_9 32.1714a
Cext_351 CTX_L10_23|CTX_L30_22|CTX_L30_3|CTX_L50_2|CTX_L8_59 CTX_L8_10 0.526295a
Cext_352 CTX_L10_23|CTX_L30_22|CTX_L30_3|CTX_L50_2|CTX_L8_59 CTX_L8_13 1.06331a
Cext_353 CTX_L10_23|CTX_L30_22|CTX_L30_3|CTX_L50_2|CTX_L8_59 CTX_L8_15 0.986388a
Cext_354 CTX_L10_23|CTX_L30_22|CTX_L30_3|CTX_L50_2|CTX_L8_59 CTX_L8_17 3.17259a
Cext_355 CTX_L10_23|CTX_L30_22|CTX_L30_3|CTX_L50_2|CTX_L8_59 CTX_L8_19 2.08496a
Cext_356 CTX_L10_23|CTX_L30_22|CTX_L30_3|CTX_L50_2|CTX_L8_59 CTX_L8_21 0.453601a
Cext_357 CTX_L10_23|CTX_L30_22|CTX_L30_3|CTX_L50_2|CTX_L8_59 CTX_L8_22 3.41271a
Cext_358 CTX_L10_23|CTX_L30_22|CTX_L30_3|CTX_L50_2|CTX_L8_59 CTX_L8_23 0.125841a
Cext_359 CTX_L10_23|CTX_L30_22|CTX_L30_3|CTX_L50_2|CTX_L8_59 CTX_L8_24 22.8913a
Cext_360 CTX_L10_23|CTX_L30_22|CTX_L30_3|CTX_L50_2|CTX_L8_59 CTX_L8_26 2.20867a
Cext_361 CTX_L10_23|CTX_L30_22|CTX_L30_3|CTX_L50_2|CTX_L8_59 CTX_L8_27 2.825a
Cext_362 CTX_L10_23|CTX_L30_22|CTX_L30_3|CTX_L50_2|CTX_L8_59 CTX_L8_28 1.60054a
Cext_363 CTX_L10_23|CTX_L30_22|CTX_L30_3|CTX_L50_2|CTX_L8_59 CTX_L8_30 3.53156a
Cext_364 CTX_L10_23|CTX_L30_22|CTX_L30_3|CTX_L50_2|CTX_L8_59 CTX_L8_31 0.491125a
Cext_365 CTX_L10_23|CTX_L30_22|CTX_L30_3|CTX_L50_2|CTX_L8_59 CTX_L8_32 3.96358a
Cext_366 CTX_L10_23|CTX_L30_22|CTX_L30_3|CTX_L50_2|CTX_L8_59 CTX_L8_34 2.23107a
Cext_367 CTX_L10_23|CTX_L30_22|CTX_L30_3|CTX_L50_2|CTX_L8_59 CTX_L8_35 23.0095a
Cext_368 CTX_L10_23|CTX_L30_22|CTX_L30_3|CTX_L50_2|CTX_L8_59 CTX_L8_44 0.874516a
Cext_369 CTX_L10_23|CTX_L30_22|CTX_L30_3|CTX_L50_2|CTX_L8_59 CTX_L8_46 2.5017a
Cext_370 CTX_L10_23|CTX_L30_22|CTX_L30_3|CTX_L50_2|CTX_L8_59 CTX_L8_48 0.391035a
Cext_371 CTX_L10_23|CTX_L30_22|CTX_L30_3|CTX_L50_2|CTX_L8_59 CTX_L8_49 109.153a
Cext_372 CTX_L10_23|CTX_L30_22|CTX_L30_3|CTX_L50_2|CTX_L8_59 CTX_L8_53 234.842a
Cext_373 CTX_L10_23|CTX_L30_22|CTX_L30_3|CTX_L50_2|CTX_L8_59 CTX_L8_54 48.0044a
Cext_374 CTX_L10_23|CTX_L30_22|CTX_L30_3|CTX_L50_2|CTX_L8_59 CTX_L8_61 104.377a
Cext_375 CTX_L10_23|CTX_L30_22|CTX_L30_3|CTX_L50_2|CTX_L8_59 CTX_L8_74 0.102269a
Cext_376 CTX_L10_23|CTX_L30_22|CTX_L30_3|CTX_L50_2|CTX_L8_59 CTX_L8_9 9.79528a
Cext_377 CTX_L10_23|CTX_L30_22|CTX_L30_3|CTX_L50_2|CTX_L8_59 VSUBS 941.398a
Cext_378 CTX_L10_25|CTX_L10_30|CTX_L30_19|CTX_L30_23|CTX_L8_51
+ CTX_L10_26|CTX_L30_25|CTX_L8_71 63.4819a
Cext_379 CTX_L10_25|CTX_L10_30|CTX_L30_19|CTX_L30_23|CTX_L8_51
+ CTX_L10_27|CTX_L8_45 30.474a
Cext_380 CTX_L10_25|CTX_L10_30|CTX_L30_19|CTX_L30_23|CTX_L8_51
+ CTX_L10_28|CTX_L30_24|CTX_L8_64 0.448418a
Cext_381 CTX_L10_25|CTX_L10_30|CTX_L30_19|CTX_L30_23|CTX_L8_51
+ CTX_L10_29|CTX_L10_4|CTX_L30_5 1.13274f
Cext_382 CTX_L10_25|CTX_L10_30|CTX_L30_19|CTX_L30_23|CTX_L8_51
+ CTX_L10_32|CTX_L8_20 153.072a
Cext_383 CTX_L10_25|CTX_L10_30|CTX_L30_19|CTX_L30_23|CTX_L8_51
+ CTX_L10_33|CTX_L30_13 3.69735a
Cext_384 CTX_L10_25|CTX_L10_30|CTX_L30_19|CTX_L30_23|CTX_L8_51 CTX_L126_0
+ 14.7725a
Cext_385 CTX_L10_25|CTX_L10_30|CTX_L30_19|CTX_L30_23|CTX_L8_51
+ CTX_L126_2|CTX_L134_0 6.03981a
Cext_386 CTX_L10_25|CTX_L10_30|CTX_L30_19|CTX_L30_23|CTX_L8_51
+ CTX_L30_26|CTX_L50_4|CTX_L50_8 0.422432a
Cext_387 CTX_L10_25|CTX_L10_30|CTX_L30_19|CTX_L30_23|CTX_L8_51 CTX_L50_5
+ 1.76827a
Cext_388 CTX_L10_25|CTX_L10_30|CTX_L30_19|CTX_L30_23|CTX_L8_51 CTX_L8_35
+ 0.121306a
Cext_389 CTX_L10_25|CTX_L10_30|CTX_L30_19|CTX_L30_23|CTX_L8_51 CTX_L8_44
+ 3.46802a
Cext_390 CTX_L10_25|CTX_L10_30|CTX_L30_19|CTX_L30_23|CTX_L8_51 CTX_L8_46 1.1326a
Cext_391 CTX_L10_25|CTX_L10_30|CTX_L30_19|CTX_L30_23|CTX_L8_51 CTX_L8_48
+ 1.19701a
Cext_392 CTX_L10_25|CTX_L10_30|CTX_L30_19|CTX_L30_23|CTX_L8_51 CTX_L8_49
+ 79.7714a
Cext_393 CTX_L10_25|CTX_L10_30|CTX_L30_19|CTX_L30_23|CTX_L8_51 CTX_L8_53
+ 21.9832a
Cext_394 CTX_L10_25|CTX_L10_30|CTX_L30_19|CTX_L30_23|CTX_L8_51 CTX_L8_54
+ 198.985a
Cext_395 CTX_L10_25|CTX_L10_30|CTX_L30_19|CTX_L30_23|CTX_L8_51 CTX_L8_55
+ 0.356161a
Cext_396 CTX_L10_25|CTX_L10_30|CTX_L30_19|CTX_L30_23|CTX_L8_51 CTX_L8_57
+ 0.686256a
Cext_397 CTX_L10_25|CTX_L10_30|CTX_L30_19|CTX_L30_23|CTX_L8_51 CTX_L8_61
+ 36.9181a
Cext_398 CTX_L10_25|CTX_L10_30|CTX_L30_19|CTX_L30_23|CTX_L8_51 CTX_L8_62
+ 9.46456a
Cext_399 CTX_L10_25|CTX_L10_30|CTX_L30_19|CTX_L30_23|CTX_L8_51 CTX_L8_66
+ 15.6391a
Cext_400 CTX_L10_25|CTX_L10_30|CTX_L30_19|CTX_L30_23|CTX_L8_51 CTX_L8_67
+ 9.21004a
Cext_401 CTX_L10_25|CTX_L10_30|CTX_L30_19|CTX_L30_23|CTX_L8_51 CTX_L8_68
+ 0.242476a
Cext_402 CTX_L10_25|CTX_L10_30|CTX_L30_19|CTX_L30_23|CTX_L8_51 CTX_L8_69
+ 23.4668a
Cext_403 CTX_L10_25|CTX_L10_30|CTX_L30_19|CTX_L30_23|CTX_L8_51 CTX_L8_73
+ 9.17378a
Cext_404 CTX_L10_25|CTX_L10_30|CTX_L30_19|CTX_L30_23|CTX_L8_51 CTX_L8_74
+ 21.1441a
Cext_405 CTX_L10_25|CTX_L10_30|CTX_L30_19|CTX_L30_23|CTX_L8_51 VSUBS 199.5a
Cext_406 CTX_L10_26|CTX_L30_25|CTX_L8_71 CTX_L10_27|CTX_L8_45 27.1516a
Cext_407 CTX_L10_26|CTX_L30_25|CTX_L8_71 CTX_L10_28|CTX_L30_24|CTX_L8_64
+ 129.598a
Cext_408 CTX_L10_26|CTX_L30_25|CTX_L8_71 CTX_L10_29|CTX_L10_4|CTX_L30_5 26.5a
Cext_409 CTX_L10_26|CTX_L30_25|CTX_L8_71 CTX_L10_32|CTX_L8_20 133.993a
Cext_410 CTX_L10_26|CTX_L30_25|CTX_L8_71 CTX_L10_33|CTX_L30_13 4.51836a
Cext_411 CTX_L10_26|CTX_L30_25|CTX_L8_71 CTX_L126_0 24.204a
Cext_412 CTX_L10_26|CTX_L30_25|CTX_L8_71 CTX_L30_11|CTX_L50_14|CTX_L50_7
+ 0.830884a
Cext_413 CTX_L10_26|CTX_L30_25|CTX_L8_71 CTX_L30_20|CTX_L50_12|CTX_L50_6
+ 1.20984a
Cext_414 CTX_L10_26|CTX_L30_25|CTX_L8_71 CTX_L30_26|CTX_L50_4|CTX_L50_8 4.91903a
Cext_415 CTX_L10_26|CTX_L30_25|CTX_L8_71 CTX_L30_27|CTX_L50_3 27.2358a
Cext_416 CTX_L10_26|CTX_L30_25|CTX_L8_71 CTX_L50_5 7.95126a
Cext_417 CTX_L10_26|CTX_L30_25|CTX_L8_71 CTX_L50_9 0.133143a
Cext_418 CTX_L10_26|CTX_L30_25|CTX_L8_71 CTX_L8_49 1.52517a
Cext_419 CTX_L10_26|CTX_L30_25|CTX_L8_71 CTX_L8_53 0.875557a
Cext_420 CTX_L10_26|CTX_L30_25|CTX_L8_71 CTX_L8_54 1.57732a
Cext_421 CTX_L10_26|CTX_L30_25|CTX_L8_71 CTX_L8_57 0.359665a
Cext_422 CTX_L10_26|CTX_L30_25|CTX_L8_71 CTX_L8_61 188.133a
Cext_423 CTX_L10_26|CTX_L30_25|CTX_L8_71 CTX_L8_62 3.10677a
Cext_424 CTX_L10_26|CTX_L30_25|CTX_L8_71 CTX_L8_63 4.30886a
Cext_425 CTX_L10_26|CTX_L30_25|CTX_L8_71 CTX_L8_65 9.69028a
Cext_426 CTX_L10_26|CTX_L30_25|CTX_L8_71 CTX_L8_66 11.3292a
Cext_427 CTX_L10_26|CTX_L30_25|CTX_L8_71 CTX_L8_67 10.8013a
Cext_428 CTX_L10_26|CTX_L30_25|CTX_L8_71 CTX_L8_68 8.8166a
Cext_429 CTX_L10_26|CTX_L30_25|CTX_L8_71 CTX_L8_69 13.1758a
Cext_430 CTX_L10_26|CTX_L30_25|CTX_L8_71 CTX_L8_70 111.835a
Cext_431 CTX_L10_26|CTX_L30_25|CTX_L8_71 CTX_L8_72 4.93314a
Cext_432 CTX_L10_26|CTX_L30_25|CTX_L8_71 CTX_L8_73 5.19778a
Cext_433 CTX_L10_26|CTX_L30_25|CTX_L8_71 CTX_L8_74 217.246a
Cext_434 CTX_L10_26|CTX_L30_25|CTX_L8_71 VSUBS 459.54a
Cext_435 CTX_L10_27|CTX_L8_45 CTX_L10_28|CTX_L30_24|CTX_L8_64 553.713a
Cext_436 CTX_L10_27|CTX_L8_45 CTX_L10_29|CTX_L10_4|CTX_L30_5 157.689a
Cext_437 CTX_L10_27|CTX_L8_45 CTX_L10_8|CTX_L8_25 2.85919a
Cext_438 CTX_L10_27|CTX_L8_45 CTX_L126_0 2.56465a
Cext_439 CTX_L10_27|CTX_L8_45 CTX_L126_2|CTX_L134_0 4.87041a
Cext_440 CTX_L10_27|CTX_L8_45 CTX_L8_35 107.411a
Cext_441 CTX_L10_27|CTX_L8_45 CTX_L8_44 243.263a
Cext_442 CTX_L10_27|CTX_L8_45 CTX_L8_48 5.29245a
Cext_443 CTX_L10_27|CTX_L8_45 CTX_L8_49 168.832a
Cext_444 CTX_L10_27|CTX_L8_45 CTX_L8_52 8.89783a
Cext_445 CTX_L10_27|CTX_L8_45 CTX_L8_55 47.1777a
Cext_446 CTX_L10_27|CTX_L8_45 CTX_L8_56 0.815403a
Cext_447 CTX_L10_27|CTX_L8_45 CTX_L8_57 17.2264a
Cext_448 CTX_L10_27|CTX_L8_45 CTX_L8_61 45.7246a
Cext_449 CTX_L10_27|CTX_L8_45 CTX_L8_63 4.61271a
Cext_450 CTX_L10_27|CTX_L8_45 CTX_L8_65 20.5142a
Cext_451 CTX_L10_27|CTX_L8_45 CTX_L8_66 16.1221a
Cext_452 CTX_L10_27|CTX_L8_45 CTX_L8_69 48.1546a
Cext_453 CTX_L10_27|CTX_L8_45 CTX_L8_72 5.03813a
Cext_454 CTX_L10_27|CTX_L8_45 CTX_L8_73 12.552a
Cext_455 CTX_L10_27|CTX_L8_45 CTX_L8_74 29.71a
Cext_456 CTX_L10_27|CTX_L8_45 VSUBS 466.369a
Cext_457 CTX_L10_28|CTX_L30_24|CTX_L8_64 CTX_L10_29|CTX_L10_4|CTX_L30_5 193.25a
Cext_458 CTX_L10_28|CTX_L30_24|CTX_L8_64 CTX_L126_0 2.86901a
Cext_459 CTX_L10_28|CTX_L30_24|CTX_L8_64 CTX_L126_2|CTX_L134_0 0.404448a
Cext_460 CTX_L10_28|CTX_L30_24|CTX_L8_64 CTX_L30_26|CTX_L50_4|CTX_L50_8
+ 0.109113a
Cext_461 CTX_L10_28|CTX_L30_24|CTX_L8_64 CTX_L8_49 0.678002a
Cext_462 CTX_L10_28|CTX_L30_24|CTX_L8_64 CTX_L8_52 1.82842a
Cext_463 CTX_L10_28|CTX_L30_24|CTX_L8_64 CTX_L8_55 3.96543a
Cext_464 CTX_L10_28|CTX_L30_24|CTX_L8_64 CTX_L8_56 1.02709a
Cext_465 CTX_L10_28|CTX_L30_24|CTX_L8_64 CTX_L8_57 9.25192a
Cext_466 CTX_L10_28|CTX_L30_24|CTX_L8_64 CTX_L8_61 51.4607a
Cext_467 CTX_L10_28|CTX_L30_24|CTX_L8_64 CTX_L8_62 0.380271a
Cext_468 CTX_L10_28|CTX_L30_24|CTX_L8_64 CTX_L8_63 1.52151a
Cext_469 CTX_L10_28|CTX_L30_24|CTX_L8_64 CTX_L8_65 235.032a
Cext_470 CTX_L10_28|CTX_L30_24|CTX_L8_64 CTX_L8_66 81.7086a
Cext_471 CTX_L10_28|CTX_L30_24|CTX_L8_64 CTX_L8_69 17.4379a
Cext_472 CTX_L10_28|CTX_L30_24|CTX_L8_64 CTX_L8_72 0.118835a
Cext_473 CTX_L10_28|CTX_L30_24|CTX_L8_64 CTX_L8_73 13.5715a
Cext_474 CTX_L10_28|CTX_L30_24|CTX_L8_64 CTX_L8_74 31.066a
Cext_475 CTX_L10_28|CTX_L30_24|CTX_L8_64 VSUBS 127.828a
Cext_476 CTX_L10_29|CTX_L10_4|CTX_L30_5 CTX_L10_3|CTX_L30_4 538.528a
Cext_477 CTX_L10_29|CTX_L10_4|CTX_L30_5 CTX_L10_32|CTX_L8_20 23.9151a
Cext_478 CTX_L10_29|CTX_L10_4|CTX_L30_5 CTX_L10_5|CTX_L8_12 0.517306a
Cext_479 CTX_L10_29|CTX_L10_4|CTX_L30_5 CTX_L10_8|CTX_L8_25 0.842305a
Cext_480 CTX_L10_29|CTX_L10_4|CTX_L30_5 CTX_L10_9|CTX_L30_9 16.9649a
Cext_481 CTX_L10_29|CTX_L10_4|CTX_L30_5 CTX_L126_0 9.10326a
Cext_482 CTX_L10_29|CTX_L10_4|CTX_L30_5 CTX_L126_2|CTX_L134_0 11.0876a
Cext_483 CTX_L10_29|CTX_L10_4|CTX_L30_5 CTX_L30_26|CTX_L50_4|CTX_L50_8 0.272947a
Cext_484 CTX_L10_29|CTX_L10_4|CTX_L30_5 CTX_L50_5 0.223818a
Cext_485 CTX_L10_29|CTX_L10_4|CTX_L30_5 CTX_L8_0 0.351239a
Cext_486 CTX_L10_29|CTX_L10_4|CTX_L30_5 CTX_L8_13 0.637483a
Cext_487 CTX_L10_29|CTX_L10_4|CTX_L30_5 CTX_L8_15 5.88697a
Cext_488 CTX_L10_29|CTX_L10_4|CTX_L30_5 CTX_L8_19 23.0034a
Cext_489 CTX_L10_29|CTX_L10_4|CTX_L30_5 CTX_L8_22 9.19082a
Cext_490 CTX_L10_29|CTX_L10_4|CTX_L30_5 CTX_L8_24 51.6857a
Cext_491 CTX_L10_29|CTX_L10_4|CTX_L30_5 CTX_L8_26 1.1056a
Cext_492 CTX_L10_29|CTX_L10_4|CTX_L30_5 CTX_L8_27 12.0086a
Cext_493 CTX_L10_29|CTX_L10_4|CTX_L30_5 CTX_L8_28 3.7908a
Cext_494 CTX_L10_29|CTX_L10_4|CTX_L30_5 CTX_L8_31 12.3494a
Cext_495 CTX_L10_29|CTX_L10_4|CTX_L30_5 CTX_L8_34 30.9934a
Cext_496 CTX_L10_29|CTX_L10_4|CTX_L30_5 CTX_L8_35 26.2616a
Cext_497 CTX_L10_29|CTX_L10_4|CTX_L30_5 CTX_L8_44 0.206194a
Cext_498 CTX_L10_29|CTX_L10_4|CTX_L30_5 CTX_L8_49 75.1664a
Cext_499 CTX_L10_29|CTX_L10_4|CTX_L30_5 CTX_L8_55 1.48494a
Cext_500 CTX_L10_29|CTX_L10_4|CTX_L30_5 CTX_L8_57 34.8127a
Cext_501 CTX_L10_29|CTX_L10_4|CTX_L30_5 CTX_L8_61 41.9939a
Cext_502 CTX_L10_29|CTX_L10_4|CTX_L30_5 CTX_L8_62 12.2657a
Cext_503 CTX_L10_29|CTX_L10_4|CTX_L30_5 CTX_L8_65 10.4755a
Cext_504 CTX_L10_29|CTX_L10_4|CTX_L30_5 CTX_L8_66 39.9108a
Cext_505 CTX_L10_29|CTX_L10_4|CTX_L30_5 CTX_L8_67 1.1056a
Cext_506 CTX_L10_29|CTX_L10_4|CTX_L30_5 CTX_L8_69 15.9484a
Cext_507 CTX_L10_29|CTX_L10_4|CTX_L30_5 CTX_L8_73 12.8298a
Cext_508 CTX_L10_29|CTX_L10_4|CTX_L30_5 CTX_L8_74 31.856a
Cext_509 CTX_L10_29|CTX_L10_4|CTX_L30_5 CTX_L8_9 34.4291a
Cext_510 CTX_L10_29|CTX_L10_4|CTX_L30_5 VSUBS 220.783a
Cext_511 CTX_L10_3|CTX_L30_4 CTX_L10_32|CTX_L8_20 29.9145a
Cext_512 CTX_L10_3|CTX_L30_4 CTX_L10_5|CTX_L8_12 57.1003a
Cext_513 CTX_L10_3|CTX_L30_4 CTX_L10_8|CTX_L8_25 40.9486a
Cext_514 CTX_L10_3|CTX_L30_4 CTX_L126_0 5.14309a
Cext_515 CTX_L10_3|CTX_L30_4 CTX_L126_2|CTX_L134_0 2.28974a
Cext_516 CTX_L10_3|CTX_L30_4 CTX_L8_1 0.912472a
Cext_517 CTX_L10_3|CTX_L30_4 CTX_L8_10 4.24935a
Cext_518 CTX_L10_3|CTX_L30_4 CTX_L8_13 10.1674a
Cext_519 CTX_L10_3|CTX_L30_4 CTX_L8_15 6.87172a
Cext_520 CTX_L10_3|CTX_L30_4 CTX_L8_17 0.512452a
Cext_521 CTX_L10_3|CTX_L30_4 CTX_L8_19 8.28435a
Cext_522 CTX_L10_3|CTX_L30_4 CTX_L8_24 1.98378a
Cext_523 CTX_L10_3|CTX_L30_4 CTX_L8_8 1.06015a
Cext_524 CTX_L10_3|CTX_L30_4 CTX_L8_9 38.5102a
Cext_525 CTX_L10_3|CTX_L30_4 VSUBS 71.8238a
Cext_526 CTX_L10_32|CTX_L8_20 CTX_L10_33|CTX_L30_13 16.2357a
Cext_527 CTX_L10_32|CTX_L8_20 CTX_L10_5|CTX_L8_12 12.0684a
Cext_528 CTX_L10_32|CTX_L8_20 CTX_L10_9|CTX_L30_9 29.787a
Cext_529 CTX_L10_32|CTX_L8_20 CTX_L126_0 31.5672a
Cext_530 CTX_L10_32|CTX_L8_20 CTX_L126_2|CTX_L134_0 6.88478a
Cext_531 CTX_L10_32|CTX_L8_20 CTX_L30_11|CTX_L50_14|CTX_L50_7 0.950207a
Cext_532 CTX_L10_32|CTX_L8_20 CTX_L30_20|CTX_L50_12|CTX_L50_6 1.61633a
Cext_533 CTX_L10_32|CTX_L8_20 CTX_L30_26|CTX_L50_4|CTX_L50_8 13.4022a
Cext_534 CTX_L10_32|CTX_L8_20 CTX_L30_27|CTX_L50_3 12.9532a
Cext_535 CTX_L10_32|CTX_L8_20 CTX_L50_5 9.83385a
Cext_536 CTX_L10_32|CTX_L8_20 CTX_L8_17 50.1198a
Cext_537 CTX_L10_32|CTX_L8_20 CTX_L8_19 133.541a
Cext_538 CTX_L10_32|CTX_L8_20 CTX_L8_22 13.2652a
Cext_539 CTX_L10_32|CTX_L8_20 CTX_L8_24 264.187a
Cext_540 CTX_L10_32|CTX_L8_20 CTX_L8_26 19.7108a
Cext_541 CTX_L10_32|CTX_L8_20 CTX_L8_27 0.246676a
Cext_542 CTX_L10_32|CTX_L8_20 CTX_L8_30 36.3158a
Cext_543 CTX_L10_32|CTX_L8_20 CTX_L8_31 0.635634a
Cext_544 CTX_L10_32|CTX_L8_20 CTX_L8_35 67.6946a
Cext_545 CTX_L10_32|CTX_L8_20 CTX_L8_46 37.2715a
Cext_546 CTX_L10_32|CTX_L8_20 CTX_L8_49 90.0539a
Cext_547 CTX_L10_32|CTX_L8_20 CTX_L8_53 3.49037a
Cext_548 CTX_L10_32|CTX_L8_20 CTX_L8_54 24.494a
Cext_549 CTX_L10_32|CTX_L8_20 CTX_L8_61 78.4425a
Cext_550 CTX_L10_32|CTX_L8_20 CTX_L8_62 1.3378a
Cext_551 CTX_L10_32|CTX_L8_20 CTX_L8_67 9.62115a
Cext_552 CTX_L10_32|CTX_L8_20 CTX_L8_68 36.6137a
Cext_553 CTX_L10_32|CTX_L8_20 CTX_L8_70 50.7244a
Cext_554 CTX_L10_32|CTX_L8_20 CTX_L8_73 0.652776a
Cext_555 CTX_L10_32|CTX_L8_20 CTX_L8_74 75.3752a
Cext_556 CTX_L10_32|CTX_L8_20 CTX_L8_9 92.0063a
Cext_557 CTX_L10_32|CTX_L8_20 VSUBS 634.711a
Cext_558 CTX_L10_33|CTX_L30_13 CTX_L10_34 238.843a
Cext_559 CTX_L10_33|CTX_L30_13 CTX_L10_35 35.5363a
Cext_560 CTX_L10_33|CTX_L30_13 CTX_L126_0 35.6569a
Cext_561 CTX_L10_33|CTX_L30_13 CTX_L126_1 45.9034a
Cext_562 CTX_L10_33|CTX_L30_13 CTX_L126_2|CTX_L134_0 74.3498a
Cext_563 CTX_L10_33|CTX_L30_13 CTX_L126_3 40.4298a
Cext_564 CTX_L10_33|CTX_L30_13 CTX_L30_11|CTX_L50_14|CTX_L50_7 499.081a
Cext_565 CTX_L10_33|CTX_L30_13 CTX_L30_12|CTX_L50_0 1.48471f
Cext_566 CTX_L10_33|CTX_L30_13 CTX_L30_18|CTX_L50_1 535.824a
Cext_567 CTX_L10_33|CTX_L30_13 CTX_L30_20|CTX_L50_12|CTX_L50_6 68.8449a
Cext_568 CTX_L10_33|CTX_L30_13 CTX_L30_26|CTX_L50_4|CTX_L50_8 40.7818a
Cext_569 CTX_L10_33|CTX_L30_13 CTX_L30_27|CTX_L50_3 11.7299a
Cext_570 CTX_L10_33|CTX_L30_13 CTX_L30_7 9.71987a
Cext_571 CTX_L10_33|CTX_L30_13 CTX_L50_11 29.5793a
Cext_572 CTX_L10_33|CTX_L30_13 CTX_L50_13 25.0481a
Cext_573 CTX_L10_33|CTX_L30_13 CTX_L50_15 27.6316a
Cext_574 CTX_L10_33|CTX_L30_13 CTX_L50_5 0.672051a
Cext_575 CTX_L10_33|CTX_L30_13 CTX_L50_9 60.6097a
Cext_576 CTX_L10_33|CTX_L30_13 CTX_L8_23 13.2375a
Cext_577 CTX_L10_33|CTX_L30_13 CTX_L8_35 0.441344a
Cext_578 CTX_L10_33|CTX_L30_13 CTX_L8_49 0.365807a
Cext_579 CTX_L10_33|CTX_L30_13 CTX_L8_61 0.560097a
Cext_580 CTX_L10_33|CTX_L30_13 CTX_L8_74 0.251827a
Cext_581 CTX_L10_33|CTX_L30_13 N 29.4672a
Cext_582 CTX_L10_33|CTX_L30_13 P 21.973a
Cext_583 CTX_L10_33|CTX_L30_13 VSUBS 1.49015f
Cext_584 CTX_L10_34 CTX_L10_35 179.466a
Cext_585 CTX_L10_34 CTX_L10_9|CTX_L30_9 38.6263a
Cext_586 CTX_L10_34 CTX_L126_0 13.0942a
Cext_587 CTX_L10_34 CTX_L126_1 81.8848a
Cext_588 CTX_L10_34 CTX_L126_2|CTX_L134_0 25.9097a
Cext_589 CTX_L10_34 CTX_L30_11|CTX_L50_14|CTX_L50_7 40.5474a
Cext_590 CTX_L10_34 CTX_L30_18|CTX_L50_1 77.7057a
Cext_591 CTX_L10_34 CTX_L30_20|CTX_L50_12|CTX_L50_6 41.3664a
Cext_592 CTX_L10_34 CTX_L30_26|CTX_L50_4|CTX_L50_8 14.291a
Cext_593 CTX_L10_34 CTX_L30_27|CTX_L50_3 3.81865a
Cext_594 CTX_L10_34 CTX_L30_7 0.379189a
Cext_595 CTX_L10_34 CTX_L50_11 72.8072a
Cext_596 CTX_L10_34 CTX_L50_13 8.97936a
Cext_597 CTX_L10_34 CTX_L50_9 52.2762a
Cext_598 CTX_L10_34 CTX_L8_23 0.292715a
Cext_599 CTX_L10_34 VSUBS 1.18126f
Cext_600 CTX_L10_35 CTX_L126_1 87.9815a
Cext_601 CTX_L10_35 CTX_L126_2|CTX_L134_0 58.0259a
Cext_602 CTX_L10_35 CTX_L30_11|CTX_L50_14|CTX_L50_7 45.9288a
Cext_603 CTX_L10_35 CTX_L30_12|CTX_L50_0 4.68442a
Cext_604 CTX_L10_35 CTX_L30_18|CTX_L50_1 35.4712a
Cext_605 CTX_L10_35 CTX_L30_20|CTX_L50_12|CTX_L50_6 3.78008a
Cext_606 CTX_L10_35 CTX_L30_28 1.87894a
Cext_607 CTX_L10_35 CTX_L30_7 54.7536a
Cext_608 CTX_L10_35 CTX_L50_11 5.14969a
Cext_609 CTX_L10_35 CTX_L50_13 35.4464a
Cext_610 CTX_L10_35 CTX_L50_15 68.0605a
Cext_611 CTX_L10_35 CTX_L8_23 17.9099a
Cext_612 CTX_L10_35 N 15.2199a
Cext_613 CTX_L10_35 P 18.783a
Cext_614 CTX_L10_35 VSUBS 1.34635f
Cext_615 CTX_L10_5|CTX_L8_12 CTX_L126_0 1.85008a
Cext_616 CTX_L10_5|CTX_L8_12 CTX_L126_2|CTX_L134_0 2.092a
Cext_617 CTX_L10_5|CTX_L8_12 CTX_L50_5 0.698448a
Cext_618 CTX_L10_5|CTX_L8_12 CTX_L8_1 0.767364a
Cext_619 CTX_L10_5|CTX_L8_12 CTX_L8_17 201.432a
Cext_620 CTX_L10_5|CTX_L8_12 CTX_L8_24 0.539607a
Cext_621 CTX_L10_5|CTX_L8_12 CTX_L8_3 0.226552a
Cext_622 CTX_L10_5|CTX_L8_12 CTX_L8_32 0.300945a
Cext_623 CTX_L10_5|CTX_L8_12 CTX_L8_9 57.8562a
Cext_624 CTX_L10_5|CTX_L8_12 VSUBS 82.6499a
Cext_625 CTX_L10_8|CTX_L8_25 CTX_L10_9|CTX_L30_9 22.4159a
Cext_626 CTX_L10_8|CTX_L8_25 CTX_L126_0 1.56482a
Cext_627 CTX_L10_8|CTX_L8_25 CTX_L126_2|CTX_L134_0 6.68704a
Cext_628 CTX_L10_8|CTX_L8_25 CTX_L8_10 11.1827a
Cext_629 CTX_L10_8|CTX_L8_25 CTX_L8_13 40.6345a
Cext_630 CTX_L10_8|CTX_L8_25 CTX_L8_15 30.8995a
Cext_631 CTX_L10_8|CTX_L8_25 CTX_L8_2 4.25323a
Cext_632 CTX_L10_8|CTX_L8_25 CTX_L8_21 2.66454a
Cext_633 CTX_L10_8|CTX_L8_25 CTX_L8_22 13.7901a
Cext_634 CTX_L10_8|CTX_L8_25 CTX_L8_24 61.6585a
Cext_635 CTX_L10_8|CTX_L8_25 CTX_L8_27 20.5831a
Cext_636 CTX_L10_8|CTX_L8_25 CTX_L8_28 205.576a
Cext_637 CTX_L10_8|CTX_L8_25 CTX_L8_29 0.115856a
Cext_638 CTX_L10_8|CTX_L8_25 CTX_L8_34 53.6766a
Cext_639 CTX_L10_8|CTX_L8_25 CTX_L8_35 0.763481a
Cext_640 CTX_L10_8|CTX_L8_25 CTX_L8_4 0.872194a
Cext_641 CTX_L10_8|CTX_L8_25 CTX_L8_5 0.491288a
Cext_642 CTX_L10_8|CTX_L8_25 CTX_L8_7 0.726648a
Cext_643 CTX_L10_8|CTX_L8_25 CTX_L8_8 5.64645a
Cext_644 CTX_L10_8|CTX_L8_25 CTX_L8_9 106.52a
Cext_645 CTX_L10_8|CTX_L8_25 VSUBS 340.694a
Cext_646 CTX_L10_9|CTX_L30_9 CTX_L126_0 75.6588a
Cext_647 CTX_L10_9|CTX_L30_9 CTX_L126_2|CTX_L134_0 16.898a
Cext_648 CTX_L10_9|CTX_L30_9 CTX_L30_18|CTX_L50_1 0.847492a
Cext_649 CTX_L10_9|CTX_L30_9 CTX_L50_5 46.501a
Cext_650 CTX_L10_9|CTX_L30_9 CTX_L50_9 2.4468a
Cext_651 CTX_L10_9|CTX_L30_9 CTX_L8_21 0.427749a
Cext_652 CTX_L10_9|CTX_L30_9 CTX_L8_22 3.37805a
Cext_653 CTX_L10_9|CTX_L30_9 CTX_L8_24 26.0993a
Cext_654 CTX_L10_9|CTX_L30_9 CTX_L8_26 5.87766a
Cext_655 CTX_L10_9|CTX_L30_9 CTX_L8_27 12.3569a
Cext_656 CTX_L10_9|CTX_L30_9 CTX_L8_28 7.20703a
Cext_657 CTX_L10_9|CTX_L30_9 CTX_L8_29 0.80431a
Cext_658 CTX_L10_9|CTX_L30_9 CTX_L8_3 0.11816a
Cext_659 CTX_L10_9|CTX_L30_9 CTX_L8_30 8.64454a
Cext_660 CTX_L10_9|CTX_L30_9 CTX_L8_31 0.194029a
Cext_661 CTX_L10_9|CTX_L30_9 CTX_L8_32 10.8556a
Cext_662 CTX_L10_9|CTX_L30_9 CTX_L8_34 3.11827a
Cext_663 CTX_L10_9|CTX_L30_9 CTX_L8_35 18.4916a
Cext_664 CTX_L10_9|CTX_L30_9 CTX_L8_46 0.510176a
Cext_665 CTX_L10_9|CTX_L30_9 CTX_L8_9 1.20841a
Cext_666 CTX_L10_9|CTX_L30_9 VSUBS 450.791a
Cext_667 CTX_L126_0 CTX_L126_2|CTX_L134_0 377.213a
Cext_668 CTX_L126_0 CTX_L30_11|CTX_L50_14|CTX_L50_7 66.2931a
Cext_669 CTX_L126_0 CTX_L30_18|CTX_L50_1 5.198a
Cext_670 CTX_L126_0 CTX_L30_20|CTX_L50_12|CTX_L50_6 87.03a
Cext_671 CTX_L126_0 CTX_L30_26|CTX_L50_4|CTX_L50_8 80.8944a
Cext_672 CTX_L126_0 CTX_L30_27|CTX_L50_3 15.1559a
Cext_673 CTX_L126_0 CTX_L50_11 5.84384a
Cext_674 CTX_L126_0 CTX_L50_5 357.536a
Cext_675 CTX_L126_0 CTX_L50_9 19.5764a
Cext_676 CTX_L126_0 CTX_L8_10 0.246279a
Cext_677 CTX_L126_0 CTX_L8_13 0.680671a
Cext_678 CTX_L126_0 CTX_L8_15 0.53915a
Cext_679 CTX_L126_0 CTX_L8_17 0.307677a
Cext_680 CTX_L126_0 CTX_L8_21 0.229142a
Cext_681 CTX_L126_0 CTX_L8_22 1.93249a
Cext_682 CTX_L126_0 CTX_L8_24 23.3041a
Cext_683 CTX_L126_0 CTX_L8_26 1.04727a
Cext_684 CTX_L126_0 CTX_L8_27 2.06251a
Cext_685 CTX_L126_0 CTX_L8_28 1.25755a
Cext_686 CTX_L126_0 CTX_L8_3 0.190859a
Cext_687 CTX_L126_0 CTX_L8_30 1.97133a
Cext_688 CTX_L126_0 CTX_L8_32 2.40161a
Cext_689 CTX_L126_0 CTX_L8_34 1.56748a
Cext_690 CTX_L126_0 CTX_L8_35 23.8843a
Cext_691 CTX_L126_0 CTX_L8_44 0.796443a
Cext_692 CTX_L126_0 CTX_L8_46 1.61507a
Cext_693 CTX_L126_0 CTX_L8_48 0.23869a
Cext_694 CTX_L126_0 CTX_L8_49 30.9927a
Cext_695 CTX_L126_0 CTX_L8_52 0.272159a
Cext_696 CTX_L126_0 CTX_L8_53 1.27931a
Cext_697 CTX_L126_0 CTX_L8_54 3.35859a
Cext_698 CTX_L126_0 CTX_L8_55 0.47611a
Cext_699 CTX_L126_0 CTX_L8_57 1.46559a
Cext_700 CTX_L126_0 CTX_L8_61 28.1185a
Cext_701 CTX_L126_0 CTX_L8_62 0.340909a
Cext_702 CTX_L126_0 CTX_L8_65 1.42128a
Cext_703 CTX_L126_0 CTX_L8_66 1.91064a
Cext_704 CTX_L126_0 CTX_L8_67 1.59129a
Cext_705 CTX_L126_0 CTX_L8_68 1.91939a
Cext_706 CTX_L126_0 CTX_L8_69 2.16285a
Cext_707 CTX_L126_0 CTX_L8_70 2.89041a
Cext_708 CTX_L126_0 CTX_L8_73 2.83492a
Cext_709 CTX_L126_0 CTX_L8_74 24.7801a
Cext_710 CTX_L126_0 CTX_L8_9 11.902a
Cext_711 CTX_L126_0 VSUBS 1.21434f
Cext_712 CTX_L126_1 CTX_L126_2|CTX_L134_0 399.608a
Cext_713 CTX_L126_1 CTX_L30_11|CTX_L50_14|CTX_L50_7 85.9247a
Cext_714 CTX_L126_1 CTX_L30_12|CTX_L50_0 10.843a
Cext_715 CTX_L126_1 CTX_L30_18|CTX_L50_1 74.5272a
Cext_716 CTX_L126_1 CTX_L30_20|CTX_L50_12|CTX_L50_6 117.56a
Cext_717 CTX_L126_1 CTX_L30_26|CTX_L50_4|CTX_L50_8 10.9151a
Cext_718 CTX_L126_1 CTX_L30_27|CTX_L50_3 1.84345a
Cext_719 CTX_L126_1 CTX_L30_28 3.38148a
Cext_720 CTX_L126_1 CTX_L30_7 71.6166a
Cext_721 CTX_L126_1 CTX_L50_11 134.674a
Cext_722 CTX_L126_1 CTX_L50_13 276.809a
Cext_723 CTX_L126_1 CTX_L50_15 35.4475a
Cext_724 CTX_L126_1 CTX_L50_9 30.5112a
Cext_725 CTX_L126_1 CTX_L8_23 14.3987a
Cext_726 CTX_L126_1 N 24.5412a
Cext_727 CTX_L126_1 P 29.4591a
Cext_728 CTX_L126_1 VSUBS 1.40347f
Cext_729 CTX_L126_2|CTX_L134_0 CTX_L30_11|CTX_L50_14|CTX_L50_7 62.8533a
Cext_730 CTX_L126_2|CTX_L134_0 CTX_L30_12|CTX_L50_0 81.9406a
Cext_731 CTX_L126_2|CTX_L134_0 CTX_L30_18|CTX_L50_1 99.4191a
Cext_732 CTX_L126_2|CTX_L134_0 CTX_L30_20|CTX_L50_12|CTX_L50_6 18.9472a
Cext_733 CTX_L126_2|CTX_L134_0 CTX_L30_28 77.7386a
Cext_734 CTX_L126_2|CTX_L134_0 CTX_L30_7 135.84a
Cext_735 CTX_L126_2|CTX_L134_0 CTX_L50_11 21.6641a
Cext_736 CTX_L126_2|CTX_L134_0 CTX_L50_13 12.5226a
Cext_737 CTX_L126_2|CTX_L134_0 CTX_L50_15 33.3997a
Cext_738 CTX_L126_2|CTX_L134_0 CTX_L50_5 18.4744a
Cext_739 CTX_L126_2|CTX_L134_0 CTX_L50_9 33.7491a
Cext_740 CTX_L126_2|CTX_L134_0 CTX_L8_10 0.257496a
Cext_741 CTX_L126_2|CTX_L134_0 CTX_L8_13 1.50064a
Cext_742 CTX_L126_2|CTX_L134_0 CTX_L8_15 1.91115a
Cext_743 CTX_L126_2|CTX_L134_0 CTX_L8_17 0.285938a
Cext_744 CTX_L126_2|CTX_L134_0 CTX_L8_19 0.771845a
Cext_745 CTX_L126_2|CTX_L134_0 CTX_L8_21 0.263321a
Cext_746 CTX_L126_2|CTX_L134_0 CTX_L8_22 0.727807a
Cext_747 CTX_L126_2|CTX_L134_0 CTX_L8_23 27.6346a
Cext_748 CTX_L126_2|CTX_L134_0 CTX_L8_24 13.155a
Cext_749 CTX_L126_2|CTX_L134_0 CTX_L8_26 1.3915a
Cext_750 CTX_L126_2|CTX_L134_0 CTX_L8_27 2.79073a
Cext_751 CTX_L126_2|CTX_L134_0 CTX_L8_28 1.57077a
Cext_752 CTX_L126_2|CTX_L134_0 CTX_L8_29 0.320598a
Cext_753 CTX_L126_2|CTX_L134_0 CTX_L8_30 2.0032a
Cext_754 CTX_L126_2|CTX_L134_0 CTX_L8_31 0.717188a
Cext_755 CTX_L126_2|CTX_L134_0 CTX_L8_32 2.8598a
Cext_756 CTX_L126_2|CTX_L134_0 CTX_L8_34 2.95263a
Cext_757 CTX_L126_2|CTX_L134_0 CTX_L8_35 14.9659a
Cext_758 CTX_L126_2|CTX_L134_0 CTX_L8_44 0.802487a
Cext_759 CTX_L126_2|CTX_L134_0 CTX_L8_46 1.2209a
Cext_760 CTX_L126_2|CTX_L134_0 CTX_L8_48 0.274764a
Cext_761 CTX_L126_2|CTX_L134_0 CTX_L8_49 13.6415a
Cext_762 CTX_L126_2|CTX_L134_0 CTX_L8_52 0.251864a
Cext_763 CTX_L126_2|CTX_L134_0 CTX_L8_53 1.10337a
Cext_764 CTX_L126_2|CTX_L134_0 CTX_L8_54 1.56047a
Cext_765 CTX_L126_2|CTX_L134_0 CTX_L8_55 1.57844a
Cext_766 CTX_L126_2|CTX_L134_0 CTX_L8_56 0.307581a
Cext_767 CTX_L126_2|CTX_L134_0 CTX_L8_57 2.25829a
Cext_768 CTX_L126_2|CTX_L134_0 CTX_L8_6 0.103417a
Cext_769 CTX_L126_2|CTX_L134_0 CTX_L8_61 8.35044a
Cext_770 CTX_L126_2|CTX_L134_0 CTX_L8_8 0.122997a
Cext_771 CTX_L126_2|CTX_L134_0 CTX_L8_9 1.90379a
Cext_772 CTX_L126_2|CTX_L134_0 N 83.5442a
Cext_773 CTX_L126_2|CTX_L134_0 P 28.7035a
Cext_774 CTX_L126_2|CTX_L134_0 VSUBS 2.72064f
Cext_775 CTX_L126_3 CTX_L30_12|CTX_L50_0 49.9541a
Cext_776 CTX_L126_3 CTX_L30_18|CTX_L50_1 74.0792a
Cext_777 CTX_L126_3 CTX_L30_28 59.4245a
Cext_778 CTX_L126_3 CTX_L30_7 275.535a
Cext_779 CTX_L126_3 CTX_L8_23 37.6766a
Cext_780 CTX_L126_3 VSUBS 1.69099f
Cext_781 CTX_L30_11|CTX_L50_14|CTX_L50_7 CTX_L30_12|CTX_L50_0 2.64463a
Cext_782 CTX_L30_11|CTX_L50_14|CTX_L50_7 CTX_L30_18|CTX_L50_1 56.3778a
Cext_783 CTX_L30_11|CTX_L50_14|CTX_L50_7 CTX_L30_20|CTX_L50_12|CTX_L50_6
+ 1.54347f
Cext_784 CTX_L30_11|CTX_L50_14|CTX_L50_7 CTX_L30_26|CTX_L50_4|CTX_L50_8 49.8673a
Cext_785 CTX_L30_11|CTX_L50_14|CTX_L50_7 CTX_L30_27|CTX_L50_3 9.57132a
Cext_786 CTX_L30_11|CTX_L50_14|CTX_L50_7 CTX_L30_28 0.180258a
Cext_787 CTX_L30_11|CTX_L50_14|CTX_L50_7 CTX_L50_11 31.929a
Cext_788 CTX_L30_11|CTX_L50_14|CTX_L50_7 CTX_L50_13 2.19768f
Cext_789 CTX_L30_11|CTX_L50_14|CTX_L50_7 CTX_L50_15 358.017a
Cext_790 CTX_L30_11|CTX_L50_14|CTX_L50_7 CTX_L50_5 120.655a
Cext_791 CTX_L30_11|CTX_L50_14|CTX_L50_7 CTX_L50_9 154.202a
Cext_792 CTX_L30_11|CTX_L50_14|CTX_L50_7 CTX_L8_35 0.11522a
Cext_793 CTX_L30_11|CTX_L50_14|CTX_L50_7 CTX_L8_49 0.616272a
Cext_794 CTX_L30_11|CTX_L50_14|CTX_L50_7 CTX_L8_61 0.182835a
Cext_795 CTX_L30_11|CTX_L50_14|CTX_L50_7 CTX_L8_74 0.29772a
Cext_796 CTX_L30_11|CTX_L50_14|CTX_L50_7 N 0.100382a
Cext_797 CTX_L30_11|CTX_L50_14|CTX_L50_7 P 0.143084a
Cext_798 CTX_L30_11|CTX_L50_14|CTX_L50_7 VSUBS 892.031a
Cext_799 CTX_L30_12|CTX_L50_0 CTX_L30_7 456.514a
Cext_800 CTX_L30_12|CTX_L50_0 CTX_L50_15 0.253581a
Cext_801 CTX_L30_12|CTX_L50_0 CTX_L8_23 73.6681a
Cext_802 CTX_L30_12|CTX_L50_0 N 1.36787f
Cext_803 CTX_L30_12|CTX_L50_0 P 0.647183a
Cext_804 CTX_L30_12|CTX_L50_0 VSUBS 805.683a
Cext_805 CTX_L30_18|CTX_L50_1 CTX_L30_20|CTX_L50_12|CTX_L50_6 159.793a
Cext_806 CTX_L30_18|CTX_L50_1 CTX_L30_7 0.176283a
Cext_807 CTX_L30_18|CTX_L50_1 CTX_L50_11 782.859a
Cext_808 CTX_L30_18|CTX_L50_1 CTX_L50_13 28.6464a
Cext_809 CTX_L30_18|CTX_L50_1 CTX_L50_15 27.7252a
Cext_810 CTX_L30_18|CTX_L50_1 CTX_L50_9 731.955a
Cext_811 CTX_L30_18|CTX_L50_1 CTX_L8_23 4.67575a
Cext_812 CTX_L30_18|CTX_L50_1 N 29.8397a
Cext_813 CTX_L30_18|CTX_L50_1 P 22.3455a
Cext_814 CTX_L30_18|CTX_L50_1 VSUBS 1.54942f
Cext_815 CTX_L30_20|CTX_L50_12|CTX_L50_6 CTX_L30_26|CTX_L50_4|CTX_L50_8 63.6129a
Cext_816 CTX_L30_20|CTX_L50_12|CTX_L50_6 CTX_L30_27|CTX_L50_3 9.1733a
Cext_817 CTX_L30_20|CTX_L50_12|CTX_L50_6 CTX_L50_11 573.936a
Cext_818 CTX_L30_20|CTX_L50_12|CTX_L50_6 CTX_L50_13 241.539a
Cext_819 CTX_L30_20|CTX_L50_12|CTX_L50_6 CTX_L50_5 338.564a
Cext_820 CTX_L30_20|CTX_L50_12|CTX_L50_6 CTX_L50_9 37.1914a
Cext_821 CTX_L30_20|CTX_L50_12|CTX_L50_6 CTX_L8_49 2.0444a
Cext_822 CTX_L30_20|CTX_L50_12|CTX_L50_6 CTX_L8_61 0.309564a
Cext_823 CTX_L30_20|CTX_L50_12|CTX_L50_6 CTX_L8_74 0.337131a
Cext_824 CTX_L30_20|CTX_L50_12|CTX_L50_6 VSUBS 634.976a
Cext_825 CTX_L30_26|CTX_L50_4|CTX_L50_8 CTX_L30_27|CTX_L50_3 257.284a
Cext_826 CTX_L30_26|CTX_L50_4|CTX_L50_8 CTX_L50_11 1.5905a
Cext_827 CTX_L30_26|CTX_L50_4|CTX_L50_8 CTX_L50_13 0.121885a
Cext_828 CTX_L30_26|CTX_L50_4|CTX_L50_8 CTX_L50_5 143.985a
Cext_829 CTX_L30_26|CTX_L50_4|CTX_L50_8 CTX_L50_9 651.981a
Cext_830 CTX_L30_26|CTX_L50_4|CTX_L50_8 CTX_L8_49 1.39878a
Cext_831 CTX_L30_26|CTX_L50_4|CTX_L50_8 CTX_L8_61 2.70002a
Cext_832 CTX_L30_26|CTX_L50_4|CTX_L50_8 CTX_L8_69 0.573654a
Cext_833 CTX_L30_26|CTX_L50_4|CTX_L50_8 CTX_L8_70 1.61289a
Cext_834 CTX_L30_26|CTX_L50_4|CTX_L50_8 CTX_L8_73 1.35567a
Cext_835 CTX_L30_26|CTX_L50_4|CTX_L50_8 CTX_L8_74 23.3546a
Cext_836 CTX_L30_26|CTX_L50_4|CTX_L50_8 VSUBS 478.71a
Cext_837 CTX_L30_27|CTX_L50_3 CTX_L30_28 0.779028a
Cext_838 CTX_L30_27|CTX_L50_3 CTX_L50_10 2.9197a
Cext_839 CTX_L30_27|CTX_L50_3 CTX_L50_11 1.82566a
Cext_840 CTX_L30_27|CTX_L50_3 CTX_L50_5 9.71741a
Cext_841 CTX_L30_27|CTX_L50_3 CTX_L50_9 14.0395a
Cext_842 CTX_L30_27|CTX_L50_3 CTX_L8_54 0.256564a
Cext_843 CTX_L30_27|CTX_L50_3 CTX_L8_61 0.421991a
Cext_844 CTX_L30_27|CTX_L50_3 CTX_L8_70 3.10149a
Cext_845 CTX_L30_27|CTX_L50_3 CTX_L8_74 18.7119a
Cext_846 CTX_L30_27|CTX_L50_3 VSUBS 458.379a
Cext_847 CTX_L30_28 CTX_L50_13 0.13858a
Cext_848 CTX_L30_28 CTX_L50_15 1.03183a
Cext_849 CTX_L30_28 N 14.3992a
Cext_850 CTX_L30_28 P 2.00042a
Cext_851 CTX_L30_28 VSUBS 1.56297f
Cext_852 CTX_L30_7 CTX_L50_11 0.363015a
Cext_853 CTX_L30_7 CTX_L50_13 1.73547a
Cext_854 CTX_L30_7 CTX_L50_15 66.7116a
Cext_855 CTX_L30_7 CTX_L50_9 0.133081a
Cext_856 CTX_L30_7 CTX_L8_23 262.504a
Cext_857 CTX_L30_7 N 123.873a
Cext_858 CTX_L30_7 P 123.843a
Cext_859 CTX_L30_7 VSUBS 2.38705f
Cext_860 CTX_L50_10 CTX_L50_11 2.54306a
Cext_861 CTX_L50_10 CTX_L50_9 14.5217a
Cext_862 CTX_L50_10 VSUBS 6.58991a
Cext_863 CTX_L50_11 CTX_L50_13 214.047a
Cext_864 CTX_L50_11 CTX_L50_9 464.459a
Cext_865 CTX_L50_11 CTX_L8_23 0.764395a
Cext_866 CTX_L50_11 VSUBS 315.365a
Cext_867 CTX_L50_13 CTX_L50_15 169.543a
Cext_868 CTX_L50_13 CTX_L8_23 1.82833a
Cext_869 CTX_L50_13 VSUBS 366.075a
Cext_870 CTX_L50_15 CTX_L8_23 2.65794a
Cext_871 CTX_L50_15 P 3.48775f
Cext_872 CTX_L50_15 VSUBS 243.208a
Cext_873 CTX_L50_5 CTX_L50_9 57.9416a
Cext_874 CTX_L50_5 CTX_L8_17 0.167142a
Cext_875 CTX_L50_5 CTX_L8_24 8.66612a
Cext_876 CTX_L50_5 CTX_L8_30 0.621492a
Cext_877 CTX_L50_5 CTX_L8_32 1.71343a
Cext_878 CTX_L50_5 CTX_L8_35 8.79458a
Cext_879 CTX_L50_5 CTX_L8_46 0.811989a
Cext_880 CTX_L50_5 CTX_L8_49 12.9241a
Cext_881 CTX_L50_5 CTX_L8_53 0.579218a
Cext_882 CTX_L50_5 CTX_L8_54 2.48495a
Cext_883 CTX_L50_5 CTX_L8_57 0.422866a
Cext_884 CTX_L50_5 CTX_L8_61 14.4049a
Cext_885 CTX_L50_5 CTX_L8_65 0.454901a
Cext_886 CTX_L50_5 CTX_L8_66 0.364647a
Cext_887 CTX_L50_5 CTX_L8_67 0.83296a
Cext_888 CTX_L50_5 CTX_L8_68 1.1907a
Cext_889 CTX_L50_5 CTX_L8_70 1.28062a
Cext_890 CTX_L50_5 CTX_L8_74 2.21319a
Cext_891 CTX_L50_5 CTX_L8_9 5.22747a
Cext_892 CTX_L50_5 VSUBS 476.382a
Cext_893 CTX_L50_9 CTX_L8_23 0.291801a
Cext_894 CTX_L50_9 CTX_L8_49 0.134357a
Cext_895 CTX_L50_9 VSUBS 605.989a
Cext_896 CTX_L8_0 CTX_L8_6 2.33144a
Cext_897 CTX_L8_0 CTX_L8_9 24.3707a
Cext_898 CTX_L8_0 VSUBS 13.4749a
Cext_899 CTX_L8_1 CTX_L8_9 22.2243a
Cext_900 CTX_L8_1 VSUBS 13.8692a
Cext_901 CTX_L8_10 CTX_L8_13 236.888a
Cext_902 CTX_L8_10 CTX_L8_21 2.66771a
Cext_903 CTX_L8_10 CTX_L8_8 20.1495a
Cext_904 CTX_L8_10 CTX_L8_9 38.5566a
Cext_905 CTX_L8_10 VSUBS 51.1973a
Cext_906 CTX_L8_13 CTX_L8_15 107.118a
Cext_907 CTX_L8_13 CTX_L8_21 30.1842a
Cext_908 CTX_L8_13 CTX_L8_24 90.4999a
Cext_909 CTX_L8_13 CTX_L8_8 2.90371a
Cext_910 CTX_L8_13 CTX_L8_9 47.6213a
Cext_911 CTX_L8_13 VSUBS 147.455a
Cext_912 CTX_L8_15 CTX_L8_24 287.237a
Cext_913 CTX_L8_15 CTX_L8_9 157.527a
Cext_914 CTX_L8_15 VSUBS 104.405a
Cext_915 CTX_L8_17 CTX_L8_24 115.24a
Cext_916 CTX_L8_17 CTX_L8_9 81.0516a
Cext_917 CTX_L8_17 VSUBS 118.714a
Cext_918 CTX_L8_19 CTX_L8_24 75.5691a
Cext_919 CTX_L8_19 CTX_L8_9 257.696a
Cext_920 CTX_L8_19 VSUBS 140.933a
Cext_921 CTX_L8_2 CTX_L8_5 6.18274a
Cext_922 CTX_L8_2 CTX_L8_9 34.8985a
Cext_923 CTX_L8_2 VSUBS 20.0892a
Cext_924 CTX_L8_21 CTX_L8_24 142.176a
Cext_925 CTX_L8_21 VSUBS 45.2165a
Cext_926 CTX_L8_22 CTX_L8_24 601.811a
Cext_927 CTX_L8_22 CTX_L8_26 32.3559a
Cext_928 CTX_L8_22 CTX_L8_27 400.769a
Cext_929 CTX_L8_22 CTX_L8_30 30.1842a
Cext_930 CTX_L8_22 VSUBS 136.768a
Cext_931 CTX_L8_23 N 11.984a
Cext_932 CTX_L8_23 P 3.85305a
Cext_933 CTX_L8_23 VSUBS 2.62474f
Cext_934 CTX_L8_24 CTX_L8_27 4.25625a
Cext_935 CTX_L8_24 CTX_L8_29 1.51405a
Cext_936 CTX_L8_24 CTX_L8_30 90.4999a
Cext_937 CTX_L8_24 CTX_L8_32 287.237a
Cext_938 CTX_L8_24 CTX_L8_35 14.6818a
Cext_939 CTX_L8_24 CTX_L8_9 24.7474a
Cext_940 CTX_L8_24 VSUBS 750.054a
Cext_941 CTX_L8_26 CTX_L8_27 241.315a
Cext_942 CTX_L8_26 CTX_L8_30 301.179a
Cext_943 CTX_L8_26 CTX_L8_31 294.646a
Cext_944 CTX_L8_26 CTX_L8_34 4.62935a
Cext_945 CTX_L8_26 CTX_L8_35 38.5566a
Cext_946 CTX_L8_26 VSUBS 112.422a
Cext_947 CTX_L8_27 CTX_L8_28 363.954a
Cext_948 CTX_L8_27 CTX_L8_29 126.042a
Cext_949 CTX_L8_27 CTX_L8_30 0.199518a
Cext_950 CTX_L8_27 CTX_L8_31 0.446751a
Cext_951 CTX_L8_27 CTX_L8_34 332.568a
Cext_952 CTX_L8_27 VSUBS 213.574a
Cext_953 CTX_L8_28 CTX_L8_34 264.772a
Cext_954 CTX_L8_28 VSUBS 98.414a
Cext_955 CTX_L8_29 CTX_L8_34 35.6315a
Cext_956 CTX_L8_29 VSUBS 51.0297a
Cext_957 CTX_L8_3 CTX_L8_9 61.2522a
Cext_958 CTX_L8_3 VSUBS 27.0147a
Cext_959 CTX_L8_30 CTX_L8_31 4.75891a
Cext_960 CTX_L8_30 CTX_L8_32 107.118a
Cext_961 CTX_L8_30 CTX_L8_35 47.6213a
Cext_962 CTX_L8_30 VSUBS 119.538a
Cext_963 CTX_L8_31 CTX_L8_34 438.367a
Cext_964 CTX_L8_31 CTX_L8_35 76.1853a
Cext_965 CTX_L8_31 VSUBS 48.8271a
Cext_966 CTX_L8_32 CTX_L8_35 157.527a
Cext_967 CTX_L8_32 VSUBS 104.298a
Cext_968 CTX_L8_34 CTX_L8_35 721.096a
Cext_969 CTX_L8_34 VSUBS 151.701a
Cext_970 CTX_L8_35 CTX_L8_44 81.0516a
Cext_971 CTX_L8_35 CTX_L8_46 96.2133a
Cext_972 CTX_L8_35 CTX_L8_49 39.4051a
Cext_973 CTX_L8_35 VSUBS 762.305a
Cext_974 CTX_L8_4 CTX_L8_7 5.21101a
Cext_975 CTX_L8_4 CTX_L8_9 44.7134a
Cext_976 CTX_L8_4 VSUBS 18.4315a
Cext_977 CTX_L8_44 CTX_L8_49 115.24a
Cext_978 CTX_L8_44 VSUBS 155.602a
Cext_979 CTX_L8_46 CTX_L8_49 115.638a
Cext_980 CTX_L8_46 VSUBS 111.862a
Cext_981 CTX_L8_48 CTX_L8_49 142.832a
Cext_982 CTX_L8_48 CTX_L8_52 2.66771a
Cext_983 CTX_L8_48 CTX_L8_55 30.1842a
Cext_984 CTX_L8_48 VSUBS 44.9921a
Cext_985 CTX_L8_49 CTX_L8_53 116.053a
Cext_986 CTX_L8_49 CTX_L8_54 115.24a
Cext_987 CTX_L8_49 CTX_L8_55 90.4999a
Cext_988 CTX_L8_49 CTX_L8_57 287.237a
Cext_989 CTX_L8_49 CTX_L8_61 29.5614a
Cext_990 CTX_L8_49 VSUBS 973.272a
Cext_991 CTX_L8_5 CTX_L8_9 45.4328a
Cext_992 CTX_L8_5 VSUBS 15.8715a
Cext_993 CTX_L8_52 CTX_L8_55 236.888a
Cext_994 CTX_L8_52 CTX_L8_56 20.1495a
Cext_995 CTX_L8_52 CTX_L8_61 38.5566a
Cext_996 CTX_L8_52 VSUBS 50.9124a
Cext_997 CTX_L8_53 CTX_L8_61 81.0516a
Cext_998 CTX_L8_53 VSUBS 106.325a
Cext_999 CTX_L8_54 CTX_L8_61 81.0516a
Cext_1000 CTX_L8_54 VSUBS 120.633a
Cext_1001 CTX_L8_55 CTX_L8_56 2.90371a
Cext_1002 CTX_L8_55 CTX_L8_57 107.118a
Cext_1003 CTX_L8_55 CTX_L8_61 47.6213a
Cext_1004 CTX_L8_55 VSUBS 147.421a
Cext_1005 CTX_L8_56 CTX_L8_61 59.8255a
Cext_1006 CTX_L8_56 VSUBS 24.7274a
Cext_1007 CTX_L8_57 CTX_L8_61 157.527a
Cext_1008 CTX_L8_57 VSUBS 105.214a
Cext_1009 CTX_L8_6 CTX_L8_9 66.407a
Cext_1010 CTX_L8_6 VSUBS 25.1739a
Cext_1011 CTX_L8_61 CTX_L8_62 76.1853a
Cext_1012 CTX_L8_61 CTX_L8_66 805.714a
Cext_1013 CTX_L8_61 CTX_L8_67 38.5566a
Cext_1014 CTX_L8_61 CTX_L8_68 47.6213a
Cext_1015 CTX_L8_61 CTX_L8_70 157.527a
Cext_1016 CTX_L8_61 CTX_L8_74 10.4806a
Cext_1017 CTX_L8_61 VSUBS 674.914a
Cext_1018 CTX_L8_62 CTX_L8_66 438.367a
Cext_1019 CTX_L8_62 CTX_L8_67 294.646a
Cext_1020 CTX_L8_62 CTX_L8_68 4.75891a
Cext_1021 CTX_L8_62 CTX_L8_69 0.446751a
Cext_1022 CTX_L8_62 VSUBS 49.0351a
Cext_1023 CTX_L8_63 CTX_L8_66 148.968a
Cext_1024 CTX_L8_63 CTX_L8_69 126.042a
Cext_1025 CTX_L8_63 CTX_L8_72 147.366a
Cext_1026 CTX_L8_63 CTX_L8_74 3.36708a
Cext_1027 CTX_L8_63 VSUBS 47.0272a
Cext_1028 CTX_L8_65 CTX_L8_66 264.772a
Cext_1029 CTX_L8_65 CTX_L8_69 363.954a
Cext_1030 CTX_L8_65 VSUBS 98.5943a
Cext_1031 CTX_L8_66 CTX_L8_67 4.62935a
Cext_1032 CTX_L8_66 CTX_L8_69 332.568a
Cext_1033 CTX_L8_66 VSUBS 158.284a
Cext_1034 CTX_L8_67 CTX_L8_68 301.179a
Cext_1035 CTX_L8_67 CTX_L8_69 241.315a
Cext_1036 CTX_L8_67 CTX_L8_73 32.3559a
Cext_1037 CTX_L8_67 VSUBS 112.884a
Cext_1038 CTX_L8_68 CTX_L8_69 0.199518a
Cext_1039 CTX_L8_68 CTX_L8_70 107.118a
Cext_1040 CTX_L8_68 CTX_L8_73 30.1842a
Cext_1041 CTX_L8_68 CTX_L8_74 90.4999a
Cext_1042 CTX_L8_68 VSUBS 120.524a
Cext_1043 CTX_L8_69 CTX_L8_72 57.7557a
Cext_1044 CTX_L8_69 CTX_L8_73 400.769a
Cext_1045 CTX_L8_69 CTX_L8_74 4.25625a
Cext_1046 CTX_L8_69 VSUBS 184.361a
Cext_1047 CTX_L8_7 CTX_L8_9 42.8624a
Cext_1048 CTX_L8_7 VSUBS 19.6131a
Cext_1049 CTX_L8_70 CTX_L8_74 287.237a
Cext_1050 CTX_L8_70 VSUBS 104.347a
Cext_1051 CTX_L8_72 CTX_L8_73 21.2332a
Cext_1052 CTX_L8_72 CTX_L8_74 33.7493a
Cext_1053 CTX_L8_72 VSUBS 132.647a
Cext_1054 CTX_L8_73 CTX_L8_74 601.811a
Cext_1055 CTX_L8_73 VSUBS 131.204a
Cext_1056 CTX_L8_74 VSUBS 779.035a
Cext_1057 CTX_L8_8 CTX_L8_9 59.8255a
Cext_1058 CTX_L8_8 VSUBS 24.5665a
Cext_1059 CTX_L8_9 VSUBS 886.331a
Cext_1060 N P 3.48775f
Cext_1061 N VSUBS 403.027a
Cext_1062 P VSUBS 89.1188a
.ENDS sense_fill_clip
