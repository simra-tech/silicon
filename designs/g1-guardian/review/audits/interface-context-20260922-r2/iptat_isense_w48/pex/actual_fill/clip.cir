* cell sense_fill_clip
.SUBCKT sense_fill_clip
* net 2 CTX_L8_9
* net 3 CTX_L8_7
* net 4 CTX_L8_4
* net 5 CTX_L8_2
* net 6 CTX_L10_8,CTX_L8_25
* net 7 CTX_L8_5
* net 8 CTX_L10_1,CTX_L10_20,CTX_L30_2,CTX_L8_41
* net 9 CTX_L8_6
* net 10 CTX_L10_13,CTX_L10_7,CTX_L30_1,CTX_L8_11,CTX_L8_33,CTX_L8_36
* net 11 CTX_L10_21,CTX_L10_24,CTX_L30_17,CTX_L8_60
* net 12 CTX_L8_0
* net 13 CTX_L8_1
* net 14 CTX_L10_5,CTX_L8_12
* net 15 CTX_L8_3
* net 16 FILL_L8_0
* net 17 FILL_L10_0
* net 18 FILL_L8_1
* net 19 FILL_L8_2
* net 20 FILL_L10_1
* net 21 FILL_L8_3
* net 22 FILL_L10_2
* net 23 FILL_L8_4
* net 24 FILL_L10_3
* net 25 FILL_L8_5
* net 26 FILL_L10_4
* net 27 FILL_L8_6
* net 28 FILL_L10_5
* net 29 FILL_L8_7
* net 30 CTX_L8_8
* net 31 CTX_L8_13
* net 32 CTX_L8_19
* net 33 CTX_L10_23,CTX_L30_22,CTX_L30_3,CTX_L50_2,CTX_L8_59
* net 34 CTX_L10_2,CTX_L8_18
* net 35 CTX_L8_10
* net 36 CTX_L8_15
* net 37 CTX_L10_29,CTX_L10_4,CTX_L30_5
* net 38 CTX_L10_3,CTX_L30_4
* net 39 CTX_L8_17
* net 40 FILL_L50_0
* net 41 FILL_L10_6
* net 42 FILL_L30_0
* net 43 FILL_L8_8
* net 44 CTX_L8_23
* net 45 FILL_L50_1
* net 46 FILL_L8_9
* net 47 FILL_L10_7
* net 48 FILL_L10_8
* net 49 FILL_L8_10
* net 50 FILL_L8_11
* net 51 FILL_L10_9
* net 52 FILL_L10_10
* net 53 FILL_L8_12
* net 54 CTX_L30_7
* net 55 FILL_L8_13
* net 56 FILL_L10_11
* net 57 FILL_L10_12
* net 58 FILL_L8_14
* net 59 FILL_L10_13
* net 60 FILL_L8_15
* net 61 FILL_L10_14
* net 62 FILL_L8_16
* net 63 FILL_L8_17
* net 64 FILL_L10_15
* net 65 CTX_L8_21
* net 66 CTX_L8_27
* net 67 FILL_L50_2
* net 68 FILL_L67_0
* net 69 CTX_L8_24
* net 70 CTX_L8_22
* net 71 CTX_L10_15,CTX_L30_8,CTX_L8_38
* net 72 CTX_L10_0,CTX_L10_17,CTX_L10_6,CTX_L30_0,CTX_L30_6,CTX_L8_14,CTX_L8_39
* net 73 CTX_L10_32,CTX_L8_20
* net 74 FILL_L67_1
* net 75 CTX_L8_32
* net 76 FILL_L8_18
* net 77 FILL_L67_2
* net 78 FILL_L10_16
* net 79 CTX_L30_18,CTX_L50_1
* net 80 FILL_L8_19
* net 81 FILL_L67_3
* net 82 FILL_L8_20
* net 83 FILL_L67_4
* net 84 FILL_L50_3
* net 85 FILL_L10_17
* net 86 FILL_L10_18
* net 87 FILL_L50_4
* net 88 FILL_L67_5
* net 89 FILL_L10_19
* net 90 FILL_L10_20
* net 91 FILL_L10_21
* net 92 FILL_L67_6
* net 93 FILL_L50_5
* net 94 FILL_L10_22
* net 95 FILL_L10_23
* net 96 FILL_L50_6
* net 97 FILL_L67_7
* net 98 FILL_L10_24
* net 99 FILL_L10_25
* net 100 FILL_L67_8
* net 101 FILL_L50_7
* net 102 FILL_L10_26
* net 103 CTX_L8_29
* net 104 CTX_L8_28
* net 105 CTX_L10_10,CTX_L30_10,CTX_L8_42
* net 106 CTX_L8_34
* net 107 CTX_L8_26
* net 108 CTX_L10_9,CTX_L30_9
* net 109 CTX_L8_30
* net 110 CTX_L126_2,CTX_L134_0
* net 111 FILL_L67_9
* net 112 FILL_L50_9
* net 113 CTX_L8_31
* net 114 CTX_L8_35
* net 115 FILL_L67_10
* net 116 CTX_L10_11,CTX_L10_12,CTX_L30_14,CTX_L8_47
* net 117 FILL_L10_27
* net 118 CTX_L30_11,CTX_L50_14,CTX_L50_7
* net 119 FILL_L8_21
* net 120 FILL_L67_11
* net 121 CTX_L10_33,CTX_L30_13
* net 122 CTX_L50_9
* net 123 FILL_L8_22
* net 124 FILL_L67_12
* net 125 FILL_L8_23
* net 126 FILL_L67_13
* net 127 CTX_L30_12,CTX_L50_0
* net 128 FILL_L50_8
* net 129 FILL_L10_29
* net 130 FILL_L8_24
* net 131 FILL_L50_11
* net 132 FILL_L67_14
* net 133 FILL_L8_25
* net 134 FILL_L10_30
* net 135 FILL_L67_15
* net 136 FILL_L50_12
* net 137 FILL_L10_31
* net 138 FILL_L8_26
* net 139 FILL_L134_0
* net 140 FILL_L8_27
* net 141 FILL_L10_32
* net 142 FILL_L50_13
* net 143 FILL_L67_16
* net 144 FILL_L10_33
* net 145 FILL_L8_28
* net 146 FILL_L50_14
* net 147 FILL_L67_17
* net 148 FILL_L134_1
* net 149 CTX_L8_44
* net 150 CTX_L10_18,CTX_L10_19,CTX_L10_31,CTX_L30_16,CTX_L8_16,CTX_L8_40,CTX_L8_50
* net 151 CTX_L10_14,CTX_L10_16,CTX_L30_15,CTX_L8_37,CTX_L8_43
* net 152 CTX_L8_46
* net 153 CTX_L126_0
* net 154 CTX_L50_5
* net 155 FILL_L10_28
* net 156 CTX_L10_34
* net 157 CTX_L50_11
* net 158 CTX_L126_1
* net 159 CTX_L50_13
* net 160 CTX_L10_35
* net 161 CTX_L50_15
* net 162 P
* net 163 N
* net 164 FILL_L50_10
* net 165 CTX_L126_3
* net 166 CTX_L8_48
* net 167 CTX_L8_49
* net 168 CTX_L10_27,CTX_L8_45
* net 169 CTX_L10_25,CTX_L10_30,CTX_L30_19,CTX_L30_23,CTX_L8_51
* net 170 CTX_L10_22,CTX_L30_21,CTX_L8_58
* net 171 FILL_L10_34
* net 172 CTX_L30_20,CTX_L50_12,CTX_L50_6
* net 173 CTX_L8_55
* net 174 CTX_L8_57
* net 175 CTX_L8_53
* net 176 CTX_L8_54
* net 177 FILL_L30_1
* net 178 FILL_L30_2
* net 179 FILL_L30_3
* net 180 FILL_L30_4
* net 181 FILL_L30_5
* net 182 FILL_L50_15
* net 183 FILL_L30_6
* net 184 FILL_L30_7
* net 185 FILL_L30_8
* net 186 FILL_L30_9
* net 187 FILL_L30_10
* net 188 FILL_L30_11
* net 189 FILL_L30_12
* net 190 FILL_L30_13
* net 191 CTX_L8_56
* net 192 CTX_L8_63
* net 193 CTX_L8_52
* net 194 FILL_L50_16
* net 195 FILL_L67_18
* net 196 CTX_L8_69
* net 197 CTX_L10_28,CTX_L30_24,CTX_L8_64
* net 198 CTX_L8_66
* net 199 CTX_L8_65
* net 200 CTX_L8_62
* net 201 CTX_L8_67
* net 202 CTX_L8_61
* net 203 FILL_L50_17
* net 204 CTX_L8_68
* net 205 FILL_L67_19
* net 206 CTX_L8_70
* net 207 CTX_L10_26,CTX_L30_25,CTX_L8_71
* net 208 FILL_L10_35
* net 209 FILL_L8_29
* net 210 FILL_L67_20
* net 211 FILL_L8_30
* net 212 FILL_L67_21
* net 213 FILL_L30_14
* net 214 FILL_L8_31
* net 215 FILL_L67_22
* net 216 FILL_L50_18
* net 217 FILL_L8_32
* net 218 FILL_L10_36
* net 219 FILL_L50_19
* net 220 FILL_L67_23
* net 221 FILL_L10_37
* net 222 FILL_L8_33
* net 223 FILL_L50_20
* net 224 FILL_L67_24
* net 225 FILL_L10_38
* net 226 FILL_L8_34
* net 227 FILL_L8_35
* net 228 FILL_L10_39
* net 229 FILL_L50_21
* net 230 FILL_L67_25
* net 231 FILL_L8_36
* net 232 FILL_L10_40
* net 233 FILL_L50_22
* net 234 FILL_L67_26
* net 235 CTX_L8_72
* net 236 CTX_L8_73
* net 237 CTX_L8_74
* net 238 CTX_L30_26,CTX_L50_4,CTX_L50_8
* net 239 FILL_L10_41
* net 240 FILL_L8_37
* net 241 FILL_L8_38
* net 242 FILL_L8_39
* net 243 CTX_L30_28
* net 244 FILL_L10_43
* net 245 FILL_L8_40
* net 246 FILL_L8_41
* net 247 FILL_L10_44
* net 248 FILL_L8_42
* net 249 FILL_L10_45
* net 250 FILL_L8_43
* net 251 FILL_L10_46
* net 252 FILL_L10_47
* net 253 FILL_L8_44
* net 254 FILL_L50_23
* net 255 FILL_L67_27
* net 256 FILL_L67_28
* net 257 CTX_L30_27,CTX_L50_3
* net 258 FILL_L67_29
* net 259 FILL_L10_42
* net 260 CTX_L50_10
* net 261 FILL_L67_30
* net 262 FILL_L30_15
* net 263 FILL_L67_31
* net 264 FILL_L67_32
* net 265 FILL_L50_24
* net 266 FILL_L67_33
* net 267 FILL_L50_25
* net 268 FILL_L67_34
* net 269 FILL_L50_26
* net 270 FILL_L67_35
* net 271 FILL_L50_27
.ENDS sense_fill_clip
