* cell sense_fill_clip
.SUBCKT sense_fill_clip
* net 2 FILL_L50_0
* net 3 FILL_L50_1
* net 4 FILL_L8_3
* net 5 FILL_L10_1
* net 6 FILL_L10_0
* net 7 FILL_L8_0
* net 8 FILL_L30_0
* net 9 FILL_L67_0
* net 10 FILL_L8_1
* net 11 FILL_L8_4
* net 12 FILL_L67_1
* net 13 FILL_L30_1
* net 14 FILL_L8_2
* net 15 FILL_L8_5
* net 16 FILL_L30_2
* net 17 FILL_L67_2
* net 18 FILL_L67_3
* net 19 CTX_L8_2
* net 20 CTX_L8_3
* net 21 CTX_L8_0
* net 22 CTX_L8_1
* net 23 CTX_L126_0
* net 24 FILL_L50_2
* net 25 FILL_L30_3
* net 26 FILL_L67_4
* net 27 CTX_L50_0
* net 28 CTX_L50_1
* net 29 CTX_L50_2
* net 30 CTX_L50_3
* net 31 CTX_L50_4
* net 32 CTX_L50_5
* net 33 CTX_L10_0
* net 34 CTX_L50_6
* net 35 FILL_L30_4
* net 36 FILL_L67_5
* net 37 CTX_L50_7
* net 38 CTX_L126_1
* net 39 CTX_L50_8
* net 40 CTX_L50_9
* net 41 CTX_L10_1
* net 42 CTX_L50_10
* net 43 CTX_L50_11
* net 44 N
* net 45 P
* net 46 CTX_L50_12
* net 47 CTX_L10_4
* net 48 CTX_L50_13
* net 49 CTX_L50_14
* net 50 CTX_L50_15
* net 51 FILL_L67_6
* net 52 FILL_L30_5
* net 53 CTX_L50_16
* net 54 CTX_L10_5
* net 55 CTX_L50_17
* net 56 CTX_L50_18
* net 57 CTX_L10_6
* net 58 CTX_L126_2
* net 59 CTX_L50_19
* net 60 CTX_L50_20
* net 61 CTX_L8_12
* net 62 CTX_L50_21
* net 63 FILL_L67_7
* net 64 CTX_L8_13
* net 65 CTX_L8_5
* net 66 CTX_L8_4
* net 67 FILL_L50_5
* net 68 FILL_L50_3
* net 69 FILL_L50_6
* net 70 FILL_L50_4
* net 71 FILL_L10_3
* net 72 FILL_L10_2
* net 73 FILL_L8_6
* net 74 FILL_L8_9
* net 75 FILL_L10_4
* net 76 FILL_L8_12
* net 77 FILL_L30_6
* net 78 FILL_L67_8
* net 79 FILL_L30_9
* net 80 FILL_L67_12
* net 81 FILL_L8_7
* net 82 FILL_L8_10
* net 83 FILL_L8_13
* net 84 FILL_L30_7
* net 85 FILL_L67_9
* net 86 FILL_L67_13
* net 87 FILL_L30_10
* net 88 FILL_L8_8
* net 89 FILL_L8_11
* net 90 FILL_L8_14
* net 91 CTX_L134_0
* net 92 FILL_L30_8
* net 93 FILL_L30_11
* net 94 FILL_L67_10
* net 95 FILL_L67_14
* net 96 FILL_L67_15
* net 97 FILL_L67_11
* net 98 CTX_L8_11
* net 99 CTX_L8_10
* net 100 CTX_L8_9
* net 101 CTX_L8_6
* net 102 CTX_L8_7
* net 103 CTX_L8_8
.ENDS sense_fill_clip
