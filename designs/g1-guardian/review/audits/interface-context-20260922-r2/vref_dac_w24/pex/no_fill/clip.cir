* cell sense_fill_clip
.SUBCKT sense_fill_clip
* net 1 CTX_L8_0
* net 2 CTX_L8_1
* net 3 CTX_L8_2
* net 4 CTX_L8_3
* net 5 CTX_L8_4
* net 6 CTX_L8_5
* net 7 CTX_L8_6
* net 8 CTX_L8_7
* net 9 CTX_L8_8
* net 10 CTX_L8_9
* net 11 CTX_L8_10
* net 12 CTX_L8_11
* net 13 CTX_L8_12
* net 14 CTX_L8_13
* net 15 CTX_L10_0
* net 16 CTX_L10_1
* net 17 N
* net 18 P
* net 19 CTX_L10_4
* net 20 CTX_L10_5
* net 21 CTX_L10_6
* net 22 CTX_L50_0
* net 23 CTX_L50_1
* net 24 CTX_L50_2
* net 25 CTX_L50_3
* net 26 CTX_L50_4
* net 27 CTX_L50_5
* net 28 CTX_L50_6
* net 29 CTX_L50_7
* net 30 CTX_L50_8
* net 31 CTX_L50_9
* net 32 CTX_L50_10
* net 33 CTX_L50_11
* net 34 CTX_L50_12
* net 35 CTX_L50_13
* net 36 CTX_L50_14
* net 37 CTX_L50_15
* net 38 CTX_L50_16
* net 39 CTX_L50_17
* net 40 CTX_L50_18
* net 41 CTX_L50_19
* net 42 CTX_L50_20
* net 43 CTX_L50_21
* net 44 CTX_L126_0
* net 45 CTX_L126_1
* net 46 CTX_L126_2
* net 47 CTX_L134_0
.ENDS sense_fill_clip
