* actual_fill floating drive P; diagnostic capacitor-network AC only
C13 0 FILL_L10_0 2.5620300000000002e-17
C14 0 FILL_L10_1 4.0211200000000004e-17
C15 0 FILL_L10_2 4.0211200000000004e-17
C16 0 FILL_L10_3 4.0211200000000004e-17
C17 0 FILL_L10_4 1.4590900000000001e-17
C18 0 FILL_L30_0 6.8914300000000002e-18
C19 0 FILL_L30_1 2.94669e-16
C20 0 FILL_L30_10 9.7463100000000006e-17
C21 0 FILL_L30_3 6.8914300000000002e-18
C22 0 FILL_L30_4 2.9761000000000002e-16
C23 0 FILL_L30_6 5.65095e-18
C24 0 FILL_L30_7 2.9761000000000002e-16
C25 0 FILL_L30_9 1.00647e-18
C26 0 FILL_L8_1 2.0255600000000004e-16
C27 0 FILL_L8_10 3.1992300000000003e-16
C28 0 FILL_L8_11 4.4157700000000008e-18
C29 0 FILL_L8_13 1.1736700000000002e-16
C30 0 FILL_L8_14 1.6022900000000002e-18
C31 0 FILL_L8_2 2.8134800000000002e-18
C32 0 FILL_L8_4 3.1992300000000003e-16
C33 0 FILL_L8_5 4.4157700000000008e-18
C34 0 FILL_L8_7 3.1992300000000003e-16
C35 0 FILL_L8_8 4.4157700000000008e-18
C44 0 FILL_L30_1 1.01523e-16
C45 0 FILL_L30_10 3.22335e-17
C46 0 FILL_L30_11 2.4169299999999998e-18
C47 0 FILL_L30_2 7.6123800000000002e-18
C48 0 FILL_L30_4 1.01523e-16
C49 0 FILL_L30_5 7.6123800000000002e-18
C50 0 FILL_L30_7 1.01523e-16
C51 0 FILL_L30_8 7.6123800000000002e-18
C52 0 FILL_L8_1 9.8309200000000016e-18
C53 0 FILL_L8_10 1.54297e-17
C54 0 FILL_L8_11 2.14778e-16
C55 0 FILL_L8_13 5.5987800000000003e-18
C56 0 FILL_L8_14 7.9214500000000012e-17
C57 0 FILL_L8_2 1.35564e-16
C58 0 FILL_L8_4 1.54297e-17
C59 0 FILL_L8_5 2.14778e-16
C60 0 FILL_L8_7 1.54297e-17
C61 0 FILL_L8_8 2.14778e-16
C62 0 N 1.1274000000000001e-15
C71 0 FILL_L30_11 7.7862100000000001e-17
C72 0 FILL_L30_2 2.3293399999999999e-16
C73 0 FILL_L30_5 2.3587399999999999e-16
C74 0 FILL_L30_8 2.3587399999999999e-16
C75 0 FILL_L8_11 2.0315199999999999e-16
C76 0 FILL_L8_14 7.4995900000000009e-17
C77 0 FILL_L8_2 1.2815600000000003e-16
C78 0 FILL_L8_5 2.0315199999999999e-16
C79 0 FILL_L8_8 2.0315199999999999e-16
C80 0 P 3.3182999999999999e-15
C92 0 FILL_L30_11 8.6358500000000011e-17
C93 0 FILL_L30_2 2.5969400000000005e-16
C94 0 FILL_L30_5 2.6263500000000003e-16
C95 0 FILL_L30_8 2.6263500000000003e-16
C96 0 FILL_L8_11 1.7880700000000001e-17
C97 0 FILL_L8_14 6.4881300000000002e-18
C98 0 FILL_L8_2 1.1392500000000002e-17
C99 0 FILL_L8_5 1.7880700000000001e-17
C100 0 FILL_L8_8 1.7880700000000001e-17
C123 0 FILL_L30_11 2.5767100000000002e-17
C124 0 FILL_L30_2 8.1156400000000016e-17
C125 0 FILL_L30_5 8.1080500000000012e-17
C126 0 FILL_L30_8 8.1156400000000016e-17
C127 0 FILL_L8_11 1.2881900000000001e-18
C128 0 FILL_L8_14 4.6743e-19
C129 0 FILL_L8_2 8.2076300000000005e-19
C130 0 FILL_L8_5 1.2881900000000001e-18
C131 0 FILL_L8_8 1.2881900000000001e-18
C141 0 FILL_L10_0 2.0210300000000001e-17
C142 0 FILL_L10_1 5.3874000000000008e-17
C143 0 FILL_L10_2 4.1288900000000002e-17
C144 0 FILL_L10_3 1.6457000000000001e-17
C145 0 FILL_L10_4 1.8482400000000004e-18
C146 0 FILL_L30_0 1.21425e-16
C147 0 FILL_L30_1 2.0736700000000002e-17
C148 0 FILL_L30_10 6.5838900000000003e-18
C149 0 FILL_L30_3 1.2288500000000002e-16
C150 0 FILL_L30_4 2.0736700000000002e-17
C151 0 FILL_L30_6 1.2288500000000002e-16
C152 0 FILL_L30_7 2.0736700000000002e-17
C153 0 FILL_L30_9 3.57534e-17
C154 0 FILL_L50_0 2.45507e-17
C155 0 FILL_L50_1 2.6939900000000003e-17
C156 0 FILL_L50_2 2.6939900000000003e-17
C157 0 FILL_L50_3 2.6939900000000003e-17
C158 0 FILL_L50_4 2.6939900000000003e-17
C159 0 FILL_L50_5 2.6939900000000003e-17
C160 0 FILL_L50_6 2.3484400000000001e-17
C161 0 FILL_L8_0 6.9447200000000004e-19
C162 0 FILL_L8_1 9.9478799999999998e-18
C163 0 FILL_L8_10 1.1880900000000001e-17
C164 0 FILL_L8_12 1.00891e-18
C165 0 FILL_L8_13 3.2624300000000004e-18
C166 0 FILL_L8_3 1.0899800000000001e-18
C167 0 FILL_L8_4 2.05508e-17
C168 0 FILL_L8_6 1.2973100000000001e-18
C169 0 FILL_L8_7 1.7660900000000004e-17
C170 0 FILL_L8_9 1.9043100000000001e-18
C192 0 FILL_L10_0 5.8429599999999999e-18
C193 0 FILL_L10_1 1.60081e-17
C194 0 FILL_L10_2 1.2006100000000001e-17
C195 0 FILL_L10_3 4.0020300000000007e-18
C196 0 FILL_L30_0 3.2677e-17
C197 0 FILL_L30_1 1.5080600000000003e-16
C198 0 FILL_L30_10 5.2054400000000006e-17
C199 0 FILL_L30_11 2.19664e-17
C200 0 FILL_L30_2 6.91856e-17
C201 0 FILL_L30_3 3.2677e-17
C202 0 FILL_L30_4 1.55367e-16
C203 0 FILL_L30_5 6.91856e-17
C204 0 FILL_L30_6 3.2677e-17
C205 0 FILL_L30_7 1.55367e-16
C206 0 FILL_L30_8 6.91856e-17
C207 0 FILL_L30_9 1.02915e-17
C208 0 FILL_L8_1 1.6775400000000001e-17
C209 0 FILL_L8_10 1.7794900000000001e-17
C210 0 FILL_L8_11 3.0949000000000004e-17
C211 0 FILL_L8_13 4.0592100000000005e-18
C212 0 FILL_L8_14 1.02099e-17
C213 0 FILL_L8_2 2.2219000000000002e-17
C214 0 FILL_L8_4 3.7619100000000003e-17
C215 0 FILL_L8_5 4.0600400000000005e-17
C216 0 FILL_L8_7 3.1011000000000002e-17
C217 0 FILL_L8_8 3.73833e-17
C218 0 P 2.0104e-17
C248 0 FILL_L30_11 3.8204000000000004e-17
C249 0 FILL_L30_2 1.1691000000000001e-16
C250 0 FILL_L30_5 1.18065e-16
C251 0 FILL_L30_8 1.17943e-16
C252 0 FILL_L8_11 1.9735600000000002e-17
C253 0 FILL_L8_14 6.2318000000000002e-18
C254 0 FILL_L8_2 1.4682000000000002e-17
C255 0 FILL_L8_5 2.7419600000000002e-17
C256 0 FILL_L8_8 2.4858200000000002e-17
C257 0 P 1.49205e-17
C287 0 FILL_L10_2 1.1255000000000002e-17
C288 0 FILL_L10_3 7.2414800000000001e-18
C289 0 FILL_L10_4 9.4386899999999996e-19
C290 0 FILL_L30_10 1.6670400000000003e-17
C291 0 FILL_L30_11 2.2276300000000002e-17
C292 0 FILL_L30_6 5.3272600000000001e-17
C293 0 FILL_L30_7 4.0365000000000004e-17
C294 0 FILL_L30_8 4.3078600000000007e-17
C295 0 FILL_L30_9 1.9303599999999999e-17
C296 0 FILL_L50_4 2.5921599999999998e-18
C297 0 FILL_L50_5 3.3323500000000002e-18
C298 0 FILL_L50_6 6.5983400000000011e-18
C299 0 FILL_L8_10 1.2847700000000001e-17
C300 0 FILL_L8_11 1.4019500000000002e-17
C301 0 FILL_L8_12 2.4268600000000001e-19
C302 0 FILL_L8_13 3.0413400000000003e-18
C303 0 FILL_L8_14 4.4735500000000004e-18
C304 0 FILL_L8_7 8.9098699999999999e-18
C305 0 FILL_L8_8 5.9874300000000002e-18
C306 0 N 6.714630000000001e-19
C307 0 P 5.3452400000000011e-18
C310 0 FILL_L10_0 2.0124000000000002e-17
C311 0 FILL_L10_1 5.5134100000000003e-17
C312 0 FILL_L10_2 4.1350600000000006e-17
C313 0 FILL_L10_3 1.3783500000000001e-17
C314 0 FILL_L30_0 2.5500200000000004e-16
C315 0 FILL_L30_3 2.5737800000000002e-16
C316 0 FILL_L30_6 2.5737800000000002e-16
C317 0 FILL_L30_9 8.3277200000000006e-17
C318 0 FILL_L50_0 1.8048800000000002e-17
C319 0 FILL_L50_1 1.8048800000000002e-17
C320 0 FILL_L50_2 1.8048800000000002e-17
C321 0 FILL_L50_3 1.8048800000000002e-17
C322 0 FILL_L50_4 1.8048800000000002e-17
C323 0 FILL_L50_5 1.8048800000000002e-17
C324 0 FILL_L50_6 1.8048800000000002e-17
C325 0 FILL_L8_0 4.3552800000000002e-19
C326 0 FILL_L8_1 3.9776400000000001e-19
C327 0 FILL_L8_10 2.7244100000000001e-19
C328 0 FILL_L8_3 1.1932300000000001e-18
C329 0 FILL_L8_4 1.08976e-18
C330 0 FILL_L8_6 8.949200000000002e-19
C331 0 FILL_L8_7 8.1732300000000011e-19
C332 0 FILL_L8_9 2.9830700000000003e-19
C335 0 FILL_L10_0 3.0798500000000002e-18
C336 0 FILL_L10_1 4.8338400000000009e-18
C337 0 FILL_L10_2 4.8338400000000009e-18
C338 0 FILL_L10_3 4.8338400000000009e-18
C339 0 FILL_L10_4 1.7539899999999999e-18
C340 0 FILL_L30_0 3.4239300000000005e-17
C341 0 FILL_L30_1 4.7835400000000005e-18
C342 0 FILL_L30_10 1.51877e-18
C343 0 FILL_L30_3 3.4239300000000005e-17
C344 0 FILL_L30_4 4.7835400000000005e-18
C345 0 FILL_L30_6 3.4239300000000005e-17
C346 0 FILL_L30_7 4.7835400000000005e-18
C347 0 FILL_L30_9 1.0871000000000002e-17
C348 0 FILL_L8_0 1.2756300000000002e-18
C349 0 FILL_L8_1 1.2957600000000001e-18
C350 0 FILL_L8_10 2.0337100000000003e-18
C351 0 FILL_L8_12 7.26478e-19
C352 0 FILL_L8_13 7.3794600000000002e-19
C353 0 FILL_L8_3 2.0021000000000003e-18
C354 0 FILL_L8_4 2.0337100000000003e-18
C355 0 FILL_L8_6 2.0021000000000003e-18
C356 0 FILL_L8_7 2.0337100000000003e-18
C357 0 FILL_L8_9 2.0021000000000003e-18
C362 0 FILL_L30_1 9.8875000000000007e-18
C363 0 FILL_L30_10 3.1392800000000001e-18
C364 0 FILL_L30_11 3.4799600000000002e-18
C365 0 FILL_L30_2 1.0960500000000001e-17
C366 0 FILL_L30_4 9.8875000000000007e-18
C367 0 FILL_L30_5 1.0960500000000001e-17
C368 0 FILL_L30_7 9.8875000000000007e-18
C369 0 FILL_L30_8 1.0960500000000001e-17
C370 0 FILL_L8_11 2.6760900000000001e-17
C371 0 FILL_L8_14 9.9449799999999996e-18
C372 0 FILL_L8_2 1.68159e-17
C373 0 FILL_L8_5 2.6760900000000001e-17
C374 0 FILL_L8_8 2.6760900000000001e-17
C375 0 N 3.0638300000000001e-17
C378 0 FILL_L30_1 5.6403900000000007e-18
C379 0 FILL_L30_10 1.7908200000000004e-18
C380 0 FILL_L30_11 2.03163e-17
C381 0 FILL_L30_2 6.3988200000000009e-17
C382 0 FILL_L30_4 5.6403900000000007e-18
C383 0 FILL_L30_5 6.3988200000000009e-17
C384 0 FILL_L30_7 5.6403900000000007e-18
C385 0 FILL_L30_8 6.3988200000000009e-17
C386 0 FILL_L8_11 1.6337900000000003e-17
C387 0 FILL_L8_14 5.5433000000000004e-18
C388 0 FILL_L8_2 1.1282800000000001e-17
C389 0 FILL_L8_5 1.9521400000000002e-17
C390 0 FILL_L8_8 1.8460200000000003e-17
C391 0 N 9.2488000000000003e-17
C392 0 P 3.3449700000000005e-17
C395 0 FILL_L30_11 5.9081900000000006e-17
C396 0 FILL_L30_2 1.7614700000000001e-16
C397 0 FILL_L30_5 1.7852300000000002e-16
C398 0 FILL_L30_8 1.7852300000000002e-16
C399 0 FILL_L8_11 9.6103600000000004e-18
C400 0 FILL_L8_14 2.6952900000000001e-18
C401 0 FILL_L8_2 7.9189800000000013e-18
C402 0 FILL_L8_5 1.6157600000000001e-17
C403 0 FILL_L8_8 1.3975199999999999e-17
C404 0 P 3.3189300000000006e-17
C408 0 FILL_L30_11 5.4302600000000003e-17
C409 0 FILL_L30_2 1.6109400000000002e-16
C410 0 FILL_L30_5 1.6347000000000002e-16
C411 0 FILL_L30_8 1.6347000000000002e-16
C412 0 FILL_L8_11 4.7020900000000001e-18
C413 0 FILL_L8_14 8.5533600000000003e-19
C414 0 FILL_L8_2 5.2247600000000004e-18
C415 0 FILL_L8_5 1.4314400000000001e-17
C416 0 FILL_L8_8 1.1034900000000001e-17
C420 0 FILL_L30_11 5.4302600000000003e-17
C421 0 FILL_L30_2 1.6109400000000002e-16
C422 0 FILL_L30_5 1.6347000000000002e-16
C423 0 FILL_L30_8 1.6347000000000002e-16
C424 0 FILL_L8_11 3.1069500000000003e-18
C425 0 FILL_L8_14 6.842690000000001e-19
C426 0 FILL_L8_2 3.2239100000000004e-18
C427 0 FILL_L8_5 9.0734900000000006e-18
C428 0 FILL_L8_8 7.04443e-18
C432 0 FILL_L30_11 5.4302600000000003e-17
C433 0 FILL_L30_2 1.6109400000000002e-16
C434 0 FILL_L30_5 1.6347000000000002e-16
C435 0 FILL_L30_8 1.6347000000000002e-16
C436 0 FILL_L8_11 2.96913e-19
C437 0 FILL_L8_2 4.3349300000000004e-19
C438 0 FILL_L8_5 1.1876500000000002e-18
C439 0 FILL_L8_8 8.9074000000000012e-19
C443 0 FILL_L30_11 8.283950000000001e-17
C444 0 FILL_L30_2 2.5097399999999998e-16
C445 0 FILL_L30_5 2.5335000000000001e-16
C446 0 FILL_L30_8 2.5335000000000001e-16
C447 0 FILL_L8_11 2.8313200000000004e-19
C448 0 FILL_L8_2 4.1337200000000004e-19
C449 0 FILL_L8_5 1.1325300000000001e-18
C450 0 FILL_L8_8 8.4939500000000011e-19
C454 0 FILL_L30_11 7.0940899999999998e-17
C455 0 FILL_L30_2 2.1349800000000001e-16
C456 0 FILL_L30_5 2.1584700000000002e-16
C457 0 FILL_L30_8 2.1587400000000001e-16
C458 0 FILL_L8_11 2.1099500000000001e-19
C459 0 FILL_L8_2 3.0805200000000001e-19
C460 0 FILL_L8_5 8.4397900000000014e-19
C461 0 FILL_L8_8 6.3298400000000003e-19
C464 0 FILL_L30_11 1.0871000000000002e-17
C465 0 FILL_L30_2 3.4239300000000005e-17
C466 0 FILL_L30_5 3.4177999999999998e-17
C467 0 FILL_L30_8 3.4239300000000005e-17
C471 0 FILL_L30_11 4.3003999999999999e-18
C472 0 FILL_L30_2 1.3544600000000001e-17
C473 0 FILL_L30_5 1.3510700000000002e-17
C474 0 FILL_L30_8 1.3544600000000001e-17
C475 0 FILL_L8_11 1.13984e-18
C476 0 FILL_L8_14 4.1360000000000006e-19
C477 0 FILL_L8_2 7.2624300000000003e-19
C478 0 FILL_L8_5 1.13984e-18
C479 0 FILL_L8_8 1.13984e-18
C482 0 FILL_L10_0 2.58843e-18
C483 0 FILL_L10_1 4.0625600000000005e-18
C484 0 FILL_L10_2 4.0625600000000005e-18
C485 0 FILL_L10_3 4.0625600000000005e-18
C486 0 FILL_L10_4 1.4741300000000001e-18
C487 0 FILL_L30_0 1.3544600000000001e-17
C488 0 FILL_L30_1 8.1080500000000005e-18
C489 0 FILL_L30_10 2.5743000000000002e-18
C490 0 FILL_L30_3 1.3544600000000001e-17
C491 0 FILL_L30_4 8.1080500000000005e-18
C492 0 FILL_L30_6 1.3544600000000001e-17
C493 0 FILL_L30_7 8.1080500000000005e-18
C494 0 FILL_L30_9 4.3003999999999999e-18
C495 0 FILL_L8_0 1.1862800000000001e-18
C496 0 FILL_L8_1 4.4638000000000001e-18
C497 0 FILL_L8_10 7.0059600000000006e-18
C498 0 FILL_L8_12 6.7559600000000002e-19
C499 0 FILL_L8_13 2.5421600000000001e-18
C500 0 FILL_L8_3 1.8618800000000002e-18
C501 0 FILL_L8_4 7.0059600000000006e-18
C502 0 FILL_L8_6 1.8618800000000002e-18
C503 0 FILL_L8_7 7.0059600000000006e-18
C504 0 FILL_L8_9 1.8618800000000002e-18
C508 0 FILL_L30_11 1.40411e-18
C509 0 FILL_L30_2 4.422380000000001e-18
C510 0 FILL_L30_5 4.4113300000000005e-18
C511 0 FILL_L30_8 4.3671000000000004e-18
C512 0 FILL_L8_11 2.2876700000000002e-19
C513 0 FILL_L8_2 1.1438300000000001e-19
C514 0 FILL_L8_5 1.5251100000000003e-19
C515 0 FILL_L8_8 2.6689400000000004e-19
C531 0 FILL_L30_11 4.0708499999999999e-19
C532 0 FILL_L30_2 1.4938900000000001e-18
C533 0 FILL_L30_5 1.4901600000000001e-18
C534 0 FILL_L30_8 1.4752200000000001e-18
C537 0 FILL_L10_0 2.1010900000000002e-18
C538 0 FILL_L10_1 3.2976800000000003e-18
C539 0 FILL_L10_2 3.2976800000000003e-18
C540 0 FILL_L10_3 3.2976800000000003e-18
C541 0 FILL_L10_4 1.1965900000000001e-18
C542 0 FILL_L30_0 7.3730700000000005e-18
C543 0 FILL_L30_1 1.5077100000000001e-17
C544 0 FILL_L30_10 4.7869700000000008e-18
C545 0 FILL_L30_3 7.3730700000000005e-18
C546 0 FILL_L30_4 1.5077100000000001e-17
C547 0 FILL_L30_6 7.3730700000000005e-18
C548 0 FILL_L30_7 1.5077100000000001e-17
C549 0 FILL_L30_9 2.3409499999999999e-18
C550 0 FILL_L8_1 1.5081500000000001e-17
C551 0 FILL_L8_10 2.4038700000000001e-17
C552 0 FILL_L8_13 8.9572299999999996e-18
C553 0 FILL_L8_4 2.4038700000000001e-17
C554 0 FILL_L8_7 2.4038700000000001e-17
C557 0 FILL_L10_0 1.6848300000000003e-18
C558 0 FILL_L10_1 2.6443500000000005e-18
C559 0 FILL_L10_2 2.6443500000000005e-18
C560 0 FILL_L10_3 2.6443500000000005e-18
C561 0 FILL_L10_4 9.5952200000000002e-19
C562 0 FILL_L30_0 4.422380000000001e-18
C563 0 FILL_L30_1 4.96112e-17
C564 0 FILL_L30_10 1.5751600000000002e-17
C565 0 FILL_L30_3 4.422380000000001e-18
C566 0 FILL_L30_4 4.96112e-17
C567 0 FILL_L30_6 4.422380000000001e-18
C568 0 FILL_L30_7 4.96112e-17
C569 0 FILL_L30_9 1.40411e-18
C570 0 FILL_L8_1 1.5181599999999999e-17
C571 0 FILL_L8_10 2.3492300000000002e-17
C572 0 FILL_L8_13 8.5612700000000016e-18
C573 0 FILL_L8_4 2.5126600000000003e-17
C574 0 FILL_L8_7 2.4581800000000003e-17
C577 0 FILL_L10_0 4.4290600000000003e-19
C578 0 FILL_L10_1 1.2134400000000001e-18
C579 0 FILL_L10_2 9.100810000000001e-19
C580 0 FILL_L10_3 3.0336000000000004e-19
C581 0 FILL_L30_1 2.2764899999999999e-16
C582 0 FILL_L30_10 7.5433700000000012e-17
C583 0 FILL_L30_4 2.3002400000000001e-16
C584 0 FILL_L30_7 2.3002400000000001e-16
C585 0 FILL_L8_1 1.0993900000000001e-17
C586 0 FILL_L8_10 1.0802800000000001e-17
C587 0 FILL_L8_13 2.2390500000000004e-18
C588 0 FILL_L8_4 2.7277200000000002e-17
C589 0 FILL_L8_7 2.1710400000000001e-17
C592 0 FILL_L30_1 3.0944200000000004e-16
C593 0 FILL_L30_10 1.0140300000000001e-16
C594 0 FILL_L30_4 3.1181700000000005e-16
C595 0 FILL_L30_7 3.1181700000000005e-16
C596 0 FILL_L8_1 1.1768100000000001e-17
C597 0 FILL_L8_10 9.1838200000000014e-18
C598 0 FILL_L8_13 8.5533600000000003e-19
C599 0 FILL_L8_4 3.2241300000000007e-17
C600 0 FILL_L8_7 2.4480100000000003e-17
C603 0 FILL_L30_1 3.0944200000000004e-16
C604 0 FILL_L30_10 1.0140300000000001e-16
C605 0 FILL_L30_4 3.1181700000000005e-16
C606 0 FILL_L30_7 3.1181700000000005e-16
C607 0 FILL_L8_1 4.4804500000000007e-18
C608 0 FILL_L8_10 3.0688000000000002e-18
C609 0 FILL_L8_11 2.6309200000000002e-19
C610 0 FILL_L8_2 3.8411500000000004e-19
C611 0 FILL_L8_4 1.2275200000000001e-17
C612 0 FILL_L8_5 1.0523700000000001e-18
C613 0 FILL_L8_7 9.2064100000000003e-18
C614 0 FILL_L8_8 7.8927700000000007e-19
C618 0 FILL_L30_1 1.7031800000000001e-16
C619 0 FILL_L30_10 5.4391500000000002e-17
C620 0 FILL_L30_11 1.0974600000000002e-18
C621 0 FILL_L30_2 3.4565600000000004e-18
C622 0 FILL_L30_4 1.7055600000000003e-16
C623 0 FILL_L30_5 3.4565600000000004e-18
C624 0 FILL_L30_7 1.7055600000000003e-16
C625 0 FILL_L30_8 3.4565600000000004e-18
C626 0 FILL_L8_11 1.7974100000000001e-17
C627 0 FILL_L8_14 6.7331700000000005e-18
C628 0 FILL_L8_2 1.12409e-17
C629 0 FILL_L8_4 1.02657e-19
C630 0 FILL_L8_5 1.8094500000000002e-17
C631 0 FILL_L8_8 1.7974100000000001e-17
C633 0 FILL_L30_1 1.8617000000000002e-17
C634 0 FILL_L30_10 5.9108900000000009e-18
C635 0 FILL_L30_11 1.9525399999999999e-18
C636 0 FILL_L30_2 6.1497500000000007e-18
C637 0 FILL_L30_4 1.8617000000000002e-17
C638 0 FILL_L30_5 6.1497500000000007e-18
C639 0 FILL_L30_7 1.8617000000000002e-17
C640 0 FILL_L30_8 6.1497500000000007e-18
C641 0 FILL_L8_11 1.5276800000000002e-17
C642 0 FILL_L8_14 5.5433000000000004e-18
C643 0 FILL_L8_2 9.7335100000000011e-18
C644 0 FILL_L8_5 1.5276800000000002e-17
C645 0 FILL_L8_8 1.5276800000000002e-17
C652 0 FILL_L30_2 2.2978700000000001e-19
C659 0 FILL_L30_11 2.2978700000000001e-19
C662 0 FILL_L30_1 1.8274000000000002e-19
C663 0 FILL_L30_11 8.9573800000000019e-18
C664 0 FILL_L30_2 3.0059499999999999e-17
C665 0 FILL_L30_4 1.8274000000000002e-19
C666 0 FILL_L30_5 3.0039800000000003e-17
C667 0 FILL_L30_7 1.2182600000000002e-19
C668 0 FILL_L30_8 2.9345400000000001e-17
C669 0 FILL_L8_11 2.4158700000000001e-17
C670 0 FILL_L8_14 8.7661400000000004e-18
C671 0 FILL_L8_2 1.5392500000000002e-17
C672 0 FILL_L8_5 2.4158700000000001e-17
C673 0 FILL_L8_8 2.4158700000000001e-17
C674 0 N 3.6098100000000003e-19
C675 0 P 4.2307500000000001e-19
C685 0 FILL_L30_11 5.2142900000000007e-19
C686 0 FILL_L30_2 1.9135000000000003e-18
C687 0 FILL_L30_5 1.90872e-18
C688 0 FILL_L30_8 1.8895800000000001e-18
C691 0 FILL_L30_2 2.2978700000000001e-19
C696 0 FILL_L30_5 2.2978700000000001e-19
C699 0 FILL_L30_5 2.2978700000000001e-19
C706 0 FILL_L30_8 2.2978700000000001e-19
C708 0 FILL_L30_8 2.2978700000000001e-19
C710 FILL_L10_0 FILL_L10_1 9.7773300000000019e-17
C711 FILL_L10_0 FILL_L30_0 5.6317700000000006e-16
C712 FILL_L10_0 FILL_L30_1 3.1998100000000002e-18
C713 FILL_L10_0 FILL_L50_0 9.0523000000000007e-18
C714 FILL_L10_0 FILL_L8_0 5.2469100000000007e-16
C715 FILL_L10_0 FILL_L8_1 1.91785e-17
C716 FILL_L10_0 0 2.7970700000000001e-16
C717 FILL_L10_1 FILL_L10_2 9.7773300000000019e-17
C718 FILL_L10_1 FILL_L30_0 4.8960399999999998e-16
C719 FILL_L10_1 FILL_L30_1 2.1332000000000003e-18
C720 FILL_L10_1 FILL_L30_3 3.6457100000000004e-16
C721 FILL_L10_1 FILL_L30_4 1.0666000000000002e-18
C722 FILL_L10_1 FILL_L50_1 2.0753100000000001e-17
C723 FILL_L10_1 FILL_L50_2 2.0753100000000001e-17
C724 FILL_L10_1 FILL_L8_3 8.2350600000000007e-16
C725 FILL_L10_1 FILL_L8_4 3.0100800000000002e-17
C726 FILL_L10_1 0 2.6896499999999997e-16
C727 FILL_L10_2 FILL_L10_3 9.7773300000000019e-17
C728 FILL_L10_2 FILL_L30_3 7.2743800000000001e-16
C729 FILL_L10_2 FILL_L30_4 4.2664099999999996e-18
C730 FILL_L10_2 FILL_L30_6 1.1839000000000001e-16
C731 FILL_L10_2 FILL_L50_3 1.6862300000000003e-17
C732 FILL_L10_2 FILL_L50_4 1.4435200000000002e-17
C733 FILL_L10_2 FILL_L8_6 8.2350600000000007e-16
C734 FILL_L10_2 FILL_L8_7 3.0100800000000002e-17
C735 FILL_L10_2 0 2.6896499999999997e-16
C736 FILL_L10_3 FILL_L10_4 9.7773300000000019e-17
C737 FILL_L10_3 FILL_L30_6 9.0101000000000002e-16
C738 FILL_L10_3 FILL_L30_7 6.3996100000000007e-18
C739 FILL_L10_3 FILL_L30_9 1.2232300000000001e-17
C740 FILL_L10_3 FILL_L50_5 6.3179400000000006e-18
C741 FILL_L10_3 FILL_L50_6 3.8908000000000001e-18
C742 FILL_L10_3 FILL_L8_10 3.0100800000000002e-17
C743 FILL_L10_3 FILL_L8_9 8.2350600000000007e-16
C744 FILL_L10_3 0 2.6896499999999997e-16
C745 FILL_L10_4 FILL_L30_10 2.7091700000000002e-18
C746 FILL_L10_4 FILL_L30_9 3.1758400000000004e-16
C747 FILL_L10_4 FILL_L8_12 2.9881500000000001e-16
C748 FILL_L10_4 FILL_L8_13 1.0922300000000001e-17
C749 FILL_L10_4 0 2.3284400000000002e-16
C750 FILL_L30_0 FILL_L30_1 7.7092600000000011e-17
C751 FILL_L30_0 FILL_L30_3 7.7092600000000011e-17
C752 FILL_L30_0 FILL_L50_0 1.51697e-16
C753 FILL_L30_0 FILL_L50_1 1.51697e-16
C754 FILL_L30_0 FILL_L8_0 3.2704500000000003e-17
C755 FILL_L30_0 FILL_L8_1 1.6757899999999999e-17
C756 FILL_L30_0 FILL_L8_3 3.11962e-17
C757 FILL_L30_0 FILL_L8_4 1.1171900000000001e-17
C758 FILL_L30_0 0 3.6299700000000003e-16
C759 FILL_L30_1 FILL_L30_2 7.7092600000000011e-17
C760 FILL_L30_1 FILL_L30_4 7.7092600000000011e-17
C761 FILL_L30_1 FILL_L8_1 1.4997300000000003e-16
C762 FILL_L30_1 FILL_L8_2 3.6390300000000006e-17
C763 FILL_L30_1 FILL_L8_4 1.40634e-16
C764 FILL_L30_1 FILL_L8_5 2.4260200000000003e-17
C765 FILL_L30_1 N 6.9818800000000003e-18
C766 FILL_L30_1 P 2.2902200000000002e-18
C767 FILL_L30_1 0 2.9470400000000001e-16
C768 FILL_L30_10 FILL_L30_11 2.4476900000000003e-17
C769 FILL_L30_10 FILL_L30_7 7.7092600000000011e-17
C770 FILL_L30_10 FILL_L30_9 2.4476900000000003e-17
C771 FILL_L30_10 FILL_L8_10 9.1148399999999992e-18
C772 FILL_L30_10 FILL_L8_13 9.3343599999999997e-17
C773 FILL_L30_10 FILL_L8_14 3.0810400000000004e-17
C774 FILL_L30_10 N 2.2167500000000005e-18
C775 FILL_L30_10 P 7.2714500000000005e-19
C776 FILL_L30_10 0 1.9812799999999999e-16
C777 FILL_L30_11 FILL_L30_8 7.7092600000000011e-17
C778 FILL_L30_11 FILL_L8_11 4.7555700000000003e-18
C779 FILL_L30_11 FILL_L8_14 6.8512e-17
C780 FILL_L30_11 N 8.0857200000000011e-18
C781 FILL_L30_11 P 2.9714800000000005e-17
C782 FILL_L30_11 0 2.36888e-16
C783 FILL_L30_2 FILL_L30_5 7.7092600000000011e-17
C784 FILL_L30_2 FILL_L8_2 1.01646e-16
C785 FILL_L30_2 FILL_L8_5 8.8973700000000006e-17
C786 FILL_L30_2 N 2.5466800000000001e-17
C787 FILL_L30_2 P 8.7439400000000006e-17
C788 FILL_L30_2 0 4.0332300000000002e-16
C789 FILL_L30_3 FILL_L30_4 7.7092600000000011e-17
C790 FILL_L30_3 FILL_L30_6 7.7092600000000011e-17
C791 FILL_L30_3 FILL_L50_2 1.51697e-16
C792 FILL_L30_3 FILL_L50_3 1.51697e-16
C793 FILL_L30_3 FILL_L8_3 2.9687900000000004e-17
C794 FILL_L30_3 FILL_L8_4 5.5859600000000004e-18
C795 FILL_L30_3 FILL_L8_6 3.4212900000000001e-17
C796 FILL_L30_3 FILL_L8_7 2.2343800000000003e-17
C797 FILL_L30_3 0 2.7171100000000005e-16
C798 FILL_L30_4 FILL_L30_5 7.7092600000000011e-17
C799 FILL_L30_4 FILL_L30_7 7.7092600000000011e-17
C800 FILL_L30_4 FILL_L8_4 1.0388500000000001e-16
C801 FILL_L30_4 FILL_L8_5 1.2130100000000001e-17
C802 FILL_L30_4 FILL_L8_7 2.0501800000000002e-16
C803 FILL_L30_4 FILL_L8_8 4.8520400000000006e-17
C804 FILL_L30_4 N 6.9818800000000003e-18
C805 FILL_L30_4 P 2.2902200000000002e-18
C806 FILL_L30_4 0 2.0777800000000001e-16
C807 FILL_L30_5 FILL_L30_8 7.7092600000000011e-17
C808 FILL_L30_5 FILL_L8_5 6.2000500000000005e-17
C809 FILL_L30_5 FILL_L8_8 1.38165e-16
C810 FILL_L30_5 N 2.5466800000000001e-17
C811 FILL_L30_5 P 8.8909700000000004e-17
C812 FILL_L30_5 0 3.19327e-16
C813 FILL_L30_6 FILL_L30_7 7.7092600000000011e-17
C814 FILL_L30_6 FILL_L30_9 7.7092600000000011e-17
C815 FILL_L30_6 FILL_L50_4 1.51697e-16
C816 FILL_L30_6 FILL_L50_5 1.51697e-16
C817 FILL_L30_6 FILL_L8_10 3.3515799999999998e-17
C818 FILL_L30_6 FILL_L8_6 1.7621300000000003e-17
C819 FILL_L30_6 FILL_L8_9 2.9176600000000002e-17
C820 FILL_L30_6 0 2.8243299999999999e-16
C821 FILL_L30_7 FILL_L30_8 7.7092600000000011e-17
C822 FILL_L30_7 FILL_L8_10 2.4852400000000001e-16
C823 FILL_L30_7 FILL_L8_11 7.2780600000000012e-17
C824 FILL_L30_7 FILL_L8_7 4.5396500000000003e-17
C825 FILL_L30_7 N 6.9818800000000003e-18
C826 FILL_L30_7 P 2.2902200000000002e-18
C827 FILL_L30_7 0 2.0857900000000001e-16
C828 FILL_L30_8 FILL_L8_11 1.76462e-16
C829 FILL_L30_8 FILL_L8_8 2.36851e-17
C830 FILL_L30_8 N 2.5466800000000001e-17
C831 FILL_L30_8 P 8.8909700000000004e-17
C832 FILL_L30_8 0 3.1925099999999998e-16
C833 FILL_L30_9 FILL_L50_6 1.2265600000000001e-16
C834 FILL_L30_9 FILL_L8_12 3.8311500000000006e-18
C835 FILL_L30_9 FILL_L8_13 1.41883e-17
C836 FILL_L30_9 0 2.22631e-16
C837 FILL_L50_0 FILL_L50_1 2.4713600000000001e-17
C838 FILL_L50_0 0 5.4242100000000005e-17
C839 FILL_L50_1 FILL_L50_2 2.4713600000000001e-17
C840 FILL_L50_1 0 2.9086600000000004e-17
C841 FILL_L50_2 FILL_L50_3 2.4713600000000001e-17
C842 FILL_L50_2 0 2.9086600000000004e-17
C843 FILL_L50_3 FILL_L50_4 2.4713600000000001e-17
C844 FILL_L50_3 0 3.1551400000000003e-17
C845 FILL_L50_4 FILL_L50_5 2.4713600000000001e-17
C846 FILL_L50_4 0 3.1787099999999999e-17
C847 FILL_L50_5 FILL_L50_6 2.4713600000000001e-17
C848 FILL_L50_5 0 3.6786900000000006e-17
C849 FILL_L50_6 0 6.464810000000001e-17
C850 FILL_L8_0 FILL_L8_1 4.44068e-17
C851 FILL_L8_0 FILL_L8_3 6.96968e-17
C852 FILL_L8_0 0 6.3189900000000005e-16
C853 FILL_L8_1 FILL_L8_2 4.44068e-17
C854 FILL_L8_1 FILL_L8_4 6.96968e-17
C855 FILL_L8_1 0 5.949080000000001e-16
C856 FILL_L8_10 FILL_L8_11 6.96968e-17
C857 FILL_L8_10 FILL_L8_13 6.96968e-17
C858 FILL_L8_10 FILL_L8_7 6.96968e-17
C859 FILL_L8_10 FILL_L8_9 6.96968e-17
C860 FILL_L8_10 0 7.5091400000000008e-16
C861 FILL_L8_11 FILL_L8_14 6.96968e-17
C862 FILL_L8_11 FILL_L8_8 6.96968e-17
C863 FILL_L8_11 N 1.9203800000000003e-16
C864 FILL_L8_11 P 1.4087300000000001e-16
C865 FILL_L8_11 0 7.9409500000000004e-16
C866 FILL_L8_12 FILL_L8_13 2.529e-17
C867 FILL_L8_12 FILL_L8_9 6.96968e-17
C868 FILL_L8_12 0 4.5416699999999999e-16
C869 FILL_L8_13 FILL_L8_14 2.529e-17
C870 FILL_L8_13 0 4.3310100000000004e-16
C871 FILL_L8_14 N 7.0963100000000007e-17
C872 FILL_L8_14 P 5.2397399999999998e-17
C873 FILL_L8_14 0 4.4876900000000007e-16
C874 FILL_L8_2 FILL_L8_5 6.96968e-17
C875 FILL_L8_2 N 1.21075e-16
C876 FILL_L8_2 P 8.8475700000000008e-17
C877 FILL_L8_2 0 6.2242100000000008e-16
C878 FILL_L8_3 FILL_L8_4 6.96968e-17
C879 FILL_L8_3 FILL_L8_6 6.96968e-17
C880 FILL_L8_3 0 8.0897100000000003e-16
C881 FILL_L8_4 FILL_L8_5 6.96968e-17
C882 FILL_L8_4 FILL_L8_7 6.96968e-17
C883 FILL_L8_4 0 7.5091400000000008e-16
C884 FILL_L8_5 FILL_L8_8 6.96968e-17
C885 FILL_L8_5 N 1.9203800000000003e-16
C886 FILL_L8_5 P 1.4087300000000001e-16
C887 FILL_L8_5 0 7.9409500000000004e-16
C888 FILL_L8_6 FILL_L8_7 6.96968e-17
C889 FILL_L8_6 FILL_L8_9 6.96968e-17
C890 FILL_L8_6 0 8.0897100000000003e-16
C891 FILL_L8_7 FILL_L8_8 6.96968e-17
C892 FILL_L8_7 0 7.5091400000000008e-16
C893 FILL_L8_8 N 1.9203800000000003e-16
C894 FILL_L8_8 P 1.4087300000000001e-16
C895 FILL_L8_8 0 7.9409500000000004e-16
C896 FILL_L8_9 0 8.0897100000000003e-16
C897 N P 3.3182999999999999e-15
C898 N 0 9.8231000000000001e-17
C899 P 0 6.9910900000000009e-17
VP P 0 DC 0 AC 1
VN N 0 DC 0 AC 0
.control
set numdgt=17
ac lin 1 1Meg 1Meg
let cp = -imag(i(VP))/(2*pi*1e6)
let cn = -imag(i(VN))/(2*pi*1e6)
print cp cn
quit
.endc
.end
