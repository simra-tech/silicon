* actual_fill grounded drive P; diagnostic capacitor-network AC only
C62 0 N 1.1274000000000001e-15
C80 0 P 3.3182999999999999e-15
C218 0 P 2.0104e-17
C257 0 P 1.49205e-17
C306 0 N 6.714630000000001e-19
C307 0 P 5.3452400000000011e-18
C375 0 N 3.0638300000000001e-17
C391 0 N 9.2488000000000003e-17
C392 0 P 3.3449700000000005e-17
C404 0 P 3.3189300000000006e-17
C674 0 N 3.6098100000000003e-19
C675 0 P 4.2307500000000001e-19
C765 0 N 6.9818800000000003e-18
C766 0 P 2.2902200000000002e-18
C774 0 N 2.2167500000000005e-18
C775 0 P 7.2714500000000005e-19
C780 0 N 8.0857200000000011e-18
C781 0 P 2.9714800000000005e-17
C786 0 N 2.5466800000000001e-17
C787 0 P 8.7439400000000006e-17
C804 0 N 6.9818800000000003e-18
C805 0 P 2.2902200000000002e-18
C810 0 N 2.5466800000000001e-17
C811 0 P 8.8909700000000004e-17
C825 0 N 6.9818800000000003e-18
C826 0 P 2.2902200000000002e-18
C830 0 N 2.5466800000000001e-17
C831 0 P 8.8909700000000004e-17
C863 0 N 1.9203800000000003e-16
C864 0 P 1.4087300000000001e-16
C871 0 N 7.0963100000000007e-17
C872 0 P 5.2397399999999998e-17
C875 0 N 1.21075e-16
C876 0 P 8.8475700000000008e-17
C885 0 N 1.9203800000000003e-16
C886 0 P 1.4087300000000001e-16
C893 0 N 1.9203800000000003e-16
C894 0 P 1.4087300000000001e-16
C897 N P 3.3182999999999999e-15
C898 N 0 9.8231000000000001e-17
C899 P 0 6.9910900000000009e-17
VP P 0 DC 0 AC 1
VN N 0 DC 0 AC 0
.control
set numdgt=17
ac lin 1 1Meg 1Meg
let cp = -imag(i(VP))/(2*pi*1e6)
let cn = -imag(i(VN))/(2*pi*1e6)
print cp cn
quit
.endc
.end
