* no_fill floating drive P; diagnostic capacitor-network AC only
C22 0 N 1.1274000000000001e-15
C32 0 P 3.3182999999999999e-15
C96 0 P 3.0019e-17
C126 0 P 2.2421600000000004e-17
C156 0 N 6.714630000000001e-19
C157 0 P 7.7712700000000004e-18
C166 0 N 3.0638300000000001e-17
C169 0 N 9.2488000000000003e-17
C170 0 P 4.9860800000000002e-17
C173 0 P 4.9860800000000002e-17
C242 0 N 1.53938e-18
C243 0 P 1.8041800000000001e-18
C269 N P 3.3182999999999999e-15
C270 N 0 2.9495900000000005e-16
C271 P 0 2.0055800000000001e-16
VP P 0 DC 0 AC 1
VN N 0 DC 0 AC 0
.control
set numdgt=17
ac lin 1 1Meg 1Meg
let cp = -imag(i(VP))/(2*pi*1e6)
let cn = -imag(i(VN))/(2*pi*1e6)
print cp cn
quit
.endc
.end
