* Extracted by KLayout with SG13G2 LVS runset on : 21/09/2026 17:03

* cell sg13g2_IOPadIn
* pin iovdd
* pin iovss
* pin iovss
* pin p2c
* pin pad
* pin vdd
* pin vss
.SUBCKT sg13g2_IOPadIn iovdd iovss iovss$1 p2c pad vdd vss
* cell instance $1 r90 *1 11.92,7.66
X$1 \$1 iovss pad pad sg13g2_DCNDiode
* cell instance $2 r90 *1 11.92,66.66
X$2 \$1 iovss$1 iovdd pad pad sg13g2_DCPDiode
* cell instance $3 r0 *1 39.745,148.5
X$3 \$1 iovss$1 pad iovdd vss p2c vdd sg13g2_LevelDown
* device instance $2 r0 *1 40,102.585 ptap1
R$2 iovss$1 \$1 ptap1 A=5379.0466p P=677.04u
* device instance $3 r0 *1 19.872,157 ptap1
R$3 vss \$1 ptap1 A=11.9235p P=80.09u
* device instance $4 r0 *1 63.237,157 ptap1
R$4 vss \$1 ptap1 A=10.0575p P=67.65u
.ENDS sg13g2_IOPadIn

* cell sg13g2_LevelDown
* pin
* pin iovss
* pin pad
* pin iovdd
* pin vss
* pin core
* pin vdd
.SUBCKT sg13g2_LevelDown \$1 iovss pad iovdd vss core vdd
* cell instance $1 r0 *1 0,-8.33
X$1 \$1 iovss pad iovdd sg13g2_SecondaryProtection
* device instance $1 r0 *1 0.51,10.505 sg13_lv_nmos
M$1 core \$20 vss \$1 sg13_lv_nmos L=0.13u W=2.75u AS=0.935p AD=0.935p PS=6.18u
+ PD=6.18u rfmode=0
* device instance $2 r0 *1 2.02,10.555 sg13_hv_nmos
M$2 vss \$7 \$20 \$1 sg13_hv_nmos L=0.45u W=2.65u AS=0.901p AD=0.5035p PS=5.98u
+ PD=3.03u rfmode=0
* device instance $3 r0 *1 2.85,10.555 sg13_hv_nmos
M$3 \$20 \$6 vdd \$1 sg13_hv_nmos L=0.45u W=2.65u AS=0.5035p AD=0.901p PS=3.03u
+ PD=5.98u rfmode=0
* device instance $4 r0 *1 10.01,-6.63 sg13_hv_nmos
M$4 \$6 pad iovss \$1 sg13_hv_nmos L=0.45u W=1.3u AS=0.442p AD=0.247p PS=3.28u
+ PD=1.68u rfmode=0
* device instance $5 r0 *1 10.84,-6.63 sg13_hv_nmos
M$5 iovss \$6 \$7 \$1 sg13_hv_nmos L=0.45u W=1.3u AS=0.247p AD=0.442p PS=1.68u
+ PD=3.28u rfmode=0
* device instance $6 r0 *1 0.51,15.495 sg13_lv_pmos
M$6 core \$20 vdd vdd sg13_lv_pmos L=0.13u W=4.75u AS=1.615p AD=1.615p
+ PS=10.18u PD=10.18u rfmode=0
* device instance $8 r0 *1 9.18,-2.23 sg13_hv_pmos
M$8 iovdd pad \$6 iovdd sg13_hv_pmos L=0.45u W=2.3u AS=0.782p AD=0.437p
+ PS=5.28u PD=2.68u rfmode=0
* device instance $9 r0 *1 10.01,-2.23 sg13_hv_pmos
M$9 \$6 pad iovdd iovdd sg13_hv_pmos L=0.45u W=2.3u AS=0.437p AD=0.437p
+ PS=2.68u PD=2.68u rfmode=0
* device instance $10 r0 *1 10.84,-2.23 sg13_hv_pmos
M$10 iovdd \$6 \$7 iovdd sg13_hv_pmos L=0.45u W=2.3u AS=0.437p AD=0.437p
+ PS=2.68u PD=2.68u rfmode=0
* device instance $11 r0 *1 11.67,-2.23 sg13_hv_pmos
M$11 \$7 \$6 iovdd iovdd sg13_hv_pmos L=0.45u W=2.3u AS=0.437p AD=0.782p
+ PS=2.68u PD=5.28u rfmode=0
* device instance $12 r0 *1 3.365,8.5 ptap1
R$12 vss \$1 ptap1 A=2.019p P=14.06u
* device instance $13 r0 *1 10.47,-8.18 ptap1
R$13 iovss \$1 ptap1 A=0.804p P=5.96u
.ENDS sg13g2_LevelDown

* cell sg13g2_DCPDiode
* pin
* pin guard
* pin cathode
* pin anode
* pin anode
.SUBCKT sg13g2_DCPDiode \$1 guard cathode anode anode$1
* device instance $1 r0 *1 16.53,7.38 dpantenna
D$1 anode$1 cathode dpantenna A=35.0028p P=58.08u m=1
* device instance $2 r0 *1 16.53,2.88 dpantenna
D$2 anode cathode dpantenna A=35.0028p P=58.08u m=1
* device instance $3 r0 *1 16.53,5.13 ptap1
R$3 guard \$1 ptap1 A=33.5104p P=197.12u
.ENDS sg13g2_DCPDiode

* cell sg13g2_DCNDiode
* pin
* pin anode
* pin cathode
* pin cathode
.SUBCKT sg13g2_DCNDiode \$2 anode cathode cathode$1
* device instance $1 r0 *1 16.53,7.38 dantenna
D$1 \$2 cathode$1 dantenna A=35.0028p P=58.08u m=1
* device instance $2 r0 *1 16.53,2.88 dantenna
D$2 \$2 cathode dantenna A=35.0028p P=58.08u m=1
* device instance $3 r0 *1 16.53,5.13 ptap1
R$3 anode \$2 ptap1 A=141.2964p P=221.76u
.ENDS sg13g2_DCNDiode

* cell sg13g2_SecondaryProtection
* pin
* pin minus
* pin core,pad
* pin plus
.SUBCKT sg13g2_SecondaryProtection \$1 minus core|pad plus
* device instance $1 r0 *1 5.48,2.37 dantenna
D$1 \$1 core|pad dantenna A=1.984p P=7.48u m=1
* device instance $2 r0 *1 3.31,7.34 dpantenna
D$2 core|pad plus dpantenna A=3.1872p P=11.24u m=1
* device instance $3 r0 *1 5.48,2.37 ptap1
R$3 minus \$1 ptap1 A=4.3112p P=25.36u
* device instance $4 r0 *1 1.44,2.37 ptap1
R$4 minus \$1 ptap1 A=4.7192p P=27.76u
.ENDS sg13g2_SecondaryProtection
