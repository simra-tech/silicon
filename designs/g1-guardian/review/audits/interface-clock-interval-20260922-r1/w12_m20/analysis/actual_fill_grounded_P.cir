* actual_fill grounded drive P; diagnostic capacitor-network AC only
C6 0 N 3.1007600000000003e-16
C90 0 P 1.6853900000000001e-16
C96 0 N 1.9407100000000002e-17
C137 0 P 3.3450300000000001e-17
C144 0 N 8.3741000000000011e-17
C226 0 P 8.4109300000000015e-17
C232 0 N 2.5210400000000003e-17
C314 0 P 5.1236000000000001e-17
C317 0 N 4.1690700000000003e-17
C388 0 P 1.0684300000000002e-16
C391 0 N 4.0732400000000004e-17
C425 0 P 1.57728e-17
C427 0 N 2.3292500000000001e-17
C459 0 P 1.5571700000000002e-17
C496 0 P 2.0110500000000001e-17
C498 N 0 6.7784899999999994e-17
C499 N 0 2.6315600000000002e-18
C500 N 0 3.75234e-16
C501 N 0 2.4187300000000001e-17
C502 N 0 2.9328299999999998e-17
C503 N 0 5.22223e-17
C504 N 0 9.9145500000000009e-18
C505 N 0 2.35818e-19
C506 N 0 1.0010300000000001e-17
C507 N 0 9.9396600000000006e-18
C508 N 0 1.2552200000000001e-18
C509 N 0 5.6099900000000005e-18
C510 N 0 5.7365300000000002e-18
C511 N 0 9.9647600000000006e-18
C512 N 0 7.4735700000000008e-18
C513 N 0 3.8211000000000004e-18
C514 N 0 1.1098200000000002e-17
C515 N 0 6.1522000000000003e-18
C516 N 0 6.9751300000000005e-19
C517 N 0 1.8821900000000001e-16
C518 N 0 1.3685600000000002e-17
C519 N 0 4.8415300000000002e-19
C520 N 0 1.6145900000000003e-17
C521 N 0 1.4599100000000002e-18
C522 N 0 3.1120900000000001e-16
C523 N 0 5.4091600000000007e-18
C524 N 0 7.2083799999999998e-19
C525 N 0 5.2807400000000005e-18
C526 N 0 2.2140600000000001e-17
C527 N 0 1.6070500000000002e-18
C528 N 0 1.6070500000000002e-18
C529 N 0 1.6070500000000002e-18
C530 N 0 2.0235000000000002e-19
C531 N 0 1.3258900000000001e-17
C532 N 0 1.3105700000000001e-17
C533 N 0 9.8265900000000003e-17
C534 N 0 2.8268299999999999e-17
C535 N 0 9.8265900000000003e-17
C536 N 0 9.8265900000000003e-17
C537 N 0 2.8268299999999999e-17
C538 N 0 9.8265900000000003e-17
C539 N 0 1.0069900000000001e-16
C540 N 0 3.5841000000000005e-17
C541 N 0 1.0759200000000001e-16
C542 N 0 1.0249800000000002e-16
C543 N 0 5.8904000000000003e-19
C544 N 0 1.3547200000000001e-17
C545 N 0 9.8265900000000003e-17
C546 N 0 2.8268299999999999e-17
C547 N 0 9.8265900000000003e-17
C548 N 0 3.8684200000000004e-18
C549 N 0 1.0850900000000002e-18
C550 N 0 1.3003700000000001e-17
C551 N 0 3.8098600000000003e-18
C552 N 0 5.5014100000000008e-19
C553 N 0 5.5014100000000008e-19
C554 N 0 4.4929300000000004e-19
C555 N 0 5.5014100000000008e-19
C556 N 0 4.1260599999999998e-19
C557 N 0 4.4929300000000004e-19
C558 N 0 4.1643499999999997e-18
C559 N 0 2.5936800000000001e-18
C560 N 0 1.6102600000000001e-18
C561 N 0 2.4064600000000002e-19
C562 N P 5.2026500000000002e-15
C563 N 0 7.7884700000000007e-16
C648 0 P 4.0914500000000007e-18
C666 0 P 5.7082699999999999e-18
C685 0 P 7.7499700000000004e-18
C716 0 P 7.2929900000000014e-17
C732 0 P 1.3229e-16
C751 0 P 1.6010000000000003e-17
C768 0 P 1.6010000000000003e-17
C784 0 P 2.16834e-17
C800 0 P 8.0306200000000015e-19
C825 0 P 1.0038200000000001e-19
C840 0 P 2.89104e-17
C868 0 P 2.6109400000000004e-17
C946 0 P 1.21025e-14
C1112 0 P 1.37274e-16
C1122 0 P 4.0224500000000005e-19
C1134 0 P 3.6219899999999999e-18
C1141 0 P 4.5547300000000009e-18
C1150 0 P 9.8917200000000009e-19
C1168 0 P 5.2655800000000004e-18
C1173 0 P 1.00978e-18
C1183 0 P 1.03039e-18
C1192 0 P 1.03039e-18
C1199 0 P 5.1998600000000002e-19
C1207 0 P 1.03039e-18
C1214 0 P 7.727910000000001e-19
C1223 0 P 5.1998600000000002e-19
C1227 0 P 1.0374000000000001e-19
C1246 0 P 1.26457e-18
C1266 0 P 3.6450800000000003e-17
C1284 0 P 5.0775300000000004e-17
C1291 0 P 2.32402e-19
C1302 0 P 6.8249799999999999e-17
C1315 0 P 5.3264600000000004e-18
C1320 0 P 7.6692700000000005e-19
C1334 0 P 2.9113100000000003e-17
C1339 0 P 1.77481e-19
C1353 0 P 5.3264600000000004e-18
C1364 0 P 5.3264600000000004e-18
C1371 0 P 9.0158900000000006e-19
C1382 0 P 4.9459900000000008e-18
C1389 0 P 8.6552600000000005e-19
C1393 0 P 4.7665400000000005e-19
C1416 0 P 8.7924000000000011e-18
C1422 0 P 2.8873199999999999e-18
C1431 0 P 5.0628200000000008e-19
C1436 0 P 2.8873199999999999e-18
C1442 0 P 2.8873199999999999e-18
C1452 0 P 2.8873199999999999e-18
C1461 0 P 2.8873199999999999e-18
C1466 0 P 2.5314100000000004e-19
C1476 0 P 2.8873199999999999e-18
C1481 0 P 2.8873199999999999e-18
C1488 0 P 2.34989e-18
C1497 0 P 2.4807800000000001e-19
C1501 0 P 1.8226100000000003e-19
C1505 0 P 1.2657e-19
C1510 0 P 2.8873199999999999e-18
C1520 0 P 5.0628200000000008e-19
C1524 0 P 2.8873199999999999e-18
C1532 0 P 2.8873199999999999e-18
C1540 0 P 2.8873199999999999e-18
C1543 0 P 5.0331300000000003e-17
C1587 0 P 2.1894100000000004e-17
C1593 0 P 5.0331300000000003e-17
C1603 0 P 2.4862500000000002e-17
C1607 0 P 5.0331300000000003e-17
C1612 0 P 5.0331300000000003e-17
C1618 0 P 2.4862500000000002e-17
C1631 0 P 4.4039900000000009e-17
C1673 0 P 1.50389e-18
C1693 0 P 1.0245300000000001e-19
C1713 0 P 1.0245300000000001e-19
C1744 0 P 1.8052299999999998e-18
C1748 0 P 1.5313900000000001e-18
C1757 0 P 2.0783900000000003e-18
C1761 0 P 1.93149e-18
C1772 0 P 2.0783900000000003e-18
C1777 0 P 1.8873400000000001e-18
C1783 0 P 4.74594e-19
C1792 0 P 1.3984600000000002e-18
C1799 0 P 2.49407e-19
C1807 P 0 7.7665999999999998e-16
VP P 0 DC 0 AC 1
VN N 0 DC 0 AC 0
.control
set numdgt=17
ac lin 1 1Meg 1Meg
let cp = -imag(i(VP))/(2*pi*1e6)
let cn = -imag(i(VN))/(2*pi*1e6)
print cp cn
quit
.endc
.end
