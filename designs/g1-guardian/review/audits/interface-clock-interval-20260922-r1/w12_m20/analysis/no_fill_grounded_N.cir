* no_fill grounded drive N; diagnostic capacitor-network AC only
C6 0 N 3.6095500000000001e-16
C12 0 P 1.7179e-16
C18 0 N 2.6050600000000002e-17
C20 0 P 3.9215300000000001e-17
C27 0 N 9.0461500000000008e-17
C46 0 P 8.4215900000000014e-17
C52 0 N 2.6562100000000001e-17
C68 0 P 5.1457900000000004e-17
C71 0 N 6.1855400000000011e-17
C90 0 P 1.2390600000000001e-16
C93 0 N 4.2740300000000001e-17
C98 0 P 1.5813000000000001e-17
C100 0 N 3.4632700000000002e-17
C105 0 P 1.5622000000000002e-17
C123 0 P 2.0289100000000004e-17
C125 N 0 6.7784899999999994e-17
C126 N 0 2.6315600000000002e-18
C127 N 0 3.75234e-16
C128 N 0 2.4187300000000001e-17
C129 N 0 3.0999e-17
C130 N 0 6.4197000000000011e-17
C131 N P 5.2026500000000002e-15
C132 N 0 1.2640300000000001e-15
C161 0 P 4.0914500000000007e-18
C171 0 P 5.7082699999999999e-18
C180 0 P 7.7499700000000004e-18
C191 0 P 7.2929900000000014e-17
C198 0 P 1.3229e-16
C207 0 P 1.6010000000000003e-17
C216 0 P 1.6010000000000003e-17
C224 0 P 2.16834e-17
C230 0 P 8.0306200000000015e-19
C238 0 P 1.0038200000000001e-19
C244 0 P 2.9340700000000003e-17
C250 0 P 2.96529e-17
C256 0 P 1.21025e-14
C261 0 P 1.3855300000000001e-16
C263 0 P 4.8156100000000007e-19
C265 P 0 1.0576300000000002e-15
VP P 0 DC 0 AC 0
VN N 0 DC 0 AC 1
.control
set numdgt=17
ac lin 1 1Meg 1Meg
let cp = -imag(i(VP))/(2*pi*1e6)
let cn = -imag(i(VN))/(2*pi*1e6)
print cp cn
quit
.endc
.end
