* cell sense_fill_clip
.SUBCKT sense_fill_clip
* net 2 CTX_L30_0,CTX_L30_6,N
* net 3 CTX_L10_1,CTX_L30_2,CTX_L8_0
* net 4 CTX_L10_0,CTX_L30_4,CTX_L50_0
* net 5 CTX_L30_1,CTX_L50_5
* net 6 CTX_L8_1
* net 7 CTX_L134_0
* net 8 CTX_L126_0,CTX_L67_0
* net 9 CTX_L10_2,CTX_L10_3,CTX_L30_3
* net 10 CTX_L50_9
* net 11 CTX_L50_10
* net 12 P
* net 13 CTX_L134_1
* net 14 CTX_L126_1,CTX_L134_2
* net 15 CTX_L30_5,CTX_L50_6
* net 16 CTX_L30_8
* net 17 CTX_L30_7
* net 18 CTX_L30_10,CTX_L50_2,CTX_L67_1
* net 19 CTX_L30_9,CTX_L50_3
* net 20 CTX_L30_14
* net 21 CTX_L30_13,CTX_L50_13
* net 22 CTX_L30_12,CTX_L50_14
* net 23 CTX_L30_11,CTX_L50_15
* net 24 CTX_L30_18,CTX_L50_4
* net 25 CTX_L30_17,CTX_L50_7
* net 26 CTX_L30_16,CTX_L50_8
* net 27 CTX_L134_3
* net 28 CTX_L30_15,CTX_L50_12
* net 29 CTX_L8_2
* net 30 CTX_L30_19
.ENDS sense_fill_clip
