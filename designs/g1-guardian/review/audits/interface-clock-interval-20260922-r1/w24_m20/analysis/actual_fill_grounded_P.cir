* actual_fill grounded drive P; diagnostic capacitor-network AC only
C13 0 N 3.6715800000000005e-16
C142 0 P 1.68612e-16
C171 0 N 7.5519000000000015e-16
C211 0 P 2.8850100000000003e-17
C227 0 N 3.2527200000000001e-17
C319 0 P 1.1550400000000001e-18
C331 0 N 8.3805000000000013e-17
C426 0 P 8.4109300000000015e-17
C453 0 P 2.3391700000000002e-18
C457 0 N 1.1109800000000002e-19
C508 0 N 2.21272e-17
C572 0 P 3.9020400000000005e-17
C614 0 P 1.2053100000000002e-18
C618 0 N 3.7072699999999998e-17
C672 0 P 9.0360700000000016e-18
C684 0 N 2.5210400000000003e-17
C788 0 P 5.1236000000000001e-17
C794 0 N 4.8670900000000008e-17
C883 0 P 1.07707e-16
C888 0 N 4.3987000000000005e-17
C941 0 P 1.5471200000000001e-17
C947 0 N 2.3292500000000001e-17
C1003 0 P 1.5571700000000002e-17
C1065 0 P 1.9836600000000001e-17
C1132 0 P 2.6109400000000004e-17
C1186 0 N 2.6446300000000002e-18
C1219 0 P 1.0038200000000001e-19
C1221 N 0 4.0591800000000001e-16
C1222 N 0 2.27029e-16
C1223 N 0 2.20457e-19
C1224 N 0 2.9221800000000006e-17
C1225 N 0 2.4110400000000001e-17
C1226 N 0 6.0517700000000003e-17
C1227 N 0 4.8415300000000002e-19
C1228 N 0 1.6145900000000003e-17
C1229 N 0 1.4599100000000002e-18
C1230 N 0 1.06939e-16
C1231 N 0 3.1262800000000003e-16
C1232 N 0 5.4091600000000007e-18
C1233 N 0 7.2083799999999998e-19
C1234 N 0 9.9145500000000009e-18
C1235 N 0 2.35818e-19
C1236 N 0 9.6007399999999998e-19
C1237 N 0 1.0010300000000001e-17
C1238 N 0 9.9396600000000006e-18
C1239 N 0 1.2552200000000001e-18
C1240 N 0 5.6099900000000005e-18
C1241 N 0 9.369080000000001e-18
C1242 N 0 9.9647600000000006e-18
C1243 N 0 7.4735700000000008e-18
C1244 N 0 6.0914400000000011e-18
C1245 N 0 1.1098200000000002e-17
C1246 N 0 6.1522000000000003e-18
C1247 N 0 5.1024000000000007e-18
C1248 N 0 4.3594600000000008e-18
C1249 N 0 4.3594600000000008e-18
C1250 N 0 1.8812000000000001e-16
C1251 N 0 1.8915400000000002e-16
C1252 N 0 6.4560799999999999e-17
C1253 N 0 1.33858e-17
C1254 N 0 8.38576e-18
C1255 N 0 1.3258900000000001e-17
C1256 N 0 1.3105700000000001e-17
C1257 N 0 2.2140600000000001e-17
C1258 N 0 1.9833200000000001e-19
C1259 N 0 1.6070500000000002e-18
C1260 N 0 1.23957e-19
C1261 N 0 1.6070500000000002e-18
C1262 N 0 2.0659600000000002e-19
C1263 N 0 1.6070500000000002e-18
C1264 N 0 2.0235000000000002e-19
C1265 N 0 5.06222e-19
C1266 N 0 5.8904000000000003e-19
C1267 N 0 5.2380000000000006e-17
C1268 N 0 1.3547200000000001e-17
C1269 N 0 9.8265900000000003e-17
C1270 N 0 2.8268299999999999e-17
C1271 N 0 9.8265900000000003e-17
C1272 N 0 9.8265900000000003e-17
C1273 N 0 2.8268299999999999e-17
C1274 N 0 9.8265900000000003e-17
C1275 N 0 9.8265900000000003e-17
C1276 N 0 2.8268299999999999e-17
C1277 N 0 9.8265900000000003e-17
C1278 N 0 1.0069900000000001e-16
C1279 N 0 4.2291800000000008e-17
C1280 N 0 7.57269e-18
C1281 N 0 1.07493e-16
C1282 N 0 1.9101800000000001e-16
C1283 N 0 1.0249800000000002e-16
C1284 N 0 4.7775400000000009e-19
C1285 N 0 7.6799600000000002e-18
C1286 N 0 1.0568400000000001e-18
C1287 N 0 1.6102600000000001e-18
C1288 N 0 1.1198800000000001e-16
C1289 N 0 3.8098600000000003e-18
C1290 N 0 5.5014100000000008e-19
C1291 N 0 5.5014100000000008e-19
C1292 N 0 4.4929300000000004e-19
C1293 N 0 5.5014100000000008e-19
C1294 N 0 4.1260599999999998e-19
C1295 N 0 4.4929300000000004e-19
C1296 N 0 4.0826600000000001e-18
C1297 N 0 2.5716600000000002e-18
C1298 N 0 3.2205200000000002e-18
C1299 N 0 1.6102600000000001e-18
C1300 N P 5.2025600000000007e-15
C1301 N 0 8.9196300000000005e-16
C1428 0 P 4.0914500000000007e-18
C1452 0 P 5.7082699999999999e-18
C1487 0 P 7.7499700000000004e-18
C1529 0 P 7.2795599999999998e-17
C1554 0 P 1.3229e-16
C1582 0 P 1.6010000000000003e-17
C1607 0 P 1.6010000000000003e-17
C1633 0 P 2.16834e-17
C1912 0 P 1.21025e-14
C2028 0 P 1.3443000000000002e-16
C2050 0 P 3.6219899999999999e-18
C2063 0 P 5.3264600000000004e-18
C2086 0 P 5.3264600000000004e-18
C2094 0 P 8.9643700000000014e-19
C2113 0 P 4.9459900000000008e-18
C2122 0 P 8.6552600000000005e-19
C2132 0 P 4.7665400000000005e-19
C2152 0 P 9.8917200000000009e-19
C2159 0 P 4.5547300000000009e-18
C2193 0 P 5.2655800000000004e-18
C2201 0 P 1.00978e-18
C2233 0 P 1.03039e-18
C2238 0 P 1.0374000000000001e-19
C2252 0 P 1.03039e-18
C2264 0 P 5.1998600000000002e-19
C2288 0 P 1.03039e-18
C2299 0 P 7.727910000000001e-19
C2310 0 P 5.1998600000000002e-19
C2326 0 P 3.8978600000000003e-19
C2370 0 P 1.26457e-18
C2410 0 P 3.6374899999999999e-17
C2436 0 P 5.0775300000000004e-17
C2447 0 P 2.3091400000000004e-18
C2466 0 P 6.8224500000000005e-17
C2477 0 P 6.8083800000000004e-18
C2509 0 P 2.9049800000000004e-17
C2520 0 P 1.77481e-19
C2555 0 P 5.3264600000000004e-18
C2589 0 P 4.0643700000000005e-18
C2621 0 P 8.7924000000000011e-18
C2633 0 P 2.8873199999999999e-18
C2650 0 P 2.8873199999999999e-18
C2659 0 P 2.8873199999999999e-18
C2674 0 P 2.8873199999999999e-18
C2696 0 P 2.8873199999999999e-18
C2724 0 P 2.8873199999999999e-18
C2745 0 P 5.0628200000000008e-19
C2755 0 P 2.8873199999999999e-18
C2761 0 P 2.5314100000000004e-19
C2781 0 P 2.8873199999999999e-18
C2788 0 P 2.34989e-18
C2798 0 P 2.8873199999999999e-18
C2811 0 P 2.4807800000000001e-19
C2816 0 P 1.8226100000000003e-19
C2821 0 P 1.2657e-19
C2826 0 P 2.8873199999999999e-18
C2846 0 P 5.0628200000000008e-19
C2849 0 P 2.8873199999999999e-18
C2856 0 P 5.0331300000000003e-17
C2877 0 P 4.4039900000000009e-17
C2955 0 P 2.1894100000000004e-17
C2963 0 P 5.0331300000000003e-17
C2971 0 P 2.4862500000000002e-17
C2980 0 P 5.0331300000000003e-17
C2985 0 P 5.0331300000000003e-17
C2993 0 P 2.4862500000000002e-17
C3002 0 P 7.0913500000000004e-18
C3109 0 P 2.1581300000000001e-18
C3144 0 P 1.0245300000000001e-19
C3167 0 P 1.0245300000000001e-19
C3220 0 P 1.8052299999999998e-18
C3224 0 P 1.3216900000000001e-18
C3241 0 P 2.0783900000000003e-18
C3245 0 P 1.93149e-18
C3260 0 P 2.03089e-18
C3267 0 P 1.7548900000000001e-18
C3277 0 P 3.9457500000000003e-19
C3294 0 P 1.3984600000000002e-18
C3300 0 P 2.49407e-19
C3305 P 0 7.1724100000000001e-16
VP P 0 DC 0 AC 1
VN N 0 DC 0 AC 0
.control
set numdgt=17
ac lin 1 1Meg 1Meg
let cp = -imag(i(VP))/(2*pi*1e6)
let cn = -imag(i(VN))/(2*pi*1e6)
print cp cn
quit
.endc
.end
