*********************************************************
*** NGSPICE file created by KLayout-PEX 0.3.12
*** -----------------------------------------------------
***     Extraction Engine: KPEX/2.5D
***     Technology: ihp_sg13g2
***     Date: 2026-09-22 16:50:59
*********************************************************

.SUBCKT sense_fill_clip
Cext_1 CTX_L10_0|CTX_L30_18|CTX_L50_1|CTX_L8_0 CTX_L10_1|CTX_L10_4|CTX_L30_2
+ 186.963a
Cext_2 CTX_L10_0|CTX_L30_18|CTX_L50_1|CTX_L8_0 CTX_L10_10|CTX_L30_21 9.71987a
Cext_3 CTX_L10_0|CTX_L30_18|CTX_L50_1|CTX_L8_0 CTX_L10_11 0.379189a
Cext_4 CTX_L10_0|CTX_L30_18|CTX_L50_1|CTX_L8_0 CTX_L10_12|CTX_L10_8|CTX_L30_14
+ 240.66a
Cext_5 CTX_L10_0|CTX_L30_18|CTX_L50_1|CTX_L8_0 CTX_L10_2|CTX_L30_0 72.7475a
Cext_6 CTX_L10_0|CTX_L30_18|CTX_L50_1|CTX_L8_0 CTX_L10_3|CTX_L30_1 135.842a
Cext_7 CTX_L10_0|CTX_L30_18|CTX_L50_1|CTX_L8_0 CTX_L10_6|CTX_L30_4 184.47a
Cext_8 CTX_L10_0|CTX_L30_18|CTX_L50_1|CTX_L8_0 CTX_L10_7|CTX_L30_11|CTX_L8_1
+ 2.89804f
Cext_9 CTX_L10_0|CTX_L30_18|CTX_L50_1|CTX_L8_0
+ CTX_L126_1|CTX_L30_10|CTX_L50_2|CTX_L67_1 111.292a
Cext_10 CTX_L10_0|CTX_L30_18|CTX_L50_1|CTX_L8_0 CTX_L126_2|CTX_L134_2 143.906a
Cext_11 CTX_L10_0|CTX_L30_18|CTX_L50_1|CTX_L8_0 CTX_L134_0 189.986a
Cext_12 CTX_L10_0|CTX_L30_18|CTX_L50_1|CTX_L8_0 CTX_L134_1 161.329a
Cext_13 CTX_L10_0|CTX_L30_18|CTX_L50_1|CTX_L8_0 CTX_L30_12|CTX_L30_22|CTX_L50_4
+ 0.176283a
Cext_14 CTX_L10_0|CTX_L30_18|CTX_L50_1|CTX_L8_0 CTX_L30_17 2.53092a
Cext_15 CTX_L10_0|CTX_L30_18|CTX_L50_1|CTX_L8_0 CTX_L30_20|CTX_L30_6|N 420.941a
Cext_16 CTX_L10_0|CTX_L30_18|CTX_L50_1|CTX_L8_0 CTX_L30_5|CTX_L50_14 0.363015a
Cext_17 CTX_L10_0|CTX_L30_18|CTX_L50_1|CTX_L8_0 CTX_L30_7|CTX_L50_17 4.22825a
Cext_18 CTX_L10_0|CTX_L30_18|CTX_L50_1|CTX_L8_0 CTX_L30_9|CTX_L50_11 0.133081a
Cext_19 CTX_L10_0|CTX_L30_18|CTX_L50_1|CTX_L8_0 CTX_L50_21 75.112a
Cext_20 CTX_L10_0|CTX_L30_18|CTX_L50_1|CTX_L8_0 CTX_L50_22 137.259a
Cext_21 CTX_L10_0|CTX_L30_18|CTX_L50_1|CTX_L8_0 CTX_L8_2 240.388a
Cext_22 CTX_L10_0|CTX_L30_18|CTX_L50_1|CTX_L8_0 P 171.862a
Cext_23 CTX_L10_0|CTX_L30_18|CTX_L50_1|CTX_L8_0 VSUBS 7.5241f
Cext_24 CTX_L10_1|CTX_L10_4|CTX_L30_2 CTX_L10_2|CTX_L30_0 89.0528a
Cext_25 CTX_L10_1|CTX_L10_4|CTX_L30_2 CTX_L10_3|CTX_L30_1 1.88498f
Cext_26 CTX_L10_1|CTX_L10_4|CTX_L30_2 CTX_L10_6|CTX_L30_4 1.88959f
Cext_27 CTX_L10_1|CTX_L10_4|CTX_L30_2 CTX_L10_7|CTX_L30_11|CTX_L8_1 24.3956a
Cext_28 CTX_L10_1|CTX_L10_4|CTX_L30_2 CTX_L134_0 1.90226a
Cext_29 CTX_L10_1|CTX_L10_4|CTX_L30_2 VSUBS 582.102a
Cext_30 CTX_L10_10|CTX_L30_21 CTX_L10_11 371.983a
Cext_31 CTX_L10_10|CTX_L30_21 CTX_L10_12|CTX_L10_8|CTX_L30_14 35.5363a
Cext_32 CTX_L10_10|CTX_L30_21 CTX_L126_1|CTX_L30_10|CTX_L50_2|CTX_L67_1 51.3548a
Cext_33 CTX_L10_10|CTX_L30_21 CTX_L126_2|CTX_L134_2 72.6998a
Cext_34 CTX_L10_10|CTX_L30_21 CTX_L134_3 14.4946a
Cext_35 CTX_L10_10|CTX_L30_21 CTX_L30_12|CTX_L30_22|CTX_L50_4 345.027a
Cext_36 CTX_L10_10|CTX_L30_21 CTX_L30_19|CTX_L50_18 487.409a
Cext_37 CTX_L10_10|CTX_L30_21 CTX_L30_20|CTX_L30_6|N 755.19a
Cext_38 CTX_L10_10|CTX_L30_21 CTX_L30_23|CTX_L50_15 66.3817a
Cext_39 CTX_L10_10|CTX_L30_21 CTX_L30_24|CTX_L50_10 50.5324a
Cext_40 CTX_L10_10|CTX_L30_21 CTX_L30_25|CTX_L50_12|CTX_L50_7|CTX_L67_4 36.3983a
Cext_41 CTX_L10_10|CTX_L30_21 CTX_L30_26|CTX_L50_5|CTX_L50_9|CTX_L67_2 52.8716a
Cext_42 CTX_L10_10|CTX_L30_21 CTX_L30_27 25.0195a
Cext_43 CTX_L10_10|CTX_L30_21 CTX_L30_30|CTX_L50_6|CTX_L50_8|CTX_L67_3 60.1171a
Cext_44 CTX_L10_10|CTX_L30_21 CTX_L30_32|CTX_L50_13 2.71845a
Cext_45 CTX_L10_10|CTX_L30_21 CTX_L30_5|CTX_L50_14 29.5793a
Cext_46 CTX_L10_10|CTX_L30_21 CTX_L30_7|CTX_L50_17 25.0481a
Cext_47 CTX_L10_10|CTX_L30_21 CTX_L30_9|CTX_L50_11 69.2423a
Cext_48 CTX_L10_10|CTX_L30_21 CTX_L50_21 27.6316a
Cext_49 CTX_L10_10|CTX_L30_21 CTX_L50_22 21.973a
Cext_50 CTX_L10_10|CTX_L30_21 CTX_L8_2 7.78191a
Cext_51 CTX_L10_10|CTX_L30_21 P 29.4672a
Cext_52 CTX_L10_10|CTX_L30_21 VSUBS 1.72115f
Cext_53 CTX_L10_11 CTX_L10_12|CTX_L10_8|CTX_L30_14 345.056a
Cext_54 CTX_L10_11 CTX_L10_5|CTX_L30_3 1.59554f
Cext_55 CTX_L10_11 CTX_L126_0|CTX_L30_8|CTX_L50_0|CTX_L67_0 97.8044a
Cext_56 CTX_L10_11 CTX_L126_1|CTX_L30_10|CTX_L50_2|CTX_L67_1 207.249a
Cext_57 CTX_L10_11 CTX_L126_2|CTX_L134_2 25.1287a
Cext_58 CTX_L10_11 CTX_L134_0 29.8962a
Cext_59 CTX_L10_11 CTX_L134_1 26.4399a
Cext_60 CTX_L10_11 CTX_L134_3 12.5289a
Cext_61 CTX_L10_11 CTX_L30_12|CTX_L30_22|CTX_L50_4 135.692a
Cext_62 CTX_L10_11 CTX_L30_13 12.0669a
Cext_63 CTX_L10_11 CTX_L30_15 12.0669a
Cext_64 CTX_L10_11 CTX_L30_16 12.0669a
Cext_65 CTX_L10_11 CTX_L30_17 12.0669a
Cext_66 CTX_L10_11 CTX_L30_19|CTX_L50_18 42.885a
Cext_67 CTX_L10_11 CTX_L30_20|CTX_L30_6|N 34.6784a
Cext_68 CTX_L10_11 CTX_L30_23|CTX_L50_15 49.6273a
Cext_69 CTX_L10_11 CTX_L30_24|CTX_L50_10 19.7174a
Cext_70 CTX_L10_11 CTX_L30_25|CTX_L50_12|CTX_L50_7|CTX_L67_4 26.1266a
Cext_71 CTX_L10_11 CTX_L30_26|CTX_L50_5|CTX_L50_9|CTX_L67_2 50.5943a
Cext_72 CTX_L10_11 CTX_L30_27 11.3124a
Cext_73 CTX_L10_11 CTX_L30_30|CTX_L50_6|CTX_L50_8|CTX_L67_3 14.3843a
Cext_74 CTX_L10_11 CTX_L30_32|CTX_L50_13 57.7231a
Cext_75 CTX_L10_11 CTX_L30_35|CTX_L50_19 1.11848a
Cext_76 CTX_L10_11 CTX_L30_36|CTX_L50_16 2.54817a
Cext_77 CTX_L10_11 CTX_L30_5|CTX_L50_14 217.59a
Cext_78 CTX_L10_11 CTX_L30_7|CTX_L50_17 59.0852a
Cext_79 CTX_L10_11 CTX_L30_9|CTX_L50_11 105.04a
Cext_80 CTX_L10_11 CTX_L50_21 11.8745a
Cext_81 CTX_L10_11 CTX_L50_22 4.96713a
Cext_82 CTX_L10_11 CTX_L8_2 6.42943a
Cext_83 CTX_L10_11 P 4.24301a
Cext_84 CTX_L10_11 VSUBS 4.05297f
Cext_85 CTX_L10_12|CTX_L10_8|CTX_L30_14 CTX_L10_7|CTX_L30_11|CTX_L8_1 53.1899a
Cext_86 CTX_L10_12|CTX_L10_8|CTX_L30_14 CTX_L10_9|CTX_L30_37|CTX_L8_3 3.9408a
Cext_87 CTX_L10_12|CTX_L10_8|CTX_L30_14
+ CTX_L126_1|CTX_L30_10|CTX_L50_2|CTX_L67_1 182.372a
Cext_88 CTX_L10_12|CTX_L10_8|CTX_L30_14 CTX_L126_2|CTX_L134_2 79.2885a
Cext_89 CTX_L10_12|CTX_L10_8|CTX_L30_14 CTX_L134_0 33.6013a
Cext_90 CTX_L10_12|CTX_L10_8|CTX_L30_14 CTX_L134_1 76.4274a
Cext_91 CTX_L10_12|CTX_L10_8|CTX_L30_14 CTX_L134_3 16.2116a
Cext_92 CTX_L10_12|CTX_L10_8|CTX_L30_14 CTX_L30_12|CTX_L30_22|CTX_L50_4 35.4712a
Cext_93 CTX_L10_12|CTX_L10_8|CTX_L30_14 CTX_L30_13 1.89819a
Cext_94 CTX_L10_12|CTX_L10_8|CTX_L30_14 CTX_L30_19|CTX_L50_18 62.4352a
Cext_95 CTX_L10_12|CTX_L10_8|CTX_L30_14 CTX_L30_20|CTX_L30_6|N 91.2509a
Cext_96 CTX_L10_12|CTX_L10_8|CTX_L30_14 CTX_L30_23|CTX_L50_15 5.55759a
Cext_97 CTX_L10_12|CTX_L10_8|CTX_L30_14
+ CTX_L30_25|CTX_L50_12|CTX_L50_7|CTX_L67_4 0.304154a
Cext_98 CTX_L10_12|CTX_L10_8|CTX_L30_14
+ CTX_L30_26|CTX_L50_5|CTX_L50_9|CTX_L67_2 0.361254a
Cext_99 CTX_L10_12|CTX_L10_8|CTX_L30_14 CTX_L30_29|CTX_L50_26 0.343508a
Cext_100 CTX_L10_12|CTX_L10_8|CTX_L30_14 CTX_L30_31|CTX_L50_25 1.1297a
Cext_101 CTX_L10_12|CTX_L10_8|CTX_L30_14 CTX_L30_32|CTX_L50_13 36.1888a
Cext_102 CTX_L10_12|CTX_L10_8|CTX_L30_14 CTX_L30_33|CTX_L50_24 1.78373a
Cext_103 CTX_L10_12|CTX_L10_8|CTX_L30_14 CTX_L30_34|CTX_L50_20 21.5976a
Cext_104 CTX_L10_12|CTX_L10_8|CTX_L30_14 CTX_L30_35|CTX_L50_19 32.9356a
Cext_105 CTX_L10_12|CTX_L10_8|CTX_L30_14 CTX_L30_36|CTX_L50_16 29.7663a
Cext_106 CTX_L10_12|CTX_L10_8|CTX_L30_14 CTX_L30_5|CTX_L50_14 9.22441a
Cext_107 CTX_L10_12|CTX_L10_8|CTX_L30_14 CTX_L30_7|CTX_L50_17 75.9891a
Cext_108 CTX_L10_12|CTX_L10_8|CTX_L30_14 CTX_L50_21 164.906a
Cext_109 CTX_L10_12|CTX_L10_8|CTX_L30_14 CTX_L50_22 91.3864a
Cext_110 CTX_L10_12|CTX_L10_8|CTX_L30_14 CTX_L8_2 90.8944a
Cext_111 CTX_L10_12|CTX_L10_8|CTX_L30_14 P 84.2159a
Cext_112 CTX_L10_12|CTX_L10_8|CTX_L30_14 VSUBS 3.66701f
Cext_113 CTX_L10_2|CTX_L30_0 CTX_L10_3|CTX_L30_1 0.246069a
Cext_114 CTX_L10_2|CTX_L30_0 CTX_L10_6|CTX_L30_4 205.348a
Cext_115 CTX_L10_2|CTX_L30_0 CTX_L10_7|CTX_L30_11|CTX_L8_1 0.368145a
Cext_116 CTX_L10_2|CTX_L30_0 VSUBS 420.572a
Cext_117 CTX_L10_3|CTX_L30_1 CTX_L10_6|CTX_L30_4 46.5825a
Cext_118 CTX_L10_3|CTX_L30_1 CTX_L10_7|CTX_L30_11|CTX_L8_1 958.866a
Cext_119 CTX_L10_3|CTX_L30_1 P 2.59717a
Cext_120 CTX_L10_3|CTX_L30_1 VSUBS 481.142a
Cext_121 CTX_L10_5|CTX_L30_3 CTX_L126_0|CTX_L30_8|CTX_L50_0|CTX_L67_0 116.644a
Cext_122 CTX_L10_5|CTX_L30_3 CTX_L134_0 2.29791a
Cext_123 CTX_L10_5|CTX_L30_3 CTX_L30_20|CTX_L30_6|N 0.111098a
Cext_124 CTX_L10_5|CTX_L30_3 CTX_L30_5|CTX_L50_14 118.653a
Cext_125 CTX_L10_5|CTX_L30_3 CTX_L30_9|CTX_L50_11 0.42777a
Cext_126 CTX_L10_5|CTX_L30_3 CTX_L50_21 4.76183a
Cext_127 CTX_L10_5|CTX_L30_3 CTX_L8_2 1.02053a
Cext_128 CTX_L10_5|CTX_L30_3 VSUBS 968.688a
Cext_129 CTX_L10_6|CTX_L30_4 CTX_L10_7|CTX_L30_11|CTX_L8_1 14.9481a
Cext_130 CTX_L10_6|CTX_L30_4 CTX_L134_0 6.79285a
Cext_131 CTX_L10_6|CTX_L30_4 VSUBS 661.796a
Cext_132 CTX_L10_7|CTX_L30_11|CTX_L8_1
+ CTX_L126_1|CTX_L30_10|CTX_L50_2|CTX_L67_1 3.46473a
Cext_133 CTX_L10_7|CTX_L30_11|CTX_L8_1 CTX_L134_0 110.623a
Cext_134 CTX_L10_7|CTX_L30_11|CTX_L8_1 CTX_L134_1 34.705a
Cext_135 CTX_L10_7|CTX_L30_11|CTX_L8_1 CTX_L30_20|CTX_L30_6|N 30.0262a
Cext_136 CTX_L10_7|CTX_L30_11|CTX_L8_1 CTX_L8_2 369.002a
Cext_137 CTX_L10_7|CTX_L30_11|CTX_L8_1 P 45.3925a
Cext_138 CTX_L10_7|CTX_L30_11|CTX_L8_1 VSUBS 4.17217f
Cext_139 CTX_L10_9|CTX_L30_37|CTX_L8_3
+ CTX_L126_1|CTX_L30_10|CTX_L50_2|CTX_L67_1 2.75503a
Cext_140 CTX_L10_9|CTX_L30_37|CTX_L8_3 CTX_L126_2|CTX_L134_2 115.339a
Cext_141 CTX_L10_9|CTX_L30_37|CTX_L8_3 CTX_L134_3 88.3778a
Cext_142 CTX_L10_9|CTX_L30_37|CTX_L8_3 CTX_L30_19|CTX_L50_18 0.395429a
Cext_143 CTX_L10_9|CTX_L30_37|CTX_L8_3 CTX_L30_28|CTX_L50_27 204.62a
Cext_144 CTX_L10_9|CTX_L30_37|CTX_L8_3 CTX_L30_29|CTX_L50_26 157.882a
Cext_145 CTX_L10_9|CTX_L30_37|CTX_L8_3 CTX_L30_31|CTX_L50_25 62.1032a
Cext_146 CTX_L10_9|CTX_L30_37|CTX_L8_3 CTX_L30_32|CTX_L50_13 0.927718a
Cext_147 CTX_L10_9|CTX_L30_37|CTX_L8_3 CTX_L30_33|CTX_L50_24 8.93467a
Cext_148 CTX_L10_9|CTX_L30_37|CTX_L8_3 CTX_L30_34|CTX_L50_20 5.4629a
Cext_149 CTX_L10_9|CTX_L30_37|CTX_L8_3 CTX_L30_35|CTX_L50_19 6.37481a
Cext_150 CTX_L10_9|CTX_L30_37|CTX_L8_3 CTX_L30_36|CTX_L50_16 551.201a
Cext_151 CTX_L10_9|CTX_L30_37|CTX_L8_3 CTX_L30_7|CTX_L50_17 0.345952a
Cext_152 CTX_L10_9|CTX_L30_37|CTX_L8_3 CTX_L50_21 0.756224a
Cext_153 CTX_L10_9|CTX_L30_37|CTX_L8_3 CTX_L50_22 1.03102a
Cext_154 CTX_L10_9|CTX_L30_37|CTX_L8_3 P 1.28462a
Cext_155 CTX_L10_9|CTX_L30_37|CTX_L8_3 VSUBS 1.58835f
Cext_156 CTX_L126_0|CTX_L30_8|CTX_L50_0|CTX_L67_0
+ CTX_L126_1|CTX_L30_10|CTX_L50_2|CTX_L67_1 3.89349a
Cext_157 CTX_L126_0|CTX_L30_8|CTX_L50_0|CTX_L67_0 CTX_L134_0 46.1311a
Cext_158 CTX_L126_0|CTX_L30_8|CTX_L50_0|CTX_L67_0 CTX_L30_20|CTX_L30_6|N
+ 38.9369a
Cext_159 CTX_L126_0|CTX_L30_8|CTX_L50_0|CTX_L67_0 CTX_L30_5|CTX_L50_14 180.81a
Cext_160 CTX_L126_0|CTX_L30_8|CTX_L50_0|CTX_L67_0 CTX_L30_7|CTX_L50_17 373.545a
Cext_161 CTX_L126_0|CTX_L30_8|CTX_L50_0|CTX_L67_0 CTX_L30_9|CTX_L50_11 362.131a
Cext_162 CTX_L126_0|CTX_L30_8|CTX_L50_0|CTX_L67_0 CTX_L50_21 45.3713a
Cext_163 CTX_L126_0|CTX_L30_8|CTX_L50_0|CTX_L67_0 CTX_L50_22 10.2886a
Cext_164 CTX_L126_0|CTX_L30_8|CTX_L50_0|CTX_L67_0 CTX_L8_2 22.3652a
Cext_165 CTX_L126_0|CTX_L30_8|CTX_L50_0|CTX_L67_0 P 9.03607a
Cext_166 CTX_L126_0|CTX_L30_8|CTX_L50_0|CTX_L67_0 VSUBS 1.96876f
Cext_167 CTX_L126_1|CTX_L30_10|CTX_L50_2|CTX_L67_1 CTX_L126_2|CTX_L134_2
+ 639.393a
Cext_168 CTX_L126_1|CTX_L30_10|CTX_L50_2|CTX_L67_1 CTX_L134_0 121.173a
Cext_169 CTX_L126_1|CTX_L30_10|CTX_L50_2|CTX_L67_1 CTX_L134_1 326.077a
Cext_170 CTX_L126_1|CTX_L30_10|CTX_L50_2|CTX_L67_1 CTX_L134_3 294.31a
Cext_171 CTX_L126_1|CTX_L30_10|CTX_L50_2|CTX_L67_1
+ CTX_L30_12|CTX_L30_22|CTX_L50_4 165.781a
Cext_172 CTX_L126_1|CTX_L30_10|CTX_L50_2|CTX_L67_1 CTX_L30_13 6.89173a
Cext_173 CTX_L126_1|CTX_L30_10|CTX_L50_2|CTX_L67_1 CTX_L30_15 6.25121a
Cext_174 CTX_L126_1|CTX_L30_10|CTX_L50_2|CTX_L67_1 CTX_L30_16 6.25121a
Cext_175 CTX_L126_1|CTX_L30_10|CTX_L50_2|CTX_L67_1 CTX_L30_17 6.25121a
Cext_176 CTX_L126_1|CTX_L30_10|CTX_L50_2|CTX_L67_1 CTX_L30_19|CTX_L50_18
+ 107.384a
Cext_177 CTX_L126_1|CTX_L30_10|CTX_L50_2|CTX_L67_1 CTX_L30_20|CTX_L30_6|N
+ 26.5621a
Cext_178 CTX_L126_1|CTX_L30_10|CTX_L50_2|CTX_L67_1 CTX_L30_23|CTX_L50_15
+ 205.981a
Cext_179 CTX_L126_1|CTX_L30_10|CTX_L50_2|CTX_L67_1 CTX_L30_24|CTX_L50_10
+ 17.5328a
Cext_180 CTX_L126_1|CTX_L30_10|CTX_L50_2|CTX_L67_1
+ CTX_L30_25|CTX_L50_12|CTX_L50_7|CTX_L67_4 26.5824a
Cext_181 CTX_L126_1|CTX_L30_10|CTX_L50_2|CTX_L67_1
+ CTX_L30_26|CTX_L50_5|CTX_L50_9|CTX_L67_2 23.3371a
Cext_182 CTX_L126_1|CTX_L30_10|CTX_L50_2|CTX_L67_1 CTX_L30_27 5.63814a
Cext_183 CTX_L126_1|CTX_L30_10|CTX_L50_2|CTX_L67_1
+ CTX_L30_30|CTX_L50_6|CTX_L50_8|CTX_L67_3 13.1685a
Cext_184 CTX_L126_1|CTX_L30_10|CTX_L50_2|CTX_L67_1 CTX_L30_32|CTX_L50_13
+ 76.8954a
Cext_185 CTX_L126_1|CTX_L30_10|CTX_L50_2|CTX_L67_1 CTX_L30_34|CTX_L50_20 12.349a
Cext_186 CTX_L126_1|CTX_L30_10|CTX_L50_2|CTX_L67_1 CTX_L30_35|CTX_L50_19
+ 16.1189a
Cext_187 CTX_L126_1|CTX_L30_10|CTX_L50_2|CTX_L67_1 CTX_L30_36|CTX_L50_16
+ 61.9076a
Cext_188 CTX_L126_1|CTX_L30_10|CTX_L50_2|CTX_L67_1 CTX_L30_5|CTX_L50_14 474.385a
Cext_189 CTX_L126_1|CTX_L30_10|CTX_L50_2|CTX_L67_1 CTX_L30_7|CTX_L50_17 582.033a
Cext_190 CTX_L126_1|CTX_L30_10|CTX_L50_2|CTX_L67_1 CTX_L30_9|CTX_L50_11 241.789a
Cext_191 CTX_L126_1|CTX_L30_10|CTX_L50_2|CTX_L67_1 CTX_L50_21 74.4845a
Cext_192 CTX_L126_1|CTX_L30_10|CTX_L50_2|CTX_L67_1 CTX_L50_22 61.7864a
Cext_193 CTX_L126_1|CTX_L30_10|CTX_L50_2|CTX_L67_1 CTX_L8_2 42.6943a
Cext_194 CTX_L126_1|CTX_L30_10|CTX_L50_2|CTX_L67_1 P 51.4579a
Cext_195 CTX_L126_1|CTX_L30_10|CTX_L50_2|CTX_L67_1 VSUBS 3.19958f
Cext_196 CTX_L126_2|CTX_L134_2 CTX_L134_3 349.853a
Cext_197 CTX_L126_2|CTX_L134_2 CTX_L30_12|CTX_L30_22|CTX_L50_4 99.6321a
Cext_198 CTX_L126_2|CTX_L134_2 CTX_L30_17 9.06623a
Cext_199 CTX_L126_2|CTX_L134_2 CTX_L30_19|CTX_L50_18 47.7622a
Cext_200 CTX_L126_2|CTX_L134_2 CTX_L30_20|CTX_L30_6|N 79.999a
Cext_201 CTX_L126_2|CTX_L134_2 CTX_L30_23|CTX_L50_15 11.8226a
Cext_202 CTX_L126_2|CTX_L134_2 CTX_L30_28|CTX_L50_27 26.6851a
Cext_203 CTX_L126_2|CTX_L134_2 CTX_L30_29|CTX_L50_26 45.2262a
Cext_204 CTX_L126_2|CTX_L134_2 CTX_L30_31|CTX_L50_25 82.3756a
Cext_205 CTX_L126_2|CTX_L134_2 CTX_L30_32|CTX_L50_13 119.497a
Cext_206 CTX_L126_2|CTX_L134_2 CTX_L30_33|CTX_L50_24 81.1973a
Cext_207 CTX_L126_2|CTX_L134_2 CTX_L30_34|CTX_L50_20 27.5271a
Cext_208 CTX_L126_2|CTX_L134_2 CTX_L30_35|CTX_L50_19 24.4149a
Cext_209 CTX_L126_2|CTX_L134_2 CTX_L30_36|CTX_L50_16 32.0149a
Cext_210 CTX_L126_2|CTX_L134_2 CTX_L30_5|CTX_L50_14 23.1011a
Cext_211 CTX_L126_2|CTX_L134_2 CTX_L30_7|CTX_L50_17 13.5171a
Cext_212 CTX_L126_2|CTX_L134_2 CTX_L30_9|CTX_L50_11 31.0131a
Cext_213 CTX_L126_2|CTX_L134_2 CTX_L50_21 46.4684a
Cext_214 CTX_L126_2|CTX_L134_2 CTX_L50_22 44.2829a
Cext_215 CTX_L126_2|CTX_L134_2 CTX_L8_2 28.2398a
Cext_216 CTX_L126_2|CTX_L134_2 P 127.316a
Cext_217 CTX_L126_2|CTX_L134_2 VSUBS 2.63776f
Cext_218 CTX_L134_0 CTX_L134_1 925.802a
Cext_219 CTX_L134_0 CTX_L30_12|CTX_L30_22|CTX_L50_4 9.2185a
Cext_220 CTX_L134_0 CTX_L30_13 4.13782a
Cext_221 CTX_L134_0 CTX_L30_20|CTX_L30_6|N 50.7247a
Cext_222 CTX_L134_0 CTX_L30_5|CTX_L50_14 30.4232a
Cext_223 CTX_L134_0 CTX_L30_7|CTX_L50_17 39.917a
Cext_224 CTX_L134_0 CTX_L30_9|CTX_L50_11 43.7739a
Cext_225 CTX_L134_0 CTX_L50_21 23.2382a
Cext_226 CTX_L134_0 CTX_L50_22 15.5918a
Cext_227 CTX_L134_0 CTX_L8_2 15.4507a
Cext_228 CTX_L134_0 P 15.5918a
Cext_229 CTX_L134_0 VSUBS 1.08237f
Cext_230 CTX_L134_1 CTX_L30_12|CTX_L30_22|CTX_L50_4 21.1681a
Cext_231 CTX_L134_1 CTX_L30_13 17.6057a
Cext_232 CTX_L134_1 CTX_L30_15 15.6967a
Cext_233 CTX_L134_1 CTX_L30_16 3.79892a
Cext_234 CTX_L134_1 CTX_L30_20|CTX_L30_6|N 40.606a
Cext_235 CTX_L134_1 CTX_L30_5|CTX_L50_14 20.8389a
Cext_236 CTX_L134_1 CTX_L30_7|CTX_L50_17 15.7179a
Cext_237 CTX_L134_1 CTX_L30_9|CTX_L50_11 29.7166a
Cext_238 CTX_L134_1 CTX_L50_21 23.1679a
Cext_239 CTX_L134_1 CTX_L50_22 15.622a
Cext_240 CTX_L134_1 CTX_L8_2 17.5541a
Cext_241 CTX_L134_1 P 15.622a
Cext_242 CTX_L134_1 VSUBS 1.12227f
Cext_243 CTX_L134_3 CTX_L30_19|CTX_L50_18 18.7796a
Cext_244 CTX_L134_3 CTX_L30_23|CTX_L50_15 15.9718a
Cext_245 CTX_L134_3 CTX_L30_24|CTX_L50_10 17.2361a
Cext_246 CTX_L134_3 CTX_L30_25|CTX_L50_12|CTX_L50_7|CTX_L67_4 32.8097a
Cext_247 CTX_L134_3 CTX_L30_26|CTX_L50_5|CTX_L50_9|CTX_L67_2 34.8059a
Cext_248 CTX_L134_3 CTX_L30_27 5.4854a
Cext_249 CTX_L134_3 CTX_L30_28|CTX_L50_27 42.4547a
Cext_250 CTX_L134_3 CTX_L30_29|CTX_L50_26 25.0701a
Cext_251 CTX_L134_3 CTX_L30_30|CTX_L50_6|CTX_L50_8|CTX_L67_3 45.6666a
Cext_252 CTX_L134_3 CTX_L30_31|CTX_L50_25 15.9817a
Cext_253 CTX_L134_3 CTX_L30_32|CTX_L50_13 46.0074a
Cext_254 CTX_L134_3 CTX_L30_33|CTX_L50_24 16.549a
Cext_255 CTX_L134_3 CTX_L30_34|CTX_L50_20 24.9302a
Cext_256 CTX_L134_3 CTX_L30_35|CTX_L50_19 22.6584a
Cext_257 CTX_L134_3 CTX_L30_36|CTX_L50_16 14.8989a
Cext_258 CTX_L134_3 CTX_L30_5|CTX_L50_14 17.6443a
Cext_259 CTX_L134_3 CTX_L30_7|CTX_L50_17 3.55947a
Cext_260 CTX_L134_3 CTX_L30_9|CTX_L50_11 19.0155a
Cext_261 CTX_L134_3 CTX_L50_21 18.0641a
Cext_262 CTX_L134_3 CTX_L50_22 14.3062a
Cext_263 CTX_L134_3 P 20.0654a
Cext_264 CTX_L134_3 VSUBS 1.30704f
Cext_265 CTX_L30_12|CTX_L30_22|CTX_L50_4 CTX_L30_13 343.817a
Cext_266 CTX_L30_12|CTX_L30_22|CTX_L50_4 CTX_L30_15 27.3286a
Cext_267 CTX_L30_12|CTX_L30_22|CTX_L50_4 CTX_L30_16 27.1984a
Cext_268 CTX_L30_12|CTX_L30_22|CTX_L50_4 CTX_L30_17 29.3183a
Cext_269 CTX_L30_12|CTX_L30_22|CTX_L50_4 CTX_L30_19|CTX_L50_18 56.3778a
Cext_270 CTX_L30_12|CTX_L30_22|CTX_L50_4 CTX_L30_23|CTX_L50_15 159.793a
Cext_271 CTX_L30_12|CTX_L30_22|CTX_L50_4 CTX_L30_5|CTX_L50_14 1.56209f
Cext_272 CTX_L30_12|CTX_L30_22|CTX_L50_4 CTX_L30_7|CTX_L50_17 28.7683a
Cext_273 CTX_L30_12|CTX_L30_22|CTX_L50_4 CTX_L30_9|CTX_L50_11 1.53823f
Cext_274 CTX_L30_12|CTX_L30_22|CTX_L50_4 CTX_L50_21 27.7252a
Cext_275 CTX_L30_12|CTX_L30_22|CTX_L50_4 CTX_L50_22 22.3455a
Cext_276 CTX_L30_12|CTX_L30_22|CTX_L50_4 CTX_L8_2 4.09701a
Cext_277 CTX_L30_12|CTX_L30_22|CTX_L50_4 P 29.8397a
Cext_278 CTX_L30_12|CTX_L30_22|CTX_L50_4 VSUBS 1.23617f
Cext_279 CTX_L30_13 CTX_L30_15 32.4616a
Cext_280 CTX_L30_13 CTX_L30_5|CTX_L50_14 3.38527a
Cext_281 CTX_L30_13 CTX_L30_9|CTX_L50_11 29.4413a
Cext_282 CTX_L30_13 CTX_L8_2 0.125841a
Cext_283 CTX_L30_13 VSUBS 186.668a
Cext_284 CTX_L30_15 CTX_L30_16 128.785a
Cext_285 CTX_L30_15 CTX_L30_5|CTX_L50_14 3.38527a
Cext_286 CTX_L30_15 CTX_L30_7|CTX_L50_17 0.121885a
Cext_287 CTX_L30_15 CTX_L30_9|CTX_L50_11 31.5779a
Cext_288 CTX_L30_15 CTX_L8_2 0.249311a
Cext_289 CTX_L30_15 VSUBS 213.947a
Cext_290 CTX_L30_16 CTX_L30_17 38.1694a
Cext_291 CTX_L30_16 CTX_L30_5|CTX_L50_14 3.38527a
Cext_292 CTX_L30_16 CTX_L30_7|CTX_L50_17 0.121885a
Cext_293 CTX_L30_16 CTX_L30_9|CTX_L50_11 31.4573a
Cext_294 CTX_L30_16 CTX_L8_2 0.249311a
Cext_295 CTX_L30_16 VSUBS 203.065a
Cext_296 CTX_L30_17 CTX_L30_19|CTX_L50_18 32.4616a
Cext_297 CTX_L30_17 CTX_L30_5|CTX_L50_14 3.38527a
Cext_298 CTX_L30_17 CTX_L30_7|CTX_L50_17 0.121885a
Cext_299 CTX_L30_17 CTX_L30_9|CTX_L50_11 33.2739a
Cext_300 CTX_L30_17 CTX_L8_2 0.125841a
Cext_301 CTX_L30_17 VSUBS 285.11a
Cext_302 CTX_L30_19|CTX_L50_18 CTX_L30_20|CTX_L30_6|N 2.64463a
Cext_303 CTX_L30_19|CTX_L50_18 CTX_L30_23|CTX_L50_15 22.0145a
Cext_304 CTX_L30_19|CTX_L50_18 CTX_L30_25|CTX_L50_12|CTX_L50_7|CTX_L67_4
+ 0.104234a
Cext_305 CTX_L30_19|CTX_L50_18 CTX_L30_26|CTX_L50_5|CTX_L50_9|CTX_L67_2
+ 0.229607a
Cext_306 CTX_L30_19|CTX_L50_18 CTX_L30_32|CTX_L50_13 26.5445a
Cext_307 CTX_L30_19|CTX_L50_18 CTX_L30_34|CTX_L50_20 17.1935a
Cext_308 CTX_L30_19|CTX_L50_18 CTX_L30_35|CTX_L50_19 658.199a
Cext_309 CTX_L30_19|CTX_L50_18 CTX_L30_36|CTX_L50_16 19.9391a
Cext_310 CTX_L30_19|CTX_L50_18 CTX_L30_5|CTX_L50_14 31.9887a
Cext_311 CTX_L30_19|CTX_L50_18 CTX_L30_7|CTX_L50_17 3.53875f
Cext_312 CTX_L30_19|CTX_L50_18 CTX_L30_9|CTX_L50_11 29.4413a
Cext_313 CTX_L30_19|CTX_L50_18 CTX_L50_21 458.707a
Cext_314 CTX_L30_19|CTX_L50_18 CTX_L50_22 0.143084a
Cext_315 CTX_L30_19|CTX_L50_18 P 0.100382a
Cext_316 CTX_L30_19|CTX_L50_18 VSUBS 587.66a
Cext_317 CTX_L30_20|CTX_L30_6|N CTX_L30_5|CTX_L50_14 406.411a
Cext_318 CTX_L30_20|CTX_L30_6|N CTX_L30_7|CTX_L50_17 227.029a
Cext_319 CTX_L30_20|CTX_L30_6|N CTX_L30_9|CTX_L50_11 0.220457a
Cext_320 CTX_L30_20|CTX_L30_6|N CTX_L50_21 30.8926a
Cext_321 CTX_L30_20|CTX_L30_6|N CTX_L50_22 24.1104a
Cext_322 CTX_L30_20|CTX_L30_6|N CTX_L8_2 80.608a
Cext_323 CTX_L30_20|CTX_L30_6|N P 5.20256f
Cext_324 CTX_L30_20|CTX_L30_6|N VSUBS 1.51261f
Cext_325 CTX_L30_23|CTX_L50_15 CTX_L30_24|CTX_L50_10 28.7369a
Cext_326 CTX_L30_23|CTX_L50_15 CTX_L30_25|CTX_L50_12|CTX_L50_7|CTX_L67_4
+ 2.39427a
Cext_327 CTX_L30_23|CTX_L50_15 CTX_L30_26|CTX_L50_5|CTX_L50_9|CTX_L67_2 129.788a
Cext_328 CTX_L30_23|CTX_L50_15 CTX_L30_27 0.460629a
Cext_329 CTX_L30_23|CTX_L50_15 CTX_L30_30|CTX_L50_6|CTX_L50_8|CTX_L67_3
+ 0.763809a
Cext_330 CTX_L30_23|CTX_L50_15 CTX_L30_32|CTX_L50_13 31.4136a
Cext_331 CTX_L30_23|CTX_L50_15 CTX_L30_35|CTX_L50_19 0.105401a
Cext_332 CTX_L30_23|CTX_L50_15 CTX_L30_36|CTX_L50_16 133.661a
Cext_333 CTX_L30_23|CTX_L50_15 CTX_L30_5|CTX_L50_14 1.02581f
Cext_334 CTX_L30_23|CTX_L50_15 CTX_L30_7|CTX_L50_17 366.359a
Cext_335 CTX_L30_23|CTX_L50_15 CTX_L30_9|CTX_L50_11 36.9628a
Cext_336 CTX_L30_23|CTX_L50_15 VSUBS 559.222a
Cext_337 CTX_L30_24|CTX_L50_10 CTX_L30_25|CTX_L50_12|CTX_L50_7|CTX_L67_4
+ 161.532a
Cext_338 CTX_L30_24|CTX_L50_10 CTX_L30_26|CTX_L50_5|CTX_L50_9|CTX_L67_2 1.21948f
Cext_339 CTX_L30_24|CTX_L50_10 CTX_L30_27 15.6369a
Cext_340 CTX_L30_24|CTX_L50_10 CTX_L30_30|CTX_L50_6|CTX_L50_8|CTX_L67_3 43.6186a
Cext_341 CTX_L30_24|CTX_L50_10 CTX_L30_32|CTX_L50_13 0.217948a
Cext_342 CTX_L30_24|CTX_L50_10 CTX_L30_5|CTX_L50_14 1.5905a
Cext_343 CTX_L30_24|CTX_L50_10 CTX_L30_7|CTX_L50_17 0.121885a
Cext_344 CTX_L30_24|CTX_L50_10 CTX_L30_9|CTX_L50_11 1.99262f
Cext_345 CTX_L30_24|CTX_L50_10 VSUBS 350.827a
Cext_346 CTX_L30_25|CTX_L50_12|CTX_L50_7|CTX_L67_4
+ CTX_L30_26|CTX_L50_5|CTX_L50_9|CTX_L67_2 382.483a
Cext_347 CTX_L30_25|CTX_L50_12|CTX_L50_7|CTX_L67_4 CTX_L30_27 28.1542a
Cext_348 CTX_L30_25|CTX_L50_12|CTX_L50_7|CTX_L67_4
+ CTX_L30_30|CTX_L50_6|CTX_L50_8|CTX_L67_3 357.766a
Cext_349 CTX_L30_25|CTX_L50_12|CTX_L50_7|CTX_L67_4 CTX_L30_32|CTX_L50_13
+ 494.774a
Cext_350 CTX_L30_25|CTX_L50_12|CTX_L50_7|CTX_L67_4 CTX_L30_34|CTX_L50_20
+ 0.115272a
Cext_351 CTX_L30_25|CTX_L50_12|CTX_L50_7|CTX_L67_4 CTX_L30_35|CTX_L50_19
+ 0.392832a
Cext_352 CTX_L30_25|CTX_L50_12|CTX_L50_7|CTX_L67_4 CTX_L30_36|CTX_L50_16
+ 1.13687a
Cext_353 CTX_L30_25|CTX_L50_12|CTX_L50_7|CTX_L67_4 CTX_L30_5|CTX_L50_14 159.979a
Cext_354 CTX_L30_25|CTX_L50_12|CTX_L50_7|CTX_L67_4 CTX_L30_7|CTX_L50_17 0.25215a
Cext_355 CTX_L30_25|CTX_L50_12|CTX_L50_7|CTX_L67_4 CTX_L30_9|CTX_L50_11 966.329a
Cext_356 CTX_L30_25|CTX_L50_12|CTX_L50_7|CTX_L67_4 VSUBS 250.56a
Cext_357 CTX_L30_26|CTX_L50_5|CTX_L50_9|CTX_L67_2 CTX_L30_27 347.218a
Cext_358 CTX_L30_26|CTX_L50_5|CTX_L50_9|CTX_L67_2
+ CTX_L30_30|CTX_L50_6|CTX_L50_8|CTX_L67_3 918.85a
Cext_359 CTX_L30_26|CTX_L50_5|CTX_L50_9|CTX_L67_2 CTX_L30_32|CTX_L50_13 29.9789a
Cext_360 CTX_L30_26|CTX_L50_5|CTX_L50_9|CTX_L67_2 CTX_L30_5|CTX_L50_14 182.15a
Cext_361 CTX_L30_26|CTX_L50_5|CTX_L50_9|CTX_L67_2 CTX_L30_7|CTX_L50_17 0.327282a
Cext_362 CTX_L30_26|CTX_L50_5|CTX_L50_9|CTX_L67_2 CTX_L30_9|CTX_L50_11 51.3113a
Cext_363 CTX_L30_26|CTX_L50_5|CTX_L50_9|CTX_L67_2 VSUBS 347.16a
Cext_364 CTX_L30_27 CTX_L30_30|CTX_L50_6|CTX_L50_8|CTX_L67_3 323.11a
Cext_365 CTX_L30_27 CTX_L30_32|CTX_L50_13 2.22693a
Cext_366 CTX_L30_27 CTX_L30_5|CTX_L50_14 3.51621a
Cext_367 CTX_L30_27 CTX_L30_7|CTX_L50_17 0.112743a
Cext_368 CTX_L30_27 CTX_L30_9|CTX_L50_11 19.3347a
Cext_369 CTX_L30_27 VSUBS 74.9475a
Cext_370 CTX_L30_28|CTX_L50_27 CTX_L30_29|CTX_L50_26 1.77086f
Cext_371 CTX_L30_28|CTX_L50_27 CTX_L30_31|CTX_L50_25 22.5158a
Cext_372 CTX_L30_28|CTX_L50_27 CTX_L30_32|CTX_L50_13 119.601a
Cext_373 CTX_L30_28|CTX_L50_27 CTX_L30_33|CTX_L50_24 22.5158a
Cext_374 CTX_L30_28|CTX_L50_27 CTX_L30_34|CTX_L50_20 22.5158a
Cext_375 CTX_L30_28|CTX_L50_27 CTX_L30_35|CTX_L50_19 22.5158a
Cext_376 CTX_L30_28|CTX_L50_27 CTX_L30_36|CTX_L50_16 24.969a
Cext_377 CTX_L30_28|CTX_L50_27 P 4.09145a
Cext_378 CTX_L30_28|CTX_L50_27 VSUBS 261.219a
Cext_379 CTX_L30_29|CTX_L50_26 CTX_L30_31|CTX_L50_25 2.18541f
Cext_380 CTX_L30_29|CTX_L50_26 CTX_L30_32|CTX_L50_13 22.837a
Cext_381 CTX_L30_29|CTX_L50_26 CTX_L30_33|CTX_L50_24 18.0477a
Cext_382 CTX_L30_29|CTX_L50_26 CTX_L30_34|CTX_L50_20 18.0477a
Cext_383 CTX_L30_29|CTX_L50_26 CTX_L30_35|CTX_L50_19 18.0477a
Cext_384 CTX_L30_29|CTX_L50_26 CTX_L30_36|CTX_L50_16 20.5009a
Cext_385 CTX_L30_29|CTX_L50_26 P 5.70827a
Cext_386 CTX_L30_29|CTX_L50_26 VSUBS 123.826a
Cext_387 CTX_L30_30|CTX_L50_6|CTX_L50_8|CTX_L67_3 CTX_L30_32|CTX_L50_13 70.7002a
Cext_388 CTX_L30_30|CTX_L50_6|CTX_L50_8|CTX_L67_3 CTX_L30_5|CTX_L50_14 43.2477a
Cext_389 CTX_L30_30|CTX_L50_6|CTX_L50_8|CTX_L67_3 CTX_L30_7|CTX_L50_17 0.121885a
Cext_390 CTX_L30_30|CTX_L50_6|CTX_L50_8|CTX_L67_3 CTX_L30_9|CTX_L50_11 44.116a
Cext_391 CTX_L30_30|CTX_L50_6|CTX_L50_8|CTX_L67_3 VSUBS 424.556a
Cext_392 CTX_L30_31|CTX_L50_25 CTX_L30_32|CTX_L50_13 15.8099a
Cext_393 CTX_L30_31|CTX_L50_25 CTX_L30_33|CTX_L50_24 2.36331f
Cext_394 CTX_L30_31|CTX_L50_25 CTX_L30_34|CTX_L50_20 16.477a
Cext_395 CTX_L30_31|CTX_L50_25 CTX_L30_35|CTX_L50_19 16.477a
Cext_396 CTX_L30_31|CTX_L50_25 CTX_L30_36|CTX_L50_16 22.1504a
Cext_397 CTX_L30_31|CTX_L50_25 P 7.74997a
Cext_398 CTX_L30_31|CTX_L50_25 VSUBS 125.293a
Cext_399 CTX_L30_32|CTX_L50_13 CTX_L30_33|CTX_L50_24 17.8393a
Cext_400 CTX_L30_32|CTX_L50_13 CTX_L30_34|CTX_L50_20 481.218a
Cext_401 CTX_L30_32|CTX_L50_13 CTX_L30_35|CTX_L50_19 62.0865a
Cext_402 CTX_L30_32|CTX_L50_13 CTX_L30_36|CTX_L50_16 54.1715a
Cext_403 CTX_L30_32|CTX_L50_13 CTX_L30_5|CTX_L50_14 534.072a
Cext_404 CTX_L30_32|CTX_L50_13 CTX_L30_7|CTX_L50_17 26.3526a
Cext_405 CTX_L30_32|CTX_L50_13 CTX_L30_9|CTX_L50_11 71.1435a
Cext_406 CTX_L30_32|CTX_L50_13 CTX_L50_21 28.3037a
Cext_407 CTX_L30_32|CTX_L50_13 CTX_L50_22 28.6731a
Cext_408 CTX_L30_32|CTX_L50_13 P 72.886a
Cext_409 CTX_L30_32|CTX_L50_13 VSUBS 1.1968f
Cext_410 CTX_L30_33|CTX_L50_24 CTX_L30_34|CTX_L50_20 2.27394f
Cext_411 CTX_L30_33|CTX_L50_24 CTX_L30_35|CTX_L50_19 18.9334a
Cext_412 CTX_L30_33|CTX_L50_24 CTX_L30_36|CTX_L50_16 24.6068a
Cext_413 CTX_L30_33|CTX_L50_24 P 132.29a
Cext_414 CTX_L30_33|CTX_L50_24 VSUBS 151.463a
Cext_415 CTX_L30_34|CTX_L50_20 CTX_L30_35|CTX_L50_19 3.23606f
Cext_416 CTX_L30_34|CTX_L50_20 CTX_L30_36|CTX_L50_16 19.2271a
Cext_417 CTX_L30_34|CTX_L50_20 CTX_L30_7|CTX_L50_17 0.217948a
Cext_418 CTX_L30_34|CTX_L50_20 CTX_L50_21 740.441a
Cext_419 CTX_L30_34|CTX_L50_20 CTX_L50_22 10.6303a
Cext_420 CTX_L30_34|CTX_L50_20 P 16.01a
Cext_421 CTX_L30_34|CTX_L50_20 VSUBS 145.928a
Cext_422 CTX_L30_35|CTX_L50_19 CTX_L30_36|CTX_L50_16 3.20437f
Cext_423 CTX_L30_35|CTX_L50_19 CTX_L30_7|CTX_L50_17 0.696967a
Cext_424 CTX_L30_35|CTX_L50_19 CTX_L50_21 10.6303a
Cext_425 CTX_L30_35|CTX_L50_19 CTX_L50_22 10.6303a
Cext_426 CTX_L30_35|CTX_L50_19 P 16.01a
Cext_427 CTX_L30_35|CTX_L50_19 VSUBS 125.685a
Cext_428 CTX_L30_36|CTX_L50_16 CTX_L30_5|CTX_L50_14 0.150239a
Cext_429 CTX_L30_36|CTX_L50_16 CTX_L30_7|CTX_L50_17 603.265a
Cext_430 CTX_L30_36|CTX_L50_16 CTX_L50_21 16.3037a
Cext_431 CTX_L30_36|CTX_L50_16 CTX_L50_22 16.3037a
Cext_432 CTX_L30_36|CTX_L50_16 P 21.6834a
Cext_433 CTX_L30_36|CTX_L50_16 VSUBS 386.812a
Cext_434 CTX_L30_5|CTX_L50_14 CTX_L30_7|CTX_L50_17 619.345a
Cext_435 CTX_L30_5|CTX_L50_14 CTX_L30_9|CTX_L50_11 623.824a
Cext_436 CTX_L30_5|CTX_L50_14 CTX_L50_21 25.9612a
Cext_437 CTX_L30_5|CTX_L50_14 CTX_L8_2 2.9824a
Cext_438 CTX_L30_5|CTX_L50_14 VSUBS 1.01306f
Cext_439 CTX_L30_7|CTX_L50_17 CTX_L30_9|CTX_L50_11 1.50813a
Cext_440 CTX_L30_7|CTX_L50_17 CTX_L50_21 623.234a
Cext_441 CTX_L30_7|CTX_L50_17 CTX_L50_22 0.105401a
Cext_442 CTX_L30_7|CTX_L50_17 CTX_L8_2 7.97379a
Cext_443 CTX_L30_7|CTX_L50_17 VSUBS 1.22027f
Cext_444 CTX_L30_9|CTX_L50_11 CTX_L8_2 1.1531a
Cext_445 CTX_L30_9|CTX_L50_11 VSUBS 1.59659f
Cext_446 CTX_L50_21 CTX_L50_22 12.1025f
Cext_447 CTX_L50_21 CTX_L8_2 23.7458a
Cext_448 CTX_L50_21 VSUBS 1.23174f
Cext_449 CTX_L50_22 CTX_L8_2 56.9286a
Cext_450 CTX_L50_22 P 12.1025f
Cext_451 CTX_L50_22 VSUBS 292.465a
Cext_452 CTX_L8_2 P 136.237a
Cext_453 CTX_L8_2 VSUBS 4.98119f
Cext_454 P VSUBS 1.01264f
.ENDS sense_fill_clip
