* no_fill grounded drive N; diagnostic capacitor-network AC only
C5 0 P 1.04575e-18
C16 0 N 1.1109800000000002e-19
C32 0 N 3.0026200000000004e-17
C35 0 P 2.2810199999999999e-17
C47 0 N 9.1250900000000002e-17
C55 0 P 7.6041600000000007e-17
C63 0 N 7.5519000000000015e-16
C71 0 P 2.94672e-17
C85 0 N 3.4678400000000008e-17
C93 0 P 2.71922e-18
C97 0 N 3.8936900000000001e-17
C104 0 P 4.6991100000000004e-18
C116 0 N 2.6562100000000001e-17
C124 0 P 3.9514000000000007e-17
C130 0 N 7.9999000000000001e-17
C138 0 P 5.6305700000000007e-17
C144 0 N 5.0724699999999999e-17
C152 0 P 1.55918e-17
C159 0 N 4.0606000000000007e-17
C167 0 P 1.5622000000000002e-17
C182 0 P 2.9728400000000003e-17
C208 0 N 4.2094100000000001e-16
C216 0 P 1.5244999999999999e-16
C218 0 N 2.6446300000000002e-18
C225 0 P 1.0038200000000001e-19
C227 N 0 4.0641100000000005e-16
C228 N 0 2.27029e-16
C229 N 0 2.20457e-19
C230 N 0 3.0892600000000002e-17
C231 N 0 2.4110400000000001e-17
C232 N 0 8.0608000000000007e-17
C233 N P 5.2025600000000007e-15
C234 N 0 1.5126100000000001e-15
C255 0 P 8.614730000000001e-15
C258 0 P 1.0500300000000001e-16
C260 P 0 6.0328999999999999e-16
VP P 0 DC 0 AC 0
VN N 0 DC 0 AC 1
.control
set numdgt=17
ac lin 1 1Meg 1Meg
let cp = -imag(i(VP))/(2*pi*1e6)
let cn = -imag(i(VN))/(2*pi*1e6)
print cp cn
quit
.endc
.end
