* actual_fill grounded drive N; diagnostic capacitor-network AC only
C14 0 P 1.04575e-18
C32 0 N 1.1109800000000002e-19
C73 0 N 2.21272e-17
C124 0 P 1.9734800000000001e-17
C136 0 N 8.3805000000000013e-17
C216 0 P 7.5935000000000008e-17
C224 0 N 7.5519000000000015e-16
C252 0 P 2.8850100000000003e-17
C266 0 N 3.2527200000000001e-17
C337 0 P 7.7408900000000006e-19
C341 0 N 3.7072699999999998e-17
C379 0 P 4.6991100000000004e-18
C391 0 N 2.5210400000000003e-17
C477 0 P 3.9366000000000005e-17
C483 0 N 4.8670900000000008e-17
C547 0 P 3.6815300000000002e-17
C553 0 N 4.3987000000000005e-17
C607 0 P 1.5471200000000001e-17
C614 0 N 2.3292500000000001e-17
C670 0 P 1.5571700000000002e-17
C738 0 P 2.5998100000000003e-17
C792 0 N 3.6715800000000005e-16
C900 0 P 1.5081500000000002e-16
C902 0 N 2.6446300000000002e-18
C926 0 P 1.0038200000000001e-19
C928 N 0 4.0591800000000001e-16
C929 N 0 2.27029e-16
C930 N 0 2.20457e-19
C931 N 0 2.9221800000000006e-17
C932 N 0 2.4110400000000001e-17
C933 N 0 6.0517700000000003e-17
C934 N 0 4.8415300000000002e-19
C935 N 0 9.9145500000000009e-18
C936 N 0 2.35818e-19
C937 N 0 9.6007399999999998e-19
C938 N 0 1.0010300000000001e-17
C939 N 0 9.9396600000000006e-18
C940 N 0 1.2552200000000001e-18
C941 N 0 5.6099900000000005e-18
C942 N 0 9.369080000000001e-18
C943 N 0 9.9647600000000006e-18
C944 N 0 7.4735700000000008e-18
C945 N 0 6.0914400000000011e-18
C946 N 0 1.6145900000000003e-17
C947 N 0 1.1098200000000002e-17
C948 N 0 6.1522000000000003e-18
C949 N 0 1.4599100000000002e-18
C950 N 0 5.1024000000000007e-18
C951 N 0 4.3594600000000008e-18
C952 N 0 4.3594600000000008e-18
C953 N 0 1.8812000000000001e-16
C954 N 0 1.8915400000000002e-16
C955 N 0 6.4560799999999999e-17
C956 N 0 1.06939e-16
C957 N 0 3.1262800000000003e-16
C958 N 0 5.4091600000000007e-18
C959 N 0 7.2083799999999998e-19
C960 N 0 1.33858e-17
C961 N 0 8.38576e-18
C962 N 0 2.2140600000000001e-17
C963 N 0 1.9833200000000001e-19
C964 N 0 1.6070500000000002e-18
C965 N 0 1.23957e-19
C966 N 0 1.6070500000000002e-18
C967 N 0 2.0659600000000002e-19
C968 N 0 1.6070500000000002e-18
C969 N 0 2.0235000000000002e-19
C970 N 0 1.3258900000000001e-17
C971 N 0 1.3105700000000001e-17
C972 N 0 9.8265900000000003e-17
C973 N 0 9.8265900000000003e-17
C974 N 0 2.8268299999999999e-17
C975 N 0 9.8265900000000003e-17
C976 N 0 9.8265900000000003e-17
C977 N 0 2.8268299999999999e-17
C978 N 0 9.8265900000000003e-17
C979 N 0 1.0069900000000001e-16
C980 N 0 4.2291800000000008e-17
C981 N 0 7.57269e-18
C982 N 0 1.07493e-16
C983 N 0 1.9101800000000001e-16
C984 N 0 1.0249800000000002e-16
C985 N 0 5.06222e-19
C986 N 0 5.8904000000000003e-19
C987 N 0 5.2380000000000006e-17
C988 N 0 1.3547200000000001e-17
C989 N 0 9.8265900000000003e-17
C990 N 0 2.8268299999999999e-17
C991 N 0 4.7775400000000009e-19
C992 N 0 1.1198800000000001e-16
C993 N 0 3.8098600000000003e-18
C994 N 0 5.5014100000000008e-19
C995 N 0 5.5014100000000008e-19
C996 N 0 4.4929300000000004e-19
C997 N 0 5.5014100000000008e-19
C998 N 0 4.1260599999999998e-19
C999 N 0 4.4929300000000004e-19
C1000 N 0 7.6799600000000002e-18
C1001 N 0 4.0826600000000001e-18
C1002 N 0 2.5716600000000002e-18
C1003 N 0 3.2205200000000002e-18
C1004 N 0 1.6102600000000001e-18
C1005 N 0 1.0568400000000001e-18
C1006 N 0 1.6102600000000001e-18
C1007 N P 5.2025600000000007e-15
C1008 N 0 8.9196300000000005e-16
C1261 0 P 8.614730000000001e-15
C1381 0 P 1.03377e-16
C1401 0 P 3.7741700000000003e-18
C1411 0 P 9.8917200000000009e-19
C1449 0 P 5.2655800000000004e-18
C1457 0 P 1.00978e-18
C1500 0 P 1.03039e-18
C1514 0 P 1.03039e-18
C1526 0 P 5.1998600000000002e-19
C1550 0 P 1.03039e-18
C1561 0 P 7.727910000000001e-19
C1572 0 P 5.1998600000000002e-19
C1584 0 P 5.3264600000000004e-18
C1638 0 P 1.26457e-18
C1653 0 P 8.9643700000000014e-19
C1681 0 P 3.6374899999999999e-17
C1707 0 P 5.0775300000000004e-17
C1718 0 P 2.3091400000000004e-18
C1733 0 P 8.6288599999999999e-18
C1744 0 P 9.6983799999999997e-19
C1759 0 P 4.9459900000000008e-18
C1767 0 P 8.6552600000000005e-19
C1775 0 P 4.7665400000000005e-19
C1810 0 P 4.0643700000000005e-18
C1835 0 P 5.4776700000000005e-18
C1860 0 P 2.8873199999999999e-18
C1877 0 P 2.8873199999999999e-18
C1898 0 P 2.82957e-18
C1909 0 P 2.8873199999999999e-18
C1929 0 P 2.8873199999999999e-18
C1935 0 P 2.5314100000000004e-19
C1960 0 P 2.8873199999999999e-18
C1967 0 P 2.34989e-18
C1985 0 P 2.4807800000000001e-19
C1998 0 P 2.8873199999999999e-18
C2007 0 P 2.8873199999999999e-18
C2094 0 P 2.1894100000000004e-17
C2100 0 P 5.0331300000000003e-17
C2108 0 P 2.4862500000000002e-17
C2117 0 P 5.0331300000000003e-17
C2122 0 P 5.0331300000000003e-17
C2129 0 P 2.4862500000000002e-17
C2150 0 P 4.4039900000000009e-17
C2230 0 P 1.0245300000000001e-19
C2253 0 P 1.0245300000000001e-19
C2306 0 P 1.8052299999999998e-18
C2310 0 P 1.3216900000000001e-18
C2327 0 P 2.0783900000000003e-18
C2331 0 P 1.93149e-18
C2343 0 P 2.49407e-19
C2347 0 P 2.2074100000000002e-19
C2354 P 0 4.0028400000000004e-16
VP P 0 DC 0 AC 0
VN N 0 DC 0 AC 1
.control
set numdgt=17
ac lin 1 1Meg 1Meg
let cp = -imag(i(VP))/(2*pi*1e6)
let cn = -imag(i(VN))/(2*pi*1e6)
print cp cn
quit
.endc
.end
