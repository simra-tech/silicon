* actual_fill grounded drive P; diagnostic capacitor-network AC only
C4 0 N 1.9407100000000002e-17
C34 0 P 1.7046600000000003e-17
C40 0 N 8.3741000000000011e-17
C106 0 P 7.5935000000000008e-17
C111 0 N 2.5210400000000003e-17
C180 0 P 3.9366000000000005e-17
C182 0 N 4.1690700000000003e-17
C235 0 P 3.6223700000000005e-17
C238 0 N 4.0732400000000004e-17
C273 0 P 1.57728e-17
C275 0 N 2.3292500000000001e-17
C308 0 P 1.5571700000000002e-17
C310 N 0 6.7784899999999994e-17
C311 N 0 3.1007600000000003e-16
C312 N 0 2.6315600000000002e-18
C313 N 0 3.75234e-16
C314 N 0 2.9328299999999998e-17
C315 N 0 2.4187300000000001e-17
C316 N 0 5.22223e-17
C317 N 0 4.8415300000000002e-19
C318 N 0 1.6145900000000003e-17
C319 N 0 1.2552200000000001e-18
C320 N 0 5.6099900000000005e-18
C321 N 0 5.7365300000000002e-18
C322 N 0 9.9647600000000006e-18
C323 N 0 7.4735700000000008e-18
C324 N 0 3.8211000000000004e-18
C325 N 0 1.1098200000000002e-17
C326 N 0 6.1522000000000003e-18
C327 N 0 1.4599100000000002e-18
C328 N 0 6.9751300000000005e-19
C329 N 0 1.8821900000000001e-16
C330 N 0 1.3685600000000002e-17
C331 N 0 3.1120900000000001e-16
C332 N 0 5.4091600000000007e-18
C333 N 0 7.2083799999999998e-19
C334 N 0 9.9145500000000009e-18
C335 N 0 2.35818e-19
C336 N 0 1.0010300000000001e-17
C337 N 0 9.9396600000000006e-18
C338 N 0 5.2807400000000005e-18
C339 N 0 1.6070500000000002e-18
C340 N 0 1.6070500000000002e-18
C341 N 0 2.0235000000000002e-19
C342 N 0 1.3258900000000001e-17
C343 N 0 1.3105700000000001e-17
C344 N 0 2.2140600000000001e-17
C345 N 0 1.6070500000000002e-18
C346 N 0 9.8265900000000003e-17
C347 N 0 2.8268299999999999e-17
C348 N 0 9.8265900000000003e-17
C349 N 0 1.0069900000000001e-16
C350 N 0 3.5841000000000005e-17
C351 N 0 1.0759200000000001e-16
C352 N 0 1.0249800000000002e-16
C353 N 0 5.8904000000000003e-19
C354 N 0 1.3547200000000001e-17
C355 N 0 9.8265900000000003e-17
C356 N 0 2.8268299999999999e-17
C357 N 0 9.8265900000000003e-17
C358 N 0 9.8265900000000003e-17
C359 N 0 2.8268299999999999e-17
C360 N 0 9.8265900000000003e-17
C361 N 0 2.4064600000000002e-19
C362 N 0 3.8098600000000003e-18
C363 N 0 5.5014100000000008e-19
C364 N 0 5.5014100000000008e-19
C365 N 0 4.4929300000000004e-19
C366 N 0 5.5014100000000008e-19
C367 N 0 4.1260599999999998e-19
C368 N 0 4.4929300000000004e-19
C369 N 0 3.8684200000000004e-18
C370 N 0 4.1643499999999997e-18
C371 N 0 2.5936800000000001e-18
C372 N 0 1.6102600000000001e-18
C373 N 0 1.0850900000000002e-18
C374 N 0 1.3003700000000001e-17
C375 N P 5.2026500000000002e-15
C376 N 0 7.7884700000000007e-16
C495 0 P 1.5097600000000002e-16
C515 0 P 1.0038200000000001e-19
C530 0 P 2.89104e-17
C557 0 P 2.5998100000000003e-17
C665 0 P 8.614730000000001e-15
C749 0 P 1.0622100000000001e-16
C759 0 P 3.7741700000000003e-18
C770 0 P 5.3264600000000004e-18
C780 0 P 1.03039e-18
C789 0 P 1.03039e-18
C796 0 P 5.1998600000000002e-19
C804 0 P 1.03039e-18
C811 0 P 7.727910000000001e-19
C820 0 P 5.1998600000000002e-19
C839 0 P 1.26457e-18
C853 0 P 9.0158900000000006e-19
C866 0 P 3.6450800000000003e-17
C884 0 P 5.0775300000000004e-17
C891 0 P 2.32402e-19
C900 0 P 8.6541499999999995e-18
C915 0 P 4.9459900000000008e-18
C923 0 P 8.6552600000000005e-19
C928 0 P 4.7665400000000005e-19
C936 0 P 9.8917200000000009e-19
C952 0 P 5.2655800000000004e-18
C957 0 P 1.00978e-18
C974 0 P 5.4776700000000005e-18
C984 0 P 2.82957e-18
C990 0 P 2.8873199999999999e-18
C1000 0 P 2.8873199999999999e-18
C1005 0 P 2.5314100000000004e-19
C1016 0 P 2.8873199999999999e-18
C1023 0 P 2.34989e-18
C1031 0 P 2.4807800000000001e-19
C1039 0 P 2.8873199999999999e-18
C1047 0 P 2.8873199999999999e-18
C1052 0 P 2.8873199999999999e-18
C1058 0 P 2.8873199999999999e-18
C1095 0 P 2.1894100000000004e-17
C1101 0 P 5.0331300000000003e-17
C1107 0 P 2.4862500000000002e-17
C1111 0 P 5.0331300000000003e-17
C1116 0 P 5.0331300000000003e-17
C1124 0 P 2.4862500000000002e-17
C1128 0 P 4.4039900000000009e-17
C1185 0 P 1.0245300000000001e-19
C1205 0 P 1.0245300000000001e-19
C1236 0 P 1.8052299999999998e-18
C1240 0 P 1.5313900000000001e-18
C1251 0 P 2.0783900000000003e-18
C1255 0 P 1.93149e-18
C1262 0 P 2.49407e-19
C1265 0 P 2.3177900000000004e-19
C1277 P 0 4.2614000000000001e-16
VP P 0 DC 0 AC 1
VN N 0 DC 0 AC 0
.control
set numdgt=17
ac lin 1 1Meg 1Meg
let cp = -imag(i(VP))/(2*pi*1e6)
let cn = -imag(i(VN))/(2*pi*1e6)
print cp cn
quit
.endc
.end
