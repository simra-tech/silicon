* no_fill floating drive P; diagnostic capacitor-network AC only
C4 0 N 2.6050600000000002e-17
C7 0 P 1.9838700000000002e-17
C13 0 N 9.0461500000000008e-17
C23 0 P 7.6041600000000007e-17
C28 0 N 2.6562100000000001e-17
C38 0 P 3.9514000000000007e-17
C40 0 N 6.1855400000000011e-17
C50 0 P 5.3222200000000003e-17
C53 0 N 4.2740300000000001e-17
C59 0 P 1.5813000000000001e-17
C61 0 N 3.4632700000000002e-17
C67 0 P 1.5622000000000002e-17
C69 N 0 6.7784899999999994e-17
C70 N 0 3.6095500000000001e-16
C71 N 0 2.6315600000000002e-18
C72 N 0 3.75234e-16
C73 N 0 3.0999e-17
C74 N 0 2.4187300000000001e-17
C75 N 0 6.4197000000000011e-17
C76 N P 5.2026500000000002e-15
C77 N 0 1.2640300000000001e-15
C91 0 P 1.5261200000000001e-16
C98 0 P 1.0038200000000001e-19
C104 0 P 2.9340700000000003e-17
C110 0 P 2.9541600000000003e-17
C117 0 P 8.614730000000001e-15
C119 0 P 1.0732e-16
C121 P 0 6.2562500000000008e-16
VP P 0 DC 0 AC 1
VN N 0 DC 0 AC 0
.control
set numdgt=17
ac lin 1 1Meg 1Meg
let cp = -imag(i(VP))/(2*pi*1e6)
let cn = -imag(i(VN))/(2*pi*1e6)
print cp cn
quit
.endc
.end
