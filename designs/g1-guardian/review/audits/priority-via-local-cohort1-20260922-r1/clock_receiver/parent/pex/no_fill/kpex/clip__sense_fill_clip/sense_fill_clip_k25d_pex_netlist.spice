*********************************************************
*** NGSPICE file created by KLayout-PEX 0.3.12
*** -----------------------------------------------------
***     Extraction Engine: KPEX/2.5D
***     Technology: ihp_sg13g2
***     Date: 2026-09-22 18:38:44
*********************************************************

.SUBCKT sense_fill_clip
Cext_1 CTX_L10_0|CTX_L30_0 CTX_L134_0 32.398a
Cext_2 CTX_L10_0|CTX_L30_0 CTX_L30_1|CTX_L50_1 325.937a
Cext_3 CTX_L10_0|CTX_L30_0 CTX_L30_3 21.4559a
Cext_4 CTX_L10_0|CTX_L30_0 CTX_L8_0 47.8457a
Cext_5 CTX_L10_0|CTX_L30_0 P|PSEG_L50_0 43.5099a
Cext_6 CTX_L10_0|CTX_L30_0 VSUBS 937.863a
Cext_7 CTX_L134_0 CTX_L30_1|CTX_L50_1 39.2207a
Cext_8 CTX_L134_0 CTX_L8_0 22.3768a
Cext_9 CTX_L134_0 P|PSEG_L50_0 34.7399a
Cext_10 CTX_L134_0 VSUBS 926.707a
Cext_11 CTX_L30_1|CTX_L50_1 CTX_L30_3 92.1172a
Cext_12 CTX_L30_1|CTX_L50_1 CTX_L8_0 50.7659a
Cext_13 CTX_L30_1|CTX_L50_1 P|PSEG_L50_0 1.11457f
Cext_14 CTX_L30_1|CTX_L50_1 VSUBS 629.563a
Cext_15 CTX_L30_3 CTX_L8_0 31.8924a
Cext_16 CTX_L30_3 P|PSEG_L50_0 47.8645a
Cext_17 CTX_L30_3 VSUBS 465.56a
Cext_18 CTX_L8_0 P|PSEG_L50_0 24.9122a
Cext_19 CTX_L8_0 VSUBS 1.0799f
Cext_20 P|PSEG_L50_0 VSUBS 429.993a
.ENDS sense_fill_clip
