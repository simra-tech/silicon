*********************************************************
*** NGSPICE file created by KLayout-PEX 0.3.12
*** -----------------------------------------------------
***     Extraction Engine: KPEX/2.5D
***     Technology: ihp_sg13g2
***     Date: 2026-09-22 18:38:48
*********************************************************

.SUBCKT sense_fill_clip
Cext_1 CTX_L10_0|CTX_L30_0 CTX_L134_0 11.982a
Cext_2 CTX_L10_0|CTX_L30_0 CTX_L30_1|CTX_L50_1 322.802a
Cext_3 CTX_L10_0|CTX_L30_0 CTX_L30_3 18.6239a
Cext_4 CTX_L10_0|CTX_L30_0 CTX_L8_0 47.2878a
Cext_5 CTX_L10_0|CTX_L30_0 FILL_L10_0 7.22267a
Cext_6 CTX_L10_0|CTX_L30_0 FILL_L10_10 63.34a
Cext_7 CTX_L10_0|CTX_L30_0 FILL_L10_11 19.5334a
Cext_8 CTX_L10_0|CTX_L30_0 FILL_L10_12 3.36627a
Cext_9 CTX_L10_0|CTX_L30_0 FILL_L10_13 12.0655a
Cext_10 CTX_L10_0|CTX_L30_0 FILL_L10_14 57.006a
Cext_11 CTX_L10_0|CTX_L30_0 FILL_L10_2 14.3144a
Cext_12 CTX_L10_0|CTX_L30_0 FILL_L10_3 62.8598a
Cext_13 CTX_L10_0|CTX_L30_0 FILL_L10_4 65.1349a
Cext_14 CTX_L10_0|CTX_L30_0 FILL_L10_5 2.44186a
Cext_15 CTX_L10_0|CTX_L30_0 FILL_L10_6 13.2753a
Cext_16 CTX_L10_0|CTX_L30_0 FILL_L10_7 63.34a
Cext_17 CTX_L10_0|CTX_L30_0 FILL_L10_8 28.4721a
Cext_18 CTX_L10_0|CTX_L30_0 FILL_L10_9 13.2753a
Cext_19 CTX_L10_0|CTX_L30_0 FILL_L126_0 61.5834a
Cext_20 CTX_L10_0|CTX_L30_0 FILL_L126_1 57.1515a
Cext_21 CTX_L10_0|CTX_L30_0 FILL_L126_2 20.7561a
Cext_22 CTX_L10_0|CTX_L30_0 FILL_L134_0 1.89124a
Cext_23 CTX_L10_0|CTX_L30_0 FILL_L30_1 2.00903a
Cext_24 CTX_L10_0|CTX_L30_0 FILL_L30_3 1.84682a
Cext_25 CTX_L10_0|CTX_L30_0 FILL_L30_4 64.7902a
Cext_26 CTX_L10_0|CTX_L30_0 FILL_L30_5 2.47285a
Cext_27 CTX_L10_0|CTX_L30_0 FILL_L30_6 3.34094a
Cext_28 CTX_L10_0|CTX_L30_0 FILL_L50_0 7.3254a
Cext_29 CTX_L10_0|CTX_L30_0 FILL_L50_1 19.3525a
Cext_30 CTX_L10_0|CTX_L30_0 FILL_L50_2 0.677039a
Cext_31 CTX_L10_0|CTX_L30_0 FILL_L50_3 9.97519a
Cext_32 CTX_L10_0|CTX_L30_0 FILL_L50_4 17.1577a
Cext_33 CTX_L10_0|CTX_L30_0 FILL_L8_1 0.898027a
Cext_34 CTX_L10_0|CTX_L30_0 FILL_L8_10 2.4305a
Cext_35 CTX_L10_0|CTX_L30_0 FILL_L8_2 3.12352a
Cext_36 CTX_L10_0|CTX_L30_0 FILL_L8_3 0.184372a
Cext_37 CTX_L10_0|CTX_L30_0 FILL_L8_4 2.56553a
Cext_38 CTX_L10_0|CTX_L30_0 FILL_L8_5 1.03421a
Cext_39 CTX_L10_0|CTX_L30_0 FILL_L8_6 2.70056a
Cext_40 CTX_L10_0|CTX_L30_0 FILL_L8_7 0.415028a
Cext_41 CTX_L10_0|CTX_L30_0 P|PSEG_L50_0 43.2078a
Cext_42 CTX_L10_0|CTX_L30_0 VSUBS 724.301a
Cext_43 CTX_L134_0 CTX_L30_1|CTX_L50_1 24.7494a
Cext_44 CTX_L134_0 CTX_L8_0 11.2708a
Cext_45 CTX_L134_0 FILL_L10_0 4.89923a
Cext_46 CTX_L134_0 FILL_L10_1 1.95616a
Cext_47 CTX_L134_0 FILL_L10_10 2.69314a
Cext_48 CTX_L134_0 FILL_L10_11 22.1009a
Cext_49 CTX_L134_0 FILL_L10_12 2.53991a
Cext_50 CTX_L134_0 FILL_L10_2 2.79057a
Cext_51 CTX_L134_0 FILL_L10_3 2.22264a
Cext_52 CTX_L134_0 FILL_L10_5 12.9949a
Cext_53 CTX_L134_0 FILL_L10_6 3.7359a
Cext_54 CTX_L134_0 FILL_L10_7 3.31508a
Cext_55 CTX_L134_0 FILL_L10_8 2.45316a
Cext_56 CTX_L134_0 FILL_L10_9 3.55911a
Cext_57 CTX_L134_0 FILL_L126_0 239.258a
Cext_58 CTX_L134_0 FILL_L126_1 363.006a
Cext_59 CTX_L134_0 FILL_L134_0 126.53a
Cext_60 CTX_L134_0 FILL_L30_0 4.05197a
Cext_61 CTX_L134_0 FILL_L30_2 0.959323a
Cext_62 CTX_L134_0 FILL_L30_3 3.99718a
Cext_63 CTX_L134_0 FILL_L30_5 3.99718a
Cext_64 CTX_L134_0 FILL_L50_0 3.59495a
Cext_65 CTX_L134_0 FILL_L50_2 4.04748a
Cext_66 CTX_L134_0 FILL_L50_3 4.007a
Cext_67 CTX_L134_0 FILL_L8_0 0.164945a
Cext_68 CTX_L134_0 FILL_L8_1 2.24708a
Cext_69 CTX_L134_0 FILL_L8_3 0.47477a
Cext_70 CTX_L134_0 P|PSEG_L50_0 13.1894a
Cext_71 CTX_L134_0 VSUBS 658.727a
Cext_72 CTX_L30_1|CTX_L50_1 CTX_L30_3 92.1172a
Cext_73 CTX_L30_1|CTX_L50_1 CTX_L8_0 50.3289a
Cext_74 CTX_L30_1|CTX_L50_1 FILL_L10_0 7.37555a
Cext_75 CTX_L30_1|CTX_L50_1 FILL_L10_1 0.769621a
Cext_76 CTX_L30_1|CTX_L50_1 FILL_L10_10 4.25022a
Cext_77 CTX_L30_1|CTX_L50_1 FILL_L10_11 6.51681a
Cext_78 CTX_L30_1|CTX_L50_1 FILL_L10_12 1.90726a
Cext_79 CTX_L30_1|CTX_L50_1 FILL_L10_13 0.166192a
Cext_80 CTX_L30_1|CTX_L50_1 FILL_L10_14 3.8252a
Cext_81 CTX_L30_1|CTX_L50_1 FILL_L10_15 2.39393a
Cext_82 CTX_L30_1|CTX_L50_1 FILL_L10_2 2.55792a
Cext_83 CTX_L30_1|CTX_L50_1 FILL_L10_3 42.4498a
Cext_84 CTX_L30_1|CTX_L50_1 FILL_L10_5 0.312602a
Cext_85 CTX_L30_1|CTX_L50_1 FILL_L10_6 10.9291a
Cext_86 CTX_L30_1|CTX_L50_1 FILL_L10_7 4.03771a
Cext_87 CTX_L30_1|CTX_L50_1 FILL_L10_8 62.9514a
Cext_88 CTX_L30_1|CTX_L50_1 FILL_L10_9 9.15144a
Cext_89 CTX_L30_1|CTX_L50_1 FILL_L126_0 97.74a
Cext_90 CTX_L30_1|CTX_L50_1 FILL_L126_1 30.2935a
Cext_91 CTX_L30_1|CTX_L50_1 FILL_L126_2 31.752a
Cext_92 CTX_L30_1|CTX_L50_1 FILL_L134_0 2.8196a
Cext_93 CTX_L30_1|CTX_L50_1 FILL_L30_0 0.280035a
Cext_94 CTX_L30_1|CTX_L50_1 FILL_L30_1 3.93602a
Cext_95 CTX_L30_1|CTX_L50_1 FILL_L30_3 16.9019a
Cext_96 CTX_L30_1|CTX_L50_1 FILL_L30_4 2.02701a
Cext_97 CTX_L30_1|CTX_L50_1 FILL_L30_6 0.22149a
Cext_98 CTX_L30_1|CTX_L50_1 FILL_L50_0 11.837a
Cext_99 CTX_L30_1|CTX_L50_1 FILL_L50_1 67.4151a
Cext_100 CTX_L30_1|CTX_L50_1 FILL_L50_2 13.371a
Cext_101 CTX_L30_1|CTX_L50_1 FILL_L50_3 44.8605a
Cext_102 CTX_L30_1|CTX_L50_1 FILL_L50_4 44.8605a
Cext_103 CTX_L30_1|CTX_L50_1 FILL_L8_0 0.220214a
Cext_104 CTX_L30_1|CTX_L50_1 FILL_L8_3 0.127097a
Cext_105 CTX_L30_1|CTX_L50_1 FILL_L8_5 4.21204a
Cext_106 CTX_L30_1|CTX_L50_1 FILL_L8_8 0.123318a
Cext_107 CTX_L30_1|CTX_L50_1 P|PSEG_L50_0 1.11457f
Cext_108 CTX_L30_1|CTX_L50_1 VSUBS 472.526a
Cext_109 CTX_L30_3 CTX_L8_0 25.1048a
Cext_110 CTX_L30_3 FILL_L10_12 8.6264a
Cext_111 CTX_L30_3 FILL_L10_13 247.574a
Cext_112 CTX_L30_3 FILL_L10_14 5.16237a
Cext_113 CTX_L30_3 FILL_L10_15 1.67183a
Cext_114 CTX_L30_3 FILL_L10_6 0.536707a
Cext_115 CTX_L30_3 FILL_L10_8 1.02445a
Cext_116 CTX_L30_3 FILL_L10_9 5.73597a
Cext_117 CTX_L30_3 FILL_L126_0 11.9976a
Cext_118 CTX_L30_3 FILL_L126_2 49.1712a
Cext_119 CTX_L30_3 FILL_L134_0 24.5397a
Cext_120 CTX_L30_3 FILL_L30_2 3.06022a
Cext_121 CTX_L30_3 FILL_L30_3 12.7509a
Cext_122 CTX_L30_3 FILL_L50_2 3.43136a
Cext_123 CTX_L30_3 FILL_L8_10 2.29495a
Cext_124 CTX_L30_3 FILL_L8_8 0.916788a
Cext_125 CTX_L30_3 FILL_L8_9 3.94458a
Cext_126 CTX_L30_3 P|PSEG_L50_0 38.3971a
Cext_127 CTX_L30_3 VSUBS 394.976a
Cext_128 CTX_L8_0 FILL_L10_0 5.51993a
Cext_129 CTX_L8_0 FILL_L10_1 1.06945a
Cext_130 CTX_L8_0 FILL_L10_12 0.146254a
Cext_131 CTX_L8_0 FILL_L10_13 6.93657a
Cext_132 CTX_L8_0 FILL_L10_2 0.304207a
Cext_133 CTX_L8_0 FILL_L10_3 5.42059a
Cext_134 CTX_L8_0 FILL_L10_5 0.307125a
Cext_135 CTX_L8_0 FILL_L10_6 5.34993a
Cext_136 CTX_L8_0 FILL_L10_8 0.365634a
Cext_137 CTX_L8_0 FILL_L10_9 5.51993a
Cext_138 CTX_L8_0 FILL_L126_0 19.1054a
Cext_139 CTX_L8_0 FILL_L126_1 29.4663a
Cext_140 CTX_L8_0 FILL_L126_2 10.4171a
Cext_141 CTX_L8_0 FILL_L134_0 2.02919a
Cext_142 CTX_L8_0 FILL_L30_0 0.817086a
Cext_143 CTX_L8_0 FILL_L30_1 1.11031a
Cext_144 CTX_L8_0 FILL_L30_2 0.110828a
Cext_145 CTX_L8_0 FILL_L30_3 6.77773a
Cext_146 CTX_L8_0 FILL_L30_4 6.75063a
Cext_147 CTX_L8_0 FILL_L30_5 1.28712a
Cext_148 CTX_L8_0 FILL_L30_6 2.1042a
Cext_149 CTX_L8_0 FILL_L50_0 1.163a
Cext_150 CTX_L8_0 FILL_L50_1 0.311084a
Cext_151 CTX_L8_0 FILL_L50_2 0.893733a
Cext_152 CTX_L8_0 FILL_L50_3 1.92171a
Cext_153 CTX_L8_0 FILL_L50_4 4.09187a
Cext_154 CTX_L8_0 FILL_L8_0 13.2848a
Cext_155 CTX_L8_0 FILL_L8_1 16.7401a
Cext_156 CTX_L8_0 FILL_L8_10 11.9563a
Cext_157 CTX_L8_0 FILL_L8_2 13.2848a
Cext_158 CTX_L8_0 FILL_L8_3 9.24351a
Cext_159 CTX_L8_0 FILL_L8_4 13.2848a
Cext_160 CTX_L8_0 FILL_L8_5 22.5347a
Cext_161 CTX_L8_0 FILL_L8_6 13.2848a
Cext_162 CTX_L8_0 FILL_L8_7 9.24351a
Cext_163 CTX_L8_0 FILL_L8_8 6.43849a
Cext_164 CTX_L8_0 FILL_L8_9 6.52574a
Cext_165 CTX_L8_0 P|PSEG_L50_0 24.2849a
Cext_166 CTX_L8_0 VSUBS 984.665a
Cext_167 FILL_L10_0 FILL_L10_1 10.3305a
Cext_168 FILL_L10_0 FILL_L10_2 20.8343a
Cext_169 FILL_L10_0 FILL_L10_3 27.9352a
Cext_170 FILL_L10_0 FILL_L126_0 14.6478a
Cext_171 FILL_L10_0 FILL_L126_1 6.12401a
Cext_172 FILL_L10_0 FILL_L30_0 0.686534a
Cext_173 FILL_L10_0 FILL_L50_0 9.37567a
Cext_174 FILL_L10_0 FILL_L8_1 2.37582a
Cext_175 FILL_L10_0 P|PSEG_L50_0 0.755529a
Cext_176 FILL_L10_0 VSUBS 109.879a
Cext_177 FILL_L10_1 FILL_L10_4 27.9352a
Cext_178 FILL_L10_1 FILL_L10_5 27.9352a
Cext_179 FILL_L10_1 FILL_L126_1 20.0006a
Cext_180 FILL_L10_1 FILL_L30_0 30.3306a
Cext_181 FILL_L10_1 FILL_L8_0 67.225a
Cext_182 FILL_L10_1 P|PSEG_L50_0 7.51172a
Cext_183 FILL_L10_1 VSUBS 88.4823a
Cext_184 FILL_L10_10 FILL_L10_11 27.9352a
Cext_185 FILL_L10_10 FILL_L10_14 27.9352a
Cext_186 FILL_L10_10 FILL_L10_7 27.9352a
Cext_187 FILL_L10_10 FILL_L126_1 4.82009a
Cext_188 FILL_L10_10 FILL_L126_2 13.0377a
Cext_189 FILL_L10_10 FILL_L134_0 3.52681a
Cext_190 FILL_L10_10 FILL_L8_6 67.225a
Cext_191 FILL_L10_10 VSUBS 48.8509a
Cext_192 FILL_L10_11 FILL_L10_15 49.166a
Cext_193 FILL_L10_11 FILL_L10_5 49.166a
Cext_194 FILL_L10_11 FILL_L10_7 27.9352a
Cext_195 FILL_L10_11 FILL_L126_1 29.2775a
Cext_196 FILL_L10_11 FILL_L126_2 30.3899a
Cext_197 FILL_L10_11 FILL_L134_0 14.9583a
Cext_198 FILL_L10_11 FILL_L30_4 0.331181a
Cext_199 FILL_L10_11 FILL_L30_5 62.4976a
Cext_200 FILL_L10_11 FILL_L50_3 5.50918a
Cext_201 FILL_L10_11 FILL_L8_7 414.106a
Cext_202 FILL_L10_11 P|PSEG_L50_0 0.162706a
Cext_203 FILL_L10_11 VSUBS 235.205a
Cext_204 FILL_L10_12 FILL_L10_13 21.1898a
Cext_205 FILL_L10_12 FILL_L10_8 20.6721a
Cext_206 FILL_L10_12 FILL_L10_9 10.4171a
Cext_207 FILL_L10_12 FILL_L126_0 4.31742a
Cext_208 FILL_L10_12 FILL_L126_2 2.39086a
Cext_209 FILL_L10_12 FILL_L134_0 2.111a
Cext_210 FILL_L10_12 FILL_L30_2 3.3538a
Cext_211 FILL_L10_12 FILL_L50_2 5.83527a
Cext_212 FILL_L10_12 FILL_L8_8 49.7465a
Cext_213 FILL_L10_12 P|PSEG_L50_0 1.00282a
Cext_214 FILL_L10_12 VSUBS 83.0156a
Cext_215 FILL_L10_13 FILL_L10_9 27.9352a
Cext_216 FILL_L10_13 FILL_L126_0 4.64328a
Cext_217 FILL_L10_13 FILL_L126_2 1.05206a
Cext_218 FILL_L10_13 FILL_L50_1 0.215898a
Cext_219 FILL_L10_13 FILL_L50_2 1.1016a
Cext_220 FILL_L10_13 FILL_L8_9 84.7511a
Cext_221 FILL_L10_13 P|PSEG_L50_0 0.251824a
Cext_222 FILL_L10_13 VSUBS 302.203a
Cext_223 FILL_L10_14 FILL_L10_15 25.1417a
Cext_224 FILL_L10_14 FILL_L126_2 16.3976a
Cext_225 FILL_L10_14 FILL_L8_10 60.5025a
Cext_226 FILL_L10_14 VSUBS 67.5513a
Cext_227 FILL_L10_15 FILL_L126_2 20.3721a
Cext_228 FILL_L10_15 FILL_L134_0 3.21634a
Cext_229 FILL_L10_15 FILL_L8_11 106.484a
Cext_230 FILL_L10_15 VSUBS 129.844a
Cext_231 FILL_L10_2 FILL_L10_8 20.6721a
Cext_232 FILL_L10_2 FILL_L126_0 27.4946a
Cext_233 FILL_L10_2 FILL_L126_1 3.79462a
Cext_234 FILL_L10_2 FILL_L50_0 28.2175a
Cext_235 FILL_L10_2 FILL_L50_1 1.9454a
Cext_236 FILL_L10_2 FILL_L8_1 129.341a
Cext_237 FILL_L10_2 P|PSEG_L50_0 0.237655a
Cext_238 FILL_L10_2 VSUBS 198.826a
Cext_239 FILL_L10_3 FILL_L10_6 27.9352a
Cext_240 FILL_L10_3 FILL_L10_8 10.4171a
Cext_241 FILL_L10_3 FILL_L126_0 13.991a
Cext_242 FILL_L10_3 FILL_L126_1 4.05904a
Cext_243 FILL_L10_3 FILL_L30_1 0.343267a
Cext_244 FILL_L10_3 FILL_L50_1 4.68784a
Cext_245 FILL_L10_3 FILL_L8_5 1.18791a
Cext_246 FILL_L10_3 P|PSEG_L50_0 2.20932a
Cext_247 FILL_L10_3 VSUBS 94.1842a
Cext_248 FILL_L10_4 FILL_L10_5 27.9352a
Cext_249 FILL_L10_4 FILL_L10_7 27.9352a
Cext_250 FILL_L10_4 FILL_L126_1 20.0851a
Cext_251 FILL_L10_4 FILL_L30_1 15.1653a
Cext_252 FILL_L10_4 FILL_L8_2 67.225a
Cext_253 FILL_L10_4 P|PSEG_L50_0 6.51956a
Cext_254 FILL_L10_4 VSUBS 48.8099a
Cext_255 FILL_L10_5 FILL_L126_0 1.01376a
Cext_256 FILL_L10_5 FILL_L126_1 74.8553a
Cext_257 FILL_L10_5 FILL_L30_0 62.4976a
Cext_258 FILL_L10_5 FILL_L30_1 31.2488a
Cext_259 FILL_L10_5 FILL_L8_3 414.106a
Cext_260 FILL_L10_5 P|PSEG_L50_0 12.9907a
Cext_261 FILL_L10_5 VSUBS 285.413a
Cext_262 FILL_L10_6 FILL_L10_8 20.8343a
Cext_263 FILL_L10_6 FILL_L10_9 27.9352a
Cext_264 FILL_L10_6 FILL_L126_0 6.2074a
Cext_265 FILL_L10_6 FILL_L126_1 0.69786a
Cext_266 FILL_L10_6 FILL_L30_3 27.0701a
Cext_267 FILL_L10_6 FILL_L8_5 2.25703a
Cext_268 FILL_L10_6 P|PSEG_L50_0 41.1622a
Cext_269 FILL_L10_6 VSUBS 85.6119a
Cext_270 FILL_L10_7 FILL_L126_1 12.6318a
Cext_271 FILL_L10_7 FILL_L126_2 5.1599a
Cext_272 FILL_L10_7 FILL_L134_0 3.59163a
Cext_273 FILL_L10_7 FILL_L8_4 67.225a
Cext_274 FILL_L10_7 P|PSEG_L50_0 0.581653a
Cext_275 FILL_L10_7 VSUBS 48.8169a
Cext_276 FILL_L10_8 FILL_L126_0 23.0016a
Cext_277 FILL_L10_8 FILL_L126_1 0.939974a
Cext_278 FILL_L10_8 FILL_L30_2 28.9443a
Cext_279 FILL_L10_8 FILL_L30_3 1.76928a
Cext_280 FILL_L10_8 FILL_L30_4 0.168263a
Cext_281 FILL_L10_8 FILL_L50_1 23.1345a
Cext_282 FILL_L10_8 FILL_L50_2 18.8137a
Cext_283 FILL_L10_8 FILL_L8_5 174.113a
Cext_284 FILL_L10_8 P|PSEG_L50_0 69.1478a
Cext_285 FILL_L10_8 VSUBS 231.769a
Cext_286 FILL_L10_9 FILL_L126_0 2.83874a
Cext_287 FILL_L10_9 FILL_L126_2 1.82207a
Cext_288 FILL_L10_9 FILL_L134_0 1.10782a
Cext_289 FILL_L10_9 FILL_L30_3 15.1653a
Cext_290 FILL_L10_9 FILL_L8_8 1.18791a
Cext_291 FILL_L10_9 P|PSEG_L50_0 1.35419a
Cext_292 FILL_L10_9 VSUBS 94.2967a
Cext_293 FILL_L126_0 FILL_L126_1 301.115a
Cext_294 FILL_L126_0 FILL_L30_0 1.94639a
Cext_295 FILL_L126_0 FILL_L30_1 1.26515a
Cext_296 FILL_L126_0 FILL_L30_2 2.44169a
Cext_297 FILL_L126_0 FILL_L50_0 54.3546a
Cext_298 FILL_L126_0 FILL_L50_1 54.9836a
Cext_299 FILL_L126_0 FILL_L50_2 19.8677a
Cext_300 FILL_L126_0 FILL_L8_1 7.95751a
Cext_301 FILL_L126_0 FILL_L8_5 5.27899a
Cext_302 FILL_L126_0 FILL_L8_9 0.527997a
Cext_303 FILL_L126_0 P|PSEG_L50_0 38.4239a
Cext_304 FILL_L126_0 VSUBS 584.073a
Cext_305 FILL_L126_1 FILL_L126_2 238.98a
Cext_306 FILL_L126_1 FILL_L134_0 80.3015a
Cext_307 FILL_L126_1 FILL_L30_0 38.5731a
Cext_308 FILL_L126_1 FILL_L30_1 38.945a
Cext_309 FILL_L126_1 FILL_L30_4 8.85886a
Cext_310 FILL_L126_1 FILL_L30_5 13.7719a
Cext_311 FILL_L126_1 FILL_L50_3 30.6745a
Cext_312 FILL_L126_1 FILL_L8_0 5.89753a
Cext_313 FILL_L126_1 FILL_L8_2 6.5277a
Cext_314 FILL_L126_1 FILL_L8_3 11.8627a
Cext_315 FILL_L126_1 FILL_L8_4 2.54936a
Cext_316 FILL_L126_1 FILL_L8_7 2.20442a
Cext_317 FILL_L126_1 P|PSEG_L50_0 155.236a
Cext_318 FILL_L126_1 VSUBS 649.258a
Cext_319 FILL_L126_2 FILL_L134_0 171.786a
Cext_320 FILL_L126_2 FILL_L30_4 4.67405a
Cext_321 FILL_L126_2 FILL_L30_5 11.4043a
Cext_322 FILL_L126_2 FILL_L30_6 30.434a
Cext_323 FILL_L126_2 FILL_L50_3 15.0644a
Cext_324 FILL_L126_2 FILL_L50_4 50.7013a
Cext_325 FILL_L126_2 FILL_L8_10 5.13664a
Cext_326 FILL_L126_2 FILL_L8_11 3.64209a
Cext_327 FILL_L126_2 FILL_L8_6 2.81127a
Cext_328 FILL_L126_2 FILL_L8_7 2.39611a
Cext_329 FILL_L126_2 VSUBS 438.147a
Cext_330 FILL_L134_0 FILL_L30_5 4.8728a
Cext_331 FILL_L134_0 FILL_L50_3 5.16535a
Cext_332 FILL_L134_0 VSUBS 322.747a
Cext_333 FILL_L30_0 FILL_L30_1 19.2731a
Cext_334 FILL_L30_0 FILL_L8_0 5.03466a
Cext_335 FILL_L30_0 FILL_L8_3 5.75048a
Cext_336 FILL_L30_0 P|PSEG_L50_0 2.20216a
Cext_337 FILL_L30_0 VSUBS 97.7161a
Cext_338 FILL_L30_1 FILL_L30_5 19.2731a
Cext_339 FILL_L30_1 FILL_L8_2 2.51733a
Cext_340 FILL_L30_1 FILL_L8_3 2.87524a
Cext_341 FILL_L30_1 P|PSEG_L50_0 1.92791a
Cext_342 FILL_L30_1 VSUBS 84.3625a
Cext_343 FILL_L30_2 FILL_L30_3 12.7509a
Cext_344 FILL_L30_2 FILL_L50_2 35.6754a
Cext_345 FILL_L30_2 FILL_L8_5 0.723996a
Cext_346 FILL_L30_2 FILL_L8_8 0.552197a
Cext_347 FILL_L30_2 P|PSEG_L50_0 9.67162a
Cext_348 FILL_L30_2 VSUBS 51.8528a
Cext_349 FILL_L30_3 FILL_L30_4 19.2731a
Cext_350 FILL_L30_3 FILL_L50_2 6.84739a
Cext_351 FILL_L30_3 FILL_L8_5 1.06002a
Cext_352 FILL_L30_3 P|PSEG_L50_0 40.2984a
Cext_353 FILL_L30_3 VSUBS 57.9284a
Cext_354 FILL_L30_4 FILL_L30_5 19.2731a
Cext_355 FILL_L30_4 FILL_L50_3 67.225a
Cext_356 FILL_L30_4 FILL_L50_4 3.05982a
Cext_357 FILL_L30_4 FILL_L8_7 1.33983a
Cext_358 FILL_L30_4 VSUBS 77.7451a
Cext_359 FILL_L30_5 FILL_L30_6 19.2731a
Cext_360 FILL_L30_5 FILL_L50_3 3.78756a
Cext_361 FILL_L30_5 FILL_L8_7 5.75048a
Cext_362 FILL_L30_5 VSUBS 70.4476a
Cext_363 FILL_L30_6 FILL_L50_4 6.84739a
Cext_364 FILL_L30_6 VSUBS 116.891a
Cext_365 FILL_L50_0 FILL_L50_1 24.7136a
Cext_366 FILL_L50_0 FILL_L8_1 1.49568a
Cext_367 FILL_L50_0 VSUBS 80.3231a
Cext_368 FILL_L50_1 FILL_L50_2 24.7136a
Cext_369 FILL_L50_1 FILL_L8_5 0.972193a
Cext_370 FILL_L50_1 FILL_L8_9 0.193759a
Cext_371 FILL_L50_1 P|PSEG_L50_0 7.18401a
Cext_372 FILL_L50_1 VSUBS 54.642a
Cext_373 FILL_L50_2 FILL_L8_5 1.49568a
Cext_374 FILL_L50_2 FILL_L8_8 0.670382a
Cext_375 FILL_L50_2 FILL_L8_9 0.77235a
Cext_376 FILL_L50_2 P|PSEG_L50_0 11.2573a
Cext_377 FILL_L50_2 VSUBS 75.2993a
Cext_378 FILL_L50_3 FILL_L50_4 24.7136a
Cext_379 FILL_L50_3 VSUBS 55.7513a
Cext_380 FILL_L50_4 VSUBS 72.5787a
Cext_381 FILL_L8_0 FILL_L8_2 19.9134a
Cext_382 FILL_L8_0 FILL_L8_3 19.9134a
Cext_383 FILL_L8_0 P|PSEG_L50_0 0.487114a
Cext_384 FILL_L8_0 VSUBS 148.969a
Cext_385 FILL_L8_1 FILL_L8_5 14.7359a
Cext_386 FILL_L8_1 VSUBS 309.973a
Cext_387 FILL_L8_10 FILL_L8_11 17.922a
Cext_388 FILL_L8_10 FILL_L8_6 19.9134a
Cext_389 FILL_L8_10 VSUBS 140.329a
Cext_390 FILL_L8_11 FILL_L8_7 35.0475a
Cext_391 FILL_L8_11 VSUBS 221.936a
Cext_392 FILL_L8_2 FILL_L8_3 19.9134a
Cext_393 FILL_L8_2 FILL_L8_4 19.9134a
Cext_394 FILL_L8_2 P|PSEG_L50_0 0.414047a
Cext_395 FILL_L8_2 VSUBS 132.381a
Cext_396 FILL_L8_3 FILL_L8_7 35.0475a
Cext_397 FILL_L8_3 P|PSEG_L50_0 0.285843a
Cext_398 FILL_L8_3 VSUBS 564.775a
Cext_399 FILL_L8_4 FILL_L8_6 19.9134a
Cext_400 FILL_L8_4 FILL_L8_7 19.9134a
Cext_401 FILL_L8_4 VSUBS 132.381a
Cext_402 FILL_L8_5 FILL_L8_8 14.7359a
Cext_403 FILL_L8_5 P|PSEG_L50_0 3.4827a
Cext_404 FILL_L8_5 VSUBS 388.966a
Cext_405 FILL_L8_6 FILL_L8_7 19.9134a
Cext_406 FILL_L8_6 VSUBS 132.381a
Cext_407 FILL_L8_7 VSUBS 535.58a
Cext_408 FILL_L8_8 FILL_L8_9 15.2359a
Cext_409 FILL_L8_8 VSUBS 136.601a
Cext_410 FILL_L8_9 P|PSEG_L50_0 0.112308a
Cext_411 FILL_L8_9 VSUBS 166.611a
Cext_412 P|PSEG_L50_0 VSUBS 345.23a
.ENDS sense_fill_clip
