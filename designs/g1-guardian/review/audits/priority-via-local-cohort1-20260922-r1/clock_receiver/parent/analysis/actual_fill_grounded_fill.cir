* Declared idealoutsideequipotential target pieces; othercontexts ground.
C40 0 P 4.3207799999999999e-17
C69 0 P 1.31894e-17
C106 0 P 1.1145700000000001e-15
C125 0 P 3.8397100000000003e-17
C164 0 P 2.4284900000000002e-17
C174 0 P 7.5552900000000004e-19
C181 0 P 7.5117200000000009e-18
C201 0 P 1.6270599999999999e-19
C212 0 P 1.00282e-18
C220 0 P 2.5182400000000001e-19
C236 0 P 2.3765500000000001e-19
C245 0 P 2.2093200000000001e-18
C252 0 P 6.5195600000000006e-18
C259 0 P 1.2990700000000001e-17
C267 0 P 4.1162200000000004e-17
C273 0 P 5.8165299999999998e-19
C283 0 P 6.9147800000000014e-17
C290 0 P 1.3541900000000001e-18
C302 0 P 3.8423900000000004e-17
C316 0 P 1.5523599999999999e-16
C335 0 P 2.2021600000000004e-18
C340 0 P 1.9279100000000001e-18
C346 0 P 9.6716200000000012e-18
C351 0 P 4.0298400000000001e-17
C370 0 P 7.184010000000001e-18
C375 0 P 1.1257300000000001e-17
C382 0 P 4.87114e-19
C393 0 P 4.1404700000000004e-19
C396 0 P 2.8584300000000005e-19
C402 0 P 3.4827e-18
C409 0 P 1.1230800000000002e-19
C411 P 0 3.4523000000000004e-16
VP P 0 DC 0 AC 1
.control
set numdgt=17
ac lin 1 1Meg 1Meg
let ceff = -imag(i(VP))/(2*pi*1e6)
print ceff
echo LOCAL_CAP_AC_END
quit
.endc
.end
