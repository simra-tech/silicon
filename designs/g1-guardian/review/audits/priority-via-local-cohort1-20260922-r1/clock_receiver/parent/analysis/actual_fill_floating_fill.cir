* Declared idealoutsideequipotential target pieces; othercontexts ground.
C4 0 F5 7.2226700000000001e-18
C5 0 F7 6.334000000000001e-17
C6 0 F8 1.9533400000000001e-17
C7 0 F9 3.3662700000000003e-18
C8 0 F10 1.2065500000000001e-17
C9 0 F11 5.7006000000000006e-17
C10 0 F13 1.4314400000000001e-17
C11 0 F14 6.2859799999999999e-17
C12 0 F15 6.5134900000000003e-17
C13 0 F16 2.4418600000000003e-18
C14 0 F17 1.3275300000000001e-17
C15 0 F18 6.334000000000001e-17
C16 0 F19 2.8472100000000001e-17
C17 0 F20 1.3275300000000001e-17
C18 0 F21 6.1583399999999999e-17
C19 0 F22 5.7151500000000003e-17
C20 0 F23 2.07561e-17
C21 0 F24 1.8912400000000001e-18
C22 0 F26 2.0090300000000002e-18
C23 0 F28 1.8468199999999999e-18
C24 0 F29 6.4790200000000002e-17
C25 0 F30 2.4728500000000003e-18
C26 0 F31 3.3409400000000002e-18
C27 0 F32 7.3254000000000011e-18
C28 0 F33 1.9352499999999999e-17
C29 0 F34 6.7703899999999997e-19
C30 0 F35 9.9751900000000009e-18
C31 0 F36 1.7157699999999999e-17
C32 0 F38 8.9802700000000007e-19
C33 0 F39 2.4304999999999999e-18
C34 0 F41 3.1235200000000002e-18
C35 0 F42 1.8437200000000003e-19
C36 0 F43 2.5655299999999999e-18
C37 0 F44 1.0342100000000002e-18
C38 0 F45 2.70056e-18
C39 0 F46 4.1502800000000006e-19
C40 0 P 4.3207799999999999e-17
C44 0 F5 4.8992300000000009e-18
C45 0 F6 1.9561599999999999e-18
C46 0 F7 2.6931400000000004e-18
C47 0 F8 2.2100900000000002e-17
C48 0 F9 2.53991e-18
C49 0 F13 2.7905700000000004e-18
C50 0 F14 2.2226400000000001e-18
C51 0 F16 1.29949e-17
C52 0 F17 3.7359000000000003e-18
C53 0 F18 3.3150800000000003e-18
C54 0 F19 2.45316e-18
C55 0 F20 3.5591100000000003e-18
C56 0 F21 2.3925800000000003e-16
C57 0 F22 3.6300599999999999e-16
C58 0 F24 1.2653000000000001e-16
C59 0 F25 4.0519700000000005e-18
C60 0 F27 9.5932300000000011e-19
C61 0 F28 3.9971800000000003e-18
C62 0 F30 3.9971800000000003e-18
C63 0 F32 3.5949500000000003e-18
C64 0 F34 4.0474800000000007e-18
C65 0 F35 4.0070000000000003e-18
C66 0 F37 1.6494500000000002e-19
C67 0 F38 2.2470800000000003e-18
C68 0 F42 4.7477000000000007e-19
C69 0 P 1.31894e-17
C73 0 F5 7.3755500000000008e-18
C74 0 F6 7.6962100000000008e-19
C75 0 F7 4.2502200000000002e-18
C76 0 F8 6.5168100000000011e-18
C77 0 F9 1.9072600000000001e-18
C78 0 F10 1.6619200000000001e-19
C79 0 F11 3.8252000000000003e-18
C80 0 F12 2.3939300000000004e-18
C81 0 F13 2.5579200000000003e-18
C82 0 F14 4.2449800000000003e-17
C83 0 F16 3.1260200000000001e-19
C84 0 F17 1.0929100000000001e-17
C85 0 F18 4.0377100000000002e-18
C86 0 F19 6.2951399999999999e-17
C87 0 F20 9.1514399999999994e-18
C88 0 F21 9.7739999999999999e-17
C89 0 F22 3.0293500000000006e-17
C90 0 F23 3.1752000000000002e-17
C91 0 F24 2.8196e-18
C92 0 F25 2.8003500000000001e-19
C93 0 F26 3.9360200000000007e-18
C94 0 F28 1.6901900000000001e-17
C95 0 F29 2.0270100000000002e-18
C96 0 F31 2.2149000000000001e-19
C97 0 F32 1.1837000000000001e-17
C98 0 F33 6.7415100000000001e-17
C99 0 F34 1.3371000000000001e-17
C100 0 F35 4.4860500000000006e-17
C101 0 F36 4.4860500000000006e-17
C102 0 F37 2.2021399999999999e-19
C103 0 F42 1.27097e-19
C104 0 F44 4.2120400000000001e-18
C105 0 F47 1.23318e-19
C106 0 P 1.1145700000000001e-15
C109 0 F9 8.6264000000000006e-18
C110 0 F10 2.4757400000000002e-16
C111 0 F11 5.1623700000000004e-18
C112 0 F12 1.67183e-18
C113 0 F17 5.3670700000000005e-19
C114 0 F19 1.0244500000000002e-18
C115 0 F20 5.7359700000000001e-18
C116 0 F21 1.1997600000000002e-17
C117 0 F23 4.9171200000000005e-17
C118 0 F24 2.4539700000000002e-17
C119 0 F27 3.0602200000000003e-18
C120 0 F28 1.27509e-17
C121 0 F34 3.4313600000000004e-18
C122 0 F39 2.2949500000000003e-18
C123 0 F47 9.1678800000000009e-19
C124 0 F48 3.9445800000000003e-18
C125 0 P 3.8397100000000003e-17
C127 0 F5 5.5199300000000002e-18
C128 0 F6 1.0694500000000001e-18
C129 0 F9 1.4625400000000001e-19
C130 0 F10 6.9365700000000005e-18
C131 0 F13 3.0420700000000004e-19
C132 0 F14 5.4205900000000005e-18
C133 0 F16 3.0712500000000001e-19
C134 0 F17 5.3499300000000003e-18
C135 0 F19 3.6563400000000006e-19
C136 0 F20 5.5199300000000002e-18
C137 0 F21 1.91054e-17
C138 0 F22 2.9466300000000002e-17
C139 0 F23 1.04171e-17
C140 0 F24 2.0291899999999998e-18
C141 0 F25 8.1708600000000006e-19
C142 0 F26 1.1103099999999999e-18
C143 0 F27 1.10828e-19
C144 0 F28 6.7777300000000005e-18
C145 0 F29 6.7506300000000009e-18
C146 0 F30 1.2871200000000001e-18
C147 0 F31 2.1042000000000003e-18
C148 0 F32 1.1630000000000001e-18
C149 0 F33 3.1108400000000004e-19
C150 0 F34 8.9373299999999998e-19
C151 0 F35 1.9217100000000001e-18
C152 0 F36 4.0918700000000006e-18
C153 0 F37 1.3284800000000002e-17
C154 0 F38 1.6740100000000002e-17
C155 0 F39 1.1956300000000002e-17
C156 0 F41 1.3284800000000002e-17
C157 0 F42 9.2435100000000014e-18
C158 0 F43 1.3284800000000002e-17
C159 0 F44 2.2534700000000004e-17
C160 0 F45 1.3284800000000002e-17
C161 0 F46 9.2435100000000014e-18
C162 0 F47 6.4384900000000003e-18
C163 0 F48 6.5257400000000004e-18
C164 0 P 2.4284900000000002e-17
C166 F5 F6 1.0330500000000002e-17
C167 F5 F13 2.08343e-17
C168 F5 F14 2.7935199999999999e-17
C169 F5 F21 1.46478e-17
C170 F5 F22 6.1240100000000004e-18
C171 F5 F25 6.8653400000000003e-19
C172 F5 F32 9.3756700000000009e-18
C173 F5 F38 2.3758200000000004e-18
C174 F5 P 7.5552900000000004e-19
C175 F5 0 1.0987900000000002e-16
C176 F6 F15 2.7935199999999999e-17
C177 F6 F16 2.7935199999999999e-17
C178 F6 F22 2.0000600000000001e-17
C179 F6 F25 3.0330600000000001e-17
C180 F6 F37 6.7224999999999998e-17
C181 F6 P 7.5117200000000009e-18
C182 F6 0 8.8482300000000003e-17
C183 F7 F8 2.7935199999999999e-17
C184 F7 F11 2.7935199999999999e-17
C185 F7 F18 2.7935199999999999e-17
C186 F7 F22 4.8200900000000005e-18
C187 F7 F23 1.30377e-17
C188 F7 F24 3.5268100000000001e-18
C189 F7 F45 6.7224999999999998e-17
C190 F7 0 4.8850900000000006e-17
C191 F8 F12 4.9165999999999999e-17
C192 F8 F16 4.9165999999999999e-17
C193 F8 F18 2.7935199999999999e-17
C194 F8 F22 2.9277500000000005e-17
C195 F8 F23 3.0389900000000005e-17
C196 F8 F24 1.4958300000000002e-17
C197 F8 F29 3.3118100000000005e-19
C198 F8 F30 6.2497600000000006e-17
C199 F8 F35 5.5091800000000004e-18
C200 F8 F46 4.1410600000000002e-16
C201 F8 P 1.6270599999999999e-19
C202 F8 0 2.3520500000000004e-16
C203 F9 F10 2.1189800000000004e-17
C204 F9 F19 2.0672100000000003e-17
C205 F9 F20 1.04171e-17
C206 F9 F21 4.3174200000000009e-18
C207 F9 F23 2.39086e-18
C208 F9 F24 2.1110000000000002e-18
C209 F9 F27 3.3538000000000002e-18
C210 F9 F34 5.8352700000000008e-18
C211 F9 F47 4.9746500000000003e-17
C212 F9 P 1.00282e-18
C213 F9 0 8.3015600000000007e-17
C214 F10 F20 2.7935199999999999e-17
C215 F10 F21 4.6432800000000003e-18
C216 F10 F23 1.05206e-18
C217 F10 F33 2.1589800000000003e-19
C218 F10 F34 1.1016e-18
C219 F10 F48 8.4751099999999996e-17
C220 F10 P 2.5182400000000001e-19
C221 F10 0 3.0220300000000001e-16
C222 F11 F12 2.5141700000000002e-17
C223 F11 F23 1.6397600000000003e-17
C224 F11 F39 6.0502500000000003e-17
C225 F11 0 6.7551300000000008e-17
C226 F12 F23 2.03721e-17
C227 F12 F24 3.2163400000000005e-18
C228 F12 F40 1.06484e-16
C229 F12 0 1.29844e-16
C230 F13 F19 2.0672100000000003e-17
C231 F13 F21 2.7494600000000002e-17
C232 F13 F22 3.7946200000000001e-18
C233 F13 F32 2.8217500000000006e-17
C234 F13 F33 1.9454000000000001e-18
C235 F13 F38 1.2934100000000001e-16
C236 F13 P 2.3765500000000001e-19
C237 F13 0 1.98826e-16
C238 F14 F17 2.7935199999999999e-17
C239 F14 F19 1.04171e-17
C240 F14 F21 1.3991000000000002e-17
C241 F14 F22 4.059040000000001e-18
C242 F14 F26 3.4326700000000001e-19
C243 F14 F33 4.6878399999999995e-18
C244 F14 F44 1.1879100000000002e-18
C245 F14 P 2.2093200000000001e-18
C246 F14 0 9.4184200000000017e-17
C247 F15 F16 2.7935199999999999e-17
C248 F15 F18 2.7935199999999999e-17
C249 F15 F22 2.0085100000000001e-17
C250 F15 F26 1.51653e-17
C251 F15 F41 6.7224999999999998e-17
C252 F15 P 6.5195600000000006e-18
C253 F15 0 4.8809900000000004e-17
C254 F16 F21 1.01376e-18
C255 F16 F22 7.4855300000000006e-17
C256 F16 F25 6.2497600000000006e-17
C257 F16 F26 3.1248800000000003e-17
C258 F16 F42 4.1410600000000002e-16
C259 F16 P 1.2990700000000001e-17
C260 F16 0 2.8541300000000004e-16
C261 F17 F19 2.08343e-17
C262 F17 F20 2.7935199999999999e-17
C263 F17 F21 6.2074000000000006e-18
C264 F17 F22 6.9786000000000013e-19
C265 F17 F28 2.7070100000000002e-17
C266 F17 F44 2.25703e-18
C267 F17 P 4.1162200000000004e-17
C268 F17 0 8.5611900000000015e-17
C269 F18 F22 1.2631800000000001e-17
C270 F18 F23 5.1599000000000006e-18
C271 F18 F24 3.5916300000000002e-18
C272 F18 F43 6.7224999999999998e-17
C273 F18 P 5.8165299999999998e-19
C274 F18 0 4.8816900000000001e-17
C275 F19 F21 2.3001600000000002e-17
C276 F19 F22 9.3997399999999999e-19
C277 F19 F27 2.8944299999999998e-17
C278 F19 F28 1.76928e-18
C279 F19 F29 1.6826300000000001e-19
C280 F19 F33 2.31345e-17
C281 F19 F34 1.8813700000000003e-17
C282 F19 F44 1.7411300000000001e-16
C283 F19 P 6.9147800000000014e-17
C284 F19 0 2.31769e-16
C285 F20 F21 2.8387400000000003e-18
C286 F20 F23 1.8220700000000001e-18
C287 F20 F24 1.10782e-18
C288 F20 F28 1.51653e-17
C289 F20 F47 1.1879100000000002e-18
C290 F20 P 1.3541900000000001e-18
C291 F20 0 9.4296700000000014e-17
C292 F21 F22 3.0111500000000001e-16
C293 F21 F25 1.9463900000000002e-18
C294 F21 F26 1.2651500000000002e-18
C295 F21 F27 2.4416900000000001e-18
C296 F21 F32 5.4354600000000002e-17
C297 F21 F33 5.4983600000000007e-17
C298 F21 F34 1.9867700000000001e-17
C299 F21 F38 7.9575100000000007e-18
C300 F21 F44 5.2789900000000004e-18
C301 F21 F48 5.2799700000000012e-19
C302 F21 P 3.8423900000000004e-17
C303 F21 0 5.84073e-16
C304 F22 F23 2.3897999999999999e-16
C305 F22 F24 8.0301500000000007e-17
C306 F22 F25 3.85731e-17
C307 F22 F26 3.8945000000000003e-17
C308 F22 F29 8.8588600000000009e-18
C309 F22 F30 1.3771900000000001e-17
C310 F22 F35 3.0674499999999998e-17
C311 F22 F37 5.8975300000000004e-18
C312 F22 F41 6.5277000000000011e-18
C313 F22 F42 1.1862700000000001e-17
C314 F22 F43 2.5493600000000004e-18
C315 F22 F46 2.2044199999999999e-18
C316 F22 P 1.5523599999999999e-16
C317 F22 0 6.4925800000000009e-16
C318 F23 F24 1.7178600000000001e-16
C319 F23 F29 4.6740500000000009e-18
C320 F23 F30 1.14043e-17
C321 F23 F31 3.0434000000000003e-17
C322 F23 F35 1.5064400000000001e-17
C323 F23 F36 5.0701300000000009e-17
C324 F23 F39 5.1366400000000006e-18
C325 F23 F40 3.6420900000000003e-18
C326 F23 F45 2.8112700000000002e-18
C327 F23 F46 2.3961100000000004e-18
C328 F23 0 4.3814700000000003e-16
C329 F24 F30 4.8728e-18
C330 F24 F35 5.1653500000000008e-18
C331 F24 0 3.2274700000000002e-16
C332 F25 F26 1.92731e-17
C333 F25 F37 5.0346600000000001e-18
C334 F25 F42 5.7504800000000001e-18
C335 F25 P 2.2021600000000004e-18
C336 F25 0 9.77161e-17
C337 F26 F30 1.92731e-17
C338 F26 F41 2.5173300000000001e-18
C339 F26 F42 2.87524e-18
C340 F26 P 1.9279100000000001e-18
C341 F26 0 8.4362499999999998e-17
C342 F27 F28 1.27509e-17
C343 F27 F34 3.5675400000000004e-17
C344 F27 F44 7.2399599999999999e-19
C345 F27 F47 5.5219700000000006e-19
C346 F27 P 9.6716200000000012e-18
C347 F27 0 5.1852800000000008e-17
C348 F28 F29 1.92731e-17
C349 F28 F34 6.8473900000000005e-18
C350 F28 F44 1.06002e-18
C351 F28 P 4.0298400000000001e-17
C352 F28 0 5.7928400000000004e-17
C353 F29 F30 1.92731e-17
C354 F29 F35 6.7224999999999998e-17
C355 F29 F36 3.0598200000000003e-18
C356 F29 F46 1.3398300000000002e-18
C357 F29 0 7.7745100000000001e-17
C358 F30 F31 1.92731e-17
C359 F30 F35 3.7875600000000001e-18
C360 F30 F46 5.7504800000000001e-18
C361 F30 0 7.0447600000000004e-17
C362 F31 F36 6.8473900000000005e-18
C363 F31 0 1.16891e-16
C364 F32 F33 2.4713600000000001e-17
C365 F32 F38 1.49568e-18
C366 F32 0 8.0323100000000001e-17
C367 F33 F34 2.4713600000000001e-17
C368 F33 F44 9.7219300000000006e-19
C369 F33 F48 1.9375899999999999e-19
C370 F33 P 7.184010000000001e-18
C371 F33 0 5.4642000000000009e-17
C372 F34 F44 1.49568e-18
C373 F34 F47 6.7038200000000004e-19
C374 F34 F48 7.7235000000000007e-19
C375 F34 P 1.1257300000000001e-17
C376 F34 0 7.5299300000000013e-17
C377 F35 F36 2.4713600000000001e-17
C378 F35 0 5.5751300000000006e-17
C379 F36 0 7.25787e-17
C380 F37 F41 1.9913400000000001e-17
C381 F37 F42 1.9913400000000001e-17
C382 F37 P 4.87114e-19
C383 F37 0 1.4896900000000002e-16
C384 F38 F44 1.4735900000000002e-17
C385 F38 0 3.0997300000000004e-16
C386 F39 F40 1.7922000000000001e-17
C387 F39 F45 1.9913400000000001e-17
C388 F39 0 1.4032900000000001e-16
C389 F40 F46 3.5047500000000004e-17
C390 F40 0 2.2193600000000002e-16
C391 F41 F42 1.9913400000000001e-17
C392 F41 F43 1.9913400000000001e-17
C393 F41 P 4.1404700000000004e-19
C394 F41 0 1.3238100000000001e-16
C395 F42 F46 3.5047500000000004e-17
C396 F42 P 2.8584300000000005e-19
C397 F42 0 5.6477499999999999e-16
C398 F43 F45 1.9913400000000001e-17
C399 F43 F46 1.9913400000000001e-17
C400 F43 0 1.3238100000000001e-16
C401 F44 F47 1.4735900000000002e-17
C402 F44 P 3.4827e-18
C403 F44 0 3.8896600000000002e-16
C404 F45 F46 1.9913400000000001e-17
C405 F45 0 1.3238100000000001e-16
C406 F46 0 5.3558000000000012e-16
C407 F47 F48 1.5235900000000001e-17
C408 F47 0 1.3660100000000001e-16
C409 F48 P 1.1230800000000002e-19
C410 F48 0 1.66611e-16
C411 P 0 3.4523000000000004e-16
VP P 0 DC 0 AC 1
.control
set numdgt=17
ac lin 1 1Meg 1Meg
let ceff = -imag(i(VP))/(2*pi*1e6)
print ceff
echo LOCAL_CAP_AC_END
quit
.endc
.end
