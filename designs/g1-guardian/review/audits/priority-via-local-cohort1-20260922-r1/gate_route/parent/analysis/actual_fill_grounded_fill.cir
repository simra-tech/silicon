* Declared idealoutsideequipotential target pieces; othercontexts ground.
C39 0 P 3.48799e-16
C58 0 P 1.7754500000000003e-19
C65 0 P 6.9045300000000005e-18
C72 0 P 8.3162200000000002e-19
C84 0 P 5.8466800000000001e-17
C96 0 P 3.1143000000000001e-16
C104 0 P 3.3264900000000002e-18
C115 0 P 8.506300000000001e-17
C123 0 P 4.7054800000000006e-17
C141 0 P 1.5186600000000002e-17
C148 0 P 1.4758100000000002e-17
C153 0 P 7.062610000000001e-18
C158 0 P 7.062610000000001e-18
C169 0 P 2.4744100000000002e-18
C178 0 P 2.2944299999999999e-17
C182 0 P 1.7402300000000002e-17
C186 0 P 1.5864800000000002e-17
C199 0 P 1.8573700000000002e-17
C203 0 P 9.5077300000000014e-18
C206 0 P 1.4297300000000002e-17
C211 0 P 3.9382000000000001e-16
C213 0 P 6.8627300000000005e-18
C215 0 P 1.76879e-17
C230 0 P 2.2218e-18
C233 0 P 3.2012600000000003e-18
C238 0 P 1.8463100000000001e-18
C240 0 P 1.4485e-18
C242 P 0 3.7134700000000001e-16
VP P 0 DC 0 AC 1
.control
set numdgt=17
ac lin 1 1Meg 1Meg
let ceff = -imag(i(VP))/(2*pi*1e6)
print ceff
echo LOCAL_CAP_AC_END
quit
.endc
.end
