* cell sense_fill_clip
.SUBCKT sense_fill_clip
* net 1 CTX_L126_0,CTX_L134_0
* net 2 P,PSEG_L50_0
.ENDS sense_fill_clip
