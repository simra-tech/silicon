*********************************************************
*** NGSPICE file created by KLayout-PEX 0.3.12
*** -----------------------------------------------------
***     Extraction Engine: KPEX/2.5D
***     Technology: ihp_sg13g2
***     Date: 2026-09-22 18:38:16
*********************************************************

.SUBCKT sense_fill_clip
Cext_1 CTX_L126_0|CTX_L134_0 FILL_L10_0 26.6544a
Cext_2 CTX_L126_0|CTX_L134_0 FILL_L10_1 85.5086a
Cext_3 CTX_L126_0|CTX_L134_0 FILL_L10_2 9.71722a
Cext_4 CTX_L126_0|CTX_L134_0 FILL_L10_3 46.727a
Cext_5 CTX_L126_0|CTX_L134_0 FILL_L10_4 157.461a
Cext_6 CTX_L126_0|CTX_L134_0 FILL_L10_5 82.129a
Cext_7 CTX_L126_0|CTX_L134_0 FILL_L10_6 42.1941a
Cext_8 CTX_L126_0|CTX_L134_0 FILL_L10_7 120.096a
Cext_9 CTX_L126_0|CTX_L134_0 FILL_L10_8 82.377a
Cext_10 CTX_L126_0|CTX_L134_0 FILL_L30_0 14.243a
Cext_11 CTX_L126_0|CTX_L134_0 FILL_L30_1 25.6135a
Cext_12 CTX_L126_0|CTX_L134_0 FILL_L30_10 74.4729a
Cext_13 CTX_L126_0|CTX_L134_0 FILL_L30_11 34.1841a
Cext_14 CTX_L126_0|CTX_L134_0 FILL_L30_2 7.95678a
Cext_15 CTX_L126_0|CTX_L134_0 FILL_L30_3 5.23859a
Cext_16 CTX_L126_0|CTX_L134_0 FILL_L30_4 34.9377a
Cext_17 CTX_L126_0|CTX_L134_0 FILL_L30_5 33.8829a
Cext_18 CTX_L126_0|CTX_L134_0 FILL_L30_6 27.9648a
Cext_19 CTX_L126_0|CTX_L134_0 FILL_L30_7 51.934a
Cext_20 CTX_L126_0|CTX_L134_0 FILL_L30_8 14.2207a
Cext_21 CTX_L126_0|CTX_L134_0 FILL_L30_9 9.70634a
Cext_22 CTX_L126_0|CTX_L134_0 FILL_L50_0 34.6796a
Cext_23 CTX_L126_0|CTX_L134_0 FILL_L50_1 47.9053a
Cext_24 CTX_L126_0|CTX_L134_0 FILL_L50_2 76.1659a
Cext_25 CTX_L126_0|CTX_L134_0 FILL_L50_3 413.965a
Cext_26 CTX_L126_0|CTX_L134_0 FILL_L50_4 73.9957a
Cext_27 CTX_L126_0|CTX_L134_0 FILL_L50_5 72.9559a
Cext_28 CTX_L126_0|CTX_L134_0 FILL_L50_6 468.579a
Cext_29 CTX_L126_0|CTX_L134_0 FILL_L50_7 35.5318a
Cext_30 CTX_L126_0|CTX_L134_0 FILL_L50_8 94.8333a
Cext_31 CTX_L126_0|CTX_L134_0 FILL_L8_0 5.01413a
Cext_32 CTX_L126_0|CTX_L134_0 FILL_L8_1 13.6201a
Cext_33 CTX_L126_0|CTX_L134_0 FILL_L8_2 5.32098a
Cext_34 CTX_L126_0|CTX_L134_0 FILL_L8_3 8.98558a
Cext_35 CTX_L126_0|CTX_L134_0 FILL_L8_4 24.7332a
Cext_36 CTX_L126_0|CTX_L134_0 FILL_L8_5 9.64176a
Cext_37 CTX_L126_0|CTX_L134_0 FILL_L8_6 6.59457a
Cext_38 CTX_L126_0|CTX_L134_0 FILL_L8_7 17.2573a
Cext_39 CTX_L126_0|CTX_L134_0 FILL_L8_8 9.76971a
Cext_40 CTX_L126_0|CTX_L134_0 P|PSEG_L50_0 375.27a
Cext_41 CTX_L126_0|CTX_L134_0 VSUBS 3.0843f
Cext_42 FILL_L10_0 FILL_L10_1 56.4292a
Cext_43 FILL_L10_0 FILL_L10_3 26.2591a
Cext_44 FILL_L10_0 FILL_L30_0 15.4853a
Cext_45 FILL_L10_0 FILL_L50_0 5.20869a
Cext_46 FILL_L10_0 FILL_L50_3 1.5977a
Cext_47 FILL_L10_0 FILL_L8_0 127.647a
Cext_48 FILL_L10_0 VSUBS 144.488a
Cext_49 FILL_L10_1 FILL_L10_2 56.4292a
Cext_50 FILL_L10_1 FILL_L10_4 97.7733a
Cext_51 FILL_L10_1 FILL_L30_0 33.262a
Cext_52 FILL_L10_1 FILL_L30_1 103.658a
Cext_53 FILL_L10_1 FILL_L30_2 1.81737a
Cext_54 FILL_L10_1 FILL_L30_7 0.711368a
Cext_55 FILL_L10_1 FILL_L50_0 10.7916a
Cext_56 FILL_L10_1 FILL_L50_1 30.9393a
Cext_57 FILL_L10_1 FILL_L50_3 25.2181a
Cext_58 FILL_L10_1 FILL_L8_1 475.281a
Cext_59 FILL_L10_1 P|PSEG_L50_0 0.563047a
Cext_60 FILL_L10_1 VSUBS 227.471a
Cext_61 FILL_L10_2 FILL_L10_5 97.7733a
Cext_62 FILL_L10_2 FILL_L30_2 93.3437a
Cext_63 FILL_L10_2 FILL_L30_3 64.9416a
Cext_64 FILL_L10_2 FILL_L50_3 187.526a
Cext_65 FILL_L10_2 FILL_L8_2 475.281a
Cext_66 FILL_L10_2 P|PSEG_L50_0 6.90453a
Cext_67 FILL_L10_2 VSUBS 269.456a
Cext_68 FILL_L10_3 FILL_L10_4 97.7733a
Cext_69 FILL_L10_3 FILL_L10_6 26.2591a
Cext_70 FILL_L10_3 FILL_L30_5 29.7794a
Cext_71 FILL_L10_3 FILL_L50_4 10.0167a
Cext_72 FILL_L10_3 FILL_L8_3 221.17a
Cext_73 FILL_L10_3 P|PSEG_L50_0 0.831622a
Cext_74 FILL_L10_3 VSUBS 197.197a
Cext_75 FILL_L10_4 FILL_L10_5 97.7733a
Cext_76 FILL_L10_4 FILL_L10_7 97.7733a
Cext_77 FILL_L10_4 FILL_L30_1 4.32643a
Cext_78 FILL_L10_4 FILL_L30_10 4.76549a
Cext_79 FILL_L10_4 FILL_L30_5 68.831a
Cext_80 FILL_L10_4 FILL_L30_7 10.4782a
Cext_81 FILL_L10_4 FILL_L50_1 8.43572a
Cext_82 FILL_L10_4 FILL_L50_4 28.1444a
Cext_83 FILL_L10_4 FILL_L50_6 5.1802a
Cext_84 FILL_L10_4 FILL_L8_4 823.506a
Cext_85 FILL_L10_4 P|PSEG_L50_0 65.4979a
Cext_86 FILL_L10_4 VSUBS 196.219a
Cext_87 FILL_L10_5 FILL_L10_8 97.7733a
Cext_88 FILL_L10_5 FILL_L30_11 1.83833a
Cext_89 FILL_L10_5 FILL_L30_2 3.54067a
Cext_90 FILL_L10_5 FILL_L30_3 1.77033a
Cext_91 FILL_L10_5 FILL_L30_5 1.30848a
Cext_92 FILL_L10_5 FILL_L30_8 5.43398a
Cext_93 FILL_L10_5 FILL_L30_9 2.71699a
Cext_94 FILL_L10_5 FILL_L50_3 108.901a
Cext_95 FILL_L10_5 FILL_L50_6 219.153a
Cext_96 FILL_L10_5 FILL_L8_5 823.506a
Cext_97 FILL_L10_5 P|PSEG_L50_0 313.532a
Cext_98 FILL_L10_5 VSUBS 268.965a
Cext_99 FILL_L10_6 FILL_L10_7 97.2146a
Cext_100 FILL_L10_6 FILL_L30_10 14.2941a
Cext_101 FILL_L10_6 FILL_L30_6 29.7794a
Cext_102 FILL_L10_6 FILL_L50_5 10.0167a
Cext_103 FILL_L10_6 FILL_L50_7 4.80802a
Cext_104 FILL_L10_6 FILL_L8_6 219.906a
Cext_105 FILL_L10_6 P|PSEG_L50_0 3.32649a
Cext_106 FILL_L10_6 VSUBS 215.756a
Cext_107 FILL_L10_7 FILL_L10_8 97.2146a
Cext_108 FILL_L10_7 FILL_L30_10 247.197a
Cext_109 FILL_L10_7 FILL_L30_11 1.67757a
Cext_110 FILL_L10_7 FILL_L30_6 63.9654a
Cext_111 FILL_L10_7 FILL_L30_7 168.484a
Cext_112 FILL_L10_7 FILL_L30_8 3.49494a
Cext_113 FILL_L10_7 FILL_L50_5 22.5874a
Cext_114 FILL_L10_7 FILL_L50_7 0.880471a
Cext_115 FILL_L10_7 FILL_L8_7 818.8a
Cext_116 FILL_L10_7 P|PSEG_L50_0 85.5555a
Cext_117 FILL_L10_7 VSUBS 268.397a
Cext_118 FILL_L10_8 FILL_L30_11 270.097a
Cext_119 FILL_L10_8 FILL_L30_8 148.648a
Cext_120 FILL_L10_8 FILL_L30_9 109.458a
Cext_121 FILL_L10_8 FILL_L50_6 155.145a
Cext_122 FILL_L10_8 FILL_L50_8 72.6359a
Cext_123 FILL_L10_8 FILL_L8_8 818.8a
Cext_124 FILL_L10_8 P|PSEG_L50_0 47.0548a
Cext_125 FILL_L10_8 VSUBS 340.727a
Cext_126 FILL_L30_0 FILL_L30_1 10.022a
Cext_127 FILL_L30_0 FILL_L30_4 19.2731a
Cext_128 FILL_L30_0 FILL_L50_0 34.957a
Cext_129 FILL_L30_0 FILL_L8_0 2.61802a
Cext_130 FILL_L30_0 FILL_L8_1 2.99025a
Cext_131 FILL_L30_0 VSUBS 63.5671a
Cext_132 FILL_L30_1 FILL_L30_2 10.022a
Cext_133 FILL_L30_1 FILL_L30_7 4.73652a
Cext_134 FILL_L30_1 FILL_L50_1 34.957a
Cext_135 FILL_L30_1 VSUBS 46.8442a
Cext_136 FILL_L30_10 FILL_L30_11 9.25111a
Cext_137 FILL_L30_10 FILL_L30_6 19.2731a
Cext_138 FILL_L30_10 FILL_L30_7 19.2731a
Cext_139 FILL_L30_10 FILL_L50_7 53.6276a
Cext_140 FILL_L30_10 FILL_L8_6 2.41663a
Cext_141 FILL_L30_10 FILL_L8_7 2.76023a
Cext_142 FILL_L30_10 P|PSEG_L50_0 15.1866a
Cext_143 FILL_L30_10 VSUBS 172.15a
Cext_144 FILL_L30_11 FILL_L30_8 19.2731a
Cext_145 FILL_L30_11 FILL_L30_9 19.2731a
Cext_146 FILL_L30_11 FILL_L50_6 11.8946a
Cext_147 FILL_L30_11 FILL_L50_8 129.072a
Cext_148 FILL_L30_11 FILL_L8_8 1.44799a
Cext_149 FILL_L30_11 P|PSEG_L50_0 14.7581a
Cext_150 FILL_L30_11 VSUBS 166.024a
Cext_151 FILL_L30_2 FILL_L30_3 10.022a
Cext_152 FILL_L30_2 FILL_L50_3 88.0086a
Cext_153 FILL_L30_2 FILL_L50_6 0.278727a
Cext_154 FILL_L30_2 P|PSEG_L50_0 7.06261a
Cext_155 FILL_L30_2 VSUBS 44.5204a
Cext_156 FILL_L30_3 FILL_L50_3 88.0086a
Cext_157 FILL_L30_3 FILL_L50_6 0.278727a
Cext_158 FILL_L30_3 FILL_L8_2 1.56866a
Cext_159 FILL_L30_3 P|PSEG_L50_0 7.06261a
Cext_160 FILL_L30_3 VSUBS 67.8821a
Cext_161 FILL_L30_4 FILL_L30_5 19.2731a
Cext_162 FILL_L30_4 FILL_L50_2 67.225a
Cext_163 FILL_L30_4 FILL_L50_3 1.48883a
Cext_164 FILL_L30_4 VSUBS 100.427a
Cext_165 FILL_L30_5 FILL_L30_6 19.2731a
Cext_166 FILL_L30_5 FILL_L50_4 67.225a
Cext_167 FILL_L30_5 FILL_L50_6 1.05707a
Cext_168 FILL_L30_5 FILL_L8_3 5.03466a
Cext_169 FILL_L30_5 FILL_L8_4 5.75048a
Cext_170 FILL_L30_5 P|PSEG_L50_0 3.35667a
Cext_171 FILL_L30_5 VSUBS 66.5629a
Cext_172 FILL_L30_6 FILL_L30_7 19.2731a
Cext_173 FILL_L30_6 FILL_L50_5 67.225a
Cext_174 FILL_L30_6 FILL_L8_6 5.03466a
Cext_175 FILL_L30_6 FILL_L8_7 5.75048a
Cext_176 FILL_L30_6 VSUBS 62.9415a
Cext_177 FILL_L30_7 FILL_L30_8 19.2731a
Cext_178 FILL_L30_7 FILL_L50_5 3.78756a
Cext_179 FILL_L30_7 P|PSEG_L50_0 22.9443a
Cext_180 FILL_L30_7 VSUBS 22.9463a
Cext_181 FILL_L30_8 FILL_L30_9 19.2731a
Cext_182 FILL_L30_8 FILL_L50_6 134.57a
Cext_183 FILL_L30_8 P|PSEG_L50_0 17.4023a
Cext_184 FILL_L30_8 VSUBS 19.8619a
Cext_185 FILL_L30_9 FILL_L50_6 134.57a
Cext_186 FILL_L30_9 FILL_L8_8 3.01665a
Cext_187 FILL_L30_9 P|PSEG_L50_0 15.8648a
Cext_188 FILL_L30_9 VSUBS 56.3096a
Cext_189 FILL_L50_0 FILL_L50_1 12.8511a
Cext_190 FILL_L50_0 FILL_L50_2 24.7136a
Cext_191 FILL_L50_0 VSUBS 52.0445a
Cext_192 FILL_L50_1 FILL_L50_3 12.8511a
Cext_193 FILL_L50_1 VSUBS 43.0983a
Cext_194 FILL_L50_2 FILL_L50_3 9.89728a
Cext_195 FILL_L50_2 FILL_L50_4 24.7136a
Cext_196 FILL_L50_2 VSUBS 71.9765a
Cext_197 FILL_L50_3 FILL_L50_6 98.8543a
Cext_198 FILL_L50_3 FILL_L8_2 17.2119a
Cext_199 FILL_L50_3 FILL_L8_5 14.9684a
Cext_200 FILL_L50_3 P|PSEG_L50_0 18.5737a
Cext_201 FILL_L50_3 VSUBS 344.484a
Cext_202 FILL_L50_4 FILL_L50_5 24.7136a
Cext_203 FILL_L50_4 FILL_L50_6 3.31559a
Cext_204 FILL_L50_4 P|PSEG_L50_0 9.56231a
Cext_205 FILL_L50_4 VSUBS 46.6837a
Cext_206 FILL_L50_5 FILL_L50_7 24.7136a
Cext_207 FILL_L50_5 P|PSEG_L50_0 14.2973a
Cext_208 FILL_L50_5 VSUBS 44.9567a
Cext_209 FILL_L50_6 FILL_L50_8 98.8543a
Cext_210 FILL_L50_6 FILL_L8_5 16.9128a
Cext_211 FILL_L50_6 FILL_L8_8 14.9684a
Cext_212 FILL_L50_6 P|PSEG_L50_0 399.336a
Cext_213 FILL_L50_6 VSUBS 212.77a
Cext_214 FILL_L50_7 P|PSEG_L50_0 6.86273a
Cext_215 FILL_L50_7 VSUBS 51.0783a
Cext_216 FILL_L50_8 P|PSEG_L50_0 17.6879a
Cext_217 FILL_L50_8 VSUBS 138.913a
Cext_218 FILL_L8_0 FILL_L8_1 40.225a
Cext_219 FILL_L8_0 FILL_L8_3 18.7186a
Cext_220 FILL_L8_0 VSUBS 251.734a
Cext_221 FILL_L8_1 FILL_L8_2 40.225a
Cext_222 FILL_L8_1 FILL_L8_4 69.6968a
Cext_223 FILL_L8_1 VSUBS 559.513a
Cext_224 FILL_L8_2 FILL_L8_5 69.6968a
Cext_225 FILL_L8_2 VSUBS 593.02a
Cext_226 FILL_L8_3 FILL_L8_4 69.6968a
Cext_227 FILL_L8_3 FILL_L8_6 18.7186a
Cext_228 FILL_L8_3 VSUBS 377.479a
Cext_229 FILL_L8_4 FILL_L8_5 69.6968a
Cext_230 FILL_L8_4 FILL_L8_7 69.6968a
Cext_231 FILL_L8_4 P|PSEG_L50_0 2.53362a
Cext_232 FILL_L8_4 VSUBS 750.914a
Cext_233 FILL_L8_5 FILL_L8_8 69.6968a
Cext_234 FILL_L8_5 P|PSEG_L50_0 3.44508a
Cext_235 FILL_L8_5 VSUBS 808.971a
Cext_236 FILL_L8_6 FILL_L8_7 69.2985a
Cext_237 FILL_L8_6 VSUBS 391.161a
Cext_238 FILL_L8_7 FILL_L8_8 69.2985a
Cext_239 FILL_L8_7 P|PSEG_L50_0 1.84631a
Cext_240 FILL_L8_7 VSUBS 805.595a
Cext_241 FILL_L8_8 P|PSEG_L50_0 1.4485a
Cext_242 FILL_L8_8 VSUBS 863.32a
Cext_243 P|PSEG_L50_0 VSUBS 400.52a
.ENDS sense_fill_clip
