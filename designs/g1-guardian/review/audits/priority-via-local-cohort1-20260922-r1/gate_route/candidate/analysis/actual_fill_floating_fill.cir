* Declared idealoutsideequipotential target pieces; othercontexts ground.
C0 0 F1 2.6654400000000002e-17
C1 0 F2 8.5508600000000014e-17
C2 0 F3 9.7172200000000004e-18
C3 0 F4 4.6727000000000001e-17
C4 0 F5 1.5746100000000002e-16
C5 0 F6 8.212900000000001e-17
C6 0 F7 4.2194100000000003e-17
C7 0 F8 1.2009600000000002e-16
C8 0 F9 8.2377000000000005e-17
C9 0 F10 1.4243e-17
C10 0 F11 2.56135e-17
C11 0 F12 7.4472900000000001e-17
C12 0 F13 3.4184100000000003e-17
C13 0 F14 7.9567800000000012e-18
C14 0 F15 5.238590000000001e-18
C15 0 F16 3.4937700000000002e-17
C16 0 F17 3.3882900000000003e-17
C17 0 F18 2.7964800000000001e-17
C18 0 F19 5.1934000000000001e-17
C19 0 F20 1.4220700000000003e-17
C20 0 F21 9.706340000000001e-18
C21 0 F22 3.4679600000000001e-17
C22 0 F23 4.79053e-17
C23 0 F24 7.6165899999999999e-17
C24 0 F25 4.1396500000000001e-16
C25 0 F26 7.3995700000000004e-17
C26 0 F27 7.2955900000000005e-17
C27 0 F28 4.68579e-16
C28 0 F29 3.5531799999999998e-17
C29 0 F30 9.4833300000000002e-17
C30 0 F31 5.0141300000000001e-18
C31 0 F32 1.3620100000000002e-17
C32 0 F33 5.3209800000000002e-18
C33 0 F34 8.9855800000000015e-18
C34 0 F35 2.4733200000000003e-17
C35 0 F36 9.6417600000000001e-18
C36 0 F37 6.5945700000000003e-18
C37 0 F38 1.7257300000000001e-17
C38 0 F39 9.769710000000001e-18
C39 0 P 3.7527000000000003e-16
C41 F1 F2 5.6429200000000008e-17
C42 F1 F4 2.6259100000000002e-17
C43 F1 F10 1.5485300000000002e-17
C44 F1 F22 5.2086900000000001e-18
C45 F1 F25 1.5977e-18
C46 F1 F31 1.2764700000000001e-16
C47 F1 0 1.4448800000000002e-16
C48 F2 F3 5.6429200000000008e-17
C49 F2 F5 9.7773300000000019e-17
C50 F2 F10 3.3262000000000001e-17
C51 F2 F11 1.0365800000000001e-16
C52 F2 F14 1.8173700000000001e-18
C53 F2 F19 7.1136800000000005e-19
C54 F2 F22 1.0791600000000002e-17
C55 F2 F23 3.09393e-17
C56 F2 F25 2.5218100000000003e-17
C57 F2 F32 4.7528100000000002e-16
C58 F2 P 5.6304699999999998e-19
C59 F2 0 2.2747100000000004e-16
C60 F3 F6 9.7773300000000019e-17
C61 F3 F14 9.3343700000000004e-17
C62 F3 F15 6.4941599999999997e-17
C63 F3 F25 1.8752600000000002e-16
C64 F3 F33 4.7528100000000002e-16
C65 F3 P 6.9045300000000005e-18
C66 F3 0 2.6945600000000002e-16
C67 F4 F5 9.7773300000000019e-17
C68 F4 F7 2.6259100000000002e-17
C69 F4 F17 2.9779400000000003e-17
C70 F4 F26 1.0016700000000002e-17
C71 F4 F34 2.2117e-16
C72 F4 P 8.3162200000000002e-19
C73 F4 0 1.9719700000000003e-16
C74 F5 F6 9.7773300000000019e-17
C75 F5 F8 9.7773300000000019e-17
C76 F5 F11 4.3264300000000003e-18
C77 F5 F12 4.7654900000000001e-18
C78 F5 F17 6.8831000000000006e-17
C79 F5 F19 1.04782e-17
C80 F5 F23 8.43572e-18
C81 F5 F26 2.8144400000000003e-17
C82 F5 F28 5.1802000000000004e-18
C83 F5 F35 8.2350600000000007e-16
C84 F5 P 6.54979e-17
C85 F5 0 1.9621900000000002e-16
C86 F6 F9 9.7773300000000019e-17
C87 F6 F13 1.8383300000000001e-18
C88 F6 F14 3.54067e-18
C89 F6 F15 1.7703300000000001e-18
C90 F6 F17 1.3084800000000001e-18
C91 F6 F20 5.4339800000000003e-18
C92 F6 F21 2.7169900000000001e-18
C93 F6 F25 1.0890100000000001e-16
C94 F6 F28 2.19153e-16
C95 F6 F36 8.2350600000000007e-16
C96 F6 P 3.1353200000000002e-16
C97 F6 0 2.6896499999999997e-16
C98 F7 F8 9.7214600000000016e-17
C99 F7 F12 1.4294100000000002e-17
C100 F7 F18 2.9779400000000003e-17
C101 F7 F27 1.0016700000000002e-17
C102 F7 F29 4.8080200000000004e-18
C103 F7 F37 2.1990600000000001e-16
C104 F7 P 3.3264900000000002e-18
C105 F7 0 2.1575600000000001e-16
C106 F8 F9 9.7214600000000016e-17
C107 F8 F12 2.47197e-16
C108 F8 F13 1.67757e-18
C109 F8 F18 6.3965400000000009e-17
C110 F8 F19 1.6848400000000002e-16
C111 F8 F20 3.4949400000000003e-18
C112 F8 F27 2.25874e-17
C113 F8 F29 8.8047100000000015e-19
C114 F8 F38 8.1880000000000001e-16
C115 F8 P 8.5555500000000001e-17
C116 F8 0 2.6839700000000003e-16
C117 F9 F13 2.7009699999999999e-16
C118 F9 F20 1.48648e-16
C119 F9 F21 1.0945800000000001e-16
C120 F9 F28 1.5514500000000003e-16
C121 F9 F30 7.2635900000000007e-17
C122 F9 F39 8.1880000000000001e-16
C123 F9 P 4.7054800000000006e-17
C124 F9 0 3.4072700000000001e-16
C125 F10 F11 1.0022000000000001e-17
C126 F10 F16 1.92731e-17
C127 F10 F22 3.4957000000000003e-17
C128 F10 F31 2.6180200000000001e-18
C129 F10 F32 2.9902500000000003e-18
C130 F10 0 6.3567100000000007e-17
C131 F11 F14 1.0022000000000001e-17
C132 F11 F19 4.7365199999999997e-18
C133 F11 F23 3.4957000000000003e-17
C134 F11 0 4.6844200000000002e-17
C135 F12 F13 9.2511100000000013e-18
C136 F12 F18 1.92731e-17
C137 F12 F19 1.92731e-17
C138 F12 F29 5.3627600000000003e-17
C139 F12 F37 2.4166300000000003e-18
C140 F12 F38 2.7602300000000001e-18
C141 F12 P 1.5186600000000002e-17
C142 F12 0 1.7215000000000002e-16
C143 F13 F20 1.92731e-17
C144 F13 F21 1.92731e-17
C145 F13 F28 1.1894600000000001e-17
C146 F13 F30 1.29072e-16
C147 F13 F39 1.4479900000000002e-18
C148 F13 P 1.4758100000000002e-17
C149 F13 0 1.66024e-16
C150 F14 F15 1.0022000000000001e-17
C151 F14 F25 8.8008600000000005e-17
C152 F14 F28 2.7872700000000002e-19
C153 F14 P 7.062610000000001e-18
C154 F14 0 4.4520400000000002e-17
C155 F15 F25 8.8008600000000005e-17
C156 F15 F28 2.7872700000000002e-19
C157 F15 F33 1.5686600000000001e-18
C158 F15 P 7.062610000000001e-18
C159 F15 0 6.7882099999999997e-17
C160 F16 F17 1.92731e-17
C161 F16 F24 6.7224999999999998e-17
C162 F16 F25 1.4888300000000001e-18
C163 F16 0 1.0042700000000001e-16
C164 F17 F18 1.92731e-17
C165 F17 F26 6.7224999999999998e-17
C166 F17 F28 1.05707e-18
C167 F17 F34 5.0346600000000001e-18
C168 F17 F35 5.7504800000000001e-18
C169 F17 P 3.35667e-18
C170 F17 0 6.6562899999999999e-17
C171 F18 F19 1.92731e-17
C172 F18 F27 6.7224999999999998e-17
C173 F18 F37 5.0346600000000001e-18
C174 F18 F38 5.7504800000000001e-18
C175 F18 0 6.2941500000000007e-17
C176 F19 F20 1.92731e-17
C177 F19 F27 3.7875600000000001e-18
C178 F19 P 2.2944299999999999e-17
C179 F19 0 2.2946300000000002e-17
C180 F20 F21 1.92731e-17
C181 F20 F28 1.3457000000000001e-16
C182 F20 P 1.7402300000000002e-17
C183 F20 0 1.9861900000000001e-17
C184 F21 F28 1.3457000000000001e-16
C185 F21 F39 3.01665e-18
C186 F21 P 1.5864800000000002e-17
C187 F21 0 5.6309600000000007e-17
C188 F22 F23 1.2851100000000001e-17
C189 F22 F24 2.4713600000000001e-17
C190 F22 0 5.2044500000000001e-17
C191 F23 F25 1.2851100000000001e-17
C192 F23 0 4.3098300000000004e-17
C193 F24 F25 9.897280000000001e-18
C194 F24 F26 2.4713600000000001e-17
C195 F24 0 7.1976500000000002e-17
C196 F25 F28 9.8854299999999996e-17
C197 F25 F33 1.72119e-17
C198 F25 F36 1.4968400000000001e-17
C199 F25 P 1.8573700000000002e-17
C200 F25 0 3.44484e-16
C201 F26 F27 2.4713600000000001e-17
C202 F26 F28 3.3155900000000002e-18
C203 F26 P 9.5623100000000001e-18
C204 F26 0 4.6683700000000007e-17
C205 F27 F29 2.4713600000000001e-17
C206 F27 P 1.4297300000000002e-17
C207 F27 0 4.4956700000000004e-17
C208 F28 F30 9.8854299999999996e-17
C209 F28 F36 1.6912800000000001e-17
C210 F28 F39 1.4968400000000001e-17
C211 F28 P 3.9933600000000003e-16
C212 F28 0 2.1277000000000003e-16
C213 F29 P 6.8627300000000005e-18
C214 F29 0 5.10783e-17
C215 F30 P 1.76879e-17
C216 F30 0 1.3891300000000002e-16
C217 F31 F32 4.0225000000000003e-17
C218 F31 F34 1.8718599999999998e-17
C219 F31 0 2.5173400000000002e-16
C220 F32 F33 4.0225000000000003e-17
C221 F32 F35 6.96968e-17
C222 F32 0 5.5951300000000005e-16
C223 F33 F36 6.96968e-17
C224 F33 0 5.9302000000000002e-16
C225 F34 F35 6.96968e-17
C226 F34 F37 1.8718599999999998e-17
C227 F34 0 3.77479e-16
C228 F35 F36 6.96968e-17
C229 F35 F38 6.96968e-17
C230 F35 P 2.53362e-18
C231 F35 0 7.5091400000000008e-16
C232 F36 F39 6.96968e-17
C233 F36 P 3.44508e-18
C234 F36 0 8.0897100000000003e-16
C235 F37 F38 6.9298500000000011e-17
C236 F37 0 3.9116100000000005e-16
C237 F38 F39 6.9298500000000011e-17
C238 F38 P 1.8463100000000001e-18
C239 F38 0 8.0559500000000013e-16
C240 F39 P 1.4485e-18
C241 F39 0 8.6332000000000009e-16
C242 P 0 4.0052e-16
VP P 0 DC 0 AC 1
.control
set numdgt=17
ac lin 1 1Meg 1Meg
let ceff = -imag(i(VP))/(2*pi*1e6)
print ceff
echo LOCAL_CAP_AC_END
quit
.endc
.end
