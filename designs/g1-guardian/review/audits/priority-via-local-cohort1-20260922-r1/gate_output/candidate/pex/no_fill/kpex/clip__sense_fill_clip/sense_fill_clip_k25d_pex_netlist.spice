*********************************************************
*** NGSPICE file created by KLayout-PEX 0.3.12
*** -----------------------------------------------------
***     Extraction Engine: KPEX/2.5D
***     Technology: ihp_sg13g2
***     Date: 2026-09-22 18:38:34
*********************************************************

.SUBCKT sense_fill_clip
Cext_1 CTX_L126_0 CTX_L134_0 796.685a
Cext_2 CTX_L126_0 P|PSEG_L50_0 542.62a
Cext_3 CTX_L126_0 VSUBS 2.59393f
Cext_4 CTX_L134_0 VSUBS 478.224a
Cext_5 P|PSEG_L50_0 VSUBS 823.031a
.ENDS sense_fill_clip
