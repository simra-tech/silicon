* Declared idealoutsideequipotential target pieces; othercontexts ground.
C1 0 F2 3.1384099999999999e-17
C2 0 F3 9.6754700000000011e-17
C3 0 F4 1.1131100000000001e-17
C4 0 F5 4.4579300000000004e-17
C5 0 F6 1.5050100000000002e-16
C6 0 F7 8.2921800000000008e-17
C7 0 F8 3.7464399999999999e-17
C8 0 F9 1.1839600000000002e-16
C9 0 F10 8.1314099999999998e-17
C10 0 F11 2.4412600000000002e-17
C11 0 F12 4.0899500000000006e-17
C12 0 F13 9.4147700000000006e-17
C13 0 F14 2.7964800000000001e-17
C14 0 F15 3.2505099999999998e-17
C15 0 F16 1.25282e-16
C16 0 F17 6.0131700000000005e-17
C17 0 F18 7.2955900000000005e-17
C18 0 F19 4.1410100000000003e-16
C19 0 F20 7.5506000000000011e-17
C20 0 F21 6.7678100000000007e-17
C21 0 F22 8.2309100000000002e-17
C22 0 F23 5.0870500000000005e-16
C23 0 F24 5.3251200000000005e-18
C24 0 F25 1.4399100000000002e-17
C25 0 F26 6.0875600000000001e-18
C26 0 F27 8.67199e-18
C27 0 F28 2.4753900000000002e-17
C28 0 F29 9.9223599999999999e-18
C29 0 F30 6.2835700000000002e-18
C30 0 F31 1.6835200000000001e-17
C31 0 F32 9.1982700000000021e-18
C32 0 P 4.5430900000000006e-16
C35 F2 F3 6.9838100000000001e-17
C36 F2 F5 2.6259100000000002e-17
C37 F2 F11 2.9779400000000003e-17
C38 F2 F13 7.1850700000000002e-19
C39 F2 F17 1.0016700000000002e-17
C40 F2 F24 1.5797900000000001e-16
C41 F2 P 5.3289700000000007e-18
C42 F2 0 1.6791900000000003e-16
C43 F3 F4 6.9838100000000001e-17
C44 F3 F6 9.7773300000000019e-17
C45 F3 F11 6.3965400000000009e-17
C46 F3 F12 1.6498900000000003e-16
C47 F3 F13 1.92122e-17
C48 F3 F17 2.25874e-17
C49 F3 F22 1.5895600000000003e-18
C50 F3 F25 5.882190000000001e-16
C51 F3 P 7.8046499999999995e-17
C52 F3 0 2.4085600000000001e-16
C53 F4 F7 9.7773300000000019e-17
C54 F4 F13 7.2221200000000009e-16
C55 F4 F26 5.882190000000001e-16
C56 F4 P 2.2083200000000003e-18
C57 F4 0 2.9288700000000001e-16
C58 F5 F6 9.7773300000000019e-17
C59 F5 F8 2.6259100000000002e-17
C60 F5 F16 6.4905100000000011e-19
C61 F5 F20 1.4846400000000001e-17
C62 F5 F23 5.3256700000000009e-19
C63 F5 F27 2.2117e-16
C64 F5 P 9.3100700000000009e-17
C65 F5 0 1.9719700000000003e-16
C66 F6 F7 9.7773300000000019e-17
C67 F6 F9 9.7773300000000019e-17
C68 F6 F12 3.0961500000000003e-18
C69 F6 F15 7.0131300000000008e-18
C70 F6 F16 1.4197900000000001e-17
C71 F6 F20 3.2030999999999999e-17
C72 F6 F22 1.4583600000000003e-17
C73 F6 F23 2.0952700000000001e-17
C74 F6 F28 8.2350600000000007e-16
C75 F6 P 4.0436800000000002e-16
C76 F6 0 1.9621900000000002e-16
C77 F7 F10 9.7773300000000019e-17
C78 F7 F13 2.3953800000000001e-16
C79 F7 F16 6.1463700000000001e-16
C80 F7 F19 7.2635900000000007e-17
C81 F7 F23 7.2635900000000007e-17
C82 F7 F29 8.2350600000000007e-16
C83 F7 P 3.6911400000000005e-17
C84 F7 0 2.6896499999999997e-16
C85 F8 F9 8.380570000000001e-17
C86 F8 F14 2.9779400000000003e-17
C87 F8 F21 1.0016700000000002e-17
C88 F8 F30 1.8957400000000004e-16
C89 F8 P 3.9587000000000004e-18
C90 F8 0 1.9232600000000002e-16
C91 F9 F10 8.380570000000001e-17
C92 F9 F14 6.3965400000000009e-17
C93 F9 F15 1.6848400000000002e-16
C94 F9 F16 3.4949400000000003e-18
C95 F9 F21 2.0753100000000001e-17
C96 F9 F22 4.7824200000000002e-17
C97 F9 F23 3.8908000000000001e-18
C98 F9 F31 7.0586200000000003e-16
C99 F9 P 1.4606900000000002e-17
C100 F9 0 2.5487200000000002e-16
C101 F10 F16 4.8960399999999998e-16
C102 F10 F23 7.2635900000000007e-17
C103 F10 F32 7.0586200000000003e-16
C104 F10 0 3.1729500000000006e-16
C105 F11 F12 1.92731e-17
C106 F11 F17 6.7224999999999998e-17
C107 F11 F18 3.0598200000000003e-18
C108 F11 F24 5.0346600000000001e-18
C109 F11 F25 5.7504800000000001e-18
C110 F11 P 7.7608700000000008e-18
C111 F11 0 9.3465599999999997e-17
C112 F12 F13 1.92731e-17
C113 F12 F17 3.7875600000000001e-18
C114 F12 P 3.0705200000000005e-17
C115 F12 0 4.8785800000000004e-17
C116 F13 F16 7.7092600000000011e-17
C117 F13 F18 6.5896400000000007e-19
C118 F13 F19 1.0756e-15
C119 F13 F26 3.5721200000000004e-17
C120 F13 F29 2.8179600000000001e-17
C121 F13 P 6.1497500000000007e-18
C122 F13 0 4.2276700000000001e-16
C123 F14 F15 1.92731e-17
C124 F14 F20 2.8422000000000002e-18
C125 F14 F21 6.7224999999999998e-17
C126 F14 F30 5.0346600000000001e-18
C127 F14 F31 5.7504800000000001e-18
C128 F14 P 1.3197500000000001e-17
C129 F14 0 8.6048900000000014e-17
C130 F15 F16 1.92731e-17
C131 F15 F22 6.7224999999999998e-17
C132 F15 P 1.3197500000000001e-17
C133 F15 0 3.7853700000000007e-17
C134 F16 F20 5.6341400000000002e-19
C135 F16 F23 1.0756e-15
C136 F16 F29 3.2704500000000003e-17
C137 F16 F32 3.11962e-17
C138 F16 P 4.3707600000000002e-18
C139 F16 0 3.7693200000000003e-16
C140 F17 F18 2.4713600000000001e-17
C141 F17 P 1.4297300000000002e-17
C142 F17 0 6.3638800000000004e-17
C143 F18 F20 2.4713600000000001e-17
C144 F18 P 1.8174600000000002e-17
C145 F18 0 7.5130500000000009e-17
C146 F19 F23 9.8854299999999996e-17
C147 F19 P 1.4739900000000002e-16
C148 F19 0 2.6636700000000002e-16
C149 F20 F21 2.4713600000000001e-17
C150 F20 F23 8.4621800000000001e-18
C151 F20 F27 2.5029e-18
C152 F20 F28 2.6423300000000002e-18
C153 F20 P 4.5536000000000002e-17
C154 F20 0 5.6606000000000002e-17
C155 F21 F22 2.4713600000000001e-17
C156 F21 0 6.3642400000000009e-17
C157 F22 F23 2.4713600000000001e-17
C158 F22 P 5.22358e-19
C159 F22 0 3.8279600000000007e-17
C160 F23 P 5.5283100000000006e-18
C161 F23 0 2.6731e-16
C162 F24 F25 4.9783400000000003e-17
C163 F24 F27 1.8718599999999998e-17
C164 F24 0 2.9757300000000002e-16
C165 F25 F26 4.9783400000000003e-17
C166 F25 F28 6.96968e-17
C167 F25 P 1.3745500000000001e-18
C168 F25 0 6.4041700000000011e-16
C169 F26 F29 6.96968e-17
C170 F26 P 1.0405899999999999e-18
C171 F26 0 6.8188600000000005e-16
C172 F27 F28 6.96968e-17
C173 F27 F30 1.8718599999999998e-17
C174 F27 P 1.6102600000000001e-18
C175 F27 0 3.77479e-16
C176 F28 F29 6.96968e-17
C177 F28 F31 6.96968e-17
C178 F28 P 3.0382100000000003e-18
C179 F28 0 7.5091400000000008e-16
C180 F29 F32 6.96968e-17
C181 F29 P 7.7211799999999999e-19
C182 F29 0 8.0897100000000003e-16
C183 F30 F31 5.9740100000000005e-17
C184 F30 0 3.4532200000000004e-16
C185 F31 F32 5.9740100000000005e-17
C186 F31 0 7.2469200000000008e-16
C187 F32 0 7.7445500000000008e-16
C188 P 0 3.5386100000000001e-16
VP P 0 DC 0 AC 1
.control
set numdgt=17
ac lin 1 1Meg 1Meg
let ceff = -imag(i(VP))/(2*pi*1e6)
print ceff
echo LOCAL_CAP_AC_END
quit
.endc
.end
