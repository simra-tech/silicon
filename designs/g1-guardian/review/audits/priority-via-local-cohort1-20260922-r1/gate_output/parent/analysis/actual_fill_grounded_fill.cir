* Declared idealoutsideequipotential target pieces; othercontexts ground.
C32 0 P 4.2659300000000005e-16
C41 0 P 5.3289700000000007e-18
C51 0 P 7.5264300000000016e-17
C56 0 P 2.2083200000000003e-18
C64 0 P 9.3167200000000005e-17
C75 0 P 3.8192800000000004e-16
C83 0 P 3.6407e-17
C89 0 P 3.9587000000000004e-18
C99 0 P 1.0856800000000001e-17
C110 0 P 7.7608700000000008e-18
C114 0 P 3.0705200000000005e-17
C121 0 P 6.1497500000000007e-18
C128 0 P 1.3197500000000001e-17
C132 0 P 1.3197500000000001e-17
C138 0 P 3.1650400000000002e-18
C141 0 P 1.4297300000000002e-17
C144 0 P 1.8174600000000002e-17
C147 0 P 1.4739900000000002e-16
C153 0 P 4.5326100000000001e-17
C158 0 P 5.22358e-19
C160 0 P 5.3432100000000007e-18
C167 0 P 1.3745500000000001e-18
C170 0 P 1.0405899999999999e-18
C174 0 P 1.6102600000000001e-18
C178 0 P 2.95708e-18
C181 0 P 7.8876800000000011e-19
C188 P 0 3.3847500000000004e-16
VP P 0 DC 0 AC 1
.control
set numdgt=17
ac lin 1 1Meg 1Meg
let ceff = -imag(i(VP))/(2*pi*1e6)
print ceff
echo LOCAL_CAP_AC_END
quit
.endc
.end
