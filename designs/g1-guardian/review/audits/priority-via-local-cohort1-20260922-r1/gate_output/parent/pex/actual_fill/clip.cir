* cell sense_fill_clip
.SUBCKT sense_fill_clip
* net 1 FILL_L8_0
* net 2 FILL_L8_1
* net 3 FILL_L8_2
* net 4 FILL_L8_3
* net 5 FILL_L8_4
* net 6 FILL_L8_5
* net 7 FILL_L8_6
* net 8 FILL_L8_7
* net 9 FILL_L8_8
* net 10 FILL_L10_0
* net 11 FILL_L10_1
* net 12 FILL_L10_2
* net 13 FILL_L10_3
* net 14 FILL_L10_4
* net 15 FILL_L10_5
* net 16 FILL_L10_6
* net 17 FILL_L10_7
* net 18 FILL_L10_8
* net 19 P,PSEG_L50_0
* net 20 FILL_L30_0
* net 21 FILL_L30_1
* net 22 FILL_L30_2
* net 23 FILL_L30_3
* net 24 FILL_L30_4
* net 25 FILL_L30_5
* net 26 FILL_L50_0
* net 27 FILL_L50_1
* net 28 FILL_L50_2
* net 29 FILL_L50_3
* net 30 FILL_L50_4
* net 31 FILL_L50_5
* net 32 FILL_L50_6
* net 33 FILL_L67_0
* net 34 FILL_L67_1
* net 35 FILL_L67_2
* net 36 FILL_L67_3
* net 37 CTX_L126_0
* net 38 CTX_L134_0
.ENDS sense_fill_clip
