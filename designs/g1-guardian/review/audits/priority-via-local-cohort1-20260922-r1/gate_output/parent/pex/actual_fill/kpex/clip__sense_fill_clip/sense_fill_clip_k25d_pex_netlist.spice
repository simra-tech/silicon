*********************************************************
*** NGSPICE file created by KLayout-PEX 0.3.12
*** -----------------------------------------------------
***     Extraction Engine: KPEX/2.5D
***     Technology: ihp_sg13g2
***     Date: 2026-09-22 18:38:26
*********************************************************

.SUBCKT sense_fill_clip
Cext_1 CTX_L126_0 CTX_L134_0 796.685a
Cext_2 CTX_L126_0 FILL_L10_0 31.3841a
Cext_3 CTX_L126_0 FILL_L10_1 96.7722a
Cext_4 CTX_L126_0 FILL_L10_2 11.1311a
Cext_5 CTX_L126_0 FILL_L10_3 44.5618a
Cext_6 CTX_L126_0 FILL_L10_4 150.883a
Cext_7 CTX_L126_0 FILL_L10_5 82.8995a
Cext_8 CTX_L126_0 FILL_L10_6 37.4644a
Cext_9 CTX_L126_0 FILL_L10_7 118.414a
Cext_10 CTX_L126_0 FILL_L10_8 81.3141a
Cext_11 CTX_L126_0 FILL_L30_0 24.4126a
Cext_12 CTX_L126_0 FILL_L30_1 40.8995a
Cext_13 CTX_L126_0 FILL_L30_2 94.1477a
Cext_14 CTX_L126_0 FILL_L30_3 27.9648a
Cext_15 CTX_L126_0 FILL_L30_4 32.5051a
Cext_16 CTX_L126_0 FILL_L30_5 125.604a
Cext_17 CTX_L126_0 FILL_L50_0 60.1317a
Cext_18 CTX_L126_0 FILL_L50_1 72.9559a
Cext_19 CTX_L126_0 FILL_L50_2 414.101a
Cext_20 CTX_L126_0 FILL_L50_3 75.61a
Cext_21 CTX_L126_0 FILL_L50_4 67.6781a
Cext_22 CTX_L126_0 FILL_L50_5 82.3091a
Cext_23 CTX_L126_0 FILL_L50_6 508.698a
Cext_24 CTX_L126_0 FILL_L8_0 5.32512a
Cext_25 CTX_L126_0 FILL_L8_1 14.3225a
Cext_26 CTX_L126_0 FILL_L8_2 6.08756a
Cext_27 CTX_L126_0 FILL_L8_3 8.74867a
Cext_28 CTX_L126_0 FILL_L8_4 24.6902a
Cext_29 CTX_L126_0 FILL_L8_5 9.99107a
Cext_30 CTX_L126_0 FILL_L8_6 6.28357a
Cext_31 CTX_L126_0 FILL_L8_7 16.7585a
Cext_32 CTX_L126_0 FILL_L8_8 9.19827a
Cext_33 CTX_L126_0 P|PSEG_L50_0 426.593a
Cext_34 CTX_L126_0 VSUBS 2.09258f
Cext_35 CTX_L134_0 VSUBS 478.224a
Cext_36 FILL_L10_0 FILL_L10_1 69.8381a
Cext_37 FILL_L10_0 FILL_L10_3 26.2591a
Cext_38 FILL_L10_0 FILL_L30_0 29.7794a
Cext_39 FILL_L10_0 FILL_L30_2 0.718507a
Cext_40 FILL_L10_0 FILL_L50_0 10.0167a
Cext_41 FILL_L10_0 FILL_L8_0 157.979a
Cext_42 FILL_L10_0 P|PSEG_L50_0 5.32897a
Cext_43 FILL_L10_0 VSUBS 167.919a
Cext_44 FILL_L10_1 FILL_L10_2 69.8381a
Cext_45 FILL_L10_1 FILL_L10_4 97.7733a
Cext_46 FILL_L10_1 FILL_L30_0 63.9654a
Cext_47 FILL_L10_1 FILL_L30_1 164.989a
Cext_48 FILL_L10_1 FILL_L30_2 19.2122a
Cext_49 FILL_L10_1 FILL_L50_0 22.5874a
Cext_50 FILL_L10_1 FILL_L50_5 1.58956a
Cext_51 FILL_L10_1 FILL_L8_1 588.219a
Cext_52 FILL_L10_1 P|PSEG_L50_0 75.2643a
Cext_53 FILL_L10_1 VSUBS 240.926a
Cext_54 FILL_L10_2 FILL_L10_5 97.7733a
Cext_55 FILL_L10_2 FILL_L30_2 722.212a
Cext_56 FILL_L10_2 FILL_L8_2 588.219a
Cext_57 FILL_L10_2 P|PSEG_L50_0 2.20832a
Cext_58 FILL_L10_2 VSUBS 292.887a
Cext_59 FILL_L10_3 FILL_L10_4 97.7733a
Cext_60 FILL_L10_3 FILL_L10_6 26.2591a
Cext_61 FILL_L10_3 FILL_L30_5 0.649051a
Cext_62 FILL_L10_3 FILL_L50_3 14.814a
Cext_63 FILL_L10_3 FILL_L50_6 0.532567a
Cext_64 FILL_L10_3 FILL_L8_3 221.17a
Cext_65 FILL_L10_3 P|PSEG_L50_0 93.1672a
Cext_66 FILL_L10_3 VSUBS 197.057a
Cext_67 FILL_L10_4 FILL_L10_5 97.7733a
Cext_68 FILL_L10_4 FILL_L10_7 97.7733a
Cext_69 FILL_L10_4 FILL_L30_1 3.09615a
Cext_70 FILL_L10_4 FILL_L30_4 7.01313a
Cext_71 FILL_L10_4 FILL_L30_5 14.617a
Cext_72 FILL_L10_4 FILL_L50_3 32.1117a
Cext_73 FILL_L10_4 FILL_L50_5 14.5836a
Cext_74 FILL_L10_4 FILL_L50_6 20.9527a
Cext_75 FILL_L10_4 FILL_L8_4 823.506a
Cext_76 FILL_L10_4 P|PSEG_L50_0 381.928a
Cext_77 FILL_L10_4 VSUBS 196.219a
Cext_78 FILL_L10_5 FILL_L10_8 97.7733a
Cext_79 FILL_L10_5 FILL_L30_2 239.538a
Cext_80 FILL_L10_5 FILL_L30_5 614.637a
Cext_81 FILL_L10_5 FILL_L50_2 72.6359a
Cext_82 FILL_L10_5 FILL_L50_6 72.6359a
Cext_83 FILL_L10_5 FILL_L8_5 823.506a
Cext_84 FILL_L10_5 P|PSEG_L50_0 36.407a
Cext_85 FILL_L10_5 VSUBS 268.825a
Cext_86 FILL_L10_6 FILL_L10_7 83.8057a
Cext_87 FILL_L10_6 FILL_L30_3 29.7794a
Cext_88 FILL_L10_6 FILL_L50_4 10.0167a
Cext_89 FILL_L10_6 FILL_L8_6 189.574a
Cext_90 FILL_L10_6 P|PSEG_L50_0 3.9587a
Cext_91 FILL_L10_6 VSUBS 192.326a
Cext_92 FILL_L10_7 FILL_L10_8 83.8057a
Cext_93 FILL_L10_7 FILL_L30_3 63.9654a
Cext_94 FILL_L10_7 FILL_L30_4 168.484a
Cext_95 FILL_L10_7 FILL_L30_5 3.49494a
Cext_96 FILL_L10_7 FILL_L50_4 20.7531a
Cext_97 FILL_L10_7 FILL_L50_5 47.8242a
Cext_98 FILL_L10_7 FILL_L50_6 3.8908a
Cext_99 FILL_L10_7 FILL_L8_7 705.862a
Cext_100 FILL_L10_7 P|PSEG_L50_0 10.8568a
Cext_101 FILL_L10_7 VSUBS 254.942a
Cext_102 FILL_L10_8 FILL_L30_5 489.604a
Cext_103 FILL_L10_8 FILL_L50_6 72.6359a
Cext_104 FILL_L10_8 FILL_L8_8 705.862a
Cext_105 FILL_L10_8 VSUBS 317.295a
Cext_106 FILL_L30_0 FILL_L30_1 19.2731a
Cext_107 FILL_L30_0 FILL_L50_0 67.225a
Cext_108 FILL_L30_0 FILL_L50_1 3.05982a
Cext_109 FILL_L30_0 FILL_L8_0 5.03466a
Cext_110 FILL_L30_0 FILL_L8_1 5.75048a
Cext_111 FILL_L30_0 P|PSEG_L50_0 7.76087a
Cext_112 FILL_L30_0 VSUBS 93.4656a
Cext_113 FILL_L30_1 FILL_L30_2 19.2731a
Cext_114 FILL_L30_1 FILL_L50_0 3.78756a
Cext_115 FILL_L30_1 P|PSEG_L50_0 30.7052a
Cext_116 FILL_L30_1 VSUBS 48.7858a
Cext_117 FILL_L30_2 FILL_L30_5 77.0926a
Cext_118 FILL_L30_2 FILL_L50_1 0.658964a
Cext_119 FILL_L30_2 FILL_L50_2 1.0756f
Cext_120 FILL_L30_2 FILL_L8_2 35.7212a
Cext_121 FILL_L30_2 FILL_L8_5 28.1796a
Cext_122 FILL_L30_2 P|PSEG_L50_0 6.14975a
Cext_123 FILL_L30_2 VSUBS 422.767a
Cext_124 FILL_L30_3 FILL_L30_4 19.2731a
Cext_125 FILL_L30_3 FILL_L50_3 2.8422a
Cext_126 FILL_L30_3 FILL_L50_4 67.225a
Cext_127 FILL_L30_3 FILL_L8_6 5.03466a
Cext_128 FILL_L30_3 FILL_L8_7 5.75048a
Cext_129 FILL_L30_3 P|PSEG_L50_0 13.1975a
Cext_130 FILL_L30_3 VSUBS 86.0489a
Cext_131 FILL_L30_4 FILL_L30_5 19.2731a
Cext_132 FILL_L30_4 FILL_L50_5 67.225a
Cext_133 FILL_L30_4 P|PSEG_L50_0 13.1975a
Cext_134 FILL_L30_4 VSUBS 37.8537a
Cext_135 FILL_L30_5 FILL_L50_3 0.563414a
Cext_136 FILL_L30_5 FILL_L50_6 1.0756f
Cext_137 FILL_L30_5 FILL_L8_5 32.7045a
Cext_138 FILL_L30_5 FILL_L8_8 31.1962a
Cext_139 FILL_L30_5 P|PSEG_L50_0 3.16504a
Cext_140 FILL_L30_5 VSUBS 377.083a
Cext_141 FILL_L50_0 FILL_L50_1 24.7136a
Cext_142 FILL_L50_0 P|PSEG_L50_0 14.2973a
Cext_143 FILL_L50_0 VSUBS 63.6388a
Cext_144 FILL_L50_1 FILL_L50_3 24.7136a
Cext_145 FILL_L50_1 P|PSEG_L50_0 18.1746a
Cext_146 FILL_L50_1 VSUBS 75.1305a
Cext_147 FILL_L50_2 FILL_L50_6 98.8543a
Cext_148 FILL_L50_2 P|PSEG_L50_0 147.399a
Cext_149 FILL_L50_2 VSUBS 266.367a
Cext_150 FILL_L50_3 FILL_L50_4 24.7136a
Cext_151 FILL_L50_3 FILL_L50_6 8.46218a
Cext_152 FILL_L50_3 FILL_L8_3 2.48899a
Cext_153 FILL_L50_3 FILL_L8_4 2.64233a
Cext_154 FILL_L50_3 P|PSEG_L50_0 45.3261a
Cext_155 FILL_L50_3 VSUBS 56.606a
Cext_156 FILL_L50_4 FILL_L50_5 24.7136a
Cext_157 FILL_L50_4 VSUBS 63.6424a
Cext_158 FILL_L50_5 FILL_L50_6 24.7136a
Cext_159 FILL_L50_5 P|PSEG_L50_0 0.522358a
Cext_160 FILL_L50_5 VSUBS 38.2796a
Cext_161 FILL_L50_6 P|PSEG_L50_0 5.34321a
Cext_162 FILL_L50_6 VSUBS 267.285a
Cext_163 FILL_L8_0 FILL_L8_1 49.7834a
Cext_164 FILL_L8_0 FILL_L8_3 18.7186a
Cext_165 FILL_L8_0 VSUBS 297.573a
Cext_166 FILL_L8_1 FILL_L8_2 49.7834a
Cext_167 FILL_L8_1 FILL_L8_4 69.6968a
Cext_168 FILL_L8_1 P|PSEG_L50_0 1.37455a
Cext_169 FILL_L8_1 VSUBS 640.417a
Cext_170 FILL_L8_2 FILL_L8_5 69.6968a
Cext_171 FILL_L8_2 P|PSEG_L50_0 1.04059a
Cext_172 FILL_L8_2 VSUBS 681.886a
Cext_173 FILL_L8_3 FILL_L8_4 69.6968a
Cext_174 FILL_L8_3 FILL_L8_6 18.7186a
Cext_175 FILL_L8_3 P|PSEG_L50_0 1.61026a
Cext_176 FILL_L8_3 VSUBS 377.479a
Cext_177 FILL_L8_4 FILL_L8_5 69.6968a
Cext_178 FILL_L8_4 FILL_L8_7 69.6968a
Cext_179 FILL_L8_4 P|PSEG_L50_0 2.95708a
Cext_180 FILL_L8_4 VSUBS 750.914a
Cext_181 FILL_L8_5 FILL_L8_8 69.6968a
Cext_182 FILL_L8_5 P|PSEG_L50_0 0.788768a
Cext_183 FILL_L8_5 VSUBS 808.971a
Cext_184 FILL_L8_6 FILL_L8_7 59.7401a
Cext_185 FILL_L8_6 VSUBS 345.322a
Cext_186 FILL_L8_7 FILL_L8_8 59.7401a
Cext_187 FILL_L8_7 VSUBS 724.692a
Cext_188 FILL_L8_8 VSUBS 774.455a
Cext_189 P|PSEG_L50_0 VSUBS 338.475a
.ENDS sense_fill_clip
