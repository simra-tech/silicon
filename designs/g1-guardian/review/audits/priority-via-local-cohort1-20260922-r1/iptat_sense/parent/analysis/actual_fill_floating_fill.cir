* Declared idealoutsideequipotential target pieces; othercontexts ground.
C2 0 F5 3.3354399999999999e-17
C3 0 F8 1.8738499999999999e-17
C4 0 F9 1.8738499999999999e-17
C5 0 F11 6.5584599999999995e-17
C6 0 F14 1.0563500000000001e-17
C7 0 F15 2.1929600000000001e-17
C8 0 F16 2.1324600000000002e-16
C9 0 F18 1.9131600000000003e-16
C10 0 F19 1.64424e-19
C11 0 F20 4.1506200000000003e-18
C12 0 F25 1.3804900000000002e-18
C13 0 F27 8.3012400000000007e-18
C14 0 F28 1.3875599999999999e-19
C15 0 F31 4.1506200000000003e-18
C16 0 F32 8.5591399999999996e-17
C17 0 F34 1.6499500000000001e-16
C18 0 F42 1.6845500000000002e-16
C19 0 P 2.61663e-18
C24 0 F5 8.7723699999999998e-17
C25 0 F6 1.14479e-16
C26 0 F7 1.0598300000000001e-16
C27 0 F8 1.0363400000000001e-17
C28 0 F10 1.2122700000000001e-18
C29 0 F11 8.7283400000000005e-19
C30 0 F12 4.1454700000000001e-19
C31 0 F14 2.1536600000000002e-16
C32 0 F16 2.5501900000000001e-17
C33 0 F21 4.9230100000000001e-17
C34 0 F22 2.6557300000000004e-19
C35 0 F23 1.28361e-18
C36 0 F24 1.80903e-17
C37 0 F25 6.59262e-17
C38 0 F26 2.1107100000000001e-16
C39 0 F27 5.0378000000000003e-18
C40 0 F28 1.7174900000000002e-17
C41 0 F29 3.7432000000000004e-16
C42 0 F30 9.7934400000000015e-19
C43 0 F32 9.0508700000000009e-19
C44 0 F33 2.7501600000000002e-19
C45 0 F37 1.6143899999999999e-17
C46 0 F38 1.34094e-17
C47 0 F39 2.0273700000000001e-18
C48 0 F40 4.7358500000000006e-17
C49 0 F41 4.1889499999999999e-17
C50 0 P 1.34664e-16
C54 0 F10 1.4020200000000002e-17
C55 0 F11 7.6529299999999995e-18
C56 0 F12 1.003e-17
C57 0 F13 1.1161200000000001e-16
C58 0 F14 8.1569000000000007e-17
C59 0 F17 8.0943100000000014e-18
C60 0 F18 9.8442900000000011e-18
C61 0 F19 5.8279000000000004e-18
C62 0 F22 4.04463e-18
C63 0 F23 3.64207e-16
C64 0 F29 1.8211200000000004e-17
C65 0 F30 5.7780400000000001e-18
C66 0 F36 1.4193700000000002e-17
C67 0 F41 5.6448500000000006e-19
C68 0 P 1.6821000000000003e-17
C71 0 F5 5.6204900000000011e-17
C72 0 F6 1.9866800000000001e-18
C73 0 F8 7.4845200000000004e-19
C74 0 F9 5.987620000000001e-19
C75 0 F10 5.0836400000000002e-18
C76 0 F11 1.10466e-16
C77 0 F12 5.0836400000000002e-18
C78 0 F14 4.1031900000000001e-17
C79 0 F15 7.2622e-19
C80 0 F16 5.83738e-18
C81 0 F17 2.9479500000000002e-18
C82 0 F18 4.7701000000000005e-18
C83 0 F19 2.9942500000000005e-18
C84 0 F21 6.375600000000001e-18
C85 0 F22 2.4654200000000002e-18
C86 0 F23 1.7338400000000001e-18
C87 0 F24 4.4445400000000004e-19
C88 0 F25 2.68844e-18
C89 0 F27 9.421680000000001e-19
C90 0 F28 1.7819100000000003e-18
C91 0 F29 3.4066600000000004e-18
C92 0 F30 3.1764600000000003e-18
C93 0 F32 4.3411400000000005e-18
C94 0 F33 1.0790500000000001e-17
C95 0 F34 8.348340000000001e-18
C96 0 F35 1.0790500000000001e-17
C97 0 F37 1.9641100000000003e-17
C98 0 F39 1.0790500000000001e-17
C99 0 F40 1.9641100000000003e-17
C100 0 F42 8.348340000000001e-18
C101 0 F43 1.0790500000000001e-17
C102 0 F44 1.0790500000000001e-17
C103 0 P 5.0254500000000006e-17
C105 0 F10 4.4395100000000005e-17
C106 0 F11 1.0522199999999999e-18
C107 0 F12 4.1661700000000004e-17
C108 0 F13 1.33601e-18
C109 0 F14 3.2409500000000003e-17
C110 0 F17 2.8473100000000005e-19
C111 0 F18 5.1625500000000001e-19
C112 0 F19 3.3457400000000002e-19
C113 0 F22 1.9647300000000004e-18
C114 0 F23 1.2059300000000002e-17
C115 0 F29 5.9424900000000008e-18
C116 0 F30 1.99149e-18
C117 0 F36 3.1118800000000001e-17
C118 0 F40 1.5851400000000001e-18
C119 0 F41 8.8063100000000004e-18
C120 0 P 1.4486000000000001e-17
C122 F5 F6 2.08343e-17
C123 F5 F8 2.7935199999999999e-17
C124 F5 F11 1.5842400000000001e-17
C125 F5 F14 1.4585200000000002e-17
C126 F5 F15 2.14973e-17
C127 F5 F17 7.1214000000000007e-19
C128 F5 F20 5.8108700000000012e-18
C129 F5 F21 4.2509200000000002e-17
C130 F5 F24 4.7277500000000007e-19
C131 F5 F25 2.0914400000000003e-17
C132 F5 F32 1.33029e-17
C133 F5 F33 1.1117900000000002e-16
C134 F5 P 1.2339800000000001e-18
C135 F5 0 3.7812900000000003e-16
C136 F6 F7 2.7935199999999999e-17
C137 F6 F14 5.9923700000000006e-18
C138 F6 F21 3.8789699999999999e-18
C139 F6 F26 2.4093700000000001e-18
C140 F6 F28 3.5599799999999999e-19
C141 F6 F37 6.7224999999999998e-17
C142 F6 F40 5.7366599999999999e-18
C143 F6 P 1.0736400000000001e-17
C144 F6 0 8.4500900000000003e-17
C145 F7 F24 7.7579399999999999e-18
C146 F7 F29 8.2590900000000012e-18
C147 F7 F38 6.7224999999999998e-17
C148 F7 F41 5.7366599999999999e-18
C149 F7 P 1.0736400000000001e-17
C150 F7 0 1.03603e-16
C151 F8 F9 2.7935199999999999e-17
C152 F8 F14 7.9558500000000007e-18
C153 F8 F16 6.2361300000000004e-17
C154 F8 F27 1.2043600000000001e-17
C155 F8 F29 9.9050999999999998e-19
C156 F8 F39 6.7224999999999998e-17
C157 F8 F40 9.8496300000000011e-19
C158 F8 F41 4.4079600000000002e-19
C159 F8 F42 4.5933800000000003e-18
C160 F8 0 7.1967800000000003e-17
C161 F9 F11 2.7935199999999999e-17
C162 F9 F14 1.1497500000000001e-17
C163 F9 F16 3.1180599999999999e-17
C164 F9 F27 6.0217800000000003e-18
C165 F9 F28 6.3030300000000001e-19
C166 F9 F29 1.8291600000000002e-19
C167 F9 F42 4.5933800000000003e-18
C168 F9 F43 6.7224999999999998e-17
C169 F9 P 1.1119700000000001e-17
C170 F9 0 7.3454100000000004e-17
C171 F10 F11 2.08343e-17
C172 F10 F12 2.7935199999999999e-17
C173 F10 F14 1.8834800000000004e-17
C174 F10 F17 2.6737000000000003e-18
C175 F10 F23 5.5857400000000008e-18
C176 F10 F28 6.8807900000000007e-19
C177 F10 F30 2.1761200000000001e-17
C178 F10 F40 6.23543e-19
C179 F10 P 1.7859000000000003e-17
C180 F10 0 9.4705400000000005e-17
C181 F11 F12 2.08343e-17
C182 F11 F14 1.0609600000000001e-16
C183 F11 F17 1.6848400000000002e-16
C184 F11 F18 2.6134399999999999e-16
C185 F11 F19 1.11779e-16
C186 F11 F22 1.1954e-18
C187 F11 F23 8.1399500000000009e-19
C188 F11 F25 3.3418100000000003e-18
C189 F11 F30 2.3908100000000001e-18
C190 F11 F31 8.8613600000000017e-17
C191 F11 F34 2.5935800000000003e-17
C192 F11 F35 1.1751300000000001e-16
C193 F11 F44 1.1751300000000001e-16
C194 F11 P 1.0181200000000001e-16
C195 F11 0 5.29872e-16
C196 F12 F13 2.7935199999999999e-17
C197 F12 F14 1.6944800000000002e-17
C198 F12 F18 3.4326700000000001e-19
C199 F12 F19 1.3368500000000001e-18
C200 F12 F22 1.4905699999999999e-17
C201 F12 F23 5.4378300000000004e-18
C202 F12 F30 1.9454000000000001e-18
C203 F12 F40 2.6003199999999999e-19
C204 F12 P 2.8294800000000004e-18
C205 F12 0 8.9694500000000012e-17
C206 F13 F14 2.4259200000000002e-18
C207 F13 F23 7.3803500000000009e-18
C208 F13 F29 4.3902900000000003e-19
C209 F13 F36 6.7224999999999998e-17
C210 F13 P 8.5075800000000014e-18
C211 F13 0 1.1140100000000001e-16
C212 F14 F16 1.0469500000000001e-17
C213 F14 F17 3.1375700000000002e-17
C214 F14 F18 1.57258e-17
C215 F14 F19 1.8309100000000001e-17
C216 F14 F21 3.8473000000000002e-17
C217 F14 F22 4.1033999999999999e-17
C218 F14 F23 1.2114600000000001e-16
C219 F14 F25 4.2324800000000008e-17
C220 F14 F26 5.7724200000000012e-17
C221 F14 F27 7.6951700000000012e-17
C222 F14 F28 6.8225800000000006e-17
C223 F14 F29 1.3296100000000001e-16
C224 F14 F30 6.5486199999999999e-17
C225 F14 F31 5.9834400000000012e-17
C226 F14 F34 2.2445100000000003e-19
C227 F14 F35 2.0360400000000002e-19
C228 F14 F36 1.2342400000000001e-18
C229 F14 F39 5.4721800000000004e-19
C230 F14 F40 4.7090200000000004e-18
C231 F14 F42 3.1817000000000006e-18
C232 F14 F43 7.4008300000000013e-19
C233 F14 F44 2.0360400000000002e-19
C234 F14 P 2.7384100000000005e-16
C235 F14 0 9.8352500000000014e-16
C236 F15 F16 4.9339300000000007e-17
C237 F15 F20 4.8186900000000004e-17
C238 F15 F21 1.76412e-18
C239 F15 F32 2.2592700000000002e-17
C240 F15 0 1.1877600000000001e-16
C241 F16 F18 4.9339300000000007e-17
C242 F16 F25 3.0598200000000003e-18
C243 F16 F27 6.8838400000000002e-16
C244 F16 F32 1.6974300000000001e-17
C245 F16 F39 8.0512999999999997e-18
C246 F16 F42 9.428830000000001e-17
C247 F16 F43 4.0256499999999998e-18
C248 F16 P 1.3039000000000001e-17
C249 F16 0 3.3137200000000003e-16
C250 F17 F18 1.92731e-17
C251 F17 F19 1.92731e-17
C252 F17 F25 1.4746500000000001e-18
C253 F17 F30 3.0598200000000003e-18
C254 F17 F31 3.7875600000000001e-18
C255 F17 P 2.6685800000000003e-17
C256 F17 0 4.3046800000000001e-17
C257 F18 F19 1.3876700000000001e-17
C258 F18 F31 6.4019700000000008e-16
C259 F18 F34 9.8934400000000009e-17
C260 F18 F35 8.0512999999999997e-18
C261 F18 F42 3.4081600000000004e-18
C262 F18 F44 8.0512999999999997e-18
C263 F18 P 6.5078100000000007e-19
C264 F18 0 3.1444600000000004e-16
C265 F19 F22 2.1418800000000003e-18
C266 F19 F31 2.6512900000000002e-18
C267 F19 P 1.9213700000000001e-17
C268 F19 0 4.8517200000000009e-17
C269 F20 F21 6.9198000000000007e-18
C270 F20 F27 6.3266700000000006e-17
C271 F20 F32 9.5410600000000003e-18
C272 F20 0 1.0031700000000001e-16
C273 F21 F24 6.9198000000000007e-18
C274 F21 F25 2.4713600000000001e-17
C275 F21 F26 2.4713600000000001e-17
C276 F21 F37 4.0827599999999999e-19
C277 F21 P 3.5131199999999997e-18
C278 F21 0 1.5025200000000001e-16
C279 F22 F23 1.7793800000000002e-17
C280 F22 F30 2.4713600000000001e-17
C281 F22 P 2.4714900000000001e-17
C282 F22 0 5.1444000000000005e-17
C283 F23 F29 3.5587500000000003e-17
C284 F23 F30 2.4713600000000001e-17
C285 F23 F36 1.9752000000000001e-18
C286 F23 P 2.5762600000000002e-17
C287 F23 0 2.1816900000000004e-16
C288 F24 F29 3.5587500000000003e-17
C289 F24 F38 8.1655300000000008e-19
C290 F24 P 1.3079600000000001e-19
C291 F24 0 6.1601199999999999e-17
C292 F25 F26 2.4713600000000001e-17
C293 F25 F27 2.4713600000000001e-17
C294 F25 0 4.4137500000000007e-17
C295 F26 F28 2.4713600000000001e-17
C296 F26 F29 2.4713600000000001e-17
C297 F26 0 8.7957699999999998e-18
C298 F27 F28 5.6909400000000008e-18
C299 F27 F29 1.2375300000000001e-17
C300 F27 F31 6.3266700000000006e-17
C301 F27 F32 8.9144400000000014e-18
C302 F27 F42 3.3367900000000005e-18
C303 F27 P 8.3723500000000015e-18
C304 F27 0 2.1679000000000002e-16
C305 F28 F29 2.4713600000000001e-17
C306 F28 F30 2.4713600000000001e-17
C307 F28 F40 8.9366100000000008e-19
C308 F28 P 9.7998700000000002e-17
C309 F28 0 3.5777299999999998e-17
C310 F29 F41 4.6396000000000003e-18
C311 F29 P 3.6238900000000005e-17
C312 F29 0 1.9316200000000003e-16
C313 F30 P 3.5287e-17
C314 F30 0 3.6233600000000004e-17
C315 F31 F42 2.7101600000000003e-18
C316 F31 P 5.5094700000000009e-17
C317 F31 0 2.07634e-16
C318 F32 F33 1.9913400000000001e-17
C319 F32 F42 2.1108200000000003e-17
C320 F32 0 2.5473900000000001e-16
C321 F33 F39 1.9913400000000001e-17
C322 F33 0 1.5147200000000001e-16
C323 F34 F35 1.9913400000000001e-17
C324 F34 F42 2.1108200000000003e-17
C325 F34 F44 1.9913400000000001e-17
C326 F34 0 4.3631800000000002e-16
C327 F35 F44 1.9913400000000001e-17
C328 F35 0 1.5147200000000001e-16
C329 F36 0 1.6809400000000001e-16
C330 F37 F38 1.9913400000000001e-17
C331 F37 F40 1.9913400000000001e-17
C332 F37 0 1.43785e-16
C333 F38 F41 1.9913400000000001e-17
C334 F38 0 1.6018500000000001e-16
C335 F39 F42 1.9913400000000001e-17
C336 F39 F43 1.9913400000000001e-17
C337 F39 0 1.34885e-16
C338 F40 F41 1.9913400000000001e-17
C339 F40 P 8.2878000000000015e-18
C340 F40 0 1.4261100000000001e-16
C341 F41 P 8.2878000000000015e-18
C342 F41 0 1.53666e-16
C343 F42 F43 1.9913400000000001e-17
C344 F42 P 1.3858900000000001e-18
C345 F42 0 4.1873500000000004e-16
C346 F43 F44 1.9913400000000001e-17
C347 F43 P 1.2193100000000001e-18
C348 F43 0 1.34885e-16
C349 F44 0 1.34885e-16
C350 P 0 6.3559600000000004e-16
VP P 0 DC 0 AC 1
.control
set numdgt=17
ac lin 1 1Meg 1Meg
let ceff = -imag(i(VP))/(2*pi*1e6)
print ceff
echo LOCAL_CAP_AC_END
quit
.endc
.end
