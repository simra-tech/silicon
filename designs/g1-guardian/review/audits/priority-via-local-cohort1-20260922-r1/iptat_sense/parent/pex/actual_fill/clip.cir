* cell sense_fill_clip
.SUBCKT sense_fill_clip
* net 2 FILL_L8_0
* net 3 FILL_L30_0
* net 4 FILL_L67_0
* net 5 FILL_L50_0
* net 6 FILL_L10_0
* net 7 FILL_L67_1
* net 8 FILL_L50_1
* net 9 FILL_L67_2
* net 10 FILL_L50_2
* net 11 FILL_L8_1
* net 12 FILL_L10_1
* net 13 FILL_L8_2
* net 14 FILL_L10_2
* net 15 FILL_L8_3
* net 16 FILL_L50_5
* net 17 FILL_L30_1
* net 18 FILL_L67_3
* net 19 FILL_L10_3
* net 20 FILL_L8_4
* net 21 FILL_L50_3
* net 22 FILL_L67_4
* net 23 FILL_L50_4
* net 24 FILL_L8_5
* net 25 CTX_L30_0
* net 26 FILL_L8_6
* net 27 FILL_L67_5
* net 28 FILL_L50_7
* net 29 CTX_L10_1
* net 30 FILL_L8_7
* net 31 FILL_L8_8
* net 32 FILL_L10_4
* net 33 P,PSEG_L10_0,PSEG_L50_0
* net 34 CTX_L8_0
* net 35 FILL_L126_0
* net 36 FILL_L50_6
* net 37 CTX_L8_1
* net 38 FILL_L8_10
* net 39 FILL_L30_3
* net 40 FILL_L67_6
* net 41 FILL_L50_9
* net 42 FILL_L8_11
* net 43 FILL_L8_9
* net 44 FILL_L10_6
* net 45 FILL_L30_2
* net 46 FILL_L67_7
* net 47 FILL_L50_8
* net 48 FILL_L10_7
* net 49 FILL_L10_5
* net 50 CTX_L30_2
* net 51 FILL_L10_8
* net 52 FILL_L8_12
* net 53 FILL_L50_11
* net 54 FILL_L67_8
* net 55 FILL_L30_4
* net 56 FILL_L50_10
.ENDS sense_fill_clip
