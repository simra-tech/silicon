*********************************************************
*** NGSPICE file created by KLayout-PEX 0.3.12
*** -----------------------------------------------------
***     Extraction Engine: KPEX/2.5D
***     Technology: ihp_sg13g2
***     Date: 2026-09-22 18:39:11
*********************************************************

.SUBCKT sense_fill_clip
Cext_1 CTX_L10_1 CTX_L30_0 4.17777a
Cext_2 CTX_L10_1 CTX_L8_0 2.75195a
Cext_3 CTX_L10_1 P|PSEG_L10_0|PSEG_L50_0 6.60412a
Cext_4 CTX_L10_1 VSUBS 886.449a
Cext_5 CTX_L30_0 CTX_L30_2 15.3011a
Cext_6 CTX_L30_0 CTX_L8_0 85.5035a
Cext_7 CTX_L30_0 CTX_L8_1 14.0929a
Cext_8 CTX_L30_0 P|PSEG_L10_0|PSEG_L50_0 135.737a
Cext_9 CTX_L30_0 VSUBS 730.592a
Cext_10 CTX_L30_2 CTX_L8_0 4.33437a
Cext_11 CTX_L30_2 CTX_L8_1 62.2938a
Cext_12 CTX_L30_2 P|PSEG_L10_0|PSEG_L50_0 21.723a
Cext_13 CTX_L30_2 VSUBS 402.398a
Cext_14 CTX_L8_0 CTX_L8_1 55.3806a
Cext_15 CTX_L8_0 P|PSEG_L10_0|PSEG_L50_0 52.1008a
Cext_16 CTX_L8_0 VSUBS 1.03351f
Cext_17 CTX_L8_1 P|PSEG_L10_0|PSEG_L50_0 18.1318a
Cext_18 CTX_L8_1 VSUBS 615.081a
Cext_19 P|PSEG_L10_0|PSEG_L50_0 VSUBS 878.742a
.ENDS sense_fill_clip
