* cell sense_fill_clip
.SUBCKT sense_fill_clip
* net 1 CTX_L8_0
* net 2 CTX_L8_1
* net 3 P,PSEG_L10_0,PSEG_L50_0
* net 4 CTX_L10_1
* net 5 CTX_L30_0
* net 6 CTX_L30_2
.ENDS sense_fill_clip
