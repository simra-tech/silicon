* Declared idealoutsideequipotential target pieces; othercontexts ground.
C19 0 P 2.45282e-18
C50 0 P 1.3550899999999999e-16
C68 0 P 1.6821000000000003e-17
C103 0 P 5.1493500000000004e-17
C120 0 P 1.4486000000000001e-17
C134 0 P 1.2472000000000002e-18
C143 0 P 1.0736400000000001e-17
C149 0 P 1.0736400000000001e-17
C169 0 P 1.2066800000000001e-17
C179 0 P 1.7859000000000003e-17
C194 0 P 1.0280800000000002e-16
C204 0 P 2.8294800000000004e-18
C210 0 P 8.5075800000000014e-18
C234 0 P 2.8363600000000004e-16
C248 0 P 1.3039000000000001e-17
C255 0 P 2.6685800000000003e-17
C263 0 P 6.5078100000000007e-19
C267 0 P 1.9213700000000001e-17
C277 0 P 4.2386600000000007e-18
C281 0 P 2.4714900000000001e-17
C286 0 P 2.5762600000000002e-17
C290 0 P 1.3079600000000001e-19
C303 0 P 8.4290900000000011e-18
C308 0 P 9.8272600000000005e-17
C311 0 P 3.6238900000000005e-17
C313 0 P 3.5287e-17
C316 0 P 5.5094700000000009e-17
C339 0 P 8.2878000000000015e-18
C341 0 P 8.2878000000000015e-18
C344 0 P 1.6313100000000001e-18
C347 0 P 1.22925e-18
C350 P 0 6.5316600000000015e-16
VP P 0 DC 0 AC 1
.control
set numdgt=17
ac lin 1 1Meg 1Meg
let ceff = -imag(i(VP))/(2*pi*1e6)
print ceff
echo LOCAL_CAP_AC_END
quit
.endc
.end
