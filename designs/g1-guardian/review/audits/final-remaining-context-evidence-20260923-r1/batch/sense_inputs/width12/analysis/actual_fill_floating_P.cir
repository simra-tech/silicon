* actual_fill floating drive P; diagnostic capacitor-network AC only
C7 0 FILL_L10_0 1.35421e-18
C8 0 FILL_L10_1 2.6679900000000002e-17
C9 0 FILL_L10_2 4.2962100000000001e-19
C10 0 FILL_L30_0 1.5466800000000002e-16
C11 0 FILL_L30_1 7.0851400000000002e-17
C12 0 FILL_L30_2 7.0218100000000007e-17
C13 0 FILL_L30_3 3.4865900000000005e-17
C14 0 FILL_L30_4 6.0320100000000006e-17
C15 0 FILL_L30_5 1.2992900000000001e-16
C16 0 FILL_L30_7 2.6923400000000003e-17
C17 0 FILL_L30_8 1.2960100000000002e-18
C18 0 FILL_L50_0 1.8808e-17
C19 0 FILL_L50_1 2.4612000000000001e-17
C20 0 FILL_L50_2 2.4415900000000003e-17
C21 0 FILL_L50_3 2.1647200000000003e-17
C22 0 FILL_L50_4 2.61741e-17
C23 0 FILL_L50_8 2.0798800000000001e-18
C24 0 FILL_L8_0 1.5866400000000002e-18
C25 0 FILL_L8_1 3.2162400000000001e-17
C26 0 N 5.1221400000000004e-17
C27 0 P 6.3681400000000001e-17
C43 0 FILL_L10_0 5.2372900000000001e-18
C44 0 FILL_L10_1 6.7441700000000007e-18
C45 0 FILL_L10_2 1.2551600000000002e-17
C46 0 FILL_L10_3 1.3520100000000001e-17
C47 0 FILL_L10_4 1.7650600000000002e-18
C48 0 FILL_L10_5 1.16528e-17
C49 0 FILL_L10_6 1.6793500000000002e-17
C50 0 FILL_L10_7 1.83019e-18
C51 0 FILL_L10_8 6.1456500000000001e-18
C52 0 FILL_L134_0 1.4776500000000001e-15
C53 0 FILL_L134_1 4.3040700000000002e-16
C54 0 FILL_L134_2 7.1352400000000007e-16
C55 0 FILL_L134_3 2.1467800000000001e-16
C56 0 FILL_L30_0 6.1406700000000011e-17
C57 0 FILL_L30_1 3.7849300000000004e-17
C58 0 FILL_L30_10 4.3264000000000002e-16
C59 0 FILL_L30_11 1.5964100000000001e-16
C60 0 FILL_L30_12 2.0556800000000002e-16
C61 0 FILL_L30_13 6.100730000000001e-17
C62 0 FILL_L30_14 4.8896200000000003e-17
C63 0 FILL_L30_15 2.0032700000000002e-16
C64 0 FILL_L30_16 3.0937500000000004e-17
C65 0 FILL_L30_17 1.4171000000000001e-16
C66 0 FILL_L30_2 2.4413799999999999e-17
C67 0 FILL_L30_3 5.6839800000000002e-17
C68 0 FILL_L30_4 6.1623300000000001e-17
C69 0 FILL_L30_5 6.3407900000000002e-16
C70 0 FILL_L30_6 1.3728200000000002e-16
C71 0 FILL_L30_7 2.9633800000000006e-16
C72 0 FILL_L30_8 5.9086399999999997e-17
C73 0 FILL_L30_9 3.2579000000000005e-17
C74 0 FILL_L50_0 5.4311000000000006e-17
C75 0 FILL_L50_1 7.7734000000000003e-17
C76 0 FILL_L50_10 9.6150700000000004e-17
C77 0 FILL_L50_11 1.4198500000000003e-16
C78 0 FILL_L50_12 6.9126200000000007e-17
C79 0 FILL_L50_13 9.5567600000000006e-17
C80 0 FILL_L50_14 8.3890300000000001e-17
C81 0 FILL_L50_15 6.2137100000000002e-17
C82 0 FILL_L50_16 7.3827100000000013e-17
C83 0 FILL_L50_2 6.6034600000000008e-17
C84 0 FILL_L50_3 7.2338600000000001e-17
C85 0 FILL_L50_4 9.4600400000000001e-17
C86 0 FILL_L50_5 8.136750000000001e-17
C87 0 FILL_L50_6 1.25789e-16
C88 0 FILL_L50_7 6.3081300000000007e-17
C89 0 FILL_L50_8 1.0455000000000001e-16
C90 0 FILL_L50_9 7.6788000000000002e-17
C91 0 FILL_L8_0 3.5719700000000003e-19
C92 0 FILL_L8_1 1.49284e-18
C93 0 FILL_L8_2 2.8720100000000002e-17
C94 0 FILL_L8_3 2.4398900000000004e-17
C95 0 FILL_L8_4 3.4504000000000001e-19
C96 0 FILL_L8_5 2.7426400000000004e-17
C97 0 FILL_L8_6 2.6935e-17
C98 0 FILL_L8_8 7.8660900000000005e-19
C99 0 N 6.4235200000000001e-16
C100 0 P 5.6866099999999997e-16
C102 0 FILL_L10_3 1.1979900000000002e-18
C103 0 FILL_L10_4 2.7691700000000002e-17
C104 0 FILL_L10_5 7.1717800000000008e-19
C105 0 FILL_L30_1 5.5893200000000004e-19
C106 0 FILL_L30_10 3.9251900000000005e-16
C107 0 FILL_L30_11 5.2856800000000008e-18
C108 0 FILL_L30_12 1.27078e-16
C109 0 FILL_L30_13 1.2913500000000001e-18
C110 0 FILL_L30_5 2.8580300000000002e-17
C111 0 FILL_L30_6 6.71456e-18
C112 0 FILL_L30_7 2.0186900000000002e-18
C113 0 FILL_L30_8 1.55297e-16
C114 0 FILL_L30_9 1.51908e-16
C115 0 FILL_L50_1 7.9189600000000012e-19
C116 0 FILL_L50_11 1.7142500000000001e-18
C117 0 FILL_L50_13 1.5161100000000001e-18
C118 0 FILL_L50_5 8.2088700000000003e-18
C119 0 FILL_L50_6 2.0187900000000003e-18
C120 0 FILL_L50_7 2.5994500000000001e-17
C121 0 FILL_L50_8 4.2404000000000009e-17
C122 0 FILL_L50_9 4.0194500000000003e-17
C123 0 FILL_L8_3 7.2120200000000005e-19
C124 0 FILL_L8_4 3.2203800000000004e-17
C125 0 N 4.6069200000000004e-17
C126 0 P 4.0853100000000003e-17
C134 0 FILL_L10_6 1.0359200000000001e-18
C135 0 FILL_L10_7 2.7683000000000003e-17
C136 0 FILL_L10_8 9.0842599999999994e-19
C137 0 FILL_L30_10 1.5212000000000002e-18
C138 0 FILL_L30_13 6.480070000000001e-17
C139 0 FILL_L30_14 6.4664700000000004e-17
C140 0 FILL_L30_15 5.0391400000000001e-16
C141 0 FILL_L30_16 6.6150499999999996e-17
C142 0 FILL_L30_17 1.6643000000000002e-16
C143 0 FILL_L30_8 1.84441e-19
C144 0 FILL_L50_10 1.2356100000000001e-18
C145 0 FILL_L50_12 5.9932299999999998e-18
C146 0 FILL_L50_13 2.3444700000000003e-17
C147 0 FILL_L50_14 2.3715200000000002e-17
C148 0 FILL_L50_15 1.0164900000000001e-17
C149 0 FILL_L50_16 2.6989900000000002e-17
C150 0 FILL_L50_8 2.3372600000000002e-19
C151 0 FILL_L8_7 3.2203800000000004e-17
C152 0 N 4.6483600000000004e-17
C153 0 P 3.0859700000000002e-17
C156 0 FILL_L30_0 8.7593999999999998e-18
C159 0 FILL_L30_0 1.7349900000000003e-18
C160 0 P 5.6114100000000006e-19
C163 0 FILL_L30_15 4.8499600000000007e-18
C164 0 P 1.2593000000000001e-18
C167 0 FILL_L30_15 1.4083900000000001e-19
C168 0 P 5.7389400000000003e-19
C171 0 FILL_L30_13 5.9677700000000003e-19
C172 0 FILL_L50_13 6.3012800000000003e-19
C173 0 N 1.36547e-19
C174 0 P 4.6315600000000007e-19
C177 0 FILL_L30_16 2.5160300000000005e-19
C178 0 N 3.0843800000000002e-19
C179 0 P 1.4728100000000001e-19
C182 0 FILL_L10_8 1.27384e-19
C183 0 FILL_L30_16 3.7353800000000007e-18
C184 0 FILL_L50_16 1.0139100000000002e-18
C185 0 N 5.13486e-19
C186 0 P 1.25658e-19
C188 0 FILL_L10_8 6.6961100000000001e-19
C189 0 FILL_L30_16 1.06289e-19
C190 0 FILL_L30_17 5.6050999999999995e-19
C191 0 FILL_L8_8 7.4830700000000007e-18
C192 0 N 9.7709200000000004e-19
C195 0 FILL_L30_0 8.2750800000000007e-19
C196 0 FILL_L30_1 3.2582399999999999e-18
C197 0 FILL_L30_3 1.5464400000000002e-19
C198 0 FILL_L50_1 9.8699499999999996e-19
C199 0 N 1.6050300000000001e-19
C200 0 P 4.5286400000000006e-19
C203 0 FILL_L30_0 2.2736900000000001e-19
C204 0 FILL_L30_3 2.7168000000000001e-19
C205 0 N 2.2961500000000001e-19
C206 0 P 1.7312e-19
C209 0 FILL_L10_0 1.4973200000000001e-19
C210 0 FILL_L30_0 1.68039e-19
C211 0 FILL_L30_2 3.2582399999999999e-18
C212 0 FILL_L30_3 7.3069500000000002e-19
C213 0 FILL_L50_2 9.8699499999999996e-19
C214 0 N 5.0207500000000008e-19
C215 0 P 1.4770400000000001e-19
C217 0 FILL_L10_0 6.5473000000000006e-19
C218 0 FILL_L30_3 4.6548600000000008e-18
C219 0 FILL_L8_0 7.31678e-18
C220 0 N 7.2933000000000013e-19
C222 FILL_L10_0 FILL_L10_1 5.0283400000000002e-18
C223 FILL_L10_0 FILL_L30_3 2.6091300000000002e-17
C224 FILL_L10_0 FILL_L8_0 6.6552700000000003e-18
C225 FILL_L10_0 0 4.27352e-17
C226 FILL_L10_1 FILL_L10_2 5.0283400000000002e-18
C227 FILL_L10_1 FILL_L30_3 5.4595100000000006e-18
C228 FILL_L10_1 FILL_L30_7 5.4595100000000006e-18
C229 FILL_L10_1 FILL_L8_1 1.2100500000000001e-17
C230 FILL_L10_1 N 3.8216800000000008e-18
C231 FILL_L10_1 0 5.4966000000000008e-17
C232 FILL_L10_2 FILL_L10_3 5.0283400000000002e-18
C233 FILL_L10_2 FILL_L30_7 4.9005100000000001e-17
C234 FILL_L10_2 FILL_L8_2 1.2100500000000001e-17
C235 FILL_L10_2 0 6.7231200000000003e-17
C236 FILL_L10_3 FILL_L10_4 5.0283400000000002e-18
C237 FILL_L10_3 FILL_L30_12 6.2909000000000006e-19
C238 FILL_L10_3 FILL_L30_6 5.2363700000000009e-19
C239 FILL_L10_3 FILL_L30_7 2.84756e-17
C240 FILL_L10_3 FILL_L8_3 1.2100500000000001e-17
C241 FILL_L10_3 N 1.8333700000000002e-18
C242 FILL_L10_3 0 6.7616400000000009e-17
C243 FILL_L10_4 FILL_L10_5 5.0283400000000002e-18
C244 FILL_L10_4 FILL_L30_12 4.3362500000000003e-17
C245 FILL_L10_4 FILL_L30_9 2.0490200000000002e-19
C246 FILL_L10_4 FILL_L8_4 1.2100500000000001e-17
C247 FILL_L10_4 0 5.4328900000000001e-17
C248 FILL_L10_5 FILL_L10_6 5.0283400000000002e-18
C249 FILL_L10_5 FILL_L30_11 4.6672000000000005e-19
C250 FILL_L10_5 FILL_L30_12 4.7479500000000007e-17
C251 FILL_L10_5 FILL_L8_5 1.2100500000000001e-17
C252 FILL_L10_5 0 6.7227500000000016e-17
C253 FILL_L10_6 FILL_L10_7 5.0283400000000002e-18
C254 FILL_L10_6 FILL_L30_12 2.5153500000000003e-18
C255 FILL_L10_6 FILL_L30_17 1.06091e-17
C256 FILL_L10_6 FILL_L8_6 1.2100500000000001e-17
C257 FILL_L10_6 N 3.7597100000000006e-18
C258 FILL_L10_6 0 6.7436600000000001e-17
C259 FILL_L10_7 FILL_L10_8 5.0283400000000002e-18
C260 FILL_L10_7 FILL_L30_17 4.8353600000000004e-17
C261 FILL_L10_7 FILL_L8_7 1.2100500000000001e-17
C262 FILL_L10_7 0 5.4300600000000005e-17
C263 FILL_L10_8 FILL_L30_17 8.2733700000000002e-18
C264 FILL_L10_8 FILL_L8_8 5.4452200000000004e-18
C265 FILL_L10_8 N 1.7197600000000002e-18
C266 FILL_L10_8 0 3.6768700000000004e-17
C267 FILL_L134_0 FILL_L134_1 4.5988900000000005e-16
C268 FILL_L134_0 FILL_L134_2 2.2994400000000001e-16
C269 FILL_L134_0 0 2.9847700000000002e-16
C270 FILL_L134_1 FILL_L134_3 4.2769700000000001e-17
C271 FILL_L134_1 0 3.3274500000000005e-16
C272 FILL_L134_2 FILL_L134_3 2.2534500000000002e-16
C273 FILL_L134_2 0 2.4677000000000001e-16
C274 FILL_L134_3 0 1.8175000000000002e-16
C275 FILL_L30_0 FILL_L30_1 1.92731e-17
C276 FILL_L30_0 FILL_L30_3 2.6050800000000002e-18
C277 FILL_L30_0 FILL_L30_5 4.4713700000000009e-17
C278 FILL_L30_0 FILL_L50_0 1.14801e-16
C279 FILL_L30_0 P 9.9699200000000006e-17
C280 FILL_L30_0 0 1.7624000000000003e-16
C281 FILL_L30_1 FILL_L30_2 1.92731e-17
C282 FILL_L30_1 FILL_L30_8 4.7365199999999997e-18
C283 FILL_L30_1 FILL_L50_1 6.7224999999999998e-17
C284 FILL_L30_1 0 7.0611000000000007e-17
C285 FILL_L30_10 FILL_L30_11 6.0833899999999998e-18
C286 FILL_L30_10 FILL_L30_12 9.4730399999999993e-18
C287 FILL_L30_10 FILL_L30_15 4.4713700000000009e-17
C288 FILL_L30_10 FILL_L30_5 4.4713700000000009e-17
C289 FILL_L30_10 FILL_L30_8 1.92731e-17
C290 FILL_L30_10 FILL_L50_10 1.3417300000000002e-16
C291 FILL_L30_10 FILL_L50_7 1.3417300000000002e-16
C292 FILL_L30_10 P 2.6094099999999997e-16
C293 FILL_L30_10 0 2.5986700000000002e-16
C294 FILL_L30_11 FILL_L30_12 1.92731e-17
C295 FILL_L30_11 FILL_L30_14 1.92731e-17
C296 FILL_L30_11 FILL_L30_9 1.92731e-17
C297 FILL_L30_11 FILL_L50_11 6.7224999999999998e-17
C298 FILL_L30_11 0 3.8601700000000003e-17
C299 FILL_L30_12 FILL_L30_17 3.2378900000000003e-17
C300 FILL_L30_12 FILL_L30_7 3.2378900000000003e-17
C301 FILL_L30_12 FILL_L30_9 1.92731e-17
C302 FILL_L30_12 FILL_L50_11 3.9597300000000006e-18
C303 FILL_L30_12 FILL_L50_9 3.9597300000000006e-18
C304 FILL_L30_12 FILL_L8_4 8.5910500000000002e-18
C305 FILL_L30_12 FILL_L8_5 9.9519099999999999e-18
C306 FILL_L30_12 FILL_L8_6 4.1414800000000004e-19
C307 FILL_L30_12 N 2.6112900000000005e-16
C308 FILL_L30_12 0 2.8338299999999998e-16
C309 FILL_L30_13 FILL_L30_14 1.92731e-17
C310 FILL_L30_13 FILL_L30_15 1.92731e-17
C311 FILL_L30_13 FILL_L30_8 7.6042400000000005e-18
C312 FILL_L30_13 FILL_L50_13 6.7224999999999998e-17
C313 FILL_L30_13 0 6.0225200000000008e-17
C314 FILL_L30_14 FILL_L30_16 1.92731e-17
C315 FILL_L30_14 FILL_L30_17 1.92731e-17
C316 FILL_L30_14 FILL_L50_14 6.7224999999999998e-17
C317 FILL_L30_14 0 3.4408200000000005e-17
C318 FILL_L30_15 FILL_L30_16 7.6042400000000005e-18
C319 FILL_L30_15 FILL_L30_17 9.4730399999999993e-18
C320 FILL_L30_15 FILL_L50_12 1.3417300000000002e-16
C321 FILL_L30_15 FILL_L50_15 1.3417300000000002e-16
C322 FILL_L30_15 P 2.5731000000000003e-16
C323 FILL_L30_15 0 3.0703800000000002e-16
C324 FILL_L30_16 FILL_L30_17 1.92731e-17
C325 FILL_L30_16 FILL_L50_16 6.7224999999999998e-17
C326 FILL_L30_16 0 6.8199100000000006e-17
C327 FILL_L30_17 FILL_L50_14 4.0001400000000005e-18
C328 FILL_L30_17 FILL_L50_16 4.0405400000000007e-18
C329 FILL_L30_17 FILL_L8_6 1.4492300000000001e-18
C330 FILL_L30_17 FILL_L8_7 1.00403e-17
C331 FILL_L30_17 FILL_L8_8 1.4492300000000001e-18
C332 FILL_L30_17 N 2.5749700000000004e-16
C333 FILL_L30_17 0 3.0423700000000004e-16
C334 FILL_L30_2 FILL_L30_3 1.92731e-17
C335 FILL_L30_2 FILL_L30_4 1.92731e-17
C336 FILL_L30_2 FILL_L50_2 6.7224999999999998e-17
C337 FILL_L30_2 0 5.9094000000000009e-17
C338 FILL_L30_3 FILL_L30_7 3.2378900000000003e-17
C339 FILL_L30_3 FILL_L50_2 4.0405400000000007e-18
C340 FILL_L30_3 FILL_L8_0 5.4633000000000008e-18
C341 FILL_L30_3 FILL_L8_1 9.0623799999999998e-19
C342 FILL_L30_3 N 1.0266700000000001e-16
C343 FILL_L30_3 0 1.6624500000000003e-16
C344 FILL_L30_4 FILL_L30_5 7.6042400000000005e-18
C345 FILL_L30_4 FILL_L30_6 1.92731e-17
C346 FILL_L30_4 FILL_L30_7 1.92731e-17
C347 FILL_L30_4 FILL_L50_4 6.7224999999999998e-17
C348 FILL_L30_4 0 4.2390500000000006e-17
C349 FILL_L30_5 FILL_L30_6 7.3000700000000009e-18
C350 FILL_L30_5 FILL_L30_7 5.8732800000000007e-18
C351 FILL_L30_5 FILL_L50_3 1.3417300000000002e-16
C352 FILL_L30_5 FILL_L50_5 1.3417300000000002e-16
C353 FILL_L30_5 P 2.6094099999999997e-16
C354 FILL_L30_5 0 2.6596800000000003e-16
C355 FILL_L30_6 FILL_L30_7 1.92731e-17
C356 FILL_L30_6 FILL_L30_9 1.92731e-17
C357 FILL_L30_6 FILL_L50_6 6.7224999999999998e-17
C358 FILL_L30_6 0 4.4506200000000001e-17
C359 FILL_L30_7 FILL_L50_4 4.0405400000000007e-18
C360 FILL_L30_7 FILL_L50_6 4.0405400000000007e-18
C361 FILL_L30_7 FILL_L8_1 9.0623799999999998e-19
C362 FILL_L30_7 FILL_L8_2 1.0425000000000001e-17
C363 FILL_L30_7 FILL_L8_3 5.4338100000000008e-18
C364 FILL_L30_7 N 2.6112900000000005e-16
C365 FILL_L30_7 0 2.7719099999999999e-16
C366 FILL_L30_8 FILL_L30_9 1.92731e-17
C367 FILL_L30_8 FILL_L50_8 6.7224999999999998e-17
C368 FILL_L30_8 0 3.7430900000000003e-17
C369 FILL_L30_9 FILL_L50_9 6.7224999999999998e-17
C370 FILL_L30_9 0 2.4295200000000003e-17
C371 FILL_L50_0 FILL_L50_1 2.4713600000000001e-17
C372 FILL_L50_0 FILL_L50_3 2.4713600000000001e-17
C373 FILL_L50_0 P 6.6567200000000001e-17
C374 FILL_L50_0 0 3.5262300000000004e-17
C375 FILL_L50_1 FILL_L50_2 2.4713600000000001e-17
C376 FILL_L50_1 FILL_L50_8 6.1876600000000009e-18
C377 FILL_L50_1 0 5.5810600000000004e-17
C378 FILL_L50_10 FILL_L50_11 7.9178300000000003e-18
C379 FILL_L50_10 FILL_L50_12 2.4713600000000001e-17
C380 FILL_L50_10 FILL_L50_7 2.4713600000000001e-17
C381 FILL_L50_10 P 6.6567200000000001e-17
C382 FILL_L50_10 0 1.6322500000000002e-17
C383 FILL_L50_11 FILL_L50_14 2.4713600000000001e-17
C384 FILL_L50_11 FILL_L50_9 2.4713600000000001e-17
C385 FILL_L50_11 N 1.5955500000000001e-17
C386 FILL_L50_11 0 2.8470500000000006e-17
C387 FILL_L50_12 FILL_L50_13 2.4713600000000001e-17
C388 FILL_L50_12 FILL_L50_15 2.4713600000000001e-17
C389 FILL_L50_12 P 6.6567200000000001e-17
C390 FILL_L50_12 0 1.2233800000000002e-17
C391 FILL_L50_13 FILL_L50_14 2.4713600000000001e-17
C392 FILL_L50_13 FILL_L50_8 9.897280000000001e-18
C393 FILL_L50_13 0 4.6198200000000001e-17
C394 FILL_L50_14 FILL_L50_16 2.4713600000000001e-17
C395 FILL_L50_14 N 1.5955500000000001e-17
C396 FILL_L50_14 0 1.9584499999999999e-17
C397 FILL_L50_15 FILL_L50_16 9.897280000000001e-18
C398 FILL_L50_15 P 6.6567200000000001e-17
C399 FILL_L50_15 0 4.2376300000000005e-17
C400 FILL_L50_16 N 1.5955500000000001e-17
C401 FILL_L50_16 0 5.1850500000000003e-17
C402 FILL_L50_2 FILL_L50_4 2.4713600000000001e-17
C403 FILL_L50_2 N 1.5955500000000001e-17
C404 FILL_L50_2 0 4.3658200000000001e-17
C405 FILL_L50_3 FILL_L50_4 9.897280000000001e-18
C406 FILL_L50_3 FILL_L50_5 2.4713600000000001e-17
C407 FILL_L50_3 P 6.6567200000000001e-17
C408 FILL_L50_3 0 1.6779399999999999e-17
C409 FILL_L50_4 FILL_L50_6 2.4713600000000001e-17
C410 FILL_L50_4 N 1.5955500000000001e-17
C411 FILL_L50_4 0 2.7192600000000001e-17
C412 FILL_L50_5 FILL_L50_6 9.5013900000000012e-18
C413 FILL_L50_5 FILL_L50_7 2.4713600000000001e-17
C414 FILL_L50_5 P 6.6567200000000001e-17
C415 FILL_L50_5 0 1.8485700000000003e-17
C416 FILL_L50_6 FILL_L50_9 2.4713600000000001e-17
C417 FILL_L50_6 N 1.5955500000000001e-17
C418 FILL_L50_6 0 3.2366000000000002e-17
C419 FILL_L50_7 FILL_L50_8 2.4713600000000001e-17
C420 FILL_L50_7 P 6.6567200000000001e-17
C421 FILL_L50_7 0 5.3588199999999998e-18
C422 FILL_L50_8 FILL_L50_9 2.4713600000000001e-17
C423 FILL_L50_8 0 3.1434799999999999e-17
C424 FILL_L50_9 N 1.5955500000000001e-17
C425 FILL_L50_9 0 1.80312e-17
C426 FILL_L8_0 FILL_L8_1 3.5844100000000005e-18
C427 FILL_L8_0 0 5.0964100000000008e-17
C428 FILL_L8_1 FILL_L8_2 3.5844100000000005e-18
C429 FILL_L8_1 N 5.14103e-19
C430 FILL_L8_1 0 7.561520000000001e-17
C431 FILL_L8_2 FILL_L8_3 3.5844100000000005e-18
C432 FILL_L8_2 0 7.8499499999999997e-17
C433 FILL_L8_3 FILL_L8_4 3.5844100000000005e-18
C434 FILL_L8_3 N 2.00261e-19
C435 FILL_L8_3 0 7.9409800000000004e-17
C436 FILL_L8_4 FILL_L8_5 3.5844100000000005e-18
C437 FILL_L8_4 0 7.561520000000001e-17
C438 FILL_L8_5 FILL_L8_6 3.5844100000000005e-18
C439 FILL_L8_5 0 7.8689800000000014e-17
C440 FILL_L8_6 FILL_L8_7 3.5844100000000005e-18
C441 FILL_L8_6 N 4.99158e-19
C442 FILL_L8_6 0 7.9007000000000011e-17
C443 FILL_L8_7 FILL_L8_8 3.5844100000000005e-18
C444 FILL_L8_7 0 7.561520000000001e-17
C445 FILL_L8_8 N 1.70371e-19
C446 FILL_L8_8 0 4.3363600000000002e-17
C447 N 0 7.8052200000000014e-16
C448 P 0 7.2170700000000009e-16
VP P 0 DC 0 AC 1
VN N 0 DC 0 AC 0
.control
set numdgt=17
ac lin 1 1Meg 1Meg
let cp = -imag(i(VP))/(2*pi*1e6)
let cn = -imag(i(VN))/(2*pi*1e6)
print cp cn
quit
.endc
.end
