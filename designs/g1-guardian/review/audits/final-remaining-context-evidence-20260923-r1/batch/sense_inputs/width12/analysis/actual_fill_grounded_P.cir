* actual_fill grounded drive P; diagnostic capacitor-network AC only
C26 0 N 5.1221400000000004e-17
C27 0 P 6.3681400000000001e-17
C99 0 N 6.4235200000000001e-16
C100 0 P 5.6866099999999997e-16
C125 0 N 4.6069200000000004e-17
C126 0 P 4.0853100000000003e-17
C152 0 N 4.6483600000000004e-17
C153 0 P 3.0859700000000002e-17
C160 0 P 5.6114100000000006e-19
C164 0 P 1.2593000000000001e-18
C168 0 P 5.7389400000000003e-19
C173 0 N 1.36547e-19
C174 0 P 4.6315600000000007e-19
C178 0 N 3.0843800000000002e-19
C179 0 P 1.4728100000000001e-19
C185 0 N 5.13486e-19
C186 0 P 1.25658e-19
C192 0 N 9.7709200000000004e-19
C199 0 N 1.6050300000000001e-19
C200 0 P 4.5286400000000006e-19
C205 0 N 2.2961500000000001e-19
C206 0 P 1.7312e-19
C214 0 N 5.0207500000000008e-19
C215 0 P 1.4770400000000001e-19
C220 0 N 7.2933000000000013e-19
C230 0 N 3.8216800000000008e-18
C241 0 N 1.8333700000000002e-18
C257 0 N 3.7597100000000006e-18
C265 0 N 1.7197600000000002e-18
C279 0 P 9.9699200000000006e-17
C292 0 P 2.6094099999999997e-16
C307 0 N 2.6112900000000005e-16
C322 0 P 2.5731000000000003e-16
C332 0 N 2.5749700000000004e-16
C342 0 N 1.0266700000000001e-16
C353 0 P 2.6094099999999997e-16
C364 0 N 2.6112900000000005e-16
C373 0 P 6.6567200000000001e-17
C381 0 P 6.6567200000000001e-17
C385 0 N 1.5955500000000001e-17
C389 0 P 6.6567200000000001e-17
C395 0 N 1.5955500000000001e-17
C398 0 P 6.6567200000000001e-17
C400 0 N 1.5955500000000001e-17
C403 0 N 1.5955500000000001e-17
C407 0 P 6.6567200000000001e-17
C410 0 N 1.5955500000000001e-17
C414 0 P 6.6567200000000001e-17
C417 0 N 1.5955500000000001e-17
C420 0 P 6.6567200000000001e-17
C424 0 N 1.5955500000000001e-17
C429 0 N 5.14103e-19
C434 0 N 2.00261e-19
C441 0 N 4.99158e-19
C445 0 N 1.70371e-19
C447 N 0 7.8052200000000014e-16
C448 P 0 7.2170700000000009e-16
VP P 0 DC 0 AC 1
VN N 0 DC 0 AC 0
.control
set numdgt=17
ac lin 1 1Meg 1Meg
let cp = -imag(i(VP))/(2*pi*1e6)
let cn = -imag(i(VN))/(2*pi*1e6)
print cp cn
quit
.endc
.end
