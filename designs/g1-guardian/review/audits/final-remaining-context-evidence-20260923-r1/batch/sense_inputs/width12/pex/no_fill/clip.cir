* cell sense_fill_clip
.SUBCKT sense_fill_clip
* net 2 CTX_L8_0
* net 3 CTX_L8_1
* net 4 CTX_L8_2
* net 5 CTX_L8_3
* net 6 CTX_L8_4
* net 7 CTX_L8_5
* net 8 CTX_L10_0,CTX_L8_6
* net 9 CTX_L10_1,CTX_L10_3,CTX_L126_0,CTX_L30_0,CTX_L30_1,CTX_L50_0,CTX_L50_1,CTX_L67_0,CTX_L67_1,CTX_L8_7,CTX_L8_9
* net 10 CTX_L10_2,CTX_L8_8
* net 11 P
* net 12 N
* net 13 CTX_L10_4,CTX_L8_10
* net 14 CTX_L8_11
* net 15 CTX_L8_12
* net 16 CTX_L8_13
* net 17 CTX_L8_14
* net 18 CTX_L8_15
* net 19 CTX_L8_16
.ENDS sense_fill_clip
