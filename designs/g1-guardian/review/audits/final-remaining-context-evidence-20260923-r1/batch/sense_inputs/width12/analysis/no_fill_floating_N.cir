* no_fill floating drive N; diagnostic capacitor-network AC only
C7 0 N 5.9684500000000006e-17
C8 0 P 9.9451700000000008e-17
C24 0 N 7.1324900000000008e-16
C25 0 P 7.8556800000000003e-16
C27 0 N 5.9684500000000006e-17
C28 0 P 1.0049100000000001e-16
C36 0 N 5.9684500000000006e-17
C37 0 P 9.9527900000000008e-17
C40 0 P 1.2313100000000001e-18
C43 0 P 5.6114100000000006e-19
C46 0 P 1.3992200000000001e-18
C49 0 P 6.3766000000000006e-19
C52 0 N 1.6050300000000001e-19
C53 0 P 5.1461800000000001e-19
C56 0 N 3.42709e-19
C57 0 P 1.7312e-19
C60 0 N 5.7054000000000009e-19
C61 0 P 1.4770400000000001e-19
C63 0 N 1.0856600000000002e-18
C66 0 N 1.6050300000000001e-19
C67 0 P 4.5286400000000006e-19
C70 0 N 2.2961500000000001e-19
C71 0 P 1.7312e-19
C74 0 N 5.0207500000000008e-19
C75 0 P 1.4770400000000001e-19
C77 0 N 9.5537800000000009e-19
C79 N 0 9.6373400000000005e-16
C80 P 0 8.8701700000000011e-16
VP P 0 DC 0 AC 0
VN N 0 DC 0 AC 1
.control
set numdgt=17
ac lin 1 1Meg 1Meg
let cp = -imag(i(VP))/(2*pi*1e6)
let cn = -imag(i(VN))/(2*pi*1e6)
print cp cn
quit
.endc
.end
