*********************************************************
*** NGSPICE file created by KLayout-PEX 0.3.12
*** -----------------------------------------------------
***     Extraction Engine: KPEX/2.5D
***     Technology: ihp_sg13g2
***     Date: 2026-09-23 06:33:19
*********************************************************

.SUBCKT sense_fill_clip
Cext_1 CTX_L10_0|CTX_L8_6
+ CTX_L10_1|CTX_L10_3|CTX_L126_0|CTX_L30_0|CTX_L30_1|CTX_L50_0|CTX_L50_1|CTX_L67_0|CTX_L67_1|CTX_L8_7|CTX_L8_9
+ 1.07416f
Cext_2 CTX_L10_0|CTX_L8_6 CTX_L8_0 33.2945a
Cext_3 CTX_L10_0|CTX_L8_6 CTX_L8_1 31.0013a
Cext_4 CTX_L10_0|CTX_L8_6 CTX_L8_2 33.2945a
Cext_5 CTX_L10_0|CTX_L8_6 CTX_L8_3 30.9715a
Cext_6 CTX_L10_0|CTX_L8_6 CTX_L8_4 33.2945a
Cext_7 CTX_L10_0|CTX_L8_6 CTX_L8_5 31.0013a
Cext_8 CTX_L10_0|CTX_L8_6 N 59.6845a
Cext_9 CTX_L10_0|CTX_L8_6 P 99.4517a
Cext_10 CTX_L10_0|CTX_L8_6 VSUBS 2.95225f
Cext_11
+ CTX_L10_1|CTX_L10_3|CTX_L126_0|CTX_L30_0|CTX_L30_1|CTX_L50_0|CTX_L50_1|CTX_L67_0|CTX_L67_1|CTX_L8_7|CTX_L8_9
+ CTX_L10_2|CTX_L8_8 1.73364f
Cext_12
+ CTX_L10_1|CTX_L10_3|CTX_L126_0|CTX_L30_0|CTX_L30_1|CTX_L50_0|CTX_L50_1|CTX_L67_0|CTX_L67_1|CTX_L8_7|CTX_L8_9
+ CTX_L10_4|CTX_L8_10 1.07611f
Cext_13
+ CTX_L10_1|CTX_L10_3|CTX_L126_0|CTX_L30_0|CTX_L30_1|CTX_L50_0|CTX_L50_1|CTX_L67_0|CTX_L67_1|CTX_L8_7|CTX_L8_9
+ CTX_L8_0 2.38138a
Cext_14
+ CTX_L10_1|CTX_L10_3|CTX_L126_0|CTX_L30_0|CTX_L30_1|CTX_L50_0|CTX_L50_1|CTX_L67_0|CTX_L67_1|CTX_L8_7|CTX_L8_9
+ CTX_L8_1 2.32007a
Cext_15
+ CTX_L10_1|CTX_L10_3|CTX_L126_0|CTX_L30_0|CTX_L30_1|CTX_L50_0|CTX_L50_1|CTX_L67_0|CTX_L67_1|CTX_L8_7|CTX_L8_9
+ CTX_L8_11 2.70559a
Cext_16
+ CTX_L10_1|CTX_L10_3|CTX_L126_0|CTX_L30_0|CTX_L30_1|CTX_L50_0|CTX_L50_1|CTX_L67_0|CTX_L67_1|CTX_L8_7|CTX_L8_9
+ CTX_L8_12 2.64567a
Cext_17
+ CTX_L10_1|CTX_L10_3|CTX_L126_0|CTX_L30_0|CTX_L30_1|CTX_L50_0|CTX_L50_1|CTX_L67_0|CTX_L67_1|CTX_L8_7|CTX_L8_9
+ CTX_L8_13 2.86322a
Cext_18
+ CTX_L10_1|CTX_L10_3|CTX_L126_0|CTX_L30_0|CTX_L30_1|CTX_L50_0|CTX_L50_1|CTX_L67_0|CTX_L67_1|CTX_L8_7|CTX_L8_9
+ CTX_L8_14 3.35422a
Cext_19
+ CTX_L10_1|CTX_L10_3|CTX_L126_0|CTX_L30_0|CTX_L30_1|CTX_L50_0|CTX_L50_1|CTX_L67_0|CTX_L67_1|CTX_L8_7|CTX_L8_9
+ CTX_L8_15 2.86322a
Cext_20
+ CTX_L10_1|CTX_L10_3|CTX_L126_0|CTX_L30_0|CTX_L30_1|CTX_L50_0|CTX_L50_1|CTX_L67_0|CTX_L67_1|CTX_L8_7|CTX_L8_9
+ CTX_L8_16 3.09064a
Cext_21
+ CTX_L10_1|CTX_L10_3|CTX_L126_0|CTX_L30_0|CTX_L30_1|CTX_L50_0|CTX_L50_1|CTX_L67_0|CTX_L67_1|CTX_L8_7|CTX_L8_9
+ CTX_L8_2 2.52009a
Cext_22
+ CTX_L10_1|CTX_L10_3|CTX_L126_0|CTX_L30_0|CTX_L30_1|CTX_L50_0|CTX_L50_1|CTX_L67_0|CTX_L67_1|CTX_L8_7|CTX_L8_9
+ CTX_L8_3 2.94006a
Cext_23
+ CTX_L10_1|CTX_L10_3|CTX_L126_0|CTX_L30_0|CTX_L30_1|CTX_L50_0|CTX_L50_1|CTX_L67_0|CTX_L67_1|CTX_L8_7|CTX_L8_9
+ CTX_L8_4 2.52009a
Cext_24
+ CTX_L10_1|CTX_L10_3|CTX_L126_0|CTX_L30_0|CTX_L30_1|CTX_L50_0|CTX_L50_1|CTX_L67_0|CTX_L67_1|CTX_L8_7|CTX_L8_9
+ CTX_L8_5 2.71164a
Cext_25
+ CTX_L10_1|CTX_L10_3|CTX_L126_0|CTX_L30_0|CTX_L30_1|CTX_L50_0|CTX_L50_1|CTX_L67_0|CTX_L67_1|CTX_L8_7|CTX_L8_9
+ N 713.249a
Cext_26
+ CTX_L10_1|CTX_L10_3|CTX_L126_0|CTX_L30_0|CTX_L30_1|CTX_L50_0|CTX_L50_1|CTX_L67_0|CTX_L67_1|CTX_L8_7|CTX_L8_9
+ P 785.568a
Cext_27
+ CTX_L10_1|CTX_L10_3|CTX_L126_0|CTX_L30_0|CTX_L30_1|CTX_L50_0|CTX_L50_1|CTX_L67_0|CTX_L67_1|CTX_L8_7|CTX_L8_9
+ VSUBS 8.13946f
Cext_28 CTX_L10_2|CTX_L8_8 N 59.6845a
Cext_29 CTX_L10_2|CTX_L8_8 P 100.491a
Cext_30 CTX_L10_2|CTX_L8_8 VSUBS 2.68052f
Cext_31 CTX_L10_4|CTX_L8_10 CTX_L8_11 33.3865a
Cext_32 CTX_L10_4|CTX_L8_10 CTX_L8_12 31.0806a
Cext_33 CTX_L10_4|CTX_L8_10 CTX_L8_13 33.3865a
Cext_34 CTX_L10_4|CTX_L8_10 CTX_L8_14 31.0508a
Cext_35 CTX_L10_4|CTX_L8_10 CTX_L8_15 33.3865a
Cext_36 CTX_L10_4|CTX_L8_10 CTX_L8_16 31.0806a
Cext_37 CTX_L10_4|CTX_L8_10 N 59.6845a
Cext_38 CTX_L10_4|CTX_L8_10 P 99.5279a
Cext_39 CTX_L10_4|CTX_L8_10 VSUBS 2.95161f
Cext_40 CTX_L8_0 CTX_L8_1 1.75621a
Cext_41 CTX_L8_0 P 1.23131a
Cext_42 CTX_L8_0 VSUBS 45.9869a
Cext_43 CTX_L8_1 CTX_L8_2 12.797a
Cext_44 CTX_L8_1 P 0.561141a
Cext_45 CTX_L8_1 VSUBS 33.3778a
Cext_46 CTX_L8_11 CTX_L8_12 2.75976a
Cext_47 CTX_L8_11 P 1.39922a
Cext_48 CTX_L8_11 VSUBS 50.4932a
Cext_49 CTX_L8_12 CTX_L8_13 14.542a
Cext_50 CTX_L8_12 P 0.63766a
Cext_51 CTX_L8_12 VSUBS 36.5012a
Cext_52 CTX_L8_13 CTX_L8_14 2.75976a
Cext_53 CTX_L8_13 N 0.160503a
Cext_54 CTX_L8_13 P 0.514618a
Cext_55 CTX_L8_13 VSUBS 39.669a
Cext_56 CTX_L8_14 CTX_L8_15 14.542a
Cext_57 CTX_L8_14 N 0.342709a
Cext_58 CTX_L8_14 P 0.17312a
Cext_59 CTX_L8_14 VSUBS 36.5012a
Cext_60 CTX_L8_15 CTX_L8_16 2.75976a
Cext_61 CTX_L8_15 N 0.57054a
Cext_62 CTX_L8_15 P 0.147704a
Cext_63 CTX_L8_15 VSUBS 39.669a
Cext_64 CTX_L8_16 N 1.08566a
Cext_65 CTX_L8_16 VSUBS 47.3254a
Cext_66 CTX_L8_2 CTX_L8_3 1.75621a
Cext_67 CTX_L8_2 N 0.160503a
Cext_68 CTX_L8_2 P 0.452864a
Cext_69 CTX_L8_2 VSUBS 36.4616a
Cext_70 CTX_L8_3 CTX_L8_4 12.797a
Cext_71 CTX_L8_3 N 0.229615a
Cext_72 CTX_L8_3 P 0.17312a
Cext_73 CTX_L8_3 VSUBS 33.3778a
Cext_74 CTX_L8_4 CTX_L8_5 1.75621a
Cext_75 CTX_L8_4 N 0.502075a
Cext_76 CTX_L8_4 P 0.147704a
Cext_77 CTX_L8_4 VSUBS 36.4616a
Cext_78 CTX_L8_5 N 0.955378a
Cext_79 CTX_L8_5 VSUBS 42.9031a
Cext_80 N VSUBS 963.734a
Cext_81 P VSUBS 887.017a
.ENDS sense_fill_clip
