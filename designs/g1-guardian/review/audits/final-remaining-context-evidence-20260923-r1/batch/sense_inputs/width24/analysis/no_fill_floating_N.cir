* no_fill floating drive N; diagnostic capacitor-network AC only
C11 0 N 5.9684500000000006e-17
C12 0 P 1.6266900000000002e-16
C36 0 N 9.2397600000000001e-16
C37 0 P 1.0405800000000002e-15
C39 0 N 5.9684500000000006e-17
C40 0 P 1.6370900000000001e-16
C52 0 N 5.9684500000000006e-17
C53 0 P 1.6274600000000001e-16
C56 0 P 2.0157700000000001e-19
C59 0 P 2.98456e-19
C62 0 P 2.0157700000000001e-19
C65 0 P 4.4545700000000006e-19
C68 0 P 7.4266300000000006e-19
C71 0 P 1.1508499999999999e-18
C74 0 P 1.3019400000000001e-18
C77 0 P 6.5354300000000003e-19
C80 0 P 6.3766000000000006e-19
C83 0 N 1.6050300000000001e-19
C84 0 P 5.1461800000000001e-19
C87 0 N 3.42709e-19
C88 0 P 1.7312e-19
C91 0 N 5.7054000000000009e-19
C92 0 P 1.4770400000000001e-19
C94 0 N 1.0856600000000002e-18
C97 0 P 1.03644e-18
C100 0 P 1.1694100000000002e-18
C103 0 P 5.6114100000000006e-19
C106 0 N 1.6050300000000001e-19
C107 0 P 4.5286400000000006e-19
C110 0 N 2.2961500000000001e-19
C111 0 P 1.7312e-19
C114 0 N 5.0207500000000008e-19
C115 0 P 1.4770400000000001e-19
C117 0 N 9.5537800000000009e-19
C119 N 0 9.6373400000000005e-16
C120 P 0 6.4328700000000009e-16
VP P 0 DC 0 AC 0
VN N 0 DC 0 AC 1
.control
set numdgt=17
ac lin 1 1Meg 1Meg
let cp = -imag(i(VP))/(2*pi*1e6)
let cn = -imag(i(VN))/(2*pi*1e6)
print cp cn
quit
.endc
.end
