* actual_fill floating drive P; diagnostic capacitor-network AC only
C11 0 FILL_L10_0 1.35421e-18
C12 0 FILL_L10_1 2.6679900000000002e-17
C13 0 FILL_L10_2 2.0247000000000005e-18
C14 0 FILL_L10_3 4.2962100000000001e-19
C15 0 FILL_L134_0 4.8458600000000002e-17
C16 0 FILL_L134_2 1.3858400000000001e-18
C17 0 FILL_L30_0 1.5287700000000003e-16
C18 0 FILL_L30_1 2.7374000000000004e-16
C19 0 FILL_L30_10 1.2960100000000002e-18
C20 0 FILL_L30_2 7.0851400000000002e-17
C21 0 FILL_L30_3 7.0218100000000007e-17
C22 0 FILL_L30_4 3.9982300000000003e-17
C23 0 FILL_L30_5 6.0320100000000006e-17
C24 0 FILL_L30_6 1.27335e-16
C25 0 FILL_L30_7 2.3052600000000005e-16
C26 0 FILL_L30_9 3.0839900000000005e-17
C27 0 FILL_L50_0 3.2675800000000006e-17
C28 0 FILL_L50_1 1.8808e-17
C29 0 FILL_L50_13 2.0798800000000001e-18
C30 0 FILL_L50_2 2.4612000000000001e-17
C31 0 FILL_L50_3 2.4415900000000003e-17
C32 0 FILL_L50_5 2.1647200000000003e-17
C33 0 FILL_L50_6 2.61741e-17
C34 0 FILL_L50_8 3.0009000000000001e-17
C35 0 FILL_L8_0 1.5866400000000002e-18
C36 0 FILL_L8_1 3.2162400000000001e-17
C37 0 FILL_L8_2 1.9298500000000003e-17
C38 0 N 5.1221400000000004e-17
C39 0 P 1.0355900000000001e-16
C62 0 FILL_L10_0 6.1678200000000007e-18
C63 0 FILL_L10_1 1.8434200000000003e-17
C64 0 FILL_L10_10 1.83019e-18
C65 0 FILL_L10_11 8.9292800000000006e-17
C66 0 FILL_L10_12 1.0526300000000002e-17
C67 0 FILL_L10_13 1.14551e-17
C68 0 FILL_L10_2 8.1900000000000009e-17
C69 0 FILL_L10_3 1.3482100000000002e-17
C70 0 FILL_L10_4 2.1257100000000004e-17
C71 0 FILL_L10_5 9.60355e-17
C72 0 FILL_L10_6 4.634680000000001e-18
C73 0 FILL_L10_7 1.3544800000000002e-17
C74 0 FILL_L10_8 8.8272700000000009e-17
C75 0 FILL_L10_9 2.8467300000000003e-17
C76 0 FILL_L134_0 7.8572800000000001e-16
C77 0 FILL_L134_1 1.4795700000000001e-15
C78 0 FILL_L134_2 8.9898299999999992e-16
C79 0 FILL_L134_3 3.8472900000000002e-16
C80 0 FILL_L134_4 7.1446300000000003e-16
C81 0 FILL_L134_5 4.5017800000000002e-16
C82 0 FILL_L30_1 1.01975e-16
C83 0 FILL_L30_10 5.9086399999999997e-17
C84 0 FILL_L30_11 3.2579000000000005e-17
C85 0 FILL_L30_12 2.5389099999999999e-16
C86 0 FILL_L30_13 7.2501400000000009e-16
C87 0 FILL_L30_14 1.5964100000000001e-16
C88 0 FILL_L30_15 3.2601900000000005e-16
C89 0 FILL_L30_16 6.100730000000001e-17
C90 0 FILL_L30_17 4.8896200000000003e-17
C91 0 FILL_L30_18 3.9751100000000004e-17
C92 0 FILL_L30_19 3.2032100000000006e-16
C93 0 FILL_L30_2 3.7849300000000004e-17
C94 0 FILL_L30_20 3.0937500000000004e-17
C95 0 FILL_L30_21 2.4642699999999999e-16
C96 0 FILL_L30_3 2.4413799999999999e-17
C97 0 FILL_L30_4 1.0156800000000001e-16
C98 0 FILL_L30_5 6.1623300000000001e-17
C99 0 FILL_L30_6 4.3521000000000003e-16
C100 0 FILL_L30_7 1.0712600000000002e-15
C101 0 FILL_L30_8 1.3728200000000002e-16
C102 0 FILL_L30_9 4.3073100000000002e-16
C103 0 FILL_L50_0 2.8223600000000004e-17
C104 0 FILL_L50_1 5.4311000000000006e-17
C105 0 FILL_L50_10 1.25789e-16
C106 0 FILL_L50_11 3.9621000000000002e-17
C107 0 FILL_L50_12 6.3081300000000007e-17
C108 0 FILL_L50_13 1.0455000000000001e-16
C109 0 FILL_L50_14 7.6788000000000002e-17
C110 0 FILL_L50_15 3.9435300000000002e-17
C111 0 FILL_L50_16 1.0893800000000002e-16
C112 0 FILL_L50_17 9.6150700000000004e-17
C113 0 FILL_L50_18 1.4198500000000003e-16
C114 0 FILL_L50_19 3.9594499999999997e-17
C115 0 FILL_L50_2 7.7734000000000003e-17
C116 0 FILL_L50_20 6.9126200000000007e-17
C117 0 FILL_L50_21 9.5567600000000006e-17
C118 0 FILL_L50_22 8.3890300000000001e-17
C119 0 FILL_L50_23 3.9378600000000004e-17
C120 0 FILL_L50_24 8.9447600000000005e-17
C121 0 FILL_L50_25 6.2137100000000002e-17
C122 0 FILL_L50_26 7.3827100000000013e-17
C123 0 FILL_L50_27 3.5401700000000002e-17
C124 0 FILL_L50_3 6.6034600000000008e-17
C125 0 FILL_L50_4 3.57065e-17
C126 0 FILL_L50_5 7.2338600000000001e-17
C127 0 FILL_L50_6 9.4600400000000001e-17
C128 0 FILL_L50_7 3.9378600000000004e-17
C129 0 FILL_L50_8 1.05645e-16
C130 0 FILL_L50_9 8.136750000000001e-17
C131 0 FILL_L8_0 8.7206200000000003e-19
C132 0 FILL_L8_1 3.7425700000000004e-18
C133 0 FILL_L8_11 1.5335100000000001e-18
C134 0 FILL_L8_12 1.3208300000000001e-18
C135 0 FILL_L8_13 5.24598e-19
C136 0 FILL_L8_2 3.1949800000000005e-18
C137 0 FILL_L8_3 2.9235000000000002e-17
C138 0 FILL_L8_4 2.65644e-17
C139 0 FILL_L8_5 1.9269300000000003e-17
C140 0 FILL_L8_6 1.9168900000000001e-18
C141 0 FILL_L8_7 2.8467000000000001e-17
C142 0 FILL_L8_8 1.0940000000000001e-18
C143 0 FILL_L8_9 2.9179200000000003e-17
C144 0 N 8.3873299999999998e-16
C145 0 P 7.8557500000000015e-16
C147 0 FILL_L10_4 1.1979900000000002e-18
C148 0 FILL_L10_6 2.7691700000000002e-17
C149 0 FILL_L10_7 7.1717800000000008e-19
C150 0 FILL_L10_8 1.7140500000000001e-18
C151 0 FILL_L134_0 4.8693500000000007e-17
C152 0 FILL_L134_2 1.8675900000000002e-18
C153 0 FILL_L30_10 1.55297e-16
C154 0 FILL_L30_11 1.51908e-16
C155 0 FILL_L30_12 3.8517700000000003e-16
C156 0 FILL_L30_13 6.9300900000000008e-16
C157 0 FILL_L30_14 5.2856800000000008e-18
C158 0 FILL_L30_15 1.34196e-16
C159 0 FILL_L30_16 1.2913500000000001e-18
C160 0 FILL_L30_2 5.5893200000000004e-19
C161 0 FILL_L30_6 3.3057500000000001e-17
C162 0 FILL_L30_7 5.6411600000000009e-17
C163 0 FILL_L30_8 6.71456e-18
C164 0 FILL_L30_9 2.0186900000000002e-18
C165 0 FILL_L50_10 2.0187900000000003e-18
C166 0 FILL_L50_12 2.5994500000000001e-17
C167 0 FILL_L50_13 4.2404000000000009e-17
C168 0 FILL_L50_14 4.0194500000000003e-17
C169 0 FILL_L50_16 3.5554200000000001e-17
C170 0 FILL_L50_18 1.7142500000000001e-18
C171 0 FILL_L50_2 7.9189600000000012e-19
C172 0 FILL_L50_21 1.5161100000000001e-18
C173 0 FILL_L50_8 1.40719e-17
C174 0 FILL_L50_9 8.2088700000000003e-18
C175 0 FILL_L8_4 7.2120200000000005e-19
C176 0 FILL_L8_6 3.2203800000000004e-17
C177 0 FILL_L8_8 1.6744399999999999e-17
C178 0 N 4.6069200000000004e-17
C179 0 P 7.0077000000000007e-17
C191 0 FILL_L10_10 2.7683000000000003e-17
C192 0 FILL_L10_11 1.5776100000000001e-18
C193 0 FILL_L10_12 9.0842599999999994e-19
C194 0 FILL_L10_9 1.0359200000000001e-18
C195 0 FILL_L134_3 3.7386400000000003e-17
C196 0 FILL_L134_5 1.33523e-18
C197 0 FILL_L30_10 1.84441e-19
C198 0 FILL_L30_12 2.3127200000000003e-18
C199 0 FILL_L30_13 3.8339300000000001e-18
C200 0 FILL_L30_16 6.480070000000001e-17
C201 0 FILL_L30_17 6.4664700000000004e-17
C202 0 FILL_L30_18 4.8356800000000005e-16
C203 0 FILL_L30_19 8.7967800000000009e-16
C204 0 FILL_L30_20 6.6150499999999996e-17
C205 0 FILL_L30_21 1.81581e-16
C206 0 FILL_L50_13 2.3372600000000002e-19
C207 0 FILL_L50_16 1.8785199999999999e-18
C208 0 FILL_L50_17 1.2356100000000001e-18
C209 0 FILL_L50_20 5.9932299999999998e-18
C210 0 FILL_L50_21 2.3444700000000003e-17
C211 0 FILL_L50_22 2.3715200000000002e-17
C212 0 FILL_L50_24 3.00304e-17
C213 0 FILL_L50_25 1.0164900000000001e-17
C214 0 FILL_L50_26 2.6989900000000002e-17
C215 0 FILL_L8_10 3.2203800000000004e-17
C216 0 FILL_L8_11 1.8198100000000002e-17
C217 0 N 4.6483600000000004e-17
C218 0 P 4.8489400000000009e-17
C221 0 FILL_L30_0 7.3101300000000001e-18
C224 0 FILL_L134_0 4.8356100000000004e-19
C225 0 FILL_L30_0 3.1957100000000004e-18
C226 0 FILL_L30_1 8.3217500000000006e-19
C227 0 FILL_L50_0 8.5726599999999999e-19
C228 0 P 2.98456e-19
C231 0 FILL_L134_3 7.1890600000000014e-19
C232 0 FILL_L30_18 4.5624400000000002e-18
C233 0 FILL_L50_24 1.0139100000000002e-18
C234 0 P 1.7149100000000002e-19
C237 0 FILL_L134_3 1.1182000000000001e-18
C238 0 FILL_L30_18 2.8536700000000002e-19
C239 0 P 4.0091100000000004e-19
C242 0 FILL_L134_3 1.09408e-18
C243 0 FILL_L30_18 1.3019300000000001e-19
C244 0 FILL_L30_19 1.7875100000000001e-19
C245 0 P 6.6839600000000007e-19
C248 0 FILL_L30_19 4.2550200000000003e-18
C249 0 P 1.02605e-18
C252 0 FILL_L30_19 4.8612500000000002e-18
C253 0 P 1.1620200000000001e-18
C256 0 FILL_L134_0 5.6093000000000012e-19
C257 0 FILL_L30_0 1.1457e-18
C258 0 FILL_L30_1 2.28238e-18
C259 0 FILL_L50_0 8.5353500000000008e-19
C260 0 P 6.5354300000000003e-19
C263 0 FILL_L30_19 1.4083900000000001e-19
C264 0 P 5.7389400000000003e-19
C267 0 FILL_L30_16 5.9677700000000003e-19
C268 0 FILL_L50_21 6.3012800000000003e-19
C269 0 N 1.36547e-19
C270 0 P 4.6315600000000007e-19
C273 0 FILL_L30_20 2.5160300000000005e-19
C274 0 N 3.0843800000000002e-19
C275 0 P 1.4728100000000001e-19
C278 0 FILL_L10_12 1.27384e-19
C279 0 FILL_L30_20 3.7353800000000007e-18
C280 0 FILL_L50_26 1.0139100000000002e-18
C281 0 N 5.13486e-19
C282 0 P 1.25658e-19
C284 0 FILL_L10_12 6.6961100000000001e-19
C285 0 FILL_L30_20 1.06289e-19
C286 0 FILL_L30_21 8.0335000000000004e-19
C287 0 FILL_L8_12 7.4830700000000007e-18
C288 0 N 9.7709200000000004e-19
C291 0 FILL_L30_1 8.4140300000000008e-18
C294 0 FILL_L30_1 8.8587399999999994e-18
C297 0 FILL_L30_1 1.7349900000000003e-18
C298 0 P 5.6114100000000006e-19
C301 0 FILL_L30_1 8.2750800000000007e-19
C302 0 FILL_L30_2 3.2582399999999999e-18
C303 0 FILL_L30_4 1.5464400000000002e-19
C304 0 FILL_L50_2 9.8699499999999996e-19
C305 0 N 1.6050300000000001e-19
C306 0 P 4.5286400000000006e-19
C309 0 FILL_L30_1 2.2736900000000001e-19
C310 0 FILL_L30_4 2.7168000000000001e-19
C311 0 N 2.2961500000000001e-19
C312 0 P 1.7312e-19
C315 0 FILL_L10_0 1.4973200000000001e-19
C316 0 FILL_L30_1 1.68039e-19
C317 0 FILL_L30_3 3.2582399999999999e-18
C318 0 FILL_L30_4 7.3069500000000002e-19
C319 0 FILL_L50_3 9.8699499999999996e-19
C320 0 N 5.0207500000000008e-19
C321 0 P 1.4770400000000001e-19
C323 0 FILL_L10_0 6.5473000000000006e-19
C324 0 FILL_L30_4 4.6548600000000008e-18
C325 0 FILL_L8_0 7.31678e-18
C326 0 N 7.2933000000000013e-19
C328 FILL_L10_0 FILL_L10_1 2.7935199999999999e-17
C329 FILL_L10_0 FILL_L10_2 1.5364400000000001e-17
C330 FILL_L10_0 FILL_L30_4 9.0728200000000013e-17
C331 FILL_L10_0 FILL_L8_0 3.6973700000000005e-17
C332 FILL_L10_0 0 7.1332200000000003e-17
C333 FILL_L10_1 FILL_L10_2 2.7935199999999999e-17
C334 FILL_L10_1 FILL_L10_3 2.7935199999999999e-17
C335 FILL_L10_1 FILL_L134_2 5.6712800000000005e-19
C336 FILL_L10_1 FILL_L30_4 3.0330600000000001e-17
C337 FILL_L10_1 FILL_L30_9 3.0330600000000001e-17
C338 FILL_L10_1 FILL_L8_1 6.7224999999999998e-17
C339 FILL_L10_1 N 1.3071400000000001e-17
C340 FILL_L10_1 0 5.716940000000001e-17
C341 FILL_L10_10 FILL_L10_11 2.7935199999999999e-17
C342 FILL_L10_10 FILL_L10_12 2.7935199999999999e-17
C343 FILL_L10_10 FILL_L10_9 2.7935199999999999e-17
C344 FILL_L10_10 FILL_L30_21 1.7668000000000002e-16
C345 FILL_L10_10 FILL_L8_10 6.7224999999999998e-17
C346 FILL_L10_10 0 5.6504000000000001e-17
C347 FILL_L10_11 FILL_L10_13 9.7773300000000019e-17
C348 FILL_L10_11 FILL_L10_8 9.7773300000000019e-17
C349 FILL_L10_11 FILL_L10_9 2.7935199999999999e-17
C350 FILL_L10_11 FILL_L134_2 4.3026400000000002e-18
C351 FILL_L10_11 FILL_L134_5 5.2878200000000006e-17
C352 FILL_L10_11 FILL_L30_17 4.2984000000000004e-19
C353 FILL_L10_11 FILL_L30_21 1.9374100000000004e-16
C354 FILL_L10_11 FILL_L50_23 2.8287299999999999e-17
C355 FILL_L10_11 FILL_L8_11 8.2350600000000007e-16
C356 FILL_L10_11 N 2.3613300000000001e-17
C357 FILL_L10_11 0 2.9546699999999999e-16
C358 FILL_L10_12 FILL_L10_13 1.2570900000000001e-17
C359 FILL_L10_12 FILL_L134_5 2.5520799999999999e-19
C360 FILL_L10_12 FILL_L30_21 4.5963200000000002e-17
C361 FILL_L10_12 FILL_L8_12 3.0251200000000004e-17
C362 FILL_L10_12 N 5.8821100000000002e-18
C363 FILL_L10_12 0 6.7443799999999999e-17
C364 FILL_L10_13 FILL_L134_5 9.6964400000000008e-18
C365 FILL_L10_13 FILL_L8_13 1.0587900000000001e-16
C366 FILL_L10_13 N 4.2503900000000004e-18
C367 FILL_L10_13 0 1.9281400000000002e-16
C368 FILL_L10_2 FILL_L10_5 9.7773300000000019e-17
C369 FILL_L10_2 FILL_L134_2 3.5255400000000001e-17
C370 FILL_L10_2 FILL_L30_3 4.3420400000000004e-19
C371 FILL_L10_2 FILL_L30_4 1.20603e-16
C372 FILL_L10_2 FILL_L50_4 2.8287299999999999e-17
C373 FILL_L10_2 FILL_L8_2 7.1762700000000003e-16
C374 FILL_L10_2 N 1.9634600000000002e-17
C375 FILL_L10_2 0 3.45905e-16
C376 FILL_L10_3 FILL_L10_4 2.7935199999999999e-17
C377 FILL_L10_3 FILL_L10_5 2.7935199999999999e-17
C378 FILL_L10_3 FILL_L30_9 1.7366200000000003e-16
C379 FILL_L10_3 FILL_L8_3 6.7224999999999998e-17
C380 FILL_L10_3 0 6.9434500000000004e-17
C381 FILL_L10_4 FILL_L10_5 2.7935199999999999e-17
C382 FILL_L10_4 FILL_L10_6 2.7935199999999999e-17
C383 FILL_L10_4 FILL_L134_2 2.8356400000000003e-19
C384 FILL_L10_4 FILL_L30_15 3.4949400000000003e-18
C385 FILL_L10_4 FILL_L30_8 5.2363700000000009e-19
C386 FILL_L10_4 FILL_L30_9 1.08904e-16
C387 FILL_L10_4 FILL_L8_4 6.7224999999999998e-17
C388 FILL_L10_4 N 6.4582100000000006e-18
C389 FILL_L10_4 0 6.9819800000000005e-17
C390 FILL_L10_5 FILL_L10_8 9.7773300000000019e-17
C391 FILL_L10_5 FILL_L134_2 5.9433600000000004e-17
C392 FILL_L10_5 FILL_L30_8 1.5273500000000002e-19
C393 FILL_L10_5 FILL_L30_9 2.3018900000000003e-16
C394 FILL_L10_5 FILL_L50_11 2.8287299999999999e-17
C395 FILL_L10_5 FILL_L8_5 8.2350600000000007e-16
C396 FILL_L10_5 N 2.3613300000000001e-17
C397 FILL_L10_5 0 2.9033900000000003e-16
C398 FILL_L10_6 FILL_L10_7 2.7935199999999999e-17
C399 FILL_L10_6 FILL_L10_8 2.7935199999999999e-17
C400 FILL_L10_6 FILL_L30_11 2.0490200000000002e-19
C401 FILL_L10_6 FILL_L30_15 1.4895200000000002e-16
C402 FILL_L10_6 FILL_L8_6 6.7224999999999998e-17
C403 FILL_L10_6 0 5.6532300000000008e-17
C404 FILL_L10_7 FILL_L10_8 2.7935199999999999e-17
C405 FILL_L10_7 FILL_L10_9 2.7935199999999999e-17
C406 FILL_L10_7 FILL_L30_14 4.6672000000000005e-19
C407 FILL_L10_7 FILL_L30_15 1.6518700000000003e-16
C408 FILL_L10_7 FILL_L8_7 6.7224999999999998e-17
C409 FILL_L10_7 0 6.9430800000000005e-17
C410 FILL_L10_8 FILL_L134_2 4.9430900000000007e-17
C411 FILL_L10_8 FILL_L134_5 7.8823400000000005e-18
C412 FILL_L10_8 FILL_L30_15 2.6709500000000005e-16
C413 FILL_L10_8 FILL_L50_15 2.8287299999999999e-17
C414 FILL_L10_8 FILL_L50_19 1.4143599999999999e-17
C415 FILL_L10_8 FILL_L8_8 8.2350600000000007e-16
C416 FILL_L10_8 N 1.88906e-17
C417 FILL_L10_8 0 2.9541800000000004e-16
C418 FILL_L10_9 FILL_L134_5 2.5520799999999999e-19
C419 FILL_L10_9 FILL_L30_15 1.3974200000000001e-17
C420 FILL_L10_9 FILL_L30_21 5.8939399999999999e-17
C421 FILL_L10_9 FILL_L8_9 6.7224999999999998e-17
C422 FILL_L10_9 N 1.3009400000000001e-17
C423 FILL_L10_9 0 6.9640000000000008e-17
C424 FILL_L134_0 FILL_L134_1 4.5988900000000005e-16
C425 FILL_L134_0 FILL_L134_3 2.2994400000000001e-16
C426 FILL_L134_0 FILL_L30_0 2.7083400000000006e-18
C427 FILL_L134_0 FILL_L30_1 4.0172700000000002e-18
C428 FILL_L134_0 FILL_L30_12 1.0318600000000001e-17
C429 FILL_L134_0 FILL_L30_13 1.5854100000000003e-17
C430 FILL_L134_0 FILL_L30_6 1.7161900000000001e-17
C431 FILL_L134_0 FILL_L30_7 2.0612400000000003e-17
C432 FILL_L134_0 FILL_L50_0 1.4539500000000002e-17
C433 FILL_L134_0 FILL_L50_16 5.7448999999999997e-17
C434 FILL_L134_0 FILL_L50_8 7.5552800000000016e-17
C435 FILL_L134_0 P 4.6075600000000005e-17
C436 FILL_L134_0 0 4.6270200000000004e-16
C437 FILL_L134_1 FILL_L134_2 4.5988900000000005e-16
C438 FILL_L134_1 FILL_L134_4 2.2994400000000001e-16
C439 FILL_L134_1 0 1.1287699999999999e-16
C440 FILL_L134_2 FILL_L134_5 2.2994400000000001e-16
C441 FILL_L134_2 FILL_L30_15 1.3048700000000001e-17
C442 FILL_L134_2 FILL_L30_4 2.7262100000000003e-18
C443 FILL_L134_2 FILL_L30_9 1.7704800000000002e-17
C444 FILL_L134_2 FILL_L50_11 1.0359400000000002e-17
C445 FILL_L134_2 FILL_L50_15 9.8568900000000006e-18
C446 FILL_L134_2 FILL_L50_19 4.6295599999999999e-18
C447 FILL_L134_2 FILL_L50_4 4.6295599999999999e-18
C448 FILL_L134_2 FILL_L50_7 9.8568900000000006e-18
C449 FILL_L134_2 FILL_L8_1 3.4623000000000003e-19
C450 FILL_L134_2 FILL_L8_2 1.7269000000000002e-18
C451 FILL_L134_2 FILL_L8_4 1.7311500000000001e-19
C452 FILL_L134_2 FILL_L8_5 3.2636700000000002e-18
C453 FILL_L134_2 FILL_L8_8 1.5734e-18
C454 FILL_L134_2 N 2.5909500000000002e-17
C455 FILL_L134_2 0 4.1259600000000002e-16
C456 FILL_L134_3 FILL_L134_4 2.2534500000000002e-16
C457 FILL_L134_3 FILL_L30_12 8.025090000000001e-19
C458 FILL_L134_3 FILL_L30_13 3.19562e-18
C459 FILL_L134_3 FILL_L30_18 1.2414e-17
C460 FILL_L134_3 FILL_L30_19 1.91112e-17
C461 FILL_L134_3 FILL_L50_16 1.1263400000000001e-17
C462 FILL_L134_3 FILL_L50_24 6.9283900000000002e-17
C463 FILL_L134_3 P 2.1008700000000001e-17
C464 FILL_L134_3 0 3.3058900000000005e-16
C465 FILL_L134_4 FILL_L134_5 2.2534500000000002e-16
C466 FILL_L134_4 0 1.5587500000000002e-16
C467 FILL_L134_5 FILL_L30_15 1.7052000000000002e-18
C468 FILL_L134_5 FILL_L30_21 1.56673e-17
C469 FILL_L134_5 FILL_L50_19 3.43931e-18
C470 FILL_L134_5 FILL_L50_23 8.7765500000000013e-18
C471 FILL_L134_5 FILL_L50_27 8.7765500000000013e-18
C472 FILL_L134_5 FILL_L8_11 1.6867800000000001e-18
C473 FILL_L134_5 FILL_L8_12 1.55803e-19
C474 FILL_L134_5 FILL_L8_13 1.5734e-18
C475 FILL_L134_5 FILL_L8_9 1.55803e-19
C476 FILL_L134_5 N 1.0733900000000001e-17
C477 FILL_L134_5 0 3.0860300000000003e-16
C478 FILL_L30_0 FILL_L30_1 2.9873400000000003e-17
C479 FILL_L30_0 FILL_L30_6 4.4713700000000009e-17
C480 FILL_L30_0 FILL_L50_0 2.4174100000000003e-16
C481 FILL_L30_0 0 1.69654e-16
C482 FILL_L30_1 FILL_L30_2 1.92731e-17
C483 FILL_L30_1 FILL_L30_4 2.6050800000000002e-18
C484 FILL_L30_1 FILL_L30_7 7.7092600000000011e-17
C485 FILL_L30_1 FILL_L50_0 9.0537100000000011e-18
C486 FILL_L30_1 FILL_L50_1 1.14801e-16
C487 FILL_L30_1 P 1.3876200000000002e-16
C488 FILL_L30_1 0 2.1537000000000001e-16
C489 FILL_L30_10 FILL_L30_11 1.92731e-17
C490 FILL_L30_10 FILL_L30_13 1.92731e-17
C491 FILL_L30_10 FILL_L30_16 7.6042400000000005e-18
C492 FILL_L30_10 FILL_L30_2 4.7365199999999997e-18
C493 FILL_L30_10 FILL_L50_13 6.7224999999999998e-17
C494 FILL_L30_10 0 3.7430900000000003e-17
C495 FILL_L30_11 FILL_L30_14 1.92731e-17
C496 FILL_L30_11 FILL_L30_15 1.92731e-17
C497 FILL_L30_11 FILL_L30_8 1.92731e-17
C498 FILL_L30_11 FILL_L50_14 6.7224999999999998e-17
C499 FILL_L30_11 0 2.4295200000000003e-17
C500 FILL_L30_12 FILL_L30_13 7.7092600000000011e-17
C501 FILL_L30_12 FILL_L30_18 4.4713700000000009e-17
C502 FILL_L30_12 FILL_L30_6 4.4713700000000009e-17
C503 FILL_L30_12 FILL_L50_16 6.2384800000000003e-16
C504 FILL_L30_12 0 2.3113000000000002e-16
C505 FILL_L30_13 FILL_L30_14 6.0833899999999998e-18
C506 FILL_L30_13 FILL_L30_15 9.4730399999999993e-18
C507 FILL_L30_13 FILL_L30_19 7.7092600000000011e-17
C508 FILL_L30_13 FILL_L30_7 7.7092600000000011e-17
C509 FILL_L30_13 FILL_L50_12 1.3417300000000002e-16
C510 FILL_L30_13 FILL_L50_16 2.3410700000000001e-17
C511 FILL_L30_13 FILL_L50_17 1.3417300000000002e-16
C512 FILL_L30_13 P 3.6174800000000003e-16
C513 FILL_L30_13 0 2.1205600000000002e-16
C514 FILL_L30_14 FILL_L30_15 1.92731e-17
C515 FILL_L30_14 FILL_L30_17 1.92731e-17
C516 FILL_L30_14 FILL_L50_18 6.7224999999999998e-17
C517 FILL_L30_14 0 3.8601700000000003e-17
C518 FILL_L30_15 FILL_L30_21 7.7092600000000011e-17
C519 FILL_L30_15 FILL_L30_9 7.7092600000000011e-17
C520 FILL_L30_15 FILL_L50_14 3.9597300000000006e-18
C521 FILL_L30_15 FILL_L50_15 1.46759e-16
C522 FILL_L30_15 FILL_L50_18 3.9597300000000006e-18
C523 FILL_L30_15 FILL_L50_19 1.46759e-16
C524 FILL_L30_15 FILL_L8_6 2.3244399999999999e-17
C525 FILL_L30_15 FILL_L8_7 2.7078900000000002e-17
C526 FILL_L30_15 FILL_L8_8 3.7323700000000007e-17
C527 FILL_L30_15 FILL_L8_9 2.30082e-18
C528 FILL_L30_15 N 3.6272300000000006e-16
C529 FILL_L30_15 0 3.5702500000000002e-16
C530 FILL_L30_16 FILL_L30_17 1.92731e-17
C531 FILL_L30_16 FILL_L30_19 1.92731e-17
C532 FILL_L30_16 FILL_L50_21 6.7224999999999998e-17
C533 FILL_L30_16 0 6.0225200000000008e-17
C534 FILL_L30_17 FILL_L30_20 1.92731e-17
C535 FILL_L30_17 FILL_L30_21 1.92731e-17
C536 FILL_L30_17 FILL_L50_22 6.7224999999999998e-17
C537 FILL_L30_17 0 3.4408200000000005e-17
C538 FILL_L30_18 FILL_L30_19 7.7092600000000011e-17
C539 FILL_L30_18 FILL_L50_24 6.2384800000000003e-16
C540 FILL_L30_18 0 2.8968300000000001e-16
C541 FILL_L30_19 FILL_L30_20 7.6042400000000005e-18
C542 FILL_L30_19 FILL_L30_21 9.4730399999999993e-18
C543 FILL_L30_19 FILL_L50_20 1.3417300000000002e-16
C544 FILL_L30_19 FILL_L50_24 2.3322800000000004e-17
C545 FILL_L30_19 FILL_L50_25 1.3417300000000002e-16
C546 FILL_L30_19 P 3.5811600000000002e-16
C547 FILL_L30_19 0 3.02834e-16
C548 FILL_L30_2 FILL_L30_3 1.92731e-17
C549 FILL_L30_2 FILL_L50_2 6.7224999999999998e-17
C550 FILL_L30_2 0 7.0611000000000007e-17
C551 FILL_L30_20 FILL_L30_21 1.92731e-17
C552 FILL_L30_20 FILL_L50_26 6.7224999999999998e-17
C553 FILL_L30_20 0 6.8199100000000006e-17
C554 FILL_L30_21 FILL_L50_22 4.0001400000000005e-18
C555 FILL_L30_21 FILL_L50_23 1.46759e-16
C556 FILL_L30_21 FILL_L50_26 4.0405400000000007e-18
C557 FILL_L30_21 FILL_L50_27 1.46759e-16
C558 FILL_L30_21 FILL_L8_10 3.1295700000000002e-17
C559 FILL_L30_21 FILL_L8_11 2.9260400000000002e-17
C560 FILL_L30_21 FILL_L8_12 8.0512999999999997e-18
C561 FILL_L30_21 FILL_L8_9 8.0512999999999997e-18
C562 FILL_L30_21 N 3.5909200000000002e-16
C563 FILL_L30_21 0 4.5001200000000002e-16
C564 FILL_L30_3 FILL_L30_4 1.92731e-17
C565 FILL_L30_3 FILL_L30_5 1.92731e-17
C566 FILL_L30_3 FILL_L50_3 6.7224999999999998e-17
C567 FILL_L30_3 0 5.9094000000000009e-17
C568 FILL_L30_4 FILL_L30_9 7.7092600000000011e-17
C569 FILL_L30_4 FILL_L50_3 4.0405400000000007e-18
C570 FILL_L30_4 FILL_L50_4 1.2738600000000002e-16
C571 FILL_L30_4 FILL_L8_0 1.4606900000000002e-17
C572 FILL_L30_4 FILL_L8_1 5.0346600000000001e-18
C573 FILL_L30_4 FILL_L8_2 1.8545800000000002e-17
C574 FILL_L30_4 N 1.4095200000000001e-16
C575 FILL_L30_4 0 2.70092e-16
C576 FILL_L30_5 FILL_L30_7 7.6042400000000005e-18
C577 FILL_L30_5 FILL_L30_8 1.92731e-17
C578 FILL_L30_5 FILL_L30_9 1.92731e-17
C579 FILL_L30_5 FILL_L50_6 6.7224999999999998e-17
C580 FILL_L30_5 0 4.2390500000000006e-17
C581 FILL_L30_6 FILL_L30_7 7.7092600000000011e-17
C582 FILL_L30_6 FILL_L50_8 6.2384800000000003e-16
C583 FILL_L30_6 0 2.3418200000000003e-16
C584 FILL_L30_7 FILL_L30_8 7.3000700000000009e-18
C585 FILL_L30_7 FILL_L30_9 5.8732800000000007e-18
C586 FILL_L30_7 FILL_L50_5 1.3417300000000002e-16
C587 FILL_L30_7 FILL_L50_8 2.3410700000000001e-17
C588 FILL_L30_7 FILL_L50_9 1.3417300000000002e-16
C589 FILL_L30_7 P 3.6174800000000003e-16
C590 FILL_L30_7 0 2.2069000000000002e-16
C591 FILL_L30_8 FILL_L30_9 1.92731e-17
C592 FILL_L30_8 FILL_L50_10 6.7224999999999998e-17
C593 FILL_L30_8 0 4.4506200000000001e-17
C594 FILL_L30_9 FILL_L50_10 4.0405400000000007e-18
C595 FILL_L30_9 FILL_L50_11 1.46759e-16
C596 FILL_L30_9 FILL_L50_6 4.0405400000000007e-18
C597 FILL_L30_9 FILL_L50_7 1.46759e-16
C598 FILL_L30_9 FILL_L8_1 5.0346600000000001e-18
C599 FILL_L30_9 FILL_L8_3 2.9793800000000006e-17
C600 FILL_L30_9 FILL_L8_4 1.60615e-17
C601 FILL_L30_9 FILL_L8_5 3.3134700000000006e-17
C602 FILL_L30_9 N 3.6272300000000006e-16
C603 FILL_L30_9 0 3.6504600000000002e-16
C604 FILL_L50_0 FILL_L50_8 5.7335500000000007e-17
C605 FILL_L50_0 P 1.8889099999999999e-17
C606 FILL_L50_0 0 1.3259200000000001e-16
C607 FILL_L50_1 FILL_L50_2 2.4713600000000001e-17
C608 FILL_L50_1 FILL_L50_5 2.4713600000000001e-17
C609 FILL_L50_1 P 6.6567200000000001e-17
C610 FILL_L50_1 0 3.5262300000000004e-17
C611 FILL_L50_10 FILL_L50_14 2.4713600000000001e-17
C612 FILL_L50_10 FILL_L50_6 2.4713600000000001e-17
C613 FILL_L50_10 FILL_L50_9 9.5013900000000012e-18
C614 FILL_L50_10 N 1.5955500000000001e-17
C615 FILL_L50_10 0 3.2366000000000002e-17
C616 FILL_L50_11 FILL_L50_15 2.4713600000000001e-17
C617 FILL_L50_11 FILL_L50_7 2.4713600000000001e-17
C618 FILL_L50_11 N 2.9064600000000002e-17
C619 FILL_L50_11 0 2.2554400000000004e-17
C620 FILL_L50_12 FILL_L50_13 2.4713600000000001e-17
C621 FILL_L50_12 FILL_L50_17 2.4713600000000001e-17
C622 FILL_L50_12 FILL_L50_9 2.4713600000000001e-17
C623 FILL_L50_12 P 6.6567200000000001e-17
C624 FILL_L50_12 0 5.3588199999999998e-18
C625 FILL_L50_13 FILL_L50_14 2.4713600000000001e-17
C626 FILL_L50_13 FILL_L50_2 6.1876600000000009e-18
C627 FILL_L50_13 FILL_L50_21 9.897280000000001e-18
C628 FILL_L50_13 0 3.1434799999999999e-17
C629 FILL_L50_14 FILL_L50_18 2.4713600000000001e-17
C630 FILL_L50_14 N 1.5955500000000001e-17
C631 FILL_L50_14 0 1.80312e-17
C632 FILL_L50_15 FILL_L50_19 2.4713600000000001e-17
C633 FILL_L50_15 N 2.9064600000000002e-17
C634 FILL_L50_15 0 2.2554400000000004e-17
C635 FILL_L50_16 FILL_L50_24 5.7335500000000007e-17
C636 FILL_L50_16 FILL_L50_8 5.7335500000000007e-17
C637 FILL_L50_16 P 4.8746100000000003e-17
C638 FILL_L50_16 0 1.6173300000000002e-16
C639 FILL_L50_17 FILL_L50_18 7.9178300000000003e-18
C640 FILL_L50_17 FILL_L50_20 2.4713600000000001e-17
C641 FILL_L50_17 P 6.6567200000000001e-17
C642 FILL_L50_17 0 1.6322500000000002e-17
C643 FILL_L50_18 FILL_L50_22 2.4713600000000001e-17
C644 FILL_L50_18 N 1.5955500000000001e-17
C645 FILL_L50_18 0 2.8470500000000006e-17
C646 FILL_L50_19 FILL_L50_23 2.4713600000000001e-17
C647 FILL_L50_19 N 2.9064600000000002e-17
C648 FILL_L50_19 0 3.1020900000000001e-17
C649 FILL_L50_2 FILL_L50_3 2.4713600000000001e-17
C650 FILL_L50_2 0 5.5810600000000004e-17
C651 FILL_L50_20 FILL_L50_21 2.4713600000000001e-17
C652 FILL_L50_20 FILL_L50_25 2.4713600000000001e-17
C653 FILL_L50_20 P 6.6567200000000001e-17
C654 FILL_L50_20 0 1.2233800000000002e-17
C655 FILL_L50_21 FILL_L50_22 2.4713600000000001e-17
C656 FILL_L50_21 0 4.6198200000000001e-17
C657 FILL_L50_22 FILL_L50_26 2.4713600000000001e-17
C658 FILL_L50_22 N 1.5955500000000001e-17
C659 FILL_L50_22 0 1.9584499999999999e-17
C660 FILL_L50_23 FILL_L50_27 2.4713600000000001e-17
C661 FILL_L50_23 N 2.9064600000000002e-17
C662 FILL_L50_23 0 2.2554400000000004e-17
C663 FILL_L50_24 P 4.8746100000000003e-17
C664 FILL_L50_24 0 2.1956300000000001e-16
C665 FILL_L50_25 FILL_L50_26 9.897280000000001e-18
C666 FILL_L50_25 P 6.6567200000000001e-17
C667 FILL_L50_25 0 4.2376300000000005e-17
C668 FILL_L50_26 N 1.5955500000000001e-17
C669 FILL_L50_26 0 5.1850500000000003e-17
C670 FILL_L50_27 N 2.9064600000000002e-17
C671 FILL_L50_27 0 5.8173100000000001e-17
C672 FILL_L50_3 FILL_L50_6 2.4713600000000001e-17
C673 FILL_L50_3 N 1.5955500000000001e-17
C674 FILL_L50_3 0 4.3658200000000001e-17
C675 FILL_L50_4 FILL_L50_7 2.4713600000000001e-17
C676 FILL_L50_4 N 2.9064600000000002e-17
C677 FILL_L50_4 0 4.8672100000000002e-17
C678 FILL_L50_5 FILL_L50_6 9.897280000000001e-18
C679 FILL_L50_5 FILL_L50_9 2.4713600000000001e-17
C680 FILL_L50_5 P 6.6567200000000001e-17
C681 FILL_L50_5 0 1.6779399999999999e-17
C682 FILL_L50_6 N 1.5955500000000001e-17
C683 FILL_L50_6 0 2.7192600000000001e-17
C684 FILL_L50_7 N 2.9064600000000002e-17
C685 FILL_L50_7 0 3.9487400000000001e-17
C686 FILL_L50_8 P 4.8746100000000003e-17
C687 FILL_L50_8 0 1.5721000000000002e-16
C688 FILL_L50_9 P 6.6567200000000001e-17
C689 FILL_L50_9 0 1.8485700000000003e-17
C690 FILL_L8_0 FILL_L8_1 1.9913400000000001e-17
C691 FILL_L8_0 FILL_L8_2 1.0952400000000002e-17
C692 FILL_L8_0 0 1.0895200000000001e-16
C693 FILL_L8_1 FILL_L8_2 1.9913400000000001e-17
C694 FILL_L8_1 FILL_L8_3 1.9913400000000001e-17
C695 FILL_L8_1 N 5.14103e-19
C696 FILL_L8_1 0 1.25459e-16
C697 FILL_L8_10 FILL_L8_11 1.9913400000000001e-17
C698 FILL_L8_10 FILL_L8_12 1.9913400000000001e-17
C699 FILL_L8_10 FILL_L8_9 1.9913400000000001e-17
C700 FILL_L8_10 0 1.25459e-16
C701 FILL_L8_11 FILL_L8_13 6.96968e-17
C702 FILL_L8_11 FILL_L8_8 6.96968e-17
C703 FILL_L8_11 FILL_L8_9 1.9913400000000001e-17
C704 FILL_L8_11 0 8.2727300000000008e-16
C705 FILL_L8_12 FILL_L8_13 8.9610199999999998e-18
C706 FILL_L8_12 N 1.70371e-19
C707 FILL_L8_12 0 1.0013900000000001e-16
C708 FILL_L8_13 0 3.0235399999999999e-16
C709 FILL_L8_2 FILL_L8_5 6.96968e-17
C710 FILL_L8_2 N 1.7191300000000003e-19
C711 FILL_L8_2 0 8.0178800000000002e-16
C712 FILL_L8_3 FILL_L8_4 1.9913400000000001e-17
C713 FILL_L8_3 FILL_L8_5 1.9913400000000001e-17
C714 FILL_L8_3 0 1.2834300000000001e-16
C715 FILL_L8_4 FILL_L8_5 1.9913400000000001e-17
C716 FILL_L8_4 FILL_L8_6 1.9913400000000001e-17
C717 FILL_L8_4 N 2.00261e-19
C718 FILL_L8_4 0 1.2925300000000001e-16
C719 FILL_L8_5 FILL_L8_8 6.96968e-17
C720 FILL_L8_5 0 8.2633300000000001e-16
C721 FILL_L8_6 FILL_L8_7 1.9913400000000001e-17
C722 FILL_L8_6 FILL_L8_8 1.9913400000000001e-17
C723 FILL_L8_6 0 1.25459e-16
C724 FILL_L8_7 FILL_L8_8 1.9913400000000001e-17
C725 FILL_L8_7 FILL_L8_9 1.9913400000000001e-17
C726 FILL_L8_7 0 1.2853299999999999e-16
C727 FILL_L8_8 0 8.2735299999999998e-16
C728 FILL_L8_9 N 4.99158e-19
C729 FILL_L8_9 0 1.2885100000000001e-16
C730 N 0 3.9141800000000002e-16
C731 P 0 3.4020400000000005e-16
VP P 0 DC 0 AC 1
VN N 0 DC 0 AC 0
.control
set numdgt=17
ac lin 1 1Meg 1Meg
let cp = -imag(i(VP))/(2*pi*1e6)
let cn = -imag(i(VN))/(2*pi*1e6)
print cp cn
quit
.endc
.end
