* cell sense_fill_clip
.SUBCKT sense_fill_clip
* net 2 CTX_L8_0
* net 3 FILL_L30_0
* net 4 FILL_L50_0
* net 5 FILL_L67_0
* net 6 CTX_L8_1
* net 7 CTX_L8_2
* net 8 CTX_L8_3
* net 9 FILL_L67_1
* net 10 FILL_L30_1
* net 11 CTX_L8_4
* net 12 CTX_L8_5
* net 13 CTX_L8_6
* net 14 CTX_L8_7
* net 15 CTX_L8_8
* net 16 CTX_L8_9
* net 17 FILL_L10_0
* net 18 FILL_L8_0
* net 19 FILL_L30_4
* net 20 FILL_L67_4
* net 21 CTX_L10_0,CTX_L8_10
* net 22 FILL_L50_1
* net 23 FILL_L67_2
* net 24 FILL_L30_2
* net 25 FILL_L50_2
* net 26 FILL_L67_3
* net 27 FILL_L30_3
* net 28 FILL_L50_3
* net 29 FILL_L50_4
* net 30 FILL_L8_2
* net 31 FILL_L10_2
* net 32 CTX_L10_1,CTX_L10_3,CTX_L126_0,CTX_L30_0,CTX_L30_1,CTX_L50_0,CTX_L50_1,CTX_L67_0,CTX_L67_1,CTX_L8_11,CTX_L8_13
* net 33 FILL_L50_5
* net 34 FILL_L30_5
* net 35 FILL_L50_6
* net 36 FILL_L10_1
* net 37 FILL_L8_1
* net 38 FILL_L50_7
* net 39 FILL_L30_6
* net 40 FILL_L50_8
* net 41 FILL_L67_5
* net 42 FILL_L67_6
* net 43 FILL_L30_7
* net 44 FILL_L10_3
* net 45 FILL_L67_7
* net 46 FILL_L8_3
* net 47 FILL_L30_9
* net 48 FILL_L134_0
* net 49 FILL_L50_9
* net 50 FILL_L134_1
* net 51 FILL_L30_8
* net 52 FILL_L50_10
* net 53 FILL_L10_4
* net 54 FILL_L8_4
* net 55 FILL_L134_2
* net 56 FILL_L50_11
* net 57 FILL_L8_5
* net 58 FILL_L10_5
* net 59 CTX_L10_2,CTX_L8_12
* net 60 FILL_L50_16
* net 61 FILL_L30_12
* net 62 FILL_L67_10
* net 63 FILL_L30_13
* net 64 FILL_L67_11
* net 65 P
* net 66 FILL_L50_12
* net 67 FILL_L30_10
* net 68 FILL_L67_8
* net 69 FILL_L50_13
* net 70 FILL_L67_9
* net 71 FILL_L30_11
* net 72 FILL_L50_14
* net 73 N
* net 74 FILL_L10_6
* net 75 FILL_L8_6
* net 76 FILL_L67_12
* net 77 FILL_L30_15
* net 78 FILL_L50_15
* net 79 FILL_L8_8
* net 80 FILL_L10_8
* net 81 FILL_L50_17
* net 82 FILL_L30_14
* net 83 FILL_L50_18
* net 84 FILL_L10_7
* net 85 FILL_L8_7
* net 86 FILL_L50_19
* net 87 FILL_L8_9
* net 88 FILL_L10_9
* net 89 CTX_L10_4,CTX_L8_14
* net 90 FILL_L30_18
* net 91 FILL_L50_24
* net 92 FILL_L67_15
* net 93 FILL_L134_3
* net 94 FILL_L67_16
* net 95 FILL_L30_19
* net 96 FILL_L50_20
* net 97 FILL_L50_21
* net 98 FILL_L30_16
* net 99 FILL_L67_13
* net 100 FILL_L134_4
* net 101 FILL_L50_22
* net 102 FILL_L67_14
* net 103 FILL_L30_17
* net 104 FILL_L30_21
* net 105 FILL_L8_10
* net 106 FILL_L10_10
* net 107 FILL_L67_17
* net 108 FILL_L134_5
* net 109 FILL_L50_23
* net 110 FILL_L10_11
* net 111 FILL_L8_11
* net 112 CTX_L8_15
* net 113 CTX_L8_16
* net 114 CTX_L8_17
* net 115 CTX_L8_18
* net 116 CTX_L8_19
* net 117 FILL_L50_25
* net 118 CTX_L8_20
* net 119 CTX_L8_21
* net 120 CTX_L8_22
* net 121 FILL_L30_20
* net 122 FILL_L50_26
* net 123 CTX_L8_23
* net 124 CTX_L8_24
* net 125 FILL_L8_12
* net 126 FILL_L10_12
* net 127 FILL_L50_27
* net 128 FILL_L8_13
* net 129 FILL_L10_13
.ENDS sense_fill_clip
