*********************************************************
*** NGSPICE file created by KLayout-PEX 0.3.12
*** -----------------------------------------------------
***     Extraction Engine: KPEX/2.5D
***     Technology: ihp_sg13g2
***     Date: 2026-09-23 06:33:33
*********************************************************

.SUBCKT sense_fill_clip
Cext_1 CTX_L10_0|CTX_L8_10
+ CTX_L10_1|CTX_L10_3|CTX_L126_0|CTX_L30_0|CTX_L30_1|CTX_L50_0|CTX_L50_1|CTX_L67_0|CTX_L67_1|CTX_L8_11|CTX_L8_13
+ 1.57934f
Cext_2 CTX_L10_0|CTX_L8_10 CTX_L8_0 33.2945a
Cext_3 CTX_L10_0|CTX_L8_10 CTX_L8_1 31.0013a
Cext_4 CTX_L10_0|CTX_L8_10 CTX_L8_2 33.2945a
Cext_5 CTX_L10_0|CTX_L8_10 CTX_L8_3 31.0013a
Cext_6 CTX_L10_0|CTX_L8_10 CTX_L8_4 33.2945a
Cext_7 CTX_L10_0|CTX_L8_10 CTX_L8_5 31.0013a
Cext_8 CTX_L10_0|CTX_L8_10 CTX_L8_6 33.2945a
Cext_9 CTX_L10_0|CTX_L8_10 CTX_L8_7 30.9715a
Cext_10 CTX_L10_0|CTX_L8_10 CTX_L8_8 33.2945a
Cext_11 CTX_L10_0|CTX_L8_10 CTX_L8_9 31.0013a
Cext_12 CTX_L10_0|CTX_L8_10 N 59.6845a
Cext_13 CTX_L10_0|CTX_L8_10 P 162.669a
Cext_14 CTX_L10_0|CTX_L8_10 VSUBS 4.48873f
Cext_15
+ CTX_L10_1|CTX_L10_3|CTX_L126_0|CTX_L30_0|CTX_L30_1|CTX_L50_0|CTX_L50_1|CTX_L67_0|CTX_L67_1|CTX_L8_11|CTX_L8_13
+ CTX_L10_2|CTX_L8_12 2.61626f
Cext_16
+ CTX_L10_1|CTX_L10_3|CTX_L126_0|CTX_L30_0|CTX_L30_1|CTX_L50_0|CTX_L50_1|CTX_L67_0|CTX_L67_1|CTX_L8_11|CTX_L8_13
+ CTX_L10_4|CTX_L8_14 1.5816f
Cext_17
+ CTX_L10_1|CTX_L10_3|CTX_L126_0|CTX_L30_0|CTX_L30_1|CTX_L50_0|CTX_L50_1|CTX_L67_0|CTX_L67_1|CTX_L8_11|CTX_L8_13
+ CTX_L8_0 0.613321a
Cext_18
+ CTX_L10_1|CTX_L10_3|CTX_L126_0|CTX_L30_0|CTX_L30_1|CTX_L50_0|CTX_L50_1|CTX_L67_0|CTX_L67_1|CTX_L8_11|CTX_L8_13
+ CTX_L8_1 0.665559a
Cext_19
+ CTX_L10_1|CTX_L10_3|CTX_L126_0|CTX_L30_0|CTX_L30_1|CTX_L50_0|CTX_L50_1|CTX_L67_0|CTX_L67_1|CTX_L8_11|CTX_L8_13
+ CTX_L8_15 0.696955a
Cext_20
+ CTX_L10_1|CTX_L10_3|CTX_L126_0|CTX_L30_0|CTX_L30_1|CTX_L50_0|CTX_L50_1|CTX_L67_0|CTX_L67_1|CTX_L8_11|CTX_L8_13
+ CTX_L8_16 0.756317a
Cext_21
+ CTX_L10_1|CTX_L10_3|CTX_L126_0|CTX_L30_0|CTX_L30_1|CTX_L50_0|CTX_L50_1|CTX_L67_0|CTX_L67_1|CTX_L8_11|CTX_L8_13
+ CTX_L8_17 1.15444a
Cext_22
+ CTX_L10_1|CTX_L10_3|CTX_L126_0|CTX_L30_0|CTX_L30_1|CTX_L50_0|CTX_L50_1|CTX_L67_0|CTX_L67_1|CTX_L8_11|CTX_L8_13
+ CTX_L8_18 2.17044a
Cext_23
+ CTX_L10_1|CTX_L10_3|CTX_L126_0|CTX_L30_0|CTX_L30_1|CTX_L50_0|CTX_L50_1|CTX_L67_0|CTX_L67_1|CTX_L8_11|CTX_L8_13
+ CTX_L8_19 2.55464a
Cext_24
+ CTX_L10_1|CTX_L10_3|CTX_L126_0|CTX_L30_0|CTX_L30_1|CTX_L50_0|CTX_L50_1|CTX_L67_0|CTX_L67_1|CTX_L8_11|CTX_L8_13
+ CTX_L8_2 0.96735a
Cext_25
+ CTX_L10_1|CTX_L10_3|CTX_L126_0|CTX_L30_0|CTX_L30_1|CTX_L50_0|CTX_L50_1|CTX_L67_0|CTX_L67_1|CTX_L8_11|CTX_L8_13
+ CTX_L8_20 2.64567a
Cext_26
+ CTX_L10_1|CTX_L10_3|CTX_L126_0|CTX_L30_0|CTX_L30_1|CTX_L50_0|CTX_L50_1|CTX_L67_0|CTX_L67_1|CTX_L8_11|CTX_L8_13
+ CTX_L8_21 2.86322a
Cext_27
+ CTX_L10_1|CTX_L10_3|CTX_L126_0|CTX_L30_0|CTX_L30_1|CTX_L50_0|CTX_L50_1|CTX_L67_0|CTX_L67_1|CTX_L8_11|CTX_L8_13
+ CTX_L8_22 3.35422a
Cext_28
+ CTX_L10_1|CTX_L10_3|CTX_L126_0|CTX_L30_0|CTX_L30_1|CTX_L50_0|CTX_L50_1|CTX_L67_0|CTX_L67_1|CTX_L8_11|CTX_L8_13
+ CTX_L8_23 2.86322a
Cext_29
+ CTX_L10_1|CTX_L10_3|CTX_L126_0|CTX_L30_0|CTX_L30_1|CTX_L50_0|CTX_L50_1|CTX_L67_0|CTX_L67_1|CTX_L8_11|CTX_L8_13
+ CTX_L8_24 4.05282a
Cext_30
+ CTX_L10_1|CTX_L10_3|CTX_L126_0|CTX_L30_0|CTX_L30_1|CTX_L50_0|CTX_L50_1|CTX_L67_0|CTX_L67_1|CTX_L8_11|CTX_L8_13
+ CTX_L8_3 1.98621a
Cext_31
+ CTX_L10_1|CTX_L10_3|CTX_L126_0|CTX_L30_0|CTX_L30_1|CTX_L50_0|CTX_L50_1|CTX_L67_0|CTX_L67_1|CTX_L8_11|CTX_L8_13
+ CTX_L8_4 2.29228a
Cext_32
+ CTX_L10_1|CTX_L10_3|CTX_L126_0|CTX_L30_0|CTX_L30_1|CTX_L50_0|CTX_L50_1|CTX_L67_0|CTX_L67_1|CTX_L8_11|CTX_L8_13
+ CTX_L8_5 2.32007a
Cext_33
+ CTX_L10_1|CTX_L10_3|CTX_L126_0|CTX_L30_0|CTX_L30_1|CTX_L50_0|CTX_L50_1|CTX_L67_0|CTX_L67_1|CTX_L8_11|CTX_L8_13
+ CTX_L8_6 2.52009a
Cext_34
+ CTX_L10_1|CTX_L10_3|CTX_L126_0|CTX_L30_0|CTX_L30_1|CTX_L50_0|CTX_L50_1|CTX_L67_0|CTX_L67_1|CTX_L8_11|CTX_L8_13
+ CTX_L8_7 2.94006a
Cext_35
+ CTX_L10_1|CTX_L10_3|CTX_L126_0|CTX_L30_0|CTX_L30_1|CTX_L50_0|CTX_L50_1|CTX_L67_0|CTX_L67_1|CTX_L8_11|CTX_L8_13
+ CTX_L8_8 2.52009a
Cext_36
+ CTX_L10_1|CTX_L10_3|CTX_L126_0|CTX_L30_0|CTX_L30_1|CTX_L50_0|CTX_L50_1|CTX_L67_0|CTX_L67_1|CTX_L8_11|CTX_L8_13
+ CTX_L8_9 3.55836a
Cext_37
+ CTX_L10_1|CTX_L10_3|CTX_L126_0|CTX_L30_0|CTX_L30_1|CTX_L50_0|CTX_L50_1|CTX_L67_0|CTX_L67_1|CTX_L8_11|CTX_L8_13
+ N 923.976a
Cext_38
+ CTX_L10_1|CTX_L10_3|CTX_L126_0|CTX_L30_0|CTX_L30_1|CTX_L50_0|CTX_L50_1|CTX_L67_0|CTX_L67_1|CTX_L8_11|CTX_L8_13
+ P 1.04058f
Cext_39
+ CTX_L10_1|CTX_L10_3|CTX_L126_0|CTX_L30_0|CTX_L30_1|CTX_L50_0|CTX_L50_1|CTX_L67_0|CTX_L67_1|CTX_L8_11|CTX_L8_13
+ VSUBS 10.7916f
Cext_40 CTX_L10_2|CTX_L8_12 N 59.6845a
Cext_41 CTX_L10_2|CTX_L8_12 P 163.709a
Cext_42 CTX_L10_2|CTX_L8_12 VSUBS 4.06308f
Cext_43 CTX_L10_4|CTX_L8_14 CTX_L8_15 33.3865a
Cext_44 CTX_L10_4|CTX_L8_14 CTX_L8_16 31.0806a
Cext_45 CTX_L10_4|CTX_L8_14 CTX_L8_17 33.3865a
Cext_46 CTX_L10_4|CTX_L8_14 CTX_L8_18 31.0806a
Cext_47 CTX_L10_4|CTX_L8_14 CTX_L8_19 33.3865a
Cext_48 CTX_L10_4|CTX_L8_14 CTX_L8_20 31.0806a
Cext_49 CTX_L10_4|CTX_L8_14 CTX_L8_21 33.3865a
Cext_50 CTX_L10_4|CTX_L8_14 CTX_L8_22 31.0508a
Cext_51 CTX_L10_4|CTX_L8_14 CTX_L8_23 33.3865a
Cext_52 CTX_L10_4|CTX_L8_14 CTX_L8_24 31.0806a
Cext_53 CTX_L10_4|CTX_L8_14 N 59.6845a
Cext_54 CTX_L10_4|CTX_L8_14 P 162.746a
Cext_55 CTX_L10_4|CTX_L8_14 VSUBS 4.48766f
Cext_56 CTX_L8_0 CTX_L8_1 1.75621a
Cext_57 CTX_L8_0 P 0.201577a
Cext_58 CTX_L8_0 VSUBS 45.9869a
Cext_59 CTX_L8_1 CTX_L8_2 12.797a
Cext_60 CTX_L8_1 P 0.298456a
Cext_61 CTX_L8_1 VSUBS 33.3778a
Cext_62 CTX_L8_15 CTX_L8_16 2.75976a
Cext_63 CTX_L8_15 P 0.201577a
Cext_64 CTX_L8_15 VSUBS 50.4932a
Cext_65 CTX_L8_16 CTX_L8_17 14.542a
Cext_66 CTX_L8_16 P 0.445457a
Cext_67 CTX_L8_16 VSUBS 36.5012a
Cext_68 CTX_L8_17 CTX_L8_18 2.75976a
Cext_69 CTX_L8_17 P 0.742663a
Cext_70 CTX_L8_17 VSUBS 39.669a
Cext_71 CTX_L8_18 CTX_L8_19 14.542a
Cext_72 CTX_L8_18 P 1.15085a
Cext_73 CTX_L8_18 VSUBS 36.5012a
Cext_74 CTX_L8_19 CTX_L8_20 2.75976a
Cext_75 CTX_L8_19 P 1.30194a
Cext_76 CTX_L8_19 VSUBS 39.669a
Cext_77 CTX_L8_2 CTX_L8_3 1.75621a
Cext_78 CTX_L8_2 P 0.653543a
Cext_79 CTX_L8_2 VSUBS 36.4616a
Cext_80 CTX_L8_20 CTX_L8_21 14.542a
Cext_81 CTX_L8_20 P 0.63766a
Cext_82 CTX_L8_20 VSUBS 36.5012a
Cext_83 CTX_L8_21 CTX_L8_22 2.75976a
Cext_84 CTX_L8_21 N 0.160503a
Cext_85 CTX_L8_21 P 0.514618a
Cext_86 CTX_L8_21 VSUBS 39.669a
Cext_87 CTX_L8_22 CTX_L8_23 14.542a
Cext_88 CTX_L8_22 N 0.342709a
Cext_89 CTX_L8_22 P 0.17312a
Cext_90 CTX_L8_22 VSUBS 36.5012a
Cext_91 CTX_L8_23 CTX_L8_24 2.75976a
Cext_92 CTX_L8_23 N 0.57054a
Cext_93 CTX_L8_23 P 0.147704a
Cext_94 CTX_L8_23 VSUBS 39.669a
Cext_95 CTX_L8_24 N 1.08566a
Cext_96 CTX_L8_24 VSUBS 47.3254a
Cext_97 CTX_L8_3 CTX_L8_4 12.797a
Cext_98 CTX_L8_3 P 1.03644a
Cext_99 CTX_L8_3 VSUBS 33.3778a
Cext_100 CTX_L8_4 CTX_L8_5 1.75621a
Cext_101 CTX_L8_4 P 1.16941a
Cext_102 CTX_L8_4 VSUBS 36.4616a
Cext_103 CTX_L8_5 CTX_L8_6 12.797a
Cext_104 CTX_L8_5 P 0.561141a
Cext_105 CTX_L8_5 VSUBS 33.3778a
Cext_106 CTX_L8_6 CTX_L8_7 1.75621a
Cext_107 CTX_L8_6 N 0.160503a
Cext_108 CTX_L8_6 P 0.452864a
Cext_109 CTX_L8_6 VSUBS 36.4616a
Cext_110 CTX_L8_7 CTX_L8_8 12.797a
Cext_111 CTX_L8_7 N 0.229615a
Cext_112 CTX_L8_7 P 0.17312a
Cext_113 CTX_L8_7 VSUBS 33.3778a
Cext_114 CTX_L8_8 CTX_L8_9 1.75621a
Cext_115 CTX_L8_8 N 0.502075a
Cext_116 CTX_L8_8 P 0.147704a
Cext_117 CTX_L8_8 VSUBS 36.4616a
Cext_118 CTX_L8_9 N 0.955378a
Cext_119 CTX_L8_9 VSUBS 42.9031a
Cext_120 N VSUBS 963.734a
Cext_121 P VSUBS 643.287a
.ENDS sense_fill_clip
