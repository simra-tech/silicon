* actual_fill grounded drive P; diagnostic capacitor-network AC only
C38 0 N 5.1221400000000004e-17
C39 0 P 1.0355900000000001e-16
C144 0 N 8.3873299999999998e-16
C145 0 P 7.8557500000000015e-16
C178 0 N 4.6069200000000004e-17
C179 0 P 7.0077000000000007e-17
C217 0 N 4.6483600000000004e-17
C218 0 P 4.8489400000000009e-17
C228 0 P 2.98456e-19
C234 0 P 1.7149100000000002e-19
C239 0 P 4.0091100000000004e-19
C245 0 P 6.6839600000000007e-19
C249 0 P 1.02605e-18
C253 0 P 1.1620200000000001e-18
C260 0 P 6.5354300000000003e-19
C264 0 P 5.7389400000000003e-19
C269 0 N 1.36547e-19
C270 0 P 4.6315600000000007e-19
C274 0 N 3.0843800000000002e-19
C275 0 P 1.4728100000000001e-19
C281 0 N 5.13486e-19
C282 0 P 1.25658e-19
C288 0 N 9.7709200000000004e-19
C298 0 P 5.6114100000000006e-19
C305 0 N 1.6050300000000001e-19
C306 0 P 4.5286400000000006e-19
C311 0 N 2.2961500000000001e-19
C312 0 P 1.7312e-19
C320 0 N 5.0207500000000008e-19
C321 0 P 1.4770400000000001e-19
C326 0 N 7.2933000000000013e-19
C339 0 N 1.3071400000000001e-17
C356 0 N 2.3613300000000001e-17
C362 0 N 5.8821100000000002e-18
C366 0 N 4.2503900000000004e-18
C374 0 N 1.9634600000000002e-17
C388 0 N 6.4582100000000006e-18
C396 0 N 2.3613300000000001e-17
C416 0 N 1.88906e-17
C422 0 N 1.3009400000000001e-17
C435 0 P 4.6075600000000005e-17
C454 0 N 2.5909500000000002e-17
C463 0 P 2.1008700000000001e-17
C476 0 N 1.0733900000000001e-17
C487 0 P 1.3876200000000002e-16
C512 0 P 3.6174800000000003e-16
C528 0 N 3.6272300000000006e-16
C546 0 P 3.5811600000000002e-16
C562 0 N 3.5909200000000002e-16
C574 0 N 1.4095200000000001e-16
C589 0 P 3.6174800000000003e-16
C602 0 N 3.6272300000000006e-16
C605 0 P 1.8889099999999999e-17
C609 0 P 6.6567200000000001e-17
C614 0 N 1.5955500000000001e-17
C618 0 N 2.9064600000000002e-17
C623 0 P 6.6567200000000001e-17
C630 0 N 1.5955500000000001e-17
C633 0 N 2.9064600000000002e-17
C637 0 P 4.8746100000000003e-17
C641 0 P 6.6567200000000001e-17
C644 0 N 1.5955500000000001e-17
C647 0 N 2.9064600000000002e-17
C653 0 P 6.6567200000000001e-17
C658 0 N 1.5955500000000001e-17
C661 0 N 2.9064600000000002e-17
C663 0 P 4.8746100000000003e-17
C666 0 P 6.6567200000000001e-17
C668 0 N 1.5955500000000001e-17
C670 0 N 2.9064600000000002e-17
C673 0 N 1.5955500000000001e-17
C676 0 N 2.9064600000000002e-17
C680 0 P 6.6567200000000001e-17
C682 0 N 1.5955500000000001e-17
C684 0 N 2.9064600000000002e-17
C686 0 P 4.8746100000000003e-17
C688 0 P 6.6567200000000001e-17
C695 0 N 5.14103e-19
C706 0 N 1.70371e-19
C710 0 N 1.7191300000000003e-19
C717 0 N 2.00261e-19
C728 0 N 4.99158e-19
C730 N 0 3.9141800000000002e-16
C731 P 0 3.4020400000000005e-16
VP P 0 DC 0 AC 1
VN N 0 DC 0 AC 0
.control
set numdgt=17
ac lin 1 1Meg 1Meg
let cp = -imag(i(VP))/(2*pi*1e6)
let cn = -imag(i(VN))/(2*pi*1e6)
print cp cn
quit
.endc
.end
