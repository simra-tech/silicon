* actual_fill grounded drive P; diagnostic capacitor-network AC only
C129 0 N 1.4377400000000001e-16
C130 0 P 2.3263500000000003e-16
C259 0 N 8.3873299999999998e-16
C260 0 P 7.8764000000000002e-16
C289 0 N 8.3815500000000008e-17
C349 0 P 5.6114100000000006e-19
C356 0 N 1.6050300000000001e-19
C357 0 P 4.5286400000000006e-19
C362 0 N 2.2961500000000001e-19
C363 0 P 1.7312e-19
C371 0 N 5.0207500000000008e-19
C372 0 P 1.4770400000000001e-19
C377 0 N 7.2933000000000013e-19
C412 0 P 1.0868000000000001e-19
C418 0 P 1.7149100000000002e-19
C427 0 P 4.0091100000000004e-19
C433 0 P 6.6839600000000007e-19
C437 0 P 1.02605e-18
C441 0 P 1.1620200000000001e-18
C445 0 P 5.7389400000000003e-19
C450 0 N 1.36547e-19
C451 0 P 4.6315600000000007e-19
C455 0 N 3.0843800000000002e-19
C456 0 P 1.4728100000000001e-19
C462 0 N 5.13486e-19
C463 0 P 1.25658e-19
C469 0 N 9.7709200000000004e-19
C492 0 P 2.98456e-19
C498 0 P 6.5354300000000003e-19
C511 0 N 1.3071400000000001e-17
C541 0 N 1.88906e-17
C563 0 N 1.3009400000000001e-17
C579 0 N 2.3613300000000001e-17
C589 0 N 1.9634600000000002e-17
C607 0 N 5.8821100000000002e-18
C613 0 N 4.2503900000000004e-18
C644 0 N 6.4582100000000006e-18
C653 0 N 2.3613300000000001e-17
C669 0 P 4.6075600000000005e-17
C689 0 N 2.5909500000000002e-17
C704 0 N 1.49447e-18
C715 0 P 2.1008700000000001e-17
C729 0 N 1.0733900000000001e-17
C737 0 N 4.2699200000000003e-19
C766 0 P 3.6174800000000003e-16
C784 0 N 3.6272300000000006e-16
C814 0 P 1.3876200000000002e-16
C830 0 P 3.6174800000000003e-16
C845 0 N 3.6272300000000006e-16
C879 0 P 3.5811600000000002e-16
C892 0 N 3.5909200000000002e-16
C903 0 N 1.4095200000000001e-16
C919 0 P 1.8889099999999999e-17
C924 0 N 1.5955500000000001e-17
C928 0 N 2.9064600000000002e-17
C936 0 P 4.8746100000000003e-17
C941 0 P 6.6567200000000001e-17
C944 0 N 1.5955500000000001e-17
C947 0 N 2.9064600000000002e-17
C954 0 P 6.6567200000000001e-17
C962 0 P 6.6567200000000001e-17
C965 0 N 1.5955500000000001e-17
C968 0 N 2.9064600000000002e-17
C982 0 P 4.8746100000000003e-17
C986 0 P 6.6567200000000001e-17
C989 0 N 1.5955500000000001e-17
C992 0 N 2.9064600000000002e-17
C1001 0 P 6.6567200000000001e-17
C1006 0 N 1.5955500000000001e-17
C1009 0 N 2.9064600000000002e-17
C1017 0 P 4.8746100000000003e-17
C1020 0 P 6.6567200000000001e-17
C1022 0 N 1.5955500000000001e-17
C1024 0 N 1.5955500000000001e-17
C1026 0 N 2.9064600000000002e-17
C1028 0 N 2.9064600000000002e-17
C1035 0 P 6.6567200000000001e-17
C1042 0 N 5.14103e-19
C1064 0 N 4.99158e-19
C1079 0 N 1.7191300000000003e-19
C1082 0 N 1.70371e-19
C1098 0 N 2.00261e-19
C1105 N 0 3.8426900000000001e-16
C1106 P 0 3.30931e-16
VP P 0 DC 0 AC 1
VN N 0 DC 0 AC 0
.control
set numdgt=17
ac lin 1 1Meg 1Meg
let cp = -imag(i(VP))/(2*pi*1e6)
let cn = -imag(i(VN))/(2*pi*1e6)
print cp cn
quit
.endc
.end
