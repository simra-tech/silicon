* actual_fill floating drive N; diagnostic capacitor-network AC only
C36 0 FILL_L10_0 1.35421e-18
C37 0 FILL_L10_1 2.6679900000000002e-17
C38 0 FILL_L10_11 2.7691700000000002e-17
C39 0 FILL_L10_12 7.1717800000000008e-19
C40 0 FILL_L10_13 1.7140500000000001e-18
C41 0 FILL_L10_17 1.0359200000000001e-18
C42 0 FILL_L10_18 2.7683000000000003e-17
C43 0 FILL_L10_19 1.5776100000000001e-18
C44 0 FILL_L10_2 2.0247000000000005e-18
C45 0 FILL_L10_23 9.0842599999999994e-19
C46 0 FILL_L10_6 4.2962100000000001e-19
C47 0 FILL_L10_7 1.1979900000000002e-18
C48 0 FILL_L134_0 6.0084000000000012e-16
C49 0 FILL_L134_2 3.25343e-18
C50 0 FILL_L134_5 2.8350800000000001e-16
C51 0 FILL_L134_7 1.33523e-18
C52 0 FILL_L30_0 1.0983900000000001e-16
C53 0 FILL_L30_1 2.97414e-16
C54 0 FILL_L30_10 4.6389200000000003e-17
C55 0 FILL_L30_11 3.4273200000000003e-16
C56 0 FILL_L30_12 2.93986e-16
C57 0 FILL_L30_13 6.71456e-18
C58 0 FILL_L30_14 3.2858600000000005e-17
C59 0 FILL_L30_15 2.0009000000000001e-16
C60 0 FILL_L30_16 1.56777e-16
C61 0 FILL_L30_17 1.51908e-16
C62 0 FILL_L30_18 6.1446100000000005e-17
C63 0 FILL_L30_19 6.5129400000000007e-17
C64 0 FILL_L30_2 2.7655099999999999e-16
C65 0 FILL_L30_20 3.4959400000000002e-17
C66 0 FILL_L30_21 7.5751500000000004e-16
C67 0 FILL_L30_22 7.0396400000000007e-16
C68 0 FILL_L30_23 5.2856800000000008e-18
C69 0 FILL_L30_24 1.34196e-16
C70 0 FILL_L30_25 1.0923900000000001e-16
C71 0 FILL_L30_26 6.6092100000000009e-17
C72 0 FILL_L30_27 6.4664700000000004e-17
C73 0 FILL_L30_28 9.2525400000000012e-17
C74 0 FILL_L30_29 1.1213000000000001e-16
C75 0 FILL_L30_3 7.1410300000000006e-17
C76 0 FILL_L30_30 8.6760700000000001e-17
C77 0 FILL_L30_31 9.3849100000000001e-16
C78 0 FILL_L30_32 8.868270000000001e-16
C79 0 FILL_L30_33 6.6150499999999996e-17
C80 0 FILL_L30_34 1.81581e-16
C81 0 FILL_L30_4 7.0218100000000007e-17
C82 0 FILL_L30_5 3.9982300000000003e-17
C83 0 FILL_L30_6 1.0339900000000001e-16
C84 0 FILL_L30_7 1.2086499999999999e-16
C85 0 FILL_L30_8 8.7039100000000007e-17
C86 0 FILL_L30_9 6.0320100000000006e-17
C87 0 FILL_L50_0 1.0369600000000001e-16
C88 0 FILL_L50_1 2.0095400000000001e-16
C89 0 FILL_L50_10 2.61741e-17
C90 0 FILL_L50_12 8.3713600000000001e-17
C91 0 FILL_L50_13 4.2760400000000001e-16
C92 0 FILL_L50_14 8.2088700000000003e-18
C93 0 FILL_L50_15 2.0187900000000003e-18
C94 0 FILL_L50_17 1.3657500000000001e-16
C95 0 FILL_L50_18 2.5994500000000001e-17
C96 0 FILL_L50_19 4.4717600000000003e-17
C97 0 FILL_L50_2 1.8808e-17
C98 0 FILL_L50_20 4.0194500000000003e-17
C99 0 FILL_L50_22 1.0250600000000001e-16
C100 0 FILL_L50_23 1.1161900000000001e-16
C101 0 FILL_L50_24 7.2245099999999998e-17
C102 0 FILL_L50_25 4.37979e-16
C103 0 FILL_L50_26 1.2356100000000001e-18
C104 0 FILL_L50_27 1.7142500000000001e-18
C105 0 FILL_L50_29 1.1141400000000001e-16
C106 0 FILL_L50_3 2.5403900000000001e-17
C107 0 FILL_L50_30 5.9932299999999998e-18
C108 0 FILL_L50_31 2.49608e-17
C109 0 FILL_L50_32 2.3715200000000002e-17
C110 0 FILL_L50_34 8.98076e-17
C111 0 FILL_L50_35 1.3525100000000002e-16
C112 0 FILL_L50_36 8.4612399999999995e-17
C113 0 FILL_L50_37 4.3368800000000002e-16
C114 0 FILL_L50_38 1.0164900000000001e-17
C115 0 FILL_L50_39 2.6989900000000002e-17
C116 0 FILL_L50_4 2.4415900000000003e-17
C117 0 FILL_L50_6 1.1225800000000001e-16
C118 0 FILL_L50_7 1.5213800000000001e-16
C119 0 FILL_L50_8 9.3563300000000008e-17
C120 0 FILL_L50_9 2.1647200000000003e-17
C121 0 FILL_L8_0 1.5866400000000002e-18
C122 0 FILL_L8_1 3.2162400000000001e-17
C123 0 FILL_L8_10 3.2203800000000004e-17
C124 0 FILL_L8_12 1.6744399999999999e-17
C125 0 FILL_L8_16 3.2203800000000004e-17
C126 0 FILL_L8_17 1.8198100000000002e-17
C127 0 FILL_L8_2 1.9298500000000003e-17
C128 0 FILL_L8_6 7.2120200000000005e-19
C129 0 N 1.4377400000000001e-16
C130 0 P 2.3263500000000003e-16
C153 0 FILL_L10_0 6.1678200000000007e-18
C154 0 FILL_L10_1 1.8434200000000003e-17
C155 0 FILL_L10_11 4.634680000000001e-18
C156 0 FILL_L10_12 1.3544800000000002e-17
C157 0 FILL_L10_13 8.8272700000000009e-17
C158 0 FILL_L10_17 2.8467300000000003e-17
C159 0 FILL_L10_18 1.83019e-18
C160 0 FILL_L10_19 8.9292800000000006e-17
C161 0 FILL_L10_2 8.1900000000000009e-17
C162 0 FILL_L10_23 1.0526300000000002e-17
C163 0 FILL_L10_24 1.14551e-17
C164 0 FILL_L10_6 1.3482100000000002e-17
C165 0 FILL_L10_7 2.1257100000000004e-17
C166 0 FILL_L10_8 9.60355e-17
C167 0 FILL_L134_0 7.8572800000000001e-16
C168 0 FILL_L134_1 1.4795700000000001e-15
C169 0 FILL_L134_2 8.9898299999999992e-16
C170 0 FILL_L134_3 5.0654000000000008e-18
C171 0 FILL_L134_5 3.8472900000000002e-16
C172 0 FILL_L134_6 7.1446300000000003e-16
C173 0 FILL_L134_7 4.5017800000000002e-16
C174 0 FILL_L134_8 2.4820500000000002e-18
C175 0 FILL_L30_10 9.9316800000000014e-17
C176 0 FILL_L30_11 7.7862300000000007e-16
C177 0 FILL_L30_12 1.0712600000000002e-15
C178 0 FILL_L30_13 1.3728200000000002e-16
C179 0 FILL_L30_14 4.3073100000000002e-16
C180 0 FILL_L30_15 2.5356999999999999e-18
C181 0 FILL_L30_16 5.9086399999999997e-17
C182 0 FILL_L30_17 3.2579000000000005e-17
C183 0 FILL_L30_18 1.0766200000000002e-16
C184 0 FILL_L30_19 1.1043500000000001e-16
C185 0 FILL_L30_2 1.01975e-16
C186 0 FILL_L30_20 1.1157200000000002e-16
C187 0 FILL_L30_21 4.4822899999999997e-16
C188 0 FILL_L30_22 7.2501400000000009e-16
C189 0 FILL_L30_23 1.5964100000000001e-16
C190 0 FILL_L30_24 3.2601900000000005e-16
C191 0 FILL_L30_25 1.90189e-17
C192 0 FILL_L30_26 6.100730000000001e-17
C193 0 FILL_L30_27 4.8896200000000003e-17
C194 0 FILL_L30_28 1.9881600000000002e-18
C195 0 FILL_L30_29 8.6048900000000004e-19
C196 0 FILL_L30_3 3.7849300000000004e-17
C197 0 FILL_L30_31 7.0716800000000015e-17
C198 0 FILL_L30_32 3.2032100000000006e-16
C199 0 FILL_L30_33 3.0937500000000004e-17
C200 0 FILL_L30_34 2.4642699999999999e-16
C201 0 FILL_L30_4 2.4413799999999999e-17
C202 0 FILL_L30_5 1.0156800000000001e-16
C203 0 FILL_L30_6 2.61303e-17
C204 0 FILL_L30_7 2.7047000000000004e-17
C205 0 FILL_L30_8 2.4506500000000001e-17
C206 0 FILL_L30_9 6.1623300000000001e-17
C207 0 FILL_L50_1 2.9655700000000002e-17
C208 0 FILL_L50_10 9.4600400000000001e-17
C209 0 FILL_L50_11 3.9378600000000004e-17
C210 0 FILL_L50_12 3.0098400000000003e-17
C211 0 FILL_L50_13 1.5529900000000001e-16
C212 0 FILL_L50_14 8.136750000000001e-17
C213 0 FILL_L50_15 1.25789e-16
C214 0 FILL_L50_16 3.9621000000000002e-17
C215 0 FILL_L50_17 1.6777400000000001e-18
C216 0 FILL_L50_18 6.3081300000000007e-17
C217 0 FILL_L50_19 1.0455000000000001e-16
C218 0 FILL_L50_2 5.4311000000000006e-17
C219 0 FILL_L50_20 7.6788000000000002e-17
C220 0 FILL_L50_21 3.9435300000000002e-17
C221 0 FILL_L50_22 2.6604100000000002e-17
C222 0 FILL_L50_23 2.8120699999999999e-17
C223 0 FILL_L50_24 2.8901299999999999e-17
C224 0 FILL_L50_25 1.4130500000000001e-16
C225 0 FILL_L50_26 9.6150700000000004e-17
C226 0 FILL_L50_27 1.4198500000000003e-16
C227 0 FILL_L50_28 3.9594499999999997e-17
C228 0 FILL_L50_29 8.8484800000000009e-18
C229 0 FILL_L50_3 7.7734000000000003e-17
C230 0 FILL_L50_30 6.9126200000000007e-17
C231 0 FILL_L50_31 9.5567600000000006e-17
C232 0 FILL_L50_32 8.3890300000000001e-17
C233 0 FILL_L50_33 3.9378600000000004e-17
C234 0 FILL_L50_34 3.0252800000000001e-18
C235 0 FILL_L50_35 1.5498200000000001e-18
C236 0 FILL_L50_37 1.0542700000000002e-16
C237 0 FILL_L50_38 6.2137100000000002e-17
C238 0 FILL_L50_39 7.3827100000000013e-17
C239 0 FILL_L50_4 6.6034600000000008e-17
C240 0 FILL_L50_40 3.5401700000000002e-17
C241 0 FILL_L50_5 3.57065e-17
C242 0 FILL_L50_6 1.3025500000000001e-17
C243 0 FILL_L50_7 1.3369400000000002e-17
C244 0 FILL_L50_8 1.0782e-17
C245 0 FILL_L50_9 7.2338600000000001e-17
C246 0 FILL_L8_0 8.7206200000000003e-19
C247 0 FILL_L8_1 3.7425700000000004e-18
C248 0 FILL_L8_10 1.9168900000000001e-18
C249 0 FILL_L8_11 2.8467000000000001e-17
C250 0 FILL_L8_12 1.0940000000000001e-18
C251 0 FILL_L8_15 2.9179200000000003e-17
C252 0 FILL_L8_17 1.5335100000000001e-18
C253 0 FILL_L8_2 3.1949800000000005e-18
C254 0 FILL_L8_20 1.3208300000000001e-18
C255 0 FILL_L8_21 5.24598e-19
C256 0 FILL_L8_5 2.9235000000000002e-17
C257 0 FILL_L8_6 2.65644e-17
C258 0 FILL_L8_7 1.9269300000000003e-17
C259 0 N 8.3873299999999998e-16
C260 0 P 7.8764000000000002e-16
C263 0 FILL_L10_1 2.7473100000000005e-18
C264 0 FILL_L10_13 1.8020300000000003e-16
C265 0 FILL_L10_17 2.7473100000000005e-18
C266 0 FILL_L10_19 1.8020300000000003e-16
C267 0 FILL_L10_2 1.57034e-16
C268 0 FILL_L10_23 1.23629e-18
C269 0 FILL_L10_24 2.3168900000000003e-17
C270 0 FILL_L10_7 1.3736600000000001e-18
C271 0 FILL_L10_8 1.8020300000000003e-16
C272 0 FILL_L134_2 1.5083900000000001e-16
C273 0 FILL_L134_3 1.7035900000000001e-15
C274 0 FILL_L134_4 1.1000900000000001e-15
C275 0 FILL_L134_7 7.3496000000000004e-17
C276 0 FILL_L134_8 8.542600000000001e-16
C277 0 FILL_L134_9 5.5053999999999997e-16
C278 0 FILL_L30_14 1.9581700000000004e-17
C279 0 FILL_L30_24 1.97195e-17
C280 0 FILL_L30_34 1.9581700000000004e-17
C281 0 FILL_L30_5 6.303270000000001e-18
C282 0 FILL_L50_11 1.2528500000000001e-17
C283 0 FILL_L50_16 1.2528500000000001e-17
C284 0 FILL_L50_21 1.2528500000000001e-17
C285 0 FILL_L50_28 1.2528500000000001e-17
C286 0 FILL_L50_33 1.2528500000000001e-17
C287 0 FILL_L50_40 1.2528500000000001e-17
C288 0 FILL_L50_5 1.2528500000000001e-17
C289 0 N 8.3815500000000008e-17
C292 0 FILL_L10_1 5.0554500000000001e-19
C293 0 FILL_L10_10 1.2231900000000001e-15
C294 0 FILL_L10_13 3.6673499999999998e-17
C295 0 FILL_L10_14 1.1146500000000001e-15
C296 0 FILL_L10_15 1.2117000000000001e-15
C297 0 FILL_L10_16 3.0063400000000004e-16
C298 0 FILL_L10_17 5.0554500000000001e-19
C299 0 FILL_L10_19 3.6673499999999998e-17
C300 0 FILL_L10_2 3.1958400000000004e-17
C301 0 FILL_L10_20 1.1146500000000001e-15
C302 0 FILL_L10_21 1.2117000000000001e-15
C303 0 FILL_L10_22 2.9475300000000001e-16
C304 0 FILL_L10_23 2.2749500000000003e-19
C305 0 FILL_L10_24 4.7151700000000002e-18
C306 0 FILL_L10_25 2.1540500000000002e-16
C307 0 FILL_L10_26 2.27882e-16
C308 0 FILL_L10_27 5.1903400000000001e-17
C309 0 FILL_L10_3 8.9924500000000008e-16
C310 0 FILL_L10_4 9.8381500000000019e-16
C311 0 FILL_L10_5 2.4873100000000002e-16
C312 0 FILL_L10_7 2.5277200000000001e-19
C313 0 FILL_L10_8 3.6673499999999998e-17
C314 0 FILL_L10_9 1.1146500000000001e-15
C315 0 FILL_L134_2 2.3010800000000001e-17
C316 0 FILL_L134_3 2.7361e-18
C317 0 FILL_L134_7 1.07571e-17
C318 0 FILL_L134_8 1.34069e-18
C319 0 FILL_L30_14 3.0417000000000001e-17
C320 0 FILL_L30_24 3.0417000000000001e-17
C321 0 FILL_L30_34 3.0417000000000001e-17
C322 0 FILL_L30_5 1.17866e-17
C323 0 FILL_L8_13 8.4538700000000014e-17
C324 0 FILL_L8_14 1.12718e-16
C325 0 FILL_L8_18 8.4538700000000014e-17
C326 0 FILL_L8_19 1.12718e-16
C327 0 FILL_L8_22 3.1802700000000001e-17
C328 0 FILL_L8_23 3.5425700000000001e-17
C329 0 FILL_L8_3 5.2736e-17
C330 0 FILL_L8_4 7.7292500000000013e-17
C331 0 FILL_L8_8 8.4538700000000014e-17
C332 0 FILL_L8_9 1.2122100000000002e-16
C337 0 FILL_L30_6 2.0548800000000002e-19
C338 0 FILL_L50_6 2.2128100000000001e-19
C342 0 FILL_L30_2 8.4140300000000008e-18
C345 0 FILL_L30_2 8.8587399999999994e-18
C348 0 FILL_L30_2 1.7349900000000003e-18
C349 0 P 5.6114100000000006e-19
C352 0 FILL_L30_2 8.2750800000000007e-19
C353 0 FILL_L30_3 3.2582399999999999e-18
C354 0 FILL_L30_5 1.5464400000000002e-19
C355 0 FILL_L50_3 9.8699499999999996e-19
C356 0 N 1.6050300000000001e-19
C357 0 P 4.5286400000000006e-19
C360 0 FILL_L30_2 2.2736900000000001e-19
C361 0 FILL_L30_5 2.7168000000000001e-19
C362 0 N 2.2961500000000001e-19
C363 0 P 1.7312e-19
C366 0 FILL_L10_0 1.4973200000000001e-19
C367 0 FILL_L30_2 1.68039e-19
C368 0 FILL_L30_4 3.2582399999999999e-18
C369 0 FILL_L30_5 7.3069500000000002e-19
C370 0 FILL_L50_4 9.8699499999999996e-19
C371 0 N 5.0207500000000008e-19
C372 0 P 1.4770400000000001e-19
C374 0 FILL_L10_0 6.5473000000000006e-19
C375 0 FILL_L30_5 4.6548600000000008e-18
C376 0 FILL_L8_0 7.31678e-18
C377 0 N 7.2933000000000013e-19
C380 0 FILL_L30_1 1.2877800000000002e-19
C381 0 FILL_L50_1 1.7483699999999999e-19
C384 0 FILL_L30_28 4.0891200000000001e-19
C387 0 FILL_L30_28 1.8630700000000001e-18
C388 0 FILL_L50_34 4.1954900000000002e-19
C391 0 FILL_L30_29 2.6666400000000002e-18
C392 0 FILL_L50_35 6.8176700000000003e-19
C395 0 FILL_L30_29 4.0927200000000005e-19
C396 0 FILL_L30_30 1.2195400000000003e-19
C397 0 FILL_L50_35 1.1189600000000001e-19
C400 0 FILL_L30_30 3.2502100000000004e-18
C401 0 FILL_L50_36 8.7405999999999992e-19
C404 0 FILL_L30_30 2.8877300000000004e-19
C405 0 FILL_L30_31 1.4205300000000003e-19
C406 0 FILL_L50_36 1.08502e-19
C407 0 FILL_L50_37 1.0083300000000001e-19
C410 0 FILL_L30_31 4.2550200000000003e-18
C411 0 FILL_L50_37 8.7405999999999992e-19
C412 0 P 1.0868000000000001e-19
C415 0 FILL_L134_5 7.1890600000000014e-19
C416 0 FILL_L30_31 4.8612500000000002e-18
C417 0 FILL_L50_37 1.0139100000000002e-18
C418 0 P 1.7149100000000002e-19
C421 0 FILL_L30_1 2.2919600000000003e-19
C422 0 FILL_L50_1 2.8525600000000004e-19
C425 0 FILL_L134_5 1.1182000000000001e-18
C426 0 FILL_L30_31 2.8536700000000002e-19
C427 0 P 4.0091100000000004e-19
C430 0 FILL_L134_5 1.09408e-18
C431 0 FILL_L30_31 1.3019300000000001e-19
C432 0 FILL_L30_32 1.7875100000000001e-19
C433 0 P 6.6839600000000007e-19
C436 0 FILL_L30_32 4.2550200000000003e-18
C437 0 P 1.02605e-18
C440 0 FILL_L30_32 4.8612500000000002e-18
C441 0 P 1.1620200000000001e-18
C444 0 FILL_L30_32 1.4083900000000001e-19
C445 0 P 5.7389400000000003e-19
C448 0 FILL_L30_26 5.9677700000000003e-19
C449 0 FILL_L50_31 6.3012800000000003e-19
C450 0 N 1.36547e-19
C451 0 P 4.6315600000000007e-19
C454 0 FILL_L30_33 2.5160300000000005e-19
C455 0 N 3.0843800000000002e-19
C456 0 P 1.4728100000000001e-19
C459 0 FILL_L10_23 1.27384e-19
C460 0 FILL_L30_33 3.7353800000000007e-18
C461 0 FILL_L50_39 1.0139100000000002e-18
C462 0 N 5.13486e-19
C463 0 P 1.25658e-19
C465 0 FILL_L10_23 6.6961100000000001e-19
C466 0 FILL_L30_33 1.06289e-19
C467 0 FILL_L30_34 8.0335000000000004e-19
C468 0 FILL_L8_20 7.4830700000000007e-18
C469 0 N 9.7709200000000004e-19
C472 0 FILL_L30_0 2.80883e-18
C473 0 FILL_L30_1 5.9752300000000004e-19
C474 0 FILL_L50_0 8.5085800000000003e-19
C475 0 FILL_L50_1 5.6712200000000009e-19
C478 0 FILL_L30_1 1.5470900000000001e-18
C479 0 FILL_L50_1 8.87327e-19
C482 0 FILL_L30_1 8.0358300000000008e-18
C485 0 FILL_L30_1 9.1875099999999996e-18
C488 0 FILL_L134_0 4.8356100000000004e-19
C489 0 FILL_L30_1 3.1957100000000004e-18
C490 0 FILL_L30_2 8.3217500000000006e-19
C491 0 FILL_L50_1 8.5726599999999999e-19
C492 0 P 2.98456e-19
C494 0 FILL_L134_0 5.6093000000000012e-19
C495 0 FILL_L30_1 1.1457e-18
C496 0 FILL_L30_2 2.28238e-18
C497 0 FILL_L50_1 8.5353500000000008e-19
C498 0 P 6.5354300000000003e-19
C500 FILL_L10_0 FILL_L10_1 2.7935199999999999e-17
C501 FILL_L10_0 FILL_L10_2 1.5364400000000001e-17
C502 FILL_L10_0 FILL_L30_5 9.0728200000000013e-17
C503 FILL_L10_0 FILL_L8_0 3.6973700000000005e-17
C504 FILL_L10_0 0 7.1332200000000003e-17
C505 FILL_L10_1 FILL_L10_2 2.7935199999999999e-17
C506 FILL_L10_1 FILL_L10_6 2.7935199999999999e-17
C507 FILL_L10_1 FILL_L134_2 5.6712800000000005e-19
C508 FILL_L10_1 FILL_L30_14 3.0330600000000001e-17
C509 FILL_L10_1 FILL_L30_5 3.0330600000000001e-17
C510 FILL_L10_1 FILL_L8_1 6.7224999999999998e-17
C511 FILL_L10_1 N 1.3071400000000001e-17
C512 FILL_L10_1 0 5.716940000000001e-17
C513 FILL_L10_10 FILL_L10_15 9.7773300000000019e-17
C514 FILL_L10_10 FILL_L10_4 9.7773300000000019e-17
C515 FILL_L10_10 FILL_L10_9 9.7773300000000019e-17
C516 FILL_L10_10 FILL_L8_9 8.2350600000000007e-16
C517 FILL_L10_10 0 2.6896499999999997e-16
C518 FILL_L10_11 FILL_L10_12 2.7935199999999999e-17
C519 FILL_L10_11 FILL_L10_13 2.7935199999999999e-17
C520 FILL_L10_11 FILL_L10_7 2.7935199999999999e-17
C521 FILL_L10_11 FILL_L30_17 2.0490200000000002e-19
C522 FILL_L10_11 FILL_L30_24 1.4895200000000002e-16
C523 FILL_L10_11 FILL_L8_10 6.7224999999999998e-17
C524 FILL_L10_11 0 5.6532300000000008e-17
C525 FILL_L10_12 FILL_L10_13 2.7935199999999999e-17
C526 FILL_L10_12 FILL_L10_17 2.7935199999999999e-17
C527 FILL_L10_12 FILL_L30_23 4.6672000000000005e-19
C528 FILL_L10_12 FILL_L30_24 1.6518700000000003e-16
C529 FILL_L10_12 FILL_L8_11 6.7224999999999998e-17
C530 FILL_L10_12 0 6.9430800000000005e-17
C531 FILL_L10_13 FILL_L10_14 9.7773300000000019e-17
C532 FILL_L10_13 FILL_L10_19 9.7773300000000019e-17
C533 FILL_L10_13 FILL_L10_8 9.7773300000000019e-17
C534 FILL_L10_13 FILL_L134_2 4.9430900000000007e-17
C535 FILL_L10_13 FILL_L134_3 2.0406000000000001e-17
C536 FILL_L10_13 FILL_L134_7 7.8823400000000005e-18
C537 FILL_L10_13 FILL_L30_24 2.6709500000000005e-16
C538 FILL_L10_13 FILL_L50_21 2.8287299999999999e-17
C539 FILL_L10_13 FILL_L50_28 1.4143599999999999e-17
C540 FILL_L10_13 FILL_L8_12 8.2350600000000007e-16
C541 FILL_L10_13 N 1.88906e-17
C542 FILL_L10_13 0 2.2268e-16
C543 FILL_L10_14 FILL_L10_15 9.7773300000000019e-17
C544 FILL_L10_14 FILL_L10_20 9.7773300000000019e-17
C545 FILL_L10_14 FILL_L10_9 9.7773300000000019e-17
C546 FILL_L10_14 FILL_L134_3 4.9389e-19
C547 FILL_L10_14 FILL_L8_13 8.2350600000000007e-16
C548 FILL_L10_14 0 1.9621900000000002e-16
C549 FILL_L10_15 FILL_L10_16 9.7773300000000019e-17
C550 FILL_L10_15 FILL_L10_21 9.7773300000000019e-17
C551 FILL_L10_15 FILL_L8_14 8.2350600000000007e-16
C552 FILL_L10_15 0 1.9621900000000002e-16
C553 FILL_L10_16 FILL_L10_22 1.8996e-17
C554 FILL_L10_16 FILL_L10_5 4.3091200000000007e-18
C555 FILL_L10_16 FILL_L8_14 9.6773699999999998e-18
C556 FILL_L10_16 0 2.4599000000000003e-16
C557 FILL_L10_17 FILL_L10_18 2.7935199999999999e-17
C558 FILL_L10_17 FILL_L10_19 2.7935199999999999e-17
C559 FILL_L10_17 FILL_L134_7 2.5520799999999999e-19
C560 FILL_L10_17 FILL_L30_24 1.3974200000000001e-17
C561 FILL_L10_17 FILL_L30_34 5.8939399999999999e-17
C562 FILL_L10_17 FILL_L8_15 6.7224999999999998e-17
C563 FILL_L10_17 N 1.3009400000000001e-17
C564 FILL_L10_17 0 6.9640000000000008e-17
C565 FILL_L10_18 FILL_L10_19 2.7935199999999999e-17
C566 FILL_L10_18 FILL_L10_23 2.7935199999999999e-17
C567 FILL_L10_18 FILL_L30_34 1.7668000000000002e-16
C568 FILL_L10_18 FILL_L8_16 6.7224999999999998e-17
C569 FILL_L10_18 0 5.6504000000000001e-17
C570 FILL_L10_19 FILL_L10_20 9.7773300000000019e-17
C571 FILL_L10_19 FILL_L10_24 9.7773300000000019e-17
C572 FILL_L10_19 FILL_L134_2 4.3026400000000002e-18
C573 FILL_L10_19 FILL_L134_7 5.2878200000000006e-17
C574 FILL_L10_19 FILL_L134_8 2.4079100000000003e-17
C575 FILL_L10_19 FILL_L30_27 4.2984000000000004e-19
C576 FILL_L10_19 FILL_L30_34 1.9374100000000004e-16
C577 FILL_L10_19 FILL_L50_33 2.8287299999999999e-17
C578 FILL_L10_19 FILL_L8_17 8.2350600000000007e-16
C579 FILL_L10_19 N 2.3613300000000001e-17
C580 FILL_L10_19 0 2.22729e-16
C581 FILL_L10_2 FILL_L10_3 8.5202500000000002e-17
C582 FILL_L10_2 FILL_L10_8 9.7773300000000019e-17
C583 FILL_L10_2 FILL_L134_2 3.5255400000000001e-17
C584 FILL_L10_2 FILL_L134_3 8.1623900000000008e-18
C585 FILL_L10_2 FILL_L30_4 4.3420400000000004e-19
C586 FILL_L10_2 FILL_L30_5 1.20603e-16
C587 FILL_L10_2 FILL_L50_5 2.8287299999999999e-17
C588 FILL_L10_2 FILL_L8_2 7.1762700000000003e-16
C589 FILL_L10_2 N 1.9634600000000002e-17
C590 FILL_L10_2 0 2.8251900000000004e-16
C591 FILL_L10_20 FILL_L10_21 9.7773300000000019e-17
C592 FILL_L10_20 FILL_L10_25 9.7773300000000019e-17
C593 FILL_L10_20 FILL_L134_8 3.9511200000000004e-19
C594 FILL_L10_20 FILL_L8_18 8.2350600000000007e-16
C595 FILL_L10_20 0 1.9621900000000002e-16
C596 FILL_L10_21 FILL_L10_22 9.7773300000000019e-17
C597 FILL_L10_21 FILL_L10_26 9.7773300000000019e-17
C598 FILL_L10_21 FILL_L8_19 8.2350600000000007e-16
C599 FILL_L10_21 0 1.9621900000000002e-16
C600 FILL_L10_22 FILL_L10_27 1.8996e-17
C601 FILL_L10_22 FILL_L8_19 9.6773699999999998e-18
C602 FILL_L10_22 0 2.3317799999999999e-16
C603 FILL_L10_23 FILL_L10_24 1.2570900000000001e-17
C604 FILL_L10_23 FILL_L134_7 2.5520799999999999e-19
C605 FILL_L10_23 FILL_L30_34 4.5963200000000002e-17
C606 FILL_L10_23 FILL_L8_20 3.0251200000000004e-17
C607 FILL_L10_23 N 5.8821100000000002e-18
C608 FILL_L10_23 0 6.7443799999999999e-17
C609 FILL_L10_24 FILL_L10_25 1.2570900000000001e-17
C610 FILL_L10_24 FILL_L134_7 9.6964400000000008e-18
C611 FILL_L10_24 FILL_L134_8 3.5853600000000005e-18
C612 FILL_L10_24 FILL_L8_21 1.0587900000000001e-16
C613 FILL_L10_24 N 4.2503900000000004e-18
C614 FILL_L10_24 0 1.8346200000000001e-16
C615 FILL_L10_25 FILL_L10_26 1.2570900000000001e-17
C616 FILL_L10_25 FILL_L8_22 1.0587900000000001e-16
C617 FILL_L10_25 0 1.8346200000000001e-16
C618 FILL_L10_26 FILL_L10_27 1.2570900000000001e-17
C619 FILL_L10_26 FILL_L8_23 1.0587900000000001e-16
C620 FILL_L10_26 0 1.8346200000000001e-16
C621 FILL_L10_27 FILL_L8_23 1.2442300000000001e-18
C622 FILL_L10_27 0 6.0722499999999997e-17
C623 FILL_L10_3 FILL_L10_4 8.5202500000000002e-17
C624 FILL_L10_3 FILL_L10_9 9.7773300000000019e-17
C625 FILL_L10_3 FILL_L134_3 1.9755600000000002e-19
C626 FILL_L10_3 FILL_L8_3 7.1762700000000003e-16
C627 FILL_L10_3 0 2.5634300000000004e-16
C628 FILL_L10_4 FILL_L10_5 8.5202500000000002e-17
C629 FILL_L10_4 FILL_L8_4 7.1762700000000003e-16
C630 FILL_L10_4 0 2.5634300000000004e-16
C631 FILL_L10_5 FILL_L8_4 8.433130000000001e-18
C632 FILL_L10_5 0 2.3259200000000003e-16
C633 FILL_L10_6 FILL_L10_7 2.7935199999999999e-17
C634 FILL_L10_6 FILL_L10_8 2.7935199999999999e-17
C635 FILL_L10_6 FILL_L30_14 1.7366200000000003e-16
C636 FILL_L10_6 FILL_L8_5 6.7224999999999998e-17
C637 FILL_L10_6 0 6.9434500000000004e-17
C638 FILL_L10_7 FILL_L10_8 2.7935199999999999e-17
C639 FILL_L10_7 FILL_L134_2 2.8356400000000003e-19
C640 FILL_L10_7 FILL_L30_13 5.2363700000000009e-19
C641 FILL_L10_7 FILL_L30_14 1.08904e-16
C642 FILL_L10_7 FILL_L30_24 3.4949400000000003e-18
C643 FILL_L10_7 FILL_L8_6 6.7224999999999998e-17
C644 FILL_L10_7 N 6.4582100000000006e-18
C645 FILL_L10_7 0 6.9819800000000005e-17
C646 FILL_L10_8 FILL_L10_9 9.7773300000000019e-17
C647 FILL_L10_8 FILL_L134_2 5.9433600000000004e-17
C648 FILL_L10_8 FILL_L134_3 2.85684e-17
C649 FILL_L10_8 FILL_L30_13 1.5273500000000002e-19
C650 FILL_L10_8 FILL_L30_14 2.3018900000000003e-16
C651 FILL_L10_8 FILL_L50_16 2.8287299999999999e-17
C652 FILL_L10_8 FILL_L8_7 8.2350600000000007e-16
C653 FILL_L10_8 N 2.3613300000000001e-17
C654 FILL_L10_8 0 2.1760100000000002e-16
C655 FILL_L10_9 FILL_L134_3 3.9511200000000004e-19
C656 FILL_L10_9 FILL_L8_8 8.2350600000000007e-16
C657 FILL_L10_9 0 1.9621900000000002e-16
C658 FILL_L134_0 FILL_L134_1 4.5988900000000005e-16
C659 FILL_L134_0 FILL_L134_5 2.2994400000000001e-16
C660 FILL_L134_0 FILL_L30_1 2.7083400000000006e-18
C661 FILL_L134_0 FILL_L30_11 1.7161900000000001e-17
C662 FILL_L134_0 FILL_L30_12 2.0612400000000003e-17
C663 FILL_L134_0 FILL_L30_2 4.0172700000000002e-18
C664 FILL_L134_0 FILL_L30_21 1.0318600000000001e-17
C665 FILL_L134_0 FILL_L30_22 1.5854100000000003e-17
C666 FILL_L134_0 FILL_L50_1 1.4539500000000002e-17
C667 FILL_L134_0 FILL_L50_13 8.1067100000000008e-17
C668 FILL_L134_0 FILL_L50_25 6.0883099999999999e-17
C669 FILL_L134_0 P 4.6075600000000005e-17
C670 FILL_L134_0 0 1.94326e-16
C671 FILL_L134_1 FILL_L134_2 4.5988900000000005e-16
C672 FILL_L134_1 FILL_L134_6 2.2994400000000001e-16
C673 FILL_L134_1 0 1.1287699999999999e-16
C674 FILL_L134_2 FILL_L134_3 4.5988900000000005e-16
C675 FILL_L134_2 FILL_L134_7 2.2994400000000001e-16
C676 FILL_L134_2 FILL_L30_14 1.7704800000000002e-17
C677 FILL_L134_2 FILL_L30_24 1.3048700000000001e-17
C678 FILL_L134_2 FILL_L30_5 2.7262100000000003e-18
C679 FILL_L134_2 FILL_L50_11 9.8568900000000006e-18
C680 FILL_L134_2 FILL_L50_16 1.0359400000000002e-17
C681 FILL_L134_2 FILL_L50_21 9.8568900000000006e-18
C682 FILL_L134_2 FILL_L50_28 4.6295599999999999e-18
C683 FILL_L134_2 FILL_L50_5 4.6295599999999999e-18
C684 FILL_L134_2 FILL_L8_1 3.4623000000000003e-19
C685 FILL_L134_2 FILL_L8_12 1.5734e-18
C686 FILL_L134_2 FILL_L8_2 1.7269000000000002e-18
C687 FILL_L134_2 FILL_L8_6 1.7311500000000001e-19
C688 FILL_L134_2 FILL_L8_7 3.2636700000000002e-18
C689 FILL_L134_2 N 2.5909500000000002e-17
C690 FILL_L134_2 0 2.2793700000000001e-16
C691 FILL_L134_3 FILL_L134_4 4.5988900000000005e-16
C692 FILL_L134_3 FILL_L134_8 2.2994400000000001e-16
C693 FILL_L134_3 FILL_L30_14 9.0245300000000004e-19
C694 FILL_L134_3 FILL_L30_24 5.6403300000000001e-19
C695 FILL_L134_3 FILL_L50_11 2.7979399999999999e-19
C696 FILL_L134_3 FILL_L50_16 2.7979399999999999e-19
C697 FILL_L134_3 FILL_L50_21 2.7979399999999999e-19
C698 FILL_L134_3 FILL_L8_12 2.9770400000000003e-19
C699 FILL_L134_3 FILL_L8_13 3.0091000000000005e-19
C700 FILL_L134_3 FILL_L8_2 1.1908200000000001e-19
C701 FILL_L134_3 FILL_L8_3 1.20364e-19
C702 FILL_L134_3 FILL_L8_7 4.1678600000000002e-19
C703 FILL_L134_3 FILL_L8_8 2.40728e-19
C704 FILL_L134_3 N 1.49447e-18
C705 FILL_L134_3 0 2.0009100000000003e-16
C706 FILL_L134_4 FILL_L134_9 1.3014900000000001e-16
C707 FILL_L134_4 0 3.7563900000000006e-16
C708 FILL_L134_5 FILL_L134_6 2.2534500000000002e-16
C709 FILL_L134_5 FILL_L30_21 8.025090000000001e-19
C710 FILL_L134_5 FILL_L30_22 3.19562e-18
C711 FILL_L134_5 FILL_L30_31 1.2414e-17
C712 FILL_L134_5 FILL_L30_32 1.91112e-17
C713 FILL_L134_5 FILL_L50_25 1.1263400000000001e-17
C714 FILL_L134_5 FILL_L50_37 7.4751400000000013e-17
C715 FILL_L134_5 P 2.1008700000000001e-17
C716 FILL_L134_5 0 1.9882500000000001e-16
C717 FILL_L134_6 FILL_L134_7 2.2534500000000002e-16
C718 FILL_L134_6 0 1.5587500000000002e-16
C719 FILL_L134_7 FILL_L134_8 2.2534500000000002e-16
C720 FILL_L134_7 FILL_L30_24 1.7052000000000002e-18
C721 FILL_L134_7 FILL_L30_34 1.56673e-17
C722 FILL_L134_7 FILL_L50_28 3.43931e-18
C723 FILL_L134_7 FILL_L50_33 8.7765500000000013e-18
C724 FILL_L134_7 FILL_L50_40 8.7765500000000013e-18
C725 FILL_L134_7 FILL_L8_15 1.55803e-19
C726 FILL_L134_7 FILL_L8_17 1.6867800000000001e-18
C727 FILL_L134_7 FILL_L8_20 1.55803e-19
C728 FILL_L134_7 FILL_L8_21 1.5734e-18
C729 FILL_L134_7 N 1.0733900000000001e-17
C730 FILL_L134_7 0 2.1812000000000003e-16
C731 FILL_L134_8 FILL_L134_9 2.2534500000000002e-16
C732 FILL_L134_8 FILL_L30_34 9.0245300000000004e-19
C733 FILL_L134_8 FILL_L50_33 2.7979399999999999e-19
C734 FILL_L134_8 FILL_L50_40 2.7979399999999999e-19
C735 FILL_L134_8 FILL_L8_17 3.5129100000000002e-19
C736 FILL_L134_8 FILL_L8_18 2.40728e-19
C737 FILL_L134_8 N 4.2699200000000003e-19
C738 FILL_L134_8 0 1.9928000000000001e-16
C739 FILL_L134_9 0 2.4098300000000002e-16
C740 FILL_L30_0 FILL_L30_1 1.92731e-17
C741 FILL_L30_0 FILL_L30_8 1.92731e-17
C742 FILL_L30_0 FILL_L50_0 6.7224999999999998e-17
C743 FILL_L30_0 0 7.1215600000000005e-17
C744 FILL_L30_1 FILL_L30_11 7.7092600000000011e-17
C745 FILL_L30_1 FILL_L30_2 2.9873400000000003e-17
C746 FILL_L30_1 FILL_L50_1 4.1679500000000005e-16
C747 FILL_L30_1 0 2.22795e-16
C748 FILL_L30_10 FILL_L30_11 1.92731e-17
C749 FILL_L30_10 FILL_L30_15 1.92731e-17
C750 FILL_L30_10 FILL_L30_8 1.92731e-17
C751 FILL_L30_10 FILL_L50_12 6.7224999999999998e-17
C752 FILL_L30_10 0 4.8989300000000005e-17
C753 FILL_L30_11 FILL_L30_12 7.7092600000000011e-17
C754 FILL_L30_11 FILL_L30_21 7.7092600000000011e-17
C755 FILL_L30_11 FILL_L30_8 1.92731e-17
C756 FILL_L30_11 FILL_L50_13 1.0756e-15
C757 FILL_L30_11 0 2.1995e-16
C758 FILL_L30_12 FILL_L30_13 7.3000700000000009e-18
C759 FILL_L30_12 FILL_L30_14 5.8732800000000007e-18
C760 FILL_L30_12 FILL_L30_2 7.7092600000000011e-17
C761 FILL_L30_12 FILL_L30_22 7.7092600000000011e-17
C762 FILL_L30_12 FILL_L30_9 7.6042400000000005e-18
C763 FILL_L30_12 FILL_L50_13 2.3410700000000001e-17
C764 FILL_L30_12 FILL_L50_14 1.3417300000000002e-16
C765 FILL_L30_12 FILL_L50_9 1.3417300000000002e-16
C766 FILL_L30_12 P 3.6174800000000003e-16
C767 FILL_L30_12 0 2.2069000000000002e-16
C768 FILL_L30_13 FILL_L30_14 1.92731e-17
C769 FILL_L30_13 FILL_L30_17 1.92731e-17
C770 FILL_L30_13 FILL_L30_9 1.92731e-17
C771 FILL_L30_13 FILL_L50_15 6.7224999999999998e-17
C772 FILL_L30_13 0 4.4506200000000001e-17
C773 FILL_L30_14 FILL_L30_24 7.7092600000000011e-17
C774 FILL_L30_14 FILL_L30_5 7.7092600000000011e-17
C775 FILL_L30_14 FILL_L30_9 1.92731e-17
C776 FILL_L30_14 FILL_L50_10 4.0405400000000007e-18
C777 FILL_L30_14 FILL_L50_11 1.46759e-16
C778 FILL_L30_14 FILL_L50_15 4.0405400000000007e-18
C779 FILL_L30_14 FILL_L50_16 1.46759e-16
C780 FILL_L30_14 FILL_L8_1 5.0346600000000001e-18
C781 FILL_L30_14 FILL_L8_5 2.9793800000000006e-17
C782 FILL_L30_14 FILL_L8_6 1.60615e-17
C783 FILL_L30_14 FILL_L8_7 3.3134700000000006e-17
C784 FILL_L30_14 N 3.6272300000000006e-16
C785 FILL_L30_14 0 3.4035300000000005e-16
C786 FILL_L30_15 FILL_L30_20 1.92731e-17
C787 FILL_L30_15 FILL_L30_21 1.92731e-17
C788 FILL_L30_15 FILL_L50_17 6.7224999999999998e-17
C789 FILL_L30_15 0 2.6436400000000002e-17
C790 FILL_L30_16 FILL_L30_17 1.92731e-17
C791 FILL_L30_16 FILL_L30_22 1.92731e-17
C792 FILL_L30_16 FILL_L30_26 7.6042400000000005e-18
C793 FILL_L30_16 FILL_L30_3 4.7365199999999997e-18
C794 FILL_L30_16 FILL_L50_19 6.7224999999999998e-17
C795 FILL_L30_16 0 3.7430900000000003e-17
C796 FILL_L30_17 FILL_L30_23 1.92731e-17
C797 FILL_L30_17 FILL_L30_24 1.92731e-17
C798 FILL_L30_17 FILL_L50_20 6.7224999999999998e-17
C799 FILL_L30_17 0 2.4295200000000003e-17
C800 FILL_L30_18 FILL_L30_19 1.92731e-17
C801 FILL_L30_18 FILL_L30_28 7.6042400000000005e-18
C802 FILL_L30_18 FILL_L30_6 4.7365199999999997e-18
C803 FILL_L30_18 FILL_L50_22 6.7224999999999998e-17
C804 FILL_L30_18 0 6.8401700000000014e-17
C805 FILL_L30_19 FILL_L30_20 1.92731e-17
C806 FILL_L30_19 FILL_L30_29 5.1708800000000005e-18
C807 FILL_L30_19 FILL_L30_7 3.2208300000000002e-18
C808 FILL_L30_19 FILL_L50_23 6.7224999999999998e-17
C809 FILL_L30_19 0 4.6188000000000007e-17
C810 FILL_L30_2 FILL_L30_3 1.92731e-17
C811 FILL_L30_2 FILL_L30_5 2.6050800000000002e-18
C812 FILL_L30_2 FILL_L50_1 9.0537100000000011e-18
C813 FILL_L30_2 FILL_L50_2 1.14801e-16
C814 FILL_L30_2 P 1.3876200000000002e-16
C815 FILL_L30_2 0 2.1537000000000001e-16
C816 FILL_L30_20 FILL_L30_21 1.92731e-17
C817 FILL_L30_20 FILL_L30_25 1.92731e-17
C818 FILL_L30_20 FILL_L50_24 6.7224999999999998e-17
C819 FILL_L30_20 0 3.2849200000000009e-17
C820 FILL_L30_21 FILL_L30_22 7.7092600000000011e-17
C821 FILL_L30_21 FILL_L30_31 7.7092600000000011e-17
C822 FILL_L30_21 FILL_L50_25 1.0756e-15
C823 FILL_L30_21 0 2.2008300000000002e-16
C824 FILL_L30_22 FILL_L30_23 6.0833899999999998e-18
C825 FILL_L30_22 FILL_L30_24 9.4730399999999993e-18
C826 FILL_L30_22 FILL_L30_32 7.7092600000000011e-17
C827 FILL_L30_22 FILL_L50_18 1.3417300000000002e-16
C828 FILL_L30_22 FILL_L50_25 2.3410700000000001e-17
C829 FILL_L30_22 FILL_L50_26 1.3417300000000002e-16
C830 FILL_L30_22 P 3.6174800000000003e-16
C831 FILL_L30_22 0 2.1205600000000002e-16
C832 FILL_L30_23 FILL_L30_24 1.92731e-17
C833 FILL_L30_23 FILL_L30_27 1.92731e-17
C834 FILL_L30_23 FILL_L50_27 6.7224999999999998e-17
C835 FILL_L30_23 0 3.8601700000000003e-17
C836 FILL_L30_24 FILL_L30_34 7.7092600000000011e-17
C837 FILL_L30_24 FILL_L50_20 3.9597300000000006e-18
C838 FILL_L30_24 FILL_L50_21 1.46759e-16
C839 FILL_L30_24 FILL_L50_27 3.9597300000000006e-18
C840 FILL_L30_24 FILL_L50_28 1.46759e-16
C841 FILL_L30_24 FILL_L8_10 2.3244399999999999e-17
C842 FILL_L30_24 FILL_L8_11 2.7078900000000002e-17
C843 FILL_L30_24 FILL_L8_12 3.7323700000000007e-17
C844 FILL_L30_24 FILL_L8_15 2.30082e-18
C845 FILL_L30_24 N 3.6272300000000006e-16
C846 FILL_L30_24 0 3.3233100000000004e-16
C847 FILL_L30_25 FILL_L30_30 1.92731e-17
C848 FILL_L30_25 FILL_L30_31 1.92731e-17
C849 FILL_L30_25 FILL_L50_29 6.7224999999999998e-17
C850 FILL_L30_25 0 4.6934300000000001e-17
C851 FILL_L30_26 FILL_L30_27 1.92731e-17
C852 FILL_L30_26 FILL_L30_32 1.92731e-17
C853 FILL_L30_26 FILL_L50_31 6.7224999999999998e-17
C854 FILL_L30_26 0 6.0225200000000008e-17
C855 FILL_L30_27 FILL_L30_33 1.92731e-17
C856 FILL_L30_27 FILL_L30_34 1.92731e-17
C857 FILL_L30_27 FILL_L50_32 6.7224999999999998e-17
C858 FILL_L30_27 0 3.4408200000000005e-17
C859 FILL_L30_28 FILL_L30_29 1.92731e-17
C860 FILL_L30_28 FILL_L50_34 6.7224999999999998e-17
C861 FILL_L30_28 0 8.5716399999999998e-17
C862 FILL_L30_29 FILL_L30_30 1.92731e-17
C863 FILL_L30_29 FILL_L50_35 6.7224999999999998e-17
C864 FILL_L30_29 0 6.2295900000000008e-17
C865 FILL_L30_3 FILL_L30_4 1.92731e-17
C866 FILL_L30_3 FILL_L50_3 6.7224999999999998e-17
C867 FILL_L30_3 0 7.0611000000000007e-17
C868 FILL_L30_30 FILL_L30_31 1.92731e-17
C869 FILL_L30_30 FILL_L50_36 6.7224999999999998e-17
C870 FILL_L30_30 0 5.9774700000000012e-17
C871 FILL_L30_31 FILL_L30_32 7.7092600000000011e-17
C872 FILL_L30_31 FILL_L50_37 1.0756e-15
C873 FILL_L30_31 0 3.0747400000000001e-16
C874 FILL_L30_32 FILL_L30_33 7.6042400000000005e-18
C875 FILL_L30_32 FILL_L30_34 9.4730399999999993e-18
C876 FILL_L30_32 FILL_L50_30 1.3417300000000002e-16
C877 FILL_L30_32 FILL_L50_37 2.3322800000000004e-17
C878 FILL_L30_32 FILL_L50_38 1.3417300000000002e-16
C879 FILL_L30_32 P 3.5811600000000002e-16
C880 FILL_L30_32 0 3.02834e-16
C881 FILL_L30_33 FILL_L30_34 1.92731e-17
C882 FILL_L30_33 FILL_L50_39 6.7224999999999998e-17
C883 FILL_L30_33 0 6.8199100000000006e-17
C884 FILL_L30_34 FILL_L50_32 4.0001400000000005e-18
C885 FILL_L30_34 FILL_L50_33 1.46759e-16
C886 FILL_L30_34 FILL_L50_39 4.0405400000000007e-18
C887 FILL_L30_34 FILL_L50_40 1.46759e-16
C888 FILL_L30_34 FILL_L8_15 8.0512999999999997e-18
C889 FILL_L30_34 FILL_L8_16 3.1295700000000002e-17
C890 FILL_L30_34 FILL_L8_17 2.9260400000000002e-17
C891 FILL_L30_34 FILL_L8_20 8.0512999999999997e-18
C892 FILL_L30_34 N 3.5909200000000002e-16
C893 FILL_L30_34 0 4.2531900000000006e-16
C894 FILL_L30_4 FILL_L30_5 1.92731e-17
C895 FILL_L30_4 FILL_L30_9 1.92731e-17
C896 FILL_L30_4 FILL_L50_4 6.7224999999999998e-17
C897 FILL_L30_4 0 5.9094000000000009e-17
C898 FILL_L30_5 FILL_L50_4 4.0405400000000007e-18
C899 FILL_L30_5 FILL_L50_5 1.2738600000000002e-16
C900 FILL_L30_5 FILL_L8_0 1.4606900000000002e-17
C901 FILL_L30_5 FILL_L8_1 5.0346600000000001e-18
C902 FILL_L30_5 FILL_L8_2 1.8545800000000002e-17
C903 FILL_L30_5 N 1.4095200000000001e-16
C904 FILL_L30_5 0 2.6052300000000004e-16
C905 FILL_L30_6 FILL_L30_7 1.92731e-17
C906 FILL_L30_6 FILL_L50_6 6.7224999999999998e-17
C907 FILL_L30_6 0 7.9960899999999995e-17
C908 FILL_L30_7 FILL_L30_8 1.92731e-17
C909 FILL_L30_7 FILL_L50_7 6.7224999999999998e-17
C910 FILL_L30_7 0 5.2324400000000002e-17
C911 FILL_L30_8 FILL_L50_8 6.7224999999999998e-17
C912 FILL_L30_8 0 3.4016200000000002e-17
C913 FILL_L30_9 FILL_L50_10 6.7224999999999998e-17
C914 FILL_L30_9 0 4.2390500000000006e-17
C915 FILL_L50_0 FILL_L50_1 2.4713600000000001e-17
C916 FILL_L50_0 FILL_L50_8 2.4713600000000001e-17
C917 FILL_L50_0 0 5.5868899999999997e-17
C918 FILL_L50_1 FILL_L50_13 9.8854299999999996e-17
C919 FILL_L50_1 P 1.8889099999999999e-17
C920 FILL_L50_1 0 1.58825e-16
C921 FILL_L50_10 FILL_L50_15 2.4713600000000001e-17
C922 FILL_L50_10 FILL_L50_4 2.4713600000000001e-17
C923 FILL_L50_10 FILL_L50_9 9.897280000000001e-18
C924 FILL_L50_10 N 1.5955500000000001e-17
C925 FILL_L50_10 0 2.7192600000000001e-17
C926 FILL_L50_11 FILL_L50_16 2.4713600000000001e-17
C927 FILL_L50_11 FILL_L50_5 2.4713600000000001e-17
C928 FILL_L50_11 N 2.9064600000000002e-17
C929 FILL_L50_11 0 3.2489e-17
C930 FILL_L50_12 FILL_L50_13 2.4713600000000001e-17
C931 FILL_L50_12 FILL_L50_17 2.4713600000000001e-17
C932 FILL_L50_12 FILL_L50_8 2.4713600000000001e-17
C933 FILL_L50_12 0 3.7063500000000003e-17
C934 FILL_L50_13 FILL_L50_25 9.8854299999999996e-17
C935 FILL_L50_13 FILL_L50_8 2.4713600000000001e-17
C936 FILL_L50_13 P 4.8746100000000003e-17
C937 FILL_L50_13 0 9.6304000000000014e-17
C938 FILL_L50_14 FILL_L50_15 9.5013900000000012e-18
C939 FILL_L50_14 FILL_L50_18 2.4713600000000001e-17
C940 FILL_L50_14 FILL_L50_9 2.4713600000000001e-17
C941 FILL_L50_14 P 6.6567200000000001e-17
C942 FILL_L50_14 0 1.8485700000000003e-17
C943 FILL_L50_15 FILL_L50_20 2.4713600000000001e-17
C944 FILL_L50_15 N 1.5955500000000001e-17
C945 FILL_L50_15 0 3.2366000000000002e-17
C946 FILL_L50_16 FILL_L50_21 2.4713600000000001e-17
C947 FILL_L50_16 N 2.9064600000000002e-17
C948 FILL_L50_16 0 1.5556e-17
C949 FILL_L50_17 FILL_L50_24 2.4713600000000001e-17
C950 FILL_L50_17 FILL_L50_25 2.4713600000000001e-17
C951 FILL_L50_17 0 2.02794e-17
C952 FILL_L50_18 FILL_L50_19 2.4713600000000001e-17
C953 FILL_L50_18 FILL_L50_26 2.4713600000000001e-17
C954 FILL_L50_18 P 6.6567200000000001e-17
C955 FILL_L50_18 0 5.3588199999999998e-18
C956 FILL_L50_19 FILL_L50_20 2.4713600000000001e-17
C957 FILL_L50_19 FILL_L50_3 6.1876600000000009e-18
C958 FILL_L50_19 FILL_L50_31 9.897280000000001e-18
C959 FILL_L50_19 0 3.1434799999999999e-17
C960 FILL_L50_2 FILL_L50_3 2.4713600000000001e-17
C961 FILL_L50_2 FILL_L50_9 2.4713600000000001e-17
C962 FILL_L50_2 P 6.6567200000000001e-17
C963 FILL_L50_2 0 3.5262300000000004e-17
C964 FILL_L50_20 FILL_L50_27 2.4713600000000001e-17
C965 FILL_L50_20 N 1.5955500000000001e-17
C966 FILL_L50_20 0 1.80312e-17
C967 FILL_L50_21 FILL_L50_28 2.4713600000000001e-17
C968 FILL_L50_21 N 2.9064600000000002e-17
C969 FILL_L50_21 0 1.5556e-17
C970 FILL_L50_22 FILL_L50_23 2.4713600000000001e-17
C971 FILL_L50_22 FILL_L50_34 9.897280000000001e-18
C972 FILL_L50_22 FILL_L50_6 6.1876600000000009e-18
C973 FILL_L50_22 0 5.7799300000000013e-17
C974 FILL_L50_23 FILL_L50_24 2.4713600000000001e-17
C975 FILL_L50_23 FILL_L50_35 6.7301500000000004e-18
C976 FILL_L50_23 FILL_L50_7 4.2076100000000004e-18
C977 FILL_L50_23 0 3.5620900000000004e-17
C978 FILL_L50_24 FILL_L50_25 2.4713600000000001e-17
C979 FILL_L50_24 FILL_L50_29 2.4713600000000001e-17
C980 FILL_L50_24 0 2.2737100000000002e-17
C981 FILL_L50_25 FILL_L50_37 9.8854299999999996e-17
C982 FILL_L50_25 P 4.8746100000000003e-17
C983 FILL_L50_25 0 1.0771300000000001e-16
C984 FILL_L50_26 FILL_L50_27 7.9178300000000003e-18
C985 FILL_L50_26 FILL_L50_30 2.4713600000000001e-17
C986 FILL_L50_26 P 6.6567200000000001e-17
C987 FILL_L50_26 0 1.6322500000000002e-17
C988 FILL_L50_27 FILL_L50_32 2.4713600000000001e-17
C989 FILL_L50_27 N 1.5955500000000001e-17
C990 FILL_L50_27 0 2.8470500000000006e-17
C991 FILL_L50_28 FILL_L50_33 2.4713600000000001e-17
C992 FILL_L50_28 N 2.9064600000000002e-17
C993 FILL_L50_28 0 2.4022500000000003e-17
C994 FILL_L50_29 FILL_L50_36 2.4713600000000001e-17
C995 FILL_L50_29 FILL_L50_37 2.4713600000000001e-17
C996 FILL_L50_29 0 3.2147700000000003e-17
C997 FILL_L50_3 FILL_L50_4 2.4713600000000001e-17
C998 FILL_L50_3 0 5.5810600000000004e-17
C999 FILL_L50_30 FILL_L50_31 2.4713600000000001e-17
C1000 FILL_L50_30 FILL_L50_38 2.4713600000000001e-17
C1001 FILL_L50_30 P 6.6567200000000001e-17
C1002 FILL_L50_30 0 1.2233800000000002e-17
C1003 FILL_L50_31 FILL_L50_32 2.4713600000000001e-17
C1004 FILL_L50_31 0 4.6198200000000001e-17
C1005 FILL_L50_32 FILL_L50_39 2.4713600000000001e-17
C1006 FILL_L50_32 N 1.5955500000000001e-17
C1007 FILL_L50_32 0 1.9584499999999999e-17
C1008 FILL_L50_33 FILL_L50_40 2.4713600000000001e-17
C1009 FILL_L50_33 N 2.9064600000000002e-17
C1010 FILL_L50_33 0 1.5556e-17
C1011 FILL_L50_34 FILL_L50_35 2.4713600000000001e-17
C1012 FILL_L50_34 0 7.0528100000000006e-17
C1013 FILL_L50_35 FILL_L50_36 2.4713600000000001e-17
C1014 FILL_L50_35 0 4.7018400000000002e-17
C1015 FILL_L50_36 FILL_L50_37 2.4713600000000001e-17
C1016 FILL_L50_36 0 4.3885500000000006e-17
C1017 FILL_L50_37 P 4.8746100000000003e-17
C1018 FILL_L50_37 0 1.9035700000000002e-16
C1019 FILL_L50_38 FILL_L50_39 9.897280000000001e-18
C1020 FILL_L50_38 P 6.6567200000000001e-17
C1021 FILL_L50_38 0 4.2376300000000005e-17
C1022 FILL_L50_39 N 1.5955500000000001e-17
C1023 FILL_L50_39 0 5.1850500000000003e-17
C1024 FILL_L50_4 N 1.5955500000000001e-17
C1025 FILL_L50_4 0 4.3658200000000001e-17
C1026 FILL_L50_40 N 2.9064600000000002e-17
C1027 FILL_L50_40 0 5.1174700000000006e-17
C1028 FILL_L50_5 N 2.9064600000000002e-17
C1029 FILL_L50_5 0 4.1673600000000006e-17
C1030 FILL_L50_6 FILL_L50_7 2.4713600000000001e-17
C1031 FILL_L50_6 0 6.6461400000000006e-17
C1032 FILL_L50_7 FILL_L50_8 2.4713600000000001e-17
C1033 FILL_L50_7 0 3.8564500000000008e-17
C1034 FILL_L50_8 0 1.9201100000000002e-17
C1035 FILL_L50_9 P 6.6567200000000001e-17
C1036 FILL_L50_9 0 1.6779399999999999e-17
C1037 FILL_L8_0 FILL_L8_1 1.9913400000000001e-17
C1038 FILL_L8_0 FILL_L8_2 1.0952400000000002e-17
C1039 FILL_L8_0 0 1.0895200000000001e-16
C1040 FILL_L8_1 FILL_L8_2 1.9913400000000001e-17
C1041 FILL_L8_1 FILL_L8_5 1.9913400000000001e-17
C1042 FILL_L8_1 N 5.14103e-19
C1043 FILL_L8_1 0 1.25459e-16
C1044 FILL_L8_10 FILL_L8_11 1.9913400000000001e-17
C1045 FILL_L8_10 FILL_L8_12 1.9913400000000001e-17
C1046 FILL_L8_10 FILL_L8_6 1.9913400000000001e-17
C1047 FILL_L8_10 0 1.25459e-16
C1048 FILL_L8_11 FILL_L8_12 1.9913400000000001e-17
C1049 FILL_L8_11 FILL_L8_15 1.9913400000000001e-17
C1050 FILL_L8_11 0 1.2853299999999999e-16
C1051 FILL_L8_12 FILL_L8_13 6.96968e-17
C1052 FILL_L8_12 FILL_L8_17 6.96968e-17
C1053 FILL_L8_12 FILL_L8_7 6.96968e-17
C1054 FILL_L8_12 0 7.693e-16
C1055 FILL_L8_13 FILL_L8_14 6.96968e-17
C1056 FILL_L8_13 FILL_L8_18 6.96968e-17
C1057 FILL_L8_13 FILL_L8_8 6.96968e-17
C1058 FILL_L8_13 0 7.5091400000000008e-16
C1059 FILL_L8_14 FILL_L8_19 6.96968e-17
C1060 FILL_L8_14 FILL_L8_9 6.96968e-17
C1061 FILL_L8_14 0 8.0897100000000003e-16
C1062 FILL_L8_15 FILL_L8_16 1.9913400000000001e-17
C1063 FILL_L8_15 FILL_L8_17 1.9913400000000001e-17
C1064 FILL_L8_15 N 4.99158e-19
C1065 FILL_L8_15 0 1.2885100000000001e-16
C1066 FILL_L8_16 FILL_L8_17 1.9913400000000001e-17
C1067 FILL_L8_16 FILL_L8_20 1.9913400000000001e-17
C1068 FILL_L8_16 0 1.25459e-16
C1069 FILL_L8_17 FILL_L8_18 6.96968e-17
C1070 FILL_L8_17 FILL_L8_21 6.96968e-17
C1071 FILL_L8_17 0 7.692200000000001e-16
C1072 FILL_L8_18 FILL_L8_19 6.96968e-17
C1073 FILL_L8_18 FILL_L8_22 6.96968e-17
C1074 FILL_L8_18 0 7.5091400000000008e-16
C1075 FILL_L8_19 FILL_L8_23 6.96968e-17
C1076 FILL_L8_19 0 8.0897100000000003e-16
C1077 FILL_L8_2 FILL_L8_3 6.0735800000000006e-17
C1078 FILL_L8_2 FILL_L8_7 6.96968e-17
C1079 FILL_L8_2 N 1.7191300000000003e-19
C1080 FILL_L8_2 0 7.5120000000000006e-16
C1081 FILL_L8_20 FILL_L8_21 8.9610199999999998e-18
C1082 FILL_L8_20 N 1.70371e-19
C1083 FILL_L8_20 0 1.0013900000000001e-16
C1084 FILL_L8_21 FILL_L8_22 8.9610199999999998e-18
C1085 FILL_L8_21 0 2.9489e-16
C1086 FILL_L8_22 FILL_L8_23 8.9610199999999998e-18
C1087 FILL_L8_22 0 2.9489e-16
C1088 FILL_L8_23 0 3.0235399999999999e-16
C1089 FILL_L8_3 FILL_L8_4 6.0735800000000006e-17
C1090 FILL_L8_3 FILL_L8_8 6.96968e-17
C1091 FILL_L8_3 0 7.3311900000000005e-16
C1092 FILL_L8_4 FILL_L8_9 6.96968e-17
C1093 FILL_L8_4 0 7.8371100000000008e-16
C1094 FILL_L8_5 FILL_L8_6 1.9913400000000001e-17
C1095 FILL_L8_5 FILL_L8_7 1.9913400000000001e-17
C1096 FILL_L8_5 0 1.2834300000000001e-16
C1097 FILL_L8_6 FILL_L8_7 1.9913400000000001e-17
C1098 FILL_L8_6 N 2.00261e-19
C1099 FILL_L8_6 0 1.2925300000000001e-16
C1100 FILL_L8_7 FILL_L8_8 6.96968e-17
C1101 FILL_L8_7 0 7.6828100000000005e-16
C1102 FILL_L8_8 FILL_L8_9 6.96968e-17
C1103 FILL_L8_8 0 7.5091400000000008e-16
C1104 FILL_L8_9 0 8.0897100000000003e-16
C1105 N 0 3.8426900000000001e-16
C1106 P 0 3.30931e-16
VP P 0 DC 0 AC 0
VN N 0 DC 0 AC 1
.control
set numdgt=17
ac lin 1 1Meg 1Meg
let cp = -imag(i(VP))/(2*pi*1e6)
let cn = -imag(i(VN))/(2*pi*1e6)
print cp cn
quit
.endc
.end
