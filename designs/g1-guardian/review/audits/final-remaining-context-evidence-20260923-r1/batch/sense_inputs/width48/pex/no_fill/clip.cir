* cell sense_fill_clip
.SUBCKT sense_fill_clip
* net 2 CTX_L8_0
* net 3 CTX_L8_1
* net 4 CTX_L8_2
* net 5 CTX_L8_3
* net 6 CTX_L8_4
* net 7 CTX_L8_5
* net 8 CTX_L8_6
* net 9 CTX_L8_7
* net 10 CTX_L8_8
* net 11 CTX_L8_9
* net 12 CTX_L8_10
* net 13 CTX_L8_11
* net 14 CTX_L8_12
* net 15 CTX_L8_13
* net 16 CTX_L8_14
* net 17 CTX_L8_15
* net 18 CTX_L8_16
* net 19 CTX_L126_2,CTX_L50_7,CTX_L67_5
* net 20 CTX_L10_0,CTX_L10_2,CTX_L10_4,CTX_L126_0,CTX_L30_0,CTX_L30_2,CTX_L30_4,CTX_L50_0,CTX_L50_2,CTX_L50_4,CTX_L67_0,CTX_L67_2,CTX_L67_4,CTX_L8_17,CTX_L8_19,CTX_L8_21
* net 21 CTX_L10_1,CTX_L10_3,CTX_L126_1,CTX_L30_1,CTX_L30_3,CTX_L50_1,CTX_L50_3,CTX_L67_1,CTX_L67_3,CTX_L8_18,CTX_L8_20
* net 22 CTX_L134_0
* net 23 P
* net 24 N
* net 25 CTX_L30_5
* net 26 CTX_L8_22
* net 27 CTX_L8_23
* net 28 CTX_L8_24
* net 29 CTX_L8_25
* net 30 CTX_L8_26
* net 31 CTX_L8_27
* net 32 CTX_L8_28
* net 33 CTX_L8_29
* net 34 CTX_L8_30
* net 35 CTX_L8_31
* net 36 CTX_L8_32
* net 37 CTX_L8_33
* net 38 CTX_L8_34
* net 39 CTX_L8_35
* net 40 CTX_L8_36
* net 41 CTX_L8_37
* net 42 CTX_L8_38
.ENDS sense_fill_clip
