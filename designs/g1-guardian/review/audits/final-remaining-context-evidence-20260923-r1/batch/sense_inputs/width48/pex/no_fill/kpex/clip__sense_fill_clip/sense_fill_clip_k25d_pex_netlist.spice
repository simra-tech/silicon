*********************************************************
*** NGSPICE file created by KLayout-PEX 0.3.12
*** -----------------------------------------------------
***     Extraction Engine: KPEX/2.5D
***     Technology: ihp_sg13g2
***     Date: 2026-09-23 06:33:51
*********************************************************

.SUBCKT sense_fill_clip
Cext_1
+ CTX_L10_0|CTX_L10_2|CTX_L10_4|CTX_L126_0|CTX_L30_0|CTX_L30_2|CTX_L30_4|CTX_L50_0|CTX_L50_2|CTX_L50_4|CTX_L67_0|CTX_L67_2|CTX_L67_4|CTX_L8_17|CTX_L8_19|CTX_L8_21
+ CTX_L10_1|CTX_L10_3|CTX_L126_1|CTX_L30_1|CTX_L30_3|CTX_L50_1|CTX_L50_3|CTX_L67_1|CTX_L67_3|CTX_L8_18|CTX_L8_20
+ 10.3151f
Cext_2
+ CTX_L10_0|CTX_L10_2|CTX_L10_4|CTX_L126_0|CTX_L30_0|CTX_L30_2|CTX_L30_4|CTX_L50_0|CTX_L50_2|CTX_L50_4|CTX_L67_0|CTX_L67_2|CTX_L67_4|CTX_L8_17|CTX_L8_19|CTX_L8_21
+ CTX_L134_0 1.78222f
Cext_3
+ CTX_L10_0|CTX_L10_2|CTX_L10_4|CTX_L126_0|CTX_L30_0|CTX_L30_2|CTX_L30_4|CTX_L50_0|CTX_L50_2|CTX_L50_4|CTX_L67_0|CTX_L67_2|CTX_L67_4|CTX_L8_17|CTX_L8_19|CTX_L8_21
+ CTX_L8_0 33.2073a
Cext_4
+ CTX_L10_0|CTX_L10_2|CTX_L10_4|CTX_L126_0|CTX_L30_0|CTX_L30_2|CTX_L30_4|CTX_L50_0|CTX_L50_2|CTX_L50_4|CTX_L67_0|CTX_L67_2|CTX_L67_4|CTX_L8_17|CTX_L8_19|CTX_L8_21
+ CTX_L8_1 35.8146a
Cext_5
+ CTX_L10_0|CTX_L10_2|CTX_L10_4|CTX_L126_0|CTX_L30_0|CTX_L30_2|CTX_L30_4|CTX_L50_0|CTX_L50_2|CTX_L50_4|CTX_L67_0|CTX_L67_2|CTX_L67_4|CTX_L8_17|CTX_L8_19|CTX_L8_21
+ CTX_L8_10 31.0013a
Cext_6
+ CTX_L10_0|CTX_L10_2|CTX_L10_4|CTX_L126_0|CTX_L30_0|CTX_L30_2|CTX_L30_4|CTX_L50_0|CTX_L50_2|CTX_L50_4|CTX_L67_0|CTX_L67_2|CTX_L67_4|CTX_L8_17|CTX_L8_19|CTX_L8_21
+ CTX_L8_11 33.2945a
Cext_7
+ CTX_L10_0|CTX_L10_2|CTX_L10_4|CTX_L126_0|CTX_L30_0|CTX_L30_2|CTX_L30_4|CTX_L50_0|CTX_L50_2|CTX_L50_4|CTX_L67_0|CTX_L67_2|CTX_L67_4|CTX_L8_17|CTX_L8_19|CTX_L8_21
+ CTX_L8_12 31.0013a
Cext_8
+ CTX_L10_0|CTX_L10_2|CTX_L10_4|CTX_L126_0|CTX_L30_0|CTX_L30_2|CTX_L30_4|CTX_L50_0|CTX_L50_2|CTX_L50_4|CTX_L67_0|CTX_L67_2|CTX_L67_4|CTX_L8_17|CTX_L8_19|CTX_L8_21
+ CTX_L8_13 33.2945a
Cext_9
+ CTX_L10_0|CTX_L10_2|CTX_L10_4|CTX_L126_0|CTX_L30_0|CTX_L30_2|CTX_L30_4|CTX_L50_0|CTX_L50_2|CTX_L50_4|CTX_L67_0|CTX_L67_2|CTX_L67_4|CTX_L8_17|CTX_L8_19|CTX_L8_21
+ CTX_L8_14 30.9715a
Cext_10
+ CTX_L10_0|CTX_L10_2|CTX_L10_4|CTX_L126_0|CTX_L30_0|CTX_L30_2|CTX_L30_4|CTX_L50_0|CTX_L50_2|CTX_L50_4|CTX_L67_0|CTX_L67_2|CTX_L67_4|CTX_L8_17|CTX_L8_19|CTX_L8_21
+ CTX_L8_15 33.2945a
Cext_11
+ CTX_L10_0|CTX_L10_2|CTX_L10_4|CTX_L126_0|CTX_L30_0|CTX_L30_2|CTX_L30_4|CTX_L50_0|CTX_L50_2|CTX_L50_4|CTX_L67_0|CTX_L67_2|CTX_L67_4|CTX_L8_17|CTX_L8_19|CTX_L8_21
+ CTX_L8_16 31.0013a
Cext_12
+ CTX_L10_0|CTX_L10_2|CTX_L10_4|CTX_L126_0|CTX_L30_0|CTX_L30_2|CTX_L30_4|CTX_L50_0|CTX_L50_2|CTX_L50_4|CTX_L67_0|CTX_L67_2|CTX_L67_4|CTX_L8_17|CTX_L8_19|CTX_L8_21
+ CTX_L8_2 35.512a
Cext_13
+ CTX_L10_0|CTX_L10_2|CTX_L10_4|CTX_L126_0|CTX_L30_0|CTX_L30_2|CTX_L30_4|CTX_L50_0|CTX_L50_2|CTX_L50_4|CTX_L67_0|CTX_L67_2|CTX_L67_4|CTX_L8_17|CTX_L8_19|CTX_L8_21
+ CTX_L8_22 33.547a
Cext_14
+ CTX_L10_0|CTX_L10_2|CTX_L10_4|CTX_L126_0|CTX_L30_0|CTX_L30_2|CTX_L30_4|CTX_L50_0|CTX_L50_2|CTX_L50_4|CTX_L67_0|CTX_L67_2|CTX_L67_4|CTX_L8_17|CTX_L8_19|CTX_L8_21
+ CTX_L8_23 36.2497a
Cext_15
+ CTX_L10_0|CTX_L10_2|CTX_L10_4|CTX_L126_0|CTX_L30_0|CTX_L30_2|CTX_L30_4|CTX_L50_0|CTX_L50_2|CTX_L50_4|CTX_L67_0|CTX_L67_2|CTX_L67_4|CTX_L8_17|CTX_L8_19|CTX_L8_21
+ CTX_L8_24 36.189a
Cext_16
+ CTX_L10_0|CTX_L10_2|CTX_L10_4|CTX_L126_0|CTX_L30_0|CTX_L30_2|CTX_L30_4|CTX_L50_0|CTX_L50_2|CTX_L50_4|CTX_L67_0|CTX_L67_2|CTX_L67_4|CTX_L8_17|CTX_L8_19|CTX_L8_21
+ CTX_L8_25 36.2497a
Cext_17
+ CTX_L10_0|CTX_L10_2|CTX_L10_4|CTX_L126_0|CTX_L30_0|CTX_L30_2|CTX_L30_4|CTX_L50_0|CTX_L50_2|CTX_L50_4|CTX_L67_0|CTX_L67_2|CTX_L67_4|CTX_L8_17|CTX_L8_19|CTX_L8_21
+ CTX_L8_26 33.7263a
Cext_18
+ CTX_L10_0|CTX_L10_2|CTX_L10_4|CTX_L126_0|CTX_L30_0|CTX_L30_2|CTX_L30_4|CTX_L50_0|CTX_L50_2|CTX_L50_4|CTX_L67_0|CTX_L67_2|CTX_L67_4|CTX_L8_17|CTX_L8_19|CTX_L8_21
+ CTX_L8_27 36.2497a
Cext_19
+ CTX_L10_0|CTX_L10_2|CTX_L10_4|CTX_L126_0|CTX_L30_0|CTX_L30_2|CTX_L30_4|CTX_L50_0|CTX_L50_2|CTX_L50_4|CTX_L67_0|CTX_L67_2|CTX_L67_4|CTX_L8_17|CTX_L8_19|CTX_L8_21
+ CTX_L8_28 33.3804a
Cext_20
+ CTX_L10_0|CTX_L10_2|CTX_L10_4|CTX_L126_0|CTX_L30_0|CTX_L30_2|CTX_L30_4|CTX_L50_0|CTX_L50_2|CTX_L50_4|CTX_L67_0|CTX_L67_2|CTX_L67_4|CTX_L8_17|CTX_L8_19|CTX_L8_21
+ CTX_L8_29 34.6739a
Cext_21
+ CTX_L10_0|CTX_L10_2|CTX_L10_4|CTX_L126_0|CTX_L30_0|CTX_L30_2|CTX_L30_4|CTX_L50_0|CTX_L50_2|CTX_L50_4|CTX_L67_0|CTX_L67_2|CTX_L67_4|CTX_L8_17|CTX_L8_19|CTX_L8_21
+ CTX_L8_3 35.8146a
Cext_22
+ CTX_L10_0|CTX_L10_2|CTX_L10_4|CTX_L126_0|CTX_L30_0|CTX_L30_2|CTX_L30_4|CTX_L50_0|CTX_L50_2|CTX_L50_4|CTX_L67_0|CTX_L67_2|CTX_L67_4|CTX_L8_17|CTX_L8_19|CTX_L8_21
+ CTX_L8_30 31.8049a
Cext_23
+ CTX_L10_0|CTX_L10_2|CTX_L10_4|CTX_L126_0|CTX_L30_0|CTX_L30_2|CTX_L30_4|CTX_L50_0|CTX_L50_2|CTX_L50_4|CTX_L67_0|CTX_L67_2|CTX_L67_4|CTX_L8_17|CTX_L8_19|CTX_L8_21
+ CTX_L8_31 34.1083a
Cext_24
+ CTX_L10_0|CTX_L10_2|CTX_L10_4|CTX_L126_0|CTX_L30_0|CTX_L30_2|CTX_L30_4|CTX_L50_0|CTX_L50_2|CTX_L50_4|CTX_L67_0|CTX_L67_2|CTX_L67_4|CTX_L8_17|CTX_L8_19|CTX_L8_21
+ CTX_L8_32 31.0806a
Cext_25
+ CTX_L10_0|CTX_L10_2|CTX_L10_4|CTX_L126_0|CTX_L30_0|CTX_L30_2|CTX_L30_4|CTX_L50_0|CTX_L50_2|CTX_L50_4|CTX_L67_0|CTX_L67_2|CTX_L67_4|CTX_L8_17|CTX_L8_19|CTX_L8_21
+ CTX_L8_33 33.3865a
Cext_26
+ CTX_L10_0|CTX_L10_2|CTX_L10_4|CTX_L126_0|CTX_L30_0|CTX_L30_2|CTX_L30_4|CTX_L50_0|CTX_L50_2|CTX_L50_4|CTX_L67_0|CTX_L67_2|CTX_L67_4|CTX_L8_17|CTX_L8_19|CTX_L8_21
+ CTX_L8_34 31.0806a
Cext_27
+ CTX_L10_0|CTX_L10_2|CTX_L10_4|CTX_L126_0|CTX_L30_0|CTX_L30_2|CTX_L30_4|CTX_L50_0|CTX_L50_2|CTX_L50_4|CTX_L67_0|CTX_L67_2|CTX_L67_4|CTX_L8_17|CTX_L8_19|CTX_L8_21
+ CTX_L8_35 33.3865a
Cext_28
+ CTX_L10_0|CTX_L10_2|CTX_L10_4|CTX_L126_0|CTX_L30_0|CTX_L30_2|CTX_L30_4|CTX_L50_0|CTX_L50_2|CTX_L50_4|CTX_L67_0|CTX_L67_2|CTX_L67_4|CTX_L8_17|CTX_L8_19|CTX_L8_21
+ CTX_L8_36 31.0508a
Cext_29
+ CTX_L10_0|CTX_L10_2|CTX_L10_4|CTX_L126_0|CTX_L30_0|CTX_L30_2|CTX_L30_4|CTX_L50_0|CTX_L50_2|CTX_L50_4|CTX_L67_0|CTX_L67_2|CTX_L67_4|CTX_L8_17|CTX_L8_19|CTX_L8_21
+ CTX_L8_37 33.3865a
Cext_30
+ CTX_L10_0|CTX_L10_2|CTX_L10_4|CTX_L126_0|CTX_L30_0|CTX_L30_2|CTX_L30_4|CTX_L50_0|CTX_L50_2|CTX_L50_4|CTX_L67_0|CTX_L67_2|CTX_L67_4|CTX_L8_17|CTX_L8_19|CTX_L8_21
+ CTX_L8_38 31.0806a
Cext_31
+ CTX_L10_0|CTX_L10_2|CTX_L10_4|CTX_L126_0|CTX_L30_0|CTX_L30_2|CTX_L30_4|CTX_L50_0|CTX_L50_2|CTX_L50_4|CTX_L67_0|CTX_L67_2|CTX_L67_4|CTX_L8_17|CTX_L8_19|CTX_L8_21
+ CTX_L8_4 33.3214a
Cext_32
+ CTX_L10_0|CTX_L10_2|CTX_L10_4|CTX_L126_0|CTX_L30_0|CTX_L30_2|CTX_L30_4|CTX_L50_0|CTX_L50_2|CTX_L50_4|CTX_L67_0|CTX_L67_2|CTX_L67_4|CTX_L8_17|CTX_L8_19|CTX_L8_21
+ CTX_L8_5 35.8146a
Cext_33
+ CTX_L10_0|CTX_L10_2|CTX_L10_4|CTX_L126_0|CTX_L30_0|CTX_L30_2|CTX_L30_4|CTX_L50_0|CTX_L50_2|CTX_L50_4|CTX_L67_0|CTX_L67_2|CTX_L67_4|CTX_L8_17|CTX_L8_19|CTX_L8_21
+ CTX_L8_6 32.9483a
Cext_34
+ CTX_L10_0|CTX_L10_2|CTX_L10_4|CTX_L126_0|CTX_L30_0|CTX_L30_2|CTX_L30_4|CTX_L50_0|CTX_L50_2|CTX_L50_4|CTX_L67_0|CTX_L67_2|CTX_L67_4|CTX_L8_17|CTX_L8_19|CTX_L8_21
+ CTX_L8_7 34.3595a
Cext_35
+ CTX_L10_0|CTX_L10_2|CTX_L10_4|CTX_L126_0|CTX_L30_0|CTX_L30_2|CTX_L30_4|CTX_L50_0|CTX_L50_2|CTX_L50_4|CTX_L67_0|CTX_L67_2|CTX_L67_4|CTX_L8_17|CTX_L8_19|CTX_L8_21
+ CTX_L8_8 31.6387a
Cext_36
+ CTX_L10_0|CTX_L10_2|CTX_L10_4|CTX_L126_0|CTX_L30_0|CTX_L30_2|CTX_L30_4|CTX_L50_0|CTX_L50_2|CTX_L50_4|CTX_L67_0|CTX_L67_2|CTX_L67_4|CTX_L8_17|CTX_L8_19|CTX_L8_21
+ CTX_L8_9 33.9297a
Cext_37
+ CTX_L10_0|CTX_L10_2|CTX_L10_4|CTX_L126_0|CTX_L30_0|CTX_L30_2|CTX_L30_4|CTX_L50_0|CTX_L50_2|CTX_L50_4|CTX_L67_0|CTX_L67_2|CTX_L67_4|CTX_L8_17|CTX_L8_19|CTX_L8_21
+ N 179.054a
Cext_38
+ CTX_L10_0|CTX_L10_2|CTX_L10_4|CTX_L126_0|CTX_L30_0|CTX_L30_2|CTX_L30_4|CTX_L50_0|CTX_L50_2|CTX_L50_4|CTX_L67_0|CTX_L67_2|CTX_L67_4|CTX_L8_17|CTX_L8_19|CTX_L8_21
+ P 521.449a
Cext_39
+ CTX_L10_0|CTX_L10_2|CTX_L10_4|CTX_L126_0|CTX_L30_0|CTX_L30_2|CTX_L30_4|CTX_L50_0|CTX_L50_2|CTX_L50_4|CTX_L67_0|CTX_L67_2|CTX_L67_4|CTX_L8_17|CTX_L8_19|CTX_L8_21
+ VSUBS 25.0517f
Cext_40
+ CTX_L10_1|CTX_L10_3|CTX_L126_1|CTX_L30_1|CTX_L30_3|CTX_L50_1|CTX_L50_3|CTX_L67_1|CTX_L67_3|CTX_L8_18|CTX_L8_20
+ CTX_L126_2|CTX_L50_7|CTX_L67_5 621.935a
Cext_41
+ CTX_L10_1|CTX_L10_3|CTX_L126_1|CTX_L30_1|CTX_L30_3|CTX_L50_1|CTX_L50_3|CTX_L67_1|CTX_L67_3|CTX_L8_18|CTX_L8_20
+ CTX_L30_5 47.7898a
Cext_42
+ CTX_L10_1|CTX_L10_3|CTX_L126_1|CTX_L30_1|CTX_L30_3|CTX_L50_1|CTX_L50_3|CTX_L67_1|CTX_L67_3|CTX_L8_18|CTX_L8_20
+ CTX_L8_10 1.98621a
Cext_43
+ CTX_L10_1|CTX_L10_3|CTX_L126_1|CTX_L30_1|CTX_L30_3|CTX_L50_1|CTX_L50_3|CTX_L67_1|CTX_L67_3|CTX_L8_18|CTX_L8_20
+ CTX_L8_11 2.29228a
Cext_44
+ CTX_L10_1|CTX_L10_3|CTX_L126_1|CTX_L30_1|CTX_L30_3|CTX_L50_1|CTX_L50_3|CTX_L67_1|CTX_L67_3|CTX_L8_18|CTX_L8_20
+ CTX_L8_12 2.32007a
Cext_45
+ CTX_L10_1|CTX_L10_3|CTX_L126_1|CTX_L30_1|CTX_L30_3|CTX_L50_1|CTX_L50_3|CTX_L67_1|CTX_L67_3|CTX_L8_18|CTX_L8_20
+ CTX_L8_13 2.52009a
Cext_46
+ CTX_L10_1|CTX_L10_3|CTX_L126_1|CTX_L30_1|CTX_L30_3|CTX_L50_1|CTX_L50_3|CTX_L67_1|CTX_L67_3|CTX_L8_18|CTX_L8_20
+ CTX_L8_14 2.94006a
Cext_47
+ CTX_L10_1|CTX_L10_3|CTX_L126_1|CTX_L30_1|CTX_L30_3|CTX_L50_1|CTX_L50_3|CTX_L67_1|CTX_L67_3|CTX_L8_18|CTX_L8_20
+ CTX_L8_15 2.52009a
Cext_48
+ CTX_L10_1|CTX_L10_3|CTX_L126_1|CTX_L30_1|CTX_L30_3|CTX_L50_1|CTX_L50_3|CTX_L67_1|CTX_L67_3|CTX_L8_18|CTX_L8_20
+ CTX_L8_16 3.55836a
Cext_49
+ CTX_L10_1|CTX_L10_3|CTX_L126_1|CTX_L30_1|CTX_L30_3|CTX_L50_1|CTX_L50_3|CTX_L67_1|CTX_L67_3|CTX_L8_18|CTX_L8_20
+ CTX_L8_29 0.696955a
Cext_50
+ CTX_L10_1|CTX_L10_3|CTX_L126_1|CTX_L30_1|CTX_L30_3|CTX_L50_1|CTX_L50_3|CTX_L67_1|CTX_L67_3|CTX_L8_18|CTX_L8_20
+ CTX_L8_30 0.756317a
Cext_51
+ CTX_L10_1|CTX_L10_3|CTX_L126_1|CTX_L30_1|CTX_L30_3|CTX_L50_1|CTX_L50_3|CTX_L67_1|CTX_L67_3|CTX_L8_18|CTX_L8_20
+ CTX_L8_31 1.15444a
Cext_52
+ CTX_L10_1|CTX_L10_3|CTX_L126_1|CTX_L30_1|CTX_L30_3|CTX_L50_1|CTX_L50_3|CTX_L67_1|CTX_L67_3|CTX_L8_18|CTX_L8_20
+ CTX_L8_32 2.17044a
Cext_53
+ CTX_L10_1|CTX_L10_3|CTX_L126_1|CTX_L30_1|CTX_L30_3|CTX_L50_1|CTX_L50_3|CTX_L67_1|CTX_L67_3|CTX_L8_18|CTX_L8_20
+ CTX_L8_33 2.55464a
Cext_54
+ CTX_L10_1|CTX_L10_3|CTX_L126_1|CTX_L30_1|CTX_L30_3|CTX_L50_1|CTX_L50_3|CTX_L67_1|CTX_L67_3|CTX_L8_18|CTX_L8_20
+ CTX_L8_34 2.64567a
Cext_55
+ CTX_L10_1|CTX_L10_3|CTX_L126_1|CTX_L30_1|CTX_L30_3|CTX_L50_1|CTX_L50_3|CTX_L67_1|CTX_L67_3|CTX_L8_18|CTX_L8_20
+ CTX_L8_35 2.86322a
Cext_56
+ CTX_L10_1|CTX_L10_3|CTX_L126_1|CTX_L30_1|CTX_L30_3|CTX_L50_1|CTX_L50_3|CTX_L67_1|CTX_L67_3|CTX_L8_18|CTX_L8_20
+ CTX_L8_36 3.35422a
Cext_57
+ CTX_L10_1|CTX_L10_3|CTX_L126_1|CTX_L30_1|CTX_L30_3|CTX_L50_1|CTX_L50_3|CTX_L67_1|CTX_L67_3|CTX_L8_18|CTX_L8_20
+ CTX_L8_37 2.86322a
Cext_58
+ CTX_L10_1|CTX_L10_3|CTX_L126_1|CTX_L30_1|CTX_L30_3|CTX_L50_1|CTX_L50_3|CTX_L67_1|CTX_L67_3|CTX_L8_18|CTX_L8_20
+ CTX_L8_38 4.05282a
Cext_59
+ CTX_L10_1|CTX_L10_3|CTX_L126_1|CTX_L30_1|CTX_L30_3|CTX_L50_1|CTX_L50_3|CTX_L67_1|CTX_L67_3|CTX_L8_18|CTX_L8_20
+ CTX_L8_7 0.613321a
Cext_60
+ CTX_L10_1|CTX_L10_3|CTX_L126_1|CTX_L30_1|CTX_L30_3|CTX_L50_1|CTX_L50_3|CTX_L67_1|CTX_L67_3|CTX_L8_18|CTX_L8_20
+ CTX_L8_8 0.665559a
Cext_61
+ CTX_L10_1|CTX_L10_3|CTX_L126_1|CTX_L30_1|CTX_L30_3|CTX_L50_1|CTX_L50_3|CTX_L67_1|CTX_L67_3|CTX_L8_18|CTX_L8_20
+ CTX_L8_9 0.96735a
Cext_62
+ CTX_L10_1|CTX_L10_3|CTX_L126_1|CTX_L30_1|CTX_L30_3|CTX_L50_1|CTX_L50_3|CTX_L67_1|CTX_L67_3|CTX_L8_18|CTX_L8_20
+ N 923.976a
Cext_63
+ CTX_L10_1|CTX_L10_3|CTX_L126_1|CTX_L30_1|CTX_L30_3|CTX_L50_1|CTX_L50_3|CTX_L67_1|CTX_L67_3|CTX_L8_18|CTX_L8_20
+ P 1.04714f
Cext_64
+ CTX_L10_1|CTX_L10_3|CTX_L126_1|CTX_L30_1|CTX_L30_3|CTX_L50_1|CTX_L50_3|CTX_L67_1|CTX_L67_3|CTX_L8_18|CTX_L8_20
+ VSUBS 15.1093f
Cext_65 CTX_L126_2|CTX_L50_7|CTX_L67_5 CTX_L30_5 14.3593f
Cext_66 CTX_L126_2|CTX_L50_7|CTX_L67_5 N 130.196a
Cext_67 CTX_L126_2|CTX_L50_7|CTX_L67_5 VSUBS 5.57289f
Cext_68 CTX_L134_0 VSUBS 657.984a
Cext_69 CTX_L30_5 N 1.31224a
Cext_70 CTX_L30_5 VSUBS 4.48574f
Cext_71 CTX_L8_0 CTX_L8_1 12.797a
Cext_72 CTX_L8_0 VSUBS 34.8711a
Cext_73 CTX_L8_1 CTX_L8_2 1.75621a
Cext_74 CTX_L8_1 VSUBS 36.4616a
Cext_75 CTX_L8_10 CTX_L8_11 12.797a
Cext_76 CTX_L8_10 CTX_L8_9 1.75621a
Cext_77 CTX_L8_10 P 1.03644a
Cext_78 CTX_L8_10 VSUBS 33.3778a
Cext_79 CTX_L8_11 CTX_L8_12 1.75621a
Cext_80 CTX_L8_11 P 1.16941a
Cext_81 CTX_L8_11 VSUBS 36.4616a
Cext_82 CTX_L8_12 CTX_L8_13 12.797a
Cext_83 CTX_L8_12 P 0.561141a
Cext_84 CTX_L8_12 VSUBS 33.3778a
Cext_85 CTX_L8_13 CTX_L8_14 1.75621a
Cext_86 CTX_L8_13 N 0.160503a
Cext_87 CTX_L8_13 P 0.452864a
Cext_88 CTX_L8_13 VSUBS 36.4616a
Cext_89 CTX_L8_14 CTX_L8_15 12.797a
Cext_90 CTX_L8_14 N 0.229615a
Cext_91 CTX_L8_14 P 0.17312a
Cext_92 CTX_L8_14 VSUBS 33.3778a
Cext_93 CTX_L8_15 CTX_L8_16 1.75621a
Cext_94 CTX_L8_15 N 0.502075a
Cext_95 CTX_L8_15 P 0.147704a
Cext_96 CTX_L8_15 VSUBS 36.4616a
Cext_97 CTX_L8_16 N 0.955378a
Cext_98 CTX_L8_16 VSUBS 42.9031a
Cext_99 CTX_L8_2 CTX_L8_3 12.797a
Cext_100 CTX_L8_2 VSUBS 33.3778a
Cext_101 CTX_L8_22 CTX_L8_23 14.542a
Cext_102 CTX_L8_22 VSUBS 38.8478a
Cext_103 CTX_L8_23 CTX_L8_24 2.75976a
Cext_104 CTX_L8_23 VSUBS 39.669a
Cext_105 CTX_L8_24 CTX_L8_25 14.542a
Cext_106 CTX_L8_24 VSUBS 36.5012a
Cext_107 CTX_L8_25 CTX_L8_26 2.75976a
Cext_108 CTX_L8_25 VSUBS 39.669a
Cext_109 CTX_L8_26 CTX_L8_27 14.542a
Cext_110 CTX_L8_26 VSUBS 36.5012a
Cext_111 CTX_L8_27 CTX_L8_28 2.75976a
Cext_112 CTX_L8_27 VSUBS 39.669a
Cext_113 CTX_L8_28 CTX_L8_29 14.542a
Cext_114 CTX_L8_28 P 0.127746a
Cext_115 CTX_L8_28 VSUBS 36.5012a
Cext_116 CTX_L8_29 CTX_L8_30 2.75976a
Cext_117 CTX_L8_29 P 0.201577a
Cext_118 CTX_L8_29 VSUBS 39.669a
Cext_119 CTX_L8_3 CTX_L8_4 1.75621a
Cext_120 CTX_L8_3 VSUBS 36.4616a
Cext_121 CTX_L8_30 CTX_L8_31 14.542a
Cext_122 CTX_L8_30 P 0.445457a
Cext_123 CTX_L8_30 VSUBS 36.5012a
Cext_124 CTX_L8_31 CTX_L8_32 2.75976a
Cext_125 CTX_L8_31 P 0.742663a
Cext_126 CTX_L8_31 VSUBS 39.669a
Cext_127 CTX_L8_32 CTX_L8_33 14.542a
Cext_128 CTX_L8_32 P 1.15085a
Cext_129 CTX_L8_32 VSUBS 36.5012a
Cext_130 CTX_L8_33 CTX_L8_34 2.75976a
Cext_131 CTX_L8_33 P 1.30194a
Cext_132 CTX_L8_33 VSUBS 39.669a
Cext_133 CTX_L8_34 CTX_L8_35 14.542a
Cext_134 CTX_L8_34 P 0.63766a
Cext_135 CTX_L8_34 VSUBS 36.5012a
Cext_136 CTX_L8_35 CTX_L8_36 2.75976a
Cext_137 CTX_L8_35 N 0.160503a
Cext_138 CTX_L8_35 P 0.514618a
Cext_139 CTX_L8_35 VSUBS 39.669a
Cext_140 CTX_L8_36 CTX_L8_37 14.542a
Cext_141 CTX_L8_36 N 0.342709a
Cext_142 CTX_L8_36 P 0.17312a
Cext_143 CTX_L8_36 VSUBS 36.5012a
Cext_144 CTX_L8_37 CTX_L8_38 2.75976a
Cext_145 CTX_L8_37 N 0.57054a
Cext_146 CTX_L8_37 P 0.147704a
Cext_147 CTX_L8_37 VSUBS 39.669a
Cext_148 CTX_L8_38 N 1.08566a
Cext_149 CTX_L8_38 VSUBS 47.3254a
Cext_150 CTX_L8_4 CTX_L8_5 12.797a
Cext_151 CTX_L8_4 VSUBS 33.3778a
Cext_152 CTX_L8_5 CTX_L8_6 1.75621a
Cext_153 CTX_L8_5 VSUBS 36.4616a
Cext_154 CTX_L8_6 CTX_L8_7 12.797a
Cext_155 CTX_L8_6 P 0.127746a
Cext_156 CTX_L8_6 VSUBS 33.3778a
Cext_157 CTX_L8_7 CTX_L8_8 1.75621a
Cext_158 CTX_L8_7 P 0.201577a
Cext_159 CTX_L8_7 VSUBS 36.4616a
Cext_160 CTX_L8_8 CTX_L8_9 12.797a
Cext_161 CTX_L8_8 P 0.298456a
Cext_162 CTX_L8_8 VSUBS 33.3778a
Cext_163 CTX_L8_9 P 0.653543a
Cext_164 CTX_L8_9 VSUBS 36.4616a
Cext_165 N VSUBS 952.734a
Cext_166 P VSUBS 615.528a
.ENDS sense_fill_clip
