* no_fill grounded drive N; diagnostic capacitor-network AC only
C36 0 N 1.7905400000000001e-16
C37 0 P 5.2144900000000001e-16
C61 0 N 9.2397600000000001e-16
C62 0 P 1.0471400000000001e-15
C65 0 N 1.3019600000000001e-16
C68 0 N 1.3122400000000002e-18
C76 0 P 1.03644e-18
C79 0 P 1.1694100000000002e-18
C82 0 P 5.6114100000000006e-19
C85 0 N 1.6050300000000001e-19
C86 0 P 4.5286400000000006e-19
C89 0 N 2.2961500000000001e-19
C90 0 P 1.7312e-19
C93 0 N 5.0207500000000008e-19
C94 0 P 1.4770400000000001e-19
C96 0 N 9.5537800000000009e-19
C113 0 P 1.2774600000000001e-19
C116 0 P 2.0157700000000001e-19
C121 0 P 4.4545700000000006e-19
C124 0 P 7.4266300000000006e-19
C127 0 P 1.1508499999999999e-18
C130 0 P 1.3019400000000001e-18
C133 0 P 6.3766000000000006e-19
C136 0 N 1.6050300000000001e-19
C137 0 P 5.1461800000000001e-19
C140 0 N 3.42709e-19
C141 0 P 1.7312e-19
C144 0 N 5.7054000000000009e-19
C145 0 P 1.4770400000000001e-19
C147 0 N 1.0856600000000002e-18
C154 0 P 1.2774600000000001e-19
C157 0 P 2.0157700000000001e-19
C160 0 P 2.98456e-19
C162 0 P 6.5354300000000003e-19
C164 N 0 9.5273400000000007e-16
C165 P 0 6.1552800000000003e-16
VP P 0 DC 0 AC 0
VN N 0 DC 0 AC 1
.control
set numdgt=17
ac lin 1 1Meg 1Meg
let cp = -imag(i(VP))/(2*pi*1e6)
let cn = -imag(i(VN))/(2*pi*1e6)
print cp cn
quit
.endc
.end
