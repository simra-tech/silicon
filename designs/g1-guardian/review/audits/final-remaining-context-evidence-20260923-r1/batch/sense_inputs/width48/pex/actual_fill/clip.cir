* cell sense_fill_clip
.SUBCKT sense_fill_clip
* net 2 CTX_L126_2,CTX_L50_7,CTX_L67_5
* net 3 CTX_L8_0
* net 4 CTX_L10_0,CTX_L10_2,CTX_L10_4,CTX_L126_0,CTX_L30_0,CTX_L30_2,CTX_L30_4,CTX_L50_0,CTX_L50_2,CTX_L50_4,CTX_L67_0,CTX_L67_2,CTX_L67_4,CTX_L8_17,CTX_L8_19,CTX_L8_21
* net 5 CTX_L8_1
* net 6 CTX_L8_2
* net 7 CTX_L8_3
* net 8 CTX_L8_4
* net 9 CTX_L8_5
* net 10 CTX_L8_6
* net 11 FILL_L67_1
* net 12 FILL_L30_1
* net 13 FILL_L50_1
* net 14 CTX_L8_7
* net 15 CTX_L8_8
* net 16 CTX_L8_9
* net 17 CTX_L8_10
* net 18 FILL_L67_2
* net 19 FILL_L30_2
* net 20 CTX_L8_11
* net 21 CTX_L8_12
* net 22 CTX_L8_13
* net 23 CTX_L8_14
* net 24 CTX_L8_15
* net 25 CTX_L8_16
* net 26 FILL_L67_5
* net 27 FILL_L30_5
* net 28 FILL_L8_0
* net 29 FILL_L10_0
* net 30 FILL_L67_0
* net 31 FILL_L50_0
* net 32 FILL_L30_0
* net 33 FILL_L50_2
* net 34 FILL_L50_3
* net 35 FILL_L67_3
* net 36 FILL_L30_3
* net 37 FILL_L30_4
* net 38 FILL_L67_4
* net 39 FILL_L50_4
* net 40 FILL_L50_5
* net 41 FILL_L10_2
* net 42 FILL_L8_2
* net 43 FILL_L10_3
* net 44 FILL_L8_3
* net 45 FILL_L10_4
* net 46 FILL_L8_4
* net 47 FILL_L10_5
* net 48 FILL_L50_6
* net 49 FILL_L30_6
* net 50 FILL_L30_7
* net 51 FILL_L50_7
* net 52 FILL_L50_8
* net 53 FILL_L30_8
* net 54 FILL_L67_6
* net 55 FILL_L50_9
* net 56 FILL_L50_10
* net 57 FILL_L30_9
* net 58 FILL_L10_1
* net 59 FILL_L8_1
* net 60 FILL_L50_11
* net 61 CTX_L10_1,CTX_L10_3,CTX_L126_1,CTX_L30_1,CTX_L30_3,CTX_L50_1,CTX_L50_3,CTX_L67_1,CTX_L67_3,CTX_L8_18,CTX_L8_20
* net 62 FILL_L30_11
* net 63 FILL_L50_13
* net 64 FILL_L67_8
* net 65 FILL_L67_9
* net 66 FILL_L30_12
* net 67 FILL_L67_10
* net 68 FILL_L8_5
* net 69 FILL_L10_6
* net 70 FILL_L30_14
* net 71 FILL_L67_7
* net 72 FILL_L50_12
* net 73 FILL_L30_10
* net 74 FILL_L134_0
* net 75 FILL_L50_14
* net 76 FILL_L134_1
* net 77 FILL_L50_15
* net 78 FILL_L30_13
* net 79 FILL_L134_2
* net 80 FILL_L50_16
* net 81 FILL_L10_8
* net 82 FILL_L8_7
* net 83 FILL_L10_9
* net 84 FILL_L8_8
* net 85 FILL_L134_3
* net 86 FILL_L8_9
* net 87 FILL_L10_10
* net 88 FILL_L134_4
* net 89 FILL_L8_6
* net 90 FILL_L10_7
* net 91 CTX_L134_0
* net 92 FILL_L67_11
* net 93 FILL_L30_15
* net 94 FILL_L50_17
* net 95 FILL_L67_17
* net 96 FILL_L30_21
* net 97 FILL_L50_25
* net 98 FILL_L30_22
* net 99 FILL_L67_18
* net 100 P
* net 101 FILL_L50_18
* net 102 FILL_L67_12
* net 103 FILL_L50_19
* net 104 FILL_L30_16
* net 105 FILL_L67_13
* net 106 FILL_L30_17
* net 107 FILL_L50_20
* net 108 N
* net 109 FILL_L8_11
* net 110 FILL_L30_24
* net 111 FILL_L10_12
* net 112 FILL_L67_19
* net 113 FILL_L8_10
* net 114 FILL_L10_11
* net 115 FILL_L50_21
* net 116 FILL_L10_13
* net 117 FILL_L8_12
* net 118 FILL_L8_13
* net 119 FILL_L10_14
* net 120 CTX_L30_5
* net 121 FILL_L10_15
* net 122 FILL_L8_14
* net 123 FILL_L10_16
* net 124 FILL_L50_22
* net 125 FILL_L30_18
* net 126 FILL_L67_14
* net 127 FILL_L30_19
* net 128 FILL_L67_15
* net 129 FILL_L50_23
* net 130 FILL_L50_24
* net 131 FILL_L30_20
* net 132 FILL_L67_16
* net 133 FILL_L50_26
* net 134 FILL_L30_23
* net 135 FILL_L50_27
* net 136 FILL_L50_28
* net 137 FILL_L8_15
* net 138 FILL_L10_17
* net 139 FILL_L30_25
* net 140 FILL_L50_29
* net 141 FILL_L67_20
* net 142 FILL_L50_37
* net 143 FILL_L30_31
* net 144 FILL_L67_24
* net 145 FILL_L134_5
* net 146 FILL_L30_32
* net 147 FILL_L67_25
* net 148 FILL_L50_30
* net 149 FILL_L30_26
* net 150 FILL_L50_31
* net 151 FILL_L67_21
* net 152 FILL_L134_6
* net 153 FILL_L50_32
* net 154 FILL_L67_22
* net 155 FILL_L30_27
* net 156 FILL_L67_26
* net 157 FILL_L8_16
* net 158 FILL_L30_34
* net 159 FILL_L10_18
* net 160 FILL_L134_7
* net 161 FILL_L50_33
* net 162 FILL_L10_19
* net 163 FILL_L8_17
* net 164 FILL_L10_20
* net 165 FILL_L8_18
* net 166 FILL_L134_8
* net 167 FILL_L10_21
* net 168 FILL_L8_19
* net 169 FILL_L134_9
* net 170 FILL_L10_22
* net 171 CTX_L8_22
* net 172 FILL_L50_34
* net 173 FILL_L30_28
* net 174 CTX_L8_23
* net 175 CTX_L8_24
* net 176 FILL_L30_29
* net 177 FILL_L50_35
* net 178 CTX_L8_25
* net 179 CTX_L8_26
* net 180 FILL_L67_23
* net 181 FILL_L50_36
* net 182 FILL_L30_30
* net 183 CTX_L8_27
* net 184 CTX_L8_28
* net 185 CTX_L8_29
* net 186 CTX_L8_30
* net 187 CTX_L8_31
* net 188 CTX_L8_32
* net 189 CTX_L8_33
* net 190 FILL_L50_38
* net 191 CTX_L8_34
* net 192 CTX_L8_35
* net 193 CTX_L8_36
* net 194 FILL_L30_33
* net 195 FILL_L50_39
* net 196 CTX_L8_37
* net 197 CTX_L8_38
* net 198 FILL_L10_23
* net 199 FILL_L8_20
* net 200 FILL_L50_40
* net 201 FILL_L8_21
* net 202 FILL_L10_24
* net 203 FILL_L8_22
* net 204 FILL_L10_25
* net 205 FILL_L8_23
* net 206 FILL_L10_26
* net 207 FILL_L10_27
.ENDS sense_fill_clip
