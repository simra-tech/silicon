*********************************************************
*** NGSPICE file created by KLayout-PEX 0.3.12
*** -----------------------------------------------------
***     Extraction Engine: KPEX/2.5D
***     Technology: ihp_sg13g2
***     Date: 2026-09-23 06:34:10
*********************************************************

.SUBCKT sense_fill_clip
Cext_1 CTX_L134_0 CTX_L30_0 161.867a
Cext_2 CTX_L134_0 CTX_L30_1 22.6882a
Cext_3 CTX_L134_0 CTX_L30_2 17.9889a
Cext_4 CTX_L134_0 CTX_L30_5 16.5879a
Cext_5 CTX_L134_0 CTX_L8_0 1.19979a
Cext_6 CTX_L134_0 N 17.5443a
Cext_7 CTX_L134_0 P 17.0754a
Cext_8 CTX_L134_0 VSUBS 1.28548f
Cext_9 CTX_L30_0 CTX_L30_1 1.26652f
Cext_10 CTX_L30_0 CTX_L8_0 289.809a
Cext_11 CTX_L30_0 VSUBS 1.16364f
Cext_12 CTX_L30_1 CTX_L30_2 279.622a
Cext_13 CTX_L30_1 CTX_L8_0 16.8702a
Cext_14 CTX_L30_1 VSUBS 482.488a
Cext_15 CTX_L30_2 CTX_L8_0 4.77902a
Cext_16 CTX_L30_2 N 4.30617f
Cext_17 CTX_L30_2 VSUBS 425.208a
Cext_18 CTX_L30_5 CTX_L30_6 153.322a
Cext_19 CTX_L30_5 CTX_L8_0 3.12869a
Cext_20 CTX_L30_5 P 4.30617f
Cext_21 CTX_L30_5 VSUBS 592.195a
Cext_22 CTX_L30_6 VSUBS 1.2222f
Cext_23 CTX_L8_0 N 4.11579a
Cext_24 CTX_L8_0 P 3.57452a
Cext_25 CTX_L8_0 VSUBS 1.78611f
Cext_26 N P 4.30617f
Cext_27 N VSUBS 121.155a
Cext_28 P VSUBS 121.155a
.ENDS sense_fill_clip
