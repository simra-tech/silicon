* no_fill grounded drive P; diagnostic capacitor-network AC only
C5 0 N 1.75443e-17
C6 0 P 1.7075400000000001e-17
C15 0 N 4.3061700000000003e-15
C19 0 P 4.3061700000000003e-15
C22 0 N 4.1157899999999996e-18
C23 0 P 3.5745200000000008e-18
C25 N P 4.3061700000000003e-15
C26 N 0 1.2115500000000002e-16
C27 P 0 1.2115500000000002e-16
VP P 0 DC 0 AC 1
VN N 0 DC 0 AC 0
.control
set numdgt=17
ac lin 1 1Meg 1Meg
let cp = -imag(i(VP))/(2*pi*1e6)
let cn = -imag(i(VN))/(2*pi*1e6)
print cp cn
quit
.endc
.end
