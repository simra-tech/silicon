* actual_fill floating drive P; diagnostic capacitor-network AC only
C4 0 FILL_L10_0 2.2981000000000001e-18
C5 0 FILL_L10_1 4.5962100000000008e-18
C6 0 FILL_L10_10 3.7514800000000002e-18
C7 0 FILL_L10_11 7.5029700000000016e-18
C8 0 FILL_L10_12 7.5029700000000016e-18
C9 0 FILL_L10_2 4.5962100000000008e-18
C10 0 FILL_L10_3 3.4471599999999999e-18
C11 0 FILL_L10_4 2.49715e-17
C12 0 FILL_L10_5 3.1326400000000003e-17
C13 0 FILL_L10_6 3.1326400000000003e-17
C14 0 FILL_L10_7 2.8149e-17
C15 0 FILL_L10_9 3.4171200000000003e-18
C16 0 FILL_L50_0 9.69991e-17
C17 0 FILL_L50_1 9.72965e-17
C18 0 FILL_L50_2 9.72965e-17
C19 0 FILL_L50_3 7.4056400000000006e-18
C20 0 FILL_L50_4 4.5098100000000005e-17
C21 0 FILL_L50_5 4.5098100000000005e-17
C22 0 FILL_L50_6 4.5098100000000005e-17
C23 0 FILL_L50_7 1.8039300000000001e-18
C24 0 N 1.75443e-17
C25 0 P 1.7075400000000001e-17
C29 0 FILL_L10_0 5.4962400000000001e-16
C30 0 FILL_L10_1 5.6078100000000003e-16
C31 0 FILL_L10_2 5.6078100000000003e-16
C32 0 FILL_L10_3 5.4454800000000001e-16
C33 0 FILL_L50_0 5.2659600000000005e-16
C34 0 FILL_L50_1 5.2753800000000005e-16
C35 0 FILL_L50_2 5.2753800000000005e-16
C36 0 FILL_L50_3 5.8556200000000003e-17
C40 0 FILL_L10_0 8.2734399999999999e-17
C41 0 FILL_L10_1 8.2734399999999999e-17
C42 0 FILL_L10_2 8.2734399999999999e-17
C43 0 FILL_L10_3 8.2734399999999999e-17
C44 0 FILL_L10_4 4.1878000000000005e-17
C45 0 FILL_L10_5 4.1878000000000005e-17
C46 0 FILL_L10_6 4.1878000000000005e-17
C47 0 FILL_L10_7 4.1878000000000005e-17
C48 0 FILL_L50_0 2.8102900000000004e-16
C49 0 FILL_L50_1 2.8121800000000003e-16
C50 0 FILL_L50_2 2.8121800000000003e-16
C51 0 FILL_L50_3 1.8739600000000002e-17
C52 0 FILL_L8_0 3.2083100000000002e-18
C53 0 FILL_L8_1 3.2083100000000002e-18
C54 0 FILL_L8_2 3.2083100000000002e-18
C55 0 FILL_L8_3 3.2083100000000002e-18
C58 0 FILL_L10_4 2.23208e-16
C59 0 FILL_L10_5 2.24529e-16
C60 0 FILL_L10_6 2.24529e-16
C61 0 FILL_L10_7 2.2260700000000003e-16
C62 0 FILL_L50_0 8.9370199999999999e-17
C63 0 FILL_L50_1 8.9370199999999999e-17
C64 0 FILL_L50_2 8.9370199999999999e-17
C65 0 FILL_L50_3 3.5748100000000002e-18
C66 0 FILL_L50_4 8.7125700000000002e-18
C67 0 FILL_L50_5 8.7125700000000002e-18
C68 0 FILL_L50_6 8.7125700000000002e-18
C69 0 FILL_L50_7 3.4850300000000004e-19
C70 0 FILL_L8_0 2.5940300000000002e-18
C71 0 FILL_L8_1 3.2205200000000002e-18
C72 0 FILL_L8_2 3.2205200000000002e-18
C73 0 FILL_L8_3 2.39681e-18
C74 0 N 4.3061700000000003e-15
C78 0 FILL_L10_10 2.5083700000000002e-17
C79 0 FILL_L10_11 2.5083700000000002e-17
C80 0 FILL_L10_12 2.5083700000000002e-17
C81 0 FILL_L10_4 1.55534e-16
C82 0 FILL_L10_5 1.5685400000000002e-16
C83 0 FILL_L10_6 1.5685400000000002e-16
C84 0 FILL_L10_7 1.5493300000000001e-16
C85 0 FILL_L10_8 3.9047600000000005e-18
C86 0 FILL_L10_9 3.9047600000000005e-18
C87 0 FILL_L50_0 3.7675999999999999e-18
C88 0 FILL_L50_1 3.7675999999999999e-18
C89 0 FILL_L50_2 3.7675999999999999e-18
C90 0 FILL_L50_3 1.5070400000000002e-19
C91 0 FILL_L50_4 1.9239000000000001e-16
C92 0 FILL_L50_5 1.9242800000000002e-16
C93 0 FILL_L50_6 1.9242800000000002e-16
C94 0 FILL_L50_7 9.1952900000000009e-18
C95 0 FILL_L8_0 2.5940300000000002e-18
C96 0 FILL_L8_1 3.2205200000000002e-18
C97 0 FILL_L8_2 3.2205200000000002e-18
C98 0 FILL_L8_3 2.39681e-18
C99 0 P 4.3061700000000003e-15
C101 0 FILL_L10_10 2.4383100000000003e-16
C102 0 FILL_L10_11 2.4587799999999998e-16
C103 0 FILL_L10_12 2.4842900000000001e-16
C104 0 FILL_L10_4 1.7544200000000003e-18
C105 0 FILL_L10_5 1.7544200000000003e-18
C106 0 FILL_L10_6 1.7544200000000003e-18
C107 0 FILL_L10_7 2.1434400000000002e-18
C108 0 FILL_L10_8 4.8997099999999999e-18
C109 0 FILL_L10_9 4.8997099999999999e-18
C110 0 FILL_L50_4 6.9643300000000006e-17
C111 0 FILL_L50_5 6.9643300000000006e-17
C112 0 FILL_L50_6 6.9643300000000006e-17
C113 0 FILL_L50_7 2.7857300000000001e-18
C114 0 FILL_L8_10 9.5569000000000011e-19
C115 0 FILL_L8_11 9.5569000000000011e-19
C116 0 FILL_L8_3 5.0706500000000002e-19
C118 0 FILL_L10_0 2.09599e-16
C119 0 FILL_L10_1 2.11903e-16
C120 0 FILL_L10_2 2.11903e-16
C121 0 FILL_L10_3 2.0855000000000003e-16
C122 0 FILL_L50_0 1.6394300000000002e-17
C123 0 FILL_L50_1 1.6394300000000002e-17
C124 0 FILL_L50_2 1.6394300000000002e-17
C125 0 FILL_L50_3 9.6280700000000004e-19
C126 0 FILL_L50_4 2.19047e-18
C127 0 FILL_L50_5 2.19047e-18
C128 0 FILL_L50_6 2.19047e-18
C129 0 FILL_L50_7 2.3365e-19
C130 0 FILL_L8_0 3.7766599999999997e-17
C131 0 FILL_L8_1 3.7766599999999997e-17
C132 0 FILL_L8_2 3.7766599999999997e-17
C133 0 FILL_L8_3 3.7766599999999997e-17
C134 0 N 1.2018100000000002e-18
C135 0 P 9.5439600000000013e-19
C137 FILL_L10_0 FILL_L10_1 6.1178200000000006e-17
C138 FILL_L10_0 FILL_L10_4 9.7773300000000019e-17
C139 FILL_L10_0 FILL_L50_0 6.2109000000000007e-17
C140 FILL_L10_0 FILL_L8_0 1.4230000000000002e-17
C141 FILL_L10_0 0 3.9475300000000001e-16
C142 FILL_L10_1 FILL_L10_2 6.1178200000000006e-17
C143 FILL_L10_1 FILL_L10_5 9.7773300000000019e-17
C144 FILL_L10_1 FILL_L50_0 1.55573e-17
C145 FILL_L10_1 FILL_L50_1 4.6101199999999999e-17
C146 FILL_L10_1 FILL_L8_1 1.4230000000000002e-17
C147 FILL_L10_1 0 3.4775400000000005e-16
C148 FILL_L10_10 FILL_L10_11 9.2465600000000005e-17
C149 FILL_L10_10 FILL_L10_4 9.7773300000000019e-17
C150 FILL_L10_10 FILL_L50_4 2.16433e-16
C151 FILL_L10_10 FILL_L8_0 9.6778099999999992e-18
C152 FILL_L10_10 FILL_L8_4 1.1704300000000003e-16
C153 FILL_L10_10 FILL_L8_5 1.1704300000000003e-16
C154 FILL_L10_10 0 5.0668400000000005e-16
C155 FILL_L10_11 FILL_L10_12 9.2465600000000005e-17
C156 FILL_L10_11 FILL_L10_5 9.7773300000000019e-17
C157 FILL_L10_11 FILL_L50_4 6.2229199999999999e-17
C158 FILL_L10_11 FILL_L50_5 1.65203e-16
C159 FILL_L10_11 FILL_L8_1 9.6778099999999992e-18
C160 FILL_L10_11 FILL_L8_6 1.1704300000000003e-16
C161 FILL_L10_11 FILL_L8_7 1.1704300000000003e-16
C162 FILL_L10_11 0 4.3788700000000005e-16
C163 FILL_L10_12 FILL_L10_6 9.7773300000000019e-17
C164 FILL_L10_12 FILL_L10_8 2.7935199999999999e-17
C165 FILL_L10_12 FILL_L50_5 1.3087799999999998e-16
C166 FILL_L10_12 FILL_L50_6 1.0357400000000001e-16
C167 FILL_L10_12 FILL_L50_7 1.6508800000000002e-19
C168 FILL_L10_12 FILL_L8_2 9.6778099999999992e-18
C169 FILL_L10_12 FILL_L8_8 1.1704300000000003e-16
C170 FILL_L10_12 FILL_L8_9 1.1704300000000003e-16
C171 FILL_L10_12 0 4.8589900000000005e-16
C172 FILL_L10_2 FILL_L10_3 6.1178200000000006e-17
C173 FILL_L10_2 FILL_L10_6 9.7773300000000019e-17
C174 FILL_L10_2 FILL_L50_1 3.5919899999999999e-17
C175 FILL_L10_2 FILL_L50_2 2.5738600000000003e-17
C176 FILL_L10_2 FILL_L8_2 1.4230000000000002e-17
C177 FILL_L10_2 0 3.4775400000000005e-16
C178 FILL_L10_3 FILL_L10_7 9.7773300000000019e-17
C179 FILL_L10_3 FILL_L50_2 5.4337100000000003e-17
C180 FILL_L10_3 FILL_L50_3 7.8070500000000004e-18
C181 FILL_L10_3 FILL_L8_3 1.4230000000000002e-17
C182 FILL_L10_3 0 3.9519700000000004e-16
C183 FILL_L10_4 FILL_L10_5 9.7773300000000019e-17
C184 FILL_L10_4 FILL_L50_0 1.3691200000000002e-16
C185 FILL_L10_4 FILL_L50_4 9.3263200000000002e-17
C186 FILL_L10_4 FILL_L8_0 8.2350600000000007e-16
C187 FILL_L10_4 N 1.2429700000000002e-16
C188 FILL_L10_4 P 1.2429700000000002e-16
C189 FILL_L10_4 0 2.6896499999999997e-16
C190 FILL_L10_5 FILL_L10_6 9.7773300000000019e-17
C191 FILL_L10_5 FILL_L50_0 3.1114599999999999e-17
C192 FILL_L10_5 FILL_L50_1 9.9819000000000008e-17
C193 FILL_L10_5 FILL_L50_4 1.4312699999999999e-17
C194 FILL_L10_5 FILL_L50_5 6.4086900000000001e-17
C195 FILL_L10_5 FILL_L8_1 8.2350600000000007e-16
C196 FILL_L10_5 N 1.2561700000000001e-16
C197 FILL_L10_5 P 1.2561700000000001e-16
C198 FILL_L10_5 0 1.9621900000000002e-16
C199 FILL_L10_6 FILL_L10_7 9.7773300000000019e-17
C200 FILL_L10_6 FILL_L50_1 7.6917500000000007e-17
C201 FILL_L10_6 FILL_L50_2 5.4016e-17
C202 FILL_L10_6 FILL_L50_5 4.7495500000000004e-17
C203 FILL_L10_6 FILL_L50_6 3.0904100000000002e-17
C204 FILL_L10_6 FILL_L8_2 8.2350600000000007e-16
C205 FILL_L10_6 N 1.2561700000000001e-16
C206 FILL_L10_6 P 1.2561700000000001e-16
C207 FILL_L10_6 0 1.9621900000000002e-16
C208 FILL_L10_7 FILL_L10_8 2.7935199999999999e-17
C209 FILL_L10_7 FILL_L10_9 2.7935199999999999e-17
C210 FILL_L10_7 FILL_L50_2 1.1883e-16
C211 FILL_L10_7 FILL_L50_3 1.5614100000000001e-17
C212 FILL_L10_7 FILL_L50_6 8.5908900000000013e-17
C213 FILL_L10_7 FILL_L50_7 7.1824900000000004e-18
C214 FILL_L10_7 FILL_L8_3 8.2350600000000007e-16
C215 FILL_L10_7 N 1.23696e-16
C216 FILL_L10_7 P 1.23696e-16
C217 FILL_L10_7 0 3.0014200000000002e-16
C218 FILL_L10_8 FILL_L10_9 2.7935199999999999e-17
C219 FILL_L10_8 FILL_L50_6 5.8646000000000007e-17
C220 FILL_L10_8 FILL_L8_10 6.7224999999999998e-17
C221 FILL_L10_8 0 7.6847200000000005e-17
C222 FILL_L10_9 FILL_L50_6 1.7023599999999999e-17
C223 FILL_L10_9 FILL_L50_7 1.1723300000000001e-17
C224 FILL_L10_9 FILL_L8_11 6.7224999999999998e-17
C225 FILL_L10_9 0 9.7631699999999998e-17
C226 FILL_L50_0 FILL_L50_1 9.8854299999999996e-17
C227 FILL_L50_0 FILL_L50_4 9.8854299999999996e-17
C228 FILL_L50_0 FILL_L8_0 1.3629e-17
C229 FILL_L50_0 FILL_L8_1 4.2766800000000003e-18
C230 FILL_L50_0 N 1.1347200000000002e-17
C231 FILL_L50_0 P 6.9818800000000003e-18
C232 FILL_L50_0 0 2.88178e-16
C233 FILL_L50_1 FILL_L50_2 9.8854299999999996e-17
C234 FILL_L50_1 FILL_L50_5 9.8854299999999996e-17
C235 FILL_L50_1 FILL_L8_1 9.8880900000000008e-18
C236 FILL_L50_1 FILL_L8_2 8.0176200000000022e-18
C237 FILL_L50_1 N 1.1347200000000002e-17
C238 FILL_L50_1 P 6.9818800000000003e-18
C239 FILL_L50_1 0 2.0494200000000002e-16
C240 FILL_L50_2 FILL_L50_3 9.8854299999999996e-17
C241 FILL_L50_2 FILL_L50_6 9.8854299999999996e-17
C242 FILL_L50_2 FILL_L8_2 6.1471500000000005e-18
C243 FILL_L50_2 FILL_L8_3 1.17586e-17
C244 FILL_L50_2 N 1.1347200000000002e-17
C245 FILL_L50_2 P 6.9818800000000003e-18
C246 FILL_L50_2 0 2.0863900000000003e-16
C247 FILL_L50_3 FILL_L50_7 3.9541700000000001e-18
C248 FILL_L50_3 FILL_L8_3 4.6933100000000006e-19
C249 FILL_L50_3 N 4.5388800000000003e-19
C250 FILL_L50_3 P 2.79275e-19
C251 FILL_L50_3 0 1.4301300000000001e-16
C252 FILL_L50_4 FILL_L50_5 9.8854299999999996e-17
C253 FILL_L50_4 FILL_L8_0 1.2659000000000002e-17
C254 FILL_L50_4 FILL_L8_1 1.9672700000000003e-18
C255 FILL_L50_4 FILL_L8_5 8.5533600000000005e-18
C256 FILL_L50_4 FILL_L8_6 4.2766800000000003e-18
C257 FILL_L50_4 N 1.46777e-17
C258 FILL_L50_4 P 2.5466800000000001e-17
C259 FILL_L50_4 0 3.1116500000000005e-16
C260 FILL_L50_5 FILL_L50_6 9.8854299999999996e-17
C261 FILL_L50_5 FILL_L8_1 8.382300000000002e-18
C262 FILL_L50_5 FILL_L8_2 6.2439600000000011e-18
C263 FILL_L50_5 FILL_L8_7 8.5533600000000005e-18
C264 FILL_L50_5 FILL_L8_8 8.5533600000000005e-18
C265 FILL_L50_5 N 1.46777e-17
C266 FILL_L50_5 P 2.5466800000000001e-17
C267 FILL_L50_5 0 2.2398700000000001e-16
C268 FILL_L50_6 FILL_L50_7 9.8854299999999996e-17
C269 FILL_L50_6 FILL_L8_10 1.4425200000000002e-17
C270 FILL_L50_6 FILL_L8_11 2.7810000000000005e-18
C271 FILL_L50_6 FILL_L8_2 4.1056100000000005e-18
C272 FILL_L50_6 FILL_L8_3 1.4588400000000002e-17
C273 FILL_L50_6 FILL_L8_9 6.4150200000000004e-18
C274 FILL_L50_6 N 1.46777e-17
C275 FILL_L50_6 P 2.5466800000000001e-17
C276 FILL_L50_6 0 2.7824900000000007e-16
C277 FILL_L50_7 FILL_L8_11 4.6933100000000006e-19
C278 FILL_L50_7 FILL_L8_3 2.1589200000000002e-19
C279 FILL_L50_7 N 5.8710600000000009e-19
C280 FILL_L50_7 P 1.01867e-18
C281 FILL_L50_7 0 1.5982800000000002e-16
C282 FILL_L8_0 FILL_L8_1 6.96968e-17
C283 FILL_L8_0 FILL_L8_4 1.9913400000000001e-17
C284 FILL_L8_0 FILL_L8_5 1.9913400000000001e-17
C285 FILL_L8_0 N 2.5940300000000002e-18
C286 FILL_L8_0 P 2.5940300000000002e-18
C287 FILL_L8_0 0 8.6141600000000013e-16
C288 FILL_L8_1 FILL_L8_2 6.96968e-17
C289 FILL_L8_1 FILL_L8_6 1.9913400000000001e-17
C290 FILL_L8_1 FILL_L8_7 1.9913400000000001e-17
C291 FILL_L8_1 N 3.2205200000000002e-18
C292 FILL_L8_1 P 3.2205200000000002e-18
C293 FILL_L8_1 0 8.0335900000000008e-16
C294 FILL_L8_10 FILL_L8_11 1.9913400000000001e-17
C295 FILL_L8_10 FILL_L8_3 1.9913400000000001e-17
C296 FILL_L8_10 FILL_L8_9 1.9913400000000001e-17
C297 FILL_L8_10 0 1.4359700000000003e-16
C298 FILL_L8_11 FILL_L8_3 1.9913400000000001e-17
C299 FILL_L8_11 0 1.6018500000000001e-16
C300 FILL_L8_2 FILL_L8_3 6.96968e-17
C301 FILL_L8_2 FILL_L8_8 1.9913400000000001e-17
C302 FILL_L8_2 FILL_L8_9 1.9913400000000001e-17
C303 FILL_L8_2 N 3.2205200000000002e-18
C304 FILL_L8_2 P 3.2205200000000002e-18
C305 FILL_L8_2 0 8.0335900000000008e-16
C306 FILL_L8_3 N 2.39681e-18
C307 FILL_L8_3 P 2.39681e-18
C308 FILL_L8_3 0 8.6141600000000013e-16
C309 FILL_L8_4 FILL_L8_5 1.9913400000000001e-17
C310 FILL_L8_4 0 1.6018500000000001e-16
C311 FILL_L8_5 FILL_L8_6 1.9913400000000001e-17
C312 FILL_L8_5 0 1.4359700000000003e-16
C313 FILL_L8_6 FILL_L8_7 1.9913400000000001e-17
C314 FILL_L8_6 0 1.4359700000000003e-16
C315 FILL_L8_7 FILL_L8_8 1.9913400000000001e-17
C316 FILL_L8_7 0 1.4359700000000003e-16
C317 FILL_L8_8 FILL_L8_9 1.9913400000000001e-17
C318 FILL_L8_8 0 1.4359700000000003e-16
C319 FILL_L8_9 0 1.4359700000000003e-16
C320 N P 4.3061700000000003e-15
C321 N 0 4.5125100000000007e-17
C322 P 0 4.5125100000000007e-17
VP P 0 DC 0 AC 1
VN N 0 DC 0 AC 0
.control
set numdgt=17
ac lin 1 1Meg 1Meg
let cp = -imag(i(VP))/(2*pi*1e6)
let cn = -imag(i(VN))/(2*pi*1e6)
print cp cn
quit
.endc
.end
