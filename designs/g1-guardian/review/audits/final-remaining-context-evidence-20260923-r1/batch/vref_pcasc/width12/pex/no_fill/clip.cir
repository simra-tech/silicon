* cell sense_fill_clip
.SUBCKT sense_fill_clip
* net 1 CTX_L8_0
* net 2 CTX_L30_0
* net 3 CTX_L30_1
* net 4 CTX_L30_2
* net 5 N
* net 6 P
* net 7 CTX_L30_5
* net 8 CTX_L30_6
* net 9 CTX_L134_0
.ENDS sense_fill_clip
