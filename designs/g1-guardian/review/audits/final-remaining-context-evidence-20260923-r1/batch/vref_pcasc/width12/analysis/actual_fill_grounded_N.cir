* actual_fill grounded drive N; diagnostic capacitor-network AC only
C24 0 N 1.75443e-17
C25 0 P 1.7075400000000001e-17
C74 0 N 4.3061700000000003e-15
C99 0 P 4.3061700000000003e-15
C134 0 N 1.2018100000000002e-18
C135 0 P 9.5439600000000013e-19
C187 0 N 1.2429700000000002e-16
C188 0 P 1.2429700000000002e-16
C196 0 N 1.2561700000000001e-16
C197 0 P 1.2561700000000001e-16
C205 0 N 1.2561700000000001e-16
C206 0 P 1.2561700000000001e-16
C215 0 N 1.23696e-16
C216 0 P 1.23696e-16
C230 0 N 1.1347200000000002e-17
C231 0 P 6.9818800000000003e-18
C237 0 N 1.1347200000000002e-17
C238 0 P 6.9818800000000003e-18
C244 0 N 1.1347200000000002e-17
C245 0 P 6.9818800000000003e-18
C249 0 N 4.5388800000000003e-19
C250 0 P 2.79275e-19
C257 0 N 1.46777e-17
C258 0 P 2.5466800000000001e-17
C265 0 N 1.46777e-17
C266 0 P 2.5466800000000001e-17
C274 0 N 1.46777e-17
C275 0 P 2.5466800000000001e-17
C279 0 N 5.8710600000000009e-19
C280 0 P 1.01867e-18
C285 0 N 2.5940300000000002e-18
C286 0 P 2.5940300000000002e-18
C291 0 N 3.2205200000000002e-18
C292 0 P 3.2205200000000002e-18
C303 0 N 3.2205200000000002e-18
C304 0 P 3.2205200000000002e-18
C306 0 N 2.39681e-18
C307 0 P 2.39681e-18
C320 N P 4.3061700000000003e-15
C321 N 0 4.5125100000000007e-17
C322 P 0 4.5125100000000007e-17
VP P 0 DC 0 AC 0
VN N 0 DC 0 AC 1
.control
set numdgt=17
ac lin 1 1Meg 1Meg
let cp = -imag(i(VP))/(2*pi*1e6)
let cn = -imag(i(VN))/(2*pi*1e6)
print cp cn
quit
.endc
.end
