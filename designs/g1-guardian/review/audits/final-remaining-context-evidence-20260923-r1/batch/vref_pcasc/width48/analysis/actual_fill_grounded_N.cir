* actual_fill grounded drive N; diagnostic capacitor-network AC only
C386 0 N 1.75443e-17
C387 0 P 1.7075400000000001e-17
C450 0 N 4.3061700000000003e-15
C475 0 P 4.3061700000000003e-15
C504 0 N 1.2018100000000002e-18
C505 0 P 9.5439600000000013e-19
C584 0 N 5.32824e-19
C585 0 P 7.1125800000000001e-19
C732 0 N 1.2429700000000002e-16
C733 0 P 1.2429700000000002e-16
C741 0 N 1.2561700000000001e-16
C742 0 P 1.2561700000000001e-16
C750 0 N 1.2561700000000001e-16
C751 0 P 1.2561700000000001e-16
C761 0 N 1.23696e-16
C762 0 P 1.23696e-16
C779 0 N 1.1347200000000002e-17
C780 0 P 6.9818800000000003e-18
C786 0 N 1.1347200000000002e-17
C787 0 P 6.9818800000000003e-18
C830 0 N 1.1347200000000002e-17
C831 0 P 6.9818800000000003e-18
C835 0 N 4.5388800000000003e-19
C836 0 P 2.79275e-19
C844 0 N 1.46777e-17
C845 0 P 2.5466800000000001e-17
C853 0 N 1.46777e-17
C854 0 P 2.5466800000000001e-17
C862 0 N 1.46777e-17
C863 0 P 2.5466800000000001e-17
C867 0 N 5.8710600000000009e-19
C868 0 P 1.01867e-18
C882 0 N 2.5940300000000002e-18
C883 0 P 2.5940300000000002e-18
C888 0 N 3.2205200000000002e-18
C889 0 P 3.2205200000000002e-18
C915 0 N 3.2205200000000002e-18
C916 0 P 3.2205200000000002e-18
C918 0 N 2.39681e-18
C919 0 P 2.39681e-18
C932 N P 4.3061700000000003e-15
C933 N 0 4.5125100000000007e-17
C934 P 0 4.5125100000000007e-17
VP P 0 DC 0 AC 0
VN N 0 DC 0 AC 1
.control
set numdgt=17
ac lin 1 1Meg 1Meg
let cp = -imag(i(VP))/(2*pi*1e6)
let cn = -imag(i(VN))/(2*pi*1e6)
print cp cn
quit
.endc
.end
