* actual_fill floating drive N; diagnostic capacitor-network AC only
C29 0 FILL_L10_10 3.9486600000000002e-16
C30 0 FILL_L10_11 3.9816600000000005e-16
C31 0 FILL_L10_12 4.0228200000000004e-16
C32 0 FILL_L10_13 5.9183199999999998e-17
C33 0 FILL_L10_14 5.9046100000000005e-17
C34 0 FILL_L10_15 5.9122199999999998e-17
C35 0 FILL_L10_16 5.9150100000000004e-17
C36 0 FILL_L10_17 5.8939399999999999e-17
C37 0 FILL_L10_18 6.9802800000000009e-17
C38 0 FILL_L10_4 1.7544200000000003e-18
C39 0 FILL_L10_5 1.7544200000000003e-18
C40 0 FILL_L10_6 1.7544200000000003e-18
C41 0 FILL_L10_7 4.3977600000000001e-18
C42 0 FILL_L10_8 8.0871399999999996e-18
C43 0 FILL_L10_9 9.6188300000000023e-18
C44 0 FILL_L50_10 6.8691400000000002e-16
C45 0 FILL_L50_11 7.1596699999999997e-17
C46 0 FILL_L50_12 1.1668200000000001e-16
C47 0 FILL_L50_13 1.0884200000000001e-16
C48 0 FILL_L50_14 1.3160800000000002e-16
C49 0 FILL_L50_15 1.6778199999999999e-17
C50 0 FILL_L50_16 2.2916000000000003e-17
C51 0 FILL_L50_17 5.3875900000000008e-18
C52 0 FILL_L50_18 4.2266500000000005e-18
C53 0 FILL_L50_19 2.6367200000000003e-19
C54 0 FILL_L50_4 9.1138200000000004e-17
C55 0 FILL_L50_5 9.1138200000000004e-17
C56 0 FILL_L50_6 9.1138200000000004e-17
C57 0 FILL_L50_7 3.6455300000000004e-18
C58 0 FILL_L50_8 6.3036500000000004e-16
C59 0 FILL_L50_9 6.32631e-16
C60 0 FILL_L8_0 3.0780400000000003e-19
C61 0 FILL_L8_1 3.0780400000000003e-19
C62 0 FILL_L8_10 2.0273700000000001e-18
C63 0 FILL_L8_11 2.0273700000000001e-18
C64 0 FILL_L8_12 1.1280200000000001e-17
C65 0 FILL_L8_13 1.1280200000000001e-17
C66 0 FILL_L8_14 1.1280200000000001e-17
C67 0 FILL_L8_15 1.1280200000000001e-17
C68 0 FILL_L8_16 1.1280200000000001e-17
C69 0 FILL_L8_17 1.1280200000000001e-17
C70 0 FILL_L8_18 3.06788e-17
C71 0 FILL_L8_19 6.7920699999999999e-17
C72 0 FILL_L8_2 3.0780400000000003e-19
C73 0 FILL_L8_3 1.0117000000000002e-18
C74 0 FILL_L8_4 5.5003100000000004e-19
C75 0 FILL_L8_5 5.5003100000000004e-19
C76 0 FILL_L8_6 5.5003100000000004e-19
C77 0 FILL_L8_7 5.5003100000000004e-19
C78 0 FILL_L8_8 5.5003100000000004e-19
C79 0 FILL_L8_9 5.5003100000000004e-19
C107 0 FILL_L50_12 1.7550300000000001e-17
C108 0 FILL_L50_13 1.7550300000000001e-17
C109 0 FILL_L50_14 1.7550300000000001e-17
C110 0 FILL_L50_15 7.0201200000000002e-19
C111 0 FILL_L50_16 8.7780300000000001e-17
C112 0 FILL_L50_17 8.5475200000000012e-17
C113 0 FILL_L50_18 8.5475200000000012e-17
C114 0 FILL_L50_19 8.0012899999999994e-18
C143 0 FILL_L50_13 1.2029600000000001e-17
C144 0 FILL_L50_16 9.5502199999999997e-18
C145 0 FILL_L50_17 3.0109100000000006e-17
C146 0 FILL_L50_18 1.08525e-17
C147 0 FILL_L50_19 4.3410100000000006e-19
C172 0 FILL_L50_16 4.3687899999999997e-18
C173 0 FILL_L50_17 4.8458400000000006e-18
C174 0 FILL_L50_18 5.0215899999999998e-18
C175 0 FILL_L50_19 2.00864e-19
C185 0 FILL_L50_12 2.0172599999999999e-18
C186 0 FILL_L50_16 7.1405400000000001e-17
C199 0 FILL_L10_14 1.1489000000000001e-19
C200 0 FILL_L50_12 2.2375800000000004e-17
C201 0 FILL_L50_16 2.1075400000000002e-16
C202 0 FILL_L50_17 3.41105e-18
C224 0 FILL_L50_12 1.1288600000000002e-17
C225 0 FILL_L50_16 2.5691300000000001e-17
C226 0 FILL_L50_17 4.8514000000000005e-17
C227 0 FILL_L50_18 4.8514000000000005e-17
C228 0 FILL_L50_19 6.522840000000001e-18
C251 0 FILL_L50_16 4.8481400000000002e-17
C252 0 FILL_L50_17 4.8514000000000005e-17
C253 0 FILL_L50_18 4.8514000000000005e-17
C254 0 FILL_L50_19 6.522840000000001e-18
C266 0 FILL_L50_12 7.4663400000000006e-18
C267 0 FILL_L50_16 1.1177700000000001e-16
C268 0 FILL_L50_17 4.5953200000000008e-18
C287 0 FILL_L50_12 2.0543300000000003e-18
C288 0 FILL_L50_13 2.0543300000000003e-18
C289 0 FILL_L50_14 7.3014600000000003e-18
C290 0 FILL_L50_16 5.6617600000000004e-18
C291 0 FILL_L50_17 4.9541900000000003e-17
C292 0 FILL_L50_18 6.28563e-17
C293 0 FILL_L50_19 6.522840000000001e-18
C314 0 FILL_L50_14 1.16877e-17
C315 0 FILL_L50_16 3.8487000000000002e-17
C316 0 FILL_L50_17 4.2775000000000002e-17
C317 0 FILL_L50_18 6.2509100000000006e-17
C318 0 FILL_L50_19 6.2968200000000005e-18
C338 0 FILL_L50_16 1.2186200000000001e-17
C339 0 FILL_L50_17 1.4338699999999999e-17
C340 0 FILL_L50_18 1.3994600000000001e-17
C341 0 FILL_L50_19 5.8405600000000004e-19
C351 0 FILL_L10_0 1.4006299999999999e-17
C352 0 FILL_L10_1 1.4006299999999999e-17
C353 0 FILL_L10_2 1.4006299999999999e-17
C354 0 FILL_L10_3 1.4006299999999999e-17
C355 0 FILL_L50_0 7.1419700000000002e-18
C356 0 FILL_L50_1 7.1419700000000002e-18
C357 0 FILL_L50_2 7.1419700000000002e-18
C358 0 FILL_L50_3 2.8567900000000004e-19
C366 0 FILL_L10_0 1.2957000000000001e-17
C367 0 FILL_L10_1 1.5402500000000001e-17
C368 0 FILL_L10_10 3.7514800000000002e-18
C369 0 FILL_L10_11 7.5029700000000016e-18
C370 0 FILL_L10_12 7.5029700000000016e-18
C371 0 FILL_L10_2 1.5402500000000001e-17
C372 0 FILL_L10_3 1.4106000000000002e-17
C373 0 FILL_L10_4 2.49715e-17
C374 0 FILL_L10_5 3.1326400000000003e-17
C375 0 FILL_L10_6 3.1326400000000003e-17
C376 0 FILL_L10_7 2.8149e-17
C377 0 FILL_L10_9 3.4171200000000003e-18
C378 0 FILL_L50_0 9.991600000000001e-17
C379 0 FILL_L50_1 1.00213e-16
C380 0 FILL_L50_2 1.00213e-16
C381 0 FILL_L50_3 7.5223199999999999e-18
C382 0 FILL_L50_4 4.5098100000000005e-17
C383 0 FILL_L50_5 4.5098100000000005e-17
C384 0 FILL_L50_6 4.5098100000000005e-17
C385 0 FILL_L50_7 1.8039300000000001e-18
C386 0 N 1.75443e-17
C387 0 P 1.7075400000000001e-17
C392 0 FILL_L10_0 2.9866300000000001e-16
C393 0 FILL_L10_1 3.0097400000000001e-16
C394 0 FILL_L10_2 3.0097400000000001e-16
C395 0 FILL_L10_3 2.9761200000000005e-16
C396 0 FILL_L50_0 3.6372900000000002e-17
C397 0 FILL_L50_1 3.6372900000000002e-17
C398 0 FILL_L50_2 3.6372900000000002e-17
C399 0 FILL_L50_3 1.4549200000000001e-18
C404 0 FILL_L10_0 7.2195500000000011e-16
C405 0 FILL_L10_1 7.3515800000000006e-16
C406 0 FILL_L10_2 7.3515800000000006e-16
C407 0 FILL_L10_3 7.1594799999999999e-16
C408 0 FILL_L50_0 5.51179e-16
C409 0 FILL_L50_1 5.52121e-16
C410 0 FILL_L50_2 5.52121e-16
C411 0 FILL_L50_3 5.9539500000000006e-17
C415 0 FILL_L10_0 8.2734399999999999e-17
C416 0 FILL_L10_1 8.2734399999999999e-17
C417 0 FILL_L10_2 8.2734399999999999e-17
C418 0 FILL_L10_3 8.2734399999999999e-17
C419 0 FILL_L10_4 4.1878000000000005e-17
C420 0 FILL_L10_5 4.1878000000000005e-17
C421 0 FILL_L10_6 4.1878000000000005e-17
C422 0 FILL_L10_7 4.1878000000000005e-17
C423 0 FILL_L50_0 2.8102900000000004e-16
C424 0 FILL_L50_1 2.8121800000000003e-16
C425 0 FILL_L50_2 2.8121800000000003e-16
C426 0 FILL_L50_3 1.8739600000000002e-17
C427 0 FILL_L8_0 3.2083100000000002e-18
C428 0 FILL_L8_1 3.2083100000000002e-18
C429 0 FILL_L8_2 3.2083100000000002e-18
C430 0 FILL_L8_3 3.2083100000000002e-18
C434 0 FILL_L10_4 2.23208e-16
C435 0 FILL_L10_5 2.24529e-16
C436 0 FILL_L10_6 2.24529e-16
C437 0 FILL_L10_7 2.2260700000000003e-16
C438 0 FILL_L50_0 8.9370199999999999e-17
C439 0 FILL_L50_1 8.9370199999999999e-17
C440 0 FILL_L50_2 8.9370199999999999e-17
C441 0 FILL_L50_3 3.5748100000000002e-18
C442 0 FILL_L50_4 8.7125700000000002e-18
C443 0 FILL_L50_5 8.7125700000000002e-18
C444 0 FILL_L50_6 8.7125700000000002e-18
C445 0 FILL_L50_7 3.4850300000000004e-19
C446 0 FILL_L8_0 2.5940300000000002e-18
C447 0 FILL_L8_1 3.2205200000000002e-18
C448 0 FILL_L8_2 3.2205200000000002e-18
C449 0 FILL_L8_3 2.39681e-18
C450 0 N 4.3061700000000003e-15
C454 0 FILL_L10_10 2.5083700000000002e-17
C455 0 FILL_L10_11 2.5083700000000002e-17
C456 0 FILL_L10_12 2.5083700000000002e-17
C457 0 FILL_L10_4 1.55534e-16
C458 0 FILL_L10_5 1.5685400000000002e-16
C459 0 FILL_L10_6 1.5685400000000002e-16
C460 0 FILL_L10_7 1.5493300000000001e-16
C461 0 FILL_L10_8 3.9047600000000005e-18
C462 0 FILL_L10_9 3.9047600000000005e-18
C463 0 FILL_L50_0 3.7675999999999999e-18
C464 0 FILL_L50_1 3.7675999999999999e-18
C465 0 FILL_L50_2 3.7675999999999999e-18
C466 0 FILL_L50_3 1.5070400000000002e-19
C467 0 FILL_L50_4 1.9239000000000001e-16
C468 0 FILL_L50_5 1.9242800000000002e-16
C469 0 FILL_L50_6 1.9242800000000002e-16
C470 0 FILL_L50_7 9.1952900000000009e-18
C471 0 FILL_L8_0 2.5940300000000002e-18
C472 0 FILL_L8_1 3.2205200000000002e-18
C473 0 FILL_L8_2 3.2205200000000002e-18
C474 0 FILL_L8_3 2.39681e-18
C475 0 P 4.3061700000000003e-15
C480 0 FILL_L10_0 4.9696200000000004e-18
C481 0 FILL_L10_1 4.9696200000000004e-18
C482 0 FILL_L10_2 4.9696200000000004e-18
C483 0 FILL_L10_3 4.1869199999999999e-18
C484 0 FILL_L50_0 1.89181e-18
C485 0 FILL_L50_1 1.89181e-18
C486 0 FILL_L50_2 1.89181e-18
C488 0 FILL_L10_0 2.4313800000000001e-16
C489 0 FILL_L10_1 2.4544200000000003e-16
C490 0 FILL_L10_2 2.4544200000000003e-16
C491 0 FILL_L10_3 2.4208900000000004e-16
C492 0 FILL_L50_0 1.6394300000000002e-17
C493 0 FILL_L50_1 1.6394300000000002e-17
C494 0 FILL_L50_2 1.6394300000000002e-17
C495 0 FILL_L50_3 9.6280700000000004e-19
C496 0 FILL_L50_4 2.19047e-18
C497 0 FILL_L50_5 2.19047e-18
C498 0 FILL_L50_6 2.19047e-18
C499 0 FILL_L50_7 2.3365e-19
C500 0 FILL_L8_0 3.7766599999999997e-17
C501 0 FILL_L8_1 3.7766599999999997e-17
C502 0 FILL_L8_2 3.7766599999999997e-17
C503 0 FILL_L8_3 3.7766599999999997e-17
C504 0 N 1.2018100000000002e-18
C505 0 P 9.5439600000000013e-19
C508 0 FILL_L50_12 1.0481100000000002e-18
C509 0 FILL_L50_16 2.7879800000000002e-18
C512 0 FILL_L50_12 3.0918500000000002e-18
C513 0 FILL_L50_16 1.0077000000000001e-17
C516 0 FILL_L50_12 7.0567200000000014e-18
C517 0 FILL_L50_16 2.0752900000000003e-17
C520 0 FILL_L50_12 1.2206500000000001e-18
C521 0 FILL_L50_13 1.0735500000000002e-18
C522 0 FILL_L50_16 7.4399100000000013e-18
C523 0 FILL_L50_17 3.04887e-18
C526 0 FILL_L50_13 6.0063100000000007e-18
C527 0 FILL_L50_17 1.17189e-17
C530 0 FILL_L50_13 1.1506500000000001e-17
C531 0 FILL_L50_17 1.93831e-17
C534 0 FILL_L50_13 7.887130000000001e-18
C535 0 FILL_L50_17 1.8932700000000001e-17
C537 0 FILL_L10_10 1.10466e-16
C538 0 FILL_L10_11 1.10466e-16
C539 0 FILL_L10_12 1.10466e-16
C540 0 FILL_L10_13 3.4745800000000005e-18
C541 0 FILL_L10_14 3.4745800000000005e-18
C542 0 FILL_L10_15 3.4745800000000005e-18
C543 0 FILL_L10_16 3.4745800000000005e-18
C544 0 FILL_L10_17 3.4745800000000005e-18
C545 0 FILL_L10_18 3.4745800000000005e-18
C546 0 FILL_L10_7 2.2228899999999999e-19
C547 0 FILL_L10_8 7.4845200000000004e-19
C548 0 FILL_L10_9 6.5863800000000004e-19
C549 0 FILL_L50_0 2.18921e-19
C550 0 FILL_L50_1 2.18921e-19
C551 0 FILL_L50_10 1.5245200000000003e-17
C552 0 FILL_L50_11 9.7569300000000008e-19
C553 0 FILL_L50_12 2.6095200000000001e-18
C554 0 FILL_L50_13 1.8184800000000001e-18
C555 0 FILL_L50_14 2.27311e-18
C556 0 FILL_L50_15 1.4547900000000001e-19
C557 0 FILL_L50_2 2.18921e-19
C558 0 FILL_L50_4 1.1734700000000001e-17
C559 0 FILL_L50_5 9.9548100000000001e-18
C560 0 FILL_L50_6 1.68661e-17
C561 0 FILL_L50_7 9.669180000000001e-19
C562 0 FILL_L50_8 1.8294200000000002e-17
C563 0 FILL_L50_9 1.21962e-17
C564 0 FILL_L8_0 8.348340000000001e-18
C565 0 FILL_L8_1 8.348340000000001e-18
C566 0 FILL_L8_10 1.0790500000000001e-17
C567 0 FILL_L8_11 1.0790500000000001e-17
C568 0 FILL_L8_12 2.9839000000000003e-17
C569 0 FILL_L8_13 2.9839000000000003e-17
C570 0 FILL_L8_14 2.9839000000000003e-17
C571 0 FILL_L8_15 2.9839000000000003e-17
C572 0 FILL_L8_16 2.9839000000000003e-17
C573 0 FILL_L8_17 2.9839000000000003e-17
C574 0 FILL_L8_18 2.9839000000000003e-17
C575 0 FILL_L8_19 2.9839000000000003e-17
C576 0 FILL_L8_2 8.348340000000001e-18
C577 0 FILL_L8_3 8.348340000000001e-18
C578 0 FILL_L8_4 1.0790500000000001e-17
C579 0 FILL_L8_5 1.0790500000000001e-17
C580 0 FILL_L8_6 1.0790500000000001e-17
C581 0 FILL_L8_7 1.0790500000000001e-17
C582 0 FILL_L8_8 1.0790500000000001e-17
C583 0 FILL_L8_9 1.0790500000000001e-17
C584 0 N 5.32824e-19
C585 0 P 7.1125800000000001e-19
C588 0 FILL_L50_13 7.887130000000001e-18
C589 0 FILL_L50_17 1.8932700000000001e-17
C592 0 FILL_L10_17 1.1489000000000001e-19
C593 0 FILL_L50_13 1.09285e-17
C594 0 FILL_L50_17 1.4560000000000003e-17
C597 0 FILL_L50_13 1.6825500000000001e-18
C598 0 FILL_L50_14 1.0980700000000002e-18
C599 0 FILL_L50_17 5.6467800000000004e-18
C600 0 FILL_L50_18 2.92087e-18
C603 0 FILL_L50_13 2.0172599999999999e-18
C604 0 FILL_L50_14 2.25915e-18
C605 0 FILL_L50_17 2.9934000000000002e-18
C606 0 FILL_L50_18 3.7081600000000003e-18
C609 0 FILL_L50_14 6.3674600000000005e-18
C610 0 FILL_L50_18 1.2470400000000001e-17
C613 0 FILL_L50_14 7.887130000000001e-18
C614 0 FILL_L50_18 1.9183e-17
C618 0 FILL_L50_14 1.2621700000000001e-17
C619 0 FILL_L50_18 1.5302000000000001e-17
C622 0 FILL_L50_14 7.4145600000000001e-18
C623 0 FILL_L50_18 1.5968600000000003e-17
C626 0 FILL_L50_14 1.11351e-17
C627 0 FILL_L50_18 1.4116400000000003e-17
C630 0 FILL_L50_14 1.1914800000000001e-18
C631 0 FILL_L50_15 1.1214800000000001e-18
C632 0 FILL_L50_18 4.8214100000000009e-18
C633 0 FILL_L50_19 2.9495000000000004e-18
C635 0 FILL_L50_14 1.9775300000000001e-18
C636 0 FILL_L50_15 2.3494400000000001e-18
C637 0 FILL_L50_18 3.0348300000000002e-18
C638 0 FILL_L50_19 4.3980800000000003e-18
C640 FILL_L10_0 FILL_L10_1 9.7773300000000019e-17
C641 FILL_L10_0 FILL_L10_4 9.7773300000000019e-17
C642 FILL_L10_0 FILL_L50_0 7.7306600000000014e-17
C643 FILL_L10_0 FILL_L8_0 1.4230000000000002e-17
C644 FILL_L10_0 0 5.3953800000000005e-16
C645 FILL_L10_1 FILL_L10_2 9.7773300000000019e-17
C646 FILL_L10_1 FILL_L10_5 9.7773300000000019e-17
C647 FILL_L10_1 FILL_L50_0 1.55573e-17
C648 FILL_L10_1 FILL_L50_1 5.5219700000000005e-17
C649 FILL_L10_1 FILL_L8_1 1.4230000000000002e-17
C650 FILL_L10_1 0 4.6531099999999998e-16
C651 FILL_L10_10 FILL_L10_11 9.7773300000000019e-17
C652 FILL_L10_10 FILL_L10_13 2.7935199999999999e-17
C653 FILL_L10_10 FILL_L10_14 2.7935199999999999e-17
C654 FILL_L10_10 FILL_L10_4 9.7773300000000019e-17
C655 FILL_L10_10 FILL_L50_12 1.46674e-18
C656 FILL_L10_10 FILL_L50_4 2.16433e-16
C657 FILL_L10_10 FILL_L50_8 3.5007500000000001e-17
C658 FILL_L10_10 FILL_L8_0 9.8589300000000015e-18
C659 FILL_L10_10 FILL_L8_4 1.1751300000000001e-16
C660 FILL_L10_10 FILL_L8_5 1.1751300000000001e-16
C661 FILL_L10_10 0 4.7710300000000005e-16
C662 FILL_L10_11 FILL_L10_12 9.7773300000000019e-17
C663 FILL_L10_11 FILL_L10_15 2.7935199999999999e-17
C664 FILL_L10_11 FILL_L10_16 2.7935199999999999e-17
C665 FILL_L10_11 FILL_L10_5 9.7773300000000019e-17
C666 FILL_L10_11 FILL_L50_13 4.8891300000000006e-19
C667 FILL_L10_11 FILL_L50_4 6.2229199999999999e-17
C668 FILL_L10_11 FILL_L50_5 1.65203e-16
C669 FILL_L10_11 FILL_L50_9 1.7475500000000002e-17
C670 FILL_L10_11 FILL_L8_1 9.8589300000000015e-18
C671 FILL_L10_11 FILL_L8_6 1.1751300000000001e-16
C672 FILL_L10_11 FILL_L8_7 1.1751300000000001e-16
C673 FILL_L10_11 0 4.0435800000000004e-16
C674 FILL_L10_12 FILL_L10_17 2.7935199999999999e-17
C675 FILL_L10_12 FILL_L10_18 2.7935199999999999e-17
C676 FILL_L10_12 FILL_L10_6 9.7773300000000019e-17
C677 FILL_L10_12 FILL_L10_8 2.7935199999999999e-17
C678 FILL_L10_12 FILL_L50_10 4.3547700000000009e-18
C679 FILL_L10_12 FILL_L50_5 1.3087799999999998e-16
C680 FILL_L10_12 FILL_L50_6 1.0357400000000001e-16
C681 FILL_L10_12 FILL_L50_7 1.6508800000000002e-19
C682 FILL_L10_12 FILL_L50_9 8.7095400000000018e-18
C683 FILL_L10_12 FILL_L8_2 9.8589300000000015e-18
C684 FILL_L10_12 FILL_L8_8 1.1751300000000001e-16
C685 FILL_L10_12 FILL_L8_9 1.1751300000000001e-16
C686 FILL_L10_12 0 4.5631900000000007e-16
C687 FILL_L10_13 FILL_L10_14 2.7935199999999999e-17
C688 FILL_L10_13 FILL_L50_8 2.2405100000000001e-17
C689 FILL_L10_13 FILL_L8_12 6.7224999999999998e-17
C690 FILL_L10_13 0 9.3964399999999999e-17
C691 FILL_L10_14 FILL_L10_15 2.7935199999999999e-17
C692 FILL_L10_14 FILL_L50_12 3.95711e-18
C693 FILL_L10_14 FILL_L50_8 5.6597300000000003e-17
C694 FILL_L10_14 FILL_L8_13 6.7224999999999998e-17
C695 FILL_L10_14 0 7.3275300000000013e-17
C696 FILL_L10_15 FILL_L10_16 2.7935199999999999e-17
C697 FILL_L10_15 FILL_L50_8 2.2405100000000001e-17
C698 FILL_L10_15 FILL_L50_9 1.1670500000000001e-17
C699 FILL_L10_15 FILL_L8_14 6.7224999999999998e-17
C700 FILL_L10_15 0 7.3182800000000002e-17
C701 FILL_L10_16 FILL_L10_17 2.7935199999999999e-17
C702 FILL_L10_16 FILL_L50_13 3.95711e-18
C703 FILL_L10_16 FILL_L50_9 5.0118000000000004e-17
C704 FILL_L10_16 FILL_L8_15 6.7224999999999998e-17
C705 FILL_L10_16 0 7.3181700000000015e-17
C706 FILL_L10_17 FILL_L10_18 2.7935199999999999e-17
C707 FILL_L10_17 FILL_L50_13 3.95711e-18
C708 FILL_L10_17 FILL_L50_9 4.6235799999999999e-17
C709 FILL_L10_17 FILL_L8_16 6.7224999999999998e-17
C710 FILL_L10_17 0 7.3405500000000003e-17
C711 FILL_L10_18 FILL_L50_10 4.1637000000000001e-17
C712 FILL_L10_18 FILL_L50_14 1.9785500000000002e-18
C713 FILL_L10_18 FILL_L50_9 3.8908000000000001e-18
C714 FILL_L10_18 FILL_L8_17 6.7224999999999998e-17
C715 FILL_L10_18 FILL_L8_18 5.7366599999999999e-18
C716 FILL_L10_18 0 7.9308400000000018e-17
C717 FILL_L10_2 FILL_L10_3 9.7773300000000019e-17
C718 FILL_L10_2 FILL_L10_6 9.7773300000000019e-17
C719 FILL_L10_2 FILL_L50_1 4.1998899999999999e-17
C720 FILL_L10_2 FILL_L50_2 2.8778099999999999e-17
C721 FILL_L10_2 FILL_L8_2 1.4230000000000002e-17
C722 FILL_L10_2 0 4.6531099999999998e-16
C723 FILL_L10_3 FILL_L10_7 9.7773300000000019e-17
C724 FILL_L10_3 FILL_L50_2 6.6495199999999997e-17
C725 FILL_L10_3 FILL_L50_3 7.8070500000000004e-18
C726 FILL_L10_3 FILL_L8_3 1.4230000000000002e-17
C727 FILL_L10_3 0 5.39179e-16
C728 FILL_L10_4 FILL_L10_5 9.7773300000000019e-17
C729 FILL_L10_4 FILL_L50_0 1.3691200000000002e-16
C730 FILL_L10_4 FILL_L50_4 9.3263200000000002e-17
C731 FILL_L10_4 FILL_L8_0 8.2350600000000007e-16
C732 FILL_L10_4 N 1.2429700000000002e-16
C733 FILL_L10_4 P 1.2429700000000002e-16
C734 FILL_L10_4 0 2.6896499999999997e-16
C735 FILL_L10_5 FILL_L10_6 9.7773300000000019e-17
C736 FILL_L10_5 FILL_L50_0 3.1114599999999999e-17
C737 FILL_L10_5 FILL_L50_1 9.9819000000000008e-17
C738 FILL_L10_5 FILL_L50_4 1.4312699999999999e-17
C739 FILL_L10_5 FILL_L50_5 6.4086900000000001e-17
C740 FILL_L10_5 FILL_L8_1 8.2350600000000007e-16
C741 FILL_L10_5 N 1.2561700000000001e-16
C742 FILL_L10_5 P 1.2561700000000001e-16
C743 FILL_L10_5 0 1.9621900000000002e-16
C744 FILL_L10_6 FILL_L10_7 9.7773300000000019e-17
C745 FILL_L10_6 FILL_L50_1 7.6917500000000007e-17
C746 FILL_L10_6 FILL_L50_2 5.4016e-17
C747 FILL_L10_6 FILL_L50_5 4.7495500000000004e-17
C748 FILL_L10_6 FILL_L50_6 3.0904100000000002e-17
C749 FILL_L10_6 FILL_L8_2 8.2350600000000007e-16
C750 FILL_L10_6 N 1.2561700000000001e-16
C751 FILL_L10_6 P 1.2561700000000001e-16
C752 FILL_L10_6 0 1.9621900000000002e-16
C753 FILL_L10_7 FILL_L10_8 2.7935199999999999e-17
C754 FILL_L10_7 FILL_L10_9 2.7935199999999999e-17
C755 FILL_L10_7 FILL_L50_10 9.7782500000000003e-19
C756 FILL_L10_7 FILL_L50_2 1.1883e-16
C757 FILL_L10_7 FILL_L50_3 1.5614100000000001e-17
C758 FILL_L10_7 FILL_L50_6 8.5908900000000013e-17
C759 FILL_L10_7 FILL_L50_7 7.1824900000000004e-18
C760 FILL_L10_7 FILL_L8_3 8.2350600000000007e-16
C761 FILL_L10_7 N 1.23696e-16
C762 FILL_L10_7 P 1.23696e-16
C763 FILL_L10_7 0 2.98858e-16
C764 FILL_L10_8 FILL_L10_9 2.7935199999999999e-17
C765 FILL_L10_8 FILL_L50_10 3.3484600000000006e-18
C766 FILL_L10_8 FILL_L50_6 5.8646000000000007e-17
C767 FILL_L10_8 FILL_L8_10 6.7224999999999998e-17
C768 FILL_L10_8 FILL_L8_18 1.2124200000000001e-18
C769 FILL_L10_8 0 7.2775499999999993e-17
C770 FILL_L10_9 FILL_L50_6 1.7023599999999999e-17
C771 FILL_L10_9 FILL_L50_7 1.1723300000000001e-17
C772 FILL_L10_9 FILL_L8_11 6.7224999999999998e-17
C773 FILL_L10_9 FILL_L8_19 1.0669300000000001e-18
C774 FILL_L10_9 0 9.2499500000000003e-17
C775 FILL_L50_0 FILL_L50_1 9.8854299999999996e-17
C776 FILL_L50_0 FILL_L50_4 9.8854299999999996e-17
C777 FILL_L50_0 FILL_L8_0 1.3629e-17
C778 FILL_L50_0 FILL_L8_1 4.2766800000000003e-18
C779 FILL_L50_0 N 1.1347200000000002e-17
C780 FILL_L50_0 P 6.9818800000000003e-18
C781 FILL_L50_0 0 2.1912600000000003e-16
C782 FILL_L50_1 FILL_L50_2 9.8854299999999996e-17
C783 FILL_L50_1 FILL_L50_5 9.8854299999999996e-17
C784 FILL_L50_1 FILL_L8_1 9.8880900000000008e-18
C785 FILL_L50_1 FILL_L8_2 8.0176200000000022e-18
C786 FILL_L50_1 N 1.1347200000000002e-17
C787 FILL_L50_1 P 6.9818800000000003e-18
C788 FILL_L50_1 0 1.3589e-16
C789 FILL_L50_10 FILL_L50_11 9.8854299999999996e-17
C790 FILL_L50_10 FILL_L50_14 9.8854299999999996e-17
C791 FILL_L50_10 FILL_L50_6 9.8854299999999996e-17
C792 FILL_L50_10 FILL_L50_9 9.8854299999999996e-17
C793 FILL_L50_10 FILL_L8_17 7.0224200000000015e-18
C794 FILL_L50_10 FILL_L8_18 2.6666100000000003e-17
C795 FILL_L50_10 FILL_L8_19 9.0805000000000019e-18
C796 FILL_L50_10 0 2.0445e-16
C797 FILL_L50_11 FILL_L50_15 3.9541700000000001e-18
C798 FILL_L50_11 FILL_L50_7 3.9541700000000001e-18
C799 FILL_L50_11 FILL_L8_19 6.8768600000000002e-18
C800 FILL_L50_11 0 1.4603800000000002e-16
C801 FILL_L50_12 FILL_L50_13 9.8854299999999996e-17
C802 FILL_L50_12 FILL_L50_16 9.8854299999999996e-17
C803 FILL_L50_12 FILL_L50_8 9.8854299999999996e-17
C804 FILL_L50_12 FILL_L8_13 1.5130200000000002e-18
C805 FILL_L50_12 0 3.2639000000000001e-16
C806 FILL_L50_13 FILL_L50_14 9.8854299999999996e-17
C807 FILL_L50_13 FILL_L50_17 9.8854299999999996e-17
C808 FILL_L50_13 FILL_L50_9 9.8854299999999996e-17
C809 FILL_L50_13 FILL_L8_15 1.5130200000000002e-18
C810 FILL_L50_13 FILL_L8_16 1.4222400000000001e-18
C811 FILL_L50_13 0 2.54667e-16
C812 FILL_L50_14 FILL_L50_15 9.8854299999999996e-17
C813 FILL_L50_14 FILL_L50_18 9.8854299999999996e-17
C814 FILL_L50_14 FILL_L8_17 7.5650800000000002e-19
C815 FILL_L50_14 FILL_L8_18 1.4676300000000002e-18
C816 FILL_L50_14 0 2.5198799999999999e-16
C817 FILL_L50_15 FILL_L50_19 3.9541700000000001e-18
C818 FILL_L50_15 0 1.5600800000000001e-16
C819 FILL_L50_16 FILL_L50_17 9.8854299999999996e-17
C820 FILL_L50_16 0 3.3002700000000001e-16
C821 FILL_L50_17 FILL_L50_18 9.8854299999999996e-17
C822 FILL_L50_17 0 2.5554499999999999e-16
C823 FILL_L50_18 FILL_L50_19 9.8854299999999996e-17
C824 FILL_L50_18 0 2.51506e-16
C825 FILL_L50_19 0 1.5030500000000001e-16
C826 FILL_L50_2 FILL_L50_3 9.8854299999999996e-17
C827 FILL_L50_2 FILL_L50_6 9.8854299999999996e-17
C828 FILL_L50_2 FILL_L8_2 6.1471500000000005e-18
C829 FILL_L50_2 FILL_L8_3 1.17586e-17
C830 FILL_L50_2 N 1.1347200000000002e-17
C831 FILL_L50_2 P 6.9818800000000003e-18
C832 FILL_L50_2 0 1.3958800000000001e-16
C833 FILL_L50_3 FILL_L50_7 3.9541700000000001e-18
C834 FILL_L50_3 FILL_L8_3 4.6933100000000006e-19
C835 FILL_L50_3 N 4.5388800000000003e-19
C836 FILL_L50_3 P 2.79275e-19
C837 FILL_L50_3 0 1.4068000000000002e-16
C838 FILL_L50_4 FILL_L50_5 9.8854299999999996e-17
C839 FILL_L50_4 FILL_L50_8 9.8854299999999996e-17
C840 FILL_L50_4 FILL_L8_0 1.2659000000000002e-17
C841 FILL_L50_4 FILL_L8_1 1.9672700000000003e-18
C842 FILL_L50_4 FILL_L8_5 8.5533600000000005e-18
C843 FILL_L50_4 FILL_L8_6 4.2766800000000003e-18
C844 FILL_L50_4 N 1.46777e-17
C845 FILL_L50_4 P 2.5466800000000001e-17
C846 FILL_L50_4 0 2.2269200000000001e-16
C847 FILL_L50_5 FILL_L50_6 9.8854299999999996e-17
C848 FILL_L50_5 FILL_L50_9 9.8854299999999996e-17
C849 FILL_L50_5 FILL_L8_1 8.382300000000002e-18
C850 FILL_L50_5 FILL_L8_2 6.2439600000000011e-18
C851 FILL_L50_5 FILL_L8_7 8.5533600000000005e-18
C852 FILL_L50_5 FILL_L8_8 8.5533600000000005e-18
C853 FILL_L50_5 N 1.46777e-17
C854 FILL_L50_5 P 2.5466800000000001e-17
C855 FILL_L50_5 0 1.3551400000000003e-16
C856 FILL_L50_6 FILL_L50_7 9.8854299999999996e-17
C857 FILL_L50_6 FILL_L8_10 1.4425200000000002e-17
C858 FILL_L50_6 FILL_L8_11 2.7810000000000005e-18
C859 FILL_L50_6 FILL_L8_2 4.1056100000000005e-18
C860 FILL_L50_6 FILL_L8_3 1.4588400000000002e-17
C861 FILL_L50_6 FILL_L8_9 6.4150200000000004e-18
C862 FILL_L50_6 N 1.46777e-17
C863 FILL_L50_6 P 2.5466800000000001e-17
C864 FILL_L50_6 0 1.8977600000000003e-16
C865 FILL_L50_7 FILL_L8_11 4.6933100000000006e-19
C866 FILL_L50_7 FILL_L8_3 2.1589200000000002e-19
C867 FILL_L50_7 N 5.8710600000000009e-19
C868 FILL_L50_7 P 1.01867e-18
C869 FILL_L50_7 0 1.56289e-16
C870 FILL_L50_8 FILL_L50_9 9.8854299999999996e-17
C871 FILL_L50_8 FILL_L8_12 4.2766800000000003e-18
C872 FILL_L50_8 FILL_L8_13 1.4044800000000001e-17
C873 FILL_L50_8 FILL_L8_14 4.2766800000000003e-18
C874 FILL_L50_8 0 2.7480000000000005e-16
C875 FILL_L50_9 FILL_L8_14 1.3407600000000001e-18
C876 FILL_L50_9 FILL_L8_15 1.12638e-17
C877 FILL_L50_9 FILL_L8_16 9.7681700000000009e-18
C878 FILL_L50_9 0 1.93545e-16
C879 FILL_L8_0 FILL_L8_1 6.96968e-17
C880 FILL_L8_0 FILL_L8_4 1.9913400000000001e-17
C881 FILL_L8_0 FILL_L8_5 1.9913400000000001e-17
C882 FILL_L8_0 N 2.5940300000000002e-18
C883 FILL_L8_0 P 2.5940300000000002e-18
C884 FILL_L8_0 0 8.5756400000000004e-16
C885 FILL_L8_1 FILL_L8_2 6.96968e-17
C886 FILL_L8_1 FILL_L8_6 1.9913400000000001e-17
C887 FILL_L8_1 FILL_L8_7 1.9913400000000001e-17
C888 FILL_L8_1 N 3.2205200000000002e-18
C889 FILL_L8_1 P 3.2205200000000002e-18
C890 FILL_L8_1 0 7.9950800000000011e-16
C891 FILL_L8_10 FILL_L8_11 1.9913400000000001e-17
C892 FILL_L8_10 FILL_L8_3 1.9913400000000001e-17
C893 FILL_L8_10 FILL_L8_9 1.9913400000000001e-17
C894 FILL_L8_10 0 1.34885e-16
C895 FILL_L8_11 FILL_L8_3 1.9913400000000001e-17
C896 FILL_L8_11 0 1.5147200000000001e-16
C897 FILL_L8_12 FILL_L8_13 1.9913400000000001e-17
C898 FILL_L8_12 0 1.5240600000000003e-16
C899 FILL_L8_13 FILL_L8_14 1.9913400000000001e-17
C900 FILL_L8_13 0 1.3581800000000002e-16
C901 FILL_L8_14 FILL_L8_15 1.9913400000000001e-17
C902 FILL_L8_14 0 1.3581800000000002e-16
C903 FILL_L8_15 FILL_L8_16 1.9913400000000001e-17
C904 FILL_L8_15 0 1.3581800000000002e-16
C905 FILL_L8_16 FILL_L8_17 1.9913400000000001e-17
C906 FILL_L8_16 0 1.3581800000000002e-16
C907 FILL_L8_17 FILL_L8_18 1.9913400000000001e-17
C908 FILL_L8_17 0 1.3581800000000002e-16
C909 FILL_L8_18 FILL_L8_19 1.9913400000000001e-17
C910 FILL_L8_18 0 1.3581800000000002e-16
C911 FILL_L8_19 0 1.5240600000000003e-16
C912 FILL_L8_2 FILL_L8_3 6.96968e-17
C913 FILL_L8_2 FILL_L8_8 1.9913400000000001e-17
C914 FILL_L8_2 FILL_L8_9 1.9913400000000001e-17
C915 FILL_L8_2 N 3.2205200000000002e-18
C916 FILL_L8_2 P 3.2205200000000002e-18
C917 FILL_L8_2 0 7.9950800000000011e-16
C918 FILL_L8_3 N 2.39681e-18
C919 FILL_L8_3 P 2.39681e-18
C920 FILL_L8_3 0 8.5756400000000004e-16
C921 FILL_L8_4 FILL_L8_5 1.9913400000000001e-17
C922 FILL_L8_4 0 1.5147200000000001e-16
C923 FILL_L8_5 FILL_L8_6 1.9913400000000001e-17
C924 FILL_L8_5 0 1.34885e-16
C925 FILL_L8_6 FILL_L8_7 1.9913400000000001e-17
C926 FILL_L8_6 0 1.34885e-16
C927 FILL_L8_7 FILL_L8_8 1.9913400000000001e-17
C928 FILL_L8_7 0 1.34885e-16
C929 FILL_L8_8 FILL_L8_9 1.9913400000000001e-17
C930 FILL_L8_8 0 1.34885e-16
C931 FILL_L8_9 0 1.34885e-16
C932 N P 4.3061700000000003e-15
C933 N 0 4.5125100000000007e-17
C934 P 0 4.5125100000000007e-17
VP P 0 DC 0 AC 0
VN N 0 DC 0 AC 1
.control
set numdgt=17
ac lin 1 1Meg 1Meg
let cp = -imag(i(VP))/(2*pi*1e6)
let cn = -imag(i(VN))/(2*pi*1e6)
print cp cn
quit
.endc
.end
