* cell sense_fill_clip
.SUBCKT sense_fill_clip
* net 1 CTX_L8_0
* net 2 CTX_L8_1
* net 3 CTX_L8_2
* net 4 CTX_L10_0,CTX_L30_7
* net 5 CTX_L30_0
* net 6 CTX_L30_1
* net 7 CTX_L30_2
* net 8 CTX_L30_3
* net 9 N
* net 10 P
* net 11 CTX_L30_6
* net 12 CTX_L134_0
* net 13 CTX_L134_1
.ENDS sense_fill_clip
