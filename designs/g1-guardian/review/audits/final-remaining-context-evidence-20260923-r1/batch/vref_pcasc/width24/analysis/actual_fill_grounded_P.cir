* actual_fill grounded drive P; diagnostic capacitor-network AC only
C84 0 N 1.75443e-17
C85 0 P 1.7075400000000001e-17
C148 0 N 4.3061700000000003e-15
C173 0 P 4.3061700000000003e-15
C200 0 N 1.2018100000000002e-18
C201 0 P 9.5439600000000013e-19
C246 0 N 5.32824e-19
C247 0 P 7.1125800000000001e-19
C335 0 N 1.2429700000000002e-16
C336 0 P 1.2429700000000002e-16
C344 0 N 1.2561700000000001e-16
C345 0 P 1.2561700000000001e-16
C353 0 N 1.2561700000000001e-16
C354 0 P 1.2561700000000001e-16
C364 0 N 1.23696e-16
C365 0 P 1.23696e-16
C382 0 N 1.1347200000000002e-17
C383 0 P 6.9818800000000003e-18
C389 0 N 1.1347200000000002e-17
C390 0 P 6.9818800000000003e-18
C406 0 N 1.1347200000000002e-17
C407 0 P 6.9818800000000003e-18
C411 0 N 4.5388800000000003e-19
C412 0 P 2.79275e-19
C420 0 N 1.46777e-17
C421 0 P 2.5466800000000001e-17
C429 0 N 1.46777e-17
C430 0 P 2.5466800000000001e-17
C438 0 N 1.46777e-17
C439 0 P 2.5466800000000001e-17
C443 0 N 5.8710600000000009e-19
C444 0 P 1.01867e-18
C458 0 N 2.5940300000000002e-18
C459 0 P 2.5940300000000002e-18
C464 0 N 3.2205200000000002e-18
C465 0 P 3.2205200000000002e-18
C491 0 N 3.2205200000000002e-18
C492 0 P 3.2205200000000002e-18
C494 0 N 2.39681e-18
C495 0 P 2.39681e-18
C508 N P 4.3061700000000003e-15
C509 N 0 4.5125100000000007e-17
C510 P 0 4.5125100000000007e-17
VP P 0 DC 0 AC 1
VN N 0 DC 0 AC 0
.control
set numdgt=17
ac lin 1 1Meg 1Meg
let cp = -imag(i(VP))/(2*pi*1e6)
let cn = -imag(i(VN))/(2*pi*1e6)
print cp cn
quit
.endc
.end
