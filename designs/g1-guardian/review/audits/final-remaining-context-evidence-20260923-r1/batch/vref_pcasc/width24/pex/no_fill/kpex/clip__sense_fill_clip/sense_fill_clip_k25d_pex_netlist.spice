*********************************************************
*** NGSPICE file created by KLayout-PEX 0.3.12
*** -----------------------------------------------------
***     Extraction Engine: KPEX/2.5D
***     Technology: ihp_sg13g2
***     Date: 2026-09-23 06:34:21
*********************************************************

.SUBCKT sense_fill_clip
Cext_1 CTX_L10_0|CTX_L30_7 CTX_L30_6 153.322a
Cext_2 CTX_L10_0|CTX_L30_7 CTX_L8_2 342.515a
Cext_3 CTX_L10_0|CTX_L30_7 VSUBS 2.07606f
Cext_4 CTX_L134_0 CTX_L134_1 632.067a
Cext_5 CTX_L134_0 CTX_L30_0 300.97a
Cext_6 CTX_L134_0 CTX_L8_0 19.4324a
Cext_7 CTX_L134_0 CTX_L8_1 0.228385a
Cext_8 CTX_L134_0 VSUBS 816.763a
Cext_9 CTX_L134_1 CTX_L30_0 308.772a
Cext_10 CTX_L134_1 CTX_L30_1 193.757a
Cext_11 CTX_L134_1 CTX_L30_2 22.6882a
Cext_12 CTX_L134_1 CTX_L30_3 17.9889a
Cext_13 CTX_L134_1 CTX_L30_6 16.5879a
Cext_14 CTX_L134_1 CTX_L8_0 3.06541a
Cext_15 CTX_L134_1 CTX_L8_1 2.28351a
Cext_16 CTX_L134_1 N 17.5443a
Cext_17 CTX_L134_1 P 17.0754a
Cext_18 CTX_L134_1 VSUBS 858.872a
Cext_19 CTX_L30_0 CTX_L30_1 1.24559f
Cext_20 CTX_L30_0 CTX_L8_0 168.654a
Cext_21 CTX_L30_0 CTX_L8_1 131.514a
Cext_22 CTX_L30_0 VSUBS 1.65573f
Cext_23 CTX_L30_1 CTX_L30_2 1.26652f
Cext_24 CTX_L30_1 CTX_L8_0 13.7891a
Cext_25 CTX_L30_1 CTX_L8_1 322.601a
Cext_26 CTX_L30_1 VSUBS 719.344a
Cext_27 CTX_L30_2 CTX_L30_3 279.622a
Cext_28 CTX_L30_2 CTX_L8_1 16.8702a
Cext_29 CTX_L30_2 VSUBS 482.488a
Cext_30 CTX_L30_3 CTX_L8_1 4.77902a
Cext_31 CTX_L30_3 CTX_L8_2 2.11758a
Cext_32 CTX_L30_3 N 4.30617f
Cext_33 CTX_L30_3 VSUBS 425.208a
Cext_34 CTX_L30_6 CTX_L8_1 3.12869a
Cext_35 CTX_L30_6 CTX_L8_2 3.0159a
Cext_36 CTX_L30_6 P 4.30617f
Cext_37 CTX_L30_6 VSUBS 592.195a
Cext_38 CTX_L8_0 CTX_L8_1 83.3964a
Cext_39 CTX_L8_0 VSUBS 1.62582f
Cext_40 CTX_L8_1 N 4.11579a
Cext_41 CTX_L8_1 P 3.57452a
Cext_42 CTX_L8_1 VSUBS 1.76353f
Cext_43 CTX_L8_2 N 2.36811a
Cext_44 CTX_L8_2 P 2.66389a
Cext_45 CTX_L8_2 VSUBS 1.78611f
Cext_46 N P 4.30617f
Cext_47 N VSUBS 121.155a
Cext_48 P VSUBS 121.155a
.ENDS sense_fill_clip
