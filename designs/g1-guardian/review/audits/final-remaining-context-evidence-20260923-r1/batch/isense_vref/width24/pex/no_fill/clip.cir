* cell sense_fill_clip
.SUBCKT sense_fill_clip
* net 1 CTX_L8_0
* net 2 CTX_L30_0
* net 3 CTX_L30_1
* net 4 CTX_L30_2
* net 5 CTX_L30_3
* net 6 CTX_L30_4
* net 7 CTX_L30_5
* net 8 CTX_L30_6
* net 9 CTX_L30_7
* net 10 CTX_L30_8
* net 11 CTX_L30_9
* net 12 N
* net 13 P
* net 14 CTX_L67_2
* net 15 CTX_L67_3
* net 16 CTX_L67_4
* net 17 CTX_L67_5
* net 18 CTX_L67_6
* net 19 CTX_L67_7
* net 20 CTX_L126_0,CTX_L134_0
* net 21 CTX_L134_1
.ENDS sense_fill_clip
