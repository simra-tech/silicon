* actual_fill grounded drive P; diagnostic capacitor-network AC only
C74 0 N 1.5677500000000002e-16
C75 0 P 1.7791999999999999e-16
C157 0 N 7.9258700000000005e-17
C158 0 P 2.8016300000000004e-17
C212 0 N 8.5401399999999999e-17
C213 0 P 3.1315100000000004e-17
C255 0 N 3.5494500000000008e-18
C256 0 P 4.1112900000000009e-18
C493 0 P 2.3926600000000002e-16
C643 0 N 6.1807400000000003e-18
C644 0 P 2.7790300000000004e-18
C672 0 N 3.3692000000000002e-17
C673 0 P 1.80546e-18
C688 0 N 1.9775600000000001e-17
C689 0 P 2.7474300000000001e-18
C705 0 N 1.07854e-17
C706 0 P 2.7081900000000002e-18
C722 0 N 2.8609500000000002e-17
C723 0 P 2.7474300000000001e-18
C732 0 N 2.4872600000000001e-17
C733 0 P 8.634800000000001e-19
C742 0 N 1.6079600000000001e-18
C743 0 P 2.8848300000000001e-17
C755 0 N 2.3630000000000001e-18
C756 0 P 1.1573600000000001e-17
C765 0 N 2.41194e-18
C766 0 P 2.5842100000000002e-18
C777 0 N 2.4469000000000001e-18
C778 0 P 2.0705300000000003e-17
C786 0 N 6.9911300000000001e-19
C787 0 P 2.2449400000000003e-17
C884 0 N 1.0953100000000001e-17
C896 0 N 1.2611500000000001e-17
C908 0 N 1.1473699999999999e-17
C921 0 N 1.3749200000000001e-17
C928 0 N 6.6644100000000003e-18
C954 0 N 1.6494e-16
C955 0 P 2.5809699999999999e-16
C963 0 N 1.3940700000000002e-17
C964 0 P 1.5803800000000002e-17
C1001 0 N 9.9727800000000003e-19
C1002 0 P 1.1720400000000001e-18
C1008 0 N 1.2466e-18
C1009 0 P 1.4650500000000002e-18
C1013 0 N 1.2466e-18
C1014 0 P 1.4650500000000002e-18
C1018 0 N 1.2466e-18
C1019 0 P 1.4650500000000002e-18
C1025 0 N 1.1842699999999999e-18
C1026 0 P 1.3918e-18
C1030 0 N 1.2466e-18
C1031 0 P 1.4650500000000002e-18
C1036 0 N 1.2466e-18
C1037 0 P 1.4650500000000002e-18
C1083 0 N 5.6019600000000004e-19
C1087 0 N 2.7309600000000002e-18
C1096 0 N 6.8059000000000009e-18
C1097 0 P 8.4701999999999998e-17
C1104 0 N 6.892050000000001e-18
C1105 0 P 8.4701999999999998e-17
C1129 0 N 2.7659700000000002e-18
C1132 0 N 2.8009800000000001e-18
C1136 0 N 2.4985800000000002e-17
C1137 0 P 2.07321e-18
C1145 0 N 1.2492900000000002e-16
C1146 0 P 1.0366100000000001e-17
C1153 0 N 1.2492900000000002e-16
C1154 0 P 1.0366100000000001e-17
C1160 0 N 1.2492900000000002e-16
C1161 0 P 1.0366100000000001e-17
C1166 0 N 1.37841e-18
C1167 0 P 1.6940400000000003e-17
C1172 0 N 6.892050000000001e-18
C1173 0 P 8.4701999999999998e-17
C1193 0 N 3.0723200000000002e-19
C1194 0 P 3.0386700000000001e-19
C1198 0 N 3.3795500000000002e-19
C1199 0 P 3.3425400000000004e-19
C1203 0 N 3.8404000000000001e-19
C1204 0 P 3.7983400000000005e-19
C1208 0 N 3.8404000000000001e-19
C1209 0 P 3.7983400000000005e-19
C1213 0 N 3.6483800000000001e-19
C1214 0 P 3.6084200000000004e-19
C1218 0 N 3.8404000000000001e-19
C1219 0 P 3.7983400000000005e-19
C1223 0 N 3.8404000000000001e-19
C1224 0 P 3.7983400000000005e-19
C1231 0 N 3.8404000000000001e-19
C1232 0 P 3.7983400000000005e-19
C1236 0 N 6.4988100000000013e-19
C1237 0 P 7.7827700000000009e-19
C1241 0 N 1.2069200000000002e-18
C1242 0 P 1.2526600000000002e-18
C1246 0 N 1.23192e-18
C1247 0 P 1.2786000000000001e-18
C1251 0 N 1.2497700000000001e-18
C1252 0 P 1.29713e-18
C1255 0 N 3.5707800000000001e-19
C1256 0 P 3.7060800000000002e-19
C1293 N P 4.4090500000000001e-15
C1294 N 0 1.9477200000000002e-16
C1295 P 0 1.8219300000000004e-16
VP P 0 DC 0 AC 1
VN N 0 DC 0 AC 0
.control
set numdgt=17
ac lin 1 1Meg 1Meg
let cp = -imag(i(VP))/(2*pi*1e6)
let cn = -imag(i(VN))/(2*pi*1e6)
print cp cn
quit
.endc
.end
