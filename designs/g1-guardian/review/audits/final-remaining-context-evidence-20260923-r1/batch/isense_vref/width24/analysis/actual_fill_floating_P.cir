* actual_fill floating drive P; diagnostic capacitor-network AC only
C15 0 FILL_L10_0 1.1828900000000002e-17
C16 0 FILL_L10_1 3.8031700000000001e-17
C17 0 FILL_L10_10 7.9345300000000006e-17
C18 0 FILL_L10_11 3.5804000000000005e-17
C19 0 FILL_L10_12 2.8683900000000003e-18
C20 0 FILL_L10_13 9.3412400000000013e-18
C21 0 FILL_L10_14 1.19226e-17
C22 0 FILL_L10_15 5.5580800000000012e-17
C23 0 FILL_L10_16 2.3812700000000003e-17
C24 0 FILL_L10_2 3.5132100000000001e-17
C25 0 FILL_L10_20 4.9870300000000005e-17
C26 0 FILL_L10_21 6.18354e-18
C27 0 FILL_L10_25 5.3000499999999998e-18
C28 0 FILL_L10_26 2.4361400000000002e-18
C29 0 FILL_L10_3 4.1517600000000002e-17
C30 0 FILL_L10_4 2.07777e-17
C31 0 FILL_L10_5 8.4743500000000008e-17
C32 0 FILL_L10_6 8.3331000000000007e-17
C33 0 FILL_L10_7 5.7422100000000008e-17
C34 0 FILL_L10_8 5.2158200000000003e-17
C35 0 FILL_L10_9 3.4006700000000006e-17
C36 0 FILL_L126_0 1.8998900000000001e-16
C37 0 FILL_L126_1 2.0038600000000001e-18
C38 0 FILL_L126_2 5.5144300000000005e-18
C39 0 FILL_L126_3 2.0205500000000002e-17
C40 0 FILL_L30_1 3.7334100000000002e-17
C41 0 FILL_L30_11 7.4668200000000005e-18
C42 0 FILL_L30_12 1.1958399999999999e-17
C43 0 FILL_L30_2 2.9867300000000004e-17
C44 0 FILL_L30_3 2.4319700000000002e-17
C45 0 FILL_L30_4 4.67744e-18
C46 0 FILL_L30_5 1.2756000000000001e-17
C47 0 FILL_L50_0 2.7930199999999999e-17
C48 0 FILL_L50_1 4.3349600000000002e-16
C49 0 FILL_L50_10 6.3755499999999996e-17
C50 0 FILL_L50_12 1.8717600000000003e-17
C51 0 FILL_L50_13 7.0203800000000005e-17
C52 0 FILL_L50_2 3.3779700000000003e-16
C53 0 FILL_L50_3 3.0717800000000001e-16
C54 0 FILL_L50_4 9.4478800000000015e-17
C55 0 FILL_L50_5 4.3161800000000002e-16
C56 0 FILL_L50_6 8.6503900000000013e-17
C57 0 FILL_L50_7 4.2979900000000003e-17
C58 0 FILL_L50_8 1.1553200000000001e-16
C59 0 FILL_L50_9 3.5851400000000005e-16
C60 0 FILL_L8_1 2.3256300000000002e-18
C61 0 FILL_L8_10 1.9168900000000001e-18
C62 0 FILL_L8_12 1.9168900000000001e-18
C63 0 FILL_L8_13 1.9604700000000001e-18
C64 0 FILL_L8_14 8.5006800000000012e-19
C65 0 FILL_L8_2 1.59293e-18
C66 0 FILL_L8_21 3.8387999999999999e-18
C67 0 FILL_L8_22 2.1348e-18
C68 0 FILL_L8_26 3.6138799999999999e-19
C69 0 FILL_L8_3 2.56139e-18
C70 0 FILL_L8_4 2.30027e-18
C71 0 FILL_L8_5 1.2701100000000002e-18
C72 0 FILL_L8_6 5.5877700000000002e-19
C73 0 FILL_L8_7 9.5844500000000003e-19
C74 0 N 1.5677500000000002e-16
C75 0 P 1.7791999999999999e-16
C94 0 FILL_L10_11 1.0673400000000002e-17
C95 0 FILL_L10_12 8.7395000000000004e-18
C96 0 FILL_L10_13 3.3382199999999998e-17
C97 0 FILL_L10_14 3.9181000000000001e-17
C98 0 FILL_L10_16 9.4210499999999996e-18
C99 0 FILL_L10_17 1.60131e-18
C100 0 FILL_L10_19 4.3440800000000007e-17
C101 0 FILL_L10_2 1.20231e-17
C102 0 FILL_L10_20 2.0580600000000003e-17
C103 0 FILL_L10_21 2.6124000000000001e-17
C104 0 FILL_L10_22 1.3575000000000001e-17
C105 0 FILL_L10_23 9.3166899999999994e-18
C106 0 FILL_L10_24 2.14851e-17
C107 0 FILL_L10_25 5.4569700000000003e-18
C108 0 FILL_L10_26 1.21146e-17
C109 0 FILL_L10_27 1.3770300000000001e-17
C110 0 FILL_L10_28 1.6208300000000003e-17
C111 0 FILL_L10_29 4.8748400000000002e-18
C112 0 FILL_L10_3 1.5962600000000002e-17
C113 0 FILL_L10_4 5.4728899999999998e-18
C114 0 FILL_L10_6 9.8655600000000004e-18
C115 0 FILL_L10_7 2.6044800000000002e-17
C116 0 FILL_L10_8 5.2935000000000004e-17
C117 0 FILL_L10_9 2.5903099999999999e-17
C118 0 FILL_L126_0 1.0151699999999999e-15
C119 0 FILL_L126_1 5.5398000000000007e-17
C120 0 FILL_L126_2 3.1691300000000003e-18
C121 0 FILL_L126_3 1.8365300000000002e-17
C122 0 FILL_L126_4 4.3092199999999999e-17
C123 0 FILL_L30_10 3.13461e-18
C124 0 FILL_L30_2 8.1142500000000013e-18
C125 0 FILL_L30_3 5.9051700000000008e-18
C126 0 FILL_L30_8 5.4095000000000011e-18
C127 0 FILL_L30_9 4.2044400000000003e-18
C128 0 FILL_L50_10 8.9184600000000012e-17
C129 0 FILL_L50_11 9.1397099999999996e-17
C130 0 FILL_L50_12 1.58319e-17
C131 0 FILL_L50_13 1.2591300000000001e-16
C132 0 FILL_L50_14 1.49933e-16
C133 0 FILL_L50_15 1.21648e-16
C134 0 FILL_L50_2 4.2576000000000005e-17
C135 0 FILL_L50_3 4.9086300000000007e-17
C136 0 FILL_L50_5 3.4193300000000004e-17
C137 0 FILL_L50_6 1.14195e-16
C138 0 FILL_L50_7 1.6209299999999999e-16
C139 0 FILL_L50_8 1.22549e-18
C140 0 FILL_L50_9 4.3342300000000004e-17
C141 0 FILL_L8_10 8.5238000000000012e-19
C142 0 FILL_L8_11 2.8883900000000003e-19
C143 0 FILL_L8_12 8.5238000000000012e-19
C144 0 FILL_L8_17 2.5709100000000003e-19
C145 0 FILL_L8_2 3.9173900000000003e-19
C146 0 FILL_L8_23 8.3188800000000006e-19
C147 0 FILL_L8_28 4.4871800000000004e-19
C148 0 FILL_L8_29 9.7203900000000013e-19
C149 0 FILL_L8_3 3.9173900000000003e-19
C150 0 FILL_L8_30 5.2146899999999999e-19
C151 0 FILL_L8_31 1.9779900000000003e-19
C152 0 FILL_L8_32 3.9559700000000001e-19
C153 0 FILL_L8_33 6.4734100000000012e-19
C154 0 FILL_L8_34 4.49542e-19
C155 0 FILL_L8_4 1.5262600000000003e-19
C156 0 FILL_L8_9 2.7439700000000003e-19
C157 0 N 7.9258700000000005e-17
C158 0 P 2.8016300000000004e-17
C162 0 FILL_L10_10 1.5964800000000001e-16
C163 0 FILL_L10_11 2.4559400000000003e-16
C164 0 FILL_L10_12 2.4559400000000003e-16
C165 0 FILL_L10_13 2.4559400000000003e-16
C166 0 FILL_L10_14 8.5946600000000005e-17
C167 0 FILL_L10_15 1.3590900000000001e-17
C168 0 FILL_L10_16 2.26515e-17
C169 0 FILL_L10_17 1.8121200000000002e-17
C170 0 FILL_L10_18 2.26515e-17
C171 0 FILL_L10_19 1.0872700000000001e-17
C172 0 FILL_L10_5 3.3993500000000003e-18
C173 0 FILL_L10_6 3.7452899999999999e-18
C174 0 FILL_L10_7 2.61218e-18
C175 0 FILL_L10_8 4.2253699999999999e-18
C176 0 FILL_L10_9 2.7194800000000002e-18
C177 0 FILL_L126_0 7.2318400000000002e-17
C178 0 FILL_L126_1 7.02147e-18
C179 0 FILL_L30_1 1.2445600000000001e-17
C180 0 FILL_L30_10 1.2333600000000002e-17
C181 0 FILL_L30_11 1.8213400000000002e-17
C182 0 FILL_L30_12 2.2766800000000001e-17
C183 0 FILL_L30_13 2.2766800000000001e-17
C184 0 FILL_L30_14 2.2766800000000001e-17
C185 0 FILL_L30_15 2.2766800000000001e-17
C186 0 FILL_L30_16 2.2766800000000001e-17
C187 0 FILL_L30_17 2.2766800000000001e-17
C188 0 FILL_L30_2 1.2445600000000001e-17
C189 0 FILL_L30_3 1.2445600000000001e-17
C190 0 FILL_L30_4 9.866840000000001e-18
C191 0 FILL_L30_5 1.2333600000000002e-17
C192 0 FILL_L30_6 1.2333600000000002e-17
C193 0 FILL_L30_7 1.2333600000000002e-17
C194 0 FILL_L30_8 1.2333600000000002e-17
C195 0 FILL_L30_9 1.2333600000000002e-17
C196 0 FILL_L50_10 1.99285e-17
C197 0 FILL_L50_11 1.9994399999999999e-17
C198 0 FILL_L50_4 3.2723900000000005e-17
C199 0 FILL_L50_5 1.6665300000000001e-16
C200 0 FILL_L50_6 1.6665300000000001e-16
C201 0 FILL_L50_7 1.6665300000000001e-16
C202 0 FILL_L50_8 1.0536700000000002e-18
C203 0 FILL_L50_9 1.9994399999999999e-17
C204 0 FILL_L8_13 1.6102600000000001e-18
C205 0 FILL_L8_14 1.6102600000000001e-18
C206 0 FILL_L8_15 1.6102600000000001e-18
C207 0 FILL_L8_16 1.6102600000000001e-18
C208 0 FILL_L8_17 1.6102600000000001e-18
C209 0 FILL_L8_18 1.6102600000000001e-18
C210 0 FILL_L8_19 1.6102600000000001e-18
C211 0 FILL_L8_20 1.6102600000000001e-18
C212 0 N 8.5401399999999999e-17
C213 0 P 3.1315100000000004e-17
C217 0 FILL_L10_10 1.4679600000000001e-19
C218 0 FILL_L10_11 3.4497e-19
C219 0 FILL_L10_12 2.7524199999999999e-19
C220 0 FILL_L10_13 2.8441600000000004e-19
C221 0 FILL_L10_14 1.8349399999999999e-19
C222 0 FILL_L10_15 1.1163200000000001e-16
C223 0 FILL_L10_16 1.7043400000000001e-16
C224 0 FILL_L10_17 1.69147e-16
C225 0 FILL_L10_18 1.7043400000000001e-16
C226 0 FILL_L10_19 5.9316699999999998e-17
C227 0 FILL_L10_20 3.64777e-18
C228 0 FILL_L10_21 5.5509600000000002e-18
C229 0 FILL_L10_22 5.4716600000000002e-18
C230 0 FILL_L10_23 5.5509600000000002e-18
C231 0 FILL_L10_24 1.9031899999999999e-18
C232 0 FILL_L126_0 3.2415300000000007e-17
C233 0 FILL_L126_1 1.3458300000000002e-18
C234 0 FILL_L30_11 1.1985400000000001e-17
C235 0 FILL_L30_12 1.4981700000000001e-17
C236 0 FILL_L30_13 1.4981700000000001e-17
C237 0 FILL_L30_14 1.4981700000000001e-17
C238 0 FILL_L30_15 1.4981700000000001e-17
C239 0 FILL_L30_16 1.4981700000000001e-17
C240 0 FILL_L30_17 1.4981700000000001e-17
C241 0 FILL_L50_10 2.44863e-16
C242 0 FILL_L50_11 2.4353000000000003e-16
C243 0 FILL_L50_8 5.3026300000000003e-17
C244 0 FILL_L50_9 2.44863e-16
C245 0 FILL_L8_21 2.7457500000000002e-18
C246 0 FILL_L8_22 4.2711700000000001e-18
C247 0 FILL_L8_23 4.2711700000000001e-18
C248 0 FILL_L8_24 4.2711700000000001e-18
C249 0 FILL_L8_25 1.4644000000000001e-18
C250 0 FILL_L8_26 2.0406600000000001e-18
C251 0 FILL_L8_27 3.1053500000000002e-18
C252 0 FILL_L8_28 3.0609799999999999e-18
C253 0 FILL_L8_29 3.1053500000000002e-18
C254 0 FILL_L8_30 8.8724200000000009e-19
C255 0 N 3.5494500000000008e-18
C256 0 P 4.1112900000000009e-18
C260 0 FILL_L10_15 9.6212600000000008e-18
C261 0 FILL_L10_16 1.4641000000000001e-17
C262 0 FILL_L10_17 1.4641000000000001e-17
C263 0 FILL_L10_18 1.4641000000000001e-17
C264 0 FILL_L10_19 5.0197900000000011e-18
C265 0 FILL_L10_20 6.1244300000000011e-18
C266 0 FILL_L10_21 9.3197800000000008e-18
C267 0 FILL_L10_22 9.3197800000000008e-18
C268 0 FILL_L10_23 9.3197800000000008e-18
C269 0 FILL_L10_24 3.1953500000000001e-18
C270 0 FILL_L126_0 5.9269400000000001e-18
C271 0 FILL_L50_10 6.9983199999999996e-17
C272 0 FILL_L50_11 6.9850000000000003e-17
C273 0 FILL_L50_12 8.5573100000000008e-19
C274 0 FILL_L50_13 4.2786600000000005e-18
C275 0 FILL_L50_14 4.2251700000000005e-18
C276 0 FILL_L50_15 4.2786600000000005e-18
C277 0 FILL_L50_8 1.4485200000000001e-17
C278 0 FILL_L50_9 6.9983199999999996e-17
C279 0 FILL_L8_21 2.5760400000000001e-18
C280 0 FILL_L8_22 4.0071700000000005e-18
C281 0 FILL_L8_23 4.0071700000000005e-18
C282 0 FILL_L8_24 4.0071700000000005e-18
C283 0 FILL_L8_25 1.3738900000000001e-18
C284 0 FILL_L8_26 2.3906999999999999e-18
C285 0 FILL_L8_27 3.6380300000000002e-18
C286 0 FILL_L8_28 3.58606e-18
C287 0 FILL_L8_29 3.6380300000000002e-18
C288 0 FILL_L8_30 1.2473200000000002e-18
C292 0 FILL_L10_15 5.5187900000000005e-18
C293 0 FILL_L10_16 8.3981600000000015e-18
C294 0 FILL_L10_17 8.3981600000000015e-18
C295 0 FILL_L10_18 8.3981600000000015e-18
C296 0 FILL_L10_19 2.8793700000000003e-18
C297 0 FILL_L10_20 1.06466e-17
C298 0 FILL_L10_21 1.62013e-17
C299 0 FILL_L10_22 1.62013e-17
C300 0 FILL_L10_23 1.62013e-17
C301 0 FILL_L10_24 5.5547200000000004e-18
C302 0 FILL_L126_0 8.5807900000000016e-18
C303 0 FILL_L50_10 2.4852000000000003e-17
C304 0 FILL_L50_11 2.4852000000000003e-17
C305 0 FILL_L50_12 1.42651e-18
C306 0 FILL_L50_13 7.1325700000000009e-18
C307 0 FILL_L50_14 7.0434200000000001e-18
C308 0 FILL_L50_15 7.1325700000000009e-18
C309 0 FILL_L50_8 4.9704100000000007e-18
C310 0 FILL_L50_9 2.4852000000000003e-17
C311 0 FILL_L8_21 2.2755800000000002e-18
C312 0 FILL_L8_22 3.5397900000000005e-18
C313 0 FILL_L8_23 3.5397900000000005e-18
C314 0 FILL_L8_24 3.5397900000000005e-18
C315 0 FILL_L8_25 1.2136400000000002e-18
C316 0 FILL_L8_26 2.6793200000000003e-18
C317 0 FILL_L8_27 4.0772300000000001e-18
C318 0 FILL_L8_28 4.0189900000000002e-18
C319 0 FILL_L8_29 4.0772300000000001e-18
C320 0 FILL_L8_30 1.39791e-18
C324 0 FILL_L10_15 2.9664000000000003e-18
C325 0 FILL_L10_16 4.6143900000000009e-18
C326 0 FILL_L10_17 4.6143900000000009e-18
C327 0 FILL_L10_18 4.6143900000000009e-18
C328 0 FILL_L10_19 1.58208e-18
C329 0 FILL_L10_20 3.9451399999999999e-17
C330 0 FILL_L10_21 6.0300000000000001e-17
C331 0 FILL_L10_22 6.0300000000000001e-17
C332 0 FILL_L10_23 6.0300000000000001e-17
C333 0 FILL_L10_24 2.0848600000000002e-17
C334 0 FILL_L126_0 8.6692500000000003e-18
C335 0 FILL_L50_10 1.4296099999999999e-17
C336 0 FILL_L50_11 1.4296099999999999e-17
C337 0 FILL_L50_12 2.3270300000000004e-18
C338 0 FILL_L50_13 1.1635100000000001e-17
C339 0 FILL_L50_14 1.1635100000000001e-17
C340 0 FILL_L50_15 1.1635100000000001e-17
C341 0 FILL_L50_8 2.8592300000000005e-18
C342 0 FILL_L50_9 1.4296099999999999e-17
C343 0 FILL_L8_21 1.7448100000000003e-18
C344 0 FILL_L8_22 2.7141400000000002e-18
C345 0 FILL_L8_23 2.7141400000000002e-18
C346 0 FILL_L8_24 2.6366000000000003e-18
C347 0 FILL_L8_25 8.5301600000000009e-19
C348 0 FILL_L8_26 2.6968600000000001e-18
C349 0 FILL_L8_27 4.1809300000000006e-18
C350 0 FILL_L8_28 4.1258100000000005e-18
C351 0 FILL_L8_29 4.1809300000000006e-18
C352 0 FILL_L8_30 1.4840700000000001e-18
C357 0 FILL_L10_20 8.0805400000000015e-17
C358 0 FILL_L10_21 1.2561700000000001e-16
C359 0 FILL_L10_22 1.2561700000000001e-16
C360 0 FILL_L10_23 1.2561700000000001e-16
C361 0 FILL_L10_24 4.4811600000000003e-17
C362 0 FILL_L126_0 3.5948400000000002e-17
C363 0 FILL_L126_1 5.7305799999999999e-18
C364 0 FILL_L126_2 5.5218500000000004e-19
C365 0 FILL_L126_3 3.6812300000000001e-18
C366 0 FILL_L50_10 8.5149200000000003e-18
C367 0 FILL_L50_11 8.5149200000000003e-18
C368 0 FILL_L50_12 4.0437600000000003e-18
C369 0 FILL_L50_13 2.0218800000000002e-17
C370 0 FILL_L50_14 2.0218800000000002e-17
C371 0 FILL_L50_15 2.0218800000000002e-17
C372 0 FILL_L50_8 1.70298e-18
C373 0 FILL_L50_9 8.5149200000000003e-18
C374 0 FILL_L8_26 1.6102600000000001e-18
C375 0 FILL_L8_27 3.2205200000000002e-18
C376 0 FILL_L8_28 3.2205200000000002e-18
C377 0 FILL_L8_29 3.2205200000000002e-18
C378 0 FILL_L8_30 1.6102600000000001e-18
C383 0 FILL_L10_20 1.5855000000000003e-16
C384 0 FILL_L10_21 2.4392500000000001e-16
C385 0 FILL_L10_22 2.4392500000000001e-16
C386 0 FILL_L10_23 2.4392500000000001e-16
C387 0 FILL_L10_24 8.5374200000000003e-17
C388 0 FILL_L126_0 1.86847e-17
C389 0 FILL_L126_1 6.3301300000000013e-19
C390 0 FILL_L50_10 5.4741900000000008e-18
C391 0 FILL_L50_11 5.4741900000000008e-18
C392 0 FILL_L50_12 3.2063899999999998e-17
C393 0 FILL_L50_13 1.6032000000000001e-16
C394 0 FILL_L50_14 1.6032000000000001e-16
C395 0 FILL_L50_15 1.6032000000000001e-16
C396 0 FILL_L50_8 1.0264100000000001e-18
C397 0 FILL_L50_9 5.4741900000000008e-18
C398 0 FILL_L8_26 1.6102600000000001e-18
C399 0 FILL_L8_27 3.2205200000000002e-18
C400 0 FILL_L8_28 3.2205200000000002e-18
C401 0 FILL_L8_29 3.2205200000000002e-18
C402 0 FILL_L8_30 1.6102600000000001e-18
C406 0 FILL_L10_20 4.1050900000000001e-17
C407 0 FILL_L10_21 6.2468800000000002e-17
C408 0 FILL_L10_22 6.2468800000000002e-17
C409 0 FILL_L10_23 6.2468800000000002e-17
C410 0 FILL_L10_24 2.1417900000000001e-17
C411 0 FILL_L10_25 3.1198300000000004e-17
C412 0 FILL_L10_26 4.7475600000000006e-17
C413 0 FILL_L10_27 4.7475600000000006e-17
C414 0 FILL_L10_28 4.7475600000000006e-17
C415 0 FILL_L10_29 1.6277400000000002e-17
C416 0 FILL_L126_0 1.4038000000000002e-17
C417 0 FILL_L126_1 6.5406300000000001e-19
C418 0 FILL_L126_3 3.8260000000000003e-18
C419 0 FILL_L126_4 3.8260000000000003e-18
C420 0 FILL_L126_5 1.9130000000000002e-19
C421 0 FILL_L50_12 5.8073200000000003e-17
C422 0 FILL_L50_13 2.6593900000000002e-16
C423 0 FILL_L50_14 2.6593900000000002e-16
C424 0 FILL_L50_15 2.6460700000000007e-16
C425 0 FILL_L8_26 2.2433999999999999e-18
C426 0 FILL_L8_27 3.4897300000000008e-18
C427 0 FILL_L8_28 3.4897300000000008e-18
C428 0 FILL_L8_29 3.3900199999999999e-18
C429 0 FILL_L8_30 1.09677e-18
C430 0 FILL_L8_31 2.7003100000000003e-18
C431 0 FILL_L8_32 4.1091600000000007e-18
C432 0 FILL_L8_33 4.1091600000000007e-18
C433 0 FILL_L8_34 4.1091600000000007e-18
C434 0 FILL_L8_35 1.4088600000000001e-18
C438 0 FILL_L10_25 8.6390800000000001e-17
C439 0 FILL_L10_26 1.34117e-16
C440 0 FILL_L10_27 1.34117e-16
C441 0 FILL_L10_28 1.34117e-16
C442 0 FILL_L10_29 4.7725700000000005e-17
C443 0 FILL_L126_0 7.3479900000000015e-18
C444 0 FILL_L126_1 1.4696000000000002e-19
C445 0 FILL_L126_2 1.5593000000000001e-18
C446 0 FILL_L126_3 1.0395400000000001e-17
C447 0 FILL_L126_4 1.0395400000000001e-17
C448 0 FILL_L126_5 2.0790700000000002e-19
C449 0 FILL_L50_12 1.3304000000000001e-17
C450 0 FILL_L50_13 6.6520100000000001e-17
C451 0 FILL_L50_14 6.6520100000000001e-17
C452 0 FILL_L50_15 6.6520100000000001e-17
C453 0 FILL_L8_31 1.6102600000000001e-18
C454 0 FILL_L8_32 3.2205200000000002e-18
C455 0 FILL_L8_33 3.2205200000000002e-18
C456 0 FILL_L8_34 3.2205200000000002e-18
C457 0 FILL_L8_35 1.6102600000000001e-18
C460 0 FILL_L10_25 4.5873100000000003e-17
C461 0 FILL_L10_26 7.1530800000000005e-17
C462 0 FILL_L10_27 7.1530800000000005e-17
C463 0 FILL_L10_28 7.1530800000000005e-17
C464 0 FILL_L10_29 2.5657700000000002e-17
C465 0 FILL_L126_0 3.3012200000000001e-18
C466 0 FILL_L126_2 1.89105e-18
C467 0 FILL_L126_3 8.770270000000001e-18
C468 0 FILL_L126_4 8.770270000000001e-18
C469 0 FILL_L126_5 9.6468099999999999e-19
C470 0 FILL_L50_12 2.2801500000000002e-18
C471 0 FILL_L50_13 1.1400800000000002e-17
C472 0 FILL_L50_14 1.1400800000000002e-17
C473 0 FILL_L50_15 1.1400800000000002e-17
C474 0 FILL_L8_31 1.04667e-18
C475 0 FILL_L8_32 2.09334e-18
C476 0 FILL_L8_33 2.09334e-18
C477 0 FILL_L8_34 2.09334e-18
C478 0 FILL_L8_35 1.04667e-18
C481 0 FILL_L10_15 3.2077500000000002e-17
C482 0 FILL_L10_16 1.0692500000000002e-17
C483 0 FILL_L10_18 2.1385000000000004e-17
C484 0 FILL_L10_19 2.5662000000000001e-17
C485 0 FILL_L126_0 2.5794400000000003e-16
C486 0 FILL_L126_1 1.5803800000000002e-17
C487 0 FILL_L126_2 1.07475e-19
C488 0 FILL_L126_3 8.5153400000000011e-19
C489 0 FILL_L50_10 2.8900200000000005e-16
C490 0 FILL_L50_11 2.8787300000000003e-16
C491 0 FILL_L50_8 6.1938099999999999e-17
C492 0 FILL_L50_9 2.8900200000000005e-16
C493 0 P 2.3926600000000002e-16
C496 0 FILL_L126_0 1.14333e-16
C497 0 FILL_L126_1 1.29301e-17
C498 0 FILL_L126_2 1.20924e-19
C499 0 FILL_L126_3 1.0618900000000002e-18
C500 0 FILL_L50_10 7.2254700000000007e-17
C501 0 FILL_L50_11 7.2141900000000015e-17
C502 0 FILL_L50_12 7.2477300000000007e-19
C503 0 FILL_L50_13 3.5332700000000003e-18
C504 0 FILL_L50_14 3.5785700000000004e-18
C505 0 FILL_L50_15 3.6238600000000007e-18
C506 0 FILL_L50_8 1.4864700000000001e-17
C507 0 FILL_L50_9 7.2254700000000007e-17
C510 0 FILL_L126_0 1.14409e-16
C511 0 FILL_L126_1 1.29301e-17
C512 0 FILL_L126_2 1.37032e-19
C513 0 FILL_L126_3 1.3176200000000001e-18
C514 0 FILL_L50_10 2.1048800000000002e-17
C515 0 FILL_L50_11 2.1048800000000002e-17
C516 0 FILL_L50_12 1.2082e-18
C517 0 FILL_L50_13 6.0410199999999999e-18
C518 0 FILL_L50_14 5.9655100000000009e-18
C519 0 FILL_L50_15 6.0410199999999999e-18
C520 0 FILL_L50_8 4.2097500000000003e-18
C521 0 FILL_L50_9 2.1048800000000002e-17
C524 0 FILL_L10_20 7.6323299999999998e-18
C525 0 FILL_L10_21 1.1872500000000002e-17
C526 0 FILL_L10_22 1.1872500000000002e-17
C527 0 FILL_L10_23 1.1872500000000002e-17
C528 0 FILL_L10_24 4.0705800000000003e-18
C529 0 FILL_L126_0 1.54542e-16
C530 0 FILL_L126_1 1.3732700000000001e-17
C531 0 FILL_L126_2 1.5653900000000002e-19
C532 0 FILL_L126_3 1.50518e-18
C533 0 FILL_L50_10 1.2108300000000001e-17
C534 0 FILL_L50_11 1.2108300000000001e-17
C535 0 FILL_L50_12 1.9709100000000002e-18
C536 0 FILL_L50_13 9.8545400000000015e-18
C537 0 FILL_L50_14 9.8545400000000015e-18
C538 0 FILL_L50_15 9.8545400000000015e-18
C539 0 FILL_L50_8 2.4216600000000003e-18
C540 0 FILL_L50_9 1.2108300000000001e-17
C543 0 FILL_L10_20 1.6029200000000001e-17
C544 0 FILL_L10_21 1.7616000000000002e-17
C545 0 FILL_L10_22 1.5522500000000003e-17
C546 0 FILL_L10_23 1.9539999999999999e-17
C547 0 FILL_L10_24 9.9976200000000009e-18
C548 0 FILL_L126_0 1.9467400000000001e-16
C549 0 FILL_L126_1 1.45354e-17
C550 0 FILL_L126_2 2.1019100000000001e-19
C551 0 FILL_L126_3 2.0210599999999999e-18
C552 0 FILL_L50_10 4.6364400000000007e-18
C553 0 FILL_L50_11 4.6364400000000007e-18
C554 0 FILL_L50_12 1.9568300000000001e-17
C555 0 FILL_L50_13 9.7841500000000004e-17
C556 0 FILL_L50_14 9.7841500000000004e-17
C557 0 FILL_L50_15 9.7841500000000004e-17
C558 0 FILL_L50_8 8.6933200000000004e-19
C559 0 FILL_L50_9 4.6364400000000007e-18
C561 0 FILL_L10_20 3.2360300000000005e-17
C562 0 FILL_L10_21 1.5062400000000001e-17
C563 0 FILL_L10_22 5.5558500000000011e-18
C564 0 FILL_L10_23 2.41847e-17
C565 0 FILL_L10_24 2.48876e-17
C566 0 FILL_L10_25 4.3272600000000003e-18
C567 0 FILL_L10_26 6.7313000000000005e-18
C568 0 FILL_L10_27 6.7313000000000005e-18
C569 0 FILL_L10_28 6.6525800000000009e-18
C570 0 FILL_L10_29 2.2291500000000002e-18
C571 0 FILL_L126_0 2.2412299999999998e-16
C572 0 FILL_L126_1 1.5124399999999999e-17
C573 0 FILL_L126_2 4.2698700000000006e-19
C574 0 FILL_L126_3 2.99348e-18
C575 0 FILL_L126_4 1.00383e-19
C576 0 FILL_L50_12 6.9671300000000006e-17
C577 0 FILL_L50_13 3.2766800000000002e-16
C578 0 FILL_L50_14 3.2766800000000002e-16
C579 0 FILL_L50_15 3.2653900000000001e-16
C580 0 FILL_L8_26 1.9152000000000001e-19
C581 0 FILL_L8_27 7.4079700000000006e-19
C582 0 FILL_L8_28 9.2858500000000002e-19
C583 0 FILL_L8_29 3.7930800000000002e-19
C585 0 FILL_L10_10 1.1412800000000001e-16
C586 0 FILL_L10_11 1.7733400000000001e-16
C587 0 FILL_L10_12 1.7733400000000001e-16
C588 0 FILL_L10_13 1.7733400000000001e-16
C589 0 FILL_L10_14 6.3205599999999999e-17
C590 0 FILL_L10_5 1.41374e-17
C591 0 FILL_L10_6 2.1152900000000001e-17
C592 0 FILL_L10_7 2.1152900000000001e-17
C593 0 FILL_L10_8 2.1152900000000001e-17
C594 0 FILL_L10_9 7.0155100000000007e-18
C595 0 FILL_L126_0 7.5760400000000009e-18
C596 0 FILL_L30_0 9.1866800000000019e-19
C597 0 FILL_L30_1 6.0052399999999999e-18
C598 0 FILL_L30_10 9.1132899999999994e-18
C599 0 FILL_L30_12 8.1445800000000007e-19
C600 0 FILL_L30_15 4.5247700000000006e-19
C601 0 FILL_L30_17 9.0495300000000003e-19
C602 0 FILL_L30_2 3.8638699999999999e-18
C603 0 FILL_L30_3 8.6923200000000006e-18
C604 0 FILL_L30_4 4.5828e-18
C605 0 FILL_L30_5 9.1132899999999994e-18
C606 0 FILL_L30_6 5.7285000000000008e-18
C607 0 FILL_L30_7 5.7285000000000008e-18
C608 0 FILL_L30_8 7.4209000000000003e-18
C609 0 FILL_L30_9 5.7285000000000008e-18
C610 0 FILL_L50_10 7.4702900000000014e-19
C611 0 FILL_L50_11 2.7245700000000001e-18
C612 0 FILL_L50_4 8.1935199999999998e-19
C613 0 FILL_L50_5 2.0200500000000003e-17
C614 0 FILL_L50_6 1.6044500000000001e-17
C615 0 FILL_L50_7 2.3567300000000002e-17
C616 0 FILL_L50_9 1.4940600000000001e-18
C617 0 FILL_L8_0 5.7799000000000003e-18
C618 0 FILL_L8_1 6.6691200000000012e-18
C619 0 FILL_L8_10 7.250820000000001e-18
C620 0 FILL_L8_11 7.250820000000001e-18
C621 0 FILL_L8_12 7.250820000000001e-18
C622 0 FILL_L8_13 1.3284800000000002e-17
C623 0 FILL_L8_14 1.3284800000000002e-17
C624 0 FILL_L8_15 1.3284800000000002e-17
C625 0 FILL_L8_16 1.3284800000000002e-17
C626 0 FILL_L8_17 1.3284800000000002e-17
C627 0 FILL_L8_18 1.3284800000000002e-17
C628 0 FILL_L8_19 1.3284800000000002e-17
C629 0 FILL_L8_2 6.6691200000000012e-18
C630 0 FILL_L8_20 1.3284800000000002e-17
C631 0 FILL_L8_21 8.0110400000000005e-18
C632 0 FILL_L8_22 9.2435100000000014e-18
C633 0 FILL_L8_23 9.2435100000000014e-18
C634 0 FILL_L8_24 9.2435100000000014e-18
C635 0 FILL_L8_25 1.23247e-18
C636 0 FILL_L8_3 6.6691200000000012e-18
C637 0 FILL_L8_4 8.8921600000000014e-19
C638 0 FILL_L8_5 7.250820000000001e-18
C639 0 FILL_L8_6 7.250820000000001e-18
C640 0 FILL_L8_7 7.250820000000001e-18
C641 0 FILL_L8_8 7.250820000000001e-18
C642 0 FILL_L8_9 7.250820000000001e-18
C643 0 N 6.1807400000000003e-18
C644 0 P 2.7790300000000004e-18
C646 FILL_L10_0 FILL_L10_1 4.6651900000000001e-17
C647 FILL_L10_0 FILL_L10_5 6.4251099999999995e-17
C648 FILL_L10_0 FILL_L30_0 9.4613699999999998e-17
C649 FILL_L10_0 FILL_L30_1 1.6912800000000001e-17
C650 FILL_L10_0 FILL_L50_0 1.9462900000000001e-17
C651 FILL_L10_0 FILL_L50_1 7.2175799999999998e-18
C652 FILL_L10_0 FILL_L8_0 2.5821100000000003e-16
C653 FILL_L10_0 0 1.9379000000000001e-16
C654 FILL_L10_1 FILL_L10_2 4.6651900000000001e-17
C655 FILL_L10_1 FILL_L10_6 9.7773300000000019e-17
C656 FILL_L10_1 FILL_L30_1 3.0656500000000003e-16
C657 FILL_L10_1 FILL_L30_2 1.7474700000000001e-18
C658 FILL_L10_1 FILL_L50_1 4.4528000000000002e-17
C659 FILL_L10_1 FILL_L50_2 1.9454000000000001e-18
C660 FILL_L10_1 FILL_L8_1 3.9293000000000006e-16
C661 FILL_L10_1 0 2.1766000000000002e-16
C662 FILL_L10_10 FILL_L10_11 9.7773300000000019e-17
C663 FILL_L10_10 FILL_L10_15 6.4251099999999995e-17
C664 FILL_L10_10 FILL_L10_5 6.4251099999999995e-17
C665 FILL_L10_10 FILL_L30_11 1.2842400000000002e-18
C666 FILL_L10_10 FILL_L30_4 5.4404800000000005e-17
C667 FILL_L10_10 FILL_L50_4 1.0909600000000001e-16
C668 FILL_L10_10 FILL_L50_5 6.2743300000000007e-17
C669 FILL_L10_10 FILL_L50_8 1.89706e-18
C670 FILL_L10_10 FILL_L8_13 1.1554800000000001e-16
C671 FILL_L10_10 FILL_L8_21 8.3087700000000008e-18
C672 FILL_L10_10 N 3.3692000000000002e-17
C673 FILL_L10_10 P 1.80546e-18
C674 FILL_L10_10 0 3.4897300000000003e-16
C675 FILL_L10_11 FILL_L10_12 9.7773300000000019e-17
C676 FILL_L10_11 FILL_L10_16 9.7773300000000019e-17
C677 FILL_L10_11 FILL_L10_6 9.7773300000000019e-17
C678 FILL_L10_11 FILL_L126_0 4.1655400000000004e-18
C679 FILL_L10_11 FILL_L30_1 8.1568600000000011e-18
C680 FILL_L10_11 FILL_L30_13 1.6053e-18
C681 FILL_L10_11 FILL_L30_6 6.8006e-17
C682 FILL_L10_11 FILL_L50_5 2.7536399999999997e-16
C683 FILL_L10_11 FILL_L50_6 1.15946e-17
C684 FILL_L10_11 FILL_L50_9 7.0288800000000001e-18
C685 FILL_L10_11 FILL_L8_14 1.1679600000000002e-16
C686 FILL_L10_11 FILL_L8_15 1.1679600000000002e-16
C687 FILL_L10_11 FILL_L8_22 9.5870400000000004e-18
C688 FILL_L10_11 N 1.9775600000000001e-17
C689 FILL_L10_11 P 2.7474300000000001e-18
C690 FILL_L10_11 0 3.5873200000000005e-16
C691 FILL_L10_12 FILL_L10_13 9.7773300000000019e-17
C692 FILL_L10_12 FILL_L10_17 9.7773300000000019e-17
C693 FILL_L10_12 FILL_L10_7 9.7773300000000019e-17
C694 FILL_L10_12 FILL_L126_0 1.0656700000000001e-17
C695 FILL_L10_12 FILL_L30_14 1.6053e-18
C696 FILL_L10_12 FILL_L30_15 7.223850000000001e-19
C697 FILL_L10_12 FILL_L30_2 8.1568600000000011e-18
C698 FILL_L10_12 FILL_L30_7 6.8006e-17
C699 FILL_L10_12 FILL_L30_8 3.4003e-17
C700 FILL_L10_12 FILL_L50_10 8.1810900000000006e-18
C701 FILL_L10_12 FILL_L50_6 2.8228100000000004e-16
C702 FILL_L10_12 FILL_L8_16 1.1679600000000002e-16
C703 FILL_L10_12 FILL_L8_17 1.1679600000000002e-16
C704 FILL_L10_12 FILL_L8_23 9.5870400000000004e-18
C705 FILL_L10_12 N 1.07854e-17
C706 FILL_L10_12 P 2.7081900000000002e-18
C707 FILL_L10_12 0 3.5873200000000005e-16
C708 FILL_L10_13 FILL_L10_14 9.7773300000000019e-17
C709 FILL_L10_13 FILL_L10_18 9.7773300000000019e-17
C710 FILL_L10_13 FILL_L10_8 9.7773300000000019e-17
C711 FILL_L10_13 FILL_L126_0 4.1416200000000009e-17
C712 FILL_L10_13 FILL_L126_1 8.4867400000000013e-19
C713 FILL_L10_13 FILL_L30_16 1.6053e-18
C714 FILL_L10_13 FILL_L30_3 6.1176500000000007e-18
C715 FILL_L10_13 FILL_L30_9 6.8006e-17
C716 FILL_L10_13 FILL_L50_11 5.9283200000000005e-18
C717 FILL_L10_13 FILL_L50_6 3.4952399999999999e-17
C718 FILL_L10_13 FILL_L50_7 2.6115600000000002e-16
C719 FILL_L10_13 FILL_L8_18 1.1679600000000002e-16
C720 FILL_L10_13 FILL_L8_19 1.1679600000000002e-16
C721 FILL_L10_13 FILL_L8_24 9.5870400000000004e-18
C722 FILL_L10_13 N 2.8609500000000002e-17
C723 FILL_L10_13 P 2.7474300000000001e-18
C724 FILL_L10_13 0 3.5873200000000005e-16
C725 FILL_L10_14 FILL_L10_19 3.3522300000000005e-17
C726 FILL_L10_14 FILL_L10_9 3.3522300000000005e-17
C727 FILL_L10_14 FILL_L126_0 3.9845600000000006e-18
C728 FILL_L10_14 FILL_L126_1 7.5080400000000009e-18
C729 FILL_L10_14 FILL_L50_7 7.3343400000000004e-17
C730 FILL_L10_14 FILL_L8_20 9.8973100000000005e-17
C731 FILL_L10_14 FILL_L8_25 1.2782700000000002e-18
C732 FILL_L10_14 N 2.4872600000000001e-17
C733 FILL_L10_14 P 8.634800000000001e-19
C734 FILL_L10_14 0 2.5334500000000003e-16
C735 FILL_L10_15 FILL_L10_16 9.7773300000000019e-17
C736 FILL_L10_15 FILL_L10_20 6.4251099999999995e-17
C737 FILL_L10_15 FILL_L30_11 1.2535900000000001e-16
C738 FILL_L10_15 FILL_L30_12 3.3825600000000003e-17
C739 FILL_L10_15 FILL_L50_8 1.06883e-16
C740 FILL_L10_15 FILL_L50_9 6.6721199999999996e-17
C741 FILL_L10_15 FILL_L8_21 5.4116100000000002e-16
C742 FILL_L10_15 N 1.6079600000000001e-18
C743 FILL_L10_15 P 2.8848300000000001e-17
C744 FILL_L10_15 0 2.3532e-16
C745 FILL_L10_16 FILL_L10_17 9.7773300000000019e-17
C746 FILL_L10_16 FILL_L10_21 9.7773300000000019e-17
C747 FILL_L10_16 FILL_L126_0 7.8477500000000005e-18
C748 FILL_L10_16 FILL_L126_3 9.3943200000000016e-19
C749 FILL_L10_16 FILL_L30_12 6.3965400000000009e-17
C750 FILL_L10_16 FILL_L30_13 1.70725e-16
C751 FILL_L10_16 FILL_L30_14 3.4949400000000003e-18
C752 FILL_L10_16 FILL_L50_10 1.3617800000000002e-17
C753 FILL_L10_16 FILL_L50_9 2.6675700000000002e-16
C754 FILL_L10_16 FILL_L8_22 8.2350600000000007e-16
C755 FILL_L10_16 N 2.3630000000000001e-18
C756 FILL_L10_16 P 1.1573600000000001e-17
C757 FILL_L10_16 0 1.9621900000000002e-16
C758 FILL_L10_17 FILL_L10_18 9.7773300000000019e-17
C759 FILL_L10_17 FILL_L10_22 9.7773300000000019e-17
C760 FILL_L10_17 FILL_L126_0 9.6767199999999998e-18
C761 FILL_L10_17 FILL_L30_14 1.5088900000000003e-16
C762 FILL_L10_17 FILL_L30_15 1.10579e-16
C763 FILL_L10_17 FILL_L50_10 2.6576100000000002e-16
C764 FILL_L10_17 FILL_L8_23 8.2350600000000007e-16
C765 FILL_L10_17 N 2.41194e-18
C766 FILL_L10_17 P 2.5842100000000002e-18
C767 FILL_L10_17 0 1.9621900000000002e-16
C768 FILL_L10_18 FILL_L10_19 9.7773300000000019e-17
C769 FILL_L10_18 FILL_L10_23 9.7773300000000019e-17
C770 FILL_L10_18 FILL_L126_0 5.1877499999999998e-17
C771 FILL_L10_18 FILL_L30_15 1.3974200000000001e-17
C772 FILL_L10_18 FILL_L30_16 1.7860600000000001e-16
C773 FILL_L10_18 FILL_L30_17 3.3825600000000003e-17
C774 FILL_L10_18 FILL_L50_10 3.7885900000000003e-17
C775 FILL_L10_18 FILL_L50_11 2.5653800000000004e-16
C776 FILL_L10_18 FILL_L8_24 8.2350600000000007e-16
C777 FILL_L10_18 N 2.4469000000000001e-18
C778 FILL_L10_18 P 2.0705300000000003e-17
C779 FILL_L10_18 0 1.9621900000000002e-16
C780 FILL_L10_19 FILL_L10_24 3.3522300000000005e-17
C781 FILL_L10_19 FILL_L126_0 2.5356300000000004e-17
C782 FILL_L10_19 FILL_L126_1 3.37819e-17
C783 FILL_L10_19 FILL_L30_17 5.7302100000000006e-17
C784 FILL_L10_19 FILL_L50_11 7.8166800000000005e-17
C785 FILL_L10_19 FILL_L8_25 2.8234500000000005e-16
C786 FILL_L10_19 N 6.9911300000000001e-19
C787 FILL_L10_19 P 2.2449400000000003e-17
C788 FILL_L10_19 0 2.0448500000000003e-16
C789 FILL_L10_2 FILL_L10_3 4.6651900000000001e-17
C790 FILL_L10_2 FILL_L10_7 9.7773300000000019e-17
C791 FILL_L10_2 FILL_L30_2 3.3991200000000002e-16
C792 FILL_L10_2 FILL_L50_2 4.8263800000000007e-17
C793 FILL_L10_2 FILL_L8_2 3.9293000000000006e-16
C794 FILL_L10_2 0 2.1766000000000002e-16
C795 FILL_L10_20 FILL_L10_21 9.7773300000000019e-17
C796 FILL_L10_20 FILL_L10_25 6.4251099999999995e-17
C797 FILL_L10_20 FILL_L126_2 1.7761800000000004e-18
C798 FILL_L10_20 FILL_L50_12 1.0121500000000001e-16
C799 FILL_L10_20 FILL_L50_13 5.2286100000000001e-17
C800 FILL_L10_20 FILL_L50_8 5.1915900000000004e-18
C801 FILL_L10_20 FILL_L8_26 5.4116100000000002e-16
C802 FILL_L10_20 0 2.3532e-16
C803 FILL_L10_21 FILL_L10_22 9.7773300000000019e-17
C804 FILL_L10_21 FILL_L10_26 9.7773300000000019e-17
C805 FILL_L10_21 FILL_L126_0 1.0445100000000002e-17
C806 FILL_L10_21 FILL_L126_3 1.4799e-17
C807 FILL_L10_21 FILL_L50_13 2.5576900000000004e-16
C808 FILL_L10_21 FILL_L50_14 9.7270000000000007e-18
C809 FILL_L10_21 FILL_L50_9 2.0308300000000002e-17
C810 FILL_L10_21 FILL_L8_27 8.2350600000000007e-16
C811 FILL_L10_21 0 1.9621900000000002e-16
C812 FILL_L10_22 FILL_L10_23 9.7773300000000019e-17
C813 FILL_L10_22 FILL_L10_27 9.7773300000000019e-17
C814 FILL_L10_22 FILL_L126_0 2.1357600000000004e-17
C815 FILL_L10_22 FILL_L50_10 2.3654000000000001e-17
C816 FILL_L10_22 FILL_L50_14 2.6800099999999998e-16
C817 FILL_L10_22 FILL_L8_28 8.2350600000000007e-16
C818 FILL_L10_22 0 1.9621900000000002e-16
C819 FILL_L10_23 FILL_L10_24 9.7773300000000019e-17
C820 FILL_L10_23 FILL_L10_28 9.7773300000000019e-17
C821 FILL_L10_23 FILL_L126_0 4.8127499999999999e-17
C822 FILL_L10_23 FILL_L126_1 1.6407700000000002e-18
C823 FILL_L10_23 FILL_L126_4 4.8200900000000005e-18
C824 FILL_L10_23 FILL_L50_11 1.6956000000000001e-17
C825 FILL_L10_23 FILL_L50_14 2.9176400000000001e-17
C826 FILL_L10_23 FILL_L50_15 2.4057300000000003e-16
C827 FILL_L10_23 FILL_L8_29 8.2350600000000007e-16
C828 FILL_L10_23 0 1.9621900000000002e-16
C829 FILL_L10_24 FILL_L10_29 3.3522300000000005e-17
C830 FILL_L10_24 FILL_L126_0 1.5431100000000001e-17
C831 FILL_L10_24 FILL_L126_1 2.1030100000000003e-17
C832 FILL_L10_24 FILL_L126_5 4.8200900000000005e-19
C833 FILL_L10_24 FILL_L50_15 6.1119500000000011e-17
C834 FILL_L10_24 FILL_L8_30 2.8234500000000005e-16
C835 FILL_L10_24 0 2.0448500000000003e-16
C836 FILL_L10_25 FILL_L10_26 2.3186300000000001e-17
C837 FILL_L10_25 FILL_L126_2 2.9695700000000004e-18
C838 FILL_L10_25 FILL_L50_12 1.20497e-17
C839 FILL_L10_25 FILL_L8_31 1.2833300000000001e-16
C840 FILL_L10_25 0 1.5278700000000001e-16
C841 FILL_L10_26 FILL_L10_27 2.3186300000000001e-17
C842 FILL_L10_26 FILL_L126_3 1.3858000000000001e-17
C843 FILL_L10_26 FILL_L50_13 4.5186300000000007e-17
C844 FILL_L10_26 FILL_L8_32 1.95289e-16
C845 FILL_L10_26 0 1.9411400000000001e-16
C846 FILL_L10_27 FILL_L10_28 2.3186300000000001e-17
C847 FILL_L10_27 FILL_L126_0 1.4641900000000001e-18
C848 FILL_L10_27 FILL_L126_4 1.78174e-18
C849 FILL_L10_27 FILL_L50_14 5.2717400000000003e-17
C850 FILL_L10_27 FILL_L8_33 1.95289e-16
C851 FILL_L10_27 0 1.9411400000000001e-16
C852 FILL_L10_28 FILL_L10_29 2.3186300000000001e-17
C853 FILL_L10_28 FILL_L126_0 9.9239400000000005e-18
C854 FILL_L10_28 FILL_L126_4 1.2076300000000001e-17
C855 FILL_L10_28 FILL_L50_15 3.76553e-17
C856 FILL_L10_28 FILL_L8_34 1.95289e-16
C857 FILL_L10_28 0 1.9411400000000001e-16
C858 FILL_L10_29 FILL_L126_1 3.2537500000000004e-19
C859 FILL_L10_29 FILL_L126_5 3.95943e-19
C860 FILL_L10_29 FILL_L8_35 6.6956100000000007e-17
C861 FILL_L10_29 0 9.9091800000000008e-17
C862 FILL_L10_3 FILL_L10_4 4.6651900000000001e-17
C863 FILL_L10_3 FILL_L10_8 9.7773300000000019e-17
C864 FILL_L10_3 FILL_L30_2 6.9870900000000006e-18
C865 FILL_L10_3 FILL_L30_3 2.6698600000000001e-16
C866 FILL_L10_3 FILL_L50_2 4.3547700000000009e-18
C867 FILL_L10_3 FILL_L50_3 4.0495900000000003e-17
C868 FILL_L10_3 FILL_L8_3 3.9293000000000006e-16
C869 FILL_L10_3 0 2.1766000000000002e-16
C870 FILL_L10_4 FILL_L10_9 3.3522300000000005e-17
C871 FILL_L10_4 FILL_L30_3 3.0888100000000004e-17
C872 FILL_L10_4 FILL_L50_3 7.0431600000000007e-18
C873 FILL_L10_4 FILL_L8_4 1.3471900000000001e-16
C874 FILL_L10_4 0 1.4009500000000001e-16
C875 FILL_L10_5 FILL_L10_6 9.7773300000000019e-17
C876 FILL_L10_5 FILL_L30_0 2.3394900000000002e-16
C877 FILL_L10_5 FILL_L30_1 6.7651200000000006e-17
C878 FILL_L10_5 FILL_L30_4 2.7060500000000002e-17
C879 FILL_L10_5 FILL_L50_0 4.7214500000000004e-17
C880 FILL_L10_5 FILL_L50_1 2.8870300000000003e-17
C881 FILL_L10_5 FILL_L50_4 1.1548100000000001e-17
C882 FILL_L10_5 FILL_L8_0 8.5444000000000005e-18
C883 FILL_L10_5 FILL_L8_5 1.16265e-16
C884 FILL_L10_5 N 1.0953100000000001e-17
C885 FILL_L10_5 0 3.63489e-16
C886 FILL_L10_6 FILL_L10_7 9.7773300000000019e-17
C887 FILL_L10_6 FILL_L30_1 6.8436300000000009e-16
C888 FILL_L10_6 FILL_L30_2 6.9898900000000003e-18
C889 FILL_L10_6 FILL_L30_6 3.3825600000000003e-17
C890 FILL_L10_6 FILL_L50_1 6.3222800000000008e-17
C891 FILL_L10_6 FILL_L50_2 7.7816000000000003e-18
C892 FILL_L10_6 FILL_L50_5 5.6264000000000008e-17
C893 FILL_L10_6 FILL_L8_1 9.8589300000000015e-18
C894 FILL_L10_6 FILL_L8_6 1.1751300000000001e-16
C895 FILL_L10_6 FILL_L8_7 1.1751300000000001e-16
C896 FILL_L10_6 N 1.2611500000000001e-17
C897 FILL_L10_6 0 3.8256400000000007e-16
C898 FILL_L10_7 FILL_L10_8 9.7773300000000019e-17
C899 FILL_L10_7 FILL_L126_0 2.9254800000000001e-18
C900 FILL_L10_7 FILL_L30_2 7.2743800000000001e-16
C901 FILL_L10_7 FILL_L30_7 3.3825600000000003e-17
C902 FILL_L10_7 FILL_L30_8 1.6912800000000001e-17
C903 FILL_L10_7 FILL_L50_2 5.9018100000000005e-17
C904 FILL_L10_7 FILL_L50_6 6.3481600000000006e-17
C905 FILL_L10_7 FILL_L8_2 9.8589300000000015e-18
C906 FILL_L10_7 FILL_L8_8 1.1751300000000001e-16
C907 FILL_L10_7 FILL_L8_9 1.1751300000000001e-16
C908 FILL_L10_7 N 1.1473699999999999e-17
C909 FILL_L10_7 0 3.8256400000000007e-16
C910 FILL_L10_8 FILL_L10_9 9.7773300000000019e-17
C911 FILL_L10_8 FILL_L126_0 2.6142000000000002e-17
C912 FILL_L10_8 FILL_L30_2 2.7948400000000001e-17
C913 FILL_L10_8 FILL_L30_3 6.1636500000000001e-16
C914 FILL_L10_8 FILL_L30_9 3.3825600000000003e-17
C915 FILL_L10_8 FILL_L50_2 1.74191e-17
C916 FILL_L10_8 FILL_L50_3 6.6242900000000013e-17
C917 FILL_L10_8 FILL_L50_7 4.5806800000000008e-17
C918 FILL_L10_8 FILL_L8_10 1.1751300000000001e-16
C919 FILL_L10_8 FILL_L8_11 1.1751300000000001e-16
C920 FILL_L10_8 FILL_L8_3 9.8589300000000015e-18
C921 FILL_L10_8 N 1.3749200000000001e-17
C922 FILL_L10_8 0 3.8256400000000007e-16
C923 FILL_L10_9 FILL_L126_1 1.28148e-18
C924 FILL_L10_9 FILL_L30_3 1.2355200000000002e-16
C925 FILL_L10_9 FILL_L50_3 2.8172600000000004e-17
C926 FILL_L10_9 FILL_L8_12 9.9690100000000005e-17
C927 FILL_L10_9 FILL_L8_4 1.3145200000000001e-18
C928 FILL_L10_9 N 6.6644100000000003e-18
C929 FILL_L10_9 0 2.6266100000000003e-16
C930 FILL_L126_0 FILL_L126_1 4.7795999999999998e-16
C931 FILL_L126_0 FILL_L126_4 2.3897999999999999e-16
C932 FILL_L126_0 FILL_L30_15 1.2208000000000002e-17
C933 FILL_L126_0 FILL_L30_16 1.24575e-17
C934 FILL_L126_0 FILL_L30_8 2.4215500000000001e-19
C935 FILL_L126_0 FILL_L30_9 2.5490000000000004e-19
C936 FILL_L126_0 FILL_L50_10 2.7208100000000004e-16
C937 FILL_L126_0 FILL_L50_11 3.3710400000000001e-16
C938 FILL_L126_0 FILL_L50_13 1.0437300000000001e-17
C939 FILL_L126_0 FILL_L50_14 1.4065700000000002e-16
C940 FILL_L126_0 FILL_L50_15 2.0100200000000002e-16
C941 FILL_L126_0 FILL_L50_2 4.0041300000000001e-18
C942 FILL_L126_0 FILL_L50_3 8.6404899999999999e-18
C943 FILL_L126_0 FILL_L50_5 1.68343e-18
C944 FILL_L126_0 FILL_L50_6 6.4902100000000008e-17
C945 FILL_L126_0 FILL_L50_7 1.2351600000000001e-16
C946 FILL_L126_0 FILL_L50_9 2.0134799999999999e-17
C947 FILL_L126_0 FILL_L8_17 1.5103400000000001e-18
C948 FILL_L126_0 FILL_L8_18 2.27072e-18
C949 FILL_L126_0 FILL_L8_19 7.5537000000000005e-19
C950 FILL_L126_0 FILL_L8_23 5.3174700000000004e-18
C951 FILL_L126_0 FILL_L8_24 1.06495e-17
C952 FILL_L126_0 FILL_L8_28 3.3341200000000001e-18
C953 FILL_L126_0 FILL_L8_29 5.11886e-18
C954 FILL_L126_0 N 1.6494e-16
C955 FILL_L126_0 P 2.5809699999999999e-16
C956 FILL_L126_0 0 2.9995000000000002e-16
C957 FILL_L126_1 FILL_L126_5 4.7796000000000004e-18
C958 FILL_L126_1 FILL_L30_17 3.71874e-19
C959 FILL_L126_1 FILL_L50_11 7.5955900000000004e-17
C960 FILL_L126_1 FILL_L50_15 3.1161400000000004e-17
C961 FILL_L126_1 FILL_L50_7 5.0260300000000008e-18
C962 FILL_L126_1 FILL_L8_25 1.11057e-19
C963 FILL_L126_1 N 1.3940700000000002e-17
C964 FILL_L126_1 P 1.5803800000000002e-17
C965 FILL_L126_1 0 4.1133900000000003e-16
C966 FILL_L126_2 FILL_L126_3 1.4338800000000001e-18
C967 FILL_L126_2 FILL_L50_12 2.3865500000000003e-17
C968 FILL_L126_2 FILL_L50_8 8.9099100000000008e-19
C969 FILL_L126_2 0 3.0417700000000004e-17
C970 FILL_L126_3 FILL_L126_4 1.4338800000000001e-18
C971 FILL_L126_3 FILL_L50_13 9.5461799999999998e-17
C972 FILL_L126_3 FILL_L50_9 3.6324999999999997e-18
C973 FILL_L126_3 0 2.4027100000000002e-16
C974 FILL_L126_4 FILL_L126_5 1.4338800000000001e-18
C975 FILL_L126_4 FILL_L50_14 2.2663300000000002e-17
C976 FILL_L126_4 FILL_L50_15 4.9104600000000003e-17
C977 FILL_L126_4 0 2.09599e-16
C978 FILL_L126_5 0 5.5818100000000003e-18
C979 FILL_L30_0 FILL_L30_1 7.7092600000000011e-17
C980 FILL_L30_0 FILL_L30_4 1.5418500000000002e-17
C981 FILL_L30_0 FILL_L50_0 2.1512000000000001e-16
C982 FILL_L30_0 FILL_L8_0 6.4410400000000004e-18
C983 FILL_L30_0 0 1.8755500000000002e-16
C984 FILL_L30_1 FILL_L30_2 7.7092600000000011e-17
C985 FILL_L30_1 FILL_L30_5 1.92731e-17
C986 FILL_L30_1 FILL_L30_6 1.92731e-17
C987 FILL_L30_1 FILL_L50_1 1.0756e-15
C988 FILL_L30_1 FILL_L50_5 1.26009e-17
C989 FILL_L30_1 FILL_L8_0 2.5173300000000001e-18
C990 FILL_L30_1 FILL_L8_1 2.7029200000000001e-17
C991 FILL_L30_1 FILL_L8_5 5.0346600000000001e-18
C992 FILL_L30_1 FILL_L8_6 1.3801800000000002e-17
C993 FILL_L30_1 FILL_L8_7 4.0256499999999998e-18
C994 FILL_L30_1 0 3.0630700000000004e-16
C995 FILL_L30_10 FILL_L30_3 1.92731e-17
C996 FILL_L30_10 FILL_L30_9 1.92731e-17
C997 FILL_L30_10 FILL_L50_7 1.3606299999999999e-16
C998 FILL_L30_10 0 8.5666400000000002e-17
C999 FILL_L30_11 FILL_L30_12 1.92731e-17
C1000 FILL_L30_11 FILL_L50_8 8.1678799999999997e-17
C1001 FILL_L30_11 N 9.9727800000000003e-19
C1002 FILL_L30_11 P 1.1720400000000001e-18
C1003 FILL_L30_11 0 4.2384700000000008e-17
C1004 FILL_L30_12 FILL_L30_13 1.92731e-17
C1005 FILL_L30_12 FILL_L50_9 1.3498800000000002e-16
C1006 FILL_L30_12 FILL_L8_21 5.0346600000000001e-18
C1007 FILL_L30_12 FILL_L8_22 5.7504800000000001e-18
C1008 FILL_L30_12 N 1.2466e-18
C1009 FILL_L30_12 P 1.4650500000000002e-18
C1010 FILL_L30_12 0 4.2393700000000003e-17
C1011 FILL_L30_13 FILL_L30_14 1.92731e-17
C1012 FILL_L30_13 FILL_L50_9 1.3498800000000002e-16
C1013 FILL_L30_13 N 1.2466e-18
C1014 FILL_L30_13 P 1.4650500000000002e-18
C1015 FILL_L30_13 0 1.9662800000000003e-17
C1016 FILL_L30_14 FILL_L30_15 1.92731e-17
C1017 FILL_L30_14 FILL_L50_10 1.3498800000000002e-16
C1018 FILL_L30_14 N 1.2466e-18
C1019 FILL_L30_14 P 1.4650500000000002e-18
C1020 FILL_L30_14 0 2.0164300000000003e-17
C1021 FILL_L30_15 FILL_L30_16 1.92731e-17
C1022 FILL_L30_15 FILL_L50_10 1.3498800000000002e-16
C1023 FILL_L30_15 FILL_L8_23 3.01665e-18
C1024 FILL_L30_15 FILL_L8_24 2.30082e-18
C1025 FILL_L30_15 N 1.1842699999999999e-18
C1026 FILL_L30_15 P 1.3918e-18
C1027 FILL_L30_15 0 3.1351500000000001e-17
C1028 FILL_L30_16 FILL_L30_17 1.92731e-17
C1029 FILL_L30_16 FILL_L50_11 1.3498800000000002e-16
C1030 FILL_L30_16 N 1.2466e-18
C1031 FILL_L30_16 P 1.4650500000000002e-18
C1032 FILL_L30_16 0 1.9256499999999999e-17
C1033 FILL_L30_17 FILL_L50_11 1.3498800000000002e-16
C1034 FILL_L30_17 FILL_L8_24 5.0346600000000001e-18
C1035 FILL_L30_17 FILL_L8_25 5.7504800000000001e-18
C1036 FILL_L30_17 N 1.2466e-18
C1037 FILL_L30_17 P 1.4650500000000002e-18
C1038 FILL_L30_17 0 6.5690000000000001e-17
C1039 FILL_L30_2 FILL_L30_3 7.7092600000000011e-17
C1040 FILL_L30_2 FILL_L30_7 1.92731e-17
C1041 FILL_L30_2 FILL_L30_8 1.92731e-17
C1042 FILL_L30_2 FILL_L50_2 1.0756e-15
C1043 FILL_L30_2 FILL_L50_6 1.26009e-17
C1044 FILL_L30_2 FILL_L8_10 2.30082e-18
C1045 FILL_L30_2 FILL_L8_2 2.9687900000000004e-17
C1046 FILL_L30_2 FILL_L8_3 1.15041e-18
C1047 FILL_L30_2 FILL_L8_8 8.0512999999999997e-18
C1048 FILL_L30_2 FILL_L8_9 1.1068e-17
C1049 FILL_L30_2 0 2.9201200000000002e-16
C1050 FILL_L30_3 FILL_L30_9 1.92731e-17
C1051 FILL_L30_3 FILL_L50_3 1.0756e-15
C1052 FILL_L30_3 FILL_L50_7 1.26009e-17
C1053 FILL_L30_3 FILL_L8_11 1.6102599999999999e-17
C1054 FILL_L30_3 FILL_L8_12 8.0512999999999997e-18
C1055 FILL_L30_3 FILL_L8_3 2.4153900000000002e-17
C1056 FILL_L30_3 FILL_L8_4 4.0256499999999998e-18
C1057 FILL_L30_3 0 4.03681e-16
C1058 FILL_L30_4 FILL_L30_5 1.92731e-17
C1059 FILL_L30_4 FILL_L50_4 8.2539300000000009e-17
C1060 FILL_L30_4 FILL_L8_0 5.6757600000000003e-19
C1061 FILL_L30_4 0 5.6554599999999999e-17
C1062 FILL_L30_5 FILL_L30_6 1.92731e-17
C1063 FILL_L30_5 FILL_L50_5 1.3606299999999999e-16
C1064 FILL_L30_5 0 6.7159300000000006e-17
C1065 FILL_L30_6 FILL_L30_7 1.92731e-17
C1066 FILL_L30_6 FILL_L50_5 1.3606299999999999e-16
C1067 FILL_L30_6 FILL_L8_1 3.5473500000000003e-19
C1068 FILL_L30_6 FILL_L8_7 8.559870000000001e-19
C1069 FILL_L30_6 0 4.1149400000000004e-17
C1070 FILL_L30_7 FILL_L30_8 1.92731e-17
C1071 FILL_L30_7 FILL_L50_6 1.3606299999999999e-16
C1072 FILL_L30_7 FILL_L8_8 1.71197e-18
C1073 FILL_L30_7 0 4.1149400000000004e-17
C1074 FILL_L30_8 FILL_L30_9 1.92731e-17
C1075 FILL_L30_8 FILL_L50_6 1.3606299999999999e-16
C1076 FILL_L30_8 FILL_L8_9 7.7038900000000003e-19
C1077 FILL_L30_8 0 5.4092300000000006e-17
C1078 FILL_L30_9 FILL_L50_7 1.3606299999999999e-16
C1079 FILL_L30_9 FILL_L8_3 7.0947000000000007e-19
C1080 FILL_L30_9 0 4.1149400000000004e-17
C1081 FILL_L50_0 FILL_L50_1 9.8854299999999996e-17
C1082 FILL_L50_0 FILL_L50_4 1.9770900000000003e-17
C1083 FILL_L50_0 N 5.6019600000000004e-19
C1084 FILL_L50_0 0 1.5834000000000002e-16
C1085 FILL_L50_1 FILL_L50_2 9.8854299999999996e-17
C1086 FILL_L50_1 FILL_L50_5 9.8854299999999996e-17
C1087 FILL_L50_1 N 2.7309600000000002e-18
C1088 FILL_L50_1 0 1.7260900000000002e-16
C1089 FILL_L50_10 FILL_L50_11 9.8854299999999996e-17
C1090 FILL_L50_10 FILL_L50_14 9.8854299999999996e-17
C1091 FILL_L50_10 FILL_L50_6 9.8854299999999996e-17
C1092 FILL_L50_10 FILL_L50_9 9.8854299999999996e-17
C1093 FILL_L50_10 FILL_L8_23 6.4578200000000007e-18
C1094 FILL_L50_10 FILL_L8_24 3.3519100000000004e-18
C1095 FILL_L50_10 FILL_L8_28 2.3715500000000003e-18
C1096 FILL_L50_10 N 6.8059000000000009e-18
C1097 FILL_L50_10 P 8.4701999999999998e-17
C1098 FILL_L50_10 0 1.16954e-16
C1099 FILL_L50_11 FILL_L50_15 9.8854299999999996e-17
C1100 FILL_L50_11 FILL_L50_7 9.8854299999999996e-17
C1101 FILL_L50_11 FILL_L8_24 1.4195600000000002e-17
C1102 FILL_L50_11 FILL_L8_25 1.2032500000000001e-17
C1103 FILL_L50_11 FILL_L8_29 1.6602600000000002e-18
C1104 FILL_L50_11 N 6.892050000000001e-18
C1105 FILL_L50_11 P 8.4701999999999998e-17
C1106 FILL_L50_11 0 2.0894700000000002e-16
C1107 FILL_L50_12 FILL_L50_13 9.8854299999999996e-17
C1108 FILL_L50_12 FILL_L50_8 1.9770900000000003e-17
C1109 FILL_L50_12 FILL_L8_26 2.9294800000000002e-18
C1110 FILL_L50_12 FILL_L8_31 2.94757e-18
C1111 FILL_L50_12 0 1.6679700000000002e-16
C1112 FILL_L50_13 FILL_L50_14 9.8854299999999996e-17
C1113 FILL_L50_13 FILL_L50_9 9.8854299999999996e-17
C1114 FILL_L50_13 FILL_L8_26 6.9525000000000006e-18
C1115 FILL_L50_13 FILL_L8_27 1.8504200000000004e-17
C1116 FILL_L50_13 FILL_L8_32 1.10534e-17
C1117 FILL_L50_13 0 2.3504500000000001e-16
C1118 FILL_L50_14 FILL_L50_15 9.8854299999999996e-17
C1119 FILL_L50_14 FILL_L8_28 1.6764299999999999e-17
C1120 FILL_L50_14 FILL_L8_29 3.3519100000000004e-18
C1121 FILL_L50_14 FILL_L8_33 1.2895600000000001e-17
C1122 FILL_L50_14 0 2.2815999999999999e-16
C1123 FILL_L50_15 FILL_L8_29 1.9995400000000001e-17
C1124 FILL_L50_15 FILL_L8_30 1.0691700000000001e-17
C1125 FILL_L50_15 FILL_L8_34 9.2111400000000007e-18
C1126 FILL_L50_15 0 3.2134900000000002e-16
C1127 FILL_L50_2 FILL_L50_3 9.8854299999999996e-17
C1128 FILL_L50_2 FILL_L50_6 9.8854299999999996e-17
C1129 FILL_L50_2 N 2.7659700000000002e-18
C1130 FILL_L50_2 0 1.72753e-16
C1131 FILL_L50_3 FILL_L50_7 9.8854299999999996e-17
C1132 FILL_L50_3 N 2.8009800000000001e-18
C1133 FILL_L50_3 0 2.5104500000000002e-16
C1134 FILL_L50_4 FILL_L50_5 9.8854299999999996e-17
C1135 FILL_L50_4 FILL_L50_8 1.9770900000000003e-17
C1136 FILL_L50_4 N 2.4985800000000002e-17
C1137 FILL_L50_4 P 2.07321e-18
C1138 FILL_L50_4 0 1.4175800000000002e-16
C1139 FILL_L50_5 FILL_L50_6 9.8854299999999996e-17
C1140 FILL_L50_5 FILL_L50_9 9.8854299999999996e-17
C1141 FILL_L50_5 FILL_L8_1 7.9344700000000002e-19
C1142 FILL_L50_5 FILL_L8_13 1.3905000000000002e-18
C1143 FILL_L50_5 FILL_L8_14 1.4679600000000001e-18
C1144 FILL_L50_5 FILL_L8_6 1.5447000000000001e-18
C1145 FILL_L50_5 N 1.2492900000000002e-16
C1146 FILL_L50_5 P 1.0366100000000001e-17
C1147 FILL_L50_5 0 1.4252800000000001e-16
C1148 FILL_L50_6 FILL_L50_7 9.8854299999999996e-17
C1149 FILL_L50_6 FILL_L8_17 7.4784099999999999e-19
C1150 FILL_L50_6 FILL_L8_18 6.7038200000000004e-19
C1151 FILL_L50_6 FILL_L8_2 1.19017e-18
C1152 FILL_L50_6 FILL_L8_9 7.7235000000000007e-19
C1153 FILL_L50_6 N 1.2492900000000002e-16
C1154 FILL_L50_6 P 1.0366100000000001e-17
C1155 FILL_L50_6 0 1.3364700000000001e-16
C1156 FILL_L50_7 FILL_L8_11 1.5447000000000001e-18
C1157 FILL_L50_7 FILL_L8_19 2.1383400000000001e-18
C1158 FILL_L50_7 FILL_L8_20 2.1383400000000001e-18
C1159 FILL_L50_7 FILL_L8_3 3.9672400000000006e-19
C1160 FILL_L50_7 N 1.2492900000000002e-16
C1161 FILL_L50_7 P 1.0366100000000001e-17
C1162 FILL_L50_7 0 2.31614e-16
C1163 FILL_L50_8 FILL_L50_9 9.8854299999999996e-17
C1164 FILL_L50_8 FILL_L8_21 4.9137300000000003e-19
C1165 FILL_L50_8 FILL_L8_26 4.8181400000000001e-19
C1166 FILL_L50_8 N 1.37841e-18
C1167 FILL_L50_8 P 1.6940400000000003e-17
C1168 FILL_L50_8 0 1.3799500000000001e-16
C1169 FILL_L50_9 FILL_L8_21 6.9525000000000006e-18
C1170 FILL_L50_9 FILL_L8_22 9.8471600000000005e-18
C1171 FILL_L50_9 FILL_L8_27 2.0251700000000002e-18
C1172 FILL_L50_9 N 6.892050000000001e-18
C1173 FILL_L50_9 P 8.4701999999999998e-17
C1174 FILL_L50_9 0 1.20168e-16
C1175 FILL_L8_0 FILL_L8_1 3.3255299999999999e-17
C1176 FILL_L8_0 FILL_L8_5 1.9913400000000001e-17
C1177 FILL_L8_0 0 4.0307300000000001e-16
C1178 FILL_L8_1 FILL_L8_2 3.3255299999999999e-17
C1179 FILL_L8_1 FILL_L8_6 1.9913400000000001e-17
C1180 FILL_L8_1 FILL_L8_7 1.9913400000000001e-17
C1181 FILL_L8_1 0 5.2374000000000001e-16
C1182 FILL_L8_10 FILL_L8_11 1.9913400000000001e-17
C1183 FILL_L8_10 FILL_L8_3 1.9913400000000001e-17
C1184 FILL_L8_10 FILL_L8_9 1.9913400000000001e-17
C1185 FILL_L8_10 0 1.3892e-16
C1186 FILL_L8_11 FILL_L8_12 1.9913400000000001e-17
C1187 FILL_L8_11 FILL_L8_3 1.9913400000000001e-17
C1188 FILL_L8_11 0 1.3892e-16
C1189 FILL_L8_12 FILL_L8_4 1.9913400000000001e-17
C1190 FILL_L8_12 0 1.5550800000000003e-16
C1191 FILL_L8_13 FILL_L8_14 1.9913400000000001e-17
C1192 FILL_L8_13 FILL_L8_21 1.9913400000000001e-17
C1193 FILL_L8_13 N 3.0723200000000002e-19
C1194 FILL_L8_13 P 3.0386700000000001e-19
C1195 FILL_L8_13 0 1.4896900000000002e-16
C1196 FILL_L8_14 FILL_L8_15 1.9913400000000001e-17
C1197 FILL_L8_14 FILL_L8_22 1.9913400000000001e-17
C1198 FILL_L8_14 N 3.3795500000000002e-19
C1199 FILL_L8_14 P 3.3425400000000004e-19
C1200 FILL_L8_14 0 1.3238100000000001e-16
C1201 FILL_L8_15 FILL_L8_16 1.9913400000000001e-17
C1202 FILL_L8_15 FILL_L8_22 1.9913400000000001e-17
C1203 FILL_L8_15 N 3.8404000000000001e-19
C1204 FILL_L8_15 P 3.7983400000000005e-19
C1205 FILL_L8_15 0 1.3238100000000001e-16
C1206 FILL_L8_16 FILL_L8_17 1.9913400000000001e-17
C1207 FILL_L8_16 FILL_L8_23 1.9913400000000001e-17
C1208 FILL_L8_16 N 3.8404000000000001e-19
C1209 FILL_L8_16 P 3.7983400000000005e-19
C1210 FILL_L8_16 0 1.3238100000000001e-16
C1211 FILL_L8_17 FILL_L8_18 1.9913400000000001e-17
C1212 FILL_L8_17 FILL_L8_23 1.9913400000000001e-17
C1213 FILL_L8_17 N 3.6483800000000001e-19
C1214 FILL_L8_17 P 3.6084200000000004e-19
C1215 FILL_L8_17 0 1.3238100000000001e-16
C1216 FILL_L8_18 FILL_L8_19 1.9913400000000001e-17
C1217 FILL_L8_18 FILL_L8_24 1.9913400000000001e-17
C1218 FILL_L8_18 N 3.8404000000000001e-19
C1219 FILL_L8_18 P 3.7983400000000005e-19
C1220 FILL_L8_18 0 1.3238100000000001e-16
C1221 FILL_L8_19 FILL_L8_20 1.9913400000000001e-17
C1222 FILL_L8_19 FILL_L8_24 1.9913400000000001e-17
C1223 FILL_L8_19 N 3.8404000000000001e-19
C1224 FILL_L8_19 P 3.7983400000000005e-19
C1225 FILL_L8_19 0 1.3238100000000001e-16
C1226 FILL_L8_2 FILL_L8_3 3.3255299999999999e-17
C1227 FILL_L8_2 FILL_L8_8 1.9913400000000001e-17
C1228 FILL_L8_2 FILL_L8_9 1.9913400000000001e-17
C1229 FILL_L8_2 0 5.2374000000000001e-16
C1230 FILL_L8_20 FILL_L8_25 1.9913400000000001e-17
C1231 FILL_L8_20 N 3.8404000000000001e-19
C1232 FILL_L8_20 P 3.7983400000000005e-19
C1233 FILL_L8_20 0 1.4896900000000002e-16
C1234 FILL_L8_21 FILL_L8_22 6.96968e-17
C1235 FILL_L8_21 FILL_L8_26 4.5800800000000004e-17
C1236 FILL_L8_21 N 6.4988100000000013e-19
C1237 FILL_L8_21 P 7.7827700000000009e-19
C1238 FILL_L8_21 0 6.2394500000000012e-16
C1239 FILL_L8_22 FILL_L8_23 6.96968e-17
C1240 FILL_L8_22 FILL_L8_27 6.96968e-17
C1241 FILL_L8_22 N 1.2069200000000002e-18
C1242 FILL_L8_22 P 1.2526600000000002e-18
C1243 FILL_L8_22 0 7.7080399999999999e-16
C1244 FILL_L8_23 FILL_L8_24 6.96968e-17
C1245 FILL_L8_23 FILL_L8_28 6.96968e-17
C1246 FILL_L8_23 N 1.23192e-18
C1247 FILL_L8_23 P 1.2786000000000001e-18
C1248 FILL_L8_23 0 7.7080399999999999e-16
C1249 FILL_L8_24 FILL_L8_25 6.96968e-17
C1250 FILL_L8_24 FILL_L8_29 6.96968e-17
C1251 FILL_L8_24 N 1.2497700000000001e-18
C1252 FILL_L8_24 P 1.29713e-18
C1253 FILL_L8_24 0 7.7080399999999999e-16
C1254 FILL_L8_25 FILL_L8_30 2.3896100000000003e-17
C1255 FILL_L8_25 N 3.5707800000000001e-19
C1256 FILL_L8_25 P 3.7060800000000002e-19
C1257 FILL_L8_25 0 4.2395400000000004e-16
C1258 FILL_L8_26 FILL_L8_27 6.96968e-17
C1259 FILL_L8_26 FILL_L8_31 4.5800800000000004e-17
C1260 FILL_L8_26 0 6.06707e-16
C1261 FILL_L8_27 FILL_L8_28 6.96968e-17
C1262 FILL_L8_27 FILL_L8_32 6.96968e-17
C1263 FILL_L8_27 0 7.5091400000000008e-16
C1264 FILL_L8_28 FILL_L8_29 6.96968e-17
C1265 FILL_L8_28 FILL_L8_33 6.96968e-17
C1266 FILL_L8_28 0 7.5091400000000008e-16
C1267 FILL_L8_29 FILL_L8_30 6.96968e-17
C1268 FILL_L8_29 FILL_L8_34 6.96968e-17
C1269 FILL_L8_29 0 7.5091400000000008e-16
C1270 FILL_L8_3 FILL_L8_4 3.3255299999999999e-17
C1271 FILL_L8_3 0 5.2374000000000001e-16
C1272 FILL_L8_30 FILL_L8_35 2.3896100000000003e-17
C1273 FILL_L8_30 0 4.2130200000000005e-16
C1274 FILL_L8_31 FILL_L8_32 1.6528100000000001e-17
C1275 FILL_L8_31 0 2.6273000000000003e-16
C1276 FILL_L8_32 FILL_L8_33 1.6528100000000001e-17
C1277 FILL_L8_32 0 3.5893900000000005e-16
C1278 FILL_L8_33 FILL_L8_34 1.6528100000000001e-17
C1279 FILL_L8_33 0 3.5893900000000005e-16
C1280 FILL_L8_34 FILL_L8_35 1.6528100000000001e-17
C1281 FILL_L8_34 0 3.5893900000000005e-16
C1282 FILL_L8_35 0 1.6192e-16
C1283 FILL_L8_4 0 2.52881e-16
C1284 FILL_L8_5 FILL_L8_6 1.9913400000000001e-17
C1285 FILL_L8_5 0 1.5550800000000003e-16
C1286 FILL_L8_6 FILL_L8_7 1.9913400000000001e-17
C1287 FILL_L8_6 0 1.3892e-16
C1288 FILL_L8_7 FILL_L8_8 1.9913400000000001e-17
C1289 FILL_L8_7 0 1.3892e-16
C1290 FILL_L8_8 FILL_L8_9 1.9913400000000001e-17
C1291 FILL_L8_8 0 1.3892e-16
C1292 FILL_L8_9 0 1.3892e-16
C1293 N P 4.4090500000000001e-15
C1294 N 0 1.9477200000000002e-16
C1295 P 0 1.8219300000000004e-16
VP P 0 DC 0 AC 1
VN N 0 DC 0 AC 0
.control
set numdgt=17
ac lin 1 1Meg 1Meg
let cp = -imag(i(VP))/(2*pi*1e6)
let cn = -imag(i(VN))/(2*pi*1e6)
print cp cn
quit
.endc
.end
