* Extracted by KLayout with SG13G2 LVS runset on : 23/09/2026 06:31

.SUBCKT sense_fill_clip
.ENDS sense_fill_clip
