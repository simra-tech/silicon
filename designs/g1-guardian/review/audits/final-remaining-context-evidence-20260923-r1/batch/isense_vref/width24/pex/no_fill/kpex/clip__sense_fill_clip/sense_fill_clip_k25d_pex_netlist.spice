*********************************************************
*** NGSPICE file created by KLayout-PEX 0.3.12
*** -----------------------------------------------------
***     Extraction Engine: KPEX/2.5D
***     Technology: ihp_sg13g2
***     Date: 2026-09-23 06:31:16
*********************************************************

.SUBCKT sense_fill_clip
Cext_1 CTX_L126_0|CTX_L134_0 CTX_L134_1 605.204a
Cext_2 CTX_L126_0|CTX_L134_0 CTX_L30_0 130.298a
Cext_3 CTX_L126_0|CTX_L134_0 CTX_L30_1 59.6783a
Cext_4 CTX_L126_0|CTX_L134_0 CTX_L30_2 3.68001a
Cext_5 CTX_L126_0|CTX_L134_0 CTX_L30_5 12.5657a
Cext_6 CTX_L126_0|CTX_L134_0 CTX_L30_7 6.73941a
Cext_7 CTX_L126_0|CTX_L134_0 CTX_L30_8 4.58896a
Cext_8 CTX_L126_0|CTX_L134_0 CTX_L30_9 1.50318a
Cext_9 CTX_L126_0|CTX_L134_0 CTX_L67_2 219.047a
Cext_10 CTX_L126_0|CTX_L134_0 CTX_L67_3 68.8563a
Cext_11 CTX_L126_0|CTX_L134_0 CTX_L67_4 34.6204a
Cext_12 CTX_L126_0|CTX_L134_0 CTX_L67_5 27.1969a
Cext_13 CTX_L126_0|CTX_L134_0 CTX_L67_6 16.0595a
Cext_14 CTX_L126_0|CTX_L134_0 CTX_L67_7 10.8564a
Cext_15 CTX_L126_0|CTX_L134_0 CTX_L8_0 106.916a
Cext_16 CTX_L126_0|CTX_L134_0 N 156.775a
Cext_17 CTX_L126_0|CTX_L134_0 P 177.92a
Cext_18 CTX_L126_0|CTX_L134_0 VSUBS 3.41971f
Cext_19 CTX_L134_1 CTX_L30_0 81.9932a
Cext_20 CTX_L134_1 CTX_L30_1 14.3583a
Cext_21 CTX_L134_1 CTX_L30_2 1.32424a
Cext_22 CTX_L134_1 CTX_L30_3 1.32424a
Cext_23 CTX_L134_1 CTX_L30_4 3.46109a
Cext_24 CTX_L134_1 CTX_L30_5 29.9588a
Cext_25 CTX_L134_1 CTX_L30_6 22.6516a
Cext_26 CTX_L134_1 CTX_L30_7 53.9966a
Cext_27 CTX_L134_1 CTX_L30_8 35.4126a
Cext_28 CTX_L134_1 CTX_L30_9 19.8447a
Cext_29 CTX_L134_1 CTX_L67_2 51.3104a
Cext_30 CTX_L134_1 CTX_L67_3 33.3676a
Cext_31 CTX_L134_1 CTX_L67_4 35.9997a
Cext_32 CTX_L134_1 CTX_L67_5 45.3395a
Cext_33 CTX_L134_1 CTX_L67_6 56.3654a
Cext_34 CTX_L134_1 CTX_L67_7 78.736a
Cext_35 CTX_L134_1 CTX_L8_0 44.5021a
Cext_36 CTX_L134_1 N 94.6775a
Cext_37 CTX_L134_1 P 51.3454a
Cext_38 CTX_L134_1 VSUBS 2.69113f
Cext_39 CTX_L30_0 CTX_L30_1 144.502a
Cext_40 CTX_L30_0 CTX_L8_0 32.5205a
Cext_41 CTX_L30_0 N 85.4872a
Cext_42 CTX_L30_0 P 31.3935a
Cext_43 CTX_L30_0 VSUBS 1.18162f
Cext_44 CTX_L30_1 CTX_L30_2 4.30617f
Cext_45 CTX_L30_1 CTX_L67_2 92.488a
Cext_46 CTX_L30_1 N 5.64301a
Cext_47 CTX_L30_1 P 6.53623a
Cext_48 CTX_L30_1 VSUBS 608.735a
Cext_49 CTX_L30_2 CTX_L30_3 4.30617f
Cext_50 CTX_L30_2 CTX_L67_3 92.488a
Cext_51 CTX_L30_2 VSUBS 121.155a
Cext_52 CTX_L30_3 CTX_L30_4 4.30617f
Cext_53 CTX_L30_3 CTX_L67_4 92.488a
Cext_54 CTX_L30_3 VSUBS 121.155a
Cext_55 CTX_L30_4 CTX_L30_5 4.30617f
Cext_56 CTX_L30_4 CTX_L67_5 92.488a
Cext_57 CTX_L30_4 VSUBS 121.155a
Cext_58 CTX_L30_5 CTX_L30_6 4.30617f
Cext_59 CTX_L30_5 CTX_L67_5 51.178a
Cext_60 CTX_L30_5 CTX_L67_6 51.178a
Cext_61 CTX_L30_5 VSUBS 121.155a
Cext_62 CTX_L30_6 CTX_L30_7 213.177a
Cext_63 CTX_L30_6 CTX_L67_6 92.488a
Cext_64 CTX_L30_6 CTX_L67_7 31.3935a
Cext_65 CTX_L30_6 VSUBS 498.868a
Cext_66 CTX_L30_7 CTX_L30_8 1.26652f
Cext_67 CTX_L30_7 CTX_L67_7 32.0937a
Cext_68 CTX_L30_7 VSUBS 556.148a
Cext_69 CTX_L30_8 CTX_L30_9 4.30617f
Cext_70 CTX_L30_8 CTX_L67_7 13.4369a
Cext_71 CTX_L30_8 VSUBS 178.435a
Cext_72 CTX_L30_9 CTX_L67_7 7.50391a
Cext_73 CTX_L30_9 VSUBS 696.695a
Cext_74 CTX_L67_2 CTX_L67_3 4.40905f
Cext_75 CTX_L67_2 P 239.266a
Cext_76 CTX_L67_2 VSUBS 395.173a
Cext_77 CTX_L67_3 CTX_L67_4 4.40905f
Cext_78 CTX_L67_3 VSUBS 51.5994a
Cext_79 CTX_L67_4 CTX_L67_5 4.40905f
Cext_80 CTX_L67_4 VSUBS 51.5994a
Cext_81 CTX_L67_5 CTX_L67_6 1.60753f
Cext_82 CTX_L67_5 VSUBS 71.7833a
Cext_83 CTX_L67_6 CTX_L67_7 1.60753f
Cext_84 CTX_L67_6 VSUBS 110.383a
Cext_85 CTX_L67_7 VSUBS 609.778a
Cext_86 CTX_L8_0 N 26.4652a
Cext_87 CTX_L8_0 P 4.90995a
Cext_88 CTX_L8_0 VSUBS 1.78611f
Cext_89 N P 4.40905f
Cext_90 N VSUBS 572.569a
Cext_91 P VSUBS 423.717a
.ENDS sense_fill_clip
