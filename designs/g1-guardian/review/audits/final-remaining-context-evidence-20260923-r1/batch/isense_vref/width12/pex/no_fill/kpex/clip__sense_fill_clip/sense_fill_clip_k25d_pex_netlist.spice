*********************************************************
*** NGSPICE file created by KLayout-PEX 0.3.12
*** -----------------------------------------------------
***     Extraction Engine: KPEX/2.5D
***     Technology: ihp_sg13g2
***     Date: 2026-09-23 06:31:04
*********************************************************

.SUBCKT sense_fill_clip
Cext_1 CTX_L126_0|CTX_L134_0 CTX_L134_1 219.051a
Cext_2 CTX_L126_0|CTX_L134_0 CTX_L30_0 122.079a
Cext_3 CTX_L126_0|CTX_L134_0 CTX_L30_1 59.6783a
Cext_4 CTX_L126_0|CTX_L134_0 CTX_L30_2 3.68001a
Cext_5 CTX_L126_0|CTX_L134_0 CTX_L67_2 219.047a
Cext_6 CTX_L126_0|CTX_L134_0 CTX_L67_3 68.8563a
Cext_7 CTX_L126_0|CTX_L134_0 CTX_L67_4 34.6204a
Cext_8 CTX_L126_0|CTX_L134_0 CTX_L67_5 1.41509a
Cext_9 CTX_L126_0|CTX_L134_0 CTX_L8_0 58.2017a
Cext_10 CTX_L126_0|CTX_L134_0 N 152.543a
Cext_11 CTX_L126_0|CTX_L134_0 P 177.92a
Cext_12 CTX_L126_0|CTX_L134_0 VSUBS 1.83634f
Cext_13 CTX_L134_1 CTX_L30_0 73.3755a
Cext_14 CTX_L134_1 CTX_L30_1 14.3583a
Cext_15 CTX_L134_1 CTX_L30_2 1.32424a
Cext_16 CTX_L134_1 CTX_L30_3 1.32424a
Cext_17 CTX_L134_1 CTX_L30_4 0.662121a
Cext_18 CTX_L134_1 CTX_L67_2 38.5554a
Cext_19 CTX_L134_1 CTX_L67_3 18.7425a
Cext_20 CTX_L134_1 CTX_L67_4 19.3985a
Cext_21 CTX_L134_1 CTX_L67_5 1.97925a
Cext_22 CTX_L134_1 CTX_L8_0 42.5766a
Cext_23 CTX_L134_1 N 84.7681a
Cext_24 CTX_L134_1 P 45.9244a
Cext_25 CTX_L134_1 VSUBS 1.32815f
Cext_26 CTX_L30_0 CTX_L30_1 144.502a
Cext_27 CTX_L30_0 CTX_L8_0 32.5205a
Cext_28 CTX_L30_0 N 85.4872a
Cext_29 CTX_L30_0 P 31.3935a
Cext_30 CTX_L30_0 VSUBS 1.18162f
Cext_31 CTX_L30_1 CTX_L30_2 4.30617f
Cext_32 CTX_L30_1 CTX_L67_2 92.488a
Cext_33 CTX_L30_1 N 5.64301a
Cext_34 CTX_L30_1 P 6.53623a
Cext_35 CTX_L30_1 VSUBS 608.735a
Cext_36 CTX_L30_2 CTX_L30_3 4.30617f
Cext_37 CTX_L30_2 CTX_L67_3 92.488a
Cext_38 CTX_L30_2 VSUBS 121.155a
Cext_39 CTX_L30_3 CTX_L30_4 4.30617f
Cext_40 CTX_L30_3 CTX_L67_4 92.488a
Cext_41 CTX_L30_3 VSUBS 121.155a
Cext_42 CTX_L30_4 CTX_L67_5 4.6244a
Cext_43 CTX_L30_4 VSUBS 660.385a
Cext_44 CTX_L67_2 CTX_L67_3 4.40905f
Cext_45 CTX_L67_2 P 239.266a
Cext_46 CTX_L67_2 VSUBS 395.173a
Cext_47 CTX_L67_3 CTX_L67_4 4.40905f
Cext_48 CTX_L67_3 VSUBS 51.5994a
Cext_49 CTX_L67_4 CTX_L67_5 4.40905f
Cext_50 CTX_L67_4 VSUBS 51.5994a
Cext_51 CTX_L67_5 VSUBS 571.385a
Cext_52 CTX_L8_0 N 26.4652a
Cext_53 CTX_L8_0 P 4.90995a
Cext_54 CTX_L8_0 VSUBS 1.78611f
Cext_55 N P 4.40905f
Cext_56 N VSUBS 572.569a
Cext_57 P VSUBS 423.717a
.ENDS sense_fill_clip
