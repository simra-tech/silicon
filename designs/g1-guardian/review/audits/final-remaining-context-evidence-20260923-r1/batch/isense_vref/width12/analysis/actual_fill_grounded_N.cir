* actual_fill grounded drive N; diagnostic capacitor-network AC only
C32 0 N 1.5254300000000001e-16
C33 0 P 1.7791999999999999e-16
C69 0 N 7.2356400000000001e-17
C70 0 P 2.5763900000000002e-17
C121 0 N 8.5401399999999999e-17
C122 0 P 3.1315100000000004e-17
C154 0 N 3.5494500000000008e-18
C155 0 P 4.1112900000000009e-18
C215 0 P 2.3926600000000002e-16
C280 0 N 6.1807400000000003e-18
C281 0 P 2.7790300000000004e-18
C287 0 N 3.7198099999999998e-18
C293 0 N 5.6605700000000005e-18
C302 0 N 1.6079600000000001e-18
C303 0 P 2.8848300000000001e-17
C314 0 N 2.3630000000000001e-18
C315 0 P 1.1573600000000001e-17
C324 0 N 2.41194e-18
C325 0 P 2.5842100000000002e-18
C336 0 N 2.4469000000000001e-18
C337 0 P 2.0705300000000003e-17
C345 0 N 6.9911300000000001e-19
C346 0 P 2.2449400000000003e-17
C354 0 N 5.579710000000001e-18
C361 0 N 5.6605700000000005e-18
C365 0 N 1.9407700000000001e-18
C375 0 N 3.3692000000000002e-17
C376 0 P 1.80546e-18
C388 0 N 1.9775600000000001e-17
C389 0 P 2.7474300000000001e-18
C402 0 N 1.07854e-17
C403 0 P 2.7081900000000002e-18
C416 0 N 2.8609500000000002e-17
C417 0 P 2.7474300000000001e-18
C424 0 N 2.4872600000000001e-17
C425 0 P 8.634800000000001e-19
C443 0 N 1.6494e-16
C444 0 P 2.5809699999999999e-16
C450 0 N 1.3940700000000002e-17
C451 0 P 1.5803800000000002e-17
C462 0 N 1.2466e-18
C463 0 P 1.4650500000000002e-18
C469 0 N 1.1842699999999999e-18
C470 0 P 1.3918e-18
C474 0 N 1.2466e-18
C475 0 P 1.4650500000000002e-18
C480 0 N 1.2466e-18
C481 0 P 1.4650500000000002e-18
C499 0 N 9.9727800000000003e-19
C500 0 P 1.1720400000000001e-18
C506 0 N 1.2466e-18
C507 0 P 1.4650500000000002e-18
C510 0 N 1.2466e-18
C511 0 P 1.4650500000000002e-18
C515 0 N 2.4985800000000002e-17
C516 0 P 2.07321e-18
C522 0 N 1.2492900000000002e-16
C523 0 P 1.0366100000000001e-17
C529 0 N 1.2492900000000002e-16
C530 0 P 1.0366100000000001e-17
C535 0 N 1.2492900000000002e-16
C536 0 P 1.0366100000000001e-17
C540 0 N 1.37841e-18
C541 0 P 1.6940400000000003e-17
C546 0 N 6.892050000000001e-18
C547 0 P 8.4701999999999998e-17
C552 0 N 6.8059000000000009e-18
C553 0 P 8.4701999999999998e-17
C557 0 N 6.892050000000001e-18
C558 0 P 8.4701999999999998e-17
C562 0 N 3.0723200000000002e-19
C563 0 P 3.0386700000000001e-19
C567 0 N 3.3795500000000002e-19
C568 0 P 3.3425400000000004e-19
C574 0 N 1.23192e-18
C575 0 P 1.2786000000000001e-18
C580 0 N 1.2497700000000001e-18
C581 0 P 1.29713e-18
C584 0 N 3.5707800000000001e-19
C585 0 P 3.7060800000000002e-19
C589 0 N 3.8404000000000001e-19
C590 0 P 3.7983400000000005e-19
C593 0 N 3.8404000000000001e-19
C594 0 P 3.7983400000000005e-19
C597 0 N 3.6483800000000001e-19
C598 0 P 3.6084200000000004e-19
C601 0 N 3.8404000000000001e-19
C602 0 P 3.7983400000000005e-19
C605 0 N 3.8404000000000001e-19
C606 0 P 3.7983400000000005e-19
C608 0 N 3.8404000000000001e-19
C609 0 P 3.7983400000000005e-19
C612 0 N 6.4988100000000013e-19
C613 0 P 7.7827700000000009e-19
C615 0 N 1.2069200000000002e-18
C616 0 P 1.2526600000000002e-18
C618 N P 4.4090500000000001e-15
C619 N 0 2.8142100000000001e-16
C620 P 0 1.8221300000000001e-16
VP P 0 DC 0 AC 0
VN N 0 DC 0 AC 1
.control
set numdgt=17
ac lin 1 1Meg 1Meg
let cp = -imag(i(VP))/(2*pi*1e6)
let cn = -imag(i(VN))/(2*pi*1e6)
print cp cn
quit
.endc
.end
