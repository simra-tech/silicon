* cell sense_fill_clip
.SUBCKT sense_fill_clip
* net 1 CTX_L8_0
* net 2 CTX_L30_0
* net 3 CTX_L30_1
* net 4 CTX_L30_2
* net 5 CTX_L30_3
* net 6 CTX_L30_4
* net 7 N
* net 8 P
* net 9 CTX_L67_2
* net 10 CTX_L67_3
* net 11 CTX_L67_4
* net 12 CTX_L67_5
* net 13 CTX_L126_0,CTX_L134_0
* net 14 CTX_L134_1
.ENDS sense_fill_clip
