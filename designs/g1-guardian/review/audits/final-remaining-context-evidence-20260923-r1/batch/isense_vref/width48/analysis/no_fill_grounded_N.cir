* no_fill grounded drive N; diagnostic capacitor-network AC only
C36 0 N 1.5677500000000002e-16
C37 0 P 1.7791999999999999e-16
C63 0 N 9.4677499999999999e-17
C64 0 P 5.1345400000000001e-17
C79 0 N 8.5487200000000008e-17
C80 0 P 3.1393500000000002e-17
C84 0 N 5.6430100000000005e-18
C85 0 P 6.5362299999999999e-18
C138 0 P 2.3926600000000002e-16
C149 0 N 2.64652e-17
C150 0 P 4.9099500000000006e-18
C153 N P 4.4090500000000001e-15
C154 N 0 5.7256900000000004e-16
C155 P 0 4.2371700000000001e-16
VP P 0 DC 0 AC 0
VN N 0 DC 0 AC 1
.control
set numdgt=17
ac lin 1 1Meg 1Meg
let cp = -imag(i(VP))/(2*pi*1e6)
let cn = -imag(i(VN))/(2*pi*1e6)
print cp cn
quit
.endc
.end
