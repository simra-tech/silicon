* actual_fill grounded drive N; diagnostic capacitor-network AC only
C181 0 N 1.5677500000000002e-16
C182 0 P 1.7791999999999999e-16
C278 0 N 7.9258700000000005e-17
C279 0 P 2.8016300000000004e-17
C368 0 N 8.5401399999999999e-17
C369 0 P 3.1315100000000004e-17
C411 0 N 3.5494500000000008e-18
C412 0 P 4.1112900000000009e-18
C848 0 P 2.3926600000000002e-16
C1003 0 N 6.1807400000000003e-18
C1004 0 P 2.7790300000000004e-18
C1147 0 N 1.0953100000000001e-17
C1160 0 N 1.2611500000000001e-17
C1173 0 N 1.1473699999999999e-17
C1187 0 N 1.3749200000000001e-17
C1195 0 N 6.6644100000000003e-18
C1216 0 N 3.3692000000000002e-17
C1217 0 P 1.80546e-18
C1231 0 N 1.9775600000000001e-17
C1232 0 P 2.7474300000000001e-18
C1247 0 N 1.07854e-17
C1248 0 P 2.7081900000000002e-18
C1263 0 N 2.8609500000000002e-17
C1264 0 P 2.7474300000000001e-18
C1272 0 N 2.4872600000000001e-17
C1273 0 P 8.634800000000001e-19
C1282 0 N 1.6079600000000001e-18
C1283 0 P 2.8848300000000001e-17
C1295 0 N 2.3630000000000001e-18
C1296 0 P 1.1573600000000001e-17
C1305 0 N 2.41194e-18
C1306 0 P 2.5842100000000002e-18
C1317 0 N 2.4469000000000001e-18
C1318 0 P 2.0705300000000003e-17
C1326 0 N 6.9911300000000001e-19
C1327 0 P 2.2449400000000003e-17
C1648 0 N 1.6494e-16
C1649 0 P 2.5809699999999999e-16
C1657 0 N 1.3940700000000002e-17
C1658 0 P 1.5803800000000002e-17
C1788 0 N 9.9727800000000003e-19
C1789 0 P 1.1720400000000001e-18
C1802 0 N 1.2466e-18
C1803 0 P 1.4650500000000002e-18
C1807 0 N 1.2466e-18
C1808 0 P 1.4650500000000002e-18
C1812 0 N 1.2466e-18
C1813 0 P 1.4650500000000002e-18
C1819 0 N 1.1842699999999999e-18
C1820 0 P 1.3918e-18
C1824 0 N 1.2466e-18
C1825 0 P 1.4650500000000002e-18
C1830 0 N 1.2466e-18
C1831 0 P 1.4650500000000002e-18
C1888 0 N 2.7659700000000002e-18
C1892 0 N 2.8009800000000001e-18
C1897 0 N 2.4985800000000002e-17
C1898 0 P 2.07321e-18
C1907 0 N 1.2492900000000002e-16
C1908 0 P 1.0366100000000001e-17
C1916 0 N 1.2492900000000002e-16
C1917 0 P 1.0366100000000001e-17
C1924 0 N 1.2492900000000002e-16
C1925 0 P 1.0366100000000001e-17
C1931 0 N 1.37841e-18
C1932 0 P 1.6940400000000003e-17
C1939 0 N 6.892050000000001e-18
C1940 0 P 8.4701999999999998e-17
C1947 0 N 6.8059000000000009e-18
C1948 0 P 8.4701999999999998e-17
C1954 0 N 6.892050000000001e-18
C1955 0 P 8.4701999999999998e-17
C2038 0 N 5.6019600000000004e-19
C2040 0 N 2.7309600000000002e-18
C2090 0 N 3.0723200000000002e-19
C2091 0 P 3.0386700000000001e-19
C2095 0 N 3.3795500000000002e-19
C2096 0 P 3.3425400000000004e-19
C2100 0 N 3.8404000000000001e-19
C2101 0 P 3.7983400000000005e-19
C2105 0 N 3.8404000000000001e-19
C2106 0 P 3.7983400000000005e-19
C2110 0 N 3.6483800000000001e-19
C2111 0 P 3.6084200000000004e-19
C2115 0 N 3.8404000000000001e-19
C2116 0 P 3.7983400000000005e-19
C2120 0 N 3.8404000000000001e-19
C2121 0 P 3.7983400000000005e-19
C2127 0 N 3.8404000000000001e-19
C2128 0 P 3.7983400000000005e-19
C2132 0 N 6.4988100000000013e-19
C2133 0 P 7.7827700000000009e-19
C2137 0 N 1.2069200000000002e-18
C2138 0 P 1.2526600000000002e-18
C2142 0 N 1.23192e-18
C2143 0 P 1.2786000000000001e-18
C2147 0 N 1.2497700000000001e-18
C2148 0 P 1.29713e-18
C2151 0 N 3.5707800000000001e-19
C2152 0 P 3.7060800000000002e-19
C2220 N P 4.4090500000000001e-15
C2221 N 0 1.9477200000000002e-16
C2222 P 0 1.8219300000000004e-16
VP P 0 DC 0 AC 0
VN N 0 DC 0 AC 1
.control
set numdgt=17
ac lin 1 1Meg 1Meg
let cp = -imag(i(VP))/(2*pi*1e6)
let cn = -imag(i(VN))/(2*pi*1e6)
print cp cn
quit
.endc
.end
