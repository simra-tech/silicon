* cell sense_fill_clip
.SUBCKT sense_fill_clip
* net 2 FILL_L8_0
* net 3 FILL_L10_0
* net 4 FILL_L8_1
* net 5 FILL_L10_1
* net 6 FILL_L8_2
* net 7 FILL_L10_2
* net 8 FILL_L10_3
* net 9 FILL_L8_3
* net 10 FILL_L10_4
* net 11 FILL_L8_4
* net 12 FILL_L134_0
* net 13 FILL_L126_0
* net 14 FILL_L30_0
* net 15 FILL_L67_0
* net 16 FILL_L50_0
* net 17 FILL_L8_5
* net 18 FILL_L10_5
* net 19 FILL_L30_1
* net 20 FILL_L50_1
* net 21 FILL_L67_1
* net 22 FILL_L10_6
* net 23 FILL_L8_6
* net 24 FILL_L134_1
* net 25 FILL_L126_1
* net 26 FILL_L8_7
* net 27 FILL_L10_7
* net 28 FILL_L30_2
* net 29 FILL_L67_2
* net 30 FILL_L50_2
* net 31 FILL_L126_2
* net 32 FILL_L134_2
* net 33 FILL_L10_8
* net 34 FILL_L8_8
* net 35 FILL_L30_3
* net 36 FILL_L67_3
* net 37 FILL_L50_3
* net 38 FILL_L10_9
* net 39 FILL_L8_9
* net 40 FILL_L126_3
* net 41 FILL_L134_3
* net 42 FILL_L30_4
* net 43 FILL_L67_4
* net 44 FILL_L50_4
* net 45 FILL_L8_10
* net 46 FILL_L10_10
* net 47 FILL_L50_5
* net 48 FILL_L67_5
* net 49 FILL_L30_5
* net 50 FILL_L10_11
* net 51 FILL_L8_11
* net 52 FILL_L8_12
* net 53 FILL_L10_12
* net 54 FILL_L67_6
* net 55 FILL_L50_6
* net 56 FILL_L30_6
* net 57 FILL_L8_13
* net 58 FILL_L10_13
* net 59 FILL_L30_7
* net 60 FILL_L50_7
* net 61 FILL_L67_7
* net 62 FILL_L10_14
* net 63 FILL_L8_14
* net 64 FILL_L50_8
* net 65 FILL_L67_8
* net 66 FILL_L30_8
* net 67 FILL_L30_9
* net 68 FILL_L67_9
* net 69 FILL_L50_9
* net 70 FILL_L30_10
* net 71 FILL_L50_10
* net 72 FILL_L67_10
* net 73 CTX_L126_0,CTX_L134_0
* net 74 FILL_L50_11
* net 75 FILL_L30_11
* net 76 FILL_L67_11
* net 77 FILL_L30_12
* net 78 FILL_L67_12
* net 79 FILL_L10_15
* net 80 FILL_L8_15
* net 81 FILL_L67_13
* net 82 FILL_L30_13
* net 83 FILL_L8_16
* net 84 FILL_L10_16
* net 85 FILL_L30_14
* net 86 FILL_L67_14
* net 87 FILL_L8_17
* net 88 FILL_L30_15
* net 89 FILL_L67_15
* net 90 FILL_L8_18
* net 91 FILL_L10_17
* net 92 FILL_L8_19
* net 93 CTX_L134_1
* net 94 FILL_L67_16
* net 95 FILL_L30_16
* net 96 FILL_L8_20
* net 97 FILL_L30_17
* net 98 FILL_L67_17
* net 99 FILL_L10_18
* net 100 FILL_L8_21
* net 101 FILL_L30_18
* net 102 FILL_L67_18
* net 103 FILL_L8_22
* net 104 FILL_L10_19
* net 105 FILL_L50_12
* net 106 FILL_L10_20
* net 107 FILL_L8_23
* net 108 FILL_L8_24
* net 109 FILL_L50_13
* net 110 FILL_L10_21
* net 111 FILL_L8_25
* net 112 FILL_L8_26
* net 113 CTX_L8_0
* net 114 FILL_L10_22
* net 115 FILL_L50_14
* net 116 FILL_L8_27
* net 117 FILL_L8_28
* net 118 FILL_L10_23
* net 119 FILL_L50_15
* net 120 FILL_L8_29
* net 121 FILL_L8_30
* net 122 FILL_L10_24
* net 123 P
* net 124 N
* net 125 CTX_L30_0
* net 126 FILL_L50_16
* net 127 FILL_L30_19
* net 128 FILL_L67_19
* net 129 FILL_L10_25
* net 130 FILL_L8_31
* net 131 FILL_L67_20
* net 132 FILL_L30_20
* net 133 FILL_L50_17
* net 134 FILL_L10_26
* net 135 FILL_L8_32
* net 136 FILL_L30_21
* net 137 FILL_L67_21
* net 138 FILL_L30_22
* net 139 FILL_L67_22
* net 140 FILL_L8_33
* net 141 FILL_L10_27
* net 142 FILL_L50_18
* net 143 FILL_L30_23
* net 144 FILL_L67_23
* net 145 FILL_L126_4
* net 146 FILL_L67_24
* net 147 FILL_L30_24
* net 148 FILL_L8_34
* net 149 FILL_L10_28
* net 150 FILL_L50_19
* net 151 FILL_L67_25
* net 152 FILL_L30_25
* net 153 FILL_L10_29
* net 154 FILL_L8_35
* net 155 FILL_L126_5
* net 156 CTX_L67_2
* net 157 CTX_L67_3
* net 158 CTX_L67_4
* net 159 CTX_L67_5
* net 160 CTX_L30_2
* net 161 CTX_L30_3
* net 162 CTX_L30_1
* net 163 CTX_L30_4
* net 164 CTX_L67_7
* net 165 CTX_L67_6
* net 166 FILL_L10_30
* net 167 FILL_L8_36
* net 168 FILL_L8_37
* net 169 FILL_L10_31
* net 170 CTX_L30_6
* net 171 CTX_L30_5
* net 172 FILL_L8_38
* net 173 FILL_L10_32
* net 174 FILL_L10_33
* net 175 FILL_L8_39
* net 176 FILL_L10_34
* net 177 FILL_L8_40
* net 178 FILL_L67_26
* net 179 FILL_L50_20
* net 180 FILL_L67_27
* net 181 FILL_L50_21
* net 182 FILL_L67_28
* net 183 FILL_L67_29
* net 184 CTX_L30_7
* net 185 FILL_L50_22
* net 186 FILL_L67_30
* net 187 FILL_L67_31
* net 188 FILL_L50_23
* net 189 FILL_L67_32
* net 190 FILL_L8_41
* net 191 FILL_L10_35
* net 192 FILL_L10_36
* net 193 FILL_L8_42
* net 194 CTX_L30_9
* net 195 CTX_L30_10
* net 196 CTX_L30_8
* net 197 CTX_L30_11
* net 198 FILL_L10_37
* net 199 FILL_L8_43
* net 200 FILL_L10_38
* net 201 FILL_L8_44
* net 202 FILL_L10_39
* net 203 FILL_L8_45
* net 204 FILL_L126_6
* net 205 FILL_L67_33
* net 206 FILL_L50_24
* net 207 FILL_L10_40
* net 208 FILL_L50_25
* net 209 FILL_L67_34
* net 210 FILL_L10_41
* net 211 FILL_L126_7
* net 212 CTX_L30_14
* net 213 CTX_L30_13
* net 214 CTX_L30_12
* net 215 FILL_L10_42
* net 216 FILL_L67_35
* net 217 FILL_L50_26
* net 218 FILL_L126_8
* net 219 FILL_L10_43
* net 220 FILL_L50_27
* net 221 FILL_L67_36
* net 222 FILL_L10_44
* net 223 FILL_L126_9
* net 224 FILL_L8_46
* net 225 FILL_L8_47
* net 226 FILL_L8_48
* net 227 FILL_L8_49
* net 228 CTX_L8_1
* net 229 CTX_L134_2
* net 230 FILL_L8_50
* net 231 FILL_L8_51
* net 232 FILL_L8_52
* net 233 FILL_L8_53
* net 234 FILL_L10_46
* net 235 FILL_L8_54
* net 236 FILL_L50_28
* net 237 FILL_L67_37
* net 238 FILL_L10_45
* net 239 CTX_L10_0,CTX_L30_15
* net 240 FILL_L8_55
* net 241 FILL_L67_38
* net 242 FILL_L50_29
* net 243 FILL_L8_56
* net 244 CTX_L10_1,CTX_L30_16
* net 245 FILL_L10_47
* net 246 FILL_L8_57
* net 247 FILL_L8_58
* net 248 FILL_L50_30
* net 249 FILL_L67_39
* net 250 FILL_L8_59
* net 251 FILL_L10_48
* net 252 FILL_L8_60
* net 253 FILL_L10_49
* net 254 FILL_L67_40
* net 255 FILL_L50_31
* net 256 FILL_L8_61
* net 257 FILL_L10_50
* net 258 FILL_L8_62
* net 259 CTX_L10_2,CTX_L30_17
* net 260 CTX_L30_18
.ENDS sense_fill_clip
