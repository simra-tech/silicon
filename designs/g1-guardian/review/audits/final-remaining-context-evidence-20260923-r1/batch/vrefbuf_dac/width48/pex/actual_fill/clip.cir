* cell sense_fill_clip
.SUBCKT sense_fill_clip
* net 2 FILL_L67_0
* net 3 FILL_L30_0
* net 4 FILL_L50_0
* net 5 FILL_L67_1
* net 6 FILL_L30_1
* net 7 FILL_L50_1
* net 8 FILL_L50_2
* net 9 FILL_L30_2
* net 10 FILL_L67_2
* net 11 FILL_L67_3
* net 12 FILL_L30_3
* net 13 FILL_L50_3
* net 14 FILL_L134_0
* net 15 FILL_L126_0
* net 16 FILL_L30_4
* net 17 FILL_L50_4
* net 18 FILL_L67_4
* net 19 FILL_L10_0
* net 20 FILL_L8_0
* net 21 FILL_L50_5
* net 22 FILL_L67_5
* net 23 FILL_L30_5
* net 24 FILL_L10_1
* net 25 FILL_L8_1
* net 26 FILL_L134_1
* net 27 FILL_L126_1
* net 28 FILL_L10_2
* net 29 FILL_L8_2
* net 30 FILL_L50_6
* net 31 FILL_L67_6
* net 32 FILL_L30_6
* net 33 FILL_L126_2
* net 34 FILL_L134_2
* net 35 FILL_L8_3
* net 36 FILL_L10_3
* net 37 FILL_L30_7
* net 38 FILL_L67_7
* net 39 FILL_L50_7
* net 40 FILL_L8_4
* net 41 FILL_L10_4
* net 42 FILL_L10_5
* net 43 FILL_L8_5
* net 44 FILL_L8_6
* net 45 FILL_L10_6
* net 46 FILL_L8_7
* net 47 FILL_L10_7
* net 48 FILL_L50_8
* net 49 FILL_L30_8
* net 50 FILL_L67_8
* net 51 FILL_L30_9
* net 52 FILL_L50_9
* net 53 FILL_L67_9
* net 54 FILL_L30_10
* net 55 FILL_L67_10
* net 56 FILL_L50_10
* net 57 CTX_L126_0,CTX_L134_0
* net 58 FILL_L67_11
* net 59 FILL_L50_11
* net 60 FILL_L30_11
* net 61 FILL_L8_8
* net 62 FILL_L67_12
* net 63 FILL_L30_12
* net 64 FILL_L10_8
* net 65 FILL_L8_9
* net 66 FILL_L67_13
* net 67 FILL_L30_13
* net 68 FILL_L8_10
* net 69 FILL_L10_9
* net 70 FILL_L30_14
* net 71 FILL_L67_14
* net 72 FILL_L8_11
* net 73 FILL_L30_15
* net 74 FILL_L8_12
* net 75 FILL_L67_15
* net 76 FILL_L10_10
* net 77 CTX_L134_1
* net 78 FILL_L8_13
* net 79 FILL_L30_16
* net 80 FILL_L67_16
* net 81 FILL_L8_14
* net 82 FILL_L30_17
* net 83 FILL_L67_17
* net 84 FILL_L10_11
* net 85 FILL_L8_15
* net 86 FILL_L67_18
* net 87 FILL_L30_18
* net 88 CTX_L67_0
* net 89 FILL_L8_16
* net 90 FILL_L50_12
* net 91 FILL_L10_12
* net 92 FILL_L8_17
* net 93 FILL_L8_18
* net 94 FILL_L50_13
* net 95 FILL_L10_13
* net 96 FILL_L8_19
* net 97 CTX_L8_0
* net 98 CTX_L30_0
* net 99 FILL_L8_20
* net 100 FILL_L10_14
* net 101 FILL_L50_14
* net 102 FILL_L8_21
* net 103 FILL_L8_22
* net 104 FILL_L10_15
* net 105 FILL_L8_23
* net 106 FILL_L50_15
* net 107 CTX_L67_1
* net 108 FILL_L50_16
* net 109 FILL_L30_19
* net 110 FILL_L67_19
* net 111 FILL_L10_16
* net 112 FILL_L8_24
* net 113 FILL_L67_20
* net 114 FILL_L30_20
* net 115 FILL_L50_17
* net 116 FILL_L10_17
* net 117 FILL_L8_25
* net 118 FILL_L30_21
* net 119 FILL_L67_21
* net 120 FILL_L67_22
* net 121 FILL_L30_22
* net 122 FILL_L8_26
* net 123 FILL_L10_18
* net 124 FILL_L50_18
* net 125 FILL_L67_23
* net 126 FILL_L30_23
* net 127 FILL_L126_3
* net 128 FILL_L67_24
* net 129 FILL_L30_24
* net 130 FILL_L10_19
* net 131 FILL_L8_27
* net 132 FILL_L50_19
* net 133 FILL_L67_25
* net 134 FILL_L30_25
* net 135 N
* net 136 CTX_L67_4
* net 137 P
* net 138 CTX_L67_5
* net 139 CTX_L30_3
* net 140 CTX_L30_4
* net 141 CTX_L30_2
* net 142 CTX_L30_1
* net 143 CTX_L67_6
* net 144 CTX_L67_7
* net 145 CTX_L30_6
* net 146 CTX_L30_5
* net 147 FILL_L50_20
* net 148 FILL_L10_20
* net 149 FILL_L8_28
* net 150 FILL_L50_21
* net 151 FILL_L8_29
* net 152 FILL_L10_21
* net 153 FILL_L10_22
* net 154 FILL_L8_30
* net 155 FILL_L50_22
* net 156 FILL_L10_23
* net 157 FILL_L8_31
* net 158 FILL_L50_23
* net 159 FILL_L67_26
* net 160 FILL_L67_27
* net 161 FILL_L67_28
* net 162 CTX_L30_7
* net 163 FILL_L67_29
* net 164 FILL_L67_30
* net 165 FILL_L67_31
* net 166 FILL_L67_32
* net 167 FILL_L10_24
* net 168 FILL_L8_32
* net 169 FILL_L8_33
* net 170 FILL_L10_25
* net 171 CTX_L30_10
* net 172 CTX_L30_11
* net 173 CTX_L30_9
* net 174 CTX_L30_8
* net 175 FILL_L10_26
* net 176 FILL_L8_34
* net 177 FILL_L8_35
* net 178 FILL_L10_27
* net 179 FILL_L126_4
* net 180 FILL_L50_24
* net 181 FILL_L67_33
* net 182 FILL_L10_28
* net 183 FILL_L67_34
* net 184 FILL_L50_25
* net 185 FILL_L10_29
* net 186 FILL_L126_5
* net 187 CTX_L30_14
* net 188 CTX_L30_13
* net 189 CTX_L30_12
* net 190 FILL_L10_30
* net 191 FILL_L67_35
* net 192 FILL_L50_26
* net 193 FILL_L126_6
* net 194 FILL_L10_31
* net 195 FILL_L50_27
* net 196 FILL_L67_36
* net 197 FILL_L8_36
* net 198 FILL_L8_37
* net 199 FILL_L8_38
* net 200 FILL_L8_39
* net 201 CTX_L134_2
* net 202 CTX_L8_1
* net 203 FILL_L8_40
* net 204 FILL_L8_41
* net 205 FILL_L8_42
* net 206 FILL_L8_43
* net 207 FILL_L50_28
* net 208 FILL_L67_37
* net 209 FILL_L10_33
* net 210 FILL_L8_44
* net 211 CTX_L10_0,CTX_L30_15,CTX_L8_3
* net 212 FILL_L10_32
* net 213 FILL_L8_45
* net 214 FILL_L50_29
* net 215 FILL_L67_38
* net 216 CTX_L10_1,CTX_L30_16,CTX_L8_4
* net 217 FILL_L8_46
* net 218 FILL_L10_34
* net 219 FILL_L8_47
* net 220 FILL_L8_48
* net 221 FILL_L67_39
* net 222 FILL_L50_30
* net 223 FILL_L8_49
* net 224 FILL_L10_35
* net 225 FILL_L10_36
* net 226 FILL_L8_50
* net 227 FILL_L50_31
* net 228 FILL_L67_40
* net 229 FILL_L8_51
* net 230 FILL_L10_37
* net 231 FILL_L10_38
* net 232 CTX_L10_2,CTX_L30_17,CTX_L8_5
* net 233 CTX_L30_18
* net 234 CTX_L30_19
* net 235 CTX_L8_2
* net 236 FILL_L10_39
* net 237 FILL_L10_40
* net 238 FILL_L126_7
* net 239 FILL_L134_3
* net 240 FILL_L50_32
* net 241 FILL_L67_41
* net 242 FILL_L30_26
* net 243 FILL_L30_27
* net 244 CTX_L8_6
* net 245 FILL_L50_33
* net 246 FILL_L67_42
* net 247 FILL_L30_28
* net 248 FILL_L134_4
* net 249 FILL_L126_8
* net 250 FILL_L30_29
* net 251 FILL_L67_43
* net 252 FILL_L50_34
* net 253 FILL_L30_30
* net 254 FILL_L126_9
* net 255 FILL_L134_5
* net 256 FILL_L30_31
* net 257 FILL_L67_44
* net 258 FILL_L50_35
* net 259 FILL_L30_32
* net 260 CTX_L8_7
* net 261 CTX_L8_8
* net 262 FILL_L10_41
* net 263 CTX_L8_9
* net 264 CTX_L8_10
* net 265 CTX_L8_11
* net 266 CTX_L8_12
* net 267 CTX_L8_13
* net 268 FILL_L10_42
* net 269 CTX_L8_14
* net 270 CTX_L8_15
* net 271 CTX_L8_16
* net 272 CTX_L8_17
* net 273 FILL_L10_43
* net 274 CTX_L8_18
.ENDS sense_fill_clip
