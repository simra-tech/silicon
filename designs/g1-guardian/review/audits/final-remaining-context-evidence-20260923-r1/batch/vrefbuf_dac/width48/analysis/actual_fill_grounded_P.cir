* actual_fill grounded drive P; diagnostic capacitor-network AC only
C233 0 N 7.3430000000000017e-17
C234 0 P 2.3268600000000002e-16
C319 0 N 2.0397800000000001e-17
C320 0 P 2.8612200000000002e-17
C452 0 P 2.7746400000000002e-17
C724 0 N 8.601380000000001e-17
C984 0 P 2.3926600000000002e-16
C998 0 N 4.4090500000000001e-15
C1424 0 P 3.2077500000000002e-17
C1436 0 P 1.0692500000000002e-17
C1454 0 P 2.1385000000000004e-17
C1814 0 N 1.1272300000000001e-16
C1815 0 P 2.5633400000000004e-16
C1826 0 N 3.9997899999999999e-19
C1827 0 P 3.5549500000000004e-19
C1845 0 N 1.0618900000000002e-18
C1846 0 P 8.5153400000000011e-19
C2118 0 N 3.6127400000000007e-17
C2119 0 P 1.4450100000000002e-16
C2126 0 N 7.2254700000000007e-17
C2127 0 P 2.8900200000000005e-16
C2134 0 N 7.2254700000000007e-17
C2135 0 P 2.8900200000000005e-16
C2140 0 N 7.1565100000000004e-17
C2141 0 P 2.8210500000000003e-16
C2150 0 N 1.8119300000000003e-18
C2157 0 N 3.5332700000000003e-18
C2164 0 N 3.5785700000000004e-18
C2169 0 N 3.6238600000000007e-18
C2373 N P 4.4090500000000001e-15
C2374 N 0 3.7342700000000001e-17
C2375 P 0 1.2339000000000002e-16
VP P 0 DC 0 AC 1
VN N 0 DC 0 AC 0
.control
set numdgt=17
ac lin 1 1Meg 1Meg
let cp = -imag(i(VP))/(2*pi*1e6)
let cn = -imag(i(VN))/(2*pi*1e6)
print cp cn
quit
.endc
.end
