* no_fill grounded drive P; diagnostic capacitor-network AC only
C57 0 N 7.3536500000000009e-17
C58 0 P 2.3286000000000005e-16
C84 0 N 3.19665e-17
C85 0 P 4.9884300000000005e-17
C109 0 P 9.2488000000000003e-17
C150 0 N 9.2488000000000003e-17
C181 0 P 2.3926600000000002e-16
C184 0 N 4.4090500000000001e-15
C232 N P 4.4090500000000001e-15
C233 N 0 5.1599400000000006e-17
C234 P 0 3.9517300000000002e-16
VP P 0 DC 0 AC 1
VN N 0 DC 0 AC 0
.control
set numdgt=17
ac lin 1 1Meg 1Meg
let cp = -imag(i(VP))/(2*pi*1e6)
let cn = -imag(i(VN))/(2*pi*1e6)
print cp cn
quit
.endc
.end
