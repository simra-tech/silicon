* cell sense_fill_clip
.SUBCKT sense_fill_clip
* net 2 CTX_L126_0,CTX_L134_0
* net 3 CTX_L134_1
* net 4 CTX_L8_0
* net 5 CTX_L30_0
* net 6 CTX_L67_0
* net 7 CTX_L67_1
* net 8 P
* net 9 CTX_L67_4
* net 10 N
* net 11 CTX_L30_1
* net 12 CTX_L30_2
* net 13 CTX_L67_5
* net 14 CTX_L30_3
* net 15 CTX_L67_6
* net 16 CTX_L30_4
* net 17 CTX_L30_5
* net 18 CTX_L67_7
* net 19 CTX_L30_6
* net 20 CTX_L30_7
* net 21 CTX_L30_8
* net 22 CTX_L30_9
* net 23 CTX_L30_10
* net 24 CTX_L30_11
* net 25 CTX_L30_12
* net 26 CTX_L30_13
* net 27 CTX_L30_14
* net 28 CTX_L8_1
* net 29 CTX_L134_2
* net 30 CTX_L10_0,CTX_L30_15,CTX_L8_3
* net 31 CTX_L10_1,CTX_L30_16,CTX_L8_4
* net 32 CTX_L10_2,CTX_L30_17,CTX_L8_5
* net 33 CTX_L30_18
* net 34 CTX_L30_19
* net 35 CTX_L8_2
* net 36 CTX_L8_6
* net 37 CTX_L8_7
* net 38 CTX_L8_8
* net 39 CTX_L8_9
* net 40 CTX_L8_10
* net 41 CTX_L8_11
* net 42 CTX_L8_12
* net 43 CTX_L8_13
* net 44 CTX_L8_14
* net 45 CTX_L8_15
* net 46 CTX_L8_16
* net 47 CTX_L8_17
* net 48 CTX_L8_18
.ENDS sense_fill_clip
