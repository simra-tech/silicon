* actual_fill grounded drive N; diagnostic capacitor-network AC only
C35 0 N 7.3459900000000008e-17
C36 0 P 2.3250500000000002e-16
C74 0 N 1.3308600000000002e-17
C75 0 P 2.2773800000000004e-17
C147 0 P 2.7746400000000002e-17
C175 0 N 8.601380000000001e-17
C364 0 P 2.3926600000000002e-16
C376 0 N 4.4090500000000001e-15
C486 0 P 3.2077500000000002e-17
C497 0 P 1.0692500000000002e-17
C513 0 P 2.1385000000000004e-17
C545 0 N 1.1272300000000001e-16
C546 0 P 2.5633400000000004e-16
C586 0 N 3.5785700000000004e-18
C590 0 N 3.6238600000000007e-18
C604 0 N 3.6127400000000007e-17
C605 0 P 1.4450100000000002e-16
C612 0 N 7.2254700000000007e-17
C613 0 P 2.8900200000000005e-16
C619 0 N 7.2254700000000007e-17
C620 0 P 2.8900200000000005e-16
C624 0 N 7.1565100000000004e-17
C625 0 P 2.8210500000000003e-16
C629 0 N 1.8119300000000003e-18
C633 0 N 3.5332700000000003e-18
C676 N P 4.4090500000000001e-15
C677 N 0 3.73934e-17
C678 P 0 1.2339000000000002e-16
VP P 0 DC 0 AC 0
VN N 0 DC 0 AC 1
.control
set numdgt=17
ac lin 1 1Meg 1Meg
let cp = -imag(i(VP))/(2*pi*1e6)
let cn = -imag(i(VN))/(2*pi*1e6)
print cp cn
quit
.endc
.end
