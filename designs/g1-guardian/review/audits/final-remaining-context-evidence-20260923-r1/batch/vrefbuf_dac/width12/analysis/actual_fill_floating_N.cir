* actual_fill floating drive N; diagnostic capacitor-network AC only
C12 0 FILL_L10_0 2.0050700000000001e-17
C13 0 FILL_L10_1 1.21915e-17
C14 0 FILL_L10_2 2.8683900000000003e-18
C15 0 FILL_L10_4 5.5580800000000012e-17
C16 0 FILL_L10_5 2.3812700000000003e-17
C17 0 FILL_L10_8 5.3373400000000003e-17
C18 0 FILL_L10_9 6.18354e-18
C19 0 FILL_L126_0 8.9795800000000004e-17
C20 0 FILL_L30_0 7.4668200000000005e-18
C21 0 FILL_L30_1 1.1958399999999999e-17
C22 0 FILL_L50_0 5.7113899999999998e-18
C23 0 FILL_L50_1 1.9519500000000002e-17
C24 0 FILL_L50_2 8.5367600000000009e-19
C25 0 FILL_L50_4 2.1162500000000001e-16
C26 0 FILL_L50_5 3.4670100000000006e-16
C27 0 FILL_L50_6 6.3755499999999996e-17
C28 0 FILL_L50_8 3.6766800000000007e-17
C29 0 FILL_L50_9 6.8615999999999999e-17
C30 0 FILL_L8_1 1.6365200000000002e-18
C31 0 FILL_L8_12 3.6138799999999999e-19
C32 0 FILL_L8_2 5.36126e-19
C33 0 FILL_L8_8 3.9220400000000001e-18
C34 0 FILL_L8_9 2.1348e-18
C35 0 N 7.3459900000000008e-17
C36 0 P 2.3250500000000002e-16
C52 0 FILL_L10_1 4.4495500000000003e-18
C53 0 FILL_L10_10 9.1295800000000016e-18
C54 0 FILL_L10_11 9.3166899999999994e-18
C55 0 FILL_L10_2 5.2607100000000006e-18
C56 0 FILL_L10_3 1.05548e-18
C57 0 FILL_L10_5 7.5453100000000007e-18
C58 0 FILL_L10_6 1.6544800000000001e-18
C59 0 FILL_L10_9 1.2868600000000001e-17
C60 0 FILL_L126_0 8.2453100000000003e-16
C61 0 FILL_L50_1 1.61449e-18
C62 0 FILL_L50_10 9.1160700000000008e-17
C63 0 FILL_L50_11 1.1452200000000002e-16
C64 0 FILL_L50_2 5.2370400000000004e-18
C65 0 FILL_L50_3 1.9377900000000001e-18
C66 0 FILL_L50_5 3.3584499999999999e-17
C67 0 FILL_L50_6 6.7518699999999998e-17
C68 0 FILL_L50_7 6.9411799999999999e-17
C69 0 FILL_L50_9 4.5055700000000003e-17
C70 0 FILL_L8_10 8.5773300000000004e-19
C71 0 FILL_L8_14 4.4871800000000004e-19
C72 0 FILL_L8_15 9.7203900000000013e-19
C73 0 FILL_L8_5 2.5709100000000003e-19
C74 0 N 1.3308600000000002e-17
C75 0 P 2.2773800000000004e-17
C80 0 FILL_L10_0 1.1859500000000001e-16
C81 0 FILL_L10_1 1.2414100000000002e-16
C82 0 FILL_L10_2 1.2414100000000002e-16
C83 0 FILL_L10_3 1.2414100000000002e-16
C84 0 FILL_L10_4 2.26515e-17
C85 0 FILL_L10_5 2.26515e-17
C86 0 FILL_L10_6 1.8121200000000002e-17
C87 0 FILL_L10_7 2.26515e-17
C88 0 FILL_L126_0 6.9599300000000002e-17
C89 0 FILL_L30_0 2.2766800000000001e-17
C90 0 FILL_L30_1 2.2766800000000001e-17
C91 0 FILL_L30_2 2.2766800000000001e-17
C92 0 FILL_L30_3 2.2766800000000001e-17
C93 0 FILL_L30_4 2.2766800000000001e-17
C94 0 FILL_L30_5 2.2766800000000001e-17
C95 0 FILL_L30_6 2.2766800000000001e-17
C96 0 FILL_L50_0 2.5742700000000001e-17
C97 0 FILL_L50_1 5.1485300000000008e-17
C98 0 FILL_L50_2 5.1485300000000008e-17
C99 0 FILL_L50_3 5.1485300000000008e-17
C100 0 FILL_L50_4 9.9971800000000015e-18
C101 0 FILL_L50_5 1.9994399999999999e-17
C102 0 FILL_L50_6 1.9994399999999999e-17
C103 0 FILL_L50_7 1.9994399999999999e-17
C104 0 FILL_L8_1 1.6102600000000001e-18
C105 0 FILL_L8_2 1.6102600000000001e-18
C106 0 FILL_L8_3 1.6102600000000001e-18
C107 0 FILL_L8_4 1.6102600000000001e-18
C108 0 FILL_L8_5 1.6102600000000001e-18
C109 0 FILL_L8_6 1.6102600000000001e-18
C110 0 FILL_L8_7 1.6102600000000001e-18
C115 0 FILL_L10_0 3.3029000000000001e-19
C116 0 FILL_L10_1 3.4497e-19
C117 0 FILL_L10_10 5.4716600000000002e-18
C118 0 FILL_L10_11 5.5509600000000002e-18
C119 0 FILL_L10_2 2.7524199999999999e-19
C120 0 FILL_L10_3 2.8441600000000004e-19
C121 0 FILL_L10_4 1.7043400000000001e-16
C122 0 FILL_L10_5 1.7043400000000001e-16
C123 0 FILL_L10_6 1.69147e-16
C124 0 FILL_L10_7 1.7043400000000001e-16
C125 0 FILL_L10_8 5.5509600000000002e-18
C126 0 FILL_L10_9 5.5509600000000002e-18
C127 0 FILL_L126_0 3.2415300000000007e-17
C128 0 FILL_L30_0 1.4981700000000001e-17
C129 0 FILL_L30_1 1.4981700000000001e-17
C130 0 FILL_L30_2 1.4981700000000001e-17
C131 0 FILL_L30_3 1.4981700000000001e-17
C132 0 FILL_L30_4 1.4981700000000001e-17
C133 0 FILL_L30_5 1.4981700000000001e-17
C134 0 FILL_L30_6 1.4981700000000001e-17
C135 0 FILL_L50_4 1.2243100000000002e-16
C136 0 FILL_L50_5 2.44863e-16
C137 0 FILL_L50_6 2.44863e-16
C138 0 FILL_L50_7 2.3672000000000003e-16
C139 0 FILL_L8_10 4.2711700000000001e-18
C140 0 FILL_L8_11 4.2711700000000001e-18
C141 0 FILL_L8_12 3.1053500000000002e-18
C142 0 FILL_L8_13 3.1053500000000002e-18
C143 0 FILL_L8_14 3.0609799999999999e-18
C144 0 FILL_L8_15 3.1053500000000002e-18
C145 0 FILL_L8_8 4.2711700000000001e-18
C146 0 FILL_L8_9 4.2711700000000001e-18
C147 0 P 2.7746400000000002e-17
C150 0 FILL_L10_10 9.3197800000000008e-18
C151 0 FILL_L10_11 9.3197800000000008e-18
C152 0 FILL_L10_4 1.4641000000000001e-17
C153 0 FILL_L10_5 1.4641000000000001e-17
C154 0 FILL_L10_6 1.4641000000000001e-17
C155 0 FILL_L10_7 1.4641000000000001e-17
C156 0 FILL_L10_8 9.3197800000000008e-18
C157 0 FILL_L10_9 9.3197800000000008e-18
C158 0 FILL_L126_0 5.9269400000000001e-18
C159 0 FILL_L50_10 4.2251700000000005e-18
C160 0 FILL_L50_11 4.2786600000000005e-18
C161 0 FILL_L50_4 3.4991599999999998e-17
C162 0 FILL_L50_5 6.9983199999999996e-17
C163 0 FILL_L50_6 6.9983199999999996e-17
C164 0 FILL_L50_7 6.9169000000000005e-17
C165 0 FILL_L50_8 2.1393300000000002e-18
C166 0 FILL_L50_9 4.2786600000000005e-18
C167 0 FILL_L8_10 4.0071700000000005e-18
C168 0 FILL_L8_11 4.0071700000000005e-18
C169 0 FILL_L8_12 3.6380300000000002e-18
C170 0 FILL_L8_13 3.6380300000000002e-18
C171 0 FILL_L8_14 3.58606e-18
C172 0 FILL_L8_15 3.6380300000000002e-18
C173 0 FILL_L8_8 4.0071700000000005e-18
C174 0 FILL_L8_9 4.0071700000000005e-18
C175 0 N 8.601380000000001e-17
C179 0 FILL_L10_10 1.62013e-17
C180 0 FILL_L10_11 1.62013e-17
C181 0 FILL_L10_4 8.3981600000000015e-18
C182 0 FILL_L10_5 8.3981600000000015e-18
C183 0 FILL_L10_6 8.3981600000000015e-18
C184 0 FILL_L10_7 8.3981600000000015e-18
C185 0 FILL_L10_8 1.62013e-17
C186 0 FILL_L10_9 1.62013e-17
C187 0 FILL_L126_0 8.5807900000000016e-18
C188 0 FILL_L50_10 7.0434200000000001e-18
C189 0 FILL_L50_11 7.1325700000000009e-18
C190 0 FILL_L50_4 1.2426000000000002e-17
C191 0 FILL_L50_5 2.4852000000000003e-17
C192 0 FILL_L50_6 2.4852000000000003e-17
C193 0 FILL_L50_7 2.4852000000000003e-17
C194 0 FILL_L50_8 3.5662900000000003e-18
C195 0 FILL_L50_9 7.1325700000000009e-18
C196 0 FILL_L8_10 3.5397900000000005e-18
C197 0 FILL_L8_11 3.5397900000000005e-18
C198 0 FILL_L8_12 4.0772300000000001e-18
C199 0 FILL_L8_13 4.0772300000000001e-18
C200 0 FILL_L8_14 4.0189900000000002e-18
C201 0 FILL_L8_15 4.0772300000000001e-18
C202 0 FILL_L8_8 3.5397900000000005e-18
C203 0 FILL_L8_9 3.5397900000000005e-18
C207 0 FILL_L10_10 6.0300000000000001e-17
C208 0 FILL_L10_11 6.0300000000000001e-17
C209 0 FILL_L10_4 4.6143900000000009e-18
C210 0 FILL_L10_5 4.6143900000000009e-18
C211 0 FILL_L10_6 4.6143900000000009e-18
C212 0 FILL_L10_7 4.6143900000000009e-18
C213 0 FILL_L10_8 5.9745399999999999e-17
C214 0 FILL_L10_9 6.0300000000000001e-17
C215 0 FILL_L126_0 8.6692500000000003e-18
C216 0 FILL_L50_10 1.1635100000000001e-17
C217 0 FILL_L50_11 1.1635100000000001e-17
C218 0 FILL_L50_4 7.1480700000000005e-18
C219 0 FILL_L50_5 1.4296099999999999e-17
C220 0 FILL_L50_6 1.4296099999999999e-17
C221 0 FILL_L50_7 1.4296099999999999e-17
C222 0 FILL_L50_8 5.8175700000000005e-18
C223 0 FILL_L50_9 1.1635100000000001e-17
C224 0 FILL_L8_10 2.7141400000000002e-18
C225 0 FILL_L8_11 2.6366000000000003e-18
C226 0 FILL_L8_12 4.019910000000001e-18
C227 0 FILL_L8_13 4.1809300000000006e-18
C228 0 FILL_L8_14 4.1258100000000005e-18
C229 0 FILL_L8_15 4.1809300000000006e-18
C230 0 FILL_L8_8 2.7141400000000002e-18
C231 0 FILL_L8_9 2.7141400000000002e-18
C236 0 FILL_L10_10 1.2561700000000001e-16
C237 0 FILL_L10_11 1.2561700000000001e-16
C238 0 FILL_L10_8 1.2007100000000001e-16
C239 0 FILL_L10_9 1.2561700000000001e-16
C240 0 FILL_L126_0 3.42827e-17
C241 0 FILL_L50_10 2.0218800000000002e-17
C242 0 FILL_L50_11 2.0218800000000002e-17
C243 0 FILL_L50_4 4.2574600000000001e-18
C244 0 FILL_L50_5 8.5149200000000003e-18
C245 0 FILL_L50_6 8.5149200000000003e-18
C246 0 FILL_L50_7 8.5149200000000003e-18
C247 0 FILL_L50_8 1.0109400000000001e-17
C248 0 FILL_L50_9 2.0218800000000002e-17
C249 0 FILL_L8_12 1.6102600000000001e-18
C250 0 FILL_L8_13 3.2205200000000002e-18
C251 0 FILL_L8_14 3.2205200000000002e-18
C252 0 FILL_L8_15 3.2205200000000002e-18
C257 0 FILL_L10_10 2.4392500000000001e-16
C258 0 FILL_L10_11 2.4392500000000001e-16
C259 0 FILL_L10_8 2.3837900000000002e-16
C260 0 FILL_L10_9 2.4392500000000001e-16
C261 0 FILL_L126_0 1.86847e-17
C262 0 FILL_L50_10 1.6032000000000001e-16
C263 0 FILL_L50_11 1.6032000000000001e-16
C264 0 FILL_L50_4 2.7370900000000001e-18
C265 0 FILL_L50_5 5.4741900000000008e-18
C266 0 FILL_L50_6 5.4741900000000008e-18
C267 0 FILL_L50_7 5.4741900000000008e-18
C268 0 FILL_L50_8 8.0159800000000004e-17
C269 0 FILL_L50_9 1.6032000000000001e-16
C270 0 FILL_L8_12 1.6102600000000001e-18
C271 0 FILL_L8_13 3.2205200000000002e-18
C272 0 FILL_L8_14 3.2205200000000002e-18
C273 0 FILL_L8_15 3.2205200000000002e-18
C276 0 FILL_L10_10 6.2468800000000002e-17
C277 0 FILL_L10_11 6.2468800000000002e-17
C278 0 FILL_L10_8 6.2468800000000002e-17
C279 0 FILL_L10_9 6.2468800000000002e-17
C280 0 FILL_L126_0 1.4038000000000002e-17
C281 0 FILL_L50_10 2.496e-16
C282 0 FILL_L50_11 2.4145700000000003e-16
C283 0 FILL_L50_8 1.248e-16
C284 0 FILL_L50_9 2.496e-16
C285 0 FILL_L8_12 3.4897300000000008e-18
C286 0 FILL_L8_13 3.4897300000000008e-18
C287 0 FILL_L8_14 3.4897300000000008e-18
C288 0 FILL_L8_15 3.3900199999999999e-18
C291 0 FILL_L10_0 1.2422800000000001e-17
C292 0 FILL_L10_1 1.14354e-17
C293 0 FILL_L10_2 1.0901600000000001e-17
C294 0 FILL_L10_3 1.1929100000000001e-17
C295 0 FILL_L10_4 2.4469000000000001e-18
C296 0 FILL_L10_5 2.3630000000000001e-18
C297 0 FILL_L10_6 2.4469000000000001e-18
C298 0 FILL_L10_7 2.4469000000000001e-18
C299 0 FILL_L126_0 1.5376800000000002e-16
C300 0 FILL_L30_0 1.2466e-18
C301 0 FILL_L30_1 1.2466e-18
C302 0 FILL_L30_2 1.2466e-18
C303 0 FILL_L30_3 1.2466e-18
C304 0 FILL_L30_4 1.1842699999999999e-18
C305 0 FILL_L30_5 1.2466e-18
C306 0 FILL_L30_6 1.2466e-18
C307 0 FILL_L50_0 1.6268100000000001e-17
C308 0 FILL_L50_1 3.2536300000000002e-17
C309 0 FILL_L50_2 3.2536300000000002e-17
C310 0 FILL_L50_3 3.2536300000000002e-17
C311 0 FILL_L50_4 3.44603e-18
C312 0 FILL_L50_5 6.892050000000001e-18
C313 0 FILL_L50_6 6.892050000000001e-18
C314 0 FILL_L50_7 6.892050000000001e-18
C315 0 FILL_L8_0 3.8404000000000001e-19
C316 0 FILL_L8_1 3.0723200000000002e-19
C317 0 FILL_L8_10 1.2497700000000001e-18
C318 0 FILL_L8_11 1.2497700000000001e-18
C319 0 FILL_L8_2 3.3795500000000002e-19
C320 0 FILL_L8_3 3.8404000000000001e-19
C321 0 FILL_L8_4 3.8404000000000001e-19
C322 0 FILL_L8_5 3.6483800000000001e-19
C323 0 FILL_L8_6 3.8404000000000001e-19
C324 0 FILL_L8_7 3.8404000000000001e-19
C325 0 FILL_L8_8 1.0783700000000002e-18
C326 0 FILL_L8_9 1.2069200000000002e-18
C328 0 FILL_L10_0 2.7474300000000001e-18
C329 0 FILL_L10_1 2.7474300000000001e-18
C330 0 FILL_L10_2 2.7081900000000002e-18
C331 0 FILL_L10_3 2.7474300000000001e-18
C332 0 FILL_L10_4 2.9747100000000001e-17
C333 0 FILL_L10_5 1.1573600000000001e-17
C334 0 FILL_L10_6 2.62166e-18
C335 0 FILL_L10_7 2.0705300000000003e-17
C336 0 FILL_L126_0 2.5648700000000005e-16
C337 0 FILL_L30_0 1.4650500000000002e-18
C338 0 FILL_L30_1 1.4650500000000002e-18
C339 0 FILL_L30_2 1.4650500000000002e-18
C340 0 FILL_L30_3 1.4650500000000002e-18
C341 0 FILL_L30_4 1.3918e-18
C342 0 FILL_L30_5 1.4650500000000002e-18
C343 0 FILL_L30_6 1.4650500000000002e-18
C344 0 FILL_L50_0 5.1830400000000006e-18
C345 0 FILL_L50_1 1.0366100000000001e-17
C346 0 FILL_L50_2 1.0366100000000001e-17
C347 0 FILL_L50_3 1.0366100000000001e-17
C348 0 FILL_L50_4 4.2350999999999999e-17
C349 0 FILL_L50_5 8.4701999999999998e-17
C350 0 FILL_L50_6 8.4701999999999998e-17
C351 0 FILL_L50_7 8.4701999999999998e-17
C352 0 FILL_L8_0 3.7983400000000005e-19
C353 0 FILL_L8_1 3.0386700000000001e-19
C354 0 FILL_L8_10 1.29713e-18
C355 0 FILL_L8_11 1.29713e-18
C356 0 FILL_L8_2 3.3425400000000004e-19
C357 0 FILL_L8_3 3.7983400000000005e-19
C358 0 FILL_L8_4 3.7983400000000005e-19
C359 0 FILL_L8_5 3.6084200000000004e-19
C360 0 FILL_L8_6 3.7983400000000005e-19
C361 0 FILL_L8_7 3.7983400000000005e-19
C362 0 FILL_L8_8 1.2230100000000001e-18
C363 0 FILL_L8_9 1.2526600000000002e-18
C364 0 P 2.3926600000000002e-16
C367 0 FILL_L126_0 1.128e-16
C368 0 FILL_L50_10 5.9655100000000009e-18
C369 0 FILL_L50_11 6.0410199999999999e-18
C370 0 FILL_L50_4 1.0524400000000001e-17
C371 0 FILL_L50_5 2.1048800000000002e-17
C372 0 FILL_L50_6 2.1048800000000002e-17
C373 0 FILL_L50_7 2.1048800000000002e-17
C374 0 FILL_L50_8 3.02051e-18
C375 0 FILL_L50_9 6.0410199999999999e-18
C376 0 N 4.4090500000000001e-15
C379 0 FILL_L10_10 1.1872500000000002e-17
C380 0 FILL_L10_11 1.1872500000000002e-17
C381 0 FILL_L10_8 1.1872500000000002e-17
C382 0 FILL_L10_9 1.1872500000000002e-17
C383 0 FILL_L126_0 1.5293199999999999e-16
C384 0 FILL_L50_10 9.8545400000000015e-18
C385 0 FILL_L50_11 9.8545400000000015e-18
C386 0 FILL_L50_4 6.0541500000000003e-18
C387 0 FILL_L50_5 1.2108300000000001e-17
C388 0 FILL_L50_6 1.2108300000000001e-17
C389 0 FILL_L50_7 1.2108300000000001e-17
C390 0 FILL_L50_8 4.9272700000000007e-18
C391 0 FILL_L50_9 9.8545400000000015e-18
C394 0 FILL_L10_10 1.5522500000000003e-17
C395 0 FILL_L10_11 1.9539999999999999e-17
C396 0 FILL_L10_8 2.1463900000000002e-17
C397 0 FILL_L10_9 1.7616000000000002e-17
C398 0 FILL_L126_0 1.93064e-16
C399 0 FILL_L50_10 9.7841500000000004e-17
C400 0 FILL_L50_11 9.7841500000000004e-17
C401 0 FILL_L50_4 2.3182200000000004e-18
C402 0 FILL_L50_5 4.6364400000000007e-18
C403 0 FILL_L50_6 4.6364400000000007e-18
C404 0 FILL_L50_7 4.6364400000000007e-18
C405 0 FILL_L50_8 4.8920800000000005e-17
C406 0 FILL_L50_9 9.7841500000000004e-17
C408 0 FILL_L10_10 5.5558500000000011e-18
C409 0 FILL_L10_11 2.41847e-17
C410 0 FILL_L10_8 3.3637999999999999e-17
C411 0 FILL_L10_9 1.5062400000000001e-17
C412 0 FILL_L126_0 2.2251400000000001e-16
C413 0 FILL_L50_10 3.2649100000000002e-16
C414 0 FILL_L50_11 3.1959500000000007e-16
C415 0 FILL_L50_8 1.6324600000000002e-16
C416 0 FILL_L50_9 3.2649100000000002e-16
C417 0 FILL_L8_12 1.9152000000000001e-19
C418 0 FILL_L8_13 7.4079700000000006e-19
C419 0 FILL_L8_14 9.2858500000000002e-19
C420 0 FILL_L8_15 3.7930800000000002e-19
C422 FILL_L10_0 FILL_L10_1 1.7599200000000001e-17
C423 FILL_L10_0 FILL_L10_4 9.7773300000000019e-17
C424 FILL_L10_0 FILL_L30_0 1.6053e-18
C425 FILL_L10_0 FILL_L50_0 1.5743600000000003e-17
C426 FILL_L10_0 FILL_L50_1 2.71888e-18
C427 FILL_L10_0 FILL_L50_4 4.7426600000000005e-18
C428 FILL_L10_0 FILL_L8_0 5.7059000000000004e-17
C429 FILL_L10_0 FILL_L8_1 5.7059000000000004e-17
C430 FILL_L10_0 FILL_L8_8 3.9217799999999999e-18
C431 FILL_L10_0 0 2.1878100000000002e-16
C432 FILL_L10_1 FILL_L10_2 1.7599200000000001e-17
C433 FILL_L10_1 FILL_L10_5 9.7773300000000019e-17
C434 FILL_L10_1 FILL_L126_0 3.8964800000000005e-18
C435 FILL_L10_1 FILL_L30_2 1.6053e-18
C436 FILL_L10_1 FILL_L50_1 2.2110700000000004e-17
C437 FILL_L10_1 FILL_L50_2 5.0580400000000011e-19
C438 FILL_L10_1 FILL_L50_5 7.0288800000000001e-18
C439 FILL_L10_1 FILL_L8_2 5.7059000000000004e-17
C440 FILL_L10_1 FILL_L8_3 5.7059000000000004e-17
C441 FILL_L10_1 FILL_L8_9 3.9217799999999999e-18
C442 FILL_L10_1 0 2.0568800000000001e-16
C443 FILL_L10_10 FILL_L10_11 9.7773300000000019e-17
C444 FILL_L10_10 FILL_L10_6 9.7773300000000019e-17
C445 FILL_L10_10 FILL_L10_9 9.7773300000000019e-17
C446 FILL_L10_10 FILL_L126_0 2.1357600000000004e-17
C447 FILL_L10_10 FILL_L50_10 2.6550500000000001e-16
C448 FILL_L10_10 FILL_L50_6 2.3654000000000001e-17
C449 FILL_L10_10 FILL_L8_14 8.2350600000000007e-16
C450 FILL_L10_10 0 2.6896499999999997e-16
C451 FILL_L10_11 FILL_L10_7 9.7773300000000019e-17
C452 FILL_L10_11 FILL_L126_0 4.8127499999999999e-17
C453 FILL_L10_11 FILL_L50_10 2.9176400000000001e-17
C454 FILL_L10_11 FILL_L50_11 2.3879000000000003e-16
C455 FILL_L10_11 FILL_L50_7 1.6956000000000001e-17
C456 FILL_L10_11 FILL_L8_15 8.2350600000000007e-16
C457 FILL_L10_11 0 3.4171100000000005e-16
C458 FILL_L10_2 FILL_L10_3 1.7599200000000001e-17
C459 FILL_L10_2 FILL_L10_6 9.7773300000000019e-17
C460 FILL_L10_2 FILL_L126_0 1.03799e-17
C461 FILL_L10_2 FILL_L30_3 1.6053e-18
C462 FILL_L10_2 FILL_L30_4 7.223850000000001e-19
C463 FILL_L10_2 FILL_L50_2 2.4155600000000001e-17
C464 FILL_L10_2 FILL_L50_6 8.2996500000000004e-18
C465 FILL_L10_2 FILL_L8_10 3.9217799999999999e-18
C466 FILL_L10_2 FILL_L8_4 5.7059000000000004e-17
C467 FILL_L10_2 FILL_L8_5 5.7059000000000004e-17
C468 FILL_L10_2 0 2.0568800000000001e-16
C469 FILL_L10_3 FILL_L10_7 9.7773300000000019e-17
C470 FILL_L10_3 FILL_L126_0 1.9687900000000001e-17
C471 FILL_L10_3 FILL_L30_5 1.6053e-18
C472 FILL_L10_3 FILL_L50_2 1.5171700000000001e-18
C473 FILL_L10_3 FILL_L50_3 1.9852100000000002e-17
C474 FILL_L10_3 FILL_L50_7 5.9283200000000005e-18
C475 FILL_L10_3 FILL_L8_11 3.9217799999999999e-18
C476 FILL_L10_3 FILL_L8_6 5.7059000000000004e-17
C477 FILL_L10_3 FILL_L8_7 5.7059000000000004e-17
C478 FILL_L10_3 0 2.1878200000000004e-16
C479 FILL_L10_4 FILL_L10_5 9.7773300000000019e-17
C480 FILL_L10_4 FILL_L10_8 9.7773300000000019e-17
C481 FILL_L10_4 FILL_L30_0 1.7860600000000001e-16
C482 FILL_L10_4 FILL_L30_1 3.3825600000000003e-17
C483 FILL_L10_4 FILL_L50_4 2.0207300000000002e-16
C484 FILL_L10_4 FILL_L50_5 6.6721199999999996e-17
C485 FILL_L10_4 FILL_L8_8 8.2350600000000007e-16
C486 FILL_L10_4 P 3.2077500000000002e-17
C487 FILL_L10_4 0 2.6895800000000005e-16
C488 FILL_L10_5 FILL_L10_6 9.7773300000000019e-17
C489 FILL_L10_5 FILL_L10_9 9.7773300000000019e-17
C490 FILL_L10_5 FILL_L126_0 7.8477500000000005e-18
C491 FILL_L10_5 FILL_L30_1 6.3965400000000009e-17
C492 FILL_L10_5 FILL_L30_2 1.70725e-16
C493 FILL_L10_5 FILL_L30_3 3.4949400000000003e-18
C494 FILL_L10_5 FILL_L50_5 2.6675700000000002e-16
C495 FILL_L10_5 FILL_L50_6 1.3617800000000002e-17
C496 FILL_L10_5 FILL_L8_9 8.2350600000000007e-16
C497 FILL_L10_5 P 1.0692500000000002e-17
C498 FILL_L10_5 0 1.9621900000000002e-16
C499 FILL_L10_6 FILL_L10_7 9.7773300000000019e-17
C500 FILL_L10_6 FILL_L126_0 9.6767199999999998e-18
C501 FILL_L10_6 FILL_L30_3 1.5088900000000003e-16
C502 FILL_L10_6 FILL_L30_4 1.10579e-16
C503 FILL_L10_6 FILL_L50_6 2.6576100000000002e-16
C504 FILL_L10_6 FILL_L8_10 8.2350600000000007e-16
C505 FILL_L10_6 0 1.9621900000000002e-16
C506 FILL_L10_7 FILL_L126_0 5.1877499999999998e-17
C507 FILL_L10_7 FILL_L30_4 1.3974200000000001e-17
C508 FILL_L10_7 FILL_L30_5 1.7860600000000001e-16
C509 FILL_L10_7 FILL_L30_6 3.3825600000000003e-17
C510 FILL_L10_7 FILL_L50_6 3.7885900000000003e-17
C511 FILL_L10_7 FILL_L50_7 2.5653800000000004e-16
C512 FILL_L10_7 FILL_L8_11 8.2350600000000007e-16
C513 FILL_L10_7 P 2.1385000000000004e-17
C514 FILL_L10_7 0 2.6896499999999997e-16
C515 FILL_L10_8 FILL_L10_9 9.7773300000000019e-17
C516 FILL_L10_8 FILL_L50_4 1.3474000000000001e-17
C517 FILL_L10_8 FILL_L50_8 1.8837800000000001e-16
C518 FILL_L10_8 FILL_L50_9 5.2286100000000001e-17
C519 FILL_L10_8 FILL_L8_12 8.2350600000000007e-16
C520 FILL_L10_8 0 3.4170300000000001e-16
C521 FILL_L10_9 FILL_L126_0 1.0445100000000002e-17
C522 FILL_L10_9 FILL_L50_10 9.7270000000000007e-18
C523 FILL_L10_9 FILL_L50_5 2.0308300000000002e-17
C524 FILL_L10_9 FILL_L50_9 2.5362900000000002e-16
C525 FILL_L10_9 FILL_L8_13 8.2350600000000007e-16
C526 FILL_L10_9 0 2.6896499999999997e-16
C527 FILL_L126_0 FILL_L30_4 1.2208000000000002e-17
C528 FILL_L126_0 FILL_L30_5 1.24575e-17
C529 FILL_L126_0 FILL_L50_1 8.7538400000000009e-19
C530 FILL_L126_0 FILL_L50_10 1.3949000000000002e-16
C531 FILL_L126_0 FILL_L50_11 1.9848500000000003e-16
C532 FILL_L126_0 FILL_L50_2 1.8368300000000004e-17
C533 FILL_L126_0 FILL_L50_3 3.10384e-17
C534 FILL_L126_0 FILL_L50_5 2.0134799999999999e-17
C535 FILL_L126_0 FILL_L50_6 2.7208100000000004e-16
C536 FILL_L126_0 FILL_L50_7 3.3710400000000001e-16
C537 FILL_L126_0 FILL_L50_9 1.0437300000000001e-17
C538 FILL_L126_0 FILL_L8_10 5.3174700000000004e-18
C539 FILL_L126_0 FILL_L8_11 1.06495e-17
C540 FILL_L126_0 FILL_L8_14 3.3341200000000001e-18
C541 FILL_L126_0 FILL_L8_15 5.11886e-18
C542 FILL_L126_0 FILL_L8_5 1.3580600000000002e-18
C543 FILL_L126_0 FILL_L8_6 2.1160400000000003e-18
C544 FILL_L126_0 FILL_L8_7 7.5537000000000005e-19
C545 FILL_L126_0 N 1.1272300000000001e-16
C546 FILL_L126_0 P 2.5633400000000004e-16
C547 FILL_L126_0 0 8.0379900000000005e-16
C548 FILL_L30_0 FILL_L30_1 1.92731e-17
C549 FILL_L30_0 FILL_L50_4 1.2731300000000002e-16
C550 FILL_L30_0 0 3.7665100000000005e-17
C551 FILL_L30_1 FILL_L30_2 1.92731e-17
C552 FILL_L30_1 FILL_L50_5 1.3498800000000002e-16
C553 FILL_L30_1 FILL_L8_8 5.0346600000000001e-18
C554 FILL_L30_1 FILL_L8_9 5.7504800000000001e-18
C555 FILL_L30_1 0 4.2393700000000003e-17
C556 FILL_L30_2 FILL_L30_3 1.92731e-17
C557 FILL_L30_2 FILL_L50_5 1.3498800000000002e-16
C558 FILL_L30_2 0 1.9662800000000003e-17
C559 FILL_L30_3 FILL_L30_4 1.92731e-17
C560 FILL_L30_3 FILL_L50_6 1.3498800000000002e-16
C561 FILL_L30_3 0 2.0164300000000003e-17
C562 FILL_L30_4 FILL_L30_5 1.92731e-17
C563 FILL_L30_4 FILL_L50_6 1.3498800000000002e-16
C564 FILL_L30_4 FILL_L8_10 3.01665e-18
C565 FILL_L30_4 FILL_L8_11 2.30082e-18
C566 FILL_L30_4 0 3.1351500000000001e-17
C567 FILL_L30_5 FILL_L30_6 1.92731e-17
C568 FILL_L30_5 FILL_L50_7 1.3498800000000002e-16
C569 FILL_L30_5 0 1.9256499999999999e-17
C570 FILL_L30_6 FILL_L50_7 1.3498800000000002e-16
C571 FILL_L30_6 FILL_L8_11 5.0346600000000001e-18
C572 FILL_L30_6 0 7.37457e-17
C573 FILL_L50_0 FILL_L50_1 3.2127600000000002e-18
C574 FILL_L50_0 FILL_L50_4 4.9427100000000007e-17
C575 FILL_L50_0 0 7.7668000000000015e-17
C576 FILL_L50_1 FILL_L50_2 3.2127600000000002e-18
C577 FILL_L50_1 FILL_L50_5 9.8854299999999996e-17
C578 FILL_L50_1 FILL_L8_1 3.6153000000000005e-19
C579 FILL_L50_1 FILL_L8_2 3.8166900000000002e-19
C580 FILL_L50_1 0 1.5121400000000002e-16
C581 FILL_L50_10 FILL_L50_11 9.5641500000000001e-17
C582 FILL_L50_10 FILL_L50_6 9.8854299999999996e-17
C583 FILL_L50_10 FILL_L50_9 9.5641500000000001e-17
C584 FILL_L50_10 FILL_L8_14 1.5584e-17
C585 FILL_L50_10 FILL_L8_15 3.3519100000000004e-18
C586 FILL_L50_10 N 3.5785700000000004e-18
C587 FILL_L50_10 0 2.3729100000000002e-16
C588 FILL_L50_11 FILL_L50_7 9.8854299999999996e-17
C589 FILL_L50_11 FILL_L8_15 1.9152300000000002e-17
C590 FILL_L50_11 N 3.6238600000000007e-18
C591 FILL_L50_11 0 3.4262700000000006e-16
C592 FILL_L50_2 FILL_L50_3 3.2127600000000002e-18
C593 FILL_L50_2 FILL_L50_6 9.8854299999999996e-17
C594 FILL_L50_2 FILL_L8_5 1.94439e-19
C595 FILL_L50_2 FILL_L8_6 1.7429900000000002e-19
C596 FILL_L50_2 0 1.50253e-16
C597 FILL_L50_3 FILL_L50_7 9.8854299999999996e-17
C598 FILL_L50_3 FILL_L8_7 5.5596900000000008e-19
C599 FILL_L50_3 0 1.5574299999999999e-16
C600 FILL_L50_4 FILL_L50_5 9.8854299999999996e-17
C601 FILL_L50_4 FILL_L50_8 4.9427100000000007e-17
C602 FILL_L50_4 FILL_L8_12 1.4704300000000001e-18
C603 FILL_L50_4 FILL_L8_8 1.6210000000000001e-18
C604 FILL_L50_4 N 3.6127400000000007e-17
C605 FILL_L50_4 P 1.4450100000000002e-16
C606 FILL_L50_4 0 1.5347499999999999e-16
C607 FILL_L50_5 FILL_L50_6 9.8854299999999996e-17
C608 FILL_L50_5 FILL_L50_9 9.8854299999999996e-17
C609 FILL_L50_5 FILL_L8_13 2.0251700000000002e-18
C610 FILL_L50_5 FILL_L8_8 6.9525000000000006e-18
C611 FILL_L50_5 FILL_L8_9 9.8471600000000005e-18
C612 FILL_L50_5 N 7.2254700000000007e-17
C613 FILL_L50_5 P 2.8900200000000005e-16
C614 FILL_L50_5 0 1.20168e-16
C615 FILL_L50_6 FILL_L50_7 9.8854299999999996e-17
C616 FILL_L50_6 FILL_L8_10 6.4578200000000007e-18
C617 FILL_L50_6 FILL_L8_11 3.3519100000000004e-18
C618 FILL_L50_6 FILL_L8_14 2.3715500000000003e-18
C619 FILL_L50_6 N 7.2254700000000007e-17
C620 FILL_L50_6 P 2.8900200000000005e-16
C621 FILL_L50_6 0 1.16954e-16
C622 FILL_L50_7 FILL_L8_11 1.4195600000000002e-17
C623 FILL_L50_7 FILL_L8_15 1.6602600000000002e-18
C624 FILL_L50_7 N 7.1565100000000004e-17
C625 FILL_L50_7 P 2.8210500000000003e-16
C626 FILL_L50_7 0 2.3274600000000002e-16
C627 FILL_L50_8 FILL_L50_9 9.5641500000000001e-17
C628 FILL_L50_8 FILL_L8_12 6.7684800000000011e-18
C629 FILL_L50_8 N 1.8119300000000003e-18
C630 FILL_L50_8 0 2.1442700000000001e-16
C631 FILL_L50_9 FILL_L8_12 6.9525000000000006e-18
C632 FILL_L50_9 FILL_L8_13 1.7492500000000001e-17
C633 FILL_L50_9 N 3.5332700000000003e-18
C634 FILL_L50_9 0 2.4282900000000003e-16
C635 FILL_L8_0 FILL_L8_1 1.2545400000000001e-17
C636 FILL_L8_0 FILL_L8_8 1.9913400000000001e-17
C637 FILL_L8_0 0 1.24071e-16
C638 FILL_L8_1 FILL_L8_2 1.2545400000000001e-17
C639 FILL_L8_1 FILL_L8_8 1.9913400000000001e-17
C640 FILL_L8_1 0 1.13621e-16
C641 FILL_L8_10 FILL_L8_11 6.96968e-17
C642 FILL_L8_10 FILL_L8_14 6.96968e-17
C643 FILL_L8_10 FILL_L8_4 1.9913400000000001e-17
C644 FILL_L8_10 FILL_L8_5 1.9913400000000001e-17
C645 FILL_L8_10 FILL_L8_9 6.96968e-17
C646 FILL_L8_10 0 7.7579500000000002e-16
C647 FILL_L8_11 FILL_L8_15 6.96968e-17
C648 FILL_L8_11 FILL_L8_6 1.9913400000000001e-17
C649 FILL_L8_11 FILL_L8_7 1.9913400000000001e-17
C650 FILL_L8_11 0 8.3385200000000006e-16
C651 FILL_L8_12 FILL_L8_13 6.96968e-17
C652 FILL_L8_12 FILL_L8_8 6.96968e-17
C653 FILL_L8_12 0 8.6702300000000009e-16
C654 FILL_L8_13 FILL_L8_14 6.96968e-17
C655 FILL_L8_13 FILL_L8_9 6.96968e-17
C656 FILL_L8_13 0 8.0897100000000003e-16
C657 FILL_L8_14 FILL_L8_15 6.96968e-17
C658 FILL_L8_14 0 8.0897100000000003e-16
C659 FILL_L8_15 0 8.6702700000000006e-16
C660 FILL_L8_2 FILL_L8_3 1.2545400000000001e-17
C661 FILL_L8_2 FILL_L8_9 1.9913400000000001e-17
C662 FILL_L8_2 0 1.13621e-16
C663 FILL_L8_3 FILL_L8_4 1.2545400000000001e-17
C664 FILL_L8_3 FILL_L8_9 1.9913400000000001e-17
C665 FILL_L8_3 0 1.13621e-16
C666 FILL_L8_4 FILL_L8_5 1.2545400000000001e-17
C667 FILL_L8_4 0 1.13621e-16
C668 FILL_L8_5 FILL_L8_6 1.2545400000000001e-17
C669 FILL_L8_5 0 1.13621e-16
C670 FILL_L8_6 FILL_L8_7 1.2545400000000001e-17
C671 FILL_L8_6 0 1.13621e-16
C672 FILL_L8_7 0 1.24071e-16
C673 FILL_L8_8 FILL_L8_9 6.96968e-17
C674 FILL_L8_8 0 8.33848e-16
C675 FILL_L8_9 0 7.7579500000000002e-16
C676 N P 4.4090500000000001e-15
C677 N 0 3.73934e-17
C678 P 0 1.2339000000000002e-16
VP P 0 DC 0 AC 0
VN N 0 DC 0 AC 1
.control
set numdgt=17
ac lin 1 1Meg 1Meg
let cp = -imag(i(VP))/(2*pi*1e6)
let cn = -imag(i(VN))/(2*pi*1e6)
print cp cn
quit
.endc
.end
