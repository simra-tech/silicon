* cell sense_fill_clip
.SUBCKT sense_fill_clip
* net 1 CTX_L30_0
* net 2 CTX_L30_1
* net 3 CTX_L30_2
* net 4 CTX_L30_3
* net 5 CTX_L30_4
* net 6 CTX_L30_5
* net 7 CTX_L30_6
* net 8 CTX_L30_7
* net 9 CTX_L67_0
* net 10 CTX_L67_1
* net 11 P
* net 12 N
* net 13 CTX_L67_4
* net 14 CTX_L67_5
* net 15 CTX_L67_6
* net 16 CTX_L67_7
* net 17 CTX_L126_0,CTX_L134_0
* net 18 CTX_L134_1
.ENDS sense_fill_clip
