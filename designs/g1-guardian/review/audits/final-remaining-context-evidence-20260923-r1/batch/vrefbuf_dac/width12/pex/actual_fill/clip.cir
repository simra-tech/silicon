* cell sense_fill_clip
.SUBCKT sense_fill_clip
* net 2 CTX_L67_0
* net 3 FILL_L8_0
* net 4 FILL_L50_0
* net 5 FILL_L10_0
* net 6 FILL_L8_1
* net 7 FILL_L8_2
* net 8 FILL_L50_1
* net 9 FILL_L10_1
* net 10 FILL_L8_3
* net 11 CTX_L30_0
* net 12 FILL_L8_4
* net 13 FILL_L10_2
* net 14 FILL_L50_2
* net 15 FILL_L8_5
* net 16 FILL_L8_6
* net 17 FILL_L10_3
* net 18 FILL_L8_7
* net 19 FILL_L50_3
* net 20 CTX_L67_1
* net 21 FILL_L50_4
* net 22 FILL_L30_0
* net 23 FILL_L67_0
* net 24 FILL_L8_8
* net 25 FILL_L10_4
* net 26 CTX_L126_0,CTX_L134_0
* net 27 FILL_L30_1
* net 28 FILL_L67_1
* net 29 FILL_L50_5
* net 30 FILL_L8_9
* net 31 FILL_L10_5
* net 32 FILL_L67_2
* net 33 FILL_L30_2
* net 34 FILL_L67_3
* net 35 FILL_L30_3
* net 36 FILL_L8_10
* net 37 FILL_L10_6
* net 38 FILL_L50_6
* net 39 CTX_L134_1
* net 40 FILL_L30_4
* net 41 FILL_L67_4
* net 42 FILL_L30_5
* net 43 FILL_L67_5
* net 44 FILL_L8_11
* net 45 FILL_L10_7
* net 46 FILL_L50_7
* net 47 FILL_L30_6
* net 48 FILL_L67_6
* net 49 CTX_L67_4
* net 50 P
* net 51 N
* net 52 CTX_L67_5
* net 53 CTX_L30_2
* net 54 CTX_L30_3
* net 55 CTX_L30_4
* net 56 CTX_L30_1
* net 57 FILL_L126_0
* net 58 CTX_L67_6
* net 59 CTX_L67_7
* net 60 CTX_L30_6
* net 61 CTX_L30_5
* net 62 FILL_L50_8
* net 63 FILL_L10_8
* net 64 FILL_L8_12
* net 65 FILL_L50_9
* net 66 FILL_L10_9
* net 67 FILL_L8_13
* net 68 FILL_L10_10
* net 69 FILL_L8_14
* net 70 FILL_L50_10
* net 71 FILL_L10_11
* net 72 FILL_L8_15
* net 73 FILL_L50_11
* net 74 FILL_L67_7
* net 75 FILL_L67_8
* net 76 FILL_L67_9
* net 77 CTX_L30_7
* net 78 FILL_L67_10
* net 79 FILL_L67_11
* net 80 FILL_L67_12
* net 81 FILL_L67_13
.ENDS sense_fill_clip
