* cell sense_fill_clip
.SUBCKT sense_fill_clip
* net 1 CTX_L8_0
* net 2 CTX_L30_0
* net 3 CTX_L30_1
* net 4 CTX_L30_2
* net 5 CTX_L30_3
* net 6 CTX_L30_4
* net 7 CTX_L30_5
* net 8 CTX_L30_6
* net 9 CTX_L30_7
* net 10 CTX_L30_8
* net 11 CTX_L30_9
* net 12 CTX_L30_10
* net 13 CTX_L30_11
* net 14 CTX_L30_12
* net 15 CTX_L30_13
* net 16 CTX_L30_14
* net 17 CTX_L67_0
* net 18 CTX_L67_1
* net 19 P
* net 20 N
* net 21 CTX_L67_4
* net 22 CTX_L67_5
* net 23 CTX_L67_6
* net 24 CTX_L67_7
* net 25 CTX_L126_0,CTX_L134_0
* net 26 CTX_L134_1
.ENDS sense_fill_clip
