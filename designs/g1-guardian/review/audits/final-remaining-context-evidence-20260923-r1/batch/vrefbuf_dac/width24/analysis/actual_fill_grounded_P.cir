* actual_fill grounded drive P; diagnostic capacitor-network AC only
C55 0 N 7.3430000000000017e-17
C56 0 P 2.3268600000000002e-16
C130 0 N 2.0397800000000001e-17
C131 0 P 2.8612200000000002e-17
C219 0 P 2.7746400000000002e-17
C352 0 N 8.601380000000001e-17
C605 0 P 2.3926600000000002e-16
C619 0 N 4.4090500000000001e-15
C759 0 P 2.1385000000000004e-17
C919 0 P 3.2077500000000002e-17
C929 0 P 1.0692500000000002e-17
C954 0 N 1.1272300000000001e-16
C955 0 P 2.5633400000000004e-16
C962 0 N 3.9997899999999999e-19
C963 0 P 3.5549500000000004e-19
C973 0 N 1.0618900000000002e-18
C974 0 P 8.5153400000000011e-19
C1063 0 N 7.2254700000000007e-17
C1064 0 P 2.8900200000000005e-16
C1070 0 N 7.1565100000000004e-17
C1071 0 P 2.8210500000000003e-16
C1078 0 N 1.8119300000000003e-18
C1086 0 N 3.5332700000000003e-18
C1093 0 N 3.5785700000000004e-18
C1098 0 N 3.6238600000000007e-18
C1135 0 N 3.6127400000000007e-17
C1136 0 P 1.4450100000000002e-16
C1141 0 N 7.2254700000000007e-17
C1142 0 P 2.8900200000000005e-16
C1196 N P 4.4090500000000001e-15
C1197 N 0 3.7342700000000001e-17
C1198 P 0 1.2339000000000002e-16
VP P 0 DC 0 AC 1
VN N 0 DC 0 AC 0
.control
set numdgt=17
ac lin 1 1Meg 1Meg
let cp = -imag(i(VP))/(2*pi*1e6)
let cn = -imag(i(VN))/(2*pi*1e6)
print cp cn
quit
.endc
.end
