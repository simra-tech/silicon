* no_fill grounded drive N; diagnostic capacitor-network AC only
C18 0 N 7.3536500000000009e-17
C19 0 P 2.3286000000000005e-16
C43 0 N 3.19665e-17
C44 0 P 4.9884300000000005e-17
C54 0 P 9.2488000000000003e-17
C71 0 N 9.2488000000000003e-17
C99 0 P 2.3926600000000002e-16
C102 0 N 4.4090500000000001e-15
C110 N P 4.4090500000000001e-15
C111 N 0 5.1599400000000006e-17
C112 P 0 3.9517300000000002e-16
VP P 0 DC 0 AC 0
VN N 0 DC 0 AC 1
.control
set numdgt=17
ac lin 1 1Meg 1Meg
let cp = -imag(i(VP))/(2*pi*1e6)
let cn = -imag(i(VN))/(2*pi*1e6)
print cp cn
quit
.endc
.end
