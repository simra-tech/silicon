* actual_fill floating drive P; diagnostic capacitor-network AC only
C2 0 FILL_L10_0 8.3812900000000005e-18
C3 0 FILL_L10_11 7.3428400000000012e-19
C4 0 FILL_L10_12 6.2395699999999998e-17
C5 0 FILL_L10_14 3.5332000000000004e-19
C6 0 FILL_L10_2 1.4228700000000002e-17
C7 0 FILL_L10_3 2.5337e-17
C8 0 FILL_L10_5 1.8827700000000001e-18
C9 0 FILL_L10_6 1.8156899999999999e-16
C10 0 FILL_L10_8 7.3428400000000012e-19
C11 0 FILL_L10_9 9.2186400000000007e-17
C12 0 FILL_L134_1 6.2922700000000002e-17
C13 0 FILL_L30_0 1.6371500000000001e-19
C14 0 FILL_L30_10 5.1455900000000001e-16
C15 0 FILL_L30_12 2.0984500000000002e-18
C16 0 FILL_L30_14 2.0984500000000002e-18
C17 0 FILL_L30_15 4.9646800000000002e-16
C18 0 FILL_L30_2 1.44482e-17
C19 0 FILL_L30_4 9.2724800000000004e-17
C20 0 FILL_L30_5 3.9665600000000004e-18
C21 0 FILL_L30_7 2.0984500000000002e-18
C22 0 FILL_L30_9 2.0984500000000002e-18
C23 0 FILL_L50_0 1.6402000000000003e-17
C24 0 FILL_L50_1 1.7054400000000004e-17
C25 0 FILL_L50_2 1.7054400000000004e-17
C26 0 FILL_L50_3 1.7054400000000004e-17
C27 0 FILL_L50_4 1.7054400000000004e-17
C28 0 FILL_L50_5 1.7054400000000004e-17
C29 0 FILL_L50_6 8.8682900000000011e-18
C30 0 FILL_L8_2 4.4939700000000001e-18
C31 0 FILL_L8_4 1.70508e-18
C32 0 FILL_L8_6 4.9390000000000005e-18
C33 0 P 1.42285e-16
C40 0 FILL_L10_0 9.6020400000000007e-18
C41 0 FILL_L10_1 1.7898500000000001e-17
C42 0 FILL_L10_10 2.14687e-17
C43 0 FILL_L10_11 1.1987300000000002e-16
C44 0 FILL_L10_12 5.9916200000000002e-17
C45 0 FILL_L10_13 2.2381000000000004e-18
C46 0 FILL_L10_14 8.190390000000001e-18
C47 0 FILL_L10_2 9.4058000000000009e-17
C48 0 FILL_L10_3 2.8863600000000001e-17
C49 0 FILL_L10_4 2.01878e-17
C50 0 FILL_L10_5 1.17759e-16
C51 0 FILL_L10_6 8.4391400000000008e-17
C52 0 FILL_L10_7 2.14687e-17
C53 0 FILL_L10_8 1.18913e-16
C54 0 FILL_L10_9 6.702290000000001e-17
C55 0 FILL_L134_0 2.3735100000000002e-16
C56 0 FILL_L134_1 8.3682100000000007e-16
C57 0 FILL_L134_2 3.8753300000000006e-16
C58 0 FILL_L30_0 1.7463800000000001e-17
C59 0 FILL_L30_1 1.4533700000000001e-17
C60 0 FILL_L30_10 7.8643300000000004e-17
C61 0 FILL_L30_11 1.4533700000000001e-17
C62 0 FILL_L30_12 3.5632100000000003e-17
C63 0 FILL_L30_13 1.4533700000000001e-17
C64 0 FILL_L30_14 3.5632100000000003e-17
C65 0 FILL_L30_15 7.8700300000000009e-17
C66 0 FILL_L30_16 7.5575300000000008e-18
C67 0 FILL_L30_2 3.5632100000000003e-17
C68 0 FILL_L30_3 1.4533700000000001e-17
C69 0 FILL_L30_4 2.1127900000000003e-17
C70 0 FILL_L30_5 3.5632100000000003e-17
C71 0 FILL_L30_6 1.4449800000000001e-17
C72 0 FILL_L30_7 3.5632100000000003e-17
C73 0 FILL_L30_8 1.4477800000000002e-17
C74 0 FILL_L30_9 3.5632100000000003e-17
C75 0 FILL_L50_0 5.9665000000000004e-17
C76 0 FILL_L50_1 6.2364300000000006e-17
C77 0 FILL_L50_2 6.2364300000000006e-17
C78 0 FILL_L50_3 6.2364300000000006e-17
C79 0 FILL_L50_4 6.2364300000000006e-17
C80 0 FILL_L50_5 6.2364300000000006e-17
C81 0 FILL_L50_6 3.1916400000000004e-17
C82 0 FILL_L8_2 6.1546400000000001e-18
C83 0 FILL_L8_4 6.1244600000000003e-18
C84 0 FILL_L8_6 5.5893600000000007e-18
C85 0 FILL_L8_7 4.1365900000000005e-19
C86 0 N 2.3051600000000003e-16
C87 0 P 3.9880000000000004e-16
C91 0 FILL_L10_1 3.5929900000000005e-17
C92 0 FILL_L10_10 4.305490000000001e-17
C93 0 FILL_L10_13 7.1249900000000005e-18
C94 0 FILL_L10_4 4.305490000000001e-17
C95 0 FILL_L10_7 4.305490000000001e-17
C96 0 FILL_L134_0 1.7462599999999998e-17
C97 0 FILL_L134_2 1.8015000000000002e-17
C98 0 FILL_L30_1 1.4591000000000002e-18
C99 0 FILL_L30_11 1.4591000000000002e-18
C100 0 FILL_L30_13 1.4591000000000002e-18
C101 0 FILL_L30_16 7.5873000000000004e-19
C102 0 FILL_L30_3 1.4591000000000002e-18
C103 0 FILL_L30_6 1.4591000000000002e-18
C104 0 FILL_L30_8 1.4591000000000002e-18
C105 0 FILL_L8_0 4.2766800000000002e-19
C106 0 FILL_L8_1 8.5533600000000003e-19
C107 0 FILL_L8_3 8.5533600000000003e-19
C108 0 FILL_L8_5 8.5533600000000003e-19
C109 0 FILL_L8_7 4.2766800000000002e-19
C113 0 FILL_L10_1 5.1613900000000002e-17
C114 0 FILL_L10_10 6.2881800000000007e-17
C115 0 FILL_L10_11 3.0543300000000003e-17
C116 0 FILL_L10_13 8.1611400000000009e-18
C117 0 FILL_L10_14 3.0245000000000004e-18
C118 0 FILL_L10_2 2.6005500000000002e-17
C119 0 FILL_L10_4 5.9534700000000007e-17
C120 0 FILL_L10_5 3.0543300000000003e-17
C121 0 FILL_L10_7 6.2677900000000011e-17
C122 0 FILL_L10_8 3.0543300000000003e-17
C123 0 FILL_L134_0 4.8004199999999999e-17
C124 0 FILL_L134_2 4.9564500000000008e-17
C125 0 FILL_L30_1 4.6119700000000003e-17
C126 0 FILL_L30_11 4.6416600000000006e-17
C127 0 FILL_L30_12 1.1021100000000002e-19
C128 0 FILL_L30_13 4.6416600000000006e-17
C129 0 FILL_L30_16 2.4005100000000002e-17
C130 0 FILL_L30_3 4.6416600000000006e-17
C131 0 FILL_L30_5 1.1021100000000002e-19
C132 0 FILL_L30_6 4.6416600000000006e-17
C133 0 FILL_L30_7 1.1021100000000002e-19
C134 0 FILL_L30_8 4.6416600000000006e-17
C135 0 FILL_L30_9 1.1021100000000002e-19
C136 0 FILL_L8_0 8.5533600000000003e-19
C137 0 FILL_L8_1 1.5611000000000001e-18
C138 0 FILL_L8_3 1.2985000000000001e-18
C139 0 FILL_L8_5 1.4170800000000001e-18
C140 0 FILL_L8_7 8.5533600000000003e-19
C143 0 FILL_L10_1 2.88868e-18
C144 0 FILL_L10_10 3.6473300000000006e-18
C145 0 FILL_L10_11 1.1965300000000001e-16
C146 0 FILL_L10_12 3.3626000000000002e-19
C147 0 FILL_L10_14 5.7431400000000004e-18
C148 0 FILL_L10_2 9.9998000000000013e-17
C149 0 FILL_L10_4 2.9178600000000004e-18
C150 0 FILL_L10_5 1.1915800000000001e-16
C151 0 FILL_L10_6 2.8582100000000001e-19
C152 0 FILL_L10_7 3.6473300000000006e-18
C153 0 FILL_L10_8 1.1915800000000001e-16
C154 0 FILL_L10_9 3.3626000000000002e-19
C155 0 FILL_L134_0 2.2532499999999999e-17
C156 0 FILL_L134_2 2.3316900000000003e-17
C157 0 FILL_L30_0 3.7103900000000002e-19
C158 0 FILL_L30_1 2.5960700000000004e-18
C159 0 FILL_L30_10 2.8165200000000004e-19
C160 0 FILL_L30_11 2.5960700000000004e-18
C161 0 FILL_L30_12 7.7299900000000005e-19
C162 0 FILL_L30_13 2.5960700000000004e-18
C163 0 FILL_L30_14 7.7299900000000005e-19
C164 0 FILL_L30_15 2.9647600000000004e-19
C165 0 FILL_L30_16 1.3499600000000002e-18
C166 0 FILL_L30_2 7.7299900000000005e-19
C167 0 FILL_L30_3 2.5960700000000004e-18
C168 0 FILL_L30_4 1.4823800000000002e-19
C169 0 FILL_L30_5 7.7299900000000005e-19
C170 0 FILL_L30_6 2.5259000000000002e-18
C171 0 FILL_L30_7 7.7299900000000005e-19
C172 0 FILL_L30_8 2.5492900000000002e-18
C173 0 FILL_L30_9 7.7299900000000005e-19
C174 0 N 1.2964900000000001e-15
C177 0 FILL_L10_0 1.1645000000000001e-19
C178 0 FILL_L10_11 2.49106e-16
C179 0 FILL_L10_12 3.6497500000000001e-19
C180 0 FILL_L10_14 6.9583300000000002e-18
C181 0 FILL_L10_2 2.0449600000000002e-16
C182 0 FILL_L10_3 1.6635700000000001e-19
C183 0 FILL_L10_5 2.4816900000000003e-16
C184 0 FILL_L10_6 3.1022899999999999e-19
C185 0 FILL_L10_8 2.4816900000000003e-16
C186 0 FILL_L10_9 3.6497500000000001e-19
C187 0 FILL_L134_0 6.3310100000000002e-18
C188 0 FILL_L134_2 7.1557400000000001e-18
C189 0 FILL_L30_0 1.2619500000000001e-18
C190 0 FILL_L30_1 1.06616e-18
C191 0 FILL_L30_11 3.1717600000000002e-18
C192 0 FILL_L30_12 2.62906e-18
C193 0 FILL_L30_13 1.06616e-18
C194 0 FILL_L30_14 3.4857500000000001e-18
C195 0 FILL_L30_16 1.20177e-18
C196 0 FILL_L30_2 3.4068800000000005e-18
C197 0 FILL_L30_3 1.06616e-18
C198 0 FILL_L30_5 2.62906e-18
C199 0 FILL_L30_6 2.1189599999999999e-18
C200 0 FILL_L30_7 4.3424500000000003e-18
C201 0 FILL_L30_8 1.06616e-18
C202 0 FILL_L30_9 2.62906e-18
C203 0 FILL_L50_0 2.0163700000000003e-18
C204 0 FILL_L50_1 2.0163700000000003e-18
C205 0 FILL_L50_2 2.0163700000000003e-18
C206 0 FILL_L50_3 2.0163700000000003e-18
C207 0 FILL_L50_4 2.0163700000000003e-18
C208 0 FILL_L50_5 2.0163700000000003e-18
C209 0 FILL_L50_6 1.0485100000000002e-18
C210 0 FILL_L8_0 2.7072500000000004e-17
C211 0 FILL_L8_1 3.1796600000000002e-17
C212 0 FILL_L8_3 3.1796600000000002e-17
C213 0 FILL_L8_5 3.1796600000000002e-17
C214 0 FILL_L8_7 4.7240600000000004e-18
C215 0 N 5.2091300000000003e-18
C216 0 P 3.0694400000000005e-18
C218 0 FILL_L10_0 4.3351700000000006e-17
C219 0 FILL_L10_11 1.9153600000000003e-17
C220 0 FILL_L10_12 2.3347900000000002e-17
C221 0 FILL_L10_14 1.7320700000000002e-19
C222 0 FILL_L10_2 1.4793300000000003e-17
C223 0 FILL_L10_3 6.8202899999999999e-17
C224 0 FILL_L10_5 1.9153600000000003e-17
C225 0 FILL_L10_6 2.9984300000000005e-17
C226 0 FILL_L10_8 1.9153600000000003e-17
C227 0 FILL_L10_9 2.3347900000000002e-17
C228 0 FILL_L134_1 7.0212800000000003e-18
C229 0 FILL_L30_0 4.8933e-18
C230 0 FILL_L30_1 1.7698100000000001e-19
C231 0 FILL_L30_10 1.6821200000000001e-17
C232 0 FILL_L30_11 3.5396200000000002e-19
C233 0 FILL_L30_12 8.7879900000000016e-18
C234 0 FILL_L30_13 3.5396200000000002e-19
C235 0 FILL_L30_14 8.7879900000000016e-18
C236 0 FILL_L30_15 1.40846e-17
C237 0 FILL_L30_16 1.8406000000000002e-19
C238 0 FILL_L30_2 7.031220000000001e-18
C239 0 FILL_L30_3 3.5396200000000002e-19
C240 0 FILL_L30_4 1.4008500000000001e-17
C241 0 FILL_L30_5 8.7879900000000016e-18
C242 0 FILL_L30_6 3.0086800000000004e-19
C243 0 FILL_L30_7 8.7879900000000016e-18
C244 0 FILL_L30_8 3.1856600000000002e-19
C245 0 FILL_L30_9 8.7879900000000016e-18
C246 0 FILL_L50_0 3.8838700000000006e-18
C247 0 FILL_L50_1 4.8891600000000004e-18
C248 0 FILL_L50_2 4.8891600000000004e-18
C249 0 FILL_L50_3 4.8891600000000004e-18
C250 0 FILL_L50_4 4.8891600000000004e-18
C251 0 FILL_L50_5 4.8891600000000004e-18
C252 0 FILL_L50_6 2.5423600000000003e-18
C253 0 FILL_L8_2 2.8605599999999999e-16
C254 0 FILL_L8_4 2.1721900000000001e-16
C255 0 FILL_L8_6 2.1721900000000001e-16
C256 0 N 2.6333000000000005e-18
C257 0 P 2.7841200000000006e-17
C259 FILL_L10_0 FILL_L10_2 1.34089e-17
C260 FILL_L10_0 FILL_L10_3 2.7935199999999999e-17
C261 FILL_L10_0 FILL_L134_1 3.7415e-19
C262 FILL_L10_0 FILL_L30_0 2.6143400000000002e-17
C263 FILL_L10_0 P 3.1740400000000003e-18
C264 FILL_L10_0 0 6.3444600000000011e-17
C265 FILL_L10_1 FILL_L10_2 8.3247000000000007e-17
C266 FILL_L10_1 FILL_L10_4 4.0785500000000002e-17
C267 FILL_L10_1 FILL_L134_0 1.7581000000000002e-17
C268 FILL_L10_1 FILL_L30_0 4.4972300000000004e-19
C269 FILL_L10_1 FILL_L30_1 1.0738000000000001e-16
C270 FILL_L10_1 FILL_L30_2 4.6846200000000002e-19
C271 FILL_L10_1 FILL_L30_3 1.7474700000000001e-18
C272 FILL_L10_1 FILL_L8_0 2.9248300000000002e-16
C273 FILL_L10_1 0 2.1673300000000003e-16
C274 FILL_L10_10 FILL_L10_11 9.7773300000000019e-17
C275 FILL_L10_10 FILL_L10_13 4.0785500000000002e-17
C276 FILL_L10_10 FILL_L10_7 4.0785500000000002e-17
C277 FILL_L10_10 FILL_L134_2 2.2042400000000002e-17
C278 FILL_L10_10 FILL_L30_11 3.1982700000000005e-17
C279 FILL_L10_10 FILL_L30_12 9.3692400000000003e-19
C280 FILL_L10_10 FILL_L30_13 1.09217e-16
C281 FILL_L10_10 FILL_L30_14 4.6846200000000002e-19
C282 FILL_L10_10 FILL_L30_16 1.7474700000000001e-18
C283 FILL_L10_10 FILL_L8_5 3.4352000000000001e-16
C284 FILL_L10_10 0 2.1177400000000001e-16
C285 FILL_L10_11 FILL_L10_12 4.1529200000000009e-17
C286 FILL_L10_11 FILL_L10_14 2.7935199999999999e-17
C287 FILL_L10_11 FILL_L10_8 9.7773300000000019e-17
C288 FILL_L10_11 FILL_L134_2 2.0213600000000002e-17
C289 FILL_L10_11 FILL_L30_12 3.95965e-17
C290 FILL_L10_11 FILL_L30_13 2.0416800000000001e-17
C291 FILL_L10_11 FILL_L30_14 1.9798300000000003e-17
C292 FILL_L10_11 FILL_L30_15 8.8358299999999996e-18
C293 FILL_L10_11 FILL_L50_5 7.9249799999999996e-18
C294 FILL_L10_11 FILL_L8_5 1.7167000000000004e-17
C295 FILL_L10_11 N 6.6245999999999997e-17
C296 FILL_L10_11 P 3.8751e-17
C297 FILL_L10_11 0 4.7719800000000001e-16
C298 FILL_L10_12 FILL_L10_9 8.4923100000000016e-17
C299 FILL_L10_12 FILL_L134_2 2.4748100000000002e-18
C300 FILL_L10_12 FILL_L30_13 4.4074299999999999e-19
C301 FILL_L10_12 FILL_L30_14 1.6577999999999999e-17
C302 FILL_L10_12 FILL_L30_15 5.9295399999999997e-16
C303 FILL_L10_12 FILL_L50_5 1.4061300000000001e-17
C304 FILL_L10_12 FILL_L8_6 7.1527400000000005e-16
C305 FILL_L10_12 N 4.9557400000000006e-19
C306 FILL_L10_12 P 1.2428200000000001e-17
C307 FILL_L10_12 0 3.4716500000000004e-16
C308 FILL_L10_13 FILL_L10_14 1.4526300000000003e-17
C309 FILL_L10_13 FILL_L134_2 3.7348600000000003e-18
C310 FILL_L10_13 FILL_L30_16 4.1050600000000006e-17
C311 FILL_L10_13 FILL_L8_7 5.1037200000000004e-17
C312 FILL_L10_13 0 9.6651100000000002e-17
C313 FILL_L10_14 FILL_L134_2 2.8216800000000003e-18
C314 FILL_L10_14 FILL_L30_16 7.2665700000000003e-18
C315 FILL_L10_14 FILL_L50_6 1.1456600000000001e-18
C316 FILL_L10_14 FILL_L8_7 1.8709600000000002e-18
C317 FILL_L10_14 N 4.8551300000000004e-19
C318 FILL_L10_14 P 3.8926300000000008e-19
C319 FILL_L10_14 0 8.1998200000000005e-17
C320 FILL_L10_2 FILL_L10_3 2.7935199999999999e-17
C321 FILL_L10_2 FILL_L10_5 9.7773300000000019e-17
C322 FILL_L10_2 FILL_L134_0 1.7137799999999998e-17
C323 FILL_L10_2 FILL_L134_1 1.4510200000000002e-17
C324 FILL_L10_2 FILL_L30_0 1.90063e-17
C325 FILL_L10_2 FILL_L30_1 2.0416800000000001e-17
C326 FILL_L10_2 FILL_L30_2 1.9798300000000003e-17
C327 FILL_L10_2 FILL_L50_0 7.9249799999999996e-18
C328 FILL_L10_2 FILL_L8_0 1.4616500000000002e-17
C329 FILL_L10_2 N 5.4525700000000006e-17
C330 FILL_L10_2 P 3.1115600000000004e-17
C331 FILL_L10_2 0 4.4545200000000001e-16
C332 FILL_L10_3 FILL_L134_1 7.0153200000000006e-19
C333 FILL_L10_3 FILL_L30_1 2.9286100000000002e-19
C334 FILL_L10_3 FILL_L30_2 2.7232700000000005e-17
C335 FILL_L10_3 FILL_L50_0 9.7220300000000003e-18
C336 FILL_L10_3 P 3.3062900000000005e-18
C337 FILL_L10_3 0 8.1828300000000001e-17
C338 FILL_L10_4 FILL_L10_5 9.7773300000000019e-17
C339 FILL_L10_4 FILL_L10_7 4.0785500000000002e-17
C340 FILL_L10_4 FILL_L134_0 1.9911600000000001e-17
C341 FILL_L10_4 FILL_L30_3 9.9299300000000009e-17
C342 FILL_L10_4 FILL_L30_5 9.3692400000000003e-19
C343 FILL_L10_4 FILL_L30_6 6.7216700000000013e-17
C344 FILL_L10_4 FILL_L8_1 3.4352000000000001e-16
C345 FILL_L10_4 0 2.1177400000000001e-16
C346 FILL_L10_5 FILL_L10_6 4.1529200000000009e-17
C347 FILL_L10_5 FILL_L10_8 9.7773300000000019e-17
C348 FILL_L10_5 FILL_L134_0 1.9969300000000001e-17
C349 FILL_L10_5 FILL_L134_1 1.5891600000000003e-17
C350 FILL_L10_5 FILL_L30_3 2.0416800000000001e-17
C351 FILL_L10_5 FILL_L30_4 4.6082400000000004e-18
C352 FILL_L10_5 FILL_L30_5 3.95965e-17
C353 FILL_L10_5 FILL_L30_6 1.02084e-17
C354 FILL_L10_5 FILL_L50_1 7.9249799999999996e-18
C355 FILL_L10_5 FILL_L50_2 3.9624899999999998e-18
C356 FILL_L10_5 FILL_L8_1 1.7167000000000004e-17
C357 FILL_L10_5 N 6.5750900000000007e-17
C358 FILL_L10_5 P 3.8255899999999997e-17
C359 FILL_L10_5 0 4.2621600000000003e-16
C360 FILL_L10_6 FILL_L10_9 8.4923100000000016e-17
C361 FILL_L10_6 FILL_L134_0 1.9901900000000003e-19
C362 FILL_L10_6 FILL_L134_1 1.4500700000000002e-17
C363 FILL_L10_6 FILL_L30_10 2.3151900000000005e-16
C364 FILL_L10_6 FILL_L30_4 6.7753000000000006e-17
C365 FILL_L10_6 FILL_L30_5 2.2408600000000003e-17
C366 FILL_L10_6 FILL_L30_6 4.9021799999999997e-19
C367 FILL_L10_6 FILL_L30_7 8.2890200000000006e-18
C368 FILL_L10_6 FILL_L50_2 1.9168500000000004e-17
C369 FILL_L10_6 FILL_L8_2 7.1527400000000005e-16
C370 FILL_L10_6 N 4.2123800000000005e-19
C371 FILL_L10_6 P 1.6183600000000001e-17
C372 FILL_L10_6 0 3.3369200000000004e-16
C373 FILL_L10_7 FILL_L10_8 9.7773300000000019e-17
C374 FILL_L10_7 FILL_L134_0 8.6938300000000014e-18
C375 FILL_L10_7 FILL_L134_2 1.9307800000000001e-17
C376 FILL_L10_7 FILL_L30_11 1.6912800000000001e-17
C377 FILL_L10_7 FILL_L30_6 6.9870900000000006e-18
C378 FILL_L10_7 FILL_L30_8 1.1315800000000001e-16
C379 FILL_L10_7 FILL_L30_9 9.3692400000000003e-19
C380 FILL_L10_7 FILL_L8_3 3.4352000000000001e-16
C381 FILL_L10_7 0 2.1177400000000001e-16
C382 FILL_L10_8 FILL_L10_9 4.1529200000000009e-17
C383 FILL_L10_8 FILL_L134_2 9.3411399999999993e-18
C384 FILL_L10_8 FILL_L30_10 8.8358299999999996e-18
C385 FILL_L10_8 FILL_L30_8 2.0416800000000001e-17
C386 FILL_L10_8 FILL_L30_9 3.95965e-17
C387 FILL_L10_8 FILL_L50_3 7.9249799999999996e-18
C388 FILL_L10_8 FILL_L8_3 1.7167000000000004e-17
C389 FILL_L10_8 N 6.5750900000000007e-17
C390 FILL_L10_8 P 3.8255899999999997e-17
C391 FILL_L10_8 0 4.2621600000000003e-16
C392 FILL_L10_9 FILL_L134_1 4.8446100000000009e-18
C393 FILL_L10_9 FILL_L134_2 4.6800700000000002e-18
C394 FILL_L10_9 FILL_L30_10 4.69188e-16
C395 FILL_L10_9 FILL_L30_11 3.8494300000000002e-19
C396 FILL_L10_9 FILL_L30_15 6.9004200000000008e-17
C397 FILL_L10_9 FILL_L30_8 3.9666900000000004e-19
C398 FILL_L10_9 FILL_L30_9 1.6577999999999999e-17
C399 FILL_L10_9 FILL_L50_3 1.4061300000000001e-17
C400 FILL_L10_9 FILL_L50_4 9.584250000000002e-18
C401 FILL_L10_9 FILL_L8_4 7.1527400000000005e-16
C402 FILL_L10_9 N 4.9557400000000006e-19
C403 FILL_L10_9 P 1.16039e-17
C404 FILL_L10_9 0 2.8398000000000003e-16
C405 FILL_L134_0 FILL_L134_1 3.8308700000000003e-16
C406 FILL_L134_0 FILL_L134_2 1.2463000000000002e-16
C407 FILL_L134_0 FILL_L30_0 1.24553e-18
C408 FILL_L134_0 FILL_L30_1 1.0544000000000002e-17
C409 FILL_L134_0 FILL_L30_2 2.5948600000000002e-18
C410 FILL_L134_0 FILL_L30_3 1.1167500000000002e-17
C411 FILL_L134_0 FILL_L30_4 6.7718600000000004e-19
C412 FILL_L134_0 FILL_L30_5 2.5948600000000002e-18
C413 FILL_L134_0 FILL_L30_6 8.4644600000000009e-18
C414 FILL_L134_0 FILL_L30_8 3.8256800000000001e-18
C415 FILL_L134_0 FILL_L8_0 2.7826300000000005e-18
C416 FILL_L134_0 FILL_L8_1 3.3774300000000002e-18
C417 FILL_L134_0 FILL_L8_3 1.5855000000000002e-19
C418 FILL_L134_0 0 4.15397e-16
C419 FILL_L134_1 FILL_L30_0 4.9968600000000002e-19
C420 FILL_L134_1 FILL_L30_10 1.8286500000000002e-17
C421 FILL_L134_1 FILL_L30_15 5.1410500000000001e-18
C422 FILL_L134_1 FILL_L30_2 5.9672200000000002e-19
C423 FILL_L134_1 FILL_L30_4 1.10137e-17
C424 FILL_L134_1 FILL_L30_5 1.04101e-18
C425 FILL_L134_1 FILL_L50_0 1.3444700000000001e-18
C426 FILL_L134_1 FILL_L50_1 1.3444700000000001e-18
C427 FILL_L134_1 FILL_L50_2 1.1428000000000002e-18
C428 FILL_L134_1 FILL_L8_2 1.6829100000000001e-19
C429 FILL_L134_1 P 5.9521200000000003e-18
C430 FILL_L134_1 0 4.0668000000000003e-16
C431 FILL_L134_2 FILL_L30_10 2.7337400000000004e-18
C432 FILL_L134_2 FILL_L30_11 1.1167500000000002e-17
C433 FILL_L134_2 FILL_L30_12 2.5948600000000002e-18
C434 FILL_L134_2 FILL_L30_13 1.1167500000000002e-17
C435 FILL_L134_2 FILL_L30_14 2.5948600000000002e-18
C436 FILL_L134_2 FILL_L30_15 1.1297000000000001e-17
C437 FILL_L134_2 FILL_L30_16 5.7097300000000005e-18
C438 FILL_L134_2 FILL_L30_6 6.2692200000000006e-19
C439 FILL_L134_2 FILL_L30_8 7.1112400000000001e-18
C440 FILL_L134_2 FILL_L30_9 2.5948600000000002e-18
C441 FILL_L134_2 FILL_L8_3 1.9288900000000001e-18
C442 FILL_L134_2 FILL_L8_5 4.1704000000000006e-18
C443 FILL_L134_2 FILL_L8_7 1.2766200000000003e-18
C444 FILL_L134_2 0 4.3832299999999999e-16
C445 FILL_L30_0 FILL_L30_2 1.92731e-17
C446 FILL_L30_0 FILL_L50_0 1.3500100000000001e-17
C447 FILL_L30_0 N 9.7296500000000008e-19
C448 FILL_L30_0 P 8.9758499999999999e-18
C449 FILL_L30_0 0 6.4075300000000006e-17
C450 FILL_L30_1 FILL_L30_3 1.92731e-17
C451 FILL_L30_1 FILL_L50_0 6.5896400000000007e-19
C452 FILL_L30_1 FILL_L8_0 3.01665e-18
C453 FILL_L30_1 N 2.6879100000000003e-19
C454 FILL_L30_1 P 2.1352400000000002e-19
C455 FILL_L30_1 0 8.1606600000000005e-17
C456 FILL_L30_10 FILL_L30_15 3.9317200000000002e-17
C457 FILL_L30_10 FILL_L30_4 1.27509e-17
C458 FILL_L30_10 FILL_L30_7 1.92731e-17
C459 FILL_L30_10 FILL_L30_8 4.7365199999999997e-18
C460 FILL_L30_10 FILL_L30_9 1.92731e-17
C461 FILL_L30_10 FILL_L50_3 6.5780100000000005e-18
C462 FILL_L30_10 FILL_L8_2 1.6424700000000002e-17
C463 FILL_L30_10 FILL_L8_4 1.6424700000000002e-17
C464 FILL_L30_10 N 4.2083100000000004e-19
C465 FILL_L30_10 P 4.5087200000000008e-18
C466 FILL_L30_10 0 2.1999100000000002e-16
C467 FILL_L30_11 FILL_L30_13 1.92731e-17
C468 FILL_L30_11 FILL_L30_8 1.92731e-17
C469 FILL_L30_11 FILL_L50_4 6.5896400000000007e-19
C470 FILL_L30_11 FILL_L8_3 2.5173300000000001e-18
C471 FILL_L30_11 FILL_L8_5 2.87524e-18
C472 FILL_L30_11 N 2.6879100000000003e-19
C473 FILL_L30_11 P 2.1352400000000002e-19
C474 FILL_L30_11 0 8.6701899999999999e-17
C475 FILL_L30_12 FILL_L30_14 1.92731e-17
C476 FILL_L30_12 FILL_L30_15 1.92731e-17
C477 FILL_L30_12 FILL_L30_9 1.92731e-17
C478 FILL_L30_12 FILL_L50_4 5.6426099999999999e-17
C479 FILL_L30_12 FILL_L50_5 1.7174900000000002e-17
C480 FILL_L30_12 N 2.0270100000000002e-18
C481 FILL_L30_12 P 1.8699700000000002e-17
C482 FILL_L30_12 0 5.8466000000000009e-17
C483 FILL_L30_13 FILL_L30_15 4.7365199999999997e-18
C484 FILL_L30_13 FILL_L30_16 1.92731e-17
C485 FILL_L30_13 FILL_L50_5 6.5896400000000007e-19
C486 FILL_L30_13 FILL_L8_5 3.01665e-18
C487 FILL_L30_13 N 2.6879100000000003e-19
C488 FILL_L30_13 P 2.1352400000000002e-19
C489 FILL_L30_13 0 6.0689700000000011e-17
C490 FILL_L30_14 FILL_L30_15 1.92731e-17
C491 FILL_L30_14 FILL_L50_5 5.6426099999999999e-17
C492 FILL_L30_14 FILL_L50_6 1.4493600000000001e-17
C493 FILL_L30_14 N 2.0270100000000002e-18
C494 FILL_L30_14 P 1.8699700000000002e-17
C495 FILL_L30_14 0 8.1002500000000003e-17
C496 FILL_L30_15 FILL_L50_5 6.5780100000000005e-18
C497 FILL_L30_15 FILL_L8_4 1.02707e-17
C498 FILL_L30_15 FILL_L8_6 1.1731e-17
C499 FILL_L30_15 N 4.4298000000000001e-19
C500 FILL_L30_15 P 4.5367200000000002e-18
C501 FILL_L30_15 0 2.5648300000000003e-16
C502 FILL_L30_16 FILL_L50_6 3.4266100000000003e-19
C503 FILL_L30_16 FILL_L8_7 1.5686600000000001e-18
C504 FILL_L30_16 N 1.3977200000000001e-19
C505 FILL_L30_16 P 1.11032e-19
C506 FILL_L30_16 0 7.1007400000000006e-17
C507 FILL_L30_2 FILL_L30_5 1.92731e-17
C508 FILL_L30_2 FILL_L50_0 5.6426099999999999e-17
C509 FILL_L30_2 FILL_L50_1 1.7174900000000002e-17
C510 FILL_L30_2 N 2.0270100000000002e-18
C511 FILL_L30_2 P 1.8699700000000002e-17
C512 FILL_L30_2 0 7.2392300000000009e-17
C513 FILL_L30_3 FILL_L30_4 4.7365199999999997e-18
C514 FILL_L30_3 FILL_L30_6 1.92731e-17
C515 FILL_L30_3 FILL_L50_1 6.5896400000000007e-19
C516 FILL_L30_3 FILL_L8_1 3.01665e-18
C517 FILL_L30_3 N 2.6879100000000003e-19
C518 FILL_L30_3 P 2.1352400000000002e-19
C519 FILL_L30_3 0 6.2572100000000003e-17
C520 FILL_L30_4 FILL_L50_1 6.5780100000000005e-18
C521 FILL_L30_4 FILL_L8_2 5.7504800000000001e-18
C522 FILL_L30_4 N 2.2149000000000001e-19
C523 FILL_L30_4 P 2.8003500000000001e-19
C524 FILL_L30_4 0 8.2001599999999997e-17
C525 FILL_L30_5 FILL_L30_7 1.92731e-17
C526 FILL_L30_5 FILL_L50_1 5.6426099999999999e-17
C527 FILL_L30_5 FILL_L50_2 1.7174900000000002e-17
C528 FILL_L30_5 N 2.0270100000000002e-18
C529 FILL_L30_5 P 1.8699700000000002e-17
C530 FILL_L30_5 0 6.1597499999999999e-17
C531 FILL_L30_6 FILL_L30_8 1.92731e-17
C532 FILL_L30_6 FILL_L50_2 5.6011900000000007e-19
C533 FILL_L30_6 FILL_L8_1 3.01665e-18
C534 FILL_L30_6 FILL_L8_3 1.15041e-18
C535 FILL_L30_6 N 1.3439599999999999e-19
C536 FILL_L30_6 P 1.0676200000000001e-19
C537 FILL_L30_6 0 7.3456300000000003e-17
C538 FILL_L30_7 FILL_L30_9 1.92731e-17
C539 FILL_L30_7 FILL_L50_2 5.6426099999999999e-17
C540 FILL_L30_7 FILL_L50_3 1.7174900000000002e-17
C541 FILL_L30_7 N 2.0270100000000002e-18
C542 FILL_L30_7 P 1.8699700000000002e-17
C543 FILL_L30_7 0 7.5691100000000015e-17
C544 FILL_L30_8 FILL_L50_3 5.9306800000000007e-19
C545 FILL_L30_8 FILL_L8_3 3.01665e-18
C546 FILL_L30_8 N 2.4191200000000001e-19
C547 FILL_L30_8 P 1.9217200000000002e-19
C548 FILL_L30_8 0 6.0387200000000005e-17
C549 FILL_L30_9 FILL_L50_3 5.6426099999999999e-17
C550 FILL_L30_9 FILL_L50_4 1.7174900000000002e-17
C551 FILL_L30_9 N 2.0270100000000002e-18
C552 FILL_L30_9 P 1.8699700000000002e-17
C553 FILL_L30_9 0 5.2373600000000006e-17
C554 FILL_L50_0 FILL_L50_1 2.4713600000000001e-17
C555 FILL_L50_0 P 7.9368600000000002e-17
C556 FILL_L50_0 0 5.56585e-17
C557 FILL_L50_1 FILL_L50_2 2.4713600000000001e-17
C558 FILL_L50_1 P 7.9368600000000002e-17
C559 FILL_L50_1 0 3.1048000000000003e-17
C560 FILL_L50_2 FILL_L50_3 2.4713600000000001e-17
C561 FILL_L50_2 P 7.9368600000000002e-17
C562 FILL_L50_2 0 2.6327500000000001e-17
C563 FILL_L50_3 FILL_L50_4 2.4713600000000001e-17
C564 FILL_L50_3 P 7.9368600000000002e-17
C565 FILL_L50_3 0 2.6005800000000004e-17
C566 FILL_L50_4 FILL_L50_5 2.4713600000000001e-17
C567 FILL_L50_4 P 7.9368600000000002e-17
C568 FILL_L50_4 0 3.1213000000000002e-17
C569 FILL_L50_5 FILL_L50_6 2.4713600000000001e-17
C570 FILL_L50_5 P 7.9368600000000002e-17
C571 FILL_L50_5 0 2.6005800000000004e-17
C572 FILL_L50_6 P 4.1271700000000005e-17
C573 FILL_L50_6 0 4.7637100000000001e-17
C574 FILL_L8_0 FILL_L8_1 2.9073500000000002e-17
C575 FILL_L8_0 0 4.5926999999999997e-16
C576 FILL_L8_1 FILL_L8_3 2.9073500000000002e-17
C577 FILL_L8_1 0 4.9925000000000008e-16
C578 FILL_L8_2 FILL_L8_4 6.0536700000000009e-17
C579 FILL_L8_2 0 6.8477300000000003e-16
C580 FILL_L8_3 FILL_L8_5 2.9073500000000002e-17
C581 FILL_L8_3 0 4.9925000000000008e-16
C582 FILL_L8_4 FILL_L8_6 6.0536700000000009e-17
C583 FILL_L8_4 0 6.856440000000001e-16
C584 FILL_L8_5 FILL_L8_7 2.9073500000000002e-17
C585 FILL_L8_5 0 4.9925000000000008e-16
C586 FILL_L8_6 0 7.3607000000000015e-16
C587 FILL_L8_7 0 1.5556899999999999e-16
C588 N P 3.4877500000000003e-15
C589 N 0 5.8416800000000005e-17
C590 P 0 2.0923900000000003e-16
VP P 0 DC 0 AC 1
VN N 0 DC 0 AC 0
.control
set numdgt=17
ac lin 1 1Meg 1Meg
let cp = -imag(i(VP))/(2*pi*1e6)
let cn = -imag(i(VN))/(2*pi*1e6)
print cp cn
quit
.endc
.end
