* cell sense_fill_clip
.SUBCKT sense_fill_clip
* net 1 CTX_L10_0,CTX_L30_0,CTX_L30_1,CTX_L50_5,CTX_L8_0
* net 2 CTX_L8_1
* net 3 CTX_L8_2
* net 4 CTX_L50_0
* net 5 CTX_L50_1
* net 6 CTX_L50_2
* net 7 N
* net 8 P
* net 9 CTX_L126_0
.ENDS sense_fill_clip
