*********************************************************
*** NGSPICE file created by KLayout-PEX 0.3.12
*** -----------------------------------------------------
***     Extraction Engine: KPEX/2.5D
***     Technology: ihp_sg13g2
***     Date: 2026-09-23 06:32:30
*********************************************************

.SUBCKT sense_fill_clip
Cext_1 CTX_L10_0|CTX_L30_0|CTX_L30_1|CTX_L50_5|CTX_L8_0 CTX_L126_0 582.146a
Cext_2 CTX_L10_0|CTX_L30_0|CTX_L30_1|CTX_L50_5|CTX_L8_0 CTX_L50_2 0.249218a
Cext_3 CTX_L10_0|CTX_L30_0|CTX_L30_1|CTX_L50_5|CTX_L8_0 CTX_L8_1 0.73738a
Cext_4 CTX_L10_0|CTX_L30_0|CTX_L30_1|CTX_L50_5|CTX_L8_0 CTX_L8_2 231.26a
Cext_5 CTX_L10_0|CTX_L30_0|CTX_L30_1|CTX_L50_5|CTX_L8_0 N 0.466823a
Cext_6 CTX_L10_0|CTX_L30_0|CTX_L30_1|CTX_L50_5|CTX_L8_0 P 213.647a
Cext_7 CTX_L10_0|CTX_L30_0|CTX_L30_1|CTX_L50_5|CTX_L8_0 VSUBS 1.71056f
Cext_8 CTX_L126_0 CTX_L50_0 9.85908a
Cext_9 CTX_L126_0 CTX_L50_1 70.7361a
Cext_10 CTX_L126_0 CTX_L50_2 297.129a
Cext_11 CTX_L126_0 CTX_L8_1 95.0388a
Cext_12 CTX_L126_0 CTX_L8_2 178.955a
Cext_13 CTX_L126_0 N 230.516a
Cext_14 CTX_L126_0 P 489.685a
Cext_15 CTX_L126_0 VSUBS 2.36001f
Cext_16 CTX_L50_0 CTX_L50_1 1.29649f
Cext_17 CTX_L50_0 CTX_L8_1 2.25399a
Cext_18 CTX_L50_0 VSUBS 687.185a
Cext_19 CTX_L50_1 CTX_L50_2 271.822a
Cext_20 CTX_L50_1 CTX_L8_1 7.26708a
Cext_21 CTX_L50_1 VSUBS 477.142a
Cext_22 CTX_L50_2 CTX_L8_1 64.7232a
Cext_23 CTX_L50_2 N 1.29649f
Cext_24 CTX_L50_2 VSUBS 436.375a
Cext_25 CTX_L8_1 CTX_L8_2 180.553a
Cext_26 CTX_L8_1 N 17.0381a
Cext_27 CTX_L8_1 P 10.2723a
Cext_28 CTX_L8_1 VSUBS 1.65066f
Cext_29 CTX_L8_2 N 8.26783a
Cext_30 CTX_L8_2 P 46.2458a
Cext_31 CTX_L8_2 VSUBS 2.20643f
Cext_32 N P 3.48775f
Cext_33 N VSUBS 155.235a
Cext_34 P VSUBS 463.834a
.ENDS sense_fill_clip
