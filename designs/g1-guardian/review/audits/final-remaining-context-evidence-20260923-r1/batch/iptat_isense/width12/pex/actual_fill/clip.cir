* cell sense_fill_clip
.SUBCKT sense_fill_clip
* net 2 FILL_L10_1
* net 3 FILL_L8_0
* net 4 FILL_L30_1
* net 5 FILL_L67_0
* net 6 FILL_L10_2
* net 7 FILL_L50_0
* net 8 FILL_L30_0
* net 9 CTX_L8_2
* net 10 FILL_L10_0
* net 11 FILL_L67_1
* net 12 CTX_L10_0,CTX_L30_0,CTX_L30_1,CTX_L50_5,CTX_L8_0
* net 13 FILL_L134_0
* net 14 FILL_L30_2
* net 15 FILL_L134_1
* net 16 FILL_L10_3
* net 17 FILL_L10_4
* net 18 FILL_L8_1
* net 19 FILL_L30_6
* net 20 FILL_L30_3
* net 21 FILL_L67_2
* net 22 FILL_L10_5
* net 23 FILL_L50_2
* net 24 FILL_L30_7
* net 25 FILL_L30_5
* net 26 FILL_L50_1
* net 27 FILL_L67_3
* net 28 FILL_L30_4
* net 29 FILL_L8_2
* net 30 FILL_L10_6
* net 31 CTX_L50_0
* net 32 CTX_L50_1
* net 33 CTX_L50_2
* net 34 CTX_L8_1
* net 35 N
* net 36 P
* net 37 CTX_L126_0
* net 38 FILL_L30_10
* net 39 FILL_L8_3
* net 40 FILL_L10_7
* net 41 FILL_L30_11
* net 42 FILL_L30_8
* net 43 FILL_L67_4
* net 44 FILL_L10_8
* net 45 FILL_L50_3
* net 46 FILL_L50_4
* net 47 FILL_L30_12
* net 48 FILL_L30_9
* net 49 FILL_L67_5
* net 50 FILL_L10_9
* net 51 FILL_L8_4
* net 52 FILL_L8_5
* net 53 FILL_L10_10
* net 54 FILL_L134_2
* net 55 FILL_L30_13
* net 56 FILL_L67_6
* net 57 FILL_L10_11
* net 58 FILL_L50_5
* net 59 FILL_L30_14
* net 60 FILL_L67_7
* net 61 FILL_L10_12
* net 62 FILL_L8_6
* net 63 FILL_L30_15
* net 64 FILL_L8_7
* net 65 FILL_L10_13
* net 66 FILL_L30_16
* net 67 FILL_L10_14
* net 68 FILL_L50_6
.ENDS sense_fill_clip
