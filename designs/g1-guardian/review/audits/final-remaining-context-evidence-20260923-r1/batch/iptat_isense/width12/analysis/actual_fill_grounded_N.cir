* actual_fill grounded drive N; diagnostic capacitor-network AC only
C33 0 P 1.42285e-16
C86 0 N 2.3051600000000003e-16
C87 0 P 3.9880000000000004e-16
C174 0 N 1.2964900000000001e-15
C215 0 N 5.2091300000000003e-18
C216 0 P 3.0694400000000005e-18
C256 0 N 2.6333000000000005e-18
C257 0 P 2.7841200000000006e-17
C263 0 P 3.1740400000000003e-18
C295 0 N 6.6245999999999997e-17
C296 0 P 3.8751e-17
C305 0 N 4.9557400000000006e-19
C306 0 P 1.2428200000000001e-17
C317 0 N 4.8551300000000004e-19
C318 0 P 3.8926300000000008e-19
C329 0 N 5.4525700000000006e-17
C330 0 P 3.1115600000000004e-17
C336 0 P 3.3062900000000005e-18
C357 0 N 6.5750900000000007e-17
C358 0 P 3.8255899999999997e-17
C370 0 N 4.2123800000000005e-19
C371 0 P 1.6183600000000001e-17
C389 0 N 6.5750900000000007e-17
C390 0 P 3.8255899999999997e-17
C402 0 N 4.9557400000000006e-19
C403 0 P 1.16039e-17
C429 0 P 5.9521200000000003e-18
C447 0 N 9.7296500000000008e-19
C448 0 P 8.9758499999999999e-18
C453 0 N 2.6879100000000003e-19
C454 0 P 2.1352400000000002e-19
C464 0 N 4.2083100000000004e-19
C465 0 P 4.5087200000000008e-18
C472 0 N 2.6879100000000003e-19
C473 0 P 2.1352400000000002e-19
C480 0 N 2.0270100000000002e-18
C481 0 P 1.8699700000000002e-17
C487 0 N 2.6879100000000003e-19
C488 0 P 2.1352400000000002e-19
C493 0 N 2.0270100000000002e-18
C494 0 P 1.8699700000000002e-17
C499 0 N 4.4298000000000001e-19
C500 0 P 4.5367200000000002e-18
C504 0 N 1.3977200000000001e-19
C505 0 P 1.11032e-19
C510 0 N 2.0270100000000002e-18
C511 0 P 1.8699700000000002e-17
C517 0 N 2.6879100000000003e-19
C518 0 P 2.1352400000000002e-19
C522 0 N 2.2149000000000001e-19
C523 0 P 2.8003500000000001e-19
C528 0 N 2.0270100000000002e-18
C529 0 P 1.8699700000000002e-17
C535 0 N 1.3439599999999999e-19
C536 0 P 1.0676200000000001e-19
C541 0 N 2.0270100000000002e-18
C542 0 P 1.8699700000000002e-17
C546 0 N 2.4191200000000001e-19
C547 0 P 1.9217200000000002e-19
C551 0 N 2.0270100000000002e-18
C552 0 P 1.8699700000000002e-17
C555 0 P 7.9368600000000002e-17
C558 0 P 7.9368600000000002e-17
C561 0 P 7.9368600000000002e-17
C564 0 P 7.9368600000000002e-17
C567 0 P 7.9368600000000002e-17
C570 0 P 7.9368600000000002e-17
C572 0 P 4.1271700000000005e-17
C588 N P 3.4877500000000003e-15
C589 N 0 5.8416800000000005e-17
C590 P 0 2.0923900000000003e-16
VP P 0 DC 0 AC 0
VN N 0 DC 0 AC 1
.control
set numdgt=17
ac lin 1 1Meg 1Meg
let cp = -imag(i(VP))/(2*pi*1e6)
let cn = -imag(i(VN))/(2*pi*1e6)
print cp cn
quit
.endc
.end
