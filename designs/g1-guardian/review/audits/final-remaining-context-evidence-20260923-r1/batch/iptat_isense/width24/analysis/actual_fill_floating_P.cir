* actual_fill floating drive P; diagnostic capacitor-network AC only
C10 0 FILL_L10_0 8.3812900000000005e-18
C11 0 FILL_L10_12 7.3428400000000012e-19
C12 0 FILL_L10_13 1.0212900000000001e-16
C13 0 FILL_L10_15 2.1103500000000001e-18
C14 0 FILL_L10_18 7.3428400000000012e-19
C15 0 FILL_L10_20 6.6261700000000005e-17
C16 0 FILL_L10_24 3.5332000000000004e-19
C17 0 FILL_L10_3 1.4228700000000002e-17
C18 0 FILL_L10_4 2.5337e-17
C19 0 FILL_L10_7 1.9448600000000002e-18
C20 0 FILL_L10_8 2.1223e-16
C21 0 FILL_L10_9 2.1412900000000003e-19
C22 0 FILL_L126_1 2.2401000000000002e-16
C23 0 FILL_L134_2 7.4885500000000004e-17
C24 0 FILL_L134_3 5.2529200000000009e-17
C25 0 FILL_L30_0 1.6371500000000001e-19
C26 0 FILL_L30_1 2.0807200000000004e-17
C27 0 FILL_L30_12 2.0984500000000002e-18
C28 0 FILL_L30_14 2.0984500000000002e-18
C29 0 FILL_L30_15 6.8278600000000003e-16
C30 0 FILL_L30_18 2.0984500000000002e-18
C31 0 FILL_L30_2 1.7484500000000003e-17
C32 0 FILL_L30_20 2.0984500000000002e-18
C33 0 FILL_L30_21 6.5566100000000001e-16
C34 0 FILL_L30_5 1.44482e-17
C35 0 FILL_L30_7 9.3436499999999997e-17
C36 0 FILL_L30_8 7.6949400000000007e-17
C37 0 FILL_L30_9 4.0371400000000004e-18
C38 0 FILL_L50_1 1.6402000000000003e-17
C39 0 FILL_L50_11 1.7054400000000004e-17
C40 0 FILL_L50_12 2.1967100000000002e-16
C41 0 FILL_L50_14 1.7054400000000004e-17
C42 0 FILL_L50_16 8.8682900000000011e-18
C43 0 FILL_L50_17 1.9284500000000001e-16
C44 0 FILL_L50_2 3.3927200000000002e-16
C45 0 FILL_L50_4 1.7054400000000004e-17
C46 0 FILL_L50_6 1.7054400000000004e-17
C47 0 FILL_L50_7 3.4562000000000003e-16
C48 0 FILL_L50_9 1.7054400000000004e-17
C49 0 FILL_L8_11 1.7948200000000001e-18
C50 0 FILL_L8_14 5.1989500000000004e-18
C51 0 FILL_L8_15 9.942790000000001e-18
C52 0 FILL_L8_2 5.1658299999999999e-18
C53 0 FILL_L8_5 4.74594e-18
C54 0 FILL_L8_6 3.7315900000000005e-18
C55 0 FILL_L8_7 8.4832900000000004e-19
C56 0 P 1.42285e-16
C64 0 FILL_L126_1 2.2685400000000004e-17
C65 0 FILL_L30_2 9.9667499999999998e-18
C66 0 FILL_L30_8 1.08371e-19
C67 0 FILL_L50_2 3.3066500000000002e-17
C68 0 FILL_L50_7 5.5247500000000006e-18
C77 0 FILL_L10_14 7.0450399999999996e-20
C78 0 FILL_L126_1 7.4750800000000001e-18
C79 0 FILL_L50_7 2.56237e-17
C80 0 FILL_L8_2 5.2728399999999999e-19
C89 0 FILL_L10_8 4.6253899999999997e-19
C90 0 FILL_L10_9 1.7065100000000001e-18
C91 0 FILL_L126_1 1.62763e-17
C92 0 FILL_L134_2 1.82911e-19
C93 0 FILL_L134_3 6.0981200000000004e-19
C94 0 FILL_L30_15 1.08371e-19
C95 0 FILL_L50_7 2.1002e-17
C96 0 FILL_L8_6 4.2764200000000001e-18
C103 0 FILL_L10_13 8.1177100000000008e-18
C104 0 FILL_L10_14 2.3954300000000004e-18
C105 0 FILL_L10_15 2.1393400000000002e-17
C106 0 FILL_L10_21 6.4794600000000011e-19
C107 0 FILL_L10_9 2.3582700000000003e-16
C108 0 FILL_L126_1 4.3888800000000009e-17
C109 0 FILL_L134_3 2.5569300000000002e-17
C110 0 FILL_L30_15 1.0369100000000001e-16
C111 0 FILL_L30_22 1.1400600000000001e-17
C112 0 FILL_L50_11 1.6825300000000003e-19
C113 0 FILL_L50_12 7.7473300000000002e-16
C114 0 FILL_L50_17 7.0261599999999999e-18
C115 0 FILL_L50_7 2.65994e-17
C116 0 FILL_L8_10 2.0661500000000001e-17
C117 0 FILL_L8_11 1.4290700000000001e-17
C118 0 FILL_L8_15 5.998400000000001e-17
C119 0 FILL_L8_7 3.1488199999999999e-17
C126 0 FILL_L10_13 7.1466600000000002e-17
C127 0 FILL_L10_14 1.2858800000000001e-17
C128 0 FILL_L10_15 2.4292200000000004e-17
C129 0 FILL_L10_19 1.2858800000000001e-17
C130 0 FILL_L10_20 7.1466600000000002e-17
C131 0 FILL_L10_21 2.4292200000000004e-17
C132 0 FILL_L10_8 7.1466600000000002e-17
C133 0 FILL_L10_9 2.4292200000000004e-17
C134 0 FILL_L126_1 2.11146e-17
C135 0 FILL_L134_2 4.3752999999999997e-19
C136 0 FILL_L134_3 3.7901100000000001e-18
C137 0 FILL_L30_1 8.822070000000001e-18
C138 0 FILL_L30_12 1.8620500000000003e-19
C139 0 FILL_L30_15 9.0548900000000013e-17
C140 0 FILL_L30_18 3.7240900000000002e-19
C141 0 FILL_L30_2 3.9148900000000001e-18
C142 0 FILL_L30_21 8.8211400000000002e-17
C143 0 FILL_L30_22 7.0965200000000002e-18
C144 0 FILL_L30_7 1.11635e-18
C145 0 FILL_L30_8 1.8379300000000002e-17
C146 0 FILL_L30_9 1.3325500000000003e-19
C147 0 FILL_L50_11 3.4198600000000004e-19
C148 0 FILL_L50_12 7.4187899999999999e-17
C149 0 FILL_L50_16 3.55666e-19
C150 0 FILL_L50_17 9.1022300000000003e-17
C151 0 FILL_L50_2 7.01759e-17
C152 0 FILL_L50_4 6.8397200000000007e-19
C153 0 FILL_L50_7 1.1980500000000001e-16
C154 0 FILL_L8_10 2.03296e-17
C155 0 FILL_L8_11 9.7302900000000004e-19
C156 0 FILL_L8_15 2.8538000000000001e-16
C157 0 FILL_L8_2 5.7987099999999999e-17
C158 0 FILL_L8_5 1.0018600000000001e-18
C159 0 FILL_L8_6 5.8027900000000012e-17
C160 0 FILL_L8_7 5.9422800000000001e-17
C169 0 FILL_L10_0 9.6020400000000007e-18
C170 0 FILL_L10_1 6.59979e-19
C171 0 FILL_L10_10 1.3199600000000002e-18
C172 0 FILL_L10_11 3.7572900000000001e-17
C173 0 FILL_L10_12 1.18913e-16
C174 0 FILL_L10_13 7.1086600000000008e-17
C175 0 FILL_L10_15 3.0043000000000003e-18
C176 0 FILL_L10_16 2.6399200000000004e-18
C177 0 FILL_L10_17 4.1520200000000008e-17
C178 0 FILL_L10_18 1.1987300000000002e-16
C179 0 FILL_L10_2 3.0222800000000002e-17
C180 0 FILL_L10_20 6.1270800000000011e-17
C181 0 FILL_L10_21 1.43518e-18
C182 0 FILL_L10_23 4.0442700000000001e-18
C183 0 FILL_L10_24 8.190390000000001e-18
C184 0 FILL_L10_3 9.4058000000000009e-17
C185 0 FILL_L10_4 2.8863600000000001e-17
C186 0 FILL_L10_6 3.2344700000000003e-17
C187 0 FILL_L10_7 1.17759e-16
C188 0 FILL_L10_8 9.2437500000000011e-17
C189 0 FILL_L126_1 3.2217800000000001e-16
C190 0 FILL_L134_1 2.9121600000000001e-16
C191 0 FILL_L134_2 8.3682100000000007e-16
C192 0 FILL_L134_5 4.4327200000000004e-16
C193 0 FILL_L30_0 1.7463800000000001e-17
C194 0 FILL_L30_1 1.9555400000000002e-18
C195 0 FILL_L30_10 4.1124800000000002e-17
C196 0 FILL_L30_11 1.4449800000000001e-17
C197 0 FILL_L30_12 3.5632100000000003e-17
C198 0 FILL_L30_13 1.4477800000000002e-17
C199 0 FILL_L30_14 3.5632100000000003e-17
C200 0 FILL_L30_15 1.1754600000000001e-16
C201 0 FILL_L30_16 4.1124800000000002e-17
C202 0 FILL_L30_17 1.4533700000000001e-17
C203 0 FILL_L30_18 3.5632100000000003e-17
C204 0 FILL_L30_19 1.4533700000000001e-17
C205 0 FILL_L30_20 3.5632100000000003e-17
C206 0 FILL_L30_21 1.1760300000000001e-16
C207 0 FILL_L30_23 3.6852400000000003e-17
C208 0 FILL_L30_24 7.5575300000000008e-18
C209 0 FILL_L30_3 2.6160300000000001e-17
C210 0 FILL_L30_4 1.4533700000000001e-17
C211 0 FILL_L30_5 3.5632100000000003e-17
C212 0 FILL_L30_6 1.4533700000000001e-17
C213 0 FILL_L30_7 2.1127900000000003e-17
C214 0 FILL_L30_9 3.5632100000000003e-17
C215 0 FILL_L50_1 5.9665000000000004e-17
C216 0 FILL_L50_11 6.2364300000000006e-17
C217 0 FILL_L50_12 5.9913200000000012e-17
C218 0 FILL_L50_14 6.2364300000000006e-17
C219 0 FILL_L50_16 3.1916400000000004e-17
C220 0 FILL_L50_17 5.2723600000000002e-17
C221 0 FILL_L50_2 1.5633400000000002e-17
C222 0 FILL_L50_4 6.2364300000000006e-17
C223 0 FILL_L50_6 6.2364300000000006e-17
C224 0 FILL_L50_7 2.1587299999999999e-17
C225 0 FILL_L50_9 6.2364300000000006e-17
C226 0 FILL_L8_11 6.1244600000000003e-18
C227 0 FILL_L8_14 5.5893600000000007e-18
C228 0 FILL_L8_15 1.1880000000000001e-17
C229 0 FILL_L8_17 4.1365900000000005e-19
C230 0 FILL_L8_5 6.1546400000000001e-18
C231 0 FILL_L8_6 1.7066500000000001e-18
C232 0 N 2.3051600000000003e-16
C233 0 P 3.9880000000000004e-16
C237 0 FILL_L126_1 1.3631800000000001e-18
C238 0 FILL_L30_8 2.28646e-18
C239 0 FILL_L50_7 3.1110300000000002e-18
C242 0 FILL_L10_8 2.3777500000000002e-19
C243 0 FILL_L126_1 7.5539400000000008e-19
C244 0 FILL_L134_2 1.2307200000000001e-19
C245 0 FILL_L50_7 3.3022700000000001e-18
C246 0 FILL_L8_6 5.8778399999999998e-19
C250 0 FILL_L10_1 6.4499200000000001e-18
C251 0 FILL_L10_10 9.9837600000000003e-18
C252 0 FILL_L10_11 6.3942599999999997e-17
C253 0 FILL_L10_16 1.4974200000000002e-17
C254 0 FILL_L10_17 7.4626800000000013e-17
C255 0 FILL_L10_2 4.9231200000000007e-17
C256 0 FILL_L10_23 9.3691899999999997e-18
C257 0 FILL_L10_5 3.99464e-18
C258 0 FILL_L10_6 5.32583e-17
C259 0 FILL_L126_0 1.1570600000000002e-17
C260 0 FILL_L126_2 1.2239100000000001e-17
C261 0 FILL_L134_1 4.1717200000000002e-17
C262 0 FILL_L134_5 4.3008299999999999e-17
C263 0 FILL_L30_10 1.2967100000000001e-16
C264 0 FILL_L30_11 1.5374400000000001e-18
C265 0 FILL_L30_13 1.5374400000000001e-18
C266 0 FILL_L30_16 1.2967100000000001e-16
C267 0 FILL_L30_17 1.5374400000000001e-18
C268 0 FILL_L30_19 1.5374400000000001e-18
C269 0 FILL_L30_23 1.14485e-16
C270 0 FILL_L30_24 7.9946700000000009e-19
C271 0 FILL_L30_3 8.0770300000000012e-17
C272 0 FILL_L30_4 1.5374400000000001e-18
C273 0 FILL_L30_6 1.5374400000000001e-18
C274 0 FILL_L50_0 1.4297300000000002e-17
C275 0 FILL_L50_10 1.4297300000000002e-17
C276 0 FILL_L50_13 1.4297300000000002e-17
C277 0 FILL_L50_15 7.43462e-18
C278 0 FILL_L50_3 1.4297300000000002e-17
C279 0 FILL_L50_5 1.4297300000000002e-17
C280 0 FILL_L50_8 1.4297300000000002e-17
C281 0 FILL_L8_1 8.5533600000000003e-19
C282 0 FILL_L8_13 1.7106700000000001e-18
C283 0 FILL_L8_17 8.5533600000000003e-19
C284 0 FILL_L8_4 1.7106700000000001e-18
C285 0 FILL_L8_9 1.7106700000000001e-18
C289 0 FILL_L10_11 6.5750900000000007e-17
C290 0 FILL_L10_17 6.5750900000000007e-17
C291 0 FILL_L10_2 5.4525700000000006e-17
C292 0 FILL_L10_23 1.1225199999999999e-17
C293 0 FILL_L10_6 6.5750900000000007e-17
C294 0 FILL_L126_0 5.1290399999999999e-18
C295 0 FILL_L126_2 5.2460300000000004e-18
C296 0 FILL_L134_1 2.7769600000000004e-17
C297 0 FILL_L134_5 2.8575200000000002e-17
C298 0 FILL_L30_10 9.8875000000000007e-18
C299 0 FILL_L30_11 2.7401300000000005e-18
C300 0 FILL_L30_13 2.7401300000000005e-18
C301 0 FILL_L30_16 9.8875000000000007e-18
C302 0 FILL_L30_17 2.7401300000000005e-18
C303 0 FILL_L30_19 2.7401300000000005e-18
C304 0 FILL_L30_23 8.7010000000000017e-18
C305 0 FILL_L30_24 1.4248700000000002e-18
C306 0 FILL_L30_3 6.1302500000000009e-18
C307 0 FILL_L30_4 2.7401300000000005e-18
C308 0 FILL_L30_6 2.7401300000000005e-18
C309 0 FILL_L8_1 8.5533600000000003e-19
C310 0 FILL_L8_13 1.7106700000000001e-18
C311 0 FILL_L8_17 8.5533600000000003e-19
C312 0 FILL_L8_4 1.7106700000000001e-18
C313 0 FILL_L8_9 1.7106700000000001e-18
C317 0 FILL_L10_11 6.2677900000000011e-17
C318 0 FILL_L10_12 3.0543300000000003e-17
C319 0 FILL_L10_17 6.2881800000000007e-17
C320 0 FILL_L10_18 3.0543300000000003e-17
C321 0 FILL_L10_2 5.1613900000000002e-17
C322 0 FILL_L10_23 8.1611400000000009e-18
C323 0 FILL_L10_24 3.0245000000000004e-18
C324 0 FILL_L10_3 2.6005500000000002e-17
C325 0 FILL_L10_6 5.9534700000000007e-17
C326 0 FILL_L10_7 3.0543300000000003e-17
C327 0 FILL_L126_0 3.8935500000000004e-18
C328 0 FILL_L126_2 3.98236e-18
C329 0 FILL_L134_1 4.8004199999999999e-17
C330 0 FILL_L134_5 4.9564500000000008e-17
C331 0 FILL_L30_10 2.62805e-18
C332 0 FILL_L30_11 4.6416600000000006e-17
C333 0 FILL_L30_12 1.1021100000000002e-19
C334 0 FILL_L30_13 4.6416600000000006e-17
C335 0 FILL_L30_14 1.1021100000000002e-19
C336 0 FILL_L30_16 2.6511800000000003e-18
C337 0 FILL_L30_17 4.6416600000000006e-17
C338 0 FILL_L30_18 1.1021100000000002e-19
C339 0 FILL_L30_19 4.6416600000000006e-17
C340 0 FILL_L30_23 2.4754100000000005e-18
C341 0 FILL_L30_24 2.4005100000000002e-17
C342 0 FILL_L30_3 1.7740800000000002e-18
C343 0 FILL_L30_4 4.6119700000000003e-17
C344 0 FILL_L30_6 4.6416600000000006e-17
C345 0 FILL_L30_9 1.1021100000000002e-19
C346 0 FILL_L8_1 8.5533600000000003e-19
C347 0 FILL_L8_13 1.4170800000000001e-18
C348 0 FILL_L8_17 8.5533600000000003e-19
C349 0 FILL_L8_4 1.5611000000000001e-18
C350 0 FILL_L8_9 1.2985000000000001e-18
C353 0 FILL_L10_11 3.6473300000000006e-18
C354 0 FILL_L10_12 1.1915800000000001e-16
C355 0 FILL_L10_13 3.3626000000000002e-19
C356 0 FILL_L10_17 3.6473300000000006e-18
C357 0 FILL_L10_18 1.1965300000000001e-16
C358 0 FILL_L10_2 2.88868e-18
C359 0 FILL_L10_20 3.3626000000000002e-19
C360 0 FILL_L10_24 5.7431400000000004e-18
C361 0 FILL_L10_3 9.9998000000000013e-17
C362 0 FILL_L10_6 2.9178600000000004e-18
C363 0 FILL_L10_7 1.1915800000000001e-16
C364 0 FILL_L10_8 2.8582100000000001e-19
C365 0 FILL_L134_1 2.2532499999999999e-17
C366 0 FILL_L134_5 2.3316900000000003e-17
C367 0 FILL_L30_0 3.7103900000000002e-19
C368 0 FILL_L30_10 2.3247300000000005e-19
C369 0 FILL_L30_11 2.5259000000000002e-18
C370 0 FILL_L30_12 7.7299900000000005e-19
C371 0 FILL_L30_13 2.5492900000000002e-18
C372 0 FILL_L30_14 7.7299900000000005e-19
C373 0 FILL_L30_15 2.8165200000000004e-19
C374 0 FILL_L30_16 1.16237e-19
C375 0 FILL_L30_17 2.5960700000000004e-18
C376 0 FILL_L30_18 7.7299900000000005e-19
C377 0 FILL_L30_19 2.5960700000000004e-18
C378 0 FILL_L30_20 7.7299900000000005e-19
C379 0 FILL_L30_21 2.9647600000000004e-19
C380 0 FILL_L30_23 1.16237e-19
C381 0 FILL_L30_24 1.3499600000000002e-18
C382 0 FILL_L30_3 1.16237e-19
C383 0 FILL_L30_4 2.5960700000000004e-18
C384 0 FILL_L30_5 7.7299900000000005e-19
C385 0 FILL_L30_6 2.5960700000000004e-18
C386 0 FILL_L30_7 1.4823800000000002e-19
C387 0 FILL_L30_9 7.7299900000000005e-19
C388 0 N 1.2964900000000001e-15
C391 0 FILL_L126_1 2.9581600000000001e-18
C392 0 FILL_L134_2 1.87383e-19
C393 0 FILL_L50_2 4.2210900000000009e-18
C397 0 FILL_L126_1 4.53916e-18
C398 0 FILL_L30_8 1.5614700000000003e-19
C399 0 FILL_L50_7 5.40996e-18
C400 0 FILL_L8_5 2.4201299999999999e-18
C402 0 FILL_L126_1 8.9557600000000004e-19
C403 0 FILL_L134_3 6.0056500000000005e-19
C404 0 FILL_L30_15 5.4399100000000002e-19
C405 0 FILL_L50_7 7.0265100000000006e-19
C406 0 FILL_L8_6 3.5375500000000001e-18
C409 0 FILL_L10_0 1.1645000000000001e-19
C410 0 FILL_L10_12 2.4816900000000003e-16
C411 0 FILL_L10_13 3.6497500000000001e-19
C412 0 FILL_L10_18 2.49106e-16
C413 0 FILL_L10_20 3.6497500000000001e-19
C414 0 FILL_L10_24 6.9583300000000002e-18
C415 0 FILL_L10_3 2.0449600000000002e-16
C416 0 FILL_L10_4 1.6635700000000001e-19
C417 0 FILL_L10_7 2.4816900000000003e-16
C418 0 FILL_L10_8 3.1022899999999999e-19
C419 0 FILL_L134_1 7.8330400000000003e-18
C420 0 FILL_L134_5 8.2393600000000005e-18
C421 0 FILL_L30_0 1.2619500000000001e-18
C422 0 FILL_L30_10 6.4725500000000003e-19
C423 0 FILL_L30_11 2.1189599999999999e-18
C424 0 FILL_L30_12 4.3424500000000003e-18
C425 0 FILL_L30_13 1.06616e-18
C426 0 FILL_L30_14 2.62906e-18
C427 0 FILL_L30_16 2.1465100000000002e-18
C428 0 FILL_L30_17 3.1717600000000002e-18
C429 0 FILL_L30_18 2.62906e-18
C430 0 FILL_L30_19 1.06616e-18
C431 0 FILL_L30_20 3.4857500000000001e-18
C432 0 FILL_L30_23 2.5560000000000001e-18
C433 0 FILL_L30_24 1.20177e-18
C434 0 FILL_L30_4 1.06616e-18
C435 0 FILL_L30_5 3.4068800000000005e-18
C436 0 FILL_L30_6 1.06616e-18
C437 0 FILL_L30_9 2.62906e-18
C438 0 FILL_L50_1 2.0163700000000003e-18
C439 0 FILL_L50_11 2.0163700000000003e-18
C440 0 FILL_L50_14 2.0163700000000003e-18
C441 0 FILL_L50_16 1.0485100000000002e-18
C442 0 FILL_L50_4 2.0163700000000003e-18
C443 0 FILL_L50_6 2.0163700000000003e-18
C444 0 FILL_L50_9 2.0163700000000003e-18
C445 0 FILL_L8_1 2.7072500000000004e-17
C446 0 FILL_L8_13 3.1796600000000002e-17
C447 0 FILL_L8_17 4.7240600000000004e-18
C448 0 FILL_L8_4 3.1796600000000002e-17
C449 0 FILL_L8_9 3.1796600000000002e-17
C450 0 N 5.2091300000000003e-18
C451 0 P 3.0694400000000005e-18
C453 0 FILL_L10_0 4.3351700000000006e-17
C454 0 FILL_L10_12 1.9153600000000003e-17
C455 0 FILL_L10_13 2.3347900000000002e-17
C456 0 FILL_L10_18 1.9153600000000003e-17
C457 0 FILL_L10_20 2.3347900000000002e-17
C458 0 FILL_L10_24 1.7320700000000002e-19
C459 0 FILL_L10_3 1.4793300000000003e-17
C460 0 FILL_L10_4 6.8202899999999999e-17
C461 0 FILL_L10_7 1.9153600000000003e-17
C462 0 FILL_L10_8 3.0946000000000002e-17
C463 0 FILL_L10_9 6.9257100000000008e-19
C464 0 FILL_L126_1 2.8831000000000003e-17
C465 0 FILL_L134_2 9.7288200000000012e-18
C466 0 FILL_L134_3 3.04209e-18
C467 0 FILL_L30_0 5.1998200000000001e-18
C468 0 FILL_L30_1 1.3232100000000002e-17
C469 0 FILL_L30_11 3.0086800000000004e-19
C470 0 FILL_L30_12 8.7879900000000016e-18
C471 0 FILL_L30_13 3.1856600000000002e-19
C472 0 FILL_L30_14 8.7879900000000016e-18
C473 0 FILL_L30_15 2.4117300000000003e-17
C474 0 FILL_L30_17 3.5396200000000002e-19
C475 0 FILL_L30_18 8.7879900000000016e-18
C476 0 FILL_L30_19 3.5396200000000002e-19
C477 0 FILL_L30_2 1.0557499999999999e-17
C478 0 FILL_L30_20 8.7879900000000016e-18
C479 0 FILL_L30_21 1.6374600000000002e-17
C480 0 FILL_L30_24 1.8406000000000002e-19
C481 0 FILL_L30_4 1.7698100000000001e-19
C482 0 FILL_L30_5 7.031220000000001e-18
C483 0 FILL_L30_6 3.5396200000000002e-19
C484 0 FILL_L30_7 1.4611400000000002e-17
C485 0 FILL_L30_8 9.8899500000000018e-18
C486 0 FILL_L30_9 8.7879900000000016e-18
C487 0 FILL_L50_1 3.8838700000000006e-18
C488 0 FILL_L50_11 4.8891600000000004e-18
C489 0 FILL_L50_12 1.0972900000000002e-18
C490 0 FILL_L50_14 4.8891600000000004e-18
C491 0 FILL_L50_16 2.5423600000000003e-18
C492 0 FILL_L50_17 2.5554899999999999e-18
C493 0 FILL_L50_2 5.8606500000000006e-17
C494 0 FILL_L50_4 4.8891600000000004e-18
C495 0 FILL_L50_6 4.8891600000000004e-18
C496 0 FILL_L50_7 4.8929600000000005e-17
C497 0 FILL_L50_9 4.8891600000000004e-18
C498 0 FILL_L8_10 3.6313700000000006e-18
C499 0 FILL_L8_11 2.1721900000000001e-16
C500 0 FILL_L8_14 2.1721900000000001e-16
C501 0 FILL_L8_2 3.4610900000000001e-17
C502 0 FILL_L8_5 2.9859400000000001e-16
C503 0 N 2.6333000000000005e-18
C504 0 P 2.80893e-17
C506 FILL_L10_0 FILL_L10_3 1.34089e-17
C507 FILL_L10_0 FILL_L10_4 2.7935199999999999e-17
C508 FILL_L10_0 FILL_L134_2 3.7415e-19
C509 FILL_L10_0 FILL_L30_0 2.6143400000000002e-17
C510 FILL_L10_0 FILL_L30_1 5.8188900000000004e-19
C511 FILL_L10_0 FILL_L50_2 1.16658e-18
C512 FILL_L10_0 P 3.1740400000000003e-18
C513 FILL_L10_0 0 6.3444600000000011e-17
C514 FILL_L10_1 FILL_L10_2 8.3247000000000007e-17
C515 FILL_L10_1 FILL_L10_5 6.8720699999999995e-17
C516 FILL_L10_1 FILL_L126_0 3.3314900000000004e-17
C517 FILL_L10_1 FILL_L134_0 7.7088700000000014e-18
C518 FILL_L10_1 FILL_L134_1 7.5328299999999997e-18
C519 FILL_L10_1 FILL_L30_10 5.2424200000000002e-18
C520 FILL_L10_1 FILL_L30_3 4.2436600000000001e-16
C521 FILL_L10_1 FILL_L50_0 1.7934800000000001e-17
C522 FILL_L10_1 FILL_L50_3 3.8908000000000001e-18
C523 FILL_L10_1 FILL_L8_0 4.9281300000000007e-16
C524 FILL_L10_1 0 2.6554600000000003e-16
C525 FILL_L10_10 FILL_L10_11 9.7773300000000019e-17
C526 FILL_L10_10 FILL_L10_16 6.8720699999999995e-17
C527 FILL_L10_10 FILL_L10_5 6.8720699999999995e-17
C528 FILL_L10_10 FILL_L126_0 9.1989400000000017e-18
C529 FILL_L10_10 FILL_L126_2 2.5510000000000004e-17
C530 FILL_L10_10 FILL_L134_0 5.7198800000000004e-18
C531 FILL_L10_10 FILL_L134_4 8.1157400000000012e-18
C532 FILL_L10_10 FILL_L134_5 2.1360000000000004e-18
C533 FILL_L10_10 FILL_L30_10 2.0961300000000003e-17
C534 FILL_L10_10 FILL_L30_16 4.8620400000000006e-16
C535 FILL_L10_10 FILL_L50_5 8.7095400000000018e-18
C536 FILL_L10_10 FILL_L50_8 2.3660500000000001e-17
C537 FILL_L10_10 FILL_L8_8 5.7880700000000008e-16
C538 FILL_L10_10 0 2.3980500000000001e-16
C539 FILL_L10_11 FILL_L10_12 9.7773300000000019e-17
C540 FILL_L10_11 FILL_L10_17 9.7773300000000019e-17
C541 FILL_L10_11 FILL_L10_6 9.7773300000000019e-17
C542 FILL_L10_11 FILL_L126_2 1.18248e-17
C543 FILL_L10_11 FILL_L134_1 1.9883400000000003e-17
C544 FILL_L10_11 FILL_L134_5 3.6526200000000005e-17
C545 FILL_L10_11 FILL_L30_10 1.3974200000000001e-17
C546 FILL_L10_11 FILL_L30_11 6.9870900000000006e-18
C547 FILL_L10_11 FILL_L30_13 1.23317e-16
C548 FILL_L10_11 FILL_L30_14 1.3979000000000001e-18
C549 FILL_L10_11 FILL_L30_16 4.01462e-16
C550 FILL_L10_11 FILL_L30_17 1.6912800000000001e-17
C551 FILL_L10_11 FILL_L50_8 1.8343100000000001e-18
C552 FILL_L10_11 FILL_L8_9 8.2350600000000007e-16
C553 FILL_L10_11 0 1.9621900000000002e-16
C554 FILL_L10_12 FILL_L10_13 4.1529200000000009e-17
C555 FILL_L10_12 FILL_L10_18 9.7773300000000019e-17
C556 FILL_L10_12 FILL_L10_7 9.7773300000000019e-17
C557 FILL_L10_12 FILL_L134_5 9.3411399999999993e-18
C558 FILL_L10_12 FILL_L30_13 2.0416800000000001e-17
C559 FILL_L10_12 FILL_L30_14 3.95965e-17
C560 FILL_L10_12 FILL_L30_15 9.70003e-18
C561 FILL_L10_12 FILL_L30_16 4.2729000000000006e-18
C562 FILL_L10_12 FILL_L50_9 7.9249799999999996e-18
C563 FILL_L10_12 FILL_L8_9 1.7167000000000004e-17
C564 FILL_L10_12 N 6.5750900000000007e-17
C565 FILL_L10_12 P 3.8255899999999997e-17
C566 FILL_L10_12 0 4.2621600000000003e-16
C567 FILL_L10_13 FILL_L10_20 9.7773300000000019e-17
C568 FILL_L10_13 FILL_L10_8 9.7773300000000019e-17
C569 FILL_L10_13 FILL_L134_2 4.8446100000000009e-18
C570 FILL_L10_13 FILL_L134_5 4.6800700000000002e-18
C571 FILL_L10_13 FILL_L30_13 3.9666900000000004e-19
C572 FILL_L10_13 FILL_L30_14 1.6577999999999999e-17
C573 FILL_L10_13 FILL_L30_15 6.1636500000000001e-16
C574 FILL_L10_13 FILL_L30_17 3.8494300000000002e-19
C575 FILL_L10_13 FILL_L30_21 8.4563900000000013e-17
C576 FILL_L10_13 FILL_L50_11 9.584250000000002e-18
C577 FILL_L10_13 FILL_L50_12 2.5649300000000001e-17
C578 FILL_L10_13 FILL_L50_9 1.4061300000000001e-17
C579 FILL_L10_13 FILL_L8_10 1.7383199999999999e-17
C580 FILL_L10_13 FILL_L8_11 8.2350600000000007e-16
C581 FILL_L10_13 FILL_L8_7 3.7105900000000004e-18
C582 FILL_L10_13 N 4.9557400000000006e-19
C583 FILL_L10_13 P 1.16039e-17
C584 FILL_L10_13 0 2.2491599999999999e-16
C585 FILL_L10_14 FILL_L10_19 1.11741e-18
C586 FILL_L10_14 FILL_L134_3 1.08219e-19
C587 FILL_L10_14 0 6.1370400000000001e-17
C588 FILL_L10_15 FILL_L10_21 2.7935199999999999e-17
C589 FILL_L10_15 FILL_L10_9 7.2313300000000002e-18
C590 FILL_L10_15 FILL_L126_1 2.1493900000000002e-18
C591 FILL_L10_15 FILL_L134_3 2.6723100000000002e-18
C592 FILL_L10_15 FILL_L30_21 2.6737000000000003e-18
C593 FILL_L10_15 FILL_L30_22 6.9870900000000006e-18
C594 FILL_L10_15 FILL_L50_12 5.4220900000000001e-18
C595 FILL_L10_15 FILL_L50_17 9.7220300000000003e-18
C596 FILL_L10_15 FILL_L8_15 1.43416e-16
C597 FILL_L10_15 0 5.6944000000000001e-17
C598 FILL_L10_16 FILL_L10_17 9.7773300000000019e-17
C599 FILL_L10_16 FILL_L10_22 6.8720699999999995e-17
C600 FILL_L10_16 FILL_L126_2 5.7272100000000008e-17
C601 FILL_L10_16 FILL_L134_4 1.8944299999999999e-17
C602 FILL_L10_16 FILL_L134_5 1.88906e-17
C603 FILL_L10_16 FILL_L30_16 1.0265900000000001e-16
C604 FILL_L10_16 FILL_L30_23 3.4133600000000002e-16
C605 FILL_L10_16 FILL_L50_10 2.0753100000000001e-17
C606 FILL_L10_16 FILL_L50_13 3.2370000000000003e-17
C607 FILL_L10_16 FILL_L8_12 5.7880700000000008e-16
C608 FILL_L10_16 0 2.3980500000000001e-16
C609 FILL_L10_17 FILL_L10_18 9.7773300000000019e-17
C610 FILL_L10_17 FILL_L10_23 9.7773300000000019e-17
C611 FILL_L10_17 FILL_L126_2 3.5588800000000003e-17
C612 FILL_L10_17 FILL_L134_5 4.3784900000000005e-17
C613 FILL_L10_17 FILL_L30_16 6.84395e-17
C614 FILL_L10_17 FILL_L30_17 3.1982700000000005e-17
C615 FILL_L10_17 FILL_L30_18 1.3986700000000001e-18
C616 FILL_L10_17 FILL_L30_19 1.1937600000000001e-16
C617 FILL_L10_17 FILL_L30_20 6.9895100000000004e-19
C618 FILL_L10_17 FILL_L30_23 2.7305700000000004e-16
C619 FILL_L10_17 FILL_L30_24 1.7474700000000001e-18
C620 FILL_L10_17 FILL_L50_13 1.8343100000000001e-18
C621 FILL_L10_17 FILL_L8_13 8.2350600000000007e-16
C622 FILL_L10_17 0 1.9621900000000002e-16
C623 FILL_L10_18 FILL_L10_20 4.1529200000000009e-17
C624 FILL_L10_18 FILL_L10_24 2.7935199999999999e-17
C625 FILL_L10_18 FILL_L134_5 2.0213600000000002e-17
C626 FILL_L10_18 FILL_L30_18 3.95965e-17
C627 FILL_L10_18 FILL_L30_19 2.0416800000000001e-17
C628 FILL_L10_18 FILL_L30_20 1.9798300000000003e-17
C629 FILL_L10_18 FILL_L30_21 9.70003e-18
C630 FILL_L10_18 FILL_L30_23 1.4243e-18
C631 FILL_L10_18 FILL_L50_14 7.9249799999999996e-18
C632 FILL_L10_18 FILL_L8_13 1.7167000000000004e-17
C633 FILL_L10_18 N 6.6245999999999997e-17
C634 FILL_L10_18 P 3.8751e-17
C635 FILL_L10_18 0 4.7719800000000001e-16
C636 FILL_L10_19 FILL_L30_22 3.8518500000000008e-18
C637 FILL_L10_19 FILL_L50_17 7.0777700000000002e-18
C638 FILL_L10_19 FILL_L8_15 2.5963000000000003e-17
C639 FILL_L10_19 0 4.2525900000000003e-17
C640 FILL_L10_2 FILL_L10_3 8.3247000000000007e-17
C641 FILL_L10_2 FILL_L10_6 9.7773300000000019e-17
C642 FILL_L10_2 FILL_L126_0 2.3656700000000001e-17
C643 FILL_L10_2 FILL_L134_1 3.1507000000000003e-17
C644 FILL_L10_2 FILL_L30_0 6.7099299999999998e-19
C645 FILL_L10_2 FILL_L30_10 3.4949400000000003e-18
C646 FILL_L10_2 FILL_L30_3 3.5960000000000006e-16
C647 FILL_L10_2 FILL_L30_4 1.1753900000000002e-16
C648 FILL_L10_2 FILL_L30_5 6.9933700000000005e-19
C649 FILL_L10_2 FILL_L30_6 1.7474700000000001e-18
C650 FILL_L10_2 FILL_L50_0 1.8343100000000001e-18
C651 FILL_L10_2 FILL_L8_1 7.0115700000000008e-16
C652 FILL_L10_2 0 2.5438100000000002e-16
C653 FILL_L10_20 FILL_L134_5 2.4748100000000002e-18
C654 FILL_L10_20 FILL_L30_19 4.4074299999999999e-19
C655 FILL_L10_20 FILL_L30_20 1.6577999999999999e-17
C656 FILL_L10_20 FILL_L30_21 7.8872900000000008e-16
C657 FILL_L10_20 FILL_L50_14 1.4061300000000001e-17
C658 FILL_L10_20 FILL_L50_17 1.1962500000000001e-17
C659 FILL_L10_20 FILL_L8_14 8.2350600000000007e-16
C660 FILL_L10_20 FILL_L8_15 1.2987100000000001e-17
C661 FILL_L10_20 N 4.9557400000000006e-19
C662 FILL_L10_20 P 1.2428200000000001e-17
C663 FILL_L10_20 0 2.9688200000000004e-16
C664 FILL_L10_21 FILL_L30_22 5.1420200000000006e-17
C665 FILL_L10_21 FILL_L50_17 2.86421e-17
C666 FILL_L10_21 FILL_L8_15 1.43416e-16
C667 FILL_L10_21 0 6.9600300000000007e-17
C668 FILL_L10_22 FILL_L10_23 1.4526300000000003e-17
C669 FILL_L10_22 FILL_L126_2 6.71723e-18
C670 FILL_L10_22 FILL_L134_4 7.343730000000001e-19
C671 FILL_L10_22 FILL_L134_5 6.9420000000000013e-19
C672 FILL_L10_22 FILL_L30_23 1.2433300000000002e-16
C673 FILL_L10_22 FILL_L50_15 6.04078e-18
C674 FILL_L10_22 FILL_L8_16 8.5994200000000013e-17
C675 FILL_L10_22 0 1.4546500000000001e-16
C676 FILL_L10_23 FILL_L10_24 1.4526300000000003e-17
C677 FILL_L10_23 FILL_L126_2 3.2144100000000001e-18
C678 FILL_L10_23 FILL_L134_5 6.4242300000000001e-18
C679 FILL_L10_23 FILL_L30_23 9.8273399999999997e-17
C680 FILL_L10_23 FILL_L30_24 4.6333300000000003e-17
C681 FILL_L10_23 FILL_L50_15 9.5384300000000008e-19
C682 FILL_L10_23 FILL_L8_17 1.2234900000000001e-16
C683 FILL_L10_23 0 1.8542400000000001e-16
C684 FILL_L10_24 FILL_L134_5 2.8216800000000003e-18
C685 FILL_L10_24 FILL_L30_24 7.2665700000000003e-18
C686 FILL_L10_24 FILL_L50_16 1.1456600000000001e-18
C687 FILL_L10_24 FILL_L8_17 1.8709600000000002e-18
C688 FILL_L10_24 N 4.8551300000000004e-19
C689 FILL_L10_24 P 3.8926300000000008e-19
C690 FILL_L10_24 0 8.1998200000000005e-17
C691 FILL_L10_3 FILL_L10_4 2.7935199999999999e-17
C692 FILL_L10_3 FILL_L10_7 9.7773300000000019e-17
C693 FILL_L10_3 FILL_L134_1 1.7137799999999998e-17
C694 FILL_L10_3 FILL_L134_2 1.4510200000000002e-17
C695 FILL_L10_3 FILL_L30_0 1.90063e-17
C696 FILL_L10_3 FILL_L30_3 4.2159300000000008e-18
C697 FILL_L10_3 FILL_L30_4 2.0416800000000001e-17
C698 FILL_L10_3 FILL_L30_5 1.9798300000000003e-17
C699 FILL_L10_3 FILL_L50_1 7.9249799999999996e-18
C700 FILL_L10_3 FILL_L8_1 1.4616500000000002e-17
C701 FILL_L10_3 N 5.4525700000000006e-17
C702 FILL_L10_3 P 3.1115600000000004e-17
C703 FILL_L10_3 0 4.4545200000000001e-16
C704 FILL_L10_4 FILL_L134_2 7.0153200000000006e-19
C705 FILL_L10_4 FILL_L30_4 2.9286100000000002e-19
C706 FILL_L10_4 FILL_L30_5 2.7232700000000005e-17
C707 FILL_L10_4 FILL_L50_1 9.7220300000000003e-18
C708 FILL_L10_4 P 3.3062900000000005e-18
C709 FILL_L10_4 0 8.1828300000000001e-17
C710 FILL_L10_5 FILL_L10_6 9.7773300000000019e-17
C711 FILL_L10_5 FILL_L126_0 3.2527400000000002e-17
C712 FILL_L10_5 FILL_L134_0 4.9429000000000001e-18
C713 FILL_L10_5 FILL_L134_1 4.6725000000000004e-18
C714 FILL_L10_5 FILL_L30_10 5.7908100000000005e-16
C715 FILL_L10_5 FILL_L50_3 1.16169e-17
C716 FILL_L10_5 FILL_L50_5 5.8084400000000003e-18
C717 FILL_L10_5 FILL_L8_3 5.7880700000000008e-16
C718 FILL_L10_5 0 2.3980500000000001e-16
C719 FILL_L10_6 FILL_L10_7 9.7773300000000019e-17
C720 FILL_L10_6 FILL_L126_0 2.4214500000000003e-17
C721 FILL_L10_6 FILL_L134_1 3.3394599999999996e-17
C722 FILL_L10_6 FILL_L30_10 4.9408600000000004e-16
C723 FILL_L10_6 FILL_L30_11 7.2296200000000005e-17
C724 FILL_L10_6 FILL_L30_6 1.0945800000000001e-16
C725 FILL_L10_6 FILL_L30_9 1.3979000000000001e-18
C726 FILL_L10_6 FILL_L50_3 1.8343100000000001e-18
C727 FILL_L10_6 FILL_L50_5 9.1715700000000002e-19
C728 FILL_L10_6 FILL_L8_4 8.2350600000000007e-16
C729 FILL_L10_6 0 1.9621900000000002e-16
C730 FILL_L10_7 FILL_L10_8 4.1529200000000009e-17
C731 FILL_L10_7 FILL_L134_1 1.9969300000000001e-17
C732 FILL_L10_7 FILL_L134_2 1.5891600000000003e-17
C733 FILL_L10_7 FILL_L30_10 5.6972e-18
C734 FILL_L10_7 FILL_L30_11 1.02084e-17
C735 FILL_L10_7 FILL_L30_6 2.0416800000000001e-17
C736 FILL_L10_7 FILL_L30_7 4.6082400000000004e-18
C737 FILL_L10_7 FILL_L30_8 3.7665100000000003e-19
C738 FILL_L10_7 FILL_L30_9 3.95965e-17
C739 FILL_L10_7 FILL_L50_4 7.9249799999999996e-18
C740 FILL_L10_7 FILL_L50_6 3.9624899999999998e-18
C741 FILL_L10_7 FILL_L50_7 2.8667100000000003e-19
C742 FILL_L10_7 FILL_L8_4 1.7167000000000004e-17
C743 FILL_L10_7 N 6.5750900000000007e-17
C744 FILL_L10_7 P 3.8255899999999997e-17
C745 FILL_L10_7 0 4.2621600000000003e-16
C746 FILL_L10_8 FILL_L126_1 2.3141100000000004e-17
C747 FILL_L10_8 FILL_L134_1 1.9901900000000003e-19
C748 FILL_L10_8 FILL_L134_2 1.94194e-17
C749 FILL_L10_8 FILL_L134_3 6.5431100000000008e-18
C750 FILL_L10_8 FILL_L30_11 4.9021799999999997e-19
C751 FILL_L10_8 FILL_L30_12 8.2890200000000006e-18
C752 FILL_L10_8 FILL_L30_15 2.9406900000000005e-16
C753 FILL_L10_8 FILL_L30_7 6.7753000000000006e-17
C754 FILL_L10_8 FILL_L30_9 2.3020700000000003e-17
C755 FILL_L10_8 FILL_L50_6 1.9168500000000004e-17
C756 FILL_L10_8 FILL_L50_7 4.1060200000000003e-17
C757 FILL_L10_8 FILL_L8_2 3.7105900000000004e-18
C758 FILL_L10_8 FILL_L8_5 8.2350600000000007e-16
C759 FILL_L10_8 FILL_L8_6 3.7105900000000004e-18
C760 FILL_L10_8 N 4.2123800000000005e-19
C761 FILL_L10_8 P 1.6183600000000001e-17
C762 FILL_L10_8 0 2.8731700000000005e-16
C763 FILL_L10_9 FILL_L126_1 3.1846400000000001e-18
C764 FILL_L10_9 FILL_L50_12 1.89964e-18
C765 FILL_L10_9 FILL_L50_7 4.0875399999999997e-18
C766 FILL_L10_9 FILL_L8_7 4.0092300000000002e-18
C767 FILL_L10_9 0 1.0796500000000001e-16
C768 FILL_L126_0 FILL_L126_2 3.1545400000000005e-17
C769 FILL_L126_0 FILL_L134_0 7.1279000000000004e-17
C770 FILL_L126_0 FILL_L134_1 1.1115300000000002e-16
C771 FILL_L126_0 FILL_L30_10 1.12312e-16
C772 FILL_L126_0 FILL_L30_11 2.05523e-18
C773 FILL_L126_0 FILL_L30_3 7.4276000000000001e-17
C774 FILL_L126_0 FILL_L30_4 2.4179200000000003e-18
C775 FILL_L126_0 FILL_L30_6 2.4179200000000003e-18
C776 FILL_L126_0 FILL_L50_0 1.9324100000000003e-17
C777 FILL_L126_0 FILL_L50_3 1.9324100000000003e-17
C778 FILL_L126_0 FILL_L50_5 1.6425499999999999e-17
C779 FILL_L126_0 FILL_L8_0 1.2651500000000002e-18
C780 FILL_L126_0 FILL_L8_3 1.5647500000000003e-18
C781 FILL_L126_0 FILL_L8_8 2.8898600000000006e-19
C782 FILL_L126_0 0 4.2923100000000004e-16
C783 FILL_L126_1 FILL_L134_2 2.8345000000000001e-17
C784 FILL_L126_1 FILL_L134_3 4.52514e-16
C785 FILL_L126_1 FILL_L30_15 2.8751200000000001e-18
C786 FILL_L126_1 FILL_L30_2 2.5975300000000002e-18
C787 FILL_L126_1 FILL_L30_21 7.1555000000000011e-19
C788 FILL_L126_1 FILL_L30_5 4.3985900000000005e-19
C789 FILL_L126_1 FILL_L30_7 5.5104600000000003e-18
C790 FILL_L126_1 FILL_L30_8 2.5669400000000003e-18
C791 FILL_L126_1 FILL_L50_12 6.3213700000000007e-17
C792 FILL_L126_1 FILL_L50_2 2.42638e-16
C793 FILL_L126_1 FILL_L50_7 3.6199100000000001e-16
C794 FILL_L126_1 FILL_L8_15 5.8168600000000005e-18
C795 FILL_L126_1 FILL_L8_2 4.489250000000001e-19
C796 FILL_L126_1 FILL_L8_5 5.1945500000000002e-19
C797 FILL_L126_1 FILL_L8_6 2.5423800000000002e-18
C798 FILL_L126_1 0 6.0814200000000009e-16
C799 FILL_L126_2 FILL_L134_4 7.3760499999999998e-17
C800 FILL_L126_2 FILL_L134_5 1.15023e-16
C801 FILL_L126_2 FILL_L30_13 2.4179200000000004e-19
C802 FILL_L126_2 FILL_L30_16 9.4354900000000012e-17
C803 FILL_L126_2 FILL_L30_17 2.4179200000000003e-18
C804 FILL_L126_2 FILL_L30_19 2.4179200000000003e-18
C805 FILL_L126_2 FILL_L30_23 1.0441100000000001e-16
C806 FILL_L126_2 FILL_L30_24 1.2573200000000001e-18
C807 FILL_L126_2 FILL_L50_10 1.9324100000000003e-17
C808 FILL_L126_2 FILL_L50_13 1.9324100000000003e-17
C809 FILL_L126_2 FILL_L50_15 1.0048500000000002e-17
C810 FILL_L126_2 FILL_L50_8 1.93241e-18
C811 FILL_L126_2 FILL_L8_12 2.5303000000000003e-18
C812 FILL_L126_2 FILL_L8_16 1.2651500000000002e-18
C813 FILL_L126_2 FILL_L8_8 1.2651500000000002e-18
C814 FILL_L126_2 0 4.3567500000000002e-16
C815 FILL_L134_0 FILL_L134_1 3.8308700000000003e-16
C816 FILL_L134_0 FILL_L134_4 3.0352700000000003e-17
C817 FILL_L134_0 FILL_L30_10 4.2279400000000003e-17
C818 FILL_L134_0 FILL_L30_3 2.8188500000000001e-17
C819 FILL_L134_0 FILL_L50_0 5.3650000000000003e-18
C820 FILL_L134_0 FILL_L50_3 5.3650000000000003e-18
C821 FILL_L134_0 FILL_L50_5 4.5602500000000001e-18
C822 FILL_L134_0 0 3.0555399999999998e-16
C823 FILL_L134_1 FILL_L134_2 3.8308700000000003e-16
C824 FILL_L134_1 FILL_L134_5 2.2994400000000001e-16
C825 FILL_L134_1 FILL_L30_0 1.5683000000000002e-18
C826 FILL_L134_1 FILL_L30_10 8.200180000000001e-17
C827 FILL_L134_1 FILL_L30_11 9.3064099999999998e-18
C828 FILL_L134_1 FILL_L30_13 3.8256800000000001e-18
C829 FILL_L134_1 FILL_L30_16 5.31345e-18
C830 FILL_L134_1 FILL_L30_3 5.4740100000000003e-17
C831 FILL_L134_1 FILL_L30_4 1.15346e-17
C832 FILL_L134_1 FILL_L30_5 3.2690300000000001e-18
C833 FILL_L134_1 FILL_L30_6 1.2158000000000001e-17
C834 FILL_L134_1 FILL_L30_7 6.7718600000000004e-19
C835 FILL_L134_1 FILL_L30_9 3.2672900000000002e-18
C836 FILL_L134_1 FILL_L50_0 7.9392199999999996e-18
C837 FILL_L134_1 FILL_L50_3 7.9392199999999996e-18
C838 FILL_L134_1 FILL_L50_5 6.7483400000000003e-18
C839 FILL_L134_1 FILL_L8_1 4.3470300000000008e-18
C840 FILL_L134_1 FILL_L8_4 4.9418400000000007e-18
C841 FILL_L134_1 FILL_L8_9 1.5855000000000002e-19
C842 FILL_L134_1 0 2.7002499999999998e-16
C843 FILL_L134_2 FILL_L134_3 3.8308700000000003e-16
C844 FILL_L134_2 FILL_L30_0 4.9968600000000002e-19
C845 FILL_L134_2 FILL_L30_1 4.9551400000000008e-19
C846 FILL_L134_2 FILL_L30_15 1.8286500000000002e-17
C847 FILL_L134_2 FILL_L30_21 5.1410500000000001e-18
C848 FILL_L134_2 FILL_L30_5 5.9672200000000002e-19
C849 FILL_L134_2 FILL_L30_7 1.09386e-17
C850 FILL_L134_2 FILL_L30_9 1.04101e-18
C851 FILL_L134_2 FILL_L50_1 1.3444700000000001e-18
C852 FILL_L134_2 FILL_L50_2 1.1180700000000001e-17
C853 FILL_L134_2 FILL_L50_4 1.3444700000000001e-18
C854 FILL_L134_2 FILL_L50_6 1.1428000000000002e-18
C855 FILL_L134_2 FILL_L50_7 1.6366299999999999e-17
C856 FILL_L134_2 FILL_L8_5 1.6829100000000001e-19
C857 FILL_L134_2 P 5.9521200000000003e-18
C858 FILL_L134_2 0 2.1383300000000002e-16
C859 FILL_L134_3 FILL_L30_15 1.4809700000000001e-18
C860 FILL_L134_3 FILL_L30_21 9.6394600000000001e-19
C861 FILL_L134_3 FILL_L30_7 4.6382000000000005e-19
C862 FILL_L134_3 FILL_L50_12 5.6401000000000007e-17
C863 FILL_L134_3 FILL_L50_2 1.1373400000000001e-17
C864 FILL_L134_3 FILL_L50_7 2.0172100000000001e-17
C865 FILL_L134_3 FILL_L8_15 6.5464200000000011e-18
C866 FILL_L134_3 FILL_L8_6 1.6998200000000003e-18
C867 FILL_L134_3 0 4.5876200000000002e-16
C868 FILL_L134_4 FILL_L134_5 3.9642400000000001e-16
C869 FILL_L134_4 FILL_L30_16 3.5982100000000005e-17
C870 FILL_L134_4 FILL_L30_23 3.9508600000000006e-17
C871 FILL_L134_4 FILL_L50_10 5.3650000000000003e-18
C872 FILL_L134_4 FILL_L50_13 5.3650000000000003e-18
C873 FILL_L134_4 FILL_L50_15 2.7898000000000004e-18
C874 FILL_L134_4 FILL_L50_8 5.365e-19
C875 FILL_L134_4 0 3.0652600000000005e-16
C876 FILL_L134_5 FILL_L30_10 8.7072500000000004e-19
C877 FILL_L134_5 FILL_L30_11 6.2692200000000006e-19
C878 FILL_L134_5 FILL_L30_13 7.1112400000000001e-18
C879 FILL_L134_5 FILL_L30_14 3.2672900000000002e-18
C880 FILL_L134_5 FILL_L30_15 2.7337400000000004e-18
C881 FILL_L134_5 FILL_L30_16 7.413280000000001e-17
C882 FILL_L134_5 FILL_L30_17 1.2158000000000001e-17
C883 FILL_L134_5 FILL_L30_18 3.2690300000000001e-18
C884 FILL_L134_5 FILL_L30_19 1.2158000000000001e-17
C885 FILL_L134_5 FILL_L30_20 3.2672900000000002e-18
C886 FILL_L134_5 FILL_L30_21 1.1297000000000001e-17
C887 FILL_L134_5 FILL_L30_23 7.5584800000000011e-17
C888 FILL_L134_5 FILL_L30_24 6.2248099999999999e-18
C889 FILL_L134_5 FILL_L50_10 7.9392199999999996e-18
C890 FILL_L134_5 FILL_L50_13 7.9392199999999996e-18
C891 FILL_L134_5 FILL_L50_15 4.1283899999999998e-18
C892 FILL_L134_5 FILL_L50_8 7.9392200000000011e-19
C893 FILL_L134_5 FILL_L8_12 2.9781400000000007e-19
C894 FILL_L134_5 FILL_L8_13 5.8019400000000004e-18
C895 FILL_L134_5 FILL_L8_17 1.9419400000000002e-18
C896 FILL_L134_5 FILL_L8_9 2.5942100000000002e-18
C897 FILL_L134_5 0 2.7368500000000003e-16
C898 FILL_L30_0 FILL_L30_1 3.6500300000000006e-18
C899 FILL_L30_0 FILL_L30_3 2.2735300000000003e-18
C900 FILL_L30_0 FILL_L30_5 1.92731e-17
C901 FILL_L30_0 FILL_L50_1 1.3500100000000001e-17
C902 FILL_L30_0 FILL_L50_2 3.9153100000000003e-19
C903 FILL_L30_0 N 9.7296500000000008e-19
C904 FILL_L30_0 P 8.9758499999999999e-18
C905 FILL_L30_0 0 5.9896099999999997e-17
C906 FILL_L30_1 FILL_L30_2 9.2511100000000013e-18
C907 FILL_L30_1 FILL_L50_2 8.0944199999999998e-17
C908 FILL_L30_1 0 5.9734900000000004e-17
C909 FILL_L30_10 FILL_L30_11 1.92731e-17
C910 FILL_L30_10 FILL_L30_16 7.7092600000000011e-17
C911 FILL_L30_10 FILL_L30_3 7.7092600000000011e-17
C912 FILL_L30_10 FILL_L30_6 1.92731e-17
C913 FILL_L30_10 FILL_L30_9 4.7365199999999997e-18
C914 FILL_L30_10 FILL_L50_3 1.5243600000000002e-16
C915 FILL_L30_10 FILL_L50_5 1.5243600000000002e-16
C916 FILL_L30_10 FILL_L8_3 3.2704500000000003e-17
C917 FILL_L30_10 FILL_L8_4 3.11962e-17
C918 FILL_L30_10 FILL_L8_8 3.4512300000000002e-18
C919 FILL_L30_10 FILL_L8_9 2.30082e-18
C920 FILL_L30_10 0 2.9082900000000002e-16
C921 FILL_L30_11 FILL_L30_13 1.92731e-17
C922 FILL_L30_11 FILL_L30_6 1.92731e-17
C923 FILL_L30_11 FILL_L50_6 5.6011900000000007e-19
C924 FILL_L30_11 FILL_L8_4 3.01665e-18
C925 FILL_L30_11 FILL_L8_9 1.15041e-18
C926 FILL_L30_11 N 1.3439599999999999e-19
C927 FILL_L30_11 P 1.0676200000000001e-19
C928 FILL_L30_11 0 5.1786099999999999e-17
C929 FILL_L30_12 FILL_L30_14 1.92731e-17
C930 FILL_L30_12 FILL_L30_15 1.92731e-17
C931 FILL_L30_12 FILL_L30_9 1.92731e-17
C932 FILL_L30_12 FILL_L50_6 5.6426099999999999e-17
C933 FILL_L30_12 FILL_L50_9 1.7174900000000002e-17
C934 FILL_L30_12 N 2.0270100000000002e-18
C935 FILL_L30_12 P 1.8699700000000002e-17
C936 FILL_L30_12 0 7.5691100000000015e-17
C937 FILL_L30_13 FILL_L30_15 4.7365199999999997e-18
C938 FILL_L30_13 FILL_L30_16 1.92731e-17
C939 FILL_L30_13 FILL_L30_17 1.92731e-17
C940 FILL_L30_13 FILL_L50_9 5.9306800000000007e-19
C941 FILL_L30_13 FILL_L8_9 3.01665e-18
C942 FILL_L30_13 N 2.4191200000000001e-19
C943 FILL_L30_13 P 1.9217200000000002e-19
C944 FILL_L30_13 0 3.554e-17
C945 FILL_L30_14 FILL_L30_15 1.92731e-17
C946 FILL_L30_14 FILL_L30_16 4.7365199999999997e-18
C947 FILL_L30_14 FILL_L30_18 1.92731e-17
C948 FILL_L30_14 FILL_L50_11 1.7174900000000002e-17
C949 FILL_L30_14 FILL_L50_9 5.6426099999999999e-17
C950 FILL_L30_14 N 2.0270100000000002e-18
C951 FILL_L30_14 P 1.8699700000000002e-17
C952 FILL_L30_14 0 5.0666400000000006e-17
C953 FILL_L30_15 FILL_L30_21 7.7092600000000011e-17
C954 FILL_L30_15 FILL_L30_7 1.27509e-17
C955 FILL_L30_15 FILL_L30_8 1.27509e-17
C956 FILL_L30_15 FILL_L50_12 3.1873100000000002e-16
C957 FILL_L30_15 FILL_L50_7 7.6660800000000001e-17
C958 FILL_L30_15 FILL_L50_9 6.5780100000000005e-18
C959 FILL_L30_15 FILL_L8_10 3.3010900000000004e-17
C960 FILL_L30_15 FILL_L8_11 3.3713500000000008e-17
C961 FILL_L30_15 FILL_L8_5 2.4153900000000002e-17
C962 FILL_L30_15 FILL_L8_6 8.7223699999999999e-18
C963 FILL_L30_15 FILL_L8_7 1.7444700000000001e-17
C964 FILL_L30_15 N 4.2083100000000004e-19
C965 FILL_L30_15 P 4.5087200000000008e-18
C966 FILL_L30_15 0 2.6574000000000001e-16
C967 FILL_L30_16 FILL_L30_17 1.92731e-17
C968 FILL_L30_16 FILL_L30_23 7.7092600000000011e-17
C969 FILL_L30_16 FILL_L50_10 1.5243600000000002e-16
C970 FILL_L30_16 FILL_L50_8 1.5243600000000002e-16
C971 FILL_L30_16 FILL_L8_12 1.2077000000000001e-17
C972 FILL_L30_16 FILL_L8_13 8.0512999999999997e-18
C973 FILL_L30_16 FILL_L8_8 3.2205199999999999e-17
C974 FILL_L30_16 FILL_L8_9 2.8179600000000001e-17
C975 FILL_L30_16 0 3.1899200000000002e-16
C976 FILL_L30_17 FILL_L30_19 1.92731e-17
C977 FILL_L30_17 FILL_L50_11 6.5896400000000007e-19
C978 FILL_L30_17 FILL_L8_13 2.87524e-18
C979 FILL_L30_17 FILL_L8_9 2.5173300000000001e-18
C980 FILL_L30_17 N 2.6879100000000003e-19
C981 FILL_L30_17 P 2.1352400000000002e-19
C982 FILL_L30_17 0 6.8208600000000009e-17
C983 FILL_L30_18 FILL_L30_20 1.92731e-17
C984 FILL_L30_18 FILL_L30_21 1.92731e-17
C985 FILL_L30_18 FILL_L50_11 5.6426099999999999e-17
C986 FILL_L30_18 FILL_L50_14 1.7174900000000002e-17
C987 FILL_L30_18 N 2.0270100000000002e-18
C988 FILL_L30_18 P 1.8699700000000002e-17
C989 FILL_L30_18 0 5.6758800000000003e-17
C990 FILL_L30_19 FILL_L30_21 4.7365199999999997e-18
C991 FILL_L30_19 FILL_L30_23 1.92731e-17
C992 FILL_L30_19 FILL_L30_24 1.92731e-17
C993 FILL_L30_19 FILL_L50_14 6.5896400000000007e-19
C994 FILL_L30_19 FILL_L8_13 3.01665e-18
C995 FILL_L30_19 N 2.6879100000000003e-19
C996 FILL_L30_19 P 2.1352400000000002e-19
C997 FILL_L30_19 0 3.5842500000000006e-17
C998 FILL_L30_2 FILL_L50_2 8.0944199999999998e-17
C999 FILL_L30_2 0 6.6159700000000004e-17
C1000 FILL_L30_20 FILL_L30_21 1.92731e-17
C1001 FILL_L30_20 FILL_L30_23 4.7365199999999997e-18
C1002 FILL_L30_20 FILL_L50_14 5.6426099999999999e-17
C1003 FILL_L30_20 FILL_L50_16 1.4493600000000001e-17
C1004 FILL_L30_20 N 2.0270100000000002e-18
C1005 FILL_L30_20 P 1.8699700000000002e-17
C1006 FILL_L30_20 0 8.01475e-17
C1007 FILL_L30_21 FILL_L30_22 1.92731e-17
C1008 FILL_L30_21 FILL_L50_12 7.3601000000000008e-17
C1009 FILL_L30_21 FILL_L50_14 6.5780100000000005e-18
C1010 FILL_L30_21 FILL_L50_17 3.3320400000000004e-16
C1011 FILL_L30_21 FILL_L8_10 1.17922e-17
C1012 FILL_L30_21 FILL_L8_11 1.2586600000000002e-17
C1013 FILL_L30_21 FILL_L8_14 3.8530100000000001e-17
C1014 FILL_L30_21 FILL_L8_15 8.9773000000000004e-17
C1015 FILL_L30_21 N 4.4298000000000001e-19
C1016 FILL_L30_21 P 4.5367200000000002e-18
C1017 FILL_L30_21 0 3.3844800000000002e-16
C1018 FILL_L30_22 FILL_L50_12 6.6458100000000004e-19
C1019 FILL_L30_22 FILL_L50_17 1.5553700000000001e-16
C1020 FILL_L30_22 FILL_L8_15 5.9345999999999998e-17
C1021 FILL_L30_22 0 6.2317100000000012e-17
C1022 FILL_L30_23 FILL_L30_24 1.0022000000000001e-17
C1023 FILL_L30_23 FILL_L50_13 1.5243600000000002e-16
C1024 FILL_L30_23 FILL_L50_15 9.8808200000000001e-17
C1025 FILL_L30_23 FILL_L8_12 2.4153900000000002e-17
C1026 FILL_L30_23 FILL_L8_13 2.0128300000000001e-17
C1027 FILL_L30_23 FILL_L8_16 1.62636e-17
C1028 FILL_L30_23 FILL_L8_17 1.2238000000000001e-17
C1029 FILL_L30_23 0 3.9997000000000007e-16
C1030 FILL_L30_24 FILL_L50_16 3.4266100000000003e-19
C1031 FILL_L30_24 FILL_L8_17 1.5686600000000001e-18
C1032 FILL_L30_24 N 1.3977200000000001e-19
C1033 FILL_L30_24 P 1.11032e-19
C1034 FILL_L30_24 0 5.8086799999999995e-17
C1035 FILL_L30_3 FILL_L30_4 1.92731e-17
C1036 FILL_L30_3 FILL_L50_0 1.4876100000000002e-16
C1037 FILL_L30_3 FILL_L8_0 1.99672e-17
C1038 FILL_L30_3 FILL_L8_1 1.99672e-17
C1039 FILL_L30_3 0 2.8521700000000003e-16
C1040 FILL_L30_4 FILL_L30_6 1.92731e-17
C1041 FILL_L30_4 FILL_L50_1 6.5896400000000007e-19
C1042 FILL_L30_4 FILL_L8_1 3.01665e-18
C1043 FILL_L30_4 N 2.6879100000000003e-19
C1044 FILL_L30_4 P 2.1352400000000002e-19
C1045 FILL_L30_4 0 5.6759400000000006e-17
C1046 FILL_L30_5 FILL_L30_9 1.92731e-17
C1047 FILL_L30_5 FILL_L50_1 5.6426099999999999e-17
C1048 FILL_L30_5 FILL_L50_4 1.7174900000000002e-17
C1049 FILL_L30_5 N 2.0270100000000002e-18
C1050 FILL_L30_5 P 1.8699700000000002e-17
C1051 FILL_L30_5 0 7.1445500000000004e-17
C1052 FILL_L30_6 FILL_L30_7 4.7365199999999997e-18
C1053 FILL_L30_6 FILL_L50_4 6.5896400000000007e-19
C1054 FILL_L30_6 FILL_L8_4 3.01665e-18
C1055 FILL_L30_6 N 2.6879100000000003e-19
C1056 FILL_L30_6 P 2.1352400000000002e-19
C1057 FILL_L30_6 0 3.7724899999999999e-17
C1058 FILL_L30_7 FILL_L30_8 1.92731e-17
C1059 FILL_L30_7 FILL_L50_4 6.5780100000000005e-18
C1060 FILL_L30_7 FILL_L8_5 5.7504800000000001e-18
C1061 FILL_L30_7 N 2.2149000000000001e-19
C1062 FILL_L30_7 P 2.8003500000000001e-19
C1063 FILL_L30_7 0 6.3508300000000006e-17
C1064 FILL_L30_8 FILL_L50_7 1.3912300000000001e-16
C1065 FILL_L30_8 FILL_L8_10 4.5649700000000006e-19
C1066 FILL_L30_8 0 7.19507e-17
C1067 FILL_L30_9 FILL_L50_4 5.6426099999999999e-17
C1068 FILL_L30_9 FILL_L50_6 1.7174900000000002e-17
C1069 FILL_L30_9 FILL_L50_7 1.4888300000000001e-18
C1070 FILL_L30_9 FILL_L8_2 1.01127e-18
C1071 FILL_L30_9 N 2.0270100000000002e-18
C1072 FILL_L30_9 P 1.8699700000000002e-17
C1073 FILL_L30_9 0 5.6325900000000006e-17
C1074 FILL_L50_0 FILL_L50_3 2.4713600000000001e-17
C1075 FILL_L50_0 0 5.2890100000000002e-17
C1076 FILL_L50_1 FILL_L50_4 2.4713600000000001e-17
C1077 FILL_L50_1 P 7.9368600000000002e-17
C1078 FILL_L50_1 0 5.56585e-17
C1079 FILL_L50_10 FILL_L50_13 2.4713600000000001e-17
C1080 FILL_L50_10 FILL_L50_8 2.4713600000000001e-17
C1081 FILL_L50_10 0 3.0953700000000002e-17
C1082 FILL_L50_11 FILL_L50_14 2.4713600000000001e-17
C1083 FILL_L50_11 FILL_L50_9 2.4713600000000001e-17
C1084 FILL_L50_11 P 7.9368600000000002e-17
C1085 FILL_L50_11 0 3.1213000000000002e-17
C1086 FILL_L50_12 FILL_L50_17 9.8854299999999996e-17
C1087 FILL_L50_12 FILL_L50_7 9.8854299999999996e-17
C1088 FILL_L50_12 FILL_L8_10 1.3634100000000001e-17
C1089 FILL_L50_12 FILL_L8_11 5.4293500000000011e-18
C1090 FILL_L50_12 FILL_L8_15 2.1858400000000001e-17
C1091 FILL_L50_12 FILL_L8_6 2.3950300000000003e-18
C1092 FILL_L50_12 FILL_L8_7 1.6475600000000002e-17
C1093 FILL_L50_12 0 1.8004300000000001e-16
C1094 FILL_L50_13 FILL_L50_15 2.4713600000000001e-17
C1095 FILL_L50_13 0 2.3938e-17
C1096 FILL_L50_14 FILL_L50_16 2.4713600000000001e-17
C1097 FILL_L50_14 P 7.9368600000000002e-17
C1098 FILL_L50_14 0 2.6005800000000004e-17
C1099 FILL_L50_15 0 4.1530800000000004e-17
C1100 FILL_L50_16 P 4.1271700000000005e-17
C1101 FILL_L50_16 0 4.7637100000000001e-17
C1102 FILL_L50_17 FILL_L8_10 1.1368100000000001e-18
C1103 FILL_L50_17 FILL_L8_14 1.3905000000000002e-18
C1104 FILL_L50_17 FILL_L8_15 1.11643e-16
C1105 FILL_L50_17 0 2.7074299999999999e-16
C1106 FILL_L50_2 FILL_L50_7 9.8854299999999996e-17
C1107 FILL_L50_2 P 3.5888400000000002e-18
C1108 FILL_L50_2 0 2.8236600000000002e-16
C1109 FILL_L50_3 FILL_L50_5 2.4713600000000001e-17
C1110 FILL_L50_3 0 3.1874000000000002e-17
C1111 FILL_L50_4 FILL_L50_6 2.4713600000000001e-17
C1112 FILL_L50_4 P 7.9368600000000002e-17
C1113 FILL_L50_4 0 3.1048000000000003e-17
C1114 FILL_L50_5 FILL_L50_8 2.4713600000000001e-17
C1115 FILL_L50_5 0 3.2804600000000002e-17
C1116 FILL_L50_6 FILL_L50_9 2.4713600000000001e-17
C1117 FILL_L50_6 P 7.9368600000000002e-17
C1118 FILL_L50_6 0 2.6327500000000001e-17
C1119 FILL_L50_7 FILL_L8_10 3.1621700000000004e-18
C1120 FILL_L50_7 FILL_L8_15 8.1418500000000007e-19
C1121 FILL_L50_7 FILL_L8_2 2.4520100000000003e-17
C1122 FILL_L50_7 FILL_L8_5 1.5666200000000001e-17
C1123 FILL_L50_7 FILL_L8_6 1.5718300000000001e-17
C1124 FILL_L50_7 0 2.7226000000000001e-16
C1125 FILL_L50_8 0 2.8980199999999999e-17
C1126 FILL_L50_9 P 7.9368600000000002e-17
C1127 FILL_L50_9 0 2.6005800000000004e-17
C1128 FILL_L8_0 FILL_L8_1 5.9341900000000009e-17
C1129 FILL_L8_0 FILL_L8_3 4.8986899999999999e-17
C1130 FILL_L8_0 0 5.9714300000000003e-16
C1131 FILL_L8_1 FILL_L8_4 6.96968e-17
C1132 FILL_L8_1 0 7.5037600000000001e-16
C1133 FILL_L8_10 FILL_L8_11 6.4864600000000005e-17
C1134 FILL_L8_10 0 1.55736e-16
C1135 FILL_L8_11 FILL_L8_14 6.96968e-17
C1136 FILL_L8_11 FILL_L8_5 6.96968e-17
C1137 FILL_L8_11 FILL_L8_7 1.9913400000000001e-17
C1138 FILL_L8_11 0 7.1111000000000003e-16
C1139 FILL_L8_12 FILL_L8_13 6.96968e-17
C1140 FILL_L8_12 FILL_L8_16 4.8986899999999999e-17
C1141 FILL_L8_12 FILL_L8_8 4.8986899999999999e-17
C1142 FILL_L8_12 0 6.3367499999999999e-16
C1143 FILL_L8_13 FILL_L8_17 6.96968e-17
C1144 FILL_L8_13 FILL_L8_9 6.96968e-17
C1145 FILL_L8_13 0 7.8503900000000001e-16
C1146 FILL_L8_14 FILL_L8_15 6.96968e-17
C1147 FILL_L8_14 0 7.6318100000000012e-16
C1148 FILL_L8_15 FILL_L8_7 7.2876000000000012e-18
C1149 FILL_L8_15 0 9.0468800000000008e-16
C1150 FILL_L8_16 FILL_L8_17 1.0355000000000001e-17
C1151 FILL_L8_16 0 2.3129000000000001e-16
C1152 FILL_L8_17 0 3.1175800000000003e-16
C1153 FILL_L8_2 FILL_L8_5 1.9913400000000001e-17
C1154 FILL_L8_2 FILL_L8_6 1.9913400000000001e-17
C1155 FILL_L8_2 0 1.3117800000000001e-16
C1156 FILL_L8_3 FILL_L8_4 6.96968e-17
C1157 FILL_L8_3 FILL_L8_8 4.8986899999999999e-17
C1158 FILL_L8_3 0 6.3367499999999999e-16
C1159 FILL_L8_4 FILL_L8_9 6.96968e-17
C1160 FILL_L8_4 0 7.8503900000000001e-16
C1161 FILL_L8_5 FILL_L8_6 1.9913400000000001e-17
C1162 FILL_L8_5 0 7.261630000000001e-16
C1163 FILL_L8_6 FILL_L8_7 1.9913400000000001e-17
C1164 FILL_L8_6 0 1.3776100000000001e-16
C1165 FILL_L8_7 0 1.4300499999999999e-16
C1166 FILL_L8_8 FILL_L8_9 6.96968e-17
C1167 FILL_L8_8 0 6.3367499999999999e-16
C1168 FILL_L8_9 0 7.8503900000000001e-16
C1169 N P 3.4877500000000003e-15
C1170 N 0 5.8416800000000005e-17
C1171 P 0 2.0760400000000003e-16
VP P 0 DC 0 AC 1
VN N 0 DC 0 AC 0
.control
set numdgt=17
ac lin 1 1Meg 1Meg
let cp = -imag(i(VP))/(2*pi*1e6)
let cn = -imag(i(VN))/(2*pi*1e6)
print cp cn
quit
.endc
.end
