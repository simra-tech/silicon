*********************************************************
*** NGSPICE file created by KLayout-PEX 0.3.12
*** -----------------------------------------------------
***     Extraction Engine: KPEX/2.5D
***     Technology: ihp_sg13g2
***     Date: 2026-09-23 06:32:41
*********************************************************

.SUBCKT sense_fill_clip
Cext_1 CTX_L10_0|CTX_L30_0|CTX_L30_1|CTX_L50_6|CTX_L8_2
+ CTX_L10_1|CTX_L8_0|CTX_L8_3 119.063a
Cext_2 CTX_L10_0|CTX_L30_0|CTX_L30_1|CTX_L50_6|CTX_L8_2 CTX_L10_2 0.134551a
Cext_3 CTX_L10_0|CTX_L30_0|CTX_L30_1|CTX_L50_6|CTX_L8_2
+ CTX_L10_3|CTX_L30_3|CTX_L8_5 6.68381a
Cext_4 CTX_L10_0|CTX_L30_0|CTX_L30_1|CTX_L50_6|CTX_L8_2
+ CTX_L10_4|CTX_L30_5|CTX_L8_7 46.011a
Cext_5 CTX_L10_0|CTX_L30_0|CTX_L30_1|CTX_L50_6|CTX_L8_2 CTX_L10_5 280.882a
Cext_6 CTX_L10_0|CTX_L30_0|CTX_L30_1|CTX_L50_6|CTX_L8_2 CTX_L126_0 624.229a
Cext_7 CTX_L10_0|CTX_L30_0|CTX_L30_1|CTX_L50_6|CTX_L8_2 CTX_L30_2 2.36945a
Cext_8 CTX_L10_0|CTX_L30_0|CTX_L30_1|CTX_L50_6|CTX_L8_2 CTX_L50_3 0.249218a
Cext_9 CTX_L10_0|CTX_L30_0|CTX_L30_1|CTX_L50_6|CTX_L8_2 CTX_L8_1 68.0371a
Cext_10 CTX_L10_0|CTX_L30_0|CTX_L30_1|CTX_L50_6|CTX_L8_2 CTX_L8_4 2.5018a
Cext_11 CTX_L10_0|CTX_L30_0|CTX_L30_1|CTX_L50_6|CTX_L8_2 CTX_L8_6 0.389431a
Cext_12 CTX_L10_0|CTX_L30_0|CTX_L30_1|CTX_L50_6|CTX_L8_2 CTX_L8_8 0.73738a
Cext_13 CTX_L10_0|CTX_L30_0|CTX_L30_1|CTX_L50_6|CTX_L8_2 CTX_L8_9 992.559a
Cext_14 CTX_L10_0|CTX_L30_0|CTX_L30_1|CTX_L50_6|CTX_L8_2 N 0.466823a
Cext_15 CTX_L10_0|CTX_L30_0|CTX_L30_1|CTX_L50_6|CTX_L8_2 P 213.647a
Cext_16 CTX_L10_0|CTX_L30_0|CTX_L30_1|CTX_L50_6|CTX_L8_2 VSUBS 2.21878f
Cext_17 CTX_L10_1|CTX_L8_0|CTX_L8_3 CTX_L10_2 59.3783a
Cext_18 CTX_L10_1|CTX_L8_0|CTX_L8_3 CTX_L10_3|CTX_L30_3|CTX_L8_5 6.83304a
Cext_19 CTX_L10_1|CTX_L8_0|CTX_L8_3 CTX_L10_5 75.8273a
Cext_20 CTX_L10_1|CTX_L8_0|CTX_L8_3 CTX_L126_0 2.04602a
Cext_21 CTX_L10_1|CTX_L8_0|CTX_L8_3 CTX_L30_2 2.13597a
Cext_22 CTX_L10_1|CTX_L8_0|CTX_L8_3 CTX_L8_1 53.9519a
Cext_23 CTX_L10_1|CTX_L8_0|CTX_L8_3 CTX_L8_9 248.477a
Cext_24 CTX_L10_1|CTX_L8_0|CTX_L8_3 VSUBS 314.308a
Cext_25 CTX_L10_2 CTX_L10_3|CTX_L30_3|CTX_L8_5 134.666a
Cext_26 CTX_L10_2 CTX_L10_5 35.1593a
Cext_27 CTX_L10_2 CTX_L30_2 0.842937a
Cext_28 CTX_L10_2 CTX_L30_4 0.545678a
Cext_29 CTX_L10_2 CTX_L8_4 15.5471a
Cext_30 CTX_L10_2 CTX_L8_6 2.39132a
Cext_31 CTX_L10_2 CTX_L8_9 6.35309a
Cext_32 CTX_L10_2 VSUBS 212.54a
Cext_33 CTX_L10_3|CTX_L30_3|CTX_L8_5 CTX_L10_4|CTX_L30_5|CTX_L8_7 20.605a
Cext_34 CTX_L10_3|CTX_L30_3|CTX_L8_5 CTX_L10_5 19.6222a
Cext_35 CTX_L10_3|CTX_L30_3|CTX_L8_5 CTX_L126_0 1.12344a
Cext_36 CTX_L10_3|CTX_L30_3|CTX_L8_5 CTX_L30_2 0.543121a
Cext_37 CTX_L10_3|CTX_L30_3|CTX_L8_5 CTX_L30_4 9.08712a
Cext_38 CTX_L10_3|CTX_L30_3|CTX_L8_5 CTX_L8_4 2.96821a
Cext_39 CTX_L10_3|CTX_L30_3|CTX_L8_5 CTX_L8_6 72.8363a
Cext_40 CTX_L10_3|CTX_L30_3|CTX_L8_5 VSUBS 123.134a
Cext_41 CTX_L10_4|CTX_L30_5|CTX_L8_7 CTX_L10_5 162.095a
Cext_42 CTX_L10_4|CTX_L30_5|CTX_L8_7 CTX_L126_0 54.1375a
Cext_43 CTX_L10_4|CTX_L30_5|CTX_L8_7 CTX_L30_4 1.01492a
Cext_44 CTX_L10_4|CTX_L30_5|CTX_L8_7 CTX_L8_6 19.2659a
Cext_45 CTX_L10_4|CTX_L30_5|CTX_L8_7 CTX_L8_9 11.9108a
Cext_46 CTX_L10_4|CTX_L30_5|CTX_L8_7 VSUBS 1.15256f
Cext_47 CTX_L10_5 CTX_L126_0 80.4879a
Cext_48 CTX_L10_5 CTX_L30_2 0.122766a
Cext_49 CTX_L10_5 CTX_L8_1 0.289732a
Cext_50 CTX_L10_5 CTX_L8_4 0.865212a
Cext_51 CTX_L10_5 CTX_L8_9 83.1455a
Cext_52 CTX_L10_5 VSUBS 1.27168f
Cext_53 CTX_L126_0 CTX_L50_0 16.4181a
Cext_54 CTX_L126_0 CTX_L50_1 19.3755a
Cext_55 CTX_L126_0 CTX_L50_2 70.7361a
Cext_56 CTX_L126_0 CTX_L50_3 297.129a
Cext_57 CTX_L126_0 CTX_L8_1 0.28104a
Cext_58 CTX_L126_0 CTX_L8_4 0.685345a
Cext_59 CTX_L126_0 CTX_L8_8 95.0388a
Cext_60 CTX_L126_0 CTX_L8_9 192.92a
Cext_61 CTX_L126_0 N 230.516a
Cext_62 CTX_L126_0 P 489.685a
Cext_63 CTX_L126_0 VSUBS 2.21075f
Cext_64 CTX_L30_2 CTX_L8_4 0.649602a
Cext_65 CTX_L30_2 CTX_L8_9 0.43552a
Cext_66 CTX_L30_2 VSUBS 14.27a
Cext_67 CTX_L30_4 CTX_L8_6 0.410069a
Cext_68 CTX_L30_4 VSUBS 14.5319a
Cext_69 CTX_L50_0 CTX_L50_1 3.48775f
Cext_70 CTX_L50_0 CTX_L8_8 3.91548a
Cext_71 CTX_L50_0 VSUBS 659.386a
Cext_72 CTX_L50_1 CTX_L50_2 1.29649f
Cext_73 CTX_L50_1 CTX_L8_8 4.44804a
Cext_74 CTX_L50_1 VSUBS 159.538a
Cext_75 CTX_L50_2 CTX_L50_3 271.822a
Cext_76 CTX_L50_2 CTX_L8_8 7.26708a
Cext_77 CTX_L50_2 VSUBS 477.142a
Cext_78 CTX_L50_3 CTX_L8_8 64.7232a
Cext_79 CTX_L50_3 N 1.29649f
Cext_80 CTX_L50_3 VSUBS 436.375a
Cext_81 CTX_L8_1 CTX_L8_9 54.2019a
Cext_82 CTX_L8_1 VSUBS 115.898a
Cext_83 CTX_L8_4 CTX_L8_6 4.77212a
Cext_84 CTX_L8_4 CTX_L8_9 93.0357a
Cext_85 CTX_L8_4 VSUBS 150.817a
Cext_86 CTX_L8_6 VSUBS 76.2887a
Cext_87 CTX_L8_8 CTX_L8_9 180.553a
Cext_88 CTX_L8_8 N 17.0381a
Cext_89 CTX_L8_8 P 10.2723a
Cext_90 CTX_L8_8 VSUBS 1.65066f
Cext_91 CTX_L8_9 N 8.26783a
Cext_92 CTX_L8_9 P 46.7669a
Cext_93 CTX_L8_9 VSUBS 3.26587f
Cext_94 N P 3.48775f
Cext_95 N VSUBS 155.235a
Cext_96 P VSUBS 463.167a
.ENDS sense_fill_clip
