* cell sense_fill_clip
.SUBCKT sense_fill_clip
* net 1 CTX_L10_1,CTX_L8_0,CTX_L8_3
* net 2 CTX_L8_1
* net 3 CTX_L10_0,CTX_L30_0,CTX_L30_1,CTX_L50_6,CTX_L8_2
* net 4 CTX_L8_4
* net 5 CTX_L10_3,CTX_L30_3,CTX_L8_5
* net 6 CTX_L8_6
* net 7 CTX_L8_8
* net 8 CTX_L10_2
* net 9 CTX_L10_5
* net 10 CTX_L10_4,CTX_L30_5,CTX_L8_7
* net 11 CTX_L30_2
* net 12 CTX_L30_4
* net 13 CTX_L50_0
* net 14 CTX_L50_1
* net 15 CTX_L50_2
* net 16 CTX_L50_3
* net 17 N
* net 18 P
* net 19 CTX_L126_0
* net 21 CTX_L8_9
.ENDS sense_fill_clip
