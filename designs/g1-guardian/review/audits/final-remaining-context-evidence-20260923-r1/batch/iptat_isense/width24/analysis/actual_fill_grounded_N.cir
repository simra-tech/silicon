* actual_fill grounded drive N; diagnostic capacitor-network AC only
C56 0 P 1.42285e-16
C232 0 N 2.3051600000000003e-16
C233 0 P 3.9880000000000004e-16
C388 0 N 1.2964900000000001e-15
C450 0 N 5.2091300000000003e-18
C451 0 P 3.0694400000000005e-18
C503 0 N 2.6333000000000005e-18
C504 0 P 2.80893e-17
C512 0 P 3.1740400000000003e-18
C564 0 N 6.5750900000000007e-17
C565 0 P 3.8255899999999997e-17
C582 0 N 4.9557400000000006e-19
C583 0 P 1.16039e-17
C633 0 N 6.6245999999999997e-17
C634 0 P 3.8751e-17
C661 0 N 4.9557400000000006e-19
C662 0 P 1.2428200000000001e-17
C688 0 N 4.8551300000000004e-19
C689 0 P 3.8926300000000008e-19
C701 0 N 5.4525700000000006e-17
C702 0 P 3.1115600000000004e-17
C708 0 P 3.3062900000000005e-18
C743 0 N 6.5750900000000007e-17
C744 0 P 3.8255899999999997e-17
C760 0 N 4.2123800000000005e-19
C761 0 P 1.6183600000000001e-17
C857 0 P 5.9521200000000003e-18
C903 0 N 9.7296500000000008e-19
C904 0 P 8.9758499999999999e-18
C926 0 N 1.3439599999999999e-19
C927 0 P 1.0676200000000001e-19
C934 0 N 2.0270100000000002e-18
C935 0 P 1.8699700000000002e-17
C942 0 N 2.4191200000000001e-19
C943 0 P 1.9217200000000002e-19
C950 0 N 2.0270100000000002e-18
C951 0 P 1.8699700000000002e-17
C964 0 N 4.2083100000000004e-19
C965 0 P 4.5087200000000008e-18
C980 0 N 2.6879100000000003e-19
C981 0 P 2.1352400000000002e-19
C987 0 N 2.0270100000000002e-18
C988 0 P 1.8699700000000002e-17
C995 0 N 2.6879100000000003e-19
C996 0 P 2.1352400000000002e-19
C1004 0 N 2.0270100000000002e-18
C1005 0 P 1.8699700000000002e-17
C1015 0 N 4.4298000000000001e-19
C1016 0 P 4.5367200000000002e-18
C1032 0 N 1.3977200000000001e-19
C1033 0 P 1.11032e-19
C1043 0 N 2.6879100000000003e-19
C1044 0 P 2.1352400000000002e-19
C1049 0 N 2.0270100000000002e-18
C1050 0 P 1.8699700000000002e-17
C1055 0 N 2.6879100000000003e-19
C1056 0 P 2.1352400000000002e-19
C1061 0 N 2.2149000000000001e-19
C1062 0 P 2.8003500000000001e-19
C1071 0 N 2.0270100000000002e-18
C1072 0 P 1.8699700000000002e-17
C1077 0 P 7.9368600000000002e-17
C1084 0 P 7.9368600000000002e-17
C1097 0 P 7.9368600000000002e-17
C1100 0 P 4.1271700000000005e-17
C1107 0 P 3.5888400000000002e-18
C1112 0 P 7.9368600000000002e-17
C1117 0 P 7.9368600000000002e-17
C1126 0 P 7.9368600000000002e-17
C1169 N P 3.4877500000000003e-15
C1170 N 0 5.8416800000000005e-17
C1171 P 0 2.0760400000000003e-16
VP P 0 DC 0 AC 0
VN N 0 DC 0 AC 1
.control
set numdgt=17
ac lin 1 1Meg 1Meg
let cp = -imag(i(VP))/(2*pi*1e6)
let cn = -imag(i(VN))/(2*pi*1e6)
print cp cn
quit
.endc
.end
