* cell sense_fill_clip
.SUBCKT sense_fill_clip
* net 2 CTX_L30_1,CTX_L50_0,CTX_L67_0
* net 3 CTX_L8_39
* net 4 CTX_L10_0,CTX_L10_1,CTX_L10_2,CTX_L30_0,CTX_L30_2,CTX_L50_13,CTX_L8_4
* net 5 CTX_L10_3,CTX_L8_0,CTX_L8_5
* net 6 CTX_L10_5,CTX_L8_1,CTX_L8_9
* net 7 CTX_L10_4,CTX_L8_2,CTX_L8_6
* net 8 CTX_L10_6,CTX_L8_10,CTX_L8_3
* net 9 CTX_L10_11,CTX_L10_16,CTX_L10_17,CTX_L10_7,CTX_L30_12,CTX_L30_3,CTX_L8_13,CTX_L8_22,CTX_L8_23,CTX_L8_29,CTX_L8_7
* net 10 CTX_L10_18,CTX_L10_34,CTX_L10_8,CTX_L30_4,CTX_L30_9,CTX_L8_15,CTX_L8_24,CTX_L8_33,CTX_L8_8
* net 11 CTX_L10_13,CTX_L10_20,CTX_L10_21,CTX_L10_9,CTX_L30_13,CTX_L30_5,CTX_L8_11,CTX_L8_17,CTX_L8_26,CTX_L8_27,CTX_L8_31
* net 12 CTX_L10_10,CTX_L10_22,CTX_L10_36,CTX_L30_11,CTX_L30_6,CTX_L8_12,CTX_L8_19,CTX_L8_28,CTX_L8_35
* net 13 CTX_L30_7
* net 14 CTX_L10_12,CTX_L10_15,CTX_L30_8,CTX_L8_14,CTX_L8_21,CTX_L8_30
* net 15 CTX_L10_35,CTX_L8_16,CTX_L8_34
* net 16 CTX_L10_14,CTX_L10_19,CTX_L30_10,CTX_L8_18,CTX_L8_25,CTX_L8_32
* net 17 CTX_L10_37,CTX_L8_20,CTX_L8_36
* net 18 CTX_L126_0
* net 19 CTX_L50_1
* net 20 CTX_L10_31
* net 21 CTX_L50_2
* net 22 CTX_L50_3
* net 23 CTX_L10_32
* net 24 CTX_L50_4
* net 25 CTX_L50_5
* net 26 CTX_L50_6
* net 27 CTX_L50_7
* net 28 CTX_L50_8
* net 29 CTX_L50_9
* net 30 CTX_L50_10
* net 31 CTX_L8_38
* net 32 N
* net 33 P
* net 34 CTX_L126_1
* net 35 CTX_L10_33
* net 36 CTX_L10_23,CTX_L10_24,CTX_L10_25,CTX_L10_26,CTX_L10_27,CTX_L10_28,CTX_L10_29,CTX_L10_30,CTX_L30_14,CTX_L8_37
* net 37 CTX_L30_16
* net 38 CTX_L30_25
* net 39 CTX_L30_18
* net 40 CTX_L30_17
* net 41 CTX_L30_19
* net 42 CTX_L30_24
* net 43 CTX_L30_23
* net 44 CTX_L30_20
* net 45 CTX_L30_22
* net 46 CTX_L30_21
* net 47 CTX_L30_15
.ENDS sense_fill_clip
