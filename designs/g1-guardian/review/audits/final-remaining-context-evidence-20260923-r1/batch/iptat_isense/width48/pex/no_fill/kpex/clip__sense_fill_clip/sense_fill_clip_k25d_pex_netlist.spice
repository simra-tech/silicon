*********************************************************
*** NGSPICE file created by KLayout-PEX 0.3.12
*** -----------------------------------------------------
***     Extraction Engine: KPEX/2.5D
***     Technology: ihp_sg13g2
***     Date: 2026-09-23 06:32:56
*********************************************************

.SUBCKT sense_fill_clip
Cext_1 CTX_L10_0|CTX_L10_1|CTX_L10_2|CTX_L30_0|CTX_L30_2|CTX_L50_13|CTX_L8_4
+ CTX_L10_10|CTX_L10_22|CTX_L10_36|CTX_L30_11|CTX_L30_6|CTX_L8_12|CTX_L8_19|CTX_L8_28|CTX_L8_35
+ 81.3157a
Cext_2 CTX_L10_0|CTX_L10_1|CTX_L10_2|CTX_L30_0|CTX_L30_2|CTX_L50_13|CTX_L8_4
+ CTX_L10_11|CTX_L10_16|CTX_L10_17|CTX_L10_7|CTX_L30_12|CTX_L30_3|CTX_L8_13|CTX_L8_22|CTX_L8_23|CTX_L8_29|CTX_L8_7
+ 178.427a
Cext_3 CTX_L10_0|CTX_L10_1|CTX_L10_2|CTX_L30_0|CTX_L30_2|CTX_L50_13|CTX_L8_4
+ CTX_L10_12|CTX_L10_15|CTX_L30_8|CTX_L8_14|CTX_L8_21|CTX_L8_30 7.56641a
Cext_4 CTX_L10_0|CTX_L10_1|CTX_L10_2|CTX_L30_0|CTX_L30_2|CTX_L50_13|CTX_L8_4
+ CTX_L10_13|CTX_L10_20|CTX_L10_21|CTX_L10_9|CTX_L30_13|CTX_L30_5|CTX_L8_11|CTX_L8_17|CTX_L8_26|CTX_L8_27|CTX_L8_31
+ 175.668a
Cext_5 CTX_L10_0|CTX_L10_1|CTX_L10_2|CTX_L30_0|CTX_L30_2|CTX_L50_13|CTX_L8_4
+ CTX_L10_14|CTX_L10_19|CTX_L30_10|CTX_L8_18|CTX_L8_25|CTX_L8_32 6.21284a
Cext_6 CTX_L10_0|CTX_L10_1|CTX_L10_2|CTX_L30_0|CTX_L30_2|CTX_L50_13|CTX_L8_4
+ CTX_L10_18|CTX_L10_34|CTX_L10_8|CTX_L30_4|CTX_L30_9|CTX_L8_15|CTX_L8_24|CTX_L8_33|CTX_L8_8
+ 81.3157a
Cext_7 CTX_L10_0|CTX_L10_1|CTX_L10_2|CTX_L30_0|CTX_L30_2|CTX_L50_13|CTX_L8_4
+ CTX_L10_23|CTX_L10_24|CTX_L10_25|CTX_L10_26|CTX_L10_27|CTX_L10_28|CTX_L10_29|CTX_L10_30|CTX_L30_14|CTX_L8_37
+ 74.0935a
Cext_8 CTX_L10_0|CTX_L10_1|CTX_L10_2|CTX_L30_0|CTX_L30_2|CTX_L50_13|CTX_L8_4
+ CTX_L10_3|CTX_L8_0|CTX_L8_5 137.371a
Cext_9 CTX_L10_0|CTX_L10_1|CTX_L10_2|CTX_L30_0|CTX_L30_2|CTX_L50_13|CTX_L8_4
+ CTX_L10_33 280.787a
Cext_10 CTX_L10_0|CTX_L10_1|CTX_L10_2|CTX_L30_0|CTX_L30_2|CTX_L50_13|CTX_L8_4
+ CTX_L10_35|CTX_L8_16|CTX_L8_34 3.8475a
Cext_11 CTX_L10_0|CTX_L10_1|CTX_L10_2|CTX_L30_0|CTX_L30_2|CTX_L50_13|CTX_L8_4
+ CTX_L10_37|CTX_L8_20|CTX_L8_36 3.8475a
Cext_12 CTX_L10_0|CTX_L10_1|CTX_L10_2|CTX_L30_0|CTX_L30_2|CTX_L50_13|CTX_L8_4
+ CTX_L10_4|CTX_L8_2|CTX_L8_6 593.069a
Cext_13 CTX_L10_0|CTX_L10_1|CTX_L10_2|CTX_L30_0|CTX_L30_2|CTX_L50_13|CTX_L8_4
+ CTX_L10_5|CTX_L8_1|CTX_L8_9 145.079a
Cext_14 CTX_L10_0|CTX_L10_1|CTX_L10_2|CTX_L30_0|CTX_L30_2|CTX_L50_13|CTX_L8_4
+ CTX_L10_6|CTX_L8_10|CTX_L8_3 603.819a
Cext_15 CTX_L10_0|CTX_L10_1|CTX_L10_2|CTX_L30_0|CTX_L30_2|CTX_L50_13|CTX_L8_4
+ CTX_L126_1 624.229a
Cext_16 CTX_L10_0|CTX_L10_1|CTX_L10_2|CTX_L30_0|CTX_L30_2|CTX_L50_13|CTX_L8_4
+ CTX_L50_10 0.249218a
Cext_17 CTX_L10_0|CTX_L10_1|CTX_L10_2|CTX_L30_0|CTX_L30_2|CTX_L50_13|CTX_L8_4
+ CTX_L8_38 0.73738a
Cext_18 CTX_L10_0|CTX_L10_1|CTX_L10_2|CTX_L30_0|CTX_L30_2|CTX_L50_13|CTX_L8_4
+ CTX_L8_39 2.48248f
Cext_19 CTX_L10_0|CTX_L10_1|CTX_L10_2|CTX_L30_0|CTX_L30_2|CTX_L50_13|CTX_L8_4 N
+ 0.466823a
Cext_20 CTX_L10_0|CTX_L10_1|CTX_L10_2|CTX_L30_0|CTX_L30_2|CTX_L50_13|CTX_L8_4 P
+ 213.647a
Cext_21 CTX_L10_0|CTX_L10_1|CTX_L10_2|CTX_L30_0|CTX_L30_2|CTX_L50_13|CTX_L8_4
+ VSUBS 3.55748f
Cext_22
+ CTX_L10_10|CTX_L10_22|CTX_L10_36|CTX_L30_11|CTX_L30_6|CTX_L8_12|CTX_L8_19|CTX_L8_28|CTX_L8_35
+ CTX_L10_13|CTX_L10_20|CTX_L10_21|CTX_L10_9|CTX_L30_13|CTX_L30_5|CTX_L8_11|CTX_L8_17|CTX_L8_26|CTX_L8_27|CTX_L8_31
+ 331.596a
Cext_23
+ CTX_L10_10|CTX_L10_22|CTX_L10_36|CTX_L30_11|CTX_L30_6|CTX_L8_12|CTX_L8_19|CTX_L8_28|CTX_L8_35
+ CTX_L10_14|CTX_L10_19|CTX_L30_10|CTX_L8_18|CTX_L8_25|CTX_L8_32 68.2272a
Cext_24
+ CTX_L10_10|CTX_L10_22|CTX_L10_36|CTX_L30_11|CTX_L30_6|CTX_L8_12|CTX_L8_19|CTX_L8_28|CTX_L8_35
+ CTX_L10_23|CTX_L10_24|CTX_L10_25|CTX_L10_26|CTX_L10_27|CTX_L10_28|CTX_L10_29|CTX_L10_30|CTX_L30_14|CTX_L8_37
+ 1.25349f
Cext_25
+ CTX_L10_10|CTX_L10_22|CTX_L10_36|CTX_L30_11|CTX_L30_6|CTX_L8_12|CTX_L8_19|CTX_L8_28|CTX_L8_35
+ CTX_L10_35|CTX_L8_16|CTX_L8_34 81.2252a
Cext_26
+ CTX_L10_10|CTX_L10_22|CTX_L10_36|CTX_L30_11|CTX_L30_6|CTX_L8_12|CTX_L8_19|CTX_L8_28|CTX_L8_35
+ CTX_L10_37|CTX_L8_20|CTX_L8_36 632.053a
Cext_27
+ CTX_L10_10|CTX_L10_22|CTX_L10_36|CTX_L30_11|CTX_L30_6|CTX_L8_12|CTX_L8_19|CTX_L8_28|CTX_L8_35
+ CTX_L30_15 28.1237a
Cext_28
+ CTX_L10_10|CTX_L10_22|CTX_L10_36|CTX_L30_11|CTX_L30_6|CTX_L8_12|CTX_L8_19|CTX_L8_28|CTX_L8_35
+ CTX_L30_16 24.0711a
Cext_29
+ CTX_L10_10|CTX_L10_22|CTX_L10_36|CTX_L30_11|CTX_L30_6|CTX_L8_12|CTX_L8_19|CTX_L8_28|CTX_L8_35
+ CTX_L30_17 24.0711a
Cext_30
+ CTX_L10_10|CTX_L10_22|CTX_L10_36|CTX_L30_11|CTX_L30_6|CTX_L8_12|CTX_L8_19|CTX_L8_28|CTX_L8_35
+ CTX_L30_18 24.0711a
Cext_31
+ CTX_L10_10|CTX_L10_22|CTX_L10_36|CTX_L30_11|CTX_L30_6|CTX_L8_12|CTX_L8_19|CTX_L8_28|CTX_L8_35
+ CTX_L30_19 24.0711a
Cext_32
+ CTX_L10_10|CTX_L10_22|CTX_L10_36|CTX_L30_11|CTX_L30_6|CTX_L8_12|CTX_L8_19|CTX_L8_28|CTX_L8_35
+ CTX_L30_20 24.0711a
Cext_33
+ CTX_L10_10|CTX_L10_22|CTX_L10_36|CTX_L30_11|CTX_L30_6|CTX_L8_12|CTX_L8_19|CTX_L8_28|CTX_L8_35
+ CTX_L30_21 24.0711a
Cext_34
+ CTX_L10_10|CTX_L10_22|CTX_L10_36|CTX_L30_11|CTX_L30_6|CTX_L8_12|CTX_L8_19|CTX_L8_28|CTX_L8_35
+ CTX_L30_22 24.0711a
Cext_35
+ CTX_L10_10|CTX_L10_22|CTX_L10_36|CTX_L30_11|CTX_L30_6|CTX_L8_12|CTX_L8_19|CTX_L8_28|CTX_L8_35
+ CTX_L30_23 24.0711a
Cext_36
+ CTX_L10_10|CTX_L10_22|CTX_L10_36|CTX_L30_11|CTX_L30_6|CTX_L8_12|CTX_L8_19|CTX_L8_28|CTX_L8_35
+ CTX_L30_24 24.0711a
Cext_37
+ CTX_L10_10|CTX_L10_22|CTX_L10_36|CTX_L30_11|CTX_L30_6|CTX_L8_12|CTX_L8_19|CTX_L8_28|CTX_L8_35
+ CTX_L30_25 5.81513a
Cext_38
+ CTX_L10_10|CTX_L10_22|CTX_L10_36|CTX_L30_11|CTX_L30_6|CTX_L8_12|CTX_L8_19|CTX_L8_28|CTX_L8_35
+ CTX_L8_39 362.154a
Cext_39
+ CTX_L10_10|CTX_L10_22|CTX_L10_36|CTX_L30_11|CTX_L30_6|CTX_L8_12|CTX_L8_19|CTX_L8_28|CTX_L8_35
+ VSUBS 1.04f
Cext_40
+ CTX_L10_11|CTX_L10_16|CTX_L10_17|CTX_L10_7|CTX_L30_12|CTX_L30_3|CTX_L8_13|CTX_L8_22|CTX_L8_23|CTX_L8_29|CTX_L8_7
+ CTX_L10_12|CTX_L10_15|CTX_L30_8|CTX_L8_14|CTX_L8_21|CTX_L8_30 852.99a
Cext_41
+ CTX_L10_11|CTX_L10_16|CTX_L10_17|CTX_L10_7|CTX_L30_12|CTX_L30_3|CTX_L8_13|CTX_L8_22|CTX_L8_23|CTX_L8_29|CTX_L8_7
+ CTX_L10_13|CTX_L10_20|CTX_L10_21|CTX_L10_9|CTX_L30_13|CTX_L30_5|CTX_L8_11|CTX_L8_17|CTX_L8_26|CTX_L8_27|CTX_L8_31
+ 2.13277a
Cext_42
+ CTX_L10_11|CTX_L10_16|CTX_L10_17|CTX_L10_7|CTX_L30_12|CTX_L30_3|CTX_L8_13|CTX_L8_22|CTX_L8_23|CTX_L8_29|CTX_L8_7
+ CTX_L10_18|CTX_L10_34|CTX_L10_8|CTX_L30_4|CTX_L30_9|CTX_L8_15|CTX_L8_24|CTX_L8_33|CTX_L8_8
+ 331.596a
Cext_43
+ CTX_L10_11|CTX_L10_16|CTX_L10_17|CTX_L10_7|CTX_L30_12|CTX_L30_3|CTX_L8_13|CTX_L8_22|CTX_L8_23|CTX_L8_29|CTX_L8_7
+ CTX_L10_23|CTX_L10_24|CTX_L10_25|CTX_L10_26|CTX_L10_27|CTX_L10_28|CTX_L10_29|CTX_L10_30|CTX_L30_14|CTX_L8_37
+ 138.67a
Cext_44
+ CTX_L10_11|CTX_L10_16|CTX_L10_17|CTX_L10_7|CTX_L30_12|CTX_L30_3|CTX_L8_13|CTX_L8_22|CTX_L8_23|CTX_L8_29|CTX_L8_7
+ CTX_L10_3|CTX_L8_0|CTX_L8_5 63.4299a
Cext_45
+ CTX_L10_11|CTX_L10_16|CTX_L10_17|CTX_L10_7|CTX_L30_12|CTX_L30_3|CTX_L8_13|CTX_L8_22|CTX_L8_23|CTX_L8_29|CTX_L8_7
+ CTX_L10_33 36.1219a
Cext_46
+ CTX_L10_11|CTX_L10_16|CTX_L10_17|CTX_L10_7|CTX_L30_12|CTX_L30_3|CTX_L8_13|CTX_L8_22|CTX_L8_23|CTX_L8_29|CTX_L8_7
+ CTX_L10_35|CTX_L8_16|CTX_L8_34 0.237316a
Cext_47
+ CTX_L10_11|CTX_L10_16|CTX_L10_17|CTX_L10_7|CTX_L30_12|CTX_L30_3|CTX_L8_13|CTX_L8_22|CTX_L8_23|CTX_L8_29|CTX_L8_7
+ CTX_L10_4|CTX_L8_2|CTX_L8_6 115.077a
Cext_48
+ CTX_L10_11|CTX_L10_16|CTX_L10_17|CTX_L10_7|CTX_L30_12|CTX_L30_3|CTX_L8_13|CTX_L8_22|CTX_L8_23|CTX_L8_29|CTX_L8_7
+ CTX_L126_1 0.685345a
Cext_49
+ CTX_L10_11|CTX_L10_16|CTX_L10_17|CTX_L10_7|CTX_L30_12|CTX_L30_3|CTX_L8_13|CTX_L8_22|CTX_L8_23|CTX_L8_29|CTX_L8_7
+ CTX_L8_39 380.058a
Cext_50
+ CTX_L10_11|CTX_L10_16|CTX_L10_17|CTX_L10_7|CTX_L30_12|CTX_L30_3|CTX_L8_13|CTX_L8_22|CTX_L8_23|CTX_L8_29|CTX_L8_7
+ VSUBS 578.824a
Cext_51 CTX_L10_12|CTX_L10_15|CTX_L30_8|CTX_L8_14|CTX_L8_21|CTX_L8_30
+ CTX_L10_18|CTX_L10_34|CTX_L10_8|CTX_L30_4|CTX_L30_9|CTX_L8_15|CTX_L8_24|CTX_L8_33|CTX_L8_8
+ 68.2272a
Cext_52 CTX_L10_12|CTX_L10_15|CTX_L30_8|CTX_L8_14|CTX_L8_21|CTX_L8_30
+ CTX_L10_23|CTX_L10_24|CTX_L10_25|CTX_L10_26|CTX_L10_27|CTX_L10_28|CTX_L10_29|CTX_L10_30|CTX_L30_14|CTX_L8_37
+ 68.1346a
Cext_53 CTX_L10_12|CTX_L10_15|CTX_L30_8|CTX_L8_14|CTX_L8_21|CTX_L8_30
+ CTX_L10_3|CTX_L8_0|CTX_L8_5 6.83304a
Cext_54 CTX_L10_12|CTX_L10_15|CTX_L30_8|CTX_L8_14|CTX_L8_21|CTX_L8_30
+ CTX_L10_33 19.6222a
Cext_55 CTX_L10_12|CTX_L10_15|CTX_L30_8|CTX_L8_14|CTX_L8_21|CTX_L8_30
+ CTX_L10_4|CTX_L8_2|CTX_L8_6 0.244628a
Cext_56 CTX_L10_12|CTX_L10_15|CTX_L30_8|CTX_L8_14|CTX_L8_21|CTX_L8_30
+ CTX_L126_1 1.12344a
Cext_57 CTX_L10_12|CTX_L10_15|CTX_L30_8|CTX_L8_14|CTX_L8_21|CTX_L8_30 CTX_L8_39
+ 219.457a
Cext_58 CTX_L10_12|CTX_L10_15|CTX_L30_8|CTX_L8_14|CTX_L8_21|CTX_L8_30 VSUBS
+ 336.545a
Cext_59
+ CTX_L10_13|CTX_L10_20|CTX_L10_21|CTX_L10_9|CTX_L30_13|CTX_L30_5|CTX_L8_11|CTX_L8_17|CTX_L8_26|CTX_L8_27|CTX_L8_31
+ CTX_L10_14|CTX_L10_19|CTX_L30_10|CTX_L8_18|CTX_L8_25|CTX_L8_32 852.99a
Cext_60
+ CTX_L10_13|CTX_L10_20|CTX_L10_21|CTX_L10_9|CTX_L30_13|CTX_L30_5|CTX_L8_11|CTX_L8_17|CTX_L8_26|CTX_L8_27|CTX_L8_31
+ CTX_L10_18|CTX_L10_34|CTX_L10_8|CTX_L30_4|CTX_L30_9|CTX_L8_15|CTX_L8_24|CTX_L8_33|CTX_L8_8
+ 29.2556a
Cext_61
+ CTX_L10_13|CTX_L10_20|CTX_L10_21|CTX_L10_9|CTX_L30_13|CTX_L30_5|CTX_L8_11|CTX_L8_17|CTX_L8_26|CTX_L8_27|CTX_L8_31
+ CTX_L10_23|CTX_L10_24|CTX_L10_25|CTX_L10_26|CTX_L10_27|CTX_L10_28|CTX_L10_29|CTX_L10_30|CTX_L30_14|CTX_L8_37
+ 138.67a
Cext_62
+ CTX_L10_13|CTX_L10_20|CTX_L10_21|CTX_L10_9|CTX_L30_13|CTX_L30_5|CTX_L8_11|CTX_L8_17|CTX_L8_26|CTX_L8_27|CTX_L8_31
+ CTX_L10_35|CTX_L8_16|CTX_L8_34 23.2501a
Cext_63
+ CTX_L10_13|CTX_L10_20|CTX_L10_21|CTX_L10_9|CTX_L30_13|CTX_L30_5|CTX_L8_11|CTX_L8_17|CTX_L8_26|CTX_L8_27|CTX_L8_31
+ CTX_L10_37|CTX_L8_20|CTX_L8_36 0.237316a
Cext_64
+ CTX_L10_13|CTX_L10_20|CTX_L10_21|CTX_L10_9|CTX_L30_13|CTX_L30_5|CTX_L8_11|CTX_L8_17|CTX_L8_26|CTX_L8_27|CTX_L8_31
+ CTX_L10_5|CTX_L8_1|CTX_L8_9 63.4299a
Cext_65
+ CTX_L10_13|CTX_L10_20|CTX_L10_21|CTX_L10_9|CTX_L30_13|CTX_L30_5|CTX_L8_11|CTX_L8_17|CTX_L8_26|CTX_L8_27|CTX_L8_31
+ CTX_L10_6|CTX_L8_10|CTX_L8_3 115.077a
Cext_66
+ CTX_L10_13|CTX_L10_20|CTX_L10_21|CTX_L10_9|CTX_L30_13|CTX_L30_5|CTX_L8_11|CTX_L8_17|CTX_L8_26|CTX_L8_27|CTX_L8_31
+ CTX_L8_39 380.691a
Cext_67
+ CTX_L10_13|CTX_L10_20|CTX_L10_21|CTX_L10_9|CTX_L30_13|CTX_L30_5|CTX_L8_11|CTX_L8_17|CTX_L8_26|CTX_L8_27|CTX_L8_31
+ VSUBS 563.056a
Cext_68 CTX_L10_14|CTX_L10_19|CTX_L30_10|CTX_L8_18|CTX_L8_25|CTX_L8_32
+ CTX_L10_18|CTX_L10_34|CTX_L10_8|CTX_L30_4|CTX_L30_9|CTX_L8_15|CTX_L8_24|CTX_L8_33|CTX_L8_8
+ 4.19627a
Cext_69 CTX_L10_14|CTX_L10_19|CTX_L30_10|CTX_L8_18|CTX_L8_25|CTX_L8_32
+ CTX_L10_23|CTX_L10_24|CTX_L10_25|CTX_L10_26|CTX_L10_27|CTX_L10_28|CTX_L10_29|CTX_L10_30|CTX_L30_14|CTX_L8_37
+ 68.1346a
Cext_70 CTX_L10_14|CTX_L10_19|CTX_L30_10|CTX_L8_18|CTX_L8_25|CTX_L8_32
+ CTX_L10_35|CTX_L8_16|CTX_L8_34 36.6756a
Cext_71 CTX_L10_14|CTX_L10_19|CTX_L30_10|CTX_L8_18|CTX_L8_25|CTX_L8_32
+ CTX_L10_5|CTX_L8_1|CTX_L8_9 6.83304a
Cext_72 CTX_L10_14|CTX_L10_19|CTX_L30_10|CTX_L8_18|CTX_L8_25|CTX_L8_32
+ CTX_L10_6|CTX_L8_10|CTX_L8_3 0.244628a
Cext_73 CTX_L10_14|CTX_L10_19|CTX_L30_10|CTX_L8_18|CTX_L8_25|CTX_L8_32
+ CTX_L8_39 219.457a
Cext_74 CTX_L10_14|CTX_L10_19|CTX_L30_10|CTX_L8_18|CTX_L8_25|CTX_L8_32 VSUBS
+ 320.294a
Cext_75
+ CTX_L10_18|CTX_L10_34|CTX_L10_8|CTX_L30_4|CTX_L30_9|CTX_L8_15|CTX_L8_24|CTX_L8_33|CTX_L8_8
+ CTX_L10_23|CTX_L10_24|CTX_L10_25|CTX_L10_26|CTX_L10_27|CTX_L10_28|CTX_L10_29|CTX_L10_30|CTX_L30_14|CTX_L8_37
+ 1.25468f
Cext_76
+ CTX_L10_18|CTX_L10_34|CTX_L10_8|CTX_L30_4|CTX_L30_9|CTX_L8_15|CTX_L8_24|CTX_L8_33|CTX_L8_8
+ CTX_L10_33 68.26a
Cext_77
+ CTX_L10_18|CTX_L10_34|CTX_L10_8|CTX_L30_4|CTX_L30_9|CTX_L8_15|CTX_L8_24|CTX_L8_33|CTX_L8_8
+ CTX_L10_35|CTX_L8_16|CTX_L8_34 632.053a
Cext_78
+ CTX_L10_18|CTX_L10_34|CTX_L10_8|CTX_L30_4|CTX_L30_9|CTX_L8_15|CTX_L8_24|CTX_L8_33|CTX_L8_8
+ CTX_L10_5|CTX_L8_1|CTX_L8_9 8.63073a
Cext_79
+ CTX_L10_18|CTX_L10_34|CTX_L10_8|CTX_L30_4|CTX_L30_9|CTX_L8_15|CTX_L8_24|CTX_L8_33|CTX_L8_8
+ CTX_L30_15 22.3828a
Cext_80
+ CTX_L10_18|CTX_L10_34|CTX_L10_8|CTX_L30_4|CTX_L30_9|CTX_L8_15|CTX_L8_24|CTX_L8_33|CTX_L8_8
+ CTX_L30_16 18.3302a
Cext_81
+ CTX_L10_18|CTX_L10_34|CTX_L10_8|CTX_L30_4|CTX_L30_9|CTX_L8_15|CTX_L8_24|CTX_L8_33|CTX_L8_8
+ CTX_L30_17 18.3302a
Cext_82
+ CTX_L10_18|CTX_L10_34|CTX_L10_8|CTX_L30_4|CTX_L30_9|CTX_L8_15|CTX_L8_24|CTX_L8_33|CTX_L8_8
+ CTX_L30_18 18.3302a
Cext_83
+ CTX_L10_18|CTX_L10_34|CTX_L10_8|CTX_L30_4|CTX_L30_9|CTX_L8_15|CTX_L8_24|CTX_L8_33|CTX_L8_8
+ CTX_L30_19 18.3302a
Cext_84
+ CTX_L10_18|CTX_L10_34|CTX_L10_8|CTX_L30_4|CTX_L30_9|CTX_L8_15|CTX_L8_24|CTX_L8_33|CTX_L8_8
+ CTX_L30_20 18.3302a
Cext_85
+ CTX_L10_18|CTX_L10_34|CTX_L10_8|CTX_L30_4|CTX_L30_9|CTX_L8_15|CTX_L8_24|CTX_L8_33|CTX_L8_8
+ CTX_L30_21 18.3302a
Cext_86
+ CTX_L10_18|CTX_L10_34|CTX_L10_8|CTX_L30_4|CTX_L30_9|CTX_L8_15|CTX_L8_24|CTX_L8_33|CTX_L8_8
+ CTX_L30_22 18.3302a
Cext_87
+ CTX_L10_18|CTX_L10_34|CTX_L10_8|CTX_L30_4|CTX_L30_9|CTX_L8_15|CTX_L8_24|CTX_L8_33|CTX_L8_8
+ CTX_L30_23 18.3302a
Cext_88
+ CTX_L10_18|CTX_L10_34|CTX_L10_8|CTX_L30_4|CTX_L30_9|CTX_L8_15|CTX_L8_24|CTX_L8_33|CTX_L8_8
+ CTX_L30_24 18.3302a
Cext_89
+ CTX_L10_18|CTX_L10_34|CTX_L10_8|CTX_L30_4|CTX_L30_9|CTX_L8_15|CTX_L8_24|CTX_L8_33|CTX_L8_8
+ CTX_L30_25 4.85832a
Cext_90
+ CTX_L10_18|CTX_L10_34|CTX_L10_8|CTX_L30_4|CTX_L30_9|CTX_L8_15|CTX_L8_24|CTX_L8_33|CTX_L8_8
+ CTX_L8_39 368.895a
Cext_91
+ CTX_L10_18|CTX_L10_34|CTX_L10_8|CTX_L30_4|CTX_L30_9|CTX_L8_15|CTX_L8_24|CTX_L8_33|CTX_L8_8
+ VSUBS 1.01772f
Cext_92
+ CTX_L10_23|CTX_L10_24|CTX_L10_25|CTX_L10_26|CTX_L10_27|CTX_L10_28|CTX_L10_29|CTX_L10_30|CTX_L30_14|CTX_L8_37
+ CTX_L10_33 174.388a
Cext_93
+ CTX_L10_23|CTX_L10_24|CTX_L10_25|CTX_L10_26|CTX_L10_27|CTX_L10_28|CTX_L10_29|CTX_L10_30|CTX_L30_14|CTX_L8_37
+ CTX_L10_35|CTX_L8_16|CTX_L8_34 858.134a
Cext_94
+ CTX_L10_23|CTX_L10_24|CTX_L10_25|CTX_L10_26|CTX_L10_27|CTX_L10_28|CTX_L10_29|CTX_L10_30|CTX_L30_14|CTX_L8_37
+ CTX_L10_37|CTX_L8_20|CTX_L8_36 569.7a
Cext_95
+ CTX_L10_23|CTX_L10_24|CTX_L10_25|CTX_L10_26|CTX_L10_27|CTX_L10_28|CTX_L10_29|CTX_L10_30|CTX_L30_14|CTX_L8_37
+ CTX_L10_4|CTX_L8_2|CTX_L8_6 2.05805a
Cext_96
+ CTX_L10_23|CTX_L10_24|CTX_L10_25|CTX_L10_26|CTX_L10_27|CTX_L10_28|CTX_L10_29|CTX_L10_30|CTX_L30_14|CTX_L8_37
+ CTX_L10_6|CTX_L8_10|CTX_L8_3 2.05805a
Cext_97
+ CTX_L10_23|CTX_L10_24|CTX_L10_25|CTX_L10_26|CTX_L10_27|CTX_L10_28|CTX_L10_29|CTX_L10_30|CTX_L30_14|CTX_L8_37
+ CTX_L126_1 54.1375a
Cext_98
+ CTX_L10_23|CTX_L10_24|CTX_L10_25|CTX_L10_26|CTX_L10_27|CTX_L10_28|CTX_L10_29|CTX_L10_30|CTX_L30_14|CTX_L8_37
+ CTX_L30_15 461.16a
Cext_99
+ CTX_L10_23|CTX_L10_24|CTX_L10_25|CTX_L10_26|CTX_L10_27|CTX_L10_28|CTX_L10_29|CTX_L10_30|CTX_L30_14|CTX_L8_37
+ CTX_L30_16 8.34814a
Cext_100
+ CTX_L10_23|CTX_L10_24|CTX_L10_25|CTX_L10_26|CTX_L10_27|CTX_L10_28|CTX_L10_29|CTX_L10_30|CTX_L30_14|CTX_L8_37
+ CTX_L30_17 6.1068a
Cext_101
+ CTX_L10_23|CTX_L10_24|CTX_L10_25|CTX_L10_26|CTX_L10_27|CTX_L10_28|CTX_L10_29|CTX_L10_30|CTX_L30_14|CTX_L8_37
+ CTX_L30_18 4.85673a
Cext_102
+ CTX_L10_23|CTX_L10_24|CTX_L10_25|CTX_L10_26|CTX_L10_27|CTX_L10_28|CTX_L10_29|CTX_L10_30|CTX_L30_14|CTX_L8_37
+ CTX_L30_19 3.89615a
Cext_103
+ CTX_L10_23|CTX_L10_24|CTX_L10_25|CTX_L10_26|CTX_L10_27|CTX_L10_28|CTX_L10_29|CTX_L10_30|CTX_L30_14|CTX_L8_37
+ CTX_L30_20 3.16414a
Cext_104
+ CTX_L10_23|CTX_L10_24|CTX_L10_25|CTX_L10_26|CTX_L10_27|CTX_L10_28|CTX_L10_29|CTX_L10_30|CTX_L30_14|CTX_L8_37
+ CTX_L30_21 2.52054a
Cext_105
+ CTX_L10_23|CTX_L10_24|CTX_L10_25|CTX_L10_26|CTX_L10_27|CTX_L10_28|CTX_L10_29|CTX_L10_30|CTX_L30_14|CTX_L8_37
+ CTX_L30_22 2.00352a
Cext_106
+ CTX_L10_23|CTX_L10_24|CTX_L10_25|CTX_L10_26|CTX_L10_27|CTX_L10_28|CTX_L10_29|CTX_L10_30|CTX_L30_14|CTX_L8_37
+ CTX_L30_23 1.69075a
Cext_107
+ CTX_L10_23|CTX_L10_24|CTX_L10_25|CTX_L10_26|CTX_L10_27|CTX_L10_28|CTX_L10_29|CTX_L10_30|CTX_L30_14|CTX_L8_37
+ CTX_L30_24 1.44276a
Cext_108
+ CTX_L10_23|CTX_L10_24|CTX_L10_25|CTX_L10_26|CTX_L10_27|CTX_L10_28|CTX_L10_29|CTX_L10_30|CTX_L30_14|CTX_L8_37
+ CTX_L30_25 0.144208a
Cext_109
+ CTX_L10_23|CTX_L10_24|CTX_L10_25|CTX_L10_26|CTX_L10_27|CTX_L10_28|CTX_L10_29|CTX_L10_30|CTX_L30_14|CTX_L8_37
+ CTX_L8_39 41.5923a
Cext_110
+ CTX_L10_23|CTX_L10_24|CTX_L10_25|CTX_L10_26|CTX_L10_27|CTX_L10_28|CTX_L10_29|CTX_L10_30|CTX_L30_14|CTX_L8_37
+ VSUBS 4.30457f
Cext_111 CTX_L10_3|CTX_L8_0|CTX_L8_5 CTX_L10_33 75.8273a
Cext_112 CTX_L10_3|CTX_L8_0|CTX_L8_5 CTX_L10_4|CTX_L8_2|CTX_L8_6 143.324a
Cext_113 CTX_L10_3|CTX_L8_0|CTX_L8_5 CTX_L10_5|CTX_L8_1|CTX_L8_9 16.022a
Cext_114 CTX_L10_3|CTX_L8_0|CTX_L8_5 CTX_L126_1 2.04602a
Cext_115 CTX_L10_3|CTX_L8_0|CTX_L8_5 CTX_L8_39 274.618a
Cext_116 CTX_L10_3|CTX_L8_0|CTX_L8_5 VSUBS 240.188a
Cext_117 CTX_L10_31 CTX_L10_32 179.466a
Cext_118 CTX_L10_31 CTX_L126_0 103.214a
Cext_119 CTX_L10_31 CTX_L30_1|CTX_L50_0|CTX_L67_0 85.936a
Cext_120 CTX_L10_31 CTX_L30_7 1.97698a
Cext_121 CTX_L10_31 CTX_L50_1 92.488a
Cext_122 CTX_L10_31 CTX_L50_2 30.6383a
Cext_123 CTX_L10_31 CTX_L50_3 22.8364a
Cext_124 CTX_L10_31 VSUBS 1.36198f
Cext_125 CTX_L10_32 CTX_L126_0 54.6016a
Cext_126 CTX_L10_32 CTX_L30_1|CTX_L50_0|CTX_L67_0 7.66327a
Cext_127 CTX_L10_32 CTX_L50_2 6.37753a
Cext_128 CTX_L10_32 CTX_L50_3 25.3818a
Cext_129 CTX_L10_32 CTX_L50_4 31.3145a
Cext_130 CTX_L10_32 CTX_L50_5 9.66042a
Cext_131 CTX_L10_32 CTX_L50_6 7.92103a
Cext_132 CTX_L10_32 VSUBS 1.36198f
Cext_133 CTX_L10_33 CTX_L10_4|CTX_L8_2|CTX_L8_6 0.289732a
Cext_134 CTX_L10_33 CTX_L126_1 80.4879a
Cext_135 CTX_L10_33 CTX_L8_39 83.0096a
Cext_136 CTX_L10_33 VSUBS 1.23874f
Cext_137 CTX_L10_35|CTX_L8_16|CTX_L8_34 CTX_L30_15 28.1237a
Cext_138 CTX_L10_35|CTX_L8_16|CTX_L8_34 CTX_L30_16 24.0711a
Cext_139 CTX_L10_35|CTX_L8_16|CTX_L8_34 CTX_L30_17 24.0711a
Cext_140 CTX_L10_35|CTX_L8_16|CTX_L8_34 CTX_L30_18 24.0711a
Cext_141 CTX_L10_35|CTX_L8_16|CTX_L8_34 CTX_L30_19 24.0711a
Cext_142 CTX_L10_35|CTX_L8_16|CTX_L8_34 CTX_L30_20 24.0711a
Cext_143 CTX_L10_35|CTX_L8_16|CTX_L8_34 CTX_L30_21 24.0711a
Cext_144 CTX_L10_35|CTX_L8_16|CTX_L8_34 CTX_L30_22 24.0711a
Cext_145 CTX_L10_35|CTX_L8_16|CTX_L8_34 CTX_L30_23 24.0711a
Cext_146 CTX_L10_35|CTX_L8_16|CTX_L8_34 CTX_L30_24 24.0711a
Cext_147 CTX_L10_35|CTX_L8_16|CTX_L8_34 CTX_L30_25 5.81513a
Cext_148 CTX_L10_35|CTX_L8_16|CTX_L8_34 CTX_L8_39 133.552a
Cext_149 CTX_L10_35|CTX_L8_16|CTX_L8_34 VSUBS 844.997a
Cext_150 CTX_L10_37|CTX_L8_20|CTX_L8_36 CTX_L30_15 21.639a
Cext_151 CTX_L10_37|CTX_L8_20|CTX_L8_36 CTX_L30_16 17.5864a
Cext_152 CTX_L10_37|CTX_L8_20|CTX_L8_36 CTX_L30_17 17.5864a
Cext_153 CTX_L10_37|CTX_L8_20|CTX_L8_36 CTX_L30_18 17.5864a
Cext_154 CTX_L10_37|CTX_L8_20|CTX_L8_36 CTX_L30_19 17.5864a
Cext_155 CTX_L10_37|CTX_L8_20|CTX_L8_36 CTX_L30_20 17.5864a
Cext_156 CTX_L10_37|CTX_L8_20|CTX_L8_36 CTX_L30_21 17.5864a
Cext_157 CTX_L10_37|CTX_L8_20|CTX_L8_36 CTX_L30_22 17.5864a
Cext_158 CTX_L10_37|CTX_L8_20|CTX_L8_36 CTX_L30_23 17.5864a
Cext_159 CTX_L10_37|CTX_L8_20|CTX_L8_36 CTX_L30_24 17.5864a
Cext_160 CTX_L10_37|CTX_L8_20|CTX_L8_36 CTX_L30_25 4.73436a
Cext_161 CTX_L10_37|CTX_L8_20|CTX_L8_36 CTX_L8_39 95.9772a
Cext_162 CTX_L10_37|CTX_L8_20|CTX_L8_36 VSUBS 1.07681f
Cext_163 CTX_L10_4|CTX_L8_2|CTX_L8_6 CTX_L10_5|CTX_L8_1|CTX_L8_9 11.1467a
Cext_164 CTX_L10_4|CTX_L8_2|CTX_L8_6 CTX_L126_1 0.28104a
Cext_165 CTX_L10_4|CTX_L8_2|CTX_L8_6 CTX_L8_39 229.194a
Cext_166 CTX_L10_4|CTX_L8_2|CTX_L8_6 VSUBS 304.777a
Cext_167 CTX_L10_5|CTX_L8_1|CTX_L8_9 CTX_L10_6|CTX_L8_10|CTX_L8_3 143.324a
Cext_168 CTX_L10_5|CTX_L8_1|CTX_L8_9 CTX_L8_39 275.84a
Cext_169 CTX_L10_5|CTX_L8_1|CTX_L8_9 VSUBS 280.557a
Cext_170 CTX_L10_6|CTX_L8_10|CTX_L8_3 CTX_L8_39 228.819a
Cext_171 CTX_L10_6|CTX_L8_10|CTX_L8_3 VSUBS 305.621a
Cext_172 CTX_L126_0 CTX_L30_1|CTX_L50_0|CTX_L67_0 1.74102f
Cext_173 CTX_L126_0 CTX_L30_7 4.47726a
Cext_174 CTX_L126_0 CTX_L50_1 283.662a
Cext_175 CTX_L126_0 CTX_L50_2 227.8a
Cext_176 CTX_L126_0 CTX_L50_3 172.825a
Cext_177 CTX_L126_0 CTX_L50_4 9.19766a
Cext_178 CTX_L126_0 CTX_L50_5 8.10807a
Cext_179 CTX_L126_0 CTX_L50_6 7.19387a
Cext_180 CTX_L126_0 VSUBS 1.95415f
Cext_181 CTX_L126_1 CTX_L50_10 297.129a
Cext_182 CTX_L126_1 CTX_L50_7 16.4181a
Cext_183 CTX_L126_1 CTX_L50_8 19.3755a
Cext_184 CTX_L126_1 CTX_L50_9 70.7361a
Cext_185 CTX_L126_1 CTX_L8_38 95.0388a
Cext_186 CTX_L126_1 CTX_L8_39 192.92a
Cext_187 CTX_L126_1 N 230.516a
Cext_188 CTX_L126_1 P 489.685a
Cext_189 CTX_L126_1 VSUBS 2.21075f
Cext_190 CTX_L30_1|CTX_L50_0|CTX_L67_0 CTX_L30_7 60.5625a
Cext_191 CTX_L30_1|CTX_L50_0|CTX_L67_0 CTX_L50_1 222.381a
Cext_192 CTX_L30_1|CTX_L50_0|CTX_L67_0 CTX_L50_2 28.2338a
Cext_193 CTX_L30_1|CTX_L50_0|CTX_L67_0 CTX_L50_3 12.5179a
Cext_194 CTX_L30_1|CTX_L50_0|CTX_L67_0 VSUBS 1.29839f
Cext_195 CTX_L30_15 CTX_L30_16 1.64561f
Cext_196 CTX_L30_15 VSUBS 101.919a
Cext_197 CTX_L30_16 CTX_L30_17 1.64561f
Cext_198 CTX_L30_16 VSUBS 67.7784a
Cext_199 CTX_L30_17 CTX_L30_18 1.64561f
Cext_200 CTX_L30_17 VSUBS 67.8859a
Cext_201 CTX_L30_18 CTX_L30_19 1.64561f
Cext_202 CTX_L30_18 VSUBS 67.9396a
Cext_203 CTX_L30_19 CTX_L30_20 1.64561f
Cext_204 CTX_L30_19 VSUBS 69.0231a
Cext_205 CTX_L30_20 CTX_L30_21 1.64561f
Cext_206 CTX_L30_20 VSUBS 69.0231a
Cext_207 CTX_L30_21 CTX_L30_22 1.64561f
Cext_208 CTX_L30_21 VSUBS 69.0231a
Cext_209 CTX_L30_22 CTX_L30_23 1.64561f
Cext_210 CTX_L30_22 VSUBS 69.0231a
Cext_211 CTX_L30_23 CTX_L30_24 1.64561f
Cext_212 CTX_L30_23 VSUBS 69.0231a
Cext_213 CTX_L30_24 CTX_L30_25 1.64561f
Cext_214 CTX_L30_24 VSUBS 69.0231a
Cext_215 CTX_L30_25 VSUBS 315.666a
Cext_216 CTX_L30_7 CTX_L50_1 2.37667a
Cext_217 CTX_L30_7 CTX_L50_2 0.263527a
Cext_218 CTX_L30_7 CTX_L50_3 0.129019a
Cext_219 CTX_L30_7 VSUBS 88.4222a
Cext_220 CTX_L50_1 CTX_L50_2 3.48775f
Cext_221 CTX_L50_1 VSUBS 616.843a
Cext_222 CTX_L50_10 CTX_L50_9 271.822a
Cext_223 CTX_L50_10 CTX_L8_38 64.7232a
Cext_224 CTX_L50_10 N 1.29649f
Cext_225 CTX_L50_10 VSUBS 436.375a
Cext_226 CTX_L50_2 CTX_L50_3 1.29649f
Cext_227 CTX_L50_2 VSUBS 159.538a
Cext_228 CTX_L50_3 CTX_L50_4 163.885a
Cext_229 CTX_L50_3 VSUBS 611.928a
Cext_230 CTX_L50_4 CTX_L50_5 3.48775f
Cext_231 CTX_L50_4 VSUBS 559.214a
Cext_232 CTX_L50_5 CTX_L50_6 3.48775f
Cext_233 CTX_L50_5 VSUBS 108.027a
Cext_234 CTX_L50_6 CTX_L50_7 163.885a
Cext_235 CTX_L50_6 VSUBS 576.578a
Cext_236 CTX_L50_7 CTX_L50_8 3.48775f
Cext_237 CTX_L50_7 CTX_L8_38 3.91548a
Cext_238 CTX_L50_7 VSUBS 576.578a
Cext_239 CTX_L50_8 CTX_L50_9 1.29649f
Cext_240 CTX_L50_8 CTX_L8_38 4.44804a
Cext_241 CTX_L50_8 VSUBS 159.538a
Cext_242 CTX_L50_9 CTX_L8_38 7.26708a
Cext_243 CTX_L50_9 VSUBS 477.142a
Cext_244 CTX_L8_38 CTX_L8_39 180.553a
Cext_245 CTX_L8_38 N 17.0381a
Cext_246 CTX_L8_38 P 10.2723a
Cext_247 CTX_L8_38 VSUBS 1.65066f
Cext_248 CTX_L8_39 N 8.26783a
Cext_249 CTX_L8_39 P 46.7669a
Cext_250 CTX_L8_39 VSUBS 5.53377f
Cext_251 N P 3.48775f
Cext_252 N VSUBS 155.235a
Cext_253 P VSUBS 463.167a
.ENDS sense_fill_clip
