* cell sense_fill_clip
.SUBCKT sense_fill_clip
* net 2 CTX_L30_1,CTX_L50_0,CTX_L67_0
* net 3 FILL_L8_0
* net 4 FILL_L10_0
* net 5 FILL_L8_1
* net 6 FILL_L30_8
* net 7 FILL_L67_1
* net 8 FILL_L10_1
* net 9 FILL_L8_2
* net 10 FILL_L10_8
* net 11 FILL_L67_2
* net 12 FILL_L30_9
* net 13 FILL_L8_3
* net 14 FILL_L10_9
* net 15 FILL_L67_3
* net 16 FILL_L10_10
* net 17 FILL_L30_0
* net 18 CTX_L8_39
* net 19 FILL_L10_2
* net 20 FILL_L67_4
* net 21 CTX_L10_0,CTX_L10_1,CTX_L10_2,CTX_L30_0,CTX_L30_2,CTX_L50_13,CTX_L8_4
* net 22 FILL_L30_1
* net 23 FILL_L67_5
* net 24 FILL_L50_2
* net 25 FILL_L30_2
* net 26 CTX_L10_3,CTX_L8_0,CTX_L8_5
* net 27 FILL_L30_3
* net 28 FILL_L67_6
* net 29 FILL_L50_3
* net 30 FILL_L10_4
* net 31 FILL_L30_4
* net 32 CTX_L10_5,CTX_L8_1,CTX_L8_9
* net 33 FILL_L30_5
* net 34 FILL_L67_7
* net 35 FILL_L50_4
* net 36 FILL_L10_5
* net 37 FILL_L10_3
* net 38 FILL_L30_6
* net 39 FILL_L134_0
* net 40 FILL_L10_6
* net 41 FILL_L30_7
* net 42 FILL_L67_0
* net 43 FILL_L10_7
* net 44 FILL_L126_0
* net 45 FILL_L134_1
* net 46 FILL_L50_0
* net 47 FILL_L134_2
* net 48 FILL_L30_10
* net 49 FILL_L50_1
* net 50 FILL_L30_11
* net 51 FILL_L134_3
* net 52 FILL_L10_11
* net 53 FILL_L134_4
* net 54 FILL_L126_1
* net 55 CTX_L10_4,CTX_L8_2,CTX_L8_6
* net 56 FILL_L126_2
* net 57 FILL_L134_5
* net 58 CTX_L10_6,CTX_L8_10,CTX_L8_3
* net 59 FILL_L134_6
* net 60 FILL_L126_3
* net 61 CTX_L10_11,CTX_L10_16,CTX_L10_17,CTX_L10_7,CTX_L30_12,CTX_L30_3,CTX_L8_13,CTX_L8_22,CTX_L8_23,CTX_L8_29,CTX_L8_7
* net 62 CTX_L10_18,CTX_L10_34,CTX_L10_8,CTX_L30_4,CTX_L30_9,CTX_L8_15,CTX_L8_24,CTX_L8_33,CTX_L8_8
* net 63 CTX_L10_13,CTX_L10_20,CTX_L10_21,CTX_L10_9,CTX_L30_13,CTX_L30_5,CTX_L8_11,CTX_L8_17,CTX_L8_26,CTX_L8_27,CTX_L8_31
* net 64 CTX_L10_10,CTX_L10_22,CTX_L10_36,CTX_L30_11,CTX_L30_6,CTX_L8_12,CTX_L8_19,CTX_L8_28,CTX_L8_35
* net 65 CTX_L30_7
* net 66 FILL_L8_5
* net 67 FILL_L10_12
* net 68 FILL_L10_14
* net 69 FILL_L30_12
* net 70 FILL_L67_8
* net 71 FILL_L8_6
* net 72 FILL_L30_19
* net 73 FILL_L67_10
* net 74 FILL_L10_15
* net 75 FILL_L10_13
* net 76 FILL_L8_7
* net 77 FILL_L10_16
* net 78 FILL_L50_5
* net 79 FILL_L30_20
* net 80 FILL_L67_11
* net 81 FILL_L8_8
* net 82 FILL_L10_17
* net 83 FILL_L30_13
* net 84 FILL_L67_12
* net 85 FILL_L10_18
* net 86 FILL_L50_6
* net 87 FILL_L30_16
* net 88 FILL_L67_13
* net 89 FILL_L30_14
* net 90 FILL_L10_19
* net 91 FILL_L8_9
* net 92 FILL_L30_15
* net 93 FILL_L8_4
* net 94 FILL_L50_9
* net 95 FILL_L67_14
* net 96 CTX_L10_12,CTX_L10_15,CTX_L30_8,CTX_L8_14,CTX_L8_21,CTX_L8_30
* net 97 FILL_L50_10
* net 98 FILL_L67_15
* net 99 CTX_L10_35,CTX_L8_16,CTX_L8_34
* net 100 CTX_L10_14,CTX_L10_19,CTX_L30_10,CTX_L8_18,CTX_L8_25,CTX_L8_32
* net 101 FILL_L67_16
* net 102 FILL_L50_11
* net 103 CTX_L10_37,CTX_L8_20,CTX_L8_36
* net 104 FILL_L30_17
* net 105 FILL_L67_9
* net 106 FILL_L30_18
* net 107 FILL_L50_7
* net 108 FILL_L30_21
* net 109 FILL_L50_8
* net 110 FILL_L30_22
* net 111 FILL_L8_10
* net 112 CTX_L126_0
* net 113 CTX_L50_1
* net 114 CTX_L10_31
* net 115 CTX_L50_2
* net 116 FILL_L10_20
* net 117 CTX_L50_3
* net 118 CTX_L10_32
* net 119 FILL_L10_21
* net 120 CTX_L50_4
* net 121 CTX_L50_5
* net 122 CTX_L50_6
* net 123 CTX_L50_7
* net 124 CTX_L50_8
* net 125 CTX_L50_9
* net 126 CTX_L50_10
* net 127 CTX_L8_38
* net 128 N
* net 129 P
* net 130 CTX_L126_1
* net 131 FILL_L30_25
* net 132 CTX_L10_33
* net 133 FILL_L8_12
* net 134 FILL_L30_26
* net 135 FILL_L10_24
* net 136 FILL_L67_17
* net 137 FILL_L8_13
* net 138 FILL_L30_27
* net 139 FILL_L67_19
* net 140 FILL_L10_25
* net 141 FILL_L10_26
* net 142 FILL_L8_14
* net 143 FILL_L50_12
* net 144 FILL_L67_20
* net 145 FILL_L30_28
* net 146 FILL_L8_15
* net 147 FILL_L10_27
* net 148 FILL_L30_23
* net 149 FILL_L67_21
* net 150 FILL_L10_28
* net 151 FILL_L30_24
* net 152 FILL_L50_13
* net 153 FILL_L67_22
* net 154 FILL_L8_17
* net 155 FILL_L10_29
* net 156 FILL_L8_16
* net 157 FILL_L8_11
* net 158 FILL_L50_16
* net 159 FILL_L67_23
* net 160 FILL_L10_22
* net 161 CTX_L10_23,CTX_L10_24,CTX_L10_25,CTX_L10_26,CTX_L10_27,CTX_L10_28,CTX_L10_29,CTX_L10_30,CTX_L30_14,CTX_L8_37
* net 162 FILL_L67_24
* net 163 FILL_L50_17
* net 164 FILL_L10_23
* net 165 FILL_L67_25
* net 166 FILL_L50_18
* net 167 FILL_L134_7
* net 168 FILL_L8_18
* net 169 FILL_L10_30
* net 170 FILL_L67_26
* net 171 FILL_L67_18
* net 172 FILL_L8_19
* net 173 FILL_L10_31
* net 174 FILL_L126_4
* net 175 FILL_L134_8
* net 176 FILL_L10_37
* net 177 FILL_L8_20
* net 178 FILL_L50_19
* net 179 FILL_L50_14
* net 180 FILL_L8_21
* net 181 FILL_L10_38
* net 182 FILL_L134_9
* net 183 FILL_L30_29
* net 184 FILL_L30_31
* net 185 FILL_L10_39
* net 186 FILL_L50_15
* net 187 FILL_L50_20
* net 188 FILL_L30_30
* net 189 FILL_L30_33
* net 190 FILL_L10_33
* net 191 FILL_L10_32
* net 192 FILL_L10_34
* net 193 CTX_L30_18
* net 194 CTX_L30_15
* net 195 CTX_L30_16
* net 196 CTX_L30_17
* net 197 FILL_L8_27
* net 198 FILL_L30_35
* net 199 FILL_L10_44
* net 200 FILL_L10_35
* net 201 FILL_L67_27
* net 202 FILL_L8_28
* net 203 FILL_L10_45
* net 204 FILL_L67_28
* net 205 FILL_L10_36
* net 206 FILL_L30_36
* net 207 FILL_L10_46
* net 208 FILL_L8_29
* net 209 FILL_L50_21
* net 210 FILL_L67_29
* net 211 FILL_L30_37
* net 212 FILL_L10_47
* net 213 FILL_L8_30
* net 214 FILL_L30_38
* net 215 FILL_L67_30
* net 216 FILL_L10_48
* net 217 FILL_L50_22
* net 218 FILL_L30_32
* net 219 FILL_L67_31
* net 220 FILL_L8_22
* net 221 FILL_L10_41
* net 222 FILL_L50_23
* net 223 FILL_L67_32
* net 224 FILL_L8_23
* net 225 FILL_L30_34
* net 226 FILL_L10_42
* net 227 FILL_L10_40
* net 228 FILL_L8_24
* net 229 FILL_L50_24
* net 230 FILL_L67_33
* net 231 FILL_L10_43
* net 232 CTX_L30_25
* net 233 CTX_L30_24
* net 234 CTX_L30_19
* net 235 CTX_L30_20
* net 236 CTX_L30_23
* net 237 CTX_L30_22
* net 238 CTX_L30_21
* net 239 FILL_L8_25
* net 240 FILL_L67_34
* net 241 FILL_L50_25
* net 242 FILL_L8_26
.ENDS sense_fill_clip
