* actual_fill grounded drive P; diagnostic capacitor-network AC only
C79 0 P 1.42285e-16
C632 0 N 2.3051600000000003e-16
C633 0 P 3.9880000000000004e-16
C867 0 N 1.2964900000000001e-15
C1168 0 N 5.2091300000000003e-18
C1169 0 P 3.0694400000000005e-18
C1237 0 N 2.6333000000000005e-18
C1238 0 P 2.80893e-17
C1265 0 N 5.4525700000000006e-17
C1266 0 P 3.1115600000000004e-17
C1273 0 P 3.3062900000000005e-18
C1347 0 N 6.5750900000000007e-17
C1348 0 P 3.8255899999999997e-17
C1365 0 N 4.2123800000000005e-19
C1366 0 P 1.6183600000000001e-17
C1372 0 P 3.1740400000000003e-18
C1450 0 N 6.5750900000000007e-17
C1451 0 P 3.8255899999999997e-17
C1467 0 N 4.9557400000000006e-19
C1468 0 P 1.16039e-17
C1561 0 N 6.6245999999999997e-17
C1562 0 P 3.8751e-17
C1585 0 N 4.9557400000000006e-19
C1586 0 P 1.2428200000000001e-17
C1629 0 N 4.8551300000000004e-19
C1630 0 P 3.8926300000000008e-19
C1830 0 P 5.9521200000000003e-18
C1911 0 N 9.7296500000000008e-19
C1912 0 P 8.9758499999999999e-18
C1921 0 N 2.6879100000000003e-19
C1922 0 P 2.1352400000000002e-19
C1927 0 N 2.0270100000000002e-18
C1928 0 P 1.8699700000000002e-17
C1941 0 N 2.6879100000000003e-19
C1942 0 P 2.1352400000000002e-19
C1948 0 N 2.2149000000000001e-19
C1949 0 P 2.8003500000000001e-19
C1962 0 N 2.0270100000000002e-18
C1963 0 P 1.8699700000000002e-17
C2003 0 N 1.3439599999999999e-19
C2004 0 P 1.0676200000000001e-19
C2010 0 N 2.0270100000000002e-18
C2011 0 P 1.8699700000000002e-17
C2018 0 N 2.4191200000000001e-19
C2019 0 P 1.9217200000000002e-19
C2026 0 N 2.0270100000000002e-18
C2027 0 P 1.8699700000000002e-17
C2038 0 N 4.2083100000000004e-19
C2039 0 P 4.5087200000000008e-18
C2068 0 N 2.6879100000000003e-19
C2069 0 P 2.1352400000000002e-19
C2078 0 N 2.0270100000000002e-18
C2079 0 P 1.8699700000000002e-17
C2086 0 N 2.6879100000000003e-19
C2087 0 P 2.1352400000000002e-19
C2093 0 N 2.0270100000000002e-18
C2094 0 P 1.8699700000000002e-17
C2106 0 N 4.4298000000000001e-19
C2107 0 P 4.5367200000000002e-18
C2138 0 N 1.3977200000000001e-19
C2139 0 P 1.11032e-19
C2165 0 P 7.9368600000000002e-17
C2181 0 P 7.9368600000000002e-17
C2186 0 P 7.9368600000000002e-17
C2207 0 P 3.5888400000000002e-18
C2210 0 P 7.9368600000000002e-17
C2213 0 P 4.1271700000000005e-17
C2234 0 P 7.9368600000000002e-17
C2237 0 P 7.9368600000000002e-17
C2320 N P 3.4877500000000003e-15
C2321 N 0 5.8416800000000005e-17
C2322 P 0 2.0760400000000003e-16
VP P 0 DC 0 AC 1
VN N 0 DC 0 AC 0
.control
set numdgt=17
ac lin 1 1Meg 1Meg
let cp = -imag(i(VP))/(2*pi*1e6)
let cn = -imag(i(VN))/(2*pi*1e6)
print cp cn
quit
.endc
.end
