* Extracted by KLayout with SG13G2 LVS runset on : 22/09/2026 01:06

.SUBCKT sense_fill_clip
.ENDS sense_fill_clip
