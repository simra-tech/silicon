* Declared idealoutsideequipotential target pieces; othercontexts ground.
C32 0 P 5.79061e-17
C58 0 P 4.2290200000000001e-16
C77 0 P 1.8143800000000001e-16
C111 0 P 7.8502200000000011e-18
C137 0 P 2.16159e-16
C155 0 P 1.6841900000000002e-16
C164 0 P 1.13127e-17
C186 0 P 4.5647399999999999e-17
C192 0 P 5.0619600000000008e-18
C213 0 P 4.3594600000000008e-18
C225 0 P 4.3594600000000008e-18
C236 0 P 5.1822600000000008e-18
C265 0 P 8.1854100000000003e-17
C285 0 P 1.52736e-16
C291 0 P 8.6213200000000015e-18
C297 0 P 9.1497400000000004e-18
C306 0 P 3.3540300000000006e-17
C312 0 P 1.8373999999999999e-18
C322 0 P 4.4223800000000008e-19
C326 0 P 1.9749500000000001e-17
C340 0 P 2.4326800000000003e-18
C344 0 P 5.9220900000000002e-17
C349 0 P 6.7429300000000005e-18
C366 0 P 1.9037500000000004e-18
C370 0 P 2.4655999999999998e-18
C375 0 P 8.5533600000000003e-19
C377 P 0 2.6101200000000001e-16
VP P 0 DC 0 AC 1
.control
set numdgt=17
ac lin 1 1Meg 1Meg
let ceff = -imag(i(VP))/(2*pi*1e6)
print ceff
echo LOCAL_CAP_AC_END
quit
.endc
.end
