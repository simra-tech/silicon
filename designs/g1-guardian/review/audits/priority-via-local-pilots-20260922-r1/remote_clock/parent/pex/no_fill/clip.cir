* cell sense_fill_clip
.SUBCKT sense_fill_clip
* net 1 CTX_L8_0
* net 2 CTX_L30_0
* net 3 P,PSEG_L50_1
* net 4 CTX_L30_2
* net 5 CTX_L30_3,CTX_L50_0
.ENDS sense_fill_clip
