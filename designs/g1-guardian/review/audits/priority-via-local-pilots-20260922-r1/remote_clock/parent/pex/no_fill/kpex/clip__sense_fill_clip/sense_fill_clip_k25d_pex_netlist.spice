*********************************************************
*** NGSPICE file created by KLayout-PEX 0.3.12
*** -----------------------------------------------------
***     Extraction Engine: KPEX/2.5D
***     Technology: ihp_sg13g2
***     Date: 2026-09-22 18:02:22
*********************************************************

.SUBCKT sense_fill_clip
Cext_1 CTX_L30_0 CTX_L30_2 45.3465a
Cext_2 CTX_L30_0 CTX_L8_0 69.2693a
Cext_3 CTX_L30_0 P|PSEG_L50_1 57.9061a
Cext_4 CTX_L30_0 VSUBS 1.01994f
Cext_5 CTX_L30_2 CTX_L30_3|CTX_L50_0 86.0468a
Cext_6 CTX_L30_2 CTX_L8_0 12.9966a
Cext_7 CTX_L30_2 P|PSEG_L50_1 422.902a
Cext_8 CTX_L30_2 VSUBS 496.248a
Cext_9 CTX_L30_3|CTX_L50_0 CTX_L8_0 1.35378a
Cext_10 CTX_L30_3|CTX_L50_0 P|PSEG_L50_1 181.438a
Cext_11 CTX_L30_3|CTX_L50_0 VSUBS 367.396a
Cext_12 CTX_L8_0 P|PSEG_L50_1 17.3112a
Cext_13 CTX_L8_0 VSUBS 1.0799f
Cext_14 P|PSEG_L50_1 VSUBS 475.894a
.ENDS sense_fill_clip
