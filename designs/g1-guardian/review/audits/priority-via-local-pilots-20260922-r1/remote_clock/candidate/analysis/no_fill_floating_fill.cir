* Declared idealoutsideequipotential target pieces; othercontexts ground.
C2 0 P 5.8921399999999998e-17
C6 0 P 4.2861200000000006e-16
C9 0 P 1.8143800000000001e-16
C11 0 P 1.8518000000000003e-17
C13 P 0 5.0659600000000002e-16
VP P 0 DC 0 AC 1
.control
set numdgt=17
ac lin 1 1Meg 1Meg
let ceff = -imag(i(VP))/(2*pi*1e6)
print ceff
echo LOCAL_CAP_AC_END
quit
.endc
.end
