* Declared idealoutsideequipotential target pieces; othercontexts ground.
C2 0 F4 1.39134e-16
C3 0 F5 1.4731500000000001e-16
C4 0 F6 3.4945600000000001e-18
C5 0 F7 5.9858000000000009e-18
C6 0 F8 3.2415600000000004e-18
C7 0 F12 1.4731500000000001e-16
C8 0 F13 1.4731500000000001e-16
C9 0 F14 1.2798400000000001e-16
C10 0 F15 1.1986100000000001e-17
C11 0 F16 1.1986100000000001e-17
C12 0 F17 1.1986100000000001e-17
C13 0 F18 1.1986100000000001e-17
C14 0 F19 1.1986100000000001e-17
C15 0 F20 8.60372e-17
C16 0 F21 1.35583e-16
C17 0 F22 2.6045700000000003e-17
C18 0 F23 3.9598700000000005e-17
C19 0 F24 5.3445400000000001e-17
C20 0 F30 1.03326e-16
C21 0 F31 1.20871e-16
C22 0 F32 1.20871e-16
C23 0 F33 1.2002e-16
C24 0 F34 2.4520700000000002e-17
C25 0 F35 1.42499e-17
C26 0 F36 4.0741100000000007e-19
C27 0 F39 1.7435500000000002e-17
C28 0 F40 2.1109600000000001e-17
C29 0 F42 2.1040800000000003e-17
C30 0 F43 2.1109600000000001e-17
C31 0 F44 1.4646900000000002e-17
C32 0 P 5.8921399999999998e-17
C36 0 F6 2.8252600000000001e-16
C37 0 F7 3.0784300000000004e-16
C38 0 F8 1.61155e-16
C39 0 F10 4.0061200000000001e-18
C40 0 F11 3.2803200000000004e-18
C41 0 F17 2.2975900000000001e-19
C42 0 F18 2.41851e-18
C43 0 F19 2.41851e-18
C44 0 F20 4.4200000000000008e-17
C45 0 F21 1.4081700000000001e-16
C46 0 F22 2.7877900000000006e-18
C47 0 F23 3.5347600000000001e-18
C48 0 F24 1.2096000000000001e-17
C49 0 F25 2.3623200000000002e-17
C50 0 F26 2.3623200000000002e-17
C51 0 F29 1.6399999999999999e-17
C52 0 F35 4.4626000000000006e-19
C53 0 F36 2.1507200000000002e-17
C54 0 F37 4.5235000000000006e-18
C55 0 F45 1.9037500000000004e-18
C56 0 F46 3.2205200000000002e-18
C57 0 F47 1.6102600000000001e-18
C58 0 P 4.2861200000000006e-16
C61 0 F6 1.4053899999999999e-16
C62 0 F9 6.2704799999999999e-17
C63 0 F10 1.3711400000000001e-17
C64 0 F20 9.0873500000000009e-17
C65 0 F21 1.01709e-17
C66 0 F22 4.5610600000000006e-18
C67 0 F23 4.5680500000000009e-18
C68 0 F25 8.0673500000000004e-18
C69 0 F27 1.8158600000000001e-17
C70 0 F28 2.51896e-17
C71 0 F29 8.1080500000000002e-19
C72 0 F37 5.4000200000000003e-17
C73 0 F38 5.6158000000000006e-18
C74 0 F45 4.163560000000001e-18
C75 0 F48 4.0046000000000002e-18
C76 0 F49 8.4016000000000004e-19
C77 0 P 1.8143800000000001e-16
C79 0 F4 5.1456700000000007e-19
C80 0 F5 5.1456700000000007e-19
C81 0 F6 3.6647600000000002e-18
C82 0 F7 3.6783200000000002e-18
C83 0 F8 1.8600600000000001e-18
C84 0 F12 5.1456700000000007e-19
C85 0 F13 5.1456700000000007e-19
C86 0 F14 5.1456700000000007e-19
C87 0 F15 4.4655300000000003e-17
C88 0 F16 5.0742300000000005e-17
C89 0 F17 5.0749100000000001e-17
C90 0 F18 5.08099e-17
C91 0 F19 4.8387000000000006e-17
C92 0 F20 1.9128000000000002e-17
C93 0 F21 3.5224499999999999e-17
C94 0 F22 1.9319000000000001e-18
C95 0 F23 2.80441e-18
C96 0 F24 8.68991e-18
C97 0 F26 9.8382400000000014e-19
C98 0 F29 1.8952800000000001e-19
C99 0 F31 5.3409800000000003e-19
C100 0 F32 1.0682e-18
C101 0 F34 1.62049e-18
C102 0 F35 2.0047900000000002e-18
C103 0 F39 1.2984600000000001e-17
C104 0 F40 1.2984600000000001e-17
C105 0 F42 1.2984600000000001e-17
C106 0 F43 1.2984600000000001e-17
C107 0 F44 1.2984600000000001e-17
C108 0 F45 7.1176600000000001e-17
C109 0 F46 7.1176600000000001e-17
C110 0 F47 3.5791600000000006e-17
C111 0 P 7.7344400000000015e-18
C113 F4 F5 2.7935199999999999e-17
C114 F4 F6 5.1652400000000006e-18
C115 F4 F15 1.39676e-17
C116 F4 F20 4.3489300000000008e-18
C117 F4 F34 1.4804999999999999e-18
C118 F4 F39 6.7224999999999998e-17
C119 F4 0 1.03463e-16
C120 F5 F12 2.7935199999999999e-17
C121 F5 F16 1.39676e-17
C122 F5 F40 6.7224999999999998e-17
C123 F5 0 8.6486000000000006e-17
C124 F6 F7 9.7773300000000019e-17
C125 F6 F9 9.7773300000000019e-17
C126 F6 F15 2.7935199999999999e-17
C127 F6 F16 2.7935199999999999e-17
C128 F6 F20 1.1231699999999999e-16
C129 F6 F21 1.0798700000000001e-17
C130 F6 F22 8.0223999999999998e-18
C131 F6 F23 7.6218100000000003e-18
C132 F6 F25 2.77894e-18
C133 F6 F31 1.69187e-18
C134 F6 F36 5.5795200000000003e-17
C135 F6 F37 4.50055e-17
C136 F6 F45 8.2350600000000007e-16
C137 F6 P 2.1726100000000002e-16
C138 F6 0 2.9288600000000004e-16
C139 F7 F8 9.7773300000000019e-17
C140 F7 F10 9.7773300000000019e-17
C141 F7 F12 5.1652400000000006e-18
C142 F7 F17 2.7935199999999999e-17
C143 F7 F18 2.7935199999999999e-17
C144 F7 F20 1.6358400000000001e-17
C145 F7 F21 1.2383600000000001e-16
C146 F7 F22 1.1115200000000001e-17
C147 F7 F23 1.1565600000000001e-17
C148 F7 F25 1.20979e-16
C149 F7 F26 1.6912800000000001e-17
C150 F7 F29 6.5466200000000005e-18
C151 F7 F32 3.7352200000000002e-18
C152 F7 F36 2.3825599999999998e-18
C153 F7 F37 8.4991600000000008e-19
C154 F7 F46 8.2350600000000007e-16
C155 F7 P 1.87396e-16
C156 F7 0 2.2014100000000001e-16
C157 F8 F11 4.9165999999999999e-17
C158 F8 F14 5.1652400000000006e-18
C159 F8 F19 2.7935199999999999e-17
C160 F8 F21 6.7682599999999998e-17
C161 F8 F23 1.1793200000000001e-17
C162 F8 F26 3.1248800000000003e-17
C163 F8 F47 4.1410600000000002e-16
C164 F8 P 1.1471900000000001e-17
C165 F8 0 2.3042799999999999e-16
C166 F9 F10 3.9668000000000002e-17
C167 F9 F20 4.8323800000000002e-17
C168 F9 F21 3.6053700000000001e-18
C169 F9 F22 2.7715000000000002e-18
C170 F9 F23 2.45865e-18
C171 F9 F27 7.65449e-17
C172 F9 F28 5.3028800000000002e-17
C173 F9 F37 1.04719e-17
C174 F9 F38 2.07599e-17
C175 F9 F48 3.3410800000000003e-16
C176 F9 0 2.40166e-16
C177 F10 F11 3.9668000000000002e-17
C178 F10 F20 7.39332e-18
C179 F10 F21 4.2978700000000004e-17
C180 F10 F22 5.0556500000000005e-18
C181 F10 F23 5.2589600000000006e-18
C182 F10 F25 1.3974200000000001e-17
C183 F10 F28 5.7796700000000009e-18
C184 F10 F29 1.7337000000000002e-16
C185 F10 F49 3.3410800000000003e-16
C186 F10 P 4.7035900000000001e-17
C187 F10 0 2.1065199999999999e-16
C188 F11 F21 2.8505700000000004e-17
C189 F11 F23 5.0031999999999997e-18
C190 F11 F29 2.8128100000000004e-17
C191 F11 F41 1.68009e-16
C192 F11 P 5.0619600000000008e-18
C193 F11 0 1.5522700000000001e-16
C194 F12 F13 2.7935199999999999e-17
C195 F12 F17 1.39676e-17
C196 F12 F21 3.6439400000000008e-18
C197 F12 F42 6.7224999999999998e-17
C198 F12 0 8.2678399999999999e-17
C199 F13 F14 2.7935199999999999e-17
C200 F13 F18 1.39676e-17
C201 F13 F21 6.9969400000000006e-18
C202 F13 F43 6.7224999999999998e-17
C203 F13 0 8.6486000000000006e-17
C204 F14 F19 1.39676e-17
C205 F14 F21 1.2723800000000002e-18
C206 F14 F44 6.7224999999999998e-17
C207 F14 0 1.03463e-16
C208 F15 F16 2.7935199999999999e-17
C209 F15 F20 1.35826e-17
C210 F15 F34 2.1761200000000001e-17
C211 F15 F36 3.8908000000000001e-18
C212 F15 F39 1.51036e-18
C213 F15 P 4.3594600000000008e-18
C214 F15 0 9.7146299999999999e-17
C215 F16 F17 2.7935199999999999e-17
C216 F16 F20 1.4768400000000002e-17
C217 F16 F21 3.4834500000000005e-18
C218 F16 F22 2.5878700000000003e-18
C219 F16 F23 2.45865e-18
C220 F16 F24 3.4326700000000001e-19
C221 F16 F31 2.2200600000000001e-18
C222 F16 F34 3.4924300000000008e-18
C223 F16 F35 7.4294100000000002e-19
C224 F16 F40 1.51036e-18
C225 F16 P 4.3594600000000008e-18
C226 F16 0 7.3700199999999996e-17
C227 F17 F18 2.7935199999999999e-17
C228 F17 F20 6.5411500000000008e-18
C229 F17 F21 1.1401600000000001e-17
C230 F17 F22 4.5041900000000005e-18
C231 F17 F23 4.6977099999999998e-18
C232 F17 F24 9.9168999999999996e-19
C233 F17 F34 1.2151900000000002e-18
C234 F17 F35 1.7927400000000002e-18
C235 F17 F42 1.51036e-18
C236 F17 P 8.3705400000000008e-18
C237 F17 0 7.3700199999999996e-17
C238 F18 F19 2.7935199999999999e-17
C239 F18 F21 2.1154200000000001e-17
C240 F18 F24 1.51653e-17
C241 F18 F34 5.6239300000000004e-19
C242 F18 F35 5.2721800000000001e-18
C243 F18 F43 1.51036e-18
C244 F18 0 7.3700199999999996e-17
C245 F19 F21 1.7626000000000002e-17
C246 F19 F24 2.7232700000000005e-17
C247 F19 F35 6.0217800000000003e-18
C248 F19 F44 1.51036e-18
C249 F19 0 9.596760000000001e-17
C250 F20 F21 4.7795999999999998e-16
C251 F20 F22 4.1358400000000003e-16
C252 F20 F24 1.9463900000000002e-18
C253 F20 F25 3.2622000000000003e-18
C254 F20 F27 1.07747e-17
C255 F20 F28 7.0138400000000009e-18
C256 F20 F30 9.739210000000001e-18
C257 F20 F34 5.0961500000000007e-17
C258 F20 F35 1.7818499999999999e-18
C259 F20 F36 5.9345799999999997e-17
C260 F20 F37 5.9219900000000009e-17
C261 F20 F38 2.6626500000000002e-17
C262 F20 F39 1.5485199999999999e-18
C263 F20 F45 1.0912400000000001e-17
C264 F20 F48 4.9722799999999999e-18
C265 F20 P 8.3188500000000013e-17
C266 F20 0 7.6289500000000004e-16
C267 F21 F23 6.4825000000000003e-16
C268 F21 F24 2.7478000000000004e-17
C269 F21 F25 3.3674400000000003e-17
C270 F21 F26 3.7544199999999998e-17
C271 F21 F28 3.0282300000000006e-18
C272 F21 F29 6.5006699999999998e-17
C273 F21 F32 2.1442399999999999e-17
C274 F21 F33 9.739210000000001e-18
C275 F21 F34 3.2139400000000004e-18
C276 F21 F35 7.22075e-17
C277 F21 F36 8.842260000000001e-19
C278 F21 F41 3.8337800000000001e-18
C279 F21 F42 1.1633400000000001e-18
C280 F21 F43 1.8624600000000002e-18
C281 F21 F44 6.9911500000000009e-19
C282 F21 F46 1.4534800000000001e-17
C283 F21 F47 9.3053000000000009e-18
C284 F21 F49 6.0812300000000004e-18
C285 F21 P 1.5528800000000002e-16
C286 F21 0 9.2758600000000008e-16
C287 F22 F23 4.5988900000000005e-16
C288 F22 F28 1.9965200000000004e-18
C289 F22 F30 3.0349300000000003e-18
C290 F22 F38 1.0821300000000001e-19
C291 F22 P 8.9682200000000008e-18
C292 F22 0 5.6465200000000005e-16
C293 F23 F28 1.8971000000000001e-18
C294 F23 F29 4.0066600000000005e-19
C295 F23 F32 3.0349300000000003e-18
C296 F23 F33 3.0349300000000003e-18
C297 F23 P 9.5311000000000016e-18
C298 F23 0 6.4675900000000006e-16
C299 F24 F35 6.7224999999999998e-17
C300 F24 0 8.6907200000000015e-17
C301 F25 F26 1.92731e-17
C302 F25 F29 1.92731e-17
C303 F25 F37 3.2948200000000003e-19
C304 F25 F46 3.01665e-18
C305 F25 F49 2.30082e-18
C306 F25 P 3.3540300000000006e-17
C307 F25 0 3.7387000000000006e-17
C308 F26 F29 1.92731e-17
C309 F26 F35 8.1569000000000009e-19
C310 F26 F46 2.5173300000000001e-18
C311 F26 F47 2.87524e-18
C312 F26 P 1.8373999999999999e-18
C313 F26 0 6.9262299999999995e-17
C314 F27 F28 8.0947200000000016e-18
C315 F27 F37 5.0409200000000003e-19
C316 F27 F38 2.8234500000000002e-17
C317 F27 0 5.1278700000000004e-17
C318 F28 F29 8.0947200000000016e-18
C319 F28 F38 1.5150300000000002e-18
C320 F28 F48 1.2066600000000002e-18
C321 F28 F49 9.2032800000000003e-19
C322 F28 P 4.4223800000000008e-19
C323 F28 0 4.6856000000000004e-17
C324 F29 F41 3.3815499999999999e-18
C325 F29 F49 3.3815499999999999e-18
C326 F29 P 1.9749500000000001e-17
C327 F29 0 1.8802500000000001e-16
C328 F30 F31 1.43339e-17
C329 F30 F34 2.4713600000000001e-17
C330 F30 0 4.8941099999999999e-17
C331 F31 F32 1.43339e-17
C332 F31 0 4.4818100000000003e-17
C333 F32 F33 1.43339e-17
C334 F32 0 4.34839e-17
C335 F33 F35 2.4713600000000001e-17
C336 F33 0 4.4339100000000005e-17
C337 F34 F35 6.1876600000000009e-18
C338 F34 F36 2.4713600000000001e-17
C339 F34 F39 6.7038200000000004e-19
C340 F34 P 2.4326800000000003e-18
C341 F34 0 6.9123700000000001e-17
C342 F35 0 7.7825400000000002e-17
C343 F36 F37 2.4713600000000001e-17
C344 F36 P 5.9441200000000004e-17
C345 F36 0 4.1722700000000004e-17
C346 F37 F38 2.4713600000000001e-17
C347 F37 F45 8.9735099999999998e-19
C348 F37 F48 8.0131300000000013e-19
C349 F37 P 6.7429300000000005e-18
C350 F37 0 4.5487600000000001e-17
C351 F38 0 4.7457000000000003e-17
C352 F39 F40 1.9913400000000001e-17
C353 F39 0 1.65843e-16
C354 F40 F42 1.9913400000000001e-17
C355 F40 0 1.49255e-16
C356 F41 F47 3.5047500000000004e-17
C357 F41 F49 2.8277000000000004e-17
C358 F41 0 2.8652500000000001e-16
C359 F42 F43 1.9913400000000001e-17
C360 F42 0 1.49255e-16
C361 F43 F44 1.9913400000000001e-17
C362 F43 0 1.49255e-16
C363 F44 0 1.65843e-16
C364 F45 F46 6.96968e-17
C365 F45 F48 6.96968e-17
C366 F45 P 1.9037500000000004e-18
C367 F45 0 8.0796800000000006e-16
C368 F46 F47 6.96968e-17
C369 F46 F49 6.96968e-17
C370 F46 P 2.4655999999999998e-18
C371 F46 0 7.4991100000000001e-16
C372 F47 0 5.1518600000000003e-16
C373 F48 F49 2.8277000000000004e-17
C374 F48 0 4.8193800000000006e-16
C375 F49 P 8.5533600000000003e-19
C376 F49 0 4.5838300000000002e-16
C377 P 0 2.7718200000000003e-16
VP P 0 DC 0 AC 1
.control
set numdgt=17
ac lin 1 1Meg 1Meg
let ceff = -imag(i(VP))/(2*pi*1e6)
print ceff
echo LOCAL_CAP_AC_END
quit
.endc
.end
