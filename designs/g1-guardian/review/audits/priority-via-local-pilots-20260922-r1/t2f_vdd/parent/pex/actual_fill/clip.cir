* cell sense_fill_clip
.SUBCKT sense_fill_clip
* net 1 CTX_L8_0
* net 2 CTX_L8_1
* net 3 CTX_L8_2
* net 4 FILL_L8_0
* net 5 FILL_L8_1
* net 6 FILL_L8_2
* net 7 FILL_L8_3
* net 8 FILL_L8_4
* net 9 FILL_L8_5
* net 10 FILL_L10_0
* net 11 FILL_L10_1
* net 12 FILL_L10_2
* net 13 FILL_L10_3
* net 14 FILL_L10_4
* net 15 FILL_L10_5
* net 16 FILL_L10_6
* net 17 FILL_L10_7
* net 18 FILL_L10_8
* net 19 FILL_L10_9
* net 20 FILL_L10_10
* net 21 CTX_L50_0
* net 22 P,PSEG_L134_0
* net 23 CTX_L134_1
.ENDS sense_fill_clip
