* Declared idealoutsideequipotential target pieces; othercontexts ground.
C12 0 P 6.07069e-16
C26 0 P 9.1970000000000006e-17
C29 0 P 6.9621000000000009e-18
C32 0 P 1.0593700000000001e-17
C51 0 P 2.9039300000000002e-17
C56 0 P 1.13226e-19
C60 0 P 2.2147100000000004e-18
C64 0 P 3.5367000000000006e-18
C69 0 P 4.4549600000000001e-18
C73 0 P 4.5320500000000005e-18
C78 0 P 1.23554e-17
C82 0 P 1.9562100000000002e-17
C87 0 P 1.4690800000000002e-17
C91 0 P 1.6352000000000001e-17
C95 0 P 1.0777700000000001e-17
C98 0 P 1.43764e-17
C101 0 P 1.5828700000000002e-19
C104 0 P 4.2825699999999999e-18
C107 0 P 1.43331e-17
C110 0 P 1.5800500000000002e-17
C113 0 P 1.3071600000000001e-17
C115 0 P 4.0195500000000003e-18
C117 P 0 1.4897000000000001e-15
VP P 0 DC 0 AC 1
.control
set numdgt=17
ac lin 1 1Meg 1Meg
let ceff = -imag(i(VP))/(2*pi*1e6)
print ceff
echo LOCAL_CAP_AC_END
quit
.endc
.end
