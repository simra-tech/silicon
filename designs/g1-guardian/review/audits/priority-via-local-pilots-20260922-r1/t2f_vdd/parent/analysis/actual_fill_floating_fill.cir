* Declared idealoutsideequipotential target pieces; othercontexts ground.
C4 0 F7 4.7026700000000004e-18
C5 0 F12 1.8856399999999999e-18
C6 0 F13 4.0741600000000005e-18
C7 0 F14 5.0580200000000006e-18
C8 0 F15 5.5521500000000009e-18
C9 0 F19 1.82596e-18
C10 0 F20 4.6788200000000003e-18
C11 0 F21 3.7539600000000005e-18
C12 0 P 6.07069e-16
C16 0 F6 2.4315800000000003e-19
C17 0 F9 4.8631500000000006e-19
C18 0 F11 4.1823100000000005e-19
C19 0 F13 4.5713600000000001e-19
C20 0 F15 4.8631500000000006e-19
C21 0 F17 1.76986e-18
C22 0 F18 1.7505900000000004e-18
C23 0 F19 1.5343100000000001e-18
C24 0 F20 1.76986e-18
C25 0 F21 7.5083300000000005e-19
C26 0 P 9.1970000000000006e-17
C29 0 P 6.9621000000000009e-18
C32 0 P 1.0593700000000001e-17
C34 0 F5 1.2608000000000001e-17
C35 0 F6 4.1822200000000002e-18
C36 0 F7 2.7745400000000003e-17
C37 0 F8 5.8374000000000007e-17
C38 0 F9 6.3952100000000002e-18
C39 0 F10 5.8374000000000007e-17
C40 0 F11 6.3952100000000002e-18
C41 0 F12 5.8374000000000007e-17
C42 0 F13 6.3952100000000002e-18
C43 0 F14 5.8374000000000007e-17
C44 0 F15 6.3952100000000002e-18
C45 0 F16 5.3635100000000003e-19
C46 0 F17 1.3408800000000001e-17
C47 0 F18 1.3408800000000001e-17
C48 0 F19 1.3408800000000001e-17
C49 0 F20 1.3408800000000001e-17
C50 0 F21 6.1680400000000011e-18
C51 0 P 2.9039300000000002e-17
C53 F5 F6 3.5101499999999998e-18
C54 F5 F8 2.7935199999999999e-17
C55 F5 F16 1.1293700000000001e-19
C56 F5 P 1.13226e-19
C57 F5 0 4.6711900000000002e-17
C58 F6 F9 2.7935199999999999e-17
C59 F6 F16 2.0317300000000001e-18
C60 F6 P 2.2147100000000004e-18
C61 F6 0 9.3399900000000005e-17
C62 F7 F14 2.7935199999999999e-17
C63 F7 F21 3.9376400000000003e-18
C64 F7 P 3.5367000000000006e-18
C65 F7 0 7.9399000000000001e-17
C66 F8 F9 4.3876900000000001e-17
C67 F8 F10 2.7935199999999999e-17
C68 F8 F17 5.6917500000000005e-18
C69 F8 P 4.4549600000000001e-18
C70 F8 0 8.3723200000000011e-17
C71 F9 F11 2.7935199999999999e-17
C72 F9 F17 2.53967e-17
C73 F9 P 4.5320500000000005e-18
C74 F9 0 9.4807500000000013e-17
C75 F10 F11 4.3876900000000001e-17
C76 F10 F12 2.7935199999999999e-17
C77 F10 F18 5.6917500000000005e-18
C78 F10 P 1.23554e-17
C79 F10 0 8.3723200000000011e-17
C80 F11 F13 2.7935199999999999e-17
C81 F11 F18 2.53967e-17
C82 F11 P 1.9562100000000002e-17
C83 F11 0 9.4807500000000013e-17
C84 F12 F13 4.3876900000000001e-17
C85 F12 F14 2.7935199999999999e-17
C86 F12 F19 5.6917500000000005e-18
C87 F12 P 1.4690800000000002e-17
C88 F12 0 8.3723200000000011e-17
C89 F13 F15 2.7935199999999999e-17
C90 F13 F19 2.53967e-17
C91 F13 P 1.6352000000000001e-17
C92 F13 0 9.4807500000000013e-17
C93 F14 F15 4.3876900000000001e-17
C94 F14 F20 5.6917500000000005e-18
C95 F14 P 1.0777700000000001e-17
C96 F14 0 8.3723200000000011e-17
C97 F15 F20 2.53967e-17
C98 F15 P 1.43764e-17
C99 F15 0 1.1559200000000001e-16
C100 F16 F17 1.9913400000000001e-17
C101 F16 P 1.5828700000000002e-19
C102 F16 0 6.6697800000000006e-17
C103 F17 F18 1.9913400000000001e-17
C104 F17 P 4.2825699999999999e-18
C105 F17 0 1.48852e-16
C106 F18 F19 1.9913400000000001e-17
C107 F18 P 1.43331e-17
C108 F18 0 1.48852e-16
C109 F19 F20 1.9913400000000001e-17
C110 F19 P 1.5800500000000002e-17
C111 F19 0 1.48852e-16
C112 F20 F21 1.9913400000000001e-17
C113 F20 P 1.3071600000000001e-17
C114 F20 0 1.48852e-16
C115 F21 P 4.0195500000000003e-18
C116 F21 0 1.0989700000000002e-16
C117 P 0 1.4897000000000001e-15
VP P 0 DC 0 AC 1
.control
set numdgt=17
ac lin 1 1Meg 1Meg
let ceff = -imag(i(VP))/(2*pi*1e6)
print ceff
echo LOCAL_CAP_AC_END
quit
.endc
.end
