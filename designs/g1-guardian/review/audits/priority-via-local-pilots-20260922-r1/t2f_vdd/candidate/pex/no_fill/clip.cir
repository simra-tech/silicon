* cell sense_fill_clip
.SUBCKT sense_fill_clip
* net 1 CTX_L8_0
* net 2 CTX_L8_1
* net 3 CTX_L8_2
* net 4 CTX_L50_0
* net 5 P,PSEG_L134_0
* net 6 CTX_L134_1
.ENDS sense_fill_clip
