*********************************************************
*** NGSPICE file created by KLayout-PEX 0.3.12
*** -----------------------------------------------------
***     Extraction Engine: KPEX/2.5D
***     Technology: ihp_sg13g2
***     Date: 2026-09-22 18:03:00
*********************************************************

.SUBCKT sense_fill_clip
Cext_1 CTX_L134_1 CTX_L50_0 15.6188a
Cext_2 CTX_L134_1 CTX_L8_0 2.9927a
Cext_3 CTX_L134_1 CTX_L8_1 3.02875a
Cext_4 CTX_L134_1 CTX_L8_2 5.66891a
Cext_5 CTX_L134_1 FILL_L10_10 4.70267a
Cext_6 CTX_L134_1 FILL_L10_6 1.88564a
Cext_7 CTX_L134_1 FILL_L10_7 4.07416a
Cext_8 CTX_L134_1 FILL_L10_8 5.05802a
Cext_9 CTX_L134_1 FILL_L10_9 5.55215a
Cext_10 CTX_L134_1 FILL_L8_3 1.82596a
Cext_11 CTX_L134_1 FILL_L8_4 4.67882a
Cext_12 CTX_L134_1 FILL_L8_5 3.75396a
Cext_13 CTX_L134_1 P|PSEG_L134_0 612.869a
Cext_14 CTX_L134_1 VSUBS 586.304a
Cext_15 CTX_L50_0 CTX_L8_0 8.73071a
Cext_16 CTX_L50_0 CTX_L8_1 3.22002a
Cext_17 CTX_L50_0 FILL_L10_1 0.243158a
Cext_18 CTX_L50_0 FILL_L10_3 0.486315a
Cext_19 CTX_L50_0 FILL_L10_5 0.418231a
Cext_20 CTX_L50_0 FILL_L10_7 0.457136a
Cext_21 CTX_L50_0 FILL_L10_9 0.486315a
Cext_22 CTX_L50_0 FILL_L8_1 1.76986a
Cext_23 CTX_L50_0 FILL_L8_2 1.75059a
Cext_24 CTX_L50_0 FILL_L8_3 1.53431a
Cext_25 CTX_L50_0 FILL_L8_4 1.76986a
Cext_26 CTX_L50_0 FILL_L8_5 0.750833a
Cext_27 CTX_L50_0 P|PSEG_L134_0 91.607a
Cext_28 CTX_L50_0 VSUBS 711.44a
Cext_29 CTX_L8_0 CTX_L8_1 9.76274a
Cext_30 CTX_L8_0 P|PSEG_L134_0 6.9621a
Cext_31 CTX_L8_0 VSUBS 183.634a
Cext_32 CTX_L8_1 CTX_L8_2 1.3135a
Cext_33 CTX_L8_1 P|PSEG_L134_0 10.5937a
Cext_34 CTX_L8_1 VSUBS 183.329a
Cext_35 CTX_L8_2 FILL_L10_0 12.608a
Cext_36 CTX_L8_2 FILL_L10_1 4.18222a
Cext_37 CTX_L8_2 FILL_L10_10 27.7454a
Cext_38 CTX_L8_2 FILL_L10_2 58.374a
Cext_39 CTX_L8_2 FILL_L10_3 6.39521a
Cext_40 CTX_L8_2 FILL_L10_4 58.374a
Cext_41 CTX_L8_2 FILL_L10_5 6.39521a
Cext_42 CTX_L8_2 FILL_L10_6 58.374a
Cext_43 CTX_L8_2 FILL_L10_7 6.39521a
Cext_44 CTX_L8_2 FILL_L10_8 58.374a
Cext_45 CTX_L8_2 FILL_L10_9 6.39521a
Cext_46 CTX_L8_2 FILL_L8_0 0.536351a
Cext_47 CTX_L8_2 FILL_L8_1 13.4088a
Cext_48 CTX_L8_2 FILL_L8_2 13.4088a
Cext_49 CTX_L8_2 FILL_L8_3 13.4088a
Cext_50 CTX_L8_2 FILL_L8_4 13.4088a
Cext_51 CTX_L8_2 FILL_L8_5 6.16804a
Cext_52 CTX_L8_2 P|PSEG_L134_0 30.9231a
Cext_53 CTX_L8_2 VSUBS 1.04856f
Cext_54 FILL_L10_0 FILL_L10_1 3.51015a
Cext_55 FILL_L10_0 FILL_L10_2 27.9352a
Cext_56 FILL_L10_0 FILL_L8_0 0.112937a
Cext_57 FILL_L10_0 P|PSEG_L134_0 0.113226a
Cext_58 FILL_L10_0 VSUBS 46.7119a
Cext_59 FILL_L10_1 FILL_L10_3 27.9352a
Cext_60 FILL_L10_1 FILL_L8_0 2.03173a
Cext_61 FILL_L10_1 P|PSEG_L134_0 2.21471a
Cext_62 FILL_L10_1 VSUBS 93.3999a
Cext_63 FILL_L10_10 FILL_L10_8 27.9352a
Cext_64 FILL_L10_10 FILL_L8_5 3.93764a
Cext_65 FILL_L10_10 P|PSEG_L134_0 3.5367a
Cext_66 FILL_L10_10 VSUBS 79.399a
Cext_67 FILL_L10_2 FILL_L10_3 43.8769a
Cext_68 FILL_L10_2 FILL_L10_4 27.9352a
Cext_69 FILL_L10_2 FILL_L8_1 5.69175a
Cext_70 FILL_L10_2 P|PSEG_L134_0 4.45496a
Cext_71 FILL_L10_2 VSUBS 83.7232a
Cext_72 FILL_L10_3 FILL_L10_5 27.9352a
Cext_73 FILL_L10_3 FILL_L8_1 25.3967a
Cext_74 FILL_L10_3 P|PSEG_L134_0 4.53205a
Cext_75 FILL_L10_3 VSUBS 94.8075a
Cext_76 FILL_L10_4 FILL_L10_5 43.8769a
Cext_77 FILL_L10_4 FILL_L10_6 27.9352a
Cext_78 FILL_L10_4 FILL_L8_2 5.69175a
Cext_79 FILL_L10_4 P|PSEG_L134_0 12.6096a
Cext_80 FILL_L10_4 VSUBS 83.7232a
Cext_81 FILL_L10_5 FILL_L10_7 27.9352a
Cext_82 FILL_L10_5 FILL_L8_2 25.3967a
Cext_83 FILL_L10_5 P|PSEG_L134_0 22.0441a
Cext_84 FILL_L10_5 VSUBS 94.8075a
Cext_85 FILL_L10_6 FILL_L10_7 43.8769a
Cext_86 FILL_L10_6 FILL_L10_8 27.9352a
Cext_87 FILL_L10_6 FILL_L8_3 5.69175a
Cext_88 FILL_L10_6 P|PSEG_L134_0 16.6103a
Cext_89 FILL_L10_6 VSUBS 83.7232a
Cext_90 FILL_L10_7 FILL_L10_9 27.9352a
Cext_91 FILL_L10_7 FILL_L8_3 25.3967a
Cext_92 FILL_L10_7 P|PSEG_L134_0 16.5643a
Cext_93 FILL_L10_7 VSUBS 94.8075a
Cext_94 FILL_L10_8 FILL_L10_9 43.8769a
Cext_95 FILL_L10_8 FILL_L8_4 5.69175a
Cext_96 FILL_L10_8 P|PSEG_L134_0 10.7777a
Cext_97 FILL_L10_8 VSUBS 83.7232a
Cext_98 FILL_L10_9 FILL_L8_4 25.3967a
Cext_99 FILL_L10_9 P|PSEG_L134_0 14.3764a
Cext_100 FILL_L10_9 VSUBS 115.592a
Cext_101 FILL_L8_0 FILL_L8_1 19.9134a
Cext_102 FILL_L8_0 P|PSEG_L134_0 0.158287a
Cext_103 FILL_L8_0 VSUBS 66.6978a
Cext_104 FILL_L8_1 FILL_L8_2 19.9134a
Cext_105 FILL_L8_1 P|PSEG_L134_0 7.48277a
Cext_106 FILL_L8_1 VSUBS 148.852a
Cext_107 FILL_L8_2 FILL_L8_3 19.9134a
Cext_108 FILL_L8_2 P|PSEG_L134_0 18.0766a
Cext_109 FILL_L8_2 VSUBS 148.852a
Cext_110 FILL_L8_3 FILL_L8_4 19.9134a
Cext_111 FILL_L8_3 P|PSEG_L134_0 17.8467a
Cext_112 FILL_L8_3 VSUBS 148.852a
Cext_113 FILL_L8_4 FILL_L8_5 19.9134a
Cext_114 FILL_L8_4 P|PSEG_L134_0 16.4058a
Cext_115 FILL_L8_4 VSUBS 148.852a
Cext_116 FILL_L8_5 P|PSEG_L134_0 5.20028a
Cext_117 FILL_L8_5 VSUBS 109.897a
Cext_118 P|PSEG_L134_0 VSUBS 1.63528f
.ENDS sense_fill_clip
