* synthetic target-piece aggregation
C1 P 0 2f
C2 P 0 3f
C3 0 0 5f
C4 P 0 1f
VP P 0 AC 1
.control
set numdgt=17
ac lin 1 1Meg 1Meg
let ceff = -imag(i(VP))/(2*pi*1e6)
print ceff
echo LOCAL_CAP_AC_END
quit
.endc
.end
