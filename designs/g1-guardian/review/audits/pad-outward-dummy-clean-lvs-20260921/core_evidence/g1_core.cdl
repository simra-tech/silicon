* chip CDL of g1_chip_top assembled by assemble_chip_cdl.py
* libraries: /foss/pdks/ihp-sg13g2/libs.ref/sg13g2_stdcell/cdl/sg13g2_stdcell.cdl /foss/pdks/ihp-sg13g2/libs.ref/sg13g2_io/cdl/sg13g2_io.cdl
************************************************************************
*
* Copyright 2023 IHP PDK Authors
*
* Licensed under the Apache License, Version 2.0 (the "License");
* you may not use this file except in compliance with the License.
* You may obtain a copy of the License at
*
*    https://www.apache.org/licenses/LICENSE-2.0
*
* Unless required by applicable law or agreed to in writing, software
* distributed under the License is distributed on an "AS IS" BASIS,
* WITHOUT WARRANTIES OR CONDITIONS OF ANY KIND, either express or implied.
* See the License for the specific language governing permissions and
* limitations under the License.
*
************************************************************************

************************************************************************
* Library Name: sg13g2_stdcell
* Cell Name:    sg13g2_a21o_1
* View Name:    schematic
************************************************************************

.SUBCKT sg13g2_a21o_1 X A1 A2 B1 VDD VSS
*.PININFO A1:I A2:I B1:I X:O VDD:B VSS:B
MN0 net1 A1 net2 VSS sg13_lv_nmos m=1 w=640.00n l=130.00n ng=1
MN1 net2 A2 VSS VSS sg13_lv_nmos m=1 w=640.00n l=130.00n ng=1
MN2 net1 B1 VSS VSS sg13_lv_nmos m=1 w=640.00n l=130.00n ng=1
MN3 X net1 VSS VSS sg13_lv_nmos m=1 w=740.00n l=130.00n ng=1
MP2 net1 B1 net3 VDD sg13_lv_pmos m=1 w=1.000u l=130.00n ng=1
MP0 net3 A1 VDD VDD sg13_lv_pmos m=1 w=1.000u l=130.00n ng=1
MP1 net3 A2 VDD VDD sg13_lv_pmos m=1 w=1.000u l=130.00n ng=1
MP3 X net1 VDD VDD sg13_lv_pmos m=1 w=1.12u l=130.00n ng=1
.ENDS

************************************************************************
* Library Name: sg13g2_stdcell
* Cell Name:    sg13g2_a21o_2
* View Name:    schematic
************************************************************************

.SUBCKT sg13g2_a21o_2 X A1 A2 B1 VDD VSS
*.PININFO A1:I A2:I B1:I X:O VDD:B VSS:B
MN0 net1 A1 net2 VSS sg13_lv_nmos m=1 w=740.00n l=130.00n ng=1
MN1 net2 A2 VSS VSS sg13_lv_nmos m=1 w=740.00n l=130.00n ng=1
MN2 net1 B1 VSS VSS sg13_lv_nmos m=1 w=740.00n l=130.00n ng=1
MN3 X net1 VSS VSS sg13_lv_nmos m=1 w=1.48u l=130.00n ng=2
MP2 net1 B1 net3 VDD sg13_lv_pmos m=1 w=1.000u l=130.00n ng=1
MP0 net3 A1 VDD VDD sg13_lv_pmos m=1 w=1.000u l=130.00n ng=1
MP1 net3 A2 VDD VDD sg13_lv_pmos m=1 w=1.000u l=130.00n ng=1
MP3 X net1 VDD VDD sg13_lv_pmos m=1 w=2.24u l=130.00n ng=2
.ENDS

************************************************************************
* Library Name: sg13g2_stdcell
* Cell Name:    sg13g2_a21oi_1
* View Name:    schematic
************************************************************************

.SUBCKT sg13g2_a21oi_1 Y A1 A2 B1 VDD VSS
*.PININFO A1:I A2:I B1:I Y:O VDD:B VSS:B
MN0 Y B1 VSS VSS sg13_lv_nmos m=1 w=740.00n l=130.00n ng=1
MN2 net1 A2 VSS VSS sg13_lv_nmos m=1 w=740.00n l=130.00n ng=1
MN1 Y A1 net1 VSS sg13_lv_nmos m=1 w=740.00n l=130.00n ng=1
MP2 Y B1 net2 VDD sg13_lv_pmos m=1 w=1.12u l=130.00n ng=1
MP1 net2 A2 VDD VDD sg13_lv_pmos m=1 w=1.12u l=130.00n ng=1
MP0 net2 A1 VDD VDD sg13_lv_pmos m=1 w=1.12u l=130.00n ng=1
.ENDS

************************************************************************
* Library Name: sg13g2_stdcell
* Cell Name:    sg13g2_a21oi_2
* View Name:    schematic
************************************************************************

.SUBCKT sg13g2_a21oi_2 Y A1 A2 B1 VDD VSS
*.PININFO A1:I A2:I B1:I Y:O VDD:B VSS:B
MN0 Y B1 VSS VSS sg13_lv_nmos m=1 w=1.48u l=130.00n ng=2
MN2 net2 A2 VSS VSS sg13_lv_nmos m=1 w=1.48u l=130.00n ng=2
MN1 Y A1 net2 VSS sg13_lv_nmos m=1 w=1.48u l=130.00n ng=2
MP2 Y B1 net1 VDD sg13_lv_pmos m=1 w=2.24u l=130.00n ng=2
MP1 net1 A2 VDD VDD sg13_lv_pmos m=1 w=2.24u l=130.00n ng=2
MP0 net1 A1 VDD VDD sg13_lv_pmos m=1 w=2.24u l=130.00n ng=2
.ENDS

************************************************************************
* Library Name: sg13g2_stdcell
* Cell Name:    sg13g2_a221oi_1
* View Name:    schematic
************************************************************************

.SUBCKT sg13g2_a221oi_1 Y A1 A2 B1 B2 C1 VDD VSS
*.PININFO A1:I A2:I B1:I B2:I C1:I Y:O VDD:B VSS:B
MP2 Y C1 net3 VDD sg13_lv_pmos m=1 w=1.12u l=130.00n ng=1
MP4 net3 B2 net1 VDD sg13_lv_pmos m=1 w=1.12u l=130.00n ng=1
MP1 net3 B1 net1 VDD sg13_lv_pmos m=1 w=1.12u l=130.00n ng=1
MP3 net1 A2 VDD VDD sg13_lv_pmos m=1 w=1.12u l=130.00n ng=1
MP0 net1 A1 VDD VDD sg13_lv_pmos m=1 w=1.12u l=130.00n ng=1
MN4 Y C1 VSS VSS sg13_lv_nmos m=1 w=740.00n l=130.00n ng=1
MN3 net4 B2 VSS VSS sg13_lv_nmos m=1 w=740.00n l=130.00n ng=1
MN2 Y B1 net4 VSS sg13_lv_nmos m=1 w=740.00n l=130.00n ng=1
MN1 net2 A2 VSS VSS sg13_lv_nmos m=1 w=740.00n l=130.00n ng=1
MN0 Y A1 net2 VSS sg13_lv_nmos m=1 w=740.00n l=130.00n ng=1
.ENDS

************************************************************************
* Library Name: sg13g2_stdcell
* Cell Name:    sg13g2_and2_1
* View Name:    schematic
************************************************************************

.SUBCKT sg13g2_and2_1 X A B VDD VSS
*.PININFO A:I B:I X:O VDD:B VSS:B
MN0 net4 A net2 VSS sg13_lv_nmos m=1 w=640.00n l=130.00n ng=1
MN2 X net4 VSS VSS sg13_lv_nmos m=1 w=740.00n l=130.00n ng=1
MN1 net2 B VSS VSS sg13_lv_nmos m=1 w=640.00n l=130.00n ng=1
MP0 net4 B VDD VDD sg13_lv_pmos m=1 w=840.00n l=130.00n ng=1
MP2 X net4 VDD VDD sg13_lv_pmos m=1 w=1.12u l=130.00n ng=1
MP1 net4 A VDD VDD sg13_lv_pmos m=1 w=840.00n l=130.00n ng=1
.ENDS

************************************************************************
* Library Name: sg13g2_stdcell
* Cell Name:    sg13g2_and2_2
* View Name:    schematic
************************************************************************

.SUBCKT sg13g2_and2_2 X A B VDD VSS
*.PININFO A:I B:I X:O VDD:B VSS:B
MN0 net1 A net2 VSS sg13_lv_nmos m=1 w=640.00n l=130.00n ng=1
MN2 X net1 VSS VSS sg13_lv_nmos m=1 w=1.48u l=130.00n ng=2
MN1 net2 B VSS VSS sg13_lv_nmos m=1 w=640.00n l=130.00n ng=1
MP0 net1 B VDD VDD sg13_lv_pmos m=1 w=840.00n l=130.00n ng=1
MP2 X net1 VDD VDD sg13_lv_pmos m=1 w=2.24u l=130.00n ng=2
MP1 net1 A VDD VDD sg13_lv_pmos m=1 w=840.00n l=130.00n ng=1
.ENDS

************************************************************************
* Library Name: sg13g2_stdcell
* Cell Name:    sg13g2_and3_1
* View Name:    schematic
************************************************************************

.SUBCKT sg13g2_and3_1 X A B C VDD VSS
*.PININFO A:I B:I C:I X:O VDD:B VSS:B
MN2 net3 C VSS VSS sg13_lv_nmos m=1 w=640.00n l=130.00n ng=1
MN3 X net2 VSS VSS sg13_lv_nmos m=1 w=740.00n l=130.00n ng=1
MN0 net2 A net1 VSS sg13_lv_nmos m=1 w=640.00n l=130.00n ng=1
MN1 net1 B net3 VSS sg13_lv_nmos m=1 w=640.00n l=130.00n ng=1
MP3 X net2 VDD VDD sg13_lv_pmos m=1 w=1.12u l=130.00n ng=1
MP1 net2 B VDD VDD sg13_lv_pmos m=1 w=840.00n l=130.00n ng=1
MP2 net2 A VDD VDD sg13_lv_pmos m=1 w=840.00n l=130.00n ng=1
MP0 net2 C VDD VDD sg13_lv_pmos m=1 w=840.00n l=130.00n ng=1
.ENDS

************************************************************************
* Library Name: sg13g2_stdcell
* Cell Name:    sg13g2_and3_2
* View Name:    schematic
************************************************************************

.SUBCKT sg13g2_and3_2 X A B C VDD VSS
*.PININFO A:I B:I C:I X:O VDD:B VSS:B
MN2 net3 C VSS VSS sg13_lv_nmos m=1 w=640.00n l=130.00n ng=1
MN3 X net2 VSS VSS sg13_lv_nmos m=1 w=1.48u l=130.00n ng=2
MN0 net2 A net1 VSS sg13_lv_nmos m=1 w=640.00n l=130.00n ng=1
MN1 net1 B net3 VSS sg13_lv_nmos m=1 w=640.00n l=130.00n ng=1
MP3 X net2 VDD VDD sg13_lv_pmos m=1 w=2.24u l=130.00n ng=2
MP1 net2 B VDD VDD sg13_lv_pmos m=1 w=840.00n l=130.00n ng=1
MP2 net2 A VDD VDD sg13_lv_pmos m=1 w=840.00n l=130.00n ng=1
MP0 net2 C VDD VDD sg13_lv_pmos m=1 w=840.00n l=130.00n ng=1
.ENDS

************************************************************************
* Library Name: sg13g2_stdcell
* Cell Name:    sg13g2_and4_1
* View Name:    schematic
************************************************************************

.SUBCKT sg13g2_and4_1 X A B C D VDD VSS
*.PININFO A:I B:I C:I D:I X:O VDD:B VSS:B
MN3 net17 D VSS VSS sg13_lv_nmos m=1 w=640.00n l=130.00n ng=1
MN2 net16 C net17 VSS sg13_lv_nmos m=1 w=640.00n l=130.00n ng=1
MN1 net15 B net16 VSS sg13_lv_nmos m=1 w=640.00n l=130.00n ng=1
MN0 net1 A net15 VSS sg13_lv_nmos m=1 w=640.00n l=130.00n ng=1
MN4 X net1 VSS VSS sg13_lv_nmos m=1 w=740.00n l=130.00n ng=1
MP3 net1 A VDD VDD sg13_lv_pmos m=1 w=840.00n l=130.00n ng=1
MP4 X net1 VDD VDD sg13_lv_pmos m=1 w=1.12u l=130.00n ng=1
MP0 net1 D VDD VDD sg13_lv_pmos m=1 w=840.00n l=130.00n ng=1
MP1 net1 C VDD VDD sg13_lv_pmos m=1 w=840.00n l=130.00n ng=1
MP2 net1 B VDD VDD sg13_lv_pmos m=1 w=840.00n l=130.00n ng=1
.ENDS

************************************************************************
* Library Name: sg13g2_stdcell
* Cell Name:    sg13g2_and4_2
* View Name:    schematic
************************************************************************

.SUBCKT sg13g2_and4_2 X A B C D VDD VSS
*.PININFO A:I B:I C:I D:I X:O VDD:B VSS:B
MN3 net17 D VSS VSS sg13_lv_nmos m=1 w=640.00n l=130.00n ng=1
MN2 net16 C net17 VSS sg13_lv_nmos m=1 w=640.00n l=130.00n ng=1
MN1 net15 B net16 VSS sg13_lv_nmos m=1 w=640.00n l=130.00n ng=1
MN0 net1 A net15 VSS sg13_lv_nmos m=1 w=640.00n l=130.00n ng=1
MN4 X net1 VSS VSS sg13_lv_nmos m=1 w=1.48u l=130.00n ng=2
MP3 net1 A VDD VDD sg13_lv_pmos m=1 w=840.00n l=130.00n ng=1
MP4 X net1 VDD VDD sg13_lv_pmos m=1 w=2.24u l=130.00n ng=2
MP0 net1 D VDD VDD sg13_lv_pmos m=1 w=840.00n l=130.00n ng=1
MP1 net1 C VDD VDD sg13_lv_pmos m=1 w=840.00n l=130.00n ng=1
MP2 net1 B VDD VDD sg13_lv_pmos m=1 w=840.00n l=130.00n ng=1
.ENDS

************************************************************************
* Library Name: sg13g2_stdcell
* Cell Name:    sg13g2_antennanp
* View Name:    schematic
************************************************************************

.SUBCKT sg13g2_antennanp A VDD VSS
*.PININFO A:I VDD:B VSS:B
DD1 VSS A dantenna m=1 w=780n l=780n a=608.4f p=3.12u
DD0 A VDD dpantenna m=1 w=1.05u l=1.34u a=1.407p p=4.78u
.ENDS

************************************************************************
* Library Name: sg13g2_stdcell
* Cell Name:    sg13g2_buf_1
* View Name:    schematic
************************************************************************

.SUBCKT sg13g2_buf_1 X A VDD VSS
*.PININFO A:I X:O VDD:B VSS:B
MN0 net1 A VSS VSS sg13_lv_nmos m=1 w=550.00n l=130.00n ng=1
MN1 X net1 VSS VSS sg13_lv_nmos m=1 w=740.00n l=130.00n ng=1
MP1 X net1 VDD VDD sg13_lv_pmos m=1 w=1.12u l=130.00n ng=1
MP0 net1 A VDD VDD sg13_lv_pmos m=1 w=840.00n l=130.00n ng=1
.ENDS

************************************************************************
* Library Name: sg13g2_stdcell
* Cell Name:    sg13g2_buf_16
* View Name:    schematic
************************************************************************

.SUBCKT sg13g2_buf_16 X A VDD VSS
*.PININFO A:I X:O VDD:B VSS:B
MN0 net1 A VSS VSS sg13_lv_nmos m=1 w=4.44u l=130.00n ng=6
MN1 X net1 VSS VSS sg13_lv_nmos m=1 w=11.84u l=130.00n ng=16
MP1 X net1 VDD VDD sg13_lv_pmos m=1 w=17.92u l=130.00n ng=16
MP0 net1 A VDD VDD sg13_lv_pmos m=1 w=6.72u l=130.00n ng=6
.ENDS

************************************************************************
* Library Name: sg13g2_stdcell
* Cell Name:    sg13g2_buf_2
* View Name:    schematic
************************************************************************

.SUBCKT sg13g2_buf_2 X A VDD VSS
*.PININFO A:I X:O VDD:B VSS:B
MN0 net1 A VSS VSS sg13_lv_nmos m=1 w=640.00n l=130.00n ng=1
MN1 X net1 VSS VSS sg13_lv_nmos m=1 w=1.48u l=130.00n ng=2
MP1 X net1 VDD VDD sg13_lv_pmos m=1 w=2.24u l=130.00n ng=2
MP0 net1 A VDD VDD sg13_lv_pmos m=1 w=1.000u l=130.00n ng=1
.ENDS

************************************************************************
* Library Name: sg13g2_stdcell
* Cell Name:    sg13g2_buf_4
* View Name:    schematic
************************************************************************

.SUBCKT sg13g2_buf_4 X A VDD VSS
*.PININFO A:I X:O VDD:B VSS:B
MN0 net1 A VSS VSS sg13_lv_nmos m=1 w=740.00n l=130.00n ng=1
MN1 X net1 VSS VSS sg13_lv_nmos m=1 w=2.96u l=130.00n ng=4
MP1 X net1 VDD VDD sg13_lv_pmos m=1 w=4.48u l=130.00n ng=4
MP0 net1 A VDD VDD sg13_lv_pmos m=1 w=1.68u l=130.00n ng=2
.ENDS

************************************************************************
* Library Name: sg13g2_stdcell
* Cell Name:    sg13g2_buf_8
* View Name:    schematic
************************************************************************

.SUBCKT sg13g2_buf_8 X A VDD VSS
*.PININFO A:I X:O VDD:B VSS:B
MN0 net1 A VSS VSS sg13_lv_nmos m=1 w=2.22u l=130.00n ng=3
MN1 X net1 VSS VSS sg13_lv_nmos m=1 w=5.92u l=130.00n ng=8
MP1 X net1 VDD VDD sg13_lv_pmos m=1 w=8.96u l=130.00n ng=8
MP0 net1 A VDD VDD sg13_lv_pmos m=1 w=3.36u l=130.00n ng=3
.ENDS

************************************************************************
* Library Name: sg13g2_stdcell
* Cell Name:    sg13g2_decap_4
* View Name:    schematic
************************************************************************

.SUBCKT sg13g2_decap_4 VDD VSS
*.PININFO VDD:B VSS:B
MN0 VSS VDD VSS VSS sg13_lv_nmos m=1 w=420.00n l=1.000u ng=1
MP0 VDD VSS VDD VDD sg13_lv_pmos m=1 w=1.000u l=1.000u ng=1
.ENDS

************************************************************************
* Library Name: sg13g2_stdcell
* Cell Name:    sg13g2_decap_8
* View Name:    schematic
************************************************************************

.SUBCKT sg13g2_decap_8 VDD VSS
*.PININFO VDD:B VSS:B
MN0 VSS VDD VSS VSS sg13_lv_nmos m=1 w=840.00n l=1.000u ng=2
MP0 VDD VSS VDD VDD sg13_lv_pmos m=1 w=2.000u l=1.000u ng=2
.ENDS

************************************************************************
* Library Name: sg13g2_stdcell
* Cell Name:    sg13g2_dfrbp_1
* View Name:    schematic
************************************************************************

.SUBCKT sg13g2_dfrbp_1 Q Q_N CLK D RESET_B VDD VSS
*.PININFO CLK:I D:I RESET_B:I Q:O Q_N:O VDD:B VSS:B
MN11 net12 net2 VSS VSS sg13_lv_nmos m=1 w=420.00n l=130.00n ng=1
MN10 net5 clkneg net12 VSS sg13_lv_nmos m=1 w=420.00n l=130.00n ng=1
MN12 net2 net5 net11 VSS sg13_lv_nmos m=1 w=420.00n l=130.00n ng=1
MN13 net11 RESET_B VSS VSS sg13_lv_nmos m=1 w=420.00n l=130.00n ng=1
MN14 Q_N net5 VSS VSS sg13_lv_nmos m=1 w=740.00n l=130.00n ng=1
MN0 Db D net10 VSS sg13_lv_nmos m=1 w=420.00n l=130.00n ng=1
MN1 net10 RESET_B VSS VSS sg13_lv_nmos m=1 w=420.00n l=130.00n ng=1
MN4 Db clkneg net6 VSS sg13_lv_nmos m=1 w=420.00n l=130.00n ng=1
MN5 net6 clkpos net9 VSS sg13_lv_nmos m=1 w=420.00n l=130.00n ng=1
MN6 net9 net4 net8 VSS sg13_lv_nmos m=1 w=420.00n l=130.00n ng=1
MN7 net8 RESET_B VSS VSS sg13_lv_nmos m=1 w=420.00n l=130.00n ng=1
MN8 net4 net6 VSS VSS sg13_lv_nmos m=1 w=740.00n l=130.00n ng=1
MN2 clkneg CLK VSS VSS sg13_lv_nmos m=1 w=740.00n l=130.00n ng=1
MN9 net4 clkpos net5 VSS sg13_lv_nmos m=1 w=740.00n l=130.00n ng=1
MN3 clkpos clkneg VSS VSS sg13_lv_nmos m=1 w=740.00n l=130.00n ng=1
MN16 Q net1 VSS VSS sg13_lv_nmos m=1 w=740.00n l=130.00n ng=1
MN15 net1 net5 VSS VSS sg13_lv_nmos m=1 w=740.00n l=130.00n ng=1
MP11 net5 clkpos net3 VDD sg13_lv_pmos m=1 w=420.00n l=130.00n ng=1
MP12 net2 net5 VDD VDD sg13_lv_pmos m=1 w=420.00n l=130.00n ng=1
MP13 net2 RESET_B VDD VDD sg13_lv_pmos m=1 w=420.00n l=130.00n ng=1
MP14 Q_N net5 VDD VDD sg13_lv_pmos m=1 w=1.12u l=130.00n ng=1
MP4 Db clkpos net6 VDD sg13_lv_pmos m=1 w=420.00n l=130.00n ng=1
MP0 Db RESET_B VDD VDD sg13_lv_pmos m=1 w=420.00n l=130.00n ng=1
MP1 Db D VDD VDD sg13_lv_pmos m=1 w=420.00n l=130.00n ng=1
MP5 net7 net4 VDD VDD sg13_lv_pmos m=1 w=420.00n l=130.00n ng=1
MP6 net6 clkneg net7 VDD sg13_lv_pmos m=1 w=420.00n l=130.00n ng=1
MP7 net6 RESET_B VDD VDD sg13_lv_pmos m=1 w=420.00n l=130.00n ng=1
MP2 clkneg CLK VDD VDD sg13_lv_pmos m=1 w=1.12u l=130.00n ng=1
MP3 clkpos clkneg VDD VDD sg13_lv_pmos m=1 w=1.12u l=130.00n ng=1
MP8 net4 net6 VDD VDD sg13_lv_pmos m=1 w=1.000u l=130.00n ng=1
MP9 net4 clkneg net5 VDD sg13_lv_pmos m=1 w=1.000u l=130.00n ng=1
MP16 Q net1 VDD VDD sg13_lv_pmos m=1 w=1.12u l=130.00n ng=1
MP10 net3 net2 VDD VDD sg13_lv_pmos m=1 w=420.00n l=130.00n ng=1
MP15 net1 net5 VDD VDD sg13_lv_pmos m=1 w=1.12u l=130.00n ng=1
.ENDS

************************************************************************
* Library Name: sg13g2_stdcell
* Cell Name:    sg13g2_dfrbp_2
* View Name:    schematic
************************************************************************

.SUBCKT sg13g2_dfrbp_2 Q Q_N CLK D RESET_B VDD VSS
*.PININFO CLK:I D:I RESET_B:I Q:O Q_N:O VDD:B VSS:B
MN11 net12 net2 VSS VSS sg13_lv_nmos m=1 w=420.00n l=130.00n ng=1
MN10 net5 clkneg net12 VSS sg13_lv_nmos m=1 w=420.00n l=130.00n ng=1
MN12 net2 net5 net11 VSS sg13_lv_nmos m=1 w=420.00n l=130.00n ng=1
MN13 net11 RESET_B VSS VSS sg13_lv_nmos m=1 w=420.00n l=130.00n ng=1
MN14 Q_N net5 VSS VSS sg13_lv_nmos m=1 w=1.48u l=130.00n ng=2
MN0 Db D net10 VSS sg13_lv_nmos m=1 w=420.00n l=130.00n ng=1
MN1 net10 RESET_B VSS VSS sg13_lv_nmos m=1 w=420.00n l=130.00n ng=1
MN4 Db clkneg net6 VSS sg13_lv_nmos m=1 w=420.00n l=130.00n ng=1
MN5 net6 clkpos net9 VSS sg13_lv_nmos m=1 w=420.00n l=130.00n ng=1
MN6 net9 net4 net8 VSS sg13_lv_nmos m=1 w=420.00n l=130.00n ng=1
MN7 net8 RESET_B VSS VSS sg13_lv_nmos m=1 w=420.00n l=130.00n ng=1
MN8 net4 net6 VSS VSS sg13_lv_nmos m=1 w=740.00n l=130.00n ng=1
MN2 clkneg CLK VSS VSS sg13_lv_nmos m=1 w=740.00n l=130.00n ng=1
MN9 net4 clkpos net5 VSS sg13_lv_nmos m=1 w=740.00n l=130.00n ng=1
MN3 clkpos clkneg VSS VSS sg13_lv_nmos m=1 w=740.00n l=130.00n ng=1
MN16 Q net1 VSS VSS sg13_lv_nmos m=1 w=1.48u l=130.00n ng=2
MN15 net1 net5 VSS VSS sg13_lv_nmos m=1 w=640.00n l=130.00n ng=1
MP11 net5 clkpos net3 VDD sg13_lv_pmos m=1 w=420.00n l=130.00n ng=1
MP12 net2 net5 VDD VDD sg13_lv_pmos m=1 w=420.00n l=130.00n ng=1
MP13 net2 RESET_B VDD VDD sg13_lv_pmos m=1 w=420.00n l=130.00n ng=1
MP14 Q_N net5 VDD VDD sg13_lv_pmos m=1 w=2.24u l=130.00n ng=2
MP4 Db clkpos net6 VDD sg13_lv_pmos m=1 w=420.00n l=130.00n ng=1
MP0 Db RESET_B VDD VDD sg13_lv_pmos m=1 w=420.00n l=130.00n ng=1
MP1 Db D VDD VDD sg13_lv_pmos m=1 w=420.00n l=130.00n ng=1
MP5 net7 net4 VDD VDD sg13_lv_pmos m=1 w=420.00n l=130.00n ng=1
MP6 net6 clkneg net7 VDD sg13_lv_pmos m=1 w=420.00n l=130.00n ng=1
MP7 net6 RESET_B VDD VDD sg13_lv_pmos m=1 w=420.00n l=130.00n ng=1
MP2 clkneg CLK VDD VDD sg13_lv_pmos m=1 w=1.12u l=130.00n ng=1
MP3 clkpos clkneg VDD VDD sg13_lv_pmos m=1 w=1.12u l=130.00n ng=1
MP8 net4 net6 VDD VDD sg13_lv_pmos m=1 w=1.000u l=130.00n ng=1
MP9 net4 clkneg net5 VDD sg13_lv_pmos m=1 w=1.000u l=130.00n ng=1
MP16 Q net1 VDD VDD sg13_lv_pmos m=1 w=2.24u l=130.00n ng=2
MP10 net3 net2 VDD VDD sg13_lv_pmos m=1 w=420.00n l=130.00n ng=1
MP15 net1 net5 VDD VDD sg13_lv_pmos m=1 w=1.000u l=130.00n ng=1
.ENDS

************************************************************************
* Library Name: sg13g2_stdcell
* Cell Name:    sg13g2_dlhq_1
* View Name:    schematic
************************************************************************

.SUBCKT sg13g2_dlhq_1 Q D GATE VDD VSS
*.PININFO D:I GATE:I Q:O VDD:B VSS:B
MP8 Q qint_b VDD VDD sg13_lv_pmos m=1 w=1.12u l=130.00n ng=1
MP6 qint GATE_BB net8 VDD sg13_lv_pmos m=1 w=420.00n l=130.00n ng=1
MP7 qint_b qint VDD VDD sg13_lv_pmos m=1 w=1.12u l=130.00n ng=1
MP2 Db D VDD VDD sg13_lv_pmos m=1 w=840.00n l=130.00n ng=1
MP0 GATE_B GATE VDD VDD sg13_lv_pmos m=1 w=840.00n l=130.00n ng=1
MP1 GATE_BB GATE_B VDD VDD sg13_lv_pmos m=1 w=840.00n l=130.00n ng=1
MP5 net8 qint_b VDD VDD sg13_lv_pmos m=1 w=420.00n l=130.00n ng=1
MP4 net4 GATE_B qint VDD sg13_lv_pmos m=1 w=1.000u l=130.00n ng=1
MP3 net4 Db VDD VDD sg13_lv_pmos m=1 w=1.000u l=130.00n ng=1
MN0 GATE_B GATE VSS VSS sg13_lv_nmos m=1 w=740.00n l=130.00n ng=1
MN1 GATE_BB GATE_B VSS VSS sg13_lv_nmos m=1 w=740.00n l=130.00n ng=1
MN5 qint GATE_B net9 VSS sg13_lv_nmos m=1 w=420.00n l=130.00n ng=1
MN8 Q qint_b VSS VSS sg13_lv_nmos m=1 w=740.00n l=130.00n ng=1
MN4 net7 Db VSS VSS sg13_lv_nmos m=1 w=740.00n l=130.00n ng=1
MN6 net9 qint_b VSS VSS sg13_lv_nmos m=1 w=420.00n l=130.00n ng=1
MN7 qint_b qint VSS VSS sg13_lv_nmos m=1 w=740.00n l=130.00n ng=1
MN3 qint GATE_BB net7 VSS sg13_lv_nmos m=1 w=740.00n l=130.00n ng=1
MN2 Db D VSS VSS sg13_lv_nmos m=1 w=550.00n l=130.00n ng=1
.ENDS

************************************************************************
* Library Name: sg13g2_stdcell
* Cell Name:    sg13g2_dlhr_1
* View Name:    schematic
************************************************************************

.SUBCKT sg13g2_dlhr_1 Q Q_N D GATE RESET_B VDD VSS
*.PININFO D:I GATE:I RESET_B:I Q:O Q_N:O VDD:B VSS:B
MP8 qint_b RESET_B VDD VDD sg13_lv_pmos m=1 w=1.12u l=130.00n ng=1
MP9 Q qint_b VDD VDD sg13_lv_pmos m=1 w=1.12u l=130.00n ng=1
MP6 qint GATE_BB net11 VDD sg13_lv_pmos m=1 w=420.00n l=130.00n ng=1
MP5 net11 qint_b VDD VDD sg13_lv_pmos m=1 w=420.00n l=130.00n ng=1
MP4 qint GATE_B net2 VDD sg13_lv_pmos m=1 w=1.000u l=130.00n ng=1
MP3 net2 Db VDD VDD sg13_lv_pmos m=1 w=1.000u l=130.00n ng=1
MP2 Db D VDD VDD sg13_lv_pmos m=1 w=840.00n l=130.00n ng=1
MP0 GATE_B GATE VDD VDD sg13_lv_pmos m=1 w=840.00n l=130.00n ng=1
MP11 Q_N qintn_b VDD VDD sg13_lv_pmos m=1 w=1.12u l=130.00n ng=1
MP7 qint_b qint VDD VDD sg13_lv_pmos m=1 w=1.12u l=130.00n ng=1
MP1 GATE_BB GATE_B VDD VDD sg13_lv_pmos m=1 w=840.00n l=130.00n ng=1
MP10 qintn_b qint_b VDD VDD sg13_lv_pmos m=1 w=840.00n l=130.00n ng=1
MN7 qint_b qint net9 VSS sg13_lv_nmos m=1 w=740.00n l=130.00n ng=1
MN8 net9 RESET_B VSS VSS sg13_lv_nmos m=1 w=740.00n l=130.00n ng=1
MN5 qint GATE_B net7 VSS sg13_lv_nmos m=1 w=420.00n l=130.00n ng=1
MN6 net7 qint_b VSS VSS sg13_lv_nmos m=1 w=420.00n l=130.00n ng=1
MN9 Q qint_b VSS VSS sg13_lv_nmos m=1 w=740.00n l=130.00n ng=1
MN3 qint GATE_BB net1 VSS sg13_lv_nmos m=1 w=640.00n l=130.00n ng=1
MN4 net1 Db VSS VSS sg13_lv_nmos m=1 w=640.00n l=130.00n ng=1
MN2 Db D VSS VSS sg13_lv_nmos m=1 w=550.00n l=130.00n ng=1
MN0 GATE_B GATE VSS VSS sg13_lv_nmos m=1 w=740.00n l=130.00n ng=1
MN11 Q_N qintn_b VSS VSS sg13_lv_nmos m=1 w=740.00n l=130.00n ng=1
MN1 GATE_BB GATE_B VSS VSS sg13_lv_nmos m=1 w=740.00n l=130.00n ng=1
MN10 qintn_b qint_b VSS VSS sg13_lv_nmos m=1 w=550.00n l=130.00n ng=1
.ENDS

************************************************************************
* Library Name: sg13g2_stdcell
* Cell Name:    sg13g2_dlhrq_1
* View Name:    schematic
************************************************************************

.SUBCKT sg13g2_dlhrq_1 Q D GATE RESET_B VDD VSS
*.PININFO D:I GATE:I RESET_B:I Q:O VDD:B VSS:B
MN8 net116 RESET_B VSS VSS sg13_lv_nmos m=1 w=740.00n l=130.00n ng=1
MN9 Q qint_b VSS VSS sg13_lv_nmos m=1 w=740.00n l=130.00n ng=1
MN1 GATE_BB GATE_B VSS VSS sg13_lv_nmos m=1 w=740.00n l=130.00n ng=1
MN5 qint GATE_B net89 VSS sg13_lv_nmos m=1 w=420.00n l=130.00n ng=1
MN7 qint_b qint net116 VSS sg13_lv_nmos m=1 w=740.00n l=130.00n ng=1
MN2 Db D VSS VSS sg13_lv_nmos m=1 w=550.00n l=130.00n ng=1
MN4 net61 Db VSS VSS sg13_lv_nmos m=1 w=640.00n l=130.00n ng=1
MN3 qint GATE_BB net61 VSS sg13_lv_nmos m=1 w=640.00n l=130.00n ng=1
MN6 net89 qint_b VSS VSS sg13_lv_nmos m=1 w=420.00n l=130.00n ng=1
MN0 GATE_B GATE VSS VSS sg13_lv_nmos m=1 w=740.00n l=130.00n ng=1
MP3 net60 Db VDD VDD sg13_lv_pmos m=1 w=1.000u l=130.00n ng=1
MP8 qint_b RESET_B VDD VDD sg13_lv_pmos m=1 w=1.000u l=130.00n ng=1
MP6 qint GATE_BB net92 VDD sg13_lv_pmos m=1 w=420.00n l=130.00n ng=1
MP9 Q qint_b VDD VDD sg13_lv_pmos m=1 w=1.12u l=130.00n ng=1
MP5 net92 qint_b VDD VDD sg13_lv_pmos m=1 w=420.00n l=130.00n ng=1
MP0 GATE_B GATE VDD VDD sg13_lv_pmos m=1 w=840.00n l=130.00n ng=1
MP2 Db D VDD VDD sg13_lv_pmos m=1 w=840.00n l=130.00n ng=1
MP4 qint GATE_B net60 VDD sg13_lv_pmos m=1 w=1.000u l=130.00n ng=1
MP1 GATE_BB GATE_B VDD VDD sg13_lv_pmos m=1 w=840.00n l=130.00n ng=1
MP7 qint_b qint VDD VDD sg13_lv_pmos m=1 w=1.000u l=130.00n ng=1
.ENDS

************************************************************************
* Library Name: sg13g2_stdcell
* Cell Name:    sg13g2_dllr_1
* View Name:    schematic
************************************************************************

.SUBCKT sg13g2_dllr_1 Q Q_N D GATE_N RESET_B VDD VSS
*.PININFO D:I GATE_N:I RESET_B:I Q:O Q_N:O VDD:B VSS:B
MN2 Db D VSS VSS sg13_lv_nmos m=1 w=550.00n l=130.00n ng=1
MN0 gnb GATE_N VSS VSS sg13_lv_nmos m=1 w=740.00n l=130.00n ng=1
MN1 gnbb gnb VSS VSS sg13_lv_nmos m=1 w=740.00n l=130.00n ng=1
MN6 net89 qint_b VSS VSS sg13_lv_nmos m=1 w=420.00n l=130.00n ng=1
MN7 qint_b qint net116 VSS sg13_lv_nmos m=1 w=740.00n l=130.00n ng=1
MN8 net116 RESET_B VSS VSS sg13_lv_nmos m=1 w=740.00n l=130.00n ng=1
MN5 qint gnbb net89 VSS sg13_lv_nmos m=1 w=420.00n l=130.00n ng=1
MN11 Q_N qintn_b VSS VSS sg13_lv_nmos m=1 w=740.00n l=130.00n ng=1
MN3 qint gnb net61 VSS sg13_lv_nmos m=1 w=640.00n l=130.00n ng=1
MN10 qintn_b qint_b VSS VSS sg13_lv_nmos m=1 w=550.00n l=130.00n ng=1
MN4 net61 Db VSS VSS sg13_lv_nmos m=1 w=640.00n l=130.00n ng=1
MN9 Q qint_b VSS VSS sg13_lv_nmos m=1 w=740.00n l=130.00n ng=1
MP1 gnbb gnb VDD VDD sg13_lv_pmos m=1 w=840.00n l=130.00n ng=1
MP4 qint gnbb net60 VDD sg13_lv_pmos m=1 w=1.000u l=130.00n ng=1
MP10 qintn_b qint_b VDD VDD sg13_lv_pmos m=1 w=840.00n l=130.00n ng=1
MP11 Q_N qintn_b VDD VDD sg13_lv_pmos m=1 w=1.12u l=130.00n ng=1
MP3 net60 Db VDD VDD sg13_lv_pmos m=1 w=1.000u l=130.00n ng=1
MP5 net92 qint_b VDD VDD sg13_lv_pmos m=1 w=420.00n l=130.00n ng=1
MP8 qint_b RESET_B VDD VDD sg13_lv_pmos m=1 w=1.12u l=130.00n ng=1
MP2 Db D VDD VDD sg13_lv_pmos m=1 w=840.00n l=130.00n ng=1
MP0 gnb GATE_N VDD VDD sg13_lv_pmos m=1 w=840.00n l=130.00n ng=1
MP9 Q qint_b VDD VDD sg13_lv_pmos m=1 w=1.12u l=130.00n ng=1
MP6 qint gnb net92 VDD sg13_lv_pmos m=1 w=420.00n l=130.00n ng=1
MP7 qint_b qint VDD VDD sg13_lv_pmos m=1 w=1.12u l=130.00n ng=1
.ENDS

************************************************************************
* Library Name: sg13g2_stdcell
* Cell Name:    sg13g2_dllrq_1
* View Name:    schematic
************************************************************************

.SUBCKT sg13g2_dllrq_1 Q D GATE_N RESET_B VDD VSS
*.PININFO D:I GATE_N:I RESET_B:I Q:O VDD:B VSS:B
MN5 qint gnbb net89 VSS sg13_lv_nmos m=1 w=420.00n l=130.00n ng=1
MN3 qint gnb net61 VSS sg13_lv_nmos m=1 w=640.00n l=130.00n ng=1
MN8 net116 RESET_B VSS VSS sg13_lv_nmos m=1 w=740.00n l=130.00n ng=1
MN9 Q qint_b VSS VSS sg13_lv_nmos m=1 w=740.00n l=130.00n ng=1
MN4 net61 Db VSS VSS sg13_lv_nmos m=1 w=640.00n l=130.00n ng=1
MN6 net89 qint_b VSS VSS sg13_lv_nmos m=1 w=420.00n l=130.00n ng=1
MN7 qint_b qint net116 VSS sg13_lv_nmos m=1 w=740.00n l=130.00n ng=1
MN2 Db D VSS VSS sg13_lv_nmos m=1 w=550.00n l=130.00n ng=1
MN0 gnb GATE_N VSS VSS sg13_lv_nmos m=1 w=740.00n l=130.00n ng=1
MN1 gnbb gnb VSS VSS sg13_lv_nmos m=1 w=740.00n l=130.00n ng=1
MP3 net59 Db VDD VDD sg13_lv_pmos m=1 w=1.000u l=130.00n ng=1
MP8 qint_b RESET_B VDD VDD sg13_lv_pmos m=1 w=1.000u l=130.00n ng=1
MP0 gnb GATE_N VDD VDD sg13_lv_pmos m=1 w=840.00n l=130.00n ng=1
MP5 net92 qint_b VDD VDD sg13_lv_pmos m=1 w=420.00n l=130.00n ng=1
MP7 qint_b qint VDD VDD sg13_lv_pmos m=1 w=1.000u l=130.00n ng=1
MP9 Q qint_b VDD VDD sg13_lv_pmos m=1 w=1.12u l=130.00n ng=1
MP4 qint gnbb net59 VDD sg13_lv_pmos m=1 w=1.000u l=130.00n ng=1
MP2 Db D VDD VDD sg13_lv_pmos m=1 w=840.00n l=130.00n ng=1
MP1 gnbb gnb VDD VDD sg13_lv_pmos m=1 w=840.00n l=130.00n ng=1
MP6 qint gnb net92 VDD sg13_lv_pmos m=1 w=420.00n l=130.00n ng=1
.ENDS

************************************************************************
* Library Name: sg13g2_stdcell
* Cell Name:    sg13g2_dlygate4sd1_1
* View Name:    schematic
************************************************************************

.SUBCKT sg13g2_dlygate4sd1_1 X A VDD VSS
*.PININFO A:I X:O VDD:B VSS:B
MP3 X net3 VDD VDD sg13_lv_pmos m=1 w=1.12u l=130.00n ng=1
MP2 net3 net2 VDD VDD sg13_lv_pmos m=1 w=1.000u l=130.00n ng=1
MP1 net2 net1 VDD VDD sg13_lv_pmos m=1 w=1.000u l=130.00n ng=1
MP0 net1 A VDD VDD sg13_lv_pmos m=1 w=420.00n l=130.00n ng=1
MN3 X net3 VSS VSS sg13_lv_nmos m=1 w=740.00n l=130.00n ng=1
MN2 net3 net2 VSS VSS sg13_lv_nmos m=1 w=420.00n l=130.00n ng=1
MN1 net2 net1 VSS VSS sg13_lv_nmos m=1 w=420.00n l=130.00n ng=1
MN0 net1 A VSS VSS sg13_lv_nmos m=1 w=420.00n l=130.00n ng=1
.ENDS

************************************************************************
* Library Name: sg13g2_stdcell
* Cell Name:    sg13g2_dlygate4sd2_1
* View Name:    schematic
************************************************************************

.SUBCKT sg13g2_dlygate4sd2_1 X A VDD VSS
*.PININFO A:I X:O VDD:B VSS:B
MP3 X net3 VDD VDD sg13_lv_pmos m=1 w=1.12u l=130.00n ng=1
MP2 net3 net2 VDD VDD sg13_lv_pmos m=1 w=1.000u l=250.00n ng=1
MP1 net2 net1 VDD VDD sg13_lv_pmos m=1 w=1.000u l=250.00n ng=1
MP0 net1 A VDD VDD sg13_lv_pmos m=1 w=420.00n l=130.00n ng=1
MN3 X net3 VSS VSS sg13_lv_nmos m=1 w=740.00n l=130.00n ng=1
MN2 net3 net2 VSS VSS sg13_lv_nmos m=1 w=420.00n l=180.00n ng=1
MN1 net2 net1 VSS VSS sg13_lv_nmos m=1 w=420.00n l=180.00n ng=1
MN0 net1 A VSS VSS sg13_lv_nmos m=1 w=420.00n l=130.00n ng=1
.ENDS

************************************************************************
* Library Name: sg13g2_stdcell
* Cell Name:    sg13g2_dlygate4sd3_1
* View Name:    schematic
************************************************************************

.SUBCKT sg13g2_dlygate4sd3_1 X A VDD VSS
*.PININFO A:I X:O VDD:B VSS:B
MP3 X net3 VDD VDD sg13_lv_pmos m=1 w=1.12u l=130.00n ng=1
MP2 net3 net2 VDD VDD sg13_lv_pmos m=1 w=1.000u l=500.0n ng=1
MP1 net2 net1 VDD VDD sg13_lv_pmos m=1 w=1.000u l=500.0n ng=1
MP0 net1 A VDD VDD sg13_lv_pmos m=1 w=420.00n l=130.00n ng=1
MN3 X net3 VSS VSS sg13_lv_nmos m=1 w=740.00n l=130.00n ng=1
MN2 net3 net2 VSS VSS sg13_lv_nmos m=1 w=420.00n l=500.0n ng=1
MN1 net2 net1 VSS VSS sg13_lv_nmos m=1 w=420.00n l=500.0n ng=1
MN0 net1 A VSS VSS sg13_lv_nmos m=1 w=420.00n l=130.00n ng=1
.ENDS

************************************************************************
* Library Name: sg13g2_stdcell
* Cell Name:    sg13g2_ebufn_2
* View Name:    schematic
************************************************************************

.SUBCKT sg13g2_ebufn_2 Z A TE_B VDD VSS
*.PININFO A:I TE_B:I Z:O VDD:B VSS:B
MN3 net4 net3 VSS VSS sg13_lv_nmos m=1 w=1.48u l=130.00n ng=2
MN2 Z net1 net4 VSS sg13_lv_nmos m=1 w=1.48u l=130.00n ng=2
MN1 net3 TE_B VSS VSS sg13_lv_nmos m=1 w=640.00n l=130.00n ng=1
MN0 net1 A VSS VSS sg13_lv_nmos m=1 w=640.00n l=130.00n ng=1
MP2 net2 TE_B VDD VDD sg13_lv_pmos m=1 w=2.24u l=130.00n ng=2
MP3 Z net1 net2 VDD sg13_lv_pmos m=1 w=2.24u l=130.00n ng=2
MP1 net3 TE_B VDD VDD sg13_lv_pmos m=1 w=1.000u l=130.00n ng=1
MP0 net1 A VDD VDD sg13_lv_pmos m=1 w=1.000u l=130.00n ng=1
.ENDS

************************************************************************
* Library Name: sg13g2_stdcell
* Cell Name:    sg13g2_ebufn_4
* View Name:    schematic
************************************************************************

.SUBCKT sg13g2_ebufn_4 Z A TE_B VDD VSS
*.PININFO A:I TE_B:I Z:O VDD:B VSS:B
MN0 net23 A VSS VSS sg13_lv_nmos m=1 w=740.00n l=130.00n ng=1
MN1 net21 TE_B VSS VSS sg13_lv_nmos m=1 w=740.00n l=130.00n ng=1
MN2 Z net23 net22 VSS sg13_lv_nmos m=1 w=2.96u l=130.00n ng=4
MN3 net22 net21 VSS VSS sg13_lv_nmos m=1 w=2.96u l=130.00n ng=4
MP0 net23 A VDD VDD sg13_lv_pmos m=1 w=1.12u l=130.00n ng=1
MP1 net21 TE_B VDD VDD sg13_lv_pmos m=1 w=1.12u l=130.00n ng=1
MP3 Z net23 net24 VDD sg13_lv_pmos m=1 w=4.48u l=130.00n ng=4
MP2 net24 TE_B VDD VDD sg13_lv_pmos m=1 w=4.48u l=130.00n ng=4
.ENDS

************************************************************************
* Library Name: sg13g2_stdcell
* Cell Name:    sg13g2_ebufn_8
* View Name:    schematic
************************************************************************

.SUBCKT sg13g2_ebufn_8 Z A TE_B VDD VSS
*.PININFO A:I TE_B:I Z:O VDD:B VSS:B
MN3 net23 net22 VSS VSS sg13_lv_nmos m=1 w=5.92u l=130.00n ng=8
MN2 Z net21 net23 VSS sg13_lv_nmos m=1 w=5.92u l=130.00n ng=8
MN1 net22 TE_B VSS VSS sg13_lv_nmos m=1 w=740.00n l=130.00n ng=1
MN0 net21 A VSS VSS sg13_lv_nmos m=1 w=1.48u l=130.00n ng=2
MP2 net24 TE_B VDD VDD sg13_lv_pmos m=1 w=8.96u l=130.00n ng=8
MP3 Z net21 net24 VDD sg13_lv_pmos m=1 w=8.96u l=130.00n ng=8
MP1 net22 TE_B VDD VDD sg13_lv_pmos m=1 w=1.12u l=130.00n ng=1
MP0 net21 A VDD VDD sg13_lv_pmos m=1 w=2.24u l=130.00n ng=2
.ENDS

************************************************************************
* Library Name: sg13g2_stdcell
* Cell Name:    sg13g2_einvn_2
* View Name:    schematic
************************************************************************

.SUBCKT sg13g2_einvn_2 Z A TE_B VDD VSS
*.PININFO A:I TE_B:I Z:O VDD:B VSS:B
MN0 TE TE_B VSS VSS sg13_lv_nmos m=1 w=420.00n l=130.00n ng=1
MN2 net1 TE VSS VSS sg13_lv_nmos m=1 w=1.48u l=130.00n ng=2
MN1 Z A net1 VSS sg13_lv_nmos m=1 w=1.48u l=130.00n ng=2
MP0 TE TE_B VDD VDD sg13_lv_pmos m=1 w=640.00n l=130.00n ng=1
MP1 net2 TE_B VDD VDD sg13_lv_pmos m=1 w=2.24u l=130.00n ng=2
MP2 Z A net2 VDD sg13_lv_pmos m=1 w=2.24u l=130.00n ng=2
.ENDS

************************************************************************
* Library Name: sg13g2_stdcell
* Cell Name:    sg13g2_einvn_4
* View Name:    schematic
************************************************************************

.SUBCKT sg13g2_einvn_4 Z A TE_B VDD VSS
*.PININFO A:I TE_B:I Z:O VDD:B VSS:B
MN2 net16 TE VSS VSS sg13_lv_nmos m=1 w=2.96u l=130.00n ng=4
MN0 TE TE_B VSS VSS sg13_lv_nmos m=1 w=740.00n l=130.00n ng=1
MN1 Z A net16 VSS sg13_lv_nmos m=1 w=2.96u l=130.00n ng=4
MP0 TE TE_B VDD VDD sg13_lv_pmos m=1 w=1.12u l=130.00n ng=1
MP1 net17 TE_B VDD VDD sg13_lv_pmos m=1 w=4.48u l=130.00n ng=4
MP2 Z A net17 VDD sg13_lv_pmos m=1 w=4.48u l=130.00n ng=4
.ENDS

************************************************************************
* Library Name: sg13g2_stdcell
* Cell Name:    sg13g2_einvn_8
* View Name:    schematic
************************************************************************

.SUBCKT sg13g2_einvn_8 Z A TE_B VDD VSS
*.PININFO A:I TE_B:I Z:O VDD:B VSS:B
MN1 Z A net29 VSS sg13_lv_nmos m=1 w=5.92u l=130.00n ng=8
MN0 TE TE_B VSS VSS sg13_lv_nmos m=1 w=740.00n l=130.00n ng=1
MN2 net29 TE VSS VSS sg13_lv_nmos m=1 w=5.92u l=130.00n ng=8
MP1 net28 TE_B VDD VDD sg13_lv_pmos m=1 w=8.96u l=130.00n ng=8
MP2 Z A net28 VDD sg13_lv_pmos m=1 w=8.96u l=130.00n ng=8
MP0 TE TE_B VDD VDD sg13_lv_pmos m=1 w=1.12u l=130.00n ng=1
.ENDS

************************************************************************
* Library Name: sg13g2_stdcell
* Cell Name:    sg13g2_inv_1
* View Name:    schematic
************************************************************************

.SUBCKT sg13g2_inv_1 Y A VDD VSS
*.PININFO A:I Y:O VDD:B VSS:B
MN0 Y A VSS VSS sg13_lv_nmos m=1 w=740.00n l=130.00n ng=1
MP0 Y A VDD VDD sg13_lv_pmos m=1 w=1.12u l=130.00n ng=1
.ENDS

************************************************************************
* Library Name: sg13g2_stdcell
* Cell Name:    sg13g2_inv_16
* View Name:    schematic
************************************************************************

.SUBCKT sg13g2_inv_16 Y A VDD VSS
*.PININFO A:I Y:O VDD:B VSS:B
MN0 Y A VSS VSS sg13_lv_nmos m=1 w=11.84u l=130.00n ng=16
MP0 Y A VDD VDD sg13_lv_pmos m=1 w=17.92u l=130.00n ng=16
.ENDS

************************************************************************
* Library Name: sg13g2_stdcell
* Cell Name:    sg13g2_inv_2
* View Name:    schematic
************************************************************************

.SUBCKT sg13g2_inv_2 Y A VDD VSS
*.PININFO A:I Y:O VDD:B VSS:B
MN0 Y A VSS VSS sg13_lv_nmos m=1 w=1.48u l=130.00n ng=2
MP0 Y A VDD VDD sg13_lv_pmos m=1 w=2.24u l=130.00n ng=2
.ENDS

************************************************************************
* Library Name: sg13g2_stdcell
* Cell Name:    sg13g2_inv_4
* View Name:    schematic
************************************************************************

.SUBCKT sg13g2_inv_4 Y A VDD VSS
*.PININFO A:I Y:O VDD:B VSS:B
MP0 Y A VDD VDD sg13_lv_pmos m=1 w=4.48u l=130.00n ng=4
MN0 Y A VSS VSS sg13_lv_nmos m=1 w=2.96u l=130.00n ng=4
.ENDS

************************************************************************
* Library Name: sg13g2_stdcell
* Cell Name:    sg13g2_inv_8
* View Name:    schematic
************************************************************************

.SUBCKT sg13g2_inv_8 Y A VDD VSS
*.PININFO A:I Y:O VDD:B VSS:B
MN0 Y A VSS VSS sg13_lv_nmos m=1 w=5.92u l=130.00n ng=8
MP0 Y A VDD VDD sg13_lv_pmos m=1 w=8.96u l=130.00n ng=8
.ENDS

************************************************************************
* Library Name: sg13g2_stdcell
* Cell Name:    sg13g2_lgcp_1
* View Name:    schematic
************************************************************************

.SUBCKT sg13g2_lgcp_1 GCLK CLK GATE VDD VSS
*.PININFO CLK:I GATE:I GCLK:O VDD:B VSS:B
MP1 CLKBB CLKB VDD VDD sg13_lv_pmos m=1 w=840.00n l=130.00n ng=1
MP3 net1 CLKBB net4 VDD sg13_lv_pmos m=1 w=1.000u l=130.00n ng=1
MP4 int_GATE net1 VDD VDD sg13_lv_pmos m=1 w=1.12u l=130.00n ng=1
MP2 net4 GATE VDD VDD sg13_lv_pmos m=1 w=1.000u l=130.00n ng=1
MP8 net3 int_GATE VDD VDD sg13_lv_pmos m=1 w=840.00n l=130.00n ng=1
MP9 GCLK net3 VDD VDD sg13_lv_pmos m=1 w=1.12u l=130.00n ng=1
MP6 net1 CLKB net6 VDD sg13_lv_pmos m=1 w=420.00n l=130.00n ng=1
MP0 CLKB CLK VDD VDD sg13_lv_pmos m=1 w=840.00n l=130.00n ng=1
MP7 net3 CLK VDD VDD sg13_lv_pmos m=1 w=840.00n l=130.00n ng=1
MP5 net6 int_GATE VDD VDD sg13_lv_pmos m=1 w=420.00n l=130.00n ng=1
MN9 GCLK net3 VSS VSS sg13_lv_nmos m=1 w=740.00n l=130.00n ng=1
MN7 net3 int_GATE net5 VSS sg13_lv_nmos m=1 w=640.00n l=130.00n ng=1
MN4 int_GATE net1 VSS VSS sg13_lv_nmos m=1 w=740.00n l=130.00n ng=1
MN1 CLKBB CLKB VSS VSS sg13_lv_nmos m=1 w=740.00n l=130.00n ng=1
MN6 net7 int_GATE VSS VSS sg13_lv_nmos m=1 w=420.00n l=130.00n ng=1
MN3 net2 GATE VSS VSS sg13_lv_nmos m=1 w=640.00n l=130.00n ng=1
MN5 net1 CLKBB net7 VSS sg13_lv_nmos m=1 w=420.00n l=130.00n ng=1
MN0 CLKB CLK VSS VSS sg13_lv_nmos m=1 w=740.00n l=130.00n ng=1
MN8 net5 CLK VSS VSS sg13_lv_nmos m=1 w=640.00n l=130.00n ng=1
MN2 net1 CLKB net2 VSS sg13_lv_nmos m=1 w=640.00n l=130.00n ng=1
.ENDS

************************************************************************
* Library Name: sg13g2_stdcell
* Cell Name:    sg13g2_mux2_1
* View Name:    schematic
************************************************************************

.SUBCKT sg13g2_mux2_1 X A0 A1 S VDD VSS
*.PININFO A0:I A1:I S:I X:O VDD:B VSS:B
MP1 net4 S VDD VDD sg13_lv_pmos m=1 w=1.000u l=130.00n ng=1
MP5 X net6 VDD VDD sg13_lv_pmos m=1 w=1.12u l=130.00n ng=1
MP4 net6 A1 net5 VDD sg13_lv_pmos m=1 w=1.000u l=130.00n ng=1
MP0 Sb S VDD VDD sg13_lv_pmos m=1 w=840.00n l=130.00n ng=1
MP3 net5 Sb VDD VDD sg13_lv_pmos m=1 w=1.000u l=130.00n ng=1
MP2 net6 A0 net4 VDD sg13_lv_pmos m=1 w=1.000u l=130.00n ng=1
MN4 net3 S VSS VSS sg13_lv_nmos m=1 w=740.00n l=130.00n ng=1
MN2 net1 Sb VSS VSS sg13_lv_nmos m=1 w=740.00n l=130.00n ng=1
MN5 X net6 VSS VSS sg13_lv_nmos m=1 w=740.00n l=130.00n ng=1
MN0 Sb S VSS VSS sg13_lv_nmos m=1 w=550.00n l=130.00n ng=1
MN3 net6 A1 net3 VSS sg13_lv_nmos m=1 w=740.00n l=130.00n ng=1
MN1 net6 A0 net1 VSS sg13_lv_nmos m=1 w=740.00n l=130.00n ng=1
.ENDS

************************************************************************
* Library Name: sg13g2_stdcell
* Cell Name:    sg13g2_mux2_2
* View Name:    schematic
************************************************************************

.SUBCKT sg13g2_mux2_2 X A0 A1 S VDD VSS
*.PININFO A0:I A1:I S:I X:O VDD:B VSS:B
MP1 net4 S VDD VDD sg13_lv_pmos m=1 w=1.000u l=130.00n ng=1
MP5 X net6 VDD VDD sg13_lv_pmos m=1 w=2.24u l=130.00n ng=2
MP4 net6 A1 net5 VDD sg13_lv_pmos m=1 w=1.000u l=130.00n ng=1
MP0 Sb S VDD VDD sg13_lv_pmos m=1 w=840.00n l=130.00n ng=1
MP3 net5 Sb VDD VDD sg13_lv_pmos m=1 w=1.000u l=130.00n ng=1
MP2 net6 A0 net4 VDD sg13_lv_pmos m=1 w=1.000u l=130.00n ng=1
MN4 net3 S VSS VSS sg13_lv_nmos m=1 w=740.00n l=130.00n ng=1
MN2 net1 Sb VSS VSS sg13_lv_nmos m=1 w=740.00n l=130.00n ng=1
MN5 X net6 VSS VSS sg13_lv_nmos m=1 w=1.48u l=130.00n ng=2
MN0 Sb S VSS VSS sg13_lv_nmos m=1 w=550.00n l=130.00n ng=1
MN3 net6 A1 net3 VSS sg13_lv_nmos m=1 w=740.00n l=130.00n ng=1
MN1 net6 A0 net1 VSS sg13_lv_nmos m=1 w=740.00n l=130.00n ng=1
.ENDS

************************************************************************
* Library Name: sg13g2_stdcell
* Cell Name:    sg13g2_mux4_1
* View Name:    schematic
************************************************************************

.SUBCKT sg13g2_mux4_1 X A0 A1 A2 A3 S0 S1 VDD VSS
*.PININFO A0:I A1:I A2:I A3:I S0:I S1:I X:O VDD:B VSS:B
MN12 X Xb VSS VSS sg13_lv_nmos m=1 w=740.00n l=130.00n ng=1
MN2 low S0b net7 VSS sg13_lv_nmos m=1 w=640.00n l=130.00n ng=1
MN3 net7 A0 VSS VSS sg13_lv_nmos m=1 w=640.00n l=130.00n ng=1
MN6 low S1b Xb VSS sg13_lv_nmos m=1 w=640.00n l=130.00n ng=1
MN11 high S1 Xb VSS sg13_lv_nmos m=1 w=640.00n l=130.00n ng=1
MN10 net4 A3 VSS VSS sg13_lv_nmos m=1 w=640.00n l=130.00n ng=1
MN9 high S0 net4 VSS sg13_lv_nmos m=1 w=640.00n l=130.00n ng=1
MN8 net6 A2 VSS VSS sg13_lv_nmos m=1 w=640.00n l=130.00n ng=1
MN7 high S0b net6 VSS sg13_lv_nmos m=1 w=640.00n l=130.00n ng=1
MN5 net2 A1 VSS VSS sg13_lv_nmos m=1 w=640.00n l=130.00n ng=1
MN4 low S0 net2 VSS sg13_lv_nmos m=1 w=640.00n l=130.00n ng=1
MN1 S1b S1 VSS VSS sg13_lv_nmos m=1 w=640.00n l=130.00n ng=1
MN0 S0b S0 VSS VSS sg13_lv_nmos m=1 w=640.00n l=130.00n ng=1
MP6 low S1 Xb VDD sg13_lv_pmos m=1 w=1.000u l=130.00n ng=1
MP11 high S1b Xb VDD sg13_lv_pmos m=1 w=1.000u l=130.00n ng=1
MP12 X Xb VDD VDD sg13_lv_pmos m=1 w=1.12u l=130.00n ng=1
MP10 high S0b net3 VDD sg13_lv_pmos m=1 w=1.000u l=130.00n ng=1
MP9 net3 A3 VDD VDD sg13_lv_pmos m=1 w=1.000u l=130.00n ng=1
MP8 high S0 net5 VDD sg13_lv_pmos m=1 w=1.000u l=130.00n ng=1
MP7 net5 A2 VDD VDD sg13_lv_pmos m=1 w=1.000u l=130.00n ng=1
MP2 net8 A0 VDD VDD sg13_lv_pmos m=1 w=1.000u l=130.00n ng=1
MP3 low S0 net8 VDD sg13_lv_pmos m=1 w=1.000u l=130.00n ng=1
MP1 S1b S1 VDD VDD sg13_lv_pmos m=1 w=1.000u l=130.00n ng=1
MP0 S0b S0 VDD VDD sg13_lv_pmos m=1 w=1.000u l=130.00n ng=1
MP5 low S0b net1 VDD sg13_lv_pmos m=1 w=1.000u l=130.00n ng=1
MP4 net1 A1 VDD VDD sg13_lv_pmos m=1 w=1.000u l=130.00n ng=1
.ENDS

************************************************************************
* Library Name: sg13g2_stdcell
* Cell Name:    sg13g2_nand2_1
* View Name:    schematic
************************************************************************

.SUBCKT sg13g2_nand2_1 Y A B VDD VSS
*.PININFO A:I B:I Y:O VDD:B VSS:B
MP1 Y B VDD VDD sg13_lv_pmos m=1 w=1.12u l=130.00n ng=1
MP0 Y A VDD VDD sg13_lv_pmos m=1 w=1.12u l=130.00n ng=1
MN1 net1 B VSS VSS sg13_lv_nmos m=1 w=740.00n l=130.00n ng=1
MN0 Y A net1 VSS sg13_lv_nmos m=1 w=740.00n l=130.00n ng=1
.ENDS

************************************************************************
* Library Name: sg13g2_stdcell
* Cell Name:    sg13g2_nand2_2
* View Name:    schematic
************************************************************************

.SUBCKT sg13g2_nand2_2 Y A B VDD VSS
*.PININFO A:I B:I Y:O VDD:B VSS:B
MP1 Y B VDD VDD sg13_lv_pmos m=1 w=2.24u l=130.00n ng=2
MP0 Y A VDD VDD sg13_lv_pmos m=1 w=2.24u l=130.00n ng=2
MN1 net1 B VSS VSS sg13_lv_nmos m=1 w=1.44u l=130.00n ng=2
MN0 Y A net1 VSS sg13_lv_nmos m=1 w=1.44u l=130.00n ng=2
.ENDS

************************************************************************
* Library Name: sg13g2_stdcell
* Cell Name:    sg13g2_nand2b_1
* View Name:    schematic
************************************************************************

.SUBCKT sg13g2_nand2b_1 Y A_N B VDD VSS
*.PININFO A_N:I B:I Y:O VDD:B VSS:B
MP2 Y net2 VDD VDD sg13_lv_pmos m=1 w=1.12u l=130.00n ng=1
MP1 net2 A_N VDD VDD sg13_lv_pmos m=1 w=840.00n l=130.00n ng=1
MP0 Y B VDD VDD sg13_lv_pmos m=1 w=1.12u l=130.00n ng=1
MN1 Y net2 net1 VSS sg13_lv_nmos m=1 w=740.00n l=130.00n ng=1
MN0 net2 A_N VSS VSS sg13_lv_nmos m=1 w=550.00n l=130.00n ng=1
MN2 net1 B VSS VSS sg13_lv_nmos m=1 w=740.00n l=130.00n ng=1
.ENDS

************************************************************************
* Library Name: sg13g2_stdcell
* Cell Name:    sg13g2_nand2b_2
* View Name:    schematic
************************************************************************

.SUBCKT sg13g2_nand2b_2 Y A_N B VDD VSS
*.PININFO A_N:I B:I Y:O VDD:B VSS:B
MP2 Y A VDD VDD sg13_lv_pmos m=1 w=2.24u l=130.00n ng=2
MP0 A A_N VDD VDD sg13_lv_pmos m=1 w=840.00n l=130.00n ng=1
MP1 Y B VDD VDD sg13_lv_pmos m=1 w=2.24u l=130.00n ng=2
MN1 Y B net1 VSS sg13_lv_nmos m=1 w=1.44u l=130.00n ng=2
MN0 A A_N VSS VSS sg13_lv_nmos m=1 w=550.00n l=130.00n ng=1
MN2 net1 A VSS VSS sg13_lv_nmos m=1 w=1.44u l=130.00n ng=2
.ENDS

************************************************************************
* Library Name: sg13g2_stdcell
* Cell Name:    sg13g2_nand3_1
* View Name:    schematic
************************************************************************

.SUBCKT sg13g2_nand3_1 Y A B C VDD VSS
*.PININFO A:I B:I C:I Y:O VDD:B VSS:B
MP0 Y A VDD VDD sg13_lv_pmos m=1 w=1.12u l=130.00n ng=1
MP1 Y B VDD VDD sg13_lv_pmos m=1 w=1.12u l=130.00n ng=1
MP2 Y C VDD VDD sg13_lv_pmos m=1 w=1.12u l=130.00n ng=1
MN1 net2 B net3 VSS sg13_lv_nmos m=1 w=740.00n l=130.00n ng=1
MN2 net3 C VSS VSS sg13_lv_nmos m=1 w=740.00n l=130.00n ng=1
MN0 Y A net2 VSS sg13_lv_nmos m=1 w=740.00n l=130.00n ng=1
.ENDS

************************************************************************
* Library Name: sg13g2_stdcell
* Cell Name:    sg13g2_nand3b_1
* View Name:    schematic
************************************************************************

.SUBCKT sg13g2_nand3b_1 Y A_N B C VDD VSS
*.PININFO A_N:I B:I C:I Y:O VDD:B VSS:B
MP0 net1 A_N VDD VDD sg13_lv_pmos m=1 w=840.00n l=130.00n ng=1
MP1 Y net1 VDD VDD sg13_lv_pmos m=1 w=1.12u l=130.00n ng=1
MP2 Y B VDD VDD sg13_lv_pmos m=1 w=1.12u l=130.00n ng=1
MP3 Y C VDD VDD sg13_lv_pmos m=1 w=1.12u l=130.00n ng=1
MN2 net2 B net3 VSS sg13_lv_nmos m=1 w=740.00n l=130.00n ng=1
MN3 net3 C VSS VSS sg13_lv_nmos m=1 w=740.00n l=130.00n ng=1
MN0 net1 A_N VSS VSS sg13_lv_nmos m=1 w=550.00n l=130.00n ng=1
MN1 Y net1 net2 VSS sg13_lv_nmos m=1 w=740.00n l=130.00n ng=1
.ENDS

************************************************************************
* Library Name: sg13g2_stdcell
* Cell Name:    sg13g2_nand4_1
* View Name:    schematic
************************************************************************

.SUBCKT sg13g2_nand4_1 Y A B C D VDD VSS
*.PININFO A:I B:I C:I D:I Y:O VDD:B VSS:B
MP3 Y D VDD VDD sg13_lv_pmos m=1 w=1.12u l=130.00n ng=1
MP0 Y A VDD VDD sg13_lv_pmos m=1 w=1.12u l=130.00n ng=1
MP1 Y B VDD VDD sg13_lv_pmos m=1 w=1.12u l=130.00n ng=1
MP2 Y C VDD VDD sg13_lv_pmos m=1 w=1.12u l=130.00n ng=1
MN1 net2 B net3 VSS sg13_lv_nmos m=1 w=740.00n l=130.00n ng=1
MN2 net3 C net5 VSS sg13_lv_nmos m=1 w=740.00n l=130.00n ng=1
MN0 Y A net2 VSS sg13_lv_nmos m=1 w=740.00n l=130.00n ng=1
MN3 net5 D VSS VSS sg13_lv_nmos m=1 w=740.00n l=130.00n ng=1
.ENDS

************************************************************************
* Library Name: sg13g2_stdcell
* Cell Name:    sg13g2_nor2_1
* View Name:    schematic
************************************************************************

.SUBCKT sg13g2_nor2_1 Y A B VDD VSS
*.PININFO A:I B:I Y:O VDD:B VSS:B
MN0 Y A VSS VSS sg13_lv_nmos m=1 w=740.00n l=130.00n ng=1
MN1 Y B VSS VSS sg13_lv_nmos m=1 w=740.00n l=130.00n ng=1
MP0 net1 A VDD VDD sg13_lv_pmos m=1 w=1.12u l=130.00n ng=1
MP1 Y B net1 VDD sg13_lv_pmos m=1 w=1.12u l=130.00n ng=1
.ENDS

************************************************************************
* Library Name: sg13g2_stdcell
* Cell Name:    sg13g2_nor2_2
* View Name:    schematic
************************************************************************

.SUBCKT sg13g2_nor2_2 Y A B VDD VSS
*.PININFO A:I B:I Y:O VDD:B VSS:B
MN0 Y A VSS VSS sg13_lv_nmos m=1 w=1.48u l=130.00n ng=2
MN1 Y B VSS VSS sg13_lv_nmos m=1 w=1.48u l=130.00n ng=2
MP0 net1 A VDD VDD sg13_lv_pmos m=1 w=2.24u l=130.00n ng=2
MP1 Y B net1 VDD sg13_lv_pmos m=1 w=2.24u l=130.00n ng=2
.ENDS

************************************************************************
* Library Name: sg13g2_stdcell
* Cell Name:    sg13g2_nor2b_1
* View Name:    schematic
************************************************************************

.SUBCKT sg13g2_nor2b_1 Y A B_N VDD VSS
*.PININFO A:I B_N:I Y:O VDD:B VSS:B
MN0 B B_N VSS VSS sg13_lv_nmos m=1 w=550.00n l=130.00n ng=1
MN1 Y A VSS VSS sg13_lv_nmos m=1 w=740.00n l=130.00n ng=1
MN2 Y B VSS VSS sg13_lv_nmos m=1 w=740.00n l=130.00n ng=1
MP0 B B_N VDD VDD sg13_lv_pmos m=1 w=840.00n l=130.00n ng=1
MP1 net1 B VDD VDD sg13_lv_pmos m=1 w=1.12u l=130.00n ng=1
MP2 Y A net1 VDD sg13_lv_pmos m=1 w=1.12u l=130.00n ng=1
.ENDS

************************************************************************
* Library Name: sg13g2_stdcell
* Cell Name:    sg13g2_nor2b_2
* View Name:    schematic
************************************************************************

.SUBCKT sg13g2_nor2b_2 Y A B_N VDD VSS
*.PININFO A:I B_N:I Y:O VDD:B VSS:B
MN0 B B_N VSS VSS sg13_lv_nmos m=1 w=640.00n l=130.00n ng=1
MN1 Y A VSS VSS sg13_lv_nmos m=1 w=1.44u l=130.00n ng=2
MN2 Y B VSS VSS sg13_lv_nmos m=1 w=1.44u l=130.00n ng=2
MP0 B B_N VDD VDD sg13_lv_pmos m=1 w=1.000u l=130.00n ng=1
MP1 net1 B VDD VDD sg13_lv_pmos m=1 w=2.24u l=130.00n ng=2
MP2 Y A net1 VDD sg13_lv_pmos m=1 w=2.24u l=130.00n ng=2
.ENDS

************************************************************************
* Library Name: sg13g2_stdcell
* Cell Name:    sg13g2_nor3_1
* View Name:    schematic
************************************************************************

.SUBCKT sg13g2_nor3_1 Y A B C VDD VSS
*.PININFO A:I B:I C:I Y:O VDD:B VSS:B
MP2 Y C net2 VDD sg13_lv_pmos m=1 w=1.12u l=130.00n ng=1
MP1 net2 B net3 VDD sg13_lv_pmos m=1 w=1.12u l=130.00n ng=1
MP0 net3 A VDD VDD sg13_lv_pmos m=1 w=1.12u l=130.00n ng=1
MN0 Y A VSS VSS sg13_lv_nmos m=1 w=770.00n l=130.00n ng=1
MN1 Y B VSS VSS sg13_lv_nmos m=1 w=770.00n l=130.00n ng=1
MN2 Y C VSS VSS sg13_lv_nmos m=1 w=770.00n l=130.00n ng=1
.ENDS

************************************************************************
* Library Name: sg13g2_stdcell
* Cell Name:    sg13g2_nor3_2
* View Name:    schematic
************************************************************************

.SUBCKT sg13g2_nor3_2 Y A B C VDD VSS
*.PININFO A:I B:I C:I Y:O VDD:B VSS:B
MP2 Y C net2 VDD sg13_lv_pmos m=1 w=2.24u l=130.00n ng=2
MP1 net2 B net3 VDD sg13_lv_pmos m=1 w=2.24u l=130.00n ng=2
MP0 net3 A VDD VDD sg13_lv_pmos m=1 w=2.24u l=130.00n ng=2
MN0 Y A VSS VSS sg13_lv_nmos m=1 w=1.48u l=130.00n ng=2
MN1 Y B VSS VSS sg13_lv_nmos m=1 w=1.48u l=130.00n ng=2
MN2 Y C VSS VSS sg13_lv_nmos m=1 w=1.48u l=130.00n ng=2
.ENDS

************************************************************************
* Library Name: sg13g2_stdcell
* Cell Name:    sg13g2_nor4_1
* View Name:    schematic
************************************************************************

.SUBCKT sg13g2_nor4_1 Y A B C D VDD VSS
*.PININFO A:I B:I C:I D:I Y:O VDD:B VSS:B
MP0 net3 A VDD VDD sg13_lv_pmos m=1 w=1.12u l=130.00n ng=1
MP1 net2 B net3 VDD sg13_lv_pmos m=1 w=1.12u l=130.00n ng=1
MP2 net1 C net2 VDD sg13_lv_pmos m=1 w=1.12u l=130.00n ng=1
MP3 Y D net1 VDD sg13_lv_pmos m=1 w=1.12u l=130.00n ng=1
MN0 Y A VSS VSS sg13_lv_nmos m=1 w=740.00n l=130.00n ng=1
MN3 Y D VSS VSS sg13_lv_nmos m=1 w=740.00n l=130.00n ng=1
MN1 Y B VSS VSS sg13_lv_nmos m=1 w=740.00n l=130.00n ng=1
MN2 Y C VSS VSS sg13_lv_nmos m=1 w=740.00n l=130.00n ng=1
.ENDS

************************************************************************
* Library Name: sg13g2_stdcell
* Cell Name:    sg13g2_nor4_2
* View Name:    schematic
************************************************************************

.SUBCKT sg13g2_nor4_2 Y A B C D VDD VSS
*.PININFO A:I B:I C:I D:I Y:O VDD:B VSS:B
MP0 net3 A VDD VDD sg13_lv_pmos m=1 w=2.24u l=130.00n ng=2
MP1 net2 B net3 VDD sg13_lv_pmos m=1 w=2.24u l=130.00n ng=2
MP2 net1 C net2 VDD sg13_lv_pmos m=1 w=2.24u l=130.00n ng=2
MP3 Y D net1 VDD sg13_lv_pmos m=1 w=2.24u l=130.00n ng=2
MN0 Y A VSS VSS sg13_lv_nmos m=1 w=1.48u l=130.00n ng=2
MN3 Y D VSS VSS sg13_lv_nmos m=1 w=1.48u l=130.00n ng=2
MN1 Y B VSS VSS sg13_lv_nmos m=1 w=1.48u l=130.00n ng=2
MN2 Y C VSS VSS sg13_lv_nmos m=1 w=1.48u l=130.00n ng=2
.ENDS

************************************************************************
* Library Name: sg13g2_stdcell
* Cell Name:    sg13g2_o21ai_1
* View Name:    schematic
************************************************************************

.SUBCKT sg13g2_o21ai_1 Y A1 A2 B1 VDD VSS
*.PININFO A1:I A2:I B1:I Y:O VDD:B VSS:B
MP0 net14 A1 VDD VDD sg13_lv_pmos m=1 w=1.12u l=150.00n ng=1
MP1 Y A2 net14 VDD sg13_lv_pmos m=1 w=1.12u l=150.00n ng=1
MP2 Y B1 VDD VDD sg13_lv_pmos m=1 w=1.12u l=150.00n ng=1
MN0 net1 A2 VSS VSS sg13_lv_nmos m=1 w=740.00n l=150.00n ng=1
MN2 net1 A1 VSS VSS sg13_lv_nmos m=1 w=740.00n l=150.00n ng=1
MN1 Y B1 net1 VSS sg13_lv_nmos m=1 w=740.00n l=150.00n ng=1
.ENDS

************************************************************************
* Library Name: sg13g2_stdcell
* Cell Name:    sg13g2_or2_1
* View Name:    schematic
************************************************************************

.SUBCKT sg13g2_or2_1 X A B VDD VSS
*.PININFO A:I B:I X:O VDD:B VSS:B
MP1 net2 B net3 VDD sg13_lv_pmos m=1 w=840.00n l=130.00n ng=1
MP0 net3 A VDD VDD sg13_lv_pmos m=1 w=840.00n l=130.00n ng=1
MP2 X net2 VDD VDD sg13_lv_pmos m=1 w=1.12u l=130.00n ng=1
MN1 net2 A VSS VSS sg13_lv_nmos m=1 w=550.00n l=130.00n ng=1
MN0 net2 B VSS VSS sg13_lv_nmos m=1 w=550.00n l=130.00n ng=1
MN2 X net2 VSS VSS sg13_lv_nmos m=1 w=740.00n l=130.00n ng=1
.ENDS

************************************************************************
* Library Name: sg13g2_stdcell
* Cell Name:    sg13g2_or2_2
* View Name:    schematic
************************************************************************

.SUBCKT sg13g2_or2_2 X A B VDD VSS
*.PININFO A:I B:I X:O VDD:B VSS:B
MP1 net2 B net3 VDD sg13_lv_pmos m=1 w=840.00n l=130.00n ng=1
MP0 net3 A VDD VDD sg13_lv_pmos m=1 w=840.00n l=130.00n ng=1
MP2 X net2 VDD VDD sg13_lv_pmos m=1 w=2.24u l=130.00n ng=2
MN1 net2 A VSS VSS sg13_lv_nmos m=1 w=550.00n l=130.00n ng=1
MN0 net2 B VSS VSS sg13_lv_nmos m=1 w=550.00n l=130.00n ng=1
MN2 X net2 VSS VSS sg13_lv_nmos m=1 w=1.48u l=130.00n ng=2
.ENDS

************************************************************************
* Library Name: sg13g2_stdcell
* Cell Name:    sg13g2_or3_1
* View Name:    schematic
************************************************************************

.SUBCKT sg13g2_or3_1 X A B C VDD VSS
*.PININFO A:I B:I C:I X:O VDD:B VSS:B
MN2 net1 C VSS VSS sg13_lv_nmos m=1 w=550.00n l=130.00n ng=1
MN3 X net1 VSS VSS sg13_lv_nmos m=1 w=740.00n l=130.00n ng=1
MN1 net1 B VSS VSS sg13_lv_nmos m=1 w=550.00n l=130.00n ng=1
MN0 net1 A VSS VSS sg13_lv_nmos m=1 w=550.00n l=130.00n ng=1
MP3 X net1 VDD VDD sg13_lv_pmos m=1 w=1.12u l=130.00n ng=1
MP1 net9 B net12 VDD sg13_lv_pmos m=1 w=1.000u l=130.00n ng=1
MP0 net12 A VDD VDD sg13_lv_pmos m=1 w=1.000u l=130.00n ng=1
MP2 net1 C net9 VDD sg13_lv_pmos m=1 w=1.000u l=130.00n ng=1
.ENDS

************************************************************************
* Library Name: sg13g2_stdcell
* Cell Name:    sg13g2_or3_2
* View Name:    schematic
************************************************************************

.SUBCKT sg13g2_or3_2 X A B C VDD VSS
*.PININFO A:I B:I C:I X:O VDD:B VSS:B
MN2 net1 C VSS VSS sg13_lv_nmos m=1 w=550.00n l=130.00n ng=1
MN3 X net1 VSS VSS sg13_lv_nmos m=1 w=1.48u l=130.00n ng=2
MN1 net1 B VSS VSS sg13_lv_nmos m=1 w=550.00n l=130.00n ng=1
MN0 net1 A VSS VSS sg13_lv_nmos m=1 w=550.00n l=130.00n ng=1
MP3 X net1 VDD VDD sg13_lv_pmos m=1 w=2.24u l=130.00n ng=2
MP1 net9 B net12 VDD sg13_lv_pmos m=1 w=1.000u l=130.00n ng=1
MP0 net12 A VDD VDD sg13_lv_pmos m=1 w=1.000u l=130.00n ng=1
MP2 net1 C net9 VDD sg13_lv_pmos m=1 w=1.000u l=130.00n ng=1
.ENDS

************************************************************************
* Library Name: sg13g2_stdcell
* Cell Name:    sg13g2_or4_1
* View Name:    schematic
************************************************************************

.SUBCKT sg13g2_or4_1 X A B C D VDD VSS
*.PININFO A:I B:I C:I D:I X:O VDD:B VSS:B
MN4 X net1 VSS VSS sg13_lv_nmos m=1 w=740.00n l=130.00n ng=1
MN3 net1 D VSS VSS sg13_lv_nmos m=1 w=550.00n l=130.00n ng=1
MN2 net1 C VSS VSS sg13_lv_nmos m=1 w=550.00n l=130.00n ng=1
MN1 net1 B VSS VSS sg13_lv_nmos m=1 w=550.00n l=130.00n ng=1
MN0 net1 A VSS VSS sg13_lv_nmos m=1 w=550.00n l=130.00n ng=1
MP0 net4 A VDD VDD sg13_lv_pmos m=1 w=1.000u l=130.00n ng=1
MP1 net3 B net4 VDD sg13_lv_pmos m=1 w=1.000u l=130.00n ng=1
MP2 net2 C net3 VDD sg13_lv_pmos m=1 w=1.000u l=130.00n ng=1
MP3 net1 D net2 VDD sg13_lv_pmos m=1 w=1.000u l=130.00n ng=1
MP4 X net1 VDD VDD sg13_lv_pmos m=1 w=1.12u l=130.00n ng=1
.ENDS

************************************************************************
* Library Name: sg13g2_stdcell
* Cell Name:    sg13g2_or4_2
* View Name:    schematic
************************************************************************

.SUBCKT sg13g2_or4_2 X A B C D VDD VSS
*.PININFO A:I B:I C:I D:I X:O VDD:B VSS:B
MN4 X net1 VSS VSS sg13_lv_nmos m=1 w=1.48u l=130.00n ng=2
MN3 net1 D VSS VSS sg13_lv_nmos m=1 w=550.00n l=130.00n ng=1
MN2 net1 C VSS VSS sg13_lv_nmos m=1 w=550.00n l=130.00n ng=1
MN1 net1 B VSS VSS sg13_lv_nmos m=1 w=550.00n l=130.00n ng=1
MN0 net1 A VSS VSS sg13_lv_nmos m=1 w=550.00n l=130.00n ng=1
MP0 net4 A VDD VDD sg13_lv_pmos m=1 w=1.000u l=130.00n ng=1
MP1 net3 B net4 VDD sg13_lv_pmos m=1 w=1.000u l=130.00n ng=1
MP2 net2 C net3 VDD sg13_lv_pmos m=1 w=1.000u l=130.00n ng=1
MP3 net1 D net2 VDD sg13_lv_pmos m=1 w=1.000u l=130.00n ng=1
MP4 X net1 VDD VDD sg13_lv_pmos m=1 w=2.24u l=130.00n ng=2
.ENDS

************************************************************************
* Library Name: sg13g2_stdcell
* Cell Name:    sg13g2_sdfbbp_1
* View Name:    schematic
************************************************************************

.SUBCKT sg13g2_sdfbbp_1 Q Q_N CLK D RESET_B SCD SCE SET_B VDD VSS
*.PININFO CLK:I D:I RESET_B:I SCD:I SCE:I SET_B:I Q:O Q_N:O VDD:B VSS:B
MP1 resetbb RESET_B VDD VDD sg13_lv_pmos m=1 w=640.00n l=130.00n ng=1
MP19 pre_q DbbLatch2 net8 VDD sg13_lv_pmos m=1 w=1.000u l=130.00n ng=1
MP20 pre_q SET_B VDD VDD sg13_lv_pmos m=1 w=1.000u l=130.00n ng=1
MP3 CLKbb CLKb VDD VDD sg13_lv_pmos m=1 w=1.12u l=130.00n ng=1
MP0 SCEb SCE VDD VDD sg13_lv_pmos m=1 w=640.00n l=130.00n ng=1
MP7 Db D net3 VDD sg13_lv_pmos m=1 w=640.00n l=130.00n ng=1
MP13 DbbTG CLKb net10 VDD sg13_lv_pmos m=1 w=420.00n l=130.00n ng=1
MP12 net10 DbLatchM VDD VDD sg13_lv_pmos m=1 w=420.00n l=130.00n ng=1
MP6 net3 SCE VDD VDD sg13_lv_pmos m=1 w=640.00n l=130.00n ng=1
MP21 Q_N pre_q VDD VDD sg13_lv_pmos m=1 w=1.12u l=130.00n ng=1
MP14 net1 DbLatchM VDD VDD sg13_lv_pmos m=1 w=840.00n l=130.00n ng=1
MP18 net8 resetbb VDD VDD sg13_lv_pmos m=1 w=1.000u l=130.00n ng=1
MP11 DbLatchM SET_B VDD VDD sg13_lv_pmos m=1 w=840.00n l=130.00n ng=1
MP4 net2 SCD VDD VDD sg13_lv_pmos m=1 w=640.00n l=130.00n ng=1
MP2 CLKb CLK VDD VDD sg13_lv_pmos m=1 w=1.12u l=130.00n ng=1
MP10 DbLatchM DbbTG net7 VDD sg13_lv_pmos m=1 w=840.00n l=130.00n ng=1
MP8 Db CLKbb DbbTG VDD sg13_lv_pmos m=1 w=640.00n l=130.00n ng=1
MP5 Db SCEb net2 VDD sg13_lv_pmos m=1 w=640.00n l=130.00n ng=1
MP22 pre_qb pre_q VDD VDD sg13_lv_pmos m=1 w=840.00n l=130.00n ng=1
MP9 net7 resetbb VDD VDD sg13_lv_pmos m=1 w=840.00n l=130.00n ng=1
MP16 net6 pre_q VDD VDD sg13_lv_pmos m=1 w=420.00n l=130.00n ng=1
MP17 DbbLatch2 CLKbb net6 VDD sg13_lv_pmos m=1 w=420.00n l=130.00n ng=1
MP15 DbbLatch2 CLKb net1 VDD sg13_lv_pmos m=1 w=840.00n l=130.00n ng=1
MP23 Q pre_qb VDD VDD sg13_lv_pmos m=1 w=1.12u l=130.00n ng=1
MN4 Db SCE net5 VSS sg13_lv_nmos m=1 w=420.00n l=130.00n ng=1
MN5 net5 SCD VSS VSS sg13_lv_nmos m=1 w=420.00n l=130.00n ng=1
MN18 pre_q DbbLatch2 net11 VSS sg13_lv_nmos m=1 w=740.00n l=130.00n ng=1
MN8 Db CLKb DbbTG VSS sg13_lv_nmos m=1 w=420.00n l=130.00n ng=1
MN7 net4 SCEb VSS VSS sg13_lv_nmos m=1 w=420.00n l=130.00n ng=1
MN3 CLKbb CLKb VSS VSS sg13_lv_nmos m=1 w=740.00n l=130.00n ng=1
MN1 resetbb RESET_B VSS VSS sg13_lv_nmos m=1 w=420.00n l=130.00n ng=1
MN17 net14 pre_q VSS VSS sg13_lv_nmos m=1 w=420.00n l=130.00n ng=1
MN9 DbLatchM DbbTG net12 VSS sg13_lv_nmos m=1 w=550.00n l=130.00n ng=1
MN0 SCEb SCE VSS VSS sg13_lv_nmos m=1 w=420.00n l=130.00n ng=1
MN10 net12 SET_B VSS VSS sg13_lv_nmos m=1 w=550.00n l=130.00n ng=1
MN13 net15 DbLatchM VSS VSS sg13_lv_nmos m=1 w=420.00n l=130.00n ng=1
MN19 net11 SET_B VSS VSS sg13_lv_nmos m=1 w=740.00n l=130.00n ng=1
MN12 DbbTG CLKbb net15 VSS sg13_lv_nmos m=1 w=420.00n l=130.00n ng=1
MN6 Db D net4 VSS sg13_lv_nmos m=1 w=420.00n l=130.00n ng=1
MN22 pre_qb pre_q VSS VSS sg13_lv_nmos m=1 w=550.00n l=130.00n ng=1
MN16 DbbLatch2 CLKb net14 VSS sg13_lv_nmos m=1 w=420.00n l=130.00n ng=1
MN23 Q pre_qb VSS VSS sg13_lv_nmos m=1 w=740.00n l=130.00n ng=1
MN15 net13 DbLatchM VSS VSS sg13_lv_nmos m=1 w=550.00n l=130.00n ng=1
MN2 CLKb CLK VSS VSS sg13_lv_nmos m=1 w=740.00n l=130.00n ng=1
MN14 DbbLatch2 CLKbb net13 VSS sg13_lv_nmos m=1 w=550.00n l=130.00n ng=1
MN11 DbLatchM resetbb net12 VSS sg13_lv_nmos m=1 w=550.00n l=130.00n ng=1
MN21 Q_N pre_q VSS VSS sg13_lv_nmos m=1 w=740.00n l=130.00n ng=1
MN20 pre_q resetbb net11 VSS sg13_lv_nmos m=1 w=740.00n l=130.00n ng=1
.ENDS

************************************************************************
* Library Name: sg13g2_stdcell
* Cell Name:    sg13g2_sighold
* View Name:    schematic
************************************************************************

.SUBCKT sg13g2_sighold SH VDD VSS
*.PININFO SH:B VDD:B VSS:B
MN1 net1 SH VSS VSS sg13_lv_nmos m=1 w=300.0n l=130.00n ng=1
MN0 SH net1 VSS VSS sg13_lv_nmos m=1 w=300.0n l=700.0n ng=1
MP1 net1 SH VDD VDD sg13_lv_pmos m=1 w=450.00n l=130.00n ng=1
MP0 SH net1 VDD VDD sg13_lv_pmos m=1 w=300.0n l=700.0n ng=1
.ENDS

************************************************************************
* Library Name: sg13g2_stdcell
* Cell Name:    sg13g2_slgcp_1
* View Name:    schematic
************************************************************************

.SUBCKT sg13g2_slgcp_1 GCLK CLK GATE SCE VDD VSS
*.PININFO CLK:I GATE:I SCE:I GCLK:O VDD:B VSS:B
MP10 GCLK net5 VDD VDD sg13_lv_pmos m=1 w=1.12u l=130.00n ng=1
MP4 net1 CLKbb net6 VDD sg13_lv_pmos m=1 w=840.00n l=130.00n ng=1
MP1 CLKbb CLKb VDD VDD sg13_lv_pmos m=1 w=840.00n l=130.00n ng=1
MP8 net5 int_GATE VDD VDD sg13_lv_pmos m=1 w=840.00n l=130.00n ng=1
MP2 net3 SCE VDD VDD sg13_lv_pmos m=1 w=840.00n l=130.00n ng=1
MP7 net6 CLKb net4 VDD sg13_lv_pmos m=1 w=420.00n l=130.00n ng=1
MP5 int_GATE net6 VDD VDD sg13_lv_pmos m=1 w=1.12u l=130.00n ng=1
MP0 CLKb CLK VDD VDD sg13_lv_pmos m=1 w=840.00n l=130.00n ng=1
MP9 net5 CLK VDD VDD sg13_lv_pmos m=1 w=840.00n l=130.00n ng=1
MP6 net4 int_GATE VDD VDD sg13_lv_pmos m=1 w=420.00n l=130.00n ng=1
MP3 net1 GATE net3 VDD sg13_lv_pmos m=1 w=840.00n l=130.00n ng=1
MN5 int_GATE net6 VSS VSS sg13_lv_nmos m=1 w=740.00n l=130.00n ng=1
MN9 net2 CLK VSS VSS sg13_lv_nmos m=1 w=640.00n l=130.00n ng=1
MN2 net1 SCE VSS VSS sg13_lv_nmos m=1 w=550.00n l=130.00n ng=1
MN4 net6 CLKb net1 VSS sg13_lv_nmos m=1 w=550.00n l=130.00n ng=1
MN7 net7 int_GATE VSS VSS sg13_lv_nmos m=1 w=420.00n l=130.00n ng=1
MN8 net5 int_GATE net2 VSS sg13_lv_nmos m=1 w=640.00n l=130.00n ng=1
MN10 GCLK net5 VSS VSS sg13_lv_nmos m=1 w=740.00n l=130.00n ng=1
MN1 CLKbb CLKb VSS VSS sg13_lv_nmos m=1 w=740.00n l=130.00n ng=1
MN3 net1 GATE VSS VSS sg13_lv_nmos m=1 w=550.00n l=130.00n ng=1
MN0 CLKb CLK VSS VSS sg13_lv_nmos m=1 w=740.00n l=130.00n ng=1
MN6 net6 CLKbb net7 VSS sg13_lv_nmos m=1 w=420.00n l=130.00n ng=1
.ENDS

************************************************************************
* Library Name: sg13g2_stdcell
* Cell Name:    sg13g2_tiehi
* View Name:    schematic
************************************************************************

.SUBCKT sg13g2_tiehi L_HI VDD VSS
*.PININFO L_HI:O VDD:B VSS:B
MN1 net3 net2 VSS VSS sg13_lv_nmos m=1 w=795.00n l=130.00n ng=1
MN0 net1 net1 VSS VSS sg13_lv_nmos m=1 w=300n l=130.00n ng=1
MP1 L_HI net3 VDD VDD sg13_lv_pmos m=1 w=1.155u l=130.00n ng=1
MP0 net2 net1 VDD VDD sg13_lv_pmos m=1 w=660.0n l=130.00n ng=1
.ENDS

************************************************************************
* Library Name: sg13g2_stdcell
* Cell Name:    sg13g2_tielo
* View Name:    schematic
************************************************************************

.SUBCKT sg13g2_tielo L_LO VDD VSS
*.PININFO L_LO:O VDD:B VSS:B
MN0 net3 net2 VSS VSS sg13_lv_nmos m=1 w=385.00n l=130.00n ng=1
MN1 L_LO net1 VSS VSS sg13_lv_nmos m=1 w=880.0n l=130.00n ng=1
MP0 net2 net2 VDD VDD sg13_lv_pmos m=1 w=300n l=130.00n ng=1
MP1 net1 net3 VDD VDD sg13_lv_pmos m=1 w=1.045u l=130.00n ng=1
.ENDS

************************************************************************
* Library Name: sg13g2_stdcell
* Cell Name:    sg13g2_xnor2_1
* View Name:    schematic
************************************************************************

.SUBCKT sg13g2_xnor2_1 Y A B VDD VSS
*.PININFO A:I B:I Y:O VDD:B VSS:B
MP4 Y net1 VDD VDD sg13_lv_pmos m=1 w=1.12u l=130.00n ng=1
MP3 Y B net4 VDD sg13_lv_pmos m=1 w=1.12u l=130.00n ng=1
MP2 net4 A VDD VDD sg13_lv_pmos m=1 w=1.12u l=130.00n ng=1
MP1 net1 B VDD VDD sg13_lv_pmos m=1 w=840.00n l=130.00n ng=1
MP0 net1 A VDD VDD sg13_lv_pmos m=1 w=840.00n l=130.00n ng=1
MN3 Y net1 net3 VSS sg13_lv_nmos m=1 w=740.00n l=130.00n ng=1
MN1 net2 A VSS VSS sg13_lv_nmos m=1 w=640.00n l=130.00n ng=1
MN0 net1 B net2 VSS sg13_lv_nmos m=1 w=640.00n l=130.00n ng=1
MN4 net3 B VSS VSS sg13_lv_nmos m=1 w=740.00n l=130.00n ng=1
MN2 net3 A VSS VSS sg13_lv_nmos m=1 w=740.00n l=130.00n ng=1
.ENDS

************************************************************************
* Library Name: sg13g2_stdcell
* Cell Name:    sg13g2_xor2_1
* View Name:    schematic
************************************************************************

.SUBCKT sg13g2_xor2_1 X A B VDD VSS
*.PININFO A:I B:I X:O VDD:B VSS:B
MN0 net1 A VSS VSS sg13_lv_nmos m=1 w=550.00n l=130.00n ng=1
MN3 X B net3 VSS sg13_lv_nmos m=1 w=740.00n l=130.00n ng=1
MN2 X net1 VSS VSS sg13_lv_nmos m=1 w=740.00n l=130.00n ng=1
MN4 net3 A VSS VSS sg13_lv_nmos m=1 w=740.00n l=130.00n ng=1
MN1 net1 B VSS VSS sg13_lv_nmos m=1 w=550.00n l=130.00n ng=1
MP0 net6 A VDD VDD sg13_lv_pmos m=1 w=1.000u l=130.00n ng=1
MP1 net1 B net6 VDD sg13_lv_pmos m=1 w=1.000u l=130.00n ng=1
MP2 net5 A VDD VDD sg13_lv_pmos m=1 w=1.12u l=130.00n ng=1
MP4 net5 B VDD VDD sg13_lv_pmos m=1 w=1.12u l=130.00n ng=1
MP3 X net1 net5 VDD sg13_lv_pmos m=1 w=1.12u l=130.00n ng=1
.ENDS

************************************************************************
* Library Name: sg13g2_stdcell
* Cell Name:    sg13g2_a22oi_1
* View Name:    schematic
************************************************************************

.SUBCKT sg13g2_a22oi_1 Y A1 A2 B1 B2 VDD VSS
*.PININFO A1:I A2:I B1:I B2:I Y:O VDD:B VSS:B
MN1 net1 B1 VSS VSS sg13_lv_nmos m=1 w=740.00n l=130.00n ng=1
MN0 Y B2 net1 VSS sg13_lv_nmos m=1 w=740.00n l=130.00n ng=1
MN3 net2 A2 VSS VSS sg13_lv_nmos m=1 w=740.00n l=130.00n ng=1
MN2 Y A1 net2 VSS sg13_lv_nmos m=1 w=740.00n l=130.00n ng=1
MP1 Y B1 net3 VDD sg13_lv_pmos m=1 w=1.12u l=130.00n ng=1
MP3 Y B2 net3 VDD sg13_lv_pmos m=1 w=1.12u l=130.00n ng=1
MP2 net3 A2 VDD VDD sg13_lv_pmos m=1 w=1.12u l=130.00n ng=1
MP0 net3 A1 VDD VDD sg13_lv_pmos m=1 w=1.12u l=130.00n ng=1
.ENDS

************************************************************************
* Library Name: sg13g2_stdcell
* Cell Name:    sg13g2_sdfrbpq_1
* View Name:    schematic
************************************************************************

.SUBCKT sg13g2_sdfrbpq_1 Q CLK D RESET_B SCD SCE VDD VSS
*.PININFO CLK:I D:I RESET_B:I SCD:I SCE:I Q:O VDD:B VSS:B
MN3 Db SCD net63 VSS sg13_lv_nmos m=1 w=740.00n l=130.00n ng=1
MN1 Db D net65 VSS sg13_lv_nmos m=1 w=740.00n l=130.00n ng=1
MN0 SCEb SCE VSS VSS sg13_lv_nmos m=1 w=550.00n l=130.00n ng=1
MN4 net63 SCE VSS VSS sg13_lv_nmos m=1 w=740.00n l=130.00n ng=1
MN2 net65 SCEb VSS VSS sg13_lv_nmos m=1 w=740.00n l=130.00n ng=1
MN17 net12 net2 VSS VSS sg13_lv_nmos m=1 w=420.00n l=130.00n ng=1
MN16 net5 clkneg net12 VSS sg13_lv_nmos m=1 w=420.00n l=130.00n ng=1
MN18 net2 net5 net11 VSS sg13_lv_nmos m=1 w=420.00n l=130.00n ng=1
MN19 net11 RESET_B VSS VSS sg13_lv_nmos m=1 w=420.00n l=130.00n ng=1
MN20 Q net2 VSS VSS sg13_lv_nmos m=1 w=740.00n l=130.00n ng=1
MN6 Dbbb Dbb net10 VSS sg13_lv_nmos m=1 w=420.00n l=130.00n ng=1
MN7 net10 RESET_B VSS VSS sg13_lv_nmos m=1 w=420.00n l=130.00n ng=1
MN10 Dbbb clkneg net6 VSS sg13_lv_nmos m=1 w=420.00n l=130.00n ng=1
MN11 net6 clkpos net9 VSS sg13_lv_nmos m=1 w=420.00n l=130.00n ng=1
MN12 net9 net4 net8 VSS sg13_lv_nmos m=1 w=420.00n l=130.00n ng=1
MN13 net8 RESET_B VSS VSS sg13_lv_nmos m=1 w=420.00n l=130.00n ng=1
MN14 net4 net6 VSS VSS sg13_lv_nmos m=1 w=740.00n l=130.00n ng=1
MN8 clkneg CLK VSS VSS sg13_lv_nmos m=1 w=740.00n l=130.00n ng=1
MN15 net4 clkpos net5 VSS sg13_lv_nmos m=1 w=740.00n l=130.00n ng=1
MN9 clkpos clkneg VSS VSS sg13_lv_nmos m=1 w=740.00n l=130.00n ng=1
MN5 Dbb Db VSS VSS sg13_lv_nmos m=1 w=740.00n l=130.00n ng=1
MP1 net64 SCE VDD VDD sg13_lv_pmos m=1 w=1.000u l=130.00n ng=1
MP3 net62 SCEb VDD VDD sg13_lv_pmos m=1 w=1.000u l=130.00n ng=1
MP0 SCEb SCE VDD VDD sg13_lv_pmos m=1 w=840.00n l=130.00n ng=1
MP4 Db SCD net62 VDD sg13_lv_pmos m=1 w=1.000u l=130.00n ng=1
MP2 Db D net64 VDD sg13_lv_pmos m=1 w=1.000u l=130.00n ng=1
MP17 net5 clkpos net3 VDD sg13_lv_pmos m=1 w=420.00n l=130.00n ng=1
MP18 net2 net5 VDD VDD sg13_lv_pmos m=1 w=420.00n l=130.00n ng=1
MP19 net2 RESET_B VDD VDD sg13_lv_pmos m=1 w=420.00n l=130.00n ng=1
MP20 Q net2 VDD VDD sg13_lv_pmos m=1 w=1.12u l=130.00n ng=1
MP10 Dbbb clkpos net6 VDD sg13_lv_pmos m=1 w=420.00n l=130.00n ng=1
MP6 Dbbb RESET_B VDD VDD sg13_lv_pmos m=1 w=420.00n l=130.00n ng=1
MP7 Dbbb Dbb VDD VDD sg13_lv_pmos m=1 w=420.00n l=130.00n ng=1
MP11 net7 net4 VDD VDD sg13_lv_pmos m=1 w=420.00n l=130.00n ng=1
MP12 net6 clkneg net7 VDD sg13_lv_pmos m=1 w=420.00n l=130.00n ng=1
MP13 net6 RESET_B VDD VDD sg13_lv_pmos m=1 w=420.00n l=130.00n ng=1
MP8 clkneg CLK VDD VDD sg13_lv_pmos m=1 w=1.12u l=130.00n ng=1
MP9 clkpos clkneg VDD VDD sg13_lv_pmos m=1 w=1.12u l=130.00n ng=1
MP14 net4 net6 VDD VDD sg13_lv_pmos m=1 w=1.000u l=130.00n ng=1
MP15 net4 clkneg net5 VDD sg13_lv_pmos m=1 w=1.000u l=130.00n ng=1
MP5 Dbb Db VDD VDD sg13_lv_pmos m=1 w=1.12u l=130.00n ng=1
MP16 net3 net2 VDD VDD sg13_lv_pmos m=1 w=420.00n l=130.00n ng=1
.ENDS

************************************************************************
* Library Name: sg13g2_stdcell
* Cell Name:    sg13g2_sdfrbpq_2
* View Name:    schematic
************************************************************************

.SUBCKT sg13g2_sdfrbpq_2 Q CLK D RESET_B SCD SCE VDD VSS
*.PININFO CLK:I D:I RESET_B:I SCD:I SCE:I Q:O VDD:B VSS:B
MN3 Db SCD net63 VSS sg13_lv_nmos m=1 w=740.00n l=130.00n ng=1
MN1 Db D net65 VSS sg13_lv_nmos m=1 w=740.00n l=130.00n ng=1
MN0 SCEb SCE VSS VSS sg13_lv_nmos m=1 w=550.00n l=130.00n ng=1
MN4 net63 SCE VSS VSS sg13_lv_nmos m=1 w=740.00n l=130.00n ng=1
MN2 net65 SCEb VSS VSS sg13_lv_nmos m=1 w=740.00n l=130.00n ng=1
MN5 Dbb Db VSS VSS sg13_lv_nmos m=1 w=740.00n l=130.00n ng=1
MN17 net12 net2 VSS VSS sg13_lv_nmos m=1 w=420.00n l=130.00n ng=1
MN16 net5 clkneg net12 VSS sg13_lv_nmos m=1 w=420.00n l=130.00n ng=1
MN18 net2 net5 net11 VSS sg13_lv_nmos m=1 w=420.00n l=130.00n ng=1
MN19 net11 RESET_B VSS VSS sg13_lv_nmos m=1 w=420.00n l=130.00n ng=1
MN20 Q net2 VSS VSS sg13_lv_nmos m=1 w=1.48u l=130.00n ng=2
MN6 Dbbb Dbb net10 VSS sg13_lv_nmos m=1 w=420.00n l=130.00n ng=1
MN7 net10 RESET_B VSS VSS sg13_lv_nmos m=1 w=420.00n l=130.00n ng=1
MN10 Dbbb clkneg net6 VSS sg13_lv_nmos m=1 w=420.00n l=130.00n ng=1
MN11 net6 clkpos net9 VSS sg13_lv_nmos m=1 w=420.00n l=130.00n ng=1
MN12 net9 net4 net8 VSS sg13_lv_nmos m=1 w=420.00n l=130.00n ng=1
MN13 net8 RESET_B VSS VSS sg13_lv_nmos m=1 w=420.00n l=130.00n ng=1
MN14 net4 net6 VSS VSS sg13_lv_nmos m=1 w=740.00n l=130.00n ng=1
MN8 clkneg CLK VSS VSS sg13_lv_nmos m=1 w=740.00n l=130.00n ng=1
MN15 net4 clkpos net5 VSS sg13_lv_nmos m=1 w=740.00n l=130.00n ng=1
MN9 clkpos clkneg VSS VSS sg13_lv_nmos m=1 w=740.00n l=130.00n ng=1
MP1 net64 SCE VDD VDD sg13_lv_pmos m=1 w=1.000u l=130.00n ng=1
MP3 net62 SCEb VDD VDD sg13_lv_pmos m=1 w=1.000u l=130.00n ng=1
MP0 SCEb SCE VDD VDD sg13_lv_pmos m=1 w=840.00n l=130.00n ng=1
MP4 Db SCD net62 VDD sg13_lv_pmos m=1 w=1.000u l=130.00n ng=1
MP2 Db D net64 VDD sg13_lv_pmos m=1 w=1.000u l=130.00n ng=1
MP5 Dbb Db VDD VDD sg13_lv_pmos m=1 w=1.12u l=130.00n ng=1
MP17 net5 clkpos net3 VDD sg13_lv_pmos m=1 w=420.00n l=130.00n ng=1
MP18 net2 net5 VDD VDD sg13_lv_pmos m=1 w=420.00n l=130.00n ng=1
MP19 net2 RESET_B VDD VDD sg13_lv_pmos m=1 w=420.00n l=130.00n ng=1
MP20 Q net2 VDD VDD sg13_lv_pmos m=1 w=2.24u l=130.00n ng=2
MP10 Dbbb clkpos net6 VDD sg13_lv_pmos m=1 w=420.00n l=130.00n ng=1
MP6 Dbbb RESET_B VDD VDD sg13_lv_pmos m=1 w=420.00n l=130.00n ng=1
MP7 Dbbb Dbb VDD VDD sg13_lv_pmos m=1 w=420.00n l=130.00n ng=1
MP11 net7 net4 VDD VDD sg13_lv_pmos m=1 w=420.00n l=130.00n ng=1
MP12 net6 clkneg net7 VDD sg13_lv_pmos m=1 w=420.00n l=130.00n ng=1
MP13 net6 RESET_B VDD VDD sg13_lv_pmos m=1 w=420.00n l=130.00n ng=1
MP8 clkneg CLK VDD VDD sg13_lv_pmos m=1 w=1.12u l=130.00n ng=1
MP9 clkpos clkneg VDD VDD sg13_lv_pmos m=1 w=1.12u l=130.00n ng=1
MP14 net4 net6 VDD VDD sg13_lv_pmos m=1 w=1.000u l=130.00n ng=1
MP15 net4 clkneg net5 VDD sg13_lv_pmos m=1 w=1.000u l=130.00n ng=1
MP16 net3 net2 VDD VDD sg13_lv_pmos m=1 w=420.00n l=130.00n ng=1
.ENDS

************************************************************************
* Library Name: sg13g2_stdcell
* Cell Name:    sg13g2_sdfrbp_2
* View Name:    schematic
************************************************************************

.SUBCKT sg13g2_sdfrbp_2 Q Q_N CLK D RESET_B SCD SCE VDD VSS
*.PININFO CLK:I D:I RESET_B:I SCD:I SCE:I Q:O Q_N:O VDD:B VSS:B
MN3 Db SCD net63 VSS sg13_lv_nmos m=1 w=740.00n l=130.00n ng=1
MN1 Db D net65 VSS sg13_lv_nmos m=1 w=740.00n l=130.00n ng=1
MN0 SCEb SCE VSS VSS sg13_lv_nmos m=1 w=550.00n l=130.00n ng=1
MN4 net63 SCE VSS VSS sg13_lv_nmos m=1 w=740.00n l=130.00n ng=1
MN2 net65 SCEb VSS VSS sg13_lv_nmos m=1 w=740.00n l=130.00n ng=1
MN5 Dbb Db VSS VSS sg13_lv_nmos m=1 w=740.00n l=130.00n ng=1
MN17 net12 net2 VSS VSS sg13_lv_nmos m=1 w=420.00n l=130.00n ng=1
MN16 net5 clkneg net12 VSS sg13_lv_nmos m=1 w=420.00n l=130.00n ng=1
MN18 net2 net5 net11 VSS sg13_lv_nmos m=1 w=420.00n l=130.00n ng=1
MN19 net11 RESET_B VSS VSS sg13_lv_nmos m=1 w=420.00n l=130.00n ng=1
MN20 Q_N net5 VSS VSS sg13_lv_nmos m=1 w=1.48u l=130.00n ng=2
MN6 Dbbb Dbb net10 VSS sg13_lv_nmos m=1 w=420.00n l=130.00n ng=1
MN7 net10 RESET_B VSS VSS sg13_lv_nmos m=1 w=420.00n l=130.00n ng=1
MN10 Dbbb clkneg net6 VSS sg13_lv_nmos m=1 w=420.00n l=130.00n ng=1
MN11 net6 clkpos net9 VSS sg13_lv_nmos m=1 w=420.00n l=130.00n ng=1
MN12 net9 net4 net8 VSS sg13_lv_nmos m=1 w=420.00n l=130.00n ng=1
MN13 net8 RESET_B VSS VSS sg13_lv_nmos m=1 w=420.00n l=130.00n ng=1
MN14 net4 net6 VSS VSS sg13_lv_nmos m=1 w=740.00n l=130.00n ng=1
MN8 clkneg CLK VSS VSS sg13_lv_nmos m=1 w=740.00n l=130.00n ng=1
MN15 net4 clkpos net5 VSS sg13_lv_nmos m=1 w=740.00n l=130.00n ng=1
MN9 clkpos clkneg VSS VSS sg13_lv_nmos m=1 w=740.00n l=130.00n ng=1
MN22 Q net1 VSS VSS sg13_lv_nmos m=1 w=1.48u l=130.00n ng=2
MN21 net1 net5 VSS VSS sg13_lv_nmos m=1 w=640.00n l=130.00n ng=1
MP1 net64 SCE VDD VDD sg13_lv_pmos m=1 w=1.000u l=130.00n ng=1
MP3 net62 SCEb VDD VDD sg13_lv_pmos m=1 w=1.000u l=130.00n ng=1
MP0 SCEb SCE VDD VDD sg13_lv_pmos m=1 w=840.00n l=130.00n ng=1
MP4 Db SCD net62 VDD sg13_lv_pmos m=1 w=1.000u l=130.00n ng=1
MP2 Db D net64 VDD sg13_lv_pmos m=1 w=1.000u l=130.00n ng=1
MP5 Dbb Db VDD VDD sg13_lv_pmos m=1 w=1.12u l=130.00n ng=1
MP17 net5 clkpos net3 VDD sg13_lv_pmos m=1 w=420.00n l=130.00n ng=1
MP18 net2 net5 VDD VDD sg13_lv_pmos m=1 w=420.00n l=130.00n ng=1
MP19 net2 RESET_B VDD VDD sg13_lv_pmos m=1 w=420.00n l=130.00n ng=1
MP20 Q_N net5 VDD VDD sg13_lv_pmos m=1 w=2.24u l=130.00n ng=2
MP10 Dbbb clkpos net6 VDD sg13_lv_pmos m=1 w=420.00n l=130.00n ng=1
MP6 Dbbb RESET_B VDD VDD sg13_lv_pmos m=1 w=420.00n l=130.00n ng=1
MP7 Dbbb Dbb VDD VDD sg13_lv_pmos m=1 w=420.00n l=130.00n ng=1
MP11 net7 net4 VDD VDD sg13_lv_pmos m=1 w=420.00n l=130.00n ng=1
MP12 net6 clkneg net7 VDD sg13_lv_pmos m=1 w=420.00n l=130.00n ng=1
MP13 net6 RESET_B VDD VDD sg13_lv_pmos m=1 w=420.00n l=130.00n ng=1
MP8 clkneg CLK VDD VDD sg13_lv_pmos m=1 w=1.12u l=130.00n ng=1
MP9 clkpos clkneg VDD VDD sg13_lv_pmos m=1 w=1.12u l=130.00n ng=1
MP14 net4 net6 VDD VDD sg13_lv_pmos m=1 w=1.000u l=130.00n ng=1
MP15 net4 clkneg net5 VDD sg13_lv_pmos m=1 w=1.000u l=130.00n ng=1
MP22 Q net1 VDD VDD sg13_lv_pmos m=1 w=2.24u l=130.00n ng=2
MP16 net3 net2 VDD VDD sg13_lv_pmos m=1 w=420.00n l=130.00n ng=1
MP21 net1 net5 VDD VDD sg13_lv_pmos m=1 w=1.000u l=130.00n ng=1
.ENDS

************************************************************************
* Library Name: sg13g2_stdcell
* Cell Name:    sg13g2_sdfrbp_1
* View Name:    schematic
************************************************************************

.SUBCKT sg13g2_sdfrbp_1 Q Q_N CLK D RESET_B SCD SCE VDD VSS
*.PININFO CLK:I D:I RESET_B:I SCD:I SCE:I Q:O Q_N:O VDD:B VSS:B
MN3 Db SCD net63 VSS sg13_lv_nmos m=1 w=740.00n l=130.00n ng=1
MN1 Db D net65 VSS sg13_lv_nmos m=1 w=740.00n l=130.00n ng=1
MN0 SCEb SCE VSS VSS sg13_lv_nmos m=1 w=550.00n l=130.00n ng=1
MN4 net63 SCE VSS VSS sg13_lv_nmos m=1 w=740.00n l=130.00n ng=1
MN2 net65 SCEb VSS VSS sg13_lv_nmos m=1 w=740.00n l=130.00n ng=1
MN5 net13 Db VSS VSS sg13_lv_nmos m=1 w=740.00n l=130.00n ng=1
MN17 net12 net2 VSS VSS sg13_lv_nmos m=1 w=420.00n l=130.00n ng=1
MN16 net5 clkneg net12 VSS sg13_lv_nmos m=1 w=420.00n l=130.00n ng=1
MN18 net2 net5 net11 VSS sg13_lv_nmos m=1 w=420.00n l=130.00n ng=1
MN19 net11 RESET_B VSS VSS sg13_lv_nmos m=1 w=420.00n l=130.00n ng=1
MN20 Q_N net5 VSS VSS sg13_lv_nmos m=1 w=740.00n l=130.00n ng=1
MN6 Dbb net13 net10 VSS sg13_lv_nmos m=1 w=420.00n l=130.00n ng=1
MN7 net10 RESET_B VSS VSS sg13_lv_nmos m=1 w=420.00n l=130.00n ng=1
MN10 Dbb clkneg net6 VSS sg13_lv_nmos m=1 w=420.00n l=130.00n ng=1
MN11 net6 clkpos net9 VSS sg13_lv_nmos m=1 w=420.00n l=130.00n ng=1
MN12 net9 net4 net8 VSS sg13_lv_nmos m=1 w=420.00n l=130.00n ng=1
MN13 net8 RESET_B VSS VSS sg13_lv_nmos m=1 w=420.00n l=130.00n ng=1
MN14 net4 net6 VSS VSS sg13_lv_nmos m=1 w=740.00n l=130.00n ng=1
MN8 clkneg CLK VSS VSS sg13_lv_nmos m=1 w=740.00n l=130.00n ng=1
MN15 net4 clkpos net5 VSS sg13_lv_nmos m=1 w=740.00n l=130.00n ng=1
MN9 clkpos clkneg VSS VSS sg13_lv_nmos m=1 w=740.00n l=130.00n ng=1
MN22 Q net1 VSS VSS sg13_lv_nmos m=1 w=740.00n l=130.00n ng=1
MN21 net1 net5 VSS VSS sg13_lv_nmos m=1 w=640.00n l=130.00n ng=1
MP1 net64 SCE VDD VDD sg13_lv_pmos m=1 w=1.000u l=130.00n ng=1
MP3 net62 SCEb VDD VDD sg13_lv_pmos m=1 w=1.000u l=130.00n ng=1
MP0 SCEb SCE VDD VDD sg13_lv_pmos m=1 w=840.00n l=130.00n ng=1
MP4 Db SCD net62 VDD sg13_lv_pmos m=1 w=1.000u l=130.00n ng=1
MP2 Db D net64 VDD sg13_lv_pmos m=1 w=1.000u l=130.00n ng=1
MP5 net13 Db VDD VDD sg13_lv_pmos m=1 w=1.12u l=130.00n ng=1
MP17 net5 clkpos net3 VDD sg13_lv_pmos m=1 w=420.00n l=130.00n ng=1
MP18 net2 net5 VDD VDD sg13_lv_pmos m=1 w=420.00n l=130.00n ng=1
MP19 net2 RESET_B VDD VDD sg13_lv_pmos m=1 w=420.00n l=130.00n ng=1
MP20 Q_N net5 VDD VDD sg13_lv_pmos m=1 w=1.12u l=130.00n ng=1
MP10 Dbb clkpos net6 VDD sg13_lv_pmos m=1 w=420.00n l=130.00n ng=1
MP6 Dbb RESET_B VDD VDD sg13_lv_pmos m=1 w=420.00n l=130.00n ng=1
MP7 Dbb net13 VDD VDD sg13_lv_pmos m=1 w=420.00n l=130.00n ng=1
MP11 net7 net4 VDD VDD sg13_lv_pmos m=1 w=420.00n l=130.00n ng=1
MP12 net6 clkneg net7 VDD sg13_lv_pmos m=1 w=420.00n l=130.00n ng=1
MP13 net6 RESET_B VDD VDD sg13_lv_pmos m=1 w=420.00n l=130.00n ng=1
MP8 clkneg CLK VDD VDD sg13_lv_pmos m=1 w=1.12u l=130.00n ng=1
MP9 clkpos clkneg VDD VDD sg13_lv_pmos m=1 w=1.12u l=130.00n ng=1
MP14 net4 net6 VDD VDD sg13_lv_pmos m=1 w=1.000u l=130.00n ng=1
MP15 net4 clkneg net5 VDD sg13_lv_pmos m=1 w=1.000u l=130.00n ng=1
MP22 Q net1 VDD VDD sg13_lv_pmos m=1 w=1.12u l=130.00n ng=1
MP16 net3 net2 VDD VDD sg13_lv_pmos m=1 w=420.00n l=130.00n ng=1
MP21 net1 net5 VDD VDD sg13_lv_pmos m=1 w=1.000u l=130.00n ng=1
.ENDS

************************************************************************
* Library Name: sg13g2_stdcell
* Cell Name:    sg13g2_dfrbpq_2
* View Name:    schematic
************************************************************************

.SUBCKT sg13g2_dfrbpq_2 Q CLK D RESET_B VDD VSS
*.PININFO CLK:I D:I RESET_B:I Q:O VDD:B VSS:B
MN11 net12 net2 VSS VSS sg13_lv_nmos m=1 w=420.00n l=130.00n ng=1
MN10 net5 clkneg net12 VSS sg13_lv_nmos m=1 w=420.00n l=130.00n ng=1
MN12 net2 net5 net11 VSS sg13_lv_nmos m=1 w=420.00n l=130.00n ng=1
MN13 net11 RESET_B VSS VSS sg13_lv_nmos m=1 w=420.00n l=130.00n ng=1
MN0 Db D net10 VSS sg13_lv_nmos m=1 w=420.00n l=130.00n ng=1
MN1 net10 RESET_B VSS VSS sg13_lv_nmos m=1 w=420.00n l=130.00n ng=1
MN4 Db clkneg net6 VSS sg13_lv_nmos m=1 w=420.00n l=130.00n ng=1
MN5 net6 clkpos net9 VSS sg13_lv_nmos m=1 w=420.00n l=130.00n ng=1
MN6 net9 net4 net8 VSS sg13_lv_nmos m=1 w=420.00n l=130.00n ng=1
MN7 net8 RESET_B VSS VSS sg13_lv_nmos m=1 w=420.00n l=130.00n ng=1
MN8 net4 net6 VSS VSS sg13_lv_nmos m=1 w=740.00n l=130.00n ng=1
MN2 clkneg CLK VSS VSS sg13_lv_nmos m=1 w=740.00n l=130.00n ng=1
MN9 net4 clkpos net5 VSS sg13_lv_nmos m=1 w=740.00n l=130.00n ng=1
MN3 clkpos clkneg VSS VSS sg13_lv_nmos m=1 w=740.00n l=130.00n ng=1
MN15 Q net1 VSS VSS sg13_lv_nmos m=1 w=1.48u l=130.00n ng=2
MN14 net1 net5 VSS VSS sg13_lv_nmos m=1 w=640.00n l=130.00n ng=1
MP11 net5 clkpos net3 VDD sg13_lv_pmos m=1 w=420.00n l=130.00n ng=1
MP12 net2 net5 VDD VDD sg13_lv_pmos m=1 w=420.00n l=130.00n ng=1
MP13 net2 RESET_B VDD VDD sg13_lv_pmos m=1 w=420.00n l=130.00n ng=1
MP4 Db clkpos net6 VDD sg13_lv_pmos m=1 w=420.00n l=130.00n ng=1
MP0 Db RESET_B VDD VDD sg13_lv_pmos m=1 w=420.00n l=130.00n ng=1
MP1 Db D VDD VDD sg13_lv_pmos m=1 w=420.00n l=130.00n ng=1
MP5 net7 net4 VDD VDD sg13_lv_pmos m=1 w=420.00n l=130.00n ng=1
MP6 net6 clkneg net7 VDD sg13_lv_pmos m=1 w=420.00n l=130.00n ng=1
MP7 net6 RESET_B VDD VDD sg13_lv_pmos m=1 w=420.00n l=130.00n ng=1
MP2 clkneg CLK VDD VDD sg13_lv_pmos m=1 w=1.12u l=130.00n ng=1
MP3 clkpos clkneg VDD VDD sg13_lv_pmos m=1 w=1.12u l=130.00n ng=1
MP8 net4 net6 VDD VDD sg13_lv_pmos m=1 w=1.000u l=130.00n ng=1
MP9 net4 clkneg net5 VDD sg13_lv_pmos m=1 w=1.000u l=130.00n ng=1
MP15 Q net1 VDD VDD sg13_lv_pmos m=1 w=2.24u l=130.00n ng=2
MP10 net3 net2 VDD VDD sg13_lv_pmos m=1 w=420.00n l=130.00n ng=1
MP14 net1 net5 VDD VDD sg13_lv_pmos m=1 w=1.000u l=130.00n ng=1
.ENDS

************************************************************************
* Library Name: sg13g2_stdcell
* Cell Name:    sg13g2_dfrbpq_1
* View Name:    schematic
************************************************************************

.SUBCKT sg13g2_dfrbpq_1 Q CLK D RESET_B VDD VSS
*.PININFO CLK:I D:I RESET_B:I Q:O VDD:B VSS:B
MN11 net12 net2 VSS VSS sg13_lv_nmos m=1 w=420.00n l=130.00n ng=1
MN10 net5 clkneg net12 VSS sg13_lv_nmos m=1 w=420.00n l=130.00n ng=1
MN12 net2 net5 net11 VSS sg13_lv_nmos m=1 w=420.00n l=130.00n ng=1
MN13 net11 RESET_B VSS VSS sg13_lv_nmos m=1 w=420.00n l=130.00n ng=1
MN0 Db D net10 VSS sg13_lv_nmos m=1 w=420.00n l=130.00n ng=1
MN1 net10 RESET_B VSS VSS sg13_lv_nmos m=1 w=420.00n l=130.00n ng=1
MN4 Db clkneg net6 VSS sg13_lv_nmos m=1 w=420.00n l=130.00n ng=1
MN5 net6 clkpos net9 VSS sg13_lv_nmos m=1 w=420.00n l=130.00n ng=1
MN6 net9 net4 net8 VSS sg13_lv_nmos m=1 w=420.00n l=130.00n ng=1
MN7 net8 RESET_B VSS VSS sg13_lv_nmos m=1 w=420.00n l=130.00n ng=1
MN8 net4 net6 VSS VSS sg13_lv_nmos m=1 w=740.00n l=130.00n ng=1
MN2 clkneg CLK VSS VSS sg13_lv_nmos m=1 w=740.00n l=130.00n ng=1
MN9 net4 clkpos net5 VSS sg13_lv_nmos m=1 w=740.00n l=130.00n ng=1
MN3 clkpos clkneg VSS VSS sg13_lv_nmos m=1 w=740.00n l=130.00n ng=1
MN15 Q net1 VSS VSS sg13_lv_nmos m=1 w=740.00n l=130.00n ng=1
MN14 net1 net5 VSS VSS sg13_lv_nmos m=1 w=740.00n l=130.00n ng=1
MP11 net5 clkpos net3 VDD sg13_lv_pmos m=1 w=420.00n l=130.00n ng=1
MP12 net2 net5 VDD VDD sg13_lv_pmos m=1 w=420.00n l=130.00n ng=1
MP13 net2 RESET_B VDD VDD sg13_lv_pmos m=1 w=420.00n l=130.00n ng=1
MP4 Db clkpos net6 VDD sg13_lv_pmos m=1 w=420.00n l=130.00n ng=1
MP0 Db RESET_B VDD VDD sg13_lv_pmos m=1 w=420.00n l=130.00n ng=1
MP1 Db D VDD VDD sg13_lv_pmos m=1 w=420.00n l=130.00n ng=1
MP5 net7 net4 VDD VDD sg13_lv_pmos m=1 w=420.00n l=130.00n ng=1
MP6 net6 clkneg net7 VDD sg13_lv_pmos m=1 w=420.00n l=130.00n ng=1
MP7 net6 RESET_B VDD VDD sg13_lv_pmos m=1 w=420.00n l=130.00n ng=1
MP2 clkneg CLK VDD VDD sg13_lv_pmos m=1 w=1.12u l=130.00n ng=1
MP3 clkpos clkneg VDD VDD sg13_lv_pmos m=1 w=1.12u l=130.00n ng=1
MP8 net4 net6 VDD VDD sg13_lv_pmos m=1 w=1.000u l=130.00n ng=1
MP9 net4 clkneg net5 VDD sg13_lv_pmos m=1 w=1.000u l=130.00n ng=1
MP15 Q net1 VDD VDD sg13_lv_pmos m=1 w=1.12u l=130.00n ng=1
MP10 net3 net2 VDD VDD sg13_lv_pmos m=1 w=420.00n l=130.00n ng=1
MP14 net1 net5 VDD VDD sg13_lv_pmos m=1 w=1.12u l=130.00n ng=1
.ENDS

************************************************************************
* Library Name: sg13g2_stdcell
* Cell Name:    sg13g2_fill_1
* View Name:    schematic
************************************************************************

.SUBCKT sg13g2_fill_1 VDD VSS
*.PININFO VDD:B VSS:B
.ENDS

************************************************************************
* Library Name: sg13g2_stdcell
* Cell Name:    sg13g2_fill_2
* View Name:    schematic
************************************************************************

.SUBCKT sg13g2_fill_2 VDD VSS
*.PININFO VDD:B VSS:B
.ENDS

************************************************************************
* Library Name: sg13g2_stdcell
* Cell Name:    sg13g2_fill_4
* View Name:    schematic
************************************************************************

.SUBCKT sg13g2_fill_4 VDD VSS
*.PININFO VDD:B VSS:B
.ENDS

************************************************************************
* Library Name: sg13g2_stdcell
* Cell Name:    sg13g2_fill_8
* View Name:    schematic
************************************************************************

.SUBCKT sg13g2_fill_8 VDD VSS
*.PININFO VDD:B VSS:B
.ENDS

************************************************************************
*
* Copyright 2024 IHP PDK Authors
*
* Licensed under the Apache License, Version 2.0 (the "License");
* you may not use this file except in compliance with the License.
* You may obtain a copy of the License at
*
*    https://www.apache.org/licenses/LICENSE-2.0
*
* Unless required by applicable law or agreed to in writing, software
* distributed under the License is distributed on an "AS IS" BASIS,
* WITHOUT WARRANTIES OR CONDITIONS OF ANY KIND, either express or implied.
* See the License for the specific language governing permissions and
* limitations under the License.
*
************************************************************************

************************************************************************
* Library Name: sg13g2_io
* Cell Name:    sg13g2_DCNDiode
* View Name:    schematic
************************************************************************

.SUBCKT sg13g2_DCNDiode anode cathode guard
*.PININFO anode:B cathode:B guard:B
DD1 sub! cathode dantenna m=1 w=1.26u l=27.78u a=35.003p p=58.08u
DD0 sub! cathode dantenna m=1 w=1.26u l=27.78u a=35.003p p=58.08u
XR0 anode sub! ptap1 A=141.253p P=47.54u
.ENDS

************************************************************************
* Library Name: sg13g2_io
* Cell Name:    sg13g2_DCPDiode
* View Name:    schematic
************************************************************************

.SUBCKT sg13g2_DCPDiode anode cathode guard
*.PININFO anode:B cathode:B guard:B
DD1 anode cathode dpantenna m=1 w=1.26u l=27.78u a=35.003p p=58.08u
DD0 anode cathode dpantenna m=1 w=1.26u l=27.78u a=35.003p p=58.08u
XR0 guard sub! ptap1 A=33.524p P=23.16u
.ENDS

************************************************************************
* Library Name: sg13g2_io
* Cell Name:    sg13g2_IOPadIOVss
* View Name:    schematic
************************************************************************

.SUBCKT sg13g2_IOPadIOVss vdd vss iovdd iovss
*.PININFO iovdd:B iovss:B vdd:B vss:B
XI3 iovss iovss iovdd / sg13g2_DCNDiode
XI2 iovss iovdd iovss / sg13g2_DCPDiode
XR1 vss sub! ptap1 A=24.01p P=19.6u
XR0 iovss sub! ptap1 A=5.487n P=296.3u
.ENDS

************************************************************************
* Library Name: sg13g2_io
* Cell Name:    sg13g2_Clamp_N43N43D4R
* View Name:    schematic
************************************************************************

.SUBCKT sg13g2_Clamp_N43N43D4R gate iovss pad
*.PININFO gate:I iovss:B pad:B
MN0<1> pad gate iovss sub! sg13_hv_nmos m=1 w=4.4u l=600.0n ng=1
MN0<2> pad gate iovss sub! sg13_hv_nmos m=1 w=4.4u l=600.0n ng=1
MN0<3> pad gate iovss sub! sg13_hv_nmos m=1 w=4.4u l=600.0n ng=1
MN0<4> pad gate iovss sub! sg13_hv_nmos m=1 w=4.4u l=600.0n ng=1
MN0<5> pad gate iovss sub! sg13_hv_nmos m=1 w=4.4u l=600.0n ng=1
MN0<6> pad gate iovss sub! sg13_hv_nmos m=1 w=4.4u l=600.0n ng=1
MN0<7> pad gate iovss sub! sg13_hv_nmos m=1 w=4.4u l=600.0n ng=1
MN0<8> pad gate iovss sub! sg13_hv_nmos m=1 w=4.4u l=600.0n ng=1
MN0<9> pad gate iovss sub! sg13_hv_nmos m=1 w=4.4u l=600.0n ng=1
MN0<10> pad gate iovss sub! sg13_hv_nmos m=1 w=4.4u l=600.0n ng=1
MN0<11> pad gate iovss sub! sg13_hv_nmos m=1 w=4.4u l=600.0n ng=1
MN0<12> pad gate iovss sub! sg13_hv_nmos m=1 w=4.4u l=600.0n ng=1
MN0<13> pad gate iovss sub! sg13_hv_nmos m=1 w=4.4u l=600.0n ng=1
MN0<14> pad gate iovss sub! sg13_hv_nmos m=1 w=4.4u l=600.0n ng=1
MN0<15> pad gate iovss sub! sg13_hv_nmos m=1 w=4.4u l=600.0n ng=1
MN0<16> pad gate iovss sub! sg13_hv_nmos m=1 w=4.4u l=600.0n ng=1
MN0<17> pad gate iovss sub! sg13_hv_nmos m=1 w=4.4u l=600.0n ng=1
MN0<18> pad gate iovss sub! sg13_hv_nmos m=1 w=4.4u l=600.0n ng=1
MN0<19> pad gate iovss sub! sg13_hv_nmos m=1 w=4.4u l=600.0n ng=1
MN0<20> pad gate iovss sub! sg13_hv_nmos m=1 w=4.4u l=600.0n ng=1
MN0<21> pad gate iovss sub! sg13_hv_nmos m=1 w=4.4u l=600.0n ng=1
MN0<22> pad gate iovss sub! sg13_hv_nmos m=1 w=4.4u l=600.0n ng=1
MN0<23> pad gate iovss sub! sg13_hv_nmos m=1 w=4.4u l=600.0n ng=1
MN0<24> pad gate iovss sub! sg13_hv_nmos m=1 w=4.4u l=600.0n ng=1
MN0<25> pad gate iovss sub! sg13_hv_nmos m=1 w=4.4u l=600.0n ng=1
MN0<26> pad gate iovss sub! sg13_hv_nmos m=1 w=4.4u l=600.0n ng=1
MN0<27> pad gate iovss sub! sg13_hv_nmos m=1 w=4.4u l=600.0n ng=1
MN0<28> pad gate iovss sub! sg13_hv_nmos m=1 w=4.4u l=600.0n ng=1
MN0<29> pad gate iovss sub! sg13_hv_nmos m=1 w=4.4u l=600.0n ng=1
MN0<30> pad gate iovss sub! sg13_hv_nmos m=1 w=4.4u l=600.0n ng=1
MN0<31> pad gate iovss sub! sg13_hv_nmos m=1 w=4.4u l=600.0n ng=1
MN0<32> pad gate iovss sub! sg13_hv_nmos m=1 w=4.4u l=600.0n ng=1
MN0<33> pad gate iovss sub! sg13_hv_nmos m=1 w=4.4u l=600.0n ng=1
MN0<34> pad gate iovss sub! sg13_hv_nmos m=1 w=4.4u l=600.0n ng=1
MN0<35> pad gate iovss sub! sg13_hv_nmos m=1 w=4.4u l=600.0n ng=1
MN0<36> pad gate iovss sub! sg13_hv_nmos m=1 w=4.4u l=600.0n ng=1
MN0<37> pad gate iovss sub! sg13_hv_nmos m=1 w=4.4u l=600.0n ng=1
MN0<38> pad gate iovss sub! sg13_hv_nmos m=1 w=4.4u l=600.0n ng=1
MN0<39> pad gate iovss sub! sg13_hv_nmos m=1 w=4.4u l=600.0n ng=1
MN0<40> pad gate iovss sub! sg13_hv_nmos m=1 w=4.4u l=600.0n ng=1
MN0<41> pad gate iovss sub! sg13_hv_nmos m=1 w=4.4u l=600.0n ng=1
MN0<42> pad gate iovss sub! sg13_hv_nmos m=1 w=4.4u l=600.0n ng=1
MN0<43> pad gate iovss sub! sg13_hv_nmos m=1 w=4.4u l=600.0n ng=1
MN0<44> pad gate iovss sub! sg13_hv_nmos m=1 w=4.4u l=600.0n ng=1
MN0<45> pad gate iovss sub! sg13_hv_nmos m=1 w=4.4u l=600.0n ng=1
MN0<46> pad gate iovss sub! sg13_hv_nmos m=1 w=4.4u l=600.0n ng=1
MN0<47> pad gate iovss sub! sg13_hv_nmos m=1 w=4.4u l=600.0n ng=1
MN0<48> pad gate iovss sub! sg13_hv_nmos m=1 w=4.4u l=600.0n ng=1
MN0<49> pad gate iovss sub! sg13_hv_nmos m=1 w=4.4u l=600.0n ng=1
MN0<50> pad gate iovss sub! sg13_hv_nmos m=1 w=4.4u l=600.0n ng=1
MN0<51> pad gate iovss sub! sg13_hv_nmos m=1 w=4.4u l=600.0n ng=1
MN0<52> pad gate iovss sub! sg13_hv_nmos m=1 w=4.4u l=600.0n ng=1
MN0<53> pad gate iovss sub! sg13_hv_nmos m=1 w=4.4u l=600.0n ng=1
MN0<54> pad gate iovss sub! sg13_hv_nmos m=1 w=4.4u l=600.0n ng=1
MN0<55> pad gate iovss sub! sg13_hv_nmos m=1 w=4.4u l=600.0n ng=1
MN0<56> pad gate iovss sub! sg13_hv_nmos m=1 w=4.4u l=600.0n ng=1
MN0<57> pad gate iovss sub! sg13_hv_nmos m=1 w=4.4u l=600.0n ng=1
MN0<58> pad gate iovss sub! sg13_hv_nmos m=1 w=4.4u l=600.0n ng=1
MN0<59> pad gate iovss sub! sg13_hv_nmos m=1 w=4.4u l=600.0n ng=1
MN0<60> pad gate iovss sub! sg13_hv_nmos m=1 w=4.4u l=600.0n ng=1
MN0<61> pad gate iovss sub! sg13_hv_nmos m=1 w=4.4u l=600.0n ng=1
MN0<62> pad gate iovss sub! sg13_hv_nmos m=1 w=4.4u l=600.0n ng=1
MN0<63> pad gate iovss sub! sg13_hv_nmos m=1 w=4.4u l=600.0n ng=1
MN0<64> pad gate iovss sub! sg13_hv_nmos m=1 w=4.4u l=600.0n ng=1
MN0<65> pad gate iovss sub! sg13_hv_nmos m=1 w=4.4u l=600.0n ng=1
MN0<66> pad gate iovss sub! sg13_hv_nmos m=1 w=4.4u l=600.0n ng=1
MN0<67> pad gate iovss sub! sg13_hv_nmos m=1 w=4.4u l=600.0n ng=1
MN0<68> pad gate iovss sub! sg13_hv_nmos m=1 w=4.4u l=600.0n ng=1
MN0<69> pad gate iovss sub! sg13_hv_nmos m=1 w=4.4u l=600.0n ng=1
MN0<70> pad gate iovss sub! sg13_hv_nmos m=1 w=4.4u l=600.0n ng=1
MN0<71> pad gate iovss sub! sg13_hv_nmos m=1 w=4.4u l=600.0n ng=1
MN0<72> pad gate iovss sub! sg13_hv_nmos m=1 w=4.4u l=600.0n ng=1
MN0<73> pad gate iovss sub! sg13_hv_nmos m=1 w=4.4u l=600.0n ng=1
MN0<74> pad gate iovss sub! sg13_hv_nmos m=1 w=4.4u l=600.0n ng=1
MN0<75> pad gate iovss sub! sg13_hv_nmos m=1 w=4.4u l=600.0n ng=1
MN0<76> pad gate iovss sub! sg13_hv_nmos m=1 w=4.4u l=600.0n ng=1
MN0<77> pad gate iovss sub! sg13_hv_nmos m=1 w=4.4u l=600.0n ng=1
MN0<78> pad gate iovss sub! sg13_hv_nmos m=1 w=4.4u l=600.0n ng=1
MN0<79> pad gate iovss sub! sg13_hv_nmos m=1 w=4.4u l=600.0n ng=1
MN0<80> pad gate iovss sub! sg13_hv_nmos m=1 w=4.4u l=600.0n ng=1
MN0<81> pad gate iovss sub! sg13_hv_nmos m=1 w=4.4u l=600.0n ng=1
MN0<82> pad gate iovss sub! sg13_hv_nmos m=1 w=4.4u l=600.0n ng=1
MN0<83> pad gate iovss sub! sg13_hv_nmos m=1 w=4.4u l=600.0n ng=1
MN0<84> pad gate iovss sub! sg13_hv_nmos m=1 w=4.4u l=600.0n ng=1
MN0<85> pad gate iovss sub! sg13_hv_nmos m=1 w=4.4u l=600.0n ng=1
MN0<86> pad gate iovss sub! sg13_hv_nmos m=1 w=4.4u l=600.0n ng=1
MN0<87> pad gate iovss sub! sg13_hv_nmos m=1 w=4.4u l=600.0n ng=1
MN0<88> pad gate iovss sub! sg13_hv_nmos m=1 w=4.4u l=600.0n ng=1
MN0<89> pad gate iovss sub! sg13_hv_nmos m=1 w=4.4u l=600.0n ng=1
MN0<90> pad gate iovss sub! sg13_hv_nmos m=1 w=4.4u l=600.0n ng=1
MN0<91> pad gate iovss sub! sg13_hv_nmos m=1 w=4.4u l=600.0n ng=1
MN0<92> pad gate iovss sub! sg13_hv_nmos m=1 w=4.4u l=600.0n ng=1
MN0<93> pad gate iovss sub! sg13_hv_nmos m=1 w=4.4u l=600.0n ng=1
MN0<94> pad gate iovss sub! sg13_hv_nmos m=1 w=4.4u l=600.0n ng=1
MN0<95> pad gate iovss sub! sg13_hv_nmos m=1 w=4.4u l=600.0n ng=1
MN0<96> pad gate iovss sub! sg13_hv_nmos m=1 w=4.4u l=600.0n ng=1
MN0<97> pad gate iovss sub! sg13_hv_nmos m=1 w=4.4u l=600.0n ng=1
MN0<98> pad gate iovss sub! sg13_hv_nmos m=1 w=4.4u l=600.0n ng=1
MN0<99> pad gate iovss sub! sg13_hv_nmos m=1 w=4.4u l=600.0n ng=1
MN0<100> pad gate iovss sub! sg13_hv_nmos m=1 w=4.4u l=600.0n ng=1
MN0<101> pad gate iovss sub! sg13_hv_nmos m=1 w=4.4u l=600.0n ng=1
MN0<102> pad gate iovss sub! sg13_hv_nmos m=1 w=4.4u l=600.0n ng=1
MN0<103> pad gate iovss sub! sg13_hv_nmos m=1 w=4.4u l=600.0n ng=1
MN0<104> pad gate iovss sub! sg13_hv_nmos m=1 w=4.4u l=600.0n ng=1
MN0<105> pad gate iovss sub! sg13_hv_nmos m=1 w=4.4u l=600.0n ng=1
MN0<106> pad gate iovss sub! sg13_hv_nmos m=1 w=4.4u l=600.0n ng=1
MN0<107> pad gate iovss sub! sg13_hv_nmos m=1 w=4.4u l=600.0n ng=1
MN0<108> pad gate iovss sub! sg13_hv_nmos m=1 w=4.4u l=600.0n ng=1
MN0<109> pad gate iovss sub! sg13_hv_nmos m=1 w=4.4u l=600.0n ng=1
MN0<110> pad gate iovss sub! sg13_hv_nmos m=1 w=4.4u l=600.0n ng=1
MN0<111> pad gate iovss sub! sg13_hv_nmos m=1 w=4.4u l=600.0n ng=1
MN0<112> pad gate iovss sub! sg13_hv_nmos m=1 w=4.4u l=600.0n ng=1
MN0<113> pad gate iovss sub! sg13_hv_nmos m=1 w=4.4u l=600.0n ng=1
MN0<114> pad gate iovss sub! sg13_hv_nmos m=1 w=4.4u l=600.0n ng=1
MN0<115> pad gate iovss sub! sg13_hv_nmos m=1 w=4.4u l=600.0n ng=1
MN0<116> pad gate iovss sub! sg13_hv_nmos m=1 w=4.4u l=600.0n ng=1
MN0<117> pad gate iovss sub! sg13_hv_nmos m=1 w=4.4u l=600.0n ng=1
MN0<118> pad gate iovss sub! sg13_hv_nmos m=1 w=4.4u l=600.0n ng=1
MN0<119> pad gate iovss sub! sg13_hv_nmos m=1 w=4.4u l=600.0n ng=1
MN0<120> pad gate iovss sub! sg13_hv_nmos m=1 w=4.4u l=600.0n ng=1
MN0<121> pad gate iovss sub! sg13_hv_nmos m=1 w=4.4u l=600.0n ng=1
MN0<122> pad gate iovss sub! sg13_hv_nmos m=1 w=4.4u l=600.0n ng=1
MN0<123> pad gate iovss sub! sg13_hv_nmos m=1 w=4.4u l=600.0n ng=1
MN0<124> pad gate iovss sub! sg13_hv_nmos m=1 w=4.4u l=600.0n ng=1
MN0<125> pad gate iovss sub! sg13_hv_nmos m=1 w=4.4u l=600.0n ng=1
MN0<126> pad gate iovss sub! sg13_hv_nmos m=1 w=4.4u l=600.0n ng=1
MN0<127> pad gate iovss sub! sg13_hv_nmos m=1 w=4.4u l=600.0n ng=1
MN0<128> pad gate iovss sub! sg13_hv_nmos m=1 w=4.4u l=600.0n ng=1
MN0<129> pad gate iovss sub! sg13_hv_nmos m=1 w=4.4u l=600.0n ng=1
MN0<130> pad gate iovss sub! sg13_hv_nmos m=1 w=4.4u l=600.0n ng=1
MN0<131> pad gate iovss sub! sg13_hv_nmos m=1 w=4.4u l=600.0n ng=1
MN0<132> pad gate iovss sub! sg13_hv_nmos m=1 w=4.4u l=600.0n ng=1
MN0<133> pad gate iovss sub! sg13_hv_nmos m=1 w=4.4u l=600.0n ng=1
MN0<134> pad gate iovss sub! sg13_hv_nmos m=1 w=4.4u l=600.0n ng=1
MN0<135> pad gate iovss sub! sg13_hv_nmos m=1 w=4.4u l=600.0n ng=1
MN0<136> pad gate iovss sub! sg13_hv_nmos m=1 w=4.4u l=600.0n ng=1
MN0<137> pad gate iovss sub! sg13_hv_nmos m=1 w=4.4u l=600.0n ng=1
MN0<138> pad gate iovss sub! sg13_hv_nmos m=1 w=4.4u l=600.0n ng=1
MN0<139> pad gate iovss sub! sg13_hv_nmos m=1 w=4.4u l=600.0n ng=1
MN0<140> pad gate iovss sub! sg13_hv_nmos m=1 w=4.4u l=600.0n ng=1
MN0<141> pad gate iovss sub! sg13_hv_nmos m=1 w=4.4u l=600.0n ng=1
MN0<142> pad gate iovss sub! sg13_hv_nmos m=1 w=4.4u l=600.0n ng=1
MN0<143> pad gate iovss sub! sg13_hv_nmos m=1 w=4.4u l=600.0n ng=1
MN0<144> pad gate iovss sub! sg13_hv_nmos m=1 w=4.4u l=600.0n ng=1
MN0<145> pad gate iovss sub! sg13_hv_nmos m=1 w=4.4u l=600.0n ng=1
MN0<146> pad gate iovss sub! sg13_hv_nmos m=1 w=4.4u l=600.0n ng=1
MN0<147> pad gate iovss sub! sg13_hv_nmos m=1 w=4.4u l=600.0n ng=1
MN0<148> pad gate iovss sub! sg13_hv_nmos m=1 w=4.4u l=600.0n ng=1
MN0<149> pad gate iovss sub! sg13_hv_nmos m=1 w=4.4u l=600.0n ng=1
MN0<150> pad gate iovss sub! sg13_hv_nmos m=1 w=4.4u l=600.0n ng=1
MN0<151> pad gate iovss sub! sg13_hv_nmos m=1 w=4.4u l=600.0n ng=1
MN0<152> pad gate iovss sub! sg13_hv_nmos m=1 w=4.4u l=600.0n ng=1
MN0<153> pad gate iovss sub! sg13_hv_nmos m=1 w=4.4u l=600.0n ng=1
MN0<154> pad gate iovss sub! sg13_hv_nmos m=1 w=4.4u l=600.0n ng=1
MN0<155> pad gate iovss sub! sg13_hv_nmos m=1 w=4.4u l=600.0n ng=1
MN0<156> pad gate iovss sub! sg13_hv_nmos m=1 w=4.4u l=600.0n ng=1
MN0<157> pad gate iovss sub! sg13_hv_nmos m=1 w=4.4u l=600.0n ng=1
MN0<158> pad gate iovss sub! sg13_hv_nmos m=1 w=4.4u l=600.0n ng=1
MN0<159> pad gate iovss sub! sg13_hv_nmos m=1 w=4.4u l=600.0n ng=1
MN0<160> pad gate iovss sub! sg13_hv_nmos m=1 w=4.4u l=600.0n ng=1
MN0<161> pad gate iovss sub! sg13_hv_nmos m=1 w=4.4u l=600.0n ng=1
MN0<162> pad gate iovss sub! sg13_hv_nmos m=1 w=4.4u l=600.0n ng=1
MN0<163> pad gate iovss sub! sg13_hv_nmos m=1 w=4.4u l=600.0n ng=1
MN0<164> pad gate iovss sub! sg13_hv_nmos m=1 w=4.4u l=600.0n ng=1
MN0<165> pad gate iovss sub! sg13_hv_nmos m=1 w=4.4u l=600.0n ng=1
MN0<166> pad gate iovss sub! sg13_hv_nmos m=1 w=4.4u l=600.0n ng=1
MN0<167> pad gate iovss sub! sg13_hv_nmos m=1 w=4.4u l=600.0n ng=1
MN0<168> pad gate iovss sub! sg13_hv_nmos m=1 w=4.4u l=600.0n ng=1
MN0<169> pad gate iovss sub! sg13_hv_nmos m=1 w=4.4u l=600.0n ng=1
MN0<170> pad gate iovss sub! sg13_hv_nmos m=1 w=4.4u l=600.0n ng=1
MN0<171> pad gate iovss sub! sg13_hv_nmos m=1 w=4.4u l=600.0n ng=1
MN0<172> pad gate iovss sub! sg13_hv_nmos m=1 w=4.4u l=600.0n ng=1
XR0 iovss sub! ptap1 A=65.61p P=32.4u
DD0 sub! gate dantenna m=1 w=480n l=480n a=230.4f p=1.92u
.ENDS

************************************************************************
* Library Name: sg13g2_io
* Cell Name:    sg13g2_RCClampResistor
* View Name:    schematic
************************************************************************

.SUBCKT sg13g2_RCClampResistor pin1 pin2
*.PININFO pin1:B pin2:B
RR15 net15 net16 5.239K $SUB=sub! $[rppd] l=20u w=1u b=0 m=1
RR20 net20 net21 5.239K $SUB=sub! $[rppd] l=20u w=1u b=0 m=1
RR23 net23 net24 5.239K $SUB=sub! $[rppd] l=20u w=1u b=0 m=1
RR17 net17 net18 5.239K $SUB=sub! $[rppd] l=20u w=1u b=0 m=1
RR16 net16 net17 5.239K $SUB=sub! $[rppd] l=20u w=1u b=0 m=1
RR25 net25 pin2 5.239K $SUB=sub! $[rppd] l=20u w=1u b=0 m=1
RR22 net22 net23 5.239K $SUB=sub! $[rppd] l=20u w=1u b=0 m=1
RR19 net19 net20 5.239K $SUB=sub! $[rppd] l=20u w=1u b=0 m=1
RR24 net24 net25 5.239K $SUB=sub! $[rppd] l=20u w=1u b=0 m=1
RR21 net21 net22 5.239K $SUB=sub! $[rppd] l=20u w=1u b=0 m=1
RR18 net18 net19 5.239K $SUB=sub! $[rppd] l=20u w=1u b=0 m=1
RR5 net5 net6 5.239K $SUB=sub! $[rppd] l=20u w=1u b=0 m=1
RR8 net8 net9 5.239K $SUB=sub! $[rppd] l=20u w=1u b=0 m=1
RR11 net11 net12 5.239K $SUB=sub! $[rppd] l=20u w=1u b=0 m=1
RR14 net14 net15 5.239K $SUB=sub! $[rppd] l=20u w=1u b=0 m=1
RR2 net2 net3 5.239K $SUB=sub! $[rppd] l=20u w=1u b=0 m=1
RR1 net1 net2 5.239K $SUB=sub! $[rppd] l=20u w=1u b=0 m=1
RR13 net13 net14 5.239K $SUB=sub! $[rppd] l=20u w=1u b=0 m=1
RR10 net10 net11 5.239K $SUB=sub! $[rppd] l=20u w=1u b=0 m=1
RR7 net7 net8 5.239K $SUB=sub! $[rppd] l=20u w=1u b=0 m=1
RR4 net4 net5 5.239K $SUB=sub! $[rppd] l=20u w=1u b=0 m=1
RR12 net12 net13 5.239K $SUB=sub! $[rppd] l=20u w=1u b=0 m=1
RR9 net9 net10 5.239K $SUB=sub! $[rppd] l=20u w=1u b=0 m=1
RR6 net6 net7 5.239K $SUB=sub! $[rppd] l=20u w=1u b=0 m=1
RR3 net3 net4 5.239K $SUB=sub! $[rppd] l=20u w=1u b=0 m=1
RR0 pin1 net1 5.239K $SUB=sub! $[rppd] l=20u w=1u b=0 m=1
.ENDS

************************************************************************
* Library Name: sg13g2_io
* Cell Name:    sg13g2_RCClampInverter
* View Name:    schematic
************************************************************************

.SUBCKT sg13g2_RCClampInverter out in iovss supply
*.PININFO in:I out:O iovss:B supply:B
MN1 iovss in iovss sub! sg13_hv_nmos m=1 w=63.000u l=9.5u ng=7
MN3 out in iovss sub! sg13_hv_nmos m=1 w=54.000u l=500.0n ng=6
MN0 iovss in iovss sub! sg13_hv_nmos m=1 w=63.000u l=9.5u ng=7
MN2 out in iovss sub! sg13_hv_nmos m=1 w=54.000u l=500.0n ng=6
XR0 iovss sub! ptap1 A=68.973p P=33.22u
MP0 out in supply supply sg13_hv_pmos m=1 w=350.000u l=500.0n ng=50
.ENDS

************************************************************************
* Library Name: sg13g2_io
* Cell Name:    sg13g2_IOPadVdd
* View Name:    schematic
************************************************************************

.SUBCKT sg13g2_IOPadVdd vdd vss iovdd iovss
*.PININFO iovdd:B iovss:B vdd:B vss:B
XI1 net3 iovss vdd / sg13g2_Clamp_N43N43D4R
XI4 vdd net1 / sg13g2_RCClampResistor
XR1 iovss sub! ptap1 A=1.97n P=177.54u
XR0 vss sub! ptap1 A=24.01p P=19.6u
XI3 net3 net1 iovss vdd / sg13g2_RCClampInverter
.ENDS

************************************************************************
* Library Name: sg13g2_io
* Cell Name:    sg13g2_IOPadIOVdd
* View Name:    schematic
************************************************************************

.SUBCKT sg13g2_IOPadIOVdd vdd vss iovdd iovss
*.PININFO iovdd:B iovss:B vdd:B vss:B
XI1 net4 iovss iovdd / sg13g2_Clamp_N43N43D4R
XI3 iovdd net1 / sg13g2_RCClampResistor
XI2 net4 net1 iovss iovdd / sg13g2_RCClampInverter
XR0 vss sub! ptap1 A=24.01p P=19.6u
XR1 iovss sub! ptap1 A=1.983n P=178.14u
.ENDS

************************************************************************
* Library Name: sg13g2_io
* Cell Name:    sg13g2_IOPadVss
* View Name:    schematic
************************************************************************

.SUBCKT sg13g2_IOPadVss vdd vss iovdd iovss
*.PININFO iovdd:B iovss:B vdd:B vss:B
XI1 iovss vss iovdd / sg13g2_DCNDiode
XI2 vss iovdd iovss / sg13g2_DCPDiode
XR1 iovss sub! ptap1 A=5.329n P=292u
XR0 vss sub! ptap1 A=23.523p P=19.4u
.ENDS

************************************************************************
* Library Name: sg13g2_io
* Cell Name:    sg13g2_Filler2000
* View Name:    schematic
************************************************************************

.SUBCKT sg13g2_Filler2000 vdd vss iovdd iovss
*.PININFO iovdd:B iovss:B vdd:B vss:B
XR1 vss sub! ptap1 A=2.856p P=6.76u
XR0 iovss sub! ptap1 A=695.113p P=105.46u
.ENDS

************************************************************************
* Library Name: sg13g2_io
* Cell Name:    sg13g2_io_inv_x1
* View Name:    schematic
************************************************************************

.SUBCKT sg13g2_io_inv_x1 nq i vdd vss
*.PININFO i:I nq:O vdd:B vss:B
MN0 nq i vss sub! sg13_lv_nmos m=1 w=3.93u l=130.00n ng=1
MP0 nq i vdd vdd sg13_lv_pmos m=1 w=4.41u l=130.00n ng=1
XR0 vss sub! ptap1 A=624.1f P=3.16
.ENDS

************************************************************************
* Library Name: sg13g2_io
* Cell Name:    sg13g2_LevelUp
* View Name:    schematic
************************************************************************

.SUBCKT sg13g2_LevelUp o i iovdd vdd vss
*.PININFO i:I o:O iovdd:B vdd:B vss:B
MN1 net2 i vss sub! sg13_lv_nmos m=1 w=2.75u l=130.00n ng=1
MP3 net2 i vdd vdd sg13_lv_pmos m=1 w=4.75u l=130.00n ng=1
MN0 o net4 vss sub! sg13_hv_nmos m=1 w=1.9u l=450.00n ng=1
MN3 net4 i vss sub! sg13_hv_nmos m=1 w=1.9u l=450.00n ng=1
MN2 net3 net2 vss sub! sg13_hv_nmos m=1 w=1.9u l=450.00n ng=1
MP0 o net4 iovdd iovdd sg13_hv_pmos m=1 w=3.9u l=450.00n ng=1
MP1 net3 net4 iovdd iovdd sg13_hv_pmos m=1 w=300.0n l=450.00n ng=1
MP2 net4 net3 iovdd iovdd sg13_hv_pmos m=1 w=300.0n l=450.00n ng=1
XR0 vss sub! ptap1 A=912.025f P=3.82u
.ENDS

************************************************************************
* Library Name: sg13g2_io
* Cell Name:    sg13g2_io_nor2_x1
* View Name:    schematic
************************************************************************

.SUBCKT sg13g2_io_nor2_x1 nq i0 i1 vdd vss
*.PININFO i0:I i1:I nq:O vdd:B vss:B
MN0 nq i0 vss sub! sg13_lv_nmos m=1 w=3.93u l=130.00n ng=1
MN1 nq i1 vss sub! sg13_lv_nmos m=1 w=3.93u l=130.00n ng=1
MP0 net1 i0 vdd vdd sg13_lv_pmos m=1 w=4.41u l=130.00n ng=1
MP1 nq i1 net1 vdd sg13_lv_pmos m=1 w=4.41u l=130.00n ng=1
XR0 vss sub! ptap1 A=656.1f P=3.24u
.ENDS

************************************************************************
* Library Name: sg13g2_io
* Cell Name:    sg13g2_io_tie
* View Name:    schematic
************************************************************************

.SUBCKT sg13g2_io_tie vdd vss
*.PININFO vdd:B vss:B
XR0 vss sub! ptap1 A=624.1f P=3.16u
.ENDS

************************************************************************
* Library Name: sg13g2_io
* Cell Name:    sg13g2_io_nand2_x1
* View Name:    schematic
************************************************************************

.SUBCKT sg13g2_io_nand2_x1 nq i0 i1 vdd vss
*.PININFO i0:I i1:I nq:O vdd:B vss:B
MP1 nq i1 vdd vdd sg13_lv_pmos m=1 w=4.41u l=130.00n ng=1
MP0 nq i0 vdd vdd sg13_lv_pmos m=1 w=4.41u l=130.00n ng=1
MN1 net1 i0 vss sub! sg13_lv_nmos m=1 w=3.93u l=130.00n ng=1
MN0 nq i1 net1 sub! sg13_lv_nmos m=1 w=3.93u l=130.00n ng=1
XR0 vss sub! ptap1 A=656.1f P=3.24u
.ENDS

************************************************************************
* Library Name: sg13g2_io
* Cell Name:    sg13g2_GateDecode
* View Name:    schematic
************************************************************************

.SUBCKT sg13g2_GateDecode ngate pgate core en iovdd vdd vss
*.PININFO core:I en:I ngate:O pgate:O iovdd:B vdd:B vss:B
XI1 net3 en vdd vss / sg13g2_io_inv_x1
XI4 ngate net4 iovdd vdd vss / sg13g2_LevelUp
XI2 pgate net2 iovdd vdd vss / sg13g2_LevelUp
XI3 net4 core net3 vdd vss / sg13g2_io_nor2_x1
XI0 vdd vss / sg13g2_io_tie
XI5 net2 core en vdd vss / sg13g2_io_nand2_x1
.ENDS

************************************************************************
* Library Name: sg13g2_io
* Cell Name:    sg13g2_Clamp_N2N2D
* View Name:    schematic
************************************************************************

.SUBCKT sg13g2_Clamp_N2N2D gate iovss pad
*.PININFO gate:I iovss:B pad:B
XR0 iovss sub! ptap1 A=55.801p P=29.88u
MN1 pad gate iovss sub! sg13_hv_nmos m=1 w=8.8u l=600.0n ng=2
DD0 sub! gate dantenna m=1 w=780.00n l=780.00n a=608.400f p=3.12u
.ENDS

************************************************************************
* Library Name: sg13g2_io
* Cell Name:    sg13g2_Clamp_P2N2D
* View Name:    schematic
************************************************************************

.SUBCKT sg13g2_Clamp_P2N2D gate iovdd iovss pad
*.PININFO gate:I iovdd:B iovss:B pad:B
DD0 gate iovdd dpantenna m=1 w=480n l=480n a=230.4f p=1.92u
MP1 pad gate iovdd iovdd sg13_hv_pmos m=1 w=13.32u l=600.0n ng=2
MP0 pad gate iovdd iovdd sg13_hv_pmos m=1 w=13.32u l=600.0n ng=2
XR0 iovss sub! ptap1 A=66.994p P=32.74u
.ENDS

************************************************************************
* Library Name: sg13g2_io
* Cell Name:    sg13g2_SecondaryProtection
* View Name:    schematic
************************************************************************

.SUBCKT sg13g2_SecondaryProtection core minus pad plus
*.PININFO core:B minus:B pad:B plus:B
RR0 pad core 586.899 $SUB=sub! $[rppd] m=1 l=2u w=1u b=0 m=1
DD1 sub! core dantenna m=1 w=640n l=3.1u a=1.984p p=7.48u
XR1 minus sub! ptap1 A=9.03p P=12.02u
DD0 core plus dpantenna m=1 w=640n l=4.98u a=3.187p p=11.24u
.ENDS

************************************************************************
* Library Name: sg13g2_io
* Cell Name:    sg13g2_LevelDown
* View Name:    schematic
************************************************************************

.SUBCKT sg13g2_LevelDown core pad iovdd iovss vdd vss
*.PININFO pad:I core:O iovdd:B iovss:B vdd:B vss:B
MP0 vdd vdd vdd vdd sg13_hv_pmos m=1 w=4.65u l=450.00n ng=1
MP2 net4 net7 iovdd iovdd sg13_hv_pmos m=1 w=4.6u l=450.00n ng=2
MP3 net7 net1 iovdd iovdd sg13_hv_pmos m=1 w=4.6u l=450.00n ng=2
MN3 net4 net7 iovss sub! sg13_hv_nmos m=1 w=1.3u l=450.00n ng=1
MN4 net7 net1 iovss sub! sg13_hv_nmos m=1 w=1.3u l=450.00n ng=1
MN2 net2 net4 vss sub! sg13_hv_nmos m=1 w=2.65u l=450.00n ng=1
MN0 vdd net7 net2 sub! sg13_hv_nmos m=1 w=2.65u l=450.00n ng=1
MN1 core net2 vss sub! sg13_lv_nmos m=1 w=2.75u l=130.00n ng=1
MP1 core net2 vdd vdd sg13_lv_pmos m=1 w=4.75u l=130.00n ng=1
XR1 iovss sub! ptap1 A=970.225f P=3.94u
XR0 vss sub! ptap1 A=2.016p P=5.68u
XI0 net1 iovss pad iovdd / sg13g2_SecondaryProtection
.ENDS

************************************************************************
* Library Name: sg13g2_io
* Cell Name:    sg13g2_IOPadInOut4mA
* View Name:    schematic
************************************************************************

.SUBCKT sg13g2_IOPadInOut4mA pad c2p p2c c2p_en vdd vss iovdd iovss
*.PININFO c2p:I c2p_en:I p2c:O iovdd:B iovss:B pad:B vdd:B vss:B
XI1 pad iovdd iovss / sg13g2_DCPDiode
XI2 net2 net1 c2p c2p_en iovdd vdd vss / sg13g2_GateDecode
XI3 net2 iovss pad / sg13g2_Clamp_N2N2D
XI0 net1 iovdd iovss pad / sg13g2_Clamp_P2N2D
XI4 p2c pad iovdd iovss vdd vss / sg13g2_LevelDown
XR0 vss sub! ptap1 A=18.966p P=17.42u
XR1 iovss sub! ptap1 A=4.314n P=262.72u
XI5 iovss pad iovdd / sg13g2_DCNDiode
.ENDS

************************************************************************
* Library Name: sg13g2_io
* Cell Name:    sg13g2_Clamp_P15N15D
* View Name:    schematic
************************************************************************

.SUBCKT sg13g2_Clamp_P15N15D gate iovdd iovss pad
*.PININFO gate:I iovdd:B iovss:B pad:B
DD0 gate iovdd dpantenna m=1 w=780.00n l=780.00n a=608.400f p=3.12u
XR0 iovss sub! ptap1 A=66.994p P=32.74u
MP1 pad gate iovdd iovdd sg13_hv_pmos m=1 w=99.9u l=600.0n ng=15
MP0 pad gate iovdd iovdd sg13_hv_pmos m=1 w=99.9u l=600.0n ng=15
.ENDS

************************************************************************
* Library Name: sg13g2_io
* Cell Name:    sg13g2_Clamp_N15N15D
* View Name:    schematic
************************************************************************

.SUBCKT sg13g2_Clamp_N15N15D gate iovss pad
*.PININFO gate:I iovss:B pad:B
XR0 iovss sub! ptap1 A=55.801p P=29.88u
MN0 pad gate iovss sub! sg13_hv_nmos m=1 w=66.000u l=600.0n ng=15
DD0 sub! gate dantenna m=1 w=780.00n l=780.00n a=608.400f p=3.12u
.ENDS

************************************************************************
* Library Name: sg13g2_io
* Cell Name:    sg13g2_IOPadInOut30mA
* View Name:    schematic
************************************************************************

.SUBCKT sg13g2_IOPadInOut30mA pad c2p p2c c2p_en vdd vss iovdd iovss
*.PININFO c2p:I c2p_en:I p2c:O iovdd:B iovss:B pad:B vdd:B vss:B
XI4 p2c pad iovdd iovss vdd vss / sg13g2_LevelDown
XI1 pad iovdd iovss / sg13g2_DCPDiode
XI0 net1 iovdd iovss pad / sg13g2_Clamp_P15N15D
XI5 iovss pad iovdd / sg13g2_DCNDiode
XI3 net2 iovss pad / sg13g2_Clamp_N15N15D
XR0 vss sub! A=19.141p P=17.5u
XR1 iovss sub! A=4.313n P=262.7u
XI2 net2 net1 c2p c2p_en iovdd vdd vss / sg13g2_GateDecode
.ENDS

************************************************************************
* Library Name: sg13g2_io
* Cell Name:    sg13g2_LevelUpInv
* View Name:    schematic
************************************************************************

.SUBCKT sg13g2_LevelUpInv o i iovdd vdd vss
*.PININFO i:I o:O iovdd:B vdd:B vss:B
MN1 net2 i vss sub! sg13_lv_nmos m=1 w=2.75u l=130.00n ng=1
MP3 net2 i vdd vdd sg13_lv_pmos m=1 w=4.75u l=130.00n ng=1
MN0 o net4 vss sub! sg13_hv_nmos m=1 w=1.9u l=450.00n ng=1
MN3 net4 net2 vss sub! sg13_hv_nmos m=1 w=1.9u l=450.00n ng=1
MN2 net3 i vss sub! sg13_hv_nmos m=1 w=1.9u l=450.00n ng=1
MP0 o net4 iovdd iovdd sg13_hv_pmos m=1 w=3.9u l=450.00n ng=1
MP1 net3 net4 iovdd iovdd sg13_hv_pmos m=1 w=300.0n l=450.00n ng=1
MP2 net4 net3 iovdd iovdd sg13_hv_pmos m=1 w=300.0n l=450.00n ng=1
XR0 vss sub! ptap1 A=1.051p P=4.1u
.ENDS

************************************************************************
* Library Name: sg13g2_io
* Cell Name:    sg13g2_GateLevelUpInv
* View Name:    schematic
************************************************************************

.SUBCKT sg13g2_GateLevelUpInv ngate pgate iovdd core vdd vss
*.PININFO core:I ngate:O pgate:O iovdd:B vdd:B vss:B
XI1 pgate core iovdd vdd vss / sg13g2_LevelUpInv
XI0 ngate core iovdd vdd vss / sg13g2_LevelUpInv
.ENDS

************************************************************************
* Library Name: sg13g2_io
* Cell Name:    sg13g2_IOPadOut4mA
* View Name:    schematic
************************************************************************

.SUBCKT sg13g2_IOPadOut4mA pad c2p vdd vss iovdd iovss
*.PININFO c2p:I pad:O iovdd:B iovss:B vdd:B vss:B
XI2 net2 net1 iovdd c2p vdd vss / sg13g2_GateLevelUpInv
XI0 net1 iovdd iovss pad / sg13g2_Clamp_P2N2D
XI3 net2 iovss pad / sg13g2_Clamp_N2N2D
XI4 iovss pad iovdd / sg13g2_DCNDiode
XI1 pad iovdd iovss / sg13g2_DCPDiode
XR1 iovss sub! ptap1 A=4.343n P=263.6u
XR0 vss sub! ptap1 A=21.902p P=18.72u
.ENDS

************************************************************************
* Library Name: sg13g2_io
* Cell Name:    sg13g2_IOPadOut30mA
* View Name:    schematic
************************************************************************

.SUBCKT sg13g2_IOPadOut30mA pad c2p vdd vss iovdd iovss
*.PININFO c2p:I pad:O iovdd:B iovss:B vdd:B vss:B
XI2 net2 net1 iovdd c2p vdd vss / sg13g2_GateLevelUpInv
XI1 net1 iovdd iovss pad / sg13g2_Clamp_P15N15D
XI3 net2 iovss pad / sg13g2_Clamp_N15N15D
XI4 iovss pad iovdd / sg13g2_DCNDiode
XI0 pad iovdd iovss / sg13g2_DCPDiode
XR0 vss sub! ptap1 A=21.902p P=18.72u
XR1 iovss sub! ptap1 A=4.313n P=262.7u
.ENDS

************************************************************************
* Library Name: sg13g2_io
* Cell Name:    sg13g2_IOPadIn
* View Name:    schematic
************************************************************************

.SUBCKT sg13g2_IOPadIn pad p2c vdd vss iovdd iovss
*.PININFO pad:I p2c:O iovdd:B iovss:B vdd:B vss:B
XI0 p2c pad iovdd iovss vdd vss / sg13g2_LevelDown
XI2 iovss pad iovdd / sg13g2_DCNDiode
XI1 pad iovdd iovss / sg13g2_DCPDiode
XR0 vss sub! ptap1 A=21.252p P=18.44u
XR1 iovss sub! ptap1 A=5.35n P=292.58u
.ENDS

************************************************************************
* Library Name: sg13g2_io
* Cell Name:    sg13g2_Clamp_P8N8D
* View Name:    schematic
************************************************************************

.SUBCKT sg13g2_Clamp_P8N8D gate iovdd iovss pad
*.PININFO gate:I iovdd:B iovss:B pad:B
XR0 iovss sub! ptap1 A=66.994p P=32.74u
MP2 pad gate iovdd iovdd sg13_hv_pmos m=1 w=53.28u l=600.0n ng=8
MP0 pad gate iovdd iovdd sg13_hv_pmos m=1 w=53.28u l=600.0n ng=8
DD0 gate iovdd dpantenna m=1 w=480n l=480n a=230.4f p=1.92u
.ENDS

************************************************************************
* Library Name: sg13g2_io
* Cell Name:    sg13g2_Clamp_N8N8D
* View Name:    schematic
************************************************************************

.SUBCKT sg13g2_Clamp_N8N8D gate iovss pad
*.PININFO gate:I iovss:B pad:B
XR0 iovss sub! ptap1 A=55.801p P=29.88u
MN0 pad gate iovss sub! sg13_hv_nmos m=1 w=35.2u l=600.0n ng=8
DD0 sub! gate dantenna m=1 w=780.00n l=780.00n a=608.400f p=3.12u
.ENDS

************************************************************************
* Library Name: sg13g2_io
* Cell Name:    sg13g2_IOPadInOut16mA
* View Name:    schematic
************************************************************************

.SUBCKT sg13g2_IOPadInOut16mA pad c2p p2c c2p_en vdd vss iovdd iovss
*.PININFO c2p:I c2p_en:I p2c:O iovdd:B iovss:B pad:B vdd:B vss:B
XI1 pad iovdd iovss / sg13g2_DCPDiode
XI2 net2 net1 c2p c2p_en iovdd vdd vss / sg13g2_GateDecode
XI5 iovss pad iovdd / sg13g2_DCNDiode
XI0 net1 iovdd iovss pad / sg13g2_Clamp_P8N8D
XI4 p2c pad iovdd iovss vdd vss / sg13g2_LevelDown
XI3 net2 iovss pad / sg13g2_Clamp_N8N8D
XR0 vss sub! ptap1 A=18.966p P=17.42u
XR1 iovss sub! ptap1 A=4.45n P=266.84u
.ENDS

************************************************************************
* Library Name: sg13g2_io
* Cell Name:    sg13g2_IOPadOut16mA
* View Name:    schematic
************************************************************************

.SUBCKT sg13g2_IOPadOut16mA pad c2p vdd vss iovdd iovss
*.PININFO c2p:I pad:O iovdd:B iovss:B vdd:B vss:B
XI2 net2 net1 iovdd c2p vdd vss / sg13g2_GateLevelUpInv
XI0 net1 iovdd iovss pad / sg13g2_Clamp_P8N8D
XI4 iovss pad iovdd / sg13g2_DCNDiode
XI3 net2 iovss pad / sg13g2_Clamp_N8N8D
XI1 pad iovdd iovss / sg13g2_DCPDiode
XR0 vss sub! ptap1 A=22.184p P=18.84u
XR1 iovss sub! ptap1 A=4.43n P=266.24u
.ENDS

************************************************************************
* Library Name: sg13g2_io
* Cell Name:    sg13g2_IOPadTriOut4mA
* View Name:    schematic
************************************************************************

.SUBCKT sg13g2_IOPadTriOut4mA pad c2p c2p_en vdd vss iovdd iovss
*.PININFO c2p:I c2p_en:I pad:O iovdd:B iovss:B vdd:B vss:B
XI2 net2 net1 c2p c2p_en iovdd vdd vss / sg13g2_GateDecode
XI4 iovss pad iovdd / sg13g2_DCNDiode
XI3 net2 iovss pad / sg13g2_Clamp_N2N2D
XI0 net1 iovdd iovss pad / sg13g2_Clamp_P2N2D
XI1 pad iovdd iovss / sg13g2_DCPDiode
XR0 vss sub! ptap1 A=21.391p P=18.5u
XR1 iovss sub! ptap1 A=4.43n P=266.24u
.ENDS

************************************************************************
* Library Name: sg13g2_io
* Cell Name:    sg13g2_IOPadTriOut16mA
* View Name:    schematic
************************************************************************

.SUBCKT sg13g2_IOPadTriOut16mA pad c2p c2p_en vdd vss iovdd iovss
*.PININFO c2p:I c2p_en:I pad:O iovdd:B iovss:B vdd:B vss:B
XI2 net2 net1 c2p c2p_en iovdd vdd vss / sg13g2_GateDecode
XI0 net1 iovdd iovss pad / sg13g2_Clamp_P8N8D
XI3 net2 iovss pad / sg13g2_Clamp_N8N8D
XI4 iovss pad iovdd / sg13g2_DCNDiode
XI1 pad iovdd iovss / sg13g2_DCPDiode
XR0 vss sub! ptap1 A=21.022p P=18.34u
XR1 iovss sub! ptap1 A=4.44n P=266.54u
.ENDS

************************************************************************
* Library Name: sg13g2_io
* Cell Name:    sg13g2_IOPadTriOut30mA
* View Name:    schematic
************************************************************************

.SUBCKT sg13g2_IOPadTriOut30mA pad c2p c2p_en vdd vss iovdd iovss
*.PININFO c2p:I c2p_en:I pad:O iovdd:B iovss:B vdd:B vss:B
XI2 net2 net1 c2p c2p_en iovdd vdd vss / sg13g2_GateDecode
XI4 iovss pad iovdd / sg13g2_DCNDiode
XI3 net2 iovss pad / sg13g2_Clamp_N15N15D
XI0 net1 iovdd iovss pad / sg13g2_Clamp_P15N15D
XI1 pad iovdd iovss / sg13g2_DCPDiode
XR0 vss sub! ptap1 A=21.298p P=18.46u
XR1 iovss sub! ptap1 A=4.43n P=266.24u
.ENDS

************************************************************************
* Library Name: sg13g2_io
* Cell Name:    sg13g2_Corner
* View Name:    schematic
************************************************************************

.SUBCKT sg13g2_Corner vdd vss iovdd iovss
*.PININFO iovdd:B iovss:B vdd:B vss:B
XR1 vss sub! ptap1 A=13.177p P=14.52u
XR0 iovss sub! ptap1 A=10.13n P=402.6u
.ENDS

************************************************************************
* Library Name: sg13g2_io
* Cell Name:    sg13g2_Filler4000
* View Name:    schematic
************************************************************************

.SUBCKT sg13g2_Filler4000 vdd vss iovdd iovss
*.PININFO iovdd:B iovss:B vdd:B vss:B
XR1 vss sub! ptap1 A=5.856p P=9.68u
XR0 iovss sub! ptap1 A=1.416n P=150.5u
.ENDS

************************************************************************
* Library Name: sg13g2_io
* Cell Name:    sg13g2_Filler1000
* View Name:    schematic
************************************************************************

.SUBCKT sg13g2_Filler1000 vdd vss iovdd iovss
*.PININFO iovdd:B iovss:B vdd:B vss:B
XR1 vss sub! ptap1 A=1.369p P=4.68u
XR0 iovss sub! ptap1 A=328.697p P=72.52u
.ENDS

************************************************************************
* Library Name: sg13g2_io
* Cell Name:    sg13g2_Filler200
* View Name:    schematic
************************************************************************

.SUBCKT sg13g2_Filler200 vdd vss iovdd iovss
*.PININFO iovdd:B iovss:B vdd:B vss:B
XR1 vss sub! ptap1 A=680.625f P=3.3u
XR0 iovss sub! ptap1 A=40.96p P=25.6u
.ENDS

************************************************************************
* Library Name: sg13g2_io
* Cell Name:    sg13g2_Filler400
* View Name:    schematic
************************************************************************

.SUBCKT sg13g2_Filler400 vdd vss iovdd iovss
*.PININFO iovdd:B iovss:B vdd:B vss:B
XR1 vss sub! ptap1 A=680.625f P=3.3u
XR0 iovss sub! ptap1 A=114.169p P=42.74u
.ENDS

************************************************************************
* Library Name: sg13g2_io
* Cell Name:    sg13g2_Filler10000
* View Name:    schematic
************************************************************************

.SUBCKT sg13g2_Filler10000 vdd vss iovdd iovss
*.PININFO iovdd:B iovss:B vdd:B vss:B
XR1 vss sub! ptap1 A=14.861p Perim=15.42u
XR0 iovss sub! ptap1 A=3.622n Perim=240.72u
.ENDS

************************************************************************
* Library Name: sg13g2_io
* Cell Name:    sg13g2_Clamp_P20N0D
* View Name:    schematic
************************************************************************

.SUBCKT sg13g2_Clamp_P20N0D iovdd iovss pad
*.PININFO iovdd:B iovss:B pad:B
MP1 pad net2 iovdd iovdd sg13_hv_pmos m=1 w=133.2u l=600.0n ng=20
MP0 pad net2 iovdd iovdd sg13_hv_pmos m=1 w=133.2u l=600.0n ng=20
RR0 net2 iovdd 6.768K $SUB=iovdd $[rppd] l=12.9u w=500n b=0 m=1
XR1 iovss sub! ptap1 A=66.994p P=32.74u
.ENDS

************************************************************************
* Library Name: sg13g2_io
* Cell Name:    sg13g2_Clamp_N20N0D
* View Name:    schematic
************************************************************************

.SUBCKT sg13g2_Clamp_N20N0D iovss pad
*.PININFO iovss:B pad:B
MN0 pad net2 iovss sub! sg13_hv_nmos m=1 w=88.000u l=600.0n ng=20
XR1 iovss sub! ptap1 A=55.801p P=29.88u
RR0 iovss net2 1.959K $SUB=sub! $[rppd] l=3.54u w=500n b=0 m=1
.ENDS

************************************************************************
* Library Name: sg13g2_io
* Cell Name:    sg13g2_IOPadAnalog
* View Name:    schematic
************************************************************************

.SUBCKT sg13g2_IOPadAnalog pad padres vdd vss iovdd iovss
*.PININFO iovdd:B iovss:B pad:B padres:B vdd:B vss:B
XI0 iovdd iovss pad / sg13g2_Clamp_P20N0D
XI5 iovss pad iovdd / sg13g2_DCNDiode
XI2 pad iovdd iovss / sg13g2_DCPDiode
XI3 padres iovss pad iovdd / sg13g2_SecondaryProtection
XI4 iovss pad / sg13g2_Clamp_N20N0D
XR0 vss sub! ptap1 A=23.863p P=19.54u
XR1 iovss sub! ptap1 A=4.3n P=262.3u
.ENDS

.SUBCKT bondpad_70x70_tm1 pad
*.PININFO pad:B
* metal-only bond pad
.ENDS

* ---- macro g1_gate (/work/designs/g1-guardian/blocks/g1_gate/layout/g1_gate.cdl) ----
* CDL for KLayout LVS, generated by layout/spice2cdl.py from g1_gate.spice (substrate net = vss)
.subckt g1_gate trip_d clr_d fast_en hard_cmp en_core gate_core fault_core tripped vdd vdda vss
XNA hard_cmp fast_en fast_n vdd vss g1_lv_nand2
XIA fast_n fast vdd vss g1_lv_inv
XU0 fast fast_h vdd vdda vss g1_lvlup
XU1 trip_d trip_h vdd vdda vss g1_lvlup
XU2 clr_d clr_h vdd vdda vss g1_lvlup
XU3 en_core en_h vdd vdda vss g1_lvlup
XN1 fast_h trip_h set_n vdda vss g1_hv_nor2
XI1 set_n set vdda vss g1_hv_inv
XI2 en_h en_hn vdda vss g1_hv_inv
XN2 en_hn clr_h rst_n vdda vss g1_hv_nor2
XI3 rst_n rst vdda vss g1_hv_inv
XL1 rst qb q vdda vss g1_hv_nor2
XL2 set q qb vdda vss g1_hv_nor2
XG en_hn q gate_h vdda vss g1_hv_nor2
XGI gate_h gate_hn vdda vss g1_hv_inv
XD1 gate_h gate_hn gate_core vdd vss g1_lvldn
XD2 qb q fault_core vdd vss g1_lvldn
XD3 q qb tripped vdd vss g1_lvldn
.ends
.subckt g1_lv_nand2 a b y vdd vss
MMP1 y a vdd vdd sg13_lv_pmos w=2u l=0.13u m=1
MMP2 y b vdd vdd sg13_lv_pmos w=2u l=0.13u m=1
MMN1 y a m vss sg13_lv_nmos w=2u l=0.13u m=1
MMN2 m b vss vss sg13_lv_nmos w=2u l=0.13u m=1
.ends
.subckt g1_lv_inv a y vdd vss
MMP y a vdd vdd sg13_lv_pmos w=2u l=0.13u m=1
MMN y a vss vss sg13_lv_nmos w=1u l=0.13u m=1
.ends
.subckt g1_lvlup a y vdd vdda vss
XI a ab vdd vss g1_lv_inv
MMN1 nb a vss vss sg13_hv_nmos w=1.9u l=0.45u m=1
MMN2 n ab vss vss sg13_hv_nmos w=1.9u l=0.45u m=1
MMP1 nb n vdda vdda sg13_hv_pmos w=0.3u l=0.45u m=1
MMP2 n nb vdda vdda sg13_hv_pmos w=0.3u l=0.45u m=1
XO nb y vdda vss g1_hv_inv
.ends
.subckt g1_hv_nor2 a b y vdda vss
MMP1 m a vdda vdda sg13_hv_pmos w=7.8u l=0.45u m=1
MMP2 y b m vdda sg13_hv_pmos w=7.8u l=0.45u m=1
MMN1 y a vss vss sg13_hv_nmos w=1.9u l=0.45u m=1
MMN2 y b vss vss sg13_hv_nmos w=1.9u l=0.45u m=1
.ends
.subckt g1_hv_inv a y vdda vss
MMP y a vdda vdda sg13_hv_pmos w=3.9u l=0.45u m=1
MMN y a vss vss sg13_hv_nmos w=1.9u l=0.45u m=1
.ends
.subckt g1_lvldn a ab y vdd vss
MMN1 yb a vss vss sg13_hv_nmos w=2u l=0.45u m=1
MMN2 y ab vss vss sg13_hv_nmos w=2u l=0.45u m=1
MMP1 y yb vdd vdd sg13_lv_pmos w=1u l=0.13u m=1
MMP2 yb y vdd vdd sg13_lv_pmos w=1u l=0.13u m=1
.ends

* ---- macro g1_osc (/work/designs/g1-guardian/blocks/g1_osc/layout/g1_osc_lvs.cdl) ----
* LVS reference netlist derived from g1_osc.spice by lvs_netlist.py (see docstring)
.subckt g1_osc en trim[0] trim[1] trim[2] trim[3] osc_clk VDD VSS
RRA VDD va VSS rppd w=1u l=117u b=0 m=1
RRB VDD vb VSS rppd w=1u l=117u b=0 m=1
XCA trim[0] trim[1] trim[2] trim[3] va VSS g1_osc_cbank
XCB trim[0] trim[1] trim[2] trim[3] vb VSS g1_osc_cbank
MMRA va rsta VSS VSS sg13_lv_nmos w=4u l=0.13u m=1
MMRB vb rstb VSS VSS sg13_lv_nmos w=4u l=0.13u m=1
RRT1 VDD vth VSS rppd w=1u l=384.3u b=0 m=1
RRT2 vth VSS VSS rppd w=1u l=384.3u b=0 m=1
CCTH vth VSS cap_cmim w=26u l=26u m=1
DDANT vth VDD dpantenna w=0.78u l=0.78u
RRBIAS VDD vbn VSS rppd w=1u l=134.3u b=0 m=1
MMBD vbn vbn VSS VSS sg13_lv_nmos w=2u l=0.5u m=1
XCMPA va vth vbn ca VDD VSS g1_osc_cmp
XCMPB vb vth vbn cb VDD VSS g1_osc_cmp
XEN en en_n VDD VSS g1_osc_inv
XNQ ca en_n qb q VDD VSS g1_osc_nor3
XNQB cb q qb VDD VSS g1_osc_nor2
XRSTB qb en rstb VDD VSS g1_osc_nand2
XRSTA q rsta VDD VSS g1_osc_inv
XB1 q qn_b VDD VSS g1_osc_inv
XB2 qn_b osc_clk VDD VSS g1_osc_inv
.ends
.subckt g1_osc_cbank t0 t1 t2 t3 top vss
CCF top vss cap_cmim w=31.65u l=31.65u m=1
CCT0 top b0 cap_cmim w=8.16u l=8.16u m=1
MMS0 b0 t0 vss vss sg13_lv_nmos w=4u l=0.13u m=1
CCT1 top b1 cap_cmim w=11.55u l=11.55u m=1
MMS1 b1 t1 vss vss sg13_lv_nmos w=4u l=0.13u m=1
CCT2 top b2 cap_cmim w=16.33u l=16.33u m=1
MMS2 b2 t2 vss vss sg13_lv_nmos w=4u l=0.13u m=1
CCT3 top b3 cap_cmim w=23.09u l=23.09u m=1
MMS3 b3 t3 vss vss sg13_lv_nmos w=4u l=0.13u m=1
.ends
.subckt g1_osc_cmp inp inn vbn out vdd vss
MMT tail vbn vss vss sg13_lv_nmos w=2u l=0.5u m=1
MM1 d1 inp tail vss sg13_lv_nmos w=4u l=0.3u m=1
MM2 o1 inn tail vss sg13_lv_nmos w=4u l=0.3u m=1
MM3 d1 d1 vdd vdd sg13_lv_pmos w=2u l=0.3u m=1
MM4 o1 d1 vdd vdd sg13_lv_pmos w=2u l=0.3u m=1
XI1 o1 o2 vdd vss g1_osc_inv
XI2 o2 out vdd vss g1_osc_inv
.ends
.subckt g1_osc_inv a y vdd vss
MMP y a vdd vdd sg13_lv_pmos w=1u l=0.13u m=1
MMN y a vss vss sg13_lv_nmos w=0.5u l=0.13u m=1
.ends
.subckt g1_osc_nor3 a0 a1 a2 y vdd vss
MMP0 p0 a0 vdd vdd sg13_lv_pmos w=3u l=0.13u m=1
MMP1 p1 a1 p0 vdd sg13_lv_pmos w=3u l=0.13u m=1
MMP2 y a2 p1 vdd sg13_lv_pmos w=3u l=0.13u m=1
MMN0 y a0 vss vss sg13_lv_nmos w=0.5u l=0.13u m=1
MMN1 y a1 vss vss sg13_lv_nmos w=0.5u l=0.13u m=1
MMN2 y a2 vss vss sg13_lv_nmos w=0.5u l=0.13u m=1
.ends
.subckt g1_osc_nor2 a0 a1 y vdd vss
MMP0 p0 a0 vdd vdd sg13_lv_pmos w=2u l=0.13u m=1
MMP1 y a1 p0 vdd sg13_lv_pmos w=2u l=0.13u m=1
MMN0 y a0 vss vss sg13_lv_nmos w=0.5u l=0.13u m=1
MMN1 y a1 vss vss sg13_lv_nmos w=0.5u l=0.13u m=1
.ends
.subckt g1_osc_nand2 a0 a1 y vdd vss
MMP0 y a0 vdd vdd sg13_lv_pmos w=1u l=0.13u m=1
MMP1 y a1 vdd vdd sg13_lv_pmos w=1u l=0.13u m=1
MMN0 y a0 n0 vss sg13_lv_nmos w=1u l=0.13u m=1
MMN1 n0 a1 vss vss sg13_lv_nmos w=1u l=0.13u m=1
.ends

* ---- macro g1_sense (/work/designs/g1-guardian/blocks/g1_sense/layout/g1_sense.cdl) ----
* CDL for KLayout LVS, generated by layout/spice2cdl.py from g1_sense.spice (substrate net = vss)
.subckt g1_sense sense_p sense_n vref iptat isense vped vref_buf vdd vss
RR1N0 sense_n vn vss rppd w=2u l=76.7u m=1 b=0
RR2N0 vn R2N_0 vss rppd w=2u l=76.7u m=1 b=0
RR2N1 R2N_0 R2N_1 vss rppd w=2u l=76.7u m=1 b=0
RR2N2 R2N_1 R2N_2 vss rppd w=2u l=76.7u m=1 b=0
RR2N3 R2N_2 R2N_3 vss rppd w=2u l=76.7u m=1 b=0
RR2N4 R2N_3 R2N_4 vss rppd w=2u l=76.7u m=1 b=0
RR2N5 R2N_4 R2N_5 vss rppd w=2u l=76.7u m=1 b=0
RR2N6 R2N_5 R2N_6 vss rppd w=2u l=76.7u m=1 b=0
RR2N7 R2N_6 R2N_7 vss rppd w=2u l=76.7u m=1 b=0
RR2N8 R2N_7 R2N_8 vss rppd w=2u l=76.7u m=1 b=0
RR2N9 R2N_8 R2N_9 vss rppd w=2u l=76.7u m=1 b=0
RR2N10 R2N_9 R2N_10 vss rppd w=2u l=76.7u m=1 b=0
RR2N11 R2N_10 R2N_11 vss rppd w=2u l=76.7u m=1 b=0
RR2N12 R2N_11 R2N_12 vss rppd w=2u l=76.7u m=1 b=0
RR2N13 R2N_12 R2N_13 vss rppd w=2u l=76.7u m=1 b=0
RR2N14 R2N_13 R2N_14 vss rppd w=2u l=76.7u m=1 b=0
RR2N15 R2N_14 R2N_15 vss rppd w=2u l=76.7u m=1 b=0
RR2N16 R2N_15 R2N_16 vss rppd w=2u l=76.7u m=1 b=0
RR2N17 R2N_16 R2N_17 vss rppd w=2u l=76.7u m=1 b=0
RR2N18 R2N_17 R2N_18 vss rppd w=2u l=76.7u m=1 b=0
RR2N19 R2N_18 isense vss rppd w=2u l=76.7u m=1 b=0
RR1P0 sense_p vp vss rppd w=2u l=76.7u m=1 b=0
RR2P0 vp R2P_0 vss rppd w=2u l=76.7u m=1 b=0
RR2P1 R2P_0 R2P_1 vss rppd w=2u l=76.7u m=1 b=0
RR2P2 R2P_1 R2P_2 vss rppd w=2u l=76.7u m=1 b=0
RR2P3 R2P_2 R2P_3 vss rppd w=2u l=76.7u m=1 b=0
RR2P4 R2P_3 R2P_4 vss rppd w=2u l=76.7u m=1 b=0
RR2P5 R2P_4 R2P_5 vss rppd w=2u l=76.7u m=1 b=0
RR2P6 R2P_5 R2P_6 vss rppd w=2u l=76.7u m=1 b=0
RR2P7 R2P_6 R2P_7 vss rppd w=2u l=76.7u m=1 b=0
RR2P8 R2P_7 R2P_8 vss rppd w=2u l=76.7u m=1 b=0
RR2P9 R2P_8 R2P_9 vss rppd w=2u l=76.7u m=1 b=0
RR2P10 R2P_9 R2P_10 vss rppd w=2u l=76.7u m=1 b=0
RR2P11 R2P_10 R2P_11 vss rppd w=2u l=76.7u m=1 b=0
RR2P12 R2P_11 R2P_12 vss rppd w=2u l=76.7u m=1 b=0
RR2P13 R2P_12 R2P_13 vss rppd w=2u l=76.7u m=1 b=0
RR2P14 R2P_13 R2P_14 vss rppd w=2u l=76.7u m=1 b=0
RR2P15 R2P_14 R2P_15 vss rppd w=2u l=76.7u m=1 b=0
RR2P16 R2P_15 R2P_16 vss rppd w=2u l=76.7u m=1 b=0
RR2P17 R2P_16 R2P_17 vss rppd w=2u l=76.7u m=1 b=0
RR2P18 R2P_17 R2P_18 vss rppd w=2u l=76.7u m=1 b=0
RR2P19 R2P_18 vped vss rppd w=2u l=76.7u m=1 b=0
RRD10 vref_buf RD1_0 vss rppd w=2u l=76.7u m=1 b=0
RRD11 RD1_0 vped_ref vss rppd w=2u l=76.7u m=1 b=0
RRD20 vped_ref RD2_0 vss rppd w=2u l=76.7u m=1 b=0
RRD21 RD2_0 RD2_1 vss rppd w=2u l=76.7u m=1 b=0
RRD22 RD2_1 RD2_2 vss rppd w=2u l=76.7u m=1 b=0
RRD23 RD2_2 RD2_3 vss rppd w=2u l=76.7u m=1 b=0
RRD24 RD2_3 RD2_4 vss rppd w=2u l=76.7u m=1 b=0
RRD25 RD2_4 RD2_5 vss rppd w=2u l=76.7u m=1 b=0
RRD26 RD2_5 RD2_6 vss rppd w=2u l=76.7u m=1 b=0
RRD27 RD2_6 RD2_7 vss rppd w=2u l=76.7u m=1 b=0
RRD28 RD2_7 RD2_8 vss rppd w=2u l=76.7u m=1 b=0
RRD29 RD2_8 RD2_9 vss rppd w=2u l=76.7u m=1 b=0
RRD210 RD2_9 RD2_10 vss rppd w=2u l=76.7u m=1 b=0
RRD211 RD2_10 RD2_11 vss rppd w=2u l=76.7u m=1 b=0
RRD212 RD2_11 RD2_12 vss rppd w=2u l=76.7u m=1 b=0
RRD213 RD2_12 RD2_13 vss rppd w=2u l=76.7u m=1 b=0
RRD214 RD2_13 RD2_14 vss rppd w=2u l=76.7u m=1 b=0
RRD215 RD2_14 RD2_15 vss rppd w=2u l=76.7u m=1 b=0
RRD216 RD2_15 RD2_16 vss rppd w=2u l=76.7u m=1 b=0
RRD217 RD2_16 RD2_17 vss rppd w=2u l=76.7u m=1 b=0
RRD218 RD2_17 RD2_18 vss rppd w=2u l=76.7u m=1 b=0
RRD219 RD2_18 RD2_19 vss rppd w=2u l=76.7u m=1 b=0
RRD220 RD2_19 RD2_20 vss rppd w=2u l=76.7u m=1 b=0
RRD221 RD2_20 RD2_21 vss rppd w=2u l=76.7u m=1 b=0
RRD222 RD2_21 RD2_22 vss rppd w=2u l=76.7u m=1 b=0
RRD223 RD2_22 RD2_23 vss rppd w=2u l=76.7u m=1 b=0
RRD224 RD2_23 RD2_24 vss rppd w=2u l=76.7u m=1 b=0
RRD225 RD2_24 RD2_25 vss rppd w=2u l=76.7u m=1 b=0
RRD226 RD2_25 RD2_26 vss rppd w=2u l=76.7u m=1 b=0
RRD227 RD2_26 RD2_27 vss rppd w=2u l=76.7u m=1 b=0
RRD228 RD2_27 RD2_28 vss rppd w=2u l=76.7u m=1 b=0
RRD229 RD2_28 RD2_29 vss rppd w=2u l=76.7u m=1 b=0
RRD230 RD2_29 RD2_30 vss rppd w=2u l=76.7u m=1 b=0
RRD231 RD2_30 RD2_31 vss rppd w=2u l=76.7u m=1 b=0
RRD232 RD2_31 RD2_32 vss rppd w=2u l=76.7u m=1 b=0
RRD233 RD2_32 RD2_33 vss rppd w=2u l=76.7u m=1 b=0
RRD234 RD2_33 RD2_34 vss rppd w=2u l=76.7u m=1 b=0
RRD235 RD2_34 RD2_35 vss rppd w=2u l=76.7u m=1 b=0
RRD236 RD2_35 RD2_36 vss rppd w=2u l=76.7u m=1 b=0
RRD237 RD2_36 RD2_37 vss rppd w=2u l=76.7u m=1 b=0
RRD238 RD2_37 RD2_38 vss rppd w=2u l=76.7u m=1 b=0
RRD239 RD2_38 RD2_39 vss rppd w=2u l=76.7u m=1 b=0
RRD240 RD2_39 RD2_40 vss rppd w=2u l=76.7u m=1 b=0
RRD241 RD2_40 RD2_41 vss rppd w=2u l=76.7u m=1 b=0
RRD242 RD2_41 RD2_42 vss rppd w=2u l=76.7u m=1 b=0
RRD243 RD2_42 RD2_43 vss rppd w=2u l=76.7u m=1 b=0
RRD244 RD2_43 RD2_44 vss rppd w=2u l=76.7u m=1 b=0
RRD245 RD2_44 RD2_45 vss rppd w=2u l=76.7u m=1 b=0
RRD246 RD2_45 RD2_46 vss rppd w=2u l=76.7u m=1 b=0
RRD247 RD2_46 RD2_47 vss rppd w=2u l=76.7u m=1 b=0
RRD248 RD2_47 RD2_48 vss rppd w=2u l=76.7u m=1 b=0
RRD249 RD2_48 RD2_49 vss rppd w=2u l=76.7u m=1 b=0
RRD250 RD2_49 vss vss rppd w=2u l=76.7u m=1 b=0
MMBI iptat iptat vss vss sg13_hv_nmos w=3.3u l=1u m=1
XOTA vp vn iptat isense vdd vss g1_ota
XBUF vped_ref vped iptat vped vdd vss g1_ota
XREF vref vref_buf iptat vref_buf vdd vss g1_ota
.ends
.subckt g1_ota inp inn vbn out vdd vss
MMB2 vbp vbn vss vss sg13_hv_nmos w=8u l=1u m=1
MMB3 vbp vbp vdd vdd sg13_hv_pmos w=16u l=1u m=1
MMB5 vbnc vbp vdd vdd sg13_hv_pmos w=16u l=1u m=1
MMB4 vbnc vbnc vss vss sg13_hv_nmos w=1.6u l=1u m=1
MMB6 vbpc vbn vss vss sg13_hv_nmos w=8u l=1u m=1
MMB7 vbpc vbpc vdd vdd sg13_hv_pmos w=3.2u l=1u m=1
MMT tail vbp vdd vdd sg13_hv_pmos w=128u l=1u m=1
MM1 fn inn tail vdd sg13_hv_pmos w=96u l=2u m=1
MM2 fp inp tail vdd sg13_hv_pmos w=96u l=2u m=1
MM3 fn vbn vss vss sg13_hv_nmos w=80u l=1u m=1
MM4 fp vbn vss vss sg13_hv_nmos w=80u l=1u m=1
MM13 mir vbnc fn vss sg13_hv_nmos w=48u l=1u m=1
MM16 out1 vbnc fp vss sg13_hv_nmos w=48u l=1u m=1
MM14 pc1 mir vdd vdd sg13_hv_pmos w=96u l=1u m=1
MM11 pc2 mir vdd vdd sg13_hv_pmos w=96u l=1u m=1
MM15 mir vbpc pc1 vdd sg13_hv_pmos w=96u l=1u m=1
MM12 out1 vbpc pc2 vdd sg13_hv_pmos w=96u l=1u m=1
MM20 out out1 vdd vdd sg13_hv_pmos w=192u l=1u m=1
MM21 out vbn vss vss sg13_hv_nmos w=96u l=1u m=1
RRZ out1 cz vss rppd w=1u l=6.2u m=1 b=0
CCC cz out cap_cmim w=23u l=23u m=1
.ends

* ---- macro g1_t2f (/work/designs/g1-guardian/blocks/g1_t2f/layout/g1_t2f_lvs.cdl) ----
* G1_T2F LVS reference, generated by make_lvs_cdl.py from xschem/g1_t2f.spice (frozen schematic)
.subckt g1_t2f vdd vdd12 vss pbias pcasc vref en mode fout
MMPO do pbias vdd vdd sg13_hv_pmos w=10u l=4u ng=1 m=1
MMCO isrc pcasc do do sg13_hv_pmos w=10u l=4u ng=1 m=1
MMPR dr pbias vdd vdd sg13_hv_pmos w=10u l=4u ng=1 m=2
MMCR vr pcasc dr dr sg13_hv_pmos w=10u l=4u ng=1 m=2
RRREF1 vr vr_1 vss rppd w=0.5u l=24.5u m=1 b=0
RRREF2 vr_1 vr_2 vss rppd w=0.5u l=24.5u m=1 b=0
RRREF3 vr_2 vr_3 vss rppd w=0.5u l=24.5u m=1 b=0
RRREF4 vr_3 vr_4 vss rppd w=0.5u l=24.5u m=1 b=0
RRREF5 vr_4 vr_5 vss rppd w=0.5u l=24.5u m=1 b=0
RRREF6 vr_5 vr_6 vss rppd w=0.5u l=24.5u m=1 b=0
RRREF7 vr_6 vr_7 vss rppd w=0.5u l=24.5u m=1 b=0
RRREF8 vr_7 vr_8 vss rppd w=0.5u l=24.5u m=1 b=0
RRREF9 vr_8 vr_9 vss rppd w=0.5u l=24.5u m=1 b=0
RRREF10 vr_9 vss vss rppd w=0.5u l=24.5u m=1 b=0
MMPB db pbias vdd vdd sg13_hv_pmos w=10u l=4u ng=1 m=1
MMCB nbias pcasc db db sg13_hv_pmos w=10u l=4u ng=1 m=1
MMNB nbias nbias vss vss sg13_hv_nmos w=10u l=2u ng=1 m=1
MMPF vcg pbias vdd vdd sg13_hv_pmos w=10u l=4u ng=1 m=1
MMSF vss vth vcg vcg sg13_hv_pmos w=2u l=2u ng=1 m=1
MMX1 vref moden vth vss sg13_hv_nmos w=4u l=0.5u ng=1 m=1
MMX2 vr mode vth vss sg13_hv_nmos w=4u l=0.5u ng=1 m=1
MIMN moden mode vss vss sg13_hv_nmos w=1u l=0.5u ng=1 m=1
MIMP moden mode vdd vdd sg13_hv_pmos w=2u l=0.5u ng=1 m=1
QQA1 ca1 vth tail1 vss npn13G2 le=900n we=70n Nx=1
QQB1 cb1 cap1 tail1 vss npn13G2 le=900n we=70n Nx=1
MMCA1 oa1 vcg ca1 vss sg13_hv_nmos w=4u l=1u ng=1 m=1
MMCB1 ob1 vcg cb1 vss sg13_hv_nmos w=4u l=1u ng=1 m=1
MMBA1 ca1 nbias vss vss sg13_hv_nmos w=0.5u l=2u ng=1 m=1
MMBB1 cb1 nbias vss vss sg13_hv_nmos w=0.5u l=2u ng=1 m=1
MMLA1 oa1 oa1 vdd vdd sg13_hv_pmos w=4u l=1u ng=1 m=1
MMLB1 ob1 oa1 vdd vdd sg13_hv_pmos w=4u l=1u ng=1 m=1
MMT1 tail1 nbias vss vss sg13_hv_nmos w=20u l=2u ng=1 m=1
MIC1AN c1 ob1 vss vss sg13_hv_nmos w=1u l=0.5u ng=1 m=1
MIC1AP c1 ob1 vdd vdd sg13_hv_pmos w=2u l=0.5u ng=1 m=1
MIC1BN sn c1 vss vss sg13_hv_nmos w=2u l=0.5u ng=1 m=1
MIC1BP sn c1 vdd vdd sg13_hv_pmos w=4u l=0.5u ng=1 m=1
QQA2 ca2 vth tail2 vss npn13G2 le=900n we=70n Nx=1
QQB2 cb2 cap2 tail2 vss npn13G2 le=900n we=70n Nx=1
MMCA2 oa2 vcg ca2 vss sg13_hv_nmos w=4u l=1u ng=1 m=1
MMCB2 ob2 vcg cb2 vss sg13_hv_nmos w=4u l=1u ng=1 m=1
MMBA2 ca2 nbias vss vss sg13_hv_nmos w=0.5u l=2u ng=1 m=1
MMBB2 cb2 nbias vss vss sg13_hv_nmos w=0.5u l=2u ng=1 m=1
MMLA2 oa2 oa2 vdd vdd sg13_hv_pmos w=4u l=1u ng=1 m=1
MMLB2 ob2 oa2 vdd vdd sg13_hv_pmos w=4u l=1u ng=1 m=1
MMT2 tail2 nbias vss vss sg13_hv_nmos w=20u l=2u ng=1 m=1
MIC2AN c2 ob2 vss vss sg13_hv_nmos w=1u l=0.5u ng=1 m=1
MIC2AP c2 ob2 vdd vdd sg13_hv_pmos w=2u l=0.5u ng=1 m=1
MIC2BN rn c2 vss vss sg13_hv_nmos w=2u l=0.5u ng=1 m=1
MIC2BP rn c2 vdd vdd sg13_hv_pmos w=4u l=0.5u ng=1 m=1
MNQPA q sn vdd vdd sg13_hv_pmos w=2u l=0.5u ng=1 m=1
MNQPB q qn vdd vdd sg13_hv_pmos w=2u l=0.5u ng=1 m=1
MNQNA q sn NQ_i vss sg13_hv_nmos w=2u l=0.5u ng=1 m=1
MNQNB NQ_i qn vss vss sg13_hv_nmos w=2u l=0.5u ng=1 m=1
MNQNPA qn rn vdd vdd sg13_hv_pmos w=2u l=0.5u ng=1 m=1
MNQNPB qn q vdd vdd sg13_hv_pmos w=2u l=0.5u ng=1 m=1
MNQNPC qn en vdd vdd sg13_hv_pmos w=2u l=0.5u ng=1 m=1
MNQNNA qn rn NQN_i vss sg13_hv_nmos w=3u l=0.5u ng=1 m=1
MNQNNB NQN_i q NQN_j vss sg13_hv_nmos w=3u l=0.5u ng=1 m=1
MNQNNC NQN_j en vss vss sg13_hv_nmos w=3u l=0.5u ng=1 m=1
MND1PA d1g qn vdd vdd sg13_hv_pmos w=2u l=0.5u ng=1 m=1
MND1PB d1g en vdd vdd sg13_hv_pmos w=2u l=0.5u ng=1 m=1
MND1NA d1g qn ND1_i vss sg13_hv_nmos w=2u l=0.5u ng=1 m=1
MND1NB ND1_i en vss vss sg13_hv_nmos w=2u l=0.5u ng=1 m=1
MND2PA d2g q vdd vdd sg13_hv_pmos w=2u l=0.5u ng=1 m=1
MND2PB d2g en vdd vdd sg13_hv_pmos w=2u l=0.5u ng=1 m=1
MND2NA d2g q ND2_i vss sg13_hv_nmos w=2u l=0.5u ng=1 m=1
MND2NB ND2_i en vss vss sg13_hv_nmos w=2u l=0.5u ng=1 m=1
MSW1 cap1 d1g isrc vdd sg13_hv_pmos w=4u l=0.5u ng=1 m=1
MD1 cap1 d1g vss vss sg13_hv_nmos w=4u l=0.5u ng=1 m=1
MSW2 cap2 d2g isrc vdd sg13_hv_pmos w=4u l=0.5u ng=1 m=1
MD2 cap2 d2g vss vss sg13_hv_nmos w=4u l=0.5u ng=1 m=1
CC1 cap1 vss cap_cmim w=28u l=28u m=1
CC2 cap2 vss cap_cmim w=28u l=28u m=1
MIAN a d2g vss vss sg13_hv_nmos w=1u l=0.5u ng=1 m=1
MIAP a d2g vdd vdd sg13_hv_pmos w=2u l=0.5u ng=1 m=1
MMLSA lsa a vss vss sg13_hv_nmos w=2u l=0.5u ng=1 m=1
MMLSB lsb d2g vss vss sg13_hv_nmos w=2u l=0.5u ng=1 m=1
MMLPA lsa lsb vdd12 vdd12 sg13_lv_pmos w=0.5u l=0.3u ng=1 m=1
MMLPB lsb lsa vdd12 vdd12 sg13_lv_pmos w=0.5u l=0.3u ng=1 m=1
MIO1N fon lsb vss vss sg13_lv_nmos w=0.5u l=0.13u ng=1 m=1
MIO1P fon lsb vdd12 vdd12 sg13_lv_pmos w=1u l=0.13u ng=1 m=1
MIO2N fout fon vss vss sg13_lv_nmos w=1u l=0.13u ng=1 m=1
MIO2P fout fon vdd12 vdd12 sg13_lv_pmos w=2u l=0.13u ng=1 m=1
QQD1 vss vss vss vss npn13G2 le=900n we=70n Nx=1
QQD2 vss vss vss vss npn13G2 le=900n we=70n Nx=1
.ends

* ---- macro g1_trip (/work/designs/g1-guardian/blocks/g1_trip/layout/g1_trip_lvs.cdl) ----
* LVS reference netlist derived from g1_trip.spice by lvs_netlist.py (see docstring)
.subckt g1_trip ISENSE VREF clk dac_soft[0] dac_soft[1] dac_soft[2] dac_soft[3] dac_soft[4] dac_soft[5] dac_soft[6] dac_soft[7] dac_hard[0] dac_hard[1] dac_hard[2] dac_hard[3] dac_hard[4] dac_hard[5] dac_hard[6] dac_hard[7] cmp_soft cmp_hard VDD IOVDD VSS
XCOND ISENSE icmp VSS g1_cond
XDACS VREF dac_soft[0] dac_soft[1] dac_soft[2] dac_soft[3] dac_soft[4] dac_soft[5] dac_soft[6] dac_soft[7] vth_soft VDD IOVDD VSS g1_dac8
XDACH VREF dac_hard[0] dac_hard[1] dac_hard[2] dac_hard[3] dac_hard[4] dac_hard[5] dac_hard[6] dac_hard[7] vth_hard VDD IOVDD VSS g1_dac8
CCHS vth_soft VSS cap_cmim w=26u l=26u m=1
CCHH vth_hard VSS cap_cmim w=26u l=26u m=1
XCLKI clk cmp_clk_n VDD VSS g1_inv
XCS icmp vth_soft clk cmp_soft cmp_soft_n VDD VSS g1_cmp
XCH icmp vth_hard cmp_clk_n cmp_hard cmp_hard_n VDD VSS g1_cmp
.ends
.subckt g1_cond isense icmp vss
RRC0 isense c0 vss rppd w=2u l=76.7u b=0 m=1
RRC1 c0 c1 vss rppd w=2u l=76.7u b=0 m=1
RRC2 c1 c2 vss rppd w=2u l=76.7u b=0 m=1
RRC3 c2 c3 vss rppd w=2u l=76.7u b=0 m=1
RRC4 c3 icmp vss rppd w=2u l=76.7u b=0 m=1
RRC5 icmp c5 vss rppd w=2u l=76.7u b=0 m=1
RRC6 c5 c6 vss rppd w=2u l=76.7u b=0 m=1
RRC7 c6 c7 vss rppd w=2u l=76.7u b=0 m=1
RRC8 c7 c8 vss rppd w=2u l=76.7u b=0 m=1
RRC9 c8 vss vss rppd w=2u l=76.7u b=0 m=1
CCH icmp vss cap_cmim w=26u l=26u m=1
.ends
.subckt g1_dac8 vref d0 d1 d2 d3 d4 d5 d6 d7 out vdd vdda vss
RRU0 s0 vss vss rppd w=4u l=1.2u b=0 m=1
RRU1 s1 s0 vss rppd w=4u l=1.2u b=0 m=1
RRU2 s2 s1 vss rppd w=4u l=1.2u b=0 m=1
RRU3 s3 s2 vss rppd w=4u l=1.2u b=0 m=1
RRU4 s4 s3 vss rppd w=4u l=1.2u b=0 m=1
RRU5 s5 s4 vss rppd w=4u l=1.2u b=0 m=1
RRU6 s6 s5 vss rppd w=4u l=1.2u b=0 m=1
RRU7 s7 s6 vss rppd w=4u l=1.2u b=0 m=1
RRU8 s8 s7 vss rppd w=4u l=1.2u b=0 m=1
RRU9 s9 s8 vss rppd w=4u l=1.2u b=0 m=1
RRU10 s10 s9 vss rppd w=4u l=1.2u b=0 m=1
RRU11 s11 s10 vss rppd w=4u l=1.2u b=0 m=1
RRU12 s12 s11 vss rppd w=4u l=1.2u b=0 m=1
RRU13 s13 s12 vss rppd w=4u l=1.2u b=0 m=1
RRU14 s14 s13 vss rppd w=4u l=1.2u b=0 m=1
RRU15 s15 s14 vss rppd w=4u l=1.2u b=0 m=1
RRU16 s16 s15 vss rppd w=4u l=1.2u b=0 m=1
RRU17 s17 s16 vss rppd w=4u l=1.2u b=0 m=1
RRU18 s18 s17 vss rppd w=4u l=1.2u b=0 m=1
RRU19 s19 s18 vss rppd w=4u l=1.2u b=0 m=1
RRU20 s20 s19 vss rppd w=4u l=1.2u b=0 m=1
RRU21 s21 s20 vss rppd w=4u l=1.2u b=0 m=1
RRU22 s22 s21 vss rppd w=4u l=1.2u b=0 m=1
RRU23 s23 s22 vss rppd w=4u l=1.2u b=0 m=1
RRU24 s24 s23 vss rppd w=4u l=1.2u b=0 m=1
RRU25 s25 s24 vss rppd w=4u l=1.2u b=0 m=1
RRU26 s26 s25 vss rppd w=4u l=1.2u b=0 m=1
RRU27 s27 s26 vss rppd w=4u l=1.2u b=0 m=1
RRU28 s28 s27 vss rppd w=4u l=1.2u b=0 m=1
RRU29 s29 s28 vss rppd w=4u l=1.2u b=0 m=1
RRU30 s30 s29 vss rppd w=4u l=1.2u b=0 m=1
RRU31 s31 s30 vss rppd w=4u l=1.2u b=0 m=1
RRU32 s32 s31 vss rppd w=4u l=1.2u b=0 m=1
RRU33 s33 s32 vss rppd w=4u l=1.2u b=0 m=1
RRU34 s34 s33 vss rppd w=4u l=1.2u b=0 m=1
RRU35 s35 s34 vss rppd w=4u l=1.2u b=0 m=1
RRU36 s36 s35 vss rppd w=4u l=1.2u b=0 m=1
RRU37 s37 s36 vss rppd w=4u l=1.2u b=0 m=1
RRU38 s38 s37 vss rppd w=4u l=1.2u b=0 m=1
RRU39 s39 s38 vss rppd w=4u l=1.2u b=0 m=1
RRU40 s40 s39 vss rppd w=4u l=1.2u b=0 m=1
RRU41 s41 s40 vss rppd w=4u l=1.2u b=0 m=1
RRU42 s42 s41 vss rppd w=4u l=1.2u b=0 m=1
RRU43 s43 s42 vss rppd w=4u l=1.2u b=0 m=1
RRU44 s44 s43 vss rppd w=4u l=1.2u b=0 m=1
RRU45 s45 s44 vss rppd w=4u l=1.2u b=0 m=1
RRU46 s46 s45 vss rppd w=4u l=1.2u b=0 m=1
RRU47 s47 s46 vss rppd w=4u l=1.2u b=0 m=1
RRU48 s48 s47 vss rppd w=4u l=1.2u b=0 m=1
RRU49 s49 s48 vss rppd w=4u l=1.2u b=0 m=1
RRU50 s50 s49 vss rppd w=4u l=1.2u b=0 m=1
RRU51 s51 s50 vss rppd w=4u l=1.2u b=0 m=1
RRU52 s52 s51 vss rppd w=4u l=1.2u b=0 m=1
RRU53 s53 s52 vss rppd w=4u l=1.2u b=0 m=1
RRU54 s54 s53 vss rppd w=4u l=1.2u b=0 m=1
RRU55 s55 s54 vss rppd w=4u l=1.2u b=0 m=1
RRU56 s56 s55 vss rppd w=4u l=1.2u b=0 m=1
RRU57 s57 s56 vss rppd w=4u l=1.2u b=0 m=1
RRU58 s58 s57 vss rppd w=4u l=1.2u b=0 m=1
RRU59 s59 s58 vss rppd w=4u l=1.2u b=0 m=1
RRU60 s60 s59 vss rppd w=4u l=1.2u b=0 m=1
RRU61 s61 s60 vss rppd w=4u l=1.2u b=0 m=1
RRU62 s62 s61 vss rppd w=4u l=1.2u b=0 m=1
RRU63 s63 s62 vss rppd w=4u l=1.2u b=0 m=1
RRU64 s64 s63 vss rppd w=4u l=1.2u b=0 m=1
RRU65 s65 s64 vss rppd w=4u l=1.2u b=0 m=1
RRU66 s66 s65 vss rppd w=4u l=1.2u b=0 m=1
RRU67 s67 s66 vss rppd w=4u l=1.2u b=0 m=1
RRU68 s68 s67 vss rppd w=4u l=1.2u b=0 m=1
RRU69 s69 s68 vss rppd w=4u l=1.2u b=0 m=1
RRU70 s70 s69 vss rppd w=4u l=1.2u b=0 m=1
RRU71 s71 s70 vss rppd w=4u l=1.2u b=0 m=1
RRU72 s72 s71 vss rppd w=4u l=1.2u b=0 m=1
RRU73 s73 s72 vss rppd w=4u l=1.2u b=0 m=1
RRU74 s74 s73 vss rppd w=4u l=1.2u b=0 m=1
RRU75 s75 s74 vss rppd w=4u l=1.2u b=0 m=1
RRU76 s76 s75 vss rppd w=4u l=1.2u b=0 m=1
RRU77 s77 s76 vss rppd w=4u l=1.2u b=0 m=1
RRU78 s78 s77 vss rppd w=4u l=1.2u b=0 m=1
RRU79 s79 s78 vss rppd w=4u l=1.2u b=0 m=1
RRU80 s80 s79 vss rppd w=4u l=1.2u b=0 m=1
RRU81 s81 s80 vss rppd w=4u l=1.2u b=0 m=1
RRU82 s82 s81 vss rppd w=4u l=1.2u b=0 m=1
RRU83 s83 s82 vss rppd w=4u l=1.2u b=0 m=1
RRU84 s84 s83 vss rppd w=4u l=1.2u b=0 m=1
RRU85 s85 s84 vss rppd w=4u l=1.2u b=0 m=1
RRU86 s86 s85 vss rppd w=4u l=1.2u b=0 m=1
RRU87 s87 s86 vss rppd w=4u l=1.2u b=0 m=1
RRU88 s88 s87 vss rppd w=4u l=1.2u b=0 m=1
RRU89 s89 s88 vss rppd w=4u l=1.2u b=0 m=1
RRU90 s90 s89 vss rppd w=4u l=1.2u b=0 m=1
RRU91 s91 s90 vss rppd w=4u l=1.2u b=0 m=1
RRU92 s92 s91 vss rppd w=4u l=1.2u b=0 m=1
RRU93 s93 s92 vss rppd w=4u l=1.2u b=0 m=1
RRU94 s94 s93 vss rppd w=4u l=1.2u b=0 m=1
RRU95 s95 s94 vss rppd w=4u l=1.2u b=0 m=1
RRU96 s96 s95 vss rppd w=4u l=1.2u b=0 m=1
RRU97 s97 s96 vss rppd w=4u l=1.2u b=0 m=1
RRU98 s98 s97 vss rppd w=4u l=1.2u b=0 m=1
RRU99 s99 s98 vss rppd w=4u l=1.2u b=0 m=1
RRU100 s100 s99 vss rppd w=4u l=1.2u b=0 m=1
RRU101 s101 s100 vss rppd w=4u l=1.2u b=0 m=1
RRU102 s102 s101 vss rppd w=4u l=1.2u b=0 m=1
RRU103 s103 s102 vss rppd w=4u l=1.2u b=0 m=1
RRU104 s104 s103 vss rppd w=4u l=1.2u b=0 m=1
RRU105 s105 s104 vss rppd w=4u l=1.2u b=0 m=1
RRU106 s106 s105 vss rppd w=4u l=1.2u b=0 m=1
RRU107 s107 s106 vss rppd w=4u l=1.2u b=0 m=1
RRU108 s108 s107 vss rppd w=4u l=1.2u b=0 m=1
RRU109 s109 s108 vss rppd w=4u l=1.2u b=0 m=1
RRU110 s110 s109 vss rppd w=4u l=1.2u b=0 m=1
RRU111 s111 s110 vss rppd w=4u l=1.2u b=0 m=1
RRU112 s112 s111 vss rppd w=4u l=1.2u b=0 m=1
RRU113 s113 s112 vss rppd w=4u l=1.2u b=0 m=1
RRU114 s114 s113 vss rppd w=4u l=1.2u b=0 m=1
RRU115 s115 s114 vss rppd w=4u l=1.2u b=0 m=1
RRU116 s116 s115 vss rppd w=4u l=1.2u b=0 m=1
RRU117 s117 s116 vss rppd w=4u l=1.2u b=0 m=1
RRU118 s118 s117 vss rppd w=4u l=1.2u b=0 m=1
RRU119 s119 s118 vss rppd w=4u l=1.2u b=0 m=1
RRU120 s120 s119 vss rppd w=4u l=1.2u b=0 m=1
RRU121 s121 s120 vss rppd w=4u l=1.2u b=0 m=1
RRU122 s122 s121 vss rppd w=4u l=1.2u b=0 m=1
RRU123 s123 s122 vss rppd w=4u l=1.2u b=0 m=1
RRU124 s124 s123 vss rppd w=4u l=1.2u b=0 m=1
RRU125 s125 s124 vss rppd w=4u l=1.2u b=0 m=1
RRU126 s126 s125 vss rppd w=4u l=1.2u b=0 m=1
RRU127 s127 s126 vss rppd w=4u l=1.2u b=0 m=1
RRU128 s128 s127 vss rppd w=4u l=1.2u b=0 m=1
RRU129 s129 s128 vss rppd w=4u l=1.2u b=0 m=1
RRU130 s130 s129 vss rppd w=4u l=1.2u b=0 m=1
RRU131 s131 s130 vss rppd w=4u l=1.2u b=0 m=1
RRU132 s132 s131 vss rppd w=4u l=1.2u b=0 m=1
RRU133 s133 s132 vss rppd w=4u l=1.2u b=0 m=1
RRU134 s134 s133 vss rppd w=4u l=1.2u b=0 m=1
RRU135 s135 s134 vss rppd w=4u l=1.2u b=0 m=1
RRU136 s136 s135 vss rppd w=4u l=1.2u b=0 m=1
RRU137 s137 s136 vss rppd w=4u l=1.2u b=0 m=1
RRU138 s138 s137 vss rppd w=4u l=1.2u b=0 m=1
RRU139 s139 s138 vss rppd w=4u l=1.2u b=0 m=1
RRU140 s140 s139 vss rppd w=4u l=1.2u b=0 m=1
RRU141 s141 s140 vss rppd w=4u l=1.2u b=0 m=1
RRU142 s142 s141 vss rppd w=4u l=1.2u b=0 m=1
RRU143 s143 s142 vss rppd w=4u l=1.2u b=0 m=1
RRU144 s144 s143 vss rppd w=4u l=1.2u b=0 m=1
RRU145 s145 s144 vss rppd w=4u l=1.2u b=0 m=1
RRU146 s146 s145 vss rppd w=4u l=1.2u b=0 m=1
RRU147 s147 s146 vss rppd w=4u l=1.2u b=0 m=1
RRU148 s148 s147 vss rppd w=4u l=1.2u b=0 m=1
RRU149 s149 s148 vss rppd w=4u l=1.2u b=0 m=1
RRU150 s150 s149 vss rppd w=4u l=1.2u b=0 m=1
RRU151 s151 s150 vss rppd w=4u l=1.2u b=0 m=1
RRU152 s152 s151 vss rppd w=4u l=1.2u b=0 m=1
RRU153 s153 s152 vss rppd w=4u l=1.2u b=0 m=1
RRU154 s154 s153 vss rppd w=4u l=1.2u b=0 m=1
RRU155 s155 s154 vss rppd w=4u l=1.2u b=0 m=1
RRU156 s156 s155 vss rppd w=4u l=1.2u b=0 m=1
RRU157 s157 s156 vss rppd w=4u l=1.2u b=0 m=1
RRU158 s158 s157 vss rppd w=4u l=1.2u b=0 m=1
RRU159 s159 s158 vss rppd w=4u l=1.2u b=0 m=1
RRU160 s160 s159 vss rppd w=4u l=1.2u b=0 m=1
RRU161 s161 s160 vss rppd w=4u l=1.2u b=0 m=1
RRU162 s162 s161 vss rppd w=4u l=1.2u b=0 m=1
RRU163 s163 s162 vss rppd w=4u l=1.2u b=0 m=1
RRU164 s164 s163 vss rppd w=4u l=1.2u b=0 m=1
RRU165 s165 s164 vss rppd w=4u l=1.2u b=0 m=1
RRU166 s166 s165 vss rppd w=4u l=1.2u b=0 m=1
RRU167 s167 s166 vss rppd w=4u l=1.2u b=0 m=1
RRU168 s168 s167 vss rppd w=4u l=1.2u b=0 m=1
RRU169 s169 s168 vss rppd w=4u l=1.2u b=0 m=1
RRU170 s170 s169 vss rppd w=4u l=1.2u b=0 m=1
RRU171 s171 s170 vss rppd w=4u l=1.2u b=0 m=1
RRU172 s172 s171 vss rppd w=4u l=1.2u b=0 m=1
RRU173 s173 s172 vss rppd w=4u l=1.2u b=0 m=1
RRU174 s174 s173 vss rppd w=4u l=1.2u b=0 m=1
RRU175 s175 s174 vss rppd w=4u l=1.2u b=0 m=1
RRU176 s176 s175 vss rppd w=4u l=1.2u b=0 m=1
RRU177 s177 s176 vss rppd w=4u l=1.2u b=0 m=1
RRU178 s178 s177 vss rppd w=4u l=1.2u b=0 m=1
RRU179 s179 s178 vss rppd w=4u l=1.2u b=0 m=1
RRU180 s180 s179 vss rppd w=4u l=1.2u b=0 m=1
RRU181 s181 s180 vss rppd w=4u l=1.2u b=0 m=1
RRU182 s182 s181 vss rppd w=4u l=1.2u b=0 m=1
RRU183 s183 s182 vss rppd w=4u l=1.2u b=0 m=1
RRU184 s184 s183 vss rppd w=4u l=1.2u b=0 m=1
RRU185 s185 s184 vss rppd w=4u l=1.2u b=0 m=1
RRU186 s186 s185 vss rppd w=4u l=1.2u b=0 m=1
RRU187 s187 s186 vss rppd w=4u l=1.2u b=0 m=1
RRU188 s188 s187 vss rppd w=4u l=1.2u b=0 m=1
RRU189 s189 s188 vss rppd w=4u l=1.2u b=0 m=1
RRU190 s190 s189 vss rppd w=4u l=1.2u b=0 m=1
RRU191 s191 s190 vss rppd w=4u l=1.2u b=0 m=1
RRU192 s192 s191 vss rppd w=4u l=1.2u b=0 m=1
RRU193 s193 s192 vss rppd w=4u l=1.2u b=0 m=1
RRU194 s194 s193 vss rppd w=4u l=1.2u b=0 m=1
RRU195 s195 s194 vss rppd w=4u l=1.2u b=0 m=1
RRU196 s196 s195 vss rppd w=4u l=1.2u b=0 m=1
RRU197 s197 s196 vss rppd w=4u l=1.2u b=0 m=1
RRU198 s198 s197 vss rppd w=4u l=1.2u b=0 m=1
RRU199 s199 s198 vss rppd w=4u l=1.2u b=0 m=1
RRU200 s200 s199 vss rppd w=4u l=1.2u b=0 m=1
RRU201 s201 s200 vss rppd w=4u l=1.2u b=0 m=1
RRU202 s202 s201 vss rppd w=4u l=1.2u b=0 m=1
RRU203 s203 s202 vss rppd w=4u l=1.2u b=0 m=1
RRU204 s204 s203 vss rppd w=4u l=1.2u b=0 m=1
RRU205 s205 s204 vss rppd w=4u l=1.2u b=0 m=1
RRU206 s206 s205 vss rppd w=4u l=1.2u b=0 m=1
RRU207 s207 s206 vss rppd w=4u l=1.2u b=0 m=1
RRU208 s208 s207 vss rppd w=4u l=1.2u b=0 m=1
RRU209 s209 s208 vss rppd w=4u l=1.2u b=0 m=1
RRU210 s210 s209 vss rppd w=4u l=1.2u b=0 m=1
RRU211 s211 s210 vss rppd w=4u l=1.2u b=0 m=1
RRU212 s212 s211 vss rppd w=4u l=1.2u b=0 m=1
RRU213 s213 s212 vss rppd w=4u l=1.2u b=0 m=1
RRU214 s214 s213 vss rppd w=4u l=1.2u b=0 m=1
RRU215 s215 s214 vss rppd w=4u l=1.2u b=0 m=1
RRU216 s216 s215 vss rppd w=4u l=1.2u b=0 m=1
RRU217 s217 s216 vss rppd w=4u l=1.2u b=0 m=1
RRU218 s218 s217 vss rppd w=4u l=1.2u b=0 m=1
RRU219 s219 s218 vss rppd w=4u l=1.2u b=0 m=1
RRU220 s220 s219 vss rppd w=4u l=1.2u b=0 m=1
RRU221 s221 s220 vss rppd w=4u l=1.2u b=0 m=1
RRU222 s222 s221 vss rppd w=4u l=1.2u b=0 m=1
RRU223 s223 s222 vss rppd w=4u l=1.2u b=0 m=1
RRU224 s224 s223 vss rppd w=4u l=1.2u b=0 m=1
RRU225 s225 s224 vss rppd w=4u l=1.2u b=0 m=1
RRU226 s226 s225 vss rppd w=4u l=1.2u b=0 m=1
RRU227 s227 s226 vss rppd w=4u l=1.2u b=0 m=1
RRU228 s228 s227 vss rppd w=4u l=1.2u b=0 m=1
RRU229 s229 s228 vss rppd w=4u l=1.2u b=0 m=1
RRU230 s230 s229 vss rppd w=4u l=1.2u b=0 m=1
RRU231 s231 s230 vss rppd w=4u l=1.2u b=0 m=1
RRU232 s232 s231 vss rppd w=4u l=1.2u b=0 m=1
RRU233 s233 s232 vss rppd w=4u l=1.2u b=0 m=1
RRU234 s234 s233 vss rppd w=4u l=1.2u b=0 m=1
RRU235 s235 s234 vss rppd w=4u l=1.2u b=0 m=1
RRU236 s236 s235 vss rppd w=4u l=1.2u b=0 m=1
RRU237 s237 s236 vss rppd w=4u l=1.2u b=0 m=1
RRU238 s238 s237 vss rppd w=4u l=1.2u b=0 m=1
RRU239 s239 s238 vss rppd w=4u l=1.2u b=0 m=1
RRU240 s240 s239 vss rppd w=4u l=1.2u b=0 m=1
RRU241 s241 s240 vss rppd w=4u l=1.2u b=0 m=1
RRU242 s242 s241 vss rppd w=4u l=1.2u b=0 m=1
RRU243 s243 s242 vss rppd w=4u l=1.2u b=0 m=1
RRU244 s244 s243 vss rppd w=4u l=1.2u b=0 m=1
RRU245 s245 s244 vss rppd w=4u l=1.2u b=0 m=1
RRU246 s246 s245 vss rppd w=4u l=1.2u b=0 m=1
RRU247 s247 s246 vss rppd w=4u l=1.2u b=0 m=1
RRU248 s248 s247 vss rppd w=4u l=1.2u b=0 m=1
RRU249 s249 s248 vss rppd w=4u l=1.2u b=0 m=1
RRU250 s250 s249 vss rppd w=4u l=1.2u b=0 m=1
RRU251 s251 s250 vss rppd w=4u l=1.2u b=0 m=1
RRU252 s252 s251 vss rppd w=4u l=1.2u b=0 m=1
RRU253 s253 s252 vss rppd w=4u l=1.2u b=0 m=1
RRU254 t0 s253 vss rppd w=4u l=1.2u b=0 m=1
RRU255 t1 t0 vss rppd w=4u l=1.2u b=0 m=1
RRU256 t2 t1 vss rppd w=4u l=1.2u b=0 m=1
RRU257 t3 t2 vss rppd w=4u l=1.2u b=0 m=1
RRU258 t4 t3 vss rppd w=4u l=1.2u b=0 m=1
RRU259 t5 t4 vss rppd w=4u l=1.2u b=0 m=1
RRU260 t6 t5 vss rppd w=4u l=1.2u b=0 m=1
RRU261 t7 t6 vss rppd w=4u l=1.2u b=0 m=1
RRU262 t8 t7 vss rppd w=4u l=1.2u b=0 m=1
RRU263 t9 t8 vss rppd w=4u l=1.2u b=0 m=1
RRU264 t10 t9 vss rppd w=4u l=1.2u b=0 m=1
RRU265 t11 t10 vss rppd w=4u l=1.2u b=0 m=1
RRU266 t12 t11 vss rppd w=4u l=1.2u b=0 m=1
RRU267 t13 t12 vss rppd w=4u l=1.2u b=0 m=1
RRU268 t14 t13 vss rppd w=4u l=1.2u b=0 m=1
RRU269 t15 t14 vss rppd w=4u l=1.2u b=0 m=1
RRU270 t16 t15 vss rppd w=4u l=1.2u b=0 m=1
RRU271 t17 t16 vss rppd w=4u l=1.2u b=0 m=1
RRU272 t18 t17 vss rppd w=4u l=1.2u b=0 m=1
RRU273 t19 t18 vss rppd w=4u l=1.2u b=0 m=1
RRU274 t20 t19 vss rppd w=4u l=1.2u b=0 m=1
RRU275 t21 t20 vss rppd w=4u l=1.2u b=0 m=1
RRU276 t22 t21 vss rppd w=4u l=1.2u b=0 m=1
RRU277 t23 t22 vss rppd w=4u l=1.2u b=0 m=1
RRU278 t24 t23 vss rppd w=4u l=1.2u b=0 m=1
RRU279 t25 t24 vss rppd w=4u l=1.2u b=0 m=1
RRU280 t26 t25 vss rppd w=4u l=1.2u b=0 m=1
RRU281 t27 t26 vss rppd w=4u l=1.2u b=0 m=1
RRU282 t28 t27 vss rppd w=4u l=1.2u b=0 m=1
RRU283 t29 t28 vss rppd w=4u l=1.2u b=0 m=1
RRU284 t30 t29 vss rppd w=4u l=1.2u b=0 m=1
RRU285 t31 t30 vss rppd w=4u l=1.2u b=0 m=1
RRU286 t32 t31 vss rppd w=4u l=1.2u b=0 m=1
RRU287 t33 t32 vss rppd w=4u l=1.2u b=0 m=1
RRU288 t34 t33 vss rppd w=4u l=1.2u b=0 m=1
RRU289 t35 t34 vss rppd w=4u l=1.2u b=0 m=1
RRU290 t36 t35 vss rppd w=4u l=1.2u b=0 m=1
RRU291 t37 t36 vss rppd w=4u l=1.2u b=0 m=1
RRU292 t38 t37 vss rppd w=4u l=1.2u b=0 m=1
RRU293 t39 t38 vss rppd w=4u l=1.2u b=0 m=1
RRU294 t40 t39 vss rppd w=4u l=1.2u b=0 m=1
RRU295 t41 t40 vss rppd w=4u l=1.2u b=0 m=1
RRU296 t42 t41 vss rppd w=4u l=1.2u b=0 m=1
RRU297 t43 t42 vss rppd w=4u l=1.2u b=0 m=1
RRU298 t44 t43 vss rppd w=4u l=1.2u b=0 m=1
RRU299 t45 t44 vss rppd w=4u l=1.2u b=0 m=1
RRU300 t46 t45 vss rppd w=4u l=1.2u b=0 m=1
RRU301 t47 t46 vss rppd w=4u l=1.2u b=0 m=1
RRU302 t48 t47 vss rppd w=4u l=1.2u b=0 m=1
RRU303 t49 t48 vss rppd w=4u l=1.2u b=0 m=1
RRU304 t50 t49 vss rppd w=4u l=1.2u b=0 m=1
RRU305 t51 t50 vss rppd w=4u l=1.2u b=0 m=1
RRU306 t52 t51 vss rppd w=4u l=1.2u b=0 m=1
RRU307 t53 t52 vss rppd w=4u l=1.2u b=0 m=1
RRU308 t54 t53 vss rppd w=4u l=1.2u b=0 m=1
RRU309 t55 t54 vss rppd w=4u l=1.2u b=0 m=1
RRU310 t56 t55 vss rppd w=4u l=1.2u b=0 m=1
RRU311 t57 t56 vss rppd w=4u l=1.2u b=0 m=1
RRU312 t58 t57 vss rppd w=4u l=1.2u b=0 m=1
RRU313 t59 t58 vss rppd w=4u l=1.2u b=0 m=1
RRU314 t60 t59 vss rppd w=4u l=1.2u b=0 m=1
RRU315 t61 t60 vss rppd w=4u l=1.2u b=0 m=1
RRU316 t62 t61 vss rppd w=4u l=1.2u b=0 m=1
RRU317 t63 t62 vss rppd w=4u l=1.2u b=0 m=1
RRU318 t64 t63 vss rppd w=4u l=1.2u b=0 m=1
RRU319 t65 t64 vss rppd w=4u l=1.2u b=0 m=1
RRU320 t66 t65 vss rppd w=4u l=1.2u b=0 m=1
RRU321 t67 t66 vss rppd w=4u l=1.2u b=0 m=1
RRU322 t68 t67 vss rppd w=4u l=1.2u b=0 m=1
RRU323 t69 t68 vss rppd w=4u l=1.2u b=0 m=1
RRU324 t70 t69 vss rppd w=4u l=1.2u b=0 m=1
RRU325 t71 t70 vss rppd w=4u l=1.2u b=0 m=1
RRU326 t72 t71 vss rppd w=4u l=1.2u b=0 m=1
RRU327 t73 t72 vss rppd w=4u l=1.2u b=0 m=1
RRU328 t74 t73 vss rppd w=4u l=1.2u b=0 m=1
RRU329 t75 t74 vss rppd w=4u l=1.2u b=0 m=1
RRU330 t76 t75 vss rppd w=4u l=1.2u b=0 m=1
RRU331 t77 t76 vss rppd w=4u l=1.2u b=0 m=1
RRU332 t78 t77 vss rppd w=4u l=1.2u b=0 m=1
RRU333 t79 t78 vss rppd w=4u l=1.2u b=0 m=1
RRU334 t80 t79 vss rppd w=4u l=1.2u b=0 m=1
RRU335 t81 t80 vss rppd w=4u l=1.2u b=0 m=1
RRU336 t82 t81 vss rppd w=4u l=1.2u b=0 m=1
RRU337 t83 t82 vss rppd w=4u l=1.2u b=0 m=1
RRU338 t84 t83 vss rppd w=4u l=1.2u b=0 m=1
RRU339 t85 t84 vss rppd w=4u l=1.2u b=0 m=1
RRU340 t86 t85 vss rppd w=4u l=1.2u b=0 m=1
RRU341 t87 t86 vss rppd w=4u l=1.2u b=0 m=1
RRU342 t88 t87 vss rppd w=4u l=1.2u b=0 m=1
RRU343 t89 t88 vss rppd w=4u l=1.2u b=0 m=1
RRU344 t90 t89 vss rppd w=4u l=1.2u b=0 m=1
RRU345 t91 t90 vss rppd w=4u l=1.2u b=0 m=1
RRU346 t92 t91 vss rppd w=4u l=1.2u b=0 m=1
RRU347 t93 t92 vss rppd w=4u l=1.2u b=0 m=1
RRU348 t94 t93 vss rppd w=4u l=1.2u b=0 m=1
RRU349 t95 t94 vss rppd w=4u l=1.2u b=0 m=1
RRU350 t96 t95 vss rppd w=4u l=1.2u b=0 m=1
RRU351 t97 t96 vss rppd w=4u l=1.2u b=0 m=1
RRU352 t98 t97 vss rppd w=4u l=1.2u b=0 m=1
RRU353 t99 t98 vss rppd w=4u l=1.2u b=0 m=1
RRU354 t100 t99 vss rppd w=4u l=1.2u b=0 m=1
RRU355 t101 t100 vss rppd w=4u l=1.2u b=0 m=1
RRU356 t102 t101 vss rppd w=4u l=1.2u b=0 m=1
RRU357 t103 t102 vss rppd w=4u l=1.2u b=0 m=1
RRU358 t104 t103 vss rppd w=4u l=1.2u b=0 m=1
RRU359 t105 t104 vss rppd w=4u l=1.2u b=0 m=1
RRU360 t106 t105 vss rppd w=4u l=1.2u b=0 m=1
RRU361 t107 t106 vss rppd w=4u l=1.2u b=0 m=1
RRU362 t108 t107 vss rppd w=4u l=1.2u b=0 m=1
RRU363 t109 t108 vss rppd w=4u l=1.2u b=0 m=1
RRU364 t110 t109 vss rppd w=4u l=1.2u b=0 m=1
RRU365 t111 t110 vss rppd w=4u l=1.2u b=0 m=1
RRU366 t112 t111 vss rppd w=4u l=1.2u b=0 m=1
RRU367 t113 t112 vss rppd w=4u l=1.2u b=0 m=1
RRU368 t114 t113 vss rppd w=4u l=1.2u b=0 m=1
RRU369 t115 t114 vss rppd w=4u l=1.2u b=0 m=1
RRU370 t116 t115 vss rppd w=4u l=1.2u b=0 m=1
RRU371 t117 t116 vss rppd w=4u l=1.2u b=0 m=1
RRU372 t118 t117 vss rppd w=4u l=1.2u b=0 m=1
RRU373 t119 t118 vss rppd w=4u l=1.2u b=0 m=1
RRU374 t120 t119 vss rppd w=4u l=1.2u b=0 m=1
RRU375 t121 t120 vss rppd w=4u l=1.2u b=0 m=1
RRU376 t122 t121 vss rppd w=4u l=1.2u b=0 m=1
RRU377 t123 t122 vss rppd w=4u l=1.2u b=0 m=1
RRU378 t124 t123 vss rppd w=4u l=1.2u b=0 m=1
RRU379 t125 t124 vss rppd w=4u l=1.2u b=0 m=1
RRU380 t126 t125 vss rppd w=4u l=1.2u b=0 m=1
RRU381 t127 t126 vss rppd w=4u l=1.2u b=0 m=1
RRU382 t128 t127 vss rppd w=4u l=1.2u b=0 m=1
RRU383 t129 t128 vss rppd w=4u l=1.2u b=0 m=1
RRU384 t130 t129 vss rppd w=4u l=1.2u b=0 m=1
RRU385 t131 t130 vss rppd w=4u l=1.2u b=0 m=1
RRU386 t132 t131 vss rppd w=4u l=1.2u b=0 m=1
RRU387 t133 t132 vss rppd w=4u l=1.2u b=0 m=1
RRU388 t134 t133 vss rppd w=4u l=1.2u b=0 m=1
RRU389 t135 t134 vss rppd w=4u l=1.2u b=0 m=1
RRU390 t136 t135 vss rppd w=4u l=1.2u b=0 m=1
RRU391 t137 t136 vss rppd w=4u l=1.2u b=0 m=1
RRU392 t138 t137 vss rppd w=4u l=1.2u b=0 m=1
RRU393 t139 t138 vss rppd w=4u l=1.2u b=0 m=1
RRU394 t140 t139 vss rppd w=4u l=1.2u b=0 m=1
RRU395 t141 t140 vss rppd w=4u l=1.2u b=0 m=1
RRU396 t142 t141 vss rppd w=4u l=1.2u b=0 m=1
RRU397 t143 t142 vss rppd w=4u l=1.2u b=0 m=1
RRU398 t144 t143 vss rppd w=4u l=1.2u b=0 m=1
RRU399 t145 t144 vss rppd w=4u l=1.2u b=0 m=1
RRU400 t146 t145 vss rppd w=4u l=1.2u b=0 m=1
RRU401 t147 t146 vss rppd w=4u l=1.2u b=0 m=1
RRU402 t148 t147 vss rppd w=4u l=1.2u b=0 m=1
RRU403 t149 t148 vss rppd w=4u l=1.2u b=0 m=1
RRU404 t150 t149 vss rppd w=4u l=1.2u b=0 m=1
RRU405 t151 t150 vss rppd w=4u l=1.2u b=0 m=1
RRU406 t152 t151 vss rppd w=4u l=1.2u b=0 m=1
RRU407 t153 t152 vss rppd w=4u l=1.2u b=0 m=1
RRU408 t154 t153 vss rppd w=4u l=1.2u b=0 m=1
RRU409 t155 t154 vss rppd w=4u l=1.2u b=0 m=1
RRU410 t156 t155 vss rppd w=4u l=1.2u b=0 m=1
RRU411 t157 t156 vss rppd w=4u l=1.2u b=0 m=1
RRU412 t158 t157 vss rppd w=4u l=1.2u b=0 m=1
RRU413 t159 t158 vss rppd w=4u l=1.2u b=0 m=1
RRU414 t160 t159 vss rppd w=4u l=1.2u b=0 m=1
RRU415 t161 t160 vss rppd w=4u l=1.2u b=0 m=1
RRU416 t162 t161 vss rppd w=4u l=1.2u b=0 m=1
RRU417 t163 t162 vss rppd w=4u l=1.2u b=0 m=1
RRU418 t164 t163 vss rppd w=4u l=1.2u b=0 m=1
RRU419 t165 t164 vss rppd w=4u l=1.2u b=0 m=1
RRU420 t166 t165 vss rppd w=4u l=1.2u b=0 m=1
RRU421 t167 t166 vss rppd w=4u l=1.2u b=0 m=1
RRU422 t168 t167 vss rppd w=4u l=1.2u b=0 m=1
RRU423 t169 t168 vss rppd w=4u l=1.2u b=0 m=1
RRU424 t170 t169 vss rppd w=4u l=1.2u b=0 m=1
RRU425 t171 t170 vss rppd w=4u l=1.2u b=0 m=1
RRU426 t172 t171 vss rppd w=4u l=1.2u b=0 m=1
RRU427 t173 t172 vss rppd w=4u l=1.2u b=0 m=1
RRU428 t174 t173 vss rppd w=4u l=1.2u b=0 m=1
RRU429 t175 t174 vss rppd w=4u l=1.2u b=0 m=1
RRU430 t176 t175 vss rppd w=4u l=1.2u b=0 m=1
RRU431 t177 t176 vss rppd w=4u l=1.2u b=0 m=1
RRU432 t178 t177 vss rppd w=4u l=1.2u b=0 m=1
RRU433 t179 t178 vss rppd w=4u l=1.2u b=0 m=1
RRU434 t180 t179 vss rppd w=4u l=1.2u b=0 m=1
RRU435 t181 t180 vss rppd w=4u l=1.2u b=0 m=1
RRU436 t182 t181 vss rppd w=4u l=1.2u b=0 m=1
RRU437 t183 t182 vss rppd w=4u l=1.2u b=0 m=1
RRU438 t184 t183 vss rppd w=4u l=1.2u b=0 m=1
RRU439 t185 t184 vss rppd w=4u l=1.2u b=0 m=1
RRU440 t186 t185 vss rppd w=4u l=1.2u b=0 m=1
RRU441 t187 t186 vss rppd w=4u l=1.2u b=0 m=1
RRU442 t188 t187 vss rppd w=4u l=1.2u b=0 m=1
RRU443 t189 t188 vss rppd w=4u l=1.2u b=0 m=1
RRU444 t190 t189 vss rppd w=4u l=1.2u b=0 m=1
RRU445 t191 t190 vss rppd w=4u l=1.2u b=0 m=1
RRU446 t192 t191 vss rppd w=4u l=1.2u b=0 m=1
RRU447 t193 t192 vss rppd w=4u l=1.2u b=0 m=1
RRU448 t194 t193 vss rppd w=4u l=1.2u b=0 m=1
RRU449 t195 t194 vss rppd w=4u l=1.2u b=0 m=1
RRU450 t196 t195 vss rppd w=4u l=1.2u b=0 m=1
RRU451 t197 t196 vss rppd w=4u l=1.2u b=0 m=1
RRU452 t198 t197 vss rppd w=4u l=1.2u b=0 m=1
RRU453 t199 t198 vss rppd w=4u l=1.2u b=0 m=1
RRU454 t200 t199 vss rppd w=4u l=1.2u b=0 m=1
RRU455 t201 t200 vss rppd w=4u l=1.2u b=0 m=1
RRU456 t202 t201 vss rppd w=4u l=1.2u b=0 m=1
RRU457 t203 t202 vss rppd w=4u l=1.2u b=0 m=1
RRU458 t204 t203 vss rppd w=4u l=1.2u b=0 m=1
RRU459 t205 t204 vss rppd w=4u l=1.2u b=0 m=1
RRU460 t206 t205 vss rppd w=4u l=1.2u b=0 m=1
RRU461 t207 t206 vss rppd w=4u l=1.2u b=0 m=1
RRU462 t208 t207 vss rppd w=4u l=1.2u b=0 m=1
RRU463 t209 t208 vss rppd w=4u l=1.2u b=0 m=1
RRU464 t210 t209 vss rppd w=4u l=1.2u b=0 m=1
RRU465 t211 t210 vss rppd w=4u l=1.2u b=0 m=1
RRU466 t212 t211 vss rppd w=4u l=1.2u b=0 m=1
RRU467 t213 t212 vss rppd w=4u l=1.2u b=0 m=1
RRU468 t214 t213 vss rppd w=4u l=1.2u b=0 m=1
RRU469 t215 t214 vss rppd w=4u l=1.2u b=0 m=1
RRU470 t216 t215 vss rppd w=4u l=1.2u b=0 m=1
RRU471 t217 t216 vss rppd w=4u l=1.2u b=0 m=1
RRU472 t218 t217 vss rppd w=4u l=1.2u b=0 m=1
RRU473 t219 t218 vss rppd w=4u l=1.2u b=0 m=1
RRU474 t220 t219 vss rppd w=4u l=1.2u b=0 m=1
RRU475 t221 t220 vss rppd w=4u l=1.2u b=0 m=1
RRU476 t222 t221 vss rppd w=4u l=1.2u b=0 m=1
RRU477 t223 t222 vss rppd w=4u l=1.2u b=0 m=1
RRU478 t224 t223 vss rppd w=4u l=1.2u b=0 m=1
RRU479 t225 t224 vss rppd w=4u l=1.2u b=0 m=1
RRU480 t226 t225 vss rppd w=4u l=1.2u b=0 m=1
RRU481 t227 t226 vss rppd w=4u l=1.2u b=0 m=1
RRU482 t228 t227 vss rppd w=4u l=1.2u b=0 m=1
RRU483 t229 t228 vss rppd w=4u l=1.2u b=0 m=1
RRU484 t230 t229 vss rppd w=4u l=1.2u b=0 m=1
RRU485 t231 t230 vss rppd w=4u l=1.2u b=0 m=1
RRU486 t232 t231 vss rppd w=4u l=1.2u b=0 m=1
RRU487 t233 t232 vss rppd w=4u l=1.2u b=0 m=1
RRU488 t234 t233 vss rppd w=4u l=1.2u b=0 m=1
RRU489 t235 t234 vss rppd w=4u l=1.2u b=0 m=1
RRU490 t236 t235 vss rppd w=4u l=1.2u b=0 m=1
RRU491 t237 t236 vss rppd w=4u l=1.2u b=0 m=1
RRU492 t238 t237 vss rppd w=4u l=1.2u b=0 m=1
RRU493 t239 t238 vss rppd w=4u l=1.2u b=0 m=1
RRU494 t240 t239 vss rppd w=4u l=1.2u b=0 m=1
RRU495 t241 t240 vss rppd w=4u l=1.2u b=0 m=1
RRU496 t242 t241 vss rppd w=4u l=1.2u b=0 m=1
RRU497 t243 t242 vss rppd w=4u l=1.2u b=0 m=1
RRU498 t244 t243 vss rppd w=4u l=1.2u b=0 m=1
RRU499 t245 t244 vss rppd w=4u l=1.2u b=0 m=1
RRU500 t246 t245 vss rppd w=4u l=1.2u b=0 m=1
RRU501 t247 t246 vss rppd w=4u l=1.2u b=0 m=1
RRU502 t248 t247 vss rppd w=4u l=1.2u b=0 m=1
RRU503 t249 t248 vss rppd w=4u l=1.2u b=0 m=1
RRU504 t250 t249 vss rppd w=4u l=1.2u b=0 m=1
RRU505 t251 t250 vss rppd w=4u l=1.2u b=0 m=1
RRU506 t252 t251 vss rppd w=4u l=1.2u b=0 m=1
RRU507 t253 t252 vss rppd w=4u l=1.2u b=0 m=1
RRU508 t254 t253 vss rppd w=4u l=1.2u b=0 m=1
RRU509 t255 t254 vss rppd w=4u l=1.2u b=0 m=1
RRU510 s510 t255 vss rppd w=4u l=1.2u b=0 m=1
RRU511 s511 s510 vss rppd w=4u l=1.2u b=0 m=1
RRU512 s512 s511 vss rppd w=4u l=1.2u b=0 m=1
RRU513 s513 s512 vss rppd w=4u l=1.2u b=0 m=1
RRU514 s514 s513 vss rppd w=4u l=1.2u b=0 m=1
RRU515 s515 s514 vss rppd w=4u l=1.2u b=0 m=1
RRU516 s516 s515 vss rppd w=4u l=1.2u b=0 m=1
RRU517 s517 s516 vss rppd w=4u l=1.2u b=0 m=1
RRU518 s518 s517 vss rppd w=4u l=1.2u b=0 m=1
RRU519 s519 s518 vss rppd w=4u l=1.2u b=0 m=1
RRU520 s520 s519 vss rppd w=4u l=1.2u b=0 m=1
RRU521 s521 s520 vss rppd w=4u l=1.2u b=0 m=1
RRU522 s522 s521 vss rppd w=4u l=1.2u b=0 m=1
RRU523 s523 s522 vss rppd w=4u l=1.2u b=0 m=1
RRU524 s524 s523 vss rppd w=4u l=1.2u b=0 m=1
RRU525 s525 s524 vss rppd w=4u l=1.2u b=0 m=1
RRU526 s526 s525 vss rppd w=4u l=1.2u b=0 m=1
RRU527 s527 s526 vss rppd w=4u l=1.2u b=0 m=1
RRU528 s528 s527 vss rppd w=4u l=1.2u b=0 m=1
RRU529 vref s528 vss rppd w=4u l=1.2u b=0 m=1
XLU0 d0 dh0 dhn0 vdd vdda vss g1_tlvlup
XLU1 d1 dh1 dhn1 vdd vdda vss g1_tlvlup
XLU2 d2 dh2 dhn2 vdd vdda vss g1_tlvlup
XLU3 d3 dh3 dhn3 vdd vdda vss g1_tlvlup
XLU4 d4 dh4 dhn4 vdd vdda vss g1_tlvlup
XLU5 d5 dh5 dhn5 vdd vdda vss g1_tlvlup
XLU6 d6 dh6 dhn6 vdd vdda vss g1_tlvlup
XLU7 d7 dh7 dhn7 vdd vdda vss g1_tlvlup
MMS0_0a t0 dhn0 m0_0 vss sg13_hv_nmos w=2u l=0.45u m=1
MMS0_0b t1 dh0 m0_0 vss sg13_hv_nmos w=2u l=0.45u m=1
MMS0_1a t2 dhn0 m0_1 vss sg13_hv_nmos w=2u l=0.45u m=1
MMS0_1b t3 dh0 m0_1 vss sg13_hv_nmos w=2u l=0.45u m=1
MMS0_2a t4 dhn0 m0_2 vss sg13_hv_nmos w=2u l=0.45u m=1
MMS0_2b t5 dh0 m0_2 vss sg13_hv_nmos w=2u l=0.45u m=1
MMS0_3a t6 dhn0 m0_3 vss sg13_hv_nmos w=2u l=0.45u m=1
MMS0_3b t7 dh0 m0_3 vss sg13_hv_nmos w=2u l=0.45u m=1
MMS0_4a t8 dhn0 m0_4 vss sg13_hv_nmos w=2u l=0.45u m=1
MMS0_4b t9 dh0 m0_4 vss sg13_hv_nmos w=2u l=0.45u m=1
MMS0_5a t10 dhn0 m0_5 vss sg13_hv_nmos w=2u l=0.45u m=1
MMS0_5b t11 dh0 m0_5 vss sg13_hv_nmos w=2u l=0.45u m=1
MMS0_6a t12 dhn0 m0_6 vss sg13_hv_nmos w=2u l=0.45u m=1
MMS0_6b t13 dh0 m0_6 vss sg13_hv_nmos w=2u l=0.45u m=1
MMS0_7a t14 dhn0 m0_7 vss sg13_hv_nmos w=2u l=0.45u m=1
MMS0_7b t15 dh0 m0_7 vss sg13_hv_nmos w=2u l=0.45u m=1
MMS0_8a t16 dhn0 m0_8 vss sg13_hv_nmos w=2u l=0.45u m=1
MMS0_8b t17 dh0 m0_8 vss sg13_hv_nmos w=2u l=0.45u m=1
MMS0_9a t18 dhn0 m0_9 vss sg13_hv_nmos w=2u l=0.45u m=1
MMS0_9b t19 dh0 m0_9 vss sg13_hv_nmos w=2u l=0.45u m=1
MMS0_10a t20 dhn0 m0_10 vss sg13_hv_nmos w=2u l=0.45u m=1
MMS0_10b t21 dh0 m0_10 vss sg13_hv_nmos w=2u l=0.45u m=1
MMS0_11a t22 dhn0 m0_11 vss sg13_hv_nmos w=2u l=0.45u m=1
MMS0_11b t23 dh0 m0_11 vss sg13_hv_nmos w=2u l=0.45u m=1
MMS0_12a t24 dhn0 m0_12 vss sg13_hv_nmos w=2u l=0.45u m=1
MMS0_12b t25 dh0 m0_12 vss sg13_hv_nmos w=2u l=0.45u m=1
MMS0_13a t26 dhn0 m0_13 vss sg13_hv_nmos w=2u l=0.45u m=1
MMS0_13b t27 dh0 m0_13 vss sg13_hv_nmos w=2u l=0.45u m=1
MMS0_14a t28 dhn0 m0_14 vss sg13_hv_nmos w=2u l=0.45u m=1
MMS0_14b t29 dh0 m0_14 vss sg13_hv_nmos w=2u l=0.45u m=1
MMS0_15a t30 dhn0 m0_15 vss sg13_hv_nmos w=2u l=0.45u m=1
MMS0_15b t31 dh0 m0_15 vss sg13_hv_nmos w=2u l=0.45u m=1
MMS0_16a t32 dhn0 m0_16 vss sg13_hv_nmos w=2u l=0.45u m=1
MMS0_16b t33 dh0 m0_16 vss sg13_hv_nmos w=2u l=0.45u m=1
MMS0_17a t34 dhn0 m0_17 vss sg13_hv_nmos w=2u l=0.45u m=1
MMS0_17b t35 dh0 m0_17 vss sg13_hv_nmos w=2u l=0.45u m=1
MMS0_18a t36 dhn0 m0_18 vss sg13_hv_nmos w=2u l=0.45u m=1
MMS0_18b t37 dh0 m0_18 vss sg13_hv_nmos w=2u l=0.45u m=1
MMS0_19a t38 dhn0 m0_19 vss sg13_hv_nmos w=2u l=0.45u m=1
MMS0_19b t39 dh0 m0_19 vss sg13_hv_nmos w=2u l=0.45u m=1
MMS0_20a t40 dhn0 m0_20 vss sg13_hv_nmos w=2u l=0.45u m=1
MMS0_20b t41 dh0 m0_20 vss sg13_hv_nmos w=2u l=0.45u m=1
MMS0_21a t42 dhn0 m0_21 vss sg13_hv_nmos w=2u l=0.45u m=1
MMS0_21b t43 dh0 m0_21 vss sg13_hv_nmos w=2u l=0.45u m=1
MMS0_22a t44 dhn0 m0_22 vss sg13_hv_nmos w=2u l=0.45u m=1
MMS0_22b t45 dh0 m0_22 vss sg13_hv_nmos w=2u l=0.45u m=1
MMS0_23a t46 dhn0 m0_23 vss sg13_hv_nmos w=2u l=0.45u m=1
MMS0_23b t47 dh0 m0_23 vss sg13_hv_nmos w=2u l=0.45u m=1
MMS0_24a t48 dhn0 m0_24 vss sg13_hv_nmos w=2u l=0.45u m=1
MMS0_24b t49 dh0 m0_24 vss sg13_hv_nmos w=2u l=0.45u m=1
MMS0_25a t50 dhn0 m0_25 vss sg13_hv_nmos w=2u l=0.45u m=1
MMS0_25b t51 dh0 m0_25 vss sg13_hv_nmos w=2u l=0.45u m=1
MMS0_26a t52 dhn0 m0_26 vss sg13_hv_nmos w=2u l=0.45u m=1
MMS0_26b t53 dh0 m0_26 vss sg13_hv_nmos w=2u l=0.45u m=1
MMS0_27a t54 dhn0 m0_27 vss sg13_hv_nmos w=2u l=0.45u m=1
MMS0_27b t55 dh0 m0_27 vss sg13_hv_nmos w=2u l=0.45u m=1
MMS0_28a t56 dhn0 m0_28 vss sg13_hv_nmos w=2u l=0.45u m=1
MMS0_28b t57 dh0 m0_28 vss sg13_hv_nmos w=2u l=0.45u m=1
MMS0_29a t58 dhn0 m0_29 vss sg13_hv_nmos w=2u l=0.45u m=1
MMS0_29b t59 dh0 m0_29 vss sg13_hv_nmos w=2u l=0.45u m=1
MMS0_30a t60 dhn0 m0_30 vss sg13_hv_nmos w=2u l=0.45u m=1
MMS0_30b t61 dh0 m0_30 vss sg13_hv_nmos w=2u l=0.45u m=1
MMS0_31a t62 dhn0 m0_31 vss sg13_hv_nmos w=2u l=0.45u m=1
MMS0_31b t63 dh0 m0_31 vss sg13_hv_nmos w=2u l=0.45u m=1
MMS0_32a t64 dhn0 m0_32 vss sg13_hv_nmos w=2u l=0.45u m=1
MMS0_32b t65 dh0 m0_32 vss sg13_hv_nmos w=2u l=0.45u m=1
MMS0_33a t66 dhn0 m0_33 vss sg13_hv_nmos w=2u l=0.45u m=1
MMS0_33b t67 dh0 m0_33 vss sg13_hv_nmos w=2u l=0.45u m=1
MMS0_34a t68 dhn0 m0_34 vss sg13_hv_nmos w=2u l=0.45u m=1
MMS0_34b t69 dh0 m0_34 vss sg13_hv_nmos w=2u l=0.45u m=1
MMS0_35a t70 dhn0 m0_35 vss sg13_hv_nmos w=2u l=0.45u m=1
MMS0_35b t71 dh0 m0_35 vss sg13_hv_nmos w=2u l=0.45u m=1
MMS0_36a t72 dhn0 m0_36 vss sg13_hv_nmos w=2u l=0.45u m=1
MMS0_36b t73 dh0 m0_36 vss sg13_hv_nmos w=2u l=0.45u m=1
MMS0_37a t74 dhn0 m0_37 vss sg13_hv_nmos w=2u l=0.45u m=1
MMS0_37b t75 dh0 m0_37 vss sg13_hv_nmos w=2u l=0.45u m=1
MMS0_38a t76 dhn0 m0_38 vss sg13_hv_nmos w=2u l=0.45u m=1
MMS0_38b t77 dh0 m0_38 vss sg13_hv_nmos w=2u l=0.45u m=1
MMS0_39a t78 dhn0 m0_39 vss sg13_hv_nmos w=2u l=0.45u m=1
MMS0_39b t79 dh0 m0_39 vss sg13_hv_nmos w=2u l=0.45u m=1
MMS0_40a t80 dhn0 m0_40 vss sg13_hv_nmos w=2u l=0.45u m=1
MMS0_40b t81 dh0 m0_40 vss sg13_hv_nmos w=2u l=0.45u m=1
MMS0_41a t82 dhn0 m0_41 vss sg13_hv_nmos w=2u l=0.45u m=1
MMS0_41b t83 dh0 m0_41 vss sg13_hv_nmos w=2u l=0.45u m=1
MMS0_42a t84 dhn0 m0_42 vss sg13_hv_nmos w=2u l=0.45u m=1
MMS0_42b t85 dh0 m0_42 vss sg13_hv_nmos w=2u l=0.45u m=1
MMS0_43a t86 dhn0 m0_43 vss sg13_hv_nmos w=2u l=0.45u m=1
MMS0_43b t87 dh0 m0_43 vss sg13_hv_nmos w=2u l=0.45u m=1
MMS0_44a t88 dhn0 m0_44 vss sg13_hv_nmos w=2u l=0.45u m=1
MMS0_44b t89 dh0 m0_44 vss sg13_hv_nmos w=2u l=0.45u m=1
MMS0_45a t90 dhn0 m0_45 vss sg13_hv_nmos w=2u l=0.45u m=1
MMS0_45b t91 dh0 m0_45 vss sg13_hv_nmos w=2u l=0.45u m=1
MMS0_46a t92 dhn0 m0_46 vss sg13_hv_nmos w=2u l=0.45u m=1
MMS0_46b t93 dh0 m0_46 vss sg13_hv_nmos w=2u l=0.45u m=1
MMS0_47a t94 dhn0 m0_47 vss sg13_hv_nmos w=2u l=0.45u m=1
MMS0_47b t95 dh0 m0_47 vss sg13_hv_nmos w=2u l=0.45u m=1
MMS0_48a t96 dhn0 m0_48 vss sg13_hv_nmos w=2u l=0.45u m=1
MMS0_48b t97 dh0 m0_48 vss sg13_hv_nmos w=2u l=0.45u m=1
MMS0_49a t98 dhn0 m0_49 vss sg13_hv_nmos w=2u l=0.45u m=1
MMS0_49b t99 dh0 m0_49 vss sg13_hv_nmos w=2u l=0.45u m=1
MMS0_50a t100 dhn0 m0_50 vss sg13_hv_nmos w=2u l=0.45u m=1
MMS0_50b t101 dh0 m0_50 vss sg13_hv_nmos w=2u l=0.45u m=1
MMS0_51a t102 dhn0 m0_51 vss sg13_hv_nmos w=2u l=0.45u m=1
MMS0_51b t103 dh0 m0_51 vss sg13_hv_nmos w=2u l=0.45u m=1
MMS0_52a t104 dhn0 m0_52 vss sg13_hv_nmos w=2u l=0.45u m=1
MMS0_52b t105 dh0 m0_52 vss sg13_hv_nmos w=2u l=0.45u m=1
MMS0_53a t106 dhn0 m0_53 vss sg13_hv_nmos w=2u l=0.45u m=1
MMS0_53b t107 dh0 m0_53 vss sg13_hv_nmos w=2u l=0.45u m=1
MMS0_54a t108 dhn0 m0_54 vss sg13_hv_nmos w=2u l=0.45u m=1
MMS0_54b t109 dh0 m0_54 vss sg13_hv_nmos w=2u l=0.45u m=1
MMS0_55a t110 dhn0 m0_55 vss sg13_hv_nmos w=2u l=0.45u m=1
MMS0_55b t111 dh0 m0_55 vss sg13_hv_nmos w=2u l=0.45u m=1
MMS0_56a t112 dhn0 m0_56 vss sg13_hv_nmos w=2u l=0.45u m=1
MMS0_56b t113 dh0 m0_56 vss sg13_hv_nmos w=2u l=0.45u m=1
MMS0_57a t114 dhn0 m0_57 vss sg13_hv_nmos w=2u l=0.45u m=1
MMS0_57b t115 dh0 m0_57 vss sg13_hv_nmos w=2u l=0.45u m=1
MMS0_58a t116 dhn0 m0_58 vss sg13_hv_nmos w=2u l=0.45u m=1
MMS0_58b t117 dh0 m0_58 vss sg13_hv_nmos w=2u l=0.45u m=1
MMS0_59a t118 dhn0 m0_59 vss sg13_hv_nmos w=2u l=0.45u m=1
MMS0_59b t119 dh0 m0_59 vss sg13_hv_nmos w=2u l=0.45u m=1
MMS0_60a t120 dhn0 m0_60 vss sg13_hv_nmos w=2u l=0.45u m=1
MMS0_60b t121 dh0 m0_60 vss sg13_hv_nmos w=2u l=0.45u m=1
MMS0_61a t122 dhn0 m0_61 vss sg13_hv_nmos w=2u l=0.45u m=1
MMS0_61b t123 dh0 m0_61 vss sg13_hv_nmos w=2u l=0.45u m=1
MMS0_62a t124 dhn0 m0_62 vss sg13_hv_nmos w=2u l=0.45u m=1
MMS0_62b t125 dh0 m0_62 vss sg13_hv_nmos w=2u l=0.45u m=1
MMS0_63a t126 dhn0 m0_63 vss sg13_hv_nmos w=2u l=0.45u m=1
MMS0_63b t127 dh0 m0_63 vss sg13_hv_nmos w=2u l=0.45u m=1
MMS0_64a t128 dhn0 m0_64 vss sg13_hv_nmos w=2u l=0.45u m=1
MMS0_64b t129 dh0 m0_64 vss sg13_hv_nmos w=2u l=0.45u m=1
MMS0_65a t130 dhn0 m0_65 vss sg13_hv_nmos w=2u l=0.45u m=1
MMS0_65b t131 dh0 m0_65 vss sg13_hv_nmos w=2u l=0.45u m=1
MMS0_66a t132 dhn0 m0_66 vss sg13_hv_nmos w=2u l=0.45u m=1
MMS0_66b t133 dh0 m0_66 vss sg13_hv_nmos w=2u l=0.45u m=1
MMS0_67a t134 dhn0 m0_67 vss sg13_hv_nmos w=2u l=0.45u m=1
MMS0_67b t135 dh0 m0_67 vss sg13_hv_nmos w=2u l=0.45u m=1
MMS0_68a t136 dhn0 m0_68 vss sg13_hv_nmos w=2u l=0.45u m=1
MMS0_68b t137 dh0 m0_68 vss sg13_hv_nmos w=2u l=0.45u m=1
MMS0_69a t138 dhn0 m0_69 vss sg13_hv_nmos w=2u l=0.45u m=1
MMS0_69b t139 dh0 m0_69 vss sg13_hv_nmos w=2u l=0.45u m=1
MMS0_70a t140 dhn0 m0_70 vss sg13_hv_nmos w=2u l=0.45u m=1
MMS0_70b t141 dh0 m0_70 vss sg13_hv_nmos w=2u l=0.45u m=1
MMS0_71a t142 dhn0 m0_71 vss sg13_hv_nmos w=2u l=0.45u m=1
MMS0_71b t143 dh0 m0_71 vss sg13_hv_nmos w=2u l=0.45u m=1
MMS0_72a t144 dhn0 m0_72 vss sg13_hv_nmos w=2u l=0.45u m=1
MMS0_72b t145 dh0 m0_72 vss sg13_hv_nmos w=2u l=0.45u m=1
MMS0_73a t146 dhn0 m0_73 vss sg13_hv_nmos w=2u l=0.45u m=1
MMS0_73b t147 dh0 m0_73 vss sg13_hv_nmos w=2u l=0.45u m=1
MMS0_74a t148 dhn0 m0_74 vss sg13_hv_nmos w=2u l=0.45u m=1
MMS0_74b t149 dh0 m0_74 vss sg13_hv_nmos w=2u l=0.45u m=1
MMS0_75a t150 dhn0 m0_75 vss sg13_hv_nmos w=2u l=0.45u m=1
MMS0_75b t151 dh0 m0_75 vss sg13_hv_nmos w=2u l=0.45u m=1
MMS0_76a t152 dhn0 m0_76 vss sg13_hv_nmos w=2u l=0.45u m=1
MMS0_76b t153 dh0 m0_76 vss sg13_hv_nmos w=2u l=0.45u m=1
MMS0_77a t154 dhn0 m0_77 vss sg13_hv_nmos w=2u l=0.45u m=1
MMS0_77b t155 dh0 m0_77 vss sg13_hv_nmos w=2u l=0.45u m=1
MMS0_78a t156 dhn0 m0_78 vss sg13_hv_nmos w=2u l=0.45u m=1
MMS0_78b t157 dh0 m0_78 vss sg13_hv_nmos w=2u l=0.45u m=1
MMS0_79a t158 dhn0 m0_79 vss sg13_hv_nmos w=2u l=0.45u m=1
MMS0_79b t159 dh0 m0_79 vss sg13_hv_nmos w=2u l=0.45u m=1
MMS0_80a t160 dhn0 m0_80 vss sg13_hv_nmos w=2u l=0.45u m=1
MMS0_80b t161 dh0 m0_80 vss sg13_hv_nmos w=2u l=0.45u m=1
MMS0_81a t162 dhn0 m0_81 vss sg13_hv_nmos w=2u l=0.45u m=1
MMS0_81b t163 dh0 m0_81 vss sg13_hv_nmos w=2u l=0.45u m=1
MMS0_82a t164 dhn0 m0_82 vss sg13_hv_nmos w=2u l=0.45u m=1
MMS0_82b t165 dh0 m0_82 vss sg13_hv_nmos w=2u l=0.45u m=1
MMS0_83a t166 dhn0 m0_83 vss sg13_hv_nmos w=2u l=0.45u m=1
MMS0_83b t167 dh0 m0_83 vss sg13_hv_nmos w=2u l=0.45u m=1
MMS0_84a t168 dhn0 m0_84 vss sg13_hv_nmos w=2u l=0.45u m=1
MMS0_84b t169 dh0 m0_84 vss sg13_hv_nmos w=2u l=0.45u m=1
MMS0_85a t170 dhn0 m0_85 vss sg13_hv_nmos w=2u l=0.45u m=1
MMS0_85b t171 dh0 m0_85 vss sg13_hv_nmos w=2u l=0.45u m=1
MMS0_86a t172 dhn0 m0_86 vss sg13_hv_nmos w=2u l=0.45u m=1
MMS0_86b t173 dh0 m0_86 vss sg13_hv_nmos w=2u l=0.45u m=1
MMS0_87a t174 dhn0 m0_87 vss sg13_hv_nmos w=2u l=0.45u m=1
MMS0_87b t175 dh0 m0_87 vss sg13_hv_nmos w=2u l=0.45u m=1
MMS0_88a t176 dhn0 m0_88 vss sg13_hv_nmos w=2u l=0.45u m=1
MMS0_88b t177 dh0 m0_88 vss sg13_hv_nmos w=2u l=0.45u m=1
MMS0_89a t178 dhn0 m0_89 vss sg13_hv_nmos w=2u l=0.45u m=1
MMS0_89b t179 dh0 m0_89 vss sg13_hv_nmos w=2u l=0.45u m=1
MMS0_90a t180 dhn0 m0_90 vss sg13_hv_nmos w=2u l=0.45u m=1
MMS0_90b t181 dh0 m0_90 vss sg13_hv_nmos w=2u l=0.45u m=1
MMS0_91a t182 dhn0 m0_91 vss sg13_hv_nmos w=2u l=0.45u m=1
MMS0_91b t183 dh0 m0_91 vss sg13_hv_nmos w=2u l=0.45u m=1
MMS0_92a t184 dhn0 m0_92 vss sg13_hv_nmos w=2u l=0.45u m=1
MMS0_92b t185 dh0 m0_92 vss sg13_hv_nmos w=2u l=0.45u m=1
MMS0_93a t186 dhn0 m0_93 vss sg13_hv_nmos w=2u l=0.45u m=1
MMS0_93b t187 dh0 m0_93 vss sg13_hv_nmos w=2u l=0.45u m=1
MMS0_94a t188 dhn0 m0_94 vss sg13_hv_nmos w=2u l=0.45u m=1
MMS0_94b t189 dh0 m0_94 vss sg13_hv_nmos w=2u l=0.45u m=1
MMS0_95a t190 dhn0 m0_95 vss sg13_hv_nmos w=2u l=0.45u m=1
MMS0_95b t191 dh0 m0_95 vss sg13_hv_nmos w=2u l=0.45u m=1
MMS0_96a t192 dhn0 m0_96 vss sg13_hv_nmos w=2u l=0.45u m=1
MMS0_96b t193 dh0 m0_96 vss sg13_hv_nmos w=2u l=0.45u m=1
MMS0_97a t194 dhn0 m0_97 vss sg13_hv_nmos w=2u l=0.45u m=1
MMS0_97b t195 dh0 m0_97 vss sg13_hv_nmos w=2u l=0.45u m=1
MMS0_98a t196 dhn0 m0_98 vss sg13_hv_nmos w=2u l=0.45u m=1
MMS0_98b t197 dh0 m0_98 vss sg13_hv_nmos w=2u l=0.45u m=1
MMS0_99a t198 dhn0 m0_99 vss sg13_hv_nmos w=2u l=0.45u m=1
MMS0_99b t199 dh0 m0_99 vss sg13_hv_nmos w=2u l=0.45u m=1
MMS0_100a t200 dhn0 m0_100 vss sg13_hv_nmos w=2u l=0.45u m=1
MMS0_100b t201 dh0 m0_100 vss sg13_hv_nmos w=2u l=0.45u m=1
MMS0_101a t202 dhn0 m0_101 vss sg13_hv_nmos w=2u l=0.45u m=1
MMS0_101b t203 dh0 m0_101 vss sg13_hv_nmos w=2u l=0.45u m=1
MMS0_102a t204 dhn0 m0_102 vss sg13_hv_nmos w=2u l=0.45u m=1
MMS0_102b t205 dh0 m0_102 vss sg13_hv_nmos w=2u l=0.45u m=1
MMS0_103a t206 dhn0 m0_103 vss sg13_hv_nmos w=2u l=0.45u m=1
MMS0_103b t207 dh0 m0_103 vss sg13_hv_nmos w=2u l=0.45u m=1
MMS0_104a t208 dhn0 m0_104 vss sg13_hv_nmos w=2u l=0.45u m=1
MMS0_104b t209 dh0 m0_104 vss sg13_hv_nmos w=2u l=0.45u m=1
MMS0_105a t210 dhn0 m0_105 vss sg13_hv_nmos w=2u l=0.45u m=1
MMS0_105b t211 dh0 m0_105 vss sg13_hv_nmos w=2u l=0.45u m=1
MMS0_106a t212 dhn0 m0_106 vss sg13_hv_nmos w=2u l=0.45u m=1
MMS0_106b t213 dh0 m0_106 vss sg13_hv_nmos w=2u l=0.45u m=1
MMS0_107a t214 dhn0 m0_107 vss sg13_hv_nmos w=2u l=0.45u m=1
MMS0_107b t215 dh0 m0_107 vss sg13_hv_nmos w=2u l=0.45u m=1
MMS0_108a t216 dhn0 m0_108 vss sg13_hv_nmos w=2u l=0.45u m=1
MMS0_108b t217 dh0 m0_108 vss sg13_hv_nmos w=2u l=0.45u m=1
MMS0_109a t218 dhn0 m0_109 vss sg13_hv_nmos w=2u l=0.45u m=1
MMS0_109b t219 dh0 m0_109 vss sg13_hv_nmos w=2u l=0.45u m=1
MMS0_110a t220 dhn0 m0_110 vss sg13_hv_nmos w=2u l=0.45u m=1
MMS0_110b t221 dh0 m0_110 vss sg13_hv_nmos w=2u l=0.45u m=1
MMS0_111a t222 dhn0 m0_111 vss sg13_hv_nmos w=2u l=0.45u m=1
MMS0_111b t223 dh0 m0_111 vss sg13_hv_nmos w=2u l=0.45u m=1
MMS0_112a t224 dhn0 m0_112 vss sg13_hv_nmos w=2u l=0.45u m=1
MMS0_112b t225 dh0 m0_112 vss sg13_hv_nmos w=2u l=0.45u m=1
MMS0_113a t226 dhn0 m0_113 vss sg13_hv_nmos w=2u l=0.45u m=1
MMS0_113b t227 dh0 m0_113 vss sg13_hv_nmos w=2u l=0.45u m=1
MMS0_114a t228 dhn0 m0_114 vss sg13_hv_nmos w=2u l=0.45u m=1
MMS0_114b t229 dh0 m0_114 vss sg13_hv_nmos w=2u l=0.45u m=1
MMS0_115a t230 dhn0 m0_115 vss sg13_hv_nmos w=2u l=0.45u m=1
MMS0_115b t231 dh0 m0_115 vss sg13_hv_nmos w=2u l=0.45u m=1
MMS0_116a t232 dhn0 m0_116 vss sg13_hv_nmos w=2u l=0.45u m=1
MMS0_116b t233 dh0 m0_116 vss sg13_hv_nmos w=2u l=0.45u m=1
MMS0_117a t234 dhn0 m0_117 vss sg13_hv_nmos w=2u l=0.45u m=1
MMS0_117b t235 dh0 m0_117 vss sg13_hv_nmos w=2u l=0.45u m=1
MMS0_118a t236 dhn0 m0_118 vss sg13_hv_nmos w=2u l=0.45u m=1
MMS0_118b t237 dh0 m0_118 vss sg13_hv_nmos w=2u l=0.45u m=1
MMS0_119a t238 dhn0 m0_119 vss sg13_hv_nmos w=2u l=0.45u m=1
MMS0_119b t239 dh0 m0_119 vss sg13_hv_nmos w=2u l=0.45u m=1
MMS0_120a t240 dhn0 m0_120 vss sg13_hv_nmos w=2u l=0.45u m=1
MMS0_120b t241 dh0 m0_120 vss sg13_hv_nmos w=2u l=0.45u m=1
MMS0_121a t242 dhn0 m0_121 vss sg13_hv_nmos w=2u l=0.45u m=1
MMS0_121b t243 dh0 m0_121 vss sg13_hv_nmos w=2u l=0.45u m=1
MMS0_122a t244 dhn0 m0_122 vss sg13_hv_nmos w=2u l=0.45u m=1
MMS0_122b t245 dh0 m0_122 vss sg13_hv_nmos w=2u l=0.45u m=1
MMS0_123a t246 dhn0 m0_123 vss sg13_hv_nmos w=2u l=0.45u m=1
MMS0_123b t247 dh0 m0_123 vss sg13_hv_nmos w=2u l=0.45u m=1
MMS0_124a t248 dhn0 m0_124 vss sg13_hv_nmos w=2u l=0.45u m=1
MMS0_124b t249 dh0 m0_124 vss sg13_hv_nmos w=2u l=0.45u m=1
MMS0_125a t250 dhn0 m0_125 vss sg13_hv_nmos w=2u l=0.45u m=1
MMS0_125b t251 dh0 m0_125 vss sg13_hv_nmos w=2u l=0.45u m=1
MMS0_126a t252 dhn0 m0_126 vss sg13_hv_nmos w=2u l=0.45u m=1
MMS0_126b t253 dh0 m0_126 vss sg13_hv_nmos w=2u l=0.45u m=1
MMS0_127a t254 dhn0 m0_127 vss sg13_hv_nmos w=2u l=0.45u m=1
MMS0_127b t255 dh0 m0_127 vss sg13_hv_nmos w=2u l=0.45u m=1
MMS1_0a m0_0 dhn1 m1_0 vss sg13_hv_nmos w=2u l=0.45u m=1
MMS1_0b m0_1 dh1 m1_0 vss sg13_hv_nmos w=2u l=0.45u m=1
MMS1_1a m0_2 dhn1 m1_1 vss sg13_hv_nmos w=2u l=0.45u m=1
MMS1_1b m0_3 dh1 m1_1 vss sg13_hv_nmos w=2u l=0.45u m=1
MMS1_2a m0_4 dhn1 m1_2 vss sg13_hv_nmos w=2u l=0.45u m=1
MMS1_2b m0_5 dh1 m1_2 vss sg13_hv_nmos w=2u l=0.45u m=1
MMS1_3a m0_6 dhn1 m1_3 vss sg13_hv_nmos w=2u l=0.45u m=1
MMS1_3b m0_7 dh1 m1_3 vss sg13_hv_nmos w=2u l=0.45u m=1
MMS1_4a m0_8 dhn1 m1_4 vss sg13_hv_nmos w=2u l=0.45u m=1
MMS1_4b m0_9 dh1 m1_4 vss sg13_hv_nmos w=2u l=0.45u m=1
MMS1_5a m0_10 dhn1 m1_5 vss sg13_hv_nmos w=2u l=0.45u m=1
MMS1_5b m0_11 dh1 m1_5 vss sg13_hv_nmos w=2u l=0.45u m=1
MMS1_6a m0_12 dhn1 m1_6 vss sg13_hv_nmos w=2u l=0.45u m=1
MMS1_6b m0_13 dh1 m1_6 vss sg13_hv_nmos w=2u l=0.45u m=1
MMS1_7a m0_14 dhn1 m1_7 vss sg13_hv_nmos w=2u l=0.45u m=1
MMS1_7b m0_15 dh1 m1_7 vss sg13_hv_nmos w=2u l=0.45u m=1
MMS1_8a m0_16 dhn1 m1_8 vss sg13_hv_nmos w=2u l=0.45u m=1
MMS1_8b m0_17 dh1 m1_8 vss sg13_hv_nmos w=2u l=0.45u m=1
MMS1_9a m0_18 dhn1 m1_9 vss sg13_hv_nmos w=2u l=0.45u m=1
MMS1_9b m0_19 dh1 m1_9 vss sg13_hv_nmos w=2u l=0.45u m=1
MMS1_10a m0_20 dhn1 m1_10 vss sg13_hv_nmos w=2u l=0.45u m=1
MMS1_10b m0_21 dh1 m1_10 vss sg13_hv_nmos w=2u l=0.45u m=1
MMS1_11a m0_22 dhn1 m1_11 vss sg13_hv_nmos w=2u l=0.45u m=1
MMS1_11b m0_23 dh1 m1_11 vss sg13_hv_nmos w=2u l=0.45u m=1
MMS1_12a m0_24 dhn1 m1_12 vss sg13_hv_nmos w=2u l=0.45u m=1
MMS1_12b m0_25 dh1 m1_12 vss sg13_hv_nmos w=2u l=0.45u m=1
MMS1_13a m0_26 dhn1 m1_13 vss sg13_hv_nmos w=2u l=0.45u m=1
MMS1_13b m0_27 dh1 m1_13 vss sg13_hv_nmos w=2u l=0.45u m=1
MMS1_14a m0_28 dhn1 m1_14 vss sg13_hv_nmos w=2u l=0.45u m=1
MMS1_14b m0_29 dh1 m1_14 vss sg13_hv_nmos w=2u l=0.45u m=1
MMS1_15a m0_30 dhn1 m1_15 vss sg13_hv_nmos w=2u l=0.45u m=1
MMS1_15b m0_31 dh1 m1_15 vss sg13_hv_nmos w=2u l=0.45u m=1
MMS1_16a m0_32 dhn1 m1_16 vss sg13_hv_nmos w=2u l=0.45u m=1
MMS1_16b m0_33 dh1 m1_16 vss sg13_hv_nmos w=2u l=0.45u m=1
MMS1_17a m0_34 dhn1 m1_17 vss sg13_hv_nmos w=2u l=0.45u m=1
MMS1_17b m0_35 dh1 m1_17 vss sg13_hv_nmos w=2u l=0.45u m=1
MMS1_18a m0_36 dhn1 m1_18 vss sg13_hv_nmos w=2u l=0.45u m=1
MMS1_18b m0_37 dh1 m1_18 vss sg13_hv_nmos w=2u l=0.45u m=1
MMS1_19a m0_38 dhn1 m1_19 vss sg13_hv_nmos w=2u l=0.45u m=1
MMS1_19b m0_39 dh1 m1_19 vss sg13_hv_nmos w=2u l=0.45u m=1
MMS1_20a m0_40 dhn1 m1_20 vss sg13_hv_nmos w=2u l=0.45u m=1
MMS1_20b m0_41 dh1 m1_20 vss sg13_hv_nmos w=2u l=0.45u m=1
MMS1_21a m0_42 dhn1 m1_21 vss sg13_hv_nmos w=2u l=0.45u m=1
MMS1_21b m0_43 dh1 m1_21 vss sg13_hv_nmos w=2u l=0.45u m=1
MMS1_22a m0_44 dhn1 m1_22 vss sg13_hv_nmos w=2u l=0.45u m=1
MMS1_22b m0_45 dh1 m1_22 vss sg13_hv_nmos w=2u l=0.45u m=1
MMS1_23a m0_46 dhn1 m1_23 vss sg13_hv_nmos w=2u l=0.45u m=1
MMS1_23b m0_47 dh1 m1_23 vss sg13_hv_nmos w=2u l=0.45u m=1
MMS1_24a m0_48 dhn1 m1_24 vss sg13_hv_nmos w=2u l=0.45u m=1
MMS1_24b m0_49 dh1 m1_24 vss sg13_hv_nmos w=2u l=0.45u m=1
MMS1_25a m0_50 dhn1 m1_25 vss sg13_hv_nmos w=2u l=0.45u m=1
MMS1_25b m0_51 dh1 m1_25 vss sg13_hv_nmos w=2u l=0.45u m=1
MMS1_26a m0_52 dhn1 m1_26 vss sg13_hv_nmos w=2u l=0.45u m=1
MMS1_26b m0_53 dh1 m1_26 vss sg13_hv_nmos w=2u l=0.45u m=1
MMS1_27a m0_54 dhn1 m1_27 vss sg13_hv_nmos w=2u l=0.45u m=1
MMS1_27b m0_55 dh1 m1_27 vss sg13_hv_nmos w=2u l=0.45u m=1
MMS1_28a m0_56 dhn1 m1_28 vss sg13_hv_nmos w=2u l=0.45u m=1
MMS1_28b m0_57 dh1 m1_28 vss sg13_hv_nmos w=2u l=0.45u m=1
MMS1_29a m0_58 dhn1 m1_29 vss sg13_hv_nmos w=2u l=0.45u m=1
MMS1_29b m0_59 dh1 m1_29 vss sg13_hv_nmos w=2u l=0.45u m=1
MMS1_30a m0_60 dhn1 m1_30 vss sg13_hv_nmos w=2u l=0.45u m=1
MMS1_30b m0_61 dh1 m1_30 vss sg13_hv_nmos w=2u l=0.45u m=1
MMS1_31a m0_62 dhn1 m1_31 vss sg13_hv_nmos w=2u l=0.45u m=1
MMS1_31b m0_63 dh1 m1_31 vss sg13_hv_nmos w=2u l=0.45u m=1
MMS1_32a m0_64 dhn1 m1_32 vss sg13_hv_nmos w=2u l=0.45u m=1
MMS1_32b m0_65 dh1 m1_32 vss sg13_hv_nmos w=2u l=0.45u m=1
MMS1_33a m0_66 dhn1 m1_33 vss sg13_hv_nmos w=2u l=0.45u m=1
MMS1_33b m0_67 dh1 m1_33 vss sg13_hv_nmos w=2u l=0.45u m=1
MMS1_34a m0_68 dhn1 m1_34 vss sg13_hv_nmos w=2u l=0.45u m=1
MMS1_34b m0_69 dh1 m1_34 vss sg13_hv_nmos w=2u l=0.45u m=1
MMS1_35a m0_70 dhn1 m1_35 vss sg13_hv_nmos w=2u l=0.45u m=1
MMS1_35b m0_71 dh1 m1_35 vss sg13_hv_nmos w=2u l=0.45u m=1
MMS1_36a m0_72 dhn1 m1_36 vss sg13_hv_nmos w=2u l=0.45u m=1
MMS1_36b m0_73 dh1 m1_36 vss sg13_hv_nmos w=2u l=0.45u m=1
MMS1_37a m0_74 dhn1 m1_37 vss sg13_hv_nmos w=2u l=0.45u m=1
MMS1_37b m0_75 dh1 m1_37 vss sg13_hv_nmos w=2u l=0.45u m=1
MMS1_38a m0_76 dhn1 m1_38 vss sg13_hv_nmos w=2u l=0.45u m=1
MMS1_38b m0_77 dh1 m1_38 vss sg13_hv_nmos w=2u l=0.45u m=1
MMS1_39a m0_78 dhn1 m1_39 vss sg13_hv_nmos w=2u l=0.45u m=1
MMS1_39b m0_79 dh1 m1_39 vss sg13_hv_nmos w=2u l=0.45u m=1
MMS1_40a m0_80 dhn1 m1_40 vss sg13_hv_nmos w=2u l=0.45u m=1
MMS1_40b m0_81 dh1 m1_40 vss sg13_hv_nmos w=2u l=0.45u m=1
MMS1_41a m0_82 dhn1 m1_41 vss sg13_hv_nmos w=2u l=0.45u m=1
MMS1_41b m0_83 dh1 m1_41 vss sg13_hv_nmos w=2u l=0.45u m=1
MMS1_42a m0_84 dhn1 m1_42 vss sg13_hv_nmos w=2u l=0.45u m=1
MMS1_42b m0_85 dh1 m1_42 vss sg13_hv_nmos w=2u l=0.45u m=1
MMS1_43a m0_86 dhn1 m1_43 vss sg13_hv_nmos w=2u l=0.45u m=1
MMS1_43b m0_87 dh1 m1_43 vss sg13_hv_nmos w=2u l=0.45u m=1
MMS1_44a m0_88 dhn1 m1_44 vss sg13_hv_nmos w=2u l=0.45u m=1
MMS1_44b m0_89 dh1 m1_44 vss sg13_hv_nmos w=2u l=0.45u m=1
MMS1_45a m0_90 dhn1 m1_45 vss sg13_hv_nmos w=2u l=0.45u m=1
MMS1_45b m0_91 dh1 m1_45 vss sg13_hv_nmos w=2u l=0.45u m=1
MMS1_46a m0_92 dhn1 m1_46 vss sg13_hv_nmos w=2u l=0.45u m=1
MMS1_46b m0_93 dh1 m1_46 vss sg13_hv_nmos w=2u l=0.45u m=1
MMS1_47a m0_94 dhn1 m1_47 vss sg13_hv_nmos w=2u l=0.45u m=1
MMS1_47b m0_95 dh1 m1_47 vss sg13_hv_nmos w=2u l=0.45u m=1
MMS1_48a m0_96 dhn1 m1_48 vss sg13_hv_nmos w=2u l=0.45u m=1
MMS1_48b m0_97 dh1 m1_48 vss sg13_hv_nmos w=2u l=0.45u m=1
MMS1_49a m0_98 dhn1 m1_49 vss sg13_hv_nmos w=2u l=0.45u m=1
MMS1_49b m0_99 dh1 m1_49 vss sg13_hv_nmos w=2u l=0.45u m=1
MMS1_50a m0_100 dhn1 m1_50 vss sg13_hv_nmos w=2u l=0.45u m=1
MMS1_50b m0_101 dh1 m1_50 vss sg13_hv_nmos w=2u l=0.45u m=1
MMS1_51a m0_102 dhn1 m1_51 vss sg13_hv_nmos w=2u l=0.45u m=1
MMS1_51b m0_103 dh1 m1_51 vss sg13_hv_nmos w=2u l=0.45u m=1
MMS1_52a m0_104 dhn1 m1_52 vss sg13_hv_nmos w=2u l=0.45u m=1
MMS1_52b m0_105 dh1 m1_52 vss sg13_hv_nmos w=2u l=0.45u m=1
MMS1_53a m0_106 dhn1 m1_53 vss sg13_hv_nmos w=2u l=0.45u m=1
MMS1_53b m0_107 dh1 m1_53 vss sg13_hv_nmos w=2u l=0.45u m=1
MMS1_54a m0_108 dhn1 m1_54 vss sg13_hv_nmos w=2u l=0.45u m=1
MMS1_54b m0_109 dh1 m1_54 vss sg13_hv_nmos w=2u l=0.45u m=1
MMS1_55a m0_110 dhn1 m1_55 vss sg13_hv_nmos w=2u l=0.45u m=1
MMS1_55b m0_111 dh1 m1_55 vss sg13_hv_nmos w=2u l=0.45u m=1
MMS1_56a m0_112 dhn1 m1_56 vss sg13_hv_nmos w=2u l=0.45u m=1
MMS1_56b m0_113 dh1 m1_56 vss sg13_hv_nmos w=2u l=0.45u m=1
MMS1_57a m0_114 dhn1 m1_57 vss sg13_hv_nmos w=2u l=0.45u m=1
MMS1_57b m0_115 dh1 m1_57 vss sg13_hv_nmos w=2u l=0.45u m=1
MMS1_58a m0_116 dhn1 m1_58 vss sg13_hv_nmos w=2u l=0.45u m=1
MMS1_58b m0_117 dh1 m1_58 vss sg13_hv_nmos w=2u l=0.45u m=1
MMS1_59a m0_118 dhn1 m1_59 vss sg13_hv_nmos w=2u l=0.45u m=1
MMS1_59b m0_119 dh1 m1_59 vss sg13_hv_nmos w=2u l=0.45u m=1
MMS1_60a m0_120 dhn1 m1_60 vss sg13_hv_nmos w=2u l=0.45u m=1
MMS1_60b m0_121 dh1 m1_60 vss sg13_hv_nmos w=2u l=0.45u m=1
MMS1_61a m0_122 dhn1 m1_61 vss sg13_hv_nmos w=2u l=0.45u m=1
MMS1_61b m0_123 dh1 m1_61 vss sg13_hv_nmos w=2u l=0.45u m=1
MMS1_62a m0_124 dhn1 m1_62 vss sg13_hv_nmos w=2u l=0.45u m=1
MMS1_62b m0_125 dh1 m1_62 vss sg13_hv_nmos w=2u l=0.45u m=1
MMS1_63a m0_126 dhn1 m1_63 vss sg13_hv_nmos w=2u l=0.45u m=1
MMS1_63b m0_127 dh1 m1_63 vss sg13_hv_nmos w=2u l=0.45u m=1
MMS2_0a m1_0 dhn2 m2_0 vss sg13_hv_nmos w=2u l=0.45u m=1
MMS2_0b m1_1 dh2 m2_0 vss sg13_hv_nmos w=2u l=0.45u m=1
MMS2_1a m1_2 dhn2 m2_1 vss sg13_hv_nmos w=2u l=0.45u m=1
MMS2_1b m1_3 dh2 m2_1 vss sg13_hv_nmos w=2u l=0.45u m=1
MMS2_2a m1_4 dhn2 m2_2 vss sg13_hv_nmos w=2u l=0.45u m=1
MMS2_2b m1_5 dh2 m2_2 vss sg13_hv_nmos w=2u l=0.45u m=1
MMS2_3a m1_6 dhn2 m2_3 vss sg13_hv_nmos w=2u l=0.45u m=1
MMS2_3b m1_7 dh2 m2_3 vss sg13_hv_nmos w=2u l=0.45u m=1
MMS2_4a m1_8 dhn2 m2_4 vss sg13_hv_nmos w=2u l=0.45u m=1
MMS2_4b m1_9 dh2 m2_4 vss sg13_hv_nmos w=2u l=0.45u m=1
MMS2_5a m1_10 dhn2 m2_5 vss sg13_hv_nmos w=2u l=0.45u m=1
MMS2_5b m1_11 dh2 m2_5 vss sg13_hv_nmos w=2u l=0.45u m=1
MMS2_6a m1_12 dhn2 m2_6 vss sg13_hv_nmos w=2u l=0.45u m=1
MMS2_6b m1_13 dh2 m2_6 vss sg13_hv_nmos w=2u l=0.45u m=1
MMS2_7a m1_14 dhn2 m2_7 vss sg13_hv_nmos w=2u l=0.45u m=1
MMS2_7b m1_15 dh2 m2_7 vss sg13_hv_nmos w=2u l=0.45u m=1
MMS2_8a m1_16 dhn2 m2_8 vss sg13_hv_nmos w=2u l=0.45u m=1
MMS2_8b m1_17 dh2 m2_8 vss sg13_hv_nmos w=2u l=0.45u m=1
MMS2_9a m1_18 dhn2 m2_9 vss sg13_hv_nmos w=2u l=0.45u m=1
MMS2_9b m1_19 dh2 m2_9 vss sg13_hv_nmos w=2u l=0.45u m=1
MMS2_10a m1_20 dhn2 m2_10 vss sg13_hv_nmos w=2u l=0.45u m=1
MMS2_10b m1_21 dh2 m2_10 vss sg13_hv_nmos w=2u l=0.45u m=1
MMS2_11a m1_22 dhn2 m2_11 vss sg13_hv_nmos w=2u l=0.45u m=1
MMS2_11b m1_23 dh2 m2_11 vss sg13_hv_nmos w=2u l=0.45u m=1
MMS2_12a m1_24 dhn2 m2_12 vss sg13_hv_nmos w=2u l=0.45u m=1
MMS2_12b m1_25 dh2 m2_12 vss sg13_hv_nmos w=2u l=0.45u m=1
MMS2_13a m1_26 dhn2 m2_13 vss sg13_hv_nmos w=2u l=0.45u m=1
MMS2_13b m1_27 dh2 m2_13 vss sg13_hv_nmos w=2u l=0.45u m=1
MMS2_14a m1_28 dhn2 m2_14 vss sg13_hv_nmos w=2u l=0.45u m=1
MMS2_14b m1_29 dh2 m2_14 vss sg13_hv_nmos w=2u l=0.45u m=1
MMS2_15a m1_30 dhn2 m2_15 vss sg13_hv_nmos w=2u l=0.45u m=1
MMS2_15b m1_31 dh2 m2_15 vss sg13_hv_nmos w=2u l=0.45u m=1
MMS2_16a m1_32 dhn2 m2_16 vss sg13_hv_nmos w=2u l=0.45u m=1
MMS2_16b m1_33 dh2 m2_16 vss sg13_hv_nmos w=2u l=0.45u m=1
MMS2_17a m1_34 dhn2 m2_17 vss sg13_hv_nmos w=2u l=0.45u m=1
MMS2_17b m1_35 dh2 m2_17 vss sg13_hv_nmos w=2u l=0.45u m=1
MMS2_18a m1_36 dhn2 m2_18 vss sg13_hv_nmos w=2u l=0.45u m=1
MMS2_18b m1_37 dh2 m2_18 vss sg13_hv_nmos w=2u l=0.45u m=1
MMS2_19a m1_38 dhn2 m2_19 vss sg13_hv_nmos w=2u l=0.45u m=1
MMS2_19b m1_39 dh2 m2_19 vss sg13_hv_nmos w=2u l=0.45u m=1
MMS2_20a m1_40 dhn2 m2_20 vss sg13_hv_nmos w=2u l=0.45u m=1
MMS2_20b m1_41 dh2 m2_20 vss sg13_hv_nmos w=2u l=0.45u m=1
MMS2_21a m1_42 dhn2 m2_21 vss sg13_hv_nmos w=2u l=0.45u m=1
MMS2_21b m1_43 dh2 m2_21 vss sg13_hv_nmos w=2u l=0.45u m=1
MMS2_22a m1_44 dhn2 m2_22 vss sg13_hv_nmos w=2u l=0.45u m=1
MMS2_22b m1_45 dh2 m2_22 vss sg13_hv_nmos w=2u l=0.45u m=1
MMS2_23a m1_46 dhn2 m2_23 vss sg13_hv_nmos w=2u l=0.45u m=1
MMS2_23b m1_47 dh2 m2_23 vss sg13_hv_nmos w=2u l=0.45u m=1
MMS2_24a m1_48 dhn2 m2_24 vss sg13_hv_nmos w=2u l=0.45u m=1
MMS2_24b m1_49 dh2 m2_24 vss sg13_hv_nmos w=2u l=0.45u m=1
MMS2_25a m1_50 dhn2 m2_25 vss sg13_hv_nmos w=2u l=0.45u m=1
MMS2_25b m1_51 dh2 m2_25 vss sg13_hv_nmos w=2u l=0.45u m=1
MMS2_26a m1_52 dhn2 m2_26 vss sg13_hv_nmos w=2u l=0.45u m=1
MMS2_26b m1_53 dh2 m2_26 vss sg13_hv_nmos w=2u l=0.45u m=1
MMS2_27a m1_54 dhn2 m2_27 vss sg13_hv_nmos w=2u l=0.45u m=1
MMS2_27b m1_55 dh2 m2_27 vss sg13_hv_nmos w=2u l=0.45u m=1
MMS2_28a m1_56 dhn2 m2_28 vss sg13_hv_nmos w=2u l=0.45u m=1
MMS2_28b m1_57 dh2 m2_28 vss sg13_hv_nmos w=2u l=0.45u m=1
MMS2_29a m1_58 dhn2 m2_29 vss sg13_hv_nmos w=2u l=0.45u m=1
MMS2_29b m1_59 dh2 m2_29 vss sg13_hv_nmos w=2u l=0.45u m=1
MMS2_30a m1_60 dhn2 m2_30 vss sg13_hv_nmos w=2u l=0.45u m=1
MMS2_30b m1_61 dh2 m2_30 vss sg13_hv_nmos w=2u l=0.45u m=1
MMS2_31a m1_62 dhn2 m2_31 vss sg13_hv_nmos w=2u l=0.45u m=1
MMS2_31b m1_63 dh2 m2_31 vss sg13_hv_nmos w=2u l=0.45u m=1
MMS3_0a m2_0 dhn3 m3_0 vss sg13_hv_nmos w=2u l=0.45u m=1
MMS3_0b m2_1 dh3 m3_0 vss sg13_hv_nmos w=2u l=0.45u m=1
MMS3_1a m2_2 dhn3 m3_1 vss sg13_hv_nmos w=2u l=0.45u m=1
MMS3_1b m2_3 dh3 m3_1 vss sg13_hv_nmos w=2u l=0.45u m=1
MMS3_2a m2_4 dhn3 m3_2 vss sg13_hv_nmos w=2u l=0.45u m=1
MMS3_2b m2_5 dh3 m3_2 vss sg13_hv_nmos w=2u l=0.45u m=1
MMS3_3a m2_6 dhn3 m3_3 vss sg13_hv_nmos w=2u l=0.45u m=1
MMS3_3b m2_7 dh3 m3_3 vss sg13_hv_nmos w=2u l=0.45u m=1
MMS3_4a m2_8 dhn3 m3_4 vss sg13_hv_nmos w=2u l=0.45u m=1
MMS3_4b m2_9 dh3 m3_4 vss sg13_hv_nmos w=2u l=0.45u m=1
MMS3_5a m2_10 dhn3 m3_5 vss sg13_hv_nmos w=2u l=0.45u m=1
MMS3_5b m2_11 dh3 m3_5 vss sg13_hv_nmos w=2u l=0.45u m=1
MMS3_6a m2_12 dhn3 m3_6 vss sg13_hv_nmos w=2u l=0.45u m=1
MMS3_6b m2_13 dh3 m3_6 vss sg13_hv_nmos w=2u l=0.45u m=1
MMS3_7a m2_14 dhn3 m3_7 vss sg13_hv_nmos w=2u l=0.45u m=1
MMS3_7b m2_15 dh3 m3_7 vss sg13_hv_nmos w=2u l=0.45u m=1
MMS3_8a m2_16 dhn3 m3_8 vss sg13_hv_nmos w=2u l=0.45u m=1
MMS3_8b m2_17 dh3 m3_8 vss sg13_hv_nmos w=2u l=0.45u m=1
MMS3_9a m2_18 dhn3 m3_9 vss sg13_hv_nmos w=2u l=0.45u m=1
MMS3_9b m2_19 dh3 m3_9 vss sg13_hv_nmos w=2u l=0.45u m=1
MMS3_10a m2_20 dhn3 m3_10 vss sg13_hv_nmos w=2u l=0.45u m=1
MMS3_10b m2_21 dh3 m3_10 vss sg13_hv_nmos w=2u l=0.45u m=1
MMS3_11a m2_22 dhn3 m3_11 vss sg13_hv_nmos w=2u l=0.45u m=1
MMS3_11b m2_23 dh3 m3_11 vss sg13_hv_nmos w=2u l=0.45u m=1
MMS3_12a m2_24 dhn3 m3_12 vss sg13_hv_nmos w=2u l=0.45u m=1
MMS3_12b m2_25 dh3 m3_12 vss sg13_hv_nmos w=2u l=0.45u m=1
MMS3_13a m2_26 dhn3 m3_13 vss sg13_hv_nmos w=2u l=0.45u m=1
MMS3_13b m2_27 dh3 m3_13 vss sg13_hv_nmos w=2u l=0.45u m=1
MMS3_14a m2_28 dhn3 m3_14 vss sg13_hv_nmos w=2u l=0.45u m=1
MMS3_14b m2_29 dh3 m3_14 vss sg13_hv_nmos w=2u l=0.45u m=1
MMS3_15a m2_30 dhn3 m3_15 vss sg13_hv_nmos w=2u l=0.45u m=1
MMS3_15b m2_31 dh3 m3_15 vss sg13_hv_nmos w=2u l=0.45u m=1
MMS4_0a m3_0 dhn4 m4_0 vss sg13_hv_nmos w=2u l=0.45u m=1
MMS4_0b m3_1 dh4 m4_0 vss sg13_hv_nmos w=2u l=0.45u m=1
MMS4_1a m3_2 dhn4 m4_1 vss sg13_hv_nmos w=2u l=0.45u m=1
MMS4_1b m3_3 dh4 m4_1 vss sg13_hv_nmos w=2u l=0.45u m=1
MMS4_2a m3_4 dhn4 m4_2 vss sg13_hv_nmos w=2u l=0.45u m=1
MMS4_2b m3_5 dh4 m4_2 vss sg13_hv_nmos w=2u l=0.45u m=1
MMS4_3a m3_6 dhn4 m4_3 vss sg13_hv_nmos w=2u l=0.45u m=1
MMS4_3b m3_7 dh4 m4_3 vss sg13_hv_nmos w=2u l=0.45u m=1
MMS4_4a m3_8 dhn4 m4_4 vss sg13_hv_nmos w=2u l=0.45u m=1
MMS4_4b m3_9 dh4 m4_4 vss sg13_hv_nmos w=2u l=0.45u m=1
MMS4_5a m3_10 dhn4 m4_5 vss sg13_hv_nmos w=2u l=0.45u m=1
MMS4_5b m3_11 dh4 m4_5 vss sg13_hv_nmos w=2u l=0.45u m=1
MMS4_6a m3_12 dhn4 m4_6 vss sg13_hv_nmos w=2u l=0.45u m=1
MMS4_6b m3_13 dh4 m4_6 vss sg13_hv_nmos w=2u l=0.45u m=1
MMS4_7a m3_14 dhn4 m4_7 vss sg13_hv_nmos w=2u l=0.45u m=1
MMS4_7b m3_15 dh4 m4_7 vss sg13_hv_nmos w=2u l=0.45u m=1
MMS5_0a m4_0 dhn5 m5_0 vss sg13_hv_nmos w=2u l=0.45u m=1
MMS5_0b m4_1 dh5 m5_0 vss sg13_hv_nmos w=2u l=0.45u m=1
MMS5_1a m4_2 dhn5 m5_1 vss sg13_hv_nmos w=2u l=0.45u m=1
MMS5_1b m4_3 dh5 m5_1 vss sg13_hv_nmos w=2u l=0.45u m=1
MMS5_2a m4_4 dhn5 m5_2 vss sg13_hv_nmos w=2u l=0.45u m=1
MMS5_2b m4_5 dh5 m5_2 vss sg13_hv_nmos w=2u l=0.45u m=1
MMS5_3a m4_6 dhn5 m5_3 vss sg13_hv_nmos w=2u l=0.45u m=1
MMS5_3b m4_7 dh5 m5_3 vss sg13_hv_nmos w=2u l=0.45u m=1
MMS6_0a m5_0 dhn6 m6_0 vss sg13_hv_nmos w=2u l=0.45u m=1
MMS6_0b m5_1 dh6 m6_0 vss sg13_hv_nmos w=2u l=0.45u m=1
MMS6_1a m5_2 dhn6 m6_1 vss sg13_hv_nmos w=2u l=0.45u m=1
MMS6_1b m5_3 dh6 m6_1 vss sg13_hv_nmos w=2u l=0.45u m=1
MMS7_0a m6_0 dhn7 out vss sg13_hv_nmos w=2u l=0.45u m=1
MMS7_0b m6_1 dh7 out vss sg13_hv_nmos w=2u l=0.45u m=1
.ends
.subckt g1_inv a y vdd vss
MMP y a vdd vdd sg13_lv_pmos w=1u l=0.13u m=1
MMN y a vss vss sg13_lv_nmos w=0.5u l=0.13u m=1
.ends
.subckt g1_cmp inp inn clk q qb vdd vss
MMTAIL tail clk vss vss sg13_lv_nmos w=16u l=0.13u m=1
MM1 xp inp tail vss sg13_lv_nmos w=12u l=0.34u m=1
MM2 xq inn tail vss sg13_lv_nmos w=12u l=0.34u m=1
MMD1 xq inp xq vss sg13_lv_nmos w=6u l=0.13u m=1
MMD2 xp inn xp vss sg13_lv_nmos w=6u l=0.13u m=1
MM3 xn yn xp vss sg13_lv_nmos w=3u l=0.13u m=1
MM4 yn xn xq vss sg13_lv_nmos w=3u l=0.13u m=1
MM5 xn yn vdd vdd sg13_lv_pmos w=3u l=0.13u m=1
MM6 yn xn vdd vdd sg13_lv_pmos w=3u l=0.13u m=1
MM7 xn clk vdd vdd sg13_lv_pmos w=6u l=0.13u m=1
MM8 yn clk vdd vdd sg13_lv_pmos w=6u l=0.13u m=1
MM9 xp clk vdd vdd sg13_lv_pmos w=3u l=0.13u m=1
MM10 xq clk vdd vdd sg13_lv_pmos w=3u l=0.13u m=1
MMIAP xnb xn vdd vdd sg13_lv_pmos w=1u l=0.13u m=1
MMIAN xnb xn vss vss sg13_lv_nmos w=4u l=0.13u m=1
MMIBP ynb yn vdd vdd sg13_lv_pmos w=1u l=0.13u m=1
MMIBN ynb yn vss vss sg13_lv_nmos w=4u l=0.13u m=1
MMNAP1 na xnb vdd vdd sg13_lv_pmos w=4u l=0.13u m=1
MMNAP2 qb q na vdd sg13_lv_pmos w=4u l=0.13u m=1
MMNAN1 qb xnb vss vss sg13_lv_nmos w=1.5u l=0.13u m=1
MMNAN2 qb q vss vss sg13_lv_nmos w=1.5u l=0.13u m=1
MMNBP1 nb ynb vdd vdd sg13_lv_pmos w=4u l=0.13u m=1
MMNBP2 q qb nb vdd sg13_lv_pmos w=4u l=0.13u m=1
MMNBN1 q ynb vss vss sg13_lv_nmos w=1.5u l=0.13u m=1
MMNBN2 q qb vss vss sg13_lv_nmos w=1.5u l=0.13u m=1
.ends
.subckt g1_tlvlup a y yb vdd vdda vss
XI a ab vdd vss g1_inv
MMN1 nb a vss vss sg13_hv_nmos w=1.9u l=0.45u m=1
MMN2 n ab vss vss sg13_hv_nmos w=1.9u l=0.45u m=1
MMP1 nb n vdda vdda sg13_hv_pmos w=0.3u l=0.45u m=1
MMP2 n nb vdda vdda sg13_hv_pmos w=0.3u l=0.45u m=1
XO nb y vdda vss g1_thv_inv
XOB y yb vdda vss g1_thv_inv
.ends
.subckt g1_thv_inv a y vdda vss
MMP y a vdda vdda sg13_hv_pmos w=3.9u l=0.45u m=1
MMN y a vss vss sg13_hv_nmos w=1.9u l=0.45u m=1
.ends

* ---- macro g1_bgr (/work/designs/g1-guardian/blocks/g1_bgr/schematic/g1_bgr_lvs.cdl) ----
* G1_BGR LVS reference netlist, generated by make_lvs_cdl.py from xschem/g1_bgr.spice (frozen schematic).
* Format conversion only, plus 9 dummy HBTs tied to vss (see the docstring of make_lvs_cdl.py).
.subckt g1_bgr vdd vss r4 vref iptat pbias pcasc vbe dvbe
MMP1 d1 pbias vdd vdd sg13_hv_pmos w=10u l=4u ng=1 m=1
MMC1 n1 pcasc d1 d1 sg13_hv_pmos w=10u l=4u ng=1 m=1
MMP2 d2 pbias vdd vdd sg13_hv_pmos w=10u l=4u ng=1 m=1
MMC2 pbias pcasc d2 d2 sg13_hv_pmos w=10u l=4u ng=1 m=1
RRB pbias pcasc vss rppd w=1u l=500u m=1 b=0
MMNC1 n1 vb2 vbe vss sg13_hv_nmos w=20u l=1u ng=1 m=1
MMNC2 pcasc vb2 c2 vss sg13_hv_nmos w=20u l=1u ng=1 m=1
MMP5 d5 pbias vdd vdd sg13_hv_pmos w=10u l=4u ng=1 m=1
MMC5 vb2 pcasc d5 d5 sg13_hv_pmos w=10u l=4u ng=1 m=1
RRX vb2 vd1 vss rppd w=1u l=192u m=1 b=0
QQD1 vd1 vd1 vd2 vss npn13G2 le=900n we=70n Nx=1
QQD2 vd2 vd2 vss vss npn13G2 le=900n we=70n Nx=1
QQ1 vbe vbe vss vss npn13G2 le=900n we=70n Nx=1
QQ1B vbe b1b vss vss npn13G2 le=900n we=70n Nx=1
QQ2A c2 vbe dvbe vss npn13G2 le=900n we=70n Nx=1
QQ2B c2 vbe dvbe vss npn13G2 le=900n we=70n Nx=1
QQ2C c2 vbe dvbe vss npn13G2 le=900n we=70n Nx=1
QQ2D c2 vbe dvbe vss npn13G2 le=900n we=70n Nx=1
QQ2E c2 vbe dvbe vss npn13G2 le=900n we=70n Nx=1
QQ2F c2 vbe dvbe vss npn13G2 le=900n we=70n Nx=1
QQ2G c2 vbe dvbe vss npn13G2 le=900n we=70n Nx=1
QQ2H c2 vbe dvbe vss npn13G2 le=900n we=70n Nx=1
RR1 dvbe vss vss rppd w=1u l=51.5u m=1 b=0
MMP3 d3 pbias vdd vdd sg13_hv_pmos w=10u l=4u ng=1 m=1
MMC3 vref pcasc d3 d3 sg13_hv_pmos w=10u l=4u ng=1 m=1
RR2 vref vbe3 vss rppd w=1u l=315u m=1 b=0
QQ3 vbe3 vbe3 vss vss npn13G2 le=900n we=70n Nx=1
MMP4 d4 pbias vdd vdd sg13_hv_pmos w=10u l=4u ng=1 m=1
MMC4 iptat pcasc d4 d4 sg13_hv_pmos w=10u l=4u ng=1 m=1
MMPS det pbias vdd vdd sg13_hv_pmos w=10u l=4u ng=1 m=1
RRDET det vss vss rhigh w=0.5u l=735u m=1 b=0
MMNI kick det vss vss sg13_hv_nmos w=1u l=0.5u ng=1 m=1
MMPI kick det vdd vdd sg13_hv_pmos w=2u l=0.5u ng=1 m=1
MMKFB pbias kick vss vss sg13_hv_nmos w=1u l=4u ng=1 m=1
MMSW1 vbe r4 b1b vss sg13_hv_nmos w=2u l=0.5u ng=1 m=1
MMSW2 b1b r4n vss vss sg13_hv_nmos w=1u l=0.5u ng=1 m=1
MMNI2 r4n r4 vss vss sg13_hv_nmos w=1u l=0.5u ng=1 m=1
MMPI2 r4n r4 vdd vdd sg13_hv_pmos w=2u l=0.5u ng=1 m=1
QDUM1 vss vss vss vss npn13G2 le=900n we=70n Nx=1
QDUM2 vss vss vss vss npn13G2 le=900n we=70n Nx=1
QDUM3 vss vss vss vss npn13G2 le=900n we=70n Nx=1
QDUM4 vss vss vss vss npn13G2 le=900n we=70n Nx=1
QDUM5 vss vss vss vss npn13G2 le=900n we=70n Nx=1
QDUM6 vss vss vss vss npn13G2 le=900n we=70n Nx=1
QDUM7 vss vss vss vss npn13G2 le=900n we=70n Nx=1
QDUM8 vss vss vss vss npn13G2 le=900n we=70n Nx=1
QDUM9 vss vss vss vss npn13G2 le=900n we=70n Nx=1
.ends

* ---- macro g1_dose_macro (/work/designs/g1-guardian/blocks/g1_dose/schematic/g1_dose_macro.cdl) ----
* G1_DOSE macro netlist (CDL) for LVS of layout/g1_dose_macro.gds: the g1_dose_pair_pcell devices with the
* macro pin names (Metal3 stubs G_SHARED, D_STD, D_ELT on the west edge; vss bar on the south edge).
.subckt g1_dose_macro D_ELT D_STD G_SHARED vss
MHV D_ELT G_SHARED vss vss sg13_hv_nmos w=3.98u l=0.45u ng=1 m=1
MLV D_STD G_SHARED vss vss sg13_lv_nmos w=3.98u l=0.13u ng=1 m=1
.ends g1_dose_macro

* ---- macro g1_dut_macro (/work/designs/g1-guardian/blocks/g1_dut/schematic/g1_dut_macro.cdl) ----
* G1_DUT macro netlist (CDL) for LVS of layout/g1_dut_macro.gds: one npn13G2 (Nx=1) with the macro pin
* names (Metal3 stubs HBT_C, HBT_B, HBT_E on the west edge; vss = p+ substrate ring, bar on the south edge).
.subckt g1_dut_macro HBT_C HBT_B HBT_E vss
Q1 HBT_C HBT_B HBT_E vss npn13G2 le=900e-9 we=70.0n Nx=1
.ends g1_dut_macro

* ---- macro g1_ls_up (/work/designs/g1-guardian/blocks/g1_ctrl/ls/sim/netlist/g1_ls_up.cdl) ----
** sch_path: /work/designs/g1-guardian/blocks/g1_ctrl/ls/xschem/g1_ls_up.sch
.subckt g1_ls_up in out vdd vdda vss
*.ipin in
*.opin out
*.iopin vdd
*.iopin vdda
*.iopin vss
MPI inb in vdd vdd sg13_lv_pmos w=2u l=0.13u ng=1 m=1
MNI inb in vss vss sg13_lv_nmos w=1u l=0.13u ng=1 m=1
MN1 nb in vss vss sg13_hv_nmos w=3.8u l=0.45u ng=1 m=1
MN2 n inb vss vss sg13_hv_nmos w=3.8u l=0.45u ng=1 m=1
MP1 nb n vdda vdda sg13_hv_pmos w=0.3u l=0.45u ng=1 m=1
MP2 n nb vdda vdda sg13_hv_pmos w=0.3u l=0.45u ng=1 m=1
MPO out nb vdda vdda sg13_hv_pmos w=3.9u l=0.45u ng=1 m=1
MNO out nb vss vss sg13_hv_nmos w=1.9u l=0.45u ng=1 m=1
.ends

* ---- digital macro g1_digital from /work/designs/g1-guardian/blocks/g1_ctrl/layout/g1_digital.pnl.v ----
.SUBCKT g1_digital bgr_r4 clk_div_out clr_d cmp_clk cmp_hard cmp_soft en fast_en fault_n gate_en osc_clk osc_en por_n sclk sdi sdo t2f_en t2f_mode trip trip_d trip_set_sel tripped VDD VSS dac_hard_7_ dac_hard_6_ dac_hard_5_ dac_hard_4_ dac_hard_3_ dac_hard_2_ dac_hard_1_ dac_hard_0_ dac_soft_7_ dac_soft_6_ dac_soft_5_ dac_soft_4_ dac_soft_3_ dac_soft_2_ dac_soft_1_ dac_soft_0_ osc_trim_3_ osc_trim_2_ osc_trim_1_ osc_trim_0_ trip_cause_1_ trip_cause_0_
XANTENNA_1 net628 VDD VSS / sg13g2_antennanp
XANTENNA_2 net601 VDD VSS / sg13g2_antennanp
XFILLER_0_0 VDD VSS / sg13g2_decap_8
XFILLER_0_116 VDD VSS / sg13g2_fill_1
XFILLER_0_121 VDD VSS / sg13g2_fill_1
XFILLER_0_149 VDD VSS / sg13g2_decap_8
XFILLER_0_240 VDD VSS / sg13g2_fill_1
XFILLER_0_322 VDD VSS / sg13g2_decap_8
XFILLER_0_329 VDD VSS / sg13g2_decap_8
XFILLER_0_336 VDD VSS / sg13g2_decap_8
XFILLER_0_343 VDD VSS / sg13g2_decap_4
XFILLER_0_355 VDD VSS / sg13g2_fill_1
XFILLER_0_37 VDD VSS / sg13g2_decap_8
XFILLER_0_44 VDD VSS / sg13g2_decap_8
XFILLER_0_504 VDD VSS / sg13g2_fill_1
XFILLER_0_51 VDD VSS / sg13g2_fill_2
XFILLER_0_53 VDD VSS / sg13g2_fill_1
XFILLER_0_532 VDD VSS / sg13g2_fill_2
XFILLER_0_619 VDD VSS / sg13g2_fill_2
XFILLER_0_621 VDD VSS / sg13g2_fill_1
XFILLER_0_7 VDD VSS / sg13g2_fill_2
XFILLER_0_81 VDD VSS / sg13g2_decap_8
XFILLER_0_88 VDD VSS / sg13g2_fill_1
XFILLER_0_9 VDD VSS / sg13g2_fill_1
XFILLER_10_0 VDD VSS / sg13g2_decap_4
XFILLER_10_115 VDD VSS / sg13g2_fill_1
XFILLER_10_143 VDD VSS / sg13g2_fill_1
XFILLER_10_238 VDD VSS / sg13g2_fill_1
XFILLER_10_283 VDD VSS / sg13g2_decap_8
XFILLER_10_290 VDD VSS / sg13g2_fill_1
XFILLER_10_31 VDD VSS / sg13g2_decap_8
XFILLER_10_353 VDD VSS / sg13g2_decap_8
XFILLER_10_360 VDD VSS / sg13g2_decap_8
XFILLER_10_367 VDD VSS / sg13g2_fill_2
XFILLER_10_369 VDD VSS / sg13g2_fill_1
XFILLER_10_38 VDD VSS / sg13g2_decap_8
XFILLER_10_399 VDD VSS / sg13g2_fill_2
XFILLER_10_439 VDD VSS / sg13g2_fill_2
XFILLER_10_45 VDD VSS / sg13g2_decap_8
XFILLER_10_52 VDD VSS / sg13g2_decap_8
XFILLER_10_59 VDD VSS / sg13g2_decap_8
XFILLER_10_66 VDD VSS / sg13g2_fill_2
XFILLER_10_666 VDD VSS / sg13g2_fill_1
XFILLER_10_68 VDD VSS / sg13g2_fill_1
XFILLER_10_81 VDD VSS / sg13g2_decap_8
XFILLER_11_0 VDD VSS / sg13g2_decap_4
XFILLER_11_124 VDD VSS / sg13g2_decap_4
XFILLER_11_128 VDD VSS / sg13g2_fill_2
XFILLER_11_170 VDD VSS / sg13g2_fill_1
XFILLER_11_208 VDD VSS / sg13g2_fill_2
XFILLER_11_240 VDD VSS / sg13g2_decap_8
XFILLER_11_247 VDD VSS / sg13g2_fill_2
XFILLER_11_249 VDD VSS / sg13g2_fill_1
XFILLER_11_277 VDD VSS / sg13g2_decap_8
XFILLER_11_284 VDD VSS / sg13g2_decap_8
XFILLER_11_291 VDD VSS / sg13g2_decap_4
XFILLER_11_31 VDD VSS / sg13g2_decap_8
XFILLER_11_335 VDD VSS / sg13g2_decap_8
XFILLER_11_342 VDD VSS / sg13g2_decap_8
XFILLER_11_349 VDD VSS / sg13g2_decap_8
XFILLER_11_356 VDD VSS / sg13g2_decap_8
XFILLER_11_363 VDD VSS / sg13g2_decap_4
XFILLER_11_367 VDD VSS / sg13g2_fill_2
XFILLER_11_38 VDD VSS / sg13g2_decap_8
XFILLER_11_441 VDD VSS / sg13g2_fill_1
XFILLER_11_45 VDD VSS / sg13g2_fill_2
XFILLER_11_455 VDD VSS / sg13g2_fill_2
XFILLER_11_457 VDD VSS / sg13g2_fill_1
XFILLER_11_47 VDD VSS / sg13g2_fill_1
XFILLER_11_494 VDD VSS / sg13g2_fill_1
XFILLER_11_607 VDD VSS / sg13g2_fill_1
XFILLER_11_635 VDD VSS / sg13g2_fill_2
XFILLER_11_637 VDD VSS / sg13g2_fill_1
XFILLER_11_714 VDD VSS / sg13g2_fill_2
XFILLER_11_87 VDD VSS / sg13g2_fill_1
XFILLER_12_0 VDD VSS / sg13g2_decap_8
XFILLER_12_105 VDD VSS / sg13g2_fill_1
XFILLER_12_120 VDD VSS / sg13g2_decap_8
XFILLER_12_127 VDD VSS / sg13g2_decap_8
XFILLER_12_14 VDD VSS / sg13g2_decap_4
XFILLER_12_18 VDD VSS / sg13g2_fill_2
XFILLER_12_208 VDD VSS / sg13g2_fill_1
XFILLER_12_252 VDD VSS / sg13g2_decap_4
XFILLER_12_260 VDD VSS / sg13g2_decap_8
XFILLER_12_267 VDD VSS / sg13g2_decap_4
XFILLER_12_286 VDD VSS / sg13g2_decap_8
XFILLER_12_293 VDD VSS / sg13g2_fill_1
XFILLER_12_299 VDD VSS / sg13g2_decap_4
XFILLER_12_309 VDD VSS / sg13g2_decap_4
XFILLER_12_313 VDD VSS / sg13g2_fill_1
XFILLER_12_352 VDD VSS / sg13g2_decap_4
XFILLER_12_410 VDD VSS / sg13g2_fill_2
XFILLER_12_47 VDD VSS / sg13g2_decap_8
XFILLER_12_54 VDD VSS / sg13g2_decap_8
XFILLER_12_61 VDD VSS / sg13g2_decap_8
XFILLER_12_626 VDD VSS / sg13g2_fill_2
XFILLER_12_628 VDD VSS / sg13g2_fill_1
XFILLER_12_68 VDD VSS / sg13g2_decap_4
XFILLER_12_7 VDD VSS / sg13g2_decap_8
XFILLER_12_714 VDD VSS / sg13g2_fill_2
XFILLER_12_72 VDD VSS / sg13g2_fill_1
XFILLER_12_77 VDD VSS / sg13g2_fill_1
XFILLER_13_0 VDD VSS / sg13g2_decap_4
XFILLER_13_115 VDD VSS / sg13g2_decap_8
XFILLER_13_122 VDD VSS / sg13g2_decap_8
XFILLER_13_129 VDD VSS / sg13g2_decap_8
XFILLER_13_136 VDD VSS / sg13g2_decap_8
XFILLER_13_143 VDD VSS / sg13g2_decap_4
XFILLER_13_147 VDD VSS / sg13g2_fill_1
XFILLER_13_198 VDD VSS / sg13g2_fill_1
XFILLER_13_230 VDD VSS / sg13g2_decap_8
XFILLER_13_237 VDD VSS / sg13g2_fill_2
XFILLER_13_239 VDD VSS / sg13g2_fill_1
XFILLER_13_31 VDD VSS / sg13g2_fill_1
XFILLER_13_318 VDD VSS / sg13g2_decap_8
XFILLER_13_413 VDD VSS / sg13g2_fill_1
XFILLER_13_468 VDD VSS / sg13g2_fill_1
XFILLER_13_478 VDD VSS / sg13g2_fill_2
XFILLER_13_48 VDD VSS / sg13g2_decap_8
XFILLER_13_55 VDD VSS / sg13g2_decap_8
XFILLER_13_62 VDD VSS / sg13g2_decap_8
XFILLER_13_69 VDD VSS / sg13g2_decap_8
XFILLER_13_713 VDD VSS / sg13g2_fill_2
XFILLER_13_715 VDD VSS / sg13g2_fill_1
XFILLER_13_76 VDD VSS / sg13g2_decap_8
XFILLER_13_83 VDD VSS / sg13g2_decap_4
XFILLER_13_87 VDD VSS / sg13g2_fill_1
XFILLER_14_0 VDD VSS / sg13g2_decap_8
XFILLER_14_14 VDD VSS / sg13g2_decap_8
XFILLER_14_140 VDD VSS / sg13g2_decap_8
XFILLER_14_147 VDD VSS / sg13g2_decap_8
XFILLER_14_154 VDD VSS / sg13g2_decap_8
XFILLER_14_161 VDD VSS / sg13g2_decap_8
XFILLER_14_168 VDD VSS / sg13g2_fill_1
XFILLER_14_180 VDD VSS / sg13g2_fill_2
XFILLER_14_21 VDD VSS / sg13g2_decap_8
XFILLER_14_241 VDD VSS / sg13g2_decap_8
XFILLER_14_248 VDD VSS / sg13g2_fill_1
XFILLER_14_254 VDD VSS / sg13g2_fill_2
XFILLER_14_256 VDD VSS / sg13g2_fill_1
XFILLER_14_32 VDD VSS / sg13g2_decap_4
XFILLER_14_324 VDD VSS / sg13g2_decap_8
XFILLER_14_331 VDD VSS / sg13g2_decap_4
XFILLER_14_340 VDD VSS / sg13g2_fill_2
XFILLER_14_342 VDD VSS / sg13g2_fill_1
XFILLER_14_351 VDD VSS / sg13g2_decap_8
XFILLER_14_358 VDD VSS / sg13g2_decap_4
XFILLER_14_36 VDD VSS / sg13g2_fill_1
XFILLER_14_362 VDD VSS / sg13g2_fill_2
XFILLER_14_391 VDD VSS / sg13g2_decap_8
XFILLER_14_398 VDD VSS / sg13g2_fill_2
XFILLER_14_41 VDD VSS / sg13g2_decap_8
XFILLER_14_412 VDD VSS / sg13g2_fill_1
XFILLER_14_479 VDD VSS / sg13g2_fill_2
XFILLER_14_48 VDD VSS / sg13g2_decap_8
XFILLER_14_481 VDD VSS / sg13g2_fill_1
XFILLER_14_522 VDD VSS / sg13g2_fill_2
XFILLER_14_524 VDD VSS / sg13g2_fill_1
XFILLER_14_55 VDD VSS / sg13g2_decap_4
XFILLER_14_63 VDD VSS / sg13g2_decap_4
XFILLER_14_648 VDD VSS / sg13g2_fill_1
XFILLER_14_67 VDD VSS / sg13g2_fill_1
XFILLER_14_685 VDD VSS / sg13g2_fill_2
XFILLER_14_7 VDD VSS / sg13g2_decap_8
XFILLER_14_714 VDD VSS / sg13g2_fill_2
XFILLER_14_73 VDD VSS / sg13g2_decap_4
XFILLER_14_77 VDD VSS / sg13g2_fill_1
XFILLER_15_0 VDD VSS / sg13g2_decap_4
XFILLER_15_125 VDD VSS / sg13g2_decap_8
XFILLER_15_159 VDD VSS / sg13g2_fill_2
XFILLER_15_161 VDD VSS / sg13g2_fill_1
XFILLER_15_221 VDD VSS / sg13g2_fill_2
XFILLER_15_223 VDD VSS / sg13g2_fill_1
XFILLER_15_291 VDD VSS / sg13g2_fill_2
XFILLER_15_328 VDD VSS / sg13g2_decap_8
XFILLER_15_338 VDD VSS / sg13g2_decap_4
XFILLER_15_342 VDD VSS / sg13g2_fill_2
XFILLER_15_382 VDD VSS / sg13g2_decap_8
XFILLER_15_389 VDD VSS / sg13g2_decap_8
XFILLER_15_396 VDD VSS / sg13g2_fill_1
XFILLER_15_402 VDD VSS / sg13g2_fill_1
XFILLER_15_474 VDD VSS / sg13g2_fill_2
XFILLER_15_476 VDD VSS / sg13g2_fill_1
XFILLER_15_491 VDD VSS / sg13g2_fill_2
XFILLER_15_50 VDD VSS / sg13g2_decap_4
XFILLER_15_565 VDD VSS / sg13g2_fill_1
XFILLER_15_606 VDD VSS / sg13g2_fill_2
XFILLER_15_671 VDD VSS / sg13g2_fill_1
XFILLER_15_704 VDD VSS / sg13g2_fill_1
XFILLER_15_714 VDD VSS / sg13g2_fill_2
XFILLER_15_81 VDD VSS / sg13g2_fill_2
XFILLER_15_83 VDD VSS / sg13g2_fill_1
XFILLER_16_0 VDD VSS / sg13g2_decap_4
XFILLER_16_130 VDD VSS / sg13g2_decap_8
XFILLER_16_137 VDD VSS / sg13g2_decap_8
XFILLER_16_144 VDD VSS / sg13g2_decap_8
XFILLER_16_151 VDD VSS / sg13g2_fill_2
XFILLER_16_197 VDD VSS / sg13g2_fill_2
XFILLER_16_205 VDD VSS / sg13g2_fill_1
XFILLER_16_223 VDD VSS / sg13g2_fill_2
XFILLER_16_256 VDD VSS / sg13g2_fill_1
XFILLER_16_284 VDD VSS / sg13g2_fill_1
XFILLER_16_293 VDD VSS / sg13g2_decap_8
XFILLER_16_31 VDD VSS / sg13g2_fill_1
XFILLER_16_335 VDD VSS / sg13g2_fill_2
XFILLER_16_374 VDD VSS / sg13g2_decap_8
XFILLER_16_381 VDD VSS / sg13g2_decap_4
XFILLER_16_385 VDD VSS / sg13g2_fill_2
XFILLER_16_418 VDD VSS / sg13g2_fill_1
XFILLER_16_454 VDD VSS / sg13g2_fill_1
XFILLER_16_47 VDD VSS / sg13g2_decap_8
XFILLER_16_473 VDD VSS / sg13g2_fill_2
XFILLER_16_475 VDD VSS / sg13g2_fill_1
XFILLER_16_54 VDD VSS / sg13g2_decap_4
XFILLER_16_58 VDD VSS / sg13g2_fill_1
XFILLER_16_606 VDD VSS / sg13g2_fill_2
XFILLER_16_608 VDD VSS / sg13g2_fill_1
XFILLER_16_663 VDD VSS / sg13g2_fill_2
XFILLER_16_715 VDD VSS / sg13g2_fill_1
XFILLER_16_75 VDD VSS / sg13g2_fill_1
XFILLER_17_0 VDD VSS / sg13g2_decap_4
XFILLER_17_139 VDD VSS / sg13g2_fill_2
XFILLER_17_153 VDD VSS / sg13g2_decap_4
XFILLER_17_161 VDD VSS / sg13g2_fill_2
XFILLER_17_211 VDD VSS / sg13g2_fill_1
XFILLER_17_239 VDD VSS / sg13g2_fill_2
XFILLER_17_258 VDD VSS / sg13g2_decap_4
XFILLER_17_262 VDD VSS / sg13g2_fill_2
XFILLER_17_299 VDD VSS / sg13g2_decap_8
XFILLER_17_306 VDD VSS / sg13g2_fill_2
XFILLER_17_308 VDD VSS / sg13g2_fill_1
XFILLER_17_313 VDD VSS / sg13g2_fill_1
XFILLER_17_375 VDD VSS / sg13g2_decap_4
XFILLER_17_40 VDD VSS / sg13g2_decap_8
XFILLER_17_438 VDD VSS / sg13g2_fill_1
XFILLER_17_47 VDD VSS / sg13g2_decap_8
XFILLER_17_531 VDD VSS / sg13g2_fill_1
XFILLER_17_54 VDD VSS / sg13g2_decap_8
XFILLER_17_541 VDD VSS / sg13g2_fill_2
XFILLER_17_543 VDD VSS / sg13g2_fill_1
XFILLER_17_571 VDD VSS / sg13g2_fill_2
XFILLER_17_61 VDD VSS / sg13g2_decap_4
XFILLER_17_681 VDD VSS / sg13g2_fill_1
XFILLER_17_714 VDD VSS / sg13g2_fill_2
XFILLER_17_74 VDD VSS / sg13g2_decap_8
XFILLER_17_81 VDD VSS / sg13g2_fill_1
XFILLER_18_0 VDD VSS / sg13g2_decap_4
XFILLER_18_115 VDD VSS / sg13g2_decap_8
XFILLER_18_122 VDD VSS / sg13g2_decap_4
XFILLER_18_126 VDD VSS / sg13g2_fill_2
XFILLER_18_155 VDD VSS / sg13g2_fill_2
XFILLER_18_223 VDD VSS / sg13g2_fill_2
XFILLER_18_253 VDD VSS / sg13g2_decap_4
XFILLER_18_257 VDD VSS / sg13g2_fill_2
XFILLER_18_292 VDD VSS / sg13g2_decap_4
XFILLER_18_296 VDD VSS / sg13g2_fill_2
XFILLER_18_325 VDD VSS / sg13g2_fill_1
XFILLER_18_335 VDD VSS / sg13g2_fill_1
XFILLER_18_368 VDD VSS / sg13g2_decap_4
XFILLER_18_414 VDD VSS / sg13g2_decap_8
XFILLER_18_421 VDD VSS / sg13g2_decap_8
XFILLER_18_474 VDD VSS / sg13g2_fill_1
XFILLER_18_58 VDD VSS / sg13g2_decap_8
XFILLER_18_65 VDD VSS / sg13g2_decap_8
XFILLER_18_650 VDD VSS / sg13g2_fill_1
XFILLER_18_714 VDD VSS / sg13g2_fill_2
XFILLER_18_72 VDD VSS / sg13g2_decap_8
XFILLER_18_79 VDD VSS / sg13g2_decap_8
XFILLER_18_86 VDD VSS / sg13g2_fill_2
XFILLER_19_0 VDD VSS / sg13g2_decap_4
XFILLER_19_115 VDD VSS / sg13g2_decap_8
XFILLER_19_122 VDD VSS / sg13g2_decap_8
XFILLER_19_129 VDD VSS / sg13g2_decap_8
XFILLER_19_136 VDD VSS / sg13g2_fill_1
XFILLER_19_169 VDD VSS / sg13g2_fill_2
XFILLER_19_242 VDD VSS / sg13g2_fill_2
XFILLER_19_244 VDD VSS / sg13g2_fill_1
XFILLER_19_295 VDD VSS / sg13g2_decap_8
XFILLER_19_302 VDD VSS / sg13g2_decap_8
XFILLER_19_309 VDD VSS / sg13g2_fill_2
XFILLER_19_31 VDD VSS / sg13g2_decap_8
XFILLER_19_311 VDD VSS / sg13g2_fill_1
XFILLER_19_343 VDD VSS / sg13g2_decap_4
XFILLER_19_347 VDD VSS / sg13g2_fill_1
XFILLER_19_351 VDD VSS / sg13g2_decap_8
XFILLER_19_358 VDD VSS / sg13g2_decap_8
XFILLER_19_365 VDD VSS / sg13g2_decap_8
XFILLER_19_372 VDD VSS / sg13g2_decap_4
XFILLER_19_38 VDD VSS / sg13g2_decap_8
XFILLER_19_407 VDD VSS / sg13g2_decap_4
XFILLER_19_411 VDD VSS / sg13g2_fill_2
XFILLER_19_426 VDD VSS / sg13g2_fill_2
XFILLER_19_45 VDD VSS / sg13g2_decap_8
XFILLER_19_497 VDD VSS / sg13g2_fill_2
XFILLER_19_52 VDD VSS / sg13g2_decap_8
XFILLER_19_557 VDD VSS / sg13g2_fill_2
XFILLER_19_59 VDD VSS / sg13g2_decap_8
XFILLER_19_66 VDD VSS / sg13g2_decap_8
XFILLER_19_667 VDD VSS / sg13g2_fill_1
XFILLER_19_708 VDD VSS / sg13g2_fill_2
XFILLER_19_715 VDD VSS / sg13g2_fill_1
XFILLER_19_73 VDD VSS / sg13g2_fill_1
XFILLER_19_87 VDD VSS / sg13g2_fill_1
XFILLER_1_0 VDD VSS / sg13g2_decap_4
XFILLER_1_115 VDD VSS / sg13g2_fill_1
XFILLER_1_132 VDD VSS / sg13g2_decap_8
XFILLER_1_139 VDD VSS / sg13g2_decap_8
XFILLER_1_146 VDD VSS / sg13g2_decap_8
XFILLER_1_180 VDD VSS / sg13g2_decap_8
XFILLER_1_190 VDD VSS / sg13g2_fill_1
XFILLER_1_195 VDD VSS / sg13g2_decap_8
XFILLER_1_202 VDD VSS / sg13g2_decap_8
XFILLER_1_209 VDD VSS / sg13g2_decap_8
XFILLER_1_216 VDD VSS / sg13g2_decap_4
XFILLER_1_220 VDD VSS / sg13g2_fill_2
XFILLER_1_262 VDD VSS / sg13g2_decap_8
XFILLER_1_269 VDD VSS / sg13g2_fill_1
XFILLER_1_273 VDD VSS / sg13g2_decap_8
XFILLER_1_280 VDD VSS / sg13g2_decap_8
XFILLER_1_287 VDD VSS / sg13g2_decap_8
XFILLER_1_294 VDD VSS / sg13g2_decap_8
XFILLER_1_301 VDD VSS / sg13g2_decap_8
XFILLER_1_308 VDD VSS / sg13g2_decap_8
XFILLER_1_315 VDD VSS / sg13g2_decap_4
XFILLER_1_319 VDD VSS / sg13g2_fill_1
XFILLER_1_347 VDD VSS / sg13g2_fill_2
XFILLER_1_58 VDD VSS / sg13g2_fill_2
XFILLER_1_60 VDD VSS / sg13g2_fill_1
XFILLER_1_662 VDD VSS / sg13g2_fill_1
XFILLER_1_714 VDD VSS / sg13g2_fill_2
XFILLER_20_0 VDD VSS / sg13g2_decap_4
XFILLER_20_123 VDD VSS / sg13g2_decap_8
XFILLER_20_130 VDD VSS / sg13g2_decap_4
XFILLER_20_134 VDD VSS / sg13g2_fill_2
XFILLER_20_139 VDD VSS / sg13g2_fill_1
XFILLER_20_148 VDD VSS / sg13g2_fill_1
XFILLER_20_218 VDD VSS / sg13g2_fill_2
XFILLER_20_224 VDD VSS / sg13g2_fill_1
XFILLER_20_235 VDD VSS / sg13g2_fill_1
XFILLER_20_249 VDD VSS / sg13g2_fill_2
XFILLER_20_278 VDD VSS / sg13g2_fill_1
XFILLER_20_292 VDD VSS / sg13g2_decap_8
XFILLER_20_299 VDD VSS / sg13g2_decap_8
XFILLER_20_31 VDD VSS / sg13g2_decap_8
XFILLER_20_336 VDD VSS / sg13g2_decap_8
XFILLER_20_343 VDD VSS / sg13g2_decap_8
XFILLER_20_350 VDD VSS / sg13g2_decap_4
XFILLER_20_354 VDD VSS / sg13g2_fill_2
XFILLER_20_373 VDD VSS / sg13g2_decap_8
XFILLER_20_38 VDD VSS / sg13g2_decap_8
XFILLER_20_380 VDD VSS / sg13g2_decap_8
XFILLER_20_387 VDD VSS / sg13g2_decap_4
XFILLER_20_395 VDD VSS / sg13g2_decap_8
XFILLER_20_402 VDD VSS / sg13g2_decap_8
XFILLER_20_409 VDD VSS / sg13g2_decap_8
XFILLER_20_416 VDD VSS / sg13g2_decap_4
XFILLER_20_424 VDD VSS / sg13g2_fill_2
XFILLER_20_426 VDD VSS / sg13g2_fill_1
XFILLER_20_45 VDD VSS / sg13g2_decap_8
XFILLER_20_508 VDD VSS / sg13g2_fill_1
XFILLER_20_52 VDD VSS / sg13g2_decap_8
XFILLER_20_550 VDD VSS / sg13g2_fill_2
XFILLER_20_552 VDD VSS / sg13g2_fill_1
XFILLER_20_562 VDD VSS / sg13g2_fill_2
XFILLER_20_59 VDD VSS / sg13g2_fill_2
XFILLER_20_654 VDD VSS / sg13g2_fill_2
XFILLER_20_713 VDD VSS / sg13g2_fill_2
XFILLER_20_715 VDD VSS / sg13g2_fill_1
XFILLER_21_0 VDD VSS / sg13g2_decap_4
XFILLER_21_128 VDD VSS / sg13g2_fill_2
XFILLER_21_172 VDD VSS / sg13g2_fill_2
XFILLER_21_212 VDD VSS / sg13g2_fill_2
XFILLER_21_245 VDD VSS / sg13g2_decap_8
XFILLER_21_252 VDD VSS / sg13g2_fill_1
XFILLER_21_288 VDD VSS / sg13g2_decap_8
XFILLER_21_31 VDD VSS / sg13g2_decap_8
XFILLER_21_326 VDD VSS / sg13g2_decap_8
XFILLER_21_333 VDD VSS / sg13g2_decap_8
XFILLER_21_367 VDD VSS / sg13g2_fill_1
XFILLER_21_38 VDD VSS / sg13g2_decap_8
XFILLER_21_380 VDD VSS / sg13g2_decap_8
XFILLER_21_387 VDD VSS / sg13g2_decap_4
XFILLER_21_391 VDD VSS / sg13g2_fill_2
XFILLER_21_422 VDD VSS / sg13g2_fill_2
XFILLER_21_45 VDD VSS / sg13g2_fill_2
XFILLER_21_461 VDD VSS / sg13g2_fill_1
XFILLER_21_47 VDD VSS / sg13g2_fill_1
XFILLER_21_61 VDD VSS / sg13g2_decap_8
XFILLER_21_615 VDD VSS / sg13g2_fill_1
XFILLER_21_68 VDD VSS / sg13g2_fill_2
XFILLER_21_70 VDD VSS / sg13g2_fill_1
XFILLER_21_714 VDD VSS / sg13g2_fill_2
XFILLER_22_0 VDD VSS / sg13g2_decap_8
XFILLER_22_149 VDD VSS / sg13g2_fill_1
XFILLER_22_198 VDD VSS / sg13g2_fill_1
XFILLER_22_252 VDD VSS / sg13g2_fill_1
XFILLER_22_288 VDD VSS / sg13g2_decap_4
XFILLER_22_292 VDD VSS / sg13g2_fill_1
XFILLER_22_329 VDD VSS / sg13g2_fill_2
XFILLER_22_374 VDD VSS / sg13g2_decap_8
XFILLER_22_381 VDD VSS / sg13g2_fill_1
XFILLER_22_418 VDD VSS / sg13g2_fill_2
XFILLER_22_42 VDD VSS / sg13g2_decap_8
XFILLER_22_457 VDD VSS / sg13g2_fill_2
XFILLER_22_49 VDD VSS / sg13g2_fill_2
XFILLER_22_496 VDD VSS / sg13g2_fill_2
XFILLER_22_51 VDD VSS / sg13g2_fill_1
XFILLER_22_557 VDD VSS / sg13g2_fill_1
XFILLER_22_59 VDD VSS / sg13g2_decap_8
XFILLER_22_612 VDD VSS / sg13g2_fill_2
XFILLER_22_66 VDD VSS / sg13g2_decap_8
XFILLER_22_713 VDD VSS / sg13g2_fill_2
XFILLER_22_715 VDD VSS / sg13g2_fill_1
XFILLER_22_73 VDD VSS / sg13g2_fill_1
XFILLER_23_0 VDD VSS / sg13g2_decap_8
XFILLER_23_121 VDD VSS / sg13g2_decap_4
XFILLER_23_14 VDD VSS / sg13g2_fill_1
XFILLER_23_142 VDD VSS / sg13g2_fill_2
XFILLER_23_213 VDD VSS / sg13g2_fill_1
XFILLER_23_247 VDD VSS / sg13g2_fill_1
XFILLER_23_270 VDD VSS / sg13g2_decap_4
XFILLER_23_307 VDD VSS / sg13g2_fill_2
XFILLER_23_319 VDD VSS / sg13g2_fill_2
XFILLER_23_348 VDD VSS / sg13g2_fill_2
XFILLER_23_350 VDD VSS / sg13g2_fill_1
XFILLER_23_383 VDD VSS / sg13g2_fill_2
XFILLER_23_425 VDD VSS / sg13g2_decap_4
XFILLER_23_438 VDD VSS / sg13g2_fill_1
XFILLER_23_457 VDD VSS / sg13g2_decap_4
XFILLER_23_475 VDD VSS / sg13g2_fill_2
XFILLER_23_477 VDD VSS / sg13g2_fill_1
XFILLER_23_490 VDD VSS / sg13g2_fill_2
XFILLER_23_559 VDD VSS / sg13g2_fill_2
XFILLER_23_561 VDD VSS / sg13g2_fill_1
XFILLER_23_60 VDD VSS / sg13g2_decap_8
XFILLER_23_67 VDD VSS / sg13g2_decap_8
XFILLER_23_7 VDD VSS / sg13g2_decap_8
XFILLER_23_714 VDD VSS / sg13g2_fill_2
XFILLER_23_74 VDD VSS / sg13g2_decap_8
XFILLER_23_81 VDD VSS / sg13g2_fill_2
XFILLER_24_0 VDD VSS / sg13g2_decap_8
XFILLER_24_115 VDD VSS / sg13g2_decap_8
XFILLER_24_122 VDD VSS / sg13g2_decap_4
XFILLER_24_126 VDD VSS / sg13g2_fill_2
XFILLER_24_14 VDD VSS / sg13g2_decap_4
XFILLER_24_18 VDD VSS / sg13g2_fill_2
XFILLER_24_212 VDD VSS / sg13g2_fill_2
XFILLER_24_214 VDD VSS / sg13g2_fill_1
XFILLER_24_255 VDD VSS / sg13g2_fill_2
XFILLER_24_27 VDD VSS / sg13g2_decap_4
XFILLER_24_280 VDD VSS / sg13g2_decap_8
XFILLER_24_287 VDD VSS / sg13g2_decap_8
XFILLER_24_294 VDD VSS / sg13g2_decap_8
XFILLER_24_301 VDD VSS / sg13g2_fill_2
XFILLER_24_31 VDD VSS / sg13g2_fill_1
XFILLER_24_323 VDD VSS / sg13g2_decap_8
XFILLER_24_330 VDD VSS / sg13g2_decap_4
XFILLER_24_382 VDD VSS / sg13g2_decap_8
XFILLER_24_389 VDD VSS / sg13g2_fill_2
XFILLER_24_422 VDD VSS / sg13g2_decap_8
XFILLER_24_433 VDD VSS / sg13g2_fill_2
XFILLER_24_435 VDD VSS / sg13g2_fill_1
XFILLER_24_440 VDD VSS / sg13g2_decap_8
XFILLER_24_447 VDD VSS / sg13g2_fill_2
XFILLER_24_453 VDD VSS / sg13g2_decap_8
XFILLER_24_460 VDD VSS / sg13g2_decap_8
XFILLER_24_467 VDD VSS / sg13g2_decap_8
XFILLER_24_474 VDD VSS / sg13g2_decap_8
XFILLER_24_481 VDD VSS / sg13g2_fill_1
XFILLER_24_51 VDD VSS / sg13g2_decap_8
XFILLER_24_565 VDD VSS / sg13g2_fill_2
XFILLER_24_58 VDD VSS / sg13g2_decap_8
XFILLER_24_65 VDD VSS / sg13g2_decap_8
XFILLER_24_7 VDD VSS / sg13g2_decap_8
XFILLER_24_715 VDD VSS / sg13g2_fill_1
XFILLER_24_72 VDD VSS / sg13g2_decap_4
XFILLER_24_76 VDD VSS / sg13g2_fill_1
XFILLER_25_0 VDD VSS / sg13g2_decap_4
XFILLER_25_120 VDD VSS / sg13g2_fill_2
XFILLER_25_122 VDD VSS / sg13g2_fill_1
XFILLER_25_128 VDD VSS / sg13g2_decap_8
XFILLER_25_135 VDD VSS / sg13g2_fill_2
XFILLER_25_147 VDD VSS / sg13g2_fill_1
XFILLER_25_207 VDD VSS / sg13g2_fill_2
XFILLER_25_250 VDD VSS / sg13g2_decap_4
XFILLER_25_254 VDD VSS / sg13g2_fill_2
XFILLER_25_284 VDD VSS / sg13g2_decap_8
XFILLER_25_291 VDD VSS / sg13g2_decap_4
XFILLER_25_295 VDD VSS / sg13g2_fill_2
XFILLER_25_31 VDD VSS / sg13g2_decap_8
XFILLER_25_328 VDD VSS / sg13g2_decap_8
XFILLER_25_335 VDD VSS / sg13g2_fill_1
XFILLER_25_377 VDD VSS / sg13g2_fill_2
XFILLER_25_38 VDD VSS / sg13g2_fill_1
XFILLER_25_416 VDD VSS / sg13g2_decap_8
XFILLER_25_43 VDD VSS / sg13g2_decap_8
XFILLER_25_450 VDD VSS / sg13g2_fill_2
XFILLER_25_492 VDD VSS / sg13g2_fill_2
XFILLER_25_50 VDD VSS / sg13g2_decap_4
XFILLER_25_506 VDD VSS / sg13g2_fill_2
XFILLER_25_535 VDD VSS / sg13g2_fill_2
XFILLER_25_81 VDD VSS / sg13g2_fill_2
XFILLER_26_0 VDD VSS / sg13g2_decap_4
XFILLER_26_147 VDD VSS / sg13g2_fill_1
XFILLER_26_225 VDD VSS / sg13g2_decap_8
XFILLER_26_232 VDD VSS / sg13g2_decap_8
XFILLER_26_239 VDD VSS / sg13g2_decap_8
XFILLER_26_246 VDD VSS / sg13g2_decap_8
XFILLER_26_288 VDD VSS / sg13g2_decap_8
XFILLER_26_31 VDD VSS / sg13g2_decap_8
XFILLER_26_322 VDD VSS / sg13g2_decap_8
XFILLER_26_329 VDD VSS / sg13g2_decap_8
XFILLER_26_336 VDD VSS / sg13g2_decap_8
XFILLER_26_343 VDD VSS / sg13g2_fill_2
XFILLER_26_372 VDD VSS / sg13g2_decap_4
XFILLER_26_38 VDD VSS / sg13g2_decap_8
XFILLER_26_412 VDD VSS / sg13g2_fill_2
XFILLER_26_414 VDD VSS / sg13g2_fill_1
XFILLER_26_447 VDD VSS / sg13g2_fill_2
XFILLER_26_449 VDD VSS / sg13g2_fill_1
XFILLER_26_45 VDD VSS / sg13g2_decap_8
XFILLER_26_52 VDD VSS / sg13g2_decap_8
XFILLER_26_59 VDD VSS / sg13g2_decap_4
XFILLER_26_618 VDD VSS / sg13g2_fill_2
XFILLER_26_629 VDD VSS / sg13g2_fill_2
XFILLER_26_63 VDD VSS / sg13g2_fill_2
XFILLER_26_631 VDD VSS / sg13g2_fill_1
XFILLER_26_695 VDD VSS / sg13g2_fill_1
XFILLER_26_705 VDD VSS / sg13g2_fill_2
XFILLER_26_92 VDD VSS / sg13g2_fill_1
XFILLER_27_0 VDD VSS / sg13g2_decap_4
XFILLER_27_147 VDD VSS / sg13g2_decap_8
XFILLER_27_154 VDD VSS / sg13g2_fill_2
XFILLER_27_156 VDD VSS / sg13g2_fill_1
XFILLER_27_209 VDD VSS / sg13g2_fill_2
XFILLER_27_219 VDD VSS / sg13g2_decap_8
XFILLER_27_226 VDD VSS / sg13g2_decap_8
XFILLER_27_233 VDD VSS / sg13g2_decap_8
XFILLER_27_240 VDD VSS / sg13g2_fill_1
XFILLER_27_284 VDD VSS / sg13g2_fill_2
XFILLER_27_286 VDD VSS / sg13g2_fill_1
XFILLER_27_298 VDD VSS / sg13g2_decap_8
XFILLER_27_305 VDD VSS / sg13g2_fill_1
XFILLER_27_333 VDD VSS / sg13g2_decap_8
XFILLER_27_340 VDD VSS / sg13g2_decap_8
XFILLER_27_347 VDD VSS / sg13g2_fill_2
XFILLER_27_349 VDD VSS / sg13g2_fill_1
XFILLER_27_35 VDD VSS / sg13g2_fill_1
XFILLER_27_354 VDD VSS / sg13g2_decap_4
XFILLER_27_358 VDD VSS / sg13g2_fill_2
XFILLER_27_367 VDD VSS / sg13g2_decap_8
XFILLER_27_374 VDD VSS / sg13g2_decap_4
XFILLER_27_378 VDD VSS / sg13g2_fill_2
XFILLER_27_40 VDD VSS / sg13g2_decap_8
XFILLER_27_466 VDD VSS / sg13g2_fill_2
XFILLER_27_47 VDD VSS / sg13g2_decap_8
XFILLER_27_500 VDD VSS / sg13g2_fill_2
XFILLER_27_502 VDD VSS / sg13g2_fill_1
XFILLER_27_512 VDD VSS / sg13g2_fill_1
XFILLER_27_54 VDD VSS / sg13g2_decap_8
XFILLER_27_550 VDD VSS / sg13g2_fill_2
XFILLER_27_552 VDD VSS / sg13g2_fill_1
XFILLER_27_580 VDD VSS / sg13g2_fill_2
XFILLER_27_61 VDD VSS / sg13g2_fill_2
XFILLER_27_684 VDD VSS / sg13g2_fill_1
XFILLER_28_0 VDD VSS / sg13g2_decap_8
XFILLER_28_129 VDD VSS / sg13g2_decap_4
XFILLER_28_133 VDD VSS / sg13g2_fill_1
XFILLER_28_138 VDD VSS / sg13g2_fill_2
XFILLER_28_14 VDD VSS / sg13g2_decap_4
XFILLER_28_198 VDD VSS / sg13g2_fill_2
XFILLER_28_200 VDD VSS / sg13g2_fill_1
XFILLER_28_209 VDD VSS / sg13g2_decap_8
XFILLER_28_216 VDD VSS / sg13g2_decap_8
XFILLER_28_227 VDD VSS / sg13g2_decap_8
XFILLER_28_234 VDD VSS / sg13g2_decap_4
XFILLER_28_238 VDD VSS / sg13g2_fill_2
XFILLER_28_267 VDD VSS / sg13g2_fill_1
XFILLER_28_326 VDD VSS / sg13g2_fill_2
XFILLER_28_341 VDD VSS / sg13g2_decap_8
XFILLER_28_348 VDD VSS / sg13g2_fill_2
XFILLER_28_366 VDD VSS / sg13g2_decap_8
XFILLER_28_373 VDD VSS / sg13g2_decap_8
XFILLER_28_380 VDD VSS / sg13g2_fill_1
XFILLER_28_408 VDD VSS / sg13g2_fill_1
XFILLER_28_432 VDD VSS / sg13g2_fill_2
XFILLER_28_434 VDD VSS / sg13g2_fill_1
XFILLER_28_448 VDD VSS / sg13g2_fill_2
XFILLER_28_45 VDD VSS / sg13g2_decap_8
XFILLER_28_450 VDD VSS / sg13g2_fill_1
XFILLER_28_458 VDD VSS / sg13g2_fill_2
XFILLER_28_492 VDD VSS / sg13g2_decap_8
XFILLER_28_499 VDD VSS / sg13g2_decap_4
XFILLER_28_503 VDD VSS / sg13g2_fill_2
XFILLER_28_52 VDD VSS / sg13g2_decap_8
XFILLER_28_536 VDD VSS / sg13g2_fill_1
XFILLER_28_542 VDD VSS / sg13g2_fill_1
XFILLER_28_548 VDD VSS / sg13g2_fill_1
XFILLER_28_59 VDD VSS / sg13g2_decap_8
XFILLER_28_590 VDD VSS / sg13g2_fill_2
XFILLER_28_646 VDD VSS / sg13g2_fill_1
XFILLER_28_66 VDD VSS / sg13g2_decap_4
XFILLER_28_683 VDD VSS / sg13g2_fill_2
XFILLER_28_7 VDD VSS / sg13g2_decap_8
XFILLER_28_81 VDD VSS / sg13g2_fill_1
XFILLER_29_0 VDD VSS / sg13g2_decap_4
XFILLER_29_123 VDD VSS / sg13g2_decap_8
XFILLER_29_130 VDD VSS / sg13g2_decap_4
XFILLER_29_134 VDD VSS / sg13g2_fill_1
XFILLER_29_256 VDD VSS / sg13g2_decap_8
XFILLER_29_263 VDD VSS / sg13g2_decap_8
XFILLER_29_270 VDD VSS / sg13g2_decap_4
XFILLER_29_274 VDD VSS / sg13g2_fill_2
XFILLER_29_303 VDD VSS / sg13g2_fill_2
XFILLER_29_359 VDD VSS / sg13g2_fill_1
XFILLER_29_378 VDD VSS / sg13g2_fill_2
XFILLER_29_380 VDD VSS / sg13g2_fill_1
XFILLER_29_408 VDD VSS / sg13g2_decap_8
XFILLER_29_415 VDD VSS / sg13g2_fill_2
XFILLER_29_444 VDD VSS / sg13g2_fill_1
XFILLER_29_458 VDD VSS / sg13g2_fill_2
XFILLER_29_487 VDD VSS / sg13g2_decap_8
XFILLER_29_494 VDD VSS / sg13g2_decap_8
XFILLER_29_501 VDD VSS / sg13g2_decap_4
XFILLER_29_505 VDD VSS / sg13g2_fill_2
XFILLER_29_51 VDD VSS / sg13g2_fill_1
XFILLER_29_550 VDD VSS / sg13g2_fill_2
XFILLER_29_68 VDD VSS / sg13g2_decap_8
XFILLER_29_715 VDD VSS / sg13g2_fill_1
XFILLER_29_75 VDD VSS / sg13g2_decap_8
XFILLER_29_82 VDD VSS / sg13g2_decap_4
XFILLER_29_86 VDD VSS / sg13g2_fill_2
XFILLER_2_0 VDD VSS / sg13g2_decap_4
XFILLER_2_117 VDD VSS / sg13g2_fill_2
XFILLER_2_151 VDD VSS / sg13g2_fill_1
XFILLER_2_172 VDD VSS / sg13g2_decap_4
XFILLER_2_176 VDD VSS / sg13g2_fill_1
XFILLER_2_204 VDD VSS / sg13g2_decap_8
XFILLER_2_211 VDD VSS / sg13g2_decap_8
XFILLER_2_218 VDD VSS / sg13g2_decap_8
XFILLER_2_225 VDD VSS / sg13g2_decap_8
XFILLER_2_232 VDD VSS / sg13g2_fill_1
XFILLER_2_242 VDD VSS / sg13g2_decap_8
XFILLER_2_249 VDD VSS / sg13g2_decap_8
XFILLER_2_256 VDD VSS / sg13g2_decap_8
XFILLER_2_263 VDD VSS / sg13g2_fill_2
XFILLER_2_278 VDD VSS / sg13g2_decap_8
XFILLER_2_285 VDD VSS / sg13g2_decap_4
XFILLER_2_294 VDD VSS / sg13g2_decap_8
XFILLER_2_301 VDD VSS / sg13g2_decap_4
XFILLER_2_31 VDD VSS / sg13g2_decap_8
XFILLER_2_324 VDD VSS / sg13g2_decap_8
XFILLER_2_331 VDD VSS / sg13g2_fill_2
XFILLER_2_38 VDD VSS / sg13g2_fill_2
XFILLER_2_40 VDD VSS / sg13g2_fill_1
XFILLER_2_45 VDD VSS / sg13g2_decap_8
XFILLER_2_52 VDD VSS / sg13g2_decap_8
XFILLER_2_59 VDD VSS / sg13g2_decap_4
XFILLER_2_714 VDD VSS / sg13g2_fill_2
XFILLER_2_88 VDD VSS / sg13g2_fill_2
XFILLER_30_0 VDD VSS / sg13g2_decap_4
XFILLER_30_128 VDD VSS / sg13g2_decap_4
XFILLER_30_132 VDD VSS / sg13g2_fill_2
XFILLER_30_169 VDD VSS / sg13g2_fill_2
XFILLER_30_198 VDD VSS / sg13g2_fill_1
XFILLER_30_253 VDD VSS / sg13g2_decap_8
XFILLER_30_260 VDD VSS / sg13g2_decap_4
XFILLER_30_274 VDD VSS / sg13g2_decap_8
XFILLER_30_281 VDD VSS / sg13g2_decap_8
XFILLER_30_297 VDD VSS / sg13g2_fill_2
XFILLER_30_304 VDD VSS / sg13g2_fill_2
XFILLER_30_323 VDD VSS / sg13g2_decap_4
XFILLER_30_394 VDD VSS / sg13g2_decap_8
XFILLER_30_401 VDD VSS / sg13g2_decap_8
XFILLER_30_408 VDD VSS / sg13g2_decap_8
XFILLER_30_415 VDD VSS / sg13g2_decap_8
XFILLER_30_422 VDD VSS / sg13g2_fill_2
XFILLER_30_455 VDD VSS / sg13g2_fill_2
XFILLER_30_457 VDD VSS / sg13g2_fill_1
XFILLER_30_48 VDD VSS / sg13g2_decap_8
XFILLER_30_490 VDD VSS / sg13g2_fill_2
XFILLER_30_497 VDD VSS / sg13g2_fill_2
XFILLER_30_531 VDD VSS / sg13g2_fill_2
XFILLER_30_55 VDD VSS / sg13g2_decap_8
XFILLER_30_560 VDD VSS / sg13g2_fill_1
XFILLER_30_62 VDD VSS / sg13g2_decap_8
XFILLER_30_645 VDD VSS / sg13g2_fill_2
XFILLER_30_69 VDD VSS / sg13g2_decap_8
XFILLER_30_715 VDD VSS / sg13g2_fill_1
XFILLER_31_0 VDD VSS / sg13g2_decap_4
XFILLER_31_236 VDD VSS / sg13g2_decap_8
XFILLER_31_243 VDD VSS / sg13g2_decap_8
XFILLER_31_250 VDD VSS / sg13g2_decap_4
XFILLER_31_254 VDD VSS / sg13g2_fill_1
XFILLER_31_291 VDD VSS / sg13g2_decap_8
XFILLER_31_298 VDD VSS / sg13g2_decap_8
XFILLER_31_305 VDD VSS / sg13g2_fill_1
XFILLER_31_31 VDD VSS / sg13g2_fill_2
XFILLER_31_313 VDD VSS / sg13g2_decap_8
XFILLER_31_320 VDD VSS / sg13g2_decap_4
XFILLER_31_324 VDD VSS / sg13g2_fill_2
XFILLER_31_33 VDD VSS / sg13g2_fill_1
XFILLER_31_388 VDD VSS / sg13g2_fill_2
XFILLER_31_390 VDD VSS / sg13g2_fill_1
XFILLER_31_404 VDD VSS / sg13g2_decap_4
XFILLER_31_408 VDD VSS / sg13g2_fill_1
XFILLER_31_418 VDD VSS / sg13g2_fill_2
XFILLER_31_42 VDD VSS / sg13g2_decap_8
XFILLER_31_420 VDD VSS / sg13g2_fill_1
XFILLER_31_425 VDD VSS / sg13g2_decap_8
XFILLER_31_432 VDD VSS / sg13g2_fill_2
XFILLER_31_438 VDD VSS / sg13g2_decap_4
XFILLER_31_446 VDD VSS / sg13g2_fill_1
XFILLER_31_451 VDD VSS / sg13g2_fill_2
XFILLER_31_453 VDD VSS / sg13g2_fill_1
XFILLER_31_481 VDD VSS / sg13g2_fill_2
XFILLER_31_483 VDD VSS / sg13g2_fill_1
XFILLER_31_49 VDD VSS / sg13g2_decap_8
XFILLER_31_550 VDD VSS / sg13g2_fill_2
XFILLER_31_56 VDD VSS / sg13g2_decap_8
XFILLER_31_63 VDD VSS / sg13g2_decap_8
XFILLER_31_643 VDD VSS / sg13g2_fill_1
XFILLER_31_714 VDD VSS / sg13g2_fill_2
XFILLER_32_0 VDD VSS / sg13g2_decap_4
XFILLER_32_140 VDD VSS / sg13g2_decap_8
XFILLER_32_147 VDD VSS / sg13g2_fill_1
XFILLER_32_219 VDD VSS / sg13g2_fill_1
XFILLER_32_278 VDD VSS / sg13g2_decap_4
XFILLER_32_314 VDD VSS / sg13g2_fill_1
XFILLER_32_35 VDD VSS / sg13g2_decap_8
XFILLER_32_350 VDD VSS / sg13g2_fill_1
XFILLER_32_378 VDD VSS / sg13g2_fill_1
XFILLER_32_388 VDD VSS / sg13g2_fill_2
XFILLER_32_42 VDD VSS / sg13g2_decap_8
XFILLER_32_448 VDD VSS / sg13g2_decap_8
XFILLER_32_455 VDD VSS / sg13g2_decap_4
XFILLER_32_459 VDD VSS / sg13g2_fill_1
XFILLER_32_49 VDD VSS / sg13g2_decap_8
XFILLER_32_549 VDD VSS / sg13g2_fill_1
XFILLER_32_558 VDD VSS / sg13g2_fill_1
XFILLER_32_56 VDD VSS / sg13g2_decap_8
XFILLER_32_567 VDD VSS / sg13g2_fill_2
XFILLER_32_620 VDD VSS / sg13g2_fill_1
XFILLER_32_715 VDD VSS / sg13g2_fill_1
XFILLER_33_0 VDD VSS / sg13g2_decap_8
XFILLER_33_130 VDD VSS / sg13g2_decap_8
XFILLER_33_137 VDD VSS / sg13g2_decap_8
XFILLER_33_14 VDD VSS / sg13g2_decap_8
XFILLER_33_144 VDD VSS / sg13g2_decap_8
XFILLER_33_151 VDD VSS / sg13g2_decap_4
XFILLER_33_21 VDD VSS / sg13g2_fill_1
XFILLER_33_215 VDD VSS / sg13g2_fill_1
XFILLER_33_237 VDD VSS / sg13g2_fill_1
XFILLER_33_251 VDD VSS / sg13g2_fill_2
XFILLER_33_273 VDD VSS / sg13g2_decap_8
XFILLER_33_280 VDD VSS / sg13g2_fill_2
XFILLER_33_353 VDD VSS / sg13g2_fill_2
XFILLER_33_414 VDD VSS / sg13g2_fill_1
XFILLER_33_469 VDD VSS / sg13g2_fill_1
XFILLER_33_474 VDD VSS / sg13g2_decap_4
XFILLER_33_478 VDD VSS / sg13g2_fill_2
XFILLER_33_489 VDD VSS / sg13g2_decap_8
XFILLER_33_496 VDD VSS / sg13g2_fill_2
XFILLER_33_526 VDD VSS / sg13g2_decap_8
XFILLER_33_538 VDD VSS / sg13g2_decap_8
XFILLER_33_54 VDD VSS / sg13g2_decap_8
XFILLER_33_545 VDD VSS / sg13g2_decap_4
XFILLER_33_549 VDD VSS / sg13g2_fill_2
XFILLER_33_595 VDD VSS / sg13g2_fill_2
XFILLER_33_597 VDD VSS / sg13g2_fill_1
XFILLER_33_61 VDD VSS / sg13g2_decap_8
XFILLER_33_625 VDD VSS / sg13g2_fill_1
XFILLER_33_671 VDD VSS / sg13g2_fill_1
XFILLER_33_68 VDD VSS / sg13g2_fill_2
XFILLER_33_7 VDD VSS / sg13g2_decap_8
XFILLER_33_70 VDD VSS / sg13g2_fill_1
XFILLER_34_0 VDD VSS / sg13g2_decap_4
XFILLER_34_115 VDD VSS / sg13g2_decap_8
XFILLER_34_122 VDD VSS / sg13g2_decap_8
XFILLER_34_129 VDD VSS / sg13g2_decap_8
XFILLER_34_136 VDD VSS / sg13g2_decap_8
XFILLER_34_143 VDD VSS / sg13g2_decap_8
XFILLER_34_150 VDD VSS / sg13g2_fill_2
XFILLER_34_152 VDD VSS / sg13g2_fill_1
XFILLER_34_211 VDD VSS / sg13g2_decap_4
XFILLER_34_215 VDD VSS / sg13g2_fill_1
XFILLER_34_274 VDD VSS / sg13g2_decap_8
XFILLER_34_281 VDD VSS / sg13g2_fill_1
XFILLER_34_336 VDD VSS / sg13g2_fill_1
XFILLER_34_345 VDD VSS / sg13g2_decap_8
XFILLER_34_352 VDD VSS / sg13g2_decap_8
XFILLER_34_359 VDD VSS / sg13g2_decap_8
XFILLER_34_366 VDD VSS / sg13g2_decap_8
XFILLER_34_373 VDD VSS / sg13g2_decap_4
XFILLER_34_377 VDD VSS / sg13g2_fill_1
XFILLER_34_40 VDD VSS / sg13g2_decap_8
XFILLER_34_418 VDD VSS / sg13g2_fill_2
XFILLER_34_446 VDD VSS / sg13g2_decap_4
XFILLER_34_454 VDD VSS / sg13g2_decap_8
XFILLER_34_469 VDD VSS / sg13g2_decap_8
XFILLER_34_47 VDD VSS / sg13g2_decap_8
XFILLER_34_476 VDD VSS / sg13g2_decap_8
XFILLER_34_483 VDD VSS / sg13g2_decap_8
XFILLER_34_490 VDD VSS / sg13g2_decap_8
XFILLER_34_497 VDD VSS / sg13g2_decap_8
XFILLER_34_508 VDD VSS / sg13g2_decap_8
XFILLER_34_515 VDD VSS / sg13g2_decap_8
XFILLER_34_522 VDD VSS / sg13g2_decap_8
XFILLER_34_529 VDD VSS / sg13g2_decap_8
XFILLER_34_536 VDD VSS / sg13g2_decap_4
XFILLER_34_54 VDD VSS / sg13g2_decap_8
XFILLER_34_540 VDD VSS / sg13g2_fill_1
XFILLER_34_61 VDD VSS / sg13g2_decap_8
XFILLER_34_68 VDD VSS / sg13g2_decap_8
XFILLER_34_710 VDD VSS / sg13g2_fill_1
XFILLER_34_75 VDD VSS / sg13g2_decap_4
XFILLER_34_79 VDD VSS / sg13g2_fill_2
XFILLER_35_0 VDD VSS / sg13g2_decap_4
XFILLER_35_120 VDD VSS / sg13g2_decap_8
XFILLER_35_127 VDD VSS / sg13g2_decap_8
XFILLER_35_134 VDD VSS / sg13g2_fill_2
XFILLER_35_136 VDD VSS / sg13g2_fill_1
XFILLER_35_284 VDD VSS / sg13g2_decap_8
XFILLER_35_291 VDD VSS / sg13g2_decap_8
XFILLER_35_298 VDD VSS / sg13g2_decap_8
XFILLER_35_305 VDD VSS / sg13g2_fill_2
XFILLER_35_307 VDD VSS / sg13g2_fill_1
XFILLER_35_312 VDD VSS / sg13g2_fill_2
XFILLER_35_321 VDD VSS / sg13g2_decap_4
XFILLER_35_325 VDD VSS / sg13g2_fill_1
XFILLER_35_330 VDD VSS / sg13g2_decap_8
XFILLER_35_346 VDD VSS / sg13g2_decap_8
XFILLER_35_353 VDD VSS / sg13g2_decap_8
XFILLER_35_360 VDD VSS / sg13g2_decap_8
XFILLER_35_367 VDD VSS / sg13g2_decap_8
XFILLER_35_374 VDD VSS / sg13g2_decap_8
XFILLER_35_381 VDD VSS / sg13g2_decap_4
XFILLER_35_385 VDD VSS / sg13g2_fill_1
XFILLER_35_390 VDD VSS / sg13g2_fill_1
XFILLER_35_404 VDD VSS / sg13g2_decap_8
XFILLER_35_411 VDD VSS / sg13g2_fill_1
XFILLER_35_443 VDD VSS / sg13g2_fill_2
XFILLER_35_477 VDD VSS / sg13g2_decap_8
XFILLER_35_484 VDD VSS / sg13g2_decap_8
XFILLER_35_491 VDD VSS / sg13g2_decap_8
XFILLER_35_498 VDD VSS / sg13g2_decap_4
XFILLER_35_502 VDD VSS / sg13g2_fill_2
XFILLER_35_508 VDD VSS / sg13g2_decap_4
XFILLER_35_525 VDD VSS / sg13g2_decap_8
XFILLER_35_532 VDD VSS / sg13g2_decap_8
XFILLER_35_539 VDD VSS / sg13g2_decap_8
XFILLER_35_546 VDD VSS / sg13g2_decap_8
XFILLER_35_553 VDD VSS / sg13g2_decap_4
XFILLER_35_557 VDD VSS / sg13g2_fill_1
XFILLER_35_571 VDD VSS / sg13g2_fill_2
XFILLER_35_573 VDD VSS / sg13g2_fill_1
XFILLER_35_609 VDD VSS / sg13g2_fill_2
XFILLER_35_66 VDD VSS / sg13g2_decap_8
XFILLER_35_682 VDD VSS / sg13g2_fill_1
XFILLER_35_715 VDD VSS / sg13g2_fill_1
XFILLER_35_73 VDD VSS / sg13g2_decap_8
XFILLER_36_102 VDD VSS / sg13g2_fill_2
XFILLER_36_221 VDD VSS / sg13g2_decap_4
XFILLER_36_225 VDD VSS / sg13g2_fill_2
XFILLER_36_258 VDD VSS / sg13g2_decap_4
XFILLER_36_262 VDD VSS / sg13g2_fill_1
XFILLER_36_294 VDD VSS / sg13g2_decap_8
XFILLER_36_301 VDD VSS / sg13g2_decap_8
XFILLER_36_308 VDD VSS / sg13g2_decap_8
XFILLER_36_315 VDD VSS / sg13g2_decap_8
XFILLER_36_322 VDD VSS / sg13g2_decap_4
XFILLER_36_353 VDD VSS / sg13g2_decap_8
XFILLER_36_36 VDD VSS / sg13g2_fill_2
XFILLER_36_360 VDD VSS / sg13g2_decap_4
XFILLER_36_364 VDD VSS / sg13g2_fill_1
XFILLER_36_392 VDD VSS / sg13g2_decap_8
XFILLER_36_399 VDD VSS / sg13g2_decap_8
XFILLER_36_406 VDD VSS / sg13g2_decap_8
XFILLER_36_413 VDD VSS / sg13g2_decap_4
XFILLER_36_417 VDD VSS / sg13g2_fill_2
XFILLER_36_424 VDD VSS / sg13g2_fill_2
XFILLER_36_426 VDD VSS / sg13g2_fill_1
XFILLER_36_431 VDD VSS / sg13g2_fill_2
XFILLER_36_433 VDD VSS / sg13g2_fill_1
XFILLER_36_471 VDD VSS / sg13g2_fill_2
XFILLER_36_534 VDD VSS / sg13g2_fill_1
XFILLER_36_54 VDD VSS / sg13g2_decap_8
XFILLER_36_545 VDD VSS / sg13g2_fill_2
XFILLER_36_61 VDD VSS / sg13g2_decap_8
XFILLER_36_68 VDD VSS / sg13g2_fill_2
XFILLER_37_0 VDD VSS / sg13g2_decap_4
XFILLER_37_108 VDD VSS / sg13g2_fill_2
XFILLER_37_137 VDD VSS / sg13g2_fill_2
XFILLER_37_204 VDD VSS / sg13g2_decap_8
XFILLER_37_211 VDD VSS / sg13g2_decap_8
XFILLER_37_218 VDD VSS / sg13g2_decap_8
XFILLER_37_225 VDD VSS / sg13g2_decap_8
XFILLER_37_232 VDD VSS / sg13g2_fill_2
XFILLER_37_234 VDD VSS / sg13g2_fill_1
XFILLER_37_239 VDD VSS / sg13g2_decap_8
XFILLER_37_246 VDD VSS / sg13g2_decap_4
XFILLER_37_250 VDD VSS / sg13g2_fill_1
XFILLER_37_256 VDD VSS / sg13g2_fill_1
XFILLER_37_298 VDD VSS / sg13g2_decap_8
XFILLER_37_305 VDD VSS / sg13g2_fill_2
XFILLER_37_312 VDD VSS / sg13g2_fill_2
XFILLER_37_318 VDD VSS / sg13g2_decap_8
XFILLER_37_325 VDD VSS / sg13g2_decap_8
XFILLER_37_332 VDD VSS / sg13g2_decap_8
XFILLER_37_339 VDD VSS / sg13g2_decap_8
XFILLER_37_346 VDD VSS / sg13g2_decap_4
XFILLER_37_350 VDD VSS / sg13g2_fill_2
XFILLER_37_38 VDD VSS / sg13g2_fill_2
XFILLER_37_401 VDD VSS / sg13g2_decap_8
XFILLER_37_408 VDD VSS / sg13g2_fill_1
XFILLER_37_44 VDD VSS / sg13g2_decap_8
XFILLER_37_441 VDD VSS / sg13g2_fill_1
XFILLER_37_473 VDD VSS / sg13g2_decap_4
XFILLER_37_477 VDD VSS / sg13g2_fill_1
XFILLER_37_490 VDD VSS / sg13g2_fill_1
XFILLER_37_51 VDD VSS / sg13g2_decap_8
XFILLER_37_557 VDD VSS / sg13g2_decap_8
XFILLER_37_564 VDD VSS / sg13g2_decap_4
XFILLER_37_568 VDD VSS / sg13g2_fill_2
XFILLER_37_58 VDD VSS / sg13g2_decap_8
XFILLER_37_584 VDD VSS / sg13g2_fill_2
XFILLER_37_603 VDD VSS / sg13g2_fill_1
XFILLER_37_65 VDD VSS / sg13g2_decap_8
XFILLER_37_663 VDD VSS / sg13g2_fill_1
XFILLER_37_72 VDD VSS / sg13g2_decap_8
XFILLER_37_79 VDD VSS / sg13g2_decap_8
XFILLER_37_86 VDD VSS / sg13g2_decap_8
XFILLER_37_97 VDD VSS / sg13g2_fill_2
XFILLER_38_0 VDD VSS / sg13g2_decap_4
XFILLER_38_118 VDD VSS / sg13g2_decap_8
XFILLER_38_125 VDD VSS / sg13g2_fill_1
XFILLER_38_153 VDD VSS / sg13g2_fill_1
XFILLER_38_207 VDD VSS / sg13g2_fill_2
XFILLER_38_213 VDD VSS / sg13g2_decap_8
XFILLER_38_220 VDD VSS / sg13g2_decap_8
XFILLER_38_227 VDD VSS / sg13g2_decap_8
XFILLER_38_234 VDD VSS / sg13g2_decap_8
XFILLER_38_241 VDD VSS / sg13g2_decap_4
XFILLER_38_245 VDD VSS / sg13g2_fill_2
XFILLER_38_255 VDD VSS / sg13g2_fill_1
XFILLER_38_259 VDD VSS / sg13g2_fill_1
XFILLER_38_270 VDD VSS / sg13g2_fill_2
XFILLER_38_272 VDD VSS / sg13g2_fill_1
XFILLER_38_290 VDD VSS / sg13g2_fill_2
XFILLER_38_292 VDD VSS / sg13g2_fill_1
XFILLER_38_324 VDD VSS / sg13g2_decap_8
XFILLER_38_331 VDD VSS / sg13g2_decap_8
XFILLER_38_338 VDD VSS / sg13g2_decap_8
XFILLER_38_345 VDD VSS / sg13g2_fill_2
XFILLER_38_347 VDD VSS / sg13g2_fill_1
XFILLER_38_366 VDD VSS / sg13g2_fill_2
XFILLER_38_377 VDD VSS / sg13g2_decap_4
XFILLER_38_386 VDD VSS / sg13g2_fill_2
XFILLER_38_388 VDD VSS / sg13g2_fill_1
XFILLER_38_425 VDD VSS / sg13g2_decap_4
XFILLER_38_437 VDD VSS / sg13g2_decap_8
XFILLER_38_44 VDD VSS / sg13g2_decap_8
XFILLER_38_444 VDD VSS / sg13g2_decap_8
XFILLER_38_451 VDD VSS / sg13g2_decap_4
XFILLER_38_455 VDD VSS / sg13g2_fill_2
XFILLER_38_497 VDD VSS / sg13g2_fill_2
XFILLER_38_51 VDD VSS / sg13g2_decap_8
XFILLER_38_553 VDD VSS / sg13g2_decap_8
XFILLER_38_560 VDD VSS / sg13g2_decap_8
XFILLER_38_58 VDD VSS / sg13g2_decap_8
XFILLER_38_593 VDD VSS / sg13g2_fill_2
XFILLER_38_595 VDD VSS / sg13g2_fill_1
XFILLER_38_65 VDD VSS / sg13g2_decap_8
XFILLER_38_72 VDD VSS / sg13g2_decap_8
XFILLER_38_79 VDD VSS / sg13g2_decap_8
XFILLER_38_86 VDD VSS / sg13g2_fill_2
XFILLER_39_0 VDD VSS / sg13g2_decap_8
XFILLER_39_120 VDD VSS / sg13g2_fill_2
XFILLER_39_122 VDD VSS / sg13g2_fill_1
XFILLER_39_14 VDD VSS / sg13g2_decap_4
XFILLER_39_18 VDD VSS / sg13g2_fill_2
XFILLER_39_198 VDD VSS / sg13g2_fill_2
XFILLER_39_205 VDD VSS / sg13g2_fill_1
XFILLER_39_217 VDD VSS / sg13g2_decap_8
XFILLER_39_251 VDD VSS / sg13g2_decap_8
XFILLER_39_258 VDD VSS / sg13g2_decap_8
XFILLER_39_265 VDD VSS / sg13g2_decap_8
XFILLER_39_272 VDD VSS / sg13g2_decap_4
XFILLER_39_276 VDD VSS / sg13g2_fill_1
XFILLER_39_365 VDD VSS / sg13g2_fill_2
XFILLER_39_380 VDD VSS / sg13g2_decap_8
XFILLER_39_387 VDD VSS / sg13g2_decap_4
XFILLER_39_395 VDD VSS / sg13g2_decap_8
XFILLER_39_402 VDD VSS / sg13g2_decap_8
XFILLER_39_409 VDD VSS / sg13g2_fill_2
XFILLER_39_411 VDD VSS / sg13g2_fill_1
XFILLER_39_422 VDD VSS / sg13g2_decap_4
XFILLER_39_426 VDD VSS / sg13g2_fill_2
XFILLER_39_435 VDD VSS / sg13g2_decap_8
XFILLER_39_442 VDD VSS / sg13g2_decap_4
XFILLER_39_452 VDD VSS / sg13g2_fill_2
XFILLER_39_458 VDD VSS / sg13g2_decap_8
XFILLER_39_465 VDD VSS / sg13g2_fill_2
XFILLER_39_47 VDD VSS / sg13g2_decap_8
XFILLER_39_477 VDD VSS / sg13g2_decap_4
XFILLER_39_486 VDD VSS / sg13g2_fill_1
XFILLER_39_522 VDD VSS / sg13g2_fill_1
XFILLER_39_54 VDD VSS / sg13g2_decap_8
XFILLER_39_561 VDD VSS / sg13g2_decap_4
XFILLER_39_565 VDD VSS / sg13g2_fill_2
XFILLER_39_591 VDD VSS / sg13g2_decap_8
XFILLER_39_598 VDD VSS / sg13g2_fill_2
XFILLER_39_61 VDD VSS / sg13g2_decap_8
XFILLER_39_621 VDD VSS / sg13g2_fill_1
XFILLER_39_667 VDD VSS / sg13g2_fill_1
XFILLER_39_68 VDD VSS / sg13g2_decap_8
XFILLER_39_7 VDD VSS / sg13g2_decap_8
XFILLER_3_0 VDD VSS / sg13g2_decap_4
XFILLER_3_133 VDD VSS / sg13g2_fill_2
XFILLER_3_148 VDD VSS / sg13g2_decap_4
XFILLER_3_152 VDD VSS / sg13g2_fill_2
XFILLER_3_158 VDD VSS / sg13g2_fill_1
XFILLER_3_164 VDD VSS / sg13g2_decap_8
XFILLER_3_171 VDD VSS / sg13g2_fill_1
XFILLER_3_199 VDD VSS / sg13g2_decap_4
XFILLER_3_203 VDD VSS / sg13g2_fill_2
XFILLER_3_232 VDD VSS / sg13g2_decap_4
XFILLER_3_236 VDD VSS / sg13g2_fill_1
XFILLER_3_264 VDD VSS / sg13g2_fill_2
XFILLER_3_266 VDD VSS / sg13g2_fill_1
XFILLER_3_271 VDD VSS / sg13g2_fill_1
XFILLER_3_31 VDD VSS / sg13g2_decap_4
XFILLER_3_311 VDD VSS / sg13g2_fill_2
XFILLER_3_313 VDD VSS / sg13g2_fill_1
XFILLER_3_428 VDD VSS / sg13g2_fill_2
XFILLER_3_551 VDD VSS / sg13g2_fill_2
XFILLER_3_553 VDD VSS / sg13g2_fill_1
XFILLER_3_581 VDD VSS / sg13g2_fill_1
XFILLER_3_62 VDD VSS / sg13g2_decap_4
XFILLER_3_699 VDD VSS / sg13g2_fill_1
XFILLER_3_713 VDD VSS / sg13g2_fill_2
XFILLER_3_715 VDD VSS / sg13g2_fill_1
XFILLER_40_0 VDD VSS / sg13g2_decap_4
XFILLER_40_131 VDD VSS / sg13g2_decap_8
XFILLER_40_138 VDD VSS / sg13g2_decap_4
XFILLER_40_142 VDD VSS / sg13g2_fill_2
XFILLER_40_147 VDD VSS / sg13g2_decap_4
XFILLER_40_185 VDD VSS / sg13g2_fill_2
XFILLER_40_214 VDD VSS / sg13g2_decap_8
XFILLER_40_221 VDD VSS / sg13g2_decap_8
XFILLER_40_228 VDD VSS / sg13g2_decap_4
XFILLER_40_232 VDD VSS / sg13g2_fill_1
XFILLER_40_260 VDD VSS / sg13g2_fill_2
XFILLER_40_262 VDD VSS / sg13g2_fill_1
XFILLER_40_267 VDD VSS / sg13g2_decap_4
XFILLER_40_276 VDD VSS / sg13g2_fill_1
XFILLER_40_281 VDD VSS / sg13g2_decap_8
XFILLER_40_288 VDD VSS / sg13g2_decap_4
XFILLER_40_292 VDD VSS / sg13g2_fill_1
XFILLER_40_297 VDD VSS / sg13g2_decap_4
XFILLER_40_301 VDD VSS / sg13g2_fill_2
XFILLER_40_339 VDD VSS / sg13g2_decap_4
XFILLER_40_391 VDD VSS / sg13g2_decap_4
XFILLER_40_415 VDD VSS / sg13g2_fill_1
XFILLER_40_437 VDD VSS / sg13g2_decap_8
XFILLER_40_444 VDD VSS / sg13g2_decap_8
XFILLER_40_451 VDD VSS / sg13g2_fill_2
XFILLER_40_453 VDD VSS / sg13g2_fill_1
XFILLER_40_467 VDD VSS / sg13g2_decap_8
XFILLER_40_474 VDD VSS / sg13g2_decap_8
XFILLER_40_481 VDD VSS / sg13g2_decap_8
XFILLER_40_488 VDD VSS / sg13g2_decap_4
XFILLER_40_49 VDD VSS / sg13g2_decap_8
XFILLER_40_492 VDD VSS / sg13g2_fill_1
XFILLER_40_520 VDD VSS / sg13g2_fill_2
XFILLER_40_56 VDD VSS / sg13g2_decap_4
XFILLER_40_567 VDD VSS / sg13g2_fill_1
XFILLER_40_605 VDD VSS / sg13g2_fill_2
XFILLER_40_87 VDD VSS / sg13g2_fill_1
XFILLER_41_0 VDD VSS / sg13g2_decap_4
XFILLER_41_108 VDD VSS / sg13g2_decap_8
XFILLER_41_115 VDD VSS / sg13g2_fill_1
XFILLER_41_132 VDD VSS / sg13g2_decap_8
XFILLER_41_139 VDD VSS / sg13g2_decap_8
XFILLER_41_146 VDD VSS / sg13g2_decap_8
XFILLER_41_192 VDD VSS / sg13g2_fill_1
XFILLER_41_220 VDD VSS / sg13g2_decap_8
XFILLER_41_227 VDD VSS / sg13g2_fill_2
XFILLER_41_246 VDD VSS / sg13g2_decap_8
XFILLER_41_253 VDD VSS / sg13g2_fill_2
XFILLER_41_289 VDD VSS / sg13g2_decap_8
XFILLER_41_296 VDD VSS / sg13g2_fill_2
XFILLER_41_298 VDD VSS / sg13g2_fill_1
XFILLER_41_304 VDD VSS / sg13g2_decap_4
XFILLER_41_308 VDD VSS / sg13g2_fill_2
XFILLER_41_313 VDD VSS / sg13g2_fill_1
XFILLER_41_323 VDD VSS / sg13g2_decap_8
XFILLER_41_330 VDD VSS / sg13g2_decap_8
XFILLER_41_337 VDD VSS / sg13g2_fill_1
XFILLER_41_342 VDD VSS / sg13g2_decap_8
XFILLER_41_380 VDD VSS / sg13g2_decap_8
XFILLER_41_387 VDD VSS / sg13g2_fill_1
XFILLER_41_391 VDD VSS / sg13g2_fill_1
XFILLER_41_478 VDD VSS / sg13g2_decap_8
XFILLER_41_518 VDD VSS / sg13g2_decap_8
XFILLER_41_525 VDD VSS / sg13g2_decap_8
XFILLER_41_53 VDD VSS / sg13g2_decap_8
XFILLER_41_532 VDD VSS / sg13g2_decap_8
XFILLER_41_539 VDD VSS / sg13g2_decap_8
XFILLER_41_546 VDD VSS / sg13g2_decap_4
XFILLER_41_555 VDD VSS / sg13g2_decap_8
XFILLER_41_562 VDD VSS / sg13g2_fill_1
XFILLER_41_60 VDD VSS / sg13g2_decap_4
XFILLER_41_628 VDD VSS / sg13g2_fill_2
XFILLER_41_64 VDD VSS / sg13g2_fill_1
XFILLER_41_714 VDD VSS / sg13g2_fill_2
XFILLER_42_0 VDD VSS / sg13g2_decap_8
XFILLER_42_14 VDD VSS / sg13g2_fill_2
XFILLER_42_140 VDD VSS / sg13g2_decap_8
XFILLER_42_147 VDD VSS / sg13g2_decap_8
XFILLER_42_154 VDD VSS / sg13g2_decap_8
XFILLER_42_161 VDD VSS / sg13g2_fill_2
XFILLER_42_198 VDD VSS / sg13g2_decap_8
XFILLER_42_205 VDD VSS / sg13g2_decap_4
XFILLER_42_244 VDD VSS / sg13g2_decap_8
XFILLER_42_251 VDD VSS / sg13g2_fill_2
XFILLER_42_273 VDD VSS / sg13g2_fill_1
XFILLER_42_286 VDD VSS / sg13g2_fill_2
XFILLER_42_319 VDD VSS / sg13g2_fill_1
XFILLER_42_324 VDD VSS / sg13g2_decap_4
XFILLER_42_328 VDD VSS / sg13g2_fill_2
XFILLER_42_340 VDD VSS / sg13g2_fill_1
XFILLER_42_349 VDD VSS / sg13g2_decap_8
XFILLER_42_356 VDD VSS / sg13g2_decap_8
XFILLER_42_363 VDD VSS / sg13g2_decap_4
XFILLER_42_375 VDD VSS / sg13g2_decap_4
XFILLER_42_379 VDD VSS / sg13g2_fill_1
XFILLER_42_452 VDD VSS / sg13g2_fill_2
XFILLER_42_458 VDD VSS / sg13g2_decap_8
XFILLER_42_465 VDD VSS / sg13g2_decap_8
XFILLER_42_472 VDD VSS / sg13g2_decap_8
XFILLER_42_479 VDD VSS / sg13g2_decap_4
XFILLER_42_50 VDD VSS / sg13g2_decap_8
XFILLER_42_521 VDD VSS / sg13g2_decap_8
XFILLER_42_528 VDD VSS / sg13g2_decap_8
XFILLER_42_535 VDD VSS / sg13g2_decap_8
XFILLER_42_542 VDD VSS / sg13g2_decap_8
XFILLER_42_57 VDD VSS / sg13g2_decap_8
XFILLER_42_576 VDD VSS / sg13g2_fill_2
XFILLER_42_582 VDD VSS / sg13g2_fill_1
XFILLER_42_596 VDD VSS / sg13g2_decap_8
XFILLER_42_603 VDD VSS / sg13g2_fill_1
XFILLER_42_608 VDD VSS / sg13g2_decap_8
XFILLER_42_615 VDD VSS / sg13g2_fill_2
XFILLER_42_617 VDD VSS / sg13g2_fill_1
XFILLER_42_64 VDD VSS / sg13g2_decap_4
XFILLER_42_659 VDD VSS / sg13g2_fill_1
XFILLER_42_68 VDD VSS / sg13g2_fill_2
XFILLER_42_7 VDD VSS / sg13g2_decap_8
XFILLER_42_76 VDD VSS / sg13g2_fill_1
XFILLER_42_82 VDD VSS / sg13g2_decap_4
XFILLER_43_0 VDD VSS / sg13g2_decap_4
XFILLER_43_102 VDD VSS / sg13g2_fill_1
XFILLER_43_130 VDD VSS / sg13g2_decap_8
XFILLER_43_137 VDD VSS / sg13g2_decap_8
XFILLER_43_144 VDD VSS / sg13g2_decap_8
XFILLER_43_151 VDD VSS / sg13g2_decap_4
XFILLER_43_155 VDD VSS / sg13g2_fill_2
XFILLER_43_233 VDD VSS / sg13g2_decap_8
XFILLER_43_240 VDD VSS / sg13g2_decap_8
XFILLER_43_247 VDD VSS / sg13g2_decap_8
XFILLER_43_31 VDD VSS / sg13g2_fill_1
XFILLER_43_334 VDD VSS / sg13g2_fill_2
XFILLER_43_336 VDD VSS / sg13g2_fill_1
XFILLER_43_347 VDD VSS / sg13g2_fill_2
XFILLER_43_349 VDD VSS / sg13g2_fill_1
XFILLER_43_36 VDD VSS / sg13g2_decap_8
XFILLER_43_404 VDD VSS / sg13g2_fill_1
XFILLER_43_412 VDD VSS / sg13g2_fill_2
XFILLER_43_43 VDD VSS / sg13g2_decap_8
XFILLER_43_441 VDD VSS / sg13g2_fill_1
XFILLER_43_462 VDD VSS / sg13g2_decap_4
XFILLER_43_471 VDD VSS / sg13g2_decap_8
XFILLER_43_478 VDD VSS / sg13g2_fill_2
XFILLER_43_50 VDD VSS / sg13g2_decap_8
XFILLER_43_525 VDD VSS / sg13g2_fill_2
XFILLER_43_532 VDD VSS / sg13g2_decap_4
XFILLER_43_536 VDD VSS / sg13g2_fill_1
XFILLER_43_544 VDD VSS / sg13g2_decap_8
XFILLER_43_551 VDD VSS / sg13g2_decap_4
XFILLER_43_559 VDD VSS / sg13g2_decap_8
XFILLER_43_566 VDD VSS / sg13g2_decap_8
XFILLER_43_57 VDD VSS / sg13g2_decap_4
XFILLER_43_573 VDD VSS / sg13g2_decap_8
XFILLER_43_580 VDD VSS / sg13g2_decap_8
XFILLER_43_587 VDD VSS / sg13g2_decap_8
XFILLER_43_594 VDD VSS / sg13g2_decap_8
XFILLER_43_601 VDD VSS / sg13g2_decap_8
XFILLER_43_608 VDD VSS / sg13g2_decap_8
XFILLER_43_61 VDD VSS / sg13g2_fill_2
XFILLER_43_615 VDD VSS / sg13g2_decap_8
XFILLER_43_622 VDD VSS / sg13g2_decap_4
XFILLER_43_647 VDD VSS / sg13g2_fill_2
XFILLER_43_653 VDD VSS / sg13g2_fill_2
XFILLER_43_87 VDD VSS / sg13g2_fill_2
XFILLER_43_89 VDD VSS / sg13g2_fill_1
XFILLER_43_98 VDD VSS / sg13g2_decap_4
XFILLER_44_0 VDD VSS / sg13g2_decap_4
XFILLER_44_115 VDD VSS / sg13g2_fill_2
XFILLER_44_130 VDD VSS / sg13g2_decap_8
XFILLER_44_170 VDD VSS / sg13g2_fill_1
XFILLER_44_202 VDD VSS / sg13g2_decap_8
XFILLER_44_213 VDD VSS / sg13g2_fill_2
XFILLER_44_220 VDD VSS / sg13g2_decap_8
XFILLER_44_227 VDD VSS / sg13g2_decap_8
XFILLER_44_234 VDD VSS / sg13g2_decap_8
XFILLER_44_241 VDD VSS / sg13g2_fill_1
XFILLER_44_269 VDD VSS / sg13g2_fill_1
XFILLER_44_297 VDD VSS / sg13g2_fill_2
XFILLER_44_299 VDD VSS / sg13g2_fill_1
XFILLER_44_31 VDD VSS / sg13g2_decap_8
XFILLER_44_358 VDD VSS / sg13g2_fill_1
XFILLER_44_38 VDD VSS / sg13g2_decap_8
XFILLER_44_428 VDD VSS / sg13g2_fill_2
XFILLER_44_45 VDD VSS / sg13g2_fill_1
XFILLER_44_469 VDD VSS / sg13g2_fill_2
XFILLER_44_567 VDD VSS / sg13g2_decap_8
XFILLER_44_574 VDD VSS / sg13g2_decap_8
XFILLER_44_581 VDD VSS / sg13g2_decap_8
XFILLER_44_588 VDD VSS / sg13g2_decap_8
XFILLER_44_595 VDD VSS / sg13g2_decap_8
XFILLER_44_602 VDD VSS / sg13g2_decap_8
XFILLER_44_609 VDD VSS / sg13g2_fill_1
XFILLER_44_685 VDD VSS / sg13g2_fill_2
XFILLER_44_714 VDD VSS / sg13g2_fill_2
XFILLER_44_78 VDD VSS / sg13g2_decap_8
XFILLER_44_85 VDD VSS / sg13g2_fill_2
XFILLER_44_87 VDD VSS / sg13g2_fill_1
XFILLER_45_0 VDD VSS / sg13g2_decap_8
XFILLER_45_115 VDD VSS / sg13g2_decap_4
XFILLER_45_123 VDD VSS / sg13g2_fill_2
XFILLER_45_133 VDD VSS / sg13g2_decap_8
XFILLER_45_14 VDD VSS / sg13g2_decap_4
XFILLER_45_140 VDD VSS / sg13g2_decap_8
XFILLER_45_147 VDD VSS / sg13g2_decap_8
XFILLER_45_154 VDD VSS / sg13g2_fill_2
XFILLER_45_156 VDD VSS / sg13g2_fill_1
XFILLER_45_18 VDD VSS / sg13g2_fill_1
XFILLER_45_208 VDD VSS / sg13g2_fill_2
XFILLER_45_210 VDD VSS / sg13g2_fill_1
XFILLER_45_223 VDD VSS / sg13g2_decap_8
XFILLER_45_23 VDD VSS / sg13g2_fill_2
XFILLER_45_230 VDD VSS / sg13g2_decap_8
XFILLER_45_25 VDD VSS / sg13g2_fill_1
XFILLER_45_273 VDD VSS / sg13g2_decap_8
XFILLER_45_280 VDD VSS / sg13g2_decap_4
XFILLER_45_284 VDD VSS / sg13g2_fill_1
XFILLER_45_30 VDD VSS / sg13g2_decap_8
XFILLER_45_37 VDD VSS / sg13g2_decap_8
XFILLER_45_44 VDD VSS / sg13g2_decap_4
XFILLER_45_479 VDD VSS / sg13g2_decap_4
XFILLER_45_483 VDD VSS / sg13g2_fill_1
XFILLER_45_511 VDD VSS / sg13g2_fill_2
XFILLER_45_52 VDD VSS / sg13g2_decap_8
XFILLER_45_523 VDD VSS / sg13g2_decap_8
XFILLER_45_576 VDD VSS / sg13g2_decap_8
XFILLER_45_583 VDD VSS / sg13g2_decap_4
XFILLER_45_587 VDD VSS / sg13g2_fill_1
XFILLER_45_59 VDD VSS / sg13g2_decap_8
XFILLER_45_592 VDD VSS / sg13g2_fill_1
XFILLER_45_620 VDD VSS / sg13g2_fill_2
XFILLER_45_622 VDD VSS / sg13g2_fill_1
XFILLER_45_66 VDD VSS / sg13g2_decap_8
XFILLER_45_7 VDD VSS / sg13g2_decap_8
XFILLER_45_73 VDD VSS / sg13g2_decap_8
XFILLER_45_80 VDD VSS / sg13g2_decap_8
XFILLER_45_87 VDD VSS / sg13g2_fill_1
XFILLER_46_0 VDD VSS / sg13g2_decap_8
XFILLER_46_133 VDD VSS / sg13g2_decap_8
XFILLER_46_14 VDD VSS / sg13g2_decap_4
XFILLER_46_140 VDD VSS / sg13g2_decap_8
XFILLER_46_147 VDD VSS / sg13g2_decap_8
XFILLER_46_154 VDD VSS / sg13g2_decap_8
XFILLER_46_161 VDD VSS / sg13g2_fill_2
XFILLER_46_163 VDD VSS / sg13g2_fill_1
XFILLER_46_168 VDD VSS / sg13g2_fill_1
XFILLER_46_18 VDD VSS / sg13g2_fill_2
XFILLER_46_223 VDD VSS / sg13g2_decap_8
XFILLER_46_230 VDD VSS / sg13g2_decap_8
XFILLER_46_237 VDD VSS / sg13g2_decap_8
XFILLER_46_263 VDD VSS / sg13g2_decap_8
XFILLER_46_270 VDD VSS / sg13g2_decap_4
XFILLER_46_274 VDD VSS / sg13g2_fill_1
XFILLER_46_306 VDD VSS / sg13g2_fill_2
XFILLER_46_335 VDD VSS / sg13g2_fill_1
XFILLER_46_35 VDD VSS / sg13g2_decap_4
XFILLER_46_362 VDD VSS / sg13g2_fill_2
XFILLER_46_39 VDD VSS / sg13g2_fill_2
XFILLER_46_394 VDD VSS / sg13g2_decap_4
XFILLER_46_398 VDD VSS / sg13g2_fill_2
XFILLER_46_445 VDD VSS / sg13g2_decap_4
XFILLER_46_449 VDD VSS / sg13g2_fill_2
XFILLER_46_459 VDD VSS / sg13g2_decap_8
XFILLER_46_466 VDD VSS / sg13g2_decap_4
XFILLER_46_474 VDD VSS / sg13g2_decap_8
XFILLER_46_481 VDD VSS / sg13g2_decap_4
XFILLER_46_485 VDD VSS / sg13g2_fill_1
XFILLER_46_506 VDD VSS / sg13g2_decap_4
XFILLER_46_530 VDD VSS / sg13g2_decap_8
XFILLER_46_537 VDD VSS / sg13g2_decap_4
XFILLER_46_546 VDD VSS / sg13g2_fill_2
XFILLER_46_57 VDD VSS / sg13g2_decap_8
XFILLER_46_582 VDD VSS / sg13g2_fill_2
XFILLER_46_64 VDD VSS / sg13g2_decap_8
XFILLER_46_652 VDD VSS / sg13g2_fill_1
XFILLER_46_674 VDD VSS / sg13g2_fill_1
XFILLER_46_684 VDD VSS / sg13g2_fill_2
XFILLER_46_686 VDD VSS / sg13g2_fill_1
XFILLER_46_7 VDD VSS / sg13g2_decap_8
XFILLER_46_71 VDD VSS / sg13g2_decap_8
XFILLER_46_714 VDD VSS / sg13g2_fill_2
XFILLER_46_78 VDD VSS / sg13g2_fill_1
XFILLER_47_0 VDD VSS / sg13g2_decap_4
XFILLER_47_120 VDD VSS / sg13g2_decap_8
XFILLER_47_127 VDD VSS / sg13g2_decap_8
XFILLER_47_134 VDD VSS / sg13g2_decap_8
XFILLER_47_141 VDD VSS / sg13g2_decap_8
XFILLER_47_148 VDD VSS / sg13g2_decap_4
XFILLER_47_152 VDD VSS / sg13g2_fill_2
XFILLER_47_167 VDD VSS / sg13g2_decap_8
XFILLER_47_174 VDD VSS / sg13g2_decap_4
XFILLER_47_182 VDD VSS / sg13g2_decap_4
XFILLER_47_213 VDD VSS / sg13g2_decap_8
XFILLER_47_220 VDD VSS / sg13g2_decap_8
XFILLER_47_227 VDD VSS / sg13g2_fill_1
XFILLER_47_255 VDD VSS / sg13g2_decap_8
XFILLER_47_262 VDD VSS / sg13g2_decap_4
XFILLER_47_31 VDD VSS / sg13g2_decap_8
XFILLER_47_319 VDD VSS / sg13g2_fill_1
XFILLER_47_38 VDD VSS / sg13g2_decap_4
XFILLER_47_383 VDD VSS / sg13g2_decap_8
XFILLER_47_390 VDD VSS / sg13g2_decap_8
XFILLER_47_397 VDD VSS / sg13g2_fill_2
XFILLER_47_399 VDD VSS / sg13g2_fill_1
XFILLER_47_42 VDD VSS / sg13g2_fill_2
XFILLER_47_432 VDD VSS / sg13g2_decap_8
XFILLER_47_439 VDD VSS / sg13g2_fill_2
XFILLER_47_441 VDD VSS / sg13g2_fill_1
XFILLER_47_446 VDD VSS / sg13g2_fill_2
XFILLER_47_452 VDD VSS / sg13g2_decap_4
XFILLER_47_456 VDD VSS / sg13g2_fill_2
XFILLER_47_478 VDD VSS / sg13g2_decap_8
XFILLER_47_485 VDD VSS / sg13g2_decap_8
XFILLER_47_492 VDD VSS / sg13g2_decap_4
XFILLER_47_527 VDD VSS / sg13g2_decap_8
XFILLER_47_53 VDD VSS / sg13g2_decap_8
XFILLER_47_534 VDD VSS / sg13g2_decap_8
XFILLER_47_541 VDD VSS / sg13g2_fill_1
XFILLER_47_547 VDD VSS / sg13g2_fill_2
XFILLER_47_554 VDD VSS / sg13g2_fill_1
XFILLER_47_590 VDD VSS / sg13g2_fill_2
XFILLER_47_60 VDD VSS / sg13g2_decap_8
XFILLER_47_601 VDD VSS / sg13g2_fill_2
XFILLER_47_67 VDD VSS / sg13g2_decap_8
XFILLER_47_674 VDD VSS / sg13g2_fill_1
XFILLER_47_714 VDD VSS / sg13g2_fill_2
XFILLER_47_74 VDD VSS / sg13g2_fill_2
XFILLER_48_0 VDD VSS / sg13g2_fill_2
XFILLER_48_119 VDD VSS / sg13g2_decap_8
XFILLER_48_12 VDD VSS / sg13g2_decap_4
XFILLER_48_126 VDD VSS / sg13g2_fill_2
XFILLER_48_128 VDD VSS / sg13g2_fill_1
XFILLER_48_156 VDD VSS / sg13g2_fill_1
XFILLER_48_165 VDD VSS / sg13g2_fill_2
XFILLER_48_2 VDD VSS / sg13g2_fill_1
XFILLER_48_206 VDD VSS / sg13g2_decap_8
XFILLER_48_213 VDD VSS / sg13g2_fill_2
XFILLER_48_258 VDD VSS / sg13g2_fill_1
XFILLER_48_296 VDD VSS / sg13g2_fill_2
XFILLER_48_369 VDD VSS / sg13g2_decap_8
XFILLER_48_376 VDD VSS / sg13g2_decap_8
XFILLER_48_383 VDD VSS / sg13g2_decap_8
XFILLER_48_390 VDD VSS / sg13g2_decap_8
XFILLER_48_397 VDD VSS / sg13g2_decap_8
XFILLER_48_404 VDD VSS / sg13g2_decap_8
XFILLER_48_411 VDD VSS / sg13g2_decap_4
XFILLER_48_429 VDD VSS / sg13g2_fill_2
XFILLER_48_43 VDD VSS / sg13g2_decap_8
XFILLER_48_431 VDD VSS / sg13g2_fill_1
XFILLER_48_437 VDD VSS / sg13g2_fill_2
XFILLER_48_439 VDD VSS / sg13g2_fill_1
XFILLER_48_486 VDD VSS / sg13g2_decap_8
XFILLER_48_493 VDD VSS / sg13g2_decap_4
XFILLER_48_50 VDD VSS / sg13g2_decap_8
XFILLER_48_533 VDD VSS / sg13g2_fill_1
XFILLER_48_57 VDD VSS / sg13g2_decap_8
XFILLER_48_588 VDD VSS / sg13g2_decap_4
XFILLER_48_592 VDD VSS / sg13g2_fill_1
XFILLER_48_596 VDD VSS / sg13g2_fill_2
XFILLER_48_598 VDD VSS / sg13g2_fill_1
XFILLER_48_603 VDD VSS / sg13g2_decap_8
XFILLER_48_614 VDD VSS / sg13g2_fill_1
XFILLER_48_64 VDD VSS / sg13g2_decap_8
XFILLER_48_650 VDD VSS / sg13g2_decap_8
XFILLER_48_657 VDD VSS / sg13g2_decap_4
XFILLER_48_661 VDD VSS / sg13g2_fill_1
XFILLER_48_71 VDD VSS / sg13g2_decap_8
XFILLER_48_714 VDD VSS / sg13g2_fill_2
XFILLER_48_78 VDD VSS / sg13g2_fill_2
XFILLER_48_80 VDD VSS / sg13g2_fill_1
XFILLER_49_0 VDD VSS / sg13g2_decap_4
XFILLER_49_115 VDD VSS / sg13g2_decap_8
XFILLER_49_122 VDD VSS / sg13g2_decap_8
XFILLER_49_129 VDD VSS / sg13g2_decap_8
XFILLER_49_136 VDD VSS / sg13g2_decap_4
XFILLER_49_140 VDD VSS / sg13g2_fill_1
XFILLER_49_158 VDD VSS / sg13g2_fill_2
XFILLER_49_160 VDD VSS / sg13g2_fill_1
XFILLER_49_258 VDD VSS / sg13g2_fill_2
XFILLER_49_260 VDD VSS / sg13g2_fill_1
XFILLER_49_31 VDD VSS / sg13g2_decap_8
XFILLER_49_311 VDD VSS / sg13g2_fill_2
XFILLER_49_321 VDD VSS / sg13g2_fill_1
XFILLER_49_328 VDD VSS / sg13g2_fill_2
XFILLER_49_360 VDD VSS / sg13g2_decap_8
XFILLER_49_367 VDD VSS / sg13g2_decap_8
XFILLER_49_374 VDD VSS / sg13g2_decap_8
XFILLER_49_38 VDD VSS / sg13g2_decap_8
XFILLER_49_381 VDD VSS / sg13g2_decap_8
XFILLER_49_388 VDD VSS / sg13g2_decap_8
XFILLER_49_395 VDD VSS / sg13g2_decap_8
XFILLER_49_402 VDD VSS / sg13g2_decap_4
XFILLER_49_438 VDD VSS / sg13g2_decap_8
XFILLER_49_445 VDD VSS / sg13g2_fill_2
XFILLER_49_45 VDD VSS / sg13g2_decap_8
XFILLER_49_52 VDD VSS / sg13g2_decap_8
XFILLER_49_545 VDD VSS / sg13g2_fill_1
XFILLER_49_579 VDD VSS / sg13g2_decap_8
XFILLER_49_586 VDD VSS / sg13g2_decap_8
XFILLER_49_59 VDD VSS / sg13g2_decap_8
XFILLER_49_593 VDD VSS / sg13g2_decap_8
XFILLER_49_600 VDD VSS / sg13g2_fill_2
XFILLER_49_631 VDD VSS / sg13g2_fill_2
XFILLER_49_638 VDD VSS / sg13g2_decap_8
XFILLER_49_645 VDD VSS / sg13g2_decap_8
XFILLER_49_652 VDD VSS / sg13g2_decap_4
XFILLER_49_656 VDD VSS / sg13g2_fill_2
XFILLER_49_66 VDD VSS / sg13g2_decap_8
XFILLER_49_73 VDD VSS / sg13g2_decap_8
XFILLER_49_80 VDD VSS / sg13g2_decap_8
XFILLER_49_87 VDD VSS / sg13g2_fill_1
XFILLER_4_0 VDD VSS / sg13g2_decap_8
XFILLER_4_115 VDD VSS / sg13g2_fill_2
XFILLER_4_126 VDD VSS / sg13g2_decap_8
XFILLER_4_164 VDD VSS / sg13g2_fill_2
XFILLER_4_166 VDD VSS / sg13g2_fill_1
XFILLER_4_210 VDD VSS / sg13g2_fill_2
XFILLER_4_34 VDD VSS / sg13g2_decap_8
XFILLER_4_41 VDD VSS / sg13g2_decap_8
XFILLER_4_48 VDD VSS / sg13g2_decap_8
XFILLER_4_495 VDD VSS / sg13g2_fill_1
XFILLER_4_55 VDD VSS / sg13g2_fill_1
XFILLER_4_558 VDD VSS / sg13g2_fill_2
XFILLER_4_641 VDD VSS / sg13g2_fill_1
XFILLER_4_69 VDD VSS / sg13g2_decap_8
XFILLER_4_76 VDD VSS / sg13g2_decap_8
XFILLER_4_83 VDD VSS / sg13g2_fill_1
XFILLER_50_0 VDD VSS / sg13g2_fill_1
XFILLER_50_104 VDD VSS / sg13g2_decap_8
XFILLER_50_111 VDD VSS / sg13g2_decap_8
XFILLER_50_118 VDD VSS / sg13g2_decap_8
XFILLER_50_125 VDD VSS / sg13g2_decap_8
XFILLER_50_132 VDD VSS / sg13g2_decap_8
XFILLER_50_139 VDD VSS / sg13g2_decap_4
XFILLER_50_143 VDD VSS / sg13g2_fill_1
XFILLER_50_183 VDD VSS / sg13g2_fill_2
XFILLER_50_343 VDD VSS / sg13g2_fill_1
XFILLER_50_348 VDD VSS / sg13g2_fill_2
XFILLER_50_350 VDD VSS / sg13g2_fill_1
XFILLER_50_354 VDD VSS / sg13g2_decap_8
XFILLER_50_361 VDD VSS / sg13g2_decap_4
XFILLER_50_396 VDD VSS / sg13g2_fill_2
XFILLER_50_398 VDD VSS / sg13g2_fill_1
XFILLER_50_404 VDD VSS / sg13g2_decap_8
XFILLER_50_439 VDD VSS / sg13g2_decap_8
XFILLER_50_446 VDD VSS / sg13g2_decap_8
XFILLER_50_453 VDD VSS / sg13g2_decap_4
XFILLER_50_494 VDD VSS / sg13g2_fill_1
XFILLER_50_512 VDD VSS / sg13g2_fill_2
XFILLER_50_514 VDD VSS / sg13g2_fill_1
XFILLER_50_542 VDD VSS / sg13g2_decap_4
XFILLER_50_546 VDD VSS / sg13g2_fill_2
XFILLER_50_55 VDD VSS / sg13g2_decap_8
XFILLER_50_587 VDD VSS / sg13g2_decap_8
XFILLER_50_594 VDD VSS / sg13g2_decap_4
XFILLER_50_598 VDD VSS / sg13g2_fill_2
XFILLER_50_62 VDD VSS / sg13g2_decap_8
XFILLER_50_630 VDD VSS / sg13g2_decap_8
XFILLER_50_637 VDD VSS / sg13g2_decap_8
XFILLER_50_644 VDD VSS / sg13g2_decap_8
XFILLER_50_69 VDD VSS / sg13g2_decap_8
XFILLER_50_714 VDD VSS / sg13g2_fill_2
XFILLER_50_76 VDD VSS / sg13g2_decap_8
XFILLER_50_83 VDD VSS / sg13g2_decap_8
XFILLER_50_90 VDD VSS / sg13g2_decap_8
XFILLER_50_97 VDD VSS / sg13g2_decap_8
XFILLER_51_0 VDD VSS / sg13g2_fill_2
XFILLER_51_115 VDD VSS / sg13g2_decap_8
XFILLER_51_127 VDD VSS / sg13g2_decap_8
XFILLER_51_134 VDD VSS / sg13g2_decap_4
XFILLER_51_138 VDD VSS / sg13g2_fill_2
XFILLER_51_2 VDD VSS / sg13g2_fill_1
XFILLER_51_255 VDD VSS / sg13g2_fill_2
XFILLER_51_257 VDD VSS / sg13g2_fill_1
XFILLER_51_271 VDD VSS / sg13g2_fill_1
XFILLER_51_30 VDD VSS / sg13g2_decap_4
XFILLER_51_302 VDD VSS / sg13g2_decap_4
XFILLER_51_320 VDD VSS / sg13g2_decap_4
XFILLER_51_328 VDD VSS / sg13g2_fill_2
XFILLER_51_335 VDD VSS / sg13g2_decap_8
XFILLER_51_34 VDD VSS / sg13g2_fill_1
XFILLER_51_342 VDD VSS / sg13g2_decap_4
XFILLER_51_360 VDD VSS / sg13g2_fill_2
XFILLER_51_371 VDD VSS / sg13g2_fill_2
XFILLER_51_410 VDD VSS / sg13g2_decap_4
XFILLER_51_458 VDD VSS / sg13g2_decap_8
XFILLER_51_48 VDD VSS / sg13g2_decap_8
XFILLER_51_493 VDD VSS / sg13g2_decap_8
XFILLER_51_506 VDD VSS / sg13g2_fill_2
XFILLER_51_521 VDD VSS / sg13g2_decap_8
XFILLER_51_528 VDD VSS / sg13g2_decap_8
XFILLER_51_535 VDD VSS / sg13g2_decap_4
XFILLER_51_545 VDD VSS / sg13g2_decap_8
XFILLER_51_55 VDD VSS / sg13g2_decap_8
XFILLER_51_552 VDD VSS / sg13g2_decap_4
XFILLER_51_556 VDD VSS / sg13g2_fill_2
XFILLER_51_569 VDD VSS / sg13g2_decap_4
XFILLER_51_577 VDD VSS / sg13g2_decap_8
XFILLER_51_584 VDD VSS / sg13g2_decap_8
XFILLER_51_591 VDD VSS / sg13g2_fill_2
XFILLER_51_62 VDD VSS / sg13g2_decap_8
XFILLER_51_652 VDD VSS / sg13g2_fill_1
XFILLER_51_685 VDD VSS / sg13g2_fill_2
XFILLER_51_69 VDD VSS / sg13g2_decap_8
XFILLER_51_714 VDD VSS / sg13g2_fill_2
XFILLER_51_76 VDD VSS / sg13g2_decap_8
XFILLER_51_83 VDD VSS / sg13g2_decap_4
XFILLER_51_87 VDD VSS / sg13g2_fill_1
XFILLER_52_0 VDD VSS / sg13g2_fill_2
XFILLER_52_134 VDD VSS / sg13g2_fill_2
XFILLER_52_136 VDD VSS / sg13g2_fill_1
XFILLER_52_2 VDD VSS / sg13g2_fill_1
XFILLER_52_262 VDD VSS / sg13g2_fill_2
XFILLER_52_276 VDD VSS / sg13g2_fill_2
XFILLER_52_278 VDD VSS / sg13g2_fill_1
XFILLER_52_291 VDD VSS / sg13g2_decap_8
XFILLER_52_298 VDD VSS / sg13g2_decap_8
XFILLER_52_30 VDD VSS / sg13g2_decap_4
XFILLER_52_305 VDD VSS / sg13g2_decap_8
XFILLER_52_312 VDD VSS / sg13g2_decap_4
XFILLER_52_34 VDD VSS / sg13g2_fill_1
XFILLER_52_344 VDD VSS / sg13g2_decap_4
XFILLER_52_348 VDD VSS / sg13g2_fill_1
XFILLER_52_401 VDD VSS / sg13g2_fill_2
XFILLER_52_441 VDD VSS / sg13g2_decap_8
XFILLER_52_448 VDD VSS / sg13g2_decap_8
XFILLER_52_455 VDD VSS / sg13g2_decap_8
XFILLER_52_462 VDD VSS / sg13g2_decap_8
XFILLER_52_469 VDD VSS / sg13g2_fill_2
XFILLER_52_522 VDD VSS / sg13g2_decap_8
XFILLER_52_529 VDD VSS / sg13g2_decap_8
XFILLER_52_536 VDD VSS / sg13g2_decap_8
XFILLER_52_543 VDD VSS / sg13g2_decap_8
XFILLER_52_550 VDD VSS / sg13g2_decap_8
XFILLER_52_557 VDD VSS / sg13g2_decap_4
XFILLER_52_561 VDD VSS / sg13g2_fill_2
XFILLER_52_573 VDD VSS / sg13g2_fill_2
XFILLER_52_60 VDD VSS / sg13g2_decap_4
XFILLER_52_602 VDD VSS / sg13g2_fill_2
XFILLER_52_604 VDD VSS / sg13g2_fill_1
XFILLER_52_64 VDD VSS / sg13g2_fill_2
XFILLER_52_649 VDD VSS / sg13g2_fill_1
XFILLER_52_661 VDD VSS / sg13g2_fill_2
XFILLER_52_714 VDD VSS / sg13g2_fill_2
XFILLER_52_82 VDD VSS / sg13g2_decap_8
XFILLER_52_89 VDD VSS / sg13g2_fill_2
XFILLER_52_96 VDD VSS / sg13g2_decap_4
XFILLER_53_0 VDD VSS / sg13g2_decap_4
XFILLER_53_115 VDD VSS / sg13g2_decap_8
XFILLER_53_122 VDD VSS / sg13g2_decap_8
XFILLER_53_129 VDD VSS / sg13g2_decap_4
XFILLER_53_133 VDD VSS / sg13g2_fill_1
XFILLER_53_138 VDD VSS / sg13g2_decap_4
XFILLER_53_142 VDD VSS / sg13g2_fill_2
XFILLER_53_208 VDD VSS / sg13g2_fill_2
XFILLER_53_251 VDD VSS / sg13g2_fill_1
XFILLER_53_265 VDD VSS / sg13g2_fill_2
XFILLER_53_267 VDD VSS / sg13g2_fill_1
XFILLER_53_307 VDD VSS / sg13g2_fill_2
XFILLER_53_319 VDD VSS / sg13g2_fill_2
XFILLER_53_321 VDD VSS / sg13g2_fill_1
XFILLER_53_325 VDD VSS / sg13g2_fill_2
XFILLER_53_332 VDD VSS / sg13g2_fill_1
XFILLER_53_338 VDD VSS / sg13g2_decap_4
XFILLER_53_342 VDD VSS / sg13g2_fill_1
XFILLER_53_40 VDD VSS / sg13g2_decap_8
XFILLER_53_401 VDD VSS / sg13g2_decap_4
XFILLER_53_451 VDD VSS / sg13g2_decap_8
XFILLER_53_458 VDD VSS / sg13g2_decap_4
XFILLER_53_47 VDD VSS / sg13g2_decap_4
XFILLER_53_503 VDD VSS / sg13g2_fill_2
XFILLER_53_505 VDD VSS / sg13g2_fill_1
XFILLER_53_51 VDD VSS / sg13g2_fill_2
XFILLER_53_543 VDD VSS / sg13g2_decap_4
XFILLER_53_547 VDD VSS / sg13g2_fill_1
XFILLER_53_553 VDD VSS / sg13g2_decap_8
XFILLER_53_560 VDD VSS / sg13g2_decap_4
XFILLER_53_601 VDD VSS / sg13g2_fill_2
XFILLER_53_63 VDD VSS / sg13g2_fill_1
XFILLER_53_640 VDD VSS / sg13g2_fill_1
XFILLER_53_674 VDD VSS / sg13g2_fill_1
XFILLER_53_715 VDD VSS / sg13g2_fill_1
XFILLER_53_78 VDD VSS / sg13g2_fill_2
XFILLER_54_0 VDD VSS / sg13g2_fill_2
XFILLER_54_110 VDD VSS / sg13g2_fill_1
XFILLER_54_143 VDD VSS / sg13g2_fill_2
XFILLER_54_145 VDD VSS / sg13g2_fill_1
XFILLER_54_189 VDD VSS / sg13g2_fill_1
XFILLER_54_2 VDD VSS / sg13g2_fill_1
XFILLER_54_253 VDD VSS / sg13g2_decap_8
XFILLER_54_260 VDD VSS / sg13g2_decap_4
XFILLER_54_264 VDD VSS / sg13g2_fill_1
XFILLER_54_288 VDD VSS / sg13g2_decap_8
XFILLER_54_295 VDD VSS / sg13g2_decap_4
XFILLER_54_299 VDD VSS / sg13g2_fill_1
XFILLER_54_341 VDD VSS / sg13g2_decap_4
XFILLER_54_345 VDD VSS / sg13g2_fill_1
XFILLER_54_363 VDD VSS / sg13g2_fill_1
XFILLER_54_39 VDD VSS / sg13g2_decap_4
XFILLER_54_401 VDD VSS / sg13g2_decap_4
XFILLER_54_499 VDD VSS / sg13g2_decap_4
XFILLER_54_509 VDD VSS / sg13g2_fill_2
XFILLER_54_527 VDD VSS / sg13g2_fill_2
XFILLER_54_529 VDD VSS / sg13g2_fill_1
XFILLER_54_553 VDD VSS / sg13g2_decap_8
XFILLER_54_560 VDD VSS / sg13g2_decap_4
XFILLER_54_601 VDD VSS / sg13g2_decap_4
XFILLER_54_605 VDD VSS / sg13g2_fill_1
XFILLER_54_610 VDD VSS / sg13g2_decap_8
XFILLER_54_617 VDD VSS / sg13g2_fill_1
XFILLER_54_624 VDD VSS / sg13g2_decap_8
XFILLER_54_631 VDD VSS / sg13g2_decap_4
XFILLER_54_635 VDD VSS / sg13g2_fill_2
XFILLER_54_665 VDD VSS / sg13g2_fill_2
XFILLER_54_670 VDD VSS / sg13g2_decap_8
XFILLER_54_677 VDD VSS / sg13g2_fill_1
XFILLER_54_710 VDD VSS / sg13g2_fill_1
XFILLER_54_715 VDD VSS / sg13g2_fill_1
XFILLER_54_80 VDD VSS / sg13g2_decap_8
XFILLER_54_87 VDD VSS / sg13g2_fill_2
XFILLER_55_0 VDD VSS / sg13g2_fill_2
XFILLER_55_116 VDD VSS / sg13g2_decap_8
XFILLER_55_123 VDD VSS / sg13g2_decap_8
XFILLER_55_130 VDD VSS / sg13g2_fill_2
XFILLER_55_132 VDD VSS / sg13g2_fill_1
XFILLER_55_137 VDD VSS / sg13g2_decap_8
XFILLER_55_2 VDD VSS / sg13g2_fill_1
XFILLER_55_215 VDD VSS / sg13g2_fill_2
XFILLER_55_245 VDD VSS / sg13g2_decap_8
XFILLER_55_252 VDD VSS / sg13g2_decap_8
XFILLER_55_259 VDD VSS / sg13g2_decap_8
XFILLER_55_266 VDD VSS / sg13g2_fill_2
XFILLER_55_268 VDD VSS / sg13g2_fill_1
XFILLER_55_273 VDD VSS / sg13g2_decap_4
XFILLER_55_277 VDD VSS / sg13g2_fill_2
XFILLER_55_283 VDD VSS / sg13g2_decap_8
XFILLER_55_290 VDD VSS / sg13g2_decap_8
XFILLER_55_297 VDD VSS / sg13g2_decap_4
XFILLER_55_301 VDD VSS / sg13g2_fill_2
XFILLER_55_332 VDD VSS / sg13g2_decap_8
XFILLER_55_339 VDD VSS / sg13g2_decap_8
XFILLER_55_346 VDD VSS / sg13g2_decap_4
XFILLER_55_354 VDD VSS / sg13g2_fill_1
XFILLER_55_364 VDD VSS / sg13g2_decap_8
XFILLER_55_371 VDD VSS / sg13g2_decap_4
XFILLER_55_375 VDD VSS / sg13g2_fill_1
XFILLER_55_379 VDD VSS / sg13g2_decap_8
XFILLER_55_386 VDD VSS / sg13g2_decap_8
XFILLER_55_39 VDD VSS / sg13g2_decap_8
XFILLER_55_393 VDD VSS / sg13g2_decap_8
XFILLER_55_400 VDD VSS / sg13g2_decap_8
XFILLER_55_407 VDD VSS / sg13g2_decap_8
XFILLER_55_414 VDD VSS / sg13g2_fill_2
XFILLER_55_458 VDD VSS / sg13g2_decap_4
XFILLER_55_46 VDD VSS / sg13g2_fill_2
XFILLER_55_48 VDD VSS / sg13g2_fill_1
XFILLER_55_507 VDD VSS / sg13g2_fill_2
XFILLER_55_509 VDD VSS / sg13g2_fill_1
XFILLER_55_516 VDD VSS / sg13g2_decap_8
XFILLER_55_523 VDD VSS / sg13g2_fill_1
XFILLER_55_53 VDD VSS / sg13g2_decap_8
XFILLER_55_567 VDD VSS / sg13g2_decap_8
XFILLER_55_574 VDD VSS / sg13g2_decap_8
XFILLER_55_593 VDD VSS / sg13g2_decap_8
XFILLER_55_60 VDD VSS / sg13g2_fill_1
XFILLER_55_600 VDD VSS / sg13g2_fill_2
XFILLER_55_633 VDD VSS / sg13g2_decap_8
XFILLER_55_640 VDD VSS / sg13g2_decap_8
XFILLER_55_647 VDD VSS / sg13g2_decap_4
XFILLER_55_655 VDD VSS / sg13g2_decap_8
XFILLER_55_662 VDD VSS / sg13g2_decap_4
XFILLER_55_670 VDD VSS / sg13g2_decap_4
XFILLER_55_674 VDD VSS / sg13g2_fill_1
XFILLER_55_679 VDD VSS / sg13g2_decap_4
XFILLER_55_714 VDD VSS / sg13g2_fill_2
XFILLER_55_74 VDD VSS / sg13g2_decap_8
XFILLER_55_81 VDD VSS / sg13g2_decap_4
XFILLER_55_85 VDD VSS / sg13g2_fill_2
XFILLER_56_0 VDD VSS / sg13g2_decap_4
XFILLER_56_118 VDD VSS / sg13g2_decap_8
XFILLER_56_125 VDD VSS / sg13g2_decap_8
XFILLER_56_132 VDD VSS / sg13g2_decap_8
XFILLER_56_139 VDD VSS / sg13g2_fill_2
XFILLER_56_219 VDD VSS / sg13g2_fill_2
XFILLER_56_239 VDD VSS / sg13g2_decap_8
XFILLER_56_246 VDD VSS / sg13g2_decap_8
XFILLER_56_253 VDD VSS / sg13g2_fill_2
XFILLER_56_255 VDD VSS / sg13g2_fill_1
XFILLER_56_292 VDD VSS / sg13g2_decap_8
XFILLER_56_299 VDD VSS / sg13g2_fill_1
XFILLER_56_303 VDD VSS / sg13g2_decap_8
XFILLER_56_310 VDD VSS / sg13g2_fill_2
XFILLER_56_329 VDD VSS / sg13g2_decap_4
XFILLER_56_333 VDD VSS / sg13g2_fill_2
XFILLER_56_339 VDD VSS / sg13g2_decap_8
XFILLER_56_346 VDD VSS / sg13g2_decap_8
XFILLER_56_353 VDD VSS / sg13g2_decap_8
XFILLER_56_360 VDD VSS / sg13g2_fill_2
XFILLER_56_362 VDD VSS / sg13g2_fill_1
XFILLER_56_395 VDD VSS / sg13g2_decap_8
XFILLER_56_402 VDD VSS / sg13g2_decap_8
XFILLER_56_409 VDD VSS / sg13g2_decap_8
XFILLER_56_416 VDD VSS / sg13g2_decap_4
XFILLER_56_420 VDD VSS / sg13g2_fill_1
XFILLER_56_43 VDD VSS / sg13g2_decap_4
XFILLER_56_434 VDD VSS / sg13g2_decap_8
XFILLER_56_441 VDD VSS / sg13g2_decap_8
XFILLER_56_448 VDD VSS / sg13g2_decap_8
XFILLER_56_455 VDD VSS / sg13g2_fill_2
XFILLER_56_462 VDD VSS / sg13g2_fill_2
XFILLER_56_464 VDD VSS / sg13g2_fill_1
XFILLER_56_47 VDD VSS / sg13g2_fill_2
XFILLER_56_474 VDD VSS / sg13g2_fill_2
XFILLER_56_484 VDD VSS / sg13g2_fill_1
XFILLER_56_489 VDD VSS / sg13g2_decap_8
XFILLER_56_502 VDD VSS / sg13g2_decap_8
XFILLER_56_509 VDD VSS / sg13g2_decap_8
XFILLER_56_516 VDD VSS / sg13g2_decap_8
XFILLER_56_523 VDD VSS / sg13g2_fill_1
XFILLER_56_53 VDD VSS / sg13g2_decap_8
XFILLER_56_530 VDD VSS / sg13g2_decap_4
XFILLER_56_584 VDD VSS / sg13g2_decap_8
XFILLER_56_591 VDD VSS / sg13g2_fill_2
XFILLER_56_593 VDD VSS / sg13g2_fill_1
XFILLER_56_60 VDD VSS / sg13g2_decap_8
XFILLER_56_630 VDD VSS / sg13g2_decap_8
XFILLER_56_637 VDD VSS / sg13g2_decap_8
XFILLER_56_644 VDD VSS / sg13g2_decap_8
XFILLER_56_651 VDD VSS / sg13g2_decap_4
XFILLER_56_655 VDD VSS / sg13g2_fill_1
XFILLER_56_661 VDD VSS / sg13g2_fill_2
XFILLER_56_663 VDD VSS / sg13g2_fill_1
XFILLER_56_67 VDD VSS / sg13g2_decap_8
XFILLER_56_683 VDD VSS / sg13g2_fill_1
XFILLER_56_696 VDD VSS / sg13g2_fill_2
XFILLER_56_702 VDD VSS / sg13g2_fill_2
XFILLER_56_74 VDD VSS / sg13g2_decap_8
XFILLER_56_81 VDD VSS / sg13g2_fill_1
XFILLER_57_115 VDD VSS / sg13g2_decap_4
XFILLER_57_119 VDD VSS / sg13g2_fill_2
XFILLER_57_148 VDD VSS / sg13g2_fill_1
XFILLER_57_154 VDD VSS / sg13g2_fill_1
XFILLER_57_228 VDD VSS / sg13g2_decap_8
XFILLER_57_235 VDD VSS / sg13g2_decap_8
XFILLER_57_242 VDD VSS / sg13g2_decap_4
XFILLER_57_246 VDD VSS / sg13g2_fill_2
XFILLER_57_269 VDD VSS / sg13g2_fill_2
XFILLER_57_271 VDD VSS / sg13g2_fill_1
XFILLER_57_295 VDD VSS / sg13g2_decap_8
XFILLER_57_302 VDD VSS / sg13g2_fill_1
XFILLER_57_31 VDD VSS / sg13g2_decap_8
XFILLER_57_327 VDD VSS / sg13g2_fill_2
XFILLER_57_356 VDD VSS / sg13g2_decap_8
XFILLER_57_363 VDD VSS / sg13g2_fill_2
XFILLER_57_365 VDD VSS / sg13g2_fill_1
XFILLER_57_38 VDD VSS / sg13g2_decap_8
XFILLER_57_407 VDD VSS / sg13g2_decap_8
XFILLER_57_414 VDD VSS / sg13g2_fill_2
XFILLER_57_426 VDD VSS / sg13g2_fill_2
XFILLER_57_434 VDD VSS / sg13g2_decap_8
XFILLER_57_441 VDD VSS / sg13g2_decap_8
XFILLER_57_448 VDD VSS / sg13g2_fill_1
XFILLER_57_45 VDD VSS / sg13g2_fill_1
XFILLER_57_485 VDD VSS / sg13g2_decap_8
XFILLER_57_492 VDD VSS / sg13g2_decap_4
XFILLER_57_496 VDD VSS / sg13g2_fill_1
XFILLER_57_50 VDD VSS / sg13g2_decap_4
XFILLER_57_523 VDD VSS / sg13g2_decap_8
XFILLER_57_530 VDD VSS / sg13g2_decap_8
XFILLER_57_537 VDD VSS / sg13g2_decap_8
XFILLER_57_544 VDD VSS / sg13g2_decap_4
XFILLER_57_548 VDD VSS / sg13g2_fill_2
XFILLER_57_555 VDD VSS / sg13g2_fill_2
XFILLER_57_638 VDD VSS / sg13g2_decap_4
XFILLER_57_645 VDD VSS / sg13g2_fill_2
XFILLER_57_647 VDD VSS / sg13g2_fill_1
XFILLER_57_651 VDD VSS / sg13g2_fill_1
XFILLER_57_69 VDD VSS / sg13g2_decap_8
XFILLER_57_709 VDD VSS / sg13g2_fill_1
XFILLER_57_714 VDD VSS / sg13g2_fill_2
XFILLER_57_76 VDD VSS / sg13g2_fill_2
XFILLER_58_0 VDD VSS / sg13g2_fill_2
XFILLER_58_120 VDD VSS / sg13g2_fill_2
XFILLER_58_195 VDD VSS / sg13g2_fill_1
XFILLER_58_2 VDD VSS / sg13g2_fill_1
XFILLER_58_227 VDD VSS / sg13g2_decap_4
XFILLER_58_231 VDD VSS / sg13g2_fill_1
XFILLER_58_30 VDD VSS / sg13g2_decap_8
XFILLER_58_300 VDD VSS / sg13g2_decap_4
XFILLER_58_313 VDD VSS / sg13g2_fill_1
XFILLER_58_322 VDD VSS / sg13g2_fill_1
XFILLER_58_333 VDD VSS / sg13g2_fill_2
XFILLER_58_362 VDD VSS / sg13g2_fill_2
XFILLER_58_364 VDD VSS / sg13g2_fill_1
XFILLER_58_37 VDD VSS / sg13g2_fill_2
XFILLER_58_39 VDD VSS / sg13g2_fill_1
XFILLER_58_401 VDD VSS / sg13g2_decap_4
XFILLER_58_405 VDD VSS / sg13g2_fill_1
XFILLER_58_438 VDD VSS / sg13g2_decap_8
XFILLER_58_445 VDD VSS / sg13g2_decap_8
XFILLER_58_452 VDD VSS / sg13g2_decap_8
XFILLER_58_459 VDD VSS / sg13g2_decap_4
XFILLER_58_463 VDD VSS / sg13g2_fill_1
XFILLER_58_472 VDD VSS / sg13g2_decap_8
XFILLER_58_479 VDD VSS / sg13g2_fill_2
XFILLER_58_481 VDD VSS / sg13g2_fill_1
XFILLER_58_487 VDD VSS / sg13g2_decap_8
XFILLER_58_506 VDD VSS / sg13g2_decap_4
XFILLER_58_518 VDD VSS / sg13g2_decap_8
XFILLER_58_525 VDD VSS / sg13g2_fill_1
XFILLER_58_533 VDD VSS / sg13g2_fill_2
XFILLER_58_535 VDD VSS / sg13g2_fill_1
XFILLER_58_585 VDD VSS / sg13g2_decap_4
XFILLER_58_589 VDD VSS / sg13g2_fill_2
XFILLER_58_715 VDD VSS / sg13g2_fill_1
XFILLER_58_85 VDD VSS / sg13g2_fill_2
XFILLER_58_87 VDD VSS / sg13g2_fill_1
XFILLER_59_0 VDD VSS / sg13g2_decap_4
XFILLER_59_116 VDD VSS / sg13g2_fill_1
XFILLER_59_125 VDD VSS / sg13g2_decap_8
XFILLER_59_132 VDD VSS / sg13g2_decap_8
XFILLER_59_139 VDD VSS / sg13g2_fill_1
XFILLER_59_223 VDD VSS / sg13g2_fill_1
XFILLER_59_229 VDD VSS / sg13g2_decap_4
XFILLER_59_233 VDD VSS / sg13g2_fill_2
XFILLER_59_244 VDD VSS / sg13g2_fill_2
XFILLER_59_246 VDD VSS / sg13g2_fill_1
XFILLER_59_282 VDD VSS / sg13g2_fill_2
XFILLER_59_287 VDD VSS / sg13g2_decap_8
XFILLER_59_294 VDD VSS / sg13g2_decap_8
XFILLER_59_301 VDD VSS / sg13g2_fill_2
XFILLER_59_303 VDD VSS / sg13g2_fill_1
XFILLER_59_31 VDD VSS / sg13g2_decap_8
XFILLER_59_334 VDD VSS / sg13g2_decap_8
XFILLER_59_341 VDD VSS / sg13g2_decap_8
XFILLER_59_348 VDD VSS / sg13g2_decap_8
XFILLER_59_355 VDD VSS / sg13g2_decap_8
XFILLER_59_362 VDD VSS / sg13g2_decap_8
XFILLER_59_369 VDD VSS / sg13g2_fill_2
XFILLER_59_371 VDD VSS / sg13g2_fill_1
XFILLER_59_38 VDD VSS / sg13g2_decap_8
XFILLER_59_445 VDD VSS / sg13g2_decap_8
XFILLER_59_452 VDD VSS / sg13g2_decap_8
XFILLER_59_459 VDD VSS / sg13g2_decap_8
XFILLER_59_466 VDD VSS / sg13g2_fill_2
XFILLER_59_474 VDD VSS / sg13g2_decap_8
XFILLER_59_481 VDD VSS / sg13g2_decap_8
XFILLER_59_488 VDD VSS / sg13g2_decap_8
XFILLER_59_495 VDD VSS / sg13g2_fill_1
XFILLER_59_518 VDD VSS / sg13g2_decap_8
XFILLER_59_525 VDD VSS / sg13g2_decap_8
XFILLER_59_532 VDD VSS / sg13g2_decap_8
XFILLER_59_539 VDD VSS / sg13g2_decap_8
XFILLER_59_546 VDD VSS / sg13g2_decap_4
XFILLER_59_550 VDD VSS / sg13g2_fill_1
XFILLER_59_562 VDD VSS / sg13g2_decap_8
XFILLER_59_569 VDD VSS / sg13g2_decap_8
XFILLER_59_576 VDD VSS / sg13g2_decap_8
XFILLER_59_583 VDD VSS / sg13g2_decap_8
XFILLER_59_590 VDD VSS / sg13g2_decap_4
XFILLER_59_594 VDD VSS / sg13g2_fill_1
XFILLER_59_644 VDD VSS / sg13g2_decap_8
XFILLER_59_651 VDD VSS / sg13g2_fill_2
XFILLER_59_653 VDD VSS / sg13g2_fill_1
XFILLER_59_664 VDD VSS / sg13g2_fill_2
XFILLER_59_679 VDD VSS / sg13g2_fill_2
XFILLER_59_69 VDD VSS / sg13g2_decap_8
XFILLER_59_713 VDD VSS / sg13g2_fill_2
XFILLER_59_715 VDD VSS / sg13g2_fill_1
XFILLER_59_76 VDD VSS / sg13g2_fill_2
XFILLER_59_88 VDD VSS / sg13g2_fill_2
XFILLER_59_90 VDD VSS / sg13g2_fill_1
XFILLER_5_0 VDD VSS / sg13g2_decap_4
XFILLER_5_115 VDD VSS / sg13g2_fill_2
XFILLER_5_225 VDD VSS / sg13g2_decap_8
XFILLER_5_232 VDD VSS / sg13g2_decap_8
XFILLER_5_239 VDD VSS / sg13g2_decap_8
XFILLER_5_246 VDD VSS / sg13g2_fill_1
XFILLER_5_277 VDD VSS / sg13g2_fill_1
XFILLER_5_305 VDD VSS / sg13g2_decap_8
XFILLER_5_31 VDD VSS / sg13g2_decap_8
XFILLER_5_312 VDD VSS / sg13g2_fill_2
XFILLER_5_314 VDD VSS / sg13g2_fill_1
XFILLER_5_38 VDD VSS / sg13g2_decap_8
XFILLER_5_45 VDD VSS / sg13g2_decap_8
XFILLER_5_52 VDD VSS / sg13g2_decap_8
XFILLER_5_59 VDD VSS / sg13g2_decap_8
XFILLER_5_590 VDD VSS / sg13g2_fill_2
XFILLER_5_628 VDD VSS / sg13g2_fill_2
XFILLER_5_657 VDD VSS / sg13g2_fill_2
XFILLER_5_66 VDD VSS / sg13g2_decap_8
XFILLER_5_686 VDD VSS / sg13g2_fill_1
XFILLER_5_714 VDD VSS / sg13g2_fill_2
XFILLER_5_73 VDD VSS / sg13g2_decap_8
XFILLER_5_80 VDD VSS / sg13g2_decap_8
XFILLER_5_87 VDD VSS / sg13g2_fill_1
XFILLER_60_0 VDD VSS / sg13g2_decap_4
XFILLER_60_120 VDD VSS / sg13g2_decap_8
XFILLER_60_127 VDD VSS / sg13g2_decap_8
XFILLER_60_134 VDD VSS / sg13g2_decap_8
XFILLER_60_141 VDD VSS / sg13g2_decap_8
XFILLER_60_148 VDD VSS / sg13g2_fill_1
XFILLER_60_208 VDD VSS / sg13g2_fill_2
XFILLER_60_239 VDD VSS / sg13g2_decap_4
XFILLER_60_283 VDD VSS / sg13g2_fill_2
XFILLER_60_293 VDD VSS / sg13g2_decap_8
XFILLER_60_300 VDD VSS / sg13g2_fill_2
XFILLER_60_31 VDD VSS / sg13g2_decap_8
XFILLER_60_329 VDD VSS / sg13g2_fill_1
XFILLER_60_334 VDD VSS / sg13g2_decap_8
XFILLER_60_341 VDD VSS / sg13g2_fill_2
XFILLER_60_38 VDD VSS / sg13g2_decap_4
XFILLER_60_385 VDD VSS / sg13g2_decap_8
XFILLER_60_392 VDD VSS / sg13g2_decap_8
XFILLER_60_399 VDD VSS / sg13g2_fill_2
XFILLER_60_407 VDD VSS / sg13g2_fill_1
XFILLER_60_440 VDD VSS / sg13g2_decap_8
XFILLER_60_447 VDD VSS / sg13g2_decap_8
XFILLER_60_454 VDD VSS / sg13g2_decap_8
XFILLER_60_461 VDD VSS / sg13g2_decap_4
XFILLER_60_473 VDD VSS / sg13g2_fill_2
XFILLER_60_475 VDD VSS / sg13g2_fill_1
XFILLER_60_488 VDD VSS / sg13g2_decap_8
XFILLER_60_495 VDD VSS / sg13g2_decap_8
XFILLER_60_502 VDD VSS / sg13g2_fill_2
XFILLER_60_504 VDD VSS / sg13g2_fill_1
XFILLER_60_521 VDD VSS / sg13g2_fill_2
XFILLER_60_523 VDD VSS / sg13g2_fill_1
XFILLER_60_529 VDD VSS / sg13g2_decap_8
XFILLER_60_536 VDD VSS / sg13g2_decap_8
XFILLER_60_543 VDD VSS / sg13g2_decap_8
XFILLER_60_550 VDD VSS / sg13g2_decap_8
XFILLER_60_557 VDD VSS / sg13g2_fill_2
XFILLER_60_559 VDD VSS / sg13g2_fill_1
XFILLER_60_565 VDD VSS / sg13g2_decap_4
XFILLER_60_569 VDD VSS / sg13g2_fill_1
XFILLER_60_575 VDD VSS / sg13g2_decap_8
XFILLER_60_582 VDD VSS / sg13g2_decap_8
XFILLER_60_589 VDD VSS / sg13g2_decap_4
XFILLER_60_593 VDD VSS / sg13g2_fill_2
XFILLER_60_619 VDD VSS / sg13g2_fill_1
XFILLER_60_628 VDD VSS / sg13g2_decap_8
XFILLER_60_635 VDD VSS / sg13g2_decap_8
XFILLER_60_642 VDD VSS / sg13g2_decap_8
XFILLER_60_649 VDD VSS / sg13g2_fill_1
XFILLER_60_668 VDD VSS / sg13g2_fill_2
XFILLER_60_670 VDD VSS / sg13g2_fill_1
XFILLER_60_676 VDD VSS / sg13g2_fill_1
XFILLER_60_71 VDD VSS / sg13g2_decap_4
XFILLER_60_714 VDD VSS / sg13g2_fill_2
XFILLER_60_75 VDD VSS / sg13g2_fill_2
XFILLER_60_91 VDD VSS / sg13g2_fill_2
XFILLER_60_93 VDD VSS / sg13g2_fill_1
XFILLER_61_0 VDD VSS / sg13g2_decap_4
XFILLER_61_112 VDD VSS / sg13g2_fill_2
XFILLER_61_114 VDD VSS / sg13g2_fill_1
XFILLER_61_121 VDD VSS / sg13g2_decap_8
XFILLER_61_128 VDD VSS / sg13g2_decap_8
XFILLER_61_13 VDD VSS / sg13g2_decap_8
XFILLER_61_135 VDD VSS / sg13g2_fill_2
XFILLER_61_142 VDD VSS / sg13g2_fill_2
XFILLER_61_144 VDD VSS / sg13g2_fill_1
XFILLER_61_152 VDD VSS / sg13g2_decap_8
XFILLER_61_159 VDD VSS / sg13g2_decap_4
XFILLER_61_20 VDD VSS / sg13g2_decap_8
XFILLER_61_221 VDD VSS / sg13g2_fill_1
XFILLER_61_245 VDD VSS / sg13g2_decap_8
XFILLER_61_252 VDD VSS / sg13g2_fill_1
XFILLER_61_258 VDD VSS / sg13g2_fill_2
XFILLER_61_27 VDD VSS / sg13g2_fill_2
XFILLER_61_270 VDD VSS / sg13g2_fill_1
XFILLER_61_29 VDD VSS / sg13g2_fill_1
XFILLER_61_302 VDD VSS / sg13g2_decap_4
XFILLER_61_362 VDD VSS / sg13g2_decap_4
XFILLER_61_366 VDD VSS / sg13g2_fill_1
XFILLER_61_417 VDD VSS / sg13g2_fill_1
XFILLER_61_428 VDD VSS / sg13g2_decap_8
XFILLER_61_435 VDD VSS / sg13g2_decap_8
XFILLER_61_442 VDD VSS / sg13g2_decap_8
XFILLER_61_449 VDD VSS / sg13g2_decap_8
XFILLER_61_456 VDD VSS / sg13g2_decap_4
XFILLER_61_460 VDD VSS / sg13g2_fill_2
XFILLER_61_47 VDD VSS / sg13g2_fill_1
XFILLER_61_471 VDD VSS / sg13g2_fill_1
XFILLER_61_489 VDD VSS / sg13g2_fill_2
XFILLER_61_491 VDD VSS / sg13g2_fill_1
XFILLER_61_496 VDD VSS / sg13g2_decap_8
XFILLER_61_503 VDD VSS / sg13g2_decap_4
XFILLER_61_533 VDD VSS / sg13g2_decap_4
XFILLER_61_537 VDD VSS / sg13g2_fill_2
XFILLER_61_545 VDD VSS / sg13g2_decap_8
XFILLER_61_552 VDD VSS / sg13g2_decap_4
XFILLER_61_574 VDD VSS / sg13g2_fill_1
XFILLER_61_581 VDD VSS / sg13g2_fill_2
XFILLER_61_583 VDD VSS / sg13g2_fill_1
XFILLER_61_606 VDD VSS / sg13g2_fill_2
XFILLER_61_620 VDD VSS / sg13g2_decap_4
XFILLER_61_624 VDD VSS / sg13g2_fill_1
XFILLER_61_631 VDD VSS / sg13g2_fill_2
XFILLER_61_638 VDD VSS / sg13g2_decap_4
XFILLER_61_645 VDD VSS / sg13g2_fill_1
XFILLER_61_666 VDD VSS / sg13g2_fill_2
XFILLER_61_668 VDD VSS / sg13g2_fill_1
XFILLER_61_674 VDD VSS / sg13g2_fill_2
XFILLER_61_676 VDD VSS / sg13g2_fill_1
XFILLER_61_704 VDD VSS / sg13g2_fill_2
XFILLER_61_706 VDD VSS / sg13g2_fill_1
XFILLER_61_71 VDD VSS / sg13g2_fill_1
XFILLER_62_0 VDD VSS / sg13g2_decap_4
XFILLER_62_155 VDD VSS / sg13g2_decap_8
XFILLER_62_162 VDD VSS / sg13g2_decap_8
XFILLER_62_169 VDD VSS / sg13g2_fill_2
XFILLER_62_265 VDD VSS / sg13g2_fill_1
XFILLER_62_287 VDD VSS / sg13g2_fill_2
XFILLER_62_31 VDD VSS / sg13g2_fill_2
XFILLER_62_33 VDD VSS / sg13g2_fill_1
XFILLER_62_395 VDD VSS / sg13g2_decap_8
XFILLER_62_402 VDD VSS / sg13g2_decap_8
XFILLER_62_409 VDD VSS / sg13g2_fill_1
XFILLER_62_418 VDD VSS / sg13g2_fill_1
XFILLER_62_440 VDD VSS / sg13g2_decap_4
XFILLER_62_444 VDD VSS / sg13g2_fill_1
XFILLER_62_450 VDD VSS / sg13g2_decap_4
XFILLER_62_459 VDD VSS / sg13g2_fill_1
XFILLER_62_486 VDD VSS / sg13g2_fill_2
XFILLER_62_488 VDD VSS / sg13g2_fill_1
XFILLER_62_498 VDD VSS / sg13g2_decap_4
XFILLER_62_502 VDD VSS / sg13g2_fill_2
XFILLER_62_509 VDD VSS / sg13g2_fill_2
XFILLER_62_520 VDD VSS / sg13g2_fill_1
XFILLER_62_534 VDD VSS / sg13g2_fill_2
XFILLER_62_536 VDD VSS / sg13g2_fill_1
XFILLER_62_543 VDD VSS / sg13g2_fill_2
XFILLER_62_545 VDD VSS / sg13g2_fill_1
XFILLER_62_561 VDD VSS / sg13g2_decap_8
XFILLER_62_568 VDD VSS / sg13g2_decap_8
XFILLER_62_635 VDD VSS / sg13g2_decap_4
XFILLER_62_639 VDD VSS / sg13g2_fill_1
XFILLER_62_656 VDD VSS / sg13g2_fill_1
XFILLER_62_685 VDD VSS / sg13g2_fill_2
XFILLER_62_714 VDD VSS / sg13g2_fill_2
XFILLER_62_77 VDD VSS / sg13g2_fill_2
XFILLER_63_0 VDD VSS / sg13g2_decap_8
XFILLER_63_140 VDD VSS / sg13g2_fill_2
XFILLER_63_151 VDD VSS / sg13g2_decap_8
XFILLER_63_158 VDD VSS / sg13g2_decap_8
XFILLER_63_165 VDD VSS / sg13g2_decap_4
XFILLER_63_169 VDD VSS / sg13g2_fill_2
XFILLER_63_248 VDD VSS / sg13g2_decap_4
XFILLER_63_252 VDD VSS / sg13g2_fill_2
XFILLER_63_286 VDD VSS / sg13g2_fill_2
XFILLER_63_297 VDD VSS / sg13g2_decap_8
XFILLER_63_304 VDD VSS / sg13g2_fill_2
XFILLER_63_406 VDD VSS / sg13g2_decap_4
XFILLER_63_410 VDD VSS / sg13g2_fill_1
XFILLER_63_42 VDD VSS / sg13g2_fill_2
XFILLER_63_44 VDD VSS / sg13g2_fill_1
XFILLER_63_444 VDD VSS / sg13g2_decap_4
XFILLER_63_448 VDD VSS / sg13g2_fill_1
XFILLER_63_492 VDD VSS / sg13g2_fill_1
XFILLER_63_516 VDD VSS / sg13g2_fill_2
XFILLER_63_518 VDD VSS / sg13g2_fill_1
XFILLER_63_555 VDD VSS / sg13g2_decap_4
XFILLER_63_559 VDD VSS / sg13g2_fill_2
XFILLER_63_578 VDD VSS / sg13g2_decap_4
XFILLER_63_622 VDD VSS / sg13g2_decap_4
XFILLER_63_626 VDD VSS / sg13g2_fill_2
XFILLER_63_634 VDD VSS / sg13g2_decap_8
XFILLER_63_641 VDD VSS / sg13g2_decap_8
XFILLER_63_648 VDD VSS / sg13g2_fill_1
XFILLER_63_7 VDD VSS / sg13g2_fill_2
XFILLER_63_9 VDD VSS / sg13g2_fill_1
XFILLER_64_156 VDD VSS / sg13g2_decap_8
XFILLER_64_163 VDD VSS / sg13g2_decap_8
XFILLER_64_170 VDD VSS / sg13g2_decap_8
XFILLER_64_185 VDD VSS / sg13g2_fill_1
XFILLER_64_193 VDD VSS / sg13g2_decap_4
XFILLER_64_216 VDD VSS / sg13g2_fill_1
XFILLER_64_226 VDD VSS / sg13g2_fill_2
XFILLER_64_228 VDD VSS / sg13g2_fill_1
XFILLER_64_234 VDD VSS / sg13g2_fill_1
XFILLER_64_262 VDD VSS / sg13g2_decap_4
XFILLER_64_266 VDD VSS / sg13g2_fill_2
XFILLER_64_285 VDD VSS / sg13g2_fill_1
XFILLER_64_291 VDD VSS / sg13g2_decap_8
XFILLER_64_298 VDD VSS / sg13g2_fill_2
XFILLER_64_300 VDD VSS / sg13g2_fill_1
XFILLER_64_306 VDD VSS / sg13g2_decap_8
XFILLER_64_31 VDD VSS / sg13g2_decap_4
XFILLER_64_313 VDD VSS / sg13g2_fill_2
XFILLER_64_35 VDD VSS / sg13g2_fill_1
XFILLER_64_357 VDD VSS / sg13g2_decap_8
XFILLER_64_364 VDD VSS / sg13g2_decap_8
XFILLER_64_371 VDD VSS / sg13g2_fill_2
XFILLER_64_373 VDD VSS / sg13g2_fill_1
XFILLER_64_387 VDD VSS / sg13g2_fill_2
XFILLER_64_40 VDD VSS / sg13g2_decap_8
XFILLER_64_461 VDD VSS / sg13g2_fill_1
XFILLER_64_47 VDD VSS / sg13g2_fill_2
XFILLER_64_49 VDD VSS / sg13g2_fill_1
XFILLER_64_504 VDD VSS / sg13g2_fill_2
XFILLER_64_510 VDD VSS / sg13g2_fill_2
XFILLER_64_522 VDD VSS / sg13g2_decap_8
XFILLER_64_529 VDD VSS / sg13g2_decap_4
XFILLER_64_533 VDD VSS / sg13g2_fill_1
XFILLER_64_54 VDD VSS / sg13g2_fill_2
XFILLER_64_545 VDD VSS / sg13g2_decap_8
XFILLER_64_552 VDD VSS / sg13g2_fill_1
XFILLER_64_563 VDD VSS / sg13g2_decap_4
XFILLER_64_606 VDD VSS / sg13g2_fill_1
XFILLER_64_628 VDD VSS / sg13g2_fill_2
XFILLER_64_657 VDD VSS / sg13g2_fill_2
XFILLER_64_702 VDD VSS / sg13g2_fill_2
XFILLER_64_704 VDD VSS / sg13g2_fill_1
XFILLER_64_713 VDD VSS / sg13g2_fill_2
XFILLER_64_715 VDD VSS / sg13g2_fill_1
XFILLER_64_80 VDD VSS / sg13g2_fill_2
XFILLER_64_82 VDD VSS / sg13g2_fill_1
XFILLER_65_0 VDD VSS / sg13g2_fill_2
XFILLER_65_100 VDD VSS / sg13g2_fill_2
XFILLER_65_102 VDD VSS / sg13g2_fill_1
XFILLER_65_131 VDD VSS / sg13g2_decap_8
XFILLER_65_138 VDD VSS / sg13g2_decap_8
XFILLER_65_154 VDD VSS / sg13g2_fill_2
XFILLER_65_192 VDD VSS / sg13g2_decap_8
XFILLER_65_199 VDD VSS / sg13g2_decap_4
XFILLER_65_2 VDD VSS / sg13g2_fill_1
XFILLER_65_207 VDD VSS / sg13g2_decap_4
XFILLER_65_211 VDD VSS / sg13g2_fill_1
XFILLER_65_216 VDD VSS / sg13g2_fill_1
XFILLER_65_220 VDD VSS / sg13g2_fill_1
XFILLER_65_248 VDD VSS / sg13g2_decap_8
XFILLER_65_255 VDD VSS / sg13g2_decap_8
XFILLER_65_262 VDD VSS / sg13g2_decap_4
XFILLER_65_266 VDD VSS / sg13g2_fill_2
XFILLER_65_285 VDD VSS / sg13g2_decap_8
XFILLER_65_292 VDD VSS / sg13g2_decap_8
XFILLER_65_299 VDD VSS / sg13g2_decap_8
XFILLER_65_30 VDD VSS / sg13g2_decap_8
XFILLER_65_306 VDD VSS / sg13g2_decap_8
XFILLER_65_313 VDD VSS / sg13g2_decap_8
XFILLER_65_320 VDD VSS / sg13g2_decap_8
XFILLER_65_327 VDD VSS / sg13g2_decap_8
XFILLER_65_334 VDD VSS / sg13g2_decap_8
XFILLER_65_341 VDD VSS / sg13g2_fill_2
XFILLER_65_346 VDD VSS / sg13g2_fill_1
XFILLER_65_352 VDD VSS / sg13g2_decap_8
XFILLER_65_363 VDD VSS / sg13g2_decap_4
XFILLER_65_367 VDD VSS / sg13g2_fill_2
XFILLER_65_37 VDD VSS / sg13g2_decap_8
XFILLER_65_434 VDD VSS / sg13g2_decap_8
XFILLER_65_44 VDD VSS / sg13g2_decap_8
XFILLER_65_441 VDD VSS / sg13g2_decap_4
XFILLER_65_445 VDD VSS / sg13g2_fill_2
XFILLER_65_470 VDD VSS / sg13g2_fill_1
XFILLER_65_492 VDD VSS / sg13g2_fill_1
XFILLER_65_502 VDD VSS / sg13g2_fill_1
XFILLER_65_508 VDD VSS / sg13g2_decap_4
XFILLER_65_51 VDD VSS / sg13g2_fill_2
XFILLER_65_512 VDD VSS / sg13g2_fill_2
XFILLER_65_528 VDD VSS / sg13g2_decap_4
XFILLER_65_532 VDD VSS / sg13g2_fill_1
XFILLER_65_552 VDD VSS / sg13g2_decap_8
XFILLER_65_559 VDD VSS / sg13g2_decap_8
XFILLER_65_566 VDD VSS / sg13g2_decap_8
XFILLER_65_57 VDD VSS / sg13g2_fill_1
XFILLER_65_573 VDD VSS / sg13g2_decap_8
XFILLER_65_580 VDD VSS / sg13g2_decap_4
XFILLER_65_606 VDD VSS / sg13g2_decap_8
XFILLER_65_613 VDD VSS / sg13g2_fill_2
XFILLER_65_625 VDD VSS / sg13g2_decap_4
XFILLER_65_656 VDD VSS / sg13g2_decap_4
XFILLER_65_669 VDD VSS / sg13g2_fill_2
XFILLER_65_671 VDD VSS / sg13g2_fill_1
XFILLER_65_679 VDD VSS / sg13g2_fill_1
XFILLER_65_68 VDD VSS / sg13g2_fill_1
XFILLER_65_688 VDD VSS / sg13g2_fill_2
XFILLER_65_698 VDD VSS / sg13g2_fill_2
XFILLER_66_0 VDD VSS / sg13g2_decap_8
XFILLER_66_125 VDD VSS / sg13g2_fill_1
XFILLER_66_160 VDD VSS / sg13g2_decap_8
XFILLER_66_167 VDD VSS / sg13g2_decap_4
XFILLER_66_198 VDD VSS / sg13g2_decap_8
XFILLER_66_205 VDD VSS / sg13g2_decap_4
XFILLER_66_209 VDD VSS / sg13g2_fill_2
XFILLER_66_238 VDD VSS / sg13g2_decap_8
XFILLER_66_245 VDD VSS / sg13g2_decap_8
XFILLER_66_252 VDD VSS / sg13g2_decap_4
XFILLER_66_256 VDD VSS / sg13g2_fill_2
XFILLER_66_266 VDD VSS / sg13g2_fill_1
XFILLER_66_275 VDD VSS / sg13g2_fill_2
XFILLER_66_306 VDD VSS / sg13g2_decap_8
XFILLER_66_313 VDD VSS / sg13g2_decap_8
XFILLER_66_320 VDD VSS / sg13g2_decap_4
XFILLER_66_382 VDD VSS / sg13g2_fill_1
XFILLER_66_41 VDD VSS / sg13g2_decap_8
XFILLER_66_413 VDD VSS / sg13g2_decap_8
XFILLER_66_420 VDD VSS / sg13g2_fill_2
XFILLER_66_422 VDD VSS / sg13g2_fill_1
XFILLER_66_431 VDD VSS / sg13g2_fill_2
XFILLER_66_436 VDD VSS / sg13g2_decap_8
XFILLER_66_443 VDD VSS / sg13g2_decap_4
XFILLER_66_463 VDD VSS / sg13g2_fill_1
XFILLER_66_48 VDD VSS / sg13g2_decap_8
XFILLER_66_505 VDD VSS / sg13g2_decap_8
XFILLER_66_512 VDD VSS / sg13g2_decap_8
XFILLER_66_519 VDD VSS / sg13g2_decap_4
XFILLER_66_55 VDD VSS / sg13g2_decap_4
XFILLER_66_560 VDD VSS / sg13g2_decap_8
XFILLER_66_567 VDD VSS / sg13g2_decap_8
XFILLER_66_574 VDD VSS / sg13g2_decap_4
XFILLER_66_578 VDD VSS / sg13g2_fill_1
XFILLER_66_589 VDD VSS / sg13g2_fill_2
XFILLER_66_608 VDD VSS / sg13g2_decap_4
XFILLER_66_622 VDD VSS / sg13g2_decap_4
XFILLER_66_653 VDD VSS / sg13g2_decap_8
XFILLER_66_660 VDD VSS / sg13g2_decap_8
XFILLER_66_667 VDD VSS / sg13g2_decap_8
XFILLER_66_674 VDD VSS / sg13g2_decap_4
XFILLER_66_678 VDD VSS / sg13g2_fill_1
XFILLER_66_7 VDD VSS / sg13g2_decap_8
XFILLER_66_714 VDD VSS / sg13g2_fill_2
XFILLER_66_77 VDD VSS / sg13g2_fill_2
XFILLER_67_0 VDD VSS / sg13g2_fill_2
XFILLER_67_128 VDD VSS / sg13g2_decap_8
XFILLER_67_135 VDD VSS / sg13g2_decap_8
XFILLER_67_142 VDD VSS / sg13g2_decap_8
XFILLER_67_149 VDD VSS / sg13g2_decap_8
XFILLER_67_156 VDD VSS / sg13g2_decap_8
XFILLER_67_163 VDD VSS / sg13g2_decap_8
XFILLER_67_170 VDD VSS / sg13g2_fill_1
XFILLER_67_198 VDD VSS / sg13g2_fill_1
XFILLER_67_2 VDD VSS / sg13g2_fill_1
XFILLER_67_211 VDD VSS / sg13g2_fill_2
XFILLER_67_237 VDD VSS / sg13g2_decap_4
XFILLER_67_241 VDD VSS / sg13g2_fill_2
XFILLER_67_270 VDD VSS / sg13g2_fill_2
XFILLER_67_304 VDD VSS / sg13g2_fill_2
XFILLER_67_318 VDD VSS / sg13g2_decap_8
XFILLER_67_325 VDD VSS / sg13g2_decap_8
XFILLER_67_332 VDD VSS / sg13g2_fill_2
XFILLER_67_334 VDD VSS / sg13g2_fill_1
XFILLER_67_394 VDD VSS / sg13g2_decap_8
XFILLER_67_401 VDD VSS / sg13g2_decap_8
XFILLER_67_408 VDD VSS / sg13g2_decap_8
XFILLER_67_415 VDD VSS / sg13g2_fill_2
XFILLER_67_422 VDD VSS / sg13g2_fill_2
XFILLER_67_424 VDD VSS / sg13g2_fill_1
XFILLER_67_43 VDD VSS / sg13g2_decap_8
XFILLER_67_430 VDD VSS / sg13g2_decap_8
XFILLER_67_437 VDD VSS / sg13g2_decap_4
XFILLER_67_441 VDD VSS / sg13g2_fill_2
XFILLER_67_481 VDD VSS / sg13g2_fill_1
XFILLER_67_486 VDD VSS / sg13g2_decap_8
XFILLER_67_497 VDD VSS / sg13g2_fill_2
XFILLER_67_50 VDD VSS / sg13g2_decap_8
XFILLER_67_503 VDD VSS / sg13g2_decap_8
XFILLER_67_510 VDD VSS / sg13g2_decap_8
XFILLER_67_517 VDD VSS / sg13g2_decap_8
XFILLER_67_524 VDD VSS / sg13g2_fill_2
XFILLER_67_526 VDD VSS / sg13g2_fill_1
XFILLER_67_562 VDD VSS / sg13g2_decap_8
XFILLER_67_569 VDD VSS / sg13g2_fill_2
XFILLER_67_57 VDD VSS / sg13g2_decap_4
XFILLER_67_584 VDD VSS / sg13g2_fill_1
XFILLER_67_61 VDD VSS / sg13g2_fill_2
XFILLER_67_612 VDD VSS / sg13g2_decap_8
XFILLER_67_619 VDD VSS / sg13g2_decap_8
XFILLER_67_626 VDD VSS / sg13g2_decap_8
XFILLER_67_633 VDD VSS / sg13g2_decap_8
XFILLER_67_640 VDD VSS / sg13g2_decap_8
XFILLER_67_647 VDD VSS / sg13g2_decap_8
XFILLER_67_654 VDD VSS / sg13g2_decap_8
XFILLER_67_661 VDD VSS / sg13g2_decap_4
XFILLER_67_665 VDD VSS / sg13g2_fill_2
XFILLER_67_70 VDD VSS / sg13g2_fill_2
XFILLER_67_714 VDD VSS / sg13g2_fill_2
XFILLER_67_72 VDD VSS / sg13g2_fill_1
XFILLER_67_77 VDD VSS / sg13g2_fill_1
XFILLER_67_82 VDD VSS / sg13g2_fill_2
XFILLER_68_141 VDD VSS / sg13g2_decap_8
XFILLER_68_148 VDD VSS / sg13g2_decap_8
XFILLER_68_155 VDD VSS / sg13g2_decap_8
XFILLER_68_162 VDD VSS / sg13g2_fill_1
XFILLER_68_234 VDD VSS / sg13g2_fill_1
XFILLER_68_311 VDD VSS / sg13g2_decap_8
XFILLER_68_318 VDD VSS / sg13g2_decap_8
XFILLER_68_337 VDD VSS / sg13g2_fill_2
XFILLER_68_339 VDD VSS / sg13g2_fill_1
XFILLER_68_344 VDD VSS / sg13g2_decap_8
XFILLER_68_351 VDD VSS / sg13g2_decap_4
XFILLER_68_373 VDD VSS / sg13g2_decap_8
XFILLER_68_380 VDD VSS / sg13g2_decap_4
XFILLER_68_390 VDD VSS / sg13g2_decap_8
XFILLER_68_397 VDD VSS / sg13g2_decap_8
XFILLER_68_404 VDD VSS / sg13g2_decap_8
XFILLER_68_411 VDD VSS / sg13g2_decap_8
XFILLER_68_426 VDD VSS / sg13g2_fill_1
XFILLER_68_431 VDD VSS / sg13g2_decap_8
XFILLER_68_438 VDD VSS / sg13g2_decap_4
XFILLER_68_442 VDD VSS / sg13g2_fill_2
XFILLER_68_45 VDD VSS / sg13g2_fill_2
XFILLER_68_47 VDD VSS / sg13g2_fill_1
XFILLER_68_474 VDD VSS / sg13g2_decap_8
XFILLER_68_481 VDD VSS / sg13g2_decap_8
XFILLER_68_488 VDD VSS / sg13g2_decap_4
XFILLER_68_492 VDD VSS / sg13g2_fill_1
XFILLER_68_496 VDD VSS / sg13g2_decap_8
XFILLER_68_508 VDD VSS / sg13g2_decap_8
XFILLER_68_515 VDD VSS / sg13g2_decap_8
XFILLER_68_522 VDD VSS / sg13g2_decap_8
XFILLER_68_529 VDD VSS / sg13g2_decap_4
XFILLER_68_533 VDD VSS / sg13g2_fill_1
XFILLER_68_542 VDD VSS / sg13g2_decap_8
XFILLER_68_552 VDD VSS / sg13g2_decap_8
XFILLER_68_559 VDD VSS / sg13g2_fill_2
XFILLER_68_564 VDD VSS / sg13g2_fill_2
XFILLER_68_566 VDD VSS / sg13g2_fill_1
XFILLER_68_621 VDD VSS / sg13g2_decap_4
XFILLER_68_625 VDD VSS / sg13g2_fill_2
XFILLER_68_657 VDD VSS / sg13g2_decap_8
XFILLER_68_664 VDD VSS / sg13g2_fill_2
XFILLER_68_666 VDD VSS / sg13g2_fill_1
XFILLER_68_671 VDD VSS / sg13g2_fill_1
XFILLER_68_75 VDD VSS / sg13g2_fill_1
XFILLER_68_85 VDD VSS / sg13g2_fill_2
XFILLER_69_109 VDD VSS / sg13g2_decap_8
XFILLER_69_116 VDD VSS / sg13g2_decap_8
XFILLER_69_123 VDD VSS / sg13g2_decap_8
XFILLER_69_130 VDD VSS / sg13g2_decap_8
XFILLER_69_137 VDD VSS / sg13g2_decap_8
XFILLER_69_144 VDD VSS / sg13g2_decap_8
XFILLER_69_151 VDD VSS / sg13g2_decap_4
XFILLER_69_155 VDD VSS / sg13g2_fill_2
XFILLER_69_189 VDD VSS / sg13g2_decap_4
XFILLER_69_209 VDD VSS / sg13g2_fill_2
XFILLER_69_211 VDD VSS / sg13g2_fill_1
XFILLER_69_218 VDD VSS / sg13g2_fill_1
XFILLER_69_227 VDD VSS / sg13g2_fill_2
XFILLER_69_269 VDD VSS / sg13g2_fill_1
XFILLER_69_302 VDD VSS / sg13g2_decap_8
XFILLER_69_309 VDD VSS / sg13g2_decap_4
XFILLER_69_31 VDD VSS / sg13g2_decap_4
XFILLER_69_313 VDD VSS / sg13g2_fill_2
XFILLER_69_35 VDD VSS / sg13g2_fill_1
XFILLER_69_352 VDD VSS / sg13g2_decap_8
XFILLER_69_359 VDD VSS / sg13g2_decap_8
XFILLER_69_366 VDD VSS / sg13g2_decap_8
XFILLER_69_373 VDD VSS / sg13g2_decap_8
XFILLER_69_380 VDD VSS / sg13g2_decap_8
XFILLER_69_387 VDD VSS / sg13g2_fill_2
XFILLER_69_389 VDD VSS / sg13g2_fill_1
XFILLER_69_399 VDD VSS / sg13g2_decap_4
XFILLER_69_403 VDD VSS / sg13g2_fill_2
XFILLER_69_409 VDD VSS / sg13g2_decap_4
XFILLER_69_437 VDD VSS / sg13g2_decap_8
XFILLER_69_444 VDD VSS / sg13g2_fill_2
XFILLER_69_449 VDD VSS / sg13g2_fill_1
XFILLER_69_45 VDD VSS / sg13g2_decap_8
XFILLER_69_454 VDD VSS / sg13g2_fill_1
XFILLER_69_468 VDD VSS / sg13g2_decap_8
XFILLER_69_475 VDD VSS / sg13g2_decap_8
XFILLER_69_482 VDD VSS / sg13g2_decap_8
XFILLER_69_52 VDD VSS / sg13g2_decap_8
XFILLER_69_523 VDD VSS / sg13g2_decap_8
XFILLER_69_530 VDD VSS / sg13g2_fill_2
XFILLER_69_559 VDD VSS / sg13g2_fill_1
XFILLER_69_569 VDD VSS / sg13g2_fill_2
XFILLER_69_571 VDD VSS / sg13g2_fill_1
XFILLER_69_581 VDD VSS / sg13g2_decap_4
XFILLER_69_59 VDD VSS / sg13g2_decap_8
XFILLER_69_647 VDD VSS / sg13g2_decap_4
XFILLER_69_651 VDD VSS / sg13g2_fill_1
XFILLER_69_66 VDD VSS / sg13g2_decap_8
XFILLER_69_670 VDD VSS / sg13g2_fill_1
XFILLER_69_702 VDD VSS / sg13g2_fill_2
XFILLER_69_73 VDD VSS / sg13g2_decap_8
XFILLER_69_80 VDD VSS / sg13g2_fill_2
XFILLER_6_0 VDD VSS / sg13g2_decap_4
XFILLER_6_126 VDD VSS / sg13g2_decap_8
XFILLER_6_133 VDD VSS / sg13g2_decap_8
XFILLER_6_152 VDD VSS / sg13g2_decap_8
XFILLER_6_159 VDD VSS / sg13g2_decap_4
XFILLER_6_243 VDD VSS / sg13g2_fill_2
XFILLER_6_245 VDD VSS / sg13g2_fill_1
XFILLER_6_284 VDD VSS / sg13g2_fill_2
XFILLER_6_31 VDD VSS / sg13g2_fill_2
XFILLER_6_361 VDD VSS / sg13g2_fill_1
XFILLER_6_462 VDD VSS / sg13g2_fill_2
XFILLER_6_576 VDD VSS / sg13g2_fill_1
XFILLER_6_60 VDD VSS / sg13g2_decap_8
XFILLER_6_67 VDD VSS / sg13g2_decap_8
XFILLER_6_74 VDD VSS / sg13g2_fill_2
XFILLER_6_80 VDD VSS / sg13g2_decap_8
XFILLER_6_87 VDD VSS / sg13g2_fill_1
XFILLER_70_0 VDD VSS / sg13g2_fill_2
XFILLER_70_132 VDD VSS / sg13g2_decap_8
XFILLER_70_139 VDD VSS / sg13g2_decap_8
XFILLER_70_146 VDD VSS / sg13g2_decap_8
XFILLER_70_153 VDD VSS / sg13g2_decap_8
XFILLER_70_160 VDD VSS / sg13g2_decap_4
XFILLER_70_198 VDD VSS / sg13g2_decap_8
XFILLER_70_205 VDD VSS / sg13g2_fill_1
XFILLER_70_237 VDD VSS / sg13g2_fill_2
XFILLER_70_274 VDD VSS / sg13g2_fill_2
XFILLER_70_276 VDD VSS / sg13g2_fill_1
XFILLER_70_289 VDD VSS / sg13g2_fill_1
XFILLER_70_349 VDD VSS / sg13g2_decap_4
XFILLER_70_353 VDD VSS / sg13g2_fill_2
XFILLER_70_360 VDD VSS / sg13g2_decap_8
XFILLER_70_367 VDD VSS / sg13g2_decap_8
XFILLER_70_374 VDD VSS / sg13g2_fill_1
XFILLER_70_399 VDD VSS / sg13g2_fill_2
XFILLER_70_401 VDD VSS / sg13g2_fill_1
XFILLER_70_449 VDD VSS / sg13g2_decap_8
XFILLER_70_456 VDD VSS / sg13g2_decap_8
XFILLER_70_463 VDD VSS / sg13g2_fill_1
XFILLER_70_468 VDD VSS / sg13g2_fill_1
XFILLER_70_47 VDD VSS / sg13g2_decap_8
XFILLER_70_473 VDD VSS / sg13g2_decap_8
XFILLER_70_480 VDD VSS / sg13g2_fill_2
XFILLER_70_517 VDD VSS / sg13g2_fill_2
XFILLER_70_524 VDD VSS / sg13g2_fill_2
XFILLER_70_54 VDD VSS / sg13g2_decap_8
XFILLER_70_557 VDD VSS / sg13g2_decap_8
XFILLER_70_564 VDD VSS / sg13g2_decap_4
XFILLER_70_601 VDD VSS / sg13g2_fill_2
XFILLER_70_608 VDD VSS / sg13g2_fill_1
XFILLER_70_61 VDD VSS / sg13g2_fill_2
XFILLER_70_632 VDD VSS / sg13g2_fill_1
XFILLER_70_665 VDD VSS / sg13g2_fill_1
XFILLER_70_67 VDD VSS / sg13g2_decap_8
XFILLER_70_698 VDD VSS / sg13g2_decap_4
XFILLER_70_706 VDD VSS / sg13g2_fill_2
XFILLER_70_708 VDD VSS / sg13g2_fill_1
XFILLER_70_74 VDD VSS / sg13g2_decap_8
XFILLER_70_81 VDD VSS / sg13g2_decap_8
XFILLER_70_88 VDD VSS / sg13g2_decap_8
XFILLER_70_95 VDD VSS / sg13g2_fill_2
XFILLER_70_97 VDD VSS / sg13g2_fill_1
XFILLER_71_103 VDD VSS / sg13g2_fill_2
XFILLER_71_105 VDD VSS / sg13g2_fill_1
XFILLER_71_115 VDD VSS / sg13g2_decap_4
XFILLER_71_124 VDD VSS / sg13g2_decap_8
XFILLER_71_131 VDD VSS / sg13g2_decap_8
XFILLER_71_138 VDD VSS / sg13g2_decap_8
XFILLER_71_145 VDD VSS / sg13g2_decap_8
XFILLER_71_152 VDD VSS / sg13g2_fill_2
XFILLER_71_158 VDD VSS / sg13g2_decap_8
XFILLER_71_165 VDD VSS / sg13g2_decap_8
XFILLER_71_172 VDD VSS / sg13g2_decap_4
XFILLER_71_203 VDD VSS / sg13g2_decap_8
XFILLER_71_210 VDD VSS / sg13g2_fill_2
XFILLER_71_222 VDD VSS / sg13g2_fill_2
XFILLER_71_276 VDD VSS / sg13g2_fill_1
XFILLER_71_308 VDD VSS / sg13g2_decap_8
XFILLER_71_315 VDD VSS / sg13g2_fill_2
XFILLER_71_334 VDD VSS / sg13g2_decap_8
XFILLER_71_341 VDD VSS / sg13g2_fill_1
XFILLER_71_379 VDD VSS / sg13g2_fill_1
XFILLER_71_389 VDD VSS / sg13g2_fill_1
XFILLER_71_414 VDD VSS / sg13g2_fill_1
XFILLER_71_436 VDD VSS / sg13g2_decap_8
XFILLER_71_443 VDD VSS / sg13g2_decap_8
XFILLER_71_450 VDD VSS / sg13g2_decap_8
XFILLER_71_457 VDD VSS / sg13g2_fill_2
XFILLER_71_501 VDD VSS / sg13g2_fill_2
XFILLER_71_534 VDD VSS / sg13g2_fill_1
XFILLER_71_550 VDD VSS / sg13g2_decap_8
XFILLER_71_557 VDD VSS / sg13g2_decap_8
XFILLER_71_564 VDD VSS / sg13g2_decap_4
XFILLER_71_574 VDD VSS / sg13g2_decap_8
XFILLER_71_581 VDD VSS / sg13g2_decap_8
XFILLER_71_588 VDD VSS / sg13g2_decap_8
XFILLER_71_603 VDD VSS / sg13g2_decap_4
XFILLER_71_607 VDD VSS / sg13g2_fill_1
XFILLER_71_612 VDD VSS / sg13g2_fill_1
XFILLER_71_621 VDD VSS / sg13g2_decap_4
XFILLER_71_625 VDD VSS / sg13g2_fill_1
XFILLER_71_630 VDD VSS / sg13g2_decap_8
XFILLER_71_637 VDD VSS / sg13g2_decap_8
XFILLER_71_644 VDD VSS / sg13g2_decap_8
XFILLER_71_651 VDD VSS / sg13g2_decap_8
XFILLER_71_658 VDD VSS / sg13g2_decap_4
XFILLER_71_667 VDD VSS / sg13g2_decap_4
XFILLER_71_707 VDD VSS / sg13g2_decap_8
XFILLER_71_71 VDD VSS / sg13g2_decap_8
XFILLER_71_714 VDD VSS / sg13g2_fill_2
XFILLER_71_78 VDD VSS / sg13g2_decap_8
XFILLER_71_85 VDD VSS / sg13g2_decap_8
XFILLER_71_92 VDD VSS / sg13g2_fill_1
XFILLER_71_97 VDD VSS / sg13g2_fill_1
XFILLER_72_0 VDD VSS / sg13g2_fill_2
XFILLER_72_118 VDD VSS / sg13g2_decap_8
XFILLER_72_125 VDD VSS / sg13g2_decap_8
XFILLER_72_164 VDD VSS / sg13g2_fill_2
XFILLER_72_169 VDD VSS / sg13g2_fill_2
XFILLER_72_230 VDD VSS / sg13g2_fill_1
XFILLER_72_355 VDD VSS / sg13g2_fill_1
XFILLER_72_422 VDD VSS / sg13g2_fill_1
XFILLER_72_431 VDD VSS / sg13g2_decap_8
XFILLER_72_438 VDD VSS / sg13g2_decap_8
XFILLER_72_445 VDD VSS / sg13g2_decap_8
XFILLER_72_483 VDD VSS / sg13g2_decap_8
XFILLER_72_490 VDD VSS / sg13g2_decap_4
XFILLER_72_502 VDD VSS / sg13g2_fill_1
XFILLER_72_512 VDD VSS / sg13g2_fill_1
XFILLER_72_523 VDD VSS / sg13g2_decap_8
XFILLER_72_530 VDD VSS / sg13g2_decap_8
XFILLER_72_537 VDD VSS / sg13g2_decap_8
XFILLER_72_544 VDD VSS / sg13g2_decap_4
XFILLER_72_548 VDD VSS / sg13g2_fill_1
XFILLER_72_555 VDD VSS / sg13g2_decap_4
XFILLER_72_602 VDD VSS / sg13g2_fill_2
XFILLER_72_604 VDD VSS / sg13g2_fill_1
XFILLER_72_642 VDD VSS / sg13g2_decap_4
XFILLER_72_646 VDD VSS / sg13g2_fill_1
XFILLER_72_650 VDD VSS / sg13g2_fill_2
XFILLER_72_652 VDD VSS / sg13g2_fill_1
XFILLER_72_666 VDD VSS / sg13g2_fill_2
XFILLER_72_668 VDD VSS / sg13g2_fill_1
XFILLER_72_682 VDD VSS / sg13g2_fill_2
XFILLER_72_684 VDD VSS / sg13g2_fill_1
XFILLER_72_70 VDD VSS / sg13g2_fill_2
XFILLER_72_712 VDD VSS / sg13g2_decap_4
XFILLER_72_72 VDD VSS / sg13g2_fill_1
XFILLER_72_86 VDD VSS / sg13g2_fill_2
XFILLER_73_105 VDD VSS / sg13g2_fill_2
XFILLER_73_124 VDD VSS / sg13g2_fill_1
XFILLER_73_132 VDD VSS / sg13g2_fill_1
XFILLER_73_138 VDD VSS / sg13g2_decap_8
XFILLER_73_155 VDD VSS / sg13g2_decap_4
XFILLER_73_159 VDD VSS / sg13g2_fill_1
XFILLER_73_192 VDD VSS / sg13g2_decap_8
XFILLER_73_199 VDD VSS / sg13g2_decap_8
XFILLER_73_206 VDD VSS / sg13g2_decap_8
XFILLER_73_213 VDD VSS / sg13g2_fill_1
XFILLER_73_300 VDD VSS / sg13g2_fill_2
XFILLER_73_366 VDD VSS / sg13g2_fill_2
XFILLER_73_423 VDD VSS / sg13g2_decap_8
XFILLER_73_430 VDD VSS / sg13g2_decap_8
XFILLER_73_437 VDD VSS / sg13g2_fill_2
XFILLER_73_439 VDD VSS / sg13g2_fill_1
XFILLER_73_484 VDD VSS / sg13g2_decap_8
XFILLER_73_491 VDD VSS / sg13g2_decap_8
XFILLER_73_498 VDD VSS / sg13g2_decap_4
XFILLER_73_556 VDD VSS / sg13g2_fill_1
XFILLER_73_588 VDD VSS / sg13g2_fill_1
XFILLER_73_616 VDD VSS / sg13g2_fill_1
XFILLER_73_631 VDD VSS / sg13g2_decap_4
XFILLER_73_635 VDD VSS / sg13g2_fill_1
XFILLER_73_668 VDD VSS / sg13g2_fill_2
XFILLER_73_675 VDD VSS / sg13g2_fill_1
XFILLER_73_699 VDD VSS / sg13g2_decap_8
XFILLER_73_706 VDD VSS / sg13g2_decap_8
XFILLER_73_713 VDD VSS / sg13g2_fill_2
XFILLER_73_715 VDD VSS / sg13g2_fill_1
XFILLER_73_72 VDD VSS / sg13g2_fill_1
XFILLER_74_118 VDD VSS / sg13g2_fill_1
XFILLER_74_138 VDD VSS / sg13g2_fill_2
XFILLER_74_148 VDD VSS / sg13g2_decap_8
XFILLER_74_155 VDD VSS / sg13g2_decap_8
XFILLER_74_162 VDD VSS / sg13g2_fill_2
XFILLER_74_208 VDD VSS / sg13g2_fill_1
XFILLER_74_348 VDD VSS / sg13g2_fill_2
XFILLER_74_408 VDD VSS / sg13g2_fill_1
XFILLER_74_413 VDD VSS / sg13g2_decap_8
XFILLER_74_420 VDD VSS / sg13g2_decap_8
XFILLER_74_427 VDD VSS / sg13g2_decap_8
XFILLER_74_434 VDD VSS / sg13g2_fill_2
XFILLER_74_44 VDD VSS / sg13g2_fill_1
XFILLER_74_552 VDD VSS / sg13g2_fill_1
XFILLER_74_578 VDD VSS / sg13g2_decap_8
XFILLER_74_585 VDD VSS / sg13g2_decap_8
XFILLER_74_592 VDD VSS / sg13g2_fill_1
XFILLER_74_650 VDD VSS / sg13g2_decap_8
XFILLER_74_657 VDD VSS / sg13g2_decap_4
XFILLER_74_661 VDD VSS / sg13g2_fill_1
XFILLER_74_674 VDD VSS / sg13g2_decap_8
XFILLER_74_681 VDD VSS / sg13g2_fill_1
XFILLER_74_714 VDD VSS / sg13g2_fill_2
XFILLER_74_76 VDD VSS / sg13g2_fill_1
XFILLER_74_81 VDD VSS / sg13g2_fill_2
XFILLER_75_0 VDD VSS / sg13g2_decap_8
XFILLER_75_123 VDD VSS / sg13g2_fill_1
XFILLER_75_144 VDD VSS / sg13g2_decap_8
XFILLER_75_151 VDD VSS / sg13g2_decap_8
XFILLER_75_158 VDD VSS / sg13g2_decap_8
XFILLER_75_165 VDD VSS / sg13g2_decap_4
XFILLER_75_237 VDD VSS / sg13g2_fill_1
XFILLER_75_254 VDD VSS / sg13g2_fill_1
XFILLER_75_344 VDD VSS / sg13g2_fill_1
XFILLER_75_372 VDD VSS / sg13g2_fill_1
XFILLER_75_377 VDD VSS / sg13g2_fill_1
XFILLER_75_406 VDD VSS / sg13g2_decap_8
XFILLER_75_413 VDD VSS / sg13g2_fill_2
XFILLER_75_415 VDD VSS / sg13g2_fill_1
XFILLER_75_419 VDD VSS / sg13g2_fill_1
XFILLER_75_491 VDD VSS / sg13g2_decap_4
XFILLER_75_500 VDD VSS / sg13g2_fill_2
XFILLER_75_502 VDD VSS / sg13g2_fill_1
XFILLER_75_531 VDD VSS / sg13g2_decap_8
XFILLER_75_538 VDD VSS / sg13g2_decap_8
XFILLER_75_545 VDD VSS / sg13g2_decap_4
XFILLER_75_549 VDD VSS / sg13g2_fill_1
XFILLER_75_590 VDD VSS / sg13g2_decap_8
XFILLER_75_597 VDD VSS / sg13g2_decap_8
XFILLER_75_604 VDD VSS / sg13g2_decap_8
XFILLER_75_611 VDD VSS / sg13g2_fill_2
XFILLER_75_613 VDD VSS / sg13g2_fill_1
XFILLER_75_656 VDD VSS / sg13g2_decap_4
XFILLER_75_660 VDD VSS / sg13g2_fill_2
XFILLER_75_677 VDD VSS / sg13g2_fill_2
XFILLER_75_679 VDD VSS / sg13g2_fill_1
XFILLER_75_696 VDD VSS / sg13g2_decap_8
XFILLER_75_703 VDD VSS / sg13g2_decap_8
XFILLER_75_710 VDD VSS / sg13g2_decap_4
XFILLER_75_714 VDD VSS / sg13g2_fill_2
XFILLER_76_0 VDD VSS / sg13g2_decap_4
XFILLER_76_123 VDD VSS / sg13g2_decap_8
XFILLER_76_130 VDD VSS / sg13g2_fill_1
XFILLER_76_134 VDD VSS / sg13g2_decap_8
XFILLER_76_146 VDD VSS / sg13g2_fill_1
XFILLER_76_151 VDD VSS / sg13g2_decap_8
XFILLER_76_158 VDD VSS / sg13g2_decap_8
XFILLER_76_165 VDD VSS / sg13g2_decap_4
XFILLER_76_169 VDD VSS / sg13g2_fill_2
XFILLER_76_198 VDD VSS / sg13g2_fill_1
XFILLER_76_320 VDD VSS / sg13g2_fill_1
XFILLER_76_358 VDD VSS / sg13g2_fill_1
XFILLER_76_390 VDD VSS / sg13g2_decap_4
XFILLER_76_4 VDD VSS / sg13g2_fill_1
XFILLER_76_421 VDD VSS / sg13g2_fill_1
XFILLER_76_459 VDD VSS / sg13g2_decap_8
XFILLER_76_485 VDD VSS / sg13g2_fill_2
XFILLER_76_487 VDD VSS / sg13g2_fill_1
XFILLER_76_522 VDD VSS / sg13g2_decap_8
XFILLER_76_529 VDD VSS / sg13g2_decap_8
XFILLER_76_536 VDD VSS / sg13g2_decap_8
XFILLER_76_543 VDD VSS / sg13g2_decap_4
XFILLER_76_547 VDD VSS / sg13g2_fill_2
XFILLER_76_592 VDD VSS / sg13g2_decap_4
XFILLER_76_596 VDD VSS / sg13g2_fill_1
XFILLER_76_601 VDD VSS / sg13g2_decap_8
XFILLER_76_608 VDD VSS / sg13g2_decap_8
XFILLER_76_615 VDD VSS / sg13g2_decap_8
XFILLER_76_622 VDD VSS / sg13g2_decap_8
XFILLER_76_629 VDD VSS / sg13g2_fill_2
XFILLER_76_658 VDD VSS / sg13g2_decap_8
XFILLER_76_665 VDD VSS / sg13g2_decap_8
XFILLER_76_672 VDD VSS / sg13g2_decap_4
XFILLER_76_676 VDD VSS / sg13g2_fill_2
XFILLER_76_710 VDD VSS / sg13g2_decap_4
XFILLER_76_714 VDD VSS / sg13g2_fill_2
XFILLER_76_90 VDD VSS / sg13g2_fill_2
XFILLER_77_0 VDD VSS / sg13g2_decap_4
XFILLER_77_122 VDD VSS / sg13g2_fill_2
XFILLER_77_138 VDD VSS / sg13g2_fill_2
XFILLER_77_140 VDD VSS / sg13g2_fill_1
XFILLER_77_158 VDD VSS / sg13g2_fill_2
XFILLER_77_160 VDD VSS / sg13g2_fill_1
XFILLER_77_278 VDD VSS / sg13g2_fill_2
XFILLER_77_280 VDD VSS / sg13g2_fill_1
XFILLER_77_318 VDD VSS / sg13g2_fill_1
XFILLER_77_350 VDD VSS / sg13g2_decap_8
XFILLER_77_357 VDD VSS / sg13g2_decap_8
XFILLER_77_378 VDD VSS / sg13g2_fill_1
XFILLER_77_389 VDD VSS / sg13g2_fill_2
XFILLER_77_447 VDD VSS / sg13g2_decap_8
XFILLER_77_454 VDD VSS / sg13g2_decap_8
XFILLER_77_461 VDD VSS / sg13g2_decap_8
XFILLER_77_468 VDD VSS / sg13g2_fill_1
XFILLER_77_479 VDD VSS / sg13g2_fill_1
XFILLER_77_485 VDD VSS / sg13g2_fill_2
XFILLER_77_487 VDD VSS / sg13g2_fill_1
XFILLER_77_495 VDD VSS / sg13g2_fill_2
XFILLER_77_515 VDD VSS / sg13g2_decap_8
XFILLER_77_522 VDD VSS / sg13g2_fill_1
XFILLER_77_527 VDD VSS / sg13g2_fill_1
XFILLER_77_533 VDD VSS / sg13g2_decap_8
XFILLER_77_540 VDD VSS / sg13g2_fill_1
XFILLER_77_546 VDD VSS / sg13g2_fill_2
XFILLER_77_576 VDD VSS / sg13g2_decap_4
XFILLER_77_580 VDD VSS / sg13g2_fill_2
XFILLER_77_619 VDD VSS / sg13g2_decap_8
XFILLER_77_626 VDD VSS / sg13g2_decap_8
XFILLER_77_633 VDD VSS / sg13g2_decap_8
XFILLER_77_663 VDD VSS / sg13g2_decap_8
XFILLER_77_670 VDD VSS / sg13g2_fill_2
XFILLER_77_711 VDD VSS / sg13g2_decap_4
XFILLER_77_715 VDD VSS / sg13g2_fill_1
XFILLER_77_94 VDD VSS / sg13g2_fill_2
XFILLER_78_0 VDD VSS / sg13g2_decap_8
XFILLER_78_129 VDD VSS / sg13g2_fill_2
XFILLER_78_131 VDD VSS / sg13g2_fill_1
XFILLER_78_159 VDD VSS / sg13g2_decap_4
XFILLER_78_198 VDD VSS / sg13g2_fill_2
XFILLER_78_231 VDD VSS / sg13g2_fill_1
XFILLER_78_280 VDD VSS / sg13g2_fill_1
XFILLER_78_308 VDD VSS / sg13g2_fill_1
XFILLER_78_344 VDD VSS / sg13g2_fill_2
XFILLER_78_373 VDD VSS / sg13g2_decap_4
XFILLER_78_404 VDD VSS / sg13g2_fill_2
XFILLER_78_445 VDD VSS / sg13g2_decap_8
XFILLER_78_452 VDD VSS / sg13g2_decap_8
XFILLER_78_459 VDD VSS / sg13g2_decap_8
XFILLER_78_466 VDD VSS / sg13g2_decap_8
XFILLER_78_473 VDD VSS / sg13g2_decap_8
XFILLER_78_480 VDD VSS / sg13g2_fill_2
XFILLER_78_511 VDD VSS / sg13g2_decap_8
XFILLER_78_518 VDD VSS / sg13g2_fill_1
XFILLER_78_564 VDD VSS / sg13g2_fill_1
XFILLER_78_568 VDD VSS / sg13g2_decap_8
XFILLER_78_575 VDD VSS / sg13g2_decap_4
XFILLER_78_582 VDD VSS / sg13g2_decap_4
XFILLER_78_625 VDD VSS / sg13g2_decap_8
XFILLER_78_632 VDD VSS / sg13g2_decap_8
XFILLER_78_639 VDD VSS / sg13g2_fill_2
XFILLER_78_647 VDD VSS / sg13g2_fill_1
XFILLER_78_666 VDD VSS / sg13g2_decap_8
XFILLER_78_673 VDD VSS / sg13g2_fill_2
XFILLER_78_711 VDD VSS / sg13g2_decap_4
XFILLER_78_715 VDD VSS / sg13g2_fill_1
XFILLER_79_0 VDD VSS / sg13g2_decap_4
XFILLER_79_107 VDD VSS / sg13g2_fill_2
XFILLER_79_109 VDD VSS / sg13g2_fill_1
XFILLER_79_119 VDD VSS / sg13g2_fill_1
XFILLER_79_136 VDD VSS / sg13g2_decap_8
XFILLER_79_143 VDD VSS / sg13g2_decap_8
XFILLER_79_150 VDD VSS / sg13g2_decap_4
XFILLER_79_270 VDD VSS / sg13g2_fill_1
XFILLER_79_298 VDD VSS / sg13g2_fill_1
XFILLER_79_389 VDD VSS / sg13g2_fill_1
XFILLER_79_417 VDD VSS / sg13g2_fill_2
XFILLER_79_419 VDD VSS / sg13g2_fill_1
XFILLER_79_447 VDD VSS / sg13g2_fill_2
XFILLER_79_459 VDD VSS / sg13g2_decap_8
XFILLER_79_466 VDD VSS / sg13g2_fill_1
XFILLER_79_483 VDD VSS / sg13g2_decap_4
XFILLER_79_487 VDD VSS / sg13g2_fill_2
XFILLER_79_494 VDD VSS / sg13g2_decap_8
XFILLER_79_501 VDD VSS / sg13g2_decap_8
XFILLER_79_508 VDD VSS / sg13g2_decap_4
XFILLER_79_512 VDD VSS / sg13g2_fill_2
XFILLER_79_540 VDD VSS / sg13g2_fill_2
XFILLER_79_554 VDD VSS / sg13g2_decap_8
XFILLER_79_561 VDD VSS / sg13g2_fill_1
XFILLER_79_570 VDD VSS / sg13g2_decap_8
XFILLER_79_577 VDD VSS / sg13g2_decap_8
XFILLER_79_58 VDD VSS / sg13g2_fill_2
XFILLER_79_584 VDD VSS / sg13g2_decap_4
XFILLER_79_588 VDD VSS / sg13g2_fill_2
XFILLER_79_627 VDD VSS / sg13g2_fill_1
XFILLER_79_672 VDD VSS / sg13g2_decap_8
XFILLER_79_679 VDD VSS / sg13g2_fill_2
XFILLER_79_681 VDD VSS / sg13g2_fill_1
XFILLER_79_695 VDD VSS / sg13g2_fill_2
XFILLER_79_702 VDD VSS / sg13g2_decap_8
XFILLER_79_709 VDD VSS / sg13g2_decap_8
XFILLER_79_78 VDD VSS / sg13g2_fill_2
XFILLER_7_0 VDD VSS / sg13g2_decap_4
XFILLER_7_213 VDD VSS / sg13g2_decap_4
XFILLER_7_217 VDD VSS / sg13g2_fill_2
XFILLER_7_250 VDD VSS / sg13g2_decap_4
XFILLER_7_254 VDD VSS / sg13g2_fill_1
XFILLER_7_282 VDD VSS / sg13g2_decap_4
XFILLER_7_286 VDD VSS / sg13g2_fill_2
XFILLER_7_315 VDD VSS / sg13g2_fill_1
XFILLER_7_394 VDD VSS / sg13g2_fill_1
XFILLER_7_43 VDD VSS / sg13g2_decap_8
XFILLER_7_50 VDD VSS / sg13g2_decap_8
XFILLER_7_57 VDD VSS / sg13g2_decap_8
XFILLER_7_64 VDD VSS / sg13g2_fill_2
XFILLER_7_714 VDD VSS / sg13g2_fill_2
XFILLER_80_115 VDD VSS / sg13g2_fill_2
XFILLER_80_117 VDD VSS / sg13g2_fill_1
XFILLER_80_213 VDD VSS / sg13g2_fill_2
XFILLER_80_330 VDD VSS / sg13g2_fill_2
XFILLER_80_332 VDD VSS / sg13g2_fill_1
XFILLER_80_424 VDD VSS / sg13g2_fill_1
XFILLER_80_429 VDD VSS / sg13g2_fill_1
XFILLER_80_485 VDD VSS / sg13g2_decap_8
XFILLER_80_492 VDD VSS / sg13g2_decap_8
XFILLER_80_499 VDD VSS / sg13g2_decap_8
XFILLER_80_506 VDD VSS / sg13g2_decap_8
XFILLER_80_513 VDD VSS / sg13g2_decap_8
XFILLER_80_520 VDD VSS / sg13g2_decap_4
XFILLER_80_545 VDD VSS / sg13g2_decap_8
XFILLER_80_552 VDD VSS / sg13g2_fill_1
XFILLER_80_579 VDD VSS / sg13g2_decap_8
XFILLER_80_586 VDD VSS / sg13g2_decap_4
XFILLER_80_590 VDD VSS / sg13g2_fill_2
XFILLER_80_714 VDD VSS / sg13g2_fill_2
XFILLER_81_0 VDD VSS / sg13g2_decap_4
XFILLER_81_137 VDD VSS / sg13g2_fill_1
XFILLER_81_206 VDD VSS / sg13g2_fill_2
XFILLER_81_240 VDD VSS / sg13g2_fill_1
XFILLER_81_272 VDD VSS / sg13g2_decap_4
XFILLER_81_276 VDD VSS / sg13g2_fill_1
XFILLER_81_356 VDD VSS / sg13g2_fill_2
XFILLER_81_358 VDD VSS / sg13g2_fill_1
XFILLER_81_4 VDD VSS / sg13g2_fill_1
XFILLER_81_418 VDD VSS / sg13g2_fill_2
XFILLER_81_50 VDD VSS / sg13g2_fill_2
XFILLER_81_52 VDD VSS / sg13g2_fill_1
XFILLER_81_540 VDD VSS / sg13g2_decap_4
XFILLER_81_544 VDD VSS / sg13g2_fill_2
XFILLER_81_591 VDD VSS / sg13g2_decap_8
XFILLER_81_598 VDD VSS / sg13g2_decap_8
XFILLER_81_605 VDD VSS / sg13g2_decap_8
XFILLER_81_612 VDD VSS / sg13g2_decap_8
XFILLER_81_619 VDD VSS / sg13g2_decap_4
XFILLER_81_628 VDD VSS / sg13g2_fill_2
XFILLER_81_630 VDD VSS / sg13g2_fill_1
XFILLER_81_668 VDD VSS / sg13g2_decap_8
XFILLER_81_675 VDD VSS / sg13g2_decap_8
XFILLER_81_714 VDD VSS / sg13g2_fill_2
XFILLER_81_80 VDD VSS / sg13g2_fill_2
XFILLER_81_82 VDD VSS / sg13g2_fill_1
XFILLER_82_0 VDD VSS / sg13g2_fill_2
XFILLER_82_110 VDD VSS / sg13g2_fill_2
XFILLER_82_166 VDD VSS / sg13g2_fill_1
XFILLER_82_2 VDD VSS / sg13g2_fill_1
XFILLER_82_242 VDD VSS / sg13g2_fill_2
XFILLER_82_271 VDD VSS / sg13g2_fill_1
XFILLER_82_281 VDD VSS / sg13g2_fill_2
XFILLER_82_283 VDD VSS / sg13g2_fill_1
XFILLER_82_293 VDD VSS / sg13g2_fill_2
XFILLER_82_30 VDD VSS / sg13g2_fill_2
XFILLER_82_366 VDD VSS / sg13g2_fill_1
XFILLER_82_387 VDD VSS / sg13g2_fill_1
XFILLER_82_415 VDD VSS / sg13g2_decap_4
XFILLER_82_419 VDD VSS / sg13g2_fill_1
XFILLER_82_424 VDD VSS / sg13g2_decap_8
XFILLER_82_468 VDD VSS / sg13g2_decap_8
XFILLER_82_475 VDD VSS / sg13g2_decap_4
XFILLER_82_479 VDD VSS / sg13g2_fill_2
XFILLER_82_486 VDD VSS / sg13g2_decap_8
XFILLER_82_493 VDD VSS / sg13g2_decap_8
XFILLER_82_50 VDD VSS / sg13g2_fill_1
XFILLER_82_500 VDD VSS / sg13g2_decap_4
XFILLER_82_504 VDD VSS / sg13g2_fill_1
XFILLER_82_532 VDD VSS / sg13g2_fill_1
XFILLER_82_546 VDD VSS / sg13g2_decap_8
XFILLER_82_598 VDD VSS / sg13g2_fill_2
XFILLER_82_600 VDD VSS / sg13g2_fill_1
XFILLER_82_604 VDD VSS / sg13g2_decap_4
XFILLER_82_614 VDD VSS / sg13g2_decap_8
XFILLER_82_621 VDD VSS / sg13g2_decap_8
XFILLER_82_628 VDD VSS / sg13g2_decap_8
XFILLER_82_635 VDD VSS / sg13g2_fill_2
XFILLER_82_637 VDD VSS / sg13g2_fill_1
XFILLER_82_684 VDD VSS / sg13g2_fill_1
XFILLER_82_713 VDD VSS / sg13g2_fill_2
XFILLER_82_715 VDD VSS / sg13g2_fill_1
XFILLER_82_82 VDD VSS / sg13g2_fill_1
XFILLER_83_0 VDD VSS / sg13g2_fill_2
XFILLER_83_153 VDD VSS / sg13g2_fill_2
XFILLER_83_2 VDD VSS / sg13g2_fill_1
XFILLER_83_246 VDD VSS / sg13g2_fill_2
XFILLER_83_248 VDD VSS / sg13g2_fill_1
XFILLER_83_323 VDD VSS / sg13g2_fill_1
XFILLER_83_34 VDD VSS / sg13g2_fill_2
XFILLER_83_353 VDD VSS / sg13g2_fill_1
XFILLER_83_36 VDD VSS / sg13g2_fill_1
XFILLER_83_443 VDD VSS / sg13g2_fill_1
XFILLER_83_454 VDD VSS / sg13g2_decap_4
XFILLER_83_461 VDD VSS / sg13g2_decap_8
XFILLER_83_468 VDD VSS / sg13g2_decap_8
XFILLER_83_475 VDD VSS / sg13g2_decap_8
XFILLER_83_482 VDD VSS / sg13g2_fill_2
XFILLER_83_484 VDD VSS / sg13g2_fill_1
XFILLER_83_490 VDD VSS / sg13g2_decap_8
XFILLER_83_497 VDD VSS / sg13g2_decap_8
XFILLER_83_504 VDD VSS / sg13g2_decap_4
XFILLER_83_508 VDD VSS / sg13g2_fill_2
XFILLER_83_518 VDD VSS / sg13g2_fill_2
XFILLER_83_554 VDD VSS / sg13g2_decap_8
XFILLER_83_565 VDD VSS / sg13g2_decap_8
XFILLER_83_572 VDD VSS / sg13g2_fill_1
XFILLER_83_625 VDD VSS / sg13g2_fill_2
XFILLER_83_636 VDD VSS / sg13g2_fill_2
XFILLER_83_647 VDD VSS / sg13g2_fill_2
XFILLER_83_649 VDD VSS / sg13g2_fill_1
XFILLER_83_664 VDD VSS / sg13g2_decap_8
XFILLER_83_671 VDD VSS / sg13g2_decap_8
XFILLER_83_678 VDD VSS / sg13g2_fill_2
XFILLER_83_680 VDD VSS / sg13g2_fill_1
XFILLER_83_706 VDD VSS / sg13g2_decap_8
XFILLER_83_713 VDD VSS / sg13g2_fill_2
XFILLER_83_715 VDD VSS / sg13g2_fill_1
XFILLER_84_0 VDD VSS / sg13g2_fill_2
XFILLER_84_161 VDD VSS / sg13g2_fill_2
XFILLER_84_199 VDD VSS / sg13g2_fill_2
XFILLER_84_2 VDD VSS / sg13g2_fill_1
XFILLER_84_354 VDD VSS / sg13g2_fill_2
XFILLER_84_396 VDD VSS / sg13g2_fill_1
XFILLER_84_457 VDD VSS / sg13g2_fill_2
XFILLER_84_469 VDD VSS / sg13g2_fill_2
XFILLER_84_474 VDD VSS / sg13g2_fill_2
XFILLER_84_476 VDD VSS / sg13g2_fill_1
XFILLER_84_487 VDD VSS / sg13g2_fill_1
XFILLER_84_496 VDD VSS / sg13g2_decap_4
XFILLER_84_508 VDD VSS / sg13g2_decap_8
XFILLER_84_515 VDD VSS / sg13g2_decap_4
XFILLER_84_519 VDD VSS / sg13g2_fill_1
XFILLER_84_525 VDD VSS / sg13g2_fill_2
XFILLER_84_543 VDD VSS / sg13g2_decap_4
XFILLER_84_557 VDD VSS / sg13g2_fill_1
XFILLER_84_563 VDD VSS / sg13g2_decap_4
XFILLER_84_575 VDD VSS / sg13g2_decap_8
XFILLER_84_661 VDD VSS / sg13g2_decap_8
XFILLER_84_668 VDD VSS / sg13g2_decap_8
XFILLER_84_675 VDD VSS / sg13g2_decap_4
XFILLER_84_679 VDD VSS / sg13g2_fill_1
XFILLER_84_684 VDD VSS / sg13g2_fill_2
XFILLER_84_706 VDD VSS / sg13g2_decap_8
XFILLER_84_713 VDD VSS / sg13g2_fill_2
XFILLER_84_715 VDD VSS / sg13g2_fill_1
XFILLER_84_84 VDD VSS / sg13g2_fill_2
XFILLER_84_86 VDD VSS / sg13g2_fill_1
XFILLER_85_0 VDD VSS / sg13g2_fill_1
XFILLER_85_108 VDD VSS / sg13g2_fill_2
XFILLER_85_137 VDD VSS / sg13g2_fill_2
XFILLER_85_139 VDD VSS / sg13g2_fill_1
XFILLER_85_234 VDD VSS / sg13g2_fill_1
XFILLER_85_316 VDD VSS / sg13g2_fill_1
XFILLER_85_385 VDD VSS / sg13g2_decap_8
XFILLER_85_392 VDD VSS / sg13g2_decap_4
XFILLER_85_396 VDD VSS / sg13g2_fill_2
XFILLER_85_435 VDD VSS / sg13g2_fill_2
XFILLER_85_437 VDD VSS / sg13g2_fill_1
XFILLER_85_453 VDD VSS / sg13g2_fill_1
XFILLER_85_46 VDD VSS / sg13g2_decap_4
XFILLER_85_460 VDD VSS / sg13g2_fill_1
XFILLER_85_50 VDD VSS / sg13g2_fill_2
XFILLER_85_532 VDD VSS / sg13g2_fill_2
XFILLER_85_534 VDD VSS / sg13g2_fill_1
XFILLER_85_548 VDD VSS / sg13g2_fill_2
XFILLER_85_562 VDD VSS / sg13g2_fill_2
XFILLER_85_564 VDD VSS / sg13g2_fill_1
XFILLER_85_575 VDD VSS / sg13g2_decap_8
XFILLER_85_582 VDD VSS / sg13g2_decap_4
XFILLER_85_586 VDD VSS / sg13g2_fill_1
XFILLER_85_591 VDD VSS / sg13g2_decap_8
XFILLER_85_598 VDD VSS / sg13g2_decap_4
XFILLER_85_613 VDD VSS / sg13g2_fill_1
XFILLER_85_634 VDD VSS / sg13g2_fill_2
XFILLER_85_636 VDD VSS / sg13g2_fill_1
XFILLER_85_644 VDD VSS / sg13g2_fill_2
XFILLER_85_673 VDD VSS / sg13g2_fill_2
XFILLER_85_712 VDD VSS / sg13g2_decap_4
XFILLER_85_79 VDD VSS / sg13g2_fill_2
XFILLER_86_0 VDD VSS / sg13g2_fill_2
XFILLER_86_2 VDD VSS / sg13g2_fill_1
XFILLER_86_228 VDD VSS / sg13g2_fill_2
XFILLER_86_297 VDD VSS / sg13g2_fill_2
XFILLER_86_299 VDD VSS / sg13g2_fill_1
XFILLER_86_30 VDD VSS / sg13g2_fill_1
XFILLER_86_385 VDD VSS / sg13g2_fill_1
XFILLER_86_395 VDD VSS / sg13g2_decap_8
XFILLER_86_471 VDD VSS / sg13g2_fill_1
XFILLER_86_514 VDD VSS / sg13g2_decap_4
XFILLER_86_518 VDD VSS / sg13g2_fill_2
XFILLER_86_530 VDD VSS / sg13g2_fill_2
XFILLER_86_595 VDD VSS / sg13g2_decap_8
XFILLER_86_624 VDD VSS / sg13g2_fill_2
XFILLER_86_626 VDD VSS / sg13g2_fill_1
XFILLER_86_667 VDD VSS / sg13g2_fill_2
XFILLER_86_669 VDD VSS / sg13g2_fill_1
XFILLER_86_715 VDD VSS / sg13g2_fill_1
XFILLER_87_0 VDD VSS / sg13g2_fill_2
XFILLER_87_2 VDD VSS / sg13g2_fill_1
XFILLER_87_202 VDD VSS / sg13g2_fill_1
XFILLER_87_235 VDD VSS / sg13g2_fill_1
XFILLER_87_30 VDD VSS / sg13g2_fill_2
XFILLER_87_301 VDD VSS / sg13g2_fill_2
XFILLER_87_316 VDD VSS / sg13g2_fill_2
XFILLER_87_373 VDD VSS / sg13g2_fill_2
XFILLER_87_375 VDD VSS / sg13g2_fill_1
XFILLER_87_517 VDD VSS / sg13g2_decap_4
XFILLER_87_59 VDD VSS / sg13g2_fill_1
XFILLER_87_592 VDD VSS / sg13g2_decap_8
XFILLER_87_599 VDD VSS / sg13g2_decap_8
XFILLER_87_606 VDD VSS / sg13g2_fill_2
XFILLER_87_630 VDD VSS / sg13g2_fill_2
XFILLER_87_659 VDD VSS / sg13g2_decap_8
XFILLER_87_666 VDD VSS / sg13g2_fill_1
XFILLER_87_711 VDD VSS / sg13g2_decap_4
XFILLER_87_715 VDD VSS / sg13g2_fill_1
XFILLER_88_0 VDD VSS / sg13g2_decap_8
XFILLER_88_127 VDD VSS / sg13g2_decap_4
XFILLER_88_131 VDD VSS / sg13g2_fill_1
XFILLER_88_159 VDD VSS / sg13g2_fill_1
XFILLER_88_229 VDD VSS / sg13g2_fill_1
XFILLER_88_274 VDD VSS / sg13g2_decap_4
XFILLER_88_278 VDD VSS / sg13g2_fill_1
XFILLER_88_306 VDD VSS / sg13g2_decap_4
XFILLER_88_433 VDD VSS / sg13g2_fill_1
XFILLER_88_468 VDD VSS / sg13g2_fill_2
XFILLER_88_523 VDD VSS / sg13g2_fill_2
XFILLER_88_529 VDD VSS / sg13g2_fill_2
XFILLER_88_531 VDD VSS / sg13g2_fill_1
XFILLER_88_540 VDD VSS / sg13g2_decap_8
XFILLER_88_547 VDD VSS / sg13g2_fill_1
XFILLER_88_553 VDD VSS / sg13g2_decap_4
XFILLER_88_557 VDD VSS / sg13g2_fill_2
XFILLER_88_564 VDD VSS / sg13g2_decap_8
XFILLER_88_571 VDD VSS / sg13g2_decap_8
XFILLER_88_578 VDD VSS / sg13g2_decap_8
XFILLER_88_585 VDD VSS / sg13g2_decap_8
XFILLER_88_592 VDD VSS / sg13g2_decap_8
XFILLER_88_599 VDD VSS / sg13g2_fill_2
XFILLER_88_655 VDD VSS / sg13g2_decap_8
XFILLER_88_66 VDD VSS / sg13g2_fill_2
XFILLER_88_662 VDD VSS / sg13g2_decap_8
XFILLER_88_669 VDD VSS / sg13g2_decap_8
XFILLER_88_676 VDD VSS / sg13g2_fill_2
XFILLER_88_68 VDD VSS / sg13g2_fill_1
XFILLER_88_7 VDD VSS / sg13g2_fill_1
XFILLER_88_709 VDD VSS / sg13g2_decap_8
XFILLER_89_0 VDD VSS / sg13g2_fill_2
XFILLER_89_112 VDD VSS / sg13g2_fill_1
XFILLER_89_140 VDD VSS / sg13g2_fill_1
XFILLER_89_243 VDD VSS / sg13g2_decap_8
XFILLER_89_257 VDD VSS / sg13g2_decap_8
XFILLER_89_264 VDD VSS / sg13g2_decap_8
XFILLER_89_271 VDD VSS / sg13g2_decap_8
XFILLER_89_278 VDD VSS / sg13g2_decap_8
XFILLER_89_285 VDD VSS / sg13g2_fill_1
XFILLER_89_346 VDD VSS / sg13g2_decap_4
XFILLER_89_365 VDD VSS / sg13g2_decap_4
XFILLER_89_369 VDD VSS / sg13g2_fill_1
XFILLER_89_374 VDD VSS / sg13g2_decap_8
XFILLER_89_381 VDD VSS / sg13g2_decap_8
XFILLER_89_388 VDD VSS / sg13g2_decap_8
XFILLER_89_395 VDD VSS / sg13g2_decap_8
XFILLER_89_402 VDD VSS / sg13g2_decap_8
XFILLER_89_409 VDD VSS / sg13g2_decap_8
XFILLER_89_416 VDD VSS / sg13g2_decap_8
XFILLER_89_423 VDD VSS / sg13g2_decap_4
XFILLER_89_427 VDD VSS / sg13g2_fill_2
XFILLER_89_484 VDD VSS / sg13g2_fill_2
XFILLER_89_537 VDD VSS / sg13g2_decap_8
XFILLER_89_544 VDD VSS / sg13g2_decap_8
XFILLER_89_551 VDD VSS / sg13g2_decap_8
XFILLER_89_558 VDD VSS / sg13g2_decap_8
XFILLER_89_565 VDD VSS / sg13g2_decap_8
XFILLER_89_572 VDD VSS / sg13g2_decap_8
XFILLER_89_579 VDD VSS / sg13g2_decap_8
XFILLER_89_586 VDD VSS / sg13g2_decap_8
XFILLER_89_593 VDD VSS / sg13g2_decap_8
XFILLER_89_600 VDD VSS / sg13g2_decap_8
XFILLER_89_607 VDD VSS / sg13g2_decap_8
XFILLER_89_614 VDD VSS / sg13g2_decap_8
XFILLER_89_621 VDD VSS / sg13g2_fill_2
XFILLER_89_632 VDD VSS / sg13g2_fill_2
XFILLER_89_639 VDD VSS / sg13g2_decap_8
XFILLER_89_646 VDD VSS / sg13g2_decap_8
XFILLER_89_653 VDD VSS / sg13g2_decap_8
XFILLER_89_660 VDD VSS / sg13g2_decap_8
XFILLER_89_667 VDD VSS / sg13g2_decap_8
XFILLER_89_674 VDD VSS / sg13g2_decap_8
XFILLER_89_681 VDD VSS / sg13g2_fill_2
XFILLER_89_710 VDD VSS / sg13g2_decap_4
XFILLER_89_714 VDD VSS / sg13g2_fill_2
XFILLER_89_83 VDD VSS / sg13g2_fill_2
XFILLER_8_0 VDD VSS / sg13g2_decap_8
XFILLER_8_11 VDD VSS / sg13g2_fill_2
XFILLER_8_126 VDD VSS / sg13g2_decap_8
XFILLER_8_133 VDD VSS / sg13g2_fill_2
XFILLER_8_206 VDD VSS / sg13g2_decap_8
XFILLER_8_213 VDD VSS / sg13g2_fill_1
XFILLER_8_268 VDD VSS / sg13g2_fill_1
XFILLER_8_32 VDD VSS / sg13g2_fill_1
XFILLER_8_445 VDD VSS / sg13g2_fill_1
XFILLER_8_46 VDD VSS / sg13g2_fill_1
XFILLER_8_482 VDD VSS / sg13g2_fill_1
XFILLER_8_564 VDD VSS / sg13g2_fill_1
XFILLER_8_623 VDD VSS / sg13g2_fill_2
XFILLER_8_652 VDD VSS / sg13g2_fill_2
XFILLER_8_654 VDD VSS / sg13g2_fill_1
XFILLER_8_659 VDD VSS / sg13g2_fill_1
XFILLER_8_7 VDD VSS / sg13g2_decap_4
XFILLER_8_714 VDD VSS / sg13g2_fill_2
XFILLER_8_79 VDD VSS / sg13g2_decap_8
XFILLER_8_86 VDD VSS / sg13g2_fill_2
XFILLER_9_0 VDD VSS / sg13g2_decap_4
XFILLER_9_126 VDD VSS / sg13g2_fill_2
XFILLER_9_168 VDD VSS / sg13g2_fill_2
XFILLER_9_170 VDD VSS / sg13g2_fill_1
XFILLER_9_198 VDD VSS / sg13g2_decap_8
XFILLER_9_205 VDD VSS / sg13g2_fill_2
XFILLER_9_207 VDD VSS / sg13g2_fill_1
XFILLER_9_243 VDD VSS / sg13g2_fill_2
XFILLER_9_245 VDD VSS / sg13g2_fill_1
XFILLER_9_31 VDD VSS / sg13g2_decap_8
XFILLER_9_312 VDD VSS / sg13g2_fill_2
XFILLER_9_38 VDD VSS / sg13g2_fill_1
XFILLER_9_394 VDD VSS / sg13g2_fill_2
XFILLER_9_401 VDD VSS / sg13g2_fill_1
XFILLER_9_46 VDD VSS / sg13g2_decap_8
XFILLER_9_53 VDD VSS / sg13g2_decap_8
XFILLER_9_60 VDD VSS / sg13g2_decap_8
XFILLER_9_652 VDD VSS / sg13g2_fill_2
XFILLER_9_654 VDD VSS / sg13g2_fill_1
XFILLER_9_67 VDD VSS / sg13g2_decap_8
XFILLER_9_714 VDD VSS / sg13g2_fill_2
XFILLER_9_74 VDD VSS / sg13g2_decap_8
XFILLER_9_81 VDD VSS / sg13g2_decap_8
XFILLER_9_88 VDD VSS / sg13g2_fill_2
XFILLER_9_98 VDD VSS / sg13g2_fill_1
X_2648_ _0359_ u_core_u_serial_tx_5_ VDD VSS / sg13g2_inv_1
X_2649_ net36 _0057_ VDD VSS / sg13g2_inv_1
X_2650_ net30 _0056_ VDD VSS / sg13g2_inv_1
X_2651_ net34 _0055_ VDD VSS / sg13g2_inv_1
X_2652_ u_core_u_seu_u_en_d_d_0_ _0054_ VDD VSS / sg13g2_inv_1
X_2653_ _0360_ _0053_ VDD VSS / sg13g2_inv_1
X_2654_ _0361_ _0052_ VDD VSS / sg13g2_inv_1
X_2655_ _0362_ _0051_ VDD VSS / sg13g2_inv_1
X_2656_ _0363_ _0050_ VDD VSS / sg13g2_inv_1
X_2657_ _0364_ _0048_ VDD VSS / sg13g2_inv_1
X_2658_ _0365_ _0047_ VDD VSS / sg13g2_inv_1
X_2659_ _0366_ _0046_ VDD VSS / sg13g2_inv_1
X_2660_ _0367_ _0045_ VDD VSS / sg13g2_inv_1
X_2661_ _0368_ _0044_ VDD VSS / sg13g2_inv_1
X_2662_ _0369_ _0042_ VDD VSS / sg13g2_inv_1
X_2663_ _0370_ _0041_ VDD VSS / sg13g2_inv_1
X_2664_ _0371_ _0040_ VDD VSS / sg13g2_inv_1
X_2665_ _0372_ _0038_ VDD VSS / sg13g2_inv_1
X_2666_ _0373_ _0035_ VDD VSS / sg13g2_inv_1
X_2667_ _0374_ _0034_ VDD VSS / sg13g2_inv_1
X_2668_ _0375_ _0033_ VDD VSS / sg13g2_inv_1
X_2669_ _0376_ _0032_ VDD VSS / sg13g2_inv_1
X_2670_ _0377_ _0031_ VDD VSS / sg13g2_inv_1
X_2671_ _0378_ _0030_ VDD VSS / sg13g2_inv_1
X_2672_ _0379_ u_core_u_seu_qa_7_ VDD VSS / sg13g2_inv_1
X_2673_ _0380_ u_core_u_seu_qa_8_ VDD VSS / sg13g2_inv_1
X_2674_ _0381_ u_core_u_seu_qa_9_ VDD VSS / sg13g2_inv_1
X_2675_ _0382_ u_core_u_seu_qa_13_ VDD VSS / sg13g2_inv_1
X_2676_ _0383_ u_core_u_seu_qa_15_ VDD VSS / sg13g2_inv_1
X_2677_ _0384_ u_core_u_seu_qa_16_ VDD VSS / sg13g2_inv_1
X_2678_ _0385_ u_core_u_seu_qa_17_ VDD VSS / sg13g2_inv_1
X_2679_ _0386_ u_core_u_seu_qa_18_ VDD VSS / sg13g2_inv_1
X_2680_ _0387_ u_core_u_seu_qa_19_ VDD VSS / sg13g2_inv_1
X_2681_ _0388_ u_core_u_seu_qa_20_ VDD VSS / sg13g2_inv_1
X_2682_ _0389_ u_core_u_seu_qa_21_ VDD VSS / sg13g2_inv_1
X_2683_ _0390_ u_core_u_seu_qa_22_ VDD VSS / sg13g2_inv_1
X_2684_ _0391_ u_core_u_seu_qa_23_ VDD VSS / sg13g2_inv_1
X_2685_ _0392_ u_core_u_seu_qa_24_ VDD VSS / sg13g2_inv_1
X_2686_ _0393_ u_core_u_seu_qa_25_ VDD VSS / sg13g2_inv_1
X_2687_ _0394_ u_core_u_seu_qa_26_ VDD VSS / sg13g2_inv_1
X_2688_ _0395_ u_core_u_seu_qa_27_ VDD VSS / sg13g2_inv_1
X_2689_ _0396_ u_core_u_seu_qa_29_ VDD VSS / sg13g2_inv_1
X_2690_ _0397_ u_core_u_seu_qa_30_ VDD VSS / sg13g2_inv_1
X_2691_ _0398_ u_core_u_seu_qa_31_ VDD VSS / sg13g2_inv_1
X_2692_ _0399_ u_core_u_seu_qa_34_ VDD VSS / sg13g2_inv_1
X_2693_ _0400_ u_core_u_seu_qa_35_ VDD VSS / sg13g2_inv_1
X_2694_ _0401_ u_core_u_seu_qa_36_ VDD VSS / sg13g2_inv_1
X_2695_ _0402_ u_core_u_seu_qa_37_ VDD VSS / sg13g2_inv_1
X_2696_ _0403_ u_core_u_seu_qa_38_ VDD VSS / sg13g2_inv_1
X_2697_ _0404_ u_core_u_seu_qa_39_ VDD VSS / sg13g2_inv_1
X_2698_ _0405_ u_core_u_seu_qa_40_ VDD VSS / sg13g2_inv_1
X_2699_ _0406_ u_core_u_seu_qa_42_ VDD VSS / sg13g2_inv_1
X_2700_ _0407_ u_core_u_seu_qa_43_ VDD VSS / sg13g2_inv_1
X_2701_ _0408_ u_core_u_seu_qa_44_ VDD VSS / sg13g2_inv_1
X_2702_ _0409_ u_core_u_seu_qa_46_ VDD VSS / sg13g2_inv_1
X_2703_ _0410_ u_core_u_seu_qa_49_ VDD VSS / sg13g2_inv_1
X_2704_ _0411_ u_core_u_seu_qa_50_ VDD VSS / sg13g2_inv_1
X_2705_ _0412_ u_core_u_seu_qa_51_ VDD VSS / sg13g2_inv_1
X_2706_ _0413_ u_core_u_seu_qa_53_ VDD VSS / sg13g2_inv_1
X_2707_ _0414_ u_core_u_seu_qa_55_ VDD VSS / sg13g2_inv_1
X_2708_ _0415_ u_core_u_seu_qa_56_ VDD VSS / sg13g2_inv_1
X_2709_ _0416_ u_core_u_seu_qa_57_ VDD VSS / sg13g2_inv_1
X_2710_ _0417_ u_core_u_seu_qa_58_ VDD VSS / sg13g2_inv_1
X_2711_ _0418_ u_core_u_seu_qa_59_ VDD VSS / sg13g2_inv_1
X_2712_ _0419_ u_core_u_seu_qa_60_ VDD VSS / sg13g2_inv_1
X_2713_ _0420_ u_core_u_seu_qa_62_ VDD VSS / sg13g2_inv_1
X_2714_ _0421_ u_core_u_seu_qa_63_ VDD VSS / sg13g2_inv_1
X_2715_ _0422_ u_core_u_seu_qa_64_ VDD VSS / sg13g2_inv_1
X_2716_ _0423_ u_core_u_seu_qa_66_ VDD VSS / sg13g2_inv_1
X_2717_ _0424_ u_core_u_seu_qa_67_ VDD VSS / sg13g2_inv_1
X_2718_ _0425_ u_core_u_seu_qa_68_ VDD VSS / sg13g2_inv_1
X_2719_ _0426_ u_core_u_seu_qa_69_ VDD VSS / sg13g2_inv_1
X_2720_ _0427_ u_core_u_seu_qa_70_ VDD VSS / sg13g2_inv_1
X_2721_ _0428_ u_core_u_seu_qa_72_ VDD VSS / sg13g2_inv_1
X_2722_ _0429_ u_core_u_seu_qa_73_ VDD VSS / sg13g2_inv_1
X_2723_ _0430_ u_core_u_seu_qa_74_ VDD VSS / sg13g2_inv_1
X_2724_ _0431_ u_core_u_seu_qa_75_ VDD VSS / sg13g2_inv_1
X_2725_ _0432_ u_core_u_seu_qa_76_ VDD VSS / sg13g2_inv_1
X_2726_ _0433_ u_core_u_seu_qa_77_ VDD VSS / sg13g2_inv_1
X_2727_ _0434_ u_core_u_seu_qa_78_ VDD VSS / sg13g2_inv_1
X_2728_ _0435_ u_core_u_seu_qa_79_ VDD VSS / sg13g2_inv_1
X_2729_ _0436_ u_core_u_seu_qa_80_ VDD VSS / sg13g2_inv_1
X_2730_ _0437_ u_core_u_seu_qa_81_ VDD VSS / sg13g2_inv_1
X_2731_ _0438_ u_core_u_seu_qa_82_ VDD VSS / sg13g2_inv_1
X_2732_ _0439_ u_core_u_seu_qa_83_ VDD VSS / sg13g2_inv_1
X_2733_ _0440_ u_core_u_seu_qa_84_ VDD VSS / sg13g2_inv_1
X_2734_ _0441_ u_core_u_seu_qa_85_ VDD VSS / sg13g2_inv_1
X_2735_ _0442_ u_core_u_seu_qa_86_ VDD VSS / sg13g2_inv_1
X_2736_ _0443_ u_core_u_seu_qa_88_ VDD VSS / sg13g2_inv_1
X_2737_ _0444_ u_core_u_seu_qa_89_ VDD VSS / sg13g2_inv_1
X_2738_ _0445_ u_core_u_seu_qa_91_ VDD VSS / sg13g2_inv_1
X_2739_ _0446_ u_core_u_seu_qa_92_ VDD VSS / sg13g2_inv_1
X_2740_ _0447_ u_core_u_seu_qa_93_ VDD VSS / sg13g2_inv_1
X_2741_ _0448_ u_core_u_seu_qa_94_ VDD VSS / sg13g2_inv_1
X_2742_ _0449_ u_core_u_seu_qa_95_ VDD VSS / sg13g2_inv_1
X_2743_ _0450_ u_core_u_seu_qa_98_ VDD VSS / sg13g2_inv_1
X_2744_ _0451_ u_core_u_seu_qa_99_ VDD VSS / sg13g2_inv_1
X_2745_ _0452_ u_core_u_seu_qa_100_ VDD VSS / sg13g2_inv_1
X_2746_ _0453_ u_core_u_seu_qa_101_ VDD VSS / sg13g2_inv_1
X_2747_ _0454_ u_core_u_seu_qa_102_ VDD VSS / sg13g2_inv_1
X_2748_ _0455_ u_core_u_seu_qa_103_ VDD VSS / sg13g2_inv_1
X_2749_ _0456_ u_core_u_seu_qa_105_ VDD VSS / sg13g2_inv_1
X_2750_ _0457_ u_core_u_seu_qa_106_ VDD VSS / sg13g2_inv_1
X_2751_ _0458_ u_core_u_seu_qa_107_ VDD VSS / sg13g2_inv_1
X_2752_ _0459_ u_core_u_seu_qa_108_ VDD VSS / sg13g2_inv_1
X_2753_ _0460_ u_core_u_seu_qa_111_ VDD VSS / sg13g2_inv_1
X_2754_ _0461_ u_core_u_seu_qa_112_ VDD VSS / sg13g2_inv_1
X_2755_ _0462_ u_core_u_seu_qa_113_ VDD VSS / sg13g2_inv_1
X_2756_ _0463_ u_core_u_seu_qa_114_ VDD VSS / sg13g2_inv_1
X_2757_ _0464_ u_core_u_seu_qa_116_ VDD VSS / sg13g2_inv_1
X_2758_ _0465_ u_core_u_seu_qa_117_ VDD VSS / sg13g2_inv_1
X_2759_ _0466_ u_core_u_seu_qa_118_ VDD VSS / sg13g2_inv_1
X_2760_ _0467_ u_core_u_seu_qa_120_ VDD VSS / sg13g2_inv_1
X_2761_ _0468_ u_core_u_seu_qa_121_ VDD VSS / sg13g2_inv_1
X_2762_ _0469_ u_core_u_seu_qa_122_ VDD VSS / sg13g2_inv_1
X_2763_ _0470_ u_core_u_seu_qa_123_ VDD VSS / sg13g2_inv_1
X_2764_ _0471_ u_core_u_seu_qa_124_ VDD VSS / sg13g2_inv_1
X_2765_ _0472_ u_core_u_seu_qa_125_ VDD VSS / sg13g2_inv_1
X_2766_ _0473_ u_core_u_seu_qa_126_ VDD VSS / sg13g2_inv_1
X_2767_ net28 net38 VDD VSS / sg13g2_inv_1
X_2768_ _0015_ u_core_u_regfile_osc_pre_0_ VDD VSS / sg13g2_inv_1
X_2769_ _0474_ u_core_u_regfile_osc_pre_3_ VDD VSS / sg13g2_inv_1
X_2770_ _0475_ net366 VDD VSS / sg13g2_inv_1
X_2771_ _0476_ u_core_rd_addr_4_ VDD VSS / sg13g2_inv_1
X_2772_ _0477_ u_core_u_regfile_wr_addr_1_ VDD VSS / sg13g2_inv_1
X_2773_ _0478_ u_core_u_regfile_wr_addr_3_ VDD VSS / sg13g2_inv_1
X_2774_ _0479_ u_core_u_regfile_wr_addr_4_ VDD VSS / sg13g2_inv_1
X_2775_ _0480_ u_core_u_regfile_osc_div_2_ VDD VSS / sg13g2_inv_1
X_2776_ _0481_ u_core_u_regfile_osc_div_1_ VDD VSS / sg13g2_inv_1
X_2777_ u_core_u_trip_hard_sample net10 VDD VSS / sg13g2_inv_1
X_2778_ _0000_ u_core_u_serial_bit_cnt_0_ VDD VSS / sg13g2_inv_1
X_2779_ _0482_ u_core_u_serial_bit_cnt_3_ VDD VSS / sg13g2_inv_1
X_2780_ _0483_ u_core_u_serial_idle_cnt_3_ VDD VSS / sg13g2_inv_1
X_2781_ _0484_ u_core_u_serial_idle_cnt_6_ VDD VSS / sg13g2_inv_1
X_2782_ _0485_ u_core_u_trip_inrush_cnt_16_ VDD VSS / sg13g2_inv_1
X_2783_ _0486_ u_core_inrush_6_ VDD VSS / sg13g2_inv_1
X_2784_ _0487_ u_core_inrush_5_ VDD VSS / sg13g2_inv_1
X_2785_ _0488_ u_core_inrush_3_ VDD VSS / sg13g2_inv_1
X_2786_ _0489_ u_core_u_trip_inrush_cnt_11_ VDD VSS / sg13g2_inv_1
X_2787_ _0490_ u_core_cmp_hard_s VDD VSS / sg13g2_inv_1
X_2788_ _0491_ u_core_u_trip_hard_cnt_7_ VDD VSS / sg13g2_inv_1
X_2789_ _0492_ u_core_hard_n_7_ VDD VSS / sg13g2_inv_1
X_2790_ _0493_ u_core_u_trip_hard_cnt_6_ VDD VSS / sg13g2_inv_1
X_2791_ _0494_ net335 VDD VSS / sg13g2_inv_1
X_2792_ _0495_ u_core_u_trip_soft_cnt_23_ VDD VSS / sg13g2_inv_1
X_2793_ _0496_ u_core_soft_time_14_ VDD VSS / sg13g2_inv_1
X_2794_ _0497_ u_core_u_trip_soft_cnt_22_ VDD VSS / sg13g2_inv_1
X_2795_ _0498_ u_core_u_trip_soft_cnt_21_ VDD VSS / sg13g2_inv_1
X_2796_ _0499_ u_core_soft_time_12_ VDD VSS / sg13g2_inv_1
X_2797_ _0500_ net343 VDD VSS / sg13g2_inv_1
X_2798_ _0501_ u_core_u_trip_soft_cnt_18_ VDD VSS / sg13g2_inv_1
X_2799_ _0502_ u_core_soft_time_9_ VDD VSS / sg13g2_inv_1
X_2800_ _0503_ u_core_u_trip_soft_cnt_17_ VDD VSS / sg13g2_inv_1
X_2801_ _0504_ u_core_u_trip_soft_cnt_16_ VDD VSS / sg13g2_inv_1
X_2802_ _0505_ u_core_u_trip_soft_cnt_5_ VDD VSS / sg13g2_inv_1
X_2803_ _0506_ u_core_u_trip_soft_cnt_15_ VDD VSS / sg13g2_inv_1
X_2804_ _0507_ u_core_u_trip_soft_cnt_14_ VDD VSS / sg13g2_inv_1
X_2805_ _0508_ u_core_u_trip_soft_cnt_13_ VDD VSS / sg13g2_inv_1
X_2806_ _0509_ u_core_u_trip_soft_cnt_12_ VDD VSS / sg13g2_inv_1
X_2807_ _0510_ u_core_u_trip_soft_cnt_11_ VDD VSS / sg13g2_inv_1
X_2808_ _0511_ u_core_u_trip_soft_cnt_10_ VDD VSS / sg13g2_inv_1
X_2809_ _0512_ u_core_u_trip_clr_mask_2_ VDD VSS / sg13g2_inv_1
X_2810_ _0513_ u_core_u_trip_hold_cnt_0_ VDD VSS / sg13g2_inv_1
X_2811_ _0514_ u_core_u_trip_hold_cnt_7_ VDD VSS / sg13g2_inv_1
X_2812_ _0515_ u_core_u_trip_hold_cnt_10_ VDD VSS / sg13g2_inv_1
X_2813_ _0516_ u_core_u_trip_hold_cnt_13_ VDD VSS / sg13g2_inv_1
X_2814_ _0517_ u_core_hold_time_5_ VDD VSS / sg13g2_inv_1
X_2815_ _0518_ u_core_hold_time_4_ VDD VSS / sg13g2_inv_1
X_2816_ _0519_ u_core_u_trip_hold_cnt_14_ VDD VSS / sg13g2_inv_1
X_2817_ _0520_ u_core_u_trip_hold_cnt_16_ VDD VSS / sg13g2_inv_1
X_2818_ _0521_ u_core_u_trip_hold_cnt_19_ VDD VSS / sg13g2_inv_1
X_2819_ _0522_ u_core_u_trip_hold_cnt_18_ VDD VSS / sg13g2_inv_1
X_2820_ _0523_ u_core_retry_cnt_2_ VDD VSS / sg13g2_inv_1
X_2821_ _0524_ u_core_retry_cnt_3_ VDD VSS / sg13g2_inv_1
X_2822_ _0525_ u_core_retry_cnt_4_ VDD VSS / sg13g2_inv_1
X_2823_ _0526_ u_core_retry_cnt_5_ VDD VSS / sg13g2_inv_1
X_2824_ _0527_ u_core_retry_cnt_6_ VDD VSS / sg13g2_inv_1
X_2825_ _0528_ u_core_retry_cnt_7_ VDD VSS / sg13g2_inv_1
X_2826_ _0529_ u_core_retry_max_3_ VDD VSS / sg13g2_inv_1
X_2827_ _0530_ u_core_retry_max_2_ VDD VSS / sg13g2_inv_1
X_2828_ _0531_ u_core_retry_max_5_ VDD VSS / sg13g2_inv_1
X_2829_ _0532_ u_core_retry_max_4_ VDD VSS / sg13g2_inv_1
X_2830_ _0533_ u_core_retry_max_6_ VDD VSS / sg13g2_inv_1
X_2831_ _0534_ u_core_retry_max_7_ VDD VSS / sg13g2_inv_1
X_2832_ _0535_ u_core_trip_cnt_15_ VDD VSS / sg13g2_inv_1
X_2833_ _0536_ u_core_soft_peak_14_ VDD VSS / sg13g2_inv_1
X_2834_ _0537_ u_core_soft_peak_11_ VDD VSS / sg13g2_inv_1
X_2835_ _0538_ u_core_soft_peak_10_ VDD VSS / sg13g2_inv_1
X_2836_ _0539_ u_core_soft_peak_7_ VDD VSS / sg13g2_inv_1
X_2837_ _0540_ u_core_soft_peak_3_ VDD VSS / sg13g2_inv_1
X_2838_ _0541_ u_core_soft_peak_2_ VDD VSS / sg13g2_inv_1
X_2839_ _0542_ u_core_soft_peak_1_ VDD VSS / sg13g2_inv_1
X_2840_ _0543_ u_core_decay_1_ VDD VSS / sg13g2_inv_1
X_2841_ _0544_ u_core_pattern_0_ VDD VSS / sg13g2_inv_1
X_2842_ _0545_ u_core_pattern_1_ VDD VSS / sg13g2_inv_1
X_2843_ _0546_ u_core_u_seu_qa_127_ VDD VSS / sg13g2_inv_1
X_2844_ _0547_ u_core_u_seu_qb_0_ VDD VSS / sg13g2_inv_1
X_2845_ _0548_ u_core_u_seu_qb_1_ VDD VSS / sg13g2_inv_1
X_2846_ _0549_ u_core_u_seu_qb_2_ VDD VSS / sg13g2_inv_1
X_2847_ _0550_ u_core_u_seu_qb_3_ VDD VSS / sg13g2_inv_1
X_2848_ _0551_ u_core_u_seu_qb_4_ VDD VSS / sg13g2_inv_1
X_2849_ _0552_ u_core_u_seu_qa_6_ VDD VSS / sg13g2_inv_1
X_2850_ _0553_ u_core_hyst_en VDD VSS / sg13g2_inv_1
X_2851_ _0554_ u_core_dac_soft_code_2_ VDD VSS / sg13g2_inv_1
X_2852_ _0555_ u_core_hyst_2 VDD VSS / sg13g2_inv_1
X_2853_ _0556_ u_core_dac_soft_code_1_ VDD VSS / sg13g2_inv_1
X_2854_ _0557_ u_core_u_trip_inrush_cnt_0_ VDD VSS / sg13g2_inv_1
X_2855_ _0558_ u_core_u_trip_inrush_cnt_1_ VDD VSS / sg13g2_inv_1
X_2856__369 net368 clknet_3_7__leaf_sclk_regs VDD VSS / sg13g2_inv_1
X_2857_ _0559_ u_core_u_serial_rd_frame u_core_u_serial_bit_cnt_4_ VDD VSS / sg13g2_and2_1
X_2858_ _0560_ u_core_u_serial_rd_frame u_core_u_serial_bit_cnt_4_ VDD VSS / sg13g2_nand2_1
X_2859_ _0561_ u_core_u_serial_bit_cnt_0_ u_core_u_serial_bit_cnt_1_ u_core_u_serial_bit_cnt_2_ u_core_u_serial_bit_cnt_3_ VDD VSS / sg13g2_nor4_1
X_2860_ _0562_ _0560_ _0561_ VDD VSS / sg13g2_nor2_1
X_2861_ _0563_ _0561_ _0559_ VDD VSS / sg13g2_nand2b_1
X_2862_ _0564_ _0559_ _0561_ VDD VSS / sg13g2_and2_1
X_2863_ _0565_ _0559_ _0561_ VDD VSS / sg13g2_nand2_1
X_2864_ _0566_ u_core_u_serial_tx_6_ _0560_ _0564_ u_core_u_serial_rd_hold_6_ VDD VSS / sg13g2_a22oi_1
X_2865_ _0192_ _0359_ _0563_ _0566_ VDD VSS / sg13g2_o21ai_1
X_2866_ _0567_ u_core_u_serial_tx_4_ _0562_ _0564_ u_core_u_serial_rd_hold_5_ VDD VSS / sg13g2_a22oi_1
X_2867_ _0191_ _0359_ _0559_ _0567_ VDD VSS / sg13g2_o21ai_1
X_2868_ _0568_ u_core_u_serial_rd_hold_4_ _0565_ VDD VSS / sg13g2_nor2_1
X_2869_ _0569_ u_core_u_serial_tx_4_ _0559_ VDD VSS / sg13g2_nor2_1
X_2870_ _0570_ u_core_u_serial_tx_3_ _0563_ VDD VSS / sg13g2_nor2_1
X_2871_ _0190_ _0568_ _0569_ _0570_ VDD VSS / sg13g2_nor3_1
X_2872_ _0571_ u_core_u_serial_tx_2_ _0563_ VDD VSS / sg13g2_nor2_1
X_2873_ _0572_ u_core_u_serial_rd_hold_3_ _0565_ VDD VSS / sg13g2_nor2_1
X_2874_ _0573_ u_core_u_serial_tx_3_ _0559_ VDD VSS / sg13g2_nor2_1
X_2875_ _0189_ _0571_ _0572_ _0573_ VDD VSS / sg13g2_nor3_1
X_2876_ _0574_ u_core_u_serial_tx_1_ _0563_ VDD VSS / sg13g2_nor2_1
X_2877_ _0575_ u_core_u_serial_rd_hold_2_ _0565_ VDD VSS / sg13g2_nor2_1
X_2878_ _0576_ u_core_u_serial_tx_2_ _0559_ VDD VSS / sg13g2_nor2_1
X_2879_ _0188_ _0574_ _0575_ _0576_ VDD VSS / sg13g2_nor3_1
X_2880_ _0577_ u_core_u_serial_tx_0_ _0563_ VDD VSS / sg13g2_nor2_1
X_2881_ _0578_ u_core_u_serial_rd_hold_1_ _0565_ VDD VSS / sg13g2_nor2_1
X_2882_ _0579_ u_core_u_serial_tx_1_ _0559_ VDD VSS / sg13g2_nor2_1
X_2883_ _0187_ _0577_ _0578_ _0579_ VDD VSS / sg13g2_nor3_1
X_2884_ _0580_ u_core_u_serial_tx_0_ _0560_ _0564_ u_core_u_serial_rd_hold_0_ VDD VSS / sg13g2_a22oi_1
X_2885_ _0186_ _0580_ VDD VSS / sg13g2_inv_1
X_2886_ _0581_ u_core_u_seu_qc_6_ u_core_u_seu_qb_6_ VDD VSS / sg13g2_nor2_1
X_2887_ _0582_ u_core_u_seu_qc_6_ u_core_u_seu_qb_6_ VDD VSS / sg13g2_nand2_1
X_2888_ u_core_u_seu_u_tmr_a_d_7_ _0552_ _0582_ _0581_ VDD VSS / sg13g2_a21oi_1
X_2889_ _0583_ u_core_u_seu_qb_7_ u_core_u_seu_qc_7_ VDD VSS / sg13g2_nor2_1
X_2890_ _0584_ u_core_u_seu_qb_7_ u_core_u_seu_qc_7_ VDD VSS / sg13g2_nand2_1
X_2891_ u_core_u_seu_u_tmr_a_d_8_ _0379_ _0583_ _0584_ VDD VSS / sg13g2_o21ai_1
X_2892_ _0585_ u_core_u_seu_qb_8_ u_core_u_seu_qc_8_ VDD VSS / sg13g2_nor2_1
X_2893_ _0586_ u_core_u_seu_qb_8_ u_core_u_seu_qc_8_ VDD VSS / sg13g2_nand2_1
X_2894_ u_core_u_seu_u_tmr_a_d_9_ _0380_ _0585_ _0586_ VDD VSS / sg13g2_o21ai_1
X_2895_ _0587_ u_core_u_seu_qb_9_ u_core_u_seu_qc_9_ VDD VSS / sg13g2_nor2_1
X_2896_ _0588_ u_core_u_seu_qb_9_ u_core_u_seu_qc_9_ VDD VSS / sg13g2_nand2_1
X_2897_ u_core_u_seu_u_tmr_a_d_10_ _0381_ _0587_ _0588_ VDD VSS / sg13g2_o21ai_1
X_2898_ _0589_ u_core_u_seu_qb_10_ u_core_u_seu_qc_10_ VDD VSS / sg13g2_nor2_1
X_2899_ _0590_ u_core_u_seu_qb_10_ u_core_u_seu_qc_10_ u_core_u_seu_qa_10_ VDD VSS / sg13g2_a21oi_1
X_2900_ u_core_u_seu_u_tmr_a_d_11_ _0589_ _0590_ VDD VSS / sg13g2_nor2_1
X_2901_ _0591_ u_core_u_seu_qb_11_ u_core_u_seu_qc_11_ VDD VSS / sg13g2_nor2_1
X_2902_ _0592_ u_core_u_seu_qb_11_ u_core_u_seu_qc_11_ u_core_u_seu_qa_11_ VDD VSS / sg13g2_a21oi_1
X_2903_ u_core_u_seu_u_tmr_a_d_12_ _0591_ _0592_ VDD VSS / sg13g2_nor2_1
X_2904_ _0593_ u_core_u_seu_qb_12_ u_core_u_seu_qc_12_ VDD VSS / sg13g2_nor2_1
X_2905_ _0594_ u_core_u_seu_qb_12_ u_core_u_seu_qc_12_ u_core_u_seu_qa_12_ VDD VSS / sg13g2_a21oi_1
X_2906_ u_core_u_seu_u_tmr_a_d_13_ _0593_ _0594_ VDD VSS / sg13g2_nor2_1
X_2907_ _0595_ u_core_u_seu_qb_13_ u_core_u_seu_qc_13_ VDD VSS / sg13g2_nor2_1
X_2908_ _0596_ u_core_u_seu_qb_13_ u_core_u_seu_qc_13_ u_core_u_seu_qa_13_ VDD VSS / sg13g2_a21oi_1
X_2909_ u_core_u_seu_u_tmr_a_d_14_ _0595_ _0596_ VDD VSS / sg13g2_nor2_1
X_2910_ _0597_ u_core_u_seu_qb_14_ u_core_u_seu_qc_14_ VDD VSS / sg13g2_nor2_1
X_2911_ _0598_ u_core_u_seu_qb_14_ u_core_u_seu_qc_14_ u_core_u_seu_qa_14_ VDD VSS / sg13g2_a21oi_1
X_2912_ u_core_u_seu_u_tmr_a_d_15_ _0597_ _0598_ VDD VSS / sg13g2_nor2_1
X_2913_ _0599_ u_core_u_seu_qb_15_ u_core_u_seu_qc_15_ VDD VSS / sg13g2_nor2_1
X_2914_ _0600_ u_core_u_seu_qb_15_ u_core_u_seu_qc_15_ VDD VSS / sg13g2_nand2_1
X_2915_ u_core_u_seu_u_tmr_a_d_16_ _0383_ _0599_ _0600_ VDD VSS / sg13g2_o21ai_1
X_2916_ _0601_ u_core_u_seu_qb_16_ u_core_u_seu_qc_16_ VDD VSS / sg13g2_nor2_1
X_2917_ _0602_ u_core_u_seu_qb_16_ u_core_u_seu_qc_16_ VDD VSS / sg13g2_nand2_1
X_2918_ u_core_u_seu_u_tmr_a_d_17_ _0384_ _0601_ _0602_ VDD VSS / sg13g2_o21ai_1
X_2919_ _0603_ u_core_u_seu_qb_17_ u_core_u_seu_qc_17_ VDD VSS / sg13g2_nor2_1
X_2920_ _0604_ u_core_u_seu_qb_17_ u_core_u_seu_qc_17_ VDD VSS / sg13g2_nand2_1
X_2921_ u_core_u_seu_u_tmr_a_d_18_ _0385_ _0603_ _0604_ VDD VSS / sg13g2_o21ai_1
X_2922_ _0605_ u_core_u_seu_qb_18_ u_core_u_seu_qc_18_ VDD VSS / sg13g2_nor2_1
X_2923_ _0606_ u_core_u_seu_qb_18_ u_core_u_seu_qc_18_ VDD VSS / sg13g2_nand2_1
X_2924_ u_core_u_seu_u_tmr_a_d_19_ _0386_ _0605_ _0606_ VDD VSS / sg13g2_o21ai_1
X_2925_ _0607_ u_core_u_seu_qb_19_ u_core_u_seu_qc_19_ VDD VSS / sg13g2_nor2_1
X_2926_ _0608_ u_core_u_seu_qb_19_ u_core_u_seu_qc_19_ VDD VSS / sg13g2_nand2_1
X_2927_ u_core_u_seu_u_tmr_a_d_20_ _0387_ _0607_ _0608_ VDD VSS / sg13g2_o21ai_1
X_2928_ _0609_ u_core_u_seu_qb_20_ u_core_u_seu_qc_20_ VDD VSS / sg13g2_nor2_1
X_2929_ _0610_ u_core_u_seu_qb_20_ u_core_u_seu_qc_20_ VDD VSS / sg13g2_nand2_1
X_2930_ u_core_u_seu_u_tmr_a_d_21_ _0388_ _0609_ _0610_ VDD VSS / sg13g2_o21ai_1
X_2931_ _0611_ u_core_u_seu_qb_21_ u_core_u_seu_qc_21_ VDD VSS / sg13g2_nor2_1
X_2932_ _0612_ u_core_u_seu_qb_21_ u_core_u_seu_qc_21_ VDD VSS / sg13g2_nand2_1
X_2933_ u_core_u_seu_u_tmr_a_d_22_ _0389_ _0611_ _0612_ VDD VSS / sg13g2_o21ai_1
X_2934_ _0613_ u_core_u_seu_qb_22_ u_core_u_seu_qc_22_ VDD VSS / sg13g2_nor2_1
X_2935_ _0614_ u_core_u_seu_qb_22_ u_core_u_seu_qc_22_ VDD VSS / sg13g2_nand2_1
X_2936_ u_core_u_seu_u_tmr_a_d_23_ _0390_ _0613_ _0614_ VDD VSS / sg13g2_o21ai_1
X_2937_ _0615_ u_core_u_seu_qb_23_ u_core_u_seu_qc_23_ VDD VSS / sg13g2_nor2_1
X_2938_ _0616_ u_core_u_seu_qb_23_ u_core_u_seu_qc_23_ VDD VSS / sg13g2_nand2_1
X_2939_ u_core_u_seu_u_tmr_a_d_24_ _0391_ _0615_ _0616_ VDD VSS / sg13g2_o21ai_1
X_2940_ _0617_ u_core_u_seu_qb_24_ u_core_u_seu_qc_24_ VDD VSS / sg13g2_nor2_1
X_2941_ _0618_ u_core_u_seu_qb_24_ u_core_u_seu_qc_24_ VDD VSS / sg13g2_nand2_1
X_2942_ u_core_u_seu_u_tmr_a_d_25_ _0392_ _0617_ _0618_ VDD VSS / sg13g2_o21ai_1
X_2943_ _0619_ u_core_u_seu_qb_25_ u_core_u_seu_qc_25_ VDD VSS / sg13g2_nor2_1
X_2944_ _0620_ u_core_u_seu_qb_25_ u_core_u_seu_qc_25_ VDD VSS / sg13g2_nand2_1
X_2945_ u_core_u_seu_u_tmr_a_d_26_ _0393_ _0619_ _0620_ VDD VSS / sg13g2_o21ai_1
X_2946_ _0621_ u_core_u_seu_qb_26_ u_core_u_seu_qc_26_ VDD VSS / sg13g2_nor2_1
X_2947_ _0622_ u_core_u_seu_qb_26_ u_core_u_seu_qc_26_ VDD VSS / sg13g2_nand2_1
X_2948_ u_core_u_seu_u_tmr_a_d_27_ _0394_ _0621_ _0622_ VDD VSS / sg13g2_o21ai_1
X_2949_ _0623_ u_core_u_seu_qb_27_ u_core_u_seu_qc_27_ VDD VSS / sg13g2_nor2_1
X_2950_ _0624_ u_core_u_seu_qb_27_ u_core_u_seu_qc_27_ VDD VSS / sg13g2_nand2_1
X_2951_ u_core_u_seu_u_tmr_a_d_28_ _0395_ _0623_ _0624_ VDD VSS / sg13g2_o21ai_1
X_2952_ _0625_ u_core_u_seu_qb_28_ u_core_u_seu_qc_28_ VDD VSS / sg13g2_nor2_1
X_2953_ _0626_ u_core_u_seu_qb_28_ u_core_u_seu_qc_28_ u_core_u_seu_qa_28_ VDD VSS / sg13g2_a21oi_1
X_2954_ u_core_u_seu_u_tmr_a_d_29_ _0625_ _0626_ VDD VSS / sg13g2_nor2_1
X_2955_ _0627_ u_core_u_seu_qb_29_ u_core_u_seu_qc_29_ VDD VSS / sg13g2_nor2_1
X_2956_ _0628_ u_core_u_seu_qb_29_ u_core_u_seu_qc_29_ VDD VSS / sg13g2_nand2_1
X_2957_ u_core_u_seu_u_tmr_a_d_30_ _0396_ _0627_ _0628_ VDD VSS / sg13g2_o21ai_1
X_2958_ _0629_ u_core_u_seu_qb_30_ u_core_u_seu_qc_30_ VDD VSS / sg13g2_nor2_1
X_2959_ _0630_ u_core_u_seu_qb_30_ u_core_u_seu_qc_30_ VDD VSS / sg13g2_nand2_1
X_2960_ u_core_u_seu_u_tmr_a_d_31_ _0397_ _0629_ _0630_ VDD VSS / sg13g2_o21ai_1
X_2961_ _0631_ u_core_u_seu_qb_31_ u_core_u_seu_qc_31_ VDD VSS / sg13g2_nor2_1
X_2962_ _0632_ u_core_u_seu_qb_31_ u_core_u_seu_qc_31_ VDD VSS / sg13g2_nand2_1
X_2963_ u_core_u_seu_u_tmr_a_d_32_ _0398_ _0631_ _0632_ VDD VSS / sg13g2_o21ai_1
X_2964_ _0633_ u_core_u_seu_qb_32_ u_core_u_seu_qc_32_ VDD VSS / sg13g2_nor2_1
X_2965_ _0634_ u_core_u_seu_qb_32_ u_core_u_seu_qc_32_ u_core_u_seu_qa_32_ VDD VSS / sg13g2_a21oi_1
X_2966_ u_core_u_seu_u_tmr_a_d_33_ _0633_ _0634_ VDD VSS / sg13g2_nor2_1
X_2967_ _0635_ u_core_u_seu_qb_33_ u_core_u_seu_qc_33_ VDD VSS / sg13g2_nor2_1
X_2968_ _0636_ u_core_u_seu_qb_33_ u_core_u_seu_qc_33_ u_core_u_seu_qa_33_ VDD VSS / sg13g2_a21oi_1
X_2969_ u_core_u_seu_u_tmr_a_d_34_ _0635_ _0636_ VDD VSS / sg13g2_nor2_1
X_2970_ _0637_ u_core_u_seu_qb_34_ u_core_u_seu_qc_34_ VDD VSS / sg13g2_nor2_1
X_2971_ _0638_ u_core_u_seu_qb_34_ u_core_u_seu_qc_34_ VDD VSS / sg13g2_nand2_1
X_2972_ u_core_u_seu_u_tmr_a_d_35_ _0399_ _0637_ _0638_ VDD VSS / sg13g2_o21ai_1
X_2973_ _0639_ u_core_u_seu_qb_35_ u_core_u_seu_qc_35_ VDD VSS / sg13g2_nor2_1
X_2974_ _0640_ u_core_u_seu_qb_35_ u_core_u_seu_qc_35_ VDD VSS / sg13g2_nand2_1
X_2975_ u_core_u_seu_u_tmr_a_d_36_ _0400_ _0639_ _0640_ VDD VSS / sg13g2_o21ai_1
X_2976_ _0641_ u_core_u_seu_qb_36_ u_core_u_seu_qc_36_ VDD VSS / sg13g2_nor2_1
X_2977_ _0642_ u_core_u_seu_qb_36_ u_core_u_seu_qc_36_ VDD VSS / sg13g2_nand2_1
X_2978_ u_core_u_seu_u_tmr_a_d_37_ _0401_ _0641_ _0642_ VDD VSS / sg13g2_o21ai_1
X_2979_ _0643_ u_core_u_seu_qb_37_ u_core_u_seu_qc_37_ VDD VSS / sg13g2_nor2_1
X_2980_ _0644_ u_core_u_seu_qb_37_ u_core_u_seu_qc_37_ VDD VSS / sg13g2_nand2_1
X_2981_ u_core_u_seu_u_tmr_a_d_38_ _0402_ _0643_ _0644_ VDD VSS / sg13g2_o21ai_1
X_2982_ _0645_ u_core_u_seu_qb_38_ u_core_u_seu_qc_38_ VDD VSS / sg13g2_nor2_1
X_2983_ _0646_ u_core_u_seu_qb_38_ u_core_u_seu_qc_38_ VDD VSS / sg13g2_nand2_1
X_2984_ u_core_u_seu_u_tmr_a_d_39_ _0403_ _0645_ _0646_ VDD VSS / sg13g2_o21ai_1
X_2985_ _0647_ u_core_u_seu_qb_39_ u_core_u_seu_qc_39_ VDD VSS / sg13g2_nor2_1
X_2986_ _0648_ u_core_u_seu_qb_39_ u_core_u_seu_qc_39_ VDD VSS / sg13g2_nand2_1
X_2987_ u_core_u_seu_u_tmr_a_d_40_ _0404_ _0647_ _0648_ VDD VSS / sg13g2_o21ai_1
X_2988_ _0649_ u_core_u_seu_qb_40_ u_core_u_seu_qc_40_ VDD VSS / sg13g2_nor2_1
X_2989_ _0650_ u_core_u_seu_qb_40_ u_core_u_seu_qc_40_ VDD VSS / sg13g2_nand2_1
X_2990_ u_core_u_seu_u_tmr_a_d_41_ _0405_ _0649_ _0650_ VDD VSS / sg13g2_o21ai_1
X_2991_ _0651_ u_core_u_seu_qb_41_ u_core_u_seu_qc_41_ VDD VSS / sg13g2_nor2_1
X_2992_ _0652_ u_core_u_seu_qb_41_ u_core_u_seu_qc_41_ u_core_u_seu_qa_41_ VDD VSS / sg13g2_a21oi_1
X_2993_ u_core_u_seu_u_tmr_a_d_42_ _0651_ _0652_ VDD VSS / sg13g2_nor2_1
X_2994_ _0653_ u_core_u_seu_qb_42_ u_core_u_seu_qc_42_ VDD VSS / sg13g2_nor2_1
X_2995_ _0654_ u_core_u_seu_qb_42_ u_core_u_seu_qc_42_ VDD VSS / sg13g2_nand2_1
X_2996_ u_core_u_seu_u_tmr_a_d_43_ _0406_ _0653_ _0654_ VDD VSS / sg13g2_o21ai_1
X_2997_ _0655_ u_core_u_seu_qb_43_ u_core_u_seu_qc_43_ VDD VSS / sg13g2_nor2_1
X_2998_ _0656_ u_core_u_seu_qb_43_ u_core_u_seu_qc_43_ VDD VSS / sg13g2_nand2_1
X_2999_ u_core_u_seu_u_tmr_a_d_44_ _0407_ _0655_ _0656_ VDD VSS / sg13g2_o21ai_1
X_3000_ _0657_ u_core_u_seu_qb_44_ u_core_u_seu_qc_44_ VDD VSS / sg13g2_nor2_1
X_3001_ _0658_ u_core_u_seu_qb_44_ u_core_u_seu_qc_44_ VDD VSS / sg13g2_nand2_1
X_3002_ u_core_u_seu_u_tmr_a_d_45_ _0408_ _0657_ _0658_ VDD VSS / sg13g2_o21ai_1
X_3003_ _0659_ u_core_u_seu_qb_45_ u_core_u_seu_qc_45_ VDD VSS / sg13g2_nor2_1
X_3004_ _0660_ u_core_u_seu_qb_45_ u_core_u_seu_qc_45_ u_core_u_seu_qa_45_ VDD VSS / sg13g2_a21oi_1
X_3005_ u_core_u_seu_u_tmr_a_d_46_ _0659_ _0660_ VDD VSS / sg13g2_nor2_1
X_3006_ _0661_ u_core_u_seu_qb_46_ u_core_u_seu_qc_46_ VDD VSS / sg13g2_nor2_1
X_3007_ _0662_ u_core_u_seu_qb_46_ u_core_u_seu_qc_46_ VDD VSS / sg13g2_nand2_1
X_3008_ u_core_u_seu_u_tmr_a_d_47_ _0409_ _0661_ _0662_ VDD VSS / sg13g2_o21ai_1
X_3009_ _0663_ u_core_u_seu_qb_47_ u_core_u_seu_qc_47_ VDD VSS / sg13g2_nor2_1
X_3010_ _0664_ u_core_u_seu_qb_47_ u_core_u_seu_qc_47_ u_core_u_seu_qa_47_ VDD VSS / sg13g2_a21oi_1
X_3011_ u_core_u_seu_u_tmr_a_d_48_ _0663_ _0664_ VDD VSS / sg13g2_nor2_1
X_3012_ _0665_ u_core_u_seu_qb_48_ u_core_u_seu_qc_48_ VDD VSS / sg13g2_nor2_1
X_3013_ _0666_ u_core_u_seu_qb_48_ u_core_u_seu_qc_48_ u_core_u_seu_qa_48_ VDD VSS / sg13g2_a21oi_1
X_3014_ u_core_u_seu_u_tmr_a_d_49_ _0665_ _0666_ VDD VSS / sg13g2_nor2_1
X_3015_ _0667_ u_core_u_seu_qb_49_ u_core_u_seu_qc_49_ VDD VSS / sg13g2_nor2_1
X_3016_ _0668_ u_core_u_seu_qb_49_ u_core_u_seu_qc_49_ VDD VSS / sg13g2_nand2_1
X_3017_ u_core_u_seu_u_tmr_a_d_50_ _0410_ _0667_ _0668_ VDD VSS / sg13g2_o21ai_1
X_3018_ _0669_ u_core_u_seu_qb_50_ u_core_u_seu_qc_50_ VDD VSS / sg13g2_nor2_1
X_3019_ _0670_ u_core_u_seu_qb_50_ u_core_u_seu_qc_50_ VDD VSS / sg13g2_nand2_1
X_3020_ u_core_u_seu_u_tmr_a_d_51_ _0411_ _0669_ _0670_ VDD VSS / sg13g2_o21ai_1
X_3021_ _0671_ u_core_u_seu_qb_51_ u_core_u_seu_qc_51_ VDD VSS / sg13g2_nor2_1
X_3022_ _0672_ u_core_u_seu_qb_51_ u_core_u_seu_qc_51_ VDD VSS / sg13g2_nand2_1
X_3023_ u_core_u_seu_u_tmr_a_d_52_ _0412_ _0671_ _0672_ VDD VSS / sg13g2_o21ai_1
X_3024_ _0673_ u_core_u_seu_qb_52_ u_core_u_seu_qc_52_ VDD VSS / sg13g2_nor2_1
X_3025_ _0674_ u_core_u_seu_qb_52_ u_core_u_seu_qc_52_ u_core_u_seu_qa_52_ VDD VSS / sg13g2_a21oi_1
X_3026_ u_core_u_seu_u_tmr_a_d_53_ _0673_ _0674_ VDD VSS / sg13g2_nor2_1
X_3027_ _0675_ u_core_u_seu_qb_53_ u_core_u_seu_qc_53_ VDD VSS / sg13g2_nor2_1
X_3028_ _0676_ u_core_u_seu_qb_53_ u_core_u_seu_qc_53_ VDD VSS / sg13g2_nand2_1
X_3029_ u_core_u_seu_u_tmr_a_d_54_ _0413_ _0675_ _0676_ VDD VSS / sg13g2_o21ai_1
X_3030_ _0677_ u_core_u_seu_qb_54_ u_core_u_seu_qc_54_ VDD VSS / sg13g2_nor2_1
X_3031_ _0678_ u_core_u_seu_qb_54_ u_core_u_seu_qc_54_ u_core_u_seu_qa_54_ VDD VSS / sg13g2_a21oi_1
X_3032_ u_core_u_seu_u_tmr_a_d_55_ _0677_ _0678_ VDD VSS / sg13g2_nor2_1
X_3033_ _0679_ u_core_u_seu_qb_55_ u_core_u_seu_qc_55_ VDD VSS / sg13g2_nor2_1
X_3034_ _0680_ u_core_u_seu_qb_55_ u_core_u_seu_qc_55_ VDD VSS / sg13g2_nand2_1
X_3035_ u_core_u_seu_u_tmr_a_d_56_ _0414_ _0679_ _0680_ VDD VSS / sg13g2_o21ai_1
X_3036_ _0681_ u_core_u_seu_qb_56_ u_core_u_seu_qc_56_ VDD VSS / sg13g2_nor2_1
X_3037_ _0682_ u_core_u_seu_qb_56_ u_core_u_seu_qc_56_ u_core_u_seu_qa_56_ VDD VSS / sg13g2_a21oi_1
X_3038_ u_core_u_seu_u_tmr_a_d_57_ _0681_ _0682_ VDD VSS / sg13g2_nor2_1
X_3039_ _0683_ u_core_u_seu_qb_57_ u_core_u_seu_qc_57_ VDD VSS / sg13g2_nor2_1
X_3040_ _0684_ u_core_u_seu_qb_57_ u_core_u_seu_qc_57_ VDD VSS / sg13g2_nand2_1
X_3041_ u_core_u_seu_u_tmr_a_d_58_ _0416_ _0683_ _0684_ VDD VSS / sg13g2_o21ai_1
X_3042_ _0685_ u_core_u_seu_qb_58_ u_core_u_seu_qc_58_ VDD VSS / sg13g2_nor2_1
X_3043_ _0686_ u_core_u_seu_qb_58_ u_core_u_seu_qc_58_ VDD VSS / sg13g2_nand2_1
X_3044_ u_core_u_seu_u_tmr_a_d_59_ _0417_ _0685_ _0686_ VDD VSS / sg13g2_o21ai_1
X_3045_ _0687_ u_core_u_seu_qb_59_ u_core_u_seu_qc_59_ VDD VSS / sg13g2_nor2_1
X_3046_ _0688_ u_core_u_seu_qb_59_ u_core_u_seu_qc_59_ VDD VSS / sg13g2_nand2_1
X_3047_ u_core_u_seu_u_tmr_a_d_60_ _0418_ _0687_ _0688_ VDD VSS / sg13g2_o21ai_1
X_3048_ _0689_ u_core_u_seu_qb_60_ u_core_u_seu_qc_60_ VDD VSS / sg13g2_nor2_1
X_3049_ _0690_ u_core_u_seu_qb_60_ u_core_u_seu_qc_60_ VDD VSS / sg13g2_nand2_1
X_3050_ u_core_u_seu_u_tmr_a_d_61_ _0419_ _0689_ _0690_ VDD VSS / sg13g2_o21ai_1
X_3051_ _0691_ u_core_u_seu_qb_61_ u_core_u_seu_qc_61_ VDD VSS / sg13g2_nor2_1
X_3052_ _0692_ u_core_u_seu_qb_61_ u_core_u_seu_qc_61_ u_core_u_seu_qa_61_ VDD VSS / sg13g2_a21oi_1
X_3053_ u_core_u_seu_u_tmr_a_d_62_ _0691_ _0692_ VDD VSS / sg13g2_nor2_1
X_3054_ _0693_ u_core_u_seu_qb_62_ u_core_u_seu_qc_62_ VDD VSS / sg13g2_nor2_1
X_3055_ _0694_ u_core_u_seu_qb_62_ u_core_u_seu_qc_62_ VDD VSS / sg13g2_nand2_1
X_3056_ u_core_u_seu_u_tmr_a_d_63_ _0420_ _0693_ _0694_ VDD VSS / sg13g2_o21ai_1
X_3057_ _0695_ u_core_u_seu_qb_63_ u_core_u_seu_qc_63_ VDD VSS / sg13g2_nor2_1
X_3058_ _0696_ u_core_u_seu_qb_63_ u_core_u_seu_qc_63_ VDD VSS / sg13g2_nand2_1
X_3059_ u_core_u_seu_u_tmr_a_d_64_ _0421_ _0695_ _0696_ VDD VSS / sg13g2_o21ai_1
X_3060_ _0697_ u_core_u_seu_qb_64_ u_core_u_seu_qc_64_ VDD VSS / sg13g2_nor2_1
X_3061_ _0698_ u_core_u_seu_qb_64_ u_core_u_seu_qc_64_ VDD VSS / sg13g2_nand2_1
X_3062_ u_core_u_seu_u_tmr_a_d_65_ _0422_ _0697_ _0698_ VDD VSS / sg13g2_o21ai_1
X_3063_ _0699_ u_core_u_seu_qb_65_ u_core_u_seu_qc_65_ VDD VSS / sg13g2_nor2_1
X_3064_ _0700_ u_core_u_seu_qb_65_ u_core_u_seu_qc_65_ VDD VSS / sg13g2_and2_1
X_3065_ _0701_ u_core_u_seu_qa_65_ _0700_ VDD VSS / sg13g2_nor2_1
X_3066_ u_core_u_seu_u_tmr_a_d_66_ _0699_ _0701_ VDD VSS / sg13g2_nor2_1
X_3067_ _0702_ u_core_u_seu_qb_66_ u_core_u_seu_qc_66_ VDD VSS / sg13g2_nor2_1
X_3068_ _0703_ u_core_u_seu_qb_66_ u_core_u_seu_qc_66_ VDD VSS / sg13g2_nand2_1
X_3069_ u_core_u_seu_u_tmr_a_d_67_ _0423_ _0702_ _0703_ VDD VSS / sg13g2_o21ai_1
X_3070_ _0704_ u_core_u_seu_qb_67_ u_core_u_seu_qc_67_ VDD VSS / sg13g2_nor2_1
X_3071_ _0705_ u_core_u_seu_qb_67_ u_core_u_seu_qc_67_ VDD VSS / sg13g2_nand2_1
X_3072_ u_core_u_seu_u_tmr_a_d_68_ _0424_ _0704_ _0705_ VDD VSS / sg13g2_o21ai_1
X_3073_ _0706_ u_core_u_seu_qb_68_ u_core_u_seu_qc_68_ VDD VSS / sg13g2_nor2_1
X_3074_ _0707_ u_core_u_seu_qb_68_ u_core_u_seu_qc_68_ VDD VSS / sg13g2_nand2_1
X_3075_ u_core_u_seu_u_tmr_a_d_69_ _0425_ _0706_ _0707_ VDD VSS / sg13g2_o21ai_1
X_3076_ _0708_ u_core_u_seu_qb_69_ u_core_u_seu_qc_69_ VDD VSS / sg13g2_nor2_1
X_3077_ _0709_ u_core_u_seu_qb_69_ u_core_u_seu_qc_69_ VDD VSS / sg13g2_nand2_1
X_3078_ u_core_u_seu_u_tmr_a_d_70_ _0426_ _0708_ _0709_ VDD VSS / sg13g2_o21ai_1
X_3079_ _0710_ u_core_u_seu_qb_70_ u_core_u_seu_qc_70_ VDD VSS / sg13g2_nor2_1
X_3080_ _0711_ u_core_u_seu_qb_70_ u_core_u_seu_qc_70_ VDD VSS / sg13g2_nand2_1
X_3081_ u_core_u_seu_u_tmr_a_d_71_ _0427_ _0710_ _0711_ VDD VSS / sg13g2_o21ai_1
X_3082_ _0712_ u_core_u_seu_qb_71_ u_core_u_seu_qc_71_ VDD VSS / sg13g2_nor2_1
X_3083_ _0713_ u_core_u_seu_qb_71_ u_core_u_seu_qc_71_ u_core_u_seu_qa_71_ VDD VSS / sg13g2_a21oi_1
X_3084_ u_core_u_seu_u_tmr_a_d_72_ _0712_ _0713_ VDD VSS / sg13g2_nor2_1
X_3085_ _0714_ u_core_u_seu_qb_72_ u_core_u_seu_qc_72_ VDD VSS / sg13g2_nor2_1
X_3086_ _0715_ u_core_u_seu_qb_72_ u_core_u_seu_qc_72_ VDD VSS / sg13g2_nand2_1
X_3087_ u_core_u_seu_u_tmr_a_d_73_ _0428_ _0714_ _0715_ VDD VSS / sg13g2_o21ai_1
X_3088_ _0716_ u_core_u_seu_qb_73_ u_core_u_seu_qc_73_ VDD VSS / sg13g2_nor2_1
X_3089_ _0717_ u_core_u_seu_qb_73_ u_core_u_seu_qc_73_ VDD VSS / sg13g2_nand2_1
X_3090_ u_core_u_seu_u_tmr_a_d_74_ _0429_ _0716_ _0717_ VDD VSS / sg13g2_o21ai_1
X_3091_ _0718_ u_core_u_seu_qb_74_ u_core_u_seu_qc_74_ VDD VSS / sg13g2_nor2_1
X_3092_ _0719_ u_core_u_seu_qb_74_ u_core_u_seu_qc_74_ VDD VSS / sg13g2_nand2_1
X_3093_ u_core_u_seu_u_tmr_a_d_75_ _0430_ _0718_ _0719_ VDD VSS / sg13g2_o21ai_1
X_3094_ _0720_ u_core_u_seu_qb_75_ u_core_u_seu_qc_75_ VDD VSS / sg13g2_nor2_1
X_3095_ _0721_ u_core_u_seu_qb_75_ u_core_u_seu_qc_75_ VDD VSS / sg13g2_nand2_1
X_3096_ u_core_u_seu_u_tmr_a_d_76_ _0431_ _0720_ _0721_ VDD VSS / sg13g2_o21ai_1
X_3097_ _0722_ u_core_u_seu_qb_76_ u_core_u_seu_qc_76_ VDD VSS / sg13g2_nor2_1
X_3098_ _0723_ u_core_u_seu_qb_76_ u_core_u_seu_qc_76_ VDD VSS / sg13g2_nand2_1
X_3099_ u_core_u_seu_u_tmr_a_d_77_ _0432_ _0722_ _0723_ VDD VSS / sg13g2_o21ai_1
X_3100_ _0724_ u_core_u_seu_qb_77_ u_core_u_seu_qc_77_ VDD VSS / sg13g2_nor2_1
X_3101_ _0725_ u_core_u_seu_qb_77_ u_core_u_seu_qc_77_ VDD VSS / sg13g2_nand2_1
X_3102_ u_core_u_seu_u_tmr_a_d_78_ _0433_ _0724_ _0725_ VDD VSS / sg13g2_o21ai_1
X_3103_ _0726_ u_core_u_seu_qb_78_ u_core_u_seu_qc_78_ VDD VSS / sg13g2_nor2_1
X_3104_ _0727_ u_core_u_seu_qb_78_ u_core_u_seu_qc_78_ VDD VSS / sg13g2_nand2_1
X_3105_ u_core_u_seu_u_tmr_a_d_79_ _0434_ _0726_ _0727_ VDD VSS / sg13g2_o21ai_1
X_3106_ _0728_ u_core_u_seu_qb_79_ u_core_u_seu_qc_79_ VDD VSS / sg13g2_nor2_1
X_3107_ _0729_ u_core_u_seu_qb_79_ u_core_u_seu_qc_79_ VDD VSS / sg13g2_nand2_1
X_3108_ u_core_u_seu_u_tmr_a_d_80_ _0435_ _0728_ _0729_ VDD VSS / sg13g2_o21ai_1
X_3109_ _0730_ u_core_u_seu_qb_80_ u_core_u_seu_qc_80_ VDD VSS / sg13g2_nor2_1
X_3110_ _0731_ u_core_u_seu_qb_80_ u_core_u_seu_qc_80_ VDD VSS / sg13g2_nand2_1
X_3111_ u_core_u_seu_u_tmr_a_d_81_ _0436_ _0730_ _0731_ VDD VSS / sg13g2_o21ai_1
X_3112_ _0732_ u_core_u_seu_qb_81_ u_core_u_seu_qc_81_ VDD VSS / sg13g2_nor2_1
X_3113_ _0733_ u_core_u_seu_qb_81_ u_core_u_seu_qc_81_ VDD VSS / sg13g2_nand2_1
X_3114_ u_core_u_seu_u_tmr_a_d_82_ _0437_ _0732_ _0733_ VDD VSS / sg13g2_o21ai_1
X_3115_ _0734_ u_core_u_seu_qb_82_ u_core_u_seu_qc_82_ VDD VSS / sg13g2_nor2_1
X_3116_ _0735_ u_core_u_seu_qb_82_ u_core_u_seu_qc_82_ VDD VSS / sg13g2_nand2_1
X_3117_ u_core_u_seu_u_tmr_a_d_83_ _0438_ _0734_ _0735_ VDD VSS / sg13g2_o21ai_1
X_3118_ _0736_ u_core_u_seu_qb_83_ u_core_u_seu_qc_83_ VDD VSS / sg13g2_nor2_1
X_3119_ _0737_ u_core_u_seu_qb_83_ u_core_u_seu_qc_83_ VDD VSS / sg13g2_nand2_1
X_3120_ u_core_u_seu_u_tmr_a_d_84_ _0439_ _0736_ _0737_ VDD VSS / sg13g2_o21ai_1
X_3121_ _0738_ u_core_u_seu_qb_84_ u_core_u_seu_qc_84_ VDD VSS / sg13g2_nor2_1
X_3122_ _0739_ u_core_u_seu_qb_84_ u_core_u_seu_qc_84_ VDD VSS / sg13g2_nand2_1
X_3123_ u_core_u_seu_u_tmr_a_d_85_ _0440_ _0738_ _0739_ VDD VSS / sg13g2_o21ai_1
X_3124_ _0740_ u_core_u_seu_qb_85_ u_core_u_seu_qc_85_ VDD VSS / sg13g2_nor2_1
X_3125_ _0741_ u_core_u_seu_qb_85_ u_core_u_seu_qc_85_ VDD VSS / sg13g2_nand2_1
X_3126_ u_core_u_seu_u_tmr_a_d_86_ _0441_ _0740_ _0741_ VDD VSS / sg13g2_o21ai_1
X_3127_ _0742_ u_core_u_seu_qb_86_ u_core_u_seu_qc_86_ VDD VSS / sg13g2_nor2_1
X_3128_ _0743_ u_core_u_seu_qb_86_ u_core_u_seu_qc_86_ VDD VSS / sg13g2_nand2_1
X_3129_ u_core_u_seu_u_tmr_a_d_87_ _0442_ _0742_ _0743_ VDD VSS / sg13g2_o21ai_1
X_3130_ _0744_ u_core_u_seu_qb_87_ u_core_u_seu_qc_87_ VDD VSS / sg13g2_nor2_1
X_3131_ _0745_ u_core_u_seu_qb_87_ u_core_u_seu_qc_87_ u_core_u_seu_qa_87_ VDD VSS / sg13g2_a21oi_1
X_3132_ u_core_u_seu_u_tmr_a_d_88_ _0744_ _0745_ VDD VSS / sg13g2_nor2_1
X_3133_ _0746_ u_core_u_seu_qb_88_ u_core_u_seu_qc_88_ VDD VSS / sg13g2_nor2_1
X_3134_ _0747_ u_core_u_seu_qb_88_ u_core_u_seu_qc_88_ VDD VSS / sg13g2_nand2_1
X_3135_ u_core_u_seu_u_tmr_a_d_89_ _0443_ _0746_ _0747_ VDD VSS / sg13g2_o21ai_1
X_3136_ _0748_ u_core_u_seu_qb_89_ u_core_u_seu_qc_89_ VDD VSS / sg13g2_nor2_1
X_3137_ _0749_ u_core_u_seu_qb_89_ u_core_u_seu_qc_89_ VDD VSS / sg13g2_nand2_1
X_3138_ u_core_u_seu_u_tmr_a_d_90_ _0444_ _0748_ _0749_ VDD VSS / sg13g2_o21ai_1
X_3139_ _0750_ u_core_u_seu_qb_90_ u_core_u_seu_qc_90_ VDD VSS / sg13g2_nor2_1
X_3140_ _0751_ u_core_u_seu_qb_90_ u_core_u_seu_qc_90_ u_core_u_seu_qa_90_ VDD VSS / sg13g2_a21oi_1
X_3141_ u_core_u_seu_u_tmr_a_d_91_ _0750_ _0751_ VDD VSS / sg13g2_nor2_1
X_3142_ _0752_ u_core_u_seu_qb_91_ u_core_u_seu_qc_91_ VDD VSS / sg13g2_nor2_1
X_3143_ _0753_ u_core_u_seu_qb_91_ u_core_u_seu_qc_91_ VDD VSS / sg13g2_nand2_1
X_3144_ u_core_u_seu_u_tmr_a_d_92_ _0445_ _0752_ _0753_ VDD VSS / sg13g2_o21ai_1
X_3145_ _0754_ u_core_u_seu_qb_92_ u_core_u_seu_qc_92_ VDD VSS / sg13g2_nor2_1
X_3146_ _0755_ u_core_u_seu_qb_92_ u_core_u_seu_qc_92_ VDD VSS / sg13g2_nand2_1
X_3147_ u_core_u_seu_u_tmr_a_d_93_ _0446_ _0754_ _0755_ VDD VSS / sg13g2_o21ai_1
X_3148_ _0756_ u_core_u_seu_qb_93_ u_core_u_seu_qc_93_ VDD VSS / sg13g2_nor2_1
X_3149_ _0757_ u_core_u_seu_qb_93_ u_core_u_seu_qc_93_ VDD VSS / sg13g2_nand2_1
X_3150_ u_core_u_seu_u_tmr_a_d_94_ _0447_ _0756_ _0757_ VDD VSS / sg13g2_o21ai_1
X_3151_ _0758_ u_core_u_seu_qb_94_ u_core_u_seu_qc_94_ VDD VSS / sg13g2_nor2_1
X_3152_ _0759_ u_core_u_seu_qb_94_ u_core_u_seu_qc_94_ VDD VSS / sg13g2_nand2_1
X_3153_ u_core_u_seu_u_tmr_a_d_95_ _0448_ _0758_ _0759_ VDD VSS / sg13g2_o21ai_1
X_3154_ _0760_ u_core_u_seu_qb_95_ u_core_u_seu_qc_95_ VDD VSS / sg13g2_nor2_1
X_3155_ _0761_ u_core_u_seu_qb_95_ u_core_u_seu_qc_95_ VDD VSS / sg13g2_nand2_1
X_3156_ u_core_u_seu_u_tmr_a_d_96_ _0449_ _0760_ _0761_ VDD VSS / sg13g2_o21ai_1
X_3157_ _0762_ u_core_u_seu_qb_96_ u_core_u_seu_qc_96_ VDD VSS / sg13g2_nor2_1
X_3158_ _0763_ u_core_u_seu_qb_96_ u_core_u_seu_qc_96_ u_core_u_seu_qa_96_ VDD VSS / sg13g2_a21oi_1
X_3159_ u_core_u_seu_u_tmr_a_d_97_ _0762_ _0763_ VDD VSS / sg13g2_nor2_1
X_3160_ _0764_ u_core_u_seu_qb_97_ u_core_u_seu_qc_97_ VDD VSS / sg13g2_nor2_1
X_3161_ _0765_ u_core_u_seu_qb_97_ u_core_u_seu_qc_97_ u_core_u_seu_qa_97_ VDD VSS / sg13g2_a21oi_1
X_3162_ u_core_u_seu_u_tmr_a_d_98_ _0764_ _0765_ VDD VSS / sg13g2_nor2_1
X_3163_ _0766_ u_core_u_seu_qb_98_ u_core_u_seu_qc_98_ VDD VSS / sg13g2_nor2_1
X_3164_ _0767_ u_core_u_seu_qb_98_ u_core_u_seu_qc_98_ VDD VSS / sg13g2_nand2_1
X_3165_ u_core_u_seu_u_tmr_a_d_99_ _0450_ _0766_ _0767_ VDD VSS / sg13g2_o21ai_1
X_3166_ _0768_ u_core_u_seu_qb_99_ u_core_u_seu_qc_99_ VDD VSS / sg13g2_nor2_1
X_3167_ _0769_ u_core_u_seu_qb_99_ u_core_u_seu_qc_99_ VDD VSS / sg13g2_nand2_1
X_3168_ u_core_u_seu_u_tmr_a_d_100_ _0451_ _0768_ _0769_ VDD VSS / sg13g2_o21ai_1
X_3169_ _0770_ u_core_u_seu_qb_100_ u_core_u_seu_qc_100_ VDD VSS / sg13g2_nor2_1
X_3170_ _0771_ u_core_u_seu_qb_100_ u_core_u_seu_qc_100_ VDD VSS / sg13g2_nand2_1
X_3171_ u_core_u_seu_u_tmr_a_d_101_ _0452_ _0770_ _0771_ VDD VSS / sg13g2_o21ai_1
X_3172_ _0772_ u_core_u_seu_qb_101_ u_core_u_seu_qc_101_ VDD VSS / sg13g2_nor2_1
X_3173_ _0773_ u_core_u_seu_qb_101_ u_core_u_seu_qc_101_ VDD VSS / sg13g2_nand2_1
X_3174_ u_core_u_seu_u_tmr_a_d_102_ _0453_ _0772_ _0773_ VDD VSS / sg13g2_o21ai_1
X_3175_ _0774_ u_core_u_seu_qb_102_ u_core_u_seu_qc_102_ VDD VSS / sg13g2_nor2_1
X_3176_ _0775_ u_core_u_seu_qb_102_ u_core_u_seu_qc_102_ VDD VSS / sg13g2_nand2_1
X_3177_ u_core_u_seu_u_tmr_a_d_103_ _0454_ _0774_ _0775_ VDD VSS / sg13g2_o21ai_1
X_3178_ _0776_ u_core_u_seu_qb_103_ u_core_u_seu_qc_103_ VDD VSS / sg13g2_nor2_1
X_3179_ _0777_ u_core_u_seu_qb_103_ u_core_u_seu_qc_103_ VDD VSS / sg13g2_nand2_1
X_3180_ u_core_u_seu_u_tmr_a_d_104_ _0455_ _0776_ _0777_ VDD VSS / sg13g2_o21ai_1
X_3181_ _0778_ u_core_u_seu_qb_104_ u_core_u_seu_qc_104_ VDD VSS / sg13g2_nor2_1
X_3182_ _0779_ u_core_u_seu_qb_104_ u_core_u_seu_qc_104_ u_core_u_seu_qa_104_ VDD VSS / sg13g2_a21oi_1
X_3183_ u_core_u_seu_u_tmr_a_d_105_ _0778_ _0779_ VDD VSS / sg13g2_nor2_1
X_3184_ _0780_ u_core_u_seu_qb_105_ u_core_u_seu_qc_105_ VDD VSS / sg13g2_nor2_1
X_3185_ _0781_ u_core_u_seu_qb_105_ u_core_u_seu_qc_105_ VDD VSS / sg13g2_nand2_1
X_3186_ u_core_u_seu_u_tmr_a_d_106_ _0456_ _0780_ _0781_ VDD VSS / sg13g2_o21ai_1
X_3187_ _0782_ u_core_u_seu_qb_106_ u_core_u_seu_qc_106_ VDD VSS / sg13g2_nor2_1
X_3188_ _0783_ u_core_u_seu_qb_106_ u_core_u_seu_qc_106_ VDD VSS / sg13g2_nand2_1
X_3189_ u_core_u_seu_u_tmr_a_d_107_ _0457_ _0782_ _0783_ VDD VSS / sg13g2_o21ai_1
X_3190_ _0784_ u_core_u_seu_qb_107_ u_core_u_seu_qc_107_ VDD VSS / sg13g2_nor2_1
X_3191_ _0785_ u_core_u_seu_qb_107_ u_core_u_seu_qc_107_ VDD VSS / sg13g2_nand2_1
X_3192_ u_core_u_seu_u_tmr_a_d_108_ _0458_ _0784_ _0785_ VDD VSS / sg13g2_o21ai_1
X_3193_ _0786_ u_core_u_seu_qb_108_ u_core_u_seu_qc_108_ VDD VSS / sg13g2_nor2_1
X_3194_ _0787_ u_core_u_seu_qb_108_ u_core_u_seu_qc_108_ VDD VSS / sg13g2_nand2_1
X_3195_ u_core_u_seu_u_tmr_a_d_109_ _0459_ _0786_ _0787_ VDD VSS / sg13g2_o21ai_1
X_3196_ _0788_ u_core_u_seu_qb_109_ u_core_u_seu_qc_109_ VDD VSS / sg13g2_nor2_1
X_3197_ _0789_ u_core_u_seu_qb_109_ u_core_u_seu_qc_109_ u_core_u_seu_qa_109_ VDD VSS / sg13g2_a21oi_1
X_3198_ u_core_u_seu_u_tmr_a_d_110_ _0788_ _0789_ VDD VSS / sg13g2_nor2_1
X_3199_ _0790_ u_core_u_seu_qb_110_ u_core_u_seu_qc_110_ VDD VSS / sg13g2_nor2_1
X_3200_ _0791_ u_core_u_seu_qb_110_ u_core_u_seu_qc_110_ u_core_u_seu_qa_110_ VDD VSS / sg13g2_a21oi_1
X_3201_ u_core_u_seu_u_tmr_a_d_111_ _0790_ _0791_ VDD VSS / sg13g2_nor2_1
X_3202_ _0792_ u_core_u_seu_qb_111_ u_core_u_seu_qc_111_ VDD VSS / sg13g2_nor2_1
X_3203_ _0793_ u_core_u_seu_qb_111_ u_core_u_seu_qc_111_ VDD VSS / sg13g2_nand2_1
X_3204_ u_core_u_seu_u_tmr_a_d_112_ _0460_ _0792_ _0793_ VDD VSS / sg13g2_o21ai_1
X_3205_ _0794_ u_core_u_seu_qb_112_ u_core_u_seu_qc_112_ VDD VSS / sg13g2_nor2_1
X_3206_ _0795_ u_core_u_seu_qb_112_ u_core_u_seu_qc_112_ VDD VSS / sg13g2_nand2_1
X_3207_ u_core_u_seu_u_tmr_a_d_113_ _0461_ _0794_ _0795_ VDD VSS / sg13g2_o21ai_1
X_3208_ _0796_ u_core_u_seu_qb_113_ u_core_u_seu_qc_113_ VDD VSS / sg13g2_nor2_1
X_3209_ _0797_ u_core_u_seu_qb_113_ u_core_u_seu_qc_113_ VDD VSS / sg13g2_nand2_1
X_3210_ u_core_u_seu_u_tmr_a_d_114_ _0462_ _0796_ _0797_ VDD VSS / sg13g2_o21ai_1
X_3211_ _0798_ u_core_u_seu_qb_114_ u_core_u_seu_qc_114_ VDD VSS / sg13g2_nor2_1
X_3212_ _0799_ u_core_u_seu_qb_114_ u_core_u_seu_qc_114_ VDD VSS / sg13g2_nand2_1
X_3213_ u_core_u_seu_u_tmr_a_d_115_ _0463_ _0798_ _0799_ VDD VSS / sg13g2_o21ai_1
X_3214_ _0800_ u_core_u_seu_qb_115_ u_core_u_seu_qc_115_ VDD VSS / sg13g2_nor2_1
X_3215_ _0801_ u_core_u_seu_qb_115_ u_core_u_seu_qc_115_ u_core_u_seu_qa_115_ VDD VSS / sg13g2_a21oi_1
X_3216_ u_core_u_seu_u_tmr_a_d_116_ _0800_ _0801_ VDD VSS / sg13g2_nor2_1
X_3217_ _0802_ u_core_u_seu_qb_116_ u_core_u_seu_qc_116_ VDD VSS / sg13g2_nor2_1
X_3218_ _0803_ u_core_u_seu_qb_116_ u_core_u_seu_qc_116_ VDD VSS / sg13g2_nand2_1
X_3219_ u_core_u_seu_u_tmr_a_d_117_ _0464_ _0802_ _0803_ VDD VSS / sg13g2_o21ai_1
X_3220_ _0804_ u_core_u_seu_qb_117_ u_core_u_seu_qc_117_ VDD VSS / sg13g2_nor2_1
X_3221_ _0805_ u_core_u_seu_qb_117_ u_core_u_seu_qc_117_ VDD VSS / sg13g2_nand2_1
X_3222_ u_core_u_seu_u_tmr_a_d_118_ _0465_ _0804_ _0805_ VDD VSS / sg13g2_o21ai_1
X_3223_ _0806_ u_core_u_seu_qb_118_ u_core_u_seu_qc_118_ VDD VSS / sg13g2_nor2_1
X_3224_ _0807_ u_core_u_seu_qb_118_ u_core_u_seu_qc_118_ VDD VSS / sg13g2_nand2_1
X_3225_ u_core_u_seu_u_tmr_a_d_119_ _0466_ _0806_ _0807_ VDD VSS / sg13g2_o21ai_1
X_3226_ _0808_ u_core_u_seu_qb_119_ u_core_u_seu_qc_119_ VDD VSS / sg13g2_nor2_1
X_3227_ _0809_ u_core_u_seu_qb_119_ u_core_u_seu_qc_119_ u_core_u_seu_qa_119_ VDD VSS / sg13g2_a21oi_1
X_3228_ u_core_u_seu_u_tmr_a_d_120_ _0808_ _0809_ VDD VSS / sg13g2_nor2_1
X_3229_ _0810_ u_core_u_seu_qb_120_ u_core_u_seu_qc_120_ VDD VSS / sg13g2_nor2_1
X_3230_ _0811_ u_core_u_seu_qb_120_ u_core_u_seu_qc_120_ VDD VSS / sg13g2_nand2_1
X_3231_ u_core_u_seu_u_tmr_a_d_121_ _0467_ _0810_ _0811_ VDD VSS / sg13g2_o21ai_1
X_3232_ _0812_ u_core_u_seu_qb_121_ u_core_u_seu_qc_121_ VDD VSS / sg13g2_nor2_1
X_3233_ _0813_ u_core_u_seu_qb_121_ u_core_u_seu_qc_121_ VDD VSS / sg13g2_nand2_1
X_3234_ u_core_u_seu_u_tmr_a_d_122_ _0468_ _0812_ _0813_ VDD VSS / sg13g2_o21ai_1
X_3235_ _0814_ u_core_u_seu_qb_122_ u_core_u_seu_qc_122_ VDD VSS / sg13g2_nor2_1
X_3236_ _0815_ u_core_u_seu_qb_122_ u_core_u_seu_qc_122_ VDD VSS / sg13g2_nand2_1
X_3237_ u_core_u_seu_u_tmr_a_d_123_ _0469_ _0814_ _0815_ VDD VSS / sg13g2_o21ai_1
X_3238_ _0816_ u_core_u_seu_qb_123_ u_core_u_seu_qc_123_ VDD VSS / sg13g2_nor2_1
X_3239_ _0817_ u_core_u_seu_qb_123_ u_core_u_seu_qc_123_ VDD VSS / sg13g2_nand2_1
X_3240_ u_core_u_seu_u_tmr_a_d_124_ _0470_ _0816_ _0817_ VDD VSS / sg13g2_o21ai_1
X_3241_ _0818_ u_core_u_seu_qb_124_ u_core_u_seu_qc_124_ VDD VSS / sg13g2_nor2_1
X_3242_ _0819_ u_core_u_seu_qb_124_ u_core_u_seu_qc_124_ VDD VSS / sg13g2_nand2_1
X_3243_ u_core_u_seu_u_tmr_a_d_125_ _0471_ _0818_ _0819_ VDD VSS / sg13g2_o21ai_1
X_3244_ _0820_ u_core_u_seu_qb_125_ u_core_u_seu_qc_125_ VDD VSS / sg13g2_nor2_1
X_3245_ _0821_ u_core_u_seu_qb_125_ u_core_u_seu_qc_125_ VDD VSS / sg13g2_nand2_1
X_3246_ u_core_u_seu_u_tmr_a_d_126_ _0472_ _0820_ _0821_ VDD VSS / sg13g2_o21ai_1
X_3247_ _0822_ u_core_u_seu_qb_126_ u_core_u_seu_qc_126_ VDD VSS / sg13g2_nor2_1
X_3248_ _0823_ u_core_u_seu_qb_126_ u_core_u_seu_qc_126_ VDD VSS / sg13g2_nand2_1
X_3249_ u_core_u_seu_u_tmr_a_d_127_ _0473_ _0822_ _0823_ VDD VSS / sg13g2_o21ai_1
X_3250_ _0824_ u_core_u_seu_u_phase_qb_0_ u_core_u_seu_u_phase_qc_0_ u_core_u_seu_u_phase_qa_0_ VDD VSS / sg13g2_a21o_1
X_3251_ u_core_u_seu_u_phase_d_0_ u_core_u_seu_u_phase_qb_0_ u_core_u_seu_u_phase_qc_0_ _0824_ VDD VSS / sg13g2_o21ai_1
X_3252_ _0825_ u_core_pattern_0_ _0545_ u_core_u_seu_u_phase_d_0_ VDD VSS / sg13g2_o21ai_1
X_3253_ _0826_ _0544_ u_core_pattern_1_ _0825_ VDD VSS / sg13g2_o21ai_1
X_3254_ u_core_u_seu_pat_bit _0826_ VDD VSS / sg13g2_inv_1
X_3255_ _0827_ u_core_u_regfile_wr_addr_0_ u_core_u_regfile_wr_en VDD VSS / sg13g2_nand2_1
X_3256_ _0828_ _0478_ net367 VDD VSS / sg13g2_nor2_1
X_3257_ _0829_ u_core_u_regfile_wr_addr_0_ _0477_ u_core_u_regfile_wr_en _0828_ VDD VSS / sg13g2_nand4_1
X_3258_ _0830_ _0479_ u_core_u_regfile_wr_addr_5_ u_core_u_regfile_wr_addr_6_ VDD VSS / sg13g2_nor3_1
X_3259_ _0831_ _0829_ _0830_ VDD VSS / sg13g2_nor2b_1
X_3260_ _0832_ net355 _0831_ VDD VSS / sg13g2_nand2_1
X_3261_ u_core_u_seu_u_tmr_a_d_0_ u_core_u_seu_pat_bit _0832_ VDD VSS / sg13g2_xnor2_1
X_3262_ u_core_u_serial_sclk_rst_n u_core_u_serial_frame_rst net292 VDD VSS / sg13g2_nor2b_1
X_3263_ _0008_ u_core_u_serial_wr_tog_d u_core_u_serial_u_sync_wr_q_0_ VDD VSS / sg13g2_xor2_1
X_3264_ _0006_ u_core_u_serial_rd_tog_d u_core_u_serial_u_sync_rd_q_0_ VDD VSS / sg13g2_xor2_1
X_3265_ net29 net38 net3 VDD VSS / sg13g2_nor2b_1
X_3266_ u_core_arst_n net3 net4 VDD VSS / sg13g2_and2_1
X_3267_ _0021_ u_core_u_regfile_osc_pre_0_ u_core_u_regfile_osc_pre_1_ VDD VSS / sg13g2_xor2_1
X_3268_ _0833_ u_core_u_regfile_osc_pre_0_ u_core_u_regfile_osc_pre_1_ u_core_u_regfile_osc_pre_2_ VDD VSS / sg13g2_nand3_1
X_3269_ _0834_ u_core_u_regfile_osc_pre_0_ u_core_u_regfile_osc_pre_1_ u_core_u_regfile_osc_pre_2_ VDD VSS / sg13g2_a21o_1
X_3270_ _0022_ _0833_ _0834_ VDD VSS / sg13g2_and2_1
X_3271_ _0835_ _0474_ _0833_ VDD VSS / sg13g2_nor2_1
X_3272_ _0023_ u_core_u_regfile_osc_pre_3_ _0833_ VDD VSS / sg13g2_xnor2_1
X_3273_ _0836_ u_core_u_regfile_osc_pre_4_ _0835_ VDD VSS / sg13g2_and2_1
X_3274_ _0024_ u_core_u_regfile_osc_pre_4_ _0835_ VDD VSS / sg13g2_xor2_1
X_3275_ _0025_ u_core_u_regfile_osc_pre_5_ _0836_ VDD VSS / sg13g2_xor2_1
X_3276_ _0837_ u_core_u_regfile_osc_pre_5_ u_core_u_regfile_osc_pre_6_ _0836_ VDD VSS / sg13g2_and3_1
X_3277_ _0838_ u_core_u_regfile_osc_pre_5_ _0836_ u_core_u_regfile_osc_pre_6_ VDD VSS / sg13g2_a21oi_1
X_3278_ _0026_ _0837_ _0838_ VDD VSS / sg13g2_nor2_1
X_3279_ _0839_ u_core_u_regfile_osc_pre_7_ _0837_ VDD VSS / sg13g2_and2_1
X_3280_ _0027_ u_core_u_regfile_osc_pre_7_ _0837_ VDD VSS / sg13g2_xor2_1
X_3281_ _0028_ u_core_u_regfile_osc_pre_8_ _0839_ VDD VSS / sg13g2_xor2_1
X_3282_ _0840_ u_core_u_regfile_osc_pre_8_ _0839_ u_core_u_regfile_osc_pre_9_ VDD VSS / sg13g2_a21oi_1
X_3283_ _0841_ u_core_u_regfile_osc_pre_8_ u_core_u_regfile_osc_pre_9_ _0839_ VDD VSS / sg13g2_nand3_1
X_3284_ _0029_ _0840_ _0841_ VDD VSS / sg13g2_nor2b_1
X_3285_ _0842_ u_core_u_regfile_osc_pre_8_ u_core_u_regfile_osc_pre_9_ u_core_u_regfile_osc_pre_10_ VDD VSS / sg13g2_and3_1
X_3286_ _0016_ u_core_u_regfile_osc_pre_10_ _0841_ VDD VSS / sg13g2_xnor2_1
X_3287_ _0843_ _0839_ _0842_ u_core_u_regfile_osc_pre_11_ VDD VSS / sg13g2_a21oi_1
X_3288_ _0844_ u_core_u_regfile_osc_pre_11_ _0839_ _0842_ VDD VSS / sg13g2_and3_1
X_3289_ _0017_ _0843_ _0844_ VDD VSS / sg13g2_nor2_1
X_3290_ _0018_ u_core_u_regfile_osc_pre_12_ _0844_ VDD VSS / sg13g2_xor2_1
X_3291_ _0845_ u_core_u_regfile_osc_pre_12_ _0844_ u_core_u_regfile_osc_pre_13_ VDD VSS / sg13g2_a21oi_1
X_3292_ _0846_ u_core_u_regfile_osc_pre_12_ u_core_u_regfile_osc_pre_13_ _0844_ VDD VSS / sg13g2_nand3_1
X_3293_ _0019_ _0845_ _0846_ VDD VSS / sg13g2_nor2b_1
X_3294_ _0020_ u_core_u_regfile_osc_pre_14_ _0846_ VDD VSS / sg13g2_xnor2_1
X_3295_ net9 u_core_u_trip_clr_pulse_0_ u_core_u_trip_clr_pulse_1_ VDD VSS / sg13g2_or2_1
X_3296_ _0847_ u_core_u_serial_idle_cnt_0_ u_core_u_serial_idle_cnt_1_ u_core_u_serial_idle_cnt_2_ VDD VSS / sg13g2_nand3_1
X_3297_ _0848_ _0483_ _0847_ VDD VSS / sg13g2_nor2_1
X_3298_ _0849_ u_core_u_serial_idle_cnt_4_ _0848_ VDD VSS / sg13g2_and2_1
X_3299_ _0850_ u_core_u_serial_idle_cnt_5_ _0849_ VDD VSS / sg13g2_nand2_1
X_3300_ _0851_ u_core_u_serial_idle_cnt_6_ _0850_ VDD VSS / sg13g2_nor2_1
X_3301_ _0852_ u_core_u_serial_idle_cnt_5_ u_core_u_serial_idle_cnt_4_ _0484_ _0848_ VDD VSS / sg13g2_nor4_1
X_3302_ _0005_ _0851_ _0852_ VDD VSS / sg13g2_or2_1
X_3303_ _0853_ net359 _0831_ VDD VSS / sg13g2_and2_1
X_3304_ _0854_ net359 _0831_ VDD VSS / sg13g2_nand2_1
X_3305_ _0855_ u_core_u_seu_u_run_cur_qb_0_ u_core_u_seu_u_run_cur_qc_0_ VDD VSS / sg13g2_nor2_1
X_3306_ _0856_ u_core_u_seu_u_run_cur_qb_0_ u_core_u_seu_u_run_cur_qc_0_ u_core_u_seu_u_run_cur_qa_0_ VDD VSS / sg13g2_a21oi_1
X_3307_ _0857_ _0855_ _0856_ VDD VSS / sg13g2_nor2_1
X_3308_ _0858_ _0857_ VDD VSS / sg13g2_inv_1
X_3309_ _0859_ u_core_u_seu_u_pat_d_qb_0_ u_core_u_seu_u_pat_d_qc_0_ u_core_u_seu_u_pat_d_qa_0_ VDD VSS / sg13g2_a21o_1
X_3310_ _0860_ u_core_u_seu_u_pat_d_qb_0_ u_core_u_seu_u_pat_d_qc_0_ _0859_ VDD VSS / sg13g2_o21ai_1
X_3311_ _0861_ _0544_ _0860_ VDD VSS / sg13g2_xnor2_1
X_3312_ _0862_ u_core_u_seu_u_pat_d_qa_1_ u_core_u_seu_u_pat_d_qc_1_ u_core_u_seu_u_pat_d_qb_1_ VDD VSS / sg13g2_a21oi_1
X_3313_ _0863_ u_core_u_seu_u_pat_d_qa_1_ u_core_u_seu_u_pat_d_qc_1_ VDD VSS / sg13g2_nor2_1
X_3314_ _0864_ _0862_ _0863_ u_core_pattern_1_ VDD VSS / sg13g2_o21ai_1
X_3315_ _0865_ u_core_u_seu_u_en_d_qa_0_ u_core_u_seu_u_en_d_qc_0_ u_core_u_seu_u_en_d_qb_0_ VDD VSS / sg13g2_o21ai_1
X_3316_ _0866_ u_core_u_seu_u_en_d_qa_0_ u_core_u_seu_u_en_d_qc_0_ _0054_ VDD VSS / sg13g2_a21oi_1
X_3317_ _0867_ _0865_ _0866_ VDD VSS / sg13g2_nand2_1
X_3318_ _0868_ u_core_pattern_1_ _0862_ _0863_ VDD VSS / sg13g2_or3_1
X_3319_ _0869_ _0861_ _0864_ _0867_ _0868_ VDD VSS / sg13g2_nand4_1
X_3320_ _0870_ u_core_u_seu_u_fill_qb_8_ u_core_u_seu_u_fill_qc_8_ VDD VSS / sg13g2_nor2_1
X_3321_ _0871_ u_core_u_seu_u_fill_qb_8_ u_core_u_seu_u_fill_qc_8_ u_core_u_seu_u_fill_qa_8_ VDD VSS / sg13g2_a21oi_1
X_3322_ _0872_ _0870_ _0871_ VDD VSS / sg13g2_nor2_1
X_3323_ _0873_ _0872_ VDD VSS / sg13g2_inv_1
X_3324_ _0874_ u_core_u_seu_u_fill_qb_5_ u_core_u_seu_u_fill_qc_5_ u_core_u_seu_u_fill_qa_5_ VDD VSS / sg13g2_a21o_1
X_3325_ _0875_ u_core_u_seu_u_fill_qb_5_ u_core_u_seu_u_fill_qc_5_ _0874_ VDD VSS / sg13g2_o21ai_1
X_3326_ _0876_ u_core_u_seu_u_fill_qb_7_ u_core_u_seu_u_fill_qc_7_ u_core_u_seu_u_fill_qa_7_ VDD VSS / sg13g2_a21o_1
X_3327_ _0877_ u_core_u_seu_u_fill_qb_7_ u_core_u_seu_u_fill_qc_7_ _0876_ VDD VSS / sg13g2_o21ai_1
X_3328_ _0878_ _0877_ VDD VSS / sg13g2_inv_1
X_3329_ _0879_ u_core_u_seu_u_fill_qb_6_ u_core_u_seu_u_fill_qc_6_ VDD VSS / sg13g2_nor2_1
X_3330_ _0880_ u_core_u_seu_u_fill_qb_6_ u_core_u_seu_u_fill_qc_6_ u_core_u_seu_u_fill_qa_6_ VDD VSS / sg13g2_a21o_1
X_3331_ _0881_ _0879_ _0880_ VDD VSS / sg13g2_nor2b_1
X_3332_ _0882_ _0879_ _0880_ VDD VSS / sg13g2_nand2b_1
X_3333_ _0883_ u_core_u_seu_u_fill_qb_4_ u_core_u_seu_u_fill_qc_4_ VDD VSS / sg13g2_nor2_1
X_3334_ _0884_ u_core_u_seu_u_fill_qb_4_ u_core_u_seu_u_fill_qc_4_ u_core_u_seu_u_fill_qa_4_ VDD VSS / sg13g2_a21oi_1
X_3335_ _0885_ _0883_ _0884_ VDD VSS / sg13g2_nor2_1
X_3336_ _0886_ u_core_u_seu_u_fill_qb_10_ u_core_u_seu_u_fill_qc_10_ VDD VSS / sg13g2_nor2_1
X_3337_ _0887_ u_core_u_seu_u_fill_qb_10_ u_core_u_seu_u_fill_qc_10_ u_core_u_seu_u_fill_qa_10_ VDD VSS / sg13g2_a21oi_1
X_3338_ _0888_ _0886_ _0887_ VDD VSS / sg13g2_nor2_1
X_3339_ _0889_ u_core_u_seu_u_fill_qb_2_ u_core_u_seu_u_fill_qc_2_ VDD VSS / sg13g2_nor2_1
X_3340_ _0890_ u_core_u_seu_u_fill_qb_2_ u_core_u_seu_u_fill_qc_2_ u_core_u_seu_u_fill_qa_2_ VDD VSS / sg13g2_a21oi_1
X_3341_ _0891_ _0889_ _0890_ VDD VSS / sg13g2_nor2_1
X_3342_ _0892_ _0881_ _0885_ _0888_ _0891_ VDD VSS / sg13g2_or4_1
X_3343_ _0893_ u_core_u_seu_u_fill_qb_0_ u_core_u_seu_u_fill_qc_0_ u_core_u_seu_u_fill_qa_0_ VDD VSS / sg13g2_a21o_1
X_3344_ _0894_ u_core_u_seu_u_fill_qb_0_ u_core_u_seu_u_fill_qc_0_ _0893_ VDD VSS / sg13g2_o21ai_1
X_3345_ _0895_ _0894_ VDD VSS / sg13g2_inv_1
X_3346_ _0896_ u_core_u_seu_u_fill_qa_1_ u_core_u_seu_u_fill_qc_1_ u_core_u_seu_u_fill_qb_1_ VDD VSS / sg13g2_a21oi_1
X_3347_ _0897_ u_core_u_seu_u_fill_qa_1_ u_core_u_seu_u_fill_qc_1_ VDD VSS / sg13g2_nor2_1
X_3348_ _0898_ _0896_ _0897_ _0894_ VDD VSS / sg13g2_o21ai_1
X_3349_ _0899_ _0898_ VDD VSS / sg13g2_inv_1
X_3350_ _0900_ u_core_u_seu_u_fill_qb_3_ u_core_u_seu_u_fill_qc_3_ u_core_u_seu_u_fill_qa_3_ VDD VSS / sg13g2_a21o_1
X_3351_ _0901_ u_core_u_seu_u_fill_qb_3_ u_core_u_seu_u_fill_qc_3_ _0900_ VDD VSS / sg13g2_o21ai_1
X_3352_ _0902_ _0901_ VDD VSS / sg13g2_inv_1
X_3353_ _0903_ u_core_u_seu_u_fill_qb_9_ u_core_u_seu_u_fill_qc_9_ VDD VSS / sg13g2_nor2_1
X_3354_ _0904_ u_core_u_seu_u_fill_qb_9_ u_core_u_seu_u_fill_qc_9_ u_core_u_seu_u_fill_qa_9_ VDD VSS / sg13g2_a21oi_1
X_3355_ _0905_ _0903_ _0904_ VDD VSS / sg13g2_nor2_1
X_3356_ _0906_ _0892_ _0898_ _0902_ _0905_ VDD VSS / sg13g2_nor4_1
X_3357_ _0907_ _0872_ _0875_ _0877_ _0906_ VDD VSS / sg13g2_nand4_1
X_3358_ _0908_ _0873_ _0878_ _0891_ _0905_ VDD VSS / sg13g2_nor4_1
X_3359_ _0909_ _0875_ _0882_ _0901_ VDD VSS / sg13g2_nand3_1
X_3360_ _0910_ _0885_ _0888_ _0898_ _0909_ VDD VSS / sg13g2_nor4_1
X_3361_ _0911_ net96 _0908_ _0910_ VDD VSS / sg13g2_nand3b_1
X_3362_ _0912_ _0885_ _0888_ _0891_ _0905_ VDD VSS / sg13g2_nor4_1
X_3363_ _0913_ _0872_ _0877_ _0899_ _0912_ VDD VSS / sg13g2_nand4_1
X_3364_ _0914_ _0909_ _0913_ VDD VSS / sg13g2_nor2_1
X_3365_ _0915_ _0914_ VDD VSS / sg13g2_inv_1
X_3366_ _0916_ net97 _0914_ u_core_u_seu_u_en_d_d_0_ VDD VSS / sg13g2_nand3b_1
X_3367_ _0917_ u_core_u_seu_u_run_cur_qb_2_ u_core_u_seu_u_run_cur_qc_2_ u_core_u_seu_u_run_cur_qa_2_ VDD VSS / sg13g2_a21o_1
X_3368_ _0918_ u_core_u_seu_u_run_cur_qb_2_ u_core_u_seu_u_run_cur_qc_2_ _0917_ VDD VSS / sg13g2_o21ai_1
X_3369_ _0919_ u_core_u_seu_u_run_cur_qb_1_ u_core_u_seu_u_run_cur_qc_1_ VDD VSS / sg13g2_nor2_1
X_3370_ _0920_ u_core_u_seu_u_run_cur_qb_1_ u_core_u_seu_u_run_cur_qc_1_ u_core_u_seu_u_run_cur_qa_1_ VDD VSS / sg13g2_a21oi_1
X_3371_ _0921_ _0919_ _0920_ VDD VSS / sg13g2_nor2_1
X_3372_ _0922_ _0857_ _0921_ VDD VSS / sg13g2_nand2_1
X_3373_ _0923_ _0918_ _0922_ VDD VSS / sg13g2_nor2_1
X_3374_ _0924_ u_core_u_seu_u_run_cur_qb_5_ u_core_u_seu_u_run_cur_qc_5_ u_core_u_seu_u_run_cur_qa_5_ VDD VSS / sg13g2_a21o_1
X_3375_ _0925_ u_core_u_seu_u_run_cur_qb_5_ u_core_u_seu_u_run_cur_qc_5_ _0924_ VDD VSS / sg13g2_o21ai_1
X_3376_ _0926_ u_core_u_seu_u_run_cur_qb_4_ u_core_u_seu_u_run_cur_qc_4_ VDD VSS / sg13g2_nor2_1
X_3377_ _0927_ u_core_u_seu_u_run_cur_qb_4_ u_core_u_seu_u_run_cur_qc_4_ u_core_u_seu_u_run_cur_qa_4_ VDD VSS / sg13g2_a21oi_1
X_3378_ _0928_ _0926_ _0927_ VDD VSS / sg13g2_nor2_1
X_3379_ _0929_ u_core_u_seu_u_run_cur_qb_3_ u_core_u_seu_u_run_cur_qc_3_ VDD VSS / sg13g2_nor2_1
X_3380_ _0930_ u_core_u_seu_u_run_cur_qb_3_ u_core_u_seu_u_run_cur_qc_3_ u_core_u_seu_u_run_cur_qa_3_ VDD VSS / sg13g2_a21oi_1
X_3381_ _0931_ _0929_ _0930_ VDD VSS / sg13g2_nor2_1
X_3382_ _0932_ _0928_ _0931_ VDD VSS / sg13g2_nand2_1
X_3383_ _0933_ _0918_ _0922_ _0925_ _0932_ VDD VSS / sg13g2_nor4_1
X_3384_ _0934_ _0918_ _0922_ _0925_ _0932_ VDD VSS / sg13g2_or4_1
X_3385_ _0935_ u_core_u_seu_u_run_cur_qb_7_ u_core_u_seu_u_run_cur_qc_7_ VDD VSS / sg13g2_nor2_1
X_3386_ _0936_ u_core_u_seu_u_run_cur_qb_7_ u_core_u_seu_u_run_cur_qc_7_ u_core_u_seu_u_run_cur_qa_7_ VDD VSS / sg13g2_a21o_1
X_3387_ _0937_ _0935_ _0936_ VDD VSS / sg13g2_nor2b_1
X_3388_ _0938_ _0935_ _0936_ VDD VSS / sg13g2_nand2b_1
X_3389_ _0939_ u_core_u_seu_u_run_cur_qb_6_ u_core_u_seu_u_run_cur_qc_6_ u_core_u_seu_u_run_cur_qa_6_ VDD VSS / sg13g2_a21o_1
X_3390_ _0940_ u_core_u_seu_u_run_cur_qb_6_ u_core_u_seu_u_run_cur_qc_6_ _0939_ VDD VSS / sg13g2_o21ai_1
X_3391_ _0941_ _0938_ _0940_ VDD VSS / sg13g2_nor2_1
X_3392_ _0942_ _0933_ _0941_ _0858_ VDD VSS / sg13g2_a21oi_1
X_3393_ _0943_ u_core_u_seu_plain_out _0826_ VDD VSS / sg13g2_xor2_1
X_3394_ _0944_ _0054_ net97 _0907_ _0943_ VDD VSS / sg13g2_or4_1
X_3395_ _0945_ _0942_ _0944_ VDD VSS / sg13g2_nor2_1
X_3396_ _0946_ net69 _0943_ VDD VSS / sg13g2_nor2_1
X_3397_ _0947_ _0857_ net68 _0945_ VDD VSS / sg13g2_a21oi_1
X_3398_ u_core_u_seu_run_cur_n_0_ net75 _0947_ VDD VSS / sg13g2_nor2_1
X_3399_ _0948_ net68 _0921_ VDD VSS / sg13g2_nand2_1
X_3400_ _0949_ _0921_ _0942_ VDD VSS / sg13g2_nand2_1
X_3401_ _0950_ _0921_ _0942_ VDD VSS / sg13g2_xor2_1
X_3402_ _0951_ net63 _0950_ VDD VSS / sg13g2_nand2_1
X_3403_ u_core_u_seu_run_cur_n_1_ _0948_ _0951_ net75 VDD VSS / sg13g2_a21oi_1
X_3404_ _0952_ _0918_ net68 VDD VSS / sg13g2_nor2b_1
X_3405_ _0953_ _0918_ _0949_ VDD VSS / sg13g2_xor2_1
X_3406_ _0954_ net63 _0953_ _0952_ VDD VSS / sg13g2_a21oi_1
X_3407_ u_core_u_seu_run_cur_n_2_ net75 _0954_ VDD VSS / sg13g2_nor2_1
X_3408_ _0955_ net68 _0931_ VDD VSS / sg13g2_nand2_1
X_3409_ _0956_ _0918_ _0929_ _0930_ _0949_ VDD VSS / sg13g2_or4_1
X_3410_ _0957_ _0923_ _0931_ _0956_ VDD VSS / sg13g2_o21ai_1
X_3411_ _0958_ _0957_ VDD VSS / sg13g2_inv_1
X_3412_ _0959_ net63 _0958_ VDD VSS / sg13g2_nand2_1
X_3413_ u_core_u_seu_run_cur_n_3_ _0955_ _0959_ net75 VDD VSS / sg13g2_a21oi_1
X_3414_ _0960_ net68 _0928_ VDD VSS / sg13g2_nand2_1
X_3415_ _0961_ _0926_ _0927_ _0956_ VDD VSS / sg13g2_or3_1
X_3416_ _0962_ _0928_ _0956_ VDD VSS / sg13g2_xnor2_1
X_3417_ _0963_ net63 _0962_ VDD VSS / sg13g2_nand2_1
X_3418_ u_core_u_seu_run_cur_n_4_ _0960_ _0963_ net75 VDD VSS / sg13g2_a21oi_1
X_3419_ _0964_ _0925_ net68 VDD VSS / sg13g2_nor2b_1
X_3420_ _0965_ _0934_ _0941_ VDD VSS / sg13g2_nor2_1
X_3421_ _0966_ _0925_ _0961_ _0965_ VDD VSS / sg13g2_a21oi_1
X_3422_ _0967_ net63 _0966_ _0964_ VDD VSS / sg13g2_a21oi_1
X_3423_ u_core_u_seu_run_cur_n_5_ net75 _0967_ VDD VSS / sg13g2_nor2_1
X_3424_ _0968_ _0940_ net68 VDD VSS / sg13g2_nand2b_1
X_3425_ _0969_ _0934_ _0937_ _0940_ VDD VSS / sg13g2_nor3_1
X_3426_ _0970_ _0934_ _0940_ _0969_ VDD VSS / sg13g2_a21oi_1
X_3427_ _0971_ _0970_ VDD VSS / sg13g2_inv_1
X_3428_ _0972_ net65 _0970_ VDD VSS / sg13g2_nand2_1
X_3429_ u_core_u_seu_run_cur_n_6_ _0968_ _0972_ net76 VDD VSS / sg13g2_a21oi_1
X_3430_ _0973_ net68 _0937_ VDD VSS / sg13g2_nand2_1
X_3431_ _0974_ _0934_ _0940_ _0938_ VDD VSS / sg13g2_o21ai_1
X_3432_ _0975_ net65 _0974_ VDD VSS / sg13g2_nand2_1
X_3433_ u_core_u_seu_run_cur_n_7_ _0973_ _0975_ net76 VDD VSS / sg13g2_a21oi_1
X_3434_ _0976_ u_core_u_seu_u_run_max_qb_0_ u_core_u_seu_u_run_max_qc_0_ VDD VSS / sg13g2_nor2_1
X_3435_ _0977_ u_core_u_seu_u_run_max_qb_0_ u_core_u_seu_u_run_max_qc_0_ u_core_u_seu_u_run_max_qa_0_ VDD VSS / sg13g2_a21o_1
X_3436_ _0978_ _0976_ _0977_ VDD VSS / sg13g2_nor2b_1
X_3437_ _0979_ _0976_ _0977_ VDD VSS / sg13g2_nand2b_1
X_3438_ _0980_ u_core_u_seu_u_run_max_qb_7_ u_core_u_seu_u_run_max_qc_7_ u_core_u_seu_u_run_max_qa_7_ VDD VSS / sg13g2_a21o_1
X_3439_ _0981_ u_core_u_seu_u_run_max_qb_7_ u_core_u_seu_u_run_max_qc_7_ _0980_ VDD VSS / sg13g2_o21ai_1
X_3440_ _0982_ u_core_u_seu_u_run_max_qb_1_ u_core_u_seu_u_run_max_qc_1_ VDD VSS / sg13g2_nor2_1
X_3441_ _0983_ u_core_u_seu_u_run_max_qb_1_ u_core_u_seu_u_run_max_qc_1_ u_core_u_seu_u_run_max_qa_1_ VDD VSS / sg13g2_a21oi_1
X_3442_ _0984_ _0982_ _0983_ VDD VSS / sg13g2_nor2_1
X_3443_ _0985_ _0942_ _0978_ _0984_ VDD VSS / sg13g2_nand3_1
X_3444_ _0986_ u_core_u_seu_u_run_max_qb_2_ u_core_u_seu_u_run_max_qc_2_ u_core_u_seu_u_run_max_qa_2_ VDD VSS / sg13g2_a21o_1
X_3445_ _0987_ u_core_u_seu_u_run_max_qb_2_ u_core_u_seu_u_run_max_qc_2_ _0986_ VDD VSS / sg13g2_o21ai_1
X_3446_ _0988_ _0942_ _0978_ _0984_ VDD VSS / sg13g2_a21oi_1
X_3447_ _0989_ _0950_ _0985_ _0987_ _0953_ VDD VSS / sg13g2_a22oi_1
X_3448_ _0990_ _0988_ _0989_ VDD VSS / sg13g2_nand2b_1
X_3449_ _0991_ u_core_u_seu_u_run_max_qb_3_ u_core_u_seu_u_run_max_qc_3_ VDD VSS / sg13g2_nor2_1
X_3450_ _0992_ u_core_u_seu_u_run_max_qb_3_ u_core_u_seu_u_run_max_qc_3_ u_core_u_seu_u_run_max_qa_3_ VDD VSS / sg13g2_a21oi_1
X_3451_ _0993_ _0991_ _0992_ VDD VSS / sg13g2_nor2_1
X_3452_ _0994_ _0993_ VDD VSS / sg13g2_inv_1
X_3453_ _0995_ _0953_ _0987_ VDD VSS / sg13g2_nor2_1
X_3454_ _0996_ _0957_ _0993_ _0995_ VDD VSS / sg13g2_a21oi_1
X_3455_ _0997_ u_core_u_seu_u_run_max_qb_4_ u_core_u_seu_u_run_max_qc_4_ VDD VSS / sg13g2_nor2_1
X_3456_ _0998_ u_core_u_seu_u_run_max_qb_4_ u_core_u_seu_u_run_max_qc_4_ u_core_u_seu_u_run_max_qa_4_ VDD VSS / sg13g2_a21oi_1
X_3457_ _0999_ _0997_ _0998_ VDD VSS / sg13g2_nor2_1
X_3458_ _1000_ _0999_ _0962_ VDD VSS / sg13g2_nor2b_1
X_3459_ _1001_ _0958_ _0994_ _0996_ _0990_ _1000_ VDD VSS / sg13g2_a221oi_1
X_3460_ _1002_ u_core_u_seu_u_run_max_qb_5_ u_core_u_seu_u_run_max_qc_5_ u_core_u_seu_u_run_max_qa_5_ VDD VSS / sg13g2_a21o_1
X_3461_ _1003_ u_core_u_seu_u_run_max_qb_5_ u_core_u_seu_u_run_max_qc_5_ _1002_ VDD VSS / sg13g2_o21ai_1
X_3462_ _1004_ _1003_ VDD VSS / sg13g2_inv_1
X_3463_ _1005_ _0962_ _0999_ VDD VSS / sg13g2_nand2b_1
X_3464_ _1006_ _0966_ _1003_ _1005_ VDD VSS / sg13g2_o21ai_1
X_3465_ _1007_ u_core_u_seu_u_run_max_qb_6_ u_core_u_seu_u_run_max_qc_6_ VDD VSS / sg13g2_nor2_1
X_3466_ _1008_ u_core_u_seu_u_run_max_qb_6_ u_core_u_seu_u_run_max_qc_6_ u_core_u_seu_u_run_max_qa_6_ VDD VSS / sg13g2_a21oi_1
X_3467_ _1009_ _1007_ _1008_ VDD VSS / sg13g2_nor2_1
X_3468_ _1010_ _1009_ VDD VSS / sg13g2_inv_1
X_3469_ _1011_ _0966_ _1003_ _1010_ _0970_ VDD VSS / sg13g2_a22oi_1
X_3470_ _1012_ _1001_ _1006_ _1011_ VDD VSS / sg13g2_o21ai_1
X_3471_ _1013_ _0974_ _0981_ VDD VSS / sg13g2_nor2_1
X_3472_ _1014_ _0971_ _1009_ _1013_ VDD VSS / sg13g2_a21oi_1
X_3473_ _1015_ _0974_ _0981_ _1012_ _1014_ VDD VSS / sg13g2_a22oi_1
X_3474_ _1016_ _0942_ net47 VDD VSS / sg13g2_or2_1
X_3475_ _1017_ _0978_ net47 _0944_ VDD VSS / sg13g2_a21oi_1
X_3476_ u_core_u_seu_run_max_n_0_ _0944_ _0979_ _1016_ _1017_ net76 VDD VSS / sg13g2_a221oi_1
X_3477_ _1018_ net64 _0984_ net73 VDD VSS / sg13g2_o21ai_1
X_3478_ _1019_ _0950_ _0984_ net47 VDD VSS / sg13g2_mux2_1
X_3479_ _1020_ _1019_ VDD VSS / sg13g2_inv_1
X_3480_ u_core_u_seu_run_max_n_1_ net64 _1020_ _1018_ VDD VSS / sg13g2_a21oi_1
X_3481_ _1021_ _0944_ _0987_ net75 VDD VSS / sg13g2_a21oi_1
X_3482_ _1022_ _0987_ net48 VDD VSS / sg13g2_nor2b_1
X_3483_ _1023_ net48 _0953_ VDD VSS / sg13g2_nor2b_1
X_3484_ _1024_ _0944_ _1022_ _1023_ VDD VSS / sg13g2_nor3_1
X_3485_ u_core_u_seu_run_max_n_2_ _1024_ _1021_ VDD VSS / sg13g2_nor2b_1
X_3486_ _1025_ net63 _0993_ net73 VDD VSS / sg13g2_o21ai_1
X_3487_ _1026_ _0957_ net48 VDD VSS / sg13g2_nor2_1
X_3488_ _1027_ _0993_ net48 _1026_ VDD VSS / sg13g2_a21oi_1
X_3489_ u_core_u_seu_run_max_n_3_ net64 _1027_ _1025_ VDD VSS / sg13g2_a21oi_1
X_3490_ _1028_ net64 _0999_ net73 VDD VSS / sg13g2_o21ai_1
X_3491_ _1029_ _0962_ _0999_ net47 VDD VSS / sg13g2_mux2_1
X_3492_ _1030_ _1029_ VDD VSS / sg13g2_inv_1
X_3493_ u_core_u_seu_run_max_n_4_ net64 _1030_ _1028_ VDD VSS / sg13g2_a21oi_1
X_3494_ _1031_ net63 _1004_ net73 VDD VSS / sg13g2_o21ai_1
X_3495_ _1032_ net47 _0966_ VDD VSS / sg13g2_nor2b_1
X_3496_ _1033_ _1004_ net47 _1032_ VDD VSS / sg13g2_a21oi_1
X_3497_ u_core_u_seu_run_max_n_5_ net63 _1033_ _1031_ VDD VSS / sg13g2_a21oi_1
X_3498_ _1034_ _1009_ net47 VDD VSS / sg13g2_nand2_1
X_3499_ _1035_ _0971_ net47 VDD VSS / sg13g2_nor2_1
X_3500_ _1036_ _0944_ _1035_ VDD VSS / sg13g2_nor2_1
X_3501_ u_core_u_seu_run_max_n_6_ _0944_ _1010_ _1034_ _1036_ net75 VDD VSS / sg13g2_a221oi_1
X_3502_ u_core_u_seu_run_max_n_7_ _0975_ _0981_ net76 VDD VSS / sg13g2_a21oi_1
X_3503_ _1037_ u_core_u_seu_u_cnt_unc_qb_0_ u_core_u_seu_u_cnt_unc_qc_0_ VDD VSS / sg13g2_nor2_1
X_3504_ _1038_ u_core_u_seu_u_cnt_unc_qb_0_ u_core_u_seu_u_cnt_unc_qc_0_ u_core_u_seu_u_cnt_unc_qa_0_ VDD VSS / sg13g2_a21oi_1
X_3505_ _1039_ _1037_ _1038_ VDD VSS / sg13g2_nor2_1
X_3506_ _1040_ u_core_u_seu_u_cnt_unc_qb_3_ u_core_u_seu_u_cnt_unc_qc_3_ u_core_u_seu_u_cnt_unc_qa_3_ VDD VSS / sg13g2_a21o_1
X_3507_ _1041_ u_core_u_seu_u_cnt_unc_qb_3_ u_core_u_seu_u_cnt_unc_qc_3_ _1040_ VDD VSS / sg13g2_o21ai_1
X_3508_ _1042_ _1041_ VDD VSS / sg13g2_inv_1
X_3509_ _1043_ u_core_u_seu_u_cnt_unc_qb_4_ u_core_u_seu_u_cnt_unc_qc_4_ VDD VSS / sg13g2_nor2_1
X_3510_ _1044_ u_core_u_seu_u_cnt_unc_qb_4_ u_core_u_seu_u_cnt_unc_qc_4_ u_core_u_seu_u_cnt_unc_qa_4_ VDD VSS / sg13g2_a21oi_1
X_3511_ _1045_ _1043_ _1044_ VDD VSS / sg13g2_nor2_1
X_3512_ _1046_ u_core_u_seu_u_cnt_unc_qb_1_ u_core_u_seu_u_cnt_unc_qc_1_ VDD VSS / sg13g2_nor2_1
X_3513_ _1047_ u_core_u_seu_u_cnt_unc_qb_1_ u_core_u_seu_u_cnt_unc_qc_1_ u_core_u_seu_u_cnt_unc_qa_1_ VDD VSS / sg13g2_a21oi_1
X_3514_ _1048_ _1046_ _1047_ VDD VSS / sg13g2_nor2_1
X_3515_ _1049_ u_core_u_seu_u_cnt_unc_qb_6_ u_core_u_seu_u_cnt_unc_qc_6_ u_core_u_seu_u_cnt_unc_qa_6_ VDD VSS / sg13g2_a21o_1
X_3516_ _1050_ u_core_u_seu_u_cnt_unc_qb_6_ u_core_u_seu_u_cnt_unc_qc_6_ _1049_ VDD VSS / sg13g2_o21ai_1
X_3517_ _1051_ u_core_u_seu_u_cnt_unc_qb_5_ u_core_u_seu_u_cnt_unc_qc_5_ VDD VSS / sg13g2_nor2_1
X_3518_ _1052_ u_core_u_seu_u_cnt_unc_qb_5_ u_core_u_seu_u_cnt_unc_qc_5_ u_core_u_seu_u_cnt_unc_qa_5_ VDD VSS / sg13g2_a21oi_1
X_3519_ _1053_ _1051_ _1052_ VDD VSS / sg13g2_nor2_1
X_3520_ _1054_ _1053_ VDD VSS / sg13g2_inv_1
X_3521_ _1055_ u_core_u_seu_u_cnt_unc_qb_2_ u_core_u_seu_u_cnt_unc_qc_2_ VDD VSS / sg13g2_nor2_1
X_3522_ _1056_ u_core_u_seu_u_cnt_unc_qb_2_ u_core_u_seu_u_cnt_unc_qc_2_ u_core_u_seu_u_cnt_unc_qa_2_ VDD VSS / sg13g2_a21oi_1
X_3523_ _1057_ _1055_ _1056_ VDD VSS / sg13g2_nor2_1
X_3524_ _1058_ _1057_ VDD VSS / sg13g2_inv_1
X_3525_ _1059_ _1039_ _1045_ _1048_ _1057_ VDD VSS / sg13g2_nand4_1
X_3526_ _1060_ _1041_ _1050_ _1054_ _1059_ VDD VSS / sg13g2_nor4_1
X_3527_ _1061_ u_core_u_seu_u_cnt_unc_qb_7_ u_core_u_seu_u_cnt_unc_qc_7_ VDD VSS / sg13g2_nor2_1
X_3528_ _1062_ u_core_u_seu_u_cnt_unc_qb_7_ u_core_u_seu_u_cnt_unc_qc_7_ u_core_u_seu_u_cnt_unc_qa_7_ VDD VSS / sg13g2_a21oi_1
X_3529_ _1063_ _1061_ _1062_ VDD VSS / sg13g2_nor2_1
X_3530_ _1064_ _1060_ _1063_ VDD VSS / sg13g2_and2_1
X_3531_ _1065_ u_core_u_seu_qb_127_ u_core_u_seu_qc_127_ VDD VSS / sg13g2_nor2_1
X_3532_ _1066_ u_core_u_seu_qb_127_ u_core_u_seu_qc_127_ VDD VSS / sg13g2_nand2_1
X_3533_ _1067_ _0546_ _1065_ _1066_ VDD VSS / sg13g2_o21ai_1
X_3534_ _1068_ _0826_ _1067_ VDD VSS / sg13g2_xor2_1
X_3535_ _1069_ net69 _1064_ _1068_ VDD VSS / sg13g2_nor3_1
X_3536_ _1070_ _1039_ _1069_ VDD VSS / sg13g2_nor2_1
X_3537_ _1071_ _1039_ _1069_ VDD VSS / sg13g2_and2_1
X_3538_ u_core_u_seu_cnt_unc_n_0_ net78 _1070_ _1071_ VDD VSS / sg13g2_nor3_1
X_3539_ _1072_ _1048_ _1071_ VDD VSS / sg13g2_nor2_1
X_3540_ _1073_ _1048_ _1071_ VDD VSS / sg13g2_nand2_1
X_3541_ _1074_ _1073_ VDD VSS / sg13g2_inv_1
X_3542_ u_core_u_seu_cnt_unc_n_1_ net79 _1072_ _1074_ VDD VSS / sg13g2_nor3_1
X_3543_ _1075_ _1058_ _1073_ VDD VSS / sg13g2_xnor2_1
X_3544_ u_core_u_seu_cnt_unc_n_2_ net79 _1075_ VDD VSS / sg13g2_nor2_1
X_3545_ _1076_ _1057_ _1074_ _1042_ VDD VSS / sg13g2_a21oi_1
X_3546_ _1077_ _1041_ _1058_ _1073_ VDD VSS / sg13g2_nor3_1
X_3547_ u_core_u_seu_cnt_unc_n_3_ net79 _1076_ _1077_ VDD VSS / sg13g2_nor3_1
X_3548_ _1078_ _1045_ _1077_ VDD VSS / sg13g2_nor2_1
X_3549_ _1079_ _1045_ _1077_ VDD VSS / sg13g2_and2_1
X_3550_ u_core_u_seu_cnt_unc_n_4_ net79 _1078_ _1079_ VDD VSS / sg13g2_nor3_1
X_3551_ _1080_ _1053_ _1079_ net73 VDD VSS / sg13g2_o21ai_1
X_3552_ _1081_ _1053_ _1079_ VDD VSS / sg13g2_nand2_1
X_3553_ u_core_u_seu_cnt_unc_n_5_ _1080_ _1081_ VDD VSS / sg13g2_nor2b_1
X_3554_ u_core_u_seu_cnt_unc_n_6_ _1060_ _1069_ _1081_ _1050_ net79 VDD VSS / sg13g2_a221oi_1
X_3555_ _1082_ _1060_ _1069_ _1063_ VDD VSS / sg13g2_a21oi_1
X_3556_ u_core_u_seu_cnt_unc_n_7_ net79 _1082_ VDD VSS / sg13g2_nor2_1
X_3557_ _1083_ u_core_u_seu_u_cnt_corr_qb_0_ u_core_u_seu_u_cnt_corr_qc_0_ u_core_u_seu_u_cnt_corr_qa_0_ VDD VSS / sg13g2_a21o_1
X_3558_ _1084_ u_core_u_seu_u_cnt_corr_qb_0_ u_core_u_seu_u_cnt_corr_qc_0_ _1083_ VDD VSS / sg13g2_o21ai_1
X_3559_ _1085_ u_core_u_seu_qa_75_ _0720_ VDD VSS / sg13g2_nor2_1
X_3560_ _1086_ u_core_u_seu_qa_1_ u_core_u_seu_qc_1_ VDD VSS / sg13g2_nand2_1
X_3561_ _1087_ u_core_u_seu_qb_1_ _1086_ VDD VSS / sg13g2_nand2_1
X_3562_ _1088_ u_core_u_seu_qa_68_ _0706_ VDD VSS / sg13g2_nor2_1
X_3563_ _1089_ u_core_u_seu_qa_99_ _0768_ VDD VSS / sg13g2_nor2_1
X_3564_ _1090_ u_core_u_seu_qa_36_ _0642_ _1089_ VDD VSS / sg13g2_a21oi_1
X_3565_ _1091_ u_core_u_seu_qa_60_ _0689_ VDD VSS / sg13g2_nor2_1
X_3566_ _1092_ u_core_u_seu_qa_39_ _0647_ VDD VSS / sg13g2_or2_1
X_3567_ _1093_ u_core_u_seu_qa_103_ _0777_ VDD VSS / sg13g2_nand2_1
X_3568_ _1094_ u_core_u_seu_qa_62_ _0693_ VDD VSS / sg13g2_nor2_1
X_3569_ _1095_ u_core_u_seu_qa_62_ _0694_ _1094_ VDD VSS / sg13g2_a21oi_1
X_3570_ _1096_ u_core_u_seu_qa_57_ _0683_ VDD VSS / sg13g2_nor2_1
X_3571_ _1097_ u_core_u_seu_qa_59_ _0687_ VDD VSS / sg13g2_or2_1
X_3572_ _1098_ u_core_u_seu_qa_7_ _0583_ VDD VSS / sg13g2_or2_1
X_3573_ _1099_ u_core_u_seu_qa_31_ _0631_ VDD VSS / sg13g2_nor2_1
X_3574_ _1100_ u_core_u_seu_qb_13_ u_core_u_seu_qc_13_ _0382_ VDD VSS / sg13g2_a21oi_1
X_3575_ _1101_ u_core_u_seu_qa_106_ _0783_ VDD VSS / sg13g2_nand2_1
X_3576_ _1102_ u_core_u_seu_qa_101_ _0772_ VDD VSS / sg13g2_nor2_1
X_3577_ _1103_ u_core_u_seu_qa_82_ _0734_ VDD VSS / sg13g2_nor2_1
X_3578_ _1104_ u_core_u_seu_qa_16_ _0601_ VDD VSS / sg13g2_nor2_1
X_3579_ _1105_ u_core_u_seu_qa_2_ u_core_u_seu_qc_2_ VDD VSS / sg13g2_nor2_1
X_3580_ _1106_ u_core_u_seu_qb_2_ _1105_ VDD VSS / sg13g2_nor2_1
X_3581_ _1107_ u_core_u_seu_qa_125_ _0820_ VDD VSS / sg13g2_nor2_1
X_3582_ _1108_ u_core_u_seu_qa_81_ _0732_ VDD VSS / sg13g2_nor2_1
X_3583_ _1109_ u_core_u_seu_qa_53_ _0675_ VDD VSS / sg13g2_nor2_1
X_3584_ _1110_ u_core_u_seu_qa_21_ _0612_ VDD VSS / sg13g2_nand2_1
X_3585_ _1111_ u_core_u_seu_qa_8_ _0585_ VDD VSS / sg13g2_or2_1
X_3586_ _1112_ u_core_u_seu_qa_84_ _0738_ VDD VSS / sg13g2_nor2_1
X_3587_ _1113_ u_core_u_seu_qa_85_ _0741_ VDD VSS / sg13g2_nand2_1
X_3588_ _1114_ u_core_u_seu_qa_25_ _0619_ VDD VSS / sg13g2_nor2_1
X_3589_ _1115_ u_core_u_seu_qb_11_ u_core_u_seu_qa_11_ u_core_u_seu_qc_11_ VDD VSS / sg13g2_nand3_1
X_3590_ _1116_ u_core_u_seu_qa_11_ _0591_ VDD VSS / sg13g2_nand2b_1
X_3591_ _1117_ u_core_u_seu_qb_14_ u_core_u_seu_qa_14_ u_core_u_seu_qc_14_ VDD VSS / sg13g2_nand3_1
X_3592_ _1118_ u_core_u_seu_qa_14_ _0597_ VDD VSS / sg13g2_nand2b_1
X_3593_ _1119_ u_core_u_seu_qb_52_ u_core_u_seu_qa_52_ u_core_u_seu_qc_52_ VDD VSS / sg13g2_nand3_1
X_3594_ _1120_ u_core_u_seu_qa_52_ _0673_ VDD VSS / sg13g2_nand2b_1
X_3595_ _1121_ u_core_u_seu_qa_64_ _0697_ VDD VSS / sg13g2_nor2_1
X_3596_ _1122_ u_core_u_seu_qb_10_ u_core_u_seu_qa_10_ u_core_u_seu_qc_10_ VDD VSS / sg13g2_nand3_1
X_3597_ _1123_ u_core_u_seu_qa_10_ _0589_ VDD VSS / sg13g2_nand2b_1
X_3598_ _1124_ u_core_u_seu_qb_28_ u_core_u_seu_qa_28_ u_core_u_seu_qc_28_ VDD VSS / sg13g2_nand3_1
X_3599_ _1125_ u_core_u_seu_qa_28_ _0625_ VDD VSS / sg13g2_nand2b_1
X_3600_ _1126_ u_core_u_seu_qb_109_ u_core_u_seu_qa_109_ u_core_u_seu_qc_109_ VDD VSS / sg13g2_nand3_1
X_3601_ _1127_ u_core_u_seu_qa_109_ _0788_ VDD VSS / sg13g2_nand2b_1
X_3602_ _1128_ u_core_u_seu_qb_5_ u_core_u_seu_qa_5_ u_core_u_seu_qc_5_ VDD VSS / sg13g2_or3_1
X_3603_ _1129_ u_core_u_seu_qa_5_ u_core_u_seu_qc_5_ VDD VSS / sg13g2_nand2_1
X_3604_ _1130_ u_core_u_seu_qb_5_ u_core_u_seu_qa_5_ u_core_u_seu_qc_5_ VDD VSS / sg13g2_nand3_1
X_3605_ _1131_ u_core_u_seu_qb_32_ u_core_u_seu_qa_32_ u_core_u_seu_qc_32_ VDD VSS / sg13g2_nand3_1
X_3606_ _1132_ u_core_u_seu_qa_32_ _0633_ VDD VSS / sg13g2_nand2b_1
X_3607_ _1133_ u_core_u_seu_qb_61_ u_core_u_seu_qa_61_ u_core_u_seu_qc_61_ VDD VSS / sg13g2_nand3_1
X_3608_ _1134_ u_core_u_seu_qa_61_ _0691_ VDD VSS / sg13g2_nand2b_1
X_3609_ _1135_ u_core_u_seu_qb_12_ u_core_u_seu_qa_12_ u_core_u_seu_qc_12_ VDD VSS / sg13g2_nand3_1
X_3610_ _1136_ u_core_u_seu_qa_12_ _0593_ VDD VSS / sg13g2_nand2b_1
X_3611_ _1137_ u_core_u_seu_qa_108_ _0786_ VDD VSS / sg13g2_nor2_1
X_3612_ _1138_ u_core_u_seu_qa_108_ _0787_ _1137_ VDD VSS / sg13g2_a21oi_1
X_3613_ _1139_ u_core_u_seu_qb_115_ u_core_u_seu_qa_115_ u_core_u_seu_qc_115_ VDD VSS / sg13g2_nand3_1
X_3614_ _1140_ u_core_u_seu_qa_115_ _0800_ VDD VSS / sg13g2_nand2b_1
X_3615_ _1141_ u_core_u_seu_qb_33_ u_core_u_seu_qa_33_ u_core_u_seu_qc_33_ VDD VSS / sg13g2_nand3_1
X_3616_ _1142_ u_core_u_seu_qa_33_ _0635_ VDD VSS / sg13g2_nand2b_1
X_3617_ _1143_ u_core_u_seu_qa_126_ _0822_ VDD VSS / sg13g2_or2_1
X_3618_ _1144_ u_core_u_seu_qa_27_ _0623_ VDD VSS / sg13g2_nor2_1
X_3619_ _1145_ u_core_u_seu_qa_17_ _0603_ VDD VSS / sg13g2_nor2_1
X_3620_ _1146_ u_core_u_seu_qa_26_ _0621_ VDD VSS / sg13g2_nor2_1
X_3621_ _1147_ u_core_u_seu_qa_98_ _0767_ VDD VSS / sg13g2_nand2_1
X_3622_ _1148_ u_core_u_seu_qa_117_ _0805_ VDD VSS / sg13g2_nand2_1
X_3623_ _1149_ u_core_u_seu_qa_117_ _0804_ VDD VSS / sg13g2_nor2_1
X_3624_ _1150_ u_core_u_seu_qa_4_ u_core_u_seu_qc_4_ VDD VSS / sg13g2_nand2_1
X_3625_ _1151_ u_core_u_seu_qa_105_ _0780_ VDD VSS / sg13g2_nor2_1
X_3626_ _1152_ u_core_u_seu_qa_105_ _0781_ _1151_ VDD VSS / sg13g2_a21oi_1
X_3627_ _1153_ u_core_u_seu_qa_56_ _0681_ VDD VSS / sg13g2_nor2_1
X_3628_ _1154_ u_core_u_seu_qa_118_ _0806_ VDD VSS / sg13g2_nor2_1
X_3629_ _1155_ u_core_u_seu_qa_27_ _0624_ VDD VSS / sg13g2_nand2_1
X_3630_ _1156_ u_core_u_seu_qa_55_ _0679_ VDD VSS / sg13g2_nor2_1
X_3631_ _1157_ u_core_u_seu_qa_42_ _0654_ VDD VSS / sg13g2_nand2_1
X_3632_ _1158_ u_core_u_seu_qa_76_ _0722_ VDD VSS / sg13g2_nor2_1
X_3633_ _1159_ u_core_u_seu_qa_40_ _0649_ VDD VSS / sg13g2_nor2_1
X_3634_ _1160_ u_core_u_seu_qa_37_ _0644_ VDD VSS / sg13g2_nand2_1
X_3635_ _1161_ u_core_u_seu_qa_77_ _0724_ VDD VSS / sg13g2_nor2_1
X_3636_ _1162_ u_core_u_seu_qa_23_ _0616_ VDD VSS / sg13g2_nand2_1
X_3637_ _1163_ u_core_u_seu_qa_89_ _0748_ VDD VSS / sg13g2_or2_1
X_3638_ _1164_ u_core_u_seu_qa_94_ _0758_ VDD VSS / sg13g2_or2_1
X_3639_ _1165_ u_core_u_seu_qa_30_ _0629_ VDD VSS / sg13g2_nor2_1
X_3640_ _1166_ u_core_u_seu_qa_0_ u_core_u_seu_qc_0_ VDD VSS / sg13g2_nand2_1
X_3641_ _1167_ u_core_u_seu_qa_75_ _0721_ VDD VSS / sg13g2_nand2_1
X_3642_ _1168_ u_core_u_seu_qa_111_ _0792_ VDD VSS / sg13g2_nor2_1
X_3643_ _1169_ u_core_u_seu_qb_56_ u_core_u_seu_qc_56_ _0415_ VDD VSS / sg13g2_a21oi_1
X_3644_ _1170_ u_core_u_seu_qa_94_ _0759_ VDD VSS / sg13g2_nand2_1
X_3645_ _1171_ u_core_u_seu_qa_3_ u_core_u_seu_qc_3_ VDD VSS / sg13g2_nand2_1
X_3646_ _1172_ u_core_u_seu_qa_92_ _0754_ VDD VSS / sg13g2_nor2_1
X_3647_ _1173_ u_core_u_seu_qa_107_ _0785_ VDD VSS / sg13g2_nand2_1
X_3648_ _1174_ u_core_u_seu_qb_87_ u_core_u_seu_qa_87_ u_core_u_seu_qc_87_ VDD VSS / sg13g2_nand3_1
X_3649_ _1175_ u_core_u_seu_qa_87_ _0744_ VDD VSS / sg13g2_nand2b_1
X_3650_ _1176_ u_core_u_seu_qa_80_ _0730_ VDD VSS / sg13g2_nor2_1
X_3651_ _1177_ u_core_u_seu_qa_102_ _0775_ VDD VSS / sg13g2_nand2_1
X_3652_ _1178_ u_core_u_seu_qa_102_ _0774_ _1177_ VDD VSS / sg13g2_o21ai_1
X_3653_ _1179_ u_core_u_seu_qa_50_ _0669_ VDD VSS / sg13g2_nor2_1
X_3654_ _1180_ u_core_u_seu_qa_43_ _0655_ VDD VSS / sg13g2_nor2_1
X_3655_ _1181_ u_core_u_seu_qa_74_ _0719_ VDD VSS / sg13g2_nand2_1
X_3656_ _1182_ u_core_u_seu_qa_74_ _0718_ _1181_ VDD VSS / sg13g2_o21ai_1
X_3657_ _1183_ u_core_u_seu_qb_104_ u_core_u_seu_qa_104_ u_core_u_seu_qc_104_ VDD VSS / sg13g2_nand3_1
X_3658_ _1184_ u_core_u_seu_qa_104_ _0778_ VDD VSS / sg13g2_nand2b_1
X_3659_ _1185_ u_core_u_seu_qb_97_ u_core_u_seu_qa_97_ u_core_u_seu_qc_97_ VDD VSS / sg13g2_nand3_1
X_3660_ _1186_ u_core_u_seu_qa_97_ _0764_ VDD VSS / sg13g2_nand2b_1
X_3661_ _1187_ u_core_u_seu_qa_88_ _0746_ VDD VSS / sg13g2_nor2_1
X_3662_ _1188_ u_core_u_seu_qa_30_ _0630_ VDD VSS / sg13g2_nand2_1
X_3663_ _1189_ u_core_u_seu_qa_112_ _0794_ VDD VSS / sg13g2_nor2_1
X_3664_ _1190_ u_core_u_seu_qa_8_ _0586_ VDD VSS / sg13g2_nand2_1
X_3665_ _1191_ u_core_u_seu_qa_67_ _0705_ VDD VSS / sg13g2_nand2_1
X_3666_ _1192_ u_core_u_seu_qa_79_ _0728_ VDD VSS / sg13g2_or2_1
X_3667_ _1193_ u_core_u_seu_qa_67_ _0704_ VDD VSS / sg13g2_nor2_1
X_3668_ _1194_ u_core_u_seu_qa_91_ _0752_ VDD VSS / sg13g2_nor2_1
X_3669_ _1195_ u_core_u_seu_qa_23_ _0615_ VDD VSS / sg13g2_or2_1
X_3670_ _1196_ u_core_u_seu_qa_69_ _0708_ VDD VSS / sg13g2_nor2_1
X_3671_ _1197_ u_core_u_seu_qa_73_ _0716_ VDD VSS / sg13g2_nor2_1
X_3672_ _1198_ u_core_u_seu_qa_18_ _0605_ VDD VSS / sg13g2_nor2_1
X_3673_ _1199_ u_core_u_seu_qa_98_ _0766_ VDD VSS / sg13g2_nor2_1
X_3674_ _1200_ u_core_u_seu_qa_114_ _0798_ VDD VSS / sg13g2_nor2_1
X_3675_ _1201_ u_core_u_seu_qa_15_ _0599_ VDD VSS / sg13g2_nor2_1
X_3676_ _1202_ u_core_u_seu_qa_1_ u_core_u_seu_qc_1_ VDD VSS / sg13g2_nor2_1
X_3677_ _1203_ u_core_u_seu_qa_122_ _0815_ VDD VSS / sg13g2_nand2_1
X_3678_ _1204_ u_core_u_seu_qa_86_ _0742_ VDD VSS / sg13g2_nor2_1
X_3679_ _1205_ u_core_u_seu_qa_44_ _0657_ VDD VSS / sg13g2_nor2_1
X_3680_ _1206_ u_core_u_seu_qa_4_ u_core_u_seu_qc_4_ _0551_ VDD VSS / sg13g2_o21ai_1
X_3681_ _1207_ u_core_u_seu_qa_2_ u_core_u_seu_qc_2_ VDD VSS / sg13g2_nand2_1
X_3682_ _1208_ u_core_u_seu_qb_2_ _1207_ VDD VSS / sg13g2_nand2_1
X_3683_ _1209_ u_core_u_seu_qa_120_ _0810_ VDD VSS / sg13g2_nor2_1
X_3684_ _1210_ u_core_u_seu_qa_0_ u_core_u_seu_qc_0_ _0547_ VDD VSS / sg13g2_o21ai_1
X_3685_ _1211_ u_core_u_seu_qa_93_ _0757_ VDD VSS / sg13g2_nand2_1
X_3686_ _1212_ u_core_u_seu_qb_47_ u_core_u_seu_qa_47_ u_core_u_seu_qc_47_ VDD VSS / sg13g2_nand3_1
X_3687_ _1213_ u_core_u_seu_qa_47_ _0663_ VDD VSS / sg13g2_nand2b_1
X_3688_ _1214_ u_core_u_seu_qa_3_ u_core_u_seu_qc_3_ VDD VSS / sg13g2_nor2_1
X_3689_ _1215_ u_core_u_seu_qb_3_ _1214_ VDD VSS / sg13g2_nor2_1
X_3690_ _1216_ u_core_u_seu_qa_116_ _0802_ VDD VSS / sg13g2_or2_1
X_3691_ _1217_ u_core_u_seu_qa_22_ _0613_ VDD VSS / sg13g2_nor2_1
X_3692_ _1218_ u_core_u_seu_qa_124_ _0818_ VDD VSS / sg13g2_nor2_1
X_3693_ _1219_ u_core_u_seu_qa_66_ _0702_ VDD VSS / sg13g2_nor2_1
X_3694_ _1220_ u_core_u_seu_qa_15_ _0600_ _1115_ _1116_ _1201_ VDD VSS / sg13g2_a221oi_1
X_3695_ _1221_ u_core_u_seu_qa_57_ _0684_ _1131_ _1132_ _1096_ VDD VSS / sg13g2_a221oi_1
X_3696_ _1222_ u_core_u_seu_qb_48_ u_core_u_seu_qa_48_ u_core_u_seu_qc_48_ VDD VSS / sg13g2_nand3_1
X_3697_ _1223_ u_core_u_seu_qa_48_ _0665_ VDD VSS / sg13g2_nand2b_1
X_3698_ _1224_ u_core_u_seu_qa_50_ _0670_ _1222_ _1223_ _1179_ VDD VSS / sg13g2_a221oi_1
X_3699_ _1225_ u_core_u_seu_qa_16_ _0602_ _1122_ _1123_ _1104_ VDD VSS / sg13g2_a221oi_1
X_3700_ _1226_ _1220_ _1221_ _1224_ _1225_ VDD VSS / sg13g2_nand4_1
X_3701_ _1227_ _1128_ _1130_ _1135_ _1136_ VDD VSS / sg13g2_a22oi_1
X_3702_ _1228_ u_core_u_seu_qa_25_ _0620_ _1183_ _1184_ _1114_ VDD VSS / sg13g2_a221oi_1
X_3703_ _1229_ u_core_u_seu_qa_64_ _0698_ _1174_ _1175_ _1121_ VDD VSS / sg13g2_a221oi_1
X_3704_ _1230_ _1117_ _1118_ _1124_ _1125_ VDD VSS / sg13g2_a22oi_1
X_3705_ _1231_ _1227_ _1228_ _1229_ _1230_ VDD VSS / sg13g2_nand4_1
X_3706_ _1232_ u_core_u_seu_qb_119_ u_core_u_seu_qa_119_ u_core_u_seu_qc_119_ VDD VSS / sg13g2_nand3_1
X_3707_ _1233_ u_core_u_seu_qa_119_ _0808_ VDD VSS / sg13g2_nand2b_1
X_3708_ _1234_ u_core_u_seu_qb_71_ u_core_u_seu_qa_71_ u_core_u_seu_qc_71_ VDD VSS / sg13g2_nand3_1
X_3709_ _1235_ u_core_u_seu_qa_71_ _0712_ VDD VSS / sg13g2_nand2b_1
X_3710_ _1236_ _1232_ _1233_ _1234_ _1235_ VDD VSS / sg13g2_a22oi_1
X_3711_ _1237_ u_core_u_seu_qa_80_ _0731_ _1185_ _1186_ _1176_ VDD VSS / sg13g2_a221oi_1
X_3712_ _1238_ u_core_u_seu_qa_84_ _0739_ _1126_ _1127_ _1112_ VDD VSS / sg13g2_a221oi_1
X_3713_ _1239_ u_core_u_seu_qb_41_ u_core_u_seu_qa_41_ u_core_u_seu_qc_41_ VDD VSS / sg13g2_nand3_1
X_3714_ _1240_ u_core_u_seu_qa_41_ _0651_ VDD VSS / sg13g2_nand2b_1
X_3715_ _1241_ u_core_u_seu_qb_110_ u_core_u_seu_qa_110_ u_core_u_seu_qc_110_ VDD VSS / sg13g2_nand3_1
X_3716_ _1242_ u_core_u_seu_qa_110_ _0790_ VDD VSS / sg13g2_nand2b_1
X_3717_ _1243_ _1239_ _1240_ _1241_ _1242_ VDD VSS / sg13g2_a22oi_1
X_3718_ _1244_ _1236_ _1237_ _1238_ _1243_ VDD VSS / sg13g2_nand4_1
X_3719_ _1245_ u_core_u_seu_qa_31_ _0632_ _1212_ _1213_ _1099_ VDD VSS / sg13g2_a221oi_1
X_3720_ _1246_ u_core_u_seu_qb_90_ u_core_u_seu_qa_90_ u_core_u_seu_qc_90_ VDD VSS / sg13g2_nand3_1
X_3721_ _1247_ u_core_u_seu_qa_90_ _0750_ VDD VSS / sg13g2_nand2b_1
X_3722_ _1248_ u_core_u_seu_qb_96_ u_core_u_seu_qa_96_ u_core_u_seu_qc_96_ VDD VSS / sg13g2_nand3_1
X_3723_ _1249_ u_core_u_seu_qa_96_ _0762_ VDD VSS / sg13g2_nand2b_1
X_3724_ _1250_ _1246_ _1247_ _1248_ _1249_ VDD VSS / sg13g2_a22oi_1
X_3725_ _1251_ u_core_u_seu_qa_43_ _0656_ _1119_ _1120_ _1180_ VDD VSS / sg13g2_a221oi_1
X_3726_ _1252_ u_core_u_seu_qa_92_ _0755_ _1141_ _1142_ _1172_ VDD VSS / sg13g2_a221oi_1
X_3727_ _1253_ _1245_ _1250_ _1251_ _1252_ VDD VSS / sg13g2_nand4_1
X_3728_ _1254_ _1226_ _1231_ _1244_ _1253_ VDD VSS / sg13g2_nor4_1
X_3729_ _1255_ u_core_u_seu_qa_60_ _0690_ _1133_ _1134_ _1091_ VDD VSS / sg13g2_a221oi_1
X_3730_ _1256_ u_core_u_seu_qa_91_ _0753_ _1194_ VDD VSS / sg13g2_a21oi_1
X_3731_ _1257_ _1095_ _1255_ _1256_ VDD VSS / sg13g2_nand3_1
X_3732_ _1258_ _0699_ _0700_ u_core_u_seu_qa_65_ VDD VSS / sg13g2_mux2_1
X_3733_ _1259_ u_core_u_seu_qb_54_ u_core_u_seu_qa_54_ u_core_u_seu_qc_54_ VDD VSS / sg13g2_and3_1
X_3734_ _1260_ u_core_u_seu_qb_54_ u_core_u_seu_qa_54_ u_core_u_seu_qc_54_ VDD VSS / sg13g2_nor3_1
X_3735_ _1261_ _1259_ _1260_ _1258_ VDD VSS / sg13g2_o21ai_1
X_3736_ _1262_ u_core_u_seu_qa_21_ _0611_ _1110_ VDD VSS / sg13g2_o21ai_1
X_3737_ _1263_ u_core_u_seu_qa_38_ _0645_ _1195_ VDD VSS / sg13g2_o21ai_1
X_3738_ _1264_ _1257_ _1261_ _1262_ _1263_ VDD VSS / sg13g2_nor4_1
X_3739_ _1265_ u_core_u_seu_qa_83_ _0736_ _1092_ VDD VSS / sg13g2_o21ai_1
X_3740_ _1266_ u_core_u_seu_qa_34_ _0638_ _0761_ u_core_u_seu_qa_95_ _1265_ VDD VSS / sg13g2_a221oi_1
X_3741_ _1267_ u_core_u_seu_qa_58_ _0686_ _0717_ u_core_u_seu_qa_73_ VDD VSS / sg13g2_a22oi_1
X_3742_ _1268_ u_core_u_seu_qa_59_ _0688_ _1109_ VDD VSS / sg13g2_a21oi_1
X_3743_ _1269_ u_core_u_seu_qa_34_ _0637_ _1170_ VDD VSS / sg13g2_o21ai_1
X_3744_ _1270_ u_core_u_seu_qa_103_ _0776_ _1093_ VDD VSS / sg13g2_o21ai_1
X_3745_ _1271_ u_core_u_seu_qb_1_ _1202_ _1087_ VDD VSS / sg13g2_o21ai_1
X_3746_ _1272_ u_core_u_seu_qa_100_ _0770_ _1173_ VDD VSS / sg13g2_o21ai_1
X_3747_ _1273_ _1269_ _1270_ _1271_ _1272_ VDD VSS / sg13g2_nor4_1
X_3748_ _1274_ _1266_ _1267_ _1268_ _1273_ VDD VSS / sg13g2_nand4_1
X_3749_ _1275_ u_core_u_seu_qa_70_ _0711_ _0811_ u_core_u_seu_qa_120_ VDD VSS / sg13g2_a22oi_1
X_3750_ _1276_ _1162_ _1208_ _1210_ _1275_ VDD VSS / sg13g2_nand4_1
X_3751_ _1277_ _1085_ _1196_ _1274_ _1276_ VDD VSS / sg13g2_nor4_1
X_3752_ _1278_ _1090_ _1254_ _1264_ _1277_ VDD VSS / sg13g2_nand4_1
X_3753_ _1279_ u_core_u_seu_qa_18_ _0606_ _0725_ u_core_u_seu_qa_77_ _1088_ VDD VSS / sg13g2_a221oi_1
X_3754_ _1280_ u_core_u_seu_qa_112_ _0795_ _1217_ VDD VSS / sg13g2_a21oi_1
X_3755_ _1281_ u_core_u_seu_qa_6_ _0582_ _0696_ u_core_u_seu_qa_63_ VDD VSS / sg13g2_a22oi_1
X_3756_ _1282_ _1216_ _1279_ _1280_ _1281_ VDD VSS / sg13g2_nand4_1
X_3757_ _1283_ u_core_u_seu_qa_89_ _0749_ _1171_ u_core_u_seu_qb_3_ VDD VSS / sg13g2_a22oi_1
X_3758_ _1284_ u_core_u_seu_qa_86_ _0743_ _1204_ VDD VSS / sg13g2_a21oi_1
X_3759_ _1285_ u_core_u_seu_qa_107_ _0784_ _1163_ VDD VSS / sg13g2_o21ai_1
X_3760_ _1286_ u_core_u_seu_qa_39_ _0648_ _0797_ u_core_u_seu_qa_113_ _1285_ VDD VSS / sg13g2_a221oi_1
X_3761_ _1287_ _1283_ _1284_ _1286_ VDD VSS / sg13g2_nand3_1
X_3762_ _1288_ u_core_u_seu_qa_22_ _0614_ _0703_ u_core_u_seu_qa_66_ _1200_ VDD VSS / sg13g2_a221oi_1
X_3763_ _1289_ u_core_u_seu_qa_58_ _0685_ _1288_ VDD VSS / sg13g2_o21ai_1
X_3764_ _1290_ u_core_u_seu_qa_113_ _0796_ _1097_ VDD VSS / sg13g2_o21ai_1
X_3765_ _1291_ u_core_u_seu_qa_69_ _0709_ _1290_ VDD VSS / sg13g2_a21oi_1
X_3766_ _1292_ u_core_u_seu_qa_101_ _0773_ _1102_ VDD VSS / sg13g2_a21oi_1
X_3767_ _1293_ u_core_u_seu_qa_81_ _0733_ _1103_ VDD VSS / sg13g2_a21oi_1
X_3768_ _1294_ _1098_ _1291_ _1292_ _1293_ VDD VSS / sg13g2_nand4_1
X_3769_ _1295_ _1282_ _1287_ _1289_ _1294_ VDD VSS / sg13g2_nor4_1
X_3770_ _1296_ u_core_u_seu_qb_4_ _1150_ _1146_ VDD VSS / sg13g2_a21oi_1
X_3771_ _1297_ u_core_u_seu_qa_51_ _0671_ _1296_ VDD VSS / sg13g2_o21ai_1
X_3772_ _1298_ u_core_u_seu_qa_29_ _0628_ _0707_ u_core_u_seu_qa_68_ VDD VSS / sg13g2_a22oi_1
X_3773_ _1299_ u_core_u_seu_qa_44_ _0658_ _1219_ VDD VSS / sg13g2_a21oi_1
X_3774_ _1300_ _1298_ _1299_ VDD VSS / sg13g2_nand2_1
X_3775_ _1301_ _1198_ _1297_ _1300_ VDD VSS / sg13g2_nor3_1
X_3776_ _1302_ u_core_u_seu_qa_127_ _1066_ _1199_ VDD VSS / sg13g2_a21oi_1
X_3777_ _1303_ u_core_u_seu_qa_35_ _0639_ _1302_ VDD VSS / sg13g2_o21ai_1
X_3778_ _1304_ u_core_u_seu_qa_127_ _1065_ _1147_ VDD VSS / sg13g2_o21ai_1
X_3779_ _1305_ u_core_u_seu_qa_121_ _0812_ _1143_ VDD VSS / sg13g2_o21ai_1
X_3780_ _1306_ _1100_ _1303_ _1304_ _1305_ VDD VSS / sg13g2_nor4_1
X_3781_ _1307_ u_core_u_seu_qa_20_ _0609_ _1164_ VDD VSS / sg13g2_o21ai_1
X_3782_ _1308_ u_core_u_seu_qa_20_ _0610_ _1197_ VDD VSS / sg13g2_a21oi_1
X_3783_ _1309_ u_core_u_seu_qa_35_ _0640_ _0737_ u_core_u_seu_qa_83_ VDD VSS / sg13g2_a22oi_1
X_3784_ _1310_ _1308_ _1309_ VDD VSS / sg13g2_nand2_1
X_3785_ _1311_ _1156_ _1178_ _1307_ _1310_ VDD VSS / sg13g2_nor4_1
X_3786_ _1312_ _1295_ _1301_ _1306_ _1311_ VDD VSS / sg13g2_nand4_1
X_3787_ _1313_ u_core_u_seu_qa_122_ _0814_ _1203_ VDD VSS / sg13g2_o21ai_1
X_3788_ _1314_ u_core_u_seu_qa_93_ _0756_ _1211_ VDD VSS / sg13g2_o21ai_1
X_3789_ _1315_ u_core_u_seu_qa_95_ _0760_ _1191_ VDD VSS / sg13g2_o21ai_1
X_3790_ _1316_ _1182_ _1313_ _1314_ _1315_ VDD VSS / sg13g2_nor4_1
X_3791_ _1317_ u_core_u_seu_qa_85_ _0740_ _1316_ VDD VSS / sg13g2_o21ai_1
X_3792_ _1318_ u_core_u_seu_qa_36_ _0641_ _1167_ VDD VSS / sg13g2_o21ai_1
X_3793_ _1319_ u_core_u_seu_qa_79_ _0729_ _0735_ u_core_u_seu_qa_82_ _1209_ VDD VSS / sg13g2_a221oi_1
X_3794_ _1320_ u_core_u_seu_qa_70_ _0710_ _1319_ VDD VSS / sg13g2_o21ai_1
X_3795_ _1321_ u_core_u_seu_qa_124_ _0819_ _1139_ _1140_ _1218_ VDD VSS / sg13g2_a221oi_1
X_3796_ _1322_ u_core_u_seu_qa_9_ _0588_ _0646_ u_core_u_seu_qa_38_ VDD VSS / sg13g2_a22oi_1
X_3797_ _1323_ _1138_ _1321_ _1322_ VDD VSS / sg13g2_nand3_1
X_3798_ _1324_ _1317_ _1318_ _1320_ _1323_ VDD VSS / sg13g2_nor4_1
X_3799_ _1325_ u_core_u_seu_qa_49_ _0668_ _0799_ u_core_u_seu_qa_114_ _1144_ VDD VSS / sg13g2_a221oi_1
X_3800_ _1326_ u_core_u_seu_qa_125_ _0821_ _1153_ VDD VSS / sg13g2_a21oi_1
X_3801_ _1327_ u_core_u_seu_qa_116_ _0803_ _1215_ VDD VSS / sg13g2_a21oi_1
X_3802_ _1328_ _1192_ _1325_ _1326_ _1327_ VDD VSS / sg13g2_nand4_1
X_3803_ _1329_ u_core_u_seu_qa_46_ _0662_ _1159_ VDD VSS / sg13g2_a21oi_1
X_3804_ _1330_ u_core_u_seu_qa_6_ _0581_ _1329_ VDD VSS / sg13g2_o21ai_1
X_3805_ _1331_ u_core_u_seu_qa_40_ _0650_ _0817_ u_core_u_seu_qa_123_ VDD VSS / sg13g2_a22oi_1
X_3806_ _1332_ u_core_u_seu_qa_123_ _0816_ _1331_ VDD VSS / sg13g2_o21ai_1
X_3807_ _1333_ u_core_u_seu_qa_46_ _0661_ _1113_ VDD VSS / sg13g2_o21ai_1
X_3808_ _1334_ _1328_ _1330_ _1332_ _1333_ VDD VSS / sg13g2_nor4_1
X_3809_ _1335_ u_core_u_seu_qa_7_ _0584_ _1107_ VDD VSS / sg13g2_a21oi_1
X_3810_ _1336_ u_core_u_seu_qa_29_ _0627_ _1190_ VDD VSS / sg13g2_o21ai_1
X_3811_ _1337_ u_core_u_seu_qa_24_ _0618_ _0672_ u_core_u_seu_qa_51_ _1336_ VDD VSS / sg13g2_a221oi_1
X_3812_ _1338_ _1111_ _1206_ _1335_ _1337_ VDD VSS / sg13g2_nand4_1
X_3813_ _1339_ u_core_u_seu_qa_76_ _0723_ _0727_ u_core_u_seu_qa_78_ _1189_ VDD VSS / sg13g2_a221oi_1
X_3814_ _1340_ u_core_u_seu_qa_78_ _0726_ _1339_ VDD VSS / sg13g2_o21ai_1
X_3815_ _1341_ u_core_u_seu_qa_99_ _0769_ _1193_ VDD VSS / sg13g2_a21oi_1
X_3816_ _1342_ u_core_u_seu_qa_19_ _0607_ _1341_ VDD VSS / sg13g2_o21ai_1
X_3817_ _1343_ u_core_u_seu_qa_19_ _0608_ _1342_ VDD VSS / sg13g2_a21o_1
X_3818_ _1344_ u_core_u_seu_qa_17_ _0604_ _0676_ u_core_u_seu_qa_53_ _1106_ VDD VSS / sg13g2_a221oi_1
X_3819_ _1345_ u_core_u_seu_qa_9_ _0587_ _1344_ VDD VSS / sg13g2_o21ai_1
X_3820_ _1346_ _1338_ _1340_ _1343_ _1345_ VDD VSS / sg13g2_nor4_1
X_3821_ _1347_ u_core_u_seu_qa_106_ _0782_ _1148_ VDD VSS / sg13g2_o21ai_1
X_3822_ _1348_ _1149_ _1161_ _1347_ VDD VSS / sg13g2_nor3_1
X_3823_ _1349_ u_core_u_seu_qa_100_ _0771_ _1158_ VDD VSS / sg13g2_a21oi_1
X_3824_ _1350_ u_core_u_seu_qa_13_ _0595_ _1101_ VDD VSS / sg13g2_o21ai_1
X_3825_ _1351_ _1145_ _1154_ _1350_ VDD VSS / sg13g2_nor3_1
X_3826_ _1352_ _1152_ _1348_ _1349_ _1351_ VDD VSS / sg13g2_nand4_1
X_3827_ _1353_ u_core_u_seu_qa_111_ _0793_ _0807_ u_core_u_seu_qa_118_ _1165_ VDD VSS / sg13g2_a221oi_1
X_3828_ _1354_ u_core_u_seu_qa_49_ _0667_ _1353_ VDD VSS / sg13g2_o21ai_1
X_3829_ _1355_ u_core_u_seu_qa_88_ _0747_ _1187_ VDD VSS / sg13g2_a21oi_1
X_3830_ _1356_ u_core_u_seu_qa_26_ _0622_ _1166_ u_core_u_seu_qb_0_ VDD VSS / sg13g2_a22oi_1
X_3831_ _1357_ u_core_u_seu_qa_63_ _0695_ _1188_ VDD VSS / sg13g2_o21ai_1
X_3832_ _1358_ _1168_ _1205_ _1357_ VDD VSS / sg13g2_nor3_1
X_3833_ _1359_ _1355_ _1356_ _1358_ VDD VSS / sg13g2_nand3_1
X_3834_ _1360_ u_core_u_seu_qa_72_ _0715_ _0813_ u_core_u_seu_qa_121_ VDD VSS / sg13g2_a22oi_1
X_3835_ _1361_ u_core_u_seu_qa_37_ _0643_ _1360_ VDD VSS / sg13g2_o21ai_1
X_3836_ _1362_ u_core_u_seu_qa_72_ _0714_ _1160_ VDD VSS / sg13g2_o21ai_1
X_3837_ _1363_ u_core_u_seu_qa_24_ _0617_ _1155_ VDD VSS / sg13g2_o21ai_1
X_3838_ _1364_ _1169_ _1361_ _1362_ _1363_ VDD VSS / sg13g2_nor4_1
X_3839_ _1365_ u_core_u_seu_qa_55_ _0680_ _1108_ VDD VSS / sg13g2_a21oi_1
X_3840_ _1366_ u_core_u_seu_qb_45_ u_core_u_seu_qa_45_ u_core_u_seu_qc_45_ VDD VSS / sg13g2_nand3_1
X_3841_ _1367_ u_core_u_seu_qa_45_ _0659_ VDD VSS / sg13g2_nand2b_1
X_3842_ _1368_ u_core_u_seu_qa_42_ _0653_ _1157_ VDD VSS / sg13g2_o21ai_1
X_3843_ _1369_ u_core_u_seu_qa_126_ _0823_ _1366_ _1367_ _1368_ VDD VSS / sg13g2_a221oi_1
X_3844_ _1370_ _1364_ _1365_ _1369_ VDD VSS / sg13g2_nand3_1
X_3845_ _1371_ _1352_ _1354_ _1359_ _1370_ VDD VSS / sg13g2_nor4_1
X_3846_ _1372_ _1324_ _1334_ _1346_ _1371_ VDD VSS / sg13g2_nand4_1
X_3847_ _1373_ _1278_ _1312_ _1372_ VDD VSS / sg13g2_nor3_1
X_3848_ _1374_ u_core_u_seu_u_cnt_corr_qb_3_ u_core_u_seu_u_cnt_corr_qc_3_ VDD VSS / sg13g2_nor2_1
X_3849_ _1375_ u_core_u_seu_u_cnt_corr_qb_3_ u_core_u_seu_u_cnt_corr_qc_3_ u_core_u_seu_u_cnt_corr_qa_3_ VDD VSS / sg13g2_a21oi_1
X_3850_ _1376_ _1374_ _1375_ VDD VSS / sg13g2_nor2_1
X_3851_ _1377_ u_core_u_seu_u_cnt_corr_qb_4_ u_core_u_seu_u_cnt_corr_qc_4_ VDD VSS / sg13g2_nor2_1
X_3852_ _1378_ u_core_u_seu_u_cnt_corr_qb_4_ u_core_u_seu_u_cnt_corr_qc_4_ u_core_u_seu_u_cnt_corr_qa_4_ VDD VSS / sg13g2_a21oi_1
X_3853_ _1379_ _1377_ _1378_ VDD VSS / sg13g2_nor2_1
X_3854_ _1380_ u_core_u_seu_u_cnt_corr_qb_1_ u_core_u_seu_u_cnt_corr_qc_1_ VDD VSS / sg13g2_nor2_1
X_3855_ _1381_ u_core_u_seu_u_cnt_corr_qb_1_ u_core_u_seu_u_cnt_corr_qc_1_ u_core_u_seu_u_cnt_corr_qa_1_ VDD VSS / sg13g2_a21oi_1
X_3856_ _1382_ _1380_ _1381_ VDD VSS / sg13g2_nor2_1
X_3857_ _1383_ u_core_u_seu_u_cnt_corr_qb_6_ u_core_u_seu_u_cnt_corr_qc_6_ u_core_u_seu_u_cnt_corr_qa_6_ VDD VSS / sg13g2_a21o_1
X_3858_ _1384_ u_core_u_seu_u_cnt_corr_qb_6_ u_core_u_seu_u_cnt_corr_qc_6_ _1383_ VDD VSS / sg13g2_o21ai_1
X_3859_ _1385_ _1384_ VDD VSS / sg13g2_inv_1
X_3860_ _1386_ u_core_u_seu_u_cnt_corr_qb_5_ u_core_u_seu_u_cnt_corr_qc_5_ VDD VSS / sg13g2_nor2_1
X_3861_ _1387_ u_core_u_seu_u_cnt_corr_qb_5_ u_core_u_seu_u_cnt_corr_qc_5_ u_core_u_seu_u_cnt_corr_qa_5_ VDD VSS / sg13g2_a21oi_1
X_3862_ _1388_ _1386_ _1387_ VDD VSS / sg13g2_nor2_1
X_3863_ _1389_ _1388_ VDD VSS / sg13g2_inv_1
X_3864_ _1390_ u_core_u_seu_u_cnt_corr_qb_2_ u_core_u_seu_u_cnt_corr_qc_2_ u_core_u_seu_u_cnt_corr_qa_2_ VDD VSS / sg13g2_a21o_1
X_3865_ _1391_ u_core_u_seu_u_cnt_corr_qb_2_ u_core_u_seu_u_cnt_corr_qc_2_ _1390_ VDD VSS / sg13g2_o21ai_1
X_3866_ _1392_ _1391_ VDD VSS / sg13g2_inv_1
X_3867_ _1393_ _1084_ _1384_ _1389_ _1391_ VDD VSS / sg13g2_nor4_1
X_3868_ _1394_ _1376_ _1379_ _1382_ _1393_ VDD VSS / sg13g2_nand4_1
X_3869_ _1395_ u_core_u_seu_u_cnt_corr_qb_10_ u_core_u_seu_u_cnt_corr_qc_10_ VDD VSS / sg13g2_nor2_1
X_3870_ _1396_ u_core_u_seu_u_cnt_corr_qb_10_ u_core_u_seu_u_cnt_corr_qc_10_ u_core_u_seu_u_cnt_corr_qa_10_ VDD VSS / sg13g2_a21oi_1
X_3871_ _1397_ _1395_ _1396_ VDD VSS / sg13g2_nor2_1
X_3872_ _1398_ u_core_u_seu_u_cnt_corr_qb_9_ u_core_u_seu_u_cnt_corr_qc_9_ VDD VSS / sg13g2_nor2_1
X_3873_ _1399_ u_core_u_seu_u_cnt_corr_qb_9_ u_core_u_seu_u_cnt_corr_qc_9_ u_core_u_seu_u_cnt_corr_qa_9_ VDD VSS / sg13g2_a21oi_1
X_3874_ _1400_ _1398_ _1399_ VDD VSS / sg13g2_nor2_1
X_3875_ _1401_ u_core_u_seu_u_cnt_corr_qb_11_ u_core_u_seu_u_cnt_corr_qc_11_ VDD VSS / sg13g2_nor2_1
X_3876_ _1402_ u_core_u_seu_u_cnt_corr_qb_11_ u_core_u_seu_u_cnt_corr_qc_11_ u_core_u_seu_u_cnt_corr_qa_11_ VDD VSS / sg13g2_a21oi_1
X_3877_ _1403_ _1401_ _1402_ VDD VSS / sg13g2_nor2_1
X_3878_ _1404_ _1397_ _1400_ _1403_ VDD VSS / sg13g2_and3_1
X_3879_ _1405_ u_core_u_seu_u_cnt_corr_qb_7_ u_core_u_seu_u_cnt_corr_qc_7_ VDD VSS / sg13g2_nor2_1
X_3880_ _1406_ u_core_u_seu_u_cnt_corr_qb_7_ u_core_u_seu_u_cnt_corr_qc_7_ u_core_u_seu_u_cnt_corr_qa_7_ VDD VSS / sg13g2_a21o_1
X_3881_ _1407_ _1405_ _1406_ VDD VSS / sg13g2_nor2b_1
X_3882_ _1408_ _1405_ _1406_ VDD VSS / sg13g2_nand2b_1
X_3883_ _1409_ u_core_u_seu_u_cnt_corr_qb_8_ u_core_u_seu_u_cnt_corr_qc_8_ VDD VSS / sg13g2_nor2_1
X_3884_ _1410_ u_core_u_seu_u_cnt_corr_qb_8_ u_core_u_seu_u_cnt_corr_qc_8_ u_core_u_seu_u_cnt_corr_qa_8_ VDD VSS / sg13g2_a21oi_1
X_3885_ _1411_ _1409_ _1410_ VDD VSS / sg13g2_nor2_1
X_3886_ _1412_ u_core_u_seu_u_cnt_corr_qb_12_ u_core_u_seu_u_cnt_corr_qc_12_ VDD VSS / sg13g2_nor2_1
X_3887_ _1413_ u_core_u_seu_u_cnt_corr_qb_12_ u_core_u_seu_u_cnt_corr_qc_12_ u_core_u_seu_u_cnt_corr_qa_12_ VDD VSS / sg13g2_a21oi_1
X_3888_ _1414_ _1412_ _1413_ VDD VSS / sg13g2_nor2_1
X_3889_ _1415_ _1404_ _1407_ _1411_ _1414_ VDD VSS / sg13g2_nand4_1
X_3890_ _1416_ u_core_u_seu_u_cnt_corr_qb_13_ u_core_u_seu_u_cnt_corr_qc_13_ VDD VSS / sg13g2_nor2_1
X_3891_ _1417_ u_core_u_seu_u_cnt_corr_qb_13_ u_core_u_seu_u_cnt_corr_qc_13_ u_core_u_seu_u_cnt_corr_qa_13_ VDD VSS / sg13g2_a21oi_1
X_3892_ _1418_ _1416_ _1417_ VDD VSS / sg13g2_nor2_1
X_3893_ _1419_ u_core_u_seu_u_cnt_corr_qb_14_ u_core_u_seu_u_cnt_corr_qc_14_ u_core_u_seu_u_cnt_corr_qa_14_ VDD VSS / sg13g2_a21o_1
X_3894_ _1420_ u_core_u_seu_u_cnt_corr_qb_14_ u_core_u_seu_u_cnt_corr_qc_14_ _1419_ VDD VSS / sg13g2_o21ai_1
X_3895_ _1421_ _1416_ _1417_ _1420_ VDD VSS / sg13g2_nor3_1
X_3896_ _1422_ u_core_u_seu_u_cnt_corr_qb_15_ u_core_u_seu_u_cnt_corr_qc_15_ VDD VSS / sg13g2_nor2_1
X_3897_ _1423_ u_core_u_seu_u_cnt_corr_qb_15_ u_core_u_seu_u_cnt_corr_qc_15_ u_core_u_seu_u_cnt_corr_qa_15_ VDD VSS / sg13g2_a21oi_1
X_3898_ _1424_ _1422_ _1423_ VDD VSS / sg13g2_nor2_1
X_3899_ _1425_ _1421_ _1424_ VDD VSS / sg13g2_nand2_1
X_3900_ _1426_ _1394_ _1415_ _1425_ VDD VSS / sg13g2_nor3_1
X_3901_ _1427_ _0054_ _0911_ _1373_ _1426_ VDD VSS / sg13g2_or4_1
X_3902_ _1428_ _1084_ _1427_ net80 VDD VSS / sg13g2_a21oi_1
X_3903_ _1429_ net69 _1084_ _1373_ _1426_ VDD VSS / sg13g2_nor4_1
X_3904_ u_core_u_seu_cnt_corr_n_0_ _1429_ _1428_ VDD VSS / sg13g2_nor2b_1
X_3905_ _1430_ _1382_ _1429_ VDD VSS / sg13g2_nor2_1
X_3906_ _1431_ _1382_ _1429_ VDD VSS / sg13g2_and2_1
X_3907_ _1432_ _1084_ _1380_ _1381_ _1427_ VDD VSS / sg13g2_nor4_1
X_3908_ u_core_u_seu_cnt_corr_n_1_ net80 _1430_ _1431_ VDD VSS / sg13g2_nor3_1
X_3909_ _1433_ _1392_ _1431_ VDD VSS / sg13g2_xnor2_1
X_3910_ u_core_u_seu_cnt_corr_n_2_ net80 _1433_ VDD VSS / sg13g2_nor2_1
X_3911_ _1434_ _1392_ _1431_ _1376_ VDD VSS / sg13g2_a21oi_1
X_3912_ _1435_ _1376_ _1392_ _1432_ VDD VSS / sg13g2_and3_1
X_3913_ u_core_u_seu_cnt_corr_n_3_ net80 _1434_ _1435_ VDD VSS / sg13g2_nor3_1
X_3914_ _1436_ _1379_ _1435_ VDD VSS / sg13g2_nor2_1
X_3915_ _1437_ _1379_ _1435_ VDD VSS / sg13g2_and2_1
X_3916_ u_core_u_seu_cnt_corr_n_4_ net80 _1436_ _1437_ VDD VSS / sg13g2_nor3_1
X_3917_ _1438_ _1388_ _1437_ net73 VDD VSS / sg13g2_o21ai_1
X_3918_ u_core_u_seu_cnt_corr_n_5_ _1388_ _1437_ _1438_ VDD VSS / sg13g2_a21oi_1
X_3919_ _1439_ _1388_ _1437_ _1385_ VDD VSS / sg13g2_a21o_1
X_3920_ _1440_ _1394_ _1427_ VDD VSS / sg13g2_or2_1
X_3921_ u_core_u_seu_cnt_corr_n_6_ net73 _1439_ _1440_ VDD VSS / sg13g2_and3_1
X_3922_ _1441_ _1408_ _1440_ VDD VSS / sg13g2_and2_1
X_3923_ _1442_ _1408_ _1440_ VDD VSS / sg13g2_nor2_1
X_3924_ u_core_u_seu_cnt_corr_n_7_ net80 _1441_ _1442_ VDD VSS / sg13g2_nor3_1
X_3925_ _1443_ _1411_ _1442_ VDD VSS / sg13g2_nor2_1
X_3926_ _1444_ _1411_ _1442_ VDD VSS / sg13g2_and2_1
X_3927_ u_core_u_seu_cnt_corr_n_8_ net77 _1443_ _1444_ VDD VSS / sg13g2_nor3_1
X_3928_ _1445_ _1400_ _1444_ VDD VSS / sg13g2_and2_1
X_3929_ _1446_ _1400_ _1444_ net73 VDD VSS / sg13g2_o21ai_1
X_3930_ u_core_u_seu_cnt_corr_n_9_ _1445_ _1446_ VDD VSS / sg13g2_nor2_1
X_3931_ _1447_ _1397_ _1445_ VDD VSS / sg13g2_nor2_1
X_3932_ _1448_ _1397_ _1400_ _1444_ VDD VSS / sg13g2_and3_1
X_3933_ u_core_u_seu_cnt_corr_n_10_ net77 _1447_ _1448_ VDD VSS / sg13g2_nor3_1
X_3934_ _1449_ _1403_ _1448_ VDD VSS / sg13g2_nor2_1
X_3935_ _1450_ _1403_ _1448_ net77 VDD VSS / sg13g2_a21oi_1
X_3936_ u_core_u_seu_cnt_corr_n_11_ _1449_ _1450_ VDD VSS / sg13g2_nor2b_1
X_3937_ _1451_ _1403_ _1448_ _1414_ VDD VSS / sg13g2_a21oi_1
X_3938_ _1452_ _1415_ _1440_ VDD VSS / sg13g2_nor2_1
X_3939_ u_core_u_seu_cnt_corr_n_12_ net81 _1451_ _1452_ VDD VSS / sg13g2_nor3_1
X_3940_ _1453_ _1418_ _1452_ VDD VSS / sg13g2_or2_1
X_3941_ _1454_ _1418_ _1452_ VDD VSS / sg13g2_nand2_1
X_3942_ _1455_ net74 _1453_ _1454_ VDD VSS / sg13g2_nand3_1
X_3943_ u_core_u_seu_cnt_corr_n_13_ _1455_ VDD VSS / sg13g2_inv_1
X_3944_ u_core_u_seu_cnt_corr_n_14_ _1421_ _1452_ _1454_ _1420_ net81 VDD VSS / sg13g2_a221oi_1
X_3945_ _1456_ _1421_ _1452_ _1424_ VDD VSS / sg13g2_a21oi_1
X_3946_ u_core_u_seu_cnt_corr_n_15_ net81 _1456_ VDD VSS / sg13g2_nor2_1
X_3947_ _1457_ u_core_u_seu_u_cnt_plain_qb_0_ u_core_u_seu_u_cnt_plain_qc_0_ VDD VSS / sg13g2_nor2_1
X_3948_ _1458_ u_core_u_seu_u_cnt_plain_qb_0_ u_core_u_seu_u_cnt_plain_qc_0_ u_core_u_seu_u_cnt_plain_qa_0_ VDD VSS / sg13g2_a21oi_1
X_3949_ _1459_ _1457_ _1458_ VDD VSS / sg13g2_nor2_1
X_3950_ _1460_ u_core_u_seu_u_cnt_plain_qb_15_ u_core_u_seu_u_cnt_plain_qc_15_ VDD VSS / sg13g2_nor2_1
X_3951_ _1461_ u_core_u_seu_u_cnt_plain_qb_15_ u_core_u_seu_u_cnt_plain_qc_15_ u_core_u_seu_u_cnt_plain_qa_15_ VDD VSS / sg13g2_a21oi_1
X_3952_ _1462_ _1460_ _1461_ VDD VSS / sg13g2_nor2_1
X_3953_ _1463_ u_core_u_seu_u_cnt_plain_qb_10_ u_core_u_seu_u_cnt_plain_qc_10_ VDD VSS / sg13g2_nor2_1
X_3954_ _1464_ u_core_u_seu_u_cnt_plain_qb_10_ u_core_u_seu_u_cnt_plain_qc_10_ u_core_u_seu_u_cnt_plain_qa_10_ VDD VSS / sg13g2_a21oi_1
X_3955_ _1465_ _1463_ _1464_ VDD VSS / sg13g2_nor2_1
X_3956_ _1466_ u_core_u_seu_u_cnt_plain_qb_11_ u_core_u_seu_u_cnt_plain_qc_11_ VDD VSS / sg13g2_nor2_1
X_3957_ _1467_ u_core_u_seu_u_cnt_plain_qb_11_ u_core_u_seu_u_cnt_plain_qc_11_ u_core_u_seu_u_cnt_plain_qa_11_ VDD VSS / sg13g2_a21oi_1
X_3958_ _1468_ _1466_ _1467_ VDD VSS / sg13g2_nor2_1
X_3959_ _1469_ u_core_u_seu_u_cnt_plain_qb_9_ u_core_u_seu_u_cnt_plain_qc_9_ VDD VSS / sg13g2_nor2_1
X_3960_ _1470_ u_core_u_seu_u_cnt_plain_qb_9_ u_core_u_seu_u_cnt_plain_qc_9_ u_core_u_seu_u_cnt_plain_qa_9_ VDD VSS / sg13g2_a21oi_1
X_3961_ _1471_ _1469_ _1470_ VDD VSS / sg13g2_nor2_1
X_3962_ _1472_ u_core_u_seu_u_cnt_plain_qb_8_ u_core_u_seu_u_cnt_plain_qc_8_ VDD VSS / sg13g2_nor2_1
X_3963_ _1473_ u_core_u_seu_u_cnt_plain_qb_8_ u_core_u_seu_u_cnt_plain_qc_8_ u_core_u_seu_u_cnt_plain_qa_8_ VDD VSS / sg13g2_a21oi_1
X_3964_ _1474_ _1472_ _1473_ VDD VSS / sg13g2_nor2_1
X_3965_ _1475_ u_core_u_seu_u_cnt_plain_qb_7_ u_core_u_seu_u_cnt_plain_qc_7_ VDD VSS / sg13g2_nor2_1
X_3966_ _1476_ u_core_u_seu_u_cnt_plain_qb_7_ u_core_u_seu_u_cnt_plain_qc_7_ u_core_u_seu_u_cnt_plain_qa_7_ VDD VSS / sg13g2_a21oi_1
X_3967_ _1477_ _1475_ _1476_ VDD VSS / sg13g2_nor2_1
X_3968_ _1478_ u_core_u_seu_u_cnt_plain_qb_12_ u_core_u_seu_u_cnt_plain_qc_12_ VDD VSS / sg13g2_nor2_1
X_3969_ _1479_ u_core_u_seu_u_cnt_plain_qb_12_ u_core_u_seu_u_cnt_plain_qc_12_ u_core_u_seu_u_cnt_plain_qa_12_ VDD VSS / sg13g2_a21oi_1
X_3970_ _1480_ _1478_ _1479_ VDD VSS / sg13g2_nor2_1
X_3971_ _1481_ _1471_ _1474_ _1477_ VDD VSS / sg13g2_and3_1
X_3972_ _1482_ _1465_ _1468_ _1480_ _1481_ VDD VSS / sg13g2_nand4_1
X_3973_ _1483_ u_core_u_seu_u_cnt_plain_qb_3_ u_core_u_seu_u_cnt_plain_qc_3_ VDD VSS / sg13g2_nor2_1
X_3974_ _1484_ u_core_u_seu_u_cnt_plain_qb_3_ u_core_u_seu_u_cnt_plain_qc_3_ u_core_u_seu_u_cnt_plain_qa_3_ VDD VSS / sg13g2_a21o_1
X_3975_ _1485_ _1483_ _1484_ VDD VSS / sg13g2_nor2b_1
X_3976_ _1486_ _1483_ _1484_ VDD VSS / sg13g2_nand2b_1
X_3977_ _1487_ u_core_u_seu_u_cnt_plain_qb_4_ u_core_u_seu_u_cnt_plain_qc_4_ VDD VSS / sg13g2_nor2_1
X_3978_ _1488_ u_core_u_seu_u_cnt_plain_qb_4_ u_core_u_seu_u_cnt_plain_qc_4_ u_core_u_seu_u_cnt_plain_qa_4_ VDD VSS / sg13g2_a21oi_1
X_3979_ _1489_ _1487_ _1488_ VDD VSS / sg13g2_nor2_1
X_3980_ _1490_ u_core_u_seu_u_cnt_plain_qb_1_ u_core_u_seu_u_cnt_plain_qc_1_ VDD VSS / sg13g2_nor2_1
X_3981_ _1491_ u_core_u_seu_u_cnt_plain_qb_1_ u_core_u_seu_u_cnt_plain_qc_1_ u_core_u_seu_u_cnt_plain_qa_1_ VDD VSS / sg13g2_a21o_1
X_3982_ _1492_ _1490_ _1491_ VDD VSS / sg13g2_nor2b_1
X_3983_ _1493_ _1490_ _1491_ VDD VSS / sg13g2_nand2b_1
X_3984_ _1494_ _1486_ _1487_ _1488_ _1493_ VDD VSS / sg13g2_nor4_1
X_3985_ _1495_ u_core_u_seu_u_cnt_plain_qb_6_ u_core_u_seu_u_cnt_plain_qc_6_ u_core_u_seu_u_cnt_plain_qa_6_ VDD VSS / sg13g2_a21o_1
X_3986_ _1496_ u_core_u_seu_u_cnt_plain_qb_6_ u_core_u_seu_u_cnt_plain_qc_6_ _1495_ VDD VSS / sg13g2_o21ai_1
X_3987_ _1497_ _1496_ VDD VSS / sg13g2_inv_1
X_3988_ _1498_ u_core_u_seu_u_cnt_plain_qb_5_ u_core_u_seu_u_cnt_plain_qc_5_ VDD VSS / sg13g2_nor2_1
X_3989_ _1499_ u_core_u_seu_u_cnt_plain_qb_5_ u_core_u_seu_u_cnt_plain_qc_5_ u_core_u_seu_u_cnt_plain_qa_5_ VDD VSS / sg13g2_a21oi_1
X_3990_ _1500_ _1498_ _1499_ VDD VSS / sg13g2_nor2_1
X_3991_ _1501_ _1496_ _1500_ VDD VSS / sg13g2_nor2b_1
X_3992_ _1502_ u_core_u_seu_u_cnt_plain_qb_2_ u_core_u_seu_u_cnt_plain_qc_2_ VDD VSS / sg13g2_nor2_1
X_3993_ _1503_ u_core_u_seu_u_cnt_plain_qb_2_ u_core_u_seu_u_cnt_plain_qc_2_ u_core_u_seu_u_cnt_plain_qa_2_ VDD VSS / sg13g2_a21oi_1
X_3994_ _1504_ _1502_ _1503_ VDD VSS / sg13g2_nor2_1
X_3995_ _1505_ _1504_ VDD VSS / sg13g2_inv_1
X_3996_ _1506_ _1459_ _1494_ _1501_ _1504_ VDD VSS / sg13g2_nand4_1
X_3997_ _1507_ u_core_u_seu_u_cnt_plain_qb_14_ u_core_u_seu_u_cnt_plain_qc_14_ VDD VSS / sg13g2_nor2_1
X_3998_ _1508_ u_core_u_seu_u_cnt_plain_qb_14_ u_core_u_seu_u_cnt_plain_qc_14_ u_core_u_seu_u_cnt_plain_qa_14_ VDD VSS / sg13g2_a21oi_1
X_3999_ _1509_ _1507_ _1508_ VDD VSS / sg13g2_nor2_1
X_4000_ _1510_ u_core_u_seu_u_cnt_plain_qb_13_ u_core_u_seu_u_cnt_plain_qc_13_ VDD VSS / sg13g2_nor2_1
X_4001_ _1511_ u_core_u_seu_u_cnt_plain_qb_13_ u_core_u_seu_u_cnt_plain_qc_13_ u_core_u_seu_u_cnt_plain_qa_13_ VDD VSS / sg13g2_a21oi_1
X_4002_ _1512_ _1510_ _1511_ VDD VSS / sg13g2_nor2_1
X_4003_ _1513_ _1509_ _1512_ VDD VSS / sg13g2_nand2_1
X_4004_ _1514_ _1482_ _1506_ _1513_ VDD VSS / sg13g2_nor3_1
X_4005_ _1515_ _1462_ _1514_ _0944_ VDD VSS / sg13g2_a21oi_1
X_4006_ _1516_ _1459_ _1489_ _1492_ _1504_ VDD VSS / sg13g2_and4_1
X_4007_ _1517_ _1485_ _1501_ _1516_ VDD VSS / sg13g2_and3_1
X_4008_ _1518_ _1462_ _1509_ _1512_ _1517_ VDD VSS / sg13g2_nand4_1
X_4009_ _1519_ _1482_ _1518_ VDD VSS / sg13g2_or2_1
X_4010_ _1520_ _1459_ _1515_ VDD VSS / sg13g2_nor2_1
X_4011_ _1521_ _1459_ _1515_ VDD VSS / sg13g2_nand2_1
X_4012_ _1522_ _1521_ VDD VSS / sg13g2_inv_1
X_4013_ u_core_u_seu_cnt_plain_n_0_ net78 _1520_ _1522_ VDD VSS / sg13g2_nor3_1
X_4014_ _1523_ _1492_ _1522_ VDD VSS / sg13g2_nand2_1
X_4015_ _1524_ net74 _1523_ VDD VSS / sg13g2_nand2_1
X_4016_ u_core_u_seu_cnt_plain_n_1_ _1493_ _1521_ _1524_ VDD VSS / sg13g2_a21oi_1
X_4017_ _1525_ _1492_ _1522_ _1504_ VDD VSS / sg13g2_a21oi_1
X_4018_ _1526_ _1505_ _1523_ VDD VSS / sg13g2_nor2_1
X_4019_ u_core_u_seu_cnt_plain_n_2_ net78 _1525_ _1526_ VDD VSS / sg13g2_nor3_1
X_4020_ _1527_ _1485_ _1526_ VDD VSS / sg13g2_nor2_1
X_4021_ _1528_ _1486_ _1505_ _1523_ VDD VSS / sg13g2_nor3_1
X_4022_ u_core_u_seu_cnt_plain_n_3_ net78 _1527_ _1528_ VDD VSS / sg13g2_nor3_1
X_4023_ _1529_ _1489_ _1528_ VDD VSS / sg13g2_nor2_1
X_4024_ _1530_ _1489_ _1528_ VDD VSS / sg13g2_and2_1
X_4025_ u_core_u_seu_cnt_plain_n_4_ net78 _1529_ _1530_ VDD VSS / sg13g2_nor3_1
X_4026_ _1531_ _1500_ _1530_ VDD VSS / sg13g2_nor2_1
X_4027_ u_core_u_seu_cnt_plain_n_5_ net360 _0831_ _1500_ _1530_ _1531_ VDD VSS / sg13g2_a221oi_1
X_4028_ _1532_ _1500_ _1530_ _1497_ VDD VSS / sg13g2_a21oi_1
X_4029_ _1533_ _1506_ _1515_ VDD VSS / sg13g2_nor2b_1
X_4030_ _1534_ net65 _1517_ _1519_ VDD VSS / sg13g2_and3_1
X_4031_ u_core_u_seu_cnt_plain_n_6_ net78 _1532_ _1534_ VDD VSS / sg13g2_nor3_1
X_4032_ _1535_ _1477_ _1534_ net74 VDD VSS / sg13g2_o21ai_1
X_4033_ _1536_ _1477_ _1534_ VDD VSS / sg13g2_and2_1
X_4034_ u_core_u_seu_cnt_plain_n_7_ _1535_ _1536_ VDD VSS / sg13g2_nor2_1
X_4035_ _1537_ _1474_ _1536_ VDD VSS / sg13g2_nor2_1
X_4036_ _1538_ _1474_ _1477_ _1533_ VDD VSS / sg13g2_and3_1
X_4037_ u_core_u_seu_cnt_plain_n_8_ net77 _1537_ _1538_ VDD VSS / sg13g2_nor3_1
X_4038_ _1539_ _1471_ _1538_ VDD VSS / sg13g2_nor2_1
X_4039_ _1540_ _1471_ _1538_ VDD VSS / sg13g2_and2_1
X_4040_ u_core_u_seu_cnt_plain_n_9_ net77 _1539_ _1540_ VDD VSS / sg13g2_nor3_1
X_4041_ _1541_ _1465_ _1540_ VDD VSS / sg13g2_nor2_1
X_4042_ _1542_ _1465_ _1540_ VDD VSS / sg13g2_and2_1
X_4043_ u_core_u_seu_cnt_plain_n_10_ net77 _1541_ _1542_ VDD VSS / sg13g2_nor3_1
X_4044_ _1543_ _1468_ _1542_ net77 VDD VSS / sg13g2_a21oi_1
X_4045_ _1544_ _1468_ _1542_ _1543_ VDD VSS / sg13g2_o21ai_1
X_4046_ u_core_u_seu_cnt_plain_n_11_ _1544_ VDD VSS / sg13g2_inv_1
X_4047_ _1545_ _1468_ _1542_ _1480_ VDD VSS / sg13g2_a21oi_1
X_4048_ _1546_ _1482_ _1534_ VDD VSS / sg13g2_nor2b_1
X_4049_ u_core_u_seu_cnt_plain_n_12_ net77 _1545_ _1546_ VDD VSS / sg13g2_nor3_1
X_4050_ _1547_ _1512_ _1546_ VDD VSS / sg13g2_nor2_1
X_4051_ _1548_ _1512_ _1546_ VDD VSS / sg13g2_and2_1
X_4052_ u_core_u_seu_cnt_plain_n_13_ net78 _1547_ _1548_ VDD VSS / sg13g2_nor3_1
X_4053_ _1549_ _1509_ _1548_ net74 VDD VSS / sg13g2_o21ai_1
X_4054_ u_core_u_seu_cnt_plain_n_14_ _1509_ _1548_ _1549_ VDD VSS / sg13g2_a21oi_1
X_4055_ _1550_ _1514_ _1515_ _1462_ VDD VSS / sg13g2_a21oi_1
X_4056_ u_core_u_seu_cnt_plain_n_15_ net78 _1550_ VDD VSS / sg13g2_nor2_1
X_4057_ u_core_u_seu_fill_cnt_n_0_ net97 _0895_ _0914_ VDD VSS / sg13g2_nor3_1
X_4058_ _1551_ _0894_ _0896_ _0897_ VDD VSS / sg13g2_nor3_1
X_4059_ u_core_u_seu_fill_cnt_n_1_ net96 _0899_ _1551_ VDD VSS / sg13g2_nor3_1
X_4060_ _1552_ _0891_ _1551_ VDD VSS / sg13g2_and2_1
X_4061_ _1553_ _0891_ _1551_ VDD VSS / sg13g2_nor2_1
X_4062_ u_core_u_seu_fill_cnt_n_2_ net97 _1552_ _1553_ VDD VSS / sg13g2_nor3_1
X_4063_ _1554_ _0902_ _1552_ VDD VSS / sg13g2_and2_1
X_4064_ _1555_ _0902_ _1552_ VDD VSS / sg13g2_nor2_1
X_4065_ u_core_u_seu_fill_cnt_n_3_ net96 _1554_ _1555_ VDD VSS / sg13g2_nor3_1
X_4066_ _1556_ _0885_ _1554_ VDD VSS / sg13g2_nor2_1
X_4067_ _1557_ _0885_ _1554_ VDD VSS / sg13g2_nand2_1
X_4068_ _1558_ _1557_ VDD VSS / sg13g2_inv_1
X_4069_ u_core_u_seu_fill_cnt_n_4_ net96 _1556_ _1558_ VDD VSS / sg13g2_nor3_1
X_4070_ _1559_ _0875_ _1557_ VDD VSS / sg13g2_or2_1
X_4071_ _1560_ net96 _1559_ VDD VSS / sg13g2_nand2b_1
X_4072_ u_core_u_seu_fill_cnt_n_5_ _0875_ _1557_ _1560_ VDD VSS / sg13g2_a21oi_1
X_4073_ _1561_ _0882_ _1559_ VDD VSS / sg13g2_nor2_1
X_4074_ _1562_ _0882_ _1559_ net96 VDD VSS / sg13g2_a21oi_1
X_4075_ u_core_u_seu_fill_cnt_n_6_ _1561_ _1562_ VDD VSS / sg13g2_nor2b_1
X_4076_ _1563_ _0878_ _1561_ VDD VSS / sg13g2_nor2_1
X_4077_ _1564_ _0877_ _0882_ _1559_ VDD VSS / sg13g2_nor3_1
X_4078_ u_core_u_seu_fill_cnt_n_7_ net96 _1563_ _1564_ VDD VSS / sg13g2_nor3_1
X_4079_ _1565_ _0872_ _1564_ VDD VSS / sg13g2_nor2_1
X_4080_ _1566_ _0872_ _1564_ VDD VSS / sg13g2_and2_1
X_4081_ u_core_u_seu_fill_cnt_n_8_ net96 _1565_ _1566_ VDD VSS / sg13g2_nor3_1
X_4082_ _1567_ _0905_ _1566_ VDD VSS / sg13g2_nor2_1
X_4083_ _1568_ _0905_ _1566_ VDD VSS / sg13g2_and2_1
X_4084_ u_core_u_seu_fill_cnt_n_9_ net97 _1567_ _1568_ VDD VSS / sg13g2_nor3_1
X_4085_ _1569_ _0888_ _1568_ VDD VSS / sg13g2_xnor2_1
X_4086_ u_core_u_seu_fill_cnt_n_10_ net97 _1569_ VDD VSS / sg13g2_nor2_1
X_4087_ _1570_ net345 net346 VDD VSS / sg13g2_nor2_1
X_4088_ _1571_ net344 u_core_u_trip_soft_cnt_18_ VDD VSS / sg13g2_or2_1
X_4089_ _1572_ u_core_u_trip_soft_cnt_13_ u_core_u_trip_soft_cnt_12_ VDD VSS / sg13g2_nor2_1
X_4090_ _1573_ u_core_u_trip_soft_cnt_7_ u_core_u_trip_soft_cnt_6_ u_core_u_trip_soft_cnt_15_ u_core_u_trip_soft_cnt_14_ VDD VSS / sg13g2_nor4_1
X_4091_ _1574_ _0510_ _0511_ _1572_ _1573_ VDD VSS / sg13g2_and4_1
X_4092_ _1575_ u_core_u_trip_soft_cnt_3_ u_core_u_trip_soft_cnt_2_ u_core_u_trip_soft_cnt_5_ u_core_u_trip_soft_cnt_4_ VDD VSS / sg13g2_nor4_1
X_4093_ _1576_ u_core_u_trip_soft_cnt_17_ u_core_u_trip_soft_cnt_16_ u_core_u_trip_soft_cnt_1_ u_core_u_trip_soft_cnt_0_ VDD VSS / sg13g2_nor4_1
X_4094_ _1577_ u_core_u_trip_soft_cnt_21_ net343 net344 u_core_u_trip_soft_cnt_18_ VDD VSS / sg13g2_nor4_1
X_4095_ _1578_ u_core_u_trip_soft_cnt_23_ u_core_u_trip_soft_cnt_22_ net345 net346 VDD VSS / sg13g2_nor4_1
X_4096_ _1579_ _1575_ _1576_ _1577_ _1578_ VDD VSS / sg13g2_and4_1
X_4097_ _1580_ _1574_ _1579_ VDD VSS / sg13g2_and2_1
X_4098_ _1581_ _0378_ _0555_ _1574_ _1579_ _0553_ VDD VSS / sg13g2_a221oi_1
X_4099_ _1582_ _0556_ _1581_ VDD VSS / sg13g2_nand2_1
X_4100_ _1583_ u_core_dac_soft_code_2_ _1582_ VDD VSS / sg13g2_nor2_1
X_4101_ _1584_ _0031_ _0554_ _0556_ _1581_ VDD VSS / sg13g2_and4_1
X_4102_ _1585_ _0032_ _1584_ VDD VSS / sg13g2_nand2_1
X_4103_ _1586_ u_core_dac_soft_code_5_ _1584_ _0032_ VDD VSS / sg13g2_nand3b_1
X_4104_ _1587_ u_core_dac_soft_code_6_ _1586_ VDD VSS / sg13g2_and2_1
X_4105_ _1588_ u_core_dac_soft_code_6_ _1586_ VDD VSS / sg13g2_nor2_1
X_4106_ _1589_ _0033_ u_core_dac_soft_code_6_ _1586_ VDD VSS / sg13g2_nor3_1
X_4107_ _1590_ _1587_ _1589_ u_core_sense_ofs_6_ VDD VSS / sg13g2_o21ai_1
X_4108_ _1591_ u_core_sense_ofs_6_ _1587_ _1589_ VDD VSS / sg13g2_nor3_1
X_4109_ _1592_ u_core_sense_ofs_6_ _1587_ _1589_ VDD VSS / sg13g2_or3_1
X_4110_ _1593_ _1590_ _1592_ VDD VSS / sg13g2_and2_1
X_4111_ _1594_ _0375_ u_core_dac_soft_code_6_ u_core_dac_soft_code_5_ VDD VSS / sg13g2_nor3_1
X_4112_ _1595_ _1586_ _1594_ VDD VSS / sg13g2_nor2_1
X_4113_ _1596_ u_core_dac_soft_code_5_ _1585_ _1595_ VDD VSS / sg13g2_a21oi_1
X_4114_ _1597_ _1596_ u_core_sense_ofs_5_ VDD VSS / sg13g2_nor2b_1
X_4115_ _1598_ u_core_sense_ofs_5_ _1596_ VDD VSS / sg13g2_nand2b_1
X_4116_ _1599_ _1585_ _1594_ VDD VSS / sg13g2_nor2_1
X_4117_ _1600_ _0032_ _1584_ VDD VSS / sg13g2_nor2_1
X_4118_ _1601_ _1599_ _1600_ VDD VSS / sg13g2_nor2_1
X_4119_ _1602_ _1601_ u_core_sense_ofs_4_ VDD VSS / sg13g2_nor2b_1
X_4120_ _1603_ _0031_ _1583_ VDD VSS / sg13g2_nor2_1
X_4121_ _1604_ _0032_ _1594_ VDD VSS / sg13g2_and2_1
X_4122_ _1605_ _1604_ _1584_ VDD VSS / sg13g2_nor2b_1
X_4123_ _1606_ _1603_ _1605_ u_core_sense_ofs_3_ VDD VSS / sg13g2_o21ai_1
X_4124_ _1607_ _1606_ VDD VSS / sg13g2_inv_1
X_4125_ _1608_ u_core_sense_ofs_3_ _1603_ _1605_ VDD VSS / sg13g2_nor3_1
X_4126_ _1609_ _1584_ _1604_ VDD VSS / sg13g2_nand2_1
X_4127_ _1610_ u_core_dac_soft_code_2_ _1582_ VDD VSS / sg13g2_xnor2_1
X_4128_ _1611_ u_core_sense_ofs_2_ _1609_ _1610_ VDD VSS / sg13g2_nand3_1
X_4129_ _1612_ _1581_ u_core_dac_soft_code_1_ VDD VSS / sg13g2_nand2b_1
X_4130_ _1613_ _1584_ _1604_ _1612_ _1582_ VDD VSS / sg13g2_a22oi_1
X_4131_ _1614_ u_core_sense_ofs_1_ _1613_ VDD VSS / sg13g2_nand2_1
X_4132_ _1615_ _0553_ u_core_hyst_2 _1580_ VDD VSS / sg13g2_nor3_1
X_4133_ _1616_ _0030_ _1615_ VDD VSS / sg13g2_xnor2_1
X_4134_ _1617_ u_core_sense_ofs_0_ _1609_ _1616_ VDD VSS / sg13g2_nand3_1
X_4135_ _1618_ u_core_sense_ofs_1_ _1613_ VDD VSS / sg13g2_xnor2_1
X_4136_ _1619_ _1617_ _1618_ _1614_ VDD VSS / sg13g2_o21ai_1
X_4137_ _1620_ _1609_ _1610_ u_core_sense_ofs_2_ VDD VSS / sg13g2_a21o_1
X_4138_ _1621_ _1611_ _1620_ VDD VSS / sg13g2_nand2_1
X_4139_ _1622_ _1621_ _1619_ VDD VSS / sg13g2_nand2b_1
X_4140_ _1623_ _1611_ _1622_ VDD VSS / sg13g2_nand2_1
X_4141_ _1624_ _1606_ _1611_ VDD VSS / sg13g2_and2_1
X_4142_ _1625_ _1622_ _1624_ _1608_ VDD VSS / sg13g2_a21oi_1
X_4143_ _1626_ u_core_sense_ofs_4_ _1601_ VDD VSS / sg13g2_xnor2_1
X_4144_ _1627_ _1625_ _1626_ _1602_ VDD VSS / sg13g2_a21oi_1
X_4145_ _1628_ u_core_sense_ofs_5_ _1596_ VDD VSS / sg13g2_xnor2_1
X_4146_ _1629_ _1626_ _1628_ VDD VSS / sg13g2_and2_1
X_4147_ _1630_ _1598_ _1602_ _1625_ _1629_ _1597_ VDD VSS / sg13g2_a221oi_1
X_4148_ _1631_ _1591_ _1630_ _1590_ VDD VSS / sg13g2_o21ai_1
X_4149_ _1632_ _0033_ u_core_sense_ofs_7_ _1588_ VDD VSS / sg13g2_nor3_1
X_4150_ _1633_ _1631_ _1632_ VDD VSS / sg13g2_nand2_1
X_4151_ _1634_ _0033_ _1588_ u_core_sense_ofs_7_ VDD VSS / sg13g2_o21ai_1
X_4152_ _1635_ _1631_ _1634_ VDD VSS / sg13g2_nor2_1
X_4153_ _1636_ _1609_ _1616_ u_core_sense_ofs_0_ VDD VSS / sg13g2_a21o_1
X_4154_ _1637_ _1617_ _1636_ VDD VSS / sg13g2_nand2_1
X_4155_ net19 _1635_ _1637_ _1633_ VDD VSS / sg13g2_o21ai_1
X_4156_ _1638_ _1617_ _1618_ VDD VSS / sg13g2_xnor2_1
X_4157_ net20 _1635_ _1638_ _1633_ VDD VSS / sg13g2_o21ai_1
X_4158_ _1639_ _1619_ _1621_ VDD VSS / sg13g2_xor2_1
X_4159_ net21 _1635_ _1639_ _1633_ VDD VSS / sg13g2_o21ai_1
X_4160_ _1640_ _1607_ _1608_ VDD VSS / sg13g2_nor2_1
X_4161_ _1641_ _1623_ _1640_ VDD VSS / sg13g2_xnor2_1
X_4162_ net22 _1635_ _1641_ _1633_ VDD VSS / sg13g2_o21ai_1
X_4163_ _1642_ _1625_ _1626_ VDD VSS / sg13g2_xnor2_1
X_4164_ net23 _1633_ _1642_ _1635_ VDD VSS / sg13g2_a21oi_1
X_4165_ _1643_ _1627_ _1628_ VDD VSS / sg13g2_xnor2_1
X_4166_ _1644_ _1643_ VDD VSS / sg13g2_inv_1
X_4167_ net24 _1635_ _1644_ _1633_ VDD VSS / sg13g2_o21ai_1
X_4168_ _1645_ _1593_ _1630_ VDD VSS / sg13g2_xor2_1
X_4169_ net25 _1635_ _1645_ _1633_ VDD VSS / sg13g2_o21ai_1
X_4170_ _1646_ _1631_ _1632_ _1634_ VDD VSS / sg13g2_o21ai_1
X_4171_ net26 _1646_ VDD VSS / sg13g2_inv_1
X_4172_ _1647_ _0039_ u_core_sense_ofs_6_ VDD VSS / sg13g2_nor2b_1
X_4173_ _1648_ _0039_ u_core_sense_ofs_6_ VDD VSS / sg13g2_xnor2_1
X_4174_ _1649_ _0372_ u_core_sense_ofs_5_ VDD VSS / sg13g2_nand2_1
X_4175_ _1650_ _0038_ u_core_sense_ofs_5_ VDD VSS / sg13g2_xor2_1
X_4176_ _1651_ _0037_ u_core_sense_ofs_4_ VDD VSS / sg13g2_nor2b_1
X_4177_ _1652_ _0037_ u_core_sense_ofs_4_ VDD VSS / sg13g2_xnor2_1
X_4178_ _1653_ _0036_ u_core_sense_ofs_3_ VDD VSS / sg13g2_nand2b_1
X_4179_ _1654_ _0036_ u_core_sense_ofs_3_ VDD VSS / sg13g2_xor2_1
X_4180_ _1655_ _0035_ u_core_sense_ofs_2_ VDD VSS / sg13g2_nor2b_1
X_4181_ _1656_ _0035_ u_core_sense_ofs_2_ VDD VSS / sg13g2_xnor2_1
X_4182_ _1657_ _0374_ u_core_sense_ofs_1_ VDD VSS / sg13g2_nand2_1
X_4183_ _1658_ u_core_sense_ofs_0_ u_core_dac_hard_code_0_ VDD VSS / sg13g2_nand2_1
X_4184_ _1659_ _0034_ u_core_sense_ofs_1_ VDD VSS / sg13g2_xor2_1
X_4185_ _1660_ _1658_ _1659_ _1657_ VDD VSS / sg13g2_o21ai_1
X_4186_ _1661_ _1656_ _1660_ _1655_ VDD VSS / sg13g2_a21oi_1
X_4187_ _1662_ _1654_ _1661_ _1653_ VDD VSS / sg13g2_o21ai_1
X_4188_ _1663_ _1652_ _1662_ _1651_ VDD VSS / sg13g2_a21oi_1
X_4189_ _1664_ _1650_ _1663_ _1649_ VDD VSS / sg13g2_o21ai_1
X_4190_ _1665_ _1648_ _1664_ _1647_ VDD VSS / sg13g2_a21oi_1
X_4191_ _1666_ _0040_ u_core_sense_ofs_7_ _1665_ VDD VSS / sg13g2_and3_1
X_4192_ _1667_ _0040_ u_core_sense_ofs_7_ _1665_ VDD VSS / sg13g2_or3_1
X_4193_ _1668_ u_core_sense_ofs_0_ u_core_dac_hard_code_0_ VDD VSS / sg13g2_xnor2_1
X_4194_ net11 _1667_ _1668_ _1666_ VDD VSS / sg13g2_a21oi_1
X_4195_ _1669_ _1658_ _1659_ VDD VSS / sg13g2_xnor2_1
X_4196_ net12 _1667_ _1669_ _1666_ VDD VSS / sg13g2_a21oi_1
X_4197_ _1670_ _1656_ _1660_ VDD VSS / sg13g2_xnor2_1
X_4198_ net13 _1667_ _1670_ _1666_ VDD VSS / sg13g2_a21oi_1
X_4199_ _1671_ _1654_ _1661_ VDD VSS / sg13g2_xnor2_1
X_4200_ net14 _1667_ _1671_ _1666_ VDD VSS / sg13g2_a21oi_1
X_4201_ _1672_ _1652_ _1662_ VDD VSS / sg13g2_xnor2_1
X_4202_ net15 _1667_ _1672_ _1666_ VDD VSS / sg13g2_a21oi_1
X_4203_ _1673_ _1650_ _1663_ VDD VSS / sg13g2_xnor2_1
X_4204_ net16 _1667_ _1673_ _1666_ VDD VSS / sg13g2_a21oi_1
X_4205_ _1674_ _1648_ _1664_ VDD VSS / sg13g2_xnor2_1
X_4206_ net17 _1667_ _1674_ _1666_ VDD VSS / sg13g2_a21oi_1
X_4207_ _1675_ _0040_ u_core_sense_ofs_7_ _1665_ VDD VSS / sg13g2_a21o_1
X_4208_ net18 _0040_ u_core_sense_ofs_7_ _1675_ VDD VSS / sg13g2_o21ai_1
X_4209_ _1676_ u_core_inrush_7_ _0485_ VDD VSS / sg13g2_nor2_1
X_4210_ _1677_ _0369_ _0489_ VDD VSS / sg13g2_nor2_1
X_4211_ _1678_ u_core_inrush_1_ u_core_u_trip_inrush_cnt_10_ VDD VSS / sg13g2_nand2b_1
X_4212_ _1679_ u_core_u_trip_inrush_cnt_9_ u_core_inrush_0_ VDD VSS / sg13g2_nor2b_1
X_4213_ _1680_ u_core_u_trip_inrush_cnt_10_ u_core_inrush_1_ VDD VSS / sg13g2_nor2b_1
X_4214_ _1681_ u_core_u_trip_inrush_cnt_12_ u_core_inrush_3_ VDD VSS / sg13g2_nand2b_1
X_4215_ _1682_ _0369_ _0489_ _1678_ _1679_ _1680_ VDD VSS / sg13g2_a221oi_1
X_4216_ _1683_ _1677_ _1682_ _1681_ VDD VSS / sg13g2_o21ai_1
X_4217_ _1684_ _0043_ u_core_u_trip_inrush_cnt_13_ _0488_ u_core_u_trip_inrush_cnt_12_ VDD VSS / sg13g2_a22oi_1
X_4218_ _1685_ u_core_u_trip_inrush_cnt_14_ u_core_inrush_5_ VDD VSS / sg13g2_nand2b_1
X_4219_ _1686_ _0043_ u_core_u_trip_inrush_cnt_13_ _1685_ VDD VSS / sg13g2_o21ai_1
X_4220_ _1687_ _1683_ _1684_ _1686_ VDD VSS / sg13g2_a21o_1
X_4221_ _1688_ _0486_ u_core_u_trip_inrush_cnt_15_ _0487_ u_core_u_trip_inrush_cnt_14_ VDD VSS / sg13g2_a22oi_1
X_4222_ _1689_ _0486_ u_core_u_trip_inrush_cnt_15_ VDD VSS / sg13g2_nor2_1
X_4223_ _1690_ u_core_inrush_7_ _0485_ _1687_ _1688_ _1689_ VDD VSS / sg13g2_a221oi_1
X_4224_ _1691_ _1676_ _1690_ VDD VSS / sg13g2_nor2_1
X_4225_ _1692_ net38 _1691_ VDD VSS / sg13g2_nor2_1
X_4226_ _1693_ _1676_ _1690_ net28 VDD VSS / sg13g2_o21ai_1
X_4227_ _1694_ _0361_ _1692_ VDD VSS / sg13g2_nand2_1
X_4228_ _1695_ _0361_ net122 _1692_ VDD VSS / sg13g2_nand3_1
X_4229_ _0009_ u_core_u_trip_decay_pre_0_ _1695_ VDD VSS / sg13g2_nor2_1
X_4230_ _1696_ u_core_u_trip_decay_pre_1_ u_core_u_trip_decay_pre_0_ VDD VSS / sg13g2_and2_1
X_4231_ _1697_ u_core_u_trip_decay_pre_1_ u_core_u_trip_decay_pre_0_ VDD VSS / sg13g2_nor2_1
X_4232_ _0010_ _1695_ _1696_ _1697_ VDD VSS / sg13g2_nor3_1
X_4233_ _1698_ u_core_u_trip_decay_pre_2_ _1696_ VDD VSS / sg13g2_xnor2_1
X_4234_ _0011_ _1695_ _1698_ VDD VSS / sg13g2_nor2_1
X_4235_ _1699_ u_core_u_trip_decay_pre_2_ u_core_u_trip_decay_pre_3_ _1696_ VDD VSS / sg13g2_and3_1
X_4236_ _1700_ u_core_u_trip_decay_pre_2_ _1696_ u_core_u_trip_decay_pre_3_ VDD VSS / sg13g2_a21oi_1
X_4237_ _0012_ _1695_ _1699_ _1700_ VDD VSS / sg13g2_nor3_1
X_4238_ _1701_ u_core_u_trip_decay_pre_4_ _1699_ VDD VSS / sg13g2_and2_1
X_4239_ _1702_ u_core_u_trip_decay_pre_4_ _1699_ VDD VSS / sg13g2_nor2_1
X_4240_ _0013_ _1695_ _1701_ _1702_ VDD VSS / sg13g2_nor3_1
X_4241_ _1703_ u_core_u_trip_decay_pre_5_ _1701_ VDD VSS / sg13g2_xnor2_1
X_4242_ _0014_ _1695_ _1703_ VDD VSS / sg13g2_nor2_1
X_4243_ _1704_ u_core_u_serial_tx_6_ _0562_ _0564_ u_core_u_serial_rd_hold_7_ VDD VSS / sg13g2_a22oi_1
X_4244_ _0007_ _1704_ VDD VSS / sg13g2_inv_1
X_4245_ _0001_ u_core_u_serial_bit_cnt_0_ u_core_u_serial_bit_cnt_1_ VDD VSS / sg13g2_xor2_1
X_4246_ _1705_ u_core_u_serial_bit_cnt_0_ u_core_u_serial_bit_cnt_1_ u_core_u_serial_bit_cnt_2_ VDD VSS / sg13g2_nand3_1
X_4247_ _1706_ u_core_u_serial_bit_cnt_0_ u_core_u_serial_bit_cnt_1_ u_core_u_serial_bit_cnt_2_ VDD VSS / sg13g2_a21o_1
X_4248_ _0002_ _1705_ _1706_ VDD VSS / sg13g2_and2_1
X_4249_ _1707_ u_core_u_serial_bit_cnt_3_ u_core_u_serial_bit_cnt_4_ _1705_ VDD VSS / sg13g2_nor3_1
X_4250_ _0003_ u_core_u_serial_bit_cnt_3_ _1705_ net121 VDD VSS / sg13g2_a21o_1
X_4251_ _1708_ _0482_ u_core_u_serial_bit_cnt_4_ _1705_ VDD VSS / sg13g2_nor3_1
X_4252_ _1709_ u_core_u_serial_rd_frame _1708_ VDD VSS / sg13g2_nor2b_1
X_4253_ _1710_ u_core_u_serial_bit_cnt_4_ _1705_ _1708_ VDD VSS / sg13g2_a21oi_1
X_4254_ _0004_ net120 _1710_ VDD VSS / sg13g2_nor2_1
X_4255_ _1711_ u_core_u_regfile_osc_pre_11_ u_core_u_regfile_osc_div_1_ VDD VSS / sg13g2_nand2b_1
X_4256_ _1712_ u_core_u_regfile_osc_pre_9_ u_core_u_regfile_osc_div_1_ _1711_ VDD VSS / sg13g2_o21ai_1
X_4257_ _1713_ u_core_u_regfile_osc_pre_13_ u_core_u_regfile_osc_div_2_ _0481_ VDD VSS / sg13g2_nand3_1
X_4258_ _1714_ u_core_u_regfile_osc_div_2_ _1712_ _1713_ VDD VSS / sg13g2_o21ai_1
X_4259_ _1715_ u_core_u_regfile_osc_pre_8_ _0481_ VDD VSS / sg13g2_nand2_1
X_4260_ _1716_ u_core_u_regfile_osc_pre_10_ u_core_u_regfile_osc_div_1_ u_core_u_regfile_osc_div_2_ VDD VSS / sg13g2_a21oi_1
X_4261_ _1717_ u_core_u_regfile_osc_pre_14_ _0481_ u_core_u_regfile_osc_pre_12_ VDD VSS / sg13g2_o21ai_1
X_4262_ _1718_ u_core_u_regfile_osc_pre_14_ u_core_u_regfile_osc_div_1_ _0480_ VDD VSS / sg13g2_a21oi_1
X_4263_ _1719_ _1715_ _1716_ _1717_ _1718_ VDD VSS / sg13g2_a22oi_1
X_4264_ net8 _1719_ _1714_ u_core_u_regfile_osc_div_0_ VDD VSS / sg13g2_mux2_1
X_4265_ _1720_ net366 net364 VDD VSS / sg13g2_nand2_1
X_4266_ _1721_ _0476_ u_core_rd_addr_5_ u_core_rd_addr_6_ VDD VSS / sg13g2_nor3_1
X_4267_ _1722_ _0476_ u_core_rd_addr_5_ u_core_rd_addr_6_ VDD VSS / sg13g2_or3_1
X_4268_ _1723_ net363 net362 VDD VSS / sg13g2_nor2b_1
X_4269_ _1724_ net363 net362 VDD VSS / sg13g2_nand2b_1
X_4270_ _1725_ _1721_ _1723_ VDD VSS / sg13g2_nand2_1
X_4271_ _1726_ _1720_ _1725_ VDD VSS / sg13g2_nor2_1
X_4272_ _1727_ net362 net363 VDD VSS / sg13g2_nor2_1
X_4273_ _1728_ _0475_ net364 VDD VSS / sg13g2_nor2_1
X_4274_ _1729_ net364 net366 VDD VSS / sg13g2_nand2b_1
X_4275_ _1730_ net362 net363 _1722_ _1729_ VDD VSS / sg13g2_nor4_1
X_4276_ _1731_ net362 net363 VDD VSS / sg13g2_nor2b_1
X_4277_ _1732_ net362 net363 VDD VSS / sg13g2_nand2b_1
X_4278_ _1733_ u_core_rd_addr_4_ u_core_rd_addr_6_ VDD VSS / sg13g2_nor2_1
X_4279_ _1734_ u_core_rd_addr_5_ _1733_ VDD VSS / sg13g2_and2_1
X_4280_ _1735_ net366 net364 VDD VSS / sg13g2_nor2_1
X_4281_ _1736_ _1734_ _1735_ VDD VSS / sg13g2_nand2_1
X_4282_ _1737_ _1732_ _1736_ VDD VSS / sg13g2_nor2_1
X_4283_ _1738_ net362 net363 VDD VSS / sg13g2_nand2_1
X_4284_ _1739_ _1722_ _1729_ _1738_ VDD VSS / sg13g2_nor3_1
X_4285_ _1740_ net92 net114 VDD VSS / sg13g2_nor2_1
X_4286_ _1741_ _1722_ _1729_ _1738_ VDD VSS / sg13g2_nor3_1
X_4287_ _1742_ u_core_rd_addr_3_ net363 _1721_ _1728_ VDD VSS / sg13g2_nand4_1
X_4288_ _1743_ net93 net115 net91 net113 VDD VSS / sg13g2_nor4_1
X_4289_ _1744_ net72 VDD VSS / sg13g2_inv_1
X_4290_ _1745_ u_core_rd_addr_4_ u_core_rd_addr_5_ u_core_rd_addr_6_ VDD VSS / sg13g2_nor3_1
X_4291_ _1746_ u_core_rd_addr_5_ _1733_ VDD VSS / sg13g2_nand2b_1
X_4292_ _1747_ _1738_ _1745_ VDD VSS / sg13g2_nand2b_1
X_4293_ _1748_ _1720_ _1747_ VDD VSS / sg13g2_nor2_1
X_4294_ _1749_ _1744_ net112 net334 VDD VSS / sg13g2_o21ai_1
X_4295_ _1750_ _1474_ net94 net92 u_core_u_regfile_osc_cnt_8_ VDD VSS / sg13g2_a22oi_1
X_4296_ _1751_ u_core_soft_peak_8_ net115 net113 _1411_ VDD VSS / sg13g2_a22oi_1
X_4297_ _1752_ _1750_ _1751_ VDD VSS / sg13g2_nand2_1
X_4298_ _1753_ u_core_trip_cnt_8_ _1743_ _1752_ VDD VSS / sg13g2_a21oi_1
X_4299_ _1754_ u_core_u_regfile_hi_hold_0_ net66 VDD VSS / sg13g2_nand2_1
X_4300_ _0066_ net66 _1753_ _1754_ VDD VSS / sg13g2_o21ai_1
X_4301_ _1755_ _1471_ net93 net91 u_core_u_regfile_osc_cnt_9_ VDD VSS / sg13g2_a22oi_1
X_4302_ _1756_ u_core_soft_peak_9_ net115 net113 _1400_ VDD VSS / sg13g2_a22oi_1
X_4303_ _1757_ _1755_ _1756_ VDD VSS / sg13g2_nand2_1
X_4304_ _1758_ u_core_trip_cnt_9_ net72 _1757_ VDD VSS / sg13g2_a21oi_1
X_4305_ _1759_ u_core_u_regfile_hi_hold_1_ net67 VDD VSS / sg13g2_nand2_1
X_4306_ _0067_ net67 _1758_ _1759_ VDD VSS / sg13g2_o21ai_1
X_4307_ _1760_ u_core_u_regfile_osc_cnt_10_ net91 net113 _1397_ VDD VSS / sg13g2_a22oi_1
X_4308_ _1761_ _1465_ net93 net115 u_core_soft_peak_10_ VDD VSS / sg13g2_a22oi_1
X_4309_ _1762_ _1760_ _1761_ VDD VSS / sg13g2_nand2_1
X_4310_ _1763_ u_core_trip_cnt_10_ net72 _1762_ VDD VSS / sg13g2_a21oi_1
X_4311_ _1764_ u_core_u_regfile_hi_hold_2_ net67 VDD VSS / sg13g2_nand2_1
X_4312_ _0068_ net67 _1763_ _1764_ VDD VSS / sg13g2_o21ai_1
X_4313_ _1765_ u_core_u_regfile_osc_cnt_11_ net91 net113 _1403_ VDD VSS / sg13g2_a22oi_1
X_4314_ _1766_ _1468_ net93 net115 u_core_soft_peak_11_ VDD VSS / sg13g2_a22oi_1
X_4315_ _1767_ _1765_ _1766_ VDD VSS / sg13g2_nand2_1
X_4316_ _1768_ u_core_trip_cnt_11_ net72 _1767_ VDD VSS / sg13g2_a21oi_1
X_4317_ _1769_ u_core_u_regfile_hi_hold_3_ net67 VDD VSS / sg13g2_nand2_1
X_4318_ _0069_ net67 _1768_ _1769_ VDD VSS / sg13g2_o21ai_1
X_4319_ _1770_ u_core_u_regfile_osc_cnt_12_ net91 net113 _1414_ VDD VSS / sg13g2_a22oi_1
X_4320_ _1771_ _1480_ net93 net115 u_core_soft_peak_12_ VDD VSS / sg13g2_a22oi_1
X_4321_ _1772_ _1770_ _1771_ VDD VSS / sg13g2_nand2_1
X_4322_ _1773_ u_core_trip_cnt_12_ net72 _1772_ VDD VSS / sg13g2_a21oi_1
X_4323_ _1774_ u_core_u_regfile_hi_hold_4_ net66 VDD VSS / sg13g2_nand2_1
X_4324_ _0070_ net66 _1773_ _1774_ VDD VSS / sg13g2_o21ai_1
X_4325_ _1775_ u_core_u_regfile_osc_cnt_13_ net91 net113 _1418_ VDD VSS / sg13g2_a22oi_1
X_4326_ _1776_ _1512_ net93 net117 u_core_soft_peak_13_ VDD VSS / sg13g2_a22oi_1
X_4327_ _1777_ _1775_ _1776_ VDD VSS / sg13g2_nand2_1
X_4328_ _1778_ u_core_trip_cnt_13_ net72 _1777_ VDD VSS / sg13g2_a21oi_1
X_4329_ _1779_ u_core_u_regfile_hi_hold_5_ net66 VDD VSS / sg13g2_nand2_1
X_4330_ _0071_ net66 _1778_ _1779_ VDD VSS / sg13g2_o21ai_1
X_4331_ _1780_ u_core_soft_peak_14_ net115 net91 u_core_u_regfile_osc_cnt_14_ VDD VSS / sg13g2_a22oi_1
X_4332_ _1781_ _1420_ _1742_ _1780_ VDD VSS / sg13g2_o21ai_1
X_4333_ _1782_ _1509_ net93 net72 u_core_trip_cnt_14_ _1781_ VDD VSS / sg13g2_a221oi_1
X_4334_ _1783_ u_core_u_regfile_hi_hold_6_ _1749_ VDD VSS / sg13g2_nand2_1
X_4335_ _0072_ net67 _1782_ _1783_ VDD VSS / sg13g2_o21ai_1
X_4336_ _1784_ _1462_ net93 net91 u_core_u_regfile_osc_cnt_15_ VDD VSS / sg13g2_a22oi_1
X_4337_ _1785_ u_core_soft_peak_15_ net115 net113 _1424_ VDD VSS / sg13g2_a22oi_1
X_4338_ _1786_ _1784_ _1785_ VDD VSS / sg13g2_nand2_1
X_4339_ _1787_ u_core_trip_cnt_15_ net72 _1786_ VDD VSS / sg13g2_a21oi_1
X_4340_ _1788_ u_core_u_regfile_hi_hold_7_ net66 VDD VSS / sg13g2_nand2_1
X_4341_ _0073_ net66 _1787_ _1788_ VDD VSS / sg13g2_o21ai_1
X_4342_ _1789_ u_core_u_regfile_osc_div_0_ _1717_ VDD VSS / sg13g2_nand2_1
X_4343_ _1790_ u_core_u_regfile_osc_pre_12_ u_core_u_regfile_osc_pre_13_ _0481_ VDD VSS / sg13g2_a21o_1
X_4344_ _1791_ u_core_u_regfile_osc_pre_11_ _0842_ _1789_ _1790_ VDD VSS / sg13g2_nand4_1
X_4345_ _1792_ u_core_u_regfile_osc_pre_8_ u_core_u_regfile_osc_pre_9_ _0481_ VDD VSS / sg13g2_a21oi_1
X_4346_ _1793_ u_core_u_regfile_osc_div_0_ _1792_ _1715_ VDD VSS / sg13g2_o21ai_1
X_4347_ _1794_ _0842_ _1793_ _0839_ VDD VSS / sg13g2_o21ai_1
X_4348_ _1795_ u_core_u_regfile_osc_div_2_ _1791_ _1794_ VDD VSS / sg13g2_a21oi_1
X_4349_ _1796_ u_core_u_regfile_osc_cnt_0_ _1795_ VDD VSS / sg13g2_and2_1
X_4350_ _1797_ u_core_u_regfile_osc_cnt_0_ _1795_ VDD VSS / sg13g2_nor2_1
X_4351_ _1798_ u_core_u_regfile_wr_addr_3_ net367 VDD VSS / sg13g2_nand2_1
X_4352_ _1799_ u_core_u_regfile_wr_addr_4_ u_core_u_regfile_wr_addr_6_ VDD VSS / sg13g2_nor2_1
X_4353_ _1800_ u_core_u_regfile_wr_addr_4_ u_core_u_regfile_wr_addr_5_ u_core_u_regfile_wr_addr_6_ VDD VSS / sg13g2_nor3_1
X_4354_ _1801_ u_core_u_regfile_wr_addr_5_ _1799_ VDD VSS / sg13g2_nand2b_1
X_4355_ _1802_ u_core_u_regfile_wr_addr_0_ u_core_u_regfile_wr_en VDD VSS / sg13g2_nor2b_1
X_4356_ _1803_ _0477_ _1802_ VDD VSS / sg13g2_and2_1
X_4357_ _1804_ _0477_ _1802_ VDD VSS / sg13g2_nand2_1
X_4358_ _1805_ _1798_ _1801_ _1804_ VDD VSS / sg13g2_nor3_1
X_4359_ _1806_ net353 _1805_ VDD VSS / sg13g2_and2_1
X_4360_ _1807_ _0478_ _1801_ VDD VSS / sg13g2_nor2_1
X_4361_ _1808_ _1798_ _1801_ _1804_ VDD VSS / sg13g2_nor3_1
X_4362_ _1809_ net353 _1808_ VDD VSS / sg13g2_and2_1
X_4363_ _1810_ net353 _1808_ VDD VSS / sg13g2_nand2_1
X_4364_ _0074_ _1796_ _1797_ net90 VDD VSS / sg13g2_nor3_1
X_4365_ _1811_ u_core_u_regfile_osc_cnt_1_ _1796_ _1810_ VDD VSS / sg13g2_o21ai_1
X_4366_ _0075_ u_core_u_regfile_osc_cnt_1_ _1796_ _1811_ VDD VSS / sg13g2_a21oi_1
X_4367_ _1812_ u_core_u_regfile_osc_cnt_1_ _1796_ u_core_u_regfile_osc_cnt_2_ VDD VSS / sg13g2_a21oi_1
X_4368_ _1813_ u_core_u_regfile_osc_cnt_0_ u_core_u_regfile_osc_cnt_1_ u_core_u_regfile_osc_cnt_2_ VDD VSS / sg13g2_nand3_1
X_4369_ _1814_ _1795_ net90 VDD VSS / sg13g2_nor2_1
X_4370_ _1815_ _1813_ _1814_ VDD VSS / sg13g2_nor2_1
X_4371_ _0076_ _1806_ _1812_ _1815_ VDD VSS / sg13g2_nor3_1
X_4372_ _1816_ u_core_u_regfile_osc_cnt_3_ _1815_ VDD VSS / sg13g2_nor2_1
X_4373_ _1817_ u_core_u_regfile_osc_cnt_3_ _1815_ VDD VSS / sg13g2_and2_1
X_4374_ _0077_ _1806_ _1816_ _1817_ VDD VSS / sg13g2_nor3_1
X_4375_ _1818_ u_core_u_regfile_osc_cnt_3_ u_core_u_regfile_osc_cnt_4_ VDD VSS / sg13g2_nand2_1
X_4376_ _1819_ u_core_u_regfile_osc_cnt_4_ _1817_ VDD VSS / sg13g2_xnor2_1
X_4377_ _0078_ _1809_ _1819_ VDD VSS / sg13g2_nor2_1
X_4378_ _1820_ u_core_u_regfile_osc_cnt_4_ _1817_ u_core_u_regfile_osc_cnt_5_ VDD VSS / sg13g2_a21oi_1
X_4379_ _1821_ u_core_u_regfile_osc_cnt_4_ u_core_u_regfile_osc_cnt_5_ _1817_ VDD VSS / sg13g2_and3_1
X_4380_ _0079_ _1809_ _1820_ _1821_ VDD VSS / sg13g2_nor3_1
X_4381_ _1822_ u_core_u_regfile_osc_cnt_6_ _1821_ VDD VSS / sg13g2_nor2_1
X_4382_ _1823_ u_core_u_regfile_osc_cnt_6_ _1821_ VDD VSS / sg13g2_and2_1
X_4383_ _0080_ _1809_ _1822_ _1823_ VDD VSS / sg13g2_nor3_1
X_4384_ _1824_ u_core_u_regfile_osc_cnt_7_ _1823_ _1810_ VDD VSS / sg13g2_o21ai_1
X_4385_ _0081_ u_core_u_regfile_osc_cnt_7_ _1823_ _1824_ VDD VSS / sg13g2_a21oi_1
X_4386_ _1825_ u_core_u_regfile_osc_cnt_7_ _1823_ u_core_u_regfile_osc_cnt_8_ VDD VSS / sg13g2_a21oi_1
X_4387_ _1826_ u_core_u_regfile_osc_cnt_5_ u_core_u_regfile_osc_cnt_6_ u_core_u_regfile_osc_cnt_7_ u_core_u_regfile_osc_cnt_8_ VDD VSS / sg13g2_nand4_1
X_4388_ _1827_ _1813_ _1814_ _1818_ _1826_ VDD VSS / sg13g2_nor4_1
X_4389_ _0082_ net90 _1825_ _1827_ VDD VSS / sg13g2_nor3_1
X_4390_ _1828_ u_core_u_regfile_osc_cnt_9_ _1827_ net90 VDD VSS / sg13g2_a21oi_1
X_4391_ _1829_ u_core_u_regfile_osc_cnt_9_ _1827_ _1828_ VDD VSS / sg13g2_o21ai_1
X_4392_ _0083_ _1829_ VDD VSS / sg13g2_inv_1
X_4393_ _1830_ u_core_u_regfile_osc_cnt_9_ _1827_ u_core_u_regfile_osc_cnt_10_ VDD VSS / sg13g2_a21oi_1
X_4394_ _1831_ u_core_u_regfile_osc_cnt_9_ u_core_u_regfile_osc_cnt_10_ _1827_ VDD VSS / sg13g2_and3_1
X_4395_ _0084_ net90 _1830_ _1831_ VDD VSS / sg13g2_nor3_1
X_4396_ _1832_ u_core_u_regfile_osc_cnt_11_ _1831_ net90 VDD VSS / sg13g2_a21oi_1
X_4397_ _1833_ u_core_u_regfile_osc_cnt_11_ _1831_ _1832_ VDD VSS / sg13g2_o21ai_1
X_4398_ _0085_ _1833_ VDD VSS / sg13g2_inv_1
X_4399_ _1834_ u_core_u_regfile_osc_cnt_11_ _1831_ u_core_u_regfile_osc_cnt_12_ VDD VSS / sg13g2_a21oi_1
X_4400_ _1835_ u_core_u_regfile_osc_cnt_11_ u_core_u_regfile_osc_cnt_12_ _1831_ VDD VSS / sg13g2_and3_1
X_4401_ _0086_ net90 _1834_ _1835_ VDD VSS / sg13g2_nor3_1
X_4402_ _1836_ u_core_u_regfile_osc_cnt_13_ _1835_ net90 VDD VSS / sg13g2_a21oi_1
X_4403_ _1837_ u_core_u_regfile_osc_cnt_13_ _1835_ _1836_ VDD VSS / sg13g2_o21ai_1
X_4404_ _0087_ _1837_ VDD VSS / sg13g2_inv_1
X_4405_ _1838_ u_core_u_regfile_osc_cnt_13_ _1835_ u_core_u_regfile_osc_cnt_14_ VDD VSS / sg13g2_a21oi_1
X_4406_ _1839_ u_core_u_regfile_osc_cnt_9_ u_core_u_regfile_osc_cnt_10_ u_core_u_regfile_osc_cnt_13_ u_core_u_regfile_osc_cnt_14_ VDD VSS / sg13g2_and4_1
X_4407_ _1840_ u_core_u_regfile_osc_cnt_11_ u_core_u_regfile_osc_cnt_12_ _1839_ VDD VSS / sg13g2_nand3_1
X_4408_ _1841_ _1813_ _1818_ _1826_ _1840_ VDD VSS / sg13g2_nor4_1
X_4409_ _1842_ _1795_ _1841_ VDD VSS / sg13g2_and2_1
X_4410_ _0088_ _1809_ _1838_ _1842_ VDD VSS / sg13g2_nor3_1
X_4411_ _1843_ u_core_u_regfile_osc_cnt_15_ _1842_ _1810_ VDD VSS / sg13g2_o21ai_1
X_4412_ _0089_ u_core_u_regfile_osc_cnt_15_ _1842_ _1843_ VDD VSS / sg13g2_a21oi_1
X_4413_ _1844_ u_core_u_regfile_wr_addr_1_ _1802_ VDD VSS / sg13g2_nand2_1
X_4414_ _1845_ u_core_u_regfile_wr_addr_3_ net367 _1801_ _1844_ VDD VSS / sg13g2_nor4_1
X_4415_ _1846_ _0030_ net110 VDD VSS / sg13g2_nor2_1
X_4416_ _0090_ net360 net110 _1846_ VDD VSS / sg13g2_a21oi_1
X_4417_ _1847_ net357 net110 VDD VSS / sg13g2_nand2_1
X_4418_ _0091_ _0556_ net110 _1847_ VDD VSS / sg13g2_o21ai_1
X_4419_ _1848_ net354 net110 VDD VSS / sg13g2_nand2_1
X_4420_ _0092_ _0554_ net110 _1848_ VDD VSS / sg13g2_o21ai_1
X_4421_ _1849_ _0031_ net110 VDD VSS / sg13g2_nor2_1
X_4422_ _0093_ net352 net110 _1849_ VDD VSS / sg13g2_a21oi_1
X_4423_ _1850_ _0032_ net111 VDD VSS / sg13g2_nor2_1
X_4424_ _0094_ net350 net111 _1850_ VDD VSS / sg13g2_a21oi_1
X_4425_ _0095_ u_core_dac_soft_code_5_ net349 net111 VDD VSS / sg13g2_mux2_1
X_4426_ _0096_ u_core_dac_soft_code_6_ net348 net111 VDD VSS / sg13g2_mux2_1
X_4427_ _1851_ _0033_ net111 VDD VSS / sg13g2_nor2_1
X_4428_ _0097_ net347 net111 _1851_ VDD VSS / sg13g2_a21oi_1
X_4429_ _1852_ u_core_u_regfile_wr_addr_0_ u_core_u_regfile_wr_addr_1_ u_core_u_regfile_wr_en VDD VSS / sg13g2_nand3_1
X_4430_ _1853_ u_core_u_regfile_wr_addr_3_ net367 _1801_ _1852_ VDD VSS / sg13g2_nor4_1
X_4431_ _0098_ u_core_dac_hard_code_0_ net360 net108 VDD VSS / sg13g2_mux2_1
X_4432_ _1854_ _0034_ net108 VDD VSS / sg13g2_nor2_1
X_4433_ _0099_ net357 net108 _1854_ VDD VSS / sg13g2_a21oi_1
X_4434_ _1855_ _0035_ net108 VDD VSS / sg13g2_nor2_1
X_4435_ _0100_ net354 net109 _1855_ VDD VSS / sg13g2_a21oi_1
X_4436_ _1856_ _0036_ net109 VDD VSS / sg13g2_nor2_1
X_4437_ _0101_ net352 net109 _1856_ VDD VSS / sg13g2_a21oi_1
X_4438_ _1857_ _0037_ net109 VDD VSS / sg13g2_nor2_1
X_4439_ _0102_ net350 net109 _1857_ VDD VSS / sg13g2_a21oi_1
X_4440_ _1858_ _0038_ net108 VDD VSS / sg13g2_nor2_1
X_4441_ _0103_ net349 net108 _1858_ VDD VSS / sg13g2_a21oi_1
X_4442_ _1859_ _0039_ net109 VDD VSS / sg13g2_nor2_1
X_4443_ _0104_ net348 net109 _1859_ VDD VSS / sg13g2_a21oi_1
X_4444_ _1860_ _0040_ net108 VDD VSS / sg13g2_nor2_1
X_4445_ _0105_ net347 net108 _1860_ VDD VSS / sg13g2_a21oi_1
X_4446_ _1861_ _0478_ net367 _1800_ VDD VSS / sg13g2_nand3_1
X_4447_ _1862_ _1852_ _1861_ VDD VSS / sg13g2_nor2_1
X_4448_ _0106_ u_core_hard_n_0_ net360 net107 VDD VSS / sg13g2_mux2_1
X_4449_ _0107_ u_core_hard_n_1_ net357 net107 VDD VSS / sg13g2_mux2_1
X_4450_ _1863_ _0041_ net107 VDD VSS / sg13g2_nor2_1
X_4451_ _0108_ net354 net107 _1863_ VDD VSS / sg13g2_a21oi_1
X_4452_ _0109_ u_core_hard_n_3_ net352 net107 VDD VSS / sg13g2_mux2_1
X_4453_ _0110_ u_core_hard_n_4_ net351 net107 VDD VSS / sg13g2_mux2_1
X_4454_ _0111_ u_core_hard_n_5_ net349 net107 VDD VSS / sg13g2_mux2_1
X_4455_ _0112_ u_core_hard_n_6_ net348 net107 VDD VSS / sg13g2_mux2_1
X_4456_ _1864_ net347 _1862_ VDD VSS / sg13g2_nand2_1
X_4457_ _0113_ _0492_ _1862_ _1864_ VDD VSS / sg13g2_o21ai_1
X_4458_ _1865_ _0828_ _1800_ VDD VSS / sg13g2_nand2_1
X_4459_ _1866_ _1804_ _1865_ VDD VSS / sg13g2_nor2_1
X_4460_ _0114_ u_core_inrush_0_ net360 net88 VDD VSS / sg13g2_mux2_1
X_4461_ _0115_ u_core_inrush_1_ net357 net88 VDD VSS / sg13g2_mux2_1
X_4462_ _1867_ _0042_ net88 VDD VSS / sg13g2_nor2_1
X_4463_ _0116_ net354 net89 _1867_ VDD VSS / sg13g2_a21oi_1
X_4464_ _1868_ net352 net89 VDD VSS / sg13g2_nand2_1
X_4465_ _0117_ _0488_ net89 _1868_ VDD VSS / sg13g2_o21ai_1
X_4466_ _1869_ _0043_ net89 VDD VSS / sg13g2_nor2_1
X_4467_ _0118_ net351 net89 _1869_ VDD VSS / sg13g2_a21oi_1
X_4468_ _1870_ u_core_u_regfile_wr_data_5_ net88 VDD VSS / sg13g2_nand2_1
X_4469_ _0119_ _0487_ net88 _1870_ VDD VSS / sg13g2_o21ai_1
X_4470_ _1871_ net348 net88 VDD VSS / sg13g2_nand2_1
X_4471_ _0120_ _0486_ net88 _1871_ VDD VSS / sg13g2_o21ai_1
X_4472_ _0121_ u_core_inrush_7_ net347 net88 VDD VSS / sg13g2_mux2_1
X_4473_ _1872_ _0829_ _1801_ VDD VSS / sg13g2_nor2_1
X_4474_ _0122_ u_core_hold_time_0_ net360 net86 VDD VSS / sg13g2_mux2_1
X_4475_ _0123_ u_core_hold_time_1_ net357 net86 VDD VSS / sg13g2_mux2_1
X_4476_ _1873_ _0044_ net86 VDD VSS / sg13g2_nor2_1
X_4477_ _0124_ net354 net86 _1873_ VDD VSS / sg13g2_a21oi_1
X_4478_ _1874_ _0045_ net86 VDD VSS / sg13g2_nor2_1
X_4479_ _0125_ net352 net86 _1874_ VDD VSS / sg13g2_a21oi_1
X_4480_ _1875_ net350 net86 VDD VSS / sg13g2_nand2_1
X_4481_ _0126_ _0518_ net86 _1875_ VDD VSS / sg13g2_o21ai_1
X_4482_ _1876_ net349 net87 VDD VSS / sg13g2_nand2_1
X_4483_ _0127_ _0517_ net87 _1876_ VDD VSS / sg13g2_o21ai_1
X_4484_ _0128_ u_core_hold_time_6_ net348 _1872_ VDD VSS / sg13g2_mux2_1
X_4485_ _0129_ u_core_hold_time_7_ net347 net87 VDD VSS / sg13g2_mux2_1
X_4486_ _1877_ _1844_ _1865_ VDD VSS / sg13g2_nor2_1
X_4487_ _1878_ _0046_ net85 VDD VSS / sg13g2_nor2_1
X_4488_ _0130_ net360 net85 _1878_ VDD VSS / sg13g2_a21oi_1
X_4489_ _1879_ _0047_ net85 VDD VSS / sg13g2_nor2_1
X_4490_ _0131_ net357 net85 _1879_ VDD VSS / sg13g2_a21oi_1
X_4491_ _1880_ net354 net84 VDD VSS / sg13g2_nand2_1
X_4492_ _0132_ _0530_ net84 _1880_ VDD VSS / sg13g2_o21ai_1
X_4493_ _1881_ net352 net83 VDD VSS / sg13g2_nand2_1
X_4494_ _0133_ _0529_ net83 _1881_ VDD VSS / sg13g2_o21ai_1
X_4495_ _1882_ net350 net83 VDD VSS / sg13g2_nand2_1
X_4496_ _0134_ _0532_ net83 _1882_ VDD VSS / sg13g2_o21ai_1
X_4497_ _1883_ net349 net83 VDD VSS / sg13g2_nand2_1
X_4498_ _0135_ _0531_ net83 _1883_ VDD VSS / sg13g2_o21ai_1
X_4499_ _1884_ u_core_u_regfile_wr_data_6_ net83 VDD VSS / sg13g2_nand2_1
X_4500_ _0136_ _0533_ net83 _1884_ VDD VSS / sg13g2_o21ai_1
X_4501_ _1885_ net347 net84 VDD VSS / sg13g2_nand2_1
X_4502_ _0137_ _0534_ net84 _1885_ VDD VSS / sg13g2_o21ai_1
X_4503_ _1886_ u_core_u_regfile_wr_addr_5_ _1799_ VDD VSS / sg13g2_nand2_1
X_4504_ _1887_ _0478_ net367 u_core_u_regfile_wr_addr_5_ _1799_ VDD VSS / sg13g2_nand4_1
X_4505_ _1888_ _1852_ _1887_ VDD VSS / sg13g2_or2_1
X_4506_ _0138_ net359 u_core_sense_ofs_0_ _1888_ VDD VSS / sg13g2_mux2_1
X_4507_ _0139_ net356 u_core_sense_ofs_1_ _1888_ VDD VSS / sg13g2_mux2_1
X_4508_ _0140_ net354 u_core_sense_ofs_2_ _1888_ VDD VSS / sg13g2_mux2_1
X_4509_ _0141_ u_core_u_regfile_wr_data_3_ u_core_sense_ofs_3_ _1888_ VDD VSS / sg13g2_mux2_1
X_4510_ _0142_ net351 u_core_sense_ofs_4_ _1888_ VDD VSS / sg13g2_mux2_1
X_4511_ _0143_ u_core_u_regfile_wr_data_5_ u_core_sense_ofs_5_ _1888_ VDD VSS / sg13g2_mux2_1
X_4512_ _0144_ u_core_u_regfile_wr_data_6_ u_core_sense_ofs_6_ _1888_ VDD VSS / sg13g2_mux2_1
X_4513_ _0145_ u_core_u_regfile_wr_data_7_ u_core_sense_ofs_7_ _1888_ VDD VSS / sg13g2_mux2_1
X_4514_ _1889_ _1804_ _1861_ VDD VSS / sg13g2_nor2_1
X_4515_ _1890_ _0048_ net105 VDD VSS / sg13g2_nor2_1
X_4516_ _0146_ net359 net105 _1890_ VDD VSS / sg13g2_a21oi_1
X_4517_ _1891_ _0049_ net105 VDD VSS / sg13g2_nor2_1
X_4518_ _0147_ net356 net106 _1891_ VDD VSS / sg13g2_a21oi_1
X_4519_ _1892_ _0050_ net106 VDD VSS / sg13g2_nor2_1
X_4520_ _0148_ net355 net106 _1892_ VDD VSS / sg13g2_a21oi_1
X_4521_ _0149_ u_core_soft_time_3_ net353 net106 VDD VSS / sg13g2_mux2_1
X_4522_ _0150_ u_core_soft_time_4_ net350 net105 VDD VSS / sg13g2_mux2_1
X_4523_ _1893_ _0051_ net105 VDD VSS / sg13g2_nor2_1
X_4524_ _0151_ net349 net105 _1893_ VDD VSS / sg13g2_a21oi_1
X_4525_ _0152_ u_core_soft_time_6_ net348 net105 VDD VSS / sg13g2_mux2_1
X_4526_ _0153_ u_core_soft_time_7_ net347 net105 VDD VSS / sg13g2_mux2_1
X_4527_ _1894_ u_core_u_regfile_wr_addr_1_ _0827_ _1861_ VDD VSS / sg13g2_nor3_1
X_4528_ _0154_ u_core_soft_time_8_ net359 _1894_ VDD VSS / sg13g2_mux2_1
X_4529_ _1895_ net356 _1894_ VDD VSS / sg13g2_nand2_1
X_4530_ _0155_ _0502_ _1894_ _1895_ VDD VSS / sg13g2_o21ai_1
X_4531_ _0156_ u_core_soft_time_10_ net355 net104 VDD VSS / sg13g2_mux2_1
X_4532_ _0157_ u_core_soft_time_11_ net353 net104 VDD VSS / sg13g2_mux2_1
X_4533_ _1896_ net350 net104 VDD VSS / sg13g2_nand2_1
X_4534_ _0158_ _0499_ net104 _1896_ VDD VSS / sg13g2_o21ai_1
X_4535_ _0159_ u_core_soft_time_13_ net349 net104 VDD VSS / sg13g2_mux2_1
X_4536_ _1897_ net348 net104 VDD VSS / sg13g2_nand2_1
X_4537_ _0160_ _0496_ net104 _1897_ VDD VSS / sg13g2_o21ai_1
X_4538_ _0161_ u_core_soft_time_15_ net347 net104 VDD VSS / sg13g2_mux2_1
X_4539_ _1898_ _1844_ _1861_ VDD VSS / sg13g2_nor2_1
X_4540_ _0162_ u_core_decay_0_ net359 _1898_ VDD VSS / sg13g2_mux2_1
X_4541_ _1899_ net356 _1898_ VDD VSS / sg13g2_nand2_1
X_4542_ _0163_ _0543_ _1898_ _1899_ VDD VSS / sg13g2_o21ai_1
X_4543_ _1900_ u_core_u_regfile_wr_data_2_ _1898_ VDD VSS / sg13g2_nand2_1
X_4544_ _0164_ _0553_ _1898_ _1900_ VDD VSS / sg13g2_o21ai_1
X_4545_ _1901_ net353 _1898_ VDD VSS / sg13g2_nand2_1
X_4546_ _0165_ _0555_ _1898_ _1901_ VDD VSS / sg13g2_o21ai_1
X_4547_ _1902_ _1852_ _1865_ VDD VSS / sg13g2_nor2_1
X_4548_ _1903_ _0052_ _1902_ VDD VSS / sg13g2_nor2_1
X_4549_ _0166_ net359 _1902_ _1903_ VDD VSS / sg13g2_a21oi_1
X_4550_ _1904_ _0053_ _1902_ VDD VSS / sg13g2_nor2_1
X_4551_ _0167_ net358 _1902_ _1904_ VDD VSS / sg13g2_a21oi_1
X_4552_ _0168_ u_core_retrig net354 _1902_ VDD VSS / sg13g2_mux2_1
X_4553_ _0169_ net42 net352 _1902_ VDD VSS / sg13g2_mux2_1
X_4554_ _0170_ u_core_force_trip net350 _1902_ VDD VSS / sg13g2_mux2_1
X_4555_ _0171_ net27 net349 _1902_ VDD VSS / sg13g2_mux2_1
X_4556_ _1905_ _0828_ _0830_ _1803_ VDD VSS / sg13g2_nand3_1
X_4557_ _1906_ _0054_ _1905_ VDD VSS / sg13g2_nand2_1
X_4558_ _0172_ net359 _1905_ _1906_ VDD VSS / sg13g2_o21ai_1
X_4559_ _1907_ net356 _1905_ VDD VSS / sg13g2_nor2_1
X_4560_ _0173_ _0544_ _1905_ _1907_ VDD VSS / sg13g2_a21oi_1
X_4561_ _1908_ net355 _1905_ VDD VSS / sg13g2_nor2_1
X_4562_ _0174_ _0545_ _1905_ _1908_ VDD VSS / sg13g2_a21oi_1
X_4563_ _1909_ _1844_ _1887_ VDD VSS / sg13g2_nor2_1
X_4564_ _0175_ u_core_u_regfile_osc_div_0_ net361 _1909_ VDD VSS / sg13g2_mux2_1
X_4565_ _1910_ net356 _1909_ VDD VSS / sg13g2_nand2_1
X_4566_ _0176_ _0481_ _1909_ _1910_ VDD VSS / sg13g2_o21ai_1
X_4567_ _0177_ u_core_u_regfile_osc_div_2_ net355 _1909_ VDD VSS / sg13g2_mux2_1
X_4568_ _1911_ _0478_ net367 _1804_ _1886_ VDD VSS / sg13g2_nor4_1
X_4569_ _0178_ net31 net361 net103 VDD VSS / sg13g2_mux2_1
X_4570_ _0179_ net32 net357 net103 VDD VSS / sg13g2_mux2_1
X_4571_ _0180_ net33 u_core_u_regfile_wr_data_2_ net103 VDD VSS / sg13g2_mux2_1
X_4572_ _1912_ _0055_ net103 VDD VSS / sg13g2_nor2_1
X_4573_ _0181_ net352 net103 _1912_ VDD VSS / sg13g2_a21oi_1
X_4574_ _1913_ _0056_ net103 VDD VSS / sg13g2_nor2_1
X_4575_ _0182_ net350 net103 _1913_ VDD VSS / sg13g2_a21oi_1
X_4576_ _1914_ _0829_ _1886_ VDD VSS / sg13g2_nor2_1
X_4577_ _1915_ _0057_ _1914_ VDD VSS / sg13g2_nor2_1
X_4578_ _0183_ net361 _1914_ _1915_ VDD VSS / sg13g2_a21oi_1
X_4579_ _0184_ net37 net358 _1914_ VDD VSS / sg13g2_mux2_1
X_4580_ _0185_ net7 u_core_u_regfile_wr_data_2_ _1914_ VDD VSS / sg13g2_mux2_1
X_4581_ _1916_ net334 u_core_u_serial_rd_hold_0_ VDD VSS / sg13g2_nand2b_1
X_4582_ _1917_ _1723_ _1734_ VDD VSS / sg13g2_nand2_1
X_4583_ _1918_ _1723_ _1745_ VDD VSS / sg13g2_nand2_1
X_4584_ _1919_ _0475_ net364 VDD VSS / sg13g2_nand2_1
X_4585_ _1920_ u_core_rd_addr_4_ u_core_rd_addr_6_ _1732_ _1919_ VDD VSS / sg13g2_nor4_1
X_4586_ _1921_ _1723_ _1733_ _1920_ VDD VSS / sg13g2_a21oi_1
X_4587_ _1922_ _1728_ _1731_ _1734_ VDD VSS / sg13g2_nand3_1
X_4588_ _1923_ _1721_ _1724_ _1732_ VDD VSS / sg13g2_nand3_1
X_4589_ _1924_ net366 _1923_ _1922_ VDD VSS / sg13g2_o21ai_1
X_4590_ _1925_ net95 net116 net82 VDD VSS / sg13g2_nor3_1
X_4591_ _1926_ _1740_ _1921_ _1925_ VDD VSS / sg13g2_nand3_1
X_4592_ _1927_ net366 net365 _1732_ _1746_ VDD VSS / sg13g2_nor4_1
X_4593_ _1928_ _1731_ _1735_ _1745_ VDD VSS / sg13g2_nand3_1
X_4594_ _1929_ _1720_ _1732_ _1746_ VDD VSS / sg13g2_nor3_1
X_4595_ _1930_ net366 _1725_ VDD VSS / sg13g2_nor2_1
X_4596_ _1931_ _1927_ net102 _1930_ VDD VSS / sg13g2_nor3_1
X_4597_ _1932_ _1727_ _1745_ VDD VSS / sg13g2_and2_1
X_4598_ _1933_ _1727_ _1745_ VDD VSS / sg13g2_nand2_1
X_4599_ _1934_ _1729_ _1732_ _1746_ VDD VSS / sg13g2_nor3_1
X_4600_ _1935_ net366 net364 _1731_ _1734_ VDD VSS / sg13g2_and4_1
X_4601_ _1936_ _1720_ _1722_ _1738_ VDD VSS / sg13g2_nor3_1
X_4602_ _1937_ _1932_ net101 net100 net99 VDD VSS / sg13g2_nor4_1
X_4603_ _1938_ net362 u_core_rd_addr_2_ _1736_ VDD VSS / sg13g2_nor3_1
X_4604_ _1939_ _1727_ _1734_ _1735_ VDD VSS / sg13g2_nand3_1
X_4605_ _1940_ _1735_ _1747_ VDD VSS / sg13g2_or2_1
X_4606_ _1941_ _1931_ _1937_ _1939_ _1940_ VDD VSS / sg13g2_nand4_1
X_4607_ _1942_ _1720_ _1918_ VDD VSS / sg13g2_nor2_1
X_4608_ _1943_ _1917_ _1919_ VDD VSS / sg13g2_nor2_1
X_4609_ _1944_ _1729_ _1747_ VDD VSS / sg13g2_nor2_1
X_4610_ _1945_ _1720_ _1917_ VDD VSS / sg13g2_nor2_1
X_4611_ _1946_ _1725_ _1735_ VDD VSS / sg13g2_nor2b_1
X_4612_ _1947_ _1926_ _1941_ net334 VDD VSS / sg13g2_o21ai_1
X_4613_ _1948_ _1919_ _1933_ VDD VSS / sg13g2_nor2_1
X_4614_ _1949_ _1724_ _1736_ VDD VSS / sg13g2_nor2_1
X_4615_ _1950_ _1747_ _1919_ VDD VSS / sg13g2_nor2_1
X_4616_ _1951_ _1729_ _1917_ VDD VSS / sg13g2_nor2_1
X_4617_ _1952_ net36 _1951_ VDD VSS / sg13g2_nand2_1
X_4618_ _1953_ _1720_ _1932_ VDD VSS / sg13g2_nand2b_1
X_4619_ _1954_ _1953_ VDD VSS / sg13g2_inv_1
X_4620_ _1955_ u_core_rd_addr_5_ _1920_ VDD VSS / sg13g2_nor2b_1
X_4621_ _1956_ u_core_rd_addr_0_ net364 _1918_ VDD VSS / sg13g2_nor3_1
X_4622_ _1957_ net364 _1933_ VDD VSS / sg13g2_nor2_1
X_4623_ _1958_ _1918_ _1919_ VDD VSS / sg13g2_nor2_1
X_4624_ _1959_ u_core_hard_n_0_ net102 VDD VSS / sg13g2_nand2_1
X_4625_ _1960_ _1729_ _1918_ VDD VSS / sg13g2_nor2_1
X_4626_ _1961_ u_core_rd_addr_5_ _1920_ VDD VSS / sg13g2_and2_1
X_4627_ _1962_ _0979_ _1939_ _1959_ VDD VSS / sg13g2_o21ai_1
X_4628_ _1963_ u_core_dac_hard_code_0_ _1954_ _1960_ u_core_hold_time_0_ VDD VSS / sg13g2_a22oi_1
X_4629_ _1964_ net31 _1949_ _1956_ u_core_inrush_0_ VDD VSS / sg13g2_a22oi_1
X_4630_ _1965_ net38 _1944_ _1948_ _0378_ VDD VSS / sg13g2_a22oi_1
X_4631_ _1966_ _1084_ _1742_ _1952_ VDD VSS / sg13g2_o21ai_1
X_4632_ _1967_ net342 _1950_ _1958_ _0366_ _1966_ VDD VSS / sg13g2_a221oi_1
X_4633_ _1968_ _1964_ _1965_ _1967_ VDD VSS / sg13g2_nand3_1
X_4634_ _1969_ _1459_ net95 net99 _1039_ _1957_ VDD VSS / sg13g2_a221oi_1
X_4635_ _1970_ _1963_ _1969_ VDD VSS / sg13g2_nand2_1
X_4636_ _1971_ u_core_u_regfile_osc_cnt_0_ net92 _1942_ _0361_ VDD VSS / sg13g2_a22oi_1
X_4637_ _1972_ u_core_soft_time_8_ net101 net100 u_core_sense_ofs_0_ VDD VSS / sg13g2_a22oi_1
X_4638_ _1973_ _0364_ _1927_ _1955_ u_core_decay_0_ VDD VSS / sg13g2_a22oi_1
X_4639_ _1974_ u_core_u_seu_u_en_d_d_0_ _1946_ _1961_ u_core_u_regfile_osc_div_0_ VDD VSS / sg13g2_a22oi_1
X_4640_ _1975_ _1971_ _1972_ _1973_ _1974_ VDD VSS / sg13g2_nand4_1
X_4641_ _1976_ _1968_ _1970_ _1975_ VDD VSS / sg13g2_nor3_1
X_4642_ _1977_ u_core_soft_peak_0_ net116 net82 u_core_u_regfile_hi_hold_0_ _1962_ VDD VSS / sg13g2_a221oi_1
X_4643_ _1978_ _0054_ _1725_ _1919_ VDD VSS / sg13g2_nor3_1
X_4644_ _1979_ u_core_trip_cnt_0_ net112 _1978_ _0914_ VDD VSS / sg13g2_a22oi_1
X_4645_ _1980_ _1976_ _1977_ _1979_ VDD VSS / sg13g2_nand3_1
X_4646_ _1981_ net19 _1943_ _1945_ net11 _1980_ VDD VSS / sg13g2_a221oi_1
X_4647_ _0193_ _1947_ _1981_ _1916_ VDD VSS / sg13g2_o21ai_1
X_4648_ _1982_ net334 u_core_u_serial_rd_hold_1_ VDD VSS / sg13g2_nand2b_1
X_4649_ _1983_ _1735_ _1932_ VDD VSS / sg13g2_nand2_1
X_4650_ _1984_ u_core_decay_1_ _1955_ _1961_ u_core_u_regfile_osc_div_1_ VDD VSS / sg13g2_a22oi_1
X_4651_ _1985_ net32 _1949_ _1950_ u_core_cmp_hard_s VDD VSS / sg13g2_a22oi_1
X_4652_ _1986_ _1048_ net99 _1944_ net39 VDD VSS / sg13g2_a22oi_1
X_4653_ _1987_ u_core_soft_time_9_ net101 net100 u_core_sense_ofs_1_ VDD VSS / sg13g2_a22oi_1
X_4654_ _1988_ u_core_inrush_1_ _1956_ _1960_ u_core_hold_time_1_ VDD VSS / sg13g2_a22oi_1
X_4655_ _1989_ _1382_ _1741_ _1948_ u_core_dac_soft_code_1_ VDD VSS / sg13g2_a22oi_1
X_4656_ _1990_ net37 _1951_ _1958_ _0365_ VDD VSS / sg13g2_a22oi_1
X_4657_ _1991_ _1986_ _1988_ _1989_ _1990_ VDD VSS / sg13g2_nand4_1
X_4658_ _1992_ u_core_hard_n_1_ net102 _1954_ _0374_ VDD VSS / sg13g2_a22oi_1
X_4659_ _1993_ _1983_ _1985_ _1992_ VDD VSS / sg13g2_nand3_1
X_4660_ _1994_ u_core_soft_peak_1_ net116 _1942_ _0360_ VDD VSS / sg13g2_a22oi_1
X_4661_ _1995_ u_core_u_regfile_osc_cnt_1_ net92 _1938_ _0984_ VDD VSS / sg13g2_a22oi_1
X_4662_ _1996_ _1984_ _1987_ _1994_ _1995_ VDD VSS / sg13g2_nand4_1
X_4663_ _1997_ _1991_ _1993_ _1996_ VDD VSS / sg13g2_nor3_1
X_4664_ _1998_ _1492_ net95 _1946_ u_core_pattern_0_ VDD VSS / sg13g2_a22oi_1
X_4665_ _1999_ _0049_ _1928_ _1998_ VDD VSS / sg13g2_o21ai_1
X_4666_ _2000_ u_core_u_regfile_hi_hold_1_ net82 _1999_ VDD VSS / sg13g2_a21oi_1
X_4667_ _2001_ u_core_trip_cnt_1_ net112 _1978_ _0915_ VDD VSS / sg13g2_a22oi_1
X_4668_ _2002_ _1997_ _2000_ _2001_ VDD VSS / sg13g2_nand3_1
X_4669_ _2003_ net20 _1943_ _1945_ net12 _2002_ VDD VSS / sg13g2_a221oi_1
X_4670_ _0194_ _1947_ _2003_ _1982_ VDD VSS / sg13g2_o21ai_1
X_4671_ _2004_ net334 u_core_u_serial_rd_hold_2_ VDD VSS / sg13g2_nand2b_1
X_4672_ _2005_ _0987_ _1939_ VDD VSS / sg13g2_nor2_1
X_4673_ _2006_ u_core_soft_peak_2_ net116 VDD VSS / sg13g2_nand2_1
X_4674_ _2007_ _1392_ net114 _1951_ net7 VDD VSS / sg13g2_a22oi_1
X_4675_ _2008_ net40 _1944_ _1954_ _0373_ VDD VSS / sg13g2_a22oi_1
X_4676_ _2009_ u_core_u_regfile_osc_cnt_2_ net92 _1927_ _0363_ VDD VSS / sg13g2_a22oi_1
X_4677_ _2010_ _1504_ net95 _1955_ u_core_hyst_en VDD VSS / sg13g2_a22oi_1
X_4678_ _2011_ u_core_pattern_1_ _1946_ _1961_ u_core_u_regfile_osc_div_2_ VDD VSS / sg13g2_a22oi_1
X_4679_ _2012_ u_core_trip_cnt_2_ net112 net82 u_core_u_regfile_hi_hold_2_ VDD VSS / sg13g2_a22oi_1
X_4680_ _2013_ _1057_ net99 _1960_ _0368_ VDD VSS / sg13g2_a22oi_1
X_4681_ _2014_ net29 _1950_ _1956_ _0369_ VDD VSS / sg13g2_a22oi_1
X_4682_ _2015_ u_core_dac_soft_code_2_ _1948_ _1949_ net33 VDD VSS / sg13g2_a22oi_1
X_4683_ _2016_ _2008_ _2013_ _2014_ _2015_ VDD VSS / sg13g2_nand4_1
X_4684_ _2017_ u_core_soft_time_10_ net101 _1958_ u_core_retry_max_2_ VDD VSS / sg13g2_a22oi_1
X_4685_ _2018_ _1983_ _2007_ _2017_ VDD VSS / sg13g2_nand3_1
X_4686_ _2019_ u_core_sense_ofs_2_ net100 _1942_ u_core_retrig VDD VSS / sg13g2_a22oi_1
X_4687_ _2020_ _0370_ net102 _2005_ VDD VSS / sg13g2_a21oi_1
X_4688_ _2021_ _2009_ _2010_ _2019_ _2020_ VDD VSS / sg13g2_nand4_1
X_4689_ _2022_ _2016_ _2018_ _2021_ VDD VSS / sg13g2_nor3_1
X_4690_ _2023_ _2006_ _2011_ _2012_ _2022_ VDD VSS / sg13g2_nand4_1
X_4691_ _2024_ net21 _1943_ _1945_ net13 _2023_ VDD VSS / sg13g2_a221oi_1
X_4692_ _0195_ _1947_ _2024_ _2004_ VDD VSS / sg13g2_o21ai_1
X_4693_ _2025_ net334 u_core_u_serial_rd_hold_3_ VDD VSS / sg13g2_nand2b_1
X_4694_ _2026_ u_core_soft_time_11_ net101 net99 _1042_ VDD VSS / sg13g2_a22oi_1
X_4695_ _2027_ u_core_soft_peak_3_ net116 _1942_ net42 VDD VSS / sg13g2_a22oi_1
X_4696_ _2028_ u_core_trip_cnt_3_ net112 net82 u_core_u_regfile_hi_hold_3_ VDD VSS / sg13g2_a22oi_1
X_4697_ _2029_ _0036_ _1953_ _2028_ VDD VSS / sg13g2_o21ai_1
X_4698_ _2030_ _0377_ _1948_ _1956_ u_core_inrush_3_ VDD VSS / sg13g2_a22oi_1
X_4699_ _2031_ u_core_soft_time_3_ _1927_ _1938_ _0993_ VDD VSS / sg13g2_a22oi_1
X_4700_ _2032_ u_core_hyst_2 _1955_ _1960_ _0367_ VDD VSS / sg13g2_a22oi_1
X_4701_ _2033_ _2027_ _2030_ _2031_ _2032_ VDD VSS / sg13g2_nand4_1
X_4702_ _2034_ _1376_ _1741_ _1958_ u_core_retry_max_3_ VDD VSS / sg13g2_a22oi_1
X_4703_ _2035_ u_core_u_regfile_osc_cnt_3_ net92 _1950_ u_core_tripped_a_s VDD VSS / sg13g2_a22oi_1
X_4704_ _2036_ _1485_ net94 _1949_ net34 VDD VSS / sg13g2_a22oi_1
X_4705_ _2037_ u_core_hard_n_3_ net102 _1935_ u_core_sense_ofs_3_ VDD VSS / sg13g2_a22oi_1
X_4706_ _2038_ _2026_ _2037_ VDD VSS / sg13g2_and2_1
X_4707_ _2039_ _2034_ _2035_ _2036_ _2038_ VDD VSS / sg13g2_nand4_1
X_4708_ _2040_ _2029_ _2033_ _2039_ VDD VSS / sg13g2_nor3_1
X_4709_ _2041_ _1691_ _1944_ _1945_ net14 VDD VSS / sg13g2_a22oi_1
X_4710_ _2042_ _2040_ _2041_ VDD VSS / sg13g2_nand2_1
X_4711_ _2043_ net22 _1943_ _2042_ VDD VSS / sg13g2_a21oi_1
X_4712_ _0196_ _1947_ _2043_ _2025_ VDD VSS / sg13g2_o21ai_1
X_4713_ _2044_ net334 u_core_u_serial_rd_hold_4_ VDD VSS / sg13g2_nand2b_1
X_4714_ _2045_ _0043_ _1956_ VDD VSS / sg13g2_nand2b_1
X_4715_ _2046_ _0525_ _0526_ _0527_ _0528_ VDD VSS / sg13g2_nand4_1
X_4716_ _2047_ u_core_retry_cnt_0_ _2046_ _1950_ VDD VSS / sg13g2_o21ai_1
X_4717_ _2048_ u_core_u_regfile_hi_hold_4_ net82 VDD VSS / sg13g2_nand2_1
X_4718_ _2049_ _0037_ net365 _0475_ VDD VSS / sg13g2_a21oi_1
X_4719_ _2050_ u_core_gave_up u_core_retrig net38 VDD VSS / sg13g2_nand3b_1
X_4720_ _2051_ _1729_ _1747_ _2050_ VDD VSS / sg13g2_nor3_1
X_4721_ _2052_ u_core_soft_time_4_ _1927_ _1938_ _0999_ VDD VSS / sg13g2_a22oi_1
X_4722_ _2053_ u_core_soft_peak_4_ net116 net102 u_core_hard_n_4_ VDD VSS / sg13g2_a22oi_1
X_4723_ _2054_ u_core_trip_cnt_4_ net112 _1949_ net30 VDD VSS / sg13g2_a22oi_1
X_4724_ _2055_ u_core_soft_time_12_ net101 _1942_ u_core_force_trip VDD VSS / sg13g2_a22oi_1
X_4725_ _2056_ u_core_u_regfile_osc_cnt_4_ _1737_ net100 u_core_sense_ofs_4_ VDD VSS / sg13g2_a22oi_1
X_4726_ _2057_ _2048_ _2054_ _2055_ _2056_ VDD VSS / sg13g2_nand4_1
X_4727_ _2058_ _1379_ _1741_ _1948_ _0376_ VDD VSS / sg13g2_a22oi_1
X_4728_ _2059_ _2045_ _2047_ _2058_ VDD VSS / sg13g2_nand3_1
X_4729_ _2060_ _1489_ net95 _2051_ VDD VSS / sg13g2_a21o_1
X_4730_ _2061_ u_core_retry_max_4_ _1958_ _1960_ u_core_hold_time_4_ _2060_ VDD VSS / sg13g2_a221oi_1
X_4731_ _2062_ _1045_ net99 _2049_ _1932_ VDD VSS / sg13g2_a22oi_1
X_4732_ _2063_ _2052_ _2053_ _2061_ _2062_ VDD VSS / sg13g2_nand4_1
X_4733_ _2064_ _2057_ _2059_ _2063_ VDD VSS / sg13g2_or3_1
X_4734_ _2065_ net23 _1943_ _1945_ net15 _2064_ VDD VSS / sg13g2_a221oi_1
X_4735_ _0197_ _1947_ _2065_ _2044_ VDD VSS / sg13g2_o21ai_1
X_4736_ _2066_ u_core_retry_cnt_1_ _2046_ _1950_ VDD VSS / sg13g2_o21ai_1
X_4737_ _2067_ _1053_ net99 VDD VSS / sg13g2_nand2_1
X_4738_ _2068_ u_core_trip_cnt_5_ net112 VDD VSS / sg13g2_nand2_1
X_4739_ _2069_ u_core_u_regfile_osc_cnt_5_ _1737_ net101 u_core_soft_time_13_ VDD VSS / sg13g2_a22oi_1
X_4740_ _2070_ u_core_soft_peak_5_ net116 net102 u_core_hard_n_5_ VDD VSS / sg13g2_a22oi_1
X_4741_ _2071_ u_core_inrush_5_ _1956_ _1960_ u_core_hold_time_5_ VDD VSS / sg13g2_a22oi_1
X_4742_ _2072_ u_core_dac_soft_code_5_ _1948_ _1954_ _0372_ VDD VSS / sg13g2_a22oi_1
X_4743_ _2073_ _2066_ _2068_ _2071_ _2072_ VDD VSS / sg13g2_nand4_1
X_4744_ _2074_ u_core_gave_up _1944_ _1958_ u_core_retry_max_5_ _2073_ VDD VSS / sg13g2_a221oi_1
X_4745_ _2075_ _1500_ net94 _1741_ _1388_ VDD VSS / sg13g2_a22oi_1
X_4746_ _2076_ _2069_ _2070_ _2075_ VDD VSS / sg13g2_nand3_1
X_4747_ _2077_ u_core_sense_ofs_5_ net100 _1938_ _1004_ _2076_ VDD VSS / sg13g2_a221oi_1
X_4748_ _2078_ _0051_ _1928_ _2067_ VDD VSS / sg13g2_o21ai_1
X_4749_ _2079_ u_core_u_regfile_hi_hold_5_ net82 _1942_ net27 _2078_ VDD VSS / sg13g2_a221oi_1
X_4750_ _2080_ _2074_ _2077_ _2079_ VDD VSS / sg13g2_nand3_1
X_4751_ _2081_ net24 _1943_ _1945_ net16 _2080_ VDD VSS / sg13g2_a221oi_1
X_4752_ _2082_ net334 u_core_u_serial_rd_hold_5_ VDD VSS / sg13g2_nand2b_1
X_4753_ _0198_ _1947_ _2081_ _2082_ VDD VSS / sg13g2_o21ai_1
X_4754_ _2083_ u_core_u_regfile_hi_hold_6_ _1924_ VDD VSS / sg13g2_nand2_1
X_4755_ _2084_ _1580_ _1944_ VDD VSS / sg13g2_nand2b_1
X_4756_ _2085_ _1050_ net99 VDD VSS / sg13g2_nor2b_1
X_4757_ _2086_ u_core_soft_time_14_ net101 net100 u_core_sense_ofs_6_ _2085_ VDD VSS / sg13g2_a221oi_1
X_4758_ _2087_ u_core_u_regfile_osc_cnt_6_ _1737_ _1938_ _1009_ VDD VSS / sg13g2_a22oi_1
X_4759_ _2088_ _1497_ net95 _1927_ u_core_soft_time_6_ VDD VSS / sg13g2_a22oi_1
X_4760_ _2089_ _1735_ _1932_ _1956_ u_core_inrush_6_ VDD VSS / sg13g2_a22oi_1
X_4761_ _2090_ u_core_hard_n_6_ net102 _1960_ u_core_hold_time_6_ VDD VSS / sg13g2_a22oi_1
X_4762_ _2091_ _2087_ _2088_ _2089_ _2090_ VDD VSS / sg13g2_nand4_1
X_4763_ _2092_ u_core_soft_peak_6_ net116 net114 _1385_ VDD VSS / sg13g2_a22oi_1
X_4764_ _2093_ _0039_ _1953_ _2092_ VDD VSS / sg13g2_o21ai_1
X_4765_ _2094_ u_core_trip_cnt_6_ _1748_ _1958_ u_core_retry_max_6_ VDD VSS / sg13g2_a22oi_1
X_4766_ _2095_ u_core_retry_cnt_2_ _2046_ _1950_ VDD VSS / sg13g2_o21ai_1
X_4767_ _2096_ u_core_dac_soft_code_6_ _1948_ VDD VSS / sg13g2_nand2_1
X_4768_ _2097_ _2094_ _2095_ _2096_ VDD VSS / sg13g2_nand3_1
X_4769_ _2098_ _2091_ _2093_ _2097_ VDD VSS / sg13g2_nor3_1
X_4770_ _2099_ _2083_ _2084_ _2086_ _2098_ VDD VSS / sg13g2_nand4_1
X_4771_ _2100_ net25 _1943_ _1945_ net17 _2099_ VDD VSS / sg13g2_a221oi_1
X_4772_ _2101_ u_core_rd_en u_core_u_serial_rd_hold_6_ VDD VSS / sg13g2_nand2b_1
X_4773_ _0199_ _1947_ _2100_ _2101_ VDD VSS / sg13g2_o21ai_1
X_4774_ _2102_ u_core_rd_en u_core_u_serial_rd_hold_7_ VDD VSS / sg13g2_nand2b_1
X_4775_ _2103_ _1063_ _1936_ _1944_ VDD VSS / sg13g2_a21oi_1
X_4776_ _2104_ u_core_soft_time_15_ _1934_ net100 u_core_sense_ofs_7_ VDD VSS / sg13g2_a22oi_1
X_4777_ _2105_ _2046_ _0524_ VDD VSS / sg13g2_nand2b_1
X_4778_ _2106_ u_core_inrush_7_ _1956_ _2105_ _1950_ VDD VSS / sg13g2_a22oi_1
X_4779_ _2107_ _2103_ _2104_ _2106_ VDD VSS / sg13g2_nand3_1
X_4780_ _2108_ u_core_u_regfile_hi_hold_7_ net82 _2107_ VDD VSS / sg13g2_a21oi_1
X_4781_ _2109_ _0981_ _1939_ VDD VSS / sg13g2_nor2_1
X_4782_ _2110_ _1477_ net95 _2109_ VDD VSS / sg13g2_a21oi_1
X_4783_ _2111_ u_core_soft_peak_7_ net117 _1960_ u_core_hold_time_7_ VDD VSS / sg13g2_a22oi_1
X_4784_ _2112_ u_core_hard_n_7_ _1929_ _1948_ _0375_ VDD VSS / sg13g2_a22oi_1
X_4785_ _2113_ u_core_soft_time_7_ _1927_ _1958_ u_core_retry_max_7_ VDD VSS / sg13g2_a22oi_1
X_4786_ _2114_ _1407_ net114 _1954_ _0371_ VDD VSS / sg13g2_a22oi_1
X_4787_ _2115_ u_core_u_regfile_osc_cnt_7_ net92 net112 u_core_trip_cnt_7_ VDD VSS / sg13g2_a22oi_1
X_4788_ _2116_ _2112_ _2113_ _2114_ _2115_ VDD VSS / sg13g2_and4_1
X_4789_ _2117_ _2108_ _2110_ _2111_ _2116_ VDD VSS / sg13g2_nand4_1
X_4790_ _2118_ net26 _1943_ _1945_ net18 _2117_ VDD VSS / sg13g2_a221oi_1
X_4791_ _0200_ _1947_ _2118_ _2102_ VDD VSS / sg13g2_o21ai_1
X_4792_ _0201_ u_core_u_serial_cmd_addr_0_ net5 net121 VDD VSS / sg13g2_mux2_1
X_4793_ _0202_ u_core_u_serial_cmd_addr_1_ u_core_u_serial_shreg_0_ net121 VDD VSS / sg13g2_mux2_1
X_4794_ _0203_ u_core_u_serial_cmd_addr_2_ u_core_u_serial_shreg_1_ net121 VDD VSS / sg13g2_mux2_1
X_4795_ _0204_ u_core_u_serial_cmd_addr_3_ u_core_u_serial_shreg_2_ net121 VDD VSS / sg13g2_mux2_1
X_4796_ _0205_ u_core_u_serial_cmd_addr_4_ u_core_u_serial_shreg_3_ net121 VDD VSS / sg13g2_mux2_1
X_4797_ _0206_ u_core_u_serial_cmd_addr_5_ u_core_u_serial_shreg_4_ net121 VDD VSS / sg13g2_mux2_1
X_4798_ _0207_ u_core_u_serial_cmd_addr_6_ u_core_u_serial_shreg_5_ net121 VDD VSS / sg13g2_mux2_1
X_4799_ _0208_ u_core_u_regfile_wr_addr_0_ u_core_u_serial_cmd_addr_0_ net119 VDD VSS / sg13g2_mux2_1
X_4800_ _2119_ u_core_u_serial_cmd_addr_1_ net118 VDD VSS / sg13g2_nand2_1
X_4801_ _0209_ _0477_ net118 _2119_ VDD VSS / sg13g2_o21ai_1
X_4802_ _0210_ u_core_u_regfile_wr_addr_2_ u_core_u_serial_cmd_addr_2_ net118 VDD VSS / sg13g2_mux2_1
X_4803_ _2120_ u_core_u_serial_cmd_addr_3_ net118 VDD VSS / sg13g2_nand2_1
X_4804_ _0211_ _0478_ net118 _2120_ VDD VSS / sg13g2_o21ai_1
X_4805_ _2121_ u_core_u_serial_cmd_addr_4_ net118 VDD VSS / sg13g2_nand2_1
X_4806_ _0212_ _0479_ net118 _2121_ VDD VSS / sg13g2_o21ai_1
X_4807_ _0213_ u_core_u_regfile_wr_addr_5_ u_core_u_serial_cmd_addr_5_ net120 VDD VSS / sg13g2_mux2_1
X_4808_ _0214_ u_core_u_regfile_wr_addr_6_ u_core_u_serial_cmd_addr_6_ net120 VDD VSS / sg13g2_mux2_1
X_4809_ _2122_ u_core_u_serial_shreg_6_ _1707_ VDD VSS / sg13g2_and2_1
X_4810_ _0215_ u_core_rd_addr_0_ net5 net98 VDD VSS / sg13g2_mux2_1
X_4811_ _0216_ net365 u_core_u_serial_shreg_0_ net98 VDD VSS / sg13g2_mux2_1
X_4812_ _0217_ u_core_rd_addr_2_ u_core_u_serial_shreg_1_ net98 VDD VSS / sg13g2_mux2_1
X_4813_ _0218_ u_core_rd_addr_3_ u_core_u_serial_shreg_2_ net98 VDD VSS / sg13g2_mux2_1
X_4814_ _2123_ u_core_u_serial_shreg_3_ net98 VDD VSS / sg13g2_nand2_1
X_4815_ _0219_ _0476_ net98 _2123_ VDD VSS / sg13g2_o21ai_1
X_4816_ _0220_ u_core_rd_addr_5_ u_core_u_serial_shreg_4_ net98 VDD VSS / sg13g2_mux2_1
X_4817_ _0221_ u_core_rd_addr_6_ u_core_u_serial_shreg_5_ net98 VDD VSS / sg13g2_mux2_1
X_4818_ _0222_ net361 net5 net119 VDD VSS / sg13g2_mux2_1
X_4819_ _0223_ net358 u_core_u_serial_shreg_0_ net119 VDD VSS / sg13g2_mux2_1
X_4820_ _0224_ net355 u_core_u_serial_shreg_1_ net120 VDD VSS / sg13g2_mux2_1
X_4821_ _0225_ net353 u_core_u_serial_shreg_2_ net118 VDD VSS / sg13g2_mux2_1
X_4822_ _0226_ net351 u_core_u_serial_shreg_3_ net119 VDD VSS / sg13g2_mux2_1
X_4823_ _0227_ u_core_u_regfile_wr_data_5_ u_core_u_serial_shreg_4_ net120 VDD VSS / sg13g2_mux2_1
X_4824_ _0228_ net348 u_core_u_serial_shreg_5_ net120 VDD VSS / sg13g2_mux2_1
X_4825_ _0229_ u_core_u_regfile_wr_data_7_ u_core_u_serial_shreg_6_ net120 VDD VSS / sg13g2_mux2_1
X_4826_ _0230_ u_core_u_serial_u_sync_wr_d_0_ _1709_ VDD VSS / sg13g2_xor2_1
X_4827_ _0231_ u_core_u_serial_u_sync_rd_d_0_ _2122_ VDD VSS / sg13g2_xor2_1
X_4828_ _2124_ u_core_u_serial_bit_cnt_3_ _1705_ u_core_u_serial_rd_frame VDD VSS / sg13g2_o21ai_1
X_4829_ _0232_ _2122_ _2124_ VDD VSS / sg13g2_nand2b_1
X_4830_ _2125_ u_core_u_serial_idle_cnt_5_ u_core_u_serial_idle_cnt_6_ _0849_ VDD VSS / sg13g2_nand3_1
X_4831_ _0233_ u_core_u_serial_idle_cnt_0_ _2125_ u_core_u_serial_u_sync_sclk_q_0_ VDD VSS / sg13g2_a21oi_1
X_4832_ _2126_ u_core_u_serial_idle_cnt_0_ u_core_u_serial_idle_cnt_1_ VDD VSS / sg13g2_xnor2_1
X_4833_ _0234_ _2125_ _2126_ u_core_u_serial_u_sync_sclk_q_0_ VDD VSS / sg13g2_a21oi_1
X_4834_ _2127_ u_core_u_serial_idle_cnt_0_ u_core_u_serial_idle_cnt_1_ u_core_u_serial_idle_cnt_2_ VDD VSS / sg13g2_a21o_1
X_4835_ _2128_ _0847_ _2127_ VDD VSS / sg13g2_nand2_1
X_4836_ _0235_ _2125_ _2128_ u_core_u_serial_u_sync_sclk_q_0_ VDD VSS / sg13g2_a21oi_1
X_4837_ _2129_ _0483_ _0847_ VDD VSS / sg13g2_xnor2_1
X_4838_ _0236_ _2125_ _2129_ u_core_u_serial_u_sync_sclk_q_0_ VDD VSS / sg13g2_a21oi_1
X_4839_ _2130_ u_core_u_serial_idle_cnt_4_ _0848_ VDD VSS / sg13g2_xnor2_1
X_4840_ _0237_ _2125_ _2130_ u_core_u_serial_u_sync_sclk_q_0_ VDD VSS / sg13g2_a21oi_1
X_4841_ _2131_ u_core_u_serial_idle_cnt_5_ _0849_ VDD VSS / sg13g2_nor2_1
X_4842_ _0238_ u_core_u_serial_u_sync_sclk_q_0_ _0851_ _2131_ VDD VSS / sg13g2_nor3_1
X_4843_ _0239_ _0484_ _0850_ u_core_u_serial_u_sync_sclk_q_0_ VDD VSS / sg13g2_a21oi_1
X_4844_ _2132_ u_core_retry_cnt_1_ u_core_retry_cnt_0_ u_core_retry_cnt_2_ _2105_ VDD VSS / sg13g2_nor4_1
X_4845_ _2133_ _1693_ _2132_ VDD VSS / sg13g2_or2_1
X_4846_ _2134_ _2050_ _2133_ VDD VSS / sg13g2_and2_1
X_4847_ _2135_ _0053_ _1693_ VDD VSS / sg13g2_nor2_1
X_4848_ _2136_ _0053_ _0490_ _1693_ VDD VSS / sg13g2_nor3_1
X_4849_ _2137_ u_core_cmp_hard_s _2135_ VDD VSS / sg13g2_nand2_1
X_4850_ _2138_ _0053_ net10 _0490_ _1693_ VDD VSS / sg13g2_nor4_1
X_4851_ _2139_ u_core_hard_n_0_ u_core_hard_n_1_ VDD VSS / sg13g2_nor2_1
X_4852_ _2140_ u_core_hard_n_0_ u_core_hard_n_1_ VDD VSS / sg13g2_or2_1
X_4853_ _2141_ u_core_hard_n_3_ _2139_ _0041_ VDD VSS / sg13g2_nand3b_1
X_4854_ _2142_ _0370_ u_core_hard_n_4_ u_core_hard_n_3_ _2140_ VDD VSS / sg13g2_nor4_1
X_4855_ _2143_ u_core_hard_n_5_ _2142_ VDD VSS / sg13g2_nor2b_1
X_4856_ _2144_ u_core_hard_n_6_ _2143_ VDD VSS / sg13g2_nor2b_1
X_4857_ _2145_ _0492_ _2144_ VDD VSS / sg13g2_nor2_1
X_4858_ _2146_ u_core_hard_n_5_ _2142_ VDD VSS / sg13g2_xnor2_1
X_4859_ _2147_ u_core_u_trip_hard_cnt_5_ _2146_ VDD VSS / sg13g2_and2_1
X_4860_ _2148_ _0370_ _2140_ u_core_hard_n_3_ VDD VSS / sg13g2_o21ai_1
X_4861_ _2149_ _2141_ _2148_ VDD VSS / sg13g2_and2_1
X_4862_ _2150_ _2141_ _2148_ u_core_u_trip_hard_cnt_3_ VDD VSS / sg13g2_a21oi_1
X_4863_ _2151_ _0370_ _2139_ VDD VSS / sg13g2_xnor2_1
X_4864_ _2152_ u_core_hard_n_0_ u_core_u_trip_hard_cnt_0_ VDD VSS / sg13g2_nand2b_1
X_4865_ _2153_ u_core_u_trip_hard_cnt_1_ u_core_hard_n_1_ VDD VSS / sg13g2_nor2b_1
X_4866_ _2154_ _2152_ _2153_ _2139_ VDD VSS / sg13g2_a21oi_1
X_4867_ _2155_ u_core_u_trip_hard_cnt_1_ u_core_u_trip_hard_cnt_0_ _2151_ u_core_u_trip_hard_cnt_2_ _2154_ VDD VSS / sg13g2_a221oi_1
X_4868_ _2156_ u_core_u_trip_hard_cnt_2_ _2151_ VDD VSS / sg13g2_nor2_1
X_4869_ _2157_ _2150_ _2155_ _2156_ VDD VSS / sg13g2_or3_1
X_4870_ _2158_ u_core_hard_n_4_ _2141_ VDD VSS / sg13g2_xor2_1
X_4871_ _2159_ u_core_u_trip_hard_cnt_3_ _2149_ _2158_ u_core_u_trip_hard_cnt_4_ VDD VSS / sg13g2_a22oi_1
X_4872_ _2160_ u_core_u_trip_hard_cnt_4_ _2158_ VDD VSS / sg13g2_nor2_1
X_4873_ _2161_ _2157_ _2159_ _2160_ VDD VSS / sg13g2_a21oi_1
X_4874_ _2162_ u_core_hard_n_6_ _2143_ VDD VSS / sg13g2_xnor2_1
X_4875_ _2163_ u_core_hard_n_6_ _2143_ VDD VSS / sg13g2_xor2_1
X_4876_ _2164_ u_core_u_trip_hard_cnt_5_ _2146_ VDD VSS / sg13g2_nor2_1
X_4877_ _2165_ _0493_ _2163_ _2164_ VDD VSS / sg13g2_a21oi_1
X_4878_ _2166_ _2147_ _2161_ _2165_ VDD VSS / sg13g2_o21ai_1
X_4879_ _2167_ _0492_ _2144_ u_core_u_trip_hard_cnt_7_ VDD VSS / sg13g2_o21ai_1
X_4880_ _2168_ _0492_ _2144_ _2162_ u_core_u_trip_hard_cnt_6_ VDD VSS / sg13g2_a22oi_1
X_4881_ _2169_ _2167_ _2168_ VDD VSS / sg13g2_and2_1
X_4882_ _2170_ _0491_ _2145_ _2166_ _2169_ VDD VSS / sg13g2_a22oi_1
X_4883_ _2171_ u_core_u_trip_clr_mask_0_ u_core_u_trip_clr_mask_1_ u_core_u_trip_clr_mask_2_ VDD VSS / sg13g2_nor3_1
X_4884_ _2172_ net28 _2171_ VDD VSS / sg13g2_and2_1
X_4885_ _2173_ _2138_ _2170_ _2172_ u_core_tripped_a_s VDD VSS / sg13g2_a22oi_1
X_4886_ _2174_ _2138_ _2170_ _2172_ u_core_tripped_a_s u_core_force_trip VDD VSS / sg13g2_a221oi_1
X_4887_ _2175_ u_core_force_trip _2173_ VDD VSS / sg13g2_nand2b_1
X_4888_ _2176_ _0496_ u_core_u_trip_soft_cnt_22_ VDD VSS / sg13g2_nand2_1
X_4889_ _2177_ u_core_soft_time_15_ _0495_ _2176_ VDD VSS / sg13g2_o21ai_1
X_4890_ _2178_ u_core_soft_time_15_ _0495_ VDD VSS / sg13g2_nand2_1
X_4891_ _2179_ u_core_soft_time_13_ u_core_u_trip_soft_cnt_21_ VDD VSS / sg13g2_nand2b_1
X_4892_ _2180_ u_core_soft_time_12_ _0500_ _2179_ VDD VSS / sg13g2_o21ai_1
X_4893_ _2181_ u_core_soft_time_11_ net344 VDD VSS / sg13g2_nor2b_1
X_4894_ _2182_ u_core_soft_time_10_ _0501_ VDD VSS / sg13g2_nor2_1
X_4895_ _2183_ net344 u_core_soft_time_11_ VDD VSS / sg13g2_nand2b_1
X_4896_ _2184_ _2181_ _2182_ _2183_ VDD VSS / sg13g2_o21ai_1
X_4897_ _2185_ u_core_u_trip_soft_cnt_14_ u_core_soft_time_6_ VDD VSS / sg13g2_nor2b_1
X_4898_ _2186_ _0049_ net345 VDD VSS / sg13g2_nor2_1
X_4899_ _2187_ _0048_ net346 VDD VSS / sg13g2_nor2_1
X_4900_ _2188_ _0050_ u_core_u_trip_soft_cnt_10_ net345 _0049_ VDD VSS / sg13g2_a22oi_1
X_4901_ _2189_ _2186_ _2187_ _2188_ VDD VSS / sg13g2_o21ai_1
X_4902_ _2190_ u_core_soft_time_3_ _0510_ _0511_ _0363_ VDD VSS / sg13g2_a22oi_1
X_4903_ _2191_ u_core_soft_time_4_ u_core_u_trip_soft_cnt_12_ VDD VSS / sg13g2_nand2b_1
X_4904_ _2192_ u_core_soft_time_3_ _0510_ _2191_ VDD VSS / sg13g2_o21ai_1
X_4905_ _2193_ _2189_ _2190_ _2192_ VDD VSS / sg13g2_a21o_1
X_4906_ _2194_ _0362_ _0508_ u_core_soft_time_4_ _0509_ VDD VSS / sg13g2_a22oi_1
X_4907_ _2195_ u_core_soft_time_6_ _0507_ VDD VSS / sg13g2_nor2_1
X_4908_ _2196_ _0051_ u_core_u_trip_soft_cnt_13_ _2193_ _2194_ _2195_ VDD VSS / sg13g2_a221oi_1
X_4909_ _2197_ u_core_soft_time_7_ u_core_u_trip_soft_cnt_15_ VDD VSS / sg13g2_nand2b_1
X_4910_ _2198_ _2185_ _2196_ _2197_ VDD VSS / sg13g2_o21ai_1
X_4911_ _2199_ u_core_soft_time_8_ _0504_ u_core_soft_time_7_ _0506_ VDD VSS / sg13g2_a22oi_1
X_4912_ _2200_ u_core_soft_time_8_ _0504_ VDD VSS / sg13g2_nor2_1
X_4913_ _2201_ _0502_ u_core_u_trip_soft_cnt_17_ _2198_ _2199_ _2200_ VDD VSS / sg13g2_a221oi_1
X_4914_ _2202_ u_core_u_trip_soft_cnt_18_ u_core_soft_time_10_ VDD VSS / sg13g2_nor2b_1
X_4915_ _2203_ _0502_ u_core_u_trip_soft_cnt_17_ _2183_ VDD VSS / sg13g2_o21ai_1
X_4916_ _2204_ _2181_ _2182_ _2202_ _2203_ VDD VSS / sg13g2_or4_1
X_4917_ _2205_ _2201_ _2204_ _2184_ VDD VSS / sg13g2_o21ai_1
X_4918_ _2206_ u_core_soft_time_13_ _0498_ VDD VSS / sg13g2_nand2_1
X_4919_ _2207_ _0496_ u_core_u_trip_soft_cnt_22_ _2178_ VDD VSS / sg13g2_o21ai_1
X_4920_ _2208_ _0499_ net343 _2206_ VDD VSS / sg13g2_o21ai_1
X_4921_ _2209_ _2177_ _2180_ _2207_ _2208_ VDD VSS / sg13g2_nor4_1
X_4922_ _2210_ _2180_ _2206_ VDD VSS / sg13g2_nand2_1
X_4923_ _2211_ _2177_ _2207_ _2210_ VDD VSS / sg13g2_nor3_1
X_4924_ _2212_ _2177_ _2178_ _2205_ _2209_ _2211_ VDD VSS / sg13g2_a221oi_1
X_4925_ _2213_ _0361_ net342 _1692_ VDD VSS / sg13g2_nand3_1
X_4926_ _2214_ _2212_ _2213_ _2174_ VDD VSS / sg13g2_o21ai_1
X_4927_ _2215_ net28 _2214_ VDD VSS / sg13g2_nand2_1
X_4928_ _2216_ net360 _1805_ VDD VSS / sg13g2_and2_1
X_4929_ _2217_ net28 _2214_ _2216_ VDD VSS / sg13g2_a21oi_1
X_4930_ _2218_ _2134_ _2217_ VDD VSS / sg13g2_and2_1
X_4931_ _2219_ _2134_ _2217_ VDD VSS / sg13g2_nand2_1
X_4932_ _2220_ u_core_u_trip_hold_cnt_20_ u_core_hold_time_7_ VDD VSS / sg13g2_nand2b_1
X_4933_ _2221_ u_core_hold_time_1_ _0519_ u_core_hold_time_0_ VDD VSS / sg13g2_o21ai_1
X_4934_ _2222_ u_core_hold_time_7_ u_core_hold_time_6_ u_core_u_trip_hold_cnt_14_ VDD VSS / sg13g2_nor3_1
X_4935_ _2223_ u_core_hold_time_5_ u_core_hold_time_4_ VDD VSS / sg13g2_nor2_1
X_4936_ _2224_ _0045_ _0044_ _2222_ _2223_ VDD VSS / sg13g2_nand4_1
X_4937_ _2225_ _2221_ _2224_ VDD VSS / sg13g2_nand2_1
X_4938_ _2226_ u_core_hold_time_1_ _0519_ _2225_ _0516_ VDD VSS / sg13g2_a22oi_1
X_4939_ _2227_ _0044_ u_core_u_trip_hold_cnt_15_ _2226_ VDD VSS / sg13g2_o21ai_1
X_4940_ _2228_ _0044_ u_core_u_trip_hold_cnt_15_ u_core_u_trip_hold_cnt_16_ _0045_ VDD VSS / sg13g2_a22oi_1
X_4941_ _2229_ _0518_ u_core_u_trip_hold_cnt_17_ VDD VSS / sg13g2_nor2_1
X_4942_ _2230_ _0367_ _0520_ _2227_ _2228_ _2229_ VDD VSS / sg13g2_a221oi_1
X_4943_ _2231_ _0518_ u_core_u_trip_hold_cnt_17_ u_core_u_trip_hold_cnt_18_ _0517_ _2230_ VDD VSS / sg13g2_a221oi_1
X_4944_ _2232_ u_core_hold_time_6_ _0521_ _0522_ u_core_hold_time_5_ _2231_ VDD VSS / sg13g2_a221oi_1
X_4945_ _2233_ u_core_hold_time_7_ u_core_u_trip_hold_cnt_20_ VDD VSS / sg13g2_nand2b_1
X_4946_ _2234_ u_core_hold_time_6_ _0521_ _2233_ VDD VSS / sg13g2_o21ai_1
X_4947_ _2235_ _2232_ _2234_ _2220_ VDD VSS / sg13g2_o21ai_1
X_4948_ _2236_ _2217_ _2235_ VDD VSS / sg13g2_nand2_1
X_4949_ _2237_ u_core_u_trip_hold_cnt_0_ _2236_ VDD VSS / sg13g2_nor2_1
X_4950_ _2238_ net50 _2237_ VDD VSS / sg13g2_nor2_1
X_4951_ _0240_ _0513_ _2134_ _2238_ VDD VSS / sg13g2_a21oi_1
X_4952_ _2239_ _2236_ _2219_ VDD VSS / sg13g2_nand2b_1
X_4953_ _2240_ _0513_ net46 VDD VSS / sg13g2_nor2_1
X_4954_ _2241_ u_core_u_trip_hold_cnt_1_ _2240_ VDD VSS / sg13g2_nor2_1
X_4955_ _0241_ u_core_u_trip_hold_cnt_1_ _2238_ _2241_ VDD VSS / sg13g2_a21oi_1
X_4956_ _2242_ u_core_u_trip_hold_cnt_2_ net49 VDD VSS / sg13g2_nand2_1
X_4957_ _2243_ u_core_u_trip_hold_cnt_0_ u_core_u_trip_hold_cnt_1_ u_core_u_trip_hold_cnt_2_ VDD VSS / sg13g2_nand3_1
X_4958_ _2244_ u_core_u_trip_hold_cnt_0_ u_core_u_trip_hold_cnt_1_ u_core_u_trip_hold_cnt_2_ VDD VSS / sg13g2_a21o_1
X_4959_ _2245_ _2243_ _2244_ VDD VSS / sg13g2_nand2_1
X_4960_ _0242_ net46 _2245_ _2242_ VDD VSS / sg13g2_o21ai_1
X_4961_ _2246_ u_core_u_trip_hold_cnt_3_ net49 VDD VSS / sg13g2_nand2_1
X_4962_ _2247_ u_core_u_trip_hold_cnt_0_ u_core_u_trip_hold_cnt_1_ u_core_u_trip_hold_cnt_3_ u_core_u_trip_hold_cnt_2_ VDD VSS / sg13g2_and4_1
X_4963_ _2248_ u_core_u_trip_hold_cnt_3_ _2243_ VDD VSS / sg13g2_xor2_1
X_4964_ _0243_ net45 _2248_ _2246_ VDD VSS / sg13g2_o21ai_1
X_4965_ _2249_ u_core_u_trip_hold_cnt_4_ net50 VDD VSS / sg13g2_nand2_1
X_4966_ _2250_ u_core_u_trip_hold_cnt_4_ _2247_ VDD VSS / sg13g2_and2_1
X_4967_ _2251_ u_core_u_trip_hold_cnt_4_ _2247_ VDD VSS / sg13g2_xnor2_1
X_4968_ _0244_ net45 _2251_ _2249_ VDD VSS / sg13g2_o21ai_1
X_4969_ _2252_ u_core_u_trip_hold_cnt_5_ net49 VDD VSS / sg13g2_nand2_1
X_4970_ _2253_ u_core_u_trip_hold_cnt_5_ _2250_ VDD VSS / sg13g2_xnor2_1
X_4971_ _0245_ net45 _2253_ _2252_ VDD VSS / sg13g2_o21ai_1
X_4972_ _2254_ u_core_u_trip_hold_cnt_6_ net49 VDD VSS / sg13g2_nand2_1
X_4973_ _2255_ u_core_u_trip_hold_cnt_5_ u_core_u_trip_hold_cnt_6_ _2250_ VDD VSS / sg13g2_nand3_1
X_4974_ _2256_ u_core_u_trip_hold_cnt_5_ _2250_ u_core_u_trip_hold_cnt_6_ VDD VSS / sg13g2_a21o_1
X_4975_ _2257_ _2255_ _2256_ VDD VSS / sg13g2_nand2_1
X_4976_ _0246_ net45 _2257_ _2254_ VDD VSS / sg13g2_o21ai_1
X_4977_ _2258_ u_core_u_trip_hold_cnt_7_ net49 VDD VSS / sg13g2_nand2_1
X_4978_ _2259_ _0514_ _2255_ VDD VSS / sg13g2_nor2_1
X_4979_ _2260_ _0514_ _2255_ VDD VSS / sg13g2_xnor2_1
X_4980_ _0247_ net45 _2260_ _2258_ VDD VSS / sg13g2_o21ai_1
X_4981_ _2261_ u_core_u_trip_hold_cnt_8_ net49 VDD VSS / sg13g2_nand2_1
X_4982_ _2262_ u_core_u_trip_hold_cnt_8_ _2259_ VDD VSS / sg13g2_xnor2_1
X_4983_ _0248_ net45 _2262_ _2261_ VDD VSS / sg13g2_o21ai_1
X_4984_ _2263_ u_core_u_trip_hold_cnt_9_ net49 VDD VSS / sg13g2_nand2_1
X_4985_ _2264_ u_core_u_trip_hold_cnt_9_ u_core_u_trip_hold_cnt_8_ _2259_ VDD VSS / sg13g2_nand3_1
X_4986_ _2265_ u_core_u_trip_hold_cnt_8_ _2259_ u_core_u_trip_hold_cnt_9_ VDD VSS / sg13g2_a21o_1
X_4987_ _2266_ _2264_ _2265_ VDD VSS / sg13g2_nand2_1
X_4988_ _0249_ net45 _2266_ _2263_ VDD VSS / sg13g2_o21ai_1
X_4989_ _2267_ u_core_u_trip_hold_cnt_10_ net49 VDD VSS / sg13g2_nand2_1
X_4990_ _2268_ _0515_ _2264_ VDD VSS / sg13g2_nor2_1
X_4991_ _2269_ _0515_ _2264_ VDD VSS / sg13g2_xnor2_1
X_4992_ _0250_ net45 _2269_ _2267_ VDD VSS / sg13g2_o21ai_1
X_4993_ _2270_ u_core_u_trip_hold_cnt_11_ net50 VDD VSS / sg13g2_nand2_1
X_4994_ _2271_ u_core_u_trip_hold_cnt_11_ _2268_ VDD VSS / sg13g2_xnor2_1
X_4995_ _0251_ net46 _2271_ _2270_ VDD VSS / sg13g2_o21ai_1
X_4996_ _2272_ u_core_u_trip_hold_cnt_12_ net50 VDD VSS / sg13g2_nand2_1
X_4997_ _2273_ u_core_u_trip_hold_cnt_11_ u_core_u_trip_hold_cnt_12_ _2268_ VDD VSS / sg13g2_nand3_1
X_4998_ _2274_ u_core_u_trip_hold_cnt_11_ _2268_ u_core_u_trip_hold_cnt_12_ VDD VSS / sg13g2_a21o_1
X_4999_ _2275_ _2273_ _2274_ VDD VSS / sg13g2_nand2_1
X_5000_ _0252_ net46 _2275_ _2272_ VDD VSS / sg13g2_o21ai_1
X_5001_ _2276_ u_core_u_trip_hold_cnt_13_ net50 VDD VSS / sg13g2_nand2_1
X_5002_ _2277_ _0516_ _2273_ VDD VSS / sg13g2_nor2_1
X_5003_ _2278_ _0516_ _2273_ VDD VSS / sg13g2_xnor2_1
X_5004_ _0253_ net46 _2278_ _2276_ VDD VSS / sg13g2_o21ai_1
X_5005_ _2279_ u_core_u_trip_hold_cnt_14_ net50 VDD VSS / sg13g2_nand2_1
X_5006_ _2280_ u_core_u_trip_hold_cnt_14_ _2277_ VDD VSS / sg13g2_xnor2_1
X_5007_ _0254_ net46 _2280_ _2279_ VDD VSS / sg13g2_o21ai_1
X_5008_ _2281_ u_core_u_trip_hold_cnt_15_ net50 VDD VSS / sg13g2_nand2_1
X_5009_ _2282_ u_core_u_trip_hold_cnt_15_ u_core_u_trip_hold_cnt_14_ _2277_ VDD VSS / sg13g2_nand3_1
X_5010_ _2283_ u_core_u_trip_hold_cnt_14_ _2277_ u_core_u_trip_hold_cnt_15_ VDD VSS / sg13g2_a21o_1
X_5011_ _2284_ _2282_ _2283_ VDD VSS / sg13g2_nand2_1
X_5012_ _0255_ net46 _2284_ _2281_ VDD VSS / sg13g2_o21ai_1
X_5013_ _2285_ u_core_u_trip_hold_cnt_16_ net51 VDD VSS / sg13g2_nand2_1
X_5014_ _2286_ _0520_ _2282_ VDD VSS / sg13g2_nor2_1
X_5015_ _2287_ _0520_ _2282_ VDD VSS / sg13g2_xnor2_1
X_5016_ _0256_ _2239_ _2287_ _2285_ VDD VSS / sg13g2_o21ai_1
X_5017_ _2288_ u_core_u_trip_hold_cnt_17_ _2286_ VDD VSS / sg13g2_and2_1
X_5018_ _2289_ _2236_ _2288_ VDD VSS / sg13g2_nor2_1
X_5019_ _2290_ net51 _2289_ VDD VSS / sg13g2_nor2_1
X_5020_ _2291_ _2219_ _2286_ u_core_u_trip_hold_cnt_17_ VDD VSS / sg13g2_a21oi_1
X_5021_ _0257_ _2290_ _2291_ VDD VSS / sg13g2_nor2_1
X_5022_ _2292_ _2239_ _2288_ _0522_ VDD VSS / sg13g2_nand3b_1
X_5023_ _0258_ _0522_ _2290_ _2292_ VDD VSS / sg13g2_o21ai_1
X_5024_ _2293_ u_core_u_trip_hold_cnt_19_ u_core_u_trip_hold_cnt_18_ _2288_ VDD VSS / sg13g2_nand3_1
X_5025_ _2294_ _2236_ _2293_ VDD VSS / sg13g2_nor2b_1
X_5026_ _2295_ net51 _2294_ VDD VSS / sg13g2_nor2_1
X_5027_ _2296_ u_core_u_trip_hold_cnt_18_ _2219_ _2288_ VDD VSS / sg13g2_nand3_1
X_5028_ _0259_ _0521_ _2296_ _2295_ VDD VSS / sg13g2_a21oi_1
X_5029_ _2297_ net51 _2294_ u_core_u_trip_hold_cnt_20_ VDD VSS / sg13g2_o21ai_1
X_5030_ _0260_ _2239_ _2293_ _2297_ VDD VSS / sg13g2_o21ai_1
X_5031_ _2298_ _2215_ _2216_ VDD VSS / sg13g2_nor2_1
X_5032_ _2299_ _2050_ _2235_ VDD VSS / sg13g2_nor2_1
X_5033_ _2300_ _2216_ net54 VDD VSS / sg13g2_nor2_1
X_5034_ _0261_ net38 _2300_ _2298_ VDD VSS / sg13g2_a21o_1
X_5035_ _2301_ u_core_force_trip _2173_ _2298_ VDD VSS / sg13g2_o21ai_1
X_5036_ _2302_ net54 _2217_ VDD VSS / sg13g2_nor2b_1
X_5037_ _2303_ net39 _2302_ VDD VSS / sg13g2_nand2_1
X_5038_ _0262_ _2301_ _2303_ VDD VSS / sg13g2_nand2_1
X_5039_ _2304_ _2175_ _2298_ _2302_ net40 VDD VSS / sg13g2_a22oi_1
X_5040_ _0263_ _2304_ VDD VSS / sg13g2_inv_1
X_5041_ _2305_ _0047_ u_core_retry_cnt_1_ VDD VSS / sg13g2_or2_1
X_5042_ _2306_ _0046_ u_core_retry_cnt_0_ _2305_ VDD VSS / sg13g2_o21ai_1
X_5043_ _2307_ _0047_ u_core_retry_cnt_1_ u_core_retry_cnt_2_ _0530_ VDD VSS / sg13g2_a22oi_1
X_5044_ _2308_ _0523_ u_core_retry_max_2_ _2306_ _2307_ VDD VSS / sg13g2_a22oi_1
X_5045_ _2309_ u_core_retry_cnt_3_ _0529_ _2308_ VDD VSS / sg13g2_a21oi_1
X_5046_ _2310_ _0524_ u_core_retry_max_3_ u_core_retry_max_4_ _0525_ _2309_ VDD VSS / sg13g2_a221oi_1
X_5047_ _2311_ u_core_retry_cnt_5_ _0531_ _0532_ u_core_retry_cnt_4_ _2310_ VDD VSS / sg13g2_a221oi_1
X_5048_ _2312_ _0526_ u_core_retry_max_5_ u_core_retry_max_6_ _0527_ _2311_ VDD VSS / sg13g2_a221oi_1
X_5049_ _2313_ u_core_retry_cnt_6_ _0533_ _0534_ u_core_retry_cnt_7_ _2312_ VDD VSS / sg13g2_a221oi_1
X_5050_ _2314_ _0047_ _0530_ _0531_ _0533_ VDD VSS / sg13g2_nor4_1
X_5051_ _2315_ _0366_ u_core_retry_max_3_ u_core_retry_max_4_ _2314_ VDD VSS / sg13g2_nand4_1
X_5052_ _2316_ u_core_retry_cnt_7_ _2315_ _0534_ VDD VSS / sg13g2_a21oi_1
X_5053_ _2317_ _2215_ _2313_ _2316_ VDD VSS / sg13g2_nor3_1
X_5054_ _2318_ u_core_retrig _2317_ u_core_gave_up VDD VSS / sg13g2_a21oi_1
X_5055_ _0264_ _2216_ _2318_ VDD VSS / sg13g2_nor2_1
X_5056_ _2319_ u_core_retry_cnt_1_ u_core_retry_cnt_0_ u_core_retry_cnt_2_ VDD VSS / sg13g2_nand3_1
X_5057_ _2320_ _0524_ _2319_ VDD VSS / sg13g2_nor2_1
X_5058_ _2321_ u_core_retry_cnt_4_ u_core_retry_cnt_5_ _2320_ VDD VSS / sg13g2_nand3_1
X_5059_ _2322_ _2321_ VDD VSS / sg13g2_inv_1
X_5060_ _2323_ u_core_retry_cnt_6_ _2322_ VDD VSS / sg13g2_nand2_1
X_5061_ _2324_ _0528_ _2050_ _2323_ VDD VSS / sg13g2_nor3_1
X_5062_ _2325_ _2134_ _2235_ _2324_ VDD VSS / sg13g2_nor3_1
X_5063_ _2326_ _2215_ _2325_ _2216_ VDD VSS / sg13g2_a21oi_1
X_5064_ _2327_ _2217_ net54 _2325_ VDD VSS / sg13g2_nand3_1
X_5065_ _2328_ u_core_retry_cnt_0_ _2326_ VDD VSS / sg13g2_nand2_1
X_5066_ _0265_ u_core_retry_cnt_0_ _2327_ _2328_ VDD VSS / sg13g2_o21ai_1
X_5067_ _2329_ u_core_retry_cnt_1_ _2326_ VDD VSS / sg13g2_nand2_1
X_5068_ _2330_ u_core_retry_cnt_1_ u_core_retry_cnt_0_ VDD VSS / sg13g2_xnor2_1
X_5069_ _0266_ _2327_ _2330_ _2329_ VDD VSS / sg13g2_o21ai_1
X_5070_ _2331_ u_core_retry_cnt_2_ _2326_ VDD VSS / sg13g2_nand2_1
X_5071_ _2332_ u_core_retry_cnt_1_ u_core_retry_cnt_0_ u_core_retry_cnt_2_ VDD VSS / sg13g2_a21o_1
X_5072_ _2333_ _2319_ _2332_ VDD VSS / sg13g2_nand2_1
X_5073_ _0267_ _2327_ _2333_ _2331_ VDD VSS / sg13g2_o21ai_1
X_5074_ _2334_ u_core_retry_cnt_3_ _2326_ VDD VSS / sg13g2_nand2_1
X_5075_ _2335_ _0524_ _2319_ VDD VSS / sg13g2_xnor2_1
X_5076_ _0268_ _2327_ _2335_ _2334_ VDD VSS / sg13g2_o21ai_1
X_5077_ _2336_ u_core_retry_cnt_4_ _2326_ VDD VSS / sg13g2_nand2_1
X_5078_ _2337_ u_core_retry_cnt_4_ _2320_ VDD VSS / sg13g2_xnor2_1
X_5079_ _0269_ _2327_ _2337_ _2336_ VDD VSS / sg13g2_o21ai_1
X_5080_ _2338_ u_core_retry_cnt_5_ _2326_ VDD VSS / sg13g2_nand2_1
X_5081_ _2339_ u_core_retry_cnt_4_ _2320_ u_core_retry_cnt_5_ VDD VSS / sg13g2_a21oi_1
X_5082_ _2340_ _2322_ _2339_ VDD VSS / sg13g2_or2_1
X_5083_ _0270_ _2327_ _2340_ _2338_ VDD VSS / sg13g2_o21ai_1
X_5084_ _2341_ u_core_retry_cnt_6_ _2326_ VDD VSS / sg13g2_nand2_1
X_5085_ _2342_ _0527_ _2321_ VDD VSS / sg13g2_xnor2_1
X_5086_ _0271_ _2327_ _2342_ _2341_ VDD VSS / sg13g2_o21ai_1
X_5087_ _2343_ u_core_retry_cnt_7_ _2326_ VDD VSS / sg13g2_nand2_1
X_5088_ _2344_ _0528_ _2323_ VDD VSS / sg13g2_xnor2_1
X_5089_ _0272_ _2327_ _2344_ _2343_ VDD VSS / sg13g2_o21ai_1
X_5090_ _2345_ u_core_trip_cnt_13_ u_core_trip_cnt_12_ u_core_trip_cnt_14_ VDD VSS / sg13g2_nand3_1
X_5091_ _2346_ u_core_trip_cnt_4_ u_core_trip_cnt_5_ u_core_trip_cnt_6_ u_core_trip_cnt_7_ VDD VSS / sg13g2_nand4_1
X_5092_ _2347_ u_core_trip_cnt_8_ u_core_trip_cnt_9_ u_core_trip_cnt_11_ u_core_trip_cnt_10_ VDD VSS / sg13g2_nand4_1
X_5093_ _2348_ u_core_trip_cnt_1_ u_core_trip_cnt_0_ u_core_trip_cnt_3_ u_core_trip_cnt_2_ VDD VSS / sg13g2_nand4_1
X_5094_ _2349_ _2345_ _2346_ _2347_ _2348_ VDD VSS / sg13g2_nor4_1
X_5095_ _2350_ u_core_trip_cnt_15_ _2349_ VDD VSS / sg13g2_nand2_1
X_5096_ _2351_ u_core_trip_cnt_1_ u_core_trip_cnt_2_ VDD VSS / sg13g2_and2_1
X_5097_ _2352_ _2346_ _2351_ VDD VSS / sg13g2_nand2b_1
X_5098_ _2353_ u_core_trip_cnt_0_ u_core_trip_cnt_3_ VDD VSS / sg13g2_nand2_1
X_5099_ _2354_ _2347_ _2352_ _2353_ VDD VSS / sg13g2_nor3_1
X_5100_ _2355_ net28 _2214_ _2350_ VDD VSS / sg13g2_and3_1
X_5101_ _2356_ net357 _1805_ VDD VSS / sg13g2_and2_1
X_5102_ _2357_ net356 _1808_ VDD VSS / sg13g2_and2_1
X_5103_ _2358_ net358 net367 _1803_ _1807_ VDD VSS / sg13g2_and4_1
X_5104_ _2359_ _2358_ VDD VSS / sg13g2_inv_1
X_5105_ _2360_ u_core_trip_cnt_0_ _2355_ VDD VSS / sg13g2_xnor2_1
X_5106_ _0273_ _2358_ _2360_ VDD VSS / sg13g2_nor2_1
X_5107_ _2361_ u_core_trip_cnt_0_ _2355_ u_core_trip_cnt_1_ VDD VSS / sg13g2_a21oi_1
X_5108_ _2362_ u_core_trip_cnt_1_ u_core_trip_cnt_0_ _2355_ VDD VSS / sg13g2_and3_1
X_5109_ _0274_ _2357_ _2361_ _2362_ VDD VSS / sg13g2_nor3_1
X_5110_ _2363_ u_core_trip_cnt_2_ _2362_ _2359_ VDD VSS / sg13g2_o21ai_1
X_5111_ _0275_ u_core_trip_cnt_2_ _2362_ _2363_ VDD VSS / sg13g2_a21oi_1
X_5112_ _2364_ u_core_trip_cnt_2_ _2362_ u_core_trip_cnt_3_ VDD VSS / sg13g2_a21oi_1
X_5113_ _2365_ u_core_trip_cnt_0_ u_core_trip_cnt_3_ _2351_ _2355_ VDD VSS / sg13g2_and4_1
X_5114_ _0276_ _2356_ _2364_ _2365_ VDD VSS / sg13g2_nor3_1
X_5115_ _2366_ u_core_trip_cnt_4_ _2365_ _2359_ VDD VSS / sg13g2_o21ai_1
X_5116_ _0277_ u_core_trip_cnt_4_ _2365_ _2366_ VDD VSS / sg13g2_a21oi_1
X_5117_ _2367_ u_core_trip_cnt_4_ _2365_ u_core_trip_cnt_5_ VDD VSS / sg13g2_a21oi_1
X_5118_ _2368_ u_core_trip_cnt_4_ u_core_trip_cnt_5_ _2365_ VDD VSS / sg13g2_and3_1
X_5119_ _0278_ _2357_ _2367_ _2368_ VDD VSS / sg13g2_nor3_1
X_5120_ _2369_ u_core_trip_cnt_6_ _2368_ VDD VSS / sg13g2_xnor2_1
X_5121_ _0279_ _2357_ _2369_ VDD VSS / sg13g2_nor2_1
X_5122_ _2370_ u_core_trip_cnt_6_ _2368_ u_core_trip_cnt_7_ VDD VSS / sg13g2_a21oi_1
X_5123_ _2371_ _2346_ _2365_ VDD VSS / sg13g2_nor2b_1
X_5124_ _0280_ _2356_ _2370_ _2371_ VDD VSS / sg13g2_nor3_1
X_5125_ _2372_ u_core_trip_cnt_8_ _2371_ _2359_ VDD VSS / sg13g2_o21ai_1
X_5126_ _2373_ u_core_trip_cnt_6_ u_core_trip_cnt_7_ u_core_trip_cnt_8_ _2368_ VDD VSS / sg13g2_and4_1
X_5127_ _0281_ u_core_trip_cnt_8_ _2371_ _2372_ VDD VSS / sg13g2_a21oi_1
X_5128_ _2374_ u_core_trip_cnt_9_ _2373_ VDD VSS / sg13g2_xnor2_1
X_5129_ _0282_ _2357_ _2374_ VDD VSS / sg13g2_nor2_1
X_5130_ _2375_ u_core_trip_cnt_9_ _2373_ u_core_trip_cnt_10_ VDD VSS / sg13g2_a21o_1
X_5131_ _2376_ u_core_trip_cnt_8_ u_core_trip_cnt_9_ u_core_trip_cnt_10_ _2371_ VDD VSS / sg13g2_nand4_1
X_5132_ _0283_ _2359_ _2375_ _2376_ VDD VSS / sg13g2_and3_1
X_5133_ _2377_ u_core_trip_cnt_11_ _2376_ VDD VSS / sg13g2_nor2b_1
X_5134_ _2378_ _2354_ _2355_ VDD VSS / sg13g2_and2_1
X_5135_ _0284_ _2358_ _2377_ _2378_ VDD VSS / sg13g2_nor3_1
X_5136_ _2379_ u_core_trip_cnt_12_ _2378_ VDD VSS / sg13g2_nor2_1
X_5137_ _2380_ u_core_trip_cnt_12_ _2378_ VDD VSS / sg13g2_and2_1
X_5138_ _0285_ _2358_ _2379_ _2380_ VDD VSS / sg13g2_nor3_1
X_5139_ _2381_ u_core_trip_cnt_13_ _2380_ _2359_ VDD VSS / sg13g2_o21ai_1
X_5140_ _0286_ u_core_trip_cnt_13_ _2380_ _2381_ VDD VSS / sg13g2_a21oi_1
X_5141_ _2382_ u_core_trip_cnt_13_ _2380_ u_core_trip_cnt_14_ VDD VSS / sg13g2_a21oi_1
X_5142_ _2383_ net28 _2214_ _2349_ VDD VSS / sg13g2_nand3_1
X_5143_ _2384_ u_core_trip_cnt_15_ _2383_ VDD VSS / sg13g2_nor2_1
X_5144_ _0287_ _2356_ _2382_ _2384_ VDD VSS / sg13g2_nor3_1
X_5145_ _0288_ _0535_ _2383_ _2357_ VDD VSS / sg13g2_a21oi_1
X_5146_ _2385_ u_core_soft_peak_5_ u_core_u_trip_soft_cnt_13_ VDD VSS / sg13g2_nand2b_1
X_5147_ _2386_ net345 _0542_ VDD VSS / sg13g2_nor2_1
X_5148_ _2387_ net346 u_core_soft_peak_0_ VDD VSS / sg13g2_nor2b_1
X_5149_ _2388_ u_core_u_trip_soft_cnt_10_ _0541_ _0542_ u_core_u_trip_soft_cnt_9_ VDD VSS / sg13g2_a22oi_1
X_5150_ _2389_ _2386_ _2387_ _2388_ VDD VSS / sg13g2_o21ai_1
X_5151_ _2390_ _0510_ u_core_soft_peak_3_ u_core_soft_peak_2_ _0511_ VDD VSS / sg13g2_a22oi_1
X_5152_ _2391_ u_core_u_trip_soft_cnt_11_ _0540_ _2389_ _2390_ VDD VSS / sg13g2_a22oi_1
X_5153_ _2392_ _0509_ u_core_soft_peak_4_ _2391_ VDD VSS / sg13g2_a21oi_1
X_5154_ _2393_ _0509_ u_core_soft_peak_4_ _2385_ VDD VSS / sg13g2_o21ai_1
X_5155_ _2394_ _2392_ _2393_ VDD VSS / sg13g2_nor2_1
X_5156_ _2395_ _0507_ u_core_soft_peak_6_ u_core_soft_peak_5_ _0508_ _2394_ VDD VSS / sg13g2_a221oi_1
X_5157_ _2396_ u_core_u_trip_soft_cnt_15_ _0539_ _2395_ VDD VSS / sg13g2_a21oi_1
X_5158_ _2397_ _0507_ u_core_soft_peak_6_ _2396_ VDD VSS / sg13g2_o21ai_1
X_5159_ _2398_ _0504_ u_core_soft_peak_8_ u_core_soft_peak_7_ _0506_ VDD VSS / sg13g2_a22oi_1
X_5160_ _2399_ u_core_soft_peak_9_ u_core_u_trip_soft_cnt_17_ VDD VSS / sg13g2_nand2b_1
X_5161_ _2400_ _0504_ u_core_soft_peak_8_ _2399_ VDD VSS / sg13g2_o21ai_1
X_5162_ _2401_ _2397_ _2398_ _2400_ VDD VSS / sg13g2_a21oi_1
X_5163_ _2402_ _0501_ u_core_soft_peak_10_ u_core_soft_peak_9_ _0503_ _2401_ VDD VSS / sg13g2_a221oi_1
X_5164_ _2403_ net344 _0537_ _0538_ u_core_u_trip_soft_cnt_18_ _2402_ VDD VSS / sg13g2_a221oi_1
X_5165_ _2404_ _0495_ u_core_soft_peak_15_ VDD VSS / sg13g2_nor2_1
X_5166_ _2405_ _0497_ u_core_soft_peak_14_ VDD VSS / sg13g2_nor2_1
X_5167_ _2406_ _0495_ u_core_soft_peak_15_ VDD VSS / sg13g2_nand2_1
X_5168_ _2407_ u_core_u_trip_soft_cnt_22_ _0536_ _2406_ VDD VSS / sg13g2_o21ai_1
X_5169_ _2408_ _2404_ _2405_ _2407_ VDD VSS / sg13g2_nor3_1
X_5170_ _2409_ u_core_soft_peak_12_ u_core_u_trip_soft_cnt_20_ VDD VSS / sg13g2_nand2b_1
X_5171_ _2410_ u_core_soft_peak_13_ u_core_u_trip_soft_cnt_21_ VDD VSS / sg13g2_nand2b_1
X_5172_ _2411_ _2409_ _2410_ VDD VSS / sg13g2_nand2_1
X_5173_ _2412_ _0498_ u_core_soft_peak_13_ VDD VSS / sg13g2_nand2_1
X_5174_ _2413_ u_core_u_trip_soft_cnt_19_ _0537_ _2412_ VDD VSS / sg13g2_o21ai_1
X_5175_ _2414_ _0500_ u_core_soft_peak_12_ VDD VSS / sg13g2_nand2_1
X_5176_ _2415_ _2408_ _2409_ _2410_ _2414_ VDD VSS / sg13g2_nand4_1
X_5177_ _2416_ _2403_ _2413_ _2415_ VDD VSS / sg13g2_nor3_1
X_5178_ _2417_ _2408_ _2411_ _2412_ VDD VSS / sg13g2_nand3_1
X_5179_ _2418_ _2404_ _2405_ _2406_ VDD VSS / sg13g2_o21ai_1
X_5180_ _2419_ _2417_ _2418_ VDD VSS / sg13g2_nand2_1
X_5181_ _2420_ net355 _1805_ VDD VSS / sg13g2_nand2_1
X_5182_ _2421_ _2420_ VDD VSS / sg13g2_inv_1
X_5183_ _2422_ _2416_ _2419_ net70 VDD VSS / sg13g2_nor3_1
X_5184_ _2423_ u_core_u_trip_soft_cnt_8_ _2420_ VDD VSS / sg13g2_and2_1
X_5185_ _0289_ _2423_ u_core_soft_peak_0_ net44 VDD VSS / sg13g2_mux2_1
X_5186_ _2424_ u_core_u_trip_soft_cnt_9_ _2420_ VDD VSS / sg13g2_and2_1
X_5187_ _0290_ _2424_ u_core_soft_peak_1_ net44 VDD VSS / sg13g2_mux2_1
X_5188_ _2425_ _0511_ net71 VDD VSS / sg13g2_nor2_1
X_5189_ _0291_ _2425_ u_core_soft_peak_2_ net44 VDD VSS / sg13g2_mux2_1
X_5190_ _2426_ _0510_ net71 VDD VSS / sg13g2_nor2_1
X_5191_ _0292_ _2426_ u_core_soft_peak_3_ net44 VDD VSS / sg13g2_mux2_1
X_5192_ _2427_ _0509_ net71 VDD VSS / sg13g2_nor2_1
X_5193_ _0293_ _2427_ u_core_soft_peak_4_ net44 VDD VSS / sg13g2_mux2_1
X_5194_ _2428_ _0508_ net71 VDD VSS / sg13g2_nor2_1
X_5195_ _0294_ _2428_ u_core_soft_peak_5_ net44 VDD VSS / sg13g2_mux2_1
X_5196_ _2429_ _0507_ net71 VDD VSS / sg13g2_nor2_1
X_5197_ _0295_ _2429_ u_core_soft_peak_6_ net44 VDD VSS / sg13g2_mux2_1
X_5198_ _2430_ _0506_ net71 VDD VSS / sg13g2_nor2_1
X_5199_ _0296_ _2430_ u_core_soft_peak_7_ net44 VDD VSS / sg13g2_mux2_1
X_5200_ _2431_ _0504_ net70 VDD VSS / sg13g2_nor2_1
X_5201_ _0297_ _2431_ u_core_soft_peak_8_ net43 VDD VSS / sg13g2_mux2_1
X_5202_ _2432_ _0503_ net70 VDD VSS / sg13g2_nor2_1
X_5203_ _0298_ _2432_ u_core_soft_peak_9_ net43 VDD VSS / sg13g2_mux2_1
X_5204_ _2433_ _0501_ net70 VDD VSS / sg13g2_nor2_1
X_5205_ _0299_ _2433_ u_core_soft_peak_10_ net43 VDD VSS / sg13g2_mux2_1
X_5206_ _2434_ u_core_u_trip_soft_cnt_19_ _2420_ VDD VSS / sg13g2_and2_1
X_5207_ _0300_ _2434_ u_core_soft_peak_11_ net43 VDD VSS / sg13g2_mux2_1
X_5208_ _2435_ _0500_ net70 VDD VSS / sg13g2_nor2_1
X_5209_ _0301_ _2435_ u_core_soft_peak_12_ net43 VDD VSS / sg13g2_mux2_1
X_5210_ _2436_ _0498_ net70 VDD VSS / sg13g2_nor2_1
X_5211_ _0302_ _2436_ u_core_soft_peak_13_ net43 VDD VSS / sg13g2_mux2_1
X_5212_ _2437_ _0497_ net70 VDD VSS / sg13g2_nor2_1
X_5213_ _0303_ _2437_ u_core_soft_peak_14_ net43 VDD VSS / sg13g2_mux2_1
X_5214_ _2438_ _0495_ net70 VDD VSS / sg13g2_nor2_1
X_5215_ _0304_ _2438_ u_core_soft_peak_15_ net43 VDD VSS / sg13g2_mux2_1
X_5216_ _2439_ u_core_u_trip_inrush_cnt_0_ _1691_ VDD VSS / sg13g2_xnor2_1
X_5217_ _0305_ net54 _2439_ VDD VSS / sg13g2_nor2_1
X_5218_ _2440_ _0557_ _0558_ _1676_ _1690_ VDD VSS / sg13g2_nor4_1
X_5219_ _2441_ u_core_u_trip_inrush_cnt_0_ _1691_ u_core_u_trip_inrush_cnt_1_ VDD VSS / sg13g2_a21oi_1
X_5220_ _0306_ net54 _2440_ _2441_ VDD VSS / sg13g2_nor3_1
X_5221_ _2442_ u_core_u_trip_inrush_cnt_2_ _2440_ VDD VSS / sg13g2_xnor2_1
X_5222_ _0307_ net52 _2442_ VDD VSS / sg13g2_nor2_1
X_5223_ _2443_ u_core_u_trip_inrush_cnt_2_ _2440_ u_core_u_trip_inrush_cnt_3_ VDD VSS / sg13g2_a21oi_1
X_5224_ _2444_ u_core_u_trip_inrush_cnt_2_ u_core_u_trip_inrush_cnt_3_ _2440_ VDD VSS / sg13g2_and3_1
X_5225_ _0308_ net53 _2443_ _2444_ VDD VSS / sg13g2_nor3_1
X_5226_ _2445_ u_core_u_trip_inrush_cnt_4_ _2444_ VDD VSS / sg13g2_and2_1
X_5227_ _2446_ u_core_u_trip_inrush_cnt_4_ _2444_ VDD VSS / sg13g2_nor2_1
X_5228_ _0309_ net53 _2445_ _2446_ VDD VSS / sg13g2_nor3_1
X_5229_ _2447_ u_core_u_trip_inrush_cnt_5_ _2445_ VDD VSS / sg13g2_xnor2_1
X_5230_ _0310_ net53 _2447_ VDD VSS / sg13g2_nor2_1
X_5231_ _2448_ u_core_u_trip_inrush_cnt_5_ _2445_ u_core_u_trip_inrush_cnt_6_ VDD VSS / sg13g2_a21oi_1
X_5232_ _2449_ u_core_u_trip_inrush_cnt_4_ u_core_u_trip_inrush_cnt_5_ u_core_u_trip_inrush_cnt_6_ _2444_ VDD VSS / sg13g2_and4_1
X_5233_ _0311_ net53 _2448_ _2449_ VDD VSS / sg13g2_nor3_1
X_5234_ _2450_ u_core_u_trip_inrush_cnt_7_ _2449_ VDD VSS / sg13g2_xnor2_1
X_5235_ _0312_ net53 _2450_ VDD VSS / sg13g2_nor2_1
X_5236_ _2451_ u_core_u_trip_inrush_cnt_7_ _2449_ u_core_u_trip_inrush_cnt_8_ VDD VSS / sg13g2_a21oi_1
X_5237_ _2452_ u_core_u_trip_inrush_cnt_7_ u_core_u_trip_inrush_cnt_8_ _2449_ VDD VSS / sg13g2_and3_1
X_5238_ _0313_ net53 _2451_ _2452_ VDD VSS / sg13g2_nor3_1
X_5239_ _2453_ u_core_u_trip_inrush_cnt_9_ _2452_ VDD VSS / sg13g2_nor2_1
X_5240_ _2454_ u_core_u_trip_inrush_cnt_9_ _2452_ VDD VSS / sg13g2_and2_1
X_5241_ _0314_ net52 _2453_ _2454_ VDD VSS / sg13g2_nor3_1
X_5242_ _2455_ u_core_u_trip_inrush_cnt_10_ _2454_ VDD VSS / sg13g2_xnor2_1
X_5243_ _0315_ net52 _2455_ VDD VSS / sg13g2_nor2_1
X_5244_ _2456_ u_core_u_trip_inrush_cnt_10_ _2454_ u_core_u_trip_inrush_cnt_11_ VDD VSS / sg13g2_a21oi_1
X_5245_ _2457_ u_core_u_trip_inrush_cnt_11_ u_core_u_trip_inrush_cnt_10_ u_core_u_trip_inrush_cnt_9_ _2452_ VDD VSS / sg13g2_and4_1
X_5246_ _0316_ net52 _2456_ _2457_ VDD VSS / sg13g2_nor3_1
X_5247_ _2458_ u_core_u_trip_inrush_cnt_12_ _2457_ VDD VSS / sg13g2_nor2_1
X_5248_ _2459_ u_core_u_trip_inrush_cnt_12_ _2457_ VDD VSS / sg13g2_and2_1
X_5249_ _0317_ net52 _2458_ _2459_ VDD VSS / sg13g2_nor3_1
X_5250_ _2460_ u_core_u_trip_inrush_cnt_13_ _2459_ VDD VSS / sg13g2_nor2_1
X_5251_ _2461_ u_core_u_trip_inrush_cnt_13_ _2459_ VDD VSS / sg13g2_and2_1
X_5252_ _0318_ net52 _2460_ _2461_ VDD VSS / sg13g2_nor3_1
X_5253_ _2462_ u_core_u_trip_inrush_cnt_14_ _2461_ VDD VSS / sg13g2_nor2_1
X_5254_ _2463_ u_core_u_trip_inrush_cnt_14_ _2461_ VDD VSS / sg13g2_and2_1
X_5255_ _0319_ net52 _2462_ _2463_ VDD VSS / sg13g2_nor3_1
X_5256_ _2464_ u_core_u_trip_inrush_cnt_15_ _2463_ VDD VSS / sg13g2_xnor2_1
X_5257_ _0320_ net52 _2464_ VDD VSS / sg13g2_nor2_1
X_5258_ _2465_ u_core_u_trip_inrush_cnt_15_ _2463_ u_core_u_trip_inrush_cnt_16_ VDD VSS / sg13g2_a21oi_1
X_5259_ _0321_ net54 _2465_ VDD VSS / sg13g2_nor2_1
X_5260_ _2466_ _0543_ _1699_ VDD VSS / sg13g2_nor2_1
X_5261_ _2467_ u_core_decay_0_ _2466_ VDD VSS / sg13g2_nor2_1
X_5262_ _2468_ _0543_ _1696_ _1701_ u_core_u_trip_decay_pre_5_ _2467_ VDD VSS / sg13g2_a221oi_1
X_5263_ _2469_ _1580_ _2468_ net122 VDD VSS / sg13g2_o21ai_1
X_5264_ _2470_ u_core_u_trip_soft_cnt_10_ net345 net346 VDD VSS / sg13g2_nand3_1
X_5265_ _2471_ u_core_u_trip_soft_cnt_14_ u_core_u_trip_soft_cnt_13_ u_core_u_trip_soft_cnt_12_ u_core_u_trip_soft_cnt_11_ VDD VSS / sg13g2_nand4_1
X_5266_ _2472_ u_core_u_trip_soft_cnt_4_ u_core_u_trip_soft_cnt_7_ u_core_u_trip_soft_cnt_6_ u_core_u_trip_soft_cnt_15_ VDD VSS / sg13g2_nand4_1
X_5267_ _2473_ _2470_ _2471_ _2472_ VDD VSS / sg13g2_nor3_1
X_5268_ _2474_ net340 u_core_u_trip_soft_cnt_23_ VDD VSS / sg13g2_nand2_1
X_5269_ _2475_ u_core_u_trip_soft_cnt_22_ u_core_u_trip_soft_cnt_21_ net343 net344 VDD VSS / sg13g2_nand4_1
X_5270_ _2476_ u_core_u_trip_soft_cnt_18_ u_core_u_trip_soft_cnt_17_ u_core_u_trip_soft_cnt_16_ u_core_u_trip_soft_cnt_1_ VDD VSS / sg13g2_nand4_1
X_5271_ _2477_ u_core_u_trip_soft_cnt_0_ u_core_u_trip_soft_cnt_3_ u_core_u_trip_soft_cnt_2_ u_core_u_trip_soft_cnt_5_ VDD VSS / sg13g2_nand4_1
X_5272_ _2478_ _2474_ _2475_ _2476_ _2477_ VDD VSS / sg13g2_nor4_1
X_5273_ _2479_ _2473_ _2478_ VDD VSS / sg13g2_nand2_1
X_5274_ _2480_ _2469_ _2479_ VDD VSS / sg13g2_nand2_1
X_5275_ _2481_ _1694_ _2480_ VDD VSS / sg13g2_or2_1
X_5276_ _2482_ _1694_ _2480_ VDD VSS / sg13g2_nor2b_1
X_5277_ _2483_ u_core_u_trip_soft_cnt_0_ net55 VDD VSS / sg13g2_nand2_1
X_5278_ _0322_ u_core_u_trip_soft_cnt_0_ net59 _2483_ VDD VSS / sg13g2_o21ai_1
X_5279_ _2484_ u_core_u_trip_soft_cnt_1_ net55 VDD VSS / sg13g2_nand2_1
X_5280_ _2485_ net335 u_core_u_trip_soft_cnt_1_ VDD VSS / sg13g2_nor2b_1
X_5281_ _2486_ net335 u_core_u_trip_soft_cnt_1_ VDD VSS / sg13g2_xnor2_1
X_5282_ _2487_ u_core_u_trip_soft_cnt_0_ _2486_ VDD VSS / sg13g2_xnor2_1
X_5283_ _0323_ net59 _2487_ _2484_ VDD VSS / sg13g2_o21ai_1
X_5284_ _2488_ u_core_u_trip_soft_cnt_2_ net55 VDD VSS / sg13g2_nand2_1
X_5285_ _2489_ net122 u_core_u_trip_soft_cnt_2_ VDD VSS / sg13g2_nand2_1
X_5286_ _2490_ net335 u_core_u_trip_soft_cnt_2_ VDD VSS / sg13g2_xor2_1
X_5287_ _2491_ u_core_u_trip_soft_cnt_0_ _2486_ _2485_ VDD VSS / sg13g2_a21oi_1
X_5288_ _2492_ _2490_ _2491_ VDD VSS / sg13g2_xnor2_1
X_5289_ _0324_ net59 _2492_ _2488_ VDD VSS / sg13g2_o21ai_1
X_5290_ _2493_ u_core_u_trip_soft_cnt_3_ net55 VDD VSS / sg13g2_nand2_1
X_5291_ _2494_ u_core_u_trip_soft_cnt_3_ net335 VDD VSS / sg13g2_nand2b_1
X_5292_ _2495_ net335 u_core_u_trip_soft_cnt_3_ VDD VSS / sg13g2_xnor2_1
X_5293_ _2496_ _2490_ _2491_ _2489_ VDD VSS / sg13g2_o21ai_1
X_5294_ _2497_ _2495_ _2496_ VDD VSS / sg13g2_xnor2_1
X_5295_ _0325_ net59 _2497_ _2493_ VDD VSS / sg13g2_o21ai_1
X_5296_ _2498_ u_core_u_trip_soft_cnt_4_ net55 VDD VSS / sg13g2_nand2_1
X_5297_ _2499_ net122 u_core_u_trip_soft_cnt_4_ VDD VSS / sg13g2_nand2_1
X_5298_ _2500_ net338 u_core_u_trip_soft_cnt_4_ VDD VSS / sg13g2_xnor2_1
X_5299_ _2501_ net338 u_core_u_trip_soft_cnt_4_ VDD VSS / sg13g2_xor2_1
X_5300_ _2502_ u_core_u_trip_soft_cnt_3_ u_core_u_trip_soft_cnt_2_ net122 VDD VSS / sg13g2_o21ai_1
X_5301_ _2503_ _2490_ _2491_ _2502_ VDD VSS / sg13g2_o21ai_1
X_5302_ _2504_ _2494_ _2503_ VDD VSS / sg13g2_nand2_1
X_5303_ _2505_ _2501_ _2504_ VDD VSS / sg13g2_xnor2_1
X_5304_ _0326_ net59 _2505_ _2498_ VDD VSS / sg13g2_o21ai_1
X_5305_ _2506_ u_core_u_trip_soft_cnt_5_ net55 VDD VSS / sg13g2_nand2_1
X_5306_ _2507_ _2501_ _2504_ _2499_ VDD VSS / sg13g2_o21ai_1
X_5307_ _2508_ net338 u_core_u_trip_soft_cnt_5_ VDD VSS / sg13g2_xnor2_1
X_5308_ _2509_ _2507_ _2508_ VDD VSS / sg13g2_xnor2_1
X_5309_ _0327_ net59 _2509_ _2506_ VDD VSS / sg13g2_o21ai_1
X_5310_ _2510_ u_core_u_trip_soft_cnt_6_ net57 VDD VSS / sg13g2_nand2_1
X_5311_ _2511_ _2494_ _2500_ _2503_ _2508_ VDD VSS / sg13g2_and4_1
X_5312_ _2512_ net338 _0505_ _2499_ VDD VSS / sg13g2_o21ai_1
X_5313_ _2513_ _2511_ _2512_ VDD VSS / sg13g2_nor2_1
X_5314_ _2514_ net122 u_core_u_trip_soft_cnt_6_ VDD VSS / sg13g2_nand2_1
X_5315_ _2515_ net338 u_core_u_trip_soft_cnt_6_ VDD VSS / sg13g2_xor2_1
X_5316_ _2516_ _2513_ _2515_ VDD VSS / sg13g2_xnor2_1
X_5317_ _0328_ net59 _2516_ _2510_ VDD VSS / sg13g2_o21ai_1
X_5318_ _2517_ u_core_u_trip_soft_cnt_7_ net57 VDD VSS / sg13g2_nand2_1
X_5319_ _2518_ net338 u_core_u_trip_soft_cnt_7_ VDD VSS / sg13g2_xnor2_1
X_5320_ _2519_ _2513_ _2515_ _2514_ VDD VSS / sg13g2_o21ai_1
X_5321_ _2520_ _2518_ _2519_ VDD VSS / sg13g2_xnor2_1
X_5322_ _0329_ net59 _2520_ _2517_ VDD VSS / sg13g2_o21ai_1
X_5323_ _2521_ net346 net57 VDD VSS / sg13g2_nand2_1
X_5324_ _2522_ net337 net346 VDD VSS / sg13g2_xor2_1
X_5325_ _2523_ _2515_ _2518_ VDD VSS / sg13g2_nor2b_1
X_5326_ _2524_ u_core_u_trip_soft_cnt_7_ u_core_u_trip_soft_cnt_6_ net122 VDD VSS / sg13g2_o21ai_1
X_5327_ _2525_ _2512_ _2524_ VDD VSS / sg13g2_nand2b_1
X_5328_ _2526_ _2511_ _2523_ _2525_ VDD VSS / sg13g2_a21oi_1
X_5329_ _2527_ _2522_ _2526_ VDD VSS / sg13g2_nor2_1
X_5330_ _2528_ _2522_ _2526_ VDD VSS / sg13g2_xnor2_1
X_5331_ _0330_ net62 _2528_ _2521_ VDD VSS / sg13g2_o21ai_1
X_5332_ _2529_ net345 net57 VDD VSS / sg13g2_nand2_1
X_5333_ _2530_ net337 net345 VDD VSS / sg13g2_xor2_1
X_5334_ _2531_ net122 net346 _2527_ VDD VSS / sg13g2_a21oi_1
X_5335_ _2532_ _2530_ _2531_ VDD VSS / sg13g2_xnor2_1
X_5336_ _0331_ net61 _2532_ _2529_ VDD VSS / sg13g2_o21ai_1
X_5337_ _2533_ net337 _0511_ VDD VSS / sg13g2_nor2_1
X_5338_ _2534_ net338 u_core_u_trip_soft_cnt_10_ VDD VSS / sg13g2_xnor2_1
X_5339_ _2535_ _2522_ _2526_ _2530_ VDD VSS / sg13g2_or3_1
X_5340_ _2536_ net337 _1570_ _2535_ VDD VSS / sg13g2_o21ai_1
X_5341_ _2537_ _2534_ _2536_ VDD VSS / sg13g2_nor2_1
X_5342_ _2538_ _2534_ _2536_ VDD VSS / sg13g2_and2_1
X_5343_ _2539_ net62 _2537_ _2538_ VDD VSS / sg13g2_nor3_1
X_5344_ _0332_ u_core_u_trip_soft_cnt_10_ net57 _2539_ VDD VSS / sg13g2_a21o_1
X_5345_ _2540_ net337 u_core_u_trip_soft_cnt_11_ VDD VSS / sg13g2_xnor2_1
X_5346_ _2541_ _2533_ _2538_ _2540_ VDD VSS / sg13g2_o21ai_1
X_5347_ _2542_ _2533_ _2538_ _2540_ VDD VSS / sg13g2_nor3_1
X_5348_ _2543_ net62 _2542_ VDD VSS / sg13g2_nor2_1
X_5349_ _2544_ u_core_u_trip_soft_cnt_11_ net57 _2541_ _2543_ VDD VSS / sg13g2_a22oi_1
X_5350_ _0333_ _2544_ VDD VSS / sg13g2_inv_1
X_5351_ _2545_ net339 u_core_u_trip_soft_cnt_12_ VDD VSS / sg13g2_xnor2_1
X_5352_ _2546_ _0511_ _1570_ net339 VDD VSS / sg13g2_a21oi_1
X_5353_ _2547_ net123 u_core_u_trip_soft_cnt_11_ _2546_ VDD VSS / sg13g2_a21oi_1
X_5354_ _2548_ _2534_ _2540_ VDD VSS / sg13g2_nand2_1
X_5355_ _2549_ _2522_ _2526_ _2530_ _2548_ VDD VSS / sg13g2_nor4_1
X_5356_ _2550_ _2549_ _2547_ VDD VSS / sg13g2_nand2b_1
X_5357_ _2551_ _2545_ _2550_ VDD VSS / sg13g2_nor2_1
X_5358_ _2552_ _2545_ _2550_ VDD VSS / sg13g2_and2_1
X_5359_ _2553_ net61 _2551_ _2552_ VDD VSS / sg13g2_nor3_1
X_5360_ _0334_ u_core_u_trip_soft_cnt_12_ net57 _2553_ VDD VSS / sg13g2_a21o_1
X_5361_ _2554_ u_core_u_trip_soft_cnt_13_ net57 VDD VSS / sg13g2_nand2_1
X_5362_ _2555_ net341 u_core_u_trip_soft_cnt_13_ VDD VSS / sg13g2_xnor2_1
X_5363_ _2556_ net123 u_core_u_trip_soft_cnt_12_ _2552_ VDD VSS / sg13g2_a21oi_1
X_5364_ _2557_ _2555_ _2556_ VDD VSS / sg13g2_xor2_1
X_5365_ _0335_ net61 _2557_ _2554_ VDD VSS / sg13g2_o21ai_1
X_5366_ _2558_ net337 u_core_u_trip_soft_cnt_14_ VDD VSS / sg13g2_xnor2_1
X_5367_ _2559_ net337 u_core_u_trip_soft_cnt_14_ VDD VSS / sg13g2_xor2_1
X_5368_ _2560_ net341 _1572_ VDD VSS / sg13g2_nor2_1
X_5369_ _2561_ _2552_ _2555_ _2560_ VDD VSS / sg13g2_a21oi_1
X_5370_ _2562_ _2561_ _2558_ VDD VSS / sg13g2_nand2b_1
X_5371_ _2563_ _2559_ _2561_ net61 VDD VSS / sg13g2_a21oi_1
X_5372_ _2564_ u_core_u_trip_soft_cnt_14_ net58 _2562_ _2563_ VDD VSS / sg13g2_a22oi_1
X_5373_ _0336_ _2564_ VDD VSS / sg13g2_inv_1
X_5374_ _2565_ u_core_u_trip_soft_cnt_15_ net58 VDD VSS / sg13g2_nand2_1
X_5375_ _2566_ net337 u_core_u_trip_soft_cnt_15_ VDD VSS / sg13g2_xnor2_1
X_5376_ _2567_ net341 _0507_ _2562_ VDD VSS / sg13g2_o21ai_1
X_5377_ _2568_ _2566_ _2567_ VDD VSS / sg13g2_xnor2_1
X_5378_ _0337_ net61 _2568_ _2565_ VDD VSS / sg13g2_o21ai_1
X_5379_ _2569_ net123 u_core_u_trip_soft_cnt_16_ VDD VSS / sg13g2_nand2_1
X_5380_ _2570_ net335 u_core_u_trip_soft_cnt_16_ VDD VSS / sg13g2_xor2_1
X_5381_ _2571_ _2545_ _2555_ _2558_ _2566_ VDD VSS / sg13g2_and4_1
X_5382_ _2572_ _0506_ _0507_ net341 VDD VSS / sg13g2_a21oi_1
X_5383_ _2573_ _2560_ _2572_ VDD VSS / sg13g2_nor2_1
X_5384_ _2574_ _2547_ _2573_ VDD VSS / sg13g2_nand2_1
X_5385_ _2575_ _2549_ _2571_ _2574_ VDD VSS / sg13g2_a21oi_1
X_5386_ _2576_ _2570_ _2575_ VDD VSS / sg13g2_or2_1
X_5387_ _2577_ _2570_ _2575_ net60 VDD VSS / sg13g2_a21oi_1
X_5388_ _2578_ u_core_u_trip_soft_cnt_16_ net55 _2576_ _2577_ VDD VSS / sg13g2_a22oi_1
X_5389_ _0338_ _2578_ VDD VSS / sg13g2_inv_1
X_5390_ _2579_ net335 u_core_u_trip_soft_cnt_17_ VDD VSS / sg13g2_xor2_1
X_5391_ _2580_ _2569_ _2576_ _2579_ VDD VSS / sg13g2_a21oi_1
X_5392_ _2581_ _2569_ _2576_ _2579_ VDD VSS / sg13g2_nand3_1
X_5393_ _2582_ net60 _2580_ VDD VSS / sg13g2_nor2_1
X_5394_ _2583_ u_core_u_trip_soft_cnt_17_ net55 _2581_ _2582_ VDD VSS / sg13g2_a22oi_1
X_5395_ _0339_ _2583_ VDD VSS / sg13g2_inv_1
X_5396_ _2584_ net336 u_core_u_trip_soft_cnt_18_ VDD VSS / sg13g2_xor2_1
X_5397_ _2585_ _2570_ _2579_ VDD VSS / sg13g2_or2_1
X_5398_ _2586_ _2575_ _2585_ VDD VSS / sg13g2_nor2_1
X_5399_ _2587_ _0503_ _0504_ net340 VDD VSS / sg13g2_a21oi_1
X_5400_ _2588_ _2586_ _2587_ VDD VSS / sg13g2_nor2_1
X_5401_ _2589_ _2584_ _2588_ VDD VSS / sg13g2_or2_1
X_5402_ _2590_ _2584_ _2588_ net60 VDD VSS / sg13g2_a21oi_1
X_5403_ _2591_ u_core_u_trip_soft_cnt_18_ net56 _2589_ _2590_ VDD VSS / sg13g2_a22oi_1
X_5404_ _0340_ _2591_ VDD VSS / sg13g2_inv_1
X_5405_ _2592_ net344 net56 VDD VSS / sg13g2_nand2_1
X_5406_ _2593_ net336 net344 VDD VSS / sg13g2_xnor2_1
X_5407_ _2594_ net336 _0501_ _2589_ VDD VSS / sg13g2_o21ai_1
X_5408_ _2595_ _2593_ _2594_ VDD VSS / sg13g2_xnor2_1
X_5409_ _0341_ net60 _2595_ _2592_ VDD VSS / sg13g2_o21ai_1
X_5410_ _2596_ net343 net56 VDD VSS / sg13g2_nand2_1
X_5411_ _2597_ net336 net343 VDD VSS / sg13g2_xor2_1
X_5412_ _2598_ _2575_ _2584_ _2585_ VDD VSS / sg13g2_nor3_1
X_5413_ _2599_ net123 _1571_ _2593_ _2598_ _2587_ VDD VSS / sg13g2_a221oi_1
X_5414_ _2600_ _2597_ _2599_ VDD VSS / sg13g2_nor2_1
X_5415_ _2601_ _2597_ _2599_ net60 VDD VSS / sg13g2_a21o_1
X_5416_ _0342_ _2600_ _2601_ _2596_ VDD VSS / sg13g2_o21ai_1
X_5417_ _2602_ u_core_u_trip_soft_cnt_21_ net56 VDD VSS / sg13g2_nand2_1
X_5418_ _2603_ net340 _0498_ VDD VSS / sg13g2_nand2_1
X_5419_ _2604_ net340 _0498_ VDD VSS / sg13g2_nor2_1
X_5420_ _2605_ net340 u_core_u_trip_soft_cnt_21_ VDD VSS / sg13g2_xor2_1
X_5421_ _2606_ net123 net343 _2600_ VDD VSS / sg13g2_a21oi_1
X_5422_ _2607_ _2605_ _2606_ VDD VSS / sg13g2_xnor2_1
X_5423_ _0343_ net60 _2607_ _2602_ VDD VSS / sg13g2_o21ai_1
X_5424_ _2608_ net123 net343 _2600_ _2603_ _2604_ VDD VSS / sg13g2_a221oi_1
X_5425_ _2609_ net340 u_core_u_trip_soft_cnt_22_ VDD VSS / sg13g2_xor2_1
X_5426_ _2610_ _2608_ _2609_ VDD VSS / sg13g2_or2_1
X_5427_ _2611_ _2608_ _2609_ net60 VDD VSS / sg13g2_a21oi_1
X_5428_ _2612_ u_core_u_trip_soft_cnt_22_ net56 _2610_ _2611_ VDD VSS / sg13g2_a22oi_1
X_5429_ _0344_ _2612_ VDD VSS / sg13g2_inv_1
X_5430_ _2613_ u_core_u_trip_soft_cnt_23_ net56 VDD VSS / sg13g2_nand2_1
X_5431_ _2614_ net340 u_core_u_trip_soft_cnt_23_ VDD VSS / sg13g2_xnor2_1
X_5432_ _2615_ net340 _0497_ _2610_ VDD VSS / sg13g2_o21ai_1
X_5433_ _2616_ _2614_ _2615_ VDD VSS / sg13g2_xnor2_1
X_5434_ _0345_ net60 _2616_ _2613_ VDD VSS / sg13g2_o21ai_1
X_5435_ _2617_ net10 _2135_ VDD VSS / sg13g2_nand2_1
X_5436_ _2618_ u_core_u_trip_hard_cnt_3_ u_core_u_trip_hard_cnt_2_ u_core_u_trip_hard_cnt_1_ u_core_u_trip_hard_cnt_0_ VDD VSS / sg13g2_and4_1
X_5437_ _2619_ u_core_u_trip_hard_cnt_4_ _2618_ VDD VSS / sg13g2_and2_1
X_5438_ _2620_ u_core_u_trip_hard_cnt_5_ _2619_ VDD VSS / sg13g2_and2_1
X_5439_ _2621_ u_core_u_trip_hard_cnt_7_ u_core_u_trip_hard_cnt_6_ _2136_ _2620_ VDD VSS / sg13g2_nand4_1
X_5440_ _2622_ _2617_ _2621_ VDD VSS / sg13g2_and2_1
X_5441_ _2623_ u_core_u_trip_hard_cnt_0_ _2138_ VDD VSS / sg13g2_nor2_1
X_5442_ _0346_ u_core_u_trip_hard_cnt_0_ _2622_ _2623_ VDD VSS / sg13g2_a21oi_1
X_5443_ _2624_ u_core_u_trip_hard_cnt_0_ _2622_ u_core_u_trip_hard_cnt_1_ VDD VSS / sg13g2_a21oi_1
X_5444_ _2625_ net10 u_core_cmp_hard_s _2135_ VDD VSS / sg13g2_o21ai_1
X_5445_ _2626_ u_core_u_trip_hard_cnt_1_ u_core_u_trip_hard_cnt_0_ _2622_ VDD VSS / sg13g2_and3_1
X_5446_ _0347_ _2624_ _2625_ _2626_ VDD VSS / sg13g2_nor3_1
X_5447_ _2627_ u_core_u_trip_hard_cnt_2_ _2626_ VDD VSS / sg13g2_nor2_1
X_5448_ _2628_ u_core_u_trip_hard_cnt_2_ _2626_ VDD VSS / sg13g2_and2_1
X_5449_ _0348_ _2625_ _2627_ _2628_ VDD VSS / sg13g2_nor3_1
X_5450_ _2629_ _2137_ _2618_ _2622_ VDD VSS / sg13g2_o21ai_1
X_5451_ _2630_ u_core_u_trip_hard_cnt_3_ _2628_ _2629_ VDD VSS / sg13g2_o21ai_1
X_5452_ _0349_ _2630_ VDD VSS / sg13g2_inv_1
X_5453_ _2631_ _2618_ _2622_ u_core_u_trip_hard_cnt_4_ VDD VSS / sg13g2_a21oi_1
X_5454_ _2632_ _2619_ _2622_ VDD VSS / sg13g2_and2_1
X_5455_ _0350_ _2625_ _2631_ _2632_ VDD VSS / sg13g2_nor3_1
X_5456_ _2633_ u_core_u_trip_hard_cnt_5_ _2632_ VDD VSS / sg13g2_nor2_1
X_5457_ _2634_ _2137_ _2620_ _2622_ VDD VSS / sg13g2_o21ai_1
X_5458_ _0351_ _2633_ _2634_ VDD VSS / sg13g2_nor2b_1
X_5459_ _2635_ _2617_ _2620_ u_core_u_trip_hard_cnt_6_ VDD VSS / sg13g2_a21oi_1
X_5460_ _2636_ _0493_ _2136_ _2634_ VDD VSS / sg13g2_a21oi_1
X_5461_ _0352_ _2635_ _2636_ VDD VSS / sg13g2_nor2_1
X_5462_ _2637_ u_core_u_trip_hard_cnt_6_ _2617_ _2620_ VDD VSS / sg13g2_nand3_1
X_5463_ _0353_ _0491_ _2637_ _2625_ VDD VSS / sg13g2_a21oi_1
X_5464_ _0354_ u_core_u_trip_clr_mask_0_ _2171_ _2300_ VDD VSS / sg13g2_o21ai_1
X_5465_ _2638_ u_core_u_trip_clr_mask_0_ u_core_u_trip_clr_mask_1_ _0512_ VDD VSS / sg13g2_nor3_1
X_5466_ _2639_ u_core_u_trip_clr_mask_0_ u_core_u_trip_clr_mask_1_ _2638_ VDD VSS / sg13g2_a21oi_1
X_5467_ _0355_ _2216_ net54 _2639_ VDD VSS / sg13g2_nor3_1
X_5468_ _2640_ u_core_u_trip_clr_mask_0_ u_core_u_trip_clr_mask_1_ u_core_u_trip_clr_mask_2_ VDD VSS / sg13g2_o21ai_1
X_5469_ _0356_ _2300_ _2640_ VDD VSS / sg13g2_nand2_1
X_5470_ _2641_ u_core_u_trip_clr_pulse_1_ _2300_ VDD VSS / sg13g2_nand2_1
X_5471_ _0357_ u_core_u_trip_clr_pulse_0_ _2641_ VDD VSS / sg13g2_nor2_1
X_5472_ _2642_ u_core_u_trip_clr_pulse_0_ u_core_u_trip_clr_pulse_1_ VDD VSS / sg13g2_nand2_1
X_5473_ _0358_ _2300_ _2642_ VDD VSS / sg13g2_nand2_1
X_5474_ _2643_ u_core_u_seu_qa_5_ u_core_u_seu_qc_5_ u_core_u_seu_qb_5_ VDD VSS / sg13g2_o21ai_1
X_5475_ u_core_u_seu_u_tmr_a_d_6_ _1129_ _2643_ VDD VSS / sg13g2_nand2_1
X_5476_ u_core_u_seu_u_tmr_a_d_2_ _0548_ _1086_ _1202_ VDD VSS / sg13g2_a21oi_1
X_5477_ _2644_ u_core_u_seu_qa_0_ u_core_u_seu_qc_0_ u_core_u_seu_qb_0_ VDD VSS / sg13g2_o21ai_1
X_5478_ u_core_u_seu_u_tmr_a_d_1_ _1166_ _2644_ VDD VSS / sg13g2_nand2_1
X_5479_ u_core_u_seu_u_tmr_a_d_3_ _0549_ _1207_ _1105_ VDD VSS / sg13g2_a21oi_1
X_5480_ _2645_ net356 _0831_ VDD VSS / sg13g2_nand2_1
X_5481_ u_core_u_seu_u_plain_d_0_ u_core_u_seu_pat_bit _2645_ VDD VSS / sg13g2_xnor2_1
X_5482_ u_core_u_seu_u_tmr_a_d_4_ _0550_ _1171_ _1214_ VDD VSS / sg13g2_a21oi_1
X_5483_ _2646_ u_core_u_seu_qa_4_ u_core_u_seu_qc_4_ u_core_u_seu_qb_4_ VDD VSS / sg13g2_o21ai_1
X_5484_ u_core_u_seu_u_tmr_a_d_5_ _1150_ _2646_ VDD VSS / sg13g2_nand2_1
X_5485__370 net369 clknet_3_7__leaf_sclk_regs VDD VSS / sg13g2_inv_1
X_5486__371 net370 clknet_3_6__leaf_sclk_regs VDD VSS / sg13g2_inv_1
X_5487__372 net371 clknet_3_6__leaf_sclk_regs VDD VSS / sg13g2_inv_1
X_5488__373 net372 clknet_3_7__leaf_sclk_regs VDD VSS / sg13g2_inv_1
X_5489__374 net373 clknet_3_7__leaf_sclk_regs VDD VSS / sg13g2_inv_1
X_5490__375 net374 clknet_3_7__leaf_sclk_regs VDD VSS / sg13g2_inv_1
X_5491__376 net375 clknet_3_7__leaf_sclk_regs VDD VSS / sg13g2_inv_1
X_5492_ u_core_u_regfile_hi_hold_0_ clknet_leaf_40_osc_clk _0066_ net302 VDD VSS / sg13g2_dfrbpq_1
X_5493_ u_core_u_regfile_hi_hold_1_ clknet_leaf_41_osc_clk _0067_ net297 VDD VSS / sg13g2_dfrbpq_1
X_5494_ u_core_u_regfile_hi_hold_2_ clknet_leaf_41_osc_clk _0068_ net297 VDD VSS / sg13g2_dfrbpq_1
X_5495_ u_core_u_regfile_hi_hold_3_ clknet_leaf_41_osc_clk _0069_ net297 VDD VSS / sg13g2_dfrbpq_1
X_5496_ u_core_u_regfile_hi_hold_4_ clknet_leaf_40_osc_clk _0070_ net297 VDD VSS / sg13g2_dfrbpq_1
X_5497_ u_core_u_regfile_hi_hold_5_ clknet_leaf_40_osc_clk _0071_ net297 VDD VSS / sg13g2_dfrbpq_1
X_5498_ u_core_u_regfile_hi_hold_6_ clknet_leaf_40_osc_clk _0072_ net302 VDD VSS / sg13g2_dfrbpq_1
X_5499_ u_core_u_regfile_hi_hold_7_ clknet_leaf_40_osc_clk _0073_ net298 VDD VSS / sg13g2_dfrbpq_1
X_5500_ u_core_u_regfile_osc_cnt_0_ clknet_leaf_29_osc_clk _0074_ net300 VDD VSS / sg13g2_dfrbpq_1
X_5501_ u_core_u_regfile_osc_cnt_1_ clknet_leaf_29_osc_clk _0075_ net300 VDD VSS / sg13g2_dfrbpq_1
X_5502_ u_core_u_regfile_osc_cnt_2_ clknet_leaf_29_osc_clk _0076_ net300 VDD VSS / sg13g2_dfrbpq_1
X_5503_ u_core_u_regfile_osc_cnt_3_ clknet_leaf_41_osc_clk _0077_ net301 VDD VSS / sg13g2_dfrbpq_1
X_5504_ u_core_u_regfile_osc_cnt_4_ clknet_leaf_41_osc_clk _0078_ net298 VDD VSS / sg13g2_dfrbpq_1
X_5505_ u_core_u_regfile_osc_cnt_5_ clknet_leaf_41_osc_clk _0079_ net296 VDD VSS / sg13g2_dfrbpq_1
X_5506_ u_core_u_regfile_osc_cnt_6_ clknet_leaf_29_osc_clk _0080_ net296 VDD VSS / sg13g2_dfrbpq_1
X_5507_ u_core_u_regfile_osc_cnt_7_ clknet_leaf_41_osc_clk _0081_ net298 VDD VSS / sg13g2_dfrbpq_1
X_5508_ u_core_u_regfile_osc_cnt_8_ clknet_leaf_41_osc_clk _0082_ net295 VDD VSS / sg13g2_dfrbpq_1
X_5509_ u_core_u_regfile_osc_cnt_9_ clknet_leaf_42_osc_clk _0083_ net223 VDD VSS / sg13g2_dfrbpq_1
X_5510_ u_core_u_regfile_osc_cnt_10_ clknet_leaf_42_osc_clk _0084_ net223 VDD VSS / sg13g2_dfrbpq_1
X_5511_ u_core_u_regfile_osc_cnt_11_ clknet_leaf_42_osc_clk _0085_ net223 VDD VSS / sg13g2_dfrbpq_1
X_5512_ u_core_u_regfile_osc_cnt_12_ clknet_leaf_42_osc_clk _0086_ net223 VDD VSS / sg13g2_dfrbpq_1
X_5513_ u_core_u_regfile_osc_cnt_13_ clknet_leaf_42_osc_clk _0087_ net295 VDD VSS / sg13g2_dfrbpq_1
X_5514_ u_core_u_regfile_osc_cnt_14_ clknet_leaf_42_osc_clk _0088_ net295 VDD VSS / sg13g2_dfrbpq_1
X_5515_ u_core_u_regfile_osc_cnt_15_ clknet_leaf_41_osc_clk _0089_ net295 VDD VSS / sg13g2_dfrbpq_1
X_5516_ _0030_ clknet_leaf_32_osc_clk _0090_ net321 VDD VSS / sg13g2_dfrbpq_1
X_5517_ u_core_dac_soft_code_1_ clknet_leaf_32_osc_clk _0091_ net322 VDD VSS / sg13g2_dfrbpq_1
X_5518_ u_core_dac_soft_code_2_ clknet_leaf_32_osc_clk _0092_ net322 VDD VSS / sg13g2_dfrbpq_1
X_5519_ _0031_ clknet_leaf_32_osc_clk _0093_ net322 VDD VSS / sg13g2_dfrbpq_1
X_5520_ _0032_ clknet_leaf_32_osc_clk _0094_ net326 VDD VSS / sg13g2_dfrbpq_1
X_5521_ u_core_dac_soft_code_5_ clknet_leaf_32_osc_clk _0095_ net326 VDD VSS / sg13g2_dfrbpq_1
X_5522_ u_core_dac_soft_code_6_ clknet_leaf_33_osc_clk _0096_ net326 VDD VSS / sg13g2_dfrbpq_1
X_5523_ _0033_ clknet_leaf_33_osc_clk _0097_ net326 VDD VSS / sg13g2_dfrbpq_1
X_5524_ u_core_dac_hard_code_0_ clknet_leaf_30_osc_clk _0098_ net315 VDD VSS / sg13g2_dfrbpq_1
X_5525_ _0034_ clknet_leaf_30_osc_clk _0099_ net315 VDD VSS / sg13g2_dfrbpq_1
X_5526_ _0035_ clknet_leaf_32_osc_clk _0100_ net321 VDD VSS / sg13g2_dfrbpq_1
X_5527_ _0036_ clknet_leaf_32_osc_clk _0101_ net315 VDD VSS / sg13g2_dfrbpq_1
X_5528_ _0037_ clknet_leaf_30_osc_clk _0102_ net315 VDD VSS / sg13g2_dfrbpq_1
X_5529_ _0038_ clknet_leaf_32_osc_clk _0103_ net315 VDD VSS / sg13g2_dfrbpq_1
X_5530_ _0039_ clknet_leaf_30_osc_clk _0104_ net315 VDD VSS / sg13g2_dfrbpq_1
X_5531_ _0040_ clknet_leaf_30_osc_clk _0105_ net315 VDD VSS / sg13g2_dfrbpq_1
X_5532_ u_core_hard_n_0_ clknet_leaf_36_osc_clk _0106_ net322 VDD VSS / sg13g2_dfrbpq_1
X_5533_ u_core_hard_n_1_ clknet_leaf_32_osc_clk _0107_ net326 VDD VSS / sg13g2_dfrbpq_1
X_5534_ _0041_ clknet_leaf_33_osc_clk _0108_ net326 VDD VSS / sg13g2_dfrbpq_1
X_5535_ u_core_hard_n_3_ clknet_leaf_36_osc_clk _0109_ net322 VDD VSS / sg13g2_dfrbpq_1
X_5536_ u_core_hard_n_4_ clknet_leaf_33_osc_clk _0110_ net327 VDD VSS / sg13g2_dfrbpq_1
X_5537_ u_core_hard_n_5_ clknet_leaf_33_osc_clk _0111_ net326 VDD VSS / sg13g2_dfrbpq_1
X_5538_ u_core_hard_n_6_ clknet_leaf_33_osc_clk _0112_ net329 VDD VSS / sg13g2_dfrbpq_1
X_5539_ u_core_hard_n_7_ clknet_leaf_32_osc_clk _0113_ net326 VDD VSS / sg13g2_dfrbpq_1
X_5540_ u_core_inrush_0_ clknet_leaf_34_osc_clk _0114_ net324 VDD VSS / sg13g2_dfrbpq_1
X_5541_ u_core_inrush_1_ clknet_leaf_35_osc_clk _0115_ net324 VDD VSS / sg13g2_dfrbpq_1
X_5542_ _0042_ clknet_leaf_35_osc_clk _0116_ net324 VDD VSS / sg13g2_dfrbpq_1
X_5543_ u_core_inrush_3_ clknet_leaf_35_osc_clk _0117_ net324 VDD VSS / sg13g2_dfrbpq_1
X_5544_ _0043_ clknet_leaf_35_osc_clk _0118_ net324 VDD VSS / sg13g2_dfrbpq_1
X_5545_ u_core_inrush_5_ clknet_leaf_35_osc_clk _0119_ net323 VDD VSS / sg13g2_dfrbpq_1
X_5546_ u_core_inrush_6_ clknet_leaf_35_osc_clk _0120_ net323 VDD VSS / sg13g2_dfrbpq_1
X_5547_ u_core_inrush_7_ clknet_leaf_35_osc_clk _0121_ net323 VDD VSS / sg13g2_dfrbpq_1
X_5548_ u_core_hold_time_0_ clknet_leaf_39_osc_clk _0122_ net303 VDD VSS / sg13g2_dfrbpq_1
X_5549_ u_core_hold_time_1_ clknet_leaf_39_osc_clk _0123_ net305 VDD VSS / sg13g2_dfrbpq_1
X_5550_ _0044_ clknet_leaf_39_osc_clk _0124_ net303 VDD VSS / sg13g2_dfrbpq_1
X_5551_ _0045_ clknet_leaf_39_osc_clk _0125_ net305 VDD VSS / sg13g2_dfrbpq_1
X_5552_ u_core_hold_time_4_ clknet_leaf_39_osc_clk _0126_ net305 VDD VSS / sg13g2_dfrbpq_1
X_5553_ u_core_hold_time_5_ clknet_leaf_38_osc_clk _0127_ net305 VDD VSS / sg13g2_dfrbpq_1
X_5554_ u_core_hold_time_6_ clknet_leaf_37_osc_clk _0128_ net323 VDD VSS / sg13g2_dfrbpq_1
X_5555_ u_core_hold_time_7_ clknet_leaf_39_osc_clk _0129_ net307 VDD VSS / sg13g2_dfrbpq_1
X_5556_ _0046_ clknet_leaf_36_osc_clk _0130_ net311 VDD VSS / sg13g2_dfrbpq_1
X_5557_ _0047_ clknet_leaf_36_osc_clk _0131_ net321 VDD VSS / sg13g2_dfrbpq_1
X_5558_ u_core_retry_max_2_ clknet_leaf_36_osc_clk _0132_ net311 VDD VSS / sg13g2_dfrbpq_1
X_5559_ u_core_retry_max_3_ clknet_leaf_37_osc_clk _0133_ net309 VDD VSS / sg13g2_dfrbpq_1
X_5560_ u_core_retry_max_4_ clknet_leaf_37_osc_clk _0134_ net311 VDD VSS / sg13g2_dfrbpq_1
X_5561_ u_core_retry_max_5_ clknet_leaf_39_osc_clk _0135_ net309 VDD VSS / sg13g2_dfrbpq_1
X_5562_ u_core_retry_max_6_ clknet_leaf_36_osc_clk _0136_ net311 VDD VSS / sg13g2_dfrbpq_1
X_5563_ u_core_retry_max_7_ clknet_leaf_40_osc_clk _0137_ net311 VDD VSS / sg13g2_dfrbpq_1
X_5564_ u_core_sense_ofs_0_ clknet_leaf_30_osc_clk _0138_ net313 VDD VSS / sg13g2_dfrbpq_1
X_5565_ u_core_sense_ofs_1_ clknet_leaf_30_osc_clk _0139_ net331 VDD VSS / sg13g2_dfrbpq_1
X_5566_ u_core_sense_ofs_2_ clknet_leaf_32_osc_clk _0140_ net322 VDD VSS / sg13g2_dfrbpq_1
X_5567_ u_core_sense_ofs_3_ clknet_leaf_32_osc_clk _0141_ net325 VDD VSS / sg13g2_dfrbpq_1
X_5568_ u_core_sense_ofs_4_ clknet_leaf_31_osc_clk _0142_ net318 VDD VSS / sg13g2_dfrbpq_1
X_5569_ u_core_sense_ofs_5_ clknet_leaf_31_osc_clk _0143_ net318 VDD VSS / sg13g2_dfrbpq_1
X_5570_ u_core_sense_ofs_6_ clknet_leaf_33_osc_clk _0144_ net327 VDD VSS / sg13g2_dfrbpq_1
X_5571_ u_core_sense_ofs_7_ clknet_leaf_33_osc_clk _0145_ net327 VDD VSS / sg13g2_dfrbpq_1
X_5572_ _0048_ clknet_leaf_26_osc_clk _0146_ net314 VDD VSS / sg13g2_dfrbpq_1
X_5573_ _0049_ clknet_leaf_29_osc_clk _0147_ net301 VDD VSS / sg13g2_dfrbpq_1
X_5574_ _0050_ clknet_leaf_27_osc_clk _0148_ net283 VDD VSS / sg13g2_dfrbpq_1
X_5575_ u_core_soft_time_3_ clknet_leaf_29_osc_clk _0149_ net301 VDD VSS / sg13g2_dfrbpq_1
X_5576_ u_core_soft_time_4_ clknet_leaf_29_osc_clk _0150_ net301 VDD VSS / sg13g2_dfrbpq_1
X_5577_ _0051_ clknet_leaf_29_osc_clk _0151_ net300 VDD VSS / sg13g2_dfrbpq_1
X_5578_ u_core_soft_time_6_ clknet_leaf_29_osc_clk _0152_ net300 VDD VSS / sg13g2_dfrbpq_1
X_5579_ u_core_soft_time_7_ clknet_leaf_29_osc_clk _0153_ net300 VDD VSS / sg13g2_dfrbpq_1
X_5580_ u_core_soft_time_8_ clknet_leaf_29_osc_clk _0154_ net301 VDD VSS / sg13g2_dfrbpq_1
X_5581_ u_core_soft_time_9_ clknet_leaf_29_osc_clk _0155_ net301 VDD VSS / sg13g2_dfrbpq_1
X_5582_ u_core_soft_time_10_ clknet_leaf_28_osc_clk _0156_ net296 VDD VSS / sg13g2_dfrbpq_1
X_5583_ u_core_soft_time_11_ clknet_leaf_28_osc_clk _0157_ net296 VDD VSS / sg13g2_dfrbpq_1
X_5584_ u_core_soft_time_12_ clknet_leaf_28_osc_clk _0158_ net296 VDD VSS / sg13g2_dfrbpq_1
X_5585_ u_core_soft_time_13_ clknet_leaf_28_osc_clk _0159_ net296 VDD VSS / sg13g2_dfrbpq_1
X_5586_ u_core_soft_time_14_ clknet_leaf_29_osc_clk _0160_ net300 VDD VSS / sg13g2_dfrbpq_1
X_5587_ u_core_soft_time_15_ clknet_leaf_28_osc_clk _0161_ net299 VDD VSS / sg13g2_dfrbpq_1
X_5588_ u_core_decay_0_ clknet_leaf_30_osc_clk _0162_ net314 VDD VSS / sg13g2_dfrbpq_1
X_5589_ u_core_decay_1_ clknet_leaf_29_osc_clk _0163_ net314 VDD VSS / sg13g2_dfrbpq_1
X_5590_ u_core_hyst_en clknet_leaf_36_osc_clk _0164_ net321 VDD VSS / sg13g2_dfrbpq_1
X_5591_ u_core_hyst_2 clknet_leaf_36_osc_clk _0165_ net321 VDD VSS / sg13g2_dfrbpq_1
X_5592_ _0052_ clknet_leaf_29_osc_clk _0166_ net301 VDD VSS / sg13g2_dfrbpq_1
X_5593_ _0053_ clknet_leaf_36_osc_clk _0167_ net321 VDD VSS / sg13g2_dfrbpq_1
X_5594_ u_core_retrig clknet_leaf_40_osc_clk _0168_ net311 VDD VSS / sg13g2_dfrbpq_1
X_5595_ net42 clknet_leaf_39_osc_clk _0169_ net304 VDD VSS / sg13g2_dfrbpq_1
X_5596_ u_core_force_trip clknet_leaf_40_osc_clk _0170_ net304 VDD VSS / sg13g2_dfrbpq_1
X_5597_ net27 clknet_leaf_40_osc_clk _0171_ net304 VDD VSS / sg13g2_dfrbpq_1
X_5598_ _0054_ clknet_leaf_26_osc_clk _0172_ net283 VDD VSS / sg13g2_dfrbpq_1
X_5599_ u_core_pattern_0_ clknet_leaf_26_osc_clk _0173_ net280 VDD VSS / sg13g2_dfrbpq_1
X_5600_ u_core_pattern_1_ clknet_leaf_26_osc_clk _0174_ net279 VDD VSS / sg13g2_dfrbpq_1
X_5601_ u_core_u_regfile_osc_div_0_ clknet_leaf_25_osc_clk _0175_ net281 VDD VSS / sg13g2_dfrbpq_1
X_5602_ u_core_u_regfile_osc_div_1_ clknet_leaf_26_osc_clk _0176_ net281 VDD VSS / sg13g2_dfrbpq_1
X_5603_ u_core_u_regfile_osc_div_2_ clknet_leaf_26_osc_clk _0177_ net281 VDD VSS / sg13g2_dfrbpq_1
X_5604_ net31 clknet_leaf_37_osc_clk _0178_ net309 VDD VSS / sg13g2_dfrbpq_1
X_5605_ net32 clknet_leaf_39_osc_clk _0179_ net307 VDD VSS / sg13g2_dfrbpq_1
X_5606_ net33 clknet_leaf_37_osc_clk _0180_ net309 VDD VSS / sg13g2_dfrbpq_1
X_5607_ _0055_ clknet_leaf_39_osc_clk _0181_ net304 VDD VSS / sg13g2_dfrbpq_1
X_5608_ _0056_ clknet_leaf_39_osc_clk _0182_ net304 VDD VSS / sg13g2_dfrbpq_1
X_5609_ _0057_ clknet_leaf_36_osc_clk _0183_ net321 VDD VSS / sg13g2_dfrbpq_1
X_5610_ net37 clknet_leaf_36_osc_clk _0184_ net321 VDD VSS / sg13g2_dfrbpq_1
X_5611_ net7 clknet_leaf_36_osc_clk _0185_ net322 VDD VSS / sg13g2_dfrbpq_1
X_5612_ u_core_u_serial_tx_0_ net369 _0186_ net317 VDD VSS / sg13g2_dfrbpq_1
X_5613_ u_core_u_serial_tx_1_ net370 _0187_ net317 VDD VSS / sg13g2_dfrbpq_1
X_5614_ u_core_u_serial_tx_2_ net371 _0188_ net317 VDD VSS / sg13g2_dfrbpq_1
X_5615_ u_core_u_serial_tx_3_ net372 _0189_ net317 VDD VSS / sg13g2_dfrbpq_1
X_5616_ u_core_u_serial_tx_4_ net373 _0190_ net318 VDD VSS / sg13g2_dfrbpq_1
X_5617_ u_core_u_serial_tx_5_ net374 _0191_ net318 VDD VSS / sg13g2_dfrbpq_1
X_5618_ u_core_u_serial_tx_6_ net375 _0192_ net318 VDD VSS / sg13g2_dfrbpq_1
X_5619_ u_core_u_serial_rd_hold_0_ clknet_leaf_31_osc_clk _0193_ net318 VDD VSS / sg13g2_dfrbpq_1
X_5620_ u_core_u_serial_rd_hold_1_ clknet_leaf_31_osc_clk _0194_ net316 VDD VSS / sg13g2_dfrbpq_1
X_5621_ u_core_u_serial_rd_hold_2_ clknet_leaf_31_osc_clk _0195_ net316 VDD VSS / sg13g2_dfrbpq_1
X_5622_ u_core_u_serial_rd_hold_3_ clknet_leaf_31_osc_clk _0196_ net318 VDD VSS / sg13g2_dfrbpq_1
X_5623_ u_core_u_serial_rd_hold_4_ clknet_leaf_31_osc_clk _0197_ net318 VDD VSS / sg13g2_dfrbpq_1
X_5624_ u_core_u_serial_rd_hold_5_ clknet_leaf_31_osc_clk _0198_ net319 VDD VSS / sg13g2_dfrbpq_1
X_5625_ u_core_u_serial_rd_hold_6_ clknet_leaf_31_osc_clk _0199_ net319 VDD VSS / sg13g2_dfrbpq_1
X_5626_ u_core_u_serial_rd_hold_7_ clknet_leaf_31_osc_clk _0200_ net319 VDD VSS / sg13g2_dfrbpq_1
X_5627_ u_core_u_serial_cmd_addr_0_ clknet_3_0__leaf_sclk_regs _0201_ net281 VDD VSS / sg13g2_dfrbpq_1
X_5628_ u_core_u_serial_cmd_addr_1_ clknet_3_3__leaf_sclk_regs _0202_ net282 VDD VSS / sg13g2_dfrbpq_1
X_5629_ u_core_u_serial_cmd_addr_2_ clknet_3_3__leaf_sclk_regs _0203_ net290 VDD VSS / sg13g2_dfrbpq_1
X_5630_ u_core_u_serial_cmd_addr_3_ clknet_3_1__leaf_sclk_regs _0204_ net282 VDD VSS / sg13g2_dfrbpq_1
X_5631_ u_core_u_serial_cmd_addr_4_ clknet_3_1__leaf_sclk_regs _0205_ net313 VDD VSS / sg13g2_dfrbpq_1
X_5632_ u_core_u_serial_cmd_addr_5_ clknet_3_4__leaf_sclk_regs _0206_ net316 VDD VSS / sg13g2_dfrbpq_1
X_5633_ u_core_u_serial_cmd_addr_6_ clknet_3_2__leaf_sclk_regs _0207_ net290 VDD VSS / sg13g2_dfrbpq_1
X_5634_ u_core_u_regfile_wr_addr_0_ clknet_3_0__leaf_sclk_regs _0208_ net282 VDD VSS / sg13g2_dfrbpq_1
X_5635_ u_core_u_regfile_wr_addr_1_ clknet_3_1__leaf_sclk_regs _0209_ net313 VDD VSS / sg13g2_dfrbpq_1
X_5636_ u_core_u_regfile_wr_addr_2_ clknet_3_5__leaf_sclk_regs _0210_ net313 VDD VSS / sg13g2_dfrbpq_1
X_5637_ u_core_u_regfile_wr_addr_3_ clknet_3_5__leaf_sclk_regs _0211_ net313 VDD VSS / sg13g2_dfrbpq_1
X_5638_ u_core_u_regfile_wr_addr_4_ clknet_3_5__leaf_sclk_regs _0212_ net313 VDD VSS / sg13g2_dfrbpq_1
X_5639_ u_core_u_regfile_wr_addr_5_ clknet_3_4__leaf_sclk_regs _0213_ net316 VDD VSS / sg13g2_dfrbpq_1
X_5640_ u_core_u_regfile_wr_addr_6_ clknet_3_4__leaf_sclk_regs _0214_ net290 VDD VSS / sg13g2_dfrbpq_1
X_5641_ u_core_rd_addr_0_ clknet_3_0__leaf_sclk_regs _0215_ net283 VDD VSS / sg13g2_dfrbpq_1
X_5642_ u_core_rd_addr_1_ clknet_3_0__leaf_sclk_regs _0216_ net283 VDD VSS / sg13g2_dfrbpq_1
X_5643_ u_core_rd_addr_2_ clknet_3_1__leaf_sclk_regs _0217_ net282 VDD VSS / sg13g2_dfrbpq_1
X_5644_ u_core_rd_addr_3_ clknet_3_1__leaf_sclk_regs _0218_ net313 VDD VSS / sg13g2_dfrbpq_1
X_5645_ u_core_rd_addr_4_ clknet_3_5__leaf_sclk_regs _0219_ net314 VDD VSS / sg13g2_dfrbpq_1
X_5646_ u_core_rd_addr_5_ clknet_3_5__leaf_sclk_regs _0220_ net314 VDD VSS / sg13g2_dfrbpq_1
X_5647_ u_core_rd_addr_6_ clknet_3_5__leaf_sclk_regs _0221_ net316 VDD VSS / sg13g2_dfrbpq_1
X_5648_ u_core_u_regfile_wr_data_0_ clknet_3_0__leaf_sclk_regs _0222_ net281 VDD VSS / sg13g2_dfrbpq_1
X_5649_ u_core_u_regfile_wr_data_1_ clknet_3_0__leaf_sclk_regs _0223_ net290 VDD VSS / sg13g2_dfrbpq_1
X_5650_ u_core_u_regfile_wr_data_2_ clknet_3_2__leaf_sclk_regs _0224_ net291 VDD VSS / sg13g2_dfrbpq_1
X_5651_ u_core_u_regfile_wr_data_3_ clknet_3_1__leaf_sclk_regs _0225_ net313 VDD VSS / sg13g2_dfrbpq_1
X_5652_ u_core_u_regfile_wr_data_4_ clknet_3_4__leaf_sclk_regs _0226_ net317 VDD VSS / sg13g2_dfrbpq_1
X_5653_ u_core_u_regfile_wr_data_5_ clknet_3_6__leaf_sclk_regs _0227_ net317 VDD VSS / sg13g2_dfrbpq_1
X_5654_ u_core_u_regfile_wr_data_6_ clknet_3_6__leaf_sclk_regs _0228_ net317 VDD VSS / sg13g2_dfrbpq_1
X_5655_ u_core_u_regfile_wr_data_7_ clknet_3_6__leaf_sclk_regs _0229_ net320 VDD VSS / sg13g2_dfrbpq_1
X_5656_ u_core_u_serial_u_sync_wr_d_0_ clknet_3_3__leaf_sclk_regs _0230_ net290 VDD VSS / sg13g2_dfrbpq_1
X_5657_ u_core_u_serial_u_sync_rd_d_0_ clknet_3_2__leaf_sclk_regs _0231_ net292 VDD VSS / sg13g2_dfrbpq_1
X_5658_ u_core_u_serial_rd_frame clknet_3_6__leaf_sclk_regs _0232_ u_core_u_serial_sclk_rst_n VDD VSS / sg13g2_dfrbpq_1
X_5659_ u_core_u_serial_idle_cnt_0_ clknet_leaf_24_osc_clk _0233_ net288 VDD VSS / sg13g2_dfrbpq_1
X_5660_ u_core_u_serial_idle_cnt_1_ clknet_leaf_24_osc_clk _0234_ net288 VDD VSS / sg13g2_dfrbpq_1
X_5661_ u_core_u_serial_idle_cnt_2_ clknet_leaf_24_osc_clk _0235_ net288 VDD VSS / sg13g2_dfrbpq_1
X_5662_ u_core_u_serial_idle_cnt_3_ clknet_leaf_24_osc_clk _0236_ net288 VDD VSS / sg13g2_dfrbpq_1
X_5663_ u_core_u_serial_idle_cnt_4_ clknet_leaf_24_osc_clk _0237_ net292 VDD VSS / sg13g2_dfrbpq_1
X_5664_ u_core_u_serial_idle_cnt_5_ clknet_leaf_24_osc_clk _0238_ net292 VDD VSS / sg13g2_dfrbpq_1
X_5665_ u_core_u_serial_idle_cnt_6_ clknet_leaf_24_osc_clk _0239_ net292 VDD VSS / sg13g2_dfrbpq_1
X_5666_ u_core_u_trip_hold_cnt_0_ clknet_leaf_46_osc_clk _0240_ net236 VDD VSS / sg13g2_dfrbpq_1
X_5667_ u_core_u_trip_hold_cnt_1_ clknet_leaf_46_osc_clk _0241_ net236 VDD VSS / sg13g2_dfrbpq_1
X_5668_ u_core_u_trip_hold_cnt_2_ clknet_leaf_47_osc_clk _0242_ net236 VDD VSS / sg13g2_dfrbpq_1
X_5669_ u_core_u_trip_hold_cnt_3_ clknet_leaf_47_osc_clk _0243_ net238 VDD VSS / sg13g2_dfrbpq_1
X_5670_ u_core_u_trip_hold_cnt_4_ clknet_leaf_47_osc_clk _0244_ net232 VDD VSS / sg13g2_dfrbpq_1
X_5671_ u_core_u_trip_hold_cnt_5_ clknet_leaf_47_osc_clk _0245_ net232 VDD VSS / sg13g2_dfrbpq_1
X_5672_ u_core_u_trip_hold_cnt_6_ clknet_leaf_47_osc_clk _0246_ net232 VDD VSS / sg13g2_dfrbpq_1
X_5673_ u_core_u_trip_hold_cnt_7_ clknet_leaf_48_osc_clk _0247_ net232 VDD VSS / sg13g2_dfrbpq_1
X_5674_ u_core_u_trip_hold_cnt_8_ clknet_leaf_48_osc_clk _0248_ net232 VDD VSS / sg13g2_dfrbpq_1
X_5675_ u_core_u_trip_hold_cnt_9_ clknet_leaf_47_osc_clk _0249_ net232 VDD VSS / sg13g2_dfrbpq_1
X_5676_ u_core_u_trip_hold_cnt_10_ clknet_leaf_47_osc_clk _0250_ net232 VDD VSS / sg13g2_dfrbpq_1
X_5677_ u_core_u_trip_hold_cnt_11_ clknet_leaf_47_osc_clk _0251_ net236 VDD VSS / sg13g2_dfrbpq_1
X_5678_ u_core_u_trip_hold_cnt_12_ clknet_leaf_47_osc_clk _0252_ net236 VDD VSS / sg13g2_dfrbpq_1
X_5679_ u_core_u_trip_hold_cnt_13_ clknet_leaf_47_osc_clk _0253_ net236 VDD VSS / sg13g2_dfrbpq_1
X_5680_ u_core_u_trip_hold_cnt_14_ clknet_leaf_47_osc_clk _0254_ net237 VDD VSS / sg13g2_dfrbpq_1
X_5681_ u_core_u_trip_hold_cnt_15_ clknet_leaf_46_osc_clk _0255_ net237 VDD VSS / sg13g2_dfrbpq_1
X_5682_ u_core_u_trip_hold_cnt_16_ clknet_leaf_46_osc_clk _0256_ net237 VDD VSS / sg13g2_dfrbpq_1
X_5683_ u_core_u_trip_hold_cnt_17_ clknet_leaf_46_osc_clk _0257_ net237 VDD VSS / sg13g2_dfrbpq_1
X_5684_ u_core_u_trip_hold_cnt_18_ clknet_leaf_46_osc_clk _0258_ net237 VDD VSS / sg13g2_dfrbpq_1
X_5685_ u_core_u_trip_hold_cnt_19_ clknet_leaf_46_osc_clk _0259_ net237 VDD VSS / sg13g2_dfrbpq_1
X_5686_ u_core_u_trip_hold_cnt_20_ clknet_leaf_46_osc_clk _0260_ net238 VDD VSS / sg13g2_dfrbpq_1
X_5687_ net38 clknet_leaf_38_osc_clk _0261_ net306 VDD VSS / sg13g2_dfrbpq_1
X_5688_ net39 clknet_leaf_38_osc_clk _0262_ net306 VDD VSS / sg13g2_dfrbpq_1
X_5689_ net40 clknet_leaf_38_osc_clk _0263_ net306 VDD VSS / sg13g2_dfrbpq_1
X_5690_ u_core_gave_up clknet_leaf_40_osc_clk _0264_ net311 VDD VSS / sg13g2_dfrbpq_1
X_5691_ u_core_retry_cnt_0_ clknet_leaf_37_osc_clk _0265_ net310 VDD VSS / sg13g2_dfrbpq_1
X_5692_ u_core_retry_cnt_1_ clknet_leaf_37_osc_clk _0266_ net310 VDD VSS / sg13g2_dfrbpq_1
X_5693_ u_core_retry_cnt_2_ clknet_leaf_37_osc_clk _0267_ net310 VDD VSS / sg13g2_dfrbpq_1
X_5694_ u_core_retry_cnt_3_ clknet_leaf_37_osc_clk _0268_ net310 VDD VSS / sg13g2_dfrbpq_1
X_5695_ u_core_retry_cnt_4_ clknet_leaf_37_osc_clk _0269_ net309 VDD VSS / sg13g2_dfrbpq_1
X_5696_ u_core_retry_cnt_5_ clknet_leaf_37_osc_clk _0270_ net309 VDD VSS / sg13g2_dfrbpq_1
X_5697_ u_core_retry_cnt_6_ clknet_leaf_37_osc_clk _0271_ net309 VDD VSS / sg13g2_dfrbpq_1
X_5698_ u_core_retry_cnt_7_ clknet_leaf_37_osc_clk _0272_ net309 VDD VSS / sg13g2_dfrbpq_1
X_5699_ u_core_trip_cnt_0_ clknet_leaf_40_osc_clk _0273_ net298 VDD VSS / sg13g2_dfrbpq_1
X_5700_ u_core_trip_cnt_1_ clknet_leaf_40_osc_clk _0274_ net297 VDD VSS / sg13g2_dfrbpq_1
X_5701_ u_core_trip_cnt_2_ clknet_leaf_41_osc_clk _0275_ net297 VDD VSS / sg13g2_dfrbpq_1
X_5702_ u_core_trip_cnt_3_ clknet_leaf_41_osc_clk _0276_ net298 VDD VSS / sg13g2_dfrbpq_1
X_5703_ u_core_trip_cnt_4_ clknet_leaf_40_osc_clk _0277_ net304 VDD VSS / sg13g2_dfrbpq_1
X_5704_ u_core_trip_cnt_5_ clknet_leaf_39_osc_clk _0278_ net303 VDD VSS / sg13g2_dfrbpq_1
X_5705_ u_core_trip_cnt_6_ clknet_leaf_39_osc_clk _0279_ net303 VDD VSS / sg13g2_dfrbpq_1
X_5706_ u_core_trip_cnt_7_ clknet_leaf_39_osc_clk _0280_ net303 VDD VSS / sg13g2_dfrbpq_1
X_5707_ u_core_trip_cnt_8_ clknet_leaf_40_osc_clk _0281_ net303 VDD VSS / sg13g2_dfrbpq_1
X_5708_ u_core_trip_cnt_9_ clknet_leaf_39_osc_clk _0282_ net303 VDD VSS / sg13g2_dfrbpq_1
X_5709_ u_core_trip_cnt_10_ clknet_leaf_45_osc_clk _0283_ net303 VDD VSS / sg13g2_dfrbpq_1
X_5710_ u_core_trip_cnt_11_ clknet_leaf_43_osc_clk _0284_ net226 VDD VSS / sg13g2_dfrbpq_1
X_5711_ u_core_trip_cnt_12_ clknet_leaf_43_osc_clk _0285_ net226 VDD VSS / sg13g2_dfrbpq_1
X_5712_ u_core_trip_cnt_13_ clknet_leaf_43_osc_clk _0286_ net226 VDD VSS / sg13g2_dfrbpq_1
X_5713_ u_core_trip_cnt_14_ clknet_leaf_43_osc_clk _0287_ net226 VDD VSS / sg13g2_dfrbpq_1
X_5714_ u_core_trip_cnt_15_ clknet_leaf_41_osc_clk _0288_ net297 VDD VSS / sg13g2_dfrbpq_1
X_5715_ u_core_soft_peak_0_ clknet_leaf_29_osc_clk _0289_ net300 VDD VSS / sg13g2_dfrbpq_1
X_5716_ u_core_soft_peak_1_ clknet_leaf_29_osc_clk _0290_ net302 VDD VSS / sg13g2_dfrbpq_1
X_5717_ u_core_soft_peak_2_ clknet_leaf_27_osc_clk _0291_ net258 VDD VSS / sg13g2_dfrbpq_1
X_5718_ u_core_soft_peak_3_ clknet_leaf_27_osc_clk _0292_ net258 VDD VSS / sg13g2_dfrbpq_1
X_5719_ u_core_soft_peak_4_ clknet_leaf_28_osc_clk _0293_ net258 VDD VSS / sg13g2_dfrbpq_1
X_5720_ u_core_soft_peak_5_ clknet_leaf_28_osc_clk _0294_ net258 VDD VSS / sg13g2_dfrbpq_1
X_5721_ u_core_soft_peak_6_ clknet_leaf_28_osc_clk _0295_ net259 VDD VSS / sg13g2_dfrbpq_1
X_5722_ u_core_soft_peak_7_ clknet_leaf_28_osc_clk _0296_ net255 VDD VSS / sg13g2_dfrbpq_1
X_5723_ u_core_soft_peak_8_ clknet_leaf_28_osc_clk _0297_ net255 VDD VSS / sg13g2_dfrbpq_1
X_5724_ u_core_soft_peak_9_ clknet_leaf_10_osc_clk _0298_ net254 VDD VSS / sg13g2_dfrbpq_1
X_5725_ u_core_soft_peak_10_ clknet_leaf_10_osc_clk _0299_ net254 VDD VSS / sg13g2_dfrbpq_1
X_5726_ u_core_soft_peak_11_ clknet_leaf_42_osc_clk _0300_ net295 VDD VSS / sg13g2_dfrbpq_1
X_5727_ u_core_soft_peak_12_ clknet_leaf_42_osc_clk _0301_ net295 VDD VSS / sg13g2_dfrbpq_1
X_5728_ u_core_soft_peak_13_ clknet_leaf_42_osc_clk _0302_ net295 VDD VSS / sg13g2_dfrbpq_1
X_5729_ u_core_soft_peak_14_ clknet_leaf_10_osc_clk _0303_ net254 VDD VSS / sg13g2_dfrbpq_1
X_5730_ u_core_soft_peak_15_ clknet_leaf_66_osc_clk _0304_ net295 VDD VSS / sg13g2_dfrbpq_1
X_5731_ u_core_u_trip_inrush_cnt_0_ clknet_leaf_35_osc_clk _0305_ net323 VDD VSS / sg13g2_dfrbpq_1
X_5732_ u_core_u_trip_inrush_cnt_1_ clknet_leaf_37_osc_clk _0306_ net323 VDD VSS / sg13g2_dfrbpq_1
X_5733_ u_core_u_trip_inrush_cnt_2_ clknet_leaf_34_osc_clk _0307_ net329 VDD VSS / sg13g2_dfrbpq_1
X_5734_ u_core_u_trip_inrush_cnt_3_ clknet_leaf_34_osc_clk _0308_ net329 VDD VSS / sg13g2_dfrbpq_1
X_5735_ u_core_u_trip_inrush_cnt_4_ clknet_leaf_34_osc_clk _0309_ net328 VDD VSS / sg13g2_dfrbpq_1
X_5736_ u_core_u_trip_inrush_cnt_5_ clknet_leaf_34_osc_clk _0310_ net328 VDD VSS / sg13g2_dfrbpq_1
X_5737_ u_core_u_trip_inrush_cnt_6_ clknet_leaf_34_osc_clk _0311_ net328 VDD VSS / sg13g2_dfrbpq_1
X_5738_ u_core_u_trip_inrush_cnt_7_ clknet_leaf_34_osc_clk _0312_ net328 VDD VSS / sg13g2_dfrbpq_1
X_5739_ u_core_u_trip_inrush_cnt_8_ clknet_leaf_34_osc_clk _0313_ net328 VDD VSS / sg13g2_dfrbpq_1
X_5740_ u_core_u_trip_inrush_cnt_9_ clknet_leaf_34_osc_clk _0314_ net329 VDD VSS / sg13g2_dfrbpq_1
X_5741_ u_core_u_trip_inrush_cnt_10_ clknet_leaf_35_osc_clk _0315_ net329 VDD VSS / sg13g2_dfrbpq_1
X_5742_ u_core_u_trip_inrush_cnt_11_ clknet_leaf_35_osc_clk _0316_ net324 VDD VSS / sg13g2_dfrbpq_1
X_5743_ u_core_u_trip_inrush_cnt_12_ clknet_leaf_35_osc_clk _0317_ net325 VDD VSS / sg13g2_dfrbpq_1
X_5744_ u_core_u_trip_inrush_cnt_13_ clknet_leaf_35_osc_clk _0318_ net325 VDD VSS / sg13g2_dfrbpq_1
X_5745_ u_core_u_trip_inrush_cnt_14_ clknet_leaf_35_osc_clk _0319_ net323 VDD VSS / sg13g2_dfrbpq_1
X_5746_ u_core_u_trip_inrush_cnt_15_ clknet_leaf_35_osc_clk _0320_ net323 VDD VSS / sg13g2_dfrbpq_1
X_5747_ u_core_u_trip_inrush_cnt_16_ clknet_leaf_35_osc_clk _0321_ net324 VDD VSS / sg13g2_dfrbpq_1
X_5748_ u_core_u_trip_soft_cnt_0_ clknet_leaf_11_osc_clk _0322_ net252 VDD VSS / sg13g2_dfrbpq_1
X_5749_ u_core_u_trip_soft_cnt_1_ clknet_leaf_11_osc_clk _0323_ net253 VDD VSS / sg13g2_dfrbpq_1
X_5750_ u_core_u_trip_soft_cnt_2_ clknet_leaf_13_osc_clk _0324_ net244 VDD VSS / sg13g2_dfrbpq_1
X_5751_ u_core_u_trip_soft_cnt_3_ clknet_leaf_12_osc_clk _0325_ net245 VDD VSS / sg13g2_dfrbpq_1
X_5752_ u_core_u_trip_soft_cnt_4_ clknet_leaf_11_osc_clk _0326_ net257 VDD VSS / sg13g2_dfrbpq_1
X_5753_ u_core_u_trip_soft_cnt_5_ clknet_leaf_12_osc_clk _0327_ net249 VDD VSS / sg13g2_dfrbpq_1
X_5754_ u_core_u_trip_soft_cnt_6_ clknet_leaf_12_osc_clk _0328_ net257 VDD VSS / sg13g2_dfrbpq_1
X_5755_ u_core_u_trip_soft_cnt_7_ clknet_leaf_11_osc_clk _0329_ net257 VDD VSS / sg13g2_dfrbpq_1
X_5756_ u_core_u_trip_soft_cnt_8_ clknet_leaf_27_osc_clk _0330_ net257 VDD VSS / sg13g2_dfrbpq_1
X_5757_ u_core_u_trip_soft_cnt_9_ clknet_leaf_27_osc_clk _0331_ net257 VDD VSS / sg13g2_dfrbpq_1
X_5758_ u_core_u_trip_soft_cnt_10_ clknet_leaf_12_osc_clk _0332_ net257 VDD VSS / sg13g2_dfrbpq_1
X_5759_ u_core_u_trip_soft_cnt_11_ clknet_leaf_27_osc_clk _0333_ net258 VDD VSS / sg13g2_dfrbpq_1
X_5760_ u_core_u_trip_soft_cnt_12_ clknet_leaf_27_osc_clk _0334_ net258 VDD VSS / sg13g2_dfrbpq_1
X_5761_ u_core_u_trip_soft_cnt_13_ clknet_leaf_27_osc_clk _0335_ net259 VDD VSS / sg13g2_dfrbpq_1
X_5762_ u_core_u_trip_soft_cnt_14_ clknet_leaf_27_osc_clk _0336_ net259 VDD VSS / sg13g2_dfrbpq_1
X_5763_ u_core_u_trip_soft_cnt_15_ clknet_leaf_28_osc_clk _0337_ net259 VDD VSS / sg13g2_dfrbpq_1
X_5764_ u_core_u_trip_soft_cnt_16_ clknet_leaf_11_osc_clk _0338_ net253 VDD VSS / sg13g2_dfrbpq_1
X_5765_ u_core_u_trip_soft_cnt_17_ clknet_leaf_11_osc_clk _0339_ net253 VDD VSS / sg13g2_dfrbpq_1
X_5766_ u_core_u_trip_soft_cnt_18_ clknet_leaf_11_osc_clk _0340_ net252 VDD VSS / sg13g2_dfrbpq_1
X_5767_ u_core_u_trip_soft_cnt_19_ clknet_leaf_10_osc_clk _0341_ net252 VDD VSS / sg13g2_dfrbpq_1
X_5768_ u_core_u_trip_soft_cnt_20_ clknet_leaf_10_osc_clk _0342_ net255 VDD VSS / sg13g2_dfrbpq_1
X_5769_ u_core_u_trip_soft_cnt_21_ clknet_leaf_10_osc_clk _0343_ net254 VDD VSS / sg13g2_dfrbpq_1
X_5770_ u_core_u_trip_soft_cnt_22_ clknet_leaf_10_osc_clk _0344_ net254 VDD VSS / sg13g2_dfrbpq_1
X_5771_ u_core_u_trip_soft_cnt_23_ clknet_leaf_28_osc_clk _0345_ net255 VDD VSS / sg13g2_dfrbpq_1
X_5772_ u_core_u_trip_hard_cnt_0_ clknet_leaf_33_osc_clk _0346_ net328 VDD VSS / sg13g2_dfrbpq_1
X_5773_ u_core_u_trip_hard_cnt_1_ clknet_leaf_33_osc_clk _0347_ net328 VDD VSS / sg13g2_dfrbpq_1
X_5774_ u_core_u_trip_hard_cnt_2_ clknet_leaf_33_osc_clk _0348_ net328 VDD VSS / sg13g2_dfrbpq_1
X_5775_ u_core_u_trip_hard_cnt_3_ clknet_leaf_33_osc_clk _0349_ net327 VDD VSS / sg13g2_dfrbpq_1
X_5776_ u_core_u_trip_hard_cnt_4_ clknet_leaf_33_osc_clk _0350_ net330 VDD VSS / sg13g2_dfrbpq_1
X_5777_ u_core_u_trip_hard_cnt_5_ clknet_leaf_34_osc_clk _0351_ net330 VDD VSS / sg13g2_dfrbpq_1
X_5778_ u_core_u_trip_hard_cnt_6_ clknet_leaf_34_osc_clk _0352_ net329 VDD VSS / sg13g2_dfrbpq_1
X_5779_ u_core_u_trip_hard_cnt_7_ clknet_leaf_34_osc_clk _0353_ net329 VDD VSS / sg13g2_dfrbpq_1
X_5780_ u_core_u_trip_clr_mask_0_ clknet_leaf_38_osc_clk _0354_ net306 VDD VSS / sg13g2_dfrbpq_1
X_5781_ u_core_u_trip_clr_mask_1_ clknet_leaf_38_osc_clk _0355_ net306 VDD VSS / sg13g2_dfrbpq_1
X_5782_ u_core_u_trip_clr_mask_2_ clknet_leaf_38_osc_clk _0356_ net306 VDD VSS / sg13g2_dfrbpq_1
X_5783_ u_core_u_trip_clr_pulse_0_ clknet_leaf_38_osc_clk _0357_ net307 VDD VSS / sg13g2_dfrbpq_1
X_5784_ u_core_u_trip_clr_pulse_1_ clknet_leaf_38_osc_clk _0358_ net307 VDD VSS / sg13g2_dfrbpq_1
X_5785_ u_core_u_seu_u_phase_qc_0_ clknet_leaf_26_osc_clk u_core_u_seu_u_phase_d_0_ net280 VDD VSS / sg13g2_dfrbpq_1
X_5786_ u_core_u_seu_u_phase_qb_0_ clknet_leaf_22_osc_clk u_core_u_seu_u_phase_d_0_ net266 VDD VSS / sg13g2_dfrbpq_1
X_5787_ u_core_u_seu_u_phase_qa_0_ clknet_leaf_15_osc_clk u_core_u_seu_u_phase_d_0_ net262 VDD VSS / sg13g2_dfrbpq_1
X_5788_ u_core_u_seu_u_fill_qc_0_ clknet_leaf_23_osc_clk u_core_u_seu_fill_cnt_n_0_ net285 VDD VSS / sg13g2_dfrbpq_1
X_5789_ u_core_u_seu_u_fill_qc_1_ clknet_leaf_23_osc_clk u_core_u_seu_fill_cnt_n_1_ net280 VDD VSS / sg13g2_dfrbpq_1
X_5790_ u_core_u_seu_u_fill_qc_2_ clknet_leaf_24_osc_clk u_core_u_seu_fill_cnt_n_2_ net288 VDD VSS / sg13g2_dfrbpq_1
X_5791_ u_core_u_seu_u_fill_qc_3_ clknet_leaf_23_osc_clk u_core_u_seu_fill_cnt_n_3_ net285 VDD VSS / sg13g2_dfrbpq_1
X_5792_ u_core_u_seu_u_fill_qc_4_ clknet_leaf_21_osc_clk u_core_u_seu_fill_cnt_n_4_ net274 VDD VSS / sg13g2_dfrbpq_1
X_5793_ u_core_u_seu_u_fill_qc_5_ clknet_leaf_23_osc_clk u_core_u_seu_fill_cnt_n_5_ net287 VDD VSS / sg13g2_dfrbpq_1
X_5794_ u_core_u_seu_u_fill_qc_6_ clknet_leaf_21_osc_clk u_core_u_seu_fill_cnt_n_6_ net276 VDD VSS / sg13g2_dfrbpq_1
X_5795_ u_core_u_seu_u_fill_qc_7_ clknet_leaf_22_osc_clk u_core_u_seu_fill_cnt_n_7_ net280 VDD VSS / sg13g2_dfrbpq_1
X_5796_ u_core_u_seu_u_fill_qc_8_ clknet_leaf_22_osc_clk u_core_u_seu_fill_cnt_n_8_ net267 VDD VSS / sg13g2_dfrbpq_1
X_5797_ u_core_u_seu_u_fill_qc_9_ clknet_leaf_21_osc_clk u_core_u_seu_fill_cnt_n_9_ net276 VDD VSS / sg13g2_dfrbpq_1
X_5798_ u_core_u_seu_u_fill_qc_10_ clknet_leaf_21_osc_clk u_core_u_seu_fill_cnt_n_10_ net274 VDD VSS / sg13g2_dfrbpq_1
X_5799_ u_core_u_seu_u_fill_qb_0_ clknet_leaf_22_osc_clk u_core_u_seu_fill_cnt_n_0_ net267 VDD VSS / sg13g2_dfrbpq_1
X_5800_ u_core_u_seu_u_fill_qb_1_ clknet_leaf_16_osc_clk u_core_u_seu_fill_cnt_n_1_ net267 VDD VSS / sg13g2_dfrbpq_1
X_5801_ u_core_u_seu_u_fill_qb_2_ clknet_leaf_22_osc_clk u_core_u_seu_fill_cnt_n_2_ net276 VDD VSS / sg13g2_dfrbpq_1
X_5802_ u_core_u_seu_u_fill_qb_3_ clknet_leaf_21_osc_clk u_core_u_seu_fill_cnt_n_3_ net276 VDD VSS / sg13g2_dfrbpq_1
X_5803_ u_core_u_seu_u_fill_qb_4_ clknet_leaf_20_osc_clk u_core_u_seu_fill_cnt_n_4_ net269 VDD VSS / sg13g2_dfrbpq_1
X_5804_ u_core_u_seu_u_fill_qb_5_ clknet_leaf_20_osc_clk u_core_u_seu_fill_cnt_n_5_ net276 VDD VSS / sg13g2_dfrbpq_1
X_5805_ u_core_u_seu_u_fill_qb_6_ clknet_leaf_17_osc_clk u_core_u_seu_fill_cnt_n_6_ net264 VDD VSS / sg13g2_dfrbpq_1
X_5806_ u_core_u_seu_u_fill_qb_7_ clknet_leaf_16_osc_clk u_core_u_seu_fill_cnt_n_7_ net266 VDD VSS / sg13g2_dfrbpq_1
X_5807_ u_core_u_seu_u_fill_qb_8_ clknet_leaf_17_osc_clk u_core_u_seu_fill_cnt_n_8_ net264 VDD VSS / sg13g2_dfrbpq_1
X_5808_ u_core_u_seu_u_fill_qb_9_ clknet_leaf_17_osc_clk u_core_u_seu_fill_cnt_n_9_ net264 VDD VSS / sg13g2_dfrbpq_1
X_5809_ u_core_u_seu_u_fill_qb_10_ clknet_leaf_22_osc_clk u_core_u_seu_fill_cnt_n_10_ net269 VDD VSS / sg13g2_dfrbpq_1
X_5810_ u_core_u_seu_u_fill_qa_0_ clknet_leaf_17_osc_clk u_core_u_seu_fill_cnt_n_0_ net262 VDD VSS / sg13g2_dfrbpq_1
X_5811_ u_core_u_seu_u_fill_qa_1_ clknet_leaf_17_osc_clk u_core_u_seu_fill_cnt_n_1_ net262 VDD VSS / sg13g2_dfrbpq_1
X_5812_ u_core_u_seu_u_fill_qa_2_ clknet_leaf_17_osc_clk u_core_u_seu_fill_cnt_n_2_ net264 VDD VSS / sg13g2_dfrbpq_1
X_5813_ u_core_u_seu_u_fill_qa_3_ clknet_leaf_18_osc_clk u_core_u_seu_fill_cnt_n_3_ net264 VDD VSS / sg13g2_dfrbpq_1
X_5814_ u_core_u_seu_u_fill_qa_4_ clknet_leaf_18_osc_clk u_core_u_seu_fill_cnt_n_4_ net263 VDD VSS / sg13g2_dfrbpq_1
X_5815_ u_core_u_seu_u_fill_qa_5_ clknet_leaf_18_osc_clk u_core_u_seu_fill_cnt_n_5_ net268 VDD VSS / sg13g2_dfrbpq_1
X_5816_ u_core_u_seu_u_fill_qa_6_ clknet_leaf_17_osc_clk u_core_u_seu_fill_cnt_n_6_ net261 VDD VSS / sg13g2_dfrbpq_1
X_5817_ u_core_u_seu_u_fill_qa_7_ clknet_leaf_15_osc_clk u_core_u_seu_fill_cnt_n_7_ net261 VDD VSS / sg13g2_dfrbpq_1
X_5818_ u_core_u_seu_u_fill_qa_8_ clknet_leaf_17_osc_clk u_core_u_seu_fill_cnt_n_8_ net261 VDD VSS / sg13g2_dfrbpq_1
X_5819_ u_core_u_seu_u_fill_qa_9_ clknet_leaf_18_osc_clk u_core_u_seu_fill_cnt_n_9_ net261 VDD VSS / sg13g2_dfrbpq_1
X_5820_ u_core_u_seu_u_fill_qa_10_ clknet_leaf_18_osc_clk u_core_u_seu_fill_cnt_n_10_ net263 VDD VSS / sg13g2_dfrbpq_1
X_5821_ u_core_u_seu_u_pat_d_qc_0_ clknet_leaf_25_osc_clk u_core_pattern_0_ net281 VDD VSS / sg13g2_dfrbpq_1
X_5822_ u_core_u_seu_u_pat_d_qc_1_ clknet_leaf_26_osc_clk u_core_pattern_1_ net280 VDD VSS / sg13g2_dfrbpq_1
X_5823_ u_core_u_seu_u_pat_d_qb_0_ clknet_leaf_22_osc_clk u_core_pattern_0_ net280 VDD VSS / sg13g2_dfrbpq_1
X_5824_ u_core_u_seu_u_pat_d_qb_1_ clknet_leaf_22_osc_clk u_core_pattern_1_ net266 VDD VSS / sg13g2_dfrbpq_1
X_5825_ u_core_u_seu_u_pat_d_qa_0_ clknet_leaf_16_osc_clk u_core_pattern_0_ net266 VDD VSS / sg13g2_dfrbpq_1
X_5826_ u_core_u_seu_u_pat_d_qa_1_ clknet_leaf_16_osc_clk u_core_pattern_1_ net249 VDD VSS / sg13g2_dfrbpq_1
X_5827_ u_core_u_seu_u_en_d_qc_0_ clknet_leaf_26_osc_clk u_core_u_seu_u_en_d_d_0_ net281 VDD VSS / sg13g2_dfrbpq_1
X_5828_ u_core_u_seu_u_en_d_qb_0_ clknet_leaf_27_osc_clk u_core_u_seu_u_en_d_d_0_ net279 VDD VSS / sg13g2_dfrbpq_1
X_5829_ u_core_u_seu_u_en_d_qa_0_ clknet_leaf_16_osc_clk u_core_u_seu_u_en_d_d_0_ net249 VDD VSS / sg13g2_dfrbpq_1
X_5830_ u_core_u_seu_plain_q_0_ clknet_leaf_9_osc_clk u_core_u_seu_u_plain_d_0_ net176 VDD VSS / sg13g2_dfrbpq_1
X_5831_ u_core_u_seu_plain_q_1_ clknet_leaf_10_osc_clk net417 net176 VDD VSS / sg13g2_dfrbpq_1
X_5832_ u_core_u_seu_plain_q_2_ clknet_leaf_66_osc_clk net377 net176 VDD VSS / sg13g2_dfrbpq_1
X_5833_ u_core_u_seu_plain_q_3_ clknet_leaf_67_osc_clk net619 net172 VDD VSS / sg13g2_dfrbpq_1
X_5834_ u_core_u_seu_plain_q_4_ clknet_leaf_65_osc_clk net392 net217 VDD VSS / sg13g2_dfrbpq_1
X_5835_ u_core_u_seu_plain_q_5_ clknet_leaf_65_osc_clk net447 net217 VDD VSS / sg13g2_dfrbpq_1
X_5836_ u_core_u_seu_plain_q_6_ clknet_leaf_62_osc_clk net632 net188 VDD VSS / sg13g2_dfrbpq_1
X_5837_ u_core_u_seu_plain_q_7_ clknet_leaf_62_osc_clk net477 net187 VDD VSS / sg13g2_dfrbpq_1
X_5838_ u_core_u_seu_plain_q_8_ clknet_leaf_63_osc_clk net430 net191 VDD VSS / sg13g2_dfrbpq_1
X_5839_ u_core_u_seu_plain_q_9_ clknet_leaf_58_osc_clk net376 net191 VDD VSS / sg13g2_dfrbpq_1
X_5840_ u_core_u_seu_plain_q_10_ clknet_leaf_58_osc_clk net565 net191 VDD VSS / sg13g2_dfrbpq_1
X_5841_ u_core_u_seu_plain_q_11_ clknet_leaf_58_osc_clk net536 net191 VDD VSS / sg13g2_dfrbpq_1
X_5842_ u_core_u_seu_plain_q_12_ clknet_leaf_58_osc_clk net473 net185 VDD VSS / sg13g2_dfrbpq_1
X_5843_ u_core_u_seu_plain_q_13_ clknet_leaf_58_osc_clk net555 net185 VDD VSS / sg13g2_dfrbpq_1
X_5844_ u_core_u_seu_plain_q_14_ clknet_leaf_58_osc_clk net572 net185 VDD VSS / sg13g2_dfrbpq_1
X_5845_ u_core_u_seu_plain_q_15_ clknet_leaf_59_osc_clk net398 net184 VDD VSS / sg13g2_dfrbpq_1
X_5846_ u_core_u_seu_plain_q_16_ clknet_leaf_59_osc_clk net480 net186 VDD VSS / sg13g2_dfrbpq_1
X_5847_ u_core_u_seu_plain_q_17_ clknet_leaf_58_osc_clk net419 net190 VDD VSS / sg13g2_dfrbpq_1
X_5848_ u_core_u_seu_plain_q_18_ clknet_leaf_58_osc_clk net623 net190 VDD VSS / sg13g2_dfrbpq_1
X_5849_ u_core_u_seu_plain_q_19_ clknet_leaf_58_osc_clk net528 net190 VDD VSS / sg13g2_dfrbpq_1
X_5850_ u_core_u_seu_plain_q_20_ clknet_leaf_59_osc_clk net415 net190 VDD VSS / sg13g2_dfrbpq_1
X_5851_ u_core_u_seu_plain_q_21_ clknet_leaf_58_osc_clk net448 net190 VDD VSS / sg13g2_dfrbpq_1
X_5852_ u_core_u_seu_plain_q_22_ clknet_leaf_58_osc_clk net484 net190 VDD VSS / sg13g2_dfrbpq_1
X_5853_ u_core_u_seu_plain_q_23_ clknet_leaf_56_osc_clk net387 net190 VDD VSS / sg13g2_dfrbpq_1
X_5854_ u_core_u_seu_plain_q_24_ clknet_leaf_57_osc_clk net421 net206 VDD VSS / sg13g2_dfrbpq_1
X_5855_ u_core_u_seu_plain_q_25_ clknet_leaf_57_osc_clk net466 net206 VDD VSS / sg13g2_dfrbpq_1
X_5856_ u_core_u_seu_plain_q_26_ clknet_leaf_56_osc_clk net443 net197 VDD VSS / sg13g2_dfrbpq_1
X_5857_ u_core_u_seu_plain_q_27_ clknet_leaf_57_osc_clk net416 net197 VDD VSS / sg13g2_dfrbpq_1
X_5858_ u_core_u_seu_plain_q_28_ clknet_leaf_54_osc_clk net383 net197 VDD VSS / sg13g2_dfrbpq_1
X_5859_ u_core_u_seu_plain_q_29_ clknet_leaf_54_osc_clk net486 net198 VDD VSS / sg13g2_dfrbpq_1
X_5860_ u_core_u_seu_plain_q_30_ clknet_leaf_52_osc_clk net399 net202 VDD VSS / sg13g2_dfrbpq_1
X_5861_ u_core_u_seu_plain_q_31_ clknet_leaf_52_osc_clk net515 net202 VDD VSS / sg13g2_dfrbpq_1
X_5862_ u_core_u_seu_plain_q_32_ clknet_leaf_52_osc_clk net534 net204 VDD VSS / sg13g2_dfrbpq_1
X_5863_ u_core_u_seu_plain_q_33_ clknet_leaf_56_osc_clk net433 net197 VDD VSS / sg13g2_dfrbpq_1
X_5864_ u_core_u_seu_plain_q_34_ clknet_leaf_56_osc_clk net561 net206 VDD VSS / sg13g2_dfrbpq_1
X_5865_ u_core_u_seu_plain_q_35_ clknet_leaf_57_osc_clk net442 net207 VDD VSS / sg13g2_dfrbpq_1
X_5866_ u_core_u_seu_plain_q_36_ clknet_leaf_57_osc_clk net574 net207 VDD VSS / sg13g2_dfrbpq_1
X_5867_ u_core_u_seu_plain_q_37_ clknet_leaf_57_osc_clk net504 net207 VDD VSS / sg13g2_dfrbpq_1
X_5868_ u_core_u_seu_plain_q_38_ clknet_leaf_52_osc_clk net379 net211 VDD VSS / sg13g2_dfrbpq_1
X_5869_ u_core_u_seu_plain_q_39_ clknet_leaf_52_osc_clk net556 net211 VDD VSS / sg13g2_dfrbpq_1
X_5870_ u_core_u_seu_plain_q_40_ clknet_leaf_52_osc_clk net560 net211 VDD VSS / sg13g2_dfrbpq_1
X_5871_ u_core_u_seu_plain_q_41_ clknet_leaf_52_osc_clk net550 net210 VDD VSS / sg13g2_dfrbpq_1
X_5872_ u_core_u_seu_plain_q_42_ clknet_leaf_52_osc_clk net544 net210 VDD VSS / sg13g2_dfrbpq_1
X_5873_ u_core_u_seu_plain_q_43_ clknet_leaf_52_osc_clk net597 net210 VDD VSS / sg13g2_dfrbpq_1
X_5874_ u_core_u_seu_plain_q_44_ clknet_leaf_53_osc_clk net380 net210 VDD VSS / sg13g2_dfrbpq_1
X_5875_ u_core_u_seu_plain_q_45_ clknet_leaf_53_osc_clk net449 net210 VDD VSS / sg13g2_dfrbpq_1
X_5876_ u_core_u_seu_plain_q_46_ clknet_leaf_53_osc_clk net455 net210 VDD VSS / sg13g2_dfrbpq_1
X_5877_ u_core_u_seu_plain_q_47_ clknet_leaf_52_osc_clk net411 net210 VDD VSS / sg13g2_dfrbpq_1
X_5878_ u_core_u_seu_plain_q_48_ clknet_leaf_52_osc_clk net454 net211 VDD VSS / sg13g2_dfrbpq_1
X_5879_ u_core_u_seu_plain_q_49_ clknet_leaf_51_osc_clk net412 net212 VDD VSS / sg13g2_dfrbpq_1
X_5880_ u_core_u_seu_plain_q_50_ clknet_leaf_51_osc_clk net617 net212 VDD VSS / sg13g2_dfrbpq_1
X_5881_ u_core_u_seu_plain_q_51_ clknet_leaf_51_osc_clk net580 net212 VDD VSS / sg13g2_dfrbpq_1
X_5882_ u_core_u_seu_plain_q_52_ clknet_leaf_51_osc_clk net510 net212 VDD VSS / sg13g2_dfrbpq_1
X_5883_ u_core_u_seu_plain_q_53_ clknet_leaf_51_osc_clk net506 net212 VDD VSS / sg13g2_dfrbpq_1
X_5884_ u_core_u_seu_plain_q_54_ clknet_leaf_50_osc_clk net625 net208 VDD VSS / sg13g2_dfrbpq_1
X_5885_ u_core_u_seu_plain_q_55_ clknet_leaf_50_osc_clk net522 net208 VDD VSS / sg13g2_dfrbpq_1
X_5886_ u_core_u_seu_plain_q_56_ clknet_leaf_50_osc_clk net529 net213 VDD VSS / sg13g2_dfrbpq_1
X_5887_ u_core_u_seu_plain_q_57_ clknet_leaf_50_osc_clk net500 net213 VDD VSS / sg13g2_dfrbpq_1
X_5888_ u_core_u_seu_plain_q_58_ clknet_leaf_50_osc_clk net503 net213 VDD VSS / sg13g2_dfrbpq_1
X_5889_ u_core_u_seu_plain_q_59_ clknet_leaf_51_osc_clk net434 net212 VDD VSS / sg13g2_dfrbpq_1
X_5890_ u_core_u_seu_plain_q_60_ clknet_leaf_57_osc_clk net501 net206 VDD VSS / sg13g2_dfrbpq_1
X_5891_ u_core_u_seu_plain_q_61_ clknet_leaf_57_osc_clk net505 net206 VDD VSS / sg13g2_dfrbpq_1
X_5892_ u_core_u_seu_plain_q_62_ clknet_leaf_57_osc_clk net514 net206 VDD VSS / sg13g2_dfrbpq_1
X_5893_ u_core_u_seu_plain_q_63_ clknet_leaf_57_osc_clk net554 net206 VDD VSS / sg13g2_dfrbpq_1
X_5894_ u_core_u_seu_plain_q_64_ clknet_leaf_57_osc_clk net521 net207 VDD VSS / sg13g2_dfrbpq_1
X_5895_ u_core_u_seu_plain_q_65_ clknet_leaf_50_osc_clk net381 net207 VDD VSS / sg13g2_dfrbpq_1
X_5896_ u_core_u_seu_plain_q_66_ clknet_leaf_50_osc_clk net562 net207 VDD VSS / sg13g2_dfrbpq_1
X_5897_ u_core_u_seu_plain_q_67_ clknet_leaf_50_osc_clk net511 net207 VDD VSS / sg13g2_dfrbpq_1
X_5898_ u_core_u_seu_plain_q_68_ clknet_leaf_50_osc_clk net496 net211 VDD VSS / sg13g2_dfrbpq_1
X_5899_ u_core_u_seu_plain_q_69_ clknet_leaf_52_osc_clk net435 net211 VDD VSS / sg13g2_dfrbpq_1
X_5900_ u_core_u_seu_plain_q_70_ clknet_leaf_52_osc_clk net513 net211 VDD VSS / sg13g2_dfrbpq_1
X_5901_ u_core_u_seu_plain_q_71_ clknet_leaf_52_osc_clk net526 net210 VDD VSS / sg13g2_dfrbpq_1
X_5902_ u_core_u_seu_plain_q_72_ clknet_leaf_52_osc_clk net576 net203 VDD VSS / sg13g2_dfrbpq_1
X_5903_ u_core_u_seu_plain_q_73_ clknet_leaf_52_osc_clk net463 net203 VDD VSS / sg13g2_dfrbpq_1
X_5904_ u_core_u_seu_plain_q_74_ clknet_leaf_53_osc_clk net378 net204 VDD VSS / sg13g2_dfrbpq_1
X_5905_ u_core_u_seu_plain_q_75_ clknet_leaf_53_osc_clk net456 net204 VDD VSS / sg13g2_dfrbpq_1
X_5906_ u_core_u_seu_plain_q_76_ clknet_leaf_53_osc_clk net607 net204 VDD VSS / sg13g2_dfrbpq_1
X_5907_ u_core_u_seu_plain_q_77_ clknet_leaf_53_osc_clk net593 net203 VDD VSS / sg13g2_dfrbpq_1
X_5908_ u_core_u_seu_plain_q_78_ clknet_leaf_53_osc_clk net575 net203 VDD VSS / sg13g2_dfrbpq_1
X_5909_ u_core_u_seu_plain_q_79_ clknet_leaf_53_osc_clk net590 net203 VDD VSS / sg13g2_dfrbpq_1
X_5910_ u_core_u_seu_plain_q_80_ clknet_leaf_53_osc_clk net601 net203 VDD VSS / sg13g2_dfrbpq_1
X_5911_ u_core_u_seu_plain_q_81_ clknet_leaf_55_osc_clk net624 net198 VDD VSS / sg13g2_dfrbpq_1
X_5912_ u_core_u_seu_plain_q_82_ clknet_leaf_55_osc_clk net502 net198 VDD VSS / sg13g2_dfrbpq_1
X_5913_ u_core_u_seu_plain_q_83_ clknet_leaf_54_osc_clk net405 net202 VDD VSS / sg13g2_dfrbpq_1
X_5914_ u_core_u_seu_plain_q_84_ clknet_leaf_54_osc_clk net577 net202 VDD VSS / sg13g2_dfrbpq_1
X_5915_ u_core_u_seu_plain_q_85_ clknet_leaf_54_osc_clk net462 net202 VDD VSS / sg13g2_dfrbpq_1
X_5916_ u_core_u_seu_plain_q_86_ clknet_leaf_54_osc_clk net569 net202 VDD VSS / sg13g2_dfrbpq_1
X_5917_ u_core_u_seu_plain_q_87_ clknet_leaf_54_osc_clk net471 net202 VDD VSS / sg13g2_dfrbpq_1
X_5918_ u_core_u_seu_plain_q_88_ clknet_leaf_52_osc_clk net394 net202 VDD VSS / sg13g2_dfrbpq_1
X_5919_ u_core_u_seu_plain_q_89_ clknet_leaf_53_osc_clk net384 net203 VDD VSS / sg13g2_dfrbpq_1
X_5920_ u_core_u_seu_plain_q_90_ clknet_leaf_53_osc_clk net495 net203 VDD VSS / sg13g2_dfrbpq_1
X_5921_ u_core_u_seu_plain_q_91_ clknet_leaf_53_osc_clk net628 net200 VDD VSS / sg13g2_dfrbpq_1
X_5922_ u_core_u_seu_plain_q_92_ clknet_leaf_48_osc_clk net638 net205 VDD VSS / sg13g2_dfrbpq_1
X_5923_ u_core_u_seu_plain_q_93_ clknet_leaf_55_osc_clk net636 net195 VDD VSS / sg13g2_dfrbpq_1
X_5924_ u_core_u_seu_plain_q_94_ clknet_leaf_55_osc_clk net598 net196 VDD VSS / sg13g2_dfrbpq_1
X_5925_ u_core_u_seu_plain_q_95_ clknet_leaf_55_osc_clk net475 net196 VDD VSS / sg13g2_dfrbpq_1
X_5926_ u_core_u_seu_plain_q_96_ clknet_leaf_54_osc_clk net393 net196 VDD VSS / sg13g2_dfrbpq_1
X_5927_ u_core_u_seu_plain_q_97_ clknet_leaf_54_osc_clk net469 net201 VDD VSS / sg13g2_dfrbpq_1
X_5928_ u_core_u_seu_plain_q_98_ clknet_leaf_54_osc_clk net608 net201 VDD VSS / sg13g2_dfrbpq_1
X_5929_ u_core_u_seu_plain_q_99_ clknet_leaf_54_osc_clk net599 net201 VDD VSS / sg13g2_dfrbpq_1
X_5930_ u_core_u_seu_plain_q_100_ clknet_leaf_53_osc_clk net459 net201 VDD VSS / sg13g2_dfrbpq_1
X_5931_ u_core_u_seu_plain_q_101_ clknet_leaf_56_osc_clk net634 net200 VDD VSS / sg13g2_dfrbpq_1
X_5932_ u_core_u_seu_plain_q_102_ clknet_leaf_50_osc_clk net618 net200 VDD VSS / sg13g2_dfrbpq_1
X_5933_ u_core_u_seu_plain_q_103_ clknet_leaf_57_osc_clk net418 net200 VDD VSS / sg13g2_dfrbpq_1
X_5934_ u_core_u_seu_plain_q_104_ clknet_leaf_49_osc_clk net404 net200 VDD VSS / sg13g2_dfrbpq_1
X_5935_ u_core_u_seu_plain_q_105_ clknet_leaf_49_osc_clk net539 net200 VDD VSS / sg13g2_dfrbpq_1
X_5936_ u_core_u_seu_plain_q_106_ clknet_leaf_54_osc_clk net633 net201 VDD VSS / sg13g2_dfrbpq_1
X_5937_ u_core_u_seu_plain_q_107_ clknet_leaf_54_osc_clk net525 net201 VDD VSS / sg13g2_dfrbpq_1
X_5938_ u_core_u_seu_plain_q_108_ clknet_leaf_53_osc_clk net428 net201 VDD VSS / sg13g2_dfrbpq_1
X_5939_ u_core_u_seu_plain_q_109_ clknet_leaf_53_osc_clk net478 net200 VDD VSS / sg13g2_dfrbpq_1
X_5940_ u_core_u_seu_plain_q_110_ clknet_leaf_50_osc_clk net630 net200 VDD VSS / sg13g2_dfrbpq_1
X_5941_ u_core_u_seu_plain_q_111_ clknet_leaf_55_osc_clk net531 net196 VDD VSS / sg13g2_dfrbpq_1
X_5942_ u_core_u_seu_plain_q_112_ clknet_leaf_54_osc_clk net420 net196 VDD VSS / sg13g2_dfrbpq_1
X_5943_ u_core_u_seu_plain_q_113_ clknet_leaf_55_osc_clk net436 net195 VDD VSS / sg13g2_dfrbpq_1
X_5944_ u_core_u_seu_plain_q_114_ clknet_leaf_55_osc_clk net582 net196 VDD VSS / sg13g2_dfrbpq_1
X_5945_ u_core_u_seu_plain_q_115_ clknet_leaf_55_osc_clk net566 net196 VDD VSS / sg13g2_dfrbpq_1
X_5946_ u_core_u_seu_plain_q_116_ clknet_leaf_55_osc_clk net573 net196 VDD VSS / sg13g2_dfrbpq_1
X_5947_ u_core_u_seu_plain_q_117_ clknet_leaf_59_osc_clk net488 net183 VDD VSS / sg13g2_dfrbpq_1
X_5948_ u_core_u_seu_plain_q_118_ clknet_leaf_55_osc_clk net385 net195 VDD VSS / sg13g2_dfrbpq_1
X_5949_ u_core_u_seu_plain_q_119_ clknet_leaf_55_osc_clk net563 net195 VDD VSS / sg13g2_dfrbpq_1
X_5950_ u_core_u_seu_plain_q_120_ clknet_leaf_55_osc_clk net614 net195 VDD VSS / sg13g2_dfrbpq_1
X_5951_ u_core_u_seu_plain_q_121_ clknet_leaf_56_osc_clk net426 net183 VDD VSS / sg13g2_dfrbpq_1
X_5952_ u_core_u_seu_plain_q_122_ clknet_leaf_56_osc_clk net519 net195 VDD VSS / sg13g2_dfrbpq_1
X_5953_ u_core_u_seu_plain_q_123_ clknet_leaf_56_osc_clk net465 net195 VDD VSS / sg13g2_dfrbpq_1
X_5954_ u_core_u_seu_plain_q_124_ clknet_leaf_56_osc_clk net553 net195 VDD VSS / sg13g2_dfrbpq_1
X_5955_ u_core_u_seu_plain_q_125_ clknet_leaf_56_osc_clk net493 net197 VDD VSS / sg13g2_dfrbpq_1
X_5956_ u_core_u_seu_plain_q_126_ clknet_leaf_55_osc_clk net396 net198 VDD VSS / sg13g2_dfrbpq_1
X_5957_ u_core_u_seu_plain_q_127_ clknet_leaf_55_osc_clk net595 net198 VDD VSS / sg13g2_dfrbpq_1
X_5958_ u_core_u_seu_plain_q_128_ clknet_leaf_54_osc_clk net395 net198 VDD VSS / sg13g2_dfrbpq_1
X_5959_ u_core_u_seu_plain_q_129_ clknet_leaf_60_osc_clk net629 net185 VDD VSS / sg13g2_dfrbpq_1
X_5960_ u_core_u_seu_plain_q_130_ clknet_leaf_59_osc_clk net402 net184 VDD VSS / sg13g2_dfrbpq_1
X_5961_ u_core_u_seu_plain_q_131_ clknet_leaf_59_osc_clk net592 net184 VDD VSS / sg13g2_dfrbpq_1
X_5962_ u_core_u_seu_plain_q_132_ clknet_leaf_59_osc_clk net589 net184 VDD VSS / sg13g2_dfrbpq_1
X_5963_ u_core_u_seu_plain_q_133_ clknet_leaf_56_osc_clk net389 net184 VDD VSS / sg13g2_dfrbpq_1
X_5964_ u_core_u_seu_plain_q_134_ clknet_leaf_56_osc_clk net579 net184 VDD VSS / sg13g2_dfrbpq_1
X_5965_ u_core_u_seu_plain_q_135_ clknet_leaf_60_osc_clk net439 net180 VDD VSS / sg13g2_dfrbpq_1
X_5966_ u_core_u_seu_plain_q_136_ clknet_leaf_60_osc_clk net605 net185 VDD VSS / sg13g2_dfrbpq_1
X_5967_ u_core_u_seu_plain_q_137_ clknet_leaf_60_osc_clk net479 net182 VDD VSS / sg13g2_dfrbpq_1
X_5968_ u_core_u_seu_plain_q_138_ clknet_leaf_60_osc_clk net578 net182 VDD VSS / sg13g2_dfrbpq_1
X_5969_ u_core_u_seu_plain_q_139_ clknet_leaf_59_osc_clk net390 net182 VDD VSS / sg13g2_dfrbpq_1
X_5970_ u_core_u_seu_plain_q_140_ clknet_leaf_60_osc_clk net445 net182 VDD VSS / sg13g2_dfrbpq_1
X_5971_ u_core_u_seu_plain_q_141_ clknet_leaf_60_osc_clk net487 net182 VDD VSS / sg13g2_dfrbpq_1
X_5972_ u_core_u_seu_plain_q_142_ clknet_leaf_59_osc_clk net424 net182 VDD VSS / sg13g2_dfrbpq_1
X_5973_ u_core_u_seu_plain_q_143_ clknet_leaf_60_osc_clk net490 net182 VDD VSS / sg13g2_dfrbpq_1
X_5974_ u_core_u_seu_plain_q_144_ clknet_leaf_59_osc_clk net401 net183 VDD VSS / sg13g2_dfrbpq_1
X_5975_ u_core_u_seu_plain_q_145_ clknet_leaf_59_osc_clk net481 net183 VDD VSS / sg13g2_dfrbpq_1
X_5976_ u_core_u_seu_plain_q_146_ clknet_leaf_59_osc_clk net533 net183 VDD VSS / sg13g2_dfrbpq_1
X_5977_ u_core_u_seu_plain_q_147_ clknet_leaf_56_osc_clk net391 net183 VDD VSS / sg13g2_dfrbpq_1
X_5978_ u_core_u_seu_plain_q_148_ clknet_leaf_60_osc_clk net429 net181 VDD VSS / sg13g2_dfrbpq_1
X_5979_ u_core_u_seu_plain_q_149_ clknet_leaf_60_osc_clk net491 net181 VDD VSS / sg13g2_dfrbpq_1
X_5980_ u_core_u_seu_plain_q_150_ clknet_leaf_60_osc_clk net461 net181 VDD VSS / sg13g2_dfrbpq_1
X_5981_ u_core_u_seu_plain_q_151_ clknet_leaf_60_osc_clk net564 net182 VDD VSS / sg13g2_dfrbpq_1
X_5982_ u_core_u_seu_plain_q_152_ clknet_leaf_59_osc_clk net400 net183 VDD VSS / sg13g2_dfrbpq_1
X_5983_ u_core_u_seu_plain_q_153_ clknet_leaf_59_osc_clk net615 net186 VDD VSS / sg13g2_dfrbpq_1
X_5984_ u_core_u_seu_plain_q_154_ clknet_leaf_59_osc_clk net552 net184 VDD VSS / sg13g2_dfrbpq_1
X_5985_ u_core_u_seu_plain_q_155_ clknet_leaf_56_osc_clk net388 net184 VDD VSS / sg13g2_dfrbpq_1
X_5986_ u_core_u_seu_plain_q_156_ clknet_leaf_56_osc_clk net609 net197 VDD VSS / sg13g2_dfrbpq_1
X_5987_ u_core_u_seu_plain_q_157_ clknet_leaf_56_osc_clk net542 net197 VDD VSS / sg13g2_dfrbpq_1
X_5988_ u_core_u_seu_plain_q_158_ clknet_leaf_56_osc_clk net568 net197 VDD VSS / sg13g2_dfrbpq_1
X_5989_ u_core_u_seu_plain_q_159_ clknet_leaf_57_osc_clk net603 net207 VDD VSS / sg13g2_dfrbpq_1
X_5990_ u_core_u_seu_plain_q_160_ clknet_leaf_57_osc_clk net616 net206 VDD VSS / sg13g2_dfrbpq_1
X_5991_ u_core_u_seu_plain_q_161_ clknet_leaf_49_osc_clk net382 net208 VDD VSS / sg13g2_dfrbpq_1
X_5992_ u_core_u_seu_plain_q_162_ clknet_leaf_50_osc_clk net427 net208 VDD VSS / sg13g2_dfrbpq_1
X_5993_ u_core_u_seu_plain_q_163_ clknet_leaf_49_osc_clk net432 net209 VDD VSS / sg13g2_dfrbpq_1
X_5994_ u_core_u_seu_plain_q_164_ clknet_leaf_49_osc_clk net527 net209 VDD VSS / sg13g2_dfrbpq_1
X_5995_ u_core_u_seu_plain_q_165_ clknet_leaf_50_osc_clk net438 net213 VDD VSS / sg13g2_dfrbpq_1
X_5996_ u_core_u_seu_plain_q_166_ clknet_leaf_50_osc_clk net545 net213 VDD VSS / sg13g2_dfrbpq_1
X_5997_ u_core_u_seu_plain_q_167_ clknet_leaf_50_osc_clk net476 net213 VDD VSS / sg13g2_dfrbpq_1
X_5998_ u_core_u_seu_plain_q_168_ clknet_leaf_50_osc_clk net567 net213 VDD VSS / sg13g2_dfrbpq_1
X_5999_ u_core_u_seu_plain_q_169_ clknet_leaf_51_osc_clk net425 net213 VDD VSS / sg13g2_dfrbpq_1
X_6000_ u_core_u_seu_plain_q_170_ clknet_leaf_51_osc_clk net457 net212 VDD VSS / sg13g2_dfrbpq_1
X_6001_ u_core_u_seu_plain_q_171_ clknet_leaf_51_osc_clk net507 net212 VDD VSS / sg13g2_dfrbpq_1
X_6002_ u_core_u_seu_plain_q_172_ clknet_leaf_51_osc_clk net537 net214 VDD VSS / sg13g2_dfrbpq_1
X_6003_ u_core_u_seu_plain_q_173_ clknet_leaf_51_osc_clk net489 net214 VDD VSS / sg13g2_dfrbpq_1
X_6004_ u_core_u_seu_plain_q_174_ clknet_leaf_51_osc_clk net627 net230 VDD VSS / sg13g2_dfrbpq_1
X_6005_ u_core_u_seu_plain_q_175_ clknet_leaf_51_osc_clk net535 net230 VDD VSS / sg13g2_dfrbpq_1
X_6006_ u_core_u_seu_plain_q_176_ clknet_leaf_51_osc_clk net494 net230 VDD VSS / sg13g2_dfrbpq_1
X_6007_ u_core_u_seu_plain_q_177_ clknet_leaf_51_osc_clk net453 net230 VDD VSS / sg13g2_dfrbpq_1
X_6008_ u_core_u_seu_plain_q_178_ clknet_leaf_50_osc_clk net583 net231 VDD VSS / sg13g2_dfrbpq_1
X_6009_ u_core_u_seu_plain_q_179_ clknet_leaf_48_osc_clk net410 net231 VDD VSS / sg13g2_dfrbpq_1
X_6010_ u_core_u_seu_plain_q_180_ clknet_leaf_48_osc_clk net482 net230 VDD VSS / sg13g2_dfrbpq_1
X_6011_ u_core_u_seu_plain_q_181_ clknet_leaf_48_osc_clk net559 net230 VDD VSS / sg13g2_dfrbpq_1
X_6012_ u_core_u_seu_plain_q_182_ clknet_leaf_48_osc_clk net499 net230 VDD VSS / sg13g2_dfrbpq_1
X_6013_ u_core_u_seu_plain_q_183_ clknet_leaf_48_osc_clk net610 net230 VDD VSS / sg13g2_dfrbpq_1
X_6014_ u_core_u_seu_plain_q_184_ clknet_leaf_14_osc_clk u_core_u_seu_plain_q_183_ net241 VDD VSS / sg13g2_dfrbpq_1
X_6015_ u_core_u_seu_plain_q_185_ clknet_leaf_14_osc_clk net472 net242 VDD VSS / sg13g2_dfrbpq_1
X_6016_ u_core_u_seu_plain_q_186_ clknet_leaf_14_osc_clk net451 net242 VDD VSS / sg13g2_dfrbpq_1
X_6017_ u_core_u_seu_plain_q_187_ clknet_leaf_14_osc_clk net602 net242 VDD VSS / sg13g2_dfrbpq_1
X_6018_ u_core_u_seu_plain_q_188_ clknet_leaf_14_osc_clk net588 net242 VDD VSS / sg13g2_dfrbpq_1
X_6019_ u_core_u_seu_plain_q_189_ clknet_leaf_15_osc_clk net626 net261 VDD VSS / sg13g2_dfrbpq_1
X_6020_ u_core_u_seu_plain_q_190_ clknet_leaf_17_osc_clk net407 net261 VDD VSS / sg13g2_dfrbpq_1
X_6021_ u_core_u_seu_plain_q_191_ clknet_leaf_17_osc_clk net516 net261 VDD VSS / sg13g2_dfrbpq_1
X_6022_ u_core_u_seu_plain_q_192_ clknet_leaf_17_osc_clk net571 net261 VDD VSS / sg13g2_dfrbpq_1
X_6023_ u_core_u_seu_plain_q_193_ clknet_leaf_17_osc_clk net508 net262 VDD VSS / sg13g2_dfrbpq_1
X_6024_ u_core_u_seu_plain_q_194_ clknet_leaf_17_osc_clk net604 net262 VDD VSS / sg13g2_dfrbpq_1
X_6025_ u_core_u_seu_plain_q_195_ clknet_leaf_17_osc_clk net581 net262 VDD VSS / sg13g2_dfrbpq_1
X_6026_ u_core_u_seu_plain_q_196_ clknet_leaf_18_osc_clk net386 net263 VDD VSS / sg13g2_dfrbpq_1
X_6027_ u_core_u_seu_plain_q_197_ clknet_leaf_18_osc_clk net458 net263 VDD VSS / sg13g2_dfrbpq_1
X_6028_ u_core_u_seu_plain_q_198_ clknet_leaf_17_osc_clk net422 net263 VDD VSS / sg13g2_dfrbpq_1
X_6029_ u_core_u_seu_plain_q_199_ clknet_leaf_18_osc_clk net406 net263 VDD VSS / sg13g2_dfrbpq_1
X_6030_ u_core_u_seu_plain_q_200_ clknet_leaf_18_osc_clk net468 net263 VDD VSS / sg13g2_dfrbpq_1
X_6031_ u_core_u_seu_plain_q_201_ clknet_leaf_18_osc_clk net530 net263 VDD VSS / sg13g2_dfrbpq_1
X_6032_ u_core_u_seu_plain_q_202_ clknet_leaf_18_osc_clk net621 net268 VDD VSS / sg13g2_dfrbpq_1
X_6033_ u_core_u_seu_plain_q_203_ clknet_leaf_18_osc_clk net611 net268 VDD VSS / sg13g2_dfrbpq_1
X_6034_ u_core_u_seu_plain_q_204_ clknet_leaf_18_osc_clk net631 net268 VDD VSS / sg13g2_dfrbpq_1
X_6035_ u_core_u_seu_plain_q_205_ clknet_leaf_18_osc_clk net586 net268 VDD VSS / sg13g2_dfrbpq_1
X_6036_ u_core_u_seu_plain_q_206_ clknet_leaf_19_osc_clk net409 net268 VDD VSS / sg13g2_dfrbpq_1
X_6037_ u_core_u_seu_plain_q_207_ clknet_leaf_19_osc_clk net596 net268 VDD VSS / sg13g2_dfrbpq_1
X_6038_ u_core_u_seu_plain_q_208_ clknet_leaf_19_osc_clk net452 net268 VDD VSS / sg13g2_dfrbpq_1
X_6039_ u_core_u_seu_plain_q_209_ clknet_leaf_19_osc_clk net606 net270 VDD VSS / sg13g2_dfrbpq_1
X_6040_ u_core_u_seu_plain_q_210_ clknet_leaf_19_osc_clk net467 net270 VDD VSS / sg13g2_dfrbpq_1
X_6041_ u_core_u_seu_plain_q_211_ clknet_leaf_20_osc_clk net547 net270 VDD VSS / sg13g2_dfrbpq_1
X_6042_ u_core_u_seu_plain_q_212_ clknet_leaf_19_osc_clk net622 net270 VDD VSS / sg13g2_dfrbpq_1
X_6043_ u_core_u_seu_plain_q_213_ clknet_leaf_19_osc_clk net594 net270 VDD VSS / sg13g2_dfrbpq_1
X_6044_ u_core_u_seu_plain_q_214_ clknet_leaf_19_osc_clk net551 net270 VDD VSS / sg13g2_dfrbpq_1
X_6045_ u_core_u_seu_plain_q_215_ clknet_leaf_19_osc_clk net464 net270 VDD VSS / sg13g2_dfrbpq_1
X_6046_ u_core_u_seu_plain_q_216_ clknet_leaf_19_osc_clk net585 net271 VDD VSS / sg13g2_dfrbpq_1
X_6047_ u_core_u_seu_plain_q_217_ clknet_leaf_19_osc_clk net570 net271 VDD VSS / sg13g2_dfrbpq_1
X_6048_ u_core_u_seu_plain_q_218_ clknet_leaf_19_osc_clk net474 net271 VDD VSS / sg13g2_dfrbpq_1
X_6049_ u_core_u_seu_plain_q_219_ clknet_leaf_20_osc_clk net403 net271 VDD VSS / sg13g2_dfrbpq_1
X_6050_ u_core_u_seu_plain_q_220_ clknet_leaf_20_osc_clk net549 net273 VDD VSS / sg13g2_dfrbpq_1
X_6051_ u_core_u_seu_plain_q_221_ clknet_leaf_20_osc_clk net587 net273 VDD VSS / sg13g2_dfrbpq_1
X_6052_ u_core_u_seu_plain_q_222_ clknet_leaf_20_osc_clk net591 net273 VDD VSS / sg13g2_dfrbpq_1
X_6053_ u_core_u_seu_plain_q_223_ clknet_leaf_20_osc_clk net460 net273 VDD VSS / sg13g2_dfrbpq_1
X_6054_ u_core_u_seu_plain_q_224_ clknet_leaf_21_osc_clk net437 net274 VDD VSS / sg13g2_dfrbpq_1
X_6055_ u_core_u_seu_plain_q_225_ clknet_leaf_21_osc_clk net600 net274 VDD VSS / sg13g2_dfrbpq_1
X_6056_ u_core_u_seu_plain_q_226_ clknet_leaf_21_osc_clk net546 net274 VDD VSS / sg13g2_dfrbpq_1
X_6057_ u_core_u_seu_plain_q_227_ clknet_leaf_18_osc_clk net637 net272 VDD VSS / sg13g2_dfrbpq_1
X_6058_ u_core_u_seu_plain_q_228_ clknet_leaf_19_osc_clk net612 net272 VDD VSS / sg13g2_dfrbpq_1
X_6059_ u_core_u_seu_plain_q_229_ clknet_leaf_19_osc_clk net446 net271 VDD VSS / sg13g2_dfrbpq_1
X_6060_ u_core_u_seu_plain_q_230_ clknet_leaf_20_osc_clk net414 net272 VDD VSS / sg13g2_dfrbpq_1
X_6061_ u_core_u_seu_plain_q_231_ clknet_leaf_20_osc_clk net509 net272 VDD VSS / sg13g2_dfrbpq_1
X_6062_ u_core_u_seu_plain_q_232_ clknet_leaf_20_osc_clk net538 net273 VDD VSS / sg13g2_dfrbpq_1
X_6063_ u_core_u_seu_plain_q_233_ clknet_leaf_20_osc_clk net540 net273 VDD VSS / sg13g2_dfrbpq_1
X_6064_ u_core_u_seu_plain_q_234_ clknet_leaf_20_osc_clk net512 net275 VDD VSS / sg13g2_dfrbpq_1
X_6065_ u_core_u_seu_plain_q_235_ clknet_leaf_21_osc_clk net423 net274 VDD VSS / sg13g2_dfrbpq_1
X_6066_ u_core_u_seu_plain_q_236_ clknet_leaf_21_osc_clk net498 net275 VDD VSS / sg13g2_dfrbpq_1
X_6067_ u_core_u_seu_plain_q_237_ clknet_leaf_21_osc_clk net517 net275 VDD VSS / sg13g2_dfrbpq_1
X_6068_ u_core_u_seu_plain_q_238_ clknet_leaf_21_osc_clk net557 net274 VDD VSS / sg13g2_dfrbpq_1
X_6069_ u_core_u_seu_plain_q_239_ clknet_leaf_21_osc_clk net532 net274 VDD VSS / sg13g2_dfrbpq_1
X_6070_ u_core_u_seu_plain_q_240_ clknet_leaf_23_osc_clk net431 net287 VDD VSS / sg13g2_dfrbpq_1
X_6071_ u_core_u_seu_plain_q_241_ clknet_leaf_19_osc_clk net520 net270 VDD VSS / sg13g2_dfrbpq_1
X_6072_ u_core_u_seu_plain_q_242_ clknet_leaf_19_osc_clk net524 net269 VDD VSS / sg13g2_dfrbpq_1
X_6073_ u_core_u_seu_plain_q_243_ clknet_leaf_19_osc_clk net483 net269 VDD VSS / sg13g2_dfrbpq_1
X_6074_ u_core_u_seu_plain_q_244_ clknet_leaf_18_osc_clk net444 net271 VDD VSS / sg13g2_dfrbpq_1
X_6075_ u_core_u_seu_plain_q_245_ clknet_leaf_20_osc_clk net408 net271 VDD VSS / sg13g2_dfrbpq_1
X_6076_ u_core_u_seu_plain_q_246_ clknet_leaf_20_osc_clk net497 net271 VDD VSS / sg13g2_dfrbpq_1
X_6077_ u_core_u_seu_plain_q_247_ clknet_leaf_20_osc_clk net541 net273 VDD VSS / sg13g2_dfrbpq_1
X_6078_ u_core_u_seu_plain_q_248_ clknet_leaf_22_osc_clk net397 net273 VDD VSS / sg13g2_dfrbpq_1
X_6079_ u_core_u_seu_plain_q_249_ clknet_leaf_21_osc_clk net413 net276 VDD VSS / sg13g2_dfrbpq_1
X_6080_ u_core_u_seu_plain_q_250_ clknet_leaf_21_osc_clk net492 net276 VDD VSS / sg13g2_dfrbpq_1
X_6081_ u_core_u_seu_plain_q_251_ clknet_leaf_21_osc_clk net543 net276 VDD VSS / sg13g2_dfrbpq_1
X_6082_ u_core_u_seu_plain_q_252_ clknet_leaf_23_osc_clk net440 net285 VDD VSS / sg13g2_dfrbpq_1
X_6083_ u_core_u_seu_plain_q_253_ clknet_leaf_23_osc_clk net548 net285 VDD VSS / sg13g2_dfrbpq_1
X_6084_ u_core_u_seu_plain_q_254_ clknet_leaf_23_osc_clk net518 net285 VDD VSS / sg13g2_dfrbpq_1
X_6085_ u_core_u_seu_plain_out clknet_leaf_23_osc_clk net485 net285 VDD VSS / sg13g2_dfrbpq_1
X_6086_ u_core_u_seu_qa_0_ clknet_leaf_5_osc_clk u_core_u_seu_u_tmr_a_d_0_ net165 VDD VSS / sg13g2_dfrbpq_1
X_6087_ u_core_u_seu_qa_1_ clknet_leaf_6_osc_clk u_core_u_seu_u_tmr_a_d_1_ net165 VDD VSS / sg13g2_dfrbpq_1
X_6088_ u_core_u_seu_qa_2_ clknet_leaf_5_osc_clk u_core_u_seu_u_tmr_a_d_2_ net166 VDD VSS / sg13g2_dfrbpq_1
X_6089_ u_core_u_seu_qa_3_ clknet_leaf_4_osc_clk u_core_u_seu_u_tmr_a_d_3_ net161 VDD VSS / sg13g2_dfrbpq_1
X_6090_ u_core_u_seu_qa_4_ clknet_leaf_4_osc_clk u_core_u_seu_u_tmr_a_d_4_ net161 VDD VSS / sg13g2_dfrbpq_1
X_6091_ u_core_u_seu_qa_5_ clknet_leaf_4_osc_clk u_core_u_seu_u_tmr_a_d_5_ net161 VDD VSS / sg13g2_dfrbpq_1
X_6092_ u_core_u_seu_qa_6_ clknet_leaf_0_osc_clk u_core_u_seu_u_tmr_a_d_6_ net134 VDD VSS / sg13g2_dfrbpq_1
X_6093_ u_core_u_seu_qa_7_ clknet_leaf_1_osc_clk u_core_u_seu_u_tmr_a_d_7_ net154 VDD VSS / sg13g2_dfrbpq_1
X_6094_ u_core_u_seu_qa_8_ clknet_leaf_3_osc_clk u_core_u_seu_u_tmr_a_d_8_ net155 VDD VSS / sg13g2_dfrbpq_1
X_6095_ u_core_u_seu_qa_9_ clknet_leaf_2_osc_clk u_core_u_seu_u_tmr_a_d_9_ net159 VDD VSS / sg13g2_dfrbpq_1
X_6096_ u_core_u_seu_qa_10_ clknet_leaf_3_osc_clk u_core_u_seu_u_tmr_a_d_10_ net155 VDD VSS / sg13g2_dfrbpq_1
X_6097_ u_core_u_seu_qa_11_ clknet_leaf_4_osc_clk u_core_u_seu_u_tmr_a_d_11_ net161 VDD VSS / sg13g2_dfrbpq_1
X_6098_ u_core_u_seu_qa_12_ clknet_leaf_4_osc_clk u_core_u_seu_u_tmr_a_d_12_ net162 VDD VSS / sg13g2_dfrbpq_1
X_6099_ u_core_u_seu_qa_13_ clknet_leaf_5_osc_clk u_core_u_seu_u_tmr_a_d_13_ net163 VDD VSS / sg13g2_dfrbpq_1
X_6100_ u_core_u_seu_qa_14_ clknet_leaf_4_osc_clk u_core_u_seu_u_tmr_a_d_14_ net162 VDD VSS / sg13g2_dfrbpq_1
X_6101_ u_core_u_seu_qa_15_ clknet_leaf_4_osc_clk u_core_u_seu_u_tmr_a_d_15_ net162 VDD VSS / sg13g2_dfrbpq_1
X_6102_ u_core_u_seu_qa_16_ clknet_leaf_4_osc_clk u_core_u_seu_u_tmr_a_d_16_ net155 VDD VSS / sg13g2_dfrbpq_1
X_6103_ u_core_u_seu_qa_17_ clknet_leaf_4_osc_clk u_core_u_seu_u_tmr_a_d_17_ net155 VDD VSS / sg13g2_dfrbpq_1
X_6104_ u_core_u_seu_qa_18_ clknet_leaf_7_osc_clk u_core_u_seu_u_tmr_a_d_18_ net159 VDD VSS / sg13g2_dfrbpq_1
X_6105_ u_core_u_seu_qa_19_ clknet_leaf_7_osc_clk u_core_u_seu_u_tmr_a_d_19_ net158 VDD VSS / sg13g2_dfrbpq_1
X_6106_ u_core_u_seu_qa_20_ clknet_leaf_73_osc_clk u_core_u_seu_u_tmr_a_d_20_ net141 VDD VSS / sg13g2_dfrbpq_1
X_6107_ u_core_u_seu_qa_21_ clknet_leaf_75_osc_clk u_core_u_seu_u_tmr_a_d_21_ net138 VDD VSS / sg13g2_dfrbpq_1
X_6108_ u_core_u_seu_qa_22_ clknet_leaf_0_osc_clk u_core_u_seu_u_tmr_a_d_22_ net132 VDD VSS / sg13g2_dfrbpq_1
X_6109_ u_core_u_seu_qa_23_ clknet_leaf_1_osc_clk u_core_u_seu_u_tmr_a_d_23_ net136 VDD VSS / sg13g2_dfrbpq_1
X_6110_ u_core_u_seu_qa_24_ clknet_leaf_3_osc_clk u_core_u_seu_u_tmr_a_d_24_ net155 VDD VSS / sg13g2_dfrbpq_1
X_6111_ u_core_u_seu_qa_25_ clknet_leaf_4_osc_clk u_core_u_seu_u_tmr_a_d_25_ net162 VDD VSS / sg13g2_dfrbpq_1
X_6112_ u_core_u_seu_qa_26_ clknet_leaf_4_osc_clk u_core_u_seu_u_tmr_a_d_26_ net162 VDD VSS / sg13g2_dfrbpq_1
X_6113_ u_core_u_seu_qa_27_ clknet_leaf_4_osc_clk u_core_u_seu_u_tmr_a_d_27_ net162 VDD VSS / sg13g2_dfrbpq_1
X_6114_ u_core_u_seu_qa_28_ clknet_leaf_4_osc_clk u_core_u_seu_u_tmr_a_d_28_ net162 VDD VSS / sg13g2_dfrbpq_1
X_6115_ u_core_u_seu_qa_29_ clknet_leaf_3_osc_clk u_core_u_seu_u_tmr_a_d_29_ net155 VDD VSS / sg13g2_dfrbpq_1
X_6116_ u_core_u_seu_qa_30_ clknet_leaf_1_osc_clk u_core_u_seu_u_tmr_a_d_30_ net154 VDD VSS / sg13g2_dfrbpq_1
X_6117_ u_core_u_seu_qa_31_ clknet_leaf_77_osc_clk u_core_u_seu_u_tmr_a_d_31_ net124 VDD VSS / sg13g2_dfrbpq_1
X_6118_ u_core_u_seu_qa_32_ clknet_leaf_77_osc_clk u_core_u_seu_u_tmr_a_d_32_ net124 VDD VSS / sg13g2_dfrbpq_1
X_6119_ u_core_u_seu_qa_33_ clknet_leaf_77_osc_clk u_core_u_seu_u_tmr_a_d_33_ net124 VDD VSS / sg13g2_dfrbpq_1
X_6120_ u_core_u_seu_qa_34_ clknet_leaf_76_osc_clk u_core_u_seu_u_tmr_a_d_34_ net128 VDD VSS / sg13g2_dfrbpq_1
X_6121_ u_core_u_seu_qa_35_ clknet_leaf_73_osc_clk u_core_u_seu_u_tmr_a_d_35_ net141 VDD VSS / sg13g2_dfrbpq_1
X_6122_ u_core_u_seu_qa_36_ clknet_leaf_74_osc_clk u_core_u_seu_u_tmr_a_d_36_ net147 VDD VSS / sg13g2_dfrbpq_1
X_6123_ u_core_u_seu_qa_37_ clknet_leaf_69_osc_clk u_core_u_seu_u_tmr_a_d_37_ net146 VDD VSS / sg13g2_dfrbpq_1
X_6124_ u_core_u_seu_qa_38_ clknet_leaf_2_osc_clk u_core_u_seu_u_tmr_a_d_38_ net136 VDD VSS / sg13g2_dfrbpq_1
X_6125_ u_core_u_seu_qa_39_ clknet_leaf_74_osc_clk u_core_u_seu_u_tmr_a_d_39_ net136 VDD VSS / sg13g2_dfrbpq_1
X_6126_ u_core_u_seu_qa_40_ clknet_leaf_72_osc_clk u_core_u_seu_u_tmr_a_d_40_ net140 VDD VSS / sg13g2_dfrbpq_1
X_6127_ u_core_u_seu_qa_41_ clknet_leaf_71_osc_clk u_core_u_seu_u_tmr_a_d_41_ net144 VDD VSS / sg13g2_dfrbpq_1
X_6128_ u_core_u_seu_qa_42_ clknet_leaf_76_osc_clk u_core_u_seu_u_tmr_a_d_42_ net128 VDD VSS / sg13g2_dfrbpq_1
X_6129_ u_core_u_seu_qa_43_ clknet_leaf_77_osc_clk u_core_u_seu_u_tmr_a_d_43_ net124 VDD VSS / sg13g2_dfrbpq_1
X_6130_ u_core_u_seu_qa_44_ clknet_leaf_77_osc_clk u_core_u_seu_u_tmr_a_d_44_ net124 VDD VSS / sg13g2_dfrbpq_1
X_6131_ u_core_u_seu_qa_45_ clknet_leaf_77_osc_clk u_core_u_seu_u_tmr_a_d_45_ net125 VDD VSS / sg13g2_dfrbpq_1
X_6132_ u_core_u_seu_qa_46_ clknet_leaf_76_osc_clk u_core_u_seu_u_tmr_a_d_46_ net128 VDD VSS / sg13g2_dfrbpq_1
X_6133_ u_core_u_seu_qa_47_ clknet_leaf_77_osc_clk u_core_u_seu_u_tmr_a_d_47_ net124 VDD VSS / sg13g2_dfrbpq_1
X_6134_ u_core_u_seu_qa_48_ clknet_leaf_3_osc_clk u_core_u_seu_u_tmr_a_d_48_ net154 VDD VSS / sg13g2_dfrbpq_1
X_6135_ u_core_u_seu_qa_49_ clknet_leaf_3_osc_clk u_core_u_seu_u_tmr_a_d_49_ net154 VDD VSS / sg13g2_dfrbpq_1
X_6136_ u_core_u_seu_qa_50_ clknet_leaf_3_osc_clk u_core_u_seu_u_tmr_a_d_50_ net154 VDD VSS / sg13g2_dfrbpq_1
X_6137_ u_core_u_seu_qa_51_ clknet_leaf_3_osc_clk u_core_u_seu_u_tmr_a_d_51_ net155 VDD VSS / sg13g2_dfrbpq_1
X_6138_ u_core_u_seu_qa_52_ clknet_leaf_0_osc_clk u_core_u_seu_u_tmr_a_d_52_ net126 VDD VSS / sg13g2_dfrbpq_1
X_6139_ u_core_u_seu_qa_53_ clknet_leaf_0_osc_clk u_core_u_seu_u_tmr_a_d_53_ net132 VDD VSS / sg13g2_dfrbpq_1
X_6140_ u_core_u_seu_qa_54_ clknet_leaf_77_osc_clk u_core_u_seu_u_tmr_a_d_54_ net130 VDD VSS / sg13g2_dfrbpq_1
X_6141_ u_core_u_seu_qa_55_ clknet_leaf_75_osc_clk u_core_u_seu_u_tmr_a_d_55_ net130 VDD VSS / sg13g2_dfrbpq_1
X_6142_ u_core_u_seu_qa_56_ clknet_leaf_77_osc_clk u_core_u_seu_u_tmr_a_d_56_ net126 VDD VSS / sg13g2_dfrbpq_1
X_6143_ u_core_u_seu_qa_57_ clknet_leaf_0_osc_clk u_core_u_seu_u_tmr_a_d_57_ net126 VDD VSS / sg13g2_dfrbpq_1
X_6144_ u_core_u_seu_qa_58_ clknet_leaf_0_osc_clk u_core_u_seu_u_tmr_a_d_58_ net133 VDD VSS / sg13g2_dfrbpq_1
X_6145_ u_core_u_seu_qa_59_ clknet_leaf_75_osc_clk u_core_u_seu_u_tmr_a_d_59_ net138 VDD VSS / sg13g2_dfrbpq_1
X_6146_ u_core_u_seu_qa_60_ clknet_leaf_0_osc_clk u_core_u_seu_u_tmr_a_d_60_ net132 VDD VSS / sg13g2_dfrbpq_1
X_6147_ u_core_u_seu_qa_61_ clknet_leaf_0_osc_clk u_core_u_seu_u_tmr_a_d_61_ net132 VDD VSS / sg13g2_dfrbpq_1
X_6148_ u_core_u_seu_qa_62_ clknet_leaf_0_osc_clk u_core_u_seu_u_tmr_a_d_62_ net132 VDD VSS / sg13g2_dfrbpq_1
X_6149_ u_core_u_seu_qa_63_ clknet_leaf_0_osc_clk u_core_u_seu_u_tmr_a_d_63_ net132 VDD VSS / sg13g2_dfrbpq_1
X_6150_ u_core_u_seu_qa_64_ clknet_leaf_0_osc_clk u_core_u_seu_u_tmr_a_d_64_ net134 VDD VSS / sg13g2_dfrbpq_1
X_6151_ u_core_u_seu_qa_65_ clknet_leaf_0_osc_clk u_core_u_seu_u_tmr_a_d_65_ net132 VDD VSS / sg13g2_dfrbpq_1
X_6152_ u_core_u_seu_qa_66_ clknet_leaf_0_osc_clk u_core_u_seu_u_tmr_a_d_66_ net132 VDD VSS / sg13g2_dfrbpq_1
X_6153_ u_core_u_seu_qa_67_ clknet_leaf_8_osc_clk u_core_u_seu_u_tmr_a_d_67_ net168 VDD VSS / sg13g2_dfrbpq_1
X_6154_ u_core_u_seu_qa_68_ clknet_leaf_2_osc_clk u_core_u_seu_u_tmr_a_d_68_ net157 VDD VSS / sg13g2_dfrbpq_1
X_6155_ u_core_u_seu_qa_69_ clknet_leaf_2_osc_clk u_core_u_seu_u_tmr_a_d_69_ net157 VDD VSS / sg13g2_dfrbpq_1
X_6156_ u_core_u_seu_qa_70_ clknet_leaf_69_osc_clk u_core_u_seu_u_tmr_a_d_70_ net147 VDD VSS / sg13g2_dfrbpq_1
X_6157_ u_core_u_seu_qa_71_ clknet_leaf_69_osc_clk u_core_u_seu_u_tmr_a_d_71_ net150 VDD VSS / sg13g2_dfrbpq_1
X_6158_ u_core_u_seu_qa_72_ clknet_leaf_69_osc_clk u_core_u_seu_u_tmr_a_d_72_ net149 VDD VSS / sg13g2_dfrbpq_1
X_6159_ u_core_u_seu_qa_73_ clknet_leaf_73_osc_clk u_core_u_seu_u_tmr_a_d_73_ net146 VDD VSS / sg13g2_dfrbpq_1
X_6160_ u_core_u_seu_qa_74_ clknet_leaf_73_osc_clk u_core_u_seu_u_tmr_a_d_74_ net146 VDD VSS / sg13g2_dfrbpq_1
X_6161_ u_core_u_seu_qa_75_ clknet_leaf_68_osc_clk u_core_u_seu_u_tmr_a_d_75_ net147 VDD VSS / sg13g2_dfrbpq_1
X_6162_ u_core_u_seu_qa_76_ clknet_leaf_8_osc_clk u_core_u_seu_u_tmr_a_d_76_ net169 VDD VSS / sg13g2_dfrbpq_1
X_6163_ u_core_u_seu_qa_77_ clknet_leaf_7_osc_clk u_core_u_seu_u_tmr_a_d_77_ net158 VDD VSS / sg13g2_dfrbpq_1
X_6164_ u_core_u_seu_qa_78_ clknet_leaf_8_osc_clk u_core_u_seu_u_tmr_a_d_78_ net169 VDD VSS / sg13g2_dfrbpq_1
X_6165_ u_core_u_seu_qa_79_ clknet_leaf_69_osc_clk u_core_u_seu_u_tmr_a_d_79_ net147 VDD VSS / sg13g2_dfrbpq_1
X_6166_ u_core_u_seu_qa_80_ clknet_leaf_72_osc_clk u_core_u_seu_u_tmr_a_d_80_ net143 VDD VSS / sg13g2_dfrbpq_1
X_6167_ u_core_u_seu_qa_81_ clknet_leaf_71_osc_clk u_core_u_seu_u_tmr_a_d_81_ net149 VDD VSS / sg13g2_dfrbpq_1
X_6168_ u_core_u_seu_qa_82_ clknet_leaf_70_osc_clk u_core_u_seu_u_tmr_a_d_82_ net149 VDD VSS / sg13g2_dfrbpq_1
X_6169_ u_core_u_seu_qa_83_ clknet_leaf_72_osc_clk u_core_u_seu_u_tmr_a_d_83_ net143 VDD VSS / sg13g2_dfrbpq_1
X_6170_ u_core_u_seu_qa_84_ clknet_leaf_71_osc_clk u_core_u_seu_u_tmr_a_d_84_ net143 VDD VSS / sg13g2_dfrbpq_1
X_6171_ u_core_u_seu_qa_85_ clknet_leaf_76_osc_clk u_core_u_seu_u_tmr_a_d_85_ net128 VDD VSS / sg13g2_dfrbpq_1
X_6172_ u_core_u_seu_qa_86_ clknet_leaf_1_osc_clk u_core_u_seu_u_tmr_a_d_86_ net134 VDD VSS / sg13g2_dfrbpq_1
X_6173_ u_core_u_seu_qa_87_ clknet_leaf_1_osc_clk u_core_u_seu_u_tmr_a_d_87_ net134 VDD VSS / sg13g2_dfrbpq_1
X_6174_ u_core_u_seu_qa_88_ clknet_leaf_1_osc_clk u_core_u_seu_u_tmr_a_d_88_ net154 VDD VSS / sg13g2_dfrbpq_1
X_6175_ u_core_u_seu_qa_89_ clknet_leaf_4_osc_clk u_core_u_seu_u_tmr_a_d_89_ net155 VDD VSS / sg13g2_dfrbpq_1
X_6176_ u_core_u_seu_qa_90_ clknet_leaf_77_osc_clk u_core_u_seu_u_tmr_a_d_90_ net125 VDD VSS / sg13g2_dfrbpq_1
X_6177_ u_core_u_seu_qa_91_ clknet_leaf_77_osc_clk u_core_u_seu_u_tmr_a_d_91_ net124 VDD VSS / sg13g2_dfrbpq_1
X_6178_ u_core_u_seu_qa_92_ clknet_leaf_77_osc_clk u_core_u_seu_u_tmr_a_d_92_ net124 VDD VSS / sg13g2_dfrbpq_1
X_6179_ u_core_u_seu_qa_93_ clknet_leaf_76_osc_clk u_core_u_seu_u_tmr_a_d_93_ net128 VDD VSS / sg13g2_dfrbpq_1
X_6180_ u_core_u_seu_qa_94_ clknet_leaf_76_osc_clk u_core_u_seu_u_tmr_a_d_94_ net129 VDD VSS / sg13g2_dfrbpq_1
X_6181_ u_core_u_seu_qa_95_ clknet_leaf_73_osc_clk u_core_u_seu_u_tmr_a_d_95_ net140 VDD VSS / sg13g2_dfrbpq_1
X_6182_ u_core_u_seu_qa_96_ clknet_leaf_73_osc_clk u_core_u_seu_u_tmr_a_d_96_ net140 VDD VSS / sg13g2_dfrbpq_1
X_6183_ u_core_u_seu_qa_97_ clknet_leaf_71_osc_clk u_core_u_seu_u_tmr_a_d_97_ net144 VDD VSS / sg13g2_dfrbpq_1
X_6184_ u_core_u_seu_qa_98_ clknet_leaf_72_osc_clk u_core_u_seu_u_tmr_a_d_98_ net140 VDD VSS / sg13g2_dfrbpq_1
X_6185_ u_core_u_seu_qa_99_ clknet_leaf_68_osc_clk u_core_u_seu_u_tmr_a_d_99_ net168 VDD VSS / sg13g2_dfrbpq_1
X_6186_ u_core_u_seu_qa_100_ clknet_leaf_8_osc_clk u_core_u_seu_u_tmr_a_d_100_ net169 VDD VSS / sg13g2_dfrbpq_1
X_6187_ u_core_u_seu_qa_101_ clknet_leaf_8_osc_clk u_core_u_seu_u_tmr_a_d_101_ net174 VDD VSS / sg13g2_dfrbpq_1
X_6188_ u_core_u_seu_qa_102_ clknet_leaf_6_osc_clk u_core_u_seu_u_tmr_a_d_102_ net174 VDD VSS / sg13g2_dfrbpq_1
X_6189_ u_core_u_seu_qa_103_ clknet_leaf_6_osc_clk u_core_u_seu_u_tmr_a_d_103_ net165 VDD VSS / sg13g2_dfrbpq_1
X_6190_ u_core_u_seu_qa_104_ clknet_leaf_4_osc_clk u_core_u_seu_u_tmr_a_d_104_ net162 VDD VSS / sg13g2_dfrbpq_1
X_6191_ u_core_u_seu_qa_105_ clknet_leaf_5_osc_clk u_core_u_seu_u_tmr_a_d_105_ net241 VDD VSS / sg13g2_dfrbpq_1
X_6192_ u_core_u_seu_qa_106_ clknet_leaf_5_osc_clk u_core_u_seu_u_tmr_a_d_106_ net163 VDD VSS / sg13g2_dfrbpq_1
X_6193_ u_core_u_seu_qa_107_ clknet_leaf_6_osc_clk u_core_u_seu_u_tmr_a_d_107_ net166 VDD VSS / sg13g2_dfrbpq_1
X_6194_ u_core_u_seu_qa_108_ clknet_leaf_68_osc_clk u_core_u_seu_u_tmr_a_d_108_ net168 VDD VSS / sg13g2_dfrbpq_1
X_6195_ u_core_u_seu_qa_109_ clknet_leaf_71_osc_clk u_core_u_seu_u_tmr_a_d_109_ net143 VDD VSS / sg13g2_dfrbpq_1
X_6196_ u_core_u_seu_qa_110_ clknet_leaf_71_osc_clk u_core_u_seu_u_tmr_a_d_110_ net144 VDD VSS / sg13g2_dfrbpq_1
X_6197_ u_core_u_seu_qa_111_ clknet_leaf_1_osc_clk u_core_u_seu_u_tmr_a_d_111_ net134 VDD VSS / sg13g2_dfrbpq_1
X_6198_ u_core_u_seu_qa_112_ clknet_leaf_2_osc_clk u_core_u_seu_u_tmr_a_d_112_ net157 VDD VSS / sg13g2_dfrbpq_1
X_6199_ u_core_u_seu_qa_113_ clknet_leaf_2_osc_clk u_core_u_seu_u_tmr_a_d_113_ net136 VDD VSS / sg13g2_dfrbpq_1
X_6200_ u_core_u_seu_qa_114_ clknet_leaf_0_osc_clk u_core_u_seu_u_tmr_a_d_114_ net134 VDD VSS / sg13g2_dfrbpq_1
X_6201_ u_core_u_seu_qa_115_ clknet_leaf_0_osc_clk u_core_u_seu_u_tmr_a_d_115_ net126 VDD VSS / sg13g2_dfrbpq_1
X_6202_ u_core_u_seu_qa_116_ clknet_leaf_3_osc_clk u_core_u_seu_u_tmr_a_d_116_ net154 VDD VSS / sg13g2_dfrbpq_1
X_6203_ u_core_u_seu_qa_117_ clknet_leaf_5_osc_clk u_core_u_seu_u_tmr_a_d_117_ net161 VDD VSS / sg13g2_dfrbpq_1
X_6204_ u_core_u_seu_qa_118_ clknet_leaf_3_osc_clk u_core_u_seu_u_tmr_a_d_118_ net154 VDD VSS / sg13g2_dfrbpq_1
X_6205_ u_core_u_seu_qa_119_ clknet_leaf_69_osc_clk u_core_u_seu_u_tmr_a_d_119_ net171 VDD VSS / sg13g2_dfrbpq_1
X_6206_ u_core_u_seu_qa_120_ clknet_leaf_69_osc_clk u_core_u_seu_u_tmr_a_d_120_ net171 VDD VSS / sg13g2_dfrbpq_1
X_6207_ u_core_u_seu_qa_121_ clknet_leaf_72_osc_clk u_core_u_seu_u_tmr_a_d_121_ net141 VDD VSS / sg13g2_dfrbpq_1
X_6208_ u_core_u_seu_qa_122_ clknet_leaf_72_osc_clk u_core_u_seu_u_tmr_a_d_122_ net140 VDD VSS / sg13g2_dfrbpq_1
X_6209_ u_core_u_seu_qa_123_ clknet_leaf_72_osc_clk u_core_u_seu_u_tmr_a_d_123_ net144 VDD VSS / sg13g2_dfrbpq_1
X_6210_ u_core_u_seu_qa_124_ clknet_leaf_76_osc_clk u_core_u_seu_u_tmr_a_d_124_ net128 VDD VSS / sg13g2_dfrbpq_1
X_6211_ u_core_u_seu_qa_125_ clknet_leaf_77_osc_clk u_core_u_seu_u_tmr_a_d_125_ net126 VDD VSS / sg13g2_dfrbpq_1
X_6212_ u_core_u_seu_qa_126_ clknet_leaf_77_osc_clk u_core_u_seu_u_tmr_a_d_126_ net125 VDD VSS / sg13g2_dfrbpq_1
X_6213_ u_core_u_seu_qa_127_ clknet_leaf_72_osc_clk u_core_u_seu_u_tmr_a_d_127_ net140 VDD VSS / sg13g2_dfrbpq_1
X_6214_ u_core_u_seu_qb_0_ clknet_leaf_11_osc_clk u_core_u_seu_pat_bit net252 VDD VSS / sg13g2_dfrbpq_1
X_6215_ u_core_u_seu_qb_1_ clknet_leaf_9_osc_clk u_core_u_seu_u_tmr_a_d_1_ net175 VDD VSS / sg13g2_dfrbpq_1
X_6216_ u_core_u_seu_qb_2_ clknet_leaf_9_osc_clk u_core_u_seu_u_tmr_a_d_2_ net175 VDD VSS / sg13g2_dfrbpq_1
X_6217_ u_core_u_seu_qb_3_ clknet_leaf_5_osc_clk u_core_u_seu_u_tmr_a_d_3_ net165 VDD VSS / sg13g2_dfrbpq_1
X_6218_ u_core_u_seu_qb_4_ clknet_leaf_5_osc_clk u_core_u_seu_u_tmr_a_d_4_ net163 VDD VSS / sg13g2_dfrbpq_1
X_6219_ u_core_u_seu_qb_5_ clknet_leaf_5_osc_clk u_core_u_seu_u_tmr_a_d_5_ net163 VDD VSS / sg13g2_dfrbpq_1
X_6220_ u_core_u_seu_qb_6_ clknet_leaf_1_osc_clk u_core_u_seu_u_tmr_a_d_6_ net134 VDD VSS / sg13g2_dfrbpq_1
X_6221_ u_core_u_seu_qb_7_ clknet_leaf_2_osc_clk u_core_u_seu_u_tmr_a_d_7_ net157 VDD VSS / sg13g2_dfrbpq_1
X_6222_ u_core_u_seu_qb_8_ clknet_leaf_7_osc_clk u_core_u_seu_u_tmr_a_d_8_ net159 VDD VSS / sg13g2_dfrbpq_1
X_6223_ u_core_u_seu_qb_9_ clknet_leaf_7_osc_clk u_core_u_seu_u_tmr_a_d_9_ net158 VDD VSS / sg13g2_dfrbpq_1
X_6224_ u_core_u_seu_qb_10_ clknet_leaf_3_osc_clk u_core_u_seu_u_tmr_a_d_10_ net161 VDD VSS / sg13g2_dfrbpq_1
X_6225_ u_core_u_seu_qb_11_ clknet_leaf_5_osc_clk u_core_u_seu_u_tmr_a_d_11_ net163 VDD VSS / sg13g2_dfrbpq_1
X_6226_ u_core_u_seu_qb_12_ clknet_leaf_5_osc_clk u_core_u_seu_u_tmr_a_d_12_ net163 VDD VSS / sg13g2_dfrbpq_1
X_6227_ u_core_u_seu_qb_13_ clknet_leaf_6_osc_clk u_core_u_seu_u_tmr_a_d_13_ net244 VDD VSS / sg13g2_dfrbpq_1
X_6228_ u_core_u_seu_qb_14_ clknet_leaf_14_osc_clk u_core_u_seu_u_tmr_a_d_14_ net241 VDD VSS / sg13g2_dfrbpq_1
X_6229_ u_core_u_seu_qb_15_ clknet_leaf_5_osc_clk u_core_u_seu_u_tmr_a_d_15_ net163 VDD VSS / sg13g2_dfrbpq_1
X_6230_ u_core_u_seu_qb_16_ clknet_leaf_5_osc_clk u_core_u_seu_u_tmr_a_d_16_ net161 VDD VSS / sg13g2_dfrbpq_1
X_6231_ u_core_u_seu_qb_17_ clknet_leaf_6_osc_clk u_core_u_seu_u_tmr_a_d_17_ net166 VDD VSS / sg13g2_dfrbpq_1
X_6232_ u_core_u_seu_qb_18_ clknet_leaf_8_osc_clk u_core_u_seu_u_tmr_a_d_18_ net174 VDD VSS / sg13g2_dfrbpq_1
X_6233_ u_core_u_seu_qb_19_ clknet_leaf_8_osc_clk u_core_u_seu_u_tmr_a_d_19_ net169 VDD VSS / sg13g2_dfrbpq_1
X_6234_ u_core_u_seu_qb_20_ clknet_leaf_69_osc_clk u_core_u_seu_u_tmr_a_d_20_ net149 VDD VSS / sg13g2_dfrbpq_1
X_6235_ u_core_u_seu_qb_21_ clknet_leaf_69_osc_clk u_core_u_seu_u_tmr_a_d_21_ net146 VDD VSS / sg13g2_dfrbpq_1
X_6236_ u_core_u_seu_qb_22_ clknet_leaf_2_osc_clk u_core_u_seu_u_tmr_a_d_22_ net136 VDD VSS / sg13g2_dfrbpq_1
X_6237_ u_core_u_seu_qb_23_ clknet_leaf_74_osc_clk u_core_u_seu_u_tmr_a_d_23_ net168 VDD VSS / sg13g2_dfrbpq_1
X_6238_ u_core_u_seu_qb_24_ clknet_leaf_5_osc_clk u_core_u_seu_u_tmr_a_d_24_ net161 VDD VSS / sg13g2_dfrbpq_1
X_6239_ u_core_u_seu_qb_25_ clknet_leaf_13_osc_clk u_core_u_seu_u_tmr_a_d_25_ net241 VDD VSS / sg13g2_dfrbpq_1
X_6240_ u_core_u_seu_qb_26_ clknet_leaf_13_osc_clk u_core_u_seu_u_tmr_a_d_26_ net244 VDD VSS / sg13g2_dfrbpq_1
X_6241_ u_core_u_seu_qb_27_ clknet_leaf_5_osc_clk u_core_u_seu_u_tmr_a_d_27_ net165 VDD VSS / sg13g2_dfrbpq_1
X_6242_ u_core_u_seu_qb_28_ clknet_leaf_13_osc_clk u_core_u_seu_u_tmr_a_d_28_ net241 VDD VSS / sg13g2_dfrbpq_1
X_6243_ u_core_u_seu_qb_29_ clknet_leaf_3_osc_clk u_core_u_seu_u_tmr_a_d_29_ net164 VDD VSS / sg13g2_dfrbpq_1
X_6244_ u_core_u_seu_qb_30_ clknet_leaf_2_osc_clk u_core_u_seu_u_tmr_a_d_30_ net156 VDD VSS / sg13g2_dfrbpq_1
X_6245_ u_core_u_seu_qb_31_ clknet_leaf_77_osc_clk u_core_u_seu_u_tmr_a_d_31_ net126 VDD VSS / sg13g2_dfrbpq_1
X_6246_ u_core_u_seu_qb_32_ clknet_leaf_76_osc_clk u_core_u_seu_u_tmr_a_d_32_ net126 VDD VSS / sg13g2_dfrbpq_1
X_6247_ u_core_u_seu_qb_33_ clknet_leaf_76_osc_clk u_core_u_seu_u_tmr_a_d_33_ net128 VDD VSS / sg13g2_dfrbpq_1
X_6248_ u_core_u_seu_qb_34_ clknet_leaf_72_osc_clk u_core_u_seu_u_tmr_a_d_34_ net140 VDD VSS / sg13g2_dfrbpq_1
X_6249_ u_core_u_seu_qb_35_ clknet_leaf_71_osc_clk u_core_u_seu_u_tmr_a_d_35_ net143 VDD VSS / sg13g2_dfrbpq_1
X_6250_ u_core_u_seu_qb_36_ clknet_leaf_69_osc_clk u_core_u_seu_u_tmr_a_d_36_ net150 VDD VSS / sg13g2_dfrbpq_1
X_6251_ u_core_u_seu_qb_37_ clknet_leaf_70_osc_clk u_core_u_seu_u_tmr_a_d_37_ net150 VDD VSS / sg13g2_dfrbpq_1
X_6252_ u_core_u_seu_qb_38_ clknet_leaf_68_osc_clk u_core_u_seu_u_tmr_a_d_38_ net147 VDD VSS / sg13g2_dfrbpq_1
X_6253_ u_core_u_seu_qb_39_ clknet_leaf_69_osc_clk u_core_u_seu_u_tmr_a_d_39_ net148 VDD VSS / sg13g2_dfrbpq_1
X_6254_ u_core_u_seu_qb_40_ clknet_leaf_71_osc_clk u_core_u_seu_u_tmr_a_d_40_ net144 VDD VSS / sg13g2_dfrbpq_1
X_6255_ u_core_u_seu_qb_41_ clknet_leaf_61_osc_clk u_core_u_seu_u_tmr_a_d_41_ net181 VDD VSS / sg13g2_dfrbpq_1
X_6256_ u_core_u_seu_qb_42_ clknet_leaf_76_osc_clk u_core_u_seu_u_tmr_a_d_42_ net129 VDD VSS / sg13g2_dfrbpq_1
X_6257_ u_core_u_seu_qb_43_ clknet_leaf_76_osc_clk u_core_u_seu_u_tmr_a_d_43_ net126 VDD VSS / sg13g2_dfrbpq_1
X_6258_ u_core_u_seu_qb_44_ clknet_leaf_75_osc_clk u_core_u_seu_u_tmr_a_d_44_ net130 VDD VSS / sg13g2_dfrbpq_1
X_6259_ u_core_u_seu_qb_45_ clknet_leaf_75_osc_clk u_core_u_seu_u_tmr_a_d_45_ net129 VDD VSS / sg13g2_dfrbpq_1
X_6260_ u_core_u_seu_qb_46_ clknet_leaf_73_osc_clk u_core_u_seu_u_tmr_a_d_46_ net141 VDD VSS / sg13g2_dfrbpq_1
X_6261_ u_core_u_seu_qb_47_ clknet_leaf_76_osc_clk u_core_u_seu_u_tmr_a_d_47_ net127 VDD VSS / sg13g2_dfrbpq_1
X_6262_ u_core_u_seu_qb_48_ clknet_leaf_3_osc_clk u_core_u_seu_u_tmr_a_d_48_ net156 VDD VSS / sg13g2_dfrbpq_1
X_6263_ u_core_u_seu_qb_49_ clknet_leaf_2_osc_clk u_core_u_seu_u_tmr_a_d_49_ net159 VDD VSS / sg13g2_dfrbpq_1
X_6264_ u_core_u_seu_qb_50_ clknet_leaf_3_osc_clk u_core_u_seu_u_tmr_a_d_50_ net156 VDD VSS / sg13g2_dfrbpq_1
X_6265_ u_core_u_seu_qb_51_ clknet_leaf_3_osc_clk u_core_u_seu_u_tmr_a_d_51_ net156 VDD VSS / sg13g2_dfrbpq_1
X_6266_ u_core_u_seu_qb_52_ clknet_leaf_75_osc_clk u_core_u_seu_u_tmr_a_d_52_ net133 VDD VSS / sg13g2_dfrbpq_1
X_6267_ u_core_u_seu_qb_53_ clknet_leaf_75_osc_clk u_core_u_seu_u_tmr_a_d_53_ net138 VDD VSS / sg13g2_dfrbpq_1
X_6268_ u_core_u_seu_qb_54_ clknet_leaf_74_osc_clk u_core_u_seu_u_tmr_a_d_54_ net146 VDD VSS / sg13g2_dfrbpq_1
X_6269_ u_core_u_seu_qb_55_ clknet_leaf_73_osc_clk u_core_u_seu_u_tmr_a_d_55_ net146 VDD VSS / sg13g2_dfrbpq_1
X_6270_ u_core_u_seu_qb_56_ clknet_leaf_75_osc_clk u_core_u_seu_u_tmr_a_d_56_ net138 VDD VSS / sg13g2_dfrbpq_1
X_6271_ u_core_u_seu_qb_57_ clknet_leaf_77_osc_clk u_core_u_seu_u_tmr_a_d_57_ net133 VDD VSS / sg13g2_dfrbpq_1
X_6272_ u_core_u_seu_qb_58_ clknet_leaf_74_osc_clk u_core_u_seu_u_tmr_a_d_58_ net136 VDD VSS / sg13g2_dfrbpq_1
X_6273_ u_core_u_seu_qb_59_ clknet_leaf_74_osc_clk u_core_u_seu_u_tmr_a_d_59_ net147 VDD VSS / sg13g2_dfrbpq_1
X_6274_ u_core_u_seu_qb_60_ clknet_leaf_1_osc_clk u_core_u_seu_u_tmr_a_d_60_ net134 VDD VSS / sg13g2_dfrbpq_1
X_6275_ u_core_u_seu_qb_61_ clknet_leaf_1_osc_clk u_core_u_seu_u_tmr_a_d_61_ net133 VDD VSS / sg13g2_dfrbpq_1
X_6276_ u_core_u_seu_qb_62_ clknet_leaf_1_osc_clk u_core_u_seu_u_tmr_a_d_62_ net133 VDD VSS / sg13g2_dfrbpq_1
X_6277_ u_core_u_seu_qb_63_ clknet_leaf_1_osc_clk u_core_u_seu_u_tmr_a_d_63_ net135 VDD VSS / sg13g2_dfrbpq_1
X_6278_ u_core_u_seu_qb_64_ clknet_leaf_1_osc_clk u_core_u_seu_u_tmr_a_d_64_ net135 VDD VSS / sg13g2_dfrbpq_1
X_6279_ u_core_u_seu_qb_65_ clknet_leaf_1_osc_clk u_core_u_seu_u_tmr_a_d_65_ net133 VDD VSS / sg13g2_dfrbpq_1
X_6280_ u_core_u_seu_qb_66_ clknet_leaf_1_osc_clk u_core_u_seu_u_tmr_a_d_66_ net136 VDD VSS / sg13g2_dfrbpq_1
X_6281_ u_core_u_seu_qb_67_ clknet_leaf_68_osc_clk u_core_u_seu_u_tmr_a_d_67_ net172 VDD VSS / sg13g2_dfrbpq_1
X_6282_ u_core_u_seu_qb_68_ clknet_leaf_8_osc_clk u_core_u_seu_u_tmr_a_d_68_ net169 VDD VSS / sg13g2_dfrbpq_1
X_6283_ u_core_u_seu_qb_69_ clknet_leaf_68_osc_clk u_core_u_seu_u_tmr_a_d_69_ net169 VDD VSS / sg13g2_dfrbpq_1
X_6284_ u_core_u_seu_qb_70_ clknet_leaf_67_osc_clk u_core_u_seu_u_tmr_a_d_70_ net171 VDD VSS / sg13g2_dfrbpq_1
X_6285_ u_core_u_seu_qb_71_ clknet_leaf_62_osc_clk u_core_u_seu_u_tmr_a_d_71_ net216 VDD VSS / sg13g2_dfrbpq_1
X_6286_ u_core_u_seu_qb_72_ clknet_leaf_70_osc_clk u_core_u_seu_u_tmr_a_d_72_ net150 VDD VSS / sg13g2_dfrbpq_1
X_6287_ u_core_u_seu_qb_73_ clknet_leaf_69_osc_clk u_core_u_seu_u_tmr_a_d_73_ net150 VDD VSS / sg13g2_dfrbpq_1
X_6288_ u_core_u_seu_qb_74_ clknet_leaf_70_osc_clk u_core_u_seu_u_tmr_a_d_74_ net149 VDD VSS / sg13g2_dfrbpq_1
X_6289_ u_core_u_seu_qb_75_ clknet_leaf_67_osc_clk u_core_u_seu_u_tmr_a_d_75_ net171 VDD VSS / sg13g2_dfrbpq_1
X_6290_ u_core_u_seu_qb_76_ clknet_leaf_66_osc_clk u_core_u_seu_u_tmr_a_d_76_ net177 VDD VSS / sg13g2_dfrbpq_1
X_6291_ u_core_u_seu_qb_77_ clknet_leaf_8_osc_clk u_core_u_seu_u_tmr_a_d_77_ net174 VDD VSS / sg13g2_dfrbpq_1
X_6292_ u_core_u_seu_qb_78_ clknet_leaf_67_osc_clk u_core_u_seu_u_tmr_a_d_78_ net177 VDD VSS / sg13g2_dfrbpq_1
X_6293_ u_core_u_seu_qb_79_ clknet_leaf_70_osc_clk u_core_u_seu_u_tmr_a_d_79_ net150 VDD VSS / sg13g2_dfrbpq_1
X_6294_ u_core_u_seu_qb_80_ clknet_leaf_61_osc_clk u_core_u_seu_u_tmr_a_d_80_ net180 VDD VSS / sg13g2_dfrbpq_1
X_6295_ u_core_u_seu_qb_81_ clknet_leaf_61_osc_clk u_core_u_seu_u_tmr_a_d_81_ net187 VDD VSS / sg13g2_dfrbpq_1
X_6296_ u_core_u_seu_qb_82_ clknet_leaf_62_osc_clk u_core_u_seu_u_tmr_a_d_82_ net188 VDD VSS / sg13g2_dfrbpq_1
X_6297_ u_core_u_seu_qb_83_ clknet_leaf_61_osc_clk u_core_u_seu_u_tmr_a_d_83_ net187 VDD VSS / sg13g2_dfrbpq_1
X_6298_ u_core_u_seu_qb_84_ clknet_leaf_61_osc_clk u_core_u_seu_u_tmr_a_d_84_ net180 VDD VSS / sg13g2_dfrbpq_1
X_6299_ u_core_u_seu_qb_85_ clknet_leaf_72_osc_clk u_core_u_seu_u_tmr_a_d_85_ net141 VDD VSS / sg13g2_dfrbpq_1
X_6300_ u_core_u_seu_qb_86_ clknet_leaf_1_osc_clk u_core_u_seu_u_tmr_a_d_86_ net135 VDD VSS / sg13g2_dfrbpq_1
X_6301_ u_core_u_seu_qb_87_ clknet_leaf_2_osc_clk u_core_u_seu_u_tmr_a_d_87_ net156 VDD VSS / sg13g2_dfrbpq_1
X_6302_ u_core_u_seu_qb_88_ clknet_leaf_2_osc_clk u_core_u_seu_u_tmr_a_d_88_ net156 VDD VSS / sg13g2_dfrbpq_1
X_6303_ u_core_u_seu_qb_89_ clknet_leaf_5_osc_clk u_core_u_seu_u_tmr_a_d_89_ net166 VDD VSS / sg13g2_dfrbpq_1
X_6304_ u_core_u_seu_qb_90_ clknet_leaf_76_osc_clk u_core_u_seu_u_tmr_a_d_90_ net129 VDD VSS / sg13g2_dfrbpq_1
X_6305_ u_core_u_seu_qb_91_ clknet_leaf_76_osc_clk u_core_u_seu_u_tmr_a_d_91_ net125 VDD VSS / sg13g2_dfrbpq_1
X_6306_ u_core_u_seu_qb_92_ clknet_leaf_76_osc_clk u_core_u_seu_u_tmr_a_d_92_ net128 VDD VSS / sg13g2_dfrbpq_1
X_6307_ u_core_u_seu_qb_93_ clknet_leaf_72_osc_clk u_core_u_seu_u_tmr_a_d_93_ net140 VDD VSS / sg13g2_dfrbpq_1
X_6308_ u_core_u_seu_qb_94_ clknet_leaf_72_osc_clk u_core_u_seu_u_tmr_a_d_94_ net142 VDD VSS / sg13g2_dfrbpq_1
X_6309_ u_core_u_seu_qb_95_ clknet_leaf_72_osc_clk u_core_u_seu_u_tmr_a_d_95_ net144 VDD VSS / sg13g2_dfrbpq_1
X_6310_ u_core_u_seu_qb_96_ clknet_leaf_71_osc_clk u_core_u_seu_u_tmr_a_d_96_ net144 VDD VSS / sg13g2_dfrbpq_1
X_6311_ u_core_u_seu_qb_97_ clknet_leaf_61_osc_clk u_core_u_seu_u_tmr_a_d_97_ net180 VDD VSS / sg13g2_dfrbpq_1
X_6312_ u_core_u_seu_qb_98_ clknet_leaf_71_osc_clk u_core_u_seu_u_tmr_a_d_98_ net145 VDD VSS / sg13g2_dfrbpq_1
X_6313_ u_core_u_seu_qb_99_ clknet_leaf_68_osc_clk u_core_u_seu_u_tmr_a_d_99_ net172 VDD VSS / sg13g2_dfrbpq_1
X_6314_ u_core_u_seu_qb_100_ clknet_leaf_9_osc_clk u_core_u_seu_u_tmr_a_d_100_ net177 VDD VSS / sg13g2_dfrbpq_1
X_6315_ u_core_u_seu_qb_101_ clknet_leaf_9_osc_clk u_core_u_seu_u_tmr_a_d_101_ net176 VDD VSS / sg13g2_dfrbpq_1
X_6316_ u_core_u_seu_qb_102_ clknet_leaf_9_osc_clk u_core_u_seu_u_tmr_a_d_102_ net175 VDD VSS / sg13g2_dfrbpq_1
X_6317_ u_core_u_seu_qb_103_ clknet_leaf_9_osc_clk u_core_u_seu_u_tmr_a_d_103_ net252 VDD VSS / sg13g2_dfrbpq_1
X_6318_ u_core_u_seu_qb_104_ clknet_leaf_13_osc_clk u_core_u_seu_u_tmr_a_d_104_ net246 VDD VSS / sg13g2_dfrbpq_1
X_6319_ u_core_u_seu_qb_105_ clknet_leaf_13_osc_clk u_core_u_seu_u_tmr_a_d_105_ net244 VDD VSS / sg13g2_dfrbpq_1
X_6320_ u_core_u_seu_qb_106_ clknet_leaf_13_osc_clk u_core_u_seu_u_tmr_a_d_106_ net244 VDD VSS / sg13g2_dfrbpq_1
X_6321_ u_core_u_seu_qb_107_ clknet_leaf_9_osc_clk u_core_u_seu_u_tmr_a_d_107_ net175 VDD VSS / sg13g2_dfrbpq_1
X_6322_ u_core_u_seu_qb_108_ clknet_leaf_67_osc_clk u_core_u_seu_u_tmr_a_d_108_ net172 VDD VSS / sg13g2_dfrbpq_1
X_6323_ u_core_u_seu_qb_109_ clknet_leaf_61_osc_clk u_core_u_seu_u_tmr_a_d_109_ net180 VDD VSS / sg13g2_dfrbpq_1
X_6324_ u_core_u_seu_qb_110_ clknet_leaf_60_osc_clk u_core_u_seu_u_tmr_a_d_110_ net181 VDD VSS / sg13g2_dfrbpq_1
X_6325_ u_core_u_seu_qb_111_ clknet_leaf_2_osc_clk u_core_u_seu_u_tmr_a_d_111_ net157 VDD VSS / sg13g2_dfrbpq_1
X_6326_ u_core_u_seu_qb_112_ clknet_leaf_8_osc_clk u_core_u_seu_u_tmr_a_d_112_ net168 VDD VSS / sg13g2_dfrbpq_1
X_6327_ u_core_u_seu_qb_113_ clknet_leaf_68_osc_clk u_core_u_seu_u_tmr_a_d_113_ net168 VDD VSS / sg13g2_dfrbpq_1
X_6328_ u_core_u_seu_qb_114_ clknet_leaf_2_osc_clk u_core_u_seu_u_tmr_a_d_114_ net136 VDD VSS / sg13g2_dfrbpq_1
X_6329_ u_core_u_seu_qb_115_ clknet_leaf_75_osc_clk u_core_u_seu_u_tmr_a_d_115_ net138 VDD VSS / sg13g2_dfrbpq_1
X_6330_ u_core_u_seu_qb_116_ clknet_leaf_7_osc_clk u_core_u_seu_u_tmr_a_d_116_ net158 VDD VSS / sg13g2_dfrbpq_1
X_6331_ u_core_u_seu_qb_117_ clknet_leaf_6_osc_clk u_core_u_seu_u_tmr_a_d_117_ net165 VDD VSS / sg13g2_dfrbpq_1
X_6332_ u_core_u_seu_qb_118_ clknet_leaf_7_osc_clk u_core_u_seu_u_tmr_a_d_118_ net158 VDD VSS / sg13g2_dfrbpq_1
X_6333_ u_core_u_seu_qb_119_ clknet_leaf_64_osc_clk u_core_u_seu_u_tmr_a_d_119_ net216 VDD VSS / sg13g2_dfrbpq_1
X_6334_ u_core_u_seu_qb_120_ clknet_leaf_65_osc_clk u_core_u_seu_u_tmr_a_d_120_ net171 VDD VSS / sg13g2_dfrbpq_1
X_6335_ u_core_u_seu_qb_121_ clknet_leaf_70_osc_clk u_core_u_seu_u_tmr_a_d_121_ net149 VDD VSS / sg13g2_dfrbpq_1
X_6336_ u_core_u_seu_qb_122_ clknet_leaf_71_osc_clk u_core_u_seu_u_tmr_a_d_122_ net144 VDD VSS / sg13g2_dfrbpq_1
X_6337_ u_core_u_seu_qb_123_ clknet_leaf_61_osc_clk u_core_u_seu_u_tmr_a_d_123_ net181 VDD VSS / sg13g2_dfrbpq_1
X_6338_ u_core_u_seu_qb_124_ clknet_leaf_73_osc_clk u_core_u_seu_u_tmr_a_d_124_ net141 VDD VSS / sg13g2_dfrbpq_1
X_6339_ u_core_u_seu_qb_125_ clknet_leaf_75_osc_clk u_core_u_seu_u_tmr_a_d_125_ net130 VDD VSS / sg13g2_dfrbpq_1
X_6340_ u_core_u_seu_qb_126_ clknet_leaf_75_osc_clk u_core_u_seu_u_tmr_a_d_126_ net130 VDD VSS / sg13g2_dfrbpq_1
X_6341_ u_core_u_seu_qb_127_ clknet_leaf_71_osc_clk u_core_u_seu_u_tmr_a_d_127_ net143 VDD VSS / sg13g2_dfrbpq_1
X_6342_ u_core_u_seu_qc_0_ clknet_leaf_10_osc_clk u_core_u_seu_pat_bit net255 VDD VSS / sg13g2_dfrbpq_1
X_6343_ u_core_u_seu_qc_1_ clknet_leaf_10_osc_clk u_core_u_seu_u_tmr_a_d_1_ net254 VDD VSS / sg13g2_dfrbpq_1
X_6344_ u_core_u_seu_qc_2_ clknet_leaf_9_osc_clk u_core_u_seu_u_tmr_a_d_2_ net176 VDD VSS / sg13g2_dfrbpq_1
X_6345_ u_core_u_seu_qc_3_ clknet_leaf_9_osc_clk u_core_u_seu_u_tmr_a_d_3_ net175 VDD VSS / sg13g2_dfrbpq_1
X_6346_ u_core_u_seu_qc_4_ clknet_leaf_6_osc_clk u_core_u_seu_u_tmr_a_d_4_ net165 VDD VSS / sg13g2_dfrbpq_1
X_6347_ u_core_u_seu_qc_5_ clknet_leaf_6_osc_clk u_core_u_seu_u_tmr_a_d_5_ net244 VDD VSS / sg13g2_dfrbpq_1
X_6348_ u_core_u_seu_qc_6_ clknet_leaf_7_osc_clk u_core_u_seu_u_tmr_a_d_6_ net157 VDD VSS / sg13g2_dfrbpq_1
X_6349_ u_core_u_seu_qc_7_ clknet_leaf_7_osc_clk u_core_u_seu_u_tmr_a_d_7_ net169 VDD VSS / sg13g2_dfrbpq_1
X_6350_ u_core_u_seu_qc_8_ clknet_leaf_8_osc_clk u_core_u_seu_u_tmr_a_d_8_ net174 VDD VSS / sg13g2_dfrbpq_1
X_6351_ u_core_u_seu_qc_9_ clknet_leaf_9_osc_clk u_core_u_seu_u_tmr_a_d_9_ net174 VDD VSS / sg13g2_dfrbpq_1
X_6352_ u_core_u_seu_qc_10_ clknet_leaf_6_osc_clk u_core_u_seu_u_tmr_a_d_10_ net165 VDD VSS / sg13g2_dfrbpq_1
X_6353_ u_core_u_seu_qc_11_ clknet_leaf_6_osc_clk u_core_u_seu_u_tmr_a_d_11_ net167 VDD VSS / sg13g2_dfrbpq_1
X_6354_ u_core_u_seu_qc_12_ clknet_leaf_13_osc_clk u_core_u_seu_u_tmr_a_d_12_ net244 VDD VSS / sg13g2_dfrbpq_1
X_6355_ u_core_u_seu_qc_13_ clknet_leaf_11_osc_clk u_core_u_seu_u_tmr_a_d_13_ net252 VDD VSS / sg13g2_dfrbpq_1
X_6356_ u_core_u_seu_qc_14_ clknet_leaf_13_osc_clk u_core_u_seu_u_tmr_a_d_14_ net245 VDD VSS / sg13g2_dfrbpq_1
X_6357_ u_core_u_seu_qc_15_ clknet_leaf_13_osc_clk u_core_u_seu_u_tmr_a_d_15_ net244 VDD VSS / sg13g2_dfrbpq_1
X_6358_ u_core_u_seu_qc_16_ clknet_leaf_6_osc_clk u_core_u_seu_u_tmr_a_d_16_ net167 VDD VSS / sg13g2_dfrbpq_1
X_6359_ u_core_u_seu_qc_17_ clknet_leaf_9_osc_clk u_core_u_seu_u_tmr_a_d_17_ net175 VDD VSS / sg13g2_dfrbpq_1
X_6360_ u_core_u_seu_qc_18_ clknet_leaf_9_osc_clk u_core_u_seu_u_tmr_a_d_18_ net176 VDD VSS / sg13g2_dfrbpq_1
X_6361_ u_core_u_seu_qc_19_ clknet_leaf_66_osc_clk u_core_u_seu_u_tmr_a_d_19_ net177 VDD VSS / sg13g2_dfrbpq_1
X_6362_ u_core_u_seu_qc_20_ clknet_leaf_70_osc_clk u_core_u_seu_u_tmr_a_d_20_ net150 VDD VSS / sg13g2_dfrbpq_1
X_6363_ u_core_u_seu_qc_21_ clknet_leaf_70_osc_clk u_core_u_seu_u_tmr_a_d_21_ net151 VDD VSS / sg13g2_dfrbpq_1
X_6364_ u_core_u_seu_qc_22_ clknet_leaf_68_osc_clk u_core_u_seu_u_tmr_a_d_22_ net168 VDD VSS / sg13g2_dfrbpq_1
X_6365_ u_core_u_seu_qc_23_ clknet_leaf_68_osc_clk u_core_u_seu_u_tmr_a_d_23_ net170 VDD VSS / sg13g2_dfrbpq_1
X_6366_ u_core_u_seu_qc_24_ clknet_leaf_6_osc_clk u_core_u_seu_u_tmr_a_d_24_ net167 VDD VSS / sg13g2_dfrbpq_1
X_6367_ u_core_u_seu_qc_25_ clknet_leaf_12_osc_clk u_core_u_seu_u_tmr_a_d_25_ net245 VDD VSS / sg13g2_dfrbpq_1
X_6368_ u_core_u_seu_qc_26_ clknet_leaf_11_osc_clk u_core_u_seu_u_tmr_a_d_26_ net253 VDD VSS / sg13g2_dfrbpq_1
X_6369_ u_core_u_seu_qc_27_ clknet_leaf_11_osc_clk u_core_u_seu_u_tmr_a_d_27_ net252 VDD VSS / sg13g2_dfrbpq_1
X_6370_ u_core_u_seu_qc_28_ clknet_leaf_13_osc_clk u_core_u_seu_u_tmr_a_d_28_ net245 VDD VSS / sg13g2_dfrbpq_1
X_6371_ u_core_u_seu_qc_29_ clknet_leaf_6_osc_clk u_core_u_seu_u_tmr_a_d_29_ net166 VDD VSS / sg13g2_dfrbpq_1
X_6372_ u_core_u_seu_qc_30_ clknet_leaf_7_osc_clk u_core_u_seu_u_tmr_a_d_30_ net158 VDD VSS / sg13g2_dfrbpq_1
X_6373_ u_core_u_seu_qc_31_ clknet_leaf_75_osc_clk u_core_u_seu_u_tmr_a_d_31_ net138 VDD VSS / sg13g2_dfrbpq_1
X_6374_ u_core_u_seu_qc_32_ clknet_leaf_75_osc_clk u_core_u_seu_u_tmr_a_d_32_ net130 VDD VSS / sg13g2_dfrbpq_1
X_6375_ u_core_u_seu_qc_33_ clknet_leaf_73_osc_clk u_core_u_seu_u_tmr_a_d_33_ net141 VDD VSS / sg13g2_dfrbpq_1
X_6376_ u_core_u_seu_qc_34_ clknet_leaf_71_osc_clk u_core_u_seu_u_tmr_a_d_34_ net145 VDD VSS / sg13g2_dfrbpq_1
X_6377_ u_core_u_seu_qc_35_ clknet_leaf_62_osc_clk u_core_u_seu_u_tmr_a_d_35_ net187 VDD VSS / sg13g2_dfrbpq_1
X_6378_ u_core_u_seu_qc_36_ clknet_leaf_64_osc_clk u_core_u_seu_u_tmr_a_d_36_ net216 VDD VSS / sg13g2_dfrbpq_1
X_6379_ u_core_u_seu_qc_37_ clknet_leaf_64_osc_clk u_core_u_seu_u_tmr_a_d_37_ net216 VDD VSS / sg13g2_dfrbpq_1
X_6380_ u_core_u_seu_qc_38_ clknet_leaf_67_osc_clk u_core_u_seu_u_tmr_a_d_38_ net171 VDD VSS / sg13g2_dfrbpq_1
X_6381_ u_core_u_seu_qc_39_ clknet_leaf_67_osc_clk u_core_u_seu_u_tmr_a_d_39_ net171 VDD VSS / sg13g2_dfrbpq_1
X_6382_ u_core_u_seu_qc_40_ clknet_leaf_61_osc_clk u_core_u_seu_u_tmr_a_d_40_ net180 VDD VSS / sg13g2_dfrbpq_1
X_6383_ u_core_u_seu_qc_41_ clknet_leaf_58_osc_clk u_core_u_seu_u_tmr_a_d_41_ net185 VDD VSS / sg13g2_dfrbpq_1
X_6384_ u_core_u_seu_qc_42_ clknet_leaf_72_osc_clk u_core_u_seu_u_tmr_a_d_42_ net142 VDD VSS / sg13g2_dfrbpq_1
X_6385_ u_core_u_seu_qc_43_ clknet_leaf_75_osc_clk u_core_u_seu_u_tmr_a_d_43_ net130 VDD VSS / sg13g2_dfrbpq_1
X_6386_ u_core_u_seu_qc_44_ clknet_leaf_73_osc_clk u_core_u_seu_u_tmr_a_d_44_ net141 VDD VSS / sg13g2_dfrbpq_1
X_6387_ u_core_u_seu_qc_45_ clknet_leaf_73_osc_clk u_core_u_seu_u_tmr_a_d_45_ net142 VDD VSS / sg13g2_dfrbpq_1
X_6388_ u_core_u_seu_qc_46_ clknet_leaf_71_osc_clk u_core_u_seu_u_tmr_a_d_46_ net143 VDD VSS / sg13g2_dfrbpq_1
X_6389_ u_core_u_seu_qc_47_ clknet_leaf_75_osc_clk u_core_u_seu_u_tmr_a_d_47_ net130 VDD VSS / sg13g2_dfrbpq_1
X_6390_ u_core_u_seu_qc_48_ clknet_leaf_7_osc_clk u_core_u_seu_u_tmr_a_d_48_ net158 VDD VSS / sg13g2_dfrbpq_1
X_6391_ u_core_u_seu_qc_49_ clknet_leaf_8_osc_clk u_core_u_seu_u_tmr_a_d_49_ net169 VDD VSS / sg13g2_dfrbpq_1
X_6392_ u_core_u_seu_qc_50_ clknet_leaf_6_osc_clk u_core_u_seu_u_tmr_a_d_50_ net166 VDD VSS / sg13g2_dfrbpq_1
X_6393_ u_core_u_seu_qc_51_ clknet_leaf_7_osc_clk u_core_u_seu_u_tmr_a_d_51_ net166 VDD VSS / sg13g2_dfrbpq_1
X_6394_ u_core_u_seu_qc_52_ clknet_leaf_74_osc_clk u_core_u_seu_u_tmr_a_d_52_ net138 VDD VSS / sg13g2_dfrbpq_1
X_6395_ u_core_u_seu_qc_53_ clknet_leaf_69_osc_clk u_core_u_seu_u_tmr_a_d_53_ net147 VDD VSS / sg13g2_dfrbpq_1
X_6396_ u_core_u_seu_qc_54_ clknet_leaf_69_osc_clk u_core_u_seu_u_tmr_a_d_54_ net150 VDD VSS / sg13g2_dfrbpq_1
X_6397_ u_core_u_seu_qc_55_ clknet_leaf_70_osc_clk u_core_u_seu_u_tmr_a_d_55_ net151 VDD VSS / sg13g2_dfrbpq_1
X_6398_ u_core_u_seu_qc_56_ clknet_leaf_69_osc_clk u_core_u_seu_u_tmr_a_d_56_ net148 VDD VSS / sg13g2_dfrbpq_1
X_6399_ u_core_u_seu_qc_57_ clknet_leaf_74_osc_clk u_core_u_seu_u_tmr_a_d_57_ net138 VDD VSS / sg13g2_dfrbpq_1
X_6400_ u_core_u_seu_qc_58_ clknet_leaf_69_osc_clk u_core_u_seu_u_tmr_a_d_58_ net148 VDD VSS / sg13g2_dfrbpq_1
X_6401_ u_core_u_seu_qc_59_ clknet_leaf_68_osc_clk u_core_u_seu_u_tmr_a_d_59_ net171 VDD VSS / sg13g2_dfrbpq_1
X_6402_ u_core_u_seu_qc_60_ clknet_leaf_74_osc_clk u_core_u_seu_u_tmr_a_d_60_ net137 VDD VSS / sg13g2_dfrbpq_1
X_6403_ u_core_u_seu_qc_61_ clknet_leaf_74_osc_clk u_core_u_seu_u_tmr_a_d_61_ net137 VDD VSS / sg13g2_dfrbpq_1
X_6404_ u_core_u_seu_qc_62_ clknet_leaf_74_osc_clk u_core_u_seu_u_tmr_a_d_62_ net137 VDD VSS / sg13g2_dfrbpq_1
X_6405_ u_core_u_seu_qc_63_ clknet_leaf_74_osc_clk u_core_u_seu_u_tmr_a_d_63_ net157 VDD VSS / sg13g2_dfrbpq_1
X_6406_ u_core_u_seu_qc_64_ clknet_leaf_7_osc_clk u_core_u_seu_u_tmr_a_d_64_ net157 VDD VSS / sg13g2_dfrbpq_1
X_6407_ u_core_u_seu_qc_65_ clknet_leaf_74_osc_clk u_core_u_seu_u_tmr_a_d_65_ net137 VDD VSS / sg13g2_dfrbpq_1
X_6408_ u_core_u_seu_qc_66_ clknet_leaf_74_osc_clk u_core_u_seu_u_tmr_a_d_66_ net147 VDD VSS / sg13g2_dfrbpq_1
X_6409_ u_core_u_seu_qc_67_ clknet_leaf_65_osc_clk u_core_u_seu_u_tmr_a_d_67_ net217 VDD VSS / sg13g2_dfrbpq_1
X_6410_ u_core_u_seu_qc_68_ clknet_leaf_66_osc_clk u_core_u_seu_u_tmr_a_d_68_ net177 VDD VSS / sg13g2_dfrbpq_1
X_6411_ u_core_u_seu_qc_69_ clknet_leaf_67_osc_clk u_core_u_seu_u_tmr_a_d_69_ net172 VDD VSS / sg13g2_dfrbpq_1
X_6412_ u_core_u_seu_qc_70_ clknet_leaf_64_osc_clk u_core_u_seu_u_tmr_a_d_70_ net217 VDD VSS / sg13g2_dfrbpq_1
X_6413_ u_core_u_seu_qc_71_ clknet_leaf_64_osc_clk u_core_u_seu_u_tmr_a_d_71_ net220 VDD VSS / sg13g2_dfrbpq_1
X_6414_ u_core_u_seu_qc_72_ clknet_leaf_62_osc_clk u_core_u_seu_u_tmr_a_d_72_ net188 VDD VSS / sg13g2_dfrbpq_1
X_6415_ u_core_u_seu_qc_73_ clknet_leaf_62_osc_clk u_core_u_seu_u_tmr_a_d_73_ net188 VDD VSS / sg13g2_dfrbpq_1
X_6416_ u_core_u_seu_qc_74_ clknet_leaf_62_osc_clk u_core_u_seu_u_tmr_a_d_74_ net188 VDD VSS / sg13g2_dfrbpq_1
X_6417_ u_core_u_seu_qc_75_ clknet_leaf_65_osc_clk u_core_u_seu_u_tmr_a_d_75_ net217 VDD VSS / sg13g2_dfrbpq_1
X_6418_ u_core_u_seu_qc_76_ clknet_leaf_66_osc_clk u_core_u_seu_u_tmr_a_d_76_ net223 VDD VSS / sg13g2_dfrbpq_1
X_6419_ u_core_u_seu_qc_77_ clknet_leaf_66_osc_clk u_core_u_seu_u_tmr_a_d_77_ net176 VDD VSS / sg13g2_dfrbpq_1
X_6420_ u_core_u_seu_qc_78_ clknet_leaf_66_osc_clk u_core_u_seu_u_tmr_a_d_78_ net224 VDD VSS / sg13g2_dfrbpq_1
X_6421_ u_core_u_seu_qc_79_ clknet_leaf_64_osc_clk u_core_u_seu_u_tmr_a_d_79_ net216 VDD VSS / sg13g2_dfrbpq_1
X_6422_ u_core_u_seu_qc_80_ clknet_leaf_63_osc_clk u_core_u_seu_u_tmr_a_d_80_ net191 VDD VSS / sg13g2_dfrbpq_1
X_6423_ u_core_u_seu_qc_81_ clknet_leaf_63_osc_clk u_core_u_seu_u_tmr_a_d_81_ net192 VDD VSS / sg13g2_dfrbpq_1
X_6424_ u_core_u_seu_qc_82_ clknet_leaf_63_osc_clk u_core_u_seu_u_tmr_a_d_82_ net220 VDD VSS / sg13g2_dfrbpq_1
X_6425_ u_core_u_seu_qc_83_ clknet_leaf_63_osc_clk u_core_u_seu_u_tmr_a_d_83_ net192 VDD VSS / sg13g2_dfrbpq_1
X_6426_ u_core_u_seu_qc_84_ clknet_leaf_58_osc_clk u_core_u_seu_u_tmr_a_d_84_ net190 VDD VSS / sg13g2_dfrbpq_1
X_6427_ u_core_u_seu_qc_85_ clknet_leaf_70_osc_clk u_core_u_seu_u_tmr_a_d_85_ net149 VDD VSS / sg13g2_dfrbpq_1
X_6428_ u_core_u_seu_qc_86_ clknet_leaf_2_osc_clk u_core_u_seu_u_tmr_a_d_86_ net160 VDD VSS / sg13g2_dfrbpq_1
X_6429_ u_core_u_seu_qc_87_ clknet_leaf_7_osc_clk u_core_u_seu_u_tmr_a_d_87_ net158 VDD VSS / sg13g2_dfrbpq_1
X_6430_ u_core_u_seu_qc_88_ clknet_leaf_7_osc_clk u_core_u_seu_u_tmr_a_d_88_ net159 VDD VSS / sg13g2_dfrbpq_1
X_6431_ u_core_u_seu_qc_89_ clknet_leaf_9_osc_clk u_core_u_seu_u_tmr_a_d_89_ net178 VDD VSS / sg13g2_dfrbpq_1
X_6432_ u_core_u_seu_qc_90_ clknet_leaf_73_osc_clk u_core_u_seu_u_tmr_a_d_90_ net142 VDD VSS / sg13g2_dfrbpq_1
X_6433_ u_core_u_seu_qc_91_ clknet_leaf_75_osc_clk u_core_u_seu_u_tmr_a_d_91_ net131 VDD VSS / sg13g2_dfrbpq_1
X_6434_ u_core_u_seu_qc_92_ clknet_leaf_76_osc_clk u_core_u_seu_u_tmr_a_d_92_ net131 VDD VSS / sg13g2_dfrbpq_1
X_6435_ u_core_u_seu_qc_93_ clknet_leaf_72_osc_clk u_core_u_seu_u_tmr_a_d_93_ net143 VDD VSS / sg13g2_dfrbpq_1
X_6436_ u_core_u_seu_qc_94_ clknet_leaf_71_osc_clk u_core_u_seu_u_tmr_a_d_94_ net145 VDD VSS / sg13g2_dfrbpq_1
X_6437_ u_core_u_seu_qc_95_ clknet_leaf_61_osc_clk u_core_u_seu_u_tmr_a_d_95_ net180 VDD VSS / sg13g2_dfrbpq_1
X_6438_ u_core_u_seu_qc_96_ clknet_leaf_61_osc_clk u_core_u_seu_u_tmr_a_d_96_ net180 VDD VSS / sg13g2_dfrbpq_1
X_6439_ u_core_u_seu_qc_97_ clknet_leaf_58_osc_clk u_core_u_seu_u_tmr_a_d_97_ net191 VDD VSS / sg13g2_dfrbpq_1
X_6440_ u_core_u_seu_qc_98_ clknet_leaf_61_osc_clk u_core_u_seu_u_tmr_a_d_98_ net187 VDD VSS / sg13g2_dfrbpq_1
X_6441_ u_core_u_seu_qc_99_ clknet_leaf_65_osc_clk u_core_u_seu_u_tmr_a_d_99_ net224 VDD VSS / sg13g2_dfrbpq_1
X_6442_ u_core_u_seu_qc_100_ clknet_leaf_66_osc_clk u_core_u_seu_u_tmr_a_d_100_ net223 VDD VSS / sg13g2_dfrbpq_1
X_6443_ u_core_u_seu_qc_101_ clknet_leaf_42_osc_clk u_core_u_seu_u_tmr_a_d_101_ net223 VDD VSS / sg13g2_dfrbpq_1
X_6444_ u_core_u_seu_qc_102_ clknet_leaf_10_osc_clk u_core_u_seu_u_tmr_a_d_102_ net254 VDD VSS / sg13g2_dfrbpq_1
X_6445_ u_core_u_seu_qc_103_ clknet_leaf_28_osc_clk u_core_u_seu_u_tmr_a_d_103_ net254 VDD VSS / sg13g2_dfrbpq_1
X_6446_ u_core_u_seu_qc_104_ clknet_leaf_13_osc_clk u_core_u_seu_u_tmr_a_d_104_ net245 VDD VSS / sg13g2_dfrbpq_1
X_6447_ u_core_u_seu_qc_105_ clknet_leaf_11_osc_clk u_core_u_seu_u_tmr_a_d_105_ net253 VDD VSS / sg13g2_dfrbpq_1
X_6448_ u_core_u_seu_qc_106_ clknet_leaf_10_osc_clk u_core_u_seu_u_tmr_a_d_106_ net253 VDD VSS / sg13g2_dfrbpq_1
X_6449_ u_core_u_seu_qc_107_ clknet_leaf_10_osc_clk u_core_u_seu_u_tmr_a_d_107_ net176 VDD VSS / sg13g2_dfrbpq_1
X_6450_ u_core_u_seu_qc_108_ clknet_leaf_65_osc_clk u_core_u_seu_u_tmr_a_d_108_ net224 VDD VSS / sg13g2_dfrbpq_1
X_6451_ u_core_u_seu_qc_109_ clknet_leaf_58_osc_clk u_core_u_seu_u_tmr_a_d_109_ net193 VDD VSS / sg13g2_dfrbpq_1
X_6452_ u_core_u_seu_qc_110_ clknet_leaf_59_osc_clk u_core_u_seu_u_tmr_a_d_110_ net186 VDD VSS / sg13g2_dfrbpq_1
X_6453_ u_core_u_seu_qc_111_ clknet_leaf_68_osc_clk u_core_u_seu_u_tmr_a_d_111_ net170 VDD VSS / sg13g2_dfrbpq_1
X_6454_ u_core_u_seu_qc_112_ clknet_leaf_68_osc_clk u_core_u_seu_u_tmr_a_d_112_ net172 VDD VSS / sg13g2_dfrbpq_1
X_6455_ u_core_u_seu_qc_113_ clknet_leaf_67_osc_clk u_core_u_seu_u_tmr_a_d_113_ net173 VDD VSS / sg13g2_dfrbpq_1
X_6456_ u_core_u_seu_qc_114_ clknet_leaf_8_osc_clk u_core_u_seu_u_tmr_a_d_114_ net168 VDD VSS / sg13g2_dfrbpq_1
X_6457_ u_core_u_seu_qc_115_ clknet_leaf_73_osc_clk u_core_u_seu_u_tmr_a_d_115_ net146 VDD VSS / sg13g2_dfrbpq_1
X_6458_ u_core_u_seu_qc_116_ clknet_leaf_8_osc_clk u_core_u_seu_u_tmr_a_d_116_ net174 VDD VSS / sg13g2_dfrbpq_1
X_6459_ u_core_u_seu_qc_117_ clknet_leaf_10_osc_clk u_core_u_seu_u_tmr_a_d_117_ net252 VDD VSS / sg13g2_dfrbpq_1
X_6460_ u_core_u_seu_qc_118_ clknet_leaf_8_osc_clk u_core_u_seu_u_tmr_a_d_118_ net174 VDD VSS / sg13g2_dfrbpq_1
X_6461_ u_core_u_seu_qc_119_ clknet_leaf_64_osc_clk u_core_u_seu_u_tmr_a_d_119_ net221 VDD VSS / sg13g2_dfrbpq_1
X_6462_ u_core_u_seu_qc_120_ clknet_leaf_64_osc_clk u_core_u_seu_u_tmr_a_d_120_ net217 VDD VSS / sg13g2_dfrbpq_1
X_6463_ u_core_u_seu_qc_121_ clknet_leaf_62_osc_clk u_core_u_seu_u_tmr_a_d_121_ net188 VDD VSS / sg13g2_dfrbpq_1
X_6464_ u_core_u_seu_qc_122_ clknet_leaf_60_osc_clk u_core_u_seu_u_tmr_a_d_122_ net181 VDD VSS / sg13g2_dfrbpq_1
X_6465_ u_core_u_seu_qc_123_ clknet_leaf_60_osc_clk u_core_u_seu_u_tmr_a_d_123_ net185 VDD VSS / sg13g2_dfrbpq_1
X_6466_ u_core_u_seu_qc_124_ clknet_leaf_70_osc_clk u_core_u_seu_u_tmr_a_d_124_ net149 VDD VSS / sg13g2_dfrbpq_1
X_6467_ u_core_u_seu_qc_125_ clknet_leaf_73_osc_clk u_core_u_seu_u_tmr_a_d_125_ net146 VDD VSS / sg13g2_dfrbpq_1
X_6468_ u_core_u_seu_qc_126_ clknet_leaf_73_osc_clk u_core_u_seu_u_tmr_a_d_126_ net148 VDD VSS / sg13g2_dfrbpq_1
X_6469_ u_core_u_seu_qc_127_ clknet_leaf_61_osc_clk u_core_u_seu_u_tmr_a_d_127_ net187 VDD VSS / sg13g2_dfrbpq_1
X_6470_ u_core_u_seu_u_cnt_plain_qc_0_ clknet_leaf_49_osc_clk u_core_u_seu_cnt_plain_n_0_ net209 VDD VSS / sg13g2_dfrbpq_1
X_6471_ u_core_u_seu_u_cnt_plain_qc_1_ clknet_leaf_49_osc_clk u_core_u_seu_cnt_plain_n_1_ net228 VDD VSS / sg13g2_dfrbpq_1
X_6472_ u_core_u_seu_u_cnt_plain_qc_2_ clknet_leaf_48_osc_clk u_core_u_seu_cnt_plain_n_2_ net231 VDD VSS / sg13g2_dfrbpq_1
X_6473_ u_core_u_seu_u_cnt_plain_qc_3_ clknet_leaf_48_osc_clk u_core_u_seu_cnt_plain_n_3_ net232 VDD VSS / sg13g2_dfrbpq_1
X_6474_ u_core_u_seu_u_cnt_plain_qc_4_ clknet_leaf_49_osc_clk u_core_u_seu_cnt_plain_n_4_ net229 VDD VSS / sg13g2_dfrbpq_1
X_6475_ u_core_u_seu_u_cnt_plain_qc_5_ clknet_leaf_45_osc_clk u_core_u_seu_cnt_plain_n_5_ net234 VDD VSS / sg13g2_dfrbpq_1
X_6476_ u_core_u_seu_u_cnt_plain_qc_6_ clknet_leaf_45_osc_clk u_core_u_seu_cnt_plain_n_6_ net234 VDD VSS / sg13g2_dfrbpq_1
X_6477_ u_core_u_seu_u_cnt_plain_qc_7_ clknet_leaf_44_osc_clk u_core_u_seu_cnt_plain_n_7_ net229 VDD VSS / sg13g2_dfrbpq_1
X_6478_ u_core_u_seu_u_cnt_plain_qc_8_ clknet_leaf_44_osc_clk u_core_u_seu_cnt_plain_n_8_ net229 VDD VSS / sg13g2_dfrbpq_1
X_6479_ u_core_u_seu_u_cnt_plain_qc_9_ clknet_leaf_44_osc_clk u_core_u_seu_cnt_plain_n_9_ net221 VDD VSS / sg13g2_dfrbpq_1
X_6480_ u_core_u_seu_u_cnt_plain_qc_10_ clknet_leaf_44_osc_clk u_core_u_seu_cnt_plain_n_10_ net220 VDD VSS / sg13g2_dfrbpq_1
X_6481_ u_core_u_seu_u_cnt_plain_qc_11_ clknet_leaf_49_osc_clk u_core_u_seu_cnt_plain_n_11_ net208 VDD VSS / sg13g2_dfrbpq_1
X_6482_ u_core_u_seu_u_cnt_plain_qc_12_ clknet_leaf_44_osc_clk u_core_u_seu_cnt_plain_n_12_ net220 VDD VSS / sg13g2_dfrbpq_1
X_6483_ u_core_u_seu_u_cnt_plain_qc_13_ clknet_leaf_49_osc_clk u_core_u_seu_cnt_plain_n_13_ net228 VDD VSS / sg13g2_dfrbpq_1
X_6484_ u_core_u_seu_u_cnt_plain_qc_14_ clknet_leaf_49_osc_clk u_core_u_seu_cnt_plain_n_14_ net208 VDD VSS / sg13g2_dfrbpq_1
X_6485_ u_core_u_seu_u_cnt_plain_qc_15_ clknet_leaf_45_osc_clk u_core_u_seu_cnt_plain_n_15_ net234 VDD VSS / sg13g2_dfrbpq_1
X_6486_ u_core_u_seu_u_cnt_plain_qb_0_ clknet_leaf_58_osc_clk u_core_u_seu_cnt_plain_n_0_ net192 VDD VSS / sg13g2_dfrbpq_1
X_6487_ u_core_u_seu_u_cnt_plain_qb_1_ clknet_leaf_63_osc_clk u_core_u_seu_cnt_plain_n_1_ net192 VDD VSS / sg13g2_dfrbpq_1
X_6488_ u_core_u_seu_u_cnt_plain_qb_2_ clknet_leaf_57_osc_clk u_core_u_seu_cnt_plain_n_2_ net208 VDD VSS / sg13g2_dfrbpq_1
X_6489_ u_core_u_seu_u_cnt_plain_qb_3_ clknet_leaf_49_osc_clk u_core_u_seu_cnt_plain_n_3_ net228 VDD VSS / sg13g2_dfrbpq_1
X_6490_ u_core_u_seu_u_cnt_plain_qb_4_ clknet_leaf_44_osc_clk u_core_u_seu_cnt_plain_n_4_ net220 VDD VSS / sg13g2_dfrbpq_1
X_6491_ u_core_u_seu_u_cnt_plain_qb_5_ clknet_leaf_43_osc_clk u_core_u_seu_cnt_plain_n_5_ net225 VDD VSS / sg13g2_dfrbpq_1
X_6492_ u_core_u_seu_u_cnt_plain_qb_6_ clknet_leaf_44_osc_clk u_core_u_seu_cnt_plain_n_6_ net221 VDD VSS / sg13g2_dfrbpq_1
X_6493_ u_core_u_seu_u_cnt_plain_qb_7_ clknet_leaf_64_osc_clk u_core_u_seu_cnt_plain_n_7_ net220 VDD VSS / sg13g2_dfrbpq_1
X_6494_ u_core_u_seu_u_cnt_plain_qb_8_ clknet_leaf_64_osc_clk u_core_u_seu_cnt_plain_n_8_ net220 VDD VSS / sg13g2_dfrbpq_1
X_6495_ u_core_u_seu_u_cnt_plain_qb_9_ clknet_leaf_64_osc_clk u_core_u_seu_cnt_plain_n_9_ net218 VDD VSS / sg13g2_dfrbpq_1
X_6496_ u_core_u_seu_u_cnt_plain_qb_10_ clknet_leaf_62_osc_clk u_core_u_seu_cnt_plain_n_10_ net216 VDD VSS / sg13g2_dfrbpq_1
X_6497_ u_core_u_seu_u_cnt_plain_qb_11_ clknet_leaf_63_osc_clk u_core_u_seu_cnt_plain_n_11_ net192 VDD VSS / sg13g2_dfrbpq_1
X_6498_ u_core_u_seu_u_cnt_plain_qb_12_ clknet_leaf_62_osc_clk u_core_u_seu_cnt_plain_n_12_ net188 VDD VSS / sg13g2_dfrbpq_1
X_6499_ u_core_u_seu_u_cnt_plain_qb_13_ clknet_leaf_63_osc_clk u_core_u_seu_cnt_plain_n_13_ net192 VDD VSS / sg13g2_dfrbpq_1
X_6500_ u_core_u_seu_u_cnt_plain_qb_14_ clknet_leaf_63_osc_clk u_core_u_seu_cnt_plain_n_14_ net192 VDD VSS / sg13g2_dfrbpq_1
X_6501_ u_core_u_seu_u_cnt_plain_qb_15_ clknet_leaf_44_osc_clk u_core_u_seu_cnt_plain_n_15_ net221 VDD VSS / sg13g2_dfrbpq_1
X_6502_ u_core_u_seu_u_cnt_plain_qa_0_ clknet_leaf_61_osc_clk u_core_u_seu_cnt_plain_n_0_ net189 VDD VSS / sg13g2_dfrbpq_1
X_6503_ u_core_u_seu_u_cnt_plain_qa_1_ clknet_leaf_62_osc_clk u_core_u_seu_cnt_plain_n_1_ net189 VDD VSS / sg13g2_dfrbpq_1
X_6504_ u_core_u_seu_u_cnt_plain_qa_2_ clknet_leaf_63_osc_clk u_core_u_seu_cnt_plain_n_2_ net191 VDD VSS / sg13g2_dfrbpq_1
X_6505_ u_core_u_seu_u_cnt_plain_qa_3_ clknet_leaf_63_osc_clk u_core_u_seu_cnt_plain_n_3_ net192 VDD VSS / sg13g2_dfrbpq_1
X_6506_ u_core_u_seu_u_cnt_plain_qa_4_ clknet_leaf_62_osc_clk u_core_u_seu_cnt_plain_n_4_ net219 VDD VSS / sg13g2_dfrbpq_1
X_6507_ u_core_u_seu_u_cnt_plain_qa_5_ clknet_leaf_65_osc_clk u_core_u_seu_cnt_plain_n_5_ net218 VDD VSS / sg13g2_dfrbpq_1
X_6508_ u_core_u_seu_u_cnt_plain_qa_6_ clknet_leaf_64_osc_clk u_core_u_seu_cnt_plain_n_6_ net218 VDD VSS / sg13g2_dfrbpq_1
X_6509_ u_core_u_seu_u_cnt_plain_qa_7_ clknet_leaf_64_osc_clk u_core_u_seu_cnt_plain_n_7_ net216 VDD VSS / sg13g2_dfrbpq_1
X_6510_ u_core_u_seu_u_cnt_plain_qa_8_ clknet_leaf_65_osc_clk u_core_u_seu_cnt_plain_n_8_ net216 VDD VSS / sg13g2_dfrbpq_1
X_6511_ u_core_u_seu_u_cnt_plain_qa_9_ clknet_leaf_67_osc_clk u_core_u_seu_cnt_plain_n_9_ net173 VDD VSS / sg13g2_dfrbpq_1
X_6512_ u_core_u_seu_u_cnt_plain_qa_10_ clknet_leaf_70_osc_clk u_core_u_seu_cnt_plain_n_10_ net151 VDD VSS / sg13g2_dfrbpq_1
X_6513_ u_core_u_seu_u_cnt_plain_qa_11_ clknet_leaf_61_osc_clk u_core_u_seu_cnt_plain_n_11_ net187 VDD VSS / sg13g2_dfrbpq_1
X_6514_ u_core_u_seu_u_cnt_plain_qa_12_ clknet_leaf_70_osc_clk u_core_u_seu_cnt_plain_n_12_ net151 VDD VSS / sg13g2_dfrbpq_1
X_6515_ u_core_u_seu_u_cnt_plain_qa_13_ clknet_leaf_62_osc_clk u_core_u_seu_cnt_plain_n_13_ net188 VDD VSS / sg13g2_dfrbpq_1
X_6516_ u_core_u_seu_u_cnt_plain_qa_14_ clknet_leaf_61_osc_clk u_core_u_seu_cnt_plain_n_14_ net187 VDD VSS / sg13g2_dfrbpq_1
X_6517_ u_core_u_seu_u_cnt_plain_qa_15_ clknet_leaf_65_osc_clk u_core_u_seu_cnt_plain_n_15_ net217 VDD VSS / sg13g2_dfrbpq_1
X_6518_ u_core_u_seu_u_cnt_corr_qc_0_ clknet_leaf_46_osc_clk u_core_u_seu_cnt_corr_n_0_ net305 VDD VSS / sg13g2_dfrbpq_1
X_6519_ u_core_u_seu_u_cnt_corr_qc_1_ clknet_leaf_38_osc_clk u_core_u_seu_cnt_corr_n_1_ net305 VDD VSS / sg13g2_dfrbpq_1
X_6520_ u_core_u_seu_u_cnt_corr_qc_2_ clknet_leaf_38_osc_clk u_core_u_seu_cnt_corr_n_2_ net305 VDD VSS / sg13g2_dfrbpq_1
X_6521_ u_core_u_seu_u_cnt_corr_qc_3_ clknet_leaf_46_osc_clk u_core_u_seu_cnt_corr_n_3_ net238 VDD VSS / sg13g2_dfrbpq_1
X_6522_ u_core_u_seu_u_cnt_corr_qc_4_ clknet_leaf_46_osc_clk u_core_u_seu_cnt_corr_n_4_ net238 VDD VSS / sg13g2_dfrbpq_1
X_6523_ u_core_u_seu_u_cnt_corr_qc_5_ clknet_leaf_46_osc_clk u_core_u_seu_cnt_corr_n_5_ net237 VDD VSS / sg13g2_dfrbpq_1
X_6524_ u_core_u_seu_u_cnt_corr_qc_6_ clknet_leaf_46_osc_clk u_core_u_seu_cnt_corr_n_6_ net237 VDD VSS / sg13g2_dfrbpq_1
X_6525_ u_core_u_seu_u_cnt_corr_qc_7_ clknet_leaf_45_osc_clk u_core_u_seu_cnt_corr_n_7_ net234 VDD VSS / sg13g2_dfrbpq_1
X_6526_ u_core_u_seu_u_cnt_corr_qc_8_ clknet_leaf_45_osc_clk u_core_u_seu_cnt_corr_n_8_ net235 VDD VSS / sg13g2_dfrbpq_1
X_6527_ u_core_u_seu_u_cnt_corr_qc_9_ clknet_leaf_43_osc_clk u_core_u_seu_cnt_corr_n_9_ net225 VDD VSS / sg13g2_dfrbpq_1
X_6528_ u_core_u_seu_u_cnt_corr_qc_10_ clknet_leaf_43_osc_clk u_core_u_seu_cnt_corr_n_10_ net225 VDD VSS / sg13g2_dfrbpq_1
X_6529_ u_core_u_seu_u_cnt_corr_qc_11_ clknet_leaf_43_osc_clk u_core_u_seu_cnt_corr_n_11_ net225 VDD VSS / sg13g2_dfrbpq_1
X_6530_ u_core_u_seu_u_cnt_corr_qc_12_ clknet_leaf_43_osc_clk u_core_u_seu_cnt_corr_n_12_ net226 VDD VSS / sg13g2_dfrbpq_1
X_6531_ u_core_u_seu_u_cnt_corr_qc_13_ clknet_leaf_42_osc_clk u_core_u_seu_cnt_corr_n_13_ net296 VDD VSS / sg13g2_dfrbpq_1
X_6532_ u_core_u_seu_u_cnt_corr_qc_14_ clknet_leaf_42_osc_clk u_core_u_seu_cnt_corr_n_14_ net227 VDD VSS / sg13g2_dfrbpq_1
X_6533_ u_core_u_seu_u_cnt_corr_qc_15_ clknet_leaf_43_osc_clk u_core_u_seu_cnt_corr_n_15_ net227 VDD VSS / sg13g2_dfrbpq_1
X_6534_ u_core_u_seu_u_cnt_corr_qb_0_ clknet_leaf_45_osc_clk u_core_u_seu_cnt_corr_n_0_ net235 VDD VSS / sg13g2_dfrbpq_1
X_6535_ u_core_u_seu_u_cnt_corr_qb_1_ clknet_leaf_45_osc_clk u_core_u_seu_cnt_corr_n_1_ net235 VDD VSS / sg13g2_dfrbpq_1
X_6536_ u_core_u_seu_u_cnt_corr_qb_2_ clknet_leaf_45_osc_clk u_core_u_seu_cnt_corr_n_2_ net235 VDD VSS / sg13g2_dfrbpq_1
X_6537_ u_core_u_seu_u_cnt_corr_qb_3_ clknet_leaf_46_osc_clk u_core_u_seu_cnt_corr_n_3_ net234 VDD VSS / sg13g2_dfrbpq_1
X_6538_ u_core_u_seu_u_cnt_corr_qb_4_ clknet_leaf_45_osc_clk u_core_u_seu_cnt_corr_n_4_ net234 VDD VSS / sg13g2_dfrbpq_1
X_6539_ u_core_u_seu_u_cnt_corr_qb_5_ clknet_leaf_45_osc_clk u_core_u_seu_cnt_corr_n_5_ net234 VDD VSS / sg13g2_dfrbpq_1
X_6540_ u_core_u_seu_u_cnt_corr_qb_6_ clknet_leaf_45_osc_clk u_core_u_seu_cnt_corr_n_6_ net234 VDD VSS / sg13g2_dfrbpq_1
X_6541_ u_core_u_seu_u_cnt_corr_qb_7_ clknet_leaf_43_osc_clk u_core_u_seu_cnt_corr_n_7_ net225 VDD VSS / sg13g2_dfrbpq_1
X_6542_ u_core_u_seu_u_cnt_corr_qb_8_ clknet_leaf_43_osc_clk u_core_u_seu_cnt_corr_n_8_ net225 VDD VSS / sg13g2_dfrbpq_1
X_6543_ u_core_u_seu_u_cnt_corr_qb_9_ clknet_leaf_65_osc_clk u_core_u_seu_cnt_corr_n_9_ net218 VDD VSS / sg13g2_dfrbpq_1
X_6544_ u_core_u_seu_u_cnt_corr_qb_10_ clknet_leaf_65_osc_clk u_core_u_seu_cnt_corr_n_10_ net218 VDD VSS / sg13g2_dfrbpq_1
X_6545_ u_core_u_seu_u_cnt_corr_qb_11_ clknet_leaf_65_osc_clk u_core_u_seu_cnt_corr_n_11_ net224 VDD VSS / sg13g2_dfrbpq_1
X_6546_ u_core_u_seu_u_cnt_corr_qb_12_ clknet_leaf_42_osc_clk u_core_u_seu_cnt_corr_n_12_ net224 VDD VSS / sg13g2_dfrbpq_1
X_6547_ u_core_u_seu_u_cnt_corr_qb_13_ clknet_leaf_66_osc_clk u_core_u_seu_cnt_corr_n_13_ net223 VDD VSS / sg13g2_dfrbpq_1
X_6548_ u_core_u_seu_u_cnt_corr_qb_14_ clknet_leaf_66_osc_clk u_core_u_seu_cnt_corr_n_14_ net178 VDD VSS / sg13g2_dfrbpq_1
X_6549_ u_core_u_seu_u_cnt_corr_qb_15_ clknet_leaf_66_osc_clk u_core_u_seu_cnt_corr_n_15_ net224 VDD VSS / sg13g2_dfrbpq_1
X_6550_ u_core_u_seu_u_cnt_corr_qa_0_ clknet_leaf_43_osc_clk u_core_u_seu_cnt_corr_n_0_ net225 VDD VSS / sg13g2_dfrbpq_1
X_6551_ u_core_u_seu_u_cnt_corr_qa_1_ clknet_leaf_43_osc_clk u_core_u_seu_cnt_corr_n_1_ net226 VDD VSS / sg13g2_dfrbpq_1
X_6552_ u_core_u_seu_u_cnt_corr_qa_2_ clknet_leaf_45_osc_clk u_core_u_seu_cnt_corr_n_2_ net226 VDD VSS / sg13g2_dfrbpq_1
X_6553_ u_core_u_seu_u_cnt_corr_qa_3_ clknet_leaf_44_osc_clk u_core_u_seu_cnt_corr_n_3_ net229 VDD VSS / sg13g2_dfrbpq_1
X_6554_ u_core_u_seu_u_cnt_corr_qa_4_ clknet_leaf_44_osc_clk u_core_u_seu_cnt_corr_n_4_ net221 VDD VSS / sg13g2_dfrbpq_1
X_6555_ u_core_u_seu_u_cnt_corr_qa_5_ clknet_leaf_44_osc_clk u_core_u_seu_cnt_corr_n_5_ net222 VDD VSS / sg13g2_dfrbpq_1
X_6556_ u_core_u_seu_u_cnt_corr_qa_6_ clknet_leaf_44_osc_clk u_core_u_seu_cnt_corr_n_6_ net225 VDD VSS / sg13g2_dfrbpq_1
X_6557_ u_core_u_seu_u_cnt_corr_qa_7_ clknet_leaf_66_osc_clk u_core_u_seu_cnt_corr_n_7_ net224 VDD VSS / sg13g2_dfrbpq_1
X_6558_ u_core_u_seu_u_cnt_corr_qa_8_ clknet_leaf_65_osc_clk u_core_u_seu_cnt_corr_n_8_ net217 VDD VSS / sg13g2_dfrbpq_1
X_6559_ u_core_u_seu_u_cnt_corr_qa_9_ clknet_leaf_67_osc_clk u_core_u_seu_cnt_corr_n_9_ net173 VDD VSS / sg13g2_dfrbpq_1
X_6560_ u_core_u_seu_u_cnt_corr_qa_10_ clknet_leaf_67_osc_clk u_core_u_seu_cnt_corr_n_10_ net173 VDD VSS / sg13g2_dfrbpq_1
X_6561_ u_core_u_seu_u_cnt_corr_qa_11_ clknet_leaf_68_osc_clk u_core_u_seu_cnt_corr_n_11_ net172 VDD VSS / sg13g2_dfrbpq_1
X_6562_ u_core_u_seu_u_cnt_corr_qa_12_ clknet_leaf_67_osc_clk u_core_u_seu_cnt_corr_n_12_ net177 VDD VSS / sg13g2_dfrbpq_1
X_6563_ u_core_u_seu_u_cnt_corr_qa_13_ clknet_leaf_9_osc_clk u_core_u_seu_cnt_corr_n_13_ net177 VDD VSS / sg13g2_dfrbpq_1
X_6564_ u_core_u_seu_u_cnt_corr_qa_14_ clknet_leaf_8_osc_clk u_core_u_seu_cnt_corr_n_14_ net175 VDD VSS / sg13g2_dfrbpq_1
X_6565_ u_core_u_seu_u_cnt_corr_qa_15_ clknet_leaf_67_osc_clk u_core_u_seu_cnt_corr_n_15_ net172 VDD VSS / sg13g2_dfrbpq_1
X_6566_ u_core_u_seu_u_cnt_unc_qc_0_ clknet_leaf_46_osc_clk u_core_u_seu_cnt_unc_n_0_ net238 VDD VSS / sg13g2_dfrbpq_1
X_6567_ u_core_u_seu_u_cnt_unc_qc_1_ clknet_leaf_47_osc_clk u_core_u_seu_cnt_unc_n_1_ net238 VDD VSS / sg13g2_dfrbpq_1
X_6568_ u_core_u_seu_u_cnt_unc_qc_2_ clknet_leaf_48_osc_clk u_core_u_seu_cnt_unc_n_2_ net233 VDD VSS / sg13g2_dfrbpq_1
X_6569_ u_core_u_seu_u_cnt_unc_qc_3_ clknet_leaf_47_osc_clk u_core_u_seu_cnt_unc_n_3_ net233 VDD VSS / sg13g2_dfrbpq_1
X_6570_ u_core_u_seu_u_cnt_unc_qc_4_ clknet_leaf_48_osc_clk u_core_u_seu_cnt_unc_n_4_ net231 VDD VSS / sg13g2_dfrbpq_1
X_6571_ u_core_u_seu_u_cnt_unc_qc_5_ clknet_leaf_48_osc_clk u_core_u_seu_cnt_unc_n_5_ net231 VDD VSS / sg13g2_dfrbpq_1
X_6572_ u_core_u_seu_u_cnt_unc_qc_6_ clknet_leaf_47_osc_clk u_core_u_seu_cnt_unc_n_6_ net236 VDD VSS / sg13g2_dfrbpq_1
X_6573_ u_core_u_seu_u_cnt_unc_qc_7_ clknet_leaf_47_osc_clk u_core_u_seu_cnt_unc_n_7_ net236 VDD VSS / sg13g2_dfrbpq_1
X_6574_ u_core_u_seu_u_cnt_unc_qb_0_ clknet_leaf_45_osc_clk u_core_u_seu_cnt_unc_n_0_ net229 VDD VSS / sg13g2_dfrbpq_1
X_6575_ u_core_u_seu_u_cnt_unc_qb_1_ clknet_leaf_49_osc_clk u_core_u_seu_cnt_unc_n_1_ net229 VDD VSS / sg13g2_dfrbpq_1
X_6576_ u_core_u_seu_u_cnt_unc_qb_2_ clknet_leaf_49_osc_clk u_core_u_seu_cnt_unc_n_2_ net228 VDD VSS / sg13g2_dfrbpq_1
X_6577_ u_core_u_seu_u_cnt_unc_qb_3_ clknet_leaf_49_osc_clk u_core_u_seu_cnt_unc_n_3_ net228 VDD VSS / sg13g2_dfrbpq_1
X_6578_ u_core_u_seu_u_cnt_unc_qb_4_ clknet_leaf_49_osc_clk u_core_u_seu_cnt_unc_n_4_ net228 VDD VSS / sg13g2_dfrbpq_1
X_6579_ u_core_u_seu_u_cnt_unc_qb_5_ clknet_leaf_49_osc_clk u_core_u_seu_cnt_unc_n_5_ net228 VDD VSS / sg13g2_dfrbpq_1
X_6580_ u_core_u_seu_u_cnt_unc_qb_6_ clknet_leaf_45_osc_clk u_core_u_seu_cnt_unc_n_6_ net229 VDD VSS / sg13g2_dfrbpq_1
X_6581_ u_core_u_seu_u_cnt_unc_qb_7_ clknet_leaf_44_osc_clk u_core_u_seu_cnt_unc_n_7_ net229 VDD VSS / sg13g2_dfrbpq_1
X_6582_ u_core_u_seu_u_cnt_unc_qa_0_ clknet_leaf_44_osc_clk u_core_u_seu_cnt_unc_n_0_ net222 VDD VSS / sg13g2_dfrbpq_1
X_6583_ u_core_u_seu_u_cnt_unc_qa_1_ clknet_leaf_44_osc_clk u_core_u_seu_cnt_unc_n_1_ net228 VDD VSS / sg13g2_dfrbpq_1
X_6584_ u_core_u_seu_u_cnt_unc_qa_2_ clknet_leaf_58_osc_clk u_core_u_seu_cnt_unc_n_2_ net208 VDD VSS / sg13g2_dfrbpq_1
X_6585_ u_core_u_seu_u_cnt_unc_qa_3_ clknet_leaf_63_osc_clk u_core_u_seu_cnt_unc_n_3_ net221 VDD VSS / sg13g2_dfrbpq_1
X_6586_ u_core_u_seu_u_cnt_unc_qa_4_ clknet_leaf_58_osc_clk u_core_u_seu_cnt_unc_n_4_ net193 VDD VSS / sg13g2_dfrbpq_1
X_6587_ u_core_u_seu_u_cnt_unc_qa_5_ clknet_leaf_63_osc_clk u_core_u_seu_cnt_unc_n_5_ net193 VDD VSS / sg13g2_dfrbpq_1
X_6588_ u_core_u_seu_u_cnt_unc_qa_6_ clknet_leaf_63_osc_clk u_core_u_seu_cnt_unc_n_6_ net221 VDD VSS / sg13g2_dfrbpq_1
X_6589_ u_core_u_seu_u_cnt_unc_qa_7_ clknet_leaf_64_osc_clk u_core_u_seu_cnt_unc_n_7_ net220 VDD VSS / sg13g2_dfrbpq_1
X_6590_ u_core_u_seu_u_run_max_qc_0_ clknet_leaf_27_osc_clk u_core_u_seu_run_max_n_0_ net279 VDD VSS / sg13g2_dfrbpq_1
X_6591_ u_core_u_seu_u_run_max_qc_1_ clknet_leaf_26_osc_clk u_core_u_seu_run_max_n_1_ net279 VDD VSS / sg13g2_dfrbpq_1
X_6592_ u_core_u_seu_u_run_max_qc_2_ clknet_leaf_27_osc_clk u_core_u_seu_run_max_n_2_ net279 VDD VSS / sg13g2_dfrbpq_1
X_6593_ u_core_u_seu_u_run_max_qc_3_ clknet_leaf_22_osc_clk u_core_u_seu_run_max_n_3_ net279 VDD VSS / sg13g2_dfrbpq_1
X_6594_ u_core_u_seu_u_run_max_qc_4_ clknet_leaf_12_osc_clk u_core_u_seu_run_max_n_4_ net258 VDD VSS / sg13g2_dfrbpq_1
X_6595_ u_core_u_seu_u_run_max_qc_5_ clknet_leaf_12_osc_clk u_core_u_seu_run_max_n_5_ net250 VDD VSS / sg13g2_dfrbpq_1
X_6596_ u_core_u_seu_u_run_max_qc_6_ clknet_leaf_11_osc_clk u_core_u_seu_run_max_n_6_ net257 VDD VSS / sg13g2_dfrbpq_1
X_6597_ u_core_u_seu_u_run_max_qc_7_ clknet_leaf_11_osc_clk u_core_u_seu_run_max_n_7_ net257 VDD VSS / sg13g2_dfrbpq_1
X_6598_ u_core_u_seu_u_run_max_qb_0_ clknet_leaf_16_osc_clk u_core_u_seu_run_max_n_0_ net250 VDD VSS / sg13g2_dfrbpq_1
X_6599_ u_core_u_seu_u_run_max_qb_1_ clknet_leaf_16_osc_clk u_core_u_seu_run_max_n_1_ net250 VDD VSS / sg13g2_dfrbpq_1
X_6600_ u_core_u_seu_u_run_max_qb_2_ clknet_leaf_16_osc_clk u_core_u_seu_run_max_n_2_ net266 VDD VSS / sg13g2_dfrbpq_1
X_6601_ u_core_u_seu_u_run_max_qb_3_ clknet_leaf_16_osc_clk u_core_u_seu_run_max_n_3_ net266 VDD VSS / sg13g2_dfrbpq_1
X_6602_ u_core_u_seu_u_run_max_qb_4_ clknet_leaf_12_osc_clk u_core_u_seu_run_max_n_4_ net249 VDD VSS / sg13g2_dfrbpq_1
X_6603_ u_core_u_seu_u_run_max_qb_5_ clknet_leaf_16_osc_clk u_core_u_seu_run_max_n_5_ net247 VDD VSS / sg13g2_dfrbpq_1
X_6604_ u_core_u_seu_u_run_max_qb_6_ clknet_leaf_12_osc_clk u_core_u_seu_run_max_n_6_ net245 VDD VSS / sg13g2_dfrbpq_1
X_6605_ u_core_u_seu_u_run_max_qb_7_ clknet_leaf_13_osc_clk u_core_u_seu_run_max_n_7_ net245 VDD VSS / sg13g2_dfrbpq_1
X_6606_ u_core_u_seu_u_run_max_qa_0_ clknet_leaf_15_osc_clk u_core_u_seu_run_max_n_0_ net247 VDD VSS / sg13g2_dfrbpq_1
X_6607_ u_core_u_seu_u_run_max_qa_1_ clknet_leaf_15_osc_clk u_core_u_seu_run_max_n_1_ net247 VDD VSS / sg13g2_dfrbpq_1
X_6608_ u_core_u_seu_u_run_max_qa_2_ clknet_leaf_15_osc_clk u_core_u_seu_run_max_n_2_ net248 VDD VSS / sg13g2_dfrbpq_1
X_6609_ u_core_u_seu_u_run_max_qa_3_ clknet_leaf_15_osc_clk u_core_u_seu_run_max_n_3_ net248 VDD VSS / sg13g2_dfrbpq_1
X_6610_ u_core_u_seu_u_run_max_qa_4_ clknet_leaf_14_osc_clk u_core_u_seu_run_max_n_4_ net242 VDD VSS / sg13g2_dfrbpq_1
X_6611_ u_core_u_seu_u_run_max_qa_5_ clknet_leaf_15_osc_clk u_core_u_seu_run_max_n_5_ net242 VDD VSS / sg13g2_dfrbpq_1
X_6612_ u_core_u_seu_u_run_max_qa_6_ clknet_leaf_14_osc_clk u_core_u_seu_run_max_n_6_ net242 VDD VSS / sg13g2_dfrbpq_1
X_6613_ u_core_u_seu_u_run_max_qa_7_ clknet_leaf_14_osc_clk u_core_u_seu_run_max_n_7_ net241 VDD VSS / sg13g2_dfrbpq_1
X_6614_ u_core_u_seu_u_run_cur_qc_0_ clknet_leaf_22_osc_clk u_core_u_seu_run_cur_n_0_ net266 VDD VSS / sg13g2_dfrbpq_1
X_6615_ u_core_u_seu_u_run_cur_qc_1_ clknet_leaf_22_osc_clk u_core_u_seu_run_cur_n_1_ net267 VDD VSS / sg13g2_dfrbpq_1
X_6616_ u_core_u_seu_u_run_cur_qc_2_ clknet_leaf_22_osc_clk u_core_u_seu_run_cur_n_2_ net266 VDD VSS / sg13g2_dfrbpq_1
X_6617_ u_core_u_seu_u_run_cur_qc_3_ clknet_leaf_12_osc_clk u_core_u_seu_run_cur_n_3_ net250 VDD VSS / sg13g2_dfrbpq_1
X_6618_ u_core_u_seu_u_run_cur_qc_4_ clknet_leaf_12_osc_clk u_core_u_seu_run_cur_n_4_ net250 VDD VSS / sg13g2_dfrbpq_1
X_6619_ u_core_u_seu_u_run_cur_qc_5_ clknet_leaf_12_osc_clk u_core_u_seu_run_cur_n_5_ net249 VDD VSS / sg13g2_dfrbpq_1
X_6620_ u_core_u_seu_u_run_cur_qc_6_ clknet_leaf_12_osc_clk u_core_u_seu_run_cur_n_6_ net249 VDD VSS / sg13g2_dfrbpq_1
X_6621_ u_core_u_seu_u_run_cur_qc_7_ clknet_leaf_12_osc_clk u_core_u_seu_run_cur_n_7_ net249 VDD VSS / sg13g2_dfrbpq_1
X_6622_ u_core_u_seu_u_run_cur_qb_0_ clknet_leaf_16_osc_clk u_core_u_seu_run_cur_n_0_ net248 VDD VSS / sg13g2_dfrbpq_1
X_6623_ u_core_u_seu_u_run_cur_qb_1_ clknet_leaf_17_osc_clk u_core_u_seu_run_cur_n_1_ net262 VDD VSS / sg13g2_dfrbpq_1
X_6624_ u_core_u_seu_u_run_cur_qb_2_ clknet_leaf_16_osc_clk u_core_u_seu_run_cur_n_2_ net265 VDD VSS / sg13g2_dfrbpq_1
X_6625_ u_core_u_seu_u_run_cur_qb_3_ clknet_leaf_16_osc_clk u_core_u_seu_run_cur_n_3_ net248 VDD VSS / sg13g2_dfrbpq_1
X_6626_ u_core_u_seu_u_run_cur_qb_4_ clknet_leaf_16_osc_clk u_core_u_seu_run_cur_n_4_ net247 VDD VSS / sg13g2_dfrbpq_1
X_6627_ u_core_u_seu_u_run_cur_qb_5_ clknet_leaf_16_osc_clk u_core_u_seu_run_cur_n_5_ net247 VDD VSS / sg13g2_dfrbpq_1
X_6628_ u_core_u_seu_u_run_cur_qb_6_ clknet_leaf_14_osc_clk u_core_u_seu_run_cur_n_6_ net243 VDD VSS / sg13g2_dfrbpq_1
X_6629_ u_core_u_seu_u_run_cur_qb_7_ clknet_leaf_13_osc_clk u_core_u_seu_run_cur_n_7_ net243 VDD VSS / sg13g2_dfrbpq_1
X_6630_ u_core_u_seu_u_run_cur_qa_0_ clknet_leaf_15_osc_clk u_core_u_seu_run_cur_n_0_ net247 VDD VSS / sg13g2_dfrbpq_1
X_6631_ u_core_u_seu_u_run_cur_qa_1_ clknet_leaf_15_osc_clk u_core_u_seu_run_cur_n_1_ net248 VDD VSS / sg13g2_dfrbpq_1
X_6632_ u_core_u_seu_u_run_cur_qa_2_ clknet_leaf_15_osc_clk u_core_u_seu_run_cur_n_2_ net248 VDD VSS / sg13g2_dfrbpq_1
X_6633_ u_core_u_seu_u_run_cur_qa_3_ clknet_leaf_15_osc_clk u_core_u_seu_run_cur_n_3_ net247 VDD VSS / sg13g2_dfrbpq_1
X_6634_ u_core_u_seu_u_run_cur_qa_4_ clknet_leaf_15_osc_clk u_core_u_seu_run_cur_n_4_ net242 VDD VSS / sg13g2_dfrbpq_1
X_6635_ u_core_u_seu_u_run_cur_qa_5_ clknet_leaf_14_osc_clk u_core_u_seu_run_cur_n_5_ net243 VDD VSS / sg13g2_dfrbpq_1
X_6636_ u_core_u_seu_u_run_cur_qa_6_ clknet_leaf_14_osc_clk u_core_u_seu_run_cur_n_6_ net241 VDD VSS / sg13g2_dfrbpq_1
X_6637_ u_core_u_seu_u_run_cur_qa_7_ clknet_leaf_14_osc_clk u_core_u_seu_run_cur_n_7_ net241 VDD VSS / sg13g2_dfrbpq_1
X_6638_ u_core_u_trip_decay_pre_0_ clknet_leaf_26_osc_clk _0009_ net279 VDD VSS / sg13g2_dfrbpq_1
X_6639_ u_core_u_trip_decay_pre_1_ clknet_leaf_26_osc_clk _0010_ net279 VDD VSS / sg13g2_dfrbpq_1
X_6640_ u_core_u_trip_decay_pre_2_ clknet_leaf_26_osc_clk _0011_ net280 VDD VSS / sg13g2_dfrbpq_1
X_6641_ u_core_u_trip_decay_pre_3_ clknet_leaf_26_osc_clk _0012_ net283 VDD VSS / sg13g2_dfrbpq_1
X_6642_ u_core_u_trip_decay_pre_4_ clknet_leaf_26_osc_clk _0013_ net283 VDD VSS / sg13g2_dfrbpq_1
X_6643_ u_core_u_trip_decay_pre_5_ clknet_leaf_26_osc_clk _0014_ net283 VDD VSS / sg13g2_dfrbpq_1
X_6644_ u_core_u_trip_u_sync_in_s0_0_ clknet_leaf_15_osc_clk net2 net247 VDD VSS / sg13g2_dfrbpq_1
X_6645_ u_core_u_trip_u_sync_in_s0_1_ clknet_leaf_38_osc_clk net1 net306 VDD VSS / sg13g2_dfrbpq_1
X_6646_ u_core_u_trip_u_sync_in_s0_2_ clknet_leaf_38_osc_clk net6 net305 VDD VSS / sg13g2_dfrbpq_1
X_6647_ u_core_cmp_soft_s clknet_leaf_12_osc_clk net613 net249 VDD VSS / sg13g2_dfrbpq_1
X_6648_ u_core_cmp_hard_s clknet_leaf_38_osc_clk net584 net306 VDD VSS / sg13g2_dfrbpq_1
X_6649_ u_core_tripped_a_s clknet_leaf_38_osc_clk net450 net308 VDD VSS / sg13g2_dfrbpq_1
X_6650_ u_core_u_regfile_osc_pre_0_ clknet_leaf_21_osc_clk _0015_ net275 VDD VSS / sg13g2_dfrbpq_1
X_6651_ u_core_u_regfile_osc_pre_1_ clknet_leaf_24_osc_clk _0021_ net287 VDD VSS / sg13g2_dfrbpq_1
X_6652_ u_core_u_regfile_osc_pre_2_ clknet_leaf_24_osc_clk _0022_ net287 VDD VSS / sg13g2_dfrbpq_1
X_6653_ u_core_u_regfile_osc_pre_3_ clknet_leaf_24_osc_clk _0023_ net287 VDD VSS / sg13g2_dfrbpq_1
X_6654_ u_core_u_regfile_osc_pre_4_ clknet_leaf_24_osc_clk _0024_ net287 VDD VSS / sg13g2_dfrbpq_1
X_6655_ u_core_u_regfile_osc_pre_5_ clknet_leaf_24_osc_clk _0025_ net287 VDD VSS / sg13g2_dfrbpq_1
X_6656_ u_core_u_regfile_osc_pre_6_ clknet_leaf_23_osc_clk _0026_ net287 VDD VSS / sg13g2_dfrbpq_1
X_6657_ u_core_u_regfile_osc_pre_7_ clknet_leaf_23_osc_clk _0027_ net285 VDD VSS / sg13g2_dfrbpq_1
X_6658_ u_core_u_regfile_osc_pre_8_ clknet_leaf_24_osc_clk _0028_ net286 VDD VSS / sg13g2_dfrbpq_1
X_6659_ u_core_u_regfile_osc_pre_9_ clknet_leaf_23_osc_clk _0029_ net286 VDD VSS / sg13g2_dfrbpq_1
X_6660_ u_core_u_regfile_osc_pre_10_ clknet_leaf_24_osc_clk _0016_ net286 VDD VSS / sg13g2_dfrbpq_1
X_6661_ u_core_u_regfile_osc_pre_11_ clknet_leaf_23_osc_clk _0017_ net286 VDD VSS / sg13g2_dfrbpq_1
X_6662_ u_core_u_regfile_osc_pre_12_ clknet_leaf_22_osc_clk _0018_ net285 VDD VSS / sg13g2_dfrbpq_1
X_6663_ u_core_u_regfile_osc_pre_13_ clknet_leaf_23_osc_clk _0019_ net284 VDD VSS / sg13g2_dfrbpq_1
X_6664_ u_core_u_regfile_osc_pre_14_ clknet_leaf_23_osc_clk _0020_ net284 VDD VSS / sg13g2_dfrbpq_1
X_6665_ net35 net368 _0007_ net319 VDD VSS / sg13g2_dfrbpq_1
X_6666_ u_core_u_regfile_wr_en clknet_leaf_25_osc_clk _0008_ net291 VDD VSS / sg13g2_dfrbpq_1
X_6667_ u_core_rd_en clknet_leaf_31_osc_clk _0006_ net320 VDD VSS / sg13g2_dfrbpq_1
X_6668_ u_core_u_serial_frame_rst clknet_leaf_24_osc_clk _0005_ net292 VDD VSS / sg13g2_dfrbpq_1
X_6669_ u_core_u_serial_wr_tog_d clknet_leaf_25_osc_clk net635 net291 VDD VSS / sg13g2_dfrbpq_1
X_6670_ u_core_u_serial_rd_tog_d clknet_leaf_31_osc_clk net620 net320 VDD VSS / sg13g2_dfrbpq_1
X_6671_ u_core_u_serial_shreg_0_ clknet_3_0__leaf_sclk_regs net5 net281 VDD VSS / sg13g2_dfrbpq_1
X_6672_ u_core_u_serial_shreg_1_ clknet_3_3__leaf_sclk_regs u_core_u_serial_shreg_0_ net290 VDD VSS / sg13g2_dfrbpq_1
X_6673_ u_core_u_serial_shreg_2_ clknet_3_3__leaf_sclk_regs u_core_u_serial_shreg_1_ net291 VDD VSS / sg13g2_dfrbpq_1
X_6674_ u_core_u_serial_shreg_3_ clknet_3_3__leaf_sclk_regs u_core_u_serial_shreg_2_ net316 VDD VSS / sg13g2_dfrbpq_1
X_6675_ u_core_u_serial_shreg_4_ clknet_3_4__leaf_sclk_regs net639 net316 VDD VSS / sg13g2_dfrbpq_1
X_6676_ u_core_u_serial_shreg_5_ clknet_3_4__leaf_sclk_regs u_core_u_serial_shreg_4_ net316 VDD VSS / sg13g2_dfrbpq_1
X_6677_ u_core_u_serial_shreg_6_ clknet_3_4__leaf_sclk_regs u_core_u_serial_shreg_5_ net293 VDD VSS / sg13g2_dfrbpq_1
X_6678_ u_core_u_serial_bit_cnt_0_ clknet_3_2__leaf_sclk_regs _0000_ u_core_u_serial_sclk_rst_n VDD VSS / sg13g2_dfrbpq_1
X_6679_ u_core_u_serial_bit_cnt_1_ clknet_3_2__leaf_sclk_regs _0001_ u_core_u_serial_sclk_rst_n VDD VSS / sg13g2_dfrbpq_1
X_6680_ u_core_u_serial_bit_cnt_2_ clknet_3_2__leaf_sclk_regs _0002_ u_core_u_serial_sclk_rst_n VDD VSS / sg13g2_dfrbpq_1
X_6681_ u_core_u_serial_bit_cnt_3_ clknet_3_2__leaf_sclk_regs _0003_ u_core_u_serial_sclk_rst_n VDD VSS / sg13g2_dfrbpq_1
X_6682_ u_core_u_serial_bit_cnt_4_ clknet_3_6__leaf_sclk_regs _0004_ u_core_u_serial_sclk_rst_n VDD VSS / sg13g2_dfrbpq_1
X_6683_ u_core_u_serial_u_sync_sclk_s0_0_ clknet_leaf_25_osc_clk clknet_1_0__leaf_sclk net292 VDD VSS / sg13g2_dfrbpq_1
X_6684_ u_core_u_serial_u_sync_sclk_q_0_ clknet_leaf_25_osc_clk net470 net292 VDD VSS / sg13g2_dfrbpq_1
X_6685_ u_core_u_serial_u_sync_wr_s0_0_ clknet_leaf_25_osc_clk u_core_u_serial_u_sync_wr_d_0_ net290 VDD VSS / sg13g2_dfrbpq_1
X_6686_ u_core_u_serial_u_sync_wr_q_0_ clknet_leaf_25_osc_clk net558 net290 VDD VSS / sg13g2_dfrbpq_1
X_6687_ u_core_u_serial_u_sync_rd_s0_0_ clknet_leaf_25_osc_clk u_core_u_serial_u_sync_rd_d_0_ net293 VDD VSS / sg13g2_dfrbpq_1
X_6688_ u_core_u_serial_u_sync_rd_q_0_ clknet_leaf_25_osc_clk net441 net293 VDD VSS / sg13g2_dfrbpq_1
X_6689_ u_core_rs0 clknet_leaf_37_osc_clk net u_core_arst_n VDD VSS / sg13g2_dfrbpq_1
X_6689__368 net VDD VSS / sg13g2_tiehi
X_6690_ u_core_rs1 clknet_leaf_37_osc_clk net523 u_core_arst_n VDD VSS / sg13g2_dfrbpq_1
X_6691_ net10 clknet_leaf_38_osc_clk u_core_u_trip_hard_sample net308 VDD VSS / sg13g2_dfrbpq_1
X_6693_ net41 net38 VDD VSS / sg13g2_buf_1
Xclkbuf_0_osc_clk clknet_0_osc_clk osc_clk VDD VSS / sg13g2_buf_16
Xclkbuf_0_sclk clknet_0_sclk sclk VDD VSS / sg13g2_buf_16
Xclkbuf_0_sclk_regs clknet_0_sclk_regs sclk_regs VDD VSS / sg13g2_buf_16
Xclkbuf_1_0__f_sclk clknet_1_0__leaf_sclk clknet_0_sclk VDD VSS / sg13g2_buf_16
Xclkbuf_3_0__f_sclk_regs clknet_3_0__leaf_sclk_regs clknet_0_sclk_regs VDD VSS / sg13g2_buf_16
Xclkbuf_3_1__f_sclk_regs clknet_3_1__leaf_sclk_regs clknet_0_sclk_regs VDD VSS / sg13g2_buf_16
Xclkbuf_3_2__f_sclk_regs clknet_3_2__leaf_sclk_regs clknet_0_sclk_regs VDD VSS / sg13g2_buf_16
Xclkbuf_3_3__f_sclk_regs clknet_3_3__leaf_sclk_regs clknet_0_sclk_regs VDD VSS / sg13g2_buf_16
Xclkbuf_3_4__f_sclk_regs clknet_3_4__leaf_sclk_regs clknet_0_sclk_regs VDD VSS / sg13g2_buf_16
Xclkbuf_3_5__f_sclk_regs clknet_3_5__leaf_sclk_regs clknet_0_sclk_regs VDD VSS / sg13g2_buf_16
Xclkbuf_3_6__f_sclk_regs clknet_3_6__leaf_sclk_regs clknet_0_sclk_regs VDD VSS / sg13g2_buf_16
Xclkbuf_3_7__f_sclk_regs clknet_3_7__leaf_sclk_regs clknet_0_sclk_regs VDD VSS / sg13g2_buf_16
Xclkbuf_4_0_0_osc_clk clknet_4_0_0_osc_clk clknet_0_osc_clk VDD VSS / sg13g2_buf_8
Xclkbuf_4_10_0_osc_clk clknet_4_10_0_osc_clk clknet_0_osc_clk VDD VSS / sg13g2_buf_8
Xclkbuf_4_11_0_osc_clk clknet_4_11_0_osc_clk clknet_0_osc_clk VDD VSS / sg13g2_buf_8
Xclkbuf_4_12_0_osc_clk clknet_4_12_0_osc_clk clknet_0_osc_clk VDD VSS / sg13g2_buf_8
Xclkbuf_4_13_0_osc_clk clknet_4_13_0_osc_clk clknet_0_osc_clk VDD VSS / sg13g2_buf_8
Xclkbuf_4_14_0_osc_clk clknet_4_14_0_osc_clk clknet_0_osc_clk VDD VSS / sg13g2_buf_8
Xclkbuf_4_15_0_osc_clk clknet_4_15_0_osc_clk clknet_0_osc_clk VDD VSS / sg13g2_buf_8
Xclkbuf_4_1_0_osc_clk clknet_4_1_0_osc_clk clknet_0_osc_clk VDD VSS / sg13g2_buf_8
Xclkbuf_4_2_0_osc_clk clknet_4_2_0_osc_clk clknet_0_osc_clk VDD VSS / sg13g2_buf_8
Xclkbuf_4_3_0_osc_clk clknet_4_3_0_osc_clk clknet_0_osc_clk VDD VSS / sg13g2_buf_8
Xclkbuf_4_4_0_osc_clk clknet_4_4_0_osc_clk clknet_0_osc_clk VDD VSS / sg13g2_buf_8
Xclkbuf_4_5_0_osc_clk clknet_4_5_0_osc_clk clknet_0_osc_clk VDD VSS / sg13g2_buf_8
Xclkbuf_4_6_0_osc_clk clknet_4_6_0_osc_clk clknet_0_osc_clk VDD VSS / sg13g2_buf_8
Xclkbuf_4_7_0_osc_clk clknet_4_7_0_osc_clk clknet_0_osc_clk VDD VSS / sg13g2_buf_8
Xclkbuf_4_8_0_osc_clk clknet_4_8_0_osc_clk clknet_0_osc_clk VDD VSS / sg13g2_buf_8
Xclkbuf_4_9_0_osc_clk clknet_4_9_0_osc_clk clknet_0_osc_clk VDD VSS / sg13g2_buf_8
Xclkbuf_leaf_0_osc_clk clknet_leaf_0_osc_clk clknet_4_0_0_osc_clk VDD VSS / sg13g2_buf_8
Xclkbuf_leaf_10_osc_clk clknet_leaf_10_osc_clk clknet_4_6_0_osc_clk VDD VSS / sg13g2_buf_8
Xclkbuf_leaf_11_osc_clk clknet_leaf_11_osc_clk clknet_4_6_0_osc_clk VDD VSS / sg13g2_buf_8
Xclkbuf_leaf_12_osc_clk clknet_leaf_12_osc_clk clknet_4_6_0_osc_clk VDD VSS / sg13g2_buf_8
Xclkbuf_leaf_13_osc_clk clknet_leaf_13_osc_clk clknet_4_4_0_osc_clk VDD VSS / sg13g2_buf_8
Xclkbuf_leaf_14_osc_clk clknet_leaf_14_osc_clk clknet_4_4_0_osc_clk VDD VSS / sg13g2_buf_8
Xclkbuf_leaf_15_osc_clk clknet_leaf_15_osc_clk clknet_4_4_0_osc_clk VDD VSS / sg13g2_buf_8
Xclkbuf_leaf_16_osc_clk clknet_leaf_16_osc_clk clknet_4_4_0_osc_clk VDD VSS / sg13g2_buf_8
Xclkbuf_leaf_17_osc_clk clknet_leaf_17_osc_clk clknet_4_4_0_osc_clk VDD VSS / sg13g2_buf_8
Xclkbuf_leaf_18_osc_clk clknet_leaf_18_osc_clk clknet_4_5_0_osc_clk VDD VSS / sg13g2_buf_8
Xclkbuf_leaf_19_osc_clk clknet_leaf_19_osc_clk clknet_4_5_0_osc_clk VDD VSS / sg13g2_buf_8
Xclkbuf_leaf_1_osc_clk clknet_leaf_1_osc_clk clknet_4_0_0_osc_clk VDD VSS / sg13g2_buf_8
Xclkbuf_leaf_20_osc_clk clknet_leaf_20_osc_clk clknet_4_5_0_osc_clk VDD VSS / sg13g2_buf_8
Xclkbuf_leaf_21_osc_clk clknet_leaf_21_osc_clk clknet_4_5_0_osc_clk VDD VSS / sg13g2_buf_8
Xclkbuf_leaf_22_osc_clk clknet_leaf_22_osc_clk clknet_4_5_0_osc_clk VDD VSS / sg13g2_buf_8
Xclkbuf_leaf_23_osc_clk clknet_leaf_23_osc_clk clknet_4_7_0_osc_clk VDD VSS / sg13g2_buf_8
Xclkbuf_leaf_24_osc_clk clknet_leaf_24_osc_clk clknet_4_7_0_osc_clk VDD VSS / sg13g2_buf_8
Xclkbuf_leaf_25_osc_clk clknet_leaf_25_osc_clk clknet_4_7_0_osc_clk VDD VSS / sg13g2_buf_8
Xclkbuf_leaf_26_osc_clk clknet_leaf_26_osc_clk clknet_4_7_0_osc_clk VDD VSS / sg13g2_buf_8
Xclkbuf_leaf_27_osc_clk clknet_leaf_27_osc_clk clknet_4_6_0_osc_clk VDD VSS / sg13g2_buf_8
Xclkbuf_leaf_28_osc_clk clknet_leaf_28_osc_clk clknet_4_6_0_osc_clk VDD VSS / sg13g2_buf_8
Xclkbuf_leaf_29_osc_clk clknet_leaf_29_osc_clk clknet_4_13_0_osc_clk VDD VSS / sg13g2_buf_8
Xclkbuf_leaf_2_osc_clk clknet_leaf_2_osc_clk clknet_4_1_0_osc_clk VDD VSS / sg13g2_buf_8
Xclkbuf_leaf_30_osc_clk clknet_leaf_30_osc_clk clknet_4_13_0_osc_clk VDD VSS / sg13g2_buf_8
Xclkbuf_leaf_31_osc_clk clknet_leaf_31_osc_clk clknet_4_13_0_osc_clk VDD VSS / sg13g2_buf_8
Xclkbuf_leaf_32_osc_clk clknet_leaf_32_osc_clk clknet_4_15_0_osc_clk VDD VSS / sg13g2_buf_8
Xclkbuf_leaf_33_osc_clk clknet_leaf_33_osc_clk clknet_4_15_0_osc_clk VDD VSS / sg13g2_buf_8
Xclkbuf_leaf_34_osc_clk clknet_leaf_34_osc_clk clknet_4_15_0_osc_clk VDD VSS / sg13g2_buf_8
Xclkbuf_leaf_35_osc_clk clknet_leaf_35_osc_clk clknet_4_15_0_osc_clk VDD VSS / sg13g2_buf_8
Xclkbuf_leaf_36_osc_clk clknet_leaf_36_osc_clk clknet_4_14_0_osc_clk VDD VSS / sg13g2_buf_8
Xclkbuf_leaf_37_osc_clk clknet_leaf_37_osc_clk clknet_4_14_0_osc_clk VDD VSS / sg13g2_buf_8
Xclkbuf_leaf_38_osc_clk clknet_leaf_38_osc_clk clknet_4_14_0_osc_clk VDD VSS / sg13g2_buf_8
Xclkbuf_leaf_39_osc_clk clknet_leaf_39_osc_clk clknet_4_12_0_osc_clk VDD VSS / sg13g2_buf_8
Xclkbuf_leaf_3_osc_clk clknet_leaf_3_osc_clk clknet_4_1_0_osc_clk VDD VSS / sg13g2_buf_8
Xclkbuf_leaf_40_osc_clk clknet_leaf_40_osc_clk clknet_4_13_0_osc_clk VDD VSS / sg13g2_buf_8
Xclkbuf_leaf_41_osc_clk clknet_leaf_41_osc_clk clknet_4_13_0_osc_clk VDD VSS / sg13g2_buf_8
Xclkbuf_leaf_42_osc_clk clknet_leaf_42_osc_clk clknet_4_12_0_osc_clk VDD VSS / sg13g2_buf_8
Xclkbuf_leaf_43_osc_clk clknet_leaf_43_osc_clk clknet_4_12_0_osc_clk VDD VSS / sg13g2_buf_8
Xclkbuf_leaf_44_osc_clk clknet_leaf_44_osc_clk clknet_4_12_0_osc_clk VDD VSS / sg13g2_buf_8
Xclkbuf_leaf_45_osc_clk clknet_leaf_45_osc_clk clknet_4_12_0_osc_clk VDD VSS / sg13g2_buf_8
Xclkbuf_leaf_46_osc_clk clknet_leaf_46_osc_clk clknet_4_14_0_osc_clk VDD VSS / sg13g2_buf_8
Xclkbuf_leaf_47_osc_clk clknet_leaf_47_osc_clk clknet_4_14_0_osc_clk VDD VSS / sg13g2_buf_8
Xclkbuf_leaf_48_osc_clk clknet_leaf_48_osc_clk clknet_4_11_0_osc_clk VDD VSS / sg13g2_buf_8
Xclkbuf_leaf_49_osc_clk clknet_leaf_49_osc_clk clknet_4_11_0_osc_clk VDD VSS / sg13g2_buf_8
Xclkbuf_leaf_4_osc_clk clknet_leaf_4_osc_clk clknet_4_1_0_osc_clk VDD VSS / sg13g2_buf_8
Xclkbuf_leaf_50_osc_clk clknet_leaf_50_osc_clk clknet_4_11_0_osc_clk VDD VSS / sg13g2_buf_8
Xclkbuf_leaf_51_osc_clk clknet_leaf_51_osc_clk clknet_4_11_0_osc_clk VDD VSS / sg13g2_buf_8
Xclkbuf_leaf_52_osc_clk clknet_leaf_52_osc_clk clknet_4_11_0_osc_clk VDD VSS / sg13g2_buf_8
Xclkbuf_leaf_53_osc_clk clknet_leaf_53_osc_clk clknet_4_10_0_osc_clk VDD VSS / sg13g2_buf_8
Xclkbuf_leaf_54_osc_clk clknet_leaf_54_osc_clk clknet_4_10_0_osc_clk VDD VSS / sg13g2_buf_8
Xclkbuf_leaf_55_osc_clk clknet_leaf_55_osc_clk clknet_4_10_0_osc_clk VDD VSS / sg13g2_buf_8
Xclkbuf_leaf_56_osc_clk clknet_leaf_56_osc_clk clknet_4_10_0_osc_clk VDD VSS / sg13g2_buf_8
Xclkbuf_leaf_57_osc_clk clknet_leaf_57_osc_clk clknet_4_10_0_osc_clk VDD VSS / sg13g2_buf_8
Xclkbuf_leaf_58_osc_clk clknet_leaf_58_osc_clk clknet_4_8_0_osc_clk VDD VSS / sg13g2_buf_8
Xclkbuf_leaf_59_osc_clk clknet_leaf_59_osc_clk clknet_4_8_0_osc_clk VDD VSS / sg13g2_buf_8
Xclkbuf_leaf_5_osc_clk clknet_leaf_5_osc_clk clknet_4_1_0_osc_clk VDD VSS / sg13g2_buf_8
Xclkbuf_leaf_60_osc_clk clknet_leaf_60_osc_clk clknet_4_8_0_osc_clk VDD VSS / sg13g2_buf_8
Xclkbuf_leaf_61_osc_clk clknet_leaf_61_osc_clk clknet_4_8_0_osc_clk VDD VSS / sg13g2_buf_8
Xclkbuf_leaf_62_osc_clk clknet_leaf_62_osc_clk clknet_4_9_0_osc_clk VDD VSS / sg13g2_buf_8
Xclkbuf_leaf_63_osc_clk clknet_leaf_63_osc_clk clknet_4_9_0_osc_clk VDD VSS / sg13g2_buf_8
Xclkbuf_leaf_64_osc_clk clknet_leaf_64_osc_clk clknet_4_9_0_osc_clk VDD VSS / sg13g2_buf_8
Xclkbuf_leaf_65_osc_clk clknet_leaf_65_osc_clk clknet_4_9_0_osc_clk VDD VSS / sg13g2_buf_8
Xclkbuf_leaf_66_osc_clk clknet_leaf_66_osc_clk clknet_4_3_0_osc_clk VDD VSS / sg13g2_buf_8
Xclkbuf_leaf_67_osc_clk clknet_leaf_67_osc_clk clknet_4_3_0_osc_clk VDD VSS / sg13g2_buf_8
Xclkbuf_leaf_68_osc_clk clknet_leaf_68_osc_clk clknet_4_2_0_osc_clk VDD VSS / sg13g2_buf_8
Xclkbuf_leaf_69_osc_clk clknet_leaf_69_osc_clk clknet_4_2_0_osc_clk VDD VSS / sg13g2_buf_8
Xclkbuf_leaf_6_osc_clk clknet_leaf_6_osc_clk clknet_4_1_0_osc_clk VDD VSS / sg13g2_buf_8
Xclkbuf_leaf_70_osc_clk clknet_leaf_70_osc_clk clknet_4_9_0_osc_clk VDD VSS / sg13g2_buf_8
Xclkbuf_leaf_71_osc_clk clknet_leaf_71_osc_clk clknet_4_8_0_osc_clk VDD VSS / sg13g2_buf_8
Xclkbuf_leaf_72_osc_clk clknet_leaf_72_osc_clk clknet_4_2_0_osc_clk VDD VSS / sg13g2_buf_8
Xclkbuf_leaf_73_osc_clk clknet_leaf_73_osc_clk clknet_4_2_0_osc_clk VDD VSS / sg13g2_buf_8
Xclkbuf_leaf_74_osc_clk clknet_leaf_74_osc_clk clknet_4_2_0_osc_clk VDD VSS / sg13g2_buf_8
Xclkbuf_leaf_75_osc_clk clknet_leaf_75_osc_clk clknet_4_0_0_osc_clk VDD VSS / sg13g2_buf_8
Xclkbuf_leaf_76_osc_clk clknet_leaf_76_osc_clk clknet_4_0_0_osc_clk VDD VSS / sg13g2_buf_8
Xclkbuf_leaf_77_osc_clk clknet_leaf_77_osc_clk clknet_4_0_0_osc_clk VDD VSS / sg13g2_buf_8
Xclkbuf_leaf_7_osc_clk clknet_leaf_7_osc_clk clknet_4_3_0_osc_clk VDD VSS / sg13g2_buf_8
Xclkbuf_leaf_8_osc_clk clknet_leaf_8_osc_clk clknet_4_3_0_osc_clk VDD VSS / sg13g2_buf_8
Xclkbuf_leaf_9_osc_clk clknet_leaf_9_osc_clk clknet_4_3_0_osc_clk VDD VSS / sg13g2_buf_8
Xclkbuf_regs_0_sclk sclk_regs sclk VDD VSS / sg13g2_buf_16
Xclkload0 _nc1 clknet_4_7_0_osc_clk VDD VSS / sg13g2_buf_8
Xclkload1 _nc2 clknet_4_15_0_osc_clk VDD VSS / sg13g2_buf_8
Xclkload10 _nc3 clknet_leaf_7_osc_clk VDD VSS / sg13g2_inv_1
Xclkload11 _nc4 clknet_leaf_9_osc_clk VDD VSS / sg13g2_inv_1
Xclkload12 _nc5 clknet_leaf_66_osc_clk VDD VSS / sg13g2_buf_8
Xclkload13 _nc6 clknet_leaf_67_osc_clk VDD VSS / sg13g2_inv_2
Xclkload14 _nc7 clknet_leaf_13_osc_clk VDD VSS / sg13g2_inv_2
Xclkload15 _nc8 clknet_leaf_14_osc_clk VDD VSS / sg13g2_buf_8
Xclkload16 _nc9 clknet_leaf_15_osc_clk VDD VSS / sg13g2_inv_2
Xclkload17 _nc10 clknet_leaf_16_osc_clk VDD VSS / sg13g2_inv_1
Xclkload18 _nc11 clknet_leaf_18_osc_clk VDD VSS / sg13g2_inv_1
Xclkload19 _nc12 clknet_leaf_20_osc_clk VDD VSS / sg13g2_inv_1
Xclkload2 _nc13 clknet_leaf_0_osc_clk VDD VSS / sg13g2_inv_1
Xclkload20 _nc14 clknet_leaf_22_osc_clk VDD VSS / sg13g2_buf_8
Xclkload21 _nc15 clknet_leaf_10_osc_clk VDD VSS / sg13g2_inv_1
Xclkload22 _nc16 clknet_leaf_11_osc_clk VDD VSS / sg13g2_inv_1
Xclkload23 _nc17 clknet_leaf_27_osc_clk VDD VSS / sg13g2_buf_8
Xclkload24 _nc18 clknet_leaf_28_osc_clk VDD VSS / sg13g2_inv_2
Xclkload25 _nc19 clknet_leaf_23_osc_clk VDD VSS / sg13g2_inv_1
Xclkload26 _nc20 clknet_leaf_25_osc_clk VDD VSS / sg13g2_inv_8
Xclkload27 _nc21 clknet_leaf_59_osc_clk VDD VSS / sg13g2_inv_2
Xclkload28 _nc22 clknet_leaf_60_osc_clk VDD VSS / sg13g2_buf_8
Xclkload29 _nc23 clknet_leaf_61_osc_clk VDD VSS / sg13g2_inv_2
Xclkload3 _nc24 clknet_leaf_2_osc_clk VDD VSS / sg13g2_inv_1
Xclkload30 _nc25 clknet_leaf_71_osc_clk VDD VSS / sg13g2_buf_8
Xclkload31 _nc26 clknet_leaf_70_osc_clk VDD VSS / sg13g2_inv_1
Xclkload32 _nc27 clknet_leaf_53_osc_clk VDD VSS / sg13g2_inv_1
Xclkload33 _nc28 clknet_leaf_54_osc_clk VDD VSS / sg13g2_inv_2
Xclkload34 _nc29 clknet_leaf_55_osc_clk VDD VSS / sg13g2_inv_2
Xclkload35 _nc30 clknet_leaf_57_osc_clk VDD VSS / sg13g2_inv_2
Xclkload36 _nc31 clknet_leaf_48_osc_clk VDD VSS / sg13g2_inv_4
Xclkload37 _nc32 clknet_leaf_51_osc_clk VDD VSS / sg13g2_inv_2
Xclkload38 _nc33 clknet_leaf_42_osc_clk VDD VSS / sg13g2_inv_2
Xclkload39 _nc34 clknet_leaf_43_osc_clk VDD VSS / sg13g2_inv_1
Xclkload4 _nc35 clknet_leaf_3_osc_clk VDD VSS / sg13g2_inv_1
Xclkload40 _nc36 clknet_leaf_31_osc_clk VDD VSS / sg13g2_inv_4
Xclkload41 _nc37 clknet_leaf_40_osc_clk VDD VSS / sg13g2_buf_8
Xclkload42 _nc38 clknet_leaf_41_osc_clk VDD VSS / sg13g2_inv_4
Xclkload43 _nc39 clknet_leaf_36_osc_clk VDD VSS / sg13g2_inv_4
Xclkload44 _nc40 clknet_leaf_46_osc_clk VDD VSS / sg13g2_inv_1
Xclkload45 _nc41 clknet_leaf_47_osc_clk VDD VSS / sg13g2_inv_1
Xclkload46 _nc42 clknet_leaf_32_osc_clk VDD VSS / sg13g2_inv_2
Xclkload47 _nc43 clknet_leaf_33_osc_clk VDD VSS / sg13g2_inv_2
Xclkload48 _nc44 clknet_leaf_34_osc_clk VDD VSS / sg13g2_buf_8
Xclkload49 _nc45 clknet_3_0__leaf_sclk_regs VDD VSS / sg13g2_inv_1
Xclkload5 _nc46 clknet_leaf_4_osc_clk VDD VSS / sg13g2_inv_1
Xclkload50 _nc47 clknet_3_1__leaf_sclk_regs VDD VSS / sg13g2_inv_1
Xclkload51 _nc48 clknet_3_2__leaf_sclk_regs VDD VSS / sg13g2_inv_1
Xclkload52 _nc49 clknet_3_3__leaf_sclk_regs VDD VSS / sg13g2_inv_1
Xclkload53 _nc50 clknet_3_4__leaf_sclk_regs VDD VSS / sg13g2_inv_1
Xclkload54 _nc51 clknet_3_5__leaf_sclk_regs VDD VSS / sg13g2_inv_1
Xclkload55 _nc52 clknet_3_7__leaf_sclk_regs VDD VSS / sg13g2_inv_1
Xclkload6 _nc53 clknet_leaf_6_osc_clk VDD VSS / sg13g2_inv_1
Xclkload7 _nc54 clknet_leaf_68_osc_clk VDD VSS / sg13g2_inv_2
Xclkload8 _nc55 clknet_leaf_72_osc_clk VDD VSS / sg13g2_inv_1
Xclkload9 _nc56 clknet_leaf_74_osc_clk VDD VSS / sg13g2_inv_2
Xfanout100 net100 _1935_ VDD VSS / sg13g2_buf_1
Xfanout101 net101 _1934_ VDD VSS / sg13g2_buf_1
Xfanout102 net102 _1929_ VDD VSS / sg13g2_buf_1
Xfanout104 net104 _1894_ VDD VSS / sg13g2_buf_1
Xfanout105 net105 _1889_ VDD VSS / sg13g2_buf_1
Xfanout106 net106 _1889_ VDD VSS / sg13g2_buf_1
Xfanout107 net107 _1862_ VDD VSS / sg13g2_buf_1
Xfanout108 net108 _1853_ VDD VSS / sg13g2_buf_1
Xfanout109 net109 _1853_ VDD VSS / sg13g2_buf_1
Xfanout110 net110 _1845_ VDD VSS / sg13g2_buf_1
Xfanout111 net111 _1845_ VDD VSS / sg13g2_buf_1
Xfanout112 net112 _1748_ VDD VSS / sg13g2_buf_1
Xfanout113 net113 _1739_ VDD VSS / sg13g2_buf_1
Xfanout114 net114 _1739_ VDD VSS / sg13g2_buf_1
Xfanout115 net115 net117 VDD VSS / sg13g2_buf_1
Xfanout116 net116 net117 VDD VSS / sg13g2_buf_1
Xfanout117 net117 _1730_ VDD VSS / sg13g2_buf_1
Xfanout118 net118 net119 VDD VSS / sg13g2_buf_1
Xfanout119 net119 net120 VDD VSS / sg13g2_buf_1
Xfanout120 net120 _1709_ VDD VSS / sg13g2_buf_1
Xfanout121 net121 _1707_ VDD VSS / sg13g2_buf_1
Xfanout122 net122 _0494_ VDD VSS / sg13g2_buf_1
Xfanout123 net123 _0494_ VDD VSS / sg13g2_buf_1
Xfanout124 net124 net127 VDD VSS / sg13g2_buf_1
Xfanout125 net125 net127 VDD VSS / sg13g2_buf_1
Xfanout126 net126 net127 VDD VSS / sg13g2_buf_1
Xfanout127 net127 net153 VDD VSS / sg13g2_buf_1
Xfanout128 net128 net131 VDD VSS / sg13g2_buf_1
Xfanout129 net129 net131 VDD VSS / sg13g2_buf_1
Xfanout130 net130 net131 VDD VSS / sg13g2_buf_1
Xfanout131 net131 net153 VDD VSS / sg13g2_buf_1
Xfanout132 net132 net135 VDD VSS / sg13g2_buf_1
Xfanout133 net133 net135 VDD VSS / sg13g2_buf_1
Xfanout134 net134 net135 VDD VSS / sg13g2_buf_1
Xfanout135 net135 net139 VDD VSS / sg13g2_buf_1
Xfanout136 net136 net139 VDD VSS / sg13g2_buf_1
Xfanout137 net137 net139 VDD VSS / sg13g2_buf_1
Xfanout138 net138 net139 VDD VSS / sg13g2_buf_1
Xfanout139 net139 net153 VDD VSS / sg13g2_buf_1
Xfanout140 net140 net142 VDD VSS / sg13g2_buf_1
Xfanout141 net141 net142 VDD VSS / sg13g2_buf_1
Xfanout142 net142 net152 VDD VSS / sg13g2_buf_1
Xfanout143 net143 net145 VDD VSS / sg13g2_buf_1
Xfanout144 net144 net152 VDD VSS / sg13g2_buf_1
Xfanout145 net145 net152 VDD VSS / sg13g2_buf_1
Xfanout146 net146 net148 VDD VSS / sg13g2_buf_1
Xfanout147 net147 net148 VDD VSS / sg13g2_buf_1
Xfanout148 net148 net152 VDD VSS / sg13g2_buf_1
Xfanout149 net149 net151 VDD VSS / sg13g2_buf_1
Xfanout150 net150 net151 VDD VSS / sg13g2_buf_1
Xfanout151 net151 net152 VDD VSS / sg13g2_buf_1
Xfanout152 net152 net153 VDD VSS / sg13g2_buf_1
Xfanout153 net153 net333 VDD VSS / sg13g2_buf_1
Xfanout154 net154 net156 VDD VSS / sg13g2_buf_1
Xfanout155 net155 net156 VDD VSS / sg13g2_buf_1
Xfanout156 net156 net160 VDD VSS / sg13g2_buf_1
Xfanout157 net157 net160 VDD VSS / sg13g2_buf_1
Xfanout158 net158 net159 VDD VSS / sg13g2_buf_1
Xfanout159 net159 net160 VDD VSS / sg13g2_buf_1
Xfanout160 net160 net179 VDD VSS / sg13g2_buf_1
Xfanout161 net161 net164 VDD VSS / sg13g2_buf_1
Xfanout162 net162 net164 VDD VSS / sg13g2_buf_1
Xfanout163 net163 net164 VDD VSS / sg13g2_buf_1
Xfanout164 net164 net167 VDD VSS / sg13g2_buf_1
Xfanout165 net165 net166 VDD VSS / sg13g2_buf_1
Xfanout166 net166 net167 VDD VSS / sg13g2_buf_1
Xfanout167 net167 net179 VDD VSS / sg13g2_buf_1
Xfanout168 net168 net170 VDD VSS / sg13g2_buf_1
Xfanout169 net169 net170 VDD VSS / sg13g2_buf_1
Xfanout170 net170 net179 VDD VSS / sg13g2_buf_1
Xfanout171 net171 net173 VDD VSS / sg13g2_buf_1
Xfanout172 net172 net173 VDD VSS / sg13g2_buf_1
Xfanout173 net173 net179 VDD VSS / sg13g2_buf_1
Xfanout174 net174 net175 VDD VSS / sg13g2_buf_1
Xfanout175 net175 net178 VDD VSS / sg13g2_buf_1
Xfanout176 net176 net177 VDD VSS / sg13g2_buf_1
Xfanout177 net177 net178 VDD VSS / sg13g2_buf_1
Xfanout178 net178 net179 VDD VSS / sg13g2_buf_1
Xfanout179 net179 net333 VDD VSS / sg13g2_buf_1
Xfanout180 net180 net181 VDD VSS / sg13g2_buf_1
Xfanout181 net181 net194 VDD VSS / sg13g2_buf_1
Xfanout182 net182 net183 VDD VSS / sg13g2_buf_1
Xfanout183 net183 net186 VDD VSS / sg13g2_buf_1
Xfanout184 net184 net185 VDD VSS / sg13g2_buf_1
Xfanout185 net185 net186 VDD VSS / sg13g2_buf_1
Xfanout186 net186 net194 VDD VSS / sg13g2_buf_1
Xfanout187 net187 net189 VDD VSS / sg13g2_buf_1
Xfanout188 net188 net189 VDD VSS / sg13g2_buf_1
Xfanout189 net189 net194 VDD VSS / sg13g2_buf_1
Xfanout190 net190 net191 VDD VSS / sg13g2_buf_1
Xfanout191 net191 net193 VDD VSS / sg13g2_buf_1
Xfanout192 net192 net193 VDD VSS / sg13g2_buf_1
Xfanout193 net193 net194 VDD VSS / sg13g2_buf_1
Xfanout194 net194 net215 VDD VSS / sg13g2_buf_1
Xfanout195 net195 net199 VDD VSS / sg13g2_buf_1
Xfanout196 net196 net199 VDD VSS / sg13g2_buf_1
Xfanout197 net197 net199 VDD VSS / sg13g2_buf_1
Xfanout198 net198 net199 VDD VSS / sg13g2_buf_1
Xfanout199 net199 net205 VDD VSS / sg13g2_buf_1
Xfanout200 net200 net201 VDD VSS / sg13g2_buf_1
Xfanout201 net201 net205 VDD VSS / sg13g2_buf_1
Xfanout202 net202 net204 VDD VSS / sg13g2_buf_1
Xfanout203 net203 net204 VDD VSS / sg13g2_buf_1
Xfanout204 net204 net205 VDD VSS / sg13g2_buf_1
Xfanout205 net205 net215 VDD VSS / sg13g2_buf_1
Xfanout206 net206 net209 VDD VSS / sg13g2_buf_1
Xfanout207 net207 net209 VDD VSS / sg13g2_buf_1
Xfanout208 net208 net209 VDD VSS / sg13g2_buf_1
Xfanout209 net209 net215 VDD VSS / sg13g2_buf_1
Xfanout210 net210 net211 VDD VSS / sg13g2_buf_1
Xfanout211 net211 net214 VDD VSS / sg13g2_buf_1
Xfanout212 net212 net214 VDD VSS / sg13g2_buf_1
Xfanout213 net213 net214 VDD VSS / sg13g2_buf_1
Xfanout214 net214 net215 VDD VSS / sg13g2_buf_1
Xfanout215 net215 net240 VDD VSS / sg13g2_buf_1
Xfanout216 net216 net219 VDD VSS / sg13g2_buf_1
Xfanout217 net217 net219 VDD VSS / sg13g2_buf_1
Xfanout218 net218 net219 VDD VSS / sg13g2_buf_1
Xfanout219 net219 net222 VDD VSS / sg13g2_buf_1
Xfanout220 net220 net221 VDD VSS / sg13g2_buf_1
Xfanout221 net221 net222 VDD VSS / sg13g2_buf_1
Xfanout222 net222 net240 VDD VSS / sg13g2_buf_1
Xfanout223 net223 net224 VDD VSS / sg13g2_buf_1
Xfanout224 net224 net227 VDD VSS / sg13g2_buf_1
Xfanout225 net225 net226 VDD VSS / sg13g2_buf_1
Xfanout226 net226 net227 VDD VSS / sg13g2_buf_1
Xfanout227 net227 net240 VDD VSS / sg13g2_buf_1
Xfanout228 net228 net239 VDD VSS / sg13g2_buf_1
Xfanout229 net229 net239 VDD VSS / sg13g2_buf_1
Xfanout230 net230 net231 VDD VSS / sg13g2_buf_1
Xfanout231 net231 net233 VDD VSS / sg13g2_buf_1
Xfanout232 net232 net233 VDD VSS / sg13g2_buf_1
Xfanout233 net233 net239 VDD VSS / sg13g2_buf_1
Xfanout234 net234 net239 VDD VSS / sg13g2_buf_1
Xfanout235 net235 net239 VDD VSS / sg13g2_buf_1
Xfanout236 net236 net238 VDD VSS / sg13g2_buf_1
Xfanout237 net237 net238 VDD VSS / sg13g2_buf_1
Xfanout238 net238 net239 VDD VSS / sg13g2_buf_1
Xfanout239 net239 net240 VDD VSS / sg13g2_buf_1
Xfanout240 net240 net333 VDD VSS / sg13g2_buf_1
Xfanout241 net241 net246 VDD VSS / sg13g2_buf_1
Xfanout242 net242 net243 VDD VSS / sg13g2_buf_1
Xfanout243 net243 net246 VDD VSS / sg13g2_buf_1
Xfanout244 net244 net246 VDD VSS / sg13g2_buf_1
Xfanout245 net245 net246 VDD VSS / sg13g2_buf_1
Xfanout246 net246 net260 VDD VSS / sg13g2_buf_1
Xfanout247 net247 net251 VDD VSS / sg13g2_buf_1
Xfanout248 net248 net251 VDD VSS / sg13g2_buf_1
Xfanout249 net249 net251 VDD VSS / sg13g2_buf_1
Xfanout250 net250 net251 VDD VSS / sg13g2_buf_1
Xfanout251 net251 net260 VDD VSS / sg13g2_buf_1
Xfanout252 net252 net256 VDD VSS / sg13g2_buf_1
Xfanout253 net253 net256 VDD VSS / sg13g2_buf_1
Xfanout254 net254 net256 VDD VSS / sg13g2_buf_1
Xfanout255 net255 net256 VDD VSS / sg13g2_buf_1
Xfanout256 net256 net260 VDD VSS / sg13g2_buf_1
Xfanout257 net257 net258 VDD VSS / sg13g2_buf_1
Xfanout258 net258 net260 VDD VSS / sg13g2_buf_1
Xfanout259 net259 net260 VDD VSS / sg13g2_buf_1
Xfanout260 net260 net333 VDD VSS / sg13g2_buf_1
Xfanout261 net261 net262 VDD VSS / sg13g2_buf_1
Xfanout262 net262 net265 VDD VSS / sg13g2_buf_1
Xfanout263 net263 net265 VDD VSS / sg13g2_buf_1
Xfanout264 net264 net265 VDD VSS / sg13g2_buf_1
Xfanout265 net265 net278 VDD VSS / sg13g2_buf_1
Xfanout266 net266 net278 VDD VSS / sg13g2_buf_1
Xfanout267 net267 net278 VDD VSS / sg13g2_buf_1
Xfanout268 net268 net269 VDD VSS / sg13g2_buf_1
Xfanout269 net269 net277 VDD VSS / sg13g2_buf_1
Xfanout270 net270 net272 VDD VSS / sg13g2_buf_1
Xfanout271 net271 net272 VDD VSS / sg13g2_buf_1
Xfanout272 net272 net277 VDD VSS / sg13g2_buf_1
Xfanout273 net273 net275 VDD VSS / sg13g2_buf_1
Xfanout274 net274 net275 VDD VSS / sg13g2_buf_1
Xfanout275 net275 net277 VDD VSS / sg13g2_buf_1
Xfanout276 net276 net277 VDD VSS / sg13g2_buf_1
Xfanout277 net277 net278 VDD VSS / sg13g2_buf_1
Xfanout278 net278 net294 VDD VSS / sg13g2_buf_1
Xfanout279 net279 net280 VDD VSS / sg13g2_buf_1
Xfanout280 net280 net284 VDD VSS / sg13g2_buf_1
Xfanout281 net281 net284 VDD VSS / sg13g2_buf_1
Xfanout282 net282 net283 VDD VSS / sg13g2_buf_1
Xfanout283 net283 net284 VDD VSS / sg13g2_buf_1
Xfanout284 net284 net294 VDD VSS / sg13g2_buf_1
Xfanout285 net285 net289 VDD VSS / sg13g2_buf_1
Xfanout286 net286 net289 VDD VSS / sg13g2_buf_1
Xfanout287 net287 net289 VDD VSS / sg13g2_buf_1
Xfanout288 net288 net289 VDD VSS / sg13g2_buf_1
Xfanout289 net289 net294 VDD VSS / sg13g2_buf_1
Xfanout290 net290 net293 VDD VSS / sg13g2_buf_1
Xfanout291 net291 net293 VDD VSS / sg13g2_buf_1
Xfanout292 net292 net293 VDD VSS / sg13g2_buf_1
Xfanout293 net293 net294 VDD VSS / sg13g2_buf_1
Xfanout294 net294 net333 VDD VSS / sg13g2_buf_1
Xfanout295 net295 net296 VDD VSS / sg13g2_buf_1
Xfanout296 net296 net299 VDD VSS / sg13g2_buf_1
Xfanout297 net297 net299 VDD VSS / sg13g2_buf_1
Xfanout298 net298 net299 VDD VSS / sg13g2_buf_1
Xfanout299 net299 net332 VDD VSS / sg13g2_buf_1
Xfanout300 net300 net301 VDD VSS / sg13g2_buf_1
Xfanout301 net301 net302 VDD VSS / sg13g2_buf_1
Xfanout302 net302 net332 VDD VSS / sg13g2_buf_1
Xfanout303 net303 net312 VDD VSS / sg13g2_buf_1
Xfanout304 net304 net312 VDD VSS / sg13g2_buf_1
Xfanout305 net305 net308 VDD VSS / sg13g2_buf_1
Xfanout306 net306 net307 VDD VSS / sg13g2_buf_1
Xfanout307 net307 net308 VDD VSS / sg13g2_buf_1
Xfanout308 net308 net312 VDD VSS / sg13g2_buf_1
Xfanout309 net309 net312 VDD VSS / sg13g2_buf_1
Xfanout310 net310 net311 VDD VSS / sg13g2_buf_1
Xfanout311 net311 net312 VDD VSS / sg13g2_buf_1
Xfanout312 net312 net332 VDD VSS / sg13g2_buf_1
Xfanout313 net313 net314 VDD VSS / sg13g2_buf_1
Xfanout314 net314 net315 VDD VSS / sg13g2_buf_1
Xfanout315 net315 net331 VDD VSS / sg13g2_buf_1
Xfanout316 net316 net317 VDD VSS / sg13g2_buf_1
Xfanout317 net317 net320 VDD VSS / sg13g2_buf_1
Xfanout318 net318 net320 VDD VSS / sg13g2_buf_1
Xfanout319 net319 net320 VDD VSS / sg13g2_buf_1
Xfanout320 net320 net331 VDD VSS / sg13g2_buf_1
Xfanout321 net321 net322 VDD VSS / sg13g2_buf_1
Xfanout322 net322 net325 VDD VSS / sg13g2_buf_1
Xfanout323 net323 net324 VDD VSS / sg13g2_buf_1
Xfanout324 net324 net325 VDD VSS / sg13g2_buf_1
Xfanout325 net325 net331 VDD VSS / sg13g2_buf_1
Xfanout326 net326 net330 VDD VSS / sg13g2_buf_1
Xfanout327 net327 net330 VDD VSS / sg13g2_buf_1
Xfanout328 net328 net329 VDD VSS / sg13g2_buf_1
Xfanout329 net329 net330 VDD VSS / sg13g2_buf_1
Xfanout330 net330 net331 VDD VSS / sg13g2_buf_1
Xfanout331 net331 net332 VDD VSS / sg13g2_buf_1
Xfanout332 net332 net333 VDD VSS / sg13g2_buf_1
Xfanout333 net333 u_core_rs1 VDD VSS / sg13g2_buf_1
Xfanout334 net334 u_core_rd_en VDD VSS / sg13g2_buf_1
Xfanout335 net335 net339 VDD VSS / sg13g2_buf_1
Xfanout336 net336 net339 VDD VSS / sg13g2_buf_1
Xfanout337 net337 net338 VDD VSS / sg13g2_buf_1
Xfanout338 net338 net339 VDD VSS / sg13g2_buf_1
Xfanout339 net339 net342 VDD VSS / sg13g2_buf_1
Xfanout340 net340 net342 VDD VSS / sg13g2_buf_1
Xfanout341 net341 net342 VDD VSS / sg13g2_buf_1
Xfanout342 net342 u_core_cmp_soft_s VDD VSS / sg13g2_buf_1
Xfanout343 net343 u_core_u_trip_soft_cnt_20_ VDD VSS / sg13g2_buf_1
Xfanout344 net344 u_core_u_trip_soft_cnt_19_ VDD VSS / sg13g2_buf_1
Xfanout345 net345 u_core_u_trip_soft_cnt_9_ VDD VSS / sg13g2_buf_1
Xfanout346 net346 u_core_u_trip_soft_cnt_8_ VDD VSS / sg13g2_buf_1
Xfanout347 net347 u_core_u_regfile_wr_data_7_ VDD VSS / sg13g2_buf_1
Xfanout348 net348 u_core_u_regfile_wr_data_6_ VDD VSS / sg13g2_buf_1
Xfanout349 net349 u_core_u_regfile_wr_data_5_ VDD VSS / sg13g2_buf_1
Xfanout350 net350 u_core_u_regfile_wr_data_4_ VDD VSS / sg13g2_buf_1
Xfanout351 net351 u_core_u_regfile_wr_data_4_ VDD VSS / sg13g2_buf_1
Xfanout352 net352 net353 VDD VSS / sg13g2_buf_1
Xfanout353 net353 u_core_u_regfile_wr_data_3_ VDD VSS / sg13g2_buf_1
Xfanout354 net354 net355 VDD VSS / sg13g2_buf_1
Xfanout355 net355 u_core_u_regfile_wr_data_2_ VDD VSS / sg13g2_buf_1
Xfanout356 net356 net358 VDD VSS / sg13g2_buf_1
Xfanout357 net357 net358 VDD VSS / sg13g2_buf_1
Xfanout358 net358 u_core_u_regfile_wr_data_1_ VDD VSS / sg13g2_buf_1
Xfanout359 net359 net361 VDD VSS / sg13g2_buf_1
Xfanout360 net360 net361 VDD VSS / sg13g2_buf_1
Xfanout361 net361 u_core_u_regfile_wr_data_0_ VDD VSS / sg13g2_buf_1
Xfanout362 net362 u_core_rd_addr_3_ VDD VSS / sg13g2_buf_1
Xfanout363 net363 u_core_rd_addr_2_ VDD VSS / sg13g2_buf_1
Xfanout364 net364 net365 VDD VSS / sg13g2_buf_1
Xfanout365 net365 u_core_rd_addr_1_ VDD VSS / sg13g2_buf_1
Xfanout366 net366 u_core_rd_addr_0_ VDD VSS / sg13g2_buf_1
Xfanout367 net367 u_core_u_regfile_wr_addr_2_ VDD VSS / sg13g2_buf_1
Xfanout43 net43 _2422_ VDD VSS / sg13g2_buf_1
Xfanout44 net44 _2422_ VDD VSS / sg13g2_buf_1
Xfanout45 net45 net46 VDD VSS / sg13g2_buf_1
Xfanout46 net46 _2239_ VDD VSS / sg13g2_buf_1
Xfanout47 net47 _1015_ VDD VSS / sg13g2_buf_1
Xfanout48 net48 _1015_ VDD VSS / sg13g2_buf_1
Xfanout49 net49 net50 VDD VSS / sg13g2_buf_1
Xfanout50 net50 _2218_ VDD VSS / sg13g2_buf_1
Xfanout51 net51 _2218_ VDD VSS / sg13g2_buf_1
Xfanout52 net52 _2299_ VDD VSS / sg13g2_buf_1
Xfanout53 net53 net54 VDD VSS / sg13g2_buf_1
Xfanout54 net54 _2299_ VDD VSS / sg13g2_buf_1
Xfanout55 net55 net58 VDD VSS / sg13g2_buf_1
Xfanout56 net56 net58 VDD VSS / sg13g2_buf_1
Xfanout57 net57 net58 VDD VSS / sg13g2_buf_1
Xfanout58 net58 _2482_ VDD VSS / sg13g2_buf_1
Xfanout59 net59 net62 VDD VSS / sg13g2_buf_1
Xfanout60 net60 net62 VDD VSS / sg13g2_buf_1
Xfanout61 net61 net62 VDD VSS / sg13g2_buf_1
Xfanout62 net62 _2481_ VDD VSS / sg13g2_buf_1
Xfanout63 net63 net64 VDD VSS / sg13g2_buf_1
Xfanout64 net64 net65 VDD VSS / sg13g2_buf_1
Xfanout65 net65 _0946_ VDD VSS / sg13g2_buf_1
Xfanout66 net66 net67 VDD VSS / sg13g2_buf_1
Xfanout67 net67 _1749_ VDD VSS / sg13g2_buf_1
Xfanout68 net68 net69 VDD VSS / sg13g2_buf_1
Xfanout69 net69 _0916_ VDD VSS / sg13g2_buf_1
Xfanout70 net70 _2421_ VDD VSS / sg13g2_buf_1
Xfanout71 net71 _2421_ VDD VSS / sg13g2_buf_1
Xfanout72 net72 _1743_ VDD VSS / sg13g2_buf_1
Xfanout73 net73 _0854_ VDD VSS / sg13g2_buf_1
Xfanout74 net74 _0854_ VDD VSS / sg13g2_buf_1
Xfanout75 net75 net76 VDD VSS / sg13g2_buf_1
Xfanout76 net76 _0853_ VDD VSS / sg13g2_buf_1
Xfanout77 net77 net81 VDD VSS / sg13g2_buf_1
Xfanout78 net78 net80 VDD VSS / sg13g2_buf_1
Xfanout79 net79 net80 VDD VSS / sg13g2_buf_1
Xfanout80 net80 net81 VDD VSS / sg13g2_buf_1
Xfanout81 net81 _0853_ VDD VSS / sg13g2_buf_1
Xfanout82 net82 _1924_ VDD VSS / sg13g2_buf_1
Xfanout83 net83 net84 VDD VSS / sg13g2_buf_1
Xfanout84 net84 net85 VDD VSS / sg13g2_buf_1
Xfanout85 net85 _1877_ VDD VSS / sg13g2_buf_1
Xfanout86 net86 net87 VDD VSS / sg13g2_buf_1
Xfanout87 net87 _1872_ VDD VSS / sg13g2_buf_1
Xfanout88 net88 _1866_ VDD VSS / sg13g2_buf_1
Xfanout89 net89 _1866_ VDD VSS / sg13g2_buf_1
Xfanout90 net90 _1806_ VDD VSS / sg13g2_buf_1
Xfanout91 net91 net92 VDD VSS / sg13g2_buf_1
Xfanout92 net92 _1737_ VDD VSS / sg13g2_buf_1
Xfanout93 net93 net94 VDD VSS / sg13g2_buf_1
Xfanout94 net94 net95 VDD VSS / sg13g2_buf_1
Xfanout95 net95 _1726_ VDD VSS / sg13g2_buf_1
Xfanout96 net96 net97 VDD VSS / sg13g2_buf_1
Xfanout97 net97 _0869_ VDD VSS / sg13g2_buf_1
Xfanout98 net98 _2122_ VDD VSS / sg13g2_buf_1
Xfanout99 net99 _1936_ VDD VSS / sg13g2_buf_1
Xhold377 net376 u_core_u_seu_plain_q_8_ VDD VSS / sg13g2_dlygate4sd3_1
Xhold378 net377 u_core_u_seu_plain_q_1_ VDD VSS / sg13g2_dlygate4sd3_1
Xhold379 net378 u_core_u_seu_plain_q_73_ VDD VSS / sg13g2_dlygate4sd3_1
Xhold380 net379 u_core_u_seu_plain_q_37_ VDD VSS / sg13g2_dlygate4sd3_1
Xhold381 net380 u_core_u_seu_plain_q_43_ VDD VSS / sg13g2_dlygate4sd3_1
Xhold382 net381 u_core_u_seu_plain_q_64_ VDD VSS / sg13g2_dlygate4sd3_1
Xhold383 net382 u_core_u_seu_plain_q_160_ VDD VSS / sg13g2_dlygate4sd3_1
Xhold384 net383 u_core_u_seu_plain_q_27_ VDD VSS / sg13g2_dlygate4sd3_1
Xhold385 net384 u_core_u_seu_plain_q_88_ VDD VSS / sg13g2_dlygate4sd3_1
Xhold386 net385 u_core_u_seu_plain_q_117_ VDD VSS / sg13g2_dlygate4sd3_1
Xhold387 net386 u_core_u_seu_plain_q_195_ VDD VSS / sg13g2_dlygate4sd3_1
Xhold388 net387 u_core_u_seu_plain_q_22_ VDD VSS / sg13g2_dlygate4sd3_1
Xhold389 net388 u_core_u_seu_plain_q_154_ VDD VSS / sg13g2_dlygate4sd3_1
Xhold390 net389 u_core_u_seu_plain_q_132_ VDD VSS / sg13g2_dlygate4sd3_1
Xhold391 net390 u_core_u_seu_plain_q_138_ VDD VSS / sg13g2_dlygate4sd3_1
Xhold392 net391 u_core_u_seu_plain_q_146_ VDD VSS / sg13g2_dlygate4sd3_1
Xhold393 net392 u_core_u_seu_plain_q_3_ VDD VSS / sg13g2_dlygate4sd3_1
Xhold394 net393 u_core_u_seu_plain_q_95_ VDD VSS / sg13g2_dlygate4sd3_1
Xhold395 net394 u_core_u_seu_plain_q_87_ VDD VSS / sg13g2_dlygate4sd3_1
Xhold396 net395 u_core_u_seu_plain_q_127_ VDD VSS / sg13g2_dlygate4sd3_1
Xhold397 net396 u_core_u_seu_plain_q_125_ VDD VSS / sg13g2_dlygate4sd3_1
Xhold398 net397 u_core_u_seu_plain_q_247_ VDD VSS / sg13g2_dlygate4sd3_1
Xhold399 net398 u_core_u_seu_plain_q_14_ VDD VSS / sg13g2_dlygate4sd3_1
Xhold400 net399 u_core_u_seu_plain_q_29_ VDD VSS / sg13g2_dlygate4sd3_1
Xhold401 net400 u_core_u_seu_plain_q_151_ VDD VSS / sg13g2_dlygate4sd3_1
Xhold402 net401 u_core_u_seu_plain_q_143_ VDD VSS / sg13g2_dlygate4sd3_1
Xhold403 net402 u_core_u_seu_plain_q_129_ VDD VSS / sg13g2_dlygate4sd3_1
Xhold404 net403 u_core_u_seu_plain_q_218_ VDD VSS / sg13g2_dlygate4sd3_1
Xhold405 net404 u_core_u_seu_plain_q_103_ VDD VSS / sg13g2_dlygate4sd3_1
Xhold406 net405 u_core_u_seu_plain_q_82_ VDD VSS / sg13g2_dlygate4sd3_1
Xhold407 net406 u_core_u_seu_plain_q_198_ VDD VSS / sg13g2_dlygate4sd3_1
Xhold408 net407 u_core_u_seu_plain_q_189_ VDD VSS / sg13g2_dlygate4sd3_1
Xhold409 net408 u_core_u_seu_plain_q_244_ VDD VSS / sg13g2_dlygate4sd3_1
Xhold410 net409 u_core_u_seu_plain_q_205_ VDD VSS / sg13g2_dlygate4sd3_1
Xhold411 net410 u_core_u_seu_plain_q_178_ VDD VSS / sg13g2_dlygate4sd3_1
Xhold412 net411 u_core_u_seu_plain_q_46_ VDD VSS / sg13g2_dlygate4sd3_1
Xhold413 net412 u_core_u_seu_plain_q_48_ VDD VSS / sg13g2_dlygate4sd3_1
Xhold414 net413 u_core_u_seu_plain_q_248_ VDD VSS / sg13g2_dlygate4sd3_1
Xhold415 net414 u_core_u_seu_plain_q_229_ VDD VSS / sg13g2_dlygate4sd3_1
Xhold416 net415 u_core_u_seu_plain_q_19_ VDD VSS / sg13g2_dlygate4sd3_1
Xhold417 net416 u_core_u_seu_plain_q_26_ VDD VSS / sg13g2_dlygate4sd3_1
Xhold418 net417 u_core_u_seu_plain_q_0_ VDD VSS / sg13g2_dlygate4sd3_1
Xhold419 net418 u_core_u_seu_plain_q_102_ VDD VSS / sg13g2_dlygate4sd3_1
Xhold420 net419 u_core_u_seu_plain_q_16_ VDD VSS / sg13g2_dlygate4sd3_1
Xhold421 net420 u_core_u_seu_plain_q_111_ VDD VSS / sg13g2_dlygate4sd3_1
Xhold422 net421 u_core_u_seu_plain_q_23_ VDD VSS / sg13g2_dlygate4sd3_1
Xhold423 net422 u_core_u_seu_plain_q_197_ VDD VSS / sg13g2_dlygate4sd3_1
Xhold424 net423 u_core_u_seu_plain_q_234_ VDD VSS / sg13g2_dlygate4sd3_1
Xhold425 net424 u_core_u_seu_plain_q_141_ VDD VSS / sg13g2_dlygate4sd3_1
Xhold426 net425 u_core_u_seu_plain_q_168_ VDD VSS / sg13g2_dlygate4sd3_1
Xhold427 net426 u_core_u_seu_plain_q_120_ VDD VSS / sg13g2_dlygate4sd3_1
Xhold428 net427 u_core_u_seu_plain_q_161_ VDD VSS / sg13g2_dlygate4sd3_1
Xhold429 net428 u_core_u_seu_plain_q_107_ VDD VSS / sg13g2_dlygate4sd3_1
Xhold430 net429 u_core_u_seu_plain_q_147_ VDD VSS / sg13g2_dlygate4sd3_1
Xhold431 net430 u_core_u_seu_plain_q_7_ VDD VSS / sg13g2_dlygate4sd3_1
Xhold432 net431 u_core_u_seu_plain_q_239_ VDD VSS / sg13g2_dlygate4sd3_1
Xhold433 net432 u_core_u_seu_plain_q_162_ VDD VSS / sg13g2_dlygate4sd3_1
Xhold434 net433 u_core_u_seu_plain_q_32_ VDD VSS / sg13g2_dlygate4sd3_1
Xhold435 net434 u_core_u_seu_plain_q_58_ VDD VSS / sg13g2_dlygate4sd3_1
Xhold436 net435 u_core_u_seu_plain_q_68_ VDD VSS / sg13g2_dlygate4sd3_1
Xhold437 net436 u_core_u_seu_plain_q_112_ VDD VSS / sg13g2_dlygate4sd3_1
Xhold438 net437 u_core_u_seu_plain_q_223_ VDD VSS / sg13g2_dlygate4sd3_1
Xhold439 net438 u_core_u_seu_plain_q_164_ VDD VSS / sg13g2_dlygate4sd3_1
Xhold440 net439 u_core_u_seu_plain_q_134_ VDD VSS / sg13g2_dlygate4sd3_1
Xhold441 net440 u_core_u_seu_plain_q_251_ VDD VSS / sg13g2_dlygate4sd3_1
Xhold442 net441 u_core_u_serial_u_sync_rd_s0_0_ VDD VSS / sg13g2_dlygate4sd3_1
Xhold443 net442 u_core_u_seu_plain_q_34_ VDD VSS / sg13g2_dlygate4sd3_1
Xhold444 net443 u_core_u_seu_plain_q_25_ VDD VSS / sg13g2_dlygate4sd3_1
Xhold445 net444 u_core_u_seu_plain_q_243_ VDD VSS / sg13g2_dlygate4sd3_1
Xhold446 net445 u_core_u_seu_plain_q_139_ VDD VSS / sg13g2_dlygate4sd3_1
Xhold447 net446 u_core_u_seu_plain_q_228_ VDD VSS / sg13g2_dlygate4sd3_1
Xhold448 net447 u_core_u_seu_plain_q_4_ VDD VSS / sg13g2_dlygate4sd3_1
Xhold449 net448 u_core_u_seu_plain_q_20_ VDD VSS / sg13g2_dlygate4sd3_1
Xhold450 net449 u_core_u_seu_plain_q_44_ VDD VSS / sg13g2_dlygate4sd3_1
Xhold451 net450 u_core_u_trip_u_sync_in_s0_2_ VDD VSS / sg13g2_dlygate4sd3_1
Xhold452 net451 u_core_u_seu_plain_q_185_ VDD VSS / sg13g2_dlygate4sd3_1
Xhold453 net452 u_core_u_seu_plain_q_207_ VDD VSS / sg13g2_dlygate4sd3_1
Xhold454 net453 u_core_u_seu_plain_q_176_ VDD VSS / sg13g2_dlygate4sd3_1
Xhold455 net454 u_core_u_seu_plain_q_47_ VDD VSS / sg13g2_dlygate4sd3_1
Xhold456 net455 u_core_u_seu_plain_q_45_ VDD VSS / sg13g2_dlygate4sd3_1
Xhold457 net456 u_core_u_seu_plain_q_74_ VDD VSS / sg13g2_dlygate4sd3_1
Xhold458 net457 u_core_u_seu_plain_q_169_ VDD VSS / sg13g2_dlygate4sd3_1
Xhold459 net458 u_core_u_seu_plain_q_196_ VDD VSS / sg13g2_dlygate4sd3_1
Xhold460 net459 u_core_u_seu_plain_q_99_ VDD VSS / sg13g2_dlygate4sd3_1
Xhold461 net460 u_core_u_seu_plain_q_222_ VDD VSS / sg13g2_dlygate4sd3_1
Xhold462 net461 u_core_u_seu_plain_q_149_ VDD VSS / sg13g2_dlygate4sd3_1
Xhold463 net462 u_core_u_seu_plain_q_84_ VDD VSS / sg13g2_dlygate4sd3_1
Xhold464 net463 u_core_u_seu_plain_q_72_ VDD VSS / sg13g2_dlygate4sd3_1
Xhold465 net464 u_core_u_seu_plain_q_214_ VDD VSS / sg13g2_dlygate4sd3_1
Xhold466 net465 u_core_u_seu_plain_q_122_ VDD VSS / sg13g2_dlygate4sd3_1
Xhold467 net466 u_core_u_seu_plain_q_24_ VDD VSS / sg13g2_dlygate4sd3_1
Xhold468 net467 u_core_u_seu_plain_q_209_ VDD VSS / sg13g2_dlygate4sd3_1
Xhold469 net468 u_core_u_seu_plain_q_199_ VDD VSS / sg13g2_dlygate4sd3_1
Xhold470 net469 u_core_u_seu_plain_q_96_ VDD VSS / sg13g2_dlygate4sd3_1
Xhold471 net470 u_core_u_serial_u_sync_sclk_s0_0_ VDD VSS / sg13g2_dlygate4sd3_1
Xhold472 net471 u_core_u_seu_plain_q_86_ VDD VSS / sg13g2_dlygate4sd3_1
Xhold473 net472 u_core_u_seu_plain_q_184_ VDD VSS / sg13g2_dlygate4sd3_1
Xhold474 net473 u_core_u_seu_plain_q_11_ VDD VSS / sg13g2_dlygate4sd3_1
Xhold475 net474 u_core_u_seu_plain_q_217_ VDD VSS / sg13g2_dlygate4sd3_1
Xhold476 net475 u_core_u_seu_plain_q_94_ VDD VSS / sg13g2_dlygate4sd3_1
Xhold477 net476 u_core_u_seu_plain_q_166_ VDD VSS / sg13g2_dlygate4sd3_1
Xhold478 net477 u_core_u_seu_plain_q_6_ VDD VSS / sg13g2_dlygate4sd3_1
Xhold479 net478 u_core_u_seu_plain_q_108_ VDD VSS / sg13g2_dlygate4sd3_1
Xhold480 net479 u_core_u_seu_plain_q_136_ VDD VSS / sg13g2_dlygate4sd3_1
Xhold481 net480 u_core_u_seu_plain_q_15_ VDD VSS / sg13g2_dlygate4sd3_1
Xhold482 net481 u_core_u_seu_plain_q_144_ VDD VSS / sg13g2_dlygate4sd3_1
Xhold483 net482 u_core_u_seu_plain_q_179_ VDD VSS / sg13g2_dlygate4sd3_1
Xhold484 net483 u_core_u_seu_plain_q_242_ VDD VSS / sg13g2_dlygate4sd3_1
Xhold485 net484 u_core_u_seu_plain_q_21_ VDD VSS / sg13g2_dlygate4sd3_1
Xhold486 net485 u_core_u_seu_plain_q_254_ VDD VSS / sg13g2_dlygate4sd3_1
Xhold487 net486 u_core_u_seu_plain_q_28_ VDD VSS / sg13g2_dlygate4sd3_1
Xhold488 net487 u_core_u_seu_plain_q_140_ VDD VSS / sg13g2_dlygate4sd3_1
Xhold489 net488 u_core_u_seu_plain_q_116_ VDD VSS / sg13g2_dlygate4sd3_1
Xhold490 net489 u_core_u_seu_plain_q_172_ VDD VSS / sg13g2_dlygate4sd3_1
Xhold491 net490 u_core_u_seu_plain_q_142_ VDD VSS / sg13g2_dlygate4sd3_1
Xhold492 net491 u_core_u_seu_plain_q_148_ VDD VSS / sg13g2_dlygate4sd3_1
Xhold493 net492 u_core_u_seu_plain_q_249_ VDD VSS / sg13g2_dlygate4sd3_1
Xhold494 net493 u_core_u_seu_plain_q_124_ VDD VSS / sg13g2_dlygate4sd3_1
Xhold495 net494 u_core_u_seu_plain_q_175_ VDD VSS / sg13g2_dlygate4sd3_1
Xhold496 net495 u_core_u_seu_plain_q_89_ VDD VSS / sg13g2_dlygate4sd3_1
Xhold497 net496 u_core_u_seu_plain_q_67_ VDD VSS / sg13g2_dlygate4sd3_1
Xhold498 net497 u_core_u_seu_plain_q_245_ VDD VSS / sg13g2_dlygate4sd3_1
Xhold499 net498 u_core_u_seu_plain_q_235_ VDD VSS / sg13g2_dlygate4sd3_1
Xhold500 net499 u_core_u_seu_plain_q_181_ VDD VSS / sg13g2_dlygate4sd3_1
Xhold501 net500 u_core_u_seu_plain_q_56_ VDD VSS / sg13g2_dlygate4sd3_1
Xhold502 net501 u_core_u_seu_plain_q_59_ VDD VSS / sg13g2_dlygate4sd3_1
Xhold503 net502 u_core_u_seu_plain_q_81_ VDD VSS / sg13g2_dlygate4sd3_1
Xhold504 net503 u_core_u_seu_plain_q_57_ VDD VSS / sg13g2_dlygate4sd3_1
Xhold505 net504 u_core_u_seu_plain_q_36_ VDD VSS / sg13g2_dlygate4sd3_1
Xhold506 net505 u_core_u_seu_plain_q_60_ VDD VSS / sg13g2_dlygate4sd3_1
Xhold507 net506 u_core_u_seu_plain_q_52_ VDD VSS / sg13g2_dlygate4sd3_1
Xhold508 net507 u_core_u_seu_plain_q_170_ VDD VSS / sg13g2_dlygate4sd3_1
Xhold509 net508 u_core_u_seu_plain_q_192_ VDD VSS / sg13g2_dlygate4sd3_1
Xhold510 net509 u_core_u_seu_plain_q_230_ VDD VSS / sg13g2_dlygate4sd3_1
Xhold511 net510 u_core_u_seu_plain_q_51_ VDD VSS / sg13g2_dlygate4sd3_1
Xhold512 net511 u_core_u_seu_plain_q_66_ VDD VSS / sg13g2_dlygate4sd3_1
Xhold513 net512 u_core_u_seu_plain_q_233_ VDD VSS / sg13g2_dlygate4sd3_1
Xhold514 net513 u_core_u_seu_plain_q_69_ VDD VSS / sg13g2_dlygate4sd3_1
Xhold515 net514 u_core_u_seu_plain_q_61_ VDD VSS / sg13g2_dlygate4sd3_1
Xhold516 net515 u_core_u_seu_plain_q_30_ VDD VSS / sg13g2_dlygate4sd3_1
Xhold517 net516 u_core_u_seu_plain_q_190_ VDD VSS / sg13g2_dlygate4sd3_1
Xhold518 net517 u_core_u_seu_plain_q_236_ VDD VSS / sg13g2_dlygate4sd3_1
Xhold519 net518 u_core_u_seu_plain_q_253_ VDD VSS / sg13g2_dlygate4sd3_1
Xhold520 net519 u_core_u_seu_plain_q_121_ VDD VSS / sg13g2_dlygate4sd3_1
Xhold521 net520 u_core_u_seu_plain_q_240_ VDD VSS / sg13g2_dlygate4sd3_1
Xhold522 net521 u_core_u_seu_plain_q_63_ VDD VSS / sg13g2_dlygate4sd3_1
Xhold523 net522 u_core_u_seu_plain_q_54_ VDD VSS / sg13g2_dlygate4sd3_1
Xhold524 net523 u_core_rs0 VDD VSS / sg13g2_dlygate4sd3_1
Xhold525 net524 u_core_u_seu_plain_q_241_ VDD VSS / sg13g2_dlygate4sd3_1
Xhold526 net525 u_core_u_seu_plain_q_106_ VDD VSS / sg13g2_dlygate4sd3_1
Xhold527 net526 u_core_u_seu_plain_q_70_ VDD VSS / sg13g2_dlygate4sd3_1
Xhold528 net527 u_core_u_seu_plain_q_163_ VDD VSS / sg13g2_dlygate4sd3_1
Xhold529 net528 u_core_u_seu_plain_q_18_ VDD VSS / sg13g2_dlygate4sd3_1
Xhold530 net529 u_core_u_seu_plain_q_55_ VDD VSS / sg13g2_dlygate4sd3_1
Xhold531 net530 u_core_u_seu_plain_q_200_ VDD VSS / sg13g2_dlygate4sd3_1
Xhold532 net531 u_core_u_seu_plain_q_110_ VDD VSS / sg13g2_dlygate4sd3_1
Xhold533 net532 u_core_u_seu_plain_q_238_ VDD VSS / sg13g2_dlygate4sd3_1
Xhold534 net533 u_core_u_seu_plain_q_145_ VDD VSS / sg13g2_dlygate4sd3_1
Xhold535 net534 u_core_u_seu_plain_q_31_ VDD VSS / sg13g2_dlygate4sd3_1
Xhold536 net535 u_core_u_seu_plain_q_174_ VDD VSS / sg13g2_dlygate4sd3_1
Xhold537 net536 u_core_u_seu_plain_q_10_ VDD VSS / sg13g2_dlygate4sd3_1
Xhold538 net537 u_core_u_seu_plain_q_171_ VDD VSS / sg13g2_dlygate4sd3_1
Xhold539 net538 u_core_u_seu_plain_q_231_ VDD VSS / sg13g2_dlygate4sd3_1
Xhold540 net539 u_core_u_seu_plain_q_104_ VDD VSS / sg13g2_dlygate4sd3_1
Xhold541 net540 u_core_u_seu_plain_q_232_ VDD VSS / sg13g2_dlygate4sd3_1
Xhold542 net541 u_core_u_seu_plain_q_246_ VDD VSS / sg13g2_dlygate4sd3_1
Xhold543 net542 u_core_u_seu_plain_q_156_ VDD VSS / sg13g2_dlygate4sd3_1
Xhold544 net543 u_core_u_seu_plain_q_250_ VDD VSS / sg13g2_dlygate4sd3_1
Xhold545 net544 u_core_u_seu_plain_q_41_ VDD VSS / sg13g2_dlygate4sd3_1
Xhold546 net545 u_core_u_seu_plain_q_165_ VDD VSS / sg13g2_dlygate4sd3_1
Xhold547 net546 u_core_u_seu_plain_q_225_ VDD VSS / sg13g2_dlygate4sd3_1
Xhold548 net547 u_core_u_seu_plain_q_210_ VDD VSS / sg13g2_dlygate4sd3_1
Xhold549 net548 u_core_u_seu_plain_q_252_ VDD VSS / sg13g2_dlygate4sd3_1
Xhold550 net549 u_core_u_seu_plain_q_219_ VDD VSS / sg13g2_dlygate4sd3_1
Xhold551 net550 u_core_u_seu_plain_q_40_ VDD VSS / sg13g2_dlygate4sd3_1
Xhold552 net551 u_core_u_seu_plain_q_213_ VDD VSS / sg13g2_dlygate4sd3_1
Xhold553 net552 u_core_u_seu_plain_q_153_ VDD VSS / sg13g2_dlygate4sd3_1
Xhold554 net553 u_core_u_seu_plain_q_123_ VDD VSS / sg13g2_dlygate4sd3_1
Xhold555 net554 u_core_u_seu_plain_q_62_ VDD VSS / sg13g2_dlygate4sd3_1
Xhold556 net555 u_core_u_seu_plain_q_12_ VDD VSS / sg13g2_dlygate4sd3_1
Xhold557 net556 u_core_u_seu_plain_q_38_ VDD VSS / sg13g2_dlygate4sd3_1
Xhold558 net557 u_core_u_seu_plain_q_237_ VDD VSS / sg13g2_dlygate4sd3_1
Xhold559 net558 u_core_u_serial_u_sync_wr_s0_0_ VDD VSS / sg13g2_dlygate4sd3_1
Xhold560 net559 u_core_u_seu_plain_q_180_ VDD VSS / sg13g2_dlygate4sd3_1
Xhold561 net560 u_core_u_seu_plain_q_39_ VDD VSS / sg13g2_dlygate4sd3_1
Xhold562 net561 u_core_u_seu_plain_q_33_ VDD VSS / sg13g2_dlygate4sd3_1
Xhold563 net562 u_core_u_seu_plain_q_65_ VDD VSS / sg13g2_dlygate4sd3_1
Xhold564 net563 u_core_u_seu_plain_q_118_ VDD VSS / sg13g2_dlygate4sd3_1
Xhold565 net564 u_core_u_seu_plain_q_150_ VDD VSS / sg13g2_dlygate4sd3_1
Xhold566 net565 u_core_u_seu_plain_q_9_ VDD VSS / sg13g2_dlygate4sd3_1
Xhold567 net566 u_core_u_seu_plain_q_114_ VDD VSS / sg13g2_dlygate4sd3_1
Xhold568 net567 u_core_u_seu_plain_q_167_ VDD VSS / sg13g2_dlygate4sd3_1
Xhold569 net568 u_core_u_seu_plain_q_157_ VDD VSS / sg13g2_dlygate4sd3_1
Xhold570 net569 u_core_u_seu_plain_q_85_ VDD VSS / sg13g2_dlygate4sd3_1
Xhold571 net570 u_core_u_seu_plain_q_216_ VDD VSS / sg13g2_dlygate4sd3_1
Xhold572 net571 u_core_u_seu_plain_q_191_ VDD VSS / sg13g2_dlygate4sd3_1
Xhold573 net572 u_core_u_seu_plain_q_13_ VDD VSS / sg13g2_dlygate4sd3_1
Xhold574 net573 u_core_u_seu_plain_q_115_ VDD VSS / sg13g2_dlygate4sd3_1
Xhold575 net574 u_core_u_seu_plain_q_35_ VDD VSS / sg13g2_dlygate4sd3_1
Xhold576 net575 u_core_u_seu_plain_q_77_ VDD VSS / sg13g2_dlygate4sd3_1
Xhold577 net576 u_core_u_seu_plain_q_71_ VDD VSS / sg13g2_dlygate4sd3_1
Xhold578 net577 u_core_u_seu_plain_q_83_ VDD VSS / sg13g2_dlygate4sd3_1
Xhold579 net578 u_core_u_seu_plain_q_137_ VDD VSS / sg13g2_dlygate4sd3_1
Xhold580 net579 u_core_u_seu_plain_q_133_ VDD VSS / sg13g2_dlygate4sd3_1
Xhold581 net580 u_core_u_seu_plain_q_50_ VDD VSS / sg13g2_dlygate4sd3_1
Xhold582 net581 u_core_u_seu_plain_q_194_ VDD VSS / sg13g2_dlygate4sd3_1
Xhold583 net582 u_core_u_seu_plain_q_113_ VDD VSS / sg13g2_dlygate4sd3_1
Xhold584 net583 u_core_u_seu_plain_q_177_ VDD VSS / sg13g2_dlygate4sd3_1
Xhold585 net584 u_core_u_trip_u_sync_in_s0_1_ VDD VSS / sg13g2_dlygate4sd3_1
Xhold586 net585 u_core_u_seu_plain_q_215_ VDD VSS / sg13g2_dlygate4sd3_1
Xhold587 net586 u_core_u_seu_plain_q_204_ VDD VSS / sg13g2_dlygate4sd3_1
Xhold588 net587 u_core_u_seu_plain_q_220_ VDD VSS / sg13g2_dlygate4sd3_1
Xhold589 net588 u_core_u_seu_plain_q_187_ VDD VSS / sg13g2_dlygate4sd3_1
Xhold590 net589 u_core_u_seu_plain_q_131_ VDD VSS / sg13g2_dlygate4sd3_1
Xhold591 net590 u_core_u_seu_plain_q_78_ VDD VSS / sg13g2_dlygate4sd3_1
Xhold592 net591 u_core_u_seu_plain_q_221_ VDD VSS / sg13g2_dlygate4sd3_1
Xhold593 net592 u_core_u_seu_plain_q_130_ VDD VSS / sg13g2_dlygate4sd3_1
Xhold594 net593 u_core_u_seu_plain_q_76_ VDD VSS / sg13g2_dlygate4sd3_1
Xhold595 net594 u_core_u_seu_plain_q_212_ VDD VSS / sg13g2_dlygate4sd3_1
Xhold596 net595 u_core_u_seu_plain_q_126_ VDD VSS / sg13g2_dlygate4sd3_1
Xhold597 net596 u_core_u_seu_plain_q_206_ VDD VSS / sg13g2_dlygate4sd3_1
Xhold598 net597 u_core_u_seu_plain_q_42_ VDD VSS / sg13g2_dlygate4sd3_1
Xhold599 net598 u_core_u_seu_plain_q_93_ VDD VSS / sg13g2_dlygate4sd3_1
Xhold600 net599 u_core_u_seu_plain_q_98_ VDD VSS / sg13g2_dlygate4sd3_1
Xhold601 net600 u_core_u_seu_plain_q_224_ VDD VSS / sg13g2_dlygate4sd3_1
Xhold602 net601 u_core_u_seu_plain_q_79_ VDD VSS / sg13g2_dlygate4sd3_1
Xhold603 net602 u_core_u_seu_plain_q_186_ VDD VSS / sg13g2_dlygate4sd3_1
Xhold604 net603 u_core_u_seu_plain_q_158_ VDD VSS / sg13g2_dlygate4sd3_1
Xhold605 net604 u_core_u_seu_plain_q_193_ VDD VSS / sg13g2_dlygate4sd3_1
Xhold606 net605 u_core_u_seu_plain_q_135_ VDD VSS / sg13g2_dlygate4sd3_1
Xhold607 net606 u_core_u_seu_plain_q_208_ VDD VSS / sg13g2_dlygate4sd3_1
Xhold608 net607 u_core_u_seu_plain_q_75_ VDD VSS / sg13g2_dlygate4sd3_1
Xhold609 net608 u_core_u_seu_plain_q_97_ VDD VSS / sg13g2_dlygate4sd3_1
Xhold610 net609 u_core_u_seu_plain_q_155_ VDD VSS / sg13g2_dlygate4sd3_1
Xhold611 net610 u_core_u_seu_plain_q_182_ VDD VSS / sg13g2_dlygate4sd3_1
Xhold612 net611 u_core_u_seu_plain_q_202_ VDD VSS / sg13g2_dlygate4sd3_1
Xhold613 net612 u_core_u_seu_plain_q_227_ VDD VSS / sg13g2_dlygate4sd3_1
Xhold614 net613 u_core_u_trip_u_sync_in_s0_0_ VDD VSS / sg13g2_dlygate4sd3_1
Xhold615 net614 u_core_u_seu_plain_q_119_ VDD VSS / sg13g2_dlygate4sd3_1
Xhold616 net615 u_core_u_seu_plain_q_152_ VDD VSS / sg13g2_dlygate4sd3_1
Xhold617 net616 u_core_u_seu_plain_q_159_ VDD VSS / sg13g2_dlygate4sd3_1
Xhold618 net617 u_core_u_seu_plain_q_49_ VDD VSS / sg13g2_dlygate4sd3_1
Xhold619 net618 u_core_u_seu_plain_q_101_ VDD VSS / sg13g2_dlygate4sd3_1
Xhold620 net619 u_core_u_seu_plain_q_2_ VDD VSS / sg13g2_dlygate4sd3_1
Xhold621 net620 u_core_u_serial_u_sync_rd_q_0_ VDD VSS / sg13g2_dlygate4sd3_1
Xhold622 net621 u_core_u_seu_plain_q_201_ VDD VSS / sg13g2_dlygate4sd3_1
Xhold623 net622 u_core_u_seu_plain_q_211_ VDD VSS / sg13g2_dlygate4sd3_1
Xhold624 net623 u_core_u_seu_plain_q_17_ VDD VSS / sg13g2_dlygate4sd3_1
Xhold625 net624 u_core_u_seu_plain_q_80_ VDD VSS / sg13g2_dlygate4sd3_1
Xhold626 net625 u_core_u_seu_plain_q_53_ VDD VSS / sg13g2_dlygate4sd3_1
Xhold627 net626 u_core_u_seu_plain_q_188_ VDD VSS / sg13g2_dlygate4sd3_1
Xhold628 net627 u_core_u_seu_plain_q_173_ VDD VSS / sg13g2_dlygate4sd3_1
Xhold629 net628 u_core_u_seu_plain_q_90_ VDD VSS / sg13g2_dlygate4sd3_1
Xhold630 net629 u_core_u_seu_plain_q_128_ VDD VSS / sg13g2_dlygate4sd3_1
Xhold631 net630 u_core_u_seu_plain_q_109_ VDD VSS / sg13g2_dlygate4sd3_1
Xhold632 net631 u_core_u_seu_plain_q_203_ VDD VSS / sg13g2_dlygate4sd3_1
Xhold633 net632 u_core_u_seu_plain_q_5_ VDD VSS / sg13g2_dlygate4sd3_1
Xhold634 net633 u_core_u_seu_plain_q_105_ VDD VSS / sg13g2_dlygate4sd3_1
Xhold635 net634 u_core_u_seu_plain_q_100_ VDD VSS / sg13g2_dlygate4sd3_1
Xhold636 net635 u_core_u_serial_u_sync_wr_q_0_ VDD VSS / sg13g2_dlygate4sd3_1
Xhold637 net636 u_core_u_seu_plain_q_92_ VDD VSS / sg13g2_dlygate4sd3_1
Xhold638 net637 u_core_u_seu_plain_q_226_ VDD VSS / sg13g2_dlygate4sd3_1
Xhold639 net638 u_core_u_seu_plain_q_91_ VDD VSS / sg13g2_dlygate4sd3_1
Xhold640 net639 u_core_u_serial_shreg_3_ VDD VSS / sg13g2_dlygate4sd3_1
Xinput1 net1 cmp_hard VDD VSS / sg13g2_buf_1
Xinput2 net2 cmp_soft VDD VSS / sg13g2_buf_1
Xinput3 net3 en VDD VSS / sg13g2_buf_1
Xinput4 net4 por_n VDD VSS / sg13g2_buf_1
Xinput5 net5 sdi VDD VSS / sg13g2_buf_1
Xinput6 net6 tripped VDD VSS / sg13g2_buf_1
Xoutput10 cmp_clk net10 VDD VSS / sg13g2_buf_1
Xoutput11 dac_hard_0_ net11 VDD VSS / sg13g2_buf_1
Xoutput12 dac_hard_1_ net12 VDD VSS / sg13g2_buf_1
Xoutput13 dac_hard_2_ net13 VDD VSS / sg13g2_buf_1
Xoutput14 dac_hard_3_ net14 VDD VSS / sg13g2_buf_1
Xoutput15 dac_hard_4_ net15 VDD VSS / sg13g2_buf_1
Xoutput16 dac_hard_5_ net16 VDD VSS / sg13g2_buf_1
Xoutput17 dac_hard_6_ net17 VDD VSS / sg13g2_buf_1
Xoutput18 dac_hard_7_ net18 VDD VSS / sg13g2_buf_1
Xoutput19 dac_soft_0_ net19 VDD VSS / sg13g2_buf_1
Xoutput20 dac_soft_1_ net20 VDD VSS / sg13g2_buf_1
Xoutput21 dac_soft_2_ net21 VDD VSS / sg13g2_buf_1
Xoutput22 dac_soft_3_ net22 VDD VSS / sg13g2_buf_1
Xoutput23 dac_soft_4_ net23 VDD VSS / sg13g2_buf_1
Xoutput24 dac_soft_5_ net24 VDD VSS / sg13g2_buf_1
Xoutput25 dac_soft_6_ net25 VDD VSS / sg13g2_buf_1
Xoutput26 dac_soft_7_ net26 VDD VSS / sg13g2_buf_1
Xoutput27 fast_en net27 VDD VSS / sg13g2_buf_1
Xoutput28 fault_n net28 VDD VSS / sg13g2_buf_1
Xoutput29 gate_en net29 VDD VSS / sg13g2_buf_1
Xoutput30 osc_en net30 VDD VSS / sg13g2_buf_1
Xoutput31 osc_trim_0_ net31 VDD VSS / sg13g2_buf_1
Xoutput32 osc_trim_1_ net32 VDD VSS / sg13g2_buf_1
Xoutput33 osc_trim_2_ net33 VDD VSS / sg13g2_buf_1
Xoutput34 osc_trim_3_ net34 VDD VSS / sg13g2_buf_1
Xoutput35 sdo net35 VDD VSS / sg13g2_buf_1
Xoutput36 t2f_en net36 VDD VSS / sg13g2_buf_1
Xoutput37 t2f_mode net37 VDD VSS / sg13g2_buf_1
Xoutput38 trip net38 VDD VSS / sg13g2_buf_1
Xoutput39 trip_cause_0_ net39 VDD VSS / sg13g2_buf_1
Xoutput40 trip_cause_1_ net40 VDD VSS / sg13g2_buf_1
Xoutput41 trip_d net41 VDD VSS / sg13g2_buf_1
Xoutput42 trip_set_sel net42 VDD VSS / sg13g2_buf_1
Xoutput7 bgr_r4 net7 VDD VSS / sg13g2_buf_1
Xoutput8 clk_div_out net8 VDD VSS / sg13g2_buf_1
Xoutput9 clr_d net9 VDD VSS / sg13g2_buf_1
Xwire103 net103 _1911_ VDD VSS / sg13g2_buf_4
.ENDS

* ---- chip ----
.SUBCKT g1_core D_ELT D_STD G_SHARED HBT_B HBT_C HBT_E SENSE_N SENSE_P VDDA VDD VSS en_i fault_n_o gate_o i_core_sclk_i i_core_sdi_i i_core_sdo_o i_core_temp_out_o i_core_vref
XANTENNA_1 en_i VDD VSS / sg13g2_antennanp
XANTENNA_2 i_core_cmp_soft VDD VSS / sg13g2_antennanp
XANTENNA_3 i_core_cmp_soft VDD VSS / sg13g2_antennanp
XANTENNA_4 i_core_sdi_i VDD VSS / sg13g2_antennanp
XANTENNA_5 i_core_tripped VDD VSS / sg13g2_antennanp
XANTENNA_6 i_core_tripped VDD VSS / sg13g2_antennanp
XFILLER_0_1006 VDD VSS / sg13g2_decap_8
XFILLER_0_1013 VDD VSS / sg13g2_decap_8
XFILLER_0_1020 VDD VSS / sg13g2_decap_8
XFILLER_0_1027 VDD VSS / sg13g2_decap_8
XFILLER_0_103 VDD VSS / sg13g2_decap_8
XFILLER_0_1034 VDD VSS / sg13g2_decap_8
XFILLER_0_1041 VDD VSS / sg13g2_decap_8
XFILLER_0_1048 VDD VSS / sg13g2_decap_8
XFILLER_0_1055 VDD VSS / sg13g2_decap_8
XFILLER_0_1062 VDD VSS / sg13g2_decap_8
XFILLER_0_1069 VDD VSS / sg13g2_decap_8
XFILLER_0_1076 VDD VSS / sg13g2_decap_8
XFILLER_0_1083 VDD VSS / sg13g2_decap_8
XFILLER_0_1090 VDD VSS / sg13g2_decap_8
XFILLER_0_1097 VDD VSS / sg13g2_decap_8
XFILLER_0_110 VDD VSS / sg13g2_decap_8
XFILLER_0_1104 VDD VSS / sg13g2_decap_8
XFILLER_0_1111 VDD VSS / sg13g2_decap_8
XFILLER_0_1118 VDD VSS / sg13g2_decap_8
XFILLER_0_1125 VDD VSS / sg13g2_decap_8
XFILLER_0_1132 VDD VSS / sg13g2_decap_8
XFILLER_0_1139 VDD VSS / sg13g2_decap_8
XFILLER_0_1146 VDD VSS / sg13g2_decap_8
XFILLER_0_1153 VDD VSS / sg13g2_decap_8
XFILLER_0_1160 VDD VSS / sg13g2_decap_8
XFILLER_0_1167 VDD VSS / sg13g2_decap_8
XFILLER_0_117 VDD VSS / sg13g2_decap_8
XFILLER_0_1174 VDD VSS / sg13g2_decap_8
XFILLER_0_1181 VDD VSS / sg13g2_decap_8
XFILLER_0_1188 VDD VSS / sg13g2_decap_8
XFILLER_0_1195 VDD VSS / sg13g2_decap_8
XFILLER_0_1202 VDD VSS / sg13g2_decap_8
XFILLER_0_1209 VDD VSS / sg13g2_decap_8
XFILLER_0_1216 VDD VSS / sg13g2_decap_8
XFILLER_0_1223 VDD VSS / sg13g2_decap_8
XFILLER_0_1230 VDD VSS / sg13g2_decap_8
XFILLER_0_1237 VDD VSS / sg13g2_decap_8
XFILLER_0_124 VDD VSS / sg13g2_decap_8
XFILLER_0_1244 VDD VSS / sg13g2_decap_8
XFILLER_0_1251 VDD VSS / sg13g2_decap_8
XFILLER_0_1258 VDD VSS / sg13g2_decap_8
XFILLER_0_1265 VDD VSS / sg13g2_decap_8
XFILLER_0_1272 VDD VSS / sg13g2_decap_8
XFILLER_0_1279 VDD VSS / sg13g2_decap_8
XFILLER_0_1286 VDD VSS / sg13g2_decap_8
XFILLER_0_1293 VDD VSS / sg13g2_fill_2
XFILLER_0_131 VDD VSS / sg13g2_decap_8
XFILLER_0_138 VDD VSS / sg13g2_decap_8
XFILLER_0_145 VDD VSS / sg13g2_decap_8
XFILLER_0_152 VDD VSS / sg13g2_decap_8
XFILLER_0_159 VDD VSS / sg13g2_decap_8
XFILLER_0_166 VDD VSS / sg13g2_decap_8
XFILLER_0_173 VDD VSS / sg13g2_decap_8
XFILLER_0_180 VDD VSS / sg13g2_decap_8
XFILLER_0_187 VDD VSS / sg13g2_decap_8
XFILLER_0_194 VDD VSS / sg13g2_decap_8
XFILLER_0_201 VDD VSS / sg13g2_decap_8
XFILLER_0_208 VDD VSS / sg13g2_decap_8
XFILLER_0_215 VDD VSS / sg13g2_decap_8
XFILLER_0_222 VDD VSS / sg13g2_decap_8
XFILLER_0_229 VDD VSS / sg13g2_decap_8
XFILLER_0_236 VDD VSS / sg13g2_decap_8
XFILLER_0_243 VDD VSS / sg13g2_decap_8
XFILLER_0_250 VDD VSS / sg13g2_decap_8
XFILLER_0_257 VDD VSS / sg13g2_decap_8
XFILLER_0_264 VDD VSS / sg13g2_decap_8
XFILLER_0_271 VDD VSS / sg13g2_decap_8
XFILLER_0_278 VDD VSS / sg13g2_decap_8
XFILLER_0_285 VDD VSS / sg13g2_decap_8
XFILLER_0_292 VDD VSS / sg13g2_decap_8
XFILLER_0_299 VDD VSS / sg13g2_decap_8
XFILLER_0_306 VDD VSS / sg13g2_decap_8
XFILLER_0_313 VDD VSS / sg13g2_decap_8
XFILLER_0_320 VDD VSS / sg13g2_decap_8
XFILLER_0_327 VDD VSS / sg13g2_decap_8
XFILLER_0_334 VDD VSS / sg13g2_decap_8
XFILLER_0_341 VDD VSS / sg13g2_decap_8
XFILLER_0_348 VDD VSS / sg13g2_decap_8
XFILLER_0_355 VDD VSS / sg13g2_decap_8
XFILLER_0_362 VDD VSS / sg13g2_decap_8
XFILLER_0_369 VDD VSS / sg13g2_decap_8
XFILLER_0_376 VDD VSS / sg13g2_decap_8
XFILLER_0_383 VDD VSS / sg13g2_decap_8
XFILLER_0_390 VDD VSS / sg13g2_decap_8
XFILLER_0_397 VDD VSS / sg13g2_decap_8
XFILLER_0_404 VDD VSS / sg13g2_decap_8
XFILLER_0_411 VDD VSS / sg13g2_decap_8
XFILLER_0_418 VDD VSS / sg13g2_decap_8
XFILLER_0_425 VDD VSS / sg13g2_decap_8
XFILLER_0_432 VDD VSS / sg13g2_decap_8
XFILLER_0_439 VDD VSS / sg13g2_decap_8
XFILLER_0_446 VDD VSS / sg13g2_decap_8
XFILLER_0_453 VDD VSS / sg13g2_decap_8
XFILLER_0_460 VDD VSS / sg13g2_decap_8
XFILLER_0_467 VDD VSS / sg13g2_decap_8
XFILLER_0_474 VDD VSS / sg13g2_decap_8
XFILLER_0_481 VDD VSS / sg13g2_decap_8
XFILLER_0_488 VDD VSS / sg13g2_decap_8
XFILLER_0_495 VDD VSS / sg13g2_decap_8
XFILLER_0_502 VDD VSS / sg13g2_decap_8
XFILLER_0_509 VDD VSS / sg13g2_decap_8
XFILLER_0_516 VDD VSS / sg13g2_decap_8
XFILLER_0_523 VDD VSS / sg13g2_decap_8
XFILLER_0_530 VDD VSS / sg13g2_decap_8
XFILLER_0_537 VDD VSS / sg13g2_decap_8
XFILLER_0_544 VDD VSS / sg13g2_decap_8
XFILLER_0_551 VDD VSS / sg13g2_decap_8
XFILLER_0_558 VDD VSS / sg13g2_decap_8
XFILLER_0_565 VDD VSS / sg13g2_decap_8
XFILLER_0_572 VDD VSS / sg13g2_decap_8
XFILLER_0_579 VDD VSS / sg13g2_decap_8
XFILLER_0_586 VDD VSS / sg13g2_decap_8
XFILLER_0_593 VDD VSS / sg13g2_decap_8
XFILLER_0_600 VDD VSS / sg13g2_decap_8
XFILLER_0_607 VDD VSS / sg13g2_decap_8
XFILLER_0_614 VDD VSS / sg13g2_decap_8
XFILLER_0_621 VDD VSS / sg13g2_decap_8
XFILLER_0_628 VDD VSS / sg13g2_decap_8
XFILLER_0_635 VDD VSS / sg13g2_decap_8
XFILLER_0_642 VDD VSS / sg13g2_decap_8
XFILLER_0_649 VDD VSS / sg13g2_decap_8
XFILLER_0_656 VDD VSS / sg13g2_decap_8
XFILLER_0_663 VDD VSS / sg13g2_decap_8
XFILLER_0_670 VDD VSS / sg13g2_decap_8
XFILLER_0_677 VDD VSS / sg13g2_decap_8
XFILLER_0_684 VDD VSS / sg13g2_decap_8
XFILLER_0_691 VDD VSS / sg13g2_decap_8
XFILLER_0_698 VDD VSS / sg13g2_decap_8
XFILLER_0_705 VDD VSS / sg13g2_decap_8
XFILLER_0_712 VDD VSS / sg13g2_decap_8
XFILLER_0_719 VDD VSS / sg13g2_decap_8
XFILLER_0_726 VDD VSS / sg13g2_decap_8
XFILLER_0_733 VDD VSS / sg13g2_decap_8
XFILLER_0_740 VDD VSS / sg13g2_decap_8
XFILLER_0_747 VDD VSS / sg13g2_decap_8
XFILLER_0_754 VDD VSS / sg13g2_decap_8
XFILLER_0_761 VDD VSS / sg13g2_decap_8
XFILLER_0_768 VDD VSS / sg13g2_decap_8
XFILLER_0_775 VDD VSS / sg13g2_decap_8
XFILLER_0_782 VDD VSS / sg13g2_decap_8
XFILLER_0_789 VDD VSS / sg13g2_decap_8
XFILLER_0_796 VDD VSS / sg13g2_decap_8
XFILLER_0_803 VDD VSS / sg13g2_decap_8
XFILLER_0_810 VDD VSS / sg13g2_decap_8
XFILLER_0_817 VDD VSS / sg13g2_decap_8
XFILLER_0_824 VDD VSS / sg13g2_decap_8
XFILLER_0_831 VDD VSS / sg13g2_decap_8
XFILLER_0_838 VDD VSS / sg13g2_decap_8
XFILLER_0_845 VDD VSS / sg13g2_decap_8
XFILLER_0_852 VDD VSS / sg13g2_decap_8
XFILLER_0_859 VDD VSS / sg13g2_decap_8
XFILLER_0_866 VDD VSS / sg13g2_decap_8
XFILLER_0_873 VDD VSS / sg13g2_decap_8
XFILLER_0_880 VDD VSS / sg13g2_decap_8
XFILLER_0_887 VDD VSS / sg13g2_decap_8
XFILLER_0_89 VDD VSS / sg13g2_decap_8
XFILLER_0_894 VDD VSS / sg13g2_decap_8
XFILLER_0_901 VDD VSS / sg13g2_decap_8
XFILLER_0_908 VDD VSS / sg13g2_decap_8
XFILLER_0_915 VDD VSS / sg13g2_decap_8
XFILLER_0_922 VDD VSS / sg13g2_decap_8
XFILLER_0_929 VDD VSS / sg13g2_decap_8
XFILLER_0_936 VDD VSS / sg13g2_decap_8
XFILLER_0_943 VDD VSS / sg13g2_decap_8
XFILLER_0_950 VDD VSS / sg13g2_decap_8
XFILLER_0_957 VDD VSS / sg13g2_decap_8
XFILLER_0_96 VDD VSS / sg13g2_decap_8
XFILLER_0_964 VDD VSS / sg13g2_decap_8
XFILLER_0_971 VDD VSS / sg13g2_decap_8
XFILLER_0_978 VDD VSS / sg13g2_decap_8
XFILLER_0_985 VDD VSS / sg13g2_decap_8
XFILLER_0_992 VDD VSS / sg13g2_decap_8
XFILLER_0_999 VDD VSS / sg13g2_decap_8
XFILLER_10_1001 VDD VSS / sg13g2_decap_8
XFILLER_10_1008 VDD VSS / sg13g2_decap_8
XFILLER_10_1015 VDD VSS / sg13g2_decap_8
XFILLER_10_1022 VDD VSS / sg13g2_decap_8
XFILLER_10_1029 VDD VSS / sg13g2_decap_8
XFILLER_10_1036 VDD VSS / sg13g2_decap_8
XFILLER_10_1043 VDD VSS / sg13g2_decap_8
XFILLER_10_1050 VDD VSS / sg13g2_decap_8
XFILLER_10_1057 VDD VSS / sg13g2_decap_8
XFILLER_10_1064 VDD VSS / sg13g2_decap_8
XFILLER_10_1071 VDD VSS / sg13g2_decap_8
XFILLER_10_1078 VDD VSS / sg13g2_decap_8
XFILLER_10_1085 VDD VSS / sg13g2_decap_8
XFILLER_10_1092 VDD VSS / sg13g2_decap_8
XFILLER_10_1099 VDD VSS / sg13g2_decap_8
XFILLER_10_1106 VDD VSS / sg13g2_decap_8
XFILLER_10_1113 VDD VSS / sg13g2_decap_8
XFILLER_10_1120 VDD VSS / sg13g2_decap_8
XFILLER_10_1127 VDD VSS / sg13g2_decap_8
XFILLER_10_1134 VDD VSS / sg13g2_decap_8
XFILLER_10_1141 VDD VSS / sg13g2_decap_8
XFILLER_10_1148 VDD VSS / sg13g2_decap_8
XFILLER_10_1155 VDD VSS / sg13g2_decap_8
XFILLER_10_1162 VDD VSS / sg13g2_decap_8
XFILLER_10_1169 VDD VSS / sg13g2_decap_8
XFILLER_10_1176 VDD VSS / sg13g2_decap_8
XFILLER_10_1183 VDD VSS / sg13g2_decap_8
XFILLER_10_1190 VDD VSS / sg13g2_decap_8
XFILLER_10_1197 VDD VSS / sg13g2_decap_8
XFILLER_10_1204 VDD VSS / sg13g2_decap_8
XFILLER_10_1211 VDD VSS / sg13g2_decap_8
XFILLER_10_1218 VDD VSS / sg13g2_decap_8
XFILLER_10_1225 VDD VSS / sg13g2_decap_8
XFILLER_10_1232 VDD VSS / sg13g2_decap_8
XFILLER_10_1239 VDD VSS / sg13g2_decap_8
XFILLER_10_1246 VDD VSS / sg13g2_decap_8
XFILLER_10_1253 VDD VSS / sg13g2_decap_8
XFILLER_10_1260 VDD VSS / sg13g2_decap_8
XFILLER_10_1267 VDD VSS / sg13g2_decap_8
XFILLER_10_1274 VDD VSS / sg13g2_decap_8
XFILLER_10_1281 VDD VSS / sg13g2_decap_8
XFILLER_10_1288 VDD VSS / sg13g2_decap_8
XFILLER_10_777 VDD VSS / sg13g2_decap_8
XFILLER_10_784 VDD VSS / sg13g2_decap_8
XFILLER_10_791 VDD VSS / sg13g2_decap_8
XFILLER_10_798 VDD VSS / sg13g2_decap_8
XFILLER_10_805 VDD VSS / sg13g2_decap_8
XFILLER_10_812 VDD VSS / sg13g2_decap_8
XFILLER_10_819 VDD VSS / sg13g2_decap_8
XFILLER_10_826 VDD VSS / sg13g2_decap_8
XFILLER_10_833 VDD VSS / sg13g2_decap_8
XFILLER_10_840 VDD VSS / sg13g2_decap_8
XFILLER_10_847 VDD VSS / sg13g2_decap_8
XFILLER_10_854 VDD VSS / sg13g2_decap_8
XFILLER_10_861 VDD VSS / sg13g2_decap_8
XFILLER_10_868 VDD VSS / sg13g2_decap_8
XFILLER_10_875 VDD VSS / sg13g2_decap_8
XFILLER_10_882 VDD VSS / sg13g2_decap_8
XFILLER_10_889 VDD VSS / sg13g2_decap_8
XFILLER_10_896 VDD VSS / sg13g2_decap_8
XFILLER_10_903 VDD VSS / sg13g2_decap_8
XFILLER_10_910 VDD VSS / sg13g2_decap_8
XFILLER_10_917 VDD VSS / sg13g2_decap_8
XFILLER_10_924 VDD VSS / sg13g2_decap_8
XFILLER_10_931 VDD VSS / sg13g2_decap_8
XFILLER_10_938 VDD VSS / sg13g2_decap_8
XFILLER_10_945 VDD VSS / sg13g2_decap_8
XFILLER_10_952 VDD VSS / sg13g2_decap_8
XFILLER_10_959 VDD VSS / sg13g2_decap_8
XFILLER_10_966 VDD VSS / sg13g2_decap_8
XFILLER_10_973 VDD VSS / sg13g2_decap_8
XFILLER_10_980 VDD VSS / sg13g2_decap_8
XFILLER_10_987 VDD VSS / sg13g2_decap_8
XFILLER_10_994 VDD VSS / sg13g2_decap_8
XFILLER_11_1001 VDD VSS / sg13g2_decap_8
XFILLER_11_1008 VDD VSS / sg13g2_decap_8
XFILLER_11_1015 VDD VSS / sg13g2_decap_8
XFILLER_11_1022 VDD VSS / sg13g2_decap_8
XFILLER_11_1029 VDD VSS / sg13g2_decap_8
XFILLER_11_1036 VDD VSS / sg13g2_decap_8
XFILLER_11_1043 VDD VSS / sg13g2_decap_8
XFILLER_11_1050 VDD VSS / sg13g2_decap_8
XFILLER_11_1057 VDD VSS / sg13g2_decap_8
XFILLER_11_1064 VDD VSS / sg13g2_decap_8
XFILLER_11_1071 VDD VSS / sg13g2_decap_8
XFILLER_11_1078 VDD VSS / sg13g2_decap_8
XFILLER_11_1085 VDD VSS / sg13g2_decap_8
XFILLER_11_1092 VDD VSS / sg13g2_decap_8
XFILLER_11_1099 VDD VSS / sg13g2_decap_8
XFILLER_11_1106 VDD VSS / sg13g2_decap_8
XFILLER_11_1113 VDD VSS / sg13g2_decap_8
XFILLER_11_1120 VDD VSS / sg13g2_decap_8
XFILLER_11_1127 VDD VSS / sg13g2_decap_8
XFILLER_11_1134 VDD VSS / sg13g2_decap_8
XFILLER_11_1141 VDD VSS / sg13g2_decap_8
XFILLER_11_1148 VDD VSS / sg13g2_decap_8
XFILLER_11_1155 VDD VSS / sg13g2_decap_8
XFILLER_11_1162 VDD VSS / sg13g2_decap_8
XFILLER_11_1169 VDD VSS / sg13g2_decap_8
XFILLER_11_1176 VDD VSS / sg13g2_decap_8
XFILLER_11_1183 VDD VSS / sg13g2_decap_8
XFILLER_11_1190 VDD VSS / sg13g2_decap_8
XFILLER_11_1197 VDD VSS / sg13g2_decap_8
XFILLER_11_1204 VDD VSS / sg13g2_decap_8
XFILLER_11_1211 VDD VSS / sg13g2_decap_8
XFILLER_11_1218 VDD VSS / sg13g2_decap_8
XFILLER_11_1225 VDD VSS / sg13g2_decap_8
XFILLER_11_1232 VDD VSS / sg13g2_decap_8
XFILLER_11_1239 VDD VSS / sg13g2_decap_8
XFILLER_11_1246 VDD VSS / sg13g2_decap_8
XFILLER_11_1253 VDD VSS / sg13g2_decap_8
XFILLER_11_1260 VDD VSS / sg13g2_decap_8
XFILLER_11_1267 VDD VSS / sg13g2_decap_8
XFILLER_11_1274 VDD VSS / sg13g2_decap_8
XFILLER_11_1281 VDD VSS / sg13g2_decap_8
XFILLER_11_1288 VDD VSS / sg13g2_decap_8
XFILLER_11_777 VDD VSS / sg13g2_decap_8
XFILLER_11_784 VDD VSS / sg13g2_decap_8
XFILLER_11_791 VDD VSS / sg13g2_decap_8
XFILLER_11_798 VDD VSS / sg13g2_decap_8
XFILLER_11_805 VDD VSS / sg13g2_decap_8
XFILLER_11_812 VDD VSS / sg13g2_decap_8
XFILLER_11_819 VDD VSS / sg13g2_decap_8
XFILLER_11_826 VDD VSS / sg13g2_decap_8
XFILLER_11_833 VDD VSS / sg13g2_decap_8
XFILLER_11_840 VDD VSS / sg13g2_decap_8
XFILLER_11_847 VDD VSS / sg13g2_decap_8
XFILLER_11_854 VDD VSS / sg13g2_decap_8
XFILLER_11_861 VDD VSS / sg13g2_decap_8
XFILLER_11_868 VDD VSS / sg13g2_decap_8
XFILLER_11_875 VDD VSS / sg13g2_decap_8
XFILLER_11_882 VDD VSS / sg13g2_decap_8
XFILLER_11_889 VDD VSS / sg13g2_decap_8
XFILLER_11_896 VDD VSS / sg13g2_decap_8
XFILLER_11_903 VDD VSS / sg13g2_decap_8
XFILLER_11_910 VDD VSS / sg13g2_decap_8
XFILLER_11_917 VDD VSS / sg13g2_decap_8
XFILLER_11_924 VDD VSS / sg13g2_decap_8
XFILLER_11_931 VDD VSS / sg13g2_decap_8
XFILLER_11_938 VDD VSS / sg13g2_decap_8
XFILLER_11_945 VDD VSS / sg13g2_decap_8
XFILLER_11_952 VDD VSS / sg13g2_decap_8
XFILLER_11_959 VDD VSS / sg13g2_decap_8
XFILLER_11_966 VDD VSS / sg13g2_decap_8
XFILLER_11_973 VDD VSS / sg13g2_decap_8
XFILLER_11_980 VDD VSS / sg13g2_decap_8
XFILLER_11_987 VDD VSS / sg13g2_decap_8
XFILLER_11_994 VDD VSS / sg13g2_decap_8
XFILLER_12_1001 VDD VSS / sg13g2_decap_8
XFILLER_12_1008 VDD VSS / sg13g2_decap_8
XFILLER_12_1015 VDD VSS / sg13g2_decap_8
XFILLER_12_1022 VDD VSS / sg13g2_decap_8
XFILLER_12_1029 VDD VSS / sg13g2_decap_8
XFILLER_12_1036 VDD VSS / sg13g2_decap_8
XFILLER_12_1043 VDD VSS / sg13g2_decap_8
XFILLER_12_1050 VDD VSS / sg13g2_decap_8
XFILLER_12_1057 VDD VSS / sg13g2_decap_8
XFILLER_12_1064 VDD VSS / sg13g2_decap_8
XFILLER_12_1071 VDD VSS / sg13g2_decap_8
XFILLER_12_1078 VDD VSS / sg13g2_decap_8
XFILLER_12_1085 VDD VSS / sg13g2_decap_8
XFILLER_12_1092 VDD VSS / sg13g2_decap_8
XFILLER_12_1099 VDD VSS / sg13g2_decap_8
XFILLER_12_1106 VDD VSS / sg13g2_decap_8
XFILLER_12_1113 VDD VSS / sg13g2_decap_8
XFILLER_12_1120 VDD VSS / sg13g2_decap_8
XFILLER_12_1127 VDD VSS / sg13g2_decap_8
XFILLER_12_1134 VDD VSS / sg13g2_decap_8
XFILLER_12_1141 VDD VSS / sg13g2_decap_8
XFILLER_12_1148 VDD VSS / sg13g2_decap_8
XFILLER_12_1155 VDD VSS / sg13g2_decap_8
XFILLER_12_1162 VDD VSS / sg13g2_decap_8
XFILLER_12_1169 VDD VSS / sg13g2_decap_8
XFILLER_12_1176 VDD VSS / sg13g2_decap_8
XFILLER_12_1183 VDD VSS / sg13g2_decap_8
XFILLER_12_1190 VDD VSS / sg13g2_decap_8
XFILLER_12_1197 VDD VSS / sg13g2_decap_8
XFILLER_12_1204 VDD VSS / sg13g2_decap_8
XFILLER_12_1211 VDD VSS / sg13g2_decap_8
XFILLER_12_1218 VDD VSS / sg13g2_decap_8
XFILLER_12_1225 VDD VSS / sg13g2_decap_8
XFILLER_12_1232 VDD VSS / sg13g2_decap_8
XFILLER_12_1239 VDD VSS / sg13g2_decap_8
XFILLER_12_1246 VDD VSS / sg13g2_decap_8
XFILLER_12_1253 VDD VSS / sg13g2_decap_8
XFILLER_12_1260 VDD VSS / sg13g2_decap_8
XFILLER_12_1267 VDD VSS / sg13g2_decap_8
XFILLER_12_1274 VDD VSS / sg13g2_decap_8
XFILLER_12_1281 VDD VSS / sg13g2_decap_8
XFILLER_12_1288 VDD VSS / sg13g2_decap_8
XFILLER_12_777 VDD VSS / sg13g2_decap_8
XFILLER_12_784 VDD VSS / sg13g2_decap_8
XFILLER_12_791 VDD VSS / sg13g2_decap_8
XFILLER_12_798 VDD VSS / sg13g2_decap_8
XFILLER_12_805 VDD VSS / sg13g2_decap_8
XFILLER_12_812 VDD VSS / sg13g2_decap_8
XFILLER_12_819 VDD VSS / sg13g2_decap_8
XFILLER_12_826 VDD VSS / sg13g2_decap_8
XFILLER_12_833 VDD VSS / sg13g2_decap_8
XFILLER_12_840 VDD VSS / sg13g2_decap_8
XFILLER_12_847 VDD VSS / sg13g2_decap_8
XFILLER_12_854 VDD VSS / sg13g2_decap_8
XFILLER_12_861 VDD VSS / sg13g2_decap_8
XFILLER_12_868 VDD VSS / sg13g2_decap_8
XFILLER_12_875 VDD VSS / sg13g2_decap_8
XFILLER_12_882 VDD VSS / sg13g2_decap_8
XFILLER_12_889 VDD VSS / sg13g2_decap_8
XFILLER_12_896 VDD VSS / sg13g2_decap_8
XFILLER_12_903 VDD VSS / sg13g2_decap_8
XFILLER_12_910 VDD VSS / sg13g2_decap_8
XFILLER_12_917 VDD VSS / sg13g2_decap_8
XFILLER_12_924 VDD VSS / sg13g2_decap_8
XFILLER_12_931 VDD VSS / sg13g2_decap_8
XFILLER_12_938 VDD VSS / sg13g2_decap_8
XFILLER_12_945 VDD VSS / sg13g2_decap_8
XFILLER_12_952 VDD VSS / sg13g2_decap_8
XFILLER_12_959 VDD VSS / sg13g2_decap_8
XFILLER_12_966 VDD VSS / sg13g2_decap_8
XFILLER_12_973 VDD VSS / sg13g2_decap_8
XFILLER_12_980 VDD VSS / sg13g2_decap_8
XFILLER_12_987 VDD VSS / sg13g2_decap_8
XFILLER_12_994 VDD VSS / sg13g2_decap_8
XFILLER_13_1001 VDD VSS / sg13g2_decap_8
XFILLER_13_1008 VDD VSS / sg13g2_decap_8
XFILLER_13_1015 VDD VSS / sg13g2_decap_8
XFILLER_13_1022 VDD VSS / sg13g2_decap_8
XFILLER_13_1029 VDD VSS / sg13g2_decap_8
XFILLER_13_1036 VDD VSS / sg13g2_decap_8
XFILLER_13_1043 VDD VSS / sg13g2_decap_8
XFILLER_13_1050 VDD VSS / sg13g2_decap_8
XFILLER_13_1057 VDD VSS / sg13g2_decap_8
XFILLER_13_1064 VDD VSS / sg13g2_decap_8
XFILLER_13_1071 VDD VSS / sg13g2_decap_8
XFILLER_13_1078 VDD VSS / sg13g2_decap_8
XFILLER_13_1085 VDD VSS / sg13g2_decap_8
XFILLER_13_1092 VDD VSS / sg13g2_decap_8
XFILLER_13_1099 VDD VSS / sg13g2_decap_8
XFILLER_13_1106 VDD VSS / sg13g2_decap_8
XFILLER_13_1113 VDD VSS / sg13g2_decap_8
XFILLER_13_1120 VDD VSS / sg13g2_decap_8
XFILLER_13_1127 VDD VSS / sg13g2_decap_8
XFILLER_13_1134 VDD VSS / sg13g2_decap_8
XFILLER_13_1141 VDD VSS / sg13g2_decap_8
XFILLER_13_1148 VDD VSS / sg13g2_decap_8
XFILLER_13_1155 VDD VSS / sg13g2_decap_8
XFILLER_13_1162 VDD VSS / sg13g2_decap_8
XFILLER_13_1169 VDD VSS / sg13g2_decap_8
XFILLER_13_1176 VDD VSS / sg13g2_decap_8
XFILLER_13_1183 VDD VSS / sg13g2_decap_8
XFILLER_13_1190 VDD VSS / sg13g2_decap_8
XFILLER_13_1197 VDD VSS / sg13g2_decap_8
XFILLER_13_1204 VDD VSS / sg13g2_decap_8
XFILLER_13_1211 VDD VSS / sg13g2_decap_8
XFILLER_13_1218 VDD VSS / sg13g2_decap_8
XFILLER_13_1225 VDD VSS / sg13g2_decap_8
XFILLER_13_1232 VDD VSS / sg13g2_decap_8
XFILLER_13_1239 VDD VSS / sg13g2_decap_8
XFILLER_13_1246 VDD VSS / sg13g2_decap_8
XFILLER_13_1253 VDD VSS / sg13g2_decap_8
XFILLER_13_1260 VDD VSS / sg13g2_decap_8
XFILLER_13_1267 VDD VSS / sg13g2_decap_8
XFILLER_13_1274 VDD VSS / sg13g2_decap_8
XFILLER_13_1281 VDD VSS / sg13g2_decap_8
XFILLER_13_1288 VDD VSS / sg13g2_decap_8
XFILLER_13_777 VDD VSS / sg13g2_decap_8
XFILLER_13_784 VDD VSS / sg13g2_decap_8
XFILLER_13_791 VDD VSS / sg13g2_decap_8
XFILLER_13_798 VDD VSS / sg13g2_decap_8
XFILLER_13_805 VDD VSS / sg13g2_decap_8
XFILLER_13_812 VDD VSS / sg13g2_decap_8
XFILLER_13_819 VDD VSS / sg13g2_decap_8
XFILLER_13_826 VDD VSS / sg13g2_decap_8
XFILLER_13_833 VDD VSS / sg13g2_decap_8
XFILLER_13_840 VDD VSS / sg13g2_decap_8
XFILLER_13_847 VDD VSS / sg13g2_decap_8
XFILLER_13_854 VDD VSS / sg13g2_decap_8
XFILLER_13_861 VDD VSS / sg13g2_decap_8
XFILLER_13_868 VDD VSS / sg13g2_decap_8
XFILLER_13_875 VDD VSS / sg13g2_decap_8
XFILLER_13_882 VDD VSS / sg13g2_decap_8
XFILLER_13_889 VDD VSS / sg13g2_decap_8
XFILLER_13_896 VDD VSS / sg13g2_decap_8
XFILLER_13_903 VDD VSS / sg13g2_decap_8
XFILLER_13_910 VDD VSS / sg13g2_decap_8
XFILLER_13_917 VDD VSS / sg13g2_decap_8
XFILLER_13_924 VDD VSS / sg13g2_decap_8
XFILLER_13_931 VDD VSS / sg13g2_decap_8
XFILLER_13_938 VDD VSS / sg13g2_decap_8
XFILLER_13_945 VDD VSS / sg13g2_decap_8
XFILLER_13_952 VDD VSS / sg13g2_decap_8
XFILLER_13_959 VDD VSS / sg13g2_decap_8
XFILLER_13_966 VDD VSS / sg13g2_decap_8
XFILLER_13_973 VDD VSS / sg13g2_decap_8
XFILLER_13_980 VDD VSS / sg13g2_decap_8
XFILLER_13_987 VDD VSS / sg13g2_decap_8
XFILLER_13_994 VDD VSS / sg13g2_decap_8
XFILLER_14_1001 VDD VSS / sg13g2_decap_8
XFILLER_14_1008 VDD VSS / sg13g2_decap_8
XFILLER_14_1015 VDD VSS / sg13g2_decap_8
XFILLER_14_1022 VDD VSS / sg13g2_decap_8
XFILLER_14_1029 VDD VSS / sg13g2_decap_8
XFILLER_14_1036 VDD VSS / sg13g2_decap_8
XFILLER_14_1043 VDD VSS / sg13g2_decap_8
XFILLER_14_1050 VDD VSS / sg13g2_decap_8
XFILLER_14_1057 VDD VSS / sg13g2_decap_8
XFILLER_14_1064 VDD VSS / sg13g2_decap_8
XFILLER_14_1071 VDD VSS / sg13g2_decap_8
XFILLER_14_1078 VDD VSS / sg13g2_decap_8
XFILLER_14_1085 VDD VSS / sg13g2_decap_8
XFILLER_14_1092 VDD VSS / sg13g2_decap_8
XFILLER_14_1099 VDD VSS / sg13g2_decap_8
XFILLER_14_1106 VDD VSS / sg13g2_decap_8
XFILLER_14_1113 VDD VSS / sg13g2_decap_8
XFILLER_14_1120 VDD VSS / sg13g2_decap_8
XFILLER_14_1127 VDD VSS / sg13g2_decap_8
XFILLER_14_1134 VDD VSS / sg13g2_decap_8
XFILLER_14_1141 VDD VSS / sg13g2_decap_8
XFILLER_14_1148 VDD VSS / sg13g2_decap_8
XFILLER_14_1155 VDD VSS / sg13g2_decap_8
XFILLER_14_1162 VDD VSS / sg13g2_decap_8
XFILLER_14_1169 VDD VSS / sg13g2_decap_8
XFILLER_14_1176 VDD VSS / sg13g2_decap_8
XFILLER_14_1183 VDD VSS / sg13g2_decap_8
XFILLER_14_1190 VDD VSS / sg13g2_decap_8
XFILLER_14_1197 VDD VSS / sg13g2_decap_8
XFILLER_14_1204 VDD VSS / sg13g2_decap_8
XFILLER_14_1211 VDD VSS / sg13g2_decap_8
XFILLER_14_1218 VDD VSS / sg13g2_decap_8
XFILLER_14_1225 VDD VSS / sg13g2_decap_8
XFILLER_14_1232 VDD VSS / sg13g2_decap_8
XFILLER_14_1239 VDD VSS / sg13g2_decap_8
XFILLER_14_1246 VDD VSS / sg13g2_decap_8
XFILLER_14_1253 VDD VSS / sg13g2_decap_8
XFILLER_14_1260 VDD VSS / sg13g2_decap_8
XFILLER_14_1267 VDD VSS / sg13g2_decap_8
XFILLER_14_1274 VDD VSS / sg13g2_decap_8
XFILLER_14_1281 VDD VSS / sg13g2_decap_8
XFILLER_14_1288 VDD VSS / sg13g2_decap_8
XFILLER_14_777 VDD VSS / sg13g2_decap_8
XFILLER_14_784 VDD VSS / sg13g2_decap_8
XFILLER_14_791 VDD VSS / sg13g2_decap_8
XFILLER_14_798 VDD VSS / sg13g2_decap_8
XFILLER_14_805 VDD VSS / sg13g2_decap_8
XFILLER_14_812 VDD VSS / sg13g2_decap_8
XFILLER_14_819 VDD VSS / sg13g2_decap_8
XFILLER_14_826 VDD VSS / sg13g2_decap_8
XFILLER_14_833 VDD VSS / sg13g2_decap_8
XFILLER_14_840 VDD VSS / sg13g2_decap_8
XFILLER_14_847 VDD VSS / sg13g2_decap_8
XFILLER_14_854 VDD VSS / sg13g2_decap_8
XFILLER_14_861 VDD VSS / sg13g2_decap_8
XFILLER_14_868 VDD VSS / sg13g2_decap_8
XFILLER_14_875 VDD VSS / sg13g2_decap_8
XFILLER_14_882 VDD VSS / sg13g2_decap_8
XFILLER_14_889 VDD VSS / sg13g2_decap_8
XFILLER_14_896 VDD VSS / sg13g2_decap_8
XFILLER_14_903 VDD VSS / sg13g2_decap_8
XFILLER_14_910 VDD VSS / sg13g2_decap_8
XFILLER_14_917 VDD VSS / sg13g2_decap_8
XFILLER_14_924 VDD VSS / sg13g2_decap_8
XFILLER_14_931 VDD VSS / sg13g2_decap_8
XFILLER_14_938 VDD VSS / sg13g2_decap_8
XFILLER_14_945 VDD VSS / sg13g2_decap_8
XFILLER_14_952 VDD VSS / sg13g2_decap_8
XFILLER_14_959 VDD VSS / sg13g2_decap_8
XFILLER_14_966 VDD VSS / sg13g2_decap_8
XFILLER_14_973 VDD VSS / sg13g2_decap_8
XFILLER_14_980 VDD VSS / sg13g2_decap_8
XFILLER_14_987 VDD VSS / sg13g2_decap_8
XFILLER_14_994 VDD VSS / sg13g2_decap_8
XFILLER_15_1001 VDD VSS / sg13g2_decap_8
XFILLER_15_1008 VDD VSS / sg13g2_decap_8
XFILLER_15_1015 VDD VSS / sg13g2_decap_8
XFILLER_15_1022 VDD VSS / sg13g2_decap_8
XFILLER_15_1029 VDD VSS / sg13g2_decap_8
XFILLER_15_1036 VDD VSS / sg13g2_decap_8
XFILLER_15_1043 VDD VSS / sg13g2_decap_8
XFILLER_15_1050 VDD VSS / sg13g2_decap_8
XFILLER_15_1057 VDD VSS / sg13g2_decap_8
XFILLER_15_1064 VDD VSS / sg13g2_decap_8
XFILLER_15_1071 VDD VSS / sg13g2_decap_8
XFILLER_15_1078 VDD VSS / sg13g2_decap_8
XFILLER_15_1085 VDD VSS / sg13g2_decap_8
XFILLER_15_1092 VDD VSS / sg13g2_decap_8
XFILLER_15_1099 VDD VSS / sg13g2_decap_8
XFILLER_15_1106 VDD VSS / sg13g2_decap_8
XFILLER_15_1113 VDD VSS / sg13g2_decap_8
XFILLER_15_1120 VDD VSS / sg13g2_decap_8
XFILLER_15_1127 VDD VSS / sg13g2_decap_8
XFILLER_15_1134 VDD VSS / sg13g2_decap_8
XFILLER_15_1141 VDD VSS / sg13g2_decap_8
XFILLER_15_1148 VDD VSS / sg13g2_decap_8
XFILLER_15_1155 VDD VSS / sg13g2_decap_8
XFILLER_15_1162 VDD VSS / sg13g2_decap_8
XFILLER_15_1169 VDD VSS / sg13g2_decap_8
XFILLER_15_1176 VDD VSS / sg13g2_decap_8
XFILLER_15_1183 VDD VSS / sg13g2_decap_8
XFILLER_15_1190 VDD VSS / sg13g2_decap_8
XFILLER_15_1197 VDD VSS / sg13g2_decap_8
XFILLER_15_1204 VDD VSS / sg13g2_decap_8
XFILLER_15_1211 VDD VSS / sg13g2_decap_8
XFILLER_15_1218 VDD VSS / sg13g2_decap_8
XFILLER_15_1225 VDD VSS / sg13g2_decap_8
XFILLER_15_1232 VDD VSS / sg13g2_decap_8
XFILLER_15_1239 VDD VSS / sg13g2_decap_8
XFILLER_15_1246 VDD VSS / sg13g2_decap_8
XFILLER_15_1253 VDD VSS / sg13g2_decap_8
XFILLER_15_1260 VDD VSS / sg13g2_decap_8
XFILLER_15_1267 VDD VSS / sg13g2_decap_8
XFILLER_15_1274 VDD VSS / sg13g2_decap_8
XFILLER_15_1281 VDD VSS / sg13g2_decap_8
XFILLER_15_1288 VDD VSS / sg13g2_decap_8
XFILLER_15_777 VDD VSS / sg13g2_decap_8
XFILLER_15_784 VDD VSS / sg13g2_decap_8
XFILLER_15_791 VDD VSS / sg13g2_decap_8
XFILLER_15_798 VDD VSS / sg13g2_decap_8
XFILLER_15_805 VDD VSS / sg13g2_decap_8
XFILLER_15_812 VDD VSS / sg13g2_decap_8
XFILLER_15_819 VDD VSS / sg13g2_decap_8
XFILLER_15_826 VDD VSS / sg13g2_decap_8
XFILLER_15_833 VDD VSS / sg13g2_decap_8
XFILLER_15_840 VDD VSS / sg13g2_decap_8
XFILLER_15_847 VDD VSS / sg13g2_decap_8
XFILLER_15_854 VDD VSS / sg13g2_decap_8
XFILLER_15_861 VDD VSS / sg13g2_decap_8
XFILLER_15_868 VDD VSS / sg13g2_decap_8
XFILLER_15_875 VDD VSS / sg13g2_decap_8
XFILLER_15_882 VDD VSS / sg13g2_decap_8
XFILLER_15_889 VDD VSS / sg13g2_decap_8
XFILLER_15_896 VDD VSS / sg13g2_decap_8
XFILLER_15_903 VDD VSS / sg13g2_decap_8
XFILLER_15_910 VDD VSS / sg13g2_decap_8
XFILLER_15_917 VDD VSS / sg13g2_decap_8
XFILLER_15_924 VDD VSS / sg13g2_decap_8
XFILLER_15_931 VDD VSS / sg13g2_decap_8
XFILLER_15_938 VDD VSS / sg13g2_decap_8
XFILLER_15_945 VDD VSS / sg13g2_decap_8
XFILLER_15_952 VDD VSS / sg13g2_decap_8
XFILLER_15_959 VDD VSS / sg13g2_decap_8
XFILLER_15_966 VDD VSS / sg13g2_decap_8
XFILLER_15_973 VDD VSS / sg13g2_decap_8
XFILLER_15_980 VDD VSS / sg13g2_decap_8
XFILLER_15_987 VDD VSS / sg13g2_decap_8
XFILLER_15_994 VDD VSS / sg13g2_decap_8
XFILLER_17_0 VDD VSS / sg13g2_fill_2
XFILLER_17_103 VDD VSS / sg13g2_decap_8
XFILLER_17_110 VDD VSS / sg13g2_decap_8
XFILLER_17_117 VDD VSS / sg13g2_decap_8
XFILLER_17_12 VDD VSS / sg13g2_decap_8
XFILLER_17_124 VDD VSS / sg13g2_decap_8
XFILLER_17_131 VDD VSS / sg13g2_decap_8
XFILLER_17_138 VDD VSS / sg13g2_decap_8
XFILLER_17_145 VDD VSS / sg13g2_decap_8
XFILLER_17_152 VDD VSS / sg13g2_decap_8
XFILLER_17_159 VDD VSS / sg13g2_decap_8
XFILLER_17_166 VDD VSS / sg13g2_decap_8
XFILLER_17_173 VDD VSS / sg13g2_decap_8
XFILLER_17_180 VDD VSS / sg13g2_decap_8
XFILLER_17_187 VDD VSS / sg13g2_decap_8
XFILLER_17_19 VDD VSS / sg13g2_decap_8
XFILLER_17_194 VDD VSS / sg13g2_decap_8
XFILLER_17_2 VDD VSS / sg13g2_fill_1
XFILLER_17_201 VDD VSS / sg13g2_decap_8
XFILLER_17_208 VDD VSS / sg13g2_decap_8
XFILLER_17_215 VDD VSS / sg13g2_decap_8
XFILLER_17_222 VDD VSS / sg13g2_decap_8
XFILLER_17_229 VDD VSS / sg13g2_decap_8
XFILLER_17_236 VDD VSS / sg13g2_decap_8
XFILLER_17_243 VDD VSS / sg13g2_decap_8
XFILLER_17_250 VDD VSS / sg13g2_decap_8
XFILLER_17_257 VDD VSS / sg13g2_decap_8
XFILLER_17_26 VDD VSS / sg13g2_decap_8
XFILLER_17_264 VDD VSS / sg13g2_decap_8
XFILLER_17_271 VDD VSS / sg13g2_decap_8
XFILLER_17_278 VDD VSS / sg13g2_decap_8
XFILLER_17_285 VDD VSS / sg13g2_decap_8
XFILLER_17_292 VDD VSS / sg13g2_decap_8
XFILLER_17_299 VDD VSS / sg13g2_decap_8
XFILLER_17_306 VDD VSS / sg13g2_decap_8
XFILLER_17_313 VDD VSS / sg13g2_decap_8
XFILLER_17_320 VDD VSS / sg13g2_decap_8
XFILLER_17_327 VDD VSS / sg13g2_decap_8
XFILLER_17_33 VDD VSS / sg13g2_decap_8
XFILLER_17_334 VDD VSS / sg13g2_decap_8
XFILLER_17_341 VDD VSS / sg13g2_decap_8
XFILLER_17_348 VDD VSS / sg13g2_decap_8
XFILLER_17_355 VDD VSS / sg13g2_decap_8
XFILLER_17_362 VDD VSS / sg13g2_decap_8
XFILLER_17_369 VDD VSS / sg13g2_decap_8
XFILLER_17_376 VDD VSS / sg13g2_decap_8
XFILLER_17_383 VDD VSS / sg13g2_decap_8
XFILLER_17_390 VDD VSS / sg13g2_decap_8
XFILLER_17_397 VDD VSS / sg13g2_decap_8
XFILLER_17_40 VDD VSS / sg13g2_decap_8
XFILLER_17_404 VDD VSS / sg13g2_decap_8
XFILLER_17_411 VDD VSS / sg13g2_decap_8
XFILLER_17_418 VDD VSS / sg13g2_decap_8
XFILLER_17_425 VDD VSS / sg13g2_decap_8
XFILLER_17_432 VDD VSS / sg13g2_decap_8
XFILLER_17_439 VDD VSS / sg13g2_decap_8
XFILLER_17_446 VDD VSS / sg13g2_decap_8
XFILLER_17_453 VDD VSS / sg13g2_decap_8
XFILLER_17_460 VDD VSS / sg13g2_decap_8
XFILLER_17_467 VDD VSS / sg13g2_decap_8
XFILLER_17_47 VDD VSS / sg13g2_decap_8
XFILLER_17_474 VDD VSS / sg13g2_decap_8
XFILLER_17_481 VDD VSS / sg13g2_decap_8
XFILLER_17_488 VDD VSS / sg13g2_decap_8
XFILLER_17_495 VDD VSS / sg13g2_decap_8
XFILLER_17_502 VDD VSS / sg13g2_decap_8
XFILLER_17_509 VDD VSS / sg13g2_decap_8
XFILLER_17_516 VDD VSS / sg13g2_decap_8
XFILLER_17_523 VDD VSS / sg13g2_decap_8
XFILLER_17_530 VDD VSS / sg13g2_decap_8
XFILLER_17_537 VDD VSS / sg13g2_decap_8
XFILLER_17_54 VDD VSS / sg13g2_decap_8
XFILLER_17_544 VDD VSS / sg13g2_decap_8
XFILLER_17_551 VDD VSS / sg13g2_decap_8
XFILLER_17_558 VDD VSS / sg13g2_decap_8
XFILLER_17_565 VDD VSS / sg13g2_decap_8
XFILLER_17_572 VDD VSS / sg13g2_decap_8
XFILLER_17_579 VDD VSS / sg13g2_decap_8
XFILLER_17_586 VDD VSS / sg13g2_decap_8
XFILLER_17_593 VDD VSS / sg13g2_decap_8
XFILLER_17_600 VDD VSS / sg13g2_decap_8
XFILLER_17_607 VDD VSS / sg13g2_decap_8
XFILLER_17_61 VDD VSS / sg13g2_decap_8
XFILLER_17_614 VDD VSS / sg13g2_decap_8
XFILLER_17_621 VDD VSS / sg13g2_decap_8
XFILLER_17_628 VDD VSS / sg13g2_decap_8
XFILLER_17_635 VDD VSS / sg13g2_decap_8
XFILLER_17_642 VDD VSS / sg13g2_decap_8
XFILLER_17_649 VDD VSS / sg13g2_decap_8
XFILLER_17_656 VDD VSS / sg13g2_decap_8
XFILLER_17_663 VDD VSS / sg13g2_decap_8
XFILLER_17_670 VDD VSS / sg13g2_decap_8
XFILLER_17_677 VDD VSS / sg13g2_decap_8
XFILLER_17_68 VDD VSS / sg13g2_decap_8
XFILLER_17_684 VDD VSS / sg13g2_decap_8
XFILLER_17_691 VDD VSS / sg13g2_decap_8
XFILLER_17_698 VDD VSS / sg13g2_decap_8
XFILLER_17_705 VDD VSS / sg13g2_decap_8
XFILLER_17_712 VDD VSS / sg13g2_decap_8
XFILLER_17_719 VDD VSS / sg13g2_decap_8
XFILLER_17_726 VDD VSS / sg13g2_decap_8
XFILLER_17_733 VDD VSS / sg13g2_decap_8
XFILLER_17_740 VDD VSS / sg13g2_decap_4
XFILLER_17_744 VDD VSS / sg13g2_fill_1
XFILLER_17_75 VDD VSS / sg13g2_decap_8
XFILLER_17_82 VDD VSS / sg13g2_decap_8
XFILLER_17_89 VDD VSS / sg13g2_decap_8
XFILLER_17_96 VDD VSS / sg13g2_decap_8
XFILLER_18_0 VDD VSS / sg13g2_decap_8
XFILLER_18_105 VDD VSS / sg13g2_decap_8
XFILLER_18_112 VDD VSS / sg13g2_decap_8
XFILLER_18_119 VDD VSS / sg13g2_decap_8
XFILLER_18_126 VDD VSS / sg13g2_decap_8
XFILLER_18_133 VDD VSS / sg13g2_decap_8
XFILLER_18_14 VDD VSS / sg13g2_decap_8
XFILLER_18_140 VDD VSS / sg13g2_decap_8
XFILLER_18_147 VDD VSS / sg13g2_decap_8
XFILLER_18_154 VDD VSS / sg13g2_decap_8
XFILLER_18_161 VDD VSS / sg13g2_decap_8
XFILLER_18_168 VDD VSS / sg13g2_decap_8
XFILLER_18_175 VDD VSS / sg13g2_decap_8
XFILLER_18_182 VDD VSS / sg13g2_decap_8
XFILLER_18_189 VDD VSS / sg13g2_decap_8
XFILLER_18_196 VDD VSS / sg13g2_decap_8
XFILLER_18_203 VDD VSS / sg13g2_decap_8
XFILLER_18_21 VDD VSS / sg13g2_decap_8
XFILLER_18_210 VDD VSS / sg13g2_decap_8
XFILLER_18_217 VDD VSS / sg13g2_decap_8
XFILLER_18_224 VDD VSS / sg13g2_decap_8
XFILLER_18_231 VDD VSS / sg13g2_decap_8
XFILLER_18_238 VDD VSS / sg13g2_decap_8
XFILLER_18_245 VDD VSS / sg13g2_decap_8
XFILLER_18_252 VDD VSS / sg13g2_decap_8
XFILLER_18_259 VDD VSS / sg13g2_decap_8
XFILLER_18_266 VDD VSS / sg13g2_decap_8
XFILLER_18_273 VDD VSS / sg13g2_decap_8
XFILLER_18_28 VDD VSS / sg13g2_decap_8
XFILLER_18_280 VDD VSS / sg13g2_decap_8
XFILLER_18_287 VDD VSS / sg13g2_decap_8
XFILLER_18_294 VDD VSS / sg13g2_decap_8
XFILLER_18_301 VDD VSS / sg13g2_decap_8
XFILLER_18_308 VDD VSS / sg13g2_decap_8
XFILLER_18_315 VDD VSS / sg13g2_decap_8
XFILLER_18_322 VDD VSS / sg13g2_decap_8
XFILLER_18_329 VDD VSS / sg13g2_decap_8
XFILLER_18_336 VDD VSS / sg13g2_decap_8
XFILLER_18_343 VDD VSS / sg13g2_decap_8
XFILLER_18_35 VDD VSS / sg13g2_decap_8
XFILLER_18_350 VDD VSS / sg13g2_decap_8
XFILLER_18_357 VDD VSS / sg13g2_decap_8
XFILLER_18_364 VDD VSS / sg13g2_decap_8
XFILLER_18_371 VDD VSS / sg13g2_decap_8
XFILLER_18_378 VDD VSS / sg13g2_decap_8
XFILLER_18_385 VDD VSS / sg13g2_decap_8
XFILLER_18_392 VDD VSS / sg13g2_decap_8
XFILLER_18_399 VDD VSS / sg13g2_decap_8
XFILLER_18_406 VDD VSS / sg13g2_decap_8
XFILLER_18_413 VDD VSS / sg13g2_decap_8
XFILLER_18_42 VDD VSS / sg13g2_decap_8
XFILLER_18_420 VDD VSS / sg13g2_decap_8
XFILLER_18_427 VDD VSS / sg13g2_decap_8
XFILLER_18_434 VDD VSS / sg13g2_decap_8
XFILLER_18_441 VDD VSS / sg13g2_decap_8
XFILLER_18_448 VDD VSS / sg13g2_decap_8
XFILLER_18_455 VDD VSS / sg13g2_decap_8
XFILLER_18_462 VDD VSS / sg13g2_decap_8
XFILLER_18_469 VDD VSS / sg13g2_decap_8
XFILLER_18_476 VDD VSS / sg13g2_decap_8
XFILLER_18_483 VDD VSS / sg13g2_decap_8
XFILLER_18_49 VDD VSS / sg13g2_decap_8
XFILLER_18_490 VDD VSS / sg13g2_decap_8
XFILLER_18_497 VDD VSS / sg13g2_decap_8
XFILLER_18_504 VDD VSS / sg13g2_decap_8
XFILLER_18_511 VDD VSS / sg13g2_decap_8
XFILLER_18_518 VDD VSS / sg13g2_decap_8
XFILLER_18_525 VDD VSS / sg13g2_decap_8
XFILLER_18_532 VDD VSS / sg13g2_decap_8
XFILLER_18_539 VDD VSS / sg13g2_decap_8
XFILLER_18_546 VDD VSS / sg13g2_decap_8
XFILLER_18_553 VDD VSS / sg13g2_decap_8
XFILLER_18_56 VDD VSS / sg13g2_decap_8
XFILLER_18_560 VDD VSS / sg13g2_decap_8
XFILLER_18_567 VDD VSS / sg13g2_decap_8
XFILLER_18_574 VDD VSS / sg13g2_decap_8
XFILLER_18_581 VDD VSS / sg13g2_decap_8
XFILLER_18_588 VDD VSS / sg13g2_decap_8
XFILLER_18_595 VDD VSS / sg13g2_decap_8
XFILLER_18_602 VDD VSS / sg13g2_decap_8
XFILLER_18_609 VDD VSS / sg13g2_decap_8
XFILLER_18_616 VDD VSS / sg13g2_decap_8
XFILLER_18_623 VDD VSS / sg13g2_decap_8
XFILLER_18_63 VDD VSS / sg13g2_decap_8
XFILLER_18_630 VDD VSS / sg13g2_decap_8
XFILLER_18_637 VDD VSS / sg13g2_decap_8
XFILLER_18_644 VDD VSS / sg13g2_decap_8
XFILLER_18_651 VDD VSS / sg13g2_decap_8
XFILLER_18_658 VDD VSS / sg13g2_decap_8
XFILLER_18_665 VDD VSS / sg13g2_decap_8
XFILLER_18_672 VDD VSS / sg13g2_decap_8
XFILLER_18_679 VDD VSS / sg13g2_decap_8
XFILLER_18_686 VDD VSS / sg13g2_decap_8
XFILLER_18_693 VDD VSS / sg13g2_decap_8
XFILLER_18_7 VDD VSS / sg13g2_decap_8
XFILLER_18_70 VDD VSS / sg13g2_decap_8
XFILLER_18_700 VDD VSS / sg13g2_decap_8
XFILLER_18_707 VDD VSS / sg13g2_decap_8
XFILLER_18_714 VDD VSS / sg13g2_decap_8
XFILLER_18_721 VDD VSS / sg13g2_decap_8
XFILLER_18_728 VDD VSS / sg13g2_decap_8
XFILLER_18_735 VDD VSS / sg13g2_decap_8
XFILLER_18_742 VDD VSS / sg13g2_decap_8
XFILLER_18_749 VDD VSS / sg13g2_fill_2
XFILLER_18_751 VDD VSS / sg13g2_fill_1
XFILLER_18_77 VDD VSS / sg13g2_decap_8
XFILLER_18_84 VDD VSS / sg13g2_decap_8
XFILLER_18_91 VDD VSS / sg13g2_decap_8
XFILLER_18_98 VDD VSS / sg13g2_decap_8
XFILLER_19_105 VDD VSS / sg13g2_decap_8
XFILLER_19_112 VDD VSS / sg13g2_decap_8
XFILLER_19_119 VDD VSS / sg13g2_decap_8
XFILLER_19_126 VDD VSS / sg13g2_decap_8
XFILLER_19_133 VDD VSS / sg13g2_decap_8
XFILLER_19_140 VDD VSS / sg13g2_decap_8
XFILLER_19_147 VDD VSS / sg13g2_decap_8
XFILLER_19_154 VDD VSS / sg13g2_decap_8
XFILLER_19_161 VDD VSS / sg13g2_decap_8
XFILLER_19_168 VDD VSS / sg13g2_decap_8
XFILLER_19_175 VDD VSS / sg13g2_decap_8
XFILLER_19_182 VDD VSS / sg13g2_decap_8
XFILLER_19_189 VDD VSS / sg13g2_decap_8
XFILLER_19_196 VDD VSS / sg13g2_decap_8
XFILLER_19_203 VDD VSS / sg13g2_decap_8
XFILLER_19_210 VDD VSS / sg13g2_decap_8
XFILLER_19_217 VDD VSS / sg13g2_decap_8
XFILLER_19_224 VDD VSS / sg13g2_decap_8
XFILLER_19_231 VDD VSS / sg13g2_decap_8
XFILLER_19_238 VDD VSS / sg13g2_decap_8
XFILLER_19_245 VDD VSS / sg13g2_decap_8
XFILLER_19_252 VDD VSS / sg13g2_decap_8
XFILLER_19_259 VDD VSS / sg13g2_decap_8
XFILLER_19_266 VDD VSS / sg13g2_decap_8
XFILLER_19_273 VDD VSS / sg13g2_decap_8
XFILLER_19_280 VDD VSS / sg13g2_decap_8
XFILLER_19_287 VDD VSS / sg13g2_decap_8
XFILLER_19_294 VDD VSS / sg13g2_decap_8
XFILLER_19_301 VDD VSS / sg13g2_decap_8
XFILLER_19_308 VDD VSS / sg13g2_decap_8
XFILLER_19_315 VDD VSS / sg13g2_decap_8
XFILLER_19_322 VDD VSS / sg13g2_decap_8
XFILLER_19_329 VDD VSS / sg13g2_decap_8
XFILLER_19_336 VDD VSS / sg13g2_decap_8
XFILLER_19_343 VDD VSS / sg13g2_decap_8
XFILLER_19_350 VDD VSS / sg13g2_decap_8
XFILLER_19_357 VDD VSS / sg13g2_decap_8
XFILLER_19_364 VDD VSS / sg13g2_decap_8
XFILLER_19_371 VDD VSS / sg13g2_decap_8
XFILLER_19_378 VDD VSS / sg13g2_decap_8
XFILLER_19_385 VDD VSS / sg13g2_decap_8
XFILLER_19_392 VDD VSS / sg13g2_decap_8
XFILLER_19_399 VDD VSS / sg13g2_decap_8
XFILLER_19_406 VDD VSS / sg13g2_decap_8
XFILLER_19_413 VDD VSS / sg13g2_decap_8
XFILLER_19_420 VDD VSS / sg13g2_decap_8
XFILLER_19_427 VDD VSS / sg13g2_decap_8
XFILLER_19_434 VDD VSS / sg13g2_decap_8
XFILLER_19_441 VDD VSS / sg13g2_decap_8
XFILLER_19_448 VDD VSS / sg13g2_decap_8
XFILLER_19_455 VDD VSS / sg13g2_decap_8
XFILLER_19_462 VDD VSS / sg13g2_decap_8
XFILLER_19_469 VDD VSS / sg13g2_decap_8
XFILLER_19_476 VDD VSS / sg13g2_decap_8
XFILLER_19_483 VDD VSS / sg13g2_decap_8
XFILLER_19_490 VDD VSS / sg13g2_decap_8
XFILLER_19_497 VDD VSS / sg13g2_decap_8
XFILLER_19_504 VDD VSS / sg13g2_decap_8
XFILLER_19_511 VDD VSS / sg13g2_decap_8
XFILLER_19_518 VDD VSS / sg13g2_decap_8
XFILLER_19_525 VDD VSS / sg13g2_decap_8
XFILLER_19_532 VDD VSS / sg13g2_decap_8
XFILLER_19_539 VDD VSS / sg13g2_decap_8
XFILLER_19_546 VDD VSS / sg13g2_decap_8
XFILLER_19_553 VDD VSS / sg13g2_decap_8
XFILLER_19_560 VDD VSS / sg13g2_decap_8
XFILLER_19_567 VDD VSS / sg13g2_decap_8
XFILLER_19_574 VDD VSS / sg13g2_decap_8
XFILLER_19_581 VDD VSS / sg13g2_decap_8
XFILLER_19_588 VDD VSS / sg13g2_decap_8
XFILLER_19_595 VDD VSS / sg13g2_decap_8
XFILLER_19_602 VDD VSS / sg13g2_decap_8
XFILLER_19_609 VDD VSS / sg13g2_decap_8
XFILLER_19_616 VDD VSS / sg13g2_decap_8
XFILLER_19_623 VDD VSS / sg13g2_decap_8
XFILLER_19_630 VDD VSS / sg13g2_decap_8
XFILLER_19_637 VDD VSS / sg13g2_decap_8
XFILLER_19_644 VDD VSS / sg13g2_decap_8
XFILLER_19_651 VDD VSS / sg13g2_decap_8
XFILLER_19_658 VDD VSS / sg13g2_decap_8
XFILLER_19_665 VDD VSS / sg13g2_decap_8
XFILLER_19_672 VDD VSS / sg13g2_decap_8
XFILLER_19_679 VDD VSS / sg13g2_decap_8
XFILLER_19_686 VDD VSS / sg13g2_decap_8
XFILLER_19_693 VDD VSS / sg13g2_decap_8
XFILLER_19_700 VDD VSS / sg13g2_decap_8
XFILLER_19_707 VDD VSS / sg13g2_decap_8
XFILLER_19_714 VDD VSS / sg13g2_decap_8
XFILLER_19_721 VDD VSS / sg13g2_decap_8
XFILLER_19_728 VDD VSS / sg13g2_decap_8
XFILLER_19_735 VDD VSS / sg13g2_decap_8
XFILLER_19_742 VDD VSS / sg13g2_decap_8
XFILLER_19_749 VDD VSS / sg13g2_decap_4
XFILLER_19_753 VDD VSS / sg13g2_fill_2
XFILLER_19_98 VDD VSS / sg13g2_decap_8
XFILLER_1_1006 VDD VSS / sg13g2_decap_8
XFILLER_1_1013 VDD VSS / sg13g2_decap_8
XFILLER_1_1020 VDD VSS / sg13g2_decap_8
XFILLER_1_1027 VDD VSS / sg13g2_decap_8
XFILLER_1_103 VDD VSS / sg13g2_decap_8
XFILLER_1_1034 VDD VSS / sg13g2_decap_8
XFILLER_1_1041 VDD VSS / sg13g2_decap_8
XFILLER_1_1048 VDD VSS / sg13g2_decap_8
XFILLER_1_1055 VDD VSS / sg13g2_decap_8
XFILLER_1_1062 VDD VSS / sg13g2_decap_8
XFILLER_1_1069 VDD VSS / sg13g2_decap_8
XFILLER_1_1076 VDD VSS / sg13g2_decap_8
XFILLER_1_1083 VDD VSS / sg13g2_decap_8
XFILLER_1_1090 VDD VSS / sg13g2_decap_8
XFILLER_1_1097 VDD VSS / sg13g2_decap_8
XFILLER_1_110 VDD VSS / sg13g2_decap_8
XFILLER_1_1104 VDD VSS / sg13g2_decap_8
XFILLER_1_1111 VDD VSS / sg13g2_decap_8
XFILLER_1_1118 VDD VSS / sg13g2_decap_8
XFILLER_1_1125 VDD VSS / sg13g2_decap_8
XFILLER_1_1132 VDD VSS / sg13g2_decap_8
XFILLER_1_1139 VDD VSS / sg13g2_decap_8
XFILLER_1_1146 VDD VSS / sg13g2_decap_8
XFILLER_1_1153 VDD VSS / sg13g2_decap_8
XFILLER_1_1160 VDD VSS / sg13g2_decap_8
XFILLER_1_1167 VDD VSS / sg13g2_decap_8
XFILLER_1_117 VDD VSS / sg13g2_decap_8
XFILLER_1_1174 VDD VSS / sg13g2_decap_8
XFILLER_1_1181 VDD VSS / sg13g2_decap_8
XFILLER_1_1188 VDD VSS / sg13g2_decap_8
XFILLER_1_1195 VDD VSS / sg13g2_decap_8
XFILLER_1_1202 VDD VSS / sg13g2_decap_8
XFILLER_1_1209 VDD VSS / sg13g2_decap_8
XFILLER_1_1216 VDD VSS / sg13g2_decap_8
XFILLER_1_1223 VDD VSS / sg13g2_decap_8
XFILLER_1_1230 VDD VSS / sg13g2_decap_8
XFILLER_1_1237 VDD VSS / sg13g2_decap_8
XFILLER_1_124 VDD VSS / sg13g2_decap_8
XFILLER_1_1244 VDD VSS / sg13g2_decap_8
XFILLER_1_1251 VDD VSS / sg13g2_decap_8
XFILLER_1_1258 VDD VSS / sg13g2_decap_8
XFILLER_1_1265 VDD VSS / sg13g2_decap_8
XFILLER_1_1272 VDD VSS / sg13g2_decap_8
XFILLER_1_1279 VDD VSS / sg13g2_decap_8
XFILLER_1_1286 VDD VSS / sg13g2_decap_8
XFILLER_1_1293 VDD VSS / sg13g2_fill_2
XFILLER_1_131 VDD VSS / sg13g2_decap_8
XFILLER_1_138 VDD VSS / sg13g2_decap_8
XFILLER_1_145 VDD VSS / sg13g2_decap_8
XFILLER_1_152 VDD VSS / sg13g2_decap_8
XFILLER_1_159 VDD VSS / sg13g2_decap_8
XFILLER_1_166 VDD VSS / sg13g2_decap_8
XFILLER_1_173 VDD VSS / sg13g2_decap_8
XFILLER_1_180 VDD VSS / sg13g2_decap_8
XFILLER_1_187 VDD VSS / sg13g2_decap_8
XFILLER_1_194 VDD VSS / sg13g2_decap_8
XFILLER_1_201 VDD VSS / sg13g2_decap_8
XFILLER_1_208 VDD VSS / sg13g2_decap_8
XFILLER_1_215 VDD VSS / sg13g2_decap_8
XFILLER_1_222 VDD VSS / sg13g2_decap_8
XFILLER_1_229 VDD VSS / sg13g2_decap_8
XFILLER_1_236 VDD VSS / sg13g2_decap_8
XFILLER_1_243 VDD VSS / sg13g2_decap_8
XFILLER_1_250 VDD VSS / sg13g2_decap_8
XFILLER_1_257 VDD VSS / sg13g2_decap_8
XFILLER_1_264 VDD VSS / sg13g2_decap_8
XFILLER_1_271 VDD VSS / sg13g2_decap_8
XFILLER_1_278 VDD VSS / sg13g2_decap_8
XFILLER_1_285 VDD VSS / sg13g2_decap_8
XFILLER_1_292 VDD VSS / sg13g2_decap_8
XFILLER_1_299 VDD VSS / sg13g2_decap_8
XFILLER_1_306 VDD VSS / sg13g2_decap_8
XFILLER_1_313 VDD VSS / sg13g2_decap_8
XFILLER_1_320 VDD VSS / sg13g2_decap_8
XFILLER_1_327 VDD VSS / sg13g2_decap_8
XFILLER_1_334 VDD VSS / sg13g2_decap_8
XFILLER_1_341 VDD VSS / sg13g2_decap_8
XFILLER_1_348 VDD VSS / sg13g2_decap_8
XFILLER_1_355 VDD VSS / sg13g2_decap_8
XFILLER_1_362 VDD VSS / sg13g2_decap_8
XFILLER_1_369 VDD VSS / sg13g2_decap_8
XFILLER_1_376 VDD VSS / sg13g2_decap_8
XFILLER_1_383 VDD VSS / sg13g2_decap_8
XFILLER_1_390 VDD VSS / sg13g2_decap_8
XFILLER_1_397 VDD VSS / sg13g2_decap_8
XFILLER_1_404 VDD VSS / sg13g2_decap_8
XFILLER_1_411 VDD VSS / sg13g2_decap_8
XFILLER_1_418 VDD VSS / sg13g2_decap_8
XFILLER_1_425 VDD VSS / sg13g2_decap_8
XFILLER_1_432 VDD VSS / sg13g2_decap_8
XFILLER_1_439 VDD VSS / sg13g2_decap_8
XFILLER_1_446 VDD VSS / sg13g2_decap_8
XFILLER_1_453 VDD VSS / sg13g2_decap_8
XFILLER_1_460 VDD VSS / sg13g2_decap_8
XFILLER_1_467 VDD VSS / sg13g2_decap_8
XFILLER_1_474 VDD VSS / sg13g2_decap_8
XFILLER_1_481 VDD VSS / sg13g2_decap_8
XFILLER_1_488 VDD VSS / sg13g2_decap_8
XFILLER_1_495 VDD VSS / sg13g2_decap_8
XFILLER_1_502 VDD VSS / sg13g2_decap_8
XFILLER_1_509 VDD VSS / sg13g2_decap_8
XFILLER_1_516 VDD VSS / sg13g2_decap_8
XFILLER_1_523 VDD VSS / sg13g2_decap_8
XFILLER_1_530 VDD VSS / sg13g2_decap_8
XFILLER_1_537 VDD VSS / sg13g2_decap_8
XFILLER_1_544 VDD VSS / sg13g2_decap_8
XFILLER_1_551 VDD VSS / sg13g2_decap_8
XFILLER_1_558 VDD VSS / sg13g2_decap_8
XFILLER_1_565 VDD VSS / sg13g2_decap_8
XFILLER_1_572 VDD VSS / sg13g2_decap_8
XFILLER_1_579 VDD VSS / sg13g2_decap_8
XFILLER_1_586 VDD VSS / sg13g2_decap_8
XFILLER_1_593 VDD VSS / sg13g2_decap_8
XFILLER_1_600 VDD VSS / sg13g2_decap_8
XFILLER_1_607 VDD VSS / sg13g2_decap_8
XFILLER_1_614 VDD VSS / sg13g2_decap_8
XFILLER_1_621 VDD VSS / sg13g2_decap_8
XFILLER_1_628 VDD VSS / sg13g2_decap_8
XFILLER_1_635 VDD VSS / sg13g2_decap_8
XFILLER_1_642 VDD VSS / sg13g2_decap_8
XFILLER_1_649 VDD VSS / sg13g2_decap_8
XFILLER_1_656 VDD VSS / sg13g2_decap_8
XFILLER_1_663 VDD VSS / sg13g2_decap_8
XFILLER_1_670 VDD VSS / sg13g2_decap_8
XFILLER_1_677 VDD VSS / sg13g2_decap_8
XFILLER_1_684 VDD VSS / sg13g2_decap_8
XFILLER_1_691 VDD VSS / sg13g2_decap_8
XFILLER_1_698 VDD VSS / sg13g2_decap_8
XFILLER_1_705 VDD VSS / sg13g2_decap_8
XFILLER_1_712 VDD VSS / sg13g2_decap_8
XFILLER_1_719 VDD VSS / sg13g2_decap_8
XFILLER_1_726 VDD VSS / sg13g2_decap_8
XFILLER_1_733 VDD VSS / sg13g2_decap_8
XFILLER_1_740 VDD VSS / sg13g2_decap_8
XFILLER_1_747 VDD VSS / sg13g2_decap_8
XFILLER_1_754 VDD VSS / sg13g2_decap_8
XFILLER_1_761 VDD VSS / sg13g2_decap_8
XFILLER_1_768 VDD VSS / sg13g2_decap_8
XFILLER_1_775 VDD VSS / sg13g2_decap_8
XFILLER_1_782 VDD VSS / sg13g2_decap_8
XFILLER_1_789 VDD VSS / sg13g2_decap_8
XFILLER_1_796 VDD VSS / sg13g2_decap_8
XFILLER_1_803 VDD VSS / sg13g2_decap_8
XFILLER_1_810 VDD VSS / sg13g2_decap_8
XFILLER_1_817 VDD VSS / sg13g2_decap_8
XFILLER_1_824 VDD VSS / sg13g2_decap_8
XFILLER_1_831 VDD VSS / sg13g2_decap_8
XFILLER_1_838 VDD VSS / sg13g2_decap_8
XFILLER_1_845 VDD VSS / sg13g2_decap_8
XFILLER_1_852 VDD VSS / sg13g2_decap_8
XFILLER_1_859 VDD VSS / sg13g2_decap_8
XFILLER_1_866 VDD VSS / sg13g2_decap_8
XFILLER_1_873 VDD VSS / sg13g2_decap_8
XFILLER_1_880 VDD VSS / sg13g2_decap_8
XFILLER_1_887 VDD VSS / sg13g2_decap_8
XFILLER_1_89 VDD VSS / sg13g2_decap_8
XFILLER_1_894 VDD VSS / sg13g2_decap_8
XFILLER_1_901 VDD VSS / sg13g2_decap_8
XFILLER_1_908 VDD VSS / sg13g2_decap_8
XFILLER_1_915 VDD VSS / sg13g2_decap_8
XFILLER_1_922 VDD VSS / sg13g2_decap_8
XFILLER_1_929 VDD VSS / sg13g2_decap_8
XFILLER_1_936 VDD VSS / sg13g2_decap_8
XFILLER_1_943 VDD VSS / sg13g2_decap_8
XFILLER_1_950 VDD VSS / sg13g2_decap_8
XFILLER_1_957 VDD VSS / sg13g2_decap_8
XFILLER_1_96 VDD VSS / sg13g2_decap_8
XFILLER_1_964 VDD VSS / sg13g2_decap_8
XFILLER_1_971 VDD VSS / sg13g2_decap_8
XFILLER_1_978 VDD VSS / sg13g2_decap_8
XFILLER_1_985 VDD VSS / sg13g2_decap_8
XFILLER_1_992 VDD VSS / sg13g2_decap_8
XFILLER_1_999 VDD VSS / sg13g2_decap_8
XFILLER_20_105 VDD VSS / sg13g2_decap_8
XFILLER_20_112 VDD VSS / sg13g2_decap_8
XFILLER_20_119 VDD VSS / sg13g2_decap_8
XFILLER_20_126 VDD VSS / sg13g2_decap_8
XFILLER_20_133 VDD VSS / sg13g2_decap_8
XFILLER_20_140 VDD VSS / sg13g2_decap_8
XFILLER_20_147 VDD VSS / sg13g2_decap_8
XFILLER_20_154 VDD VSS / sg13g2_decap_8
XFILLER_20_161 VDD VSS / sg13g2_decap_8
XFILLER_20_168 VDD VSS / sg13g2_decap_8
XFILLER_20_175 VDD VSS / sg13g2_decap_8
XFILLER_20_182 VDD VSS / sg13g2_decap_8
XFILLER_20_189 VDD VSS / sg13g2_decap_8
XFILLER_20_196 VDD VSS / sg13g2_decap_8
XFILLER_20_203 VDD VSS / sg13g2_decap_8
XFILLER_20_210 VDD VSS / sg13g2_decap_8
XFILLER_20_217 VDD VSS / sg13g2_decap_8
XFILLER_20_224 VDD VSS / sg13g2_decap_8
XFILLER_20_231 VDD VSS / sg13g2_decap_8
XFILLER_20_238 VDD VSS / sg13g2_decap_8
XFILLER_20_245 VDD VSS / sg13g2_decap_8
XFILLER_20_252 VDD VSS / sg13g2_decap_8
XFILLER_20_259 VDD VSS / sg13g2_decap_8
XFILLER_20_266 VDD VSS / sg13g2_decap_8
XFILLER_20_273 VDD VSS / sg13g2_decap_8
XFILLER_20_280 VDD VSS / sg13g2_decap_8
XFILLER_20_287 VDD VSS / sg13g2_decap_8
XFILLER_20_294 VDD VSS / sg13g2_decap_8
XFILLER_20_301 VDD VSS / sg13g2_decap_8
XFILLER_20_308 VDD VSS / sg13g2_decap_8
XFILLER_20_315 VDD VSS / sg13g2_decap_8
XFILLER_20_322 VDD VSS / sg13g2_decap_8
XFILLER_20_329 VDD VSS / sg13g2_decap_8
XFILLER_20_336 VDD VSS / sg13g2_decap_8
XFILLER_20_343 VDD VSS / sg13g2_decap_8
XFILLER_20_350 VDD VSS / sg13g2_decap_8
XFILLER_20_357 VDD VSS / sg13g2_decap_8
XFILLER_20_364 VDD VSS / sg13g2_decap_8
XFILLER_20_371 VDD VSS / sg13g2_decap_8
XFILLER_20_378 VDD VSS / sg13g2_decap_8
XFILLER_20_385 VDD VSS / sg13g2_decap_8
XFILLER_20_392 VDD VSS / sg13g2_decap_8
XFILLER_20_399 VDD VSS / sg13g2_decap_8
XFILLER_20_406 VDD VSS / sg13g2_decap_8
XFILLER_20_413 VDD VSS / sg13g2_decap_8
XFILLER_20_420 VDD VSS / sg13g2_decap_8
XFILLER_20_427 VDD VSS / sg13g2_decap_8
XFILLER_20_434 VDD VSS / sg13g2_decap_8
XFILLER_20_441 VDD VSS / sg13g2_decap_8
XFILLER_20_448 VDD VSS / sg13g2_decap_8
XFILLER_20_455 VDD VSS / sg13g2_decap_8
XFILLER_20_462 VDD VSS / sg13g2_decap_8
XFILLER_20_469 VDD VSS / sg13g2_decap_8
XFILLER_20_476 VDD VSS / sg13g2_decap_8
XFILLER_20_483 VDD VSS / sg13g2_decap_8
XFILLER_20_490 VDD VSS / sg13g2_decap_8
XFILLER_20_497 VDD VSS / sg13g2_decap_8
XFILLER_20_504 VDD VSS / sg13g2_decap_8
XFILLER_20_511 VDD VSS / sg13g2_decap_8
XFILLER_20_518 VDD VSS / sg13g2_decap_8
XFILLER_20_525 VDD VSS / sg13g2_decap_8
XFILLER_20_532 VDD VSS / sg13g2_decap_8
XFILLER_20_539 VDD VSS / sg13g2_decap_8
XFILLER_20_546 VDD VSS / sg13g2_decap_8
XFILLER_20_553 VDD VSS / sg13g2_decap_8
XFILLER_20_560 VDD VSS / sg13g2_decap_8
XFILLER_20_567 VDD VSS / sg13g2_decap_8
XFILLER_20_574 VDD VSS / sg13g2_decap_8
XFILLER_20_581 VDD VSS / sg13g2_decap_8
XFILLER_20_588 VDD VSS / sg13g2_decap_8
XFILLER_20_595 VDD VSS / sg13g2_decap_8
XFILLER_20_602 VDD VSS / sg13g2_decap_8
XFILLER_20_609 VDD VSS / sg13g2_decap_8
XFILLER_20_616 VDD VSS / sg13g2_decap_8
XFILLER_20_623 VDD VSS / sg13g2_decap_8
XFILLER_20_630 VDD VSS / sg13g2_decap_8
XFILLER_20_637 VDD VSS / sg13g2_decap_8
XFILLER_20_644 VDD VSS / sg13g2_decap_8
XFILLER_20_651 VDD VSS / sg13g2_decap_8
XFILLER_20_658 VDD VSS / sg13g2_decap_8
XFILLER_20_665 VDD VSS / sg13g2_decap_8
XFILLER_20_672 VDD VSS / sg13g2_decap_8
XFILLER_20_679 VDD VSS / sg13g2_decap_8
XFILLER_20_686 VDD VSS / sg13g2_decap_8
XFILLER_20_693 VDD VSS / sg13g2_decap_8
XFILLER_20_700 VDD VSS / sg13g2_decap_8
XFILLER_20_707 VDD VSS / sg13g2_decap_8
XFILLER_20_714 VDD VSS / sg13g2_decap_8
XFILLER_20_721 VDD VSS / sg13g2_decap_8
XFILLER_20_728 VDD VSS / sg13g2_decap_8
XFILLER_20_735 VDD VSS / sg13g2_decap_8
XFILLER_20_742 VDD VSS / sg13g2_decap_8
XFILLER_20_749 VDD VSS / sg13g2_decap_4
XFILLER_20_753 VDD VSS / sg13g2_fill_2
XFILLER_20_98 VDD VSS / sg13g2_decap_8
XFILLER_21_105 VDD VSS / sg13g2_decap_8
XFILLER_21_112 VDD VSS / sg13g2_decap_8
XFILLER_21_119 VDD VSS / sg13g2_decap_8
XFILLER_21_126 VDD VSS / sg13g2_decap_8
XFILLER_21_133 VDD VSS / sg13g2_decap_8
XFILLER_21_140 VDD VSS / sg13g2_decap_8
XFILLER_21_147 VDD VSS / sg13g2_decap_8
XFILLER_21_154 VDD VSS / sg13g2_decap_8
XFILLER_21_161 VDD VSS / sg13g2_decap_8
XFILLER_21_168 VDD VSS / sg13g2_decap_8
XFILLER_21_175 VDD VSS / sg13g2_decap_8
XFILLER_21_182 VDD VSS / sg13g2_decap_8
XFILLER_21_189 VDD VSS / sg13g2_decap_8
XFILLER_21_196 VDD VSS / sg13g2_decap_8
XFILLER_21_203 VDD VSS / sg13g2_decap_8
XFILLER_21_210 VDD VSS / sg13g2_decap_8
XFILLER_21_217 VDD VSS / sg13g2_decap_8
XFILLER_21_224 VDD VSS / sg13g2_decap_8
XFILLER_21_231 VDD VSS / sg13g2_decap_8
XFILLER_21_238 VDD VSS / sg13g2_decap_8
XFILLER_21_245 VDD VSS / sg13g2_decap_8
XFILLER_21_252 VDD VSS / sg13g2_decap_8
XFILLER_21_259 VDD VSS / sg13g2_decap_8
XFILLER_21_266 VDD VSS / sg13g2_decap_8
XFILLER_21_273 VDD VSS / sg13g2_decap_8
XFILLER_21_280 VDD VSS / sg13g2_decap_8
XFILLER_21_287 VDD VSS / sg13g2_decap_8
XFILLER_21_294 VDD VSS / sg13g2_decap_8
XFILLER_21_301 VDD VSS / sg13g2_decap_8
XFILLER_21_308 VDD VSS / sg13g2_decap_8
XFILLER_21_315 VDD VSS / sg13g2_decap_8
XFILLER_21_322 VDD VSS / sg13g2_decap_8
XFILLER_21_329 VDD VSS / sg13g2_decap_8
XFILLER_21_336 VDD VSS / sg13g2_decap_8
XFILLER_21_343 VDD VSS / sg13g2_decap_8
XFILLER_21_350 VDD VSS / sg13g2_decap_8
XFILLER_21_357 VDD VSS / sg13g2_decap_8
XFILLER_21_364 VDD VSS / sg13g2_decap_8
XFILLER_21_371 VDD VSS / sg13g2_decap_8
XFILLER_21_378 VDD VSS / sg13g2_decap_8
XFILLER_21_385 VDD VSS / sg13g2_decap_8
XFILLER_21_392 VDD VSS / sg13g2_decap_8
XFILLER_21_399 VDD VSS / sg13g2_decap_8
XFILLER_21_406 VDD VSS / sg13g2_decap_8
XFILLER_21_413 VDD VSS / sg13g2_decap_8
XFILLER_21_420 VDD VSS / sg13g2_decap_8
XFILLER_21_427 VDD VSS / sg13g2_decap_8
XFILLER_21_434 VDD VSS / sg13g2_decap_8
XFILLER_21_441 VDD VSS / sg13g2_decap_8
XFILLER_21_448 VDD VSS / sg13g2_decap_8
XFILLER_21_455 VDD VSS / sg13g2_decap_8
XFILLER_21_462 VDD VSS / sg13g2_decap_8
XFILLER_21_469 VDD VSS / sg13g2_decap_8
XFILLER_21_476 VDD VSS / sg13g2_decap_8
XFILLER_21_483 VDD VSS / sg13g2_decap_8
XFILLER_21_490 VDD VSS / sg13g2_decap_8
XFILLER_21_497 VDD VSS / sg13g2_decap_8
XFILLER_21_504 VDD VSS / sg13g2_decap_8
XFILLER_21_511 VDD VSS / sg13g2_decap_8
XFILLER_21_518 VDD VSS / sg13g2_decap_8
XFILLER_21_525 VDD VSS / sg13g2_decap_8
XFILLER_21_532 VDD VSS / sg13g2_decap_8
XFILLER_21_539 VDD VSS / sg13g2_decap_8
XFILLER_21_546 VDD VSS / sg13g2_decap_8
XFILLER_21_553 VDD VSS / sg13g2_decap_8
XFILLER_21_560 VDD VSS / sg13g2_decap_8
XFILLER_21_567 VDD VSS / sg13g2_decap_8
XFILLER_21_574 VDD VSS / sg13g2_decap_8
XFILLER_21_581 VDD VSS / sg13g2_decap_8
XFILLER_21_588 VDD VSS / sg13g2_decap_8
XFILLER_21_595 VDD VSS / sg13g2_decap_8
XFILLER_21_602 VDD VSS / sg13g2_decap_8
XFILLER_21_609 VDD VSS / sg13g2_decap_8
XFILLER_21_616 VDD VSS / sg13g2_decap_8
XFILLER_21_623 VDD VSS / sg13g2_decap_8
XFILLER_21_630 VDD VSS / sg13g2_decap_8
XFILLER_21_637 VDD VSS / sg13g2_decap_8
XFILLER_21_644 VDD VSS / sg13g2_decap_8
XFILLER_21_651 VDD VSS / sg13g2_decap_8
XFILLER_21_658 VDD VSS / sg13g2_decap_8
XFILLER_21_665 VDD VSS / sg13g2_decap_8
XFILLER_21_672 VDD VSS / sg13g2_decap_8
XFILLER_21_679 VDD VSS / sg13g2_decap_8
XFILLER_21_686 VDD VSS / sg13g2_decap_8
XFILLER_21_693 VDD VSS / sg13g2_decap_8
XFILLER_21_700 VDD VSS / sg13g2_decap_8
XFILLER_21_707 VDD VSS / sg13g2_decap_8
XFILLER_21_714 VDD VSS / sg13g2_decap_8
XFILLER_21_721 VDD VSS / sg13g2_decap_8
XFILLER_21_728 VDD VSS / sg13g2_decap_8
XFILLER_21_735 VDD VSS / sg13g2_decap_8
XFILLER_21_742 VDD VSS / sg13g2_decap_8
XFILLER_21_749 VDD VSS / sg13g2_decap_4
XFILLER_21_753 VDD VSS / sg13g2_fill_2
XFILLER_21_98 VDD VSS / sg13g2_decap_8
XFILLER_22_105 VDD VSS / sg13g2_decap_8
XFILLER_22_112 VDD VSS / sg13g2_decap_8
XFILLER_22_119 VDD VSS / sg13g2_decap_8
XFILLER_22_126 VDD VSS / sg13g2_decap_8
XFILLER_22_133 VDD VSS / sg13g2_decap_8
XFILLER_22_140 VDD VSS / sg13g2_decap_8
XFILLER_22_147 VDD VSS / sg13g2_decap_8
XFILLER_22_154 VDD VSS / sg13g2_decap_8
XFILLER_22_161 VDD VSS / sg13g2_decap_8
XFILLER_22_168 VDD VSS / sg13g2_decap_8
XFILLER_22_175 VDD VSS / sg13g2_decap_8
XFILLER_22_182 VDD VSS / sg13g2_decap_8
XFILLER_22_189 VDD VSS / sg13g2_decap_8
XFILLER_22_196 VDD VSS / sg13g2_decap_8
XFILLER_22_203 VDD VSS / sg13g2_decap_8
XFILLER_22_210 VDD VSS / sg13g2_decap_8
XFILLER_22_217 VDD VSS / sg13g2_decap_8
XFILLER_22_224 VDD VSS / sg13g2_decap_8
XFILLER_22_231 VDD VSS / sg13g2_decap_8
XFILLER_22_238 VDD VSS / sg13g2_decap_8
XFILLER_22_245 VDD VSS / sg13g2_decap_8
XFILLER_22_252 VDD VSS / sg13g2_decap_8
XFILLER_22_259 VDD VSS / sg13g2_decap_8
XFILLER_22_266 VDD VSS / sg13g2_decap_8
XFILLER_22_273 VDD VSS / sg13g2_decap_8
XFILLER_22_280 VDD VSS / sg13g2_decap_8
XFILLER_22_287 VDD VSS / sg13g2_decap_8
XFILLER_22_294 VDD VSS / sg13g2_decap_8
XFILLER_22_301 VDD VSS / sg13g2_decap_8
XFILLER_22_308 VDD VSS / sg13g2_decap_8
XFILLER_22_315 VDD VSS / sg13g2_decap_8
XFILLER_22_322 VDD VSS / sg13g2_decap_8
XFILLER_22_329 VDD VSS / sg13g2_decap_8
XFILLER_22_336 VDD VSS / sg13g2_decap_8
XFILLER_22_343 VDD VSS / sg13g2_decap_8
XFILLER_22_350 VDD VSS / sg13g2_decap_8
XFILLER_22_357 VDD VSS / sg13g2_decap_8
XFILLER_22_364 VDD VSS / sg13g2_decap_8
XFILLER_22_371 VDD VSS / sg13g2_decap_8
XFILLER_22_378 VDD VSS / sg13g2_decap_8
XFILLER_22_385 VDD VSS / sg13g2_decap_8
XFILLER_22_392 VDD VSS / sg13g2_decap_8
XFILLER_22_399 VDD VSS / sg13g2_decap_8
XFILLER_22_406 VDD VSS / sg13g2_decap_8
XFILLER_22_413 VDD VSS / sg13g2_decap_8
XFILLER_22_420 VDD VSS / sg13g2_decap_8
XFILLER_22_427 VDD VSS / sg13g2_decap_8
XFILLER_22_434 VDD VSS / sg13g2_decap_8
XFILLER_22_441 VDD VSS / sg13g2_decap_8
XFILLER_22_448 VDD VSS / sg13g2_decap_8
XFILLER_22_455 VDD VSS / sg13g2_decap_8
XFILLER_22_462 VDD VSS / sg13g2_decap_8
XFILLER_22_469 VDD VSS / sg13g2_decap_8
XFILLER_22_476 VDD VSS / sg13g2_decap_8
XFILLER_22_483 VDD VSS / sg13g2_decap_8
XFILLER_22_490 VDD VSS / sg13g2_decap_8
XFILLER_22_497 VDD VSS / sg13g2_decap_8
XFILLER_22_504 VDD VSS / sg13g2_decap_8
XFILLER_22_511 VDD VSS / sg13g2_decap_8
XFILLER_22_518 VDD VSS / sg13g2_decap_8
XFILLER_22_525 VDD VSS / sg13g2_decap_8
XFILLER_22_532 VDD VSS / sg13g2_decap_8
XFILLER_22_539 VDD VSS / sg13g2_decap_8
XFILLER_22_546 VDD VSS / sg13g2_decap_8
XFILLER_22_553 VDD VSS / sg13g2_decap_8
XFILLER_22_560 VDD VSS / sg13g2_decap_8
XFILLER_22_567 VDD VSS / sg13g2_decap_8
XFILLER_22_574 VDD VSS / sg13g2_decap_8
XFILLER_22_581 VDD VSS / sg13g2_decap_8
XFILLER_22_588 VDD VSS / sg13g2_decap_8
XFILLER_22_595 VDD VSS / sg13g2_decap_8
XFILLER_22_602 VDD VSS / sg13g2_decap_8
XFILLER_22_609 VDD VSS / sg13g2_decap_8
XFILLER_22_616 VDD VSS / sg13g2_decap_8
XFILLER_22_623 VDD VSS / sg13g2_decap_8
XFILLER_22_630 VDD VSS / sg13g2_decap_8
XFILLER_22_637 VDD VSS / sg13g2_decap_8
XFILLER_22_644 VDD VSS / sg13g2_decap_8
XFILLER_22_651 VDD VSS / sg13g2_decap_8
XFILLER_22_658 VDD VSS / sg13g2_decap_8
XFILLER_22_665 VDD VSS / sg13g2_decap_8
XFILLER_22_672 VDD VSS / sg13g2_decap_8
XFILLER_22_679 VDD VSS / sg13g2_decap_8
XFILLER_22_686 VDD VSS / sg13g2_decap_8
XFILLER_22_693 VDD VSS / sg13g2_decap_8
XFILLER_22_700 VDD VSS / sg13g2_decap_8
XFILLER_22_707 VDD VSS / sg13g2_decap_8
XFILLER_22_714 VDD VSS / sg13g2_decap_8
XFILLER_22_721 VDD VSS / sg13g2_decap_8
XFILLER_22_728 VDD VSS / sg13g2_decap_8
XFILLER_22_735 VDD VSS / sg13g2_decap_8
XFILLER_22_742 VDD VSS / sg13g2_decap_8
XFILLER_22_749 VDD VSS / sg13g2_decap_4
XFILLER_22_753 VDD VSS / sg13g2_fill_2
XFILLER_22_98 VDD VSS / sg13g2_decap_8
XFILLER_23_105 VDD VSS / sg13g2_decap_8
XFILLER_23_112 VDD VSS / sg13g2_decap_8
XFILLER_23_119 VDD VSS / sg13g2_decap_8
XFILLER_23_126 VDD VSS / sg13g2_decap_8
XFILLER_23_133 VDD VSS / sg13g2_decap_8
XFILLER_23_140 VDD VSS / sg13g2_decap_8
XFILLER_23_147 VDD VSS / sg13g2_decap_8
XFILLER_23_154 VDD VSS / sg13g2_decap_8
XFILLER_23_161 VDD VSS / sg13g2_decap_8
XFILLER_23_168 VDD VSS / sg13g2_decap_8
XFILLER_23_175 VDD VSS / sg13g2_decap_8
XFILLER_23_182 VDD VSS / sg13g2_decap_8
XFILLER_23_189 VDD VSS / sg13g2_decap_8
XFILLER_23_196 VDD VSS / sg13g2_decap_8
XFILLER_23_203 VDD VSS / sg13g2_decap_8
XFILLER_23_210 VDD VSS / sg13g2_decap_8
XFILLER_23_217 VDD VSS / sg13g2_decap_8
XFILLER_23_224 VDD VSS / sg13g2_decap_8
XFILLER_23_231 VDD VSS / sg13g2_decap_8
XFILLER_23_238 VDD VSS / sg13g2_decap_8
XFILLER_23_245 VDD VSS / sg13g2_decap_8
XFILLER_23_252 VDD VSS / sg13g2_decap_8
XFILLER_23_259 VDD VSS / sg13g2_decap_8
XFILLER_23_266 VDD VSS / sg13g2_decap_8
XFILLER_23_273 VDD VSS / sg13g2_decap_8
XFILLER_23_280 VDD VSS / sg13g2_decap_8
XFILLER_23_287 VDD VSS / sg13g2_decap_8
XFILLER_23_294 VDD VSS / sg13g2_decap_8
XFILLER_23_301 VDD VSS / sg13g2_decap_8
XFILLER_23_308 VDD VSS / sg13g2_decap_8
XFILLER_23_315 VDD VSS / sg13g2_decap_8
XFILLER_23_322 VDD VSS / sg13g2_decap_8
XFILLER_23_329 VDD VSS / sg13g2_decap_8
XFILLER_23_336 VDD VSS / sg13g2_decap_8
XFILLER_23_343 VDD VSS / sg13g2_decap_8
XFILLER_23_350 VDD VSS / sg13g2_decap_8
XFILLER_23_357 VDD VSS / sg13g2_decap_8
XFILLER_23_364 VDD VSS / sg13g2_decap_8
XFILLER_23_371 VDD VSS / sg13g2_decap_8
XFILLER_23_378 VDD VSS / sg13g2_decap_8
XFILLER_23_385 VDD VSS / sg13g2_decap_8
XFILLER_23_392 VDD VSS / sg13g2_decap_8
XFILLER_23_399 VDD VSS / sg13g2_decap_8
XFILLER_23_406 VDD VSS / sg13g2_decap_8
XFILLER_23_413 VDD VSS / sg13g2_decap_8
XFILLER_23_420 VDD VSS / sg13g2_decap_8
XFILLER_23_427 VDD VSS / sg13g2_decap_8
XFILLER_23_434 VDD VSS / sg13g2_decap_8
XFILLER_23_441 VDD VSS / sg13g2_decap_8
XFILLER_23_448 VDD VSS / sg13g2_decap_8
XFILLER_23_455 VDD VSS / sg13g2_decap_8
XFILLER_23_462 VDD VSS / sg13g2_decap_8
XFILLER_23_469 VDD VSS / sg13g2_decap_8
XFILLER_23_476 VDD VSS / sg13g2_decap_8
XFILLER_23_483 VDD VSS / sg13g2_decap_8
XFILLER_23_490 VDD VSS / sg13g2_decap_8
XFILLER_23_497 VDD VSS / sg13g2_decap_8
XFILLER_23_504 VDD VSS / sg13g2_decap_8
XFILLER_23_511 VDD VSS / sg13g2_decap_8
XFILLER_23_518 VDD VSS / sg13g2_decap_8
XFILLER_23_525 VDD VSS / sg13g2_decap_8
XFILLER_23_532 VDD VSS / sg13g2_decap_8
XFILLER_23_539 VDD VSS / sg13g2_decap_8
XFILLER_23_546 VDD VSS / sg13g2_decap_8
XFILLER_23_553 VDD VSS / sg13g2_decap_8
XFILLER_23_560 VDD VSS / sg13g2_decap_8
XFILLER_23_567 VDD VSS / sg13g2_decap_8
XFILLER_23_574 VDD VSS / sg13g2_decap_8
XFILLER_23_581 VDD VSS / sg13g2_decap_8
XFILLER_23_588 VDD VSS / sg13g2_decap_8
XFILLER_23_595 VDD VSS / sg13g2_decap_8
XFILLER_23_602 VDD VSS / sg13g2_decap_8
XFILLER_23_609 VDD VSS / sg13g2_decap_8
XFILLER_23_616 VDD VSS / sg13g2_decap_8
XFILLER_23_623 VDD VSS / sg13g2_decap_8
XFILLER_23_630 VDD VSS / sg13g2_decap_8
XFILLER_23_637 VDD VSS / sg13g2_decap_8
XFILLER_23_644 VDD VSS / sg13g2_decap_8
XFILLER_23_651 VDD VSS / sg13g2_decap_8
XFILLER_23_658 VDD VSS / sg13g2_decap_8
XFILLER_23_665 VDD VSS / sg13g2_decap_8
XFILLER_23_672 VDD VSS / sg13g2_decap_8
XFILLER_23_679 VDD VSS / sg13g2_decap_8
XFILLER_23_686 VDD VSS / sg13g2_decap_8
XFILLER_23_693 VDD VSS / sg13g2_decap_8
XFILLER_23_700 VDD VSS / sg13g2_decap_8
XFILLER_23_707 VDD VSS / sg13g2_decap_8
XFILLER_23_714 VDD VSS / sg13g2_decap_8
XFILLER_23_721 VDD VSS / sg13g2_decap_8
XFILLER_23_728 VDD VSS / sg13g2_decap_8
XFILLER_23_735 VDD VSS / sg13g2_decap_8
XFILLER_23_742 VDD VSS / sg13g2_decap_8
XFILLER_23_749 VDD VSS / sg13g2_decap_4
XFILLER_23_753 VDD VSS / sg13g2_fill_2
XFILLER_23_98 VDD VSS / sg13g2_decap_8
XFILLER_24_105 VDD VSS / sg13g2_decap_8
XFILLER_24_112 VDD VSS / sg13g2_decap_8
XFILLER_24_119 VDD VSS / sg13g2_decap_8
XFILLER_24_126 VDD VSS / sg13g2_decap_8
XFILLER_24_133 VDD VSS / sg13g2_decap_8
XFILLER_24_140 VDD VSS / sg13g2_decap_8
XFILLER_24_147 VDD VSS / sg13g2_decap_8
XFILLER_24_154 VDD VSS / sg13g2_decap_8
XFILLER_24_161 VDD VSS / sg13g2_decap_8
XFILLER_24_168 VDD VSS / sg13g2_decap_8
XFILLER_24_175 VDD VSS / sg13g2_decap_8
XFILLER_24_182 VDD VSS / sg13g2_decap_8
XFILLER_24_189 VDD VSS / sg13g2_decap_8
XFILLER_24_196 VDD VSS / sg13g2_decap_8
XFILLER_24_203 VDD VSS / sg13g2_decap_8
XFILLER_24_210 VDD VSS / sg13g2_decap_8
XFILLER_24_217 VDD VSS / sg13g2_decap_8
XFILLER_24_224 VDD VSS / sg13g2_decap_8
XFILLER_24_231 VDD VSS / sg13g2_decap_8
XFILLER_24_238 VDD VSS / sg13g2_decap_8
XFILLER_24_245 VDD VSS / sg13g2_decap_8
XFILLER_24_252 VDD VSS / sg13g2_decap_8
XFILLER_24_259 VDD VSS / sg13g2_decap_8
XFILLER_24_266 VDD VSS / sg13g2_decap_8
XFILLER_24_273 VDD VSS / sg13g2_decap_8
XFILLER_24_280 VDD VSS / sg13g2_decap_8
XFILLER_24_287 VDD VSS / sg13g2_decap_8
XFILLER_24_294 VDD VSS / sg13g2_decap_8
XFILLER_24_301 VDD VSS / sg13g2_decap_8
XFILLER_24_308 VDD VSS / sg13g2_decap_8
XFILLER_24_315 VDD VSS / sg13g2_decap_8
XFILLER_24_322 VDD VSS / sg13g2_decap_8
XFILLER_24_329 VDD VSS / sg13g2_decap_8
XFILLER_24_336 VDD VSS / sg13g2_decap_8
XFILLER_24_343 VDD VSS / sg13g2_decap_8
XFILLER_24_350 VDD VSS / sg13g2_decap_8
XFILLER_24_357 VDD VSS / sg13g2_decap_8
XFILLER_24_364 VDD VSS / sg13g2_decap_8
XFILLER_24_371 VDD VSS / sg13g2_decap_8
XFILLER_24_378 VDD VSS / sg13g2_decap_8
XFILLER_24_385 VDD VSS / sg13g2_decap_8
XFILLER_24_392 VDD VSS / sg13g2_decap_8
XFILLER_24_399 VDD VSS / sg13g2_decap_8
XFILLER_24_406 VDD VSS / sg13g2_decap_8
XFILLER_24_413 VDD VSS / sg13g2_decap_8
XFILLER_24_420 VDD VSS / sg13g2_decap_8
XFILLER_24_427 VDD VSS / sg13g2_decap_8
XFILLER_24_434 VDD VSS / sg13g2_decap_8
XFILLER_24_441 VDD VSS / sg13g2_decap_8
XFILLER_24_448 VDD VSS / sg13g2_decap_8
XFILLER_24_455 VDD VSS / sg13g2_decap_8
XFILLER_24_462 VDD VSS / sg13g2_decap_8
XFILLER_24_469 VDD VSS / sg13g2_decap_8
XFILLER_24_476 VDD VSS / sg13g2_decap_8
XFILLER_24_483 VDD VSS / sg13g2_decap_8
XFILLER_24_490 VDD VSS / sg13g2_decap_8
XFILLER_24_497 VDD VSS / sg13g2_decap_8
XFILLER_24_504 VDD VSS / sg13g2_decap_8
XFILLER_24_511 VDD VSS / sg13g2_decap_8
XFILLER_24_518 VDD VSS / sg13g2_decap_8
XFILLER_24_525 VDD VSS / sg13g2_decap_8
XFILLER_24_532 VDD VSS / sg13g2_decap_8
XFILLER_24_539 VDD VSS / sg13g2_decap_8
XFILLER_24_546 VDD VSS / sg13g2_decap_8
XFILLER_24_553 VDD VSS / sg13g2_decap_8
XFILLER_24_560 VDD VSS / sg13g2_decap_8
XFILLER_24_567 VDD VSS / sg13g2_decap_8
XFILLER_24_574 VDD VSS / sg13g2_decap_8
XFILLER_24_581 VDD VSS / sg13g2_decap_8
XFILLER_24_588 VDD VSS / sg13g2_decap_8
XFILLER_24_595 VDD VSS / sg13g2_decap_8
XFILLER_24_602 VDD VSS / sg13g2_decap_8
XFILLER_24_609 VDD VSS / sg13g2_decap_8
XFILLER_24_616 VDD VSS / sg13g2_decap_8
XFILLER_24_623 VDD VSS / sg13g2_decap_8
XFILLER_24_630 VDD VSS / sg13g2_decap_8
XFILLER_24_637 VDD VSS / sg13g2_decap_8
XFILLER_24_644 VDD VSS / sg13g2_decap_8
XFILLER_24_651 VDD VSS / sg13g2_decap_8
XFILLER_24_658 VDD VSS / sg13g2_decap_8
XFILLER_24_665 VDD VSS / sg13g2_decap_8
XFILLER_24_672 VDD VSS / sg13g2_decap_8
XFILLER_24_679 VDD VSS / sg13g2_decap_8
XFILLER_24_686 VDD VSS / sg13g2_decap_8
XFILLER_24_693 VDD VSS / sg13g2_decap_8
XFILLER_24_700 VDD VSS / sg13g2_decap_8
XFILLER_24_707 VDD VSS / sg13g2_decap_8
XFILLER_24_714 VDD VSS / sg13g2_decap_8
XFILLER_24_721 VDD VSS / sg13g2_decap_8
XFILLER_24_728 VDD VSS / sg13g2_decap_8
XFILLER_24_735 VDD VSS / sg13g2_decap_8
XFILLER_24_742 VDD VSS / sg13g2_decap_8
XFILLER_24_749 VDD VSS / sg13g2_decap_4
XFILLER_24_753 VDD VSS / sg13g2_fill_2
XFILLER_24_98 VDD VSS / sg13g2_decap_8
XFILLER_25_105 VDD VSS / sg13g2_decap_8
XFILLER_25_112 VDD VSS / sg13g2_decap_8
XFILLER_25_119 VDD VSS / sg13g2_decap_8
XFILLER_25_126 VDD VSS / sg13g2_decap_8
XFILLER_25_133 VDD VSS / sg13g2_decap_8
XFILLER_25_140 VDD VSS / sg13g2_decap_8
XFILLER_25_147 VDD VSS / sg13g2_decap_8
XFILLER_25_154 VDD VSS / sg13g2_decap_8
XFILLER_25_161 VDD VSS / sg13g2_decap_8
XFILLER_25_168 VDD VSS / sg13g2_decap_8
XFILLER_25_175 VDD VSS / sg13g2_decap_8
XFILLER_25_182 VDD VSS / sg13g2_decap_8
XFILLER_25_189 VDD VSS / sg13g2_decap_8
XFILLER_25_196 VDD VSS / sg13g2_decap_8
XFILLER_25_203 VDD VSS / sg13g2_decap_8
XFILLER_25_210 VDD VSS / sg13g2_decap_8
XFILLER_25_217 VDD VSS / sg13g2_decap_8
XFILLER_25_224 VDD VSS / sg13g2_decap_8
XFILLER_25_231 VDD VSS / sg13g2_decap_8
XFILLER_25_238 VDD VSS / sg13g2_decap_8
XFILLER_25_245 VDD VSS / sg13g2_decap_8
XFILLER_25_252 VDD VSS / sg13g2_decap_8
XFILLER_25_259 VDD VSS / sg13g2_decap_8
XFILLER_25_266 VDD VSS / sg13g2_decap_8
XFILLER_25_273 VDD VSS / sg13g2_decap_8
XFILLER_25_280 VDD VSS / sg13g2_decap_8
XFILLER_25_287 VDD VSS / sg13g2_decap_8
XFILLER_25_294 VDD VSS / sg13g2_decap_8
XFILLER_25_301 VDD VSS / sg13g2_decap_8
XFILLER_25_308 VDD VSS / sg13g2_decap_8
XFILLER_25_315 VDD VSS / sg13g2_decap_8
XFILLER_25_322 VDD VSS / sg13g2_decap_8
XFILLER_25_329 VDD VSS / sg13g2_decap_8
XFILLER_25_336 VDD VSS / sg13g2_decap_8
XFILLER_25_343 VDD VSS / sg13g2_decap_8
XFILLER_25_350 VDD VSS / sg13g2_decap_8
XFILLER_25_357 VDD VSS / sg13g2_decap_8
XFILLER_25_364 VDD VSS / sg13g2_decap_8
XFILLER_25_371 VDD VSS / sg13g2_decap_8
XFILLER_25_378 VDD VSS / sg13g2_decap_8
XFILLER_25_385 VDD VSS / sg13g2_decap_8
XFILLER_25_392 VDD VSS / sg13g2_decap_8
XFILLER_25_399 VDD VSS / sg13g2_decap_8
XFILLER_25_406 VDD VSS / sg13g2_decap_8
XFILLER_25_413 VDD VSS / sg13g2_decap_8
XFILLER_25_420 VDD VSS / sg13g2_decap_8
XFILLER_25_427 VDD VSS / sg13g2_decap_8
XFILLER_25_434 VDD VSS / sg13g2_decap_8
XFILLER_25_441 VDD VSS / sg13g2_decap_8
XFILLER_25_448 VDD VSS / sg13g2_decap_8
XFILLER_25_455 VDD VSS / sg13g2_decap_8
XFILLER_25_462 VDD VSS / sg13g2_decap_8
XFILLER_25_469 VDD VSS / sg13g2_decap_8
XFILLER_25_476 VDD VSS / sg13g2_decap_8
XFILLER_25_483 VDD VSS / sg13g2_decap_8
XFILLER_25_490 VDD VSS / sg13g2_decap_8
XFILLER_25_497 VDD VSS / sg13g2_decap_8
XFILLER_25_504 VDD VSS / sg13g2_decap_8
XFILLER_25_511 VDD VSS / sg13g2_decap_8
XFILLER_25_518 VDD VSS / sg13g2_decap_8
XFILLER_25_525 VDD VSS / sg13g2_decap_8
XFILLER_25_532 VDD VSS / sg13g2_decap_8
XFILLER_25_539 VDD VSS / sg13g2_decap_8
XFILLER_25_546 VDD VSS / sg13g2_decap_8
XFILLER_25_553 VDD VSS / sg13g2_decap_8
XFILLER_25_560 VDD VSS / sg13g2_decap_8
XFILLER_25_567 VDD VSS / sg13g2_decap_8
XFILLER_25_574 VDD VSS / sg13g2_decap_8
XFILLER_25_581 VDD VSS / sg13g2_decap_8
XFILLER_25_588 VDD VSS / sg13g2_decap_8
XFILLER_25_595 VDD VSS / sg13g2_decap_8
XFILLER_25_602 VDD VSS / sg13g2_decap_8
XFILLER_25_609 VDD VSS / sg13g2_decap_8
XFILLER_25_616 VDD VSS / sg13g2_decap_8
XFILLER_25_623 VDD VSS / sg13g2_decap_8
XFILLER_25_630 VDD VSS / sg13g2_decap_8
XFILLER_25_637 VDD VSS / sg13g2_decap_8
XFILLER_25_644 VDD VSS / sg13g2_decap_8
XFILLER_25_651 VDD VSS / sg13g2_decap_8
XFILLER_25_658 VDD VSS / sg13g2_decap_8
XFILLER_25_665 VDD VSS / sg13g2_decap_8
XFILLER_25_672 VDD VSS / sg13g2_decap_8
XFILLER_25_679 VDD VSS / sg13g2_decap_8
XFILLER_25_686 VDD VSS / sg13g2_decap_8
XFILLER_25_693 VDD VSS / sg13g2_decap_8
XFILLER_25_700 VDD VSS / sg13g2_decap_8
XFILLER_25_707 VDD VSS / sg13g2_decap_8
XFILLER_25_714 VDD VSS / sg13g2_decap_8
XFILLER_25_721 VDD VSS / sg13g2_decap_8
XFILLER_25_728 VDD VSS / sg13g2_decap_8
XFILLER_25_735 VDD VSS / sg13g2_decap_8
XFILLER_25_742 VDD VSS / sg13g2_decap_8
XFILLER_25_749 VDD VSS / sg13g2_decap_4
XFILLER_25_753 VDD VSS / sg13g2_fill_2
XFILLER_25_98 VDD VSS / sg13g2_decap_8
XFILLER_26_105 VDD VSS / sg13g2_decap_8
XFILLER_26_112 VDD VSS / sg13g2_decap_8
XFILLER_26_119 VDD VSS / sg13g2_decap_8
XFILLER_26_126 VDD VSS / sg13g2_decap_8
XFILLER_26_133 VDD VSS / sg13g2_decap_8
XFILLER_26_140 VDD VSS / sg13g2_decap_8
XFILLER_26_147 VDD VSS / sg13g2_decap_8
XFILLER_26_154 VDD VSS / sg13g2_decap_8
XFILLER_26_161 VDD VSS / sg13g2_decap_8
XFILLER_26_168 VDD VSS / sg13g2_decap_8
XFILLER_26_175 VDD VSS / sg13g2_decap_8
XFILLER_26_182 VDD VSS / sg13g2_decap_8
XFILLER_26_189 VDD VSS / sg13g2_decap_8
XFILLER_26_196 VDD VSS / sg13g2_decap_8
XFILLER_26_203 VDD VSS / sg13g2_decap_8
XFILLER_26_210 VDD VSS / sg13g2_decap_8
XFILLER_26_217 VDD VSS / sg13g2_decap_8
XFILLER_26_224 VDD VSS / sg13g2_decap_8
XFILLER_26_231 VDD VSS / sg13g2_decap_8
XFILLER_26_238 VDD VSS / sg13g2_decap_8
XFILLER_26_245 VDD VSS / sg13g2_decap_8
XFILLER_26_252 VDD VSS / sg13g2_decap_8
XFILLER_26_259 VDD VSS / sg13g2_decap_8
XFILLER_26_266 VDD VSS / sg13g2_decap_8
XFILLER_26_273 VDD VSS / sg13g2_decap_8
XFILLER_26_280 VDD VSS / sg13g2_decap_8
XFILLER_26_287 VDD VSS / sg13g2_decap_8
XFILLER_26_294 VDD VSS / sg13g2_decap_8
XFILLER_26_301 VDD VSS / sg13g2_decap_8
XFILLER_26_308 VDD VSS / sg13g2_decap_8
XFILLER_26_315 VDD VSS / sg13g2_decap_8
XFILLER_26_322 VDD VSS / sg13g2_decap_8
XFILLER_26_329 VDD VSS / sg13g2_decap_8
XFILLER_26_336 VDD VSS / sg13g2_decap_8
XFILLER_26_343 VDD VSS / sg13g2_decap_8
XFILLER_26_350 VDD VSS / sg13g2_decap_8
XFILLER_26_357 VDD VSS / sg13g2_decap_8
XFILLER_26_364 VDD VSS / sg13g2_decap_8
XFILLER_26_371 VDD VSS / sg13g2_decap_8
XFILLER_26_378 VDD VSS / sg13g2_decap_8
XFILLER_26_385 VDD VSS / sg13g2_decap_8
XFILLER_26_392 VDD VSS / sg13g2_decap_8
XFILLER_26_399 VDD VSS / sg13g2_decap_8
XFILLER_26_406 VDD VSS / sg13g2_decap_8
XFILLER_26_413 VDD VSS / sg13g2_decap_8
XFILLER_26_420 VDD VSS / sg13g2_decap_8
XFILLER_26_427 VDD VSS / sg13g2_decap_8
XFILLER_26_434 VDD VSS / sg13g2_decap_8
XFILLER_26_441 VDD VSS / sg13g2_decap_8
XFILLER_26_448 VDD VSS / sg13g2_decap_8
XFILLER_26_455 VDD VSS / sg13g2_decap_8
XFILLER_26_462 VDD VSS / sg13g2_decap_8
XFILLER_26_469 VDD VSS / sg13g2_decap_8
XFILLER_26_476 VDD VSS / sg13g2_decap_8
XFILLER_26_483 VDD VSS / sg13g2_decap_8
XFILLER_26_490 VDD VSS / sg13g2_decap_8
XFILLER_26_497 VDD VSS / sg13g2_decap_8
XFILLER_26_504 VDD VSS / sg13g2_decap_8
XFILLER_26_511 VDD VSS / sg13g2_decap_8
XFILLER_26_518 VDD VSS / sg13g2_decap_8
XFILLER_26_525 VDD VSS / sg13g2_decap_8
XFILLER_26_532 VDD VSS / sg13g2_decap_8
XFILLER_26_539 VDD VSS / sg13g2_decap_8
XFILLER_26_546 VDD VSS / sg13g2_decap_8
XFILLER_26_553 VDD VSS / sg13g2_decap_8
XFILLER_26_560 VDD VSS / sg13g2_decap_8
XFILLER_26_567 VDD VSS / sg13g2_decap_8
XFILLER_26_574 VDD VSS / sg13g2_decap_8
XFILLER_26_581 VDD VSS / sg13g2_decap_8
XFILLER_26_588 VDD VSS / sg13g2_decap_8
XFILLER_26_595 VDD VSS / sg13g2_decap_8
XFILLER_26_602 VDD VSS / sg13g2_decap_8
XFILLER_26_609 VDD VSS / sg13g2_decap_8
XFILLER_26_616 VDD VSS / sg13g2_decap_8
XFILLER_26_623 VDD VSS / sg13g2_decap_8
XFILLER_26_630 VDD VSS / sg13g2_decap_8
XFILLER_26_637 VDD VSS / sg13g2_decap_8
XFILLER_26_644 VDD VSS / sg13g2_decap_8
XFILLER_26_651 VDD VSS / sg13g2_decap_8
XFILLER_26_658 VDD VSS / sg13g2_decap_8
XFILLER_26_665 VDD VSS / sg13g2_decap_8
XFILLER_26_672 VDD VSS / sg13g2_decap_8
XFILLER_26_679 VDD VSS / sg13g2_decap_8
XFILLER_26_686 VDD VSS / sg13g2_decap_8
XFILLER_26_693 VDD VSS / sg13g2_decap_8
XFILLER_26_700 VDD VSS / sg13g2_decap_8
XFILLER_26_707 VDD VSS / sg13g2_decap_8
XFILLER_26_714 VDD VSS / sg13g2_decap_8
XFILLER_26_721 VDD VSS / sg13g2_decap_8
XFILLER_26_728 VDD VSS / sg13g2_decap_8
XFILLER_26_735 VDD VSS / sg13g2_decap_8
XFILLER_26_742 VDD VSS / sg13g2_decap_8
XFILLER_26_749 VDD VSS / sg13g2_decap_4
XFILLER_26_753 VDD VSS / sg13g2_fill_2
XFILLER_26_98 VDD VSS / sg13g2_decap_8
XFILLER_27_105 VDD VSS / sg13g2_decap_8
XFILLER_27_112 VDD VSS / sg13g2_decap_8
XFILLER_27_119 VDD VSS / sg13g2_decap_8
XFILLER_27_126 VDD VSS / sg13g2_decap_8
XFILLER_27_133 VDD VSS / sg13g2_decap_8
XFILLER_27_140 VDD VSS / sg13g2_decap_8
XFILLER_27_147 VDD VSS / sg13g2_decap_8
XFILLER_27_154 VDD VSS / sg13g2_decap_8
XFILLER_27_161 VDD VSS / sg13g2_decap_8
XFILLER_27_168 VDD VSS / sg13g2_decap_8
XFILLER_27_175 VDD VSS / sg13g2_decap_8
XFILLER_27_182 VDD VSS / sg13g2_decap_8
XFILLER_27_189 VDD VSS / sg13g2_decap_8
XFILLER_27_196 VDD VSS / sg13g2_decap_8
XFILLER_27_203 VDD VSS / sg13g2_decap_8
XFILLER_27_210 VDD VSS / sg13g2_decap_8
XFILLER_27_217 VDD VSS / sg13g2_decap_8
XFILLER_27_224 VDD VSS / sg13g2_decap_8
XFILLER_27_231 VDD VSS / sg13g2_decap_8
XFILLER_27_238 VDD VSS / sg13g2_decap_8
XFILLER_27_245 VDD VSS / sg13g2_decap_8
XFILLER_27_252 VDD VSS / sg13g2_decap_8
XFILLER_27_259 VDD VSS / sg13g2_decap_8
XFILLER_27_266 VDD VSS / sg13g2_decap_8
XFILLER_27_273 VDD VSS / sg13g2_decap_8
XFILLER_27_280 VDD VSS / sg13g2_decap_8
XFILLER_27_287 VDD VSS / sg13g2_decap_8
XFILLER_27_294 VDD VSS / sg13g2_decap_8
XFILLER_27_301 VDD VSS / sg13g2_decap_8
XFILLER_27_308 VDD VSS / sg13g2_decap_8
XFILLER_27_315 VDD VSS / sg13g2_decap_8
XFILLER_27_322 VDD VSS / sg13g2_decap_8
XFILLER_27_329 VDD VSS / sg13g2_decap_8
XFILLER_27_336 VDD VSS / sg13g2_decap_8
XFILLER_27_343 VDD VSS / sg13g2_decap_8
XFILLER_27_350 VDD VSS / sg13g2_decap_8
XFILLER_27_357 VDD VSS / sg13g2_decap_8
XFILLER_27_364 VDD VSS / sg13g2_decap_8
XFILLER_27_371 VDD VSS / sg13g2_decap_8
XFILLER_27_378 VDD VSS / sg13g2_decap_8
XFILLER_27_385 VDD VSS / sg13g2_decap_8
XFILLER_27_392 VDD VSS / sg13g2_decap_8
XFILLER_27_399 VDD VSS / sg13g2_decap_8
XFILLER_27_406 VDD VSS / sg13g2_decap_8
XFILLER_27_413 VDD VSS / sg13g2_decap_8
XFILLER_27_420 VDD VSS / sg13g2_decap_8
XFILLER_27_427 VDD VSS / sg13g2_decap_8
XFILLER_27_434 VDD VSS / sg13g2_decap_8
XFILLER_27_441 VDD VSS / sg13g2_decap_8
XFILLER_27_448 VDD VSS / sg13g2_decap_8
XFILLER_27_455 VDD VSS / sg13g2_decap_8
XFILLER_27_462 VDD VSS / sg13g2_decap_8
XFILLER_27_469 VDD VSS / sg13g2_decap_8
XFILLER_27_476 VDD VSS / sg13g2_decap_8
XFILLER_27_483 VDD VSS / sg13g2_decap_8
XFILLER_27_490 VDD VSS / sg13g2_decap_8
XFILLER_27_497 VDD VSS / sg13g2_decap_8
XFILLER_27_504 VDD VSS / sg13g2_decap_8
XFILLER_27_511 VDD VSS / sg13g2_decap_8
XFILLER_27_518 VDD VSS / sg13g2_decap_8
XFILLER_27_525 VDD VSS / sg13g2_decap_8
XFILLER_27_532 VDD VSS / sg13g2_decap_8
XFILLER_27_539 VDD VSS / sg13g2_decap_8
XFILLER_27_546 VDD VSS / sg13g2_decap_8
XFILLER_27_553 VDD VSS / sg13g2_decap_8
XFILLER_27_560 VDD VSS / sg13g2_decap_8
XFILLER_27_567 VDD VSS / sg13g2_decap_8
XFILLER_27_574 VDD VSS / sg13g2_decap_8
XFILLER_27_581 VDD VSS / sg13g2_decap_8
XFILLER_27_588 VDD VSS / sg13g2_decap_8
XFILLER_27_595 VDD VSS / sg13g2_decap_8
XFILLER_27_602 VDD VSS / sg13g2_decap_8
XFILLER_27_609 VDD VSS / sg13g2_decap_8
XFILLER_27_616 VDD VSS / sg13g2_decap_8
XFILLER_27_623 VDD VSS / sg13g2_decap_8
XFILLER_27_630 VDD VSS / sg13g2_decap_8
XFILLER_27_637 VDD VSS / sg13g2_decap_8
XFILLER_27_644 VDD VSS / sg13g2_decap_8
XFILLER_27_651 VDD VSS / sg13g2_decap_8
XFILLER_27_658 VDD VSS / sg13g2_decap_8
XFILLER_27_665 VDD VSS / sg13g2_decap_8
XFILLER_27_672 VDD VSS / sg13g2_decap_8
XFILLER_27_679 VDD VSS / sg13g2_decap_8
XFILLER_27_686 VDD VSS / sg13g2_decap_8
XFILLER_27_693 VDD VSS / sg13g2_decap_8
XFILLER_27_700 VDD VSS / sg13g2_decap_8
XFILLER_27_707 VDD VSS / sg13g2_decap_8
XFILLER_27_714 VDD VSS / sg13g2_decap_8
XFILLER_27_721 VDD VSS / sg13g2_decap_8
XFILLER_27_728 VDD VSS / sg13g2_decap_8
XFILLER_27_735 VDD VSS / sg13g2_decap_8
XFILLER_27_742 VDD VSS / sg13g2_decap_8
XFILLER_27_749 VDD VSS / sg13g2_decap_4
XFILLER_27_753 VDD VSS / sg13g2_fill_2
XFILLER_27_98 VDD VSS / sg13g2_decap_8
XFILLER_28_105 VDD VSS / sg13g2_decap_8
XFILLER_28_112 VDD VSS / sg13g2_decap_8
XFILLER_28_119 VDD VSS / sg13g2_decap_8
XFILLER_28_126 VDD VSS / sg13g2_decap_8
XFILLER_28_133 VDD VSS / sg13g2_decap_8
XFILLER_28_140 VDD VSS / sg13g2_decap_8
XFILLER_28_147 VDD VSS / sg13g2_decap_8
XFILLER_28_154 VDD VSS / sg13g2_decap_8
XFILLER_28_161 VDD VSS / sg13g2_decap_8
XFILLER_28_168 VDD VSS / sg13g2_decap_8
XFILLER_28_175 VDD VSS / sg13g2_decap_8
XFILLER_28_182 VDD VSS / sg13g2_decap_8
XFILLER_28_189 VDD VSS / sg13g2_decap_8
XFILLER_28_196 VDD VSS / sg13g2_decap_8
XFILLER_28_203 VDD VSS / sg13g2_decap_8
XFILLER_28_210 VDD VSS / sg13g2_decap_8
XFILLER_28_217 VDD VSS / sg13g2_decap_8
XFILLER_28_224 VDD VSS / sg13g2_decap_8
XFILLER_28_231 VDD VSS / sg13g2_decap_8
XFILLER_28_238 VDD VSS / sg13g2_decap_8
XFILLER_28_245 VDD VSS / sg13g2_decap_8
XFILLER_28_252 VDD VSS / sg13g2_decap_8
XFILLER_28_259 VDD VSS / sg13g2_decap_8
XFILLER_28_266 VDD VSS / sg13g2_decap_8
XFILLER_28_273 VDD VSS / sg13g2_decap_8
XFILLER_28_280 VDD VSS / sg13g2_decap_8
XFILLER_28_287 VDD VSS / sg13g2_decap_8
XFILLER_28_294 VDD VSS / sg13g2_decap_8
XFILLER_28_301 VDD VSS / sg13g2_decap_8
XFILLER_28_308 VDD VSS / sg13g2_decap_8
XFILLER_28_315 VDD VSS / sg13g2_decap_8
XFILLER_28_322 VDD VSS / sg13g2_decap_8
XFILLER_28_329 VDD VSS / sg13g2_decap_8
XFILLER_28_336 VDD VSS / sg13g2_decap_8
XFILLER_28_343 VDD VSS / sg13g2_decap_8
XFILLER_28_350 VDD VSS / sg13g2_decap_8
XFILLER_28_357 VDD VSS / sg13g2_decap_8
XFILLER_28_364 VDD VSS / sg13g2_decap_8
XFILLER_28_371 VDD VSS / sg13g2_decap_8
XFILLER_28_378 VDD VSS / sg13g2_decap_8
XFILLER_28_385 VDD VSS / sg13g2_decap_8
XFILLER_28_392 VDD VSS / sg13g2_decap_8
XFILLER_28_399 VDD VSS / sg13g2_decap_8
XFILLER_28_406 VDD VSS / sg13g2_decap_8
XFILLER_28_413 VDD VSS / sg13g2_decap_8
XFILLER_28_420 VDD VSS / sg13g2_decap_8
XFILLER_28_427 VDD VSS / sg13g2_decap_8
XFILLER_28_434 VDD VSS / sg13g2_decap_8
XFILLER_28_441 VDD VSS / sg13g2_decap_8
XFILLER_28_448 VDD VSS / sg13g2_decap_8
XFILLER_28_455 VDD VSS / sg13g2_decap_8
XFILLER_28_462 VDD VSS / sg13g2_decap_8
XFILLER_28_469 VDD VSS / sg13g2_decap_8
XFILLER_28_476 VDD VSS / sg13g2_decap_8
XFILLER_28_483 VDD VSS / sg13g2_decap_8
XFILLER_28_490 VDD VSS / sg13g2_decap_8
XFILLER_28_497 VDD VSS / sg13g2_decap_8
XFILLER_28_504 VDD VSS / sg13g2_decap_8
XFILLER_28_511 VDD VSS / sg13g2_decap_8
XFILLER_28_518 VDD VSS / sg13g2_decap_8
XFILLER_28_525 VDD VSS / sg13g2_decap_8
XFILLER_28_532 VDD VSS / sg13g2_decap_8
XFILLER_28_539 VDD VSS / sg13g2_decap_8
XFILLER_28_546 VDD VSS / sg13g2_decap_8
XFILLER_28_553 VDD VSS / sg13g2_decap_8
XFILLER_28_560 VDD VSS / sg13g2_decap_8
XFILLER_28_567 VDD VSS / sg13g2_decap_8
XFILLER_28_574 VDD VSS / sg13g2_decap_8
XFILLER_28_581 VDD VSS / sg13g2_decap_8
XFILLER_28_588 VDD VSS / sg13g2_decap_8
XFILLER_28_595 VDD VSS / sg13g2_decap_8
XFILLER_28_602 VDD VSS / sg13g2_decap_8
XFILLER_28_609 VDD VSS / sg13g2_decap_8
XFILLER_28_616 VDD VSS / sg13g2_decap_8
XFILLER_28_623 VDD VSS / sg13g2_decap_8
XFILLER_28_630 VDD VSS / sg13g2_decap_8
XFILLER_28_637 VDD VSS / sg13g2_decap_8
XFILLER_28_644 VDD VSS / sg13g2_decap_8
XFILLER_28_651 VDD VSS / sg13g2_decap_8
XFILLER_28_658 VDD VSS / sg13g2_decap_8
XFILLER_28_665 VDD VSS / sg13g2_decap_8
XFILLER_28_672 VDD VSS / sg13g2_decap_8
XFILLER_28_679 VDD VSS / sg13g2_decap_8
XFILLER_28_686 VDD VSS / sg13g2_decap_8
XFILLER_28_693 VDD VSS / sg13g2_decap_8
XFILLER_28_700 VDD VSS / sg13g2_decap_8
XFILLER_28_707 VDD VSS / sg13g2_decap_8
XFILLER_28_714 VDD VSS / sg13g2_decap_8
XFILLER_28_721 VDD VSS / sg13g2_decap_8
XFILLER_28_728 VDD VSS / sg13g2_decap_8
XFILLER_28_735 VDD VSS / sg13g2_decap_8
XFILLER_28_742 VDD VSS / sg13g2_decap_8
XFILLER_28_749 VDD VSS / sg13g2_decap_4
XFILLER_28_753 VDD VSS / sg13g2_fill_2
XFILLER_28_98 VDD VSS / sg13g2_decap_8
XFILLER_29_105 VDD VSS / sg13g2_decap_8
XFILLER_29_112 VDD VSS / sg13g2_decap_8
XFILLER_29_119 VDD VSS / sg13g2_decap_8
XFILLER_29_126 VDD VSS / sg13g2_decap_8
XFILLER_29_133 VDD VSS / sg13g2_decap_8
XFILLER_29_140 VDD VSS / sg13g2_decap_8
XFILLER_29_147 VDD VSS / sg13g2_decap_8
XFILLER_29_154 VDD VSS / sg13g2_decap_8
XFILLER_29_161 VDD VSS / sg13g2_decap_8
XFILLER_29_168 VDD VSS / sg13g2_decap_8
XFILLER_29_175 VDD VSS / sg13g2_decap_8
XFILLER_29_182 VDD VSS / sg13g2_decap_8
XFILLER_29_189 VDD VSS / sg13g2_decap_8
XFILLER_29_196 VDD VSS / sg13g2_decap_8
XFILLER_29_203 VDD VSS / sg13g2_decap_8
XFILLER_29_210 VDD VSS / sg13g2_decap_8
XFILLER_29_217 VDD VSS / sg13g2_decap_8
XFILLER_29_224 VDD VSS / sg13g2_decap_8
XFILLER_29_231 VDD VSS / sg13g2_decap_8
XFILLER_29_238 VDD VSS / sg13g2_decap_8
XFILLER_29_245 VDD VSS / sg13g2_decap_8
XFILLER_29_252 VDD VSS / sg13g2_decap_8
XFILLER_29_259 VDD VSS / sg13g2_decap_8
XFILLER_29_266 VDD VSS / sg13g2_decap_8
XFILLER_29_273 VDD VSS / sg13g2_decap_8
XFILLER_29_280 VDD VSS / sg13g2_decap_8
XFILLER_29_287 VDD VSS / sg13g2_decap_8
XFILLER_29_294 VDD VSS / sg13g2_decap_8
XFILLER_29_301 VDD VSS / sg13g2_decap_8
XFILLER_29_308 VDD VSS / sg13g2_decap_8
XFILLER_29_315 VDD VSS / sg13g2_decap_8
XFILLER_29_322 VDD VSS / sg13g2_decap_8
XFILLER_29_329 VDD VSS / sg13g2_decap_8
XFILLER_29_336 VDD VSS / sg13g2_decap_8
XFILLER_29_343 VDD VSS / sg13g2_decap_8
XFILLER_29_350 VDD VSS / sg13g2_decap_8
XFILLER_29_357 VDD VSS / sg13g2_decap_8
XFILLER_29_364 VDD VSS / sg13g2_decap_8
XFILLER_29_371 VDD VSS / sg13g2_decap_8
XFILLER_29_378 VDD VSS / sg13g2_decap_8
XFILLER_29_385 VDD VSS / sg13g2_decap_8
XFILLER_29_392 VDD VSS / sg13g2_decap_8
XFILLER_29_399 VDD VSS / sg13g2_decap_8
XFILLER_29_406 VDD VSS / sg13g2_decap_8
XFILLER_29_413 VDD VSS / sg13g2_decap_8
XFILLER_29_420 VDD VSS / sg13g2_decap_8
XFILLER_29_427 VDD VSS / sg13g2_decap_8
XFILLER_29_434 VDD VSS / sg13g2_decap_8
XFILLER_29_441 VDD VSS / sg13g2_decap_8
XFILLER_29_448 VDD VSS / sg13g2_decap_8
XFILLER_29_455 VDD VSS / sg13g2_decap_8
XFILLER_29_462 VDD VSS / sg13g2_decap_8
XFILLER_29_469 VDD VSS / sg13g2_decap_8
XFILLER_29_476 VDD VSS / sg13g2_decap_8
XFILLER_29_483 VDD VSS / sg13g2_decap_8
XFILLER_29_490 VDD VSS / sg13g2_decap_8
XFILLER_29_497 VDD VSS / sg13g2_decap_8
XFILLER_29_504 VDD VSS / sg13g2_decap_8
XFILLER_29_511 VDD VSS / sg13g2_decap_8
XFILLER_29_518 VDD VSS / sg13g2_decap_8
XFILLER_29_525 VDD VSS / sg13g2_decap_8
XFILLER_29_532 VDD VSS / sg13g2_decap_8
XFILLER_29_539 VDD VSS / sg13g2_decap_8
XFILLER_29_546 VDD VSS / sg13g2_decap_8
XFILLER_29_553 VDD VSS / sg13g2_decap_8
XFILLER_29_560 VDD VSS / sg13g2_decap_8
XFILLER_29_567 VDD VSS / sg13g2_decap_8
XFILLER_29_574 VDD VSS / sg13g2_decap_8
XFILLER_29_581 VDD VSS / sg13g2_decap_8
XFILLER_29_588 VDD VSS / sg13g2_decap_8
XFILLER_29_595 VDD VSS / sg13g2_decap_8
XFILLER_29_602 VDD VSS / sg13g2_decap_8
XFILLER_29_609 VDD VSS / sg13g2_decap_8
XFILLER_29_616 VDD VSS / sg13g2_decap_8
XFILLER_29_623 VDD VSS / sg13g2_decap_8
XFILLER_29_630 VDD VSS / sg13g2_decap_8
XFILLER_29_637 VDD VSS / sg13g2_decap_8
XFILLER_29_644 VDD VSS / sg13g2_decap_8
XFILLER_29_651 VDD VSS / sg13g2_decap_8
XFILLER_29_658 VDD VSS / sg13g2_decap_8
XFILLER_29_665 VDD VSS / sg13g2_decap_8
XFILLER_29_672 VDD VSS / sg13g2_decap_8
XFILLER_29_679 VDD VSS / sg13g2_decap_8
XFILLER_29_686 VDD VSS / sg13g2_decap_8
XFILLER_29_693 VDD VSS / sg13g2_decap_8
XFILLER_29_700 VDD VSS / sg13g2_decap_8
XFILLER_29_707 VDD VSS / sg13g2_decap_8
XFILLER_29_714 VDD VSS / sg13g2_decap_8
XFILLER_29_721 VDD VSS / sg13g2_decap_8
XFILLER_29_728 VDD VSS / sg13g2_decap_8
XFILLER_29_735 VDD VSS / sg13g2_decap_8
XFILLER_29_742 VDD VSS / sg13g2_decap_8
XFILLER_29_749 VDD VSS / sg13g2_decap_4
XFILLER_29_753 VDD VSS / sg13g2_fill_2
XFILLER_29_98 VDD VSS / sg13g2_decap_8
XFILLER_2_1006 VDD VSS / sg13g2_decap_8
XFILLER_2_1013 VDD VSS / sg13g2_decap_8
XFILLER_2_1020 VDD VSS / sg13g2_decap_8
XFILLER_2_1027 VDD VSS / sg13g2_decap_8
XFILLER_2_103 VDD VSS / sg13g2_decap_8
XFILLER_2_1034 VDD VSS / sg13g2_decap_8
XFILLER_2_1041 VDD VSS / sg13g2_decap_8
XFILLER_2_1048 VDD VSS / sg13g2_decap_8
XFILLER_2_1055 VDD VSS / sg13g2_decap_8
XFILLER_2_1062 VDD VSS / sg13g2_decap_8
XFILLER_2_1069 VDD VSS / sg13g2_decap_8
XFILLER_2_1076 VDD VSS / sg13g2_decap_8
XFILLER_2_1083 VDD VSS / sg13g2_decap_8
XFILLER_2_1090 VDD VSS / sg13g2_decap_8
XFILLER_2_1097 VDD VSS / sg13g2_decap_8
XFILLER_2_110 VDD VSS / sg13g2_decap_8
XFILLER_2_1104 VDD VSS / sg13g2_decap_8
XFILLER_2_1111 VDD VSS / sg13g2_decap_8
XFILLER_2_1118 VDD VSS / sg13g2_decap_8
XFILLER_2_1125 VDD VSS / sg13g2_decap_8
XFILLER_2_1132 VDD VSS / sg13g2_decap_8
XFILLER_2_1139 VDD VSS / sg13g2_decap_8
XFILLER_2_1146 VDD VSS / sg13g2_decap_8
XFILLER_2_1153 VDD VSS / sg13g2_decap_8
XFILLER_2_1160 VDD VSS / sg13g2_decap_8
XFILLER_2_1167 VDD VSS / sg13g2_decap_8
XFILLER_2_117 VDD VSS / sg13g2_decap_8
XFILLER_2_1174 VDD VSS / sg13g2_decap_8
XFILLER_2_1181 VDD VSS / sg13g2_decap_8
XFILLER_2_1188 VDD VSS / sg13g2_decap_8
XFILLER_2_1195 VDD VSS / sg13g2_decap_8
XFILLER_2_1202 VDD VSS / sg13g2_decap_8
XFILLER_2_1209 VDD VSS / sg13g2_decap_8
XFILLER_2_1216 VDD VSS / sg13g2_decap_8
XFILLER_2_1223 VDD VSS / sg13g2_decap_8
XFILLER_2_1230 VDD VSS / sg13g2_decap_8
XFILLER_2_1237 VDD VSS / sg13g2_decap_8
XFILLER_2_124 VDD VSS / sg13g2_decap_8
XFILLER_2_1244 VDD VSS / sg13g2_decap_8
XFILLER_2_1251 VDD VSS / sg13g2_decap_8
XFILLER_2_1258 VDD VSS / sg13g2_decap_8
XFILLER_2_1265 VDD VSS / sg13g2_decap_8
XFILLER_2_1272 VDD VSS / sg13g2_decap_8
XFILLER_2_1279 VDD VSS / sg13g2_decap_8
XFILLER_2_1286 VDD VSS / sg13g2_decap_8
XFILLER_2_1293 VDD VSS / sg13g2_fill_2
XFILLER_2_131 VDD VSS / sg13g2_decap_8
XFILLER_2_138 VDD VSS / sg13g2_decap_8
XFILLER_2_145 VDD VSS / sg13g2_decap_8
XFILLER_2_152 VDD VSS / sg13g2_decap_8
XFILLER_2_159 VDD VSS / sg13g2_decap_8
XFILLER_2_166 VDD VSS / sg13g2_decap_8
XFILLER_2_173 VDD VSS / sg13g2_decap_8
XFILLER_2_180 VDD VSS / sg13g2_decap_8
XFILLER_2_187 VDD VSS / sg13g2_decap_8
XFILLER_2_194 VDD VSS / sg13g2_decap_8
XFILLER_2_201 VDD VSS / sg13g2_decap_8
XFILLER_2_208 VDD VSS / sg13g2_decap_8
XFILLER_2_215 VDD VSS / sg13g2_decap_8
XFILLER_2_222 VDD VSS / sg13g2_decap_8
XFILLER_2_229 VDD VSS / sg13g2_decap_8
XFILLER_2_236 VDD VSS / sg13g2_decap_8
XFILLER_2_243 VDD VSS / sg13g2_decap_8
XFILLER_2_250 VDD VSS / sg13g2_decap_8
XFILLER_2_257 VDD VSS / sg13g2_decap_8
XFILLER_2_264 VDD VSS / sg13g2_decap_8
XFILLER_2_271 VDD VSS / sg13g2_decap_8
XFILLER_2_278 VDD VSS / sg13g2_decap_8
XFILLER_2_285 VDD VSS / sg13g2_decap_8
XFILLER_2_292 VDD VSS / sg13g2_decap_8
XFILLER_2_299 VDD VSS / sg13g2_decap_8
XFILLER_2_306 VDD VSS / sg13g2_decap_8
XFILLER_2_313 VDD VSS / sg13g2_decap_8
XFILLER_2_320 VDD VSS / sg13g2_decap_8
XFILLER_2_327 VDD VSS / sg13g2_decap_8
XFILLER_2_334 VDD VSS / sg13g2_decap_8
XFILLER_2_341 VDD VSS / sg13g2_decap_8
XFILLER_2_348 VDD VSS / sg13g2_decap_8
XFILLER_2_355 VDD VSS / sg13g2_decap_8
XFILLER_2_362 VDD VSS / sg13g2_decap_8
XFILLER_2_369 VDD VSS / sg13g2_decap_8
XFILLER_2_376 VDD VSS / sg13g2_decap_8
XFILLER_2_383 VDD VSS / sg13g2_decap_8
XFILLER_2_390 VDD VSS / sg13g2_decap_8
XFILLER_2_397 VDD VSS / sg13g2_decap_8
XFILLER_2_404 VDD VSS / sg13g2_decap_8
XFILLER_2_411 VDD VSS / sg13g2_decap_8
XFILLER_2_418 VDD VSS / sg13g2_decap_8
XFILLER_2_425 VDD VSS / sg13g2_decap_8
XFILLER_2_432 VDD VSS / sg13g2_decap_8
XFILLER_2_439 VDD VSS / sg13g2_decap_8
XFILLER_2_446 VDD VSS / sg13g2_decap_8
XFILLER_2_453 VDD VSS / sg13g2_decap_8
XFILLER_2_460 VDD VSS / sg13g2_decap_8
XFILLER_2_467 VDD VSS / sg13g2_decap_8
XFILLER_2_474 VDD VSS / sg13g2_decap_8
XFILLER_2_481 VDD VSS / sg13g2_decap_8
XFILLER_2_488 VDD VSS / sg13g2_decap_8
XFILLER_2_495 VDD VSS / sg13g2_decap_8
XFILLER_2_502 VDD VSS / sg13g2_decap_8
XFILLER_2_509 VDD VSS / sg13g2_decap_8
XFILLER_2_516 VDD VSS / sg13g2_decap_8
XFILLER_2_523 VDD VSS / sg13g2_decap_8
XFILLER_2_530 VDD VSS / sg13g2_decap_8
XFILLER_2_537 VDD VSS / sg13g2_decap_8
XFILLER_2_544 VDD VSS / sg13g2_decap_8
XFILLER_2_551 VDD VSS / sg13g2_decap_8
XFILLER_2_558 VDD VSS / sg13g2_decap_8
XFILLER_2_565 VDD VSS / sg13g2_decap_8
XFILLER_2_572 VDD VSS / sg13g2_decap_8
XFILLER_2_579 VDD VSS / sg13g2_decap_8
XFILLER_2_586 VDD VSS / sg13g2_decap_8
XFILLER_2_593 VDD VSS / sg13g2_decap_8
XFILLER_2_600 VDD VSS / sg13g2_decap_8
XFILLER_2_607 VDD VSS / sg13g2_decap_8
XFILLER_2_614 VDD VSS / sg13g2_decap_8
XFILLER_2_621 VDD VSS / sg13g2_decap_8
XFILLER_2_628 VDD VSS / sg13g2_decap_8
XFILLER_2_635 VDD VSS / sg13g2_decap_8
XFILLER_2_642 VDD VSS / sg13g2_decap_8
XFILLER_2_649 VDD VSS / sg13g2_decap_8
XFILLER_2_656 VDD VSS / sg13g2_decap_8
XFILLER_2_663 VDD VSS / sg13g2_decap_8
XFILLER_2_670 VDD VSS / sg13g2_decap_8
XFILLER_2_677 VDD VSS / sg13g2_decap_8
XFILLER_2_684 VDD VSS / sg13g2_decap_8
XFILLER_2_691 VDD VSS / sg13g2_decap_8
XFILLER_2_698 VDD VSS / sg13g2_decap_8
XFILLER_2_705 VDD VSS / sg13g2_decap_8
XFILLER_2_712 VDD VSS / sg13g2_decap_8
XFILLER_2_719 VDD VSS / sg13g2_decap_8
XFILLER_2_726 VDD VSS / sg13g2_decap_8
XFILLER_2_733 VDD VSS / sg13g2_decap_8
XFILLER_2_740 VDD VSS / sg13g2_decap_8
XFILLER_2_747 VDD VSS / sg13g2_decap_8
XFILLER_2_754 VDD VSS / sg13g2_decap_8
XFILLER_2_761 VDD VSS / sg13g2_decap_8
XFILLER_2_768 VDD VSS / sg13g2_decap_8
XFILLER_2_775 VDD VSS / sg13g2_decap_8
XFILLER_2_782 VDD VSS / sg13g2_decap_8
XFILLER_2_789 VDD VSS / sg13g2_decap_8
XFILLER_2_796 VDD VSS / sg13g2_decap_8
XFILLER_2_803 VDD VSS / sg13g2_decap_8
XFILLER_2_810 VDD VSS / sg13g2_decap_8
XFILLER_2_817 VDD VSS / sg13g2_decap_8
XFILLER_2_824 VDD VSS / sg13g2_decap_8
XFILLER_2_831 VDD VSS / sg13g2_decap_8
XFILLER_2_838 VDD VSS / sg13g2_decap_8
XFILLER_2_845 VDD VSS / sg13g2_decap_8
XFILLER_2_852 VDD VSS / sg13g2_decap_8
XFILLER_2_859 VDD VSS / sg13g2_decap_8
XFILLER_2_866 VDD VSS / sg13g2_decap_8
XFILLER_2_873 VDD VSS / sg13g2_decap_8
XFILLER_2_880 VDD VSS / sg13g2_decap_8
XFILLER_2_887 VDD VSS / sg13g2_decap_8
XFILLER_2_89 VDD VSS / sg13g2_decap_8
XFILLER_2_894 VDD VSS / sg13g2_decap_8
XFILLER_2_901 VDD VSS / sg13g2_decap_8
XFILLER_2_908 VDD VSS / sg13g2_decap_8
XFILLER_2_915 VDD VSS / sg13g2_decap_8
XFILLER_2_922 VDD VSS / sg13g2_decap_8
XFILLER_2_929 VDD VSS / sg13g2_decap_8
XFILLER_2_936 VDD VSS / sg13g2_decap_8
XFILLER_2_943 VDD VSS / sg13g2_decap_8
XFILLER_2_950 VDD VSS / sg13g2_decap_8
XFILLER_2_957 VDD VSS / sg13g2_decap_8
XFILLER_2_96 VDD VSS / sg13g2_decap_8
XFILLER_2_964 VDD VSS / sg13g2_decap_8
XFILLER_2_971 VDD VSS / sg13g2_decap_8
XFILLER_2_978 VDD VSS / sg13g2_decap_8
XFILLER_2_985 VDD VSS / sg13g2_decap_8
XFILLER_2_992 VDD VSS / sg13g2_decap_8
XFILLER_2_999 VDD VSS / sg13g2_decap_8
XFILLER_30_105 VDD VSS / sg13g2_decap_8
XFILLER_30_112 VDD VSS / sg13g2_decap_8
XFILLER_30_119 VDD VSS / sg13g2_decap_8
XFILLER_30_126 VDD VSS / sg13g2_decap_8
XFILLER_30_133 VDD VSS / sg13g2_decap_8
XFILLER_30_140 VDD VSS / sg13g2_decap_8
XFILLER_30_147 VDD VSS / sg13g2_decap_8
XFILLER_30_154 VDD VSS / sg13g2_decap_8
XFILLER_30_161 VDD VSS / sg13g2_decap_8
XFILLER_30_168 VDD VSS / sg13g2_decap_8
XFILLER_30_175 VDD VSS / sg13g2_decap_8
XFILLER_30_182 VDD VSS / sg13g2_decap_8
XFILLER_30_189 VDD VSS / sg13g2_decap_8
XFILLER_30_196 VDD VSS / sg13g2_decap_8
XFILLER_30_203 VDD VSS / sg13g2_decap_8
XFILLER_30_210 VDD VSS / sg13g2_decap_8
XFILLER_30_217 VDD VSS / sg13g2_decap_8
XFILLER_30_224 VDD VSS / sg13g2_decap_8
XFILLER_30_231 VDD VSS / sg13g2_decap_8
XFILLER_30_238 VDD VSS / sg13g2_decap_8
XFILLER_30_245 VDD VSS / sg13g2_decap_8
XFILLER_30_252 VDD VSS / sg13g2_decap_8
XFILLER_30_259 VDD VSS / sg13g2_decap_8
XFILLER_30_266 VDD VSS / sg13g2_decap_8
XFILLER_30_273 VDD VSS / sg13g2_decap_8
XFILLER_30_280 VDD VSS / sg13g2_decap_8
XFILLER_30_287 VDD VSS / sg13g2_decap_8
XFILLER_30_294 VDD VSS / sg13g2_decap_8
XFILLER_30_301 VDD VSS / sg13g2_decap_8
XFILLER_30_308 VDD VSS / sg13g2_decap_8
XFILLER_30_315 VDD VSS / sg13g2_decap_8
XFILLER_30_322 VDD VSS / sg13g2_decap_8
XFILLER_30_329 VDD VSS / sg13g2_decap_8
XFILLER_30_336 VDD VSS / sg13g2_decap_8
XFILLER_30_343 VDD VSS / sg13g2_decap_8
XFILLER_30_350 VDD VSS / sg13g2_decap_8
XFILLER_30_357 VDD VSS / sg13g2_decap_8
XFILLER_30_364 VDD VSS / sg13g2_decap_8
XFILLER_30_371 VDD VSS / sg13g2_decap_8
XFILLER_30_378 VDD VSS / sg13g2_decap_8
XFILLER_30_385 VDD VSS / sg13g2_decap_8
XFILLER_30_392 VDD VSS / sg13g2_decap_8
XFILLER_30_399 VDD VSS / sg13g2_decap_8
XFILLER_30_406 VDD VSS / sg13g2_decap_8
XFILLER_30_413 VDD VSS / sg13g2_decap_8
XFILLER_30_420 VDD VSS / sg13g2_decap_8
XFILLER_30_427 VDD VSS / sg13g2_decap_8
XFILLER_30_434 VDD VSS / sg13g2_decap_8
XFILLER_30_441 VDD VSS / sg13g2_decap_8
XFILLER_30_448 VDD VSS / sg13g2_decap_8
XFILLER_30_455 VDD VSS / sg13g2_decap_8
XFILLER_30_462 VDD VSS / sg13g2_decap_8
XFILLER_30_469 VDD VSS / sg13g2_decap_8
XFILLER_30_476 VDD VSS / sg13g2_decap_8
XFILLER_30_483 VDD VSS / sg13g2_decap_8
XFILLER_30_490 VDD VSS / sg13g2_decap_8
XFILLER_30_497 VDD VSS / sg13g2_decap_8
XFILLER_30_504 VDD VSS / sg13g2_decap_8
XFILLER_30_511 VDD VSS / sg13g2_decap_8
XFILLER_30_518 VDD VSS / sg13g2_decap_8
XFILLER_30_525 VDD VSS / sg13g2_decap_8
XFILLER_30_532 VDD VSS / sg13g2_decap_8
XFILLER_30_539 VDD VSS / sg13g2_decap_8
XFILLER_30_546 VDD VSS / sg13g2_decap_8
XFILLER_30_553 VDD VSS / sg13g2_decap_8
XFILLER_30_560 VDD VSS / sg13g2_decap_8
XFILLER_30_567 VDD VSS / sg13g2_decap_8
XFILLER_30_574 VDD VSS / sg13g2_decap_8
XFILLER_30_581 VDD VSS / sg13g2_decap_8
XFILLER_30_588 VDD VSS / sg13g2_decap_8
XFILLER_30_595 VDD VSS / sg13g2_decap_8
XFILLER_30_602 VDD VSS / sg13g2_decap_8
XFILLER_30_609 VDD VSS / sg13g2_decap_8
XFILLER_30_616 VDD VSS / sg13g2_decap_8
XFILLER_30_623 VDD VSS / sg13g2_decap_8
XFILLER_30_630 VDD VSS / sg13g2_decap_8
XFILLER_30_637 VDD VSS / sg13g2_decap_8
XFILLER_30_644 VDD VSS / sg13g2_decap_8
XFILLER_30_651 VDD VSS / sg13g2_decap_8
XFILLER_30_658 VDD VSS / sg13g2_decap_8
XFILLER_30_665 VDD VSS / sg13g2_decap_8
XFILLER_30_672 VDD VSS / sg13g2_decap_8
XFILLER_30_679 VDD VSS / sg13g2_decap_8
XFILLER_30_686 VDD VSS / sg13g2_decap_8
XFILLER_30_693 VDD VSS / sg13g2_decap_8
XFILLER_30_700 VDD VSS / sg13g2_decap_8
XFILLER_30_707 VDD VSS / sg13g2_decap_8
XFILLER_30_714 VDD VSS / sg13g2_decap_8
XFILLER_30_721 VDD VSS / sg13g2_decap_8
XFILLER_30_728 VDD VSS / sg13g2_decap_8
XFILLER_30_735 VDD VSS / sg13g2_decap_8
XFILLER_30_742 VDD VSS / sg13g2_decap_8
XFILLER_30_749 VDD VSS / sg13g2_decap_4
XFILLER_30_753 VDD VSS / sg13g2_fill_2
XFILLER_30_98 VDD VSS / sg13g2_decap_8
XFILLER_31_105 VDD VSS / sg13g2_decap_8
XFILLER_31_112 VDD VSS / sg13g2_decap_8
XFILLER_31_119 VDD VSS / sg13g2_decap_8
XFILLER_31_126 VDD VSS / sg13g2_decap_8
XFILLER_31_133 VDD VSS / sg13g2_decap_8
XFILLER_31_140 VDD VSS / sg13g2_decap_8
XFILLER_31_147 VDD VSS / sg13g2_decap_8
XFILLER_31_154 VDD VSS / sg13g2_decap_8
XFILLER_31_161 VDD VSS / sg13g2_decap_8
XFILLER_31_168 VDD VSS / sg13g2_decap_8
XFILLER_31_175 VDD VSS / sg13g2_decap_8
XFILLER_31_182 VDD VSS / sg13g2_decap_8
XFILLER_31_189 VDD VSS / sg13g2_decap_8
XFILLER_31_196 VDD VSS / sg13g2_decap_8
XFILLER_31_203 VDD VSS / sg13g2_decap_8
XFILLER_31_210 VDD VSS / sg13g2_decap_8
XFILLER_31_217 VDD VSS / sg13g2_decap_8
XFILLER_31_224 VDD VSS / sg13g2_decap_8
XFILLER_31_231 VDD VSS / sg13g2_decap_8
XFILLER_31_238 VDD VSS / sg13g2_decap_8
XFILLER_31_245 VDD VSS / sg13g2_decap_8
XFILLER_31_252 VDD VSS / sg13g2_decap_8
XFILLER_31_259 VDD VSS / sg13g2_decap_8
XFILLER_31_266 VDD VSS / sg13g2_decap_8
XFILLER_31_273 VDD VSS / sg13g2_decap_8
XFILLER_31_280 VDD VSS / sg13g2_decap_8
XFILLER_31_287 VDD VSS / sg13g2_decap_8
XFILLER_31_294 VDD VSS / sg13g2_decap_8
XFILLER_31_301 VDD VSS / sg13g2_decap_8
XFILLER_31_308 VDD VSS / sg13g2_decap_8
XFILLER_31_315 VDD VSS / sg13g2_decap_8
XFILLER_31_322 VDD VSS / sg13g2_decap_8
XFILLER_31_329 VDD VSS / sg13g2_decap_8
XFILLER_31_336 VDD VSS / sg13g2_decap_8
XFILLER_31_343 VDD VSS / sg13g2_decap_8
XFILLER_31_350 VDD VSS / sg13g2_decap_8
XFILLER_31_357 VDD VSS / sg13g2_decap_8
XFILLER_31_364 VDD VSS / sg13g2_decap_8
XFILLER_31_371 VDD VSS / sg13g2_decap_8
XFILLER_31_378 VDD VSS / sg13g2_decap_8
XFILLER_31_385 VDD VSS / sg13g2_decap_8
XFILLER_31_392 VDD VSS / sg13g2_decap_8
XFILLER_31_399 VDD VSS / sg13g2_decap_8
XFILLER_31_406 VDD VSS / sg13g2_decap_8
XFILLER_31_413 VDD VSS / sg13g2_decap_8
XFILLER_31_420 VDD VSS / sg13g2_decap_8
XFILLER_31_427 VDD VSS / sg13g2_decap_8
XFILLER_31_434 VDD VSS / sg13g2_decap_8
XFILLER_31_441 VDD VSS / sg13g2_decap_8
XFILLER_31_448 VDD VSS / sg13g2_decap_8
XFILLER_31_455 VDD VSS / sg13g2_decap_8
XFILLER_31_462 VDD VSS / sg13g2_decap_8
XFILLER_31_469 VDD VSS / sg13g2_decap_8
XFILLER_31_476 VDD VSS / sg13g2_decap_8
XFILLER_31_483 VDD VSS / sg13g2_decap_8
XFILLER_31_490 VDD VSS / sg13g2_decap_8
XFILLER_31_497 VDD VSS / sg13g2_decap_8
XFILLER_31_504 VDD VSS / sg13g2_decap_8
XFILLER_31_511 VDD VSS / sg13g2_decap_8
XFILLER_31_518 VDD VSS / sg13g2_decap_8
XFILLER_31_525 VDD VSS / sg13g2_decap_8
XFILLER_31_532 VDD VSS / sg13g2_decap_8
XFILLER_31_539 VDD VSS / sg13g2_decap_8
XFILLER_31_546 VDD VSS / sg13g2_decap_8
XFILLER_31_553 VDD VSS / sg13g2_decap_8
XFILLER_31_560 VDD VSS / sg13g2_decap_8
XFILLER_31_567 VDD VSS / sg13g2_decap_8
XFILLER_31_574 VDD VSS / sg13g2_decap_8
XFILLER_31_581 VDD VSS / sg13g2_decap_8
XFILLER_31_588 VDD VSS / sg13g2_decap_8
XFILLER_31_595 VDD VSS / sg13g2_decap_8
XFILLER_31_602 VDD VSS / sg13g2_decap_8
XFILLER_31_609 VDD VSS / sg13g2_decap_8
XFILLER_31_616 VDD VSS / sg13g2_decap_8
XFILLER_31_623 VDD VSS / sg13g2_decap_8
XFILLER_31_630 VDD VSS / sg13g2_decap_8
XFILLER_31_637 VDD VSS / sg13g2_decap_8
XFILLER_31_644 VDD VSS / sg13g2_decap_8
XFILLER_31_651 VDD VSS / sg13g2_decap_8
XFILLER_31_658 VDD VSS / sg13g2_decap_8
XFILLER_31_665 VDD VSS / sg13g2_decap_8
XFILLER_31_672 VDD VSS / sg13g2_decap_8
XFILLER_31_679 VDD VSS / sg13g2_decap_8
XFILLER_31_686 VDD VSS / sg13g2_decap_8
XFILLER_31_693 VDD VSS / sg13g2_decap_8
XFILLER_31_700 VDD VSS / sg13g2_decap_8
XFILLER_31_707 VDD VSS / sg13g2_decap_8
XFILLER_31_714 VDD VSS / sg13g2_decap_8
XFILLER_31_721 VDD VSS / sg13g2_decap_8
XFILLER_31_728 VDD VSS / sg13g2_decap_8
XFILLER_31_735 VDD VSS / sg13g2_decap_8
XFILLER_31_742 VDD VSS / sg13g2_decap_8
XFILLER_31_749 VDD VSS / sg13g2_decap_4
XFILLER_31_753 VDD VSS / sg13g2_fill_2
XFILLER_31_98 VDD VSS / sg13g2_decap_8
XFILLER_32_372 VDD VSS / sg13g2_decap_8
XFILLER_32_379 VDD VSS / sg13g2_decap_8
XFILLER_32_386 VDD VSS / sg13g2_decap_8
XFILLER_32_393 VDD VSS / sg13g2_decap_8
XFILLER_32_400 VDD VSS / sg13g2_decap_8
XFILLER_32_407 VDD VSS / sg13g2_decap_8
XFILLER_32_414 VDD VSS / sg13g2_decap_8
XFILLER_32_421 VDD VSS / sg13g2_decap_8
XFILLER_32_428 VDD VSS / sg13g2_decap_8
XFILLER_32_435 VDD VSS / sg13g2_decap_8
XFILLER_32_442 VDD VSS / sg13g2_decap_8
XFILLER_32_449 VDD VSS / sg13g2_decap_8
XFILLER_32_456 VDD VSS / sg13g2_decap_8
XFILLER_32_463 VDD VSS / sg13g2_decap_8
XFILLER_32_470 VDD VSS / sg13g2_decap_8
XFILLER_32_477 VDD VSS / sg13g2_decap_8
XFILLER_32_484 VDD VSS / sg13g2_decap_8
XFILLER_32_491 VDD VSS / sg13g2_decap_8
XFILLER_32_498 VDD VSS / sg13g2_decap_8
XFILLER_32_505 VDD VSS / sg13g2_decap_8
XFILLER_32_512 VDD VSS / sg13g2_decap_8
XFILLER_32_519 VDD VSS / sg13g2_decap_8
XFILLER_32_526 VDD VSS / sg13g2_decap_8
XFILLER_32_533 VDD VSS / sg13g2_decap_8
XFILLER_32_540 VDD VSS / sg13g2_decap_8
XFILLER_32_547 VDD VSS / sg13g2_decap_8
XFILLER_32_554 VDD VSS / sg13g2_decap_8
XFILLER_32_561 VDD VSS / sg13g2_decap_8
XFILLER_32_568 VDD VSS / sg13g2_decap_8
XFILLER_32_575 VDD VSS / sg13g2_decap_8
XFILLER_32_582 VDD VSS / sg13g2_decap_8
XFILLER_32_589 VDD VSS / sg13g2_decap_8
XFILLER_32_596 VDD VSS / sg13g2_decap_8
XFILLER_32_603 VDD VSS / sg13g2_decap_8
XFILLER_32_610 VDD VSS / sg13g2_decap_8
XFILLER_32_617 VDD VSS / sg13g2_decap_8
XFILLER_32_624 VDD VSS / sg13g2_decap_8
XFILLER_32_631 VDD VSS / sg13g2_decap_8
XFILLER_32_638 VDD VSS / sg13g2_decap_8
XFILLER_32_645 VDD VSS / sg13g2_decap_8
XFILLER_32_652 VDD VSS / sg13g2_decap_8
XFILLER_32_659 VDD VSS / sg13g2_decap_8
XFILLER_32_666 VDD VSS / sg13g2_decap_8
XFILLER_32_673 VDD VSS / sg13g2_decap_8
XFILLER_32_680 VDD VSS / sg13g2_decap_8
XFILLER_32_687 VDD VSS / sg13g2_decap_8
XFILLER_32_694 VDD VSS / sg13g2_decap_8
XFILLER_32_701 VDD VSS / sg13g2_decap_8
XFILLER_32_708 VDD VSS / sg13g2_decap_8
XFILLER_32_715 VDD VSS / sg13g2_decap_8
XFILLER_32_722 VDD VSS / sg13g2_decap_8
XFILLER_32_729 VDD VSS / sg13g2_decap_8
XFILLER_32_736 VDD VSS / sg13g2_decap_8
XFILLER_32_743 VDD VSS / sg13g2_decap_8
XFILLER_32_750 VDD VSS / sg13g2_decap_4
XFILLER_32_754 VDD VSS / sg13g2_fill_1
XFILLER_33_372 VDD VSS / sg13g2_decap_8
XFILLER_33_379 VDD VSS / sg13g2_decap_8
XFILLER_33_386 VDD VSS / sg13g2_decap_8
XFILLER_33_393 VDD VSS / sg13g2_decap_8
XFILLER_33_400 VDD VSS / sg13g2_decap_8
XFILLER_33_407 VDD VSS / sg13g2_decap_8
XFILLER_33_414 VDD VSS / sg13g2_decap_8
XFILLER_33_421 VDD VSS / sg13g2_decap_8
XFILLER_33_428 VDD VSS / sg13g2_decap_8
XFILLER_33_435 VDD VSS / sg13g2_decap_8
XFILLER_33_442 VDD VSS / sg13g2_decap_8
XFILLER_33_449 VDD VSS / sg13g2_decap_8
XFILLER_33_456 VDD VSS / sg13g2_decap_8
XFILLER_33_463 VDD VSS / sg13g2_decap_8
XFILLER_33_470 VDD VSS / sg13g2_decap_8
XFILLER_33_477 VDD VSS / sg13g2_decap_8
XFILLER_33_484 VDD VSS / sg13g2_decap_8
XFILLER_33_491 VDD VSS / sg13g2_decap_8
XFILLER_33_498 VDD VSS / sg13g2_decap_8
XFILLER_33_505 VDD VSS / sg13g2_decap_8
XFILLER_33_512 VDD VSS / sg13g2_decap_8
XFILLER_33_519 VDD VSS / sg13g2_decap_8
XFILLER_33_526 VDD VSS / sg13g2_decap_8
XFILLER_33_533 VDD VSS / sg13g2_decap_8
XFILLER_33_540 VDD VSS / sg13g2_decap_8
XFILLER_33_547 VDD VSS / sg13g2_decap_8
XFILLER_33_554 VDD VSS / sg13g2_decap_8
XFILLER_33_561 VDD VSS / sg13g2_decap_8
XFILLER_33_568 VDD VSS / sg13g2_decap_8
XFILLER_33_575 VDD VSS / sg13g2_decap_8
XFILLER_33_582 VDD VSS / sg13g2_decap_8
XFILLER_33_589 VDD VSS / sg13g2_decap_8
XFILLER_33_596 VDD VSS / sg13g2_decap_8
XFILLER_33_603 VDD VSS / sg13g2_decap_8
XFILLER_33_610 VDD VSS / sg13g2_decap_8
XFILLER_33_617 VDD VSS / sg13g2_decap_8
XFILLER_33_624 VDD VSS / sg13g2_decap_8
XFILLER_33_631 VDD VSS / sg13g2_decap_8
XFILLER_33_638 VDD VSS / sg13g2_decap_8
XFILLER_33_645 VDD VSS / sg13g2_decap_8
XFILLER_33_652 VDD VSS / sg13g2_decap_8
XFILLER_33_659 VDD VSS / sg13g2_decap_8
XFILLER_33_666 VDD VSS / sg13g2_decap_8
XFILLER_33_673 VDD VSS / sg13g2_decap_8
XFILLER_33_680 VDD VSS / sg13g2_decap_8
XFILLER_33_687 VDD VSS / sg13g2_decap_8
XFILLER_33_694 VDD VSS / sg13g2_decap_8
XFILLER_33_701 VDD VSS / sg13g2_decap_8
XFILLER_33_708 VDD VSS / sg13g2_decap_8
XFILLER_33_715 VDD VSS / sg13g2_decap_8
XFILLER_33_722 VDD VSS / sg13g2_decap_8
XFILLER_33_729 VDD VSS / sg13g2_decap_8
XFILLER_33_736 VDD VSS / sg13g2_decap_8
XFILLER_33_743 VDD VSS / sg13g2_decap_8
XFILLER_33_750 VDD VSS / sg13g2_decap_4
XFILLER_33_754 VDD VSS / sg13g2_fill_1
XFILLER_34_372 VDD VSS / sg13g2_decap_8
XFILLER_34_379 VDD VSS / sg13g2_decap_8
XFILLER_34_386 VDD VSS / sg13g2_decap_8
XFILLER_34_393 VDD VSS / sg13g2_decap_8
XFILLER_34_400 VDD VSS / sg13g2_decap_8
XFILLER_34_407 VDD VSS / sg13g2_decap_8
XFILLER_34_414 VDD VSS / sg13g2_decap_8
XFILLER_34_421 VDD VSS / sg13g2_decap_8
XFILLER_34_428 VDD VSS / sg13g2_decap_8
XFILLER_34_435 VDD VSS / sg13g2_decap_8
XFILLER_34_442 VDD VSS / sg13g2_decap_8
XFILLER_34_449 VDD VSS / sg13g2_decap_8
XFILLER_34_456 VDD VSS / sg13g2_decap_8
XFILLER_34_463 VDD VSS / sg13g2_decap_8
XFILLER_34_470 VDD VSS / sg13g2_decap_8
XFILLER_34_477 VDD VSS / sg13g2_decap_8
XFILLER_34_484 VDD VSS / sg13g2_decap_8
XFILLER_34_491 VDD VSS / sg13g2_decap_8
XFILLER_34_498 VDD VSS / sg13g2_decap_8
XFILLER_34_505 VDD VSS / sg13g2_decap_8
XFILLER_34_512 VDD VSS / sg13g2_decap_8
XFILLER_34_519 VDD VSS / sg13g2_decap_8
XFILLER_34_526 VDD VSS / sg13g2_decap_8
XFILLER_34_533 VDD VSS / sg13g2_decap_8
XFILLER_34_540 VDD VSS / sg13g2_decap_8
XFILLER_34_547 VDD VSS / sg13g2_decap_8
XFILLER_34_554 VDD VSS / sg13g2_decap_8
XFILLER_34_561 VDD VSS / sg13g2_decap_8
XFILLER_34_568 VDD VSS / sg13g2_decap_8
XFILLER_34_575 VDD VSS / sg13g2_decap_8
XFILLER_34_582 VDD VSS / sg13g2_decap_8
XFILLER_34_589 VDD VSS / sg13g2_decap_8
XFILLER_34_596 VDD VSS / sg13g2_decap_8
XFILLER_34_603 VDD VSS / sg13g2_decap_8
XFILLER_34_610 VDD VSS / sg13g2_decap_8
XFILLER_34_617 VDD VSS / sg13g2_decap_8
XFILLER_34_624 VDD VSS / sg13g2_decap_8
XFILLER_34_631 VDD VSS / sg13g2_decap_8
XFILLER_34_638 VDD VSS / sg13g2_decap_8
XFILLER_34_645 VDD VSS / sg13g2_decap_8
XFILLER_34_652 VDD VSS / sg13g2_decap_8
XFILLER_34_659 VDD VSS / sg13g2_decap_8
XFILLER_34_666 VDD VSS / sg13g2_decap_8
XFILLER_34_673 VDD VSS / sg13g2_decap_8
XFILLER_34_680 VDD VSS / sg13g2_decap_8
XFILLER_34_687 VDD VSS / sg13g2_decap_8
XFILLER_34_694 VDD VSS / sg13g2_decap_8
XFILLER_34_701 VDD VSS / sg13g2_decap_8
XFILLER_34_708 VDD VSS / sg13g2_decap_8
XFILLER_34_715 VDD VSS / sg13g2_decap_8
XFILLER_34_722 VDD VSS / sg13g2_decap_8
XFILLER_34_729 VDD VSS / sg13g2_decap_8
XFILLER_34_736 VDD VSS / sg13g2_decap_8
XFILLER_34_743 VDD VSS / sg13g2_decap_8
XFILLER_34_750 VDD VSS / sg13g2_decap_4
XFILLER_34_754 VDD VSS / sg13g2_fill_1
XFILLER_36_1005 VDD VSS / sg13g2_decap_8
XFILLER_36_1012 VDD VSS / sg13g2_decap_8
XFILLER_36_1019 VDD VSS / sg13g2_decap_8
XFILLER_36_1026 VDD VSS / sg13g2_decap_8
XFILLER_36_1033 VDD VSS / sg13g2_decap_8
XFILLER_36_1040 VDD VSS / sg13g2_decap_8
XFILLER_36_1047 VDD VSS / sg13g2_decap_8
XFILLER_36_1054 VDD VSS / sg13g2_decap_8
XFILLER_36_1061 VDD VSS / sg13g2_decap_8
XFILLER_36_1068 VDD VSS / sg13g2_decap_8
XFILLER_36_1075 VDD VSS / sg13g2_decap_8
XFILLER_36_1082 VDD VSS / sg13g2_decap_8
XFILLER_36_1089 VDD VSS / sg13g2_decap_8
XFILLER_36_1096 VDD VSS / sg13g2_decap_8
XFILLER_36_1103 VDD VSS / sg13g2_decap_8
XFILLER_36_1110 VDD VSS / sg13g2_decap_8
XFILLER_36_1117 VDD VSS / sg13g2_decap_8
XFILLER_36_1124 VDD VSS / sg13g2_decap_8
XFILLER_36_1131 VDD VSS / sg13g2_decap_8
XFILLER_36_1138 VDD VSS / sg13g2_decap_8
XFILLER_36_1145 VDD VSS / sg13g2_decap_8
XFILLER_36_1152 VDD VSS / sg13g2_decap_8
XFILLER_36_1159 VDD VSS / sg13g2_decap_8
XFILLER_36_1166 VDD VSS / sg13g2_decap_8
XFILLER_36_1173 VDD VSS / sg13g2_decap_8
XFILLER_36_1180 VDD VSS / sg13g2_decap_8
XFILLER_36_1187 VDD VSS / sg13g2_decap_8
XFILLER_36_1194 VDD VSS / sg13g2_decap_8
XFILLER_36_1201 VDD VSS / sg13g2_decap_8
XFILLER_36_1208 VDD VSS / sg13g2_decap_8
XFILLER_36_1215 VDD VSS / sg13g2_decap_8
XFILLER_36_1222 VDD VSS / sg13g2_decap_8
XFILLER_36_1229 VDD VSS / sg13g2_decap_8
XFILLER_36_1236 VDD VSS / sg13g2_decap_8
XFILLER_36_1243 VDD VSS / sg13g2_decap_8
XFILLER_36_1250 VDD VSS / sg13g2_decap_8
XFILLER_36_1257 VDD VSS / sg13g2_decap_8
XFILLER_36_1264 VDD VSS / sg13g2_decap_8
XFILLER_36_1271 VDD VSS / sg13g2_decap_8
XFILLER_36_1278 VDD VSS / sg13g2_decap_8
XFILLER_36_1285 VDD VSS / sg13g2_decap_8
XFILLER_36_1292 VDD VSS / sg13g2_fill_2
XFILLER_36_1294 VDD VSS / sg13g2_fill_1
XFILLER_36_781 VDD VSS / sg13g2_decap_8
XFILLER_36_788 VDD VSS / sg13g2_decap_8
XFILLER_36_795 VDD VSS / sg13g2_decap_8
XFILLER_36_802 VDD VSS / sg13g2_decap_8
XFILLER_36_809 VDD VSS / sg13g2_decap_8
XFILLER_36_816 VDD VSS / sg13g2_decap_8
XFILLER_36_823 VDD VSS / sg13g2_decap_8
XFILLER_36_830 VDD VSS / sg13g2_decap_8
XFILLER_36_837 VDD VSS / sg13g2_decap_8
XFILLER_36_844 VDD VSS / sg13g2_decap_8
XFILLER_36_851 VDD VSS / sg13g2_decap_8
XFILLER_36_858 VDD VSS / sg13g2_decap_8
XFILLER_36_865 VDD VSS / sg13g2_decap_8
XFILLER_36_872 VDD VSS / sg13g2_decap_8
XFILLER_36_879 VDD VSS / sg13g2_decap_8
XFILLER_36_886 VDD VSS / sg13g2_decap_8
XFILLER_36_893 VDD VSS / sg13g2_decap_8
XFILLER_36_900 VDD VSS / sg13g2_decap_8
XFILLER_36_907 VDD VSS / sg13g2_decap_8
XFILLER_36_914 VDD VSS / sg13g2_decap_8
XFILLER_36_921 VDD VSS / sg13g2_decap_8
XFILLER_36_928 VDD VSS / sg13g2_decap_8
XFILLER_36_935 VDD VSS / sg13g2_decap_8
XFILLER_36_942 VDD VSS / sg13g2_decap_8
XFILLER_36_949 VDD VSS / sg13g2_decap_8
XFILLER_36_956 VDD VSS / sg13g2_decap_8
XFILLER_36_963 VDD VSS / sg13g2_decap_8
XFILLER_36_970 VDD VSS / sg13g2_decap_8
XFILLER_36_977 VDD VSS / sg13g2_decap_8
XFILLER_36_984 VDD VSS / sg13g2_decap_8
XFILLER_36_991 VDD VSS / sg13g2_decap_8
XFILLER_36_998 VDD VSS / sg13g2_decap_8
XFILLER_37_1005 VDD VSS / sg13g2_decap_8
XFILLER_37_1012 VDD VSS / sg13g2_decap_8
XFILLER_37_1019 VDD VSS / sg13g2_decap_8
XFILLER_37_1026 VDD VSS / sg13g2_decap_8
XFILLER_37_1033 VDD VSS / sg13g2_decap_8
XFILLER_37_1040 VDD VSS / sg13g2_decap_8
XFILLER_37_1047 VDD VSS / sg13g2_decap_8
XFILLER_37_1054 VDD VSS / sg13g2_decap_8
XFILLER_37_1061 VDD VSS / sg13g2_decap_8
XFILLER_37_1068 VDD VSS / sg13g2_decap_8
XFILLER_37_1075 VDD VSS / sg13g2_decap_8
XFILLER_37_1082 VDD VSS / sg13g2_decap_8
XFILLER_37_1089 VDD VSS / sg13g2_decap_8
XFILLER_37_1096 VDD VSS / sg13g2_decap_8
XFILLER_37_1103 VDD VSS / sg13g2_decap_8
XFILLER_37_1110 VDD VSS / sg13g2_decap_8
XFILLER_37_1117 VDD VSS / sg13g2_decap_8
XFILLER_37_1124 VDD VSS / sg13g2_decap_8
XFILLER_37_1131 VDD VSS / sg13g2_decap_8
XFILLER_37_1138 VDD VSS / sg13g2_decap_8
XFILLER_37_1145 VDD VSS / sg13g2_decap_8
XFILLER_37_1152 VDD VSS / sg13g2_decap_8
XFILLER_37_1159 VDD VSS / sg13g2_decap_8
XFILLER_37_1166 VDD VSS / sg13g2_decap_8
XFILLER_37_1173 VDD VSS / sg13g2_decap_8
XFILLER_37_1180 VDD VSS / sg13g2_decap_8
XFILLER_37_1187 VDD VSS / sg13g2_decap_8
XFILLER_37_1194 VDD VSS / sg13g2_decap_8
XFILLER_37_1201 VDD VSS / sg13g2_decap_8
XFILLER_37_1208 VDD VSS / sg13g2_decap_8
XFILLER_37_1215 VDD VSS / sg13g2_decap_8
XFILLER_37_1222 VDD VSS / sg13g2_decap_8
XFILLER_37_1229 VDD VSS / sg13g2_decap_8
XFILLER_37_1236 VDD VSS / sg13g2_decap_8
XFILLER_37_1243 VDD VSS / sg13g2_decap_8
XFILLER_37_1250 VDD VSS / sg13g2_decap_8
XFILLER_37_1257 VDD VSS / sg13g2_decap_8
XFILLER_37_1264 VDD VSS / sg13g2_decap_8
XFILLER_37_1271 VDD VSS / sg13g2_decap_8
XFILLER_37_1278 VDD VSS / sg13g2_decap_8
XFILLER_37_1285 VDD VSS / sg13g2_decap_8
XFILLER_37_1292 VDD VSS / sg13g2_fill_2
XFILLER_37_1294 VDD VSS / sg13g2_fill_1
XFILLER_37_781 VDD VSS / sg13g2_decap_8
XFILLER_37_788 VDD VSS / sg13g2_decap_8
XFILLER_37_795 VDD VSS / sg13g2_decap_8
XFILLER_37_802 VDD VSS / sg13g2_decap_8
XFILLER_37_809 VDD VSS / sg13g2_decap_8
XFILLER_37_816 VDD VSS / sg13g2_decap_8
XFILLER_37_823 VDD VSS / sg13g2_decap_8
XFILLER_37_830 VDD VSS / sg13g2_decap_8
XFILLER_37_837 VDD VSS / sg13g2_decap_8
XFILLER_37_844 VDD VSS / sg13g2_decap_8
XFILLER_37_851 VDD VSS / sg13g2_decap_8
XFILLER_37_858 VDD VSS / sg13g2_decap_8
XFILLER_37_865 VDD VSS / sg13g2_decap_8
XFILLER_37_872 VDD VSS / sg13g2_decap_8
XFILLER_37_879 VDD VSS / sg13g2_decap_8
XFILLER_37_886 VDD VSS / sg13g2_decap_8
XFILLER_37_893 VDD VSS / sg13g2_decap_8
XFILLER_37_900 VDD VSS / sg13g2_decap_8
XFILLER_37_907 VDD VSS / sg13g2_decap_8
XFILLER_37_914 VDD VSS / sg13g2_decap_8
XFILLER_37_921 VDD VSS / sg13g2_decap_8
XFILLER_37_928 VDD VSS / sg13g2_decap_8
XFILLER_37_935 VDD VSS / sg13g2_decap_8
XFILLER_37_942 VDD VSS / sg13g2_decap_8
XFILLER_37_949 VDD VSS / sg13g2_decap_8
XFILLER_37_956 VDD VSS / sg13g2_decap_8
XFILLER_37_963 VDD VSS / sg13g2_decap_8
XFILLER_37_970 VDD VSS / sg13g2_decap_8
XFILLER_37_977 VDD VSS / sg13g2_decap_8
XFILLER_37_984 VDD VSS / sg13g2_decap_8
XFILLER_37_991 VDD VSS / sg13g2_decap_8
XFILLER_37_998 VDD VSS / sg13g2_decap_8
XFILLER_38_1005 VDD VSS / sg13g2_decap_8
XFILLER_38_1012 VDD VSS / sg13g2_decap_8
XFILLER_38_1019 VDD VSS / sg13g2_decap_8
XFILLER_38_1026 VDD VSS / sg13g2_decap_8
XFILLER_38_1033 VDD VSS / sg13g2_decap_8
XFILLER_38_1040 VDD VSS / sg13g2_decap_8
XFILLER_38_1047 VDD VSS / sg13g2_decap_8
XFILLER_38_1054 VDD VSS / sg13g2_decap_8
XFILLER_38_1061 VDD VSS / sg13g2_decap_8
XFILLER_38_1068 VDD VSS / sg13g2_decap_8
XFILLER_38_1075 VDD VSS / sg13g2_decap_8
XFILLER_38_1082 VDD VSS / sg13g2_decap_8
XFILLER_38_1089 VDD VSS / sg13g2_decap_8
XFILLER_38_1096 VDD VSS / sg13g2_decap_8
XFILLER_38_1103 VDD VSS / sg13g2_decap_8
XFILLER_38_1110 VDD VSS / sg13g2_decap_8
XFILLER_38_1117 VDD VSS / sg13g2_decap_8
XFILLER_38_1124 VDD VSS / sg13g2_decap_8
XFILLER_38_1131 VDD VSS / sg13g2_decap_8
XFILLER_38_1138 VDD VSS / sg13g2_decap_8
XFILLER_38_1145 VDD VSS / sg13g2_decap_8
XFILLER_38_1152 VDD VSS / sg13g2_decap_8
XFILLER_38_1159 VDD VSS / sg13g2_decap_8
XFILLER_38_1166 VDD VSS / sg13g2_decap_8
XFILLER_38_1173 VDD VSS / sg13g2_decap_8
XFILLER_38_1180 VDD VSS / sg13g2_decap_8
XFILLER_38_1187 VDD VSS / sg13g2_decap_8
XFILLER_38_1194 VDD VSS / sg13g2_decap_8
XFILLER_38_1201 VDD VSS / sg13g2_decap_8
XFILLER_38_1208 VDD VSS / sg13g2_decap_8
XFILLER_38_1215 VDD VSS / sg13g2_decap_8
XFILLER_38_1222 VDD VSS / sg13g2_decap_8
XFILLER_38_1229 VDD VSS / sg13g2_decap_8
XFILLER_38_1236 VDD VSS / sg13g2_decap_8
XFILLER_38_1243 VDD VSS / sg13g2_decap_8
XFILLER_38_1250 VDD VSS / sg13g2_decap_8
XFILLER_38_1257 VDD VSS / sg13g2_decap_8
XFILLER_38_1264 VDD VSS / sg13g2_decap_8
XFILLER_38_1271 VDD VSS / sg13g2_decap_8
XFILLER_38_1278 VDD VSS / sg13g2_decap_8
XFILLER_38_1285 VDD VSS / sg13g2_decap_8
XFILLER_38_1292 VDD VSS / sg13g2_fill_2
XFILLER_38_1294 VDD VSS / sg13g2_fill_1
XFILLER_38_781 VDD VSS / sg13g2_decap_8
XFILLER_38_788 VDD VSS / sg13g2_decap_8
XFILLER_38_795 VDD VSS / sg13g2_decap_8
XFILLER_38_802 VDD VSS / sg13g2_decap_8
XFILLER_38_809 VDD VSS / sg13g2_decap_8
XFILLER_38_816 VDD VSS / sg13g2_decap_8
XFILLER_38_823 VDD VSS / sg13g2_decap_8
XFILLER_38_830 VDD VSS / sg13g2_decap_8
XFILLER_38_837 VDD VSS / sg13g2_decap_8
XFILLER_38_844 VDD VSS / sg13g2_decap_8
XFILLER_38_851 VDD VSS / sg13g2_decap_8
XFILLER_38_858 VDD VSS / sg13g2_decap_8
XFILLER_38_865 VDD VSS / sg13g2_decap_8
XFILLER_38_872 VDD VSS / sg13g2_decap_8
XFILLER_38_879 VDD VSS / sg13g2_decap_8
XFILLER_38_886 VDD VSS / sg13g2_decap_8
XFILLER_38_893 VDD VSS / sg13g2_decap_8
XFILLER_38_900 VDD VSS / sg13g2_decap_8
XFILLER_38_907 VDD VSS / sg13g2_decap_8
XFILLER_38_914 VDD VSS / sg13g2_decap_8
XFILLER_38_921 VDD VSS / sg13g2_decap_8
XFILLER_38_928 VDD VSS / sg13g2_decap_8
XFILLER_38_935 VDD VSS / sg13g2_decap_8
XFILLER_38_942 VDD VSS / sg13g2_decap_8
XFILLER_38_949 VDD VSS / sg13g2_decap_8
XFILLER_38_956 VDD VSS / sg13g2_decap_8
XFILLER_38_963 VDD VSS / sg13g2_decap_8
XFILLER_38_970 VDD VSS / sg13g2_decap_8
XFILLER_38_977 VDD VSS / sg13g2_decap_8
XFILLER_38_984 VDD VSS / sg13g2_decap_8
XFILLER_38_991 VDD VSS / sg13g2_decap_8
XFILLER_38_998 VDD VSS / sg13g2_decap_8
XFILLER_39_1005 VDD VSS / sg13g2_decap_8
XFILLER_39_1012 VDD VSS / sg13g2_decap_8
XFILLER_39_1019 VDD VSS / sg13g2_decap_8
XFILLER_39_1026 VDD VSS / sg13g2_decap_8
XFILLER_39_1033 VDD VSS / sg13g2_decap_8
XFILLER_39_1040 VDD VSS / sg13g2_decap_8
XFILLER_39_1047 VDD VSS / sg13g2_decap_8
XFILLER_39_1054 VDD VSS / sg13g2_decap_8
XFILLER_39_1061 VDD VSS / sg13g2_decap_8
XFILLER_39_1068 VDD VSS / sg13g2_decap_8
XFILLER_39_1075 VDD VSS / sg13g2_decap_8
XFILLER_39_1082 VDD VSS / sg13g2_decap_8
XFILLER_39_1089 VDD VSS / sg13g2_decap_8
XFILLER_39_1096 VDD VSS / sg13g2_decap_8
XFILLER_39_1103 VDD VSS / sg13g2_decap_8
XFILLER_39_1110 VDD VSS / sg13g2_decap_8
XFILLER_39_1117 VDD VSS / sg13g2_decap_8
XFILLER_39_1124 VDD VSS / sg13g2_decap_8
XFILLER_39_1131 VDD VSS / sg13g2_decap_8
XFILLER_39_1138 VDD VSS / sg13g2_decap_8
XFILLER_39_1145 VDD VSS / sg13g2_decap_8
XFILLER_39_1152 VDD VSS / sg13g2_decap_8
XFILLER_39_1159 VDD VSS / sg13g2_decap_8
XFILLER_39_1166 VDD VSS / sg13g2_decap_8
XFILLER_39_1173 VDD VSS / sg13g2_decap_8
XFILLER_39_1180 VDD VSS / sg13g2_decap_8
XFILLER_39_1187 VDD VSS / sg13g2_decap_8
XFILLER_39_1194 VDD VSS / sg13g2_decap_8
XFILLER_39_1201 VDD VSS / sg13g2_decap_8
XFILLER_39_1208 VDD VSS / sg13g2_decap_8
XFILLER_39_1215 VDD VSS / sg13g2_decap_8
XFILLER_39_1222 VDD VSS / sg13g2_decap_8
XFILLER_39_1229 VDD VSS / sg13g2_decap_8
XFILLER_39_1236 VDD VSS / sg13g2_decap_8
XFILLER_39_1243 VDD VSS / sg13g2_decap_8
XFILLER_39_1250 VDD VSS / sg13g2_decap_8
XFILLER_39_1257 VDD VSS / sg13g2_decap_8
XFILLER_39_1264 VDD VSS / sg13g2_decap_8
XFILLER_39_1271 VDD VSS / sg13g2_decap_8
XFILLER_39_1278 VDD VSS / sg13g2_decap_8
XFILLER_39_1285 VDD VSS / sg13g2_decap_8
XFILLER_39_1292 VDD VSS / sg13g2_fill_2
XFILLER_39_1294 VDD VSS / sg13g2_fill_1
XFILLER_39_781 VDD VSS / sg13g2_decap_8
XFILLER_39_788 VDD VSS / sg13g2_decap_8
XFILLER_39_795 VDD VSS / sg13g2_decap_8
XFILLER_39_802 VDD VSS / sg13g2_decap_8
XFILLER_39_809 VDD VSS / sg13g2_decap_8
XFILLER_39_816 VDD VSS / sg13g2_decap_8
XFILLER_39_823 VDD VSS / sg13g2_decap_8
XFILLER_39_830 VDD VSS / sg13g2_decap_8
XFILLER_39_837 VDD VSS / sg13g2_decap_8
XFILLER_39_844 VDD VSS / sg13g2_decap_8
XFILLER_39_851 VDD VSS / sg13g2_decap_8
XFILLER_39_858 VDD VSS / sg13g2_decap_8
XFILLER_39_865 VDD VSS / sg13g2_decap_8
XFILLER_39_872 VDD VSS / sg13g2_decap_8
XFILLER_39_879 VDD VSS / sg13g2_decap_8
XFILLER_39_886 VDD VSS / sg13g2_decap_8
XFILLER_39_893 VDD VSS / sg13g2_decap_8
XFILLER_39_900 VDD VSS / sg13g2_decap_8
XFILLER_39_907 VDD VSS / sg13g2_decap_8
XFILLER_39_914 VDD VSS / sg13g2_decap_8
XFILLER_39_921 VDD VSS / sg13g2_decap_8
XFILLER_39_928 VDD VSS / sg13g2_decap_8
XFILLER_39_935 VDD VSS / sg13g2_decap_8
XFILLER_39_942 VDD VSS / sg13g2_decap_8
XFILLER_39_949 VDD VSS / sg13g2_decap_8
XFILLER_39_956 VDD VSS / sg13g2_decap_8
XFILLER_39_963 VDD VSS / sg13g2_decap_8
XFILLER_39_970 VDD VSS / sg13g2_decap_8
XFILLER_39_977 VDD VSS / sg13g2_decap_8
XFILLER_39_984 VDD VSS / sg13g2_decap_8
XFILLER_39_991 VDD VSS / sg13g2_decap_8
XFILLER_39_998 VDD VSS / sg13g2_decap_8
XFILLER_3_1006 VDD VSS / sg13g2_decap_8
XFILLER_3_1013 VDD VSS / sg13g2_decap_8
XFILLER_3_1020 VDD VSS / sg13g2_decap_8
XFILLER_3_1027 VDD VSS / sg13g2_decap_8
XFILLER_3_103 VDD VSS / sg13g2_decap_8
XFILLER_3_1034 VDD VSS / sg13g2_decap_8
XFILLER_3_1041 VDD VSS / sg13g2_decap_8
XFILLER_3_1048 VDD VSS / sg13g2_decap_8
XFILLER_3_1055 VDD VSS / sg13g2_decap_8
XFILLER_3_1062 VDD VSS / sg13g2_decap_8
XFILLER_3_1069 VDD VSS / sg13g2_decap_8
XFILLER_3_1076 VDD VSS / sg13g2_decap_8
XFILLER_3_1083 VDD VSS / sg13g2_decap_8
XFILLER_3_1090 VDD VSS / sg13g2_decap_8
XFILLER_3_1097 VDD VSS / sg13g2_decap_8
XFILLER_3_110 VDD VSS / sg13g2_decap_8
XFILLER_3_1104 VDD VSS / sg13g2_decap_8
XFILLER_3_1111 VDD VSS / sg13g2_decap_8
XFILLER_3_1118 VDD VSS / sg13g2_decap_8
XFILLER_3_1125 VDD VSS / sg13g2_decap_8
XFILLER_3_1132 VDD VSS / sg13g2_decap_8
XFILLER_3_1139 VDD VSS / sg13g2_decap_8
XFILLER_3_1146 VDD VSS / sg13g2_decap_8
XFILLER_3_1153 VDD VSS / sg13g2_decap_8
XFILLER_3_1160 VDD VSS / sg13g2_decap_8
XFILLER_3_1167 VDD VSS / sg13g2_decap_8
XFILLER_3_117 VDD VSS / sg13g2_decap_8
XFILLER_3_1174 VDD VSS / sg13g2_decap_8
XFILLER_3_1181 VDD VSS / sg13g2_decap_8
XFILLER_3_1188 VDD VSS / sg13g2_decap_8
XFILLER_3_1195 VDD VSS / sg13g2_decap_8
XFILLER_3_1202 VDD VSS / sg13g2_decap_8
XFILLER_3_1209 VDD VSS / sg13g2_decap_8
XFILLER_3_1216 VDD VSS / sg13g2_decap_8
XFILLER_3_1223 VDD VSS / sg13g2_decap_8
XFILLER_3_1230 VDD VSS / sg13g2_decap_8
XFILLER_3_1237 VDD VSS / sg13g2_decap_8
XFILLER_3_124 VDD VSS / sg13g2_decap_8
XFILLER_3_1244 VDD VSS / sg13g2_decap_8
XFILLER_3_1251 VDD VSS / sg13g2_decap_8
XFILLER_3_1258 VDD VSS / sg13g2_decap_8
XFILLER_3_1265 VDD VSS / sg13g2_decap_8
XFILLER_3_1272 VDD VSS / sg13g2_decap_8
XFILLER_3_1279 VDD VSS / sg13g2_decap_8
XFILLER_3_1286 VDD VSS / sg13g2_decap_8
XFILLER_3_1293 VDD VSS / sg13g2_fill_2
XFILLER_3_131 VDD VSS / sg13g2_decap_8
XFILLER_3_138 VDD VSS / sg13g2_decap_8
XFILLER_3_145 VDD VSS / sg13g2_decap_8
XFILLER_3_152 VDD VSS / sg13g2_decap_8
XFILLER_3_159 VDD VSS / sg13g2_decap_8
XFILLER_3_166 VDD VSS / sg13g2_decap_8
XFILLER_3_173 VDD VSS / sg13g2_decap_8
XFILLER_3_180 VDD VSS / sg13g2_decap_8
XFILLER_3_187 VDD VSS / sg13g2_decap_8
XFILLER_3_194 VDD VSS / sg13g2_decap_8
XFILLER_3_201 VDD VSS / sg13g2_decap_8
XFILLER_3_208 VDD VSS / sg13g2_decap_8
XFILLER_3_215 VDD VSS / sg13g2_decap_8
XFILLER_3_222 VDD VSS / sg13g2_decap_8
XFILLER_3_229 VDD VSS / sg13g2_decap_8
XFILLER_3_236 VDD VSS / sg13g2_decap_8
XFILLER_3_243 VDD VSS / sg13g2_decap_8
XFILLER_3_250 VDD VSS / sg13g2_decap_8
XFILLER_3_257 VDD VSS / sg13g2_decap_8
XFILLER_3_264 VDD VSS / sg13g2_decap_8
XFILLER_3_271 VDD VSS / sg13g2_decap_8
XFILLER_3_278 VDD VSS / sg13g2_decap_8
XFILLER_3_285 VDD VSS / sg13g2_decap_8
XFILLER_3_292 VDD VSS / sg13g2_decap_8
XFILLER_3_299 VDD VSS / sg13g2_decap_8
XFILLER_3_306 VDD VSS / sg13g2_decap_8
XFILLER_3_313 VDD VSS / sg13g2_decap_8
XFILLER_3_320 VDD VSS / sg13g2_decap_8
XFILLER_3_327 VDD VSS / sg13g2_decap_8
XFILLER_3_334 VDD VSS / sg13g2_decap_8
XFILLER_3_341 VDD VSS / sg13g2_decap_8
XFILLER_3_348 VDD VSS / sg13g2_decap_8
XFILLER_3_355 VDD VSS / sg13g2_decap_8
XFILLER_3_362 VDD VSS / sg13g2_decap_8
XFILLER_3_369 VDD VSS / sg13g2_decap_8
XFILLER_3_376 VDD VSS / sg13g2_decap_8
XFILLER_3_383 VDD VSS / sg13g2_decap_8
XFILLER_3_390 VDD VSS / sg13g2_decap_8
XFILLER_3_397 VDD VSS / sg13g2_decap_8
XFILLER_3_404 VDD VSS / sg13g2_decap_8
XFILLER_3_411 VDD VSS / sg13g2_decap_8
XFILLER_3_418 VDD VSS / sg13g2_decap_8
XFILLER_3_425 VDD VSS / sg13g2_decap_8
XFILLER_3_432 VDD VSS / sg13g2_decap_8
XFILLER_3_439 VDD VSS / sg13g2_decap_8
XFILLER_3_446 VDD VSS / sg13g2_decap_8
XFILLER_3_453 VDD VSS / sg13g2_decap_8
XFILLER_3_460 VDD VSS / sg13g2_decap_8
XFILLER_3_467 VDD VSS / sg13g2_decap_8
XFILLER_3_474 VDD VSS / sg13g2_decap_8
XFILLER_3_481 VDD VSS / sg13g2_decap_8
XFILLER_3_488 VDD VSS / sg13g2_decap_8
XFILLER_3_495 VDD VSS / sg13g2_decap_8
XFILLER_3_502 VDD VSS / sg13g2_decap_8
XFILLER_3_509 VDD VSS / sg13g2_decap_8
XFILLER_3_516 VDD VSS / sg13g2_decap_8
XFILLER_3_523 VDD VSS / sg13g2_decap_8
XFILLER_3_530 VDD VSS / sg13g2_decap_8
XFILLER_3_537 VDD VSS / sg13g2_decap_8
XFILLER_3_544 VDD VSS / sg13g2_decap_8
XFILLER_3_551 VDD VSS / sg13g2_decap_8
XFILLER_3_558 VDD VSS / sg13g2_decap_8
XFILLER_3_565 VDD VSS / sg13g2_decap_8
XFILLER_3_572 VDD VSS / sg13g2_decap_8
XFILLER_3_579 VDD VSS / sg13g2_decap_8
XFILLER_3_586 VDD VSS / sg13g2_decap_8
XFILLER_3_593 VDD VSS / sg13g2_decap_8
XFILLER_3_600 VDD VSS / sg13g2_decap_8
XFILLER_3_607 VDD VSS / sg13g2_decap_8
XFILLER_3_614 VDD VSS / sg13g2_decap_8
XFILLER_3_621 VDD VSS / sg13g2_decap_8
XFILLER_3_628 VDD VSS / sg13g2_decap_8
XFILLER_3_635 VDD VSS / sg13g2_decap_8
XFILLER_3_642 VDD VSS / sg13g2_decap_8
XFILLER_3_649 VDD VSS / sg13g2_decap_8
XFILLER_3_656 VDD VSS / sg13g2_decap_8
XFILLER_3_663 VDD VSS / sg13g2_decap_8
XFILLER_3_670 VDD VSS / sg13g2_decap_8
XFILLER_3_677 VDD VSS / sg13g2_decap_8
XFILLER_3_684 VDD VSS / sg13g2_decap_8
XFILLER_3_691 VDD VSS / sg13g2_decap_8
XFILLER_3_698 VDD VSS / sg13g2_decap_8
XFILLER_3_705 VDD VSS / sg13g2_decap_8
XFILLER_3_712 VDD VSS / sg13g2_decap_8
XFILLER_3_719 VDD VSS / sg13g2_decap_8
XFILLER_3_726 VDD VSS / sg13g2_decap_8
XFILLER_3_733 VDD VSS / sg13g2_decap_8
XFILLER_3_740 VDD VSS / sg13g2_decap_8
XFILLER_3_747 VDD VSS / sg13g2_decap_8
XFILLER_3_754 VDD VSS / sg13g2_decap_8
XFILLER_3_761 VDD VSS / sg13g2_decap_8
XFILLER_3_768 VDD VSS / sg13g2_decap_8
XFILLER_3_775 VDD VSS / sg13g2_decap_8
XFILLER_3_782 VDD VSS / sg13g2_decap_8
XFILLER_3_789 VDD VSS / sg13g2_decap_8
XFILLER_3_796 VDD VSS / sg13g2_decap_8
XFILLER_3_803 VDD VSS / sg13g2_decap_8
XFILLER_3_810 VDD VSS / sg13g2_decap_8
XFILLER_3_817 VDD VSS / sg13g2_decap_8
XFILLER_3_824 VDD VSS / sg13g2_decap_8
XFILLER_3_831 VDD VSS / sg13g2_decap_8
XFILLER_3_838 VDD VSS / sg13g2_decap_8
XFILLER_3_845 VDD VSS / sg13g2_decap_8
XFILLER_3_852 VDD VSS / sg13g2_decap_8
XFILLER_3_859 VDD VSS / sg13g2_decap_8
XFILLER_3_866 VDD VSS / sg13g2_decap_8
XFILLER_3_873 VDD VSS / sg13g2_decap_8
XFILLER_3_880 VDD VSS / sg13g2_decap_8
XFILLER_3_887 VDD VSS / sg13g2_decap_8
XFILLER_3_89 VDD VSS / sg13g2_decap_8
XFILLER_3_894 VDD VSS / sg13g2_decap_8
XFILLER_3_901 VDD VSS / sg13g2_decap_8
XFILLER_3_908 VDD VSS / sg13g2_decap_8
XFILLER_3_915 VDD VSS / sg13g2_decap_8
XFILLER_3_922 VDD VSS / sg13g2_decap_8
XFILLER_3_929 VDD VSS / sg13g2_decap_8
XFILLER_3_936 VDD VSS / sg13g2_decap_8
XFILLER_3_943 VDD VSS / sg13g2_decap_8
XFILLER_3_950 VDD VSS / sg13g2_decap_8
XFILLER_3_957 VDD VSS / sg13g2_decap_8
XFILLER_3_96 VDD VSS / sg13g2_decap_8
XFILLER_3_964 VDD VSS / sg13g2_decap_8
XFILLER_3_971 VDD VSS / sg13g2_decap_8
XFILLER_3_978 VDD VSS / sg13g2_decap_8
XFILLER_3_985 VDD VSS / sg13g2_decap_8
XFILLER_3_992 VDD VSS / sg13g2_decap_8
XFILLER_3_999 VDD VSS / sg13g2_decap_8
XFILLER_40_1005 VDD VSS / sg13g2_decap_8
XFILLER_40_1012 VDD VSS / sg13g2_decap_8
XFILLER_40_1019 VDD VSS / sg13g2_decap_8
XFILLER_40_1026 VDD VSS / sg13g2_decap_8
XFILLER_40_1033 VDD VSS / sg13g2_decap_8
XFILLER_40_1040 VDD VSS / sg13g2_decap_8
XFILLER_40_1047 VDD VSS / sg13g2_decap_8
XFILLER_40_1054 VDD VSS / sg13g2_decap_8
XFILLER_40_1061 VDD VSS / sg13g2_decap_8
XFILLER_40_1068 VDD VSS / sg13g2_decap_8
XFILLER_40_1075 VDD VSS / sg13g2_decap_8
XFILLER_40_1082 VDD VSS / sg13g2_decap_8
XFILLER_40_1089 VDD VSS / sg13g2_decap_8
XFILLER_40_1096 VDD VSS / sg13g2_decap_8
XFILLER_40_1103 VDD VSS / sg13g2_decap_8
XFILLER_40_1110 VDD VSS / sg13g2_decap_8
XFILLER_40_1117 VDD VSS / sg13g2_decap_8
XFILLER_40_1124 VDD VSS / sg13g2_decap_8
XFILLER_40_1131 VDD VSS / sg13g2_decap_8
XFILLER_40_1138 VDD VSS / sg13g2_decap_8
XFILLER_40_1145 VDD VSS / sg13g2_decap_8
XFILLER_40_1152 VDD VSS / sg13g2_decap_8
XFILLER_40_1159 VDD VSS / sg13g2_decap_8
XFILLER_40_1166 VDD VSS / sg13g2_decap_8
XFILLER_40_1173 VDD VSS / sg13g2_decap_8
XFILLER_40_1180 VDD VSS / sg13g2_decap_8
XFILLER_40_1187 VDD VSS / sg13g2_decap_8
XFILLER_40_1194 VDD VSS / sg13g2_decap_8
XFILLER_40_1201 VDD VSS / sg13g2_decap_8
XFILLER_40_1208 VDD VSS / sg13g2_decap_8
XFILLER_40_1215 VDD VSS / sg13g2_decap_8
XFILLER_40_1222 VDD VSS / sg13g2_decap_8
XFILLER_40_1229 VDD VSS / sg13g2_decap_8
XFILLER_40_1236 VDD VSS / sg13g2_decap_8
XFILLER_40_1243 VDD VSS / sg13g2_decap_8
XFILLER_40_1250 VDD VSS / sg13g2_decap_8
XFILLER_40_1257 VDD VSS / sg13g2_decap_8
XFILLER_40_1264 VDD VSS / sg13g2_decap_8
XFILLER_40_1271 VDD VSS / sg13g2_decap_8
XFILLER_40_1278 VDD VSS / sg13g2_decap_8
XFILLER_40_1285 VDD VSS / sg13g2_decap_8
XFILLER_40_1292 VDD VSS / sg13g2_fill_2
XFILLER_40_1294 VDD VSS / sg13g2_fill_1
XFILLER_40_781 VDD VSS / sg13g2_decap_8
XFILLER_40_788 VDD VSS / sg13g2_decap_8
XFILLER_40_795 VDD VSS / sg13g2_decap_8
XFILLER_40_802 VDD VSS / sg13g2_decap_8
XFILLER_40_809 VDD VSS / sg13g2_decap_8
XFILLER_40_816 VDD VSS / sg13g2_decap_8
XFILLER_40_823 VDD VSS / sg13g2_decap_8
XFILLER_40_830 VDD VSS / sg13g2_decap_8
XFILLER_40_837 VDD VSS / sg13g2_decap_8
XFILLER_40_844 VDD VSS / sg13g2_decap_8
XFILLER_40_851 VDD VSS / sg13g2_decap_8
XFILLER_40_858 VDD VSS / sg13g2_decap_8
XFILLER_40_865 VDD VSS / sg13g2_decap_8
XFILLER_40_872 VDD VSS / sg13g2_decap_8
XFILLER_40_879 VDD VSS / sg13g2_decap_8
XFILLER_40_886 VDD VSS / sg13g2_decap_8
XFILLER_40_893 VDD VSS / sg13g2_decap_8
XFILLER_40_900 VDD VSS / sg13g2_decap_8
XFILLER_40_907 VDD VSS / sg13g2_decap_8
XFILLER_40_914 VDD VSS / sg13g2_decap_8
XFILLER_40_921 VDD VSS / sg13g2_decap_8
XFILLER_40_928 VDD VSS / sg13g2_decap_8
XFILLER_40_935 VDD VSS / sg13g2_decap_8
XFILLER_40_942 VDD VSS / sg13g2_decap_8
XFILLER_40_949 VDD VSS / sg13g2_decap_8
XFILLER_40_956 VDD VSS / sg13g2_decap_8
XFILLER_40_963 VDD VSS / sg13g2_decap_8
XFILLER_40_970 VDD VSS / sg13g2_decap_8
XFILLER_40_977 VDD VSS / sg13g2_decap_8
XFILLER_40_984 VDD VSS / sg13g2_decap_8
XFILLER_40_991 VDD VSS / sg13g2_decap_8
XFILLER_40_998 VDD VSS / sg13g2_decap_8
XFILLER_41_1005 VDD VSS / sg13g2_decap_8
XFILLER_41_1012 VDD VSS / sg13g2_decap_8
XFILLER_41_1019 VDD VSS / sg13g2_decap_8
XFILLER_41_1026 VDD VSS / sg13g2_decap_8
XFILLER_41_1033 VDD VSS / sg13g2_decap_8
XFILLER_41_1040 VDD VSS / sg13g2_decap_8
XFILLER_41_1047 VDD VSS / sg13g2_decap_8
XFILLER_41_1054 VDD VSS / sg13g2_decap_8
XFILLER_41_1061 VDD VSS / sg13g2_decap_8
XFILLER_41_1068 VDD VSS / sg13g2_decap_8
XFILLER_41_1075 VDD VSS / sg13g2_decap_8
XFILLER_41_1082 VDD VSS / sg13g2_decap_8
XFILLER_41_1089 VDD VSS / sg13g2_decap_8
XFILLER_41_1096 VDD VSS / sg13g2_decap_8
XFILLER_41_1103 VDD VSS / sg13g2_decap_8
XFILLER_41_1110 VDD VSS / sg13g2_decap_8
XFILLER_41_1117 VDD VSS / sg13g2_decap_8
XFILLER_41_1124 VDD VSS / sg13g2_decap_8
XFILLER_41_1131 VDD VSS / sg13g2_decap_8
XFILLER_41_1138 VDD VSS / sg13g2_decap_8
XFILLER_41_1145 VDD VSS / sg13g2_decap_8
XFILLER_41_1152 VDD VSS / sg13g2_decap_8
XFILLER_41_1159 VDD VSS / sg13g2_decap_8
XFILLER_41_1166 VDD VSS / sg13g2_decap_8
XFILLER_41_1173 VDD VSS / sg13g2_decap_8
XFILLER_41_1180 VDD VSS / sg13g2_decap_8
XFILLER_41_1187 VDD VSS / sg13g2_decap_8
XFILLER_41_1194 VDD VSS / sg13g2_decap_8
XFILLER_41_1201 VDD VSS / sg13g2_decap_8
XFILLER_41_1208 VDD VSS / sg13g2_decap_8
XFILLER_41_1215 VDD VSS / sg13g2_decap_8
XFILLER_41_1222 VDD VSS / sg13g2_decap_8
XFILLER_41_1229 VDD VSS / sg13g2_decap_8
XFILLER_41_1236 VDD VSS / sg13g2_decap_8
XFILLER_41_1243 VDD VSS / sg13g2_decap_8
XFILLER_41_1250 VDD VSS / sg13g2_decap_8
XFILLER_41_1257 VDD VSS / sg13g2_decap_8
XFILLER_41_1264 VDD VSS / sg13g2_decap_8
XFILLER_41_1271 VDD VSS / sg13g2_decap_8
XFILLER_41_1278 VDD VSS / sg13g2_decap_8
XFILLER_41_1285 VDD VSS / sg13g2_decap_8
XFILLER_41_1292 VDD VSS / sg13g2_fill_2
XFILLER_41_1294 VDD VSS / sg13g2_fill_1
XFILLER_41_781 VDD VSS / sg13g2_decap_8
XFILLER_41_788 VDD VSS / sg13g2_decap_8
XFILLER_41_795 VDD VSS / sg13g2_decap_8
XFILLER_41_802 VDD VSS / sg13g2_decap_8
XFILLER_41_809 VDD VSS / sg13g2_decap_8
XFILLER_41_816 VDD VSS / sg13g2_decap_8
XFILLER_41_823 VDD VSS / sg13g2_decap_8
XFILLER_41_830 VDD VSS / sg13g2_decap_8
XFILLER_41_837 VDD VSS / sg13g2_decap_8
XFILLER_41_844 VDD VSS / sg13g2_decap_8
XFILLER_41_851 VDD VSS / sg13g2_decap_8
XFILLER_41_858 VDD VSS / sg13g2_decap_8
XFILLER_41_865 VDD VSS / sg13g2_decap_8
XFILLER_41_872 VDD VSS / sg13g2_decap_8
XFILLER_41_879 VDD VSS / sg13g2_decap_8
XFILLER_41_886 VDD VSS / sg13g2_decap_8
XFILLER_41_893 VDD VSS / sg13g2_decap_8
XFILLER_41_900 VDD VSS / sg13g2_decap_8
XFILLER_41_907 VDD VSS / sg13g2_decap_8
XFILLER_41_914 VDD VSS / sg13g2_decap_8
XFILLER_41_921 VDD VSS / sg13g2_decap_8
XFILLER_41_928 VDD VSS / sg13g2_decap_8
XFILLER_41_935 VDD VSS / sg13g2_decap_8
XFILLER_41_942 VDD VSS / sg13g2_decap_8
XFILLER_41_949 VDD VSS / sg13g2_decap_8
XFILLER_41_956 VDD VSS / sg13g2_decap_8
XFILLER_41_963 VDD VSS / sg13g2_decap_8
XFILLER_41_970 VDD VSS / sg13g2_decap_8
XFILLER_41_977 VDD VSS / sg13g2_decap_8
XFILLER_41_984 VDD VSS / sg13g2_decap_8
XFILLER_41_991 VDD VSS / sg13g2_decap_8
XFILLER_41_998 VDD VSS / sg13g2_decap_8
XFILLER_42_1005 VDD VSS / sg13g2_decap_8
XFILLER_42_1012 VDD VSS / sg13g2_decap_8
XFILLER_42_1019 VDD VSS / sg13g2_decap_8
XFILLER_42_1026 VDD VSS / sg13g2_decap_8
XFILLER_42_1033 VDD VSS / sg13g2_decap_8
XFILLER_42_1040 VDD VSS / sg13g2_decap_8
XFILLER_42_1047 VDD VSS / sg13g2_decap_8
XFILLER_42_1054 VDD VSS / sg13g2_decap_8
XFILLER_42_1061 VDD VSS / sg13g2_decap_8
XFILLER_42_1068 VDD VSS / sg13g2_decap_8
XFILLER_42_1075 VDD VSS / sg13g2_decap_8
XFILLER_42_1082 VDD VSS / sg13g2_decap_8
XFILLER_42_1089 VDD VSS / sg13g2_decap_8
XFILLER_42_1096 VDD VSS / sg13g2_decap_8
XFILLER_42_1103 VDD VSS / sg13g2_decap_8
XFILLER_42_1110 VDD VSS / sg13g2_decap_8
XFILLER_42_1117 VDD VSS / sg13g2_decap_8
XFILLER_42_1124 VDD VSS / sg13g2_decap_8
XFILLER_42_1131 VDD VSS / sg13g2_decap_8
XFILLER_42_1138 VDD VSS / sg13g2_decap_8
XFILLER_42_1145 VDD VSS / sg13g2_decap_8
XFILLER_42_1152 VDD VSS / sg13g2_decap_8
XFILLER_42_1159 VDD VSS / sg13g2_decap_8
XFILLER_42_1166 VDD VSS / sg13g2_decap_8
XFILLER_42_1173 VDD VSS / sg13g2_decap_8
XFILLER_42_1180 VDD VSS / sg13g2_decap_8
XFILLER_42_1187 VDD VSS / sg13g2_decap_8
XFILLER_42_1194 VDD VSS / sg13g2_decap_8
XFILLER_42_1201 VDD VSS / sg13g2_decap_8
XFILLER_42_1208 VDD VSS / sg13g2_decap_8
XFILLER_42_1215 VDD VSS / sg13g2_decap_8
XFILLER_42_1222 VDD VSS / sg13g2_decap_8
XFILLER_42_1229 VDD VSS / sg13g2_decap_8
XFILLER_42_1236 VDD VSS / sg13g2_decap_8
XFILLER_42_1243 VDD VSS / sg13g2_decap_8
XFILLER_42_1250 VDD VSS / sg13g2_decap_8
XFILLER_42_1257 VDD VSS / sg13g2_decap_8
XFILLER_42_1264 VDD VSS / sg13g2_decap_8
XFILLER_42_1271 VDD VSS / sg13g2_decap_8
XFILLER_42_1278 VDD VSS / sg13g2_decap_8
XFILLER_42_1285 VDD VSS / sg13g2_decap_8
XFILLER_42_1292 VDD VSS / sg13g2_fill_2
XFILLER_42_1294 VDD VSS / sg13g2_fill_1
XFILLER_42_781 VDD VSS / sg13g2_decap_8
XFILLER_42_788 VDD VSS / sg13g2_decap_8
XFILLER_42_795 VDD VSS / sg13g2_decap_8
XFILLER_42_802 VDD VSS / sg13g2_decap_8
XFILLER_42_809 VDD VSS / sg13g2_decap_8
XFILLER_42_816 VDD VSS / sg13g2_decap_8
XFILLER_42_823 VDD VSS / sg13g2_decap_8
XFILLER_42_830 VDD VSS / sg13g2_decap_8
XFILLER_42_837 VDD VSS / sg13g2_decap_8
XFILLER_42_844 VDD VSS / sg13g2_decap_8
XFILLER_42_851 VDD VSS / sg13g2_decap_8
XFILLER_42_858 VDD VSS / sg13g2_decap_8
XFILLER_42_865 VDD VSS / sg13g2_decap_8
XFILLER_42_872 VDD VSS / sg13g2_decap_8
XFILLER_42_879 VDD VSS / sg13g2_decap_8
XFILLER_42_886 VDD VSS / sg13g2_decap_8
XFILLER_42_893 VDD VSS / sg13g2_decap_8
XFILLER_42_900 VDD VSS / sg13g2_decap_8
XFILLER_42_907 VDD VSS / sg13g2_decap_8
XFILLER_42_914 VDD VSS / sg13g2_decap_8
XFILLER_42_921 VDD VSS / sg13g2_decap_8
XFILLER_42_928 VDD VSS / sg13g2_decap_8
XFILLER_42_935 VDD VSS / sg13g2_decap_8
XFILLER_42_942 VDD VSS / sg13g2_decap_8
XFILLER_42_949 VDD VSS / sg13g2_decap_8
XFILLER_42_956 VDD VSS / sg13g2_decap_8
XFILLER_42_963 VDD VSS / sg13g2_decap_8
XFILLER_42_970 VDD VSS / sg13g2_decap_8
XFILLER_42_977 VDD VSS / sg13g2_decap_8
XFILLER_42_984 VDD VSS / sg13g2_decap_8
XFILLER_42_991 VDD VSS / sg13g2_decap_8
XFILLER_42_998 VDD VSS / sg13g2_decap_8
XFILLER_43_1005 VDD VSS / sg13g2_decap_8
XFILLER_43_1012 VDD VSS / sg13g2_decap_8
XFILLER_43_1019 VDD VSS / sg13g2_decap_8
XFILLER_43_1026 VDD VSS / sg13g2_decap_8
XFILLER_43_1033 VDD VSS / sg13g2_decap_8
XFILLER_43_1040 VDD VSS / sg13g2_decap_8
XFILLER_43_1047 VDD VSS / sg13g2_decap_8
XFILLER_43_1054 VDD VSS / sg13g2_decap_8
XFILLER_43_1061 VDD VSS / sg13g2_decap_8
XFILLER_43_1068 VDD VSS / sg13g2_decap_8
XFILLER_43_1075 VDD VSS / sg13g2_decap_8
XFILLER_43_1082 VDD VSS / sg13g2_decap_8
XFILLER_43_1089 VDD VSS / sg13g2_decap_8
XFILLER_43_1096 VDD VSS / sg13g2_decap_8
XFILLER_43_1103 VDD VSS / sg13g2_decap_8
XFILLER_43_1110 VDD VSS / sg13g2_decap_8
XFILLER_43_1117 VDD VSS / sg13g2_decap_8
XFILLER_43_1124 VDD VSS / sg13g2_decap_8
XFILLER_43_1131 VDD VSS / sg13g2_decap_8
XFILLER_43_1138 VDD VSS / sg13g2_decap_8
XFILLER_43_1145 VDD VSS / sg13g2_decap_8
XFILLER_43_1152 VDD VSS / sg13g2_decap_8
XFILLER_43_1159 VDD VSS / sg13g2_decap_8
XFILLER_43_1166 VDD VSS / sg13g2_decap_8
XFILLER_43_1173 VDD VSS / sg13g2_decap_8
XFILLER_43_1180 VDD VSS / sg13g2_decap_8
XFILLER_43_1187 VDD VSS / sg13g2_decap_8
XFILLER_43_1194 VDD VSS / sg13g2_decap_8
XFILLER_43_1201 VDD VSS / sg13g2_decap_8
XFILLER_43_1208 VDD VSS / sg13g2_decap_8
XFILLER_43_1215 VDD VSS / sg13g2_decap_8
XFILLER_43_1222 VDD VSS / sg13g2_decap_8
XFILLER_43_1229 VDD VSS / sg13g2_decap_8
XFILLER_43_1236 VDD VSS / sg13g2_decap_8
XFILLER_43_1243 VDD VSS / sg13g2_decap_8
XFILLER_43_1250 VDD VSS / sg13g2_decap_8
XFILLER_43_1257 VDD VSS / sg13g2_decap_8
XFILLER_43_1264 VDD VSS / sg13g2_decap_8
XFILLER_43_1271 VDD VSS / sg13g2_decap_8
XFILLER_43_1278 VDD VSS / sg13g2_decap_8
XFILLER_43_1285 VDD VSS / sg13g2_decap_8
XFILLER_43_1292 VDD VSS / sg13g2_fill_2
XFILLER_43_1294 VDD VSS / sg13g2_fill_1
XFILLER_43_781 VDD VSS / sg13g2_decap_8
XFILLER_43_788 VDD VSS / sg13g2_decap_8
XFILLER_43_795 VDD VSS / sg13g2_decap_8
XFILLER_43_802 VDD VSS / sg13g2_decap_8
XFILLER_43_809 VDD VSS / sg13g2_decap_8
XFILLER_43_816 VDD VSS / sg13g2_decap_8
XFILLER_43_823 VDD VSS / sg13g2_decap_8
XFILLER_43_830 VDD VSS / sg13g2_decap_8
XFILLER_43_837 VDD VSS / sg13g2_decap_8
XFILLER_43_844 VDD VSS / sg13g2_decap_8
XFILLER_43_851 VDD VSS / sg13g2_decap_8
XFILLER_43_858 VDD VSS / sg13g2_decap_8
XFILLER_43_865 VDD VSS / sg13g2_decap_8
XFILLER_43_872 VDD VSS / sg13g2_decap_8
XFILLER_43_879 VDD VSS / sg13g2_decap_8
XFILLER_43_886 VDD VSS / sg13g2_decap_8
XFILLER_43_893 VDD VSS / sg13g2_decap_8
XFILLER_43_900 VDD VSS / sg13g2_decap_8
XFILLER_43_907 VDD VSS / sg13g2_decap_8
XFILLER_43_914 VDD VSS / sg13g2_decap_8
XFILLER_43_921 VDD VSS / sg13g2_decap_8
XFILLER_43_928 VDD VSS / sg13g2_decap_8
XFILLER_43_935 VDD VSS / sg13g2_decap_8
XFILLER_43_942 VDD VSS / sg13g2_decap_8
XFILLER_43_949 VDD VSS / sg13g2_decap_8
XFILLER_43_956 VDD VSS / sg13g2_decap_8
XFILLER_43_963 VDD VSS / sg13g2_decap_8
XFILLER_43_970 VDD VSS / sg13g2_decap_8
XFILLER_43_977 VDD VSS / sg13g2_decap_8
XFILLER_43_984 VDD VSS / sg13g2_decap_8
XFILLER_43_991 VDD VSS / sg13g2_decap_8
XFILLER_43_998 VDD VSS / sg13g2_decap_8
XFILLER_44_1005 VDD VSS / sg13g2_decap_8
XFILLER_44_1012 VDD VSS / sg13g2_decap_8
XFILLER_44_1019 VDD VSS / sg13g2_decap_8
XFILLER_44_1026 VDD VSS / sg13g2_decap_8
XFILLER_44_1033 VDD VSS / sg13g2_decap_8
XFILLER_44_1040 VDD VSS / sg13g2_decap_8
XFILLER_44_1047 VDD VSS / sg13g2_decap_8
XFILLER_44_1054 VDD VSS / sg13g2_decap_8
XFILLER_44_1061 VDD VSS / sg13g2_decap_8
XFILLER_44_1068 VDD VSS / sg13g2_decap_8
XFILLER_44_1075 VDD VSS / sg13g2_decap_8
XFILLER_44_1082 VDD VSS / sg13g2_decap_8
XFILLER_44_1089 VDD VSS / sg13g2_decap_8
XFILLER_44_1096 VDD VSS / sg13g2_decap_8
XFILLER_44_1103 VDD VSS / sg13g2_decap_8
XFILLER_44_1110 VDD VSS / sg13g2_decap_8
XFILLER_44_1117 VDD VSS / sg13g2_decap_8
XFILLER_44_1124 VDD VSS / sg13g2_decap_8
XFILLER_44_1131 VDD VSS / sg13g2_decap_8
XFILLER_44_1138 VDD VSS / sg13g2_decap_8
XFILLER_44_1145 VDD VSS / sg13g2_decap_8
XFILLER_44_1152 VDD VSS / sg13g2_decap_8
XFILLER_44_1159 VDD VSS / sg13g2_decap_8
XFILLER_44_1166 VDD VSS / sg13g2_decap_8
XFILLER_44_1173 VDD VSS / sg13g2_decap_8
XFILLER_44_1180 VDD VSS / sg13g2_decap_8
XFILLER_44_1187 VDD VSS / sg13g2_decap_8
XFILLER_44_1194 VDD VSS / sg13g2_decap_8
XFILLER_44_1201 VDD VSS / sg13g2_decap_8
XFILLER_44_1208 VDD VSS / sg13g2_decap_8
XFILLER_44_1215 VDD VSS / sg13g2_decap_8
XFILLER_44_1222 VDD VSS / sg13g2_decap_8
XFILLER_44_1229 VDD VSS / sg13g2_decap_8
XFILLER_44_1236 VDD VSS / sg13g2_decap_8
XFILLER_44_1243 VDD VSS / sg13g2_decap_8
XFILLER_44_1250 VDD VSS / sg13g2_decap_8
XFILLER_44_1257 VDD VSS / sg13g2_decap_8
XFILLER_44_1264 VDD VSS / sg13g2_decap_8
XFILLER_44_1271 VDD VSS / sg13g2_decap_8
XFILLER_44_1278 VDD VSS / sg13g2_decap_8
XFILLER_44_1285 VDD VSS / sg13g2_decap_8
XFILLER_44_1292 VDD VSS / sg13g2_fill_2
XFILLER_44_1294 VDD VSS / sg13g2_fill_1
XFILLER_44_781 VDD VSS / sg13g2_decap_8
XFILLER_44_788 VDD VSS / sg13g2_decap_8
XFILLER_44_795 VDD VSS / sg13g2_decap_8
XFILLER_44_802 VDD VSS / sg13g2_decap_8
XFILLER_44_809 VDD VSS / sg13g2_decap_8
XFILLER_44_816 VDD VSS / sg13g2_decap_8
XFILLER_44_823 VDD VSS / sg13g2_decap_8
XFILLER_44_830 VDD VSS / sg13g2_decap_8
XFILLER_44_837 VDD VSS / sg13g2_decap_8
XFILLER_44_844 VDD VSS / sg13g2_decap_8
XFILLER_44_851 VDD VSS / sg13g2_decap_8
XFILLER_44_858 VDD VSS / sg13g2_decap_8
XFILLER_44_865 VDD VSS / sg13g2_decap_8
XFILLER_44_872 VDD VSS / sg13g2_decap_8
XFILLER_44_879 VDD VSS / sg13g2_decap_8
XFILLER_44_886 VDD VSS / sg13g2_decap_8
XFILLER_44_893 VDD VSS / sg13g2_decap_8
XFILLER_44_900 VDD VSS / sg13g2_decap_8
XFILLER_44_907 VDD VSS / sg13g2_decap_8
XFILLER_44_914 VDD VSS / sg13g2_decap_8
XFILLER_44_921 VDD VSS / sg13g2_decap_8
XFILLER_44_928 VDD VSS / sg13g2_decap_8
XFILLER_44_935 VDD VSS / sg13g2_decap_8
XFILLER_44_942 VDD VSS / sg13g2_decap_8
XFILLER_44_949 VDD VSS / sg13g2_decap_8
XFILLER_44_956 VDD VSS / sg13g2_decap_8
XFILLER_44_963 VDD VSS / sg13g2_decap_8
XFILLER_44_970 VDD VSS / sg13g2_decap_8
XFILLER_44_977 VDD VSS / sg13g2_decap_8
XFILLER_44_984 VDD VSS / sg13g2_decap_8
XFILLER_44_991 VDD VSS / sg13g2_decap_8
XFILLER_44_998 VDD VSS / sg13g2_decap_8
XFILLER_45_1005 VDD VSS / sg13g2_decap_8
XFILLER_45_1012 VDD VSS / sg13g2_decap_8
XFILLER_45_1019 VDD VSS / sg13g2_decap_8
XFILLER_45_1026 VDD VSS / sg13g2_decap_8
XFILLER_45_1033 VDD VSS / sg13g2_decap_8
XFILLER_45_1040 VDD VSS / sg13g2_decap_8
XFILLER_45_1047 VDD VSS / sg13g2_decap_8
XFILLER_45_1054 VDD VSS / sg13g2_decap_8
XFILLER_45_1061 VDD VSS / sg13g2_decap_8
XFILLER_45_1068 VDD VSS / sg13g2_decap_8
XFILLER_45_1075 VDD VSS / sg13g2_decap_8
XFILLER_45_1082 VDD VSS / sg13g2_decap_8
XFILLER_45_1089 VDD VSS / sg13g2_decap_8
XFILLER_45_1096 VDD VSS / sg13g2_decap_8
XFILLER_45_1103 VDD VSS / sg13g2_decap_8
XFILLER_45_1110 VDD VSS / sg13g2_decap_8
XFILLER_45_1117 VDD VSS / sg13g2_decap_8
XFILLER_45_1124 VDD VSS / sg13g2_decap_8
XFILLER_45_1131 VDD VSS / sg13g2_decap_8
XFILLER_45_1138 VDD VSS / sg13g2_decap_8
XFILLER_45_1145 VDD VSS / sg13g2_decap_8
XFILLER_45_1152 VDD VSS / sg13g2_decap_8
XFILLER_45_1159 VDD VSS / sg13g2_decap_8
XFILLER_45_1166 VDD VSS / sg13g2_decap_8
XFILLER_45_1173 VDD VSS / sg13g2_decap_8
XFILLER_45_1180 VDD VSS / sg13g2_decap_8
XFILLER_45_1187 VDD VSS / sg13g2_decap_8
XFILLER_45_1194 VDD VSS / sg13g2_decap_8
XFILLER_45_1201 VDD VSS / sg13g2_decap_8
XFILLER_45_1208 VDD VSS / sg13g2_decap_8
XFILLER_45_1215 VDD VSS / sg13g2_decap_8
XFILLER_45_1222 VDD VSS / sg13g2_decap_8
XFILLER_45_1229 VDD VSS / sg13g2_decap_8
XFILLER_45_1236 VDD VSS / sg13g2_decap_8
XFILLER_45_1243 VDD VSS / sg13g2_decap_8
XFILLER_45_1250 VDD VSS / sg13g2_decap_8
XFILLER_45_1257 VDD VSS / sg13g2_decap_8
XFILLER_45_1264 VDD VSS / sg13g2_decap_8
XFILLER_45_1271 VDD VSS / sg13g2_decap_8
XFILLER_45_1278 VDD VSS / sg13g2_decap_8
XFILLER_45_1285 VDD VSS / sg13g2_decap_8
XFILLER_45_1292 VDD VSS / sg13g2_fill_2
XFILLER_45_1294 VDD VSS / sg13g2_fill_1
XFILLER_45_781 VDD VSS / sg13g2_decap_8
XFILLER_45_788 VDD VSS / sg13g2_decap_8
XFILLER_45_795 VDD VSS / sg13g2_decap_8
XFILLER_45_802 VDD VSS / sg13g2_decap_8
XFILLER_45_809 VDD VSS / sg13g2_decap_8
XFILLER_45_816 VDD VSS / sg13g2_decap_8
XFILLER_45_823 VDD VSS / sg13g2_decap_8
XFILLER_45_830 VDD VSS / sg13g2_decap_8
XFILLER_45_837 VDD VSS / sg13g2_decap_8
XFILLER_45_844 VDD VSS / sg13g2_decap_8
XFILLER_45_851 VDD VSS / sg13g2_decap_8
XFILLER_45_858 VDD VSS / sg13g2_decap_8
XFILLER_45_865 VDD VSS / sg13g2_decap_8
XFILLER_45_872 VDD VSS / sg13g2_decap_8
XFILLER_45_879 VDD VSS / sg13g2_decap_8
XFILLER_45_886 VDD VSS / sg13g2_decap_8
XFILLER_45_893 VDD VSS / sg13g2_decap_8
XFILLER_45_900 VDD VSS / sg13g2_decap_8
XFILLER_45_907 VDD VSS / sg13g2_decap_8
XFILLER_45_914 VDD VSS / sg13g2_decap_8
XFILLER_45_921 VDD VSS / sg13g2_decap_8
XFILLER_45_928 VDD VSS / sg13g2_decap_8
XFILLER_45_935 VDD VSS / sg13g2_decap_8
XFILLER_45_942 VDD VSS / sg13g2_decap_8
XFILLER_45_949 VDD VSS / sg13g2_decap_8
XFILLER_45_956 VDD VSS / sg13g2_decap_8
XFILLER_45_963 VDD VSS / sg13g2_decap_8
XFILLER_45_970 VDD VSS / sg13g2_decap_8
XFILLER_45_977 VDD VSS / sg13g2_decap_8
XFILLER_45_984 VDD VSS / sg13g2_decap_8
XFILLER_45_991 VDD VSS / sg13g2_decap_8
XFILLER_45_998 VDD VSS / sg13g2_decap_8
XFILLER_46_1005 VDD VSS / sg13g2_decap_8
XFILLER_46_1012 VDD VSS / sg13g2_decap_8
XFILLER_46_1019 VDD VSS / sg13g2_decap_8
XFILLER_46_1026 VDD VSS / sg13g2_decap_8
XFILLER_46_1033 VDD VSS / sg13g2_decap_8
XFILLER_46_1040 VDD VSS / sg13g2_decap_8
XFILLER_46_1047 VDD VSS / sg13g2_decap_8
XFILLER_46_1054 VDD VSS / sg13g2_decap_8
XFILLER_46_1061 VDD VSS / sg13g2_decap_8
XFILLER_46_1068 VDD VSS / sg13g2_decap_8
XFILLER_46_1075 VDD VSS / sg13g2_decap_8
XFILLER_46_1082 VDD VSS / sg13g2_decap_8
XFILLER_46_1089 VDD VSS / sg13g2_decap_8
XFILLER_46_1096 VDD VSS / sg13g2_decap_8
XFILLER_46_1103 VDD VSS / sg13g2_decap_8
XFILLER_46_1110 VDD VSS / sg13g2_decap_8
XFILLER_46_1117 VDD VSS / sg13g2_decap_8
XFILLER_46_1124 VDD VSS / sg13g2_decap_8
XFILLER_46_1131 VDD VSS / sg13g2_decap_8
XFILLER_46_1138 VDD VSS / sg13g2_decap_8
XFILLER_46_1145 VDD VSS / sg13g2_decap_8
XFILLER_46_1152 VDD VSS / sg13g2_decap_8
XFILLER_46_1159 VDD VSS / sg13g2_decap_8
XFILLER_46_1166 VDD VSS / sg13g2_decap_8
XFILLER_46_1173 VDD VSS / sg13g2_decap_8
XFILLER_46_1180 VDD VSS / sg13g2_decap_8
XFILLER_46_1187 VDD VSS / sg13g2_decap_8
XFILLER_46_1194 VDD VSS / sg13g2_decap_8
XFILLER_46_1201 VDD VSS / sg13g2_decap_8
XFILLER_46_1208 VDD VSS / sg13g2_decap_8
XFILLER_46_1215 VDD VSS / sg13g2_decap_8
XFILLER_46_1222 VDD VSS / sg13g2_decap_8
XFILLER_46_1229 VDD VSS / sg13g2_decap_8
XFILLER_46_1236 VDD VSS / sg13g2_decap_8
XFILLER_46_1243 VDD VSS / sg13g2_decap_8
XFILLER_46_1250 VDD VSS / sg13g2_decap_8
XFILLER_46_1257 VDD VSS / sg13g2_decap_8
XFILLER_46_1264 VDD VSS / sg13g2_decap_8
XFILLER_46_1271 VDD VSS / sg13g2_decap_8
XFILLER_46_1278 VDD VSS / sg13g2_decap_8
XFILLER_46_1285 VDD VSS / sg13g2_decap_8
XFILLER_46_1292 VDD VSS / sg13g2_fill_2
XFILLER_46_1294 VDD VSS / sg13g2_fill_1
XFILLER_46_781 VDD VSS / sg13g2_decap_8
XFILLER_46_788 VDD VSS / sg13g2_decap_8
XFILLER_46_795 VDD VSS / sg13g2_decap_8
XFILLER_46_802 VDD VSS / sg13g2_decap_8
XFILLER_46_809 VDD VSS / sg13g2_decap_8
XFILLER_46_816 VDD VSS / sg13g2_decap_8
XFILLER_46_823 VDD VSS / sg13g2_decap_8
XFILLER_46_830 VDD VSS / sg13g2_decap_8
XFILLER_46_837 VDD VSS / sg13g2_decap_8
XFILLER_46_844 VDD VSS / sg13g2_decap_8
XFILLER_46_851 VDD VSS / sg13g2_decap_8
XFILLER_46_858 VDD VSS / sg13g2_decap_8
XFILLER_46_865 VDD VSS / sg13g2_decap_8
XFILLER_46_872 VDD VSS / sg13g2_decap_8
XFILLER_46_879 VDD VSS / sg13g2_decap_8
XFILLER_46_886 VDD VSS / sg13g2_decap_8
XFILLER_46_893 VDD VSS / sg13g2_decap_8
XFILLER_46_900 VDD VSS / sg13g2_decap_8
XFILLER_46_907 VDD VSS / sg13g2_decap_8
XFILLER_46_914 VDD VSS / sg13g2_decap_8
XFILLER_46_921 VDD VSS / sg13g2_decap_8
XFILLER_46_928 VDD VSS / sg13g2_decap_8
XFILLER_46_935 VDD VSS / sg13g2_decap_8
XFILLER_46_942 VDD VSS / sg13g2_decap_8
XFILLER_46_949 VDD VSS / sg13g2_decap_8
XFILLER_46_956 VDD VSS / sg13g2_decap_8
XFILLER_46_963 VDD VSS / sg13g2_decap_8
XFILLER_46_970 VDD VSS / sg13g2_decap_8
XFILLER_46_977 VDD VSS / sg13g2_decap_8
XFILLER_46_984 VDD VSS / sg13g2_decap_8
XFILLER_46_991 VDD VSS / sg13g2_decap_8
XFILLER_46_998 VDD VSS / sg13g2_decap_8
XFILLER_47_1005 VDD VSS / sg13g2_decap_8
XFILLER_47_1012 VDD VSS / sg13g2_decap_8
XFILLER_47_1019 VDD VSS / sg13g2_decap_8
XFILLER_47_1026 VDD VSS / sg13g2_decap_8
XFILLER_47_1033 VDD VSS / sg13g2_decap_8
XFILLER_47_1040 VDD VSS / sg13g2_decap_8
XFILLER_47_1047 VDD VSS / sg13g2_decap_8
XFILLER_47_1054 VDD VSS / sg13g2_decap_8
XFILLER_47_1061 VDD VSS / sg13g2_decap_8
XFILLER_47_1068 VDD VSS / sg13g2_decap_8
XFILLER_47_1075 VDD VSS / sg13g2_decap_8
XFILLER_47_1082 VDD VSS / sg13g2_decap_8
XFILLER_47_1089 VDD VSS / sg13g2_decap_8
XFILLER_47_1096 VDD VSS / sg13g2_decap_8
XFILLER_47_1103 VDD VSS / sg13g2_decap_8
XFILLER_47_1110 VDD VSS / sg13g2_decap_8
XFILLER_47_1117 VDD VSS / sg13g2_decap_8
XFILLER_47_1124 VDD VSS / sg13g2_decap_8
XFILLER_47_1131 VDD VSS / sg13g2_decap_8
XFILLER_47_1138 VDD VSS / sg13g2_decap_8
XFILLER_47_1145 VDD VSS / sg13g2_decap_8
XFILLER_47_1152 VDD VSS / sg13g2_decap_8
XFILLER_47_1159 VDD VSS / sg13g2_decap_8
XFILLER_47_1166 VDD VSS / sg13g2_decap_8
XFILLER_47_1173 VDD VSS / sg13g2_decap_8
XFILLER_47_1180 VDD VSS / sg13g2_decap_8
XFILLER_47_1187 VDD VSS / sg13g2_decap_8
XFILLER_47_1194 VDD VSS / sg13g2_decap_8
XFILLER_47_1201 VDD VSS / sg13g2_decap_8
XFILLER_47_1208 VDD VSS / sg13g2_decap_8
XFILLER_47_1215 VDD VSS / sg13g2_decap_8
XFILLER_47_1222 VDD VSS / sg13g2_decap_8
XFILLER_47_1229 VDD VSS / sg13g2_decap_8
XFILLER_47_1236 VDD VSS / sg13g2_decap_8
XFILLER_47_1243 VDD VSS / sg13g2_decap_8
XFILLER_47_1250 VDD VSS / sg13g2_decap_8
XFILLER_47_1257 VDD VSS / sg13g2_decap_8
XFILLER_47_1264 VDD VSS / sg13g2_decap_8
XFILLER_47_1271 VDD VSS / sg13g2_decap_8
XFILLER_47_1278 VDD VSS / sg13g2_decap_8
XFILLER_47_1285 VDD VSS / sg13g2_decap_8
XFILLER_47_1292 VDD VSS / sg13g2_fill_2
XFILLER_47_1294 VDD VSS / sg13g2_fill_1
XFILLER_47_781 VDD VSS / sg13g2_decap_8
XFILLER_47_788 VDD VSS / sg13g2_decap_8
XFILLER_47_795 VDD VSS / sg13g2_decap_8
XFILLER_47_802 VDD VSS / sg13g2_decap_8
XFILLER_47_809 VDD VSS / sg13g2_decap_8
XFILLER_47_816 VDD VSS / sg13g2_decap_8
XFILLER_47_823 VDD VSS / sg13g2_decap_8
XFILLER_47_830 VDD VSS / sg13g2_decap_8
XFILLER_47_837 VDD VSS / sg13g2_decap_8
XFILLER_47_844 VDD VSS / sg13g2_decap_8
XFILLER_47_851 VDD VSS / sg13g2_decap_8
XFILLER_47_858 VDD VSS / sg13g2_decap_8
XFILLER_47_865 VDD VSS / sg13g2_decap_8
XFILLER_47_872 VDD VSS / sg13g2_decap_8
XFILLER_47_879 VDD VSS / sg13g2_decap_8
XFILLER_47_886 VDD VSS / sg13g2_decap_8
XFILLER_47_893 VDD VSS / sg13g2_decap_8
XFILLER_47_900 VDD VSS / sg13g2_decap_8
XFILLER_47_907 VDD VSS / sg13g2_decap_8
XFILLER_47_914 VDD VSS / sg13g2_decap_8
XFILLER_47_921 VDD VSS / sg13g2_decap_8
XFILLER_47_928 VDD VSS / sg13g2_decap_8
XFILLER_47_935 VDD VSS / sg13g2_decap_8
XFILLER_47_942 VDD VSS / sg13g2_decap_8
XFILLER_47_949 VDD VSS / sg13g2_decap_8
XFILLER_47_956 VDD VSS / sg13g2_decap_8
XFILLER_47_963 VDD VSS / sg13g2_decap_8
XFILLER_47_970 VDD VSS / sg13g2_decap_8
XFILLER_47_977 VDD VSS / sg13g2_decap_8
XFILLER_47_984 VDD VSS / sg13g2_decap_8
XFILLER_47_991 VDD VSS / sg13g2_decap_8
XFILLER_47_998 VDD VSS / sg13g2_decap_8
XFILLER_48_1005 VDD VSS / sg13g2_decap_8
XFILLER_48_1012 VDD VSS / sg13g2_decap_8
XFILLER_48_1019 VDD VSS / sg13g2_decap_8
XFILLER_48_1026 VDD VSS / sg13g2_decap_8
XFILLER_48_1033 VDD VSS / sg13g2_decap_8
XFILLER_48_1040 VDD VSS / sg13g2_decap_8
XFILLER_48_1047 VDD VSS / sg13g2_decap_8
XFILLER_48_1054 VDD VSS / sg13g2_decap_8
XFILLER_48_1061 VDD VSS / sg13g2_decap_8
XFILLER_48_1068 VDD VSS / sg13g2_decap_8
XFILLER_48_1075 VDD VSS / sg13g2_decap_8
XFILLER_48_1082 VDD VSS / sg13g2_decap_8
XFILLER_48_1089 VDD VSS / sg13g2_decap_8
XFILLER_48_1096 VDD VSS / sg13g2_decap_8
XFILLER_48_1103 VDD VSS / sg13g2_decap_8
XFILLER_48_1110 VDD VSS / sg13g2_decap_8
XFILLER_48_1117 VDD VSS / sg13g2_decap_8
XFILLER_48_1124 VDD VSS / sg13g2_decap_8
XFILLER_48_1131 VDD VSS / sg13g2_decap_8
XFILLER_48_1138 VDD VSS / sg13g2_decap_8
XFILLER_48_1145 VDD VSS / sg13g2_decap_8
XFILLER_48_1152 VDD VSS / sg13g2_decap_8
XFILLER_48_1159 VDD VSS / sg13g2_decap_8
XFILLER_48_1166 VDD VSS / sg13g2_decap_8
XFILLER_48_1173 VDD VSS / sg13g2_decap_8
XFILLER_48_1180 VDD VSS / sg13g2_decap_8
XFILLER_48_1187 VDD VSS / sg13g2_decap_8
XFILLER_48_1194 VDD VSS / sg13g2_decap_8
XFILLER_48_1201 VDD VSS / sg13g2_decap_8
XFILLER_48_1208 VDD VSS / sg13g2_decap_8
XFILLER_48_1215 VDD VSS / sg13g2_decap_8
XFILLER_48_1222 VDD VSS / sg13g2_decap_8
XFILLER_48_1229 VDD VSS / sg13g2_decap_8
XFILLER_48_1236 VDD VSS / sg13g2_decap_8
XFILLER_48_1243 VDD VSS / sg13g2_decap_8
XFILLER_48_1250 VDD VSS / sg13g2_decap_8
XFILLER_48_1257 VDD VSS / sg13g2_decap_8
XFILLER_48_1264 VDD VSS / sg13g2_decap_8
XFILLER_48_1271 VDD VSS / sg13g2_decap_8
XFILLER_48_1278 VDD VSS / sg13g2_decap_8
XFILLER_48_1285 VDD VSS / sg13g2_decap_8
XFILLER_48_1292 VDD VSS / sg13g2_fill_2
XFILLER_48_1294 VDD VSS / sg13g2_fill_1
XFILLER_48_781 VDD VSS / sg13g2_decap_8
XFILLER_48_788 VDD VSS / sg13g2_decap_8
XFILLER_48_795 VDD VSS / sg13g2_decap_8
XFILLER_48_802 VDD VSS / sg13g2_decap_8
XFILLER_48_809 VDD VSS / sg13g2_decap_8
XFILLER_48_816 VDD VSS / sg13g2_decap_8
XFILLER_48_823 VDD VSS / sg13g2_decap_8
XFILLER_48_830 VDD VSS / sg13g2_decap_8
XFILLER_48_837 VDD VSS / sg13g2_decap_8
XFILLER_48_844 VDD VSS / sg13g2_decap_8
XFILLER_48_851 VDD VSS / sg13g2_decap_8
XFILLER_48_858 VDD VSS / sg13g2_decap_8
XFILLER_48_865 VDD VSS / sg13g2_decap_8
XFILLER_48_872 VDD VSS / sg13g2_decap_8
XFILLER_48_879 VDD VSS / sg13g2_decap_8
XFILLER_48_886 VDD VSS / sg13g2_decap_8
XFILLER_48_893 VDD VSS / sg13g2_decap_8
XFILLER_48_900 VDD VSS / sg13g2_decap_8
XFILLER_48_907 VDD VSS / sg13g2_decap_8
XFILLER_48_914 VDD VSS / sg13g2_decap_8
XFILLER_48_921 VDD VSS / sg13g2_decap_8
XFILLER_48_928 VDD VSS / sg13g2_decap_8
XFILLER_48_935 VDD VSS / sg13g2_decap_8
XFILLER_48_942 VDD VSS / sg13g2_decap_8
XFILLER_48_949 VDD VSS / sg13g2_decap_8
XFILLER_48_956 VDD VSS / sg13g2_decap_8
XFILLER_48_963 VDD VSS / sg13g2_decap_8
XFILLER_48_970 VDD VSS / sg13g2_decap_8
XFILLER_48_977 VDD VSS / sg13g2_decap_8
XFILLER_48_984 VDD VSS / sg13g2_decap_8
XFILLER_48_991 VDD VSS / sg13g2_decap_8
XFILLER_48_998 VDD VSS / sg13g2_decap_8
XFILLER_49_1005 VDD VSS / sg13g2_decap_8
XFILLER_49_1012 VDD VSS / sg13g2_decap_8
XFILLER_49_1019 VDD VSS / sg13g2_decap_8
XFILLER_49_1026 VDD VSS / sg13g2_decap_8
XFILLER_49_1033 VDD VSS / sg13g2_decap_8
XFILLER_49_1040 VDD VSS / sg13g2_decap_8
XFILLER_49_1047 VDD VSS / sg13g2_decap_8
XFILLER_49_1054 VDD VSS / sg13g2_decap_8
XFILLER_49_1061 VDD VSS / sg13g2_decap_8
XFILLER_49_1068 VDD VSS / sg13g2_decap_8
XFILLER_49_1075 VDD VSS / sg13g2_decap_8
XFILLER_49_1082 VDD VSS / sg13g2_decap_8
XFILLER_49_1089 VDD VSS / sg13g2_decap_8
XFILLER_49_1096 VDD VSS / sg13g2_decap_8
XFILLER_49_1103 VDD VSS / sg13g2_decap_8
XFILLER_49_1110 VDD VSS / sg13g2_decap_8
XFILLER_49_1117 VDD VSS / sg13g2_decap_8
XFILLER_49_1124 VDD VSS / sg13g2_decap_8
XFILLER_49_1131 VDD VSS / sg13g2_decap_8
XFILLER_49_1138 VDD VSS / sg13g2_decap_8
XFILLER_49_1145 VDD VSS / sg13g2_decap_8
XFILLER_49_1152 VDD VSS / sg13g2_decap_8
XFILLER_49_1159 VDD VSS / sg13g2_decap_8
XFILLER_49_1166 VDD VSS / sg13g2_decap_8
XFILLER_49_1173 VDD VSS / sg13g2_decap_8
XFILLER_49_1180 VDD VSS / sg13g2_decap_8
XFILLER_49_1187 VDD VSS / sg13g2_decap_8
XFILLER_49_1194 VDD VSS / sg13g2_decap_8
XFILLER_49_1201 VDD VSS / sg13g2_decap_8
XFILLER_49_1208 VDD VSS / sg13g2_decap_8
XFILLER_49_1215 VDD VSS / sg13g2_decap_8
XFILLER_49_1222 VDD VSS / sg13g2_decap_8
XFILLER_49_1229 VDD VSS / sg13g2_decap_8
XFILLER_49_1236 VDD VSS / sg13g2_decap_8
XFILLER_49_1243 VDD VSS / sg13g2_decap_8
XFILLER_49_1250 VDD VSS / sg13g2_decap_8
XFILLER_49_1257 VDD VSS / sg13g2_decap_8
XFILLER_49_1264 VDD VSS / sg13g2_decap_8
XFILLER_49_1271 VDD VSS / sg13g2_decap_8
XFILLER_49_1278 VDD VSS / sg13g2_decap_8
XFILLER_49_1285 VDD VSS / sg13g2_decap_8
XFILLER_49_1292 VDD VSS / sg13g2_fill_2
XFILLER_49_1294 VDD VSS / sg13g2_fill_1
XFILLER_49_781 VDD VSS / sg13g2_decap_8
XFILLER_49_788 VDD VSS / sg13g2_decap_8
XFILLER_49_795 VDD VSS / sg13g2_decap_8
XFILLER_49_802 VDD VSS / sg13g2_decap_8
XFILLER_49_809 VDD VSS / sg13g2_decap_8
XFILLER_49_816 VDD VSS / sg13g2_decap_8
XFILLER_49_823 VDD VSS / sg13g2_decap_8
XFILLER_49_830 VDD VSS / sg13g2_decap_8
XFILLER_49_837 VDD VSS / sg13g2_decap_8
XFILLER_49_844 VDD VSS / sg13g2_decap_8
XFILLER_49_851 VDD VSS / sg13g2_decap_8
XFILLER_49_858 VDD VSS / sg13g2_decap_8
XFILLER_49_865 VDD VSS / sg13g2_decap_8
XFILLER_49_872 VDD VSS / sg13g2_decap_8
XFILLER_49_879 VDD VSS / sg13g2_decap_8
XFILLER_49_886 VDD VSS / sg13g2_decap_8
XFILLER_49_893 VDD VSS / sg13g2_decap_8
XFILLER_49_900 VDD VSS / sg13g2_decap_8
XFILLER_49_907 VDD VSS / sg13g2_decap_8
XFILLER_49_914 VDD VSS / sg13g2_decap_8
XFILLER_49_921 VDD VSS / sg13g2_decap_8
XFILLER_49_928 VDD VSS / sg13g2_decap_8
XFILLER_49_935 VDD VSS / sg13g2_decap_8
XFILLER_49_942 VDD VSS / sg13g2_decap_8
XFILLER_49_949 VDD VSS / sg13g2_decap_8
XFILLER_49_956 VDD VSS / sg13g2_decap_8
XFILLER_49_963 VDD VSS / sg13g2_decap_8
XFILLER_49_970 VDD VSS / sg13g2_decap_8
XFILLER_49_977 VDD VSS / sg13g2_decap_8
XFILLER_49_984 VDD VSS / sg13g2_decap_8
XFILLER_49_991 VDD VSS / sg13g2_decap_8
XFILLER_49_998 VDD VSS / sg13g2_decap_8
XFILLER_4_1006 VDD VSS / sg13g2_decap_8
XFILLER_4_1013 VDD VSS / sg13g2_decap_8
XFILLER_4_1020 VDD VSS / sg13g2_decap_8
XFILLER_4_1027 VDD VSS / sg13g2_decap_8
XFILLER_4_103 VDD VSS / sg13g2_decap_8
XFILLER_4_1034 VDD VSS / sg13g2_decap_8
XFILLER_4_1041 VDD VSS / sg13g2_decap_8
XFILLER_4_1048 VDD VSS / sg13g2_decap_8
XFILLER_4_1055 VDD VSS / sg13g2_decap_8
XFILLER_4_1062 VDD VSS / sg13g2_decap_8
XFILLER_4_1069 VDD VSS / sg13g2_decap_8
XFILLER_4_1076 VDD VSS / sg13g2_decap_8
XFILLER_4_1083 VDD VSS / sg13g2_decap_8
XFILLER_4_1090 VDD VSS / sg13g2_decap_8
XFILLER_4_1097 VDD VSS / sg13g2_decap_8
XFILLER_4_110 VDD VSS / sg13g2_decap_8
XFILLER_4_1104 VDD VSS / sg13g2_decap_8
XFILLER_4_1111 VDD VSS / sg13g2_decap_8
XFILLER_4_1118 VDD VSS / sg13g2_decap_8
XFILLER_4_1125 VDD VSS / sg13g2_decap_8
XFILLER_4_1132 VDD VSS / sg13g2_decap_8
XFILLER_4_1139 VDD VSS / sg13g2_decap_8
XFILLER_4_1146 VDD VSS / sg13g2_decap_8
XFILLER_4_1153 VDD VSS / sg13g2_decap_8
XFILLER_4_1160 VDD VSS / sg13g2_decap_8
XFILLER_4_1167 VDD VSS / sg13g2_decap_8
XFILLER_4_117 VDD VSS / sg13g2_decap_8
XFILLER_4_1174 VDD VSS / sg13g2_decap_8
XFILLER_4_1181 VDD VSS / sg13g2_decap_8
XFILLER_4_1188 VDD VSS / sg13g2_decap_8
XFILLER_4_1195 VDD VSS / sg13g2_decap_8
XFILLER_4_1202 VDD VSS / sg13g2_decap_8
XFILLER_4_1209 VDD VSS / sg13g2_decap_8
XFILLER_4_1216 VDD VSS / sg13g2_decap_8
XFILLER_4_1223 VDD VSS / sg13g2_decap_8
XFILLER_4_1230 VDD VSS / sg13g2_decap_8
XFILLER_4_1237 VDD VSS / sg13g2_decap_8
XFILLER_4_124 VDD VSS / sg13g2_decap_8
XFILLER_4_1244 VDD VSS / sg13g2_decap_8
XFILLER_4_1251 VDD VSS / sg13g2_decap_8
XFILLER_4_1258 VDD VSS / sg13g2_decap_8
XFILLER_4_1265 VDD VSS / sg13g2_decap_8
XFILLER_4_1272 VDD VSS / sg13g2_decap_8
XFILLER_4_1279 VDD VSS / sg13g2_decap_8
XFILLER_4_1286 VDD VSS / sg13g2_decap_8
XFILLER_4_1293 VDD VSS / sg13g2_fill_2
XFILLER_4_131 VDD VSS / sg13g2_decap_8
XFILLER_4_138 VDD VSS / sg13g2_decap_8
XFILLER_4_145 VDD VSS / sg13g2_decap_8
XFILLER_4_152 VDD VSS / sg13g2_decap_8
XFILLER_4_159 VDD VSS / sg13g2_decap_8
XFILLER_4_166 VDD VSS / sg13g2_decap_8
XFILLER_4_173 VDD VSS / sg13g2_decap_8
XFILLER_4_180 VDD VSS / sg13g2_decap_8
XFILLER_4_187 VDD VSS / sg13g2_decap_8
XFILLER_4_194 VDD VSS / sg13g2_decap_8
XFILLER_4_201 VDD VSS / sg13g2_decap_8
XFILLER_4_208 VDD VSS / sg13g2_decap_8
XFILLER_4_215 VDD VSS / sg13g2_decap_8
XFILLER_4_222 VDD VSS / sg13g2_decap_8
XFILLER_4_229 VDD VSS / sg13g2_decap_8
XFILLER_4_236 VDD VSS / sg13g2_decap_8
XFILLER_4_243 VDD VSS / sg13g2_decap_8
XFILLER_4_250 VDD VSS / sg13g2_decap_8
XFILLER_4_257 VDD VSS / sg13g2_decap_8
XFILLER_4_264 VDD VSS / sg13g2_decap_8
XFILLER_4_271 VDD VSS / sg13g2_decap_8
XFILLER_4_278 VDD VSS / sg13g2_decap_8
XFILLER_4_285 VDD VSS / sg13g2_decap_8
XFILLER_4_292 VDD VSS / sg13g2_decap_8
XFILLER_4_299 VDD VSS / sg13g2_decap_8
XFILLER_4_306 VDD VSS / sg13g2_decap_8
XFILLER_4_313 VDD VSS / sg13g2_decap_8
XFILLER_4_320 VDD VSS / sg13g2_decap_8
XFILLER_4_327 VDD VSS / sg13g2_decap_8
XFILLER_4_334 VDD VSS / sg13g2_decap_8
XFILLER_4_341 VDD VSS / sg13g2_decap_8
XFILLER_4_348 VDD VSS / sg13g2_decap_8
XFILLER_4_355 VDD VSS / sg13g2_decap_8
XFILLER_4_362 VDD VSS / sg13g2_decap_8
XFILLER_4_369 VDD VSS / sg13g2_decap_8
XFILLER_4_376 VDD VSS / sg13g2_decap_8
XFILLER_4_383 VDD VSS / sg13g2_decap_8
XFILLER_4_390 VDD VSS / sg13g2_decap_8
XFILLER_4_397 VDD VSS / sg13g2_decap_8
XFILLER_4_404 VDD VSS / sg13g2_decap_8
XFILLER_4_411 VDD VSS / sg13g2_decap_8
XFILLER_4_418 VDD VSS / sg13g2_decap_8
XFILLER_4_425 VDD VSS / sg13g2_decap_8
XFILLER_4_432 VDD VSS / sg13g2_decap_8
XFILLER_4_439 VDD VSS / sg13g2_decap_8
XFILLER_4_446 VDD VSS / sg13g2_decap_8
XFILLER_4_453 VDD VSS / sg13g2_decap_8
XFILLER_4_460 VDD VSS / sg13g2_decap_8
XFILLER_4_467 VDD VSS / sg13g2_decap_8
XFILLER_4_474 VDD VSS / sg13g2_decap_8
XFILLER_4_481 VDD VSS / sg13g2_decap_8
XFILLER_4_488 VDD VSS / sg13g2_decap_8
XFILLER_4_495 VDD VSS / sg13g2_decap_8
XFILLER_4_502 VDD VSS / sg13g2_decap_8
XFILLER_4_509 VDD VSS / sg13g2_decap_8
XFILLER_4_516 VDD VSS / sg13g2_decap_8
XFILLER_4_523 VDD VSS / sg13g2_decap_8
XFILLER_4_530 VDD VSS / sg13g2_decap_8
XFILLER_4_537 VDD VSS / sg13g2_decap_8
XFILLER_4_544 VDD VSS / sg13g2_decap_8
XFILLER_4_551 VDD VSS / sg13g2_decap_8
XFILLER_4_558 VDD VSS / sg13g2_decap_8
XFILLER_4_565 VDD VSS / sg13g2_decap_8
XFILLER_4_572 VDD VSS / sg13g2_decap_8
XFILLER_4_579 VDD VSS / sg13g2_decap_8
XFILLER_4_586 VDD VSS / sg13g2_decap_8
XFILLER_4_593 VDD VSS / sg13g2_decap_8
XFILLER_4_600 VDD VSS / sg13g2_decap_8
XFILLER_4_607 VDD VSS / sg13g2_decap_8
XFILLER_4_614 VDD VSS / sg13g2_decap_8
XFILLER_4_621 VDD VSS / sg13g2_decap_8
XFILLER_4_628 VDD VSS / sg13g2_decap_8
XFILLER_4_635 VDD VSS / sg13g2_decap_8
XFILLER_4_642 VDD VSS / sg13g2_decap_8
XFILLER_4_649 VDD VSS / sg13g2_decap_8
XFILLER_4_656 VDD VSS / sg13g2_decap_8
XFILLER_4_663 VDD VSS / sg13g2_decap_8
XFILLER_4_670 VDD VSS / sg13g2_decap_8
XFILLER_4_677 VDD VSS / sg13g2_decap_8
XFILLER_4_684 VDD VSS / sg13g2_decap_8
XFILLER_4_691 VDD VSS / sg13g2_decap_8
XFILLER_4_698 VDD VSS / sg13g2_decap_8
XFILLER_4_705 VDD VSS / sg13g2_decap_8
XFILLER_4_712 VDD VSS / sg13g2_decap_8
XFILLER_4_719 VDD VSS / sg13g2_decap_8
XFILLER_4_726 VDD VSS / sg13g2_decap_8
XFILLER_4_733 VDD VSS / sg13g2_decap_8
XFILLER_4_740 VDD VSS / sg13g2_decap_8
XFILLER_4_747 VDD VSS / sg13g2_decap_8
XFILLER_4_754 VDD VSS / sg13g2_decap_8
XFILLER_4_761 VDD VSS / sg13g2_decap_8
XFILLER_4_768 VDD VSS / sg13g2_decap_8
XFILLER_4_775 VDD VSS / sg13g2_decap_8
XFILLER_4_782 VDD VSS / sg13g2_decap_8
XFILLER_4_789 VDD VSS / sg13g2_decap_8
XFILLER_4_796 VDD VSS / sg13g2_decap_8
XFILLER_4_803 VDD VSS / sg13g2_decap_8
XFILLER_4_810 VDD VSS / sg13g2_decap_8
XFILLER_4_817 VDD VSS / sg13g2_decap_8
XFILLER_4_824 VDD VSS / sg13g2_decap_8
XFILLER_4_831 VDD VSS / sg13g2_decap_8
XFILLER_4_838 VDD VSS / sg13g2_decap_8
XFILLER_4_845 VDD VSS / sg13g2_decap_8
XFILLER_4_852 VDD VSS / sg13g2_decap_8
XFILLER_4_859 VDD VSS / sg13g2_decap_8
XFILLER_4_866 VDD VSS / sg13g2_decap_8
XFILLER_4_873 VDD VSS / sg13g2_decap_8
XFILLER_4_880 VDD VSS / sg13g2_decap_8
XFILLER_4_887 VDD VSS / sg13g2_decap_8
XFILLER_4_89 VDD VSS / sg13g2_decap_8
XFILLER_4_894 VDD VSS / sg13g2_decap_8
XFILLER_4_901 VDD VSS / sg13g2_decap_8
XFILLER_4_908 VDD VSS / sg13g2_decap_8
XFILLER_4_915 VDD VSS / sg13g2_decap_8
XFILLER_4_922 VDD VSS / sg13g2_decap_8
XFILLER_4_929 VDD VSS / sg13g2_decap_8
XFILLER_4_936 VDD VSS / sg13g2_decap_8
XFILLER_4_943 VDD VSS / sg13g2_decap_8
XFILLER_4_950 VDD VSS / sg13g2_decap_8
XFILLER_4_957 VDD VSS / sg13g2_decap_8
XFILLER_4_96 VDD VSS / sg13g2_decap_8
XFILLER_4_964 VDD VSS / sg13g2_decap_8
XFILLER_4_971 VDD VSS / sg13g2_decap_8
XFILLER_4_978 VDD VSS / sg13g2_decap_8
XFILLER_4_985 VDD VSS / sg13g2_decap_8
XFILLER_4_992 VDD VSS / sg13g2_decap_8
XFILLER_4_999 VDD VSS / sg13g2_decap_8
XFILLER_50_1005 VDD VSS / sg13g2_decap_8
XFILLER_50_1012 VDD VSS / sg13g2_decap_8
XFILLER_50_1019 VDD VSS / sg13g2_decap_8
XFILLER_50_1026 VDD VSS / sg13g2_decap_8
XFILLER_50_1033 VDD VSS / sg13g2_decap_8
XFILLER_50_1040 VDD VSS / sg13g2_decap_8
XFILLER_50_1047 VDD VSS / sg13g2_decap_8
XFILLER_50_1054 VDD VSS / sg13g2_decap_8
XFILLER_50_1061 VDD VSS / sg13g2_decap_8
XFILLER_50_1068 VDD VSS / sg13g2_decap_8
XFILLER_50_1075 VDD VSS / sg13g2_decap_8
XFILLER_50_1082 VDD VSS / sg13g2_decap_8
XFILLER_50_1089 VDD VSS / sg13g2_decap_8
XFILLER_50_1096 VDD VSS / sg13g2_decap_8
XFILLER_50_1103 VDD VSS / sg13g2_decap_8
XFILLER_50_1110 VDD VSS / sg13g2_decap_8
XFILLER_50_1117 VDD VSS / sg13g2_decap_8
XFILLER_50_1124 VDD VSS / sg13g2_decap_8
XFILLER_50_1131 VDD VSS / sg13g2_decap_8
XFILLER_50_1138 VDD VSS / sg13g2_decap_8
XFILLER_50_1145 VDD VSS / sg13g2_decap_8
XFILLER_50_1152 VDD VSS / sg13g2_decap_8
XFILLER_50_1159 VDD VSS / sg13g2_decap_8
XFILLER_50_1166 VDD VSS / sg13g2_decap_8
XFILLER_50_1173 VDD VSS / sg13g2_decap_8
XFILLER_50_1180 VDD VSS / sg13g2_decap_8
XFILLER_50_1187 VDD VSS / sg13g2_decap_8
XFILLER_50_1194 VDD VSS / sg13g2_decap_8
XFILLER_50_1201 VDD VSS / sg13g2_decap_8
XFILLER_50_1208 VDD VSS / sg13g2_decap_8
XFILLER_50_1215 VDD VSS / sg13g2_decap_8
XFILLER_50_1222 VDD VSS / sg13g2_decap_8
XFILLER_50_1229 VDD VSS / sg13g2_decap_8
XFILLER_50_1236 VDD VSS / sg13g2_decap_8
XFILLER_50_1243 VDD VSS / sg13g2_decap_8
XFILLER_50_1250 VDD VSS / sg13g2_decap_8
XFILLER_50_1257 VDD VSS / sg13g2_decap_8
XFILLER_50_1264 VDD VSS / sg13g2_decap_8
XFILLER_50_1271 VDD VSS / sg13g2_decap_8
XFILLER_50_1278 VDD VSS / sg13g2_decap_8
XFILLER_50_1285 VDD VSS / sg13g2_decap_8
XFILLER_50_1292 VDD VSS / sg13g2_fill_2
XFILLER_50_1294 VDD VSS / sg13g2_fill_1
XFILLER_50_781 VDD VSS / sg13g2_decap_8
XFILLER_50_788 VDD VSS / sg13g2_decap_8
XFILLER_50_795 VDD VSS / sg13g2_decap_8
XFILLER_50_802 VDD VSS / sg13g2_decap_8
XFILLER_50_809 VDD VSS / sg13g2_decap_8
XFILLER_50_816 VDD VSS / sg13g2_decap_8
XFILLER_50_823 VDD VSS / sg13g2_decap_8
XFILLER_50_830 VDD VSS / sg13g2_decap_8
XFILLER_50_837 VDD VSS / sg13g2_decap_8
XFILLER_50_844 VDD VSS / sg13g2_decap_8
XFILLER_50_851 VDD VSS / sg13g2_decap_8
XFILLER_50_858 VDD VSS / sg13g2_decap_8
XFILLER_50_865 VDD VSS / sg13g2_decap_8
XFILLER_50_872 VDD VSS / sg13g2_decap_8
XFILLER_50_879 VDD VSS / sg13g2_decap_8
XFILLER_50_886 VDD VSS / sg13g2_decap_8
XFILLER_50_893 VDD VSS / sg13g2_decap_8
XFILLER_50_900 VDD VSS / sg13g2_decap_8
XFILLER_50_907 VDD VSS / sg13g2_decap_8
XFILLER_50_914 VDD VSS / sg13g2_decap_8
XFILLER_50_921 VDD VSS / sg13g2_decap_8
XFILLER_50_928 VDD VSS / sg13g2_decap_8
XFILLER_50_935 VDD VSS / sg13g2_decap_8
XFILLER_50_942 VDD VSS / sg13g2_decap_8
XFILLER_50_949 VDD VSS / sg13g2_decap_8
XFILLER_50_956 VDD VSS / sg13g2_decap_8
XFILLER_50_963 VDD VSS / sg13g2_decap_8
XFILLER_50_970 VDD VSS / sg13g2_decap_8
XFILLER_50_977 VDD VSS / sg13g2_decap_8
XFILLER_50_984 VDD VSS / sg13g2_decap_8
XFILLER_50_991 VDD VSS / sg13g2_decap_8
XFILLER_50_998 VDD VSS / sg13g2_decap_8
XFILLER_5_1006 VDD VSS / sg13g2_decap_8
XFILLER_5_1013 VDD VSS / sg13g2_decap_8
XFILLER_5_1020 VDD VSS / sg13g2_decap_8
XFILLER_5_1027 VDD VSS / sg13g2_decap_8
XFILLER_5_103 VDD VSS / sg13g2_decap_8
XFILLER_5_1034 VDD VSS / sg13g2_decap_8
XFILLER_5_1041 VDD VSS / sg13g2_decap_8
XFILLER_5_1048 VDD VSS / sg13g2_decap_8
XFILLER_5_1055 VDD VSS / sg13g2_decap_8
XFILLER_5_1062 VDD VSS / sg13g2_decap_8
XFILLER_5_1069 VDD VSS / sg13g2_decap_8
XFILLER_5_1076 VDD VSS / sg13g2_decap_8
XFILLER_5_1083 VDD VSS / sg13g2_decap_8
XFILLER_5_1090 VDD VSS / sg13g2_decap_8
XFILLER_5_1097 VDD VSS / sg13g2_decap_8
XFILLER_5_110 VDD VSS / sg13g2_decap_8
XFILLER_5_1104 VDD VSS / sg13g2_decap_8
XFILLER_5_1111 VDD VSS / sg13g2_decap_8
XFILLER_5_1118 VDD VSS / sg13g2_decap_8
XFILLER_5_1125 VDD VSS / sg13g2_decap_8
XFILLER_5_1132 VDD VSS / sg13g2_decap_8
XFILLER_5_1139 VDD VSS / sg13g2_decap_8
XFILLER_5_1146 VDD VSS / sg13g2_decap_8
XFILLER_5_1153 VDD VSS / sg13g2_decap_8
XFILLER_5_1160 VDD VSS / sg13g2_decap_8
XFILLER_5_1167 VDD VSS / sg13g2_decap_8
XFILLER_5_117 VDD VSS / sg13g2_decap_8
XFILLER_5_1174 VDD VSS / sg13g2_decap_8
XFILLER_5_1181 VDD VSS / sg13g2_decap_8
XFILLER_5_1188 VDD VSS / sg13g2_decap_8
XFILLER_5_1195 VDD VSS / sg13g2_decap_8
XFILLER_5_1202 VDD VSS / sg13g2_decap_8
XFILLER_5_1209 VDD VSS / sg13g2_decap_8
XFILLER_5_1216 VDD VSS / sg13g2_decap_8
XFILLER_5_1223 VDD VSS / sg13g2_decap_8
XFILLER_5_1230 VDD VSS / sg13g2_decap_8
XFILLER_5_1237 VDD VSS / sg13g2_decap_8
XFILLER_5_124 VDD VSS / sg13g2_decap_8
XFILLER_5_1244 VDD VSS / sg13g2_decap_8
XFILLER_5_1251 VDD VSS / sg13g2_decap_8
XFILLER_5_1258 VDD VSS / sg13g2_decap_8
XFILLER_5_1265 VDD VSS / sg13g2_decap_8
XFILLER_5_1272 VDD VSS / sg13g2_decap_8
XFILLER_5_1279 VDD VSS / sg13g2_decap_8
XFILLER_5_1286 VDD VSS / sg13g2_decap_8
XFILLER_5_1293 VDD VSS / sg13g2_fill_2
XFILLER_5_131 VDD VSS / sg13g2_decap_8
XFILLER_5_138 VDD VSS / sg13g2_decap_8
XFILLER_5_145 VDD VSS / sg13g2_decap_8
XFILLER_5_152 VDD VSS / sg13g2_decap_8
XFILLER_5_159 VDD VSS / sg13g2_decap_8
XFILLER_5_166 VDD VSS / sg13g2_decap_8
XFILLER_5_173 VDD VSS / sg13g2_decap_8
XFILLER_5_180 VDD VSS / sg13g2_decap_8
XFILLER_5_187 VDD VSS / sg13g2_decap_8
XFILLER_5_194 VDD VSS / sg13g2_decap_8
XFILLER_5_201 VDD VSS / sg13g2_decap_8
XFILLER_5_208 VDD VSS / sg13g2_decap_8
XFILLER_5_215 VDD VSS / sg13g2_decap_8
XFILLER_5_222 VDD VSS / sg13g2_decap_8
XFILLER_5_229 VDD VSS / sg13g2_decap_8
XFILLER_5_236 VDD VSS / sg13g2_decap_8
XFILLER_5_243 VDD VSS / sg13g2_decap_8
XFILLER_5_250 VDD VSS / sg13g2_decap_8
XFILLER_5_257 VDD VSS / sg13g2_decap_8
XFILLER_5_264 VDD VSS / sg13g2_decap_8
XFILLER_5_271 VDD VSS / sg13g2_decap_8
XFILLER_5_278 VDD VSS / sg13g2_decap_8
XFILLER_5_285 VDD VSS / sg13g2_decap_8
XFILLER_5_292 VDD VSS / sg13g2_decap_8
XFILLER_5_299 VDD VSS / sg13g2_decap_8
XFILLER_5_306 VDD VSS / sg13g2_decap_8
XFILLER_5_313 VDD VSS / sg13g2_decap_8
XFILLER_5_320 VDD VSS / sg13g2_decap_8
XFILLER_5_327 VDD VSS / sg13g2_decap_8
XFILLER_5_334 VDD VSS / sg13g2_decap_8
XFILLER_5_341 VDD VSS / sg13g2_decap_8
XFILLER_5_348 VDD VSS / sg13g2_decap_8
XFILLER_5_355 VDD VSS / sg13g2_decap_8
XFILLER_5_362 VDD VSS / sg13g2_decap_8
XFILLER_5_369 VDD VSS / sg13g2_decap_8
XFILLER_5_376 VDD VSS / sg13g2_decap_8
XFILLER_5_383 VDD VSS / sg13g2_decap_8
XFILLER_5_390 VDD VSS / sg13g2_decap_8
XFILLER_5_397 VDD VSS / sg13g2_decap_8
XFILLER_5_404 VDD VSS / sg13g2_decap_8
XFILLER_5_411 VDD VSS / sg13g2_decap_8
XFILLER_5_418 VDD VSS / sg13g2_decap_8
XFILLER_5_425 VDD VSS / sg13g2_decap_8
XFILLER_5_432 VDD VSS / sg13g2_decap_8
XFILLER_5_439 VDD VSS / sg13g2_decap_8
XFILLER_5_446 VDD VSS / sg13g2_decap_8
XFILLER_5_453 VDD VSS / sg13g2_decap_8
XFILLER_5_460 VDD VSS / sg13g2_decap_8
XFILLER_5_467 VDD VSS / sg13g2_decap_8
XFILLER_5_474 VDD VSS / sg13g2_decap_8
XFILLER_5_481 VDD VSS / sg13g2_decap_8
XFILLER_5_488 VDD VSS / sg13g2_decap_8
XFILLER_5_495 VDD VSS / sg13g2_decap_8
XFILLER_5_502 VDD VSS / sg13g2_decap_8
XFILLER_5_509 VDD VSS / sg13g2_decap_8
XFILLER_5_516 VDD VSS / sg13g2_decap_8
XFILLER_5_523 VDD VSS / sg13g2_decap_8
XFILLER_5_530 VDD VSS / sg13g2_decap_8
XFILLER_5_537 VDD VSS / sg13g2_decap_8
XFILLER_5_544 VDD VSS / sg13g2_decap_8
XFILLER_5_551 VDD VSS / sg13g2_decap_8
XFILLER_5_558 VDD VSS / sg13g2_decap_8
XFILLER_5_565 VDD VSS / sg13g2_decap_8
XFILLER_5_572 VDD VSS / sg13g2_decap_8
XFILLER_5_579 VDD VSS / sg13g2_decap_8
XFILLER_5_586 VDD VSS / sg13g2_decap_8
XFILLER_5_593 VDD VSS / sg13g2_decap_8
XFILLER_5_600 VDD VSS / sg13g2_decap_8
XFILLER_5_607 VDD VSS / sg13g2_decap_8
XFILLER_5_614 VDD VSS / sg13g2_decap_8
XFILLER_5_621 VDD VSS / sg13g2_decap_8
XFILLER_5_628 VDD VSS / sg13g2_decap_8
XFILLER_5_635 VDD VSS / sg13g2_decap_8
XFILLER_5_642 VDD VSS / sg13g2_decap_8
XFILLER_5_649 VDD VSS / sg13g2_decap_8
XFILLER_5_656 VDD VSS / sg13g2_decap_8
XFILLER_5_663 VDD VSS / sg13g2_decap_8
XFILLER_5_670 VDD VSS / sg13g2_decap_8
XFILLER_5_677 VDD VSS / sg13g2_decap_8
XFILLER_5_684 VDD VSS / sg13g2_decap_8
XFILLER_5_691 VDD VSS / sg13g2_decap_8
XFILLER_5_698 VDD VSS / sg13g2_decap_8
XFILLER_5_705 VDD VSS / sg13g2_decap_8
XFILLER_5_712 VDD VSS / sg13g2_decap_8
XFILLER_5_719 VDD VSS / sg13g2_decap_8
XFILLER_5_726 VDD VSS / sg13g2_decap_8
XFILLER_5_733 VDD VSS / sg13g2_decap_8
XFILLER_5_740 VDD VSS / sg13g2_decap_8
XFILLER_5_747 VDD VSS / sg13g2_decap_8
XFILLER_5_754 VDD VSS / sg13g2_decap_8
XFILLER_5_761 VDD VSS / sg13g2_decap_8
XFILLER_5_768 VDD VSS / sg13g2_decap_8
XFILLER_5_775 VDD VSS / sg13g2_decap_8
XFILLER_5_782 VDD VSS / sg13g2_decap_8
XFILLER_5_789 VDD VSS / sg13g2_decap_8
XFILLER_5_796 VDD VSS / sg13g2_decap_8
XFILLER_5_803 VDD VSS / sg13g2_decap_8
XFILLER_5_810 VDD VSS / sg13g2_decap_8
XFILLER_5_817 VDD VSS / sg13g2_decap_8
XFILLER_5_824 VDD VSS / sg13g2_decap_8
XFILLER_5_831 VDD VSS / sg13g2_decap_8
XFILLER_5_838 VDD VSS / sg13g2_decap_8
XFILLER_5_845 VDD VSS / sg13g2_decap_8
XFILLER_5_852 VDD VSS / sg13g2_decap_8
XFILLER_5_859 VDD VSS / sg13g2_decap_8
XFILLER_5_866 VDD VSS / sg13g2_decap_8
XFILLER_5_873 VDD VSS / sg13g2_decap_8
XFILLER_5_880 VDD VSS / sg13g2_decap_8
XFILLER_5_887 VDD VSS / sg13g2_decap_8
XFILLER_5_89 VDD VSS / sg13g2_decap_8
XFILLER_5_894 VDD VSS / sg13g2_decap_8
XFILLER_5_901 VDD VSS / sg13g2_decap_8
XFILLER_5_908 VDD VSS / sg13g2_decap_8
XFILLER_5_915 VDD VSS / sg13g2_decap_8
XFILLER_5_922 VDD VSS / sg13g2_decap_8
XFILLER_5_929 VDD VSS / sg13g2_decap_8
XFILLER_5_936 VDD VSS / sg13g2_decap_8
XFILLER_5_943 VDD VSS / sg13g2_decap_8
XFILLER_5_950 VDD VSS / sg13g2_decap_8
XFILLER_5_957 VDD VSS / sg13g2_decap_8
XFILLER_5_96 VDD VSS / sg13g2_decap_8
XFILLER_5_964 VDD VSS / sg13g2_decap_8
XFILLER_5_971 VDD VSS / sg13g2_decap_8
XFILLER_5_978 VDD VSS / sg13g2_decap_8
XFILLER_5_985 VDD VSS / sg13g2_decap_8
XFILLER_5_992 VDD VSS / sg13g2_decap_8
XFILLER_5_999 VDD VSS / sg13g2_decap_8
XFILLER_6_1006 VDD VSS / sg13g2_decap_8
XFILLER_6_1013 VDD VSS / sg13g2_decap_8
XFILLER_6_1020 VDD VSS / sg13g2_decap_8
XFILLER_6_1027 VDD VSS / sg13g2_decap_8
XFILLER_6_103 VDD VSS / sg13g2_decap_8
XFILLER_6_1034 VDD VSS / sg13g2_decap_8
XFILLER_6_1041 VDD VSS / sg13g2_decap_8
XFILLER_6_1048 VDD VSS / sg13g2_decap_8
XFILLER_6_1055 VDD VSS / sg13g2_decap_8
XFILLER_6_1062 VDD VSS / sg13g2_decap_8
XFILLER_6_1069 VDD VSS / sg13g2_decap_8
XFILLER_6_1076 VDD VSS / sg13g2_decap_8
XFILLER_6_1083 VDD VSS / sg13g2_decap_8
XFILLER_6_1090 VDD VSS / sg13g2_decap_8
XFILLER_6_1097 VDD VSS / sg13g2_decap_8
XFILLER_6_110 VDD VSS / sg13g2_decap_8
XFILLER_6_1104 VDD VSS / sg13g2_decap_8
XFILLER_6_1111 VDD VSS / sg13g2_decap_8
XFILLER_6_1118 VDD VSS / sg13g2_decap_8
XFILLER_6_1125 VDD VSS / sg13g2_decap_8
XFILLER_6_1132 VDD VSS / sg13g2_decap_8
XFILLER_6_1139 VDD VSS / sg13g2_decap_8
XFILLER_6_1146 VDD VSS / sg13g2_decap_8
XFILLER_6_1153 VDD VSS / sg13g2_decap_8
XFILLER_6_1160 VDD VSS / sg13g2_decap_8
XFILLER_6_1167 VDD VSS / sg13g2_decap_8
XFILLER_6_117 VDD VSS / sg13g2_decap_8
XFILLER_6_1174 VDD VSS / sg13g2_decap_8
XFILLER_6_1181 VDD VSS / sg13g2_decap_8
XFILLER_6_1188 VDD VSS / sg13g2_decap_8
XFILLER_6_1195 VDD VSS / sg13g2_decap_8
XFILLER_6_1202 VDD VSS / sg13g2_decap_8
XFILLER_6_1209 VDD VSS / sg13g2_decap_8
XFILLER_6_1216 VDD VSS / sg13g2_decap_8
XFILLER_6_1223 VDD VSS / sg13g2_decap_8
XFILLER_6_1230 VDD VSS / sg13g2_decap_8
XFILLER_6_1237 VDD VSS / sg13g2_decap_8
XFILLER_6_124 VDD VSS / sg13g2_decap_8
XFILLER_6_1244 VDD VSS / sg13g2_decap_8
XFILLER_6_1251 VDD VSS / sg13g2_decap_8
XFILLER_6_1258 VDD VSS / sg13g2_decap_8
XFILLER_6_1265 VDD VSS / sg13g2_decap_8
XFILLER_6_1272 VDD VSS / sg13g2_decap_8
XFILLER_6_1279 VDD VSS / sg13g2_decap_8
XFILLER_6_1286 VDD VSS / sg13g2_decap_8
XFILLER_6_1293 VDD VSS / sg13g2_fill_2
XFILLER_6_131 VDD VSS / sg13g2_decap_8
XFILLER_6_138 VDD VSS / sg13g2_decap_8
XFILLER_6_145 VDD VSS / sg13g2_decap_8
XFILLER_6_152 VDD VSS / sg13g2_decap_8
XFILLER_6_159 VDD VSS / sg13g2_decap_8
XFILLER_6_166 VDD VSS / sg13g2_decap_8
XFILLER_6_173 VDD VSS / sg13g2_decap_8
XFILLER_6_180 VDD VSS / sg13g2_decap_8
XFILLER_6_187 VDD VSS / sg13g2_decap_8
XFILLER_6_194 VDD VSS / sg13g2_decap_8
XFILLER_6_201 VDD VSS / sg13g2_decap_8
XFILLER_6_208 VDD VSS / sg13g2_decap_8
XFILLER_6_215 VDD VSS / sg13g2_decap_8
XFILLER_6_222 VDD VSS / sg13g2_decap_8
XFILLER_6_229 VDD VSS / sg13g2_decap_8
XFILLER_6_236 VDD VSS / sg13g2_decap_8
XFILLER_6_243 VDD VSS / sg13g2_decap_8
XFILLER_6_250 VDD VSS / sg13g2_decap_8
XFILLER_6_257 VDD VSS / sg13g2_decap_8
XFILLER_6_264 VDD VSS / sg13g2_decap_8
XFILLER_6_271 VDD VSS / sg13g2_decap_8
XFILLER_6_278 VDD VSS / sg13g2_decap_8
XFILLER_6_285 VDD VSS / sg13g2_decap_8
XFILLER_6_292 VDD VSS / sg13g2_decap_8
XFILLER_6_299 VDD VSS / sg13g2_decap_8
XFILLER_6_306 VDD VSS / sg13g2_decap_8
XFILLER_6_313 VDD VSS / sg13g2_decap_8
XFILLER_6_320 VDD VSS / sg13g2_decap_8
XFILLER_6_327 VDD VSS / sg13g2_decap_8
XFILLER_6_334 VDD VSS / sg13g2_decap_8
XFILLER_6_341 VDD VSS / sg13g2_decap_8
XFILLER_6_348 VDD VSS / sg13g2_decap_8
XFILLER_6_355 VDD VSS / sg13g2_decap_8
XFILLER_6_362 VDD VSS / sg13g2_decap_8
XFILLER_6_369 VDD VSS / sg13g2_decap_8
XFILLER_6_376 VDD VSS / sg13g2_decap_8
XFILLER_6_383 VDD VSS / sg13g2_decap_8
XFILLER_6_390 VDD VSS / sg13g2_decap_8
XFILLER_6_397 VDD VSS / sg13g2_decap_8
XFILLER_6_404 VDD VSS / sg13g2_decap_8
XFILLER_6_411 VDD VSS / sg13g2_decap_8
XFILLER_6_418 VDD VSS / sg13g2_decap_8
XFILLER_6_425 VDD VSS / sg13g2_decap_8
XFILLER_6_432 VDD VSS / sg13g2_decap_8
XFILLER_6_439 VDD VSS / sg13g2_decap_8
XFILLER_6_446 VDD VSS / sg13g2_decap_8
XFILLER_6_453 VDD VSS / sg13g2_decap_8
XFILLER_6_460 VDD VSS / sg13g2_decap_8
XFILLER_6_467 VDD VSS / sg13g2_decap_8
XFILLER_6_474 VDD VSS / sg13g2_decap_8
XFILLER_6_481 VDD VSS / sg13g2_decap_8
XFILLER_6_488 VDD VSS / sg13g2_decap_8
XFILLER_6_495 VDD VSS / sg13g2_decap_8
XFILLER_6_502 VDD VSS / sg13g2_decap_8
XFILLER_6_509 VDD VSS / sg13g2_decap_8
XFILLER_6_516 VDD VSS / sg13g2_decap_8
XFILLER_6_523 VDD VSS / sg13g2_decap_8
XFILLER_6_530 VDD VSS / sg13g2_decap_8
XFILLER_6_537 VDD VSS / sg13g2_decap_8
XFILLER_6_544 VDD VSS / sg13g2_decap_8
XFILLER_6_551 VDD VSS / sg13g2_decap_8
XFILLER_6_558 VDD VSS / sg13g2_decap_8
XFILLER_6_565 VDD VSS / sg13g2_decap_8
XFILLER_6_572 VDD VSS / sg13g2_decap_8
XFILLER_6_579 VDD VSS / sg13g2_decap_8
XFILLER_6_586 VDD VSS / sg13g2_decap_8
XFILLER_6_593 VDD VSS / sg13g2_decap_8
XFILLER_6_600 VDD VSS / sg13g2_decap_8
XFILLER_6_607 VDD VSS / sg13g2_decap_8
XFILLER_6_614 VDD VSS / sg13g2_decap_8
XFILLER_6_621 VDD VSS / sg13g2_decap_8
XFILLER_6_628 VDD VSS / sg13g2_decap_8
XFILLER_6_635 VDD VSS / sg13g2_decap_8
XFILLER_6_642 VDD VSS / sg13g2_decap_8
XFILLER_6_649 VDD VSS / sg13g2_decap_8
XFILLER_6_656 VDD VSS / sg13g2_decap_8
XFILLER_6_663 VDD VSS / sg13g2_decap_8
XFILLER_6_670 VDD VSS / sg13g2_decap_8
XFILLER_6_677 VDD VSS / sg13g2_decap_8
XFILLER_6_684 VDD VSS / sg13g2_decap_8
XFILLER_6_691 VDD VSS / sg13g2_decap_8
XFILLER_6_698 VDD VSS / sg13g2_decap_8
XFILLER_6_705 VDD VSS / sg13g2_decap_8
XFILLER_6_712 VDD VSS / sg13g2_decap_8
XFILLER_6_719 VDD VSS / sg13g2_decap_8
XFILLER_6_726 VDD VSS / sg13g2_decap_8
XFILLER_6_733 VDD VSS / sg13g2_decap_8
XFILLER_6_740 VDD VSS / sg13g2_decap_8
XFILLER_6_747 VDD VSS / sg13g2_decap_8
XFILLER_6_754 VDD VSS / sg13g2_decap_8
XFILLER_6_761 VDD VSS / sg13g2_decap_8
XFILLER_6_768 VDD VSS / sg13g2_decap_8
XFILLER_6_775 VDD VSS / sg13g2_decap_8
XFILLER_6_782 VDD VSS / sg13g2_decap_8
XFILLER_6_789 VDD VSS / sg13g2_decap_8
XFILLER_6_796 VDD VSS / sg13g2_decap_8
XFILLER_6_803 VDD VSS / sg13g2_decap_8
XFILLER_6_810 VDD VSS / sg13g2_decap_8
XFILLER_6_817 VDD VSS / sg13g2_decap_8
XFILLER_6_824 VDD VSS / sg13g2_decap_8
XFILLER_6_831 VDD VSS / sg13g2_decap_8
XFILLER_6_838 VDD VSS / sg13g2_decap_8
XFILLER_6_845 VDD VSS / sg13g2_decap_8
XFILLER_6_852 VDD VSS / sg13g2_decap_8
XFILLER_6_859 VDD VSS / sg13g2_decap_8
XFILLER_6_866 VDD VSS / sg13g2_decap_8
XFILLER_6_873 VDD VSS / sg13g2_decap_8
XFILLER_6_880 VDD VSS / sg13g2_decap_8
XFILLER_6_887 VDD VSS / sg13g2_decap_8
XFILLER_6_89 VDD VSS / sg13g2_decap_8
XFILLER_6_894 VDD VSS / sg13g2_decap_8
XFILLER_6_901 VDD VSS / sg13g2_decap_8
XFILLER_6_908 VDD VSS / sg13g2_decap_8
XFILLER_6_915 VDD VSS / sg13g2_decap_8
XFILLER_6_922 VDD VSS / sg13g2_decap_8
XFILLER_6_929 VDD VSS / sg13g2_decap_8
XFILLER_6_936 VDD VSS / sg13g2_decap_8
XFILLER_6_943 VDD VSS / sg13g2_decap_8
XFILLER_6_950 VDD VSS / sg13g2_decap_8
XFILLER_6_957 VDD VSS / sg13g2_decap_8
XFILLER_6_96 VDD VSS / sg13g2_decap_8
XFILLER_6_964 VDD VSS / sg13g2_decap_8
XFILLER_6_971 VDD VSS / sg13g2_decap_8
XFILLER_6_978 VDD VSS / sg13g2_decap_8
XFILLER_6_985 VDD VSS / sg13g2_decap_8
XFILLER_6_992 VDD VSS / sg13g2_decap_8
XFILLER_6_999 VDD VSS / sg13g2_decap_8
XFILLER_7_1006 VDD VSS / sg13g2_decap_8
XFILLER_7_1013 VDD VSS / sg13g2_decap_8
XFILLER_7_1020 VDD VSS / sg13g2_decap_8
XFILLER_7_1027 VDD VSS / sg13g2_decap_8
XFILLER_7_103 VDD VSS / sg13g2_decap_8
XFILLER_7_1034 VDD VSS / sg13g2_decap_8
XFILLER_7_1041 VDD VSS / sg13g2_decap_8
XFILLER_7_1048 VDD VSS / sg13g2_decap_8
XFILLER_7_1055 VDD VSS / sg13g2_decap_8
XFILLER_7_1062 VDD VSS / sg13g2_decap_8
XFILLER_7_1069 VDD VSS / sg13g2_decap_8
XFILLER_7_1076 VDD VSS / sg13g2_decap_8
XFILLER_7_1083 VDD VSS / sg13g2_decap_8
XFILLER_7_1090 VDD VSS / sg13g2_decap_8
XFILLER_7_1097 VDD VSS / sg13g2_decap_8
XFILLER_7_110 VDD VSS / sg13g2_decap_8
XFILLER_7_1104 VDD VSS / sg13g2_decap_8
XFILLER_7_1111 VDD VSS / sg13g2_decap_8
XFILLER_7_1118 VDD VSS / sg13g2_decap_8
XFILLER_7_1125 VDD VSS / sg13g2_decap_8
XFILLER_7_1132 VDD VSS / sg13g2_decap_8
XFILLER_7_1139 VDD VSS / sg13g2_decap_8
XFILLER_7_1146 VDD VSS / sg13g2_decap_8
XFILLER_7_1153 VDD VSS / sg13g2_decap_8
XFILLER_7_1160 VDD VSS / sg13g2_decap_8
XFILLER_7_1167 VDD VSS / sg13g2_decap_8
XFILLER_7_117 VDD VSS / sg13g2_decap_8
XFILLER_7_1174 VDD VSS / sg13g2_decap_8
XFILLER_7_1181 VDD VSS / sg13g2_decap_8
XFILLER_7_1188 VDD VSS / sg13g2_decap_8
XFILLER_7_1195 VDD VSS / sg13g2_decap_8
XFILLER_7_1202 VDD VSS / sg13g2_decap_8
XFILLER_7_1209 VDD VSS / sg13g2_decap_8
XFILLER_7_1216 VDD VSS / sg13g2_decap_8
XFILLER_7_1223 VDD VSS / sg13g2_decap_8
XFILLER_7_1230 VDD VSS / sg13g2_decap_8
XFILLER_7_1237 VDD VSS / sg13g2_decap_8
XFILLER_7_124 VDD VSS / sg13g2_decap_8
XFILLER_7_1244 VDD VSS / sg13g2_decap_8
XFILLER_7_1251 VDD VSS / sg13g2_decap_8
XFILLER_7_1258 VDD VSS / sg13g2_decap_8
XFILLER_7_1265 VDD VSS / sg13g2_decap_8
XFILLER_7_1272 VDD VSS / sg13g2_decap_8
XFILLER_7_1279 VDD VSS / sg13g2_decap_8
XFILLER_7_1286 VDD VSS / sg13g2_decap_8
XFILLER_7_1293 VDD VSS / sg13g2_fill_2
XFILLER_7_131 VDD VSS / sg13g2_decap_8
XFILLER_7_138 VDD VSS / sg13g2_decap_8
XFILLER_7_145 VDD VSS / sg13g2_decap_8
XFILLER_7_152 VDD VSS / sg13g2_decap_8
XFILLER_7_159 VDD VSS / sg13g2_decap_8
XFILLER_7_166 VDD VSS / sg13g2_decap_8
XFILLER_7_173 VDD VSS / sg13g2_decap_8
XFILLER_7_180 VDD VSS / sg13g2_decap_8
XFILLER_7_187 VDD VSS / sg13g2_decap_8
XFILLER_7_194 VDD VSS / sg13g2_decap_8
XFILLER_7_201 VDD VSS / sg13g2_decap_8
XFILLER_7_208 VDD VSS / sg13g2_decap_8
XFILLER_7_215 VDD VSS / sg13g2_decap_8
XFILLER_7_222 VDD VSS / sg13g2_decap_8
XFILLER_7_229 VDD VSS / sg13g2_decap_8
XFILLER_7_236 VDD VSS / sg13g2_decap_8
XFILLER_7_243 VDD VSS / sg13g2_decap_8
XFILLER_7_250 VDD VSS / sg13g2_decap_8
XFILLER_7_257 VDD VSS / sg13g2_decap_8
XFILLER_7_264 VDD VSS / sg13g2_decap_8
XFILLER_7_271 VDD VSS / sg13g2_decap_8
XFILLER_7_278 VDD VSS / sg13g2_decap_8
XFILLER_7_285 VDD VSS / sg13g2_decap_8
XFILLER_7_292 VDD VSS / sg13g2_decap_8
XFILLER_7_299 VDD VSS / sg13g2_decap_8
XFILLER_7_306 VDD VSS / sg13g2_decap_8
XFILLER_7_313 VDD VSS / sg13g2_decap_8
XFILLER_7_320 VDD VSS / sg13g2_decap_8
XFILLER_7_327 VDD VSS / sg13g2_decap_8
XFILLER_7_334 VDD VSS / sg13g2_decap_8
XFILLER_7_341 VDD VSS / sg13g2_decap_8
XFILLER_7_348 VDD VSS / sg13g2_decap_8
XFILLER_7_355 VDD VSS / sg13g2_decap_8
XFILLER_7_362 VDD VSS / sg13g2_decap_8
XFILLER_7_369 VDD VSS / sg13g2_decap_8
XFILLER_7_376 VDD VSS / sg13g2_decap_8
XFILLER_7_383 VDD VSS / sg13g2_decap_8
XFILLER_7_390 VDD VSS / sg13g2_decap_8
XFILLER_7_397 VDD VSS / sg13g2_decap_8
XFILLER_7_404 VDD VSS / sg13g2_decap_8
XFILLER_7_411 VDD VSS / sg13g2_decap_8
XFILLER_7_418 VDD VSS / sg13g2_decap_8
XFILLER_7_425 VDD VSS / sg13g2_decap_8
XFILLER_7_432 VDD VSS / sg13g2_decap_8
XFILLER_7_439 VDD VSS / sg13g2_decap_8
XFILLER_7_446 VDD VSS / sg13g2_decap_8
XFILLER_7_453 VDD VSS / sg13g2_decap_8
XFILLER_7_460 VDD VSS / sg13g2_decap_8
XFILLER_7_467 VDD VSS / sg13g2_decap_8
XFILLER_7_474 VDD VSS / sg13g2_decap_8
XFILLER_7_481 VDD VSS / sg13g2_decap_8
XFILLER_7_488 VDD VSS / sg13g2_decap_8
XFILLER_7_495 VDD VSS / sg13g2_decap_8
XFILLER_7_502 VDD VSS / sg13g2_decap_8
XFILLER_7_509 VDD VSS / sg13g2_decap_8
XFILLER_7_516 VDD VSS / sg13g2_decap_8
XFILLER_7_523 VDD VSS / sg13g2_decap_8
XFILLER_7_530 VDD VSS / sg13g2_decap_8
XFILLER_7_537 VDD VSS / sg13g2_decap_8
XFILLER_7_544 VDD VSS / sg13g2_decap_8
XFILLER_7_551 VDD VSS / sg13g2_decap_8
XFILLER_7_558 VDD VSS / sg13g2_decap_8
XFILLER_7_565 VDD VSS / sg13g2_decap_8
XFILLER_7_572 VDD VSS / sg13g2_decap_8
XFILLER_7_579 VDD VSS / sg13g2_decap_8
XFILLER_7_586 VDD VSS / sg13g2_decap_8
XFILLER_7_593 VDD VSS / sg13g2_decap_8
XFILLER_7_600 VDD VSS / sg13g2_decap_8
XFILLER_7_607 VDD VSS / sg13g2_decap_8
XFILLER_7_614 VDD VSS / sg13g2_decap_8
XFILLER_7_621 VDD VSS / sg13g2_decap_8
XFILLER_7_628 VDD VSS / sg13g2_decap_8
XFILLER_7_635 VDD VSS / sg13g2_decap_8
XFILLER_7_642 VDD VSS / sg13g2_decap_8
XFILLER_7_649 VDD VSS / sg13g2_decap_8
XFILLER_7_656 VDD VSS / sg13g2_decap_8
XFILLER_7_663 VDD VSS / sg13g2_decap_8
XFILLER_7_670 VDD VSS / sg13g2_decap_8
XFILLER_7_677 VDD VSS / sg13g2_decap_8
XFILLER_7_684 VDD VSS / sg13g2_decap_8
XFILLER_7_691 VDD VSS / sg13g2_decap_8
XFILLER_7_698 VDD VSS / sg13g2_decap_8
XFILLER_7_705 VDD VSS / sg13g2_decap_8
XFILLER_7_712 VDD VSS / sg13g2_decap_8
XFILLER_7_719 VDD VSS / sg13g2_decap_8
XFILLER_7_726 VDD VSS / sg13g2_decap_8
XFILLER_7_733 VDD VSS / sg13g2_decap_8
XFILLER_7_740 VDD VSS / sg13g2_decap_8
XFILLER_7_747 VDD VSS / sg13g2_decap_8
XFILLER_7_754 VDD VSS / sg13g2_decap_8
XFILLER_7_761 VDD VSS / sg13g2_decap_8
XFILLER_7_768 VDD VSS / sg13g2_decap_8
XFILLER_7_775 VDD VSS / sg13g2_decap_8
XFILLER_7_782 VDD VSS / sg13g2_decap_8
XFILLER_7_789 VDD VSS / sg13g2_decap_8
XFILLER_7_796 VDD VSS / sg13g2_decap_8
XFILLER_7_803 VDD VSS / sg13g2_decap_8
XFILLER_7_810 VDD VSS / sg13g2_decap_8
XFILLER_7_817 VDD VSS / sg13g2_decap_8
XFILLER_7_824 VDD VSS / sg13g2_decap_8
XFILLER_7_831 VDD VSS / sg13g2_decap_8
XFILLER_7_838 VDD VSS / sg13g2_decap_8
XFILLER_7_845 VDD VSS / sg13g2_decap_8
XFILLER_7_852 VDD VSS / sg13g2_decap_8
XFILLER_7_859 VDD VSS / sg13g2_decap_8
XFILLER_7_866 VDD VSS / sg13g2_decap_8
XFILLER_7_873 VDD VSS / sg13g2_decap_8
XFILLER_7_880 VDD VSS / sg13g2_decap_8
XFILLER_7_887 VDD VSS / sg13g2_decap_8
XFILLER_7_89 VDD VSS / sg13g2_decap_8
XFILLER_7_894 VDD VSS / sg13g2_decap_8
XFILLER_7_901 VDD VSS / sg13g2_decap_8
XFILLER_7_908 VDD VSS / sg13g2_decap_8
XFILLER_7_915 VDD VSS / sg13g2_decap_8
XFILLER_7_922 VDD VSS / sg13g2_decap_8
XFILLER_7_929 VDD VSS / sg13g2_decap_8
XFILLER_7_936 VDD VSS / sg13g2_decap_8
XFILLER_7_943 VDD VSS / sg13g2_decap_8
XFILLER_7_950 VDD VSS / sg13g2_decap_8
XFILLER_7_957 VDD VSS / sg13g2_decap_8
XFILLER_7_96 VDD VSS / sg13g2_decap_8
XFILLER_7_964 VDD VSS / sg13g2_decap_8
XFILLER_7_971 VDD VSS / sg13g2_decap_8
XFILLER_7_978 VDD VSS / sg13g2_decap_8
XFILLER_7_985 VDD VSS / sg13g2_decap_8
XFILLER_7_992 VDD VSS / sg13g2_decap_8
XFILLER_7_999 VDD VSS / sg13g2_decap_8
XFILLER_8_1001 VDD VSS / sg13g2_decap_8
XFILLER_8_1008 VDD VSS / sg13g2_decap_8
XFILLER_8_1015 VDD VSS / sg13g2_decap_8
XFILLER_8_1022 VDD VSS / sg13g2_decap_8
XFILLER_8_1029 VDD VSS / sg13g2_decap_8
XFILLER_8_1036 VDD VSS / sg13g2_decap_8
XFILLER_8_1043 VDD VSS / sg13g2_decap_8
XFILLER_8_1050 VDD VSS / sg13g2_decap_8
XFILLER_8_1057 VDD VSS / sg13g2_decap_8
XFILLER_8_1064 VDD VSS / sg13g2_decap_8
XFILLER_8_1071 VDD VSS / sg13g2_decap_8
XFILLER_8_1078 VDD VSS / sg13g2_decap_8
XFILLER_8_1085 VDD VSS / sg13g2_decap_8
XFILLER_8_1092 VDD VSS / sg13g2_decap_8
XFILLER_8_1099 VDD VSS / sg13g2_decap_8
XFILLER_8_1106 VDD VSS / sg13g2_decap_8
XFILLER_8_1113 VDD VSS / sg13g2_decap_8
XFILLER_8_1120 VDD VSS / sg13g2_decap_8
XFILLER_8_1127 VDD VSS / sg13g2_decap_8
XFILLER_8_1134 VDD VSS / sg13g2_decap_8
XFILLER_8_1141 VDD VSS / sg13g2_decap_8
XFILLER_8_1148 VDD VSS / sg13g2_decap_8
XFILLER_8_1155 VDD VSS / sg13g2_decap_8
XFILLER_8_1162 VDD VSS / sg13g2_decap_8
XFILLER_8_1169 VDD VSS / sg13g2_decap_8
XFILLER_8_1176 VDD VSS / sg13g2_decap_8
XFILLER_8_1183 VDD VSS / sg13g2_decap_8
XFILLER_8_1190 VDD VSS / sg13g2_decap_8
XFILLER_8_1197 VDD VSS / sg13g2_decap_8
XFILLER_8_1204 VDD VSS / sg13g2_decap_8
XFILLER_8_1211 VDD VSS / sg13g2_decap_8
XFILLER_8_1218 VDD VSS / sg13g2_decap_8
XFILLER_8_1225 VDD VSS / sg13g2_decap_8
XFILLER_8_1232 VDD VSS / sg13g2_decap_8
XFILLER_8_1239 VDD VSS / sg13g2_decap_8
XFILLER_8_1246 VDD VSS / sg13g2_decap_8
XFILLER_8_1253 VDD VSS / sg13g2_decap_8
XFILLER_8_1260 VDD VSS / sg13g2_decap_8
XFILLER_8_1267 VDD VSS / sg13g2_decap_8
XFILLER_8_1274 VDD VSS / sg13g2_decap_8
XFILLER_8_1281 VDD VSS / sg13g2_decap_8
XFILLER_8_1288 VDD VSS / sg13g2_decap_8
XFILLER_8_777 VDD VSS / sg13g2_decap_8
XFILLER_8_784 VDD VSS / sg13g2_decap_8
XFILLER_8_791 VDD VSS / sg13g2_decap_8
XFILLER_8_798 VDD VSS / sg13g2_decap_8
XFILLER_8_805 VDD VSS / sg13g2_decap_8
XFILLER_8_812 VDD VSS / sg13g2_decap_8
XFILLER_8_819 VDD VSS / sg13g2_decap_8
XFILLER_8_826 VDD VSS / sg13g2_decap_8
XFILLER_8_833 VDD VSS / sg13g2_decap_8
XFILLER_8_840 VDD VSS / sg13g2_decap_8
XFILLER_8_847 VDD VSS / sg13g2_decap_8
XFILLER_8_854 VDD VSS / sg13g2_decap_8
XFILLER_8_861 VDD VSS / sg13g2_decap_8
XFILLER_8_868 VDD VSS / sg13g2_decap_8
XFILLER_8_875 VDD VSS / sg13g2_decap_8
XFILLER_8_882 VDD VSS / sg13g2_decap_8
XFILLER_8_889 VDD VSS / sg13g2_decap_8
XFILLER_8_896 VDD VSS / sg13g2_decap_8
XFILLER_8_903 VDD VSS / sg13g2_decap_8
XFILLER_8_910 VDD VSS / sg13g2_decap_8
XFILLER_8_917 VDD VSS / sg13g2_decap_8
XFILLER_8_924 VDD VSS / sg13g2_decap_8
XFILLER_8_931 VDD VSS / sg13g2_decap_8
XFILLER_8_938 VDD VSS / sg13g2_decap_8
XFILLER_8_945 VDD VSS / sg13g2_decap_8
XFILLER_8_952 VDD VSS / sg13g2_decap_8
XFILLER_8_959 VDD VSS / sg13g2_decap_8
XFILLER_8_966 VDD VSS / sg13g2_decap_8
XFILLER_8_973 VDD VSS / sg13g2_decap_8
XFILLER_8_980 VDD VSS / sg13g2_decap_8
XFILLER_8_987 VDD VSS / sg13g2_decap_8
XFILLER_8_994 VDD VSS / sg13g2_decap_8
XFILLER_9_1001 VDD VSS / sg13g2_decap_8
XFILLER_9_1008 VDD VSS / sg13g2_decap_8
XFILLER_9_1015 VDD VSS / sg13g2_decap_8
XFILLER_9_1022 VDD VSS / sg13g2_decap_8
XFILLER_9_1029 VDD VSS / sg13g2_decap_8
XFILLER_9_1036 VDD VSS / sg13g2_decap_8
XFILLER_9_1043 VDD VSS / sg13g2_decap_8
XFILLER_9_1050 VDD VSS / sg13g2_decap_8
XFILLER_9_1057 VDD VSS / sg13g2_decap_8
XFILLER_9_1064 VDD VSS / sg13g2_decap_8
XFILLER_9_1071 VDD VSS / sg13g2_decap_8
XFILLER_9_1078 VDD VSS / sg13g2_decap_8
XFILLER_9_1085 VDD VSS / sg13g2_decap_8
XFILLER_9_1092 VDD VSS / sg13g2_decap_8
XFILLER_9_1099 VDD VSS / sg13g2_decap_8
XFILLER_9_1106 VDD VSS / sg13g2_decap_8
XFILLER_9_1113 VDD VSS / sg13g2_decap_8
XFILLER_9_1120 VDD VSS / sg13g2_decap_8
XFILLER_9_1127 VDD VSS / sg13g2_decap_8
XFILLER_9_1134 VDD VSS / sg13g2_decap_8
XFILLER_9_1141 VDD VSS / sg13g2_decap_8
XFILLER_9_1148 VDD VSS / sg13g2_decap_8
XFILLER_9_1155 VDD VSS / sg13g2_decap_8
XFILLER_9_1162 VDD VSS / sg13g2_decap_8
XFILLER_9_1169 VDD VSS / sg13g2_decap_8
XFILLER_9_1176 VDD VSS / sg13g2_decap_8
XFILLER_9_1183 VDD VSS / sg13g2_decap_8
XFILLER_9_1190 VDD VSS / sg13g2_decap_8
XFILLER_9_1197 VDD VSS / sg13g2_decap_8
XFILLER_9_1204 VDD VSS / sg13g2_decap_8
XFILLER_9_1211 VDD VSS / sg13g2_decap_8
XFILLER_9_1218 VDD VSS / sg13g2_decap_8
XFILLER_9_1225 VDD VSS / sg13g2_decap_8
XFILLER_9_1232 VDD VSS / sg13g2_decap_8
XFILLER_9_1239 VDD VSS / sg13g2_decap_8
XFILLER_9_1246 VDD VSS / sg13g2_decap_8
XFILLER_9_1253 VDD VSS / sg13g2_decap_8
XFILLER_9_1260 VDD VSS / sg13g2_decap_8
XFILLER_9_1267 VDD VSS / sg13g2_decap_8
XFILLER_9_1274 VDD VSS / sg13g2_decap_8
XFILLER_9_1281 VDD VSS / sg13g2_decap_8
XFILLER_9_1288 VDD VSS / sg13g2_decap_8
XFILLER_9_777 VDD VSS / sg13g2_decap_8
XFILLER_9_784 VDD VSS / sg13g2_decap_8
XFILLER_9_791 VDD VSS / sg13g2_decap_8
XFILLER_9_798 VDD VSS / sg13g2_decap_8
XFILLER_9_805 VDD VSS / sg13g2_decap_8
XFILLER_9_812 VDD VSS / sg13g2_decap_8
XFILLER_9_819 VDD VSS / sg13g2_decap_8
XFILLER_9_826 VDD VSS / sg13g2_decap_8
XFILLER_9_833 VDD VSS / sg13g2_decap_8
XFILLER_9_840 VDD VSS / sg13g2_decap_8
XFILLER_9_847 VDD VSS / sg13g2_decap_8
XFILLER_9_854 VDD VSS / sg13g2_decap_8
XFILLER_9_861 VDD VSS / sg13g2_decap_8
XFILLER_9_868 VDD VSS / sg13g2_decap_8
XFILLER_9_875 VDD VSS / sg13g2_decap_8
XFILLER_9_882 VDD VSS / sg13g2_decap_8
XFILLER_9_889 VDD VSS / sg13g2_decap_8
XFILLER_9_896 VDD VSS / sg13g2_decap_8
XFILLER_9_903 VDD VSS / sg13g2_decap_8
XFILLER_9_910 VDD VSS / sg13g2_decap_8
XFILLER_9_917 VDD VSS / sg13g2_decap_8
XFILLER_9_924 VDD VSS / sg13g2_decap_8
XFILLER_9_931 VDD VSS / sg13g2_decap_8
XFILLER_9_938 VDD VSS / sg13g2_decap_8
XFILLER_9_945 VDD VSS / sg13g2_decap_8
XFILLER_9_952 VDD VSS / sg13g2_decap_8
XFILLER_9_959 VDD VSS / sg13g2_decap_8
XFILLER_9_966 VDD VSS / sg13g2_decap_8
XFILLER_9_973 VDD VSS / sg13g2_decap_8
XFILLER_9_980 VDD VSS / sg13g2_decap_8
XFILLER_9_987 VDD VSS / sg13g2_decap_8
XFILLER_9_994 VDD VSS / sg13g2_decap_8
Xi_core_u_bgr VDDA VSS i_core_bgr_r4_33 i_core_vref i_core_iptat i_core_pbias i_core_pcasc i_core_unused_vbe i_core_dvbe / g1_bgr
Xi_core_u_digital i_core_bgr_r4_12 i_core_clk_div_out i_core_clr_d i_core_cmp_clk i_core_cmp_hard i_core_cmp_soft en_i i_core_fast_en i_core_fault_n_dig i_core_gate_en i_core_osc_clk i_core_osc_en net i_core_sclk_i i_core_sdi_i i_core_sdo_o i_core_t2f_en_12 i_core_t2f_mode_12 i_core_trip i_core_trip_d i_core_trip_set_sel i_core_tripped VDD VSS i_core_dac_hard_7_ i_core_dac_hard_6_ i_core_dac_hard_5_ i_core_dac_hard_4_ i_core_dac_hard_3_ i_core_dac_hard_2_ i_core_dac_hard_1_ i_core_dac_hard_0_ i_core_dac_soft_7_ i_core_dac_soft_6_ i_core_dac_soft_5_ i_core_dac_soft_4_ i_core_dac_soft_3_ i_core_dac_soft_2_ i_core_dac_soft_1_ i_core_dac_soft_0_ i_core_osc_trim_3_ i_core_osc_trim_2_ i_core_osc_trim_1_ i_core_osc_trim_0_ i_core_trip_cause_1_ i_core_trip_cause_0_ / g1_digital
Xi_core_u_digital_1 net VDD VSS / sg13g2_tiehi
Xi_core_u_dose D_ELT D_STD G_SHARED VSS / g1_dose_macro
Xi_core_u_dut HBT_C HBT_B HBT_E VSS / g1_dut_macro
Xi_core_u_gate i_core_trip_d i_core_clr_d i_core_fast_en i_core_cmp_hard en_i gate_o fault_n_o i_core_tripped VDD VDDA VSS / g1_gate
Xi_core_u_ls_en i_core_t2f_en_12 i_core_t2f_en_33 VDD VDDA VSS / g1_ls_up
Xi_core_u_ls_mode i_core_t2f_mode_12 i_core_t2f_mode_33 VDD VDDA VSS / g1_ls_up
Xi_core_u_ls_r4 i_core_bgr_r4_12 i_core_bgr_r4_33 VDD VDDA VSS / g1_ls_up
Xi_core_u_osc i_core_osc_en i_core_osc_trim_0_ i_core_osc_trim_1_ i_core_osc_trim_2_ i_core_osc_trim_3_ i_core_osc_clk VDD VSS / g1_osc
Xi_core_u_sense SENSE_P SENSE_N i_core_vref i_core_iptat i_core_isense i_core_unused_vped i_core_vref_buf VDDA VSS / g1_sense
Xi_core_u_t2f VDDA VDD VSS i_core_pbias i_core_pcasc i_core_vref i_core_t2f_en_33 i_core_t2f_mode_33 i_core_temp_out_o / g1_t2f
Xi_core_u_trip i_core_isense i_core_vref_buf i_core_cmp_clk i_core_dac_soft_0_ i_core_dac_soft_1_ i_core_dac_soft_2_ i_core_dac_soft_3_ i_core_dac_soft_4_ i_core_dac_soft_5_ i_core_dac_soft_6_ i_core_dac_soft_7_ i_core_dac_hard_0_ i_core_dac_hard_1_ i_core_dac_hard_2_ i_core_dac_hard_3_ i_core_dac_hard_4_ i_core_dac_hard_5_ i_core_dac_hard_6_ i_core_dac_hard_7_ i_core_cmp_soft i_core_cmp_hard VDD VDDA VSS / g1_trip
.ENDS
