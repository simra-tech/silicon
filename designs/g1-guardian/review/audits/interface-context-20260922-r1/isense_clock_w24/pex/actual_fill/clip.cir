* cell sense_fill_clip
.SUBCKT sense_fill_clip
* net 2 FILL_L10_3
* net 3 FILL_L8_4
* net 4 FILL_L8_5
* net 5 CTX_L126_0,CTX_L30_0,CTX_L50_1,CTX_L67_0
* net 6 FILL_L30_2
* net 7 FILL_L8_0
* net 8 FILL_L10_4
* net 9 FILL_L30_3
* net 10 CTX_L134_0
* net 11 FILL_L10_0
* net 12 FILL_L10_1
* net 13 FILL_L8_1
* net 14 FILL_L10_2
* net 15 FILL_L8_2
* net 16 FILL_L30_0
* net 17 CTX_L8_0
* net 18 FILL_L10_6
* net 19 FILL_L30_1
* net 20 FILL_L8_3
* net 21 FILL_L67_0
* net 22 FILL_L8_6
* net 23 FILL_L67_1
* net 24 FILL_L10_5
* net 25 CTX_L30_8,CTX_L50_0
* net 26 FILL_L67_2
* net 27 CTX_L10_0,CTX_L30_1,CTX_L8_1
* net 28 FILL_L30_4
* net 29 FILL_L126_0
* net 30 FILL_L67_3
* net 31 FILL_L30_6
* net 32 FILL_L8_8
* net 33 FILL_L10_7
* net 34 CTX_L30_2,CTX_L50_3
* net 35 CTX_L30_3
* net 36 FILL_L8_9
* net 37 FILL_L8_7
* net 38 CTX_L10_1,CTX_L10_3,CTX_L30_4
* net 39 FILL_L30_5
* net 40 FILL_L10_8
* net 41 FILL_L67_4
* net 42 FILL_L67_5
* net 43 FILL_L8_10
* net 44 FILL_L67_6
* net 45 CTX_L134_1
* net 46 FILL_L50_0
* net 47 FILL_L8_11
* net 48 FILL_L8_12
* net 49 FILL_L50_2
* net 50 FILL_L67_7
* net 51 FILL_L8_13
* net 52 FILL_L8_14
* net 53 FILL_L67_8
* net 54 FILL_L50_3
* net 55 FILL_L8_15
* net 56 FILL_L10_9
* net 57 CTX_L50_2
* net 58 CTX_L10_2
* net 59 CTX_L50_4
* net 60 FILL_L30_8
* net 61 FILL_L8_16
* net 62 CTX_L50_5
* net 63 FILL_L30_9
* net 64 CTX_L50_6
* net 65 CTX_L50_7
* net 66 CTX_L8_2
* net 67 P
* net 68 N
* net 69 FILL_L50_1
* net 70 FILL_L8_17
* net 71 FILL_L10_10
* net 72 FILL_L30_7
* net 73 FILL_L30_11
* net 74 FILL_L8_18
* net 75 FILL_L10_11
* net 76 FILL_L67_9
* net 77 CTX_L30_5
* net 78 CTX_L30_6
* net 79 FILL_L8_19
* net 80 FILL_L67_10
* net 81 FILL_L30_12
* net 82 FILL_L8_20
* net 83 FILL_L30_13
* net 84 FILL_L67_11
* net 85 FILL_L50_4
* net 86 FILL_L10_12
* net 87 FILL_L8_21
* net 88 FILL_L10_13
* net 89 FILL_L8_22
* net 90 FILL_L50_6
* net 91 FILL_L67_12
* net 92 FILL_L30_10
* net 93 FILL_L8_23
* net 94 FILL_L10_14
* net 95 FILL_L50_7
* net 96 FILL_L67_13
* net 97 FILL_L8_26
* net 98 FILL_L10_15
* net 99 FILL_L10_17
* net 100 FILL_L67_14
* net 101 CTX_L30_7
* net 102 FILL_L8_27
* net 103 FILL_L67_15
* net 104 FILL_L30_15
* net 105 FILL_L30_14
* net 106 FILL_L8_28
* net 107 FILL_L8_24
* net 108 FILL_L67_16
* net 109 FILL_L50_8
* net 110 FILL_L50_5
* net 111 FILL_L10_16
* net 112 FILL_L8_25
* net 113 FILL_L8_29
* net 114 FILL_L10_18
* net 115 FILL_L8_30
* net 116 FILL_L10_19
* net 117 FILL_L67_17
* net 118 FILL_L50_9
* net 119 FILL_L10_20
* net 120 FILL_L8_31
* net 121 FILL_L50_10
* net 122 FILL_L67_18
* net 123 FILL_L8_32
* net 124 FILL_L10_21
* net 125 FILL_L8_33
* net 126 FILL_L8_34
* net 127 FILL_L10_22
* net 128 FILL_L8_35
* net 129 FILL_L10_23
* net 130 FILL_L8_36
* net 131 FILL_L10_24
* net 132 FILL_L8_37
* net 133 FILL_L8_38
* net 134 FILL_L10_25
* net 135 FILL_L8_39
* net 136 FILL_L10_26
.ENDS sense_fill_clip
