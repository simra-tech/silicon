*********************************************************
*** NGSPICE file created by KLayout-PEX 0.3.12
*** -----------------------------------------------------
***     Extraction Engine: KPEX/2.5D
***     Technology: ihp_sg13g2
***     Date: 2026-09-22 15:40:39
*********************************************************

.SUBCKT sense_fill_clip
Cext_1 CTX_L10_0|CTX_L30_0|CTX_L8_0 CTX_L126_0|CTX_L134_0 53.9166a
Cext_2 CTX_L10_0|CTX_L30_0|CTX_L8_0 CTX_L126_1 40.0577a
Cext_3 CTX_L10_0|CTX_L30_0|CTX_L8_0 CTX_L126_2|CTX_L50_2|CTX_L67_0 20.2316f
Cext_4 CTX_L10_0|CTX_L30_0|CTX_L8_0 P 4.71142a
Cext_5 CTX_L10_0|CTX_L30_0|CTX_L8_0 VSUBS 7.65311f
Cext_6 CTX_L126_0|CTX_L134_0 CTX_L126_1 3.19489f
Cext_7 CTX_L126_0|CTX_L134_0 CTX_L126_2|CTX_L50_2|CTX_L67_0 3.9007f
Cext_8 CTX_L126_0|CTX_L134_0 P 66.404a
Cext_9 CTX_L126_0|CTX_L134_0 VSUBS 5.23073f
Cext_10 CTX_L126_1 CTX_L126_2|CTX_L50_2|CTX_L67_0 595.27a
Cext_11 CTX_L126_1 N 1.71248f
Cext_12 CTX_L126_1 P 548.317a
Cext_13 CTX_L126_1 VSUBS 3.5726f
Cext_14 CTX_L126_2|CTX_L50_2|CTX_L67_0 P 164.211a
Cext_15 CTX_L126_2|CTX_L50_2|CTX_L67_0 VSUBS 6.30685f
Cext_16 N P 494.271a
Cext_17 N VSUBS 1.38256f
Cext_18 P VSUBS 835.728a
.ENDS sense_fill_clip
