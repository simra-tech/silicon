* cell sense_fill_clip
.SUBCKT sense_fill_clip
* net 2 CTX_L126_2,CTX_L50_2,CTX_L67_0
* net 3 CTX_L10_0,CTX_L30_0,CTX_L8_0
* net 4 CTX_L126_0,CTX_L134_0
* net 5 CTX_L126_1
* net 6 N
* net 7 P
.ENDS sense_fill_clip
