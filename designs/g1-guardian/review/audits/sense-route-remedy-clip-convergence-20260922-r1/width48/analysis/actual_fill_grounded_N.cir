* actual_fill grounded drive N; diagnostic capacitor-network AC only
C64 0 P 3.0624200000000002e-18
C145 0 P 4.6038100000000002e-17
C236 0 N 1.53134e-15
C237 0 P 5.4831700000000005e-16
C263 0 P 1.0868200000000001e-16
C319 0 N 2.8846700000000002e-18
C330 0 N 3.9447900000000001e-17
C338 0 N 1.15514e-16
C339 0 P 2.8584100000000002e-17
C352 0 P 8.9281499999999994e-17
C361 0 P 4.0051600000000003e-18
C427 0 N 9.6155500000000016e-19
C437 0 N 2.6568300000000004e-17
C444 0 N 7.0157100000000007e-17
C445 0 P 1.7113500000000001e-17
C457 0 P 8.9281499999999994e-17
C465 0 P 4.0051600000000003e-18
C523 0 N 2.0128599999999999e-17
C529 0 N 4.4774400000000001e-17
C530 0 P 1.13782e-17
C540 0 P 8.2002300000000006e-17
C547 0 N 2.87551e-18
C557 0 P 3.2041300000000005e-18
C608 0 N 1.9231100000000003e-18
C617 0 N 3.0132600000000003e-17
C623 0 N 8.9148100000000001e-17
C624 0 P 2.12233e-17
C629 0 N 9.8324800000000015e-19
C630 0 P 1.6254500000000001e-18
C639 0 P 7.4447200000000006e-17
C646 0 P 3.2041300000000005e-18
C664 0 P 7.5550600000000002e-18
C680 0 P 3.6514799999999999e-18
C707 0 N 4.9648100000000005e-18
C716 0 N 9.4484500000000007e-16
C717 0 P 1.6977000000000002e-16
C722 0 P 3.6514799999999999e-18
C727 0 P 3.6514799999999999e-18
C760 0 N 4.9648100000000005e-18
C767 0 N 9.4484500000000007e-16
C768 0 P 1.6977000000000002e-16
C782 0 P 3.6514799999999999e-18
C786 0 P 3.6514799999999999e-18
C807 0 N 2.4824000000000004e-18
C811 0 N 4.7242300000000004e-16
C812 0 P 8.4884800000000009e-17
C827 0 N 4.9648100000000005e-18
C834 0 N 8.7084400000000013e-16
C835 0 P 1.6977000000000002e-16
C839 0 P 3.6514799999999999e-18
C844 0 P 3.6514799999999999e-18
C859 0 P 3.9494400000000005e-17
C867 0 N 1.1294400000000001e-16
C871 0 P 3.9494400000000005e-17
C874 0 P 3.9494400000000005e-17
C889 0 N 1.1294400000000001e-16
C892 0 P 3.9494400000000005e-17
C894 0 P 3.9494400000000005e-17
C905 0 N 5.64721e-17
C910 0 N 1.1294400000000001e-16
C913 0 P 3.9494400000000005e-17
C915 0 P 3.9494400000000005e-17
C945 0 N 2.2955000000000002e-18
C950 0 N 5.9953800000000002e-18
C951 0 P 4.8823900000000006e-18
C956 0 P 5.1604000000000007e-18
C990 0 N 2.2955000000000002e-18
C994 0 N 1.52694e-17
C995 0 P 4.8823900000000006e-18
C999 0 P 5.1604000000000007e-18
C1030 0 N 2.2955000000000002e-18
C1034 0 N 1.85099e-17
C1035 0 P 4.8823900000000006e-18
C1038 0 N 3.2792900000000005e-19
C1042 0 P 5.1604000000000007e-18
C1066 0 N 3.7572800000000005e-19
C1067 0 P 6.9748400000000006e-19
C1070 0 N 1.9675800000000004e-18
C1073 0 N 8.8601800000000006e-18
C1074 0 P 4.1849e-18
C1077 0 P 4.4231999999999997e-18
C1086 0 P 7.3720000000000001e-19
C1092 N P 4.9427100000000006e-16
C1093 N 0 5.3047500000000011e-16
C1094 P 0 3.5934700000000001e-16
VP P 0 DC 0 AC 0
VN N 0 DC 0 AC 1
.control
set numdgt=17
ac lin 1 1Meg 1Meg
let cp = -imag(i(VP))/(2*pi*1e6)
let cn = -imag(i(VN))/(2*pi*1e6)
print cp cn
quit
.endc
.end
