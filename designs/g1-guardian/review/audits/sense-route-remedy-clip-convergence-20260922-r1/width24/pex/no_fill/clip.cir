* cell sense_fill_clip
.SUBCKT sense_fill_clip
* net 1 CTX_L30_0
* net 2 N
* net 3 P
* net 4 CTX_L126_1,CTX_L50_2,CTX_L67_0
* net 5 CTX_L126_0
* net 6 CTX_L134_0
.ENDS sense_fill_clip
