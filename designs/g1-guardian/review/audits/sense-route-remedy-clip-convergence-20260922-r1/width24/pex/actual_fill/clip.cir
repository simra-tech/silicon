* cell sense_fill_clip
.SUBCKT sense_fill_clip
* net 2 FILL_L67_1
* net 3 FILL_L50_1
* net 4 FILL_L30_1
* net 5 FILL_L8_0
* net 6 FILL_L10_0
* net 7 FILL_L30_2
* net 8 FILL_L67_2
* net 9 FILL_L50_2
* net 10 FILL_L8_1
* net 11 FILL_L10_1
* net 12 FILL_L8_2
* net 13 FILL_L10_2
* net 14 FILL_L67_3
* net 15 FILL_L30_3
* net 16 FILL_L50_0
* net 17 FILL_L67_0
* net 18 FILL_L30_0
* net 19 FILL_L10_3
* net 20 FILL_L8_3
* net 21 FILL_L8_4
* net 22 FILL_L10_4
* net 23 CTX_L126_1,CTX_L50_2,CTX_L67_0
* net 24 FILL_L10_5
* net 25 FILL_L8_5
* net 26 FILL_L10_6
* net 27 FILL_L8_6
* net 28 FILL_L8_7
* net 29 FILL_L10_7
* net 30 FILL_L50_3
* net 31 FILL_L67_5
* net 32 FILL_L30_5
* net 33 FILL_L50_4
* net 34 FILL_L30_4
* net 35 FILL_L67_4
* net 36 FILL_L8_8
* net 37 FILL_L10_8
* net 38 FILL_L8_9
* net 39 FILL_L10_9
* net 40 FILL_L50_5
* net 41 FILL_L67_6
* net 42 FILL_L30_6
* net 43 FILL_L10_10
* net 44 FILL_L8_10
* net 45 FILL_L67_7
* net 46 FILL_L30_7
* net 47 FILL_L50_6
* net 48 FILL_L10_11
* net 49 FILL_L8_11
* net 50 CTX_L126_0
* net 51 N
* net 52 FILL_L8_12
* net 53 FILL_L10_12
* net 54 FILL_L30_8
* net 55 FILL_L67_8
* net 56 P
* net 57 FILL_L67_9
* net 58 FILL_L50_7
* net 59 FILL_L30_9
* net 60 FILL_L10_13
* net 61 FILL_L8_13
* net 62 FILL_L10_14
* net 63 FILL_L8_14
* net 64 CTX_L30_0
* net 65 FILL_L8_15
* net 66 FILL_L10_15
* net 67 FILL_L8_16
* net 68 FILL_L10_16
* net 69 FILL_L8_17
* net 70 FILL_L10_17
* net 71 FILL_L30_10
* net 72 FILL_L67_10
* net 73 FILL_L50_8
* net 74 FILL_L10_18
* net 75 FILL_L8_18
* net 76 FILL_L8_19
* net 77 FILL_L10_19
* net 78 FILL_L67_11
* net 79 FILL_L50_9
* net 80 FILL_L30_11
* net 81 FILL_L30_12
* net 82 FILL_L50_10
* net 83 FILL_L67_12
* net 84 FILL_L30_13
* net 85 CTX_L134_0
* net 86 FILL_L67_13
* net 87 FILL_L67_14
* net 88 FILL_L30_14
* net 89 FILL_L50_11
* net 90 FILL_L30_16
* net 91 FILL_L50_13
* net 92 FILL_L67_16
* net 93 FILL_L8_20
* net 94 FILL_L10_20
* net 95 FILL_L67_17
* net 96 FILL_L50_14
* net 97 FILL_L30_17
* net 98 FILL_L10_21
* net 99 FILL_L8_21
* net 100 FILL_L8_22
* net 101 FILL_L10_22
* net 102 FILL_L30_18
* net 103 FILL_L67_18
* net 104 FILL_L67_15
* net 105 FILL_L30_15
* net 106 FILL_L50_12
* net 107 FILL_L10_23
* net 108 FILL_L8_23
* net 109 FILL_L8_24
* net 110 FILL_L10_24
.ENDS sense_fill_clip
