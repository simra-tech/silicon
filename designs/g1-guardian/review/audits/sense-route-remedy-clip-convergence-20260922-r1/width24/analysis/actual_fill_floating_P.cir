* actual_fill floating drive P; diagnostic capacitor-network AC only
C3 0 FILL_L10_0 1.2756000000000001e-17
C4 0 FILL_L10_1 6.0895900000000006e-18
C5 0 FILL_L10_10 8.0474700000000008e-17
C6 0 FILL_L10_11 6.2784700000000011e-17
C7 0 FILL_L10_12 2.6335800000000001e-17
C8 0 FILL_L10_13 9.1861300000000003e-17
C9 0 FILL_L10_14 1.4924700000000002e-17
C10 0 FILL_L10_15 7.2219800000000017e-17
C11 0 FILL_L10_16 5.1298700000000003e-17
C12 0 FILL_L10_17 2.1446500000000001e-17
C13 0 FILL_L10_18 8.7459600000000006e-17
C14 0 FILL_L10_19 1.4924700000000002e-17
C15 0 FILL_L10_2 2.0268600000000002e-18
C16 0 FILL_L10_20 7.4240300000000007e-17
C17 0 FILL_L10_21 6.488970000000001e-17
C18 0 FILL_L10_22 2.7826899999999998e-17
C19 0 FILL_L10_23 7.7241299999999999e-17
C20 0 FILL_L10_24 1.2792600000000001e-17
C21 0 FILL_L10_3 1.13531e-17
C22 0 FILL_L10_4 2.1320899999999999e-18
C23 0 FILL_L10_5 9.5251100000000006e-17
C24 0 FILL_L10_6 8.2465300000000008e-17
C25 0 FILL_L10_7 3.4743000000000007e-17
C26 0 FILL_L10_8 9.2996e-17
C27 0 FILL_L10_9 1.4924700000000002e-17
C28 0 FILL_L30_0 3.3841600000000003e-18
C29 0 FILL_L30_1 4.1664900000000007e-17
C30 0 FILL_L30_10 3.3841600000000003e-18
C31 0 FILL_L30_11 5.3462400000000009e-17
C32 0 FILL_L30_12 1.1616700000000002e-16
C33 0 FILL_L30_13 1.5336100000000001e-16
C34 0 FILL_L30_14 3.3841600000000003e-18
C35 0 FILL_L30_15 3.3841600000000003e-18
C36 0 FILL_L30_16 2.6731200000000005e-17
C37 0 FILL_L30_17 5.808350000000001e-17
C38 0 FILL_L30_18 7.668040000000001e-17
C39 0 FILL_L30_2 8.6299800000000016e-17
C40 0 FILL_L30_3 1.4029400000000003e-16
C41 0 FILL_L30_4 3.3841600000000003e-18
C42 0 FILL_L30_5 3.3841600000000003e-18
C43 0 FILL_L30_6 5.3462400000000009e-17
C44 0 FILL_L30_7 1.1616700000000002e-16
C45 0 FILL_L30_8 1.5336100000000001e-16
C46 0 FILL_L30_9 3.3841600000000003e-18
C47 0 FILL_L50_0 1.8184500000000001e-17
C48 0 FILL_L50_1 2.2051900000000001e-16
C49 0 FILL_L50_10 5.0919e-16
C50 0 FILL_L50_11 1.8184500000000001e-17
C51 0 FILL_L50_12 1.8184500000000001e-17
C52 0 FILL_L50_13 1.2039100000000001e-16
C53 0 FILL_L50_14 2.54595e-16
C54 0 FILL_L50_2 4.5789299999999998e-16
C55 0 FILL_L50_3 1.8184500000000001e-17
C56 0 FILL_L50_4 1.8184500000000001e-17
C57 0 FILL_L50_5 2.4078200000000002e-16
C58 0 FILL_L50_6 5.0919e-16
C59 0 FILL_L50_7 1.8184500000000001e-17
C60 0 FILL_L50_8 1.8184500000000001e-17
C61 0 FILL_L50_9 2.4078200000000002e-16
C62 0 FILL_L8_0 3.1992900000000003e-18
C63 0 FILL_L8_1 2.0748700000000004e-18
C64 0 FILL_L8_10 1.2673600000000002e-17
C65 0 FILL_L8_11 1.8010700000000002e-17
C66 0 FILL_L8_12 1.1296700000000001e-17
C67 0 FILL_L8_13 4.1769700000000002e-18
C68 0 FILL_L8_15 1.3052000000000001e-17
C69 0 FILL_L8_16 1.9289500000000002e-17
C70 0 FILL_L8_17 1.1774200000000002e-17
C71 0 FILL_L8_18 3.8630300000000002e-18
C72 0 FILL_L8_2 1.1131200000000001e-18
C73 0 FILL_L8_20 8.1246800000000001e-18
C74 0 FILL_L8_21 1.2813000000000001e-17
C75 0 FILL_L8_22 8.9378700000000016e-18
C76 0 FILL_L8_23 3.3639800000000005e-18
C77 0 FILL_L8_3 1.1269300000000001e-18
C78 0 FILL_L8_5 1.0945499999999999e-17
C79 0 FILL_L8_6 1.3609100000000001e-17
C80 0 FILL_L8_7 9.5735800000000002e-18
C81 0 FILL_L8_8 4.8048500000000003e-18
C82 0 N 1.53134e-15
C83 0 P 5.4831700000000005e-16
C87 0 FILL_L10_12 3.4458800000000001e-19
C88 0 FILL_L10_13 1.2096500000000001e-16
C89 0 FILL_L10_14 9.6428200000000012e-17
C90 0 FILL_L10_18 1.14996e-16
C91 0 FILL_L10_19 9.6428200000000012e-17
C92 0 FILL_L10_22 6.8917600000000003e-19
C93 0 FILL_L10_23 1.01979e-16
C94 0 FILL_L10_24 8.2652700000000004e-17
C95 0 FILL_L10_3 1.30175e-17
C96 0 FILL_L10_4 1.37755e-17
C97 0 FILL_L10_7 1.0337600000000001e-18
C98 0 FILL_L10_8 1.2096500000000001e-16
C99 0 FILL_L10_9 9.6428200000000012e-17
C100 0 FILL_L30_13 4.0385200000000008e-18
C101 0 FILL_L30_18 2.0192600000000004e-18
C102 0 FILL_L30_3 4.0385200000000008e-18
C103 0 FILL_L30_8 4.0385200000000008e-18
C104 0 FILL_L50_0 1.7627800000000001e-17
C105 0 FILL_L50_11 1.7627800000000001e-17
C106 0 FILL_L50_12 1.7627800000000001e-17
C107 0 FILL_L50_3 1.7627800000000001e-17
C108 0 FILL_L50_4 1.7627800000000001e-17
C109 0 FILL_L50_7 1.7627800000000001e-17
C110 0 FILL_L50_8 1.7627800000000001e-17
C111 0 P 1.0868200000000001e-16
C114 0 FILL_L10_10 9.5999400000000013e-19
C115 0 FILL_L10_13 4.1969200000000003e-17
C116 0 FILL_L10_14 1.50744e-17
C117 0 FILL_L10_15 4.1183300000000002e-19
C118 0 FILL_L10_18 4.7649000000000003e-17
C119 0 FILL_L10_19 2.0869000000000002e-17
C120 0 FILL_L10_20 2.1586300000000002e-18
C121 0 FILL_L10_23 4.2703500000000001e-17
C122 0 FILL_L10_24 1.8358800000000001e-17
C123 0 FILL_L10_5 1.6800800000000002e-18
C124 0 FILL_L10_8 1.2320600000000002e-17
C125 0 FILL_L10_9 4.0001800000000002e-18
C126 0 FILL_L30_10 6.7427500000000006e-18
C127 0 FILL_L30_11 1.136e-18
C128 0 FILL_L30_13 1.4364500000000001e-17
C129 0 FILL_L30_14 1.1436400000000002e-17
C130 0 FILL_L30_15 1.0095800000000001e-17
C131 0 FILL_L30_16 1.136e-18
C132 0 FILL_L30_18 7.3098599999999994e-18
C133 0 FILL_L50_11 2.0322600000000003e-17
C134 0 FILL_L50_12 1.8574900000000001e-17
C135 0 FILL_L50_13 6.049850000000001e-18
C136 0 FILL_L50_4 3.8611500000000004e-18
C137 0 FILL_L50_5 7.414170000000001e-18
C138 0 FILL_L50_7 4.9401700000000009e-18
C139 0 FILL_L50_8 1.41985e-17
C140 0 FILL_L50_9 1.0610900000000001e-17
C141 0 FILL_L8_15 2.5128200000000004e-19
C142 0 FILL_L8_18 5.3184800000000004e-18
C143 0 FILL_L8_19 3.7491800000000006e-18
C144 0 FILL_L8_20 2.5231900000000001e-19
C145 0 FILL_L8_23 5.1681100000000008e-18
C146 0 FILL_L8_24 3.5963400000000004e-18
C147 0 P 4.6038100000000002e-17
C149 0 FILL_L10_12 1.0329800000000001e-19
C150 0 FILL_L10_13 1.7424600000000002e-17
C151 0 FILL_L10_14 8.8782300000000005e-16
C152 0 FILL_L10_18 1.6410600000000001e-17
C153 0 FILL_L10_19 8.8782300000000005e-16
C154 0 FILL_L10_22 2.0659600000000002e-19
C155 0 FILL_L10_23 1.4645700000000002e-17
C156 0 FILL_L10_24 7.1147700000000002e-16
C157 0 FILL_L10_3 1.7649600000000001e-18
C158 0 FILL_L10_4 1.7634600000000003e-16
C159 0 FILL_L10_7 3.0989299999999998e-19
C160 0 FILL_L10_8 1.7424600000000002e-17
C161 0 FILL_L10_9 8.8782300000000005e-16
C162 0 FILL_L30_0 9.5269300000000005e-18
C163 0 FILL_L30_10 9.5269300000000005e-18
C164 0 FILL_L30_13 1.0835100000000002e-17
C165 0 FILL_L30_14 9.5269300000000005e-18
C166 0 FILL_L30_15 9.5269300000000005e-18
C167 0 FILL_L30_18 5.4175400000000004e-18
C168 0 FILL_L30_3 1.0835100000000002e-17
C169 0 FILL_L30_4 9.5269300000000005e-18
C170 0 FILL_L30_5 9.5269300000000005e-18
C171 0 FILL_L30_8 1.0835100000000002e-17
C172 0 FILL_L30_9 9.5269300000000005e-18
C173 0 FILL_L8_14 5.0814800000000005e-17
C174 0 FILL_L8_19 5.0814800000000005e-17
C175 0 FILL_L8_24 2.9178200000000004e-17
C176 0 FILL_L8_4 2.1636600000000004e-17
C177 0 FILL_L8_9 5.0814800000000005e-17
C178 0 P 3.0624200000000002e-18
C180 FILL_L10_0 FILL_L10_1 1.39676e-17
C181 FILL_L10_0 FILL_L10_5 9.7773300000000019e-17
C182 FILL_L10_0 FILL_L30_1 1.4128900000000001e-16
C183 FILL_L10_0 FILL_L30_2 1.6912800000000001e-17
C184 FILL_L10_0 FILL_L50_1 8.4311500000000015e-18
C185 FILL_L10_0 FILL_L50_2 7.2175799999999998e-18
C186 FILL_L10_0 FILL_L8_0 1.1764400000000002e-16
C187 FILL_L10_0 0 1.95255e-16
C188 FILL_L10_1 FILL_L10_2 1.39676e-17
C189 FILL_L10_1 FILL_L10_6 9.7773300000000019e-17
C190 FILL_L10_1 FILL_L30_2 2.0556600000000001e-16
C191 FILL_L10_1 FILL_L30_3 1.7474700000000001e-18
C192 FILL_L10_1 FILL_L50_2 3.1589700000000003e-18
C193 FILL_L10_1 FILL_L8_1 1.1764400000000002e-16
C194 FILL_L10_1 N 2.87551e-18
C195 FILL_L10_1 0 1.8486400000000003e-16
C196 FILL_L10_10 FILL_L10_11 9.7773300000000019e-17
C197 FILL_L10_10 FILL_L10_15 9.7773300000000019e-17
C198 FILL_L10_10 FILL_L10_5 9.7773300000000019e-17
C199 FILL_L10_10 FILL_L30_11 6.9898900000000003e-18
C200 FILL_L10_10 FILL_L30_6 6.0117900000000002e-16
C201 FILL_L10_10 FILL_L30_7 1.0147700000000001e-16
C202 FILL_L10_10 FILL_L50_5 6.3222800000000008e-17
C203 FILL_L10_10 FILL_L50_6 4.3305500000000004e-17
C204 FILL_L10_10 FILL_L50_9 7.7816000000000003e-18
C205 FILL_L10_10 FILL_L8_10 8.2350600000000007e-16
C206 FILL_L10_10 N 9.6155500000000016e-19
C207 FILL_L10_10 0 2.6895800000000005e-16
C208 FILL_L10_11 FILL_L10_12 9.7773300000000019e-17
C209 FILL_L10_11 FILL_L10_16 9.7773300000000019e-17
C210 FILL_L10_11 FILL_L10_6 9.7773300000000019e-17
C211 FILL_L10_11 FILL_L30_12 1.0484800000000001e-17
C212 FILL_L10_11 FILL_L30_7 8.6356200000000011e-16
C213 FILL_L10_11 FILL_L30_8 1.0484800000000001e-17
C214 FILL_L10_11 FILL_L50_10 1.1672400000000001e-17
C215 FILL_L10_11 FILL_L50_6 3.7907600000000003e-17
C216 FILL_L10_11 FILL_L8_11 8.2350600000000007e-16
C217 FILL_L10_11 N 2.6568300000000004e-17
C218 FILL_L10_11 0 1.9621900000000002e-16
C219 FILL_L10_12 FILL_L10_13 9.7773300000000019e-17
C220 FILL_L10_12 FILL_L10_17 9.7773300000000019e-17
C221 FILL_L10_12 FILL_L10_7 9.7773300000000019e-17
C222 FILL_L10_12 FILL_L30_13 1.2232300000000001e-17
C223 FILL_L10_12 FILL_L30_8 9.0101000000000002e-16
C224 FILL_L10_12 FILL_L8_12 8.2350600000000007e-16
C225 FILL_L10_12 N 7.0157100000000007e-17
C226 FILL_L10_12 P 1.7113500000000001e-17
C227 FILL_L10_12 0 1.9621900000000002e-16
C228 FILL_L10_13 FILL_L10_14 9.7773300000000019e-17
C229 FILL_L10_13 FILL_L10_18 9.7773300000000019e-17
C230 FILL_L10_13 FILL_L10_8 9.7773300000000019e-17
C231 FILL_L10_13 FILL_L30_10 3.4949400000000003e-18
C232 FILL_L10_13 FILL_L30_5 6.3965400000000009e-17
C233 FILL_L10_13 FILL_L30_8 5.4807800000000005e-17
C234 FILL_L10_13 FILL_L30_9 1.9620000000000001e-16
C235 FILL_L10_13 FILL_L50_4 2.0753100000000001e-17
C236 FILL_L10_13 FILL_L50_7 5.5976900000000003e-17
C237 FILL_L10_13 FILL_L50_8 3.8908000000000001e-18
C238 FILL_L10_13 FILL_L8_13 8.2350600000000007e-16
C239 FILL_L10_13 P 8.9281499999999994e-17
C240 FILL_L10_13 0 1.9621900000000002e-16
C241 FILL_L10_14 FILL_L10_19 9.7773300000000019e-17
C242 FILL_L10_14 FILL_L10_9 9.7773300000000019e-17
C243 FILL_L10_14 FILL_L30_8 1.1714400000000001e-18
C244 FILL_L10_14 FILL_L30_9 1.9833799999999999e-18
C245 FILL_L10_14 FILL_L50_7 3.5854900000000002e-18
C246 FILL_L10_14 FILL_L8_14 8.2350600000000007e-16
C247 FILL_L10_14 P 4.0051600000000003e-18
C248 FILL_L10_14 0 2.6896499999999997e-16
C249 FILL_L10_15 FILL_L10_16 9.7773300000000019e-17
C250 FILL_L10_15 FILL_L10_20 9.7773300000000019e-17
C251 FILL_L10_15 FILL_L30_11 6.3039000000000007e-16
C252 FILL_L10_15 FILL_L30_12 1.1839000000000001e-16
C253 FILL_L10_15 FILL_L50_10 5.0523100000000002e-17
C254 FILL_L10_15 FILL_L50_9 5.9018100000000005e-17
C255 FILL_L10_15 FILL_L8_15 8.2350600000000007e-16
C256 FILL_L10_15 0 2.6895800000000005e-16
C257 FILL_L10_16 FILL_L10_17 9.7773300000000019e-17
C258 FILL_L10_16 FILL_L10_21 9.7773300000000019e-17
C259 FILL_L10_16 FILL_L30_12 9.0101000000000002e-16
C260 FILL_L10_16 FILL_L30_13 1.2232300000000001e-17
C261 FILL_L10_16 FILL_L50_10 2.2112800000000001e-17
C262 FILL_L10_16 FILL_L8_16 8.2350600000000007e-16
C263 FILL_L10_16 N 2.0128599999999999e-17
C264 FILL_L10_16 0 1.9621900000000002e-16
C265 FILL_L10_17 FILL_L10_18 9.7773300000000019e-17
C266 FILL_L10_17 FILL_L10_22 9.7773300000000019e-17
C267 FILL_L10_17 FILL_L30_13 9.2695400000000007e-16
C268 FILL_L10_17 FILL_L8_17 8.2350600000000007e-16
C269 FILL_L10_17 N 4.4774400000000001e-17
C270 FILL_L10_17 P 1.13782e-17
C271 FILL_L10_17 0 1.9621900000000002e-16
C272 FILL_L10_18 FILL_L10_19 9.7773300000000019e-17
C273 FILL_L10_18 FILL_L10_23 9.7773300000000019e-17
C274 FILL_L10_18 FILL_L30_10 1.7636500000000003e-16
C275 FILL_L10_18 FILL_L30_13 6.1794900000000007e-17
C276 FILL_L10_18 FILL_L30_14 1.23317e-16
C277 FILL_L10_18 FILL_L50_11 3.5206000000000008e-17
C278 FILL_L10_18 FILL_L50_8 4.9659000000000004e-17
C279 FILL_L10_18 FILL_L8_18 8.2350600000000007e-16
C280 FILL_L10_18 P 8.2002300000000006e-17
C281 FILL_L10_18 0 1.9621900000000002e-16
C282 FILL_L10_19 FILL_L10_24 9.7773300000000019e-17
C283 FILL_L10_19 FILL_L30_10 1.9833799999999999e-18
C284 FILL_L10_19 FILL_L30_13 1.1714400000000001e-18
C285 FILL_L10_19 FILL_L30_14 9.9168999999999996e-19
C286 FILL_L10_19 FILL_L50_11 1.7927400000000002e-18
C287 FILL_L10_19 FILL_L50_8 3.5854900000000002e-18
C288 FILL_L10_19 FILL_L8_19 8.2350600000000007e-16
C289 FILL_L10_19 P 3.2041300000000005e-18
C290 FILL_L10_19 0 2.6896499999999997e-16
C291 FILL_L10_2 FILL_L10_3 1.39676e-17
C292 FILL_L10_2 FILL_L10_7 9.7773300000000019e-17
C293 FILL_L10_2 FILL_L30_3 2.2208100000000002e-16
C294 FILL_L10_2 FILL_L8_2 1.1764400000000002e-16
C295 FILL_L10_2 N 9.8324800000000015e-19
C296 FILL_L10_2 P 1.6254500000000001e-18
C297 FILL_L10_2 0 1.8486400000000003e-16
C298 FILL_L10_20 FILL_L10_21 8.380570000000001e-17
C299 FILL_L10_20 FILL_L30_11 2.7948400000000001e-17
C300 FILL_L10_20 FILL_L30_16 4.0575599999999999e-16
C301 FILL_L10_20 FILL_L30_17 6.7651200000000006e-17
C302 FILL_L10_20 FILL_L50_13 5.7811700000000011e-17
C303 FILL_L10_20 FILL_L50_14 2.8870300000000003e-17
C304 FILL_L10_20 FILL_L50_9 1.74191e-17
C305 FILL_L10_20 FILL_L8_20 7.0586200000000003e-16
C306 FILL_L10_20 N 1.9231100000000003e-18
C307 FILL_L10_20 0 3.1728900000000001e-16
C308 FILL_L10_21 FILL_L10_22 8.380570000000001e-17
C309 FILL_L10_21 FILL_L30_12 4.1922500000000005e-17
C310 FILL_L10_21 FILL_L30_17 5.8316300000000005e-16
C311 FILL_L10_21 FILL_L30_18 6.9898900000000003e-18
C312 FILL_L10_21 FILL_L50_10 2.6128600000000001e-17
C313 FILL_L10_21 FILL_L50_14 4.8766599999999997e-17
C314 FILL_L10_21 FILL_L8_21 7.0586200000000003e-16
C315 FILL_L10_21 N 3.0132600000000003e-17
C316 FILL_L10_21 0 2.5494200000000004e-16
C317 FILL_L10_22 FILL_L10_23 8.380570000000001e-17
C318 FILL_L10_22 FILL_L30_13 4.8909600000000001e-17
C319 FILL_L10_22 FILL_L30_18 6.0937200000000001e-16
C320 FILL_L10_22 FILL_L8_22 7.0586200000000003e-16
C321 FILL_L10_22 N 8.9148100000000001e-17
C322 FILL_L10_22 P 2.12233e-17
C323 FILL_L10_22 0 2.5494200000000004e-16
C324 FILL_L10_23 FILL_L10_24 8.380570000000001e-17
C325 FILL_L10_23 FILL_L30_14 1.3974200000000001e-17
C326 FILL_L10_23 FILL_L30_15 1.9807600000000001e-16
C327 FILL_L10_23 FILL_L30_18 3.4391000000000001e-17
C328 FILL_L10_23 FILL_L50_11 8.7095400000000018e-18
C329 FILL_L10_23 FILL_L50_12 5.2993000000000008e-17
C330 FILL_L10_23 FILL_L8_23 7.0586200000000003e-16
C331 FILL_L10_23 P 7.4447200000000006e-17
C332 FILL_L10_23 0 2.5494200000000004e-16
C333 FILL_L10_24 FILL_L30_15 1.9833799999999999e-18
C334 FILL_L10_24 FILL_L30_18 5.8572200000000004e-19
C335 FILL_L10_24 FILL_L50_12 3.5854900000000002e-18
C336 FILL_L10_24 FILL_L8_24 7.0586200000000003e-16
C337 FILL_L10_24 P 3.2041300000000005e-18
C338 FILL_L10_24 0 3.1729500000000006e-16
C339 FILL_L10_3 FILL_L10_4 1.39676e-17
C340 FILL_L10_3 FILL_L10_8 9.7773300000000019e-17
C341 FILL_L10_3 FILL_L30_0 8.2604900000000006e-17
C342 FILL_L10_3 FILL_L30_3 6.9870900000000006e-18
C343 FILL_L10_3 FILL_L50_0 1.4452900000000001e-17
C344 FILL_L10_3 FILL_L8_3 1.1764400000000002e-16
C345 FILL_L10_3 P 7.5550600000000002e-18
C346 FILL_L10_3 0 1.8486400000000003e-16
C347 FILL_L10_4 FILL_L10_9 9.7773300000000019e-17
C348 FILL_L10_4 FILL_L30_0 9.9168999999999996e-19
C349 FILL_L10_4 FILL_L50_0 1.7927400000000002e-18
C350 FILL_L10_4 FILL_L8_4 1.1764400000000002e-16
C351 FILL_L10_4 0 1.9525600000000002e-16
C352 FILL_L10_5 FILL_L10_6 9.7773300000000019e-17
C353 FILL_L10_5 FILL_L30_1 4.7322300000000008e-16
C354 FILL_L10_5 FILL_L30_2 6.7651200000000006e-17
C355 FILL_L10_5 FILL_L30_6 6.7651200000000006e-17
C356 FILL_L10_5 FILL_L50_1 6.7449200000000012e-17
C357 FILL_L10_5 FILL_L50_2 2.8870300000000003e-17
C358 FILL_L10_5 FILL_L50_5 2.8870300000000003e-17
C359 FILL_L10_5 FILL_L8_5 8.2350600000000007e-16
C360 FILL_L10_5 N 2.8846700000000002e-18
C361 FILL_L10_5 0 2.6895800000000005e-16
C362 FILL_L10_6 FILL_L10_7 9.7773300000000019e-17
C363 FILL_L10_6 FILL_L30_2 6.8436300000000009e-16
C364 FILL_L10_6 FILL_L30_3 6.9898900000000003e-18
C365 FILL_L10_6 FILL_L30_7 1.0147700000000001e-16
C366 FILL_L10_6 FILL_L50_2 6.3222800000000008e-17
C367 FILL_L10_6 FILL_L50_6 4.3305500000000004e-17
C368 FILL_L10_6 FILL_L8_6 8.2350600000000007e-16
C369 FILL_L10_6 N 3.9447900000000001e-17
C370 FILL_L10_6 0 1.9621900000000002e-16
C371 FILL_L10_7 FILL_L10_8 9.7773300000000019e-17
C372 FILL_L10_7 FILL_L30_3 7.2743800000000001e-16
C373 FILL_L10_7 FILL_L30_8 1.1839000000000001e-16
C374 FILL_L10_7 FILL_L8_7 8.2350600000000007e-16
C375 FILL_L10_7 N 1.15514e-16
C376 FILL_L10_7 P 2.8584100000000002e-17
C377 FILL_L10_7 0 1.9621900000000002e-16
C378 FILL_L10_8 FILL_L10_9 9.7773300000000019e-17
C379 FILL_L10_8 FILL_L30_0 1.3974200000000001e-17
C380 FILL_L10_8 FILL_L30_3 3.4391000000000001e-17
C381 FILL_L10_8 FILL_L30_4 2.04081e-16
C382 FILL_L10_8 FILL_L30_5 3.3825600000000003e-17
C383 FILL_L10_8 FILL_L50_0 8.7095400000000018e-18
C384 FILL_L10_8 FILL_L50_3 5.7811700000000011e-17
C385 FILL_L10_8 FILL_L50_4 1.4435200000000002e-17
C386 FILL_L10_8 FILL_L8_8 8.2350600000000007e-16
C387 FILL_L10_8 P 8.9281499999999994e-17
C388 FILL_L10_8 0 1.9621900000000002e-16
C389 FILL_L10_9 FILL_L30_3 5.8572200000000004e-19
C390 FILL_L10_9 FILL_L30_4 1.9833799999999999e-18
C391 FILL_L10_9 FILL_L50_3 3.5854900000000002e-18
C392 FILL_L10_9 FILL_L8_9 8.2350600000000007e-16
C393 FILL_L10_9 P 4.0051600000000003e-18
C394 FILL_L10_9 0 2.6896499999999997e-16
C395 FILL_L30_0 FILL_L30_3 1.92731e-17
C396 FILL_L30_0 FILL_L30_4 1.92731e-17
C397 FILL_L30_0 FILL_L50_0 6.7224999999999998e-17
C398 FILL_L30_0 FILL_L8_3 3.01665e-18
C399 FILL_L30_0 FILL_L8_8 2.30082e-18
C400 FILL_L30_0 P 3.6514799999999999e-18
C401 FILL_L30_0 0 6.8591499999999997e-17
C402 FILL_L30_1 FILL_L30_2 7.7092600000000011e-17
C403 FILL_L30_1 FILL_L30_6 3.8546300000000006e-17
C404 FILL_L30_1 FILL_L50_1 5.3779999999999998e-16
C405 FILL_L30_1 FILL_L8_0 1.6102599999999999e-17
C406 FILL_L30_1 FILL_L8_5 1.6102599999999999e-17
C407 FILL_L30_1 0 2.5657499999999998e-16
C408 FILL_L30_10 FILL_L30_13 1.92731e-17
C409 FILL_L30_10 FILL_L30_14 1.92731e-17
C410 FILL_L30_10 FILL_L30_9 1.92731e-17
C411 FILL_L30_10 FILL_L50_8 6.7224999999999998e-17
C412 FILL_L30_10 P 3.6514799999999999e-18
C413 FILL_L30_10 0 2.40277e-17
C414 FILL_L30_11 FILL_L30_12 7.7092600000000011e-17
C415 FILL_L30_11 FILL_L30_16 3.8546300000000006e-17
C416 FILL_L30_11 FILL_L30_6 3.8546300000000006e-17
C417 FILL_L30_11 FILL_L50_9 5.3779999999999998e-16
C418 FILL_L30_11 FILL_L8_15 6.0333000000000001e-18
C419 FILL_L30_11 FILL_L8_20 4.60164e-18
C420 FILL_L30_11 0 1.8749100000000003e-16
C421 FILL_L30_12 FILL_L30_13 7.7092600000000011e-17
C422 FILL_L30_12 FILL_L30_17 7.7092600000000011e-17
C423 FILL_L30_12 FILL_L30_7 7.7092600000000011e-17
C424 FILL_L30_12 FILL_L50_10 1.0756e-15
C425 FILL_L30_12 FILL_L8_15 1.7621300000000003e-17
C426 FILL_L30_12 FILL_L8_16 2.9176600000000002e-17
C427 FILL_L30_12 FILL_L8_21 6.9024600000000003e-18
C428 FILL_L30_12 N 4.9648100000000005e-18
C429 FILL_L30_12 0 1.9966800000000001e-16
C430 FILL_L30_13 FILL_L30_14 1.92731e-17
C431 FILL_L30_13 FILL_L30_18 7.7092600000000011e-17
C432 FILL_L30_13 FILL_L30_8 7.7092600000000011e-17
C433 FILL_L30_13 FILL_L8_17 2.11165e-17
C434 FILL_L30_13 FILL_L8_18 8.0528700000000005e-18
C435 FILL_L30_13 FILL_L8_22 8.0528700000000005e-18
C436 FILL_L30_13 N 9.4484500000000007e-16
C437 FILL_L30_13 P 1.6977000000000002e-16
C438 FILL_L30_13 0 1.9565100000000003e-16
C439 FILL_L30_14 FILL_L30_15 1.92731e-17
C440 FILL_L30_14 FILL_L50_11 6.7224999999999998e-17
C441 FILL_L30_14 FILL_L8_18 3.01665e-18
C442 FILL_L30_14 FILL_L8_23 2.30082e-18
C443 FILL_L30_14 P 3.6514799999999999e-18
C444 FILL_L30_14 0 3.72395e-17
C445 FILL_L30_15 FILL_L30_18 1.92731e-17
C446 FILL_L30_15 FILL_L50_12 6.7224999999999998e-17
C447 FILL_L30_15 P 3.6514799999999999e-18
C448 FILL_L30_15 0 4.4774900000000004e-17
C449 FILL_L30_16 FILL_L30_17 3.8546300000000006e-17
C450 FILL_L30_16 FILL_L50_13 2.6889999999999999e-16
C451 FILL_L30_16 0 1.4345400000000001e-16
C452 FILL_L30_17 FILL_L30_18 3.8546300000000006e-17
C453 FILL_L30_17 FILL_L50_14 5.3779999999999998e-16
C454 FILL_L30_17 FILL_L8_20 1.0069300000000001e-17
C455 FILL_L30_17 FILL_L8_21 1.1501000000000001e-17
C456 FILL_L30_17 N 2.4824000000000004e-18
C457 FILL_L30_17 0 2.0625800000000001e-16
C458 FILL_L30_18 FILL_L8_22 6.0333000000000001e-18
C459 FILL_L30_18 FILL_L8_23 4.60164e-18
C460 FILL_L30_18 N 4.7242300000000004e-16
C461 FILL_L30_18 P 8.4884800000000009e-17
C462 FILL_L30_18 0 2.02581e-16
C463 FILL_L30_2 FILL_L30_3 7.7092600000000011e-17
C464 FILL_L30_2 FILL_L30_7 7.7092600000000011e-17
C465 FILL_L30_2 FILL_L50_2 1.0756e-15
C466 FILL_L30_2 FILL_L8_0 2.5173300000000001e-18
C467 FILL_L30_2 FILL_L8_1 2.7029200000000001e-17
C468 FILL_L30_2 FILL_L8_5 1.0069300000000001e-17
C469 FILL_L30_2 FILL_L8_6 3.5654900000000003e-17
C470 FILL_L30_2 N 4.9648100000000005e-18
C471 FILL_L30_2 0 3.1975000000000002e-16
C472 FILL_L30_3 FILL_L30_4 1.92731e-17
C473 FILL_L30_3 FILL_L30_8 7.7092600000000011e-17
C474 FILL_L30_3 FILL_L8_2 2.9687900000000004e-17
C475 FILL_L30_3 FILL_L8_3 1.15041e-18
C476 FILL_L30_3 FILL_L8_7 3.4212900000000001e-17
C477 FILL_L30_3 FILL_L8_8 4.60164e-18
C478 FILL_L30_3 N 8.7084400000000013e-16
C479 FILL_L30_3 P 1.6977000000000002e-16
C480 FILL_L30_3 0 3.3027100000000006e-16
C481 FILL_L30_4 FILL_L30_5 1.92731e-17
C482 FILL_L30_4 FILL_L50_3 6.7224999999999998e-17
C483 FILL_L30_4 P 3.6514799999999999e-18
C484 FILL_L30_4 0 2.3119900000000003e-17
C485 FILL_L30_5 FILL_L30_8 1.92731e-17
C486 FILL_L30_5 FILL_L30_9 1.92731e-17
C487 FILL_L30_5 FILL_L50_4 6.7224999999999998e-17
C488 FILL_L30_5 FILL_L8_13 5.7504800000000001e-18
C489 FILL_L30_5 FILL_L8_8 5.0346600000000001e-18
C490 FILL_L30_5 P 3.6514799999999999e-18
C491 FILL_L30_5 0 5.0275900000000005e-17
C492 FILL_L30_6 FILL_L30_7 7.7092600000000011e-17
C493 FILL_L30_6 FILL_L50_5 5.3779999999999998e-16
C494 FILL_L30_6 FILL_L8_10 1.1501000000000001e-17
C495 FILL_L30_6 FILL_L8_5 1.0069300000000001e-17
C496 FILL_L30_6 0 1.9677300000000002e-16
C497 FILL_L30_7 FILL_L30_8 7.7092600000000011e-17
C498 FILL_L30_7 FILL_L50_6 1.0756e-15
C499 FILL_L30_7 FILL_L8_10 1.5103999999999999e-17
C500 FILL_L30_7 FILL_L8_11 3.4502900000000002e-17
C501 FILL_L30_7 FILL_L8_6 1.5103999999999999e-17
C502 FILL_L30_7 N 4.9648100000000005e-18
C503 FILL_L30_7 0 2.1257400000000002e-16
C504 FILL_L30_8 FILL_L30_9 1.92731e-17
C505 FILL_L30_8 FILL_L8_12 2.9176600000000002e-17
C506 FILL_L30_8 FILL_L8_13 6.9024600000000003e-18
C507 FILL_L30_8 FILL_L8_7 1.7621300000000003e-17
C508 FILL_L30_8 N 9.4484500000000007e-16
C509 FILL_L30_8 P 1.6977000000000002e-16
C510 FILL_L30_8 0 2.0771800000000002e-16
C511 FILL_L30_9 FILL_L50_7 6.7224999999999998e-17
C512 FILL_L30_9 P 3.6514799999999999e-18
C513 FILL_L30_9 0 2.35262e-17
C514 FILL_L50_0 FILL_L50_3 2.4713600000000001e-17
C515 FILL_L50_0 P 3.9494400000000005e-17
C516 FILL_L50_0 0 5.1308900000000003e-17
C517 FILL_L50_1 FILL_L50_2 9.8854299999999996e-17
C518 FILL_L50_1 FILL_L50_5 4.9427100000000007e-17
C519 FILL_L50_1 0 2.0119100000000001e-16
C520 FILL_L50_10 FILL_L50_14 9.8854299999999996e-17
C521 FILL_L50_10 FILL_L50_6 9.8854299999999996e-17
C522 FILL_L50_10 FILL_L50_9 9.8854299999999996e-17
C523 FILL_L50_10 N 1.1294400000000001e-16
C524 FILL_L50_10 0 1.0262300000000001e-16
C525 FILL_L50_11 FILL_L50_12 2.4713600000000001e-17
C526 FILL_L50_11 FILL_L50_8 2.4713600000000001e-17
C527 FILL_L50_11 P 3.9494400000000005e-17
C528 FILL_L50_11 0 2.2225900000000001e-17
C529 FILL_L50_12 P 3.9494400000000005e-17
C530 FILL_L50_12 0 3.7044800000000005e-17
C531 FILL_L50_13 FILL_L50_14 4.9427100000000007e-17
C532 FILL_L50_13 FILL_L50_9 4.9427100000000007e-17
C533 FILL_L50_13 0 1.3134600000000001e-16
C534 FILL_L50_14 N 5.64721e-17
C535 FILL_L50_14 0 1.6022800000000003e-16
C536 FILL_L50_2 FILL_L50_6 9.8854299999999996e-17
C537 FILL_L50_2 N 1.1294400000000001e-16
C538 FILL_L50_2 0 1.8646600000000003e-16
C539 FILL_L50_3 FILL_L50_4 2.4713600000000001e-17
C540 FILL_L50_3 P 3.9494400000000005e-17
C541 FILL_L50_3 0 1.57818e-17
C542 FILL_L50_4 FILL_L50_7 2.4713600000000001e-17
C543 FILL_L50_4 P 3.9494400000000005e-17
C544 FILL_L50_4 0 2.8160199999999999e-17
C545 FILL_L50_5 FILL_L50_6 9.8854299999999996e-17
C546 FILL_L50_5 FILL_L50_9 4.9427100000000007e-17
C547 FILL_L50_5 0 1.5492900000000002e-16
C548 FILL_L50_6 N 1.1294400000000001e-16
C549 FILL_L50_6 0 9.9142000000000004e-17
C550 FILL_L50_7 FILL_L50_8 2.4713600000000001e-17
C551 FILL_L50_7 P 3.9494400000000005e-17
C552 FILL_L50_7 0 1.5975e-17
C553 FILL_L50_8 P 3.9494400000000005e-17
C554 FILL_L50_8 0 1.62107e-17
C555 FILL_L50_9 0 1.5674900000000002e-16
C556 FILL_L8_0 FILL_L8_1 9.9566900000000006e-18
C557 FILL_L8_0 FILL_L8_5 6.96968e-17
C558 FILL_L8_0 0 3.1161100000000002e-16
C559 FILL_L8_1 FILL_L8_2 9.9566900000000006e-18
C560 FILL_L8_1 FILL_L8_6 6.96968e-17
C561 FILL_L8_1 N 3.2792900000000005e-19
C562 FILL_L8_1 0 3.0331700000000001e-16
C563 FILL_L8_10 FILL_L8_11 6.96968e-17
C564 FILL_L8_10 FILL_L8_15 6.96968e-17
C565 FILL_L8_10 FILL_L8_5 6.96968e-17
C566 FILL_L8_10 0 8.0896600000000004e-16
C567 FILL_L8_11 FILL_L8_12 6.96968e-17
C568 FILL_L8_11 FILL_L8_16 6.96968e-17
C569 FILL_L8_11 FILL_L8_6 6.96968e-17
C570 FILL_L8_11 N 2.2955000000000002e-18
C571 FILL_L8_11 0 7.5091400000000008e-16
C572 FILL_L8_12 FILL_L8_13 6.96968e-17
C573 FILL_L8_12 FILL_L8_17 6.96968e-17
C574 FILL_L8_12 FILL_L8_7 6.96968e-17
C575 FILL_L8_12 N 1.52694e-17
C576 FILL_L8_12 P 4.8823900000000006e-18
C577 FILL_L8_12 0 7.5091400000000008e-16
C578 FILL_L8_13 FILL_L8_14 6.96968e-17
C579 FILL_L8_13 FILL_L8_18 6.96968e-17
C580 FILL_L8_13 FILL_L8_8 6.96968e-17
C581 FILL_L8_13 P 5.1604000000000007e-18
C582 FILL_L8_13 0 7.5091400000000008e-16
C583 FILL_L8_14 FILL_L8_19 6.96968e-17
C584 FILL_L8_14 FILL_L8_9 6.96968e-17
C585 FILL_L8_14 0 8.0897100000000003e-16
C586 FILL_L8_15 FILL_L8_16 6.96968e-17
C587 FILL_L8_15 FILL_L8_20 6.96968e-17
C588 FILL_L8_15 0 8.0896600000000004e-16
C589 FILL_L8_16 FILL_L8_17 6.96968e-17
C590 FILL_L8_16 FILL_L8_21 6.96968e-17
C591 FILL_L8_16 N 2.2955000000000002e-18
C592 FILL_L8_16 0 7.5091400000000008e-16
C593 FILL_L8_17 FILL_L8_18 6.96968e-17
C594 FILL_L8_17 FILL_L8_22 6.96968e-17
C595 FILL_L8_17 N 1.85099e-17
C596 FILL_L8_17 P 4.8823900000000006e-18
C597 FILL_L8_17 0 7.5091400000000008e-16
C598 FILL_L8_18 FILL_L8_19 6.96968e-17
C599 FILL_L8_18 FILL_L8_23 6.96968e-17
C600 FILL_L8_18 P 5.1604000000000007e-18
C601 FILL_L8_18 0 7.5091400000000008e-16
C602 FILL_L8_19 FILL_L8_24 6.96968e-17
C603 FILL_L8_19 0 8.0897100000000003e-16
C604 FILL_L8_2 FILL_L8_3 9.9566900000000006e-18
C605 FILL_L8_2 FILL_L8_7 6.96968e-17
C606 FILL_L8_2 N 3.7572800000000005e-19
C607 FILL_L8_2 P 6.9748400000000006e-19
C608 FILL_L8_2 0 3.0331700000000001e-16
C609 FILL_L8_20 FILL_L8_21 5.9740100000000005e-17
C610 FILL_L8_20 0 7.7445100000000011e-16
C611 FILL_L8_21 FILL_L8_22 5.9740100000000005e-17
C612 FILL_L8_21 N 1.9675800000000004e-18
C613 FILL_L8_21 0 7.2469200000000008e-16
C614 FILL_L8_22 FILL_L8_23 5.9740100000000005e-17
C615 FILL_L8_22 N 8.8601800000000006e-18
C616 FILL_L8_22 P 4.1849e-18
C617 FILL_L8_22 0 7.2469200000000008e-16
C618 FILL_L8_23 FILL_L8_24 5.9740100000000005e-17
C619 FILL_L8_23 P 4.4231999999999997e-18
C620 FILL_L8_23 0 7.2469200000000008e-16
C621 FILL_L8_24 0 7.7445500000000008e-16
C622 FILL_L8_3 FILL_L8_4 9.9566900000000006e-18
C623 FILL_L8_3 FILL_L8_8 6.96968e-17
C624 FILL_L8_3 P 7.3720000000000001e-19
C625 FILL_L8_3 0 3.0331700000000001e-16
C626 FILL_L8_4 FILL_L8_9 6.96968e-17
C627 FILL_L8_4 0 3.1161100000000002e-16
C628 FILL_L8_5 FILL_L8_6 6.96968e-17
C629 FILL_L8_5 0 8.0896600000000004e-16
C630 FILL_L8_6 FILL_L8_7 6.96968e-17
C631 FILL_L8_6 N 2.2955000000000002e-18
C632 FILL_L8_6 0 7.5091400000000008e-16
C633 FILL_L8_7 FILL_L8_8 6.96968e-17
C634 FILL_L8_7 N 5.9953800000000002e-18
C635 FILL_L8_7 P 4.8823900000000006e-18
C636 FILL_L8_7 0 7.5091400000000008e-16
C637 FILL_L8_8 FILL_L8_9 6.96968e-17
C638 FILL_L8_8 P 5.1604000000000007e-18
C639 FILL_L8_8 0 7.5091400000000008e-16
C640 FILL_L8_9 0 8.0897100000000003e-16
C641 N P 4.9427100000000006e-16
C642 N 0 5.3047500000000011e-16
C643 P 0 3.5934700000000001e-16
VP P 0 DC 0 AC 1
VN N 0 DC 0 AC 0
.control
set numdgt=17
ac lin 1 1Meg 1Meg
let cp = -imag(i(VP))/(2*pi*1e6)
let cn = -imag(i(VN))/(2*pi*1e6)
print cp cn
quit
.endc
.end
