* actual_fill grounded drive N; diagnostic capacitor-network AC only
C82 0 N 1.53134e-15
C83 0 P 5.4831700000000005e-16
C111 0 P 1.0868200000000001e-16
C147 0 P 4.6038100000000002e-17
C178 0 P 3.0624200000000002e-18
C194 0 N 2.87551e-18
C206 0 N 9.6155500000000016e-19
C217 0 N 2.6568300000000004e-17
C225 0 N 7.0157100000000007e-17
C226 0 P 1.7113500000000001e-17
C239 0 P 8.9281499999999994e-17
C247 0 P 4.0051600000000003e-18
C263 0 N 2.0128599999999999e-17
C269 0 N 4.4774400000000001e-17
C270 0 P 1.13782e-17
C280 0 P 8.2002300000000006e-17
C289 0 P 3.2041300000000005e-18
C295 0 N 9.8324800000000015e-19
C296 0 P 1.6254500000000001e-18
C306 0 N 1.9231100000000003e-18
C315 0 N 3.0132600000000003e-17
C321 0 N 8.9148100000000001e-17
C322 0 P 2.12233e-17
C331 0 P 7.4447200000000006e-17
C337 0 P 3.2041300000000005e-18
C345 0 P 7.5550600000000002e-18
C360 0 N 2.8846700000000002e-18
C369 0 N 3.9447900000000001e-17
C375 0 N 1.15514e-16
C376 0 P 2.8584100000000002e-17
C387 0 P 8.9281499999999994e-17
C393 0 P 4.0051600000000003e-18
C400 0 P 3.6514799999999999e-18
C412 0 P 3.6514799999999999e-18
C428 0 N 4.9648100000000005e-18
C436 0 N 9.4484500000000007e-16
C437 0 P 1.6977000000000002e-16
C443 0 P 3.6514799999999999e-18
C447 0 P 3.6514799999999999e-18
C456 0 N 2.4824000000000004e-18
C460 0 N 4.7242300000000004e-16
C461 0 P 8.4884800000000009e-17
C470 0 N 4.9648100000000005e-18
C478 0 N 8.7084400000000013e-16
C479 0 P 1.6977000000000002e-16
C483 0 P 3.6514799999999999e-18
C490 0 P 3.6514799999999999e-18
C502 0 N 4.9648100000000005e-18
C508 0 N 9.4484500000000007e-16
C509 0 P 1.6977000000000002e-16
C512 0 P 3.6514799999999999e-18
C515 0 P 3.9494400000000005e-17
C523 0 N 1.1294400000000001e-16
C527 0 P 3.9494400000000005e-17
C529 0 P 3.9494400000000005e-17
C534 0 N 5.64721e-17
C537 0 N 1.1294400000000001e-16
C540 0 P 3.9494400000000005e-17
C543 0 P 3.9494400000000005e-17
C548 0 N 1.1294400000000001e-16
C551 0 P 3.9494400000000005e-17
C553 0 P 3.9494400000000005e-17
C561 0 N 3.2792900000000005e-19
C570 0 N 2.2955000000000002e-18
C575 0 N 1.52694e-17
C576 0 P 4.8823900000000006e-18
C581 0 P 5.1604000000000007e-18
C591 0 N 2.2955000000000002e-18
C595 0 N 1.85099e-17
C596 0 P 4.8823900000000006e-18
C600 0 P 5.1604000000000007e-18
C606 0 N 3.7572800000000005e-19
C607 0 P 6.9748400000000006e-19
C612 0 N 1.9675800000000004e-18
C615 0 N 8.8601800000000006e-18
C616 0 P 4.1849e-18
C619 0 P 4.4231999999999997e-18
C624 0 P 7.3720000000000001e-19
C631 0 N 2.2955000000000002e-18
C634 0 N 5.9953800000000002e-18
C635 0 P 4.8823900000000006e-18
C638 0 P 5.1604000000000007e-18
C641 N P 4.9427100000000006e-16
C642 N 0 5.3047500000000011e-16
C643 P 0 3.5934700000000001e-16
VP P 0 DC 0 AC 0
VN N 0 DC 0 AC 1
.control
set numdgt=17
ac lin 1 1Meg 1Meg
let cp = -imag(i(VP))/(2*pi*1e6)
let cn = -imag(i(VN))/(2*pi*1e6)
print cp cn
quit
.endc
.end
