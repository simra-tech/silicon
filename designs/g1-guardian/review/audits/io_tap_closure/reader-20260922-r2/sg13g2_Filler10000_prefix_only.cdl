.SUBCKT sg13g2_Filler10000 vdd vss iovdd iovss
*.PININFO iovdd:B iovss:B vdd:B vss:B
R_PROBE_XR1 vss sub! ptap1 A=14.861p Perim=15.42u
R_PROBE_XR0 iovss sub! ptap1 A=3.622n Perim=240.72u
.ENDS
