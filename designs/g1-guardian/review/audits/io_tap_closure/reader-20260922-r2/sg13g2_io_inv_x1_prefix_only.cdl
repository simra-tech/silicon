.SUBCKT sg13g2_io_inv_x1 nq i vdd vss
*.PININFO i:I nq:O vdd:B vss:B
MN0 nq i vss sub! sg13_lv_nmos m=1 w=3.93u l=130.00n ng=1
MP0 nq i vdd vdd sg13_lv_pmos m=1 w=4.41u l=130.00n ng=1
R_PROBE_XR0 vss sub! ptap1 A=624.1f P=3.16
.ENDS
