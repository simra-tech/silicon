* Extracted by KLayout with SG13G2 LVS runset on : 19/09/2026 14:26

.SUBCKT g1_osc VDD VSS en osc_clk trim[0] trim[1] trim[2] trim[3] va vb vbn vth
M$1 VSS trim[0] \$33 VSS sg13_lv_nmos L=0.13u W=4u AS=1.36p AD=1.36p PS=8.68u
+ PD=8.68u rfmode=0
M$2 \$28 vb \$29 VSS sg13_lv_nmos L=0.3u W=4u AS=1.36p AD=1.36p PS=8.68u
+ PD=8.68u rfmode=0
M$3 VSS trim[3] \$39 VSS sg13_lv_nmos L=0.13u W=4u AS=1.36p AD=1.36p PS=8.68u
+ PD=8.68u rfmode=0
M$4 VSS en \$43 VSS sg13_lv_nmos L=0.13u W=0.5u AS=0.17p AD=0.17p PS=1.68u
+ PD=1.68u rfmode=0
M$5 VSS \$44 \$19 VSS sg13_lv_nmos L=0.13u W=0.5u AS=0.17p AD=0.17p PS=1.68u
+ PD=1.68u rfmode=0
M$6 VSS \$30 \$31 VSS sg13_lv_nmos L=0.13u W=0.5u AS=0.17p AD=0.17p PS=1.68u
+ PD=1.68u rfmode=0
M$7 VSS \$43 \$44 VSS sg13_lv_nmos L=0.13u W=0.5u AS=0.17p AD=0.17p PS=1.68u
+ PD=1.68u rfmode=0
M$8 VSS \$22 \$44 VSS sg13_lv_nmos L=0.13u W=0.5u AS=0.17p AD=0.17p PS=1.68u
+ PD=1.68u rfmode=0
M$9 VSS \$25 \$26 VSS sg13_lv_nmos L=0.13u W=0.5u AS=0.17p AD=0.17p PS=1.68u
+ PD=1.68u rfmode=0
M$10 VSS vbn \$23 VSS sg13_lv_nmos L=0.5u W=2u AS=0.68p AD=0.68p PS=4.68u
+ PD=4.68u rfmode=0
M$11 VSS \$31 \$32 VSS sg13_lv_nmos L=0.13u W=0.5u AS=0.17p AD=0.17p PS=1.68u
+ PD=1.68u rfmode=0
M$12 VSS \$46 osc_clk VSS sg13_lv_nmos L=0.13u W=0.5u AS=0.17p AD=0.17p
+ PS=1.68u PD=1.68u rfmode=0
M$13 \$23 va \$24 VSS sg13_lv_nmos L=0.3u W=4u AS=1.36p AD=1.36p PS=8.68u
+ PD=8.68u rfmode=0
M$14 VSS trim[1] \$35 VSS sg13_lv_nmos L=0.13u W=4u AS=1.36p AD=1.36p PS=8.68u
+ PD=8.68u rfmode=0
M$15 VSS \$32 \$22 VSS sg13_lv_nmos L=0.13u W=0.5u AS=0.17p AD=0.17p PS=1.68u
+ PD=1.68u rfmode=0
M$16 VSS trim[1] \$36 VSS sg13_lv_nmos L=0.13u W=4u AS=1.36p AD=1.36p PS=8.68u
+ PD=8.68u rfmode=0
M$17 VSS trim[2] \$38 VSS sg13_lv_nmos L=0.13u W=4u AS=1.36p AD=1.36p PS=8.68u
+ PD=8.68u rfmode=0
M$18 VSS \$44 \$46 VSS sg13_lv_nmos L=0.13u W=0.5u AS=0.17p AD=0.17p PS=1.68u
+ PD=1.68u rfmode=0
M$19 VSS \$20 vb VSS sg13_lv_nmos L=0.13u W=4u AS=1.36p AD=1.36p PS=8.68u
+ PD=8.68u rfmode=0
M$20 VSS \$44 \$22 VSS sg13_lv_nmos L=0.13u W=0.5u AS=0.17p AD=0.17p PS=1.68u
+ PD=1.68u rfmode=0
M$21 VSS trim[2] \$37 VSS sg13_lv_nmos L=0.13u W=4u AS=1.36p AD=1.36p PS=8.68u
+ PD=8.68u rfmode=0
M$22 \$23 vth \$25 VSS sg13_lv_nmos L=0.3u W=4u AS=1.36p AD=1.36p PS=8.68u
+ PD=8.68u rfmode=0
M$23 VSS \$19 va VSS sg13_lv_nmos L=0.13u W=4u AS=1.36p AD=1.36p PS=8.68u
+ PD=8.68u rfmode=0
M$24 \$45 \$22 \$20 VSS sg13_lv_nmos L=0.13u W=1u AS=0.34p AD=0.34p PS=2.68u
+ PD=2.68u rfmode=0
M$25 VSS en \$45 VSS sg13_lv_nmos L=0.13u W=1u AS=0.34p AD=0.34p PS=2.68u
+ PD=2.68u rfmode=0
M$26 VSS trim[0] \$34 VSS sg13_lv_nmos L=0.13u W=4u AS=1.36p AD=1.36p PS=8.68u
+ PD=8.68u rfmode=0
M$27 \$28 vth \$30 VSS sg13_lv_nmos L=0.3u W=4u AS=1.36p AD=1.36p PS=8.68u
+ PD=8.68u rfmode=0
M$28 VSS \$27 \$44 VSS sg13_lv_nmos L=0.13u W=0.5u AS=0.17p AD=0.17p PS=1.68u
+ PD=1.68u rfmode=0
M$29 VSS trim[3] \$40 VSS sg13_lv_nmos L=0.13u W=4u AS=1.36p AD=1.36p PS=8.68u
+ PD=8.68u rfmode=0
M$30 VSS \$26 \$27 VSS sg13_lv_nmos L=0.13u W=0.5u AS=0.17p AD=0.17p PS=1.68u
+ PD=1.68u rfmode=0
M$31 VSS vbn \$28 VSS sg13_lv_nmos L=0.5u W=2u AS=0.68p AD=0.68p PS=4.68u
+ PD=4.68u rfmode=0
M$32 VSS vbn vbn VSS sg13_lv_nmos L=0.5u W=2u AS=0.68p AD=0.68p PS=4.68u
+ PD=4.68u rfmode=0
M$33 \$50 \$22 \$44 VDD sg13_lv_pmos L=0.13u W=3u AS=1.02p AD=1.02p PS=6.68u
+ PD=6.68u rfmode=0
M$34 \$48 \$43 \$50 VDD sg13_lv_pmos L=0.13u W=3u AS=1.02p AD=1.02p PS=6.68u
+ PD=6.68u rfmode=0
M$35 VDD \$27 \$48 VDD sg13_lv_pmos L=0.13u W=3u AS=1.02p AD=1.02p PS=6.68u
+ PD=6.68u rfmode=0
M$36 \$49 \$44 \$22 VDD sg13_lv_pmos L=0.13u W=2u AS=0.68p AD=0.68p PS=4.68u
+ PD=4.68u rfmode=0
M$37 VDD \$32 \$49 VDD sg13_lv_pmos L=0.13u W=2u AS=0.68p AD=0.68p PS=4.68u
+ PD=4.68u rfmode=0
M$38 VDD en \$43 VDD sg13_lv_pmos L=0.13u W=1u AS=0.34p AD=0.34p PS=2.68u
+ PD=2.68u rfmode=0
M$39 VDD \$31 \$32 VDD sg13_lv_pmos L=0.13u W=1u AS=0.34p AD=0.34p PS=2.68u
+ PD=2.68u rfmode=0
M$40 VDD \$44 \$46 VDD sg13_lv_pmos L=0.13u W=1u AS=0.34p AD=0.34p PS=2.68u
+ PD=2.68u rfmode=0
M$41 VDD \$22 \$20 VDD sg13_lv_pmos L=0.13u W=1u AS=0.34p AD=0.34p PS=2.68u
+ PD=2.68u rfmode=0
M$42 VDD \$29 \$29 VDD sg13_lv_pmos L=0.3u W=2u AS=0.68p AD=0.68p PS=4.68u
+ PD=4.68u rfmode=0
M$43 VDD \$29 \$30 VDD sg13_lv_pmos L=0.3u W=2u AS=0.68p AD=0.68p PS=4.68u
+ PD=4.68u rfmode=0
M$44 VDD \$30 \$31 VDD sg13_lv_pmos L=0.13u W=1u AS=0.34p AD=0.34p PS=2.68u
+ PD=2.68u rfmode=0
M$45 VDD en \$20 VDD sg13_lv_pmos L=0.13u W=1u AS=0.34p AD=0.34p PS=2.68u
+ PD=2.68u rfmode=0
M$46 VDD \$26 \$27 VDD sg13_lv_pmos L=0.13u W=1u AS=0.34p AD=0.34p PS=2.68u
+ PD=2.68u rfmode=0
M$47 VDD \$24 \$25 VDD sg13_lv_pmos L=0.3u W=2u AS=0.68p AD=0.68p PS=4.68u
+ PD=4.68u rfmode=0
M$48 VDD \$46 osc_clk VDD sg13_lv_pmos L=0.13u W=1u AS=0.34p AD=0.34p PS=2.68u
+ PD=2.68u rfmode=0
M$49 VDD \$44 \$19 VDD sg13_lv_pmos L=0.13u W=1u AS=0.34p AD=0.34p PS=2.68u
+ PD=2.68u rfmode=0
M$50 VDD \$25 \$26 VDD sg13_lv_pmos L=0.13u W=1u AS=0.34p AD=0.34p PS=2.68u
+ PD=2.68u rfmode=0
M$51 VDD \$24 \$24 VDD sg13_lv_pmos L=0.3u W=2u AS=0.68p AD=0.68p PS=4.68u
+ PD=4.68u rfmode=0
D$52 vth VDD dpantenna A=0.6084p P=3.12u m=1
R$53 va VDD VSS rppd w=1u l=117u ps=0u b=0 m=1
R$55 VDD vb VSS rppd w=1u l=117u ps=0u b=0 m=1
R$59 vth VDD VSS rppd w=1u l=384.3u ps=0u b=0 m=1
R$67 VSS vth VSS rppd w=1u l=384.3u ps=0u b=0 m=1
R$69 vbn VDD VSS rppd w=1u l=134.3u ps=0u b=0 m=1
C$71 va \$39 cap_cmim w=23.09u l=23.09u A=533.1481p P=92.36u m=1
C$72 va \$37 cap_cmim w=16.33u l=16.33u A=266.6689p P=65.32u m=1
C$73 va VSS cap_cmim w=31.65u l=31.65u A=1001.7225p P=126.6u m=1
C$74 vb \$40 cap_cmim w=23.09u l=23.09u A=533.1481p P=92.36u m=1
C$75 va \$33 cap_cmim w=8.16u l=8.16u A=66.5856p P=32.64u m=1
C$76 va \$35 cap_cmim w=11.55u l=11.55u A=133.4025p P=46.2u m=1
C$77 vb \$38 cap_cmim w=16.33u l=16.33u A=266.6689p P=65.32u m=1
C$78 vb \$34 cap_cmim w=8.16u l=8.16u A=66.5856p P=32.64u m=1
C$79 vb \$36 cap_cmim w=11.55u l=11.55u A=133.4025p P=46.2u m=1
C$80 vb VSS cap_cmim w=31.65u l=31.65u A=1001.7225p P=126.6u m=1
C$81 vth VSS cap_cmim w=26u l=26u A=676p P=104u m=1
.ENDS g1_osc
