*********************************************************
*** NGSPICE file created by KLayout-PEX 0.3.12
*** -----------------------------------------------------
***     Extraction Engine: KPEX/2.5D
***     Technology: ihp_sg13g2
***     Date: 2026-09-19 14:26:56
*********************************************************

.SUBCKT g1_osc VDD VSS b0 b1 b2 b3 bb0 bb1 bb2 bb3 en osc_clk trim[0] trim[1]
+ trim[2] trim[3] va vb vbn vth
M$1 vb \$22 VSS VSS sg13_lv_nmos L=0.13U W=4U AS=1.36P AD=1.36P PS=8.68U
+ PD=8.68U rfmode=0
M$2 va \$20 VSS VSS sg13_lv_nmos L=0.13U W=4U AS=1.36P AD=1.36P PS=8.68U
+ PD=8.68U rfmode=0
M$3 bb3 trim[3] VSS VSS sg13_lv_nmos L=0.13U W=4U AS=1.36P AD=1.36P PS=8.68U
+ PD=8.68U rfmode=0
M$4 \$22 \$25 \$26 VSS sg13_lv_nmos L=0.13U W=1U AS=0.34P AD=0.34P PS=2.68U
+ PD=2.68U rfmode=0
M$5 osc_clk \$27 VSS VSS sg13_lv_nmos L=0.13U W=0.5U AS=0.17P AD=0.17P PS=1.68U
+ PD=1.68U rfmode=0
M$6 \$14 \$31 VSS VSS sg13_lv_nmos L=0.13U W=0.5U AS=0.17P AD=0.17P PS=1.68U
+ PD=1.68U rfmode=0
M$7 \$32 vbn VSS VSS sg13_lv_nmos L=0.5U W=2U AS=0.68P AD=0.68P PS=4.68U
+ PD=4.68U rfmode=0
M$8 \$27 \$24 VSS VSS sg13_lv_nmos L=0.13U W=0.5U AS=0.17P AD=0.17P PS=1.68U
+ PD=1.68U rfmode=0
M$9 \$26 en VSS VSS sg13_lv_nmos L=0.13U W=1U AS=0.34P AD=0.34P PS=2.68U
+ PD=2.68U rfmode=0
M$10 \$20 \$24 VSS VSS sg13_lv_nmos L=0.13U W=0.5U AS=0.17P AD=0.17P PS=1.68U
+ PD=1.68U rfmode=0
M$11 \$24 \$25 VSS VSS sg13_lv_nmos L=0.13U W=0.5U AS=0.17P AD=0.17P PS=1.68U
+ PD=1.68U rfmode=0
M$12 vbn vbn VSS VSS sg13_lv_nmos L=0.5U W=2U AS=0.68P AD=0.68P PS=4.68U
+ PD=4.68U rfmode=0
M$13 \$25 \$36 VSS VSS sg13_lv_nmos L=0.13U W=0.5U AS=0.17P AD=0.17P PS=1.68U
+ PD=1.68U rfmode=0
M$14 \$31 vth \$29 VSS sg13_lv_nmos L=0.3U W=4U AS=1.36P AD=1.36P PS=8.68U
+ PD=8.68U rfmode=0
M$15 \$36 \$35 VSS VSS sg13_lv_nmos L=0.13U W=0.5U AS=0.17P AD=0.17P PS=1.68U
+ PD=1.68U rfmode=0
M$16 \$34 vth \$32 VSS sg13_lv_nmos L=0.3U W=4U AS=1.36P AD=1.36P PS=8.68U
+ PD=8.68U rfmode=0
M$17 \$29 vbn VSS VSS sg13_lv_nmos L=0.5U W=2U AS=0.68P AD=0.68P PS=4.68U
+ PD=4.68U rfmode=0
M$18 \$15 \$14 VSS VSS sg13_lv_nmos L=0.13U W=0.5U AS=0.17P AD=0.17P PS=1.68U
+ PD=1.68U rfmode=0
M$19 b1 trim[1] VSS VSS sg13_lv_nmos L=0.13U W=4U AS=1.36P AD=1.36P PS=8.68U
+ PD=8.68U rfmode=0
M$20 \$25 \$24 VSS VSS sg13_lv_nmos L=0.13U W=0.5U AS=0.17P AD=0.17P PS=1.68U
+ PD=1.68U rfmode=0
M$21 \$24 \$15 VSS VSS sg13_lv_nmos L=0.13U W=0.5U AS=0.17P AD=0.17P PS=1.68U
+ PD=1.68U rfmode=0
M$22 \$35 \$34 VSS VSS sg13_lv_nmos L=0.13U W=0.5U AS=0.17P AD=0.17P PS=1.68U
+ PD=1.68U rfmode=0
M$23 \$30 va \$29 VSS sg13_lv_nmos L=0.3U W=4U AS=1.36P AD=1.36P PS=8.68U
+ PD=8.68U rfmode=0
M$24 \$47 en VSS VSS sg13_lv_nmos L=0.13U W=0.5U AS=0.17P AD=0.17P PS=1.68U
+ PD=1.68U rfmode=0
M$25 bb0 trim[0] VSS VSS sg13_lv_nmos L=0.13U W=4U AS=1.36P AD=1.36P PS=8.68U
+ PD=8.68U rfmode=0
M$26 \$24 \$47 VSS VSS sg13_lv_nmos L=0.13U W=0.5U AS=0.17P AD=0.17P PS=1.68U
+ PD=1.68U rfmode=0
M$27 b0 trim[0] VSS VSS sg13_lv_nmos L=0.13U W=4U AS=1.36P AD=1.36P PS=8.68U
+ PD=8.68U rfmode=0
M$28 bb1 trim[1] VSS VSS sg13_lv_nmos L=0.13U W=4U AS=1.36P AD=1.36P PS=8.68U
+ PD=8.68U rfmode=0
M$29 b3 trim[3] VSS VSS sg13_lv_nmos L=0.13U W=4U AS=1.36P AD=1.36P PS=8.68U
+ PD=8.68U rfmode=0
M$30 \$33 vb \$32 VSS sg13_lv_nmos L=0.3U W=4U AS=1.36P AD=1.36P PS=8.68U
+ PD=8.68U rfmode=0
M$31 b2 trim[2] VSS VSS sg13_lv_nmos L=0.13U W=4U AS=1.36P AD=1.36P PS=8.68U
+ PD=8.68U rfmode=0
M$32 bb2 trim[2] VSS VSS sg13_lv_nmos L=0.13U W=4U AS=1.36P AD=1.36P PS=8.68U
+ PD=8.68U rfmode=0
M$33 \$24 \$25 \$50 VDD sg13_lv_pmos L=0.13U W=3U AS=1.02P AD=1.02P PS=6.68U
+ PD=6.68U rfmode=0
M$34 \$50 \$47 \$48 VDD sg13_lv_pmos L=0.13U W=3U AS=1.02P AD=1.02P PS=6.68U
+ PD=6.68U rfmode=0
M$35 \$48 \$15 VDD VDD sg13_lv_pmos L=0.13U W=3U AS=1.02P AD=1.02P PS=6.68U
+ PD=6.68U rfmode=0
M$36 \$25 \$24 \$49 VDD sg13_lv_pmos L=0.13U W=2U AS=0.68P AD=0.68P PS=4.68U
+ PD=4.68U rfmode=0
M$37 \$49 \$36 VDD VDD sg13_lv_pmos L=0.13U W=2U AS=0.68P AD=0.68P PS=4.68U
+ PD=4.68U rfmode=0
M$38 \$47 en VDD VDD sg13_lv_pmos L=0.13U W=1U AS=0.34P AD=0.34P PS=2.68U
+ PD=2.68U rfmode=0
M$39 \$36 \$35 VDD VDD sg13_lv_pmos L=0.13U W=1U AS=0.34P AD=0.34P PS=2.68U
+ PD=2.68U rfmode=0
M$40 \$27 \$24 VDD VDD sg13_lv_pmos L=0.13U W=1U AS=0.34P AD=0.34P PS=2.68U
+ PD=2.68U rfmode=0
M$41 \$22 \$25 VDD VDD sg13_lv_pmos L=0.13U W=1U AS=0.34P AD=0.34P PS=2.68U
+ PD=2.68U rfmode=0
M$42 \$33 \$33 VDD VDD sg13_lv_pmos L=0.3U W=2U AS=0.68P AD=0.68P PS=4.68U
+ PD=4.68U rfmode=0
M$43 \$34 \$33 VDD VDD sg13_lv_pmos L=0.3U W=2U AS=0.68P AD=0.68P PS=4.68U
+ PD=4.68U rfmode=0
M$44 \$35 \$34 VDD VDD sg13_lv_pmos L=0.13U W=1U AS=0.34P AD=0.34P PS=2.68U
+ PD=2.68U rfmode=0
M$45 \$22 en VDD VDD sg13_lv_pmos L=0.13U W=1U AS=0.34P AD=0.34P PS=2.68U
+ PD=2.68U rfmode=0
M$46 \$15 \$14 VDD VDD sg13_lv_pmos L=0.13U W=1U AS=0.34P AD=0.34P PS=2.68U
+ PD=2.68U rfmode=0
M$47 \$31 \$30 VDD VDD sg13_lv_pmos L=0.3U W=2U AS=0.68P AD=0.68P PS=4.68U
+ PD=4.68U rfmode=0
M$48 osc_clk \$27 VDD VDD sg13_lv_pmos L=0.13U W=1U AS=0.34P AD=0.34P PS=2.68U
+ PD=2.68U rfmode=0
M$49 \$20 \$24 VDD VDD sg13_lv_pmos L=0.13U W=1U AS=0.34P AD=0.34P PS=2.68U
+ PD=2.68U rfmode=0
M$50 \$14 \$31 VDD VDD sg13_lv_pmos L=0.13U W=1U AS=0.34P AD=0.34P PS=2.68U
+ PD=2.68U rfmode=0
M$51 \$30 \$30 VDD VDD sg13_lv_pmos L=0.3U W=2U AS=0.68P AD=0.68P PS=4.68U
+ PD=4.68U rfmode=0
D$52 vth VDD dpantenna A=0.6084P P=3.12U m=1
R$53 \$3 VDD VSS 1 rppd l=58.5 ps=0 b=0 m=1
R$54 \$4 VDD VSS 1 rppd l=58.5 ps=0 b=0 m=1
R$55 \$4 vb VSS 1 rppd l=58.5 ps=0 b=0 m=1
R$56 \$3 va VSS 1 rppd l=58.5 ps=0 b=0 m=1
R$57 \$5 VDD VSS 1 rppd l=64.05 ps=0 b=0 m=1
R$58 \$5 \$52 VSS 1 rppd l=64.05 ps=0 b=0 m=1
R$59 \$6 \$52 VSS 1 rppd l=64.05 ps=0 b=0 m=1
R$60 \$6 \$53 VSS 1 rppd l=64.05 ps=0 b=0 m=1
R$61 \$7 \$53 VSS 1 rppd l=64.05 ps=0 b=0 m=1
R$62 \$7 vth VSS 1 rppd l=64.05 ps=0 b=0 m=1
R$63 \$8 vth VSS 1 rppd l=64.05 ps=0 b=0 m=1
R$64 \$8 \$54 VSS 1 rppd l=64.05 ps=0 b=0 m=1
R$65 \$9 \$54 VSS 1 rppd l=64.05 ps=0 b=0 m=1
R$66 \$9 \$55 VSS 1 rppd l=64.05 ps=0 b=0 m=1
R$67 \$10 \$55 VSS 1 rppd l=64.05 ps=0 b=0 m=1
R$68 \$10 VSS VSS 1 rppd l=64.05 ps=0 b=0 m=1
R$69 \$11 VDD VSS 1 rppd l=67.15 ps=0 b=0 m=1
R$70 \$11 vbn VSS 1 rppd l=67.15 ps=0 b=0 m=1
Cext_1 \$10 \$11 16.6579a
Cext_2 \$10 \$9 16.6579a
Cext_3 \$10 VSS 1.90595a
Cext_4 \$10 VSUBS 538.771a
Cext_5 \$11 VSS 3.02072a
Cext_6 \$11 VSUBS 552.598a
Cext_7 \$14 \$15 10.6295f
Cext_8 \$14 \$20 1.13601a
Cext_9 \$14 \$22 3.54668a
Cext_10 \$14 \$24 102.47a
Cext_11 \$14 \$25 82.925a
Cext_12 \$14 \$26 25.4358a
Cext_13 \$14 \$27 49.5074a
Cext_14 \$14 \$30 263.861a
Cext_15 \$14 \$31 1.54582f
Cext_16 \$14 \$32 169.756a
Cext_17 \$14 \$33 222.087a
Cext_18 \$14 \$34 64.8261a
Cext_19 \$14 \$35 59.7024a
Cext_20 \$14 \$36 7.34025f
Cext_21 \$14 \$47 51.5668a
Cext_22 \$14 b0 18.2284a
Cext_23 \$14 b1 17.0201a
Cext_24 \$14 b2 17.0201a
Cext_25 \$14 b3 17.0201a
Cext_26 \$14 bb0 17.0201a
Cext_27 \$14 bb1 17.0201a
Cext_28 \$14 bb2 17.0201a
Cext_29 \$14 bb3 18.2628a
Cext_30 \$14 en 53.134a
Cext_31 \$14 osc_clk 51.7586a
Cext_32 \$14 trim[0] 29.6919a
Cext_33 \$14 trim[1] 29.5914a
Cext_34 \$14 trim[2] 29.5914a
Cext_35 \$14 trim[3] 25.0468a
Cext_36 \$14 va 153.364a
Cext_37 \$14 vb 29.724a
Cext_38 \$14 vbn 81.6161a
Cext_39 \$14 VDD 151.847a
Cext_40 \$14 VSS 323.998a
Cext_41 \$14 VSUBS 1.89281f
Cext_42 \$14 vth 1.75808f
Cext_43 \$15 \$20 13.2277a
Cext_44 \$15 \$22 15.0783a
Cext_45 \$15 \$24 1.35792f
Cext_46 \$15 \$25 80.5627a
Cext_47 \$15 \$26 25.4358a
Cext_48 \$15 \$27 47.1451a
Cext_49 \$15 \$30 62.5345a
Cext_50 \$15 \$31 391.955a
Cext_51 \$15 \$32 598.027a
Cext_52 \$15 \$33 57.5756a
Cext_53 \$15 \$34 8.81892f
Cext_54 \$15 \$35 45.2259a
Cext_55 \$15 \$36 580.045a
Cext_56 \$15 \$47 267.146a
Cext_57 \$15 \$48 1.22014f
Cext_58 \$15 \$50 0.896578a
Cext_59 \$15 b0 18.3468a
Cext_60 \$15 b1 17.1385a
Cext_61 \$15 b2 17.1385a
Cext_62 \$15 b3 17.1385a
Cext_63 \$15 bb0 17.1385a
Cext_64 \$15 bb1 17.1385a
Cext_65 \$15 bb2 17.1385a
Cext_66 \$15 bb3 18.3812a
Cext_67 \$15 en 94.0757a
Cext_68 \$15 osc_clk 50.5931a
Cext_69 \$15 trim[0] 29.3467a
Cext_70 \$15 trim[1] 29.2462a
Cext_71 \$15 trim[2] 29.2462a
Cext_72 \$15 trim[3] 24.7016a
Cext_73 \$15 va 40.0946a
Cext_74 \$15 vb 30.2345a
Cext_75 \$15 vbn 45.8398a
Cext_76 \$15 VDD 175.497a
Cext_77 \$15 VSS 201.742a
Cext_78 \$15 VSUBS 2.11986f
Cext_79 \$15 vth 46.1575a
Cext_80 \$20 \$22 1.29934f
Cext_81 \$20 \$24 1.14573f
Cext_82 \$20 \$25 50.382a
Cext_83 \$20 \$26 23.5086a
Cext_84 \$20 \$27 46.4825a
Cext_85 \$20 \$30 3.8756f
Cext_86 \$20 \$31 4.22563f
Cext_87 \$20 \$33 0.239279a
Cext_88 \$20 \$34 0.38988a
Cext_89 \$20 \$36 14.6847a
Cext_90 \$20 \$47 25.1185a
Cext_91 \$20 \$48 280.12a
Cext_92 \$20 \$49 285.733a
Cext_93 \$20 \$50 242.019a
Cext_94 \$20 bb3 3.55295a
Cext_95 \$20 en 325.795a
Cext_96 \$20 osc_clk 29.6164a
Cext_97 \$20 trim[3] 84.6657a
Cext_98 \$20 va 740.683a
Cext_99 \$20 vb 61.5245a
Cext_100 \$20 VDD 135.664a
Cext_101 \$20 VSS 531.875a
Cext_102 \$20 VSUBS 2.40287f
Cext_103 \$22 \$24 191.391a
Cext_104 \$22 \$25 1.25402f
Cext_105 \$22 \$26 664.904a
Cext_106 \$22 \$27 50.9036a
Cext_107 \$22 \$30 3.65411f
Cext_108 \$22 \$31 73.8516a
Cext_109 \$22 \$33 0.946963a
Cext_110 \$22 \$34 1.13601a
Cext_111 \$22 \$36 6.70966f
Cext_112 \$22 \$47 226.16a
Cext_113 \$22 \$48 36.0858a
Cext_114 \$22 \$49 115.085a
Cext_115 \$22 \$50 269.131a
Cext_116 \$22 en 552.873a
Cext_117 \$22 osc_clk 46.6735a
Cext_118 \$22 trim[3] 0.475957a
Cext_119 \$22 va 16.9498a
Cext_120 \$22 vb 861.124a
Cext_121 \$22 VDD 271.328a
Cext_122 \$22 VSS 192.032a
Cext_123 \$22 VSUBS 2.08429f
Cext_124 \$24 \$25 9.66497f
Cext_125 \$24 \$26 936.81a
Cext_126 \$24 \$27 2.39932f
Cext_127 \$24 \$30 113.721a
Cext_128 \$24 \$31 135.908a
Cext_129 \$24 \$33 120.62a
Cext_130 \$24 \$34 106.931a
Cext_131 \$24 \$35 114.293a
Cext_132 \$24 \$36 149.17a
Cext_133 \$24 \$47 1.60002f
Cext_134 \$24 \$48 23.5086a
Cext_135 \$24 \$49 91.5875a
Cext_136 \$24 \$50 574.363a
Cext_137 \$24 en 8.22203f
Cext_138 \$24 osc_clk 474.395a
Cext_139 \$24 va 0.824592a
Cext_140 \$24 vb 3.27644a
Cext_141 \$24 VDD 175.773a
Cext_142 \$24 VSS 514.148a
Cext_143 \$24 VSUBS 4.41793f
Cext_144 \$25 \$26 1.03119f
Cext_145 \$25 \$27 4.62989f
Cext_146 \$25 \$30 87.6804a
Cext_147 \$25 \$31 101.047a
Cext_148 \$25 \$33 96.7839a
Cext_149 \$25 \$34 82.925a
Cext_150 \$25 \$35 83.8483a
Cext_151 \$25 \$36 1.22538f
Cext_152 \$25 \$47 135.273a
Cext_153 \$25 \$48 23.5086a
Cext_154 \$25 \$49 493.121a
Cext_155 \$25 \$50 61.0703a
Cext_156 \$25 en 125.155a
Cext_157 \$25 osc_clk 75.3a
Cext_158 \$25 vb 0.298178a
Cext_159 \$25 VDD 129.425a
Cext_160 \$25 VSS 405.73a
Cext_161 \$25 VSUBS 3.34405f
Cext_162 \$26 \$27 13.871a
Cext_163 \$26 \$30 23.5086a
Cext_164 \$26 \$31 35.0593a
Cext_165 \$26 \$33 25.4358a
Cext_166 \$26 \$34 25.4358a
Cext_167 \$26 \$35 25.4358a
Cext_168 \$26 \$36 25.4358a
Cext_169 \$26 \$47 25.4358a
Cext_170 \$26 en 1.3487f
Cext_171 \$26 VDD 5.45034a
Cext_172 \$26 VSS 105.183a
Cext_173 \$26 VSUBS 807.193a
Cext_174 \$27 \$30 648.11a
Cext_175 \$27 \$31 79.262a
Cext_176 \$27 \$33 63.5401a
Cext_177 \$27 \$34 49.5074a
Cext_178 \$27 \$35 49.0983a
Cext_179 \$27 \$36 47.1451a
Cext_180 \$27 \$47 47.1451a
Cext_181 \$27 \$48 23.5086a
Cext_182 \$27 \$49 23.5086a
Cext_183 \$27 \$50 21.2327a
Cext_184 \$27 en 123.168a
Cext_185 \$27 osc_clk 7.14936f
Cext_186 \$27 va 0.15842a
Cext_187 \$27 VDD 162.86a
Cext_188 \$27 VSS 110.493a
Cext_189 \$27 VSUBS 1.8181f
Cext_190 \$29 \$30 328.412a
Cext_191 \$29 \$31 343.624a
Cext_192 \$29 va 512.195a
Cext_193 \$29 vbn 1.57844f
Cext_194 \$29 VSS 99.3798a
Cext_195 \$29 VSUBS 528.6a
Cext_196 \$29 vth 70.5511a
Cext_197 \$3 \$4 112.166a
Cext_198 \$3 \$5 19.4868a
Cext_199 \$3 \$6 0.435309a
Cext_200 \$3 VSS 5.57995a
Cext_201 \$3 VSUBS 899.272a
Cext_202 \$30 \$31 1.49559f
Cext_203 \$30 \$32 41.2058a
Cext_204 \$30 \$33 50.0715a
Cext_205 \$30 \$34 60.125a
Cext_206 \$30 \$35 63.6437a
Cext_207 \$30 \$36 125.718a
Cext_208 \$30 \$47 61.4055a
Cext_209 \$30 b0 20.6948a
Cext_210 \$30 b1 19.4865a
Cext_211 \$30 b2 19.4865a
Cext_212 \$30 b3 19.4865a
Cext_213 \$30 bb0 17.0201a
Cext_214 \$30 bb1 17.0201a
Cext_215 \$30 bb2 17.0201a
Cext_216 \$30 bb3 17.0201a
Cext_217 \$30 en 69.0207a
Cext_218 \$30 osc_clk 108.218a
Cext_219 \$30 trim[0] 498.615a
Cext_220 \$30 trim[1] 498.514a
Cext_221 \$30 trim[2] 498.514a
Cext_222 \$30 trim[3] 499.843a
Cext_223 \$30 va 6.14195f
Cext_224 \$30 vb 26.7297a
Cext_225 \$30 vbn 3.02069f
Cext_226 \$30 VDD 289.357a
Cext_227 \$30 VSS 9.98916a
Cext_228 \$30 VSUBS 2.12402f
Cext_229 \$30 vth 34.7167a
Cext_230 \$31 \$32 54.294a
Cext_231 \$31 \$33 42.4455a
Cext_232 \$31 \$34 61.5555a
Cext_233 \$31 \$35 63.7635a
Cext_234 \$31 \$36 71.4041a
Cext_235 \$31 \$47 62.9721a
Cext_236 \$31 b0 20.8009a
Cext_237 \$31 b1 20.8009a
Cext_238 \$31 b2 20.8009a
Cext_239 \$31 b3 20.8009a
Cext_240 \$31 bb0 18.3345a
Cext_241 \$31 bb1 18.3345a
Cext_242 \$31 bb2 18.3345a
Cext_243 \$31 bb3 18.3345a
Cext_244 \$31 en 65.9611a
Cext_245 \$31 osc_clk 58.2546a
Cext_246 \$31 trim[0] 514.482a
Cext_247 \$31 trim[1] 514.364a
Cext_248 \$31 trim[2] 514.364a
Cext_249 \$31 trim[3] 514.364a
Cext_250 \$31 va 22.5816a
Cext_251 \$31 vb 43.7478a
Cext_252 \$31 vbn 2.72209f
Cext_253 \$31 VDD 224.735a
Cext_254 \$31 VSS 211.62a
Cext_255 \$31 VSUBS 3.00807f
Cext_256 \$31 vth 767.835a
Cext_257 \$32 \$33 779.492a
Cext_258 \$32 \$34 560.844a
Cext_259 \$32 va 41.2058a
Cext_260 \$32 vb 783.074a
Cext_261 \$32 vbn 1.23282f
Cext_262 \$32 VSS 97.349a
Cext_263 \$32 VSUBS 793.462a
Cext_264 \$32 vth 116.192a
Cext_265 \$33 \$34 9.35821f
Cext_266 \$33 \$35 227.74a
Cext_267 \$33 \$36 1.70708a
Cext_268 \$33 \$47 4.63079f
Cext_269 \$33 b0 19.0574a
Cext_270 \$33 b1 17.849a
Cext_271 \$33 b2 17.849a
Cext_272 \$33 b3 17.849a
Cext_273 \$33 bb0 17.849a
Cext_274 \$33 bb1 17.849a
Cext_275 \$33 bb2 17.849a
Cext_276 \$33 bb3 19.0918a
Cext_277 \$33 en 72.5942a
Cext_278 \$33 osc_clk 84.9624a
Cext_279 \$33 trim[0] 29.1239a
Cext_280 \$33 trim[1] 29.0234a
Cext_281 \$33 trim[2] 29.0234a
Cext_282 \$33 trim[3] 24.4788a
Cext_283 \$33 va 37.1358a
Cext_284 \$33 vb 5.2786f
Cext_285 \$33 vbn 41.2389a
Cext_286 \$33 VDD 303.841a
Cext_287 \$33 VSS 3.55576a
Cext_288 \$33 VSUBS 1.9346f
Cext_289 \$33 vth 45.4679a
Cext_290 \$34 \$35 1.71792f
Cext_291 \$34 \$36 382.577a
Cext_292 \$34 \$47 145.475a
Cext_293 \$34 b0 18.5152a
Cext_294 \$34 b1 17.3068a
Cext_295 \$34 b2 17.3068a
Cext_296 \$34 b3 17.3068a
Cext_297 \$34 bb0 17.3068a
Cext_298 \$34 bb1 17.3068a
Cext_299 \$34 bb2 17.3068a
Cext_300 \$34 bb3 18.5496a
Cext_301 \$34 en 53.5788a
Cext_302 \$34 osc_clk 52.4793a
Cext_303 \$34 trim[0] 29.2845a
Cext_304 \$34 trim[1] 29.0234a
Cext_305 \$34 trim[2] 29.0234a
Cext_306 \$34 trim[3] 24.4788a
Cext_307 \$34 va 52.2598a
Cext_308 \$34 vb 21.5808a
Cext_309 \$34 vbn 55.1913a
Cext_310 \$34 VDD 227.264a
Cext_311 \$34 VSS 152.706a
Cext_312 \$34 VSUBS 1.75216f
Cext_313 \$34 vth 1.0116f
Cext_314 \$35 \$36 1.39652f
Cext_315 \$35 \$47 5.23453f
Cext_316 \$35 \$48 0.145066a
Cext_317 \$35 b0 230.672a
Cext_318 \$35 b1 182.614a
Cext_319 \$35 b2 182.614a
Cext_320 \$35 b3 182.614a
Cext_321 \$35 bb0 182.614a
Cext_322 \$35 bb1 182.614a
Cext_323 \$35 bb2 182.614a
Cext_324 \$35 bb3 184.361a
Cext_325 \$35 en 5.11452f
Cext_326 \$35 osc_clk 51.3495a
Cext_327 \$35 trim[0] 36.4837a
Cext_328 \$35 trim[1] 35.8659a
Cext_329 \$35 trim[2] 35.8659a
Cext_330 \$35 trim[3] 31.3214a
Cext_331 \$35 va 58.9028a
Cext_332 \$35 vb 3.63107f
Cext_333 \$35 vbn 195.243a
Cext_334 \$35 VDD 160.081a
Cext_335 \$35 VSS 323.998a
Cext_336 \$35 VSUBS 2.32222f
Cext_337 \$35 vth 239.545a
Cext_338 \$36 \$47 90.513a
Cext_339 \$36 \$48 62.6065a
Cext_340 \$36 \$49 1.41264f
Cext_341 \$36 \$50 40.4364a
Cext_342 \$36 b0 18.2284a
Cext_343 \$36 b1 17.0201a
Cext_344 \$36 b2 17.0201a
Cext_345 \$36 b3 17.0201a
Cext_346 \$36 bb0 17.0201a
Cext_347 \$36 bb1 17.0201a
Cext_348 \$36 bb2 17.0201a
Cext_349 \$36 bb3 18.2628a
Cext_350 \$36 en 96.7417a
Cext_351 \$36 osc_clk 50.133a
Cext_352 \$36 trim[0] 30.3619a
Cext_353 \$36 trim[1] 29.9751a
Cext_354 \$36 trim[2] 29.9751a
Cext_355 \$36 trim[3] 25.4305a
Cext_356 \$36 va 3.03243f
Cext_357 \$36 vb 21.0333a
Cext_358 \$36 vbn 45.527a
Cext_359 \$36 VDD 161.315a
Cext_360 \$36 VSS 204.672a
Cext_361 \$36 VSUBS 2.0304f
Cext_362 \$36 vth 8.3107a
Cext_363 \$4 VSS 1.90575a
Cext_364 \$4 VSUBS 538.771a
Cext_365 \$47 \$48 104.614a
Cext_366 \$47 \$49 0.145066a
Cext_367 \$47 \$50 909.605a
Cext_368 \$47 en 1.92915f
Cext_369 \$47 osc_clk 50.5931a
Cext_370 \$47 trim[3] 0.293346a
Cext_371 \$47 va 1.39024a
Cext_372 \$47 vb 90.8067a
Cext_373 \$47 VDD 146.344a
Cext_374 \$47 VSS 201.742a
Cext_375 \$47 VSUBS 1.81457f
Cext_376 \$48 \$49 11.7204a
Cext_377 \$48 \$50 1.04568f
Cext_378 \$48 en 128.506a
Cext_379 \$48 osc_clk 34.6659a
Cext_380 \$48 VDD 343.549a
Cext_381 \$48 VSS 3.04012a
Cext_382 \$48 VSUBS 823.746a
Cext_383 \$49 \$50 79.3398a
Cext_384 \$49 en 41.8431a
Cext_385 \$49 osc_clk 33.9458a
Cext_386 \$49 VDD 202.103a
Cext_387 \$49 VSS 3.04012a
Cext_388 \$49 VSUBS 848.794a
Cext_389 \$5 \$6 16.5508a
Cext_390 \$5 VSS 1.90595a
Cext_391 \$5 VSUBS 538.771a
Cext_392 \$50 en 36.1006a
Cext_393 \$50 osc_clk 32.39a
Cext_394 \$50 VDD 16.9341a
Cext_395 \$50 VSS 2.48322a
Cext_396 \$50 VSUBS 652.946a
Cext_397 \$52 \$53 16.6579a
Cext_398 \$52 VDD 22.6989a
Cext_399 \$52 VSUBS 538.771a
Cext_400 \$52 vth 2.56667a
Cext_401 \$53 VDD 2.87737a
Cext_402 \$53 VSUBS 538.771a
Cext_403 \$53 vth 27.8301a
Cext_404 \$54 \$55 16.6579a
Cext_405 \$54 VDD 2.33853a
Cext_406 \$54 VSS 2.56667a
Cext_407 \$54 VSUBS 538.771a
Cext_408 \$54 vth 21.4267a
Cext_409 \$55 VDD 2.33853a
Cext_410 \$55 VSS 27.8301a
Cext_411 \$55 VSUBS 538.771a
Cext_412 \$55 vth 0.855517a
Cext_413 \$6 \$7 16.6579a
Cext_414 \$6 VSS 1.90595a
Cext_415 \$6 VSUBS 538.771a
Cext_416 \$7 \$8 16.6579a
Cext_417 \$7 VSS 1.90595a
Cext_418 \$7 VSUBS 538.771a
Cext_419 \$8 \$9 16.6579a
Cext_420 \$8 VSS 1.90595a
Cext_421 \$8 VSUBS 538.771a
Cext_422 \$9 VSS 1.90595a
Cext_423 \$9 VSUBS 538.771a
Cext_424 b0 b1 1.8122f
Cext_425 b0 b2 28.3487a
Cext_426 b0 b3 28.3487a
Cext_427 b0 bb0 516.605a
Cext_428 b0 bb1 62.5046a
Cext_429 b0 bb2 26.4179a
Cext_430 b0 bb3 26.4179a
Cext_431 b0 en 3.96779f
Cext_432 b0 osc_clk 86.4088a
Cext_433 b0 trim[0] 767.992a
Cext_434 b0 trim[1] 24.4694a
Cext_435 b0 trim[2] 24.4694a
Cext_436 b0 trim[3] 24.4694a
Cext_437 b0 va 3.88116f
Cext_438 b0 vb 52.8665a
Cext_439 b0 vbn 587.462a
Cext_440 b0 vth 0.113924a
Cext_441 b1 b2 31.3631a
Cext_442 b1 b3 31.3631a
Cext_443 b1 bb0 1.42816f
Cext_444 b1 bb1 605.981a
Cext_445 b1 bb2 29.4324a
Cext_446 b1 bb3 29.4324a
Cext_447 b1 en 33.8337a
Cext_448 b1 osc_clk 309.204a
Cext_449 b1 trim[0] 811.741a
Cext_450 b1 trim[1] 771.16a
Cext_451 b1 trim[2] 27.4838a
Cext_452 b1 trim[3] 30.7302a
Cext_453 b1 va 1.6597f
Cext_454 b1 vb 3.75809f
Cext_455 b1 vth 0.267801a
Cext_456 b2 b3 1.20045f
Cext_457 b2 bb0 117.229a
Cext_458 b2 bb1 341.649a
Cext_459 b2 bb2 853.686a
Cext_460 b2 bb3 110.347a
Cext_461 b2 en 33.8337a
Cext_462 b2 trim[1] 987.005a
Cext_463 b2 trim[2] 776.695a
Cext_464 b2 trim[3] 190.756a
Cext_465 b2 va 48.3832a
Cext_466 b2 vb 75.3782a
Cext_467 b2 vth 77.5981a
Cext_468 b3 bb0 529.335a
Cext_469 b3 bb1 30.0505a
Cext_470 b3 bb2 310.119a
Cext_471 b3 bb3 879.017a
Cext_472 b3 en 33.8337a
Cext_473 b3 trim[2] 1.10384f
Cext_474 b3 trim[3] 780.943a
Cext_475 b3 va 48.3832a
Cext_476 b3 vb 167.533a
Cext_477 b3 vth 44.0686a
Cext_478 bb0 bb1 7.87022f
Cext_479 bb0 bb2 37.0499a
Cext_480 bb0 bb3 34.5152a
Cext_481 bb0 en 31.9029a
Cext_482 bb0 osc_clk 569.351a
Cext_483 bb0 trim[0] 2.34995f
Cext_484 bb0 trim[1] 36.9955a
Cext_485 bb0 trim[2] 36.457a
Cext_486 bb0 trim[3] 102.885a
Cext_487 bb0 va 77.373a
Cext_488 bb0 vb 131.503a
Cext_489 bb0 vbn 132.884a
Cext_490 bb0 vth 372.283a
Cext_491 bb1 bb2 3.16898f
Cext_492 bb1 bb3 62.7499a
Cext_493 bb1 en 31.9029a
Cext_494 bb1 osc_clk 13.1578a
Cext_495 bb1 trim[0] 3.47551a
Cext_496 bb1 trim[1] 2.70631f
Cext_497 bb1 trim[2] 38.5874a
Cext_498 bb1 trim[3] 39.6942a
Cext_499 bb1 va 77.5932a
Cext_500 bb1 vb 116.466a
Cext_501 bb1 vth 67.5919a
Cext_502 bb2 bb3 3.49329f
Cext_503 bb2 en 31.9029a
Cext_504 bb2 trim[1] 3.32285a
Cext_505 bb2 trim[2] 2.94677f
Cext_506 bb2 trim[3] 39.8791a
Cext_507 bb2 va 57.1235a
Cext_508 bb2 vb 82.1861a
Cext_509 bb2 vth 45.5319a
Cext_510 bb3 en 40.4206a
Cext_511 bb3 trim[2] 3.32285a
Cext_512 bb3 trim[3] 3.19004f
Cext_513 bb3 va 72.1305a
Cext_514 bb3 vb 122.531a
Cext_515 bb3 vth 61.2706a
Cext_516 en osc_clk 1.03278f
Cext_517 en trim[0] 248.945a
Cext_518 en trim[1] 29.9544a
Cext_519 en trim[2] 29.9544a
Cext_520 en trim[3] 30.1979a
Cext_521 en va 1.55177f
Cext_522 en vb 45.1641a
Cext_523 en vbn 39.8689a
Cext_524 en vth 46.6665a
Cext_525 osc_clk va 61.5743a
Cext_526 osc_clk vb 279.734a
Cext_527 osc_clk vth 0.302908a
Cext_528 trim[0] trim[1] 337.362a
Cext_529 trim[0] va 3.78993f
Cext_530 trim[0] vb 1.66541f
Cext_531 trim[0] vbn 162.619a
Cext_532 trim[0] vth 42.1904a
Cext_533 trim[1] trim[2] 807.676a
Cext_534 trim[1] va 130.865a
Cext_535 trim[1] vb 4.06513f
Cext_536 trim[1] vbn 34.2365a
Cext_537 trim[1] vth 3.17319f
Cext_538 trim[2] trim[3] 1.48515f
Cext_539 trim[2] va 133.879a
Cext_540 trim[2] vb 96.1114a
Cext_541 trim[2] vbn 1.8053f
Cext_542 trim[2] vth 3.40139f
Cext_543 trim[3] va 1.10817f
Cext_544 trim[3] vb 177.21a
Cext_545 trim[3] vbn 1.81207f
Cext_546 trim[3] vth 135.611a
Cext_547 va vb 3.20348f
Cext_548 va vbn 379.736a
Cext_549 va vth 3.50347f
Cext_550 vb vbn 129.665a
Cext_551 vb vth 2.25378f
Cext_552 vbn vth 243.077a
Cext_553 VDD b0 85.585a
Cext_554 VDD b1 70.6541a
Cext_555 VDD b2 34.9925a
Cext_556 VDD b3 34.9925a
Cext_557 VDD bb0 51.3369a
Cext_558 VDD bb1 51.3369a
Cext_559 VDD bb2 32.628a
Cext_560 VDD bb3 36.0579a
Cext_561 VDD en 534.479a
Cext_562 VDD osc_clk 362.488a
Cext_563 VDD trim[0] 29.0028a
Cext_564 VDD trim[1] 25.4851a
Cext_565 VDD trim[2] 24.3218a
Cext_566 VDD trim[3] 24.3218a
Cext_567 VDD va 82.103a
Cext_568 VDD vb 265.014a
Cext_569 VDD vbn 83.9096a
Cext_570 VDD VSS 2.8321f
Cext_571 VDD VSUBS 41.759f
Cext_572 VDD vth 132.955a
Cext_573 VSS b0 462.59a
Cext_574 VSS b1 522.424a
Cext_575 VSS b2 438.505a
Cext_576 VSS b3 1.88595f
Cext_577 VSS bb0 491.694a
Cext_578 VSS bb1 3.59722f
Cext_579 VSS bb2 525.003a
Cext_580 VSS bb3 4.848f
Cext_581 VSS en 383.026a
Cext_582 VSS osc_clk 152.556a
Cext_583 VSS trim[0] 1.01844f
Cext_584 VSS trim[1] 1.01547f
Cext_585 VSS trim[2] 1.01382f
Cext_586 VSS trim[3] 1.43072f
Cext_587 VSS va 560.877a
Cext_588 VSS vb 2.80259f
Cext_589 VSS vbn 1.22922f
Cext_590 VSS VSUBS 98.4246f
Cext_591 VSS vth 4.69171f
Cext_592 VSUBS b0 3.75019f
Cext_593 VSUBS b1 3.83514f
Cext_594 VSUBS b2 1.61204f
Cext_595 VSUBS b3 1.95914f
Cext_596 VSUBS bb0 4.36991f
Cext_597 VSUBS bb1 3.2974f
Cext_598 VSUBS bb2 1.89501f
Cext_599 VSUBS bb3 2.50545f
Cext_600 VSUBS en 7.27274f
Cext_601 VSUBS osc_clk 4.00186f
Cext_602 VSUBS trim[0] 2.77906f
Cext_603 VSUBS trim[1] 2.51851f
Cext_604 VSUBS trim[2] 2.69863f
Cext_605 VSUBS trim[3] 4.50772f
Cext_606 VSUBS va 10.8668f
Cext_607 VSUBS vb 11.2541f
Cext_608 VSUBS vbn 5.80056f
Cext_609 VSUBS vth 10.3128f
.ENDS g1_osc
