* Extracted by KLayout with SG13G2 LVS runset on : 19/09/2026 14:26

.SUBCKT g1_osc VDD VSS b0 b1 b2 b3 bb0 bb1 bb2 bb3 en osc_clk trim[0] trim[1]
+ trim[2] trim[3] va vb vbn vth
M$1 VSS \$22 vb VSS sg13_lv_nmos L=0.13u W=4u AS=1.36p AD=1.36p PS=8.68u
+ PD=8.68u rfmode=0
M$2 VSS \$20 va VSS sg13_lv_nmos L=0.13u W=4u AS=1.36p AD=1.36p PS=8.68u
+ PD=8.68u rfmode=0
M$3 VSS trim[3] bb3 VSS sg13_lv_nmos L=0.13u W=4u AS=1.36p AD=1.36p PS=8.68u
+ PD=8.68u rfmode=0
M$4 \$26 \$25 \$22 VSS sg13_lv_nmos L=0.13u W=1u AS=0.34p AD=0.34p PS=2.68u
+ PD=2.68u rfmode=0
M$5 VSS \$27 osc_clk VSS sg13_lv_nmos L=0.13u W=0.5u AS=0.17p AD=0.17p PS=1.68u
+ PD=1.68u rfmode=0
M$6 VSS \$31 \$14 VSS sg13_lv_nmos L=0.13u W=0.5u AS=0.17p AD=0.17p PS=1.68u
+ PD=1.68u rfmode=0
M$7 VSS vbn \$32 VSS sg13_lv_nmos L=0.5u W=2u AS=0.68p AD=0.68p PS=4.68u
+ PD=4.68u rfmode=0
M$8 VSS \$24 \$27 VSS sg13_lv_nmos L=0.13u W=0.5u AS=0.17p AD=0.17p PS=1.68u
+ PD=1.68u rfmode=0
M$9 VSS en \$26 VSS sg13_lv_nmos L=0.13u W=1u AS=0.34p AD=0.34p PS=2.68u
+ PD=2.68u rfmode=0
M$10 VSS \$24 \$20 VSS sg13_lv_nmos L=0.13u W=0.5u AS=0.17p AD=0.17p PS=1.68u
+ PD=1.68u rfmode=0
M$11 VSS \$25 \$24 VSS sg13_lv_nmos L=0.13u W=0.5u AS=0.17p AD=0.17p PS=1.68u
+ PD=1.68u rfmode=0
M$12 VSS vbn vbn VSS sg13_lv_nmos L=0.5u W=2u AS=0.68p AD=0.68p PS=4.68u
+ PD=4.68u rfmode=0
M$13 VSS \$36 \$25 VSS sg13_lv_nmos L=0.13u W=0.5u AS=0.17p AD=0.17p PS=1.68u
+ PD=1.68u rfmode=0
M$14 \$29 vth \$31 VSS sg13_lv_nmos L=0.3u W=4u AS=1.36p AD=1.36p PS=8.68u
+ PD=8.68u rfmode=0
M$15 VSS \$35 \$36 VSS sg13_lv_nmos L=0.13u W=0.5u AS=0.17p AD=0.17p PS=1.68u
+ PD=1.68u rfmode=0
M$16 \$32 vth \$34 VSS sg13_lv_nmos L=0.3u W=4u AS=1.36p AD=1.36p PS=8.68u
+ PD=8.68u rfmode=0
M$17 VSS vbn \$29 VSS sg13_lv_nmos L=0.5u W=2u AS=0.68p AD=0.68p PS=4.68u
+ PD=4.68u rfmode=0
M$18 VSS \$14 \$15 VSS sg13_lv_nmos L=0.13u W=0.5u AS=0.17p AD=0.17p PS=1.68u
+ PD=1.68u rfmode=0
M$19 VSS trim[1] b1 VSS sg13_lv_nmos L=0.13u W=4u AS=1.36p AD=1.36p PS=8.68u
+ PD=8.68u rfmode=0
M$20 VSS \$24 \$25 VSS sg13_lv_nmos L=0.13u W=0.5u AS=0.17p AD=0.17p PS=1.68u
+ PD=1.68u rfmode=0
M$21 VSS \$15 \$24 VSS sg13_lv_nmos L=0.13u W=0.5u AS=0.17p AD=0.17p PS=1.68u
+ PD=1.68u rfmode=0
M$22 VSS \$34 \$35 VSS sg13_lv_nmos L=0.13u W=0.5u AS=0.17p AD=0.17p PS=1.68u
+ PD=1.68u rfmode=0
M$23 \$29 va \$30 VSS sg13_lv_nmos L=0.3u W=4u AS=1.36p AD=1.36p PS=8.68u
+ PD=8.68u rfmode=0
M$24 VSS en \$47 VSS sg13_lv_nmos L=0.13u W=0.5u AS=0.17p AD=0.17p PS=1.68u
+ PD=1.68u rfmode=0
M$25 VSS trim[0] bb0 VSS sg13_lv_nmos L=0.13u W=4u AS=1.36p AD=1.36p PS=8.68u
+ PD=8.68u rfmode=0
M$26 VSS \$47 \$24 VSS sg13_lv_nmos L=0.13u W=0.5u AS=0.17p AD=0.17p PS=1.68u
+ PD=1.68u rfmode=0
M$27 VSS trim[0] b0 VSS sg13_lv_nmos L=0.13u W=4u AS=1.36p AD=1.36p PS=8.68u
+ PD=8.68u rfmode=0
M$28 VSS trim[1] bb1 VSS sg13_lv_nmos L=0.13u W=4u AS=1.36p AD=1.36p PS=8.68u
+ PD=8.68u rfmode=0
M$29 VSS trim[3] b3 VSS sg13_lv_nmos L=0.13u W=4u AS=1.36p AD=1.36p PS=8.68u
+ PD=8.68u rfmode=0
M$30 \$32 vb \$33 VSS sg13_lv_nmos L=0.3u W=4u AS=1.36p AD=1.36p PS=8.68u
+ PD=8.68u rfmode=0
M$31 VSS trim[2] b2 VSS sg13_lv_nmos L=0.13u W=4u AS=1.36p AD=1.36p PS=8.68u
+ PD=8.68u rfmode=0
M$32 VSS trim[2] bb2 VSS sg13_lv_nmos L=0.13u W=4u AS=1.36p AD=1.36p PS=8.68u
+ PD=8.68u rfmode=0
M$33 \$50 \$25 \$24 VDD sg13_lv_pmos L=0.13u W=3u AS=1.02p AD=1.02p PS=6.68u
+ PD=6.68u rfmode=0
M$34 \$48 \$47 \$50 VDD sg13_lv_pmos L=0.13u W=3u AS=1.02p AD=1.02p PS=6.68u
+ PD=6.68u rfmode=0
M$35 VDD \$15 \$48 VDD sg13_lv_pmos L=0.13u W=3u AS=1.02p AD=1.02p PS=6.68u
+ PD=6.68u rfmode=0
M$36 \$49 \$24 \$25 VDD sg13_lv_pmos L=0.13u W=2u AS=0.68p AD=0.68p PS=4.68u
+ PD=4.68u rfmode=0
M$37 VDD \$36 \$49 VDD sg13_lv_pmos L=0.13u W=2u AS=0.68p AD=0.68p PS=4.68u
+ PD=4.68u rfmode=0
M$38 VDD en \$47 VDD sg13_lv_pmos L=0.13u W=1u AS=0.34p AD=0.34p PS=2.68u
+ PD=2.68u rfmode=0
M$39 VDD \$35 \$36 VDD sg13_lv_pmos L=0.13u W=1u AS=0.34p AD=0.34p PS=2.68u
+ PD=2.68u rfmode=0
M$40 VDD \$24 \$27 VDD sg13_lv_pmos L=0.13u W=1u AS=0.34p AD=0.34p PS=2.68u
+ PD=2.68u rfmode=0
M$41 VDD \$25 \$22 VDD sg13_lv_pmos L=0.13u W=1u AS=0.34p AD=0.34p PS=2.68u
+ PD=2.68u rfmode=0
M$42 VDD \$33 \$33 VDD sg13_lv_pmos L=0.3u W=2u AS=0.68p AD=0.68p PS=4.68u
+ PD=4.68u rfmode=0
M$43 VDD \$33 \$34 VDD sg13_lv_pmos L=0.3u W=2u AS=0.68p AD=0.68p PS=4.68u
+ PD=4.68u rfmode=0
M$44 VDD \$34 \$35 VDD sg13_lv_pmos L=0.13u W=1u AS=0.34p AD=0.34p PS=2.68u
+ PD=2.68u rfmode=0
M$45 VDD en \$22 VDD sg13_lv_pmos L=0.13u W=1u AS=0.34p AD=0.34p PS=2.68u
+ PD=2.68u rfmode=0
M$46 VDD \$14 \$15 VDD sg13_lv_pmos L=0.13u W=1u AS=0.34p AD=0.34p PS=2.68u
+ PD=2.68u rfmode=0
M$47 VDD \$30 \$31 VDD sg13_lv_pmos L=0.3u W=2u AS=0.68p AD=0.68p PS=4.68u
+ PD=4.68u rfmode=0
M$48 VDD \$27 osc_clk VDD sg13_lv_pmos L=0.13u W=1u AS=0.34p AD=0.34p PS=2.68u
+ PD=2.68u rfmode=0
M$49 VDD \$24 \$20 VDD sg13_lv_pmos L=0.13u W=1u AS=0.34p AD=0.34p PS=2.68u
+ PD=2.68u rfmode=0
M$50 VDD \$31 \$14 VDD sg13_lv_pmos L=0.13u W=1u AS=0.34p AD=0.34p PS=2.68u
+ PD=2.68u rfmode=0
M$51 VDD \$30 \$30 VDD sg13_lv_pmos L=0.3u W=2u AS=0.68p AD=0.68p PS=4.68u
+ PD=4.68u rfmode=0
D$52 vth VDD dpantenna A=0.6084p P=3.12u m=1
R$53 \$3 VDD VSS rppd w=1u l=58.5u ps=0u b=0 m=1
R$54 \$4 VDD VSS rppd w=1u l=58.5u ps=0u b=0 m=1
R$55 \$4 vb VSS rppd w=1u l=58.5u ps=0u b=0 m=1
R$56 \$3 va VSS rppd w=1u l=58.5u ps=0u b=0 m=1
R$57 \$5 VDD VSS rppd w=1u l=64.05u ps=0u b=0 m=1
R$58 \$5 \$52 VSS rppd w=1u l=64.05u ps=0u b=0 m=1
R$59 \$6 \$52 VSS rppd w=1u l=64.05u ps=0u b=0 m=1
R$60 \$6 \$53 VSS rppd w=1u l=64.05u ps=0u b=0 m=1
R$61 \$7 \$53 VSS rppd w=1u l=64.05u ps=0u b=0 m=1
R$62 \$7 vth VSS rppd w=1u l=64.05u ps=0u b=0 m=1
R$63 \$8 vth VSS rppd w=1u l=64.05u ps=0u b=0 m=1
R$64 \$8 \$54 VSS rppd w=1u l=64.05u ps=0u b=0 m=1
R$65 \$9 \$54 VSS rppd w=1u l=64.05u ps=0u b=0 m=1
R$66 \$9 \$55 VSS rppd w=1u l=64.05u ps=0u b=0 m=1
R$67 \$10 \$55 VSS rppd w=1u l=64.05u ps=0u b=0 m=1
R$68 \$10 VSS VSS rppd w=1u l=64.05u ps=0u b=0 m=1
R$69 \$11 VDD VSS rppd w=1u l=67.15u ps=0u b=0 m=1
R$70 \$11 vbn VSS rppd w=1u l=67.15u ps=0u b=0 m=1
.ENDS g1_osc
