* G1_OSC start-up: VDD ramps 0 -> 1.2 V in 1 us, en tied to vdd; first osc_clk edge and settled frequency
.lib /foss/pdks/ihp-sg13g2/libs.tech/ngspice/models/cornerMOSlv.lib @@MOS@@
.lib /foss/pdks/ihp-sg13g2/libs.tech/ngspice/models/cornerRES.lib @@RES@@
.lib /foss/pdks/ihp-sg13g2/libs.tech/ngspice/models/cornerCAP.lib @@CAP@@
.lib /foss/pdks/ihp-sg13g2/libs.tech/ngspice/models/cornerDIO.lib dio_tt
* (dio_tt: the antenna diode dantenna on vth, revision 5; the diode library has one corner set)
.temp @@TEMP@@
* rshunt: 1 TOhm from every node to ground; without it the operating point with the antenna diode
* (revision 5) does not converge and the transient crawls (the rppd body node sub! is floating)
.option rshunt=1e12
.include netlist/g1_osc.spice
Vdd vdd 0 pwl(0 0 1u 1.2 10u 1.2)
Vt0 trim0 0 dc 0
Vt1 trim1 0 dc 0
Vt2 trim2 0 dc 0
Vt3 trim3 0 dc 1.2
X1 vdd trim0 trim1 trim2 trim3 osc_clk vdd 0 g1_osc
Cload osc_clk 0 50f
.control
set filetype=ascii
tran 0.2n 4u
meas tran tfirst when v(osc_clk)=0.6 rise=1
meas tran tvdd when v(vdd)=1.08 rise=1
meas tran t1 when v(osc_clk)=0.6 rise=15
meas tran t2 when v(osc_clk)=0.6 rise=25
let fmhz = 10e-6/(t2-t1)
let tus = tfirst*1e6
let tvu = tvdd*1e6
echo "STARTUP first_edge_us=" $&tus " vdd_at_1.08V_us=" $&tvu " f_MHz_end=" $&fmhz
.endc
.end
