* G1_OSC testbench: frequency, duty cycle, supply current at one corner/temperature/supply/trim code
* @@ fields are substituted by run_osc.sh (variants written to build/g1_osc/).
.param VDD=1.08
.lib /foss/pdks/ihp-sg13g2/libs.tech/ngspice/models/cornerMOSlv.lib mos_ss_mismatch
.lib /foss/pdks/ihp-sg13g2/libs.tech/ngspice/models/cornerRES.lib res_wcs_mismatch
.lib /foss/pdks/ihp-sg13g2/libs.tech/ngspice/models/cornerCAP.lib cap_wcs_mismatch
.lib /foss/pdks/ihp-sg13g2/libs.tech/ngspice/models/cornerDIO.lib dio_tt
* (dio_tt: the antenna diode dantenna on vth, revision 5; the diode library has one corner set)
.temp 125
* rshunt: 1 TOhm from every node to ground; without it the operating point with the antenna diode
* (revision 5) does not converge and the transient crawls (the rppd body node sub! is floating)
.option seed=62001 rshunt=1e12
.include mismatch.spice
.include stdcells.spice
.include clock_load.spice
Vdd vdd 0 dc {VDD}
Ven en 0 PWL(0 0 0.05u 0 0.051u 1.08)
Vt0 trim0 0 dc {VDD*0}
Vt1 trim1 0 dc {VDD*0}
Vt2 trim2 0 dc {VDD*0}
Vt3 trim3 0 dc {VDD*0}
X1 en trim0 trim1 trim2 trim3 osc_clk vdd 0 g1_osc
* Replaced50fFstand-in withreceiver/SPEF network
Vddclk vddclk 0 dc {VDD}
.control
set num_threads=1
set numdgt=15
set wr_singlescale
set wr_vecnames
save v(osc_clk) v(sp__11993_A) v(sp__11993_X) v(en) i(vdd) i(vddclk) v(leaf0) v(leaf1) v(leaf2) v(leaf3) v(leaf4) v(leaf5) v(leaf6) v(leaf7) v(leaf8) v(leaf9) v(leaf10) v(leaf11) v(leaf12) v(leaf13) v(leaf14) v(leaf15)
op
echo OSC_FP_BEFORE_BEGIN
print @n.x1.xm1.nsg13_lv_nmos[w]
print @n.x1.xm1.nsg13_lv_nmos[l]
print @n.x1.xm1.nsg13_lv_nmos[delvto]
print @n.x1.xm1.nsg13_lv_nmos[factuo]
print @n.x1.xm2.nsg13_lv_nmos[w]
print @n.x1.xm2.nsg13_lv_nmos[l]
print @n.x1.xm2.nsg13_lv_nmos[delvto]
print @n.x1.xm2.nsg13_lv_nmos[factuo]
print @n.x1.xm3.nsg13_lv_nmos[w]
print @n.x1.xm3.nsg13_lv_nmos[l]
print @n.x1.xm3.nsg13_lv_nmos[delvto]
print @n.x1.xm3.nsg13_lv_nmos[factuo]
print @n.x1.xm4.nsg13_lv_nmos[w]
print @n.x1.xm4.nsg13_lv_nmos[l]
print @n.x1.xm4.nsg13_lv_nmos[delvto]
print @n.x1.xm4.nsg13_lv_nmos[factuo]
print @n.x1.xm5.nsg13_lv_nmos[w]
print @n.x1.xm5.nsg13_lv_nmos[l]
print @n.x1.xm5.nsg13_lv_nmos[delvto]
print @n.x1.xm5.nsg13_lv_nmos[factuo]
print @n.x1.xm6.nsg13_lv_nmos[w]
print @n.x1.xm6.nsg13_lv_nmos[l]
print @n.x1.xm6.nsg13_lv_nmos[delvto]
print @n.x1.xm6.nsg13_lv_nmos[factuo]
print @n.x1.xm7.nsg13_lv_nmos[w]
print @n.x1.xm7.nsg13_lv_nmos[l]
print @n.x1.xm7.nsg13_lv_nmos[delvto]
print @n.x1.xm7.nsg13_lv_nmos[factuo]
print @n.x1.xm8.nsg13_lv_nmos[w]
print @n.x1.xm8.nsg13_lv_nmos[l]
print @n.x1.xm8.nsg13_lv_nmos[delvto]
print @n.x1.xm8.nsg13_lv_nmos[factuo]
print @n.x1.xm9.nsg13_lv_nmos[w]
print @n.x1.xm9.nsg13_lv_nmos[l]
print @n.x1.xm9.nsg13_lv_nmos[delvto]
print @n.x1.xm9.nsg13_lv_nmos[factuo]
print @n.x1.xm10.nsg13_lv_nmos[w]
print @n.x1.xm10.nsg13_lv_nmos[l]
print @n.x1.xm10.nsg13_lv_nmos[delvto]
print @n.x1.xm10.nsg13_lv_nmos[factuo]
print @n.x1.xm11.nsg13_lv_nmos[w]
print @n.x1.xm11.nsg13_lv_nmos[l]
print @n.x1.xm11.nsg13_lv_nmos[delvto]
print @n.x1.xm11.nsg13_lv_nmos[factuo]
print @n.x1.xm12.nsg13_lv_nmos[w]
print @n.x1.xm12.nsg13_lv_nmos[l]
print @n.x1.xm12.nsg13_lv_nmos[delvto]
print @n.x1.xm12.nsg13_lv_nmos[factuo]
print @n.x1.xm13.nsg13_lv_nmos[w]
print @n.x1.xm13.nsg13_lv_nmos[l]
print @n.x1.xm13.nsg13_lv_nmos[delvto]
print @n.x1.xm13.nsg13_lv_nmos[factuo]
print @n.x1.xm14.nsg13_lv_nmos[w]
print @n.x1.xm14.nsg13_lv_nmos[l]
print @n.x1.xm14.nsg13_lv_nmos[delvto]
print @n.x1.xm14.nsg13_lv_nmos[factuo]
print @n.x1.xm15.nsg13_lv_nmos[w]
print @n.x1.xm15.nsg13_lv_nmos[l]
print @n.x1.xm15.nsg13_lv_nmos[delvto]
print @n.x1.xm15.nsg13_lv_nmos[factuo]
print @n.x1.xm16.nsg13_lv_nmos[w]
print @n.x1.xm16.nsg13_lv_nmos[l]
print @n.x1.xm16.nsg13_lv_nmos[delvto]
print @n.x1.xm16.nsg13_lv_nmos[factuo]
print @n.x1.xm17.nsg13_lv_nmos[w]
print @n.x1.xm17.nsg13_lv_nmos[l]
print @n.x1.xm17.nsg13_lv_nmos[delvto]
print @n.x1.xm17.nsg13_lv_nmos[factuo]
print @n.x1.xm18.nsg13_lv_nmos[w]
print @n.x1.xm18.nsg13_lv_nmos[l]
print @n.x1.xm18.nsg13_lv_nmos[delvto]
print @n.x1.xm18.nsg13_lv_nmos[factuo]
print @n.x1.xm19.nsg13_lv_nmos[w]
print @n.x1.xm19.nsg13_lv_nmos[l]
print @n.x1.xm19.nsg13_lv_nmos[delvto]
print @n.x1.xm19.nsg13_lv_nmos[factuo]
print @n.x1.xm20.nsg13_lv_nmos[w]
print @n.x1.xm20.nsg13_lv_nmos[l]
print @n.x1.xm20.nsg13_lv_nmos[delvto]
print @n.x1.xm20.nsg13_lv_nmos[factuo]
print @n.x1.xm21.nsg13_lv_nmos[w]
print @n.x1.xm21.nsg13_lv_nmos[l]
print @n.x1.xm21.nsg13_lv_nmos[delvto]
print @n.x1.xm21.nsg13_lv_nmos[factuo]
print @n.x1.xm22.nsg13_lv_nmos[w]
print @n.x1.xm22.nsg13_lv_nmos[l]
print @n.x1.xm22.nsg13_lv_nmos[delvto]
print @n.x1.xm22.nsg13_lv_nmos[factuo]
print @n.x1.xm23.nsg13_lv_nmos[w]
print @n.x1.xm23.nsg13_lv_nmos[l]
print @n.x1.xm23.nsg13_lv_nmos[delvto]
print @n.x1.xm23.nsg13_lv_nmos[factuo]
print @n.x1.xm24.nsg13_lv_nmos[w]
print @n.x1.xm24.nsg13_lv_nmos[l]
print @n.x1.xm24.nsg13_lv_nmos[delvto]
print @n.x1.xm24.nsg13_lv_nmos[factuo]
print @n.x1.xm25.nsg13_lv_nmos[w]
print @n.x1.xm25.nsg13_lv_nmos[l]
print @n.x1.xm25.nsg13_lv_nmos[delvto]
print @n.x1.xm25.nsg13_lv_nmos[factuo]
print @n.x1.xm26.nsg13_lv_nmos[w]
print @n.x1.xm26.nsg13_lv_nmos[l]
print @n.x1.xm26.nsg13_lv_nmos[delvto]
print @n.x1.xm26.nsg13_lv_nmos[factuo]
print @n.x1.xm27.nsg13_lv_nmos[w]
print @n.x1.xm27.nsg13_lv_nmos[l]
print @n.x1.xm27.nsg13_lv_nmos[delvto]
print @n.x1.xm27.nsg13_lv_nmos[factuo]
print @n.x1.xm28.nsg13_lv_nmos[w]
print @n.x1.xm28.nsg13_lv_nmos[l]
print @n.x1.xm28.nsg13_lv_nmos[delvto]
print @n.x1.xm28.nsg13_lv_nmos[factuo]
print @n.x1.xm29.nsg13_lv_nmos[w]
print @n.x1.xm29.nsg13_lv_nmos[l]
print @n.x1.xm29.nsg13_lv_nmos[delvto]
print @n.x1.xm29.nsg13_lv_nmos[factuo]
print @n.x1.xm30.nsg13_lv_nmos[w]
print @n.x1.xm30.nsg13_lv_nmos[l]
print @n.x1.xm30.nsg13_lv_nmos[delvto]
print @n.x1.xm30.nsg13_lv_nmos[factuo]
print @n.x1.xm31.nsg13_lv_nmos[w]
print @n.x1.xm31.nsg13_lv_nmos[l]
print @n.x1.xm31.nsg13_lv_nmos[delvto]
print @n.x1.xm31.nsg13_lv_nmos[factuo]
print @n.x1.xm32.nsg13_lv_nmos[w]
print @n.x1.xm32.nsg13_lv_nmos[l]
print @n.x1.xm32.nsg13_lv_nmos[delvto]
print @n.x1.xm32.nsg13_lv_nmos[factuo]
print @n.x1.xm33.nsg13_lv_pmos[w]
print @n.x1.xm33.nsg13_lv_pmos[l]
print @n.x1.xm33.nsg13_lv_pmos[delvto]
print @n.x1.xm33.nsg13_lv_pmos[factuo]
print @n.x1.xm34.nsg13_lv_pmos[w]
print @n.x1.xm34.nsg13_lv_pmos[l]
print @n.x1.xm34.nsg13_lv_pmos[delvto]
print @n.x1.xm34.nsg13_lv_pmos[factuo]
print @n.x1.xm35.nsg13_lv_pmos[w]
print @n.x1.xm35.nsg13_lv_pmos[l]
print @n.x1.xm35.nsg13_lv_pmos[delvto]
print @n.x1.xm35.nsg13_lv_pmos[factuo]
print @n.x1.xm36.nsg13_lv_pmos[w]
print @n.x1.xm36.nsg13_lv_pmos[l]
print @n.x1.xm36.nsg13_lv_pmos[delvto]
print @n.x1.xm36.nsg13_lv_pmos[factuo]
print @n.x1.xm37.nsg13_lv_pmos[w]
print @n.x1.xm37.nsg13_lv_pmos[l]
print @n.x1.xm37.nsg13_lv_pmos[delvto]
print @n.x1.xm37.nsg13_lv_pmos[factuo]
print @n.x1.xm38.nsg13_lv_pmos[w]
print @n.x1.xm38.nsg13_lv_pmos[l]
print @n.x1.xm38.nsg13_lv_pmos[delvto]
print @n.x1.xm38.nsg13_lv_pmos[factuo]
print @n.x1.xm39.nsg13_lv_pmos[w]
print @n.x1.xm39.nsg13_lv_pmos[l]
print @n.x1.xm39.nsg13_lv_pmos[delvto]
print @n.x1.xm39.nsg13_lv_pmos[factuo]
print @n.x1.xm40.nsg13_lv_pmos[w]
print @n.x1.xm40.nsg13_lv_pmos[l]
print @n.x1.xm40.nsg13_lv_pmos[delvto]
print @n.x1.xm40.nsg13_lv_pmos[factuo]
print @n.x1.xm41.nsg13_lv_pmos[w]
print @n.x1.xm41.nsg13_lv_pmos[l]
print @n.x1.xm41.nsg13_lv_pmos[delvto]
print @n.x1.xm41.nsg13_lv_pmos[factuo]
print @n.x1.xm42.nsg13_lv_pmos[w]
print @n.x1.xm42.nsg13_lv_pmos[l]
print @n.x1.xm42.nsg13_lv_pmos[delvto]
print @n.x1.xm42.nsg13_lv_pmos[factuo]
print @n.x1.xm43.nsg13_lv_pmos[w]
print @n.x1.xm43.nsg13_lv_pmos[l]
print @n.x1.xm43.nsg13_lv_pmos[delvto]
print @n.x1.xm43.nsg13_lv_pmos[factuo]
print @n.x1.xm44.nsg13_lv_pmos[w]
print @n.x1.xm44.nsg13_lv_pmos[l]
print @n.x1.xm44.nsg13_lv_pmos[delvto]
print @n.x1.xm44.nsg13_lv_pmos[factuo]
print @n.x1.xm45.nsg13_lv_pmos[w]
print @n.x1.xm45.nsg13_lv_pmos[l]
print @n.x1.xm45.nsg13_lv_pmos[delvto]
print @n.x1.xm45.nsg13_lv_pmos[factuo]
print @n.x1.xm46.nsg13_lv_pmos[w]
print @n.x1.xm46.nsg13_lv_pmos[l]
print @n.x1.xm46.nsg13_lv_pmos[delvto]
print @n.x1.xm46.nsg13_lv_pmos[factuo]
print @n.x1.xm47.nsg13_lv_pmos[w]
print @n.x1.xm47.nsg13_lv_pmos[l]
print @n.x1.xm47.nsg13_lv_pmos[delvto]
print @n.x1.xm47.nsg13_lv_pmos[factuo]
print @n.x1.xm48.nsg13_lv_pmos[w]
print @n.x1.xm48.nsg13_lv_pmos[l]
print @n.x1.xm48.nsg13_lv_pmos[delvto]
print @n.x1.xm48.nsg13_lv_pmos[factuo]
print @n.x1.xm49.nsg13_lv_pmos[w]
print @n.x1.xm49.nsg13_lv_pmos[l]
print @n.x1.xm49.nsg13_lv_pmos[delvto]
print @n.x1.xm49.nsg13_lv_pmos[factuo]
print @n.x1.xm50.nsg13_lv_pmos[w]
print @n.x1.xm50.nsg13_lv_pmos[l]
print @n.x1.xm50.nsg13_lv_pmos[delvto]
print @n.x1.xm50.nsg13_lv_pmos[factuo]
print @n.x1.xm51.nsg13_lv_pmos[w]
print @n.x1.xm51.nsg13_lv_pmos[l]
print @n.x1.xm51.nsg13_lv_pmos[delvto]
print @n.x1.xm51.nsg13_lv_pmos[factuo]
print @n.x1.xr53.nr1[nsmm_rsh]
print @n.x1.xr53.nr1[nsmm_w]
print @n.x1.xr53.nr1[nsmm_l]
print @n.x1.xr54.nr1[nsmm_rsh]
print @n.x1.xr54.nr1[nsmm_w]
print @n.x1.xr54.nr1[nsmm_l]
print @n.x1.xr55.nr1[nsmm_rsh]
print @n.x1.xr55.nr1[nsmm_w]
print @n.x1.xr55.nr1[nsmm_l]
print @n.x1.xr56.nr1[nsmm_rsh]
print @n.x1.xr56.nr1[nsmm_w]
print @n.x1.xr56.nr1[nsmm_l]
print @n.x1.xr57.nr1[nsmm_rsh]
print @n.x1.xr57.nr1[nsmm_w]
print @n.x1.xr57.nr1[nsmm_l]
print @n.x1.xr58.nr1[nsmm_rsh]
print @n.x1.xr58.nr1[nsmm_w]
print @n.x1.xr58.nr1[nsmm_l]
print @n.x1.xr59.nr1[nsmm_rsh]
print @n.x1.xr59.nr1[nsmm_w]
print @n.x1.xr59.nr1[nsmm_l]
print @n.x1.xr60.nr1[nsmm_rsh]
print @n.x1.xr60.nr1[nsmm_w]
print @n.x1.xr60.nr1[nsmm_l]
print @n.x1.xr61.nr1[nsmm_rsh]
print @n.x1.xr61.nr1[nsmm_w]
print @n.x1.xr61.nr1[nsmm_l]
print @n.x1.xr62.nr1[nsmm_rsh]
print @n.x1.xr62.nr1[nsmm_w]
print @n.x1.xr62.nr1[nsmm_l]
print @n.x1.xr63.nr1[nsmm_rsh]
print @n.x1.xr63.nr1[nsmm_w]
print @n.x1.xr63.nr1[nsmm_l]
print @n.x1.xr64.nr1[nsmm_rsh]
print @n.x1.xr64.nr1[nsmm_w]
print @n.x1.xr64.nr1[nsmm_l]
print @n.x1.xr65.nr1[nsmm_rsh]
print @n.x1.xr65.nr1[nsmm_w]
print @n.x1.xr65.nr1[nsmm_l]
print @n.x1.xr66.nr1[nsmm_rsh]
print @n.x1.xr66.nr1[nsmm_w]
print @n.x1.xr66.nr1[nsmm_l]
print @n.x1.xr67.nr1[nsmm_rsh]
print @n.x1.xr67.nr1[nsmm_w]
print @n.x1.xr67.nr1[nsmm_l]
print @n.x1.xr68.nr1[nsmm_rsh]
print @n.x1.xr68.nr1[nsmm_w]
print @n.x1.xr68.nr1[nsmm_l]
print @n.x1.xr69.nr1[nsmm_rsh]
print @n.x1.xr69.nr1[nsmm_w]
print @n.x1.xr69.nr1[nsmm_l]
print @n.x1.xr70.nr1[nsmm_rsh]
print @n.x1.xr70.nr1[nsmm_w]
print @n.x1.xr70.nr1[nsmm_l]
print @c.x1.xcf_a.c1[scale]
print @c.x1.xct0_a.c1[scale]
print @c.x1.xct1_a.c1[scale]
print @c.x1.xct2_a.c1[scale]
print @c.x1.xct3_a.c1[scale]
print @c.x1.xcf_b.c1[scale]
print @c.x1.xct0_b.c1[scale]
print @c.x1.xct1_b.c1[scale]
print @c.x1.xct2_b.c1[scale]
print @c.x1.xct3_b.c1[scale]
print @c.x1.xcth.c1[scale]
echo OSC_FP_BEFORE_END
echo CLOCK_FP_BEFORE_BEGIN
print @n.xroot.xn0.nsg13_lv_nmos[delvto]
print @n.xroot.xn0.nsg13_lv_nmos[factuo]
print @n.xroot.xn1.nsg13_lv_nmos[delvto]
print @n.xroot.xn1.nsg13_lv_nmos[factuo]
print @n.xroot.xp1.nsg13_lv_pmos[delvto]
print @n.xroot.xp1.nsg13_lv_pmos[factuo]
print @n.xroot.xp0.nsg13_lv_pmos[delvto]
print @n.xroot.xp0.nsg13_lv_pmos[factuo]
print @n.xleaf0.xn0.nsg13_lv_nmos[delvto]
print @n.xleaf0.xn0.nsg13_lv_nmos[factuo]
print @n.xleaf0.xn1.nsg13_lv_nmos[delvto]
print @n.xleaf0.xn1.nsg13_lv_nmos[factuo]
print @n.xleaf0.xp1.nsg13_lv_pmos[delvto]
print @n.xleaf0.xp1.nsg13_lv_pmos[factuo]
print @n.xleaf0.xp0.nsg13_lv_pmos[delvto]
print @n.xleaf0.xp0.nsg13_lv_pmos[factuo]
print @n.xleaf1.xn0.nsg13_lv_nmos[delvto]
print @n.xleaf1.xn0.nsg13_lv_nmos[factuo]
print @n.xleaf1.xn1.nsg13_lv_nmos[delvto]
print @n.xleaf1.xn1.nsg13_lv_nmos[factuo]
print @n.xleaf1.xp1.nsg13_lv_pmos[delvto]
print @n.xleaf1.xp1.nsg13_lv_pmos[factuo]
print @n.xleaf1.xp0.nsg13_lv_pmos[delvto]
print @n.xleaf1.xp0.nsg13_lv_pmos[factuo]
print @n.xleaf2.xn0.nsg13_lv_nmos[delvto]
print @n.xleaf2.xn0.nsg13_lv_nmos[factuo]
print @n.xleaf2.xn1.nsg13_lv_nmos[delvto]
print @n.xleaf2.xn1.nsg13_lv_nmos[factuo]
print @n.xleaf2.xp1.nsg13_lv_pmos[delvto]
print @n.xleaf2.xp1.nsg13_lv_pmos[factuo]
print @n.xleaf2.xp0.nsg13_lv_pmos[delvto]
print @n.xleaf2.xp0.nsg13_lv_pmos[factuo]
print @n.xleaf3.xn0.nsg13_lv_nmos[delvto]
print @n.xleaf3.xn0.nsg13_lv_nmos[factuo]
print @n.xleaf3.xn1.nsg13_lv_nmos[delvto]
print @n.xleaf3.xn1.nsg13_lv_nmos[factuo]
print @n.xleaf3.xp1.nsg13_lv_pmos[delvto]
print @n.xleaf3.xp1.nsg13_lv_pmos[factuo]
print @n.xleaf3.xp0.nsg13_lv_pmos[delvto]
print @n.xleaf3.xp0.nsg13_lv_pmos[factuo]
print @n.xleaf4.xn0.nsg13_lv_nmos[delvto]
print @n.xleaf4.xn0.nsg13_lv_nmos[factuo]
print @n.xleaf4.xn1.nsg13_lv_nmos[delvto]
print @n.xleaf4.xn1.nsg13_lv_nmos[factuo]
print @n.xleaf4.xp1.nsg13_lv_pmos[delvto]
print @n.xleaf4.xp1.nsg13_lv_pmos[factuo]
print @n.xleaf4.xp0.nsg13_lv_pmos[delvto]
print @n.xleaf4.xp0.nsg13_lv_pmos[factuo]
print @n.xleaf5.xn0.nsg13_lv_nmos[delvto]
print @n.xleaf5.xn0.nsg13_lv_nmos[factuo]
print @n.xleaf5.xn1.nsg13_lv_nmos[delvto]
print @n.xleaf5.xn1.nsg13_lv_nmos[factuo]
print @n.xleaf5.xp1.nsg13_lv_pmos[delvto]
print @n.xleaf5.xp1.nsg13_lv_pmos[factuo]
print @n.xleaf5.xp0.nsg13_lv_pmos[delvto]
print @n.xleaf5.xp0.nsg13_lv_pmos[factuo]
print @n.xleaf6.xn0.nsg13_lv_nmos[delvto]
print @n.xleaf6.xn0.nsg13_lv_nmos[factuo]
print @n.xleaf6.xn1.nsg13_lv_nmos[delvto]
print @n.xleaf6.xn1.nsg13_lv_nmos[factuo]
print @n.xleaf6.xp1.nsg13_lv_pmos[delvto]
print @n.xleaf6.xp1.nsg13_lv_pmos[factuo]
print @n.xleaf6.xp0.nsg13_lv_pmos[delvto]
print @n.xleaf6.xp0.nsg13_lv_pmos[factuo]
print @n.xleaf7.xn0.nsg13_lv_nmos[delvto]
print @n.xleaf7.xn0.nsg13_lv_nmos[factuo]
print @n.xleaf7.xn1.nsg13_lv_nmos[delvto]
print @n.xleaf7.xn1.nsg13_lv_nmos[factuo]
print @n.xleaf7.xp1.nsg13_lv_pmos[delvto]
print @n.xleaf7.xp1.nsg13_lv_pmos[factuo]
print @n.xleaf7.xp0.nsg13_lv_pmos[delvto]
print @n.xleaf7.xp0.nsg13_lv_pmos[factuo]
print @n.xleaf8.xn0.nsg13_lv_nmos[delvto]
print @n.xleaf8.xn0.nsg13_lv_nmos[factuo]
print @n.xleaf8.xn1.nsg13_lv_nmos[delvto]
print @n.xleaf8.xn1.nsg13_lv_nmos[factuo]
print @n.xleaf8.xp1.nsg13_lv_pmos[delvto]
print @n.xleaf8.xp1.nsg13_lv_pmos[factuo]
print @n.xleaf8.xp0.nsg13_lv_pmos[delvto]
print @n.xleaf8.xp0.nsg13_lv_pmos[factuo]
print @n.xleaf9.xn0.nsg13_lv_nmos[delvto]
print @n.xleaf9.xn0.nsg13_lv_nmos[factuo]
print @n.xleaf9.xn1.nsg13_lv_nmos[delvto]
print @n.xleaf9.xn1.nsg13_lv_nmos[factuo]
print @n.xleaf9.xp1.nsg13_lv_pmos[delvto]
print @n.xleaf9.xp1.nsg13_lv_pmos[factuo]
print @n.xleaf9.xp0.nsg13_lv_pmos[delvto]
print @n.xleaf9.xp0.nsg13_lv_pmos[factuo]
print @n.xleaf10.xn0.nsg13_lv_nmos[delvto]
print @n.xleaf10.xn0.nsg13_lv_nmos[factuo]
print @n.xleaf10.xn1.nsg13_lv_nmos[delvto]
print @n.xleaf10.xn1.nsg13_lv_nmos[factuo]
print @n.xleaf10.xp1.nsg13_lv_pmos[delvto]
print @n.xleaf10.xp1.nsg13_lv_pmos[factuo]
print @n.xleaf10.xp0.nsg13_lv_pmos[delvto]
print @n.xleaf10.xp0.nsg13_lv_pmos[factuo]
print @n.xleaf11.xn0.nsg13_lv_nmos[delvto]
print @n.xleaf11.xn0.nsg13_lv_nmos[factuo]
print @n.xleaf11.xn1.nsg13_lv_nmos[delvto]
print @n.xleaf11.xn1.nsg13_lv_nmos[factuo]
print @n.xleaf11.xp1.nsg13_lv_pmos[delvto]
print @n.xleaf11.xp1.nsg13_lv_pmos[factuo]
print @n.xleaf11.xp0.nsg13_lv_pmos[delvto]
print @n.xleaf11.xp0.nsg13_lv_pmos[factuo]
print @n.xleaf12.xn0.nsg13_lv_nmos[delvto]
print @n.xleaf12.xn0.nsg13_lv_nmos[factuo]
print @n.xleaf12.xn1.nsg13_lv_nmos[delvto]
print @n.xleaf12.xn1.nsg13_lv_nmos[factuo]
print @n.xleaf12.xp1.nsg13_lv_pmos[delvto]
print @n.xleaf12.xp1.nsg13_lv_pmos[factuo]
print @n.xleaf12.xp0.nsg13_lv_pmos[delvto]
print @n.xleaf12.xp0.nsg13_lv_pmos[factuo]
print @n.xleaf13.xn0.nsg13_lv_nmos[delvto]
print @n.xleaf13.xn0.nsg13_lv_nmos[factuo]
print @n.xleaf13.xn1.nsg13_lv_nmos[delvto]
print @n.xleaf13.xn1.nsg13_lv_nmos[factuo]
print @n.xleaf13.xp1.nsg13_lv_pmos[delvto]
print @n.xleaf13.xp1.nsg13_lv_pmos[factuo]
print @n.xleaf13.xp0.nsg13_lv_pmos[delvto]
print @n.xleaf13.xp0.nsg13_lv_pmos[factuo]
print @n.xleaf14.xn0.nsg13_lv_nmos[delvto]
print @n.xleaf14.xn0.nsg13_lv_nmos[factuo]
print @n.xleaf14.xn1.nsg13_lv_nmos[delvto]
print @n.xleaf14.xn1.nsg13_lv_nmos[factuo]
print @n.xleaf14.xp1.nsg13_lv_pmos[delvto]
print @n.xleaf14.xp1.nsg13_lv_pmos[factuo]
print @n.xleaf14.xp0.nsg13_lv_pmos[delvto]
print @n.xleaf14.xp0.nsg13_lv_pmos[factuo]
print @n.xleaf15.xn0.nsg13_lv_nmos[delvto]
print @n.xleaf15.xn0.nsg13_lv_nmos[factuo]
print @n.xleaf15.xn1.nsg13_lv_nmos[delvto]
print @n.xleaf15.xn1.nsg13_lv_nmos[factuo]
print @n.xleaf15.xp1.nsg13_lv_pmos[delvto]
print @n.xleaf15.xp1.nsg13_lv_pmos[factuo]
print @n.xleaf15.xp0.nsg13_lv_pmos[delvto]
print @n.xleaf15.xp0.nsg13_lv_pmos[factuo]
print @n.xtree_12021.xn0.nsg13_lv_nmos[delvto]
print @n.xtree_12021.xn0.nsg13_lv_nmos[factuo]
print @n.xtree_12021.xn1.nsg13_lv_nmos[delvto]
print @n.xtree_12021.xn1.nsg13_lv_nmos[factuo]
print @n.xtree_12021.xp1.nsg13_lv_pmos[delvto]
print @n.xtree_12021.xp1.nsg13_lv_pmos[factuo]
print @n.xtree_12021.xp0.nsg13_lv_pmos[delvto]
print @n.xtree_12021.xp0.nsg13_lv_pmos[factuo]
print @n.xtree_12022.xn0.nsg13_lv_nmos[delvto]
print @n.xtree_12022.xn0.nsg13_lv_nmos[factuo]
print @n.xtree_12022.xn1.nsg13_lv_nmos[delvto]
print @n.xtree_12022.xn1.nsg13_lv_nmos[factuo]
print @n.xtree_12022.xp1.nsg13_lv_pmos[delvto]
print @n.xtree_12022.xp1.nsg13_lv_pmos[factuo]
print @n.xtree_12022.xp0.nsg13_lv_pmos[delvto]
print @n.xtree_12022.xp0.nsg13_lv_pmos[factuo]
print @n.xtree_12023.xn0.nsg13_lv_nmos[delvto]
print @n.xtree_12023.xn0.nsg13_lv_nmos[factuo]
print @n.xtree_12023.xn1.nsg13_lv_nmos[delvto]
print @n.xtree_12023.xn1.nsg13_lv_nmos[factuo]
print @n.xtree_12023.xp1.nsg13_lv_pmos[delvto]
print @n.xtree_12023.xp1.nsg13_lv_pmos[factuo]
print @n.xtree_12023.xp0.nsg13_lv_pmos[delvto]
print @n.xtree_12023.xp0.nsg13_lv_pmos[factuo]
print @n.xtree_12024.xn0.nsg13_lv_nmos[delvto]
print @n.xtree_12024.xn0.nsg13_lv_nmos[factuo]
print @n.xtree_12024.xn1.nsg13_lv_nmos[delvto]
print @n.xtree_12024.xn1.nsg13_lv_nmos[factuo]
print @n.xtree_12024.xp1.nsg13_lv_pmos[delvto]
print @n.xtree_12024.xp1.nsg13_lv_pmos[factuo]
print @n.xtree_12024.xp0.nsg13_lv_pmos[delvto]
print @n.xtree_12024.xp0.nsg13_lv_pmos[factuo]
print @n.xtree_12025.xn0.nsg13_lv_nmos[delvto]
print @n.xtree_12025.xn0.nsg13_lv_nmos[factuo]
print @n.xtree_12025.xn1.nsg13_lv_nmos[delvto]
print @n.xtree_12025.xn1.nsg13_lv_nmos[factuo]
print @n.xtree_12025.xp1.nsg13_lv_pmos[delvto]
print @n.xtree_12025.xp1.nsg13_lv_pmos[factuo]
print @n.xtree_12025.xp0.nsg13_lv_pmos[delvto]
print @n.xtree_12025.xp0.nsg13_lv_pmos[factuo]
print @n.xtree_12026.xn0.nsg13_lv_nmos[delvto]
print @n.xtree_12026.xn0.nsg13_lv_nmos[factuo]
print @n.xtree_12026.xn1.nsg13_lv_nmos[delvto]
print @n.xtree_12026.xn1.nsg13_lv_nmos[factuo]
print @n.xtree_12026.xp1.nsg13_lv_pmos[delvto]
print @n.xtree_12026.xp1.nsg13_lv_pmos[factuo]
print @n.xtree_12026.xp0.nsg13_lv_pmos[delvto]
print @n.xtree_12026.xp0.nsg13_lv_pmos[factuo]
print @n.xtree_12027.xn0.nsg13_lv_nmos[delvto]
print @n.xtree_12027.xn0.nsg13_lv_nmos[factuo]
print @n.xtree_12027.xn1.nsg13_lv_nmos[delvto]
print @n.xtree_12027.xn1.nsg13_lv_nmos[factuo]
print @n.xtree_12027.xp1.nsg13_lv_pmos[delvto]
print @n.xtree_12027.xp1.nsg13_lv_pmos[factuo]
print @n.xtree_12027.xp0.nsg13_lv_pmos[delvto]
print @n.xtree_12027.xp0.nsg13_lv_pmos[factuo]
print @n.xtree_12028.xn0.nsg13_lv_nmos[delvto]
print @n.xtree_12028.xn0.nsg13_lv_nmos[factuo]
print @n.xtree_12028.xn1.nsg13_lv_nmos[delvto]
print @n.xtree_12028.xn1.nsg13_lv_nmos[factuo]
print @n.xtree_12028.xp1.nsg13_lv_pmos[delvto]
print @n.xtree_12028.xp1.nsg13_lv_pmos[factuo]
print @n.xtree_12028.xp0.nsg13_lv_pmos[delvto]
print @n.xtree_12028.xp0.nsg13_lv_pmos[factuo]
print @n.xtree_12029.xn0.nsg13_lv_nmos[delvto]
print @n.xtree_12029.xn0.nsg13_lv_nmos[factuo]
print @n.xtree_12029.xn1.nsg13_lv_nmos[delvto]
print @n.xtree_12029.xn1.nsg13_lv_nmos[factuo]
print @n.xtree_12029.xp1.nsg13_lv_pmos[delvto]
print @n.xtree_12029.xp1.nsg13_lv_pmos[factuo]
print @n.xtree_12029.xp0.nsg13_lv_pmos[delvto]
print @n.xtree_12029.xp0.nsg13_lv_pmos[factuo]
print @n.xtree_12030.xn0.nsg13_lv_nmos[delvto]
print @n.xtree_12030.xn0.nsg13_lv_nmos[factuo]
print @n.xtree_12030.xn1.nsg13_lv_nmos[delvto]
print @n.xtree_12030.xn1.nsg13_lv_nmos[factuo]
print @n.xtree_12030.xp1.nsg13_lv_pmos[delvto]
print @n.xtree_12030.xp1.nsg13_lv_pmos[factuo]
print @n.xtree_12030.xp0.nsg13_lv_pmos[delvto]
print @n.xtree_12030.xp0.nsg13_lv_pmos[factuo]
print @n.xtree_12031.xn0.nsg13_lv_nmos[delvto]
print @n.xtree_12031.xn0.nsg13_lv_nmos[factuo]
print @n.xtree_12031.xn1.nsg13_lv_nmos[delvto]
print @n.xtree_12031.xn1.nsg13_lv_nmos[factuo]
print @n.xtree_12031.xp1.nsg13_lv_pmos[delvto]
print @n.xtree_12031.xp1.nsg13_lv_pmos[factuo]
print @n.xtree_12031.xp0.nsg13_lv_pmos[delvto]
print @n.xtree_12031.xp0.nsg13_lv_pmos[factuo]
print @n.xtree_12032.xn0.nsg13_lv_nmos[delvto]
print @n.xtree_12032.xn0.nsg13_lv_nmos[factuo]
print @n.xtree_12032.xn1.nsg13_lv_nmos[delvto]
print @n.xtree_12032.xn1.nsg13_lv_nmos[factuo]
print @n.xtree_12032.xp1.nsg13_lv_pmos[delvto]
print @n.xtree_12032.xp1.nsg13_lv_pmos[factuo]
print @n.xtree_12032.xp0.nsg13_lv_pmos[delvto]
print @n.xtree_12032.xp0.nsg13_lv_pmos[factuo]
print @n.xtree_12033.xn0.nsg13_lv_nmos[delvto]
print @n.xtree_12033.xn0.nsg13_lv_nmos[factuo]
print @n.xtree_12033.xn1.nsg13_lv_nmos[delvto]
print @n.xtree_12033.xn1.nsg13_lv_nmos[factuo]
print @n.xtree_12033.xp1.nsg13_lv_pmos[delvto]
print @n.xtree_12033.xp1.nsg13_lv_pmos[factuo]
print @n.xtree_12033.xp0.nsg13_lv_pmos[delvto]
print @n.xtree_12033.xp0.nsg13_lv_pmos[factuo]
print @n.xtree_12034.xn0.nsg13_lv_nmos[delvto]
print @n.xtree_12034.xn0.nsg13_lv_nmos[factuo]
print @n.xtree_12034.xn1.nsg13_lv_nmos[delvto]
print @n.xtree_12034.xn1.nsg13_lv_nmos[factuo]
print @n.xtree_12034.xp1.nsg13_lv_pmos[delvto]
print @n.xtree_12034.xp1.nsg13_lv_pmos[factuo]
print @n.xtree_12034.xp0.nsg13_lv_pmos[delvto]
print @n.xtree_12034.xp0.nsg13_lv_pmos[factuo]
print @n.xtree_12035.xn0.nsg13_lv_nmos[delvto]
print @n.xtree_12035.xn0.nsg13_lv_nmos[factuo]
print @n.xtree_12035.xn1.nsg13_lv_nmos[delvto]
print @n.xtree_12035.xn1.nsg13_lv_nmos[factuo]
print @n.xtree_12035.xp1.nsg13_lv_pmos[delvto]
print @n.xtree_12035.xp1.nsg13_lv_pmos[factuo]
print @n.xtree_12035.xp0.nsg13_lv_pmos[delvto]
print @n.xtree_12035.xp0.nsg13_lv_pmos[factuo]
print @n.xtree_12036.xn0.nsg13_lv_nmos[delvto]
print @n.xtree_12036.xn0.nsg13_lv_nmos[factuo]
print @n.xtree_12036.xn1.nsg13_lv_nmos[delvto]
print @n.xtree_12036.xn1.nsg13_lv_nmos[factuo]
print @n.xtree_12036.xp1.nsg13_lv_pmos[delvto]
print @n.xtree_12036.xp1.nsg13_lv_pmos[factuo]
print @n.xtree_12036.xp0.nsg13_lv_pmos[delvto]
print @n.xtree_12036.xp0.nsg13_lv_pmos[factuo]
print @n.xtree_12037.xn0.nsg13_lv_nmos[delvto]
print @n.xtree_12037.xn0.nsg13_lv_nmos[factuo]
print @n.xtree_12037.xn1.nsg13_lv_nmos[delvto]
print @n.xtree_12037.xn1.nsg13_lv_nmos[factuo]
print @n.xtree_12037.xp1.nsg13_lv_pmos[delvto]
print @n.xtree_12037.xp1.nsg13_lv_pmos[factuo]
print @n.xtree_12037.xp0.nsg13_lv_pmos[delvto]
print @n.xtree_12037.xp0.nsg13_lv_pmos[factuo]
print @n.xtree_12038.xn0.nsg13_lv_nmos[delvto]
print @n.xtree_12038.xn0.nsg13_lv_nmos[factuo]
print @n.xtree_12038.xn1.nsg13_lv_nmos[delvto]
print @n.xtree_12038.xn1.nsg13_lv_nmos[factuo]
print @n.xtree_12038.xp1.nsg13_lv_pmos[delvto]
print @n.xtree_12038.xp1.nsg13_lv_pmos[factuo]
print @n.xtree_12038.xp0.nsg13_lv_pmos[delvto]
print @n.xtree_12038.xp0.nsg13_lv_pmos[factuo]
print @n.xtree_12039.xn0.nsg13_lv_nmos[delvto]
print @n.xtree_12039.xn0.nsg13_lv_nmos[factuo]
print @n.xtree_12039.xn1.nsg13_lv_nmos[delvto]
print @n.xtree_12039.xn1.nsg13_lv_nmos[factuo]
print @n.xtree_12039.xp1.nsg13_lv_pmos[delvto]
print @n.xtree_12039.xp1.nsg13_lv_pmos[factuo]
print @n.xtree_12039.xp0.nsg13_lv_pmos[delvto]
print @n.xtree_12039.xp0.nsg13_lv_pmos[factuo]
print @n.xtree_12040.xn0.nsg13_lv_nmos[delvto]
print @n.xtree_12040.xn0.nsg13_lv_nmos[factuo]
print @n.xtree_12040.xn1.nsg13_lv_nmos[delvto]
print @n.xtree_12040.xn1.nsg13_lv_nmos[factuo]
print @n.xtree_12040.xp1.nsg13_lv_pmos[delvto]
print @n.xtree_12040.xp1.nsg13_lv_pmos[factuo]
print @n.xtree_12040.xp0.nsg13_lv_pmos[delvto]
print @n.xtree_12040.xp0.nsg13_lv_pmos[factuo]
print @n.xtree_12041.xn0.nsg13_lv_nmos[delvto]
print @n.xtree_12041.xn0.nsg13_lv_nmos[factuo]
print @n.xtree_12041.xn1.nsg13_lv_nmos[delvto]
print @n.xtree_12041.xn1.nsg13_lv_nmos[factuo]
print @n.xtree_12041.xp1.nsg13_lv_pmos[delvto]
print @n.xtree_12041.xp1.nsg13_lv_pmos[factuo]
print @n.xtree_12041.xp0.nsg13_lv_pmos[delvto]
print @n.xtree_12041.xp0.nsg13_lv_pmos[factuo]
print @n.xtree_12042.xn0.nsg13_lv_nmos[delvto]
print @n.xtree_12042.xn0.nsg13_lv_nmos[factuo]
print @n.xtree_12042.xn1.nsg13_lv_nmos[delvto]
print @n.xtree_12042.xn1.nsg13_lv_nmos[factuo]
print @n.xtree_12042.xp1.nsg13_lv_pmos[delvto]
print @n.xtree_12042.xp1.nsg13_lv_pmos[factuo]
print @n.xtree_12042.xp0.nsg13_lv_pmos[delvto]
print @n.xtree_12042.xp0.nsg13_lv_pmos[factuo]
print @n.xtree_12043.xn0.nsg13_lv_nmos[delvto]
print @n.xtree_12043.xn0.nsg13_lv_nmos[factuo]
print @n.xtree_12043.xn1.nsg13_lv_nmos[delvto]
print @n.xtree_12043.xn1.nsg13_lv_nmos[factuo]
print @n.xtree_12043.xp1.nsg13_lv_pmos[delvto]
print @n.xtree_12043.xp1.nsg13_lv_pmos[factuo]
print @n.xtree_12043.xp0.nsg13_lv_pmos[delvto]
print @n.xtree_12043.xp0.nsg13_lv_pmos[factuo]
print @n.xtree_12044.xn0.nsg13_lv_nmos[delvto]
print @n.xtree_12044.xn0.nsg13_lv_nmos[factuo]
print @n.xtree_12044.xn1.nsg13_lv_nmos[delvto]
print @n.xtree_12044.xn1.nsg13_lv_nmos[factuo]
print @n.xtree_12044.xp1.nsg13_lv_pmos[delvto]
print @n.xtree_12044.xp1.nsg13_lv_pmos[factuo]
print @n.xtree_12044.xp0.nsg13_lv_pmos[delvto]
print @n.xtree_12044.xp0.nsg13_lv_pmos[factuo]
print @n.xtree_12045.xn0.nsg13_lv_nmos[delvto]
print @n.xtree_12045.xn0.nsg13_lv_nmos[factuo]
print @n.xtree_12045.xn1.nsg13_lv_nmos[delvto]
print @n.xtree_12045.xn1.nsg13_lv_nmos[factuo]
print @n.xtree_12045.xp1.nsg13_lv_pmos[delvto]
print @n.xtree_12045.xp1.nsg13_lv_pmos[factuo]
print @n.xtree_12045.xp0.nsg13_lv_pmos[delvto]
print @n.xtree_12045.xp0.nsg13_lv_pmos[factuo]
print @n.xtree_12046.xn0.nsg13_lv_nmos[delvto]
print @n.xtree_12046.xn0.nsg13_lv_nmos[factuo]
print @n.xtree_12046.xn1.nsg13_lv_nmos[delvto]
print @n.xtree_12046.xn1.nsg13_lv_nmos[factuo]
print @n.xtree_12046.xp1.nsg13_lv_pmos[delvto]
print @n.xtree_12046.xp1.nsg13_lv_pmos[factuo]
print @n.xtree_12046.xp0.nsg13_lv_pmos[delvto]
print @n.xtree_12046.xp0.nsg13_lv_pmos[factuo]
print @n.xtree_12047.xn0.nsg13_lv_nmos[delvto]
print @n.xtree_12047.xn0.nsg13_lv_nmos[factuo]
print @n.xtree_12047.xn1.nsg13_lv_nmos[delvto]
print @n.xtree_12047.xn1.nsg13_lv_nmos[factuo]
print @n.xtree_12047.xp1.nsg13_lv_pmos[delvto]
print @n.xtree_12047.xp1.nsg13_lv_pmos[factuo]
print @n.xtree_12047.xp0.nsg13_lv_pmos[delvto]
print @n.xtree_12047.xp0.nsg13_lv_pmos[factuo]
print @n.xtree_12048.xn0.nsg13_lv_nmos[delvto]
print @n.xtree_12048.xn0.nsg13_lv_nmos[factuo]
print @n.xtree_12048.xn1.nsg13_lv_nmos[delvto]
print @n.xtree_12048.xn1.nsg13_lv_nmos[factuo]
print @n.xtree_12048.xp1.nsg13_lv_pmos[delvto]
print @n.xtree_12048.xp1.nsg13_lv_pmos[factuo]
print @n.xtree_12048.xp0.nsg13_lv_pmos[delvto]
print @n.xtree_12048.xp0.nsg13_lv_pmos[factuo]
print @n.xtree_12049.xn0.nsg13_lv_nmos[delvto]
print @n.xtree_12049.xn0.nsg13_lv_nmos[factuo]
print @n.xtree_12049.xn1.nsg13_lv_nmos[delvto]
print @n.xtree_12049.xn1.nsg13_lv_nmos[factuo]
print @n.xtree_12049.xp1.nsg13_lv_pmos[delvto]
print @n.xtree_12049.xp1.nsg13_lv_pmos[factuo]
print @n.xtree_12049.xp0.nsg13_lv_pmos[delvto]
print @n.xtree_12049.xp0.nsg13_lv_pmos[factuo]
print @n.xtree_12050.xn0.nsg13_lv_nmos[delvto]
print @n.xtree_12050.xn0.nsg13_lv_nmos[factuo]
print @n.xtree_12050.xn1.nsg13_lv_nmos[delvto]
print @n.xtree_12050.xn1.nsg13_lv_nmos[factuo]
print @n.xtree_12050.xp1.nsg13_lv_pmos[delvto]
print @n.xtree_12050.xp1.nsg13_lv_pmos[factuo]
print @n.xtree_12050.xp0.nsg13_lv_pmos[delvto]
print @n.xtree_12050.xp0.nsg13_lv_pmos[factuo]
print @n.xtree_12051.xn0.nsg13_lv_nmos[delvto]
print @n.xtree_12051.xn0.nsg13_lv_nmos[factuo]
print @n.xtree_12051.xn1.nsg13_lv_nmos[delvto]
print @n.xtree_12051.xn1.nsg13_lv_nmos[factuo]
print @n.xtree_12051.xp1.nsg13_lv_pmos[delvto]
print @n.xtree_12051.xp1.nsg13_lv_pmos[factuo]
print @n.xtree_12051.xp0.nsg13_lv_pmos[delvto]
print @n.xtree_12051.xp0.nsg13_lv_pmos[factuo]
print @n.xtree_12052.xn0.nsg13_lv_nmos[delvto]
print @n.xtree_12052.xn0.nsg13_lv_nmos[factuo]
print @n.xtree_12052.xn1.nsg13_lv_nmos[delvto]
print @n.xtree_12052.xn1.nsg13_lv_nmos[factuo]
print @n.xtree_12052.xp1.nsg13_lv_pmos[delvto]
print @n.xtree_12052.xp1.nsg13_lv_pmos[factuo]
print @n.xtree_12052.xp0.nsg13_lv_pmos[delvto]
print @n.xtree_12052.xp0.nsg13_lv_pmos[factuo]
print @n.xtree_12053.xn0.nsg13_lv_nmos[delvto]
print @n.xtree_12053.xn0.nsg13_lv_nmos[factuo]
print @n.xtree_12053.xn1.nsg13_lv_nmos[delvto]
print @n.xtree_12053.xn1.nsg13_lv_nmos[factuo]
print @n.xtree_12053.xp1.nsg13_lv_pmos[delvto]
print @n.xtree_12053.xp1.nsg13_lv_pmos[factuo]
print @n.xtree_12053.xp0.nsg13_lv_pmos[delvto]
print @n.xtree_12053.xp0.nsg13_lv_pmos[factuo]
print @n.xtree_12054.xn0.nsg13_lv_nmos[delvto]
print @n.xtree_12054.xn0.nsg13_lv_nmos[factuo]
print @n.xtree_12054.xn1.nsg13_lv_nmos[delvto]
print @n.xtree_12054.xn1.nsg13_lv_nmos[factuo]
print @n.xtree_12054.xp1.nsg13_lv_pmos[delvto]
print @n.xtree_12054.xp1.nsg13_lv_pmos[factuo]
print @n.xtree_12054.xp0.nsg13_lv_pmos[delvto]
print @n.xtree_12054.xp0.nsg13_lv_pmos[factuo]
print @n.xtree_12055.xn0.nsg13_lv_nmos[delvto]
print @n.xtree_12055.xn0.nsg13_lv_nmos[factuo]
print @n.xtree_12055.xn1.nsg13_lv_nmos[delvto]
print @n.xtree_12055.xn1.nsg13_lv_nmos[factuo]
print @n.xtree_12055.xp1.nsg13_lv_pmos[delvto]
print @n.xtree_12055.xp1.nsg13_lv_pmos[factuo]
print @n.xtree_12055.xp0.nsg13_lv_pmos[delvto]
print @n.xtree_12055.xp0.nsg13_lv_pmos[factuo]
print @n.xtree_12056.xn0.nsg13_lv_nmos[delvto]
print @n.xtree_12056.xn0.nsg13_lv_nmos[factuo]
print @n.xtree_12056.xn1.nsg13_lv_nmos[delvto]
print @n.xtree_12056.xn1.nsg13_lv_nmos[factuo]
print @n.xtree_12056.xp1.nsg13_lv_pmos[delvto]
print @n.xtree_12056.xp1.nsg13_lv_pmos[factuo]
print @n.xtree_12056.xp0.nsg13_lv_pmos[delvto]
print @n.xtree_12056.xp0.nsg13_lv_pmos[factuo]
print @n.xtree_12057.xn0.nsg13_lv_nmos[delvto]
print @n.xtree_12057.xn0.nsg13_lv_nmos[factuo]
print @n.xtree_12057.xn1.nsg13_lv_nmos[delvto]
print @n.xtree_12057.xn1.nsg13_lv_nmos[factuo]
print @n.xtree_12057.xp1.nsg13_lv_pmos[delvto]
print @n.xtree_12057.xp1.nsg13_lv_pmos[factuo]
print @n.xtree_12057.xp0.nsg13_lv_pmos[delvto]
print @n.xtree_12057.xp0.nsg13_lv_pmos[factuo]
print @n.xtree_12058.xn0.nsg13_lv_nmos[delvto]
print @n.xtree_12058.xn0.nsg13_lv_nmos[factuo]
print @n.xtree_12058.xn1.nsg13_lv_nmos[delvto]
print @n.xtree_12058.xn1.nsg13_lv_nmos[factuo]
print @n.xtree_12058.xp1.nsg13_lv_pmos[delvto]
print @n.xtree_12058.xp1.nsg13_lv_pmos[factuo]
print @n.xtree_12058.xp0.nsg13_lv_pmos[delvto]
print @n.xtree_12058.xp0.nsg13_lv_pmos[factuo]
print @n.xtree_12059.xn0.nsg13_lv_nmos[delvto]
print @n.xtree_12059.xn0.nsg13_lv_nmos[factuo]
print @n.xtree_12059.xn1.nsg13_lv_nmos[delvto]
print @n.xtree_12059.xn1.nsg13_lv_nmos[factuo]
print @n.xtree_12059.xp1.nsg13_lv_pmos[delvto]
print @n.xtree_12059.xp1.nsg13_lv_pmos[factuo]
print @n.xtree_12059.xp0.nsg13_lv_pmos[delvto]
print @n.xtree_12059.xp0.nsg13_lv_pmos[factuo]
print @n.xtree_12060.xn0.nsg13_lv_nmos[delvto]
print @n.xtree_12060.xn0.nsg13_lv_nmos[factuo]
print @n.xtree_12060.xn1.nsg13_lv_nmos[delvto]
print @n.xtree_12060.xn1.nsg13_lv_nmos[factuo]
print @n.xtree_12060.xp1.nsg13_lv_pmos[delvto]
print @n.xtree_12060.xp1.nsg13_lv_pmos[factuo]
print @n.xtree_12060.xp0.nsg13_lv_pmos[delvto]
print @n.xtree_12060.xp0.nsg13_lv_pmos[factuo]
print @n.xtree_12061.xn0.nsg13_lv_nmos[delvto]
print @n.xtree_12061.xn0.nsg13_lv_nmos[factuo]
print @n.xtree_12061.xn1.nsg13_lv_nmos[delvto]
print @n.xtree_12061.xn1.nsg13_lv_nmos[factuo]
print @n.xtree_12061.xp1.nsg13_lv_pmos[delvto]
print @n.xtree_12061.xp1.nsg13_lv_pmos[factuo]
print @n.xtree_12061.xp0.nsg13_lv_pmos[delvto]
print @n.xtree_12061.xp0.nsg13_lv_pmos[factuo]
print @n.xtree_12062.xn0.nsg13_lv_nmos[delvto]
print @n.xtree_12062.xn0.nsg13_lv_nmos[factuo]
print @n.xtree_12062.xn1.nsg13_lv_nmos[delvto]
print @n.xtree_12062.xn1.nsg13_lv_nmos[factuo]
print @n.xtree_12062.xp1.nsg13_lv_pmos[delvto]
print @n.xtree_12062.xp1.nsg13_lv_pmos[factuo]
print @n.xtree_12062.xp0.nsg13_lv_pmos[delvto]
print @n.xtree_12062.xp0.nsg13_lv_pmos[factuo]
print @n.xtree_12063.xn0.nsg13_lv_nmos[delvto]
print @n.xtree_12063.xn0.nsg13_lv_nmos[factuo]
print @n.xtree_12063.xn1.nsg13_lv_nmos[delvto]
print @n.xtree_12063.xn1.nsg13_lv_nmos[factuo]
print @n.xtree_12063.xp1.nsg13_lv_pmos[delvto]
print @n.xtree_12063.xp1.nsg13_lv_pmos[factuo]
print @n.xtree_12063.xp0.nsg13_lv_pmos[delvto]
print @n.xtree_12063.xp0.nsg13_lv_pmos[factuo]
print @n.xtree_12064.xn0.nsg13_lv_nmos[delvto]
print @n.xtree_12064.xn0.nsg13_lv_nmos[factuo]
print @n.xtree_12064.xn1.nsg13_lv_nmos[delvto]
print @n.xtree_12064.xn1.nsg13_lv_nmos[factuo]
print @n.xtree_12064.xp1.nsg13_lv_pmos[delvto]
print @n.xtree_12064.xp1.nsg13_lv_pmos[factuo]
print @n.xtree_12064.xp0.nsg13_lv_pmos[delvto]
print @n.xtree_12064.xp0.nsg13_lv_pmos[factuo]
print @n.xtree_12065.xn0.nsg13_lv_nmos[delvto]
print @n.xtree_12065.xn0.nsg13_lv_nmos[factuo]
print @n.xtree_12065.xn1.nsg13_lv_nmos[delvto]
print @n.xtree_12065.xn1.nsg13_lv_nmos[factuo]
print @n.xtree_12065.xp1.nsg13_lv_pmos[delvto]
print @n.xtree_12065.xp1.nsg13_lv_pmos[factuo]
print @n.xtree_12065.xp0.nsg13_lv_pmos[delvto]
print @n.xtree_12065.xp0.nsg13_lv_pmos[factuo]
print @n.xtree_12066.xn0.nsg13_lv_nmos[delvto]
print @n.xtree_12066.xn0.nsg13_lv_nmos[factuo]
print @n.xtree_12066.xn1.nsg13_lv_nmos[delvto]
print @n.xtree_12066.xn1.nsg13_lv_nmos[factuo]
print @n.xtree_12066.xp1.nsg13_lv_pmos[delvto]
print @n.xtree_12066.xp1.nsg13_lv_pmos[factuo]
print @n.xtree_12066.xp0.nsg13_lv_pmos[delvto]
print @n.xtree_12066.xp0.nsg13_lv_pmos[factuo]
print @n.xtree_12067.xn0.nsg13_lv_nmos[delvto]
print @n.xtree_12067.xn0.nsg13_lv_nmos[factuo]
print @n.xtree_12067.xn1.nsg13_lv_nmos[delvto]
print @n.xtree_12067.xn1.nsg13_lv_nmos[factuo]
print @n.xtree_12067.xp1.nsg13_lv_pmos[delvto]
print @n.xtree_12067.xp1.nsg13_lv_pmos[factuo]
print @n.xtree_12067.xp0.nsg13_lv_pmos[delvto]
print @n.xtree_12067.xp0.nsg13_lv_pmos[factuo]
print @n.xtree_12068.xn0.nsg13_lv_nmos[delvto]
print @n.xtree_12068.xn0.nsg13_lv_nmos[factuo]
print @n.xtree_12068.xn1.nsg13_lv_nmos[delvto]
print @n.xtree_12068.xn1.nsg13_lv_nmos[factuo]
print @n.xtree_12068.xp1.nsg13_lv_pmos[delvto]
print @n.xtree_12068.xp1.nsg13_lv_pmos[factuo]
print @n.xtree_12068.xp0.nsg13_lv_pmos[delvto]
print @n.xtree_12068.xp0.nsg13_lv_pmos[factuo]
print @n.xtree_12069.xn0.nsg13_lv_nmos[delvto]
print @n.xtree_12069.xn0.nsg13_lv_nmos[factuo]
print @n.xtree_12069.xn1.nsg13_lv_nmos[delvto]
print @n.xtree_12069.xn1.nsg13_lv_nmos[factuo]
print @n.xtree_12069.xp1.nsg13_lv_pmos[delvto]
print @n.xtree_12069.xp1.nsg13_lv_pmos[factuo]
print @n.xtree_12069.xp0.nsg13_lv_pmos[delvto]
print @n.xtree_12069.xp0.nsg13_lv_pmos[factuo]
print @n.xtree_12070.xn0.nsg13_lv_nmos[delvto]
print @n.xtree_12070.xn0.nsg13_lv_nmos[factuo]
print @n.xtree_12070.xn1.nsg13_lv_nmos[delvto]
print @n.xtree_12070.xn1.nsg13_lv_nmos[factuo]
print @n.xtree_12070.xp1.nsg13_lv_pmos[delvto]
print @n.xtree_12070.xp1.nsg13_lv_pmos[factuo]
print @n.xtree_12070.xp0.nsg13_lv_pmos[delvto]
print @n.xtree_12070.xp0.nsg13_lv_pmos[factuo]
print @n.xtree_12071.xn0.nsg13_lv_nmos[delvto]
print @n.xtree_12071.xn0.nsg13_lv_nmos[factuo]
print @n.xtree_12071.xn1.nsg13_lv_nmos[delvto]
print @n.xtree_12071.xn1.nsg13_lv_nmos[factuo]
print @n.xtree_12071.xp1.nsg13_lv_pmos[delvto]
print @n.xtree_12071.xp1.nsg13_lv_pmos[factuo]
print @n.xtree_12071.xp0.nsg13_lv_pmos[delvto]
print @n.xtree_12071.xp0.nsg13_lv_pmos[factuo]
print @n.xtree_12072.xn0.nsg13_lv_nmos[delvto]
print @n.xtree_12072.xn0.nsg13_lv_nmos[factuo]
print @n.xtree_12072.xn1.nsg13_lv_nmos[delvto]
print @n.xtree_12072.xn1.nsg13_lv_nmos[factuo]
print @n.xtree_12072.xp1.nsg13_lv_pmos[delvto]
print @n.xtree_12072.xp1.nsg13_lv_pmos[factuo]
print @n.xtree_12072.xp0.nsg13_lv_pmos[delvto]
print @n.xtree_12072.xp0.nsg13_lv_pmos[factuo]
print @n.xtree_12073.xn0.nsg13_lv_nmos[delvto]
print @n.xtree_12073.xn0.nsg13_lv_nmos[factuo]
print @n.xtree_12073.xn1.nsg13_lv_nmos[delvto]
print @n.xtree_12073.xn1.nsg13_lv_nmos[factuo]
print @n.xtree_12073.xp1.nsg13_lv_pmos[delvto]
print @n.xtree_12073.xp1.nsg13_lv_pmos[factuo]
print @n.xtree_12073.xp0.nsg13_lv_pmos[delvto]
print @n.xtree_12073.xp0.nsg13_lv_pmos[factuo]
print @n.xtree_12074.xn0.nsg13_lv_nmos[delvto]
print @n.xtree_12074.xn0.nsg13_lv_nmos[factuo]
print @n.xtree_12074.xn1.nsg13_lv_nmos[delvto]
print @n.xtree_12074.xn1.nsg13_lv_nmos[factuo]
print @n.xtree_12074.xp1.nsg13_lv_pmos[delvto]
print @n.xtree_12074.xp1.nsg13_lv_pmos[factuo]
print @n.xtree_12074.xp0.nsg13_lv_pmos[delvto]
print @n.xtree_12074.xp0.nsg13_lv_pmos[factuo]
print @n.xtree_12075.xn0.nsg13_lv_nmos[delvto]
print @n.xtree_12075.xn0.nsg13_lv_nmos[factuo]
print @n.xtree_12075.xn1.nsg13_lv_nmos[delvto]
print @n.xtree_12075.xn1.nsg13_lv_nmos[factuo]
print @n.xtree_12075.xp1.nsg13_lv_pmos[delvto]
print @n.xtree_12075.xp1.nsg13_lv_pmos[factuo]
print @n.xtree_12075.xp0.nsg13_lv_pmos[delvto]
print @n.xtree_12075.xp0.nsg13_lv_pmos[factuo]
print @n.xtree_12076.xn0.nsg13_lv_nmos[delvto]
print @n.xtree_12076.xn0.nsg13_lv_nmos[factuo]
print @n.xtree_12076.xn1.nsg13_lv_nmos[delvto]
print @n.xtree_12076.xn1.nsg13_lv_nmos[factuo]
print @n.xtree_12076.xp1.nsg13_lv_pmos[delvto]
print @n.xtree_12076.xp1.nsg13_lv_pmos[factuo]
print @n.xtree_12076.xp0.nsg13_lv_pmos[delvto]
print @n.xtree_12076.xp0.nsg13_lv_pmos[factuo]
print @n.xtree_12077.xn0.nsg13_lv_nmos[delvto]
print @n.xtree_12077.xn0.nsg13_lv_nmos[factuo]
print @n.xtree_12077.xn1.nsg13_lv_nmos[delvto]
print @n.xtree_12077.xn1.nsg13_lv_nmos[factuo]
print @n.xtree_12077.xp1.nsg13_lv_pmos[delvto]
print @n.xtree_12077.xp1.nsg13_lv_pmos[factuo]
print @n.xtree_12077.xp0.nsg13_lv_pmos[delvto]
print @n.xtree_12077.xp0.nsg13_lv_pmos[factuo]
print @n.xtree_12078.xn0.nsg13_lv_nmos[delvto]
print @n.xtree_12078.xn0.nsg13_lv_nmos[factuo]
print @n.xtree_12078.xn1.nsg13_lv_nmos[delvto]
print @n.xtree_12078.xn1.nsg13_lv_nmos[factuo]
print @n.xtree_12078.xp1.nsg13_lv_pmos[delvto]
print @n.xtree_12078.xp1.nsg13_lv_pmos[factuo]
print @n.xtree_12078.xp0.nsg13_lv_pmos[delvto]
print @n.xtree_12078.xp0.nsg13_lv_pmos[factuo]
print @n.xtree_12079.xn0.nsg13_lv_nmos[delvto]
print @n.xtree_12079.xn0.nsg13_lv_nmos[factuo]
print @n.xtree_12079.xn1.nsg13_lv_nmos[delvto]
print @n.xtree_12079.xn1.nsg13_lv_nmos[factuo]
print @n.xtree_12079.xp1.nsg13_lv_pmos[delvto]
print @n.xtree_12079.xp1.nsg13_lv_pmos[factuo]
print @n.xtree_12079.xp0.nsg13_lv_pmos[delvto]
print @n.xtree_12079.xp0.nsg13_lv_pmos[factuo]
print @n.xtree_12080.xn0.nsg13_lv_nmos[delvto]
print @n.xtree_12080.xn0.nsg13_lv_nmos[factuo]
print @n.xtree_12080.xn1.nsg13_lv_nmos[delvto]
print @n.xtree_12080.xn1.nsg13_lv_nmos[factuo]
print @n.xtree_12080.xp1.nsg13_lv_pmos[delvto]
print @n.xtree_12080.xp1.nsg13_lv_pmos[factuo]
print @n.xtree_12080.xp0.nsg13_lv_pmos[delvto]
print @n.xtree_12080.xp0.nsg13_lv_pmos[factuo]
print @n.xtree_12081.xn0.nsg13_lv_nmos[delvto]
print @n.xtree_12081.xn0.nsg13_lv_nmos[factuo]
print @n.xtree_12081.xn1.nsg13_lv_nmos[delvto]
print @n.xtree_12081.xn1.nsg13_lv_nmos[factuo]
print @n.xtree_12081.xp1.nsg13_lv_pmos[delvto]
print @n.xtree_12081.xp1.nsg13_lv_pmos[factuo]
print @n.xtree_12081.xp0.nsg13_lv_pmos[delvto]
print @n.xtree_12081.xp0.nsg13_lv_pmos[factuo]
print @n.xtree_12082.xn0.nsg13_lv_nmos[delvto]
print @n.xtree_12082.xn0.nsg13_lv_nmos[factuo]
print @n.xtree_12082.xn1.nsg13_lv_nmos[delvto]
print @n.xtree_12082.xn1.nsg13_lv_nmos[factuo]
print @n.xtree_12082.xp1.nsg13_lv_pmos[delvto]
print @n.xtree_12082.xp1.nsg13_lv_pmos[factuo]
print @n.xtree_12082.xp0.nsg13_lv_pmos[delvto]
print @n.xtree_12082.xp0.nsg13_lv_pmos[factuo]
print @n.xtree_12083.xn0.nsg13_lv_nmos[delvto]
print @n.xtree_12083.xn0.nsg13_lv_nmos[factuo]
print @n.xtree_12083.xn1.nsg13_lv_nmos[delvto]
print @n.xtree_12083.xn1.nsg13_lv_nmos[factuo]
print @n.xtree_12083.xp1.nsg13_lv_pmos[delvto]
print @n.xtree_12083.xp1.nsg13_lv_pmos[factuo]
print @n.xtree_12083.xp0.nsg13_lv_pmos[delvto]
print @n.xtree_12083.xp0.nsg13_lv_pmos[factuo]
print @n.xtree_12084.xn0.nsg13_lv_nmos[delvto]
print @n.xtree_12084.xn0.nsg13_lv_nmos[factuo]
print @n.xtree_12084.xn1.nsg13_lv_nmos[delvto]
print @n.xtree_12084.xn1.nsg13_lv_nmos[factuo]
print @n.xtree_12084.xp1.nsg13_lv_pmos[delvto]
print @n.xtree_12084.xp1.nsg13_lv_pmos[factuo]
print @n.xtree_12084.xp0.nsg13_lv_pmos[delvto]
print @n.xtree_12084.xp0.nsg13_lv_pmos[factuo]
print @n.xtree_12085.xn0.nsg13_lv_nmos[delvto]
print @n.xtree_12085.xn0.nsg13_lv_nmos[factuo]
print @n.xtree_12085.xn1.nsg13_lv_nmos[delvto]
print @n.xtree_12085.xn1.nsg13_lv_nmos[factuo]
print @n.xtree_12085.xp1.nsg13_lv_pmos[delvto]
print @n.xtree_12085.xp1.nsg13_lv_pmos[factuo]
print @n.xtree_12085.xp0.nsg13_lv_pmos[delvto]
print @n.xtree_12085.xp0.nsg13_lv_pmos[factuo]
print @n.xtree_12086.xn0.nsg13_lv_nmos[delvto]
print @n.xtree_12086.xn0.nsg13_lv_nmos[factuo]
print @n.xtree_12086.xn1.nsg13_lv_nmos[delvto]
print @n.xtree_12086.xn1.nsg13_lv_nmos[factuo]
print @n.xtree_12086.xp1.nsg13_lv_pmos[delvto]
print @n.xtree_12086.xp1.nsg13_lv_pmos[factuo]
print @n.xtree_12086.xp0.nsg13_lv_pmos[delvto]
print @n.xtree_12086.xp0.nsg13_lv_pmos[factuo]
print @n.xtree_12087.xn0.nsg13_lv_nmos[delvto]
print @n.xtree_12087.xn0.nsg13_lv_nmos[factuo]
print @n.xtree_12087.xn1.nsg13_lv_nmos[delvto]
print @n.xtree_12087.xn1.nsg13_lv_nmos[factuo]
print @n.xtree_12087.xp1.nsg13_lv_pmos[delvto]
print @n.xtree_12087.xp1.nsg13_lv_pmos[factuo]
print @n.xtree_12087.xp0.nsg13_lv_pmos[delvto]
print @n.xtree_12087.xp0.nsg13_lv_pmos[factuo]
print @n.xtree_12088.xn0.nsg13_lv_nmos[delvto]
print @n.xtree_12088.xn0.nsg13_lv_nmos[factuo]
print @n.xtree_12088.xn1.nsg13_lv_nmos[delvto]
print @n.xtree_12088.xn1.nsg13_lv_nmos[factuo]
print @n.xtree_12088.xp1.nsg13_lv_pmos[delvto]
print @n.xtree_12088.xp1.nsg13_lv_pmos[factuo]
print @n.xtree_12088.xp0.nsg13_lv_pmos[delvto]
print @n.xtree_12088.xp0.nsg13_lv_pmos[factuo]
print @n.xtree_12089.xn0.nsg13_lv_nmos[delvto]
print @n.xtree_12089.xn0.nsg13_lv_nmos[factuo]
print @n.xtree_12089.xn1.nsg13_lv_nmos[delvto]
print @n.xtree_12089.xn1.nsg13_lv_nmos[factuo]
print @n.xtree_12089.xp1.nsg13_lv_pmos[delvto]
print @n.xtree_12089.xp1.nsg13_lv_pmos[factuo]
print @n.xtree_12089.xp0.nsg13_lv_pmos[delvto]
print @n.xtree_12089.xp0.nsg13_lv_pmos[factuo]
print @n.xtree_12090.xn0.nsg13_lv_nmos[delvto]
print @n.xtree_12090.xn0.nsg13_lv_nmos[factuo]
print @n.xtree_12090.xn1.nsg13_lv_nmos[delvto]
print @n.xtree_12090.xn1.nsg13_lv_nmos[factuo]
print @n.xtree_12090.xp1.nsg13_lv_pmos[delvto]
print @n.xtree_12090.xp1.nsg13_lv_pmos[factuo]
print @n.xtree_12090.xp0.nsg13_lv_pmos[delvto]
print @n.xtree_12090.xp0.nsg13_lv_pmos[factuo]
print @n.xtree_12091.xn0.nsg13_lv_nmos[delvto]
print @n.xtree_12091.xn0.nsg13_lv_nmos[factuo]
print @n.xtree_12091.xn1.nsg13_lv_nmos[delvto]
print @n.xtree_12091.xn1.nsg13_lv_nmos[factuo]
print @n.xtree_12091.xp1.nsg13_lv_pmos[delvto]
print @n.xtree_12091.xp1.nsg13_lv_pmos[factuo]
print @n.xtree_12091.xp0.nsg13_lv_pmos[delvto]
print @n.xtree_12091.xp0.nsg13_lv_pmos[factuo]
print @n.xtree_12092.xn0.nsg13_lv_nmos[delvto]
print @n.xtree_12092.xn0.nsg13_lv_nmos[factuo]
print @n.xtree_12092.xn1.nsg13_lv_nmos[delvto]
print @n.xtree_12092.xn1.nsg13_lv_nmos[factuo]
print @n.xtree_12092.xp1.nsg13_lv_pmos[delvto]
print @n.xtree_12092.xp1.nsg13_lv_pmos[factuo]
print @n.xtree_12092.xp0.nsg13_lv_pmos[delvto]
print @n.xtree_12092.xp0.nsg13_lv_pmos[factuo]
print @n.xtree_12093.xn0.nsg13_lv_nmos[delvto]
print @n.xtree_12093.xn0.nsg13_lv_nmos[factuo]
print @n.xtree_12093.xn1.nsg13_lv_nmos[delvto]
print @n.xtree_12093.xn1.nsg13_lv_nmos[factuo]
print @n.xtree_12093.xp1.nsg13_lv_pmos[delvto]
print @n.xtree_12093.xp1.nsg13_lv_pmos[factuo]
print @n.xtree_12093.xp0.nsg13_lv_pmos[delvto]
print @n.xtree_12093.xp0.nsg13_lv_pmos[factuo]
print @n.xtree_12094.xn0.nsg13_lv_nmos[delvto]
print @n.xtree_12094.xn0.nsg13_lv_nmos[factuo]
print @n.xtree_12094.xn1.nsg13_lv_nmos[delvto]
print @n.xtree_12094.xn1.nsg13_lv_nmos[factuo]
print @n.xtree_12094.xp1.nsg13_lv_pmos[delvto]
print @n.xtree_12094.xp1.nsg13_lv_pmos[factuo]
print @n.xtree_12094.xp0.nsg13_lv_pmos[delvto]
print @n.xtree_12094.xp0.nsg13_lv_pmos[factuo]
print @n.xtree_12095.xn0.nsg13_lv_nmos[delvto]
print @n.xtree_12095.xn0.nsg13_lv_nmos[factuo]
print @n.xtree_12095.xn1.nsg13_lv_nmos[delvto]
print @n.xtree_12095.xn1.nsg13_lv_nmos[factuo]
print @n.xtree_12095.xp1.nsg13_lv_pmos[delvto]
print @n.xtree_12095.xp1.nsg13_lv_pmos[factuo]
print @n.xtree_12095.xp0.nsg13_lv_pmos[delvto]
print @n.xtree_12095.xp0.nsg13_lv_pmos[factuo]
print @n.xtree_12096.xn0.nsg13_lv_nmos[delvto]
print @n.xtree_12096.xn0.nsg13_lv_nmos[factuo]
print @n.xtree_12096.xn1.nsg13_lv_nmos[delvto]
print @n.xtree_12096.xn1.nsg13_lv_nmos[factuo]
print @n.xtree_12096.xp1.nsg13_lv_pmos[delvto]
print @n.xtree_12096.xp1.nsg13_lv_pmos[factuo]
print @n.xtree_12096.xp0.nsg13_lv_pmos[delvto]
print @n.xtree_12096.xp0.nsg13_lv_pmos[factuo]
print @n.xtree_12097.xn0.nsg13_lv_nmos[delvto]
print @n.xtree_12097.xn0.nsg13_lv_nmos[factuo]
print @n.xtree_12097.xn1.nsg13_lv_nmos[delvto]
print @n.xtree_12097.xn1.nsg13_lv_nmos[factuo]
print @n.xtree_12097.xp1.nsg13_lv_pmos[delvto]
print @n.xtree_12097.xp1.nsg13_lv_pmos[factuo]
print @n.xtree_12097.xp0.nsg13_lv_pmos[delvto]
print @n.xtree_12097.xp0.nsg13_lv_pmos[factuo]
print @n.xtree_12098.xn0.nsg13_lv_nmos[delvto]
print @n.xtree_12098.xn0.nsg13_lv_nmos[factuo]
print @n.xtree_12098.xn1.nsg13_lv_nmos[delvto]
print @n.xtree_12098.xn1.nsg13_lv_nmos[factuo]
print @n.xtree_12098.xp1.nsg13_lv_pmos[delvto]
print @n.xtree_12098.xp1.nsg13_lv_pmos[factuo]
print @n.xtree_12098.xp0.nsg13_lv_pmos[delvto]
print @n.xtree_12098.xp0.nsg13_lv_pmos[factuo]
echo CLOCK_FP_BEFORE_END
tran 0.2n 6e-06
echo OSC_FP_AFTER_BEGIN
print @n.x1.xm1.nsg13_lv_nmos[w]
print @n.x1.xm1.nsg13_lv_nmos[l]
print @n.x1.xm1.nsg13_lv_nmos[delvto]
print @n.x1.xm1.nsg13_lv_nmos[factuo]
print @n.x1.xm2.nsg13_lv_nmos[w]
print @n.x1.xm2.nsg13_lv_nmos[l]
print @n.x1.xm2.nsg13_lv_nmos[delvto]
print @n.x1.xm2.nsg13_lv_nmos[factuo]
print @n.x1.xm3.nsg13_lv_nmos[w]
print @n.x1.xm3.nsg13_lv_nmos[l]
print @n.x1.xm3.nsg13_lv_nmos[delvto]
print @n.x1.xm3.nsg13_lv_nmos[factuo]
print @n.x1.xm4.nsg13_lv_nmos[w]
print @n.x1.xm4.nsg13_lv_nmos[l]
print @n.x1.xm4.nsg13_lv_nmos[delvto]
print @n.x1.xm4.nsg13_lv_nmos[factuo]
print @n.x1.xm5.nsg13_lv_nmos[w]
print @n.x1.xm5.nsg13_lv_nmos[l]
print @n.x1.xm5.nsg13_lv_nmos[delvto]
print @n.x1.xm5.nsg13_lv_nmos[factuo]
print @n.x1.xm6.nsg13_lv_nmos[w]
print @n.x1.xm6.nsg13_lv_nmos[l]
print @n.x1.xm6.nsg13_lv_nmos[delvto]
print @n.x1.xm6.nsg13_lv_nmos[factuo]
print @n.x1.xm7.nsg13_lv_nmos[w]
print @n.x1.xm7.nsg13_lv_nmos[l]
print @n.x1.xm7.nsg13_lv_nmos[delvto]
print @n.x1.xm7.nsg13_lv_nmos[factuo]
print @n.x1.xm8.nsg13_lv_nmos[w]
print @n.x1.xm8.nsg13_lv_nmos[l]
print @n.x1.xm8.nsg13_lv_nmos[delvto]
print @n.x1.xm8.nsg13_lv_nmos[factuo]
print @n.x1.xm9.nsg13_lv_nmos[w]
print @n.x1.xm9.nsg13_lv_nmos[l]
print @n.x1.xm9.nsg13_lv_nmos[delvto]
print @n.x1.xm9.nsg13_lv_nmos[factuo]
print @n.x1.xm10.nsg13_lv_nmos[w]
print @n.x1.xm10.nsg13_lv_nmos[l]
print @n.x1.xm10.nsg13_lv_nmos[delvto]
print @n.x1.xm10.nsg13_lv_nmos[factuo]
print @n.x1.xm11.nsg13_lv_nmos[w]
print @n.x1.xm11.nsg13_lv_nmos[l]
print @n.x1.xm11.nsg13_lv_nmos[delvto]
print @n.x1.xm11.nsg13_lv_nmos[factuo]
print @n.x1.xm12.nsg13_lv_nmos[w]
print @n.x1.xm12.nsg13_lv_nmos[l]
print @n.x1.xm12.nsg13_lv_nmos[delvto]
print @n.x1.xm12.nsg13_lv_nmos[factuo]
print @n.x1.xm13.nsg13_lv_nmos[w]
print @n.x1.xm13.nsg13_lv_nmos[l]
print @n.x1.xm13.nsg13_lv_nmos[delvto]
print @n.x1.xm13.nsg13_lv_nmos[factuo]
print @n.x1.xm14.nsg13_lv_nmos[w]
print @n.x1.xm14.nsg13_lv_nmos[l]
print @n.x1.xm14.nsg13_lv_nmos[delvto]
print @n.x1.xm14.nsg13_lv_nmos[factuo]
print @n.x1.xm15.nsg13_lv_nmos[w]
print @n.x1.xm15.nsg13_lv_nmos[l]
print @n.x1.xm15.nsg13_lv_nmos[delvto]
print @n.x1.xm15.nsg13_lv_nmos[factuo]
print @n.x1.xm16.nsg13_lv_nmos[w]
print @n.x1.xm16.nsg13_lv_nmos[l]
print @n.x1.xm16.nsg13_lv_nmos[delvto]
print @n.x1.xm16.nsg13_lv_nmos[factuo]
print @n.x1.xm17.nsg13_lv_nmos[w]
print @n.x1.xm17.nsg13_lv_nmos[l]
print @n.x1.xm17.nsg13_lv_nmos[delvto]
print @n.x1.xm17.nsg13_lv_nmos[factuo]
print @n.x1.xm18.nsg13_lv_nmos[w]
print @n.x1.xm18.nsg13_lv_nmos[l]
print @n.x1.xm18.nsg13_lv_nmos[delvto]
print @n.x1.xm18.nsg13_lv_nmos[factuo]
print @n.x1.xm19.nsg13_lv_nmos[w]
print @n.x1.xm19.nsg13_lv_nmos[l]
print @n.x1.xm19.nsg13_lv_nmos[delvto]
print @n.x1.xm19.nsg13_lv_nmos[factuo]
print @n.x1.xm20.nsg13_lv_nmos[w]
print @n.x1.xm20.nsg13_lv_nmos[l]
print @n.x1.xm20.nsg13_lv_nmos[delvto]
print @n.x1.xm20.nsg13_lv_nmos[factuo]
print @n.x1.xm21.nsg13_lv_nmos[w]
print @n.x1.xm21.nsg13_lv_nmos[l]
print @n.x1.xm21.nsg13_lv_nmos[delvto]
print @n.x1.xm21.nsg13_lv_nmos[factuo]
print @n.x1.xm22.nsg13_lv_nmos[w]
print @n.x1.xm22.nsg13_lv_nmos[l]
print @n.x1.xm22.nsg13_lv_nmos[delvto]
print @n.x1.xm22.nsg13_lv_nmos[factuo]
print @n.x1.xm23.nsg13_lv_nmos[w]
print @n.x1.xm23.nsg13_lv_nmos[l]
print @n.x1.xm23.nsg13_lv_nmos[delvto]
print @n.x1.xm23.nsg13_lv_nmos[factuo]
print @n.x1.xm24.nsg13_lv_nmos[w]
print @n.x1.xm24.nsg13_lv_nmos[l]
print @n.x1.xm24.nsg13_lv_nmos[delvto]
print @n.x1.xm24.nsg13_lv_nmos[factuo]
print @n.x1.xm25.nsg13_lv_nmos[w]
print @n.x1.xm25.nsg13_lv_nmos[l]
print @n.x1.xm25.nsg13_lv_nmos[delvto]
print @n.x1.xm25.nsg13_lv_nmos[factuo]
print @n.x1.xm26.nsg13_lv_nmos[w]
print @n.x1.xm26.nsg13_lv_nmos[l]
print @n.x1.xm26.nsg13_lv_nmos[delvto]
print @n.x1.xm26.nsg13_lv_nmos[factuo]
print @n.x1.xm27.nsg13_lv_nmos[w]
print @n.x1.xm27.nsg13_lv_nmos[l]
print @n.x1.xm27.nsg13_lv_nmos[delvto]
print @n.x1.xm27.nsg13_lv_nmos[factuo]
print @n.x1.xm28.nsg13_lv_nmos[w]
print @n.x1.xm28.nsg13_lv_nmos[l]
print @n.x1.xm28.nsg13_lv_nmos[delvto]
print @n.x1.xm28.nsg13_lv_nmos[factuo]
print @n.x1.xm29.nsg13_lv_nmos[w]
print @n.x1.xm29.nsg13_lv_nmos[l]
print @n.x1.xm29.nsg13_lv_nmos[delvto]
print @n.x1.xm29.nsg13_lv_nmos[factuo]
print @n.x1.xm30.nsg13_lv_nmos[w]
print @n.x1.xm30.nsg13_lv_nmos[l]
print @n.x1.xm30.nsg13_lv_nmos[delvto]
print @n.x1.xm30.nsg13_lv_nmos[factuo]
print @n.x1.xm31.nsg13_lv_nmos[w]
print @n.x1.xm31.nsg13_lv_nmos[l]
print @n.x1.xm31.nsg13_lv_nmos[delvto]
print @n.x1.xm31.nsg13_lv_nmos[factuo]
print @n.x1.xm32.nsg13_lv_nmos[w]
print @n.x1.xm32.nsg13_lv_nmos[l]
print @n.x1.xm32.nsg13_lv_nmos[delvto]
print @n.x1.xm32.nsg13_lv_nmos[factuo]
print @n.x1.xm33.nsg13_lv_pmos[w]
print @n.x1.xm33.nsg13_lv_pmos[l]
print @n.x1.xm33.nsg13_lv_pmos[delvto]
print @n.x1.xm33.nsg13_lv_pmos[factuo]
print @n.x1.xm34.nsg13_lv_pmos[w]
print @n.x1.xm34.nsg13_lv_pmos[l]
print @n.x1.xm34.nsg13_lv_pmos[delvto]
print @n.x1.xm34.nsg13_lv_pmos[factuo]
print @n.x1.xm35.nsg13_lv_pmos[w]
print @n.x1.xm35.nsg13_lv_pmos[l]
print @n.x1.xm35.nsg13_lv_pmos[delvto]
print @n.x1.xm35.nsg13_lv_pmos[factuo]
print @n.x1.xm36.nsg13_lv_pmos[w]
print @n.x1.xm36.nsg13_lv_pmos[l]
print @n.x1.xm36.nsg13_lv_pmos[delvto]
print @n.x1.xm36.nsg13_lv_pmos[factuo]
print @n.x1.xm37.nsg13_lv_pmos[w]
print @n.x1.xm37.nsg13_lv_pmos[l]
print @n.x1.xm37.nsg13_lv_pmos[delvto]
print @n.x1.xm37.nsg13_lv_pmos[factuo]
print @n.x1.xm38.nsg13_lv_pmos[w]
print @n.x1.xm38.nsg13_lv_pmos[l]
print @n.x1.xm38.nsg13_lv_pmos[delvto]
print @n.x1.xm38.nsg13_lv_pmos[factuo]
print @n.x1.xm39.nsg13_lv_pmos[w]
print @n.x1.xm39.nsg13_lv_pmos[l]
print @n.x1.xm39.nsg13_lv_pmos[delvto]
print @n.x1.xm39.nsg13_lv_pmos[factuo]
print @n.x1.xm40.nsg13_lv_pmos[w]
print @n.x1.xm40.nsg13_lv_pmos[l]
print @n.x1.xm40.nsg13_lv_pmos[delvto]
print @n.x1.xm40.nsg13_lv_pmos[factuo]
print @n.x1.xm41.nsg13_lv_pmos[w]
print @n.x1.xm41.nsg13_lv_pmos[l]
print @n.x1.xm41.nsg13_lv_pmos[delvto]
print @n.x1.xm41.nsg13_lv_pmos[factuo]
print @n.x1.xm42.nsg13_lv_pmos[w]
print @n.x1.xm42.nsg13_lv_pmos[l]
print @n.x1.xm42.nsg13_lv_pmos[delvto]
print @n.x1.xm42.nsg13_lv_pmos[factuo]
print @n.x1.xm43.nsg13_lv_pmos[w]
print @n.x1.xm43.nsg13_lv_pmos[l]
print @n.x1.xm43.nsg13_lv_pmos[delvto]
print @n.x1.xm43.nsg13_lv_pmos[factuo]
print @n.x1.xm44.nsg13_lv_pmos[w]
print @n.x1.xm44.nsg13_lv_pmos[l]
print @n.x1.xm44.nsg13_lv_pmos[delvto]
print @n.x1.xm44.nsg13_lv_pmos[factuo]
print @n.x1.xm45.nsg13_lv_pmos[w]
print @n.x1.xm45.nsg13_lv_pmos[l]
print @n.x1.xm45.nsg13_lv_pmos[delvto]
print @n.x1.xm45.nsg13_lv_pmos[factuo]
print @n.x1.xm46.nsg13_lv_pmos[w]
print @n.x1.xm46.nsg13_lv_pmos[l]
print @n.x1.xm46.nsg13_lv_pmos[delvto]
print @n.x1.xm46.nsg13_lv_pmos[factuo]
print @n.x1.xm47.nsg13_lv_pmos[w]
print @n.x1.xm47.nsg13_lv_pmos[l]
print @n.x1.xm47.nsg13_lv_pmos[delvto]
print @n.x1.xm47.nsg13_lv_pmos[factuo]
print @n.x1.xm48.nsg13_lv_pmos[w]
print @n.x1.xm48.nsg13_lv_pmos[l]
print @n.x1.xm48.nsg13_lv_pmos[delvto]
print @n.x1.xm48.nsg13_lv_pmos[factuo]
print @n.x1.xm49.nsg13_lv_pmos[w]
print @n.x1.xm49.nsg13_lv_pmos[l]
print @n.x1.xm49.nsg13_lv_pmos[delvto]
print @n.x1.xm49.nsg13_lv_pmos[factuo]
print @n.x1.xm50.nsg13_lv_pmos[w]
print @n.x1.xm50.nsg13_lv_pmos[l]
print @n.x1.xm50.nsg13_lv_pmos[delvto]
print @n.x1.xm50.nsg13_lv_pmos[factuo]
print @n.x1.xm51.nsg13_lv_pmos[w]
print @n.x1.xm51.nsg13_lv_pmos[l]
print @n.x1.xm51.nsg13_lv_pmos[delvto]
print @n.x1.xm51.nsg13_lv_pmos[factuo]
print @n.x1.xr53.nr1[nsmm_rsh]
print @n.x1.xr53.nr1[nsmm_w]
print @n.x1.xr53.nr1[nsmm_l]
print @n.x1.xr54.nr1[nsmm_rsh]
print @n.x1.xr54.nr1[nsmm_w]
print @n.x1.xr54.nr1[nsmm_l]
print @n.x1.xr55.nr1[nsmm_rsh]
print @n.x1.xr55.nr1[nsmm_w]
print @n.x1.xr55.nr1[nsmm_l]
print @n.x1.xr56.nr1[nsmm_rsh]
print @n.x1.xr56.nr1[nsmm_w]
print @n.x1.xr56.nr1[nsmm_l]
print @n.x1.xr57.nr1[nsmm_rsh]
print @n.x1.xr57.nr1[nsmm_w]
print @n.x1.xr57.nr1[nsmm_l]
print @n.x1.xr58.nr1[nsmm_rsh]
print @n.x1.xr58.nr1[nsmm_w]
print @n.x1.xr58.nr1[nsmm_l]
print @n.x1.xr59.nr1[nsmm_rsh]
print @n.x1.xr59.nr1[nsmm_w]
print @n.x1.xr59.nr1[nsmm_l]
print @n.x1.xr60.nr1[nsmm_rsh]
print @n.x1.xr60.nr1[nsmm_w]
print @n.x1.xr60.nr1[nsmm_l]
print @n.x1.xr61.nr1[nsmm_rsh]
print @n.x1.xr61.nr1[nsmm_w]
print @n.x1.xr61.nr1[nsmm_l]
print @n.x1.xr62.nr1[nsmm_rsh]
print @n.x1.xr62.nr1[nsmm_w]
print @n.x1.xr62.nr1[nsmm_l]
print @n.x1.xr63.nr1[nsmm_rsh]
print @n.x1.xr63.nr1[nsmm_w]
print @n.x1.xr63.nr1[nsmm_l]
print @n.x1.xr64.nr1[nsmm_rsh]
print @n.x1.xr64.nr1[nsmm_w]
print @n.x1.xr64.nr1[nsmm_l]
print @n.x1.xr65.nr1[nsmm_rsh]
print @n.x1.xr65.nr1[nsmm_w]
print @n.x1.xr65.nr1[nsmm_l]
print @n.x1.xr66.nr1[nsmm_rsh]
print @n.x1.xr66.nr1[nsmm_w]
print @n.x1.xr66.nr1[nsmm_l]
print @n.x1.xr67.nr1[nsmm_rsh]
print @n.x1.xr67.nr1[nsmm_w]
print @n.x1.xr67.nr1[nsmm_l]
print @n.x1.xr68.nr1[nsmm_rsh]
print @n.x1.xr68.nr1[nsmm_w]
print @n.x1.xr68.nr1[nsmm_l]
print @n.x1.xr69.nr1[nsmm_rsh]
print @n.x1.xr69.nr1[nsmm_w]
print @n.x1.xr69.nr1[nsmm_l]
print @n.x1.xr70.nr1[nsmm_rsh]
print @n.x1.xr70.nr1[nsmm_w]
print @n.x1.xr70.nr1[nsmm_l]
print @c.x1.xcf_a.c1[scale]
print @c.x1.xct0_a.c1[scale]
print @c.x1.xct1_a.c1[scale]
print @c.x1.xct2_a.c1[scale]
print @c.x1.xct3_a.c1[scale]
print @c.x1.xcf_b.c1[scale]
print @c.x1.xct0_b.c1[scale]
print @c.x1.xct1_b.c1[scale]
print @c.x1.xct2_b.c1[scale]
print @c.x1.xct3_b.c1[scale]
print @c.x1.xcth.c1[scale]
echo OSC_FP_AFTER_END
echo CLOCK_FP_AFTER_BEGIN
print @n.xroot.xn0.nsg13_lv_nmos[delvto]
print @n.xroot.xn0.nsg13_lv_nmos[factuo]
print @n.xroot.xn1.nsg13_lv_nmos[delvto]
print @n.xroot.xn1.nsg13_lv_nmos[factuo]
print @n.xroot.xp1.nsg13_lv_pmos[delvto]
print @n.xroot.xp1.nsg13_lv_pmos[factuo]
print @n.xroot.xp0.nsg13_lv_pmos[delvto]
print @n.xroot.xp0.nsg13_lv_pmos[factuo]
print @n.xleaf0.xn0.nsg13_lv_nmos[delvto]
print @n.xleaf0.xn0.nsg13_lv_nmos[factuo]
print @n.xleaf0.xn1.nsg13_lv_nmos[delvto]
print @n.xleaf0.xn1.nsg13_lv_nmos[factuo]
print @n.xleaf0.xp1.nsg13_lv_pmos[delvto]
print @n.xleaf0.xp1.nsg13_lv_pmos[factuo]
print @n.xleaf0.xp0.nsg13_lv_pmos[delvto]
print @n.xleaf0.xp0.nsg13_lv_pmos[factuo]
print @n.xleaf1.xn0.nsg13_lv_nmos[delvto]
print @n.xleaf1.xn0.nsg13_lv_nmos[factuo]
print @n.xleaf1.xn1.nsg13_lv_nmos[delvto]
print @n.xleaf1.xn1.nsg13_lv_nmos[factuo]
print @n.xleaf1.xp1.nsg13_lv_pmos[delvto]
print @n.xleaf1.xp1.nsg13_lv_pmos[factuo]
print @n.xleaf1.xp0.nsg13_lv_pmos[delvto]
print @n.xleaf1.xp0.nsg13_lv_pmos[factuo]
print @n.xleaf2.xn0.nsg13_lv_nmos[delvto]
print @n.xleaf2.xn0.nsg13_lv_nmos[factuo]
print @n.xleaf2.xn1.nsg13_lv_nmos[delvto]
print @n.xleaf2.xn1.nsg13_lv_nmos[factuo]
print @n.xleaf2.xp1.nsg13_lv_pmos[delvto]
print @n.xleaf2.xp1.nsg13_lv_pmos[factuo]
print @n.xleaf2.xp0.nsg13_lv_pmos[delvto]
print @n.xleaf2.xp0.nsg13_lv_pmos[factuo]
print @n.xleaf3.xn0.nsg13_lv_nmos[delvto]
print @n.xleaf3.xn0.nsg13_lv_nmos[factuo]
print @n.xleaf3.xn1.nsg13_lv_nmos[delvto]
print @n.xleaf3.xn1.nsg13_lv_nmos[factuo]
print @n.xleaf3.xp1.nsg13_lv_pmos[delvto]
print @n.xleaf3.xp1.nsg13_lv_pmos[factuo]
print @n.xleaf3.xp0.nsg13_lv_pmos[delvto]
print @n.xleaf3.xp0.nsg13_lv_pmos[factuo]
print @n.xleaf4.xn0.nsg13_lv_nmos[delvto]
print @n.xleaf4.xn0.nsg13_lv_nmos[factuo]
print @n.xleaf4.xn1.nsg13_lv_nmos[delvto]
print @n.xleaf4.xn1.nsg13_lv_nmos[factuo]
print @n.xleaf4.xp1.nsg13_lv_pmos[delvto]
print @n.xleaf4.xp1.nsg13_lv_pmos[factuo]
print @n.xleaf4.xp0.nsg13_lv_pmos[delvto]
print @n.xleaf4.xp0.nsg13_lv_pmos[factuo]
print @n.xleaf5.xn0.nsg13_lv_nmos[delvto]
print @n.xleaf5.xn0.nsg13_lv_nmos[factuo]
print @n.xleaf5.xn1.nsg13_lv_nmos[delvto]
print @n.xleaf5.xn1.nsg13_lv_nmos[factuo]
print @n.xleaf5.xp1.nsg13_lv_pmos[delvto]
print @n.xleaf5.xp1.nsg13_lv_pmos[factuo]
print @n.xleaf5.xp0.nsg13_lv_pmos[delvto]
print @n.xleaf5.xp0.nsg13_lv_pmos[factuo]
print @n.xleaf6.xn0.nsg13_lv_nmos[delvto]
print @n.xleaf6.xn0.nsg13_lv_nmos[factuo]
print @n.xleaf6.xn1.nsg13_lv_nmos[delvto]
print @n.xleaf6.xn1.nsg13_lv_nmos[factuo]
print @n.xleaf6.xp1.nsg13_lv_pmos[delvto]
print @n.xleaf6.xp1.nsg13_lv_pmos[factuo]
print @n.xleaf6.xp0.nsg13_lv_pmos[delvto]
print @n.xleaf6.xp0.nsg13_lv_pmos[factuo]
print @n.xleaf7.xn0.nsg13_lv_nmos[delvto]
print @n.xleaf7.xn0.nsg13_lv_nmos[factuo]
print @n.xleaf7.xn1.nsg13_lv_nmos[delvto]
print @n.xleaf7.xn1.nsg13_lv_nmos[factuo]
print @n.xleaf7.xp1.nsg13_lv_pmos[delvto]
print @n.xleaf7.xp1.nsg13_lv_pmos[factuo]
print @n.xleaf7.xp0.nsg13_lv_pmos[delvto]
print @n.xleaf7.xp0.nsg13_lv_pmos[factuo]
print @n.xleaf8.xn0.nsg13_lv_nmos[delvto]
print @n.xleaf8.xn0.nsg13_lv_nmos[factuo]
print @n.xleaf8.xn1.nsg13_lv_nmos[delvto]
print @n.xleaf8.xn1.nsg13_lv_nmos[factuo]
print @n.xleaf8.xp1.nsg13_lv_pmos[delvto]
print @n.xleaf8.xp1.nsg13_lv_pmos[factuo]
print @n.xleaf8.xp0.nsg13_lv_pmos[delvto]
print @n.xleaf8.xp0.nsg13_lv_pmos[factuo]
print @n.xleaf9.xn0.nsg13_lv_nmos[delvto]
print @n.xleaf9.xn0.nsg13_lv_nmos[factuo]
print @n.xleaf9.xn1.nsg13_lv_nmos[delvto]
print @n.xleaf9.xn1.nsg13_lv_nmos[factuo]
print @n.xleaf9.xp1.nsg13_lv_pmos[delvto]
print @n.xleaf9.xp1.nsg13_lv_pmos[factuo]
print @n.xleaf9.xp0.nsg13_lv_pmos[delvto]
print @n.xleaf9.xp0.nsg13_lv_pmos[factuo]
print @n.xleaf10.xn0.nsg13_lv_nmos[delvto]
print @n.xleaf10.xn0.nsg13_lv_nmos[factuo]
print @n.xleaf10.xn1.nsg13_lv_nmos[delvto]
print @n.xleaf10.xn1.nsg13_lv_nmos[factuo]
print @n.xleaf10.xp1.nsg13_lv_pmos[delvto]
print @n.xleaf10.xp1.nsg13_lv_pmos[factuo]
print @n.xleaf10.xp0.nsg13_lv_pmos[delvto]
print @n.xleaf10.xp0.nsg13_lv_pmos[factuo]
print @n.xleaf11.xn0.nsg13_lv_nmos[delvto]
print @n.xleaf11.xn0.nsg13_lv_nmos[factuo]
print @n.xleaf11.xn1.nsg13_lv_nmos[delvto]
print @n.xleaf11.xn1.nsg13_lv_nmos[factuo]
print @n.xleaf11.xp1.nsg13_lv_pmos[delvto]
print @n.xleaf11.xp1.nsg13_lv_pmos[factuo]
print @n.xleaf11.xp0.nsg13_lv_pmos[delvto]
print @n.xleaf11.xp0.nsg13_lv_pmos[factuo]
print @n.xleaf12.xn0.nsg13_lv_nmos[delvto]
print @n.xleaf12.xn0.nsg13_lv_nmos[factuo]
print @n.xleaf12.xn1.nsg13_lv_nmos[delvto]
print @n.xleaf12.xn1.nsg13_lv_nmos[factuo]
print @n.xleaf12.xp1.nsg13_lv_pmos[delvto]
print @n.xleaf12.xp1.nsg13_lv_pmos[factuo]
print @n.xleaf12.xp0.nsg13_lv_pmos[delvto]
print @n.xleaf12.xp0.nsg13_lv_pmos[factuo]
print @n.xleaf13.xn0.nsg13_lv_nmos[delvto]
print @n.xleaf13.xn0.nsg13_lv_nmos[factuo]
print @n.xleaf13.xn1.nsg13_lv_nmos[delvto]
print @n.xleaf13.xn1.nsg13_lv_nmos[factuo]
print @n.xleaf13.xp1.nsg13_lv_pmos[delvto]
print @n.xleaf13.xp1.nsg13_lv_pmos[factuo]
print @n.xleaf13.xp0.nsg13_lv_pmos[delvto]
print @n.xleaf13.xp0.nsg13_lv_pmos[factuo]
print @n.xleaf14.xn0.nsg13_lv_nmos[delvto]
print @n.xleaf14.xn0.nsg13_lv_nmos[factuo]
print @n.xleaf14.xn1.nsg13_lv_nmos[delvto]
print @n.xleaf14.xn1.nsg13_lv_nmos[factuo]
print @n.xleaf14.xp1.nsg13_lv_pmos[delvto]
print @n.xleaf14.xp1.nsg13_lv_pmos[factuo]
print @n.xleaf14.xp0.nsg13_lv_pmos[delvto]
print @n.xleaf14.xp0.nsg13_lv_pmos[factuo]
print @n.xleaf15.xn0.nsg13_lv_nmos[delvto]
print @n.xleaf15.xn0.nsg13_lv_nmos[factuo]
print @n.xleaf15.xn1.nsg13_lv_nmos[delvto]
print @n.xleaf15.xn1.nsg13_lv_nmos[factuo]
print @n.xleaf15.xp1.nsg13_lv_pmos[delvto]
print @n.xleaf15.xp1.nsg13_lv_pmos[factuo]
print @n.xleaf15.xp0.nsg13_lv_pmos[delvto]
print @n.xleaf15.xp0.nsg13_lv_pmos[factuo]
print @n.xtree_12021.xn0.nsg13_lv_nmos[delvto]
print @n.xtree_12021.xn0.nsg13_lv_nmos[factuo]
print @n.xtree_12021.xn1.nsg13_lv_nmos[delvto]
print @n.xtree_12021.xn1.nsg13_lv_nmos[factuo]
print @n.xtree_12021.xp1.nsg13_lv_pmos[delvto]
print @n.xtree_12021.xp1.nsg13_lv_pmos[factuo]
print @n.xtree_12021.xp0.nsg13_lv_pmos[delvto]
print @n.xtree_12021.xp0.nsg13_lv_pmos[factuo]
print @n.xtree_12022.xn0.nsg13_lv_nmos[delvto]
print @n.xtree_12022.xn0.nsg13_lv_nmos[factuo]
print @n.xtree_12022.xn1.nsg13_lv_nmos[delvto]
print @n.xtree_12022.xn1.nsg13_lv_nmos[factuo]
print @n.xtree_12022.xp1.nsg13_lv_pmos[delvto]
print @n.xtree_12022.xp1.nsg13_lv_pmos[factuo]
print @n.xtree_12022.xp0.nsg13_lv_pmos[delvto]
print @n.xtree_12022.xp0.nsg13_lv_pmos[factuo]
print @n.xtree_12023.xn0.nsg13_lv_nmos[delvto]
print @n.xtree_12023.xn0.nsg13_lv_nmos[factuo]
print @n.xtree_12023.xn1.nsg13_lv_nmos[delvto]
print @n.xtree_12023.xn1.nsg13_lv_nmos[factuo]
print @n.xtree_12023.xp1.nsg13_lv_pmos[delvto]
print @n.xtree_12023.xp1.nsg13_lv_pmos[factuo]
print @n.xtree_12023.xp0.nsg13_lv_pmos[delvto]
print @n.xtree_12023.xp0.nsg13_lv_pmos[factuo]
print @n.xtree_12024.xn0.nsg13_lv_nmos[delvto]
print @n.xtree_12024.xn0.nsg13_lv_nmos[factuo]
print @n.xtree_12024.xn1.nsg13_lv_nmos[delvto]
print @n.xtree_12024.xn1.nsg13_lv_nmos[factuo]
print @n.xtree_12024.xp1.nsg13_lv_pmos[delvto]
print @n.xtree_12024.xp1.nsg13_lv_pmos[factuo]
print @n.xtree_12024.xp0.nsg13_lv_pmos[delvto]
print @n.xtree_12024.xp0.nsg13_lv_pmos[factuo]
print @n.xtree_12025.xn0.nsg13_lv_nmos[delvto]
print @n.xtree_12025.xn0.nsg13_lv_nmos[factuo]
print @n.xtree_12025.xn1.nsg13_lv_nmos[delvto]
print @n.xtree_12025.xn1.nsg13_lv_nmos[factuo]
print @n.xtree_12025.xp1.nsg13_lv_pmos[delvto]
print @n.xtree_12025.xp1.nsg13_lv_pmos[factuo]
print @n.xtree_12025.xp0.nsg13_lv_pmos[delvto]
print @n.xtree_12025.xp0.nsg13_lv_pmos[factuo]
print @n.xtree_12026.xn0.nsg13_lv_nmos[delvto]
print @n.xtree_12026.xn0.nsg13_lv_nmos[factuo]
print @n.xtree_12026.xn1.nsg13_lv_nmos[delvto]
print @n.xtree_12026.xn1.nsg13_lv_nmos[factuo]
print @n.xtree_12026.xp1.nsg13_lv_pmos[delvto]
print @n.xtree_12026.xp1.nsg13_lv_pmos[factuo]
print @n.xtree_12026.xp0.nsg13_lv_pmos[delvto]
print @n.xtree_12026.xp0.nsg13_lv_pmos[factuo]
print @n.xtree_12027.xn0.nsg13_lv_nmos[delvto]
print @n.xtree_12027.xn0.nsg13_lv_nmos[factuo]
print @n.xtree_12027.xn1.nsg13_lv_nmos[delvto]
print @n.xtree_12027.xn1.nsg13_lv_nmos[factuo]
print @n.xtree_12027.xp1.nsg13_lv_pmos[delvto]
print @n.xtree_12027.xp1.nsg13_lv_pmos[factuo]
print @n.xtree_12027.xp0.nsg13_lv_pmos[delvto]
print @n.xtree_12027.xp0.nsg13_lv_pmos[factuo]
print @n.xtree_12028.xn0.nsg13_lv_nmos[delvto]
print @n.xtree_12028.xn0.nsg13_lv_nmos[factuo]
print @n.xtree_12028.xn1.nsg13_lv_nmos[delvto]
print @n.xtree_12028.xn1.nsg13_lv_nmos[factuo]
print @n.xtree_12028.xp1.nsg13_lv_pmos[delvto]
print @n.xtree_12028.xp1.nsg13_lv_pmos[factuo]
print @n.xtree_12028.xp0.nsg13_lv_pmos[delvto]
print @n.xtree_12028.xp0.nsg13_lv_pmos[factuo]
print @n.xtree_12029.xn0.nsg13_lv_nmos[delvto]
print @n.xtree_12029.xn0.nsg13_lv_nmos[factuo]
print @n.xtree_12029.xn1.nsg13_lv_nmos[delvto]
print @n.xtree_12029.xn1.nsg13_lv_nmos[factuo]
print @n.xtree_12029.xp1.nsg13_lv_pmos[delvto]
print @n.xtree_12029.xp1.nsg13_lv_pmos[factuo]
print @n.xtree_12029.xp0.nsg13_lv_pmos[delvto]
print @n.xtree_12029.xp0.nsg13_lv_pmos[factuo]
print @n.xtree_12030.xn0.nsg13_lv_nmos[delvto]
print @n.xtree_12030.xn0.nsg13_lv_nmos[factuo]
print @n.xtree_12030.xn1.nsg13_lv_nmos[delvto]
print @n.xtree_12030.xn1.nsg13_lv_nmos[factuo]
print @n.xtree_12030.xp1.nsg13_lv_pmos[delvto]
print @n.xtree_12030.xp1.nsg13_lv_pmos[factuo]
print @n.xtree_12030.xp0.nsg13_lv_pmos[delvto]
print @n.xtree_12030.xp0.nsg13_lv_pmos[factuo]
print @n.xtree_12031.xn0.nsg13_lv_nmos[delvto]
print @n.xtree_12031.xn0.nsg13_lv_nmos[factuo]
print @n.xtree_12031.xn1.nsg13_lv_nmos[delvto]
print @n.xtree_12031.xn1.nsg13_lv_nmos[factuo]
print @n.xtree_12031.xp1.nsg13_lv_pmos[delvto]
print @n.xtree_12031.xp1.nsg13_lv_pmos[factuo]
print @n.xtree_12031.xp0.nsg13_lv_pmos[delvto]
print @n.xtree_12031.xp0.nsg13_lv_pmos[factuo]
print @n.xtree_12032.xn0.nsg13_lv_nmos[delvto]
print @n.xtree_12032.xn0.nsg13_lv_nmos[factuo]
print @n.xtree_12032.xn1.nsg13_lv_nmos[delvto]
print @n.xtree_12032.xn1.nsg13_lv_nmos[factuo]
print @n.xtree_12032.xp1.nsg13_lv_pmos[delvto]
print @n.xtree_12032.xp1.nsg13_lv_pmos[factuo]
print @n.xtree_12032.xp0.nsg13_lv_pmos[delvto]
print @n.xtree_12032.xp0.nsg13_lv_pmos[factuo]
print @n.xtree_12033.xn0.nsg13_lv_nmos[delvto]
print @n.xtree_12033.xn0.nsg13_lv_nmos[factuo]
print @n.xtree_12033.xn1.nsg13_lv_nmos[delvto]
print @n.xtree_12033.xn1.nsg13_lv_nmos[factuo]
print @n.xtree_12033.xp1.nsg13_lv_pmos[delvto]
print @n.xtree_12033.xp1.nsg13_lv_pmos[factuo]
print @n.xtree_12033.xp0.nsg13_lv_pmos[delvto]
print @n.xtree_12033.xp0.nsg13_lv_pmos[factuo]
print @n.xtree_12034.xn0.nsg13_lv_nmos[delvto]
print @n.xtree_12034.xn0.nsg13_lv_nmos[factuo]
print @n.xtree_12034.xn1.nsg13_lv_nmos[delvto]
print @n.xtree_12034.xn1.nsg13_lv_nmos[factuo]
print @n.xtree_12034.xp1.nsg13_lv_pmos[delvto]
print @n.xtree_12034.xp1.nsg13_lv_pmos[factuo]
print @n.xtree_12034.xp0.nsg13_lv_pmos[delvto]
print @n.xtree_12034.xp0.nsg13_lv_pmos[factuo]
print @n.xtree_12035.xn0.nsg13_lv_nmos[delvto]
print @n.xtree_12035.xn0.nsg13_lv_nmos[factuo]
print @n.xtree_12035.xn1.nsg13_lv_nmos[delvto]
print @n.xtree_12035.xn1.nsg13_lv_nmos[factuo]
print @n.xtree_12035.xp1.nsg13_lv_pmos[delvto]
print @n.xtree_12035.xp1.nsg13_lv_pmos[factuo]
print @n.xtree_12035.xp0.nsg13_lv_pmos[delvto]
print @n.xtree_12035.xp0.nsg13_lv_pmos[factuo]
print @n.xtree_12036.xn0.nsg13_lv_nmos[delvto]
print @n.xtree_12036.xn0.nsg13_lv_nmos[factuo]
print @n.xtree_12036.xn1.nsg13_lv_nmos[delvto]
print @n.xtree_12036.xn1.nsg13_lv_nmos[factuo]
print @n.xtree_12036.xp1.nsg13_lv_pmos[delvto]
print @n.xtree_12036.xp1.nsg13_lv_pmos[factuo]
print @n.xtree_12036.xp0.nsg13_lv_pmos[delvto]
print @n.xtree_12036.xp0.nsg13_lv_pmos[factuo]
print @n.xtree_12037.xn0.nsg13_lv_nmos[delvto]
print @n.xtree_12037.xn0.nsg13_lv_nmos[factuo]
print @n.xtree_12037.xn1.nsg13_lv_nmos[delvto]
print @n.xtree_12037.xn1.nsg13_lv_nmos[factuo]
print @n.xtree_12037.xp1.nsg13_lv_pmos[delvto]
print @n.xtree_12037.xp1.nsg13_lv_pmos[factuo]
print @n.xtree_12037.xp0.nsg13_lv_pmos[delvto]
print @n.xtree_12037.xp0.nsg13_lv_pmos[factuo]
print @n.xtree_12038.xn0.nsg13_lv_nmos[delvto]
print @n.xtree_12038.xn0.nsg13_lv_nmos[factuo]
print @n.xtree_12038.xn1.nsg13_lv_nmos[delvto]
print @n.xtree_12038.xn1.nsg13_lv_nmos[factuo]
print @n.xtree_12038.xp1.nsg13_lv_pmos[delvto]
print @n.xtree_12038.xp1.nsg13_lv_pmos[factuo]
print @n.xtree_12038.xp0.nsg13_lv_pmos[delvto]
print @n.xtree_12038.xp0.nsg13_lv_pmos[factuo]
print @n.xtree_12039.xn0.nsg13_lv_nmos[delvto]
print @n.xtree_12039.xn0.nsg13_lv_nmos[factuo]
print @n.xtree_12039.xn1.nsg13_lv_nmos[delvto]
print @n.xtree_12039.xn1.nsg13_lv_nmos[factuo]
print @n.xtree_12039.xp1.nsg13_lv_pmos[delvto]
print @n.xtree_12039.xp1.nsg13_lv_pmos[factuo]
print @n.xtree_12039.xp0.nsg13_lv_pmos[delvto]
print @n.xtree_12039.xp0.nsg13_lv_pmos[factuo]
print @n.xtree_12040.xn0.nsg13_lv_nmos[delvto]
print @n.xtree_12040.xn0.nsg13_lv_nmos[factuo]
print @n.xtree_12040.xn1.nsg13_lv_nmos[delvto]
print @n.xtree_12040.xn1.nsg13_lv_nmos[factuo]
print @n.xtree_12040.xp1.nsg13_lv_pmos[delvto]
print @n.xtree_12040.xp1.nsg13_lv_pmos[factuo]
print @n.xtree_12040.xp0.nsg13_lv_pmos[delvto]
print @n.xtree_12040.xp0.nsg13_lv_pmos[factuo]
print @n.xtree_12041.xn0.nsg13_lv_nmos[delvto]
print @n.xtree_12041.xn0.nsg13_lv_nmos[factuo]
print @n.xtree_12041.xn1.nsg13_lv_nmos[delvto]
print @n.xtree_12041.xn1.nsg13_lv_nmos[factuo]
print @n.xtree_12041.xp1.nsg13_lv_pmos[delvto]
print @n.xtree_12041.xp1.nsg13_lv_pmos[factuo]
print @n.xtree_12041.xp0.nsg13_lv_pmos[delvto]
print @n.xtree_12041.xp0.nsg13_lv_pmos[factuo]
print @n.xtree_12042.xn0.nsg13_lv_nmos[delvto]
print @n.xtree_12042.xn0.nsg13_lv_nmos[factuo]
print @n.xtree_12042.xn1.nsg13_lv_nmos[delvto]
print @n.xtree_12042.xn1.nsg13_lv_nmos[factuo]
print @n.xtree_12042.xp1.nsg13_lv_pmos[delvto]
print @n.xtree_12042.xp1.nsg13_lv_pmos[factuo]
print @n.xtree_12042.xp0.nsg13_lv_pmos[delvto]
print @n.xtree_12042.xp0.nsg13_lv_pmos[factuo]
print @n.xtree_12043.xn0.nsg13_lv_nmos[delvto]
print @n.xtree_12043.xn0.nsg13_lv_nmos[factuo]
print @n.xtree_12043.xn1.nsg13_lv_nmos[delvto]
print @n.xtree_12043.xn1.nsg13_lv_nmos[factuo]
print @n.xtree_12043.xp1.nsg13_lv_pmos[delvto]
print @n.xtree_12043.xp1.nsg13_lv_pmos[factuo]
print @n.xtree_12043.xp0.nsg13_lv_pmos[delvto]
print @n.xtree_12043.xp0.nsg13_lv_pmos[factuo]
print @n.xtree_12044.xn0.nsg13_lv_nmos[delvto]
print @n.xtree_12044.xn0.nsg13_lv_nmos[factuo]
print @n.xtree_12044.xn1.nsg13_lv_nmos[delvto]
print @n.xtree_12044.xn1.nsg13_lv_nmos[factuo]
print @n.xtree_12044.xp1.nsg13_lv_pmos[delvto]
print @n.xtree_12044.xp1.nsg13_lv_pmos[factuo]
print @n.xtree_12044.xp0.nsg13_lv_pmos[delvto]
print @n.xtree_12044.xp0.nsg13_lv_pmos[factuo]
print @n.xtree_12045.xn0.nsg13_lv_nmos[delvto]
print @n.xtree_12045.xn0.nsg13_lv_nmos[factuo]
print @n.xtree_12045.xn1.nsg13_lv_nmos[delvto]
print @n.xtree_12045.xn1.nsg13_lv_nmos[factuo]
print @n.xtree_12045.xp1.nsg13_lv_pmos[delvto]
print @n.xtree_12045.xp1.nsg13_lv_pmos[factuo]
print @n.xtree_12045.xp0.nsg13_lv_pmos[delvto]
print @n.xtree_12045.xp0.nsg13_lv_pmos[factuo]
print @n.xtree_12046.xn0.nsg13_lv_nmos[delvto]
print @n.xtree_12046.xn0.nsg13_lv_nmos[factuo]
print @n.xtree_12046.xn1.nsg13_lv_nmos[delvto]
print @n.xtree_12046.xn1.nsg13_lv_nmos[factuo]
print @n.xtree_12046.xp1.nsg13_lv_pmos[delvto]
print @n.xtree_12046.xp1.nsg13_lv_pmos[factuo]
print @n.xtree_12046.xp0.nsg13_lv_pmos[delvto]
print @n.xtree_12046.xp0.nsg13_lv_pmos[factuo]
print @n.xtree_12047.xn0.nsg13_lv_nmos[delvto]
print @n.xtree_12047.xn0.nsg13_lv_nmos[factuo]
print @n.xtree_12047.xn1.nsg13_lv_nmos[delvto]
print @n.xtree_12047.xn1.nsg13_lv_nmos[factuo]
print @n.xtree_12047.xp1.nsg13_lv_pmos[delvto]
print @n.xtree_12047.xp1.nsg13_lv_pmos[factuo]
print @n.xtree_12047.xp0.nsg13_lv_pmos[delvto]
print @n.xtree_12047.xp0.nsg13_lv_pmos[factuo]
print @n.xtree_12048.xn0.nsg13_lv_nmos[delvto]
print @n.xtree_12048.xn0.nsg13_lv_nmos[factuo]
print @n.xtree_12048.xn1.nsg13_lv_nmos[delvto]
print @n.xtree_12048.xn1.nsg13_lv_nmos[factuo]
print @n.xtree_12048.xp1.nsg13_lv_pmos[delvto]
print @n.xtree_12048.xp1.nsg13_lv_pmos[factuo]
print @n.xtree_12048.xp0.nsg13_lv_pmos[delvto]
print @n.xtree_12048.xp0.nsg13_lv_pmos[factuo]
print @n.xtree_12049.xn0.nsg13_lv_nmos[delvto]
print @n.xtree_12049.xn0.nsg13_lv_nmos[factuo]
print @n.xtree_12049.xn1.nsg13_lv_nmos[delvto]
print @n.xtree_12049.xn1.nsg13_lv_nmos[factuo]
print @n.xtree_12049.xp1.nsg13_lv_pmos[delvto]
print @n.xtree_12049.xp1.nsg13_lv_pmos[factuo]
print @n.xtree_12049.xp0.nsg13_lv_pmos[delvto]
print @n.xtree_12049.xp0.nsg13_lv_pmos[factuo]
print @n.xtree_12050.xn0.nsg13_lv_nmos[delvto]
print @n.xtree_12050.xn0.nsg13_lv_nmos[factuo]
print @n.xtree_12050.xn1.nsg13_lv_nmos[delvto]
print @n.xtree_12050.xn1.nsg13_lv_nmos[factuo]
print @n.xtree_12050.xp1.nsg13_lv_pmos[delvto]
print @n.xtree_12050.xp1.nsg13_lv_pmos[factuo]
print @n.xtree_12050.xp0.nsg13_lv_pmos[delvto]
print @n.xtree_12050.xp0.nsg13_lv_pmos[factuo]
print @n.xtree_12051.xn0.nsg13_lv_nmos[delvto]
print @n.xtree_12051.xn0.nsg13_lv_nmos[factuo]
print @n.xtree_12051.xn1.nsg13_lv_nmos[delvto]
print @n.xtree_12051.xn1.nsg13_lv_nmos[factuo]
print @n.xtree_12051.xp1.nsg13_lv_pmos[delvto]
print @n.xtree_12051.xp1.nsg13_lv_pmos[factuo]
print @n.xtree_12051.xp0.nsg13_lv_pmos[delvto]
print @n.xtree_12051.xp0.nsg13_lv_pmos[factuo]
print @n.xtree_12052.xn0.nsg13_lv_nmos[delvto]
print @n.xtree_12052.xn0.nsg13_lv_nmos[factuo]
print @n.xtree_12052.xn1.nsg13_lv_nmos[delvto]
print @n.xtree_12052.xn1.nsg13_lv_nmos[factuo]
print @n.xtree_12052.xp1.nsg13_lv_pmos[delvto]
print @n.xtree_12052.xp1.nsg13_lv_pmos[factuo]
print @n.xtree_12052.xp0.nsg13_lv_pmos[delvto]
print @n.xtree_12052.xp0.nsg13_lv_pmos[factuo]
print @n.xtree_12053.xn0.nsg13_lv_nmos[delvto]
print @n.xtree_12053.xn0.nsg13_lv_nmos[factuo]
print @n.xtree_12053.xn1.nsg13_lv_nmos[delvto]
print @n.xtree_12053.xn1.nsg13_lv_nmos[factuo]
print @n.xtree_12053.xp1.nsg13_lv_pmos[delvto]
print @n.xtree_12053.xp1.nsg13_lv_pmos[factuo]
print @n.xtree_12053.xp0.nsg13_lv_pmos[delvto]
print @n.xtree_12053.xp0.nsg13_lv_pmos[factuo]
print @n.xtree_12054.xn0.nsg13_lv_nmos[delvto]
print @n.xtree_12054.xn0.nsg13_lv_nmos[factuo]
print @n.xtree_12054.xn1.nsg13_lv_nmos[delvto]
print @n.xtree_12054.xn1.nsg13_lv_nmos[factuo]
print @n.xtree_12054.xp1.nsg13_lv_pmos[delvto]
print @n.xtree_12054.xp1.nsg13_lv_pmos[factuo]
print @n.xtree_12054.xp0.nsg13_lv_pmos[delvto]
print @n.xtree_12054.xp0.nsg13_lv_pmos[factuo]
print @n.xtree_12055.xn0.nsg13_lv_nmos[delvto]
print @n.xtree_12055.xn0.nsg13_lv_nmos[factuo]
print @n.xtree_12055.xn1.nsg13_lv_nmos[delvto]
print @n.xtree_12055.xn1.nsg13_lv_nmos[factuo]
print @n.xtree_12055.xp1.nsg13_lv_pmos[delvto]
print @n.xtree_12055.xp1.nsg13_lv_pmos[factuo]
print @n.xtree_12055.xp0.nsg13_lv_pmos[delvto]
print @n.xtree_12055.xp0.nsg13_lv_pmos[factuo]
print @n.xtree_12056.xn0.nsg13_lv_nmos[delvto]
print @n.xtree_12056.xn0.nsg13_lv_nmos[factuo]
print @n.xtree_12056.xn1.nsg13_lv_nmos[delvto]
print @n.xtree_12056.xn1.nsg13_lv_nmos[factuo]
print @n.xtree_12056.xp1.nsg13_lv_pmos[delvto]
print @n.xtree_12056.xp1.nsg13_lv_pmos[factuo]
print @n.xtree_12056.xp0.nsg13_lv_pmos[delvto]
print @n.xtree_12056.xp0.nsg13_lv_pmos[factuo]
print @n.xtree_12057.xn0.nsg13_lv_nmos[delvto]
print @n.xtree_12057.xn0.nsg13_lv_nmos[factuo]
print @n.xtree_12057.xn1.nsg13_lv_nmos[delvto]
print @n.xtree_12057.xn1.nsg13_lv_nmos[factuo]
print @n.xtree_12057.xp1.nsg13_lv_pmos[delvto]
print @n.xtree_12057.xp1.nsg13_lv_pmos[factuo]
print @n.xtree_12057.xp0.nsg13_lv_pmos[delvto]
print @n.xtree_12057.xp0.nsg13_lv_pmos[factuo]
print @n.xtree_12058.xn0.nsg13_lv_nmos[delvto]
print @n.xtree_12058.xn0.nsg13_lv_nmos[factuo]
print @n.xtree_12058.xn1.nsg13_lv_nmos[delvto]
print @n.xtree_12058.xn1.nsg13_lv_nmos[factuo]
print @n.xtree_12058.xp1.nsg13_lv_pmos[delvto]
print @n.xtree_12058.xp1.nsg13_lv_pmos[factuo]
print @n.xtree_12058.xp0.nsg13_lv_pmos[delvto]
print @n.xtree_12058.xp0.nsg13_lv_pmos[factuo]
print @n.xtree_12059.xn0.nsg13_lv_nmos[delvto]
print @n.xtree_12059.xn0.nsg13_lv_nmos[factuo]
print @n.xtree_12059.xn1.nsg13_lv_nmos[delvto]
print @n.xtree_12059.xn1.nsg13_lv_nmos[factuo]
print @n.xtree_12059.xp1.nsg13_lv_pmos[delvto]
print @n.xtree_12059.xp1.nsg13_lv_pmos[factuo]
print @n.xtree_12059.xp0.nsg13_lv_pmos[delvto]
print @n.xtree_12059.xp0.nsg13_lv_pmos[factuo]
print @n.xtree_12060.xn0.nsg13_lv_nmos[delvto]
print @n.xtree_12060.xn0.nsg13_lv_nmos[factuo]
print @n.xtree_12060.xn1.nsg13_lv_nmos[delvto]
print @n.xtree_12060.xn1.nsg13_lv_nmos[factuo]
print @n.xtree_12060.xp1.nsg13_lv_pmos[delvto]
print @n.xtree_12060.xp1.nsg13_lv_pmos[factuo]
print @n.xtree_12060.xp0.nsg13_lv_pmos[delvto]
print @n.xtree_12060.xp0.nsg13_lv_pmos[factuo]
print @n.xtree_12061.xn0.nsg13_lv_nmos[delvto]
print @n.xtree_12061.xn0.nsg13_lv_nmos[factuo]
print @n.xtree_12061.xn1.nsg13_lv_nmos[delvto]
print @n.xtree_12061.xn1.nsg13_lv_nmos[factuo]
print @n.xtree_12061.xp1.nsg13_lv_pmos[delvto]
print @n.xtree_12061.xp1.nsg13_lv_pmos[factuo]
print @n.xtree_12061.xp0.nsg13_lv_pmos[delvto]
print @n.xtree_12061.xp0.nsg13_lv_pmos[factuo]
print @n.xtree_12062.xn0.nsg13_lv_nmos[delvto]
print @n.xtree_12062.xn0.nsg13_lv_nmos[factuo]
print @n.xtree_12062.xn1.nsg13_lv_nmos[delvto]
print @n.xtree_12062.xn1.nsg13_lv_nmos[factuo]
print @n.xtree_12062.xp1.nsg13_lv_pmos[delvto]
print @n.xtree_12062.xp1.nsg13_lv_pmos[factuo]
print @n.xtree_12062.xp0.nsg13_lv_pmos[delvto]
print @n.xtree_12062.xp0.nsg13_lv_pmos[factuo]
print @n.xtree_12063.xn0.nsg13_lv_nmos[delvto]
print @n.xtree_12063.xn0.nsg13_lv_nmos[factuo]
print @n.xtree_12063.xn1.nsg13_lv_nmos[delvto]
print @n.xtree_12063.xn1.nsg13_lv_nmos[factuo]
print @n.xtree_12063.xp1.nsg13_lv_pmos[delvto]
print @n.xtree_12063.xp1.nsg13_lv_pmos[factuo]
print @n.xtree_12063.xp0.nsg13_lv_pmos[delvto]
print @n.xtree_12063.xp0.nsg13_lv_pmos[factuo]
print @n.xtree_12064.xn0.nsg13_lv_nmos[delvto]
print @n.xtree_12064.xn0.nsg13_lv_nmos[factuo]
print @n.xtree_12064.xn1.nsg13_lv_nmos[delvto]
print @n.xtree_12064.xn1.nsg13_lv_nmos[factuo]
print @n.xtree_12064.xp1.nsg13_lv_pmos[delvto]
print @n.xtree_12064.xp1.nsg13_lv_pmos[factuo]
print @n.xtree_12064.xp0.nsg13_lv_pmos[delvto]
print @n.xtree_12064.xp0.nsg13_lv_pmos[factuo]
print @n.xtree_12065.xn0.nsg13_lv_nmos[delvto]
print @n.xtree_12065.xn0.nsg13_lv_nmos[factuo]
print @n.xtree_12065.xn1.nsg13_lv_nmos[delvto]
print @n.xtree_12065.xn1.nsg13_lv_nmos[factuo]
print @n.xtree_12065.xp1.nsg13_lv_pmos[delvto]
print @n.xtree_12065.xp1.nsg13_lv_pmos[factuo]
print @n.xtree_12065.xp0.nsg13_lv_pmos[delvto]
print @n.xtree_12065.xp0.nsg13_lv_pmos[factuo]
print @n.xtree_12066.xn0.nsg13_lv_nmos[delvto]
print @n.xtree_12066.xn0.nsg13_lv_nmos[factuo]
print @n.xtree_12066.xn1.nsg13_lv_nmos[delvto]
print @n.xtree_12066.xn1.nsg13_lv_nmos[factuo]
print @n.xtree_12066.xp1.nsg13_lv_pmos[delvto]
print @n.xtree_12066.xp1.nsg13_lv_pmos[factuo]
print @n.xtree_12066.xp0.nsg13_lv_pmos[delvto]
print @n.xtree_12066.xp0.nsg13_lv_pmos[factuo]
print @n.xtree_12067.xn0.nsg13_lv_nmos[delvto]
print @n.xtree_12067.xn0.nsg13_lv_nmos[factuo]
print @n.xtree_12067.xn1.nsg13_lv_nmos[delvto]
print @n.xtree_12067.xn1.nsg13_lv_nmos[factuo]
print @n.xtree_12067.xp1.nsg13_lv_pmos[delvto]
print @n.xtree_12067.xp1.nsg13_lv_pmos[factuo]
print @n.xtree_12067.xp0.nsg13_lv_pmos[delvto]
print @n.xtree_12067.xp0.nsg13_lv_pmos[factuo]
print @n.xtree_12068.xn0.nsg13_lv_nmos[delvto]
print @n.xtree_12068.xn0.nsg13_lv_nmos[factuo]
print @n.xtree_12068.xn1.nsg13_lv_nmos[delvto]
print @n.xtree_12068.xn1.nsg13_lv_nmos[factuo]
print @n.xtree_12068.xp1.nsg13_lv_pmos[delvto]
print @n.xtree_12068.xp1.nsg13_lv_pmos[factuo]
print @n.xtree_12068.xp0.nsg13_lv_pmos[delvto]
print @n.xtree_12068.xp0.nsg13_lv_pmos[factuo]
print @n.xtree_12069.xn0.nsg13_lv_nmos[delvto]
print @n.xtree_12069.xn0.nsg13_lv_nmos[factuo]
print @n.xtree_12069.xn1.nsg13_lv_nmos[delvto]
print @n.xtree_12069.xn1.nsg13_lv_nmos[factuo]
print @n.xtree_12069.xp1.nsg13_lv_pmos[delvto]
print @n.xtree_12069.xp1.nsg13_lv_pmos[factuo]
print @n.xtree_12069.xp0.nsg13_lv_pmos[delvto]
print @n.xtree_12069.xp0.nsg13_lv_pmos[factuo]
print @n.xtree_12070.xn0.nsg13_lv_nmos[delvto]
print @n.xtree_12070.xn0.nsg13_lv_nmos[factuo]
print @n.xtree_12070.xn1.nsg13_lv_nmos[delvto]
print @n.xtree_12070.xn1.nsg13_lv_nmos[factuo]
print @n.xtree_12070.xp1.nsg13_lv_pmos[delvto]
print @n.xtree_12070.xp1.nsg13_lv_pmos[factuo]
print @n.xtree_12070.xp0.nsg13_lv_pmos[delvto]
print @n.xtree_12070.xp0.nsg13_lv_pmos[factuo]
print @n.xtree_12071.xn0.nsg13_lv_nmos[delvto]
print @n.xtree_12071.xn0.nsg13_lv_nmos[factuo]
print @n.xtree_12071.xn1.nsg13_lv_nmos[delvto]
print @n.xtree_12071.xn1.nsg13_lv_nmos[factuo]
print @n.xtree_12071.xp1.nsg13_lv_pmos[delvto]
print @n.xtree_12071.xp1.nsg13_lv_pmos[factuo]
print @n.xtree_12071.xp0.nsg13_lv_pmos[delvto]
print @n.xtree_12071.xp0.nsg13_lv_pmos[factuo]
print @n.xtree_12072.xn0.nsg13_lv_nmos[delvto]
print @n.xtree_12072.xn0.nsg13_lv_nmos[factuo]
print @n.xtree_12072.xn1.nsg13_lv_nmos[delvto]
print @n.xtree_12072.xn1.nsg13_lv_nmos[factuo]
print @n.xtree_12072.xp1.nsg13_lv_pmos[delvto]
print @n.xtree_12072.xp1.nsg13_lv_pmos[factuo]
print @n.xtree_12072.xp0.nsg13_lv_pmos[delvto]
print @n.xtree_12072.xp0.nsg13_lv_pmos[factuo]
print @n.xtree_12073.xn0.nsg13_lv_nmos[delvto]
print @n.xtree_12073.xn0.nsg13_lv_nmos[factuo]
print @n.xtree_12073.xn1.nsg13_lv_nmos[delvto]
print @n.xtree_12073.xn1.nsg13_lv_nmos[factuo]
print @n.xtree_12073.xp1.nsg13_lv_pmos[delvto]
print @n.xtree_12073.xp1.nsg13_lv_pmos[factuo]
print @n.xtree_12073.xp0.nsg13_lv_pmos[delvto]
print @n.xtree_12073.xp0.nsg13_lv_pmos[factuo]
print @n.xtree_12074.xn0.nsg13_lv_nmos[delvto]
print @n.xtree_12074.xn0.nsg13_lv_nmos[factuo]
print @n.xtree_12074.xn1.nsg13_lv_nmos[delvto]
print @n.xtree_12074.xn1.nsg13_lv_nmos[factuo]
print @n.xtree_12074.xp1.nsg13_lv_pmos[delvto]
print @n.xtree_12074.xp1.nsg13_lv_pmos[factuo]
print @n.xtree_12074.xp0.nsg13_lv_pmos[delvto]
print @n.xtree_12074.xp0.nsg13_lv_pmos[factuo]
print @n.xtree_12075.xn0.nsg13_lv_nmos[delvto]
print @n.xtree_12075.xn0.nsg13_lv_nmos[factuo]
print @n.xtree_12075.xn1.nsg13_lv_nmos[delvto]
print @n.xtree_12075.xn1.nsg13_lv_nmos[factuo]
print @n.xtree_12075.xp1.nsg13_lv_pmos[delvto]
print @n.xtree_12075.xp1.nsg13_lv_pmos[factuo]
print @n.xtree_12075.xp0.nsg13_lv_pmos[delvto]
print @n.xtree_12075.xp0.nsg13_lv_pmos[factuo]
print @n.xtree_12076.xn0.nsg13_lv_nmos[delvto]
print @n.xtree_12076.xn0.nsg13_lv_nmos[factuo]
print @n.xtree_12076.xn1.nsg13_lv_nmos[delvto]
print @n.xtree_12076.xn1.nsg13_lv_nmos[factuo]
print @n.xtree_12076.xp1.nsg13_lv_pmos[delvto]
print @n.xtree_12076.xp1.nsg13_lv_pmos[factuo]
print @n.xtree_12076.xp0.nsg13_lv_pmos[delvto]
print @n.xtree_12076.xp0.nsg13_lv_pmos[factuo]
print @n.xtree_12077.xn0.nsg13_lv_nmos[delvto]
print @n.xtree_12077.xn0.nsg13_lv_nmos[factuo]
print @n.xtree_12077.xn1.nsg13_lv_nmos[delvto]
print @n.xtree_12077.xn1.nsg13_lv_nmos[factuo]
print @n.xtree_12077.xp1.nsg13_lv_pmos[delvto]
print @n.xtree_12077.xp1.nsg13_lv_pmos[factuo]
print @n.xtree_12077.xp0.nsg13_lv_pmos[delvto]
print @n.xtree_12077.xp0.nsg13_lv_pmos[factuo]
print @n.xtree_12078.xn0.nsg13_lv_nmos[delvto]
print @n.xtree_12078.xn0.nsg13_lv_nmos[factuo]
print @n.xtree_12078.xn1.nsg13_lv_nmos[delvto]
print @n.xtree_12078.xn1.nsg13_lv_nmos[factuo]
print @n.xtree_12078.xp1.nsg13_lv_pmos[delvto]
print @n.xtree_12078.xp1.nsg13_lv_pmos[factuo]
print @n.xtree_12078.xp0.nsg13_lv_pmos[delvto]
print @n.xtree_12078.xp0.nsg13_lv_pmos[factuo]
print @n.xtree_12079.xn0.nsg13_lv_nmos[delvto]
print @n.xtree_12079.xn0.nsg13_lv_nmos[factuo]
print @n.xtree_12079.xn1.nsg13_lv_nmos[delvto]
print @n.xtree_12079.xn1.nsg13_lv_nmos[factuo]
print @n.xtree_12079.xp1.nsg13_lv_pmos[delvto]
print @n.xtree_12079.xp1.nsg13_lv_pmos[factuo]
print @n.xtree_12079.xp0.nsg13_lv_pmos[delvto]
print @n.xtree_12079.xp0.nsg13_lv_pmos[factuo]
print @n.xtree_12080.xn0.nsg13_lv_nmos[delvto]
print @n.xtree_12080.xn0.nsg13_lv_nmos[factuo]
print @n.xtree_12080.xn1.nsg13_lv_nmos[delvto]
print @n.xtree_12080.xn1.nsg13_lv_nmos[factuo]
print @n.xtree_12080.xp1.nsg13_lv_pmos[delvto]
print @n.xtree_12080.xp1.nsg13_lv_pmos[factuo]
print @n.xtree_12080.xp0.nsg13_lv_pmos[delvto]
print @n.xtree_12080.xp0.nsg13_lv_pmos[factuo]
print @n.xtree_12081.xn0.nsg13_lv_nmos[delvto]
print @n.xtree_12081.xn0.nsg13_lv_nmos[factuo]
print @n.xtree_12081.xn1.nsg13_lv_nmos[delvto]
print @n.xtree_12081.xn1.nsg13_lv_nmos[factuo]
print @n.xtree_12081.xp1.nsg13_lv_pmos[delvto]
print @n.xtree_12081.xp1.nsg13_lv_pmos[factuo]
print @n.xtree_12081.xp0.nsg13_lv_pmos[delvto]
print @n.xtree_12081.xp0.nsg13_lv_pmos[factuo]
print @n.xtree_12082.xn0.nsg13_lv_nmos[delvto]
print @n.xtree_12082.xn0.nsg13_lv_nmos[factuo]
print @n.xtree_12082.xn1.nsg13_lv_nmos[delvto]
print @n.xtree_12082.xn1.nsg13_lv_nmos[factuo]
print @n.xtree_12082.xp1.nsg13_lv_pmos[delvto]
print @n.xtree_12082.xp1.nsg13_lv_pmos[factuo]
print @n.xtree_12082.xp0.nsg13_lv_pmos[delvto]
print @n.xtree_12082.xp0.nsg13_lv_pmos[factuo]
print @n.xtree_12083.xn0.nsg13_lv_nmos[delvto]
print @n.xtree_12083.xn0.nsg13_lv_nmos[factuo]
print @n.xtree_12083.xn1.nsg13_lv_nmos[delvto]
print @n.xtree_12083.xn1.nsg13_lv_nmos[factuo]
print @n.xtree_12083.xp1.nsg13_lv_pmos[delvto]
print @n.xtree_12083.xp1.nsg13_lv_pmos[factuo]
print @n.xtree_12083.xp0.nsg13_lv_pmos[delvto]
print @n.xtree_12083.xp0.nsg13_lv_pmos[factuo]
print @n.xtree_12084.xn0.nsg13_lv_nmos[delvto]
print @n.xtree_12084.xn0.nsg13_lv_nmos[factuo]
print @n.xtree_12084.xn1.nsg13_lv_nmos[delvto]
print @n.xtree_12084.xn1.nsg13_lv_nmos[factuo]
print @n.xtree_12084.xp1.nsg13_lv_pmos[delvto]
print @n.xtree_12084.xp1.nsg13_lv_pmos[factuo]
print @n.xtree_12084.xp0.nsg13_lv_pmos[delvto]
print @n.xtree_12084.xp0.nsg13_lv_pmos[factuo]
print @n.xtree_12085.xn0.nsg13_lv_nmos[delvto]
print @n.xtree_12085.xn0.nsg13_lv_nmos[factuo]
print @n.xtree_12085.xn1.nsg13_lv_nmos[delvto]
print @n.xtree_12085.xn1.nsg13_lv_nmos[factuo]
print @n.xtree_12085.xp1.nsg13_lv_pmos[delvto]
print @n.xtree_12085.xp1.nsg13_lv_pmos[factuo]
print @n.xtree_12085.xp0.nsg13_lv_pmos[delvto]
print @n.xtree_12085.xp0.nsg13_lv_pmos[factuo]
print @n.xtree_12086.xn0.nsg13_lv_nmos[delvto]
print @n.xtree_12086.xn0.nsg13_lv_nmos[factuo]
print @n.xtree_12086.xn1.nsg13_lv_nmos[delvto]
print @n.xtree_12086.xn1.nsg13_lv_nmos[factuo]
print @n.xtree_12086.xp1.nsg13_lv_pmos[delvto]
print @n.xtree_12086.xp1.nsg13_lv_pmos[factuo]
print @n.xtree_12086.xp0.nsg13_lv_pmos[delvto]
print @n.xtree_12086.xp0.nsg13_lv_pmos[factuo]
print @n.xtree_12087.xn0.nsg13_lv_nmos[delvto]
print @n.xtree_12087.xn0.nsg13_lv_nmos[factuo]
print @n.xtree_12087.xn1.nsg13_lv_nmos[delvto]
print @n.xtree_12087.xn1.nsg13_lv_nmos[factuo]
print @n.xtree_12087.xp1.nsg13_lv_pmos[delvto]
print @n.xtree_12087.xp1.nsg13_lv_pmos[factuo]
print @n.xtree_12087.xp0.nsg13_lv_pmos[delvto]
print @n.xtree_12087.xp0.nsg13_lv_pmos[factuo]
print @n.xtree_12088.xn0.nsg13_lv_nmos[delvto]
print @n.xtree_12088.xn0.nsg13_lv_nmos[factuo]
print @n.xtree_12088.xn1.nsg13_lv_nmos[delvto]
print @n.xtree_12088.xn1.nsg13_lv_nmos[factuo]
print @n.xtree_12088.xp1.nsg13_lv_pmos[delvto]
print @n.xtree_12088.xp1.nsg13_lv_pmos[factuo]
print @n.xtree_12088.xp0.nsg13_lv_pmos[delvto]
print @n.xtree_12088.xp0.nsg13_lv_pmos[factuo]
print @n.xtree_12089.xn0.nsg13_lv_nmos[delvto]
print @n.xtree_12089.xn0.nsg13_lv_nmos[factuo]
print @n.xtree_12089.xn1.nsg13_lv_nmos[delvto]
print @n.xtree_12089.xn1.nsg13_lv_nmos[factuo]
print @n.xtree_12089.xp1.nsg13_lv_pmos[delvto]
print @n.xtree_12089.xp1.nsg13_lv_pmos[factuo]
print @n.xtree_12089.xp0.nsg13_lv_pmos[delvto]
print @n.xtree_12089.xp0.nsg13_lv_pmos[factuo]
print @n.xtree_12090.xn0.nsg13_lv_nmos[delvto]
print @n.xtree_12090.xn0.nsg13_lv_nmos[factuo]
print @n.xtree_12090.xn1.nsg13_lv_nmos[delvto]
print @n.xtree_12090.xn1.nsg13_lv_nmos[factuo]
print @n.xtree_12090.xp1.nsg13_lv_pmos[delvto]
print @n.xtree_12090.xp1.nsg13_lv_pmos[factuo]
print @n.xtree_12090.xp0.nsg13_lv_pmos[delvto]
print @n.xtree_12090.xp0.nsg13_lv_pmos[factuo]
print @n.xtree_12091.xn0.nsg13_lv_nmos[delvto]
print @n.xtree_12091.xn0.nsg13_lv_nmos[factuo]
print @n.xtree_12091.xn1.nsg13_lv_nmos[delvto]
print @n.xtree_12091.xn1.nsg13_lv_nmos[factuo]
print @n.xtree_12091.xp1.nsg13_lv_pmos[delvto]
print @n.xtree_12091.xp1.nsg13_lv_pmos[factuo]
print @n.xtree_12091.xp0.nsg13_lv_pmos[delvto]
print @n.xtree_12091.xp0.nsg13_lv_pmos[factuo]
print @n.xtree_12092.xn0.nsg13_lv_nmos[delvto]
print @n.xtree_12092.xn0.nsg13_lv_nmos[factuo]
print @n.xtree_12092.xn1.nsg13_lv_nmos[delvto]
print @n.xtree_12092.xn1.nsg13_lv_nmos[factuo]
print @n.xtree_12092.xp1.nsg13_lv_pmos[delvto]
print @n.xtree_12092.xp1.nsg13_lv_pmos[factuo]
print @n.xtree_12092.xp0.nsg13_lv_pmos[delvto]
print @n.xtree_12092.xp0.nsg13_lv_pmos[factuo]
print @n.xtree_12093.xn0.nsg13_lv_nmos[delvto]
print @n.xtree_12093.xn0.nsg13_lv_nmos[factuo]
print @n.xtree_12093.xn1.nsg13_lv_nmos[delvto]
print @n.xtree_12093.xn1.nsg13_lv_nmos[factuo]
print @n.xtree_12093.xp1.nsg13_lv_pmos[delvto]
print @n.xtree_12093.xp1.nsg13_lv_pmos[factuo]
print @n.xtree_12093.xp0.nsg13_lv_pmos[delvto]
print @n.xtree_12093.xp0.nsg13_lv_pmos[factuo]
print @n.xtree_12094.xn0.nsg13_lv_nmos[delvto]
print @n.xtree_12094.xn0.nsg13_lv_nmos[factuo]
print @n.xtree_12094.xn1.nsg13_lv_nmos[delvto]
print @n.xtree_12094.xn1.nsg13_lv_nmos[factuo]
print @n.xtree_12094.xp1.nsg13_lv_pmos[delvto]
print @n.xtree_12094.xp1.nsg13_lv_pmos[factuo]
print @n.xtree_12094.xp0.nsg13_lv_pmos[delvto]
print @n.xtree_12094.xp0.nsg13_lv_pmos[factuo]
print @n.xtree_12095.xn0.nsg13_lv_nmos[delvto]
print @n.xtree_12095.xn0.nsg13_lv_nmos[factuo]
print @n.xtree_12095.xn1.nsg13_lv_nmos[delvto]
print @n.xtree_12095.xn1.nsg13_lv_nmos[factuo]
print @n.xtree_12095.xp1.nsg13_lv_pmos[delvto]
print @n.xtree_12095.xp1.nsg13_lv_pmos[factuo]
print @n.xtree_12095.xp0.nsg13_lv_pmos[delvto]
print @n.xtree_12095.xp0.nsg13_lv_pmos[factuo]
print @n.xtree_12096.xn0.nsg13_lv_nmos[delvto]
print @n.xtree_12096.xn0.nsg13_lv_nmos[factuo]
print @n.xtree_12096.xn1.nsg13_lv_nmos[delvto]
print @n.xtree_12096.xn1.nsg13_lv_nmos[factuo]
print @n.xtree_12096.xp1.nsg13_lv_pmos[delvto]
print @n.xtree_12096.xp1.nsg13_lv_pmos[factuo]
print @n.xtree_12096.xp0.nsg13_lv_pmos[delvto]
print @n.xtree_12096.xp0.nsg13_lv_pmos[factuo]
print @n.xtree_12097.xn0.nsg13_lv_nmos[delvto]
print @n.xtree_12097.xn0.nsg13_lv_nmos[factuo]
print @n.xtree_12097.xn1.nsg13_lv_nmos[delvto]
print @n.xtree_12097.xn1.nsg13_lv_nmos[factuo]
print @n.xtree_12097.xp1.nsg13_lv_pmos[delvto]
print @n.xtree_12097.xp1.nsg13_lv_pmos[factuo]
print @n.xtree_12097.xp0.nsg13_lv_pmos[delvto]
print @n.xtree_12097.xp0.nsg13_lv_pmos[factuo]
print @n.xtree_12098.xn0.nsg13_lv_nmos[delvto]
print @n.xtree_12098.xn0.nsg13_lv_nmos[factuo]
print @n.xtree_12098.xn1.nsg13_lv_nmos[delvto]
print @n.xtree_12098.xn1.nsg13_lv_nmos[factuo]
print @n.xtree_12098.xp1.nsg13_lv_pmos[delvto]
print @n.xtree_12098.xp1.nsg13_lv_pmos[factuo]
print @n.xtree_12098.xp0.nsg13_lv_pmos[delvto]
print @n.xtree_12098.xp0.nsg13_lv_pmos[factuo]
echo CLOCK_FP_AFTER_END
wrdata receiver.dat v(osc_clk) v(sp__11993_A) v(sp__11993_X) v(en) i(vdd) i(vddclk) v(leaf0) v(leaf1) v(leaf2) v(leaf3) v(leaf4) v(leaf5) v(leaf6) v(leaf7) v(leaf8) v(leaf9) v(leaf10) v(leaf11) v(leaf12) v(leaf13) v(leaf14) v(leaf15)
quit
.endc
.end
