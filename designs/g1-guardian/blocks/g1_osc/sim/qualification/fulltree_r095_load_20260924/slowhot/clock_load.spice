Rassembly osc_clk clk_port 459.7558
Cassembly_near osc_clk 0 3.019265e-14
Cassembly_far clk_port 0 3.019265e-14
Xroot sp__11993_X sp__11993_A vddclk 0 sg13g2_buf_16
Xleaf0 leaf0 sp__12008_A vddclk 0 sg13g2_buf_8
Xleaf1 leaf1 sp__12009_A vddclk 0 sg13g2_buf_8
Xleaf2 leaf2 sp__12010_A vddclk 0 sg13g2_buf_8
Xleaf3 leaf3 sp__12011_A vddclk 0 sg13g2_buf_8
Xleaf4 leaf4 sp__12018_A vddclk 0 sg13g2_buf_8
Xleaf5 leaf5 sp__12016_A vddclk 0 sg13g2_buf_8
Xleaf6 leaf6 sp__12015_A vddclk 0 sg13g2_buf_8
Xleaf7 leaf7 sp__12017_A vddclk 0 sg13g2_buf_8
Xleaf8 leaf8 sp__12014_A vddclk 0 sg13g2_buf_8
Xleaf9 leaf9 sp__12007_A vddclk 0 sg13g2_buf_8
Xleaf10 leaf10 sp__12006_A vddclk 0 sg13g2_buf_8
Xleaf11 leaf11 sp__12019_A vddclk 0 sg13g2_buf_8
Xleaf12 leaf12 sp__12020_A vddclk 0 sg13g2_buf_8
Xleaf13 leaf13 sp__12005_A vddclk 0 sg13g2_buf_8
Xleaf14 leaf14 sp__12012_A vddclk 0 sg13g2_buf_8
Xleaf15 leaf15 sp__12013_A vddclk 0 sg13g2_buf_8
* Exact full CTRL SPEF input and 95 downstream clock nets; PF/OHM units
Rtree_29_1 clk_port sp__29_8 20.1957
Rtree_29_2 sp__29_8 sp__29_10 88.3534
Rtree_29_3 sp__29_10 sp__29_16 40.4146
Rtree_29_4 sp__29_16 sp__29_18 67.0942
Rtree_29_5 sp__29_18 sp__11993_A 40
Ctree_29_1 clk_port 0 1.84946e-17
Ctree_29_3 sp__29_18 0 7.32916e-15
Ctree_29_4 sp__29_16 0 9.42799e-15
Ctree_29_5 sp__29_10 0 9.11143e-15
Ctree_29_6 sp__29_8 0 7.03109e-15
Rtree_2686_1 sp__11993_X sp__2686_8 40.5356
Rtree_2686_2 sp__2686_8 sp__2686_15 45.3174
Rtree_2686_3 sp__2686_15 sp__2686_27 49.0949
Rtree_2686_4 sp__2686_27 sp__2686_35 46.6332
Rtree_2686_5 sp__2686_35 sp__2686_43 44.8101
Rtree_2686_6 sp__2686_43 sp__2686_45 10.0528
Rtree_2686_7 sp__2686_45 sp__2686_53 40.7519
Rtree_2686_8 sp__2686_53 sp__2686_55 0.9682
Rtree_2686_9 sp__2686_55 sp__2686_68 48.3739
Rtree_2686_10 sp__2686_68 sp__2686_72 34.8114
Rtree_2686_11 sp__2686_72 sp__2686_86 48.8557
Rtree_2686_12 sp__2686_86 sp__2686_88 3.811
Rtree_2686_13 sp__2686_88 sp__12013_A 40
Rtree_2686_14 sp__2686_88 sp__2686_106 31.6828
Rtree_2686_15 sp__2686_106 sp__2686_116 47.8482
Rtree_2686_16 sp__2686_116 sp__2686_120 21.5862
Rtree_2686_17 sp__2686_120 sp__12012_A 40
Rtree_2686_18 sp__2686_106 sp__12005_A 40
Rtree_2686_19 sp__2686_72 sp__2686_139 38.1718
Rtree_2686_20 sp__2686_139 sp__2686_143 22.9149
Rtree_2686_21 sp__2686_143 sp__12020_A 20.9682
Rtree_2686_22 sp__2686_139 sp__2686_161 49.1979
Rtree_2686_23 sp__2686_161 sp__2686_163 1.339
Rtree_2686_24 sp__2686_163 sp__2686_167 35.8929
Rtree_2686_25 sp__2686_167 sp__2686_171 40
Rtree_2686_26 sp__2686_171 sp__12019_A 21.1845
Rtree_2686_27 sp__2686_163 sp__2686_185 39.3846
Rtree_2686_28 sp__2686_185 sp__2686_195 9.7541
Rtree_2686_29 sp__2686_195 sp__12006_A 21.1845
Rtree_2686_30 sp__2686_185 sp__2686_213 46.3886
Rtree_2686_31 sp__2686_213 sp__12007_A 40
Rtree_2686_32 sp__2686_53 sp__12014_A 20
Rtree_2686_33 sp__2686_15 sp__2686_252 47.5808
Rtree_2686_34 sp__2686_252 sp__2686_258 44.9811
Rtree_2686_35 sp__2686_258 sp__2686_264 30.8665
Rtree_2686_36 sp__2686_264 sp__2686_270 20.7519
Rtree_2686_37 sp__2686_270 sp__12017_A 20
Rtree_2686_38 sp__2686_270 sp__2686_277 1.1845
Rtree_2686_39 sp__2686_277 sp__2686_294 9.1882
Rtree_2686_40 sp__2686_294 sp__2686_298 20.5974
Rtree_2686_41 sp__2686_298 sp__2686_300 30.0142
Rtree_2686_42 sp__2686_300 sp__2686_306 7.1997
Rtree_2686_43 sp__2686_306 sp__12015_A 40
Rtree_2686_44 sp__2686_300 sp__2686_322 48.5387
Rtree_2686_45 sp__2686_322 sp__2686_338 37.0298
Rtree_2686_46 sp__2686_338 sp__12016_A 21.8128
Rtree_2686_47 sp__2686_294 sp__2686_366 30.1985
Rtree_2686_48 sp__2686_366 sp__2686_370 31.5669
Rtree_2686_49 sp__2686_370 sp__2686_374 22.3278
Rtree_2686_50 sp__2686_374 sp__12018_A 40.5356
Rtree_2686_51 sp__2686_8 sp__2686_392 47.9851
Rtree_2686_52 sp__2686_392 sp__2686_394 20
Rtree_2686_53 sp__2686_394 sp__2686_404 44.7646
Rtree_2686_54 sp__2686_404 sp__2686_408 25.7268
Rtree_2686_55 sp__2686_408 sp__2686_412 49.5198
Rtree_2686_56 sp__2686_412 sp__2686_424 49.3112
Rtree_2686_57 sp__2686_424 sp__2686_428 31.3506
Rtree_2686_58 sp__2686_428 sp__2686_436 42.4308
Rtree_2686_59 sp__2686_436 sp__12011_A 21.5656
Rtree_2686_60 sp__2686_412 sp__2686_454 30.6193
Rtree_2686_61 sp__2686_454 sp__12010_A 21.1845
Rtree_2686_62 sp__2686_408 sp__2686_472 41.6583
Rtree_2686_63 sp__2686_472 sp__2686_478 38.0353
Rtree_2686_64 sp__2686_478 sp__2686_482 21.0197
Rtree_2686_65 sp__2686_482 sp__12009_A 20.9167
Rtree_2686_66 sp__2686_394 sp__2686_498 26.9113
Rtree_2686_67 sp__2686_498 sp__12008_A 21.1845
Ctree_2686_1 sp__12008_A 0 1.44757e-16
Ctree_2686_2 sp__12009_A 0 9.73044e-17
Ctree_2686_3 sp__12010_A 0 1.56882e-16
Ctree_2686_4 sp__12011_A 0 1.59584e-16
Ctree_2686_5 sp__12018_A 0 5.14788e-17
Ctree_2686_6 sp__12016_A 0 1.81539e-16
Ctree_2686_11 sp__12006_A 0 1.5024e-16
Ctree_2686_12 sp__12019_A 0 1.4639e-16
Ctree_2686_13 sp__12020_A 0 1.07452e-16
Ctree_2686_17 sp__11993_X 0 6.48786e-17
Ctree_2686_18 sp__2686_498 0 1.03614e-15
Ctree_2686_19 sp__2686_482 0 2.27215e-16
Ctree_2686_20 sp__2686_478 0 2.15446e-15
Ctree_2686_21 sp__2686_472 0 2.20279e-15
Ctree_2686_22 sp__2686_454 0 1.35461e-15
Ctree_2686_23 sp__2686_436 0 4.78089e-16
Ctree_2686_24 sp__2686_428 0 1.40673e-15
Ctree_2686_25 sp__2686_424 0 2.20341e-15
Ctree_2686_26 sp__2686_412 0 5.97345e-15
Ctree_2686_27 sp__2686_408 0 4.43954e-15
Ctree_2686_28 sp__2686_404 0 1.32742e-15
Ctree_2686_29 sp__2686_394 0 1.61804e-15
Ctree_2686_30 sp__2686_392 0 3.06397e-15
Ctree_2686_31 sp__2686_374 0 3.32198e-16
Ctree_2686_32 sp__2686_370 0 1.25159e-15
Ctree_2686_33 sp__2686_366 0 1.97668e-15
Ctree_2686_34 sp__2686_338 0 2.17893e-15
Ctree_2686_35 sp__2686_322 0 2.77528e-15
Ctree_2686_36 sp__2686_306 0 8.71353e-16
Ctree_2686_37 sp__2686_300 0 4.98423e-15
Ctree_2686_38 sp__2686_298 0 3.37948e-15
Ctree_2686_39 sp__2686_294 0 2.03585e-15
Ctree_2686_40 sp__2686_277 0 1.12191e-15
Ctree_2686_41 sp__2686_270 0 2.19404e-16
Ctree_2686_42 sp__2686_264 0 1.11585e-15
Ctree_2686_43 sp__2686_258 0 1.63508e-15
Ctree_2686_44 sp__2686_252 0 1.33539e-15
Ctree_2686_45 sp__2686_213 0 3.90421e-15
Ctree_2686_46 sp__2686_195 0 1.2681e-15
Ctree_2686_47 sp__2686_185 0 7.58002e-15
Ctree_2686_48 sp__2686_171 0 1.4639e-16
Ctree_2686_49 sp__2686_167 0 1.39027e-15
Ctree_2686_50 sp__2686_163 0 4.13594e-15
Ctree_2686_51 sp__2686_161 0 1.23537e-15
Ctree_2686_52 sp__2686_143 0 4.62992e-16
Ctree_2686_53 sp__2686_139 0 6.37437e-15
Ctree_2686_54 sp__2686_120 0 2.03535e-16
Ctree_2686_55 sp__2686_116 0 3.35065e-15
Ctree_2686_56 sp__2686_106 0 6.79108e-15
Ctree_2686_57 sp__2686_88 0 4.0958e-15
Ctree_2686_58 sp__2686_86 0 1.54227e-15
Ctree_2686_59 sp__2686_72 0 7.5843e-15
Ctree_2686_60 sp__2686_68 0 2.47704e-15
Ctree_2686_61 sp__2686_55 0 1.04871e-15
Ctree_2686_62 sp__2686_53 0 1.66469e-16
Ctree_2686_63 sp__2686_45 0 1.22169e-15
Ctree_2686_64 sp__2686_43 0 1.76522e-15
Ctree_2686_65 sp__2686_35 0 1.38494e-15
Ctree_2686_66 sp__2686_27 0 1.79523e-15
Ctree_2686_67 sp__2686_15 0 4.74066e-15
Ctree_2686_68 sp__2686_8 0 6.11047e-15
Ctree_2686_77 sp__12016_A 0 1.54008e-17
Rtree_2698_1 leaf13 sp__2698_6 26.1594
Rtree_2698_2 sp__2698_6 sp__2698_12 29.1361
Rtree_2698_3 sp__2698_12 sp__2698_22 36.7272
Rtree_2698_4 sp__2698_22 sp__12094_A 20
Rtree_2698_5 sp__2698_12 sp__12093_A 44.5526
Rtree_2698_6 sp__2698_6 sp__2698_40 32.2158
Rtree_2698_7 sp__2698_40 sp__2698_42 20
Rtree_2698_8 sp__2698_42 sp__2698_48 25.7371
Rtree_2698_9 sp__2698_48 sp__12021_A 45.047
Rtree_2698_10 sp__2698_48 sp__2698_61 37.8396
Rtree_2698_11 sp__2698_61 sp__12095_A 20
Rtree_2698_12 sp__2698_42 sp__12032_A 30.7017
Ctree_2698_1 sp__12032_A 0 1.13702e-15
Ctree_2698_3 sp__12021_A 0 4.31424e-16
Ctree_2698_4 sp__12093_A 0 3.4512e-16
Ctree_2698_6 leaf13 0 6.70451e-16
Ctree_2698_7 sp__2698_61 0 1.64195e-15
Ctree_2698_8 sp__2698_48 0 2.58504e-15
Ctree_2698_9 sp__2698_42 0 1.64869e-15
Ctree_2698_10 sp__2698_40 0 8.77107e-16
Ctree_2698_11 sp__2698_22 0 1.81391e-15
Ctree_2698_12 sp__2698_12 0 2.98838e-15
Ctree_2698_13 sp__2698_6 0 2.37692e-15
Ctree_2698_19 sp__12032_A 0 7.97663e-17
Ctree_2698_26 sp__12093_A sp__2786_114 6.38962e-16
Ctree_2698_27 sp__12093_A sp__2786_116 1.81192e-16
Ctree_2698_28 sp__2698_12 sp__11565_CLK 2.87672e-16
Ctree_2698_29 sp__2698_12 sp__2786_116 4.21269e-16
Ctree_2698_30 sp__2698_12 sp__2786_118 1.59511e-16
Ctree_2698_31 sp__2698_12 0 5.31907e-16
Ctree_2698_37 sp__2698_22 0 1.11266e-15
Ctree_2698_41 sp__2698_40 0 3.94816e-16
Ctree_2698_42 sp__2698_40 0 3.96105e-16
Ctree_2698_43 sp__2698_40 0 3.96481e-16
Ctree_2698_44 sp__2698_40 0 1.81999e-15
Ctree_2698_45 sp__2698_40 0 3.94816e-16
Ctree_2698_60 sp__2698_61 0 1.69687e-15
Ctree_2698_62 sp__2698_22 0 4.98357e-16
Ctree_2698_64 sp__2698_12 0 2.72747e-16
Ctree_2698_67 sp__2698_6 0 2.09605e-16
Ctree_2698_69 sp__2698_22 0 3.16792e-16
Rtree_2699_1 leaf10 sp__2699_8 43.3166
Rtree_2699_2 sp__2699_8 sp__12072_A 45.7268
Rtree_2699_3 sp__2699_8 sp__2699_19 10.7326
Rtree_2699_4 sp__2699_19 sp__2699_27 42.8634
Rtree_2699_5 sp__2699_27 sp__2699_35 45.647
Rtree_2699_6 sp__2699_35 sp__2699_39 37.6542
Rtree_2699_7 sp__2699_39 sp__12071_A 40
Rtree_2699_8 sp__2699_39 sp__2699_50 30.2382
Rtree_2699_9 sp__2699_50 sp__12069_A 22.266
Rtree_2699_10 sp__2699_50 sp__12070_A 24.2484
Rtree_2699_11 sp__2699_19 sp__12073_A 40.5974
Ctree_2699_1 sp__12073_A 0 5.67873e-17
Ctree_2699_2 sp__12070_A 0 5.69884e-16
Ctree_2699_3 sp__12069_A 0 2.08995e-16
Ctree_2699_5 sp__12072_A 0 6.40966e-16
Ctree_2699_6 leaf10 0 4.91383e-16
Ctree_2699_7 sp__2699_50 0 1.37941e-15
Ctree_2699_8 sp__2699_39 0 2.21986e-15
Ctree_2699_9 sp__2699_35 0 4.02018e-15
Ctree_2699_10 sp__2699_27 0 2.70188e-15
Ctree_2699_11 sp__2699_19 0 1.50781e-15
Ctree_2699_12 sp__2699_8 0 2.28234e-15
Ctree_2699_20 sp__12072_A 0 3.70494e-16
Ctree_2699_22 sp__12072_A 0 1.4409e-16
Ctree_2699_25 sp__12073_A 0 1.04971e-16
Ctree_2699_30 sp__2699_19 0 8.05415e-16
Ctree_2699_31 sp__2699_19 0 6.47352e-16
Ctree_2699_34 sp__2699_19 0 3.32193e-16
Ctree_2699_36 sp__2699_27 0 1.54008e-17
Ctree_2699_38 sp__2699_27 0 7.30101e-17
Ctree_2699_39 sp__2699_27 0 6.72703e-17
Ctree_2699_40 sp__2699_27 0 1.44877e-16
Ctree_2699_41 sp__2699_35 0 5.32875e-16
Ctree_2699_44 sp__2699_35 sp__2764_115 2.72538e-16
Ctree_2699_45 sp__2699_35 sp__2764_117 8.3737e-16
Ctree_2699_46 sp__2699_35 sp__2764_128 3.22904e-16
Ctree_2699_48 sp__2699_35 sp__2766_167 3.38011e-16
Ctree_2699_49 sp__2699_35 0 1.10936e-16
Ctree_2699_51 sp__2699_35 0 1.44691e-16
Ctree_2699_52 sp__2699_35 0 5.33062e-16
Ctree_2699_56 sp__2699_35 0 8.85253e-16
Ctree_2699_57 sp__2699_35 0 1.14552e-15
Ctree_2699_60 sp__2699_39 0 2.63494e-15
Ctree_2699_61 sp__2699_39 0 3.43546e-16
Ctree_2699_67 sp__2699_50 0 8.04742e-16
Ctree_2699_68 sp__2699_50 0 1.94513e-15
Ctree_2699_69 sp__2699_50 0 1.28379e-16
Rtree_2700_1 leaf9 sp__2700_8 41.339
Rtree_2700_2 sp__2700_8 sp__2700_14 31.2064
Rtree_2700_3 sp__2700_14 sp__12064_A 20
Rtree_2700_4 sp__2700_8 sp__12066_A 42.266
Rtree_2700_5 leaf9 sp__2700_37 48.2606
Rtree_2700_6 sp__2700_37 sp__2700_39 20
Rtree_2700_7 sp__2700_39 sp__2700_45 25.5826
Rtree_2700_8 sp__2700_45 sp__2700_51 36.8308
Rtree_2700_9 sp__2700_51 sp__12068_A 20
Rtree_2700_10 sp__2700_45 sp__12067_A 47.519
Rtree_2700_11 sp__2700_39 sp__2700_71 33.6166
Rtree_2700_12 sp__2700_71 sp__12063_A 43.9964
Ctree_2700_1 sp__12063_A 0 3.79959e-16
Ctree_2700_2 sp__12067_A 0 1.05921e-15
Ctree_2700_4 sp__12066_A 0 2.00837e-16
Ctree_2700_6 leaf9 0 1.08662e-15
Ctree_2700_7 sp__2700_71 0 1.62049e-15
Ctree_2700_8 sp__2700_51 0 1.60214e-15
Ctree_2700_9 sp__2700_45 0 3.23193e-15
Ctree_2700_10 sp__2700_39 0 1.81111e-15
Ctree_2700_11 sp__2700_37 0 9.12723e-16
Ctree_2700_12 sp__2700_14 0 1.48455e-15
Ctree_2700_13 sp__2700_8 0 1.85929e-15
Ctree_2700_14 sp__12063_A 0 5.94314e-16
Ctree_2700_19 sp__12066_A 0 3.37562e-16
Ctree_2700_20 sp__12066_A 0 1.75513e-16
Ctree_2700_27 sp__2700_8 0 5.27974e-17
Ctree_2700_28 sp__2700_14 0 8.02924e-17
Ctree_2700_29 sp__2700_14 0 3.38113e-16
Ctree_2700_31 sp__2700_14 0 3.30848e-16
Ctree_2700_33 sp__2700_14 0 2.41236e-16
Ctree_2700_34 sp__2700_37 0 1.34688e-15
Ctree_2700_35 sp__2700_37 0 1.50315e-16
Ctree_2700_37 sp__2700_37 0 2.16289e-17
Ctree_2700_41 sp__2700_45 0 5.24903e-16
Ctree_2700_45 sp__2700_51 sp__11188_CLK 2.72898e-16
Ctree_2700_52 sp__2700_51 0 7.55411e-16
Ctree_2700_53 sp__2700_51 0 1.40791e-15
Ctree_2700_58 sp__2700_71 0 1.84476e-15
Rtree_2701_1 leaf0 sp__2701_4 20
Rtree_2701_2 sp__2701_4 sp__2701_16 45.7286
Rtree_2701_3 sp__2701_16 sp__2701_22 9.6408
Rtree_2701_4 sp__2701_22 sp__2701_34 47.6735
Rtree_2701_5 sp__2701_34 sp__12059_A 41.5579
Rtree_2701_6 sp__2701_34 sp__2701_53 33.699
Rtree_2701_7 sp__2701_53 sp__12060_A 41.1845
Rtree_2701_8 sp__2701_53 sp__2701_68 49.9009
Rtree_2701_9 sp__2701_68 sp__12053_A 20.3502
Rtree_2701_10 sp__2701_22 sp__12058_A 20
Rtree_2701_11 sp__2701_4 sp__2701_84 42.8454
Rtree_2701_12 sp__2701_84 sp__12057_A 40.5356
Ctree_2701_1 sp__12057_A 0 6.43933e-17
Ctree_2701_3 sp__12053_A 0 2.56615e-17
Ctree_2701_4 sp__12060_A 0 1.32013e-16
Ctree_2701_5 sp__12059_A 0 2.18737e-15
Ctree_2701_7 sp__2701_84 0 2.16384e-15
Ctree_2701_8 sp__2701_68 0 2.80741e-15
Ctree_2701_9 sp__2701_53 0 3.8982e-15
Ctree_2701_10 sp__2701_34 0 3.72048e-15
Ctree_2701_11 sp__2701_22 0 1.56477e-15
Ctree_2701_12 sp__2701_16 0 1.54196e-15
Ctree_2701_13 sp__2701_4 0 2.62531e-15
Ctree_2701_14 sp__12053_A 0 2.21754e-17
Ctree_2701_15 sp__12057_A 0 1.54008e-17
Ctree_2701_20 sp__12059_A 0 7.989e-17
Ctree_2701_21 sp__12059_A 0 4.33288e-16
Ctree_2701_24 sp__12059_A 0 2.7207e-16
Ctree_2701_25 sp__12059_A 0 4.33891e-16
Ctree_2701_29 sp__12059_A 0 2.72564e-16
Ctree_2701_33 sp__12059_A 0 4.00858e-16
Ctree_2701_35 sp__2701_16 0 3.9595e-16
Ctree_2701_37 sp__2701_16 0 3.93946e-16
Ctree_2701_38 sp__2701_22 0 2.41297e-16
Ctree_2701_39 sp__2701_22 0 1.3562e-16
Ctree_2701_41 sp__2701_22 0 1.54285e-17
Ctree_2701_42 sp__2701_22 0 4.02019e-16
Ctree_2701_43 sp__2701_34 0 7.99455e-17
Ctree_2701_44 sp__2701_53 sp__2753_38 1.02796e-15
Ctree_2701_45 sp__2701_53 0 1.08063e-15
Ctree_2701_47 sp__2701_53 0 1.08279e-15
Ctree_2701_48 sp__2701_68 0 1.4448e-16
Ctree_2701_49 sp__2701_68 0 4.77425e-17
Ctree_2701_55 sp__2701_68 0 1.43979e-16
Ctree_2701_59 sp__2701_68 0 4.78521e-17
Ctree_2701_64 sp__2701_68 0 5.48855e-16
Ctree_2701_65 sp__2701_68 0 1.18051e-15
Ctree_2701_73 sp__2701_84 0 4.44546e-16
Ctree_2701_75 sp__2701_84 0 3.95369e-16
Ctree_2701_76 sp__2701_84 0 2.8427e-16
Ctree_2701_77 sp__2701_84 0 2.65159e-16
Ctree_2701_81 sp__2701_84 0 4.46767e-16
Ctree_2701_82 sp__2701_84 0 1.28965e-15
Ctree_2701_84 sp__12059_A 0 7.93152e-17
Ctree_2701_85 sp__2701_34 0 1.80939e-16
Ctree_2701_89 sp__2701_16 0 2.41088e-16
Ctree_2701_96 sp__2701_53 0 3.41267e-16
Ctree_2701_97 sp__2701_68 0 1.97591e-15
Ctree_2701_98 sp__2701_34 0 1.28837e-15
Ctree_2701_104 sp__12059_A 0 7.97732e-17
Ctree_2701_105 sp__12059_A 0 7.94174e-17
Ctree_2701_107 sp__12059_A 0 7.97723e-17
Ctree_2701_108 sp__2701_34 0 4.9662e-16
Ctree_2701_112 sp__2701_84 0 2.32155e-16
Ctree_2701_116 sp__2701_16 0 2.41088e-16
Ctree_2701_118 sp__2701_84 0 4.43828e-16
Rtree_2702_1 leaf1 sp__2702_6 40
Rtree_2702_2 sp__2702_6 sp__2702_12 24.1612
Rtree_2702_3 sp__2702_12 sp__2702_14 14.1625
Rtree_2702_4 sp__2702_14 sp__2702_18 36.171
Rtree_2702_5 sp__2702_18 sp__2702_22 40
Rtree_2702_6 sp__2702_22 sp__12055_A 40.5356
Rtree_2702_7 sp__2702_14 sp__2702_37 45.0126
Rtree_2702_8 sp__2702_37 sp__12056_A 20
Rtree_2702_9 sp__2702_12 sp__2702_46 34.935
Rtree_2702_10 sp__2702_46 sp__12042_A 40.3193
Rtree_2702_11 sp__2702_6 sp__2702_59 40.2189
Rtree_2702_12 sp__2702_59 sp__2702_65 41.8334
Rtree_2702_13 sp__2702_65 sp__12044_A 20
Rtree_2702_14 sp__2702_65 sp__12045_A 45.6264
Ctree_2702_1 sp__12045_A 0 2.49283e-15
Ctree_2702_3 sp__12042_A 0 2.56389e-17
Ctree_2702_5 sp__12055_A 0 4.73926e-17
Ctree_2702_7 sp__2702_65 0 2.72323e-15
Ctree_2702_8 sp__2702_59 0 2.10065e-15
Ctree_2702_9 sp__2702_46 0 1.68286e-15
Ctree_2702_10 sp__2702_37 0 5.41404e-16
Ctree_2702_11 sp__2702_22 0 4.73926e-17
Ctree_2702_12 sp__2702_18 0 1.52002e-15
Ctree_2702_13 sp__2702_14 0 3.48073e-15
Ctree_2702_14 sp__2702_12 0 3.46938e-15
Ctree_2702_15 sp__2702_6 0 2.2631e-15
Ctree_2702_22 sp__12045_A 0 4.67626e-16
Ctree_2702_26 sp__12045_A 0 1.05001e-15
Ctree_2702_29 sp__12055_A sp__2748_16 1.54008e-17
Ctree_2702_32 sp__2702_37 0 1.43908e-16
Ctree_2702_35 sp__2702_37 0 6.38414e-17
Ctree_2702_36 sp__2702_46 sp__2735_10 1.2816e-16
Ctree_2702_38 sp__2702_46 0 7.34081e-17
Ctree_2702_40 sp__2702_46 0 1.78388e-16
Ctree_2702_43 sp__2702_59 0 5.0782e-16
Ctree_2702_46 sp__2702_59 0 2.60607e-16
Ctree_2702_47 sp__2702_59 0 4.6889e-16
Ctree_2702_51 sp__12045_A 0 1.81686e-16
Ctree_2702_52 sp__2702_46 0 2.6599e-16
Ctree_2702_54 sp__12045_A 0 1.44107e-16
Ctree_2702_55 sp__12045_A 0 6.16032e-18
Ctree_2702_56 sp__12042_A 0 4.78356e-17
Ctree_2702_57 sp__12055_A 0 7.99576e-17
Ctree_2702_62 sp__12045_A 0 2.08878e-16
Ctree_2702_63 sp__12045_A 0 7.9808e-17
Ctree_2702_65 sp__12045_A 0 4.77425e-17
Ctree_2702_66 sp__12045_A 0 2.09763e-16
Ctree_2702_68 sp__2702_14 0 2.42922e-16
Ctree_2702_70 sp__2702_37 0 3.38585e-16
Ctree_2702_71 sp__2702_12 0 1.2653e-16
Ctree_2702_74 sp__2702_46 0 1.26354e-16
Ctree_2702_77 sp__2702_46 0 4.99886e-16
Ctree_2702_80 sp__2702_12 0 5.33075e-16
Ctree_2702_81 sp__2702_14 0 1.38987e-15
Ctree_2702_82 sp__2702_59 0 7.26925e-16
Ctree_2702_85 sp__2702_12 0 1.2559e-16
Ctree_2702_88 sp__2702_46 0 2.16263e-17
Ctree_2702_90 sp__12045_A 0 1.45031e-16
Ctree_2702_92 sp__2702_14 0 4.74743e-17
Ctree_2702_95 sp__12042_A 0 4.77425e-17
Rtree_2703_1 leaf2 sp__2703_4 20
Rtree_2703_2 sp__2703_4 sp__2703_10 28.7988
Rtree_2703_3 sp__2703_10 sp__2703_14 38.4274
Rtree_2703_4 sp__2703_14 sp__2703_20 40.8446
Rtree_2703_5 sp__2703_20 sp__12061_A 20
Rtree_2703_6 sp__2703_20 sp__12062_A 33.3282
Rtree_2703_7 sp__2703_10 sp__12052_A 46.5714
Rtree_2703_8 sp__2703_4 sp__2703_61 40.7872
Rtree_2703_9 sp__2703_61 sp__2703_67 38.4988
Rtree_2703_10 sp__2703_67 sp__12050_A 20
Rtree_2703_11 sp__2703_61 sp__12051_A 49.476
Ctree_2703_1 sp__12051_A 0 9.5939e-16
Ctree_2703_3 sp__12052_A 0 6.74307e-16
Ctree_2703_4 sp__12062_A 0 1.51617e-15
Ctree_2703_7 sp__2703_67 0 2.21537e-15
Ctree_2703_8 sp__2703_61 0 5.43087e-15
Ctree_2703_9 sp__2703_20 0 1.57949e-15
Ctree_2703_10 sp__2703_14 0 1.83998e-15
Ctree_2703_11 sp__2703_10 0 3.58814e-15
Ctree_2703_12 sp__2703_4 0 3.3933e-15
Ctree_2703_17 sp__12051_A 0 7.47964e-17
Ctree_2703_18 sp__12051_A 0 3.3599e-16
Ctree_2703_19 sp__12051_A 0 6.56556e-16
Ctree_2703_20 sp__12051_A 0 4.98459e-16
Ctree_2703_29 sp__12062_A 0 1.95821e-16
Ctree_2703_30 sp__12062_A 0 1.44324e-16
Ctree_2703_32 sp__2703_10 sp__10904_CLK 1.12435e-16
Ctree_2703_35 sp__2703_10 0 4.78524e-17
Ctree_2703_38 sp__2703_14 0 2.84735e-16
Ctree_2703_43 sp__2703_61 0 1.44416e-16
Ctree_2703_45 sp__2703_61 0 4.78195e-17
Ctree_2703_46 sp__2703_61 0 6.47823e-17
Ctree_2703_50 sp__2703_61 0 4.74263e-17
Ctree_2703_51 sp__2703_61 0 1.92607e-16
Ctree_2703_52 sp__2703_61 0 9.70798e-17
Ctree_2703_53 sp__2703_61 0 1.44146e-16
Ctree_2703_56 sp__2703_67 0 4.69735e-17
Ctree_2703_57 sp__2703_67 0 4.35716e-16
Ctree_2703_58 sp__2703_67 0 1.13203e-16
Ctree_2703_68 sp__2703_61 0 2.40328e-16
Ctree_2703_75 sp__12052_A 0 3.41949e-16
Ctree_2703_79 sp__2703_10 0 6.08842e-16
Ctree_2703_87 sp__2703_67 0 3.86626e-16
Ctree_2703_90 sp__2703_10 0 4.78524e-17
Ctree_2703_91 sp__2703_61 0 8.02379e-17
Ctree_2703_93 sp__2703_14 0 2.17271e-16
Ctree_2703_94 sp__2703_14 0 1.53532e-15
Ctree_2703_95 sp__2703_14 0 6.23811e-16
Ctree_2703_96 sp__2703_20 0 1.81034e-16
Ctree_2703_99 sp__2703_10 0 2.9007e-16
Rtree_2704_1 leaf3 sp__2704_4 20
Rtree_2704_2 sp__2704_4 sp__2704_14 48.4048
Rtree_2704_3 sp__2704_14 sp__12101_A 20
Rtree_2704_4 sp__2704_4 sp__2704_35 18.128
Rtree_2704_5 sp__2704_35 sp__2704_39 34.6878
Rtree_2704_6 sp__2704_39 sp__12049_A 40
Rtree_2704_7 sp__2704_35 sp__2704_48 1.4008
Rtree_2704_8 sp__2704_48 sp__2704_52 32.7102
Rtree_2704_9 sp__2704_52 sp__12046_A 42.6986
Rtree_2704_10 sp__2704_48 sp__2704_71 40.1262
Rtree_2704_11 sp__2704_71 sp__12047_A 49.2288
Rtree_2704_12 sp__2704_71 sp__2704_98 39.57
Rtree_2704_13 sp__2704_98 sp__12048_A 20
Ctree_2704_2 sp__12047_A 0 8.70882e-16
Ctree_2704_3 sp__12046_A 0 2.40975e-16
Ctree_2704_7 sp__2704_98 0 1.76241e-15
Ctree_2704_8 sp__2704_71 0 4.57145e-15
Ctree_2704_9 sp__2704_52 0 1.41589e-15
Ctree_2704_10 sp__2704_48 0 3.23915e-15
Ctree_2704_11 sp__2704_39 0 1.49393e-15
Ctree_2704_12 sp__2704_35 0 3.44941e-15
Ctree_2704_13 sp__2704_14 0 8.35202e-16
Ctree_2704_14 sp__2704_4 0 2.66461e-15
Ctree_2704_15 sp__12046_A 0 4.77425e-17
Ctree_2704_16 sp__12046_A 0 2.25556e-16
Ctree_2704_17 sp__12047_A 0 1.30062e-16
Ctree_2704_18 sp__12047_A 0 4.77425e-17
Ctree_2704_20 sp__12047_A 0 1.45104e-16
Ctree_2704_21 sp__12047_A 0 2.42105e-16
Ctree_2704_23 sp__12047_A 0 3.38241e-16
Ctree_2704_24 sp__12047_A 0 3.61318e-16
Ctree_2704_25 sp__12047_A 0 7.62389e-17
Ctree_2704_27 sp__2704_14 0 6.91791e-16
Ctree_2704_28 sp__2704_14 0 1.2785e-16
Ctree_2704_30 sp__2704_35 0 8.00842e-17
Ctree_2704_31 sp__2704_35 0 1.12695e-16
Ctree_2704_32 sp__2704_35 0 2.4211e-16
Ctree_2704_33 sp__2704_35 sp__10909_CLK 3.39475e-16
Ctree_2704_35 sp__2704_35 0 1.44994e-16
Ctree_2704_36 sp__2704_35 0 2.4211e-16
Ctree_2704_37 sp__2704_35 0 3.21111e-16
Ctree_2704_39 sp__2704_35 0 1.12426e-16
Ctree_2704_41 sp__2704_35 0 8.01938e-17
Ctree_2704_49 sp__2704_39 0 3.40704e-16
Ctree_2704_52 sp__2704_48 0 2.09413e-16
Ctree_2704_54 sp__2704_52 0 2.87361e-16
Ctree_2704_55 sp__2704_52 0 1.45393e-15
Ctree_2704_64 sp__2704_71 0 1.56122e-15
Ctree_2704_65 sp__2704_71 0 7.28321e-16
Ctree_2704_75 sp__2704_71 0 8.01933e-17
Ctree_2704_76 sp__2704_98 0 4.48348e-16
Ctree_2704_77 sp__2704_35 0 4.79124e-17
Ctree_2704_79 sp__2704_52 0 3.92347e-16
Ctree_2704_80 sp__12046_A 0 3.38092e-16
Ctree_2704_81 sp__2704_14 0 8.00842e-17
Ctree_2704_83 sp__2704_35 0 1.54008e-17
Ctree_2704_85 sp__2704_39 0 4.99098e-16
Ctree_2704_87 sp__2704_14 0 3.3366e-16
Ctree_2704_88 sp__2704_14 0 4.33751e-16
Ctree_2704_93 sp__2704_98 0 1.83978e-16
Ctree_2704_95 sp__2704_98 0 7.62389e-17
Ctree_2704_96 sp__2704_98 0 3.45607e-16
Ctree_2704_97 sp__2704_98 0 6.14093e-16
Ctree_2704_98 sp__2704_98 0 1.27744e-16
Rtree_2705_1 leaf14 sp__2705_10 41.751
Rtree_2705_2 sp__2705_10 sp__2705_12 15.9238
Rtree_2705_3 sp__2705_12 sp__2705_18 43.072
Rtree_2705_4 sp__2705_18 sp__2705_26 41.5656
Rtree_2705_5 sp__2705_26 sp__12065_A 20
Rtree_2705_6 sp__2705_12 sp__12054_A 40
Rtree_2705_7 sp__2705_10 sp__2705_44 34.3582
Rtree_2705_8 sp__2705_44 sp__12043_A 20
Rtree_2705_9 leaf14 sp__2705_56 37.0643
Rtree_2705_10 sp__2705_56 sp__2705_58 20
Rtree_2705_11 sp__2705_58 sp__12076_A 42.8634
Rtree_2705_12 sp__2705_58 sp__12087_A 49.9086
Ctree_2705_1 sp__12087_A 0 6.46889e-16
Ctree_2705_2 sp__12076_A 0 1.4459e-16
Ctree_2705_6 leaf14 0 2.33795e-15
Ctree_2705_7 sp__2705_58 0 7.91479e-16
Ctree_2705_8 sp__2705_56 0 2.15572e-15
Ctree_2705_9 sp__2705_44 0 1.5856e-15
Ctree_2705_10 sp__2705_26 0 1.65723e-16
Ctree_2705_11 sp__2705_18 0 2.35324e-15
Ctree_2705_12 sp__2705_12 0 3.38814e-15
Ctree_2705_13 sp__2705_10 0 2.96846e-15
Ctree_2705_14 sp__12076_A 0 5.03098e-16
Ctree_2705_16 sp__12087_A 0 2.07865e-16
Ctree_2705_20 sp__12087_A 0 7.52149e-17
Ctree_2705_21 sp__12087_A 0 1.81887e-15
Ctree_2705_22 sp__2705_10 0 8.0216e-17
Ctree_2705_23 sp__2705_10 0 1.54008e-17
Ctree_2705_26 sp__2705_12 0 3.23496e-15
Ctree_2705_32 sp__2705_18 0 7.97219e-17
Ctree_2705_34 sp__2705_18 0 2.11906e-16
Ctree_2705_35 sp__2705_18 0 7.989e-17
Ctree_2705_36 sp__2705_18 0 1.11995e-16
Ctree_2705_37 sp__2705_18 0 1.44601e-16
Ctree_2705_42 sp__2705_18 0 1.75483e-16
Ctree_2705_44 sp__2705_18 0 1.54008e-17
Ctree_2705_45 sp__2705_18 0 6.34263e-16
Ctree_2705_46 sp__2705_18 0 5.00629e-16
Ctree_2705_47 sp__2705_18 0 4.42584e-16
Ctree_2705_51 sp__2705_26 0 1.44015e-16
Ctree_2705_63 sp__2705_44 0 2.41166e-16
Ctree_2705_67 sp__2705_56 0 1.12799e-16
Ctree_2705_74 sp__2705_56 0 2.08676e-16
Ctree_2705_76 sp__2705_18 0 1.11917e-16
Ctree_2705_78 sp__2705_18 0 2.07674e-16
Ctree_2705_79 sp__12076_A 0 5.0063e-16
Ctree_2705_80 sp__12087_A 0 2.34311e-16
Ctree_2705_84 sp__2705_18 0 7.9225e-17
Ctree_2705_85 sp__2705_26 0 1.44015e-16
Ctree_2705_90 sp__12076_A 0 8.01938e-17
Ctree_2705_92 sp__2705_12 0 4.45731e-16
Ctree_2705_97 sp__2705_10 0 1.43369e-16
Ctree_2705_99 sp__2705_44 0 9.83698e-16
Rtree_2706_1 leaf15 sp__2706_6 40
Rtree_2706_2 sp__2706_6 sp__2706_12 31.7626
Rtree_2706_3 sp__2706_12 sp__12092_A 20
Rtree_2706_4 leaf15 sp__2706_22 20
Rtree_2706_5 sp__2706_22 sp__2706_44 40.2546
Rtree_2706_6 sp__2706_44 sp__12091_A 48.0134
Rtree_2706_7 sp__2706_44 sp__12090_A 45.0882
Rtree_2706_8 sp__2706_22 sp__2706_78 47.8383
Rtree_2706_9 sp__2706_78 sp__2706_86 42.8943
Rtree_2706_10 sp__2706_86 sp__12086_A 20
Rtree_2706_11 sp__2706_78 sp__12085_A 32.0201
Ctree_2706_1 sp__12085_A 0 1.26356e-15
Ctree_2706_3 sp__12090_A 0 5.07626e-16
Ctree_2706_4 sp__12091_A 0 6.6375e-16
Ctree_2706_7 sp__2706_86 0 2.58655e-16
Ctree_2706_8 sp__2706_78 0 2.28954e-15
Ctree_2706_9 sp__2706_44 0 3.52717e-15
Ctree_2706_10 sp__2706_22 0 3.12312e-15
Ctree_2706_11 sp__2706_12 0 1.01704e-15
Ctree_2706_12 sp__2706_6 0 1.01704e-15
Ctree_2706_13 sp__12085_A 0 4.34754e-16
Ctree_2706_16 sp__12085_A sp__2779_72 2.07986e-16
Ctree_2706_20 sp__12090_A 0 3.38563e-16
Ctree_2706_22 sp__12091_A 0 7.14088e-16
Ctree_2706_29 sp__2706_12 0 1.34055e-15
Ctree_2706_31 sp__2706_44 0 1.4404e-16
Ctree_2706_32 sp__2706_44 0 1.12426e-16
Ctree_2706_33 sp__2706_44 0 5.60495e-17
Ctree_2706_40 sp__2706_44 0 6.32751e-17
Ctree_2706_41 sp__2706_44 0 8.00842e-17
Ctree_2706_42 sp__2706_44 0 4.7803e-17
Ctree_2706_45 sp__2706_78 0 1.76564e-16
Ctree_2706_47 sp__2706_78 0 8.00842e-17
Ctree_2706_48 sp__2706_78 0 2.32418e-16
Ctree_2706_51 sp__2706_78 0 2.33569e-16
Ctree_2706_52 sp__2706_86 sp__2779_10 4.71546e-16
Ctree_2706_53 sp__2706_86 sp__2779_14 7.34778e-17
Ctree_2706_55 sp__2706_86 0 4.77425e-17
Ctree_2706_56 sp__2706_12 0 6.89104e-16
Ctree_2706_57 sp__2706_44 0 1.76067e-16
Ctree_2706_58 sp__12085_A 0 1.96583e-16
Ctree_2706_59 sp__2706_12 0 4.77288e-17
Ctree_2706_61 sp__12085_A 0 1.11883e-16
Ctree_2706_62 sp__2706_44 0 4.78521e-17
Ctree_2706_64 sp__12091_A 0 6.05863e-16
Ctree_2706_65 sp__2706_12 0 2.19989e-17
Ctree_2706_66 sp__2706_78 0 1.80882e-16
Ctree_2706_68 sp__12091_A 0 2.3464e-16
Ctree_2706_69 sp__2706_12 0 7.49788e-17
Ctree_2706_71 sp__12085_A 0 1.77088e-16
Ctree_2706_72 sp__2706_86 0 1.26358e-16
Rtree_2707_1 leaf8 sp__2707_6 40
Rtree_2707_2 sp__2707_6 sp__2707_8 2.575
Rtree_2707_3 sp__2707_8 sp__2707_10 8.2606
Rtree_2707_4 sp__2707_10 sp__2707_16 42.4231
Rtree_2707_5 sp__2707_16 sp__12096_A 20
Rtree_2707_6 sp__2707_10 sp__12097_A 41.6171
Rtree_2707_7 sp__2707_8 sp__2707_40 47.9104
Rtree_2707_8 sp__2707_40 sp__2707_48 46.1697
Rtree_2707_9 sp__2707_48 sp__12098_A 45.7268
Rtree_2707_10 sp__2707_6 sp__2707_59 16.4182
Rtree_2707_11 sp__2707_59 sp__12084_A 49.8571
Rtree_2707_12 sp__2707_59 sp__2707_80 36.4079
Rtree_2707_13 sp__2707_80 sp__12083_A 20
Ctree_2707_2 sp__12084_A 0 1.05758e-15
Ctree_2707_3 sp__12098_A 0 5.79592e-16
Ctree_2707_4 sp__12097_A 0 1.69265e-16
Ctree_2707_7 sp__2707_80 0 1.77298e-15
Ctree_2707_8 sp__2707_59 0 4.78198e-15
Ctree_2707_9 sp__2707_48 0 1.11078e-15
Ctree_2707_10 sp__2707_40 0 1.40198e-15
Ctree_2707_11 sp__2707_16 0 1.69977e-15
Ctree_2707_12 sp__2707_10 0 2.75686e-15
Ctree_2707_13 sp__2707_8 0 2.10187e-15
Ctree_2707_14 sp__2707_6 0 2.29467e-15
Ctree_2707_16 sp__12084_A sp__2777_60 2.08855e-16
Ctree_2707_17 sp__12084_A sp__2777_77 1.12501e-16
Ctree_2707_19 sp__12084_A 0 1.43171e-16
Ctree_2707_22 sp__12098_A 0 2.74228e-16
Ctree_2707_23 sp__12098_A 0 2.09374e-16
Ctree_2707_24 sp__12098_A 0 1.12519e-16
Ctree_2707_25 sp__12098_A 0 1.12426e-16
Ctree_2707_27 sp__2707_10 0 1.2816e-16
Ctree_2707_28 sp__2707_10 0 3.71223e-16
Ctree_2707_33 sp__2707_16 0 1.12198e-16
Ctree_2707_35 sp__2707_16 sp__11631_CLK 2.57898e-16
Ctree_2707_37 sp__2707_16 0 7.9706e-17
Ctree_2707_38 sp__2707_16 sp__2789_8 4.77425e-17
Ctree_2707_39 sp__2707_16 sp__2789_23 4.5128e-16
Ctree_2707_40 sp__2707_16 sp__2789_58 9.71949e-17
Ctree_2707_42 sp__2707_16 0 1.7673e-16
Ctree_2707_44 sp__2707_16 0 6.58337e-16
Ctree_2707_45 sp__2707_16 0 2.31238e-16
Ctree_2707_46 sp__2707_16 0 2.08615e-16
Ctree_2707_47 sp__2707_16 0 2.87342e-16
Ctree_2707_49 sp__2707_16 0 1.03732e-15
Ctree_2707_50 sp__2707_16 0 6.03707e-16
Ctree_2707_51 sp__2707_16 0 1.24655e-15
Ctree_2707_57 sp__2707_40 0 8.00842e-17
Ctree_2707_60 sp__2707_48 0 2.35187e-16
Ctree_2707_66 sp__2707_59 0 2.34224e-16
Ctree_2707_85 sp__2707_40 0 1.54008e-17
Ctree_2707_86 sp__2707_16 0 3.94167e-16
Ctree_2707_89 sp__12097_A 0 2.41313e-16
Ctree_2707_90 sp__2707_16 0 1.79386e-16
Ctree_2707_91 sp__2707_48 0 5.03018e-17
Ctree_2707_93 sp__2707_10 0 7.15064e-17
Ctree_2707_94 sp__2707_16 0 2.17891e-17
Ctree_2707_98 sp__2707_80 0 1.53311e-17
Rtree_2708_1 leaf6 sp__2708_6 40
Rtree_2708_2 sp__2708_6 sp__2708_16 32.6175
Rtree_2708_3 sp__2708_16 sp__2708_26 45.9328
Rtree_2708_4 sp__2708_26 sp__12027_A 20.3502
Rtree_2708_5 sp__2708_26 sp__12026_A 40.01
Rtree_2708_6 sp__2708_16 sp__12029_A 40.9347
Rtree_2708_7 sp__2708_6 sp__2708_77 20
Rtree_2708_8 sp__2708_77 sp__2708_83 48.0469
Rtree_2708_9 sp__2708_83 sp__12025_A 45.7062
Rtree_2708_10 sp__2708_77 sp__2708_106 49.1567
Rtree_2708_11 sp__2708_106 sp__12028_A 20
Ctree_2708_2 sp__12025_A 0 5.55342e-16
Ctree_2708_3 sp__12029_A 0 2.01298e-15
Ctree_2708_4 sp__12026_A 0 2.05125e-15
Ctree_2708_5 sp__12027_A 0 3.68553e-17
Ctree_2708_7 sp__2708_106 0 7.72378e-16
Ctree_2708_8 sp__2708_83 0 2.94384e-15
Ctree_2708_9 sp__2708_77 0 3.16088e-15
Ctree_2708_10 sp__2708_26 0 2.55439e-15
Ctree_2708_11 sp__2708_16 0 3.67048e-15
Ctree_2708_12 sp__2708_6 0 1.19121e-15
Ctree_2708_14 sp__12025_A 0 4.77537e-17
Ctree_2708_15 sp__12025_A sp__12106_A 1.54446e-17
Ctree_2708_16 sp__12025_A 0 4.76068e-17
Ctree_2708_19 sp__12025_A 0 1.76452e-16
Ctree_2708_20 sp__12025_A 0 1.28689e-16
Ctree_2708_22 sp__12026_A 0 1.46423e-16
Ctree_2708_24 sp__12026_A 0 4.77425e-17
Ctree_2708_28 sp__12026_A sp__12107_A 8.00842e-17
Ctree_2708_30 sp__12026_A 0 2.40746e-16
Ctree_2708_38 sp__12029_A 0 8.0194e-17
Ctree_2708_39 sp__12029_A 0 3.06392e-16
Ctree_2708_44 sp__12029_A 0 2.40957e-16
Ctree_2708_45 sp__12029_A 0 1.12689e-16
Ctree_2708_47 sp__12029_A 0 5.23348e-17
Ctree_2708_50 sp__12029_A 0 3.07057e-16
Ctree_2708_51 sp__12029_A 0 4.72458e-17
Ctree_2708_53 sp__2708_16 sp__11905_CLK 1.12426e-16
Ctree_2708_56 sp__2708_16 0 1.28787e-16
Ctree_2708_58 sp__2708_26 0 1.53311e-17
Ctree_2708_59 sp__2708_26 0 3.9332e-16
Ctree_2708_61 sp__2708_83 0 5.04221e-16
Ctree_2708_65 sp__2708_83 0 5.8539e-16
Ctree_2708_67 sp__12029_A 0 4.77425e-17
Ctree_2708_70 sp__12029_A 0 2.41469e-16
Ctree_2708_72 sp__12029_A 0 2.60809e-17
Ctree_2708_75 sp__12025_A 0 1.76541e-16
Ctree_2708_76 sp__12029_A 0 1.1236e-16
Ctree_2708_83 sp__2708_106 0 4.77425e-17
Ctree_2708_84 sp__2708_26 0 5.00215e-16
Ctree_2708_85 sp__12029_A 0 1.75815e-16
Ctree_2708_86 sp__2708_16 0 4.77425e-17
Ctree_2708_87 sp__2708_16 0 1.54556e-17
Ctree_2708_90 sp__2708_106 0 8.79502e-16
Ctree_2708_91 sp__2708_16 0 6.1009e-16
Ctree_2708_94 sp__2708_106 0 2.3682e-16
Rtree_2709_1 leaf5 sp__2709_12 37.2799
Rtree_2709_2 sp__2709_12 sp__2709_16 29.0022
Rtree_2709_3 sp__2709_16 sp__2709_20 32.2158
Rtree_2709_4 sp__2709_20 sp__12034_A 20
Rtree_2709_5 sp__2709_16 sp__2709_31 38.623
Rtree_2709_6 sp__2709_31 sp__12035_A 20
Rtree_2709_7 sp__2709_12 sp__2709_46 46.6435
Rtree_2709_8 sp__2709_46 sp__2709_54 42.1527
Rtree_2709_9 sp__2709_54 sp__2709_60 31.7626
Rtree_2709_10 sp__2709_60 sp__2709_66 30.1558
Rtree_2709_11 sp__2709_66 sp__12031_A 20
Rtree_2709_12 sp__2709_60 sp__2709_79 31.8038
Rtree_2709_13 sp__2709_79 sp__12030_A 20
Rtree_2709_14 sp__2709_54 sp__12033_A 20
Ctree_2709_6 leaf5 0 1.88567e-15
Ctree_2709_7 sp__2709_79 0 1.19671e-15
Ctree_2709_8 sp__2709_66 0 9.40661e-16
Ctree_2709_9 sp__2709_60 0 3.23528e-15
Ctree_2709_10 sp__2709_54 0 1.24171e-15
Ctree_2709_11 sp__2709_46 0 6.56417e-16
Ctree_2709_12 sp__2709_31 0 1.87567e-15
Ctree_2709_13 sp__2709_20 0 1.24813e-15
Ctree_2709_14 sp__2709_16 0 3.76612e-15
Ctree_2709_15 sp__2709_12 0 3.04061e-15
Ctree_2709_18 sp__2709_12 0 4.79124e-17
Ctree_2709_25 sp__2709_16 0 7.23198e-16
Ctree_2709_28 sp__2709_20 0 5.97636e-16
Ctree_2709_31 sp__2709_20 0 2.4194e-16
Ctree_2709_34 sp__2709_20 0 1.77399e-16
Ctree_2709_41 sp__2709_31 0 3.07238e-16
Ctree_2709_53 sp__2709_46 0 6.19063e-16
Ctree_2709_56 sp__2709_46 0 3.46091e-16
Ctree_2709_58 sp__2709_46 0 1.83978e-16
Ctree_2709_59 sp__2709_54 sp__2726_25 2.91502e-16
Ctree_2709_60 sp__2709_54 0 2.91459e-16
Ctree_2709_61 sp__2709_54 0 3.24351e-17
Ctree_2709_62 sp__2709_54 0 4.77425e-17
Ctree_2709_63 sp__2709_60 0 1.8387e-16
Ctree_2709_64 sp__2709_60 0 8.00842e-17
Ctree_2709_66 sp__2709_60 0 3.24964e-16
Ctree_2709_67 sp__2709_60 0 8.00842e-17
Ctree_2709_68 sp__2709_60 0 1.04734e-15
Ctree_2709_70 sp__2709_66 0 4.03324e-16
Ctree_2709_76 sp__2709_66 0 3.96383e-16
Ctree_2709_79 sp__2709_66 0 5.32854e-16
Ctree_2709_80 sp__2709_66 0 1.54008e-17
Ctree_2709_81 sp__2709_79 sp__11112_CLK 1.12426e-16
Ctree_2709_82 sp__2709_79 0 4.36055e-16
Ctree_2709_86 sp__2709_79 0 5.32427e-16
Ctree_2709_87 sp__2709_79 0 8.00842e-17
Ctree_2709_88 sp__2709_79 0 2.09544e-16
Ctree_2709_91 sp__2709_12 0 8.00842e-17
Ctree_2709_94 sp__2709_12 0 4.78521e-17
Ctree_2709_97 sp__2709_20 0 3.37982e-16
Ctree_2709_98 sp__2709_16 0 5.63531e-16
Ctree_2709_100 sp__2709_31 0 7.54784e-16
Ctree_2709_101 sp__2709_12 0 1.12503e-16
Ctree_2709_102 sp__2709_12 0 3.37934e-16
Ctree_2709_103 sp__2709_12 0 8.01938e-17
Rtree_2710_1 leaf7 sp__2710_8 40.5356
Rtree_2710_2 sp__2710_8 sp__2710_12 23.7801
Rtree_2710_3 sp__2710_12 sp__2710_18 32.2879
Rtree_2710_4 sp__2710_18 sp__2710_20 20
Rtree_2710_5 sp__2710_20 sp__12023_A 25.0779
Rtree_2710_6 sp__2710_20 sp__2710_41 38.8799
Rtree_2710_7 sp__2710_41 sp__12024_A 41.4008
Rtree_2710_8 sp__2710_12 sp__2710_54 30.2382
Rtree_2710_9 sp__2710_54 sp__2710_68 34.3891
Rtree_2710_10 sp__2710_68 sp__12022_A 20
Rtree_2710_11 sp__2710_54 sp__2710_79 33.3694
Rtree_2710_12 sp__2710_79 sp__12041_A 20
Rtree_2710_13 leaf7 sp__2710_103 36.5442
Rtree_2710_14 sp__2710_103 sp__12040_A 20
Ctree_2710_4 sp__12024_A 0 1.27511e-16
Ctree_2710_5 sp__12023_A 0 6.37356e-16
Ctree_2710_6 leaf7 0 1.79129e-15
Ctree_2710_7 sp__2710_103 0 1.73494e-15
Ctree_2710_8 sp__2710_79 0 1.30844e-15
Ctree_2710_9 sp__2710_68 0 1.46549e-15
Ctree_2710_10 sp__2710_54 0 3.29616e-15
Ctree_2710_11 sp__2710_41 0 1.78301e-15
Ctree_2710_12 sp__2710_20 0 2.29286e-15
Ctree_2710_13 sp__2710_18 0 9.53256e-16
Ctree_2710_14 sp__2710_12 0 1.78059e-15
Ctree_2710_15 sp__2710_8 0 3.61462e-16
Ctree_2710_16 sp__12023_A 0 3.38818e-17
Ctree_2710_20 sp__12024_A 0 2.08769e-16
Ctree_2710_21 sp__2710_18 0 7.30101e-17
Ctree_2710_22 sp__2710_18 0 1.79079e-16
Ctree_2710_23 sp__2710_18 0 2.34278e-16
Ctree_2710_26 sp__2710_41 0 8.00842e-17
Ctree_2710_28 sp__2710_41 0 3.38665e-16
Ctree_2710_29 sp__2710_41 0 3.16566e-17
Ctree_2710_30 sp__2710_41 0 1.34763e-15
Ctree_2710_31 sp__2710_41 0 9.59556e-16
Ctree_2710_32 sp__2710_54 0 2.21656e-15
Ctree_2710_34 sp__2710_68 sp__2715_8 2.42483e-16
Ctree_2710_38 sp__2710_68 0 1.11271e-15
Ctree_2710_39 sp__2710_68 0 3.64932e-17
Ctree_2710_40 sp__2710_79 sp__2734_87 2.0805e-16
Ctree_2710_41 sp__2710_79 0 3.40856e-16
Ctree_2710_42 sp__2710_79 0 4.47167e-16
Ctree_2710_43 sp__2710_79 0 1.81192e-16
Ctree_2710_45 sp__2710_79 0 1.80603e-16
Ctree_2710_51 sp__2710_103 0 1.76474e-16
Ctree_2710_52 sp__2710_103 0 8.00842e-17
Ctree_2710_53 sp__2710_103 0 5.97281e-16
Ctree_2710_54 sp__2710_103 0 1.44156e-16
Ctree_2710_57 sp__2710_103 0 1.11388e-16
Ctree_2710_58 sp__2710_103 0 4.77425e-17
Ctree_2710_59 sp__2710_103 0 1.76972e-16
Ctree_2710_61 sp__2710_103 0 4.78521e-17
Ctree_2710_62 sp__2710_103 0 2.72856e-16
Ctree_2710_63 sp__2710_103 0 1.1159e-16
Ctree_2710_65 sp__12024_A 0 1.43932e-16
Ctree_2710_66 sp__2710_103 0 9.65975e-18
Ctree_2710_68 sp__2710_8 0 8.0057e-17
Ctree_2710_70 sp__2710_41 0 1.2846e-16
Ctree_2710_76 sp__2710_54 0 1.68343e-15
Ctree_2710_77 sp__2710_79 0 2.34598e-16
Ctree_2710_79 sp__2710_18 0 2.20083e-15
Ctree_2710_82 sp__2710_103 0 8.60337e-17
Ctree_2710_86 sp__2710_41 0 4.78134e-17
Rtree_2711_1 leaf4 sp__2711_8 43.3166
Rtree_2711_2 sp__2711_8 sp__2711_12 21.6171
Rtree_2711_3 sp__2711_12 sp__12100_A 20
Rtree_2711_4 sp__2711_12 sp__2711_27 44.1406
Rtree_2711_5 sp__2711_27 sp__2711_33 49.1876
Rtree_2711_6 sp__2711_33 sp__2711_41 35.5427
Rtree_2711_7 sp__2711_41 sp__2711_43 20
Rtree_2711_8 sp__2711_43 sp__2711_49 36.1813
Rtree_2711_9 sp__2711_49 sp__12038_A 40.9682
Rtree_2711_10 sp__2711_43 sp__12037_A 20.3193
Rtree_2711_11 sp__2711_33 sp__12036_A 20
Rtree_2711_12 leaf4 sp__2711_81 48.3636
Rtree_2711_13 sp__2711_81 sp__12039_A 40
Ctree_2711_3 sp__12037_A 0 2.26193e-17
Ctree_2711_4 sp__12038_A 0 1.14768e-16
Ctree_2711_6 leaf4 0 1.08e-15
Ctree_2711_7 sp__2711_81 0 7.87449e-16
Ctree_2711_8 sp__2711_49 0 1.82749e-15
Ctree_2711_9 sp__2711_43 0 1.73534e-15
Ctree_2711_10 sp__2711_41 0 1.30788e-15
Ctree_2711_11 sp__2711_33 0 2.27449e-15
Ctree_2711_12 sp__2711_27 0 1.35805e-15
Ctree_2711_13 sp__2711_12 0 5.79214e-16
Ctree_2711_14 sp__2711_8 0 4.80322e-16
Ctree_2711_15 sp__12037_A 0 3.24516e-17
Ctree_2711_17 sp__12038_A 0 7.90445e-17
Ctree_2711_19 sp__2711_8 0 2.22695e-17
Ctree_2711_21 sp__2711_8 0 4.43001e-16
Ctree_2711_26 sp__2711_27 0 1.2816e-16
Ctree_2711_31 sp__2711_33 sp__2729_8 8.02379e-17
Ctree_2711_33 sp__2711_33 sp__2729_160 3.2279e-16
Ctree_2711_34 sp__2711_33 sp__2729_170 4.77425e-17
Ctree_2711_44 sp__2711_41 0 7.66753e-16
Ctree_2711_45 sp__2711_41 0 6.95567e-16
Ctree_2711_46 sp__2711_41 0 1.75513e-16
Ctree_2711_48 sp__2711_41 0 3.89935e-16
Ctree_2711_50 sp__2711_49 0 1.12516e-16
Ctree_2711_52 sp__2711_49 0 7.20886e-16
Ctree_2711_57 sp__2711_81 0 6.57476e-16
Ctree_2711_63 sp__2711_27 0 1.82121e-16
Ctree_2711_66 sp__2711_12 0 1.44102e-16
Ctree_2711_67 sp__2711_41 0 5.55983e-16
Ctree_2711_70 sp__2711_33 0 1.43938e-16
Ctree_2711_71 sp__2711_8 0 2.89003e-16
Ctree_2711_72 sp__2711_81 0 2.7343e-16
Rtree_2712_1 leaf11 sp__2712_8 40.3193
Rtree_2712_2 sp__2712_8 sp__2712_10 13.2046
Rtree_2712_3 sp__2712_10 sp__12078_A 40.9167
Rtree_2712_4 sp__2712_10 sp__2712_25 31.9995
Rtree_2712_5 sp__2712_25 sp__2712_27 20
Rtree_2712_6 sp__2712_27 sp__2712_33 42.9484
Rtree_2712_7 sp__2712_33 sp__12089_A 20
Rtree_2712_8 sp__2712_27 sp__12077_A 49.785
Rtree_2712_9 sp__2712_8 sp__2712_51 7.7662
Rtree_2712_10 sp__2712_51 sp__12074_A 45.9637
Rtree_2712_11 sp__2712_51 sp__2712_68 41.3622
Rtree_2712_12 sp__2712_68 sp__12075_A 31.9995
Ctree_2712_1 sp__12075_A 0 1.3085e-15
Ctree_2712_2 sp__12074_A 0 6.34036e-16
Ctree_2712_3 sp__12077_A 0 1.05132e-15
Ctree_2712_5 sp__12078_A 0 7.0471e-17
Ctree_2712_6 leaf11 0 3.46921e-17
Ctree_2712_7 sp__2712_68 0 3.45073e-15
Ctree_2712_8 sp__2712_51 0 3.6362e-15
Ctree_2712_9 sp__2712_33 0 2.26484e-15
Ctree_2712_10 sp__2712_27 0 3.31616e-15
Ctree_2712_11 sp__2712_25 0 1.24923e-15
Ctree_2712_12 sp__2712_10 0 2.36e-15
Ctree_2712_13 sp__2712_8 0 1.93493e-15
Ctree_2712_16 sp__12074_A 0 8.00842e-17
Ctree_2712_17 sp__12074_A 0 2.73694e-16
Ctree_2712_21 sp__12075_A 0 2.72708e-16
Ctree_2712_22 sp__12075_A 0 9.19991e-16
Ctree_2712_24 sp__12077_A 0 4.75886e-17
Ctree_2712_25 sp__12077_A sp__2770_8 8.00842e-17
Ctree_2712_27 sp__12077_A 0 9.89168e-16
Ctree_2712_30 sp__12077_A 0 7.91362e-17
Ctree_2712_33 sp__12078_A 0 1.2816e-16
Ctree_2712_35 sp__2712_10 0 1.29777e-15
Ctree_2712_36 sp__2712_10 0 9.22816e-16
Ctree_2712_38 sp__2712_10 0 4.78119e-16
Ctree_2712_45 sp__2712_25 0 3.6885e-16
Ctree_2712_47 sp__2712_33 sp__12124_A 1.54008e-17
Ctree_2712_49 sp__2712_33 sp__2782_10 1.83978e-16
Ctree_2712_50 sp__2712_33 sp__2782_16 7.61954e-17
Ctree_2712_51 sp__2712_33 sp__2782_60 6.68652e-16
Ctree_2712_58 sp__2712_33 0 1.44015e-16
Ctree_2712_59 sp__2712_33 0 2.14883e-15
Ctree_2712_62 sp__2712_51 0 2.12543e-16
Ctree_2712_64 sp__2712_68 sp__2765_14 2.29687e-16
Ctree_2712_65 sp__2712_68 sp__2765_44 4.96835e-16
Ctree_2712_69 sp__2712_68 0 6.07582e-16
Ctree_2712_72 sp__2712_68 0 9.07233e-16
Ctree_2712_74 sp__2712_68 0 2.35376e-16
Ctree_2712_78 sp__2712_10 0 4.97644e-16
Ctree_2712_80 sp__2712_25 0 5.63474e-16
Rtree_2713_1 leaf12 sp__2713_4 20
Rtree_2713_2 sp__2713_4 sp__2713_8 10.6502
Rtree_2713_3 sp__2713_8 sp__2713_16 44.3466
Rtree_2713_4 sp__2713_16 sp__12081_A 20
Rtree_2713_5 sp__2713_8 sp__2713_29 48.2091
Rtree_2713_6 sp__2713_29 sp__12082_A 24.6453
Rtree_2713_7 sp__2713_4 sp__2713_40 28.0093
Rtree_2713_8 sp__2713_40 sp__2713_44 22.3278
Rtree_2713_9 sp__2713_44 sp__2713_50 42.8557
Rtree_2713_10 sp__2713_50 sp__12088_A 41.4008
Rtree_2713_11 sp__2713_44 sp__12079_A 20.3193
Rtree_2713_12 sp__2713_40 sp__2713_72 34.7599
Rtree_2713_13 sp__2713_72 sp__12080_A 20
Ctree_2713_2 sp__12079_A 0 2.08455e-17
Ctree_2713_3 sp__12088_A 0 1.71329e-16
Ctree_2713_4 sp__12082_A 0 4.17715e-16
Ctree_2713_7 sp__2713_72 0 1.3027e-15
Ctree_2713_8 sp__2713_50 0 2.37849e-15
Ctree_2713_9 sp__2713_44 0 2.54017e-15
Ctree_2713_10 sp__2713_40 0 2.45487e-15
Ctree_2713_11 sp__2713_29 0 1.15375e-15
Ctree_2713_12 sp__2713_16 0 3.25952e-16
Ctree_2713_13 sp__2713_8 0 2.24224e-15
Ctree_2713_14 sp__2713_4 0 2.02026e-15
Ctree_2713_15 sp__12079_A 0 4.78524e-17
Ctree_2713_17 sp__12082_A sp__2775_8 5.16923e-16
Ctree_2713_18 sp__12082_A sp__2775_10 1.12635e-16
Ctree_2713_21 sp__12082_A 0 1.75908e-16
Ctree_2713_25 sp__2713_8 0 3.38245e-16
Ctree_2713_30 sp__2713_8 0 6.46834e-17
Ctree_2713_31 sp__2713_8 0 8.0128e-17
Ctree_2713_32 sp__2713_8 0 2.09856e-16
Ctree_2713_36 sp__2713_16 0 3.38547e-16
Ctree_2713_37 sp__2713_16 0 4.96087e-16
Ctree_2713_39 sp__2713_29 0 1.75513e-16
Ctree_2713_42 sp__2713_29 0 8.78228e-16
Ctree_2713_46 sp__2713_40 0 3.3942e-16
Ctree_2713_48 sp__2713_40 0 1.43932e-16
Ctree_2713_52 sp__2713_40 0 2.40613e-16
Ctree_2713_58 sp__2713_50 0 6.61386e-16
Ctree_2713_60 sp__2713_50 0 3.71477e-16
Ctree_2713_61 sp__2713_50 0 1.81192e-16
Ctree_2713_63 sp__2713_50 0 1.50826e-15
Ctree_2713_66 sp__2713_50 0 1.82023e-16
Ctree_2713_67 sp__2713_72 sp__2772_125 9.28206e-16
Ctree_2713_68 sp__2713_72 sp__2773_44 6.04009e-16
Ctree_2713_72 sp__2713_72 0 6.58895e-16
Ctree_2713_75 sp__12088_A 0 1.54449e-17
Ctree_2713_81 sp__2713_50 0 1.29078e-16
Ctree_2713_83 sp__12079_A 0 3.24568e-17
Ctree_2713_84 sp__2713_50 0 3.71604e-16
Ctree_2713_86 sp__2713_16 0 3.37302e-16
Ctree_2713_87 sp__2713_29 0 1.81192e-16
Ctree_2713_88 sp__2713_29 0 2.12127e-16
Ctree_2713_89 sp__2713_72 0 3.39908e-16
Rtree_2714_1 sp__12021_X sp__2714_8 28.6726
Rtree_2714_2 sp__2714_8 sp__2714_14 46.7774
Rtree_2714_3 sp__2714_14 sp__2714_16 2.266
Rtree_2714_4 sp__2714_16 sp__2714_18 1.8334
Rtree_2714_5 sp__2714_18 sp__2714_20 3.9964
Rtree_2714_6 sp__2714_20 sp__2714_22 3.9964
Rtree_2714_7 sp__2714_22 sp__2714_24 2.266
Rtree_2714_8 sp__2714_24 sp__2714_26 1.8334
Rtree_2714_9 sp__2714_26 sp__11446_CLK 20
Rtree_2714_10 sp__2714_26 sp__2714_37 4.6968
Rtree_2714_11 sp__2714_37 sp__11442_CLK 22.266
Rtree_2714_12 sp__2714_37 sp__11437_CLK 20
Rtree_2714_13 sp__2714_24 sp__11447_CLK 20
Rtree_2714_14 sp__2714_22 sp__11450_CLK 20
Rtree_2714_15 sp__2714_20 sp__11445_CLK 20
Rtree_2714_16 sp__2714_18 sp__11448_CLK 20
Rtree_2714_17 sp__2714_16 sp__11449_CLK 20
Rtree_2714_18 sp__2714_14 sp__11391_CLK 20
Rtree_2714_19 sp__2714_8 sp__11499_CLK 21.8334
Rtree_2714_20 sp__12021_X sp__2714_95 42.266
Rtree_2714_21 sp__2714_95 sp__2714_99 23.3166
Rtree_2714_22 sp__2714_99 sp__12112_A 22.6162
Rtree_2714_23 sp__2714_99 sp__11451_CLK 20
Rtree_2714_24 sp__2714_95 sp__2714_115 3.811
Rtree_2714_25 sp__2714_115 sp__2714_119 21.8334
Rtree_2714_26 sp__2714_119 sp__11500_CLK 26.5096
Rtree_2714_27 sp__2714_119 sp__11438_CLK 20
Rtree_2714_28 sp__2714_115 sp__2714_135 1.5862
Rtree_2714_29 sp__2714_135 sp__11407_CLK 46.1594
Rtree_2714_30 sp__2714_135 sp__11443_CLK 46.0358
Ctree_2714_1 sp__11443_CLK 0 4.56636e-16
Ctree_2714_2 sp__11407_CLK 0 5.583e-16
Ctree_2714_4 sp__11500_CLK 0 6.66319e-16
Ctree_2714_6 sp__12112_A 0 2.54524e-16
Ctree_2714_7 sp__11499_CLK 0 1.91702e-16
Ctree_2714_15 sp__11442_CLK 0 2.03026e-16
Ctree_2714_17 sp__12021_X 0 1.14034e-15
Ctree_2714_18 sp__2714_135 0 1.14152e-15
Ctree_2714_19 sp__2714_119 0 8.47343e-16
Ctree_2714_20 sp__2714_115 0 7.63832e-16
Ctree_2714_21 sp__2714_99 0 6.06089e-16
Ctree_2714_22 sp__2714_95 0 1.01956e-15
Ctree_2714_23 sp__2714_37 0 6.40572e-16
Ctree_2714_24 sp__2714_26 0 6.21719e-16
Ctree_2714_25 sp__2714_24 0 3.91901e-16
Ctree_2714_26 sp__2714_22 0 5.97133e-16
Ctree_2714_27 sp__2714_20 0 7.84071e-16
Ctree_2714_28 sp__2714_18 0 5.65743e-16
Ctree_2714_29 sp__2714_16 0 3.73588e-16
Ctree_2714_30 sp__2714_14 0 5.42775e-16
Ctree_2714_31 sp__2714_8 0 1.46053e-15
Ctree_2714_37 sp__11443_CLK 0 1.29713e-15
Ctree_2714_41 sp__12112_A 0 3.39552e-16
Ctree_2714_43 sp__2714_8 0 4.77425e-17
Ctree_2714_48 sp__2714_14 0 1.27744e-16
Ctree_2714_49 sp__2714_14 0 1.79811e-16
Ctree_2714_50 sp__2714_14 0 9.27887e-16
Ctree_2714_52 sp__2714_14 0 1.45694e-15
Ctree_2714_64 sp__2714_37 0 8.0216e-17
Ctree_2714_65 sp__2714_37 0 4.78685e-17
Ctree_2714_68 sp__2714_95 0 2.42236e-16
Ctree_2714_72 sp__2714_115 0 1.81608e-16
Ctree_2714_75 sp__2714_135 0 3.41949e-16
Ctree_2714_78 sp__2714_8 0 4.77425e-17
Ctree_2714_84 sp__2714_8 0 3.04995e-16
Ctree_2714_85 sp__11443_CLK 0 2.87759e-16
Ctree_2714_86 sp__2714_8 0 1.43531e-16
Ctree_2714_92 sp__11407_CLK 0 3.37693e-16
Ctree_2714_93 sp__11407_CLK 0 5.9845e-16
Rtree_2715_1 sp__12022_X sp__2715_8 22.9561
Rtree_2715_2 sp__2715_8 sp__11068_CLK 20
Rtree_2715_3 sp__2715_8 sp__2715_19 23.1724
Rtree_2715_4 sp__2715_19 sp__2715_21 1.8334
Rtree_2715_5 sp__2715_21 sp__11747_CLK 46.0358
Rtree_2715_6 sp__2715_21 sp__11067_CLK 42.266
Rtree_2715_7 sp__2715_19 sp__11641_CLK 40
Rtree_2715_8 sp__12022_X sp__2715_55 21.751
Rtree_2715_9 sp__2715_55 sp__2715_59 22.266
Rtree_2715_10 sp__2715_59 sp__2715_61 1.5862
Rtree_2715_11 sp__2715_61 sp__2715_65 21.8334
Rtree_2715_12 sp__2715_65 sp__2715_67 1.8334
Rtree_2715_13 sp__2715_67 sp__2715_71 30.4854
Rtree_2715_14 sp__2715_71 sp__11066_CLK 46.4272
Rtree_2715_15 sp__2715_71 sp__11758_CLK 40
Rtree_2715_16 sp__2715_67 sp__12114_A 20
Rtree_2715_17 sp__2715_65 sp__11069_CLK 20
Rtree_2715_18 sp__2715_61 sp__11130_CLK 48.6932
Rtree_2715_19 sp__2715_59 sp__2715_120 24.0582
Rtree_2715_20 sp__2715_120 sp__2715_122 1.8334
Rtree_2715_21 sp__2715_122 sp__11748_CLK 24.3466
Rtree_2715_22 sp__2715_122 sp__2715_133 0.3502
Rtree_2715_23 sp__2715_133 sp__2715_137 21.5862
Rtree_2715_24 sp__2715_137 sp__11028_CLK 42.6909
Rtree_2715_25 sp__2715_137 sp__11743_CLK 45.2942
Rtree_2715_26 sp__2715_133 sp__11024_CLK 20
Rtree_2715_27 sp__2715_120 sp__11023_CLK 20
Rtree_2715_28 sp__2715_55 sp__11642_CLK 20
Ctree_2715_4 sp__11743_CLK 0 4.7973e-16
Ctree_2715_5 sp__11028_CLK 0 2.53507e-16
Ctree_2715_6 sp__11748_CLK 0 4.37637e-16
Ctree_2715_7 sp__11130_CLK 0 8.49832e-16
Ctree_2715_11 sp__11066_CLK 0 6.33143e-16
Ctree_2715_13 sp__11067_CLK 0 2.86267e-16
Ctree_2715_14 sp__11747_CLK 0 5.49107e-16
Ctree_2715_16 sp__12022_X 0 3.93448e-16
Ctree_2715_17 sp__2715_137 0 8.48933e-16
Ctree_2715_18 sp__2715_133 0 1.43422e-16
Ctree_2715_19 sp__2715_122 0 6.69389e-16
Ctree_2715_20 sp__2715_120 0 4.21123e-16
Ctree_2715_21 sp__2715_71 0 1.70774e-15
Ctree_2715_22 sp__2715_67 0 1.26222e-15
Ctree_2715_23 sp__2715_65 0 2.64757e-16
Ctree_2715_24 sp__2715_61 0 1.00404e-15
Ctree_2715_25 sp__2715_59 0 5.0713e-16
Ctree_2715_26 sp__2715_55 0 3.71036e-16
Ctree_2715_27 sp__2715_21 0 9.49236e-16
Ctree_2715_28 sp__2715_19 0 3.91404e-16
Ctree_2715_29 sp__2715_8 0 5.12912e-16
Ctree_2715_30 sp__11028_CLK 0 1.40976e-16
Ctree_2715_32 sp__11066_CLK 0 2.37794e-16
Ctree_2715_33 sp__11066_CLK 0 1.54556e-17
Ctree_2715_40 sp__11130_CLK 0 8.02105e-17
Ctree_2715_43 sp__11130_CLK 0 4.76068e-17
Ctree_2715_44 sp__11130_CLK 0 2.41264e-16
Ctree_2715_45 sp__11130_CLK 0 2.72987e-16
Ctree_2715_47 sp__11743_CLK 0 8.23756e-16
Ctree_2715_56 sp__11748_CLK 0 3.39552e-16
Ctree_2715_58 sp__2715_19 0 1.54008e-17
Ctree_2715_61 sp__2715_55 0 2.08824e-16
Ctree_2715_64 sp__2715_59 0 3.39267e-16
Ctree_2715_65 sp__2715_61 0 3.18607e-16
Ctree_2715_66 sp__2715_65 0 2.35055e-16
Ctree_2715_67 sp__2715_65 0 1.81192e-16
Ctree_2715_68 sp__2715_120 0 4.99181e-16
Ctree_2715_69 sp__2715_120 0 3.68237e-16
Ctree_2715_72 sp__2715_137 0 3.46091e-16
Ctree_2715_73 sp__11747_CLK 0 2.87757e-16
Ctree_2715_74 sp__11747_CLK 0 3.93736e-16
Ctree_2715_77 sp__2715_120 0 5.49517e-16
Ctree_2715_79 sp__11130_CLK 0 1.60629e-16
Ctree_2715_80 sp__11747_CLK 0 1.59096e-16
Ctree_2715_81 sp__2715_19 0 2.88173e-16
Ctree_2715_82 sp__2715_21 0 3.95068e-16
Ctree_2715_83 sp__2715_19 0 1.2816e-16
Ctree_2715_88 sp__2715_67 0 1.76642e-16
Ctree_2715_89 sp__11066_CLK 0 3.46273e-16
Ctree_2715_91 sp__2715_61 0 2.34224e-16
Ctree_2715_92 sp__2715_65 0 3.94151e-16
Rtree_2716_1 sp__12023_X sp__2716_8 44.0582
Rtree_2716_2 sp__2716_8 sp__2716_12 20.5974
Rtree_2716_3 sp__2716_12 sp__2716_16 2.4308
Rtree_2716_4 sp__2716_16 sp__2716_18 0.3502
Rtree_2716_5 sp__2716_18 sp__2716_22 6.5714
Rtree_2716_6 sp__2716_22 sp__2716_30 44.841
Rtree_2716_7 sp__2716_30 sp__11513_CLK 20
Rtree_2716_8 sp__2716_22 sp__11668_CLK 20
Rtree_2716_9 sp__2716_18 sp__11047_CLK 24.6562
Rtree_2716_10 sp__2716_16 sp__11667_CLK 20
Rtree_2716_11 sp__2716_12 sp__11048_CLK 20.5356
Rtree_2716_12 sp__2716_8 sp__2716_65 26.1594
Rtree_2716_13 sp__2716_65 sp__2716_67 2.266
Rtree_2716_14 sp__2716_67 sp__2716_73 42.8222
Rtree_2716_15 sp__2716_73 sp__11896_CLK 20
Rtree_2716_16 sp__2716_67 sp__2716_82 2.4308
Rtree_2716_17 sp__2716_82 sp__11051_CLK 20
Rtree_2716_18 sp__2716_82 sp__2716_91 3.1106
Rtree_2716_19 sp__2716_91 sp__11895_CLK 20
Rtree_2716_20 sp__2716_91 sp__11054_CLK 22.1836
Rtree_2716_21 sp__2716_65 sp__12115_A 20.3502
Rtree_2716_22 sp__12023_X sp__11746_CLK 41.751
Rtree_2716_23 sp__12023_X sp__2716_133 20.3502
Rtree_2716_24 sp__2716_133 sp__2716_141 45.3354
Rtree_2716_25 sp__2716_141 sp__11654_CLK 23.3578
Rtree_2716_26 sp__2716_141 sp__11065_CLK 20
Rtree_2716_27 sp__2716_133 sp__2716_157 3.9964
Rtree_2716_28 sp__2716_157 sp__11064_CLK 20
Rtree_2716_29 sp__2716_157 sp__11063_CLK 22.9252
Ctree_2716_1 sp__11063_CLK 0 2.97074e-16
Ctree_2716_4 sp__11654_CLK 0 3.19995e-16
Ctree_2716_5 sp__11746_CLK 0 1.7926e-16
Ctree_2716_6 sp__12115_A 0 2.77263e-17
Ctree_2716_7 sp__11054_CLK 0 2.14204e-16
Ctree_2716_11 sp__11048_CLK 0 2.13614e-17
Ctree_2716_13 sp__11047_CLK 0 4.64457e-16
Ctree_2716_16 sp__12023_X 0 6.10479e-16
Ctree_2716_17 sp__2716_157 0 7.20625e-16
Ctree_2716_18 sp__2716_141 0 8.84467e-16
Ctree_2716_19 sp__2716_133 0 1.01752e-15
Ctree_2716_20 sp__2716_91 0 4.4692e-16
Ctree_2716_21 sp__2716_82 0 4.88109e-16
Ctree_2716_22 sp__2716_73 0 2.08488e-16
Ctree_2716_23 sp__2716_67 0 7.21244e-16
Ctree_2716_24 sp__2716_65 0 9.10673e-16
Ctree_2716_25 sp__2716_30 0 4.60937e-16
Ctree_2716_26 sp__2716_22 0 1.09551e-15
Ctree_2716_27 sp__2716_18 0 1.12761e-15
Ctree_2716_28 sp__2716_16 0 1.7027e-16
Ctree_2716_29 sp__2716_12 0 2.26604e-16
Ctree_2716_30 sp__2716_8 0 1.09085e-15
Ctree_2716_31 sp__11047_CLK 0 4.79124e-17
Ctree_2716_40 sp__2716_8 0 1.82023e-16
Ctree_2716_44 sp__2716_22 0 2.40985e-16
Ctree_2716_45 sp__2716_22 0 1.92751e-16
Ctree_2716_48 sp__2716_30 0 4.65073e-16
Ctree_2716_51 sp__2716_65 0 8.00842e-17
Ctree_2716_55 sp__2716_65 0 2.73693e-16
Ctree_2716_58 sp__2716_73 0 1.82023e-16
Ctree_2716_60 sp__2716_91 0 3.3958e-16
Ctree_2716_61 sp__2716_141 0 4.78524e-17
Ctree_2716_62 sp__2716_141 0 2.07854e-16
Ctree_2716_64 sp__2716_141 0 2.87757e-16
Ctree_2716_65 sp__2716_157 0 1.54556e-17
Ctree_2716_68 sp__2716_22 0 2.42149e-16
Ctree_2716_69 sp__2716_8 0 7.51285e-17
Ctree_2716_70 sp__2716_73 0 4.4761e-16
Ctree_2716_72 sp__2716_73 0 1.80955e-16
Ctree_2716_75 sp__11048_CLK 0 8.0194e-17
Ctree_2716_76 sp__2716_16 0 2.73946e-16
Ctree_2716_78 sp__2716_65 0 5.64322e-16
Rtree_2717_1 sp__12024_X sp__2717_6 22.266
Rtree_2717_2 sp__2717_6 sp__2717_8 2.266
Rtree_2717_3 sp__2717_8 sp__2717_12 20.9682
Rtree_2717_4 sp__2717_12 sp__2717_18 24.2848
Rtree_2717_5 sp__2717_18 sp__2717_24 24.0994
Rtree_2717_6 sp__2717_24 sp__2717_26 6.0358
Rtree_2717_7 sp__2717_26 sp__11903_CLK 42.575
Rtree_2717_8 sp__2717_26 sp__2717_39 26.1594
Rtree_2717_9 sp__2717_39 sp__11946_CLK 20
Rtree_2717_10 sp__2717_39 sp__11901_CLK 23.4196
Rtree_2717_11 sp__2717_24 sp__11050_CLK 42.1836
Rtree_2717_12 sp__2717_18 sp__11052_CLK 20
Rtree_2717_13 sp__2717_12 sp__11666_CLK 46.1962
Rtree_2717_14 sp__2717_8 sp__11920_CLK 20
Rtree_2717_15 sp__2717_6 sp__2717_95 40.8446
Rtree_2717_16 sp__2717_95 sp__11919_CLK 20
Rtree_2717_17 sp__12024_X sp__2717_109 22.06
Rtree_2717_18 sp__2717_109 sp__2717_117 4.6762
Rtree_2717_19 sp__2717_117 sp__2717_123 3.4608
Rtree_2717_20 sp__2717_123 sp__11917_CLK 20
Rtree_2717_21 sp__2717_123 sp__2717_130 1.279
Rtree_2717_22 sp__2717_130 sp__11894_CLK 20
Rtree_2717_23 sp__2717_130 sp__2717_137 1.0918
Rtree_2717_24 sp__2717_137 sp__2717_143 48.755
Rtree_2717_25 sp__2717_143 sp__11893_CLK 20
Rtree_2717_26 sp__2717_137 sp__2717_150 2.266
Rtree_2717_27 sp__2717_150 sp__11057_CLK 20
Rtree_2717_28 sp__2717_150 sp__11916_CLK 26.9216
Rtree_2717_29 sp__2717_117 sp__11918_CLK 20
Rtree_2717_30 sp__2717_109 sp__11053_CLK 21.9982
Ctree_2717_1 sp__11053_CLK 0 1.6322e-16
Ctree_2717_3 sp__11916_CLK 0 7.34649e-16
Ctree_2717_10 sp__11666_CLK 0 6.58961e-16
Ctree_2717_12 sp__11050_CLK 0 2.32168e-16
Ctree_2717_13 sp__11901_CLK 0 3.19696e-16
Ctree_2717_15 sp__11903_CLK 0 1.52001e-16
Ctree_2717_16 sp__12024_X 0 3.91941e-16
Ctree_2717_17 sp__2717_150 0 9.84532e-16
Ctree_2717_18 sp__2717_143 0 9.93421e-16
Ctree_2717_19 sp__2717_137 0 1.33166e-15
Ctree_2717_20 sp__2717_130 0 2.78018e-16
Ctree_2717_21 sp__2717_123 0 4.88023e-16
Ctree_2717_22 sp__2717_117 0 7.28728e-16
Ctree_2717_23 sp__2717_109 0 7.56714e-16
Ctree_2717_24 sp__2717_95 0 7.65142e-17
Ctree_2717_25 sp__2717_39 0 9.06222e-16
Ctree_2717_26 sp__2717_26 0 1.193e-15
Ctree_2717_27 sp__2717_24 0 9.93096e-16
Ctree_2717_28 sp__2717_18 0 6.40341e-16
Ctree_2717_29 sp__2717_12 0 1.08806e-15
Ctree_2717_30 sp__2717_8 0 2.94262e-16
Ctree_2717_31 sp__2717_6 0 5.04377e-16
Ctree_2717_34 sp__11666_CLK 0 4.76038e-17
Ctree_2717_36 sp__11666_CLK 0 1.12426e-16
Ctree_2717_37 sp__11666_CLK 0 7.89557e-17
Ctree_2717_41 sp__11666_CLK 0 2.33327e-16
Ctree_2717_43 sp__11666_CLK 0 2.42349e-17
Ctree_2717_48 sp__11903_CLK 0 5.55909e-16
Ctree_2717_57 sp__2717_18 0 1.29466e-16
Ctree_2717_59 sp__2717_18 0 7.10381e-16
Ctree_2717_61 sp__2717_24 0 3.3777e-16
Ctree_2717_62 sp__2717_24 0 2.34311e-16
Ctree_2717_63 sp__2717_24 0 1.59511e-16
Ctree_2717_65 sp__2717_26 0 8.16755e-16
Ctree_2717_66 sp__2717_26 0 1.59183e-16
Ctree_2717_68 sp__2717_26 0 2.34224e-16
Ctree_2717_73 sp__2717_109 0 7.99451e-17
Ctree_2717_77 sp__2717_123 0 7.99873e-17
Ctree_2717_90 sp__2717_39 0 3.39398e-16
Ctree_2717_93 sp__2717_6 0 1.93335e-16
Ctree_2717_94 sp__2717_8 0 3.23785e-16
Ctree_2717_95 sp__2717_12 0 1.43758e-16
Ctree_2717_97 sp__11916_CLK 0 1.76426e-16
Ctree_2717_100 sp__2717_18 0 1.44298e-16
Ctree_2717_101 sp__2717_24 0 8.00842e-17
Ctree_2717_103 sp__2717_95 0 1.80645e-16
Ctree_2717_104 sp__11050_CLK 0 8.01609e-17
Ctree_2717_105 sp__2717_24 0 3.93736e-16
Ctree_2717_106 sp__2717_26 0 7.51285e-17
Ctree_2717_109 sp__11053_CLK 0 2.07913e-16
Rtree_2718_1 sp__12025_X sp__2718_8 41.8334
Rtree_2718_2 sp__2718_8 sp__2718_10 20
Rtree_2718_3 sp__2718_10 sp__2718_12 1.6171
Rtree_2718_4 sp__2718_12 sp__2718_16 25.7886
Rtree_2718_5 sp__2718_16 sp__2718_18 1.8334
Rtree_2718_6 sp__2718_18 sp__2718_22 22.8222
Rtree_2718_7 sp__2718_22 sp__11928_CLK 26.8598
Rtree_2718_8 sp__2718_22 sp__2718_35 1.8334
Rtree_2718_9 sp__2718_35 sp__11541_CLK 23.9964
Rtree_2718_10 sp__2718_35 sp__11538_CLK 20
Rtree_2718_11 sp__2718_22 sp__11617_CLK 20
Rtree_2718_12 sp__2718_18 sp__11904_CLK 48.0552
Rtree_2718_13 sp__2718_16 sp__11539_CLK 43.9964
Rtree_2718_14 sp__2718_12 sp__11618_CLK 20
Rtree_2718_15 sp__2718_10 sp__12106_A 21.1021
Rtree_2718_16 sp__12025_X sp__2718_97 45.1809
Rtree_2718_17 sp__2718_97 sp__11049_CLK 40
Rtree_2718_18 sp__2718_97 sp__2718_106 0.8446
Rtree_2718_19 sp__2718_106 sp__11745_CLK 43.9964
Rtree_2718_20 sp__2718_106 sp__2718_117 1.5862
Rtree_2718_21 sp__2718_117 sp__11669_CLK 42.266
Rtree_2718_22 sp__2718_117 sp__2718_132 22.9252
Rtree_2718_23 sp__2718_132 sp__2718_134 2.266
Rtree_2718_24 sp__2718_134 sp__2718_136 2.0497
Rtree_2718_25 sp__2718_136 sp__11619_CLK 24.9749
Rtree_2718_26 sp__2718_136 sp__11656_CLK 22.0497
Rtree_2718_27 sp__2718_134 sp__11653_CLK 20.5974
Rtree_2718_28 sp__2718_132 sp__11655_CLK 20.5974
Ctree_2718_1 sp__11655_CLK 0 3.71349e-17
Ctree_2718_2 sp__11653_CLK 0 3.50007e-17
Ctree_2718_3 sp__11656_CLK 0 2.04718e-16
Ctree_2718_4 sp__11619_CLK 0 4.90817e-16
Ctree_2718_5 sp__11669_CLK 0 2.2555e-16
Ctree_2718_6 sp__11745_CLK 0 4.15322e-16
Ctree_2718_8 sp__12106_A 0 9.46016e-17
Ctree_2718_10 sp__11539_CLK 0 3.60951e-16
Ctree_2718_11 sp__11904_CLK 0 8.20135e-16
Ctree_2718_14 sp__11541_CLK 0 4.23266e-16
Ctree_2718_15 sp__11928_CLK 0 6.72454e-16
Ctree_2718_16 sp__12025_X 0 5.77126e-16
Ctree_2718_17 sp__2718_136 0 8.94861e-16
Ctree_2718_18 sp__2718_134 0 4.54994e-16
Ctree_2718_19 sp__2718_132 0 5.59088e-16
Ctree_2718_20 sp__2718_117 0 6.57967e-16
Ctree_2718_21 sp__2718_106 0 6.10542e-16
Ctree_2718_22 sp__2718_97 0 5.17763e-16
Ctree_2718_23 sp__2718_35 0 5.88852e-16
Ctree_2718_24 sp__2718_22 0 1.08008e-15
Ctree_2718_25 sp__2718_18 0 1.21763e-15
Ctree_2718_26 sp__2718_16 0 9.30182e-16
Ctree_2718_27 sp__2718_12 0 5.68698e-16
Ctree_2718_28 sp__2718_10 0 2.49521e-16
Ctree_2718_29 sp__2718_8 0 1.23453e-16
Ctree_2718_31 sp__11539_CLK 0 3.07051e-16
Ctree_2718_36 sp__11619_CLK 0 4.99659e-16
Ctree_2718_41 sp__11669_CLK 0 2.41957e-16
Ctree_2718_44 sp__11745_CLK 0 1.12519e-16
Ctree_2718_45 sp__11904_CLK 0 8.03475e-17
Ctree_2718_46 sp__11904_CLK 0 4.77863e-17
Ctree_2718_49 sp__11904_CLK 0 1.77247e-16
Ctree_2718_51 sp__11928_CLK 0 4.79124e-17
Ctree_2718_56 sp__11928_CLK 0 8.02269e-17
Ctree_2718_57 sp__11928_CLK 0 8.00842e-17
Ctree_2718_60 sp__2718_8 0 3.95068e-16
Ctree_2718_62 sp__2718_16 0 1.22646e-15
Ctree_2718_65 sp__2718_18 0 3.72797e-16
Ctree_2718_68 sp__2718_22 0 6.08025e-16
Ctree_2718_73 sp__2718_97 0 4.46855e-16
Ctree_2718_74 sp__2718_97 0 1.43605e-16
Ctree_2718_76 sp__2718_106 0 1.82023e-16
Ctree_2718_78 sp__2718_117 0 3.40704e-16
Ctree_2718_80 sp__2718_132 0 2.33873e-16
Ctree_2718_93 sp__2718_97 0 4.46352e-16
Ctree_2718_97 sp__2718_35 0 2.41847e-16
Ctree_2718_98 sp__11539_CLK 0 8.02269e-17
Rtree_2719_1 sp__12026_X sp__11911_CLK 41.6171
Rtree_2719_2 sp__12026_X sp__2719_20 41.4008
Rtree_2719_3 sp__2719_20 sp__2719_22 2.575
Rtree_2719_4 sp__2719_22 sp__2719_26 24.7998
Rtree_2719_5 sp__2719_26 sp__2719_28 0.3502
Rtree_2719_6 sp__2719_28 sp__2719_30 1.4008
Rtree_2719_7 sp__2719_30 sp__2719_34 2.8634
Rtree_2719_8 sp__2719_34 sp__11313_CLK 20
Rtree_2719_9 sp__2719_34 sp__2719_43 2.678
Rtree_2719_10 sp__2719_43 sp__2719_45 2.266
Rtree_2719_11 sp__2719_45 sp__11936_CLK 21.8334
Rtree_2719_12 sp__2719_45 sp__2719_58 43.0694
Rtree_2719_13 sp__2719_58 sp__11912_CLK 20
Rtree_2719_14 sp__2719_43 sp__11935_CLK 20
Rtree_2719_15 sp__2719_30 sp__11314_CLK 20
Rtree_2719_16 sp__2719_28 sp__11315_CLK 20.5356
Rtree_2719_17 sp__2719_26 sp__2719_82 2.6986
Rtree_2719_18 sp__2719_82 sp__2719_86 2.1836
Rtree_2719_19 sp__2719_86 sp__11316_CLK 20
Rtree_2719_20 sp__2719_86 sp__11317_CLK 22.266
Rtree_2719_21 sp__2719_82 sp__11934_CLK 20
Rtree_2719_22 sp__2719_22 sp__12107_A 40.5356
Rtree_2719_23 sp__2719_20 sp__2719_114 2.0806
Rtree_2719_24 sp__2719_114 sp__11909_CLK 45.0264
Rtree_2719_25 sp__2719_114 sp__2719_127 9.2494
Rtree_2719_26 sp__2719_127 sp__2719_135 31.8038
Rtree_2719_27 sp__2719_135 sp__11527_CLK 20
Rtree_2719_28 sp__2719_127 sp__11927_CLK 45.2736
Ctree_2719_1 sp__11927_CLK 0 4.64114e-16
Ctree_2719_3 sp__11909_CLK 0 5.48269e-16
Ctree_2719_4 sp__12107_A 0 4.37077e-17
Ctree_2719_6 sp__11317_CLK 0 2.06703e-16
Ctree_2719_8 sp__11315_CLK 0 4.25779e-17
Ctree_2719_12 sp__11936_CLK 0 1.68457e-16
Ctree_2719_14 sp__11911_CLK 0 1.47626e-16
Ctree_2719_15 sp__12026_X 0 2.85035e-16
Ctree_2719_16 sp__2719_135 0 1.09322e-15
Ctree_2719_17 sp__2719_127 0 2.30666e-15
Ctree_2719_18 sp__2719_114 0 1.42887e-15
Ctree_2719_19 sp__2719_86 0 4.1337e-16
Ctree_2719_20 sp__2719_82 0 4.44117e-16
Ctree_2719_21 sp__2719_58 0 1.21141e-16
Ctree_2719_22 sp__2719_45 0 4.92733e-16
Ctree_2719_23 sp__2719_43 0 4.25126e-16
Ctree_2719_24 sp__2719_34 0 4.51676e-16
Ctree_2719_25 sp__2719_30 0 3.53652e-16
Ctree_2719_26 sp__2719_28 0 1.90192e-16
Ctree_2719_27 sp__2719_26 0 7.25673e-16
Ctree_2719_28 sp__2719_22 0 6.66726e-16
Ctree_2719_29 sp__2719_20 0 4.2713e-16
Ctree_2719_32 sp__11909_CLK 0 4.77425e-17
Ctree_2719_33 sp__11909_CLK 0 1.38607e-17
Ctree_2719_34 sp__11909_CLK 0 1.77109e-16
Ctree_2719_36 sp__11927_CLK 0 8.01609e-17
Ctree_2719_38 sp__11927_CLK 0 2.72747e-16
Ctree_2719_43 sp__12107_A 0 8.00842e-17
Ctree_2719_45 sp__2719_22 0 5.56795e-16
Ctree_2719_47 sp__2719_26 0 2.34224e-16
Ctree_2719_55 sp__2719_58 0 4.80494e-16
Ctree_2719_56 sp__2719_58 0 1.81608e-16
Ctree_2719_57 sp__2719_58 0 6.62932e-16
Ctree_2719_61 sp__2719_114 0 4.47597e-16
Ctree_2719_62 sp__2719_127 0 1.08979e-15
Ctree_2719_66 sp__2719_135 0 3.06833e-16
Ctree_2719_67 sp__2719_135 0 1.44924e-16
Ctree_2719_69 sp__2719_135 0 3.8639e-17
Ctree_2719_70 sp__2719_135 0 5.49146e-16
Ctree_2719_71 sp__2719_135 0 6.94299e-16
Ctree_2719_72 sp__2719_135 0 5.42639e-16
Ctree_2719_74 sp__2719_135 0 4.77425e-17
Ctree_2719_81 sp__11927_CLK 0 3.94652e-16
Rtree_2720_1 sp__12027_X sp__2720_8 41.6171
Rtree_2720_2 sp__2720_8 sp__2720_10 2.575
Rtree_2720_3 sp__2720_10 sp__2720_12 2.8222
Rtree_2720_4 sp__2720_12 sp__2720_16 21.5862
Rtree_2720_5 sp__2720_16 sp__2720_18 3.9964
Rtree_2720_6 sp__2720_18 sp__2720_20 1.8334
Rtree_2720_7 sp__2720_20 sp__2720_22 2.266
Rtree_2720_8 sp__2720_22 sp__11943_CLK 20.3502
Rtree_2720_9 sp__2720_22 sp__2720_31 1.8334
Rtree_2720_10 sp__2720_31 sp__11910_CLK 22.266
Rtree_2720_11 sp__2720_31 sp__11933_CLK 20
Rtree_2720_12 sp__2720_20 sp__11932_CLK 20
Rtree_2720_13 sp__2720_18 sp__11929_CLK 20
Rtree_2720_14 sp__2720_16 sp__11931_CLK 20
Rtree_2720_15 sp__2720_16 sp__2720_60 3.2572
Rtree_2720_16 sp__2720_60 sp__11318_CLK 22.6162
Rtree_2720_17 sp__2720_60 sp__11930_CLK 20
Rtree_2720_18 sp__2720_12 sp__2720_78 22.266
Rtree_2720_19 sp__2720_78 sp__11908_CLK 20
Rtree_2720_20 sp__2720_78 sp__11116_CLK 27.0246
Rtree_2720_21 sp__2720_10 sp__12108_A 40
Rtree_2720_22 sp__2720_8 sp__2720_105 3.0694
Rtree_2720_23 sp__2720_105 sp__2720_107 20
Rtree_2720_24 sp__2720_107 sp__11905_CLK 28.6932
Rtree_2720_25 sp__2720_107 sp__11907_CLK 20
Rtree_2720_26 sp__2720_105 sp__2720_129 27.7662
Rtree_2720_27 sp__2720_129 sp__11906_CLK 22.5338
Rtree_2720_28 sp__2720_129 sp__11086_CLK 26.5096
Ctree_2720_1 sp__11086_CLK 0 6.34319e-16
Ctree_2720_2 sp__11906_CLK 0 2.64016e-16
Ctree_2720_4 sp__11905_CLK 0 8.80555e-16
Ctree_2720_6 sp__11116_CLK 0 5.2539e-16
Ctree_2720_9 sp__11318_CLK 0 2.09195e-16
Ctree_2720_14 sp__11910_CLK 0 1.92103e-16
Ctree_2720_15 sp__11943_CLK 0 2.77263e-17
Ctree_2720_16 sp__12027_X 0 1.33357e-16
Ctree_2720_17 sp__2720_129 0 1.35191e-15
Ctree_2720_18 sp__2720_107 0 8.80555e-16
Ctree_2720_19 sp__2720_105 0 7.20154e-16
Ctree_2720_20 sp__2720_78 0 6.66568e-16
Ctree_2720_21 sp__2720_60 0 5.44535e-16
Ctree_2720_22 sp__2720_31 0 3.50439e-16
Ctree_2720_23 sp__2720_22 0 4.16685e-16
Ctree_2720_24 sp__2720_20 0 3.90828e-16
Ctree_2720_25 sp__2720_18 0 5.15459e-16
Ctree_2720_26 sp__2720_16 0 7.87559e-16
Ctree_2720_27 sp__2720_12 0 4.24652e-16
Ctree_2720_28 sp__2720_10 0 3.96698e-16
Ctree_2720_29 sp__2720_8 0 6.10129e-16
Ctree_2720_30 sp__11086_CLK 0 4.77425e-17
Ctree_2720_31 sp__11086_CLK 0 8.00842e-17
Ctree_2720_32 sp__11086_CLK 0 1.4463e-16
Ctree_2720_36 sp__11086_CLK 0 1.61141e-16
Ctree_2720_41 sp__11905_CLK 0 2.07986e-16
Ctree_2720_42 sp__11905_CLK 0 5.95291e-16
Ctree_2720_43 sp__11906_CLK 0 1.54008e-17
Ctree_2720_44 sp__11906_CLK 0 1.12019e-16
Ctree_2720_47 sp__2720_8 0 1.76229e-16
Ctree_2720_48 sp__2720_8 0 1.54008e-17
Ctree_2720_49 sp__2720_10 0 5.50214e-16
Ctree_2720_50 sp__2720_12 0 6.09994e-16
Ctree_2720_52 sp__2720_16 0 3.41914e-16
Ctree_2720_64 sp__2720_105 0 4.78118e-16
Ctree_2720_65 sp__2720_105 0 1.79389e-16
Ctree_2720_66 sp__2720_129 0 1.34506e-15
Ctree_2720_67 sp__2720_129 0 3.15205e-16
Ctree_2720_69 sp__2720_8 0 2.41847e-16
Ctree_2720_74 sp__11086_CLK 0 2.41336e-16
Ctree_2720_78 sp__11905_CLK 0 1.4407e-16
Ctree_2720_83 sp__11905_CLK 0 1.764e-16
Ctree_2720_84 sp__2720_129 0 1.26325e-16
Ctree_2720_85 sp__2720_129 0 7.624e-16
Ctree_2720_86 sp__11086_CLK 0 3.38113e-16
Rtree_2721_1 sp__12028_X sp__2721_10 41.9673
Rtree_2721_2 sp__2721_10 sp__2721_14 25.2942
Rtree_2721_3 sp__2721_14 sp__2721_26 9.888
Rtree_2721_4 sp__2721_26 sp__2721_28 1.8334
Rtree_2721_5 sp__2721_28 sp__11926_CLK 22.266
Rtree_2721_6 sp__2721_28 sp__11925_CLK 20
Rtree_2721_7 sp__2721_26 sp__11902_CLK 20
Rtree_2721_8 sp__2721_14 sp__11924_CLK 20
Rtree_2721_9 sp__2721_14 sp__2721_52 2.266
Rtree_2721_10 sp__2721_52 sp__11921_CLK 20
Rtree_2721_11 sp__2721_52 sp__2721_59 1.8334
Rtree_2721_12 sp__2721_59 sp__11125_CLK 20
Rtree_2721_13 sp__2721_59 sp__11923_CLK 23.9964
Rtree_2721_14 sp__2721_10 sp__2721_73 4.7998
Rtree_2721_15 sp__2721_73 sp__11897_CLK 40
Rtree_2721_16 sp__2721_73 sp__2721_86 33.184
Rtree_2721_17 sp__2721_86 sp__11898_CLK 20
Rtree_2721_18 sp__12028_X sp__2721_100 21.9673
Rtree_2721_19 sp__2721_100 sp__11128_CLK 20
Rtree_2721_20 sp__2721_100 sp__2721_107 2.266
Rtree_2721_21 sp__2721_107 sp__12109_A 20
Rtree_2721_22 sp__2721_107 sp__2721_118 3.9314
Rtree_2721_23 sp__2721_118 sp__11899_CLK 20
Rtree_2721_24 sp__2721_118 sp__2721_129 4.4496
Rtree_2721_25 sp__2721_129 sp__2721_133 23.3166
Rtree_2721_26 sp__2721_133 sp__2721_135 4.0582
Rtree_2721_27 sp__2721_135 sp__11900_CLK 43.1724
Rtree_2721_28 sp__2721_135 sp__11105_CLK 43.9964
Rtree_2721_29 sp__2721_133 sp__11124_CLK 40
Rtree_2721_30 sp__2721_129 sp__2721_172 49.3318
Rtree_2721_31 sp__2721_172 sp__11099_CLK 20
Ctree_2721_3 sp__11105_CLK 0 4.0544e-16
Ctree_2721_4 sp__11900_CLK 0 2.96359e-16
Ctree_2721_10 sp__11923_CLK 0 3.7562e-16
Ctree_2721_16 sp__11926_CLK 0 2.48466e-16
Ctree_2721_17 sp__12028_X 0 3.80436e-16
Ctree_2721_18 sp__2721_172 0 9.63327e-16
Ctree_2721_19 sp__2721_135 0 1.06219e-15
Ctree_2721_20 sp__2721_133 0 6.22215e-16
Ctree_2721_21 sp__2721_129 0 1.67978e-15
Ctree_2721_22 sp__2721_118 0 8.82194e-16
Ctree_2721_23 sp__2721_107 0 6.45977e-16
Ctree_2721_24 sp__2721_100 0 4.00293e-16
Ctree_2721_25 sp__2721_86 0 1.09686e-15
Ctree_2721_26 sp__2721_73 0 1.33737e-15
Ctree_2721_27 sp__2721_59 0 5.87601e-16
Ctree_2721_28 sp__2721_52 0 4.44996e-16
Ctree_2721_29 sp__2721_28 0 4.23855e-16
Ctree_2721_30 sp__2721_26 0 1.25495e-15
Ctree_2721_31 sp__2721_14 0 1.72028e-15
Ctree_2721_32 sp__2721_10 0 8.46754e-16
Ctree_2721_35 sp__11105_CLK 0 8.00842e-17
Ctree_2721_40 sp__11900_CLK 0 2.88087e-16
Ctree_2721_43 sp__11923_CLK 0 3.05904e-16
Ctree_2721_44 sp__11923_CLK 0 3.6999e-16
Ctree_2721_47 sp__2721_14 0 3.6363e-16
Ctree_2721_48 sp__2721_14 0 1.27936e-16
Ctree_2721_49 sp__2721_14 0 2.8637e-16
Ctree_2721_54 sp__2721_26 0 1.12651e-16
Ctree_2721_58 sp__2721_73 0 1.00463e-15
Ctree_2721_61 sp__2721_86 0 2.41897e-16
Ctree_2721_62 sp__2721_86 0 1.12454e-16
Ctree_2721_63 sp__2721_86 0 4.87126e-16
Ctree_2721_64 sp__2721_86 0 1.1716e-15
Ctree_2721_65 sp__2721_86 0 3.06581e-16
Ctree_2721_68 sp__2721_100 0 2.41847e-16
Ctree_2721_69 sp__2721_107 0 1.29367e-16
Ctree_2721_72 sp__2721_129 0 1.35668e-16
Ctree_2721_73 sp__2721_133 0 6.93064e-16
Ctree_2721_74 sp__2721_133 0 7.52149e-17
Ctree_2721_77 sp__2721_135 0 6.60643e-16
Ctree_2721_79 sp__2721_135 0 7.52158e-17
Ctree_2721_83 sp__2721_10 0 2.02407e-16
Ctree_2721_84 sp__2721_10 0 1.54008e-17
Ctree_2721_91 sp__2721_14 0 3.89357e-16
Ctree_2721_92 sp__2721_14 0 1.79357e-16
Ctree_2721_94 sp__2721_73 0 8.33101e-16
Ctree_2721_95 sp__2721_86 0 2.32989e-16
Ctree_2721_99 sp__11926_CLK 0 4.77425e-17
Ctree_2721_101 sp__2721_28 0 2.72967e-16
Ctree_2721_102 sp__2721_26 0 1.12563e-16
Rtree_2722_1 sp__12029_X sp__2722_4 20
Rtree_2722_2 sp__2722_4 sp__11110_CLK 25.8607
Rtree_2722_3 sp__2722_4 sp__2722_19 25.0882
Rtree_2722_4 sp__2722_19 sp__2722_27 23.5535
Rtree_2722_5 sp__2722_27 sp__2722_31 25.047
Rtree_2722_6 sp__2722_31 sp__11117_CLK 41.8334
Rtree_2722_7 sp__2722_31 sp__2722_42 20
Rtree_2722_8 sp__2722_42 sp__2722_44 2.266
Rtree_2722_9 sp__2722_44 sp__2722_48 2.4308
Rtree_2722_10 sp__2722_48 sp__2722_50 1.339
Rtree_2722_11 sp__2722_50 sp__11319_CLK 24.3466
Rtree_2722_12 sp__2722_50 sp__11320_CLK 20
Rtree_2722_13 sp__2722_48 sp__11321_CLK 22.266
Rtree_2722_14 sp__2722_44 sp__11322_CLK 20
Rtree_2722_15 sp__2722_42 sp__2722_78 1.8334
Rtree_2722_16 sp__2722_78 sp__11324_CLK 22.8634
Rtree_2722_17 sp__2722_78 sp__11323_CLK 20
Rtree_2722_18 sp__2722_27 sp__11115_CLK 20
Rtree_2722_19 sp__2722_19 sp__11327_CLK 40.3193
Rtree_2722_20 sp__12029_X sp__2722_115 46.7774
Rtree_2722_21 sp__2722_115 sp__2722_117 20
Rtree_2722_22 sp__2722_117 sp__2722_119 3.9964
Rtree_2722_23 sp__2722_119 sp__11109_CLK 20.3502
Rtree_2722_24 sp__2722_119 sp__2722_134 43.3578
Rtree_2722_25 sp__2722_134 sp__11922_CLK 20
Rtree_2722_26 sp__2722_117 sp__2722_143 23.1312
Rtree_2722_27 sp__2722_143 sp__11111_CLK 42.3072
Rtree_2722_28 sp__2722_143 sp__2722_158 21.339
Rtree_2722_29 sp__2722_158 sp__11106_CLK 21.4008
Rtree_2722_30 sp__2722_158 sp__2722_167 2.6986
Rtree_2722_31 sp__2722_167 sp__11107_CLK 20
Rtree_2722_32 sp__2722_167 sp__11104_CLK 22.266
Ctree_2722_1 sp__11104_CLK 0 2.03575e-16
Ctree_2722_3 sp__11106_CLK 0 1.18593e-16
Ctree_2722_4 sp__11111_CLK 0 2.12092e-16
Ctree_2722_6 sp__11109_CLK 0 2.77263e-17
Ctree_2722_7 sp__11327_CLK 0 3.23333e-17
Ctree_2722_10 sp__11324_CLK 0 2.86431e-16
Ctree_2722_12 sp__11321_CLK 0 1.22343e-16
Ctree_2722_14 sp__11319_CLK 0 4.52742e-16
Ctree_2722_15 sp__11117_CLK 0 1.084e-16
Ctree_2722_16 sp__11110_CLK 0 5.48351e-16
Ctree_2722_17 sp__12029_X 0 3.35616e-16
Ctree_2722_18 sp__2722_167 0 4.59427e-16
Ctree_2722_19 sp__2722_158 0 4.9768e-16
Ctree_2722_20 sp__2722_143 0 7.10783e-16
Ctree_2722_21 sp__2722_134 0 2.86389e-16
Ctree_2722_22 sp__2722_119 0 7.41185e-16
Ctree_2722_23 sp__2722_117 0 8.02526e-16
Ctree_2722_24 sp__2722_115 0 3.35616e-16
Ctree_2722_25 sp__2722_78 0 4.62399e-16
Ctree_2722_26 sp__2722_50 0 5.58754e-16
Ctree_2722_27 sp__2722_48 0 4.51508e-16
Ctree_2722_28 sp__2722_44 0 4.24681e-16
Ctree_2722_29 sp__2722_42 0 3.77497e-16
Ctree_2722_30 sp__2722_31 0 4.11584e-16
Ctree_2722_31 sp__2722_27 0 5.92653e-16
Ctree_2722_32 sp__2722_19 0 8.52174e-16
Ctree_2722_33 sp__2722_4 0 1.07872e-15
Ctree_2722_34 sp__11104_CLK 0 3.38399e-16
Ctree_2722_35 sp__11106_CLK 0 2.09555e-16
Ctree_2722_36 sp__11110_CLK 0 2.42181e-16
Ctree_2722_39 sp__11111_CLK 0 1.44768e-16
Ctree_2722_40 sp__11117_CLK 0 3.95688e-16
Ctree_2722_50 sp__2722_19 0 3.38547e-16
Ctree_2722_53 sp__2722_27 0 7.51285e-17
Ctree_2722_56 sp__2722_27 0 2.09505e-16
Ctree_2722_57 sp__2722_27 0 1.83244e-16
Ctree_2722_58 sp__2722_31 0 1.09254e-15
Ctree_2722_64 sp__2722_115 0 9.08269e-16
Ctree_2722_65 sp__2722_115 0 2.89002e-16
Ctree_2722_66 sp__2722_115 0 1.2493e-15
Ctree_2722_71 sp__2722_134 0 2.74561e-16
Ctree_2722_75 sp__2722_134 0 2.3464e-16
Ctree_2722_79 sp__2722_167 0 4.02168e-16
Ctree_2722_87 sp__11106_CLK 0 1.76741e-16
Ctree_2722_88 sp__11111_CLK 0 2.89306e-16
Ctree_2722_89 sp__2722_158 0 2.12127e-16
Rtree_2723_1 sp__12030_X sp__2723_8 40.5974
Rtree_2723_2 sp__2723_8 sp__2723_10 3.5638
Rtree_2723_3 sp__2723_10 sp__2723_12 1.339
Rtree_2723_4 sp__2723_12 sp__2723_16 25.5414
Rtree_2723_5 sp__2723_16 sp__2723_18 0.5974
Rtree_2723_6 sp__2723_18 sp__11113_CLK 22.4617
Rtree_2723_7 sp__2723_18 sp__2723_29 0.7519
Rtree_2723_8 sp__2723_29 sp__2723_31 1.8334
Rtree_2723_9 sp__2723_31 sp__11328_CLK 20.8446
Rtree_2723_10 sp__2723_31 sp__2723_40 2.266
Rtree_2723_11 sp__2723_40 sp__11326_CLK 20.5974
Rtree_2723_12 sp__2723_40 sp__2723_49 1.8334
Rtree_2723_13 sp__2723_49 sp__11118_CLK 23.1106
Rtree_2723_14 sp__2723_49 sp__11325_CLK 20
Rtree_2723_15 sp__2723_29 sp__11329_CLK 20
Rtree_2723_16 sp__2723_16 sp__2723_70 3.3475
Rtree_2723_17 sp__2723_70 sp__11331_CLK 20
Rtree_2723_18 sp__2723_70 sp__11333_CLK 25.5826
Rtree_2723_19 sp__2723_12 sp__2723_86 20
Rtree_2723_20 sp__2723_86 sp__2723_88 2.4823
Rtree_2723_21 sp__2723_88 sp__2723_92 2.6162
Rtree_2723_22 sp__2723_92 sp__11330_CLK 20
Rtree_2723_23 sp__2723_92 sp__11119_CLK 22.4308
Rtree_2723_24 sp__2723_88 sp__11114_CLK 20
Rtree_2723_25 sp__2723_86 sp__11334_CLK 21.6171
Rtree_2723_26 sp__2723_10 sp__2723_120 20
Rtree_2723_27 sp__2723_120 sp__11332_CLK 21.3493
Rtree_2723_28 sp__2723_120 sp__11356_CLK 23.3475
Rtree_2723_29 sp__2723_8 sp__11112_CLK 48.8889
Rtree_2723_30 sp__12030_X sp__2723_154 23.9964
Rtree_2723_31 sp__2723_154 sp__12110_A 20
Rtree_2723_32 sp__2723_154 sp__2723_167 46.077
Rtree_2723_33 sp__2723_167 sp__11373_CLK 20
Ctree_2723_3 sp__11112_CLK 0 9.80176e-16
Ctree_2723_4 sp__11356_CLK 0 2.75837e-16
Ctree_2723_5 sp__11332_CLK 0 1.14715e-16
Ctree_2723_6 sp__11334_CLK 0 1.27043e-16
Ctree_2723_8 sp__11119_CLK 0 2.54308e-16
Ctree_2723_10 sp__11333_CLK 0 5.24962e-16
Ctree_2723_14 sp__11118_CLK 0 2.85996e-16
Ctree_2723_15 sp__11326_CLK 0 2.36489e-17
Ctree_2723_16 sp__11328_CLK 0 4.32204e-17
Ctree_2723_17 sp__11113_CLK 0 1.83893e-16
Ctree_2723_18 sp__12030_X 0 3.91049e-16
Ctree_2723_19 sp__2723_167 0 5.60706e-16
Ctree_2723_20 sp__2723_154 0 9.30161e-16
Ctree_2723_21 sp__2723_120 0 3.90552e-16
Ctree_2723_22 sp__2723_92 0 4.98472e-16
Ctree_2723_23 sp__2723_88 0 4.86493e-16
Ctree_2723_24 sp__2723_86 0 3.69372e-16
Ctree_2723_25 sp__2723_70 0 7.7836e-16
Ctree_2723_26 sp__2723_49 0 4.69515e-16
Ctree_2723_27 sp__2723_40 0 4.18607e-16
Ctree_2723_28 sp__2723_31 0 4.43477e-16
Ctree_2723_29 sp__2723_29 0 2.47406e-16
Ctree_2723_30 sp__2723_18 0 2.85701e-16
Ctree_2723_31 sp__2723_16 0 8.00023e-16
Ctree_2723_32 sp__2723_12 0 6.39243e-16
Ctree_2723_33 sp__2723_10 0 3.39433e-16
Ctree_2723_34 sp__2723_8 0 1.20536e-15
Ctree_2723_48 sp__11332_CLK 0 1.12535e-16
Ctree_2723_52 sp__11333_CLK 0 1.21957e-16
Ctree_2723_53 sp__11333_CLK 0 2.2688e-16
Ctree_2723_54 sp__11334_CLK 0 2.25268e-16
Ctree_2723_55 sp__11334_CLK 0 2.41847e-16
Ctree_2723_56 sp__11356_CLK 0 4.35837e-16
Ctree_2723_57 sp__11356_CLK 0 5.00052e-16
Ctree_2723_59 sp__2723_8 0 1.06566e-16
Ctree_2723_60 sp__2723_8 0 1.28663e-16
Ctree_2723_61 sp__2723_10 0 4.99656e-16
Ctree_2723_62 sp__2723_10 0 7.62802e-16
Ctree_2723_64 sp__2723_12 0 7.51285e-17
Ctree_2723_75 sp__2723_70 0 5.00349e-16
Ctree_2723_76 sp__2723_70 0 4.03663e-16
Ctree_2723_77 sp__2723_88 0 3.53707e-16
Ctree_2723_79 sp__2723_88 0 8.02102e-17
Ctree_2723_80 sp__2723_92 0 3.36921e-16
Ctree_2723_83 sp__2723_154 0 5.98231e-16
Ctree_2723_86 sp__2723_167 0 3.42036e-16
Ctree_2723_87 sp__2723_167 0 3.71477e-16
Ctree_2723_88 sp__2723_167 0 1.77345e-16
Rtree_2724_1 sp__12031_X sp__2724_8 43.0694
Rtree_2724_2 sp__2724_8 sp__2724_10 0.8446
Rtree_2724_3 sp__2724_10 sp__11342_CLK 41.3802
Rtree_2724_4 sp__2724_10 sp__11357_CLK 41.8334
Rtree_2724_5 sp__2724_8 sp__2724_34 22.266
Rtree_2724_6 sp__2724_34 sp__2724_38 2.6162
Rtree_2724_7 sp__2724_38 sp__2724_40 1.8334
Rtree_2724_8 sp__2724_40 sp__2724_44 2.1836
Rtree_2724_9 sp__2724_44 sp__11371_CLK 20.5356
Rtree_2724_10 sp__2724_44 sp__2724_59 44.0994
Rtree_2724_11 sp__2724_59 sp__11372_CLK 20
Rtree_2724_12 sp__2724_40 sp__2724_68 22.0806
Rtree_2724_13 sp__2724_68 sp__2724_70 1.0918
Rtree_2724_14 sp__2724_70 sp__2724_74 24.0582
Rtree_2724_15 sp__2724_74 sp__2724_76 2.266
Rtree_2724_16 sp__2724_76 sp__11336_CLK 21.8334
Rtree_2724_17 sp__2724_76 sp__11337_CLK 20
Rtree_2724_18 sp__2724_74 sp__2724_90 1.8334
Rtree_2724_19 sp__2724_90 sp__11338_CLK 20
Rtree_2724_20 sp__2724_90 sp__2724_97 2.266
Rtree_2724_21 sp__2724_97 sp__11339_CLK 20
Rtree_2724_22 sp__2724_97 sp__11341_CLK 24.3466
Rtree_2724_23 sp__2724_70 sp__11370_CLK 40
Rtree_2724_24 sp__2724_68 sp__11335_CLK 47.8898
Rtree_2724_25 sp__2724_38 sp__11344_CLK 20
Rtree_2724_26 sp__2724_34 sp__11343_CLK 20
Rtree_2724_27 sp__12031_X sp__2724_148 43.605
Rtree_2724_28 sp__2724_148 sp__11358_CLK 40
Rtree_2724_29 sp__2724_148 sp__2724_161 24.841
Rtree_2724_30 sp__2724_161 sp__2724_165 2.6162
Rtree_2724_31 sp__2724_165 sp__2724_173 43.4196
Rtree_2724_32 sp__2724_173 sp__11345_CLK 20
Rtree_2724_33 sp__2724_165 sp__11347_CLK 20
Rtree_2724_34 sp__2724_161 sp__11346_CLK 20.3502
Ctree_2724_1 sp__11346_CLK 0 2.36489e-17
Ctree_2724_7 sp__11335_CLK 0 7.89858e-16
Ctree_2724_9 sp__11341_CLK 0 3.7836e-16
Ctree_2724_13 sp__11336_CLK 0 1.75191e-16
Ctree_2724_15 sp__11371_CLK 0 4.34917e-17
Ctree_2724_16 sp__11357_CLK 0 1.86243e-16
Ctree_2724_17 sp__11342_CLK 0 1.17276e-16
Ctree_2724_18 sp__12031_X 0 4.54947e-16
Ctree_2724_19 sp__2724_173 0 2.66042e-16
Ctree_2724_20 sp__2724_165 0 5.13774e-16
Ctree_2724_21 sp__2724_161 0 6.53079e-16
Ctree_2724_22 sp__2724_148 0 6.70848e-16
Ctree_2724_23 sp__2724_97 0 5.73946e-16
Ctree_2724_24 sp__2724_90 0 3.68361e-16
Ctree_2724_25 sp__2724_76 0 3.88911e-16
Ctree_2724_26 sp__2724_74 0 8.85864e-16
Ctree_2724_27 sp__2724_70 0 6.29165e-16
Ctree_2724_28 sp__2724_68 0 1.14131e-15
Ctree_2724_29 sp__2724_59 0 2.61594e-16
Ctree_2724_30 sp__2724_44 0 4.83528e-16
Ctree_2724_31 sp__2724_40 0 6.08574e-16
Ctree_2724_32 sp__2724_38 0 4.77692e-16
Ctree_2724_33 sp__2724_34 0 4.50131e-16
Ctree_2724_34 sp__2724_10 0 3.74764e-16
Ctree_2724_35 sp__2724_8 0 4.17957e-16
Ctree_2724_37 sp__11335_CLK 0 5.33316e-16
Ctree_2724_38 sp__11335_CLK 0 1.54008e-17
Ctree_2724_40 sp__11335_CLK 0 1.12689e-16
Ctree_2724_44 sp__11335_CLK 0 4.35789e-16
Ctree_2724_53 sp__11341_CLK 0 4.77702e-17
Ctree_2724_55 sp__11342_CLK 0 1.82519e-16
Ctree_2724_59 sp__11371_CLK 0 7.99869e-17
Ctree_2724_60 sp__11371_CLK 0 8.00842e-17
Ctree_2724_62 sp__2724_8 0 4.4773e-16
Ctree_2724_63 sp__2724_8 0 6.38493e-16
Ctree_2724_65 sp__2724_10 0 1.60265e-16
Ctree_2724_66 sp__2724_34 0 3.39277e-16
Ctree_2724_72 sp__2724_44 0 2.5685e-16
Ctree_2724_74 sp__2724_44 0 1.75635e-16
Ctree_2724_75 sp__2724_59 0 3.38246e-16
Ctree_2724_76 sp__2724_59 0 3.98565e-16
Ctree_2724_77 sp__2724_59 0 3.98565e-16
Ctree_2724_78 sp__2724_59 0 3.38246e-16
Ctree_2724_96 sp__2724_148 0 3.38558e-16
Ctree_2724_99 sp__2724_161 0 1.76664e-16
Ctree_2724_104 sp__2724_173 0 1.84493e-16
Ctree_2724_105 sp__2724_173 0 1.84492e-16
Rtree_2725_1 sp__12032_X sp__2725_6 40
Rtree_2725_2 sp__2725_6 sp__2725_8 1.5862
Rtree_2725_3 sp__2725_8 sp__2725_12 34.1934
Rtree_2725_4 sp__2725_12 sp__2725_14 0.5356
Rtree_2725_5 sp__2725_14 sp__11471_CLK 22.266
Rtree_2725_6 sp__2725_14 sp__11472_CLK 20
Rtree_2725_7 sp__2725_12 sp__2725_28 1.4008
Rtree_2725_8 sp__2725_28 sp__11415_CLK 20
Rtree_2725_9 sp__2725_28 sp__2725_35 2.266
Rtree_2725_10 sp__2725_35 sp__11473_CLK 20
Rtree_2725_11 sp__2725_35 sp__11392_CLK 22.6548
Rtree_2725_12 sp__2725_8 sp__11496_CLK 41.4008
Rtree_2725_13 sp__2725_6 sp__2725_62 25.047
Rtree_2725_14 sp__2725_62 sp__2725_64 1.4008
Rtree_2725_15 sp__2725_64 sp__11577_CLK 23.9964
Rtree_2725_16 sp__2725_64 sp__11519_CLK 20.3502
Rtree_2725_17 sp__2725_62 sp__2725_82 0.8858
Rtree_2725_18 sp__2725_82 sp__2725_84 2.266
Rtree_2725_19 sp__2725_84 sp__11576_CLK 20
Rtree_2725_20 sp__2725_84 sp__2725_97 2.7872
Rtree_2725_21 sp__2725_97 sp__2725_101 22.266
Rtree_2725_22 sp__2725_101 sp__2725_103 0.5974
Rtree_2725_23 sp__2725_103 sp__11578_CLK 43.3166
Rtree_2725_24 sp__2725_103 sp__2725_118 22.1836
Rtree_2725_25 sp__2725_118 sp__2725_122 2.8634
Rtree_2725_26 sp__2725_122 sp__11575_CLK 20
Rtree_2725_27 sp__2725_122 sp__11574_CLK 22.4308
Rtree_2725_28 sp__2725_118 sp__11573_CLK 20
Rtree_2725_29 sp__2725_101 sp__11579_CLK 43.0694
Rtree_2725_30 sp__2725_97 sp__11408_CLK 20
Rtree_2725_31 sp__2725_82 sp__11599_CLK 20
Ctree_2725_3 sp__11579_CLK 0 3.67137e-16
Ctree_2725_5 sp__11574_CLK 0 2.61572e-16
Ctree_2725_7 sp__11578_CLK 0 3.98091e-16
Ctree_2725_9 sp__11519_CLK 0 1.38632e-17
Ctree_2725_10 sp__11577_CLK 0 4.66858e-16
Ctree_2725_11 sp__11496_CLK 0 1.69562e-16
Ctree_2725_12 sp__11392_CLK 0 3.4087e-16
Ctree_2725_16 sp__11471_CLK 0 2.10054e-16
Ctree_2725_18 sp__2725_122 0 5.36052e-16
Ctree_2725_19 sp__2725_118 0 4.78095e-16
Ctree_2725_20 sp__2725_103 0 6.75659e-16
Ctree_2725_21 sp__2725_101 0 6.46066e-16
Ctree_2725_22 sp__2725_97 0 4.8099e-16
Ctree_2725_23 sp__2725_84 0 5.26109e-16
Ctree_2725_24 sp__2725_82 0 3.1735e-16
Ctree_2725_25 sp__2725_64 0 6.56259e-16
Ctree_2725_26 sp__2725_62 0 6.95369e-16
Ctree_2725_27 sp__2725_35 0 5.59249e-16
Ctree_2725_28 sp__2725_28 0 3.47708e-16
Ctree_2725_29 sp__2725_14 0 2.52021e-16
Ctree_2725_30 sp__2725_12 0 1.28045e-15
Ctree_2725_31 sp__2725_8 0 1.39736e-15
Ctree_2725_32 sp__2725_6 0 5.71222e-16
Ctree_2725_39 sp__11577_CLK sp__2736_30 2.08195e-16
Ctree_2725_45 sp__11579_CLK 0 1.28663e-16
Ctree_2725_47 sp__2725_8 0 3.40324e-16
Ctree_2725_49 sp__2725_12 0 1.19555e-15
Ctree_2725_50 sp__2725_12 0 4.8052e-16
Ctree_2725_58 sp__2725_62 0 6.61887e-16
Ctree_2725_66 sp__2725_97 0 1.12705e-16
Ctree_2725_68 sp__2725_101 0 3.39317e-16
Ctree_2725_69 sp__2725_118 0 3.23417e-17
Ctree_2725_71 sp__2725_118 0 2.08615e-16
Ctree_2725_72 sp__2725_122 0 8.01938e-17
Rtree_2726_1 sp__12033_X sp__2726_4 20
Rtree_2726_2 sp__2726_4 sp__2726_14 42.472
Rtree_2726_3 sp__2726_14 sp__12111_A 20
Rtree_2726_4 sp__2726_4 sp__2726_25 24.841
Rtree_2726_5 sp__2726_25 sp__2726_27 4.3054
Rtree_2726_6 sp__2726_27 sp__11340_CLK 41.8334
Rtree_2726_7 sp__2726_27 sp__11374_CLK 41.8334
Rtree_2726_8 sp__2726_25 sp__2726_47 20
Rtree_2726_9 sp__2726_47 sp__2726_49 2.266
Rtree_2726_10 sp__2726_49 sp__11348_CLK 20
Rtree_2726_11 sp__2726_49 sp__2726_58 2.9252
Rtree_2726_12 sp__2726_58 sp__11350_CLK 20
Rtree_2726_13 sp__2726_58 sp__2726_67 2.5282
Rtree_2726_14 sp__2726_67 sp__2726_69 1.8334
Rtree_2726_15 sp__2726_69 sp__2726_75 43.5638
Rtree_2726_16 sp__2726_75 sp__11361_CLK 20
Rtree_2726_17 sp__2726_69 sp__2726_84 2.6162
Rtree_2726_18 sp__2726_84 sp__2726_92 46.3242
Rtree_2726_19 sp__2726_92 sp__11359_CLK 20
Rtree_2726_20 sp__2726_84 sp__11360_CLK 20
Rtree_2726_21 sp__2726_67 sp__11349_CLK 20.3502
Rtree_2726_22 sp__2726_47 sp__2726_117 3.9346
Rtree_2726_23 sp__2726_117 sp__11375_CLK 20.9682
Rtree_2726_24 sp__2726_117 sp__2726_136 46.4066
Rtree_2726_25 sp__2726_136 sp__11102_CLK 20
Rtree_2726_26 sp__2726_4 sp__2726_145 1.751
Rtree_2726_27 sp__2726_145 sp__2726_151 42.8222
Rtree_2726_28 sp__2726_151 sp__11103_CLK 23.9964
Rtree_2726_29 sp__2726_151 sp__2726_162 4.3466
Rtree_2726_30 sp__2726_162 sp__11351_CLK 20.3502
Rtree_2726_31 sp__2726_162 sp__2726_173 2.1836
Rtree_2726_32 sp__2726_173 sp__11352_CLK 20
Rtree_2726_33 sp__2726_173 sp__2726_182 2.8634
Rtree_2726_34 sp__2726_182 sp__11363_CLK 20
Rtree_2726_35 sp__2726_182 sp__11362_CLK 24.3466
Rtree_2726_36 sp__2726_145 sp__11376_CLK 20
Ctree_2726_2 sp__11362_CLK 0 3.87447e-16
Ctree_2726_5 sp__11351_CLK 0 2.77263e-17
Ctree_2726_6 sp__11103_CLK 0 3.73597e-16
Ctree_2726_8 sp__11375_CLK 0 9.025e-17
Ctree_2726_9 sp__11349_CLK 0 2.77263e-17
Ctree_2726_15 sp__11374_CLK 0 1.69181e-16
Ctree_2726_16 sp__11340_CLK 0 1.94228e-16
Ctree_2726_19 sp__2726_182 0 6.30334e-16
Ctree_2726_20 sp__2726_173 0 4.4721e-16
Ctree_2726_21 sp__2726_162 0 7.01572e-16
Ctree_2726_22 sp__2726_151 0 1.10695e-15
Ctree_2726_23 sp__2726_145 0 4.58828e-16
Ctree_2726_24 sp__2726_136 0 6.5698e-16
Ctree_2726_25 sp__2726_117 0 1.10944e-15
Ctree_2726_26 sp__2726_92 0 5.93668e-16
Ctree_2726_27 sp__2726_84 0 8.13822e-16
Ctree_2726_28 sp__2726_75 0 2.50361e-16
Ctree_2726_29 sp__2726_69 0 6.52697e-16
Ctree_2726_30 sp__2726_67 0 4.71568e-16
Ctree_2726_31 sp__2726_58 0 5.22449e-16
Ctree_2726_32 sp__2726_49 0 5.15656e-16
Ctree_2726_33 sp__2726_47 0 6.1708e-16
Ctree_2726_34 sp__2726_27 0 9.01651e-16
Ctree_2726_35 sp__2726_25 0 9.40435e-16
Ctree_2726_36 sp__2726_14 0 1.51353e-16
Ctree_2726_37 sp__2726_4 0 7.48544e-16
Ctree_2726_39 sp__11103_CLK 0 5.97505e-16
Ctree_2726_40 sp__11103_CLK 0 2.42138e-16
Ctree_2726_41 sp__11340_CLK 0 2.38641e-16
Ctree_2726_48 sp__11374_CLK 0 2.74189e-16
Ctree_2726_49 sp__11375_CLK 0 4.77201e-17
Ctree_2726_51 sp__11375_CLK 0 4.77863e-17
Ctree_2726_52 sp__2726_14 0 3.45425e-16
Ctree_2726_53 sp__2726_14 0 8.00842e-17
Ctree_2726_54 sp__2726_14 0 3.45673e-16
Ctree_2726_55 sp__2726_25 0 4.52949e-16
Ctree_2726_56 sp__2726_25 0 1.54008e-17
Ctree_2726_57 sp__2726_25 0 8.00842e-17
Ctree_2726_59 sp__2726_49 0 1.44713e-16
Ctree_2726_62 sp__2726_58 0 1.28618e-16
Ctree_2726_69 sp__2726_75 0 5.01045e-16
Ctree_2726_71 sp__2726_84 0 1.12221e-16
Ctree_2726_80 sp__2726_117 0 1.945e-16
Ctree_2726_84 sp__2726_117 0 1.54008e-17
Ctree_2726_85 sp__2726_117 0 2.08955e-16
Ctree_2726_86 sp__2726_136 0 3.06501e-16
Ctree_2726_87 sp__2726_136 0 1.30055e-16
Ctree_2726_88 sp__2726_136 0 1.21836e-16
Ctree_2726_93 sp__2726_162 0 8.03692e-17
Ctree_2726_94 sp__2726_162 0 8.00842e-17
Ctree_2726_95 sp__2726_162 0 8.00842e-17
Ctree_2726_102 sp__11375_CLK 0 7.9586e-17
Ctree_2726_103 sp__2726_117 0 1.11946e-16
Rtree_2727_1 sp__12034_X sp__2727_8 41.6171
Rtree_2727_2 sp__2727_8 sp__2727_10 3.5638
Rtree_2727_3 sp__2727_10 sp__11364_CLK 42.3278
Rtree_2727_4 sp__2727_10 sp__2727_23 21.8334
Rtree_2727_5 sp__2727_23 sp__2727_27 2.8634
Rtree_2727_6 sp__2727_27 sp__2727_31 23.9964
Rtree_2727_7 sp__2727_31 sp__2727_35 21.339
Rtree_2727_8 sp__2727_35 sp__2727_37 4.2127
Rtree_2727_9 sp__2727_37 sp__11101_CLK 28.4769
Rtree_2727_10 sp__2727_37 sp__2727_54 1.6583
Rtree_2727_11 sp__2727_54 sp__11378_CLK 20
Rtree_2727_12 sp__2727_54 sp__2727_65 22.8325
Rtree_2727_13 sp__2727_65 sp__11379_CLK 42.4823
Rtree_2727_14 sp__2727_65 sp__2727_80 24.6865
Rtree_2727_15 sp__2727_80 sp__2727_84 21.8334
Rtree_2727_16 sp__2727_84 sp__2727_88 21.8334
Rtree_2727_17 sp__2727_88 sp__2727_94 41.5862
Rtree_2727_18 sp__2727_94 sp__11368_CLK 20
Rtree_2727_19 sp__2727_88 sp__2727_101 2.266
Rtree_2727_20 sp__2727_101 sp__11949_CLK 21.8334
Rtree_2727_21 sp__2727_101 sp__11091_CLK 21.339
Rtree_2727_22 sp__2727_84 sp__2727_121 23.1106
Rtree_2727_23 sp__2727_121 sp__2727_123 3.9964
Rtree_2727_24 sp__2727_123 sp__2727_125 1.8334
Rtree_2727_25 sp__2727_125 sp__11096_CLK 22.8634
Rtree_2727_26 sp__2727_125 sp__11093_CLK 20.5974
Rtree_2727_27 sp__2727_123 sp__2727_147 42.575
Rtree_2727_28 sp__2727_147 sp__11380_CLK 20
Rtree_2727_29 sp__2727_121 sp__11097_CLK 20.5974
Rtree_2727_30 sp__2727_80 sp__11367_CLK 20
Rtree_2727_31 sp__2727_35 sp__11353_CLK 20
Rtree_2727_32 sp__2727_31 sp__11366_CLK 43.605
Rtree_2727_33 sp__2727_27 sp__11354_CLK 20
Rtree_2727_34 sp__2727_23 sp__11365_CLK 20
Rtree_2727_35 sp__2727_8 sp__11355_CLK 42.0806
Ctree_2727_1 sp__11355_CLK 0 2.47911e-16
Ctree_2727_4 sp__11366_CLK 0 3.35826e-16
Ctree_2727_7 sp__11097_CLK 0 4.95132e-17
Ctree_2727_9 sp__11093_CLK 0 3.71349e-17
Ctree_2727_10 sp__11096_CLK 0 2.65588e-16
Ctree_2727_11 sp__11091_CLK 0 1.09717e-16
Ctree_2727_12 sp__11949_CLK 0 1.67815e-16
Ctree_2727_14 sp__11379_CLK 0 2.60765e-16
Ctree_2727_16 sp__11101_CLK 0 8.60167e-16
Ctree_2727_17 sp__11364_CLK 0 2.49102e-16
Ctree_2727_18 sp__12034_X 0 1.54533e-16
Ctree_2727_19 sp__2727_147 0 2.46693e-16
Ctree_2727_20 sp__2727_125 0 5.00691e-16
Ctree_2727_21 sp__2727_123 0 8.46945e-16
Ctree_2727_22 sp__2727_121 0 7.81676e-16
Ctree_2727_23 sp__2727_101 0 4.90363e-16
Ctree_2727_24 sp__2727_94 0 1.11565e-16
Ctree_2727_25 sp__2727_88 0 5.25271e-16
Ctree_2727_26 sp__2727_84 0 7.78766e-16
Ctree_2727_27 sp__2727_80 0 7.20989e-16
Ctree_2727_28 sp__2727_65 0 1.02307e-15
Ctree_2727_29 sp__2727_54 0 4.16417e-16
Ctree_2727_30 sp__2727_37 0 1.41222e-15
Ctree_2727_31 sp__2727_35 0 5.69245e-16
Ctree_2727_32 sp__2727_31 0 8.88627e-16
Ctree_2727_33 sp__2727_27 0 6.75183e-16
Ctree_2727_34 sp__2727_23 0 4.56619e-16
Ctree_2727_35 sp__2727_10 0 8.10729e-16
Ctree_2727_36 sp__2727_8 0 7.74113e-16
Ctree_2727_53 sp__11949_CLK 0 1.54556e-17
Ctree_2727_56 sp__2727_8 0 1.54008e-17
Ctree_2727_57 sp__2727_8 0 2.41815e-16
Ctree_2727_75 sp__2727_80 0 1.82525e-16
Ctree_2727_90 sp__2727_147 0 2.34681e-16
Ctree_2727_93 sp__2727_10 0 2.87256e-16
Ctree_2727_94 sp__11366_CLK 0 7.62389e-17
Ctree_2727_95 sp__2727_94 0 3.45063e-16
Ctree_2727_97 sp__11366_CLK 0 3.39475e-16
Rtree_2728_1 sp__12035_X sp__2728_6 21.4008
Rtree_2728_2 sp__2728_6 sp__2728_14 23.8625
Rtree_2728_3 sp__2728_14 sp__2728_20 26.1697
Rtree_2728_4 sp__2728_20 sp__2728_26 23.2628
Rtree_2728_5 sp__2728_26 sp__11098_CLK 40
Rtree_2728_6 sp__2728_26 sp__2728_35 1.0918
Rtree_2728_7 sp__2728_35 sp__2728_39 22.266
Rtree_2728_8 sp__2728_39 sp__2728_41 3.9964
Rtree_2728_9 sp__2728_41 sp__2728_43 1.8334
Rtree_2728_10 sp__2728_43 sp__2728_51 3.5638
Rtree_2728_11 sp__2728_51 sp__11913_CLK 21.8334
Rtree_2728_12 sp__2728_51 sp__11123_CLK 20
Rtree_2728_13 sp__2728_43 sp__2728_69 43.0694
Rtree_2728_14 sp__2728_69 sp__11085_CLK 20
Rtree_2728_15 sp__2728_41 sp__11915_CLK 20.5974
Rtree_2728_16 sp__2728_39 sp__11914_CLK 20.5974
Rtree_2728_17 sp__2728_35 sp__2728_90 1.8334
Rtree_2728_18 sp__2728_90 sp__11892_CLK 43.9964
Rtree_2728_19 sp__2728_90 sp__2728_105 23.1724
Rtree_2728_20 sp__2728_105 sp__2728_109 23.0694
Rtree_2728_21 sp__2728_109 sp__11122_CLK 45.4384
Rtree_2728_22 sp__2728_109 sp__11961_CLK 46.1594
Rtree_2728_23 sp__2728_105 sp__11094_CLK 20
Rtree_2728_24 sp__2728_20 sp__12113_A 20
Rtree_2728_25 sp__2728_14 sp__2728_145 21.1845
Rtree_2728_26 sp__2728_145 sp__11100_CLK 20
Rtree_2728_27 sp__2728_145 sp__2728_156 29.9086
Rtree_2728_28 sp__2728_156 sp__2728_162 30.2794
Rtree_2728_29 sp__2728_162 sp__11108_CLK 20
Rtree_2728_30 sp__2728_156 sp__2728_173 30.8356
Rtree_2728_31 sp__2728_173 sp__11377_CLK 20
Rtree_2728_32 sp__2728_6 sp__11095_CLK 20
Ctree_2728_7 sp__11961_CLK 0 5.38406e-16
Ctree_2728_8 sp__11122_CLK 0 5.32366e-16
Ctree_2728_9 sp__11892_CLK 0 3.19655e-16
Ctree_2728_10 sp__11914_CLK 0 4.95132e-17
Ctree_2728_11 sp__11915_CLK 0 4.7379e-17
Ctree_2728_14 sp__11913_CLK 0 1.91729e-16
Ctree_2728_16 sp__12035_X 0 1.38026e-16
Ctree_2728_17 sp__2728_173 0 1.01634e-15
Ctree_2728_18 sp__2728_162 0 9.79848e-16
Ctree_2728_19 sp__2728_156 0 2.75857e-15
Ctree_2728_20 sp__2728_145 0 8.72829e-16
Ctree_2728_21 sp__2728_109 0 1.42636e-15
Ctree_2728_22 sp__2728_105 0 6.34591e-16
Ctree_2728_23 sp__2728_90 0 6.6896e-16
Ctree_2728_24 sp__2728_69 0 2.05594e-16
Ctree_2728_25 sp__2728_51 0 5.16563e-16
Ctree_2728_26 sp__2728_43 0 7.47641e-16
Ctree_2728_27 sp__2728_41 0 6.24619e-16
Ctree_2728_28 sp__2728_39 0 5.57671e-16
Ctree_2728_29 sp__2728_35 0 2.6147e-16
Ctree_2728_30 sp__2728_26 0 3.36513e-16
Ctree_2728_31 sp__2728_20 0 9.48814e-16
Ctree_2728_32 sp__2728_14 0 1.17099e-15
Ctree_2728_33 sp__2728_6 0 5.43235e-16
Ctree_2728_42 sp__11961_CLK 0 5.31697e-16
Ctree_2728_43 sp__11961_CLK 0 8.87549e-16
Ctree_2728_47 sp__2728_20 0 4.6793e-17
Ctree_2728_49 sp__2728_20 0 7.51285e-17
Ctree_2728_52 sp__2728_26 0 1.54008e-17
Ctree_2728_53 sp__2728_26 0 4.481e-16
Ctree_2728_54 sp__2728_35 0 2.34704e-16
Ctree_2728_55 sp__2728_39 0 3.22734e-16
Ctree_2728_56 sp__2728_41 0 1.75818e-16
Ctree_2728_59 sp__2728_43 0 1.54008e-17
Ctree_2728_62 sp__2728_69 0 2.87672e-16
Ctree_2728_64 sp__2728_69 0 6.59876e-16
Ctree_2728_65 sp__2728_90 0 3.96405e-16
Ctree_2728_67 sp__2728_105 0 2.87935e-16
Ctree_2728_68 sp__2728_105 0 4.77425e-17
Ctree_2728_69 sp__2728_105 0 4.77425e-17
Ctree_2728_72 sp__2728_109 0 2.20248e-17
Ctree_2728_73 sp__2728_145 0 1.76501e-16
Ctree_2728_74 sp__2728_156 0 1.9264e-16
Ctree_2728_77 sp__2728_156 0 4.99799e-16
Ctree_2728_78 sp__2728_156 0 1.04363e-15
Ctree_2728_79 sp__2728_156 0 7.13368e-16
Ctree_2728_81 sp__2728_162 0 8.77916e-16
Ctree_2728_88 sp__2728_173 0 1.76301e-16
Ctree_2728_93 sp__2728_173 0 9.21443e-16
Ctree_2728_96 sp__2728_20 0 4.34882e-16
Ctree_2728_99 sp__2728_162 0 1.26855e-16
Ctree_2728_100 sp__2728_162 0 2.11035e-16
Ctree_2728_106 sp__11122_CLK 0 2.88087e-16
Ctree_2728_108 sp__2728_26 0 4.48515e-16
Ctree_2728_109 sp__2728_35 0 2.1252e-16
Ctree_2728_110 sp__2728_90 0 3.74381e-16
Ctree_2728_111 sp__2728_105 0 1.59274e-16
Rtree_2729_1 sp__12036_X sp__2729_8 22.6162
Rtree_2729_2 sp__2729_8 sp__11384_CLK 20
Rtree_2729_3 sp__2729_8 sp__2729_15 3.9964
Rtree_2729_4 sp__2729_15 sp__2729_21 42.0806
Rtree_2729_5 sp__2729_21 sp__2729_27 4.4496
Rtree_2729_6 sp__2729_27 sp__11955_CLK 20
Rtree_2729_7 sp__2729_27 sp__2729_40 43.6359
Rtree_2729_8 sp__2729_40 sp__11369_CLK 24.0891
Rtree_2729_9 sp__2729_40 sp__11092_CLK 23.7801
Rtree_2729_10 sp__2729_21 sp__2729_64 2.1836
Rtree_2729_11 sp__2729_64 sp__2729_72 44.223
Rtree_2729_12 sp__2729_72 sp__2729_76 3.0488
Rtree_2729_13 sp__2729_76 sp__2729_84 43.8522
Rtree_2729_14 sp__2729_84 sp__11962_CLK 20
Rtree_2729_15 sp__2729_76 sp__11383_CLK 20
Rtree_2729_16 sp__2729_72 sp__2729_98 22.8222
Rtree_2729_17 sp__2729_98 sp__2729_102 20.9682
Rtree_2729_18 sp__2729_102 sp__11382_CLK 20
Rtree_2729_19 sp__2729_102 sp__12118_A 31.2682
Rtree_2729_20 sp__2729_98 sp__11381_CLK 44.5732
Rtree_2729_21 sp__2729_64 sp__11956_CLK 20
Rtree_2729_22 sp__2729_15 sp__11090_CLK 20
Rtree_2729_23 sp__12036_X sp__2729_152 23.3475
Rtree_2729_24 sp__2729_152 sp__2729_160 43.605
Rtree_2729_25 sp__2729_160 sp__2729_170 43.2754
Rtree_2729_26 sp__2729_170 sp__11963_CLK 20
Rtree_2729_27 sp__2729_160 sp__11088_CLK 20
Rtree_2729_28 sp__2729_152 sp__11960_CLK 20
Rtree_2729_29 sp__12036_X sp__2729_194 45.047
Rtree_2729_30 sp__2729_194 sp__11958_CLK 40
Rtree_2729_31 sp__2729_194 sp__11087_CLK 43.605
Ctree_2729_1 sp__11087_CLK 0 3.55513e-16
Ctree_2729_8 sp__11381_CLK 0 4.26783e-16
Ctree_2729_9 sp__12118_A 0 1.08958e-15
Ctree_2729_13 sp__11092_CLK 0 3.43313e-16
Ctree_2729_14 sp__11369_CLK 0 3.97995e-16
Ctree_2729_17 sp__12036_X 0 9.64912e-16
Ctree_2729_18 sp__2729_194 0 7.18575e-16
Ctree_2729_19 sp__2729_170 0 2.89262e-16
Ctree_2729_20 sp__2729_160 0 6.22905e-16
Ctree_2729_21 sp__2729_152 0 6.77275e-16
Ctree_2729_22 sp__2729_102 0 1.17519e-15
Ctree_2729_23 sp__2729_98 0 8.02941e-16
Ctree_2729_24 sp__2729_84 0 3.6064e-16
Ctree_2729_25 sp__2729_76 0 6.54714e-16
Ctree_2729_26 sp__2729_72 0 9.47078e-16
Ctree_2729_27 sp__2729_64 0 5.57976e-16
Ctree_2729_28 sp__2729_40 0 9.79755e-16
Ctree_2729_29 sp__2729_27 0 7.54896e-16
Ctree_2729_30 sp__2729_21 0 8.60576e-16
Ctree_2729_31 sp__2729_15 0 5.01121e-16
Ctree_2729_32 sp__2729_8 0 6.10728e-16
Ctree_2729_35 sp__11087_CLK 0 1.54008e-17
Ctree_2729_38 sp__11092_CLK 0 1.54008e-17
Ctree_2729_39 sp__11092_CLK 0 1.43171e-16
Ctree_2729_40 sp__11381_CLK 0 1.12078e-16
Ctree_2729_43 sp__12118_A 0 2.08173e-16
Ctree_2729_44 sp__12118_A 0 2.42286e-16
Ctree_2729_45 sp__12118_A 0 2.58589e-16
Ctree_2729_55 sp__2729_15 0 4.69121e-16
Ctree_2729_57 sp__2729_21 0 4.47182e-16
Ctree_2729_58 sp__2729_27 0 1.54446e-17
Ctree_2729_59 sp__2729_27 0 4.77425e-17
Ctree_2729_61 sp__2729_40 0 2.37794e-16
Ctree_2729_62 sp__2729_40 0 7.23241e-16
Ctree_2729_64 sp__2729_64 0 1.0226e-16
Ctree_2729_65 sp__2729_64 0 2.09505e-16
Ctree_2729_69 sp__2729_72 0 1.81192e-16
Ctree_2729_70 sp__2729_72 0 2.09676e-16
Ctree_2729_74 sp__2729_76 0 4.78028e-17
Ctree_2729_84 sp__2729_102 0 1.44448e-16
Ctree_2729_88 sp__2729_160 0 1.54008e-17
Ctree_2729_89 sp__2729_160 0 2.88173e-16
Ctree_2729_91 sp__2729_170 0 2.87672e-16
Ctree_2729_92 sp__2729_170 0 4.77425e-17
Ctree_2729_93 sp__2729_170 0 2.41374e-16
Ctree_2729_95 sp__2729_194 0 6.05447e-16
Ctree_2729_101 sp__2729_152 0 2.4205e-16
Ctree_2729_103 sp__12118_A 0 1.45095e-16
Ctree_2729_104 sp__11092_CLK 0 3.05219e-16
Ctree_2729_105 sp__11369_CLK 0 1.24763e-16
Ctree_2729_106 sp__2729_194 0 2.87256e-16
Ctree_2729_113 sp__11369_CLK 0 4.78359e-17
Rtree_2730_1 sp__12037_X sp__2730_8 41.6171
Rtree_2730_2 sp__2730_8 sp__2730_10 0.8446
Rtree_2730_3 sp__2730_10 sp__2730_14 26.8134
Rtree_2730_4 sp__2730_14 sp__11954_CLK 20
Rtree_2730_5 sp__2730_14 sp__2730_23 5.0882
Rtree_2730_6 sp__2730_23 sp__11953_CLK 20
Rtree_2730_7 sp__2730_23 sp__2730_34 24.1612
Rtree_2730_8 sp__2730_34 sp__2730_38 24.5526
Rtree_2730_9 sp__2730_38 sp__11950_CLK 22.1836
Rtree_2730_10 sp__2730_38 sp__11951_CLK 22.6162
Rtree_2730_11 sp__2730_34 sp__11952_CLK 40
Rtree_2730_12 sp__2730_10 sp__2730_65 20
Rtree_2730_13 sp__2730_65 sp__10960_CLK 20
Rtree_2730_14 sp__2730_65 sp__2730_72 0.7246
Rtree_2730_15 sp__2730_72 sp__10958_CLK 24.6968
Rtree_2730_16 sp__2730_72 sp__10959_CLK 20
Rtree_2730_17 sp__2730_8 sp__2730_90 1.5862
Rtree_2730_18 sp__2730_90 sp__10961_CLK 43.9964
Rtree_2730_19 sp__2730_90 sp__2730_101 4.5526
Rtree_2730_20 sp__2730_101 sp__10962_CLK 40
Rtree_2730_21 sp__2730_101 sp__2730_110 2.0806
Rtree_2730_22 sp__2730_110 sp__2730_112 20
Rtree_2730_23 sp__2730_112 sp__10964_CLK 21.8334
Rtree_2730_24 sp__2730_112 sp__10963_CLK 22.8634
Rtree_2730_25 sp__2730_110 sp__11967_CLK 44.7998
Rtree_2730_26 sp__12037_X sp__2730_144 23.9084
Rtree_2730_27 sp__2730_144 sp__2730_146 0.3502
Rtree_2730_28 sp__2730_146 sp__11957_CLK 22.3964
Rtree_2730_29 sp__2730_146 sp__11089_CLK 20
Rtree_2730_30 sp__2730_144 sp__11959_CLK 23.6248
Ctree_2730_1 sp__11959_CLK 0 3.90672e-16
Ctree_2730_3 sp__11957_CLK 0 2.28695e-16
Ctree_2730_4 sp__11967_CLK 0 4.37936e-16
Ctree_2730_5 sp__10963_CLK 0 2.92405e-16
Ctree_2730_6 sp__10964_CLK 0 1.54003e-16
Ctree_2730_8 sp__10961_CLK 0 2.52127e-16
Ctree_2730_10 sp__10958_CLK 0 4.14801e-16
Ctree_2730_13 sp__11951_CLK 0 2.59531e-16
Ctree_2730_14 sp__11950_CLK 0 2.16115e-16
Ctree_2730_17 sp__12037_X 0 5.50491e-16
Ctree_2730_18 sp__2730_146 0 2.56422e-16
Ctree_2730_19 sp__2730_144 0 8.17756e-16
Ctree_2730_20 sp__2730_112 0 4.46408e-16
Ctree_2730_21 sp__2730_110 0 6.38893e-16
Ctree_2730_22 sp__2730_101 0 5.97542e-16
Ctree_2730_23 sp__2730_90 0 8.11045e-16
Ctree_2730_24 sp__2730_72 0 5.658e-16
Ctree_2730_25 sp__2730_65 0 1.51e-16
Ctree_2730_26 sp__2730_38 0 7.99756e-16
Ctree_2730_27 sp__2730_34 0 6.50993e-16
Ctree_2730_28 sp__2730_23 0 7.60997e-16
Ctree_2730_29 sp__2730_14 0 1.16487e-15
Ctree_2730_30 sp__2730_10 0 8.18113e-16
Ctree_2730_31 sp__2730_8 0 4.00824e-16
Ctree_2730_37 sp__11950_CLK 0 1.43888e-16
Ctree_2730_42 sp__11959_CLK 0 2.4669e-17
Ctree_2730_50 sp__2730_23 0 5.98581e-16
Ctree_2730_53 sp__2730_38 0 4.47798e-16
Ctree_2730_57 sp__2730_101 0 5.07615e-16
Ctree_2730_59 sp__2730_110 0 7.35528e-17
Ctree_2730_61 sp__2730_144 0 1.40528e-16
Ctree_2730_71 sp__2730_34 0 4.79276e-16
Ctree_2730_72 sp__2730_38 0 7.17243e-16
Ctree_2730_74 sp__2730_14 0 1.8416e-16
Ctree_2730_76 sp__11950_CLK 0 1.54008e-17
Ctree_2730_77 sp__11951_CLK 0 1.12099e-16
Ctree_2730_82 sp__2730_34 0 3.48636e-16
Ctree_2730_85 sp__2730_144 0 1.4396e-16
Ctree_2730_88 sp__10964_CLK 0 2.7466e-16
Rtree_2731_1 sp__12038_X sp__2731_6 20.3502
Rtree_2731_2 sp__2731_6 sp__2731_12 22.4308
Rtree_2731_3 sp__2731_12 sp__11985_CLK 40.8446
Rtree_2731_4 sp__2731_12 sp__2731_25 21.8334
Rtree_2731_5 sp__2731_25 sp__2731_29 20.5356
Rtree_2731_6 sp__2731_29 sp__2731_35 27.3748
Rtree_2731_7 sp__2731_35 sp__2731_39 5.3354
Rtree_2731_8 sp__2731_39 sp__10900_CLK 26.077
Rtree_2731_9 sp__2731_39 sp__11120_CLK 20
Rtree_2731_10 sp__2731_35 sp__11984_CLK 20
Rtree_2731_11 sp__2731_29 sp__2731_64 30.5884
Rtree_2731_12 sp__2731_64 sp__11965_CLK 20
Rtree_2731_13 sp__2731_25 sp__11968_CLK 20
Rtree_2731_14 sp__2731_6 sp__2731_76 2.266
Rtree_2731_15 sp__2731_76 sp__12119_A 20
Rtree_2731_16 sp__2731_76 sp__2731_85 27.8898
Rtree_2731_17 sp__2731_85 sp__2731_87 5.2942
Rtree_2731_18 sp__2731_87 sp__11982_CLK 43.0844
Rtree_2731_19 sp__2731_87 sp__11983_CLK 40
Rtree_2731_20 sp__2731_85 sp__2731_107 2.575
Rtree_2731_21 sp__2731_107 sp__11986_CLK 40
Rtree_2731_22 sp__2731_107 sp__11987_CLK 46.7774
Ctree_2731_1 sp__11987_CLK 0 6.02068e-16
Ctree_2731_4 sp__11982_CLK 0 2.66517e-16
Ctree_2731_10 sp__10900_CLK 0 5.79671e-16
Ctree_2731_11 sp__11985_CLK 0 7.81487e-17
Ctree_2731_12 sp__12038_X 0 2.77263e-17
Ctree_2731_13 sp__2731_107 0 7.97977e-16
Ctree_2731_14 sp__2731_87 0 6.34189e-16
Ctree_2731_15 sp__2731_85 0 1.32318e-15
Ctree_2731_16 sp__2731_76 0 9.98357e-16
Ctree_2731_17 sp__2731_64 0 8.95414e-16
Ctree_2731_18 sp__2731_39 0 1.09365e-15
Ctree_2731_19 sp__2731_35 0 1.03445e-15
Ctree_2731_20 sp__2731_29 0 1.47224e-15
Ctree_2731_21 sp__2731_25 0 2.2279e-16
Ctree_2731_22 sp__2731_12 0 5.10482e-16
Ctree_2731_23 sp__2731_6 0 5.32387e-16
Ctree_2731_24 sp__10900_CLK 0 2.59051e-16
Ctree_2731_25 sp__10900_CLK 0 3.39344e-16
Ctree_2731_28 sp__11982_CLK 0 2.89003e-16
Ctree_2731_38 sp__11987_CLK 0 5.53544e-16
Ctree_2731_50 sp__2731_35 0 1.19502e-15
Ctree_2731_55 sp__2731_39 0 1.45003e-16
Ctree_2731_59 sp__2731_64 0 9.27791e-16
Ctree_2731_61 sp__2731_76 0 2.08878e-16
Ctree_2731_63 sp__2731_85 0 1.54008e-17
Ctree_2731_65 sp__2731_85 0 2.09681e-16
Ctree_2731_66 sp__2731_85 0 9.062e-16
Ctree_2731_67 sp__2731_87 0 9.82154e-16
Ctree_2731_69 sp__2731_87 0 1.59096e-16
Ctree_2731_72 sp__2731_107 0 3.42035e-16
Ctree_2731_83 sp__2731_85 0 4.79124e-17
Ctree_2731_84 sp__11987_CLK 0 1.28742e-16
Rtree_2732_1 sp__12039_X sp__2732_6 23.3475
Rtree_2732_2 sp__2732_6 sp__2732_12 25.8298
Rtree_2732_3 sp__2732_12 sp__11942_CLK 40
Rtree_2732_4 sp__2732_12 sp__2732_21 0.8446
Rtree_2732_5 sp__2732_21 sp__11941_CLK 41.8334
Rtree_2732_6 sp__2732_21 sp__2732_32 4.5526
Rtree_2732_7 sp__2732_32 sp__2732_40 44.4084
Rtree_2732_8 sp__2732_40 sp__10897_CLK 42.266
Rtree_2732_9 sp__2732_32 sp__2732_53 30.4854
Rtree_2732_10 sp__2732_53 sp__10871_CLK 20
Rtree_2732_11 sp__2732_6 sp__11940_CLK 20
Rtree_2732_12 sp__12039_X sp__2732_72 41.8334
Rtree_2732_13 sp__2732_72 sp__2732_74 3.5638
Rtree_2732_14 sp__2732_74 sp__2732_78 21.8334
Rtree_2732_15 sp__2732_78 sp__2732_84 8.343
Rtree_2732_16 sp__2732_84 sp__2732_92 44.4084
Rtree_2732_17 sp__2732_92 sp__2732_96 4.3466
Rtree_2732_18 sp__2732_96 sp__2732_100 2.1836
Rtree_2732_19 sp__2732_100 sp__11890_CLK 20.5974
Rtree_2732_20 sp__2732_100 sp__2732_109 2.266
Rtree_2732_21 sp__2732_109 sp__10899_CLK 20
Rtree_2732_22 sp__2732_109 sp__2732_118 4.5938
Rtree_2732_23 sp__2732_118 sp__10898_CLK 20
Rtree_2732_24 sp__2732_118 sp__2732_127 21.8334
Rtree_2732_25 sp__2732_127 sp__11084_CLK 42.3278
Rtree_2732_26 sp__2732_127 sp__10901_CLK 45.3354
Rtree_2732_27 sp__2732_96 sp__11937_CLK 20
Rtree_2732_28 sp__2732_92 sp__11938_CLK 20
Rtree_2732_29 sp__2732_84 sp__11939_CLK 20
Rtree_2732_30 sp__2732_78 sp__11121_CLK 20
Rtree_2732_31 sp__2732_74 sp__10902_CLK 43.9964
Rtree_2732_32 sp__2732_72 sp__11126_CLK 41.5862
Ctree_2732_1 sp__11126_CLK 0 9.82331e-17
Ctree_2732_2 sp__10902_CLK 0 4.64512e-16
Ctree_2732_7 sp__10901_CLK 0 5.50664e-16
Ctree_2732_8 sp__11084_CLK 0 2.54426e-16
Ctree_2732_11 sp__11890_CLK 0 4.57023e-17
Ctree_2732_14 sp__10897_CLK 0 2.17596e-16
Ctree_2732_15 sp__11941_CLK 0 1.90138e-16
Ctree_2732_17 sp__12039_X 0 5.02868e-16
Ctree_2732_18 sp__2732_127 0 1.00881e-15
Ctree_2732_19 sp__2732_118 0 7.49342e-16
Ctree_2732_20 sp__2732_109 0 7.68761e-16
Ctree_2732_21 sp__2732_100 0 4.89394e-16
Ctree_2732_22 sp__2732_96 0 7.28964e-16
Ctree_2732_23 sp__2732_92 0 1.07641e-15
Ctree_2732_24 sp__2732_84 0 1.42623e-15
Ctree_2732_25 sp__2732_78 0 9.97307e-16
Ctree_2732_26 sp__2732_74 0 8.33436e-16
Ctree_2732_27 sp__2732_72 0 5.33218e-16
Ctree_2732_28 sp__2732_53 0 6.42269e-16
Ctree_2732_29 sp__2732_40 0 6.34127e-16
Ctree_2732_30 sp__2732_32 0 1.50027e-15
Ctree_2732_31 sp__2732_21 0 7.23652e-16
Ctree_2732_32 sp__2732_12 0 6.63705e-16
Ctree_2732_33 sp__2732_6 0 8.69394e-16
Ctree_2732_35 sp__10897_CLK 0 3.3942e-16
Ctree_2732_36 sp__10901_CLK 0 2.73119e-16
Ctree_2732_46 sp__11126_CLK 0 3.41534e-16
Ctree_2732_48 sp__2732_6 0 2.09746e-16
Ctree_2732_49 sp__2732_6 0 8.00842e-17
Ctree_2732_50 sp__2732_6 0 4.84072e-16
Ctree_2732_51 sp__2732_12 0 2.40536e-16
Ctree_2732_52 sp__2732_12 0 4.78192e-17
Ctree_2732_54 sp__2732_12 0 4.77425e-17
Ctree_2732_55 sp__2732_12 0 1.44791e-16
Ctree_2732_56 sp__2732_12 0 3.3743e-16
Ctree_2732_59 sp__2732_40 0 5.30962e-16
Ctree_2732_60 sp__2732_40 0 3.70493e-16
Ctree_2732_61 sp__2732_53 0 1.29659e-16
Ctree_2732_65 sp__2732_74 0 7.66204e-16
Ctree_2732_67 sp__2732_78 0 2.34172e-16
Ctree_2732_68 sp__2732_78 0 1.59096e-16
Ctree_2732_69 sp__2732_84 0 8.01938e-17
Ctree_2732_70 sp__2732_84 0 1.75709e-16
Ctree_2732_72 sp__2732_84 0 2.73562e-16
Ctree_2732_75 sp__2732_84 0 2.40459e-16
Ctree_2732_80 sp__2732_92 0 4.77425e-17
Ctree_2732_98 sp__2732_12 0 1.44068e-16
Ctree_2732_104 sp__2732_32 0 2.35228e-16
Ctree_2732_105 sp__2732_53 0 1.06894e-16
Ctree_2732_106 sp__2732_40 0 8.0216e-17
Ctree_2732_110 sp__2732_53 0 4.48427e-16
Ctree_2732_111 sp__2732_53 0 6.59135e-16
Ctree_2732_115 sp__10897_CLK 0 8.0216e-17
Ctree_2732_116 sp__11941_CLK 0 1.6063e-16
Ctree_2732_117 sp__11941_CLK 0 1.1215e-16
Ctree_2732_118 sp__2732_109 0 2.07986e-16
Ctree_2732_125 sp__10902_CLK 0 2.41258e-16
Ctree_2732_127 sp__2732_53 0 2.15209e-15
Rtree_2733_1 sp__12040_X sp__2733_8 42.266
Rtree_2733_2 sp__2733_8 sp__2733_10 2.3278
Rtree_2733_3 sp__2733_10 sp__2733_12 0.8446
Rtree_2733_4 sp__2733_12 sp__2733_14 4.7998
Rtree_2733_5 sp__2733_14 sp__2733_16 3.5638
Rtree_2733_6 sp__2733_16 sp__11055_CLK 43.0282
Rtree_2733_7 sp__2733_16 sp__2733_33 22.266
Rtree_2733_8 sp__2733_33 sp__2733_41 44.4084
Rtree_2733_9 sp__2733_41 sp__2733_55 5.8195
Rtree_2733_10 sp__2733_55 sp__2733_63 43.1415
Rtree_2733_11 sp__2733_63 sp__11127_CLK 20
Rtree_2733_12 sp__2733_55 sp__11891_CLK 24.1303
Rtree_2733_13 sp__2733_41 sp__11889_CLK 20
Rtree_2733_14 sp__2733_33 sp__11058_CLK 20
Rtree_2733_15 sp__2733_14 sp__11056_CLK 40
Rtree_2733_16 sp__2733_12 sp__11059_CLK 41.8334
Rtree_2733_17 sp__2733_10 sp__12116_A 40
Rtree_2733_18 sp__2733_8 sp__2733_112 2.3278
Rtree_2733_19 sp__2733_112 sp__2733_122 26.5302
Rtree_2733_20 sp__2733_122 sp__2733_132 46.8598
Rtree_2733_21 sp__2733_132 sp__11061_CLK 20
Rtree_2733_22 sp__2733_122 sp__11060_CLK 20
Rtree_2733_23 sp__2733_112 sp__2733_144 10.7326
Rtree_2733_24 sp__2733_144 sp__2733_146 20
Rtree_2733_25 sp__2733_146 sp__11016_CLK 22.4308
Rtree_2733_26 sp__2733_146 sp__11017_CLK 20
Rtree_2733_27 sp__2733_144 sp__10873_CLK 45.5826
Ctree_2733_1 sp__10873_CLK 0 4.74505e-16
Ctree_2733_3 sp__11016_CLK 0 2.2173e-16
Ctree_2733_7 sp__11059_CLK 0 1.708e-16
Ctree_2733_11 sp__11891_CLK 0 4.3447e-16
Ctree_2733_13 sp__11055_CLK 0 2.39213e-16
Ctree_2733_14 sp__12040_X 0 2.40596e-16
Ctree_2733_15 sp__2733_146 0 2.2173e-16
Ctree_2733_16 sp__2733_144 0 1.54273e-15
Ctree_2733_17 sp__2733_132 0 6.25275e-16
Ctree_2733_18 sp__2733_122 0 1.31372e-15
Ctree_2733_19 sp__2733_112 0 2.04578e-15
Ctree_2733_20 sp__2733_63 0 2.31339e-16
Ctree_2733_21 sp__2733_55 0 1.21574e-15
Ctree_2733_22 sp__2733_41 0 9.09826e-16
Ctree_2733_23 sp__2733_33 0 6.23352e-16
Ctree_2733_24 sp__2733_16 0 8.542e-16
Ctree_2733_25 sp__2733_14 0 9.11973e-16
Ctree_2733_26 sp__2733_12 0 8.31133e-16
Ctree_2733_27 sp__2733_10 0 3.65371e-16
Ctree_2733_28 sp__2733_8 0 7.9519e-16
Ctree_2733_30 sp__10873_CLK 0 5.98225e-16
Ctree_2733_31 sp__10873_CLK 0 3.46272e-16
Ctree_2733_33 sp__11055_CLK 0 2.08815e-16
Ctree_2733_34 sp__11059_CLK 0 2.7365e-16
Ctree_2733_41 sp__2733_41 0 1.54008e-17
Ctree_2733_43 sp__2733_55 0 8.00842e-17
Ctree_2733_47 sp__2733_63 0 3.94653e-16
Ctree_2733_50 sp__2733_122 0 8.00842e-17
Ctree_2733_51 sp__2733_122 0 2.41066e-16
Ctree_2733_52 sp__2733_132 0 4.77425e-17
Ctree_2733_53 sp__2733_132 0 3.06531e-16
Ctree_2733_54 sp__2733_132 0 1.44791e-16
Ctree_2733_55 sp__2733_132 0 5.15776e-16
Ctree_2733_58 sp__2733_144 0 8.59816e-16
Ctree_2733_59 sp__2733_144 0 2.38126e-16
Ctree_2733_60 sp__11891_CLK 0 7.17476e-17
Ctree_2733_63 sp__2733_55 0 7.00114e-17
Ctree_2733_66 sp__2733_122 0 2.09306e-16
Ctree_2733_68 sp__11016_CLK 0 2.0896e-16
Ctree_2733_69 sp__2733_122 0 1.54556e-17
Ctree_2733_70 sp__11055_CLK 0 2.08661e-16
Ctree_2733_72 sp__2733_55 0 7.90445e-17
Ctree_2733_73 sp__2733_122 0 1.54008e-17
Ctree_2733_74 sp__2733_144 0 1.29043e-16
Ctree_2733_76 sp__10873_CLK 0 1.30162e-16
Ctree_2733_77 sp__2733_132 0 2.41759e-16
Ctree_2733_79 sp__2733_63 0 1.8128e-16
Ctree_2733_87 sp__2733_41 0 3.97606e-16
Ctree_2733_88 sp__11055_CLK 0 2.3837e-16
Ctree_2733_91 sp__2733_122 0 1.12519e-16
Ctree_2733_96 sp__2733_16 0 3.99241e-16
Ctree_2733_97 sp__2733_132 0 1.2816e-16
Rtree_2734_1 sp__12041_X sp__2734_8 41.5862
Rtree_2734_2 sp__2734_8 sp__2734_10 4.7998
Rtree_2734_3 sp__2734_10 sp__2734_14 1.6274
Rtree_2734_4 sp__2734_14 sp__2734_18 28.5078
Rtree_2734_5 sp__2734_18 sp__11070_CLK 21.8334
Rtree_2734_6 sp__2734_18 sp__2734_35 47.9104
Rtree_2734_7 sp__2734_35 sp__11062_CLK 20
Rtree_2734_8 sp__2734_14 sp__11021_CLK 40
Rtree_2734_9 sp__2734_10 sp__2734_57 45.7783
Rtree_2734_10 sp__2734_57 sp__2734_61 22.4823
Rtree_2734_11 sp__2734_61 sp__2734_73 46.5302
Rtree_2734_12 sp__2734_73 sp__11744_CLK 20
Rtree_2734_13 sp__2734_61 sp__11022_CLK 20
Rtree_2734_14 sp__2734_8 sp__2734_87 22.2322
Rtree_2734_15 sp__2734_87 sp__2734_91 20.5974
Rtree_2734_16 sp__2734_91 sp__2734_101 25.7886
Rtree_2734_17 sp__2734_101 sp__11018_CLK 28.0032
Rtree_2734_18 sp__2734_101 sp__11020_CLK 20
Rtree_2734_19 sp__2734_91 sp__11019_CLK 45.7268
Rtree_2734_20 sp__2734_87 sp__12117_A 20
Rtree_2734_21 sp__12041_X sp__2734_146 46.5302
Rtree_2734_22 sp__2734_146 sp__2734_148 20
Rtree_2734_23 sp__2734_148 sp__2734_150 1.8334
Rtree_2734_24 sp__2734_150 sp__2734_152 2.266
Rtree_2734_25 sp__2734_152 sp__2734_156 20.5356
Rtree_2734_26 sp__2734_156 sp__10883_CLK 44.9028
Rtree_2734_27 sp__2734_156 sp__10884_CLK 43.7286
Rtree_2734_28 sp__2734_152 sp__10882_CLK 20
Rtree_2734_29 sp__2734_150 sp__10881_CLK 20
Rtree_2734_30 sp__2734_148 sp__10886_CLK 20
Ctree_2734_4 sp__10884_CLK 0 3.66126e-16
Ctree_2734_5 sp__10883_CLK 0 4.90786e-16
Ctree_2734_7 sp__11019_CLK 0 6.43468e-16
Ctree_2734_9 sp__11018_CLK 0 9.27562e-16
Ctree_2734_14 sp__11070_CLK 0 1.82537e-16
Ctree_2734_15 sp__12041_X 0 7.21486e-16
Ctree_2734_16 sp__2734_156 0 8.9999e-16
Ctree_2734_17 sp__2734_152 0 2.747e-16
Ctree_2734_18 sp__2734_150 0 3.98664e-16
Ctree_2734_19 sp__2734_148 0 1.67041e-16
Ctree_2734_20 sp__2734_146 0 5.42242e-16
Ctree_2734_21 sp__2734_101 0 1.48764e-15
Ctree_2734_22 sp__2734_91 0 1.27818e-15
Ctree_2734_23 sp__2734_87 0 3.6853e-16
Ctree_2734_24 sp__2734_73 0 5.89241e-16
Ctree_2734_25 sp__2734_61 0 8.35413e-16
Ctree_2734_26 sp__2734_57 0 8.07968e-16
Ctree_2734_27 sp__2734_35 0 6.13414e-16
Ctree_2734_28 sp__2734_18 0 1.74485e-15
Ctree_2734_29 sp__2734_14 0 1.06169e-15
Ctree_2734_30 sp__2734_10 0 1.05898e-15
Ctree_2734_31 sp__2734_8 0 8.57533e-16
Ctree_2734_39 sp__11018_CLK 0 2.83588e-16
Ctree_2734_51 sp__2734_35 0 2.09296e-16
Ctree_2734_52 sp__2734_35 0 8.21813e-16
Ctree_2734_53 sp__2734_35 0 7.15749e-16
Ctree_2734_61 sp__2734_73 0 2.41631e-16
Ctree_2734_67 sp__2734_146 0 7.12287e-16
Ctree_2734_74 sp__2734_10 0 1.27744e-16
Ctree_2734_76 sp__2734_57 0 2.4105e-16
Ctree_2734_77 sp__2734_57 0 2.08615e-16
Ctree_2734_78 sp__2734_61 0 4.79124e-17
Ctree_2734_79 sp__2734_61 0 1.12651e-16
Ctree_2734_83 sp__2734_73 0 1.12826e-16
Ctree_2734_85 sp__2734_73 0 2.08487e-16
Ctree_2734_87 sp__10883_CLK 0 8.0128e-17
Ctree_2734_88 sp__2734_10 0 6.94438e-16
Ctree_2734_89 sp__2734_14 0 2.3701e-16
Ctree_2734_92 sp__2734_18 0 4.97643e-16
Ctree_2734_94 sp__2734_57 0 1.76405e-16
Ctree_2734_96 sp__2734_57 0 1.7637e-16
Ctree_2734_98 sp__2734_73 0 2.14736e-17
Ctree_2734_102 sp__2734_101 0 4.98294e-16
Ctree_2734_104 sp__2734_73 0 4.93922e-16
Ctree_2734_105 sp__2734_18 0 2.54111e-17
Rtree_2735_1 sp__12042_X sp__2735_10 42.8634
Rtree_2735_2 sp__2735_10 sp__2735_12 2.3278
Rtree_2735_3 sp__2735_12 sp__2735_16 22.0806
Rtree_2735_4 sp__2735_16 sp__2735_20 22.266
Rtree_2735_5 sp__2735_20 sp__11014_CLK 42.8222
Rtree_2735_6 sp__2735_20 sp__2735_35 25.3354
Rtree_2735_7 sp__2735_35 sp__2735_39 21.8334
Rtree_2735_8 sp__2735_39 sp__10885_CLK 43.8522
Rtree_2735_9 sp__2735_39 sp__10878_CLK 41.5862
Rtree_2735_10 sp__2735_35 sp__10876_CLK 20
Rtree_2735_11 sp__2735_16 sp__2735_68 2.1836
Rtree_2735_12 sp__2735_68 sp__2735_76 44.0994
Rtree_2735_13 sp__2735_76 sp__2735_80 5.2118
Rtree_2735_14 sp__2735_80 sp__2735_84 25.7886
Rtree_2735_15 sp__2735_84 sp__10880_CLK 40.9682
Rtree_2735_16 sp__2735_84 sp__2735_95 0.8446
Rtree_2735_17 sp__2735_95 sp__10879_CLK 40.9682
Rtree_2735_18 sp__2735_95 sp__10872_CLK 43.9758
Rtree_2735_19 sp__2735_80 sp__10888_CLK 22.3072
Rtree_2735_20 sp__2735_76 sp__11015_CLK 20
Rtree_2735_21 sp__2735_68 sp__10874_CLK 20
Rtree_2735_22 sp__2735_12 sp__10875_CLK 40
Rtree_2735_23 sp__2735_10 sp__10877_CLK 43.9964
Rtree_2735_24 sp__12042_X sp__2735_161 45.0882
Rtree_2735_25 sp__2735_161 sp__2735_163 20
Rtree_2735_26 sp__2735_163 sp__2735_165 1.8334
Rtree_2735_27 sp__2735_165 sp__2735_169 2.6162
Rtree_2735_28 sp__2735_169 sp__10799_CLK 20.3502
Rtree_2735_29 sp__2735_169 sp__10805_CLK 29.8754
Rtree_2735_30 sp__2735_165 sp__10801_CLK 20
Rtree_2735_31 sp__2735_163 sp__10800_CLK 20
Rtree_2735_32 sp__2735_161 sp__10891_CLK 47.1632
Ctree_2735_1 sp__10891_CLK 0 7.49722e-16
Ctree_2735_4 sp__10805_CLK 0 1.09431e-15
Ctree_2735_5 sp__10799_CLK 0 1.80126e-17
Ctree_2735_6 sp__10877_CLK 0 4.21098e-16
Ctree_2735_10 sp__10888_CLK 0 1.87945e-16
Ctree_2735_11 sp__10872_CLK 0 3.93375e-16
Ctree_2735_12 sp__10879_CLK 0 1.12367e-16
Ctree_2735_13 sp__10880_CLK 0 9.21972e-17
Ctree_2735_15 sp__10878_CLK 0 5.83459e-17
Ctree_2735_16 sp__10885_CLK 0 2.57794e-16
Ctree_2735_17 sp__11014_CLK 0 3.06401e-16
Ctree_2735_18 sp__12042_X 0 7.56954e-16
Ctree_2735_19 sp__2735_169 0 1.38584e-15
Ctree_2735_20 sp__2735_165 0 4.6971e-16
Ctree_2735_21 sp__2735_163 0 1.9619e-16
Ctree_2735_22 sp__2735_161 0 1.2467e-15
Ctree_2735_23 sp__2735_95 0 5.73222e-16
Ctree_2735_24 sp__2735_84 0 5.64333e-16
Ctree_2735_25 sp__2735_80 0 1.19444e-15
Ctree_2735_26 sp__2735_76 0 1.01017e-15
Ctree_2735_27 sp__2735_68 0 6.28826e-16
Ctree_2735_28 sp__2735_39 0 5.15554e-16
Ctree_2735_29 sp__2735_35 0 7.72412e-16
Ctree_2735_30 sp__2735_20 0 1.10397e-15
Ctree_2735_31 sp__2735_16 0 6.87943e-16
Ctree_2735_32 sp__2735_12 0 4.92195e-16
Ctree_2735_33 sp__2735_10 0 9.30393e-16
Ctree_2735_35 sp__10805_CLK 0 7.9703e-17
Ctree_2735_36 sp__10805_CLK 0 4.2478e-16
Ctree_2735_42 sp__10872_CLK 0 1.82121e-16
Ctree_2735_44 sp__10878_CLK 0 3.42364e-16
Ctree_2735_45 sp__10885_CLK 0 3.39317e-16
Ctree_2735_46 sp__10885_CLK 0 3.40704e-16
Ctree_2735_51 sp__10888_CLK 0 1.44562e-16
Ctree_2735_52 sp__10891_CLK 0 4.77425e-17
Ctree_2735_54 sp__10891_CLK 0 3.37693e-16
Ctree_2735_66 sp__2735_20 0 1.54556e-17
Ctree_2735_79 sp__2735_68 0 6.47382e-17
Ctree_2735_82 sp__2735_76 0 3.37353e-16
Ctree_2735_87 sp__2735_80 0 7.8864e-17
Ctree_2735_89 sp__2735_84 0 2.88184e-16
Ctree_2735_90 sp__2735_84 0 1.03713e-15
Ctree_2735_91 sp__2735_95 0 1.81192e-16
Ctree_2735_93 sp__2735_161 0 2.34224e-16
Ctree_2735_94 sp__2735_165 0 4.77425e-17
Ctree_2735_99 sp__10891_CLK 0 4.78356e-17
Ctree_2735_100 sp__10891_CLK 0 2.72729e-16
Ctree_2735_103 sp__2735_35 0 8.0122e-17
Ctree_2735_104 sp__10885_CLK 0 8.00951e-17
Ctree_2735_106 sp__2735_84 0 2.89113e-16
Ctree_2735_107 sp__10891_CLK 0 2.40405e-16
Ctree_2735_115 sp__10880_CLK 0 1.4444e-16
Ctree_2735_117 sp__10877_CLK 0 1.03517e-16
Ctree_2735_118 sp__10878_CLK 0 3.20595e-16
Ctree_2735_119 sp__10885_CLK 0 3.42035e-16
Ctree_2735_121 sp__10872_CLK 0 2.09123e-16
Ctree_2735_123 sp__2735_161 0 3.81442e-16
Ctree_2735_124 sp__2735_161 0 3.38732e-16
Ctree_2735_125 sp__2735_10 0 8.01609e-17
Ctree_2735_128 sp__10805_CLK 0 2.0972e-16
Ctree_2735_142 sp__2735_10 0 8.01609e-17
Rtree_2736_1 sp__12043_X sp__2736_8 22.6162
Rtree_2736_2 sp__2736_8 sp__2736_14 41.0918
Rtree_2736_3 sp__2736_14 sp__2736_18 4.3466
Rtree_2736_4 sp__2736_18 sp__2736_24 25.7062
Rtree_2736_5 sp__2736_24 sp__2736_30 25.8916
Rtree_2736_6 sp__2736_30 sp__11600_CLK 20
Rtree_2736_7 sp__2736_30 sp__2736_37 1.8334
Rtree_2736_8 sp__2736_37 sp__11543_CLK 20
Rtree_2736_9 sp__2736_37 sp__11601_CLK 22.266
Rtree_2736_10 sp__2736_24 sp__11497_CLK 40.5356
Rtree_2736_11 sp__2736_18 sp__11627_CLK 20
Rtree_2736_12 sp__2736_14 sp__12123_A 20
Rtree_2736_13 sp__2736_8 sp__2736_72 4.3466
Rtree_2736_14 sp__2736_72 sp__11453_CLK 20
Rtree_2736_15 sp__2736_72 sp__2736_85 25.6856
Rtree_2736_16 sp__2736_85 sp__2736_89 23.811
Rtree_2736_17 sp__2736_89 sp__11520_CLK 22.6162
Rtree_2736_18 sp__2736_89 sp__11394_CLK 22.4308
Rtree_2736_19 sp__2736_85 sp__11562_CLK 40.3502
Rtree_2736_20 sp__12043_X sp__2736_123 20.8446
Rtree_2736_21 sp__2736_123 sp__2736_127 22.575
Rtree_2736_22 sp__2736_127 sp__2736_133 24.3466
Rtree_2736_23 sp__2736_133 sp__2736_139 4.6968
Rtree_2736_24 sp__2736_139 sp__2736_147 44.5938
Rtree_2736_25 sp__2736_147 sp__11423_CLK 20
Rtree_2736_26 sp__2736_139 sp__11535_CLK 20
Rtree_2736_27 sp__2736_133 sp__11498_CLK 20
Rtree_2736_28 sp__2736_127 sp__2736_164 1.0918
Rtree_2736_29 sp__2736_164 sp__11454_CLK 40
Rtree_2736_30 sp__2736_164 sp__11727_CLK 45.5002
Rtree_2736_31 sp__2736_123 sp__11624_CLK 22.1836
Ctree_2736_1 sp__11624_CLK 0 2.33097e-16
Ctree_2736_2 sp__11727_CLK 0 3.61913e-16
Ctree_2736_7 sp__11562_CLK 0 3.29875e-17
Ctree_2736_8 sp__11394_CLK 0 2.34662e-16
Ctree_2736_9 sp__11520_CLK 0 2.80771e-16
Ctree_2736_13 sp__11497_CLK 0 6.59029e-17
Ctree_2736_14 sp__11601_CLK 0 2.01674e-16
Ctree_2736_17 sp__12043_X 0 3.16262e-16
Ctree_2736_18 sp__2736_164 0 4.05265e-16
Ctree_2736_19 sp__2736_147 0 3.40906e-16
Ctree_2736_20 sp__2736_139 0 7.74985e-16
Ctree_2736_21 sp__2736_133 0 8.14789e-16
Ctree_2736_22 sp__2736_127 0 5.72995e-16
Ctree_2736_23 sp__2736_123 0 4.5577e-16
Ctree_2736_24 sp__2736_89 0 8.47731e-16
Ctree_2736_25 sp__2736_85 0 8.82455e-16
Ctree_2736_26 sp__2736_72 0 9.91642e-16
Ctree_2736_27 sp__2736_37 0 3.68281e-16
Ctree_2736_28 sp__2736_30 0 5.91303e-16
Ctree_2736_29 sp__2736_24 0 8.84907e-16
Ctree_2736_30 sp__2736_18 0 8.05952e-16
Ctree_2736_31 sp__2736_14 0 5.36484e-16
Ctree_2736_32 sp__2736_8 0 8.41835e-16
Ctree_2736_33 sp__11394_CLK 0 2.08615e-16
Ctree_2736_36 sp__11601_CLK 0 3.38755e-16
Ctree_2736_39 sp__11624_CLK 0 1.54008e-17
Ctree_2736_40 sp__11727_CLK 0 7.22028e-16
Ctree_2736_41 sp__11727_CLK 0 2.72791e-16
Ctree_2736_42 sp__11727_CLK 0 6.99604e-16
Ctree_2736_43 sp__11727_CLK 0 1.54008e-17
Ctree_2736_45 sp__2736_8 0 3.05849e-16
Ctree_2736_46 sp__2736_14 0 7.62389e-17
Ctree_2736_47 sp__2736_18 0 2.40957e-16
Ctree_2736_52 sp__2736_24 0 1.43358e-16
Ctree_2736_53 sp__2736_24 0 2.3464e-16
Ctree_2736_54 sp__2736_24 0 8.00842e-17
Ctree_2736_55 sp__2736_24 0 1.06064e-16
Ctree_2736_57 sp__2736_30 0 5.30224e-16
Ctree_2736_59 sp__2736_30 0 5.01044e-16
Ctree_2736_60 sp__2736_37 0 2.74057e-16
Ctree_2736_63 sp__2736_85 0 7.09073e-16
Ctree_2736_65 sp__2736_85 0 3.05772e-16
Ctree_2736_67 sp__2736_89 0 8.16797e-16
Ctree_2736_68 sp__2736_127 0 2.91031e-16
Ctree_2736_69 sp__2736_127 0 5.55982e-16
Ctree_2736_70 sp__2736_133 0 3.37221e-16
Ctree_2736_71 sp__2736_133 0 1.43171e-16
Ctree_2736_72 sp__2736_133 0 2.72747e-16
Ctree_2736_73 sp__2736_133 0 3.2182e-16
Ctree_2736_74 sp__2736_139 0 1.39299e-16
Ctree_2736_75 sp__2736_139 0 6.99179e-17
Ctree_2736_80 sp__2736_147 0 5.00807e-16
Ctree_2736_81 sp__2736_147 0 2.7343e-16
Ctree_2736_82 sp__2736_164 0 2.37686e-16
Ctree_2736_83 sp__2736_164 0 2.15263e-16
Ctree_2736_85 sp__2736_139 0 2.72856e-16
Ctree_2736_88 sp__2736_127 0 1.30055e-16
Ctree_2736_91 sp__2736_24 0 5.49933e-16
Ctree_2736_94 sp__2736_147 0 5.00391e-16
Ctree_2736_95 sp__2736_24 0 6.03292e-16
Ctree_2736_96 sp__2736_30 0 5.01044e-16
Ctree_2736_99 sp__2736_8 0 2.08824e-16
Ctree_2736_100 sp__2736_72 0 3.38415e-16
Ctree_2736_101 sp__2736_18 0 4.02852e-16
Rtree_2737_1 sp__12044_X sp__2737_10 45.459
Rtree_2737_2 sp__2737_10 sp__2737_12 1.5862
Rtree_2737_3 sp__2737_12 sp__2737_24 42.6394
Rtree_2737_4 sp__2737_24 sp__10887_CLK 27.4572
Rtree_2737_5 sp__2737_12 sp__2737_35 22.266
Rtree_2737_6 sp__2737_35 sp__10863_CLK 20
Rtree_2737_7 sp__2737_35 sp__10864_CLK 22.4308
Rtree_2737_8 sp__2737_10 sp__10824_CLK 40
Rtree_2737_9 sp__12044_X sp__2737_63 22.0497
Rtree_2737_10 sp__2737_63 sp__2737_69 23.914
Rtree_2737_11 sp__2737_69 sp__10823_CLK 40
Rtree_2737_12 sp__2737_69 sp__2737_84 27.9104
Rtree_2737_13 sp__2737_84 sp__2737_92 43.4196
Rtree_2737_14 sp__2737_92 sp__10829_CLK 20
Rtree_2737_15 sp__2737_84 sp__10827_CLK 20
Rtree_2737_16 sp__2737_63 sp__10830_CLK 20
Ctree_2737_6 sp__10864_CLK 0 2.30297e-16
Ctree_2737_8 sp__10887_CLK 0 7.6802e-16
Ctree_2737_9 sp__12044_X 0 6.85404e-16
Ctree_2737_10 sp__2737_92 0 3.39348e-16
Ctree_2737_11 sp__2737_84 0 9.8308e-16
Ctree_2737_12 sp__2737_69 0 8.87935e-16
Ctree_2737_13 sp__2737_63 0 4.48836e-16
Ctree_2737_14 sp__2737_35 0 4.61708e-16
Ctree_2737_15 sp__2737_24 0 3.23193e-15
Ctree_2737_16 sp__2737_12 0 2.82064e-15
Ctree_2737_17 sp__2737_10 0 6.06092e-16
Ctree_2737_20 sp__10864_CLK 0 2.73748e-16
Ctree_2737_24 sp__10887_CLK 0 2.72747e-16
Ctree_2737_26 sp__2737_10 0 8.73184e-16
Ctree_2737_28 sp__2737_12 0 3.41206e-16
Ctree_2737_35 sp__2737_24 0 6.06801e-16
Ctree_2737_36 sp__2737_35 0 1.54008e-17
Ctree_2737_40 sp__2737_63 0 3.06739e-16
Ctree_2737_41 sp__2737_69 0 4.63058e-16
Ctree_2737_42 sp__2737_69 0 2.41149e-16
Ctree_2737_43 sp__2737_69 0 2.73562e-16
Ctree_2737_46 sp__2737_84 0 5.80145e-16
Ctree_2737_47 sp__2737_84 0 4.77425e-17
Ctree_2737_48 sp__2737_84 0 1.8091e-16
Ctree_2737_49 sp__10887_CLK 0 1.7634e-16
Ctree_2737_50 sp__2737_92 0 3.42013e-16
Ctree_2737_51 sp__2737_84 0 1.54008e-17
Ctree_2737_52 sp__2737_92 0 2.40057e-16
Ctree_2737_56 sp__2737_92 0 3.23417e-17
Ctree_2737_60 sp__2737_24 0 7.33225e-17
Ctree_2737_61 sp__2737_69 0 4.47657e-16
Ctree_2737_62 sp__2737_84 0 6.55311e-16
Ctree_2737_63 sp__2737_84 0 1.26146e-16
Ctree_2737_66 sp__2737_10 0 2.08348e-16
Ctree_2737_67 sp__2737_24 0 9.26631e-16
Rtree_2738_1 sp__12045_X sp__2738_6 21.6171
Rtree_2738_2 sp__2738_6 sp__2738_8 5.7268
Rtree_2738_3 sp__2738_8 sp__10918_CLK 20.3502
Rtree_2738_4 sp__2738_8 sp__2738_19 26.5302
Rtree_2738_5 sp__2738_19 sp__10868_CLK 40
Rtree_2738_6 sp__2738_19 sp__10867_CLK 48.7138
Rtree_2738_7 sp__2738_6 sp__12135_A 20
Rtree_2738_8 sp__12045_X sp__2738_51 40
Rtree_2738_9 sp__2738_51 sp__2738_55 25.047
Rtree_2738_10 sp__2738_55 sp__2738_75 48.3018
Rtree_2738_11 sp__2738_75 sp__2738_77 1.8334
Rtree_2738_12 sp__2738_77 sp__10920_CLK 21.5862
Rtree_2738_13 sp__2738_77 sp__10919_CLK 22.266
Rtree_2738_14 sp__2738_75 sp__10921_CLK 20.3502
Rtree_2738_15 sp__2738_55 sp__2738_108 36.8817
Rtree_2738_16 sp__2738_108 sp__11969_CLK 47.0967
Rtree_2738_17 sp__2738_108 sp__11966_CLK 40.3193
Rtree_2738_18 sp__2738_51 sp__2738_130 5.047
Rtree_2738_19 sp__2738_130 sp__10922_CLK 40.5356
Rtree_2738_20 sp__2738_130 sp__2738_145 22.7398
Rtree_2738_21 sp__2738_145 sp__10923_CLK 22.0812
Rtree_2738_22 sp__2738_145 sp__2738_154 0.8446
Rtree_2738_23 sp__2738_154 sp__10925_CLK 20
Rtree_2738_24 sp__2738_154 sp__10924_CLK 23.7496
Ctree_2738_1 sp__10924_CLK 0 4.97924e-16
Ctree_2738_3 sp__10923_CLK 0 1.84972e-16
Ctree_2738_4 sp__10922_CLK 0 4.27252e-17
Ctree_2738_5 sp__11966_CLK 0 3.39368e-17
Ctree_2738_6 sp__11969_CLK 0 4.0464e-16
Ctree_2738_7 sp__10921_CLK 0 2.36489e-17
Ctree_2738_8 sp__10919_CLK 0 2.16629e-16
Ctree_2738_9 sp__10920_CLK 0 1.25584e-16
Ctree_2738_11 sp__10867_CLK 0 9.28925e-16
Ctree_2738_13 sp__10918_CLK 0 3.15674e-17
Ctree_2738_14 sp__12045_X 0 1.72122e-16
Ctree_2738_15 sp__2738_154 0 5.65442e-16
Ctree_2738_16 sp__2738_145 0 5.5504e-16
Ctree_2738_17 sp__2738_130 0 9.14533e-16
Ctree_2738_18 sp__2738_108 0 1.77129e-15
Ctree_2738_19 sp__2738_77 0 5.17734e-16
Ctree_2738_20 sp__2738_75 0 9.93638e-16
Ctree_2738_21 sp__2738_55 0 2.56317e-15
Ctree_2738_22 sp__2738_51 0 1.00525e-15
Ctree_2738_23 sp__2738_19 0 1.57441e-15
Ctree_2738_24 sp__2738_8 0 1.33927e-15
Ctree_2738_25 sp__2738_6 0 8.34343e-16
Ctree_2738_30 sp__10867_CLK 0 1.43531e-16
Ctree_2738_31 sp__10867_CLK 0 5.02475e-16
Ctree_2738_33 sp__10922_CLK 0 8.01938e-17
Ctree_2738_35 sp__10923_CLK 0 8.02598e-17
Ctree_2738_38 sp__11969_CLK 0 4.77425e-17
Ctree_2738_39 sp__11969_CLK 0 9.83813e-16
Ctree_2738_40 sp__11969_CLK 0 6.63131e-16
Ctree_2738_41 sp__2738_6 0 4.7856e-17
Ctree_2738_42 sp__2738_8 0 8.00842e-17
Ctree_2738_45 sp__2738_19 0 5.49448e-16
Ctree_2738_49 sp__2738_75 0 4.77425e-17
Ctree_2738_53 sp__2738_108 0 4.7803e-17
Ctree_2738_54 sp__2738_108 0 2.91332e-16
Ctree_2738_55 sp__2738_108 0 7.51285e-17
Ctree_2738_58 sp__2738_130 0 2.90123e-16
Ctree_2738_62 sp__2738_145 0 2.25618e-17
Ctree_2738_67 sp__2738_75 0 8.01938e-17
Ctree_2738_68 sp__2738_108 0 1.44041e-16
Ctree_2738_69 sp__2738_55 0 1.255e-16
Ctree_2738_72 sp__2738_75 0 1.1231e-16
Ctree_2738_73 sp__2738_75 0 8.02927e-17
Ctree_2738_74 sp__10867_CLK 0 1.82216e-16
Ctree_2738_76 sp__2738_8 0 2.08999e-16
Ctree_2738_89 sp__2738_108 0 5.53671e-16
Ctree_2738_92 sp__2738_75 0 2.41297e-16
Ctree_2738_94 sp__2738_75 0 3.24568e-17
Ctree_2738_95 sp__2738_75 0 4.78524e-17
Ctree_2738_96 sp__2738_108 0 2.33942e-16
Ctree_2738_97 sp__2738_108 0 7.48466e-17
Ctree_2738_98 sp__2738_75 0 1.54008e-17
Ctree_2738_99 sp__2738_108 0 3.21143e-17
Ctree_2738_100 sp__2738_55 0 4.48394e-16
Ctree_2738_101 sp__2738_55 0 3.77e-16
Ctree_2738_102 sp__2738_75 0 1.29579e-16
Ctree_2738_103 sp__2738_108 0 3.94151e-16
Ctree_2738_106 sp__2738_108 0 7.87297e-16
Ctree_2738_108 sp__10922_CLK 0 8.01938e-17
Ctree_2738_112 sp__2738_108 0 4.77425e-17
Ctree_2738_113 sp__2738_108 0 5.0063e-16
Ctree_2738_114 sp__2738_108 0 1.81192e-16
Rtree_2739_1 sp__12046_X sp__2739_8 43.0694
Rtree_2739_2 sp__2739_8 sp__2739_10 2.0806
Rtree_2739_3 sp__2739_10 sp__10865_CLK 41.8437
Rtree_2739_4 sp__2739_10 sp__2739_25 22.4823
Rtree_2739_5 sp__2739_25 sp__2739_29 23.9964
Rtree_2739_6 sp__2739_29 sp__2739_31 0.8446
Rtree_2739_7 sp__2739_31 sp__2739_35 25.7886
Rtree_2739_8 sp__2739_35 sp__10826_CLK 20
Rtree_2739_9 sp__2739_35 sp__2739_46 30.7738
Rtree_2739_10 sp__2739_46 sp__10828_CLK 45.6444
Rtree_2739_11 sp__2739_31 sp__10825_CLK 42.266
Rtree_2739_12 sp__2739_29 sp__10815_CLK 44.841
Rtree_2739_13 sp__2739_25 sp__10866_CLK 20
Rtree_2739_14 sp__2739_8 sp__12141_A 41.6171
Rtree_2739_15 sp__12046_X sp__2739_96 20
Rtree_2739_16 sp__2739_96 sp__2739_104 44.0994
Rtree_2739_17 sp__2739_104 sp__10816_CLK 20
Rtree_2739_18 sp__2739_104 sp__2739_113 2.4308
Rtree_2739_19 sp__2739_113 sp__10817_CLK 20
Rtree_2739_20 sp__2739_113 sp__2739_120 2.266
Rtree_2739_21 sp__2739_120 sp__2739_126 46.7774
Rtree_2739_22 sp__2739_126 sp__10832_CLK 20
Rtree_2739_23 sp__2739_126 sp__10838_CLK 22.678
Rtree_2739_24 sp__2739_120 sp__2739_144 8.24
Rtree_2739_25 sp__2739_144 sp__10819_CLK 20
Rtree_2739_26 sp__2739_144 sp__2739_157 42.4308
Rtree_2739_27 sp__2739_157 sp__10820_CLK 20
Rtree_2739_28 sp__2739_96 sp__10818_CLK 22.1836
Ctree_2739_1 sp__10818_CLK 0 2.50677e-16
Ctree_2739_4 sp__10838_CLK 0 2.76003e-16
Ctree_2739_8 sp__12141_A 0 1.76885e-16
Ctree_2739_10 sp__10815_CLK 0 4.96712e-16
Ctree_2739_11 sp__10825_CLK 0 2.52808e-16
Ctree_2739_12 sp__10828_CLK 0 5.98867e-16
Ctree_2739_14 sp__10865_CLK 0 1.46585e-16
Ctree_2739_15 sp__12046_X 0 2.27755e-16
Ctree_2739_16 sp__2739_157 0 2.19348e-16
Ctree_2739_17 sp__2739_144 0 1.05171e-15
Ctree_2739_18 sp__2739_126 0 8.49694e-16
Ctree_2739_19 sp__2739_120 0 1.6256e-15
Ctree_2739_20 sp__2739_113 0 4.30429e-16
Ctree_2739_21 sp__2739_104 0 5.96869e-16
Ctree_2739_22 sp__2739_96 0 6.36669e-16
Ctree_2739_23 sp__2739_46 0 1.47808e-15
Ctree_2739_24 sp__2739_35 0 1.46176e-15
Ctree_2739_25 sp__2739_31 0 8.68814e-16
Ctree_2739_26 sp__2739_29 0 9.45453e-16
Ctree_2739_27 sp__2739_25 0 7.01617e-16
Ctree_2739_28 sp__2739_10 0 5.85488e-16
Ctree_2739_29 sp__2739_8 0 5.57214e-16
Ctree_2739_30 sp__10815_CLK 0 4.77425e-17
Ctree_2739_31 sp__10815_CLK 0 1.06064e-16
Ctree_2739_32 sp__10815_CLK 0 7.51285e-17
Ctree_2739_33 sp__10815_CLK 0 1.81192e-16
Ctree_2739_35 sp__10818_CLK 0 1.54008e-17
Ctree_2739_38 sp__10825_CLK 0 1.54008e-17
Ctree_2739_40 sp__10825_CLK 0 1.54008e-17
Ctree_2739_44 sp__10838_CLK 0 1.54008e-17
Ctree_2739_47 sp__10865_CLK 0 2.3464e-16
Ctree_2739_49 sp__10865_CLK 0 1.12558e-16
Ctree_2739_50 sp__12141_A 0 2.40437e-16
Ctree_2739_52 sp__2739_8 0 6.60971e-16
Ctree_2739_54 sp__2739_10 0 4.46352e-16
Ctree_2739_58 sp__2739_29 0 5.6384e-16
Ctree_2739_61 sp__2739_31 0 1.59096e-16
Ctree_2739_62 sp__2739_31 0 1.81192e-16
Ctree_2739_63 sp__2739_35 0 7.34783e-17
Ctree_2739_67 sp__2739_35 0 1.27853e-16
Ctree_2739_69 sp__2739_46 0 9.73176e-16
Ctree_2739_73 sp__2739_104 0 1.81192e-16
Ctree_2739_74 sp__2739_104 0 2.40328e-16
Ctree_2739_75 sp__2739_104 0 1.54008e-17
Ctree_2739_76 sp__2739_104 0 1.12536e-16
Ctree_2739_77 sp__2739_113 0 2.59183e-16
Ctree_2739_83 sp__2739_126 0 1.81695e-16
Ctree_2739_84 sp__2739_126 0 8.65877e-16
Ctree_2739_85 sp__2739_126 0 4.46767e-16
Ctree_2739_86 sp__2739_144 0 4.77425e-17
Ctree_2739_91 sp__2739_157 0 1.44431e-16
Ctree_2739_93 sp__2739_157 0 2.7377e-16
Ctree_2739_94 sp__2739_144 0 5.98427e-16
Ctree_2739_95 sp__10828_CLK 0 2.08491e-16
Ctree_2739_98 sp__10815_CLK 0 4.77425e-17
Ctree_2739_100 sp__2739_46 0 8.00842e-17
Ctree_2739_101 sp__2739_35 0 5.50685e-16
Ctree_2739_103 sp__2739_46 0 2.86127e-16
Ctree_2739_107 sp__2739_120 0 3.39212e-16
Ctree_2739_108 sp__2739_144 0 2.09484e-16
Ctree_2739_109 sp__2739_104 0 3.05011e-16
Ctree_2739_111 sp__2739_46 0 7.60313e-16
Ctree_2739_112 sp__2739_46 0 3.89481e-16
Ctree_2739_115 sp__10828_CLK 0 3.70823e-16
Rtree_2740_1 sp__12047_X sp__2740_4 20
Rtree_2740_2 sp__2740_4 sp__2740_10 23.1106
Rtree_2740_3 sp__2740_10 sp__2740_12 1.8334
Rtree_2740_4 sp__2740_12 sp__2740_14 3.5638
Rtree_2740_5 sp__2740_14 sp__2740_16 0.8446
Rtree_2740_6 sp__2740_16 sp__2740_20 28.2606
Rtree_2740_7 sp__2740_20 sp__10869_CLK 20
Rtree_2740_8 sp__2740_20 sp__10870_CLK 23.1106
Rtree_2740_9 sp__2740_16 sp__10822_CLK 42.266
Rtree_2740_10 sp__2740_14 sp__10821_CLK 40
Rtree_2740_11 sp__2740_12 sp__2740_54 23.9964
Rtree_2740_12 sp__2740_54 sp__10833_CLK 22.1836
Rtree_2740_13 sp__2740_54 sp__10835_CLK 20
Rtree_2740_14 sp__2740_10 sp__12142_A 40
Rtree_2740_15 sp__2740_4 sp__2740_85 12.5042
Rtree_2740_16 sp__2740_85 sp__10836_CLK 22.4308
Rtree_2740_17 sp__2740_85 sp__10837_CLK 20
Rtree_2740_18 sp__12047_X sp__2740_106 23.3475
Rtree_2740_19 sp__2740_106 sp__2740_112 46.7774
Rtree_2740_20 sp__2740_112 sp__2740_116 2.9252
Rtree_2740_21 sp__2740_116 sp__2740_122 23.1106
Rtree_2740_22 sp__2740_122 sp__11071_CLK 40
Rtree_2740_23 sp__2740_122 sp__11075_CLK 44.6556
Rtree_2740_24 sp__2740_116 sp__11072_CLK 20
Rtree_2740_25 sp__2740_112 sp__11073_CLK 20
Rtree_2740_26 sp__2740_106 sp__11074_CLK 20
Ctree_2740_4 sp__11075_CLK 0 3.35456e-16
Ctree_2740_7 sp__10836_CLK 0 2.37804e-16
Ctree_2740_10 sp__10833_CLK 0 2.20198e-16
Ctree_2740_12 sp__10822_CLK 0 2.09893e-16
Ctree_2740_13 sp__10870_CLK 0 3.01566e-16
Ctree_2740_15 sp__12047_X 0 3.47715e-16
Ctree_2740_16 sp__2740_122 0 5.78313e-16
Ctree_2740_17 sp__2740_116 0 4.90543e-16
Ctree_2740_18 sp__2740_112 0 8.97888e-16
Ctree_2740_19 sp__2740_106 0 9.97916e-16
Ctree_2740_20 sp__2740_85 0 1.48023e-15
Ctree_2740_21 sp__2740_54 0 6.60629e-16
Ctree_2740_22 sp__2740_20 0 9.1277e-16
Ctree_2740_23 sp__2740_16 0 8.69755e-16
Ctree_2740_24 sp__2740_14 0 2.58613e-16
Ctree_2740_25 sp__2740_12 0 7.55462e-16
Ctree_2740_26 sp__2740_10 0 4.4536e-16
Ctree_2740_27 sp__2740_4 0 1.58271e-15
Ctree_2740_34 sp__11075_CLK 0 2.07943e-16
Ctree_2740_36 sp__2740_10 0 1.59424e-16
Ctree_2740_38 sp__2740_12 0 3.738e-16
Ctree_2740_39 sp__2740_14 0 3.41949e-16
Ctree_2740_40 sp__2740_14 0 1.81608e-16
Ctree_2740_41 sp__2740_14 0 2.66733e-16
Ctree_2740_42 sp__2740_16 0 1.60341e-16
Ctree_2740_43 sp__2740_20 0 1.77423e-15
Ctree_2740_52 sp__2740_85 0 4.7803e-17
Ctree_2740_55 sp__2740_85 0 5.57065e-16
Ctree_2740_60 sp__2740_106 0 2.09505e-16
Ctree_2740_69 sp__2740_85 0 4.77396e-17
Ctree_2740_70 sp__2740_85 0 4.78524e-17
Ctree_2740_73 sp__2740_10 0 4.78356e-17
Ctree_2740_74 sp__2740_85 0 2.21754e-17
Ctree_2740_84 sp__11075_CLK 0 5.89183e-16
Ctree_2740_85 sp__2740_122 0 1.82525e-16
Ctree_2740_87 sp__10870_CLK 0 1.76921e-16
Ctree_2740_91 sp__2740_85 0 8.0216e-17
Ctree_2740_92 sp__2740_85 0 4.77425e-17
Ctree_2740_96 sp__2740_122 0 2.74561e-16
Ctree_2740_97 sp__2740_116 0 2.74594e-16
Ctree_2740_99 sp__2740_112 0 5.52686e-16
Rtree_2741_1 sp__12048_X sp__2741_10 42.4617
Rtree_2741_2 sp__2741_10 sp__2741_14 23.3166
Rtree_2741_3 sp__2741_14 sp__11076_CLK 20.8446
Rtree_2741_4 sp__2741_14 sp__2741_23 3.9964
Rtree_2741_5 sp__2741_23 sp__2741_27 21.8334
Rtree_2741_6 sp__2741_27 sp__2741_29 3.811
Rtree_2741_7 sp__2741_29 sp__2741_39 49.8262
Rtree_2741_8 sp__2741_39 sp__10839_CLK 40
Rtree_2741_9 sp__2741_29 sp__11078_CLK 40
Rtree_2741_10 sp__2741_27 sp__2741_57 25.7886
Rtree_2741_11 sp__2741_57 sp__11039_CLK 22.1498
Rtree_2741_12 sp__2741_57 sp__2741_74 42.9252
Rtree_2741_13 sp__2741_74 sp__11033_CLK 20
Rtree_2741_14 sp__2741_74 sp__11032_CLK 22.266
Rtree_2741_15 sp__2741_23 sp__11077_CLK 20
Rtree_2741_16 sp__2741_10 sp__12143_A 40
Rtree_2741_17 sp__12048_X sp__2741_105 23.5638
Rtree_2741_18 sp__2741_105 sp__11037_CLK 22.781
Rtree_2741_19 sp__2741_105 sp__2741_118 0.3502
Rtree_2741_20 sp__2741_118 sp__2741_120 3.9964
Rtree_2741_21 sp__2741_120 sp__11035_CLK 20
Rtree_2741_22 sp__2741_120 sp__2741_129 2.678
Rtree_2741_23 sp__2741_129 sp__11036_CLK 20
Rtree_2741_24 sp__2741_129 sp__11034_CLK 22.6162
Rtree_2741_25 sp__2741_118 sp__11038_CLK 20.3502
Ctree_2741_1 sp__11038_CLK 0 2.77263e-17
Ctree_2741_2 sp__11034_CLK 0 2.20387e-16
Ctree_2741_5 sp__11037_CLK 0 2.28035e-16
Ctree_2741_8 sp__11032_CLK 0 2.2615e-16
Ctree_2741_10 sp__11039_CLK 0 2.55516e-16
Ctree_2741_13 sp__11076_CLK 0 7.00014e-17
Ctree_2741_14 sp__12048_X 0 5.99082e-16
Ctree_2741_15 sp__2741_129 0 4.60839e-16
Ctree_2741_16 sp__2741_120 0 5.58975e-16
Ctree_2741_17 sp__2741_118 0 3.73976e-16
Ctree_2741_18 sp__2741_105 0 6.21687e-16
Ctree_2741_19 sp__2741_74 0 5.08319e-16
Ctree_2741_20 sp__2741_57 0 1.06619e-15
Ctree_2741_21 sp__2741_39 0 8.61383e-16
Ctree_2741_22 sp__2741_29 0 1.18472e-15
Ctree_2741_23 sp__2741_27 0 1.06047e-15
Ctree_2741_24 sp__2741_23 0 6.36385e-16
Ctree_2741_25 sp__2741_14 0 8.41632e-16
Ctree_2741_26 sp__2741_10 0 5.77027e-16
Ctree_2741_27 sp__11032_CLK 0 3.397e-16
Ctree_2741_32 sp__11039_CLK 0 1.54008e-17
Ctree_2741_35 sp__2741_14 0 1.27744e-16
Ctree_2741_41 sp__2741_29 0 4.80714e-16
Ctree_2741_42 sp__2741_29 0 3.41176e-16
Ctree_2741_44 sp__2741_39 0 2.32866e-16
Ctree_2741_47 sp__2741_57 0 2.33463e-16
Ctree_2741_48 sp__2741_57 0 7.45875e-16
Ctree_2741_51 sp__2741_74 0 2.09714e-16
Ctree_2741_74 sp__2741_105 0 1.54556e-17
Rtree_2742_1 sp__12049_X sp__2742_8 46.0358
Rtree_2742_2 sp__2742_8 sp__2742_10 0.8446
Rtree_2742_3 sp__2742_10 sp__2742_12 1.0918
Rtree_2742_4 sp__2742_12 sp__10843_CLK 45.5517
Rtree_2742_5 sp__2742_12 sp__2742_27 23.3475
Rtree_2742_6 sp__2742_27 sp__2742_33 42.3278
Rtree_2742_7 sp__2742_33 sp__10841_CLK 20
Rtree_2742_8 sp__2742_27 sp__10840_CLK 22.266
Rtree_2742_9 sp__2742_10 sp__2742_49 24.6453
Rtree_2742_10 sp__2742_49 sp__2742_53 3.1106
Rtree_2742_11 sp__2742_53 sp__10846_CLK 21.8334
Rtree_2742_12 sp__2742_53 sp__2742_68 45.0882
Rtree_2742_13 sp__2742_68 sp__10845_CLK 20
Rtree_2742_14 sp__2742_49 sp__10844_CLK 20
Rtree_2742_15 sp__2742_8 sp__10842_CLK 41.6171
Rtree_2742_16 sp__12049_X sp__2742_98 43.2033
Rtree_2742_17 sp__2742_98 sp__2742_102 23.9964
Rtree_2742_18 sp__2742_102 sp__11046_CLK 20.3502
Rtree_2742_19 sp__2742_102 sp__2742_117 41.7914
Rtree_2742_20 sp__2742_117 sp__2742_127 44.7586
Rtree_2742_21 sp__2742_127 sp__11030_CLK 20
Rtree_2742_22 sp__2742_117 sp__11045_CLK 20
Rtree_2742_23 sp__2742_98 sp__2742_139 2.0806
Rtree_2742_24 sp__2742_139 sp__11044_CLK 40
Rtree_2742_25 sp__2742_139 sp__2742_152 23.1724
Rtree_2742_26 sp__2742_152 sp__11043_CLK 20
Rtree_2742_27 sp__2742_152 sp__2742_161 4.5938
Rtree_2742_28 sp__2742_161 sp__11042_CLK 20
Rtree_2742_29 sp__2742_161 sp__2742_170 5.0882
Rtree_2742_30 sp__2742_170 sp__11041_CLK 20
Rtree_2742_31 sp__2742_170 sp__11040_CLK 22.6162
Ctree_2742_1 sp__11040_CLK 0 2.35637e-16
Ctree_2742_8 sp__11046_CLK 0 3.65091e-17
Ctree_2742_9 sp__10842_CLK 0 1.11374e-16
Ctree_2742_12 sp__10846_CLK 0 1.68427e-16
Ctree_2742_13 sp__10840_CLK 0 2.25825e-16
Ctree_2742_15 sp__10843_CLK 0 5.24662e-16
Ctree_2742_16 sp__12049_X 0 9.67533e-16
Ctree_2742_17 sp__2742_170 0 6.64391e-16
Ctree_2742_18 sp__2742_161 0 8.49944e-16
Ctree_2742_19 sp__2742_152 0 7.5145e-16
Ctree_2742_20 sp__2742_139 0 5.55571e-16
Ctree_2742_21 sp__2742_127 0 4.13387e-16
Ctree_2742_22 sp__2742_117 0 7.17046e-16
Ctree_2742_23 sp__2742_102 0 7.02608e-16
Ctree_2742_24 sp__2742_98 0 9.47321e-16
Ctree_2742_25 sp__2742_68 0 3.64008e-16
Ctree_2742_26 sp__2742_53 0 8.37393e-16
Ctree_2742_27 sp__2742_49 0 7.25849e-16
Ctree_2742_28 sp__2742_33 0 1.1848e-16
Ctree_2742_29 sp__2742_27 0 7.01972e-16
Ctree_2742_30 sp__2742_12 0 9.95179e-16
Ctree_2742_31 sp__2742_10 0 6.34799e-16
Ctree_2742_32 sp__2742_8 0 8.20396e-16
Ctree_2742_36 sp__10842_CLK 0 2.42281e-16
Ctree_2742_41 sp__10843_CLK 0 7.52158e-17
Ctree_2742_53 sp__2742_33 0 3.41949e-16
Ctree_2742_54 sp__2742_33 0 7.52149e-17
Ctree_2742_55 sp__2742_33 0 5.0165e-16
Ctree_2742_57 sp__2742_49 0 9.71568e-17
Ctree_2742_58 sp__2742_49 0 3.06531e-16
Ctree_2742_59 sp__2742_53 0 4.77425e-17
Ctree_2742_68 sp__2742_102 0 4.99116e-16
Ctree_2742_69 sp__2742_102 0 2.41979e-16
Ctree_2742_70 sp__2742_102 0 1.76274e-16
Ctree_2742_71 sp__2742_102 0 3.23417e-17
Ctree_2742_73 sp__2742_117 0 2.35055e-16
Ctree_2742_88 sp__2742_161 0 2.74594e-16
Ctree_2742_93 sp__2742_98 0 1.54008e-17
Ctree_2742_96 sp__2742_53 0 7.9225e-17
Ctree_2742_99 sp__2742_68 0 9.24324e-16
Ctree_2742_100 sp__2742_68 0 4.78356e-17
Ctree_2742_101 sp__2742_8 0 2.34013e-16
Ctree_2742_108 sp__2742_170 0 5.98734e-16
Ctree_2742_109 sp__2742_127 0 6.0761e-16
Rtree_2743_1 sp__12050_X sp__2743_6 21.6171
Rtree_2743_2 sp__2743_6 sp__2743_8 3.9964
Rtree_2743_3 sp__2743_8 sp__12138_A 21.8334
Rtree_2743_4 sp__2743_8 sp__2743_17 0.3502
Rtree_2743_5 sp__2743_17 sp__2743_21 21.0918
Rtree_2743_6 sp__2743_21 sp__2743_25 27.8898
Rtree_2743_7 sp__2743_25 sp__10834_CLK 20
Rtree_2743_8 sp__2743_25 sp__10831_CLK 22.9252
Rtree_2743_9 sp__2743_21 sp__10909_CLK 43.605
Rtree_2743_10 sp__2743_17 sp__10910_CLK 20
Rtree_2743_11 sp__2743_6 sp__10856_CLK 20.3502
Rtree_2743_12 sp__12050_X sp__2743_71 47.6735
Rtree_2743_13 sp__2743_71 sp__10855_CLK 43.8522
Rtree_2743_14 sp__2743_71 sp__2743_86 22.0806
Rtree_2743_15 sp__2743_86 sp__10857_CLK 20
Rtree_2743_16 sp__2743_86 sp__10861_CLK 30.2794
Rtree_2743_17 sp__12138_A sp__2743_115 43.5638
Rtree_2743_18 sp__2743_115 sp__2743_117 20
Rtree_2743_19 sp__2743_117 sp__2743_121 2.3999
Rtree_2743_20 sp__2743_121 sp__10908_CLK 22.0497
Rtree_2743_21 sp__2743_121 sp__2743_134 48.0134
Rtree_2743_22 sp__2743_134 sp__2743_136 3.7801
Rtree_2743_23 sp__2743_136 sp__10889_CLK 22.8634
Rtree_2743_24 sp__2743_136 sp__10890_CLK 20
Rtree_2743_25 sp__2743_117 sp__10892_CLK 20
Ctree_2743_3 sp__10889_CLK 0 2.83561e-16
Ctree_2743_4 sp__10908_CLK 0 2.27938e-16
Ctree_2743_5 sp__10861_CLK 0 9.54727e-16
Ctree_2743_7 sp__10855_CLK 0 4.07823e-16
Ctree_2743_8 sp__10856_CLK 0 2.81507e-17
Ctree_2743_10 sp__10909_CLK 0 2.75425e-16
Ctree_2743_11 sp__10831_CLK 0 2.5106e-16
Ctree_2743_13 sp__12138_A 0 5.2422e-16
Ctree_2743_14 sp__12050_X 0 8.50961e-16
Ctree_2743_15 sp__2743_136 0 7.07021e-16
Ctree_2743_16 sp__2743_134 0 1.22596e-15
Ctree_2743_17 sp__2743_121 0 1.25815e-15
Ctree_2743_18 sp__2743_117 0 2.27709e-16
Ctree_2743_19 sp__2743_115 0 3.21452e-16
Ctree_2743_20 sp__2743_86 0 1.12286e-15
Ctree_2743_21 sp__2743_71 0 1.244e-15
Ctree_2743_22 sp__2743_25 0 9.80845e-16
Ctree_2743_23 sp__2743_21 0 1.07643e-15
Ctree_2743_24 sp__2743_17 0 9.93724e-17
Ctree_2743_25 sp__2743_8 0 6.95063e-16
Ctree_2743_26 sp__2743_6 0 6.7521e-16
Ctree_2743_27 sp__10831_CLK 0 2.74715e-16
Ctree_2743_28 sp__10855_CLK 0 7.48209e-17
Ctree_2743_30 sp__10855_CLK 0 1.7645e-16
Ctree_2743_32 sp__10861_CLK 0 1.54008e-17
Ctree_2743_33 sp__10861_CLK 0 9.61594e-17
Ctree_2743_34 sp__10861_CLK 0 1.67052e-16
Ctree_2743_35 sp__10861_CLK 0 4.34441e-16
Ctree_2743_37 sp__10861_CLK 0 2.08857e-16
Ctree_2743_38 sp__10908_CLK 0 1.43951e-16
Ctree_2743_40 sp__10909_CLK 0 2.88087e-16
Ctree_2743_47 sp__2743_21 0 2.3464e-16
Ctree_2743_50 sp__2743_25 0 5.3252e-16
Ctree_2743_55 sp__2743_71 0 4.77425e-17
Ctree_2743_56 sp__2743_71 0 6.60969e-16
Ctree_2743_57 sp__2743_86 0 4.41958e-16
Ctree_2743_58 sp__2743_121 0 2.09507e-16
Ctree_2743_59 sp__2743_134 0 4.90416e-16
Ctree_2743_62 sp__2743_134 0 5.5301e-16
Ctree_2743_65 sp__10908_CLK 0 1.12241e-16
Ctree_2743_66 sp__2743_121 0 3.23417e-17
Ctree_2743_69 sp__2743_25 0 3.3894e-16
Ctree_2743_73 sp__10861_CLK 0 2.73295e-16
Ctree_2743_74 sp__10861_CLK 0 1.10917e-16
Ctree_2743_79 sp__2743_71 0 2.74479e-16
Ctree_2743_82 sp__2743_115 0 6.55131e-16
Ctree_2743_83 sp__10855_CLK 0 2.85554e-16
Ctree_2743_84 sp__2743_134 0 2.85836e-16
Ctree_2743_87 sp__2743_134 0 1.24859e-16
Ctree_2743_100 sp__2743_25 0 2.09615e-16
Ctree_2743_101 sp__2743_71 0 2.42138e-16
Ctree_2743_102 sp__2743_71 0 7.24899e-16
Rtree_2744_1 sp__12051_X sp__2744_4 20
Rtree_2744_2 sp__2744_4 sp__2744_10 24.3157
Rtree_2744_3 sp__2744_10 sp__2744_14 21.6171
Rtree_2744_4 sp__2744_14 sp__2744_18 5.0882
Rtree_2744_5 sp__2744_18 sp__2744_22 23.1312
Rtree_2744_6 sp__2744_22 sp__2744_24 0.8446
Rtree_2744_7 sp__2744_24 sp__2744_26 4.3054
Rtree_2744_8 sp__2744_26 sp__2744_40 16.1401
Rtree_2744_9 sp__2744_40 sp__10859_CLK 42.0909
Rtree_2744_10 sp__2744_40 sp__10858_CLK 42.9149
Rtree_2744_11 sp__2744_26 sp__10996_CLK 40.9682
Rtree_2744_12 sp__2744_24 sp__10995_CLK 40.9682
Rtree_2744_13 sp__2744_22 sp__2744_84 22.8016
Rtree_2744_14 sp__2744_84 sp__2744_88 4.3466
Rtree_2744_15 sp__2744_88 sp__11990_CLK 20
Rtree_2744_16 sp__2744_88 sp__2744_95 3.9964
Rtree_2744_17 sp__2744_95 sp__11031_CLK 28.3174
Rtree_2744_18 sp__2744_95 sp__11988_CLK 20
Rtree_2744_19 sp__2744_84 sp__10997_CLK 20
Rtree_2744_20 sp__2744_18 sp__10994_CLK 20
Rtree_2744_21 sp__2744_14 sp__10993_CLK 20
Rtree_2744_22 sp__2744_10 sp__10991_CLK 43.5741
Rtree_2744_23 sp__2744_4 sp__2744_143 22.678
Rtree_2744_24 sp__2744_143 sp__2744_145 1.5862
Rtree_2744_25 sp__2744_145 sp__2744_151 27.8692
Rtree_2744_26 sp__2744_151 sp__2744_155 2.6471
Rtree_2744_27 sp__2744_155 sp__10853_CLK 22.6471
Rtree_2744_28 sp__2744_155 sp__10905_CLK 20.6412
Rtree_2744_29 sp__2744_151 sp__10903_CLK 20
Rtree_2744_30 sp__2744_145 sp__10992_CLK 40
Rtree_2744_31 sp__2744_143 sp__10990_CLK 42.1836
Ctree_2744_1 sp__10990_CLK 0 2.18215e-16
Ctree_2744_4 sp__10905_CLK 0 4.33382e-17
Ctree_2744_5 sp__10853_CLK 0 2.44217e-16
Ctree_2744_6 sp__10991_CLK 0 3.44625e-16
Ctree_2744_11 sp__11031_CLK 0 8.20971e-16
Ctree_2744_13 sp__10995_CLK 0 9.34387e-17
Ctree_2744_14 sp__10996_CLK 0 8.19481e-17
Ctree_2744_15 sp__10858_CLK 0 2.42906e-16
Ctree_2744_16 sp__10859_CLK 0 1.95644e-16
Ctree_2744_18 sp__2744_155 0 5.34596e-16
Ctree_2744_19 sp__2744_151 0 1.19535e-15
Ctree_2744_20 sp__2744_145 0 1.0718e-15
Ctree_2744_21 sp__2744_143 0 6.26973e-16
Ctree_2744_22 sp__2744_95 0 1.18369e-15
Ctree_2744_23 sp__2744_88 0 7.5457e-16
Ctree_2744_24 sp__2744_84 0 6.88347e-16
Ctree_2744_25 sp__2744_40 0 1.92874e-15
Ctree_2744_26 sp__2744_26 0 2.05399e-15
Ctree_2744_27 sp__2744_24 0 6.49507e-16
Ctree_2744_28 sp__2744_22 0 6.4546e-16
Ctree_2744_29 sp__2744_18 0 7.84137e-16
Ctree_2744_30 sp__2744_14 0 6.66414e-16
Ctree_2744_31 sp__2744_10 0 9.64306e-16
Ctree_2744_32 sp__2744_4 0 7.47924e-16
Ctree_2744_36 sp__10858_CLK 0 4.35192e-16
Ctree_2744_38 sp__10859_CLK 0 1.1209e-16
Ctree_2744_44 sp__11031_CLK 0 6.30088e-16
Ctree_2744_52 sp__2744_14 0 2.4222e-16
Ctree_2744_54 sp__2744_18 0 2.26655e-16
Ctree_2744_55 sp__2744_18 0 1.12689e-16
Ctree_2744_62 sp__2744_26 0 1.24824e-16
Ctree_2744_67 sp__2744_40 0 7.09776e-16
Ctree_2744_68 sp__2744_40 0 7.46098e-17
Ctree_2744_69 sp__2744_40 0 3.33688e-16
Ctree_2744_75 sp__2744_88 0 5.98031e-16
Ctree_2744_78 sp__2744_95 0 5.18344e-16
Ctree_2744_80 sp__2744_143 0 1.59836e-16
Ctree_2744_82 sp__2744_145 0 2.89801e-16
Ctree_2744_83 sp__2744_151 0 2.88669e-16
Ctree_2744_94 sp__2744_40 0 1.81298e-16
Ctree_2744_99 sp__10996_CLK 0 1.4409e-16
Ctree_2744_100 sp__2744_40 0 4.22875e-16
Ctree_2744_101 sp__10996_CLK 0 1.4409e-16
Ctree_2744_106 sp__2744_40 0 3.91322e-16
Ctree_2744_107 sp__10859_CLK 0 2.87874e-16
Ctree_2744_108 sp__2744_40 0 7.35518e-17
Ctree_2744_111 sp__10858_CLK 0 4.0334e-16
Ctree_2744_114 sp__10991_CLK 0 3.71059e-16
Ctree_2744_117 sp__2744_22 0 4.68407e-16
Ctree_2744_119 sp__2744_40 0 6.00959e-16
Ctree_2744_121 sp__2744_10 0 1.26443e-16
Rtree_2745_1 sp__12052_X sp__2745_8 44.5526
Rtree_2745_2 sp__2745_8 sp__2745_16 47.622
Rtree_2745_3 sp__2745_16 sp__10852_CLK 41.8334
Rtree_2745_4 sp__2745_16 sp__2745_41 47.0143
Rtree_2745_5 sp__2745_41 sp__11818_CLK 40.3193
Rtree_2745_6 sp__2745_8 sp__2745_54 20.5356
Rtree_2745_7 sp__2745_54 sp__11081_CLK 20
Rtree_2745_8 sp__2745_54 sp__2745_65 22.4617
Rtree_2745_9 sp__2745_65 sp__2745_71 23.0797
Rtree_2745_10 sp__2745_71 sp__2745_85 47.1276
Rtree_2745_11 sp__2745_85 sp__10987_CLK 20
Rtree_2745_12 sp__2745_71 sp__11080_CLK 20
Rtree_2745_13 sp__2745_65 sp__11079_CLK 40.3193
Rtree_2745_14 sp__12052_X sp__2745_109 20
Rtree_2745_15 sp__2745_109 sp__2745_111 2.4823
Rtree_2745_16 sp__2745_111 sp__2745_113 1.8334
Rtree_2745_17 sp__2745_113 sp__2745_115 2.266
Rtree_2745_18 sp__2745_115 sp__11819_CLK 22.4308
Rtree_2745_19 sp__2745_115 sp__11991_CLK 20
Rtree_2745_20 sp__2745_113 sp__11945_CLK 20
Rtree_2745_21 sp__2745_111 sp__11948_CLK 20
Rtree_2745_22 sp__2745_109 sp__2745_141 1.6171
Rtree_2745_23 sp__2745_141 sp__11944_CLK 20
Rtree_2745_24 sp__2745_141 sp__2745_148 2.266
Rtree_2745_25 sp__2745_148 sp__11947_CLK 20
Rtree_2745_26 sp__2745_148 sp__2745_155 1.8334
Rtree_2745_27 sp__2745_155 sp__11083_CLK 20
Rtree_2745_28 sp__2745_155 sp__2745_162 3.4093
Rtree_2745_29 sp__2745_162 sp__2745_164 2.0806
Rtree_2745_30 sp__2745_164 sp__10988_CLK 21.2463
Rtree_2745_31 sp__2745_164 sp__10986_CLK 21.0403
Rtree_2745_32 sp__2745_162 sp__11082_CLK 22.8531
Ctree_2745_1 sp__11082_CLK 0 2.35183e-16
Ctree_2745_2 sp__10986_CLK 0 8.6828e-17
Ctree_2745_3 sp__10988_CLK 0 1.19501e-16
Ctree_2745_10 sp__11819_CLK 0 2.30128e-16
Ctree_2745_11 sp__11079_CLK 0 2.50478e-17
Ctree_2745_15 sp__11818_CLK 0 3.62296e-17
Ctree_2745_16 sp__10852_CLK 0 2.37757e-16
Ctree_2745_17 sp__12052_X 0 4.20341e-16
Ctree_2745_18 sp__2745_164 0 4.41055e-16
Ctree_2745_19 sp__2745_162 0 8.16089e-16
Ctree_2745_20 sp__2745_155 0 5.43448e-16
Ctree_2745_21 sp__2745_148 0 4.36368e-16
Ctree_2745_22 sp__2745_141 0 3.93806e-16
Ctree_2745_23 sp__2745_115 0 4.47233e-16
Ctree_2745_24 sp__2745_113 0 3.91103e-16
Ctree_2745_25 sp__2745_111 0 4.12205e-16
Ctree_2745_26 sp__2745_109 0 3.92913e-16
Ctree_2745_27 sp__2745_85 0 7.5029e-16
Ctree_2745_28 sp__2745_71 0 1.02554e-15
Ctree_2745_29 sp__2745_65 0 5.34862e-16
Ctree_2745_30 sp__2745_54 0 3.00677e-16
Ctree_2745_31 sp__2745_41 0 7.39666e-16
Ctree_2745_32 sp__2745_16 0 1.79981e-15
Ctree_2745_33 sp__2745_8 0 1.34507e-15
Ctree_2745_34 sp__10988_CLK 0 8.01938e-17
Ctree_2745_35 sp__11082_CLK 0 3.71609e-16
Ctree_2745_39 sp__2745_8 0 3.95482e-16
Ctree_2745_40 sp__2745_16 0 2.40531e-16
Ctree_2745_43 sp__2745_41 0 3.35053e-16
Ctree_2745_44 sp__2745_41 0 3.04995e-16
Ctree_2745_47 sp__2745_65 0 1.27744e-16
Ctree_2745_48 sp__2745_65 0 5.28594e-17
Ctree_2745_50 sp__2745_71 0 1.27352e-16
Ctree_2745_53 sp__2745_85 0 2.40196e-16
Ctree_2745_74 sp__2745_41 0 1.43469e-16
Ctree_2745_79 sp__2745_41 0 4.77425e-17
Ctree_2745_80 sp__2745_85 0 2.07598e-16
Ctree_2745_82 sp__2745_71 0 3.69256e-16
Ctree_2745_83 sp__2745_85 0 1.43531e-16
Ctree_2745_86 sp__2745_41 0 1.22936e-16
Ctree_2745_90 sp__2745_85 0 7.99179e-17
Ctree_2745_92 sp__2745_85 0 2.51854e-17
Ctree_2745_93 sp__2745_54 0 1.54008e-17
Ctree_2745_94 sp__2745_65 0 2.40913e-16
Rtree_2746_1 sp__12053_X sp__2746_6 21.1845
Rtree_2746_2 sp__2746_6 sp__2746_12 26.3551
Rtree_2746_3 sp__2746_12 sp__2746_16 23.811
Rtree_2746_4 sp__2746_16 sp__2746_22 25.3354
Rtree_2746_5 sp__2746_22 sp__11005_CLK 42.8222
Rtree_2746_6 sp__2746_22 sp__2746_35 22.266
Rtree_2746_7 sp__2746_35 sp__11007_CLK 21.8334
Rtree_2746_8 sp__2746_35 sp__2746_50 42.6162
Rtree_2746_9 sp__2746_50 sp__11004_CLK 20
Rtree_2746_10 sp__2746_16 sp__11003_CLK 20
Rtree_2746_11 sp__2746_12 sp__10894_CLK 43.9964
Rtree_2746_12 sp__2746_6 sp__2746_73 0.6695
Rtree_2746_13 sp__2746_73 sp__10907_CLK 20
Rtree_2746_14 sp__2746_73 sp__2746_80 2.266
Rtree_2746_15 sp__2746_80 sp__10906_CLK 20.7287
Rtree_2746_16 sp__2746_80 sp__2746_95 24.3157
Rtree_2746_17 sp__2746_95 sp__2746_101 23.6977
Rtree_2746_18 sp__2746_101 sp__10854_CLK 20
Rtree_2746_19 sp__2746_101 sp__2746_114 45.2402
Rtree_2746_20 sp__2746_114 sp__10860_CLK 20
Rtree_2746_21 sp__2746_95 sp__10904_CLK 43.5741
Rtree_2746_22 sp__12053_X sp__2746_139 45.5105
Rtree_2746_23 sp__2746_139 sp__2746_143 21.8334
Rtree_2746_24 sp__2746_143 sp__10847_CLK 22.1836
Rtree_2746_25 sp__2746_143 sp__10849_CLK 20
Rtree_2746_26 sp__2746_139 sp__2746_159 3.0694
Rtree_2746_27 sp__2746_159 sp__10851_CLK 42.266
Rtree_2746_28 sp__2746_159 sp__2746_172 22.0806
Rtree_2746_29 sp__2746_172 sp__10848_CLK 20
Rtree_2746_30 sp__2746_172 sp__10850_CLK 24.512
Ctree_2746_1 sp__10850_CLK 0 4.85523e-16
Ctree_2746_3 sp__10851_CLK 0 2.40167e-16
Ctree_2746_5 sp__10847_CLK 0 2.28383e-16
Ctree_2746_6 sp__10904_CLK 0 3.29006e-16
Ctree_2746_9 sp__10906_CLK 0 4.09267e-17
Ctree_2746_11 sp__10894_CLK 0 4.14122e-16
Ctree_2746_14 sp__11007_CLK 0 2.0494e-16
Ctree_2746_15 sp__11005_CLK 0 1.36606e-16
Ctree_2746_16 sp__12053_X 0 6.34442e-16
Ctree_2746_17 sp__2746_172 0 6.23448e-16
Ctree_2746_18 sp__2746_159 0 5.07735e-16
Ctree_2746_19 sp__2746_143 0 3.42928e-16
Ctree_2746_20 sp__2746_139 0 7.71125e-16
Ctree_2746_21 sp__2746_114 0 5.41545e-16
Ctree_2746_22 sp__2746_101 0 9.29572e-16
Ctree_2746_23 sp__2746_95 0 1.17738e-15
Ctree_2746_24 sp__2746_80 0 7.7408e-16
Ctree_2746_25 sp__2746_73 0 3.35172e-16
Ctree_2746_26 sp__2746_50 0 2.4124e-16
Ctree_2746_27 sp__2746_35 0 6.80344e-16
Ctree_2746_28 sp__2746_22 0 8.38034e-16
Ctree_2746_29 sp__2746_16 0 8.46688e-16
Ctree_2746_30 sp__2746_12 0 1.36624e-15
Ctree_2746_31 sp__2746_6 0 7.42573e-16
Ctree_2746_40 sp__10851_CLK 0 4.77425e-17
Ctree_2746_41 sp__10851_CLK 0 2.25004e-16
Ctree_2746_42 sp__10851_CLK 0 8.0216e-17
Ctree_2746_47 sp__10906_CLK 0 4.18115e-17
Ctree_2746_48 sp__11007_CLK 0 1.77109e-16
Ctree_2746_50 sp__2746_6 0 1.7724e-16
Ctree_2746_56 sp__2746_22 0 1.44768e-16
Ctree_2746_59 sp__2746_35 0 2.7432e-16
Ctree_2746_60 sp__2746_35 0 6.47382e-17
Ctree_2746_61 sp__2746_50 0 4.47081e-16
Ctree_2746_72 sp__2746_114 0 3.94513e-16
Ctree_2746_75 sp__2746_139 0 4.7803e-17
Ctree_2746_80 sp__2746_143 0 3.95396e-16
Ctree_2746_82 sp__2746_159 0 1.28663e-16
Ctree_2746_83 sp__2746_159 0 6.38131e-16
Ctree_2746_84 sp__2746_159 0 5.30319e-17
Ctree_2746_85 sp__2746_159 0 4.24998e-16
Ctree_2746_86 sp__2746_172 0 4.25916e-16
Ctree_2746_88 sp__2746_172 0 7.52158e-17
Ctree_2746_89 sp__2746_139 0 4.67578e-16
Ctree_2746_91 sp__10850_CLK 0 4.79124e-17
Ctree_2746_92 sp__2746_101 0 2.72397e-16
Ctree_2746_93 sp__2746_139 0 1.77295e-16
Ctree_2746_100 sp__2746_12 0 3.93908e-16
Ctree_2746_101 sp__11005_CLK 0 4.46352e-16
Ctree_2746_102 sp__2746_22 0 2.64779e-16
Ctree_2746_105 sp__10894_CLK 0 5.97428e-16
Ctree_2746_107 sp__2746_22 0 4.79124e-17
Ctree_2746_120 sp__11005_CLK 0 2.34224e-16
Ctree_2746_121 sp__11005_CLK 0 3.71223e-16
Ctree_2746_122 sp__2746_22 0 2.85421e-16
Rtree_2747_1 sp__12054_X sp__2747_8 41.8334
Rtree_2747_2 sp__2747_8 sp__2747_18 27.3336
Rtree_2747_3 sp__2747_18 sp__2747_24 43.5638
Rtree_2747_4 sp__2747_24 sp__2747_26 1.8334
Rtree_2747_5 sp__2747_26 sp__2747_28 2.266
Rtree_2747_6 sp__2747_28 sp__2747_30 1.5606
Rtree_2747_7 sp__2747_30 sp__2747_40 49.024
Rtree_2747_8 sp__2747_40 sp__11434_CLK 20
Rtree_2747_9 sp__2747_30 sp__11433_CLK 20
Rtree_2747_10 sp__2747_28 sp__11435_CLK 20
Rtree_2747_11 sp__2747_26 sp__11436_CLK 20
Rtree_2747_12 sp__2747_24 sp__2747_62 2.266
Rtree_2747_13 sp__2747_62 sp__11414_CLK 20
Rtree_2747_14 sp__2747_62 sp__2747_69 1.8334
Rtree_2747_15 sp__2747_69 sp__11395_CLK 20
Rtree_2747_16 sp__2747_69 sp__11409_CLK 22.266
Rtree_2747_17 sp__2747_18 sp__11393_CLK 20
Rtree_2747_18 sp__2747_8 sp__12134_A 40.5356
Rtree_2747_19 sp__12054_X sp__2747_102 23.9964
Rtree_2747_20 sp__2747_102 sp__11501_CLK 24.4496
Rtree_2747_21 sp__2747_102 sp__2747_117 23.5638
Rtree_2747_22 sp__2747_117 sp__2747_125 42.8634
Rtree_2747_23 sp__2747_125 sp__11503_CLK 40
Rtree_2747_24 sp__2747_117 sp__2747_134 3.5638
Rtree_2747_25 sp__2747_134 sp__11561_CLK 40
Rtree_2747_26 sp__2747_134 sp__2747_147 25.8298
Rtree_2747_27 sp__2747_147 sp__11563_CLK 20
Rtree_2747_28 sp__2747_147 sp__2747_154 1.8334
Rtree_2747_29 sp__2747_154 sp__11564_CLK 20
Rtree_2747_30 sp__2747_154 sp__2747_163 2.8634
Rtree_2747_31 sp__2747_163 sp__11542_CLK 20.5974
Rtree_2747_32 sp__2747_163 sp__11523_CLK 24.5938
Ctree_2747_1 sp__11523_CLK 0 4.5227e-16
Ctree_2747_2 sp__11542_CLK 0 4.72978e-17
Ctree_2747_7 sp__11501_CLK 0 4.40724e-16
Ctree_2747_8 sp__12134_A 0 6.2708e-17
Ctree_2747_10 sp__11409_CLK 0 1.93375e-16
Ctree_2747_17 sp__12054_X 0 5.49841e-16
Ctree_2747_18 sp__2747_163 0 7.4821e-16
Ctree_2747_19 sp__2747_154 0 4.10042e-16
Ctree_2747_20 sp__2747_147 0 7.08519e-16
Ctree_2747_21 sp__2747_134 0 9.85421e-16
Ctree_2747_22 sp__2747_125 0 3.29399e-16
Ctree_2747_23 sp__2747_117 0 1.10981e-15
Ctree_2747_24 sp__2747_102 0 1.18267e-15
Ctree_2747_25 sp__2747_69 0 3.71034e-16
Ctree_2747_26 sp__2747_62 0 3.8642e-16
Ctree_2747_27 sp__2747_40 0 7.36731e-16
Ctree_2747_28 sp__2747_30 0 8.97888e-16
Ctree_2747_29 sp__2747_28 0 3.75362e-16
Ctree_2747_30 sp__2747_26 0 3.75441e-16
Ctree_2747_31 sp__2747_24 0 7.39032e-16
Ctree_2747_32 sp__2747_18 0 9.22383e-16
Ctree_2747_33 sp__2747_8 0 7.66054e-16
Ctree_2747_36 sp__11501_CLK 0 1.54556e-17
Ctree_2747_37 sp__11501_CLK 0 1.54008e-17
Ctree_2747_44 sp__2747_8 0 3.95068e-16
Ctree_2747_46 sp__2747_18 0 2.08161e-16
Ctree_2747_48 sp__2747_18 0 2.87256e-16
Ctree_2747_50 sp__2747_18 0 4.46581e-16
Ctree_2747_51 sp__2747_18 0 7.48842e-17
Ctree_2747_52 sp__2747_18 0 7.50571e-17
Ctree_2747_53 sp__2747_18 0 4.48472e-16
Ctree_2747_54 sp__2747_24 0 2.3547e-16
Ctree_2747_65 sp__2747_40 0 6.65303e-16
Ctree_2747_66 sp__2747_40 0 8.00842e-17
Ctree_2747_67 sp__2747_40 0 4.51435e-16
Ctree_2747_69 sp__2747_40 0 5.28594e-17
Ctree_2747_72 sp__2747_40 0 1.54008e-17
Ctree_2747_75 sp__2747_102 0 3.5534e-16
Ctree_2747_76 sp__2747_102 0 4.77425e-17
Ctree_2747_81 sp__2747_117 0 3.66431e-16
Ctree_2747_82 sp__2747_117 0 7.51285e-17
Ctree_2747_83 sp__2747_117 0 3.15205e-16
Ctree_2747_87 sp__2747_125 0 8.00842e-17
Ctree_2747_90 sp__2747_134 0 2.14736e-17
Ctree_2747_95 sp__2747_134 0 1.81608e-16
Ctree_2747_99 sp__2747_147 0 3.95067e-16
Ctree_2747_100 sp__2747_147 0 2.08615e-16
Ctree_2747_101 sp__2747_147 0 3.86899e-16
Ctree_2747_104 sp__2747_154 0 2.73979e-16
Ctree_2747_107 sp__2747_163 0 3.37874e-16
Ctree_2747_109 sp__2747_18 0 2.08879e-16
Ctree_2747_111 sp__11523_CLK 0 3.39043e-16
Ctree_2747_114 sp__2747_40 0 3.98085e-16
Ctree_2747_115 sp__2747_40 0 1.54008e-17
Rtree_2748_1 sp__12055_X sp__2748_6 20.5974
Rtree_2748_2 sp__2748_6 sp__2748_16 44.9131
Rtree_2748_3 sp__2748_16 sp__2748_20 2.6162
Rtree_2748_4 sp__2748_20 sp__2748_24 25.7268
Rtree_2748_5 sp__2748_24 sp__10999_CLK 43.5638
Rtree_2748_6 sp__2748_24 sp__2748_35 8.0134
Rtree_2748_7 sp__2748_35 sp__11006_CLK 47.8898
Rtree_2748_8 sp__2748_35 sp__11002_CLK 42.8222
Rtree_2748_9 sp__2748_20 sp__2748_57 27.0246
Rtree_2748_10 sp__2748_57 sp__2748_63 23.3578
Rtree_2748_11 sp__2748_63 sp__10798_CLK 20.3502
Rtree_2748_12 sp__2748_63 sp__2748_74 2.6162
Rtree_2748_13 sp__2748_74 sp__10797_CLK 22.1836
Rtree_2748_14 sp__2748_74 sp__2748_87 24.3054
Rtree_2748_15 sp__2748_87 sp__10791_CLK 48.4048
Rtree_2748_16 sp__2748_87 sp__10796_CLK 40.5356
Rtree_2748_17 sp__2748_57 sp__10795_CLK 40
Rtree_2748_18 sp__2748_16 sp__10998_CLK 20
Rtree_2748_19 sp__2748_6 sp__2748_123 1.6171
Rtree_2748_20 sp__2748_123 sp__12136_A 20
Rtree_2748_21 sp__2748_123 sp__2748_136 27.5705
Rtree_2748_22 sp__2748_136 sp__2748_140 20.7519
Rtree_2748_23 sp__2748_140 sp__10893_CLK 20
Rtree_2748_24 sp__2748_140 sp__10862_CLK 24.6968
Rtree_2748_25 sp__2748_136 sp__2748_158 3.3166
Rtree_2748_26 sp__2748_158 sp__2748_168 27.8589
Rtree_2748_27 sp__2748_168 sp__10896_CLK 21.8334
Rtree_2748_28 sp__2748_168 sp__10895_CLK 20
Rtree_2748_29 sp__2748_158 sp__10989_CLK 42.9149
Ctree_2748_1 sp__10989_CLK 0 3.10748e-16
Ctree_2748_3 sp__10896_CLK 0 1.63163e-16
Ctree_2748_4 sp__10862_CLK 0 4.72647e-16
Ctree_2748_9 sp__10796_CLK 0 5.61002e-17
Ctree_2748_10 sp__10791_CLK 0 7.83355e-16
Ctree_2748_11 sp__10797_CLK 0 1.88586e-16
Ctree_2748_12 sp__10798_CLK 0 2.63376e-17
Ctree_2748_13 sp__11002_CLK 0 3.00581e-16
Ctree_2748_14 sp__11006_CLK 0 7.0104e-16
Ctree_2748_15 sp__10999_CLK 0 2.9101e-16
Ctree_2748_16 sp__12055_X 0 4.89998e-17
Ctree_2748_17 sp__2748_168 0 8.79319e-16
Ctree_2748_18 sp__2748_158 0 1.31042e-15
Ctree_2748_19 sp__2748_140 0 5.49489e-16
Ctree_2748_20 sp__2748_136 0 1.17654e-15
Ctree_2748_21 sp__2748_123 0 1.01198e-15
Ctree_2748_22 sp__2748_87 0 1.03088e-15
Ctree_2748_23 sp__2748_74 0 6.33728e-16
Ctree_2748_24 sp__2748_63 0 5.85882e-16
Ctree_2748_25 sp__2748_57 0 8.44939e-16
Ctree_2748_26 sp__2748_35 0 1.58932e-15
Ctree_2748_27 sp__2748_24 0 1.41996e-15
Ctree_2748_28 sp__2748_20 0 1.34255e-15
Ctree_2748_29 sp__2748_16 0 6.53768e-16
Ctree_2748_30 sp__2748_6 0 6.36389e-16
Ctree_2748_31 sp__10791_CLK 0 4.92437e-16
Ctree_2748_33 sp__10791_CLK 0 4.93958e-16
Ctree_2748_34 sp__10791_CLK 0 5.21835e-16
Ctree_2748_35 sp__10797_CLK 0 2.08879e-16
Ctree_2748_36 sp__10989_CLK 0 4.34733e-16
Ctree_2748_38 sp__11002_CLK 0 2.31238e-16
Ctree_2748_42 sp__2748_16 0 4.43366e-16
Ctree_2748_43 sp__2748_16 0 1.76198e-16
Ctree_2748_46 sp__2748_24 0 2.09149e-16
Ctree_2748_47 sp__2748_24 0 2.90195e-16
Ctree_2748_48 sp__2748_24 0 1.54008e-17
Ctree_2748_50 sp__2748_35 0 4.2436e-16
Ctree_2748_51 sp__2748_35 0 4.96398e-16
Ctree_2748_52 sp__2748_57 0 6.0428e-16
Ctree_2748_53 sp__2748_57 0 2.1061e-16
Ctree_2748_56 sp__2748_63 0 2.07986e-16
Ctree_2748_57 sp__2748_63 0 1.44658e-16
Ctree_2748_58 sp__2748_63 0 2.35055e-16
Ctree_2748_60 sp__2748_74 0 2.72615e-16
Ctree_2748_61 sp__2748_87 0 9.19422e-16
Ctree_2748_62 sp__2748_87 0 8.97326e-16
Ctree_2748_63 sp__2748_168 0 1.81192e-16
Ctree_2748_66 sp__10797_CLK 0 2.3014e-16
Ctree_2748_70 sp__2748_140 0 1.12399e-16
Ctree_2748_75 sp__10796_CLK 0 8.00842e-17
Ctree_2748_77 sp__2748_57 0 4.41969e-16
Ctree_2748_78 sp__11006_CLK 0 1.92153e-16
Ctree_2748_84 sp__10896_CLK 0 2.7432e-16
Ctree_2748_85 sp__2748_168 0 2.08316e-16
Ctree_2748_86 sp__10862_CLK 0 6.18355e-16
Ctree_2748_90 sp__2748_136 0 1.81192e-16
Ctree_2748_91 sp__11006_CLK 0 9.53806e-16
Ctree_2748_92 sp__2748_136 0 1.79542e-16
Ctree_2748_94 sp__2748_136 0 1.28355e-16
Ctree_2748_95 sp__10999_CLK 0 7.48106e-17
Ctree_2748_96 sp__2748_20 0 2.57163e-16
Ctree_2748_97 sp__2748_24 0 8.19448e-16
Ctree_2748_98 sp__2748_63 0 1.5529e-16
Ctree_2748_101 sp__2748_136 0 1.22192e-16
Ctree_2748_107 sp__2748_158 0 7.07967e-16
Ctree_2748_109 sp__2748_16 0 4.96485e-16
Ctree_2748_113 sp__2748_168 0 8.65319e-16
Ctree_2748_114 sp__2748_35 0 4.41978e-16
Ctree_2748_115 sp__10999_CLK 0 7.6277e-16
Ctree_2748_116 sp__2748_35 0 5.22956e-16
Ctree_2748_118 sp__11006_CLK 0 7.2703e-16
Ctree_2748_120 sp__2748_57 0 5.00082e-16
Ctree_2748_121 sp__2748_35 0 1.81694e-16
Ctree_2748_122 sp__2748_35 0 1.2816e-16
Rtree_2749_1 sp__12056_X sp__2749_4 20
Rtree_2749_2 sp__2749_4 sp__2749_6 1.6171
Rtree_2749_3 sp__2749_6 sp__10793_CLK 23.9964
Rtree_2749_4 sp__2749_6 sp__2749_17 22.8222
Rtree_2749_5 sp__2749_17 sp__10794_CLK 40
Rtree_2749_6 sp__2749_17 sp__2749_26 7.2718
Rtree_2749_7 sp__2749_26 sp__2749_30 23.9964
Rtree_2749_8 sp__2749_30 sp__2749_42 49.0022
Rtree_2749_9 sp__2749_42 sp__11013_CLK 20
Rtree_2749_10 sp__2749_30 sp__11000_CLK 20.3502
Rtree_2749_11 sp__2749_26 sp__11001_CLK 44.7998
Rtree_2749_12 sp__2749_4 sp__2749_69 41.8334
Rtree_2749_13 sp__2749_69 sp__12137_A 21.6171
Rtree_2749_14 sp__2749_69 sp__2749_82 25.5517
Rtree_2749_15 sp__2749_82 sp__2749_86 25.047
Rtree_2749_16 sp__2749_86 sp__2749_90 4.3466
Rtree_2749_17 sp__2749_90 sp__10814_CLK 28.1988
Rtree_2749_18 sp__2749_90 sp__10807_CLK 20
Rtree_2749_19 sp__2749_86 sp__2749_118 43.0282
Rtree_2749_20 sp__2749_118 sp__10804_CLK 20
Rtree_2749_21 sp__2749_82 sp__2749_125 20
Rtree_2749_22 sp__2749_125 sp__2749_129 6.3242
Rtree_2749_23 sp__2749_129 sp__10803_CLK 20
Rtree_2749_24 sp__2749_129 sp__10802_CLK 22.6162
Rtree_2749_25 sp__2749_125 sp__10806_CLK 20.3502
Rtree_2749_26 sp__12137_A sp__10792_CLK 41.8334
Ctree_2749_1 sp__10792_CLK 0 1.46036e-16
Ctree_2749_2 sp__10806_CLK 0 2.77263e-17
Ctree_2749_3 sp__10802_CLK 0 2.25083e-16
Ctree_2749_7 sp__10814_CLK 0 8.19424e-16
Ctree_2749_8 sp__12137_A 0 2.80209e-16
Ctree_2749_9 sp__11001_CLK 0 5.12441e-16
Ctree_2749_10 sp__11000_CLK 0 3.28e-17
Ctree_2749_13 sp__10793_CLK 0 3.86445e-16
Ctree_2749_15 sp__2749_129 0 9.04073e-16
Ctree_2749_16 sp__2749_125 0 7.06716e-16
Ctree_2749_17 sp__2749_118 0 2.98434e-16
Ctree_2749_18 sp__2749_90 0 1.23945e-15
Ctree_2749_19 sp__2749_86 0 1.27271e-15
Ctree_2749_20 sp__2749_82 0 1.12872e-15
Ctree_2749_21 sp__2749_69 0 7.9822e-16
Ctree_2749_22 sp__2749_42 0 9.35404e-16
Ctree_2749_23 sp__2749_30 0 1.36153e-15
Ctree_2749_24 sp__2749_26 0 1.51535e-15
Ctree_2749_25 sp__2749_17 0 7.87002e-16
Ctree_2749_26 sp__2749_6 0 7.39606e-16
Ctree_2749_27 sp__2749_4 0 2.65321e-16
Ctree_2749_29 sp__10793_CLK 0 5.97466e-16
Ctree_2749_32 sp__10814_CLK 0 2.73441e-16
Ctree_2749_38 sp__11001_CLK 0 2.87361e-16
Ctree_2749_43 sp__2749_6 0 1.61471e-16
Ctree_2749_44 sp__2749_17 0 4.9609e-16
Ctree_2749_45 sp__2749_17 0 1.2816e-16
Ctree_2749_47 sp__2749_17 0 3.91622e-16
Ctree_2749_48 sp__2749_26 0 1.06064e-16
Ctree_2749_53 sp__2749_42 0 1.81298e-16
Ctree_2749_58 sp__2749_69 0 3.89781e-16
Ctree_2749_61 sp__2749_82 0 3.38482e-16
Ctree_2749_64 sp__2749_86 0 3.88588e-16
Ctree_2749_66 sp__2749_90 0 3.24568e-17
Ctree_2749_67 sp__2749_90 0 2.08703e-16
Ctree_2749_69 sp__2749_118 0 1.122e-16
Ctree_2749_71 sp__2749_118 0 1.83049e-16
Ctree_2749_72 sp__2749_118 0 1.4391e-16
Ctree_2749_73 sp__2749_129 0 1.77406e-16
Ctree_2749_76 sp__2749_129 0 1.44358e-16
Ctree_2749_83 sp__2749_26 0 4.9798e-16
Ctree_2749_86 sp__2749_42 0 4.96963e-16
Ctree_2749_87 sp__2749_42 0 4.75829e-17
Ctree_2749_89 sp__12137_A 0 2.41116e-16
Ctree_2749_90 sp__2749_82 0 9.71292e-17
Ctree_2749_92 sp__10792_CLK 0 2.74452e-16
Ctree_2749_93 sp__11001_CLK 0 1.8023e-16
Ctree_2749_94 sp__10802_CLK 0 3.38245e-16
Ctree_2749_96 sp__10792_CLK 0 2.74452e-16
Ctree_2749_97 sp__12137_A 0 2.41088e-16
Ctree_2749_98 sp__2749_82 0 1.12426e-16
Ctree_2749_101 sp__2749_90 0 2.08922e-16
Ctree_2749_102 sp__2749_90 0 1.12552e-16
Ctree_2749_103 sp__2749_86 0 7.30101e-17
Ctree_2749_105 sp__10814_CLK 0 1.76274e-16
Ctree_2749_106 sp__2749_90 0 1.76575e-16
Ctree_2749_109 sp__2749_69 0 3.88914e-16
Ctree_2749_110 sp__2749_30 0 4.48894e-16
Ctree_2749_111 sp__2749_30 0 1.54008e-17
Ctree_2749_112 sp__2749_26 0 5.4966e-16
Ctree_2749_113 sp__11001_CLK 0 5.18162e-17
Ctree_2749_114 sp__2749_26 0 3.38268e-16
Ctree_2749_115 sp__2749_30 0 4.77425e-17
Rtree_2750_1 sp__12057_X sp__2750_8 43.9964
Rtree_2750_2 sp__2750_8 sp__2750_10 0.8446
Rtree_2750_3 sp__2750_10 sp__2750_12 1.339
Rtree_2750_4 sp__2750_12 sp__2750_14 2.575
Rtree_2750_5 sp__2750_14 sp__2750_16 1.8334
Rtree_2750_6 sp__2750_16 sp__2750_18 2.575
Rtree_2750_7 sp__2750_18 sp__11027_CLK 41.6274
Rtree_2750_8 sp__2750_18 sp__2750_33 22.5138
Rtree_2750_9 sp__2750_33 sp__11025_CLK 20
Rtree_2750_10 sp__2750_33 sp__11026_CLK 22.1836
Rtree_2750_11 sp__2750_16 sp__12132_A 40.5356
Rtree_2750_12 sp__2750_14 sp__2750_60 21.4008
Rtree_2750_13 sp__2750_60 sp__11742_CLK 20.8446
Rtree_2750_14 sp__2750_60 sp__10810_CLK 22.266
Rtree_2750_15 sp__2750_12 sp__10812_CLK 42.329
Rtree_2750_16 sp__2750_10 sp__10811_CLK 40.5356
Rtree_2750_17 sp__2750_8 sp__2750_94 4.0582
Rtree_2750_18 sp__2750_94 sp__2750_98 21.4008
Rtree_2750_19 sp__2750_98 sp__2750_104 24.0994
Rtree_2750_20 sp__2750_104 sp__2750_106 1.0918
Rtree_2750_21 sp__2750_106 sp__10809_CLK 43.3166
Rtree_2750_22 sp__2750_106 sp__11845_CLK 48.9404
Rtree_2750_23 sp__2750_104 sp__10808_CLK 42.575
Rtree_2750_24 sp__2750_98 sp__11831_CLK 20
Rtree_2750_25 sp__2750_94 sp__11830_CLK 44.5938
Rtree_2750_26 sp__12057_X sp__10813_CLK 41.6171
Ctree_2750_1 sp__10813_CLK 0 1.5913e-16
Ctree_2750_2 sp__11830_CLK 0 4.45346e-16
Ctree_2750_4 sp__10808_CLK 0 2.43221e-16
Ctree_2750_5 sp__11845_CLK 0 9.31509e-16
Ctree_2750_6 sp__10809_CLK 0 3.64103e-16
Ctree_2750_7 sp__10811_CLK 0 3.01051e-17
Ctree_2750_8 sp__10812_CLK 0 2.52183e-16
Ctree_2750_9 sp__10810_CLK 0 2.20632e-16
Ctree_2750_10 sp__11742_CLK 0 6.68694e-17
Ctree_2750_11 sp__12132_A 0 3.88548e-17
Ctree_2750_12 sp__11026_CLK 0 2.27639e-16
Ctree_2750_14 sp__11027_CLK 0 1.3516e-16
Ctree_2750_15 sp__12057_X 0 5.37858e-16
Ctree_2750_16 sp__2750_106 0 1.40602e-15
Ctree_2750_17 sp__2750_104 0 7.72826e-16
Ctree_2750_18 sp__2750_98 0 5.67817e-16
Ctree_2750_19 sp__2750_94 0 9.57609e-16
Ctree_2750_20 sp__2750_60 0 4.50637e-16
Ctree_2750_21 sp__2750_33 0 4.64195e-16
Ctree_2750_22 sp__2750_18 0 5.56989e-16
Ctree_2750_23 sp__2750_16 0 3.31034e-16
Ctree_2750_24 sp__2750_14 0 3.70305e-16
Ctree_2750_25 sp__2750_12 0 4.09718e-16
Ctree_2750_26 sp__2750_10 0 1.44006e-16
Ctree_2750_27 sp__2750_8 0 7.98999e-16
Ctree_2750_28 sp__10808_CLK 0 3.37984e-16
Ctree_2750_34 sp__10809_CLK 0 4.43782e-16
Ctree_2750_35 sp__10812_CLK 0 2.73639e-16
Ctree_2750_36 sp__10813_CLK 0 2.41089e-16
Ctree_2750_40 sp__11027_CLK 0 1.83978e-16
Ctree_2750_41 sp__11027_CLK 0 5.38157e-17
Ctree_2750_42 sp__11830_CLK 0 8.00842e-17
Ctree_2750_44 sp__11845_CLK 0 4.77425e-17
Ctree_2750_50 sp__2750_10 0 1.8387e-16
Ctree_2750_51 sp__2750_12 0 2.89686e-16
Ctree_2750_52 sp__2750_14 0 5.61128e-16
Ctree_2750_53 sp__2750_16 0 3.99906e-16
Ctree_2750_54 sp__2750_18 0 5.62351e-16
Ctree_2750_57 sp__2750_33 0 4.77425e-17
Ctree_2750_61 sp__2750_94 0 6.14271e-16
Ctree_2750_62 sp__2750_98 0 2.08063e-16
Ctree_2750_64 sp__2750_104 0 2.07854e-16
Ctree_2750_66 sp__2750_104 0 2.09317e-16
Ctree_2750_67 sp__2750_104 0 1.12426e-16
Ctree_2750_68 sp__2750_104 0 4.77425e-17
Ctree_2750_71 sp__2750_106 0 1.5729e-16
Ctree_2750_78 sp__2750_12 0 5.33401e-17
Ctree_2750_79 sp__2750_14 0 5.40002e-16
Ctree_2750_80 sp__2750_16 0 1.30055e-16
Ctree_2750_81 sp__11845_CLK 0 2.09544e-16
Ctree_2750_85 sp__11845_CLK 0 4.99211e-16
Ctree_2750_88 sp__11830_CLK 0 8.70568e-16
Ctree_2750_89 sp__2750_94 0 1.83827e-16
Ctree_2750_92 sp__2750_8 0 5.95777e-16
Ctree_2750_94 sp__2750_10 0 5.38157e-17
Ctree_2750_95 sp__2750_12 0 2.3567e-16
Ctree_2750_96 sp__10811_CLK 0 8.0194e-17
Rtree_2751_1 sp__12058_X sp__2751_10 43.0179
Rtree_2751_2 sp__2751_10 sp__2751_12 0.5974
Rtree_2751_3 sp__2751_12 sp__2751_14 1.5862
Rtree_2751_4 sp__2751_14 sp__2751_16 3.811
Rtree_2751_5 sp__2751_16 sp__2751_22 24.5938
Rtree_2751_6 sp__2751_22 sp__11828_CLK 20
Rtree_2751_7 sp__2751_22 sp__2751_31 2.8634
Rtree_2751_8 sp__2751_31 sp__11841_CLK 22.1836
Rtree_2751_9 sp__2751_31 sp__11849_CLK 20
Rtree_2751_10 sp__2751_16 sp__11832_CLK 45.7268
Rtree_2751_11 sp__2751_14 sp__11840_CLK 40.5356
Rtree_2751_12 sp__2751_12 sp__11827_CLK 44.7792
Rtree_2751_13 sp__2751_10 sp__12133_A 41.8334
Rtree_2751_14 sp__12058_X sp__2751_96 23.2144
Rtree_2751_15 sp__2751_96 sp__11011_CLK 20
Rtree_2751_16 sp__2751_96 sp__2751_105 2.678
Rtree_2751_17 sp__2751_105 sp__11010_CLK 20
Rtree_2751_18 sp__2751_105 sp__2751_114 0.9167
Rtree_2751_19 sp__2751_114 sp__2751_120 4.9131
Rtree_2751_20 sp__2751_120 sp__2751_124 6.077
Rtree_2751_21 sp__2751_124 sp__2751_130 41.5862
Rtree_2751_22 sp__2751_130 sp__11790_CLK 23.1106
Rtree_2751_23 sp__2751_130 sp__11826_CLK 22.4308
Rtree_2751_24 sp__2751_124 sp__11850_CLK 20
Rtree_2751_25 sp__2751_120 sp__11829_CLK 20.3502
Rtree_2751_26 sp__2751_114 sp__2751_164 22.0497
Rtree_2751_27 sp__2751_164 sp__11012_CLK 41.339
Rtree_2751_28 sp__2751_164 sp__11009_CLK 47.622
Ctree_2751_1 sp__11009_CLK 0 7.21899e-16
Ctree_2751_2 sp__11012_CLK 0 1.18195e-16
Ctree_2751_3 sp__11829_CLK 0 2.73229e-17
Ctree_2751_5 sp__11826_CLK 0 2.12155e-16
Ctree_2751_6 sp__11790_CLK 0 2.73741e-16
Ctree_2751_9 sp__12133_A 0 2.05275e-16
Ctree_2751_10 sp__11827_CLK 0 4.7354e-16
Ctree_2751_11 sp__11840_CLK 0 4.73766e-17
Ctree_2751_12 sp__11832_CLK 0 5.43472e-16
Ctree_2751_14 sp__11841_CLK 0 1.87507e-16
Ctree_2751_16 sp__12058_X 0 5.92373e-16
Ctree_2751_17 sp__2751_164 0 1.07201e-15
Ctree_2751_18 sp__2751_130 0 6.73343e-16
Ctree_2751_19 sp__2751_124 0 7.97875e-16
Ctree_2751_20 sp__2751_120 0 1.02303e-15
Ctree_2751_21 sp__2751_114 0 6.87857e-16
Ctree_2751_22 sp__2751_105 0 2.76798e-16
Ctree_2751_23 sp__2751_96 0 5.44659e-16
Ctree_2751_24 sp__2751_31 0 4.19382e-16
Ctree_2751_25 sp__2751_22 0 6.53e-16
Ctree_2751_26 sp__2751_16 0 1.2309e-15
Ctree_2751_27 sp__2751_14 0 4.14782e-16
Ctree_2751_28 sp__2751_12 0 6.11793e-16
Ctree_2751_29 sp__2751_10 0 4.96277e-16
Ctree_2751_32 sp__11790_CLK 0 3.37264e-16
Ctree_2751_34 sp__11826_CLK 0 2.56731e-16
Ctree_2751_39 sp__11827_CLK 0 2.7443e-16
Ctree_2751_41 sp__11832_CLK 0 3.71477e-16
Ctree_2751_42 sp__12133_A 0 8.00812e-17
Ctree_2751_44 sp__2751_10 0 7.9947e-17
Ctree_2751_45 sp__2751_10 0 1.43171e-16
Ctree_2751_46 sp__2751_10 0 3.41119e-16
Ctree_2751_49 sp__2751_12 0 1.2816e-16
Ctree_2751_50 sp__2751_14 0 3.41119e-16
Ctree_2751_52 sp__2751_16 0 8.18406e-16
Ctree_2751_55 sp__2751_22 0 1.2816e-16
Ctree_2751_56 sp__2751_22 0 4.99383e-16
Ctree_2751_57 sp__2751_96 0 2.07881e-16
Ctree_2751_58 sp__2751_96 0 3.14112e-16
Ctree_2751_63 sp__2751_124 0 1.7542e-16
Ctree_2751_69 sp__2751_130 0 1.77919e-16
Ctree_2751_70 sp__11827_CLK 0 3.37693e-16
Ctree_2751_73 sp__11832_CLK 0 1.77032e-16
Ctree_2751_74 sp__11841_CLK 0 2.95814e-16
Ctree_2751_76 sp__2751_31 0 2.58898e-16
Ctree_2751_77 sp__2751_124 0 8.00842e-17
Ctree_2751_82 sp__11832_CLK 0 3.39054e-16
Ctree_2751_85 sp__11832_CLK 0 4.77154e-17
Ctree_2751_86 sp__2751_22 0 8.00842e-17
Ctree_2751_87 sp__11841_CLK 0 2.08725e-16
Ctree_2751_89 sp__2751_31 0 3.39213e-16
Ctree_2751_90 sp__11840_CLK 0 8.01938e-17
Ctree_2751_91 sp__2751_124 0 5.93716e-16
Ctree_2751_92 sp__2751_124 0 6.46834e-17
Ctree_2751_93 sp__11009_CLK 0 2.74693e-16
Ctree_2751_94 sp__11009_CLK 0 4.78359e-17
Ctree_2751_95 sp__11009_CLK 0 6.59098e-16
Ctree_2751_96 sp__11009_CLK 0 2.31865e-16
Ctree_2751_98 sp__11012_CLK 0 1.83737e-16
Rtree_2752_1 sp__12059_X sp__2752_4 20
Rtree_2752_2 sp__2752_4 sp__2752_10 25.1191
Rtree_2752_3 sp__2752_10 sp__11789_CLK 41.4111
Rtree_2752_4 sp__2752_10 sp__2752_25 20.6681
Rtree_2752_5 sp__2752_25 sp__11779_CLK 20
Rtree_2752_6 sp__2752_25 sp__11781_CLK 23.1106
Rtree_2752_7 sp__2752_4 sp__2752_45 2.9664
Rtree_2752_8 sp__2752_45 sp__11881_CLK 20
Rtree_2752_9 sp__2752_45 sp__2752_52 0.8446
Rtree_2752_10 sp__2752_52 sp__11882_CLK 23.9964
Rtree_2752_11 sp__2752_52 sp__2752_61 3.9964
Rtree_2752_12 sp__2752_61 sp__2752_63 20
Rtree_2752_13 sp__2752_63 sp__2752_65 4.7998
Rtree_2752_14 sp__2752_65 sp__2752_69 22.8222
Rtree_2752_15 sp__2752_69 sp__11778_CLK 20
Rtree_2752_16 sp__2752_69 sp__2752_78 21.8334
Rtree_2752_17 sp__2752_78 sp__2752_80 6.0358
Rtree_2752_18 sp__2752_80 sp__2752_82 2.0806
Rtree_2752_19 sp__2752_82 sp__11855_CLK 45.8298
Rtree_2752_20 sp__2752_82 sp__2752_101 44.5938
Rtree_2752_21 sp__2752_101 sp__11854_CLK 40
Rtree_2752_22 sp__2752_80 sp__11800_CLK 40
Rtree_2752_23 sp__2752_78 sp__11853_CLK 40.8446
Rtree_2752_24 sp__2752_65 sp__11791_CLK 42.266
Rtree_2752_25 sp__2752_63 sp__2752_137 4.3466
Rtree_2752_26 sp__2752_137 sp__11880_CLK 41.8334
Rtree_2752_27 sp__2752_137 sp__11776_CLK 45.3354
Rtree_2752_28 sp__2752_61 sp__11777_CLK 20
Rtree_2752_29 sp__2752_61 sp__11852_CLK 21.8334
Ctree_2752_1 sp__11852_CLK 0 1.86149e-16
Ctree_2752_3 sp__11776_CLK 0 7.39381e-16
Ctree_2752_4 sp__11880_CLK 0 1.5521e-16
Ctree_2752_5 sp__11791_CLK 0 2.51286e-16
Ctree_2752_6 sp__11853_CLK 0 6.66777e-17
Ctree_2752_9 sp__11855_CLK 0 5.4858e-16
Ctree_2752_11 sp__11882_CLK 0 3.90939e-16
Ctree_2752_13 sp__11781_CLK 0 2.7709e-16
Ctree_2752_15 sp__11789_CLK 0 1.17016e-16
Ctree_2752_17 sp__2752_137 0 1.20343e-15
Ctree_2752_18 sp__2752_101 0 4.7488e-16
Ctree_2752_19 sp__2752_82 0 1.20542e-15
Ctree_2752_20 sp__2752_80 0 6.58523e-16
Ctree_2752_21 sp__2752_78 0 7.52236e-16
Ctree_2752_22 sp__2752_69 0 5.32276e-16
Ctree_2752_23 sp__2752_65 0 1.03815e-15
Ctree_2752_24 sp__2752_63 0 7.72417e-16
Ctree_2752_25 sp__2752_61 0 6.56314e-16
Ctree_2752_26 sp__2752_52 0 9.27973e-16
Ctree_2752_27 sp__2752_45 0 3.55193e-16
Ctree_2752_28 sp__2752_25 0 4.79331e-16
Ctree_2752_29 sp__2752_10 0 7.62493e-16
Ctree_2752_30 sp__2752_4 0 7.3156e-16
Ctree_2752_34 sp__11776_CLK 0 8.00842e-17
Ctree_2752_35 sp__11781_CLK 0 3.38911e-16
Ctree_2752_37 sp__11789_CLK 0 4.77425e-17
Ctree_2752_38 sp__11791_CLK 0 2.39682e-16
Ctree_2752_40 sp__11855_CLK 0 2.85869e-16
Ctree_2752_41 sp__11855_CLK 0 7.51285e-17
Ctree_2752_42 sp__11855_CLK 0 3.39186e-16
Ctree_2752_47 sp__11882_CLK 0 4.78524e-17
Ctree_2752_49 sp__11882_CLK 0 1.12358e-16
Ctree_2752_50 sp__2752_10 0 2.82671e-16
Ctree_2752_51 sp__2752_10 0 4.67694e-16
Ctree_2752_59 sp__2752_65 0 4.99327e-16
Ctree_2752_64 sp__2752_80 0 9.55697e-16
Ctree_2752_65 sp__2752_82 0 4.1865e-16
Ctree_2752_67 sp__2752_101 0 4.77425e-17
Ctree_2752_68 sp__2752_137 0 3.67676e-16
Ctree_2752_71 sp__11880_CLK 0 2.72747e-16
Ctree_2752_72 sp__11880_CLK 0 2.72823e-16
Ctree_2752_73 sp__11882_CLK 0 4.78359e-17
Ctree_2752_82 sp__2752_137 0 6.05865e-16
Ctree_2752_84 sp__11776_CLK 0 8.00842e-17
Ctree_2752_86 sp__11855_CLK 0 3.39328e-16
Ctree_2752_87 sp__11789_CLK 0 2.35075e-16
Ctree_2752_88 sp__2752_10 0 2.65884e-16
Ctree_2752_91 sp__2752_45 0 1.54556e-17
Ctree_2752_92 sp__11882_CLK 0 1.76236e-16
Ctree_2752_105 sp__2752_101 0 2.73639e-16
Ctree_2752_108 sp__2752_101 0 4.78195e-17
Rtree_2753_1 sp__12060_X sp__2753_4 20
Rtree_2753_2 sp__2753_4 sp__2753_8 23.9964
Rtree_2753_3 sp__2753_8 sp__2753_10 2.575
Rtree_2753_4 sp__2753_10 sp__2753_12 2.8222
Rtree_2753_5 sp__2753_12 sp__11838_CLK 45.5826
Rtree_2753_6 sp__2753_12 sp__2753_25 20
Rtree_2753_7 sp__2753_25 sp__11784_CLK 20
Rtree_2753_8 sp__2753_25 sp__2753_32 4.8616
Rtree_2753_9 sp__2753_32 sp__2753_38 44.7998
Rtree_2753_10 sp__2753_38 sp__2753_42 1.5656
Rtree_2753_11 sp__2753_42 sp__2753_50 43.914
Rtree_2753_12 sp__2753_50 sp__11851_CLK 20
Rtree_2753_13 sp__2753_42 sp__11839_CLK 20
Rtree_2753_14 sp__2753_38 sp__2753_62 1.4008
Rtree_2753_15 sp__2753_62 sp__11833_CLK 22.1836
Rtree_2753_16 sp__2753_62 sp__11825_CLK 20
Rtree_2753_17 sp__2753_32 sp__2753_80 7.622
Rtree_2753_18 sp__2753_80 sp__11824_CLK 20
Rtree_2753_19 sp__2753_80 sp__2753_93 45.0306
Rtree_2753_20 sp__2753_93 sp__11008_CLK 20
Rtree_2753_21 sp__2753_10 sp__2753_106 30.3212
Rtree_2753_22 sp__2753_106 sp__2753_114 42.4308
Rtree_2753_23 sp__2753_114 sp__11879_CLK 20
Rtree_2753_24 sp__2753_8 sp__2753_123 21.5862
Rtree_2753_25 sp__2753_123 sp__2753_129 23.914
Rtree_2753_26 sp__2753_129 sp__11775_CLK 40
Rtree_2753_27 sp__2753_129 sp__11873_CLK 48.0546
Rtree_2753_28 sp__2753_123 sp__11837_CLK 20
Rtree_2753_29 sp__2753_4 sp__2753_168 46.9834
Rtree_2753_30 sp__2753_168 sp__2753_176 3.5638
Rtree_2753_31 sp__2753_176 sp__2753_182 46.7774
Rtree_2753_32 sp__2753_182 sp__11835_CLK 20
Rtree_2753_33 sp__2753_176 sp__11834_CLK 20
Rtree_2753_34 sp__2753_168 sp__11774_CLK 20
Ctree_2753_5 sp__11873_CLK 0 5.79478e-16
Ctree_2753_11 sp__11833_CLK 0 2.21507e-16
Ctree_2753_15 sp__11838_CLK 0 5.91585e-16
Ctree_2753_17 sp__2753_182 0 3.29139e-16
Ctree_2753_18 sp__2753_176 0 6.38709e-16
Ctree_2753_19 sp__2753_168 0 8.8273e-16
Ctree_2753_20 sp__2753_129 0 8.33271e-16
Ctree_2753_21 sp__2753_123 0 3.68272e-16
Ctree_2753_22 sp__2753_114 0 1.80786e-16
Ctree_2753_23 sp__2753_106 0 1.31464e-15
Ctree_2753_24 sp__2753_93 0 6.25777e-16
Ctree_2753_25 sp__2753_80 0 1.37412e-15
Ctree_2753_26 sp__2753_62 0 3.83666e-16
Ctree_2753_27 sp__2753_50 0 3.42417e-16
Ctree_2753_28 sp__2753_42 0 5.0274e-16
Ctree_2753_29 sp__2753_38 0 5.29887e-16
Ctree_2753_30 sp__2753_32 0 1.5086e-15
Ctree_2753_31 sp__2753_25 0 5.52847e-16
Ctree_2753_32 sp__2753_12 0 7.86729e-16
Ctree_2753_33 sp__2753_10 0 1.51453e-15
Ctree_2753_34 sp__2753_8 0 7.72353e-16
Ctree_2753_35 sp__2753_4 0 1.0455e-15
Ctree_2753_37 sp__11838_CLK 0 8.0194e-17
Ctree_2753_38 sp__11838_CLK 0 3.37302e-16
Ctree_2753_40 sp__11873_CLK 0 3.1572e-16
Ctree_2753_41 sp__11873_CLK 0 8.65876e-16
Ctree_2753_42 sp__11873_CLK 0 4.98343e-16
Ctree_2753_46 sp__2753_10 0 5.53247e-16
Ctree_2753_48 sp__2753_12 0 6.09183e-16
Ctree_2753_52 sp__2753_38 0 1.02796e-15
Ctree_2753_55 sp__2753_50 0 2.74088e-16
Ctree_2753_56 sp__2753_50 0 4.47685e-16
Ctree_2753_59 sp__2753_80 0 5.66139e-16
Ctree_2753_61 sp__2753_93 0 1.54556e-17
Ctree_2753_64 sp__2753_106 0 1.12426e-16
Ctree_2753_67 sp__2753_106 0 2.08206e-16
Ctree_2753_68 sp__2753_123 0 3.40288e-16
Ctree_2753_70 sp__2753_129 0 2.72955e-16
Ctree_2753_71 sp__2753_129 0 1.26358e-16
Ctree_2753_72 sp__2753_129 0 4.43058e-16
Ctree_2753_73 sp__2753_129 0 3.38434e-16
Ctree_2753_76 sp__2753_168 0 2.85201e-16
Ctree_2753_78 sp__2753_168 0 3.06035e-16
Ctree_2753_79 sp__2753_176 0 1.54556e-17
Ctree_2753_80 sp__2753_182 0 9.81238e-16
Ctree_2753_81 sp__2753_182 0 1.45986e-15
Ctree_2753_83 sp__2753_106 0 1.44528e-16
Ctree_2753_84 sp__2753_106 0 2.4058e-16
Ctree_2753_85 sp__2753_106 0 3.37605e-16
Ctree_2753_86 sp__2753_114 0 2.72647e-16
Ctree_2753_88 sp__2753_32 0 1.12558e-16
Ctree_2753_92 sp__2753_80 0 4.77425e-17
Ctree_2753_94 sp__2753_168 0 1.75721e-16
Ctree_2753_96 sp__2753_168 0 1.54008e-17
Ctree_2753_97 sp__2753_8 0 1.43908e-16
Ctree_2753_99 sp__11873_CLK 0 5.95418e-16
Ctree_2753_105 sp__2753_176 0 2.32936e-16
Ctree_2753_107 sp__2753_106 0 8.00842e-17
Ctree_2753_108 sp__2753_114 0 1.2816e-16
Ctree_2753_110 sp__2753_114 0 2.72647e-16
Ctree_2753_111 sp__2753_80 0 3.55983e-16
Ctree_2753_113 sp__2753_8 0 8.00842e-17
Ctree_2753_114 sp__11838_CLK 0 2.8427e-16
Ctree_2753_115 sp__2753_168 0 4.4611e-16
Ctree_2753_116 sp__2753_8 0 1.54008e-17
Ctree_2753_122 sp__2753_129 0 2.72878e-16
Ctree_2753_123 sp__2753_168 0 1.76694e-16
Ctree_2753_126 sp__2753_114 0 1.28247e-16
Ctree_2753_127 sp__11873_CLK 0 2.85866e-16
Rtree_2754_1 sp__12061_X sp__2754_8 41.4008
Rtree_2754_2 sp__2754_8 sp__2754_10 1.0918
Rtree_2754_3 sp__2754_10 sp__2754_14 26.5302
Rtree_2754_4 sp__2754_14 sp__2754_18 21.8334
Rtree_2754_5 sp__2754_18 sp__2754_28 25.7268
Rtree_2754_6 sp__2754_28 sp__11822_CLK 22.9664
Rtree_2754_7 sp__2754_28 sp__2754_41 1.8334
Rtree_2754_8 sp__2754_41 sp__2754_47 30.4648
Rtree_2754_9 sp__2754_47 sp__12139_A 41.4008
Rtree_2754_10 sp__2754_41 sp__2754_60 25.047
Rtree_2754_11 sp__2754_60 sp__11836_CLK 41.5862
Rtree_2754_12 sp__2754_60 sp__2754_81 28.7962
Rtree_2754_13 sp__2754_81 sp__11823_CLK 20
Rtree_2754_14 sp__2754_81 sp__11817_CLK 28.7344
Rtree_2754_15 sp__2754_18 sp__10980_CLK 41.0918
Rtree_2754_16 sp__2754_14 sp__10981_CLK 23.8802
Rtree_2754_17 sp__2754_10 sp__11821_CLK 40
Rtree_2754_18 sp__2754_8 sp__2754_122 2.575
Rtree_2754_19 sp__2754_122 sp__10982_CLK 44.4496
Rtree_2754_20 sp__2754_122 sp__2754_137 2.3278
Rtree_2754_21 sp__2754_137 sp__2754_141 23.9964
Rtree_2754_22 sp__2754_141 sp__10965_CLK 20
Rtree_2754_23 sp__2754_141 sp__2754_150 2.4308
Rtree_2754_24 sp__2754_150 sp__11865_CLK 22.266
Rtree_2754_25 sp__2754_150 sp__10966_CLK 20
Rtree_2754_26 sp__2754_137 sp__2754_166 21.0918
Rtree_2754_27 sp__2754_166 sp__11820_CLK 20
Rtree_2754_28 sp__2754_166 sp__2754_175 3.1106
Rtree_2754_29 sp__2754_175 sp__10985_CLK 20
Rtree_2754_30 sp__2754_175 sp__2754_182 5.7268
Rtree_2754_31 sp__2754_182 sp__10983_CLK 23.6668
Rtree_2754_32 sp__2754_182 sp__10984_CLK 20
Ctree_2754_2 sp__10983_CLK 0 3.25187e-16
Ctree_2754_6 sp__11865_CLK 0 2.04937e-16
Ctree_2754_8 sp__10982_CLK 0 4.62563e-16
Ctree_2754_10 sp__10981_CLK 0 4.78916e-16
Ctree_2754_11 sp__10980_CLK 0 4.76994e-17
Ctree_2754_12 sp__11817_CLK 0 8.85356e-16
Ctree_2754_14 sp__11836_CLK 0 6.44122e-17
Ctree_2754_15 sp__12139_A 0 1.76829e-16
Ctree_2754_16 sp__11822_CLK 0 2.86078e-16
Ctree_2754_17 sp__12061_X 0 1.57464e-16
Ctree_2754_18 sp__2754_182 0 9.03083e-16
Ctree_2754_19 sp__2754_175 0 8.80302e-16
Ctree_2754_20 sp__2754_166 0 4.21328e-16
Ctree_2754_21 sp__2754_150 0 4.22755e-16
Ctree_2754_22 sp__2754_141 0 5.94044e-16
Ctree_2754_23 sp__2754_137 0 7.19099e-16
Ctree_2754_24 sp__2754_122 0 9.39168e-16
Ctree_2754_25 sp__2754_81 0 1.85014e-15
Ctree_2754_26 sp__2754_60 0 1.25526e-15
Ctree_2754_27 sp__2754_47 0 1.11669e-15
Ctree_2754_28 sp__2754_41 0 1.38064e-15
Ctree_2754_29 sp__2754_28 0 1.04225e-15
Ctree_2754_30 sp__2754_18 0 7.80833e-16
Ctree_2754_31 sp__2754_14 0 1.38058e-15
Ctree_2754_32 sp__2754_10 0 8.07449e-16
Ctree_2754_33 sp__2754_8 0 5.07586e-16
Ctree_2754_34 sp__10980_CLK 0 2.10621e-16
Ctree_2754_35 sp__10981_CLK 0 1.54008e-17
Ctree_2754_36 sp__10981_CLK 0 1.54008e-17
Ctree_2754_38 sp__10982_CLK 0 8.00842e-17
Ctree_2754_40 sp__10982_CLK 0 4.77425e-17
Ctree_2754_44 sp__11817_CLK 0 3.06673e-16
Ctree_2754_47 sp__11822_CLK 0 2.72647e-16
Ctree_2754_50 sp__11822_CLK 0 8.01609e-17
Ctree_2754_51 sp__11865_CLK 0 3.38121e-16
Ctree_2754_54 sp__2754_10 0 2.124e-16
Ctree_2754_56 sp__2754_14 0 4.92558e-16
Ctree_2754_57 sp__2754_14 0 1.78834e-16
Ctree_2754_59 sp__2754_18 0 1.43807e-16
Ctree_2754_60 sp__2754_28 0 4.65187e-16
Ctree_2754_61 sp__2754_28 0 1.44271e-16
Ctree_2754_62 sp__2754_28 0 1.28248e-16
Ctree_2754_67 sp__2754_47 0 6.55763e-16
Ctree_2754_68 sp__2754_47 0 6.55592e-16
Ctree_2754_71 sp__2754_81 0 1.12198e-16
Ctree_2754_72 sp__2754_81 0 4.7803e-17
Ctree_2754_75 sp__2754_81 0 2.40196e-16
Ctree_2754_77 sp__2754_122 0 5.2358e-16
Ctree_2754_80 sp__2754_137 0 2.12124e-16
Ctree_2754_84 sp__2754_141 0 3.39289e-16
Ctree_2754_85 sp__2754_150 0 2.72774e-16
Ctree_2754_91 sp__2754_182 0 3.39245e-16
Ctree_2754_100 sp__2754_81 0 8.00842e-17
Ctree_2754_101 sp__2754_14 0 2.79436e-16
Ctree_2754_102 sp__10982_CLK 0 1.11969e-16
Ctree_2754_103 sp__10982_CLK 0 8.0216e-17
Ctree_2754_106 sp__2754_47 0 1.75699e-16
Ctree_2754_112 sp__2754_18 0 8.00842e-17
Ctree_2754_115 sp__2754_81 0 1.44271e-16
Ctree_2754_117 sp__11836_CLK 0 3.41206e-16
Ctree_2754_118 sp__2754_60 0 1.05583e-15
Ctree_2754_120 sp__2754_47 0 5.48217e-16
Ctree_2754_121 sp__11836_CLK 0 3.41119e-16
Ctree_2754_122 sp__2754_60 0 1.07676e-15
Ctree_2754_123 sp__2754_81 0 4.76053e-17
Ctree_2754_125 sp__2754_14 0 2.30583e-16
Ctree_2754_127 sp__10980_CLK 0 2.32389e-16
Ctree_2754_128 sp__2754_28 0 1.2816e-16
Rtree_2755_1 sp__12062_X sp__2755_8 43.3166
Rtree_2755_2 sp__2755_8 sp__2755_10 20
Rtree_2755_3 sp__2755_10 sp__2755_12 2.266
Rtree_2755_4 sp__2755_12 sp__2755_14 4.2127
Rtree_2755_5 sp__2755_14 sp__2755_16 1.6171
Rtree_2755_6 sp__2755_16 sp__10971_CLK 20
Rtree_2755_7 sp__2755_16 sp__10970_CLK 22.8634
Rtree_2755_8 sp__2755_14 sp__2755_34 22.3278
Rtree_2755_9 sp__2755_34 sp__2755_44 26.7465
Rtree_2755_10 sp__2755_44 sp__2755_48 22.8222
Rtree_2755_11 sp__2755_48 sp__2755_52 20.8446
Rtree_2755_12 sp__2755_52 sp__10975_CLK 20
Rtree_2755_13 sp__2755_52 sp__2755_59 1.8334
Rtree_2755_14 sp__2755_59 sp__10976_CLK 20
Rtree_2755_15 sp__2755_59 sp__2755_72 4.0582
Rtree_2755_16 sp__2755_72 sp__11871_CLK 20
Rtree_2755_17 sp__2755_72 sp__2755_79 1.8334
Rtree_2755_18 sp__2755_79 sp__2755_83 20.8446
Rtree_2755_19 sp__2755_83 sp__11872_CLK 46.0358
Rtree_2755_20 sp__2755_83 sp__2755_96 23.9964
Rtree_2755_21 sp__2755_96 sp__10978_CLK 20
Rtree_2755_22 sp__2755_96 sp__2755_111 43.708
Rtree_2755_23 sp__2755_111 sp__10979_CLK 20
Rtree_2755_24 sp__2755_79 sp__10977_CLK 20
Rtree_2755_25 sp__2755_48 sp__10974_CLK 46.1594
Rtree_2755_26 sp__2755_44 sp__12140_A 20
Rtree_2755_27 sp__2755_34 sp__11868_CLK 40.291
Rtree_2755_28 sp__2755_12 sp__10969_CLK 20
Rtree_2755_29 sp__2755_10 sp__2755_151 1.8334
Rtree_2755_30 sp__2755_151 sp__10968_CLK 20
Rtree_2755_31 sp__2755_151 sp__10967_CLK 20.418
Rtree_2755_32 sp__2755_8 sp__11866_CLK 40.5974
Ctree_2755_1 sp__11866_CLK 0 6.95205e-17
Ctree_2755_2 sp__10967_CLK 0 2.25113e-16
Ctree_2755_5 sp__11868_CLK 0 2.3745e-17
Ctree_2755_7 sp__10974_CLK 0 7.3264e-16
Ctree_2755_11 sp__11872_CLK 0 5.90611e-16
Ctree_2755_15 sp__10970_CLK 0 3.1692e-16
Ctree_2755_17 sp__12062_X 0 4.48548e-16
Ctree_2755_18 sp__2755_151 0 3.89095e-16
Ctree_2755_19 sp__2755_111 0 3.29451e-16
Ctree_2755_20 sp__2755_96 0 7.95882e-16
Ctree_2755_21 sp__2755_83 0 1.12917e-15
Ctree_2755_22 sp__2755_79 0 2.77787e-16
Ctree_2755_23 sp__2755_72 0 5.64594e-16
Ctree_2755_24 sp__2755_59 0 5.49981e-16
Ctree_2755_25 sp__2755_52 0 2.65081e-16
Ctree_2755_26 sp__2755_48 0 1.08292e-15
Ctree_2755_27 sp__2755_44 0 9.86613e-16
Ctree_2755_28 sp__2755_34 0 8.60411e-16
Ctree_2755_29 sp__2755_16 0 4.72653e-16
Ctree_2755_30 sp__2755_14 0 6.79758e-16
Ctree_2755_31 sp__2755_12 0 5.88454e-16
Ctree_2755_32 sp__2755_10 0 3.54701e-16
Ctree_2755_33 sp__2755_8 0 5.18069e-16
Ctree_2755_39 sp__11868_CLK 0 4.35073e-17
Ctree_2755_40 sp__11868_CLK 0 4.35073e-17
Ctree_2755_42 sp__2755_12 0 3.24037e-16
Ctree_2755_45 sp__2755_14 0 6.12795e-16
Ctree_2755_47 sp__2755_16 0 2.40957e-16
Ctree_2755_48 sp__2755_34 0 4.6648e-16
Ctree_2755_49 sp__2755_44 0 2.33188e-16
Ctree_2755_50 sp__2755_44 0 1.816e-16
Ctree_2755_52 sp__2755_44 0 2.1786e-17
Ctree_2755_57 sp__2755_48 0 4.72477e-16
Ctree_2755_58 sp__2755_52 0 1.82517e-16
Ctree_2755_65 sp__2755_96 0 1.12018e-16
Ctree_2755_66 sp__2755_111 0 1.76293e-16
Ctree_2755_67 sp__2755_151 0 2.5837e-16
Ctree_2755_70 sp__2755_34 0 4.88266e-16
Ctree_2755_71 sp__2755_44 0 4.37723e-16
Ctree_2755_72 sp__11872_CLK 0 1.28271e-15
Ctree_2755_73 sp__2755_83 0 1.6011e-16
Ctree_2755_80 sp__2755_111 0 7.33225e-17
Ctree_2755_83 sp__2755_111 0 4.67945e-17
Ctree_2755_84 sp__2755_111 0 1.29499e-16
Ctree_2755_89 sp__2755_111 0 2.82236e-16
Ctree_2755_90 sp__2755_111 0 1.26146e-16
Rtree_2756_1 sp__12063_X sp__2756_14 45.2942
Rtree_2756_2 sp__2756_14 sp__2756_18 22.266
Rtree_2756_3 sp__2756_18 sp__11869_CLK 20
Rtree_2756_4 sp__2756_18 sp__2756_27 2.1836
Rtree_2756_5 sp__2756_27 sp__2756_31 22.266
Rtree_2756_6 sp__2756_31 sp__2756_33 1.0918
Rtree_2756_7 sp__2756_33 sp__2756_35 4.7998
Rtree_2756_8 sp__2756_35 sp__11308_CLK 42.1913
Rtree_2756_9 sp__2756_35 sp__11309_CLK 41.8334
Rtree_2756_10 sp__2756_33 sp__11310_CLK 40
Rtree_2756_11 sp__2756_31 sp__2756_66 23.5638
Rtree_2756_12 sp__2756_66 sp__11312_CLK 22.9252
Rtree_2756_13 sp__2756_66 sp__2756_77 2.266
Rtree_2756_14 sp__2756_77 sp__2756_83 43.5638
Rtree_2756_15 sp__2756_83 sp__12130_A 20
Rtree_2756_16 sp__2756_77 sp__10972_CLK 20
Rtree_2756_17 sp__2756_27 sp__2756_97 23.3166
Rtree_2756_18 sp__2756_97 sp__2756_99 3.811
Rtree_2756_19 sp__2756_99 sp__2756_101 2.98443
Rtree_2756_20 sp__2756_101 sp__2756_107 2.58787
Rtree_2756_21 sp__2756_107 sp__11771_CLK 45.7165
Rtree_2756_22 sp__2756_107 sp__11772_CLK 46.7465
Rtree_2756_23 sp__2756_101 sp__11221_CLK 40
Rtree_2756_24 sp__2756_99 sp__2756_146 21.4638
Rtree_2756_25 sp__2756_146 sp__11870_CLK 20
Rtree_2756_26 sp__2756_146 sp__10973_CLK 24.2024
Rtree_2756_27 sp__2756_97 sp__11311_CLK 40
Rtree_2756_28 sp__2756_14 sp__11867_CLK 44.3054
Ctree_2756_1 sp__11867_CLK 0 4.80988e-16
Ctree_2756_3 sp__10973_CLK 0 3.82446e-16
Ctree_2756_6 sp__11772_CLK 0 6.66622e-16
Ctree_2756_7 sp__11771_CLK 0 6.22541e-16
Ctree_2756_10 sp__11312_CLK 0 2.65171e-16
Ctree_2756_12 sp__11309_CLK 0 1.71292e-16
Ctree_2756_13 sp__11308_CLK 0 1.86805e-16
Ctree_2756_15 sp__12063_X 0 5.87767e-16
Ctree_2756_16 sp__2756_146 0 5.97663e-16
Ctree_2756_17 sp__2756_107 0 1.61844e-15
Ctree_2756_18 sp__2756_101 0 7.49673e-16
Ctree_2756_19 sp__2756_99 0 1.01044e-15
Ctree_2756_20 sp__2756_97 0 6.03366e-16
Ctree_2756_21 sp__2756_83 0 3.35463e-16
Ctree_2756_22 sp__2756_77 0 5.39561e-16
Ctree_2756_23 sp__2756_66 0 8.47397e-16
Ctree_2756_24 sp__2756_35 0 8.2712e-16
Ctree_2756_25 sp__2756_33 0 5.75689e-16
Ctree_2756_26 sp__2756_31 0 7.47643e-16
Ctree_2756_27 sp__2756_27 0 7.05252e-16
Ctree_2756_28 sp__2756_18 0 4.47092e-16
Ctree_2756_29 sp__2756_14 0 1.30198e-15
Ctree_2756_31 sp__10973_CLK 0 3.84678e-17
Ctree_2756_33 sp__11309_CLK 0 2.726e-16
Ctree_2756_36 sp__11771_CLK 0 1.53283e-17
Ctree_2756_37 sp__11771_CLK 0 2.79156e-16
Ctree_2756_39 sp__11771_CLK 0 3.05942e-16
Ctree_2756_40 sp__11771_CLK 0 1.12349e-16
Ctree_2756_42 sp__11772_CLK 0 2.14475e-17
Ctree_2756_43 sp__11772_CLK 0 6.11107e-16
Ctree_2756_46 sp__11772_CLK 0 1.72301e-16
Ctree_2756_48 sp__11867_CLK 0 4.92806e-16
Ctree_2756_51 sp__2756_14 0 1.76239e-16
Ctree_2756_52 sp__2756_14 0 2.40438e-16
Ctree_2756_54 sp__2756_18 0 3.38399e-16
Ctree_2756_59 sp__2756_83 0 1.24547e-16
Ctree_2756_60 sp__2756_83 0 1.77127e-16
Ctree_2756_61 sp__2756_83 0 6.40956e-16
Ctree_2756_62 sp__2756_97 0 7.03412e-16
Ctree_2756_64 sp__2756_97 0 2.79156e-16
Ctree_2756_66 sp__2756_99 0 7.02675e-16
Ctree_2756_74 sp__2756_27 0 2.4156e-16
Ctree_2756_75 sp__11867_CLK 0 7.30101e-17
Ctree_2756_81 sp__11312_CLK 0 2.742e-16
Ctree_2756_82 sp__2756_77 0 3.23773e-16
Ctree_2756_83 sp__2756_31 0 1.7673e-16
Ctree_2756_84 sp__11308_CLK 0 4.40909e-16
Ctree_2756_85 sp__2756_33 0 2.28663e-16
Ctree_2756_86 sp__2756_35 0 1.01555e-15
Ctree_2756_87 sp__2756_66 0 7.44029e-16
Rtree_2757_1 sp__12064_X sp__2757_4 20
Rtree_2757_2 sp__2757_4 sp__2757_6 2.266
Rtree_2757_3 sp__2757_6 sp__2757_16 42.5338
Rtree_2757_4 sp__2757_16 sp__2757_20 22.0497
Rtree_2757_5 sp__2757_20 sp__2757_22 2.575
Rtree_2757_6 sp__2757_22 sp__2757_24 3.5638
Rtree_2757_7 sp__2757_24 sp__2757_30 22.8943
Rtree_2757_8 sp__2757_30 sp__11783_CLK 20
Rtree_2757_9 sp__2757_30 sp__2757_37 1.8334
Rtree_2757_10 sp__2757_37 sp__2757_43 40.5974
Rtree_2757_11 sp__2757_43 sp__11878_CLK 20
Rtree_2757_12 sp__2757_37 sp__2757_54 22.0909
Rtree_2757_13 sp__2757_54 sp__2757_56 2.8222
Rtree_2757_14 sp__2757_56 sp__11780_CLK 45.3045
Rtree_2757_15 sp__2757_56 sp__2757_75 42.2145
Rtree_2757_16 sp__2757_75 sp__11788_CLK 41.8334
Rtree_2757_17 sp__2757_54 sp__11782_CLK 47.6941
Rtree_2757_18 sp__2757_24 sp__2757_101 22.0497
Rtree_2757_19 sp__2757_101 sp__11233_CLK 20
Rtree_2757_20 sp__2757_101 sp__11290_CLK 22.6162
Rtree_2757_21 sp__2757_22 sp__11234_CLK 40.3193
Rtree_2757_22 sp__2757_20 sp__2757_126 0.8446
Rtree_2757_23 sp__2757_126 sp__11292_CLK 42.0497
Rtree_2757_24 sp__2757_126 sp__11293_CLK 43.8831
Rtree_2757_25 sp__2757_16 sp__11769_CLK 20
Rtree_2757_26 sp__2757_6 sp__11877_CLK 20
Rtree_2757_27 sp__2757_4 sp__2757_158 3.9964
Rtree_2757_28 sp__2757_158 sp__2757_162 21.5862
Rtree_2757_29 sp__2757_162 sp__2757_166 21.8334
Rtree_2757_30 sp__2757_166 sp__11876_CLK 20
Rtree_2757_31 sp__2757_166 sp__2757_173 6.1594
Rtree_2757_32 sp__2757_173 sp__2757_179 42.8222
Rtree_2757_33 sp__2757_179 sp__11874_CLK 20
Rtree_2757_34 sp__2757_173 sp__2757_192 42.678
Rtree_2757_35 sp__2757_192 sp__11773_CLK 20
Rtree_2757_36 sp__2757_162 sp__11875_CLK 45.0882
Rtree_2757_37 sp__2757_158 sp__11770_CLK 20
Ctree_2757_2 sp__11875_CLK 0 4.11828e-16
Ctree_2757_8 sp__11293_CLK 0 4.05972e-16
Ctree_2757_9 sp__11292_CLK 0 2.07401e-16
Ctree_2757_10 sp__11234_CLK 0 2.60565e-17
Ctree_2757_11 sp__11290_CLK 0 2.19111e-16
Ctree_2757_13 sp__11782_CLK 0 7.44516e-16
Ctree_2757_14 sp__11788_CLK 0 1.85078e-16
Ctree_2757_15 sp__11780_CLK 0 4.96824e-16
Ctree_2757_19 sp__2757_192 0 2.31352e-16
Ctree_2757_20 sp__2757_179 0 3.04117e-16
Ctree_2757_21 sp__2757_173 0 1.1172e-15
Ctree_2757_22 sp__2757_166 0 7.30123e-16
Ctree_2757_23 sp__2757_162 0 6.78315e-16
Ctree_2757_24 sp__2757_158 0 5.37764e-16
Ctree_2757_25 sp__2757_126 0 7.055e-16
Ctree_2757_26 sp__2757_101 0 4.86585e-16
Ctree_2757_27 sp__2757_75 0 3.8656e-16
Ctree_2757_28 sp__2757_56 0 9.93286e-16
Ctree_2757_29 sp__2757_54 0 1.22055e-15
Ctree_2757_30 sp__2757_43 0 7.93572e-17
Ctree_2757_31 sp__2757_37 0 4.11417e-16
Ctree_2757_32 sp__2757_30 0 4.08207e-16
Ctree_2757_33 sp__2757_24 0 8.69272e-16
Ctree_2757_34 sp__2757_22 0 6.16171e-16
Ctree_2757_35 sp__2757_20 0 5.0606e-16
Ctree_2757_36 sp__2757_16 0 3.84227e-16
Ctree_2757_37 sp__2757_6 0 4.13874e-16
Ctree_2757_38 sp__2757_4 0 6.17733e-16
Ctree_2757_39 sp__11234_CLK 0 4.77425e-17
Ctree_2757_40 sp__11234_CLK 0 4.77425e-17
Ctree_2757_41 sp__11290_CLK 0 2.7343e-16
Ctree_2757_42 sp__11290_CLK 0 3.38377e-16
Ctree_2757_43 sp__11292_CLK 0 4.77425e-17
Ctree_2757_45 sp__11293_CLK sp__2760_28 7.21512e-16
Ctree_2757_46 sp__11293_CLK 0 4.77425e-17
Ctree_2757_47 sp__11293_CLK 0 4.77425e-17
Ctree_2757_48 sp__11780_CLK 0 2.08041e-16
Ctree_2757_50 sp__11780_CLK 0 2.8524e-16
Ctree_2757_52 sp__11780_CLK 0 5.96263e-16
Ctree_2757_53 sp__11782_CLK 0 4.98184e-16
Ctree_2757_55 sp__11782_CLK 0 2.07637e-16
Ctree_2757_58 sp__11782_CLK 0 1.44009e-16
Ctree_2757_59 sp__11788_CLK 0 2.74365e-16
Ctree_2757_61 sp__11788_CLK 0 1.54449e-17
Ctree_2757_62 sp__11875_CLK 0 3.39174e-16
Ctree_2757_63 sp__11875_CLK 0 3.39174e-16
Ctree_2757_64 sp__11875_CLK 0 2.29033e-16
Ctree_2757_65 sp__2757_6 0 2.41088e-16
Ctree_2757_66 sp__2757_6 0 3.22713e-16
Ctree_2757_67 sp__2757_16 0 1.60217e-16
Ctree_2757_68 sp__2757_16 0 2.87638e-16
Ctree_2757_69 sp__2757_20 0 3.05904e-16
Ctree_2757_70 sp__2757_20 0 3.05904e-16
Ctree_2757_71 sp__2757_22 sp__2760_28 5.19405e-16
Ctree_2757_73 sp__2757_24 sp__2760_28 7.23012e-16
Ctree_2757_74 sp__2757_24 0 7.30101e-17
Ctree_2757_76 sp__2757_30 sp__2760_28 1.76396e-16
Ctree_2757_77 sp__2757_30 0 3.05367e-16
Ctree_2757_78 sp__2757_30 0 3.05275e-16
Ctree_2757_80 sp__2757_37 0 2.57423e-16
Ctree_2757_81 sp__2757_37 0 2.72747e-16
Ctree_2757_82 sp__2757_43 0 2.14736e-17
Ctree_2757_83 sp__2757_54 0 9.72114e-17
Ctree_2757_84 sp__2757_54 0 1.12558e-16
Ctree_2757_85 sp__2757_54 0 2.79156e-16
Ctree_2757_86 sp__2757_56 0 5.88376e-16
Ctree_2757_87 sp__2757_75 0 2.40196e-16
Ctree_2757_88 sp__2757_75 0 2.40196e-16
Ctree_2757_90 sp__2757_101 0 1.54008e-17
Ctree_2757_91 sp__2757_126 sp__2760_28 1.5461e-16
Ctree_2757_92 sp__2757_158 0 1.44999e-16
Ctree_2757_94 sp__2757_158 0 1.1159e-16
Ctree_2757_95 sp__2757_158 0 3.23417e-17
Ctree_2757_97 sp__2757_166 0 2.74189e-16
Ctree_2757_98 sp__2757_166 0 2.74189e-16
Ctree_2757_99 sp__2757_173 0 2.40306e-16
Ctree_2757_101 sp__2757_173 0 9.19906e-16
Ctree_2757_103 sp__2757_179 0 5.92415e-16
Ctree_2757_104 sp__2757_192 0 1.43729e-16
Ctree_2757_105 sp__2757_192 0 1.76083e-16
Ctree_2757_106 sp__2757_192 0 2.72538e-16
Ctree_2757_107 sp__2757_192 0 1.24547e-16
Ctree_2757_108 sp__2757_158 0 4.77425e-17
Ctree_2757_109 sp__2757_16 0 1.24776e-16
Ctree_2757_110 sp__2757_16 0 1.24547e-16
Ctree_2757_111 sp__11292_CLK 0 1.10936e-16
Ctree_2757_112 sp__11292_CLK 0 2.08271e-16
Ctree_2757_113 sp__11293_CLK 0 7.30101e-17
Ctree_2757_115 sp__11875_CLK 0 5.69207e-16
Ctree_2757_116 sp__2757_162 0 3.32975e-16
Ctree_2757_117 sp__11782_CLK 0 2.08008e-16
Ctree_2757_118 sp__11782_CLK 0 3.05116e-16
Ctree_2757_119 sp__2757_75 0 1.24547e-16
Ctree_2757_121 sp__11780_CLK 0 7.98865e-17
Ctree_2757_122 sp__2757_162 0 1.76083e-16
Rtree_2758_1 sp__12065_X sp__2758_4 20
Rtree_2758_2 sp__2758_4 sp__2758_6 2.266
Rtree_2758_3 sp__2758_6 sp__2758_18 49.0022
Rtree_2758_4 sp__2758_18 sp__2758_24 24.9955
Rtree_2758_5 sp__2758_24 sp__2758_26 2.8222
Rtree_2758_6 sp__2758_26 sp__2758_30 25.7886
Rtree_2758_7 sp__2758_30 sp__11401_CLK 21.6171
Rtree_2758_8 sp__2758_30 sp__2758_39 2.4823
Rtree_2758_9 sp__2758_39 sp__11389_CLK 20
Rtree_2758_10 sp__2758_39 sp__2758_46 2.266
Rtree_2758_11 sp__2758_46 sp__11396_CLK 20
Rtree_2758_12 sp__2758_46 sp__2758_53 1.8334
Rtree_2758_13 sp__2758_53 sp__11390_CLK 20
Rtree_2758_14 sp__2758_53 sp__2758_60 2.266
Rtree_2758_15 sp__2758_60 sp__11400_CLK 20
Rtree_2758_16 sp__2758_60 sp__2758_67 1.8334
Rtree_2758_17 sp__2758_67 sp__11397_CLK 20
Rtree_2758_18 sp__2758_67 sp__2758_74 3.9964
Rtree_2758_19 sp__2758_74 sp__11399_CLK 20
Rtree_2758_20 sp__2758_74 sp__2758_81 2.266
Rtree_2758_21 sp__2758_81 sp__11413_CLK 20
Rtree_2758_22 sp__2758_81 sp__2758_88 0.9682
Rtree_2758_23 sp__2758_88 sp__2758_96 45.768
Rtree_2758_24 sp__2758_96 sp__11411_CLK 20
Rtree_2758_25 sp__2758_88 sp__2758_107 3.8316
Rtree_2758_26 sp__2758_107 sp__11410_CLK 20
Rtree_2758_27 sp__2758_107 sp__11489_CLK 21.8334
Rtree_2758_28 sp__2758_26 sp__11474_CLK 40.7519
Rtree_2758_29 sp__2758_24 sp__11402_CLK 48.6417
Rtree_2758_30 sp__2758_18 sp__11388_CLK 20
Rtree_2758_31 sp__2758_6 sp__12145_A 20
Rtree_2758_32 sp__2758_4 sp__2758_159 42.5338
Rtree_2758_33 sp__2758_159 sp__11412_CLK 20
Ctree_2758_4 sp__11402_CLK 0 6.75198e-16
Ctree_2758_5 sp__11474_CLK 0 8.43522e-17
Ctree_2758_6 sp__11489_CLK 0 1.7921e-16
Ctree_2758_16 sp__11401_CLK 0 1.46033e-16
Ctree_2758_18 sp__2758_159 0 2.17418e-16
Ctree_2758_19 sp__2758_107 0 5.95183e-16
Ctree_2758_20 sp__2758_96 0 6.50876e-16
Ctree_2758_21 sp__2758_88 0 1.14835e-15
Ctree_2758_22 sp__2758_81 0 2.88284e-16
Ctree_2758_23 sp__2758_74 0 5.70385e-16
Ctree_2758_24 sp__2758_67 0 5.29139e-16
Ctree_2758_25 sp__2758_60 0 3.58124e-16
Ctree_2758_26 sp__2758_53 0 3.63247e-16
Ctree_2758_27 sp__2758_46 0 3.7761e-16
Ctree_2758_28 sp__2758_39 0 4.51131e-16
Ctree_2758_29 sp__2758_30 0 7.8352e-16
Ctree_2758_30 sp__2758_26 0 6.76161e-16
Ctree_2758_31 sp__2758_24 0 1.38175e-15
Ctree_2758_32 sp__2758_18 0 1.29589e-15
Ctree_2758_33 sp__2758_6 0 9.86631e-16
Ctree_2758_34 sp__2758_4 0 4.16211e-16
Ctree_2758_37 sp__11402_CLK 0 1.0125e-15
Ctree_2758_39 sp__11402_CLK 0 4.78521e-17
Ctree_2758_42 sp__11402_CLK 0 2.09676e-16
Ctree_2758_47 sp__2758_6 0 1.94028e-16
Ctree_2758_48 sp__2758_6 0 4.78685e-17
Ctree_2758_49 sp__2758_6 0 2.74321e-16
Ctree_2758_50 sp__2758_18 0 8.03692e-17
Ctree_2758_52 sp__2758_18 0 9.80411e-16
Ctree_2758_54 sp__2758_18 0 4.33769e-16
Ctree_2758_56 sp__2758_26 0 5.88172e-16
Ctree_2758_58 sp__2758_30 0 5.00766e-16
Ctree_2758_59 sp__2758_30 0 7.68176e-16
Ctree_2758_74 sp__2758_81 0 1.45173e-16
Ctree_2758_77 sp__2758_88 0 1.29557e-16
Ctree_2758_84 sp__2758_159 0 2.73469e-16
Ctree_2758_85 sp__2758_159 0 1.28247e-16
Ctree_2758_86 sp__2758_159 0 7.99579e-17
Ctree_2758_88 sp__2758_96 0 1.44562e-16
Ctree_2758_89 sp__2758_96 0 7.9407e-17
Ctree_2758_94 sp__2758_30 0 2.88465e-16
Ctree_2758_97 sp__11402_CLK 0 3.40374e-16
Ctree_2758_98 sp__2758_18 0 3.40702e-16
Rtree_2759_1 sp__12066_X sp__2759_8 43.811
Rtree_2759_2 sp__2759_8 sp__2759_10 20
Rtree_2759_3 sp__2759_10 sp__11307_CLK 20
Rtree_2759_4 sp__2759_10 sp__2759_19 2.4308
Rtree_2759_5 sp__2759_19 sp__2759_23 22.6986
Rtree_2759_6 sp__2759_23 sp__2759_25 0.5974
Rtree_2759_7 sp__2759_25 sp__2759_31 24.7174
Rtree_2759_8 sp__2759_31 sp__11294_CLK 20.3502
Rtree_2759_9 sp__2759_31 sp__2759_40 2.266
Rtree_2759_10 sp__2759_40 sp__2759_44 21.339
Rtree_2759_11 sp__2759_44 sp__2759_46 5.5414
Rtree_2759_12 sp__2759_46 sp__2759_48 2.0806
Rtree_2759_13 sp__2759_48 sp__11291_CLK 43.4196
Rtree_2759_14 sp__2759_48 sp__11194_CLK 43.9964
Rtree_2759_15 sp__2759_46 sp__11183_CLK 40
Rtree_2759_16 sp__2759_44 sp__2759_81 22.1836
Rtree_2759_17 sp__2759_81 sp__2759_83 2.266
Rtree_2759_18 sp__2759_83 sp__2759_85 1.8334
Rtree_2759_19 sp__2759_85 sp__2759_89 22.266
Rtree_2759_20 sp__2759_89 sp__2759_91 1.5862
Rtree_2759_21 sp__2759_91 sp__11195_CLK 43.3166
Rtree_2759_22 sp__2759_91 sp__11196_CLK 41.902
Rtree_2759_23 sp__2759_89 sp__11197_CLK 42.0806
Rtree_2759_24 sp__2759_85 sp__11239_CLK 20
Rtree_2759_25 sp__2759_83 sp__11231_CLK 20.3502
Rtree_2759_26 sp__2759_81 sp__2759_134 20
Rtree_2759_27 sp__2759_134 sp__11184_CLK 42.0806
Rtree_2759_28 sp__2759_134 sp__2759_145 4.7998
Rtree_2759_29 sp__2759_145 sp__11186_CLK 40
Rtree_2759_30 sp__2759_145 sp__11187_CLK 44.5938
Rtree_2759_31 sp__2759_40 sp__11185_CLK 20
Rtree_2759_32 sp__2759_25 sp__11295_CLK 40.5356
Rtree_2759_33 sp__2759_23 sp__11297_CLK 44.223
Rtree_2759_34 sp__2759_19 sp__11296_CLK 20
Ctree_2759_2 sp__11297_CLK 0 5.25856e-16
Ctree_2759_3 sp__11295_CLK 0 3.8977e-17
Ctree_2759_5 sp__11187_CLK 0 4.23074e-16
Ctree_2759_7 sp__11184_CLK 0 1.62491e-16
Ctree_2759_8 sp__11231_CLK 0 2.53125e-17
Ctree_2759_10 sp__11197_CLK 0 2.30179e-16
Ctree_2759_11 sp__11196_CLK 0 2.27011e-16
Ctree_2759_12 sp__11195_CLK 0 4.85324e-16
Ctree_2759_14 sp__11194_CLK 0 3.71737e-16
Ctree_2759_15 sp__11291_CLK 0 3.71394e-16
Ctree_2759_16 sp__11294_CLK 0 3.29727e-17
Ctree_2759_18 sp__12066_X 0 3.13425e-16
Ctree_2759_19 sp__2759_145 0 9.15113e-16
Ctree_2759_20 sp__2759_134 0 6.5453e-16
Ctree_2759_21 sp__2759_91 0 9.02217e-16
Ctree_2759_22 sp__2759_89 0 6.38895e-16
Ctree_2759_23 sp__2759_85 0 3.94831e-16
Ctree_2759_24 sp__2759_83 0 4.2985e-16
Ctree_2759_25 sp__2759_81 0 4.13222e-16
Ctree_2759_26 sp__2759_48 0 9.74556e-16
Ctree_2759_27 sp__2759_46 0 6.99742e-16
Ctree_2759_28 sp__2759_44 0 7.2948e-16
Ctree_2759_29 sp__2759_40 0 2.74881e-16
Ctree_2759_30 sp__2759_31 0 8.48653e-16
Ctree_2759_31 sp__2759_25 0 7.34758e-16
Ctree_2759_32 sp__2759_23 0 8.54471e-16
Ctree_2759_33 sp__2759_19 0 4.84725e-16
Ctree_2759_34 sp__2759_10 0 2.34609e-16
Ctree_2759_35 sp__2759_8 0 3.13425e-16
Ctree_2759_36 sp__11184_CLK 0 4.38048e-16
Ctree_2759_37 sp__11184_CLK 0 1.80365e-16
Ctree_2759_38 sp__11187_CLK 0 4.40245e-16
Ctree_2759_41 sp__11194_CLK 0 2.7432e-16
Ctree_2759_43 sp__11194_CLK 0 5.97477e-16
Ctree_2759_49 sp__11196_CLK 0 3.86039e-17
Ctree_2759_51 sp__11197_CLK 0 4.12608e-16
Ctree_2759_52 sp__11291_CLK 0 2.09505e-16
Ctree_2759_53 sp__11291_CLK 0 1.54008e-17
Ctree_2759_54 sp__11291_CLK 0 3.32193e-16
Ctree_2759_57 sp__11295_CLK 0 8.00842e-17
Ctree_2759_59 sp__11297_CLK 0 2.08062e-16
Ctree_2759_62 sp__2759_8 0 3.82385e-16
Ctree_2759_63 sp__2759_8 0 7.9483e-16
Ctree_2759_64 sp__2759_19 0 2.72615e-16
Ctree_2759_66 sp__2759_23 0 4.02797e-16
Ctree_2759_69 sp__2759_31 0 3.30922e-16
Ctree_2759_70 sp__2759_40 0 3.05898e-16
Ctree_2759_72 sp__2759_44 0 2.79156e-16
Ctree_2759_73 sp__2759_44 0 2.57683e-16
Ctree_2759_74 sp__2759_46 0 4.66825e-16
Ctree_2759_76 sp__2759_46 0 5.40878e-16
Ctree_2759_77 sp__2759_46 0 3.87402e-16
Ctree_2759_78 sp__2759_46 0 2.79156e-16
Ctree_2759_79 sp__2759_48 0 4.12293e-16
Ctree_2759_81 sp__2759_81 0 2.72538e-16
Ctree_2759_82 sp__2759_81 0 2.07854e-16
Ctree_2759_83 sp__2759_83 0 3.22937e-16
Ctree_2759_86 sp__2759_85 0 1.4431e-16
Ctree_2759_87 sp__2759_85 0 2.08615e-16
Ctree_2759_88 sp__2759_89 0 1.12426e-16
Ctree_2759_90 sp__2759_89 0 3.38872e-16
Ctree_2759_92 sp__2759_91 0 1.27221e-16
Ctree_2759_93 sp__2759_145 0 1.00208e-15
Ctree_2759_94 sp__11187_CLK 0 3.39018e-16
Ctree_2759_97 sp__2759_40 0 2.73441e-16
Rtree_2760_1 sp__12067_X sp__2760_4 20
Rtree_2760_2 sp__2760_4 sp__2760_6 0.9682
Rtree_2760_3 sp__2760_6 sp__2760_10 24.4294
Rtree_2760_4 sp__2760_10 sp__2760_12 1.8334
Rtree_2760_5 sp__2760_12 sp__2760_26 43.5432
Rtree_2760_6 sp__2760_26 sp__2760_28 44.599
Rtree_2760_7 sp__2760_28 sp__12131_A 48.24
Rtree_2760_8 sp__2760_26 sp__2760_43 20.5974
Rtree_2760_9 sp__2760_43 sp__11299_CLK 20
Rtree_2760_10 sp__2760_43 sp__2760_50 2.266
Rtree_2760_11 sp__2760_50 sp__11298_CLK 20
Rtree_2760_12 sp__2760_50 sp__11303_CLK 23.4814
Rtree_2760_13 sp__2760_12 sp__2760_76 42.6986
Rtree_2760_14 sp__2760_76 sp__2760_78 1.8334
Rtree_2760_15 sp__2760_78 sp__11179_CLK 40.8446
Rtree_2760_16 sp__2760_78 sp__11188_CLK 41.8334
Rtree_2760_17 sp__2760_76 sp__2760_98 0.8446
Rtree_2760_18 sp__2760_98 sp__11180_CLK 44.3466
Rtree_2760_19 sp__2760_98 sp__2760_111 3.0694
Rtree_2760_20 sp__2760_111 sp__11181_CLK 46.077
Rtree_2760_21 sp__2760_111 sp__11301_CLK 40.5974
Rtree_2760_22 sp__2760_10 sp__11300_CLK 40.5356
Rtree_2760_23 sp__2760_6 sp__2760_142 1.4008
Rtree_2760_24 sp__2760_142 sp__11304_CLK 20
Rtree_2760_25 sp__2760_142 sp__2760_149 2.266
Rtree_2760_26 sp__2760_149 sp__11305_CLK 21.8334
Rtree_2760_27 sp__2760_149 sp__11306_CLK 20.3502
Rtree_2760_28 sp__2760_4 sp__2760_167 3.914
Rtree_2760_29 sp__2760_167 sp__2760_169 6.1594
Rtree_2760_30 sp__2760_169 sp__11178_CLK 22.1836
Rtree_2760_31 sp__2760_169 sp__11182_CLK 20
Rtree_2760_32 sp__2760_167 sp__11302_CLK 20
Ctree_2760_3 sp__11178_CLK 0 1.95003e-16
Ctree_2760_4 sp__11306_CLK 0 3.06411e-17
Ctree_2760_5 sp__11305_CLK 0 1.89876e-16
Ctree_2760_7 sp__11300_CLK 0 4.25262e-17
Ctree_2760_8 sp__11301_CLK 0 5.8778e-17
Ctree_2760_9 sp__11181_CLK 0 5.35338e-16
Ctree_2760_10 sp__11180_CLK 0 4.54191e-16
Ctree_2760_11 sp__11188_CLK 0 1.8652e-16
Ctree_2760_12 sp__11179_CLK 0 7.61e-17
Ctree_2760_13 sp__11303_CLK 0 2.95592e-16
Ctree_2760_16 sp__12131_A 0 9.71442e-16
Ctree_2760_18 sp__2760_169 0 7.62666e-16
Ctree_2760_19 sp__2760_167 0 9.782e-16
Ctree_2760_20 sp__2760_149 0 4.52786e-16
Ctree_2760_21 sp__2760_142 0 3.61884e-16
Ctree_2760_22 sp__2760_111 0 8.31749e-16
Ctree_2760_23 sp__2760_98 0 7.71318e-16
Ctree_2760_24 sp__2760_78 0 4.14431e-16
Ctree_2760_25 sp__2760_76 0 4.65826e-16
Ctree_2760_26 sp__2760_50 0 5.54538e-16
Ctree_2760_27 sp__2760_43 0 2.86847e-16
Ctree_2760_28 sp__2760_28 0 5.91023e-15
Ctree_2760_29 sp__2760_26 0 5.25121e-15
Ctree_2760_30 sp__2760_12 0 7.61384e-16
Ctree_2760_31 sp__2760_10 0 9.17737e-16
Ctree_2760_32 sp__2760_6 0 8.46647e-16
Ctree_2760_33 sp__2760_4 0 4.94705e-16
Ctree_2760_34 sp__11178_CLK sp__2762_152 2.74397e-16
Ctree_2760_37 sp__11179_CLK 0 1.78734e-16
Ctree_2760_38 sp__11180_CLK 0 1.54008e-17
Ctree_2760_40 sp__11180_CLK 0 1.76187e-16
Ctree_2760_42 sp__11181_CLK 0 8.55703e-16
Ctree_2760_45 sp__11181_CLK 0 2.72747e-16
Ctree_2760_46 sp__11301_CLK 0 1.24547e-16
Ctree_2760_48 sp__11303_CLK 0 2.08571e-16
Ctree_2760_56 sp__12131_A 0 3.37982e-16
Ctree_2760_60 sp__2760_26 0 2.87093e-16
Ctree_2760_61 sp__2760_26 0 1.4388e-16
Ctree_2760_65 sp__2760_28 0 5.96273e-16
Ctree_2760_66 sp__2760_28 0 9.01634e-16
Ctree_2760_69 sp__2760_28 0 1.24547e-16
Ctree_2760_72 sp__2760_28 0 1.78877e-15
Ctree_2760_76 sp__2760_43 0 1.26149e-16
Ctree_2760_80 sp__2760_76 0 3.36888e-16
Ctree_2760_82 sp__2760_76 0 4.01406e-16
Ctree_2760_84 sp__2760_78 0 3.7e-16
Ctree_2760_86 sp__2760_98 0 1.55658e-16
Ctree_2760_87 sp__2760_111 0 5.95176e-16
Ctree_2760_89 sp__2760_111 0 3.63751e-16
Ctree_2760_96 sp__2760_167 0 4.52211e-16
Ctree_2760_97 sp__2760_169 0 8.00842e-17
Ctree_2760_98 sp__2760_169 sp__2762_152 5.33952e-16
Ctree_2760_99 sp__2760_169 0 2.42149e-16
Ctree_2760_107 sp__11300_CLK 0 8.0216e-17
Ctree_2760_108 sp__11180_CLK 0 4.02037e-16
Ctree_2760_109 sp__11300_CLK 0 8.0216e-17
Ctree_2760_112 sp__2760_6 0 1.45031e-16
Ctree_2760_114 sp__2760_142 0 1.61763e-16
Ctree_2760_116 sp__2760_28 0 8.5366e-16
Ctree_2760_119 sp__2760_28 0 1.24547e-16
Rtree_2761_1 sp__12068_X sp__2761_8 23.6977
Rtree_2761_2 sp__2761_8 sp__2761_10 2.266
Rtree_2761_3 sp__2761_10 sp__11217_CLK 23.0282
Rtree_2761_4 sp__2761_10 sp__11202_CLK 20
Rtree_2761_5 sp__2761_8 sp__11201_CLK 20
Rtree_2761_6 sp__12068_X sp__2761_40 41.6171
Rtree_2761_7 sp__2761_40 sp__2761_42 2.0806
Rtree_2761_8 sp__2761_42 sp__2761_44 0.8446
Rtree_2761_9 sp__2761_44 sp__2761_46 1.8334
Rtree_2761_10 sp__2761_46 sp__2761_48 1.339
Rtree_2761_11 sp__2761_48 sp__2761_50 2.3278
Rtree_2761_12 sp__2761_50 sp__2761_56 21.7175
Rtree_2761_13 sp__2761_56 sp__11198_CLK 20
Rtree_2761_14 sp__2761_56 sp__2761_65 0.857475
Rtree_2761_15 sp__2761_65 sp__2761_69 4.7792
Rtree_2761_16 sp__2761_69 sp__11160_CLK 22.4308
Rtree_2761_17 sp__2761_69 sp__2761_82 23.811
Rtree_2761_18 sp__2761_82 sp__11167_CLK 43.3578
Rtree_2761_19 sp__2761_82 sp__11159_CLK 40
Rtree_2761_20 sp__2761_65 sp__11168_CLK 21.8334
Rtree_2761_21 sp__2761_50 sp__11169_CLK 46.1594
Rtree_2761_22 sp__2761_48 sp__2761_122 22.1836
Rtree_2761_23 sp__2761_122 sp__2761_130 43.3578
Rtree_2761_24 sp__2761_130 sp__11161_CLK 20
Rtree_2761_25 sp__2761_122 sp__11199_CLK 20
Rtree_2761_26 sp__2761_46 sp__11170_CLK 43.9964
Rtree_2761_27 sp__2761_44 sp__11200_CLK 40
Rtree_2761_28 sp__2761_42 sp__11171_CLK 42.266
Rtree_2761_29 sp__2761_40 sp__2761_167 2.3278
Rtree_2761_30 sp__2761_167 sp__11172_CLK 43.9681
Rtree_2761_31 sp__2761_167 sp__2761_180 22.8222
Rtree_2761_32 sp__2761_180 sp__11176_CLK 21.8334
Rtree_2761_33 sp__2761_180 sp__11177_CLK 20
Ctree_2761_2 sp__11176_CLK 0 1.59257e-16
Ctree_2761_3 sp__11172_CLK 0 3.25506e-16
Ctree_2761_4 sp__11171_CLK 0 2.34016e-16
Ctree_2761_6 sp__11170_CLK 0 3.90268e-16
Ctree_2761_9 sp__11169_CLK 0 7.62763e-16
Ctree_2761_10 sp__11168_CLK 0 2.27132e-16
Ctree_2761_12 sp__11167_CLK 0 3.00827e-16
Ctree_2761_13 sp__11160_CLK 0 2.44873e-16
Ctree_2761_17 sp__11217_CLK 0 2.89815e-16
Ctree_2761_18 sp__12068_X 0 5.68132e-16
Ctree_2761_19 sp__2761_180 0 3.78755e-16
Ctree_2761_20 sp__2761_167 0 7.84978e-16
Ctree_2761_21 sp__2761_130 0 2.48928e-16
Ctree_2761_22 sp__2761_122 0 5.01843e-16
Ctree_2761_23 sp__2761_82 0 6.07272e-16
Ctree_2761_24 sp__2761_69 0 1.04117e-15
Ctree_2761_25 sp__2761_65 0 7.71153e-16
Ctree_2761_26 sp__2761_56 0 2.15454e-16
Ctree_2761_27 sp__2761_50 0 1.08504e-15
Ctree_2761_28 sp__2761_48 0 4.94362e-16
Ctree_2761_29 sp__2761_46 0 5.51963e-16
Ctree_2761_30 sp__2761_44 0 1.11991e-16
Ctree_2761_31 sp__2761_42 0 4.61627e-16
Ctree_2761_32 sp__2761_40 0 6.01402e-16
Ctree_2761_33 sp__2761_10 0 4.96525e-16
Ctree_2761_34 sp__2761_8 0 6.10269e-16
Ctree_2761_35 sp__11160_CLK 0 1.54008e-17
Ctree_2761_38 sp__11167_CLK 0 2.30271e-16
Ctree_2761_39 sp__11167_CLK 0 3.3754e-16
Ctree_2761_40 sp__11167_CLK 0 2.30424e-16
Ctree_2761_43 sp__11169_CLK 0 2.08063e-16
Ctree_2761_48 sp__11170_CLK 0 1.43908e-16
Ctree_2761_49 sp__11170_CLK 0 5.94043e-16
Ctree_2761_50 sp__11170_CLK 0 1.02862e-16
Ctree_2761_51 sp__11171_CLK 0 4.77425e-17
Ctree_2761_53 sp__11172_CLK 0 5.32559e-16
Ctree_2761_55 sp__11172_CLK 0 5.93036e-16
Ctree_2761_56 sp__11176_CLK sp__2762_152 2.7466e-16
Ctree_2761_67 sp__2761_42 0 7.48842e-17
Ctree_2761_69 sp__2761_42 0 1.58304e-16
Ctree_2761_71 sp__2761_44 0 1.82517e-16
Ctree_2761_72 sp__2761_44 0 1.61027e-16
Ctree_2761_73 sp__2761_46 0 3.91039e-16
Ctree_2761_74 sp__2761_46 0 3.70454e-16
Ctree_2761_75 sp__2761_48 0 1.26146e-16
Ctree_2761_76 sp__2761_48 0 2.64468e-16
Ctree_2761_77 sp__2761_50 0 4.7305e-16
Ctree_2761_78 sp__2761_50 0 2.33463e-16
Ctree_2761_79 sp__2761_56 0 1.9636e-17
Ctree_2761_81 sp__2761_56 0 3.35365e-16
Ctree_2761_82 sp__2761_65 0 7.59807e-17
Ctree_2761_83 sp__2761_69 0 2.25765e-16
Ctree_2761_87 sp__2761_82 0 2.31079e-16
Ctree_2761_88 sp__2761_82 0 7.89638e-16
Ctree_2761_89 sp__2761_122 0 1.54008e-17
Ctree_2761_91 sp__2761_130 0 2.33463e-16
Ctree_2761_93 sp__2761_130 0 2.33544e-16
Ctree_2761_96 sp__2761_167 0 1.2526e-16
Ctree_2761_98 sp__2761_180 0 5.99103e-16
Ctree_2761_100 sp__2761_40 0 2.3994e-16
Ctree_2761_102 sp__2761_130 0 3.37221e-16
Ctree_2761_109 sp__2761_130 0 2.40306e-16
Ctree_2761_112 sp__2761_167 0 1.76396e-16
Ctree_2761_115 sp__2761_69 0 1.77147e-16
Rtree_2762_1 sp__12069_X sp__2762_8 41.8334
Rtree_2762_2 sp__2762_8 sp__2762_12 22.8222
Rtree_2762_3 sp__2762_12 sp__11220_CLK 20.7519
Rtree_2762_4 sp__2762_12 sp__2762_21 7.2409
Rtree_2762_5 sp__2762_21 sp__11208_CLK 20
Rtree_2762_6 sp__2762_21 sp__2762_30 22.266
Rtree_2762_7 sp__2762_30 sp__2762_34 23.5638
Rtree_2762_8 sp__2762_34 sp__2762_36 0.5974
Rtree_2762_9 sp__2762_36 sp__11219_CLK 20.3502
Rtree_2762_10 sp__2762_36 sp__2762_45 2.266
Rtree_2762_11 sp__2762_45 sp__2762_49 22.0806
Rtree_2762_12 sp__2762_49 sp__11218_CLK 41.5862
Rtree_2762_13 sp__2762_49 sp__2762_62 23.53
Rtree_2762_14 sp__2762_62 sp__11229_CLK 24.841
Rtree_2762_15 sp__2762_62 sp__11237_CLK 20
Rtree_2762_16 sp__2762_45 sp__12126_A 20
Rtree_2762_17 sp__2762_45 sp__11238_CLK 22.781
Rtree_2762_18 sp__2762_34 sp__11207_CLK 21.8334
Rtree_2762_19 sp__2762_30 sp__2762_103 22.8222
Rtree_2762_20 sp__2762_103 sp__11204_CLK 20
Rtree_2762_21 sp__2762_103 sp__2762_112 2.4308
Rtree_2762_22 sp__2762_112 sp__11203_CLK 20
Rtree_2762_23 sp__2762_112 sp__2762_121 2.8634
Rtree_2762_24 sp__2762_121 sp__11173_CLK 20
Rtree_2762_25 sp__2762_121 sp__2762_128 1.8334
Rtree_2762_26 sp__2762_128 sp__11174_CLK 20
Rtree_2762_27 sp__2762_128 sp__2762_135 2.266
Rtree_2762_28 sp__2762_135 sp__11175_CLK 20
Rtree_2762_29 sp__2762_135 sp__2762_152 44.4342
Rtree_2762_30 sp__2762_152 sp__11209_CLK 20
Rtree_2762_31 sp__2762_8 sp__2762_161 21.6171
Rtree_2762_32 sp__2762_161 sp__11206_CLK 20
Rtree_2762_33 sp__2762_161 sp__11205_CLK 20.6366
Ctree_2762_1 sp__11205_CLK 0 1.79407e-16
Ctree_2762_9 sp__11207_CLK 0 1.67302e-16
Ctree_2762_10 sp__11238_CLK 0 2.48816e-16
Ctree_2762_13 sp__11229_CLK 0 4.72351e-16
Ctree_2762_14 sp__11218_CLK 0 7.12467e-17
Ctree_2762_15 sp__11219_CLK 0 2.68908e-17
Ctree_2762_17 sp__11220_CLK 0 6.29879e-17
Ctree_2762_18 sp__12069_X 0 1.7578e-16
Ctree_2762_19 sp__2762_161 0 3.27644e-16
Ctree_2762_20 sp__2762_152 0 4.12605e-15
Ctree_2762_21 sp__2762_135 0 4.32227e-15
Ctree_2762_22 sp__2762_128 0 3.78713e-16
Ctree_2762_23 sp__2762_121 0 4.41075e-16
Ctree_2762_24 sp__2762_112 0 4.83037e-16
Ctree_2762_25 sp__2762_103 0 4.95607e-16
Ctree_2762_26 sp__2762_62 0 9.25067e-16
Ctree_2762_27 sp__2762_49 0 6.1443e-16
Ctree_2762_28 sp__2762_45 0 5.59701e-16
Ctree_2762_29 sp__2762_36 0 2.82308e-16
Ctree_2762_30 sp__2762_34 0 5.91866e-16
Ctree_2762_31 sp__2762_30 0 9.07995e-16
Ctree_2762_32 sp__2762_21 0 9.82955e-16
Ctree_2762_33 sp__2762_12 0 1.02653e-15
Ctree_2762_34 sp__2762_8 0 5.51877e-16
Ctree_2762_37 sp__11207_CLK 0 2.723e-16
Ctree_2762_38 sp__11218_CLK 0 2.34459e-16
Ctree_2762_39 sp__11218_CLK 0 1.27744e-16
Ctree_2762_40 sp__11218_CLK 0 3.40178e-16
Ctree_2762_43 sp__11238_CLK 0 1.53311e-17
Ctree_2762_50 sp__2762_21 0 1.12358e-16
Ctree_2762_52 sp__2762_21 0 4.35239e-16
Ctree_2762_61 sp__2762_49 0 4.29378e-16
Ctree_2762_62 sp__2762_49 0 3.43849e-16
Ctree_2762_75 sp__2762_152 0 8.00842e-17
Ctree_2762_76 sp__2762_152 0 5.00271e-16
Ctree_2762_77 sp__2762_152 0 1.66502e-15
Ctree_2762_78 sp__2762_152 0 1.21767e-15
Ctree_2762_80 sp__2762_152 0 1.98898e-15
Ctree_2762_83 sp__2762_152 0 5.30951e-16
Ctree_2762_89 sp__2762_152 0 6.62755e-16
Rtree_2763_1 sp__12070_X sp__2763_8 43.1312
Rtree_2763_2 sp__2763_8 sp__2763_10 14.935
Rtree_2763_3 sp__2763_10 sp__2763_12 1.339
Rtree_2763_4 sp__2763_12 sp__2763_16 2.1218
Rtree_2763_5 sp__2763_16 sp__2763_18 0.5974
Rtree_2763_6 sp__2763_18 sp__2763_22 24.0582
Rtree_2763_7 sp__2763_22 sp__11241_CLK 22.678
Rtree_2763_8 sp__2763_22 sp__2763_35 1.877
Rtree_2763_9 sp__2763_35 sp__2763_37 1.6171
Rtree_2763_10 sp__2763_37 sp__2763_45 41.9055
Rtree_2763_11 sp__2763_45 sp__11226_CLK 20
Rtree_2763_12 sp__2763_37 sp__2763_52 4.2127
Rtree_2763_13 sp__2763_52 sp__11212_CLK 20
Rtree_2763_14 sp__2763_52 sp__2763_63 25.5826
Rtree_2763_15 sp__2763_63 sp__2763_65 1.5862
Rtree_2763_16 sp__2763_65 sp__2763_67 1.5862
Rtree_2763_17 sp__2763_67 sp__2763_69 62.3974
Rtree_2763_18 sp__2763_69 sp__12127_A 41.8334
Rtree_2763_19 sp__2763_67 sp__11157_CLK 42.266
Rtree_2763_20 sp__2763_65 sp__11158_CLK 40
Rtree_2763_21 sp__2763_63 sp__11257_CLK 41.8334
Rtree_2763_22 sp__2763_35 sp__11225_CLK 20.3502
Rtree_2763_23 sp__2763_18 sp__11236_CLK 44.3466
Rtree_2763_24 sp__2763_16 sp__11235_CLK 40
Rtree_2763_25 sp__2763_12 sp__2763_130 20
Rtree_2763_26 sp__2763_130 sp__2763_134 6.077
Rtree_2763_27 sp__2763_134 sp__2763_142 5.01867
Rtree_2763_28 sp__2763_142 sp__11213_CLK 20
Rtree_2763_29 sp__2763_142 sp__11214_CLK 23.1595
Rtree_2763_30 sp__2763_134 sp__11216_CLK 20
Rtree_2763_31 sp__2763_130 sp__11227_CLK 22.266
Rtree_2763_32 sp__2763_10 sp__2763_176 21.8334
Rtree_2763_33 sp__2763_176 sp__11215_CLK 26.077
Rtree_2763_34 sp__2763_176 sp__11228_CLK 20
Ctree_2763_2 sp__11215_CLK 0 5.66549e-16
Ctree_2763_3 sp__11227_CLK 0 1.91108e-16
Ctree_2763_5 sp__11214_CLK 0 2.87202e-16
Ctree_2763_8 sp__11236_CLK 0 3.64476e-16
Ctree_2763_9 sp__11225_CLK 0 2.77263e-17
Ctree_2763_10 sp__11257_CLK 0 1.53029e-16
Ctree_2763_12 sp__11157_CLK 0 2.13732e-16
Ctree_2763_13 sp__12127_A 0 1.53705e-16
Ctree_2763_16 sp__11241_CLK 0 2.73449e-16
Ctree_2763_17 sp__12070_X 0 3.26066e-16
Ctree_2763_18 sp__2763_176 0 7.18987e-16
Ctree_2763_19 sp__2763_142 0 8.11872e-16
Ctree_2763_20 sp__2763_134 0 1.06174e-15
Ctree_2763_21 sp__2763_130 0 7.2818e-16
Ctree_2763_22 sp__2763_69 0 6.03696e-15
Ctree_2763_23 sp__2763_67 0 6.24143e-15
Ctree_2763_24 sp__2763_65 0 3.50357e-16
Ctree_2763_25 sp__2763_63 0 1.03082e-15
Ctree_2763_26 sp__2763_52 0 1.15017e-15
Ctree_2763_27 sp__2763_45 0 2.38105e-16
Ctree_2763_28 sp__2763_37 0 8.99668e-16
Ctree_2763_29 sp__2763_35 0 4.95964e-16
Ctree_2763_30 sp__2763_22 0 8.62835e-16
Ctree_2763_31 sp__2763_18 0 7.08396e-16
Ctree_2763_32 sp__2763_16 0 1.71102e-16
Ctree_2763_33 sp__2763_12 0 1.80157e-16
Ctree_2763_34 sp__2763_10 0 1.49856e-15
Ctree_2763_35 sp__2763_8 0 1.62363e-15
Ctree_2763_37 sp__11157_CLK 0 3.06701e-16
Ctree_2763_44 sp__11236_CLK 0 2.73299e-16
Ctree_2763_48 sp__11257_CLK 0 2.7331e-16
Ctree_2763_49 sp__11257_CLK 0 2.7331e-16
Ctree_2763_51 sp__12127_A 0 2.72731e-16
Ctree_2763_52 sp__12127_A 0 2.40313e-16
Ctree_2763_55 sp__2763_10 0 7.20524e-16
Ctree_2763_58 sp__2763_10 0 1.50049e-15
Ctree_2763_60 sp__2763_10 0 6.64168e-16
Ctree_2763_62 sp__2763_12 0 2.70366e-16
Ctree_2763_63 sp__2763_12 0 2.92275e-16
Ctree_2763_64 sp__2763_16 0 1.30344e-16
Ctree_2763_65 sp__2763_16 0 3.46605e-16
Ctree_2763_66 sp__2763_18 0 1.07921e-16
Ctree_2763_67 sp__2763_22 0 8.83982e-16
Ctree_2763_75 sp__2763_45 0 1.54556e-17
Ctree_2763_87 sp__2763_67 0 2.85836e-16
Ctree_2763_90 sp__2763_69 sp__11736_CLK 6.06728e-16
Ctree_2763_91 sp__2763_69 sp__11737_CLK 5.32085e-16
Ctree_2763_92 sp__2763_69 sp__2771_59 3.2018e-16
Ctree_2763_93 sp__2763_69 0 5.54077e-16
Ctree_2763_94 sp__2763_69 0 2.31735e-16
Ctree_2763_95 sp__2763_69 0 7.48178e-17
Ctree_2763_96 sp__2763_69 0 7.33225e-17
Ctree_2763_97 sp__2763_69 0 7.58987e-16
Ctree_2763_98 sp__2763_69 0 7.6712e-16
Ctree_2763_99 sp__2763_69 0 5.53661e-16
Ctree_2763_100 sp__2763_69 0 7.61457e-16
Ctree_2763_112 sp__2763_134 0 2.41701e-16
Ctree_2763_121 sp__2763_69 0 1.24456e-15
Rtree_2764_1 sp__12071_X sp__2764_6 40
Rtree_2764_2 sp__2764_6 sp__2764_12 35.8414
Rtree_2764_3 sp__2764_12 sp__11245_CLK 20
Rtree_2764_4 sp__2764_12 sp__2764_23 23.1106
Rtree_2764_5 sp__2764_23 sp__2764_25 1.8334
Rtree_2764_6 sp__2764_25 sp__2764_27 1.0918
Rtree_2764_7 sp__2764_27 sp__2764_29 1.5862
Rtree_2764_8 sp__2764_29 sp__2764_31 2.8222
Rtree_2764_9 sp__2764_31 sp__2764_33 1.5862
Rtree_2764_10 sp__2764_33 sp__2764_35 1.0918
Rtree_2764_11 sp__2764_35 sp__2764_37 1.5862
Rtree_2764_12 sp__2764_37 sp__11248_CLK 47.004
Rtree_2764_13 sp__2764_37 sp__11247_CLK 40.5356
Rtree_2764_14 sp__2764_35 sp__11249_CLK 42.266
Rtree_2764_15 sp__2764_33 sp__11222_CLK 41.8334
Rtree_2764_16 sp__2764_31 sp__2764_77 20
Rtree_2764_17 sp__2764_77 sp__11255_CLK 23.5638
Rtree_2764_18 sp__2764_77 sp__11243_CLK 24.7792
Rtree_2764_19 sp__2764_29 sp__11242_CLK 40.5356
Rtree_2764_20 sp__2764_27 sp__11244_CLK 42.266
Rtree_2764_21 sp__2764_25 sp__2764_115 21.8334
Rtree_2764_22 sp__2764_115 sp__2764_117 5.7268
Rtree_2764_23 sp__2764_117 sp__11210_CLK 20
Rtree_2764_24 sp__2764_117 sp__2764_128 23.8522
Rtree_2764_25 sp__2764_128 sp__2764_130 56.7118
Rtree_2764_26 sp__2764_130 sp__12128_A 40
Rtree_2764_27 sp__2764_128 sp__11256_CLK 40
Rtree_2764_28 sp__2764_115 sp__2764_146 0.3502
Rtree_2764_29 sp__2764_146 sp__11224_CLK 20
Rtree_2764_30 sp__2764_146 sp__2764_159 3.3784
Rtree_2764_31 sp__2764_159 sp__11223_CLK 20
Rtree_2764_32 sp__2764_159 sp__11211_CLK 23.605
Rtree_2764_33 sp__2764_23 sp__11240_CLK 44.429
Ctree_2764_1 sp__11240_CLK 0 4.51179e-16
Ctree_2764_2 sp__11211_CLK 0 3.5345e-16
Ctree_2764_8 sp__11244_CLK 0 2.58418e-16
Ctree_2764_9 sp__11242_CLK 0 5.77802e-17
Ctree_2764_10 sp__11243_CLK 0 4.69015e-16
Ctree_2764_11 sp__11255_CLK 0 3.67046e-16
Ctree_2764_12 sp__11222_CLK 0 1.77183e-16
Ctree_2764_13 sp__11249_CLK 0 2.51589e-16
Ctree_2764_14 sp__11247_CLK 0 5.06963e-17
Ctree_2764_15 sp__11248_CLK 0 6.1138e-16
Ctree_2764_18 sp__2764_159 0 6.7962e-16
Ctree_2764_19 sp__2764_146 0 3.53897e-16
Ctree_2764_20 sp__2764_130 0 4.67588e-15
Ctree_2764_21 sp__2764_128 0 4.93363e-15
Ctree_2764_22 sp__2764_117 0 7.24749e-16
Ctree_2764_23 sp__2764_115 0 6.75967e-16
Ctree_2764_24 sp__2764_77 0 8.36061e-16
Ctree_2764_25 sp__2764_37 0 7.651e-16
Ctree_2764_26 sp__2764_35 0 4.23626e-16
Ctree_2764_27 sp__2764_33 0 3.43424e-16
Ctree_2764_28 sp__2764_31 0 2.89628e-16
Ctree_2764_29 sp__2764_29 0 3.83902e-16
Ctree_2764_30 sp__2764_27 0 4.88198e-16
Ctree_2764_31 sp__2764_25 0 4.36022e-16
Ctree_2764_32 sp__2764_23 0 8.85643e-16
Ctree_2764_33 sp__2764_12 0 1.89847e-15
Ctree_2764_34 sp__2764_6 0 1.62273e-15
Ctree_2764_42 sp__11243_CLK 0 1.11971e-16
Ctree_2764_50 sp__11247_CLK 0 7.97939e-17
Ctree_2764_56 sp__11248_CLK 0 1.11762e-16
Ctree_2764_57 sp__11248_CLK 0 6.4484e-17
Ctree_2764_58 sp__11248_CLK 0 5.62684e-16
Ctree_2764_68 sp__2764_12 0 6.10676e-16
Ctree_2764_69 sp__2764_12 0 1.46075e-15
Ctree_2764_71 sp__2764_23 0 5.60315e-16
Ctree_2764_73 sp__2764_25 0 3.96057e-16
Ctree_2764_75 sp__2764_27 0 2.34936e-16
Ctree_2764_78 sp__2764_29 0 3.40416e-16
Ctree_2764_81 sp__2764_31 0 6.16167e-16
Ctree_2764_84 sp__2764_33 0 3.46423e-16
Ctree_2764_86 sp__2764_35 0 2.37686e-16
Ctree_2764_88 sp__2764_37 0 3.46091e-16
Ctree_2764_89 sp__2764_117 0 7.88065e-16
Ctree_2764_90 sp__2764_128 0 3.13179e-16
Ctree_2764_91 sp__2764_128 0 3.38305e-16
Ctree_2764_92 sp__2764_128 0 3.34808e-16
Ctree_2764_93 sp__2764_130 0 4.40984e-16
Ctree_2764_95 sp__2764_130 0 3.9332e-16
Ctree_2764_96 sp__2764_130 0 3.40288e-16
Ctree_2764_97 sp__2764_130 0 1.79542e-16
Ctree_2764_100 sp__2764_130 0 6.03612e-16
Ctree_2764_104 sp__2764_130 0 1.02112e-14
Ctree_2764_112 sp__2764_159 0 1.54008e-17
Rtree_2765_1 sp__12072_X sp__2765_6 33.081
Rtree_2765_2 sp__2765_6 sp__2765_14 41.6274
Rtree_2765_3 sp__2765_14 sp__11163_CLK 20
Rtree_2765_4 sp__2765_14 sp__2765_25 22.6162
Rtree_2765_5 sp__2765_25 sp__2765_27 3.5638
Rtree_2765_6 sp__2765_27 sp__2765_31 21.339
Rtree_2765_7 sp__2765_31 sp__11162_CLK 20
Rtree_2765_8 sp__2765_31 sp__2765_44 44.5938
Rtree_2765_9 sp__2765_44 sp__11152_CLK 20
Rtree_2765_10 sp__2765_27 sp__2765_53 21.8334
Rtree_2765_11 sp__2765_53 sp__11285_CLK 20
Rtree_2765_12 sp__2765_53 sp__2765_62 2.6162
Rtree_2765_13 sp__2765_62 sp__2765_66 23.9964
Rtree_2765_14 sp__2765_66 sp__2765_68 4.0582
Rtree_2765_15 sp__2765_68 sp__2765_72 20.8446
Rtree_2765_16 sp__2765_72 sp__2765_76 7.404
Rtree_2765_17 sp__2765_76 sp__2765_80 3.4196
Rtree_2765_18 sp__2765_80 sp__11250_CLK 20
Rtree_2765_19 sp__2765_80 sp__2765_89 4.43157
Rtree_2765_20 sp__2765_89 sp__11251_CLK 20
Rtree_2765_21 sp__2765_89 sp__11252_CLK 22.799
Rtree_2765_22 sp__2765_76 sp__11276_CLK 20
Rtree_2765_23 sp__2765_72 sp__11284_CLK 20
Rtree_2765_24 sp__2765_68 sp__11262_CLK 42.266
Rtree_2765_25 sp__2765_66 sp__2765_128 1.0918
Rtree_2765_26 sp__2765_128 sp__11253_CLK 41.8334
Rtree_2765_27 sp__2765_128 sp__2765_141 22.0806
Rtree_2765_28 sp__2765_141 sp__11254_CLK 20
Rtree_2765_29 sp__2765_141 sp__11287_CLK 22.6162
Rtree_2765_30 sp__2765_62 sp__11263_CLK 20
Rtree_2765_31 sp__2765_25 sp__2765_162 2.0806
Rtree_2765_32 sp__2765_162 sp__11155_CLK 40
Rtree_2765_33 sp__2765_162 sp__2765_171 1.339
Rtree_2765_34 sp__2765_171 sp__11286_CLK 41.8334
Rtree_2765_35 sp__2765_171 sp__11230_CLK 45.5826
Ctree_2765_1 sp__11230_CLK 0 4.14045e-16
Ctree_2765_2 sp__11286_CLK 0 1.47215e-16
Ctree_2765_5 sp__11287_CLK 0 3.14855e-16
Ctree_2765_7 sp__11253_CLK 0 2.03056e-16
Ctree_2765_8 sp__11262_CLK 0 2.61124e-16
Ctree_2765_11 sp__11252_CLK 0 2.59288e-16
Ctree_2765_18 sp__12072_X 0 1.2688e-15
Ctree_2765_19 sp__2765_171 0 6.24997e-16
Ctree_2765_20 sp__2765_162 0 1.59276e-16
Ctree_2765_21 sp__2765_141 0 5.04606e-16
Ctree_2765_22 sp__2765_128 0 5.35234e-16
Ctree_2765_23 sp__2765_89 0 6.65388e-16
Ctree_2765_24 sp__2765_80 0 6.74258e-16
Ctree_2765_25 sp__2765_76 0 1.0595e-15
Ctree_2765_26 sp__2765_72 0 8.82206e-16
Ctree_2765_27 sp__2765_68 0 8.4833e-16
Ctree_2765_28 sp__2765_66 0 1.01922e-15
Ctree_2765_29 sp__2765_62 0 6.23112e-16
Ctree_2765_30 sp__2765_53 0 4.25464e-16
Ctree_2765_31 sp__2765_44 0 3.80257e-16
Ctree_2765_32 sp__2765_31 0 5.01252e-16
Ctree_2765_33 sp__2765_27 0 5.86813e-16
Ctree_2765_34 sp__2765_25 0 6.82099e-16
Ctree_2765_35 sp__2765_14 0 4.17334e-16
Ctree_2765_36 sp__2765_6 0 1.38259e-15
Ctree_2765_37 sp__11230_CLK 0 5.97962e-16
Ctree_2765_38 sp__11230_CLK 0 3.38485e-16
Ctree_2765_39 sp__11230_CLK 0 1.54008e-17
Ctree_2765_40 sp__11230_CLK 0 4.36172e-16
Ctree_2765_43 sp__11253_CLK 0 1.54008e-17
Ctree_2765_45 sp__11253_CLK 0 4.78356e-17
Ctree_2765_49 sp__11286_CLK 0 2.7432e-16
Ctree_2765_50 sp__11286_CLK 0 2.7432e-16
Ctree_2765_53 sp__2765_6 0 1.9529e-15
Ctree_2765_56 sp__2765_6 0 3.70675e-16
Ctree_2765_58 sp__2765_14 0 2.29534e-16
Ctree_2765_59 sp__2765_25 0 1.54008e-17
Ctree_2765_62 sp__2765_27 0 5.9469e-16
Ctree_2765_63 sp__2765_27 0 7.33225e-17
Ctree_2765_66 sp__2765_31 0 2.82222e-16
Ctree_2765_67 sp__2765_44 0 3.3743e-16
Ctree_2765_69 sp__2765_44 0 3.37474e-16
Ctree_2765_73 sp__2765_62 0 9.71568e-17
Ctree_2765_76 sp__2765_66 0 5.97311e-16
Ctree_2765_81 sp__2765_76 0 3.37476e-16
Ctree_2765_93 sp__2765_141 0 3.97607e-16
Ctree_2765_95 sp__2765_162 0 4.41629e-16
Ctree_2765_96 sp__2765_171 0 2.83615e-16
Ctree_2765_97 sp__11230_CLK 0 3.17011e-16
Ctree_2765_98 sp__2765_27 0 2.30923e-16
Ctree_2765_99 sp__2765_162 0 4.21043e-16
Ctree_2765_100 sp__2765_171 0 2.61519e-16
Rtree_2766_1 sp__12073_X sp__2766_10 42.4617
Rtree_2766_2 sp__2766_10 sp__2766_14 24.6453
Rtree_2766_3 sp__2766_14 sp__2766_20 24.3466
Rtree_2766_4 sp__2766_20 sp__2766_22 3.811
Rtree_2766_5 sp__2766_22 sp__2766_28 30.5266
Rtree_2766_6 sp__2766_28 sp__12129_A 20
Rtree_2766_7 sp__2766_22 sp__2766_37 20.5356
Rtree_2766_8 sp__2766_37 sp__11288_CLK 20
Rtree_2766_9 sp__2766_37 sp__2766_46 2.6162
Rtree_2766_10 sp__2766_46 sp__11164_CLK 20
Rtree_2766_11 sp__2766_46 sp__2766_53 1.8334
Rtree_2766_12 sp__2766_53 sp__2766_57 22.0806
Rtree_2766_13 sp__2766_57 sp__2766_63 25.3354
Rtree_2766_14 sp__2766_63 sp__2766_67 23.5638
Rtree_2766_15 sp__2766_67 sp__2766_69 2.0806
Rtree_2766_16 sp__2766_69 sp__11189_CLK 41.339
Rtree_2766_17 sp__2766_69 sp__2766_80 20
Rtree_2766_18 sp__2766_80 sp__11232_CLK 23.9964
Rtree_2766_19 sp__2766_80 sp__2766_89 2.266
Rtree_2766_20 sp__2766_89 sp__2766_95 43.5638
Rtree_2766_21 sp__2766_95 sp__11289_CLK 20
Rtree_2766_22 sp__2766_89 sp__11787_CLK 23.9964
Rtree_2766_23 sp__2766_67 sp__2766_111 21.8334
Rtree_2766_24 sp__2766_111 sp__2766_113 3.9964
Rtree_2766_25 sp__2766_113 sp__11153_CLK 22.6162
Rtree_2766_26 sp__2766_113 sp__11154_CLK 20
Rtree_2766_27 sp__2766_111 sp__11190_CLK 20
Rtree_2766_28 sp__2766_63 sp__11191_CLK 20
Rtree_2766_29 sp__2766_57 sp__11192_CLK 40
Rtree_2766_30 sp__2766_53 sp__11193_CLK 22.6162
Rtree_2766_31 sp__2766_20 sp__2766_159 21.751
Rtree_2766_32 sp__2766_159 sp__2766_167 43.605
Rtree_2766_33 sp__2766_167 sp__11156_CLK 20
Rtree_2766_34 sp__2766_159 sp__11165_CLK 20
Rtree_2766_35 sp__2766_14 sp__11166_CLK 20.3502
Ctree_2766_1 sp__11166_CLK 0 3.02124e-17
Ctree_2766_4 sp__11193_CLK 0 2.66065e-16
Ctree_2766_9 sp__11153_CLK 0 2.60904e-16
Ctree_2766_10 sp__11787_CLK 0 3.87274e-16
Ctree_2766_12 sp__11232_CLK 0 3.50204e-16
Ctree_2766_13 sp__11189_CLK 0 8.17047e-17
Ctree_2766_17 sp__12073_X 0 2.02745e-16
Ctree_2766_18 sp__2766_167 0 3.29444e-16
Ctree_2766_19 sp__2766_159 0 4.91119e-16
Ctree_2766_20 sp__2766_113 0 6.37257e-16
Ctree_2766_21 sp__2766_111 0 5.73159e-16
Ctree_2766_22 sp__2766_95 0 2.03185e-16
Ctree_2766_23 sp__2766_89 0 8.78482e-16
Ctree_2766_24 sp__2766_80 0 6.38227e-16
Ctree_2766_25 sp__2766_69 0 2.00582e-16
Ctree_2766_26 sp__2766_67 0 7.51554e-16
Ctree_2766_27 sp__2766_63 0 9.27728e-16
Ctree_2766_28 sp__2766_57 0 6.83985e-16
Ctree_2766_29 sp__2766_53 0 6.72372e-16
Ctree_2766_30 sp__2766_46 0 4.47653e-16
Ctree_2766_31 sp__2766_37 0 2.82594e-16
Ctree_2766_32 sp__2766_28 0 1.13157e-15
Ctree_2766_33 sp__2766_22 0 1.3609e-15
Ctree_2766_34 sp__2766_20 0 5.99721e-16
Ctree_2766_35 sp__2766_14 0 7.33301e-16
Ctree_2766_36 sp__2766_10 0 6.47993e-16
Ctree_2766_37 sp__11153_CLK 0 3.38585e-16
Ctree_2766_39 sp__11189_CLK 0 2.27773e-16
Ctree_2766_40 sp__11189_CLK 0 7.30101e-17
Ctree_2766_41 sp__11189_CLK 0 2.79309e-16
Ctree_2766_42 sp__11193_CLK 0 3.22713e-16
Ctree_2766_44 sp__11232_CLK 0 3.38223e-16
Ctree_2766_45 sp__11232_CLK 0 2.40957e-16
Ctree_2766_46 sp__11232_CLK 0 5.31438e-16
Ctree_2766_47 sp__11787_CLK 0 3.70301e-16
Ctree_2766_50 sp__2766_10 0 1.79079e-16
Ctree_2766_52 sp__2766_10 0 2.41716e-16
Ctree_2766_53 sp__2766_10 0 2.41847e-16
Ctree_2766_55 sp__2766_14 0 6.79833e-16
Ctree_2766_56 sp__2766_14 0 1.77241e-16
Ctree_2766_57 sp__2766_20 0 5.15366e-17
Ctree_2766_58 sp__2766_20 0 7.52211e-16
Ctree_2766_60 sp__2766_20 0 8.0194e-17
Ctree_2766_61 sp__2766_20 0 8.02013e-16
Ctree_2766_62 sp__2766_22 0 7.89368e-16
Ctree_2766_63 sp__2766_22 0 8.09556e-16
Ctree_2766_66 sp__2766_28 0 1.25056e-16
Ctree_2766_72 sp__2766_28 0 2.79784e-16
Ctree_2766_73 sp__2766_37 0 8.0194e-17
Ctree_2766_75 sp__2766_46 0 3.23129e-16
Ctree_2766_77 sp__2766_53 0 4.78356e-17
Ctree_2766_81 sp__2766_57 0 4.35989e-16
Ctree_2766_83 sp__2766_63 0 2.83593e-16
Ctree_2766_84 sp__2766_63 0 5.96593e-16
Ctree_2766_88 sp__2766_67 0 2.59183e-16
Ctree_2766_90 sp__2766_67 0 7.33256e-17
Ctree_2766_93 sp__2766_69 0 1.76396e-16
Ctree_2766_94 sp__2766_69 0 2.59183e-16
Ctree_2766_95 sp__2766_69 0 4.35266e-16
Ctree_2766_98 sp__2766_95 0 7.45529e-16
Ctree_2766_99 sp__2766_95 0 7.45529e-16
Ctree_2766_100 sp__2766_111 0 1.54008e-17
Ctree_2766_102 sp__2766_111 0 2.08769e-16
Ctree_2766_104 sp__2766_113 0 5.97428e-16
Ctree_2766_105 sp__2766_159 0 1.10936e-16
Ctree_2766_106 sp__2766_159 0 2.08063e-16
Ctree_2766_109 sp__2766_167 0 2.73087e-16
Ctree_2766_110 sp__2766_167 0 2.82152e-16
Ctree_2766_112 sp__11787_CLK 0 4.3527e-16
Rtree_2767_1 sp__12074_X sp__2767_4 20
Rtree_2767_2 sp__2767_4 sp__2767_8 4.3466
Rtree_2767_3 sp__2767_8 sp__2767_12 4.5938
Rtree_2767_4 sp__2767_12 sp__2767_16 21.8334
Rtree_2767_5 sp__2767_16 sp__2767_18 2.3278
Rtree_2767_6 sp__2767_18 sp__2767_20 2.575
Rtree_2767_7 sp__2767_20 sp__2767_22 0.8446
Rtree_2767_8 sp__2767_22 sp__11738_CLK 43.1724
Rtree_2767_9 sp__2767_22 sp__2767_35 20
Rtree_2767_10 sp__2767_35 sp__11141_CLK 22.266
Rtree_2767_11 sp__2767_35 sp__11140_CLK 20
Rtree_2767_12 sp__2767_20 sp__2767_51 23.9964
Rtree_2767_13 sp__2767_51 sp__11138_CLK 23.4196
Rtree_2767_14 sp__2767_51 sp__11139_CLK 20
Rtree_2767_15 sp__2767_18 sp__11682_CLK 44.3466
Rtree_2767_16 sp__2767_16 sp__2767_80 21.339
Rtree_2767_17 sp__2767_80 sp__11143_CLK 20
Rtree_2767_18 sp__2767_80 sp__11146_CLK 22.6162
Rtree_2767_19 sp__2767_12 sp__11142_CLK 20
Rtree_2767_20 sp__2767_8 sp__11147_CLK 20
Rtree_2767_21 sp__2767_4 sp__2767_108 21.0918
Rtree_2767_22 sp__2767_108 sp__11148_CLK 41.8334
Rtree_2767_23 sp__2767_108 sp__2767_119 2.8222
Rtree_2767_24 sp__2767_119 sp__2767_121 20
Rtree_2767_25 sp__2767_121 sp__11750_CLK 20
Rtree_2767_26 sp__2767_121 sp__2767_130 2.6162
Rtree_2767_27 sp__2767_130 sp__11725_CLK 20.3502
Rtree_2767_28 sp__2767_130 sp__2767_145 44.841
Rtree_2767_29 sp__2767_145 sp__11785_CLK 20
Rtree_2767_30 sp__2767_145 sp__2767_154 3.1724
Rtree_2767_31 sp__2767_154 sp__11885_CLK 20
Rtree_2767_32 sp__2767_154 sp__2767_171 48.2606
Rtree_2767_33 sp__2767_171 sp__11883_CLK 20
Rtree_2767_34 sp__2767_119 sp__2767_182 25.8916
Rtree_2767_35 sp__2767_182 sp__11151_CLK 22.6162
Rtree_2767_36 sp__2767_182 sp__11150_CLK 20
Ctree_2767_2 sp__11151_CLK 0 2.73561e-16
Ctree_2767_6 sp__11725_CLK 0 3.16592e-17
Ctree_2767_8 sp__11148_CLK 0 1.49562e-16
Ctree_2767_11 sp__11146_CLK 0 2.50912e-16
Ctree_2767_13 sp__11682_CLK 0 4.65554e-16
Ctree_2767_15 sp__11138_CLK 0 2.91308e-16
Ctree_2767_17 sp__11141_CLK 0 2.22795e-16
Ctree_2767_18 sp__11738_CLK 0 2.40112e-16
Ctree_2767_20 sp__2767_182 0 8.21384e-16
Ctree_2767_21 sp__2767_171 0 8.82939e-16
Ctree_2767_22 sp__2767_154 0 1.17247e-15
Ctree_2767_23 sp__2767_145 0 8.29929e-16
Ctree_2767_24 sp__2767_130 0 8.31595e-16
Ctree_2767_25 sp__2767_121 0 2.59541e-16
Ctree_2767_26 sp__2767_119 0 8.01183e-16
Ctree_2767_27 sp__2767_108 0 5.01862e-16
Ctree_2767_28 sp__2767_80 0 4.11528e-16
Ctree_2767_29 sp__2767_51 0 6.55975e-16
Ctree_2767_30 sp__2767_35 0 2.22795e-16
Ctree_2767_31 sp__2767_22 0 2.71787e-16
Ctree_2767_32 sp__2767_20 0 5.10762e-16
Ctree_2767_33 sp__2767_18 0 8.64933e-16
Ctree_2767_34 sp__2767_16 0 6.8042e-16
Ctree_2767_35 sp__2767_12 0 7.80063e-16
Ctree_2767_36 sp__2767_8 0 9.27697e-16
Ctree_2767_37 sp__2767_4 0 4.81419e-16
Ctree_2767_39 sp__11138_CLK 0 2.73847e-16
Ctree_2767_40 sp__11138_CLK 0 1.54008e-17
Ctree_2767_44 sp__11146_CLK 0 3.37787e-16
Ctree_2767_46 sp__11148_CLK 0 2.73116e-16
Ctree_2767_47 sp__11148_CLK 0 2.73116e-16
Ctree_2767_49 sp__11151_CLK 0 3.38662e-16
Ctree_2767_54 sp__11738_CLK 0 1.77043e-16
Ctree_2767_55 sp__11738_CLK 0 2.86251e-16
Ctree_2767_56 sp__11738_CLK 0 2.87705e-16
Ctree_2767_58 sp__2767_8 0 8.01612e-17
Ctree_2767_59 sp__2767_8 0 5.98187e-16
Ctree_2767_68 sp__2767_18 0 7.52158e-17
Ctree_2767_70 sp__2767_20 0 5.53661e-16
Ctree_2767_71 sp__2767_20 0 4.78533e-16
Ctree_2767_72 sp__2767_22 0 1.81608e-16
Ctree_2767_73 sp__2767_22 0 1.59926e-16
Ctree_2767_74 sp__2767_51 0 5.96121e-16
Ctree_2767_80 sp__2767_108 0 2.33758e-16
Ctree_2767_81 sp__2767_119 0 5.82844e-16
Ctree_2767_83 sp__2767_130 0 3.59266e-16
Ctree_2767_86 sp__2767_145 0 2.41034e-16
Ctree_2767_87 sp__2767_145 0 2.40711e-16
Ctree_2767_91 sp__2767_154 0 2.72808e-16
Ctree_2767_92 sp__2767_171 0 1.75829e-16
Ctree_2767_94 sp__2767_171 0 1.75829e-16
Ctree_2767_95 sp__2767_171 0 2.40196e-16
Ctree_2767_96 sp__2767_171 0 4.72729e-17
Ctree_2767_97 sp__2767_171 0 3.35491e-16
Ctree_2767_101 sp__2767_182 0 2.40614e-16
Ctree_2767_102 sp__2767_182 0 1.76068e-16
Ctree_2767_104 sp__2767_182 0 8.88658e-16
Ctree_2767_105 sp__11141_CLK 0 1.44899e-16
Rtree_2768_1 sp__12075_X sp__2768_8 47.2718
Rtree_2768_2 sp__2768_8 sp__2768_14 25.0882
Rtree_2768_3 sp__2768_14 sp__2768_18 21.0918
Rtree_2768_4 sp__2768_18 sp__2768_24 25.8298
Rtree_2768_5 sp__2768_24 sp__2768_28 5.0882
Rtree_2768_6 sp__2768_28 sp__11282_CLK 20.3502
Rtree_2768_7 sp__2768_28 sp__11751_CLK 22.8634
Rtree_2768_8 sp__2768_24 sp__2768_46 1.8334
Rtree_2768_9 sp__2768_46 sp__2768_48 2.266
Rtree_2768_10 sp__2768_48 sp__2768_50 1.8334
Rtree_2768_11 sp__2768_50 sp__2768_58 44.5938
Rtree_2768_12 sp__2768_58 sp__11246_CLK 20
Rtree_2768_13 sp__2768_50 sp__11274_CLK 20
Rtree_2768_14 sp__2768_48 sp__2768_72 21.5862
Rtree_2768_15 sp__2768_72 sp__2768_74 2.8222
Rtree_2768_16 sp__2768_74 sp__2768_76 2.3278
Rtree_2768_17 sp__2768_76 sp__11271_CLK 41.8334
Rtree_2768_18 sp__2768_76 sp__2768_89 22.266
Rtree_2768_19 sp__2768_89 sp__11268_CLK 22.4308
Rtree_2768_20 sp__2768_89 sp__11281_CLK 20
Rtree_2768_21 sp__2768_74 sp__11259_CLK 46.1594
Rtree_2768_22 sp__2768_72 sp__11273_CLK 40
Rtree_2768_23 sp__2768_46 sp__11275_CLK 20.3502
Rtree_2768_24 sp__2768_24 sp__11283_CLK 20
Rtree_2768_25 sp__2768_18 sp__2768_135 25.7268
Rtree_2768_26 sp__2768_135 sp__2768_139 2.6162
Rtree_2768_27 sp__2768_139 sp__11145_CLK 20
Rtree_2768_28 sp__2768_139 sp__2768_150 23.1724
Rtree_2768_29 sp__2768_150 sp__11149_CLK 44.6968
Rtree_2768_30 sp__2768_150 sp__11144_CLK 40
Rtree_2768_31 sp__2768_135 sp__11260_CLK 20
Rtree_2768_32 sp__2768_14 sp__11261_CLK 20
Rtree_2768_33 sp__2768_8 sp__12120_A 41.4008
Ctree_2768_1 sp__12120_A 0 1.67786e-16
Ctree_2768_5 sp__11149_CLK 0 4.39822e-16
Ctree_2768_8 sp__11275_CLK 0 2.68908e-17
Ctree_2768_10 sp__11259_CLK 0 6.3424e-16
Ctree_2768_12 sp__11268_CLK 0 2.56492e-16
Ctree_2768_13 sp__11271_CLK 0 7.04368e-17
Ctree_2768_16 sp__11751_CLK 0 2.90667e-16
Ctree_2768_17 sp__11282_CLK 0 2.9025e-17
Ctree_2768_18 sp__12075_X 0 4.67913e-16
Ctree_2768_19 sp__2768_150 0 7.30733e-16
Ctree_2768_20 sp__2768_139 0 5.72562e-16
Ctree_2768_21 sp__2768_135 0 8.05668e-16
Ctree_2768_22 sp__2768_89 0 4.52686e-16
Ctree_2768_23 sp__2768_76 0 3.97933e-16
Ctree_2768_24 sp__2768_74 0 1.00351e-15
Ctree_2768_25 sp__2768_72 0 3.54856e-16
Ctree_2768_26 sp__2768_58 0 4.28892e-16
Ctree_2768_27 sp__2768_50 0 6.17516e-16
Ctree_2768_28 sp__2768_48 0 5.611e-16
Ctree_2768_29 sp__2768_46 0 4.79826e-16
Ctree_2768_30 sp__2768_28 0 8.77827e-16
Ctree_2768_31 sp__2768_24 0 1.29251e-15
Ctree_2768_32 sp__2768_18 0 1.15711e-15
Ctree_2768_33 sp__2768_14 0 3.26771e-16
Ctree_2768_34 sp__2768_8 0 8.66411e-16
Ctree_2768_35 sp__11149_CLK 0 1.53457e-17
Ctree_2768_37 sp__11149_CLK 0 4.49106e-16
Ctree_2768_45 sp__11271_CLK 0 3.98443e-16
Ctree_2768_46 sp__11271_CLK 0 3.99967e-16
Ctree_2768_52 sp__2768_8 0 6.11511e-16
Ctree_2768_54 sp__2768_8 0 1.50266e-15
Ctree_2768_55 sp__2768_14 0 2.12659e-16
Ctree_2768_56 sp__2768_14 0 7.77454e-16
Ctree_2768_57 sp__2768_14 0 8.00842e-17
Ctree_2768_58 sp__2768_14 0 9.92527e-16
Ctree_2768_59 sp__2768_18 0 2.34936e-16
Ctree_2768_61 sp__2768_24 0 1.75734e-16
Ctree_2768_64 sp__2768_24 0 7.65856e-16
Ctree_2768_72 sp__2768_50 0 1.4333e-16
Ctree_2768_73 sp__2768_50 0 1.11749e-16
Ctree_2768_76 sp__2768_58 0 5.04876e-16
Ctree_2768_77 sp__2768_72 0 7.48842e-17
Ctree_2768_79 sp__2768_72 0 3.41711e-16
Ctree_2768_81 sp__2768_74 0 6.10432e-16
Ctree_2768_82 sp__2768_76 0 7.31655e-17
Ctree_2768_84 sp__2768_76 0 3.46937e-16
Ctree_2768_85 sp__2768_76 0 3.73918e-16
Ctree_2768_89 sp__2768_135 0 1.12198e-16
Ctree_2768_90 sp__2768_135 0 1.75488e-16
Ctree_2768_91 sp__2768_135 0 8.55123e-16
Ctree_2768_98 sp__2768_150 0 2.87769e-16
Rtree_2769_1 sp__12076_X sp__2769_4 20
Rtree_2769_2 sp__2769_4 sp__2769_6 1.4008
Rtree_2769_3 sp__2769_6 sp__2769_10 4.5938
Rtree_2769_4 sp__2769_10 sp__2769_20 43.9269
Rtree_2769_5 sp__2769_20 sp__11387_CLK 20
Rtree_2769_6 sp__2769_10 sp__11602_CLK 20
Rtree_2769_7 sp__2769_6 sp__2769_36 43.811
Rtree_2769_8 sp__2769_36 sp__11516_CLK 20
Rtree_2769_9 sp__2769_4 sp__2769_47 25.5826
Rtree_2769_10 sp__2769_47 sp__2769_49 1.8334
Rtree_2769_11 sp__2769_49 sp__11398_CLK 45.2942
Rtree_2769_12 sp__2769_49 sp__2769_62 22.266
Rtree_2769_13 sp__2769_62 sp__11491_CLK 20
Rtree_2769_14 sp__2769_62 sp__2769_71 3.1724
Rtree_2769_15 sp__2769_71 sp__11528_CLK 20
Rtree_2769_16 sp__2769_71 sp__2769_78 2.266
Rtree_2769_17 sp__2769_78 sp__2769_84 44.3054
Rtree_2769_18 sp__2769_84 sp__11540_CLK 20
Rtree_2769_19 sp__2769_78 sp__2769_93 21.8334
Rtree_2769_20 sp__2769_93 sp__11490_CLK 49.991
Rtree_2769_21 sp__2769_93 sp__11525_CLK 40.5974
Rtree_2769_22 sp__2769_47 sp__2769_113 20
Rtree_2769_23 sp__2769_113 sp__2769_115 1.8334
Rtree_2769_24 sp__2769_115 sp__2769_117 2.266
Rtree_2769_25 sp__2769_117 sp__11517_CLK 20
Rtree_2769_26 sp__2769_117 sp__2769_126 3.5106
Rtree_2769_27 sp__2769_126 sp__2769_130 2.1836
Rtree_2769_28 sp__2769_130 sp__11537_CLK 22.266
Rtree_2769_29 sp__2769_130 sp__11529_CLK 20
Rtree_2769_30 sp__2769_126 sp__2769_148 44.7998
Rtree_2769_31 sp__2769_148 sp__11502_CLK 20
Rtree_2769_32 sp__2769_115 sp__11524_CLK 20
Rtree_2769_33 sp__2769_113 sp__11518_CLK 20
Rtree_2769_34 sp__12076_X sp__11385_CLK 44.1303
Ctree_2769_1 sp__11385_CLK 0 4.27267e-16
Ctree_2769_6 sp__11537_CLK 0 2.58507e-16
Ctree_2769_8 sp__11525_CLK 0 4.41971e-17
Ctree_2769_9 sp__11490_CLK 0 6.08653e-16
Ctree_2769_13 sp__11398_CLK 0 6.05781e-16
Ctree_2769_17 sp__12076_X 0 4.27267e-16
Ctree_2769_18 sp__2769_148 0 6.37689e-16
Ctree_2769_19 sp__2769_130 0 4.96666e-16
Ctree_2769_20 sp__2769_126 0 1.34919e-15
Ctree_2769_21 sp__2769_117 0 6.97443e-16
Ctree_2769_22 sp__2769_115 0 4.28141e-16
Ctree_2769_23 sp__2769_113 0 2.0404e-16
Ctree_2769_24 sp__2769_93 0 8.51599e-16
Ctree_2769_25 sp__2769_84 0 3.07997e-16
Ctree_2769_26 sp__2769_78 0 7.3082e-16
Ctree_2769_27 sp__2769_71 0 5.00701e-16
Ctree_2769_28 sp__2769_62 0 4.7391e-16
Ctree_2769_29 sp__2769_49 0 9.74657e-16
Ctree_2769_30 sp__2769_47 0 6.37518e-16
Ctree_2769_31 sp__2769_36 0 3.84481e-16
Ctree_2769_32 sp__2769_20 0 3.42506e-16
Ctree_2769_33 sp__2769_10 0 8.58833e-16
Ctree_2769_34 sp__2769_6 0 1.06974e-15
Ctree_2769_35 sp__2769_4 0 6.34853e-16
Ctree_2769_36 sp__11385_CLK 0 4.77425e-17
Ctree_2769_39 sp__11385_CLK 0 2.73507e-16
Ctree_2769_45 sp__11490_CLK 0 1.24056e-15
Ctree_2769_46 sp__11490_CLK 0 3.99531e-16
Ctree_2769_47 sp__11490_CLK 0 1.69376e-15
Ctree_2769_48 sp__11525_CLK 0 1.30344e-16
Ctree_2769_52 sp__2769_20 0 3.4162e-16
Ctree_2769_53 sp__2769_20 0 3.42145e-16
Ctree_2769_56 sp__2769_36 0 1.2816e-16
Ctree_2769_64 sp__2769_62 0 3.39437e-16
Ctree_2769_67 sp__2769_71 0 4.77537e-17
Ctree_2769_68 sp__2769_71 0 2.26446e-16
Ctree_2769_72 sp__2769_78 0 2.40371e-16
Ctree_2769_73 sp__2769_84 0 1.83828e-16
Ctree_2769_74 sp__2769_84 0 9.40124e-16
Ctree_2769_80 sp__2769_126 0 4.77425e-17
Ctree_2769_81 sp__2769_126 0 4.77425e-17
Ctree_2769_83 sp__2769_130 0 1.54008e-17
Ctree_2769_89 sp__2769_47 0 3.93736e-16
Ctree_2769_90 sp__2769_117 0 1.76581e-16
Rtree_2770_1 sp__12077_X sp__2770_8 22.6162
Rtree_2770_2 sp__2770_8 sp__2770_14 22.4617
Rtree_2770_3 sp__2770_14 sp__11277_CLK 41.7837
Rtree_2770_4 sp__2770_14 sp__11278_CLK 42.4823
Rtree_2770_5 sp__2770_8 sp__12121_A 20
Rtree_2770_6 sp__12077_X sp__2770_48 43.9964
Rtree_2770_7 sp__2770_48 sp__2770_50 3.3166
Rtree_2770_8 sp__2770_50 sp__11623_CLK 44.1612
Rtree_2770_9 sp__2770_50 sp__11763_CLK 43.9964
Rtree_2770_10 sp__2770_48 sp__2770_72 1.0918
Rtree_2770_11 sp__2770_72 sp__11264_CLK 40
Rtree_2770_12 sp__2770_72 sp__2770_81 2.8222
Rtree_2770_13 sp__2770_81 sp__2770_83 20
Rtree_2770_14 sp__2770_83 sp__11764_CLK 22.6162
Rtree_2770_15 sp__2770_83 sp__2770_94 1.8334
Rtree_2770_16 sp__2770_94 sp__11265_CLK 20.3502
Rtree_2770_17 sp__2770_94 sp__2770_103 2.266
Rtree_2770_18 sp__2770_103 sp__2770_107 2.1836
Rtree_2770_19 sp__2770_107 sp__2770_109 3.9964
Rtree_2770_20 sp__2770_109 sp__11270_CLK 22.6162
Rtree_2770_21 sp__2770_109 sp__2770_120 20
Rtree_2770_22 sp__2770_120 sp__11279_CLK 43.4196
Rtree_2770_23 sp__2770_120 sp__2770_135 26.5302
Rtree_2770_24 sp__2770_135 sp__11272_CLK 22.266
Rtree_2770_25 sp__2770_135 sp__11269_CLK 20.3502
Rtree_2770_26 sp__2770_109 sp__11280_CLK 20
Rtree_2770_27 sp__2770_107 sp__11267_CLK 20.3502
Rtree_2770_28 sp__2770_103 sp__11266_CLK 20
Rtree_2770_29 sp__2770_81 sp__11258_CLK 45.7886
Ctree_2770_1 sp__11258_CLK 0 5.09906e-16
Ctree_2770_3 sp__11267_CLK 0 2.77263e-17
Ctree_2770_5 sp__11269_CLK 0 2.77263e-17
Ctree_2770_6 sp__11272_CLK 0 2.49339e-16
Ctree_2770_7 sp__11279_CLK 0 2.35787e-16
Ctree_2770_8 sp__11270_CLK 0 2.74274e-16
Ctree_2770_9 sp__11265_CLK 0 2.77263e-17
Ctree_2770_10 sp__11764_CLK 0 2.67066e-16
Ctree_2770_12 sp__11763_CLK 0 4.2077e-16
Ctree_2770_13 sp__11623_CLK 0 4.2535e-16
Ctree_2770_15 sp__11278_CLK 0 3.0062e-16
Ctree_2770_16 sp__11277_CLK 0 1.41654e-16
Ctree_2770_17 sp__12077_X 0 6.87644e-16
Ctree_2770_18 sp__2770_135 0 5.28433e-16
Ctree_2770_19 sp__2770_120 0 4.87155e-16
Ctree_2770_20 sp__2770_109 0 6.69818e-16
Ctree_2770_21 sp__2770_107 0 6.57624e-16
Ctree_2770_22 sp__2770_103 0 4.86815e-16
Ctree_2770_23 sp__2770_94 0 4.91406e-16
Ctree_2770_24 sp__2770_83 0 4.78284e-16
Ctree_2770_25 sp__2770_81 0 7.4679e-16
Ctree_2770_26 sp__2770_72 0 3.30815e-16
Ctree_2770_27 sp__2770_50 0 1.09057e-15
Ctree_2770_28 sp__2770_48 0 7.5555e-16
Ctree_2770_29 sp__2770_14 0 6.60662e-16
Ctree_2770_30 sp__2770_8 0 4.88863e-16
Ctree_2770_31 sp__11258_CLK 0 1.2396e-15
Ctree_2770_35 sp__11277_CLK 0 3.45758e-16
Ctree_2770_36 sp__11277_CLK 0 3.45758e-16
Ctree_2770_40 sp__11279_CLK 0 3.41949e-16
Ctree_2770_41 sp__11279_CLK 0 3.42449e-16
Ctree_2770_42 sp__11623_CLK 0 3.9953e-16
Ctree_2770_45 sp__11763_CLK 0 5.96334e-16
Ctree_2770_50 sp__2770_14 0 1.83978e-16
Ctree_2770_51 sp__2770_14 0 1.6207e-16
Ctree_2770_53 sp__2770_48 0 2.40196e-16
Ctree_2770_54 sp__2770_48 0 2.40069e-16
Ctree_2770_55 sp__2770_50 0 7.00925e-16
Ctree_2770_56 sp__2770_72 0 2.15371e-16
Ctree_2770_57 sp__2770_81 0 5.94409e-16
Ctree_2770_64 sp__2770_135 0 1.40798e-15
Ctree_2770_65 sp__2770_135 0 1.38713e-15
Rtree_2771_1 sp__12078_X sp__2771_10 41.751
Rtree_2771_2 sp__2771_10 sp__2771_12 1.339
Rtree_2771_3 sp__2771_12 sp__2771_14 3.5638
Rtree_2771_4 sp__2771_14 sp__2771_16 1.8334
Rtree_2771_5 sp__2771_16 sp__2771_18 0.8446
Rtree_2771_6 sp__2771_18 sp__11812_CLK 40.8446
Rtree_2771_7 sp__2771_18 sp__11596_CLK 42.266
Rtree_2771_8 sp__2771_16 sp__2771_42 24.3466
Rtree_2771_9 sp__2771_42 sp__2771_46 23.7801
Rtree_2771_10 sp__2771_46 sp__11736_CLK 43.1415
Rtree_2771_11 sp__2771_46 sp__2771_59 1.5862
Rtree_2771_12 sp__2771_59 sp__2771_63 22.0497
Rtree_2771_13 sp__2771_63 sp__2771_67 24.8658
Rtree_2771_14 sp__2771_67 sp__11636_CLK 44.0582
Rtree_2771_15 sp__2771_67 sp__11554_CLK 42.8222
Rtree_2771_16 sp__2771_63 sp__11610_CLK 20
Rtree_2771_17 sp__2771_59 sp__11737_CLK 42.8943
Rtree_2771_18 sp__2771_42 sp__12122_A 20
Rtree_2771_19 sp__2771_14 sp__11593_CLK 41.8334
Rtree_2771_20 sp__2771_12 sp__11768_CLK 40
Rtree_2771_21 sp__2771_10 sp__2771_126 22.266
Rtree_2771_22 sp__2771_126 sp__2771_132 40.5974
Rtree_2771_23 sp__2771_132 sp__11815_CLK 20
Rtree_2771_24 sp__2771_126 sp__2771_147 46.6744
Rtree_2771_25 sp__2771_147 sp__11594_CLK 20
Rtree_2771_26 sp__2771_10 sp__2771_154 5.2942
Rtree_2771_27 sp__2771_154 sp__2771_158 21.8334
Rtree_2771_28 sp__2771_158 sp__11597_CLK 20
Rtree_2771_29 sp__2771_158 sp__11622_CLK 23.1106
Rtree_2771_30 sp__2771_154 sp__2771_174 1.339
Rtree_2771_31 sp__2771_174 sp__11801_CLK 42.266
Rtree_2771_32 sp__2771_174 sp__11739_CLK 40.5974
Rtree_2771_33 sp__12078_X sp__2771_203 45.6753
Rtree_2771_34 sp__2771_203 sp__11681_CLK 40.5356
Ctree_2771_1 sp__11681_CLK 0 4.37077e-17
Ctree_2771_2 sp__11739_CLK 0 3.75824e-17
Ctree_2771_3 sp__11801_CLK 0 2.05201e-16
Ctree_2771_4 sp__11622_CLK 0 3.17119e-16
Ctree_2771_9 sp__11593_CLK 0 2.08643e-16
Ctree_2771_11 sp__11737_CLK 0 1.34705e-16
Ctree_2771_13 sp__11554_CLK 0 1.11671e-16
Ctree_2771_14 sp__11636_CLK 0 1.93939e-16
Ctree_2771_15 sp__11736_CLK 0 1.4523e-16
Ctree_2771_16 sp__11596_CLK 0 2.54907e-16
Ctree_2771_17 sp__11812_CLK 0 9.93249e-17
Ctree_2771_18 sp__12078_X 0 6.23948e-16
Ctree_2771_19 sp__2771_203 0 4.60615e-16
Ctree_2771_20 sp__2771_174 0 3.27924e-16
Ctree_2771_21 sp__2771_158 0 4.87697e-16
Ctree_2771_22 sp__2771_154 0 7.11683e-16
Ctree_2771_23 sp__2771_147 0 5.46586e-16
Ctree_2771_24 sp__2771_132 0 4.27964e-17
Ctree_2771_25 sp__2771_126 0 7.61501e-16
Ctree_2771_26 sp__2771_67 0 9.71828e-16
Ctree_2771_27 sp__2771_63 0 8.80288e-16
Ctree_2771_28 sp__2771_59 0 4.08304e-16
Ctree_2771_29 sp__2771_46 0 6.13726e-16
Ctree_2771_30 sp__2771_42 0 8.94876e-16
Ctree_2771_31 sp__2771_18 0 4.44276e-16
Ctree_2771_32 sp__2771_16 0 7.85198e-16
Ctree_2771_33 sp__2771_14 0 7.81596e-16
Ctree_2771_34 sp__2771_12 0 4.78953e-16
Ctree_2771_35 sp__2771_10 0 9.50365e-16
Ctree_2771_36 sp__11554_CLK 0 6.1009e-16
Ctree_2771_38 sp__11593_CLK 0 1.75513e-16
Ctree_2771_39 sp__11596_CLK 0 8.02927e-17
Ctree_2771_42 sp__11636_CLK 0 2.88789e-16
Ctree_2771_43 sp__11636_CLK 0 2.16079e-16
Ctree_2771_44 sp__11636_CLK 0 2.37643e-16
Ctree_2771_45 sp__11681_CLK 0 8.00842e-17
Ctree_2771_46 sp__11681_CLK 0 8.00842e-17
Ctree_2771_47 sp__11736_CLK 0 6.06225e-16
Ctree_2771_48 sp__11737_CLK 0 5.54596e-16
Ctree_2771_49 sp__11739_CLK 0 1.28248e-16
Ctree_2771_57 sp__2771_42 0 3.3819e-16
Ctree_2771_58 sp__2771_46 0 4.77425e-17
Ctree_2771_59 sp__2771_46 0 1.758e-16
Ctree_2771_60 sp__2771_46 0 7.94972e-17
Ctree_2771_61 sp__2771_46 0 7.94957e-17
Ctree_2771_62 sp__2771_59 0 3.41949e-16
Ctree_2771_64 sp__2771_63 0 4.77425e-17
Ctree_2771_73 sp__2771_147 0 1.43724e-16
Ctree_2771_74 sp__2771_147 0 1.80998e-16
Ctree_2771_76 sp__2771_154 0 5.54492e-16
Ctree_2771_78 sp__2771_158 0 2.73087e-16
Ctree_2771_79 sp__2771_174 0 2.88502e-16
Ctree_2771_81 sp__2771_203 0 2.08956e-16
Ctree_2771_82 sp__2771_203 0 4.73078e-17
Ctree_2771_83 sp__2771_203 0 4.6638e-16
Ctree_2771_84 sp__2771_203 0 3.94981e-16
Ctree_2771_85 sp__2771_203 0 1.06064e-16
Ctree_2771_86 sp__2771_203 0 5.0146e-16
Ctree_2771_92 sp__11801_CLK 0 3.38949e-16
Ctree_2771_94 sp__2771_147 0 1.81338e-16
Ctree_2771_97 sp__11554_CLK 0 5.87817e-16
Ctree_2771_98 sp__11636_CLK 0 8.81159e-16
Ctree_2771_104 sp__11736_CLK 0 4.77425e-17
Rtree_2772_1 sp__12079_X sp__2772_8 42.6986
Rtree_2772_2 sp__2772_8 sp__2772_10 5.047
Rtree_2772_3 sp__2772_10 sp__2772_16 31.8553
Rtree_2772_4 sp__2772_16 sp__11676_CLK 20
Rtree_2772_5 sp__2772_10 sp__2772_23 20
Rtree_2772_6 sp__2772_23 sp__11814_CLK 20.7519
Rtree_2772_7 sp__2772_23 sp__2772_34 2.1883
Rtree_2772_8 sp__2772_34 sp__11595_CLK 20
Rtree_2772_9 sp__2772_34 sp__2772_43 3.3578
Rtree_2772_10 sp__2772_43 sp__11715_CLK 20
Rtree_2772_11 sp__2772_43 sp__2772_52 25.7268
Rtree_2772_12 sp__2772_52 sp__11714_CLK 47.2718
Rtree_2772_13 sp__2772_52 sp__11584_CLK 41.5862
Rtree_2772_14 sp__2772_8 sp__2772_76 22.5853
Rtree_2772_15 sp__2772_76 sp__2772_80 22.266
Rtree_2772_16 sp__2772_80 sp__11135_CLK 42.9252
Rtree_2772_17 sp__2772_80 sp__2772_93 1.99563
Rtree_2772_18 sp__2772_93 sp__11802_CLK 40
Rtree_2772_19 sp__2772_93 sp__11136_CLK 45.6676
Rtree_2772_20 sp__2772_76 sp__11762_CLK 20
Rtree_2772_21 sp__12079_X sp__2772_125 44.3054
Rtree_2772_22 sp__2772_125 sp__2772_127 20
Rtree_2772_23 sp__2772_127 sp__2772_131 2.1836
Rtree_2772_24 sp__2772_131 sp__2772_135 3.0226
Rtree_2772_25 sp__2772_135 sp__11805_CLK 22.9252
Rtree_2772_26 sp__2772_135 sp__11795_CLK 20
Rtree_2772_27 sp__2772_131 sp__11713_CLK 20
Rtree_2772_28 sp__2772_127 sp__11797_CLK 20
Ctree_2772_4 sp__11805_CLK 0 3.01136e-16
Ctree_2772_6 sp__11136_CLK 0 4.87551e-16
Ctree_2772_8 sp__11135_CLK 0 3.24531e-16
Ctree_2772_9 sp__11584_CLK 0 1.4998e-16
Ctree_2772_10 sp__11714_CLK 0 7.23286e-16
Ctree_2772_13 sp__11814_CLK 0 8.73101e-17
Ctree_2772_15 sp__12079_X 0 5.15976e-16
Ctree_2772_16 sp__2772_135 0 5.97911e-16
Ctree_2772_17 sp__2772_131 0 5.02148e-16
Ctree_2772_18 sp__2772_127 0 2.05373e-16
Ctree_2772_19 sp__2772_125 0 1.69168e-16
Ctree_2772_20 sp__2772_93 0 7.13067e-16
Ctree_2772_21 sp__2772_80 0 7.65963e-16
Ctree_2772_22 sp__2772_76 0 4.37227e-16
Ctree_2772_23 sp__2772_52 0 1.49678e-15
Ctree_2772_24 sp__2772_43 0 9.21242e-16
Ctree_2772_25 sp__2772_34 0 5.17241e-16
Ctree_2772_26 sp__2772_23 0 3.06823e-16
Ctree_2772_27 sp__2772_16 0 9.70048e-16
Ctree_2772_28 sp__2772_10 0 1.24047e-15
Ctree_2772_29 sp__2772_8 0 8.38546e-16
Ctree_2772_32 sp__11135_CLK 0 1.54556e-17
Ctree_2772_34 sp__11136_CLK 0 5.97034e-16
Ctree_2772_36 sp__11136_CLK 0 1.81192e-16
Ctree_2772_45 sp__2772_10 0 1.08923e-15
Ctree_2772_46 sp__2772_10 0 7.45354e-16
Ctree_2772_51 sp__2772_16 0 1.09109e-15
Ctree_2772_53 sp__2772_16 0 8.72683e-16
Ctree_2772_54 sp__2772_16 0 3.37896e-16
Ctree_2772_58 sp__2772_16 0 7.97045e-17
Ctree_2772_63 sp__2772_52 0 2.41165e-16
Ctree_2772_64 sp__2772_76 0 9.66454e-17
Ctree_2772_66 sp__2772_76 0 3.9332e-16
Ctree_2772_68 sp__2772_80 0 3.38911e-16
Ctree_2772_69 sp__2772_80 0 1.54008e-17
Ctree_2772_73 sp__2772_125 0 9.2779e-16
Ctree_2772_75 sp__2772_131 0 2.07854e-16
Ctree_2772_76 sp__2772_131 0 8.00842e-17
Ctree_2772_82 sp__2772_43 0 8.0194e-17
Ctree_2772_84 sp__11136_CLK 0 1.7634e-16
Ctree_2772_87 sp__11136_CLK 0 4.35793e-16
Ctree_2772_89 sp__11714_CLK 0 3.94566e-16
Rtree_2773_1 sp__12080_X sp__2773_8 21.5347
Rtree_2773_2 sp__2773_8 sp__2773_10 0.5356
Rtree_2773_3 sp__2773_10 sp__11799_CLK 21.8334
Rtree_2773_4 sp__2773_10 sp__2773_23 41.339
Rtree_2773_5 sp__2773_23 sp__11886_CLK 20
Rtree_2773_6 sp__2773_8 sp__2773_36 45.459
Rtree_2773_7 sp__2773_36 sp__2773_44 44.6556
Rtree_2773_8 sp__2773_44 sp__2773_46 1.8334
Rtree_2773_9 sp__2773_46 sp__11724_CLK 20
Rtree_2773_10 sp__2773_46 sp__2773_57 5.1912
Rtree_2773_11 sp__2773_57 sp__2773_61 22.266
Rtree_2773_12 sp__2773_61 sp__11137_CLK 43.4196
Rtree_2773_13 sp__2773_61 sp__11721_CLK 41.339
Rtree_2773_14 sp__2773_57 sp__11803_CLK 20
Rtree_2773_15 sp__2773_44 sp__11796_CLK 20
Rtree_2773_16 sp__2773_36 sp__11804_CLK 22.0812
Rtree_2773_17 sp__12080_X sp__2773_107 22.1836
Rtree_2773_18 sp__2773_107 sp__2773_111 21.6171
Rtree_2773_19 sp__2773_111 sp__2773_113 0.5974
Rtree_2773_20 sp__2773_113 sp__2773_119 23.3269
Rtree_2773_21 sp__2773_119 sp__11798_CLK 20
Rtree_2773_22 sp__2773_119 sp__2773_134 42.781
Rtree_2773_23 sp__2773_134 sp__11723_CLK 20
Rtree_2773_24 sp__2773_113 sp__2773_149 31.0725
Rtree_2773_25 sp__2773_149 sp__11887_CLK 20
Rtree_2773_26 sp__2773_111 sp__2773_156 5.7886
Rtree_2773_27 sp__2773_156 sp__11786_CLK 40.7519
Rtree_2773_28 sp__2773_156 sp__11884_CLK 44.0685
Rtree_2773_29 sp__2773_107 sp__11722_CLK 20.5974
Ctree_2773_1 sp__11722_CLK 0 4.57066e-17
Ctree_2773_2 sp__11884_CLK 0 3.13332e-16
Ctree_2773_3 sp__11786_CLK 0 7.45742e-17
Ctree_2773_7 sp__11804_CLK 0 2.44363e-16
Ctree_2773_10 sp__11721_CLK 0 1.45953e-16
Ctree_2773_11 sp__11137_CLK 0 3.71369e-16
Ctree_2773_14 sp__11799_CLK 0 2.30117e-16
Ctree_2773_15 sp__12080_X 0 4.03415e-16
Ctree_2773_16 sp__2773_156 0 6.54703e-16
Ctree_2773_17 sp__2773_149 0 1.03333e-15
Ctree_2773_18 sp__2773_134 0 2.48145e-16
Ctree_2773_19 sp__2773_119 0 4.17429e-16
Ctree_2773_20 sp__2773_113 0 1.22564e-15
Ctree_2773_21 sp__2773_111 0 4.44505e-16
Ctree_2773_22 sp__2773_107 0 4.24496e-16
Ctree_2773_23 sp__2773_61 0 7.13273e-16
Ctree_2773_24 sp__2773_57 0 6.97598e-16
Ctree_2773_25 sp__2773_46 0 6.89081e-16
Ctree_2773_26 sp__2773_44 0 6.48785e-16
Ctree_2773_27 sp__2773_36 0 1.01872e-15
Ctree_2773_28 sp__2773_23 0 5.79881e-17
Ctree_2773_29 sp__2773_10 0 3.47902e-16
Ctree_2773_30 sp__2773_8 0 5.52109e-16
Ctree_2773_40 sp__11804_CLK 0 8.0194e-17
Ctree_2773_45 sp__11884_CLK 0 3.69229e-16
Ctree_2773_46 sp__11884_CLK 0 3.39602e-16
Ctree_2773_47 sp__11884_CLK 0 3.1954e-16
Ctree_2773_49 sp__2773_23 0 2.89003e-16
Ctree_2773_50 sp__2773_23 0 1.8261e-16
Ctree_2773_51 sp__2773_23 0 7.52158e-17
Ctree_2773_52 sp__2773_36 0 8.01573e-17
Ctree_2773_53 sp__2773_36 0 1.75798e-16
Ctree_2773_54 sp__2773_36 0 8.69964e-16
Ctree_2773_55 sp__2773_36 0 8.67765e-16
Ctree_2773_58 sp__2773_57 0 2.0803e-16
Ctree_2773_60 sp__2773_57 0 1.54008e-17
Ctree_2773_62 sp__2773_61 0 2.74397e-16
Ctree_2773_63 sp__2773_61 0 6.48697e-17
Ctree_2773_64 sp__2773_107 0 2.07854e-16
Ctree_2773_66 sp__2773_111 0 2.25059e-16
Ctree_2773_67 sp__2773_113 0 1.2816e-16
Ctree_2773_68 sp__2773_113 0 1.06064e-16
Ctree_2773_69 sp__2773_119 0 2.65159e-16
Ctree_2773_70 sp__2773_119 0 2.87256e-16
Ctree_2773_71 sp__2773_119 0 1.12503e-16
Ctree_2773_72 sp__2773_119 0 1.12503e-16
Ctree_2773_73 sp__2773_119 0 5.52415e-16
Ctree_2773_74 sp__2773_134 0 4.78521e-17
Ctree_2773_75 sp__2773_134 0 3.36432e-16
Ctree_2773_76 sp__2773_134 0 2.40739e-16
Ctree_2773_77 sp__2773_134 0 3.23965e-17
Ctree_2773_79 sp__2773_149 0 1.44403e-16
Ctree_2773_80 sp__2773_149 0 3.70035e-16
Ctree_2773_84 sp__2773_149 0 1.44861e-16
Ctree_2773_86 sp__2773_149 0 3.0533e-16
Ctree_2773_87 sp__2773_156 0 5.28487e-16
Ctree_2773_88 sp__2773_156 0 2.331e-16
Ctree_2773_89 sp__2773_156 0 2.9007e-16
Ctree_2773_90 sp__2773_156 0 1.22963e-15
Ctree_2773_91 sp__2773_46 0 2.08747e-16
Ctree_2773_93 sp__2773_57 0 8.02267e-17
Ctree_2773_95 sp__2773_149 0 4.77425e-17
Ctree_2773_99 sp__11137_CLK 0 2.73825e-16
Ctree_2773_108 sp__2773_8 0 1.54008e-17
Ctree_2773_109 sp__2773_107 0 1.54556e-17
Ctree_2773_110 sp__2773_149 0 2.40328e-16
Rtree_2774_1 sp__12081_X sp__2774_8 41.4008
Rtree_2774_2 sp__2774_8 sp__2774_10 3.3166
Rtree_2774_3 sp__2774_10 sp__11794_CLK 42.0806
Rtree_2774_4 sp__2774_10 sp__2774_21 20
Rtree_2774_5 sp__2774_21 sp__2774_23 2.266
Rtree_2774_6 sp__2774_23 sp__2774_27 21.5518
Rtree_2774_7 sp__2774_27 sp__2774_29 5.047
Rtree_2774_8 sp__2774_29 sp__2774_31 2.575
Rtree_2774_9 sp__2774_31 sp__2774_33 1.5862
Rtree_2774_10 sp__2774_33 sp__11632_CLK 42.678
Rtree_2774_11 sp__2774_33 sp__11677_CLK 40
Rtree_2774_12 sp__2774_31 sp__11808_CLK 41.9636
Rtree_2774_13 sp__2774_29 sp__11678_CLK 42.266
Rtree_2774_14 sp__2774_27 sp__11720_CLK 42.0806
Rtree_2774_15 sp__2774_23 sp__11807_CLK 20
Rtree_2774_16 sp__2774_21 sp__2774_95 45.2942
Rtree_2774_17 sp__2774_95 sp__11711_CLK 20
Rtree_2774_18 sp__2774_8 sp__2774_102 1.5862
Rtree_2774_19 sp__2774_102 sp__11793_CLK 40
Rtree_2774_20 sp__2774_102 sp__2774_111 4.0582
Rtree_2774_21 sp__2774_111 sp__11888_CLK 42.266
Rtree_2774_22 sp__2774_111 sp__2774_122 2.8222
Rtree_2774_23 sp__2774_122 sp__11760_CLK 44.3466
Rtree_2774_24 sp__2774_122 sp__2774_137 21.0918
Rtree_2774_25 sp__2774_137 sp__11712_CLK 23.9964
Rtree_2774_26 sp__2774_137 sp__11792_CLK 20.721
Rtree_2774_27 sp__12081_X sp__11761_CLK 43.3475
Ctree_2774_1 sp__11761_CLK 0 3.73829e-16
Ctree_2774_2 sp__11792_CLK 0 5.70836e-17
Ctree_2774_3 sp__11712_CLK 0 4.17548e-16
Ctree_2774_4 sp__11760_CLK 0 4.16039e-16
Ctree_2774_5 sp__11888_CLK 0 2.05991e-16
Ctree_2774_9 sp__11720_CLK 0 1.81863e-16
Ctree_2774_10 sp__11678_CLK 0 2.1163e-16
Ctree_2774_11 sp__11808_CLK 0 4.09563e-16
Ctree_2774_13 sp__11632_CLK 0 2.48832e-16
Ctree_2774_14 sp__11794_CLK 0 9.08645e-17
Ctree_2774_15 sp__12081_X 0 5.29483e-16
Ctree_2774_16 sp__2774_137 0 5.92757e-16
Ctree_2774_17 sp__2774_122 0 8.03583e-16
Ctree_2774_18 sp__2774_111 0 6.96401e-16
Ctree_2774_19 sp__2774_102 0 2.8454e-16
Ctree_2774_20 sp__2774_95 0 4.98232e-16
Ctree_2774_21 sp__2774_33 0 3.56331e-16
Ctree_2774_22 sp__2774_31 0 6.74272e-16
Ctree_2774_23 sp__2774_29 0 9.68877e-16
Ctree_2774_24 sp__2774_27 0 9.54974e-16
Ctree_2774_25 sp__2774_23 0 3.48886e-16
Ctree_2774_26 sp__2774_21 0 6.74043e-16
Ctree_2774_27 sp__2774_10 0 2.23255e-16
Ctree_2774_28 sp__2774_8 0 3.51592e-16
Ctree_2774_30 sp__11632_CLK 0 1.84311e-16
Ctree_2774_31 sp__11678_CLK 0 1.54008e-17
Ctree_2774_32 sp__11678_CLK 0 3.39042e-16
Ctree_2774_33 sp__11678_CLK 0 1.54008e-17
Ctree_2774_35 sp__11712_CLK 0 9.65044e-17
Ctree_2774_38 sp__11720_CLK 0 2.38973e-16
Ctree_2774_40 sp__11760_CLK 0 2.72538e-16
Ctree_2774_41 sp__11761_CLK 0 4.74248e-17
Ctree_2774_43 sp__11794_CLK 0 4.44932e-16
Ctree_2774_44 sp__11794_CLK 0 4.44932e-16
Ctree_2774_50 sp__2774_8 0 2.08074e-16
Ctree_2774_52 sp__2774_10 0 7.13173e-16
Ctree_2774_53 sp__2774_10 0 6.91492e-16
Ctree_2774_54 sp__2774_23 0 3.23855e-16
Ctree_2774_55 sp__2774_23 0 3.3931e-16
Ctree_2774_56 sp__2774_27 0 1.54008e-17
Ctree_2774_58 sp__2774_27 0 1.12569e-16
Ctree_2774_59 sp__2774_27 0 2.08758e-16
Ctree_2774_60 sp__2774_29 0 1.79315e-16
Ctree_2774_61 sp__2774_31 0 2.38126e-16
Ctree_2774_62 sp__2774_31 0 5.38157e-17
Ctree_2774_63 sp__2774_33 0 1.30011e-16
Ctree_2774_64 sp__2774_95 0 4.77425e-17
Ctree_2774_65 sp__2774_95 0 1.81192e-16
Ctree_2774_66 sp__2774_95 0 1.82315e-16
Ctree_2774_67 sp__2774_95 0 1.60112e-16
Ctree_2774_68 sp__2774_95 0 8.00842e-17
Ctree_2774_69 sp__2774_95 0 1.75513e-16
Ctree_2774_70 sp__2774_102 0 3.40704e-16
Ctree_2774_71 sp__2774_102 0 3.18607e-16
Ctree_2774_73 sp__2774_111 0 8.71525e-16
Ctree_2774_74 sp__2774_111 0 5.83766e-16
Ctree_2774_76 sp__2774_122 0 5.50686e-16
Ctree_2774_77 sp__2774_137 0 1.2816e-16
Ctree_2774_80 sp__11632_CLK 0 7.62389e-17
Ctree_2774_81 sp__2774_29 0 1.04877e-16
Ctree_2774_82 sp__2774_31 0 5.39371e-16
Ctree_2774_83 sp__2774_33 0 3.23335e-16
Ctree_2774_85 sp__2774_29 0 1.27305e-16
Ctree_2774_89 sp__11888_CLK 0 1.54008e-17
Ctree_2774_90 sp__11761_CLK 0 1.44768e-16
Ctree_2774_91 sp__11761_CLK 0 2.09714e-16
Ctree_2774_92 sp__11760_CLK 0 1.122e-16
Ctree_2774_93 sp__11760_CLK 0 3.22292e-16
Ctree_2774_96 sp__11888_CLK 0 2.42285e-16
Rtree_2775_1 sp__12082_X sp__2775_4 20
Rtree_2775_2 sp__2775_4 sp__2775_8 3.914
Rtree_2775_3 sp__2775_8 sp__2775_10 2.266
Rtree_2775_4 sp__2775_10 sp__11816_CLK 22.1836
Rtree_2775_5 sp__2775_10 sp__11716_CLK 20
Rtree_2775_6 sp__2775_8 sp__11134_CLK 20
Rtree_2775_7 sp__2775_4 sp__2775_31 0.5356
Rtree_2775_8 sp__2775_31 sp__2775_35 25.2942
Rtree_2775_9 sp__2775_35 sp__2775_37 0.8446
Rtree_2775_10 sp__2775_37 sp__2775_39 0.8446
Rtree_2775_11 sp__2775_39 sp__2775_49 33.3282
Rtree_2775_12 sp__2775_49 sp__11809_CLK 27.313
Rtree_2775_13 sp__2775_49 sp__11633_CLK 20
Rtree_2775_14 sp__2775_39 sp__2775_67 21.8334
Rtree_2775_15 sp__2775_67 sp__11708_CLK 21.0918
Rtree_2775_16 sp__2775_67 sp__11844_CLK 22.266
Rtree_2775_17 sp__2775_37 sp__11133_CLK 42.266
Rtree_2775_18 sp__2775_35 sp__11857_CLK 40
Rtree_2775_19 sp__2775_31 sp__2775_99 1.8334
Rtree_2775_20 sp__2775_99 sp__2775_103 22.0806
Rtree_2775_21 sp__2775_103 sp__11843_CLK 40
Rtree_2775_22 sp__2775_103 sp__2775_114 26.5302
Rtree_2775_23 sp__2775_114 sp__2775_116 2.266
Rtree_2775_24 sp__2775_116 sp__11842_CLK 20.3502
Rtree_2775_25 sp__2775_116 sp__11749_CLK 23.9964
Rtree_2775_26 sp__2775_114 sp__11806_CLK 20.3502
Rtree_2775_27 sp__2775_99 sp__11740_CLK 22.266
Ctree_2775_1 sp__11740_CLK 0 2.12689e-16
Ctree_2775_2 sp__11806_CLK 0 2.77263e-17
Ctree_2775_3 sp__11749_CLK 0 4.26648e-16
Ctree_2775_4 sp__11842_CLK 0 2.36489e-17
Ctree_2775_7 sp__11133_CLK 0 2.56082e-16
Ctree_2775_8 sp__11844_CLK 0 1.88141e-16
Ctree_2775_9 sp__11708_CLK 0 8.64409e-17
Ctree_2775_11 sp__11809_CLK 0 6.90282e-16
Ctree_2775_14 sp__11816_CLK 0 2.20526e-16
Ctree_2775_16 sp__2775_116 0 6.84658e-16
Ctree_2775_17 sp__2775_114 0 9.82044e-16
Ctree_2775_18 sp__2775_103 0 9.61835e-16
Ctree_2775_19 sp__2775_99 0 6.60115e-16
Ctree_2775_20 sp__2775_67 0 4.69065e-16
Ctree_2775_21 sp__2775_49 0 1.96145e-15
Ctree_2775_22 sp__2775_39 0 1.53133e-15
Ctree_2775_23 sp__2775_37 0 3.89801e-16
Ctree_2775_24 sp__2775_35 0 5.50065e-16
Ctree_2775_25 sp__2775_31 0 7.4635e-16
Ctree_2775_26 sp__2775_10 0 4.37086e-16
Ctree_2775_27 sp__2775_8 0 5.58515e-16
Ctree_2775_28 sp__2775_4 0 4.00737e-16
Ctree_2775_32 sp__11740_CLK 0 6.4771e-17
Ctree_2775_33 sp__11809_CLK 0 4.98517e-16
Ctree_2775_34 sp__11809_CLK 0 4.71353e-17
Ctree_2775_36 sp__11809_CLK 0 1.76426e-16
Ctree_2775_48 sp__2775_35 0 9.80823e-16
Ctree_2775_49 sp__2775_37 0 1.81192e-16
Ctree_2775_51 sp__2775_39 0 1.81608e-16
Ctree_2775_52 sp__2775_49 0 3.14057e-16
Ctree_2775_53 sp__2775_49 0 2.72347e-16
Ctree_2775_55 sp__2775_49 0 2.08075e-16
Ctree_2775_59 sp__2775_49 0 6.0693e-16
Ctree_2775_65 sp__2775_99 0 1.54556e-17
Ctree_2775_68 sp__2775_114 0 1.2816e-16
Ctree_2775_74 sp__2775_49 0 1.76054e-16
Ctree_2775_76 sp__11749_CLK 0 8.00842e-17
Ctree_2775_83 sp__11749_CLK 0 1.76583e-16
Rtree_2776_1 sp__12083_X sp__2776_10 42.7398
Rtree_2776_2 sp__2776_10 sp__2776_12 2.3278
Rtree_2776_3 sp__2776_12 sp__2776_18 22.7707
Rtree_2776_4 sp__2776_18 sp__11660_CLK 21.1845
Rtree_2776_5 sp__2776_18 sp__2776_29 24.3054
Rtree_2776_6 sp__2776_29 sp__2776_35 24.1863
Rtree_2776_7 sp__2776_35 sp__2776_43 45.2118
Rtree_2776_8 sp__2776_43 sp__11131_CLK 20
Rtree_2776_9 sp__2776_35 sp__11718_CLK 21.4008
Rtree_2776_10 sp__2776_29 sp__2776_59 25.0779
Rtree_2776_11 sp__2776_59 sp__2776_65 46.7774
Rtree_2776_12 sp__2776_65 sp__11709_CLK 20
Rtree_2776_13 sp__2776_59 sp__11589_CLK 20
Rtree_2776_14 sp__2776_12 sp__11847_CLK 44.3466
Rtree_2776_15 sp__2776_10 sp__12104_A 40
Rtree_2776_16 sp__12083_X sp__2776_100 23.2595
Rtree_2776_17 sp__2776_100 sp__11846_CLK 20
Rtree_2776_18 sp__2776_100 sp__2776_111 3.2136
Rtree_2776_19 sp__2776_111 sp__11741_CLK 20
Rtree_2776_20 sp__2776_111 sp__11029_CLK 24.3466
Rtree_2776_21 sp__12083_X sp__2776_134 43.5638
Rtree_2776_22 sp__2776_134 sp__2776_138 21.8334
Rtree_2776_23 sp__2776_138 sp__2776_140 1.1845
Rtree_2776_24 sp__2776_140 sp__11848_CLK 20.6301
Rtree_2776_25 sp__2776_140 sp__2776_151 24.3054
Rtree_2776_26 sp__2776_151 sp__11856_CLK 45.4281
Rtree_2776_27 sp__2776_151 sp__11717_CLK 45.7371
Rtree_2776_28 sp__2776_138 sp__11719_CLK 20
Ctree_2776_2 sp__11717_CLK 0 4.32805e-16
Ctree_2776_3 sp__11856_CLK 0 5.21114e-16
Ctree_2776_4 sp__11848_CLK 0 1.14869e-16
Ctree_2776_5 sp__11029_CLK 0 3.7388e-16
Ctree_2776_9 sp__11847_CLK 0 4.71628e-16
Ctree_2776_12 sp__11718_CLK 0 1.40978e-16
Ctree_2776_14 sp__11660_CLK 0 1.3969e-16
Ctree_2776_15 sp__12083_X 0 8.02802e-16
Ctree_2776_16 sp__2776_151 0 1.12843e-15
Ctree_2776_17 sp__2776_140 0 4.02212e-16
Ctree_2776_18 sp__2776_138 0 2.75956e-16
Ctree_2776_19 sp__2776_134 0 3.78488e-16
Ctree_2776_20 sp__2776_111 0 6.68731e-16
Ctree_2776_21 sp__2776_100 0 6.68862e-16
Ctree_2776_22 sp__2776_65 0 3.41267e-16
Ctree_2776_23 sp__2776_59 0 9.09981e-16
Ctree_2776_24 sp__2776_43 0 3.94057e-16
Ctree_2776_25 sp__2776_35 0 9.74733e-16
Ctree_2776_26 sp__2776_29 0 1.22979e-15
Ctree_2776_27 sp__2776_18 0 6.38235e-16
Ctree_2776_28 sp__2776_12 0 9.34703e-16
Ctree_2776_29 sp__2776_10 0 3.99343e-16
Ctree_2776_30 sp__11029_CLK 0 5.01194e-16
Ctree_2776_34 sp__11717_CLK 0 5.87173e-16
Ctree_2776_36 sp__11717_CLK 0 6.12876e-16
Ctree_2776_37 sp__11718_CLK 0 1.54008e-17
Ctree_2776_43 sp__11848_CLK 0 7.91347e-17
Ctree_2776_45 sp__11856_CLK 0 4.66926e-16
Ctree_2776_46 sp__11856_CLK 0 7.91347e-17
Ctree_2776_48 sp__2776_10 0 2.6843e-16
Ctree_2776_49 sp__2776_12 0 2.34461e-16
Ctree_2776_53 sp__2776_29 0 9.01046e-16
Ctree_2776_54 sp__2776_29 0 6.07262e-16
Ctree_2776_59 sp__2776_35 0 2.89002e-16
Ctree_2776_60 sp__2776_35 0 2.09746e-16
Ctree_2776_62 sp__2776_43 0 4.47597e-16
Ctree_2776_64 sp__2776_59 0 3.70718e-16
Ctree_2776_66 sp__2776_65 0 1.29077e-16
Ctree_2776_67 sp__2776_65 0 8.51002e-16
Ctree_2776_68 sp__2776_65 0 4.77703e-16
Ctree_2776_70 sp__2776_65 0 3.93823e-16
Ctree_2776_71 sp__2776_65 0 7.12845e-16
Ctree_2776_78 sp__2776_134 0 7.65874e-16
Ctree_2776_81 sp__2776_138 0 2.58974e-16
Ctree_2776_83 sp__2776_140 0 1.61138e-16
Ctree_2776_84 sp__2776_151 0 9.26131e-16
Ctree_2776_85 sp__2776_151 0 9.2921e-16
Ctree_2776_90 sp__2776_43 0 4.67379e-16
Ctree_2776_94 sp__2776_43 0 4.67379e-16
Ctree_2776_98 sp__11856_CLK 0 1.76551e-16
Ctree_2776_99 sp__2776_134 0 1.81192e-16
Rtree_2777_1 sp__12084_X sp__2777_10 42.2763
Rtree_2777_2 sp__2777_10 sp__2777_14 22.575
Rtree_2777_3 sp__2777_14 sp__11754_CLK 20.5356
Rtree_2777_4 sp__2777_14 sp__2777_25 3.914
Rtree_2777_5 sp__2777_25 sp__2777_33 45.0882
Rtree_2777_6 sp__2777_33 sp__11679_CLK 20
Rtree_2777_7 sp__2777_33 sp__11588_CLK 22.4308
Rtree_2777_8 sp__2777_25 sp__11859_CLK 20
Rtree_2777_9 sp__2777_10 sp__2777_60 22.7527
Rtree_2777_10 sp__2777_60 sp__12105_A 20
Rtree_2777_11 sp__2777_60 sp__2777_77 25.1165
Rtree_2777_12 sp__2777_77 sp__2777_81 27.7662
Rtree_2777_13 sp__2777_81 sp__11864_CLK 20
Rtree_2777_14 sp__2777_81 sp__11591_CLK 22.266
Rtree_2777_15 sp__2777_77 sp__2777_97 2.8943
Rtree_2777_16 sp__2777_97 sp__11710_CLK 40.291
Rtree_2777_17 sp__2777_97 sp__2777_108 0.8446
Rtree_2777_18 sp__2777_108 sp__11861_CLK 42.0497
Rtree_2777_19 sp__2777_108 sp__2777_125 24.2333
Rtree_2777_20 sp__2777_125 sp__2777_129 2.8634
Rtree_2777_21 sp__2777_129 sp__11621_CLK 20.3502
Rtree_2777_22 sp__2777_129 sp__11858_CLK 21.8334
Rtree_2777_23 sp__2777_125 sp__11132_CLK 20
Rtree_2777_24 sp__12084_X sp__2777_163 48.0134
Rtree_2777_25 sp__2777_163 sp__2777_167 22.266
Rtree_2777_26 sp__2777_167 sp__2777_177 45.253
Rtree_2777_27 sp__2777_177 sp__11810_CLK 20
Rtree_2777_28 sp__2777_167 sp__11583_CLK 20
Rtree_2777_29 sp__2777_163 sp__11680_CLK 40.5974
Ctree_2777_1 sp__11680_CLK 0 4.53903e-17
Ctree_2777_5 sp__11858_CLK 0 1.90971e-16
Ctree_2777_6 sp__11621_CLK 0 2.68908e-17
Ctree_2777_7 sp__11861_CLK 0 1.85036e-16
Ctree_2777_8 sp__11710_CLK 0 3.02172e-17
Ctree_2777_9 sp__11591_CLK 0 2.46615e-16
Ctree_2777_13 sp__11588_CLK 0 2.35489e-16
Ctree_2777_15 sp__11754_CLK 0 5.50187e-17
Ctree_2777_16 sp__12084_X 0 1.06631e-15
Ctree_2777_17 sp__2777_177 0 3.28989e-16
Ctree_2777_18 sp__2777_167 0 5.38083e-16
Ctree_2777_19 sp__2777_163 0 1.02985e-15
Ctree_2777_20 sp__2777_129 0 4.82549e-16
Ctree_2777_21 sp__2777_125 0 6.34113e-16
Ctree_2777_22 sp__2777_108 0 6.38956e-16
Ctree_2777_23 sp__2777_97 0 3.26842e-16
Ctree_2777_24 sp__2777_81 0 1.05132e-15
Ctree_2777_25 sp__2777_77 0 1.50312e-15
Ctree_2777_26 sp__2777_60 0 7.63813e-16
Ctree_2777_27 sp__2777_33 0 6.40021e-16
Ctree_2777_28 sp__2777_25 0 7.69046e-16
Ctree_2777_29 sp__2777_14 0 7.60866e-16
Ctree_2777_30 sp__2777_10 0 9.0981e-16
Ctree_2777_36 sp__11680_CLK 0 1.28439e-16
Ctree_2777_38 sp__11710_CLK 0 4.35073e-17
Ctree_2777_42 sp__11861_CLK 0 3.05382e-16
Ctree_2777_45 sp__2777_10 0 1.75513e-16
Ctree_2777_50 sp__2777_25 0 4.02611e-16
Ctree_2777_51 sp__2777_25 0 1.75513e-16
Ctree_2777_53 sp__2777_33 0 6.06694e-16
Ctree_2777_60 sp__2777_97 0 4.20667e-16
Ctree_2777_64 sp__2777_125 0 2.08181e-16
Ctree_2777_65 sp__2777_125 0 2.40299e-16
Ctree_2777_67 sp__2777_129 0 1.22532e-16
Ctree_2777_70 sp__2777_163 0 1.27823e-16
Ctree_2777_71 sp__2777_163 0 4.97832e-16
Ctree_2777_72 sp__2777_163 0 3.04809e-16
Ctree_2777_74 sp__2777_167 0 3.22567e-16
Ctree_2777_76 sp__2777_177 0 2.40467e-16
Ctree_2777_77 sp__2777_177 0 7.18783e-16
Ctree_2777_80 sp__2777_81 0 1.2816e-16
Ctree_2777_81 sp__2777_81 0 3.40704e-16
Ctree_2777_82 sp__2777_77 0 2.09505e-16
Ctree_2777_90 sp__2777_177 0 7.18864e-16
Rtree_2778_1 sp__12085_X sp__2778_4 20
Rtree_2778_2 sp__2778_4 sp__2778_12 49.5378
Rtree_2778_3 sp__2778_12 sp__11700_CLK 20
Rtree_2778_4 sp__2778_4 sp__2778_19 1.8334
Rtree_2778_5 sp__2778_19 sp__11664_CLK 20
Rtree_2778_6 sp__2778_19 sp__2778_26 2.266
Rtree_2778_7 sp__2778_26 sp__2778_32 42.3278
Rtree_2778_8 sp__2778_32 sp__11493_CLK 20
Rtree_2778_9 sp__2778_26 sp__2778_41 21.8334
Rtree_2778_10 sp__2778_41 sp__2778_43 4.5526
Rtree_2778_11 sp__2778_43 sp__2778_45 2.0806
Rtree_2778_12 sp__2778_45 sp__2778_47 0.8446
Rtree_2778_13 sp__2778_47 sp__2778_53 27.313
Rtree_2778_14 sp__2778_53 sp__2778_63 4.5011
Rtree_2778_15 sp__2778_63 sp__2778_65 1.339
Rtree_2778_16 sp__2778_65 sp__2778_69 3.5747
Rtree_2778_17 sp__2778_69 sp__11551_CLK 20.3502
Rtree_2778_18 sp__2778_69 sp__11460_CLK 22.4308
Rtree_2778_19 sp__2778_65 sp__11484_CLK 21.1845
Rtree_2778_20 sp__2778_63 sp__11663_CLK 20.7519
Rtree_2778_21 sp__2778_53 sp__11626_CLK 20
Rtree_2778_22 sp__2778_47 sp__11752_CLK 42.266
Rtree_2778_23 sp__2778_45 sp__12153_A 41.8334
Rtree_2778_24 sp__2778_43 sp__11582_CLK 40
Rtree_2778_25 sp__2778_41 sp__2778_131 1.5862
Rtree_2778_26 sp__2778_131 sp__11753_CLK 46.1594
Rtree_2778_27 sp__2778_131 sp__2778_142 1.0918
Rtree_2778_28 sp__2778_142 sp__11580_CLK 40
Rtree_2778_29 sp__2778_142 sp__2778_151 2.0806
Rtree_2778_30 sp__2778_151 sp__11860_CLK 42.266
Rtree_2778_31 sp__2778_151 sp__11612_CLK 45.7886
Ctree_2778_1 sp__11612_CLK 0 2.35943e-16
Ctree_2778_2 sp__11860_CLK 0 2.15057e-16
Ctree_2778_4 sp__11753_CLK 0 5.59975e-16
Ctree_2778_6 sp__12153_A 0 1.78246e-16
Ctree_2778_7 sp__11752_CLK 0 2.3241e-16
Ctree_2778_9 sp__11663_CLK 0 5.09957e-17
Ctree_2778_10 sp__11484_CLK 0 1.02621e-16
Ctree_2778_11 sp__11460_CLK 0 2.56088e-16
Ctree_2778_12 sp__11551_CLK 0 2.77263e-17
Ctree_2778_17 sp__2778_151 0 5.30545e-16
Ctree_2778_18 sp__2778_142 0 1.42807e-16
Ctree_2778_19 sp__2778_131 0 7.51455e-16
Ctree_2778_20 sp__2778_69 0 6.36961e-16
Ctree_2778_21 sp__2778_65 0 5.6291e-16
Ctree_2778_22 sp__2778_63 0 5.89784e-16
Ctree_2778_23 sp__2778_53 0 1.11021e-15
Ctree_2778_24 sp__2778_47 0 9.43366e-16
Ctree_2778_25 sp__2778_45 0 3.34205e-16
Ctree_2778_26 sp__2778_43 0 6.10374e-16
Ctree_2778_27 sp__2778_41 0 8.20898e-16
Ctree_2778_28 sp__2778_32 0 2.80891e-16
Ctree_2778_29 sp__2778_26 0 7.01693e-16
Ctree_2778_30 sp__2778_19 0 3.82095e-16
Ctree_2778_31 sp__2778_12 0 9.76976e-16
Ctree_2778_32 sp__2778_4 0 1.14414e-15
Ctree_2778_35 sp__11484_CLK 0 3.23858e-17
Ctree_2778_36 sp__11484_CLK 0 8.0057e-17
Ctree_2778_37 sp__11612_CLK 0 4.78205e-16
Ctree_2778_38 sp__11612_CLK 0 7.6579e-16
Ctree_2778_39 sp__11612_CLK 0 1.22181e-15
Ctree_2778_41 sp__11752_CLK 0 1.54008e-17
Ctree_2778_42 sp__11752_CLK 0 3.39398e-16
Ctree_2778_43 sp__12153_A 0 1.54008e-17
Ctree_2778_45 sp__12153_A 0 2.72746e-16
Ctree_2778_46 sp__2778_12 0 5.97072e-16
Ctree_2778_52 sp__2778_41 0 1.54008e-17
Ctree_2778_54 sp__2778_43 0 1.28576e-16
Ctree_2778_56 sp__2778_43 0 1.27866e-16
Ctree_2778_59 sp__2778_45 0 4.47549e-16
Ctree_2778_61 sp__2778_45 0 1.59096e-16
Ctree_2778_62 sp__2778_47 0 1.81192e-16
Ctree_2778_63 sp__2778_47 0 1.59839e-16
Ctree_2778_65 sp__2778_53 0 3.41119e-16
Ctree_2778_66 sp__2778_53 0 3.41206e-16
Ctree_2778_71 sp__2778_69 0 1.12426e-16
Ctree_2778_73 sp__2778_131 0 2.65575e-16
Ctree_2778_74 sp__2778_131 0 7.51285e-17
Ctree_2778_76 sp__2778_142 0 5.34469e-17
Ctree_2778_77 sp__2778_142 0 1.81695e-16
Ctree_2778_79 sp__2778_142 0 7.52158e-17
Ctree_2778_80 sp__2778_151 0 4.48513e-16
Ctree_2778_81 sp__2778_151 0 4.26331e-16
Ctree_2778_83 sp__11860_CLK 0 3.38454e-16
Ctree_2778_84 sp__2778_12 0 1.30055e-16
Ctree_2778_85 sp__2778_12 0 3.94686e-16
Ctree_2778_86 sp__2778_19 0 1.43679e-16
Ctree_2778_88 sp__11663_CLK 0 1.12426e-16
Ctree_2778_89 sp__2778_63 0 4.77104e-17
Ctree_2778_91 sp__11753_CLK 0 5.32072e-16
Ctree_2778_93 sp__2778_19 0 2.7331e-16
Ctree_2778_94 sp__2778_26 0 3.15144e-16
Ctree_2778_97 sp__11753_CLK 0 9.19852e-16
Ctree_2778_98 sp__2778_12 0 4.52905e-16
Rtree_2779_1 sp__12086_X sp__2779_10 44.0376
Rtree_2779_2 sp__2779_10 sp__2779_14 1.9055
Rtree_2779_3 sp__2779_14 sp__2779_20 5.2221
Rtree_2779_4 sp__2779_20 sp__11694_CLK 43.4608
Rtree_2779_5 sp__2779_20 sp__2779_39 46.592
Rtree_2779_6 sp__2779_39 sp__11534_CLK 40.3502
Rtree_2779_7 sp__2779_39 sp__11422_CLK 42.4308
Rtree_2779_8 sp__2779_14 sp__11699_CLK 40.3193
Rtree_2779_9 sp__2779_10 sp__2779_72 21.4008
Rtree_2779_10 sp__2779_72 sp__11455_CLK 20
Rtree_2779_11 sp__2779_72 sp__2779_81 2.6471
Rtree_2779_12 sp__2779_81 sp__2779_89 44.1303
Rtree_2779_13 sp__2779_89 sp__11505_CLK 20
Rtree_2779_14 sp__2779_81 sp__11552_CLK 20.3193
Rtree_2779_15 sp__12086_X sp__2779_108 21.6171
Rtree_2779_16 sp__2779_108 sp__2779_112 2.1836
Rtree_2779_17 sp__2779_112 sp__2779_120 44.0994
Rtree_2779_18 sp__2779_120 sp__2779_124 2.4308
Rtree_2779_19 sp__2779_124 sp__2779_132 43.605
Rtree_2779_20 sp__2779_132 sp__11457_CLK 21.8334
Rtree_2779_21 sp__2779_132 sp__11533_CLK 20
Rtree_2779_22 sp__2779_124 sp__11697_CLK 20
Rtree_2779_23 sp__2779_120 sp__11464_CLK 20
Rtree_2779_24 sp__2779_112 sp__11586_CLK 20
Rtree_2779_25 sp__2779_108 sp__11695_CLK 20
Rtree_2779_26 sp__12086_X sp__2779_173 47.2718
Rtree_2779_27 sp__2779_173 sp__2779_175 20
Rtree_2779_28 sp__2779_175 sp__11456_CLK 22.0497
Rtree_2779_29 sp__2779_175 sp__2779_186 5.0573
Rtree_2779_30 sp__2779_186 sp__11549_CLK 20
Rtree_2779_31 sp__2779_186 sp__11504_CLK 22.4308
Ctree_2779_1 sp__11504_CLK 0 2.29441e-16
Ctree_2779_3 sp__11456_CLK 0 2.12602e-16
Ctree_2779_9 sp__11457_CLK 0 1.66764e-16
Ctree_2779_10 sp__11552_CLK 0 2.29856e-17
Ctree_2779_13 sp__11699_CLK 0 3.93886e-17
Ctree_2779_14 sp__11422_CLK 0 2.24791e-16
Ctree_2779_15 sp__11534_CLK 0 1.47335e-17
Ctree_2779_16 sp__11694_CLK 0 2.30258e-16
Ctree_2779_17 sp__12086_X 0 1.18848e-15
Ctree_2779_18 sp__2779_186 0 7.07793e-16
Ctree_2779_19 sp__2779_175 0 6.90954e-16
Ctree_2779_20 sp__2779_173 0 7.3122e-16
Ctree_2779_21 sp__2779_132 0 5.01105e-16
Ctree_2779_22 sp__2779_124 0 5.81239e-16
Ctree_2779_23 sp__2779_120 0 6.03325e-16
Ctree_2779_24 sp__2779_112 0 5.9331e-16
Ctree_2779_25 sp__2779_108 0 4.12751e-16
Ctree_2779_26 sp__2779_89 0 4.09801e-16
Ctree_2779_27 sp__2779_81 0 6.80913e-16
Ctree_2779_28 sp__2779_72 0 3.92479e-16
Ctree_2779_29 sp__2779_39 0 7.87531e-16
Ctree_2779_30 sp__2779_20 0 1.29838e-15
Ctree_2779_31 sp__2779_14 0 7.52052e-16
Ctree_2779_32 sp__2779_10 0 6.18294e-16
Ctree_2779_35 sp__11456_CLK 0 3.06287e-16
Ctree_2779_38 sp__11504_CLK 0 1.12096e-16
Ctree_2779_41 sp__11694_CLK 0 3.92207e-16
Ctree_2779_43 sp__2779_10 0 5.47275e-16
Ctree_2779_45 sp__2779_20 0 2.34224e-16
Ctree_2779_48 sp__2779_20 0 1.59043e-16
Ctree_2779_51 sp__2779_39 0 6.0613e-16
Ctree_2779_53 sp__2779_39 0 9.33677e-16
Ctree_2779_54 sp__2779_89 0 4.44197e-16
Ctree_2779_56 sp__2779_120 0 1.54446e-17
Ctree_2779_58 sp__2779_120 0 3.90334e-16
Ctree_2779_63 sp__2779_132 0 2.87204e-16
Ctree_2779_70 sp__2779_186 0 5.8e-16
Ctree_2779_71 sp__2779_186 0 4.78524e-17
Ctree_2779_77 sp__11504_CLK 0 1.44018e-16
Ctree_2779_79 sp__11457_CLK 0 2.73671e-16
Ctree_2779_80 sp__2779_10 0 1.45031e-16
Ctree_2779_81 sp__2779_89 0 3.0522e-16
Ctree_2779_84 sp__2779_173 0 2.3464e-16
Ctree_2779_87 sp__11552_CLK 0 4.78195e-17
Ctree_2779_89 sp__2779_81 0 3.05352e-16
Ctree_2779_91 sp__2779_120 0 3.38206e-16
Ctree_2779_93 sp__2779_10 0 1.45031e-16
Ctree_2779_94 sp__2779_108 0 4.76068e-17
Ctree_2779_98 sp__11694_CLK 0 3.92207e-16
Ctree_2779_99 sp__2779_20 0 2.19989e-17
Ctree_2779_104 sp__11422_CLK 0 1.06392e-16
Ctree_2779_105 sp__11534_CLK 0 7.4933e-17
Ctree_2779_106 sp__11422_CLK 0 1.27878e-16
Ctree_2779_107 sp__11534_CLK 0 7.47964e-17
Rtree_2780_1 sp__12087_X sp__2780_6 40
Rtree_2780_2 sp__2780_6 sp__2780_10 23.3166
Rtree_2780_3 sp__2780_10 sp__2780_12 2.6986
Rtree_2780_4 sp__2780_12 sp__2780_18 43.0694
Rtree_2780_5 sp__2780_18 sp__11386_CLK 20
Rtree_2780_6 sp__2780_12 sp__2780_29 4.6968
Rtree_2780_7 sp__2780_29 sp__11530_CLK 20
Rtree_2780_8 sp__2780_29 sp__11492_CLK 21.902
Rtree_2780_9 sp__2780_10 sp__12152_A 21.4008
Rtree_2780_10 sp__2780_6 sp__2780_52 0.5974
Rtree_2780_11 sp__2780_52 sp__2780_56 21.4008
Rtree_2780_12 sp__2780_56 sp__2780_62 41.339
Rtree_2780_13 sp__2780_62 sp__11488_CLK 20
Rtree_2780_14 sp__2780_56 sp__2780_69 2.266
Rtree_2780_15 sp__2780_69 sp__11630_CLK 20
Rtree_2780_16 sp__2780_69 sp__2780_82 26.9216
Rtree_2780_17 sp__2780_82 sp__11526_CLK 41.5862
Rtree_2780_18 sp__2780_82 sp__2780_95 25.5414
Rtree_2780_19 sp__2780_95 sp__2780_97 1.1822
Rtree_2780_20 sp__2780_97 sp__11645_CLK 23.4608
Rtree_2780_21 sp__2780_97 sp__11652_CLK 20
Rtree_2780_22 sp__2780_95 sp__11646_CLK 20
Rtree_2780_23 sp__2780_52 sp__2780_120 4.0582
Rtree_2780_24 sp__2780_120 sp__2780_126 23.296
Rtree_2780_25 sp__2780_126 sp__2780_128 1.7454
Rtree_2780_26 sp__2780_128 sp__2780_132 3.3578
Rtree_2780_27 sp__2780_132 sp__2780_142 46.6744
Rtree_2780_28 sp__2780_142 sp__11691_CLK 20
Rtree_2780_29 sp__2780_132 sp__11670_CLK 22.0012
Rtree_2780_30 sp__2780_132 sp__11487_CLK 20
Rtree_2780_31 sp__2780_128 sp__11651_CLK 20
Rtree_2780_32 sp__2780_126 sp__11665_CLK 20
Rtree_2780_33 sp__2780_120 sp__11657_CLK 41.133
Ctree_2780_1 sp__11657_CLK 0 6.94978e-17
Ctree_2780_5 sp__11670_CLK 0 2.34993e-16
Ctree_2780_9 sp__11645_CLK 0 3.13432e-16
Ctree_2780_10 sp__11526_CLK 0 9.99513e-17
Ctree_2780_13 sp__12152_A 0 1.55553e-16
Ctree_2780_14 sp__11492_CLK 0 1.85897e-16
Ctree_2780_18 sp__2780_142 0 6.40051e-16
Ctree_2780_19 sp__2780_132 0 1.14064e-15
Ctree_2780_20 sp__2780_128 0 4.56563e-16
Ctree_2780_21 sp__2780_126 0 4.70766e-16
Ctree_2780_22 sp__2780_120 0 5.26573e-16
Ctree_2780_23 sp__2780_97 0 5.23364e-16
Ctree_2780_24 sp__2780_95 0 4.90145e-16
Ctree_2780_25 sp__2780_82 0 1.01511e-15
Ctree_2780_26 sp__2780_69 0 8.3958e-16
Ctree_2780_27 sp__2780_62 0 6.37969e-17
Ctree_2780_28 sp__2780_56 0 3.88685e-16
Ctree_2780_29 sp__2780_52 0 3.2144e-16
Ctree_2780_30 sp__2780_29 0 7.20954e-16
Ctree_2780_31 sp__2780_18 0 2.85297e-16
Ctree_2780_32 sp__2780_12 0 1.10783e-15
Ctree_2780_33 sp__2780_10 0 6.02825e-16
Ctree_2780_34 sp__2780_6 0 1.83705e-16
Ctree_2780_35 sp__11492_CLK 0 2.08271e-16
Ctree_2780_36 sp__11492_CLK 0 2.08271e-16
Ctree_2780_37 sp__11526_CLK 0 1.8387e-16
Ctree_2780_40 sp__11657_CLK 0 1.05719e-16
Ctree_2780_41 sp__11657_CLK 0 1.27744e-16
Ctree_2780_46 sp__2780_10 0 1.81192e-16
Ctree_2780_47 sp__2780_10 0 4.46767e-16
Ctree_2780_48 sp__2780_10 0 7.13173e-16
Ctree_2780_51 sp__2780_12 0 1.12651e-16
Ctree_2780_53 sp__2780_12 0 8.00842e-17
Ctree_2780_55 sp__2780_29 0 1.54556e-17
Ctree_2780_59 sp__2780_29 0 1.80959e-17
Ctree_2780_61 sp__2780_52 0 1.05753e-16
Ctree_2780_62 sp__2780_52 0 1.2785e-16
Ctree_2780_63 sp__2780_56 0 2.08063e-16
Ctree_2780_64 sp__2780_56 0 2.08063e-16
Ctree_2780_65 sp__2780_62 0 7.33225e-17
Ctree_2780_66 sp__2780_62 0 2.11363e-16
Ctree_2780_67 sp__2780_62 0 2.84685e-16
Ctree_2780_68 sp__2780_69 0 4.77425e-17
Ctree_2780_70 sp__2780_69 0 3.22883e-16
Ctree_2780_71 sp__2780_82 0 2.41089e-16
Ctree_2780_72 sp__2780_82 0 4.77425e-17
Ctree_2780_74 sp__2780_82 0 3.23417e-17
Ctree_2780_76 sp__2780_82 0 2.72538e-16
Ctree_2780_77 sp__2780_95 0 1.04877e-16
Ctree_2780_80 sp__2780_120 0 8.45899e-16
Ctree_2780_81 sp__2780_120 0 8.67685e-16
Ctree_2780_85 sp__2780_132 0 3.22161e-16
Ctree_2780_89 sp__2780_142 0 1.122e-16
Ctree_2780_90 sp__2780_142 0 1.54556e-17
Ctree_2780_91 sp__2780_142 0 5.53763e-16
Ctree_2780_92 sp__2780_142 0 1.28576e-16
Ctree_2780_94 sp__2780_82 0 2.72538e-16
Ctree_2780_95 sp__2780_142 0 1.54008e-17
Ctree_2780_98 sp__2780_126 0 4.01841e-16
Ctree_2780_99 sp__2780_82 0 1.75513e-16
Ctree_2780_100 sp__2780_95 0 8.27954e-16
Ctree_2780_101 sp__11526_CLK 0 3.45714e-16
Ctree_2780_102 sp__2780_95 0 1.20222e-15
Ctree_2780_103 sp__2780_18 0 3.40704e-16
Ctree_2780_104 sp__2780_12 0 7.91262e-17
Rtree_2781_1 sp__12088_X sp__2781_6 22.0497
Rtree_2781_2 sp__2781_6 sp__2781_8 1.4008
Rtree_2781_3 sp__2781_8 sp__2781_16 25.4384
Rtree_2781_4 sp__2781_16 sp__11634_CLK 42.266
Rtree_2781_5 sp__2781_16 sp__11726_CLK 41.8334
Rtree_2781_6 sp__2781_8 sp__12125_A 20
Rtree_2781_7 sp__2781_6 sp__2781_43 22.575
Rtree_2781_8 sp__2781_43 sp__2781_51 27.4778
Rtree_2781_9 sp__2781_51 sp__2781_61 42.0085
Rtree_2781_10 sp__2781_61 sp__11765_CLK 21.8437
Rtree_2781_11 sp__2781_61 sp__11587_CLK 22.8531
Rtree_2781_12 sp__2781_51 sp__11467_CLK 20
Rtree_2781_13 sp__2781_43 sp__2781_86 20.5356
Rtree_2781_14 sp__2781_86 sp__11696_CLK 21.0918
Rtree_2781_15 sp__2781_86 sp__2781_95 6.1594
Rtree_2781_16 sp__2781_95 sp__11550_CLK 20
Rtree_2781_17 sp__2781_95 sp__11662_CLK 22.678
Rtree_2781_18 sp__12088_X sp__2781_118 42.575
Rtree_2781_19 sp__2781_118 sp__2781_122 21.8334
Rtree_2781_20 sp__2781_122 sp__11592_CLK 26.5096
Rtree_2781_21 sp__2781_122 sp__11811_CLK 20.5974
Rtree_2781_22 sp__2781_118 sp__2781_142 21.339
Rtree_2781_23 sp__2781_142 sp__2781_144 2.266
Rtree_2781_24 sp__2781_144 sp__11585_CLK 20.3502
Rtree_2781_25 sp__2781_144 sp__11813_CLK 22.5338
Rtree_2781_26 sp__2781_142 sp__11661_CLK 20
Ctree_2781_2 sp__11813_CLK 0 2.05448e-16
Ctree_2781_3 sp__11585_CLK 0 2.73888e-17
Ctree_2781_4 sp__11811_CLK 0 4.95132e-17
Ctree_2781_5 sp__11592_CLK 0 5.99033e-16
Ctree_2781_6 sp__11662_CLK 0 2.59302e-16
Ctree_2781_8 sp__11696_CLK 0 8.64409e-17
Ctree_2781_10 sp__11587_CLK 0 3.18518e-16
Ctree_2781_11 sp__11765_CLK 0 2.17322e-16
Ctree_2781_13 sp__11726_CLK 0 1.54371e-16
Ctree_2781_14 sp__11634_CLK 0 2.53087e-16
Ctree_2781_15 sp__12088_X 0 4.61148e-16
Ctree_2781_16 sp__2781_144 0 4.75608e-16
Ctree_2781_17 sp__2781_142 0 3.58069e-16
Ctree_2781_18 sp__2781_122 0 8.19669e-16
Ctree_2781_19 sp__2781_118 0 5.19783e-16
Ctree_2781_20 sp__2781_95 0 8.85992e-16
Ctree_2781_21 sp__2781_86 0 7.63446e-16
Ctree_2781_22 sp__2781_61 0 7.59801e-16
Ctree_2781_23 sp__2781_51 0 9.07831e-16
Ctree_2781_24 sp__2781_43 0 8.90057e-16
Ctree_2781_25 sp__2781_16 0 9.22726e-16
Ctree_2781_26 sp__2781_8 0 6.80413e-16
Ctree_2781_27 sp__2781_6 0 5.48802e-16
Ctree_2781_32 sp__11592_CLK 0 9.21819e-16
Ctree_2781_43 sp__11726_CLK 0 3.95052e-16
Ctree_2781_47 sp__11813_CLK 0 2.72216e-16
Ctree_2781_53 sp__2781_16 0 2.32418e-16
Ctree_2781_54 sp__2781_16 0 4.98774e-16
Ctree_2781_56 sp__2781_43 0 2.33917e-16
Ctree_2781_58 sp__2781_51 0 7.9703e-17
Ctree_2781_65 sp__2781_86 0 8.00842e-17
Ctree_2781_66 sp__2781_95 0 2.40773e-16
Ctree_2781_67 sp__2781_95 0 8.0216e-17
Ctree_2781_71 sp__2781_95 0 1.54008e-17
Ctree_2781_73 sp__2781_118 0 5.51697e-16
Ctree_2781_76 sp__2781_122 0 2.73074e-16
Ctree_2781_77 sp__2781_142 0 2.66746e-16
Ctree_2781_78 sp__2781_144 0 2.08768e-16
Ctree_2781_81 sp__11587_CLK 0 4.77425e-17
Ctree_2781_91 sp__2781_43 0 5.50675e-16
Ctree_2781_92 sp__2781_51 0 7.13588e-16
Ctree_2781_95 sp__2781_95 0 2.42018e-16
Rtree_2782_1 sp__12089_X sp__2782_8 41.6171
Rtree_2782_2 sp__2782_8 sp__2782_10 0.8446
Rtree_2782_3 sp__2782_10 sp__2782_16 24.3775
Rtree_2782_4 sp__2782_16 sp__11609_CLK 20.3502
Rtree_2782_5 sp__2782_16 sp__2782_25 1.4008
Rtree_2782_6 sp__2782_25 sp__11426_CLK 26.9422
Rtree_2782_7 sp__2782_25 sp__2782_42 43.0256
Rtree_2782_8 sp__2782_42 sp__11482_CLK 20
Rtree_2782_9 sp__2782_10 sp__12124_A 40.3193
Rtree_2782_10 sp__2782_8 sp__2782_60 23.0694
Rtree_2782_11 sp__2782_60 sp__2782_62 1.8334
Rtree_2782_12 sp__2782_62 sp__2782_64 2.0497
Rtree_2782_13 sp__2782_64 sp__11553_CLK 20
Rtree_2782_14 sp__2782_64 sp__11495_CLK 24.6968
Rtree_2782_15 sp__2782_62 sp__2782_88 41.9055
Rtree_2782_16 sp__2782_88 sp__11635_CLK 20
Rtree_2782_17 sp__2782_60 sp__2782_99 21.7819
Rtree_2782_18 sp__2782_99 sp__2782_103 22.7616
Rtree_2782_19 sp__2782_103 sp__11675_CLK 20
Rtree_2782_20 sp__2782_103 sp__2782_112 2.678
Rtree_2782_21 sp__2782_112 sp__11735_CLK 20
Rtree_2782_22 sp__2782_112 sp__2782_129 24.4599
Rtree_2782_23 sp__2782_129 sp__2782_131 3.811
Rtree_2782_24 sp__2782_131 sp__2782_133 3.5638
Rtree_2782_25 sp__2782_133 sp__11687_CLK 40.8446
Rtree_2782_26 sp__2782_133 sp__2782_146 21.8334
Rtree_2782_27 sp__2782_146 sp__11640_CLK 22.8634
Rtree_2782_28 sp__2782_146 sp__2782_161 43.3166
Rtree_2782_29 sp__2782_161 sp__11548_CLK 20
Rtree_2782_30 sp__2782_131 sp__11466_CLK 42.266
Rtree_2782_31 sp__2782_129 sp__11611_CLK 44.4084
Rtree_2782_32 sp__2782_99 sp__2782_190 21.5862
Rtree_2782_33 sp__2782_190 sp__11469_CLK 20.9682
Rtree_2782_34 sp__2782_190 sp__11494_CLK 21.5656
Ctree_2782_1 sp__11494_CLK 0 1.72182e-16
Ctree_2782_2 sp__11469_CLK 0 9.22781e-17
Ctree_2782_3 sp__11611_CLK 0 3.59964e-16
Ctree_2782_4 sp__11466_CLK 0 2.35138e-16
Ctree_2782_6 sp__11640_CLK 0 2.88768e-16
Ctree_2782_7 sp__11687_CLK 0 7.32639e-17
Ctree_2782_11 sp__11495_CLK 0 4.67743e-16
Ctree_2782_13 sp__12124_A 0 2.43946e-17
Ctree_2782_15 sp__11426_CLK 0 6.91914e-16
Ctree_2782_16 sp__11609_CLK 0 2.77263e-17
Ctree_2782_17 sp__12089_X 0 1.42082e-16
Ctree_2782_18 sp__2782_190 0 3.73976e-16
Ctree_2782_19 sp__2782_161 0 1.28056e-16
Ctree_2782_20 sp__2782_146 0 5.77454e-16
Ctree_2782_21 sp__2782_133 0 4.04833e-16
Ctree_2782_22 sp__2782_131 0 7.21172e-16
Ctree_2782_23 sp__2782_129 0 1.1102e-15
Ctree_2782_24 sp__2782_112 0 7.12297e-16
Ctree_2782_25 sp__2782_103 0 5.83033e-16
Ctree_2782_26 sp__2782_99 0 5.82623e-16
Ctree_2782_27 sp__2782_88 0 1.18534e-16
Ctree_2782_28 sp__2782_64 0 6.72997e-16
Ctree_2782_29 sp__2782_62 0 4.98606e-16
Ctree_2782_30 sp__2782_60 0 5.41118e-16
Ctree_2782_31 sp__2782_42 0 1.55658e-16
Ctree_2782_32 sp__2782_25 0 1.00408e-15
Ctree_2782_33 sp__2782_16 0 5.97469e-16
Ctree_2782_34 sp__2782_10 0 4.85741e-16
Ctree_2782_35 sp__2782_8 0 3.89269e-16
Ctree_2782_36 sp__11426_CLK 0 1.4431e-16
Ctree_2782_41 sp__11466_CLK 0 4.77425e-17
Ctree_2782_42 sp__11466_CLK 0 1.76188e-16
Ctree_2782_46 sp__11469_CLK 0 1.43465e-16
Ctree_2782_49 sp__11495_CLK 0 1.76704e-16
Ctree_2782_53 sp__11611_CLK 0 3.17852e-16
Ctree_2782_54 sp__11611_CLK 0 1.75513e-16
Ctree_2782_55 sp__11611_CLK 0 1.79321e-16
Ctree_2782_58 sp__11611_CLK 0 6.81124e-17
Ctree_2782_59 sp__11640_CLK 0 1.54008e-17
Ctree_2782_62 sp__11687_CLK 0 7.51285e-17
Ctree_2782_65 sp__2782_8 0 2.41407e-16
Ctree_2782_69 sp__2782_42 0 5.44517e-16
Ctree_2782_71 sp__2782_42 0 5.44517e-16
Ctree_2782_76 sp__2782_88 0 3.94166e-16
Ctree_2782_77 sp__2782_99 0 1.44117e-16
Ctree_2782_78 sp__2782_99 0 1.30055e-16
Ctree_2782_80 sp__2782_103 0 1.43938e-16
Ctree_2782_83 sp__2782_112 0 1.54008e-17
Ctree_2782_87 sp__2782_129 0 3.23417e-17
Ctree_2782_88 sp__2782_129 0 3.38779e-16
Ctree_2782_90 sp__2782_129 0 4.77699e-17
Ctree_2782_92 sp__2782_131 0 1.81192e-16
Ctree_2782_94 sp__2782_133 0 3.94151e-16
Ctree_2782_95 sp__2782_133 0 1.59096e-16
Ctree_2782_96 sp__2782_133 0 5.0063e-16
Ctree_2782_97 sp__2782_133 0 1.59096e-16
Ctree_2782_98 sp__2782_146 0 2.7343e-16
Ctree_2782_99 sp__2782_146 0 1.76405e-16
Ctree_2782_100 sp__2782_161 0 7.15662e-16
Ctree_2782_101 sp__2782_161 0 7.15662e-16
Ctree_2782_102 sp__2782_190 0 3.4502e-16
Ctree_2782_105 sp__2782_129 0 1.54008e-17
Ctree_2782_108 sp__11611_CLK 0 2.35075e-16
Ctree_2782_109 sp__2782_131 0 1.06082e-16
Ctree_2782_110 sp__2782_133 0 1.81695e-16
Ctree_2782_111 sp__2782_131 0 2.8427e-16
Ctree_2782_113 sp__2782_131 0 2.85628e-16
Ctree_2782_114 sp__11426_CLK 0 1.11326e-16
Rtree_2783_1 sp__12090_X sp__2783_4 20
Rtree_2783_2 sp__2783_4 sp__2783_10 2.9011
Rtree_2783_3 sp__2783_10 sp__11483_CLK 20.5974
Rtree_2783_4 sp__2783_10 sp__2783_21 22.266
Rtree_2783_5 sp__2783_21 sp__2783_23 3.3166
Rtree_2783_6 sp__2783_23 sp__2783_25 0.5974
Rtree_2783_7 sp__2783_25 sp__2783_27 0.8446
Rtree_2783_8 sp__2783_27 sp__2783_29 5.5414
Rtree_2783_9 sp__2783_29 sp__11606_CLK 44.3054
Rtree_2783_10 sp__2783_29 sp__11512_CLK 40
Rtree_2783_11 sp__2783_27 sp__12154_A 42.266
Rtree_2783_12 sp__2783_25 sp__2783_64 21.8334
Rtree_2783_13 sp__2783_64 sp__2783_68 4.5938
Rtree_2783_14 sp__2783_68 sp__2783_76 4.0582
Rtree_2783_15 sp__2783_76 sp__2783_82 46.7774
Rtree_2783_16 sp__2783_82 sp__11508_CLK 20
Rtree_2783_17 sp__2783_76 sp__11507_CLK 20
Rtree_2783_18 sp__2783_68 sp__11425_CLK 20
Rtree_2783_19 sp__2783_64 sp__11547_CLK 20
Rtree_2783_20 sp__2783_23 sp__11607_CLK 40
Rtree_2783_21 sp__2783_21 sp__11608_CLK 43.5638
Rtree_2783_22 sp__2783_4 sp__2783_120 1.6171
Rtree_2783_23 sp__2783_120 sp__2783_124 21.5518
Rtree_2783_24 sp__2783_124 sp__2783_126 1.0918
Rtree_2783_25 sp__2783_126 sp__11506_CLK 42.3278
Rtree_2783_26 sp__2783_126 sp__11598_CLK 42.266
Rtree_2783_27 sp__2783_124 sp__2783_146 3.811
Rtree_2783_28 sp__2783_146 sp__11468_CLK 40
Rtree_2783_29 sp__2783_146 sp__2783_159 26.1388
Rtree_2783_30 sp__2783_159 sp__11465_CLK 22.266
Rtree_2783_31 sp__2783_159 sp__11734_CLK 20.5974
Rtree_2783_32 sp__2783_120 sp__11683_CLK 20.3502
Ctree_2783_1 sp__11683_CLK 0 2.36489e-17
Ctree_2783_2 sp__11734_CLK 0 4.72978e-17
Ctree_2783_3 sp__11465_CLK 0 2.35051e-16
Ctree_2783_5 sp__11598_CLK 0 1.82592e-16
Ctree_2783_6 sp__11506_CLK 0 2.04597e-16
Ctree_2783_7 sp__11608_CLK 0 3.11045e-16
Ctree_2783_13 sp__12154_A 0 2.05964e-16
Ctree_2783_15 sp__11606_CLK 0 4.48896e-16
Ctree_2783_16 sp__11483_CLK 0 4.73699e-17
Ctree_2783_18 sp__2783_159 0 8.28195e-16
Ctree_2783_19 sp__2783_146 0 8.83478e-16
Ctree_2783_20 sp__2783_126 0 4.86608e-16
Ctree_2783_21 sp__2783_124 0 6.28033e-16
Ctree_2783_22 sp__2783_120 0 3.78623e-16
Ctree_2783_23 sp__2783_82 0 2.86559e-16
Ctree_2783_24 sp__2783_76 0 6.459e-16
Ctree_2783_25 sp__2783_68 0 8.28723e-16
Ctree_2783_26 sp__2783_64 0 6.53671e-16
Ctree_2783_27 sp__2783_29 0 7.6847e-16
Ctree_2783_28 sp__2783_27 0 5.91373e-16
Ctree_2783_29 sp__2783_25 0 2.9624e-16
Ctree_2783_30 sp__2783_23 0 3.22852e-16
Ctree_2783_31 sp__2783_21 0 8.4166e-16
Ctree_2783_32 sp__2783_10 0 6.01797e-16
Ctree_2783_33 sp__2783_4 0 4.64542e-16
Ctree_2783_38 sp__11598_CLK 0 3.38756e-16
Ctree_2783_39 sp__11598_CLK 0 3.38756e-16
Ctree_2783_43 sp__11606_CLK 0 1.84117e-16
Ctree_2783_44 sp__11608_CLK 0 7.75951e-16
Ctree_2783_46 sp__12154_A 0 1.54008e-17
Ctree_2783_47 sp__12154_A 0 3.38377e-16
Ctree_2783_48 sp__2783_10 0 1.75859e-16
Ctree_2783_51 sp__2783_21 0 4.79124e-17
Ctree_2783_53 sp__2783_23 0 7.24014e-16
Ctree_2783_54 sp__2783_25 0 1.30012e-16
Ctree_2783_55 sp__2783_27 0 1.83978e-16
Ctree_2783_56 sp__2783_29 0 5.58018e-16
Ctree_2783_57 sp__2783_29 0 1.1306e-15
Ctree_2783_58 sp__2783_64 0 2.08041e-16
Ctree_2783_64 sp__2783_82 0 4.49759e-16
Ctree_2783_66 sp__2783_82 0 8.76918e-16
Ctree_2783_67 sp__2783_82 0 1.46285e-15
Ctree_2783_72 sp__2783_146 0 4.98917e-16
Ctree_2783_74 sp__2783_159 0 1.81192e-16
Ctree_2783_75 sp__2783_159 0 1.54008e-17
Ctree_2783_76 sp__2783_159 0 2.13286e-16
Ctree_2783_77 sp__2783_159 0 1.60013e-16
Ctree_2783_78 sp__2783_159 0 3.72054e-16
Ctree_2783_85 sp__2783_124 0 1.11839e-16
Ctree_2783_86 sp__11506_CLK 0 4.99852e-16
Ctree_2783_87 sp__2783_126 0 2.31653e-16
Ctree_2783_88 sp__2783_146 0 2.87256e-16
Rtree_2784_1 sp__12091_X sp__2784_10 22.3175
Rtree_2784_2 sp__2784_10 sp__2784_14 21.8334
Rtree_2784_3 sp__2784_14 sp__2784_16 2.575
Rtree_2784_4 sp__2784_16 sp__2784_22 27.1276
Rtree_2784_5 sp__2784_22 sp__11674_CLK 20
Rtree_2784_6 sp__2784_22 sp__11405_CLK 22.266
Rtree_2784_7 sp__2784_16 sp__11420_CLK 40
Rtree_2784_8 sp__2784_14 sp__2784_53 31.948
Rtree_2784_9 sp__2784_53 sp__2784_59 46.7774
Rtree_2784_10 sp__2784_59 sp__11480_CLK 20
Rtree_2784_11 sp__2784_53 sp__11481_CLK 20
Rtree_2784_12 sp__2784_10 sp__11559_CLK 20
Rtree_2784_13 sp__12091_X sp__2784_81 22.266
Rtree_2784_14 sp__2784_81 sp__11731_CLK 20
Rtree_2784_15 sp__2784_81 sp__2784_96 43.9552
Rtree_2784_16 sp__2784_96 sp__11637_CLK 20
Rtree_2784_17 sp__2784_96 sp__2784_105 23.9964
Rtree_2784_18 sp__2784_105 sp__2784_107 1.5862
Rtree_2784_19 sp__2784_107 sp__2784_115 24.944
Rtree_2784_20 sp__2784_115 sp__2784_123 46.8186
Rtree_2784_21 sp__2784_123 sp__11458_CLK 20
Rtree_2784_22 sp__2784_115 sp__11766_CLK 20
Rtree_2784_23 sp__2784_107 sp__11685_CLK 42.266
Rtree_2784_24 sp__2784_105 sp__2784_144 0.5974
Rtree_2784_25 sp__2784_144 sp__11459_CLK 40
Rtree_2784_26 sp__2784_144 sp__2784_153 1.0918
Rtree_2784_27 sp__2784_153 sp__11756_CLK 45.7268
Rtree_2784_28 sp__2784_153 sp__2784_166 23.0694
Rtree_2784_29 sp__2784_166 sp__2784_174 25.6856
Rtree_2784_30 sp__2784_174 sp__11686_CLK 40
Rtree_2784_31 sp__2784_174 sp__11767_CLK 45.0882
Rtree_2784_32 sp__2784_166 sp__11568_CLK 21.726
Ctree_2784_1 sp__11568_CLK 0 2.12785e-16
Ctree_2784_2 sp__11767_CLK 0 5.2882e-16
Ctree_2784_4 sp__11756_CLK 0 6.20474e-16
Ctree_2784_6 sp__11685_CLK 0 2.41011e-16
Ctree_2784_15 sp__11405_CLK 0 2.44916e-16
Ctree_2784_17 sp__12091_X 0 5.27367e-16
Ctree_2784_18 sp__2784_174 0 9.88801e-16
Ctree_2784_19 sp__2784_166 0 7.94855e-16
Ctree_2784_20 sp__2784_153 0 8.03267e-16
Ctree_2784_21 sp__2784_144 0 1.05204e-16
Ctree_2784_22 sp__2784_123 0 5.58177e-16
Ctree_2784_23 sp__2784_115 0 1.05665e-15
Ctree_2784_24 sp__2784_107 0 8.27281e-16
Ctree_2784_25 sp__2784_105 0 5.1146e-16
Ctree_2784_26 sp__2784_96 0 7.99812e-16
Ctree_2784_27 sp__2784_81 0 7.01593e-16
Ctree_2784_28 sp__2784_59 0 3.92832e-16
Ctree_2784_29 sp__2784_53 0 1.56782e-15
Ctree_2784_30 sp__2784_22 0 6.84689e-16
Ctree_2784_31 sp__2784_16 0 7.23313e-16
Ctree_2784_32 sp__2784_14 0 1.64148e-15
Ctree_2784_33 sp__2784_10 0 4.29366e-16
Ctree_2784_39 sp__11685_CLK 0 1.54008e-17
Ctree_2784_44 sp__11756_CLK 0 1.12096e-16
Ctree_2784_47 sp__11756_CLK 0 7.91362e-17
Ctree_2784_52 sp__11767_CLK 0 4.77425e-17
Ctree_2784_53 sp__11767_CLK 0 7.48178e-17
Ctree_2784_59 sp__2784_16 0 7.65281e-17
Ctree_2784_60 sp__2784_22 0 4.84847e-16
Ctree_2784_61 sp__2784_22 0 6.62676e-16
Ctree_2784_63 sp__2784_22 0 1.04171e-15
Ctree_2784_64 sp__2784_53 0 4.99458e-16
Ctree_2784_67 sp__2784_59 0 1.46528e-15
Ctree_2784_68 sp__2784_59 0 8.21899e-16
Ctree_2784_74 sp__2784_105 0 1.12426e-16
Ctree_2784_76 sp__2784_107 0 2.12127e-16
Ctree_2784_77 sp__2784_107 0 3.40288e-16
Ctree_2784_78 sp__2784_115 0 2.40459e-16
Ctree_2784_79 sp__2784_115 0 1.43937e-16
Ctree_2784_80 sp__2784_115 0 8.00842e-17
Ctree_2784_82 sp__2784_115 0 1.28662e-16
Ctree_2784_84 sp__2784_115 0 1.2816e-16
Ctree_2784_85 sp__2784_123 0 4.99799e-16
Ctree_2784_86 sp__2784_123 0 4.98057e-16
Ctree_2784_87 sp__2784_123 0 3.36958e-16
Ctree_2784_90 sp__2784_144 0 1.28576e-16
Ctree_2784_91 sp__2784_153 0 1.28663e-16
Ctree_2784_92 sp__2784_153 0 2.34726e-16
Ctree_2784_93 sp__2784_166 0 6.38372e-16
Ctree_2784_94 sp__2784_166 0 6.60141e-16
Ctree_2784_99 sp__2784_174 0 6.61058e-16
Ctree_2784_105 sp__2784_174 0 2.09664e-16
Ctree_2784_106 sp__11756_CLK 0 1.1233e-16
Ctree_2784_107 sp__2784_123 0 1.81192e-16
Ctree_2784_113 sp__2784_123 0 3.37055e-16
Rtree_2785_1 sp__12092_X sp__2785_10 43.9449
Rtree_2785_2 sp__2785_10 sp__2785_12 1.8334
Rtree_2785_3 sp__2785_12 sp__2785_16 22.266
Rtree_2785_4 sp__2785_16 sp__2785_24 44.6556
Rtree_2785_5 sp__2785_24 sp__11693_CLK 20
Rtree_2785_6 sp__2785_16 sp__11567_CLK 20
Rtree_2785_7 sp__2785_12 sp__2785_38 3.605
Rtree_2785_8 sp__2785_38 sp__11571_CLK 42.7192
Rtree_2785_9 sp__2785_38 sp__2785_55 21.4008
Rtree_2785_10 sp__2785_55 sp__2785_59 2.6162
Rtree_2785_11 sp__2785_59 sp__2785_61 1.8334
Rtree_2785_12 sp__2785_61 sp__11703_CLK 20
Rtree_2785_13 sp__2785_61 sp__2785_70 2.8634
Rtree_2785_14 sp__2785_70 sp__11701_CLK 20
Rtree_2785_15 sp__2785_70 sp__2785_79 21.8334
Rtree_2785_16 sp__2785_79 sp__2785_81 2.8222
Rtree_2785_17 sp__2785_81 sp__12155_A 46.283
Rtree_2785_18 sp__2785_81 sp__11706_CLK 40
Rtree_2785_19 sp__2785_79 sp__2785_105 1.0918
Rtree_2785_20 sp__2785_105 sp__2785_111 22.6162
Rtree_2785_21 sp__2785_111 sp__11704_CLK 22.678
Rtree_2785_22 sp__2785_111 sp__11536_CLK 20
Rtree_2785_23 sp__2785_105 sp__11707_CLK 43.0694
Rtree_2785_24 sp__2785_59 sp__11702_CLK 20.5974
Rtree_2785_25 sp__2785_55 sp__11424_CLK 20
Rtree_2785_26 sp__2785_10 sp__11698_CLK 40
Rtree_2785_27 sp__12092_X sp__2785_158 20
Rtree_2785_28 sp__2785_158 sp__2785_164 44.0582
Rtree_2785_29 sp__2785_164 sp__11421_CLK 20
Rtree_2785_30 sp__2785_158 sp__11572_CLK 21.8334
Ctree_2785_1 sp__11572_CLK 0 1.47803e-16
Ctree_2785_5 sp__11702_CLK 0 4.23736e-17
Ctree_2785_6 sp__11707_CLK 0 1.96567e-16
Ctree_2785_8 sp__11704_CLK 0 2.77605e-16
Ctree_2785_10 sp__12155_A 0 6.01489e-16
Ctree_2785_13 sp__11571_CLK 0 1.66016e-16
Ctree_2785_16 sp__12092_X 0 3.26712e-16
Ctree_2785_17 sp__2785_164 0 5.27787e-16
Ctree_2785_18 sp__2785_158 0 6.7559e-16
Ctree_2785_19 sp__2785_111 0 5.77737e-16
Ctree_2785_20 sp__2785_105 0 5.86188e-16
Ctree_2785_21 sp__2785_81 0 8.45832e-16
Ctree_2785_22 sp__2785_79 0 5.39419e-16
Ctree_2785_23 sp__2785_70 0 4.6813e-16
Ctree_2785_24 sp__2785_61 0 4.37586e-16
Ctree_2785_25 sp__2785_59 0 4.4913e-16
Ctree_2785_26 sp__2785_55 0 3.90555e-16
Ctree_2785_27 sp__2785_38 0 6.05986e-16
Ctree_2785_28 sp__2785_24 0 3.72845e-16
Ctree_2785_29 sp__2785_16 0 6.32452e-16
Ctree_2785_30 sp__2785_12 0 6.58059e-16
Ctree_2785_31 sp__2785_10 0 4.44033e-16
Ctree_2785_32 sp__11571_CLK 0 8.00842e-17
Ctree_2785_33 sp__11571_CLK 0 3.96486e-16
Ctree_2785_34 sp__11571_CLK 0 2.88932e-16
Ctree_2785_35 sp__11572_CLK 0 2.74189e-16
Ctree_2785_36 sp__11572_CLK 0 2.74321e-16
Ctree_2785_39 sp__11707_CLK 0 2.89769e-16
Ctree_2785_41 sp__12155_A 0 2.08162e-16
Ctree_2785_42 sp__12155_A 0 2.68474e-16
Ctree_2785_44 sp__2785_10 0 1.06151e-16
Ctree_2785_46 sp__2785_12 0 3.95546e-16
Ctree_2785_50 sp__2785_24 0 4.46513e-16
Ctree_2785_53 sp__2785_24 0 6.02171e-16
Ctree_2785_55 sp__2785_38 0 5.85058e-16
Ctree_2785_60 sp__2785_59 0 3.38212e-16
Ctree_2785_62 sp__2785_61 0 2.57497e-16
Ctree_2785_64 sp__2785_70 0 3.22014e-16
Ctree_2785_68 sp__2785_164 0 2.86945e-16
Ctree_2785_70 sp__2785_10 0 4.99838e-16
Ctree_2785_72 sp__12155_A 0 1.23139e-16
Ctree_2785_78 sp__11707_CLK 0 6.63455e-16
Ctree_2785_79 sp__12155_A 0 2.85421e-16
Ctree_2785_80 sp__2785_81 0 6.05446e-16
Ctree_2785_81 sp__2785_105 0 2.35075e-16
Ctree_2785_84 sp__2785_10 0 4.02609e-16
Rtree_2786_1 sp__12093_X sp__2786_6 21.0918
Rtree_2786_2 sp__2786_6 sp__2786_8 1.6171
Rtree_2786_3 sp__2786_8 sp__11440_CLK 22.678
Rtree_2786_4 sp__2786_8 sp__2786_19 3.9964
Rtree_2786_5 sp__2786_19 sp__2786_21 0.3193
Rtree_2786_6 sp__2786_21 sp__2786_23 1.6171
Rtree_2786_7 sp__2786_23 sp__11558_CLK 23.9964
Rtree_2786_8 sp__2786_23 sp__2786_32 20
Rtree_2786_9 sp__2786_32 sp__11557_CLK 46.283
Rtree_2786_10 sp__2786_32 sp__11639_CLK 41.5862
Rtree_2786_11 sp__2786_21 sp__2786_58 26.7053
Rtree_2786_12 sp__2786_58 sp__2786_64 22.8634
Rtree_2786_13 sp__2786_64 sp__11673_CLK 20
Rtree_2786_14 sp__2786_64 sp__2786_71 0.443
Rtree_2786_15 sp__2786_71 sp__11672_CLK 23.4608
Rtree_2786_16 sp__2786_71 sp__11569_CLK 20
Rtree_2786_17 sp__2786_58 sp__11688_CLK 40.5974
Rtree_2786_18 sp__2786_19 sp__11732_CLK 20
Rtree_2786_19 sp__2786_8 sp__11684_CLK 20
Rtree_2786_20 sp__2786_6 sp__2786_110 1.5656
Rtree_2786_21 sp__2786_110 sp__2786_114 23.0694
Rtree_2786_22 sp__2786_114 sp__2786_116 2.8222
Rtree_2786_23 sp__2786_116 sp__2786_118 0.8446
Rtree_2786_24 sp__2786_118 sp__11565_CLK 47.4469
Rtree_2786_25 sp__2786_118 sp__11638_CLK 42.4823
Rtree_2786_26 sp__2786_116 sp__2786_146 45.5105
Rtree_2786_27 sp__2786_146 sp__11444_CLK 41.5862
Rtree_2786_28 sp__2786_146 sp__11566_CLK 45.5826
Rtree_2786_29 sp__2786_114 sp__11628_CLK 40.3193
Rtree_2786_30 sp__2786_110 sp__11406_CLK 21.6171
Ctree_2786_1 sp__11406_CLK 0 1.58213e-16
Ctree_2786_2 sp__11628_CLK 0 2.60565e-17
Ctree_2786_3 sp__11566_CLK 0 4.25666e-16
Ctree_2786_4 sp__11444_CLK 0 1.40565e-16
Ctree_2786_5 sp__11638_CLK 0 2.74779e-16
Ctree_2786_6 sp__11565_CLK 0 7.61929e-16
Ctree_2786_9 sp__11688_CLK 0 7.16757e-17
Ctree_2786_11 sp__11672_CLK 0 3.33225e-16
Ctree_2786_13 sp__11639_CLK 0 1.30467e-16
Ctree_2786_14 sp__11557_CLK 0 4.8995e-16
Ctree_2786_15 sp__11558_CLK 0 4.17372e-16
Ctree_2786_16 sp__11440_CLK 0 2.30433e-16
Ctree_2786_17 sp__12093_X 0 8.2947e-17
Ctree_2786_18 sp__2786_146 0 1.05424e-15
Ctree_2786_19 sp__2786_118 0 1.10896e-15
Ctree_2786_20 sp__2786_116 0 8.20748e-16
Ctree_2786_21 sp__2786_114 0 5.47367e-16
Ctree_2786_22 sp__2786_110 0 5.37517e-16
Ctree_2786_23 sp__2786_71 0 5.16905e-16
Ctree_2786_24 sp__2786_64 0 4.5188e-16
Ctree_2786_25 sp__2786_58 0 7.36953e-16
Ctree_2786_26 sp__2786_32 0 6.20417e-16
Ctree_2786_27 sp__2786_23 0 6.04863e-16
Ctree_2786_28 sp__2786_21 0 6.13109e-16
Ctree_2786_29 sp__2786_19 0 3.89383e-16
Ctree_2786_30 sp__2786_8 0 7.82301e-16
Ctree_2786_31 sp__2786_6 0 3.92445e-16
Ctree_2786_33 sp__11406_CLK 0 2.40515e-16
Ctree_2786_34 sp__11440_CLK 0 1.54008e-17
Ctree_2786_38 sp__11444_CLK 0 3.40374e-16
Ctree_2786_39 sp__11557_CLK 0 2.88502e-16
Ctree_2786_41 sp__11557_CLK 0 9.75846e-16
Ctree_2786_48 sp__11565_CLK 0 3.93736e-16
Ctree_2786_51 sp__11566_CLK 0 5.00215e-16
Ctree_2786_52 sp__11566_CLK 0 1.81192e-16
Ctree_2786_53 sp__11566_CLK 0 7.11927e-16
Ctree_2786_54 sp__11628_CLK 0 4.77425e-17
Ctree_2786_55 sp__11638_CLK 0 3.23417e-17
Ctree_2786_56 sp__11638_CLK 0 8.00842e-17
Ctree_2786_57 sp__11639_CLK 0 3.20354e-16
Ctree_2786_62 sp__2786_58 0 1.03427e-15
Ctree_2786_64 sp__2786_58 0 1.0873e-15
Ctree_2786_71 sp__2786_146 0 7.895e-16
Ctree_2786_73 sp__2786_146 0 6.61428e-16
Ctree_2786_79 sp__11628_CLK 0 4.77425e-17
Rtree_2787_1 sp__12094_X sp__2787_10 41.5656
Rtree_2787_2 sp__2787_10 sp__2787_14 20.7519
Rtree_2787_3 sp__2787_14 sp__11478_CLK 24.6968
Rtree_2787_4 sp__2787_14 sp__11431_CLK 20
Rtree_2787_5 sp__12094_X sp__2787_35 20
Rtree_2787_6 sp__2787_35 sp__2787_41 42.3278
Rtree_2787_7 sp__2787_41 sp__2787_49 44.9955
Rtree_2787_8 sp__2787_49 sp__2787_53 3.6977
Rtree_2787_9 sp__2787_53 sp__11479_CLK 22.0608
Rtree_2787_10 sp__2787_53 sp__11419_CLK 20
Rtree_2787_11 sp__2787_49 sp__2787_75 25.6444
Rtree_2787_12 sp__2787_75 sp__2787_79 20.7519
Rtree_2787_13 sp__2787_79 sp__11470_CLK 20
Rtree_2787_14 sp__2787_79 sp__11733_CLK 23.4608
Rtree_2787_15 sp__2787_75 sp__11555_CLK 42.5235
Rtree_2787_16 sp__2787_41 sp__11603_CLK 21.4008
Rtree_2787_17 sp__2787_35 sp__2787_119 23.5741
Rtree_2787_18 sp__2787_119 sp__2787_125 27.2203
Rtree_2787_19 sp__2787_125 sp__2787_129 20.8446
Rtree_2787_20 sp__2787_129 sp__2787_135 22.4308
Rtree_2787_21 sp__2787_135 sp__11556_CLK 20
Rtree_2787_22 sp__2787_135 sp__2787_142 2.266
Rtree_2787_23 sp__2787_142 sp__11560_CLK 20
Rtree_2787_24 sp__2787_142 sp__11545_CLK 21.8334
Rtree_2787_25 sp__2787_129 sp__2787_158 22.266
Rtree_2787_26 sp__2787_158 sp__2787_162 2.4308
Rtree_2787_27 sp__2787_162 sp__11604_CLK 20
Rtree_2787_28 sp__2787_162 sp__11427_CLK 22.6162
Rtree_2787_29 sp__2787_158 sp__11605_CLK 20
Rtree_2787_30 sp__2787_125 sp__11546_CLK 20
Rtree_2787_31 sp__2787_119 sp__11509_CLK 42.9149
Ctree_2787_1 sp__11509_CLK 0 2.76474e-16
Ctree_2787_4 sp__11427_CLK 0 2.49542e-16
Ctree_2787_6 sp__11545_CLK 0 1.48844e-16
Ctree_2787_9 sp__11603_CLK 0 1.39911e-16
Ctree_2787_10 sp__11555_CLK 0 2.58211e-16
Ctree_2787_11 sp__11733_CLK 0 3.27349e-16
Ctree_2787_14 sp__11479_CLK 0 2.9929e-16
Ctree_2787_16 sp__11478_CLK 0 4.42329e-16
Ctree_2787_17 sp__12094_X 0 1.62916e-16
Ctree_2787_18 sp__2787_162 0 4.85097e-16
Ctree_2787_19 sp__2787_158 0 4.58822e-16
Ctree_2787_20 sp__2787_142 0 3.48843e-16
Ctree_2787_21 sp__2787_135 0 4.28267e-16
Ctree_2787_22 sp__2787_129 0 5.46295e-16
Ctree_2787_23 sp__2787_125 0 4.27094e-16
Ctree_2787_24 sp__2787_119 0 8.31626e-16
Ctree_2787_25 sp__2787_79 0 3.9453e-16
Ctree_2787_26 sp__2787_75 0 6.80428e-16
Ctree_2787_27 sp__2787_53 0 6.69168e-16
Ctree_2787_28 sp__2787_49 0 1.06672e-15
Ctree_2787_29 sp__2787_41 0 5.75016e-16
Ctree_2787_30 sp__2787_35 0 3.16112e-16
Ctree_2787_31 sp__2787_14 0 4.98047e-16
Ctree_2787_32 sp__2787_10 0 2.18633e-16
Ctree_2787_35 sp__11478_CLK 0 4.90161e-16
Ctree_2787_39 sp__11509_CLK 0 2.25213e-16
Ctree_2787_40 sp__11509_CLK 0 2.09357e-16
Ctree_2787_41 sp__11545_CLK sp__2788_134 2.59314e-16
Ctree_2787_43 sp__11555_CLK 0 2.69336e-16
Ctree_2787_46 sp__11603_CLK 0 1.92563e-16
Ctree_2787_53 sp__2787_10 0 1.43932e-16
Ctree_2787_54 sp__2787_14 0 1.12733e-16
Ctree_2787_56 sp__2787_41 0 5.07205e-16
Ctree_2787_57 sp__2787_41 0 5.07494e-16
Ctree_2787_58 sp__2787_49 0 1.77241e-16
Ctree_2787_59 sp__2787_49 0 1.84793e-16
Ctree_2787_60 sp__2787_49 0 6.68909e-16
Ctree_2787_61 sp__2787_49 0 2.91899e-16
Ctree_2787_63 sp__2787_53 0 2.40957e-16
Ctree_2787_64 sp__2787_53 0 1.11596e-16
Ctree_2787_66 sp__2787_75 0 2.574e-16
Ctree_2787_67 sp__2787_75 0 6.14745e-16
Ctree_2787_68 sp__2787_75 0 8.30006e-16
Ctree_2787_69 sp__2787_75 0 2.72801e-16
Ctree_2787_71 sp__2787_79 0 1.122e-16
Ctree_2787_72 sp__2787_119 0 6.14745e-16
Ctree_2787_73 sp__2787_119 0 5.8539e-16
Ctree_2787_74 sp__2787_125 0 1.31692e-15
Ctree_2787_75 sp__2787_125 0 1.31749e-15
Ctree_2787_77 sp__2787_135 sp__2788_134 2.40515e-16
Ctree_2787_78 sp__2787_142 sp__2788_134 3.22654e-16
Ctree_2787_85 sp__2787_53 0 8.0128e-17
Rtree_2788_1 sp__12095_X sp__2788_8 41.6171
Rtree_2788_2 sp__2788_8 sp__2788_12 24.7998
Rtree_2788_3 sp__2788_12 sp__2788_14 0.5974
Rtree_2788_4 sp__2788_14 sp__2788_18 2.4308
Rtree_2788_5 sp__2788_18 sp__11476_CLK 22.4823
Rtree_2788_6 sp__2788_18 sp__2788_29 25.2942
Rtree_2788_7 sp__2788_29 sp__2788_31 0.8446
Rtree_2788_8 sp__2788_31 sp__2788_35 20.8446
Rtree_2788_9 sp__2788_35 sp__2788_37 0.7519
Rtree_2788_10 sp__2788_37 sp__11428_CLK 21.8334
Rtree_2788_11 sp__2788_37 sp__11432_CLK 20
Rtree_2788_12 sp__2788_35 sp__2788_51 1.6171
Rtree_2788_13 sp__2788_51 sp__11417_CLK 20
Rtree_2788_14 sp__2788_51 sp__11416_CLK 23.9964
Rtree_2788_15 sp__2788_31 sp__11477_CLK 43.3475
Rtree_2788_16 sp__2788_29 sp__11418_CLK 44.6453
Rtree_2788_17 sp__2788_14 sp__11510_CLK 25.5105
Rtree_2788_18 sp__2788_12 sp__11429_CLK 20.3193
Rtree_2788_19 sp__2788_8 sp__2788_97 1.8334
Rtree_2788_20 sp__2788_97 sp__2788_101 24.2127
Rtree_2788_21 sp__2788_101 sp__11475_CLK 24.0994
Rtree_2788_22 sp__2788_101 sp__11430_CLK 20
Rtree_2788_23 sp__2788_97 sp__2788_117 1.339
Rtree_2788_24 sp__2788_117 sp__11511_CLK 40.3193
Rtree_2788_25 sp__2788_117 sp__2788_134 33.3179
Rtree_2788_26 sp__2788_134 sp__11441_CLK 20
Rtree_2788_27 sp__2788_134 sp__2788_141 1.3758
Rtree_2788_28 sp__2788_141 sp__11544_CLK 20
Rtree_2788_29 sp__2788_141 sp__2788_148 2.266
Rtree_2788_30 sp__2788_148 sp__2788_154 42.8222
Rtree_2788_31 sp__2788_154 sp__11439_CLK 20
Rtree_2788_32 sp__2788_148 sp__11570_CLK 21.8334
Ctree_2788_1 sp__11570_CLK 0 2.25761e-16
Ctree_2788_5 sp__11511_CLK 0 2.57843e-17
Ctree_2788_7 sp__11475_CLK 0 3.63043e-16
Ctree_2788_8 sp__11429_CLK 0 1.51957e-17
Ctree_2788_9 sp__11510_CLK 0 5.17826e-16
Ctree_2788_10 sp__11418_CLK 0 3.44756e-16
Ctree_2788_11 sp__11477_CLK 0 2.02844e-16
Ctree_2788_12 sp__11416_CLK 0 3.46502e-16
Ctree_2788_15 sp__11428_CLK 0 1.63231e-16
Ctree_2788_16 sp__11476_CLK 0 2.47908e-16
Ctree_2788_17 sp__12095_X 0 2.16953e-16
Ctree_2788_18 sp__2788_154 0 2.7906e-16
Ctree_2788_19 sp__2788_148 0 7.31059e-16
Ctree_2788_20 sp__2788_141 0 4.27561e-16
Ctree_2788_21 sp__2788_134 0 1.43134e-15
Ctree_2788_22 sp__2788_117 0 1.30519e-15
Ctree_2788_23 sp__2788_101 0 8.36131e-16
Ctree_2788_24 sp__2788_97 0 5.93904e-16
Ctree_2788_25 sp__2788_51 0 4.79358e-16
Ctree_2788_26 sp__2788_37 0 2.13428e-16
Ctree_2788_27 sp__2788_35 0 2.77008e-16
Ctree_2788_28 sp__2788_31 0 3.84212e-16
Ctree_2788_29 sp__2788_29 0 9.44114e-16
Ctree_2788_30 sp__2788_18 0 9.96684e-16
Ctree_2788_31 sp__2788_14 0 8.01954e-16
Ctree_2788_32 sp__2788_12 0 3.44196e-16
Ctree_2788_33 sp__2788_8 0 5.70077e-16
Ctree_2788_51 sp__2788_12 0 1.84493e-16
Ctree_2788_52 sp__2788_12 0 1.0488e-15
Ctree_2788_54 sp__2788_29 0 2.34158e-16
Ctree_2788_55 sp__2788_29 0 2.36475e-16
Ctree_2788_63 sp__2788_97 0 2.38459e-16
Ctree_2788_64 sp__2788_97 0 1.61555e-16
Ctree_2788_65 sp__2788_97 0 3.99906e-16
Ctree_2788_66 sp__2788_117 0 2.69852e-16
Ctree_2788_67 sp__2788_117 0 2.92275e-16
Ctree_2788_70 sp__2788_134 0 3.46091e-16
Ctree_2788_71 sp__2788_134 0 3.78148e-16
Ctree_2788_73 sp__2788_134 0 2.9279e-16
Rtree_2789_1 sp__12096_X sp__2789_8 21.1021
Rtree_2789_2 sp__2789_8 sp__2789_16 43.5741
Rtree_2789_3 sp__2789_16 sp__11404_CLK 20
Rtree_2789_4 sp__2789_8 sp__2789_23 3.1312
Rtree_2789_5 sp__2789_23 sp__2789_31 44.3157
Rtree_2789_6 sp__2789_31 sp__12102_A 21.8334
Rtree_2789_7 sp__2789_31 sp__2789_40 0.8446
Rtree_2789_8 sp__2789_40 sp__11522_CLK 20
Rtree_2789_9 sp__2789_40 sp__11692_CLK 25.6856
Rtree_2789_10 sp__2789_23 sp__2789_58 0.7519
Rtree_2789_11 sp__2789_58 sp__2789_62 22.575
Rtree_2789_12 sp__2789_62 sp__2789_64 6.7774
Rtree_2789_13 sp__2789_64 sp__11521_CLK 44.4084
Rtree_2789_14 sp__2789_64 sp__11403_CLK 40
Rtree_2789_15 sp__2789_62 sp__2789_84 20
Rtree_2789_16 sp__2789_84 sp__11629_CLK 22.6162
Rtree_2789_17 sp__2789_84 sp__11462_CLK 20
Rtree_2789_18 sp__2789_58 sp__11631_CLK 21.8334
Rtree_2789_19 sp__12096_X sp__2789_114 43.3166
Rtree_2789_20 sp__2789_114 sp__2789_122 22.2272
Rtree_2789_21 sp__2789_122 sp__2789_124 1.8334
Rtree_2789_22 sp__2789_124 sp__2789_130 2.9664
Rtree_2789_23 sp__2789_130 sp__2789_132 1.8334
Rtree_2789_24 sp__2789_132 sp__11647_CLK 24.0482
Rtree_2789_25 sp__2789_132 sp__2789_147 44.0582
Rtree_2789_26 sp__2789_147 sp__11705_CLK 20
Rtree_2789_27 sp__2789_130 sp__11728_CLK 20.5974
Rtree_2789_28 sp__2789_124 sp__11671_CLK 20
Rtree_2789_29 sp__2789_122 sp__11729_CLK 20
Rtree_2789_30 sp__2789_114 sp__2789_173 20.5974
Rtree_2789_31 sp__2789_173 sp__11648_CLK 20
Rtree_2789_32 sp__2789_173 sp__11689_CLK 21.8334
Ctree_2789_1 sp__11689_CLK 0 1.93556e-16
Ctree_2789_5 sp__11728_CLK 0 3.71349e-17
Ctree_2789_7 sp__11647_CLK 0 4.58097e-16
Ctree_2789_8 sp__11631_CLK 0 1.87464e-16
Ctree_2789_10 sp__11629_CLK 0 2.76136e-16
Ctree_2789_12 sp__11521_CLK 0 3.24534e-16
Ctree_2789_13 sp__11692_CLK 0 4.90848e-16
Ctree_2789_15 sp__12102_A 0 1.8349e-16
Ctree_2789_17 sp__12096_X 0 4.15029e-16
Ctree_2789_18 sp__2789_173 0 2.61136e-16
Ctree_2789_19 sp__2789_147 0 3.80932e-16
Ctree_2789_20 sp__2789_132 0 1.05721e-15
Ctree_2789_21 sp__2789_130 0 4.98011e-16
Ctree_2789_22 sp__2789_124 0 4.33472e-16
Ctree_2789_23 sp__2789_122 0 4.77782e-16
Ctree_2789_24 sp__2789_114 0 6.56648e-16
Ctree_2789_25 sp__2789_84 0 2.76136e-16
Ctree_2789_26 sp__2789_64 0 7.80172e-16
Ctree_2789_27 sp__2789_62 0 5.58524e-16
Ctree_2789_28 sp__2789_58 0 3.55326e-16
Ctree_2789_29 sp__2789_40 0 5.5939e-16
Ctree_2789_30 sp__2789_31 0 7.36606e-16
Ctree_2789_31 sp__2789_23 0 8.51144e-16
Ctree_2789_32 sp__2789_16 0 2.71339e-16
Ctree_2789_33 sp__2789_8 0 6.85894e-16
Ctree_2789_34 sp__11521_CLK 0 1.54008e-17
Ctree_2789_35 sp__11521_CLK 0 2.40476e-16
Ctree_2789_36 sp__11521_CLK 0 3.93687e-16
Ctree_2789_37 sp__11521_CLK 0 5.50995e-16
Ctree_2789_38 sp__11629_CLK 0 1.7634e-16
Ctree_2789_46 sp__11647_CLK 0 1.10809e-16
Ctree_2789_51 sp__11692_CLK 0 8.01938e-17
Ctree_2789_53 sp__11692_CLK 0 2.74228e-16
Ctree_2789_54 sp__11692_CLK 0 1.44295e-16
Ctree_2789_58 sp__2789_8 0 2.21754e-17
Ctree_2789_61 sp__2789_16 0 2.34224e-16
Ctree_2789_62 sp__2789_23 0 1.44691e-16
Ctree_2789_63 sp__2789_31 0 1.12558e-16
Ctree_2789_64 sp__2789_31 0 2.86378e-16
Ctree_2789_69 sp__2789_62 0 2.65663e-16
Ctree_2789_70 sp__2789_62 0 7.51285e-17
Ctree_2789_71 sp__2789_62 0 2.12871e-16
Ctree_2789_72 sp__2789_62 0 5.31565e-16
Ctree_2789_73 sp__2789_64 0 4.99799e-16
Ctree_2789_74 sp__2789_64 0 1.43388e-15
Ctree_2789_75 sp__2789_64 0 1.2816e-16
Ctree_2789_76 sp__2789_114 0 3.9332e-16
Ctree_2789_77 sp__2789_114 0 1.81279e-16
Ctree_2789_86 sp__2789_147 0 7.21442e-16
Ctree_2789_90 sp__2789_16 0 3.37221e-16
Ctree_2789_92 sp__2789_16 0 2.34224e-16
Ctree_2789_93 sp__2789_16 0 2.40196e-16
Rtree_2790_1 sp__12097_X sp__2790_6 40
Rtree_2790_2 sp__2790_6 sp__2790_12 24.9646
Rtree_2790_3 sp__2790_12 sp__2790_14 2.266
Rtree_2790_4 sp__2790_14 sp__2790_18 2.1836
Rtree_2790_5 sp__2790_18 sp__2790_24 6.8598
Rtree_2790_6 sp__2790_24 sp__2790_32 46.386
Rtree_2790_7 sp__2790_32 sp__2790_40 43.605
Rtree_2790_8 sp__2790_40 sp__11452_CLK 20
Rtree_2790_9 sp__2790_32 sp__11625_CLK 20
Rtree_2790_10 sp__2790_24 sp__11755_CLK 20
Rtree_2790_11 sp__2790_18 sp__11463_CLK 20
Rtree_2790_12 sp__2790_14 sp__11581_CLK 20
Rtree_2790_13 sp__2790_12 sp__2790_69 21.8334
Rtree_2790_14 sp__2790_69 sp__2790_75 24.4084
Rtree_2790_15 sp__2790_75 sp__11485_CLK 20
Rtree_2790_16 sp__2790_75 sp__11649_CLK 24.5938
Rtree_2790_17 sp__2790_69 sp__11690_CLK 40
Rtree_2790_18 sp__2790_6 sp__2790_98 3.1054
Rtree_2790_19 sp__2790_98 sp__11461_CLK 43.5638
Rtree_2790_20 sp__2790_98 sp__11532_CLK 44.944
Rtree_2790_21 sp__12097_X sp__2790_127 23.9964
Rtree_2790_22 sp__2790_127 sp__2790_131 21.4008
Rtree_2790_23 sp__2790_131 sp__2790_137 24.7792
Rtree_2790_24 sp__2790_137 sp__11486_CLK 20
Rtree_2790_25 sp__2790_137 sp__2790_150 44.1612
Rtree_2790_26 sp__2790_150 sp__11531_CLK 20
Rtree_2790_27 sp__2790_131 sp__2790_157 2.3278
Rtree_2790_28 sp__2790_157 sp__11590_CLK 42.6018
Rtree_2790_29 sp__2790_157 sp__2790_168 0.8446
Rtree_2790_30 sp__2790_168 sp__11759_CLK 40.9682
Rtree_2790_31 sp__2790_168 sp__11863_CLK 45.7062
Rtree_2790_32 sp__2790_127 sp__11757_CLK 20.5974
Ctree_2790_1 sp__11757_CLK 0 4.72978e-17
Ctree_2790_2 sp__11863_CLK 0 6.38e-16
Ctree_2790_3 sp__11759_CLK 0 1.09406e-16
Ctree_2790_4 sp__11590_CLK 0 2.59541e-16
Ctree_2790_7 sp__11532_CLK 0 5.31159e-16
Ctree_2790_8 sp__11461_CLK 0 3.84877e-16
Ctree_2790_10 sp__11649_CLK 0 4.55032e-16
Ctree_2790_17 sp__12097_X 0 4.37091e-16
Ctree_2790_18 sp__2790_168 0 8.29843e-16
Ctree_2790_19 sp__2790_157 0 5.99316e-16
Ctree_2790_20 sp__2790_150 0 4.48936e-16
Ctree_2790_21 sp__2790_137 0 1.02277e-15
Ctree_2790_22 sp__2790_131 0 9.9102e-16
Ctree_2790_23 sp__2790_127 0 6.44241e-16
Ctree_2790_24 sp__2790_98 0 1.28862e-15
Ctree_2790_25 sp__2790_75 0 9.62294e-16
Ctree_2790_26 sp__2790_69 0 6.42996e-16
Ctree_2790_27 sp__2790_40 0 2.7593e-16
Ctree_2790_28 sp__2790_32 0 7.0476e-16
Ctree_2790_29 sp__2790_24 0 1.05305e-15
Ctree_2790_30 sp__2790_18 0 8.58364e-16
Ctree_2790_31 sp__2790_14 0 5.05595e-16
Ctree_2790_32 sp__2790_12 0 7.07101e-16
Ctree_2790_33 sp__2790_6 0 6.72496e-16
Ctree_2790_36 sp__11461_CLK 0 4.67065e-16
Ctree_2790_39 sp__11590_CLK 0 3.37558e-16
Ctree_2790_43 sp__11649_CLK 0 3.05239e-16
Ctree_2790_44 sp__11649_CLK 0 4.77425e-17
Ctree_2790_53 sp__2790_12 0 7.09443e-16
Ctree_2790_56 sp__2790_24 0 2.73978e-16
Ctree_2790_57 sp__2790_24 0 8.54641e-16
Ctree_2790_59 sp__2790_32 0 9.80008e-16
Ctree_2790_60 sp__2790_32 0 4.48187e-16
Ctree_2790_61 sp__2790_32 0 2.72808e-16
Ctree_2790_62 sp__2790_40 0 2.88317e-16
Ctree_2790_63 sp__2790_40 0 3.37556e-16
Ctree_2790_64 sp__2790_69 0 2.34224e-16
Ctree_2790_65 sp__2790_75 0 1.54008e-17
Ctree_2790_66 sp__2790_75 0 1.07226e-16
Ctree_2790_80 sp__2790_137 0 1.29089e-16
Ctree_2790_90 sp__2790_127 0 2.41259e-16
Ctree_2790_93 sp__2790_127 0 1.54556e-17
Ctree_2790_95 sp__2790_12 0 1.43171e-16
Ctree_2790_104 sp__2790_137 0 1.44875e-16
Ctree_2790_105 sp__2790_150 0 3.3318e-16
Ctree_2790_106 sp__2790_12 0 6.58279e-16
Ctree_2790_108 sp__2790_32 0 2.57241e-16
Ctree_2790_109 sp__2790_40 0 2.73207e-16
Ctree_2790_110 sp__2790_12 0 1.92608e-16
Ctree_2790_111 sp__2790_14 0 4.77425e-17
Ctree_2790_112 sp__2790_69 0 2.34224e-16
Ctree_2790_114 sp__11532_CLK 0 2.85628e-16
Rtree_2791_1 sp__12098_X sp__2791_8 42.6986
Rtree_2791_2 sp__2791_8 sp__2791_10 1.339
Rtree_2791_3 sp__2791_10 sp__2791_12 2.3278
Rtree_2791_4 sp__2791_12 sp__2791_14 2.0806
Rtree_2791_5 sp__2791_14 sp__2791_20 4.944
Rtree_2791_6 sp__2791_20 sp__2791_22 3.811
Rtree_2791_7 sp__2791_22 sp__11515_CLK 43.8522
Rtree_2791_8 sp__2791_22 sp__11730_CLK 40
Rtree_2791_9 sp__2791_20 sp__2791_48 21.5474
Rtree_2791_10 sp__2791_48 sp__11644_CLK 23.1106
Rtree_2791_11 sp__2791_48 sp__11514_CLK 20
Rtree_2791_12 sp__2791_14 sp__11620_CLK 43.914
Rtree_2791_13 sp__2791_12 sp__11658_CLK 41.8334
Rtree_2791_14 sp__2791_10 sp__12103_A 40.5356
Rtree_2791_15 sp__2791_8 sp__2791_95 22.575
Rtree_2791_16 sp__2791_95 sp__2791_101 27.4366
Rtree_2791_17 sp__2791_101 sp__2791_107 23.0488
Rtree_2791_18 sp__2791_107 sp__2791_113 22.0291
Rtree_2791_19 sp__2791_113 sp__11650_CLK 44.5011
Rtree_2791_20 sp__2791_113 sp__11862_CLK 41.1845
Rtree_2791_21 sp__2791_107 sp__11613_CLK 20
Rtree_2791_22 sp__2791_101 sp__2791_140 2.575
Rtree_2791_23 sp__2791_140 sp__11659_CLK 41.4008
Rtree_2791_24 sp__2791_140 sp__11614_CLK 45.0264
Rtree_2791_25 sp__2791_95 sp__11615_CLK 20.8858
Rtree_2791_26 sp__12098_X sp__2791_178 41.8334
Rtree_2791_27 sp__2791_178 sp__11616_CLK 45.4384
Rtree_2791_28 sp__2791_178 sp__2791_193 2.3278
Rtree_2791_29 sp__2791_193 sp__11129_CLK 40.166
Rtree_2791_30 sp__2791_193 sp__11643_CLK 44.0994
Ctree_2791_1 sp__11643_CLK 0 3.99641e-16
Ctree_2791_2 sp__11129_CLK 0 5.80868e-17
Ctree_2791_3 sp__11616_CLK 0 4.59109e-16
Ctree_2791_4 sp__11615_CLK 0 8.28018e-17
Ctree_2791_5 sp__11614_CLK 0 3.70083e-16
Ctree_2791_6 sp__11659_CLK 0 1.51622e-16
Ctree_2791_8 sp__11862_CLK 0 1.15452e-16
Ctree_2791_9 sp__11650_CLK 0 4.92719e-16
Ctree_2791_10 sp__12103_A 0 5.42695e-17
Ctree_2791_11 sp__11658_CLK 0 1.66433e-16
Ctree_2791_12 sp__11620_CLK 0 4.31731e-16
Ctree_2791_14 sp__11644_CLK 0 2.56503e-16
Ctree_2791_16 sp__11515_CLK 0 4.22389e-16
Ctree_2791_17 sp__12098_X 0 4.37611e-16
Ctree_2791_18 sp__2791_193 0 6.96702e-16
Ctree_2791_19 sp__2791_178 0 8.87181e-16
Ctree_2791_20 sp__2791_140 0 6.84363e-16
Ctree_2791_21 sp__2791_113 0 8.45505e-16
Ctree_2791_22 sp__2791_107 0 5.49767e-16
Ctree_2791_23 sp__2791_101 0 1.13646e-15
Ctree_2791_24 sp__2791_95 0 1.02621e-15
Ctree_2791_25 sp__2791_48 0 4.76838e-16
Ctree_2791_26 sp__2791_22 0 8.65346e-16
Ctree_2791_27 sp__2791_20 0 9.68306e-16
Ctree_2791_28 sp__2791_14 0 8.57236e-16
Ctree_2791_29 sp__2791_12 0 4.4557e-16
Ctree_2791_30 sp__2791_10 0 3.51875e-16
Ctree_2791_31 sp__2791_8 0 6.69518e-16
Ctree_2791_37 sp__11614_CLK 0 8.50915e-16
Ctree_2791_39 sp__11616_CLK 0 4.77425e-17
Ctree_2791_40 sp__11616_CLK 0 1.93003e-16
Ctree_2791_42 sp__11620_CLK 0 4.77425e-17
Ctree_2791_47 sp__11643_CLK 0 8.00842e-17
Ctree_2791_51 sp__11650_CLK 0 4.36322e-16
Ctree_2791_52 sp__11658_CLK 0 2.74359e-16
Ctree_2791_58 sp__12103_A 0 8.0216e-17
Ctree_2791_60 sp__2791_8 0 4.03929e-16
Ctree_2791_61 sp__2791_10 0 5.30319e-17
Ctree_2791_62 sp__2791_12 0 4.79779e-16
Ctree_2791_64 sp__2791_14 0 4.25086e-16
Ctree_2791_65 sp__2791_20 0 8.7526e-16
Ctree_2791_70 sp__2791_101 0 5.54577e-16
Ctree_2791_72 sp__2791_107 0 2.09648e-16
Ctree_2791_77 sp__2791_140 0 5.33312e-16
Ctree_2791_78 sp__11615_CLK 0 1.54008e-17
Ctree_2791_79 sp__2791_101 0 2.74228e-16
Ctree_2791_80 sp__11614_CLK 0 1.4474e-16
Ctree_2791_81 sp__11515_CLK 0 2.41353e-16
Ctree_2791_83 sp__11616_CLK 0 4.53057e-16
Ctree_2791_84 sp__2791_193 0 2.15263e-16
Ctree_2791_85 sp__11616_CLK 0 2.73197e-16
Ctree_2791_86 sp__11616_CLK 0 2.53411e-16
Ctree_2791_90 sp__2791_14 0 2.34311e-16
Ctree_2791_91 sp__2791_20 0 3.42364e-16
Ctree_2791_97 sp__11862_CLK 0 1.76369e-16
Ctree_2791_101 sp__11644_CLK 0 3.39377e-16
Ctree_2791_105 sp__2791_178 0 2.7432e-16
Xtree_12021 sp__12021_X sp__12021_A vddclk 0 sg13g2_buf_8
Xtree_12022 sp__12022_X sp__12022_A vddclk 0 sg13g2_buf_8
Xtree_12023 sp__12023_X sp__12023_A vddclk 0 sg13g2_buf_8
Xtree_12024 sp__12024_X sp__12024_A vddclk 0 sg13g2_buf_8
Xtree_12025 sp__12025_X sp__12025_A vddclk 0 sg13g2_buf_8
Xtree_12026 sp__12026_X sp__12026_A vddclk 0 sg13g2_buf_8
Xtree_12027 sp__12027_X sp__12027_A vddclk 0 sg13g2_buf_8
Xtree_12028 sp__12028_X sp__12028_A vddclk 0 sg13g2_buf_8
Xtree_12029 sp__12029_X sp__12029_A vddclk 0 sg13g2_buf_8
Xtree_12030 sp__12030_X sp__12030_A vddclk 0 sg13g2_buf_8
Xtree_12031 sp__12031_X sp__12031_A vddclk 0 sg13g2_buf_8
Xtree_12032 sp__12032_X sp__12032_A vddclk 0 sg13g2_buf_8
Xtree_12033 sp__12033_X sp__12033_A vddclk 0 sg13g2_buf_8
Xtree_12034 sp__12034_X sp__12034_A vddclk 0 sg13g2_buf_8
Xtree_12035 sp__12035_X sp__12035_A vddclk 0 sg13g2_buf_8
Xtree_12036 sp__12036_X sp__12036_A vddclk 0 sg13g2_buf_8
Xtree_12037 sp__12037_X sp__12037_A vddclk 0 sg13g2_buf_8
Xtree_12038 sp__12038_X sp__12038_A vddclk 0 sg13g2_buf_8
Xtree_12039 sp__12039_X sp__12039_A vddclk 0 sg13g2_buf_8
Xtree_12040 sp__12040_X sp__12040_A vddclk 0 sg13g2_buf_8
Xtree_12041 sp__12041_X sp__12041_A vddclk 0 sg13g2_buf_8
Xtree_12042 sp__12042_X sp__12042_A vddclk 0 sg13g2_buf_8
Xtree_12043 sp__12043_X sp__12043_A vddclk 0 sg13g2_buf_8
Xtree_12044 sp__12044_X sp__12044_A vddclk 0 sg13g2_buf_8
Xtree_12045 sp__12045_X sp__12045_A vddclk 0 sg13g2_buf_8
Xtree_12046 sp__12046_X sp__12046_A vddclk 0 sg13g2_buf_8
Xtree_12047 sp__12047_X sp__12047_A vddclk 0 sg13g2_buf_8
Xtree_12048 sp__12048_X sp__12048_A vddclk 0 sg13g2_buf_8
Xtree_12049 sp__12049_X sp__12049_A vddclk 0 sg13g2_buf_8
Xtree_12050 sp__12050_X sp__12050_A vddclk 0 sg13g2_buf_8
Xtree_12051 sp__12051_X sp__12051_A vddclk 0 sg13g2_buf_8
Xtree_12052 sp__12052_X sp__12052_A vddclk 0 sg13g2_buf_8
Xtree_12053 sp__12053_X sp__12053_A vddclk 0 sg13g2_buf_8
Xtree_12054 sp__12054_X sp__12054_A vddclk 0 sg13g2_buf_8
Xtree_12055 sp__12055_X sp__12055_A vddclk 0 sg13g2_buf_8
Xtree_12056 sp__12056_X sp__12056_A vddclk 0 sg13g2_buf_8
Xtree_12057 sp__12057_X sp__12057_A vddclk 0 sg13g2_buf_8
Xtree_12058 sp__12058_X sp__12058_A vddclk 0 sg13g2_buf_8
Xtree_12059 sp__12059_X sp__12059_A vddclk 0 sg13g2_buf_8
Xtree_12060 sp__12060_X sp__12060_A vddclk 0 sg13g2_buf_8
Xtree_12061 sp__12061_X sp__12061_A vddclk 0 sg13g2_buf_8
Xtree_12062 sp__12062_X sp__12062_A vddclk 0 sg13g2_buf_8
Xtree_12063 sp__12063_X sp__12063_A vddclk 0 sg13g2_buf_8
Xtree_12064 sp__12064_X sp__12064_A vddclk 0 sg13g2_buf_8
Xtree_12065 sp__12065_X sp__12065_A vddclk 0 sg13g2_buf_8
Xtree_12066 sp__12066_X sp__12066_A vddclk 0 sg13g2_buf_8
Xtree_12067 sp__12067_X sp__12067_A vddclk 0 sg13g2_buf_8
Xtree_12068 sp__12068_X sp__12068_A vddclk 0 sg13g2_buf_8
Xtree_12069 sp__12069_X sp__12069_A vddclk 0 sg13g2_buf_8
Xtree_12070 sp__12070_X sp__12070_A vddclk 0 sg13g2_buf_8
Xtree_12071 sp__12071_X sp__12071_A vddclk 0 sg13g2_buf_8
Xtree_12072 sp__12072_X sp__12072_A vddclk 0 sg13g2_buf_8
Xtree_12073 sp__12073_X sp__12073_A vddclk 0 sg13g2_buf_8
Xtree_12074 sp__12074_X sp__12074_A vddclk 0 sg13g2_buf_8
Xtree_12075 sp__12075_X sp__12075_A vddclk 0 sg13g2_buf_8
Xtree_12076 sp__12076_X sp__12076_A vddclk 0 sg13g2_buf_8
Xtree_12077 sp__12077_X sp__12077_A vddclk 0 sg13g2_buf_8
Xtree_12078 sp__12078_X sp__12078_A vddclk 0 sg13g2_buf_8
Xtree_12079 sp__12079_X sp__12079_A vddclk 0 sg13g2_buf_8
Xtree_12080 sp__12080_X sp__12080_A vddclk 0 sg13g2_buf_8
Xtree_12081 sp__12081_X sp__12081_A vddclk 0 sg13g2_buf_8
Xtree_12082 sp__12082_X sp__12082_A vddclk 0 sg13g2_buf_8
Xtree_12083 sp__12083_X sp__12083_A vddclk 0 sg13g2_buf_8
Xtree_12084 sp__12084_X sp__12084_A vddclk 0 sg13g2_buf_8
Xtree_12085 sp__12085_X sp__12085_A vddclk 0 sg13g2_buf_8
Xtree_12086 sp__12086_X sp__12086_A vddclk 0 sg13g2_buf_8
Xtree_12087 sp__12087_X sp__12087_A vddclk 0 sg13g2_buf_8
Xtree_12088 sp__12088_X sp__12088_A vddclk 0 sg13g2_buf_8
Xtree_12089 sp__12089_X sp__12089_A vddclk 0 sg13g2_buf_8
Xtree_12090 sp__12090_X sp__12090_A vddclk 0 sg13g2_buf_8
Xtree_12091 sp__12091_X sp__12091_A vddclk 0 sg13g2_buf_8
Xtree_12092 sp__12092_X sp__12092_A vddclk 0 sg13g2_buf_8
Xtree_12093 sp__12093_X sp__12093_A vddclk 0 sg13g2_buf_8
Xtree_12094 sp__12094_X sp__12094_A vddclk 0 sg13g2_buf_8
Xtree_12095 sp__12095_X sp__12095_A vddclk 0 sg13g2_buf_8
Xtree_12096 sp__12096_X sp__12096_A vddclk 0 sg13g2_buf_8
Xtree_12097 sp__12097_X sp__12097_A vddclk 0 sg13g2_buf_8
Xtree_12098 sp__12098_X sp__12098_A vddclk 0 sg13g2_buf_8
Cterminal_0 sp__11572_CLK 0 2.58675e-15
Cterminal_1 sp__11421_CLK 0 2.58675e-15
Cterminal_2 sp__11698_CLK 0 2.58675e-15
Cterminal_3 sp__11424_CLK 0 2.58675e-15
Cterminal_4 sp__11702_CLK 0 2.58675e-15
Cterminal_5 sp__11707_CLK 0 2.58675e-15
Cterminal_6 sp__11536_CLK 0 2.58675e-15
Cterminal_7 sp__11704_CLK 0 2.58675e-15
Cterminal_8 sp__11706_CLK 0 2.58675e-15
Cterminal_9 sp__12155_A 0 5.34309e-15
Cterminal_10 sp__11701_CLK 0 2.58675e-15
Cterminal_11 sp__11703_CLK 0 2.58675e-15
Cterminal_12 sp__11571_CLK 0 2.58675e-15
Cterminal_13 sp__11567_CLK 0 2.58675e-15
Cterminal_14 sp__11693_CLK 0 2.58675e-15
Cterminal_15 sp__11568_CLK 0 2.58675e-15
Cterminal_16 sp__11767_CLK 0 2.58675e-15
Cterminal_17 sp__11686_CLK 0 2.58675e-15
Cterminal_18 sp__11756_CLK 0 2.58675e-15
Cterminal_19 sp__11459_CLK 0 2.58675e-15
Cterminal_20 sp__11685_CLK 0 2.58675e-15
Cterminal_21 sp__11766_CLK 0 2.58675e-15
Cterminal_22 sp__11458_CLK 0 2.58675e-15
Cterminal_23 sp__11637_CLK 0 2.58675e-15
Cterminal_24 sp__11731_CLK 0 2.58675e-15
Cterminal_25 sp__11559_CLK 0 2.58675e-15
Cterminal_26 sp__11481_CLK 0 2.58675e-15
Cterminal_27 sp__11480_CLK 0 2.58675e-15
Cterminal_28 sp__11420_CLK 0 2.58675e-15
Cterminal_29 sp__11405_CLK 0 2.58675e-15
Cterminal_30 sp__11674_CLK 0 2.58675e-15
Cterminal_31 sp__11683_CLK 0 2.58675e-15
Cterminal_32 sp__11734_CLK 0 2.58675e-15
Cterminal_33 sp__11465_CLK 0 2.58675e-15
Cterminal_34 sp__11468_CLK 0 2.58675e-15
Cterminal_35 sp__11598_CLK 0 2.58675e-15
Cterminal_36 sp__11506_CLK 0 2.58675e-15
Cterminal_37 sp__11608_CLK 0 2.58675e-15
Cterminal_38 sp__11607_CLK 0 2.58675e-15
Cterminal_39 sp__11547_CLK 0 2.58675e-15
Cterminal_40 sp__11425_CLK 0 2.58675e-15
Cterminal_41 sp__11507_CLK 0 2.58675e-15
Cterminal_42 sp__11508_CLK 0 2.58675e-15
Cterminal_43 sp__12154_A 0 2.7026e-15
Cterminal_44 sp__11512_CLK 0 2.58675e-15
Cterminal_45 sp__11606_CLK 0 2.58675e-15
Cterminal_46 sp__11483_CLK 0 2.58675e-15
Cterminal_47 sp__11504_CLK 0 2.58675e-15
Cterminal_48 sp__11549_CLK 0 2.58675e-15
Cterminal_49 sp__11456_CLK 0 2.58675e-15
Cterminal_50 sp__11695_CLK 0 2.58675e-15
Cterminal_51 sp__11586_CLK 0 2.58675e-15
Cterminal_52 sp__11464_CLK 0 2.58675e-15
Cterminal_53 sp__11697_CLK 0 2.58675e-15
Cterminal_54 sp__11533_CLK 0 2.58675e-15
Cterminal_55 sp__11457_CLK 0 2.58675e-15
Cterminal_56 sp__11552_CLK 0 2.58675e-15
Cterminal_57 sp__11505_CLK 0 2.58675e-15
Cterminal_58 sp__11455_CLK 0 2.58675e-15
Cterminal_59 sp__11699_CLK 0 2.58675e-15
Cterminal_60 sp__11422_CLK 0 2.58675e-15
Cterminal_61 sp__11534_CLK 0 2.58675e-15
Cterminal_62 sp__11694_CLK 0 2.58675e-15
Cterminal_63 sp__11612_CLK 0 2.58675e-15
Cterminal_64 sp__11860_CLK 0 2.58675e-15
Cterminal_65 sp__11580_CLK 0 2.58675e-15
Cterminal_66 sp__11753_CLK 0 2.58675e-15
Cterminal_67 sp__11582_CLK 0 2.58675e-15
Cterminal_68 sp__12153_A 0 5.34309e-15
Cterminal_69 sp__11752_CLK 0 2.58675e-15
Cterminal_70 sp__11626_CLK 0 2.58675e-15
Cterminal_71 sp__11663_CLK 0 2.58675e-15
Cterminal_72 sp__11484_CLK 0 2.58675e-15
Cterminal_73 sp__11460_CLK 0 2.58675e-15
Cterminal_74 sp__11551_CLK 0 2.58675e-15
Cterminal_75 sp__11493_CLK 0 2.58675e-15
Cterminal_76 sp__11664_CLK 0 2.58675e-15
Cterminal_77 sp__11700_CLK 0 2.58675e-15
Cterminal_78 sp__11412_CLK 0 2.58675e-15
Cterminal_79 sp__12145_A 0 2.7026e-15
Cterminal_80 sp__11388_CLK 0 2.58675e-15
Cterminal_81 sp__11402_CLK 0 2.58675e-15
Cterminal_82 sp__11474_CLK 0 2.58675e-15
Cterminal_83 sp__11489_CLK 0 2.58675e-15
Cterminal_84 sp__11410_CLK 0 2.58675e-15
Cterminal_85 sp__11411_CLK 0 2.58675e-15
Cterminal_86 sp__11413_CLK 0 2.58675e-15
Cterminal_87 sp__11399_CLK 0 2.58675e-15
Cterminal_88 sp__11397_CLK 0 2.58675e-15
Cterminal_89 sp__11400_CLK 0 2.58675e-15
Cterminal_90 sp__11390_CLK 0 2.58675e-15
Cterminal_91 sp__11396_CLK 0 2.58675e-15
Cterminal_92 sp__11389_CLK 0 2.58675e-15
Cterminal_93 sp__11401_CLK 0 2.58675e-15
Cterminal_94 sp__11523_CLK 0 2.58675e-15
Cterminal_95 sp__11542_CLK 0 2.58675e-15
Cterminal_96 sp__11564_CLK 0 2.58675e-15
Cterminal_97 sp__11563_CLK 0 2.58675e-15
Cterminal_98 sp__11561_CLK 0 2.58675e-15
Cterminal_99 sp__11503_CLK 0 2.58675e-15
Cterminal_100 sp__11501_CLK 0 2.58675e-15
Cterminal_101 sp__12134_A 0 2.7026e-15
Cterminal_102 sp__11393_CLK 0 2.58675e-15
Cterminal_103 sp__11409_CLK 0 2.58675e-15
Cterminal_104 sp__11395_CLK 0 2.58675e-15
Cterminal_105 sp__11414_CLK 0 2.58675e-15
Cterminal_106 sp__11436_CLK 0 2.58675e-15
Cterminal_107 sp__11435_CLK 0 2.58675e-15
Cterminal_108 sp__11433_CLK 0 2.58675e-15
Cterminal_109 sp__11434_CLK 0 2.58675e-15
Cterminal_110 sp__11624_CLK 0 2.58675e-15
Cterminal_111 sp__11727_CLK 0 2.58675e-15
Cterminal_112 sp__11454_CLK 0 2.58675e-15
Cterminal_113 sp__11498_CLK 0 2.58675e-15
Cterminal_114 sp__11535_CLK 0 2.58675e-15
Cterminal_115 sp__11423_CLK 0 2.58675e-15
Cterminal_116 sp__11562_CLK 0 2.58675e-15
Cterminal_117 sp__11394_CLK 0 2.58675e-15
Cterminal_118 sp__11520_CLK 0 2.58675e-15
Cterminal_119 sp__11453_CLK 0 2.58675e-15
Cterminal_120 sp__12123_A 0 2.7026e-15
Cterminal_121 sp__11627_CLK 0 2.58675e-15
Cterminal_122 sp__11497_CLK 0 2.58675e-15
Cterminal_123 sp__11601_CLK 0 2.58675e-15
Cterminal_124 sp__11543_CLK 0 2.58675e-15
Cterminal_125 sp__11600_CLK 0 2.58675e-15
Cterminal_126 sp__11385_CLK 0 2.58675e-15
Cterminal_127 sp__11518_CLK 0 2.58675e-15
Cterminal_128 sp__11524_CLK 0 2.58675e-15
Cterminal_129 sp__11502_CLK 0 2.58675e-15
Cterminal_130 sp__11529_CLK 0 2.58675e-15
Cterminal_131 sp__11537_CLK 0 2.58675e-15
Cterminal_132 sp__11517_CLK 0 2.58675e-15
Cterminal_133 sp__11525_CLK 0 2.58675e-15
Cterminal_134 sp__11490_CLK 0 2.58675e-15
Cterminal_135 sp__11540_CLK 0 2.58675e-15
Cterminal_136 sp__11528_CLK 0 2.58675e-15
Cterminal_137 sp__11491_CLK 0 2.58675e-15
Cterminal_138 sp__11398_CLK 0 2.58675e-15
Cterminal_139 sp__11516_CLK 0 2.58675e-15
Cterminal_140 sp__11602_CLK 0 2.58675e-15
Cterminal_141 sp__11387_CLK 0 2.58675e-15
Cterminal_142 sp__11657_CLK 0 2.58675e-15
Cterminal_143 sp__11665_CLK 0 2.58675e-15
Cterminal_144 sp__11651_CLK 0 2.58675e-15
Cterminal_145 sp__11487_CLK 0 2.58675e-15
Cterminal_146 sp__11670_CLK 0 2.58675e-15
Cterminal_147 sp__11691_CLK 0 2.58675e-15
Cterminal_148 sp__11646_CLK 0 2.58675e-15
Cterminal_149 sp__11652_CLK 0 2.58675e-15
Cterminal_150 sp__11645_CLK 0 2.58675e-15
Cterminal_151 sp__11526_CLK 0 2.58675e-15
Cterminal_152 sp__11630_CLK 0 2.58675e-15
Cterminal_153 sp__11488_CLK 0 2.58675e-15
Cterminal_154 sp__12152_A 0 2.7026e-15
Cterminal_155 sp__11492_CLK 0 2.58675e-15
Cterminal_156 sp__11530_CLK 0 2.58675e-15
Cterminal_157 sp__11386_CLK 0 2.58675e-15
Cterminal_158 sp__11509_CLK 0 2.58675e-15
Cterminal_159 sp__11546_CLK 0 2.58675e-15
Cterminal_160 sp__11605_CLK 0 2.58675e-15
Cterminal_161 sp__11427_CLK 0 2.58675e-15
Cterminal_162 sp__11604_CLK 0 2.58675e-15
Cterminal_163 sp__11545_CLK 0 2.58675e-15
Cterminal_164 sp__11560_CLK 0 2.58675e-15
Cterminal_165 sp__11556_CLK 0 2.58675e-15
Cterminal_166 sp__11603_CLK 0 2.58675e-15
Cterminal_167 sp__11555_CLK 0 2.58675e-15
Cterminal_168 sp__11733_CLK 0 2.58675e-15
Cterminal_169 sp__11470_CLK 0 2.58675e-15
Cterminal_170 sp__11419_CLK 0 2.58675e-15
Cterminal_171 sp__11479_CLK 0 2.58675e-15
Cterminal_172 sp__11431_CLK 0 2.58675e-15
Cterminal_173 sp__11478_CLK 0 2.58675e-15
Cterminal_174 sp__11406_CLK 0 2.58675e-15
Cterminal_175 sp__11628_CLK 0 2.58675e-15
Cterminal_176 sp__11566_CLK 0 2.58675e-15
Cterminal_177 sp__11444_CLK 0 2.58675e-15
Cterminal_178 sp__11638_CLK 0 2.58675e-15
Cterminal_179 sp__11565_CLK 0 2.58675e-15
Cterminal_180 sp__11684_CLK 0 2.58675e-15
Cterminal_181 sp__11732_CLK 0 2.58675e-15
Cterminal_182 sp__11688_CLK 0 2.58675e-15
Cterminal_183 sp__11569_CLK 0 2.58675e-15
Cterminal_184 sp__11672_CLK 0 2.58675e-15
Cterminal_185 sp__11673_CLK 0 2.58675e-15
Cterminal_186 sp__11639_CLK 0 2.58675e-15
Cterminal_187 sp__11557_CLK 0 2.58675e-15
Cterminal_188 sp__11558_CLK 0 2.58675e-15
Cterminal_189 sp__11440_CLK 0 2.58675e-15
Cterminal_190 sp__11443_CLK 0 2.58675e-15
Cterminal_191 sp__11407_CLK 0 2.58675e-15
Cterminal_192 sp__11438_CLK 0 2.58675e-15
Cterminal_193 sp__11500_CLK 0 2.58675e-15
Cterminal_194 sp__11451_CLK 0 2.58675e-15
Cterminal_195 sp__12112_A 0 2.7026e-15
Cterminal_196 sp__11499_CLK 0 2.58675e-15
Cterminal_197 sp__11391_CLK 0 2.58675e-15
Cterminal_198 sp__11449_CLK 0 2.58675e-15
Cterminal_199 sp__11448_CLK 0 2.58675e-15
Cterminal_200 sp__11445_CLK 0 2.58675e-15
Cterminal_201 sp__11450_CLK 0 2.58675e-15
Cterminal_202 sp__11447_CLK 0 2.58675e-15
Cterminal_203 sp__11437_CLK 0 2.58675e-15
Cterminal_204 sp__11442_CLK 0 2.58675e-15
Cterminal_205 sp__11446_CLK 0 2.58675e-15
Cterminal_206 sp__11570_CLK 0 2.58675e-15
Cterminal_207 sp__11439_CLK 0 2.58675e-15
Cterminal_208 sp__11544_CLK 0 2.58675e-15
Cterminal_209 sp__11441_CLK 0 2.58675e-15
Cterminal_210 sp__11511_CLK 0 2.58675e-15
Cterminal_211 sp__11430_CLK 0 2.58675e-15
Cterminal_212 sp__11475_CLK 0 2.58675e-15
Cterminal_213 sp__11429_CLK 0 2.58675e-15
Cterminal_214 sp__11510_CLK 0 2.58675e-15
Cterminal_215 sp__11418_CLK 0 2.58675e-15
Cterminal_216 sp__11477_CLK 0 2.58675e-15
Cterminal_217 sp__11416_CLK 0 2.58675e-15
Cterminal_218 sp__11417_CLK 0 2.58675e-15
Cterminal_219 sp__11432_CLK 0 2.58675e-15
Cterminal_220 sp__11428_CLK 0 2.58675e-15
Cterminal_221 sp__11476_CLK 0 2.58675e-15
Cterminal_222 sp__11599_CLK 0 2.58675e-15
Cterminal_223 sp__11408_CLK 0 2.58675e-15
Cterminal_224 sp__11579_CLK 0 2.58675e-15
Cterminal_225 sp__11573_CLK 0 2.58675e-15
Cterminal_226 sp__11574_CLK 0 2.58675e-15
Cterminal_227 sp__11575_CLK 0 2.58675e-15
Cterminal_228 sp__11578_CLK 0 2.58675e-15
Cterminal_229 sp__11576_CLK 0 2.58675e-15
Cterminal_230 sp__11519_CLK 0 2.58675e-15
Cterminal_231 sp__11577_CLK 0 2.58675e-15
Cterminal_232 sp__11496_CLK 0 2.58675e-15
Cterminal_233 sp__11392_CLK 0 2.58675e-15
Cterminal_234 sp__11473_CLK 0 2.58675e-15
Cterminal_235 sp__11415_CLK 0 2.58675e-15
Cterminal_236 sp__11472_CLK 0 2.58675e-15
Cterminal_237 sp__11471_CLK 0 2.58675e-15
Cterminal_238 sp__11761_CLK 0 2.58675e-15
Cterminal_239 sp__11792_CLK 0 2.58675e-15
Cterminal_240 sp__11712_CLK 0 2.58675e-15
Cterminal_241 sp__11760_CLK 0 2.58675e-15
Cterminal_242 sp__11888_CLK 0 2.58675e-15
Cterminal_243 sp__11793_CLK 0 2.58675e-15
Cterminal_244 sp__11711_CLK 0 2.58675e-15
Cterminal_245 sp__11807_CLK 0 2.58675e-15
Cterminal_246 sp__11720_CLK 0 2.58675e-15
Cterminal_247 sp__11678_CLK 0 2.58675e-15
Cterminal_248 sp__11808_CLK 0 2.58675e-15
Cterminal_249 sp__11677_CLK 0 2.58675e-15
Cterminal_250 sp__11632_CLK 0 2.58675e-15
Cterminal_251 sp__11794_CLK 0 2.58675e-15
Cterminal_252 sp__11740_CLK 0 2.58675e-15
Cterminal_253 sp__11806_CLK 0 2.58675e-15
Cterminal_254 sp__11749_CLK 0 2.58675e-15
Cterminal_255 sp__11842_CLK 0 2.58675e-15
Cterminal_256 sp__11843_CLK 0 2.58675e-15
Cterminal_257 sp__11857_CLK 0 2.58675e-15
Cterminal_258 sp__11133_CLK 0 2.58675e-15
Cterminal_259 sp__11844_CLK 0 2.58675e-15
Cterminal_260 sp__11708_CLK 0 2.58675e-15
Cterminal_261 sp__11633_CLK 0 2.58675e-15
Cterminal_262 sp__11809_CLK 0 2.58675e-15
Cterminal_263 sp__11134_CLK 0 2.58675e-15
Cterminal_264 sp__11716_CLK 0 2.58675e-15
Cterminal_265 sp__11816_CLK 0 2.58675e-15
Cterminal_266 sp__11661_CLK 0 2.58675e-15
Cterminal_267 sp__11813_CLK 0 2.58675e-15
Cterminal_268 sp__11585_CLK 0 2.58675e-15
Cterminal_269 sp__11811_CLK 0 2.58675e-15
Cterminal_270 sp__11592_CLK 0 2.58675e-15
Cterminal_271 sp__11662_CLK 0 2.58675e-15
Cterminal_272 sp__11550_CLK 0 2.58675e-15
Cterminal_273 sp__11696_CLK 0 2.58675e-15
Cterminal_274 sp__11467_CLK 0 2.58675e-15
Cterminal_275 sp__11587_CLK 0 2.58675e-15
Cterminal_276 sp__11765_CLK 0 2.58675e-15
Cterminal_277 sp__12125_A 0 2.7026e-15
Cterminal_278 sp__11726_CLK 0 2.58675e-15
Cterminal_279 sp__11634_CLK 0 2.58675e-15
Cterminal_280 sp__11797_CLK 0 2.58675e-15
Cterminal_281 sp__11713_CLK 0 2.58675e-15
Cterminal_282 sp__11795_CLK 0 2.58675e-15
Cterminal_283 sp__11805_CLK 0 2.58675e-15
Cterminal_284 sp__11762_CLK 0 2.58675e-15
Cterminal_285 sp__11136_CLK 0 2.58675e-15
Cterminal_286 sp__11802_CLK 0 2.58675e-15
Cterminal_287 sp__11135_CLK 0 2.58675e-15
Cterminal_288 sp__11584_CLK 0 2.58675e-15
Cterminal_289 sp__11714_CLK 0 2.58675e-15
Cterminal_290 sp__11715_CLK 0 2.58675e-15
Cterminal_291 sp__11595_CLK 0 2.58675e-15
Cterminal_292 sp__11814_CLK 0 2.58675e-15
Cterminal_293 sp__11676_CLK 0 2.58675e-15
Cterminal_294 sp__11722_CLK 0 2.58675e-15
Cterminal_295 sp__11884_CLK 0 2.58675e-15
Cterminal_296 sp__11786_CLK 0 2.58675e-15
Cterminal_297 sp__11887_CLK 0 2.58675e-15
Cterminal_298 sp__11723_CLK 0 2.58675e-15
Cterminal_299 sp__11798_CLK 0 2.58675e-15
Cterminal_300 sp__11804_CLK 0 2.58675e-15
Cterminal_301 sp__11796_CLK 0 2.58675e-15
Cterminal_302 sp__11803_CLK 0 2.58675e-15
Cterminal_303 sp__11721_CLK 0 2.58675e-15
Cterminal_304 sp__11137_CLK 0 2.58675e-15
Cterminal_305 sp__11724_CLK 0 2.58675e-15
Cterminal_306 sp__11886_CLK 0 2.58675e-15
Cterminal_307 sp__11799_CLK 0 2.58675e-15
Cterminal_308 sp__11681_CLK 0 2.58675e-15
Cterminal_309 sp__11739_CLK 0 2.58675e-15
Cterminal_310 sp__11801_CLK 0 2.58675e-15
Cterminal_311 sp__11622_CLK 0 2.58675e-15
Cterminal_312 sp__11597_CLK 0 2.58675e-15
Cterminal_313 sp__11594_CLK 0 2.58675e-15
Cterminal_314 sp__11815_CLK 0 2.58675e-15
Cterminal_315 sp__11768_CLK 0 2.58675e-15
Cterminal_316 sp__11593_CLK 0 2.58675e-15
Cterminal_317 sp__12122_A 0 5.34309e-15
Cterminal_318 sp__11737_CLK 0 2.58675e-15
Cterminal_319 sp__11610_CLK 0 2.58675e-15
Cterminal_320 sp__11554_CLK 0 2.58675e-15
Cterminal_321 sp__11636_CLK 0 2.58675e-15
Cterminal_322 sp__11736_CLK 0 2.58675e-15
Cterminal_323 sp__11596_CLK 0 2.58675e-15
Cterminal_324 sp__11812_CLK 0 2.58675e-15
Cterminal_325 sp__11494_CLK 0 2.58675e-15
Cterminal_326 sp__11469_CLK 0 2.58675e-15
Cterminal_327 sp__11611_CLK 0 2.58675e-15
Cterminal_328 sp__11466_CLK 0 2.58675e-15
Cterminal_329 sp__11548_CLK 0 2.58675e-15
Cterminal_330 sp__11640_CLK 0 2.58675e-15
Cterminal_331 sp__11687_CLK 0 2.58675e-15
Cterminal_332 sp__11735_CLK 0 2.58675e-15
Cterminal_333 sp__11675_CLK 0 2.58675e-15
Cterminal_334 sp__11635_CLK 0 2.58675e-15
Cterminal_335 sp__11495_CLK 0 2.58675e-15
Cterminal_336 sp__11553_CLK 0 2.58675e-15
Cterminal_337 sp__12124_A 0 8.00451e-15
Cterminal_338 sp__11482_CLK 0 2.58675e-15
Cterminal_339 sp__11426_CLK 0 2.58675e-15
Cterminal_340 sp__11609_CLK 0 2.58675e-15
Cterminal_341 sp__11258_CLK 0 2.58675e-15
Cterminal_342 sp__11266_CLK 0 2.58675e-15
Cterminal_343 sp__11267_CLK 0 2.58675e-15
Cterminal_344 sp__11280_CLK 0 2.58675e-15
Cterminal_345 sp__11269_CLK 0 2.58675e-15
Cterminal_346 sp__11272_CLK 0 2.58675e-15
Cterminal_347 sp__11279_CLK 0 2.58675e-15
Cterminal_348 sp__11270_CLK 0 2.58675e-15
Cterminal_349 sp__11265_CLK 0 2.58675e-15
Cterminal_350 sp__11764_CLK 0 2.58675e-15
Cterminal_351 sp__11264_CLK 0 2.58675e-15
Cterminal_352 sp__11763_CLK 0 2.58675e-15
Cterminal_353 sp__11623_CLK 0 2.58675e-15
Cterminal_354 sp__12121_A 0 8.00451e-15
Cterminal_355 sp__11278_CLK 0 2.58675e-15
Cterminal_356 sp__11277_CLK 0 2.58675e-15
Cterminal_357 sp__11150_CLK 0 2.58675e-15
Cterminal_358 sp__11151_CLK 0 2.58675e-15
Cterminal_359 sp__11883_CLK 0 2.58675e-15
Cterminal_360 sp__11885_CLK 0 2.58675e-15
Cterminal_361 sp__11785_CLK 0 2.58675e-15
Cterminal_362 sp__11725_CLK 0 2.58675e-15
Cterminal_363 sp__11750_CLK 0 2.58675e-15
Cterminal_364 sp__11148_CLK 0 2.58675e-15
Cterminal_365 sp__11147_CLK 0 2.58675e-15
Cterminal_366 sp__11142_CLK 0 2.58675e-15
Cterminal_367 sp__11146_CLK 0 2.58675e-15
Cterminal_368 sp__11143_CLK 0 2.58675e-15
Cterminal_369 sp__11682_CLK 0 2.58675e-15
Cterminal_370 sp__11139_CLK 0 2.58675e-15
Cterminal_371 sp__11138_CLK 0 2.58675e-15
Cterminal_372 sp__11140_CLK 0 2.58675e-15
Cterminal_373 sp__11141_CLK 0 2.58675e-15
Cterminal_374 sp__11738_CLK 0 2.58675e-15
Cterminal_375 sp__12120_A 0 5.34309e-15
Cterminal_376 sp__11261_CLK 0 2.58675e-15
Cterminal_377 sp__11260_CLK 0 2.58675e-15
Cterminal_378 sp__11144_CLK 0 2.58675e-15
Cterminal_379 sp__11149_CLK 0 2.58675e-15
Cterminal_380 sp__11145_CLK 0 2.58675e-15
Cterminal_381 sp__11283_CLK 0 2.58675e-15
Cterminal_382 sp__11275_CLK 0 2.58675e-15
Cterminal_383 sp__11273_CLK 0 2.58675e-15
Cterminal_384 sp__11259_CLK 0 2.58675e-15
Cterminal_385 sp__11281_CLK 0 2.58675e-15
Cterminal_386 sp__11268_CLK 0 2.58675e-15
Cterminal_387 sp__11271_CLK 0 2.58675e-15
Cterminal_388 sp__11274_CLK 0 2.58675e-15
Cterminal_389 sp__11246_CLK 0 2.58675e-15
Cterminal_390 sp__11751_CLK 0 2.58675e-15
Cterminal_391 sp__11282_CLK 0 2.58675e-15
Cterminal_392 sp__11230_CLK 0 2.58675e-15
Cterminal_393 sp__11286_CLK 0 2.58675e-15
Cterminal_394 sp__11155_CLK 0 2.58675e-15
Cterminal_395 sp__11263_CLK 0 2.58675e-15
Cterminal_396 sp__11287_CLK 0 2.58675e-15
Cterminal_397 sp__11254_CLK 0 2.58675e-15
Cterminal_398 sp__11253_CLK 0 2.58675e-15
Cterminal_399 sp__11262_CLK 0 2.58675e-15
Cterminal_400 sp__11284_CLK 0 2.58675e-15
Cterminal_401 sp__11276_CLK 0 2.58675e-15
Cterminal_402 sp__11252_CLK 0 2.58675e-15
Cterminal_403 sp__11251_CLK 0 2.58675e-15
Cterminal_404 sp__11250_CLK 0 2.58675e-15
Cterminal_405 sp__11285_CLK 0 2.58675e-15
Cterminal_406 sp__11152_CLK 0 2.58675e-15
Cterminal_407 sp__11162_CLK 0 2.58675e-15
Cterminal_408 sp__11163_CLK 0 2.58675e-15
Cterminal_409 sp__11240_CLK 0 2.58675e-15
Cterminal_410 sp__11211_CLK 0 2.58675e-15
Cterminal_411 sp__11223_CLK 0 2.58675e-15
Cterminal_412 sp__11224_CLK 0 2.58675e-15
Cterminal_413 sp__11256_CLK 0 2.58675e-15
Cterminal_414 sp__12128_A 0 5.34309e-15
Cterminal_415 sp__11210_CLK 0 2.58675e-15
Cterminal_416 sp__11244_CLK 0 2.58675e-15
Cterminal_417 sp__11242_CLK 0 2.58675e-15
Cterminal_418 sp__11243_CLK 0 2.58675e-15
Cterminal_419 sp__11255_CLK 0 2.58675e-15
Cterminal_420 sp__11222_CLK 0 2.58675e-15
Cterminal_421 sp__11249_CLK 0 2.58675e-15
Cterminal_422 sp__11247_CLK 0 2.58675e-15
Cterminal_423 sp__11248_CLK 0 2.58675e-15
Cterminal_424 sp__11245_CLK 0 2.58675e-15
Cterminal_425 sp__11205_CLK 0 2.58675e-15
Cterminal_426 sp__11206_CLK 0 2.58675e-15
Cterminal_427 sp__11209_CLK 0 2.58675e-15
Cterminal_428 sp__11175_CLK 0 2.58675e-15
Cterminal_429 sp__11174_CLK 0 2.58675e-15
Cterminal_430 sp__11173_CLK 0 2.58675e-15
Cterminal_431 sp__11203_CLK 0 2.58675e-15
Cterminal_432 sp__11204_CLK 0 2.58675e-15
Cterminal_433 sp__11207_CLK 0 2.58675e-15
Cterminal_434 sp__11238_CLK 0 2.58675e-15
Cterminal_435 sp__12126_A 0 2.7026e-15
Cterminal_436 sp__11237_CLK 0 2.58675e-15
Cterminal_437 sp__11229_CLK 0 2.58675e-15
Cterminal_438 sp__11218_CLK 0 2.58675e-15
Cterminal_439 sp__11219_CLK 0 2.58675e-15
Cterminal_440 sp__11208_CLK 0 2.58675e-15
Cterminal_441 sp__11220_CLK 0 2.58675e-15
Cterminal_442 sp__11228_CLK 0 2.58675e-15
Cterminal_443 sp__11215_CLK 0 2.58675e-15
Cterminal_444 sp__11227_CLK 0 2.58675e-15
Cterminal_445 sp__11216_CLK 0 2.58675e-15
Cterminal_446 sp__11214_CLK 0 2.58675e-15
Cterminal_447 sp__11213_CLK 0 2.58675e-15
Cterminal_448 sp__11235_CLK 0 2.58675e-15
Cterminal_449 sp__11236_CLK 0 2.58675e-15
Cterminal_450 sp__11225_CLK 0 2.58675e-15
Cterminal_451 sp__11257_CLK 0 2.58675e-15
Cterminal_452 sp__11158_CLK 0 2.58675e-15
Cterminal_453 sp__11157_CLK 0 2.58675e-15
Cterminal_454 sp__12127_A 0 5.34309e-15
Cterminal_455 sp__11212_CLK 0 2.58675e-15
Cterminal_456 sp__11226_CLK 0 2.58675e-15
Cterminal_457 sp__11241_CLK 0 2.58675e-15
Cterminal_458 sp__11166_CLK 0 2.58675e-15
Cterminal_459 sp__11165_CLK 0 2.58675e-15
Cterminal_460 sp__11156_CLK 0 2.58675e-15
Cterminal_461 sp__11193_CLK 0 2.58675e-15
Cterminal_462 sp__11192_CLK 0 2.58675e-15
Cterminal_463 sp__11191_CLK 0 2.58675e-15
Cterminal_464 sp__11190_CLK 0 2.58675e-15
Cterminal_465 sp__11154_CLK 0 2.58675e-15
Cterminal_466 sp__11153_CLK 0 2.58675e-15
Cterminal_467 sp__11787_CLK 0 2.58675e-15
Cterminal_468 sp__11289_CLK 0 2.58675e-15
Cterminal_469 sp__11232_CLK 0 2.58675e-15
Cterminal_470 sp__11189_CLK 0 2.58675e-15
Cterminal_471 sp__11164_CLK 0 2.58675e-15
Cterminal_472 sp__11288_CLK 0 2.58675e-15
Cterminal_473 sp__12129_A 0 5.34309e-15
Cterminal_474 sp__11770_CLK 0 2.58675e-15
Cterminal_475 sp__11875_CLK 0 2.58675e-15
Cterminal_476 sp__11773_CLK 0 2.58675e-15
Cterminal_477 sp__11874_CLK 0 2.58675e-15
Cterminal_478 sp__11876_CLK 0 2.58675e-15
Cterminal_479 sp__11877_CLK 0 2.58675e-15
Cterminal_480 sp__11769_CLK 0 2.58675e-15
Cterminal_481 sp__11293_CLK 0 2.58675e-15
Cterminal_482 sp__11292_CLK 0 2.58675e-15
Cterminal_483 sp__11234_CLK 0 2.58675e-15
Cterminal_484 sp__11290_CLK 0 2.58675e-15
Cterminal_485 sp__11233_CLK 0 2.58675e-15
Cterminal_486 sp__11782_CLK 0 2.58675e-15
Cterminal_487 sp__11788_CLK 0 2.58675e-15
Cterminal_488 sp__11780_CLK 0 2.58675e-15
Cterminal_489 sp__11878_CLK 0 2.58675e-15
Cterminal_490 sp__11783_CLK 0 2.58675e-15
Cterminal_491 sp__11296_CLK 0 2.58675e-15
Cterminal_492 sp__11297_CLK 0 2.58675e-15
Cterminal_493 sp__11295_CLK 0 2.58675e-15
Cterminal_494 sp__11185_CLK 0 2.58675e-15
Cterminal_495 sp__11187_CLK 0 2.58675e-15
Cterminal_496 sp__11186_CLK 0 2.58675e-15
Cterminal_497 sp__11184_CLK 0 2.58675e-15
Cterminal_498 sp__11231_CLK 0 2.58675e-15
Cterminal_499 sp__11239_CLK 0 2.58675e-15
Cterminal_500 sp__11197_CLK 0 2.58675e-15
Cterminal_501 sp__11196_CLK 0 2.58675e-15
Cterminal_502 sp__11195_CLK 0 2.58675e-15
Cterminal_503 sp__11183_CLK 0 2.58675e-15
Cterminal_504 sp__11194_CLK 0 2.58675e-15
Cterminal_505 sp__11291_CLK 0 2.58675e-15
Cterminal_506 sp__11294_CLK 0 2.58675e-15
Cterminal_507 sp__11307_CLK 0 2.58675e-15
Cterminal_508 sp__11177_CLK 0 2.58675e-15
Cterminal_509 sp__11176_CLK 0 2.58675e-15
Cterminal_510 sp__11172_CLK 0 2.58675e-15
Cterminal_511 sp__11171_CLK 0 2.58675e-15
Cterminal_512 sp__11200_CLK 0 2.58675e-15
Cterminal_513 sp__11170_CLK 0 2.58675e-15
Cterminal_514 sp__11199_CLK 0 2.58675e-15
Cterminal_515 sp__11161_CLK 0 2.58675e-15
Cterminal_516 sp__11169_CLK 0 2.58675e-15
Cterminal_517 sp__11168_CLK 0 2.58675e-15
Cterminal_518 sp__11159_CLK 0 2.58675e-15
Cterminal_519 sp__11167_CLK 0 2.58675e-15
Cterminal_520 sp__11160_CLK 0 2.58675e-15
Cterminal_521 sp__11198_CLK 0 2.58675e-15
Cterminal_522 sp__11201_CLK 0 2.58675e-15
Cterminal_523 sp__11202_CLK 0 2.58675e-15
Cterminal_524 sp__11217_CLK 0 2.58675e-15
Cterminal_525 sp__11302_CLK 0 2.58675e-15
Cterminal_526 sp__11182_CLK 0 2.58675e-15
Cterminal_527 sp__11178_CLK 0 2.58675e-15
Cterminal_528 sp__11306_CLK 0 2.58675e-15
Cterminal_529 sp__11305_CLK 0 2.58675e-15
Cterminal_530 sp__11304_CLK 0 2.58675e-15
Cterminal_531 sp__11300_CLK 0 2.58675e-15
Cterminal_532 sp__11301_CLK 0 2.58675e-15
Cterminal_533 sp__11181_CLK 0 2.58675e-15
Cterminal_534 sp__11180_CLK 0 2.58675e-15
Cterminal_535 sp__11188_CLK 0 2.58675e-15
Cterminal_536 sp__11179_CLK 0 2.58675e-15
Cterminal_537 sp__11303_CLK 0 2.58675e-15
Cterminal_538 sp__11298_CLK 0 2.58675e-15
Cterminal_539 sp__11299_CLK 0 2.58675e-15
Cterminal_540 sp__12131_A 0 5.34309e-15
Cterminal_541 sp__11867_CLK 0 2.58675e-15
Cterminal_542 sp__11311_CLK 0 2.58675e-15
Cterminal_543 sp__10973_CLK 0 2.58675e-15
Cterminal_544 sp__11870_CLK 0 2.58675e-15
Cterminal_545 sp__11221_CLK 0 2.58675e-15
Cterminal_546 sp__11772_CLK 0 2.58675e-15
Cterminal_547 sp__11771_CLK 0 2.58675e-15
Cterminal_548 sp__10972_CLK 0 2.58675e-15
Cterminal_549 sp__12130_A 0 1.05523e-14
Cterminal_550 sp__11312_CLK 0 2.58675e-15
Cterminal_551 sp__11310_CLK 0 2.58675e-15
Cterminal_552 sp__11309_CLK 0 2.58675e-15
Cterminal_553 sp__11308_CLK 0 2.58675e-15
Cterminal_554 sp__11869_CLK 0 2.58675e-15
Cterminal_555 sp__11689_CLK 0 2.58675e-15
Cterminal_556 sp__11648_CLK 0 2.58675e-15
Cterminal_557 sp__11729_CLK 0 2.58675e-15
Cterminal_558 sp__11671_CLK 0 2.58675e-15
Cterminal_559 sp__11728_CLK 0 2.58675e-15
Cterminal_560 sp__11705_CLK 0 2.58675e-15
Cterminal_561 sp__11647_CLK 0 2.58675e-15
Cterminal_562 sp__11631_CLK 0 2.58675e-15
Cterminal_563 sp__11462_CLK 0 2.58675e-15
Cterminal_564 sp__11629_CLK 0 2.58675e-15
Cterminal_565 sp__11403_CLK 0 2.58675e-15
Cterminal_566 sp__11521_CLK 0 2.58675e-15
Cterminal_567 sp__11692_CLK 0 2.58675e-15
Cterminal_568 sp__11522_CLK 0 2.58675e-15
Cterminal_569 sp__12102_A 0 2.7026e-15
Cterminal_570 sp__11404_CLK 0 2.58675e-15
Cterminal_571 sp__11757_CLK 0 2.58675e-15
Cterminal_572 sp__11863_CLK 0 2.58675e-15
Cterminal_573 sp__11759_CLK 0 2.58675e-15
Cterminal_574 sp__11590_CLK 0 2.58675e-15
Cterminal_575 sp__11531_CLK 0 2.58675e-15
Cterminal_576 sp__11486_CLK 0 2.58675e-15
Cterminal_577 sp__11532_CLK 0 2.58675e-15
Cterminal_578 sp__11461_CLK 0 2.58675e-15
Cterminal_579 sp__11690_CLK 0 2.58675e-15
Cterminal_580 sp__11649_CLK 0 2.58675e-15
Cterminal_581 sp__11485_CLK 0 2.58675e-15
Cterminal_582 sp__11581_CLK 0 2.58675e-15
Cterminal_583 sp__11463_CLK 0 2.58675e-15
Cterminal_584 sp__11755_CLK 0 2.58675e-15
Cterminal_585 sp__11625_CLK 0 2.58675e-15
Cterminal_586 sp__11452_CLK 0 2.58675e-15
Cterminal_587 sp__11643_CLK 0 2.58675e-15
Cterminal_588 sp__11129_CLK 0 2.58675e-15
Cterminal_589 sp__11616_CLK 0 2.58675e-15
Cterminal_590 sp__11615_CLK 0 2.58675e-15
Cterminal_591 sp__11614_CLK 0 2.58675e-15
Cterminal_592 sp__11659_CLK 0 2.58675e-15
Cterminal_593 sp__11613_CLK 0 2.58675e-15
Cterminal_594 sp__11862_CLK 0 2.58675e-15
Cterminal_595 sp__11650_CLK 0 2.58675e-15
Cterminal_596 sp__12103_A 0 2.7026e-15
Cterminal_597 sp__11658_CLK 0 2.58675e-15
Cterminal_598 sp__11620_CLK 0 2.58675e-15
Cterminal_599 sp__11514_CLK 0 2.58675e-15
Cterminal_600 sp__11644_CLK 0 2.58675e-15
Cterminal_601 sp__11730_CLK 0 2.58675e-15
Cterminal_602 sp__11515_CLK 0 2.58675e-15
Cterminal_603 sp__11680_CLK 0 2.58675e-15
Cterminal_604 sp__11583_CLK 0 2.58675e-15
Cterminal_605 sp__11810_CLK 0 2.58675e-15
Cterminal_606 sp__11132_CLK 0 2.58675e-15
Cterminal_607 sp__11858_CLK 0 2.58675e-15
Cterminal_608 sp__11621_CLK 0 2.58675e-15
Cterminal_609 sp__11861_CLK 0 2.58675e-15
Cterminal_610 sp__11710_CLK 0 2.58675e-15
Cterminal_611 sp__11591_CLK 0 2.58675e-15
Cterminal_612 sp__11864_CLK 0 2.58675e-15
Cterminal_613 sp__12105_A 0 5.34309e-15
Cterminal_614 sp__11859_CLK 0 2.58675e-15
Cterminal_615 sp__11588_CLK 0 2.58675e-15
Cterminal_616 sp__11679_CLK 0 2.58675e-15
Cterminal_617 sp__11754_CLK 0 2.58675e-15
Cterminal_618 sp__11719_CLK 0 2.58675e-15
Cterminal_619 sp__11717_CLK 0 2.58675e-15
Cterminal_620 sp__11856_CLK 0 2.58675e-15
Cterminal_621 sp__11848_CLK 0 2.58675e-15
Cterminal_622 sp__11029_CLK 0 2.58675e-15
Cterminal_623 sp__11741_CLK 0 2.58675e-15
Cterminal_624 sp__11846_CLK 0 2.58675e-15
Cterminal_625 sp__12104_A 0 8.00451e-15
Cterminal_626 sp__11847_CLK 0 2.58675e-15
Cterminal_627 sp__11589_CLK 0 2.58675e-15
Cterminal_628 sp__11709_CLK 0 2.58675e-15
Cterminal_629 sp__11718_CLK 0 2.58675e-15
Cterminal_630 sp__11131_CLK 0 2.58675e-15
Cterminal_631 sp__11660_CLK 0 2.58675e-15
Cterminal_632 sp__11063_CLK 0 2.58675e-15
Cterminal_633 sp__11064_CLK 0 2.58675e-15
Cterminal_634 sp__11065_CLK 0 2.58675e-15
Cterminal_635 sp__11654_CLK 0 2.58675e-15
Cterminal_636 sp__11746_CLK 0 2.58675e-15
Cterminal_637 sp__12115_A 0 2.7026e-15
Cterminal_638 sp__11054_CLK 0 2.58675e-15
Cterminal_639 sp__11895_CLK 0 2.58675e-15
Cterminal_640 sp__11051_CLK 0 2.58675e-15
Cterminal_641 sp__11896_CLK 0 2.58675e-15
Cterminal_642 sp__11048_CLK 0 2.58675e-15
Cterminal_643 sp__11667_CLK 0 2.58675e-15
Cterminal_644 sp__11047_CLK 0 2.58675e-15
Cterminal_645 sp__11668_CLK 0 2.58675e-15
Cterminal_646 sp__11513_CLK 0 2.58675e-15
Cterminal_647 sp__11053_CLK 0 2.58675e-15
Cterminal_648 sp__11918_CLK 0 2.58675e-15
Cterminal_649 sp__11916_CLK 0 2.58675e-15
Cterminal_650 sp__11057_CLK 0 2.58675e-15
Cterminal_651 sp__11893_CLK 0 2.58675e-15
Cterminal_652 sp__11894_CLK 0 2.58675e-15
Cterminal_653 sp__11917_CLK 0 2.58675e-15
Cterminal_654 sp__11919_CLK 0 2.58675e-15
Cterminal_655 sp__11920_CLK 0 2.58675e-15
Cterminal_656 sp__11666_CLK 0 2.58675e-15
Cterminal_657 sp__11052_CLK 0 2.58675e-15
Cterminal_658 sp__11050_CLK 0 2.58675e-15
Cterminal_659 sp__11901_CLK 0 2.58675e-15
Cterminal_660 sp__11946_CLK 0 2.58675e-15
Cterminal_661 sp__11903_CLK 0 2.58675e-15
Cterminal_662 sp__11642_CLK 0 2.58675e-15
Cterminal_663 sp__11023_CLK 0 2.58675e-15
Cterminal_664 sp__11024_CLK 0 2.58675e-15
Cterminal_665 sp__11743_CLK 0 2.58675e-15
Cterminal_666 sp__11028_CLK 0 2.58675e-15
Cterminal_667 sp__11748_CLK 0 2.58675e-15
Cterminal_668 sp__11130_CLK 0 2.58675e-15
Cterminal_669 sp__11069_CLK 0 2.58675e-15
Cterminal_670 sp__12114_A 0 2.7026e-15
Cterminal_671 sp__11758_CLK 0 2.58675e-15
Cterminal_672 sp__11066_CLK 0 2.58675e-15
Cterminal_673 sp__11641_CLK 0 2.58675e-15
Cterminal_674 sp__11067_CLK 0 2.58675e-15
Cterminal_675 sp__11747_CLK 0 2.58675e-15
Cterminal_676 sp__11068_CLK 0 2.58675e-15
Cterminal_677 sp__10886_CLK 0 2.58675e-15
Cterminal_678 sp__10881_CLK 0 2.58675e-15
Cterminal_679 sp__10882_CLK 0 2.58675e-15
Cterminal_680 sp__10884_CLK 0 2.58675e-15
Cterminal_681 sp__10883_CLK 0 2.58675e-15
Cterminal_682 sp__12117_A 0 5.34309e-15
Cterminal_683 sp__11019_CLK 0 2.58675e-15
Cterminal_684 sp__11020_CLK 0 2.58675e-15
Cterminal_685 sp__11018_CLK 0 2.58675e-15
Cterminal_686 sp__11022_CLK 0 2.58675e-15
Cterminal_687 sp__11744_CLK 0 2.58675e-15
Cterminal_688 sp__11021_CLK 0 2.58675e-15
Cterminal_689 sp__11062_CLK 0 2.58675e-15
Cterminal_690 sp__11070_CLK 0 2.58675e-15
Cterminal_691 sp__10873_CLK 0 2.58675e-15
Cterminal_692 sp__11017_CLK 0 2.58675e-15
Cterminal_693 sp__11016_CLK 0 2.58675e-15
Cterminal_694 sp__11060_CLK 0 2.58675e-15
Cterminal_695 sp__11061_CLK 0 2.58675e-15
Cterminal_696 sp__12116_A 0 8.00451e-15
Cterminal_697 sp__11059_CLK 0 2.58675e-15
Cterminal_698 sp__11056_CLK 0 2.58675e-15
Cterminal_699 sp__11058_CLK 0 2.58675e-15
Cterminal_700 sp__11889_CLK 0 2.58675e-15
Cterminal_701 sp__11891_CLK 0 2.58675e-15
Cterminal_702 sp__11127_CLK 0 2.58675e-15
Cterminal_703 sp__11055_CLK 0 2.58675e-15
Cterminal_704 sp__11086_CLK 0 2.58675e-15
Cterminal_705 sp__11906_CLK 0 2.58675e-15
Cterminal_706 sp__11907_CLK 0 2.58675e-15
Cterminal_707 sp__11905_CLK 0 2.58675e-15
Cterminal_708 sp__12108_A 0 5.34309e-15
Cterminal_709 sp__11116_CLK 0 2.58675e-15
Cterminal_710 sp__11908_CLK 0 2.58675e-15
Cterminal_711 sp__11930_CLK 0 2.58675e-15
Cterminal_712 sp__11318_CLK 0 2.58675e-15
Cterminal_713 sp__11931_CLK 0 2.58675e-15
Cterminal_714 sp__11929_CLK 0 2.58675e-15
Cterminal_715 sp__11932_CLK 0 2.58675e-15
Cterminal_716 sp__11933_CLK 0 2.58675e-15
Cterminal_717 sp__11910_CLK 0 2.58675e-15
Cterminal_718 sp__11943_CLK 0 2.58675e-15
Cterminal_719 sp__11927_CLK 0 2.58675e-15
Cterminal_720 sp__11527_CLK 0 2.58675e-15
Cterminal_721 sp__11909_CLK 0 2.58675e-15
Cterminal_722 sp__12107_A 0 8.00451e-15
Cterminal_723 sp__11934_CLK 0 2.58675e-15
Cterminal_724 sp__11317_CLK 0 2.58675e-15
Cterminal_725 sp__11316_CLK 0 2.58675e-15
Cterminal_726 sp__11315_CLK 0 2.58675e-15
Cterminal_727 sp__11314_CLK 0 2.58675e-15
Cterminal_728 sp__11935_CLK 0 2.58675e-15
Cterminal_729 sp__11912_CLK 0 2.58675e-15
Cterminal_730 sp__11936_CLK 0 2.58675e-15
Cterminal_731 sp__11313_CLK 0 2.58675e-15
Cterminal_732 sp__11911_CLK 0 2.58675e-15
Cterminal_733 sp__11104_CLK 0 2.58675e-15
Cterminal_734 sp__11107_CLK 0 2.58675e-15
Cterminal_735 sp__11106_CLK 0 2.58675e-15
Cterminal_736 sp__11111_CLK 0 2.58675e-15
Cterminal_737 sp__11922_CLK 0 2.58675e-15
Cterminal_738 sp__11109_CLK 0 2.58675e-15
Cterminal_739 sp__11327_CLK 0 2.58675e-15
Cterminal_740 sp__11115_CLK 0 2.58675e-15
Cterminal_741 sp__11323_CLK 0 2.58675e-15
Cterminal_742 sp__11324_CLK 0 2.58675e-15
Cterminal_743 sp__11322_CLK 0 2.58675e-15
Cterminal_744 sp__11321_CLK 0 2.58675e-15
Cterminal_745 sp__11320_CLK 0 2.58675e-15
Cterminal_746 sp__11319_CLK 0 2.58675e-15
Cterminal_747 sp__11117_CLK 0 2.58675e-15
Cterminal_748 sp__11110_CLK 0 2.58675e-15
Cterminal_749 sp__11655_CLK 0 2.58675e-15
Cterminal_750 sp__11653_CLK 0 2.58675e-15
Cterminal_751 sp__11656_CLK 0 2.58675e-15
Cterminal_752 sp__11619_CLK 0 2.58675e-15
Cterminal_753 sp__11669_CLK 0 2.58675e-15
Cterminal_754 sp__11745_CLK 0 2.58675e-15
Cterminal_755 sp__11049_CLK 0 2.58675e-15
Cterminal_756 sp__12106_A 0 5.34309e-15
Cterminal_757 sp__11618_CLK 0 2.58675e-15
Cterminal_758 sp__11539_CLK 0 2.58675e-15
Cterminal_759 sp__11904_CLK 0 2.58675e-15
Cterminal_760 sp__11617_CLK 0 2.58675e-15
Cterminal_761 sp__11538_CLK 0 2.58675e-15
Cterminal_762 sp__11541_CLK 0 2.58675e-15
Cterminal_763 sp__11928_CLK 0 2.58675e-15
Cterminal_764 sp__11099_CLK 0 2.58675e-15
Cterminal_765 sp__11124_CLK 0 2.58675e-15
Cterminal_766 sp__11105_CLK 0 2.58675e-15
Cterminal_767 sp__11900_CLK 0 2.58675e-15
Cterminal_768 sp__11899_CLK 0 2.58675e-15
Cterminal_769 sp__12109_A 0 2.7026e-15
Cterminal_770 sp__11128_CLK 0 2.58675e-15
Cterminal_771 sp__11898_CLK 0 2.58675e-15
Cterminal_772 sp__11897_CLK 0 2.58675e-15
Cterminal_773 sp__11923_CLK 0 2.58675e-15
Cterminal_774 sp__11125_CLK 0 2.58675e-15
Cterminal_775 sp__11921_CLK 0 2.58675e-15
Cterminal_776 sp__11924_CLK 0 2.58675e-15
Cterminal_777 sp__11902_CLK 0 2.58675e-15
Cterminal_778 sp__11925_CLK 0 2.58675e-15
Cterminal_779 sp__11926_CLK 0 2.58675e-15
Cterminal_780 sp__11355_CLK 0 2.58675e-15
Cterminal_781 sp__11365_CLK 0 2.58675e-15
Cterminal_782 sp__11354_CLK 0 2.58675e-15
Cterminal_783 sp__11366_CLK 0 2.58675e-15
Cterminal_784 sp__11353_CLK 0 2.58675e-15
Cterminal_785 sp__11367_CLK 0 2.58675e-15
Cterminal_786 sp__11097_CLK 0 2.58675e-15
Cterminal_787 sp__11380_CLK 0 2.58675e-15
Cterminal_788 sp__11093_CLK 0 2.58675e-15
Cterminal_789 sp__11096_CLK 0 2.58675e-15
Cterminal_790 sp__11091_CLK 0 2.58675e-15
Cterminal_791 sp__11949_CLK 0 2.58675e-15
Cterminal_792 sp__11368_CLK 0 2.58675e-15
Cterminal_793 sp__11379_CLK 0 2.58675e-15
Cterminal_794 sp__11378_CLK 0 2.58675e-15
Cterminal_795 sp__11101_CLK 0 2.58675e-15
Cterminal_796 sp__11364_CLK 0 2.58675e-15
Cterminal_797 sp__11095_CLK 0 2.58675e-15
Cterminal_798 sp__11377_CLK 0 2.58675e-15
Cterminal_799 sp__11108_CLK 0 2.58675e-15
Cterminal_800 sp__11100_CLK 0 2.58675e-15
Cterminal_801 sp__12113_A 0 8.00451e-15
Cterminal_802 sp__11094_CLK 0 2.58675e-15
Cterminal_803 sp__11961_CLK 0 2.58675e-15
Cterminal_804 sp__11122_CLK 0 2.58675e-15
Cterminal_805 sp__11892_CLK 0 2.58675e-15
Cterminal_806 sp__11914_CLK 0 2.58675e-15
Cterminal_807 sp__11915_CLK 0 2.58675e-15
Cterminal_808 sp__11085_CLK 0 2.58675e-15
Cterminal_809 sp__11123_CLK 0 2.58675e-15
Cterminal_810 sp__11913_CLK 0 2.58675e-15
Cterminal_811 sp__11098_CLK 0 2.58675e-15
Cterminal_812 sp__11346_CLK 0 2.58675e-15
Cterminal_813 sp__11347_CLK 0 2.58675e-15
Cterminal_814 sp__11345_CLK 0 2.58675e-15
Cterminal_815 sp__11358_CLK 0 2.58675e-15
Cterminal_816 sp__11343_CLK 0 2.58675e-15
Cterminal_817 sp__11344_CLK 0 2.58675e-15
Cterminal_818 sp__11335_CLK 0 2.58675e-15
Cterminal_819 sp__11370_CLK 0 2.58675e-15
Cterminal_820 sp__11341_CLK 0 2.58675e-15
Cterminal_821 sp__11339_CLK 0 2.58675e-15
Cterminal_822 sp__11338_CLK 0 2.58675e-15
Cterminal_823 sp__11337_CLK 0 2.58675e-15
Cterminal_824 sp__11336_CLK 0 2.58675e-15
Cterminal_825 sp__11372_CLK 0 2.58675e-15
Cterminal_826 sp__11371_CLK 0 2.58675e-15
Cterminal_827 sp__11357_CLK 0 2.58675e-15
Cterminal_828 sp__11342_CLK 0 2.58675e-15
Cterminal_829 sp__11373_CLK 0 2.58675e-15
Cterminal_830 sp__12110_A 0 2.7026e-15
Cterminal_831 sp__11112_CLK 0 2.58675e-15
Cterminal_832 sp__11356_CLK 0 2.58675e-15
Cterminal_833 sp__11332_CLK 0 2.58675e-15
Cterminal_834 sp__11334_CLK 0 2.58675e-15
Cterminal_835 sp__11114_CLK 0 2.58675e-15
Cterminal_836 sp__11119_CLK 0 2.58675e-15
Cterminal_837 sp__11330_CLK 0 2.58675e-15
Cterminal_838 sp__11333_CLK 0 2.58675e-15
Cterminal_839 sp__11331_CLK 0 2.58675e-15
Cterminal_840 sp__11329_CLK 0 2.58675e-15
Cterminal_841 sp__11325_CLK 0 2.58675e-15
Cterminal_842 sp__11118_CLK 0 2.58675e-15
Cterminal_843 sp__11326_CLK 0 2.58675e-15
Cterminal_844 sp__11328_CLK 0 2.58675e-15
Cterminal_845 sp__11113_CLK 0 2.58675e-15
Cterminal_846 sp__11376_CLK 0 2.58675e-15
Cterminal_847 sp__11362_CLK 0 2.58675e-15
Cterminal_848 sp__11363_CLK 0 2.58675e-15
Cterminal_849 sp__11352_CLK 0 2.58675e-15
Cterminal_850 sp__11351_CLK 0 2.58675e-15
Cterminal_851 sp__11103_CLK 0 2.58675e-15
Cterminal_852 sp__11102_CLK 0 2.58675e-15
Cterminal_853 sp__11375_CLK 0 2.58675e-15
Cterminal_854 sp__11349_CLK 0 2.58675e-15
Cterminal_855 sp__11360_CLK 0 2.58675e-15
Cterminal_856 sp__11359_CLK 0 2.58675e-15
Cterminal_857 sp__11361_CLK 0 2.58675e-15
Cterminal_858 sp__11350_CLK 0 2.58675e-15
Cterminal_859 sp__11348_CLK 0 2.58675e-15
Cterminal_860 sp__11374_CLK 0 2.58675e-15
Cterminal_861 sp__11340_CLK 0 2.58675e-15
Cterminal_862 sp__12111_A 0 2.7026e-15
Cterminal_863 sp__12100_A 0 8.00451e-15
Cterminal_864 sp__11987_CLK 0 2.58675e-15
Cterminal_865 sp__11986_CLK 0 2.58675e-15
Cterminal_866 sp__11983_CLK 0 2.58675e-15
Cterminal_867 sp__11982_CLK 0 2.58675e-15
Cterminal_868 sp__12119_A 0 2.11172e-14
Cterminal_869 sp__11968_CLK 0 2.58675e-15
Cterminal_870 sp__11965_CLK 0 2.58675e-15
Cterminal_871 sp__11984_CLK 0 2.58675e-15
Cterminal_872 sp__11120_CLK 0 2.58675e-15
Cterminal_873 sp__10900_CLK 0 2.58675e-15
Cterminal_874 sp__11985_CLK 0 2.58675e-15
Cterminal_875 sp__11959_CLK 0 2.58675e-15
Cterminal_876 sp__11089_CLK 0 2.58675e-15
Cterminal_877 sp__11957_CLK 0 2.58675e-15
Cterminal_878 sp__11967_CLK 0 2.58675e-15
Cterminal_879 sp__10963_CLK 0 2.58675e-15
Cterminal_880 sp__10964_CLK 0 2.58675e-15
Cterminal_881 sp__10962_CLK 0 2.58675e-15
Cterminal_882 sp__10961_CLK 0 2.58675e-15
Cterminal_883 sp__10959_CLK 0 2.58675e-15
Cterminal_884 sp__10958_CLK 0 2.58675e-15
Cterminal_885 sp__10960_CLK 0 2.58675e-15
Cterminal_886 sp__11952_CLK 0 2.58675e-15
Cterminal_887 sp__11951_CLK 0 2.58675e-15
Cterminal_888 sp__11950_CLK 0 2.58675e-15
Cterminal_889 sp__11953_CLK 0 2.58675e-15
Cterminal_890 sp__11954_CLK 0 2.58675e-15
Cterminal_891 sp__11087_CLK 0 2.58675e-15
Cterminal_892 sp__11958_CLK 0 2.58675e-15
Cterminal_893 sp__11960_CLK 0 2.58675e-15
Cterminal_894 sp__11088_CLK 0 2.58675e-15
Cterminal_895 sp__11963_CLK 0 2.58675e-15
Cterminal_896 sp__11090_CLK 0 2.58675e-15
Cterminal_897 sp__11956_CLK 0 2.58675e-15
Cterminal_898 sp__11381_CLK 0 2.58675e-15
Cterminal_899 sp__12118_A 0 2.7026e-15
Cterminal_900 sp__11382_CLK 0 2.58675e-15
Cterminal_901 sp__11383_CLK 0 2.58675e-15
Cterminal_902 sp__11962_CLK 0 2.58675e-15
Cterminal_903 sp__11092_CLK 0 2.58675e-15
Cterminal_904 sp__11369_CLK 0 2.58675e-15
Cterminal_905 sp__11955_CLK 0 2.58675e-15
Cterminal_906 sp__11384_CLK 0 2.58675e-15
Cterminal_907 sp__11126_CLK 0 2.58675e-15
Cterminal_908 sp__10902_CLK 0 2.58675e-15
Cterminal_909 sp__11121_CLK 0 2.58675e-15
Cterminal_910 sp__11939_CLK 0 2.58675e-15
Cterminal_911 sp__11938_CLK 0 2.58675e-15
Cterminal_912 sp__11937_CLK 0 2.58675e-15
Cterminal_913 sp__10901_CLK 0 2.58675e-15
Cterminal_914 sp__11084_CLK 0 2.58675e-15
Cterminal_915 sp__10898_CLK 0 2.58675e-15
Cterminal_916 sp__10899_CLK 0 2.58675e-15
Cterminal_917 sp__11890_CLK 0 2.58675e-15
Cterminal_918 sp__11940_CLK 0 2.58675e-15
Cterminal_919 sp__10871_CLK 0 2.58675e-15
Cterminal_920 sp__10897_CLK 0 2.58675e-15
Cterminal_921 sp__11941_CLK 0 2.58675e-15
Cterminal_922 sp__11942_CLK 0 2.58675e-15
Cterminal_923 sp__12101_A 0 8.00451e-15
Cterminal_924 sp__11040_CLK 0 2.58675e-15
Cterminal_925 sp__11041_CLK 0 2.58675e-15
Cterminal_926 sp__11042_CLK 0 2.58675e-15
Cterminal_927 sp__11043_CLK 0 2.58675e-15
Cterminal_928 sp__11044_CLK 0 2.58675e-15
Cterminal_929 sp__11045_CLK 0 2.58675e-15
Cterminal_930 sp__11030_CLK 0 2.58675e-15
Cterminal_931 sp__11046_CLK 0 2.58675e-15
Cterminal_932 sp__10842_CLK 0 2.58675e-15
Cterminal_933 sp__10844_CLK 0 2.58675e-15
Cterminal_934 sp__10845_CLK 0 2.58675e-15
Cterminal_935 sp__10846_CLK 0 2.58675e-15
Cterminal_936 sp__10840_CLK 0 2.58675e-15
Cterminal_937 sp__10841_CLK 0 2.58675e-15
Cterminal_938 sp__10843_CLK 0 2.58675e-15
Cterminal_939 sp__10818_CLK 0 2.58675e-15
Cterminal_940 sp__10820_CLK 0 2.58675e-15
Cterminal_941 sp__10819_CLK 0 2.58675e-15
Cterminal_942 sp__10838_CLK 0 2.58675e-15
Cterminal_943 sp__10832_CLK 0 2.58675e-15
Cterminal_944 sp__10817_CLK 0 2.58675e-15
Cterminal_945 sp__10816_CLK 0 2.58675e-15
Cterminal_946 sp__12141_A 0 5.34309e-15
Cterminal_947 sp__10866_CLK 0 2.58675e-15
Cterminal_948 sp__10815_CLK 0 2.58675e-15
Cterminal_949 sp__10825_CLK 0 2.58675e-15
Cterminal_950 sp__10828_CLK 0 2.58675e-15
Cterminal_951 sp__10826_CLK 0 2.58675e-15
Cterminal_952 sp__10865_CLK 0 2.58675e-15
Cterminal_953 sp__11074_CLK 0 2.58675e-15
Cterminal_954 sp__11073_CLK 0 2.58675e-15
Cterminal_955 sp__11072_CLK 0 2.58675e-15
Cterminal_956 sp__11075_CLK 0 2.58675e-15
Cterminal_957 sp__11071_CLK 0 2.58675e-15
Cterminal_958 sp__10837_CLK 0 2.58675e-15
Cterminal_959 sp__10836_CLK 0 2.58675e-15
Cterminal_960 sp__12142_A 0 5.34309e-15
Cterminal_961 sp__10835_CLK 0 2.58675e-15
Cterminal_962 sp__10833_CLK 0 2.58675e-15
Cterminal_963 sp__10821_CLK 0 2.58675e-15
Cterminal_964 sp__10822_CLK 0 2.58675e-15
Cterminal_965 sp__10870_CLK 0 2.58675e-15
Cterminal_966 sp__10869_CLK 0 2.58675e-15
Cterminal_967 sp__11038_CLK 0 2.58675e-15
Cterminal_968 sp__11034_CLK 0 2.58675e-15
Cterminal_969 sp__11036_CLK 0 2.58675e-15
Cterminal_970 sp__11035_CLK 0 2.58675e-15
Cterminal_971 sp__11037_CLK 0 2.58675e-15
Cterminal_972 sp__12143_A 0 8.00451e-15
Cterminal_973 sp__11077_CLK 0 2.58675e-15
Cterminal_974 sp__11032_CLK 0 2.58675e-15
Cterminal_975 sp__11033_CLK 0 2.58675e-15
Cterminal_976 sp__11039_CLK 0 2.58675e-15
Cterminal_977 sp__11078_CLK 0 2.58675e-15
Cterminal_978 sp__10839_CLK 0 2.58675e-15
Cterminal_979 sp__11076_CLK 0 2.58675e-15
Cterminal_980 sp__10984_CLK 0 2.58675e-15
Cterminal_981 sp__10983_CLK 0 2.58675e-15
Cterminal_982 sp__10985_CLK 0 2.58675e-15
Cterminal_983 sp__11820_CLK 0 2.58675e-15
Cterminal_984 sp__10966_CLK 0 2.58675e-15
Cterminal_985 sp__11865_CLK 0 2.58675e-15
Cterminal_986 sp__10965_CLK 0 2.58675e-15
Cterminal_987 sp__10982_CLK 0 2.58675e-15
Cterminal_988 sp__11821_CLK 0 2.58675e-15
Cterminal_989 sp__10981_CLK 0 2.58675e-15
Cterminal_990 sp__10980_CLK 0 2.58675e-15
Cterminal_991 sp__11817_CLK 0 2.58675e-15
Cterminal_992 sp__11823_CLK 0 2.58675e-15
Cterminal_993 sp__11836_CLK 0 2.58675e-15
Cterminal_994 sp__12139_A 0 2.7026e-15
Cterminal_995 sp__11822_CLK 0 2.58675e-15
Cterminal_996 sp__11866_CLK 0 2.58675e-15
Cterminal_997 sp__10967_CLK 0 2.58675e-15
Cterminal_998 sp__10968_CLK 0 2.58675e-15
Cterminal_999 sp__10969_CLK 0 2.58675e-15
Cterminal_1000 sp__11868_CLK 0 2.58675e-15
Cterminal_1001 sp__12140_A 0 2.7026e-15
Cterminal_1002 sp__10974_CLK 0 2.58675e-15
Cterminal_1003 sp__10977_CLK 0 2.58675e-15
Cterminal_1004 sp__10979_CLK 0 2.58675e-15
Cterminal_1005 sp__10978_CLK 0 2.58675e-15
Cterminal_1006 sp__11872_CLK 0 2.58675e-15
Cterminal_1007 sp__11871_CLK 0 2.58675e-15
Cterminal_1008 sp__10976_CLK 0 2.58675e-15
Cterminal_1009 sp__10975_CLK 0 2.58675e-15
Cterminal_1010 sp__10970_CLK 0 2.58675e-15
Cterminal_1011 sp__10971_CLK 0 2.58675e-15
Cterminal_1012 sp__11082_CLK 0 2.58675e-15
Cterminal_1013 sp__10986_CLK 0 2.58675e-15
Cterminal_1014 sp__10988_CLK 0 2.58675e-15
Cterminal_1015 sp__11083_CLK 0 2.58675e-15
Cterminal_1016 sp__11947_CLK 0 2.58675e-15
Cterminal_1017 sp__11944_CLK 0 2.58675e-15
Cterminal_1018 sp__11948_CLK 0 2.58675e-15
Cterminal_1019 sp__11945_CLK 0 2.58675e-15
Cterminal_1020 sp__11991_CLK 0 2.58675e-15
Cterminal_1021 sp__11819_CLK 0 2.58675e-15
Cterminal_1022 sp__11079_CLK 0 2.58675e-15
Cterminal_1023 sp__11080_CLK 0 2.58675e-15
Cterminal_1024 sp__10987_CLK 0 2.58675e-15
Cterminal_1025 sp__11081_CLK 0 2.58675e-15
Cterminal_1026 sp__11818_CLK 0 2.58675e-15
Cterminal_1027 sp__10852_CLK 0 2.58675e-15
Cterminal_1028 sp__10892_CLK 0 2.58675e-15
Cterminal_1029 sp__10890_CLK 0 2.58675e-15
Cterminal_1030 sp__10889_CLK 0 2.58675e-15
Cterminal_1031 sp__10908_CLK 0 2.58675e-15
Cterminal_1032 sp__10861_CLK 0 2.58675e-15
Cterminal_1033 sp__10857_CLK 0 2.58675e-15
Cterminal_1034 sp__10855_CLK 0 2.58675e-15
Cterminal_1035 sp__10856_CLK 0 2.58675e-15
Cterminal_1036 sp__10910_CLK 0 2.58675e-15
Cterminal_1037 sp__10909_CLK 0 2.58675e-15
Cterminal_1038 sp__10831_CLK 0 2.58675e-15
Cterminal_1039 sp__10834_CLK 0 2.58675e-15
Cterminal_1040 sp__12138_A 0 1.05523e-14
Cterminal_1041 sp__10990_CLK 0 2.58675e-15
Cterminal_1042 sp__10992_CLK 0 2.58675e-15
Cterminal_1043 sp__10903_CLK 0 2.58675e-15
Cterminal_1044 sp__10905_CLK 0 2.58675e-15
Cterminal_1045 sp__10853_CLK 0 2.58675e-15
Cterminal_1046 sp__10991_CLK 0 2.58675e-15
Cterminal_1047 sp__10993_CLK 0 2.58675e-15
Cterminal_1048 sp__10994_CLK 0 2.58675e-15
Cterminal_1049 sp__10997_CLK 0 2.58675e-15
Cterminal_1050 sp__11988_CLK 0 2.58675e-15
Cterminal_1051 sp__11031_CLK 0 2.58675e-15
Cterminal_1052 sp__11990_CLK 0 2.58675e-15
Cterminal_1053 sp__10995_CLK 0 2.58675e-15
Cterminal_1054 sp__10996_CLK 0 2.58675e-15
Cterminal_1055 sp__10858_CLK 0 2.58675e-15
Cterminal_1056 sp__10859_CLK 0 2.58675e-15
Cterminal_1057 sp__10989_CLK 0 2.58675e-15
Cterminal_1058 sp__10895_CLK 0 2.58675e-15
Cterminal_1059 sp__10896_CLK 0 2.58675e-15
Cterminal_1060 sp__10862_CLK 0 2.58675e-15
Cterminal_1061 sp__10893_CLK 0 2.58675e-15
Cterminal_1062 sp__12136_A 0 8.00451e-15
Cterminal_1063 sp__10998_CLK 0 2.58675e-15
Cterminal_1064 sp__10795_CLK 0 2.58675e-15
Cterminal_1065 sp__10796_CLK 0 2.58675e-15
Cterminal_1066 sp__10791_CLK 0 2.58675e-15
Cterminal_1067 sp__10797_CLK 0 2.58675e-15
Cterminal_1068 sp__10798_CLK 0 2.58675e-15
Cterminal_1069 sp__11002_CLK 0 2.58675e-15
Cterminal_1070 sp__11006_CLK 0 2.58675e-15
Cterminal_1071 sp__10999_CLK 0 2.58675e-15
Cterminal_1072 sp__10792_CLK 0 2.58675e-15
Cterminal_1073 sp__10806_CLK 0 2.58675e-15
Cterminal_1074 sp__10802_CLK 0 2.58675e-15
Cterminal_1075 sp__10803_CLK 0 2.58675e-15
Cterminal_1076 sp__10804_CLK 0 2.58675e-15
Cterminal_1077 sp__10807_CLK 0 2.58675e-15
Cterminal_1078 sp__10814_CLK 0 2.58675e-15
Cterminal_1079 sp__12137_A 0 1.05523e-14
Cterminal_1080 sp__11001_CLK 0 2.58675e-15
Cterminal_1081 sp__11000_CLK 0 2.58675e-15
Cterminal_1082 sp__11013_CLK 0 2.58675e-15
Cterminal_1083 sp__10794_CLK 0 2.58675e-15
Cterminal_1084 sp__10793_CLK 0 2.58675e-15
Cterminal_1085 sp__10891_CLK 0 2.58675e-15
Cterminal_1086 sp__10800_CLK 0 2.58675e-15
Cterminal_1087 sp__10801_CLK 0 2.58675e-15
Cterminal_1088 sp__10805_CLK 0 2.58675e-15
Cterminal_1089 sp__10799_CLK 0 2.58675e-15
Cterminal_1090 sp__10877_CLK 0 2.58675e-15
Cterminal_1091 sp__10875_CLK 0 2.58675e-15
Cterminal_1092 sp__10874_CLK 0 2.58675e-15
Cterminal_1093 sp__11015_CLK 0 2.58675e-15
Cterminal_1094 sp__10888_CLK 0 2.58675e-15
Cterminal_1095 sp__10872_CLK 0 2.58675e-15
Cterminal_1096 sp__10879_CLK 0 2.58675e-15
Cterminal_1097 sp__10880_CLK 0 2.58675e-15
Cterminal_1098 sp__10876_CLK 0 2.58675e-15
Cterminal_1099 sp__10878_CLK 0 2.58675e-15
Cterminal_1100 sp__10885_CLK 0 2.58675e-15
Cterminal_1101 sp__11014_CLK 0 2.58675e-15
Cterminal_1102 sp__10830_CLK 0 2.58675e-15
Cterminal_1103 sp__10827_CLK 0 2.58675e-15
Cterminal_1104 sp__10829_CLK 0 2.58675e-15
Cterminal_1105 sp__10823_CLK 0 2.58675e-15
Cterminal_1106 sp__10824_CLK 0 2.58675e-15
Cterminal_1107 sp__10864_CLK 0 2.58675e-15
Cterminal_1108 sp__10863_CLK 0 2.58675e-15
Cterminal_1109 sp__10887_CLK 0 2.58675e-15
Cterminal_1110 sp__10924_CLK 0 2.58675e-15
Cterminal_1111 sp__10925_CLK 0 2.58675e-15
Cterminal_1112 sp__10923_CLK 0 2.58675e-15
Cterminal_1113 sp__10922_CLK 0 2.58675e-15
Cterminal_1114 sp__11966_CLK 0 2.58675e-15
Cterminal_1115 sp__11969_CLK 0 2.58675e-15
Cterminal_1116 sp__10921_CLK 0 2.58675e-15
Cterminal_1117 sp__10919_CLK 0 2.58675e-15
Cterminal_1118 sp__10920_CLK 0 2.58675e-15
Cterminal_1119 sp__12135_A 0 1.05523e-14
Cterminal_1120 sp__10867_CLK 0 2.58675e-15
Cterminal_1121 sp__10868_CLK 0 2.58675e-15
Cterminal_1122 sp__10918_CLK 0 2.58675e-15
Cterminal_1123 sp__11852_CLK 0 2.58675e-15
Cterminal_1124 sp__11777_CLK 0 2.58675e-15
Cterminal_1125 sp__11776_CLK 0 2.58675e-15
Cterminal_1126 sp__11880_CLK 0 2.58675e-15
Cterminal_1127 sp__11791_CLK 0 2.58675e-15
Cterminal_1128 sp__11853_CLK 0 2.58675e-15
Cterminal_1129 sp__11800_CLK 0 2.58675e-15
Cterminal_1130 sp__11854_CLK 0 2.58675e-15
Cterminal_1131 sp__11855_CLK 0 2.58675e-15
Cterminal_1132 sp__11778_CLK 0 2.58675e-15
Cterminal_1133 sp__11882_CLK 0 2.58675e-15
Cterminal_1134 sp__11881_CLK 0 2.58675e-15
Cterminal_1135 sp__11781_CLK 0 2.58675e-15
Cterminal_1136 sp__11779_CLK 0 2.58675e-15
Cterminal_1137 sp__11789_CLK 0 2.58675e-15
Cterminal_1138 sp__11774_CLK 0 2.58675e-15
Cterminal_1139 sp__11834_CLK 0 2.58675e-15
Cterminal_1140 sp__11835_CLK 0 2.58675e-15
Cterminal_1141 sp__11837_CLK 0 2.58675e-15
Cterminal_1142 sp__11873_CLK 0 2.58675e-15
Cterminal_1143 sp__11775_CLK 0 2.58675e-15
Cterminal_1144 sp__11879_CLK 0 2.58675e-15
Cterminal_1145 sp__11008_CLK 0 2.58675e-15
Cterminal_1146 sp__11824_CLK 0 2.58675e-15
Cterminal_1147 sp__11825_CLK 0 2.58675e-15
Cterminal_1148 sp__11833_CLK 0 2.58675e-15
Cterminal_1149 sp__11839_CLK 0 2.58675e-15
Cterminal_1150 sp__11851_CLK 0 2.58675e-15
Cterminal_1151 sp__11784_CLK 0 2.58675e-15
Cterminal_1152 sp__11838_CLK 0 2.58675e-15
Cterminal_1153 sp__10850_CLK 0 2.58675e-15
Cterminal_1154 sp__10848_CLK 0 2.58675e-15
Cterminal_1155 sp__10851_CLK 0 2.58675e-15
Cterminal_1156 sp__10849_CLK 0 2.58675e-15
Cterminal_1157 sp__10847_CLK 0 2.58675e-15
Cterminal_1158 sp__10904_CLK 0 2.58675e-15
Cterminal_1159 sp__10860_CLK 0 2.58675e-15
Cterminal_1160 sp__10854_CLK 0 2.58675e-15
Cterminal_1161 sp__10906_CLK 0 2.58675e-15
Cterminal_1162 sp__10907_CLK 0 2.58675e-15
Cterminal_1163 sp__10894_CLK 0 2.58675e-15
Cterminal_1164 sp__11003_CLK 0 2.58675e-15
Cterminal_1165 sp__11004_CLK 0 2.58675e-15
Cterminal_1166 sp__11007_CLK 0 2.58675e-15
Cterminal_1167 sp__11005_CLK 0 2.58675e-15
Cterminal_1168 sp__11009_CLK 0 2.58675e-15
Cterminal_1169 sp__11012_CLK 0 2.58675e-15
Cterminal_1170 sp__11829_CLK 0 2.58675e-15
Cterminal_1171 sp__11850_CLK 0 2.58675e-15
Cterminal_1172 sp__11826_CLK 0 2.58675e-15
Cterminal_1173 sp__11790_CLK 0 2.58675e-15
Cterminal_1174 sp__11010_CLK 0 2.58675e-15
Cterminal_1175 sp__11011_CLK 0 2.58675e-15
Cterminal_1176 sp__12133_A 0 2.7026e-15
Cterminal_1177 sp__11827_CLK 0 2.58675e-15
Cterminal_1178 sp__11840_CLK 0 2.58675e-15
Cterminal_1179 sp__11832_CLK 0 2.58675e-15
Cterminal_1180 sp__11849_CLK 0 2.58675e-15
Cterminal_1181 sp__11841_CLK 0 2.58675e-15
Cterminal_1182 sp__11828_CLK 0 2.58675e-15
Cterminal_1183 sp__10813_CLK 0 2.58675e-15
Cterminal_1184 sp__11830_CLK 0 2.58675e-15
Cterminal_1185 sp__11831_CLK 0 2.58675e-15
Cterminal_1186 sp__10808_CLK 0 2.58675e-15
Cterminal_1187 sp__11845_CLK 0 2.58675e-15
Cterminal_1188 sp__10809_CLK 0 2.58675e-15
Cterminal_1189 sp__10811_CLK 0 2.58675e-15
Cterminal_1190 sp__10812_CLK 0 2.58675e-15
Cterminal_1191 sp__10810_CLK 0 2.58675e-15
Cterminal_1192 sp__11742_CLK 0 2.58675e-15
Cterminal_1193 sp__12132_A 0 5.34309e-15
Cterminal_1194 sp__11026_CLK 0 2.58675e-15
Cterminal_1195 sp__11025_CLK 0 2.58675e-15
Cterminal_1196 sp__11027_CLK 0 2.58675e-15
