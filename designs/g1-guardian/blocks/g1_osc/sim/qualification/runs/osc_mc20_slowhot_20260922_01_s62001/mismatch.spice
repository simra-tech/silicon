* post-layout netlist of osc: kpex 2.5D CC parasitic capacitances, PDK devices from the layout
* generated by make_pex_netlist.py from g1_osc_k25d_pex_netlist.spice (see its docstring)
.subckt g1_osc en trim0 trim1 trim2 trim3 osc_clk vdd vss
XM1 vb n22 vss vss sg13_lv_nmos w=4u l=0.13u ng=1 m=1 mm_ok=1
XM2 va n20 vss vss sg13_lv_nmos w=4u l=0.13u ng=1 m=1 mm_ok=1
XM3 bb3 trim3 vss vss sg13_lv_nmos w=4u l=0.13u ng=1 m=1 mm_ok=1
XM4 n22 n25 n26 vss sg13_lv_nmos w=1u l=0.13u ng=1 m=1 mm_ok=1
XM5 osc_clk n27 vss vss sg13_lv_nmos w=0.5u l=0.13u ng=1 m=1 mm_ok=1
XM6 n14 n31 vss vss sg13_lv_nmos w=0.5u l=0.13u ng=1 m=1 mm_ok=1
XM7 n32 vbn vss vss sg13_lv_nmos w=2u l=0.5u ng=1 m=1 mm_ok=1
XM8 n27 n24 vss vss sg13_lv_nmos w=0.5u l=0.13u ng=1 m=1 mm_ok=1
XM9 n26 en vss vss sg13_lv_nmos w=1u l=0.13u ng=1 m=1 mm_ok=1
XM10 n20 n24 vss vss sg13_lv_nmos w=0.5u l=0.13u ng=1 m=1 mm_ok=1
XM11 n24 n25 vss vss sg13_lv_nmos w=0.5u l=0.13u ng=1 m=1 mm_ok=1
XM12 vbn vbn vss vss sg13_lv_nmos w=2u l=0.5u ng=1 m=1 mm_ok=1
XM13 n25 n36 vss vss sg13_lv_nmos w=0.5u l=0.13u ng=1 m=1 mm_ok=1
XM14 n31 vth n29 vss sg13_lv_nmos w=4u l=0.3u ng=1 m=1 mm_ok=1
XM15 n36 n35 vss vss sg13_lv_nmos w=0.5u l=0.13u ng=1 m=1 mm_ok=1
XM16 n34 vth n32 vss sg13_lv_nmos w=4u l=0.3u ng=1 m=1 mm_ok=1
XM17 n29 vbn vss vss sg13_lv_nmos w=2u l=0.5u ng=1 m=1 mm_ok=1
XM18 n15 n14 vss vss sg13_lv_nmos w=0.5u l=0.13u ng=1 m=1 mm_ok=1
XM19 b1 trim1 vss vss sg13_lv_nmos w=4u l=0.13u ng=1 m=1 mm_ok=1
XM20 n25 n24 vss vss sg13_lv_nmos w=0.5u l=0.13u ng=1 m=1 mm_ok=1
XM21 n24 n15 vss vss sg13_lv_nmos w=0.5u l=0.13u ng=1 m=1 mm_ok=1
XM22 n35 n34 vss vss sg13_lv_nmos w=0.5u l=0.13u ng=1 m=1 mm_ok=1
XM23 n30 va n29 vss sg13_lv_nmos w=4u l=0.3u ng=1 m=1 mm_ok=1
XM24 n47 en vss vss sg13_lv_nmos w=0.5u l=0.13u ng=1 m=1 mm_ok=1
XM25 bb0 trim0 vss vss sg13_lv_nmos w=4u l=0.13u ng=1 m=1 mm_ok=1
XM26 n24 n47 vss vss sg13_lv_nmos w=0.5u l=0.13u ng=1 m=1 mm_ok=1
XM27 b0 trim0 vss vss sg13_lv_nmos w=4u l=0.13u ng=1 m=1 mm_ok=1
XM28 bb1 trim1 vss vss sg13_lv_nmos w=4u l=0.13u ng=1 m=1 mm_ok=1
XM29 b3 trim3 vss vss sg13_lv_nmos w=4u l=0.13u ng=1 m=1 mm_ok=1
XM30 n33 vb n32 vss sg13_lv_nmos w=4u l=0.3u ng=1 m=1 mm_ok=1
XM31 b2 trim2 vss vss sg13_lv_nmos w=4u l=0.13u ng=1 m=1 mm_ok=1
XM32 bb2 trim2 vss vss sg13_lv_nmos w=4u l=0.13u ng=1 m=1 mm_ok=1
XM33 n24 n25 n50 vdd sg13_lv_pmos w=3u l=0.13u ng=1 m=1 mm_ok=1
XM34 n50 n47 n48 vdd sg13_lv_pmos w=3u l=0.13u ng=1 m=1 mm_ok=1
XM35 n48 n15 vdd vdd sg13_lv_pmos w=3u l=0.13u ng=1 m=1 mm_ok=1
XM36 n25 n24 n49 vdd sg13_lv_pmos w=2u l=0.13u ng=1 m=1 mm_ok=1
XM37 n49 n36 vdd vdd sg13_lv_pmos w=2u l=0.13u ng=1 m=1 mm_ok=1
XM38 n47 en vdd vdd sg13_lv_pmos w=1u l=0.13u ng=1 m=1 mm_ok=1
XM39 n36 n35 vdd vdd sg13_lv_pmos w=1u l=0.13u ng=1 m=1 mm_ok=1
XM40 n27 n24 vdd vdd sg13_lv_pmos w=1u l=0.13u ng=1 m=1 mm_ok=1
XM41 n22 n25 vdd vdd sg13_lv_pmos w=1u l=0.13u ng=1 m=1 mm_ok=1
XM42 n33 n33 vdd vdd sg13_lv_pmos w=2u l=0.3u ng=1 m=1 mm_ok=1
XM43 n34 n33 vdd vdd sg13_lv_pmos w=2u l=0.3u ng=1 m=1 mm_ok=1
XM44 n35 n34 vdd vdd sg13_lv_pmos w=1u l=0.13u ng=1 m=1 mm_ok=1
XM45 n22 en vdd vdd sg13_lv_pmos w=1u l=0.13u ng=1 m=1 mm_ok=1
XM46 n15 n14 vdd vdd sg13_lv_pmos w=1u l=0.13u ng=1 m=1 mm_ok=1
XM47 n31 n30 vdd vdd sg13_lv_pmos w=2u l=0.3u ng=1 m=1 mm_ok=1
XM48 osc_clk n27 vdd vdd sg13_lv_pmos w=1u l=0.13u ng=1 m=1 mm_ok=1
XM49 n20 n24 vdd vdd sg13_lv_pmos w=1u l=0.13u ng=1 m=1 mm_ok=1
XM50 n14 n31 vdd vdd sg13_lv_pmos w=1u l=0.13u ng=1 m=1 mm_ok=1
XM51 n30 n30 vdd vdd sg13_lv_pmos w=2u l=0.3u ng=1 m=1 mm_ok=1
XD52 vth vdd dpantenna l=0.78u w=0.78u
XR53 n3 vdd vss rppd w=1u l=58.5u b=0 m=1 mm_ok=1
XR54 n4 vdd vss rppd w=1u l=58.5u b=0 m=1 mm_ok=1
XR55 n4 vb vss rppd w=1u l=58.5u b=0 m=1 mm_ok=1
XR56 n3 va vss rppd w=1u l=58.5u b=0 m=1 mm_ok=1
XR57 n5 vdd vss rppd w=1u l=64.05u b=0 m=1 mm_ok=1
XR58 n5 n52 vss rppd w=1u l=64.05u b=0 m=1 mm_ok=1
XR59 n6 n52 vss rppd w=1u l=64.05u b=0 m=1 mm_ok=1
XR60 n6 n53 vss rppd w=1u l=64.05u b=0 m=1 mm_ok=1
XR61 n7 n53 vss rppd w=1u l=64.05u b=0 m=1 mm_ok=1
XR62 n7 vth vss rppd w=1u l=64.05u b=0 m=1 mm_ok=1
XR63 n8 vth vss rppd w=1u l=64.05u b=0 m=1 mm_ok=1
XR64 n8 n54 vss rppd w=1u l=64.05u b=0 m=1 mm_ok=1
XR65 n9 n54 vss rppd w=1u l=64.05u b=0 m=1 mm_ok=1
XR66 n9 n55 vss rppd w=1u l=64.05u b=0 m=1 mm_ok=1
XR67 n10 n55 vss rppd w=1u l=64.05u b=0 m=1 mm_ok=1
XR68 n10 vss vss rppd w=1u l=64.05u b=0 m=1 mm_ok=1
XR69 n11 vdd vss rppd w=1u l=67.15u b=0 m=1 mm_ok=1
XR70 n11 vbn vss rppd w=1u l=67.15u b=0 m=1 mm_ok=1
Cext_1 n10 n11 16.6579a
Cext_2 n10 n9 16.6579a
Cext_3 n10 vss 1.90595a
Cext_4 n10 vss 538.771a
Cext_5 n11 vss 3.02072a
Cext_6 n11 vss 552.598a
Cext_7 n14 n15 10.6295f
Cext_8 n14 n20 1.13601a
Cext_9 n14 n22 3.54668a
Cext_10 n14 n24 102.47a
Cext_11 n14 n25 82.925a
Cext_12 n14 n26 25.4358a
Cext_13 n14 n27 49.5074a
Cext_14 n14 n30 263.861a
Cext_15 n14 n31 1.54582f
Cext_16 n14 n32 169.756a
Cext_17 n14 n33 222.087a
Cext_18 n14 n34 64.8261a
Cext_19 n14 n35 59.7024a
Cext_20 n14 n36 7.34025f
Cext_21 n14 n47 51.5668a
Cext_22 n14 b0 18.2284a
Cext_23 n14 b1 17.0201a
Cext_24 n14 b2 17.0201a
Cext_25 n14 b3 17.0201a
Cext_26 n14 bb0 17.0201a
Cext_27 n14 bb1 17.0201a
Cext_28 n14 bb2 17.0201a
Cext_29 n14 bb3 18.2628a
Cext_30 n14 en 53.134a
Cext_31 n14 osc_clk 51.7586a
Cext_32 n14 trim0 29.6919a
Cext_33 n14 trim1 29.5914a
Cext_34 n14 trim2 29.5914a
Cext_35 n14 trim3 25.0468a
Cext_36 n14 va 153.364a
Cext_37 n14 vb 29.724a
Cext_38 n14 vbn 81.6161a
Cext_39 n14 vdd 151.847a
Cext_40 n14 vss 323.998a
Cext_41 n14 vss 1.89281f
Cext_42 n14 vth 1.75808f
Cext_43 n15 n20 13.2277a
Cext_44 n15 n22 15.0783a
Cext_45 n15 n24 1.35792f
Cext_46 n15 n25 80.5627a
Cext_47 n15 n26 25.4358a
Cext_48 n15 n27 47.1451a
Cext_49 n15 n30 62.5345a
Cext_50 n15 n31 391.955a
Cext_51 n15 n32 598.027a
Cext_52 n15 n33 57.5756a
Cext_53 n15 n34 8.81892f
Cext_54 n15 n35 45.2259a
Cext_55 n15 n36 580.045a
Cext_56 n15 n47 267.146a
Cext_57 n15 n48 1.22014f
Cext_58 n15 n50 0.896578a
Cext_59 n15 b0 18.3468a
Cext_60 n15 b1 17.1385a
Cext_61 n15 b2 17.1385a
Cext_62 n15 b3 17.1385a
Cext_63 n15 bb0 17.1385a
Cext_64 n15 bb1 17.1385a
Cext_65 n15 bb2 17.1385a
Cext_66 n15 bb3 18.3812a
Cext_67 n15 en 94.0757a
Cext_68 n15 osc_clk 50.5931a
Cext_69 n15 trim0 29.3467a
Cext_70 n15 trim1 29.2462a
Cext_71 n15 trim2 29.2462a
Cext_72 n15 trim3 24.7016a
Cext_73 n15 va 40.0946a
Cext_74 n15 vb 30.2345a
Cext_75 n15 vbn 45.8398a
Cext_76 n15 vdd 175.497a
Cext_77 n15 vss 201.742a
Cext_78 n15 vss 2.11986f
Cext_79 n15 vth 46.1575a
Cext_80 n20 n22 1.29934f
Cext_81 n20 n24 1.14573f
Cext_82 n20 n25 50.382a
Cext_83 n20 n26 23.5086a
Cext_84 n20 n27 46.4825a
Cext_85 n20 n30 3.8756f
Cext_86 n20 n31 4.22563f
Cext_87 n20 n33 0.239279a
Cext_88 n20 n34 0.38988a
Cext_89 n20 n36 14.6847a
Cext_90 n20 n47 25.1185a
Cext_91 n20 n48 280.12a
Cext_92 n20 n49 285.733a
Cext_93 n20 n50 242.019a
Cext_94 n20 bb3 3.55295a
Cext_95 n20 en 325.795a
Cext_96 n20 osc_clk 29.6164a
Cext_97 n20 trim3 84.6657a
Cext_98 n20 va 740.683a
Cext_99 n20 vb 61.5245a
Cext_100 n20 vdd 135.664a
Cext_101 n20 vss 531.875a
Cext_102 n20 vss 2.40287f
Cext_103 n22 n24 191.391a
Cext_104 n22 n25 1.25402f
Cext_105 n22 n26 664.904a
Cext_106 n22 n27 50.9036a
Cext_107 n22 n30 3.65411f
Cext_108 n22 n31 73.8516a
Cext_109 n22 n33 0.946963a
Cext_110 n22 n34 1.13601a
Cext_111 n22 n36 6.70966f
Cext_112 n22 n47 226.16a
Cext_113 n22 n48 36.0858a
Cext_114 n22 n49 115.085a
Cext_115 n22 n50 269.131a
Cext_116 n22 en 552.873a
Cext_117 n22 osc_clk 46.6735a
Cext_118 n22 trim3 0.475957a
Cext_119 n22 va 16.9498a
Cext_120 n22 vb 861.124a
Cext_121 n22 vdd 271.328a
Cext_122 n22 vss 192.032a
Cext_123 n22 vss 2.08429f
Cext_124 n24 n25 9.66497f
Cext_125 n24 n26 936.81a
Cext_126 n24 n27 2.39932f
Cext_127 n24 n30 113.721a
Cext_128 n24 n31 135.908a
Cext_129 n24 n33 120.62a
Cext_130 n24 n34 106.931a
Cext_131 n24 n35 114.293a
Cext_132 n24 n36 149.17a
Cext_133 n24 n47 1.60002f
Cext_134 n24 n48 23.5086a
Cext_135 n24 n49 91.5875a
Cext_136 n24 n50 574.363a
Cext_137 n24 en 8.22203f
Cext_138 n24 osc_clk 474.395a
Cext_139 n24 va 0.824592a
Cext_140 n24 vb 3.27644a
Cext_141 n24 vdd 175.773a
Cext_142 n24 vss 514.148a
Cext_143 n24 vss 4.41793f
Cext_144 n25 n26 1.03119f
Cext_145 n25 n27 4.62989f
Cext_146 n25 n30 87.6804a
Cext_147 n25 n31 101.047a
Cext_148 n25 n33 96.7839a
Cext_149 n25 n34 82.925a
Cext_150 n25 n35 83.8483a
Cext_151 n25 n36 1.22538f
Cext_152 n25 n47 135.273a
Cext_153 n25 n48 23.5086a
Cext_154 n25 n49 493.121a
Cext_155 n25 n50 61.0703a
Cext_156 n25 en 125.155a
Cext_157 n25 osc_clk 75.3a
Cext_158 n25 vb 0.298178a
Cext_159 n25 vdd 129.425a
Cext_160 n25 vss 405.73a
Cext_161 n25 vss 3.34405f
Cext_162 n26 n27 13.871a
Cext_163 n26 n30 23.5086a
Cext_164 n26 n31 35.0593a
Cext_165 n26 n33 25.4358a
Cext_166 n26 n34 25.4358a
Cext_167 n26 n35 25.4358a
Cext_168 n26 n36 25.4358a
Cext_169 n26 n47 25.4358a
Cext_170 n26 en 1.3487f
Cext_171 n26 vdd 5.45034a
Cext_172 n26 vss 105.183a
Cext_173 n26 vss 807.193a
Cext_174 n27 n30 648.11a
Cext_175 n27 n31 79.262a
Cext_176 n27 n33 63.5401a
Cext_177 n27 n34 49.5074a
Cext_178 n27 n35 49.0983a
Cext_179 n27 n36 47.1451a
Cext_180 n27 n47 47.1451a
Cext_181 n27 n48 23.5086a
Cext_182 n27 n49 23.5086a
Cext_183 n27 n50 21.2327a
Cext_184 n27 en 123.168a
Cext_185 n27 osc_clk 7.14936f
Cext_186 n27 va 0.15842a
Cext_187 n27 vdd 162.86a
Cext_188 n27 vss 110.493a
Cext_189 n27 vss 1.8181f
Cext_190 n29 n30 328.412a
Cext_191 n29 n31 343.624a
Cext_192 n29 va 512.195a
Cext_193 n29 vbn 1.57844f
Cext_194 n29 vss 99.3798a
Cext_195 n29 vss 528.6a
Cext_196 n29 vth 70.5511a
Cext_197 n3 n4 112.166a
Cext_198 n3 n5 19.4868a
Cext_199 n3 n6 0.435309a
Cext_200 n3 vss 5.57995a
Cext_201 n3 vss 899.272a
Cext_202 n30 n31 1.49559f
Cext_203 n30 n32 41.2058a
Cext_204 n30 n33 50.0715a
Cext_205 n30 n34 60.125a
Cext_206 n30 n35 63.6437a
Cext_207 n30 n36 125.718a
Cext_208 n30 n47 61.4055a
Cext_209 n30 b0 20.6948a
Cext_210 n30 b1 19.4865a
Cext_211 n30 b2 19.4865a
Cext_212 n30 b3 19.4865a
Cext_213 n30 bb0 17.0201a
Cext_214 n30 bb1 17.0201a
Cext_215 n30 bb2 17.0201a
Cext_216 n30 bb3 17.0201a
Cext_217 n30 en 69.0207a
Cext_218 n30 osc_clk 108.218a
Cext_219 n30 trim0 498.615a
Cext_220 n30 trim1 498.514a
Cext_221 n30 trim2 498.514a
Cext_222 n30 trim3 499.843a
Cext_223 n30 va 6.14195f
Cext_224 n30 vb 26.7297a
Cext_225 n30 vbn 3.02069f
Cext_226 n30 vdd 289.357a
Cext_227 n30 vss 9.98916a
Cext_228 n30 vss 2.12402f
Cext_229 n30 vth 34.7167a
Cext_230 n31 n32 54.294a
Cext_231 n31 n33 42.4455a
Cext_232 n31 n34 61.5555a
Cext_233 n31 n35 63.7635a
Cext_234 n31 n36 71.4041a
Cext_235 n31 n47 62.9721a
Cext_236 n31 b0 20.8009a
Cext_237 n31 b1 20.8009a
Cext_238 n31 b2 20.8009a
Cext_239 n31 b3 20.8009a
Cext_240 n31 bb0 18.3345a
Cext_241 n31 bb1 18.3345a
Cext_242 n31 bb2 18.3345a
Cext_243 n31 bb3 18.3345a
Cext_244 n31 en 65.9611a
Cext_245 n31 osc_clk 58.2546a
Cext_246 n31 trim0 514.482a
Cext_247 n31 trim1 514.364a
Cext_248 n31 trim2 514.364a
Cext_249 n31 trim3 514.364a
Cext_250 n31 va 22.5816a
Cext_251 n31 vb 43.7478a
Cext_252 n31 vbn 2.72209f
Cext_253 n31 vdd 224.735a
Cext_254 n31 vss 211.62a
Cext_255 n31 vss 3.00807f
Cext_256 n31 vth 767.835a
Cext_257 n32 n33 779.492a
Cext_258 n32 n34 560.844a
Cext_259 n32 va 41.2058a
Cext_260 n32 vb 783.074a
Cext_261 n32 vbn 1.23282f
Cext_262 n32 vss 97.349a
Cext_263 n32 vss 793.462a
Cext_264 n32 vth 116.192a
Cext_265 n33 n34 9.35821f
Cext_266 n33 n35 227.74a
Cext_267 n33 n36 1.70708a
Cext_268 n33 n47 4.63079f
Cext_269 n33 b0 19.0574a
Cext_270 n33 b1 17.849a
Cext_271 n33 b2 17.849a
Cext_272 n33 b3 17.849a
Cext_273 n33 bb0 17.849a
Cext_274 n33 bb1 17.849a
Cext_275 n33 bb2 17.849a
Cext_276 n33 bb3 19.0918a
Cext_277 n33 en 72.5942a
Cext_278 n33 osc_clk 84.9624a
Cext_279 n33 trim0 29.1239a
Cext_280 n33 trim1 29.0234a
Cext_281 n33 trim2 29.0234a
Cext_282 n33 trim3 24.4788a
Cext_283 n33 va 37.1358a
Cext_284 n33 vb 5.2786f
Cext_285 n33 vbn 41.2389a
Cext_286 n33 vdd 303.841a
Cext_287 n33 vss 3.55576a
Cext_288 n33 vss 1.9346f
Cext_289 n33 vth 45.4679a
Cext_290 n34 n35 1.71792f
Cext_291 n34 n36 382.577a
Cext_292 n34 n47 145.475a
Cext_293 n34 b0 18.5152a
Cext_294 n34 b1 17.3068a
Cext_295 n34 b2 17.3068a
Cext_296 n34 b3 17.3068a
Cext_297 n34 bb0 17.3068a
Cext_298 n34 bb1 17.3068a
Cext_299 n34 bb2 17.3068a
Cext_300 n34 bb3 18.5496a
Cext_301 n34 en 53.5788a
Cext_302 n34 osc_clk 52.4793a
Cext_303 n34 trim0 29.2845a
Cext_304 n34 trim1 29.0234a
Cext_305 n34 trim2 29.0234a
Cext_306 n34 trim3 24.4788a
Cext_307 n34 va 52.2598a
Cext_308 n34 vb 21.5808a
Cext_309 n34 vbn 55.1913a
Cext_310 n34 vdd 227.264a
Cext_311 n34 vss 152.706a
Cext_312 n34 vss 1.75216f
Cext_313 n34 vth 1.0116f
Cext_314 n35 n36 1.39652f
Cext_315 n35 n47 5.23453f
Cext_316 n35 n48 0.145066a
Cext_317 n35 b0 230.672a
Cext_318 n35 b1 182.614a
Cext_319 n35 b2 182.614a
Cext_320 n35 b3 182.614a
Cext_321 n35 bb0 182.614a
Cext_322 n35 bb1 182.614a
Cext_323 n35 bb2 182.614a
Cext_324 n35 bb3 184.361a
Cext_325 n35 en 5.11452f
Cext_326 n35 osc_clk 51.3495a
Cext_327 n35 trim0 36.4837a
Cext_328 n35 trim1 35.8659a
Cext_329 n35 trim2 35.8659a
Cext_330 n35 trim3 31.3214a
Cext_331 n35 va 58.9028a
Cext_332 n35 vb 3.63107f
Cext_333 n35 vbn 195.243a
Cext_334 n35 vdd 160.081a
Cext_335 n35 vss 323.998a
Cext_336 n35 vss 2.32222f
Cext_337 n35 vth 239.545a
Cext_338 n36 n47 90.513a
Cext_339 n36 n48 62.6065a
Cext_340 n36 n49 1.41264f
Cext_341 n36 n50 40.4364a
Cext_342 n36 b0 18.2284a
Cext_343 n36 b1 17.0201a
Cext_344 n36 b2 17.0201a
Cext_345 n36 b3 17.0201a
Cext_346 n36 bb0 17.0201a
Cext_347 n36 bb1 17.0201a
Cext_348 n36 bb2 17.0201a
Cext_349 n36 bb3 18.2628a
Cext_350 n36 en 96.7417a
Cext_351 n36 osc_clk 50.133a
Cext_352 n36 trim0 30.3619a
Cext_353 n36 trim1 29.9751a
Cext_354 n36 trim2 29.9751a
Cext_355 n36 trim3 25.4305a
Cext_356 n36 va 3.03243f
Cext_357 n36 vb 21.0333a
Cext_358 n36 vbn 45.527a
Cext_359 n36 vdd 161.315a
Cext_360 n36 vss 204.672a
Cext_361 n36 vss 2.0304f
Cext_362 n36 vth 8.3107a
Cext_363 n4 vss 1.90575a
Cext_364 n4 vss 538.771a
Cext_365 n47 n48 104.614a
Cext_366 n47 n49 0.145066a
Cext_367 n47 n50 909.605a
Cext_368 n47 en 1.92915f
Cext_369 n47 osc_clk 50.5931a
Cext_370 n47 trim3 0.293346a
Cext_371 n47 va 1.39024a
Cext_372 n47 vb 90.8067a
Cext_373 n47 vdd 146.344a
Cext_374 n47 vss 201.742a
Cext_375 n47 vss 1.81457f
Cext_376 n48 n49 11.7204a
Cext_377 n48 n50 1.04568f
Cext_378 n48 en 128.506a
Cext_379 n48 osc_clk 34.6659a
Cext_380 n48 vdd 343.549a
Cext_381 n48 vss 3.04012a
Cext_382 n48 vss 823.746a
Cext_383 n49 n50 79.3398a
Cext_384 n49 en 41.8431a
Cext_385 n49 osc_clk 33.9458a
Cext_386 n49 vdd 202.103a
Cext_387 n49 vss 3.04012a
Cext_388 n49 vss 848.794a
Cext_389 n5 n6 16.5508a
Cext_390 n5 vss 1.90595a
Cext_391 n5 vss 538.771a
Cext_392 n50 en 36.1006a
Cext_393 n50 osc_clk 32.39a
Cext_394 n50 vdd 16.9341a
Cext_395 n50 vss 2.48322a
Cext_396 n50 vss 652.946a
Cext_397 n52 n53 16.6579a
Cext_398 n52 vdd 22.6989a
Cext_399 n52 vss 538.771a
Cext_400 n52 vth 2.56667a
Cext_401 n53 vdd 2.87737a
Cext_402 n53 vss 538.771a
Cext_403 n53 vth 27.8301a
Cext_404 n54 n55 16.6579a
Cext_405 n54 vdd 2.33853a
Cext_406 n54 vss 2.56667a
Cext_407 n54 vss 538.771a
Cext_408 n54 vth 21.4267a
Cext_409 n55 vdd 2.33853a
Cext_410 n55 vss 27.8301a
Cext_411 n55 vss 538.771a
Cext_412 n55 vth 0.855517a
Cext_413 n6 n7 16.6579a
Cext_414 n6 vss 1.90595a
Cext_415 n6 vss 538.771a
Cext_416 n7 n8 16.6579a
Cext_417 n7 vss 1.90595a
Cext_418 n7 vss 538.771a
Cext_419 n8 n9 16.6579a
Cext_420 n8 vss 1.90595a
Cext_421 n8 vss 538.771a
Cext_422 n9 vss 1.90595a
Cext_423 n9 vss 538.771a
Cext_424 b0 b1 1.8122f
Cext_425 b0 b2 28.3487a
Cext_426 b0 b3 28.3487a
Cext_427 b0 bb0 516.605a
Cext_428 b0 bb1 62.5046a
Cext_429 b0 bb2 26.4179a
Cext_430 b0 bb3 26.4179a
Cext_431 b0 en 3.96779f
Cext_432 b0 osc_clk 86.4088a
Cext_433 b0 trim0 767.992a
Cext_434 b0 trim1 24.4694a
Cext_435 b0 trim2 24.4694a
Cext_436 b0 trim3 24.4694a
Cext_437 b0 va 3.88116f
Cext_438 b0 vb 52.8665a
Cext_439 b0 vbn 587.462a
Cext_440 b0 vth 0.113924a
Cext_441 b1 b2 31.3631a
Cext_442 b1 b3 31.3631a
Cext_443 b1 bb0 1.42816f
Cext_444 b1 bb1 605.981a
Cext_445 b1 bb2 29.4324a
Cext_446 b1 bb3 29.4324a
Cext_447 b1 en 33.8337a
Cext_448 b1 osc_clk 309.204a
Cext_449 b1 trim0 811.741a
Cext_450 b1 trim1 771.16a
Cext_451 b1 trim2 27.4838a
Cext_452 b1 trim3 30.7302a
Cext_453 b1 va 1.6597f
Cext_454 b1 vb 3.75809f
Cext_455 b1 vth 0.267801a
Cext_456 b2 b3 1.20045f
Cext_457 b2 bb0 117.229a
Cext_458 b2 bb1 341.649a
Cext_459 b2 bb2 853.686a
Cext_460 b2 bb3 110.347a
Cext_461 b2 en 33.8337a
Cext_462 b2 trim1 987.005a
Cext_463 b2 trim2 776.695a
Cext_464 b2 trim3 190.756a
Cext_465 b2 va 48.3832a
Cext_466 b2 vb 75.3782a
Cext_467 b2 vth 77.5981a
Cext_468 b3 bb0 529.335a
Cext_469 b3 bb1 30.0505a
Cext_470 b3 bb2 310.119a
Cext_471 b3 bb3 879.017a
Cext_472 b3 en 33.8337a
Cext_473 b3 trim2 1.10384f
Cext_474 b3 trim3 780.943a
Cext_475 b3 va 48.3832a
Cext_476 b3 vb 167.533a
Cext_477 b3 vth 44.0686a
Cext_478 bb0 bb1 7.87022f
Cext_479 bb0 bb2 37.0499a
Cext_480 bb0 bb3 34.5152a
Cext_481 bb0 en 31.9029a
Cext_482 bb0 osc_clk 569.351a
Cext_483 bb0 trim0 2.34995f
Cext_484 bb0 trim1 36.9955a
Cext_485 bb0 trim2 36.457a
Cext_486 bb0 trim3 102.885a
Cext_487 bb0 va 77.373a
Cext_488 bb0 vb 131.503a
Cext_489 bb0 vbn 132.884a
Cext_490 bb0 vth 372.283a
Cext_491 bb1 bb2 3.16898f
Cext_492 bb1 bb3 62.7499a
Cext_493 bb1 en 31.9029a
Cext_494 bb1 osc_clk 13.1578a
Cext_495 bb1 trim0 3.47551a
Cext_496 bb1 trim1 2.70631f
Cext_497 bb1 trim2 38.5874a
Cext_498 bb1 trim3 39.6942a
Cext_499 bb1 va 77.5932a
Cext_500 bb1 vb 116.466a
Cext_501 bb1 vth 67.5919a
Cext_502 bb2 bb3 3.49329f
Cext_503 bb2 en 31.9029a
Cext_504 bb2 trim1 3.32285a
Cext_505 bb2 trim2 2.94677f
Cext_506 bb2 trim3 39.8791a
Cext_507 bb2 va 57.1235a
Cext_508 bb2 vb 82.1861a
Cext_509 bb2 vth 45.5319a
Cext_510 bb3 en 40.4206a
Cext_511 bb3 trim2 3.32285a
Cext_512 bb3 trim3 3.19004f
Cext_513 bb3 va 72.1305a
Cext_514 bb3 vb 122.531a
Cext_515 bb3 vth 61.2706a
Cext_516 en osc_clk 1.03278f
Cext_517 en trim0 248.945a
Cext_518 en trim1 29.9544a
Cext_519 en trim2 29.9544a
Cext_520 en trim3 30.1979a
Cext_521 en va 1.55177f
Cext_522 en vb 45.1641a
Cext_523 en vbn 39.8689a
Cext_524 en vth 46.6665a
Cext_525 osc_clk va 61.5743a
Cext_526 osc_clk vb 279.734a
Cext_527 osc_clk vth 0.302908a
Cext_528 trim0 trim1 337.362a
Cext_529 trim0 va 3.78993f
Cext_530 trim0 vb 1.66541f
Cext_531 trim0 vbn 162.619a
Cext_532 trim0 vth 42.1904a
Cext_533 trim1 trim2 807.676a
Cext_534 trim1 va 130.865a
Cext_535 trim1 vb 4.06513f
Cext_536 trim1 vbn 34.2365a
Cext_537 trim1 vth 3.17319f
Cext_538 trim2 trim3 1.48515f
Cext_539 trim2 va 133.879a
Cext_540 trim2 vb 96.1114a
Cext_541 trim2 vbn 1.8053f
Cext_542 trim2 vth 3.40139f
Cext_543 trim3 va 1.10817f
Cext_544 trim3 vb 177.21a
Cext_545 trim3 vbn 1.81207f
Cext_546 trim3 vth 135.611a
Cext_547 va vb 3.20348f
Cext_548 va vbn 379.736a
Cext_549 va vth 3.50347f
Cext_550 vb vbn 129.665a
Cext_551 vb vth 2.25378f
Cext_552 vbn vth 243.077a
Cext_553 vdd b0 85.585a
Cext_554 vdd b1 70.6541a
Cext_555 vdd b2 34.9925a
Cext_556 vdd b3 34.9925a
Cext_557 vdd bb0 51.3369a
Cext_558 vdd bb1 51.3369a
Cext_559 vdd bb2 32.628a
Cext_560 vdd bb3 36.0579a
Cext_561 vdd en 534.479a
Cext_562 vdd osc_clk 362.488a
Cext_563 vdd trim0 29.0028a
Cext_564 vdd trim1 25.4851a
Cext_565 vdd trim2 24.3218a
Cext_566 vdd trim3 24.3218a
Cext_567 vdd va 82.103a
Cext_568 vdd vb 265.014a
Cext_569 vdd vbn 83.9096a
Cext_570 vdd vss 2.8321f
Cext_571 vdd vss 41.759f
Cext_572 vdd vth 132.955a
Cext_573 vss b0 462.59a
Cext_574 vss b1 522.424a
Cext_575 vss b2 438.505a
Cext_576 vss b3 1.88595f
Cext_577 vss bb0 491.694a
Cext_578 vss bb1 3.59722f
Cext_579 vss bb2 525.003a
Cext_580 vss bb3 4.848f
Cext_581 vss en 383.026a
Cext_582 vss osc_clk 152.556a
Cext_583 vss trim0 1.01844f
Cext_584 vss trim1 1.01547f
Cext_585 vss trim2 1.01382f
Cext_586 vss trim3 1.43072f
Cext_587 vss va 560.877a
Cext_588 vss vb 2.80259f
Cext_589 vss vbn 1.22922f
Cext_590 vss vss 98.4246f
Cext_591 vss vth 4.69171f
Cext_592 vss b0 3.75019f
Cext_593 vss b1 3.83514f
Cext_594 vss b2 1.61204f
Cext_595 vss b3 1.95914f
Cext_596 vss bb0 4.36991f
Cext_597 vss bb1 3.2974f
Cext_598 vss bb2 1.89501f
Cext_599 vss bb3 2.50545f
Cext_600 vss en 7.27274f
Cext_601 vss osc_clk 4.00186f
Cext_602 vss trim0 2.77906f
Cext_603 vss trim1 2.51851f
Cext_604 vss trim2 2.69863f
Cext_605 vss trim3 4.50772f
Cext_606 vss va 10.8668f
Cext_607 vss vb 11.2541f
Cext_608 vss vbn 5.80056f
Cext_609 vss vth 10.3128f
XCF_A va vss cap_cmim w=31.65u l=31.65u m=1 mm_ok=1
XCT0_A va b0 cap_cmim w=8.16u l=8.16u m=1 mm_ok=1
XCT1_A va b1 cap_cmim w=11.55u l=11.55u m=1 mm_ok=1
XCT2_A va b2 cap_cmim w=16.33u l=16.33u m=1 mm_ok=1
XCT3_A va b3 cap_cmim w=23.09u l=23.09u m=1 mm_ok=1
XCF_B vb vss cap_cmim w=31.65u l=31.65u m=1 mm_ok=1
XCT0_B vb bb0 cap_cmim w=8.16u l=8.16u m=1 mm_ok=1
XCT1_B vb bb1 cap_cmim w=11.55u l=11.55u m=1 mm_ok=1
XCT2_B vb bb2 cap_cmim w=16.33u l=16.33u m=1 mm_ok=1
XCT3_B vb bb3 cap_cmim w=23.09u l=23.09u m=1 mm_ok=1
XCTH vth vss cap_cmim w=26u l=26u m=1 mm_ok=1
.ends
