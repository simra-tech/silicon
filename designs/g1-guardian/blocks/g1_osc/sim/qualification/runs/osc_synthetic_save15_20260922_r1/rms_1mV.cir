* G1_OSC testbench: frequency, duty cycle, supply current at one corner/temperature/supply/trim code
* @@ fields are substituted by run_osc.sh (variants written to build/g1_osc/).
.param VDD=1.2
.lib /foss/pdks/ihp-sg13g2/libs.tech/ngspice/models/cornerMOSlv.lib mos_tt
.lib /foss/pdks/ihp-sg13g2/libs.tech/ngspice/models/cornerRES.lib res_typ
.lib /foss/pdks/ihp-sg13g2/libs.tech/ngspice/models/cornerCAP.lib cap_typ
.lib /foss/pdks/ihp-sg13g2/libs.tech/ngspice/models/cornerDIO.lib dio_tt
* (dio_tt: the antenna diode dantenna on vth, revision 5; the diode library has one corner set)
.temp 27
* rshunt: 1 TOhm from every node to ground; without it the operating point with the antenna diode
* (revision 5) does not converge and the transient crawls (the rppd body node sub! is floating)
.option rshunt=1e12
.include osc.spice
* supply replaced by stored synthetic PWL
Ven en 0 pulse(0 {VDD} 50n 1n 1n 100 200)
Vt0 trim0 0 dc {VDD*0}
Vt1 trim1 0 dc {VDD*0}
Vt2 trim2 0 dc {VDD*0}
Vt3 trim3 0 dc {VDD*1}
X1 en trim0 trim1 trim2 trim3 osc_clk vdd 0 g1_osc
Cload osc_clk 0 50f
Vnoise vdd 0 PWL(
+ 0 1.2
+ 2e-09 1.19999967257841
+ 4e-09 1.19999916073975
+ 6e-09 1.19999975425675
+ 8e-09 1.20000310404827
+ 1e-08 1.20000404923216
+ 1.2e-08 1.20000349455945
+ 1.4e-08 1.20000430217267
+ 1.6e-08 1.20000567337714
+ 1.8e-08 1.20000738541126
+ 2e-08 1.20001075579345
+ 2.2e-08 1.20001378658964
+ 2.4e-08 1.20000218378597
+ 2.6e-08 1.20000705200096
+ 2.8e-08 1.20001169236856
+ 3e-08 1.20002136273027
+ 3.2e-08 1.20003132565034
+ 3.4e-08 1.20002115057994
+ 3.6e-08 1.20002317724925
+ 3.8e-08 1.20002174900588
+ 4e-08 1.20002166734668
+ 4.2e-08 1.20001606989925
+ 4.4e-08 1.2000296009115
+ 4.6e-08 1.20003097142029
+ 4.8e-08 1.20003223566702
+ 5e-08 1.20003798785925
+ 5.2e-08 1.20005136184998
+ 5.4e-08 1.20006407337896
+ 5.6e-08 1.20007400960343
+ 5.8e-08 1.20007112558225
+ 6e-08 1.20009174231484
+ 6.2e-08 1.20009235430094
+ 6.4e-08 1.20009304244704
+ 6.6e-08 1.20009342334959
+ 6.8e-08 1.20011296201756
+ 7e-08 1.20008903017835
+ 7.2e-08 1.2000940707779
+ 7.4e-08 1.20009160262051
+ 7.6e-08 1.20006744106767
+ 7.8e-08 1.20004016676622
+ 8e-08 1.20003889093811
+ 8.2e-08 1.20000978463811
+ 8.4e-08 1.20002714543724
+ 8.6e-08 1.20003407178301
+ 8.8e-08 1.20003034680287
+ 9e-08 1.20001351173803
+ 9.2e-08 1.20004244664501
+ 9.4e-08 1.20002859368023
+ 9.6e-08 1.20006512051896
+ 9.8e-08 1.20005454855972
+ 1e-07 1.2000376392731
+ 1.02e-07 1.20005921706429
+ 1.04e-07 1.2000810171082
+ 1.06e-07 1.20006496092341
+ 1.08e-07 1.20011284354543
+ 1.1e-07 1.20013940815872
+ 1.12e-07 1.20018104691693
+ 1.14e-07 1.20020980913273
+ 1.16e-07 1.20019861782945
+ 1.18e-07 1.20015841342915
+ 1.2e-07 1.20016158975135
+ 1.22e-07 1.20019651108194
+ 1.24e-07 1.2001771766548
+ 1.26e-07 1.20016807948267
+ 1.28e-07 1.20015688268233
+ 1.3e-07 1.20015656935057
+ 1.32e-07 1.20010133316117
+ 1.34e-07 1.20010365447486
+ 1.36e-07 1.20012377561778
+ 1.38e-07 1.2001165122849
+ 1.4e-07 1.2001319345676
+ 1.42e-07 1.20014202524006
+ 1.44e-07 1.20015442286474
+ 1.46e-07 1.2001972918122
+ 1.48e-07 1.20022837970765
+ 1.5e-07 1.20025797297263
+ 1.52e-07 1.20027520456622
+ 1.54e-07 1.20029228513294
+ 1.56e-07 1.20025045008375
+ 1.58e-07 1.20024565576558
+ 1.6e-07 1.20020260250008
+ 1.62e-07 1.20021645903639
+ 1.64e-07 1.20019895849508
+ 1.66e-07 1.20022757042304
+ 1.68e-07 1.20022730454261
+ 1.7e-07 1.20023887997148
+ 1.72e-07 1.20022841780543
+ 1.74e-07 1.20023258844536
+ 1.76e-07 1.20024488545925
+ 1.78e-07 1.20025225191544
+ 1.8e-07 1.20023809430609
+ 1.82e-07 1.20016785696675
+ 1.84e-07 1.20017624217273
+ 1.86e-07 1.20013527778525
+ 1.88e-07 1.20005618838346
+ 1.9e-07 1.20007547583322
+ 1.92e-07 1.20005604448471
+ 1.94e-07 1.19998427020548
+ 1.96e-07 1.19999260064155
+ 1.98e-07 1.2000262203197
+ 2e-07 1.20002881099165
+ 2.02e-07 1.20006205972867
+ 2.04e-07 1.1999890016133
+ 2.06e-07 1.1999707453032
+ 2.08e-07 1.19997582149139
+ 2.1e-07 1.19998729346472
+ 2.12e-07 1.19993883539543
+ 2.14e-07 1.19992511459983
+ 2.16e-07 1.19993179600183
+ 2.18e-07 1.19988059545786
+ 2.2e-07 1.19990174895619
+ 2.22e-07 1.19997097820817
+ 2.24e-07 1.20002376015542
+ 2.26e-07 1.20006981535648
+ 2.28e-07 1.20005356560599
+ 2.3e-07 1.20001220164216
+ 2.32e-07 1.20008093543511
+ 2.34e-07 1.20003068668262
+ 2.36e-07 1.20003507542264
+ 2.38e-07 1.19995139793482
+ 2.4e-07 1.19994649491187
+ 2.42e-07 1.19992401982733
+ 2.44e-07 1.19993610377076
+ 2.46e-07 1.20002522792578
+ 2.48e-07 1.19996822545179
+ 2.5e-07 1.19998306236151
+ 2.52e-07 1.2000620218672
+ 2.54e-07 1.20012583567227
+ 2.56e-07 1.20013238869006
+ 2.58e-07 1.20006295253802
+ 2.6e-07 1.2000040660386
+ 2.62e-07 1.19996493834422
+ 2.64e-07 1.20014108768173
+ 2.66e-07 1.20014245699239
+ 2.68e-07 1.20022026958995
+ 2.7e-07 1.20019398035184
+ 2.72e-07 1.20021935643782
+ 2.74e-07 1.20030152991184
+ 2.76e-07 1.2002385997691
+ 2.78e-07 1.20028283125255
+ 2.8e-07 1.20034287774917
+ 2.82e-07 1.20039949201208
+ 2.84e-07 1.2003771099999
+ 2.86e-07 1.20037395581036
+ 2.88e-07 1.20029614709039
+ 2.9e-07 1.20029875948346
+ 2.92e-07 1.20028061228091
+ 2.94e-07 1.20019783536029
+ 2.96e-07 1.2002189578882
+ 2.98e-07 1.20020406281479
+ 3e-07 1.20025539505366
+ 3.02e-07 1.20023594116071
+ 3.04e-07 1.20024750615509
+ 3.06e-07 1.20012310978162
+ 3.08e-07 1.2000643143636
+ 3.1e-07 1.20012970159281
+ 3.12e-07 1.20002082301698
+ 3.14e-07 1.19986523035765
+ 3.16e-07 1.1998500072432
+ 3.18e-07 1.19982796954996
+ 3.2e-07 1.19995420125673
+ 3.22e-07 1.19996665726774
+ 3.24e-07 1.20000862317677
+ 3.26e-07 1.19995009033406
+ 3.28e-07 1.19986169094605
+ 3.3e-07 1.19984165337018
+ 3.32e-07 1.19991126108865
+ 3.34e-07 1.19982978879115
+ 3.36e-07 1.19983978385579
+ 3.38e-07 1.1997909908852
+ 3.4e-07 1.19971141599068
+ 3.42e-07 1.19970302136581
+ 3.44e-07 1.1996579338169
+ 3.46e-07 1.19965384884177
+ 3.48e-07 1.19967238500772
+ 3.5e-07 1.19970709464888
+ 3.52e-07 1.19973477728382
+ 3.54e-07 1.19974029281278
+ 3.56e-07 1.19968188397037
+ 3.58e-07 1.19971865796925
+ 3.6e-07 1.19978042730827
+ 3.62e-07 1.19986314418118
+ 3.64e-07 1.19991138223846
+ 3.66e-07 1.1999047380579
+ 3.68e-07 1.19995329929352
+ 3.7e-07 1.19998022424518
+ 3.72e-07 1.20003583932823
+ 3.74e-07 1.20002535355096
+ 3.76e-07 1.19997837852433
+ 3.78e-07 1.1999937146722
+ 3.8e-07 1.20004580446494
+ 3.82e-07 1.20004752049116
+ 3.84e-07 1.1999587476234
+ 3.86e-07 1.20010447330989
+ 3.88e-07 1.20011607403646
+ 3.9e-07 1.20027819794757
+ 3.92e-07 1.20031330940077
+ 3.94e-07 1.2003284356292
+ 3.96e-07 1.2002656430818
+ 3.98e-07 1.20033499874939
+ 4e-07 1.20032484082332
+ 4.02e-07 1.20026842509356
+ 4.04e-07 1.20019577059441
+ 4.06e-07 1.20020249497871
+ 4.08e-07 1.20016239146666
+ 4.1e-07 1.20019956564691
+ 4.12e-07 1.20002369312455
+ 4.14e-07 1.19992054500164
+ 4.16e-07 1.19994323689717
+ 4.18e-07 1.19997911125052
+ 4.2e-07 1.20000299247038
+ 4.22e-07 1.1999680678511
+ 4.24e-07 1.20001576704071
+ 4.26e-07 1.19999417077203
+ 4.28e-07 1.20005822960342
+ 4.3e-07 1.2000668256853
+ 4.32e-07 1.20012875102718
+ 4.34e-07 1.20011428867626
+ 4.36e-07 1.19987594043234
+ 4.38e-07 1.19972810996926
+ 4.4e-07 1.19964066412157
+ 4.42e-07 1.19968003435273
+ 4.44e-07 1.19968686675063
+ 4.46e-07 1.19967521504687
+ 4.48e-07 1.19969615944323
+ 4.5e-07 1.1998094308059
+ 4.52e-07 1.19986834634988
+ 4.54e-07 1.19995029554586
+ 4.56e-07 1.19993202209887
+ 4.58e-07 1.1999133568502
+ 4.6e-07 1.19993244105049
+ 4.62e-07 1.20006434291581
+ 4.64e-07 1.20003587981448
+ 4.66e-07 1.20002721243819
+ 4.68e-07 1.19997828251662
+ 4.7e-07 1.19991007282772
+ 4.72e-07 1.20001430619189
+ 4.74e-07 1.19992256143858
+ 4.76e-07 1.19991622807471
+ 4.78e-07 1.19998233953881
+ 4.8e-07 1.19989144482191
+ 4.82e-07 1.19973545960012
+ 4.84e-07 1.1998270304898
+ 4.86e-07 1.19977882040689
+ 4.88e-07 1.19963471505197
+ 4.9e-07 1.19962825139915
+ 4.92e-07 1.19962769206587
+ 4.94e-07 1.19969849883539
+ 4.96e-07 1.19975329123501
+ 4.98e-07 1.19982962141679
+ 5e-07 1.19993375375635
+ 5.02e-07 1.19993890138108
+ 5.04e-07 1.19990629460151
+ 5.06e-07 1.19988938554018
+ 5.08e-07 1.19985473791224
+ 5.1e-07 1.20002150340415
+ 5.12e-07 1.20004502045895
+ 5.14e-07 1.20005137591844
+ 5.16e-07 1.20007825870216
+ 5.18e-07 1.20020496737102
+ 5.2e-07 1.20029649173414
+ 5.22e-07 1.20027247398065
+ 5.24e-07 1.20022966491574
+ 5.26e-07 1.20028275587389
+ 5.28e-07 1.20035217876396
+ 5.3e-07 1.20046381720283
+ 5.32e-07 1.2004280861182
+ 5.34e-07 1.20047340758521
+ 5.36e-07 1.20049090148882
+ 5.38e-07 1.20037454865887
+ 5.4e-07 1.20052745001168
+ 5.42e-07 1.20037905118481
+ 5.44e-07 1.20032477663131
+ 5.46e-07 1.20035462531272
+ 5.48e-07 1.20038739543892
+ 5.5e-07 1.20036214681148
+ 5.52e-07 1.20036004947732
+ 5.54e-07 1.2002309969509
+ 5.56e-07 1.20050695699123
+ 5.58e-07 1.20059668100632
+ 5.6e-07 1.20045805824971
+ 5.62e-07 1.20052722677625
+ 5.64e-07 1.20049536614446
+ 5.66e-07 1.20026041981173
+ 5.68e-07 1.20032409913393
+ 5.7e-07 1.20025644937002
+ 5.72e-07 1.20029204633051
+ 5.74e-07 1.20032834437422
+ 5.76e-07 1.20031041468654
+ 5.78e-07 1.20026439844254
+ 5.8e-07 1.20025499849369
+ 5.82e-07 1.20030659790304
+ 5.84e-07 1.20046725378039
+ 5.86e-07 1.20058623012609
+ 5.88e-07 1.20059616017054
+ 5.9e-07 1.20052782741405
+ 5.92e-07 1.20052889078687
+ 5.94e-07 1.20031408287011
+ 5.96e-07 1.20004022904402
+ 5.98e-07 1.19999605086994
+ 6e-07 1.19988389882963
+ 6.02e-07 1.20000856260694
+ 6.04e-07 1.19999095215729
+ 6.06e-07 1.20018711255086
+ 6.08e-07 1.20005448287933
+ 6.1e-07 1.1997335338884
+ 6.12e-07 1.19975671692528
+ 6.14e-07 1.19958181026161
+ 6.16e-07 1.1995021891796
+ 6.18e-07 1.19950925257777
+ 6.2e-07 1.19970249942871
+ 6.22e-07 1.19968439983353
+ 6.24e-07 1.19979244923916
+ 6.26e-07 1.19965946660534
+ 6.28e-07 1.19965701410524
+ 6.3e-07 1.19957134393547
+ 6.32e-07 1.1995804655833
+ 6.34e-07 1.19959258096807
+ 6.36e-07 1.19950484319937
+ 6.38e-07 1.19942879445184
+ 6.4e-07 1.19936540131319
+ 6.42e-07 1.19944232850012
+ 6.44e-07 1.19943456446503
+ 6.46e-07 1.19956328205411
+ 6.48e-07 1.19941899641389
+ 6.5e-07 1.19941595764011
+ 6.52e-07 1.19920098566254
+ 6.54e-07 1.19932936425629
+ 6.56e-07 1.1993414591726
+ 6.58e-07 1.19940768543855
+ 6.6e-07 1.19945842543427
+ 6.62e-07 1.19955773767084
+ 6.64e-07 1.19950400197091
+ 6.66e-07 1.199701651923
+ 6.68e-07 1.19956756600122
+ 6.7e-07 1.19988705635424
+ 6.72e-07 1.19990392138846
+ 6.74e-07 1.19998859707373
+ 6.76e-07 1.20016521334884
+ 6.78e-07 1.20038808628011
+ 6.8e-07 1.2006152381111
+ 6.82e-07 1.20048922535547
+ 6.84e-07 1.20057881087679
+ 6.86e-07 1.2005708100493
+ 6.88e-07 1.20059654797044
+ 6.9e-07 1.20061063274955
+ 6.92e-07 1.20060610558017
+ 6.94e-07 1.20078890694626
+ 6.96e-07 1.20070082598369
+ 6.98e-07 1.20074798351792
+ 7e-07 1.20057769383891
+ 7.02e-07 1.20074017561899
+ 7.04e-07 1.20078891688355
+ 7.06e-07 1.20060952339936
+ 7.08e-07 1.20061597190439
+ 7.1e-07 1.20076006130018
+ 7.12e-07 1.20086330990954
+ 7.14e-07 1.20067847097162
+ 7.16e-07 1.20061136924576
+ 7.18e-07 1.20059489297679
+ 7.2e-07 1.20096973081394
+ 7.22e-07 1.20077203510597
+ 7.24e-07 1.20067457686487
+ 7.26e-07 1.20051755228588
+ 7.28e-07 1.20044823555407
+ 7.3e-07 1.20048701832987
+ 7.32e-07 1.20054988465516
+ 7.34e-07 1.20047920177318
+ 7.36e-07 1.20021966538189
+ 7.38e-07 1.20036287363149
+ 7.4e-07 1.2003378926404
+ 7.42e-07 1.20035695681348
+ 7.44e-07 1.20035417779837
+ 7.46e-07 1.20014399420046
+ 7.48e-07 1.20018098538576
+ 7.5e-07 1.20030126029086
+ 7.52e-07 1.20017185724462
+ 7.54e-07 1.20015708793136
+ 7.56e-07 1.19989944944252
+ 7.58e-07 1.20009990170629
+ 7.6e-07 1.19999245236215
+ 7.62e-07 1.2001949750482
+ 7.64e-07 1.20010700431704
+ 7.66e-07 1.20012270346794
+ 7.68e-07 1.19990748467391
+ 7.7e-07 1.20022833675877
+ 7.72e-07 1.19993531021976
+ 7.74e-07 1.19994362818945
+ 7.76e-07 1.20009003219802
+ 7.78e-07 1.19990576314831
+ 7.8e-07 1.19979532936461
+ 7.82e-07 1.19977068604079
+ 7.84e-07 1.19995769645649
+ 7.86e-07 1.19993346779995
+ 7.88e-07 1.19998533420472
+ 7.9e-07 1.20021969776492
+ 7.92e-07 1.20012542512818
+ 7.94e-07 1.19999449244447
+ 7.96e-07 1.19994460177073
+ 7.98e-07 1.19965444226733
+ 8e-07 1.19956108091092
+ 8.02e-07 1.19986844091932
+ 8.04e-07 1.1998396688336
+ 8.06e-07 1.1999618792875
+ 8.08e-07 1.20007723102859
+ 8.1e-07 1.19971478755718
+ 8.12e-07 1.19969012587387
+ 8.14e-07 1.19969012205037
+ 8.16e-07 1.19993509775459
+ 8.18e-07 1.20024906527616
+ 8.2e-07 1.20036592084587
+ 8.22e-07 1.20018336923728
+ 8.24e-07 1.200109479387
+ 8.26e-07 1.20005811065088
+ 8.28e-07 1.19992148649564
+ 8.3e-07 1.19993197725935
+ 8.32e-07 1.20015840631212
+ 8.34e-07 1.20036055141202
+ 8.36e-07 1.20035370688119
+ 8.38e-07 1.2003404914045
+ 8.4e-07 1.20074051965033
+ 8.42e-07 1.20072974408158
+ 8.44e-07 1.20072805426
+ 8.46e-07 1.20071875900421
+ 8.48e-07 1.20070121215932
+ 8.5e-07 1.20089634244988
+ 8.52e-07 1.20117715866773
+ 8.54e-07 1.20126454931279
+ 8.56e-07 1.2010694746362
+ 8.58e-07 1.20075668167575
+ 8.6e-07 1.20068867166101
+ 8.62e-07 1.20065279658482
+ 8.64e-07 1.20054054908656
+ 8.66e-07 1.20065662296467
+ 8.68e-07 1.20073374152922
+ 8.7e-07 1.20072134049215
+ 8.72e-07 1.20092473596706
+ 8.74e-07 1.20118947304691
+ 8.76e-07 1.20116493523782
+ 8.78e-07 1.20100721729102
+ 8.8e-07 1.20139215847694
+ 8.82e-07 1.20132611194656
+ 8.84e-07 1.20116877760417
+ 8.86e-07 1.20124088342544
+ 8.88e-07 1.20110426380186
+ 8.9e-07 1.20114358267533
+ 8.92e-07 1.20121521610962
+ 8.94e-07 1.20081371690189
+ 8.96e-07 1.20084741574047
+ 8.98e-07 1.20070573936467
+ 9e-07 1.20051839870296
+ 9.02e-07 1.2005436158015
+ 9.04e-07 1.20058420207138
+ 9.06e-07 1.20071489965288
+ 9.08e-07 1.20072165671207
+ 9.1e-07 1.20074069026177
+ 9.12e-07 1.20097913761882
+ 9.14e-07 1.20054000828131
+ 9.16e-07 1.20051647018904
+ 9.18e-07 1.20050669959549
+ 9.2e-07 1.20029286861409
+ 9.22e-07 1.20007302814267
+ 9.24e-07 1.19998811588913
+ 9.26e-07 1.20017147327941
+ 9.28e-07 1.20038407615957
+ 9.3e-07 1.20041638034648
+ 9.32e-07 1.20039234829793
+ 9.34e-07 1.20043851979905
+ 9.36e-07 1.20047847405744
+ 9.38e-07 1.20038377395174
+ 9.4e-07 1.20079450969286
+ 9.42e-07 1.2006280620217
+ 9.44e-07 1.20075976689169
+ 9.46e-07 1.20082441128787
+ 9.48e-07 1.20091418395748
+ 9.5e-07 1.20065708443524
+ 9.52e-07 1.20059271718759
+ 9.54e-07 1.20075706066453
+ 9.56e-07 1.20055816274435
+ 9.58e-07 1.20041987967233
+ 9.6e-07 1.20054275363085
+ 9.62e-07 1.20032259115629
+ 9.64e-07 1.20022670367374
+ 9.66e-07 1.20033077698567
+ 9.68e-07 1.20038937514533
+ 9.7e-07 1.20027855677937
+ 9.72e-07 1.20040605601737
+ 9.74e-07 1.20021871491513
+ 9.76e-07 1.2005126757117
+ 9.78e-07 1.20023694400979
+ 9.8e-07 1.20040814065887
+ 9.82e-07 1.20020347017674
+ 9.84e-07 1.20032858167349
+ 9.86e-07 1.20007139096762
+ 9.88e-07 1.20036201192529
+ 9.9e-07 1.20044011077878
+ 9.92e-07 1.20045588264015
+ 9.94e-07 1.20027029015705
+ 9.96e-07 1.19993828112565
+ 9.98e-07 1.19994609574293
+ 1e-06 1.20012318904135
+ 1.002e-06 1.20000037420259
+ 1.004e-06 1.19979406832226
+ 1.006e-06 1.19988677019334
+ 1.008e-06 1.19978939761281
+ 1.01e-06 1.19981559184783
+ 1.012e-06 1.20017048183862
+ 1.014e-06 1.19989429923329
+ 1.016e-06 1.19969855301849
+ 1.018e-06 1.19992625751765
+ 1.02e-06 1.20009665419406
+ 1.022e-06 1.19966910069469
+ 1.024e-06 1.19957188785904
+ 1.026e-06 1.20000281588974
+ 1.028e-06 1.19984336934784
+ 1.03e-06 1.20007880857045
+ 1.032e-06 1.20041940310134
+ 1.034e-06 1.19996486477956
+ 1.036e-06 1.2001779947334
+ 1.038e-06 1.200182138627
+ 1.04e-06 1.19992879954697
+ 1.042e-06 1.1997776910626
+ 1.044e-06 1.19970566592161
+ 1.046e-06 1.20003419339401
+ 1.048e-06 1.19978531763125
+ 1.05e-06 1.19956105562152
+ 1.052e-06 1.20000362188631
+ 1.054e-06 1.20013893917744
+ 1.056e-06 1.19977892795121
+ 1.058e-06 1.19969579089982
+ 1.06e-06 1.19932013573267
+ 1.062e-06 1.19942721150676
+ 1.064e-06 1.199544645603
+ 1.066e-06 1.19961780004061
+ 1.068e-06 1.19953023940482
+ 1.07e-06 1.19956172640427
+ 1.072e-06 1.19963138053818
+ 1.074e-06 1.19988387070062
+ 1.076e-06 1.19998874047866
+ 1.078e-06 1.19989424068142
+ 1.08e-06 1.19997818200434
+ 1.082e-06 1.1996072918874
+ 1.084e-06 1.20007386902716
+ 1.086e-06 1.20026985955406
+ 1.088e-06 1.20012381429808
+ 1.09e-06 1.19993422043236
+ 1.092e-06 1.19979849796424
+ 1.094e-06 1.19990379425338
+ 1.096e-06 1.19967536914092
+ 1.098e-06 1.19965195406149
+ 1.1e-06 1.19956804164513
+ 1.102e-06 1.19964536748808
+ 1.104e-06 1.19953829018016
+ 1.106e-06 1.19954662054638
+ 1.108e-06 1.19942930353657
+ 1.11e-06 1.19960844499635
+ 1.112e-06 1.19960660733892
+ 1.114e-06 1.19997119915335
+ 1.116e-06 1.19987230368275
+ 1.118e-06 1.19987494783214
+ 1.12e-06 1.2000298688487
+ 1.122e-06 1.20022295802273
+ 1.124e-06 1.20005003721282
+ 1.126e-06 1.20018583991872
+ 1.128e-06 1.20011912386117
+ 1.13e-06 1.2002427669787
+ 1.132e-06 1.20005104295149
+ 1.134e-06 1.20015237398686
+ 1.136e-06 1.19973224746805
+ 1.138e-06 1.19975709875461
+ 1.14e-06 1.20008109983453
+ 1.142e-06 1.2000711042911
+ 1.144e-06 1.19988065762098
+ 1.146e-06 1.19981978119589
+ 1.148e-06 1.19966262447883
+ 1.15e-06 1.19983936272115
+ 1.152e-06 1.19963638576329
+ 1.154e-06 1.1998107734826
+ 1.156e-06 1.19977039592092
+ 1.158e-06 1.19998827650556
+ 1.16e-06 1.19977388485383
+ 1.162e-06 1.1999034644252
+ 1.164e-06 1.19976299658189
+ 1.166e-06 1.19995982493054
+ 1.168e-06 1.20005514396675
+ 1.17e-06 1.1998245094283
+ 1.172e-06 1.20000966755628
+ 1.174e-06 1.20001709293183
+ 1.176e-06 1.19980825182049
+ 1.178e-06 1.19977921949214
+ 1.18e-06 1.19985364564224
+ 1.182e-06 1.19998411904788
+ 1.184e-06 1.2002258495791
+ 1.186e-06 1.2004159827547
+ 1.188e-06 1.20032576696122
+ 1.19e-06 1.20038717322785
+ 1.192e-06 1.20049513380554
+ 1.194e-06 1.20037343988284
+ 1.196e-06 1.20054381257734
+ 1.198e-06 1.20068875460366
+ 1.2e-06 1.20053555540338
+ 1.202e-06 1.2009237564836
+ 1.204e-06 1.20065929013515
+ 1.206e-06 1.20064024247186
+ 1.208e-06 1.20077088543795
+ 1.21e-06 1.20048507760579
+ 1.212e-06 1.20073439669702
+ 1.214e-06 1.20105187899775
+ 1.216e-06 1.20095667197061
+ 1.218e-06 1.20113388017712
+ 1.22e-06 1.20117123467483
+ 1.222e-06 1.20123946042841
+ 1.224e-06 1.20147308175007
+ 1.226e-06 1.20119023714413
+ 1.228e-06 1.20111414499595
+ 1.23e-06 1.20101317365381
+ 1.232e-06 1.20098567489778
+ 1.234e-06 1.20098589229219
+ 1.236e-06 1.20110681835492
+ 1.238e-06 1.20098846017387
+ 1.24e-06 1.2010556268524
+ 1.242e-06 1.20089941435564
+ 1.244e-06 1.20096648448228
+ 1.246e-06 1.20058854060406
+ 1.248e-06 1.20051315695727
+ 1.25e-06 1.20050218857716
+ 1.252e-06 1.20040758794212
+ 1.254e-06 1.20004369267617
+ 1.256e-06 1.20034881247443
+ 1.258e-06 1.20041556064706
+ 1.26e-06 1.2006043270855
+ 1.262e-06 1.2009683549512
+ 1.264e-06 1.20078322741378
+ 1.266e-06 1.2007614456957
+ 1.268e-06 1.200783788344
+ 1.27e-06 1.20090540822799
+ 1.272e-06 1.20090189148467
+ 1.274e-06 1.20127853008651
+ 1.276e-06 1.20117754351667
+ 1.278e-06 1.20143443210926
+ 1.28e-06 1.20146223721593
+ 1.282e-06 1.20148958433022
+ 1.284e-06 1.20135631008956
+ 1.286e-06 1.20108452955906
+ 1.288e-06 1.20082846398229
+ 1.29e-06 1.20094682115513
+ 1.292e-06 1.2009889944114
+ 1.294e-06 1.20070620301954
+ 1.296e-06 1.2003040834934
+ 1.298e-06 1.20045243726034
+ 1.3e-06 1.20040819914891
+ 1.302e-06 1.20019761662057
+ 1.304e-06 1.20000020284817
+ 1.306e-06 1.20000769891806
+ 1.308e-06 1.20014891141558
+ 1.31e-06 1.19993455052387
+ 1.312e-06 1.20006288782939
+ 1.314e-06 1.20007386997915
+ 1.316e-06 1.20016049702931
+ 1.318e-06 1.19970843655914
+ 1.32e-06 1.19989383659775
+ 1.322e-06 1.20010607060943
+ 1.324e-06 1.19976088117625
+ 1.326e-06 1.19982333020005
+ 1.328e-06 1.20006071598356
+ 1.33e-06 1.20017785614116
+ 1.332e-06 1.20028717559285
+ 1.334e-06 1.20004092444882
+ 1.336e-06 1.20014169246073
+ 1.338e-06 1.20000723950469
+ 1.34e-06 1.20040928086648
+ 1.342e-06 1.20007580139045
+ 1.344e-06 1.20012808293942
+ 1.346e-06 1.20023053887508
+ 1.348e-06 1.20032940118827
+ 1.35e-06 1.20038478814954
+ 1.352e-06 1.2006692592165
+ 1.354e-06 1.20071991991617
+ 1.356e-06 1.2007827588033
+ 1.358e-06 1.20081877484073
+ 1.36e-06 1.20080287572745
+ 1.362e-06 1.20071535694298
+ 1.364e-06 1.20084246585622
+ 1.366e-06 1.20107178994039
+ 1.368e-06 1.20105583800612
+ 1.37e-06 1.20097917546295
+ 1.372e-06 1.20092527974149
+ 1.374e-06 1.20102453752976
+ 1.376e-06 1.20126658186825
+ 1.378e-06 1.20126885740885
+ 1.38e-06 1.2012235434995
+ 1.382e-06 1.20115665098129
+ 1.384e-06 1.20070261244518
+ 1.386e-06 1.20051342672426
+ 1.388e-06 1.20068984735448
+ 1.39e-06 1.20054994606214
+ 1.392e-06 1.20040706246346
+ 1.394e-06 1.20035582777498
+ 1.396e-06 1.20028041438052
+ 1.398e-06 1.19998215874878
+ 1.4e-06 1.20010337487775
+ 1.402e-06 1.20014496683929
+ 1.404e-06 1.20035016500998
+ 1.406e-06 1.20046228454656
+ 1.408e-06 1.20030893683057
+ 1.41e-06 1.20035780062544
+ 1.412e-06 1.20030704767619
+ 1.414e-06 1.20044199158354
+ 1.416e-06 1.20077146343656
+ 1.418e-06 1.20072773353723
+ 1.42e-06 1.20089672417994
+ 1.422e-06 1.2008962053129
+ 1.424e-06 1.20114206069749
+ 1.426e-06 1.20095930292647
+ 1.428e-06 1.20112559843916
+ 1.43e-06 1.20116452534479
+ 1.432e-06 1.20111043093062
+ 1.434e-06 1.20093387950662
+ 1.436e-06 1.20079633278995
+ 1.438e-06 1.20091128306173
+ 1.44e-06 1.20100719400196
+ 1.442e-06 1.200863734159
+ 1.444e-06 1.20063441295974
+ 1.446e-06 1.20042453632602
+ 1.448e-06 1.20040289102047
+ 1.45e-06 1.20024579214484
+ 1.452e-06 1.20048345676173
+ 1.454e-06 1.20060287865737
+ 1.456e-06 1.20047886217992
+ 1.458e-06 1.20054397613046
+ 1.46e-06 1.20066488574992
+ 1.462e-06 1.2004816471948
+ 1.464e-06 1.20097271843404
+ 1.466e-06 1.20110450190518
+ 1.468e-06 1.20068678155678
+ 1.47e-06 1.200462812868
+ 1.472e-06 1.20072452783023
+ 1.474e-06 1.20047337373818
+ 1.476e-06 1.20078149599996
+ 1.478e-06 1.20068401653189
+ 1.48e-06 1.20076110347253
+ 1.482e-06 1.20081501935872
+ 1.484e-06 1.20050849777813
+ 1.486e-06 1.2005164562244
+ 1.488e-06 1.20078782574528
+ 1.49e-06 1.20063827446518
+ 1.492e-06 1.20047890272723
+ 1.494e-06 1.2007229778
+ 1.496e-06 1.20091913448885
+ 1.498e-06 1.20047794004622
+ 1.5e-06 1.20026727880482
+ 1.502e-06 1.20055448396135
+ 1.504e-06 1.2007553480542
+ 1.506e-06 1.20084523151172
+ 1.508e-06 1.20073401216045
+ 1.51e-06 1.20055518331426
+ 1.512e-06 1.20054181335639
+ 1.514e-06 1.20058847210194
+ 1.516e-06 1.2004519404668
+ 1.518e-06 1.20018905737003
+ 1.52e-06 1.20037674369159
+ 1.522e-06 1.20051485987168
+ 1.524e-06 1.20078434366672
+ 1.526e-06 1.20078921373901
+ 1.528e-06 1.2009553781293
+ 1.53e-06 1.20105590480819
+ 1.532e-06 1.20082600037551
+ 1.534e-06 1.20083874639412
+ 1.536e-06 1.2008440826408
+ 1.538e-06 1.20107868005016
+ 1.54e-06 1.20127679053318
+ 1.542e-06 1.20147704526031
+ 1.544e-06 1.20117853276047
+ 1.546e-06 1.20133399966288
+ 1.548e-06 1.201394441654
+ 1.55e-06 1.20137783277392
+ 1.552e-06 1.20121945168319
+ 1.554e-06 1.20081422056148
+ 1.556e-06 1.20079095383335
+ 1.558e-06 1.20108208992069
+ 1.56e-06 1.20116465090568
+ 1.562e-06 1.20093920936205
+ 1.564e-06 1.20112884162044
+ 1.566e-06 1.2010705258126
+ 1.568e-06 1.2010083522541
+ 1.57e-06 1.20063851258701
+ 1.572e-06 1.20058450757503
+ 1.574e-06 1.20091188977147
+ 1.576e-06 1.20079319982694
+ 1.578e-06 1.20075061325727
+ 1.58e-06 1.20074096854303
+ 1.582e-06 1.20085199726488
+ 1.584e-06 1.20091276008244
+ 1.586e-06 1.20101257713429
+ 1.588e-06 1.2008932436454
+ 1.59e-06 1.20126462045466
+ 1.592e-06 1.2014424295442
+ 1.594e-06 1.20123260219165
+ 1.596e-06 1.20108272114137
+ 1.598e-06 1.20146548354755
+ 1.6e-06 1.20131624348885
+ 1.602e-06 1.20155770842948
+ 1.604e-06 1.20163740514278
+ 1.606e-06 1.20151310176044
+ 1.608e-06 1.2013013825719
+ 1.61e-06 1.2013909606225
+ 1.612e-06 1.20117878465984
+ 1.614e-06 1.20099706595058
+ 1.616e-06 1.20073301770311
+ 1.618e-06 1.20070544357631
+ 1.62e-06 1.20079608473065
+ 1.622e-06 1.20077274544098
+ 1.624e-06 1.20076348855616
+ 1.626e-06 1.20074182782648
+ 1.628e-06 1.2006616479047
+ 1.63e-06 1.20053500095786
+ 1.632e-06 1.20074092134946
+ 1.634e-06 1.20095889091019
+ 1.636e-06 1.20107880819877
+ 1.638e-06 1.20125190844048
+ 1.64e-06 1.2010266486241
+ 1.642e-06 1.20117528282969
+ 1.644e-06 1.20089572067697
+ 1.646e-06 1.20094403854143
+ 1.648e-06 1.2008017980903
+ 1.65e-06 1.20096202628269
+ 1.652e-06 1.20088366121933
+ 1.654e-06 1.20093268796221
+ 1.656e-06 1.20098705114068
+ 1.658e-06 1.20055937422926
+ 1.66e-06 1.2005574653563
+ 1.662e-06 1.20063214581103
+ 1.664e-06 1.20061083928416
+ 1.666e-06 1.20029393237363
+ 1.668e-06 1.19996723542325
+ 1.67e-06 1.19976678117188
+ 1.672e-06 1.19973461679781
+ 1.674e-06 1.19963157280881
+ 1.676e-06 1.19948551623928
+ 1.678e-06 1.19903699106533
+ 1.68e-06 1.19932191767017
+ 1.682e-06 1.19944538735964
+ 1.684e-06 1.19940677513568
+ 1.686e-06 1.19958599645186
+ 1.688e-06 1.1993632062808
+ 1.69e-06 1.19931460236692
+ 1.692e-06 1.19904027531373
+ 1.694e-06 1.19913516090762
+ 1.696e-06 1.19901041648717
+ 1.698e-06 1.19883048641395
+ 1.7e-06 1.19878741776262
+ 1.702e-06 1.19895256631701
+ 1.704e-06 1.19916049844496
+ 1.706e-06 1.19911471239211
+ 1.708e-06 1.1990980008864
+ 1.71e-06 1.19910827956749
+ 1.712e-06 1.19907716843488
+ 1.714e-06 1.19877455389565
+ 1.716e-06 1.19852028653696
+ 1.718e-06 1.19889584572211
+ 1.72e-06 1.19868348825351
+ 1.722e-06 1.19854295827253
+ 1.724e-06 1.1986051952642
+ 1.726e-06 1.19840195993514
+ 1.728e-06 1.19856403888358
+ 1.73e-06 1.19870221162164
+ 1.732e-06 1.19838974734624
+ 1.734e-06 1.19865835118177
+ 1.736e-06 1.19875866903677
+ 1.738e-06 1.19903162399895
+ 1.74e-06 1.19881774796173
+ 1.742e-06 1.19861782327311
+ 1.744e-06 1.1987345776844
+ 1.746e-06 1.1985586812193
+ 1.748e-06 1.19861011704506
+ 1.75e-06 1.19852114357863
+ 1.752e-06 1.19839612569599
+ 1.754e-06 1.19827780467335
+ 1.756e-06 1.19804152286706
+ 1.758e-06 1.19825176360199
+ 1.76e-06 1.19786723435039
+ 1.762e-06 1.19800128471829
+ 1.764e-06 1.19774466301318
+ 1.766e-06 1.19762793821586
+ 1.768e-06 1.1977209760853
+ 1.77e-06 1.19767297471068
+ 1.772e-06 1.19772239547931
+ 1.774e-06 1.19766828967661
+ 1.776e-06 1.197871000896
+ 1.778e-06 1.19812517516222
+ 1.78e-06 1.19815041743057
+ 1.782e-06 1.19794656618581
+ 1.784e-06 1.19816661355907
+ 1.786e-06 1.1983694538713
+ 1.788e-06 1.19843850508377
+ 1.79e-06 1.19871876783231
+ 1.792e-06 1.19857891578146
+ 1.794e-06 1.19824609318263
+ 1.796e-06 1.19834945396984
+ 1.798e-06 1.19856348415289
+ 1.8e-06 1.19864936761588
+ 1.802e-06 1.19868809587919
+ 1.804e-06 1.19864653954743
+ 1.806e-06 1.19868228944065
+ 1.808e-06 1.19856671493836
+ 1.81e-06 1.1986636061747
+ 1.812e-06 1.19844068253113
+ 1.814e-06 1.19840983340992
+ 1.816e-06 1.19825054633689
+ 1.818e-06 1.1982423353
+ 1.82e-06 1.19841715135809
+ 1.822e-06 1.19851787053949
+ 1.824e-06 1.19857266261465
+ 1.826e-06 1.19838219577015
+ 1.828e-06 1.19829910612596
+ 1.83e-06 1.19817936160255
+ 1.832e-06 1.19805129544458
+ 1.834e-06 1.19840136473099
+ 1.836e-06 1.19795123901354
+ 1.838e-06 1.19820054340232
+ 1.84e-06 1.19831195233268
+ 1.842e-06 1.19827036581678
+ 1.844e-06 1.19837405787497
+ 1.846e-06 1.19811201148737
+ 1.848e-06 1.19796565972583
+ 1.85e-06 1.19799356604535
+ 1.852e-06 1.19778153411491
+ 1.854e-06 1.19798009997145
+ 1.856e-06 1.1981466173138
+ 1.858e-06 1.19809459009978
+ 1.86e-06 1.19792133194855
+ 1.862e-06 1.19772529502042
+ 1.864e-06 1.19771231338189
+ 1.866e-06 1.19740178403664
+ 1.868e-06 1.19733999302761
+ 1.87e-06 1.19747989513052
+ 1.872e-06 1.19744026158007
+ 1.874e-06 1.19753489472168
+ 1.876e-06 1.198014430756
+ 1.878e-06 1.19810445510737
+ 1.88e-06 1.1982747982429
+ 1.882e-06 1.19816208424448
+ 1.884e-06 1.19818496619576
+ 1.886e-06 1.19807200609681
+ 1.888e-06 1.1979046442364
+ 1.89e-06 1.19840431892946
+ 1.892e-06 1.19854018084241
+ 1.894e-06 1.19884172299566
+ 1.896e-06 1.19897824014831
+ 1.898e-06 1.19882813930531
+ 1.9e-06 1.19895663279221
+ 1.902e-06 1.1985772927891
+ 1.904e-06 1.19866607522825
+ 1.906e-06 1.19886829812408
+ 1.908e-06 1.19924436041072
+ 1.91e-06 1.19897836301802
+ 1.912e-06 1.1991401180447
+ 1.914e-06 1.19918277865449
+ 1.916e-06 1.19946228583784
+ 1.918e-06 1.19952490781225
+ 1.92e-06 1.19958869643713
+ 1.922e-06 1.19976526233285
+ 1.924e-06 1.19965111466371
+ 1.926e-06 1.1998856641885
+ 1.928e-06 1.20003399110699
+ 1.93e-06 1.19996914166011
+ 1.932e-06 1.20007180918998
+ 1.934e-06 1.20006011350314
+ 1.936e-06 1.19986860152029
+ 1.938e-06 1.19979457522014
+ 1.94e-06 1.19976537678999
+ 1.942e-06 1.1995387491233
+ 1.944e-06 1.19944386218758
+ 1.946e-06 1.19930645030321
+ 1.948e-06 1.19953196256601
+ 1.95e-06 1.19975817563857
+ 1.952e-06 1.20005506683318
+ 1.954e-06 1.20029622782968
+ 1.956e-06 1.20018721935707
+ 1.958e-06 1.19998990219712
+ 1.96e-06 1.20025335332094
+ 1.962e-06 1.20025449288325
+ 1.964e-06 1.20034235322632
+ 1.966e-06 1.20007055771396
+ 1.968e-06 1.19974873960643
+ 1.97e-06 1.19960962482133
+ 1.972e-06 1.19943237785085
+ 1.974e-06 1.1998909857851
+ 1.976e-06 1.20008637156199
+ 1.978e-06 1.20032223507487
+ 1.98e-06 1.20030331487817
+ 1.982e-06 1.20038885986642
+ 1.984e-06 1.20004661634597
+ 1.986e-06 1.20004552902356
+ 1.988e-06 1.20018063507939
+ 1.99e-06 1.19975560219686
+ 1.992e-06 1.19993557812368
+ 1.994e-06 1.20023754215456
+ 1.996e-06 1.20003553928485
+ 1.998e-06 1.20014298331689
+ 2e-06 1.20029809719695
+ 2.002e-06 1.20025096866201
+ 2.004e-06 1.2001086440418
+ 2.006e-06 1.20023241187399
+ 2.008e-06 1.20056138494169
+ 2.01e-06 1.2004044419945
+ 2.012e-06 1.20053959491021
+ 2.014e-06 1.20037897171025
+ 2.016e-06 1.20038748111838
+ 2.018e-06 1.2003941267396
+ 2.02e-06 1.20021608502007
+ 2.022e-06 1.20039132361742
+ 2.024e-06 1.20038108285779
+ 2.026e-06 1.2005008959767
+ 2.028e-06 1.20064325328981
+ 2.03e-06 1.20050929956557
+ 2.032e-06 1.20090161369791
+ 2.034e-06 1.20094945507689
+ 2.036e-06 1.20089732020404
+ 2.038e-06 1.20086938745846
+ 2.04e-06 1.20087940030313
+ 2.042e-06 1.20104398433245
+ 2.044e-06 1.20092205937693
+ 2.046e-06 1.20087881914598
+ 2.048e-06 1.2008407551509
+ 2.05e-06 1.20107270051728
+ 2.052e-06 1.20104589682053
+ 2.054e-06 1.20146780984701
+ 2.056e-06 1.20136846428892
+ 2.058e-06 1.20138754889871
+ 2.06e-06 1.20138916677102
+ 2.062e-06 1.20132793482438
+ 2.064e-06 1.20148229274083
+ 2.066e-06 1.2014437836754
+ 2.068e-06 1.20133137998364
+ 2.07e-06 1.20136112015175
+ 2.072e-06 1.20105978908866
+ 2.074e-06 1.2009086423485
+ 2.076e-06 1.20103305255144
+ 2.078e-06 1.20126250445422
+ 2.08e-06 1.20121719638004
+ 2.082e-06 1.20144701510182
+ 2.084e-06 1.20101993174957
+ 2.086e-06 1.20110599066191
+ 2.088e-06 1.20091516826779
+ 2.09e-06 1.20067458577221
+ 2.092e-06 1.20106178363867
+ 2.094e-06 1.20122033061531
+ 2.096e-06 1.20130829490938
+ 2.098e-06 1.20117997151027
+ 2.1e-06 1.20134822281497
+ 2.102e-06 1.20126283970249
+ 2.104e-06 1.2012596831253
+ 2.106e-06 1.20078037814802
+ 2.108e-06 1.20093716421163
+ 2.11e-06 1.20088576510032
+ 2.112e-06 1.20103669138394
+ 2.114e-06 1.2008413985821
+ 2.116e-06 1.20088773658806
+ 2.118e-06 1.20074481356211
+ 2.12e-06 1.2004384523673
+ 2.122e-06 1.20076241792775
+ 2.124e-06 1.20040700726727
+ 2.126e-06 1.20034167120645
+ 2.128e-06 1.20039133715954
+ 2.13e-06 1.2006891087085
+ 2.132e-06 1.20063304900361
+ 2.134e-06 1.20049667992056
+ 2.136e-06 1.20059042366088
+ 2.138e-06 1.20037530654955
+ 2.14e-06 1.2002637983147
+ 2.142e-06 1.19992702049698
+ 2.144e-06 1.19980453747247
+ 2.146e-06 1.19960323104279
+ 2.148e-06 1.19961788411417
+ 2.15e-06 1.19938382255658
+ 2.152e-06 1.19964949616472
+ 2.154e-06 1.19933278620357
+ 2.156e-06 1.19960215380276
+ 2.158e-06 1.19947344524992
+ 2.16e-06 1.19952251823082
+ 2.162e-06 1.19932636032488
+ 2.164e-06 1.19924786383877
+ 2.166e-06 1.19931749359898
+ 2.168e-06 1.19929535227721
+ 2.17e-06 1.19921134792954
+ 2.172e-06 1.19907755333539
+ 2.174e-06 1.19884096304046
+ 2.176e-06 1.19881325112249
+ 2.178e-06 1.19912180722269
+ 2.18e-06 1.19936247329603
+ 2.182e-06 1.19953886206487
+ 2.184e-06 1.19974811226692
+ 2.186e-06 1.19949771337232
+ 2.188e-06 1.19947982136179
+ 2.19e-06 1.19958864184116
+ 2.192e-06 1.19970865070046
+ 2.194e-06 1.19983776501468
+ 2.196e-06 1.19971168917686
+ 2.198e-06 1.19962319953715
+ 2.2e-06 1.19969753030997
+ 2.202e-06 1.19980650896276
+ 2.204e-06 1.20007248419471
+ 2.206e-06 1.20011350471939
+ 2.208e-06 1.2000138823586
+ 2.21e-06 1.19988857433986
+ 2.212e-06 1.19998039048941
+ 2.214e-06 1.19994150015513
+ 2.216e-06 1.19985489805567
+ 2.218e-06 1.19973439331943
+ 2.22e-06 1.19957733601697
+ 2.222e-06 1.19934533514044
+ 2.224e-06 1.19922268912788
+ 2.226e-06 1.19921271217019
+ 2.228e-06 1.1992988830996
+ 2.23e-06 1.1994288390415
+ 2.232e-06 1.19932357922248
+ 2.234e-06 1.19953544472523
+ 2.236e-06 1.19949382268083
+ 2.238e-06 1.19958065553206
+ 2.24e-06 1.19975184629807
+ 2.242e-06 1.19953292883946
+ 2.244e-06 1.19997609280155
+ 2.246e-06 1.19975516233538
+ 2.248e-06 1.1999126091707
+ 2.25e-06 1.20003938240541
+ 2.252e-06 1.20004764326687
+ 2.254e-06 1.20013624943495
+ 2.256e-06 1.20026658374722
+ 2.258e-06 1.20036755395418
+ 2.26e-06 1.20043178680882
+ 2.262e-06 1.2002631187312
+ 2.264e-06 1.20029250643499
+ 2.266e-06 1.20027221705771
+ 2.268e-06 1.20008262369233
+ 2.27e-06 1.20006257218265
+ 2.272e-06 1.20022321684565
+ 2.274e-06 1.20045376336807
+ 2.276e-06 1.20023550355577
+ 2.278e-06 1.20027499796705
+ 2.28e-06 1.20026314072581
+ 2.282e-06 1.20019824787362
+ 2.284e-06 1.20012840726002
+ 2.286e-06 1.20017625236848
+ 2.288e-06 1.19992105445759
+ 2.29e-06 1.19996022863341
+ 2.292e-06 1.19981092598517
+ 2.294e-06 1.19977846064541
+ 2.296e-06 1.19994741232418
+ 2.298e-06 1.19964493210225
+ 2.3e-06 1.19960013237895
+ 2.302e-06 1.19987295845747
+ 2.304e-06 1.19970635467078
+ 2.306e-06 1.19938961019455
+ 2.308e-06 1.19926876337282
+ 2.31e-06 1.19914544050832
+ 2.312e-06 1.19923375887482
+ 2.314e-06 1.19927553785137
+ 2.316e-06 1.19953735704944
+ 2.318e-06 1.19954091678775
+ 2.32e-06 1.19988770614435
+ 2.322e-06 1.19997759535724
+ 2.324e-06 1.20010304946523
+ 2.326e-06 1.2000977308678
+ 2.328e-06 1.20009763871979
+ 2.33e-06 1.20024014335164
+ 2.332e-06 1.2000833351195
+ 2.334e-06 1.1996354103006
+ 2.336e-06 1.19929592504968
+ 2.338e-06 1.19916876943602
+ 2.34e-06 1.19889646116552
+ 2.342e-06 1.19888410944248
+ 2.344e-06 1.19906271307902
+ 2.346e-06 1.19921335625742
+ 2.348e-06 1.19923150904653
+ 2.35e-06 1.19899174903254
+ 2.352e-06 1.19910828679682
+ 2.354e-06 1.19917164318244
+ 2.356e-06 1.19918822377077
+ 2.358e-06 1.19933588310391
+ 2.36e-06 1.19951397772003
+ 2.362e-06 1.19956206399622
+ 2.364e-06 1.199317888477
+ 2.366e-06 1.19942038276731
+ 2.368e-06 1.19922821803248
+ 2.37e-06 1.19918432073312
+ 2.372e-06 1.19913388155488
+ 2.374e-06 1.19891115495404
+ 2.376e-06 1.19884499299574
+ 2.378e-06 1.19885842078374
+ 2.38e-06 1.1987175629297
+ 2.382e-06 1.19902710479179
+ 2.384e-06 1.19891388653778
+ 2.386e-06 1.19889553595491
+ 2.388e-06 1.1989866963964
+ 2.39e-06 1.19893561347772
+ 2.392e-06 1.19884986012886
+ 2.394e-06 1.19904877741734
+ 2.396e-06 1.199128805871
+ 2.398e-06 1.19908013559438
+ 2.4e-06 1.19939545937873
+ 2.402e-06 1.19946992727417
+ 2.404e-06 1.19952438914815
+ 2.406e-06 1.19948735026001
+ 2.408e-06 1.19956954999309
+ 2.41e-06 1.19927357999455
+ 2.412e-06 1.19928280741427
+ 2.414e-06 1.19921343987088
+ 2.416e-06 1.19929219283766
+ 2.418e-06 1.19929551212352
+ 2.42e-06 1.19927124171605
+ 2.422e-06 1.19949116281965
+ 2.424e-06 1.19934478961451
+ 2.426e-06 1.19923854363608
+ 2.428e-06 1.19927552110144
+ 2.43e-06 1.19938654851541
+ 2.432e-06 1.19935700512532
+ 2.434e-06 1.19928658471028
+ 2.436e-06 1.1996821575038
+ 2.438e-06 1.19976534290367
+ 2.44e-06 1.19934524049639
+ 2.442e-06 1.19913997073201
+ 2.444e-06 1.1992189291164
+ 2.446e-06 1.1993693763524
+ 2.448e-06 1.19940197025652
+ 2.45e-06 1.19961446250536
+ 2.452e-06 1.1995485372454
+ 2.454e-06 1.19982178602748
+ 2.456e-06 1.1999915926978
+ 2.458e-06 1.20003339096757
+ 2.46e-06 1.19940359557292
+ 2.462e-06 1.19920607832369
+ 2.464e-06 1.19929610903317
+ 2.466e-06 1.19942382075085
+ 2.468e-06 1.19913831445486
+ 2.47e-06 1.19912535347843
+ 2.472e-06 1.19904342705736
+ 2.474e-06 1.19954702524198
+ 2.476e-06 1.19955692007326
+ 2.478e-06 1.19983799614892
+ 2.48e-06 1.19975126504705
+ 2.482e-06 1.1995833969342
+ 2.484e-06 1.19959750167868
+ 2.486e-06 1.19959331031089
+ 2.488e-06 1.19967505326264
+ 2.49e-06 1.19982548484416
+ 2.492e-06 1.19975875450235
+ 2.494e-06 1.19945181390112
+ 2.496e-06 1.19929009859963
+ 2.498e-06 1.19939817906569
+ 2.5e-06 1.19923789332089
+ 2.502e-06 1.19936430269787
+ 2.504e-06 1.19971285112373
+ 2.506e-06 1.19971431329767
+ 2.508e-06 1.19998895260673
+ 2.51e-06 1.20027324810974
+ 2.512e-06 1.20029384882597
+ 2.514e-06 1.19991878175488
+ 2.516e-06 1.19968074330328
+ 2.518e-06 1.19965916374984
+ 2.52e-06 1.19983612621832
+ 2.522e-06 1.19997329390629
+ 2.524e-06 1.19971446365341
+ 2.526e-06 1.19977689130081
+ 2.528e-06 1.19966783837149
+ 2.53e-06 1.1994382751726
+ 2.532e-06 1.19950452314321
+ 2.534e-06 1.19950271443769
+ 2.536e-06 1.19940404262137
+ 2.538e-06 1.19936378895591
+ 2.54e-06 1.19942160239914
+ 2.542e-06 1.19982592786552
+ 2.544e-06 1.19939773022046
+ 2.546e-06 1.19919647971475
+ 2.548e-06 1.19901628059231
+ 2.55e-06 1.1991625992628
+ 2.552e-06 1.19931875110362
+ 2.554e-06 1.1990721282833
+ 2.556e-06 1.19867614865277
+ 2.558e-06 1.19873530322559
+ 2.56e-06 1.19867613712735
+ 2.562e-06 1.19861134185221
+ 2.564e-06 1.19899459809261
+ 2.566e-06 1.19935860184281
+ 2.568e-06 1.19928145306689
+ 2.57e-06 1.19923450311644
+ 2.572e-06 1.19885080239479
+ 2.574e-06 1.19863174992987
+ 2.576e-06 1.19878114997354
+ 2.578e-06 1.19890075639486
+ 2.58e-06 1.19906871095895
+ 2.582e-06 1.19906611546349
+ 2.584e-06 1.19894682747344
+ 2.586e-06 1.19915866445079
+ 2.588e-06 1.19882973541226
+ 2.59e-06 1.19876367153164
+ 2.592e-06 1.19850779712823
+ 2.594e-06 1.19856625791915
+ 2.596e-06 1.19860732996015
+ 2.598e-06 1.19880780194486
+ 2.6e-06 1.1988229459353
+ 2.602e-06 1.1987856475303
+ 2.604e-06 1.19863941662321
+ 2.606e-06 1.19856241677525
+ 2.608e-06 1.19849041585158
+ 2.61e-06 1.19829035627942
+ 2.612e-06 1.19872247880727
+ 2.614e-06 1.19869409160537
+ 2.616e-06 1.19914743748697
+ 2.618e-06 1.19928348235695
+ 2.62e-06 1.19952079204109
+ 2.622e-06 1.19947394605905
+ 2.624e-06 1.1997602469947
+ 2.626e-06 1.19975061987907
+ 2.628e-06 1.20000838906648
+ 2.63e-06 1.19983321339942
+ 2.632e-06 1.19960396525187
+ 2.634e-06 1.19949888654329
+ 2.636e-06 1.19944117116288
+ 2.638e-06 1.19976804262803
+ 2.64e-06 1.19993751561061
+ 2.642e-06 1.19984579659363
+ 2.644e-06 1.19956104729298
+ 2.646e-06 1.19947365537577
+ 2.648e-06 1.19973799280559
+ 2.65e-06 1.19975050117142
+ 2.652e-06 1.19961814249907
+ 2.654e-06 1.19944366953614
+ 2.656e-06 1.19954546415736
+ 2.658e-06 1.19952082582831
+ 2.66e-06 1.19970202321
+ 2.662e-06 1.1997527214313
+ 2.664e-06 1.19963595293957
+ 2.666e-06 1.19956842816827
+ 2.668e-06 1.19966886030905
+ 2.67e-06 1.19958592506445
+ 2.672e-06 1.19957933423739
+ 2.674e-06 1.19954846554677
+ 2.676e-06 1.1997676270478
+ 2.678e-06 1.19992835503955
+ 2.68e-06 1.20022782606995
+ 2.682e-06 1.20031340619985
+ 2.684e-06 1.20090991636878
+ 2.686e-06 1.20097145738024
+ 2.688e-06 1.20127430551282
+ 2.69e-06 1.20114403853304
+ 2.692e-06 1.20104359066125
+ 2.694e-06 1.20091053529417
+ 2.696e-06 1.20108336364203
+ 2.698e-06 1.20112533991806
+ 2.7e-06 1.20121777290821
+ 2.702e-06 1.20154703516873
+ 2.704e-06 1.20138971357457
+ 2.706e-06 1.20132029364153
+ 2.708e-06 1.20117348548803
+ 2.71e-06 1.20092005312809
+ 2.712e-06 1.20090564833187
+ 2.714e-06 1.20076241183459
+ 2.716e-06 1.20074188747754
+ 2.718e-06 1.20047582406205
+ 2.72e-06 1.20102179774982
+ 2.722e-06 1.20120023216822
+ 2.724e-06 1.20131870281936
+ 2.726e-06 1.20114267418545
+ 2.728e-06 1.2010203133968
+ 2.73e-06 1.20091503002594
+ 2.732e-06 1.20078689260109
+ 2.734e-06 1.20084686956952
+ 2.736e-06 1.2005551431648
+ 2.738e-06 1.20022866554074
+ 2.74e-06 1.20025926469586
+ 2.742e-06 1.20031786971806
+ 2.744e-06 1.2001883829282
+ 2.746e-06 1.20027768046104
+ 2.748e-06 1.2005539428886
+ 2.75e-06 1.20031938220954
+ 2.752e-06 1.20032734353773
+ 2.754e-06 1.2007892727822
+ 2.756e-06 1.20100776048266
+ 2.758e-06 1.20085918725024
+ 2.76e-06 1.20083407144379
+ 2.762e-06 1.20078617172048
+ 2.764e-06 1.20069034974664
+ 2.766e-06 1.20079709194243
+ 2.768e-06 1.2004941807732
+ 2.77e-06 1.20051742298232
+ 2.772e-06 1.2001028744828
+ 2.774e-06 1.20009034190079
+ 2.776e-06 1.19957947551849
+ 2.778e-06 1.19958062333381
+ 2.78e-06 1.19970786809567
+ 2.782e-06 1.19968151009003
+ 2.784e-06 1.19969220820155
+ 2.786e-06 1.20007817609468
+ 2.788e-06 1.20025565379864
+ 2.79e-06 1.20049850047784
+ 2.792e-06 1.20065563965868
+ 2.794e-06 1.20041115806805
+ 2.796e-06 1.20079702495823
+ 2.798e-06 1.20084805946102
+ 2.8e-06 1.20051518982597
+ 2.802e-06 1.20076067201041
+ 2.804e-06 1.20059995180172
+ 2.806e-06 1.20089844282135
+ 2.808e-06 1.20089050368589
+ 2.81e-06 1.201000718619
+ 2.812e-06 1.20096905661126
+ 2.814e-06 1.20133142205019
+ 2.816e-06 1.20088927237497
+ 2.818e-06 1.2010864297737
+ 2.82e-06 1.20108136870472
+ 2.822e-06 1.20089652549487
+ 2.824e-06 1.20074159725994
+ 2.826e-06 1.20073965845133
+ 2.828e-06 1.20084014987688
+ 2.83e-06 1.20070085422143
+ 2.832e-06 1.20036798628654
+ 2.834e-06 1.20026206724735
+ 2.836e-06 1.20000219850558
+ 2.838e-06 1.19995646881059
+ 2.84e-06 1.20002171876008
+ 2.842e-06 1.20028567564015
+ 2.844e-06 1.20026244112879
+ 2.846e-06 1.19988188882753
+ 2.848e-06 1.19975342376174
+ 2.85e-06 1.19993682528576
+ 2.852e-06 1.2000544817436
+ 2.854e-06 1.19981549813646
+ 2.856e-06 1.19988194334673
+ 2.858e-06 1.19949158543022
+ 2.86e-06 1.19949406830802
+ 2.862e-06 1.19941831404038
+ 2.864e-06 1.19934305374212
+ 2.866e-06 1.19899943361016
+ 2.868e-06 1.19915485292174
+ 2.87e-06 1.19895639647754
+ 2.872e-06 1.19880376577414
+ 2.874e-06 1.19866647218608
+ 2.876e-06 1.198362614808
+ 2.878e-06 1.19834780341106
+ 2.88e-06 1.19833176106612
+ 2.882e-06 1.1983381247
+ 2.884e-06 1.1986668552878
+ 2.886e-06 1.198712878864
+ 2.888e-06 1.19884009916594
+ 2.89e-06 1.19894400964627
+ 2.892e-06 1.1993143368101
+ 2.894e-06 1.19894103881663
+ 2.896e-06 1.19878518445972
+ 2.898e-06 1.19864123445283
+ 2.9e-06 1.1985399302305
+ 2.902e-06 1.19874329820034
+ 2.904e-06 1.19862218899989
+ 2.906e-06 1.1986409339589
+ 2.908e-06 1.19884224924623
+ 2.91e-06 1.19891810900465
+ 2.912e-06 1.19895585826395
+ 2.914e-06 1.1992934115766
+ 2.916e-06 1.19917960866122
+ 2.918e-06 1.19932416001699
+ 2.92e-06 1.19945919421397
+ 2.922e-06 1.19923541806736
+ 2.924e-06 1.19950988267563
+ 2.926e-06 1.19965989305
+ 2.928e-06 1.19976241752802
+ 2.93e-06 1.19984068579111
+ 2.932e-06 1.19956802560655
+ 2.934e-06 1.19964637581174
+ 2.936e-06 1.19973941057262
+ 2.938e-06 1.1996674988783
+ 2.94e-06 1.19974370798755
+ 2.942e-06 1.19973993499575
+ 2.944e-06 1.1997305986657
+ 2.946e-06 1.19990904982657
+ 2.948e-06 1.20015728990495
+ 2.95e-06 1.20040435477558
+ 2.952e-06 1.20044612702391
+ 2.954e-06 1.200185038511
+ 2.956e-06 1.20022995078617
+ 2.958e-06 1.20004041230481
+ 2.96e-06 1.19998896079824
+ 2.962e-06 1.20004652976532
+ 2.964e-06 1.19966147658561
+ 2.966e-06 1.19955834252586
+ 2.968e-06 1.19932488082862
+ 2.97e-06 1.19935529220861
+ 2.972e-06 1.19964467997617
+ 2.974e-06 1.19932679128817
+ 2.976e-06 1.19957101185243
+ 2.978e-06 1.19978753347691
+ 2.98e-06 1.19966344382785
+ 2.982e-06 1.19952367324964
+ 2.984e-06 1.19958466069285
+ 2.986e-06 1.19981334252277
+ 2.988e-06 1.19994654880714
+ 2.99e-06 1.19985622047852
+ 2.992e-06 1.19979250465162
+ 2.994e-06 1.19966139808184
+ 2.996e-06 1.19951298506148
+ 2.998e-06 1.1994600583114
+ 3e-06 1.19957295694592
+ 3.002e-06 1.19932206547241
+ 3.004e-06 1.1993808021248
+ 3.006e-06 1.19963784483896
+ 3.008e-06 1.19987980300308
+ 3.01e-06 1.19995194468021
+ 3.012e-06 1.20034321449665
+ 3.014e-06 1.20037016515293
+ 3.016e-06 1.20036248613317
+ 3.018e-06 1.20051758021201
+ 3.02e-06 1.20038244433232
+ 3.022e-06 1.20062165172579
+ 3.024e-06 1.2007423870032
+ 3.026e-06 1.20096801656284
+ 3.028e-06 1.20092354561309
+ 3.03e-06 1.20117335193515
+ 3.032e-06 1.20128949766977
+ 3.034e-06 1.20087663298699
+ 3.036e-06 1.2011897899534
+ 3.038e-06 1.2014293566984
+ 3.04e-06 1.20125260371162
+ 3.042e-06 1.20129293508691
+ 3.044e-06 1.20116939132363
+ 3.046e-06 1.20137054113072
+ 3.048e-06 1.20140392376957
+ 3.05e-06 1.20119764209333
+ 3.052e-06 1.20117081532796
+ 3.054e-06 1.20089159878472
+ 3.056e-06 1.20049840817732
+ 3.058e-06 1.20077637076804
+ 3.06e-06 1.20077386770617
+ 3.062e-06 1.20062967959776
+ 3.064e-06 1.20070439524845
+ 3.066e-06 1.20041419437041
+ 3.068e-06 1.20066297531702
+ 3.07e-06 1.20092684175269
+ 3.072e-06 1.20095093930672
+ 3.074e-06 1.20105803433567
+ 3.076e-06 1.20149500348721
+ 3.078e-06 1.20103893915019
+ 3.08e-06 1.2011386036186
+ 3.082e-06 1.20117972008839
+ 3.084e-06 1.2010650031671
+ 3.086e-06 1.20113117187665
+ 3.088e-06 1.20118005165284
+ 3.09e-06 1.20101054974279
+ 3.092e-06 1.20094076102561
+ 3.094e-06 1.2007506056331
+ 3.096e-06 1.20073813096974
+ 3.098e-06 1.20076567084219
+ 3.1e-06 1.20069736437039
+ 3.102e-06 1.2007210599152
+ 3.104e-06 1.20053753042226
+ 3.106e-06 1.20043247120458
+ 3.108e-06 1.20029565747628
+ 3.11e-06 1.20059246520799
+ 3.112e-06 1.20060059779756
+ 3.114e-06 1.2003657911316
+ 3.116e-06 1.20064330616955
+ 3.118e-06 1.20068008297813
+ 3.12e-06 1.20109084310022
+ 3.122e-06 1.20138543957356
+ 3.124e-06 1.20122006935994
+ 3.126e-06 1.20121891564779
+ 3.128e-06 1.20120598334325
+ 3.13e-06 1.20119570111965
+ 3.132e-06 1.20100342205967
+ 3.134e-06 1.20103203414391
+ 3.136e-06 1.20086969793727
+ 3.138e-06 1.20079650132566
+ 3.14e-06 1.20094077862438
+ 3.142e-06 1.2010430204833
+ 3.144e-06 1.20103590975107
+ 3.146e-06 1.20078483761927
+ 3.148e-06 1.20119958284599
+ 3.15e-06 1.20123128106253
+ 3.152e-06 1.20085284769351
+ 3.154e-06 1.2009192385468
+ 3.156e-06 1.20088978888689
+ 3.158e-06 1.2008691812067
+ 3.16e-06 1.20083284649774
+ 3.162e-06 1.20034781716316
+ 3.164e-06 1.20032721793033
+ 3.166e-06 1.19985354649561
+ 3.168e-06 1.20004858683759
+ 3.17e-06 1.20021696489602
+ 3.172e-06 1.20082629801875
+ 3.174e-06 1.20103210684278
+ 3.176e-06 1.20080467129424
+ 3.178e-06 1.20048271568702
+ 3.18e-06 1.20050554151863
+ 3.182e-06 1.20082975479077
+ 3.184e-06 1.20074661580796
+ 3.186e-06 1.20100868290535
+ 3.188e-06 1.20082328575645
+ 3.19e-06 1.20077941884851
+ 3.192e-06 1.20108741812331
+ 3.194e-06 1.20099459957734
+ 3.196e-06 1.20114412812079
+ 3.198e-06 1.20111797907261
+ 3.2e-06 1.20109973993591
+ 3.202e-06 1.20109523629355
+ 3.204e-06 1.20110805663181
+ 3.206e-06 1.20098673655709
+ 3.208e-06 1.20119888792267
+ 3.21e-06 1.20123667052453
+ 3.212e-06 1.20096902133622
+ 3.214e-06 1.20115057015295
+ 3.216e-06 1.20105748470405
+ 3.218e-06 1.20088697921152
+ 3.22e-06 1.20082064001735
+ 3.222e-06 1.20077887143808
+ 3.224e-06 1.20126372332615
+ 3.226e-06 1.20132923334817
+ 3.228e-06 1.20114525698505
+ 3.23e-06 1.20125807692109
+ 3.232e-06 1.20096519967033
+ 3.234e-06 1.20083841892456
+ 3.236e-06 1.20126480219817
+ 3.238e-06 1.20137245848696
+ 3.24e-06 1.20084809800115
+ 3.242e-06 1.20087232351644
+ 3.244e-06 1.2008873388927
+ 3.246e-06 1.20069601082263
+ 3.248e-06 1.20050854596092
+ 3.25e-06 1.20039838460861
+ 3.252e-06 1.20019524415292
+ 3.254e-06 1.20001196385978
+ 3.256e-06 1.19999501952457
+ 3.258e-06 1.20017887906718
+ 3.26e-06 1.20022659666674
+ 3.262e-06 1.2001636971856
+ 3.264e-06 1.19998333325651
+ 3.266e-06 1.19994277517488
+ 3.268e-06 1.19961384355838
+ 3.27e-06 1.19945838412923
+ 3.272e-06 1.1995938588594
+ 3.274e-06 1.1995215459681
+ 3.276e-06 1.19950942060666
+ 3.278e-06 1.19980466986553
+ 3.28e-06 1.19975024359296
+ 3.282e-06 1.19974581114843
+ 3.284e-06 1.20003495437084
+ 3.286e-06 1.19982099483532
+ 3.288e-06 1.20000255410403
+ 3.29e-06 1.19994982423265
+ 3.292e-06 1.19966229383985
+ 3.294e-06 1.19972254661389
+ 3.296e-06 1.19949805005282
+ 3.298e-06 1.19955179468298
+ 3.3e-06 1.19931351018805
+ 3.302e-06 1.19942292271532
+ 3.304e-06 1.19945443872109
+ 3.306e-06 1.1990935116871
+ 3.308e-06 1.19898153116351
+ 3.31e-06 1.19890428235873
+ 3.312e-06 1.19908361125237
+ 3.314e-06 1.19884319984359
+ 3.316e-06 1.19892663947042
+ 3.318e-06 1.19874699584236
+ 3.32e-06 1.19888586158231
+ 3.322e-06 1.19888013780544
+ 3.324e-06 1.19916407617515
+ 3.326e-06 1.19895672224155
+ 3.328e-06 1.19924293251791
+ 3.33e-06 1.19954066862165
+ 3.332e-06 1.19936295709211
+ 3.334e-06 1.19919882159903
+ 3.336e-06 1.19909624388369
+ 3.338e-06 1.19886753317469
+ 3.34e-06 1.19896963393181
+ 3.342e-06 1.19908986018835
+ 3.344e-06 1.19898163496941
+ 3.346e-06 1.19872258719456
+ 3.348e-06 1.19865657215684
+ 3.35e-06 1.19834598126508
+ 3.352e-06 1.19844173528511
+ 3.354e-06 1.19849215066325
+ 3.356e-06 1.19870728955967
+ 3.358e-06 1.19827579763569
+ 3.36e-06 1.19829211683742
+ 3.362e-06 1.198243285351
+ 3.364e-06 1.19854961932952
+ 3.366e-06 1.19855841402269
+ 3.368e-06 1.1983167566717
+ 3.37e-06 1.19854187806226
+ 3.372e-06 1.19832489426391
+ 3.374e-06 1.1985056447176
+ 3.376e-06 1.19842858279852
+ 3.378e-06 1.19871947098241
+ 3.38e-06 1.19856662956773
+ 3.382e-06 1.1988145145147
+ 3.384e-06 1.19900496531461
+ 3.386e-06 1.19878052428281
+ 3.388e-06 1.19892526495436
+ 3.39e-06 1.19903397772324
+ 3.392e-06 1.19917327068163
+ 3.394e-06 1.19952581919505
+ 3.396e-06 1.19923012213202
+ 3.398e-06 1.19921457557457
+ 3.4e-06 1.19914579964224
+ 3.402e-06 1.19953418853463
+ 3.404e-06 1.19967128063018
+ 3.406e-06 1.19967154217445
+ 3.408e-06 1.19992251449215
+ 3.41e-06 1.19987965494037
+ 3.412e-06 1.20033979748554
+ 3.414e-06 1.20026695803662
+ 3.416e-06 1.20017175801913
+ 3.418e-06 1.20032558423839
+ 3.42e-06 1.20027563318075
+ 3.422e-06 1.20059170798694
+ 3.424e-06 1.20079889600486
+ 3.426e-06 1.20065676848917
+ 3.428e-06 1.20047403899923
+ 3.43e-06 1.20074021452307
+ 3.432e-06 1.20071929503701
+ 3.434e-06 1.2006570477737
+ 3.436e-06 1.20038727234274
+ 3.438e-06 1.20038300893238
+ 3.44e-06 1.2002859947411
+ 3.442e-06 1.2003034035925
+ 3.444e-06 1.20000039223686
+ 3.446e-06 1.19956858754235
+ 3.448e-06 1.19961365780706
+ 3.45e-06 1.19963470150682
+ 3.452e-06 1.20006180666633
+ 3.454e-06 1.19980876821126
+ 3.456e-06 1.19998906965474
+ 3.458e-06 1.19995582645752
+ 3.46e-06 1.1999582038789
+ 3.462e-06 1.19947324984184
+ 3.464e-06 1.19943302094944
+ 3.466e-06 1.19934871798953
+ 3.468e-06 1.19934215413465
+ 3.47e-06 1.19950834415184
+ 3.472e-06 1.19923892449303
+ 3.474e-06 1.19902368515856
+ 3.476e-06 1.19903393667529
+ 3.478e-06 1.19920757530076
+ 3.48e-06 1.19978357807663
+ 3.482e-06 1.19959959620565
+ 3.484e-06 1.19970216441444
+ 3.486e-06 1.19990360299874
+ 3.488e-06 1.19984680726889
+ 3.49e-06 1.19963853870754
+ 3.492e-06 1.19977615296839
+ 3.494e-06 1.19963334323021
+ 3.496e-06 1.19971541462288
+ 3.498e-06 1.20010012282725
+ 3.5e-06 1.19988791359642
+ 3.502e-06 1.20006132556699
+ 3.504e-06 1.20016238045315
+ 3.506e-06 1.20027121928231
+ 3.508e-06 1.19996387406137
+ 3.51e-06 1.19993427940392
+ 3.512e-06 1.19961264707926
+ 3.514e-06 1.19940179308844
+ 3.516e-06 1.19918650146833
+ 3.518e-06 1.19890938263974
+ 3.52e-06 1.19906589249773
+ 3.522e-06 1.19882334807046
+ 3.524e-06 1.19912621371207
+ 3.526e-06 1.19917556491131
+ 3.528e-06 1.19912763147907
+ 3.53e-06 1.19903039663116
+ 3.532e-06 1.198995871794
+ 3.534e-06 1.1991228513907
+ 3.536e-06 1.19862826033748
+ 3.538e-06 1.19837685632352
+ 3.54e-06 1.19846637346832
+ 3.542e-06 1.19870589521442
+ 3.544e-06 1.19871024358903
+ 3.546e-06 1.19877101324721
+ 3.548e-06 1.19922905015517
+ 3.55e-06 1.19936580033256
+ 3.552e-06 1.19948681865019
+ 3.554e-06 1.19957688824353
+ 3.556e-06 1.1993345406948
+ 3.558e-06 1.19943145926361
+ 3.56e-06 1.19935159630606
+ 3.562e-06 1.19940834228003
+ 3.564e-06 1.19952171609119
+ 3.566e-06 1.19945528820234
+ 3.568e-06 1.19960672103804
+ 3.57e-06 1.19979293800796
+ 3.572e-06 1.19979710871988
+ 3.574e-06 1.19970208967562
+ 3.576e-06 1.19982124251599
+ 3.578e-06 1.19982601611934
+ 3.58e-06 1.19979066590592
+ 3.582e-06 1.1998533589322
+ 3.584e-06 1.20016280714633
+ 3.586e-06 1.20028701887895
+ 3.588e-06 1.20003765656233
+ 3.59e-06 1.19992387183379
+ 3.592e-06 1.19983502937404
+ 3.594e-06 1.19954682001946
+ 3.596e-06 1.19982355039014
+ 3.598e-06 1.19984892454997
+ 3.6e-06 1.19987900479792
+ 3.602e-06 1.20011632885103
+ 3.604e-06 1.19994702888444
+ 3.606e-06 1.19978188474982
+ 3.608e-06 1.19978760454597
+ 3.61e-06 1.19965091874597
+ 3.612e-06 1.19969522418134
+ 3.614e-06 1.19954628243885
+ 3.616e-06 1.1993683147677
+ 3.618e-06 1.19950198623989
+ 3.62e-06 1.19964951587999
+ 3.622e-06 1.19939718324648
+ 3.624e-06 1.1993902087908
+ 3.626e-06 1.19948450672528
+ 3.628e-06 1.19955859164436
+ 3.63e-06 1.19986026864905
+ 3.632e-06 1.19955813587387
+ 3.634e-06 1.19947574120168
+ 3.636e-06 1.19947348679512
+ 3.638e-06 1.19945496043999
+ 3.64e-06 1.19946583448612
+ 3.642e-06 1.19941724683537
+ 3.644e-06 1.19950119708112
+ 3.646e-06 1.19947042719319
+ 3.648e-06 1.19928136326834
+ 3.65e-06 1.19927466384971
+ 3.652e-06 1.19952878407968
+ 3.654e-06 1.19972073113109
+ 3.656e-06 1.19985263005858
+ 3.658e-06 1.19973643566193
+ 3.66e-06 1.19973423984793
+ 3.662e-06 1.19973893049232
+ 3.664e-06 1.19932890113312
+ 3.666e-06 1.19946449290684
+ 3.668e-06 1.19967717761237
+ 3.67e-06 1.20011719799161
+ 3.672e-06 1.20013873715404
+ 3.674e-06 1.20023947370204
+ 3.676e-06 1.20019539016802
+ 3.678e-06 1.19997937845068
+ 3.68e-06 1.20024947312748
+ 3.682e-06 1.19973932014203
+ 3.684e-06 1.19974325345642
+ 3.686e-06 1.19946616918023
+ 3.688e-06 1.19972718309068
+ 3.69e-06 1.19990730012298
+ 3.692e-06 1.2001364409997
+ 3.694e-06 1.20016088727369
+ 3.696e-06 1.19996960700201
+ 3.698e-06 1.19988374598793
+ 3.7e-06 1.19954608685041
+ 3.702e-06 1.19964522097063
+ 3.704e-06 1.19984387512171
+ 3.706e-06 1.19969426027834
+ 3.708e-06 1.20000104150485
+ 3.71e-06 1.2000480489196
+ 3.712e-06 1.20051371529232
+ 3.714e-06 1.20080075210914
+ 3.716e-06 1.20071255948703
+ 3.718e-06 1.20070765843782
+ 3.72e-06 1.20081040458456
+ 3.722e-06 1.20087802961135
+ 3.724e-06 1.20097189836927
+ 3.726e-06 1.20111424583125
+ 3.728e-06 1.20106371399689
+ 3.73e-06 1.20033249835459
+ 3.732e-06 1.20037649093687
+ 3.734e-06 1.20040066663578
+ 3.736e-06 1.20018566625912
+ 3.738e-06 1.19980195669294
+ 3.74e-06 1.19944250201585
+ 3.742e-06 1.19958369450871
+ 3.744e-06 1.19948405461757
+ 3.746e-06 1.1996362135296
+ 3.748e-06 1.19958476188099
+ 3.75e-06 1.19953589291232
+ 3.752e-06 1.1992892530419
+ 3.754e-06 1.19934975333241
+ 3.756e-06 1.19919025736592
+ 3.758e-06 1.19932099772792
+ 3.76e-06 1.19947040980873
+ 3.762e-06 1.19967677901136
+ 3.764e-06 1.19959105384528
+ 3.766e-06 1.199415576488
+ 3.768e-06 1.19960791199216
+ 3.77e-06 1.19968025621241
+ 3.772e-06 1.19979551347315
+ 3.774e-06 1.19942387092897
+ 3.776e-06 1.19945150074253
+ 3.778e-06 1.19920044807714
+ 3.78e-06 1.19923771393056
+ 3.782e-06 1.19907019915682
+ 3.784e-06 1.19874987424571
+ 3.786e-06 1.19866787608768
+ 3.788e-06 1.19848070333811
+ 3.79e-06 1.1985649961493
+ 3.792e-06 1.19831029820615
+ 3.794e-06 1.19877726135352
+ 3.796e-06 1.19852171712531
+ 3.798e-06 1.19905379304846
+ 3.8e-06 1.19904652622381
+ 3.802e-06 1.19908560080206
+ 3.804e-06 1.19888142517308
+ 3.806e-06 1.1990928819872
+ 3.808e-06 1.19921385719203
+ 3.81e-06 1.19906393841308
+ 3.812e-06 1.19903591898967
+ 3.814e-06 1.19904315192225
+ 3.816e-06 1.19904478217573
+ 3.818e-06 1.19909456583825
+ 3.82e-06 1.19886207400495
+ 3.822e-06 1.19875487581766
+ 3.824e-06 1.19898149471764
+ 3.826e-06 1.19871729478999
+ 3.828e-06 1.19858730827798
+ 3.83e-06 1.19878113440242
+ 3.832e-06 1.1986580506455
+ 3.834e-06 1.19877139351938
+ 3.836e-06 1.19882229635135
+ 3.838e-06 1.19883987067118
+ 3.84e-06 1.19862421712671
+ 3.842e-06 1.19844272302918
+ 3.844e-06 1.19859654375538
+ 3.846e-06 1.19847350944078
+ 3.848e-06 1.19845914964025
+ 3.85e-06 1.19872339988611
+ 3.852e-06 1.19889463950213
+ 3.854e-06 1.19898347860608
+ 3.856e-06 1.19864614326134
+ 3.858e-06 1.19874970859127
+ 3.86e-06 1.19884760455594
+ 3.862e-06 1.19893831533549
+ 3.864e-06 1.19936132316561
+ 3.866e-06 1.19911308795945
+ 3.868e-06 1.19903934996922
+ 3.87e-06 1.19899518473943
+ 3.872e-06 1.19878841787309
+ 3.874e-06 1.19853320904561
+ 3.876e-06 1.19882336617091
+ 3.878e-06 1.19884610125465
+ 3.88e-06 1.1986453054595
+ 3.882e-06 1.19872494888442
+ 3.884e-06 1.19854732464335
+ 3.886e-06 1.19846562367822
+ 3.888e-06 1.19827165002778
+ 3.89e-06 1.19816623143883
+ 3.892e-06 1.19841331873621
+ 3.894e-06 1.19874079216552
+ 3.896e-06 1.19846510070046
+ 3.898e-06 1.19830659191064
+ 3.9e-06 1.19807450252599
+ 3.902e-06 1.19812677921976
+ 3.904e-06 1.19815269893785
+ 3.906e-06 1.19817971977336
+ 3.908e-06 1.19828430165005
+ 3.91e-06 1.19824127680704
+ 3.912e-06 1.198259556638
+ 3.914e-06 1.19812130186297
+ 3.916e-06 1.1979965835282
+ 3.918e-06 1.19787665443483
+ 3.92e-06 1.19772763918068
+ 3.922e-06 1.19758017383012
+ 3.924e-06 1.19765764930178
+ 3.926e-06 1.1977736075028
+ 3.928e-06 1.19823970635792
+ 3.93e-06 1.19826448771603
+ 3.932e-06 1.19835500128462
+ 3.934e-06 1.19846863181605
+ 3.936e-06 1.19822987910716
+ 3.938e-06 1.19863322790408
+ 3.94e-06 1.19856353100443
+ 3.942e-06 1.19839082587346
+ 3.944e-06 1.19861973205649
+ 3.946e-06 1.1984621467002
+ 3.948e-06 1.1985767529967
+ 3.95e-06 1.19858200345658
+ 3.952e-06 1.19860772526446
+ 3.954e-06 1.19863249742459
+ 3.956e-06 1.19883567253039
+ 3.958e-06 1.19863777122342
+ 3.96e-06 1.19882089742094
+ 3.962e-06 1.19857853121674
+ 3.964e-06 1.19857987606913
+ 3.966e-06 1.19869001980856
+ 3.968e-06 1.19893793376584
+ 3.97e-06 1.1991121231994
+ 3.972e-06 1.19905473707032
+ 3.974e-06 1.19919696026376
+ 3.976e-06 1.19914918818219
+ 3.978e-06 1.19925465237346
+ 3.98e-06 1.19925492713337
+ 3.982e-06 1.19926631465656
+ 3.984e-06 1.19890973852649
+ 3.986e-06 1.19890561379433
+ 3.988e-06 1.19880488003414
+ 3.99e-06 1.19874197142519
+ 3.992e-06 1.19884920669372
+ 3.994e-06 1.19882927946449
+ 3.996e-06 1.19877663915153
+ 3.998e-06 1.19859082754542
+ 4e-06 1.19904864502583
+ 4.002e-06 1.19914972236743
+ 4.004e-06 1.19935365192635
+ 4.006e-06 1.19935842063031
+ 4.008e-06 1.19936951709904
+ 4.01e-06 1.19960746237532
+ 4.012e-06 1.20003000788256
+ 4.014e-06 1.199949892209
+ 4.016e-06 1.19981917679652
+ 4.018e-06 1.1997518926453
+ 4.02e-06 1.19968844311717
+ 4.022e-06 1.19946719324159
+ 4.024e-06 1.19916370700432
+ 4.026e-06 1.19946976938687
+ 4.028e-06 1.1991937243618
+ 4.03e-06 1.19922482827873
+ 4.032e-06 1.19940167764478
+ 4.034e-06 1.19962790674004
+ 4.036e-06 1.19944580950302
+ 4.038e-06 1.1995418527052
+ 4.04e-06 1.19958657875828
+ 4.042e-06 1.19939831696855
+ 4.044e-06 1.19967861927302
+ 4.046e-06 1.1995879499806
+ 4.048e-06 1.19986352329445
+ 4.05e-06 1.19965526929154
+ 4.052e-06 1.19952841758653
+ 4.054e-06 1.19942823963232
+ 4.056e-06 1.19924456115704
+ 4.058e-06 1.19936605928974
+ 4.06e-06 1.19955907968756
+ 4.062e-06 1.19954469932886
+ 4.064e-06 1.1995886817263
+ 4.066e-06 1.19952076178372
+ 4.068e-06 1.19965086285945
+ 4.07e-06 1.1997507944
+ 4.072e-06 1.19923824395514
+ 4.074e-06 1.1990482489859
+ 4.076e-06 1.19902525743801
+ 4.078e-06 1.19896607348717
+ 4.08e-06 1.19893255482512
+ 4.082e-06 1.1990877445555
+ 4.084e-06 1.19912921787223
+ 4.086e-06 1.19918551431969
+ 4.088e-06 1.19928020104615
+ 4.09e-06 1.19909232759558
+ 4.092e-06 1.19911470065591
+ 4.094e-06 1.1990282994066
+ 4.096e-06 1.19910213297449
+ 4.098e-06 1.1993735403674
+ 4.1e-06 1.19927233896828
+ 4.102e-06 1.19930548205324
+ 4.104e-06 1.19937141886267
+ 4.106e-06 1.19924287131545
+ 4.108e-06 1.19954259113149
+ 4.11e-06 1.199176495496
+ 4.112e-06 1.19945075586844
+ 4.114e-06 1.19954084005159
+ 4.116e-06 1.19927496760847
+ 4.118e-06 1.19935409095405
+ 4.12e-06 1.19923393712522
+ 4.122e-06 1.19935767309992
+ 4.124e-06 1.19943080614164
+ 4.126e-06 1.19949624306607
+ 4.128e-06 1.19943198197059
+ 4.13e-06 1.19967729308962
+ 4.132e-06 1.19939525438419
+ 4.134e-06 1.19926450715784
+ 4.136e-06 1.19920714683633
+ 4.138e-06 1.19932387177247
+ 4.14e-06 1.19914038488544
+ 4.142e-06 1.19899654817984
+ 4.144e-06 1.19872889391885
+ 4.146e-06 1.19863696876746
+ 4.148e-06 1.19892781587257
+ 4.15e-06 1.19882651876473
+ 4.152e-06 1.19878329943671
+ 4.154e-06 1.19909487568095
+ 4.156e-06 1.19900917889882
+ 4.158e-06 1.19876807116611
+ 4.16e-06 1.19876812042832
+ 4.162e-06 1.19858124783844
+ 4.164e-06 1.19870043767335
+ 4.166e-06 1.19905293854282
+ 4.168e-06 1.19896186875431
+ 4.17e-06 1.19900432674729
+ 4.172e-06 1.19910915728665
+ 4.174e-06 1.19935906864557
+ 4.176e-06 1.19959225837695
+ 4.178e-06 1.19984748872108
+ 4.18e-06 1.19989520875038
+ 4.182e-06 1.19972334238549
+ 4.184e-06 1.19959665196327
+ 4.186e-06 1.19943331590785
+ 4.188e-06 1.19920185090086
+ 4.19e-06 1.19861939249049
+ 4.192e-06 1.19894397320227
+ 4.194e-06 1.19906375759189
+ 4.196e-06 1.19915199576765
+ 4.198e-06 1.1988566746182
+ 4.2e-06 1.19896480654265
+ 4.202e-06 1.19877150425769
+ 4.204e-06 1.19898400939539
+ 4.206e-06 1.19883702890526
+ 4.208e-06 1.19876654762571
+ 4.21e-06 1.19912639570981
+ 4.212e-06 1.19931470455765
+ 4.214e-06 1.19973796290264
+ 4.216e-06 1.19971499481243
+ 4.218e-06 1.19952531633124
+ 4.22e-06 1.19948072053067
+ 4.222e-06 1.1994752948167
+ 4.224e-06 1.19975477965784
+ 4.226e-06 1.20009820480764
+ 4.228e-06 1.20002354936292
+ 4.23e-06 1.19996559811024
+ 4.232e-06 1.19998398997992
+ 4.234e-06 1.20012888181665
+ 4.236e-06 1.20002853897436
+ 4.238e-06 1.20003602665725
+ 4.24e-06 1.19991798648978
+ 4.242e-06 1.19992597201567
+ 4.244e-06 1.19963857055085
+ 4.246e-06 1.19956644917324
+ 4.248e-06 1.20010388745968
+ 4.25e-06 1.20008800884703
+ 4.252e-06 1.20004557944853
+ 4.254e-06 1.19964333350359
+ 4.256e-06 1.19992870212477
+ 4.258e-06 1.19978701931057
+ 4.26e-06 1.19992223730129
+ 4.262e-06 1.19977227504344
+ 4.264e-06 1.19995179324685
+ 4.266e-06 1.19981231447456
+ 4.268e-06 1.19988764540468
+ 4.27e-06 1.20012425324421
+ 4.272e-06 1.20030063068906
+ 4.274e-06 1.20021373271896
+ 4.276e-06 1.20039808142561
+ 4.278e-06 1.20018956190638
+ 4.28e-06 1.20019152362797
+ 4.282e-06 1.20006611150521
+ 4.284e-06 1.20029709889734
+ 4.286e-06 1.2001996751669
+ 4.288e-06 1.20026149859299
+ 4.29e-06 1.20003167389052
+ 4.292e-06 1.19977027220746
+ 4.294e-06 1.19995150963381
+ 4.296e-06 1.19991995425423
+ 4.298e-06 1.19982373449691
+ 4.3e-06 1.19939139607154
+ 4.302e-06 1.19907055165955
+ 4.304e-06 1.19902240678985
+ 4.306e-06 1.19911108988047
+ 4.308e-06 1.19916313456478
+ 4.31e-06 1.19891601318938
+ 4.312e-06 1.19897289299798
+ 4.314e-06 1.19938059616265
+ 4.316e-06 1.19923191997901
+ 4.318e-06 1.19921975513888
+ 4.32e-06 1.19958013185876
+ 4.322e-06 1.19909653150486
+ 4.324e-06 1.19935584585207
+ 4.326e-06 1.19931046382523
+ 4.328e-06 1.19916337440176
+ 4.33e-06 1.19906944641687
+ 4.332e-06 1.19922452987469
+ 4.334e-06 1.19931041975846
+ 4.336e-06 1.19916719990037
+ 4.338e-06 1.19926129091551
+ 4.34e-06 1.19922836609486
+ 4.342e-06 1.19916192693597
+ 4.344e-06 1.19956258369942
+ 4.346e-06 1.19983546507995
+ 4.348e-06 1.20021660433166
+ 4.35e-06 1.20042365747071
+ 4.352e-06 1.20022743080559
+ 4.354e-06 1.20021710224891
+ 4.356e-06 1.20025037600533
+ 4.358e-06 1.20027819241993
+ 4.36e-06 1.20048205454319
+ 4.362e-06 1.20020497119468
+ 4.364e-06 1.20054999586393
+ 4.366e-06 1.20050885711173
+ 4.368e-06 1.20024742362507
+ 4.37e-06 1.20026535264295
+ 4.372e-06 1.20000177661569
+ 4.374e-06 1.20026138372636
+ 4.376e-06 1.20031579473157
+ 4.378e-06 1.20056818269987
+ 4.38e-06 1.20080143800216
+ 4.382e-06 1.20086233657004
+ 4.384e-06 1.20097184883354
+ 4.386e-06 1.20110472032646
+ 4.388e-06 1.2015728526419
+ 4.39e-06 1.20172456250518
+ 4.392e-06 1.20178634078794
+ 4.394e-06 1.20167310337015
+ 4.396e-06 1.2017130777322
+ 4.398e-06 1.20174650750924
+ 4.4e-06 1.20182068469684
+ 4.402e-06 1.20208084949003
+ 4.404e-06 1.20180640072343
+ 4.406e-06 1.20189851220933
+ 4.408e-06 1.20156740154149
+ 4.41e-06 1.20167664991181
+ 4.412e-06 1.20128356804541
+ 4.414e-06 1.20128716940469
+ 4.416e-06 1.20124993031231
+ 4.418e-06 1.20111390461115
+ 4.42e-06 1.20096872137493
+ 4.422e-06 1.2007922578496
+ 4.424e-06 1.20076125658976
+ 4.426e-06 1.20054468217952
+ 4.428e-06 1.20032051934558
+ 4.43e-06 1.20033654906109
+ 4.432e-06 1.20053432838979
+ 4.434e-06 1.20039304776361
+ 4.436e-06 1.20054583831729
+ 4.438e-06 1.2001626477907
+ 4.44e-06 1.20026781851266
+ 4.442e-06 1.20032801103155
+ 4.444e-06 1.19999348772197
+ 4.446e-06 1.20018430133365
+ 4.448e-06 1.20043335828255
+ 4.45e-06 1.19993632050018
+ 4.452e-06 1.19994322470058
+ 4.454e-06 1.20017414958909
+ 4.456e-06 1.2003363282187
+ 4.458e-06 1.19990551554212
+ 4.46e-06 1.19964152873171
+ 4.462e-06 1.19958316217897
+ 4.464e-06 1.19947102108825
+ 4.466e-06 1.19933849104881
+ 4.468e-06 1.19962728354113
+ 4.47e-06 1.1996565199786
+ 4.472e-06 1.1997379421247
+ 4.474e-06 1.19976948593826
+ 4.476e-06 1.19983927744214
+ 4.478e-06 1.19998640225724
+ 4.48e-06 1.20008501502137
+ 4.482e-06 1.20009725395321
+ 4.484e-06 1.19964052612582
+ 4.486e-06 1.19946260549571
+ 4.488e-06 1.19934845361259
+ 4.49e-06 1.19934680126783
+ 4.492e-06 1.19934653170999
+ 4.494e-06 1.19914447074415
+ 4.496e-06 1.19914327609856
+ 4.498e-06 1.19949448114689
+ 4.5e-06 1.19968426824402
+ 4.502e-06 1.20008839407798
+ 4.504e-06 1.20040690754241
+ 4.506e-06 1.20026183338134
+ 4.508e-06 1.20015367683394
+ 4.51e-06 1.20029894344507
+ 4.512e-06 1.20015013568713
+ 4.514e-06 1.19983827530732
+ 4.516e-06 1.20005217906733
+ 4.518e-06 1.19997616772076
+ 4.52e-06 1.19990809171447
+ 4.522e-06 1.19984188755525
+ 4.524e-06 1.19993806835586
+ 4.526e-06 1.1999676268711
+ 4.528e-06 1.19952638206341
+ 4.53e-06 1.19988627421787
+ 4.532e-06 1.19975790643912
+ 4.534e-06 1.19941476987761
+ 4.536e-06 1.19955486245192
+ 4.538e-06 1.19976883325477
+ 4.54e-06 1.19973882516804
+ 4.542e-06 1.19985115133146
+ 4.544e-06 1.19976841554403
+ 4.546e-06 1.19987022909509
+ 4.548e-06 1.1998856205869
+ 4.55e-06 1.19971491976648
+ 4.552e-06 1.1994850175939
+ 4.554e-06 1.19931611192708
+ 4.556e-06 1.19933415561868
+ 4.558e-06 1.19907821871239
+ 4.56e-06 1.1989021911155
+ 4.562e-06 1.19887910168499
+ 4.564e-06 1.19924320323569
+ 4.566e-06 1.19935248147677
+ 4.568e-06 1.19914978778647
+ 4.57e-06 1.19902669973031
+ 4.572e-06 1.19907460678543
+ 4.574e-06 1.19914422892659
+ 4.576e-06 1.19911824891576
+ 4.578e-06 1.19914289274783
+ 4.58e-06 1.19911940864332
+ 4.582e-06 1.19896736453064
+ 4.584e-06 1.19879607255517
+ 4.586e-06 1.19884770372926
+ 4.588e-06 1.19900656301262
+ 4.59e-06 1.19910751386249
+ 4.592e-06 1.19892311665989
+ 4.594e-06 1.19894303591389
+ 4.596e-06 1.1990604023294
+ 4.598e-06 1.19916903589536
+ 4.6e-06 1.19901110843368
+ 4.602e-06 1.19891045459781
+ 4.604e-06 1.19877474329866
+ 4.606e-06 1.19892650839864
+ 4.608e-06 1.19849571645964
+ 4.61e-06 1.19826204394373
+ 4.612e-06 1.19812987901983
+ 4.614e-06 1.19806244912144
+ 4.616e-06 1.19783816325166
+ 4.618e-06 1.19738400628316
+ 4.62e-06 1.19792961753615
+ 4.622e-06 1.19805529102344
+ 4.624e-06 1.1982358473058
+ 4.626e-06 1.19836397618082
+ 4.628e-06 1.19804109199064
+ 4.63e-06 1.19822831367744
+ 4.632e-06 1.19823636323292
+ 4.634e-06 1.1983687561979
+ 4.636e-06 1.19842023123477
+ 4.638e-06 1.19858918146852
+ 4.64e-06 1.19795533719233
+ 4.642e-06 1.19790258984319
+ 4.644e-06 1.19772523193797
+ 4.646e-06 1.19789209081483
+ 4.648e-06 1.19786738421591
+ 4.65e-06 1.19803015021704
+ 4.652e-06 1.19811376238079
+ 4.654e-06 1.19823969252655
+ 4.656e-06 1.19834246026664
+ 4.658e-06 1.19848910182037
+ 4.66e-06 1.19879214644375
+ 4.662e-06 1.19880507439163
+ 4.664e-06 1.19885218803184
+ 4.666e-06 1.19891407899666
+ 4.668e-06 1.19942164654284
+ 4.67e-06 1.19947408895511
+ 4.672e-06 1.19943623013402
+ 4.674e-06 1.1993212399954
+ 4.676e-06 1.19926585796939
+ 4.678e-06 1.19900746671296
+ 4.68e-06 1.198669105813
+ 4.682e-06 1.19857339684774
+ 4.684e-06 1.19861276970177
+ 4.686e-06 1.19878483842429
+ 4.688e-06 1.19871004706911
+ 4.69e-06 1.19873688736497
+ 4.692e-06 1.19883468985931
+ 4.694e-06 1.19864512707002
+ 4.696e-06 1.19901190244243
+ 4.698e-06 1.19909103767662
+ 4.7e-06 1.19898117377013
+ 4.702e-06 1.1992341623799
+ 4.704e-06 1.1991349921523
+ 4.706e-06 1.19932595269673
+ 4.708e-06 1.19924110110007
+ 4.71e-06 1.19941480621089
+ 4.712e-06 1.19932419449864
+ 4.714e-06 1.19914380034847
+ 4.716e-06 1.19911595293426
+ 4.718e-06 1.19910466694123
+ 4.72e-06 1.1989555404029
+ 4.722e-06 1.19909514443522
+ 4.724e-06 1.19903129833694
+ 4.726e-06 1.19884992911491
+ 4.728e-06 1.19870157476335
+ 4.73e-06 1.19870814246677
+ 4.732e-06 1.19874455871993
+ 4.734e-06 1.19875359200096
+ 4.736e-06 1.19862777692475
+ 4.738e-06 1.19886267660657
+ 4.74e-06 1.19884672216719
+ 4.742e-06 1.19893632889774
+ 4.744e-06 1.19908701896007
+ 4.746e-06 1.19930595924517
+ 4.748e-06 1.19972393476138
+ 4.75e-06 1.19979910332636
+ 4.752e-06 1.19955276552126
+ 4.754e-06 1.19927995531906
+ 4.756e-06 1.19910232696467
+ 4.758e-06 1.19899377194556
+ 4.76e-06 1.19933091064438
+ 4.762e-06 1.19907835389165
+ 4.764e-06 1.19893693016301
+ 4.766e-06 1.19895647814877
+ 4.768e-06 1.19868411179138
+ 4.77e-06 1.19866729764929
+ 4.772e-06 1.19878822586117
+ 4.774e-06 1.1990362352773
+ 4.776e-06 1.19955324084206
+ 4.778e-06 1.19931268369576
+ 4.78e-06 1.19981724000747
+ 4.782e-06 1.19959612368697
+ 4.784e-06 1.19963844611137
+ 4.786e-06 1.19989001283588
+ 4.788e-06 1.19981316521271
+ 4.79e-06 1.19963196888488
+ 4.792e-06 1.19965131297386
+ 4.794e-06 1.19980617184105
+ 4.796e-06 1.19991190766567
+ 4.798e-06 1.20001110644464
+ 4.8e-06 1.19983994017213
+ 4.802e-06 1.20006989447917
+ 4.804e-06 1.20016349716087
+ 4.806e-06 1.20012534765009
+ 4.808e-06 1.19980456663069
+ 4.81e-06 1.19970725630447
+ 4.812e-06 1.20001255481116
+ 4.814e-06 1.2001287048975
+ 4.816e-06 1.1998882747387
+ 4.818e-06 1.20007110470503
+ 4.82e-06 1.20005596566385
+ 4.822e-06 1.20004339706867
+ 4.824e-06 1.20016211473022
+ 4.826e-06 1.20023889812851
+ 4.828e-06 1.20023796816558
+ 4.83e-06 1.20037887363454
+ 4.832e-06 1.20045564653348
+ 4.834e-06 1.20035964626535
+ 4.836e-06 1.20032738656903
+ 4.838e-06 1.20029903746219
+ 4.84e-06 1.20025226834149
+ 4.842e-06 1.20032268964604
+ 4.844e-06 1.20033593517234
+ 4.846e-06 1.20021086031355
+ 4.848e-06 1.20038953538363
+ 4.85e-06 1.20023049081293
+ 4.852e-06 1.20033636871147
+ 4.854e-06 1.19979119418102
+ 4.856e-06 1.20023808131778
+ 4.858e-06 1.2000005442848
+ 4.86e-06 1.19981683831137
+ 4.862e-06 1.19953993927927
+ 4.864e-06 1.19953744332535
+ 4.866e-06 1.19930840261932
+ 4.868e-06 1.19894019221517
+ 4.87e-06 1.19894711067318
+ 4.872e-06 1.1988650431969
+ 4.874e-06 1.19866906333544
+ 4.876e-06 1.19864632821306
+ 4.878e-06 1.19838488375464
+ 4.88e-06 1.19842154369907
+ 4.882e-06 1.19837392549989
+ 4.884e-06 1.19844223477052
+ 4.886e-06 1.19856752166067
+ 4.888e-06 1.19900000683074
+ 4.89e-06 1.1991453495418
+ 4.892e-06 1.19908659043908
+ 4.894e-06 1.19874818837512
+ 4.896e-06 1.19864826586314
+ 4.898e-06 1.19882220272223
+ 4.9e-06 1.19916119851348
+ 4.902e-06 1.19947930865802
+ 4.904e-06 1.19975611388198
+ 4.906e-06 1.19950184317018
+ 4.908e-06 1.19968722175853
+ 4.91e-06 1.19999150385643
+ 4.912e-06 1.20009891867196
+ 4.914e-06 1.20007851676073
+ 4.916e-06 1.19990597451417
+ 4.918e-06 1.2001841762664
+ 4.92e-06 1.20029350318055
+ 4.922e-06 1.20013015478416
+ 4.924e-06 1.2002937581889
+ 4.926e-06 1.20004996110019
+ 4.928e-06 1.20028827033299
+ 4.93e-06 1.19992727362299
+ 4.932e-06 1.20007860982162
+ 4.934e-06 1.20039298708275
+ 4.936e-06 1.20038146249464
+ 4.938e-06 1.20060043021524
+ 4.94e-06 1.20076320484831
+ 4.942e-06 1.20103426029233
+ 4.944e-06 1.20120861637283
+ 4.946e-06 1.20088784425963
+ 4.948e-06 1.20087243523866
+ 4.95e-06 1.20076579511384
+ 4.952e-06 1.20071184724361
+ 4.954e-06 1.2005947952884
+ 4.956e-06 1.20057394107538
+ 4.958e-06 1.20074267546733
+ 4.96e-06 1.20057147276165
+ 4.962e-06 1.20036627831355
+ 4.964e-06 1.20068766315794
+ 4.966e-06 1.20082385677351
+ 4.968e-06 1.20061963517441
+ 4.97e-06 1.2008357092967
+ 4.972e-06 1.20105376149598
+ 4.974e-06 1.20113497880118
+ 4.976e-06 1.20116588698425
+ 4.978e-06 1.20102692102098
+ 4.98e-06 1.2007075286846
+ 4.982e-06 1.20089923462577
+ 4.984e-06 1.20116776994083
+ 4.986e-06 1.20132909387833
+ 4.988e-06 1.20087531528124
+ 4.99e-06 1.20084267797692
+ 4.992e-06 1.20067019462513
+ 4.994e-06 1.2006577952003
+ 4.996e-06 1.20076659905012
+ 4.998e-06 1.20093086286003
+ 5e-06 1.20121528855337
+ 5.002e-06 1.20122537980223
+ 5.004e-06 1.20099993151995
+ 5.006e-06 1.20097621046653
+ 5.008e-06 1.20056080260509
+ 5.01e-06 1.20066145090133
+ 5.012e-06 1.20044280738644
+ 5.014e-06 1.20034875550837
+ 5.016e-06 1.20029758298533
+ 5.018e-06 1.20029897491983
+ 5.02e-06 1.19987236235233
+ 5.022e-06 1.19987721069571
+ 5.024e-06 1.20008282966077
+ 5.026e-06 1.19979334563173
+ 5.028e-06 1.19959591803305
+ 5.03e-06 1.19908882676706
+ 5.032e-06 1.19901580611409
+ 5.034e-06 1.19904163095045
+ 5.036e-06 1.19884666907686
+ 5.038e-06 1.19871359927682
+ 5.04e-06 1.19863338926299
+ 5.042e-06 1.19877699121791
+ 5.044e-06 1.1983909144629
+ 5.046e-06 1.19850467083558
+ 5.048e-06 1.19883481407034
+ 5.05e-06 1.19921734868043
+ 5.052e-06 1.19886612949436
+ 5.054e-06 1.19851032102515
+ 5.056e-06 1.19851485405763
+ 5.058e-06 1.19841036540308
+ 5.06e-06 1.19847464565677
+ 5.062e-06 1.19836455090267
+ 5.064e-06 1.19830012273909
+ 5.066e-06 1.19821359074444
+ 5.068e-06 1.19823125678838
+ 5.07e-06 1.19804552308791
+ 5.072e-06 1.19803383400428
+ 5.074e-06 1.19826477719058
+ 5.076e-06 1.19838505982333
+ 5.078e-06 1.19852257980546
+ 5.08e-06 1.19855830937195
+ 5.082e-06 1.19850463981162
+ 5.084e-06 1.19836095874243
+ 5.086e-06 1.19807211226537
+ 5.088e-06 1.19845803022784
+ 5.09e-06 1.19833838306561
+ 5.092e-06 1.19796391748669
+ 5.094e-06 1.19779620768589
+ 5.096e-06 1.19782102656414
+ 5.098e-06 1.19799868397924
+ 5.1e-06 1.19751510883006
+ 5.102e-06 1.19772715104894
+ 5.104e-06 1.19757055472098
+ 5.106e-06 1.19760209575597
+ 5.108e-06 1.19754686858481
+ 5.11e-06 1.19798268120158
+ 5.112e-06 1.1975868517183
+ 5.114e-06 1.19786929577978
+ 5.116e-06 1.19826841006092
+ 5.118e-06 1.19802486413468
+ 5.12e-06 1.19799906356156
+ 5.122e-06 1.19751984622404
+ 5.124e-06 1.19732664404093
+ 5.126e-06 1.19744685558517
+ 5.128e-06 1.19757890673004
+ 5.13e-06 1.19753602158485
+ 5.132e-06 1.19769240958633
+ 5.134e-06 1.19765701401461
+ 5.136e-06 1.19761067871464
+ 5.138e-06 1.19756631803376
+ 5.14e-06 1.19729152160363
+ 5.142e-06 1.19741873965871
+ 5.144e-06 1.19752069853244
+ 5.146e-06 1.19747026578472
+ 5.148e-06 1.19789976328339
+ 5.15e-06 1.19833102888987
+ 5.152e-06 1.19842790133966
+ 5.154e-06 1.19892385499441
+ 5.156e-06 1.19914797770643
+ 5.158e-06 1.19939604245828
+ 5.16e-06 1.19923861060918
+ 5.162e-06 1.19921690775743
+ 5.164e-06 1.19957350620218
+ 5.166e-06 1.19964993578093
+ 5.168e-06 1.19959756899222
+ 5.17e-06 1.1994867949104
+ 5.172e-06 1.1994720394396
+ 5.174e-06 1.19912425170613
+ 5.176e-06 1.19901741985624
+ 5.178e-06 1.19905178858457
+ 5.18e-06 1.19909901910091
+ 5.182e-06 1.19960988354821
+ 5.184e-06 1.19943175339652
+ 5.186e-06 1.19943154819592
+ 5.188e-06 1.19947212927516
+ 5.19e-06 1.19935692717222
+ 5.192e-06 1.19896227288082
+ 5.194e-06 1.19909078349438
+ 5.196e-06 1.19887662817928
+ 5.198e-06 1.19922496425163
+ 5.2e-06 1.1992602723759
+ 5.202e-06 1.19943635038458
+ 5.204e-06 1.19943693947993
+ 5.206e-06 1.19931102442551
+ 5.208e-06 1.19945652925503
+ 5.21e-06 1.20007134068224
+ 5.212e-06 1.20050085321062
+ 5.214e-06 1.20068528749765
+ 5.216e-06 1.20061197909542
+ 5.218e-06 1.20059690799146
+ 5.22e-06 1.20077143984289
+ 5.222e-06 1.20079011591262
+ 5.224e-06 1.20047268678227
+ 5.226e-06 1.20067825731074
+ 5.228e-06 1.20045848406962
+ 5.23e-06 1.20016126224264
+ 5.232e-06 1.19990298532704
+ 5.234e-06 1.19982385623087
+ 5.236e-06 1.20026901753762
+ 5.238e-06 1.20029715835412
+ 5.24e-06 1.20026153453889
+ 5.242e-06 1.20021577496388
+ 5.244e-06 1.20018575460388
+ 5.246e-06 1.20031077160164
+ 5.248e-06 1.20033306698227
+ 5.25e-06 1.20014578271202
+ 5.252e-06 1.20026602231653
+ 5.254e-06 1.20046767020731
+ 5.256e-06 1.20033741763544
+ 5.258e-06 1.20048127895973
+ 5.26e-06 1.20065262931747
+ 5.262e-06 1.20071111608125
+ 5.264e-06 1.20105651142852
+ 5.266e-06 1.20114889200871
+ 5.268e-06 1.20135735572937
+ 5.27e-06 1.20111438906515
+ 5.272e-06 1.20101163285072
+ 5.274e-06 1.20079015281365
+ 5.276e-06 1.200783706208
+ 5.278e-06 1.20074664164087
+ 5.28e-06 1.20091238755829
+ 5.282e-06 1.20103028953343
+ 5.284e-06 1.20118913919747
+ 5.286e-06 1.20115507205457
+ 5.288e-06 1.20101146795555
+ 5.29e-06 1.20105934019391
+ 5.292e-06 1.20116392201205
+ 5.294e-06 1.20090426806882
+ 5.296e-06 1.20083302183277
+ 5.298e-06 1.20058905453262
+ 5.3e-06 1.2005579597565
+ 5.302e-06 1.20018698634995
+ 5.304e-06 1.19987688101798
+ 5.306e-06 1.1998752438636
+ 5.308e-06 1.19977954836416
+ 5.31e-06 1.19980004395934
+ 5.312e-06 1.19987906594049
+ 5.314e-06 1.20002452317134
+ 5.316e-06 1.20012172298316
+ 5.318e-06 1.20031082784268
+ 5.32e-06 1.20033843654946
+ 5.322e-06 1.20031954581653
+ 5.324e-06 1.20009369058221
+ 5.326e-06 1.20031837896965
+ 5.328e-06 1.20040869642347
+ 5.33e-06 1.20028814531467
+ 5.332e-06 1.20047944964683
+ 5.334e-06 1.20030555160618
+ 5.336e-06 1.20021415109887
+ 5.338e-06 1.19994237469158
+ 5.34e-06 1.20019272883947
+ 5.342e-06 1.19978977602313
+ 5.344e-06 1.19962204740762
+ 5.346e-06 1.19941088021358
+ 5.348e-06 1.19943366571158
+ 5.35e-06 1.19944761993758
+ 5.352e-06 1.19976077958136
+ 5.354e-06 1.19982050563204
+ 5.356e-06 1.19989657523144
+ 5.358e-06 1.19979882855159
+ 5.36e-06 1.19971461001045
+ 5.362e-06 1.19984036210763
+ 5.364e-06 1.19960891988053
+ 5.366e-06 1.20001124478514
+ 5.368e-06 1.20025314507042
+ 5.37e-06 1.20021558992431
+ 5.372e-06 1.20053605763866
+ 5.374e-06 1.19999862784606
+ 5.376e-06 1.19995325939269
+ 5.378e-06 1.19991972504023
+ 5.38e-06 1.1997504697974
+ 5.382e-06 1.19983941144569
+ 5.384e-06 1.20001665524599
+ 5.386e-06 1.20019105834456
+ 5.388e-06 1.20026205143938
+ 5.39e-06 1.20041511564475
+ 5.392e-06 1.20035941149821
+ 5.394e-06 1.20028749133065
+ 5.396e-06 1.20033195101809
+ 5.398e-06 1.20055510650026
+ 5.4e-06 1.2007513582026
+ 5.402e-06 1.20082880900149
+ 5.404e-06 1.20108170402618
+ 5.406e-06 1.20127513433425
+ 5.408e-06 1.20116600055002
+ 5.41e-06 1.20142225940889
+ 5.412e-06 1.20115077947634
+ 5.414e-06 1.20120406174634
+ 5.416e-06 1.20106359363224
+ 5.418e-06 1.20093672483229
+ 5.42e-06 1.20152004317057
+ 5.422e-06 1.20211318785002
+ 5.424e-06 1.20206197452997
+ 5.426e-06 1.20223063529926
+ 5.428e-06 1.20205608862316
+ 5.43e-06 1.20244181508238
+ 5.432e-06 1.20230518432413
+ 5.434e-06 1.20208896224817
+ 5.436e-06 1.20226228814087
+ 5.438e-06 1.20196406919813
+ 5.44e-06 1.20220007172647
+ 5.442e-06 1.20208047399258
+ 5.444e-06 1.20218098140486
+ 5.446e-06 1.20198570014431
+ 5.448e-06 1.20183024308305
+ 5.45e-06 1.20176635039975
+ 5.452e-06 1.20165884594637
+ 5.454e-06 1.2014448003323
+ 5.456e-06 1.20125179958014
+ 5.458e-06 1.20125657443211
+ 5.46e-06 1.20135014045115
+ 5.462e-06 1.20128836949811
+ 5.464e-06 1.20121298859107
+ 5.466e-06 1.20093949548721
+ 5.468e-06 1.20121212218024
+ 5.47e-06 1.20135201455419
+ 5.472e-06 1.20124465367378
+ 5.474e-06 1.20101880760463
+ 5.476e-06 1.2011746188804
+ 5.478e-06 1.20131704817615
+ 5.48e-06 1.20097591523705
+ 5.482e-06 1.20061702843536
+ 5.484e-06 1.20030303149404
+ 5.486e-06 1.20054941944969
+ 5.488e-06 1.20034563017085
+ 5.49e-06 1.20033584256641
+ 5.492e-06 1.20050326464344
+ 5.494e-06 1.20034161095959
+ 5.496e-06 1.20006767547784
+ 5.498e-06 1.20032941797923
+ 5.5e-06 1.20032059860506
+ 5.502e-06 1.2001959463617
+ 5.504e-06 1.20006368124704
+ 5.506e-06 1.20009434555836
+ 5.508e-06 1.20000419981557
+ 5.51e-06 1.20038337456054
+ 5.512e-06 1.20058414944532
+ 5.514e-06 1.20055386075819
+ 5.516e-06 1.20047122677673
+ 5.518e-06 1.20028560841823
+ 5.52e-06 1.20028544410174
+ 5.522e-06 1.2004286458924
+ 5.524e-06 1.20062226636637
+ 5.526e-06 1.20064751557378
+ 5.528e-06 1.20084383287171
+ 5.53e-06 1.20105298133154
+ 5.532e-06 1.20073959316357
+ 5.534e-06 1.20077503295237
+ 5.536e-06 1.20107284378333
+ 5.538e-06 1.20103034814621
+ 5.54e-06 1.20106573498413
+ 5.542e-06 1.20106365575909
+ 5.544e-06 1.20115309572665
+ 5.546e-06 1.20111159884265
+ 5.548e-06 1.20094182210893
+ 5.55e-06 1.20066834014962
+ 5.552e-06 1.2004397137644
+ 5.554e-06 1.20019032792739
+ 5.556e-06 1.20000298103949
+ 5.558e-06 1.20025299638783
+ 5.56e-06 1.20042163717639
+ 5.562e-06 1.20035215573994
+ 5.564e-06 1.20088551883408
+ 5.566e-06 1.20109864677778
+ 5.568e-06 1.20100671809944
+ 5.57e-06 1.20073084644549
+ 5.572e-06 1.20047821241378
+ 5.574e-06 1.20042101008701
+ 5.576e-06 1.20040877849905
+ 5.578e-06 1.2003817154418
+ 5.58e-06 1.20012019645446
+ 5.582e-06 1.20010479213882
+ 5.584e-06 1.20034238783776
+ 5.586e-06 1.20032823513424
+ 5.588e-06 1.20047897552155
+ 5.59e-06 1.2004820801294
+ 5.592e-06 1.20048885569723
+ 5.594e-06 1.20026244697997
+ 5.596e-06 1.20034687251989
+ 5.598e-06 1.20039137441135
+ 5.6e-06 1.20021463298174
+ 5.602e-06 1.20007114081114
+ 5.604e-06 1.20014510042956
+ 5.606e-06 1.20016068612694
+ 5.608e-06 1.20011357560453
+ 5.61e-06 1.200060597028
+ 5.612e-06 1.20016227140558
+ 5.614e-06 1.20034488880429
+ 5.616e-06 1.20049279184035
+ 5.618e-06 1.20082394574695
+ 5.62e-06 1.20085757375175
+ 5.622e-06 1.20098039956148
+ 5.624e-06 1.20075691775656
+ 5.626e-06 1.2008765351351
+ 5.628e-06 1.20112357483349
+ 5.63e-06 1.20090586051418
+ 5.632e-06 1.20060982111264
+ 5.634e-06 1.20052953562002
+ 5.636e-06 1.20036668277723
+ 5.638e-06 1.20050869538924
+ 5.64e-06 1.20084813180368
+ 5.642e-06 1.20082996483633
+ 5.644e-06 1.20095638401135
+ 5.646e-06 1.20081738689746
+ 5.648e-06 1.20089508270823
+ 5.65e-06 1.20083482529409
+ 5.652e-06 1.20085313705011
+ 5.654e-06 1.20085268976583
+ 5.656e-06 1.20071947720498
+ 5.658e-06 1.20082330732027
+ 5.66e-06 1.20070311966004
+ 5.662e-06 1.20095832892821
+ 5.664e-06 1.20089598872761
+ 5.666e-06 1.20066418521775
+ 5.668e-06 1.2007748516
+ 5.67e-06 1.20083441203157
+ 5.672e-06 1.20090957209741
+ 5.674e-06 1.2009168980263
+ 5.676e-06 1.20081964545464
+ 5.678e-06 1.20067070061923
+ 5.68e-06 1.20084652736057
+ 5.682e-06 1.20102197148732
+ 5.684e-06 1.20076766884197
+ 5.686e-06 1.20080946347757
+ 5.688e-06 1.20119560372428
+ 5.69e-06 1.20139974978433
+ 5.692e-06 1.20099455575083
+ 5.694e-06 1.20098323278343
+ 5.696e-06 1.2008889477473
+ 5.698e-06 1.2010716619919
+ 5.7e-06 1.20132040034764
+ 5.702e-06 1.20148910967693
+ 5.704e-06 1.20160763619367
+ 5.706e-06 1.2016545159155
+ 5.708e-06 1.20158500081026
+ 5.71e-06 1.20137994704604
+ 5.712e-06 1.20106885204462
+ 5.714e-06 1.20126833988847
+ 5.716e-06 1.20124452574746
+ 5.718e-06 1.20098126461231
+ 5.72e-06 1.20073151307165
+ 5.722e-06 1.20044199049135
+ 5.724e-06 1.20031374279997
+ 5.726e-06 1.20055440608471
+ 5.728e-06 1.20057487402015
+ 5.73e-06 1.20028322322936
+ 5.732e-06 1.20027779916328
+ 5.734e-06 1.20061372105185
+ 5.736e-06 1.20073922357859
+ 5.738e-06 1.20057117761918
+ 5.74e-06 1.2006684735374
+ 5.742e-06 1.20074338636286
+ 5.744e-06 1.20075312760114
+ 5.746e-06 1.20081939900675
+ 5.748e-06 1.20077997428956
+ 5.75e-06 1.20096027880257
+ 5.752e-06 1.20092471093429
+ 5.754e-06 1.20068200597123
+ 5.756e-06 1.20073067289676
+ 5.758e-06 1.20071476981362
+ 5.76e-06 1.20063251534951
+ 5.762e-06 1.20047195424101
+ 5.764e-06 1.20070840308929
+ 5.766e-06 1.20043081978547
+ 5.768e-06 1.20030801548774
+ 5.77e-06 1.20054501982415
+ 5.772e-06 1.20051654226813
+ 5.774e-06 1.20030405907782
+ 5.776e-06 1.20013725401209
+ 5.778e-06 1.20023228285195
+ 5.78e-06 1.20032461450714
+ 5.782e-06 1.20012063997961
+ 5.784e-06 1.20004463289067
+ 5.786e-06 1.19975652216106
+ 5.788e-06 1.1995184759857
+ 5.79e-06 1.19929501251223
+ 5.792e-06 1.19955814397421
+ 5.794e-06 1.19958759769054
+ 5.796e-06 1.19937739804734
+ 5.798e-06 1.19928378546289
+ 5.8e-06 1.19914196433039
+ 5.802e-06 1.19925589848014
+ 5.804e-06 1.19947301987024
+ 5.806e-06 1.1993224636214
+ 5.808e-06 1.19938681670567
+ 5.81e-06 1.1994530968205
+ 5.812e-06 1.19962914619577
+ 5.814e-06 1.19934928963639
+ 5.816e-06 1.19927265257087
+ 5.818e-06 1.19955789478236
+ 5.82e-06 1.19959637817353
+ 5.822e-06 1.19933133579756
+ 5.824e-06 1.19959649493028
+ 5.826e-06 1.19948341103138
+ 5.828e-06 1.19960349834078
+ 5.83e-06 1.19961480139045
+ 5.832e-06 1.1994589824042
+ 5.834e-06 1.1996150578804
+ 5.836e-06 1.20015076291837
+ 5.838e-06 1.19981420028184
+ 5.84e-06 1.1998495834655
+ 5.842e-06 1.19971422238912
+ 5.844e-06 1.19965169843403
+ 5.846e-06 1.19984366240425
+ 5.848e-06 1.19947127969001
+ 5.85e-06 1.19966163979413
+ 5.852e-06 1.19961133405491
+ 5.854e-06 1.19994932435418
+ 5.856e-06 1.19994009712105
+ 5.858e-06 1.20016004764521
+ 5.86e-06 1.20053762532962
+ 5.862e-06 1.20066891731536
+ 5.864e-06 1.20073134490331
+ 5.866e-06 1.20059374476963
+ 5.868e-06 1.20013728990706
+ 5.87e-06 1.20025320191082
+ 5.872e-06 1.20038674306321
+ 5.874e-06 1.20038052801529
+ 5.876e-06 1.20042543368947
+ 5.878e-06 1.20018025538606
+ 5.88e-06 1.20040338322835
+ 5.882e-06 1.20063916457288
+ 5.884e-06 1.20054444183837
+ 5.886e-06 1.20070081776214
+ 5.888e-06 1.20063271912156
+ 5.89e-06 1.20067955159824
+ 5.892e-06 1.20056296616078
+ 5.894e-06 1.20033682311081
+ 5.896e-06 1.20043117326663
+ 5.898e-06 1.20052509456695
+ 5.9e-06 1.20049926555319
+ 5.902e-06 1.20034192461379
+ 5.904e-06 1.20054111538241
+ 5.906e-06 1.20062019035957
+ 5.908e-06 1.20040824409169
+ 5.91e-06 1.20075497416857
+ 5.912e-06 1.20098871945676
+ 5.914e-06 1.20093426625343
+ 5.916e-06 1.20084497465879
+ 5.918e-06 1.20067812201213
+ 5.92e-06 1.20046466724941
+ 5.922e-06 1.20072442261165
+ 5.924e-06 1.20085678703242
+ 5.926e-06 1.20096246155808
+ 5.928e-06 1.20048031298014
+ 5.93e-06 1.20048839423079
+ 5.932e-06 1.2002936757935
+ 5.934e-06 1.200345626092
+ 5.936e-06 1.20012655995075
+ 5.938e-06 1.19988272261308
+ 5.94e-06 1.19959956837839
+ 5.942e-06 1.19949635759286
+ 5.944e-06 1.1993362804389
+ 5.946e-06 1.19949257504147
+ 5.948e-06 1.19937709954904
+ 5.95e-06 1.19921106256343
+ 5.952e-06 1.19909624888258
+ 5.954e-06 1.19906221349722
+ 5.956e-06 1.19917377643469
+ 5.958e-06 1.19914525053723
+ 5.96e-06 1.19915374057287
+ 5.962e-06 1.1990748358389
+ 5.964e-06 1.19925736064133
+ 5.966e-06 1.19914439617657
+ 5.968e-06 1.19926664984771
+ 5.97e-06 1.19934146699698
+ 5.972e-06 1.19930084205459
+ 5.974e-06 1.1993162482618
+ 5.976e-06 1.19900978010436
+ 5.978e-06 1.19904610101612
+ 5.98e-06 1.19884867549092
+ 5.982e-06 1.19869564520064
+ 5.984e-06 1.19882630352887
+ 5.986e-06 1.19900216163947
+ 5.988e-06 1.19903784404838
+ 5.99e-06 1.19891548420736
+ 5.992e-06 1.19877376707665
+ 5.994e-06 1.19904215858681
+ 5.996e-06 1.19928996628957
+ 5.998e-06 1.19908973446701
+ 6e-06 1.19920840432054
+ 6.002e-06 1.19954396978236
+ 6.004e-06 1.19961462344816
+ 6.006e-06 1.1995342484667
+ 6.008e-06 1.1999405558893
+ 6.01e-06 1.20035447834525
+ 6.012e-06 1.20026345700517
+ 6.014e-06 1.20010701673381
+ 6.016e-06 1.19996699358052
+ 6.018e-06 1.20003768968679
+ 6.02e-06 1.20005114877115
+ 6.022e-06 1.20005334872595
+ 6.024e-06 1.20000849270869
+ 6.026e-06 1.1999423026545
+ 6.028e-06 1.2001694520451
+ 6.03e-06 1.19980016439767
+ 6.032e-06 1.19967130134187
+ 6.034e-06 1.19994467326296
+ 6.036e-06 1.20025554966909
+ 6.038e-06 1.20014100392028
+ 6.04e-06 1.19999258079999
+ 6.042e-06 1.19992409035658
+ 6.044e-06 1.20019172867782
+ 6.046e-06 1.20006491394163
+ 6.048e-06 1.20004504484558
+ 6.05e-06 1.19980639875592
+ 6.052e-06 1.19967542062014
+ 6.054e-06 1.19990707934898
+ 6.056e-06 1.19992727349481
+ 6.058e-06 1.19972282391037
+ 6.06e-06 1.19991769040159
+ 6.062e-06 1.19950175177919
+ 6.064e-06 1.19945601420658
+ 6.066e-06 1.19930225248063
+ 6.068e-06 1.19935555649309
+ 6.07e-06 1.19933260341495
+ 6.072e-06 1.19950020496336
+ 6.074e-06 1.19982719401864
+ 6.076e-06 1.19960627102448
+ 6.078e-06 1.199607622014
+ 6.08e-06 1.19949743767568
+ 6.082e-06 1.19963860148418
+ 6.084e-06 1.19951744520996
+ 6.086e-06 1.19958653641098
+ 6.088e-06 1.19992214997415
+ 6.09e-06 1.19980635306484
+ 6.092e-06 1.20005404830783
+ 6.094e-06 1.19975310058271
+ 6.096e-06 1.19943973379726
+ 6.098e-06 1.19950897689297
+ 6.1e-06 1.19955176647152
+ 6.102e-06 1.19978206647815
+ 6.104e-06 1.19978577107874
+ 6.106e-06 1.20004362751961
+ 6.108e-06 1.20006338783164
+ 6.11e-06 1.19996962033327
+ 6.112e-06 1.20006719420857
+ 6.114e-06 1.20008150722456
+ 6.116e-06 1.20006438214364
+ 6.118e-06 1.20000212495126
+ 6.12e-06 1.19993420547461
+ 6.122e-06 1.19983896883339
+ 6.124e-06 1.19969196241176
+ 6.126e-06 1.19966745467488
+ 6.128e-06 1.19957710639988
+ 6.13e-06 1.19907439984829
+ 6.132e-06 1.19913236076664
+ 6.134e-06 1.19913542272381
+ 6.136e-06 1.19891551776166
+ 6.138e-06 1.19897422594118
+ 6.14e-06 1.19899990282103
+ 6.142e-06 1.19919061998442
+ 6.144e-06 1.19899174697754
+ 6.146e-06 1.19911472422293
+ 6.148e-06 1.19924799113673
+ 6.15e-06 1.19878152583541
+ 6.152e-06 1.19875866375593
+ 6.154e-06 1.19905026498758
+ 6.156e-06 1.19906831980611
+ 6.158e-06 1.19935078473237
+ 6.16e-06 1.19930160582424
+ 6.162e-06 1.19951728305055
+ 6.164e-06 1.19982025278022
+ 6.166e-06 1.19983976813176
+ 6.168e-06 1.19978973669882
+ 6.17e-06 1.19981317092969
+ 6.172e-06 1.19986008586778
+ 6.174e-06 1.19965234490409
+ 6.176e-06 1.19920710141552
+ 6.178e-06 1.19895907281182
+ 6.18e-06 1.1991991620566
+ 6.182e-06 1.19916061368399
+ 6.184e-06 1.19901543236139
+ 6.186e-06 1.19903695834879
+ 6.188e-06 1.19900283778616
+ 6.19e-06 1.19918126761335
+ 6.192e-06 1.1990682574317
+ 6.194e-06 1.19943422206394
+ 6.196e-06 1.19973666580958
+ 6.198e-06 1.19972021532876
+ 6.2e-06 1.19978510830872
+ 6.202e-06 1.19975928692847
+ 6.204e-06 1.2000883477745
+ 6.206e-06 1.20009982987192
+ 6.208e-06 1.20017703315411
+ 6.21e-06 1.20005059158699
+ 6.212e-06 1.19998919820832
+ 6.214e-06 1.19986232722606
+ 6.216e-06 1.19975629693981
+ 6.218e-06 1.19975831160661
+ 6.22e-06 1.19966700634876
+ 6.222e-06 1.19994848826454
+ 6.224e-06 1.19993419529549
+ 6.226e-06 1.19987404955408
+ 6.228e-06 1.19983251669767
+ 6.23e-06 1.19972959699205
+ 6.232e-06 1.19927158343226
+ 6.234e-06 1.19904024746171
+ 6.236e-06 1.19880672211344
+ 6.238e-06 1.19891261128118
+ 6.24e-06 1.19907875355778
+ 6.242e-06 1.19925286181399
+ 6.244e-06 1.19920289608921
+ 6.246e-06 1.19913272821729
+ 6.248e-06 1.19915479894532
+ 6.25e-06 1.19898327036965
+ 6.252e-06 1.19902930485259
+ 6.254e-06 1.19910204872213
+ 6.256e-06 1.19912844935621
+ 6.258e-06 1.19906417611784
+ 6.26e-06 1.19923920938303
+ 6.262e-06 1.19936516501414
+ 6.264e-06 1.19964741018655
+ 6.266e-06 1.20008150327086
+ 6.268e-06 1.19992986692709
+ 6.27e-06 1.1996598777274
+ 6.272e-06 1.19929273888545
+ 6.274e-06 1.19900452939217
+ 6.276e-06 1.19918770026013
+ 6.278e-06 1.19935035516338
+ 6.28e-06 1.19921768361452
+ 6.282e-06 1.19932714707718
+ 6.284e-06 1.19944232787192
+ 6.286e-06 1.19957714755668
+ 6.288e-06 1.19958249982323
+ 6.29e-06 1.19927568081644
+ 6.292e-06 1.19924914196577
+ 6.294e-06 1.19938776825944
+ 6.296e-06 1.19917356780877
+ 6.298e-06 1.19923248237678
+ 6.3e-06 1.19936580414512
+ 6.302e-06 1.19934256676834
+ 6.304e-06 1.19913652655202
+ 6.306e-06 1.19904574739699
+ 6.308e-06 1.1990883661006
+ 6.31e-06 1.19861635304969
+ 6.312e-06 1.19878538770337
+ 6.314e-06 1.19911483093992
+ 6.316e-06 1.19897904167762
+ 6.318e-06 1.19886139271149
+ 6.32e-06 1.198930746277
+ 6.322e-06 1.19895689891395
+ 6.324e-06 1.19907103267463
+ 6.326e-06 1.19877015676012
+ 6.328e-06 1.19875882952097
+ 6.33e-06 1.19924501072714
+ 6.332e-06 1.1991658600644
+ 6.334e-06 1.19905859444063
+ 6.336e-06 1.1989227269914
+ 6.338e-06 1.19917154579204
+ 6.34e-06 1.19937025414638
+ 6.342e-06 1.19911920062602
+ 6.344e-06 1.19912361726391
+ 6.346e-06 1.19908290118863
+ 6.348e-06 1.19911845502572
+ 6.35e-06 1.19869898910627
+ 6.352e-06 1.19843007252133
+ 6.354e-06 1.19892244930852
+ 6.356e-06 1.19885843472872
+ 6.358e-06 1.19859182597808
+ 6.36e-06 1.19869472050715
+ 6.362e-06 1.19874414455716
+ 6.364e-06 1.19834937062909
+ 6.366e-06 1.19844501253341
+ 6.368e-06 1.19846312454909
+ 6.37e-06 1.19855938384022
+ 6.372e-06 1.19875327658574
+ 6.374e-06 1.198918190854
+ 6.376e-06 1.19906297902738
+ 6.378e-06 1.19910219122809
+ 6.38e-06 1.19894780201706
+ 6.382e-06 1.19893853437571
+ 6.384e-06 1.19899315383948
+ 6.386e-06 1.19911663037445
+ 6.388e-06 1.19895919884409
+ 6.39e-06 1.19936698764946
+ 6.392e-06 1.19963790563733
+ 6.394e-06 1.1994872255602
+ 6.396e-06 1.19920641321461
+ 6.398e-06 1.19934980173843
+ 6.4e-06 1.19932638759777
+ 6.402e-06 1.19935493725672
+ 6.404e-06 1.1991455115656
+ 6.406e-06 1.19952495365099
+ 6.408e-06 1.19969729526159
+ 6.41e-06 1.19943911757957
+ 6.412e-06 1.19920012014002
+ 6.414e-06 1.19918049438793
+ 6.416e-06 1.19920390273365
+ 6.418e-06 1.19942672295261
+ 6.42e-06 1.19933385834028
+ 6.422e-06 1.19956523904213
+ 6.424e-06 1.19993685013875
+ 6.426e-06 1.19972286894059
+ 6.428e-06 1.19985234871779
+ 6.43e-06 1.19952530637175
+ 6.432e-06 1.19939435095521
+ 6.434e-06 1.1993765207331
+ 6.436e-06 1.19944581445217
+ 6.438e-06 1.19959517580011
+ 6.44e-06 1.19949516997307
+ 6.442e-06 1.19930535710363
+ 6.444e-06 1.19914253812314
+ 6.446e-06 1.19907574870771
+ 6.448e-06 1.1992418633486
+ 6.45e-06 1.19903402965025
+ 6.452e-06 1.19912943473331
+ 6.454e-06 1.19923581017503
+ 6.456e-06 1.19915324656514
+ 6.458e-06 1.19945842198308
+ 6.46e-06 1.19936050605366
+ 6.462e-06 1.19951077991344
+ 6.464e-06 1.19959406538206
+ 6.466e-06 1.19945057662624
+ 6.468e-06 1.19955866149078
+ 6.47e-06 1.19964898602854
+ 6.472e-06 1.19990397198018
+ 6.474e-06 1.19987696372635
+ 6.476e-06 1.19992811891098
+ 6.478e-06 1.20010587216707
+ 6.48e-06 1.19994841201306
+ 6.482e-06 1.19990386486906
+ 6.484e-06 1.19989385469122
+ 6.486e-06 1.19991278605896
+ 6.488e-06 1.19988225007667
+ 6.49e-06 1.19973759205707
+ 6.492e-06 1.19980968167959
+ 6.494e-06 1.19958938434084
+ 6.496e-06 1.19957273101631
+ 6.498e-06 1.19987330963173
+ 6.5e-06 1.20014645233553
+ 6.502e-06 1.20022860515147
+ 6.504e-06 1.20001120793546
+ 6.506e-06 1.19982703233756
+ 6.508e-06 1.19986670449643
+ 6.51e-06 1.19987170505181
+ 6.512e-06 1.19984071322405
+ 6.514e-06 1.20003257604572
+ 6.516e-06 1.19992464017443
+ 6.518e-06 1.20029488642953
+ 6.52e-06 1.20047071627414
+ 6.522e-06 1.2005052258083
+ 6.524e-06 1.20042785936964
+ 6.526e-06 1.20021445673296
+ 6.528e-06 1.20049996176782
+ 6.53e-06 1.20068460126726
+ 6.532e-06 1.20080375770061
+ 6.534e-06 1.20077311886112
+ 6.536e-06 1.20053987622914
+ 6.538e-06 1.20007560639795
+ 6.54e-06 1.20032399092194
+ 6.542e-06 1.2000356915232
+ 6.544e-06 1.20000251670298
+ 6.546e-06 1.19986277521774
+ 6.548e-06 1.20016767942143
+ 6.55e-06 1.19975255457565
+ 6.552e-06 1.19973953954787
+ 6.554e-06 1.19996033785493
+ 6.556e-06 1.20008680550016
+ 6.558e-06 1.19990249532692
+ 6.56e-06 1.19997604435393
+ 6.562e-06 1.2001216107917
+ 6.564e-06 1.20000779760033
+ 6.566e-06 1.2001641289466
+ 6.568e-06 1.20028788003899
+ 6.57e-06 1.20018521117249
+ 6.572e-06 1.2001840562093
+ 6.574e-06 1.19984966238101
+ 6.576e-06 1.19968754480986
+ 6.578e-06 1.19937064066249
+ 6.58e-06 1.19963366079189
+ 6.582e-06 1.1994578189619
+ 6.584e-06 1.19914145960758
+ 6.586e-06 1.19931676862854
+ 6.588e-06 1.19961547923651
+ 6.59e-06 1.19973917285088
+ 6.592e-06 1.19973978423613
+ 6.594e-06 1.19987743671448
+ 6.596e-06 1.19975166797999
+ 6.598e-06 1.19991426653127
+ 6.6e-06 1.19984453554538
+ 6.602e-06 1.19987060705468
+ 6.604e-06 1.20008445922173
+ 6.606e-06 1.20015743164242
+ 6.608e-06 1.20015672202148
+ 6.61e-06 1.20028899866867
+ 6.612e-06 1.20042228020114
+ 6.614e-06 1.20056261271875
+ 6.616e-06 1.20041178087693
+ 6.618e-06 1.20032945175232
+ 6.62e-06 1.20040562927817
+ 6.622e-06 1.20053560548279
+ 6.624e-06 1.200326282993
+ 6.626e-06 1.20014853113414
+ 6.628e-06 1.20034786783397
+ 6.63e-06 1.20001315598156
+ 6.632e-06 1.20026776838076
+ 6.634e-06 1.20045123977689
+ 6.636e-06 1.20033552182661
+ 6.638e-06 1.20032807718929
+ 6.64e-06 1.20021430032698
+ 6.642e-06 1.19981877668253
+ 6.644e-06 1.1995562948906
+ 6.646e-06 1.19953228138834
+ 6.648e-06 1.19948983481267
+ 6.65e-06 1.19945240976883
+ 6.652e-06 1.19940839392535
+ 6.654e-06 1.19920975023783
+ 6.656e-06 1.19932297454738
+ 6.658e-06 1.19932455007648
+ 6.66e-06 1.19889016252781
+ 6.662e-06 1.19904330731474
+ 6.664e-06 1.19905925632008
+ 6.666e-06 1.1987472448234
+ 6.668e-06 1.19898914604478
+ 6.67e-06 1.198811627147
+ 6.672e-06 1.19864103697694
+ 6.674e-06 1.1989036019225
+ 6.676e-06 1.19914245240786
+ 6.678e-06 1.19932963003688
+ 6.68e-06 1.1992962354806
+ 6.682e-06 1.19978509628199
+ 6.684e-06 1.19960036346978
+ 6.686e-06 1.19983432707633
+ 6.688e-06 1.19961717978535
+ 6.69e-06 1.19957929317679
+ 6.692e-06 1.19989745814005
+ 6.694e-06 1.19983868790659
+ 6.696e-06 1.19978454144322
+ 6.698e-06 1.19944929678544
+ 6.7e-06 1.19941820191582
+ 6.702e-06 1.19939767268255
+ 6.704e-06 1.19915398500567
+ 6.706e-06 1.1992292305266
+ 6.708e-06 1.19925058318903
+ 6.71e-06 1.19929023715615
+ 6.712e-06 1.19927387504137
+ 6.714e-06 1.19944602866352
+ 6.716e-06 1.19917097835191
+ 6.718e-06 1.19894032869532
+ 6.72e-06 1.19919566621593
+ 6.722e-06 1.19942992842432
+ 6.724e-06 1.19946566053906
+ 6.726e-06 1.19957754499398
+ 6.728e-06 1.19956875098399
+ 6.73e-06 1.19967435199584
+ 6.732e-06 1.19981151541963
+ 6.734e-06 1.19990273634346
+ 6.736e-06 1.19967890391973
+ 6.738e-06 1.19938451042197
+ 6.74e-06 1.19928554398432
+ 6.742e-06 1.19943046254024
+ 6.744e-06 1.19923770832378
+ 6.746e-06 1.19953242890582
+ 6.748e-06 1.19946472487113
+ 6.75e-06 1.19968152878054
+ 6.752e-06 1.19976956476027
+ 6.754e-06 1.19987572952956
+ 6.756e-06 1.19990854477219
+ 6.758e-06 1.19986230827843
+ 6.76e-06 1.19954658013294
+ 6.762e-06 1.19951979956894
+ 6.764e-06 1.19935657913297
+ 6.766e-06 1.19931754891781
+ 6.768e-06 1.19938234649488
+ 6.77e-06 1.19916897537808
+ 6.772e-06 1.19896634442083
+ 6.774e-06 1.19935853196967
+ 6.776e-06 1.19925764154776
+ 6.778e-06 1.19896043737401
+ 6.78e-06 1.19888897969261
+ 6.782e-06 1.19878033618329
+ 6.784e-06 1.19877635879606
+ 6.786e-06 1.19866323521304
+ 6.788e-06 1.19869326767838
+ 6.79e-06 1.19835528848474
+ 6.792e-06 1.19859283030497
+ 6.794e-06 1.19893590384147
+ 6.796e-06 1.19915001942848
+ 6.798e-06 1.19896240936053
+ 6.8e-06 1.19921734161705
+ 6.802e-06 1.19912926048616
+ 6.804e-06 1.19904121836351
+ 6.806e-06 1.19906099328596
+ 6.808e-06 1.19893919579013
+ 6.81e-06 1.19888996512626
+ 6.812e-06 1.19913751498844
+ 6.814e-06 1.19940518827797
+ 6.816e-06 1.19906547368601
+ 6.818e-06 1.19907176723751
+ 6.82e-06 1.19912864068323
+ 6.822e-06 1.1991020308658
+ 6.824e-06 1.1992367893865
+ 6.826e-06 1.19955911490602
+ 6.828e-06 1.199561701403
+ 6.83e-06 1.19915618515889
+ 6.832e-06 1.19895993831855
+ 6.834e-06 1.19903022721557
+ 6.836e-06 1.19896380561829
+ 6.838e-06 1.19900333340065
+ 6.84e-06 1.19896430863959
+ 6.842e-06 1.19904232429783
+ 6.844e-06 1.19896545481956
+ 6.846e-06 1.19894795388313
+ 6.848e-06 1.19929932190159
+ 6.85e-06 1.19933341702892
+ 6.852e-06 1.19915900242738
+ 6.854e-06 1.19925569471519
+ 6.856e-06 1.19955738409224
+ 6.858e-06 1.19942368806343
+ 6.86e-06 1.19954881190234
+ 6.862e-06 1.19948566711268
+ 6.864e-06 1.19967059246229
+ 6.866e-06 1.19971337357692
+ 6.868e-06 1.19952099585788
+ 6.87e-06 1.19969541926723
+ 6.872e-06 1.19954121113378
+ 6.874e-06 1.19939610989776
+ 6.876e-06 1.19937481013342
+ 6.878e-06 1.19940818164585
+ 6.88e-06 1.1992977731771
+ 6.882e-06 1.19977777210265
+ 6.884e-06 1.19965815905602
+ 6.886e-06 1.19954253580499
+ 6.888e-06 1.19971904118543
+ 6.89e-06 1.19995677908695
+ 6.892e-06 1.19987858411421
+ 6.894e-06 1.19990776951984
+ 6.896e-06 1.19975227712076
+ 6.898e-06 1.19972616694608
+ 6.9e-06 1.19989183865967
+ 6.902e-06 1.19983420156256
+ 6.904e-06 1.19944707678755
+ 6.906e-06 1.19968210279397
+ 6.908e-06 1.19957686249654
+ 6.91e-06 1.19955669646152
+ 6.912e-06 1.20005396730112
+ 6.914e-06 1.20042015447708
+ 6.916e-06 1.20045521571487
+ 6.918e-06 1.20059384105252
+ 6.92e-06 1.20062094437093
+ 6.922e-06 1.20053388147953
+ 6.924e-06 1.2006628536508
+ 6.926e-06 1.20094721198385
+ 6.928e-06 1.20099956570494
+ 6.93e-06 1.20094202172479
+ 6.932e-06 1.20087638178943
+ 6.934e-06 1.20082915605998
+ 6.936e-06 1.20057609235911
+ 6.938e-06 1.20060364372891
+ 6.94e-06 1.20061793867298
+ 6.942e-06 1.20057413261292
+ 6.944e-06 1.20035032766313
+ 6.946e-06 1.20035360943839
+ 6.948e-06 1.20015013850732
+ 6.95e-06 1.2004715373545
+ 6.952e-06 1.20043881923043
+ 6.954e-06 1.20055474239438
+ 6.956e-06 1.20030574466399
+ 6.958e-06 1.20032799495083
+ 6.96e-06 1.20021156307999
+ 6.962e-06 1.20019368543638
+ 6.964e-06 1.20053298283222
+ 6.966e-06 1.20087360844418
+ 6.968e-06 1.2009062082617
+ 6.97e-06 1.20080944632245
+ 6.972e-06 1.20098219833836
+ 6.974e-06 1.2010877418271
+ 6.976e-06 1.20111274656924
+ 6.978e-06 1.20135727990285
+ 6.98e-06 1.20136187645602
+ 6.982e-06 1.20145617723255
+ 6.984e-06 1.20174063321618
+ 6.986e-06 1.20151417647668
+ 6.988e-06 1.20170880800271
+ 6.99e-06 1.2014220534091
+ 6.992e-06 1.20139800610855
+ 6.994e-06 1.2014483670582
+ 6.996e-06 1.20114814816624
+ 6.998e-06 1.201195864723
+ 7e-06 1.2011005409161
+ 7.002e-06 1.20089890206045
+ 7.004e-06 1.20077818697182
+ 7.006e-06 1.20048782643685
+ 7.008e-06 1.2002038037451
+ 7.01e-06 1.20014624957125
+ 7.012e-06 1.20036484080143
+ 7.014e-06 1.20019407382464
+ 7.016e-06 1.20003532970944
+ 7.018e-06 1.20020639483751
+ 7.02e-06 1.19997823946365
+ 7.022e-06 1.20010306336533
+ 7.024e-06 1.20016025863364
+ 7.026e-06 1.20034652629458
+ 7.028e-06 1.20039991055798
+ 7.03e-06 1.20048800761937
+ 7.032e-06 1.20025165274661
+ 7.034e-06 1.19997439072721
+ 7.036e-06 1.19981907503804
+ 7.038e-06 1.199831803901
+ 7.04e-06 1.20017584179924
+ 7.042e-06 1.20022028321628
+ 7.044e-06 1.200171847455
+ 7.046e-06 1.20009802429206
+ 7.048e-06 1.20028076198997
+ 7.05e-06 1.20040859478348
+ 7.052e-06 1.20067797708297
+ 7.054e-06 1.20053144249392
+ 7.056e-06 1.20063213838542
+ 7.058e-06 1.20056798682256
+ 7.06e-06 1.20013461205526
+ 7.062e-06 1.19991128597715
+ 7.064e-06 1.19979053964431
+ 7.066e-06 1.19951255621789
+ 7.068e-06 1.19928141625891
+ 7.07e-06 1.19920525722587
+ 7.072e-06 1.19912327874327
+ 7.074e-06 1.19898545149434
+ 7.076e-06 1.19883911629243
+ 7.078e-06 1.19852636420457
+ 7.08e-06 1.19838770156321
+ 7.082e-06 1.19804643861899
+ 7.084e-06 1.19808751297084
+ 7.086e-06 1.19787905084785
+ 7.088e-06 1.19815425692746
+ 7.09e-06 1.19801099069619
+ 7.092e-06 1.19824586266847
+ 7.094e-06 1.1985465768666
+ 7.096e-06 1.1985603404608
+ 7.098e-06 1.1984076412012
+ 7.1e-06 1.19863213478804
+ 7.102e-06 1.19852703176759
+ 7.104e-06 1.1981864015967
+ 7.106e-06 1.19813858820441
+ 7.108e-06 1.19832057236787
+ 7.11e-06 1.19857498927915
+ 7.112e-06 1.19869715943779
+ 7.114e-06 1.19898378620203
+ 7.116e-06 1.19893292479585
+ 7.118e-06 1.19872616218289
+ 7.12e-06 1.19862421929857
+ 7.122e-06 1.19866274950493
+ 7.124e-06 1.19867678734633
+ 7.126e-06 1.19869507066041
+ 7.128e-06 1.19858197925099
+ 7.13e-06 1.19846143308339
+ 7.132e-06 1.19845803604684
+ 7.134e-06 1.19877222534078
+ 7.136e-06 1.19908591353982
+ 7.138e-06 1.19930351471369
+ 7.14e-06 1.19913127733402
+ 7.142e-06 1.19930529598617
+ 7.144e-06 1.19930054489306
+ 7.146e-06 1.19953242776914
+ 7.148e-06 1.19928372921634
+ 7.15e-06 1.1993617294682
+ 7.152e-06 1.19914770892315
+ 7.154e-06 1.19925828884562
+ 7.156e-06 1.19951371815576
+ 7.158e-06 1.19958063713301
+ 7.16e-06 1.19955490038644
+ 7.162e-06 1.19928319691805
+ 7.164e-06 1.19953802329468
+ 7.166e-06 1.19935971748065
+ 7.168e-06 1.19935005767625
+ 7.17e-06 1.19948257512032
+ 7.172e-06 1.19956795770368
+ 7.174e-06 1.19905102124567
+ 7.176e-06 1.1989493323888
+ 7.178e-06 1.19896808209098
+ 7.18e-06 1.19931737400494
+ 7.182e-06 1.19908698640485
+ 7.184e-06 1.19944506086337
+ 7.186e-06 1.19921909866138
+ 7.188e-06 1.19953034054394
+ 7.19e-06 1.19957962623973
+ 7.192e-06 1.20000026809708
+ 7.194e-06 1.19968089773569
+ 7.196e-06 1.19992967281481
+ 7.198e-06 1.19974019198129
+ 7.2e-06 1.19968057996687
+ 7.202e-06 1.19963570145073
+ 7.204e-06 1.19977121086332
+ 7.206e-06 1.19964583316678
+ 7.208e-06 1.19987995291663
+ 7.21e-06 1.19954282855735
+ 7.212e-06 1.19935974956741
+ 7.214e-06 1.19934760418056
+ 7.216e-06 1.19941192973873
+ 7.218e-06 1.19975556989586
+ 7.22e-06 1.1994513281678
+ 7.222e-06 1.19924534591277
+ 7.224e-06 1.19945692477178
+ 7.226e-06 1.19961888517104
+ 7.228e-06 1.19995329460646
+ 7.23e-06 1.20035690395463
+ 7.232e-06 1.20048858576715
+ 7.234e-06 1.20063062375545
+ 7.236e-06 1.20039559306588
+ 7.238e-06 1.20047196595834
+ 7.24e-06 1.20052965457434
+ 7.242e-06 1.20038463587153
+ 7.244e-06 1.2005661153558
+ 7.246e-06 1.20078714880034
+ 7.248e-06 1.20064252320703
+ 7.25e-06 1.20047213304251
+ 7.252e-06 1.20036437966302
+ 7.254e-06 1.20027228840164
+ 7.256e-06 1.20047024992711
+ 7.258e-06 1.20051717778905
+ 7.26e-06 1.20070335626999
+ 7.262e-06 1.20091900598097
+ 7.264e-06 1.20080476688289
+ 7.266e-06 1.20089298297864
+ 7.268e-06 1.20083729050369
+ 7.27e-06 1.20078623896832
+ 7.272e-06 1.20044483634219
+ 7.274e-06 1.20060604175323
+ 7.276e-06 1.2005599467083
+ 7.278e-06 1.20062493791636
+ 7.28e-06 1.20058489386184
+ 7.282e-06 1.20042495343145
+ 7.284e-06 1.20040091287661
+ 7.286e-06 1.20035452461568
+ 7.288e-06 1.20034448290217
+ 7.29e-06 1.20041690116356
+ 7.292e-06 1.200154475272
+ 7.294e-06 1.19980488279998
+ 7.296e-06 1.20001374593192
+ 7.298e-06 1.20016934693987
+ 7.3e-06 1.2003418743935
+ 7.302e-06 1.20060435139135
+ 7.304e-06 1.20058736379569
+ 7.306e-06 1.20067236911774
+ 7.308e-06 1.20067974814775
+ 7.31e-06 1.20048568853752
+ 7.312e-06 1.20031224923088
+ 7.314e-06 1.20026015865934
+ 7.316e-06 1.20031440599827
+ 7.318e-06 1.20036237633047
+ 7.32e-06 1.20023366916903
+ 7.322e-06 1.20013212222511
+ 7.324e-06 1.2002037684118
+ 7.326e-06 1.2001677404683
+ 7.328e-06 1.20024349022261
+ 7.33e-06 1.20041914431316
+ 7.332e-06 1.20055622457566
+ 7.334e-06 1.20027638968646
+ 7.336e-06 1.20054934606088
+ 7.338e-06 1.20048028280105
+ 7.34e-06 1.20035856692538
+ 7.342e-06 1.20004662576344
+ 7.344e-06 1.19996786112651
+ 7.346e-06 1.20014663569663
+ 7.348e-06 1.20015039264557
+ 7.35e-06 1.1998454492513
+ 7.352e-06 1.1998158287943
+ 7.354e-06 1.1994258079275
+ 7.356e-06 1.19948137416539
+ 7.358e-06 1.19917933472367
+ 7.36e-06 1.19908979557614
+ 7.362e-06 1.1989920188426
+ 7.364e-06 1.198974682257
+ 7.366e-06 1.19867770268396
+ 7.368e-06 1.19868124053077
+ 7.37e-06 1.19852851269013
+ 7.372e-06 1.19847731511853
+ 7.374e-06 1.19855043860037
+ 7.376e-06 1.19835793849044
+ 7.378e-06 1.19845815902641
+ 7.38e-06 1.19862773708811
+ 7.382e-06 1.19865413240398
+ 7.384e-06 1.19858136777316
+ 7.386e-06 1.19813002093202
+ 7.388e-06 1.19820686657782
+ 7.39e-06 1.19825505787877
+ 7.392e-06 1.19830367720699
+ 7.394e-06 1.19834859319516
+ 7.396e-06 1.19830300368933
+ 7.398e-06 1.1983336047645
+ 7.4e-06 1.19841791646597
+ 7.402e-06 1.19854971398237
+ 7.404e-06 1.19837182065947
+ 7.406e-06 1.19876676728213
+ 7.408e-06 1.19919318808052
+ 7.41e-06 1.19905467651762
+ 7.412e-06 1.19913523704826
+ 7.414e-06 1.19928370331475
+ 7.416e-06 1.19936300010448
+ 7.418e-06 1.19915546901156
+ 7.42e-06 1.19907241504759
+ 7.422e-06 1.19934657225914
+ 7.424e-06 1.19927420946306
+ 7.426e-06 1.19911510507397
+ 7.428e-06 1.19935924746842
+ 7.43e-06 1.19962155847389
+ 7.432e-06 1.19923435810758
+ 7.434e-06 1.1994478218062
+ 7.436e-06 1.19919738468598
+ 7.438e-06 1.1991705933369
+ 7.44e-06 1.19887791086799
+ 7.442e-06 1.19848195895024
+ 7.444e-06 1.19839690271425
+ 7.446e-06 1.19839925138325
+ 7.448e-06 1.19861730658982
+ 7.45e-06 1.19858657032863
+ 7.452e-06 1.19848017905753
+ 7.454e-06 1.19853930802196
+ 7.456e-06 1.19869891195023
+ 7.458e-06 1.19870515786885
+ 7.46e-06 1.19882334366886
+ 7.462e-06 1.19878774835123
+ 7.464e-06 1.19854934211853
+ 7.466e-06 1.19880012942705
+ 7.468e-06 1.19903765364257
+ 7.47e-06 1.19890859721754
+ 7.472e-06 1.19873769156322
+ 7.474e-06 1.19923778709699
+ 7.476e-06 1.19899145485957
+ 7.478e-06 1.19898777773242
+ 7.48e-06 1.1989610299249
+ 7.482e-06 1.19913927404031
+ 7.484e-06 1.1989556489497
+ 7.486e-06 1.19904430330438
+ 7.488e-06 1.19890723364568
+ 7.49e-06 1.19908512111133
+ 7.492e-06 1.19901776468549
+ 7.494e-06 1.19888025481111
+ 7.496e-06 1.19874131442528
+ 7.498e-06 1.19887550016561
+ 7.5e-06 1.19874251698835
+ 7.502e-06 1.19870512695333
+ 7.504e-06 1.1986962381624
+ 7.506e-06 1.19869417271979
+ 7.508e-06 1.19885616146777
+ 7.51e-06 1.19902830856965
+ 7.512e-06 1.19920856898964
+ 7.514e-06 1.19919041885911
+ 7.516e-06 1.1994039807985
+ 7.518e-06 1.19944083125838
+ 7.52e-06 1.19911101765804
+ 7.522e-06 1.19893279357131
+ 7.524e-06 1.19871860295616
+ 7.526e-06 1.19841516586501
+ 7.528e-06 1.19854118198593
+ 7.53e-06 1.19850369040797
+ 7.532e-06 1.19875886286408
+ 7.534e-06 1.19878733710301
+ 7.536e-06 1.1987439437164
+ 7.538e-06 1.1988944076838
+ 7.54e-06 1.1991348669616
+ 7.542e-06 1.19895163964711
+ 7.544e-06 1.19891926575049
+ 7.546e-06 1.19893816599016
+ 7.548e-06 1.19927965534326
+ 7.55e-06 1.19927705779889
+ 7.552e-06 1.19920245997097
+ 7.554e-06 1.19912158493503
+ 7.556e-06 1.19914079665514
+ 7.558e-06 1.19914293082743
+ 7.56e-06 1.19891125571196
+ 7.562e-06 1.19911644478642
+ 7.564e-06 1.19924304008165
+ 7.566e-06 1.19879328833385
+ 7.568e-06 1.19900695789115
+ 7.57e-06 1.19930655771893
+ 7.572e-06 1.1995868558265
+ 7.574e-06 1.19929911266316
+ 7.576e-06 1.19917850653338
+ 7.578e-06 1.19946410708885
+ 7.58e-06 1.19940627169597
+ 7.582e-06 1.19922102285948
+ 7.584e-06 1.19962069684278
+ 7.586e-06 1.19965891097082
+ 7.588e-06 1.19969786451134
+ 7.59e-06 1.19970723912851
+ 7.592e-06 1.19985206935937
+ 7.594e-06 1.19959279450577
+ 7.596e-06 1.19996072364888
+ 7.598e-06 1.19999349348313
+ 7.6e-06 1.19988907892
+ 7.602e-06 1.1999573060775
+ 7.604e-06 1.20014341654517
+ 7.606e-06 1.20011898995956
+ 7.608e-06 1.20013749111118
+ 7.61e-06 1.19995570415722
+ 7.612e-06 1.19978633302207
+ 7.614e-06 1.19961997495994
+ 7.616e-06 1.19936769992459
+ 7.618e-06 1.19938052574799
+ 7.62e-06 1.19936081957861
+ 7.622e-06 1.19956137213259
+ 7.624e-06 1.19954721172988
+ 7.626e-06 1.19983629582511
+ 7.628e-06 1.19980625954214
+ 7.63e-06 1.1996139519125
+ 7.632e-06 1.20000214026779
+ 7.634e-06 1.19991302203559
+ 7.636e-06 1.19996561705073
+ 7.638e-06 1.20018316225977
+ 7.64e-06 1.200446928858
+ 7.642e-06 1.20031463285902
+ 7.644e-06 1.20043790523072
+ 7.646e-06 1.20044162077912
+ 7.648e-06 1.20051839545639
+ 7.65e-06 1.20049334190103
+ 7.652e-06 1.2005200341607
+ 7.654e-06 1.20089401350867
+ 7.656e-06 1.20081508889071
+ 7.658e-06 1.20094204734047
+ 7.66e-06 1.20099996675852
+ 7.662e-06 1.20098216654042
+ 7.664e-06 1.2012424774189
+ 7.666e-06 1.20125421476414
+ 7.668e-06 1.20105037802497
+ 7.67e-06 1.20099409201016
+ 7.672e-06 1.20099032238429
+ 7.674e-06 1.20122480754554
+ 7.676e-06 1.20133522139689
+ 7.678e-06 1.20139812878014
+ 7.68e-06 1.20120924302043
+ 7.682e-06 1.20126176479031
+ 7.684e-06 1.20123472609709
+ 7.686e-06 1.20127377030968
+ 7.688e-06 1.20148745641612
+ 7.69e-06 1.20171343292464
+ 7.692e-06 1.20177063395759
+ 7.694e-06 1.20178775917234
+ 7.696e-06 1.2020685445559
+ 7.698e-06 1.20172479053775
+ 7.7e-06 1.20193317997104
+ 7.702e-06 1.20185650689811
+ 7.704e-06 1.20161978565298
+ 7.706e-06 1.20166215956824
+ 7.708e-06 1.20163538582533
+ 7.71e-06 1.20145726504569
+ 7.712e-06 1.20161787495248
+ 7.714e-06 1.20135069653802
+ 7.716e-06 1.20108018509867
+ 7.718e-06 1.20080532267737
+ 7.72e-06 1.20057983947079
+ 7.722e-06 1.2001823797634
+ 7.724e-06 1.20019919284927
+ 7.726e-06 1.20000989392554
+ 7.728e-06 1.20000515133342
+ 7.73e-06 1.20037024018277
+ 7.732e-06 1.20017898937273
+ 7.734e-06 1.19997994692362
+ 7.736e-06 1.20022840337655
+ 7.738e-06 1.20047958754724
+ 7.74e-06 1.20065696062957
+ 7.742e-06 1.20059272390539
+ 7.744e-06 1.20030555418735
+ 7.746e-06 1.20029646511942
+ 7.748e-06 1.20036562365403
+ 7.75e-06 1.20047406660527
+ 7.752e-06 1.20029869322776
+ 7.754e-06 1.20048395149875
+ 7.756e-06 1.20070083875195
+ 7.758e-06 1.20097973436135
+ 7.76e-06 1.20100311158536
+ 7.762e-06 1.20087558798297
+ 7.764e-06 1.2010418338076
+ 7.766e-06 1.20051477086105
+ 7.768e-06 1.20083236743044
+ 7.77e-06 1.20082391631244
+ 7.772e-06 1.20083098931699
+ 7.774e-06 1.20087141488695
+ 7.776e-06 1.2011106300898
+ 7.778e-06 1.20093247319095
+ 7.78e-06 1.20079372032981
+ 7.782e-06 1.20105895267489
+ 7.784e-06 1.20113110523185
+ 7.786e-06 1.20096797236494
+ 7.788e-06 1.20089602552753
+ 7.79e-06 1.20096628042169
+ 7.792e-06 1.20062958628654
+ 7.794e-06 1.20068006769699
+ 7.796e-06 1.2008178078727
+ 7.798e-06 1.20102080295498
+ 7.8e-06 1.20090587234919
+ 7.802e-06 1.20078584274547
+ 7.804e-06 1.20092931339166
+ 7.806e-06 1.20057641751674
+ 7.808e-06 1.20069925711601
+ 7.81e-06 1.20081330641917
+ 7.812e-06 1.20114642899722
+ 7.814e-06 1.20119518724577
+ 7.816e-06 1.20122260303092
+ 7.818e-06 1.20105030979139
+ 7.82e-06 1.20144234533439
+ 7.822e-06 1.20145710632621
+ 7.824e-06 1.20140124779595
+ 7.826e-06 1.20139738503685
+ 7.828e-06 1.20147227170658
+ 7.83e-06 1.20126677417501
+ 7.832e-06 1.20111419378252
+ 7.834e-06 1.2009919009648
+ 7.836e-06 1.20100539434284
+ 7.838e-06 1.2009004808902
+ 7.84e-06 1.2008701404556
+ 7.842e-06 1.20083116161728
+ 7.844e-06 1.20073327299237
+ 7.846e-06 1.20057590324102
+ 7.848e-06 1.20010316033068
+ 7.85e-06 1.20017385383294
+ 7.852e-06 1.20029202587976
+ 7.854e-06 1.20055812517811
+ 7.856e-06 1.2004609768016
+ 7.858e-06 1.20028179191025
+ 7.86e-06 1.20029427646688
+ 7.862e-06 1.20013673930835
+ 7.864e-06 1.20008953610362
+ 7.866e-06 1.20007335636229
+ 7.868e-06 1.20030211447068
+ 7.87e-06 1.20023083953113
+ 7.872e-06 1.19991772232954
+ 7.874e-06 1.19999143563318
+ 7.876e-06 1.20045272044465
+ 7.878e-06 1.20065910645686
+ 7.88e-06 1.20033105884101
+ 7.882e-06 1.20021831368019
+ 7.884e-06 1.20052144573992
+ 7.886e-06 1.20076056769598
+ 7.888e-06 1.20084548258647
+ 7.89e-06 1.20094395340318
+ 7.892e-06 1.20107534146317
+ 7.894e-06 1.20082745196297
+ 7.896e-06 1.20080597134628
+ 7.898e-06 1.20096391911477
+ 7.9e-06 1.20078649583807
+ 7.902e-06 1.20053138145619
+ 7.904e-06 1.20081276722927
+ 7.906e-06 1.2006978395501
+ 7.908e-06 1.2005822013597
+ 7.91e-06 1.20060938638403
+ 7.912e-06 1.20063976699931
+ 7.914e-06 1.20068674087898
+ 7.916e-06 1.20094298029645
+ 7.918e-06 1.20098229060621
+ 7.92e-06 1.20136775741918
+ 7.922e-06 1.20130254142975
+ 7.924e-06 1.20160340417581
+ 7.926e-06 1.20172138468441
+ 7.928e-06 1.20181821366845
+ 7.93e-06 1.20171083788015
+ 7.932e-06 1.20192808171475
+ 7.934e-06 1.20173271164525
+ 7.936e-06 1.2013275734503
+ 7.938e-06 1.20157110310011
+ 7.94e-06 1.20173796755749
+ 7.942e-06 1.20139621590839
+ 7.944e-06 1.20160871058516
+ 7.946e-06 1.20138478507657
+ 7.948e-06 1.20134298670735
+ 7.95e-06 1.201551841708
+ 7.952e-06 1.20181420756798
+ 7.954e-06 1.20143915571369
+ 7.956e-06 1.20138734623986
+ 7.958e-06 1.20134839881025
+ 7.96e-06 1.20115214165051
+ 7.962e-06 1.20096167878916
+ 7.964e-06 1.20097083140213
+ 7.966e-06 1.20096822004799
+ 7.968e-06 1.20113452695251
+ 7.97e-06 1.20097603612192
+ 7.972e-06 1.20072736257801
+ 7.974e-06 1.20077896584217
+ 7.976e-06 1.20066193552852
+ 7.978e-06 1.20073976994321
+ 7.98e-06 1.20067467037243
+ 7.982e-06 1.20056573416013
+ 7.984e-06 1.20039930537194
+ 7.986e-06 1.20013808060045
+ 7.988e-06 1.19996803077541
+ 7.99e-06 1.19961685702296
+ 7.992e-06 1.19945763268097
+ 7.994e-06 1.19947774001182
+ 7.996e-06 1.199290484356
+ 7.998e-06 1.19917114928944
+ 8e-06 1.19943193249209
+ 8.002e-06 1.19942785818748
+ 8.004e-06 1.19952564810764
+ 8.006e-06 1.19958588062075
+ 8.008e-06 1.19956312567545
+ 8.01e-06 1.19963272544518
+ 8.012e-06 1.19963020876551
+ 8.014e-06 1.19955571379872
+ 8.016e-06 1.19973881109326
+ 8.018e-06 1.19959118098654
+ 8.02e-06 1.19951593343384
+ 8.022e-06 1.1995126365933
+ 8.024e-06 1.19980996570039
+ 8.026e-06 1.19984724606687
+ 8.028e-06 1.19969142854666
+ 8.03e-06 1.19924736182315
+ 8.032e-06 1.19945625352574
+ 8.034e-06 1.1994771263774
+ 8.036e-06 1.19911086682705
+ 8.038e-06 1.19898088824504
+ 8.04e-06 1.19911597443625
+ 8.042e-06 1.19918785640337
+ 8.044e-06 1.19907238087874
+ 8.046e-06 1.19934589352383
+ 8.048e-06 1.20008146372436
+ 8.05e-06 1.20062995722908
+ 8.052e-06 1.20087938489835
+ 8.054e-06 1.20099242451155
+ 8.056e-06 1.20153748889936
+ 8.058e-06 1.20148567541949
+ 8.06e-06 1.2013795864763
+ 8.062e-06 1.2014373447916
+ 8.064e-06 1.20121485703079
+ 8.066e-06 1.20119211760649
+ 8.068e-06 1.20104092427191
+ 8.07e-06 1.20108856625795
+ 8.072e-06 1.20116839773134
+ 8.074e-06 1.20090770289664
+ 8.076e-06 1.20072154508225
+ 8.078e-06 1.20063772599447
+ 8.08e-06 1.20118659274503
+ 8.082e-06 1.20103919648019
+ 8.084e-06 1.20124560980923
+ 8.086e-06 1.20148023384662
+ 8.088e-06 1.20120150979179
+ 8.09e-06 1.20131959859503
+ 8.092e-06 1.2011074973679
+ 8.094e-06 1.20093031229129
+ 8.096e-06 1.20126081386703
+ 8.098e-06 1.20174491689484
+ 8.1e-06 1.20191857312703
+ 8.102e-06 1.20192644139009
+ 8.104e-06 1.2017144596572
+ 8.106e-06 1.20182147135938
+ 8.108e-06 1.20153506931371
+ 8.11e-06 1.20147290011651
+ 8.112e-06 1.20176588525551
+ 8.114e-06 1.20172914591686
+ 8.116e-06 1.20143498449589
+ 8.118e-06 1.20112359265686
+ 8.12e-06 1.20105787750372
+ 8.122e-06 1.20117775094148
+ 8.124e-06 1.20116242659918
+ 8.126e-06 1.20127917404556
+ 8.128e-06 1.20120381378851
+ 8.13e-06 1.20108762696772
+ 8.132e-06 1.20084778935679
+ 8.134e-06 1.2008375517967
+ 8.136e-06 1.2008802119177
+ 8.138e-06 1.2010364449732
+ 8.14e-06 1.20077650338484
+ 8.142e-06 1.20111270246982
+ 8.144e-06 1.20096835803761
+ 8.146e-06 1.20104771051835
+ 8.148e-06 1.20075004256282
+ 8.15e-06 1.20071442397368
+ 8.152e-06 1.20060922522053
+ 8.154e-06 1.20084889291754
+ 8.156e-06 1.20079072212536
+ 8.158e-06 1.20081822521455
+ 8.16e-06 1.20081689447138
+ 8.162e-06 1.20077427177827
+ 8.164e-06 1.20082659279151
+ 8.166e-06 1.20096578558847
+ 8.168e-06 1.20086596709848
+ 8.17e-06 1.20037523817152
+ 8.172e-06 1.20036517474958
+ 8.174e-06 1.20021677167878
+ 8.176e-06 1.20034096188894
+ 8.178e-06 1.20072205163634
+ 8.18e-06 1.20052621204794
+ 8.182e-06 1.200591938961
+ 8.184e-06 1.20077126218613
+ 8.186e-06 1.20103618668959
+ 8.188e-06 1.20088697955228
+ 8.19e-06 1.20134553137668
+ 8.192e-06 1.20101525088818
+ 8.194e-06 1.20102254569951
+ 8.196e-06 1.20081830740563
+ 8.198e-06 1.20073497810585
+ 8.2e-06 1.20061790332822
+ 8.202e-06 1.20073655818704
+ 8.204e-06 1.20096322760855
+ 8.206e-06 1.20092333955674
+ 8.208e-06 1.20059154744188
+ 8.21e-06 1.20079794445431
+ 8.212e-06 1.20080229291284
+ 8.214e-06 1.20094187505153
+ 8.216e-06 1.20071817162597
+ 8.218e-06 1.2005197422209
+ 8.22e-06 1.20093859983761
+ 8.222e-06 1.2010377950905
+ 8.224e-06 1.20099235657162
+ 8.226e-06 1.20102712347098
+ 8.228e-06 1.20094143640868
+ 8.23e-06 1.20091912873638
+ 8.232e-06 1.20096870232615
+ 8.234e-06 1.20122524441533
+ 8.236e-06 1.20133016394297
+ 8.238e-06 1.20144200934913
+ 8.24e-06 1.20148587309502
+ 8.242e-06 1.2013869997779
+ 8.244e-06 1.20101491038645
+ 8.246e-06 1.20121189842535
+ 8.248e-06 1.20165154774175
+ 8.25e-06 1.20142327204227
+ 8.252e-06 1.20152258569146
+ 8.254e-06 1.20157894076746
+ 8.256e-06 1.20147321172834
+ 8.258e-06 1.20166677968966
+ 8.26e-06 1.20154159561078
+ 8.262e-06 1.20151461675913
+ 8.264e-06 1.20143239902117
+ 8.266e-06 1.20138583208496
+ 8.268e-06 1.20154171530767
+ 8.27e-06 1.20127703779959
+ 8.272e-06 1.20092953706116
+ 8.274e-06 1.20057117330775
+ 8.276e-06 1.20061639453559
+ 8.278e-06 1.20057163589726
+ 8.28e-06 1.20054837723556
+ 8.282e-06 1.20017900641489
+ 8.284e-06 1.20025880360929
+ 8.286e-06 1.20049911674671
+ 8.288e-06 1.2007906849783
+ 8.29e-06 1.20092586566292
+ 8.292e-06 1.20072250218163
+ 8.294e-06 1.20084302852017
+ 8.296e-06 1.20049664585304
+ 8.298e-06 1.20068371105332
+ 8.3e-06 1.20068397292189
+ 8.302e-06 1.20049879097588
+ 8.304e-06 1.20028737630272
+ 8.306e-06 1.20042196484428
+ 8.308e-06 1.20002648090093
+ 8.31e-06 1.20021438356694
+ 8.312e-06 1.20021087445033
+ 8.314e-06 1.20022783592261
+ 8.316e-06 1.19980128876178
+ 8.318e-06 1.19971798011043
+ 8.32e-06 1.20013750724605
+ 8.322e-06 1.20001517363959
+ 8.324e-06 1.20014328174963
+ 8.326e-06 1.19991576053479
+ 8.328e-06 1.20015907261866
+ 8.33e-06 1.20020379848746
+ 8.332e-06 1.20051836562688
+ 8.334e-06 1.20052108577493
+ 8.336e-06 1.20040736278244
+ 8.338e-06 1.20064260319523
+ 8.34e-06 1.20089716616118
+ 8.342e-06 1.20104363803782
+ 8.344e-06 1.20099235777942
+ 8.346e-06 1.20089780520482
+ 8.348e-06 1.20110033770573
+ 8.35e-06 1.20085374629873
+ 8.352e-06 1.2007196143481
+ 8.354e-06 1.20064140614383
+ 8.356e-06 1.20061018125892
+ 8.358e-06 1.20087590890649
+ 8.36e-06 1.20080776289982
+ 8.362e-06 1.20071882651819
+ 8.364e-06 1.20098925307077
+ 8.366e-06 1.20084441394555
+ 8.368e-06 1.20113507285405
+ 8.37e-06 1.20106383096738
+ 8.372e-06 1.20074830443316
+ 8.374e-06 1.20051819738509
+ 8.376e-06 1.20007279226084
+ 8.378e-06 1.20005708869131
+ 8.38e-06 1.19973794023869
+ 8.382e-06 1.19988099598379
+ 8.384e-06 1.20014415162301
+ 8.386e-06 1.20016366168812
+ 8.388e-06 1.20055472032277
+ 8.39e-06 1.20084880797039
+ 8.392e-06 1.20063802674787
+ 8.394e-06 1.20064339658747
+ 8.396e-06 1.20042793160681
+ 8.398e-06 1.20024334960792
+ 8.4e-06 1.20014981681775
+ 8.402e-06 1.20045434813788
+ 8.404e-06 1.20056855646605
+ 8.406e-06 1.20062592530935
+ 8.408e-06 1.20058001488992
+ 8.41e-06 1.20107506489544
+ 8.412e-06 1.20087750092153
+ 8.414e-06 1.20077785293614
+ 8.416e-06 1.20050484701701
+ 8.418e-06 1.20040846729738
+ 8.42e-06 1.20028676336283
+ 8.422e-06 1.20037116357118
+ 8.424e-06 1.20067035424139
+ 8.426e-06 1.20071685365357
+ 8.428e-06 1.20058566650622
+ 8.43e-06 1.20069657276743
+ 8.432e-06 1.20115235243154
+ 8.434e-06 1.20110852754614
+ 8.436e-06 1.20070075455592
+ 8.438e-06 1.20068240178864
+ 8.44e-06 1.20032595398949
+ 8.442e-06 1.20035498960206
+ 8.444e-06 1.20005963243276
+ 8.446e-06 1.19989920089293
+ 8.448e-06 1.19981426889859
+ 8.45e-06 1.19970352098321
+ 8.452e-06 1.19976621548113
+ 8.454e-06 1.19953487088332
+ 8.456e-06 1.19903989067356
+ 8.458e-06 1.19930187525499
+ 8.46e-06 1.19916852837927
+ 8.462e-06 1.1994739137943
+ 8.464e-06 1.19950260348593
+ 8.466e-06 1.19944238047059
+ 8.468e-06 1.19974204458471
+ 8.47e-06 1.19978163766423
+ 8.472e-06 1.19994678591479
+ 8.474e-06 1.20010847517343
+ 8.476e-06 1.2002546054107
+ 8.478e-06 1.19990641028963
+ 8.48e-06 1.19978568533915
+ 8.482e-06 1.19967517543351
+ 8.484e-06 1.19953341608044
+ 8.486e-06 1.19906663899095
+ 8.488e-06 1.19915388903743
+ 8.49e-06 1.19916258749556
+ 8.492e-06 1.19918183043131
+ 8.494e-06 1.19932168101474
+ 8.496e-06 1.19913237231754
+ 8.498e-06 1.19922963192296
+ 8.5e-06 1.19929517787372
+ 8.502e-06 1.19958248480523
+ 8.504e-06 1.1997011930605
+ 8.506e-06 1.19966076488758
+ 8.508e-06 1.19954185567185
+ 8.51e-06 1.19975356399487
+ 8.512e-06 1.19987348390849
+ 8.514e-06 1.19955657858539
+ 8.516e-06 1.19920537757107
+ 8.518e-06 1.19900834335283
+ 8.52e-06 1.19900996704617
+ 8.522e-06 1.19879824201872
+ 8.524e-06 1.19847985495975
+ 8.526e-06 1.19841280177077
+ 8.528e-06 1.19819964716264
+ 8.53e-06 1.19812675577036
+ 8.532e-06 1.19820345286834
+ 8.534e-06 1.19809394240117
+ 8.536e-06 1.19790037690167
+ 8.538e-06 1.19744529605406
+ 8.54e-06 1.19789992723506
+ 8.542e-06 1.19812280975763
+ 8.544e-06 1.19794836731399
+ 8.546e-06 1.1981621882453
+ 8.548e-06 1.19833151344004
+ 8.55e-06 1.19857563683835
+ 8.552e-06 1.19849362367241
+ 8.554e-06 1.1982404785214
+ 8.556e-06 1.19836646440506
+ 8.558e-06 1.19884855229434
+ 8.56e-06 1.19890555072426
+ 8.562e-06 1.19867405828687
+ 8.564e-06 1.19847655717595
+ 8.566e-06 1.19852150465072
+ 8.568e-06 1.19856133310654
+ 8.57e-06 1.19860700819687
+ 8.572e-06 1.19869618834599
+ 8.574e-06 1.19893311447609
+ 8.576e-06 1.19916869873804
+ 8.578e-06 1.19945162611286
+ 8.58e-06 1.19959109263975
+ 8.582e-06 1.19937890058949
+ 8.584e-06 1.19928177871746
+ 8.586e-06 1.19906370096974
+ 8.588e-06 1.19893398268856
+ 8.59e-06 1.19928992734804
+ 8.592e-06 1.19945333745323
+ 8.594e-06 1.19933583283339
+ 8.596e-06 1.19917675310691
+ 8.598e-06 1.19908307615128
+ 8.6e-06 1.19896735735193
+ 8.602e-06 1.19901050993589
+ 8.604e-06 1.19886627422018
+ 8.606e-06 1.1989811334484
+ 8.608e-06 1.1990761590198
+ 8.61e-06 1.19888326337853
+ 8.612e-06 1.19900380841712
+ 8.614e-06 1.19882363967069
+ 8.616e-06 1.19889746098336
+ 8.618e-06 1.1987251530562
+ 8.62e-06 1.19845518068751
+ 8.622e-06 1.19867042442414
+ 8.624e-06 1.19835692418525
+ 8.626e-06 1.19857653703671
+ 8.628e-06 1.1985205676223
+ 8.63e-06 1.19854692595832
+ 8.632e-06 1.19877406100857
+ 8.634e-06 1.19891980055797
+ 8.636e-06 1.19917214439685
+ 8.638e-06 1.1992687849002
+ 8.64e-06 1.19923405251361
+ 8.642e-06 1.19909453426325
+ 8.644e-06 1.19893207443446
+ 8.646e-06 1.19911228865405
+ 8.648e-06 1.19938103902705
+ 8.65e-06 1.19907862814367
+ 8.652e-06 1.19897844163146
+ 8.654e-06 1.19906921323978
+ 8.656e-06 1.19915286067686
+ 8.658e-06 1.19937956805357
+ 8.66e-06 1.19947516566319
+ 8.662e-06 1.19951778557899
+ 8.664e-06 1.19930808696832
+ 8.666e-06 1.19929679006898
+ 8.668e-06 1.19921328574564
+ 8.67e-06 1.19897474194915
+ 8.672e-06 1.19915878246022
+ 8.674e-06 1.19910112564484
+ 8.676e-06 1.19923050678973
+ 8.678e-06 1.19916830266879
+ 8.68e-06 1.19909221723774
+ 8.682e-06 1.19883055983525
+ 8.684e-06 1.19892757605384
+ 8.686e-06 1.1986896816914
+ 8.688e-06 1.19859131460578
+ 8.69e-06 1.19874945486906
+ 8.692e-06 1.19886060946628
+ 8.694e-06 1.19859925518693
+ 8.696e-06 1.19835520761816
+ 8.698e-06 1.19821306127024
+ 8.7e-06 1.19843447316945
+ 8.702e-06 1.19853795172444
+ 8.704e-06 1.19855697033635
+ 8.706e-06 1.1986270293912
+ 8.708e-06 1.19844727917667
+ 8.71e-06 1.19807883932146
+ 8.712e-06 1.19829262857286
+ 8.714e-06 1.19836991828688
+ 8.716e-06 1.19858368742957
+ 8.718e-06 1.19868467517638
+ 8.72e-06 1.19865900943017
+ 8.722e-06 1.1986206451036
+ 8.724e-06 1.19868221285609
+ 8.726e-06 1.19890456232243
+ 8.728e-06 1.19913237601948
+ 8.73e-06 1.19953106315781
+ 8.732e-06 1.19978837166114
+ 8.734e-06 1.2000119114541
+ 8.736e-06 1.19978519281394
+ 8.738e-06 1.20026303906394
+ 8.74e-06 1.20014297535149
+ 8.742e-06 1.19997137138848
+ 8.744e-06 1.20009246334674
+ 8.746e-06 1.19991416303202
+ 8.748e-06 1.20009621646981
+ 8.75e-06 1.19980748807196
+ 8.752e-06 1.19994926889465
+ 8.754e-06 1.19986764926266
+ 8.756e-06 1.19971387825807
+ 8.758e-06 1.19960429978068
+ 8.76e-06 1.19962592884065
+ 8.762e-06 1.19986304903298
+ 8.764e-06 1.19994118202867
+ 8.766e-06 1.20012511642718
+ 8.768e-06 1.20027438251307
+ 8.77e-06 1.20016849069519
+ 8.772e-06 1.20013313483138
+ 8.774e-06 1.20004637317224
+ 8.776e-06 1.20008427814561
+ 8.778e-06 1.20014685609116
+ 8.78e-06 1.20012280986541
+ 8.782e-06 1.19994061082026
+ 8.784e-06 1.2003430426456
+ 8.786e-06 1.20013236192859
+ 8.788e-06 1.20015950537163
+ 8.79e-06 1.20034403592978
+ 8.792e-06 1.2003891614242
+ 8.794e-06 1.20059985068197
+ 8.796e-06 1.20035740430625
+ 8.798e-06 1.20012613625094
+ 8.8e-06 1.19956995547233
+ 8.802e-06 1.19978869749949
+ 8.804e-06 1.20004107813757
+ 8.806e-06 1.19977416255742
+ 8.808e-06 1.19962760725408
+ 8.81e-06 1.19955337884213
+ 8.812e-06 1.19942578330891
+ 8.814e-06 1.19918367767488
+ 8.816e-06 1.1994044113484
+ 8.818e-06 1.19956049242201
+ 8.82e-06 1.19932124739609
+ 8.822e-06 1.19936838340776
+ 8.824e-06 1.19975030226669
+ 8.826e-06 1.20008532975463
+ 8.828e-06 1.19996215251142
+ 8.83e-06 1.19998802251707
+ 8.832e-06 1.20012446841732
+ 8.834e-06 1.20007849923938
+ 8.836e-06 1.19986079464155
+ 8.838e-06 1.19996770884115
+ 8.84e-06 1.19953027817845
+ 8.842e-06 1.19959363091971
+ 8.844e-06 1.19924418082202
+ 8.846e-06 1.19948328232548
+ 8.848e-06 1.19929045918612
+ 8.85e-06 1.19931955732696
+ 8.852e-06 1.19920510496679
+ 8.854e-06 1.19917584568737
+ 8.856e-06 1.1992554927813
+ 8.858e-06 1.1990475849033
+ 8.86e-06 1.19931812515534
+ 8.862e-06 1.19929064118231
+ 8.864e-06 1.1989749750081
+ 8.866e-06 1.19901679528106
+ 8.868e-06 1.19851402893327
+ 8.87e-06 1.19844163673185
+ 8.872e-06 1.19853448250716
+ 8.874e-06 1.19865069749005
+ 8.876e-06 1.19865778775722
+ 8.878e-06 1.1986374424071
+ 8.88e-06 1.19921414581265
+ 8.882e-06 1.19904934152218
+ 8.884e-06 1.1990344328212
+ 8.886e-06 1.19886127858226
+ 8.888e-06 1.19889113298966
+ 8.89e-06 1.19901462460992
+ 8.892e-06 1.1991737710133
+ 8.894e-06 1.19924246189095
+ 8.896e-06 1.19932934294133
+ 8.898e-06 1.19917903018873
+ 8.9e-06 1.1993585426068
+ 8.902e-06 1.1990818997474
+ 8.904e-06 1.19887999998676
+ 8.906e-06 1.1987996436022
+ 8.908e-06 1.19872917866624
+ 8.91e-06 1.19880133111436
+ 8.912e-06 1.19884162903937
+ 8.914e-06 1.19947798844936
+ 8.916e-06 1.1991228922726
+ 8.918e-06 1.19882207979753
+ 8.92e-06 1.19897702570617
+ 8.922e-06 1.19868780781039
+ 8.924e-06 1.19864673627607
+ 8.926e-06 1.19851764039616
+ 8.928e-06 1.19805943527119
+ 8.93e-06 1.19839228365086
+ 8.932e-06 1.19827868557616
+ 8.934e-06 1.19836345932807
+ 8.936e-06 1.19821221523908
+ 8.938e-06 1.19810762295604
+ 8.94e-06 1.19796140104779
+ 8.942e-06 1.19812204135238
+ 8.944e-06 1.19813831225292
+ 8.946e-06 1.19826783700255
+ 8.948e-06 1.19801646292423
+ 8.95e-06 1.19823231737221
+ 8.952e-06 1.19865318795326
+ 8.954e-06 1.19850604763215
+ 8.956e-06 1.19866344324023
+ 8.958e-06 1.19899605455287
+ 8.96e-06 1.19915314808297
+ 8.962e-06 1.19910954871609
+ 8.964e-06 1.19873658217092
+ 8.966e-06 1.19899781209603
+ 8.968e-06 1.19901786790426
+ 8.97e-06 1.19919518370459
+ 8.972e-06 1.19960678789095
+ 8.974e-06 1.19938326868127
+ 8.976e-06 1.19960415472343
+ 8.978e-06 1.19925476916525
+ 8.98e-06 1.19902074248141
+ 8.982e-06 1.19912481838774
+ 8.984e-06 1.19933543034252
+ 8.986e-06 1.19953157199093
+ 8.988e-06 1.19951784800138
+ 8.99e-06 1.1994940489372
+ 8.992e-06 1.19923390110602
+ 8.994e-06 1.19942410699485
+ 8.996e-06 1.19998137992409
+ 8.998e-06 1.20033038633753
+ 9e-06 1.20011242418037
+ 9.002e-06 1.20001464192334
+ 9.004e-06 1.20007859469476
+ 9.006e-06 1.19990782644309
+ 9.008e-06 1.20020921991744
+ 9.01e-06 1.20037669199676
+ 9.012e-06 1.20062473984534
+ 9.014e-06 1.20050725480511
+ 9.016e-06 1.20037315414658
+ 9.018e-06 1.2005654542332
+ 9.02e-06 1.2006694100939
+ 9.022e-06 1.2006311468996
+ 9.024e-06 1.20063414964973
+ 9.026e-06 1.20072145898054
+ 9.028e-06 1.20080376495742
+ 9.03e-06 1.20096795177166
+ 9.032e-06 1.20100173312847
+ 9.034e-06 1.20115524731708
+ 9.036e-06 1.20133561498051
+ 9.038e-06 1.20148096409807
+ 9.04e-06 1.20110358064588
+ 9.042e-06 1.20088066222177
+ 9.044e-06 1.20061433109889
+ 9.046e-06 1.20039124330425
+ 9.048e-06 1.20050306724233
+ 9.05e-06 1.200362152501
+ 9.052e-06 1.2005063227807
+ 9.054e-06 1.20065936247438
+ 9.056e-06 1.20059971381923
+ 9.058e-06 1.20094825736679
+ 9.06e-06 1.20054150830624
+ 9.062e-06 1.20078245854561
+ 9.064e-06 1.20052327122125
+ 9.066e-06 1.20056526320114
+ 9.068e-06 1.20051202747313
+ 9.07e-06 1.20057477066211
+ 9.072e-06 1.20034067358374
+ 9.074e-06 1.20044688149598
+ 9.076e-06 1.2003443210389
+ 9.078e-06 1.20042118384313
+ 9.08e-06 1.20041613194417
+ 9.082e-06 1.20026332738371
+ 9.084e-06 1.20021631851915
+ 9.086e-06 1.1999661767971
+ 9.088e-06 1.19996057770069
+ 9.09e-06 1.19993953759219
+ 9.092e-06 1.1998502715501
+ 9.094e-06 1.19985913525913
+ 9.096e-06 1.19972412759925
+ 9.098e-06 1.19952235001004
+ 9.1e-06 1.19939337167222
+ 9.102e-06 1.19953023335158
+ 9.104e-06 1.19953159944226
+ 9.106e-06 1.19941180691434
+ 9.108e-06 1.19938959644659
+ 9.11e-06 1.19965826200052
+ 9.112e-06 1.19978890066121
+ 9.114e-06 1.20014452210082
+ 9.116e-06 1.20001864852924
+ 9.118e-06 1.19961669640016
+ 9.12e-06 1.19967504755489
+ 9.122e-06 1.19981242072101
+ 9.124e-06 1.19965084884289
+ 9.126e-06 1.19958971320109
+ 9.128e-06 1.20014450365414
+ 9.13e-06 1.20037040394267
+ 9.132e-06 1.20043196790075
+ 9.134e-06 1.20033999374371
+ 9.136e-06 1.20042679868586
+ 9.138e-06 1.20064068794601
+ 9.14e-06 1.20029312449139
+ 9.142e-06 1.20042393660913
+ 9.144e-06 1.20037004069
+ 9.146e-06 1.20025655277323
+ 9.148e-06 1.20046332087908
+ 9.15e-06 1.20078837525325
+ 9.152e-06 1.20050641895187
+ 9.154e-06 1.20046092058438
+ 9.156e-06 1.20048315850727
+ 9.158e-06 1.20059252501024
+ 9.16e-06 1.2005596824202
+ 9.162e-06 1.20042773559291
+ 9.164e-06 1.20033065018882
+ 9.166e-06 1.20043723719672
+ 9.168e-06 1.20025947899065
+ 9.17e-06 1.20015815198731
+ 9.172e-06 1.20029658025423
+ 9.174e-06 1.20021379061798
+ 9.176e-06 1.20056746498016
+ 9.178e-06 1.20052688611674
+ 9.18e-06 1.20043853788477
+ 9.182e-06 1.20048512973696
+ 9.184e-06 1.20006776012595
+ 9.186e-06 1.19958574042108
+ 9.188e-06 1.1997315991751
+ 9.19e-06 1.19953318300818
+ 9.192e-06 1.19964380018472
+ 9.194e-06 1.1997529650679
+ 9.196e-06 1.19971053117362
+ 9.198e-06 1.1995034121258
+ 9.2e-06 1.19942246961716
+ 9.202e-06 1.19946304228075
+ 9.204e-06 1.19960935795792
+ 9.206e-06 1.19941235620378
+ 9.208e-06 1.19958695965022
+ 9.21e-06 1.1998382892174
+ 9.212e-06 1.19957379072587
+ 9.214e-06 1.1996440444629
+ 9.216e-06 1.19990059985623
+ 9.218e-06 1.19990634114347
+ 9.22e-06 1.19973994014288
+ 9.222e-06 1.1996388529548
+ 9.224e-06 1.1996494169507
+ 9.226e-06 1.19983931919782
+ 9.228e-06 1.20008495876317
+ 9.23e-06 1.20028397393223
+ 9.232e-06 1.20030861079533
+ 9.234e-06 1.20030090572572
+ 9.236e-06 1.20075471447841
+ 9.238e-06 1.20083078325618
+ 9.24e-06 1.20101449037009
+ 9.242e-06 1.20093376262071
+ 9.244e-06 1.2007346446193
+ 9.246e-06 1.20091933181986
+ 9.248e-06 1.2009578313698
+ 9.25e-06 1.2007840206685
+ 9.252e-06 1.20035607942316
+ 9.254e-06 1.20022907049747
+ 9.256e-06 1.20020343652647
+ 9.258e-06 1.20006173888448
+ 9.26e-06 1.20030797955832
+ 9.262e-06 1.20051203606564
+ 9.264e-06 1.20050613562464
+ 9.266e-06 1.20067608799323
+ 9.268e-06 1.20030012059171
+ 9.27e-06 1.20019537713144
+ 9.272e-06 1.20011986591242
+ 9.274e-06 1.20031782643879
+ 9.276e-06 1.20006300000709
+ 9.278e-06 1.19997769974991
+ 9.28e-06 1.20008186694304
+ 9.282e-06 1.19975178687857
+ 9.284e-06 1.19968669688598
+ 9.286e-06 1.20004760581957
+ 9.288e-06 1.20021722486152
+ 9.29e-06 1.20005400256794
+ 9.292e-06 1.20030806535804
+ 9.294e-06 1.20032353641435
+ 9.296e-06 1.20038217389312
+ 9.298e-06 1.20039151542987
+ 9.3e-06 1.20028269130406
+ 9.302e-06 1.2001561526264
+ 9.304e-06 1.19988600754585
+ 9.306e-06 1.19992356653742
+ 9.308e-06 1.19956251062772
+ 9.31e-06 1.19943974805716
+ 9.312e-06 1.19944141739363
+ 9.314e-06 1.19935753023033
+ 9.316e-06 1.19929664421528
+ 9.318e-06 1.19917873747518
+ 9.32e-06 1.19900377946519
+ 9.322e-06 1.19869889132671
+ 9.324e-06 1.19850095078017
+ 9.326e-06 1.19883100445026
+ 9.328e-06 1.1989083167334
+ 9.33e-06 1.19900726144113
+ 9.332e-06 1.19891674872056
+ 9.334e-06 1.19887112043739
+ 9.336e-06 1.19868305471443
+ 9.338e-06 1.19877722000502
+ 9.34e-06 1.19897698970128
+ 9.342e-06 1.19905283027448
+ 9.344e-06 1.19914975084862
+ 9.346e-06 1.19908163074582
+ 9.348e-06 1.19914913364506
+ 9.35e-06 1.19928613277824
+ 9.352e-06 1.19897820076219
+ 9.354e-06 1.19923485147959
+ 9.356e-06 1.19951494170991
+ 9.358e-06 1.19989573308269
+ 9.36e-06 1.19997897756668
+ 9.362e-06 1.19950087116441
+ 9.364e-06 1.19981636879043
+ 9.366e-06 1.1998399237101
+ 9.368e-06 1.19995932134932
+ 9.37e-06 1.19984796535684
+ 9.372e-06 1.19983895867421
+ 9.374e-06 1.20001065143386
+ 9.376e-06 1.19987772691458
+ 9.378e-06 1.19980429677272
+ 9.38e-06 1.19987309418614
+ 9.382e-06 1.2001087582458
+ 9.384e-06 1.2002499500071
+ 9.386e-06 1.20025867783223
+ 9.388e-06 1.19989203104953
+ 9.39e-06 1.19993648947869
+ 9.392e-06 1.19992577505819
+ 9.394e-06 1.20003729744465
+ 9.396e-06 1.20024461441387
+ 9.398e-06 1.20003955333777
+ 9.4e-06 1.20010911604139
+ 9.402e-06 1.19984110270362
+ 9.404e-06 1.19985665261625
+ 9.406e-06 1.1997730739216
+ 9.408e-06 1.19953713416703
+ 9.41e-06 1.19940243484969
+ 9.412e-06 1.19895217466616
+ 9.414e-06 1.19904834770758
+ 9.416e-06 1.19929180228846
+ 9.418e-06 1.19909043028658
+ 9.42e-06 1.19900904731068
+ 9.422e-06 1.1991322408021
+ 9.424e-06 1.19915149960452
+ 9.426e-06 1.19911695620238
+ 9.428e-06 1.1989417739991
+ 9.43e-06 1.19934114694316
+ 9.432e-06 1.19935807680794
+ 9.434e-06 1.19931188326041
+ 9.436e-06 1.19945063281035
+ 9.438e-06 1.19942772603867
+ 9.44e-06 1.19955316431325
+ 9.442e-06 1.19910698403695
+ 9.444e-06 1.19940175775033
+ 9.446e-06 1.1993670742468
+ 9.448e-06 1.19936775272957
+ 9.45e-06 1.19954828024696
+ 9.452e-06 1.19931495081226
+ 9.454e-06 1.19941830333314
+ 9.456e-06 1.19929762955519
+ 9.458e-06 1.19910204688069
+ 9.46e-06 1.19902993097143
+ 9.462e-06 1.19896782966851
+ 9.464e-06 1.19911642361655
+ 9.466e-06 1.1994743576382
+ 9.468e-06 1.19954595751614
+ 9.47e-06 1.19969677837445
+ 9.472e-06 1.19965599188601
+ 9.474e-06 1.19959975854833
+ 9.476e-06 1.19983332944947
+ 9.478e-06 1.19991580284153
+ 9.48e-06 1.19984181544332
+ 9.482e-06 1.19988858120586
+ 9.484e-06 1.20004560865097
+ 9.486e-06 1.19990644243986
+ 9.488e-06 1.20022601577634
+ 9.49e-06 1.20035508818024
+ 9.492e-06 1.2005905275726
+ 9.494e-06 1.20066001561265
+ 9.496e-06 1.20064689620917
+ 9.498e-06 1.20079109356077
+ 9.5e-06 1.20067849809339
+ 9.502e-06 1.20078284596638
+ 9.504e-06 1.20068755754306
+ 9.506e-06 1.2004263257557
+ 9.508e-06 1.20012514071776
+ 9.51e-06 1.19988952637614
+ 9.512e-06 1.1999366077795
+ 9.514e-06 1.19999970602775
+ 9.516e-06 1.19983881398871
+ 9.518e-06 1.19969294657978
+ 9.52e-06 1.19975546654209
+ 9.522e-06 1.19966421534011
+ 9.524e-06 1.19993929291588
+ 9.526e-06 1.2001463774897
+ 9.528e-06 1.20001649062474
+ 9.53e-06 1.19973827922807
+ 9.532e-06 1.19989653748062
+ 9.534e-06 1.19973279666374
+ 9.536e-06 1.19987149382583
+ 9.538e-06 1.20002325227347
+ 9.54e-06 1.19985641259429
+ 9.542e-06 1.19967945867119
+ 9.544e-06 1.19961212549516
+ 9.546e-06 1.19975299812687
+ 9.548e-06 1.19987037853869
+ 9.55e-06 1.19993440887983
+ 9.552e-06 1.20027546211338
+ 9.554e-06 1.20024679639247
+ 9.556e-06 1.20025256651172
+ 9.558e-06 1.20063332129378
+ 9.56e-06 1.20060525313095
+ 9.562e-06 1.20031541313804
+ 9.564e-06 1.20027290281661
+ 9.566e-06 1.20054691254189
+ 9.568e-06 1.20052564237062
+ 9.57e-06 1.20048361398139
+ 9.572e-06 1.20089814826366
+ 9.574e-06 1.20083791028849
+ 9.576e-06 1.20107536675173
+ 9.578e-06 1.20102076458682
+ 9.58e-06 1.20081899255775
+ 9.582e-06 1.20104103186435
+ 9.584e-06 1.20109479215404
+ 9.586e-06 1.20097776110826
+ 9.588e-06 1.20071215795343
+ 9.59e-06 1.20064518070286
+ 9.592e-06 1.200731291349
+ 9.594e-06 1.20107345016266
+ 9.596e-06 1.20117964408623
+ 9.598e-06 1.20122456838923
+ 9.6e-06 1.20128269736714
+ 9.602e-06 1.20146373206443
+ 9.604e-06 1.20134246762055
+ 9.606e-06 1.20138820561805
+ 9.608e-06 1.2015076839868
+ 9.61e-06 1.201572729214
+ 9.612e-06 1.2017016147005
+ 9.614e-06 1.20147557446731
+ 9.616e-06 1.20145771887287
+ 9.618e-06 1.20126519199469
+ 9.62e-06 1.20144109040749
+ 9.622e-06 1.20133782393496
+ 9.624e-06 1.20112675610118
+ 9.626e-06 1.20121111474264
+ 9.628e-06 1.20100822469519
+ 9.63e-06 1.2011680650666
+ 9.632e-06 1.20131014965172
+ 9.634e-06 1.20127618567883
+ 9.636e-06 1.20119937967869
+ 9.638e-06 1.20114290378211
+ 9.64e-06 1.20083900696319
+ 9.642e-06 1.20082982200482
+ 9.644e-06 1.20091633125161
+ 9.646e-06 1.20116743883821
+ 9.648e-06 1.20100506352535
+ 9.65e-06 1.20091157514882
+ 9.652e-06 1.20099226898338
+ 9.654e-06 1.20108979022702
+ 9.656e-06 1.20121828190268
+ 9.658e-06 1.20127945668374
+ 9.66e-06 1.20139025582085
+ 9.662e-06 1.20146719470302
+ 9.664e-06 1.20126925248457
+ 9.666e-06 1.20096100734767
+ 9.668e-06 1.20089311168401
+ 9.67e-06 1.20088881397938
+ 9.672e-06 1.20052693848404
+ 9.674e-06 1.20038431032107
+ 9.676e-06 1.20059908471384
+ 9.678e-06 1.20046699037291
+ 9.68e-06 1.20053842695583
+ 9.682e-06 1.20045675441814
+ 9.684e-06 1.20024285856215
+ 9.686e-06 1.2000346701491
+ 9.688e-06 1.19976597401
+ 9.69e-06 1.19963409862523
+ 9.692e-06 1.19995819887449
+ 9.694e-06 1.20009834977892
+ 9.696e-06 1.20001549593953
+ 9.698e-06 1.20002370173589
+ 9.7e-06 1.19996554557344
+ 9.702e-06 1.20016836700561
+ 9.704e-06 1.200248519007
+ 9.706e-06 1.20005857591106
+ 9.708e-06 1.19987312155466
+ 9.71e-06 1.19955129371351
+ 9.712e-06 1.19939484712445
+ 9.714e-06 1.19949522183452
+ 9.716e-06 1.19911288654591
+ 9.718e-06 1.19892855773065
+ 9.72e-06 1.19921112552451
+ 9.722e-06 1.1993766154978
+ 9.724e-06 1.19903045813607
+ 9.726e-06 1.19910756955459
+ 9.728e-06 1.19910429028641
+ 9.73e-06 1.19930246474556
+ 9.732e-06 1.19936556456953
+ 9.734e-06 1.19933583950916
+ 9.736e-06 1.19968510909573
+ 9.738e-06 1.19931975321509
+ 9.74e-06 1.1991594987366
+ 9.742e-06 1.19893829716084
+ 9.744e-06 1.19876570593959
+ 9.746e-06 1.19882462316867
+ 9.748e-06 1.19887425196271
+ 9.75e-06 1.19878681128332
+ 9.752e-06 1.19901398421416
+ 9.754e-06 1.19918224176044
+ 9.756e-06 1.19930494262313
+ 9.758e-06 1.19925500305736
+ 9.76e-06 1.19878023846395
+ 9.762e-06 1.19876657236815
+ 9.764e-06 1.19873507938751
+ 9.766e-06 1.19876689824345
+ 9.768e-06 1.19882258500014
+ 9.77e-06 1.19926136209307
+ 9.772e-06 1.19946333327915
+ 9.774e-06 1.19944942790211
+ 9.776e-06 1.19968649959036
+ 9.778e-06 1.19989779901921
+ 9.78e-06 1.19978559185681
+ 9.782e-06 1.1998932958105
+ 9.784e-06 1.20000258899143
+ 9.786e-06 1.19997703290014
+ 9.788e-06 1.19988001923828
+ 9.79e-06 1.19999872937968
+ 9.792e-06 1.19996148291053
+ 9.794e-06 1.19987005203691
+ 9.796e-06 1.1997208287524
+ 9.798e-06 1.20018056335604
+ 9.8e-06 1.20033791391007
+ 9.802e-06 1.20066546562866
+ 9.804e-06 1.20073879310597
+ 9.806e-06 1.20096890020275
+ 9.808e-06 1.20137673530696
+ 9.81e-06 1.20168260247751
+ 9.812e-06 1.20139313023417
+ 9.814e-06 1.2013987480392
+ 9.816e-06 1.20143031265621
+ 9.818e-06 1.20129291443048
+ 9.82e-06 1.20142584670092
+ 9.822e-06 1.2016382591443
+ 9.824e-06 1.20184270783047
+ 9.826e-06 1.20184335207067
+ 9.828e-06 1.20159674229956
+ 9.83e-06 1.2014904365845
+ 9.832e-06 1.20158766200271
+ 9.834e-06 1.20117331743851
+ 9.836e-06 1.20105117392887
+ 9.838e-06 1.20123731288402
+ 9.84e-06 1.20095955673199
+ 9.842e-06 1.20064661670624
+ 9.844e-06 1.20041622393061
+ 9.846e-06 1.20051852774907
+ 9.848e-06 1.20037309890399
+ 9.85e-06 1.20045727410607
+ 9.852e-06 1.20060807175599
+ 9.854e-06 1.20076558796555
+ 9.856e-06 1.20061968158419
+ 9.858e-06 1.20048757789972
+ 9.86e-06 1.20067782268658
+ 9.862e-06 1.20084798896774
+ 9.864e-06 1.20079940750863
+ 9.866e-06 1.20079741174081
+ 9.868e-06 1.20068808641761
+ 9.87e-06 1.2006725602016
+ 9.872e-06 1.20071174128842
+ 9.874e-06 1.20042768242155
+ 9.876e-06 1.20032184117246
+ 9.878e-06 1.20067727561357
+ 9.88e-06 1.20047031316292
+ 9.882e-06 1.20037026185807
+ 9.884e-06 1.20026320451118
+ 9.886e-06 1.19994912091972
+ 9.888e-06 1.20024574130762
+ 9.89e-06 1.19994160970822
+ 9.892e-06 1.20009710339727
+ 9.894e-06 1.20012434717894
+ 9.896e-06 1.20004994612917
+ 9.898e-06 1.19991221479899
+ 9.9e-06 1.19967231206852
+ 9.902e-06 1.19957184821507
+ 9.904e-06 1.19967009799307
+ 9.906e-06 1.19955455169753
+ 9.908e-06 1.19909578021312
+ 9.91e-06 1.19926617415595
+ 9.912e-06 1.19896247377464
+ 9.914e-06 1.19911022517865
+ 9.916e-06 1.19892822173804
+ 9.918e-06 1.1989070017193
+ 9.92e-06 1.19919925268775
+ 9.922e-06 1.19956385253939
+ 9.924e-06 1.20009362464955
+ 9.926e-06 1.20015139054703
+ 9.928e-06 1.20001916972
+ 9.93e-06 1.20019351800581
+ 9.932e-06 1.19996402209212
+ 9.934e-06 1.20033368060133
+ 9.936e-06 1.19997979932126
+ 9.938e-06 1.19999929351545
+ 9.94e-06 1.19978474786136
+ 9.942e-06 1.20010184128831
+ 9.944e-06 1.20026738254724
+ 9.946e-06 1.20019258139281
+ 9.948e-06 1.20046261382536
+ 9.95e-06 1.2004637374368
+ 9.952e-06 1.20037348647568
+ 9.954e-06 1.20009769288255
+ 9.956e-06 1.19980125181302
+ 9.958e-06 1.19963914401971
+ 9.96e-06 1.20012326405924
+ 9.962e-06 1.20021578613836
+ 9.964e-06 1.20022742939448
+ 9.966e-06 1.20025935493556
+ 9.968e-06 1.1999501132055
+ 9.97e-06 1.20011523195754
+ 9.972e-06 1.19998239150325
+ 9.974e-06 1.20018095482031
+ 9.976e-06 1.20021259069101
+ 9.978e-06 1.20024723588166
+ 9.98e-06 1.20035568881442
+ 9.982e-06 1.20038838325627
+ 9.984e-06 1.20026348977601
+ 9.986e-06 1.20004415890324
+ 9.988e-06 1.2000422641637
+ 9.99e-06 1.19985858227941
+ 9.992e-06 1.19948055103999
+ 9.994e-06 1.199326331484
+ 9.996e-06 1.1990111043915
+ 9.998e-06 1.19906556186846
+ 1e-05 1.19894462953859
+ 1.0002e-05 1.1993295846698
+ 1.0004e-05 1.1992068946629
+ 1.0006e-05 1.19946270606987
+ 1.0008e-05 1.19910932945454
+ 1.001e-05 1.19930599620614
+ 1.0012e-05 1.19967875713613
+ 1.0014e-05 1.19973169186778
+ 1.0016e-05 1.19981666619047
+ 1.0018e-05 1.19956287433882
+ 1.002e-05 1.1993442695558
+ 1.0022e-05 1.19918189225301
+ 1.0024e-05 1.19917730491817
+ 1.0026e-05 1.19913548493683
+ 1.0028e-05 1.19908936433327
+ 1.003e-05 1.19944160549197
+ 1.0032e-05 1.19947410097637
+ 1.0034e-05 1.19936665431157
+ 1.0036e-05 1.19929703113155
+ 1.0038e-05 1.19917253019062
+ 1.004e-05 1.1992250168142
+ 1.0042e-05 1.19932084028979
+ 1.0044e-05 1.19901874494165
+ 1.0046e-05 1.19898417105388
+ 1.0048e-05 1.19899459318668
+ 1.005e-05 1.19873396841322
+ 1.0052e-05 1.1986867561074
+ 1.0054e-05 1.19876186792543
+ 1.0056e-05 1.19885127340554
+ 1.0058e-05 1.19917767626211
+ 1.006e-05 1.19921486715497
+ 1.0062e-05 1.1993775828391
+ 1.0064e-05 1.19912851668895
+ 1.0066e-05 1.19934021086051
+ 1.0068e-05 1.19916090181242
+ 1.007e-05 1.19912150936242
+ 1.0072e-05 1.19898945616932
+ 1.0074e-05 1.19885686679775
+ 1.0076e-05 1.19901423022188
+ 1.0078e-05 1.1988012888752
+ 1.008e-05 1.19892121917856
+ 1.0082e-05 1.19881285026975
+ 1.0084e-05 1.19912576876559
+ 1.0086e-05 1.19926893554466
+ 1.0088e-05 1.1997374715423
+ 1.009e-05 1.19989169858735
+ 1.0092e-05 1.20003202348194
+ 1.0094e-05 1.2002925759249
+ 1.0096e-05 1.2001496902017
+ 1.0098e-05 1.19996738406106
+ 1.01e-05 1.2000429342115
+ 1.0102e-05 1.1998086373909
+ 1.0104e-05 1.19962498994134
+ 1.0106e-05 1.19958767501471
+ 1.0108e-05 1.19976687508479
+ 1.011e-05 1.19957666122892
+ 1.0112e-05 1.19976062518457
+ 1.0114e-05 1.19954783472988
+ 1.0116e-05 1.19944243716074
+ 1.0118e-05 1.19959587315952
+ 1.012e-05 1.19974113854495
+ 1.0122e-05 1.19975531273669
+ 1.0124e-05 1.19949563092159
+ 1.0126e-05 1.19978010047662
+ 1.0128e-05 1.19991900645552
+ 1.013e-05 1.19975479530689
+ 1.0132e-05 1.19956178188382
+ 1.0134e-05 1.19947621778883
+ 1.0136e-05 1.19960997679819
+ 1.0138e-05 1.19967942155857
+ 1.014e-05 1.19983798144045
+ 1.0142e-05 1.19977866639382
+ 1.0144e-05 1.19977176716405
+ 1.0146e-05 1.19999728420312
+ 1.0148e-05 1.19995361168195
+ 1.015e-05 1.19977804368641
+ 1.0152e-05 1.19967152783637
+ 1.0154e-05 1.1998075454533
+ 1.0156e-05 1.200421913604
+ 1.0158e-05 1.20040666807291
+ 1.016e-05 1.20047456483399
+ 1.0162e-05 1.20043497045984
+ 1.0164e-05 1.20028482580355
+ 1.0166e-05 1.20075753256826
+ 1.0168e-05 1.20078529448383
+ 1.017e-05 1.20019161673306
+ 1.0172e-05 1.20009863170713
+ 1.0174e-05 1.20022178828759
+ 1.0176e-05 1.20015219217198
+ 1.0178e-05 1.20009187379337
+ 1.018e-05 1.19989654966655
+ 1.0182e-05 1.19982173240653
+ 1.0184e-05 1.19958712212764
+ 1.0186e-05 1.19951399278624
+ 1.0188e-05 1.19963988838323
+ 1.019e-05 1.19957277116564
+ 1.0192e-05 1.19950202835031
+ 1.0194e-05 1.19948974037222
+ 1.0196e-05 1.19951358220141
+ 1.0198e-05 1.1993943940966
+ 1.02e-05 1.19929669277264
+ 1.0202e-05 1.19935317604732
+ 1.0204e-05 1.1991725326704
+ 1.0206e-05 1.19911088072896
+ 1.0208e-05 1.19879606690199
+ 1.021e-05 1.19870769245348
+ 1.0212e-05 1.19854312376325
+ 1.0214e-05 1.19865400159927
+ 1.0216e-05 1.1984188881048
+ 1.0218e-05 1.19825839823651
+ 1.022e-05 1.19814502346932
+ 1.0222e-05 1.19821132733166
+ 1.0224e-05 1.19834244349451
+ 1.0226e-05 1.19858104875106
+ 1.0228e-05 1.19897213680604
+ 1.023e-05 1.19907558519633
+ 1.0232e-05 1.19890822469288
+ 1.0234e-05 1.1991338743729
+ 1.0236e-05 1.19903903668296
+ 1.0238e-05 1.19891158770967
+ 1.024e-05 1.19877350583673
+ 1.0242e-05 1.19865499103302
+ 1.0244e-05 1.19853804106196
+ 1.0246e-05 1.19850023474893
+ 1.0248e-05 1.19887378078472
+ 1.025e-05 1.19892191414836
+ 1.0252e-05 1.19881633107434
+ 1.0254e-05 1.19874551397863
+ 1.0256e-05 1.19859771073243
+ 1.0258e-05 1.19841245755826
+ 1.026e-05 1.19829388152969
+ 1.0262e-05 1.19820869604757
+ 1.0264e-05 1.19812007888734
+ 1.0266e-05 1.19812739527077
+ 1.0268e-05 1.1979986621362
+ 1.027e-05 1.1980754146994
+ 1.0272e-05 1.19807707664598
+ 1.0274e-05 1.19780945660623
+ 1.0276e-05 1.19779739403171
+ 1.0278e-05 1.19793489285901
+ 1.028e-05 1.19780093126249
+ 1.0282e-05 1.19810618586687
+ 1.0284e-05 1.19799860210708
+ 1.0286e-05 1.19800659896313
+ 1.0288e-05 1.19823840850899
+ 1.029e-05 1.19798900308451
+ 1.0292e-05 1.19787978371877
+ 1.0294e-05 1.19803791338791
+ 1.0296e-05 1.19768540081761
+ 1.0298e-05 1.19780890344336
+ 1.03e-05 1.19764888098009
+ 1.0302e-05 1.19735869320268
+ 1.0304e-05 1.19705296519346
+ 1.0306e-05 1.19739045878372
+ 1.0308e-05 1.19753307330695
+ 1.031e-05 1.1975394314865
+ 1.0312e-05 1.19782494853249
+ 1.0314e-05 1.19789641109999
+ 1.0316e-05 1.19799439278473
+ 1.0318e-05 1.19809368258339
+ 1.032e-05 1.19881485889382
+ 1.0322e-05 1.19856808244005
+ 1.0324e-05 1.19879447136663
+ 1.0326e-05 1.19845003127671
+ 1.0328e-05 1.19827767686163
+ 1.033e-05 1.1984479297558
+ 1.0332e-05 1.19849575452295
+ 1.0334e-05 1.19856275747824
+ 1.0336e-05 1.1989009005432
+ 1.0338e-05 1.19885844972544
+ 1.034e-05 1.19864105616689
+ 1.0342e-05 1.19905394275392
+ 1.0344e-05 1.19926123090334
+ 1.0346e-05 1.1992391825218
+ 1.0348e-05 1.19935089436049
+ 1.035e-05 1.19957681443212
+ 1.0352e-05 1.19949620666612
+ 1.0354e-05 1.19988023647377
+ 1.0356e-05 1.20006535586483
+ 1.0358e-05 1.20017566235449
+ 1.036e-05 1.20002495591047
+ 1.0362e-05 1.19989168492888
+ 1.0364e-05 1.20032185301309
+ 1.0366e-05 1.20003643829663
+ 1.0368e-05 1.19976047282443
+ 1.037e-05 1.19985478301555
+ 1.0372e-05 1.20022165310527
+ 1.0374e-05 1.20019037020466
+ 1.0376e-05 1.20037041315063
+ 1.0378e-05 1.20035110664596
+ 1.038e-05 1.20043264399719
+ 1.0382e-05 1.20010436339808
+ 1.0384e-05 1.19976843429033
+ 1.0386e-05 1.19986848487648
+ 1.0388e-05 1.2002097864628
+ 1.039e-05 1.19989524939033
+ 1.0392e-05 1.20005197276308
+ 1.0394e-05 1.20015555753734
+ 1.0396e-05 1.19998342782256
+ 1.0398e-05 1.19986814547539
+ 1.04e-05 1.19963916183351
+ 1.0402e-05 1.19935236165823
+ 1.0404e-05 1.19908166769136
+ 1.0406e-05 1.19921842074881
+ 1.0408e-05 1.19917920146702
+ 1.041e-05 1.19896567483576
+ 1.0412e-05 1.19880453360892
+ 1.0414e-05 1.1988406621403
+ 1.0416e-05 1.19881566939727
+ 1.0418e-05 1.19878037843968
+ 1.042e-05 1.19865943044326
+ 1.0422e-05 1.19895864452987
+ 1.0424e-05 1.19889891911325
+ 1.0426e-05 1.19926340044941
+ 1.0428e-05 1.19921325567709
+ 1.043e-05 1.19916468557419
+ 1.0432e-05 1.19922057542791
+ 1.0434e-05 1.19940461971942
+ 1.0436e-05 1.19946044348163
+ 1.0438e-05 1.19956161248303
+ 1.044e-05 1.19949224762653
+ 1.0442e-05 1.19946675192572
+ 1.0444e-05 1.19960290924519
+ 1.0446e-05 1.19929733220655
+ 1.0448e-05 1.19953917002941
+ 1.045e-05 1.19957261067401
+ 1.0452e-05 1.19959567845909
+ 1.0454e-05 1.19941092052996
+ 1.0456e-05 1.19957794130902
+ 1.0458e-05 1.19955204279119
+ 1.046e-05 1.1992288045509
+ 1.0462e-05 1.1992267188091
+ 1.0464e-05 1.19914415596927
+ 1.0466e-05 1.19896911912249
+ 1.0468e-05 1.19907749356402
+ 1.047e-05 1.19931777392278
+ 1.0472e-05 1.19963640238342
+ 1.0474e-05 1.19967048535691
+ 1.0476e-05 1.1994892068471
+ 1.0478e-05 1.19942613741051
+ 1.048e-05 1.19944974854625
+ 1.0482e-05 1.1995188804492
+ 1.0484e-05 1.19972546914154
+ 1.0486e-05 1.19965574634496
+ 1.0488e-05 1.19983154470792
+ 1.049e-05 1.19986358235399
+ 1.0492e-05 1.19964542345369
+ 1.0494e-05 1.19992899940565
+ 1.0496e-05 1.20033121023507
+ 1.0498e-05 1.20033070162181
+ 1.05e-05 1.2005936946148
+ 1.0502e-05 1.20044384381015
+ 1.0504e-05 1.20044448062078
+ 1.0506e-05 1.20026926171329
+ 1.0508e-05 1.20028597809537
+ 1.051e-05 1.20016759573806
+ 1.0512e-05 1.20010397115199
+ 1.0514e-05 1.20016800985752
+ 1.0516e-05 1.20027771776922
+ 1.0518e-05 1.200108262728
+ 1.052e-05 1.20021316167877
+ 1.0522e-05 1.20022691845627
+ 1.0524e-05 1.20019408122544
+ 1.0526e-05 1.20001448771529
+ 1.0528e-05 1.20007561709165
+ 1.053e-05 1.20018401486655
+ 1.0532e-05 1.20030893929609
+ 1.0534e-05 1.20028836109394
+ 1.0536e-05 1.19991266119271
+ 1.0538e-05 1.19970828289713
+ 1.054e-05 1.19949996791936
+ 1.0542e-05 1.19952782354726
+ 1.0544e-05 1.19925152435685
+ 1.0546e-05 1.19928154361808
+ 1.0548e-05 1.19912464244576
+ 1.055e-05 1.19936814211589
+ 1.0552e-05 1.19951512344944
+ 1.0554e-05 1.19951158409192
+ 1.0556e-05 1.19964423179365
+ 1.0558e-05 1.19933208679125
+ 1.056e-05 1.19929204741282
+ 1.0562e-05 1.1991412300997
+ 1.0564e-05 1.19894574344886
+ 1.0566e-05 1.19886755607932
+ 1.0568e-05 1.19913704864875
+ 1.057e-05 1.19914594856822
+ 1.0572e-05 1.19921641975964
+ 1.0574e-05 1.19871766498547
+ 1.0576e-05 1.19885252264212
+ 1.0578e-05 1.19872119282641
+ 1.058e-05 1.19858129208357
+ 1.0582e-05 1.19876944907083
+ 1.0584e-05 1.19867314440268
+ 1.0586e-05 1.19862877377869
+ 1.0588e-05 1.19810953064085
+ 1.059e-05 1.19792028957904
+ 1.0592e-05 1.19787763874621
+ 1.0594e-05 1.1979879270166
+ 1.0596e-05 1.19790713448296
+ 1.0598e-05 1.19819588776972
+ 1.06e-05 1.19832675403328
+ 1.0602e-05 1.1983907441358
+ 1.0604e-05 1.19847941977476
+ 1.0606e-05 1.19871936758944
+ 1.0608e-05 1.19914065153397
+ 1.061e-05 1.19926234443052
+ 1.0612e-05 1.19938528390409
+ 1.0614e-05 1.19912804863236
+ 1.0616e-05 1.199365247577
+ 1.0618e-05 1.19938270448679
+ 1.062e-05 1.19955582730862
+ 1.0622e-05 1.199298895969
+ 1.0624e-05 1.19926487770985
+ 1.0626e-05 1.19954798855576
+ 1.0628e-05 1.19934211070179
+ 1.063e-05 1.19947665109282
+ 1.0632e-05 1.19927357703623
+ 1.0634e-05 1.19914891451907
+ 1.0636e-05 1.19909750433216
+ 1.0638e-05 1.19913802478618
+ 1.064e-05 1.19921636539272
+ 1.0642e-05 1.19906413100022
+ 1.0644e-05 1.19915415357004
+ 1.0646e-05 1.1989477943004
+ 1.0648e-05 1.19918858111428
+ 1.065e-05 1.19890605174277
+ 1.0652e-05 1.19915546003383
+ 1.0654e-05 1.19882540947792
+ 1.0656e-05 1.19876936112424
+ 1.0658e-05 1.19876030252643
+ 1.066e-05 1.19894931661283
+ 1.0662e-05 1.19885279783347
+ 1.0664e-05 1.19855520918712
+ 1.0666e-05 1.19869254770996
+ 1.0668e-05 1.19871032483698
+ 1.067e-05 1.19887510407054
+ 1.0672e-05 1.19859840731449
+ 1.0674e-05 1.19852645050719
+ 1.0676e-05 1.19837886038461
+ 1.0678e-05 1.19820104488517
+ 1.068e-05 1.19820005551999
+ 1.0682e-05 1.19825378684563
+ 1.0684e-05 1.19821776187598
+ 1.0686e-05 1.19811808771928
+ 1.0688e-05 1.19831870989201
+ 1.069e-05 1.19848527054044
+ 1.0692e-05 1.1983919222983
+ 1.0694e-05 1.19845134970279
+ 1.0696e-05 1.19820533218756
+ 1.0698e-05 1.19841885948056
+ 1.07e-05 1.19867345856799
+ 1.0702e-05 1.19846679371294
+ 1.0704e-05 1.19854846453562
+ 1.0706e-05 1.19893170335584
+ 1.0708e-05 1.19894009715814
+ 1.071e-05 1.19892424486366
+ 1.0712e-05 1.19858164805455
+ 1.0714e-05 1.19859865743732
+ 1.0716e-05 1.1986265866167
+ 1.0718e-05 1.19846377243433
+ 1.072e-05 1.1984733633447
+ 1.0722e-05 1.19824110194736
+ 1.0724e-05 1.19824146377188
+ 1.0726e-05 1.19829830828201
+ 1.0728e-05 1.19798042633433
+ 1.073e-05 1.19782496074154
+ 1.0732e-05 1.19762382124364
+ 1.0734e-05 1.19741265352142
+ 1.0736e-05 1.19744676631854
+ 1.0738e-05 1.19726345760824
+ 1.074e-05 1.19723874283269
+ 1.0742e-05 1.19678480438651
+ 1.0744e-05 1.19664527740834
+ 1.0746e-05 1.19644222542406
+ 1.0748e-05 1.19622008640929
+ 1.075e-05 1.19642347520065
+ 1.0752e-05 1.19648533936371
+ 1.0754e-05 1.19657755520373
+ 1.0756e-05 1.19673387020923
+ 1.0758e-05 1.19634939805876
+ 1.076e-05 1.19638878202429
+ 1.0762e-05 1.19637125327874
+ 1.0764e-05 1.19624138306966
+ 1.0766e-05 1.19652624388854
+ 1.0768e-05 1.19677025361344
+ 1.077e-05 1.19673455384754
+ 1.0772e-05 1.19647733258928
+ 1.0774e-05 1.19612301297513
+ 1.0776e-05 1.19618149412959
+ 1.0778e-05 1.19592770708967
+ 1.078e-05 1.1961223798501
+ 1.0782e-05 1.19601670712988
+ 1.0784e-05 1.19611848181042
+ 1.0786e-05 1.19642521050891
+ 1.0788e-05 1.19669333196417
+ 1.079e-05 1.19666123784793
+ 1.0792e-05 1.1966613836791
+ 1.0794e-05 1.19647471876498
+ 1.0796e-05 1.19688137668406
+ 1.0798e-05 1.19714885032461
+ 1.08e-05 1.19717134887538
+ 1.0802e-05 1.19714269639443
+ 1.0804e-05 1.19717722445983
+ 1.0806e-05 1.19752189296653
+ 1.0808e-05 1.19740411756467
+ 1.081e-05 1.19729359530728
+ 1.0812e-05 1.19726780881043
+ 1.0814e-05 1.19739023094849
+ 1.0816e-05 1.1973958860277
+ 1.0818e-05 1.19771628555206
+ 1.082e-05 1.1975718721113
+ 1.0822e-05 1.19758512125945
+ 1.0824e-05 1.19768995204861
+ 1.0826e-05 1.19796560674341
+ 1.0828e-05 1.19803690475477
+ 1.083e-05 1.19814990423795
+ 1.0832e-05 1.19830694260385
+ 1.0834e-05 1.19873880369082
+ 1.0836e-05 1.19913611813889
+ 1.0838e-05 1.1993121679138
+ 1.084e-05 1.19980065887617
+ 1.0842e-05 1.19949002175955
+ 1.0844e-05 1.19973187210232
+ 1.0846e-05 1.19990644627206
+ 1.0848e-05 1.19971299344809
+ 1.085e-05 1.19955833173419
+ 1.0852e-05 1.19933459581152
+ 1.0854e-05 1.19925821522859
+ 1.0856e-05 1.19932337871918
+ 1.0858e-05 1.19984519066595
+ 1.086e-05 1.2003269301529
+ 1.0862e-05 1.20051606906771
+ 1.0864e-05 1.20101108685529
+ 1.0866e-05 1.20095630822076
+ 1.0868e-05 1.20097836703363
+ 1.087e-05 1.20102900671212
+ 1.0872e-05 1.20091009428339
+ 1.0874e-05 1.20071733603394
+ 1.0876e-05 1.20043178709633
+ 1.0878e-05 1.20033380567126
+ 1.088e-05 1.20033856400908
+ 1.0882e-05 1.20075453167044
+ 1.0884e-05 1.20070143934308
+ 1.0886e-05 1.20068067403733
+ 1.0888e-05 1.20071516462889
+ 1.089e-05 1.20104178352445
+ 1.0892e-05 1.2011520396009
+ 1.0894e-05 1.20114853517445
+ 1.0896e-05 1.20122518449889
+ 1.0898e-05 1.20116530421244
+ 1.09e-05 1.20104144777223
+ 1.0902e-05 1.20107258049936
+ 1.0904e-05 1.20046984856548
+ 1.0906e-05 1.20037023611224
+ 1.0908e-05 1.20044527538357
+ 1.091e-05 1.20060913683293
+ 1.0912e-05 1.20059467999665
+ 1.0914e-05 1.20093864084734
+ 1.0916e-05 1.20124565554096
+ 1.0918e-05 1.2010083684969
+ 1.092e-05 1.20137778776903
+ 1.0922e-05 1.20156749168134
+ 1.0924e-05 1.20130577252922
+ 1.0926e-05 1.20150247933665
+ 1.0928e-05 1.20128558960282
+ 1.093e-05 1.201385583511
+ 1.0932e-05 1.20152902388018
+ 1.0934e-05 1.20142452967468
+ 1.0936e-05 1.20208625146946
+ 1.0938e-05 1.20179444460081
+ 1.094e-05 1.20140524862133
+ 1.0942e-05 1.20145333475054
+ 1.0944e-05 1.20142216842126
+ 1.0946e-05 1.20111427671142
+ 1.0948e-05 1.20112314536039
+ 1.095e-05 1.20077034687937
+ 1.0952e-05 1.20062700246238
+ 1.0954e-05 1.20070730861277
+ 1.0956e-05 1.20040457499781
+ 1.0958e-05 1.20018162154709
+ 1.096e-05 1.1999012734776
+ 1.0962e-05 1.19994550748904
+ 1.0964e-05 1.19988890545138
+ 1.0966e-05 1.19998207449902
+ 1.0968e-05 1.20001933547104
+ 1.097e-05 1.19978800338514
+ 1.0972e-05 1.19992029710415
+ 1.0974e-05 1.19997476553174
+ 1.0976e-05 1.20006806052632
+ 1.0978e-05 1.20042328141106
+ 1.098e-05 1.2002976094462
+ 1.0982e-05 1.20038598144098
+ 1.0984e-05 1.20035935155152
+ 1.0986e-05 1.19999776037068
+ 1.0988e-05 1.20031181998878
+ 1.099e-05 1.20051415797624
+ 1.0992e-05 1.2004652592506
+ 1.0994e-05 1.20065176413431
+ 1.0996e-05 1.20056015167359
+ 1.0998e-05 1.20052676392481
+ 1.1e-05 1.20022463766849
+ 1.1002e-05 1.19999671619357
+ 1.1004e-05 1.20015507836416
+ 1.1006e-05 1.19999252305694
+ 1.1008e-05 1.19997042689456
+ 1.101e-05 1.19954781916388
+ 1.1012e-05 1.19938657932386
+ 1.1014e-05 1.19935976470465
+ 1.1016e-05 1.19947895505846
+ 1.1018e-05 1.19941633383339
+ 1.102e-05 1.19907344984882
+ 1.1022e-05 1.19920076329706
+ 1.1024e-05 1.19922638416169
+ 1.1026e-05 1.1994060062513
+ 1.1028e-05 1.19938524010962
+ 1.103e-05 1.19931447967835
+ 1.1032e-05 1.19955889487727
+ 1.1034e-05 1.199276077222
+ 1.1036e-05 1.19952648044236
+ 1.1038e-05 1.1994802566917
+ 1.104e-05 1.1994956538485
+ 1.1042e-05 1.19978242316569
+ 1.1044e-05 1.19973958410758
+ 1.1046e-05 1.19997549552357
+ 1.1048e-05 1.19994876219593
+ 1.105e-05 1.19943000117054
+ 1.1052e-05 1.19934234835753
+ 1.1054e-05 1.19985758284969
+ 1.1056e-05 1.19994403520463
+ 1.1058e-05 1.20039126424597
+ 1.106e-05 1.20036371542997
+ 1.1062e-05 1.20022857571314
+ 1.1064e-05 1.2004180057628
+ 1.1066e-05 1.2000379358771
+ 1.1068e-05 1.19997121280543
+ 1.107e-05 1.19981754439534
+ 1.1072e-05 1.19982064861209
+ 1.1074e-05 1.19982567384147
+ 1.1076e-05 1.2001961456224
+ 1.1078e-05 1.20011993437378
+ 1.108e-05 1.20040213887473
+ 1.1082e-05 1.20059031419913
+ 1.1084e-05 1.20066381569867
+ 1.1086e-05 1.20082283609082
+ 1.1088e-05 1.2007729517292
+ 1.109e-05 1.200372316712
+ 1.1092e-05 1.20003973932055
+ 1.1094e-05 1.19979793375792
+ 1.1096e-05 1.19980259398199
+ 1.1098e-05 1.20007777410069
+ 1.11e-05 1.20036553825574
+ 1.1102e-05 1.20020199207229
+ 1.1104e-05 1.2004703927548
+ 1.1106e-05 1.20054734027149
+ 1.1108e-05 1.20023557460198
+ 1.111e-05 1.19985616385689
+ 1.1112e-05 1.19978818037177
+ 1.1114e-05 1.19960688519995
+ 1.1116e-05 1.19926288724184
+ 1.1118e-05 1.19960146706502
+ 1.112e-05 1.1997454266907
+ 1.1122e-05 1.19998747431565
+ 1.1124e-05 1.2000549723252
+ 1.1126e-05 1.19987643213074
+ 1.1128e-05 1.19981396062896
+ 1.113e-05 1.19980323833787
+ 1.1132e-05 1.19961611416045
+ 1.1134e-05 1.19968247842758
+ 1.1136e-05 1.19980243668904
+ 1.1138e-05 1.2000571994368
+ 1.114e-05 1.20024439976172
+ 1.1142e-05 1.20026493055557
+ 1.1144e-05 1.20021168267556
+ 1.1146e-05 1.20000558376171
+ 1.1148e-05 1.19990653782562
+ 1.115e-05 1.19988620539955
+ 1.1152e-05 1.19982098838473
+ 1.1154e-05 1.19986289290239
+ 1.1156e-05 1.19986822834619
+ 1.1158e-05 1.20022978911282
+ 1.116e-05 1.20044721730622
+ 1.1162e-05 1.20085659583826
+ 1.1164e-05 1.20085482017439
+ 1.1166e-05 1.20110321967244
+ 1.1168e-05 1.20074726729
+ 1.117e-05 1.20069982418348
+ 1.1172e-05 1.20066183735239
+ 1.1174e-05 1.20094325957228
+ 1.1176e-05 1.20096630835391
+ 1.1178e-05 1.20091468252483
+ 1.118e-05 1.20096824473873
+ 1.1182e-05 1.20065409539909
+ 1.1184e-05 1.20064964417001
+ 1.1186e-05 1.20069127270896
+ 1.1188e-05 1.2007230827491
+ 1.119e-05 1.20057553885268
+ 1.1192e-05 1.2004712199817
+ 1.1194e-05 1.20031434559758
+ 1.1196e-05 1.20042917746661
+ 1.1198e-05 1.20033666296925
+ 1.12e-05 1.19995199027001
+ 1.1202e-05 1.20010561001992
+ 1.1204e-05 1.20006127230998
+ 1.1206e-05 1.20009356371999
+ 1.1208e-05 1.20016080870207
+ 1.121e-05 1.20026233165886
+ 1.1212e-05 1.20010906216278
+ 1.1214e-05 1.19984329974425
+ 1.1216e-05 1.19953754692315
+ 1.1218e-05 1.1996320984232
+ 1.122e-05 1.19947310978112
+ 1.1222e-05 1.19945079029496
+ 1.1224e-05 1.19960858978509
+ 1.1226e-05 1.19945366672168
+ 1.1228e-05 1.19949658206077
+ 1.123e-05 1.19935165947973
+ 1.1232e-05 1.1993421085308
+ 1.1234e-05 1.19973511320145
+ 1.1236e-05 1.19973193661151
+ 1.1238e-05 1.19963606625168
+ 1.124e-05 1.19961165537186
+ 1.1242e-05 1.19959040589007
+ 1.1244e-05 1.19981372985654
+ 1.1246e-05 1.19984887361135
+ 1.1248e-05 1.19976282639981
+ 1.125e-05 1.19973889167222
+ 1.1252e-05 1.20002629105207
+ 1.1254e-05 1.19963919220307
+ 1.1256e-05 1.19950110812202
+ 1.1258e-05 1.19948069961587
+ 1.126e-05 1.19986358979427
+ 1.1262e-05 1.19986141971574
+ 1.1264e-05 1.1998300475948
+ 1.1266e-05 1.19962793691287
+ 1.1268e-05 1.19944467463614
+ 1.127e-05 1.19942421145202
+ 1.1272e-05 1.1996748098264
+ 1.1274e-05 1.19943637700374
+ 1.1276e-05 1.19971019064383
+ 1.1278e-05 1.19976814016493
+ 1.128e-05 1.19922230662762
+ 1.1282e-05 1.19959712201001
+ 1.1284e-05 1.19973780118283
+ 1.1286e-05 1.19987339877253
+ 1.1288e-05 1.19992317025255
+ 1.129e-05 1.19977172387602
+ 1.1292e-05 1.20021615813228
+ 1.1294e-05 1.20037967954094
+ 1.1296e-05 1.20042587079496
+ 1.1298e-05 1.19987033329624
+ 1.13e-05 1.19982641487838
+ 1.1302e-05 1.20014702246886
+ 1.1304e-05 1.20013692541338
+ 1.1306e-05 1.20005689526972
+ 1.1308e-05 1.19994695448844
+ 1.131e-05 1.19991323268846
+ 1.1312e-05 1.19976100844335
+ 1.1314e-05 1.19937763615826
+ 1.1316e-05 1.19932108442787
+ 1.1318e-05 1.19916972608338
+ 1.132e-05 1.19943651484728
+ 1.1322e-05 1.19970753879993
+ 1.1324e-05 1.19976744891574
+ 1.1326e-05 1.19961917580404
+ 1.1328e-05 1.19979089450462
+ 1.133e-05 1.20000266329814
+ 1.1332e-05 1.20032990757171
+ 1.1334e-05 1.20001945951232
+ 1.1336e-05 1.20021142103392
+ 1.1338e-05 1.19996561718501
+ 1.134e-05 1.19998787235408
+ 1.1342e-05 1.20009302229879
+ 1.1344e-05 1.20018341883264
+ 1.1346e-05 1.20043886329492
+ 1.1348e-05 1.20068544643276
+ 1.135e-05 1.20049610888048
+ 1.1352e-05 1.20058437581687
+ 1.1354e-05 1.20083997474616
+ 1.1356e-05 1.20094732688564
+ 1.1358e-05 1.20063572889606
+ 1.136e-05 1.20058264135082
+ 1.1362e-05 1.20003438648805
+ 1.1364e-05 1.20011479385489
+ 1.1366e-05 1.20004641775709
+ 1.1368e-05 1.19970253381506
+ 1.137e-05 1.19950797954242
+ 1.1372e-05 1.19918212998855
+ 1.1374e-05 1.19905637289212
+ 1.1376e-05 1.19889324954833
+ 1.1378e-05 1.19897901057182
+ 1.138e-05 1.19914084637047
+ 1.1382e-05 1.19937028700382
+ 1.1384e-05 1.1991355160615
+ 1.1386e-05 1.19929569525027
+ 1.1388e-05 1.19927284406832
+ 1.139e-05 1.19970370946096
+ 1.1392e-05 1.19980010691233
+ 1.1394e-05 1.19949944529543
+ 1.1396e-05 1.199210499944
+ 1.1398e-05 1.19939930072484
+ 1.14e-05 1.19900313610129
+ 1.1402e-05 1.19917143803975
+ 1.1404e-05 1.19936871261883
+ 1.1406e-05 1.19953960330205
+ 1.1408e-05 1.19946761766033
+ 1.141e-05 1.19913657474853
+ 1.1412e-05 1.19941525722194
+ 1.1414e-05 1.1994558879495
+ 1.1416e-05 1.19967081277795
+ 1.1418e-05 1.1995056860539
+ 1.142e-05 1.19975692958553
+ 1.1422e-05 1.19979430673243
+ 1.1424e-05 1.19928397523276
+ 1.1426e-05 1.19949242892419
+ 1.1428e-05 1.1994914008303
+ 1.143e-05 1.19971487628983
+ 1.1432e-05 1.19966025893318
+ 1.1434e-05 1.19961069859723
+ 1.1436e-05 1.20004723943525
+ 1.1438e-05 1.20024043258103
+ 1.144e-05 1.19990430518896
+ 1.1442e-05 1.19963395494835
+ 1.1444e-05 1.19982925577286
+ 1.1446e-05 1.20012762036636
+ 1.1448e-05 1.20035821250605
+ 1.145e-05 1.20043707576261
+ 1.1452e-05 1.19977566401434
+ 1.1454e-05 1.19981993483182
+ 1.1456e-05 1.19969378944517
+ 1.1458e-05 1.19934971540562
+ 1.146e-05 1.19958525783633
+ 1.1462e-05 1.19959476931896
+ 1.1464e-05 1.19958886944593
+ 1.1466e-05 1.19941226264767
+ 1.1468e-05 1.19933694273794
+ 1.147e-05 1.19930612556633
+ 1.1472e-05 1.19913732323691
+ 1.1474e-05 1.19950909382452
+ 1.1476e-05 1.19938260040958
+ 1.1478e-05 1.19933315635091
+ 1.148e-05 1.19954771206156
+ 1.1482e-05 1.19946811100444
+ 1.1484e-05 1.19939420452186
+ 1.1486e-05 1.1994794054286
+ 1.1488e-05 1.19945717822667
+ 1.149e-05 1.19947410230272
+ 1.1492e-05 1.19950998894008
+ 1.1494e-05 1.19962281855509
+ 1.1496e-05 1.19947322890621
+ 1.1498e-05 1.19954606381444
+ 1.15e-05 1.19949864652802
+ 1.1502e-05 1.1994031084505
+ 1.1504e-05 1.19902841694103
+ 1.1506e-05 1.19889557997873
+ 1.1508e-05 1.19873804226907
+ 1.151e-05 1.19852964552581
+ 1.1512e-05 1.19860909392896
+ 1.1514e-05 1.19888901475585
+ 1.1516e-05 1.19878483397704
+ 1.1518e-05 1.19871593769249
+ 1.152e-05 1.19864210328321
+ 1.1522e-05 1.19890003490124
+ 1.1524e-05 1.19884499652538
+ 1.1526e-05 1.19873863679984
+ 1.1528e-05 1.19879749137354
+ 1.153e-05 1.19858941160482
+ 1.1532e-05 1.1985673534455
+ 1.1534e-05 1.19897725663338
+ 1.1536e-05 1.19892201229556
+ 1.1538e-05 1.19894355832248
+ 1.154e-05 1.19899666392469
+ 1.1542e-05 1.19906892767558
+ 1.1544e-05 1.19886553811031
+ 1.1546e-05 1.19888357937975
+ 1.1548e-05 1.19870414280283
+ 1.155e-05 1.19853269941711
+ 1.1552e-05 1.19896463848894
+ 1.1554e-05 1.19916456786403
+ 1.1556e-05 1.19931823687985
+ 1.1558e-05 1.19957524955291
+ 1.156e-05 1.19940827269138
+ 1.1562e-05 1.19974101370409
+ 1.1564e-05 1.19969524373319
+ 1.1566e-05 1.1997952052679
+ 1.1568e-05 1.19970658597788
+ 1.157e-05 1.1995928316734
+ 1.1572e-05 1.19985440707543
+ 1.1574e-05 1.19949838858499
+ 1.1576e-05 1.19941677706606
+ 1.1578e-05 1.19947467219818
+ 1.158e-05 1.19981825851796
+ 1.1582e-05 1.20009505137602
+ 1.1584e-05 1.20020335387864
+ 1.1586e-05 1.20039189815823
+ 1.1588e-05 1.20035462658238
+ 1.159e-05 1.20027178489385
+ 1.1592e-05 1.20023440125577
+ 1.1594e-05 1.20023157550221
+ 1.1596e-05 1.19995851003798
+ 1.1598e-05 1.19993328952948
+ 1.16e-05 1.19988193217968
+ 1.1602e-05 1.19968426523544
+ 1.1604e-05 1.19954060401181
+ 1.1606e-05 1.19930466048249
+ 1.1608e-05 1.19936937173443
+ 1.161e-05 1.19954119954067
+ 1.1612e-05 1.19950240110232
+ 1.1614e-05 1.1997522677454
+ 1.1616e-05 1.19964926674333
+ 1.1618e-05 1.19977589540996
+ 1.162e-05 1.19982788973682
+ 1.1622e-05 1.20014388801555
+ 1.1624e-05 1.20021659358882
+ 1.1626e-05 1.20011315041236
+ 1.1628e-05 1.20013715548257
+ 1.163e-05 1.20035408334359
+ 1.1632e-05 1.20025121937432
+ 1.1634e-05 1.20021141454904
+ 1.1636e-05 1.20018266483957
+ 1.1638e-05 1.20006304168127
+ 1.164e-05 1.20018728086561
+ 1.1642e-05 1.20002902156636
+ 1.1644e-05 1.19971686438583
+ 1.1646e-05 1.19961902253335
+ 1.1648e-05 1.19965293633098
+ 1.165e-05 1.19955989269541
+ 1.1652e-05 1.19963515335327
+ 1.1654e-05 1.19969338422206
+ 1.1656e-05 1.19961843328932
+ 1.1658e-05 1.19960943986146
+ 1.166e-05 1.19971366154666
+ 1.1662e-05 1.19987709679222
+ 1.1664e-05 1.19980663236345
+ 1.1666e-05 1.20009939245748
+ 1.1668e-05 1.20005752965457
+ 1.167e-05 1.20015152675297
+ 1.1672e-05 1.20026399743882
+ 1.1674e-05 1.19993218018895
+ 1.1676e-05 1.19935584185336
+ 1.1678e-05 1.19969692357948
+ 1.168e-05 1.19957852641621
+ 1.1682e-05 1.19928954123833
+ 1.1684e-05 1.19952078098061
+ 1.1686e-05 1.19931098969467
+ 1.1688e-05 1.1995477879957
+ 1.169e-05 1.19959591811892
+ 1.1692e-05 1.19971503378595
+ 1.1694e-05 1.19980984845699
+ 1.1696e-05 1.19976053134186
+ 1.1698e-05 1.19963084213951
+ 1.17e-05 1.19962348925977
+ 1.1702e-05 1.19936564803061
+ 1.1704e-05 1.1993959036241
+ 1.1706e-05 1.19945962174268
+ 1.1708e-05 1.19980867732699
+ 1.171e-05 1.1995573007122
+ 1.1712e-05 1.19926763016837
+ 1.1714e-05 1.19915221431408
+ 1.1716e-05 1.19915919919095
+ 1.1718e-05 1.1995191195774
+ 1.172e-05 1.19967568147262
+ 1.1722e-05 1.19987763975469
+ 1.1724e-05 1.1998887899326
+ 1.1726e-05 1.20007482942629
+ 1.1728e-05 1.20032509314944
+ 1.173e-05 1.20050704299277
+ 1.1732e-05 1.20040852759965
+ 1.1734e-05 1.20004722139252
+ 1.1736e-05 1.20009272670418
+ 1.1738e-05 1.20009315338823
+ 1.174e-05 1.19998516126666
+ 1.1742e-05 1.20030460986963
+ 1.1744e-05 1.20005181173588
+ 1.1746e-05 1.2003205052969
+ 1.1748e-05 1.20033133362799
+ 1.175e-05 1.20009059312106
+ 1.1752e-05 1.20036643654271
+ 1.1754e-05 1.20041029034292
+ 1.1756e-05 1.20032228333211
+ 1.1758e-05 1.20023442124395
+ 1.176e-05 1.19995289543123
+ 1.1762e-05 1.20001979455683
+ 1.1764e-05 1.20014561879841
+ 1.1766e-05 1.20001130279131
+ 1.1768e-05 1.19996975443749
+ 1.177e-05 1.19980687678768
+ 1.1772e-05 1.19946868695934
+ 1.1774e-05 1.19966873251856
+ 1.1776e-05 1.19971202708066
+ 1.1778e-05 1.19973942603307
+ 1.178e-05 1.19973829854587
+ 1.1782e-05 1.19985529962132
+ 1.1784e-05 1.1997526388713
+ 1.1786e-05 1.19977881923868
+ 1.1788e-05 1.19942129789622
+ 1.179e-05 1.19936954627103
+ 1.1792e-05 1.19927581001451
+ 1.1794e-05 1.19890070932672
+ 1.1796e-05 1.1986945210976
+ 1.1798e-05 1.19833664583167
+ 1.18e-05 1.19843734099253
+ 1.1802e-05 1.19827386384339
+ 1.1804e-05 1.19828522736704
+ 1.1806e-05 1.19837203749877
+ 1.1808e-05 1.19828685756495
+ 1.181e-05 1.19832775931523
+ 1.1812e-05 1.19861350991417
+ 1.1814e-05 1.19848210807133
+ 1.1816e-05 1.19829837482854
+ 1.1818e-05 1.19828635009892
+ 1.182e-05 1.19852071433403
+ 1.1822e-05 1.19850932260699
+ 1.1824e-05 1.19845981767369
+ 1.1826e-05 1.19826073210993
+ 1.1828e-05 1.19820287612421
+ 1.183e-05 1.19817099042071
+ 1.1832e-05 1.19828397068362
+ 1.1834e-05 1.19836661205255
+ 1.1836e-05 1.19802282526825
+ 1.1838e-05 1.19818942808115
+ 1.184e-05 1.19810690067881
+ 1.1842e-05 1.19777550021661
+ 1.1844e-05 1.19777595953746
+ 1.1846e-05 1.19765268410486
+ 1.1848e-05 1.19746182952638
+ 1.185e-05 1.19751025773373
+ 1.1852e-05 1.19750675439559
+ 1.1854e-05 1.19775848570362
+ 1.1856e-05 1.19742925908843
+ 1.1858e-05 1.19735945113049
+ 1.186e-05 1.1975178233551
+ 1.1862e-05 1.197678847631
+ 1.1864e-05 1.19776087878129
+ 1.1866e-05 1.19782981296843
+ 1.1868e-05 1.19805059280077
+ 1.187e-05 1.19851047599867
+ 1.1872e-05 1.19847805336896
+ 1.1874e-05 1.19810141509436
+ 1.1876e-05 1.19830641989526
+ 1.1878e-05 1.19819486385703
+ 1.188e-05 1.19845694540624
+ 1.1882e-05 1.19869427379073
+ 1.1884e-05 1.19871352015499
+ 1.1886e-05 1.19901510888765
+ 1.1888e-05 1.19904059946701
+ 1.189e-05 1.19901795256066
+ 1.1892e-05 1.19872019462669
+ 1.1894e-05 1.19855530265566
+ 1.1896e-05 1.19892061041674
+ 1.1898e-05 1.1986272432135
+ 1.19e-05 1.19826388251896
+ 1.1902e-05 1.19798581088198
+ 1.1904e-05 1.19836851515815
+ 1.1906e-05 1.19846934670292
+ 1.1908e-05 1.19844060481278
+ 1.191e-05 1.19862378790851
+ 1.1912e-05 1.19874145284939
+ 1.1914e-05 1.19863223652059
+ 1.1916e-05 1.19885426111564
+ 1.1918e-05 1.1987627411087
+ 1.192e-05 1.19907915296427
+ 1.1922e-05 1.19915653247997
+ 1.1924e-05 1.19910564284341
+ 1.1926e-05 1.19903766872446
+ 1.1928e-05 1.19904212929792
+ 1.193e-05 1.19929182012507
+ 1.1932e-05 1.19919901502476
+ 1.1934e-05 1.19902873174768
+ 1.1936e-05 1.19873725899448
+ 1.1938e-05 1.1987653970497
+ 1.194e-05 1.19887283600213
+ 1.1942e-05 1.19922724856995
+ 1.1944e-05 1.19985822384175
+ 1.1946e-05 1.2000953683408
+ 1.1948e-05 1.19989303826976
+ 1.195e-05 1.20011546800092
+ 1.1952e-05 1.20035452277772
+ 1.1954e-05 1.2004989480789
+ 1.1956e-05 1.20054911489054
+ 1.1958e-05 1.2002762187529
+ 1.196e-05 1.20034828377364
+ 1.1962e-05 1.20009645669207
+ 1.1964e-05 1.20025881621064
+ 1.1966e-05 1.2003483495228
+ 1.1968e-05 1.19999270787623
+ 1.197e-05 1.19991219882943
+ 1.1972e-05 1.19974993340709
+ 1.1974e-05 1.19988296790559
+ 1.1976e-05 1.1996476881149
+ 1.1978e-05 1.19965835454913
+ 1.198e-05 1.19975357873064
+ 1.1982e-05 1.19994542899579
+ 1.1984e-05 1.20014018125596
+ 1.1986e-05 1.20020323409987
+ 1.1988e-05 1.2002419162912
+ 1.199e-05 1.20022040597657
+ 1.1992e-05 1.19998375527867
+ 1.1994e-05 1.19992096714608
+ 1.1996e-05 1.20002315700247
+ 1.1998e-05 1.20017083861236
+ 1.2e-05 1.20041603276706
+ 1.2002e-05 1.20050157037121
+ 1.2004e-05 1.20036907580833
+ 1.2006e-05 1.2005055435807
+ 1.2008e-05 1.20076333447182
+ 1.201e-05 1.20085733659938
+ 1.2012e-05 1.2009190138985
+ 1.2014e-05 1.20104662663137
+ 1.2016e-05 1.20110471184668
+ 1.2018e-05 1.2008153695067
+ 1.202e-05 1.20050772018954
+ 1.2022e-05 1.2005320850572
+ 1.2024e-05 1.20067523160929
+ 1.2026e-05 1.2008701585015
+ 1.2028e-05 1.20095775282709
+ 1.203e-05 1.20090715965029
+ 1.2032e-05 1.20083292274811
+ 1.2034e-05 1.20056253317493
+ 1.2036e-05 1.20046212787449
+ 1.2038e-05 1.20027600578216
+ 1.204e-05 1.20066405684006
+ 1.2042e-05 1.19996049729688
+ 1.2044e-05 1.20024452860436
+ 1.2046e-05 1.20064459576504
+ 1.2048e-05 1.20061080099471
+ 1.205e-05 1.20057736046775
+ 1.2052e-05 1.20070152162845
+ 1.2054e-05 1.20056590218923
+ 1.2056e-05 1.20020883096533
+ 1.2058e-05 1.20009252108042
+ 1.206e-05 1.20023480674881
+ 1.2062e-05 1.20033518309086
+ 1.2064e-05 1.20052295666519
+ 1.2066e-05 1.20071703020972
+ 1.2068e-05 1.20065389596718
+ 1.207e-05 1.20051335876708
+ 1.2072e-05 1.20061785558682
+ 1.2074e-05 1.20070092463626
+ 1.2076e-05 1.20089240881151
+ 1.2078e-05 1.2008364768277
+ 1.208e-05 1.2008112488662
+ 1.2082e-05 1.20087603706403
+ 1.2084e-05 1.20114389251084
+ 1.2086e-05 1.20097023528959
+ 1.2088e-05 1.2008189360863
+ 1.209e-05 1.20104263673039
+ 1.2092e-05 1.20106739988192
+ 1.2094e-05 1.20114564970931
+ 1.2096e-05 1.20101100345078
+ 1.2098e-05 1.20135758326135
+ 1.21e-05 1.20139003767659
+ 1.2102e-05 1.20140919947887
+ 1.2104e-05 1.20127290770496
+ 1.2106e-05 1.2009451398689
+ 1.2108e-05 1.20085422059044
+ 1.211e-05 1.20063911271317
+ 1.2112e-05 1.20053940636561
+ 1.2114e-05 1.20069733140627
+ 1.2116e-05 1.20077835733585
+ 1.2118e-05 1.20057386801013
+ 1.212e-05 1.20036744551386
+ 1.2122e-05 1.20006282234132
+ 1.2124e-05 1.2000379862683
+ 1.2126e-05 1.20040483792802
+ 1.2128e-05 1.20024404427711
+ 1.213e-05 1.20037926448657
+ 1.2132e-05 1.20015151997155
+ 1.2134e-05 1.20005386575985
+ 1.2136e-05 1.2002405847195
+ 1.2138e-05 1.20025340227268
+ 1.214e-05 1.20023285197583
+ 1.2142e-05 1.20050510956995
+ 1.2144e-05 1.20035971264643
+ 1.2146e-05 1.2000205002196
+ 1.2148e-05 1.20017755427435
+ 1.215e-05 1.20032910121321
+ 1.2152e-05 1.20037587517314
+ 1.2154e-05 1.20051401815545
+ 1.2156e-05 1.20035166300308
+ 1.2158e-05 1.20043821764097
+ 1.216e-05 1.20033404508652
+ 1.2162e-05 1.20043375056462
+ 1.2164e-05 1.20046810704657
+ 1.2166e-05 1.20012173042986
+ 1.2168e-05 1.20030761701923
+ 1.217e-05 1.20034699835456
+ 1.2172e-05 1.20055974626509
+ 1.2174e-05 1.20059044738391
+ 1.2176e-05 1.20077239708909
+ 1.2178e-05 1.20084677177739
+ 1.218e-05 1.20066795424353
+ 1.2182e-05 1.20050179107143
+ 1.2184e-05 1.20037347589902
+ 1.2186e-05 1.20037319809499
+ 1.2188e-05 1.20030967011328
+ 1.219e-05 1.20053931101722
+ 1.2192e-05 1.20034647709786
+ 1.2194e-05 1.20014734630701
+ 1.2196e-05 1.19985464428671
+ 1.2198e-05 1.1995339706595
+ 1.22e-05 1.19923739874613
+ 1.2202e-05 1.19928196910788
+ 1.2204e-05 1.19944868948382
+ 1.2206e-05 1.19953976896232
+ 1.2208e-05 1.19935155211701
+ 1.221e-05 1.199524768566
+ 1.2212e-05 1.19941164149364
+ 1.2214e-05 1.19943528413589
+ 1.2216e-05 1.19968699895127
+ 1.2218e-05 1.19957167411335
+ 1.222e-05 1.19987006143115
+ 1.2222e-05 1.20003979915419
+ 1.2224e-05 1.19975215134996
+ 1.2226e-05 1.20011559206286
+ 1.2228e-05 1.20022395362717
+ 1.223e-05 1.20018104813716
+ 1.2232e-05 1.20030795395925
+ 1.2234e-05 1.20043817359546
+ 1.2236e-05 1.20031326464403
+ 1.2238e-05 1.20052973507114
+ 1.224e-05 1.20081252781589
+ 1.2242e-05 1.20136959099368
+ 1.2244e-05 1.20105780072981
+ 1.2246e-05 1.20071076814838
+ 1.2248e-05 1.20089712731783
+ 1.225e-05 1.20097355115236
+ 1.2252e-05 1.2008362133045
+ 1.2254e-05 1.20117246675768
+ 1.2256e-05 1.20121645028299
+ 1.2258e-05 1.20140853958891
+ 1.226e-05 1.20120350202509
+ 1.2262e-05 1.2008967317086
+ 1.2264e-05 1.20148337845846
+ 1.2266e-05 1.20150026814623
+ 1.2268e-05 1.20135113415633
+ 1.227e-05 1.20100130369617
+ 1.2272e-05 1.20082718468168
+ 1.2274e-05 1.20090285470429
+ 1.2276e-05 1.20083360245616
+ 1.2278e-05 1.2009737440819
+ 1.228e-05 1.20094839832082
+ 1.2282e-05 1.20133101705574
+ 1.2284e-05 1.20124753217256
+ 1.2286e-05 1.20048999636973
+ 1.2288e-05 1.20048214503672
+ 1.229e-05 1.20035466582927
+ 1.2292e-05 1.20053369702385
+ 1.2294e-05 1.20035773303105
+ 1.2296e-05 1.20031090574902
+ 1.2298e-05 1.20023145681874
+ 1.23e-05 1.20007423713883
+ 1.2302e-05 1.2001564617942
+ 1.2304e-05 1.2000729310144
+ 1.2306e-05 1.20027433356114
+ 1.2308e-05 1.20012509861158
+ 1.231e-05 1.2000615220754
+ 1.2312e-05 1.19994036180278
+ 1.2314e-05 1.19974675874045
+ 1.2316e-05 1.19928828478515
+ 1.2318e-05 1.19935979026949
+ 1.232e-05 1.19949969035371
+ 1.2322e-05 1.19951735624461
+ 1.2324e-05 1.1994590165208
+ 1.2326e-05 1.19945026679596
+ 1.2328e-05 1.19985935388575
+ 1.233e-05 1.19982280978657
+ 1.2332e-05 1.19980855239408
+ 1.2334e-05 1.1995208086204
+ 1.2336e-05 1.19940345314409
+ 1.2338e-05 1.19963833730405
+ 1.234e-05 1.19921318556431
+ 1.2342e-05 1.19933036855028
+ 1.2344e-05 1.19935339311782
+ 1.2346e-05 1.19946015220187
+ 1.2348e-05 1.19917091596738
+ 1.235e-05 1.19913697344595
+ 1.2352e-05 1.19909993114652
+ 1.2354e-05 1.19919715516781
+ 1.2356e-05 1.19901166300567
+ 1.2358e-05 1.19889942814635
+ 1.236e-05 1.19875700789734
+ 1.2362e-05 1.19873509544385
+ 1.2364e-05 1.19860632455426
+ 1.2366e-05 1.1987584915361
+ 1.2368e-05 1.19864368804201
+ 1.237e-05 1.19881951555977
+ 1.2372e-05 1.19864772458474
+ 1.2374e-05 1.19873735811437
+ 1.2376e-05 1.19844569997631
+ 1.2378e-05 1.19868664986089
+ 1.238e-05 1.19895880542409
+ 1.2382e-05 1.1989006343983
+ 1.2384e-05 1.19912264154607
+ 1.2386e-05 1.19904227870848
+ 1.2388e-05 1.19892075510891
+ 1.239e-05 1.19882508371936
+ 1.2392e-05 1.19889090638852
+ 1.2394e-05 1.19874575056985
+ 1.2396e-05 1.19865280058362
+ 1.2398e-05 1.19894514896024
+ 1.24e-05 1.1984562332948
+ 1.2402e-05 1.19865782841086
+ 1.2404e-05 1.19870171595037
+ 1.2406e-05 1.19887767508674
+ 1.2408e-05 1.19890359351543
+ 1.241e-05 1.19857328821005
+ 1.2412e-05 1.19855871663238
+ 1.2414e-05 1.19847807748412
+ 1.2416e-05 1.19851348276037
+ 1.2418e-05 1.19850302877696
+ 1.242e-05 1.19847040311497
+ 1.2422e-05 1.19860837810249
+ 1.2424e-05 1.19820244705515
+ 1.2426e-05 1.19824329658941
+ 1.2428e-05 1.19813154601794
+ 1.243e-05 1.19840044007895
+ 1.2432e-05 1.19831228975364
+ 1.2434e-05 1.19861208684794
+ 1.2436e-05 1.19867842748987
+ 1.2438e-05 1.19839353171548
+ 1.244e-05 1.19856997234749
+ 1.2442e-05 1.19891340775172
+ 1.2444e-05 1.19889016930645
+ 1.2446e-05 1.19877059358534
+ 1.2448e-05 1.1989249544398
+ 1.245e-05 1.19920944480358
+ 1.2452e-05 1.19929559982384
+ 1.2454e-05 1.19927339124927
+ 1.2456e-05 1.19926567089302
+ 1.2458e-05 1.1991352695227
+ 1.246e-05 1.19922262732342
+ 1.2462e-05 1.19907429284582
+ 1.2464e-05 1.199203282092
+ 1.2466e-05 1.19904510504241
+ 1.2468e-05 1.19919245981106
+ 1.247e-05 1.19913196894984
+ 1.2472e-05 1.19916537242741
+ 1.2474e-05 1.19899701727966
+ 1.2476e-05 1.19895031636854
+ 1.2478e-05 1.19890208132247
+ 1.248e-05 1.1989676398771
+ 1.2482e-05 1.19891126976571
+ 1.2484e-05 1.19938154597172
+ 1.2486e-05 1.19940200614994
+ 1.2488e-05 1.19953792211733
+ 1.249e-05 1.19967401926469
+ 1.2492e-05 1.19989984250628
+ 1.2494e-05 1.19993401932924
+ 1.2496e-05 1.19991964793113
+ 1.2498e-05 1.20026031437321
+ 1.25e-05 1.20041721907184
+ 1.2502e-05 1.20055581319699
+ 1.2504e-05 1.20094327674858
+ 1.2506e-05 1.20128396786774
+ 1.2508e-05 1.20142482167409
+ 1.251e-05 1.20150875222978
+ 1.2512e-05 1.20150400679358
+ 1.2514e-05 1.20139655435343
+ 1.2516e-05 1.20158854754485
+ 1.2518e-05 1.20170160639044
+ 1.252e-05 1.20188958641084
+ 1.2522e-05 1.20203297393076
+ 1.2524e-05 1.20208229624183
+ 1.2526e-05 1.20197937985709
+ 1.2528e-05 1.20202619618638
+ 1.253e-05 1.20229092952777
+ 1.2532e-05 1.20235247141062
+ 1.2534e-05 1.20235783914937
+ 1.2536e-05 1.20218067883599
+ 1.2538e-05 1.20194545466565
+ 1.254e-05 1.20195161210992
+ 1.2542e-05 1.20177107887066
+ 1.2544e-05 1.20185375244072
+ 1.2546e-05 1.20150334918827
+ 1.2548e-05 1.20134637562786
+ 1.255e-05 1.20152540425503
+ 1.2552e-05 1.20155541911933
+ 1.2554e-05 1.20150730440729
+ 1.2556e-05 1.20158987452985
+ 1.2558e-05 1.20165966767505
+ 1.256e-05 1.20154136998193
+ 1.2562e-05 1.20157640029207
+ 1.2564e-05 1.20156711047977
+ 1.2566e-05 1.2015885323816
+ 1.2568e-05 1.20178031177384
+ 1.257e-05 1.20183501755169
+ 1.2572e-05 1.20199448229226
+ 1.2574e-05 1.20143479507164
+ 1.2576e-05 1.20133634392315
+ 1.2578e-05 1.20148167386131
+ 1.258e-05 1.20154884176884
+ 1.2582e-05 1.20119200796759
+ 1.2584e-05 1.20121884778414
+ 1.2586e-05 1.20157215792791
+ 1.2588e-05 1.20114948658912
+ 1.259e-05 1.20116504184901
+ 1.2592e-05 1.20083650675312
+ 1.2594e-05 1.20093487845577
+ 1.2596e-05 1.2008963654889
+ 1.2598e-05 1.20084363901593
+ 1.26e-05 1.20065723413315
+ 1.2602e-05 1.20056156103342
+ 1.2604e-05 1.20052327833467
+ 1.2606e-05 1.20054191541124
+ 1.2608e-05 1.20056865439534
+ 1.261e-05 1.20054620907286
+ 1.2612e-05 1.20055461607178
+ 1.2614e-05 1.20032696695036
+ 1.2616e-05 1.20055733705168
+ 1.2618e-05 1.20030768813197
+ 1.262e-05 1.20007038631194
+ 1.2622e-05 1.20045631939696
+ 1.2624e-05 1.20055902053405
+ 1.2626e-05 1.20080902265024
+ 1.2628e-05 1.20089549724641
+ 1.263e-05 1.20089287585244
+ 1.2632e-05 1.20087880248711
+ 1.2634e-05 1.20078499579408
+ 1.2636e-05 1.2007868780646
+ 1.2638e-05 1.20073178341465
+ 1.264e-05 1.20094774964811
+ 1.2642e-05 1.20081337844054
+ 1.2644e-05 1.20099472384091
+ 1.2646e-05 1.20077360803271
+ 1.2648e-05 1.20070489468414
+ 1.265e-05 1.20048214404204
+ 1.2652e-05 1.20047990994482
+ 1.2654e-05 1.20064472192701
+ 1.2656e-05 1.20057134815083
+ 1.2658e-05 1.20051428695237
+ 1.266e-05 1.20049331328046
+ 1.2662e-05 1.200180959434
+ 1.2664e-05 1.20011149435083
+ 1.2666e-05 1.2002892920135
+ 1.2668e-05 1.20002602373864
+ 1.267e-05 1.20031876229355
+ 1.2672e-05 1.20043998205645
+ 1.2674e-05 1.20023113820618
+ 1.2676e-05 1.20002859863124
+ 1.2678e-05 1.20016848643267
+ 1.268e-05 1.2003512876519
+ 1.2682e-05 1.20090943171909
+ 1.2684e-05 1.20110267176483
+ 1.2686e-05 1.20094624173808
+ 1.2688e-05 1.20091060648804
+ 1.269e-05 1.20127071402633
+ 1.2692e-05 1.2011883908199
+ 1.2694e-05 1.2010176695467
+ 1.2696e-05 1.20124166089805
+ 1.2698e-05 1.20082991036847
+ 1.27e-05 1.20086949097317
+ 1.2702e-05 1.20071619038093
+ 1.2704e-05 1.20057473937996
+ 1.2706e-05 1.20053621731683
+ 1.2708e-05 1.20017821466423
+ 1.271e-05 1.20021989498438
+ 1.2712e-05 1.20025239167645
+ 1.2714e-05 1.20022338882876
+ 1.2716e-05 1.20067761199448
+ 1.2718e-05 1.20081762773621
+ 1.272e-05 1.20080557025435
+ 1.2722e-05 1.2006061456202
+ 1.2724e-05 1.20077968951702
+ 1.2726e-05 1.20074695094497
+ 1.2728e-05 1.20078832396445
+ 1.273e-05 1.2006063985573
+ 1.2732e-05 1.2008175677539
+ 1.2734e-05 1.20067522575545
+ 1.2736e-05 1.20044947509594
+ 1.2738e-05 1.20052998023255
+ 1.274e-05 1.20072780077404
+ 1.2742e-05 1.2005320454362
+ 1.2744e-05 1.20066846055019
+ 1.2746e-05 1.20097776767295
+ 1.2748e-05 1.2009997876946
+ 1.275e-05 1.20124299321267
+ 1.2752e-05 1.20131758675414
+ 1.2754e-05 1.20104410163787
+ 1.2756e-05 1.20079490899279
+ 1.2758e-05 1.20076216363186
+ 1.276e-05 1.2004696894789
+ 1.2762e-05 1.20051470127892
+ 1.2764e-05 1.20055919088909
+ 1.2766e-05 1.20056472964243
+ 1.2768e-05 1.2004096929919
+ 1.277e-05 1.20046950206761
+ 1.2772e-05 1.20033596465441
+ 1.2774e-05 1.20079904788779
+ 1.2776e-05 1.20072434053712
+ 1.2778e-05 1.20073337220562
+ 1.278e-05 1.2004430756002
+ 1.2782e-05 1.20013090957062
+ 1.2784e-05 1.1998194516922
+ 1.2786e-05 1.19953830438716
+ 1.2788e-05 1.19925301179211
+ 1.279e-05 1.19915498904624
+ 1.2792e-05 1.19933147935876
+ 1.2794e-05 1.19937814413899
+ 1.2796e-05 1.19934140028891
+ 1.2798e-05 1.19973657183163
+ 1.28e-05 1.20009941058426
+ 1.2802e-05 1.20009558773302
+ 1.2804e-05 1.20009097277245
+ 1.2806e-05 1.19974306715754
+ 1.2808e-05 1.19997805373549
+ 1.281e-05 1.20030150932714
+ 1.2812e-05 1.20047461897191
+ 1.2814e-05 1.20051173145331
+ 1.2816e-05 1.20078797977766
+ 1.2818e-05 1.20101215167906
+ 1.282e-05 1.20112352508304
+ 1.2822e-05 1.20125635159983
+ 1.2824e-05 1.20114635381666
+ 1.2826e-05 1.2010110599295
+ 1.2828e-05 1.20086805209802
+ 1.283e-05 1.20081019940953
+ 1.2832e-05 1.20052916522376
+ 1.2834e-05 1.20047275720203
+ 1.2836e-05 1.20069820061719
+ 1.2838e-05 1.20052361811501
+ 1.284e-05 1.20097154484679
+ 1.2842e-05 1.20096878901868
+ 1.2844e-05 1.20103234597421
+ 1.2846e-05 1.20119120724286
+ 1.2848e-05 1.20115751779191
+ 1.285e-05 1.20095635471869
+ 1.2852e-05 1.20073763790396
+ 1.2854e-05 1.20046034185394
+ 1.2856e-05 1.20048860764751
+ 1.2858e-05 1.20037786146327
+ 1.286e-05 1.20044362411435
+ 1.2862e-05 1.2005414294859
+ 1.2864e-05 1.20030307891411
+ 1.2866e-05 1.20024917298132
+ 1.2868e-05 1.19988175183271
+ 1.287e-05 1.20016841906545
+ 1.2872e-05 1.20032128654541
+ 1.2874e-05 1.20021020771723
+ 1.2876e-05 1.200395824797
+ 1.2878e-05 1.20016528455074
+ 1.288e-05 1.2002334930263
+ 1.2882e-05 1.20036297443688
+ 1.2884e-05 1.20034517133156
+ 1.2886e-05 1.20058721834396
+ 1.2888e-05 1.20037751783333
+ 1.289e-05 1.20071503264285
+ 1.2892e-05 1.20066376687039
+ 1.2894e-05 1.20053487077339
+ 1.2896e-05 1.20040595961432
+ 1.2898e-05 1.20037532878071
+ 1.29e-05 1.20049698135564
+ 1.2902e-05 1.20039730362569
+ 1.2904e-05 1.20038075063059
+ 1.2906e-05 1.20022600074314
+ 1.2908e-05 1.1997315792397
+ 1.291e-05 1.19986058233103
+ 1.2912e-05 1.19985070840589
+ 1.2914e-05 1.19990542622802
+ 1.2916e-05 1.19989118756802
+ 1.2918e-05 1.1998012949876
+ 1.292e-05 1.19964561669743
+ 1.2922e-05 1.199952250227
+ 1.2924e-05 1.19988714895578
+ 1.2926e-05 1.19991124343293
+ 1.2928e-05 1.19988623333221
+ 1.293e-05 1.19992701798593
+ 1.2932e-05 1.19997823005496
+ 1.2934e-05 1.20012983460112
+ 1.2936e-05 1.20021779804034
+ 1.2938e-05 1.20033627773846
+ 1.294e-05 1.20088502263845
+ 1.2942e-05 1.20075955049488
+ 1.2944e-05 1.20094621351357
+ 1.2946e-05 1.20067245887783
+ 1.2948e-05 1.20061380469846
+ 1.295e-05 1.20044900983597
+ 1.2952e-05 1.20019910892093
+ 1.2954e-05 1.19972638961853
+ 1.2956e-05 1.19958926548449
+ 1.2958e-05 1.19978686796997
+ 1.296e-05 1.19975543708635
+ 1.2962e-05 1.1993703701249
+ 1.2964e-05 1.19900438315415
+ 1.2966e-05 1.1989311140816
+ 1.2968e-05 1.19905005700976
+ 1.297e-05 1.19890865956916
+ 1.2972e-05 1.19948813360453
+ 1.2974e-05 1.19945914910953
+ 1.2976e-05 1.19946484569865
+ 1.2978e-05 1.19893901131469
+ 1.298e-05 1.19903599675466
+ 1.2982e-05 1.19900069099731
+ 1.2984e-05 1.19857727813942
+ 1.2986e-05 1.19866917682953
+ 1.2988e-05 1.19859257076556
+ 1.299e-05 1.19857955877944
+ 1.2992e-05 1.19881444303778
+ 1.2994e-05 1.19883044554486
+ 1.2996e-05 1.19906089132383
+ 1.2998e-05 1.19910449176374
+ 1.3e-05 1.19900482598897
+ 1.3002e-05 1.19891399920671
+ 1.3004e-05 1.19927945535001
+ 1.3006e-05 1.19956546383455
+ 1.3008e-05 1.19931601442803
+ 1.301e-05 1.19882508735188
+ 1.3012e-05 1.19880658956937
+ 1.3014e-05 1.19893790964682
+ 1.3016e-05 1.1989212691755
+ 1.3018e-05 1.19887232152898
+ 1.302e-05 1.19899420665126
+ 1.3022e-05 1.19868754589798
+ 1.3024e-05 1.19861067426149
+ 1.3026e-05 1.19849639427539
+ 1.3028e-05 1.19814761907423
+ 1.303e-05 1.19824110389878
+ 1.3032e-05 1.19839221024239
+ 1.3034e-05 1.19860755410327
+ 1.3036e-05 1.19846429510971
+ 1.3038e-05 1.19831316448432
+ 1.304e-05 1.19829130830451
+ 1.3042e-05 1.19892671671858
+ 1.3044e-05 1.19886260548808
+ 1.3046e-05 1.1988900113565
+ 1.3048e-05 1.19871495154692
+ 1.305e-05 1.19885544335078
+ 1.3052e-05 1.19865167554022
+ 1.3054e-05 1.19918730126178
+ 1.3056e-05 1.19910605773537
+ 1.3058e-05 1.19941924206556
+ 1.306e-05 1.19961964698678
+ 1.3062e-05 1.19988094445845
+ 1.3064e-05 1.20014161485503
+ 1.3066e-05 1.20011378308455
+ 1.3068e-05 1.19994456799018
+ 1.307e-05 1.19982514227709
+ 1.3072e-05 1.19970018645369
+ 1.3074e-05 1.19953547393486
+ 1.3076e-05 1.19933589724737
+ 1.3078e-05 1.19931474581615
+ 1.308e-05 1.19943974581061
+ 1.3082e-05 1.1991008560856
+ 1.3084e-05 1.19933713047135
+ 1.3086e-05 1.19941989886853
+ 1.3088e-05 1.19939868630561
+ 1.309e-05 1.19914441729678
+ 1.3092e-05 1.19916391742781
+ 1.3094e-05 1.19934710922203
+ 1.3096e-05 1.19931446358027
+ 1.3098e-05 1.19934591452708
+ 1.31e-05 1.19928687087176
+ 1.3102e-05 1.19930216200311
+ 1.3104e-05 1.19893314558179
+ 1.3106e-05 1.1989889751468
+ 1.3108e-05 1.19903427127442
+ 1.311e-05 1.19921627748106
+ 1.3112e-05 1.19939581727056
+ 1.3114e-05 1.19931432863064
+ 1.3116e-05 1.19928761171074
+ 1.3118e-05 1.19901713768863
+ 1.312e-05 1.19870330587705
+ 1.3122e-05 1.19886599715622
+ 1.3124e-05 1.19916770179167
+ 1.3126e-05 1.19916385271112
+ 1.3128e-05 1.19924130588439
+ 1.313e-05 1.19901288843401
+ 1.3132e-05 1.19915745267205
+ 1.3134e-05 1.19943070271948
+ 1.3136e-05 1.19936167627923
+ 1.3138e-05 1.19939272395529
+ 1.314e-05 1.19961483049637
+ 1.3142e-05 1.19929403306558
+ 1.3144e-05 1.19933736946888
+ 1.3146e-05 1.19946847553919
+ 1.3148e-05 1.19960186954246
+ 1.315e-05 1.19989683319595
+ 1.3152e-05 1.20011347211829
+ 1.3154e-05 1.1998949226406
+ 1.3156e-05 1.19977920061552
+ 1.3158e-05 1.19969168051577
+ 1.316e-05 1.19989151502543
+ 1.3162e-05 1.20013531144124
+ 1.3164e-05 1.20003529082053
+ 1.3166e-05 1.20036865600302
+ 1.3168e-05 1.20023946102057
+ 1.317e-05 1.19988611322658
+ 1.3172e-05 1.19966596658934
+ 1.3174e-05 1.19973987376984
+ 1.3176e-05 1.19991532983604
+ 1.3178e-05 1.2002348666059
+ 1.318e-05 1.20004614004962
+ 1.3182e-05 1.20012276176297
+ 1.3184e-05 1.20017096698717
+ 1.3186e-05 1.20001837540762
+ 1.3188e-05 1.19990192250288
+ 1.319e-05 1.19995748151457
+ 1.3192e-05 1.20039085118008
+ 1.3194e-05 1.20029282147578
+ 1.3196e-05 1.20047601373405
+ 1.3198e-05 1.20043409375822
+ 1.32e-05 1.20043869831074
+ 1.3202e-05 1.20087849782868
+ 1.3204e-05 1.20085756530482
+ 1.3206e-05 1.20098794826601
+ 1.3208e-05 1.20132383811496
+ 1.321e-05 1.20143024270086
+ 1.3212e-05 1.20156071647848
+ 1.3214e-05 1.20176540146117
+ 1.3216e-05 1.20195829651124
+ 1.3218e-05 1.20181928081731
+ 1.322e-05 1.20172308104175
+ 1.3222e-05 1.20173681942954
+ 1.3224e-05 1.20204322121942
+ 1.3226e-05 1.20189420359047
+ 1.3228e-05 1.20206941336602
+ 1.323e-05 1.20214736599498
+ 1.3232e-05 1.20187234534084
+ 1.3234e-05 1.20174922469306
+ 1.3236e-05 1.20165445761591
+ 1.3238e-05 1.20173506716599
+ 1.324e-05 1.20172148230199
+ 1.3242e-05 1.20167667834805
+ 1.3244e-05 1.20116805981551
+ 1.3246e-05 1.20079714175165
+ 1.3248e-05 1.20074598738668
+ 1.325e-05 1.20036327278492
+ 1.3252e-05 1.2004750219751
+ 1.3254e-05 1.2006140555899
+ 1.3256e-05 1.20022537403874
+ 1.3258e-05 1.20018167549535
+ 1.326e-05 1.20035411379748
+ 1.3262e-05 1.20018899435254
+ 1.3264e-05 1.20009097479157
+ 1.3266e-05 1.20030175446708
+ 1.3268e-05 1.20031701136905
+ 1.327e-05 1.20009582192509
+ 1.3272e-05 1.2004189962379
+ 1.3274e-05 1.20050083832532
+ 1.3276e-05 1.20038882893354
+ 1.3278e-05 1.20061670423655
+ 1.328e-05 1.20059760906016
+ 1.3282e-05 1.2005533866297
+ 1.3284e-05 1.20037571867751
+ 1.3286e-05 1.20053691355691
+ 1.3288e-05 1.20045927381624
+ 1.329e-05 1.20035382338485
+ 1.3292e-05 1.20041088179948
+ 1.3294e-05 1.2003646697589
+ 1.3296e-05 1.20019242818981
+ 1.3298e-05 1.20045975658902
+ 1.33e-05 1.20038051919706
+ 1.3302e-05 1.20050963552477
+ 1.3304e-05 1.20038007824393
+ 1.3306e-05 1.20056792909874
+ 1.3308e-05 1.20070889654514
+ 1.331e-05 1.20086082594951
+ 1.3312e-05 1.20081710557708
+ 1.3314e-05 1.20105904277229
+ 1.3316e-05 1.20106611529649
+ 1.3318e-05 1.20110586680793
+ 1.332e-05 1.20104484487432
+ 1.3322e-05 1.20114105314931
+ 1.3324e-05 1.2012227957692
+ 1.3326e-05 1.20128077880091
+ 1.3328e-05 1.20108736360381
+ 1.333e-05 1.20099645352696
+ 1.3332e-05 1.20117416288521
+ 1.3334e-05 1.20103504743634
+ 1.3336e-05 1.20090956336556
+ 1.3338e-05 1.20108311801073
+ 1.334e-05 1.2012824644471
+ 1.3342e-05 1.20118230922999
+ 1.3344e-05 1.20099438422184
+ 1.3346e-05 1.20086221135434
+ 1.3348e-05 1.20107019563848
+ 1.335e-05 1.20127948026989
+ 1.3352e-05 1.2016525974741
+ 1.3354e-05 1.20162681349201
+ 1.3356e-05 1.20144402789176
+ 1.3358e-05 1.20112723326798
+ 1.336e-05 1.20092919257519
+ 1.3362e-05 1.20064506073917
+ 1.3364e-05 1.20100953235405
+ 1.3366e-05 1.20078422649795
+ 1.3368e-05 1.2007324285804
+ 1.337e-05 1.20064045622896
+ 1.3372e-05 1.20030121456118
+ 1.3374e-05 1.20032829943239
+ 1.3376e-05 1.20013514314126
+ 1.3378e-05 1.20024498252581
+ 1.338e-05 1.20004038243003
+ 1.3382e-05 1.20024974171815
+ 1.3384e-05 1.20031972587616
+ 1.3386e-05 1.20022311197418
+ 1.3388e-05 1.2004493762416
+ 1.339e-05 1.20009072315812
+ 1.3392e-05 1.20025186298545
+ 1.3394e-05 1.20021761438771
+ 1.3396e-05 1.20027811897799
+ 1.3398e-05 1.20040262005447
+ 1.34e-05 1.20028427623873
+ 1.3402e-05 1.2000845128405
+ 1.3404e-05 1.19986628535322
+ 1.3406e-05 1.19978686763987
+ 1.3408e-05 1.19991093118215
+ 1.341e-05 1.19995356345501
+ 1.3412e-05 1.19984575524334
+ 1.3414e-05 1.19955407626333
+ 1.3416e-05 1.19931360396961
+ 1.3418e-05 1.1995590106862
+ 1.342e-05 1.19979572319589
+ 1.3422e-05 1.1998095415595
+ 1.3424e-05 1.19924596085206
+ 1.3426e-05 1.1993033092504
+ 1.3428e-05 1.19936705561803
+ 1.343e-05 1.19941514283666
+ 1.3432e-05 1.19955775331141
+ 1.3434e-05 1.19954661036824
+ 1.3436e-05 1.19963267629633
+ 1.3438e-05 1.19933305068476
+ 1.344e-05 1.19942939400773
+ 1.3442e-05 1.19968475394257
+ 1.3444e-05 1.19983179029269
+ 1.3446e-05 1.19990371746824
+ 1.3448e-05 1.19971022163031
+ 1.345e-05 1.19954546403429
+ 1.3452e-05 1.1997281971009
+ 1.3454e-05 1.1996932291674
+ 1.3456e-05 1.20004410635828
+ 1.3458e-05 1.19999425326102
+ 1.346e-05 1.19977154564225
+ 1.3462e-05 1.19975460220157
+ 1.3464e-05 1.19948243286249
+ 1.3466e-05 1.19932739110829
+ 1.3468e-05 1.19934347303998
+ 1.347e-05 1.19903762820933
+ 1.3472e-05 1.19918881043027
+ 1.3474e-05 1.19908521436668
+ 1.3476e-05 1.19924290771237
+ 1.3478e-05 1.19896503387066
+ 1.348e-05 1.1989809271963
+ 1.3482e-05 1.19959910272086
+ 1.3484e-05 1.19948516594005
+ 1.3486e-05 1.19954923460245
+ 1.3488e-05 1.1998536009191
+ 1.349e-05 1.19968513979854
+ 1.3492e-05 1.20004685737468
+ 1.3494e-05 1.200033897899
+ 1.3496e-05 1.19982465121985
+ 1.3498e-05 1.19934984544872
+ 1.35e-05 1.19953208247601
+ 1.3502e-05 1.19958062791823
+ 1.3504e-05 1.19978102519466
+ 1.3506e-05 1.19980713573564
+ 1.3508e-05 1.1999823812703
+ 1.351e-05 1.20009443087562
+ 1.3512e-05 1.20030853405205
+ 1.3514e-05 1.20008037410081
+ 1.3516e-05 1.2002639869471
+ 1.3518e-05 1.20017529779201
+ 1.352e-05 1.20038043007779
+ 1.3522e-05 1.20068024932275
+ 1.3524e-05 1.20056762707959
+ 1.3526e-05 1.20087729062144
+ 1.3528e-05 1.20098255805745
+ 1.353e-05 1.20121875615226
+ 1.3532e-05 1.20155741263709
+ 1.3534e-05 1.20151640445306
+ 1.3536e-05 1.20166470199649
+ 1.3538e-05 1.20174399036465
+ 1.354e-05 1.20160930612449
+ 1.3542e-05 1.20159531833875
+ 1.3544e-05 1.20126541873433
+ 1.3546e-05 1.20145679406267
+ 1.3548e-05 1.20158675990868
+ 1.355e-05 1.20131660547344
+ 1.3552e-05 1.20084614382954
+ 1.3554e-05 1.20103603341067
+ 1.3556e-05 1.20114634663558
+ 1.3558e-05 1.20118017504377
+ 1.356e-05 1.20105726579193
+ 1.3562e-05 1.20081444676028
+ 1.3564e-05 1.20104789371812
+ 1.3566e-05 1.20059840160199
+ 1.3568e-05 1.20079235261285
+ 1.357e-05 1.20061428660842
+ 1.3572e-05 1.20073563262933
+ 1.3574e-05 1.20053496904292
+ 1.3576e-05 1.20048550862893
+ 1.3578e-05 1.20012157264138
+ 1.358e-05 1.20010843806783
+ 1.3582e-05 1.19973454624488
+ 1.3584e-05 1.19963905173371
+ 1.3586e-05 1.19935976696155
+ 1.3588e-05 1.19930984413355
+ 1.359e-05 1.19933414073074
+ 1.3592e-05 1.19905117456944
+ 1.3594e-05 1.19888818800261
+ 1.3596e-05 1.19890216696337
+ 1.3598e-05 1.19885912878281
+ 1.36e-05 1.19904386741238
+ 1.3602e-05 1.19888189724783
+ 1.3604e-05 1.19875377434943
+ 1.3606e-05 1.19880901799053
+ 1.3608e-05 1.19914465691857
+ 1.361e-05 1.19906203188149
+ 1.3612e-05 1.19884342471644
+ 1.3614e-05 1.19867006903309
+ 1.3616e-05 1.19862229491889
+ 1.3618e-05 1.19855011831122
+ 1.362e-05 1.198768792874
+ 1.3622e-05 1.19906223470208
+ 1.3624e-05 1.19908966099691
+ 1.3626e-05 1.19929028922419
+ 1.3628e-05 1.19924182780309
+ 1.363e-05 1.19924377688064
+ 1.3632e-05 1.19925633898775
+ 1.3634e-05 1.19900416057626
+ 1.3636e-05 1.19890737181139
+ 1.3638e-05 1.1989577487493
+ 1.364e-05 1.19900603302166
+ 1.3642e-05 1.19904121112554
+ 1.3644e-05 1.19905119220809
+ 1.3646e-05 1.19921751393044
+ 1.3648e-05 1.1995350765412
+ 1.365e-05 1.20001396469096
+ 1.3652e-05 1.19986273971873
+ 1.3654e-05 1.19987440492114
+ 1.3656e-05 1.19964843885021
+ 1.3658e-05 1.19954999255926
+ 1.366e-05 1.19949408507173
+ 1.3662e-05 1.19949970003807
+ 1.3664e-05 1.19936060007614
+ 1.3666e-05 1.19954772809961
+ 1.3668e-05 1.19954449653316
+ 1.367e-05 1.19951780870951
+ 1.3672e-05 1.19989860539479
+ 1.3674e-05 1.19979765046849
+ 1.3676e-05 1.19933117658646
+ 1.3678e-05 1.19964760136261
+ 1.368e-05 1.20003711543
+ 1.3682e-05 1.20034534309452
+ 1.3684e-05 1.20038571912527
+ 1.3686e-05 1.200303473054
+ 1.3688e-05 1.20010059140306
+ 1.369e-05 1.20011475910532
+ 1.3692e-05 1.20019530479983
+ 1.3694e-05 1.20024250112197
+ 1.3696e-05 1.20009279384377
+ 1.3698e-05 1.20014173806431
+ 1.37e-05 1.19994997890015
+ 1.3702e-05 1.20014219974183
+ 1.3704e-05 1.20011377226045
+ 1.3706e-05 1.19994844726118
+ 1.3708e-05 1.20016852779752
+ 1.371e-05 1.20053722812519
+ 1.3712e-05 1.20064254750469
+ 1.3714e-05 1.20045287390582
+ 1.3716e-05 1.20041826620941
+ 1.3718e-05 1.20073472455842
+ 1.372e-05 1.20107872263655
+ 1.3722e-05 1.20096528293091
+ 1.3724e-05 1.200978448501
+ 1.3726e-05 1.20077596684287
+ 1.3728e-05 1.20071494382877
+ 1.373e-05 1.20053540562895
+ 1.3732e-05 1.20044499796273
+ 1.3734e-05 1.20005802947113
+ 1.3736e-05 1.20015686338238
+ 1.3738e-05 1.20018751339658
+ 1.374e-05 1.19991603871216
+ 1.3742e-05 1.19984401245701
+ 1.3744e-05 1.19993545873754
+ 1.3746e-05 1.19959896438997
+ 1.3748e-05 1.1993611390155
+ 1.375e-05 1.19949377897528
+ 1.3752e-05 1.19959259569823
+ 1.3754e-05 1.19952679570241
+ 1.3756e-05 1.19968760179363
+ 1.3758e-05 1.19982818078843
+ 1.376e-05 1.1999173893669
+ 1.3762e-05 1.19989428142751
+ 1.3764e-05 1.19992772836233
+ 1.3766e-05 1.19981765639902
+ 1.3768e-05 1.1997709159046
+ 1.377e-05 1.19964835314781
+ 1.3772e-05 1.19993154599762
+ 1.3774e-05 1.20008588049002
+ 1.3776e-05 1.20028994098045
+ 1.3778e-05 1.20055668180674
+ 1.378e-05 1.20066472676738
+ 1.3782e-05 1.20064578616199
+ 1.3784e-05 1.20060108085233
+ 1.3786e-05 1.20057324356935
+ 1.3788e-05 1.20051504579317
+ 1.379e-05 1.20022232971297
+ 1.3792e-05 1.20049890536286
+ 1.3794e-05 1.20049522572757
+ 1.3796e-05 1.2004656470451
+ 1.3798e-05 1.20035021262194
+ 1.38e-05 1.20014315505077
+ 1.3802e-05 1.19972992494638
+ 1.3804e-05 1.1995747201978
+ 1.3806e-05 1.19982370060413
+ 1.3808e-05 1.1998374750176
+ 1.381e-05 1.20008996045512
+ 1.3812e-05 1.20020526292061
+ 1.3814e-05 1.20052486171406
+ 1.3816e-05 1.20023780629486
+ 1.3818e-05 1.20018662374114
+ 1.382e-05 1.20032402908819
+ 1.3822e-05 1.20060724677428
+ 1.3824e-05 1.2007581955519
+ 1.3826e-05 1.20087664983683
+ 1.3828e-05 1.20079377313407
+ 1.383e-05 1.20079552492526
+ 1.3832e-05 1.20052650778481
+ 1.3834e-05 1.20046968269676
+ 1.3836e-05 1.20031344137938
+ 1.3838e-05 1.20027519703972
+ 1.384e-05 1.20042404295825
+ 1.3842e-05 1.20038210174264
+ 1.3844e-05 1.20035005991912
+ 1.3846e-05 1.20000065509917
+ 1.3848e-05 1.20005113639639
+ 1.385e-05 1.20018902491129
+ 1.3852e-05 1.20020286308744
+ 1.3854e-05 1.20013148905456
+ 1.3856e-05 1.2005004844594
+ 1.3858e-05 1.20068719706099
+ 1.386e-05 1.20077269293827
+ 1.3862e-05 1.20107445296864
+ 1.3864e-05 1.20108740210495
+ 1.3866e-05 1.20119004959866
+ 1.3868e-05 1.20112260190982
+ 1.387e-05 1.20118963887714
+ 1.3872e-05 1.20068790431418
+ 1.3874e-05 1.20064863291776
+ 1.3876e-05 1.20057450876985
+ 1.3878e-05 1.20037116738534
+ 1.388e-05 1.20009504895817
+ 1.3882e-05 1.20013208634013
+ 1.3884e-05 1.2001410529411
+ 1.3886e-05 1.20034891683633
+ 1.3888e-05 1.20020223992437
+ 1.389e-05 1.20050393254825
+ 1.3892e-05 1.20033586984232
+ 1.3894e-05 1.20028363602913
+ 1.3896e-05 1.2005467307045
+ 1.3898e-05 1.20065318879821
+ 1.39e-05 1.20066216879118
+ 1.3902e-05 1.20059639657906
+ 1.3904e-05 1.20041802094496
+ 1.3906e-05 1.20031781441107
+ 1.3908e-05 1.2002145666407
+ 1.391e-05 1.20044878074505
+ 1.3912e-05 1.20048973499792
+ 1.3914e-05 1.20050880464664
+ 1.3916e-05 1.2004114818075
+ 1.3918e-05 1.20020514866585
+ 1.392e-05 1.20025841277391
+ 1.3922e-05 1.20037989922555
+ 1.3924e-05 1.20005951245284
+ 1.3926e-05 1.19987215773252
+ 1.3928e-05 1.19965902714341
+ 1.393e-05 1.19980737827282
+ 1.3932e-05 1.19977998986399
+ 1.3934e-05 1.19965037779876
+ 1.3936e-05 1.19960718042689
+ 1.3938e-05 1.19953239981276
+ 1.394e-05 1.19950951645691
+ 1.3942e-05 1.19914661074158
+ 1.3944e-05 1.19888805881506
+ 1.3946e-05 1.19853635489023
+ 1.3948e-05 1.19878475528495
+ 1.395e-05 1.19898816009456
+ 1.3952e-05 1.19905983153937
+ 1.3954e-05 1.19893941776855
+ 1.3956e-05 1.19889754711209
+ 1.3958e-05 1.19911948049318
+ 1.396e-05 1.19904319693808
+ 1.3962e-05 1.19934706777304
+ 1.3964e-05 1.19938740849618
+ 1.3966e-05 1.19874331430544
+ 1.3968e-05 1.19864961332607
+ 1.397e-05 1.1985951254058
+ 1.3972e-05 1.19872830847327
+ 1.3974e-05 1.19877898970663
+ 1.3976e-05 1.19854035836637
+ 1.3978e-05 1.1987681066849
+ 1.398e-05 1.19867814639333
+ 1.3982e-05 1.19838753170538
+ 1.3984e-05 1.19867129664198
+ 1.3986e-05 1.19869097012915
+ 1.3988e-05 1.19903525464305
+ 1.399e-05 1.19892294354036
+ 1.3992e-05 1.19899994420487
+ 1.3994e-05 1.19925740031346
+ 1.3996e-05 1.19885845167456
+ 1.3998e-05 1.19869955343376
+ 1.4e-05 1.19857455588993
+ 1.4002e-05 1.19874254022144
+ 1.4004e-05 1.19878525308799
+ 1.4006e-05 1.198782476292
+ 1.4008e-05 1.19877823124702
+ 1.401e-05 1.19886087848814
+ 1.4012e-05 1.19900379575173
+ 1.4014e-05 1.19894063328852
+ 1.4016e-05 1.19897154079633
+ 1.4018e-05 1.19931808854546
+ 1.402e-05 1.19916586550198
+ 1.4022e-05 1.19941014402488
+ 1.4024e-05 1.1994046960819
+ 1.4026e-05 1.19952450524168
+ 1.4028e-05 1.19953363917565
+ 1.403e-05 1.19903458512143
+ 1.4032e-05 1.1990588627759
+ 1.4034e-05 1.19860804713288
+ 1.4036e-05 1.19858493332595
+ 1.4038e-05 1.1984268986921
+ 1.404e-05 1.19848625928726
+ 1.4042e-05 1.19866850182359
+ 1.4044e-05 1.19881739067056
+ 1.4046e-05 1.19857220230278
+ 1.4048e-05 1.19853719035064
+ 1.405e-05 1.19837446713549
+ 1.4052e-05 1.1979865098087
+ 1.4054e-05 1.19809352546344
+ 1.4056e-05 1.19827294982183
+ 1.4058e-05 1.19800306091208
+ 1.406e-05 1.19811072435244
+ 1.4062e-05 1.197983707325
+ 1.4064e-05 1.19832059463713
+ 1.4066e-05 1.19858521731025
+ 1.4068e-05 1.19874361874136
+ 1.407e-05 1.19888544403457
+ 1.4072e-05 1.19901799448619
+ 1.4074e-05 1.19886251797828
+ 1.4076e-05 1.19862719300673
+ 1.4078e-05 1.19843019414755
+ 1.408e-05 1.1982220945466
+ 1.4082e-05 1.19825124590586
+ 1.4084e-05 1.19829454638395
+ 1.4086e-05 1.1982158024494
+ 1.4088e-05 1.19812215212914
+ 1.409e-05 1.19783463333101
+ 1.4092e-05 1.19811190706004
+ 1.4094e-05 1.19793155716664
+ 1.4096e-05 1.19789025369301
+ 1.4098e-05 1.19768410174587
+ 1.41e-05 1.19766486567953
+ 1.4102e-05 1.19773813407484
+ 1.4104e-05 1.197752276083
+ 1.4106e-05 1.19771595655714
+ 1.4108e-05 1.19814192909374
+ 1.411e-05 1.19808289301803
+ 1.4112e-05 1.19814739197929
+ 1.4114e-05 1.19787837771831
+ 1.4116e-05 1.19776942202229
+ 1.4118e-05 1.19787943269594
+ 1.412e-05 1.19779659469691
+ 1.4122e-05 1.19783612532456
+ 1.4124e-05 1.19786939438697
+ 1.4126e-05 1.19774355263413
+ 1.4128e-05 1.19779462738398
+ 1.413e-05 1.19759984378588
+ 1.4132e-05 1.19747949271288
+ 1.4134e-05 1.1975287252838
+ 1.4136e-05 1.19737140229854
+ 1.4138e-05 1.19744342627994
+ 1.414e-05 1.19755433982748
+ 1.4142e-05 1.19772893609663
+ 1.4144e-05 1.19752265976856
+ 1.4146e-05 1.19749040305495
+ 1.4148e-05 1.19761417567729
+ 1.415e-05 1.19725438350835
+ 1.4152e-05 1.19739315668628
+ 1.4154e-05 1.19762385186544
+ 1.4156e-05 1.19752721741065
+ 1.4158e-05 1.19746484966626
+ 1.416e-05 1.19726799445871
+ 1.4162e-05 1.19742268592649
+ 1.4164e-05 1.19736646177848
+ 1.4166e-05 1.19707510556644
+ 1.4168e-05 1.19692250491699
+ 1.417e-05 1.19700791727666
+ 1.4172e-05 1.19693434520204
+ 1.4174e-05 1.19682999773622
+ 1.4176e-05 1.19717395235858
+ 1.4178e-05 1.19723138565658
+ 1.418e-05 1.19739132404196
+ 1.4182e-05 1.19759572737764
+ 1.4184e-05 1.19780279272758
+ 1.4186e-05 1.19788240757317
+ 1.4188e-05 1.19774342408664
+ 1.419e-05 1.19805193736584
+ 1.4192e-05 1.19786988708948
+ 1.4194e-05 1.19816623233717
+ 1.4196e-05 1.19849024545421
+ 1.4198e-05 1.19819420468572
+ 1.42e-05 1.19815144263022
+ 1.4202e-05 1.19830905062855
+ 1.4204e-05 1.19851228727011
+ 1.4206e-05 1.19887230134473
+ 1.4208e-05 1.19883137165531
+ 1.421e-05 1.19884971392482
+ 1.4212e-05 1.19902854564335
+ 1.4214e-05 1.19933557695724
+ 1.4216e-05 1.1991048779225
+ 1.4218e-05 1.19928470897621
+ 1.422e-05 1.19945173630655
+ 1.4222e-05 1.19932843213072
+ 1.4224e-05 1.19953885500883
+ 1.4226e-05 1.19938512640393
+ 1.4228e-05 1.19904947019377
+ 1.423e-05 1.19877490735074
+ 1.4232e-05 1.19884619696135
+ 1.4234e-05 1.19900843937569
+ 1.4236e-05 1.19922033757949
+ 1.4238e-05 1.1993199431823
+ 1.424e-05 1.19934561183955
+ 1.4242e-05 1.19932334247819
+ 1.4244e-05 1.1993230621931
+ 1.4246e-05 1.19938724457231
+ 1.4248e-05 1.19929689729603
+ 1.425e-05 1.19930330492567
+ 1.4252e-05 1.19921694005411
+ 1.4254e-05 1.19940496521591
+ 1.4256e-05 1.19934797305776
+ 1.4258e-05 1.1995031214455
+ 1.426e-05 1.19982125070683
+ 1.4262e-05 1.19963970649195
+ 1.4264e-05 1.19966212951749
+ 1.4266e-05 1.19990621229535
+ 1.4268e-05 1.19944855052529
+ 1.427e-05 1.19912885482301
+ 1.4272e-05 1.19928479102865
+ 1.4274e-05 1.19928580142522
+ 1.4276e-05 1.1991675658703
+ 1.4278e-05 1.19948607292459
+ 1.428e-05 1.1997355524693
+ 1.4282e-05 1.19964002496506
+ 1.4284e-05 1.19984793338244
+ 1.4286e-05 1.19974275551428
+ 1.4288e-05 1.19987647366068
+ 1.429e-05 1.19989906763719
+ 1.4292e-05 1.19969427457405
+ 1.4294e-05 1.19946544967863
+ 1.4296e-05 1.19968186707939
+ 1.4298e-05 1.19987895748914
+ 1.43e-05 1.19978919232472
+ 1.4302e-05 1.19960012210451
+ 1.4304e-05 1.19942251661728
+ 1.4306e-05 1.19939501957653
+ 1.4308e-05 1.19932554396974
+ 1.431e-05 1.1993995705645
+ 1.4312e-05 1.19946689183836
+ 1.4314e-05 1.19957506751259
+ 1.4316e-05 1.19932233499184
+ 1.4318e-05 1.19965171268044
+ 1.432e-05 1.19941185595446
+ 1.4322e-05 1.19931396261051
+ 1.4324e-05 1.19912573190306
+ 1.4326e-05 1.19894751647477
+ 1.4328e-05 1.19899131977775
+ 1.433e-05 1.19913171513129
+ 1.4332e-05 1.19902743101747
+ 1.4334e-05 1.19868511646907
+ 1.4336e-05 1.19852870346705
+ 1.4338e-05 1.19841195333633
+ 1.434e-05 1.19822705319337
+ 1.4342e-05 1.19819596566224
+ 1.4344e-05 1.19844961689544
+ 1.4346e-05 1.19834402293374
+ 1.4348e-05 1.198440191193
+ 1.435e-05 1.19843015503282
+ 1.4352e-05 1.19844141008112
+ 1.4354e-05 1.1982445924682
+ 1.4356e-05 1.19831266361772
+ 1.4358e-05 1.19816845711786
+ 1.436e-05 1.19805323067958
+ 1.4362e-05 1.19806180828764
+ 1.4364e-05 1.1980861280403
+ 1.4366e-05 1.19817310865218
+ 1.4368e-05 1.19793621932632
+ 1.437e-05 1.19768928694196
+ 1.4372e-05 1.19786654306589
+ 1.4374e-05 1.19782899895767
+ 1.4376e-05 1.19779705331113
+ 1.4378e-05 1.19784695487218
+ 1.438e-05 1.19771307656043
+ 1.4382e-05 1.19803583851843
+ 1.4384e-05 1.1981984040991
+ 1.4386e-05 1.19829047649483
+ 1.4388e-05 1.19853304784235
+ 1.439e-05 1.19867396466541
+ 1.4392e-05 1.19899551319613
+ 1.4394e-05 1.19899570062575
+ 1.4396e-05 1.19907583589432
+ 1.4398e-05 1.19932195629521
+ 1.44e-05 1.19935135008552
+ 1.4402e-05 1.1996279067002
+ 1.4404e-05 1.19971195680872
+ 1.4406e-05 1.19990232518609
+ 1.4408e-05 1.19974806797704
+ 1.441e-05 1.2000369169201
+ 1.4412e-05 1.2000364019297
+ 1.4414e-05 1.20033200289355
+ 1.4416e-05 1.20044957457262
+ 1.4418e-05 1.20054641701807
+ 1.442e-05 1.2009959861682
+ 1.4422e-05 1.20100342261482
+ 1.4424e-05 1.20091734449676
+ 1.4426e-05 1.20080081841427
+ 1.4428e-05 1.20070195803704
+ 1.443e-05 1.20100209908316
+ 1.4432e-05 1.20096770503052
+ 1.4434e-05 1.20080467502289
+ 1.4436e-05 1.20087068260593
+ 1.4438e-05 1.20075473142498
+ 1.444e-05 1.20039233725298
+ 1.4442e-05 1.20031493249407
+ 1.4444e-05 1.2004875577227
+ 1.4446e-05 1.20065744922082
+ 1.4448e-05 1.20079755691608
+ 1.445e-05 1.20048190210887
+ 1.4452e-05 1.2004032122294
+ 1.4454e-05 1.20041478618815
+ 1.4456e-05 1.20062911352956
+ 1.4458e-05 1.20052303230856
+ 1.446e-05 1.2006108857793
+ 1.4462e-05 1.20092697796012
+ 1.4464e-05 1.20103769806779
+ 1.4466e-05 1.20122428688096
+ 1.4468e-05 1.20110459519327
+ 1.447e-05 1.20139240518606
+ 1.4472e-05 1.20165714261944
+ 1.4474e-05 1.20133678037049
+ 1.4476e-05 1.20113628129506
+ 1.4478e-05 1.20101272276465
+ 1.448e-05 1.2009809366984
+ 1.4482e-05 1.20088123182346
+ 1.4484e-05 1.20089728488323
+ 1.4486e-05 1.20099397748591
+ 1.4488e-05 1.20071288957835
+ 1.449e-05 1.20099008417846
+ 1.4492e-05 1.20066952953693
+ 1.4494e-05 1.20067842142926
+ 1.4496e-05 1.20060133478758
+ 1.4498e-05 1.20033098881519
+ 1.45e-05 1.20036349611155
+ 1.4502e-05 1.20045797920741
+ 1.4504e-05 1.20037965710646
+ 1.4506e-05 1.2003616993988
+ 1.4508e-05 1.20026938372475
+ 1.451e-05 1.20069226211363
+ 1.4512e-05 1.20078284786242
+ 1.4514e-05 1.20048354086851
+ 1.4516e-05 1.2003440720908
+ 1.4518e-05 1.20032634643343
+ 1.452e-05 1.20022590574101
+ 1.4522e-05 1.200120792763
+ 1.4524e-05 1.20009886423757
+ 1.4526e-05 1.19991331734118
+ 1.4528e-05 1.1999923314579
+ 1.453e-05 1.19976064403209
+ 1.4532e-05 1.19961313118183
+ 1.4534e-05 1.19949793448387
+ 1.4536e-05 1.19945152406259
+ 1.4538e-05 1.1992426245778
+ 1.454e-05 1.19934388209259
+ 1.4542e-05 1.19916782901439
+ 1.4544e-05 1.19904288005048
+ 1.4546e-05 1.19907143354882
+ 1.4548e-05 1.19903573559817
+ 1.455e-05 1.19896878055755
+ 1.4552e-05 1.19887443717148
+ 1.4554e-05 1.19863626502259
+ 1.4556e-05 1.19820311951683
+ 1.4558e-05 1.19838641729067
+ 1.456e-05 1.19821599799152
+ 1.4562e-05 1.19837582481772
+ 1.4564e-05 1.1982057970973
+ 1.4566e-05 1.19802084659828
+ 1.4568e-05 1.19782100008949
+ 1.457e-05 1.19806991152454
+ 1.4572e-05 1.19839955790824
+ 1.4574e-05 1.19841510324123
+ 1.4576e-05 1.19866019570492
+ 1.4578e-05 1.19895280205725
+ 1.458e-05 1.19879988657484
+ 1.4582e-05 1.19855231763473
+ 1.4584e-05 1.19868274310431
+ 1.4586e-05 1.19882321108772
+ 1.4588e-05 1.19886475090025
+ 1.459e-05 1.19883696551482
+ 1.4592e-05 1.19868906659771
+ 1.4594e-05 1.19871021492792
+ 1.4596e-05 1.19863310668529
+ 1.4598e-05 1.1987468732567
+ 1.46e-05 1.19870868527415
+ 1.4602e-05 1.19862794037758
+ 1.4604e-05 1.1985580038847
+ 1.4606e-05 1.19850593926338
+ 1.4608e-05 1.19860219354883
+ 1.461e-05 1.19925856503518
+ 1.4612e-05 1.19948889126655
+ 1.4614e-05 1.19964905737066
+ 1.4616e-05 1.19943573430773
+ 1.4618e-05 1.1997546771998
+ 1.462e-05 1.19921766728424
+ 1.4622e-05 1.19905031124648
+ 1.4624e-05 1.19901797960032
+ 1.4626e-05 1.19912274211903
+ 1.4628e-05 1.19933302335257
+ 1.463e-05 1.1992563647781
+ 1.4632e-05 1.19900402527637
+ 1.4634e-05 1.1991915309092
+ 1.4636e-05 1.19900137048373
+ 1.4638e-05 1.19909847751712
+ 1.464e-05 1.19911272441027
+ 1.4642e-05 1.19914659454196
+ 1.4644e-05 1.19915626962916
+ 1.4646e-05 1.19933189344617
+ 1.4648e-05 1.19938099222659
+ 1.465e-05 1.19954415001393
+ 1.4652e-05 1.19928926275053
+ 1.4654e-05 1.19904478699236
+ 1.4656e-05 1.1990314635335
+ 1.4658e-05 1.19940972286989
+ 1.466e-05 1.19927827797139
+ 1.4662e-05 1.19936186822277
+ 1.4664e-05 1.19953384892983
+ 1.4666e-05 1.19962080810217
+ 1.4668e-05 1.19935807379015
+ 1.467e-05 1.19988591504062
+ 1.4672e-05 1.20006733977631
+ 1.4674e-05 1.20011481729984
+ 1.4676e-05 1.20036090362369
+ 1.4678e-05 1.20040624304349
+ 1.468e-05 1.20035369476261
+ 1.4682e-05 1.2003385312197
+ 1.4684e-05 1.20021184807465
+ 1.4686e-05 1.20025118326986
+ 1.4688e-05 1.20035775412305
+ 1.469e-05 1.20025683274178
+ 1.4692e-05 1.19991388792798
+ 1.4694e-05 1.199895582863
+ 1.4696e-05 1.19969198345651
+ 1.4698e-05 1.19956515913743
+ 1.47e-05 1.19932320788972
+ 1.4702e-05 1.19913649125171
+ 1.4704e-05 1.19934544043065
+ 1.4706e-05 1.19929034972991
+ 1.4708e-05 1.19903103899731
+ 1.471e-05 1.1989066424644
+ 1.4712e-05 1.19899612940095
+ 1.4714e-05 1.19927030288089
+ 1.4716e-05 1.19931492349731
+ 1.4718e-05 1.19947105768161
+ 1.472e-05 1.19933333150793
+ 1.4722e-05 1.19947354237505
+ 1.4724e-05 1.19921768030896
+ 1.4726e-05 1.19983495074089
+ 1.4728e-05 1.19993939162702
+ 1.473e-05 1.20029589129633
+ 1.4732e-05 1.20045941412636
+ 1.4734e-05 1.20054073997034
+ 1.4736e-05 1.20064960516238
+ 1.4738e-05 1.20047578419403
+ 1.474e-05 1.20058109311348
+ 1.4742e-05 1.20069254590501
+ 1.4744e-05 1.20070908310908
+ 1.4746e-05 1.20066059842842
+ 1.4748e-05 1.20050306922273
+ 1.475e-05 1.20043963921349
+ 1.4752e-05 1.20008787638165
+ 1.4754e-05 1.20000547502034
+ 1.4756e-05 1.20011100754636
+ 1.4758e-05 1.19996393844741
+ 1.476e-05 1.19978651987684
+ 1.4762e-05 1.19996713338202
+ 1.4764e-05 1.19991375232072
+ 1.4766e-05 1.19998534571619
+ 1.4768e-05 1.19966964338928
+ 1.477e-05 1.19959252151699
+ 1.4772e-05 1.19953040129048
+ 1.4774e-05 1.19958098426733
+ 1.4776e-05 1.19950895888612
+ 1.4778e-05 1.19934557377855
+ 1.478e-05 1.19890767437074
+ 1.4782e-05 1.19908199886311
+ 1.4784e-05 1.19883923704151
+ 1.4786e-05 1.19884423150026
+ 1.4788e-05 1.1987690730751
+ 1.479e-05 1.19857752140808
+ 1.4792e-05 1.19847366884686
+ 1.4794e-05 1.19832320778086
+ 1.4796e-05 1.19864482351402
+ 1.4798e-05 1.19854903949056
+ 1.48e-05 1.19876361403521
+ 1.4802e-05 1.1986569663048
+ 1.4804e-05 1.19888941885152
+ 1.4806e-05 1.19874202705332
+ 1.4808e-05 1.19859695106039
+ 1.481e-05 1.19876844718838
+ 1.4812e-05 1.19918536202081
+ 1.4814e-05 1.19920126235704
+ 1.4816e-05 1.19916279889565
+ 1.4818e-05 1.19880108651221
+ 1.482e-05 1.19880440521546
+ 1.4822e-05 1.19889563203995
+ 1.4824e-05 1.19884743750288
+ 1.4826e-05 1.19881012235238
+ 1.4828e-05 1.19878599687202
+ 1.483e-05 1.19865098397548
+ 1.4832e-05 1.19880563659762
+ 1.4834e-05 1.19910768077251
+ 1.4836e-05 1.19911100224815
+ 1.4838e-05 1.19934612509308
+ 1.484e-05 1.19953194418555
+ 1.4842e-05 1.1996883912186
+ 1.4844e-05 1.19956916980088
+ 1.4846e-05 1.19973523464194
+ 1.4848e-05 1.1998823672359
+ 1.485e-05 1.19979601060102
+ 1.4852e-05 1.19967912160977
+ 1.4854e-05 1.19969439115098
+ 1.4856e-05 1.19954743153734
+ 1.4858e-05 1.19984434410055
+ 1.486e-05 1.19981743697521
+ 1.4862e-05 1.2000281090331
+ 1.4864e-05 1.2003163025639
+ 1.4866e-05 1.20027966981288
+ 1.4868e-05 1.20007728323437
+ 1.487e-05 1.20010082745505
+ 1.4872e-05 1.19977804352707
+ 1.4874e-05 1.19963028482173
+ 1.4876e-05 1.19976611284581
+ 1.4878e-05 1.20000090909206
+ 1.488e-05 1.19992037245853
+ 1.4882e-05 1.19982557490397
+ 1.4884e-05 1.1998694442653
+ 1.4886e-05 1.20010188424458
+ 1.4888e-05 1.20005606704701
+ 1.489e-05 1.19995621292645
+ 1.4892e-05 1.20004847746798
+ 1.4894e-05 1.19961669535841
+ 1.4896e-05 1.19959678990973
+ 1.4898e-05 1.19953273465007
+ 1.49e-05 1.19956880146237
+ 1.4902e-05 1.19944435601974
+ 1.4904e-05 1.19986866072038
+ 1.4906e-05 1.2002252930268
+ 1.4908e-05 1.20011969401112
+ 1.491e-05 1.20020792035149
+ 1.4912e-05 1.20029423866658
+ 1.4914e-05 1.20038062492571
+ 1.4916e-05 1.20064253809286
+ 1.4918e-05 1.20035732844537
+ 1.492e-05 1.2004345070934
+ 1.4922e-05 1.20046392475995
+ 1.4924e-05 1.20052338844733
+ 1.4926e-05 1.2004733575683
+ 1.4928e-05 1.20064199700588
+ 1.493e-05 1.20031347214013
+ 1.4932e-05 1.2001390186973
+ 1.4934e-05 1.20035802765862
+ 1.4936e-05 1.20015768881453
+ 1.4938e-05 1.20025886562477
+ 1.494e-05 1.20018853806228
+ 1.4942e-05 1.20047439974927
+ 1.4944e-05 1.20053231670574
+ 1.4946e-05 1.20039165197573
+ 1.4948e-05 1.20047441975895
+ 1.495e-05 1.20057197638586
+ 1.4952e-05 1.2006247563746
+ 1.4954e-05 1.20072545353962
+ 1.4956e-05 1.20077600945383
+ 1.4958e-05 1.20068820132559
+ 1.496e-05 1.20089331695536
+ 1.4962e-05 1.20057943131399
+ 1.4964e-05 1.20066163526366
+ 1.4966e-05 1.20029953633773
+ 1.4968e-05 1.20025084602588
+ 1.497e-05 1.20037290523262
+ 1.4972e-05 1.20081296620592
+ 1.4974e-05 1.20082027968567
+ 1.4976e-05 1.20055434660807
+ 1.4978e-05 1.20052860535948
+ 1.498e-05 1.20030589011412
+ 1.4982e-05 1.20018492738687
+ 1.4984e-05 1.20003076171605
+ 1.4986e-05 1.20017143151231
+ 1.4988e-05 1.20010269619467
+ 1.499e-05 1.20025721085331
+ 1.4992e-05 1.20019849459286
+ 1.4994e-05 1.20028855689689
+ 1.4996e-05 1.20008618613166
+ 1.4998e-05 1.19995928615415
+ 1.5e-05 1.19966056888695
+ 1.5002e-05 1.19966201498694
+ 1.5004e-05 1.19992183705635
+ 1.5006e-05 1.19977626927624
+ 1.5008e-05 1.19968875560557
+ 1.501e-05 1.19947128622168
+ 1.5012e-05 1.19981155393692
+ 1.5014e-05 1.19989977155529
+ 1.5016e-05 1.20001430056879
+ 1.5018e-05 1.20012830162733
+ 1.502e-05 1.20002522510692
+ 1.5022e-05 1.20001625561063
+ 1.5024e-05 1.20022897253547
+ 1.5026e-05 1.20007047858701
+ 1.5028e-05 1.20063617942516
+ 1.503e-05 1.20080435370997
+ 1.5032e-05 1.20057524144456
+ 1.5034e-05 1.20064547420217
+ 1.5036e-05 1.20051673488207
+ 1.5038e-05 1.20059393273197
+ 1.504e-05 1.20064008134235
+ 1.5042e-05 1.2006060368589
+ 1.5044e-05 1.20026096665546
+ 1.5046e-05 1.20015841959388
+ 1.5048e-05 1.19983730247083
+ 1.505e-05 1.19980931462492
+ 1.5052e-05 1.19982579518137
+ 1.5054e-05 1.19991392910414
+ 1.5056e-05 1.19972497730383
+ 1.5058e-05 1.19986115012148
+ 1.506e-05 1.19995758561406
+ 1.5062e-05 1.20003235076912
+ 1.5064e-05 1.20006460552345
+ 1.5066e-05 1.20023282030731
+ 1.5068e-05 1.19990041611523
+ 1.507e-05 1.19988042940397
+ 1.5072e-05 1.19993160440269
+ 1.5074e-05 1.20001575709157
+ 1.5076e-05 1.1999012589372
+ 1.5078e-05 1.19977591628187
+ 1.508e-05 1.19959545536224
+ 1.5082e-05 1.19940671608781
+ 1.5084e-05 1.19964533881914
+ 1.5086e-05 1.19985993772983
+ 1.5088e-05 1.19996284421604
+ 1.509e-05 1.19966603552757
+ 1.5092e-05 1.19936251547668
+ 1.5094e-05 1.19908606553372
+ 1.5096e-05 1.19853789429945
+ 1.5098e-05 1.19867588245771
+ 1.51e-05 1.19844050738925
+ 1.5102e-05 1.19826341606539
+ 1.5104e-05 1.19829215058465
+ 1.5106e-05 1.19827764576577
+ 1.5108e-05 1.19834236829555
+ 1.511e-05 1.1983275607246
+ 1.5112e-05 1.19834524859493
+ 1.5114e-05 1.19824973220403
+ 1.5116e-05 1.19832154540937
+ 1.5118e-05 1.19822774400604
+ 1.512e-05 1.198509647766
+ 1.5122e-05 1.19840179813239
+ 1.5124e-05 1.19819892910597
+ 1.5126e-05 1.19810105083056
+ 1.5128e-05 1.19806064713593
+ 1.513e-05 1.19823836701263
+ 1.5132e-05 1.19848661771305
+ 1.5134e-05 1.19824360169317
+ 1.5136e-05 1.19793803867426
+ 1.5138e-05 1.19777965663877
+ 1.514e-05 1.19767724608964
+ 1.5142e-05 1.19771371726167
+ 1.5144e-05 1.19767064866897
+ 1.5146e-05 1.1976074886719
+ 1.5148e-05 1.1976450849633
+ 1.515e-05 1.19746784530311
+ 1.5152e-05 1.19726616910632
+ 1.5154e-05 1.19756879775344
+ 1.5156e-05 1.19775705516997
+ 1.5158e-05 1.19829154036943
+ 1.516e-05 1.19863540409595
+ 1.5162e-05 1.19871977178935
+ 1.5164e-05 1.19852324510224
+ 1.5166e-05 1.19863370177722
+ 1.5168e-05 1.19862330409066
+ 1.517e-05 1.1990117703814
+ 1.5172e-05 1.19920937858811
+ 1.5174e-05 1.19914806745475
+ 1.5176e-05 1.1985943211341
+ 1.5178e-05 1.19886151070013
+ 1.518e-05 1.19889860201057
+ 1.5182e-05 1.19920169209693
+ 1.5184e-05 1.199217664823
+ 1.5186e-05 1.19940394681908
+ 1.5188e-05 1.19958633628985
+ 1.519e-05 1.19951891428932
+ 1.5192e-05 1.19940159000998
+ 1.5194e-05 1.19959384641098
+ 1.5196e-05 1.19973792643467
+ 1.5198e-05 1.19950722577033
+ 1.52e-05 1.19937710099984
+ 1.5202e-05 1.19962840730581
+ 1.5204e-05 1.19972324022541
+ 1.5206e-05 1.20016629201288
+ 1.5208e-05 1.20016409405225
+ 1.521e-05 1.20023074037524
+ 1.5212e-05 1.19978179426504
+ 1.5214e-05 1.19976423719174
+ 1.5216e-05 1.199746566496
+ 1.5218e-05 1.19979447818052
+ 1.522e-05 1.19977992816859
+ 1.5222e-05 1.19994031511518
+ 1.5224e-05 1.19992857519901
+ 1.5226e-05 1.19987579720832
+ 1.5228e-05 1.19985436516927
+ 1.523e-05 1.20008809950691
+ 1.5232e-05 1.20009572470703
+ 1.5234e-05 1.20044555046949
+ 1.5236e-05 1.20002247433045
+ 1.5238e-05 1.20010252704361
+ 1.524e-05 1.1999129926136
+ 1.5242e-05 1.19947662562523
+ 1.5244e-05 1.19927710919047
+ 1.5246e-05 1.19919995669941
+ 1.5248e-05 1.19951370066754
+ 1.525e-05 1.19985712619468
+ 1.5252e-05 1.19969469235068
+ 1.5254e-05 1.19982614981275
+ 1.5256e-05 1.19963239486443
+ 1.5258e-05 1.19938991887067
+ 1.526e-05 1.19934794309642
+ 1.5262e-05 1.19965559108951
+ 1.5264e-05 1.19977696759303
+ 1.5266e-05 1.1998145052144
+ 1.5268e-05 1.19995090427985
+ 1.527e-05 1.19999174884006
+ 1.5272e-05 1.19987128710355
+ 1.5274e-05 1.19992919292954
+ 1.5276e-05 1.1998782420961
+ 1.5278e-05 1.19991267057298
+ 1.528e-05 1.19974088825508
+ 1.5282e-05 1.19999581464015
+ 1.5284e-05 1.2001663672524
+ 1.5286e-05 1.20032529565745
+ 1.5288e-05 1.20055609191509
+ 1.529e-05 1.2007677929824
+ 1.5292e-05 1.20088168399939
+ 1.5294e-05 1.20118336835562
+ 1.5296e-05 1.20112163888295
+ 1.5298e-05 1.20123666976961
+ 1.53e-05 1.20101048291313
+ 1.5302e-05 1.2007625549953
+ 1.5304e-05 1.20091700949824
+ 1.5306e-05 1.20081795462872
+ 1.5308e-05 1.2007648055989
+ 1.531e-05 1.20094657762747
+ 1.5312e-05 1.20098333800254
+ 1.5314e-05 1.20080150804761
+ 1.5316e-05 1.20025491995272
+ 1.5318e-05 1.20024618058566
+ 1.532e-05 1.20023555936156
+ 1.5322e-05 1.20019662310361
+ 1.5324e-05 1.20017574850165
+ 1.5326e-05 1.20037269991148
+ 1.5328e-05 1.20011736690598
+ 1.533e-05 1.20038792994215
+ 1.5332e-05 1.20060637835518
+ 1.5334e-05 1.20050535924181
+ 1.5336e-05 1.20048798896398
+ 1.5338e-05 1.20043060796461
+ 1.534e-05 1.20092032398178
+ 1.5342e-05 1.20114919618763
+ 1.5344e-05 1.20083669399995
+ 1.5346e-05 1.20094996634418
+ 1.5348e-05 1.20103884272874
+ 1.535e-05 1.20143130740077
+ 1.5352e-05 1.20123838359424
+ 1.5354e-05 1.20115412881157
+ 1.5356e-05 1.20133615815861
+ 1.5358e-05 1.20119663359264
+ 1.536e-05 1.20132447879661
+ 1.5362e-05 1.2018716755847
+ 1.5364e-05 1.20173623414451
+ 1.5366e-05 1.20156136564465
+ 1.5368e-05 1.20128866805354
+ 1.537e-05 1.20154316179218
+ 1.5372e-05 1.20150836986915
+ 1.5374e-05 1.20117573163417
+ 1.5376e-05 1.20118626327836
+ 1.5378e-05 1.20121855188441
+ 1.538e-05 1.20125196199207
+ 1.5382e-05 1.2012113169143
+ 1.5384e-05 1.20128285134112
+ 1.5386e-05 1.20113143520711
+ 1.5388e-05 1.20092888551043
+ 1.539e-05 1.20068204190809
+ 1.5392e-05 1.20038344663163
+ 1.5394e-05 1.20000584581216
+ 1.5396e-05 1.20034030148265
+ 1.5398e-05 1.20041891327901
+ 1.54e-05 1.20077871711791
+ 1.5402e-05 1.20074496917219
+ 1.5404e-05 1.20064784418274
+ 1.5406e-05 1.20051964710439
+ 1.5408e-05 1.2003867323233
+ 1.541e-05 1.20030814781775
+ 1.5412e-05 1.20032898813685
+ 1.5414e-05 1.20017549883903
+ 1.5416e-05 1.1997044778157
+ 1.5418e-05 1.19979547489063
+ 1.542e-05 1.19940135644294
+ 1.5422e-05 1.19903738907391
+ 1.5424e-05 1.19911066567621
+ 1.5426e-05 1.19922900964935
+ 1.5428e-05 1.19936586308872
+ 1.543e-05 1.19933604154154
+ 1.5432e-05 1.19906068729675
+ 1.5434e-05 1.19899609046423
+ 1.5436e-05 1.19897267187943
+ 1.5438e-05 1.19906119137969
+ 1.544e-05 1.1993022380279
+ 1.5442e-05 1.19901272633383
+ 1.5444e-05 1.19923152660296
+ 1.5446e-05 1.19951014750431
+ 1.5448e-05 1.1994921453539
+ 1.545e-05 1.19963621215829
+ 1.5452e-05 1.19959501901875
+ 1.5454e-05 1.19989318066931
+ 1.5456e-05 1.20018104061974
+ 1.5458e-05 1.20021113101143
+ 1.546e-05 1.20008205511446
+ 1.5462e-05 1.19972592925568
+ 1.5464e-05 1.19956151983618
+ 1.5466e-05 1.1997718008479
+ 1.5468e-05 1.19977912693828
+ 1.547e-05 1.19989084639096
+ 1.5472e-05 1.1997826559757
+ 1.5474e-05 1.19966150824357
+ 1.5476e-05 1.19936116041092
+ 1.5478e-05 1.19957259893473
+ 1.548e-05 1.19959155443504
+ 1.5482e-05 1.19955711592051
+ 1.5484e-05 1.19955951311099
+ 1.5486e-05 1.19931522015232
+ 1.5488e-05 1.19953256952125
+ 1.549e-05 1.19951552316908
+ 1.5492e-05 1.19960884734736
+ 1.5494e-05 1.19983287451985
+ 1.5496e-05 1.19994765291976
+ 1.5498e-05 1.20000297614652
+ 1.55e-05 1.19994136006875
+ 1.5502e-05 1.1996370598518
+ 1.5504e-05 1.19950046252683
+ 1.5506e-05 1.19914670249444
+ 1.5508e-05 1.19934858787577
+ 1.551e-05 1.19938320969783
+ 1.5512e-05 1.19937208797966
+ 1.5514e-05 1.19954539023873
+ 1.5516e-05 1.19930187004919
+ 1.5518e-05 1.19955508207183
+ 1.552e-05 1.19938111782992
+ 1.5522e-05 1.19940749689717
+ 1.5524e-05 1.20000697833948
+ 1.5526e-05 1.19997998810282
+ 1.5528e-05 1.19992617815318
+ 1.553e-05 1.19970453475237
+ 1.5532e-05 1.19964262750041
+ 1.5534e-05 1.19933541547683
+ 1.5536e-05 1.19941282598044
+ 1.5538e-05 1.19928854478313
+ 1.554e-05 1.19929808846246
+ 1.5542e-05 1.19927176338577
+ 1.5544e-05 1.19935350956374
+ 1.5546e-05 1.1993114609026
+ 1.5548e-05 1.1996092487611
+ 1.555e-05 1.19952344282174
+ 1.5552e-05 1.19949765621982
+ 1.5554e-05 1.19959210057882
+ 1.5556e-05 1.19979403811615
+ 1.5558e-05 1.19995850216545
+ 1.556e-05 1.19998270377198
+ 1.5562e-05 1.19993890986795
+ 1.5564e-05 1.19992577817308
+ 1.5566e-05 1.19976149760852
+ 1.5568e-05 1.19972571242101
+ 1.557e-05 1.19957513103519
+ 1.5572e-05 1.19952787837517
+ 1.5574e-05 1.19936804219588
+ 1.5576e-05 1.19948821178484
+ 1.5578e-05 1.19923335429114
+ 1.558e-05 1.19915031240047
+ 1.5582e-05 1.19907631098404
+ 1.5584e-05 1.19904033811384
+ 1.5586e-05 1.19956037691952
+ 1.5588e-05 1.19941220939648
+ 1.559e-05 1.1995932865942
+ 1.5592e-05 1.19963555150057
+ 1.5594e-05 1.19965174676678
+ 1.5596e-05 1.19970713886895
+ 1.5598e-05 1.19974901558938
+ 1.56e-05 1.1997476452092
+ 1.5602e-05 1.19950281832166
+ 1.5604e-05 1.19909834454799
+ 1.5606e-05 1.19918924917327
+ 1.5608e-05 1.19902532485729
+ 1.561e-05 1.19908732581871
+ 1.5612e-05 1.1990253622817
+ 1.5614e-05 1.19903744931454
+ 1.5616e-05 1.19904003659306
+ 1.5618e-05 1.19910001287242
+ 1.562e-05 1.19912746358345
+ 1.5622e-05 1.19885407676617
+ 1.5624e-05 1.19881385296061
+ 1.5626e-05 1.199001265638
+ 1.5628e-05 1.19907584744849
+ 1.563e-05 1.19947744486085
+ 1.5632e-05 1.19954104972538
+ 1.5634e-05 1.19940219209273
+ 1.5636e-05 1.1997739384602
+ 1.5638e-05 1.19984070930741
+ 1.564e-05 1.19967025512963
+ 1.5642e-05 1.19948804859865
+ 1.5644e-05 1.19968781726759
+ 1.5646e-05 1.19987124450572
+ 1.5648e-05 1.19995640163485
+ 1.565e-05 1.19937136871779
+ 1.5652e-05 1.19957879478644
+ 1.5654e-05 1.19992228668667
+ 1.5656e-05 1.19989295516752
+ 1.5658e-05 1.1998559812939
+ 1.566e-05 1.19970806174506
+ 1.5662e-05 1.19998873895862
+ 1.5664e-05 1.19980132415903
+ 1.5666e-05 1.19996384436762
+ 1.5668e-05 1.20018913724157
+ 1.567e-05 1.20019496707911
+ 1.5672e-05 1.19999939762328
+ 1.5674e-05 1.19978822349211
+ 1.5676e-05 1.19972302080082
+ 1.5678e-05 1.19958053645302
+ 1.568e-05 1.19958016893982
+ 1.5682e-05 1.19983605772293
+ 1.5684e-05 1.19988101934612
+ 1.5686e-05 1.20012301108094
+ 1.5688e-05 1.2003875062453
+ 1.569e-05 1.2000743887007
+ 1.5692e-05 1.20039400567439
+ 1.5694e-05 1.20033955280226
+ 1.5696e-05 1.20026613486048
+ 1.5698e-05 1.20013496721001
+ 1.57e-05 1.2004106565052
+ 1.5702e-05 1.2003119447808
+ 1.5704e-05 1.20047167326063
+ 1.5706e-05 1.20035384255483
+ 1.5708e-05 1.20024812848504
+ 1.571e-05 1.20052598618516
+ 1.5712e-05 1.20051679631143
+ 1.5714e-05 1.20069918937507
+ 1.5716e-05 1.20086697952731
+ 1.5718e-05 1.20108844415414
+ 1.572e-05 1.20097861046303
+ 1.5722e-05 1.2010905123572
+ 1.5724e-05 1.20061826808578
+ 1.5726e-05 1.20088113837857
+ 1.5728e-05 1.20062232994158
+ 1.573e-05 1.20031498474678
+ 1.5732e-05 1.20028764795874
+ 1.5734e-05 1.20040062587282
+ 1.5736e-05 1.20082636314859
+ 1.5738e-05 1.20096725904329
+ 1.574e-05 1.20112087882377
+ 1.5742e-05 1.20123451511811
+ 1.5744e-05 1.20111309500081
+ 1.5746e-05 1.20128110375215
+ 1.5748e-05 1.20134649460542
+ 1.575e-05 1.20132015545234
+ 1.5752e-05 1.20132350893534
+ 1.5754e-05 1.20127510711615
+ 1.5756e-05 1.20163540699815
+ 1.5758e-05 1.20141045865173
+ 1.576e-05 1.20159103579481
+ 1.5762e-05 1.20142544789488
+ 1.5764e-05 1.20110021962734
+ 1.5766e-05 1.20118947854529
+ 1.5768e-05 1.20116429772549
+ 1.577e-05 1.2011495728674
+ 1.5772e-05 1.20099023489677
+ 1.5774e-05 1.20084044467921
+ 1.5776e-05 1.2007324725686
+ 1.5778e-05 1.20047427829658
+ 1.578e-05 1.20062964802431
+ 1.5782e-05 1.20054450991552
+ 1.5784e-05 1.20088093295805
+ 1.5786e-05 1.2006275087345
+ 1.5788e-05 1.20071763051221
+ 1.579e-05 1.20061753486901
+ 1.5792e-05 1.20093453521339
+ 1.5794e-05 1.20087390745545
+ 1.5796e-05 1.20038799605665
+ 1.5798e-05 1.20042734734405
+ 1.58e-05 1.20044712328849
+ 1.5802e-05 1.20071515550695
+ 1.5804e-05 1.20067854357369
+ 1.5806e-05 1.2009099506371
+ 1.5808e-05 1.20086057482368
+ 1.581e-05 1.20065706507961
+ 1.5812e-05 1.20088781759636
+ 1.5814e-05 1.20058928009228
+ 1.5816e-05 1.20066514024275
+ 1.5818e-05 1.2007896583599
+ 1.582e-05 1.20078122411762
+ 1.5822e-05 1.20073164795863
+ 1.5824e-05 1.20094412741643
+ 1.5826e-05 1.20096825673223
+ 1.5828e-05 1.20093587676838
+ 1.583e-05 1.20075221742744
+ 1.5832e-05 1.20060359517942
+ 1.5834e-05 1.20082818426166
+ 1.5836e-05 1.2006972411059
+ 1.5838e-05 1.20066686383598
+ 1.584e-05 1.2008874637182
+ 1.5842e-05 1.20068282243014
+ 1.5844e-05 1.20093438975701
+ 1.5846e-05 1.2010945684373
+ 1.5848e-05 1.20086255424068
+ 1.585e-05 1.20113807652652
+ 1.5852e-05 1.20121568394212
+ 1.5854e-05 1.2009098336091
+ 1.5856e-05 1.20088327445005
+ 1.5858e-05 1.20100712873012
+ 1.586e-05 1.2010459103454
+ 1.5862e-05 1.20079639809323
+ 1.5864e-05 1.20090278985581
+ 1.5866e-05 1.20116699818383
+ 1.5868e-05 1.20117295656692
+ 1.587e-05 1.20113676428761
+ 1.5872e-05 1.20149239435878
+ 1.5874e-05 1.20159903239369
+ 1.5876e-05 1.20178361550374
+ 1.5878e-05 1.20154560080975
+ 1.588e-05 1.20155178312842
+ 1.5882e-05 1.20133598116328
+ 1.5884e-05 1.20132471675448
+ 1.5886e-05 1.20131454499749
+ 1.5888e-05 1.20123991295888
+ 1.589e-05 1.20113521406701
+ 1.5892e-05 1.20143579645622
+ 1.5894e-05 1.20162520528985
+ 1.5896e-05 1.20192670802237
+ 1.5898e-05 1.2016329548683
+ 1.59e-05 1.20142163977376
+ 1.5902e-05 1.20136259496442
+ 1.5904e-05 1.20166429547375
+ 1.5906e-05 1.20206103886847
+ 1.5908e-05 1.20248143152792
+ 1.591e-05 1.20253178812301
+ 1.5912e-05 1.20256986601399
+ 1.5914e-05 1.20245532859607
+ 1.5916e-05 1.20229383445693
+ 1.5918e-05 1.20211859380558
+ 1.592e-05 1.20194405648579
+ 1.5922e-05 1.2018468778094
+ 1.5924e-05 1.20187245166675
+ 1.5926e-05 1.20156696106888
+ 1.5928e-05 1.20158009659708
+ 1.593e-05 1.20135321238582
+ 1.5932e-05 1.2011714436403
+ 1.5934e-05 1.20119813087729
+ 1.5936e-05 1.20113188257767
+ 1.5938e-05 1.20115927551628
+ 1.594e-05 1.20107834321892
+ 1.5942e-05 1.20098144855956
+ 1.5944e-05 1.20107897465033
+ 1.5946e-05 1.20074679956581
+ 1.5948e-05 1.20072971137991
+ 1.595e-05 1.20086439979087
+ 1.5952e-05 1.20037540319742
+ 1.5954e-05 1.20036658696477
+ 1.5956e-05 1.2003794220098
+ 1.5958e-05 1.20070262058009
+ 1.596e-05 1.20063131560243
+ 1.5962e-05 1.20082707950027
+ 1.5964e-05 1.20083573066632
+ 1.5966e-05 1.20078547622753
+ 1.5968e-05 1.20098400024144
+ 1.597e-05 1.20111793755932
+ 1.5972e-05 1.20133115061015
+ 1.5974e-05 1.20116207681914
+ 1.5976e-05 1.2011060165448
+ 1.5978e-05 1.20086856915921
+ 1.598e-05 1.20095715642976
+ 1.5982e-05 1.20074685813353
+ 1.5984e-05 1.20057706444556
+ 1.5986e-05 1.20065026675304
+ 1.5988e-05 1.20075343404107
+ 1.599e-05 1.20079356916052
+ 1.5992e-05 1.20076094275464
+ 1.5994e-05 1.20100775807575
+ 1.5996e-05 1.20105723272294
+ 1.5998e-05 1.20110779160205
+ 1.6e-05 1.20114090704739
+ 1.6002e-05 1.2011461436548
+ 1.6004e-05 1.20096310987831
+ 1.6006e-05 1.20112560346206
+ 1.6008e-05 1.20094260853508
+ 1.601e-05 1.20088677116027
+ 1.6012e-05 1.20110190231871
+ 1.6014e-05 1.20062884828672
+ 1.6016e-05 1.20013178059222
+ 1.6018e-05 1.20009779592761
+ 1.602e-05 1.20038924954112
+ 1.6022e-05 1.20040183763211
+ 1.6024e-05 1.20068452635993
+ 1.6026e-05 1.20072073759129
+ 1.6028e-05 1.20029166503404
+ 1.603e-05 1.20033148294718
+ 1.6032e-05 1.20038489658429
+ 1.6034e-05 1.20026334338459
+ 1.6036e-05 1.20005459550316
+ 1.6038e-05 1.19994088063095
+ 1.604e-05 1.20011242192099
+ 1.6042e-05 1.20018059993601
+ 1.6044e-05 1.20004903962558
+ 1.6046e-05 1.20012164583741
+ 1.6048e-05 1.19969763883984
+ 1.605e-05 1.19971367561583
+ 1.6052e-05 1.19967200874573
+ 1.6054e-05 1.19968401351608
+ 1.6056e-05 1.19987604770197
+ 1.6058e-05 1.19991087801278
+ 1.606e-05 1.20005408299998
+ 1.6062e-05 1.20004401503643
+ 1.6064e-05 1.200189151115
+ 1.6066e-05 1.20029359287751
+ 1.6068e-05 1.2000599417482
+ 1.607e-05 1.20018060251115
+ 1.6072e-05 1.20026732646979
+ 1.6074e-05 1.20029363660457
+ 1.6076e-05 1.20027812724825
+ 1.6078e-05 1.20033052229964
+ 1.608e-05 1.20049343158585
+ 1.6082e-05 1.2005607547658
+ 1.6084e-05 1.20092619782702
+ 1.6086e-05 1.20042863685667
+ 1.6088e-05 1.19999868205831
+ 1.609e-05 1.20008188094709
+ 1.6092e-05 1.19999769147296
+ 1.6094e-05 1.19997361634086
+ 1.6096e-05 1.19986898269882
+ 1.6098e-05 1.2000438877432
+ 1.61e-05 1.19993491337235
+ 1.6102e-05 1.19989800478022
+ 1.6104e-05 1.19971544034127
+ 1.6106e-05 1.19970757362009
+ 1.6108e-05 1.19950459727621
+ 1.611e-05 1.19954915737654
+ 1.6112e-05 1.19918081964038
+ 1.6114e-05 1.19904308213477
+ 1.6116e-05 1.19897076740021
+ 1.6118e-05 1.19923182295945
+ 1.612e-05 1.19922588883605
+ 1.6122e-05 1.19937931788922
+ 1.6124e-05 1.19914752824092
+ 1.6126e-05 1.19908287282352
+ 1.6128e-05 1.19901422629501
+ 1.613e-05 1.19916499192883
+ 1.6132e-05 1.19915061354028
+ 1.6134e-05 1.19894660177688
+ 1.6136e-05 1.19898019350334
+ 1.6138e-05 1.19904005086692
+ 1.614e-05 1.19922423098791
+ 1.6142e-05 1.19923401203848
+ 1.6144e-05 1.19937712535662
+ 1.6146e-05 1.19947230116374
+ 1.6148e-05 1.19987413267295
+ 1.615e-05 1.20002449637153
+ 1.6152e-05 1.19998316571611
+ 1.6154e-05 1.1997423403897
+ 1.6156e-05 1.19932243425467
+ 1.6158e-05 1.19908402028164
+ 1.616e-05 1.19919207948623
+ 1.6162e-05 1.19892973311057
+ 1.6164e-05 1.198983794991
+ 1.6166e-05 1.19907979662322
+ 1.6168e-05 1.19881865707821
+ 1.617e-05 1.19832233903666
+ 1.6172e-05 1.19790557027519
+ 1.6174e-05 1.19794990931325
+ 1.6176e-05 1.19756527091333
+ 1.6178e-05 1.19742586710841
+ 1.618e-05 1.19735816636673
+ 1.6182e-05 1.19743990971279
+ 1.6184e-05 1.1973006442731
+ 1.6186e-05 1.19726389132968
+ 1.6188e-05 1.19778101610297
+ 1.619e-05 1.19764485549742
+ 1.6192e-05 1.19736022085028
+ 1.6194e-05 1.1973785660276
+ 1.6196e-05 1.19784548184468
+ 1.6198e-05 1.19763904581128
+ 1.62e-05 1.19783413980951
+ 1.6202e-05 1.19744828395653
+ 1.6204e-05 1.19731248891695
+ 1.6206e-05 1.19730525235598
+ 1.6208e-05 1.19726069663491
+ 1.621e-05 1.19736505319913
+ 1.6212e-05 1.19712383560028
+ 1.6214e-05 1.19721578115629
+ 1.6216e-05 1.19772831852751
+ 1.6218e-05 1.1977952276643
+ 1.622e-05 1.198003004311
+ 1.6222e-05 1.19777351477007
+ 1.6224e-05 1.19754500609798
+ 1.6226e-05 1.1978015978136
+ 1.6228e-05 1.19801790499409
+ 1.623e-05 1.19839724813462
+ 1.6232e-05 1.19850217557236
+ 1.6234e-05 1.1980734375358
+ 1.6236e-05 1.19815964996172
+ 1.6238e-05 1.19804786988464
+ 1.624e-05 1.19794949124454
+ 1.6242e-05 1.19797050939518
+ 1.6244e-05 1.19821297935605
+ 1.6246e-05 1.19782860595479
+ 1.6248e-05 1.19781130672723
+ 1.625e-05 1.19763558732958
+ 1.6252e-05 1.19761631414966
+ 1.6254e-05 1.19758824120873
+ 1.6256e-05 1.19744788934792
+ 1.6258e-05 1.19756762958945
+ 1.626e-05 1.19774888518387
+ 1.6262e-05 1.19807471148652
+ 1.6264e-05 1.19797842840131
+ 1.6266e-05 1.19801412362699
+ 1.6268e-05 1.19806293874472
+ 1.627e-05 1.19848359629483
+ 1.6272e-05 1.19861556881173
+ 1.6274e-05 1.19872857267508
+ 1.6276e-05 1.19873159432057
+ 1.6278e-05 1.19879516687863
+ 1.628e-05 1.1987026598047
+ 1.6282e-05 1.19882417593117
+ 1.6284e-05 1.19896968953718
+ 1.6286e-05 1.19890729301515
+ 1.6288e-05 1.19912792864568
+ 1.629e-05 1.19898635997813
+ 1.6292e-05 1.19906135505784
+ 1.6294e-05 1.19909146014561
+ 1.6296e-05 1.19901794481278
+ 1.6298e-05 1.199207090501
+ 1.63e-05 1.19877380174242
+ 1.6302e-05 1.19913215933525
+ 1.6304e-05 1.19908418992919
+ 1.6306e-05 1.19904489551925
+ 1.6308e-05 1.19928540486088
+ 1.631e-05 1.199363708875
+ 1.6312e-05 1.19942391590741
+ 1.6314e-05 1.19953896978249
+ 1.6316e-05 1.19950453425735
+ 1.6318e-05 1.19957823148817
+ 1.632e-05 1.19940113451067
+ 1.6322e-05 1.19955873918855
+ 1.6324e-05 1.19953247559543
+ 1.6326e-05 1.19960678259444
+ 1.6328e-05 1.1996183750965
+ 1.633e-05 1.19974969573854
+ 1.6332e-05 1.19991307338025
+ 1.6334e-05 1.19977609771783
+ 1.6336e-05 1.19940145828682
+ 1.6338e-05 1.19921437444315
+ 1.634e-05 1.19955769232828
+ 1.6342e-05 1.1993067315878
+ 1.6344e-05 1.19954162892689
+ 1.6346e-05 1.19960115562603
+ 1.6348e-05 1.19971167830042
+ 1.635e-05 1.19970196783921
+ 1.6352e-05 1.1994411449991
+ 1.6354e-05 1.19938878766606
+ 1.6356e-05 1.19944493180833
+ 1.6358e-05 1.19929161628317
+ 1.636e-05 1.19960085823001
+ 1.6362e-05 1.19947683134117
+ 1.6364e-05 1.19948391280476
+ 1.6366e-05 1.19975505554801
+ 1.6368e-05 1.19980105216721
+ 1.637e-05 1.19958822225617
+ 1.6372e-05 1.19948396151933
+ 1.6374e-05 1.19979113082079
+ 1.6376e-05 1.19967232553974
+ 1.6378e-05 1.19994699526187
+ 1.638e-05 1.20000904755151
+ 1.6382e-05 1.19968875205131
+ 1.6384e-05 1.19951644664496
+ 1.6386e-05 1.19948863639826
+ 1.6388e-05 1.19927731114282
+ 1.639e-05 1.19914294555746
+ 1.6392e-05 1.19878525372153
+ 1.6394e-05 1.19875679193794
+ 1.6396e-05 1.198867928107
+ 1.6398e-05 1.19900796372863
+ 1.64e-05 1.19865846449031
+ 1.6402e-05 1.19843080413706
+ 1.6404e-05 1.19846154978967
+ 1.6406e-05 1.19867880271521
+ 1.6408e-05 1.19870810844209
+ 1.641e-05 1.19859962795563
+ 1.6412e-05 1.19874956341197
+ 1.6414e-05 1.19882821118713
+ 1.6416e-05 1.19894059996342
+ 1.6418e-05 1.19888396068042
+ 1.642e-05 1.19888806146231
+ 1.6422e-05 1.19880975835393
+ 1.6424e-05 1.19879990488656
+ 1.6426e-05 1.19883924921434
+ 1.6428e-05 1.19892715900828
+ 1.643e-05 1.1988258271717
+ 1.6432e-05 1.1988525929167
+ 1.6434e-05 1.19911925349644
+ 1.6436e-05 1.19903764723661
+ 1.6438e-05 1.19931248112476
+ 1.644e-05 1.19928292032376
+ 1.6442e-05 1.19955254536269
+ 1.6444e-05 1.1996995766696
+ 1.6446e-05 1.20017205972381
+ 1.6448e-05 1.20022087350213
+ 1.645e-05 1.19993771999299
+ 1.6452e-05 1.2001689952095
+ 1.6454e-05 1.20026598491543
+ 1.6456e-05 1.20010499562891
+ 1.6458e-05 1.20014663482488
+ 1.646e-05 1.20023546800183
+ 1.6462e-05 1.20039948852433
+ 1.6464e-05 1.20048728324097
+ 1.6466e-05 1.20065048975738
+ 1.6468e-05 1.20062000914586
+ 1.647e-05 1.20055651716408
+ 1.6472e-05 1.20046289087745
+ 1.6474e-05 1.20040670757326
+ 1.6476e-05 1.20068025045539
+ 1.6478e-05 1.20100865575918
+ 1.648e-05 1.2009431277748
+ 1.6482e-05 1.20071202981673
+ 1.6484e-05 1.20057375605304
+ 1.6486e-05 1.20053974585602
+ 1.6488e-05 1.20066969404093
+ 1.649e-05 1.20063257381555
+ 1.6492e-05 1.20075175737402
+ 1.6494e-05 1.20086241914379
+ 1.6496e-05 1.20124437702886
+ 1.6498e-05 1.20128994256542
+ 1.65e-05 1.20150433598183
+ 1.6502e-05 1.20129298009035
+ 1.6504e-05 1.20122165015923
+ 1.6506e-05 1.20143431857163
+ 1.6508e-05 1.20179760519614
+ 1.651e-05 1.20151241130064
+ 1.6512e-05 1.20127702874235
+ 1.6514e-05 1.2011488533741
+ 1.6516e-05 1.20088230611262
+ 1.6518e-05 1.20080438108416
+ 1.652e-05 1.20068649594327
+ 1.6522e-05 1.20036988567856
+ 1.6524e-05 1.20012383428281
+ 1.6526e-05 1.20014070602326
+ 1.6528e-05 1.19994568625073
+ 1.653e-05 1.20000860218806
+ 1.6532e-05 1.20007782635723
+ 1.6534e-05 1.20036664874779
+ 1.6536e-05 1.20032126636925
+ 1.6538e-05 1.20036905105273
+ 1.654e-05 1.20054441982474
+ 1.6542e-05 1.2006061637106
+ 1.6544e-05 1.20033915601816
+ 1.6546e-05 1.20014347166765
+ 1.6548e-05 1.20043932611086
+ 1.655e-05 1.20020846094262
+ 1.6552e-05 1.20037363599639
+ 1.6554e-05 1.20025027682662
+ 1.6556e-05 1.20006466924609
+ 1.6558e-05 1.2001720684329
+ 1.656e-05 1.2000375574782
+ 1.6562e-05 1.20006152510801
+ 1.6564e-05 1.20002328558902
+ 1.6566e-05 1.19984124293984
+ 1.6568e-05 1.19931188498793
+ 1.657e-05 1.19939269965162
+ 1.6572e-05 1.19931532667509
+ 1.6574e-05 1.19928388697613
+ 1.6576e-05 1.19877098075324
+ 1.6578e-05 1.19867636379484
+ 1.658e-05 1.19842675957065
+ 1.6582e-05 1.19857385437217
+ 1.6584e-05 1.19861258823797
+ 1.6586e-05 1.19884999828157
+ 1.6588e-05 1.19870827171437
+ 1.659e-05 1.19890836289365
+ 1.6592e-05 1.19902238138759
+ 1.6594e-05 1.19905666727846
+ 1.6596e-05 1.19886903464676
+ 1.6598e-05 1.19903865986695
+ 1.66e-05 1.19935184337451
+ 1.6602e-05 1.19907210701245
+ 1.6604e-05 1.19935145632026
+ 1.6606e-05 1.19931868221209
+ 1.6608e-05 1.19914128504879
+ 1.661e-05 1.19890117380607
+ 1.6612e-05 1.19880312976446
+ 1.6614e-05 1.19831058725577
+ 1.6616e-05 1.19833069910032
+ 1.6618e-05 1.19845270734539
+ 1.662e-05 1.19850786889077
+ 1.6622e-05 1.19845294994134
+ 1.6624e-05 1.19838411393358
+ 1.6626e-05 1.19846915790299
+ 1.6628e-05 1.19850334146324
+ 1.663e-05 1.1983552492844
+ 1.6632e-05 1.19831375704131
+ 1.6634e-05 1.19829527408749
+ 1.6636e-05 1.19805546922915
+ 1.6638e-05 1.1984232107796
+ 1.664e-05 1.19822983640418
+ 1.6642e-05 1.19806633573455
+ 1.6644e-05 1.19817975644772
+ 1.6646e-05 1.19834647473839
+ 1.6648e-05 1.19844439774265
+ 1.665e-05 1.19869558321805
+ 1.6652e-05 1.19850842214549
+ 1.6654e-05 1.19861219268577
+ 1.6656e-05 1.19867381110403
+ 1.6658e-05 1.19895046507635
+ 1.666e-05 1.19848770050526
+ 1.6662e-05 1.19870365315072
+ 1.6664e-05 1.19861957641851
+ 1.6666e-05 1.19905327717096
+ 1.6668e-05 1.19901148915394
+ 1.667e-05 1.19907214019276
+ 1.6672e-05 1.1993195142378
+ 1.6674e-05 1.19922173369652
+ 1.6676e-05 1.19959449533854
+ 1.6678e-05 1.19962015859433
+ 1.668e-05 1.19926291421138
+ 1.6682e-05 1.19948995685187
+ 1.6684e-05 1.19949714250641
+ 1.6686e-05 1.19945817747774
+ 1.6688e-05 1.19985329963734
+ 1.669e-05 1.19994113671484
+ 1.6692e-05 1.200134703134
+ 1.6694e-05 1.20039529327043
+ 1.6696e-05 1.20004453795289
+ 1.6698e-05 1.19997698012012
+ 1.67e-05 1.1999322116325
+ 1.6702e-05 1.20002057481841
+ 1.6704e-05 1.2000948414802
+ 1.6706e-05 1.20003801857
+ 1.6708e-05 1.20034452886774
+ 1.671e-05 1.20024907605484
+ 1.6712e-05 1.20012278927463
+ 1.6714e-05 1.20017444799123
+ 1.6716e-05 1.20018981683922
+ 1.6718e-05 1.20023544339675
+ 1.672e-05 1.19993289647493
+ 1.6722e-05 1.19968887430751
+ 1.6724e-05 1.19958016280535
+ 1.6726e-05 1.19971129935495
+ 1.6728e-05 1.19964845285074
+ 1.673e-05 1.19947537069308
+ 1.6732e-05 1.1995099794492
+ 1.6734e-05 1.19964906411057
+ 1.6736e-05 1.1997584097728
+ 1.6738e-05 1.19969302419297
+ 1.674e-05 1.20003657141955
+ 1.6742e-05 1.20017197619021
+ 1.6744e-05 1.19994317706119
+ 1.6746e-05 1.19978632188534
+ 1.6748e-05 1.19993469721124
+ 1.675e-05 1.1996388070297
+ 1.6752e-05 1.19977127715877
+ 1.6754e-05 1.19998419601799
+ 1.6756e-05 1.20003028131475
+ 1.6758e-05 1.20013820351932
+ 1.676e-05 1.20012420596146
+ 1.6762e-05 1.19998468790677
+ 1.6764e-05 1.19981452916944
+ 1.6766e-05 1.19964067657102
+ 1.6768e-05 1.19981897025647
+ 1.677e-05 1.20019628019509
+ 1.6772e-05 1.20022028442806
+ 1.6774e-05 1.20030092774164
+ 1.6776e-05 1.20020781456556
+ 1.6778e-05 1.20002766701687
+ 1.678e-05 1.20003836929039
+ 1.6782e-05 1.20004330948766
+ 1.6784e-05 1.20018834413294
+ 1.6786e-05 1.19993111241688
+ 1.6788e-05 1.19980360340406
+ 1.679e-05 1.19983774855936
+ 1.6792e-05 1.20032991128096
+ 1.6794e-05 1.20007198651547
+ 1.6796e-05 1.19997511389401
+ 1.6798e-05 1.19961483338837
+ 1.68e-05 1.19952839292434
+ 1.6802e-05 1.19958404380524
+ 1.6804e-05 1.1993050580561
+ 1.6806e-05 1.19929133325071
+ 1.6808e-05 1.19914706137737
+ 1.681e-05 1.19960222568663
+ 1.6812e-05 1.19959979347005
+ 1.6814e-05 1.19979952025891
+ 1.6816e-05 1.19972045194403
+ 1.6818e-05 1.19976868866819
+ 1.682e-05 1.19991512557869
+ 1.6822e-05 1.19991645219198
+ 1.6824e-05 1.20040275176287
+ 1.6826e-05 1.20041831868344
+ 1.6828e-05 1.20013524148185
+ 1.683e-05 1.20034765945567
+ 1.6832e-05 1.20082575195502
+ 1.6834e-05 1.20064912654021
+ 1.6836e-05 1.20021506476267
+ 1.6838e-05 1.20050041426499
+ 1.684e-05 1.20055413439442
+ 1.6842e-05 1.20083461762415
+ 1.6844e-05 1.20077295081636
+ 1.6846e-05 1.20096700425178
+ 1.6848e-05 1.2009370816429
+ 1.685e-05 1.2004879380077
+ 1.6852e-05 1.20027148568407
+ 1.6854e-05 1.20069126061436
+ 1.6856e-05 1.20086249752297
+ 1.6858e-05 1.20099208818606
+ 1.686e-05 1.20072095351478
+ 1.6862e-05 1.20050153653572
+ 1.6864e-05 1.20055429468761
+ 1.6866e-05 1.20057801580855
+ 1.6868e-05 1.20029148649993
+ 1.687e-05 1.20002522812173
+ 1.6872e-05 1.20019791307185
+ 1.6874e-05 1.20013371780466
+ 1.6876e-05 1.20047034441305
+ 1.6878e-05 1.20032053269566
+ 1.688e-05 1.20039179321755
+ 1.6882e-05 1.20046000353511
+ 1.6884e-05 1.20053052568638
+ 1.6886e-05 1.20067793412952
+ 1.6888e-05 1.20052299096752
+ 1.689e-05 1.20061274343677
+ 1.6892e-05 1.20055745703787
+ 1.6894e-05 1.20044889299341
+ 1.6896e-05 1.20083707096119
+ 1.6898e-05 1.20080297679678
+ 1.69e-05 1.20047644367391
+ 1.6902e-05 1.20047223139827
+ 1.6904e-05 1.20031838092467
+ 1.6906e-05 1.20028934176328
+ 1.6908e-05 1.19993374944854
+ 1.691e-05 1.19974932552332
+ 1.6912e-05 1.19972137306188
+ 1.6914e-05 1.19947984313597
+ 1.6916e-05 1.1995773509491
+ 1.6918e-05 1.19948070431684
+ 1.692e-05 1.19952389096012
+ 1.6922e-05 1.19939965755776
+ 1.6924e-05 1.19936414473927
+ 1.6926e-05 1.19909297951574
+ 1.6928e-05 1.19911644692897
+ 1.693e-05 1.19916187391462
+ 1.6932e-05 1.1992604677886
+ 1.6934e-05 1.19927248454028
+ 1.6936e-05 1.19928109900298
+ 1.6938e-05 1.19932699065151
+ 1.694e-05 1.19937864781586
+ 1.6942e-05 1.19898055288369
+ 1.6944e-05 1.19896222808968
+ 1.6946e-05 1.19865143985873
+ 1.6948e-05 1.19910985503796
+ 1.695e-05 1.19922352444324
+ 1.6952e-05 1.19917506191588
+ 1.6954e-05 1.19890937174715
+ 1.6956e-05 1.19878253507041
+ 1.6958e-05 1.19882810263598
+ 1.696e-05 1.1986774372837
+ 1.6962e-05 1.19891548171443
+ 1.6964e-05 1.1988256475471
+ 1.6966e-05 1.1987145241832
+ 1.6968e-05 1.19883773413236
+ 1.697e-05 1.19874172739335
+ 1.6972e-05 1.1987573067592
+ 1.6974e-05 1.19858795726543
+ 1.6976e-05 1.19848135860812
+ 1.6978e-05 1.19847196961138
+ 1.698e-05 1.19862806036395
+ 1.6982e-05 1.19836267437517
+ 1.6984e-05 1.19836604594142
+ 1.6986e-05 1.19841700756112
+ 1.6988e-05 1.19836950739337
+ 1.699e-05 1.19819741676321
+ 1.6992e-05 1.19829575627064
+ 1.6994e-05 1.19811864336747
+ 1.6996e-05 1.19816611200731
+ 1.6998e-05 1.19827112886161
+ 1.7e-05 1.19808764087277
+ 1.7002e-05 1.19817973375691
+ 1.7004e-05 1.19831263783789
+ 1.7006e-05 1.19827424116328
+ 1.7008e-05 1.19825521118633
+ 1.701e-05 1.19837747025831
+ 1.7012e-05 1.19830279924551
+ 1.7014e-05 1.19817898828585
+ 1.7016e-05 1.19822786535864
+ 1.7018e-05 1.19811171060473
+ 1.702e-05 1.19822038846738
+ 1.7022e-05 1.1980036970447
+ 1.7024e-05 1.19797888083392
+ 1.7026e-05 1.19767873816017
+ 1.7028e-05 1.19803083829365
+ 1.703e-05 1.19772167370557
+ 1.7032e-05 1.19754555441108
+ 1.7034e-05 1.19728968600004
+ 1.7036e-05 1.19723156067252
+ 1.7038e-05 1.19725368188832
+ 1.704e-05 1.197053848736
+ 1.7042e-05 1.19728017225053
+ 1.7044e-05 1.19734710671156
+ 1.7046e-05 1.19719413567605
+ 1.7048e-05 1.19720364404307
+ 1.705e-05 1.19747486495464
+ 1.7052e-05 1.19733334659475
+ 1.7054e-05 1.19726271896128
+ 1.7056e-05 1.19752566266966
+ 1.7058e-05 1.19765005599219
+ 1.706e-05 1.19733193640408
+ 1.7062e-05 1.19745608617812
+ 1.7064e-05 1.19752306994046
+ 1.7066e-05 1.19761887180292
+ 1.7068e-05 1.19756350776129
+ 1.707e-05 1.19776396182011
+ 1.7072e-05 1.19768189047732
+ 1.7074e-05 1.19762837395158
+ 1.7076e-05 1.197254615121
+ 1.7078e-05 1.19722015812857
+ 1.708e-05 1.19716208714282
+ 1.7082e-05 1.19697282524186
+ 1.7084e-05 1.19739531528854
+ 1.7086e-05 1.19740906299266
+ 1.7088e-05 1.19727191840327
+ 1.709e-05 1.19764088264275
+ 1.7092e-05 1.19746168059011
+ 1.7094e-05 1.19738172522163
+ 1.7096e-05 1.19744335112878
+ 1.7098e-05 1.19730306267171
+ 1.71e-05 1.19746406230584
+ 1.7102e-05 1.19765729143681
+ 1.7104e-05 1.19781258317214
+ 1.7106e-05 1.19767855208933
+ 1.7108e-05 1.19764467411748
+ 1.711e-05 1.19775718977474
+ 1.7112e-05 1.197902743809
+ 1.7114e-05 1.19791845276357
+ 1.7116e-05 1.19813627023403
+ 1.7118e-05 1.19811822808173
+ 1.712e-05 1.1981039668889
+ 1.7122e-05 1.1980797190752
+ 1.7124e-05 1.19787343703409
+ 1.7126e-05 1.1981435950218
+ 1.7128e-05 1.19826025027871
+ 1.713e-05 1.1982795789107
+ 1.7132e-05 1.19802263433255
+ 1.7134e-05 1.19821847479957
+ 1.7136e-05 1.19830161032206
+ 1.7138e-05 1.19853157314949
+ 1.714e-05 1.19877516869481
+ 1.7142e-05 1.19882174337331
+ 1.7144e-05 1.19910624352738
+ 1.7146e-05 1.19927525815457
+ 1.7148e-05 1.19903993818973
+ 1.715e-05 1.19939388499259
+ 1.7152e-05 1.19918053627783
+ 1.7154e-05 1.19939869470303
+ 1.7156e-05 1.19969920019631
+ 1.7158e-05 1.19958797465995
+ 1.716e-05 1.19966613763056
+ 1.7162e-05 1.19982043070114
+ 1.7164e-05 1.1996066445793
+ 1.7166e-05 1.19949889240822
+ 1.7168e-05 1.19933006652493
+ 1.717e-05 1.19936380391568
+ 1.7172e-05 1.19912048695044
+ 1.7174e-05 1.19884405643627
+ 1.7176e-05 1.19872965455587
+ 1.7178e-05 1.19900566817773
+ 1.718e-05 1.19880268748076
+ 1.7182e-05 1.1990883403634
+ 1.7184e-05 1.19880236666798
+ 1.7186e-05 1.19895282114244
+ 1.7188e-05 1.19936716487877
+ 1.719e-05 1.19953305041464
+ 1.7192e-05 1.19950029658612
+ 1.7194e-05 1.19922787086269
+ 1.7196e-05 1.19925905631291
+ 1.7198e-05 1.19912427140157
+ 1.72e-05 1.19913664698345
+ 1.7202e-05 1.19903334109781
+ 1.7204e-05 1.19904414748017
+ 1.7206e-05 1.19915956816476
+ 1.7208e-05 1.19890772034766
+ 1.721e-05 1.19900827739686
+ 1.7212e-05 1.1989133824544
+ 1.7214e-05 1.199033043949
+ 1.7216e-05 1.19904192224237
+ 1.7218e-05 1.19884868074163
+ 1.722e-05 1.19887777634722
+ 1.7222e-05 1.19957363121699
+ 1.7224e-05 1.1993700953628
+ 1.7226e-05 1.19960680754619
+ 1.7228e-05 1.19988652763516
+ 1.723e-05 1.1996709013843
+ 1.7232e-05 1.19961073770537
+ 1.7234e-05 1.19912854288352
+ 1.7236e-05 1.19940229077521
+ 1.7238e-05 1.19961227631406
+ 1.724e-05 1.19972711640218
+ 1.7242e-05 1.19959245300786
+ 1.7244e-05 1.19980572395598
+ 1.7246e-05 1.19999839608756
+ 1.7248e-05 1.20011692285599
+ 1.725e-05 1.20013453012887
+ 1.7252e-05 1.20030935184102
+ 1.7254e-05 1.20005531870068
+ 1.7256e-05 1.20014509627308
+ 1.7258e-05 1.19973417840716
+ 1.726e-05 1.20005261301188
+ 1.7262e-05 1.20021300307539
+ 1.7264e-05 1.20033500279112
+ 1.7266e-05 1.20013257659816
+ 1.7268e-05 1.20024420436373
+ 1.727e-05 1.20037355367441
+ 1.7272e-05 1.20024044809939
+ 1.7274e-05 1.20032619848389
+ 1.7276e-05 1.20031674020463
+ 1.7278e-05 1.20018082925151
+ 1.728e-05 1.20013742673439
+ 1.7282e-05 1.20011992486656
+ 1.7284e-05 1.2000819335249
+ 1.7286e-05 1.19969179649036
+ 1.7288e-05 1.19951095789316
+ 1.729e-05 1.19966491502872
+ 1.7292e-05 1.19985574114804
+ 1.7294e-05 1.20004711566327
+ 1.7296e-05 1.19986280790554
+ 1.7298e-05 1.19974767699431
+ 1.73e-05 1.19983044049149
+ 1.7302e-05 1.19958044711224
+ 1.7304e-05 1.19960529798779
+ 1.7306e-05 1.19977169274039
+ 1.7308e-05 1.19990572770204
+ 1.731e-05 1.20016539321796
+ 1.7312e-05 1.20039066511704
+ 1.7314e-05 1.20051696641421
+ 1.7316e-05 1.20041282192715
+ 1.7318e-05 1.20042517045791
+ 1.732e-05 1.20034673620676
+ 1.7322e-05 1.20001189746588
+ 1.7324e-05 1.20002180551203
+ 1.7326e-05 1.20018597929636
+ 1.7328e-05 1.20025691751805
+ 1.733e-05 1.2003199461993
+ 1.7332e-05 1.20064575088226
+ 1.7334e-05 1.20095181866497
+ 1.7336e-05 1.20094431593924
+ 1.7338e-05 1.20105326285456
+ 1.734e-05 1.20100149900193
+ 1.7342e-05 1.20106843885471
+ 1.7344e-05 1.20089588329604
+ 1.7346e-05 1.20075540938296
+ 1.7348e-05 1.20079357870338
+ 1.735e-05 1.20079449091226
+ 1.7352e-05 1.20084219051679
+ 1.7354e-05 1.20058848197372
+ 1.7356e-05 1.20067600751345
+ 1.7358e-05 1.20098659472649
+ 1.736e-05 1.20088865704121
+ 1.7362e-05 1.20093540550096
+ 1.7364e-05 1.20085418722075
+ 1.7366e-05 1.20094323964226
+ 1.7368e-05 1.20104368852303
+ 1.737e-05 1.20116023688428
+ 1.7372e-05 1.20081706709621
+ 1.7374e-05 1.20069548463712
+ 1.7376e-05 1.20082087411821
+ 1.7378e-05 1.20082889701998
+ 1.738e-05 1.20087238585144
+ 1.7382e-05 1.20105913013886
+ 1.7384e-05 1.20091919749204
+ 1.7386e-05 1.20072972014555
+ 1.7388e-05 1.20043697795576
+ 1.739e-05 1.20034767806891
+ 1.7392e-05 1.19999859248143
+ 1.7394e-05 1.20018281066237
+ 1.7396e-05 1.20022006083445
+ 1.7398e-05 1.20057457593102
+ 1.74e-05 1.2006803637149
+ 1.7402e-05 1.20107202282843
+ 1.7404e-05 1.20085582717729
+ 1.7406e-05 1.20057858777059
+ 1.7408e-05 1.20064479902449
+ 1.741e-05 1.20076958591722
+ 1.7412e-05 1.20077836658954
+ 1.7414e-05 1.20077200130766
+ 1.7416e-05 1.20077764530099
+ 1.7418e-05 1.20064984209114
+ 1.742e-05 1.2006112920085
+ 1.7422e-05 1.20056811951921
+ 1.7424e-05 1.20058540572605
+ 1.7426e-05 1.20069469066224
+ 1.7428e-05 1.20052848476771
+ 1.743e-05 1.20040301772712
+ 1.7432e-05 1.20050174728658
+ 1.7434e-05 1.20077769967814
+ 1.7436e-05 1.20058150578329
+ 1.7438e-05 1.2006777354118
+ 1.744e-05 1.20034641106131
+ 1.7442e-05 1.20063930357294
+ 1.7444e-05 1.20069802418223
+ 1.7446e-05 1.20055421679806
+ 1.7448e-05 1.20049058953079
+ 1.745e-05 1.20058598487146
+ 1.7452e-05 1.20081787552856
+ 1.7454e-05 1.2009382954782
+ 1.7456e-05 1.20082174735886
+ 1.7458e-05 1.20090485845246
+ 1.746e-05 1.20096674083782
+ 1.7462e-05 1.20095420206484
+ 1.7464e-05 1.2010751394664
+ 1.7466e-05 1.20107809869527
+ 1.7468e-05 1.20091436515036
+ 1.747e-05 1.20062923666138
+ 1.7472e-05 1.20071173783923
+ 1.7474e-05 1.20035288720182
+ 1.7476e-05 1.20037080766353
+ 1.7478e-05 1.20047347599441
+ 1.748e-05 1.20088690835008
+ 1.7482e-05 1.20082688389943
+ 1.7484e-05 1.20070903619584
+ 1.7486e-05 1.20054040055311
+ 1.7488e-05 1.2008794436469
+ 1.749e-05 1.20093243647064
+ 1.7492e-05 1.20094119412447
+ 1.7494e-05 1.20068755970122
+ 1.7496e-05 1.20063748562454
+ 1.7498e-05 1.20090912065554
+ 1.75e-05 1.20070686394556
+ 1.7502e-05 1.20078217551961
+ 1.7504e-05 1.2008174621924
+ 1.7506e-05 1.20077654412426
+ 1.7508e-05 1.20072554256897
+ 1.751e-05 1.20073261578456
+ 1.7512e-05 1.20062113249444
+ 1.7514e-05 1.20063383908863
+ 1.7516e-05 1.20083453762153
+ 1.7518e-05 1.20074957584093
+ 1.752e-05 1.2004238719488
+ 1.7522e-05 1.20027969193988
+ 1.7524e-05 1.20001338383607
+ 1.7526e-05 1.19938541921008
+ 1.7528e-05 1.19958094007978
+ 1.753e-05 1.19991290980229
+ 1.7532e-05 1.19989313262795
+ 1.7534e-05 1.19983608775943
+ 1.7536e-05 1.19954413612065
+ 1.7538e-05 1.19963867608167
+ 1.754e-05 1.19988249826969
+ 1.7542e-05 1.19978087761248
+ 1.7544e-05 1.19953888295401
+ 1.7546e-05 1.19951736867478
+ 1.7548e-05 1.19948448018529
+ 1.755e-05 1.19955137631571
+ 1.7552e-05 1.19959175353671
+ 1.7554e-05 1.19988314544952
+ 1.7556e-05 1.20004960789951
+ 1.7558e-05 1.19971130498465
+ 1.756e-05 1.19952779673012
+ 1.7562e-05 1.19921893674743
+ 1.7564e-05 1.19886703403489
+ 1.7566e-05 1.19883692608936
+ 1.7568e-05 1.19905086544983
+ 1.757e-05 1.19917017319035
+ 1.7572e-05 1.1992787993675
+ 1.7574e-05 1.19907704887316
+ 1.7576e-05 1.19896144229347
+ 1.7578e-05 1.19937911129468
+ 1.758e-05 1.19908113635677
+ 1.7582e-05 1.19902143959061
+ 1.7584e-05 1.19901648221607
+ 1.7586e-05 1.19897090626493
+ 1.7588e-05 1.19887776346897
+ 1.759e-05 1.19898088522623
+ 1.7592e-05 1.19926311209953
+ 1.7594e-05 1.19946750533919
+ 1.7596e-05 1.19910421172988
+ 1.7598e-05 1.19928150091828
+ 1.76e-05 1.19875017818591
+ 1.7602e-05 1.19882953624904
+ 1.7604e-05 1.19904290486429
+ 1.7606e-05 1.19933163123297
+ 1.7608e-05 1.19937664590675
+ 1.761e-05 1.19936302062391
+ 1.7612e-05 1.19943906022657
+ 1.7614e-05 1.19943960019274
+ 1.7616e-05 1.19947319225912
+ 1.7618e-05 1.19937889799328
+ 1.762e-05 1.19935393399251
+ 1.7622e-05 1.19921232851276
+ 1.7624e-05 1.19908656426423
+ 1.7626e-05 1.19900962114896
+ 1.7628e-05 1.19934032398673
+ 1.763e-05 1.19947954107249
+ 1.7632e-05 1.19949061646626
+ 1.7634e-05 1.19939037869667
+ 1.7636e-05 1.19970071904566
+ 1.7638e-05 1.19980029952964
+ 1.764e-05 1.19936313474451
+ 1.7642e-05 1.19920596260815
+ 1.7644e-05 1.19950705150407
+ 1.7646e-05 1.19956553282003
+ 1.7648e-05 1.19983529241787
+ 1.765e-05 1.20005448609191
+ 1.7652e-05 1.20033082521801
+ 1.7654e-05 1.19995131982261
+ 1.7656e-05 1.19987283307503
+ 1.7658e-05 1.20004279680523
+ 1.766e-05 1.2004329626737
+ 1.7662e-05 1.20031420252032
+ 1.7664e-05 1.20057377612377
+ 1.7666e-05 1.20041346824942
+ 1.7668e-05 1.20005443755672
+ 1.767e-05 1.1996148219054
+ 1.7672e-05 1.19961650158573
+ 1.7674e-05 1.19971332338434
+ 1.7676e-05 1.19940947580715
+ 1.7678e-05 1.19939746612302
+ 1.768e-05 1.19927777775657
+ 1.7682e-05 1.19893773719966
+ 1.7684e-05 1.19883346611155
+ 1.7686e-05 1.19887910137427
+ 1.7688e-05 1.19870946148417
+ 1.769e-05 1.19891948922203
+ 1.7692e-05 1.19910539875152
+ 1.7694e-05 1.19933069558276
+ 1.7696e-05 1.19944678997246
+ 1.7698e-05 1.19926817465076
+ 1.77e-05 1.19910794082068
+ 1.7702e-05 1.1991813121349
+ 1.7704e-05 1.1992315938586
+ 1.7706e-05 1.1992220809824
+ 1.7708e-05 1.19925025979174
+ 1.771e-05 1.19909050787799
+ 1.7712e-05 1.19904290903342
+ 1.7714e-05 1.19915030641141
+ 1.7716e-05 1.19900275326881
+ 1.7718e-05 1.19896577609934
+ 1.772e-05 1.19908296433975
+ 1.7722e-05 1.19901923049864
+ 1.7724e-05 1.19863220163238
+ 1.7726e-05 1.19896727639422
+ 1.7728e-05 1.19905325436919
+ 1.773e-05 1.1991972418138
+ 1.7732e-05 1.19936279579878
+ 1.7734e-05 1.19947959770546
+ 1.7736e-05 1.1993053916701
+ 1.7738e-05 1.19949856010203
+ 1.774e-05 1.19919777794512
+ 1.7742e-05 1.19909391037027
+ 1.7744e-05 1.19906469070729
+ 1.7746e-05 1.19893877222363
+ 1.7748e-05 1.1990602638031
+ 1.775e-05 1.19909803400667
+ 1.7752e-05 1.19927906593946
+ 1.7754e-05 1.1992847839405
+ 1.7756e-05 1.19905859601615
+ 1.7758e-05 1.19881079247318
+ 1.776e-05 1.19889355126918
+ 1.7762e-05 1.1986848073264
+ 1.7764e-05 1.19862716076549
+ 1.7766e-05 1.19871620042609
+ 1.7768e-05 1.19884704701686
+ 1.777e-05 1.1985899183938
+ 1.7772e-05 1.19831373738429
+ 1.7774e-05 1.19849578523217
+ 1.7776e-05 1.19820794994821
+ 1.7778e-05 1.1986295567411
+ 1.778e-05 1.19830804318108
+ 1.7782e-05 1.19855213111133
+ 1.7784e-05 1.1985566062395
+ 1.7786e-05 1.19856873883319
+ 1.7788e-05 1.1987807121896
+ 1.779e-05 1.19880772651817
+ 1.7792e-05 1.19874032188252
+ 1.7794e-05 1.19837758808858
+ 1.7796e-05 1.19850532710034
+ 1.7798e-05 1.1985860184203
+ 1.78e-05 1.19879211196308
+ 1.7802e-05 1.19882580565459
+ 1.7804e-05 1.19845380736956
+ 1.7806e-05 1.19870098350736
+ 1.7808e-05 1.19870422087701
+ 1.781e-05 1.19935942047251
+ 1.7812e-05 1.19900615851878
+ 1.7814e-05 1.19906988951304
+ 1.7816e-05 1.19945562354201
+ 1.7818e-05 1.19952546885367
+ 1.782e-05 1.19938385769115
+ 1.7822e-05 1.19918998456095
+ 1.7824e-05 1.19895045715387
+ 1.7826e-05 1.19920197467734
+ 1.7828e-05 1.19924419045123
+ 1.783e-05 1.19961194575414
+ 1.7832e-05 1.19954574254459
+ 1.7834e-05 1.19973424369422
+ 1.7836e-05 1.19951716394433
+ 1.7838e-05 1.19961674648695
+ 1.784e-05 1.19974334170114
+ 1.7842e-05 1.19980910195503
+ 1.7844e-05 1.19986378684628
+ 1.7846e-05 1.19988635531482
+ 1.7848e-05 1.1995432757428
+ 1.785e-05 1.19909884721205
+ 1.7852e-05 1.19924528637926
+ 1.7854e-05 1.19939400417603
+ 1.7856e-05 1.19912689995546
+ 1.7858e-05 1.19896952870319
+ 1.786e-05 1.1990346968165
+ 1.7862e-05 1.19884992217888
+ 1.7864e-05 1.19870323839745
+ 1.7866e-05 1.19876282318196
+ 1.7868e-05 1.19864205874008
+ 1.787e-05 1.19864698961071
+ 1.7872e-05 1.19853859097697
+ 1.7874e-05 1.19854931683778
+ 1.7876e-05 1.1985909188095
+ 1.7878e-05 1.1986028110413
+ 1.788e-05 1.19858960619167
+ 1.7882e-05 1.19883461357547
+ 1.7884e-05 1.19922816048683
+ 1.7886e-05 1.1992489814281
+ 1.7888e-05 1.19929316718057
+ 1.789e-05 1.19940525612417
+ 1.7892e-05 1.19951015613665
+ 1.7894e-05 1.19958765067209
+ 1.7896e-05 1.19962411690716
+ 1.7898e-05 1.19983129817762
+ 1.79e-05 1.19998086125125
+ 1.7902e-05 1.20013398803074
+ 1.7904e-05 1.2003979383791
+ 1.7906e-05 1.20019882269055
+ 1.7908e-05 1.20007996080481
+ 1.791e-05 1.19993330577851
+ 1.7912e-05 1.20007536183711
+ 1.7914e-05 1.19991726211905
+ 1.7916e-05 1.19975600508058
+ 1.7918e-05 1.19972523870901
+ 1.792e-05 1.19960098203852
+ 1.7922e-05 1.19980797812044
+ 1.7924e-05 1.19967760582408
+ 1.7926e-05 1.19939251569371
+ 1.7928e-05 1.19949893366101
+ 1.793e-05 1.19909426627968
+ 1.7932e-05 1.19925222839587
+ 1.7934e-05 1.19904033763339
+ 1.7936e-05 1.1989749074481
+ 1.7938e-05 1.19876152263994
+ 1.794e-05 1.19867865294366
+ 1.7942e-05 1.19867779954929
+ 1.7944e-05 1.19844582933324
+ 1.7946e-05 1.19846000877158
+ 1.7948e-05 1.19832635124519
+ 1.795e-05 1.19810242902361
+ 1.7952e-05 1.19828939429777
+ 1.7954e-05 1.19826853247058
+ 1.7956e-05 1.19797189879324
+ 1.7958e-05 1.19814846555489
+ 1.796e-05 1.19811441246874
+ 1.7962e-05 1.19791045615564
+ 1.7964e-05 1.19773265942759
+ 1.7966e-05 1.19777817512189
+ 1.7968e-05 1.19727234016878
+ 1.797e-05 1.19749661172441
+ 1.7972e-05 1.1972602885606
+ 1.7974e-05 1.19745142367164
+ 1.7976e-05 1.19742976301547
+ 1.7978e-05 1.19764746313527
+ 1.798e-05 1.19769623756737
+ 1.7982e-05 1.19759052553042
+ 1.7984e-05 1.19775962912437
+ 1.7986e-05 1.19814425802837
+ 1.7988e-05 1.19820960099357
+ 1.799e-05 1.19804140530528
+ 1.7992e-05 1.19806773836439
+ 1.7994e-05 1.19817491113976
+ 1.7996e-05 1.19835942656032
+ 1.7998e-05 1.19799884667641
+ 1.8e-05 1.19800723966547
+ 1.8002e-05 1.19839337587731
+ 1.8004e-05 1.19866920909555
+ 1.8006e-05 1.19873650137279
+ 1.8008e-05 1.19919298775959
+ 1.801e-05 1.1992020009956
+ 1.8012e-05 1.19932081870622
+ 1.8014e-05 1.19916991710495
+ 1.8016e-05 1.19924970326907
+ 1.8018e-05 1.19918220899119
+ 1.802e-05 1.19902334618065
+ 1.8022e-05 1.19886978011209
+ 1.8024e-05 1.19908677463345
+ 1.8026e-05 1.19900736761742
+ 1.8028e-05 1.19896924175495
+ 1.803e-05 1.1988457552925
+ 1.8032e-05 1.19886807539457
+ 1.8034e-05 1.19866016446977
+ 1.8036e-05 1.1984529909536
+ 1.8038e-05 1.19883245867537
+ 1.804e-05 1.1989791270229
+ 1.8042e-05 1.19900737384923
+ 1.8044e-05 1.19883957173798
+ 1.8046e-05 1.19871847793348
+ 1.8048e-05 1.19864479141808
+ 1.805e-05 1.19883464163053
+ 1.8052e-05 1.19908431561792
+ 1.8054e-05 1.19914573802009
+ 1.8056e-05 1.19924977614814
+ 1.8058e-05 1.19948065799805
+ 1.806e-05 1.19955562524065
+ 1.8062e-05 1.19985052900979
+ 1.8064e-05 1.19985116742505
+ 1.8066e-05 1.19969434846081
+ 1.8068e-05 1.19974611749275
+ 1.807e-05 1.19981337858525
+ 1.8072e-05 1.19964336792184
+ 1.8074e-05 1.19939917434253
+ 1.8076e-05 1.19958726974976
+ 1.8078e-05 1.19989438643272
+ 1.808e-05 1.19972651314195
+ 1.8082e-05 1.19957238833933
+ 1.8084e-05 1.19977384896783
+ 1.8086e-05 1.19995608965405
+ 1.8088e-05 1.19983659790294
+ 1.809e-05 1.19979262372816
+ 1.8092e-05 1.1998752417617
+ 1.8094e-05 1.19988878372087
+ 1.8096e-05 1.19999709521266
+ 1.8098e-05 1.20008767268155
+ 1.81e-05 1.19990935115068
+ 1.8102e-05 1.1999638291432
+ 1.8104e-05 1.19993209485351
+ 1.8106e-05 1.20008216753054
+ 1.8108e-05 1.19993209297751
+ 1.811e-05 1.19998690279395
+ 1.8112e-05 1.19985473257468
+ 1.8114e-05 1.19943433024005
+ 1.8116e-05 1.19955291173948
+ 1.8118e-05 1.19940892842416
+ 1.812e-05 1.19953130035764
+ 1.8122e-05 1.19973096971052
+ 1.8124e-05 1.19964914552276
+ 1.8126e-05 1.19973226419203
+ 1.8128e-05 1.19970402446514
+ 1.813e-05 1.19976249669026
+ 1.8132e-05 1.19954036660791
+ 1.8134e-05 1.19939378061901
+ 1.8136e-05 1.19961854573802
+ 1.8138e-05 1.20012557104896
+ 1.814e-05 1.20014209506905
+ 1.8142e-05 1.20033238936683
+ 1.8144e-05 1.20069936453118
+ 1.8146e-05 1.20065392866037
+ 1.8148e-05 1.20076137008598
+ 1.815e-05 1.20103238352662
+ 1.8152e-05 1.20091612429146
+ 1.8154e-05 1.20109927433379
+ 1.8156e-05 1.20127439192578
+ 1.8158e-05 1.20176557657906
+ 1.816e-05 1.20169740383627
+ 1.8162e-05 1.201803915503
+ 1.8164e-05 1.20181630674055
+ 1.8166e-05 1.20204738043368
+ 1.8168e-05 1.20178892921181
+ 1.817e-05 1.20172355744139
+ 1.8172e-05 1.20203957697824
+ 1.8174e-05 1.20184391039848
+ 1.8176e-05 1.20183322699465
+ 1.8178e-05 1.20190930253865
+ 1.818e-05 1.20203675303138
+ 1.8182e-05 1.20220046362963
+ 1.8184e-05 1.20247777819099
+ 1.8186e-05 1.20213082494488
+ 1.8188e-05 1.20215594856796
+ 1.819e-05 1.20223796321986
+ 1.8192e-05 1.20215447220061
+ 1.8194e-05 1.20195578166937
+ 1.8196e-05 1.2017577371646
+ 1.8198e-05 1.20187048003385
+ 1.82e-05 1.20199041697663
+ 1.8202e-05 1.20198059712334
+ 1.8204e-05 1.2018477527263
+ 1.8206e-05 1.20215830447035
+ 1.8208e-05 1.20233474696897
+ 1.821e-05 1.20228590866177
+ 1.8212e-05 1.20252246308714
+ 1.8214e-05 1.20229029372285
+ 1.8216e-05 1.20233811004793
+ 1.8218e-05 1.20236768604791
+ 1.822e-05 1.2023119302541
+ 1.8222e-05 1.20223228384203
+ 1.8224e-05 1.20194368140802
+ 1.8226e-05 1.20157060461065
+ 1.8228e-05 1.20167917228975
+ 1.823e-05 1.20147050900123
+ 1.8232e-05 1.20136682669805
+ 1.8234e-05 1.20132642788829
+ 1.8236e-05 1.20097135407473
+ 1.8238e-05 1.20089388675956
+ 1.824e-05 1.20035398488051
+ 1.8242e-05 1.20052060188183
+ 1.8244e-05 1.20083157782905
+ 1.8246e-05 1.20083491854355
+ 1.8248e-05 1.20082816638938
+ 1.825e-05 1.20100797875754
+ 1.8252e-05 1.2010024177553
+ 1.8254e-05 1.20087754342456
+ 1.8256e-05 1.20069939524863
+ 1.8258e-05 1.20065946140898
+ 1.826e-05 1.20061939548356
+ 1.8262e-05 1.20089832662769
+ 1.8264e-05 1.20083337330529
+ 1.8266e-05 1.20073628504511
+ 1.8268e-05 1.20064423207577
+ 1.827e-05 1.20028512293026
+ 1.8272e-05 1.2001650633109
+ 1.8274e-05 1.20012972889445
+ 1.8276e-05 1.19998833688806
+ 1.8278e-05 1.2001396039396
+ 1.828e-05 1.19997750031267
+ 1.8282e-05 1.20023261387971
+ 1.8284e-05 1.20039913802602
+ 1.8286e-05 1.20053909383794
+ 1.8288e-05 1.20008672698305
+ 1.829e-05 1.20006751953039
+ 1.8292e-05 1.19978500651611
+ 1.8294e-05 1.19988003278482
+ 1.8296e-05 1.20025951390934
+ 1.8298e-05 1.20032507038009
+ 1.83e-05 1.20061838991634
+ 1.8302e-05 1.20075764303673
+ 1.8304e-05 1.20078703457184
+ 1.8306e-05 1.20080126126519
+ 1.8308e-05 1.20079316050482
+ 1.831e-05 1.20031617913084
+ 1.8312e-05 1.20008114565392
+ 1.8314e-05 1.19992324140104
+ 1.8316e-05 1.19989148927348
+ 1.8318e-05 1.19969543563889
+ 1.832e-05 1.19962078009204
+ 1.8322e-05 1.19974867104848
+ 1.8324e-05 1.19956707709243
+ 1.8326e-05 1.19951178839706
+ 1.8328e-05 1.19951071674096
+ 1.833e-05 1.19916746074823
+ 1.8332e-05 1.19914434688109
+ 1.8334e-05 1.19921104491172
+ 1.8336e-05 1.19909474643791
+ 1.8338e-05 1.19911507544373
+ 1.834e-05 1.19925302228107
+ 1.8342e-05 1.19973349148265
+ 1.8344e-05 1.20003887166991
+ 1.8346e-05 1.20020050198515
+ 1.8348e-05 1.20047595849504
+ 1.835e-05 1.20033283495852
+ 1.8352e-05 1.20060650526169
+ 1.8354e-05 1.20042563841747
+ 1.8356e-05 1.20049529061761
+ 1.8358e-05 1.20053466984951
+ 1.836e-05 1.20047901233602
+ 1.8362e-05 1.20051290483207
+ 1.8364e-05 1.20047216979269
+ 1.8366e-05 1.20024693749472
+ 1.8368e-05 1.20021416791034
+ 1.837e-05 1.20028146009809
+ 1.8372e-05 1.20032108552639
+ 1.8374e-05 1.20052534114048
+ 1.8376e-05 1.2007988779806
+ 1.8378e-05 1.20079411798116
+ 1.838e-05 1.20105352391211
+ 1.8382e-05 1.20127776497629
+ 1.8384e-05 1.20113336539188
+ 1.8386e-05 1.20120273433564
+ 1.8388e-05 1.20107072538972
+ 1.839e-05 1.20160744909789
+ 1.8392e-05 1.20154177927121
+ 1.8394e-05 1.20143288713267
+ 1.8396e-05 1.20108719324293
+ 1.8398e-05 1.20134632661476
+ 1.84e-05 1.20160661351945
+ 1.8402e-05 1.20178714814461
+ 1.8404e-05 1.20166462525241
+ 1.8406e-05 1.20173786471808
+ 1.8408e-05 1.20143326132636
+ 1.841e-05 1.20129248106242
+ 1.8412e-05 1.20161836320136
+ 1.8414e-05 1.20184201546689
+ 1.8416e-05 1.2016810812295
+ 1.8418e-05 1.20161033391843
+ 1.842e-05 1.20142277450565
+ 1.8422e-05 1.20142285113107
+ 1.8424e-05 1.20128344866685
+ 1.8426e-05 1.20130663683191
+ 1.8428e-05 1.2013074252437
+ 1.843e-05 1.20139240948747
+ 1.8432e-05 1.20156218668765
+ 1.8434e-05 1.2013625597522
+ 1.8436e-05 1.20136983780011
+ 1.8438e-05 1.20115373960516
+ 1.844e-05 1.20139885048994
+ 1.8442e-05 1.20125607383964
+ 1.8444e-05 1.20109493635751
+ 1.8446e-05 1.20110019086613
+ 1.8448e-05 1.20058065677088
+ 1.845e-05 1.20060355316407
+ 1.8452e-05 1.20040774773143
+ 1.8454e-05 1.20018403563341
+ 1.8456e-05 1.2000244981496
+ 1.8458e-05 1.19982206602279
+ 1.846e-05 1.1997710846753
+ 1.8462e-05 1.19955674226194
+ 1.8464e-05 1.19946699711455
+ 1.8466e-05 1.19923573744856
+ 1.8468e-05 1.198843478563
+ 1.847e-05 1.1988811063007
+ 1.8472e-05 1.19898246444696
+ 1.8474e-05 1.19929188294925
+ 1.8476e-05 1.19923370489682
+ 1.8478e-05 1.19958567018615
+ 1.848e-05 1.19948609085934
+ 1.8482e-05 1.19950981280875
+ 1.8484e-05 1.19940884918317
+ 1.8486e-05 1.19954530630106
+ 1.8488e-05 1.19950443349404
+ 1.849e-05 1.1993117935283
+ 1.8492e-05 1.19943176286165
+ 1.8494e-05 1.19959208386021
+ 1.8496e-05 1.1995305789314
+ 1.8498e-05 1.19965297062761
+ 1.85e-05 1.19970838173315
+ 1.8502e-05 1.19987818209396
+ 1.8504e-05 1.19979418804169
+ 1.8506e-05 1.19974454948677
+ 1.8508e-05 1.19956429235859
+ 1.851e-05 1.19929174832881
+ 1.8512e-05 1.19976343599308
+ 1.8514e-05 1.19988469252442
+ 1.8516e-05 1.20017875314029
+ 1.8518e-05 1.20012803741074
+ 1.852e-05 1.20059405313431
+ 1.8522e-05 1.20093974276582
+ 1.8524e-05 1.20128818567591
+ 1.8526e-05 1.20132467733393
+ 1.8528e-05 1.20126350076534
+ 1.853e-05 1.20135649841774
+ 1.8532e-05 1.20132000197735
+ 1.8534e-05 1.2014880513265
+ 1.8536e-05 1.20136297937628
+ 1.8538e-05 1.20132711229968
+ 1.854e-05 1.20122028048801
+ 1.8542e-05 1.20130545852241
+ 1.8544e-05 1.20133065045194
+ 1.8546e-05 1.20118407255855
+ 1.8548e-05 1.20145803734372
+ 1.855e-05 1.20171823533762
+ 1.8552e-05 1.20168186147044
+ 1.8554e-05 1.20164222752783
+ 1.8556e-05 1.20147075777314
+ 1.8558e-05 1.2010078731367
+ 1.856e-05 1.20105419331228
+ 1.8562e-05 1.20084366440838
+ 1.8564e-05 1.20086049501635
+ 1.8566e-05 1.20048614907652
+ 1.8568e-05 1.20055839950674
+ 1.857e-05 1.20058590575272
+ 1.8572e-05 1.20090265986323
+ 1.8574e-05 1.20097828148415
+ 1.8576e-05 1.20113518720573
+ 1.8578e-05 1.20104053640572
+ 1.858e-05 1.20111418593892
+ 1.8582e-05 1.20091435880654
+ 1.8584e-05 1.20083183491691
+ 1.8586e-05 1.20052280123929
+ 1.8588e-05 1.20080281665993
+ 1.859e-05 1.20090551538796
+ 1.8592e-05 1.2006988177017
+ 1.8594e-05 1.20063533499662
+ 1.8596e-05 1.20024696976309
+ 1.8598e-05 1.1999238774918
+ 1.86e-05 1.19939155896523
+ 1.8602e-05 1.19944017769655
+ 1.8604e-05 1.19946593528792
+ 1.8606e-05 1.19935595733481
+ 1.8608e-05 1.19941796344805
+ 1.861e-05 1.19952736602471
+ 1.8612e-05 1.19935182124859
+ 1.8614e-05 1.19931470199513
+ 1.8616e-05 1.19927290164062
+ 1.8618e-05 1.19893803791091
+ 1.862e-05 1.19921908477893
+ 1.8622e-05 1.19926230317232
+ 1.8624e-05 1.19905684839568
+ 1.8626e-05 1.19898609421648
+ 1.8628e-05 1.19909852479877
+ 1.863e-05 1.19922706455343
+ 1.8632e-05 1.19952108846344
+ 1.8634e-05 1.19980659305322
+ 1.8636e-05 1.20001671179281
+ 1.8638e-05 1.19991089811933
+ 1.864e-05 1.19992743867875
+ 1.8642e-05 1.19980138842403
+ 1.8644e-05 1.19945246265615
+ 1.8646e-05 1.19957061690054
+ 1.8648e-05 1.19965929080063
+ 1.865e-05 1.19953580122026
+ 1.8652e-05 1.19942295446448
+ 1.8654e-05 1.19984692497253
+ 1.8656e-05 1.19966110598867
+ 1.8658e-05 1.19962809900697
+ 1.866e-05 1.19960911429492
+ 1.8662e-05 1.20020387281273
+ 1.8664e-05 1.20054767081412
+ 1.8666e-05 1.20051561776788
+ 1.8668e-05 1.20061287988027
+ 1.867e-05 1.20065281976368
+ 1.8672e-05 1.20079251589385
+ 1.8674e-05 1.20079730796668
+ 1.8676e-05 1.20097433964787
+ 1.8678e-05 1.20107603263089
+ 1.868e-05 1.20098742233974
+ 1.8682e-05 1.20049173845974
+ 1.8684e-05 1.20033371459511
+ 1.8686e-05 1.20025481410096
+ 1.8688e-05 1.19997597490834
+ 1.869e-05 1.2002200540265
+ 1.8692e-05 1.20016290835951
+ 1.8694e-05 1.19995064093313
+ 1.8696e-05 1.20024892125828
+ 1.8698e-05 1.20012358443329
+ 1.87e-05 1.20008106516805
+ 1.8702e-05 1.19959321204755
+ 1.8704e-05 1.19944042473818
+ 1.8706e-05 1.19926957471712
+ 1.8708e-05 1.19936208039717
+ 1.871e-05 1.19892709580194
+ 1.8712e-05 1.19895780001479
+ 1.8714e-05 1.19890135134231
+ 1.8716e-05 1.19892654967638
+ 1.8718e-05 1.19874519967233
+ 1.872e-05 1.19907591702951
+ 1.8722e-05 1.19930498469495
+ 1.8724e-05 1.19959902977317
+ 1.8726e-05 1.19950861155881
+ 1.8728e-05 1.19967555058936
+ 1.873e-05 1.19969600696321
+ 1.8732e-05 1.19946239405086
+ 1.8734e-05 1.19961017521404
+ 1.8736e-05 1.19936711277046
+ 1.8738e-05 1.19922095099349
+ 1.874e-05 1.19937915858247
+ 1.8742e-05 1.19937320485071
+ 1.8744e-05 1.19931090425726
+ 1.8746e-05 1.19923707130817
+ 1.8748e-05 1.19920269886368
+ 1.875e-05 1.19925601698862
+ 1.8752e-05 1.19926584999697
+ 1.8754e-05 1.19928490703096
+ 1.8756e-05 1.19947222121974
+ 1.8758e-05 1.19987358488688
+ 1.876e-05 1.20020743165627
+ 1.8762e-05 1.20023767113153
+ 1.8764e-05 1.20025084688217
+ 1.8766e-05 1.19994526697925
+ 1.8768e-05 1.2000021598496
+ 1.877e-05 1.19992954884335
+ 1.8772e-05 1.20025354310886
+ 1.8774e-05 1.20023541128729
+ 1.8776e-05 1.20038210676384
+ 1.8778e-05 1.20008178235892
+ 1.878e-05 1.19994162966288
+ 1.8782e-05 1.20004206121386
+ 1.8784e-05 1.19985790975675
+ 1.8786e-05 1.19975619767157
+ 1.8788e-05 1.19994465635673
+ 1.879e-05 1.20016997081115
+ 1.8792e-05 1.19982029344729
+ 1.8794e-05 1.19953726253787
+ 1.8796e-05 1.19986732348975
+ 1.8798e-05 1.19974816212707
+ 1.88e-05 1.19986490605267
+ 1.8802e-05 1.1999205935346
+ 1.8804e-05 1.19962819003524
+ 1.8806e-05 1.20001500284219
+ 1.8808e-05 1.19963612254147
+ 1.881e-05 1.19987662210541
+ 1.8812e-05 1.20001281166088
+ 1.8814e-05 1.1997030811919
+ 1.8816e-05 1.19967020169018
+ 1.8818e-05 1.19945018201107
+ 1.882e-05 1.19965380156454
+ 1.8822e-05 1.19993336841811
+ 1.8824e-05 1.20001693478278
+ 1.8826e-05 1.20024093613025
+ 1.8828e-05 1.20033013429667
+ 1.883e-05 1.20034952119217
+ 1.8832e-05 1.20021024099255
+ 1.8834e-05 1.20008780463137
+ 1.8836e-05 1.20003130134382
+ 1.8838e-05 1.19996035990501
+ 1.884e-05 1.19973876450307
+ 1.8842e-05 1.19950538971689
+ 1.8844e-05 1.19956340219086
+ 1.8846e-05 1.19971193715349
+ 1.8848e-05 1.199737325094
+ 1.885e-05 1.199697658306
+ 1.8852e-05 1.19985977648662
+ 1.8854e-05 1.20023454183536
+ 1.8856e-05 1.20052701434223
+ 1.8858e-05 1.20018227308182
+ 1.886e-05 1.19973921345836
+ 1.8862e-05 1.19968731627109
+ 1.8864e-05 1.19997294584763
+ 1.8866e-05 1.19994015419825
+ 1.8868e-05 1.20001721173452
+ 1.887e-05 1.19994331758855
+ 1.8872e-05 1.20011725943275
+ 1.8874e-05 1.20007573310499
+ 1.8876e-05 1.19990272988743
+ 1.8878e-05 1.19989066312789
+ 1.888e-05 1.20011529833747
+ 1.8882e-05 1.20003773310773
+ 1.8884e-05 1.20001051952535
+ 1.8886e-05 1.19991444385395
+ 1.8888e-05 1.19975999606941
+ 1.889e-05 1.19955663603112
+ 1.8892e-05 1.1999221870065
+ 1.8894e-05 1.20017662486602
+ 1.8896e-05 1.20035855798673
+ 1.8898e-05 1.20046410109504
+ 1.89e-05 1.20035278556068
+ 1.8902e-05 1.20033012452639
+ 1.8904e-05 1.2003986155591
+ 1.8906e-05 1.20034102132325
+ 1.8908e-05 1.20038825597885
+ 1.891e-05 1.20021647711602
+ 1.8912e-05 1.20007714085721
+ 1.8914e-05 1.20018853905855
+ 1.8916e-05 1.20049857215039
+ 1.8918e-05 1.2004872045381
+ 1.892e-05 1.20063196786695
+ 1.8922e-05 1.20043395450507
+ 1.8924e-05 1.20048141036412
+ 1.8926e-05 1.20036450914236
+ 1.8928e-05 1.20063948514203
+ 1.893e-05 1.20094966927608
+ 1.8932e-05 1.20124721833066
+ 1.8934e-05 1.20125036985198
+ 1.8936e-05 1.20148138884213
+ 1.8938e-05 1.20150200948271
+ 1.894e-05 1.20177041709168
+ 1.8942e-05 1.20197492984257
+ 1.8944e-05 1.20204197086284
+ 1.8946e-05 1.20205084573401
+ 1.8948e-05 1.20208486478108
+ 1.895e-05 1.20196343927984
+ 1.8952e-05 1.20180090055614
+ 1.8954e-05 1.20163281188394
+ 1.8956e-05 1.20177678471358
+ 1.8958e-05 1.20216452763569
+ 1.896e-05 1.20215728708607
+ 1.8962e-05 1.20199579802556
+ 1.8964e-05 1.20171147663853
+ 1.8966e-05 1.20181881226158
+ 1.8968e-05 1.20209604358394
+ 1.897e-05 1.20206783547343
+ 1.8972e-05 1.20215067879121
+ 1.8974e-05 1.20214145938566
+ 1.8976e-05 1.20202262309269
+ 1.8978e-05 1.20183740365942
+ 1.898e-05 1.20182684947004
+ 1.8982e-05 1.20203561029748
+ 1.8984e-05 1.20209849194008
+ 1.8986e-05 1.20205971405691
+ 1.8988e-05 1.2016892387454
+ 1.899e-05 1.20142902854951
+ 1.8992e-05 1.20138892797898
+ 1.8994e-05 1.20133874290519
+ 1.8996e-05 1.20117353370822
+ 1.8998e-05 1.20127468616935
+ 1.9e-05 1.20121688884138
+ 1.9002e-05 1.20143095150449
+ 1.9004e-05 1.20118693436434
+ 1.9006e-05 1.20131646361635
+ 1.9008e-05 1.2010991005847
+ 1.901e-05 1.20150598091796
+ 1.9012e-05 1.20138915562748
+ 1.9014e-05 1.20152026143058
+ 1.9016e-05 1.20139034132066
+ 1.9018e-05 1.20114733036465
+ 1.902e-05 1.20113604472627
+ 1.9022e-05 1.20083888792367
+ 1.9024e-05 1.20085842187077
+ 1.9026e-05 1.20099301563772
+ 1.9028e-05 1.20120589742495
+ 1.903e-05 1.20111539615978
+ 1.9032e-05 1.20078793560873
+ 1.9034e-05 1.20104415173818
+ 1.9036e-05 1.20090872167533
+ 1.9038e-05 1.20086410248145
+ 1.904e-05 1.20079974093768
+ 1.9042e-05 1.20088696259245
+ 1.9044e-05 1.20108701910852
+ 1.9046e-05 1.2007714166529
+ 1.9048e-05 1.20097450519133
+ 1.905e-05 1.2008410204804
+ 1.9052e-05 1.20057359751899
+ 1.9054e-05 1.20089270230666
+ 1.9056e-05 1.20111054858648
+ 1.9058e-05 1.20109347168287
+ 1.906e-05 1.20117456642131
+ 1.9062e-05 1.20089446512334
+ 1.9064e-05 1.20084712652205
+ 1.9066e-05 1.20068633150204
+ 1.9068e-05 1.20086701069246
+ 1.907e-05 1.20065589522127
+ 1.9072e-05 1.20074637932754
+ 1.9074e-05 1.20087417811904
+ 1.9076e-05 1.20072029095857
+ 1.9078e-05 1.20070875768311
+ 1.908e-05 1.20078022851324
+ 1.9082e-05 1.20054359114946
+ 1.9084e-05 1.2006808107065
+ 1.9086e-05 1.20062865378913
+ 1.9088e-05 1.20073235215953
+ 1.909e-05 1.20058956735703
+ 1.9092e-05 1.20072671599673
+ 1.9094e-05 1.20092348541368
+ 1.9096e-05 1.20091089538881
+ 1.9098e-05 1.20082376863379
+ 1.91e-05 1.20096557261781
+ 1.9102e-05 1.20086326694074
+ 1.9104e-05 1.20082244747436
+ 1.9106e-05 1.20112973720551
+ 1.9108e-05 1.20108984871206
+ 1.911e-05 1.20090462615418
+ 1.9112e-05 1.20114686725126
+ 1.9114e-05 1.20130798041065
+ 1.9116e-05 1.20140400464054
+ 1.9118e-05 1.20130289475813
+ 1.912e-05 1.20132886188672
+ 1.9122e-05 1.20113966197063
+ 1.9124e-05 1.2011244624506
+ 1.9126e-05 1.20149067668004
+ 1.9128e-05 1.2013977053091
+ 1.913e-05 1.2015193435901
+ 1.9132e-05 1.20182182078813
+ 1.9134e-05 1.2019503537546
+ 1.9136e-05 1.20163552612971
+ 1.9138e-05 1.20179842106127
+ 1.914e-05 1.20186530249545
+ 1.9142e-05 1.2018277117676
+ 1.9144e-05 1.2017524878957
+ 1.9146e-05 1.20187454587425
+ 1.9148e-05 1.20181702343476
+ 1.915e-05 1.20182804280859
+ 1.9152e-05 1.20159908280295
+ 1.9154e-05 1.20153456283918
+ 1.9156e-05 1.20128763294449
+ 1.9158e-05 1.20099961133323
+ 1.916e-05 1.20098009923992
+ 1.9162e-05 1.20073772742684
+ 1.9164e-05 1.20071434576788
+ 1.9166e-05 1.2005876479315
+ 1.9168e-05 1.20073825661898
+ 1.917e-05 1.20054182147819
+ 1.9172e-05 1.20060686973487
+ 1.9174e-05 1.20017497335381
+ 1.9176e-05 1.19991224390204
+ 1.9178e-05 1.19964547126676
+ 1.918e-05 1.199626009072
+ 1.9182e-05 1.19935112491173
+ 1.9184e-05 1.19958078305871
+ 1.9186e-05 1.19980098032505
+ 1.9188e-05 1.19951240860119
+ 1.919e-05 1.19962153973855
+ 1.9192e-05 1.19969256121076
+ 1.9194e-05 1.19971765274715
+ 1.9196e-05 1.19979358148069
+ 1.9198e-05 1.1995774936716
+ 1.92e-05 1.19974772954713
+ 1.9202e-05 1.20000398941252
+ 1.9204e-05 1.19979433572601
+ 1.9206e-05 1.19969635613204
+ 1.9208e-05 1.19968059648656
+ 1.921e-05 1.1995622890667
+ 1.9212e-05 1.19937481796692
+ 1.9214e-05 1.19949348922682
+ 1.9216e-05 1.19922811210272
+ 1.9218e-05 1.19899372778717
+ 1.922e-05 1.1988293719107
+ 1.9222e-05 1.1993286256571
+ 1.9224e-05 1.19968334124595
+ 1.9226e-05 1.19985774440725
+ 1.9228e-05 1.19998519537105
+ 1.923e-05 1.20021667010765
+ 1.9232e-05 1.19997559836686
+ 1.9234e-05 1.1999984576643
+ 1.9236e-05 1.20042870359504
+ 1.9238e-05 1.20049783955616
+ 1.924e-05 1.20083086943827
+ 1.9242e-05 1.20122850450159
+ 1.9244e-05 1.20078336186762
+ 1.9246e-05 1.20054603109448
+ 1.9248e-05 1.20070824748578
+ 1.925e-05 1.20087410801522
+ 1.9252e-05 1.20089818004413
+ 1.9254e-05 1.20066893043867
+ 1.9256e-05 1.20069888581801
+ 1.9258e-05 1.20059420556509
+ 1.926e-05 1.20071953242464
+ 1.9262e-05 1.20089433387424
+ 1.9264e-05 1.20121321434615
+ 1.9266e-05 1.20143948034634
+ 1.9268e-05 1.20126039782996
+ 1.927e-05 1.20126471845127
+ 1.9272e-05 1.20117412909979
+ 1.9274e-05 1.20142584912801
+ 1.9276e-05 1.20143609080273
+ 1.9278e-05 1.20103598473543
+ 1.928e-05 1.20046761097032
+ 1.9282e-05 1.20034543037943
+ 1.9284e-05 1.2004153263687
+ 1.9286e-05 1.20045196918135
+ 1.9288e-05 1.2007595470957
+ 1.929e-05 1.20047448825569
+ 1.9292e-05 1.20016740090075
+ 1.9294e-05 1.20062226266686
+ 1.9296e-05 1.20041209214468
+ 1.9298e-05 1.20058858126335
+ 1.93e-05 1.20047051625093
+ 1.9302e-05 1.20074289110015
+ 1.9304e-05 1.20080090588636
+ 1.9306e-05 1.2009788394313
+ 1.9308e-05 1.20103966882951
+ 1.931e-05 1.20111428609684
+ 1.9312e-05 1.20124916480612
+ 1.9314e-05 1.20145357148838
+ 1.9316e-05 1.20165759908784
+ 1.9318e-05 1.20172729023008
+ 1.932e-05 1.20178297521998
+ 1.9322e-05 1.20197270873307
+ 1.9324e-05 1.20204993791171
+ 1.9326e-05 1.20208900322477
+ 1.9328e-05 1.20184435213327
+ 1.933e-05 1.20204127379354
+ 1.9332e-05 1.20204814573662
+ 1.9334e-05 1.20193002324041
+ 1.9336e-05 1.20156905271684
+ 1.9338e-05 1.20163751549492
+ 1.934e-05 1.20189037556344
+ 1.9342e-05 1.20185107981469
+ 1.9344e-05 1.20181404595528
+ 1.9346e-05 1.20150376052591
+ 1.9348e-05 1.20117383512738
+ 1.935e-05 1.20083627891329
+ 1.9352e-05 1.2011031097397
+ 1.9354e-05 1.20113399436437
+ 1.9356e-05 1.20113020287047
+ 1.9358e-05 1.20109898639666
+ 1.936e-05 1.20101249998729
+ 1.9362e-05 1.20096033959485
+ 1.9364e-05 1.20107704049671
+ 1.9366e-05 1.20138511881381
+ 1.9368e-05 1.2014537157709
+ 1.937e-05 1.20133008824202
+ 1.9372e-05 1.20126054055284
+ 1.9374e-05 1.20149499847713
+ 1.9376e-05 1.20127746269847
+ 1.9378e-05 1.20149840255276
+ 1.938e-05 1.20161935487997
+ 1.9382e-05 1.20145545734669
+ 1.9384e-05 1.20131867299236
+ 1.9386e-05 1.20132749557991
+ 1.9388e-05 1.20058489949714
+ 1.939e-05 1.20026825439399
+ 1.9392e-05 1.20033413100035
+ 1.9394e-05 1.20009893718438
+ 1.9396e-05 1.2000788024958
+ 1.9398e-05 1.19994527743201
+ 1.94e-05 1.19996894771874
+ 1.9402e-05 1.20019062898049
+ 1.9404e-05 1.20029044677924
+ 1.9406e-05 1.20068227543673
+ 1.9408e-05 1.2005553174965
+ 1.941e-05 1.20059378245921
+ 1.9412e-05 1.20043972801055
+ 1.9414e-05 1.20065577077844
+ 1.9416e-05 1.20057032311275
+ 1.9418e-05 1.20097463297799
+ 1.942e-05 1.20059644427631
+ 1.9422e-05 1.20072803292544
+ 1.9424e-05 1.2006992652347
+ 1.9426e-05 1.20074742691177
+ 1.9428e-05 1.20107092299931
+ 1.943e-05 1.20090032630409
+ 1.9432e-05 1.20097511630247
+ 1.9434e-05 1.2008264995071
+ 1.9436e-05 1.20064168258204
+ 1.9438e-05 1.20052065594882
+ 1.944e-05 1.20014428045843
+ 1.9442e-05 1.20011291379734
+ 1.9444e-05 1.19992471347352
+ 1.9446e-05 1.19978500206356
+ 1.9448e-05 1.19957164820632
+ 1.945e-05 1.20016735614185
+ 1.9452e-05 1.20025046814798
+ 1.9454e-05 1.20028179536485
+ 1.9456e-05 1.2002938878436
+ 1.9458e-05 1.20040740234729
+ 1.946e-05 1.20046721323799
+ 1.9462e-05 1.2007384857445
+ 1.9464e-05 1.20074151920119
+ 1.9466e-05 1.20049733386784
+ 1.9468e-05 1.20043733727677
+ 1.947e-05 1.20037079723068
+ 1.9472e-05 1.2005249274753
+ 1.9474e-05 1.20058336120455
+ 1.9476e-05 1.20065060269987
+ 1.9478e-05 1.20064976001932
+ 1.948e-05 1.20099846340784
+ 1.9482e-05 1.20067292747185
+ 1.9484e-05 1.20050465241894
+ 1.9486e-05 1.20049038273701
+ 1.9488e-05 1.20049329201334
+ 1.949e-05 1.20063733549948
+ 1.9492e-05 1.2006177267173
+ 1.9494e-05 1.20027039970481
+ 1.9496e-05 1.20006054884112
+ 1.9498e-05 1.19975280800564
+ 1.95e-05 1.19971227289618
+ 1.9502e-05 1.19990463122655
+ 1.9504e-05 1.20016999732474
+ 1.9506e-05 1.19997154601924
+ 1.9508e-05 1.20066792417293
+ 1.951e-05 1.20047261461248
+ 1.9512e-05 1.20050181682693
+ 1.9514e-05 1.20062121379434
+ 1.9516e-05 1.20063981490849
+ 1.9518e-05 1.20097855836013
+ 1.952e-05 1.20105182686094
+ 1.9522e-05 1.2010046845827
+ 1.9524e-05 1.20101825989622
+ 1.9526e-05 1.20107560992758
+ 1.9528e-05 1.20076474467801
+ 1.953e-05 1.2005693109327
+ 1.9532e-05 1.20103694546933
+ 1.9534e-05 1.20131256897177
+ 1.9536e-05 1.20112745187826
+ 1.9538e-05 1.20116612829585
+ 1.954e-05 1.20108516270755
+ 1.9542e-05 1.20121595096505
+ 1.9544e-05 1.20113717085133
+ 1.9546e-05 1.20105458883499
+ 1.9548e-05 1.20113712284038
+ 1.955e-05 1.20128807883705
+ 1.9552e-05 1.20122664889507
+ 1.9554e-05 1.20119501529937
+ 1.9556e-05 1.20145182053749
+ 1.9558e-05 1.2011704557326
+ 1.956e-05 1.20095615724444
+ 1.9562e-05 1.20101286629415
+ 1.9564e-05 1.20077786687926
+ 1.9566e-05 1.20085284444816
+ 1.9568e-05 1.2007729195056
+ 1.957e-05 1.20066059163187
+ 1.9572e-05 1.20065349486712
+ 1.9574e-05 1.20075399535138
+ 1.9576e-05 1.20090448399905
+ 1.9578e-05 1.20053033168457
+ 1.958e-05 1.2003725487356
+ 1.9582e-05 1.2006704080441
+ 1.9584e-05 1.20085765017211
+ 1.9586e-05 1.20034958547099
+ 1.9588e-05 1.20018108836349
+ 1.959e-05 1.2002302604898
+ 1.9592e-05 1.20022996011797
+ 1.9594e-05 1.20053823406229
+ 1.9596e-05 1.20034471925012
+ 1.9598e-05 1.20007004784248
+ 1.96e-05 1.20029992576354
+ 1.9602e-05 1.20030481017584
+ 1.9604e-05 1.20049906920275
+ 1.9606e-05 1.20038244619065
+ 1.9608e-05 1.20056701530653
+ 1.961e-05 1.20043694797965
+ 1.9612e-05 1.20003538109236
+ 1.9614e-05 1.200174048967
+ 1.9616e-05 1.20016965903923
+ 1.9618e-05 1.20021054128756
+ 1.962e-05 1.2003725728621
+ 1.9622e-05 1.20015198925327
+ 1.9624e-05 1.20026479829023
+ 1.9626e-05 1.20021399312424
+ 1.9628e-05 1.20025600284998
+ 1.963e-05 1.20037404691356
+ 1.9632e-05 1.2005112310828
+ 1.9634e-05 1.20054235038785
+ 1.9636e-05 1.20044130656501
+ 1.9638e-05 1.20067975887155
+ 1.964e-05 1.20090602646562
+ 1.9642e-05 1.20080160493147
+ 1.9644e-05 1.20077044297848
+ 1.9646e-05 1.20089534132657
+ 1.9648e-05 1.20111005459412
+ 1.965e-05 1.20104440100634
+ 1.9652e-05 1.20089173645482
+ 1.9654e-05 1.20070849988354
+ 1.9656e-05 1.2007516629417
+ 1.9658e-05 1.20053603952535
+ 1.966e-05 1.20036573396635
+ 1.9662e-05 1.20037720926148
+ 1.9664e-05 1.20035848766099
+ 1.9666e-05 1.2002508924052
+ 1.9668e-05 1.20007454610576
+ 1.967e-05 1.20062237971887
+ 1.9672e-05 1.20076059489888
+ 1.9674e-05 1.2009652506655
+ 1.9676e-05 1.20126859023425
+ 1.9678e-05 1.20099678959607
+ 1.968e-05 1.2010948972012
+ 1.9682e-05 1.2012616556699
+ 1.9684e-05 1.20145994702181
+ 1.9686e-05 1.20133631953298
+ 1.9688e-05 1.20141545897402
+ 1.969e-05 1.20110308985228
+ 1.9692e-05 1.20123167663936
+ 1.9694e-05 1.20168340809799
+ 1.9696e-05 1.20169097253525
+ 1.9698e-05 1.20195087353022
+ 1.97e-05 1.2022079980147
+ 1.9702e-05 1.20221323418116
+ 1.9704e-05 1.20207007812702
+ 1.9706e-05 1.20216478744724
+ 1.9708e-05 1.2023265590755
+ 1.971e-05 1.20217980961363
+ 1.9712e-05 1.20174881367873
+ 1.9714e-05 1.20165981522912
+ 1.9716e-05 1.20118809099909
+ 1.9718e-05 1.20128179615538
+ 1.972e-05 1.20153382784426
+ 1.9722e-05 1.20127591844785
+ 1.9724e-05 1.20111700051163
+ 1.9726e-05 1.20099531320925
+ 1.9728e-05 1.20082580801275
+ 1.973e-05 1.20128192473047
+ 1.9732e-05 1.20135191434159
+ 1.9734e-05 1.20151490174405
+ 1.9736e-05 1.20130117303125
+ 1.9738e-05 1.20117558443177
+ 1.974e-05 1.20130032510406
+ 1.9742e-05 1.20095208123665
+ 1.9744e-05 1.20077293696311
+ 1.9746e-05 1.20070492663169
+ 1.9748e-05 1.200996747015
+ 1.975e-05 1.20085659722558
+ 1.9752e-05 1.20106827185048
+ 1.9754e-05 1.20079471462639
+ 1.9756e-05 1.2007146128893
+ 1.9758e-05 1.20017521443304
+ 1.976e-05 1.20018649075764
+ 1.9762e-05 1.19987768730408
+ 1.9764e-05 1.20001227605381
+ 1.9766e-05 1.20020805797196
+ 1.9768e-05 1.20015250237595
+ 1.977e-05 1.20025630667686
+ 1.9772e-05 1.20034344823125
+ 1.9774e-05 1.20011315327155
+ 1.9776e-05 1.20015327984425
+ 1.9778e-05 1.20016289866571
+ 1.978e-05 1.20011531206808
+ 1.9782e-05 1.19989355767673
+ 1.9784e-05 1.19973718798321
+ 1.9786e-05 1.19964585239872
+ 1.9788e-05 1.20003190156814
+ 1.979e-05 1.20011800256292
+ 1.9792e-05 1.19998536290039
+ 1.9794e-05 1.20005110482053
+ 1.9796e-05 1.19981882320958
+ 1.9798e-05 1.2001276817927
+ 1.98e-05 1.20033352535547
+ 1.9802e-05 1.20086135657212
+ 1.9804e-05 1.20094325378064
+ 1.9806e-05 1.20095820328126
+ 1.9808e-05 1.20086132799713
+ 1.981e-05 1.20083171477985
+ 1.9812e-05 1.20084261296321
+ 1.9814e-05 1.20092867395052
+ 1.9816e-05 1.20067054455001
+ 1.9818e-05 1.20095035461323
+ 1.982e-05 1.20092309461007
+ 1.9822e-05 1.20104423872377
+ 1.9824e-05 1.20100104013559
+ 1.9826e-05 1.20088918289684
+ 1.9828e-05 1.20085609175515
+ 1.983e-05 1.20052340313819
+ 1.9832e-05 1.20043933414997
+ 1.9834e-05 1.2004870160894
+ 1.9836e-05 1.20033049145628
+ 1.9838e-05 1.20033066651212
+ 1.984e-05 1.20009994665093
+ 1.9842e-05 1.20013004618166
+ 1.9844e-05 1.19966615142204
+ 1.9846e-05 1.19972040573106
+ 1.9848e-05 1.19976321775189
+ 1.985e-05 1.20002195467483
+ 1.9852e-05 1.19999863703628
+ 1.9854e-05 1.19984094384997
+ 1.9856e-05 1.19989218201423
+ 1.9858e-05 1.19990840896218
+ 1.986e-05 1.1999563871888
+ 1.9862e-05 1.20010707598848
+ 1.9864e-05 1.20021786735683
+ 1.9866e-05 1.2000813249267
+ 1.9868e-05 1.20012562210071
+ 1.987e-05 1.20017411032414
+ 1.9872e-05 1.20011681879476
+ 1.9874e-05 1.20024126734029
+ 1.9876e-05 1.20032499072291
+ 1.9878e-05 1.20070045251771
+ 1.988e-05 1.20038955100169
+ 1.9882e-05 1.20059013154911
+ 1.9884e-05 1.20020213765653
+ 1.9886e-05 1.20022464348116
+ 1.9888e-05 1.20017072702778
+ 1.989e-05 1.19974393190316
+ 1.9892e-05 1.19976476564761
+ 1.9894e-05 1.19971740638224
+ 1.9896e-05 1.19968611513221
+ 1.9898e-05 1.19973705686161
+ 1.99e-05 1.19966230670349
+ 1.9902e-05 1.19955768511112
+ 1.9904e-05 1.19948512007984
+ 1.9906e-05 1.19940885919811
+ 1.9908e-05 1.19942552234534
+ 1.991e-05 1.19961095735489
+ 1.9912e-05 1.19940436898743
+ 1.9914e-05 1.19938462485503
+ 1.9916e-05 1.19902288898055
+ 1.9918e-05 1.1986118765294
+ 1.992e-05 1.19870617589318
+ 1.9922e-05 1.19843698500948
+ 1.9924e-05 1.19809220382897
+ 1.9926e-05 1.19807077663064
+ 1.9928e-05 1.197953856938
+ 1.993e-05 1.19771965488381
+ 1.9932e-05 1.19757530727861
+ 1.9934e-05 1.1975480209732
+ 1.9936e-05 1.19757223145004
+ 1.9938e-05 1.19761168838221
+ 1.994e-05 1.19767773949756
+ 1.9942e-05 1.19769298516363
+ 1.9944e-05 1.1977395755211
+ 1.9946e-05 1.1980024329309
+ 1.9948e-05 1.19820831349736
+ 1.995e-05 1.19833990449575
+ 1.9952e-05 1.19862585119662
+ 1.9954e-05 1.19839804308881
+ 1.9956e-05 1.19831134810494
+ 1.9958e-05 1.1983840374295
+ 1.996e-05 1.19822071981921
+ 1.9962e-05 1.19845626873295
+ 1.9964e-05 1.19881903544418
+ 1.9966e-05 1.1991549180669
+ 1.9968e-05 1.1990625996891
+ 1.997e-05 1.19901353388937
+ 1.9972e-05 1.19904733123361
+ 1.9974e-05 1.19881432347389
+ 1.9976e-05 1.19858472348653
+ 1.9978e-05 1.19812653789417
+ 1.998e-05 1.19830364374908
+ 1.9982e-05 1.19812229037628
+ 1.9984e-05 1.19798693716053
+ 1.9986e-05 1.1981649939382
+ 1.9988e-05 1.19863284487375
+ 1.999e-05 1.19877863354695
+ 1.9992e-05 1.19897065827843
+ 1.9994e-05 1.19897338711144
+ 1.9996e-05 1.1989392020811
+ 1.9998e-05 1.19912705141258
+ 2e-05 1.19895842122325
+ )
.control
set num_threads=1
set numdgt=15
set wr_singlescale
set wr_vecnames
save v(osc_clk) v(vdd) i(vnoise) v(x1.va) v(x1.vb)
tran 0.2n 2e-05
wrdata rms_1mV.dat v(osc_clk) v(vdd) i(vnoise) v(x1.va) v(x1.vb)
quit
.endc
.end
