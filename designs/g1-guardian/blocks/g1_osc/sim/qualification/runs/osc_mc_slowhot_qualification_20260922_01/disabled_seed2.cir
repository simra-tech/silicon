* G1_OSC testbench: frequency, duty cycle, supply current at one corner/temperature/supply/trim code
* @@ fields are substituted by run_osc.sh (variants written to build/g1_osc/).
.param VDD=1.08
.lib /foss/pdks/ihp-sg13g2/libs.tech/ngspice/models/cornerMOSlv.lib mos_ss_mismatch
.lib /foss/pdks/ihp-sg13g2/libs.tech/ngspice/models/cornerRES.lib res_wcs_mismatch
.lib /foss/pdks/ihp-sg13g2/libs.tech/ngspice/models/cornerCAP.lib cap_wcs_mismatch
.lib /foss/pdks/ihp-sg13g2/libs.tech/ngspice/models/cornerDIO.lib dio_tt
* (dio_tt: the antenna diode dantenna on vth, revision 5; the diode library has one corner set)
.temp 125
* rshunt: 1 TOhm from every node to ground; without it the operating point with the antenna diode
* (revision 5) does not converge and the transient crawls (the rppd body node sub! is floating)
.option seed=62002 rshunt=1e12
.include disabled.spice
Vdd vdd 0 dc {VDD}
Ven en 0 pulse(0 {VDD} 50n 1n 1n 100 200)
Vt0 trim0 0 dc {VDD*0}
Vt1 trim1 0 dc {VDD*0}
Vt2 trim2 0 dc {VDD*0}
Vt3 trim3 0 dc {VDD*1}
X1 en trim0 trim1 trim2 trim3 osc_clk vdd 0 g1_osc
Cload osc_clk 0 50f
.control
set num_threads=1
set filetype=ascii
set numdgt=15
set wr_singlescale
set wr_vecnames
op
print @n.x1.xm1.nsg13_lv_nmos[w]
print @n.x1.xm1.nsg13_lv_nmos[l]
print @n.x1.xm1.nsg13_lv_nmos[delvto]
print @n.x1.xm1.nsg13_lv_nmos[factuo]
print @n.x1.xm2.nsg13_lv_nmos[w]
print @n.x1.xm2.nsg13_lv_nmos[l]
print @n.x1.xm2.nsg13_lv_nmos[delvto]
print @n.x1.xm2.nsg13_lv_nmos[factuo]
print @n.x1.xm3.nsg13_lv_nmos[w]
print @n.x1.xm3.nsg13_lv_nmos[l]
print @n.x1.xm3.nsg13_lv_nmos[delvto]
print @n.x1.xm3.nsg13_lv_nmos[factuo]
print @n.x1.xm4.nsg13_lv_nmos[w]
print @n.x1.xm4.nsg13_lv_nmos[l]
print @n.x1.xm4.nsg13_lv_nmos[delvto]
print @n.x1.xm4.nsg13_lv_nmos[factuo]
print @n.x1.xm5.nsg13_lv_nmos[w]
print @n.x1.xm5.nsg13_lv_nmos[l]
print @n.x1.xm5.nsg13_lv_nmos[delvto]
print @n.x1.xm5.nsg13_lv_nmos[factuo]
print @n.x1.xm6.nsg13_lv_nmos[w]
print @n.x1.xm6.nsg13_lv_nmos[l]
print @n.x1.xm6.nsg13_lv_nmos[delvto]
print @n.x1.xm6.nsg13_lv_nmos[factuo]
print @n.x1.xm7.nsg13_lv_nmos[w]
print @n.x1.xm7.nsg13_lv_nmos[l]
print @n.x1.xm7.nsg13_lv_nmos[delvto]
print @n.x1.xm7.nsg13_lv_nmos[factuo]
print @n.x1.xm8.nsg13_lv_nmos[w]
print @n.x1.xm8.nsg13_lv_nmos[l]
print @n.x1.xm8.nsg13_lv_nmos[delvto]
print @n.x1.xm8.nsg13_lv_nmos[factuo]
print @n.x1.xm9.nsg13_lv_nmos[w]
print @n.x1.xm9.nsg13_lv_nmos[l]
print @n.x1.xm9.nsg13_lv_nmos[delvto]
print @n.x1.xm9.nsg13_lv_nmos[factuo]
print @n.x1.xm10.nsg13_lv_nmos[w]
print @n.x1.xm10.nsg13_lv_nmos[l]
print @n.x1.xm10.nsg13_lv_nmos[delvto]
print @n.x1.xm10.nsg13_lv_nmos[factuo]
print @n.x1.xm11.nsg13_lv_nmos[w]
print @n.x1.xm11.nsg13_lv_nmos[l]
print @n.x1.xm11.nsg13_lv_nmos[delvto]
print @n.x1.xm11.nsg13_lv_nmos[factuo]
print @n.x1.xm12.nsg13_lv_nmos[w]
print @n.x1.xm12.nsg13_lv_nmos[l]
print @n.x1.xm12.nsg13_lv_nmos[delvto]
print @n.x1.xm12.nsg13_lv_nmos[factuo]
print @n.x1.xm13.nsg13_lv_nmos[w]
print @n.x1.xm13.nsg13_lv_nmos[l]
print @n.x1.xm13.nsg13_lv_nmos[delvto]
print @n.x1.xm13.nsg13_lv_nmos[factuo]
print @n.x1.xm14.nsg13_lv_nmos[w]
print @n.x1.xm14.nsg13_lv_nmos[l]
print @n.x1.xm14.nsg13_lv_nmos[delvto]
print @n.x1.xm14.nsg13_lv_nmos[factuo]
print @n.x1.xm15.nsg13_lv_nmos[w]
print @n.x1.xm15.nsg13_lv_nmos[l]
print @n.x1.xm15.nsg13_lv_nmos[delvto]
print @n.x1.xm15.nsg13_lv_nmos[factuo]
print @n.x1.xm16.nsg13_lv_nmos[w]
print @n.x1.xm16.nsg13_lv_nmos[l]
print @n.x1.xm16.nsg13_lv_nmos[delvto]
print @n.x1.xm16.nsg13_lv_nmos[factuo]
print @n.x1.xm17.nsg13_lv_nmos[w]
print @n.x1.xm17.nsg13_lv_nmos[l]
print @n.x1.xm17.nsg13_lv_nmos[delvto]
print @n.x1.xm17.nsg13_lv_nmos[factuo]
print @n.x1.xm18.nsg13_lv_nmos[w]
print @n.x1.xm18.nsg13_lv_nmos[l]
print @n.x1.xm18.nsg13_lv_nmos[delvto]
print @n.x1.xm18.nsg13_lv_nmos[factuo]
print @n.x1.xm19.nsg13_lv_nmos[w]
print @n.x1.xm19.nsg13_lv_nmos[l]
print @n.x1.xm19.nsg13_lv_nmos[delvto]
print @n.x1.xm19.nsg13_lv_nmos[factuo]
print @n.x1.xm20.nsg13_lv_nmos[w]
print @n.x1.xm20.nsg13_lv_nmos[l]
print @n.x1.xm20.nsg13_lv_nmos[delvto]
print @n.x1.xm20.nsg13_lv_nmos[factuo]
print @n.x1.xm21.nsg13_lv_nmos[w]
print @n.x1.xm21.nsg13_lv_nmos[l]
print @n.x1.xm21.nsg13_lv_nmos[delvto]
print @n.x1.xm21.nsg13_lv_nmos[factuo]
print @n.x1.xm22.nsg13_lv_nmos[w]
print @n.x1.xm22.nsg13_lv_nmos[l]
print @n.x1.xm22.nsg13_lv_nmos[delvto]
print @n.x1.xm22.nsg13_lv_nmos[factuo]
print @n.x1.xm23.nsg13_lv_nmos[w]
print @n.x1.xm23.nsg13_lv_nmos[l]
print @n.x1.xm23.nsg13_lv_nmos[delvto]
print @n.x1.xm23.nsg13_lv_nmos[factuo]
print @n.x1.xm24.nsg13_lv_nmos[w]
print @n.x1.xm24.nsg13_lv_nmos[l]
print @n.x1.xm24.nsg13_lv_nmos[delvto]
print @n.x1.xm24.nsg13_lv_nmos[factuo]
print @n.x1.xm25.nsg13_lv_nmos[w]
print @n.x1.xm25.nsg13_lv_nmos[l]
print @n.x1.xm25.nsg13_lv_nmos[delvto]
print @n.x1.xm25.nsg13_lv_nmos[factuo]
print @n.x1.xm26.nsg13_lv_nmos[w]
print @n.x1.xm26.nsg13_lv_nmos[l]
print @n.x1.xm26.nsg13_lv_nmos[delvto]
print @n.x1.xm26.nsg13_lv_nmos[factuo]
print @n.x1.xm27.nsg13_lv_nmos[w]
print @n.x1.xm27.nsg13_lv_nmos[l]
print @n.x1.xm27.nsg13_lv_nmos[delvto]
print @n.x1.xm27.nsg13_lv_nmos[factuo]
print @n.x1.xm28.nsg13_lv_nmos[w]
print @n.x1.xm28.nsg13_lv_nmos[l]
print @n.x1.xm28.nsg13_lv_nmos[delvto]
print @n.x1.xm28.nsg13_lv_nmos[factuo]
print @n.x1.xm29.nsg13_lv_nmos[w]
print @n.x1.xm29.nsg13_lv_nmos[l]
print @n.x1.xm29.nsg13_lv_nmos[delvto]
print @n.x1.xm29.nsg13_lv_nmos[factuo]
print @n.x1.xm30.nsg13_lv_nmos[w]
print @n.x1.xm30.nsg13_lv_nmos[l]
print @n.x1.xm30.nsg13_lv_nmos[delvto]
print @n.x1.xm30.nsg13_lv_nmos[factuo]
print @n.x1.xm31.nsg13_lv_nmos[w]
print @n.x1.xm31.nsg13_lv_nmos[l]
print @n.x1.xm31.nsg13_lv_nmos[delvto]
print @n.x1.xm31.nsg13_lv_nmos[factuo]
print @n.x1.xm32.nsg13_lv_nmos[w]
print @n.x1.xm32.nsg13_lv_nmos[l]
print @n.x1.xm32.nsg13_lv_nmos[delvto]
print @n.x1.xm32.nsg13_lv_nmos[factuo]
print @n.x1.xm33.nsg13_lv_pmos[w]
print @n.x1.xm33.nsg13_lv_pmos[l]
print @n.x1.xm33.nsg13_lv_pmos[delvto]
print @n.x1.xm33.nsg13_lv_pmos[factuo]
print @n.x1.xm34.nsg13_lv_pmos[w]
print @n.x1.xm34.nsg13_lv_pmos[l]
print @n.x1.xm34.nsg13_lv_pmos[delvto]
print @n.x1.xm34.nsg13_lv_pmos[factuo]
print @n.x1.xm35.nsg13_lv_pmos[w]
print @n.x1.xm35.nsg13_lv_pmos[l]
print @n.x1.xm35.nsg13_lv_pmos[delvto]
print @n.x1.xm35.nsg13_lv_pmos[factuo]
print @n.x1.xm36.nsg13_lv_pmos[w]
print @n.x1.xm36.nsg13_lv_pmos[l]
print @n.x1.xm36.nsg13_lv_pmos[delvto]
print @n.x1.xm36.nsg13_lv_pmos[factuo]
print @n.x1.xm37.nsg13_lv_pmos[w]
print @n.x1.xm37.nsg13_lv_pmos[l]
print @n.x1.xm37.nsg13_lv_pmos[delvto]
print @n.x1.xm37.nsg13_lv_pmos[factuo]
print @n.x1.xm38.nsg13_lv_pmos[w]
print @n.x1.xm38.nsg13_lv_pmos[l]
print @n.x1.xm38.nsg13_lv_pmos[delvto]
print @n.x1.xm38.nsg13_lv_pmos[factuo]
print @n.x1.xm39.nsg13_lv_pmos[w]
print @n.x1.xm39.nsg13_lv_pmos[l]
print @n.x1.xm39.nsg13_lv_pmos[delvto]
print @n.x1.xm39.nsg13_lv_pmos[factuo]
print @n.x1.xm40.nsg13_lv_pmos[w]
print @n.x1.xm40.nsg13_lv_pmos[l]
print @n.x1.xm40.nsg13_lv_pmos[delvto]
print @n.x1.xm40.nsg13_lv_pmos[factuo]
print @n.x1.xm41.nsg13_lv_pmos[w]
print @n.x1.xm41.nsg13_lv_pmos[l]
print @n.x1.xm41.nsg13_lv_pmos[delvto]
print @n.x1.xm41.nsg13_lv_pmos[factuo]
print @n.x1.xm42.nsg13_lv_pmos[w]
print @n.x1.xm42.nsg13_lv_pmos[l]
print @n.x1.xm42.nsg13_lv_pmos[delvto]
print @n.x1.xm42.nsg13_lv_pmos[factuo]
print @n.x1.xm43.nsg13_lv_pmos[w]
print @n.x1.xm43.nsg13_lv_pmos[l]
print @n.x1.xm43.nsg13_lv_pmos[delvto]
print @n.x1.xm43.nsg13_lv_pmos[factuo]
print @n.x1.xm44.nsg13_lv_pmos[w]
print @n.x1.xm44.nsg13_lv_pmos[l]
print @n.x1.xm44.nsg13_lv_pmos[delvto]
print @n.x1.xm44.nsg13_lv_pmos[factuo]
print @n.x1.xm45.nsg13_lv_pmos[w]
print @n.x1.xm45.nsg13_lv_pmos[l]
print @n.x1.xm45.nsg13_lv_pmos[delvto]
print @n.x1.xm45.nsg13_lv_pmos[factuo]
print @n.x1.xm46.nsg13_lv_pmos[w]
print @n.x1.xm46.nsg13_lv_pmos[l]
print @n.x1.xm46.nsg13_lv_pmos[delvto]
print @n.x1.xm46.nsg13_lv_pmos[factuo]
print @n.x1.xm47.nsg13_lv_pmos[w]
print @n.x1.xm47.nsg13_lv_pmos[l]
print @n.x1.xm47.nsg13_lv_pmos[delvto]
print @n.x1.xm47.nsg13_lv_pmos[factuo]
print @n.x1.xm48.nsg13_lv_pmos[w]
print @n.x1.xm48.nsg13_lv_pmos[l]
print @n.x1.xm48.nsg13_lv_pmos[delvto]
print @n.x1.xm48.nsg13_lv_pmos[factuo]
print @n.x1.xm49.nsg13_lv_pmos[w]
print @n.x1.xm49.nsg13_lv_pmos[l]
print @n.x1.xm49.nsg13_lv_pmos[delvto]
print @n.x1.xm49.nsg13_lv_pmos[factuo]
print @n.x1.xm50.nsg13_lv_pmos[w]
print @n.x1.xm50.nsg13_lv_pmos[l]
print @n.x1.xm50.nsg13_lv_pmos[delvto]
print @n.x1.xm50.nsg13_lv_pmos[factuo]
print @n.x1.xm51.nsg13_lv_pmos[w]
print @n.x1.xm51.nsg13_lv_pmos[l]
print @n.x1.xm51.nsg13_lv_pmos[delvto]
print @n.x1.xm51.nsg13_lv_pmos[factuo]
print @n.x1.xr53.nr1[nsmm_rsh]
print @n.x1.xr53.nr1[nsmm_w]
print @n.x1.xr53.nr1[nsmm_l]
print @n.x1.xr54.nr1[nsmm_rsh]
print @n.x1.xr54.nr1[nsmm_w]
print @n.x1.xr54.nr1[nsmm_l]
print @n.x1.xr55.nr1[nsmm_rsh]
print @n.x1.xr55.nr1[nsmm_w]
print @n.x1.xr55.nr1[nsmm_l]
print @n.x1.xr56.nr1[nsmm_rsh]
print @n.x1.xr56.nr1[nsmm_w]
print @n.x1.xr56.nr1[nsmm_l]
print @n.x1.xr57.nr1[nsmm_rsh]
print @n.x1.xr57.nr1[nsmm_w]
print @n.x1.xr57.nr1[nsmm_l]
print @n.x1.xr58.nr1[nsmm_rsh]
print @n.x1.xr58.nr1[nsmm_w]
print @n.x1.xr58.nr1[nsmm_l]
print @n.x1.xr59.nr1[nsmm_rsh]
print @n.x1.xr59.nr1[nsmm_w]
print @n.x1.xr59.nr1[nsmm_l]
print @n.x1.xr60.nr1[nsmm_rsh]
print @n.x1.xr60.nr1[nsmm_w]
print @n.x1.xr60.nr1[nsmm_l]
print @n.x1.xr61.nr1[nsmm_rsh]
print @n.x1.xr61.nr1[nsmm_w]
print @n.x1.xr61.nr1[nsmm_l]
print @n.x1.xr62.nr1[nsmm_rsh]
print @n.x1.xr62.nr1[nsmm_w]
print @n.x1.xr62.nr1[nsmm_l]
print @n.x1.xr63.nr1[nsmm_rsh]
print @n.x1.xr63.nr1[nsmm_w]
print @n.x1.xr63.nr1[nsmm_l]
print @n.x1.xr64.nr1[nsmm_rsh]
print @n.x1.xr64.nr1[nsmm_w]
print @n.x1.xr64.nr1[nsmm_l]
print @n.x1.xr65.nr1[nsmm_rsh]
print @n.x1.xr65.nr1[nsmm_w]
print @n.x1.xr65.nr1[nsmm_l]
print @n.x1.xr66.nr1[nsmm_rsh]
print @n.x1.xr66.nr1[nsmm_w]
print @n.x1.xr66.nr1[nsmm_l]
print @n.x1.xr67.nr1[nsmm_rsh]
print @n.x1.xr67.nr1[nsmm_w]
print @n.x1.xr67.nr1[nsmm_l]
print @n.x1.xr68.nr1[nsmm_rsh]
print @n.x1.xr68.nr1[nsmm_w]
print @n.x1.xr68.nr1[nsmm_l]
print @n.x1.xr69.nr1[nsmm_rsh]
print @n.x1.xr69.nr1[nsmm_w]
print @n.x1.xr69.nr1[nsmm_l]
print @n.x1.xr70.nr1[nsmm_rsh]
print @n.x1.xr70.nr1[nsmm_w]
print @n.x1.xr70.nr1[nsmm_l]
print @c.x1.xcf_a.c1[scale]
print @c.x1.xct0_a.c1[scale]
print @c.x1.xct1_a.c1[scale]
print @c.x1.xct2_a.c1[scale]
print @c.x1.xct3_a.c1[scale]
print @c.x1.xcf_b.c1[scale]
print @c.x1.xct0_b.c1[scale]
print @c.x1.xct1_b.c1[scale]
print @c.x1.xct2_b.c1[scale]
print @c.x1.xct3_b.c1[scale]
print @c.x1.xcth.c1[scale]
quit
.endc
.end
