* G1_OSC testbench: frequency, duty cycle, supply current at one corner/temperature/supply/trim code
* @@ fields are substituted by run_osc.sh (variants written to build/g1_osc/).
.param VDD=1.32
.lib /foss/pdks/ihp-sg13g2/libs.tech/ngspice/models/cornerMOSlv.lib mos_ff
.lib /foss/pdks/ihp-sg13g2/libs.tech/ngspice/models/cornerRES.lib res_bcs
.lib /foss/pdks/ihp-sg13g2/libs.tech/ngspice/models/cornerCAP.lib cap_bcs
.lib /foss/pdks/ihp-sg13g2/libs.tech/ngspice/models/cornerDIO.lib dio_tt
* (dio_tt: the antenna diode dantenna on vth, revision 5; the diode library has one corner set)
.temp -40
* rshunt: 1 TOhm from every node to ground; without it the operating point with the antenna diode
* (revision 5) does not converge and the transient crawls (the rppd body node sub! is floating)
.option rshunt=1e12
.include osc.spice
.include stdcells.spice
.include clock_load.spice
Vdd vdd 0 dc {VDD}
Ven en 0 PWL(0 0 0.05u 0 1.05u 1.32)
Vt0 trim0 0 dc {VDD*0}
Vt1 trim1 0 dc {VDD*0}
Vt2 trim2 0 dc {VDD*0}
Vt3 trim3 0 dc {VDD*0}
X1 en trim0 trim1 trim2 trim3 osc_clk vdd 0 g1_osc
* Replaced50fFstand-in withreceiver/SPEF network
Vddclk vddclk 0 dc {VDD}
.control
set num_threads=1
set numdgt=15
set wr_singlescale
set wr_vecnames
tran 0.2n 6e-06
wrdata receiver.dat v(osc_clk) v(sp__11993_A) v(sp__11993_X) v(en) i(vdd) i(vddclk) v(leaf0) v(leaf1) v(leaf2) v(leaf3) v(leaf4) v(leaf5) v(leaf6) v(leaf7) v(leaf8) v(leaf9) v(leaf10) v(leaf11) v(leaf12) v(leaf13) v(leaf14) v(leaf15)
quit
.endc
.end
