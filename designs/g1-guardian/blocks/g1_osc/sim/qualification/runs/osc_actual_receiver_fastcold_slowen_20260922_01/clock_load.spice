* Exact internal SPEF + actual receiver cells; estimatedassembly piRC
C_input_1 clk_port 0 1.84946e-17
C_input_3 sp__29_18 0 7.32916e-15
C_input_4 sp__29_16 0 9.42799e-15
C_input_5 sp__29_10 0 9.11143e-15
C_input_6 sp__29_8 0 7.03109e-15
R_input_1 clk_port sp__29_8 20.1957
R_input_2 sp__29_8 sp__29_10 88.3534
R_input_3 sp__29_10 sp__29_16 40.4146
R_input_4 sp__29_16 sp__29_18 67.0942
R_input_5 sp__29_18 sp__11993_A 40
C_root_output_1 sp__12008_A 0 1.44757e-16
C_root_output_2 sp__12009_A 0 9.73044e-17
C_root_output_3 sp__12010_A 0 1.56882e-16
C_root_output_4 sp__12011_A 0 1.59584e-16
C_root_output_5 sp__12018_A 0 5.14788e-17
C_root_output_6 sp__12016_A 0 1.81539e-16
C_root_output_11 sp__12006_A 0 1.5024e-16
C_root_output_12 sp__12019_A 0 1.4639e-16
C_root_output_13 sp__12020_A 0 1.07452e-16
C_root_output_17 sp__11993_X 0 6.48786e-17
C_root_output_18 sp__2686_498 0 1.03614e-15
C_root_output_19 sp__2686_482 0 2.27215e-16
C_root_output_20 sp__2686_478 0 2.15446e-15
C_root_output_21 sp__2686_472 0 2.20279e-15
C_root_output_22 sp__2686_454 0 1.35461e-15
C_root_output_23 sp__2686_436 0 4.78089e-16
C_root_output_24 sp__2686_428 0 1.40673e-15
C_root_output_25 sp__2686_424 0 2.20341e-15
C_root_output_26 sp__2686_412 0 5.97345e-15
C_root_output_27 sp__2686_408 0 4.43954e-15
C_root_output_28 sp__2686_404 0 1.32742e-15
C_root_output_29 sp__2686_394 0 1.61804e-15
C_root_output_30 sp__2686_392 0 3.06397e-15
C_root_output_31 sp__2686_374 0 3.32198e-16
C_root_output_32 sp__2686_370 0 1.25159e-15
C_root_output_33 sp__2686_366 0 1.97668e-15
C_root_output_34 sp__2686_338 0 2.17893e-15
C_root_output_35 sp__2686_322 0 2.77528e-15
C_root_output_36 sp__2686_306 0 8.71353e-16
C_root_output_37 sp__2686_300 0 4.98423e-15
C_root_output_38 sp__2686_298 0 3.37948e-15
C_root_output_39 sp__2686_294 0 2.03585e-15
C_root_output_40 sp__2686_277 0 1.12191e-15
C_root_output_41 sp__2686_270 0 2.19404e-16
C_root_output_42 sp__2686_264 0 1.11585e-15
C_root_output_43 sp__2686_258 0 1.63508e-15
C_root_output_44 sp__2686_252 0 1.33539e-15
C_root_output_45 sp__2686_213 0 3.90421e-15
C_root_output_46 sp__2686_195 0 1.2681e-15
C_root_output_47 sp__2686_185 0 7.58002e-15
C_root_output_48 sp__2686_171 0 1.4639e-16
C_root_output_49 sp__2686_167 0 1.39027e-15
C_root_output_50 sp__2686_163 0 4.13594e-15
C_root_output_51 sp__2686_161 0 1.23537e-15
C_root_output_52 sp__2686_143 0 4.62992e-16
C_root_output_53 sp__2686_139 0 6.37437e-15
C_root_output_54 sp__2686_120 0 2.03535e-16
C_root_output_55 sp__2686_116 0 3.35065e-15
C_root_output_56 sp__2686_106 0 6.79108e-15
C_root_output_57 sp__2686_88 0 4.0958e-15
C_root_output_58 sp__2686_86 0 1.54227e-15
C_root_output_59 sp__2686_72 0 7.5843e-15
C_root_output_60 sp__2686_68 0 2.47704e-15
C_root_output_61 sp__2686_55 0 1.04871e-15
C_root_output_62 sp__2686_53 0 1.66469e-16
C_root_output_63 sp__2686_45 0 1.22169e-15
C_root_output_64 sp__2686_43 0 1.76522e-15
C_root_output_65 sp__2686_35 0 1.38494e-15
C_root_output_66 sp__2686_27 0 1.79523e-15
C_root_output_67 sp__2686_15 0 4.74066e-15
C_root_output_68 sp__2686_8 0 6.11047e-15
C_root_output_77 sp__12016_A sp__3428_96 1.54008e-17
R_root_output_1 sp__11993_X sp__2686_8 40.5356
R_root_output_2 sp__2686_8 sp__2686_15 45.3174
R_root_output_3 sp__2686_15 sp__2686_27 49.0949
R_root_output_4 sp__2686_27 sp__2686_35 46.6332
R_root_output_5 sp__2686_35 sp__2686_43 44.8101
R_root_output_6 sp__2686_43 sp__2686_45 10.0528
R_root_output_7 sp__2686_45 sp__2686_53 40.7519
R_root_output_8 sp__2686_53 sp__2686_55 0.9682
R_root_output_9 sp__2686_55 sp__2686_68 48.3739
R_root_output_10 sp__2686_68 sp__2686_72 34.8114
R_root_output_11 sp__2686_72 sp__2686_86 48.8557
R_root_output_12 sp__2686_86 sp__2686_88 3.811
R_root_output_13 sp__2686_88 sp__12013_A 40
R_root_output_14 sp__2686_88 sp__2686_106 31.6828
R_root_output_15 sp__2686_106 sp__2686_116 47.8482
R_root_output_16 sp__2686_116 sp__2686_120 21.5862
R_root_output_17 sp__2686_120 sp__12012_A 40
R_root_output_18 sp__2686_106 sp__12005_A 40
R_root_output_19 sp__2686_72 sp__2686_139 38.1718
R_root_output_20 sp__2686_139 sp__2686_143 22.9149
R_root_output_21 sp__2686_143 sp__12020_A 20.9682
R_root_output_22 sp__2686_139 sp__2686_161 49.1979
R_root_output_23 sp__2686_161 sp__2686_163 1.339
R_root_output_24 sp__2686_163 sp__2686_167 35.8929
R_root_output_25 sp__2686_167 sp__2686_171 40
R_root_output_26 sp__2686_171 sp__12019_A 21.1845
R_root_output_27 sp__2686_163 sp__2686_185 39.3846
R_root_output_28 sp__2686_185 sp__2686_195 9.7541
R_root_output_29 sp__2686_195 sp__12006_A 21.1845
R_root_output_30 sp__2686_185 sp__2686_213 46.3886
R_root_output_31 sp__2686_213 sp__12007_A 40
R_root_output_32 sp__2686_53 sp__12014_A 20
R_root_output_33 sp__2686_15 sp__2686_252 47.5808
R_root_output_34 sp__2686_252 sp__2686_258 44.9811
R_root_output_35 sp__2686_258 sp__2686_264 30.8665
R_root_output_36 sp__2686_264 sp__2686_270 20.7519
R_root_output_37 sp__2686_270 sp__12017_A 20
R_root_output_38 sp__2686_270 sp__2686_277 1.1845
R_root_output_39 sp__2686_277 sp__2686_294 9.1882
R_root_output_40 sp__2686_294 sp__2686_298 20.5974
R_root_output_41 sp__2686_298 sp__2686_300 30.0142
R_root_output_42 sp__2686_300 sp__2686_306 7.1997
R_root_output_43 sp__2686_306 sp__12015_A 40
R_root_output_44 sp__2686_300 sp__2686_322 48.5387
R_root_output_45 sp__2686_322 sp__2686_338 37.0298
R_root_output_46 sp__2686_338 sp__12016_A 21.8128
R_root_output_47 sp__2686_294 sp__2686_366 30.1985
R_root_output_48 sp__2686_366 sp__2686_370 31.5669
R_root_output_49 sp__2686_370 sp__2686_374 22.3278
R_root_output_50 sp__2686_374 sp__12018_A 40.5356
R_root_output_51 sp__2686_8 sp__2686_392 47.9851
R_root_output_52 sp__2686_392 sp__2686_394 20
R_root_output_53 sp__2686_394 sp__2686_404 44.7646
R_root_output_54 sp__2686_404 sp__2686_408 25.7268
R_root_output_55 sp__2686_408 sp__2686_412 49.5198
R_root_output_56 sp__2686_412 sp__2686_424 49.3112
R_root_output_57 sp__2686_424 sp__2686_428 31.3506
R_root_output_58 sp__2686_428 sp__2686_436 42.4308
R_root_output_59 sp__2686_436 sp__12011_A 21.5656
R_root_output_60 sp__2686_412 sp__2686_454 30.6193
R_root_output_61 sp__2686_454 sp__12010_A 21.1845
R_root_output_62 sp__2686_408 sp__2686_472 41.6583
R_root_output_63 sp__2686_472 sp__2686_478 38.0353
R_root_output_64 sp__2686_478 sp__2686_482 21.0197
R_root_output_65 sp__2686_482 sp__12009_A 20.9167
R_root_output_66 sp__2686_394 sp__2686_498 26.9113
R_root_output_67 sp__2686_498 sp__12008_A 21.1845
Vquiet_0 sp__3428_96 0 0
Rassembly osc_clk clk_port 459.7558
Cassembly_near osc_clk 0 3.019265e-14
Cassembly_far clk_port 0 3.019265e-14
Xroot sp__11993_X sp__11993_A vddclk 0 sg13g2_buf_16
Xleaf0 leaf0 sp__12008_A vddclk 0 sg13g2_buf_8
Cleaf0 leaf0 0 1e-13
Xleaf1 leaf1 sp__12009_A vddclk 0 sg13g2_buf_8
Cleaf1 leaf1 0 1e-13
Xleaf2 leaf2 sp__12010_A vddclk 0 sg13g2_buf_8
Cleaf2 leaf2 0 1e-13
Xleaf3 leaf3 sp__12011_A vddclk 0 sg13g2_buf_8
Cleaf3 leaf3 0 1e-13
Xleaf4 leaf4 sp__12018_A vddclk 0 sg13g2_buf_8
Cleaf4 leaf4 0 1e-13
Xleaf5 leaf5 sp__12016_A vddclk 0 sg13g2_buf_8
Cleaf5 leaf5 0 1e-13
Xleaf6 leaf6 sp__12015_A vddclk 0 sg13g2_buf_8
Cleaf6 leaf6 0 1e-13
Xleaf7 leaf7 sp__12017_A vddclk 0 sg13g2_buf_8
Cleaf7 leaf7 0 1e-13
Xleaf8 leaf8 sp__12014_A vddclk 0 sg13g2_buf_8
Cleaf8 leaf8 0 1e-13
Xleaf9 leaf9 sp__12007_A vddclk 0 sg13g2_buf_8
Cleaf9 leaf9 0 1e-13
Xleaf10 leaf10 sp__12006_A vddclk 0 sg13g2_buf_8
Cleaf10 leaf10 0 1e-13
Xleaf11 leaf11 sp__12019_A vddclk 0 sg13g2_buf_8
Cleaf11 leaf11 0 1e-13
Xleaf12 leaf12 sp__12020_A vddclk 0 sg13g2_buf_8
Cleaf12 leaf12 0 1e-13
Xleaf13 leaf13 sp__12005_A vddclk 0 sg13g2_buf_8
Cleaf13 leaf13 0 1e-13
Xleaf14 leaf14 sp__12012_A vddclk 0 sg13g2_buf_8
Cleaf14 leaf14 0 1e-13
Xleaf15 leaf15 sp__12013_A vddclk 0 sg13g2_buf_8
Cleaf15 leaf15 0 1e-13
