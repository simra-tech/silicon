.SUBCKT sg13g2_Filler200 iovss iovss$1 iovss$2 vss
R$1 iovss \$1 ptap1 A=13.7536p P=50.24u
R$2 iovss$1 \$1 ptap1 A=13.4736p P=49.24u
R$3 iovss$2 \$1 ptap1 A=13.748p P=50.22u
R$4 vss \$1 ptap1 A=0.678p P=5.12u
.ENDS sg13g2_Filler200
