*********************************************************
*** NGSPICE file created by KLayout-PEX 0.3.12
*** -----------------------------------------------------
***     Extraction Engine: KPEX/2.5D
***     Technology: ihp_sg13g2
***     Date: 2026-09-19 11:08:28
*********************************************************

.SUBCKT g1_trip IOVDD|vdda ISENSE|isense VDD|vdd VREF|vref VSS|vss clk
+ clk|cmp_clk_n cmp_hard|q cmp_soft|q d0|dac_hard[0] d0|dac_soft[0]
+ d1|dac_hard[1] d1|dac_soft[1] d2|dac_hard[2] d2|dac_soft[2] d3|dac_hard[3]
+ d3|dac_soft[3] d4|dac_hard[4] d4|dac_soft[4] d5|dac_hard[5] d5|dac_soft[5]
+ d6|dac_hard[6] d6|dac_soft[6] d7|dac_hard[7] d7|dac_soft[7] icmp|inp
+ inn|out|vth_hard inn|out|vth_soft qb qb$1
M$1 \$18 d0|dac_soft[0] VSS|vss VSS|vss sg13_lv_nmos L=0.13U W=0.5U AS=0.17P
+ AD=0.17P PS=1.68U PD=1.68U rfmode=0
M$2 \$19 d1|dac_soft[1] VSS|vss VSS|vss sg13_lv_nmos L=0.13U W=0.5U AS=0.17P
+ AD=0.17P PS=1.68U PD=1.68U rfmode=0
M$3 \$20 d2|dac_soft[2] VSS|vss VSS|vss sg13_lv_nmos L=0.13U W=0.5U AS=0.17P
+ AD=0.17P PS=1.68U PD=1.68U rfmode=0
M$4 \$21 d3|dac_soft[3] VSS|vss VSS|vss sg13_lv_nmos L=0.13U W=0.5U AS=0.17P
+ AD=0.17P PS=1.68U PD=1.68U rfmode=0
M$5 \$22 d4|dac_soft[4] VSS|vss VSS|vss sg13_lv_nmos L=0.13U W=0.5U AS=0.17P
+ AD=0.17P PS=1.68U PD=1.68U rfmode=0
M$6 \$23 d5|dac_soft[5] VSS|vss VSS|vss sg13_lv_nmos L=0.13U W=0.5U AS=0.17P
+ AD=0.17P PS=1.68U PD=1.68U rfmode=0
M$7 \$24 d6|dac_soft[6] VSS|vss VSS|vss sg13_lv_nmos L=0.13U W=0.5U AS=0.17P
+ AD=0.17P PS=1.68U PD=1.68U rfmode=0
M$8 \$25 d7|dac_soft[7] VSS|vss VSS|vss sg13_lv_nmos L=0.13U W=0.5U AS=0.17P
+ AD=0.17P PS=1.68U PD=1.68U rfmode=0
M$9 \$26 d0|dac_hard[0] VSS|vss VSS|vss sg13_lv_nmos L=0.13U W=0.5U AS=0.17P
+ AD=0.17P PS=1.68U PD=1.68U rfmode=0
M$10 \$27 d1|dac_hard[1] VSS|vss VSS|vss sg13_lv_nmos L=0.13U W=0.5U AS=0.17P
+ AD=0.17P PS=1.68U PD=1.68U rfmode=0
M$11 \$28 d2|dac_hard[2] VSS|vss VSS|vss sg13_lv_nmos L=0.13U W=0.5U AS=0.17P
+ AD=0.17P PS=1.68U PD=1.68U rfmode=0
M$12 \$29 d3|dac_hard[3] VSS|vss VSS|vss sg13_lv_nmos L=0.13U W=0.5U AS=0.17P
+ AD=0.17P PS=1.68U PD=1.68U rfmode=0
M$13 \$30 d4|dac_hard[4] VSS|vss VSS|vss sg13_lv_nmos L=0.13U W=0.5U AS=0.17P
+ AD=0.17P PS=1.68U PD=1.68U rfmode=0
M$14 \$31 d5|dac_hard[5] VSS|vss VSS|vss sg13_lv_nmos L=0.13U W=0.5U AS=0.17P
+ AD=0.17P PS=1.68U PD=1.68U rfmode=0
M$15 \$32 d6|dac_hard[6] VSS|vss VSS|vss sg13_lv_nmos L=0.13U W=0.5U AS=0.17P
+ AD=0.17P PS=1.68U PD=1.68U rfmode=0
M$16 \$33 d7|dac_hard[7] VSS|vss VSS|vss sg13_lv_nmos L=0.13U W=0.5U AS=0.17P
+ AD=0.17P PS=1.68U PD=1.68U rfmode=0
M$17 \$34 d0|dac_soft[0] VSS|vss VSS|vss sg13_lv_nmos L=0.45U W=1.9U AS=0.646P
+ AD=0.646P PS=4.48U PD=4.48U rfmode=0
M$18 \$66 \$18 VSS|vss VSS|vss sg13_lv_nmos L=0.45U W=1.9U AS=0.646P AD=0.646P
+ PS=4.48U PD=4.48U rfmode=0
M$19 \$35 \$34 VSS|vss VSS|vss sg13_lv_nmos L=0.45U W=1.9U AS=0.646P AD=0.646P
+ PS=4.48U PD=4.48U rfmode=0
M$20 \$67 \$35 VSS|vss VSS|vss sg13_lv_nmos L=0.45U W=1.9U AS=0.646P AD=0.646P
+ PS=4.48U PD=4.48U rfmode=0
M$21 \$36 d1|dac_soft[1] VSS|vss VSS|vss sg13_lv_nmos L=0.45U W=1.9U AS=0.646P
+ AD=0.646P PS=4.48U PD=4.48U rfmode=0
M$22 \$68 \$19 VSS|vss VSS|vss sg13_lv_nmos L=0.45U W=1.9U AS=0.646P AD=0.646P
+ PS=4.48U PD=4.48U rfmode=0
M$23 \$37 \$36 VSS|vss VSS|vss sg13_lv_nmos L=0.45U W=1.9U AS=0.646P AD=0.646P
+ PS=4.48U PD=4.48U rfmode=0
M$24 \$69 \$37 VSS|vss VSS|vss sg13_lv_nmos L=0.45U W=1.9U AS=0.646P AD=0.646P
+ PS=4.48U PD=4.48U rfmode=0
M$25 \$38 d2|dac_soft[2] VSS|vss VSS|vss sg13_lv_nmos L=0.45U W=1.9U AS=0.646P
+ AD=0.646P PS=4.48U PD=4.48U rfmode=0
M$26 \$70 \$20 VSS|vss VSS|vss sg13_lv_nmos L=0.45U W=1.9U AS=0.646P AD=0.646P
+ PS=4.48U PD=4.48U rfmode=0
M$27 \$39 \$38 VSS|vss VSS|vss sg13_lv_nmos L=0.45U W=1.9U AS=0.646P AD=0.646P
+ PS=4.48U PD=4.48U rfmode=0
M$28 \$71 \$39 VSS|vss VSS|vss sg13_lv_nmos L=0.45U W=1.9U AS=0.646P AD=0.646P
+ PS=4.48U PD=4.48U rfmode=0
M$29 \$40 d3|dac_soft[3] VSS|vss VSS|vss sg13_lv_nmos L=0.45U W=1.9U AS=0.646P
+ AD=0.646P PS=4.48U PD=4.48U rfmode=0
M$30 \$72 \$21 VSS|vss VSS|vss sg13_lv_nmos L=0.45U W=1.9U AS=0.646P AD=0.646P
+ PS=4.48U PD=4.48U rfmode=0
M$31 \$41 \$40 VSS|vss VSS|vss sg13_lv_nmos L=0.45U W=1.9U AS=0.646P AD=0.646P
+ PS=4.48U PD=4.48U rfmode=0
M$32 \$73 \$41 VSS|vss VSS|vss sg13_lv_nmos L=0.45U W=1.9U AS=0.646P AD=0.646P
+ PS=4.48U PD=4.48U rfmode=0
M$33 \$42 d4|dac_soft[4] VSS|vss VSS|vss sg13_lv_nmos L=0.45U W=1.9U AS=0.646P
+ AD=0.646P PS=4.48U PD=4.48U rfmode=0
M$34 \$74 \$22 VSS|vss VSS|vss sg13_lv_nmos L=0.45U W=1.9U AS=0.646P AD=0.646P
+ PS=4.48U PD=4.48U rfmode=0
M$35 \$43 \$42 VSS|vss VSS|vss sg13_lv_nmos L=0.45U W=1.9U AS=0.646P AD=0.646P
+ PS=4.48U PD=4.48U rfmode=0
M$36 \$75 \$43 VSS|vss VSS|vss sg13_lv_nmos L=0.45U W=1.9U AS=0.646P AD=0.646P
+ PS=4.48U PD=4.48U rfmode=0
M$37 \$44 d5|dac_soft[5] VSS|vss VSS|vss sg13_lv_nmos L=0.45U W=1.9U AS=0.646P
+ AD=0.646P PS=4.48U PD=4.48U rfmode=0
M$38 \$76 \$23 VSS|vss VSS|vss sg13_lv_nmos L=0.45U W=1.9U AS=0.646P AD=0.646P
+ PS=4.48U PD=4.48U rfmode=0
M$39 \$45 \$44 VSS|vss VSS|vss sg13_lv_nmos L=0.45U W=1.9U AS=0.646P AD=0.646P
+ PS=4.48U PD=4.48U rfmode=0
M$40 \$77 \$45 VSS|vss VSS|vss sg13_lv_nmos L=0.45U W=1.9U AS=0.646P AD=0.646P
+ PS=4.48U PD=4.48U rfmode=0
M$41 \$46 d6|dac_soft[6] VSS|vss VSS|vss sg13_lv_nmos L=0.45U W=1.9U AS=0.646P
+ AD=0.646P PS=4.48U PD=4.48U rfmode=0
M$42 \$78 \$24 VSS|vss VSS|vss sg13_lv_nmos L=0.45U W=1.9U AS=0.646P AD=0.646P
+ PS=4.48U PD=4.48U rfmode=0
M$43 \$47 \$46 VSS|vss VSS|vss sg13_lv_nmos L=0.45U W=1.9U AS=0.646P AD=0.646P
+ PS=4.48U PD=4.48U rfmode=0
M$44 \$79 \$47 VSS|vss VSS|vss sg13_lv_nmos L=0.45U W=1.9U AS=0.646P AD=0.646P
+ PS=4.48U PD=4.48U rfmode=0
M$45 \$48 d7|dac_soft[7] VSS|vss VSS|vss sg13_lv_nmos L=0.45U W=1.9U AS=0.646P
+ AD=0.646P PS=4.48U PD=4.48U rfmode=0
M$46 \$80 \$25 VSS|vss VSS|vss sg13_lv_nmos L=0.45U W=1.9U AS=0.646P AD=0.646P
+ PS=4.48U PD=4.48U rfmode=0
M$47 \$49 \$48 VSS|vss VSS|vss sg13_lv_nmos L=0.45U W=1.9U AS=0.646P AD=0.646P
+ PS=4.48U PD=4.48U rfmode=0
M$48 \$81 \$49 VSS|vss VSS|vss sg13_lv_nmos L=0.45U W=1.9U AS=0.646P AD=0.646P
+ PS=4.48U PD=4.48U rfmode=0
M$49 \$50 d0|dac_hard[0] VSS|vss VSS|vss sg13_lv_nmos L=0.45U W=1.9U AS=0.646P
+ AD=0.646P PS=4.48U PD=4.48U rfmode=0
M$50 \$82 \$26 VSS|vss VSS|vss sg13_lv_nmos L=0.45U W=1.9U AS=0.646P AD=0.646P
+ PS=4.48U PD=4.48U rfmode=0
M$51 \$51 \$50 VSS|vss VSS|vss sg13_lv_nmos L=0.45U W=1.9U AS=0.646P AD=0.646P
+ PS=4.48U PD=4.48U rfmode=0
M$52 \$83 \$51 VSS|vss VSS|vss sg13_lv_nmos L=0.45U W=1.9U AS=0.646P AD=0.646P
+ PS=4.48U PD=4.48U rfmode=0
M$53 \$52 d1|dac_hard[1] VSS|vss VSS|vss sg13_lv_nmos L=0.45U W=1.9U AS=0.646P
+ AD=0.646P PS=4.48U PD=4.48U rfmode=0
M$54 \$84 \$27 VSS|vss VSS|vss sg13_lv_nmos L=0.45U W=1.9U AS=0.646P AD=0.646P
+ PS=4.48U PD=4.48U rfmode=0
M$55 \$53 \$52 VSS|vss VSS|vss sg13_lv_nmos L=0.45U W=1.9U AS=0.646P AD=0.646P
+ PS=4.48U PD=4.48U rfmode=0
M$56 \$85 \$53 VSS|vss VSS|vss sg13_lv_nmos L=0.45U W=1.9U AS=0.646P AD=0.646P
+ PS=4.48U PD=4.48U rfmode=0
M$57 \$54 d2|dac_hard[2] VSS|vss VSS|vss sg13_lv_nmos L=0.45U W=1.9U AS=0.646P
+ AD=0.646P PS=4.48U PD=4.48U rfmode=0
M$58 \$86 \$28 VSS|vss VSS|vss sg13_lv_nmos L=0.45U W=1.9U AS=0.646P AD=0.646P
+ PS=4.48U PD=4.48U rfmode=0
M$59 \$55 \$54 VSS|vss VSS|vss sg13_lv_nmos L=0.45U W=1.9U AS=0.646P AD=0.646P
+ PS=4.48U PD=4.48U rfmode=0
M$60 \$87 \$55 VSS|vss VSS|vss sg13_lv_nmos L=0.45U W=1.9U AS=0.646P AD=0.646P
+ PS=4.48U PD=4.48U rfmode=0
M$61 \$56 d3|dac_hard[3] VSS|vss VSS|vss sg13_lv_nmos L=0.45U W=1.9U AS=0.646P
+ AD=0.646P PS=4.48U PD=4.48U rfmode=0
M$62 \$88 \$29 VSS|vss VSS|vss sg13_lv_nmos L=0.45U W=1.9U AS=0.646P AD=0.646P
+ PS=4.48U PD=4.48U rfmode=0
M$63 \$57 \$56 VSS|vss VSS|vss sg13_lv_nmos L=0.45U W=1.9U AS=0.646P AD=0.646P
+ PS=4.48U PD=4.48U rfmode=0
M$64 \$89 \$57 VSS|vss VSS|vss sg13_lv_nmos L=0.45U W=1.9U AS=0.646P AD=0.646P
+ PS=4.48U PD=4.48U rfmode=0
M$65 \$58 d4|dac_hard[4] VSS|vss VSS|vss sg13_lv_nmos L=0.45U W=1.9U AS=0.646P
+ AD=0.646P PS=4.48U PD=4.48U rfmode=0
M$66 \$90 \$30 VSS|vss VSS|vss sg13_lv_nmos L=0.45U W=1.9U AS=0.646P AD=0.646P
+ PS=4.48U PD=4.48U rfmode=0
M$67 \$59 \$58 VSS|vss VSS|vss sg13_lv_nmos L=0.45U W=1.9U AS=0.646P AD=0.646P
+ PS=4.48U PD=4.48U rfmode=0
M$68 \$91 \$59 VSS|vss VSS|vss sg13_lv_nmos L=0.45U W=1.9U AS=0.646P AD=0.646P
+ PS=4.48U PD=4.48U rfmode=0
M$69 \$60 d5|dac_hard[5] VSS|vss VSS|vss sg13_lv_nmos L=0.45U W=1.9U AS=0.646P
+ AD=0.646P PS=4.48U PD=4.48U rfmode=0
M$70 \$92 \$31 VSS|vss VSS|vss sg13_lv_nmos L=0.45U W=1.9U AS=0.646P AD=0.646P
+ PS=4.48U PD=4.48U rfmode=0
M$71 \$61 \$60 VSS|vss VSS|vss sg13_lv_nmos L=0.45U W=1.9U AS=0.646P AD=0.646P
+ PS=4.48U PD=4.48U rfmode=0
M$72 \$93 \$61 VSS|vss VSS|vss sg13_lv_nmos L=0.45U W=1.9U AS=0.646P AD=0.646P
+ PS=4.48U PD=4.48U rfmode=0
M$73 \$62 d6|dac_hard[6] VSS|vss VSS|vss sg13_lv_nmos L=0.45U W=1.9U AS=0.646P
+ AD=0.646P PS=4.48U PD=4.48U rfmode=0
M$74 \$94 \$32 VSS|vss VSS|vss sg13_lv_nmos L=0.45U W=1.9U AS=0.646P AD=0.646P
+ PS=4.48U PD=4.48U rfmode=0
M$75 \$63 \$62 VSS|vss VSS|vss sg13_lv_nmos L=0.45U W=1.9U AS=0.646P AD=0.646P
+ PS=4.48U PD=4.48U rfmode=0
M$76 \$95 \$63 VSS|vss VSS|vss sg13_lv_nmos L=0.45U W=1.9U AS=0.646P AD=0.646P
+ PS=4.48U PD=4.48U rfmode=0
M$77 \$64 d7|dac_hard[7] VSS|vss VSS|vss sg13_lv_nmos L=0.45U W=1.9U AS=0.646P
+ AD=0.646P PS=4.48U PD=4.48U rfmode=0
M$78 \$96 \$33 VSS|vss VSS|vss sg13_lv_nmos L=0.45U W=1.9U AS=0.646P AD=0.646P
+ PS=4.48U PD=4.48U rfmode=0
M$79 \$65 \$64 VSS|vss VSS|vss sg13_lv_nmos L=0.45U W=1.9U AS=0.646P AD=0.646P
+ PS=4.48U PD=4.48U rfmode=0
M$80 \$97 \$65 VSS|vss VSS|vss sg13_lv_nmos L=0.45U W=1.9U AS=0.646P AD=0.646P
+ PS=4.48U PD=4.48U rfmode=0
M$81 \$217 \$67 \$187 VSS|vss sg13_lv_nmos L=0.45U W=2U AS=0.68P AD=0.38P
+ PS=4.68U PD=2.38U rfmode=0
M$82 \$218 \$35 \$217 VSS|vss sg13_lv_nmos L=0.45U W=2U AS=0.38P AD=0.68P
+ PS=2.38U PD=4.68U rfmode=0
M$83 \$162 \$67 \$133 VSS|vss sg13_lv_nmos L=0.45U W=2U AS=0.68P AD=0.38P
+ PS=4.68U PD=2.38U rfmode=0
M$84 \$161 \$35 \$162 VSS|vss sg13_lv_nmos L=0.45U W=2U AS=0.38P AD=0.68P
+ PS=2.38U PD=4.68U rfmode=0
M$85 \$115 \$67 \$101 VSS|vss sg13_lv_nmos L=0.45U W=2U AS=0.68P AD=0.38P
+ PS=4.68U PD=2.38U rfmode=0
M$86 \$114 \$35 \$115 VSS|vss sg13_lv_nmos L=0.45U W=2U AS=0.38P AD=0.68P
+ PS=2.38U PD=4.68U rfmode=0
M$87 \$134 \$69 \$115 VSS|vss sg13_lv_nmos L=0.45U W=2U AS=0.68P AD=0.38P
+ PS=4.68U PD=2.38U rfmode=0
M$88 \$162 \$37 \$134 VSS|vss sg13_lv_nmos L=0.45U W=2U AS=0.38P AD=0.68P
+ PS=2.38U PD=4.68U rfmode=0
M$89 \$189 \$69 \$217 VSS|vss sg13_lv_nmos L=0.45U W=2U AS=0.68P AD=0.38P
+ PS=4.68U PD=2.38U rfmode=0
M$90 \$265 \$37 \$189 VSS|vss sg13_lv_nmos L=0.45U W=2U AS=0.38P AD=0.68P
+ PS=2.38U PD=4.68U rfmode=0
M$91 \$188 \$71 \$134 VSS|vss sg13_lv_nmos L=0.45U W=2U AS=0.68P AD=0.38P
+ PS=4.68U PD=2.38U rfmode=0
M$92 \$189 \$39 \$188 VSS|vss sg13_lv_nmos L=0.45U W=2U AS=0.38P AD=0.68P
+ PS=2.38U PD=4.68U rfmode=0
M$93 \$135 \$35 \$116 VSS|vss sg13_lv_nmos L=0.45U W=2U AS=0.68P AD=0.38P
+ PS=4.68U PD=2.38U rfmode=0
M$94 \$136 \$67 \$135 VSS|vss sg13_lv_nmos L=0.45U W=2U AS=0.38P AD=0.68P
+ PS=2.38U PD=4.68U rfmode=0
M$95 \$243 \$35 \$219 VSS|vss sg13_lv_nmos L=0.45U W=2U AS=0.68P AD=0.38P
+ PS=4.68U PD=2.38U rfmode=0
M$96 \$252 \$67 \$243 VSS|vss sg13_lv_nmos L=0.45U W=2U AS=0.38P AD=0.68P
+ PS=2.38U PD=4.68U rfmode=0
M$97 \$190 \$35 \$163 VSS|vss sg13_lv_nmos L=0.45U W=2U AS=0.68P AD=0.38P
+ PS=4.68U PD=2.38U rfmode=0
M$98 \$191 \$67 \$190 VSS|vss sg13_lv_nmos L=0.45U W=2U AS=0.38P AD=0.68P
+ PS=2.38U PD=4.68U rfmode=0
M$99 \$164 \$37 \$135 VSS|vss sg13_lv_nmos L=0.45U W=2U AS=0.68P AD=0.38P
+ PS=4.68U PD=2.38U rfmode=0
M$100 \$190 \$69 \$164 VSS|vss sg13_lv_nmos L=0.45U W=2U AS=0.38P AD=0.68P
+ PS=2.38U PD=4.68U rfmode=0
M$101 \$221 \$39 \$164 VSS|vss sg13_lv_nmos L=0.45U W=2U AS=0.68P AD=0.38P
+ PS=4.68U PD=2.38U rfmode=0
M$102 \$220 \$71 \$221 VSS|vss sg13_lv_nmos L=0.45U W=2U AS=0.38P AD=0.68P
+ PS=2.38U PD=4.68U rfmode=0
M$103 \$165 \$67 \$137 VSS|vss sg13_lv_nmos L=0.45U W=2U AS=0.68P AD=0.38P
+ PS=4.68U PD=2.38U rfmode=0
M$104 \$166 \$35 \$165 VSS|vss sg13_lv_nmos L=0.45U W=2U AS=0.38P AD=0.68P
+ PS=2.38U PD=4.68U rfmode=0
M$105 \$117 \$67 \$102 VSS|vss sg13_lv_nmos L=0.45U W=2U AS=0.68P AD=0.38P
+ PS=4.68U PD=2.38U rfmode=0
M$106 \$118 \$35 \$117 VSS|vss sg13_lv_nmos L=0.45U W=2U AS=0.38P AD=0.68P
+ PS=2.38U PD=4.68U rfmode=0
M$107 \$223 \$67 \$192 VSS|vss sg13_lv_nmos L=0.45U W=2U AS=0.68P AD=0.38P
+ PS=4.68U PD=2.38U rfmode=0
M$108 \$222 \$35 \$223 VSS|vss sg13_lv_nmos L=0.45U W=2U AS=0.38P AD=0.68P
+ PS=2.38U PD=4.68U rfmode=0
M$109 \$138 \$69 \$117 VSS|vss sg13_lv_nmos L=0.45U W=2U AS=0.68P AD=0.38P
+ PS=4.68U PD=2.38U rfmode=0
M$110 \$165 \$37 \$138 VSS|vss sg13_lv_nmos L=0.45U W=2U AS=0.38P AD=0.68P
+ PS=2.38U PD=4.68U rfmode=0
M$111 \$194 \$69 \$223 VSS|vss sg13_lv_nmos L=0.45U W=2U AS=0.68P AD=0.38P
+ PS=4.68U PD=2.38U rfmode=0
M$112 \$266 \$37 \$194 VSS|vss sg13_lv_nmos L=0.45U W=2U AS=0.38P AD=0.68P
+ PS=2.38U PD=4.68U rfmode=0
M$113 \$193 \$71 \$138 VSS|vss sg13_lv_nmos L=0.45U W=2U AS=0.68P AD=0.38P
+ PS=4.68U PD=2.38U rfmode=0
M$114 \$194 \$39 \$193 VSS|vss sg13_lv_nmos L=0.45U W=2U AS=0.38P AD=0.68P
+ PS=2.38U PD=4.68U rfmode=0
M$115 \$244 \$35 \$224 VSS|vss sg13_lv_nmos L=0.45U W=2U AS=0.68P AD=0.38P
+ PS=4.68U PD=2.38U rfmode=0
M$116 \$254 \$67 \$244 VSS|vss sg13_lv_nmos L=0.45U W=2U AS=0.38P AD=0.68P
+ PS=2.38U PD=4.68U rfmode=0
M$117 \$139 \$35 \$119 VSS|vss sg13_lv_nmos L=0.45U W=2U AS=0.68P AD=0.38P
+ PS=4.68U PD=2.38U rfmode=0
M$118 \$140 \$67 \$139 VSS|vss sg13_lv_nmos L=0.45U W=2U AS=0.38P AD=0.68P
+ PS=2.38U PD=4.68U rfmode=0
M$119 \$195 \$35 \$167 VSS|vss sg13_lv_nmos L=0.45U W=2U AS=0.68P AD=0.38P
+ PS=4.68U PD=2.38U rfmode=0
M$120 \$196 \$67 \$195 VSS|vss sg13_lv_nmos L=0.45U W=2U AS=0.38P AD=0.68P
+ PS=2.38U PD=4.68U rfmode=0
M$121 \$168 \$37 \$139 VSS|vss sg13_lv_nmos L=0.45U W=2U AS=0.68P AD=0.38P
+ PS=4.68U PD=2.38U rfmode=0
M$122 \$195 \$69 \$168 VSS|vss sg13_lv_nmos L=0.45U W=2U AS=0.38P AD=0.68P
+ PS=2.38U PD=4.68U rfmode=0
M$123 \$225 \$39 \$168 VSS|vss sg13_lv_nmos L=0.45U W=2U AS=0.68P AD=0.38P
+ PS=4.68U PD=2.38U rfmode=0
M$124 \$226 \$71 \$225 VSS|vss sg13_lv_nmos L=0.45U W=2U AS=0.38P AD=0.68P
+ PS=2.38U PD=4.68U rfmode=0
M$125 \$232 \$83 \$202 VSS|vss sg13_lv_nmos L=0.45U W=2U AS=0.68P AD=0.38P
+ PS=4.68U PD=2.38U rfmode=0
M$126 \$233 \$51 \$232 VSS|vss sg13_lv_nmos L=0.45U W=2U AS=0.38P AD=0.68P
+ PS=2.38U PD=4.68U rfmode=0
M$127 \$175 \$83 \$145 VSS|vss sg13_lv_nmos L=0.45U W=2U AS=0.68P AD=0.38P
+ PS=4.68U PD=2.38U rfmode=0
M$128 \$174 \$51 \$175 VSS|vss sg13_lv_nmos L=0.45U W=2U AS=0.38P AD=0.68P
+ PS=2.38U PD=4.68U rfmode=0
M$129 \$124 \$83 \$107 VSS|vss sg13_lv_nmos L=0.45U W=2U AS=0.68P AD=0.38P
+ PS=4.68U PD=2.38U rfmode=0
M$130 \$125 \$51 \$124 VSS|vss sg13_lv_nmos L=0.45U W=2U AS=0.38P AD=0.68P
+ PS=2.38U PD=4.68U rfmode=0
M$131 \$203 \$87 \$146 VSS|vss sg13_lv_nmos L=0.45U W=2U AS=0.68P AD=0.38P
+ PS=4.68U PD=2.38U rfmode=0
M$132 \$204 \$55 \$203 VSS|vss sg13_lv_nmos L=0.45U W=2U AS=0.38P AD=0.68P
+ PS=2.38U PD=4.68U rfmode=0
M$133 \$146 \$85 \$124 VSS|vss sg13_lv_nmos L=0.45U W=2U AS=0.68P AD=0.38P
+ PS=4.68U PD=2.38U rfmode=0
M$134 \$175 \$53 \$146 VSS|vss sg13_lv_nmos L=0.45U W=2U AS=0.38P AD=0.68P
+ PS=2.38U PD=4.68U rfmode=0
M$135 \$205 \$51 \$176 VSS|vss sg13_lv_nmos L=0.45U W=2U AS=0.68P AD=0.38P
+ PS=4.68U PD=2.38U rfmode=0
M$136 \$206 \$83 \$205 VSS|vss sg13_lv_nmos L=0.45U W=2U AS=0.38P AD=0.68P
+ PS=2.38U PD=4.68U rfmode=0
M$137 \$245 \$51 \$234 VSS|vss sg13_lv_nmos L=0.45U W=2U AS=0.68P AD=0.38P
+ PS=4.68U PD=2.38U rfmode=0
M$138 \$261 \$83 \$245 VSS|vss sg13_lv_nmos L=0.45U W=2U AS=0.38P AD=0.68P
+ PS=2.38U PD=4.68U rfmode=0
M$139 \$148 \$51 \$126 VSS|vss sg13_lv_nmos L=0.45U W=2U AS=0.68P AD=0.38P
+ PS=4.68U PD=2.38U rfmode=0
M$140 \$147 \$83 \$148 VSS|vss sg13_lv_nmos L=0.45U W=2U AS=0.38P AD=0.68P
+ PS=2.38U PD=4.68U rfmode=0
M$141 \$177 \$53 \$148 VSS|vss sg13_lv_nmos L=0.45U W=2U AS=0.68P AD=0.38P
+ PS=4.68U PD=2.38U rfmode=0
M$142 \$205 \$85 \$177 VSS|vss sg13_lv_nmos L=0.45U W=2U AS=0.38P AD=0.68P
+ PS=2.38U PD=4.68U rfmode=0
M$143 \$235 \$55 \$177 VSS|vss sg13_lv_nmos L=0.45U W=2U AS=0.68P AD=0.38P
+ PS=4.68U PD=2.38U rfmode=0
M$144 \$236 \$87 \$235 VSS|vss sg13_lv_nmos L=0.45U W=2U AS=0.38P AD=0.68P
+ PS=2.38U PD=4.68U rfmode=0
M$145 \$237 \$83 \$207 VSS|vss sg13_lv_nmos L=0.45U W=2U AS=0.68P AD=0.38P
+ PS=4.68U PD=2.38U rfmode=0
M$146 \$238 \$51 \$237 VSS|vss sg13_lv_nmos L=0.45U W=2U AS=0.38P AD=0.68P
+ PS=2.38U PD=4.68U rfmode=0
M$147 \$178 \$83 \$149 VSS|vss sg13_lv_nmos L=0.45U W=2U AS=0.68P AD=0.38P
+ PS=4.68U PD=2.38U rfmode=0
M$148 \$179 \$51 \$178 VSS|vss sg13_lv_nmos L=0.45U W=2U AS=0.38P AD=0.68P
+ PS=2.38U PD=4.68U rfmode=0
M$149 \$128 \$83 \$108 VSS|vss sg13_lv_nmos L=0.45U W=2U AS=0.68P AD=0.38P
+ PS=4.68U PD=2.38U rfmode=0
M$150 \$127 \$51 \$128 VSS|vss sg13_lv_nmos L=0.45U W=2U AS=0.38P AD=0.68P
+ PS=2.38U PD=4.68U rfmode=0
M$151 \$208 \$87 \$150 VSS|vss sg13_lv_nmos L=0.45U W=2U AS=0.68P AD=0.38P
+ PS=4.68U PD=2.38U rfmode=0
M$152 \$209 \$55 \$208 VSS|vss sg13_lv_nmos L=0.45U W=2U AS=0.38P AD=0.68P
+ PS=2.38U PD=4.68U rfmode=0
M$153 \$150 \$85 \$128 VSS|vss sg13_lv_nmos L=0.45U W=2U AS=0.68P AD=0.38P
+ PS=4.68U PD=2.38U rfmode=0
M$154 \$178 \$53 \$150 VSS|vss sg13_lv_nmos L=0.45U W=2U AS=0.38P AD=0.68P
+ PS=2.38U PD=4.68U rfmode=0
M$155 \$209 \$85 \$237 VSS|vss sg13_lv_nmos L=0.45U W=2U AS=0.68P AD=0.38P
+ PS=4.68U PD=2.38U rfmode=0
M$156 \$268 \$53 \$209 VSS|vss sg13_lv_nmos L=0.45U W=2U AS=0.38P AD=0.68P
+ PS=2.38U PD=4.68U rfmode=0
M$157 \$151 \$51 \$129 VSS|vss sg13_lv_nmos L=0.45U W=2U AS=0.68P AD=0.38P
+ PS=4.68U PD=2.38U rfmode=0
M$158 \$152 \$83 \$151 VSS|vss sg13_lv_nmos L=0.45U W=2U AS=0.38P AD=0.68P
+ PS=2.38U PD=4.68U rfmode=0
M$159 \$246 \$51 \$239 VSS|vss sg13_lv_nmos L=0.45U W=2U AS=0.68P AD=0.38P
+ PS=4.68U PD=2.38U rfmode=0
M$160 \$263 \$83 \$246 VSS|vss sg13_lv_nmos L=0.45U W=2U AS=0.38P AD=0.68P
+ PS=2.38U PD=4.68U rfmode=0
M$161 \$210 \$51 \$180 VSS|vss sg13_lv_nmos L=0.45U W=2U AS=0.68P AD=0.38P
+ PS=4.68U PD=2.38U rfmode=0
M$162 \$211 \$83 \$210 VSS|vss sg13_lv_nmos L=0.45U W=2U AS=0.38P AD=0.68P
+ PS=2.38U PD=4.68U rfmode=0
M$163 \$181 \$53 \$151 VSS|vss sg13_lv_nmos L=0.45U W=2U AS=0.68P AD=0.38P
+ PS=4.68U PD=2.38U rfmode=0
M$164 \$210 \$85 \$181 VSS|vss sg13_lv_nmos L=0.45U W=2U AS=0.38P AD=0.68P
+ PS=2.38U PD=4.68U rfmode=0
M$165 \$240 \$55 \$181 VSS|vss sg13_lv_nmos L=0.45U W=2U AS=0.68P AD=0.38P
+ PS=4.68U PD=2.38U rfmode=0
M$166 \$241 \$87 \$240 VSS|vss sg13_lv_nmos L=0.45U W=2U AS=0.38P AD=0.68P
+ PS=2.38U PD=4.68U rfmode=0
M$167 \$204 \$85 \$232 VSS|vss sg13_lv_nmos L=0.45U W=2U AS=0.68P AD=0.38P
+ PS=4.68U PD=2.38U rfmode=0
M$168 \$267 \$53 \$204 VSS|vss sg13_lv_nmos L=0.45U W=2U AS=0.38P AD=0.68P
+ PS=2.38U PD=4.68U rfmode=0
M$169 \$265 \$67 \$251 VSS|vss sg13_lv_nmos L=0.45U W=2U AS=0.68P AD=0.38P
+ PS=4.68U PD=2.38U rfmode=0
M$170 \$273 \$35 \$265 VSS|vss sg13_lv_nmos L=0.45U W=2U AS=0.38P AD=0.68P
+ PS=2.38U PD=4.68U rfmode=0
M$171 \$220 \$37 \$243 VSS|vss sg13_lv_nmos L=0.45U W=2U AS=0.68P AD=0.38P
+ PS=4.68U PD=2.38U rfmode=0
M$172 \$288 \$69 \$220 VSS|vss sg13_lv_nmos L=0.45U W=2U AS=0.38P AD=0.68P
+ PS=2.38U PD=4.68U rfmode=0
M$173 \$266 \$67 \$253 VSS|vss sg13_lv_nmos L=0.45U W=2U AS=0.68P AD=0.38P
+ PS=4.68U PD=2.38U rfmode=0
M$174 \$275 \$35 \$266 VSS|vss sg13_lv_nmos L=0.45U W=2U AS=0.38P AD=0.68P
+ PS=2.38U PD=4.68U rfmode=0
M$175 \$226 \$37 \$244 VSS|vss sg13_lv_nmos L=0.45U W=2U AS=0.68P AD=0.38P
+ PS=4.68U PD=2.38U rfmode=0
M$176 \$290 \$69 \$226 VSS|vss sg13_lv_nmos L=0.45U W=2U AS=0.38P AD=0.68P
+ PS=2.38U PD=4.68U rfmode=0
M$177 \$267 \$83 \$260 VSS|vss sg13_lv_nmos L=0.45U W=2U AS=0.68P AD=0.38P
+ PS=4.68U PD=2.38U rfmode=0
M$178 \$282 \$51 \$267 VSS|vss sg13_lv_nmos L=0.45U W=2U AS=0.38P AD=0.68P
+ PS=2.38U PD=4.68U rfmode=0
M$179 \$236 \$53 \$245 VSS|vss sg13_lv_nmos L=0.45U W=2U AS=0.68P AD=0.38P
+ PS=4.68U PD=2.38U rfmode=0
M$180 \$292 \$85 \$236 VSS|vss sg13_lv_nmos L=0.45U W=2U AS=0.38P AD=0.68P
+ PS=2.38U PD=4.68U rfmode=0
M$181 \$268 \$83 \$262 VSS|vss sg13_lv_nmos L=0.45U W=2U AS=0.68P AD=0.38P
+ PS=4.68U PD=2.38U rfmode=0
M$182 \$284 \$51 \$268 VSS|vss sg13_lv_nmos L=0.45U W=2U AS=0.38P AD=0.68P
+ PS=2.38U PD=4.68U rfmode=0
M$183 \$241 \$53 \$246 VSS|vss sg13_lv_nmos L=0.45U W=2U AS=0.68P AD=0.38P
+ PS=4.68U PD=2.38U rfmode=0
M$184 \$294 \$85 \$241 VSS|vss sg13_lv_nmos L=0.45U W=2U AS=0.38P AD=0.68P
+ PS=2.38U PD=4.68U rfmode=0
M$185 \$287 \$73 \$188 VSS|vss sg13_lv_nmos L=0.45U W=2U AS=0.68P AD=0.38P
+ PS=4.68U PD=2.38U rfmode=0
M$186 \$300 \$41 \$287 VSS|vss sg13_lv_nmos L=0.45U W=2U AS=0.38P AD=0.68P
+ PS=2.38U PD=4.68U rfmode=0
M$187 \$290 \$35 \$276 VSS|vss sg13_lv_nmos L=0.45U W=2U AS=0.68P AD=0.38P
+ PS=4.68U PD=2.38U rfmode=0
M$188 \$304 \$67 \$290 VSS|vss sg13_lv_nmos L=0.45U W=2U AS=0.38P AD=0.68P
+ PS=2.38U PD=4.68U rfmode=0
M$189 \$291 \$89 \$203 VSS|vss sg13_lv_nmos L=0.45U W=2U AS=0.68P AD=0.38P
+ PS=4.68U PD=2.38U rfmode=0
M$190 \$311 \$57 \$291 VSS|vss sg13_lv_nmos L=0.45U W=2U AS=0.38P AD=0.68P
+ PS=2.38U PD=4.68U rfmode=0
M$191 \$293 \$89 \$208 VSS|vss sg13_lv_nmos L=0.45U W=2U AS=0.68P AD=0.38P
+ PS=4.68U PD=2.38U rfmode=0
M$192 \$314 \$57 \$293 VSS|vss sg13_lv_nmos L=0.45U W=2U AS=0.38P AD=0.68P
+ PS=2.38U PD=4.68U rfmode=0
M$193 \$294 \$51 \$285 VSS|vss sg13_lv_nmos L=0.45U W=2U AS=0.68P AD=0.38P
+ PS=4.68U PD=2.38U rfmode=0
M$194 \$315 \$83 \$294 VSS|vss sg13_lv_nmos L=0.45U W=2U AS=0.38P AD=0.68P
+ PS=2.38U PD=4.68U rfmode=0
M$195 \$288 \$35 \$274 VSS|vss sg13_lv_nmos L=0.45U W=2U AS=0.68P AD=0.38P
+ PS=4.68U PD=2.38U rfmode=0
M$196 \$301 \$67 \$288 VSS|vss sg13_lv_nmos L=0.45U W=2U AS=0.38P AD=0.68P
+ PS=2.38U PD=4.68U rfmode=0
M$197 \$289 \$73 \$193 VSS|vss sg13_lv_nmos L=0.45U W=2U AS=0.68P AD=0.38P
+ PS=4.68U PD=2.38U rfmode=0
M$198 \$303 \$41 \$289 VSS|vss sg13_lv_nmos L=0.45U W=2U AS=0.38P AD=0.68P
+ PS=2.38U PD=4.68U rfmode=0
M$199 \$292 \$51 \$283 VSS|vss sg13_lv_nmos L=0.45U W=2U AS=0.68P AD=0.38P
+ PS=4.68U PD=2.38U rfmode=0
M$200 \$312 \$83 \$292 VSS|vss sg13_lv_nmos L=0.45U W=2U AS=0.38P AD=0.68P
+ PS=2.38U PD=4.68U rfmode=0
M$201 \$317 \$67 \$299 VSS|vss sg13_lv_nmos L=0.45U W=2U AS=0.68P AD=0.38P
+ PS=4.68U PD=2.38U rfmode=0
M$202 \$329 \$35 \$317 VSS|vss sg13_lv_nmos L=0.45U W=2U AS=0.38P AD=0.68P
+ PS=2.38U PD=4.68U rfmode=0
M$203 \$318 \$41 \$221 VSS|vss sg13_lv_nmos L=0.45U W=2U AS=0.68P AD=0.38P
+ PS=4.68U PD=2.38U rfmode=0
M$204 \$331 \$73 \$318 VSS|vss sg13_lv_nmos L=0.45U W=2U AS=0.38P AD=0.68P
+ PS=2.38U PD=4.68U rfmode=0
M$205 \$319 \$67 \$302 VSS|vss sg13_lv_nmos L=0.45U W=2U AS=0.68P AD=0.38P
+ PS=4.68U PD=2.38U rfmode=0
M$206 \$332 \$35 \$319 VSS|vss sg13_lv_nmos L=0.45U W=2U AS=0.38P AD=0.68P
+ PS=2.38U PD=4.68U rfmode=0
M$207 \$320 \$41 \$225 VSS|vss sg13_lv_nmos L=0.45U W=2U AS=0.68P AD=0.38P
+ PS=4.68U PD=2.38U rfmode=0
M$208 \$334 \$73 \$320 VSS|vss sg13_lv_nmos L=0.45U W=2U AS=0.38P AD=0.68P
+ PS=2.38U PD=4.68U rfmode=0
M$209 \$321 \$83 \$310 VSS|vss sg13_lv_nmos L=0.45U W=2U AS=0.68P AD=0.38P
+ PS=4.68U PD=2.38U rfmode=0
M$210 \$340 \$51 \$321 VSS|vss sg13_lv_nmos L=0.45U W=2U AS=0.38P AD=0.68P
+ PS=2.38U PD=4.68U rfmode=0
M$211 \$322 \$57 \$235 VSS|vss sg13_lv_nmos L=0.45U W=2U AS=0.68P AD=0.38P
+ PS=4.68U PD=2.38U rfmode=0
M$212 \$342 \$89 \$322 VSS|vss sg13_lv_nmos L=0.45U W=2U AS=0.38P AD=0.68P
+ PS=2.38U PD=4.68U rfmode=0
M$213 \$323 \$83 \$313 VSS|vss sg13_lv_nmos L=0.45U W=2U AS=0.68P AD=0.38P
+ PS=4.68U PD=2.38U rfmode=0
M$214 \$343 \$51 \$323 VSS|vss sg13_lv_nmos L=0.45U W=2U AS=0.38P AD=0.68P
+ PS=2.38U PD=4.68U rfmode=0
M$215 \$324 \$57 \$240 VSS|vss sg13_lv_nmos L=0.45U W=2U AS=0.68P AD=0.38P
+ PS=4.68U PD=2.38U rfmode=0
M$216 \$345 \$89 \$324 VSS|vss sg13_lv_nmos L=0.45U W=2U AS=0.38P AD=0.68P
+ PS=2.38U PD=4.68U rfmode=0
M$217 \$352 \$69 \$317 VSS|vss sg13_lv_nmos L=0.45U W=2U AS=0.68P AD=0.38P
+ PS=4.68U PD=2.38U rfmode=0
M$218 \$373 \$37 \$352 VSS|vss sg13_lv_nmos L=0.45U W=2U AS=0.38P AD=0.68P
+ PS=2.38U PD=4.68U rfmode=0
M$219 \$357 \$35 \$333 VSS|vss sg13_lv_nmos L=0.45U W=2U AS=0.68P AD=0.38P
+ PS=4.68U PD=2.38U rfmode=0
M$220 \$358 \$67 \$357 VSS|vss sg13_lv_nmos L=0.45U W=2U AS=0.38P AD=0.68P
+ PS=2.38U PD=4.68U rfmode=0
M$221 \$365 \$85 \$321 VSS|vss sg13_lv_nmos L=0.45U W=2U AS=0.68P AD=0.38P
+ PS=4.68U PD=2.38U rfmode=0
M$222 \$377 \$53 \$365 VSS|vss sg13_lv_nmos L=0.45U W=2U AS=0.38P AD=0.68P
+ PS=2.38U PD=4.68U rfmode=0
M$223 \$367 \$51 \$341 VSS|vss sg13_lv_nmos L=0.45U W=2U AS=0.68P AD=0.38P
+ PS=4.68U PD=2.38U rfmode=0
M$224 \$366 \$83 \$367 VSS|vss sg13_lv_nmos L=0.45U W=2U AS=0.38P AD=0.68P
+ PS=2.38U PD=4.68U rfmode=0
M$225 \$369 \$85 \$323 VSS|vss sg13_lv_nmos L=0.45U W=2U AS=0.68P AD=0.38P
+ PS=4.68U PD=2.38U rfmode=0
M$226 \$379 \$53 \$369 VSS|vss sg13_lv_nmos L=0.45U W=2U AS=0.38P AD=0.68P
+ PS=2.38U PD=4.68U rfmode=0
M$227 \$370 \$51 \$344 VSS|vss sg13_lv_nmos L=0.45U W=2U AS=0.68P AD=0.38P
+ PS=4.68U PD=2.38U rfmode=0
M$228 \$371 \$83 \$370 VSS|vss sg13_lv_nmos L=0.45U W=2U AS=0.38P AD=0.68P
+ PS=2.38U PD=4.68U rfmode=0
M$229 \$353 \$35 \$330 VSS|vss sg13_lv_nmos L=0.45U W=2U AS=0.68P AD=0.38P
+ PS=4.68U PD=2.38U rfmode=0
M$230 \$354 \$67 \$353 VSS|vss sg13_lv_nmos L=0.45U W=2U AS=0.38P AD=0.68P
+ PS=2.38U PD=4.68U rfmode=0
M$231 \$356 \$69 \$319 VSS|vss sg13_lv_nmos L=0.45U W=2U AS=0.68P AD=0.38P
+ PS=4.68U PD=2.38U rfmode=0
M$232 \$375 \$37 \$356 VSS|vss sg13_lv_nmos L=0.45U W=2U AS=0.38P AD=0.68P
+ PS=2.38U PD=4.68U rfmode=0
M$233 \$373 \$67 \$351 VSS|vss sg13_lv_nmos L=0.45U W=2U AS=0.68P AD=0.38P
+ PS=4.68U PD=2.38U rfmode=0
M$234 \$385 \$35 \$373 VSS|vss sg13_lv_nmos L=0.45U W=2U AS=0.38P AD=0.68P
+ PS=2.38U PD=4.68U rfmode=0
M$235 \$374 \$37 \$353 VSS|vss sg13_lv_nmos L=0.45U W=2U AS=0.68P AD=0.38P
+ PS=4.68U PD=2.38U rfmode=0
M$236 \$399 \$69 \$374 VSS|vss sg13_lv_nmos L=0.45U W=2U AS=0.38P AD=0.68P
+ PS=2.38U PD=4.68U rfmode=0
M$237 \$375 \$67 \$355 VSS|vss sg13_lv_nmos L=0.45U W=2U AS=0.68P AD=0.38P
+ PS=4.68U PD=2.38U rfmode=0
M$238 \$387 \$35 \$375 VSS|vss sg13_lv_nmos L=0.45U W=2U AS=0.38P AD=0.68P
+ PS=2.38U PD=4.68U rfmode=0
M$239 \$376 \$37 \$357 VSS|vss sg13_lv_nmos L=0.45U W=2U AS=0.68P AD=0.38P
+ PS=4.68U PD=2.38U rfmode=0
M$240 \$400 \$69 \$376 VSS|vss sg13_lv_nmos L=0.45U W=2U AS=0.38P AD=0.68P
+ PS=2.38U PD=4.68U rfmode=0
M$241 \$377 \$83 \$364 VSS|vss sg13_lv_nmos L=0.45U W=2U AS=0.68P AD=0.38P
+ PS=4.68U PD=2.38U rfmode=0
M$242 \$394 \$51 \$377 VSS|vss sg13_lv_nmos L=0.45U W=2U AS=0.38P AD=0.68P
+ PS=2.38U PD=4.68U rfmode=0
M$243 \$378 \$53 \$367 VSS|vss sg13_lv_nmos L=0.45U W=2U AS=0.68P AD=0.38P
+ PS=4.68U PD=2.38U rfmode=0
M$244 \$401 \$85 \$378 VSS|vss sg13_lv_nmos L=0.45U W=2U AS=0.38P AD=0.68P
+ PS=2.38U PD=4.68U rfmode=0
M$245 \$379 \$83 \$368 VSS|vss sg13_lv_nmos L=0.45U W=2U AS=0.68P AD=0.38P
+ PS=4.68U PD=2.38U rfmode=0
M$246 \$396 \$51 \$379 VSS|vss sg13_lv_nmos L=0.45U W=2U AS=0.38P AD=0.68P
+ PS=2.38U PD=4.68U rfmode=0
M$247 \$380 \$53 \$370 VSS|vss sg13_lv_nmos L=0.45U W=2U AS=0.68P AD=0.38P
+ PS=4.68U PD=2.38U rfmode=0
M$248 \$402 \$85 \$380 VSS|vss sg13_lv_nmos L=0.45U W=2U AS=0.38P AD=0.68P
+ PS=2.38U PD=4.68U rfmode=0
M$249 \$300 \$71 \$352 VSS|vss sg13_lv_nmos L=0.45U W=2U AS=0.68P AD=0.38P
+ PS=4.68U PD=2.38U rfmode=0
M$250 \$408 \$39 \$300 VSS|vss sg13_lv_nmos L=0.45U W=2U AS=0.38P AD=0.68P
+ PS=2.38U PD=4.68U rfmode=0
M$251 \$303 \$71 \$356 VSS|vss sg13_lv_nmos L=0.45U W=2U AS=0.68P AD=0.38P
+ PS=4.68U PD=2.38U rfmode=0
M$252 \$411 \$39 \$303 VSS|vss sg13_lv_nmos L=0.45U W=2U AS=0.38P AD=0.68P
+ PS=2.38U PD=4.68U rfmode=0
M$253 \$400 \$35 \$388 VSS|vss sg13_lv_nmos L=0.45U W=2U AS=0.68P AD=0.38P
+ PS=4.68U PD=2.38U rfmode=0
M$254 \$412 \$67 \$400 VSS|vss sg13_lv_nmos L=0.45U W=2U AS=0.38P AD=0.68P
+ PS=2.38U PD=4.68U rfmode=0
M$255 \$311 \$87 \$365 VSS|vss sg13_lv_nmos L=0.45U W=2U AS=0.68P AD=0.38P
+ PS=4.68U PD=2.38U rfmode=0
M$256 \$419 \$55 \$311 VSS|vss sg13_lv_nmos L=0.45U W=2U AS=0.38P AD=0.68P
+ PS=2.38U PD=4.68U rfmode=0
M$257 \$401 \$51 \$395 VSS|vss sg13_lv_nmos L=0.45U W=2U AS=0.68P AD=0.38P
+ PS=4.68U PD=2.38U rfmode=0
M$258 \$420 \$83 \$401 VSS|vss sg13_lv_nmos L=0.45U W=2U AS=0.38P AD=0.68P
+ PS=2.38U PD=4.68U rfmode=0
M$259 \$314 \$87 \$369 VSS|vss sg13_lv_nmos L=0.45U W=2U AS=0.68P AD=0.38P
+ PS=4.68U PD=2.38U rfmode=0
M$260 \$422 \$55 \$314 VSS|vss sg13_lv_nmos L=0.45U W=2U AS=0.38P AD=0.68P
+ PS=2.38U PD=4.68U rfmode=0
M$261 \$402 \$51 \$397 VSS|vss sg13_lv_nmos L=0.45U W=2U AS=0.68P AD=0.38P
+ PS=4.68U PD=2.38U rfmode=0
M$262 \$423 \$83 \$402 VSS|vss sg13_lv_nmos L=0.45U W=2U AS=0.38P AD=0.68P
+ PS=2.38U PD=4.68U rfmode=0
M$263 \$399 \$35 \$386 VSS|vss sg13_lv_nmos L=0.45U W=2U AS=0.68P AD=0.38P
+ PS=4.68U PD=2.38U rfmode=0
M$264 \$409 \$67 \$399 VSS|vss sg13_lv_nmos L=0.45U W=2U AS=0.38P AD=0.68P
+ PS=2.38U PD=4.68U rfmode=0
M$265 \$425 \$67 \$407 VSS|vss sg13_lv_nmos L=0.45U W=2U AS=0.68P AD=0.38P
+ PS=4.68U PD=2.38U rfmode=0
M$266 \$433 \$35 \$425 VSS|vss sg13_lv_nmos L=0.45U W=2U AS=0.38P AD=0.68P
+ PS=2.38U PD=4.68U rfmode=0
M$267 \$331 \$39 \$374 VSS|vss sg13_lv_nmos L=0.45U W=2U AS=0.68P AD=0.38P
+ PS=4.68U PD=2.38U rfmode=0
M$268 \$435 \$71 \$331 VSS|vss sg13_lv_nmos L=0.45U W=2U AS=0.38P AD=0.68P
+ PS=2.38U PD=4.68U rfmode=0
M$269 \$426 \$67 \$410 VSS|vss sg13_lv_nmos L=0.45U W=2U AS=0.68P AD=0.38P
+ PS=4.68U PD=2.38U rfmode=0
M$270 \$436 \$35 \$426 VSS|vss sg13_lv_nmos L=0.45U W=2U AS=0.38P AD=0.68P
+ PS=2.38U PD=4.68U rfmode=0
M$271 \$334 \$39 \$376 VSS|vss sg13_lv_nmos L=0.45U W=2U AS=0.68P AD=0.38P
+ PS=4.68U PD=2.38U rfmode=0
M$272 \$438 \$71 \$334 VSS|vss sg13_lv_nmos L=0.45U W=2U AS=0.38P AD=0.68P
+ PS=2.38U PD=4.68U rfmode=0
M$273 \$427 \$83 \$418 VSS|vss sg13_lv_nmos L=0.45U W=2U AS=0.68P AD=0.38P
+ PS=4.68U PD=2.38U rfmode=0
M$274 \$444 \$51 \$427 VSS|vss sg13_lv_nmos L=0.45U W=2U AS=0.38P AD=0.68P
+ PS=2.38U PD=4.68U rfmode=0
M$275 \$342 \$55 \$378 VSS|vss sg13_lv_nmos L=0.45U W=2U AS=0.68P AD=0.38P
+ PS=4.68U PD=2.38U rfmode=0
M$276 \$446 \$87 \$342 VSS|vss sg13_lv_nmos L=0.45U W=2U AS=0.38P AD=0.68P
+ PS=2.38U PD=4.68U rfmode=0
M$277 \$428 \$83 \$421 VSS|vss sg13_lv_nmos L=0.45U W=2U AS=0.68P AD=0.38P
+ PS=4.68U PD=2.38U rfmode=0
M$278 \$447 \$51 \$428 VSS|vss sg13_lv_nmos L=0.45U W=2U AS=0.38P AD=0.68P
+ PS=2.38U PD=4.68U rfmode=0
M$279 \$345 \$55 \$380 VSS|vss sg13_lv_nmos L=0.45U W=2U AS=0.68P AD=0.38P
+ PS=4.68U PD=2.38U rfmode=0
M$280 \$449 \$87 \$345 VSS|vss sg13_lv_nmos L=0.45U W=2U AS=0.38P AD=0.68P
+ PS=2.38U PD=4.68U rfmode=0
M$281 \$408 \$69 \$425 VSS|vss sg13_lv_nmos L=0.45U W=2U AS=0.68P AD=0.38P
+ PS=4.68U PD=2.38U rfmode=0
M$282 \$473 \$37 \$408 VSS|vss sg13_lv_nmos L=0.45U W=2U AS=0.38P AD=0.68P
+ PS=2.38U PD=4.68U rfmode=0
M$283 \$451 \$35 \$434 VSS|vss sg13_lv_nmos L=0.45U W=2U AS=0.68P AD=0.38P
+ PS=4.68U PD=2.38U rfmode=0
M$284 \$460 \$67 \$451 VSS|vss sg13_lv_nmos L=0.45U W=2U AS=0.38P AD=0.68P
+ PS=2.38U PD=4.68U rfmode=0
M$285 \$452 \$35 \$437 VSS|vss sg13_lv_nmos L=0.45U W=2U AS=0.68P AD=0.38P
+ PS=4.68U PD=2.38U rfmode=0
M$286 \$462 \$67 \$452 VSS|vss sg13_lv_nmos L=0.45U W=2U AS=0.38P AD=0.68P
+ PS=2.38U PD=4.68U rfmode=0
M$287 \$419 \$85 \$427 VSS|vss sg13_lv_nmos L=0.45U W=2U AS=0.68P AD=0.38P
+ PS=4.68U PD=2.38U rfmode=0
M$288 \$475 \$53 \$419 VSS|vss sg13_lv_nmos L=0.45U W=2U AS=0.38P AD=0.68P
+ PS=2.38U PD=4.68U rfmode=0
M$289 \$453 \$51 \$445 VSS|vss sg13_lv_nmos L=0.45U W=2U AS=0.68P AD=0.38P
+ PS=4.68U PD=2.38U rfmode=0
M$290 \$469 \$83 \$453 VSS|vss sg13_lv_nmos L=0.45U W=2U AS=0.38P AD=0.68P
+ PS=2.38U PD=4.68U rfmode=0
M$291 \$422 \$85 \$428 VSS|vss sg13_lv_nmos L=0.45U W=2U AS=0.68P AD=0.38P
+ PS=4.68U PD=2.38U rfmode=0
M$292 \$476 \$53 \$422 VSS|vss sg13_lv_nmos L=0.45U W=2U AS=0.38P AD=0.68P
+ PS=2.38U PD=4.68U rfmode=0
M$293 \$454 \$51 \$448 VSS|vss sg13_lv_nmos L=0.45U W=2U AS=0.68P AD=0.38P
+ PS=4.68U PD=2.38U rfmode=0
M$294 \$471 \$83 \$454 VSS|vss sg13_lv_nmos L=0.45U W=2U AS=0.38P AD=0.68P
+ PS=2.38U PD=4.68U rfmode=0
M$295 \$411 \$69 \$426 VSS|vss sg13_lv_nmos L=0.45U W=2U AS=0.68P AD=0.38P
+ PS=4.68U PD=2.38U rfmode=0
M$296 \$474 \$37 \$411 VSS|vss sg13_lv_nmos L=0.45U W=2U AS=0.38P AD=0.68P
+ PS=2.38U PD=4.68U rfmode=0
M$297 \$473 \$67 \$459 VSS|vss sg13_lv_nmos L=0.45U W=2U AS=0.68P AD=0.38P
+ PS=4.68U PD=2.38U rfmode=0
M$298 \$481 \$35 \$473 VSS|vss sg13_lv_nmos L=0.45U W=2U AS=0.38P AD=0.68P
+ PS=2.38U PD=4.68U rfmode=0
M$299 \$435 \$37 \$451 VSS|vss sg13_lv_nmos L=0.45U W=2U AS=0.68P AD=0.38P
+ PS=4.68U PD=2.38U rfmode=0
M$300 \$502 \$69 \$435 VSS|vss sg13_lv_nmos L=0.45U W=2U AS=0.38P AD=0.68P
+ PS=2.38U PD=4.68U rfmode=0
M$301 \$474 \$67 \$461 VSS|vss sg13_lv_nmos L=0.45U W=2U AS=0.68P AD=0.38P
+ PS=4.68U PD=2.38U rfmode=0
M$302 \$483 \$35 \$474 VSS|vss sg13_lv_nmos L=0.45U W=2U AS=0.38P AD=0.68P
+ PS=2.38U PD=4.68U rfmode=0
M$303 \$438 \$37 \$452 VSS|vss sg13_lv_nmos L=0.45U W=2U AS=0.68P AD=0.38P
+ PS=4.68U PD=2.38U rfmode=0
M$304 \$507 \$69 \$438 VSS|vss sg13_lv_nmos L=0.45U W=2U AS=0.38P AD=0.68P
+ PS=2.38U PD=4.68U rfmode=0
M$305 \$475 \$83 \$468 VSS|vss sg13_lv_nmos L=0.45U W=2U AS=0.68P AD=0.38P
+ PS=4.68U PD=2.38U rfmode=0
M$306 \$490 \$51 \$475 VSS|vss sg13_lv_nmos L=0.45U W=2U AS=0.38P AD=0.68P
+ PS=2.38U PD=4.68U rfmode=0
M$307 \$446 \$53 \$453 VSS|vss sg13_lv_nmos L=0.45U W=2U AS=0.68P AD=0.38P
+ PS=4.68U PD=2.38U rfmode=0
M$308 \$517 \$85 \$446 VSS|vss sg13_lv_nmos L=0.45U W=2U AS=0.38P AD=0.68P
+ PS=2.38U PD=4.68U rfmode=0
M$309 \$476 \$83 \$470 VSS|vss sg13_lv_nmos L=0.45U W=2U AS=0.68P AD=0.38P
+ PS=4.68U PD=2.38U rfmode=0
M$310 \$492 \$51 \$476 VSS|vss sg13_lv_nmos L=0.45U W=2U AS=0.38P AD=0.68P
+ PS=2.38U PD=4.68U rfmode=0
M$311 \$449 \$53 \$454 VSS|vss sg13_lv_nmos L=0.45U W=2U AS=0.68P AD=0.38P
+ PS=4.68U PD=2.38U rfmode=0
M$312 \$522 \$85 \$449 VSS|vss sg13_lv_nmos L=0.45U W=2U AS=0.38P AD=0.68P
+ PS=2.38U PD=4.68U rfmode=0
M$313 \$500 \$75 \$287 VSS|vss sg13_lv_nmos L=0.45U W=2U AS=0.68P AD=0.38P
+ PS=4.68U PD=2.38U rfmode=0
M$314 \$501 \$43 \$500 VSS|vss sg13_lv_nmos L=0.45U W=2U AS=0.38P AD=0.68P
+ PS=2.38U PD=4.68U rfmode=0
M$315 \$505 \$75 \$289 VSS|vss sg13_lv_nmos L=0.45U W=2U AS=0.68P AD=0.38P
+ PS=4.68U PD=2.38U rfmode=0
M$316 \$506 \$43 \$505 VSS|vss sg13_lv_nmos L=0.45U W=2U AS=0.38P AD=0.68P
+ PS=2.38U PD=4.68U rfmode=0
M$317 \$507 \$35 \$484 VSS|vss sg13_lv_nmos L=0.45U W=2U AS=0.68P AD=0.38P
+ PS=4.68U PD=2.38U rfmode=0
M$318 \$508 \$67 \$507 VSS|vss sg13_lv_nmos L=0.45U W=2U AS=0.38P AD=0.68P
+ PS=2.38U PD=4.68U rfmode=0
M$319 \$515 \$91 \$291 VSS|vss sg13_lv_nmos L=0.45U W=2U AS=0.68P AD=0.38P
+ PS=4.68U PD=2.38U rfmode=0
M$320 \$516 \$59 \$515 VSS|vss sg13_lv_nmos L=0.45U W=2U AS=0.38P AD=0.68P
+ PS=2.38U PD=4.68U rfmode=0
M$321 \$517 \$51 \$491 VSS|vss sg13_lv_nmos L=0.45U W=2U AS=0.68P AD=0.38P
+ PS=4.68U PD=2.38U rfmode=0
M$322 \$518 \$83 \$517 VSS|vss sg13_lv_nmos L=0.45U W=2U AS=0.38P AD=0.68P
+ PS=2.38U PD=4.68U rfmode=0
M$323 \$522 \$51 \$493 VSS|vss sg13_lv_nmos L=0.45U W=2U AS=0.68P AD=0.38P
+ PS=4.68U PD=2.38U rfmode=0
M$324 \$523 \$83 \$522 VSS|vss sg13_lv_nmos L=0.45U W=2U AS=0.38P AD=0.68P
+ PS=2.38U PD=4.68U rfmode=0
M$325 \$502 \$35 \$482 VSS|vss sg13_lv_nmos L=0.45U W=2U AS=0.68P AD=0.38P
+ PS=4.68U PD=2.38U rfmode=0
M$326 \$503 \$67 \$502 VSS|vss sg13_lv_nmos L=0.45U W=2U AS=0.38P AD=0.68P
+ PS=2.38U PD=4.68U rfmode=0
M$327 \$520 \$91 \$293 VSS|vss sg13_lv_nmos L=0.45U W=2U AS=0.68P AD=0.38P
+ PS=4.68U PD=2.38U rfmode=0
M$328 \$521 \$59 \$520 VSS|vss sg13_lv_nmos L=0.45U W=2U AS=0.38P AD=0.68P
+ PS=2.38U PD=4.68U rfmode=0
M$329 \$525 \$67 \$499 VSS|vss sg13_lv_nmos L=0.45U W=2U AS=0.68P AD=0.38P
+ PS=4.68U PD=2.38U rfmode=0
M$330 \$537 \$35 \$525 VSS|vss sg13_lv_nmos L=0.45U W=2U AS=0.38P AD=0.68P
+ PS=2.38U PD=4.68U rfmode=0
M$331 \$526 \$43 \$318 VSS|vss sg13_lv_nmos L=0.45U W=2U AS=0.68P AD=0.38P
+ PS=4.68U PD=2.38U rfmode=0
M$332 \$539 \$75 \$526 VSS|vss sg13_lv_nmos L=0.45U W=2U AS=0.38P AD=0.68P
+ PS=2.38U PD=4.68U rfmode=0
M$333 \$527 \$67 \$504 VSS|vss sg13_lv_nmos L=0.45U W=2U AS=0.68P AD=0.38P
+ PS=4.68U PD=2.38U rfmode=0
M$334 \$540 \$35 \$527 VSS|vss sg13_lv_nmos L=0.45U W=2U AS=0.38P AD=0.68P
+ PS=2.38U PD=4.68U rfmode=0
M$335 \$528 \$43 \$320 VSS|vss sg13_lv_nmos L=0.45U W=2U AS=0.68P AD=0.38P
+ PS=4.68U PD=2.38U rfmode=0
M$336 \$542 \$75 \$528 VSS|vss sg13_lv_nmos L=0.45U W=2U AS=0.38P AD=0.68P
+ PS=2.38U PD=4.68U rfmode=0
M$337 \$529 \$83 \$514 VSS|vss sg13_lv_nmos L=0.45U W=2U AS=0.68P AD=0.38P
+ PS=4.68U PD=2.38U rfmode=0
M$338 \$548 \$51 \$529 VSS|vss sg13_lv_nmos L=0.45U W=2U AS=0.38P AD=0.68P
+ PS=2.38U PD=4.68U rfmode=0
M$339 \$530 \$59 \$322 VSS|vss sg13_lv_nmos L=0.45U W=2U AS=0.68P AD=0.38P
+ PS=4.68U PD=2.38U rfmode=0
M$340 \$550 \$91 \$530 VSS|vss sg13_lv_nmos L=0.45U W=2U AS=0.38P AD=0.68P
+ PS=2.38U PD=4.68U rfmode=0
M$341 \$531 \$83 \$519 VSS|vss sg13_lv_nmos L=0.45U W=2U AS=0.68P AD=0.38P
+ PS=4.68U PD=2.38U rfmode=0
M$342 \$551 \$51 \$531 VSS|vss sg13_lv_nmos L=0.45U W=2U AS=0.38P AD=0.68P
+ PS=2.38U PD=4.68U rfmode=0
M$343 \$532 \$59 \$324 VSS|vss sg13_lv_nmos L=0.45U W=2U AS=0.68P AD=0.38P
+ PS=4.68U PD=2.38U rfmode=0
M$344 \$553 \$91 \$532 VSS|vss sg13_lv_nmos L=0.45U W=2U AS=0.38P AD=0.68P
+ PS=2.38U PD=4.68U rfmode=0
M$345 \$555 \$69 \$525 VSS|vss sg13_lv_nmos L=0.45U W=2U AS=0.68P AD=0.38P
+ PS=4.68U PD=2.38U rfmode=0
M$346 \$580 \$37 \$555 VSS|vss sg13_lv_nmos L=0.45U W=2U AS=0.38P AD=0.68P
+ PS=2.38U PD=4.68U rfmode=0
M$347 \$558 \$35 \$541 VSS|vss sg13_lv_nmos L=0.45U W=2U AS=0.68P AD=0.38P
+ PS=4.68U PD=2.38U rfmode=0
M$348 \$570 \$67 \$558 VSS|vss sg13_lv_nmos L=0.45U W=2U AS=0.38P AD=0.68P
+ PS=2.38U PD=4.68U rfmode=0
M$349 \$559 \$85 \$529 VSS|vss sg13_lv_nmos L=0.45U W=2U AS=0.68P AD=0.38P
+ PS=4.68U PD=2.38U rfmode=0
M$350 \$584 \$53 \$559 VSS|vss sg13_lv_nmos L=0.45U W=2U AS=0.38P AD=0.68P
+ PS=2.38U PD=4.68U rfmode=0
M$351 \$560 \$51 \$549 VSS|vss sg13_lv_nmos L=0.45U W=2U AS=0.68P AD=0.38P
+ PS=4.68U PD=2.38U rfmode=0
M$352 \$577 \$83 \$560 VSS|vss sg13_lv_nmos L=0.45U W=2U AS=0.38P AD=0.68P
+ PS=2.38U PD=4.68U rfmode=0
M$353 \$562 \$51 \$552 VSS|vss sg13_lv_nmos L=0.45U W=2U AS=0.68P AD=0.38P
+ PS=4.68U PD=2.38U rfmode=0
M$354 \$579 \$83 \$562 VSS|vss sg13_lv_nmos L=0.45U W=2U AS=0.38P AD=0.68P
+ PS=2.38U PD=4.68U rfmode=0
M$355 \$556 \$35 \$538 VSS|vss sg13_lv_nmos L=0.45U W=2U AS=0.68P AD=0.38P
+ PS=4.68U PD=2.38U rfmode=0
M$356 \$568 \$67 \$556 VSS|vss sg13_lv_nmos L=0.45U W=2U AS=0.38P AD=0.68P
+ PS=2.38U PD=4.68U rfmode=0
M$357 \$557 \$69 \$527 VSS|vss sg13_lv_nmos L=0.45U W=2U AS=0.68P AD=0.38P
+ PS=4.68U PD=2.38U rfmode=0
M$358 \$582 \$37 \$557 VSS|vss sg13_lv_nmos L=0.45U W=2U AS=0.38P AD=0.68P
+ PS=2.38U PD=4.68U rfmode=0
M$359 \$561 \$85 \$531 VSS|vss sg13_lv_nmos L=0.45U W=2U AS=0.68P AD=0.38P
+ PS=4.68U PD=2.38U rfmode=0
M$360 \$586 \$53 \$561 VSS|vss sg13_lv_nmos L=0.45U W=2U AS=0.38P AD=0.68P
+ PS=2.38U PD=4.68U rfmode=0
M$361 \$580 \$67 \$567 VSS|vss sg13_lv_nmos L=0.45U W=2U AS=0.68P AD=0.38P
+ PS=4.68U PD=2.38U rfmode=0
M$362 \$592 \$35 \$580 VSS|vss sg13_lv_nmos L=0.45U W=2U AS=0.38P AD=0.68P
+ PS=2.38U PD=4.68U rfmode=0
M$363 \$581 \$37 \$556 VSS|vss sg13_lv_nmos L=0.45U W=2U AS=0.68P AD=0.38P
+ PS=4.68U PD=2.38U rfmode=0
M$364 \$607 \$69 \$581 VSS|vss sg13_lv_nmos L=0.45U W=2U AS=0.38P AD=0.68P
+ PS=2.38U PD=4.68U rfmode=0
M$365 \$582 \$67 \$569 VSS|vss sg13_lv_nmos L=0.45U W=2U AS=0.68P AD=0.38P
+ PS=4.68U PD=2.38U rfmode=0
M$366 \$594 \$35 \$582 VSS|vss sg13_lv_nmos L=0.45U W=2U AS=0.38P AD=0.68P
+ PS=2.38U PD=4.68U rfmode=0
M$367 \$583 \$37 \$558 VSS|vss sg13_lv_nmos L=0.45U W=2U AS=0.68P AD=0.38P
+ PS=4.68U PD=2.38U rfmode=0
M$368 \$609 \$69 \$583 VSS|vss sg13_lv_nmos L=0.45U W=2U AS=0.38P AD=0.68P
+ PS=2.38U PD=4.68U rfmode=0
M$369 \$584 \$83 \$576 VSS|vss sg13_lv_nmos L=0.45U W=2U AS=0.68P AD=0.38P
+ PS=4.68U PD=2.38U rfmode=0
M$370 \$601 \$51 \$584 VSS|vss sg13_lv_nmos L=0.45U W=2U AS=0.38P AD=0.68P
+ PS=2.38U PD=4.68U rfmode=0
M$371 \$585 \$53 \$560 VSS|vss sg13_lv_nmos L=0.45U W=2U AS=0.68P AD=0.38P
+ PS=4.68U PD=2.38U rfmode=0
M$372 \$611 \$85 \$585 VSS|vss sg13_lv_nmos L=0.45U W=2U AS=0.38P AD=0.68P
+ PS=2.38U PD=4.68U rfmode=0
M$373 \$586 \$83 \$578 VSS|vss sg13_lv_nmos L=0.45U W=2U AS=0.68P AD=0.38P
+ PS=4.68U PD=2.38U rfmode=0
M$374 \$603 \$51 \$586 VSS|vss sg13_lv_nmos L=0.45U W=2U AS=0.38P AD=0.68P
+ PS=2.38U PD=4.68U rfmode=0
M$375 \$587 \$53 \$562 VSS|vss sg13_lv_nmos L=0.45U W=2U AS=0.68P AD=0.38P
+ PS=4.68U PD=2.38U rfmode=0
M$376 \$613 \$85 \$587 VSS|vss sg13_lv_nmos L=0.45U W=2U AS=0.38P AD=0.68P
+ PS=2.38U PD=4.68U rfmode=0
M$377 \$606 \$71 \$555 VSS|vss sg13_lv_nmos L=0.45U W=2U AS=0.68P AD=0.38P
+ PS=4.68U PD=2.38U rfmode=0
M$378 \$619 \$39 \$606 VSS|vss sg13_lv_nmos L=0.45U W=2U AS=0.38P AD=0.68P
+ PS=2.38U PD=4.68U rfmode=0
M$379 \$607 \$35 \$593 VSS|vss sg13_lv_nmos L=0.45U W=2U AS=0.68P AD=0.38P
+ PS=4.68U PD=2.38U rfmode=0
M$380 \$620 \$67 \$607 VSS|vss sg13_lv_nmos L=0.45U W=2U AS=0.38P AD=0.68P
+ PS=2.38U PD=4.68U rfmode=0
M$381 \$608 \$71 \$557 VSS|vss sg13_lv_nmos L=0.45U W=2U AS=0.68P AD=0.38P
+ PS=4.68U PD=2.38U rfmode=0
M$382 \$622 \$39 \$608 VSS|vss sg13_lv_nmos L=0.45U W=2U AS=0.38P AD=0.68P
+ PS=2.38U PD=4.68U rfmode=0
M$383 \$609 \$35 \$595 VSS|vss sg13_lv_nmos L=0.45U W=2U AS=0.68P AD=0.38P
+ PS=4.68U PD=2.38U rfmode=0
M$384 \$623 \$67 \$609 VSS|vss sg13_lv_nmos L=0.45U W=2U AS=0.38P AD=0.68P
+ PS=2.38U PD=4.68U rfmode=0
M$385 \$610 \$87 \$559 VSS|vss sg13_lv_nmos L=0.45U W=2U AS=0.68P AD=0.38P
+ PS=4.68U PD=2.38U rfmode=0
M$386 \$629 \$55 \$610 VSS|vss sg13_lv_nmos L=0.45U W=2U AS=0.38P AD=0.68P
+ PS=2.38U PD=4.68U rfmode=0
M$387 \$611 \$51 \$602 VSS|vss sg13_lv_nmos L=0.45U W=2U AS=0.68P AD=0.38P
+ PS=4.68U PD=2.38U rfmode=0
M$388 \$630 \$83 \$611 VSS|vss sg13_lv_nmos L=0.45U W=2U AS=0.38P AD=0.68P
+ PS=2.38U PD=4.68U rfmode=0
M$389 \$612 \$87 \$561 VSS|vss sg13_lv_nmos L=0.45U W=2U AS=0.68P AD=0.38P
+ PS=4.68U PD=2.38U rfmode=0
M$390 \$632 \$55 \$612 VSS|vss sg13_lv_nmos L=0.45U W=2U AS=0.38P AD=0.68P
+ PS=2.38U PD=4.68U rfmode=0
M$391 \$613 \$51 \$604 VSS|vss sg13_lv_nmos L=0.45U W=2U AS=0.68P AD=0.38P
+ PS=4.68U PD=2.38U rfmode=0
M$392 \$633 \$83 \$613 VSS|vss sg13_lv_nmos L=0.45U W=2U AS=0.38P AD=0.68P
+ PS=2.38U PD=4.68U rfmode=0
M$393 \$638 \$67 \$618 VSS|vss sg13_lv_nmos L=0.45U W=2U AS=0.68P AD=0.38P
+ PS=4.68U PD=2.38U rfmode=0
M$394 \$639 \$35 \$638 VSS|vss sg13_lv_nmos L=0.45U W=2U AS=0.38P AD=0.68P
+ PS=2.38U PD=4.68U rfmode=0
M$395 \$642 \$39 \$581 VSS|vss sg13_lv_nmos L=0.45U W=2U AS=0.68P AD=0.38P
+ PS=4.68U PD=2.38U rfmode=0
M$396 \$641 \$71 \$642 VSS|vss sg13_lv_nmos L=0.45U W=2U AS=0.38P AD=0.68P
+ PS=2.38U PD=4.68U rfmode=0
M$397 \$643 \$67 \$621 VSS|vss sg13_lv_nmos L=0.45U W=2U AS=0.68P AD=0.38P
+ PS=4.68U PD=2.38U rfmode=0
M$398 \$644 \$35 \$643 VSS|vss sg13_lv_nmos L=0.45U W=2U AS=0.38P AD=0.68P
+ PS=2.38U PD=4.68U rfmode=0
M$399 \$646 \$39 \$583 VSS|vss sg13_lv_nmos L=0.45U W=2U AS=0.68P AD=0.38P
+ PS=4.68U PD=2.38U rfmode=0
M$400 \$647 \$71 \$646 VSS|vss sg13_lv_nmos L=0.45U W=2U AS=0.38P AD=0.68P
+ PS=2.38U PD=4.68U rfmode=0
M$401 \$652 \$83 \$628 VSS|vss sg13_lv_nmos L=0.45U W=2U AS=0.68P AD=0.38P
+ PS=4.68U PD=2.38U rfmode=0
M$402 \$653 \$51 \$652 VSS|vss sg13_lv_nmos L=0.45U W=2U AS=0.38P AD=0.68P
+ PS=2.38U PD=4.68U rfmode=0
M$403 \$655 \$55 \$585 VSS|vss sg13_lv_nmos L=0.45U W=2U AS=0.68P AD=0.38P
+ PS=4.68U PD=2.38U rfmode=0
M$404 \$656 \$87 \$655 VSS|vss sg13_lv_nmos L=0.45U W=2U AS=0.38P AD=0.68P
+ PS=2.38U PD=4.68U rfmode=0
M$405 \$657 \$83 \$631 VSS|vss sg13_lv_nmos L=0.45U W=2U AS=0.68P AD=0.38P
+ PS=4.68U PD=2.38U rfmode=0
M$406 \$658 \$51 \$657 VSS|vss sg13_lv_nmos L=0.45U W=2U AS=0.38P AD=0.68P
+ PS=2.38U PD=4.68U rfmode=0
M$407 \$660 \$55 \$587 VSS|vss sg13_lv_nmos L=0.45U W=2U AS=0.68P AD=0.38P
+ PS=4.68U PD=2.38U rfmode=0
M$408 \$661 \$87 \$660 VSS|vss sg13_lv_nmos L=0.45U W=2U AS=0.38P AD=0.68P
+ PS=2.38U PD=4.68U rfmode=0
M$409 \$619 \$69 \$638 VSS|vss sg13_lv_nmos L=0.45U W=2U AS=0.68P AD=0.38P
+ PS=4.68U PD=2.38U rfmode=0
M$410 \$686 \$37 \$619 VSS|vss sg13_lv_nmos L=0.45U W=2U AS=0.38P AD=0.68P
+ PS=2.38U PD=4.68U rfmode=0
M$411 \$662 \$35 \$640 VSS|vss sg13_lv_nmos L=0.45U W=2U AS=0.68P AD=0.38P
+ PS=4.68U PD=2.38U rfmode=0
M$412 \$671 \$67 \$662 VSS|vss sg13_lv_nmos L=0.45U W=2U AS=0.38P AD=0.68P
+ PS=2.38U PD=4.68U rfmode=0
M$413 \$663 \$35 \$645 VSS|vss sg13_lv_nmos L=0.45U W=2U AS=0.68P AD=0.38P
+ PS=4.68U PD=2.38U rfmode=0
M$414 \$673 \$67 \$663 VSS|vss sg13_lv_nmos L=0.45U W=2U AS=0.38P AD=0.68P
+ PS=2.38U PD=4.68U rfmode=0
M$415 \$629 \$85 \$652 VSS|vss sg13_lv_nmos L=0.45U W=2U AS=0.68P AD=0.38P
+ PS=4.68U PD=2.38U rfmode=0
M$416 \$697 \$53 \$629 VSS|vss sg13_lv_nmos L=0.45U W=2U AS=0.38P AD=0.68P
+ PS=2.38U PD=4.68U rfmode=0
M$417 \$664 \$51 \$654 VSS|vss sg13_lv_nmos L=0.45U W=2U AS=0.68P AD=0.38P
+ PS=4.68U PD=2.38U rfmode=0
M$418 \$679 \$83 \$664 VSS|vss sg13_lv_nmos L=0.45U W=2U AS=0.38P AD=0.68P
+ PS=2.38U PD=4.68U rfmode=0
M$419 \$632 \$85 \$657 VSS|vss sg13_lv_nmos L=0.45U W=2U AS=0.68P AD=0.38P
+ PS=4.68U PD=2.38U rfmode=0
M$420 \$700 \$53 \$632 VSS|vss sg13_lv_nmos L=0.45U W=2U AS=0.38P AD=0.68P
+ PS=2.38U PD=4.68U rfmode=0
M$421 \$665 \$51 \$659 VSS|vss sg13_lv_nmos L=0.45U W=2U AS=0.68P AD=0.38P
+ PS=4.68U PD=2.38U rfmode=0
M$422 \$681 \$83 \$665 VSS|vss sg13_lv_nmos L=0.45U W=2U AS=0.38P AD=0.68P
+ PS=2.38U PD=4.68U rfmode=0
M$423 \$622 \$69 \$643 VSS|vss sg13_lv_nmos L=0.45U W=2U AS=0.68P AD=0.38P
+ PS=4.68U PD=2.38U rfmode=0
M$424 \$689 \$37 \$622 VSS|vss sg13_lv_nmos L=0.45U W=2U AS=0.38P AD=0.68P
+ PS=2.38U PD=4.68U rfmode=0
M$425 \$686 \$67 \$670 VSS|vss sg13_lv_nmos L=0.45U W=2U AS=0.68P AD=0.38P
+ PS=4.68U PD=2.38U rfmode=0
M$426 \$687 \$35 \$686 VSS|vss sg13_lv_nmos L=0.45U W=2U AS=0.38P AD=0.68P
+ PS=2.38U PD=4.68U rfmode=0
M$427 \$641 \$37 \$662 VSS|vss sg13_lv_nmos L=0.45U W=2U AS=0.68P AD=0.38P
+ PS=4.68U PD=2.38U rfmode=0
M$428 \$702 \$69 \$641 VSS|vss sg13_lv_nmos L=0.45U W=2U AS=0.38P AD=0.68P
+ PS=2.38U PD=4.68U rfmode=0
M$429 \$689 \$67 \$672 VSS|vss sg13_lv_nmos L=0.45U W=2U AS=0.68P AD=0.38P
+ PS=4.68U PD=2.38U rfmode=0
M$430 \$690 \$35 \$689 VSS|vss sg13_lv_nmos L=0.45U W=2U AS=0.38P AD=0.68P
+ PS=2.38U PD=4.68U rfmode=0
M$431 \$647 \$37 \$663 VSS|vss sg13_lv_nmos L=0.45U W=2U AS=0.68P AD=0.38P
+ PS=4.68U PD=2.38U rfmode=0
M$432 \$703 \$69 \$647 VSS|vss sg13_lv_nmos L=0.45U W=2U AS=0.38P AD=0.68P
+ PS=2.38U PD=4.68U rfmode=0
M$433 \$697 \$83 \$678 VSS|vss sg13_lv_nmos L=0.45U W=2U AS=0.68P AD=0.38P
+ PS=4.68U PD=2.38U rfmode=0
M$434 \$696 \$51 \$697 VSS|vss sg13_lv_nmos L=0.45U W=2U AS=0.38P AD=0.68P
+ PS=2.38U PD=4.68U rfmode=0
M$435 \$656 \$53 \$664 VSS|vss sg13_lv_nmos L=0.45U W=2U AS=0.68P AD=0.38P
+ PS=4.68U PD=2.38U rfmode=0
M$436 \$704 \$85 \$656 VSS|vss sg13_lv_nmos L=0.45U W=2U AS=0.38P AD=0.68P
+ PS=2.38U PD=4.68U rfmode=0
M$437 \$700 \$83 \$680 VSS|vss sg13_lv_nmos L=0.45U W=2U AS=0.68P AD=0.38P
+ PS=4.68U PD=2.38U rfmode=0
M$438 \$699 \$51 \$700 VSS|vss sg13_lv_nmos L=0.45U W=2U AS=0.38P AD=0.68P
+ PS=2.38U PD=4.68U rfmode=0
M$439 \$661 \$53 \$665 VSS|vss sg13_lv_nmos L=0.45U W=2U AS=0.68P AD=0.38P
+ PS=4.68U PD=2.38U rfmode=0
M$440 \$705 \$85 \$661 VSS|vss sg13_lv_nmos L=0.45U W=2U AS=0.38P AD=0.68P
+ PS=2.38U PD=4.68U rfmode=0
M$441 \$501 \$73 \$606 VSS|vss sg13_lv_nmos L=0.45U W=2U AS=0.68P AD=0.38P
+ PS=4.68U PD=2.38U rfmode=0
M$442 \$711 \$41 \$501 VSS|vss sg13_lv_nmos L=0.45U W=2U AS=0.38P AD=0.68P
+ PS=2.38U PD=4.68U rfmode=0
M$443 \$702 \$35 \$688 VSS|vss sg13_lv_nmos L=0.45U W=2U AS=0.68P AD=0.38P
+ PS=4.68U PD=2.38U rfmode=0
M$444 \$712 \$67 \$702 VSS|vss sg13_lv_nmos L=0.45U W=2U AS=0.38P AD=0.68P
+ PS=2.38U PD=4.68U rfmode=0
M$445 \$506 \$73 \$608 VSS|vss sg13_lv_nmos L=0.45U W=2U AS=0.68P AD=0.38P
+ PS=4.68U PD=2.38U rfmode=0
M$446 \$714 \$41 \$506 VSS|vss sg13_lv_nmos L=0.45U W=2U AS=0.38P AD=0.68P
+ PS=2.38U PD=4.68U rfmode=0
M$447 \$703 \$35 \$691 VSS|vss sg13_lv_nmos L=0.45U W=2U AS=0.68P AD=0.38P
+ PS=4.68U PD=2.38U rfmode=0
M$448 \$715 \$67 \$703 VSS|vss sg13_lv_nmos L=0.45U W=2U AS=0.38P AD=0.68P
+ PS=2.38U PD=4.68U rfmode=0
M$449 \$516 \$89 \$610 VSS|vss sg13_lv_nmos L=0.45U W=2U AS=0.68P AD=0.38P
+ PS=4.68U PD=2.38U rfmode=0
M$450 \$721 \$57 \$516 VSS|vss sg13_lv_nmos L=0.45U W=2U AS=0.38P AD=0.68P
+ PS=2.38U PD=4.68U rfmode=0
M$451 \$704 \$51 \$698 VSS|vss sg13_lv_nmos L=0.45U W=2U AS=0.68P AD=0.38P
+ PS=4.68U PD=2.38U rfmode=0
M$452 \$722 \$83 \$704 VSS|vss sg13_lv_nmos L=0.45U W=2U AS=0.38P AD=0.68P
+ PS=2.38U PD=4.68U rfmode=0
M$453 \$521 \$89 \$612 VSS|vss sg13_lv_nmos L=0.45U W=2U AS=0.68P AD=0.38P
+ PS=4.68U PD=2.38U rfmode=0
M$454 \$724 \$57 \$521 VSS|vss sg13_lv_nmos L=0.45U W=2U AS=0.38P AD=0.68P
+ PS=2.38U PD=4.68U rfmode=0
M$455 \$705 \$51 \$701 VSS|vss sg13_lv_nmos L=0.45U W=2U AS=0.68P AD=0.38P
+ PS=4.68U PD=2.38U rfmode=0
M$456 \$725 \$83 \$705 VSS|vss sg13_lv_nmos L=0.45U W=2U AS=0.38P AD=0.68P
+ PS=2.38U PD=4.68U rfmode=0
M$457 \$731 \$67 \$710 VSS|vss sg13_lv_nmos L=0.45U W=2U AS=0.68P AD=0.38P
+ PS=4.68U PD=2.38U rfmode=0
M$458 \$730 \$35 \$731 VSS|vss sg13_lv_nmos L=0.45U W=2U AS=0.38P AD=0.68P
+ PS=2.38U PD=4.68U rfmode=0
M$459 \$539 \$41 \$642 VSS|vss sg13_lv_nmos L=0.45U W=2U AS=0.68P AD=0.38P
+ PS=4.68U PD=2.38U rfmode=0
M$460 \$733 \$73 \$539 VSS|vss sg13_lv_nmos L=0.45U W=2U AS=0.38P AD=0.68P
+ PS=2.38U PD=4.68U rfmode=0
M$461 \$734 \$67 \$713 VSS|vss sg13_lv_nmos L=0.45U W=2U AS=0.68P AD=0.38P
+ PS=4.68U PD=2.38U rfmode=0
M$462 \$735 \$35 \$734 VSS|vss sg13_lv_nmos L=0.45U W=2U AS=0.38P AD=0.68P
+ PS=2.38U PD=4.68U rfmode=0
M$463 \$542 \$41 \$646 VSS|vss sg13_lv_nmos L=0.45U W=2U AS=0.68P AD=0.38P
+ PS=4.68U PD=2.38U rfmode=0
M$464 \$736 \$73 \$542 VSS|vss sg13_lv_nmos L=0.45U W=2U AS=0.38P AD=0.68P
+ PS=2.38U PD=4.68U rfmode=0
M$465 \$742 \$83 \$720 VSS|vss sg13_lv_nmos L=0.45U W=2U AS=0.68P AD=0.38P
+ PS=4.68U PD=2.38U rfmode=0
M$466 \$741 \$51 \$742 VSS|vss sg13_lv_nmos L=0.45U W=2U AS=0.38P AD=0.68P
+ PS=2.38U PD=4.68U rfmode=0
M$467 \$550 \$57 \$655 VSS|vss sg13_lv_nmos L=0.45U W=2U AS=0.68P AD=0.38P
+ PS=4.68U PD=2.38U rfmode=0
M$468 \$744 \$89 \$550 VSS|vss sg13_lv_nmos L=0.45U W=2U AS=0.38P AD=0.68P
+ PS=2.38U PD=4.68U rfmode=0
M$469 \$745 \$83 \$723 VSS|vss sg13_lv_nmos L=0.45U W=2U AS=0.68P AD=0.38P
+ PS=4.68U PD=2.38U rfmode=0
M$470 \$746 \$51 \$745 VSS|vss sg13_lv_nmos L=0.45U W=2U AS=0.38P AD=0.68P
+ PS=2.38U PD=4.68U rfmode=0
M$471 \$553 \$57 \$660 VSS|vss sg13_lv_nmos L=0.45U W=2U AS=0.68P AD=0.38P
+ PS=4.68U PD=2.38U rfmode=0
M$472 \$748 \$89 \$553 VSS|vss sg13_lv_nmos L=0.45U W=2U AS=0.38P AD=0.68P
+ PS=2.38U PD=4.68U rfmode=0
M$473 \$749 \$69 \$731 VSS|vss sg13_lv_nmos L=0.45U W=2U AS=0.68P AD=0.38P
+ PS=4.68U PD=2.38U rfmode=0
M$474 \$779 \$37 \$749 VSS|vss sg13_lv_nmos L=0.45U W=2U AS=0.38P AD=0.68P
+ PS=2.38U PD=4.68U rfmode=0
M$475 \$753 \$35 \$752 VSS|vss sg13_lv_nmos L=0.45U W=2U AS=0.68P AD=0.38P
+ PS=4.68U PD=2.38U rfmode=0
M$476 \$765 \$67 \$753 VSS|vss sg13_lv_nmos L=0.45U W=2U AS=0.38P AD=0.68P
+ PS=2.38U PD=4.68U rfmode=0
M$477 \$754 \$85 \$742 VSS|vss sg13_lv_nmos L=0.45U W=2U AS=0.68P AD=0.38P
+ PS=4.68U PD=2.38U rfmode=0
M$478 \$790 \$53 \$754 VSS|vss sg13_lv_nmos L=0.45U W=2U AS=0.38P AD=0.68P
+ PS=2.38U PD=4.68U rfmode=0
M$479 \$755 \$51 \$743 VSS|vss sg13_lv_nmos L=0.45U W=2U AS=0.68P AD=0.38P
+ PS=4.68U PD=2.38U rfmode=0
M$480 \$771 \$83 \$755 VSS|vss sg13_lv_nmos L=0.45U W=2U AS=0.38P AD=0.68P
+ PS=2.38U PD=4.68U rfmode=0
M$481 \$756 \$85 \$745 VSS|vss sg13_lv_nmos L=0.45U W=2U AS=0.68P AD=0.38P
+ PS=4.68U PD=2.38U rfmode=0
M$482 \$794 \$53 \$756 VSS|vss sg13_lv_nmos L=0.45U W=2U AS=0.38P AD=0.68P
+ PS=2.38U PD=4.68U rfmode=0
M$483 \$750 \$35 \$732 VSS|vss sg13_lv_nmos L=0.45U W=2U AS=0.68P AD=0.38P
+ PS=4.68U PD=2.38U rfmode=0
M$484 \$763 \$67 \$750 VSS|vss sg13_lv_nmos L=0.45U W=2U AS=0.38P AD=0.68P
+ PS=2.38U PD=4.68U rfmode=0
M$485 \$751 \$69 \$734 VSS|vss sg13_lv_nmos L=0.45U W=2U AS=0.68P AD=0.38P
+ PS=4.68U PD=2.38U rfmode=0
M$486 \$783 \$37 \$751 VSS|vss sg13_lv_nmos L=0.45U W=2U AS=0.38P AD=0.68P
+ PS=2.38U PD=4.68U rfmode=0
M$487 \$757 \$51 \$747 VSS|vss sg13_lv_nmos L=0.45U W=2U AS=0.68P AD=0.38P
+ PS=4.68U PD=2.38U rfmode=0
M$488 \$773 \$83 \$757 VSS|vss sg13_lv_nmos L=0.45U W=2U AS=0.38P AD=0.68P
+ PS=2.38U PD=4.68U rfmode=0
M$489 \$779 \$67 \$762 VSS|vss sg13_lv_nmos L=0.45U W=2U AS=0.68P AD=0.38P
+ PS=4.68U PD=2.38U rfmode=0
M$490 \$778 \$35 \$779 VSS|vss sg13_lv_nmos L=0.45U W=2U AS=0.38P AD=0.68P
+ PS=2.38U PD=4.68U rfmode=0
M$491 \$781 \$37 \$750 VSS|vss sg13_lv_nmos L=0.45U W=2U AS=0.68P AD=0.38P
+ PS=4.68U PD=2.38U rfmode=0
M$492 \$798 \$69 \$781 VSS|vss sg13_lv_nmos L=0.45U W=2U AS=0.38P AD=0.68P
+ PS=2.38U PD=4.68U rfmode=0
M$493 \$783 \$67 \$764 VSS|vss sg13_lv_nmos L=0.45U W=2U AS=0.68P AD=0.38P
+ PS=4.68U PD=2.38U rfmode=0
M$494 \$782 \$35 \$783 VSS|vss sg13_lv_nmos L=0.45U W=2U AS=0.38P AD=0.68P
+ PS=2.38U PD=4.68U rfmode=0
M$495 \$785 \$37 \$753 VSS|vss sg13_lv_nmos L=0.45U W=2U AS=0.68P AD=0.38P
+ PS=4.68U PD=2.38U rfmode=0
M$496 \$799 \$69 \$785 VSS|vss sg13_lv_nmos L=0.45U W=2U AS=0.38P AD=0.68P
+ PS=2.38U PD=4.68U rfmode=0
M$497 \$790 \$83 \$770 VSS|vss sg13_lv_nmos L=0.45U W=2U AS=0.68P AD=0.38P
+ PS=4.68U PD=2.38U rfmode=0
M$498 \$791 \$51 \$790 VSS|vss sg13_lv_nmos L=0.45U W=2U AS=0.38P AD=0.68P
+ PS=2.38U PD=4.68U rfmode=0
M$499 \$793 \$53 \$755 VSS|vss sg13_lv_nmos L=0.45U W=2U AS=0.68P AD=0.38P
+ PS=4.68U PD=2.38U rfmode=0
M$500 \$800 \$85 \$793 VSS|vss sg13_lv_nmos L=0.45U W=2U AS=0.38P AD=0.68P
+ PS=2.38U PD=4.68U rfmode=0
M$501 \$794 \$83 \$772 VSS|vss sg13_lv_nmos L=0.45U W=2U AS=0.68P AD=0.38P
+ PS=4.68U PD=2.38U rfmode=0
M$502 \$795 \$51 \$794 VSS|vss sg13_lv_nmos L=0.45U W=2U AS=0.38P AD=0.68P
+ PS=2.38U PD=4.68U rfmode=0
M$503 \$797 \$53 \$757 VSS|vss sg13_lv_nmos L=0.45U W=2U AS=0.68P AD=0.38P
+ PS=4.68U PD=2.38U rfmode=0
M$504 \$801 \$85 \$797 VSS|vss sg13_lv_nmos L=0.45U W=2U AS=0.38P AD=0.68P
+ PS=2.38U PD=4.68U rfmode=0
M$505 \$711 \$71 \$749 VSS|vss sg13_lv_nmos L=0.45U W=2U AS=0.68P AD=0.38P
+ PS=4.68U PD=2.38U rfmode=0
M$506 \$807 \$39 \$711 VSS|vss sg13_lv_nmos L=0.45U W=2U AS=0.38P AD=0.68P
+ PS=2.38U PD=4.68U rfmode=0
M$507 \$798 \$35 \$780 VSS|vss sg13_lv_nmos L=0.45U W=2U AS=0.68P AD=0.38P
+ PS=4.68U PD=2.38U rfmode=0
M$508 \$808 \$67 \$798 VSS|vss sg13_lv_nmos L=0.45U W=2U AS=0.38P AD=0.68P
+ PS=2.38U PD=4.68U rfmode=0
M$509 \$799 \$35 \$784 VSS|vss sg13_lv_nmos L=0.45U W=2U AS=0.68P AD=0.38P
+ PS=4.68U PD=2.38U rfmode=0
M$510 \$811 \$67 \$799 VSS|vss sg13_lv_nmos L=0.45U W=2U AS=0.38P AD=0.68P
+ PS=2.38U PD=4.68U rfmode=0
M$511 \$721 \$87 \$754 VSS|vss sg13_lv_nmos L=0.45U W=2U AS=0.68P AD=0.38P
+ PS=4.68U PD=2.38U rfmode=0
M$512 \$817 \$55 \$721 VSS|vss sg13_lv_nmos L=0.45U W=2U AS=0.38P AD=0.68P
+ PS=2.38U PD=4.68U rfmode=0
M$513 \$800 \$51 \$792 VSS|vss sg13_lv_nmos L=0.45U W=2U AS=0.68P AD=0.38P
+ PS=4.68U PD=2.38U rfmode=0
M$514 \$818 \$83 \$800 VSS|vss sg13_lv_nmos L=0.45U W=2U AS=0.38P AD=0.68P
+ PS=2.38U PD=4.68U rfmode=0
M$515 \$724 \$87 \$756 VSS|vss sg13_lv_nmos L=0.45U W=2U AS=0.68P AD=0.38P
+ PS=4.68U PD=2.38U rfmode=0
M$516 \$820 \$55 \$724 VSS|vss sg13_lv_nmos L=0.45U W=2U AS=0.38P AD=0.68P
+ PS=2.38U PD=4.68U rfmode=0
M$517 \$801 \$51 \$796 VSS|vss sg13_lv_nmos L=0.45U W=2U AS=0.68P AD=0.38P
+ PS=4.68U PD=2.38U rfmode=0
M$518 \$821 \$83 \$801 VSS|vss sg13_lv_nmos L=0.45U W=2U AS=0.38P AD=0.68P
+ PS=2.38U PD=4.68U rfmode=0
M$519 \$714 \$71 \$751 VSS|vss sg13_lv_nmos L=0.45U W=2U AS=0.68P AD=0.38P
+ PS=4.68U PD=2.38U rfmode=0
M$520 \$810 \$39 \$714 VSS|vss sg13_lv_nmos L=0.45U W=2U AS=0.38P AD=0.68P
+ PS=2.38U PD=4.68U rfmode=0
M$521 \$826 \$67 \$806 VSS|vss sg13_lv_nmos L=0.45U W=2U AS=0.68P AD=0.38P
+ PS=4.68U PD=2.38U rfmode=0
M$522 \$825 \$35 \$826 VSS|vss sg13_lv_nmos L=0.45U W=2U AS=0.38P AD=0.68P
+ PS=2.38U PD=4.68U rfmode=0
M$523 \$733 \$39 \$781 VSS|vss sg13_lv_nmos L=0.45U W=2U AS=0.68P AD=0.38P
+ PS=4.68U PD=2.38U rfmode=0
M$524 \$828 \$71 \$733 VSS|vss sg13_lv_nmos L=0.45U W=2U AS=0.38P AD=0.68P
+ PS=2.38U PD=4.68U rfmode=0
M$525 \$829 \$67 \$809 VSS|vss sg13_lv_nmos L=0.45U W=2U AS=0.68P AD=0.38P
+ PS=4.68U PD=2.38U rfmode=0
M$526 \$830 \$35 \$829 VSS|vss sg13_lv_nmos L=0.45U W=2U AS=0.38P AD=0.68P
+ PS=2.38U PD=4.68U rfmode=0
M$527 \$736 \$39 \$785 VSS|vss sg13_lv_nmos L=0.45U W=2U AS=0.68P AD=0.38P
+ PS=4.68U PD=2.38U rfmode=0
M$528 \$832 \$71 \$736 VSS|vss sg13_lv_nmos L=0.45U W=2U AS=0.38P AD=0.68P
+ PS=2.38U PD=4.68U rfmode=0
M$529 \$837 \$83 \$816 VSS|vss sg13_lv_nmos L=0.45U W=2U AS=0.68P AD=0.38P
+ PS=4.68U PD=2.38U rfmode=0
M$530 \$838 \$51 \$837 VSS|vss sg13_lv_nmos L=0.45U W=2U AS=0.38P AD=0.68P
+ PS=2.38U PD=4.68U rfmode=0
M$531 \$744 \$55 \$793 VSS|vss sg13_lv_nmos L=0.45U W=2U AS=0.68P AD=0.38P
+ PS=4.68U PD=2.38U rfmode=0
M$532 \$840 \$87 \$744 VSS|vss sg13_lv_nmos L=0.45U W=2U AS=0.38P AD=0.68P
+ PS=2.38U PD=4.68U rfmode=0
M$533 \$842 \$83 \$819 VSS|vss sg13_lv_nmos L=0.45U W=2U AS=0.68P AD=0.38P
+ PS=4.68U PD=2.38U rfmode=0
M$534 \$841 \$51 \$842 VSS|vss sg13_lv_nmos L=0.45U W=2U AS=0.38P AD=0.68P
+ PS=2.38U PD=4.68U rfmode=0
M$535 \$748 \$55 \$797 VSS|vss sg13_lv_nmos L=0.45U W=2U AS=0.68P AD=0.38P
+ PS=4.68U PD=2.38U rfmode=0
M$536 \$844 \$87 \$748 VSS|vss sg13_lv_nmos L=0.45U W=2U AS=0.38P AD=0.68P
+ PS=2.38U PD=4.68U rfmode=0
M$537 \$807 \$69 \$826 VSS|vss sg13_lv_nmos L=0.45U W=2U AS=0.68P AD=0.38P
+ PS=4.68U PD=2.38U rfmode=0
M$538 \$866 \$37 \$807 VSS|vss sg13_lv_nmos L=0.45U W=2U AS=0.38P AD=0.68P
+ PS=2.38U PD=4.68U rfmode=0
M$539 \$846 \$35 \$827 VSS|vss sg13_lv_nmos L=0.45U W=2U AS=0.68P AD=0.38P
+ PS=4.68U PD=2.38U rfmode=0
M$540 \$855 \$67 \$846 VSS|vss sg13_lv_nmos L=0.45U W=2U AS=0.38P AD=0.68P
+ PS=2.38U PD=4.68U rfmode=0
M$541 \$810 \$69 \$829 VSS|vss sg13_lv_nmos L=0.45U W=2U AS=0.68P AD=0.38P
+ PS=4.68U PD=2.38U rfmode=0
M$542 \$867 \$37 \$810 VSS|vss sg13_lv_nmos L=0.45U W=2U AS=0.38P AD=0.68P
+ PS=2.38U PD=4.68U rfmode=0
M$543 \$817 \$85 \$837 VSS|vss sg13_lv_nmos L=0.45U W=2U AS=0.68P AD=0.38P
+ PS=4.68U PD=2.38U rfmode=0
M$544 \$868 \$53 \$817 VSS|vss sg13_lv_nmos L=0.45U W=2U AS=0.38P AD=0.68P
+ PS=2.38U PD=4.68U rfmode=0
M$545 \$848 \$51 \$839 VSS|vss sg13_lv_nmos L=0.45U W=2U AS=0.68P AD=0.38P
+ PS=4.68U PD=2.38U rfmode=0
M$546 \$863 \$83 \$848 VSS|vss sg13_lv_nmos L=0.45U W=2U AS=0.38P AD=0.68P
+ PS=2.38U PD=4.68U rfmode=0
M$547 \$820 \$85 \$842 VSS|vss sg13_lv_nmos L=0.45U W=2U AS=0.68P AD=0.38P
+ PS=4.68U PD=2.38U rfmode=0
M$548 \$869 \$53 \$820 VSS|vss sg13_lv_nmos L=0.45U W=2U AS=0.38P AD=0.68P
+ PS=2.38U PD=4.68U rfmode=0
M$549 \$849 \$51 \$843 VSS|vss sg13_lv_nmos L=0.45U W=2U AS=0.68P AD=0.38P
+ PS=4.68U PD=2.38U rfmode=0
M$550 \$865 \$83 \$849 VSS|vss sg13_lv_nmos L=0.45U W=2U AS=0.38P AD=0.68P
+ PS=2.38U PD=4.68U rfmode=0
M$551 \$847 \$35 \$831 VSS|vss sg13_lv_nmos L=0.45U W=2U AS=0.68P AD=0.38P
+ PS=4.68U PD=2.38U rfmode=0
M$552 \$857 \$67 \$847 VSS|vss sg13_lv_nmos L=0.45U W=2U AS=0.38P AD=0.68P
+ PS=2.38U PD=4.68U rfmode=0
M$553 \$866 \$67 \$854 VSS|vss sg13_lv_nmos L=0.45U W=2U AS=0.68P AD=0.38P
+ PS=4.68U PD=2.38U rfmode=0
M$554 \$873 \$35 \$866 VSS|vss sg13_lv_nmos L=0.45U W=2U AS=0.38P AD=0.68P
+ PS=2.38U PD=4.68U rfmode=0
M$555 \$828 \$37 \$846 VSS|vss sg13_lv_nmos L=0.45U W=2U AS=0.68P AD=0.38P
+ PS=4.68U PD=2.38U rfmode=0
M$556 \$887 \$69 \$828 VSS|vss sg13_lv_nmos L=0.45U W=2U AS=0.38P AD=0.68P
+ PS=2.38U PD=4.68U rfmode=0
M$557 \$867 \$67 \$856 VSS|vss sg13_lv_nmos L=0.45U W=2U AS=0.68P AD=0.38P
+ PS=4.68U PD=2.38U rfmode=0
M$558 \$875 \$35 \$867 VSS|vss sg13_lv_nmos L=0.45U W=2U AS=0.38P AD=0.68P
+ PS=2.38U PD=4.68U rfmode=0
M$559 \$832 \$37 \$847 VSS|vss sg13_lv_nmos L=0.45U W=2U AS=0.68P AD=0.38P
+ PS=4.68U PD=2.38U rfmode=0
M$560 \$889 \$69 \$832 VSS|vss sg13_lv_nmos L=0.45U W=2U AS=0.38P AD=0.68P
+ PS=2.38U PD=4.68U rfmode=0
M$561 \$868 \$83 \$862 VSS|vss sg13_lv_nmos L=0.45U W=2U AS=0.68P AD=0.38P
+ PS=4.68U PD=2.38U rfmode=0
M$562 \$881 \$51 \$868 VSS|vss sg13_lv_nmos L=0.45U W=2U AS=0.38P AD=0.68P
+ PS=2.38U PD=4.68U rfmode=0
M$563 \$840 \$53 \$848 VSS|vss sg13_lv_nmos L=0.45U W=2U AS=0.68P AD=0.38P
+ PS=4.68U PD=2.38U rfmode=0
M$564 \$891 \$85 \$840 VSS|vss sg13_lv_nmos L=0.45U W=2U AS=0.38P AD=0.68P
+ PS=2.38U PD=4.68U rfmode=0
M$565 \$869 \$83 \$864 VSS|vss sg13_lv_nmos L=0.45U W=2U AS=0.68P AD=0.38P
+ PS=4.68U PD=2.38U rfmode=0
M$566 \$883 \$51 \$869 VSS|vss sg13_lv_nmos L=0.45U W=2U AS=0.38P AD=0.68P
+ PS=2.38U PD=4.68U rfmode=0
M$567 \$844 \$53 \$849 VSS|vss sg13_lv_nmos L=0.45U W=2U AS=0.68P AD=0.38P
+ PS=4.68U PD=2.38U rfmode=0
M$568 \$893 \$85 \$844 VSS|vss sg13_lv_nmos L=0.45U W=2U AS=0.38P AD=0.68P
+ PS=2.38U PD=4.68U rfmode=0
M$569 \$886 \$77 \$500 VSS|vss sg13_lv_nmos L=0.45U W=2U AS=0.68P AD=0.38P
+ PS=4.68U PD=2.38U rfmode=0
M$570 \$1276 \$45 \$886 VSS|vss sg13_lv_nmos L=0.45U W=2U AS=0.38P AD=0.68P
+ PS=2.38U PD=4.68U rfmode=0
M$571 \$887 \$35 \$874 VSS|vss sg13_lv_nmos L=0.45U W=2U AS=0.68P AD=0.38P
+ PS=4.68U PD=2.38U rfmode=0
M$572 \$899 \$67 \$887 VSS|vss sg13_lv_nmos L=0.45U W=2U AS=0.38P AD=0.68P
+ PS=2.38U PD=4.68U rfmode=0
M$573 \$888 \$77 \$505 VSS|vss sg13_lv_nmos L=0.45U W=2U AS=0.68P AD=0.38P
+ PS=4.68U PD=2.38U rfmode=0
M$574 \$1278 \$45 \$888 VSS|vss sg13_lv_nmos L=0.45U W=2U AS=0.38P AD=0.68P
+ PS=2.38U PD=4.68U rfmode=0
M$575 \$889 \$35 \$876 VSS|vss sg13_lv_nmos L=0.45U W=2U AS=0.68P AD=0.38P
+ PS=4.68U PD=2.38U rfmode=0
M$576 \$901 \$67 \$889 VSS|vss sg13_lv_nmos L=0.45U W=2U AS=0.38P AD=0.68P
+ PS=2.38U PD=4.68U rfmode=0
M$577 \$890 \$93 \$515 VSS|vss sg13_lv_nmos L=0.45U W=2U AS=0.68P AD=0.38P
+ PS=4.68U PD=2.38U rfmode=0
M$578 \$1280 \$61 \$890 VSS|vss sg13_lv_nmos L=0.45U W=2U AS=0.38P AD=0.68P
+ PS=2.38U PD=4.68U rfmode=0
M$579 \$891 \$51 \$882 VSS|vss sg13_lv_nmos L=0.45U W=2U AS=0.68P AD=0.38P
+ PS=4.68U PD=2.38U rfmode=0
M$580 \$907 \$83 \$891 VSS|vss sg13_lv_nmos L=0.45U W=2U AS=0.38P AD=0.68P
+ PS=2.38U PD=4.68U rfmode=0
M$581 \$892 \$93 \$520 VSS|vss sg13_lv_nmos L=0.45U W=2U AS=0.68P AD=0.38P
+ PS=4.68U PD=2.38U rfmode=0
M$582 \$1282 \$61 \$892 VSS|vss sg13_lv_nmos L=0.45U W=2U AS=0.38P AD=0.68P
+ PS=2.38U PD=4.68U rfmode=0
M$583 \$893 \$51 \$884 VSS|vss sg13_lv_nmos L=0.45U W=2U AS=0.68P AD=0.38P
+ PS=4.68U PD=2.38U rfmode=0
M$584 \$909 \$83 \$893 VSS|vss sg13_lv_nmos L=0.45U W=2U AS=0.38P AD=0.68P
+ PS=2.38U PD=4.68U rfmode=0
M$585 \$914 \$67 \$898 VSS|vss sg13_lv_nmos L=0.45U W=2U AS=0.68P AD=0.38P
+ PS=4.68U PD=2.38U rfmode=0
M$586 \$915 \$35 \$914 VSS|vss sg13_lv_nmos L=0.45U W=2U AS=0.38P AD=0.68P
+ PS=2.38U PD=4.68U rfmode=0
M$587 \$917 \$45 \$526 VSS|vss sg13_lv_nmos L=0.45U W=2U AS=0.68P AD=0.38P
+ PS=4.68U PD=2.38U rfmode=0
M$588 \$1305 \$77 \$917 VSS|vss sg13_lv_nmos L=0.45U W=2U AS=0.38P AD=0.68P
+ PS=2.38U PD=4.68U rfmode=0
M$589 \$918 \$67 \$900 VSS|vss sg13_lv_nmos L=0.45U W=2U AS=0.68P AD=0.38P
+ PS=4.68U PD=2.38U rfmode=0
M$590 \$919 \$35 \$918 VSS|vss sg13_lv_nmos L=0.45U W=2U AS=0.38P AD=0.68P
+ PS=2.38U PD=4.68U rfmode=0
M$591 \$921 \$45 \$528 VSS|vss sg13_lv_nmos L=0.45U W=2U AS=0.68P AD=0.38P
+ PS=4.68U PD=2.38U rfmode=0
M$592 \$1307 \$77 \$921 VSS|vss sg13_lv_nmos L=0.45U W=2U AS=0.38P AD=0.68P
+ PS=2.38U PD=4.68U rfmode=0
M$593 \$927 \$83 \$906 VSS|vss sg13_lv_nmos L=0.45U W=2U AS=0.68P AD=0.38P
+ PS=4.68U PD=2.38U rfmode=0
M$594 \$926 \$51 \$927 VSS|vss sg13_lv_nmos L=0.45U W=2U AS=0.38P AD=0.68P
+ PS=2.38U PD=4.68U rfmode=0
M$595 \$929 \$61 \$530 VSS|vss sg13_lv_nmos L=0.45U W=2U AS=0.68P AD=0.38P
+ PS=4.68U PD=2.38U rfmode=0
M$596 \$1309 \$93 \$929 VSS|vss sg13_lv_nmos L=0.45U W=2U AS=0.38P AD=0.68P
+ PS=2.38U PD=4.68U rfmode=0
M$597 \$931 \$83 \$908 VSS|vss sg13_lv_nmos L=0.45U W=2U AS=0.68P AD=0.38P
+ PS=4.68U PD=2.38U rfmode=0
M$598 \$930 \$51 \$931 VSS|vss sg13_lv_nmos L=0.45U W=2U AS=0.38P AD=0.68P
+ PS=2.38U PD=4.68U rfmode=0
M$599 \$933 \$61 \$532 VSS|vss sg13_lv_nmos L=0.45U W=2U AS=0.68P AD=0.38P
+ PS=4.68U PD=2.38U rfmode=0
M$600 \$1311 \$93 \$933 VSS|vss sg13_lv_nmos L=0.45U W=2U AS=0.38P AD=0.68P
+ PS=2.38U PD=4.68U rfmode=0
M$601 \$934 \$69 \$914 VSS|vss sg13_lv_nmos L=0.45U W=2U AS=0.68P AD=0.38P
+ PS=4.68U PD=2.38U rfmode=0
M$602 \$962 \$37 \$934 VSS|vss sg13_lv_nmos L=0.45U W=2U AS=0.38P AD=0.68P
+ PS=2.38U PD=4.68U rfmode=0
M$603 \$935 \$35 \$916 VSS|vss sg13_lv_nmos L=0.45U W=2U AS=0.68P AD=0.38P
+ PS=4.68U PD=2.38U rfmode=0
M$604 \$947 \$67 \$935 VSS|vss sg13_lv_nmos L=0.45U W=2U AS=0.38P AD=0.68P
+ PS=2.38U PD=4.68U rfmode=0
M$605 \$936 \$69 \$918 VSS|vss sg13_lv_nmos L=0.45U W=2U AS=0.68P AD=0.38P
+ PS=4.68U PD=2.38U rfmode=0
M$606 \$964 \$37 \$936 VSS|vss sg13_lv_nmos L=0.45U W=2U AS=0.38P AD=0.68P
+ PS=2.38U PD=4.68U rfmode=0
M$607 \$937 \$35 \$920 VSS|vss sg13_lv_nmos L=0.45U W=2U AS=0.68P AD=0.38P
+ PS=4.68U PD=2.38U rfmode=0
M$608 \$949 \$67 \$937 VSS|vss sg13_lv_nmos L=0.45U W=2U AS=0.38P AD=0.68P
+ PS=2.38U PD=4.68U rfmode=0
M$609 \$938 \$85 \$927 VSS|vss sg13_lv_nmos L=0.45U W=2U AS=0.68P AD=0.38P
+ PS=4.68U PD=2.38U rfmode=0
M$610 \$970 \$53 \$938 VSS|vss sg13_lv_nmos L=0.45U W=2U AS=0.38P AD=0.68P
+ PS=2.38U PD=4.68U rfmode=0
M$611 \$940 \$85 \$931 VSS|vss sg13_lv_nmos L=0.45U W=2U AS=0.68P AD=0.38P
+ PS=4.68U PD=2.38U rfmode=0
M$612 \$974 \$53 \$940 VSS|vss sg13_lv_nmos L=0.45U W=2U AS=0.38P AD=0.68P
+ PS=2.38U PD=4.68U rfmode=0
M$613 \$941 \$51 \$932 VSS|vss sg13_lv_nmos L=0.45U W=2U AS=0.68P AD=0.38P
+ PS=4.68U PD=2.38U rfmode=0
M$614 \$957 \$83 \$941 VSS|vss sg13_lv_nmos L=0.45U W=2U AS=0.38P AD=0.68P
+ PS=2.38U PD=4.68U rfmode=0
M$615 \$939 \$51 \$928 VSS|vss sg13_lv_nmos L=0.45U W=2U AS=0.68P AD=0.38P
+ PS=4.68U PD=2.38U rfmode=0
M$616 \$955 \$83 \$939 VSS|vss sg13_lv_nmos L=0.45U W=2U AS=0.38P AD=0.68P
+ PS=2.38U PD=4.68U rfmode=0
M$617 \$962 \$67 \$946 VSS|vss sg13_lv_nmos L=0.45U W=2U AS=0.68P AD=0.38P
+ PS=4.68U PD=2.38U rfmode=0
M$618 \$961 \$35 \$962 VSS|vss sg13_lv_nmos L=0.45U W=2U AS=0.38P AD=0.68P
+ PS=2.38U PD=4.68U rfmode=0
M$619 \$963 \$37 \$935 VSS|vss sg13_lv_nmos L=0.45U W=2U AS=0.68P AD=0.38P
+ PS=4.68U PD=2.38U rfmode=0
M$620 \$985 \$69 \$963 VSS|vss sg13_lv_nmos L=0.45U W=2U AS=0.38P AD=0.68P
+ PS=2.38U PD=4.68U rfmode=0
M$621 \$964 \$67 \$948 VSS|vss sg13_lv_nmos L=0.45U W=2U AS=0.68P AD=0.38P
+ PS=4.68U PD=2.38U rfmode=0
M$622 \$965 \$35 \$964 VSS|vss sg13_lv_nmos L=0.45U W=2U AS=0.38P AD=0.68P
+ PS=2.38U PD=4.68U rfmode=0
M$623 \$966 \$37 \$937 VSS|vss sg13_lv_nmos L=0.45U W=2U AS=0.68P AD=0.38P
+ PS=4.68U PD=2.38U rfmode=0
M$624 \$987 \$69 \$966 VSS|vss sg13_lv_nmos L=0.45U W=2U AS=0.38P AD=0.68P
+ PS=2.38U PD=4.68U rfmode=0
M$625 \$970 \$83 \$954 VSS|vss sg13_lv_nmos L=0.45U W=2U AS=0.68P AD=0.38P
+ PS=4.68U PD=2.38U rfmode=0
M$626 \$971 \$51 \$970 VSS|vss sg13_lv_nmos L=0.45U W=2U AS=0.38P AD=0.68P
+ PS=2.38U PD=4.68U rfmode=0
M$627 \$973 \$53 \$939 VSS|vss sg13_lv_nmos L=0.45U W=2U AS=0.68P AD=0.38P
+ PS=4.68U PD=2.38U rfmode=0
M$628 \$989 \$85 \$973 VSS|vss sg13_lv_nmos L=0.45U W=2U AS=0.38P AD=0.68P
+ PS=2.38U PD=4.68U rfmode=0
M$629 \$974 \$83 \$956 VSS|vss sg13_lv_nmos L=0.45U W=2U AS=0.68P AD=0.38P
+ PS=4.68U PD=2.38U rfmode=0
M$630 \$975 \$51 \$974 VSS|vss sg13_lv_nmos L=0.45U W=2U AS=0.38P AD=0.68P
+ PS=2.38U PD=4.68U rfmode=0
M$631 \$977 \$53 \$941 VSS|vss sg13_lv_nmos L=0.45U W=2U AS=0.68P AD=0.38P
+ PS=4.68U PD=2.38U rfmode=0
M$632 \$991 \$85 \$977 VSS|vss sg13_lv_nmos L=0.45U W=2U AS=0.38P AD=0.68P
+ PS=2.38U PD=4.68U rfmode=0
M$633 \$967 \$47 \$921 VSS|vss sg13_lv_nmos L=0.45U W=2U AS=0.68P AD=0.38P
+ PS=4.68U PD=2.38U rfmode=0
M$634 \$888 \$79 \$967 VSS|vss sg13_lv_nmos L=0.45U W=2U AS=0.38P AD=0.68P
+ PS=2.38U PD=4.68U rfmode=0
M$635 \$978 \$63 \$933 VSS|vss sg13_lv_nmos L=0.45U W=2U AS=0.68P AD=0.38P
+ PS=4.68U PD=2.38U rfmode=0
M$636 \$892 \$95 \$978 VSS|vss sg13_lv_nmos L=0.45U W=2U AS=0.38P AD=0.68P
+ PS=2.38U PD=4.68U rfmode=0
M$637 \$984 \$71 \$934 VSS|vss sg13_lv_nmos L=0.45U W=2U AS=0.68P AD=0.38P
+ PS=4.68U PD=2.38U rfmode=0
M$638 \$997 \$39 \$984 VSS|vss sg13_lv_nmos L=0.45U W=2U AS=0.38P AD=0.68P
+ PS=2.38U PD=4.68U rfmode=0
M$639 \$987 \$35 \$981 VSS|vss sg13_lv_nmos L=0.45U W=2U AS=0.68P AD=0.38P
+ PS=4.68U PD=2.38U rfmode=0
M$640 \$1001 \$67 \$987 VSS|vss sg13_lv_nmos L=0.45U W=2U AS=0.38P AD=0.68P
+ PS=2.38U PD=4.68U rfmode=0
M$641 \$988 \$87 \$938 VSS|vss sg13_lv_nmos L=0.45U W=2U AS=0.68P AD=0.38P
+ PS=4.68U PD=2.38U rfmode=0
M$642 \$1007 \$55 \$988 VSS|vss sg13_lv_nmos L=0.45U W=2U AS=0.38P AD=0.68P
+ PS=2.38U PD=4.68U rfmode=0
M$643 \$989 \$51 \$972 VSS|vss sg13_lv_nmos L=0.45U W=2U AS=0.68P AD=0.38P
+ PS=4.68U PD=2.38U rfmode=0
M$644 \$1008 \$83 \$989 VSS|vss sg13_lv_nmos L=0.45U W=2U AS=0.38P AD=0.68P
+ PS=2.38U PD=4.68U rfmode=0
M$645 \$991 \$51 \$976 VSS|vss sg13_lv_nmos L=0.45U W=2U AS=0.68P AD=0.38P
+ PS=4.68U PD=2.38U rfmode=0
M$646 \$1011 \$83 \$991 VSS|vss sg13_lv_nmos L=0.45U W=2U AS=0.38P AD=0.68P
+ PS=2.38U PD=4.68U rfmode=0
M$647 \$985 \$35 \$980 VSS|vss sg13_lv_nmos L=0.45U W=2U AS=0.68P AD=0.38P
+ PS=4.68U PD=2.38U rfmode=0
M$648 \$998 \$67 \$985 VSS|vss sg13_lv_nmos L=0.45U W=2U AS=0.38P AD=0.68P
+ PS=2.38U PD=4.68U rfmode=0
M$649 \$986 \$71 \$936 VSS|vss sg13_lv_nmos L=0.45U W=2U AS=0.68P AD=0.38P
+ PS=4.68U PD=2.38U rfmode=0
M$650 \$1000 \$39 \$986 VSS|vss sg13_lv_nmos L=0.45U W=2U AS=0.38P AD=0.68P
+ PS=2.38U PD=4.68U rfmode=0
M$651 \$990 \$87 \$940 VSS|vss sg13_lv_nmos L=0.45U W=2U AS=0.68P AD=0.38P
+ PS=4.68U PD=2.38U rfmode=0
M$652 \$1010 \$55 \$990 VSS|vss sg13_lv_nmos L=0.45U W=2U AS=0.38P AD=0.68P
+ PS=2.38U PD=4.68U rfmode=0
M$653 \$1016 \$67 \$996 VSS|vss sg13_lv_nmos L=0.45U W=2U AS=0.68P AD=0.38P
+ PS=4.68U PD=2.38U rfmode=0
M$654 \$1017 \$35 \$1016 VSS|vss sg13_lv_nmos L=0.45U W=2U AS=0.38P AD=0.68P
+ PS=2.38U PD=4.68U rfmode=0
M$655 \$1019 \$39 \$963 VSS|vss sg13_lv_nmos L=0.45U W=2U AS=0.68P AD=0.38P
+ PS=4.68U PD=2.38U rfmode=0
M$656 \$1020 \$71 \$1019 VSS|vss sg13_lv_nmos L=0.45U W=2U AS=0.38P AD=0.68P
+ PS=2.38U PD=4.68U rfmode=0
M$657 \$1021 \$67 \$999 VSS|vss sg13_lv_nmos L=0.45U W=2U AS=0.68P AD=0.38P
+ PS=4.68U PD=2.38U rfmode=0
M$658 \$1022 \$35 \$1021 VSS|vss sg13_lv_nmos L=0.45U W=2U AS=0.38P AD=0.68P
+ PS=2.38U PD=4.68U rfmode=0
M$659 \$1024 \$39 \$966 VSS|vss sg13_lv_nmos L=0.45U W=2U AS=0.68P AD=0.38P
+ PS=4.68U PD=2.38U rfmode=0
M$660 \$1025 \$71 \$1024 VSS|vss sg13_lv_nmos L=0.45U W=2U AS=0.38P AD=0.68P
+ PS=2.38U PD=4.68U rfmode=0
M$661 \$1032 \$83 \$1006 VSS|vss sg13_lv_nmos L=0.45U W=2U AS=0.68P AD=0.38P
+ PS=4.68U PD=2.38U rfmode=0
M$662 \$1031 \$51 \$1032 VSS|vss sg13_lv_nmos L=0.45U W=2U AS=0.38P AD=0.68P
+ PS=2.38U PD=4.68U rfmode=0
M$663 \$1034 \$55 \$973 VSS|vss sg13_lv_nmos L=0.45U W=2U AS=0.68P AD=0.38P
+ PS=4.68U PD=2.38U rfmode=0
M$664 \$1035 \$87 \$1034 VSS|vss sg13_lv_nmos L=0.45U W=2U AS=0.38P AD=0.68P
+ PS=2.38U PD=4.68U rfmode=0
M$665 \$1036 \$83 \$1009 VSS|vss sg13_lv_nmos L=0.45U W=2U AS=0.68P AD=0.38P
+ PS=4.68U PD=2.38U rfmode=0
M$666 \$1037 \$51 \$1036 VSS|vss sg13_lv_nmos L=0.45U W=2U AS=0.38P AD=0.68P
+ PS=2.38U PD=4.68U rfmode=0
M$667 \$1039 \$55 \$977 VSS|vss sg13_lv_nmos L=0.45U W=2U AS=0.68P AD=0.38P
+ PS=4.68U PD=2.38U rfmode=0
M$668 \$1040 \$87 \$1039 VSS|vss sg13_lv_nmos L=0.45U W=2U AS=0.38P AD=0.68P
+ PS=2.38U PD=4.68U rfmode=0
M$669 inn|out|vth_soft \$49 \$967 VSS|vss sg13_lv_nmos L=0.45U W=2U AS=0.68P
+ AD=0.38P PS=4.68U PD=2.38U rfmode=0
M$670 \$1049 \$81 inn|out|vth_soft VSS|vss sg13_lv_nmos L=0.45U W=2U AS=0.38P
+ AD=0.68P PS=2.38U PD=4.68U rfmode=0
M$671 inn|out|vth_hard \$65 \$978 VSS|vss sg13_lv_nmos L=0.45U W=2U AS=0.68P
+ AD=0.38P PS=4.68U PD=2.38U rfmode=0
M$672 \$1059 \$97 inn|out|vth_hard VSS|vss sg13_lv_nmos L=0.45U W=2U AS=0.38P
+ AD=0.68P PS=2.38U PD=4.68U rfmode=0
M$673 \$997 \$69 \$1016 VSS|vss sg13_lv_nmos L=0.45U W=2U AS=0.68P AD=0.38P
+ PS=4.68U PD=2.38U rfmode=0
M$674 \$1064 \$37 \$997 VSS|vss sg13_lv_nmos L=0.45U W=2U AS=0.38P AD=0.68P
+ PS=2.38U PD=4.68U rfmode=0
M$675 \$1045 \$35 \$1018 VSS|vss sg13_lv_nmos L=0.45U W=2U AS=0.68P AD=0.38P
+ PS=4.68U PD=2.38U rfmode=0
M$676 \$1046 \$67 \$1045 VSS|vss sg13_lv_nmos L=0.45U W=2U AS=0.38P AD=0.68P
+ PS=2.38U PD=4.68U rfmode=0
M$677 \$1047 \$35 \$1023 VSS|vss sg13_lv_nmos L=0.45U W=2U AS=0.68P AD=0.38P
+ PS=4.68U PD=2.38U rfmode=0
M$678 \$1048 \$67 \$1047 VSS|vss sg13_lv_nmos L=0.45U W=2U AS=0.38P AD=0.68P
+ PS=2.38U PD=4.68U rfmode=0
M$679 \$1007 \$85 \$1032 VSS|vss sg13_lv_nmos L=0.45U W=2U AS=0.68P AD=0.38P
+ PS=4.68U PD=2.38U rfmode=0
M$680 \$1066 \$53 \$1007 VSS|vss sg13_lv_nmos L=0.45U W=2U AS=0.38P AD=0.68P
+ PS=2.38U PD=4.68U rfmode=0
M$681 \$1054 \$51 \$1033 VSS|vss sg13_lv_nmos L=0.45U W=2U AS=0.68P AD=0.38P
+ PS=4.68U PD=2.38U rfmode=0
M$682 \$1055 \$83 \$1054 VSS|vss sg13_lv_nmos L=0.45U W=2U AS=0.38P AD=0.68P
+ PS=2.38U PD=4.68U rfmode=0
M$683 \$1010 \$85 \$1036 VSS|vss sg13_lv_nmos L=0.45U W=2U AS=0.68P AD=0.38P
+ PS=4.68U PD=2.38U rfmode=0
M$684 \$1067 \$53 \$1010 VSS|vss sg13_lv_nmos L=0.45U W=2U AS=0.38P AD=0.68P
+ PS=2.38U PD=4.68U rfmode=0
M$685 \$1058 \$51 \$1038 VSS|vss sg13_lv_nmos L=0.45U W=2U AS=0.68P AD=0.38P
+ PS=4.68U PD=2.38U rfmode=0
M$686 \$1057 \$83 \$1058 VSS|vss sg13_lv_nmos L=0.45U W=2U AS=0.38P AD=0.68P
+ PS=2.38U PD=4.68U rfmode=0
M$687 \$1000 \$69 \$1021 VSS|vss sg13_lv_nmos L=0.45U W=2U AS=0.68P AD=0.38P
+ PS=4.68U PD=2.38U rfmode=0
M$688 \$1065 \$37 \$1000 VSS|vss sg13_lv_nmos L=0.45U W=2U AS=0.38P AD=0.68P
+ PS=2.38U PD=4.68U rfmode=0
M$689 \$1064 \$67 \$1044 VSS|vss sg13_lv_nmos L=0.45U W=2U AS=0.68P AD=0.38P
+ PS=4.68U PD=2.38U rfmode=0
M$690 \$1072 \$35 \$1064 VSS|vss sg13_lv_nmos L=0.45U W=2U AS=0.38P AD=0.68P
+ PS=2.38U PD=4.68U rfmode=0
M$691 \$1020 \$37 \$1045 VSS|vss sg13_lv_nmos L=0.45U W=2U AS=0.68P AD=0.38P
+ PS=4.68U PD=2.38U rfmode=0
M$692 \$1085 \$69 \$1020 VSS|vss sg13_lv_nmos L=0.45U W=2U AS=0.38P AD=0.68P
+ PS=2.38U PD=4.68U rfmode=0
M$693 \$1065 \$67 \$1062 VSS|vss sg13_lv_nmos L=0.45U W=2U AS=0.68P AD=0.38P
+ PS=4.68U PD=2.38U rfmode=0
M$694 \$1074 \$35 \$1065 VSS|vss sg13_lv_nmos L=0.45U W=2U AS=0.38P AD=0.68P
+ PS=2.38U PD=4.68U rfmode=0
M$695 \$1025 \$37 \$1047 VSS|vss sg13_lv_nmos L=0.45U W=2U AS=0.68P AD=0.38P
+ PS=4.68U PD=2.38U rfmode=0
M$696 \$1087 \$69 \$1025 VSS|vss sg13_lv_nmos L=0.45U W=2U AS=0.38P AD=0.68P
+ PS=2.38U PD=4.68U rfmode=0
M$697 \$1066 \$83 \$1053 VSS|vss sg13_lv_nmos L=0.45U W=2U AS=0.68P AD=0.38P
+ PS=4.68U PD=2.38U rfmode=0
M$698 \$1080 \$51 \$1066 VSS|vss sg13_lv_nmos L=0.45U W=2U AS=0.38P AD=0.68P
+ PS=2.38U PD=4.68U rfmode=0
M$699 \$1035 \$53 \$1054 VSS|vss sg13_lv_nmos L=0.45U W=2U AS=0.68P AD=0.38P
+ PS=4.68U PD=2.38U rfmode=0
M$700 \$1089 \$85 \$1035 VSS|vss sg13_lv_nmos L=0.45U W=2U AS=0.38P AD=0.68P
+ PS=2.38U PD=4.68U rfmode=0
M$701 \$1067 \$83 \$1056 VSS|vss sg13_lv_nmos L=0.45U W=2U AS=0.68P AD=0.38P
+ PS=4.68U PD=2.38U rfmode=0
M$702 \$1082 \$51 \$1067 VSS|vss sg13_lv_nmos L=0.45U W=2U AS=0.38P AD=0.68P
+ PS=2.38U PD=4.68U rfmode=0
M$703 \$1040 \$53 \$1058 VSS|vss sg13_lv_nmos L=0.45U W=2U AS=0.68P AD=0.38P
+ PS=4.68U PD=2.38U rfmode=0
M$704 \$1091 \$85 \$1040 VSS|vss sg13_lv_nmos L=0.45U W=2U AS=0.38P AD=0.68P
+ PS=2.38U PD=4.68U rfmode=0
M$705 \$1049 \$47 \$917 VSS|vss sg13_lv_nmos L=0.45U W=2U AS=0.68P AD=0.38P
+ PS=4.68U PD=2.38U rfmode=0
M$706 \$886 \$79 \$1049 VSS|vss sg13_lv_nmos L=0.45U W=2U AS=0.38P AD=0.68P
+ PS=2.38U PD=4.68U rfmode=0
M$707 \$1059 \$63 \$929 VSS|vss sg13_lv_nmos L=0.45U W=2U AS=0.68P AD=0.38P
+ PS=4.68U PD=2.38U rfmode=0
M$708 \$890 \$95 \$1059 VSS|vss sg13_lv_nmos L=0.45U W=2U AS=0.38P AD=0.68P
+ PS=2.38U PD=4.68U rfmode=0
M$709 \$1084 \$73 \$984 VSS|vss sg13_lv_nmos L=0.45U W=2U AS=0.68P AD=0.38P
+ PS=4.68U PD=2.38U rfmode=0
M$710 \$1097 \$41 \$1084 VSS|vss sg13_lv_nmos L=0.45U W=2U AS=0.38P AD=0.68P
+ PS=2.38U PD=4.68U rfmode=0
M$711 \$1085 \$35 \$1073 VSS|vss sg13_lv_nmos L=0.45U W=2U AS=0.68P AD=0.38P
+ PS=4.68U PD=2.38U rfmode=0
M$712 \$1098 \$67 \$1085 VSS|vss sg13_lv_nmos L=0.45U W=2U AS=0.38P AD=0.68P
+ PS=2.38U PD=4.68U rfmode=0
M$713 \$1086 \$73 \$986 VSS|vss sg13_lv_nmos L=0.45U W=2U AS=0.68P AD=0.38P
+ PS=4.68U PD=2.38U rfmode=0
M$714 \$1100 \$41 \$1086 VSS|vss sg13_lv_nmos L=0.45U W=2U AS=0.38P AD=0.68P
+ PS=2.38U PD=4.68U rfmode=0
M$715 \$1087 \$35 \$1075 VSS|vss sg13_lv_nmos L=0.45U W=2U AS=0.68P AD=0.38P
+ PS=4.68U PD=2.38U rfmode=0
M$716 \$1101 \$67 \$1087 VSS|vss sg13_lv_nmos L=0.45U W=2U AS=0.38P AD=0.68P
+ PS=2.38U PD=4.68U rfmode=0
M$717 \$1088 \$89 \$988 VSS|vss sg13_lv_nmos L=0.45U W=2U AS=0.68P AD=0.38P
+ PS=4.68U PD=2.38U rfmode=0
M$718 \$1107 \$57 \$1088 VSS|vss sg13_lv_nmos L=0.45U W=2U AS=0.38P AD=0.68P
+ PS=2.38U PD=4.68U rfmode=0
M$719 \$1089 \$51 \$1081 VSS|vss sg13_lv_nmos L=0.45U W=2U AS=0.68P AD=0.38P
+ PS=4.68U PD=2.38U rfmode=0
M$720 \$1108 \$83 \$1089 VSS|vss sg13_lv_nmos L=0.45U W=2U AS=0.38P AD=0.68P
+ PS=2.38U PD=4.68U rfmode=0
M$721 \$1090 \$89 \$990 VSS|vss sg13_lv_nmos L=0.45U W=2U AS=0.68P AD=0.38P
+ PS=4.68U PD=2.38U rfmode=0
M$722 \$1110 \$57 \$1090 VSS|vss sg13_lv_nmos L=0.45U W=2U AS=0.38P AD=0.68P
+ PS=2.38U PD=4.68U rfmode=0
M$723 \$1091 \$51 \$1083 VSS|vss sg13_lv_nmos L=0.45U W=2U AS=0.68P AD=0.38P
+ PS=4.68U PD=2.38U rfmode=0
M$724 \$1111 \$83 \$1091 VSS|vss sg13_lv_nmos L=0.45U W=2U AS=0.38P AD=0.68P
+ PS=2.38U PD=4.68U rfmode=0
M$725 \$1116 \$67 \$1096 VSS|vss sg13_lv_nmos L=0.45U W=2U AS=0.68P AD=0.38P
+ PS=4.68U PD=2.38U rfmode=0
M$726 \$1117 \$35 \$1116 VSS|vss sg13_lv_nmos L=0.45U W=2U AS=0.38P AD=0.68P
+ PS=2.38U PD=4.68U rfmode=0
M$727 \$1119 \$41 \$1019 VSS|vss sg13_lv_nmos L=0.45U W=2U AS=0.68P AD=0.38P
+ PS=4.68U PD=2.38U rfmode=0
M$728 \$1120 \$73 \$1119 VSS|vss sg13_lv_nmos L=0.45U W=2U AS=0.38P AD=0.68P
+ PS=2.38U PD=4.68U rfmode=0
M$729 \$1121 \$67 \$1099 VSS|vss sg13_lv_nmos L=0.45U W=2U AS=0.68P AD=0.38P
+ PS=4.68U PD=2.38U rfmode=0
M$730 \$1122 \$35 \$1121 VSS|vss sg13_lv_nmos L=0.45U W=2U AS=0.38P AD=0.68P
+ PS=2.38U PD=4.68U rfmode=0
M$731 \$1124 \$41 \$1024 VSS|vss sg13_lv_nmos L=0.45U W=2U AS=0.68P AD=0.38P
+ PS=4.68U PD=2.38U rfmode=0
M$732 \$1125 \$73 \$1124 VSS|vss sg13_lv_nmos L=0.45U W=2U AS=0.38P AD=0.68P
+ PS=2.38U PD=4.68U rfmode=0
M$733 \$1130 \$83 \$1106 VSS|vss sg13_lv_nmos L=0.45U W=2U AS=0.68P AD=0.38P
+ PS=4.68U PD=2.38U rfmode=0
M$734 \$1131 \$51 \$1130 VSS|vss sg13_lv_nmos L=0.45U W=2U AS=0.38P AD=0.68P
+ PS=2.38U PD=4.68U rfmode=0
M$735 \$1133 \$57 \$1034 VSS|vss sg13_lv_nmos L=0.45U W=2U AS=0.68P AD=0.38P
+ PS=4.68U PD=2.38U rfmode=0
M$736 \$1134 \$89 \$1133 VSS|vss sg13_lv_nmos L=0.45U W=2U AS=0.38P AD=0.68P
+ PS=2.38U PD=4.68U rfmode=0
M$737 \$1135 \$83 \$1109 VSS|vss sg13_lv_nmos L=0.45U W=2U AS=0.68P AD=0.38P
+ PS=4.68U PD=2.38U rfmode=0
M$738 \$1136 \$51 \$1135 VSS|vss sg13_lv_nmos L=0.45U W=2U AS=0.38P AD=0.68P
+ PS=2.38U PD=4.68U rfmode=0
M$739 \$1138 \$57 \$1039 VSS|vss sg13_lv_nmos L=0.45U W=2U AS=0.68P AD=0.38P
+ PS=4.68U PD=2.38U rfmode=0
M$740 \$1139 \$89 \$1138 VSS|vss sg13_lv_nmos L=0.45U W=2U AS=0.38P AD=0.68P
+ PS=2.38U PD=4.68U rfmode=0
M$741 \$1140 \$69 \$1116 VSS|vss sg13_lv_nmos L=0.45U W=2U AS=0.68P AD=0.38P
+ PS=4.68U PD=2.38U rfmode=0
M$742 \$1168 \$37 \$1140 VSS|vss sg13_lv_nmos L=0.45U W=2U AS=0.38P AD=0.68P
+ PS=2.38U PD=4.68U rfmode=0
M$743 \$1143 \$35 \$1123 VSS|vss sg13_lv_nmos L=0.45U W=2U AS=0.68P AD=0.38P
+ PS=4.68U PD=2.38U rfmode=0
M$744 \$1155 \$67 \$1143 VSS|vss sg13_lv_nmos L=0.45U W=2U AS=0.38P AD=0.68P
+ PS=2.38U PD=4.68U rfmode=0
M$745 \$1145 \$51 \$1132 VSS|vss sg13_lv_nmos L=0.45U W=2U AS=0.68P AD=0.38P
+ PS=4.68U PD=2.38U rfmode=0
M$746 \$1161 \$83 \$1145 VSS|vss sg13_lv_nmos L=0.45U W=2U AS=0.38P AD=0.68P
+ PS=2.38U PD=4.68U rfmode=0
M$747 \$1146 \$85 \$1135 VSS|vss sg13_lv_nmos L=0.45U W=2U AS=0.68P AD=0.38P
+ PS=4.68U PD=2.38U rfmode=0
M$748 \$1184 \$53 \$1146 VSS|vss sg13_lv_nmos L=0.45U W=2U AS=0.38P AD=0.68P
+ PS=2.38U PD=4.68U rfmode=0
M$749 \$1147 \$51 \$1137 VSS|vss sg13_lv_nmos L=0.45U W=2U AS=0.68P AD=0.38P
+ PS=4.68U PD=2.38U rfmode=0
M$750 \$1163 \$83 \$1147 VSS|vss sg13_lv_nmos L=0.45U W=2U AS=0.38P AD=0.68P
+ PS=2.38U PD=4.68U rfmode=0
M$751 \$1141 \$35 \$1118 VSS|vss sg13_lv_nmos L=0.45U W=2U AS=0.68P AD=0.38P
+ PS=4.68U PD=2.38U rfmode=0
M$752 \$1153 \$67 \$1141 VSS|vss sg13_lv_nmos L=0.45U W=2U AS=0.38P AD=0.68P
+ PS=2.38U PD=4.68U rfmode=0
M$753 \$1142 \$69 \$1121 VSS|vss sg13_lv_nmos L=0.45U W=2U AS=0.68P AD=0.38P
+ PS=4.68U PD=2.38U rfmode=0
M$754 \$1172 \$37 \$1142 VSS|vss sg13_lv_nmos L=0.45U W=2U AS=0.38P AD=0.68P
+ PS=2.38U PD=4.68U rfmode=0
M$755 \$1144 \$85 \$1130 VSS|vss sg13_lv_nmos L=0.45U W=2U AS=0.68P AD=0.38P
+ PS=4.68U PD=2.38U rfmode=0
M$756 \$1180 \$53 \$1144 VSS|vss sg13_lv_nmos L=0.45U W=2U AS=0.38P AD=0.68P
+ PS=2.38U PD=4.68U rfmode=0
M$757 \$1168 \$67 \$1152 VSS|vss sg13_lv_nmos L=0.45U W=2U AS=0.68P AD=0.38P
+ PS=4.68U PD=2.38U rfmode=0
M$758 \$1169 \$35 \$1168 VSS|vss sg13_lv_nmos L=0.45U W=2U AS=0.38P AD=0.68P
+ PS=2.38U PD=4.68U rfmode=0
M$759 \$1171 \$37 \$1141 VSS|vss sg13_lv_nmos L=0.45U W=2U AS=0.68P AD=0.38P
+ PS=4.68U PD=2.38U rfmode=0
M$760 \$1188 \$69 \$1171 VSS|vss sg13_lv_nmos L=0.45U W=2U AS=0.38P AD=0.68P
+ PS=2.38U PD=4.68U rfmode=0
M$761 \$1172 \$67 \$1154 VSS|vss sg13_lv_nmos L=0.45U W=2U AS=0.68P AD=0.38P
+ PS=4.68U PD=2.38U rfmode=0
M$762 \$1173 \$35 \$1172 VSS|vss sg13_lv_nmos L=0.45U W=2U AS=0.38P AD=0.68P
+ PS=2.38U PD=4.68U rfmode=0
M$763 \$1175 \$37 \$1143 VSS|vss sg13_lv_nmos L=0.45U W=2U AS=0.68P AD=0.38P
+ PS=4.68U PD=2.38U rfmode=0
M$764 \$1189 \$69 \$1175 VSS|vss sg13_lv_nmos L=0.45U W=2U AS=0.38P AD=0.68P
+ PS=2.38U PD=4.68U rfmode=0
M$765 \$1180 \$83 \$1160 VSS|vss sg13_lv_nmos L=0.45U W=2U AS=0.68P AD=0.38P
+ PS=4.68U PD=2.38U rfmode=0
M$766 \$1181 \$51 \$1180 VSS|vss sg13_lv_nmos L=0.45U W=2U AS=0.38P AD=0.68P
+ PS=2.38U PD=4.68U rfmode=0
M$767 \$1183 \$53 \$1145 VSS|vss sg13_lv_nmos L=0.45U W=2U AS=0.68P AD=0.38P
+ PS=4.68U PD=2.38U rfmode=0
M$768 \$1190 \$85 \$1183 VSS|vss sg13_lv_nmos L=0.45U W=2U AS=0.38P AD=0.68P
+ PS=2.38U PD=4.68U rfmode=0
M$769 \$1184 \$83 \$1162 VSS|vss sg13_lv_nmos L=0.45U W=2U AS=0.68P AD=0.38P
+ PS=4.68U PD=2.38U rfmode=0
M$770 \$1185 \$51 \$1184 VSS|vss sg13_lv_nmos L=0.45U W=2U AS=0.38P AD=0.68P
+ PS=2.38U PD=4.68U rfmode=0
M$771 \$1187 \$53 \$1147 VSS|vss sg13_lv_nmos L=0.45U W=2U AS=0.68P AD=0.38P
+ PS=4.68U PD=2.38U rfmode=0
M$772 \$1191 \$85 \$1187 VSS|vss sg13_lv_nmos L=0.45U W=2U AS=0.38P AD=0.68P
+ PS=2.38U PD=4.68U rfmode=0
M$773 \$1097 \$71 \$1140 VSS|vss sg13_lv_nmos L=0.45U W=2U AS=0.68P AD=0.38P
+ PS=4.68U PD=2.38U rfmode=0
M$774 \$1197 \$39 \$1097 VSS|vss sg13_lv_nmos L=0.45U W=2U AS=0.38P AD=0.68P
+ PS=2.38U PD=4.68U rfmode=0
M$775 \$1188 \$35 \$1170 VSS|vss sg13_lv_nmos L=0.45U W=2U AS=0.68P AD=0.38P
+ PS=4.68U PD=2.38U rfmode=0
M$776 \$1198 \$67 \$1188 VSS|vss sg13_lv_nmos L=0.45U W=2U AS=0.38P AD=0.68P
+ PS=2.38U PD=4.68U rfmode=0
M$777 \$1100 \$71 \$1142 VSS|vss sg13_lv_nmos L=0.45U W=2U AS=0.68P AD=0.38P
+ PS=4.68U PD=2.38U rfmode=0
M$778 \$1200 \$39 \$1100 VSS|vss sg13_lv_nmos L=0.45U W=2U AS=0.38P AD=0.68P
+ PS=2.38U PD=4.68U rfmode=0
M$779 \$1190 \$51 \$1182 VSS|vss sg13_lv_nmos L=0.45U W=2U AS=0.68P AD=0.38P
+ PS=4.68U PD=2.38U rfmode=0
M$780 \$1208 \$83 \$1190 VSS|vss sg13_lv_nmos L=0.45U W=2U AS=0.38P AD=0.68P
+ PS=2.38U PD=4.68U rfmode=0
M$781 \$1110 \$87 \$1146 VSS|vss sg13_lv_nmos L=0.45U W=2U AS=0.68P AD=0.38P
+ PS=4.68U PD=2.38U rfmode=0
M$782 \$1210 \$55 \$1110 VSS|vss sg13_lv_nmos L=0.45U W=2U AS=0.38P AD=0.68P
+ PS=2.38U PD=4.68U rfmode=0
M$783 \$1191 \$51 \$1186 VSS|vss sg13_lv_nmos L=0.45U W=2U AS=0.68P AD=0.38P
+ PS=4.68U PD=2.38U rfmode=0
M$784 \$1211 \$83 \$1191 VSS|vss sg13_lv_nmos L=0.45U W=2U AS=0.38P AD=0.68P
+ PS=2.38U PD=4.68U rfmode=0
M$785 \$1189 \$35 \$1174 VSS|vss sg13_lv_nmos L=0.45U W=2U AS=0.68P AD=0.38P
+ PS=4.68U PD=2.38U rfmode=0
M$786 \$1201 \$67 \$1189 VSS|vss sg13_lv_nmos L=0.45U W=2U AS=0.38P AD=0.68P
+ PS=2.38U PD=4.68U rfmode=0
M$787 \$1107 \$87 \$1144 VSS|vss sg13_lv_nmos L=0.45U W=2U AS=0.68P AD=0.38P
+ PS=4.68U PD=2.38U rfmode=0
M$788 \$1207 \$55 \$1107 VSS|vss sg13_lv_nmos L=0.45U W=2U AS=0.38P AD=0.68P
+ PS=2.38U PD=4.68U rfmode=0
M$789 \$1217 \$67 \$1196 VSS|vss sg13_lv_nmos L=0.45U W=2U AS=0.68P AD=0.38P
+ PS=4.68U PD=2.38U rfmode=0
M$790 \$1216 \$35 \$1217 VSS|vss sg13_lv_nmos L=0.45U W=2U AS=0.38P AD=0.68P
+ PS=2.38U PD=4.68U rfmode=0
M$791 \$1120 \$39 \$1171 VSS|vss sg13_lv_nmos L=0.45U W=2U AS=0.68P AD=0.38P
+ PS=4.68U PD=2.38U rfmode=0
M$792 \$1219 \$71 \$1120 VSS|vss sg13_lv_nmos L=0.45U W=2U AS=0.38P AD=0.68P
+ PS=2.38U PD=4.68U rfmode=0
M$793 \$1220 \$67 \$1199 VSS|vss sg13_lv_nmos L=0.45U W=2U AS=0.68P AD=0.38P
+ PS=4.68U PD=2.38U rfmode=0
M$794 \$1221 \$35 \$1220 VSS|vss sg13_lv_nmos L=0.45U W=2U AS=0.38P AD=0.68P
+ PS=2.38U PD=4.68U rfmode=0
M$795 \$1125 \$39 \$1175 VSS|vss sg13_lv_nmos L=0.45U W=2U AS=0.68P AD=0.38P
+ PS=4.68U PD=2.38U rfmode=0
M$796 \$1223 \$71 \$1125 VSS|vss sg13_lv_nmos L=0.45U W=2U AS=0.38P AD=0.68P
+ PS=2.38U PD=4.68U rfmode=0
M$797 \$1227 \$83 \$1206 VSS|vss sg13_lv_nmos L=0.45U W=2U AS=0.68P AD=0.38P
+ PS=4.68U PD=2.38U rfmode=0
M$798 \$1228 \$51 \$1227 VSS|vss sg13_lv_nmos L=0.45U W=2U AS=0.38P AD=0.68P
+ PS=2.38U PD=4.68U rfmode=0
M$799 \$1134 \$55 \$1183 VSS|vss sg13_lv_nmos L=0.45U W=2U AS=0.68P AD=0.38P
+ PS=4.68U PD=2.38U rfmode=0
M$800 \$1230 \$87 \$1134 VSS|vss sg13_lv_nmos L=0.45U W=2U AS=0.38P AD=0.68P
+ PS=2.38U PD=4.68U rfmode=0
M$801 \$1232 \$83 \$1209 VSS|vss sg13_lv_nmos L=0.45U W=2U AS=0.68P AD=0.38P
+ PS=4.68U PD=2.38U rfmode=0
M$802 \$1231 \$51 \$1232 VSS|vss sg13_lv_nmos L=0.45U W=2U AS=0.38P AD=0.68P
+ PS=2.38U PD=4.68U rfmode=0
M$803 \$1139 \$55 \$1187 VSS|vss sg13_lv_nmos L=0.45U W=2U AS=0.68P AD=0.38P
+ PS=4.68U PD=2.38U rfmode=0
M$804 \$1234 \$87 \$1139 VSS|vss sg13_lv_nmos L=0.45U W=2U AS=0.38P AD=0.68P
+ PS=2.38U PD=4.68U rfmode=0
M$805 \$1197 \$69 \$1217 VSS|vss sg13_lv_nmos L=0.45U W=2U AS=0.68P AD=0.38P
+ PS=4.68U PD=2.38U rfmode=0
M$806 \$1256 \$37 \$1197 VSS|vss sg13_lv_nmos L=0.45U W=2U AS=0.38P AD=0.68P
+ PS=2.38U PD=4.68U rfmode=0
M$807 \$1236 \$35 \$1222 VSS|vss sg13_lv_nmos L=0.45U W=2U AS=0.68P AD=0.38P
+ PS=4.68U PD=2.38U rfmode=0
M$808 \$1247 \$67 \$1236 VSS|vss sg13_lv_nmos L=0.45U W=2U AS=0.38P AD=0.68P
+ PS=2.38U PD=4.68U rfmode=0
M$809 \$1210 \$85 \$1232 VSS|vss sg13_lv_nmos L=0.45U W=2U AS=0.68P AD=0.38P
+ PS=4.68U PD=2.38U rfmode=0
M$810 \$1259 \$53 \$1210 VSS|vss sg13_lv_nmos L=0.45U W=2U AS=0.38P AD=0.68P
+ PS=2.38U PD=4.68U rfmode=0
M$811 \$1239 \$51 \$1233 VSS|vss sg13_lv_nmos L=0.45U W=2U AS=0.68P AD=0.38P
+ PS=4.68U PD=2.38U rfmode=0
M$812 \$1255 \$83 \$1239 VSS|vss sg13_lv_nmos L=0.45U W=2U AS=0.38P AD=0.68P
+ PS=2.38U PD=4.68U rfmode=0
M$813 \$1235 \$35 \$1218 VSS|vss sg13_lv_nmos L=0.45U W=2U AS=0.68P AD=0.38P
+ PS=4.68U PD=2.38U rfmode=0
M$814 \$1245 \$67 \$1235 VSS|vss sg13_lv_nmos L=0.45U W=2U AS=0.38P AD=0.68P
+ PS=2.38U PD=4.68U rfmode=0
M$815 \$1200 \$69 \$1220 VSS|vss sg13_lv_nmos L=0.45U W=2U AS=0.68P AD=0.38P
+ PS=4.68U PD=2.38U rfmode=0
M$816 \$1257 \$37 \$1200 VSS|vss sg13_lv_nmos L=0.45U W=2U AS=0.38P AD=0.68P
+ PS=2.38U PD=4.68U rfmode=0
M$817 \$1207 \$85 \$1227 VSS|vss sg13_lv_nmos L=0.45U W=2U AS=0.68P AD=0.38P
+ PS=4.68U PD=2.38U rfmode=0
M$818 \$1258 \$53 \$1207 VSS|vss sg13_lv_nmos L=0.45U W=2U AS=0.38P AD=0.68P
+ PS=2.38U PD=4.68U rfmode=0
M$819 \$1238 \$51 \$1229 VSS|vss sg13_lv_nmos L=0.45U W=2U AS=0.68P AD=0.38P
+ PS=4.68U PD=2.38U rfmode=0
M$820 \$1253 \$83 \$1238 VSS|vss sg13_lv_nmos L=0.45U W=2U AS=0.38P AD=0.68P
+ PS=2.38U PD=4.68U rfmode=0
M$821 \$1256 \$67 \$1244 VSS|vss sg13_lv_nmos L=0.45U W=2U AS=0.68P AD=0.38P
+ PS=4.68U PD=2.38U rfmode=0
M$822 \$1264 \$35 \$1256 VSS|vss sg13_lv_nmos L=0.45U W=2U AS=0.38P AD=0.68P
+ PS=2.38U PD=4.68U rfmode=0
M$823 \$1219 \$37 \$1235 VSS|vss sg13_lv_nmos L=0.45U W=2U AS=0.68P AD=0.38P
+ PS=4.68U PD=2.38U rfmode=0
M$824 \$1277 \$69 \$1219 VSS|vss sg13_lv_nmos L=0.45U W=2U AS=0.38P AD=0.68P
+ PS=2.38U PD=4.68U rfmode=0
M$825 \$1257 \$67 \$1246 VSS|vss sg13_lv_nmos L=0.45U W=2U AS=0.68P AD=0.38P
+ PS=4.68U PD=2.38U rfmode=0
M$826 \$1266 \$35 \$1257 VSS|vss sg13_lv_nmos L=0.45U W=2U AS=0.38P AD=0.68P
+ PS=2.38U PD=4.68U rfmode=0
M$827 \$1223 \$37 \$1236 VSS|vss sg13_lv_nmos L=0.45U W=2U AS=0.68P AD=0.38P
+ PS=4.68U PD=2.38U rfmode=0
M$828 \$1279 \$69 \$1223 VSS|vss sg13_lv_nmos L=0.45U W=2U AS=0.38P AD=0.68P
+ PS=2.38U PD=4.68U rfmode=0
M$829 \$1258 \$83 \$1252 VSS|vss sg13_lv_nmos L=0.45U W=2U AS=0.68P AD=0.38P
+ PS=4.68U PD=2.38U rfmode=0
M$830 \$1272 \$51 \$1258 VSS|vss sg13_lv_nmos L=0.45U W=2U AS=0.38P AD=0.68P
+ PS=2.38U PD=4.68U rfmode=0
M$831 \$1230 \$53 \$1238 VSS|vss sg13_lv_nmos L=0.45U W=2U AS=0.68P AD=0.38P
+ PS=4.68U PD=2.38U rfmode=0
M$832 \$1281 \$85 \$1230 VSS|vss sg13_lv_nmos L=0.45U W=2U AS=0.38P AD=0.68P
+ PS=2.38U PD=4.68U rfmode=0
M$833 \$1259 \$83 \$1254 VSS|vss sg13_lv_nmos L=0.45U W=2U AS=0.68P AD=0.38P
+ PS=4.68U PD=2.38U rfmode=0
M$834 \$1274 \$51 \$1259 VSS|vss sg13_lv_nmos L=0.45U W=2U AS=0.38P AD=0.68P
+ PS=2.38U PD=4.68U rfmode=0
M$835 \$1234 \$53 \$1239 VSS|vss sg13_lv_nmos L=0.45U W=2U AS=0.68P AD=0.38P
+ PS=4.68U PD=2.38U rfmode=0
M$836 \$1283 \$85 \$1234 VSS|vss sg13_lv_nmos L=0.45U W=2U AS=0.38P AD=0.68P
+ PS=2.38U PD=4.68U rfmode=0
M$837 \$1276 \$75 \$1084 VSS|vss sg13_lv_nmos L=0.45U W=2U AS=0.68P AD=0.38P
+ PS=4.68U PD=2.38U rfmode=0
M$838 \$1289 \$43 \$1276 VSS|vss sg13_lv_nmos L=0.45U W=2U AS=0.38P AD=0.68P
+ PS=2.38U PD=4.68U rfmode=0
M$839 \$1277 \$35 \$1265 VSS|vss sg13_lv_nmos L=0.45U W=2U AS=0.68P AD=0.38P
+ PS=4.68U PD=2.38U rfmode=0
M$840 \$1290 \$67 \$1277 VSS|vss sg13_lv_nmos L=0.45U W=2U AS=0.38P AD=0.68P
+ PS=2.38U PD=4.68U rfmode=0
M$841 \$1278 \$75 \$1086 VSS|vss sg13_lv_nmos L=0.45U W=2U AS=0.68P AD=0.38P
+ PS=4.68U PD=2.38U rfmode=0
M$842 \$1292 \$43 \$1278 VSS|vss sg13_lv_nmos L=0.45U W=2U AS=0.38P AD=0.68P
+ PS=2.38U PD=4.68U rfmode=0
M$843 \$1279 \$35 \$1267 VSS|vss sg13_lv_nmos L=0.45U W=2U AS=0.68P AD=0.38P
+ PS=4.68U PD=2.38U rfmode=0
M$844 \$1293 \$67 \$1279 VSS|vss sg13_lv_nmos L=0.45U W=2U AS=0.38P AD=0.68P
+ PS=2.38U PD=4.68U rfmode=0
M$845 \$1282 \$91 \$1090 VSS|vss sg13_lv_nmos L=0.45U W=2U AS=0.68P AD=0.38P
+ PS=4.68U PD=2.38U rfmode=0
M$846 \$1302 \$59 \$1282 VSS|vss sg13_lv_nmos L=0.45U W=2U AS=0.38P AD=0.68P
+ PS=2.38U PD=4.68U rfmode=0
M$847 \$1283 \$51 \$1275 VSS|vss sg13_lv_nmos L=0.45U W=2U AS=0.68P AD=0.38P
+ PS=4.68U PD=2.38U rfmode=0
M$848 \$1303 \$83 \$1283 VSS|vss sg13_lv_nmos L=0.45U W=2U AS=0.38P AD=0.68P
+ PS=2.38U PD=4.68U rfmode=0
M$849 \$1280 \$91 \$1088 VSS|vss sg13_lv_nmos L=0.45U W=2U AS=0.68P AD=0.38P
+ PS=4.68U PD=2.38U rfmode=0
M$850 \$1299 \$59 \$1280 VSS|vss sg13_lv_nmos L=0.45U W=2U AS=0.38P AD=0.68P
+ PS=2.38U PD=4.68U rfmode=0
M$851 \$1281 \$51 \$1273 VSS|vss sg13_lv_nmos L=0.45U W=2U AS=0.68P AD=0.38P
+ PS=4.68U PD=2.38U rfmode=0
M$852 \$1300 \$83 \$1281 VSS|vss sg13_lv_nmos L=0.45U W=2U AS=0.38P AD=0.68P
+ PS=2.38U PD=4.68U rfmode=0
M$853 \$1304 \$67 \$1288 VSS|vss sg13_lv_nmos L=0.45U W=2U AS=0.68P AD=0.38P
+ PS=4.68U PD=2.38U rfmode=0
M$854 \$1316 \$35 \$1304 VSS|vss sg13_lv_nmos L=0.45U W=2U AS=0.38P AD=0.68P
+ PS=2.38U PD=4.68U rfmode=0
M$855 \$1305 \$43 \$1119 VSS|vss sg13_lv_nmos L=0.45U W=2U AS=0.68P AD=0.38P
+ PS=4.68U PD=2.38U rfmode=0
M$856 \$1318 \$75 \$1305 VSS|vss sg13_lv_nmos L=0.45U W=2U AS=0.38P AD=0.68P
+ PS=2.38U PD=4.68U rfmode=0
M$857 \$1306 \$67 \$1291 VSS|vss sg13_lv_nmos L=0.45U W=2U AS=0.68P AD=0.38P
+ PS=4.68U PD=2.38U rfmode=0
M$858 \$1319 \$35 \$1306 VSS|vss sg13_lv_nmos L=0.45U W=2U AS=0.38P AD=0.68P
+ PS=2.38U PD=4.68U rfmode=0
M$859 \$1307 \$43 \$1124 VSS|vss sg13_lv_nmos L=0.45U W=2U AS=0.68P AD=0.38P
+ PS=4.68U PD=2.38U rfmode=0
M$860 \$1321 \$75 \$1307 VSS|vss sg13_lv_nmos L=0.45U W=2U AS=0.38P AD=0.68P
+ PS=2.38U PD=4.68U rfmode=0
M$861 \$1308 \$83 \$1298 VSS|vss sg13_lv_nmos L=0.45U W=2U AS=0.68P AD=0.38P
+ PS=4.68U PD=2.38U rfmode=0
M$862 \$1326 \$51 \$1308 VSS|vss sg13_lv_nmos L=0.45U W=2U AS=0.38P AD=0.68P
+ PS=2.38U PD=4.68U rfmode=0
M$863 \$1309 \$59 \$1133 VSS|vss sg13_lv_nmos L=0.45U W=2U AS=0.68P AD=0.38P
+ PS=4.68U PD=2.38U rfmode=0
M$864 \$1328 \$91 \$1309 VSS|vss sg13_lv_nmos L=0.45U W=2U AS=0.38P AD=0.68P
+ PS=2.38U PD=4.68U rfmode=0
M$865 \$1310 \$83 \$1301 VSS|vss sg13_lv_nmos L=0.45U W=2U AS=0.68P AD=0.38P
+ PS=4.68U PD=2.38U rfmode=0
M$866 \$1329 \$51 \$1310 VSS|vss sg13_lv_nmos L=0.45U W=2U AS=0.38P AD=0.68P
+ PS=2.38U PD=4.68U rfmode=0
M$867 \$1311 \$59 \$1138 VSS|vss sg13_lv_nmos L=0.45U W=2U AS=0.68P AD=0.38P
+ PS=4.68U PD=2.38U rfmode=0
M$868 \$1331 \$91 \$1311 VSS|vss sg13_lv_nmos L=0.45U W=2U AS=0.38P AD=0.68P
+ PS=2.38U PD=4.68U rfmode=0
M$869 \$1332 \$69 \$1304 VSS|vss sg13_lv_nmos L=0.45U W=2U AS=0.68P AD=0.38P
+ PS=4.68U PD=2.38U rfmode=0
M$870 \$1356 \$37 \$1332 VSS|vss sg13_lv_nmos L=0.45U W=2U AS=0.38P AD=0.68P
+ PS=2.38U PD=4.68U rfmode=0
M$871 \$1334 \$69 \$1306 VSS|vss sg13_lv_nmos L=0.45U W=2U AS=0.68P AD=0.38P
+ PS=4.68U PD=2.38U rfmode=0
M$872 \$1358 \$37 \$1334 VSS|vss sg13_lv_nmos L=0.45U W=2U AS=0.38P AD=0.68P
+ PS=2.38U PD=4.68U rfmode=0
M$873 \$1335 \$35 \$1320 VSS|vss sg13_lv_nmos L=0.45U W=2U AS=0.68P AD=0.38P
+ PS=4.68U PD=2.38U rfmode=0
M$874 \$1347 \$67 \$1335 VSS|vss sg13_lv_nmos L=0.45U W=2U AS=0.38P AD=0.68P
+ PS=2.38U PD=4.68U rfmode=0
M$875 \$1336 \$85 \$1308 VSS|vss sg13_lv_nmos L=0.45U W=2U AS=0.68P AD=0.38P
+ PS=4.68U PD=2.38U rfmode=0
M$876 \$1360 \$53 \$1336 VSS|vss sg13_lv_nmos L=0.45U W=2U AS=0.38P AD=0.68P
+ PS=2.38U PD=4.68U rfmode=0
M$877 \$1337 \$51 \$1327 VSS|vss sg13_lv_nmos L=0.45U W=2U AS=0.68P AD=0.38P
+ PS=4.68U PD=2.38U rfmode=0
M$878 \$1353 \$83 \$1337 VSS|vss sg13_lv_nmos L=0.45U W=2U AS=0.38P AD=0.68P
+ PS=2.38U PD=4.68U rfmode=0
M$879 \$1338 \$85 \$1310 VSS|vss sg13_lv_nmos L=0.45U W=2U AS=0.68P AD=0.38P
+ PS=4.68U PD=2.38U rfmode=0
M$880 \$1362 \$53 \$1338 VSS|vss sg13_lv_nmos L=0.45U W=2U AS=0.38P AD=0.68P
+ PS=2.38U PD=4.68U rfmode=0
M$881 \$1339 \$51 \$1330 VSS|vss sg13_lv_nmos L=0.45U W=2U AS=0.68P AD=0.38P
+ PS=4.68U PD=2.38U rfmode=0
M$882 \$1355 \$83 \$1339 VSS|vss sg13_lv_nmos L=0.45U W=2U AS=0.38P AD=0.68P
+ PS=2.38U PD=4.68U rfmode=0
M$883 \$1333 \$35 \$1317 VSS|vss sg13_lv_nmos L=0.45U W=2U AS=0.68P AD=0.38P
+ PS=4.68U PD=2.38U rfmode=0
M$884 \$1345 \$67 \$1333 VSS|vss sg13_lv_nmos L=0.45U W=2U AS=0.38P AD=0.68P
+ PS=2.38U PD=4.68U rfmode=0
M$885 \$1356 \$67 \$1344 VSS|vss sg13_lv_nmos L=0.45U W=2U AS=0.68P AD=0.38P
+ PS=4.68U PD=2.38U rfmode=0
M$886 \$1368 \$35 \$1356 VSS|vss sg13_lv_nmos L=0.45U W=2U AS=0.38P AD=0.68P
+ PS=2.38U PD=4.68U rfmode=0
M$887 \$1357 \$37 \$1333 VSS|vss sg13_lv_nmos L=0.45U W=2U AS=0.68P AD=0.38P
+ PS=4.68U PD=2.38U rfmode=0
M$888 \$1381 \$69 \$1357 VSS|vss sg13_lv_nmos L=0.45U W=2U AS=0.38P AD=0.68P
+ PS=2.38U PD=4.68U rfmode=0
M$889 \$1358 \$67 \$1346 VSS|vss sg13_lv_nmos L=0.45U W=2U AS=0.68P AD=0.38P
+ PS=4.68U PD=2.38U rfmode=0
M$890 \$1370 \$35 \$1358 VSS|vss sg13_lv_nmos L=0.45U W=2U AS=0.38P AD=0.68P
+ PS=2.38U PD=4.68U rfmode=0
M$891 \$1359 \$37 \$1335 VSS|vss sg13_lv_nmos L=0.45U W=2U AS=0.68P AD=0.38P
+ PS=4.68U PD=2.38U rfmode=0
M$892 \$1383 \$69 \$1359 VSS|vss sg13_lv_nmos L=0.45U W=2U AS=0.38P AD=0.68P
+ PS=2.38U PD=4.68U rfmode=0
M$893 \$1360 \$83 \$1352 VSS|vss sg13_lv_nmos L=0.45U W=2U AS=0.68P AD=0.38P
+ PS=4.68U PD=2.38U rfmode=0
M$894 \$1376 \$51 \$1360 VSS|vss sg13_lv_nmos L=0.45U W=2U AS=0.38P AD=0.68P
+ PS=2.38U PD=4.68U rfmode=0
M$895 \$1361 \$53 \$1337 VSS|vss sg13_lv_nmos L=0.45U W=2U AS=0.68P AD=0.38P
+ PS=4.68U PD=2.38U rfmode=0
M$896 \$1385 \$85 \$1361 VSS|vss sg13_lv_nmos L=0.45U W=2U AS=0.38P AD=0.68P
+ PS=2.38U PD=4.68U rfmode=0
M$897 \$1362 \$83 \$1354 VSS|vss sg13_lv_nmos L=0.45U W=2U AS=0.68P AD=0.38P
+ PS=4.68U PD=2.38U rfmode=0
M$898 \$1378 \$51 \$1362 VSS|vss sg13_lv_nmos L=0.45U W=2U AS=0.38P AD=0.68P
+ PS=2.38U PD=4.68U rfmode=0
M$899 \$1363 \$53 \$1339 VSS|vss sg13_lv_nmos L=0.45U W=2U AS=0.68P AD=0.38P
+ PS=4.68U PD=2.38U rfmode=0
M$900 \$1387 \$85 \$1363 VSS|vss sg13_lv_nmos L=0.45U W=2U AS=0.38P AD=0.68P
+ PS=2.38U PD=4.68U rfmode=0
M$901 \$1380 \$71 \$1332 VSS|vss sg13_lv_nmos L=0.45U W=2U AS=0.68P AD=0.38P
+ PS=4.68U PD=2.38U rfmode=0
M$902 \$1393 \$39 \$1380 VSS|vss sg13_lv_nmos L=0.45U W=2U AS=0.38P AD=0.68P
+ PS=2.38U PD=4.68U rfmode=0
M$903 \$1383 \$35 \$1371 VSS|vss sg13_lv_nmos L=0.45U W=2U AS=0.68P AD=0.38P
+ PS=4.68U PD=2.38U rfmode=0
M$904 \$1397 \$67 \$1383 VSS|vss sg13_lv_nmos L=0.45U W=2U AS=0.38P AD=0.68P
+ PS=2.38U PD=4.68U rfmode=0
M$905 \$1384 \$87 \$1336 VSS|vss sg13_lv_nmos L=0.45U W=2U AS=0.68P AD=0.38P
+ PS=4.68U PD=2.38U rfmode=0
M$906 \$1403 \$55 \$1384 VSS|vss sg13_lv_nmos L=0.45U W=2U AS=0.38P AD=0.68P
+ PS=2.38U PD=4.68U rfmode=0
M$907 \$1385 \$51 \$1377 VSS|vss sg13_lv_nmos L=0.45U W=2U AS=0.68P AD=0.38P
+ PS=4.68U PD=2.38U rfmode=0
M$908 \$1404 \$83 \$1385 VSS|vss sg13_lv_nmos L=0.45U W=2U AS=0.38P AD=0.68P
+ PS=2.38U PD=4.68U rfmode=0
M$909 \$1386 \$87 \$1338 VSS|vss sg13_lv_nmos L=0.45U W=2U AS=0.68P AD=0.38P
+ PS=4.68U PD=2.38U rfmode=0
M$910 \$1406 \$55 \$1386 VSS|vss sg13_lv_nmos L=0.45U W=2U AS=0.38P AD=0.68P
+ PS=2.38U PD=4.68U rfmode=0
M$911 \$1387 \$51 \$1379 VSS|vss sg13_lv_nmos L=0.45U W=2U AS=0.68P AD=0.38P
+ PS=4.68U PD=2.38U rfmode=0
M$912 \$1407 \$83 \$1387 VSS|vss sg13_lv_nmos L=0.45U W=2U AS=0.38P AD=0.68P
+ PS=2.38U PD=4.68U rfmode=0
M$913 \$1381 \$35 \$1369 VSS|vss sg13_lv_nmos L=0.45U W=2U AS=0.68P AD=0.38P
+ PS=4.68U PD=2.38U rfmode=0
M$914 \$1394 \$67 \$1381 VSS|vss sg13_lv_nmos L=0.45U W=2U AS=0.38P AD=0.68P
+ PS=2.38U PD=4.68U rfmode=0
M$915 \$1382 \$71 \$1334 VSS|vss sg13_lv_nmos L=0.45U W=2U AS=0.68P AD=0.38P
+ PS=4.68U PD=2.38U rfmode=0
M$916 \$1396 \$39 \$1382 VSS|vss sg13_lv_nmos L=0.45U W=2U AS=0.38P AD=0.68P
+ PS=2.38U PD=4.68U rfmode=0
M$917 \$1408 \$67 \$1392 VSS|vss sg13_lv_nmos L=0.45U W=2U AS=0.68P AD=0.38P
+ PS=4.68U PD=2.38U rfmode=0
M$918 \$1420 \$35 \$1408 VSS|vss sg13_lv_nmos L=0.45U W=2U AS=0.38P AD=0.68P
+ PS=2.38U PD=4.68U rfmode=0
M$919 \$1409 \$39 \$1357 VSS|vss sg13_lv_nmos L=0.45U W=2U AS=0.68P AD=0.38P
+ PS=4.68U PD=2.38U rfmode=0
M$920 \$1422 \$71 \$1409 VSS|vss sg13_lv_nmos L=0.45U W=2U AS=0.38P AD=0.68P
+ PS=2.38U PD=4.68U rfmode=0
M$921 \$1410 \$67 \$1395 VSS|vss sg13_lv_nmos L=0.45U W=2U AS=0.68P AD=0.38P
+ PS=4.68U PD=2.38U rfmode=0
M$922 \$1423 \$35 \$1410 VSS|vss sg13_lv_nmos L=0.45U W=2U AS=0.38P AD=0.68P
+ PS=2.38U PD=4.68U rfmode=0
M$923 \$1411 \$39 \$1359 VSS|vss sg13_lv_nmos L=0.45U W=2U AS=0.68P AD=0.38P
+ PS=4.68U PD=2.38U rfmode=0
M$924 \$1425 \$71 \$1411 VSS|vss sg13_lv_nmos L=0.45U W=2U AS=0.38P AD=0.68P
+ PS=2.38U PD=4.68U rfmode=0
M$925 \$1412 \$83 \$1402 VSS|vss sg13_lv_nmos L=0.45U W=2U AS=0.68P AD=0.38P
+ PS=4.68U PD=2.38U rfmode=0
M$926 \$1430 \$51 \$1412 VSS|vss sg13_lv_nmos L=0.45U W=2U AS=0.38P AD=0.68P
+ PS=2.38U PD=4.68U rfmode=0
M$927 \$1413 \$55 \$1361 VSS|vss sg13_lv_nmos L=0.45U W=2U AS=0.68P AD=0.38P
+ PS=4.68U PD=2.38U rfmode=0
M$928 \$1432 \$87 \$1413 VSS|vss sg13_lv_nmos L=0.45U W=2U AS=0.38P AD=0.68P
+ PS=2.38U PD=4.68U rfmode=0
M$929 \$1414 \$83 \$1405 VSS|vss sg13_lv_nmos L=0.45U W=2U AS=0.68P AD=0.38P
+ PS=4.68U PD=2.38U rfmode=0
M$930 \$1433 \$51 \$1414 VSS|vss sg13_lv_nmos L=0.45U W=2U AS=0.38P AD=0.68P
+ PS=2.38U PD=4.68U rfmode=0
M$931 \$1415 \$55 \$1363 VSS|vss sg13_lv_nmos L=0.45U W=2U AS=0.68P AD=0.38P
+ PS=4.68U PD=2.38U rfmode=0
M$932 \$1435 \$87 \$1415 VSS|vss sg13_lv_nmos L=0.45U W=2U AS=0.38P AD=0.68P
+ PS=2.38U PD=4.68U rfmode=0
M$933 \$1393 \$69 \$1408 VSS|vss sg13_lv_nmos L=0.45U W=2U AS=0.68P AD=0.38P
+ PS=4.68U PD=2.38U rfmode=0
M$934 \$1456 \$37 \$1393 VSS|vss sg13_lv_nmos L=0.45U W=2U AS=0.38P AD=0.68P
+ PS=2.38U PD=4.68U rfmode=0
M$935 \$1396 \$69 \$1410 VSS|vss sg13_lv_nmos L=0.45U W=2U AS=0.68P AD=0.38P
+ PS=4.68U PD=2.38U rfmode=0
M$936 \$1457 \$37 \$1396 VSS|vss sg13_lv_nmos L=0.45U W=2U AS=0.38P AD=0.68P
+ PS=2.38U PD=4.68U rfmode=0
M$937 \$1437 \$35 \$1424 VSS|vss sg13_lv_nmos L=0.45U W=2U AS=0.68P AD=0.38P
+ PS=4.68U PD=2.38U rfmode=0
M$938 \$1446 \$67 \$1437 VSS|vss sg13_lv_nmos L=0.45U W=2U AS=0.38P AD=0.68P
+ PS=2.38U PD=4.68U rfmode=0
M$939 \$1403 \$85 \$1412 VSS|vss sg13_lv_nmos L=0.45U W=2U AS=0.68P AD=0.38P
+ PS=4.68U PD=2.38U rfmode=0
M$940 \$1458 \$53 \$1403 VSS|vss sg13_lv_nmos L=0.45U W=2U AS=0.38P AD=0.68P
+ PS=2.38U PD=4.68U rfmode=0
M$941 \$1438 \$51 \$1431 VSS|vss sg13_lv_nmos L=0.45U W=2U AS=0.68P AD=0.38P
+ PS=4.68U PD=2.38U rfmode=0
M$942 \$1452 \$83 \$1438 VSS|vss sg13_lv_nmos L=0.45U W=2U AS=0.38P AD=0.68P
+ PS=2.38U PD=4.68U rfmode=0
M$943 \$1406 \$85 \$1414 VSS|vss sg13_lv_nmos L=0.45U W=2U AS=0.68P AD=0.38P
+ PS=4.68U PD=2.38U rfmode=0
M$944 \$1459 \$53 \$1406 VSS|vss sg13_lv_nmos L=0.45U W=2U AS=0.38P AD=0.68P
+ PS=2.38U PD=4.68U rfmode=0
M$945 \$1439 \$51 \$1434 VSS|vss sg13_lv_nmos L=0.45U W=2U AS=0.68P AD=0.38P
+ PS=4.68U PD=2.38U rfmode=0
M$946 \$1454 \$83 \$1439 VSS|vss sg13_lv_nmos L=0.45U W=2U AS=0.38P AD=0.68P
+ PS=2.38U PD=4.68U rfmode=0
M$947 \$1436 \$35 \$1421 VSS|vss sg13_lv_nmos L=0.45U W=2U AS=0.68P AD=0.38P
+ PS=4.68U PD=2.38U rfmode=0
M$948 \$1444 \$67 \$1436 VSS|vss sg13_lv_nmos L=0.45U W=2U AS=0.38P AD=0.68P
+ PS=2.38U PD=4.68U rfmode=0
M$949 \$1456 \$67 \$1443 VSS|vss sg13_lv_nmos L=0.45U W=2U AS=0.68P AD=0.38P
+ PS=4.68U PD=2.38U rfmode=0
M$950 \$1464 \$35 \$1456 VSS|vss sg13_lv_nmos L=0.45U W=2U AS=0.38P AD=0.68P
+ PS=2.38U PD=4.68U rfmode=0
M$951 \$1422 \$37 \$1436 VSS|vss sg13_lv_nmos L=0.45U W=2U AS=0.68P AD=0.38P
+ PS=4.68U PD=2.38U rfmode=0
M$952 \$1482 \$69 \$1422 VSS|vss sg13_lv_nmos L=0.45U W=2U AS=0.38P AD=0.68P
+ PS=2.38U PD=4.68U rfmode=0
M$953 \$1457 \$67 \$1445 VSS|vss sg13_lv_nmos L=0.45U W=2U AS=0.68P AD=0.38P
+ PS=4.68U PD=2.38U rfmode=0
M$954 \$1466 \$35 \$1457 VSS|vss sg13_lv_nmos L=0.45U W=2U AS=0.38P AD=0.68P
+ PS=2.38U PD=4.68U rfmode=0
M$955 \$1425 \$37 \$1437 VSS|vss sg13_lv_nmos L=0.45U W=2U AS=0.68P AD=0.38P
+ PS=4.68U PD=2.38U rfmode=0
M$956 \$1486 \$69 \$1425 VSS|vss sg13_lv_nmos L=0.45U W=2U AS=0.38P AD=0.68P
+ PS=2.38U PD=4.68U rfmode=0
M$957 \$1458 \$83 \$1451 VSS|vss sg13_lv_nmos L=0.45U W=2U AS=0.68P AD=0.38P
+ PS=4.68U PD=2.38U rfmode=0
M$958 \$1472 \$51 \$1458 VSS|vss sg13_lv_nmos L=0.45U W=2U AS=0.38P AD=0.68P
+ PS=2.38U PD=4.68U rfmode=0
M$959 \$1432 \$53 \$1438 VSS|vss sg13_lv_nmos L=0.45U W=2U AS=0.68P AD=0.38P
+ PS=4.68U PD=2.38U rfmode=0
M$960 \$1495 \$85 \$1432 VSS|vss sg13_lv_nmos L=0.45U W=2U AS=0.38P AD=0.68P
+ PS=2.38U PD=4.68U rfmode=0
M$961 \$1459 \$83 \$1453 VSS|vss sg13_lv_nmos L=0.45U W=2U AS=0.68P AD=0.38P
+ PS=4.68U PD=2.38U rfmode=0
M$962 \$1474 \$51 \$1459 VSS|vss sg13_lv_nmos L=0.45U W=2U AS=0.38P AD=0.68P
+ PS=2.38U PD=4.68U rfmode=0
M$963 \$1435 \$53 \$1439 VSS|vss sg13_lv_nmos L=0.45U W=2U AS=0.68P AD=0.38P
+ PS=4.68U PD=2.38U rfmode=0
M$964 \$1498 \$85 \$1435 VSS|vss sg13_lv_nmos L=0.45U W=2U AS=0.38P AD=0.68P
+ PS=2.38U PD=4.68U rfmode=0
M$965 \$1289 \$73 \$1380 VSS|vss sg13_lv_nmos L=0.45U W=2U AS=0.68P AD=0.38P
+ PS=4.68U PD=2.38U rfmode=0
M$966 \$1481 \$41 \$1289 VSS|vss sg13_lv_nmos L=0.45U W=2U AS=0.38P AD=0.68P
+ PS=2.38U PD=4.68U rfmode=0
M$967 \$1482 \$35 \$1465 VSS|vss sg13_lv_nmos L=0.45U W=2U AS=0.68P AD=0.38P
+ PS=4.68U PD=2.38U rfmode=0
M$968 \$1483 \$67 \$1482 VSS|vss sg13_lv_nmos L=0.45U W=2U AS=0.38P AD=0.68P
+ PS=2.38U PD=4.68U rfmode=0
M$969 \$1486 \$35 \$1467 VSS|vss sg13_lv_nmos L=0.45U W=2U AS=0.68P AD=0.38P
+ PS=4.68U PD=2.38U rfmode=0
M$970 \$1487 \$67 \$1486 VSS|vss sg13_lv_nmos L=0.45U W=2U AS=0.38P AD=0.68P
+ PS=2.38U PD=4.68U rfmode=0
M$971 \$1299 \$89 \$1384 VSS|vss sg13_lv_nmos L=0.45U W=2U AS=0.68P AD=0.38P
+ PS=4.68U PD=2.38U rfmode=0
M$972 \$1493 \$57 \$1299 VSS|vss sg13_lv_nmos L=0.45U W=2U AS=0.38P AD=0.68P
+ PS=2.38U PD=4.68U rfmode=0
M$973 \$1302 \$89 \$1386 VSS|vss sg13_lv_nmos L=0.45U W=2U AS=0.68P AD=0.38P
+ PS=4.68U PD=2.38U rfmode=0
M$974 \$1497 \$57 \$1302 VSS|vss sg13_lv_nmos L=0.45U W=2U AS=0.38P AD=0.68P
+ PS=2.38U PD=4.68U rfmode=0
M$975 \$1498 \$51 \$1475 VSS|vss sg13_lv_nmos L=0.45U W=2U AS=0.68P AD=0.38P
+ PS=4.68U PD=2.38U rfmode=0
M$976 \$1499 \$83 \$1498 VSS|vss sg13_lv_nmos L=0.45U W=2U AS=0.38P AD=0.68P
+ PS=2.38U PD=4.68U rfmode=0
M$977 \$1292 \$73 \$1382 VSS|vss sg13_lv_nmos L=0.45U W=2U AS=0.68P AD=0.38P
+ PS=4.68U PD=2.38U rfmode=0
M$978 \$1485 \$41 \$1292 VSS|vss sg13_lv_nmos L=0.45U W=2U AS=0.38P AD=0.68P
+ PS=2.38U PD=4.68U rfmode=0
M$979 \$1495 \$51 \$1473 VSS|vss sg13_lv_nmos L=0.45U W=2U AS=0.68P AD=0.38P
+ PS=4.68U PD=2.38U rfmode=0
M$980 \$1494 \$83 \$1495 VSS|vss sg13_lv_nmos L=0.45U W=2U AS=0.38P AD=0.68P
+ PS=2.38U PD=4.68U rfmode=0
M$981 \$1500 \$67 \$1480 VSS|vss sg13_lv_nmos L=0.45U W=2U AS=0.68P AD=0.38P
+ PS=4.68U PD=2.38U rfmode=0
M$982 \$1508 \$35 \$1500 VSS|vss sg13_lv_nmos L=0.45U W=2U AS=0.38P AD=0.68P
+ PS=2.38U PD=4.68U rfmode=0
M$983 \$1318 \$41 \$1409 VSS|vss sg13_lv_nmos L=0.45U W=2U AS=0.68P AD=0.38P
+ PS=4.68U PD=2.38U rfmode=0
M$984 \$1510 \$73 \$1318 VSS|vss sg13_lv_nmos L=0.45U W=2U AS=0.38P AD=0.68P
+ PS=2.38U PD=4.68U rfmode=0
M$985 \$1501 \$67 \$1484 VSS|vss sg13_lv_nmos L=0.45U W=2U AS=0.68P AD=0.38P
+ PS=4.68U PD=2.38U rfmode=0
M$986 \$1511 \$35 \$1501 VSS|vss sg13_lv_nmos L=0.45U W=2U AS=0.38P AD=0.68P
+ PS=2.38U PD=4.68U rfmode=0
M$987 \$1321 \$41 \$1411 VSS|vss sg13_lv_nmos L=0.45U W=2U AS=0.68P AD=0.38P
+ PS=4.68U PD=2.38U rfmode=0
M$988 \$1513 \$73 \$1321 VSS|vss sg13_lv_nmos L=0.45U W=2U AS=0.38P AD=0.68P
+ PS=2.38U PD=4.68U rfmode=0
M$989 \$1502 \$83 \$1492 VSS|vss sg13_lv_nmos L=0.45U W=2U AS=0.68P AD=0.38P
+ PS=4.68U PD=2.38U rfmode=0
M$990 \$1518 \$51 \$1502 VSS|vss sg13_lv_nmos L=0.45U W=2U AS=0.38P AD=0.68P
+ PS=2.38U PD=4.68U rfmode=0
M$991 \$1328 \$57 \$1413 VSS|vss sg13_lv_nmos L=0.45U W=2U AS=0.68P AD=0.38P
+ PS=4.68U PD=2.38U rfmode=0
M$992 \$1520 \$89 \$1328 VSS|vss sg13_lv_nmos L=0.45U W=2U AS=0.38P AD=0.68P
+ PS=2.38U PD=4.68U rfmode=0
M$993 \$1503 \$83 \$1496 VSS|vss sg13_lv_nmos L=0.45U W=2U AS=0.68P AD=0.38P
+ PS=4.68U PD=2.38U rfmode=0
M$994 \$1521 \$51 \$1503 VSS|vss sg13_lv_nmos L=0.45U W=2U AS=0.38P AD=0.68P
+ PS=2.38U PD=4.68U rfmode=0
M$995 \$1331 \$57 \$1415 VSS|vss sg13_lv_nmos L=0.45U W=2U AS=0.68P AD=0.38P
+ PS=4.68U PD=2.38U rfmode=0
M$996 \$1523 \$89 \$1331 VSS|vss sg13_lv_nmos L=0.45U W=2U AS=0.38P AD=0.68P
+ PS=2.38U PD=4.68U rfmode=0
M$997 \$1524 \$69 \$1500 VSS|vss sg13_lv_nmos L=0.45U W=2U AS=0.68P AD=0.38P
+ PS=4.68U PD=2.38U rfmode=0
M$998 \$1548 \$37 \$1524 VSS|vss sg13_lv_nmos L=0.45U W=2U AS=0.38P AD=0.68P
+ PS=2.38U PD=4.68U rfmode=0
M$999 \$1525 \$35 \$1509 VSS|vss sg13_lv_nmos L=0.45U W=2U AS=0.68P AD=0.38P
+ PS=4.68U PD=2.38U rfmode=0
M$1000 \$1537 \$67 \$1525 VSS|vss sg13_lv_nmos L=0.45U W=2U AS=0.38P AD=0.68P
+ PS=2.38U PD=4.68U rfmode=0
M$1001 \$1527 \$35 \$1512 VSS|vss sg13_lv_nmos L=0.45U W=2U AS=0.68P AD=0.38P
+ PS=4.68U PD=2.38U rfmode=0
M$1002 \$1539 \$67 \$1527 VSS|vss sg13_lv_nmos L=0.45U W=2U AS=0.38P AD=0.68P
+ PS=2.38U PD=4.68U rfmode=0
M$1003 \$1528 \$85 \$1502 VSS|vss sg13_lv_nmos L=0.45U W=2U AS=0.68P AD=0.38P
+ PS=4.68U PD=2.38U rfmode=0
M$1004 \$1552 \$53 \$1528 VSS|vss sg13_lv_nmos L=0.45U W=2U AS=0.38P AD=0.68P
+ PS=2.38U PD=4.68U rfmode=0
M$1005 \$1529 \$51 \$1519 VSS|vss sg13_lv_nmos L=0.45U W=2U AS=0.68P AD=0.38P
+ PS=4.68U PD=2.38U rfmode=0
M$1006 \$1545 \$83 \$1529 VSS|vss sg13_lv_nmos L=0.45U W=2U AS=0.38P AD=0.68P
+ PS=2.38U PD=4.68U rfmode=0
M$1007 \$1530 \$85 \$1503 VSS|vss sg13_lv_nmos L=0.45U W=2U AS=0.68P AD=0.38P
+ PS=4.68U PD=2.38U rfmode=0
M$1008 \$1554 \$53 \$1530 VSS|vss sg13_lv_nmos L=0.45U W=2U AS=0.38P AD=0.68P
+ PS=2.38U PD=4.68U rfmode=0
M$1009 \$1531 \$51 \$1522 VSS|vss sg13_lv_nmos L=0.45U W=2U AS=0.68P AD=0.38P
+ PS=4.68U PD=2.38U rfmode=0
M$1010 \$1547 \$83 \$1531 VSS|vss sg13_lv_nmos L=0.45U W=2U AS=0.38P AD=0.68P
+ PS=2.38U PD=4.68U rfmode=0
M$1011 \$1526 \$69 \$1501 VSS|vss sg13_lv_nmos L=0.45U W=2U AS=0.68P AD=0.38P
+ PS=4.68U PD=2.38U rfmode=0
M$1012 \$1550 \$37 \$1526 VSS|vss sg13_lv_nmos L=0.45U W=2U AS=0.38P AD=0.68P
+ PS=2.38U PD=4.68U rfmode=0
M$1013 \$1548 \$67 \$1536 VSS|vss sg13_lv_nmos L=0.45U W=2U AS=0.68P AD=0.38P
+ PS=4.68U PD=2.38U rfmode=0
M$1014 \$1560 \$35 \$1548 VSS|vss sg13_lv_nmos L=0.45U W=2U AS=0.38P AD=0.68P
+ PS=2.38U PD=4.68U rfmode=0
M$1015 \$1549 \$37 \$1525 VSS|vss sg13_lv_nmos L=0.45U W=2U AS=0.68P AD=0.38P
+ PS=4.68U PD=2.38U rfmode=0
M$1016 \$1572 \$69 \$1549 VSS|vss sg13_lv_nmos L=0.45U W=2U AS=0.38P AD=0.68P
+ PS=2.38U PD=4.68U rfmode=0
M$1017 \$1550 \$67 \$1538 VSS|vss sg13_lv_nmos L=0.45U W=2U AS=0.68P AD=0.38P
+ PS=4.68U PD=2.38U rfmode=0
M$1018 \$1562 \$35 \$1550 VSS|vss sg13_lv_nmos L=0.45U W=2U AS=0.38P AD=0.68P
+ PS=2.38U PD=4.68U rfmode=0
M$1019 \$1551 \$37 \$1527 VSS|vss sg13_lv_nmos L=0.45U W=2U AS=0.68P AD=0.38P
+ PS=4.68U PD=2.38U rfmode=0
M$1020 \$1573 \$69 \$1551 VSS|vss sg13_lv_nmos L=0.45U W=2U AS=0.38P AD=0.68P
+ PS=2.38U PD=4.68U rfmode=0
M$1021 \$1552 \$83 \$1544 VSS|vss sg13_lv_nmos L=0.45U W=2U AS=0.68P AD=0.38P
+ PS=4.68U PD=2.38U rfmode=0
M$1022 \$1568 \$51 \$1552 VSS|vss sg13_lv_nmos L=0.45U W=2U AS=0.38P AD=0.68P
+ PS=2.38U PD=4.68U rfmode=0
M$1023 \$1553 \$53 \$1529 VSS|vss sg13_lv_nmos L=0.45U W=2U AS=0.68P AD=0.38P
+ PS=4.68U PD=2.38U rfmode=0
M$1024 \$1574 \$85 \$1553 VSS|vss sg13_lv_nmos L=0.45U W=2U AS=0.38P AD=0.68P
+ PS=2.38U PD=4.68U rfmode=0
M$1025 \$1554 \$83 \$1546 VSS|vss sg13_lv_nmos L=0.45U W=2U AS=0.68P AD=0.38P
+ PS=4.68U PD=2.38U rfmode=0
M$1026 \$1570 \$51 \$1554 VSS|vss sg13_lv_nmos L=0.45U W=2U AS=0.38P AD=0.68P
+ PS=2.38U PD=4.68U rfmode=0
M$1027 \$1555 \$53 \$1531 VSS|vss sg13_lv_nmos L=0.45U W=2U AS=0.68P AD=0.38P
+ PS=4.68U PD=2.38U rfmode=0
M$1028 \$1575 \$85 \$1555 VSS|vss sg13_lv_nmos L=0.45U W=2U AS=0.38P AD=0.68P
+ PS=2.38U PD=4.68U rfmode=0
M$1029 \$1481 \$71 \$1524 VSS|vss sg13_lv_nmos L=0.45U W=2U AS=0.68P AD=0.38P
+ PS=4.68U PD=2.38U rfmode=0
M$1030 \$1581 \$39 \$1481 VSS|vss sg13_lv_nmos L=0.45U W=2U AS=0.38P AD=0.68P
+ PS=2.38U PD=4.68U rfmode=0
M$1031 \$1485 \$71 \$1526 VSS|vss sg13_lv_nmos L=0.45U W=2U AS=0.68P AD=0.38P
+ PS=4.68U PD=2.38U rfmode=0
M$1032 \$1584 \$39 \$1485 VSS|vss sg13_lv_nmos L=0.45U W=2U AS=0.38P AD=0.68P
+ PS=2.38U PD=4.68U rfmode=0
M$1033 \$1573 \$35 \$1563 VSS|vss sg13_lv_nmos L=0.45U W=2U AS=0.68P AD=0.38P
+ PS=4.68U PD=2.38U rfmode=0
M$1034 \$1585 \$67 \$1573 VSS|vss sg13_lv_nmos L=0.45U W=2U AS=0.38P AD=0.68P
+ PS=2.38U PD=4.68U rfmode=0
M$1035 \$1493 \$87 \$1528 VSS|vss sg13_lv_nmos L=0.45U W=2U AS=0.68P AD=0.38P
+ PS=4.68U PD=2.38U rfmode=0
M$1036 \$1591 \$55 \$1493 VSS|vss sg13_lv_nmos L=0.45U W=2U AS=0.38P AD=0.68P
+ PS=2.38U PD=4.68U rfmode=0
M$1037 \$1574 \$51 \$1569 VSS|vss sg13_lv_nmos L=0.45U W=2U AS=0.68P AD=0.38P
+ PS=4.68U PD=2.38U rfmode=0
M$1038 \$1592 \$83 \$1574 VSS|vss sg13_lv_nmos L=0.45U W=2U AS=0.38P AD=0.68P
+ PS=2.38U PD=4.68U rfmode=0
M$1039 \$1497 \$87 \$1530 VSS|vss sg13_lv_nmos L=0.45U W=2U AS=0.68P AD=0.38P
+ PS=4.68U PD=2.38U rfmode=0
M$1040 \$1594 \$55 \$1497 VSS|vss sg13_lv_nmos L=0.45U W=2U AS=0.38P AD=0.68P
+ PS=2.38U PD=4.68U rfmode=0
M$1041 \$1575 \$51 \$1571 VSS|vss sg13_lv_nmos L=0.45U W=2U AS=0.68P AD=0.38P
+ PS=4.68U PD=2.38U rfmode=0
M$1042 \$1595 \$83 \$1575 VSS|vss sg13_lv_nmos L=0.45U W=2U AS=0.38P AD=0.68P
+ PS=2.38U PD=4.68U rfmode=0
M$1043 \$1572 \$35 \$1561 VSS|vss sg13_lv_nmos L=0.45U W=2U AS=0.68P AD=0.38P
+ PS=4.68U PD=2.38U rfmode=0
M$1044 \$1582 \$67 \$1572 VSS|vss sg13_lv_nmos L=0.45U W=2U AS=0.38P AD=0.68P
+ PS=2.38U PD=4.68U rfmode=0
M$1045 \$1600 \$67 \$1580 VSS|vss sg13_lv_nmos L=0.45U W=2U AS=0.68P AD=0.38P
+ PS=4.68U PD=2.38U rfmode=0
M$1046 \$1601 \$35 \$1600 VSS|vss sg13_lv_nmos L=0.45U W=2U AS=0.38P AD=0.68P
+ PS=2.38U PD=4.68U rfmode=0
M$1047 \$1510 \$39 \$1549 VSS|vss sg13_lv_nmos L=0.45U W=2U AS=0.68P AD=0.38P
+ PS=4.68U PD=2.38U rfmode=0
M$1048 \$1603 \$71 \$1510 VSS|vss sg13_lv_nmos L=0.45U W=2U AS=0.38P AD=0.68P
+ PS=2.38U PD=4.68U rfmode=0
M$1049 \$1604 \$67 \$1583 VSS|vss sg13_lv_nmos L=0.45U W=2U AS=0.68P AD=0.38P
+ PS=4.68U PD=2.38U rfmode=0
M$1050 \$1605 \$35 \$1604 VSS|vss sg13_lv_nmos L=0.45U W=2U AS=0.38P AD=0.68P
+ PS=2.38U PD=4.68U rfmode=0
M$1051 \$1513 \$39 \$1551 VSS|vss sg13_lv_nmos L=0.45U W=2U AS=0.68P AD=0.38P
+ PS=4.68U PD=2.38U rfmode=0
M$1052 \$1607 \$71 \$1513 VSS|vss sg13_lv_nmos L=0.45U W=2U AS=0.38P AD=0.68P
+ PS=2.38U PD=4.68U rfmode=0
M$1053 \$1613 \$83 \$1590 VSS|vss sg13_lv_nmos L=0.45U W=2U AS=0.68P AD=0.38P
+ PS=4.68U PD=2.38U rfmode=0
M$1054 \$1612 \$51 \$1613 VSS|vss sg13_lv_nmos L=0.45U W=2U AS=0.38P AD=0.68P
+ PS=2.38U PD=4.68U rfmode=0
M$1055 \$1520 \$55 \$1553 VSS|vss sg13_lv_nmos L=0.45U W=2U AS=0.68P AD=0.38P
+ PS=4.68U PD=2.38U rfmode=0
M$1056 \$1615 \$87 \$1520 VSS|vss sg13_lv_nmos L=0.45U W=2U AS=0.38P AD=0.68P
+ PS=2.38U PD=4.68U rfmode=0
M$1057 \$1616 \$83 \$1593 VSS|vss sg13_lv_nmos L=0.45U W=2U AS=0.68P AD=0.38P
+ PS=4.68U PD=2.38U rfmode=0
M$1058 \$1617 \$51 \$1616 VSS|vss sg13_lv_nmos L=0.45U W=2U AS=0.38P AD=0.68P
+ PS=2.38U PD=4.68U rfmode=0
M$1059 \$1523 \$55 \$1555 VSS|vss sg13_lv_nmos L=0.45U W=2U AS=0.68P AD=0.38P
+ PS=4.68U PD=2.38U rfmode=0
M$1060 \$1619 \$87 \$1523 VSS|vss sg13_lv_nmos L=0.45U W=2U AS=0.38P AD=0.68P
+ PS=2.38U PD=4.68U rfmode=0
M$1061 \$1581 \$69 \$1600 VSS|vss sg13_lv_nmos L=0.45U W=2U AS=0.68P AD=0.38P
+ PS=4.68U PD=2.38U rfmode=0
M$1062 \$1640 \$37 \$1581 VSS|vss sg13_lv_nmos L=0.45U W=2U AS=0.38P AD=0.68P
+ PS=2.38U PD=4.68U rfmode=0
M$1063 \$1620 \$35 \$1602 VSS|vss sg13_lv_nmos L=0.45U W=2U AS=0.68P AD=0.38P
+ PS=4.68U PD=2.38U rfmode=0
M$1064 \$1629 \$67 \$1620 VSS|vss sg13_lv_nmos L=0.45U W=2U AS=0.38P AD=0.68P
+ PS=2.38U PD=4.68U rfmode=0
M$1065 \$1621 \$35 \$1606 VSS|vss sg13_lv_nmos L=0.45U W=2U AS=0.68P AD=0.38P
+ PS=4.68U PD=2.38U rfmode=0
M$1066 \$1631 \$67 \$1621 VSS|vss sg13_lv_nmos L=0.45U W=2U AS=0.38P AD=0.68P
+ PS=2.38U PD=4.68U rfmode=0
M$1067 \$1591 \$85 \$1613 VSS|vss sg13_lv_nmos L=0.45U W=2U AS=0.68P AD=0.38P
+ PS=4.68U PD=2.38U rfmode=0
M$1068 \$1642 \$53 \$1591 VSS|vss sg13_lv_nmos L=0.45U W=2U AS=0.38P AD=0.68P
+ PS=2.38U PD=4.68U rfmode=0
M$1069 \$1594 \$85 \$1616 VSS|vss sg13_lv_nmos L=0.45U W=2U AS=0.68P AD=0.38P
+ PS=4.68U PD=2.38U rfmode=0
M$1070 \$1643 \$53 \$1594 VSS|vss sg13_lv_nmos L=0.45U W=2U AS=0.38P AD=0.68P
+ PS=2.38U PD=4.68U rfmode=0
M$1071 \$1623 \$51 \$1618 VSS|vss sg13_lv_nmos L=0.45U W=2U AS=0.68P AD=0.38P
+ PS=4.68U PD=2.38U rfmode=0
M$1072 \$1639 \$83 \$1623 VSS|vss sg13_lv_nmos L=0.45U W=2U AS=0.38P AD=0.68P
+ PS=2.38U PD=4.68U rfmode=0
M$1073 \$1584 \$69 \$1604 VSS|vss sg13_lv_nmos L=0.45U W=2U AS=0.68P AD=0.38P
+ PS=4.68U PD=2.38U rfmode=0
M$1074 \$1641 \$37 \$1584 VSS|vss sg13_lv_nmos L=0.45U W=2U AS=0.38P AD=0.68P
+ PS=2.38U PD=4.68U rfmode=0
M$1075 \$1622 \$51 \$1614 VSS|vss sg13_lv_nmos L=0.45U W=2U AS=0.68P AD=0.38P
+ PS=4.68U PD=2.38U rfmode=0
M$1076 \$1637 \$83 \$1622 VSS|vss sg13_lv_nmos L=0.45U W=2U AS=0.38P AD=0.68P
+ PS=2.38U PD=4.68U rfmode=0
M$1077 \$1640 \$67 \$1628 VSS|vss sg13_lv_nmos L=0.45U W=2U AS=0.68P AD=0.38P
+ PS=4.68U PD=2.38U rfmode=0
M$1078 \$1648 \$35 \$1640 VSS|vss sg13_lv_nmos L=0.45U W=2U AS=0.38P AD=0.68P
+ PS=2.38U PD=4.68U rfmode=0
M$1079 \$1603 \$37 \$1620 VSS|vss sg13_lv_nmos L=0.45U W=2U AS=0.68P AD=0.38P
+ PS=4.68U PD=2.38U rfmode=0
M$1080 \$1659 \$69 \$1603 VSS|vss sg13_lv_nmos L=0.45U W=2U AS=0.38P AD=0.68P
+ PS=2.38U PD=4.68U rfmode=0
M$1081 \$1641 \$67 \$1630 VSS|vss sg13_lv_nmos L=0.45U W=2U AS=0.68P AD=0.38P
+ PS=4.68U PD=2.38U rfmode=0
M$1082 \$1650 \$35 \$1641 VSS|vss sg13_lv_nmos L=0.45U W=2U AS=0.38P AD=0.68P
+ PS=2.38U PD=4.68U rfmode=0
M$1083 \$1607 \$37 \$1621 VSS|vss sg13_lv_nmos L=0.45U W=2U AS=0.68P AD=0.38P
+ PS=4.68U PD=2.38U rfmode=0
M$1084 \$1660 \$69 \$1607 VSS|vss sg13_lv_nmos L=0.45U W=2U AS=0.38P AD=0.68P
+ PS=2.38U PD=4.68U rfmode=0
M$1085 \$1642 \$83 \$1636 VSS|vss sg13_lv_nmos L=0.45U W=2U AS=0.68P AD=0.38P
+ PS=4.68U PD=2.38U rfmode=0
M$1086 \$1655 \$51 \$1642 VSS|vss sg13_lv_nmos L=0.45U W=2U AS=0.38P AD=0.68P
+ PS=2.38U PD=4.68U rfmode=0
M$1087 \$1615 \$53 \$1622 VSS|vss sg13_lv_nmos L=0.45U W=2U AS=0.68P AD=0.38P
+ PS=4.68U PD=2.38U rfmode=0
M$1088 \$1663 \$85 \$1615 VSS|vss sg13_lv_nmos L=0.45U W=2U AS=0.38P AD=0.68P
+ PS=2.38U PD=4.68U rfmode=0
M$1089 \$1643 \$83 \$1638 VSS|vss sg13_lv_nmos L=0.45U W=2U AS=0.68P AD=0.38P
+ PS=4.68U PD=2.38U rfmode=0
M$1090 \$1657 \$51 \$1643 VSS|vss sg13_lv_nmos L=0.45U W=2U AS=0.38P AD=0.68P
+ PS=2.38U PD=4.68U rfmode=0
M$1091 \$1619 \$53 \$1623 VSS|vss sg13_lv_nmos L=0.45U W=2U AS=0.68P AD=0.38P
+ PS=4.68U PD=2.38U rfmode=0
M$1092 \$1664 \$85 \$1619 VSS|vss sg13_lv_nmos L=0.45U W=2U AS=0.38P AD=0.68P
+ PS=2.38U PD=4.68U rfmode=0
M$1093 \$1659 \$35 \$1649 VSS|vss sg13_lv_nmos L=0.45U W=2U AS=0.68P AD=0.38P
+ PS=4.68U PD=2.38U rfmode=0
M$1094 \$1667 \$67 \$1659 VSS|vss sg13_lv_nmos L=0.45U W=2U AS=0.38P AD=0.68P
+ PS=2.38U PD=4.68U rfmode=0
M$1095 \$1660 \$35 \$1651 VSS|vss sg13_lv_nmos L=0.45U W=2U AS=0.68P AD=0.38P
+ PS=4.68U PD=2.38U rfmode=0
M$1096 \$1668 \$67 \$1660 VSS|vss sg13_lv_nmos L=0.45U W=2U AS=0.38P AD=0.68P
+ PS=2.38U PD=4.68U rfmode=0
M$1097 \$1663 \$51 \$1656 VSS|vss sg13_lv_nmos L=0.45U W=2U AS=0.68P AD=0.38P
+ PS=4.68U PD=2.38U rfmode=0
M$1098 \$1670 \$83 \$1663 VSS|vss sg13_lv_nmos L=0.45U W=2U AS=0.38P AD=0.68P
+ PS=2.38U PD=4.68U rfmode=0
M$1099 \$1664 \$51 \$1658 VSS|vss sg13_lv_nmos L=0.45U W=2U AS=0.68P AD=0.38P
+ PS=4.68U PD=2.38U rfmode=0
M$1100 \$1671 \$83 \$1664 VSS|vss sg13_lv_nmos L=0.45U W=2U AS=0.38P AD=0.68P
+ PS=2.38U PD=4.68U rfmode=0
M$1101 VSS|vss qb cmp_soft|q VSS|vss sg13_lv_nmos L=0.13U W=1.5U AS=0.51P
+ AD=0.51P PS=3.68U PD=3.68U rfmode=0
M$1102 VSS|vss \$1688 cmp_soft|q VSS|vss sg13_lv_nmos L=0.13U W=1.5U AS=0.51P
+ AD=0.51P PS=3.68U PD=3.68U rfmode=0
M$1103 VSS|vss \$1691 \$1688 VSS|vss sg13_lv_nmos L=0.13U W=4U AS=1.36P
+ AD=1.36P PS=8.68U PD=8.68U rfmode=0
M$1104 \$1693 \$1689 \$1691 VSS|vss sg13_lv_nmos L=0.13U W=3U AS=1.02P AD=1.02P
+ PS=6.68U PD=6.68U rfmode=0
M$1105 \$1692 inn|out|vth_soft \$1692 VSS|vss sg13_lv_nmos L=0.13U W=6U
+ AS=2.04P AD=2.04P PS=12.68U PD=12.68U rfmode=0
M$1106 \$1694 inn|out|vth_soft \$1693 VSS|vss sg13_lv_nmos L=0.34U W=6U
+ AS=2.04P AD=1.14P PS=12.68U PD=6.38U rfmode=0
M$1107 \$1693 inn|out|vth_soft \$1694 VSS|vss sg13_lv_nmos L=0.34U W=6U
+ AS=1.14P AD=2.04P PS=6.38U PD=12.68U rfmode=0
M$1108 \$1694 clk VSS|vss VSS|vss sg13_lv_nmos L=0.13U W=4U AS=1.36P AD=0.76P
+ PS=8.68U PD=4.38U rfmode=0
M$1109 VSS|vss clk \$1694 VSS|vss sg13_lv_nmos L=0.13U W=4U AS=0.76P AD=0.76P
+ PS=4.38U PD=4.38U rfmode=0
M$1110 \$1694 clk VSS|vss VSS|vss sg13_lv_nmos L=0.13U W=4U AS=0.76P AD=0.76P
+ PS=4.38U PD=4.38U rfmode=0
M$1111 VSS|vss clk \$1694 VSS|vss sg13_lv_nmos L=0.13U W=4U AS=0.76P AD=1.36P
+ PS=4.38U PD=8.68U rfmode=0
M$1112 \$1694 icmp|inp \$1692 VSS|vss sg13_lv_nmos L=0.34U W=6U AS=2.04P
+ AD=1.14P PS=12.68U PD=6.38U rfmode=0
M$1113 \$1692 icmp|inp \$1694 VSS|vss sg13_lv_nmos L=0.34U W=6U AS=1.14P
+ AD=2.04P PS=6.38U PD=12.68U rfmode=0
M$1114 \$1693 icmp|inp \$1693 VSS|vss sg13_lv_nmos L=0.13U W=6U AS=2.04P
+ AD=2.04P PS=12.68U PD=12.68U rfmode=0
M$1115 \$1689 \$1691 \$1692 VSS|vss sg13_lv_nmos L=0.13U W=3U AS=1.02P AD=1.02P
+ PS=6.68U PD=6.68U rfmode=0
M$1116 \$1695 \$1689 VSS|vss VSS|vss sg13_lv_nmos L=0.13U W=4U AS=1.36P
+ AD=1.36P PS=8.68U PD=8.68U rfmode=0
M$1117 qb \$1695 VSS|vss VSS|vss sg13_lv_nmos L=0.13U W=1.5U AS=0.51P AD=0.51P
+ PS=3.68U PD=3.68U rfmode=0
M$1118 qb cmp_soft|q VSS|vss VSS|vss sg13_lv_nmos L=0.13U W=1.5U AS=0.51P
+ AD=0.51P PS=3.68U PD=3.68U rfmode=0
M$1119 VSS|vss qb$1 cmp_hard|q VSS|vss sg13_lv_nmos L=0.13U W=1.5U AS=0.51P
+ AD=0.51P PS=3.68U PD=3.68U rfmode=0
M$1120 VSS|vss \$1697 cmp_hard|q VSS|vss sg13_lv_nmos L=0.13U W=1.5U AS=0.51P
+ AD=0.51P PS=3.68U PD=3.68U rfmode=0
M$1121 VSS|vss \$1698 \$1697 VSS|vss sg13_lv_nmos L=0.13U W=4U AS=1.36P
+ AD=1.36P PS=8.68U PD=8.68U rfmode=0
M$1122 \$1700 \$1690 \$1698 VSS|vss sg13_lv_nmos L=0.13U W=3U AS=1.02P AD=1.02P
+ PS=6.68U PD=6.68U rfmode=0
M$1123 \$1699 inn|out|vth_hard \$1699 VSS|vss sg13_lv_nmos L=0.13U W=6U
+ AS=2.04P AD=2.04P PS=12.68U PD=12.68U rfmode=0
M$1124 \$1701 inn|out|vth_hard \$1700 VSS|vss sg13_lv_nmos L=0.34U W=6U
+ AS=2.04P AD=1.14P PS=12.68U PD=6.38U rfmode=0
M$1125 \$1700 inn|out|vth_hard \$1701 VSS|vss sg13_lv_nmos L=0.34U W=6U
+ AS=1.14P AD=2.04P PS=6.38U PD=12.68U rfmode=0
M$1126 \$1701 clk|cmp_clk_n VSS|vss VSS|vss sg13_lv_nmos L=0.13U W=4U AS=1.36P
+ AD=0.76P PS=8.68U PD=4.38U rfmode=0
M$1127 VSS|vss clk|cmp_clk_n \$1701 VSS|vss sg13_lv_nmos L=0.13U W=4U AS=0.76P
+ AD=0.76P PS=4.38U PD=4.38U rfmode=0
M$1128 \$1701 clk|cmp_clk_n VSS|vss VSS|vss sg13_lv_nmos L=0.13U W=4U AS=0.76P
+ AD=0.76P PS=4.38U PD=4.38U rfmode=0
M$1129 VSS|vss clk|cmp_clk_n \$1701 VSS|vss sg13_lv_nmos L=0.13U W=4U AS=0.76P
+ AD=1.36P PS=4.38U PD=8.68U rfmode=0
M$1130 \$1701 icmp|inp \$1699 VSS|vss sg13_lv_nmos L=0.34U W=6U AS=2.04P
+ AD=1.14P PS=12.68U PD=6.38U rfmode=0
M$1131 \$1699 icmp|inp \$1701 VSS|vss sg13_lv_nmos L=0.34U W=6U AS=1.14P
+ AD=2.04P PS=6.38U PD=12.68U rfmode=0
M$1132 \$1700 icmp|inp \$1700 VSS|vss sg13_lv_nmos L=0.13U W=6U AS=2.04P
+ AD=2.04P PS=12.68U PD=12.68U rfmode=0
M$1133 \$1690 \$1698 \$1699 VSS|vss sg13_lv_nmos L=0.13U W=3U AS=1.02P AD=1.02P
+ PS=6.68U PD=6.68U rfmode=0
M$1134 \$1702 \$1690 VSS|vss VSS|vss sg13_lv_nmos L=0.13U W=4U AS=1.36P
+ AD=1.36P PS=8.68U PD=8.68U rfmode=0
M$1135 qb$1 \$1702 VSS|vss VSS|vss sg13_lv_nmos L=0.13U W=1.5U AS=0.51P
+ AD=0.51P PS=3.68U PD=3.68U rfmode=0
M$1136 qb$1 cmp_hard|q VSS|vss VSS|vss sg13_lv_nmos L=0.13U W=1.5U AS=0.51P
+ AD=0.51P PS=3.68U PD=3.68U rfmode=0
M$1137 clk|cmp_clk_n clk VSS|vss VSS|vss sg13_lv_nmos L=0.13U W=0.5U AS=0.17P
+ AD=0.17P PS=1.68U PD=1.68U rfmode=0
M$1138 VDD|vdd d0|dac_soft[0] \$18 VDD|vdd sg13_lv_pmos L=0.13U W=1U AS=0.34P
+ AD=0.34P PS=2.68U PD=2.68U rfmode=0
M$1139 VDD|vdd d1|dac_soft[1] \$19 VDD|vdd sg13_lv_pmos L=0.13U W=1U AS=0.34P
+ AD=0.34P PS=2.68U PD=2.68U rfmode=0
M$1140 VDD|vdd d2|dac_soft[2] \$20 VDD|vdd sg13_lv_pmos L=0.13U W=1U AS=0.34P
+ AD=0.34P PS=2.68U PD=2.68U rfmode=0
M$1141 VDD|vdd d3|dac_soft[3] \$21 VDD|vdd sg13_lv_pmos L=0.13U W=1U AS=0.34P
+ AD=0.34P PS=2.68U PD=2.68U rfmode=0
M$1142 VDD|vdd d4|dac_soft[4] \$22 VDD|vdd sg13_lv_pmos L=0.13U W=1U AS=0.34P
+ AD=0.34P PS=2.68U PD=2.68U rfmode=0
M$1143 VDD|vdd d5|dac_soft[5] \$23 VDD|vdd sg13_lv_pmos L=0.13U W=1U AS=0.34P
+ AD=0.34P PS=2.68U PD=2.68U rfmode=0
M$1144 VDD|vdd d6|dac_soft[6] \$24 VDD|vdd sg13_lv_pmos L=0.13U W=1U AS=0.34P
+ AD=0.34P PS=2.68U PD=2.68U rfmode=0
M$1145 VDD|vdd d7|dac_soft[7] \$25 VDD|vdd sg13_lv_pmos L=0.13U W=1U AS=0.34P
+ AD=0.34P PS=2.68U PD=2.68U rfmode=0
M$1146 VDD|vdd d0|dac_hard[0] \$26 VDD|vdd sg13_lv_pmos L=0.13U W=1U AS=0.34P
+ AD=0.34P PS=2.68U PD=2.68U rfmode=0
M$1147 VDD|vdd d1|dac_hard[1] \$27 VDD|vdd sg13_lv_pmos L=0.13U W=1U AS=0.34P
+ AD=0.34P PS=2.68U PD=2.68U rfmode=0
M$1148 VDD|vdd d2|dac_hard[2] \$28 VDD|vdd sg13_lv_pmos L=0.13U W=1U AS=0.34P
+ AD=0.34P PS=2.68U PD=2.68U rfmode=0
M$1149 VDD|vdd d3|dac_hard[3] \$29 VDD|vdd sg13_lv_pmos L=0.13U W=1U AS=0.34P
+ AD=0.34P PS=2.68U PD=2.68U rfmode=0
M$1150 VDD|vdd d4|dac_hard[4] \$30 VDD|vdd sg13_lv_pmos L=0.13U W=1U AS=0.34P
+ AD=0.34P PS=2.68U PD=2.68U rfmode=0
M$1151 VDD|vdd d5|dac_hard[5] \$31 VDD|vdd sg13_lv_pmos L=0.13U W=1U AS=0.34P
+ AD=0.34P PS=2.68U PD=2.68U rfmode=0
M$1152 VDD|vdd d6|dac_hard[6] \$32 VDD|vdd sg13_lv_pmos L=0.13U W=1U AS=0.34P
+ AD=0.34P PS=2.68U PD=2.68U rfmode=0
M$1153 VDD|vdd d7|dac_hard[7] \$33 VDD|vdd sg13_lv_pmos L=0.13U W=1U AS=0.34P
+ AD=0.34P PS=2.68U PD=2.68U rfmode=0
M$1154 \$34 \$66 IOVDD|vdda IOVDD|vdda sg13_lv_pmos L=0.45U W=0.3U AS=0.102P
+ AD=0.102P PS=1.28U PD=1.28U rfmode=0
M$1155 \$66 \$34 IOVDD|vdda IOVDD|vdda sg13_lv_pmos L=0.45U W=0.3U AS=0.102P
+ AD=0.102P PS=1.28U PD=1.28U rfmode=0
M$1156 \$35 \$34 IOVDD|vdda IOVDD|vdda sg13_lv_pmos L=0.45U W=3.9U AS=1.326P
+ AD=1.326P PS=8.48U PD=8.48U rfmode=0
M$1157 \$67 \$35 IOVDD|vdda IOVDD|vdda sg13_lv_pmos L=0.45U W=3.9U AS=1.326P
+ AD=1.326P PS=8.48U PD=8.48U rfmode=0
M$1158 \$36 \$68 IOVDD|vdda IOVDD|vdda sg13_lv_pmos L=0.45U W=0.3U AS=0.102P
+ AD=0.102P PS=1.28U PD=1.28U rfmode=0
M$1159 \$68 \$36 IOVDD|vdda IOVDD|vdda sg13_lv_pmos L=0.45U W=0.3U AS=0.102P
+ AD=0.102P PS=1.28U PD=1.28U rfmode=0
M$1160 \$37 \$36 IOVDD|vdda IOVDD|vdda sg13_lv_pmos L=0.45U W=3.9U AS=1.326P
+ AD=1.326P PS=8.48U PD=8.48U rfmode=0
M$1161 \$69 \$37 IOVDD|vdda IOVDD|vdda sg13_lv_pmos L=0.45U W=3.9U AS=1.326P
+ AD=1.326P PS=8.48U PD=8.48U rfmode=0
M$1162 \$38 \$70 IOVDD|vdda IOVDD|vdda sg13_lv_pmos L=0.45U W=0.3U AS=0.102P
+ AD=0.102P PS=1.28U PD=1.28U rfmode=0
M$1163 \$70 \$38 IOVDD|vdda IOVDD|vdda sg13_lv_pmos L=0.45U W=0.3U AS=0.102P
+ AD=0.102P PS=1.28U PD=1.28U rfmode=0
M$1164 \$39 \$38 IOVDD|vdda IOVDD|vdda sg13_lv_pmos L=0.45U W=3.9U AS=1.326P
+ AD=1.326P PS=8.48U PD=8.48U rfmode=0
M$1165 \$71 \$39 IOVDD|vdda IOVDD|vdda sg13_lv_pmos L=0.45U W=3.9U AS=1.326P
+ AD=1.326P PS=8.48U PD=8.48U rfmode=0
M$1166 \$40 \$72 IOVDD|vdda IOVDD|vdda sg13_lv_pmos L=0.45U W=0.3U AS=0.102P
+ AD=0.102P PS=1.28U PD=1.28U rfmode=0
M$1167 \$72 \$40 IOVDD|vdda IOVDD|vdda sg13_lv_pmos L=0.45U W=0.3U AS=0.102P
+ AD=0.102P PS=1.28U PD=1.28U rfmode=0
M$1168 \$41 \$40 IOVDD|vdda IOVDD|vdda sg13_lv_pmos L=0.45U W=3.9U AS=1.326P
+ AD=1.326P PS=8.48U PD=8.48U rfmode=0
M$1169 \$73 \$41 IOVDD|vdda IOVDD|vdda sg13_lv_pmos L=0.45U W=3.9U AS=1.326P
+ AD=1.326P PS=8.48U PD=8.48U rfmode=0
M$1170 \$42 \$74 IOVDD|vdda IOVDD|vdda sg13_lv_pmos L=0.45U W=0.3U AS=0.102P
+ AD=0.102P PS=1.28U PD=1.28U rfmode=0
M$1171 \$74 \$42 IOVDD|vdda IOVDD|vdda sg13_lv_pmos L=0.45U W=0.3U AS=0.102P
+ AD=0.102P PS=1.28U PD=1.28U rfmode=0
M$1172 \$43 \$42 IOVDD|vdda IOVDD|vdda sg13_lv_pmos L=0.45U W=3.9U AS=1.326P
+ AD=1.326P PS=8.48U PD=8.48U rfmode=0
M$1173 \$75 \$43 IOVDD|vdda IOVDD|vdda sg13_lv_pmos L=0.45U W=3.9U AS=1.326P
+ AD=1.326P PS=8.48U PD=8.48U rfmode=0
M$1174 \$44 \$76 IOVDD|vdda IOVDD|vdda sg13_lv_pmos L=0.45U W=0.3U AS=0.102P
+ AD=0.102P PS=1.28U PD=1.28U rfmode=0
M$1175 \$76 \$44 IOVDD|vdda IOVDD|vdda sg13_lv_pmos L=0.45U W=0.3U AS=0.102P
+ AD=0.102P PS=1.28U PD=1.28U rfmode=0
M$1176 \$45 \$44 IOVDD|vdda IOVDD|vdda sg13_lv_pmos L=0.45U W=3.9U AS=1.326P
+ AD=1.326P PS=8.48U PD=8.48U rfmode=0
M$1177 \$77 \$45 IOVDD|vdda IOVDD|vdda sg13_lv_pmos L=0.45U W=3.9U AS=1.326P
+ AD=1.326P PS=8.48U PD=8.48U rfmode=0
M$1178 \$46 \$78 IOVDD|vdda IOVDD|vdda sg13_lv_pmos L=0.45U W=0.3U AS=0.102P
+ AD=0.102P PS=1.28U PD=1.28U rfmode=0
M$1179 \$78 \$46 IOVDD|vdda IOVDD|vdda sg13_lv_pmos L=0.45U W=0.3U AS=0.102P
+ AD=0.102P PS=1.28U PD=1.28U rfmode=0
M$1180 \$47 \$46 IOVDD|vdda IOVDD|vdda sg13_lv_pmos L=0.45U W=3.9U AS=1.326P
+ AD=1.326P PS=8.48U PD=8.48U rfmode=0
M$1181 \$79 \$47 IOVDD|vdda IOVDD|vdda sg13_lv_pmos L=0.45U W=3.9U AS=1.326P
+ AD=1.326P PS=8.48U PD=8.48U rfmode=0
M$1182 \$48 \$80 IOVDD|vdda IOVDD|vdda sg13_lv_pmos L=0.45U W=0.3U AS=0.102P
+ AD=0.102P PS=1.28U PD=1.28U rfmode=0
M$1183 \$80 \$48 IOVDD|vdda IOVDD|vdda sg13_lv_pmos L=0.45U W=0.3U AS=0.102P
+ AD=0.102P PS=1.28U PD=1.28U rfmode=0
M$1184 \$49 \$48 IOVDD|vdda IOVDD|vdda sg13_lv_pmos L=0.45U W=3.9U AS=1.326P
+ AD=1.326P PS=8.48U PD=8.48U rfmode=0
M$1185 \$81 \$49 IOVDD|vdda IOVDD|vdda sg13_lv_pmos L=0.45U W=3.9U AS=1.326P
+ AD=1.326P PS=8.48U PD=8.48U rfmode=0
M$1186 \$50 \$82 IOVDD|vdda IOVDD|vdda sg13_lv_pmos L=0.45U W=0.3U AS=0.102P
+ AD=0.102P PS=1.28U PD=1.28U rfmode=0
M$1187 \$82 \$50 IOVDD|vdda IOVDD|vdda sg13_lv_pmos L=0.45U W=0.3U AS=0.102P
+ AD=0.102P PS=1.28U PD=1.28U rfmode=0
M$1188 \$51 \$50 IOVDD|vdda IOVDD|vdda sg13_lv_pmos L=0.45U W=3.9U AS=1.326P
+ AD=1.326P PS=8.48U PD=8.48U rfmode=0
M$1189 \$83 \$51 IOVDD|vdda IOVDD|vdda sg13_lv_pmos L=0.45U W=3.9U AS=1.326P
+ AD=1.326P PS=8.48U PD=8.48U rfmode=0
M$1190 \$52 \$84 IOVDD|vdda IOVDD|vdda sg13_lv_pmos L=0.45U W=0.3U AS=0.102P
+ AD=0.102P PS=1.28U PD=1.28U rfmode=0
M$1191 \$84 \$52 IOVDD|vdda IOVDD|vdda sg13_lv_pmos L=0.45U W=0.3U AS=0.102P
+ AD=0.102P PS=1.28U PD=1.28U rfmode=0
M$1192 \$53 \$52 IOVDD|vdda IOVDD|vdda sg13_lv_pmos L=0.45U W=3.9U AS=1.326P
+ AD=1.326P PS=8.48U PD=8.48U rfmode=0
M$1193 \$85 \$53 IOVDD|vdda IOVDD|vdda sg13_lv_pmos L=0.45U W=3.9U AS=1.326P
+ AD=1.326P PS=8.48U PD=8.48U rfmode=0
M$1194 \$54 \$86 IOVDD|vdda IOVDD|vdda sg13_lv_pmos L=0.45U W=0.3U AS=0.102P
+ AD=0.102P PS=1.28U PD=1.28U rfmode=0
M$1195 \$86 \$54 IOVDD|vdda IOVDD|vdda sg13_lv_pmos L=0.45U W=0.3U AS=0.102P
+ AD=0.102P PS=1.28U PD=1.28U rfmode=0
M$1196 \$55 \$54 IOVDD|vdda IOVDD|vdda sg13_lv_pmos L=0.45U W=3.9U AS=1.326P
+ AD=1.326P PS=8.48U PD=8.48U rfmode=0
M$1197 \$87 \$55 IOVDD|vdda IOVDD|vdda sg13_lv_pmos L=0.45U W=3.9U AS=1.326P
+ AD=1.326P PS=8.48U PD=8.48U rfmode=0
M$1198 \$56 \$88 IOVDD|vdda IOVDD|vdda sg13_lv_pmos L=0.45U W=0.3U AS=0.102P
+ AD=0.102P PS=1.28U PD=1.28U rfmode=0
M$1199 \$88 \$56 IOVDD|vdda IOVDD|vdda sg13_lv_pmos L=0.45U W=0.3U AS=0.102P
+ AD=0.102P PS=1.28U PD=1.28U rfmode=0
M$1200 \$57 \$56 IOVDD|vdda IOVDD|vdda sg13_lv_pmos L=0.45U W=3.9U AS=1.326P
+ AD=1.326P PS=8.48U PD=8.48U rfmode=0
M$1201 \$89 \$57 IOVDD|vdda IOVDD|vdda sg13_lv_pmos L=0.45U W=3.9U AS=1.326P
+ AD=1.326P PS=8.48U PD=8.48U rfmode=0
M$1202 \$58 \$90 IOVDD|vdda IOVDD|vdda sg13_lv_pmos L=0.45U W=0.3U AS=0.102P
+ AD=0.102P PS=1.28U PD=1.28U rfmode=0
M$1203 \$90 \$58 IOVDD|vdda IOVDD|vdda sg13_lv_pmos L=0.45U W=0.3U AS=0.102P
+ AD=0.102P PS=1.28U PD=1.28U rfmode=0
M$1204 \$59 \$58 IOVDD|vdda IOVDD|vdda sg13_lv_pmos L=0.45U W=3.9U AS=1.326P
+ AD=1.326P PS=8.48U PD=8.48U rfmode=0
M$1205 \$91 \$59 IOVDD|vdda IOVDD|vdda sg13_lv_pmos L=0.45U W=3.9U AS=1.326P
+ AD=1.326P PS=8.48U PD=8.48U rfmode=0
M$1206 \$60 \$92 IOVDD|vdda IOVDD|vdda sg13_lv_pmos L=0.45U W=0.3U AS=0.102P
+ AD=0.102P PS=1.28U PD=1.28U rfmode=0
M$1207 \$92 \$60 IOVDD|vdda IOVDD|vdda sg13_lv_pmos L=0.45U W=0.3U AS=0.102P
+ AD=0.102P PS=1.28U PD=1.28U rfmode=0
M$1208 \$61 \$60 IOVDD|vdda IOVDD|vdda sg13_lv_pmos L=0.45U W=3.9U AS=1.326P
+ AD=1.326P PS=8.48U PD=8.48U rfmode=0
M$1209 \$93 \$61 IOVDD|vdda IOVDD|vdda sg13_lv_pmos L=0.45U W=3.9U AS=1.326P
+ AD=1.326P PS=8.48U PD=8.48U rfmode=0
M$1210 \$62 \$94 IOVDD|vdda IOVDD|vdda sg13_lv_pmos L=0.45U W=0.3U AS=0.102P
+ AD=0.102P PS=1.28U PD=1.28U rfmode=0
M$1211 \$94 \$62 IOVDD|vdda IOVDD|vdda sg13_lv_pmos L=0.45U W=0.3U AS=0.102P
+ AD=0.102P PS=1.28U PD=1.28U rfmode=0
M$1212 \$63 \$62 IOVDD|vdda IOVDD|vdda sg13_lv_pmos L=0.45U W=3.9U AS=1.326P
+ AD=1.326P PS=8.48U PD=8.48U rfmode=0
M$1213 \$95 \$63 IOVDD|vdda IOVDD|vdda sg13_lv_pmos L=0.45U W=3.9U AS=1.326P
+ AD=1.326P PS=8.48U PD=8.48U rfmode=0
M$1214 \$64 \$96 IOVDD|vdda IOVDD|vdda sg13_lv_pmos L=0.45U W=0.3U AS=0.102P
+ AD=0.102P PS=1.28U PD=1.28U rfmode=0
M$1215 \$96 \$64 IOVDD|vdda IOVDD|vdda sg13_lv_pmos L=0.45U W=0.3U AS=0.102P
+ AD=0.102P PS=1.28U PD=1.28U rfmode=0
M$1216 \$65 \$64 IOVDD|vdda IOVDD|vdda sg13_lv_pmos L=0.45U W=3.9U AS=1.326P
+ AD=1.326P PS=8.48U PD=8.48U rfmode=0
M$1217 \$97 \$65 IOVDD|vdda IOVDD|vdda sg13_lv_pmos L=0.45U W=3.9U AS=1.326P
+ AD=1.326P PS=8.48U PD=8.48U rfmode=0
M$1218 \$1706 qb cmp_soft|q VDD|vdd sg13_lv_pmos L=0.13U W=4U AS=1.36P AD=1.36P
+ PS=8.68U PD=8.68U rfmode=0
M$1219 VDD|vdd \$1688 \$1706 VDD|vdd sg13_lv_pmos L=0.13U W=4U AS=1.36P
+ AD=1.36P PS=8.68U PD=8.68U rfmode=0
M$1220 VDD|vdd \$1691 \$1688 VDD|vdd sg13_lv_pmos L=0.13U W=1U AS=0.34P
+ AD=0.34P PS=2.68U PD=2.68U rfmode=0
M$1221 VDD|vdd \$1689 \$1691 VDD|vdd sg13_lv_pmos L=0.13U W=3U AS=1.02P
+ AD=1.02P PS=6.68U PD=6.68U rfmode=0
M$1222 VDD|vdd clk \$1691 VDD|vdd sg13_lv_pmos L=0.13U W=6U AS=2.04P AD=2.04P
+ PS=12.68U PD=12.68U rfmode=0
M$1223 VDD|vdd clk \$1693 VDD|vdd sg13_lv_pmos L=0.13U W=3U AS=1.02P AD=1.02P
+ PS=6.68U PD=6.68U rfmode=0
M$1224 \$1692 clk VDD|vdd VDD|vdd sg13_lv_pmos L=0.13U W=3U AS=1.02P AD=1.02P
+ PS=6.68U PD=6.68U rfmode=0
M$1225 \$1689 clk VDD|vdd VDD|vdd sg13_lv_pmos L=0.13U W=6U AS=2.04P AD=2.04P
+ PS=12.68U PD=12.68U rfmode=0
M$1226 \$1689 \$1691 VDD|vdd VDD|vdd sg13_lv_pmos L=0.13U W=3U AS=1.02P
+ AD=1.02P PS=6.68U PD=6.68U rfmode=0
M$1227 \$1695 \$1689 VDD|vdd VDD|vdd sg13_lv_pmos L=0.13U W=1U AS=0.34P
+ AD=0.34P PS=2.68U PD=2.68U rfmode=0
M$1228 \$1707 \$1695 VDD|vdd VDD|vdd sg13_lv_pmos L=0.13U W=4U AS=1.36P
+ AD=1.36P PS=8.68U PD=8.68U rfmode=0
M$1229 qb cmp_soft|q \$1707 VDD|vdd sg13_lv_pmos L=0.13U W=4U AS=1.36P AD=1.36P
+ PS=8.68U PD=8.68U rfmode=0
M$1230 clk|cmp_clk_n clk VDD|vdd VDD|vdd sg13_lv_pmos L=0.13U W=1U AS=0.34P
+ AD=0.34P PS=2.68U PD=2.68U rfmode=0
M$1231 \$1705 qb$1 cmp_hard|q VDD|vdd sg13_lv_pmos L=0.13U W=4U AS=1.36P
+ AD=1.36P PS=8.68U PD=8.68U rfmode=0
M$1232 VDD|vdd \$1697 \$1705 VDD|vdd sg13_lv_pmos L=0.13U W=4U AS=1.36P
+ AD=1.36P PS=8.68U PD=8.68U rfmode=0
M$1233 VDD|vdd \$1698 \$1697 VDD|vdd sg13_lv_pmos L=0.13U W=1U AS=0.34P
+ AD=0.34P PS=2.68U PD=2.68U rfmode=0
M$1234 VDD|vdd \$1690 \$1698 VDD|vdd sg13_lv_pmos L=0.13U W=3U AS=1.02P
+ AD=1.02P PS=6.68U PD=6.68U rfmode=0
M$1235 VDD|vdd clk|cmp_clk_n \$1698 VDD|vdd sg13_lv_pmos L=0.13U W=6U AS=2.04P
+ AD=2.04P PS=12.68U PD=12.68U rfmode=0
M$1236 VDD|vdd clk|cmp_clk_n \$1700 VDD|vdd sg13_lv_pmos L=0.13U W=3U AS=1.02P
+ AD=1.02P PS=6.68U PD=6.68U rfmode=0
M$1237 \$1699 clk|cmp_clk_n VDD|vdd VDD|vdd sg13_lv_pmos L=0.13U W=3U AS=1.02P
+ AD=1.02P PS=6.68U PD=6.68U rfmode=0
M$1238 \$1690 clk|cmp_clk_n VDD|vdd VDD|vdd sg13_lv_pmos L=0.13U W=6U AS=2.04P
+ AD=2.04P PS=12.68U PD=12.68U rfmode=0
M$1239 \$1690 \$1698 VDD|vdd VDD|vdd sg13_lv_pmos L=0.13U W=3U AS=1.02P
+ AD=1.02P PS=6.68U PD=6.68U rfmode=0
M$1240 \$1702 \$1690 VDD|vdd VDD|vdd sg13_lv_pmos L=0.13U W=1U AS=0.34P
+ AD=0.34P PS=2.68U PD=2.68U rfmode=0
M$1241 \$1708 \$1702 VDD|vdd VDD|vdd sg13_lv_pmos L=0.13U W=4U AS=1.36P
+ AD=1.36P PS=8.68U PD=8.68U rfmode=0
M$1242 qb$1 cmp_hard|q \$1708 VDD|vdd sg13_lv_pmos L=0.13U W=4U AS=1.36P
+ AD=1.36P PS=8.68U PD=8.68U rfmode=0
R$1243 \$100 \$111 VSS|vss 4 rppd l=1.2 ps=0 b=0 m=1
R$1244 \$100 \$112 VSS|vss 4 rppd l=1.2 ps=0 b=0 m=1
R$1245 \$101 \$113 VSS|vss 4 rppd l=1.2 ps=0 b=0 m=1
R$1246 \$101 \$114 VSS|vss 4 rppd l=1.2 ps=0 b=0 m=1
R$1247 \$102 \$116 VSS|vss 4 rppd l=1.2 ps=0 b=0 m=1
R$1248 \$102 \$118 VSS|vss 4 rppd l=1.2 ps=0 b=0 m=1
R$1249 \$103 \$119 VSS|vss 4 rppd l=1.2 ps=0 b=0 m=1
R$1250 \$103 \$120 VSS|vss 4 rppd l=1.2 ps=0 b=0 m=1
R$1251 \$106 \$121 VSS|vss 4 rppd l=1.2 ps=0 b=0 m=1
R$1252 \$106 \$122 VSS|vss 4 rppd l=1.2 ps=0 b=0 m=1
R$1253 \$107 \$123 VSS|vss 4 rppd l=1.2 ps=0 b=0 m=1
R$1254 \$107 \$125 VSS|vss 4 rppd l=1.2 ps=0 b=0 m=1
R$1255 \$108 \$126 VSS|vss 4 rppd l=1.2 ps=0 b=0 m=1
R$1256 \$108 \$127 VSS|vss 4 rppd l=1.2 ps=0 b=0 m=1
R$1257 \$109 \$129 VSS|vss 4 rppd l=1.2 ps=0 b=0 m=1
R$1258 \$109 \$130 VSS|vss 4 rppd l=1.2 ps=0 b=0 m=1
R$1259 VSS|vss \$154 VSS|vss 4 rppd l=1.2 ps=0 b=0 m=1
R$1260 \$111 \$155 VSS|vss 4 rppd l=1.2 ps=0 b=0 m=1
R$1261 \$112 \$131 VSS|vss 4 rppd l=1.2 ps=0 b=0 m=1
R$1262 \$113 \$132 VSS|vss 4 rppd l=1.2 ps=0 b=0 m=1
R$1263 \$114 \$133 VSS|vss 4 rppd l=1.2 ps=0 b=0 m=1
R$1264 \$116 \$136 VSS|vss 4 rppd l=1.2 ps=0 b=0 m=1
R$1265 \$118 \$137 VSS|vss 4 rppd l=1.2 ps=0 b=0 m=1
R$1266 \$119 \$140 VSS|vss 4 rppd l=1.2 ps=0 b=0 m=1
R$1267 \$120 \$141 VSS|vss 4 rppd l=1.2 ps=0 b=0 m=1
R$1268 VSS|vss \$142 VSS|vss 4 rppd l=1.2 ps=0 b=0 m=1
R$1269 \$121 \$143 VSS|vss 4 rppd l=1.2 ps=0 b=0 m=1
R$1270 \$122 \$144 VSS|vss 4 rppd l=1.2 ps=0 b=0 m=1
R$1271 \$123 \$156 VSS|vss 4 rppd l=1.2 ps=0 b=0 m=1
R$1272 \$125 \$145 VSS|vss 4 rppd l=1.2 ps=0 b=0 m=1
R$1273 \$126 \$147 VSS|vss 4 rppd l=1.2 ps=0 b=0 m=1
R$1274 \$127 \$149 VSS|vss 4 rppd l=1.2 ps=0 b=0 m=1
R$1275 \$129 \$152 VSS|vss 4 rppd l=1.2 ps=0 b=0 m=1
R$1276 \$130 \$153 VSS|vss 4 rppd l=1.2 ps=0 b=0 m=1
R$1277 \$154 \$157 VSS|vss 4 rppd l=1.2 ps=0 b=0 m=1
R$1278 \$155 \$158 VSS|vss 4 rppd l=1.2 ps=0 b=0 m=1
R$1279 \$131 \$159 VSS|vss 4 rppd l=1.2 ps=0 b=0 m=1
R$1280 \$132 \$160 VSS|vss 4 rppd l=1.2 ps=0 b=0 m=1
R$1281 \$133 \$161 VSS|vss 4 rppd l=1.2 ps=0 b=0 m=1
R$1282 \$136 \$163 VSS|vss 4 rppd l=1.2 ps=0 b=0 m=1
R$1283 \$137 \$166 VSS|vss 4 rppd l=1.2 ps=0 b=0 m=1
R$1284 \$140 \$167 VSS|vss 4 rppd l=1.2 ps=0 b=0 m=1
R$1285 \$141 \$169 VSS|vss 4 rppd l=1.2 ps=0 b=0 m=1
R$1286 \$142 \$170 VSS|vss 4 rppd l=1.2 ps=0 b=0 m=1
R$1287 \$143 \$171 VSS|vss 4 rppd l=1.2 ps=0 b=0 m=1
R$1288 \$144 \$172 VSS|vss 4 rppd l=1.2 ps=0 b=0 m=1
R$1289 \$156 \$173 VSS|vss 4 rppd l=1.2 ps=0 b=0 m=1
R$1290 \$145 \$174 VSS|vss 4 rppd l=1.2 ps=0 b=0 m=1
R$1291 \$147 \$176 VSS|vss 4 rppd l=1.2 ps=0 b=0 m=1
R$1292 \$149 \$179 VSS|vss 4 rppd l=1.2 ps=0 b=0 m=1
R$1293 \$152 \$180 VSS|vss 4 rppd l=1.2 ps=0 b=0 m=1
R$1294 \$153 \$182 VSS|vss 4 rppd l=1.2 ps=0 b=0 m=1
R$1295 \$157 \$183 VSS|vss 4 rppd l=1.2 ps=0 b=0 m=1
R$1296 \$158 \$184 VSS|vss 4 rppd l=1.2 ps=0 b=0 m=1
R$1297 \$159 \$185 VSS|vss 4 rppd l=1.2 ps=0 b=0 m=1
R$1298 \$160 \$186 VSS|vss 4 rppd l=1.2 ps=0 b=0 m=1
R$1299 \$161 \$187 VSS|vss 4 rppd l=1.2 ps=0 b=0 m=1
R$1300 \$163 \$191 VSS|vss 4 rppd l=1.2 ps=0 b=0 m=1
R$1301 \$166 \$192 VSS|vss 4 rppd l=1.2 ps=0 b=0 m=1
R$1302 \$167 \$196 VSS|vss 4 rppd l=1.2 ps=0 b=0 m=1
R$1303 \$169 \$197 VSS|vss 4 rppd l=1.2 ps=0 b=0 m=1
R$1304 \$170 \$198 VSS|vss 4 rppd l=1.2 ps=0 b=0 m=1
R$1305 \$171 \$199 VSS|vss 4 rppd l=1.2 ps=0 b=0 m=1
R$1306 \$172 \$200 VSS|vss 4 rppd l=1.2 ps=0 b=0 m=1
R$1307 \$173 \$201 VSS|vss 4 rppd l=1.2 ps=0 b=0 m=1
R$1308 \$174 \$202 VSS|vss 4 rppd l=1.2 ps=0 b=0 m=1
R$1309 \$176 \$206 VSS|vss 4 rppd l=1.2 ps=0 b=0 m=1
R$1310 \$179 \$207 VSS|vss 4 rppd l=1.2 ps=0 b=0 m=1
R$1311 \$180 \$211 VSS|vss 4 rppd l=1.2 ps=0 b=0 m=1
R$1312 \$182 \$212 VSS|vss 4 rppd l=1.2 ps=0 b=0 m=1
R$1313 \$183 \$213 VSS|vss 4 rppd l=1.2 ps=0 b=0 m=1
R$1314 \$184 \$214 VSS|vss 4 rppd l=1.2 ps=0 b=0 m=1
R$1315 \$185 \$215 VSS|vss 4 rppd l=1.2 ps=0 b=0 m=1
R$1316 \$186 \$216 VSS|vss 4 rppd l=1.2 ps=0 b=0 m=1
R$1317 \$187 \$218 VSS|vss 4 rppd l=1.2 ps=0 b=0 m=1
R$1318 \$191 \$219 VSS|vss 4 rppd l=1.2 ps=0 b=0 m=1
R$1319 \$192 \$222 VSS|vss 4 rppd l=1.2 ps=0 b=0 m=1
R$1320 \$196 \$224 VSS|vss 4 rppd l=1.2 ps=0 b=0 m=1
R$1321 \$197 \$227 VSS|vss 4 rppd l=1.2 ps=0 b=0 m=1
R$1322 \$198 \$228 VSS|vss 4 rppd l=1.2 ps=0 b=0 m=1
R$1323 \$199 \$229 VSS|vss 4 rppd l=1.2 ps=0 b=0 m=1
R$1324 \$200 \$230 VSS|vss 4 rppd l=1.2 ps=0 b=0 m=1
R$1325 \$201 \$231 VSS|vss 4 rppd l=1.2 ps=0 b=0 m=1
R$1326 \$202 \$233 VSS|vss 4 rppd l=1.2 ps=0 b=0 m=1
R$1327 \$206 \$234 VSS|vss 4 rppd l=1.2 ps=0 b=0 m=1
R$1328 \$207 \$238 VSS|vss 4 rppd l=1.2 ps=0 b=0 m=1
R$1329 \$211 \$239 VSS|vss 4 rppd l=1.2 ps=0 b=0 m=1
R$1330 \$212 \$242 VSS|vss 4 rppd l=1.2 ps=0 b=0 m=1
R$1331 \$213 \$247 VSS|vss 4 rppd l=1.2 ps=0 b=0 m=1
R$1332 \$214 \$248 VSS|vss 4 rppd l=1.2 ps=0 b=0 m=1
R$1333 \$215 \$249 VSS|vss 4 rppd l=1.2 ps=0 b=0 m=1
R$1334 \$216 \$250 VSS|vss 4 rppd l=1.2 ps=0 b=0 m=1
R$1335 \$218 \$251 VSS|vss 4 rppd l=1.2 ps=0 b=0 m=1
R$1336 \$219 \$252 VSS|vss 4 rppd l=1.2 ps=0 b=0 m=1
R$1337 \$222 \$253 VSS|vss 4 rppd l=1.2 ps=0 b=0 m=1
R$1338 \$224 \$254 VSS|vss 4 rppd l=1.2 ps=0 b=0 m=1
R$1339 \$227 \$255 VSS|vss 4 rppd l=1.2 ps=0 b=0 m=1
R$1340 \$228 \$256 VSS|vss 4 rppd l=1.2 ps=0 b=0 m=1
R$1341 \$229 \$257 VSS|vss 4 rppd l=1.2 ps=0 b=0 m=1
R$1342 \$230 \$258 VSS|vss 4 rppd l=1.2 ps=0 b=0 m=1
R$1343 \$231 \$259 VSS|vss 4 rppd l=1.2 ps=0 b=0 m=1
R$1344 \$233 \$260 VSS|vss 4 rppd l=1.2 ps=0 b=0 m=1
R$1345 \$234 \$261 VSS|vss 4 rppd l=1.2 ps=0 b=0 m=1
R$1346 \$238 \$262 VSS|vss 4 rppd l=1.2 ps=0 b=0 m=1
R$1347 \$239 \$263 VSS|vss 4 rppd l=1.2 ps=0 b=0 m=1
R$1348 \$242 \$264 VSS|vss 4 rppd l=1.2 ps=0 b=0 m=1
R$1349 \$247 \$269 VSS|vss 4 rppd l=1.2 ps=0 b=0 m=1
R$1350 \$248 \$270 VSS|vss 4 rppd l=1.2 ps=0 b=0 m=1
R$1351 \$249 \$271 VSS|vss 4 rppd l=1.2 ps=0 b=0 m=1
R$1352 \$250 \$272 VSS|vss 4 rppd l=1.2 ps=0 b=0 m=1
R$1353 \$251 \$273 VSS|vss 4 rppd l=1.2 ps=0 b=0 m=1
R$1354 \$252 \$274 VSS|vss 4 rppd l=1.2 ps=0 b=0 m=1
R$1355 \$253 \$275 VSS|vss 4 rppd l=1.2 ps=0 b=0 m=1
R$1356 \$254 \$276 VSS|vss 4 rppd l=1.2 ps=0 b=0 m=1
R$1357 \$255 \$277 VSS|vss 4 rppd l=1.2 ps=0 b=0 m=1
R$1358 \$256 \$278 VSS|vss 4 rppd l=1.2 ps=0 b=0 m=1
R$1359 \$257 \$279 VSS|vss 4 rppd l=1.2 ps=0 b=0 m=1
R$1360 \$258 \$280 VSS|vss 4 rppd l=1.2 ps=0 b=0 m=1
R$1361 \$259 \$281 VSS|vss 4 rppd l=1.2 ps=0 b=0 m=1
R$1362 \$260 \$282 VSS|vss 4 rppd l=1.2 ps=0 b=0 m=1
R$1363 \$261 \$283 VSS|vss 4 rppd l=1.2 ps=0 b=0 m=1
R$1364 \$262 \$284 VSS|vss 4 rppd l=1.2 ps=0 b=0 m=1
R$1365 \$263 \$285 VSS|vss 4 rppd l=1.2 ps=0 b=0 m=1
R$1366 \$264 \$286 VSS|vss 4 rppd l=1.2 ps=0 b=0 m=1
R$1367 \$269 \$295 VSS|vss 4 rppd l=1.2 ps=0 b=0 m=1
R$1368 \$270 \$296 VSS|vss 4 rppd l=1.2 ps=0 b=0 m=1
R$1369 \$271 \$297 VSS|vss 4 rppd l=1.2 ps=0 b=0 m=1
R$1370 \$272 \$298 VSS|vss 4 rppd l=1.2 ps=0 b=0 m=1
R$1371 \$273 \$299 VSS|vss 4 rppd l=1.2 ps=0 b=0 m=1
R$1372 \$274 \$301 VSS|vss 4 rppd l=1.2 ps=0 b=0 m=1
R$1373 \$275 \$302 VSS|vss 4 rppd l=1.2 ps=0 b=0 m=1
R$1374 \$276 \$304 VSS|vss 4 rppd l=1.2 ps=0 b=0 m=1
R$1375 \$277 \$305 VSS|vss 4 rppd l=1.2 ps=0 b=0 m=1
R$1376 \$278 \$306 VSS|vss 4 rppd l=1.2 ps=0 b=0 m=1
R$1377 \$279 \$307 VSS|vss 4 rppd l=1.2 ps=0 b=0 m=1
R$1378 \$280 \$308 VSS|vss 4 rppd l=1.2 ps=0 b=0 m=1
R$1379 \$281 \$309 VSS|vss 4 rppd l=1.2 ps=0 b=0 m=1
R$1380 \$282 \$310 VSS|vss 4 rppd l=1.2 ps=0 b=0 m=1
R$1381 \$283 \$312 VSS|vss 4 rppd l=1.2 ps=0 b=0 m=1
R$1382 \$284 \$313 VSS|vss 4 rppd l=1.2 ps=0 b=0 m=1
R$1383 \$285 \$315 VSS|vss 4 rppd l=1.2 ps=0 b=0 m=1
R$1384 \$286 \$316 VSS|vss 4 rppd l=1.2 ps=0 b=0 m=1
R$1385 \$295 \$325 VSS|vss 4 rppd l=1.2 ps=0 b=0 m=1
R$1386 \$296 \$326 VSS|vss 4 rppd l=1.2 ps=0 b=0 m=1
R$1387 \$297 \$327 VSS|vss 4 rppd l=1.2 ps=0 b=0 m=1
R$1388 \$298 \$328 VSS|vss 4 rppd l=1.2 ps=0 b=0 m=1
R$1389 \$299 \$329 VSS|vss 4 rppd l=1.2 ps=0 b=0 m=1
R$1390 \$301 \$330 VSS|vss 4 rppd l=1.2 ps=0 b=0 m=1
R$1391 \$302 \$332 VSS|vss 4 rppd l=1.2 ps=0 b=0 m=1
R$1392 \$304 \$333 VSS|vss 4 rppd l=1.2 ps=0 b=0 m=1
R$1393 \$305 \$335 VSS|vss 4 rppd l=1.2 ps=0 b=0 m=1
R$1394 \$306 \$336 VSS|vss 4 rppd l=1.2 ps=0 b=0 m=1
R$1395 \$307 \$337 VSS|vss 4 rppd l=1.2 ps=0 b=0 m=1
R$1396 \$308 \$338 VSS|vss 4 rppd l=1.2 ps=0 b=0 m=1
R$1397 \$309 \$339 VSS|vss 4 rppd l=1.2 ps=0 b=0 m=1
R$1398 \$310 \$340 VSS|vss 4 rppd l=1.2 ps=0 b=0 m=1
R$1399 \$312 \$341 VSS|vss 4 rppd l=1.2 ps=0 b=0 m=1
R$1400 \$313 \$343 VSS|vss 4 rppd l=1.2 ps=0 b=0 m=1
R$1401 \$315 \$344 VSS|vss 4 rppd l=1.2 ps=0 b=0 m=1
R$1402 \$316 \$346 VSS|vss 4 rppd l=1.2 ps=0 b=0 m=1
R$1403 \$325 \$347 VSS|vss 4 rppd l=1.2 ps=0 b=0 m=1
R$1404 \$326 \$348 VSS|vss 4 rppd l=1.2 ps=0 b=0 m=1
R$1405 \$327 \$349 VSS|vss 4 rppd l=1.2 ps=0 b=0 m=1
R$1406 \$328 \$350 VSS|vss 4 rppd l=1.2 ps=0 b=0 m=1
R$1407 \$329 \$351 VSS|vss 4 rppd l=1.2 ps=0 b=0 m=1
R$1408 \$330 \$354 VSS|vss 4 rppd l=1.2 ps=0 b=0 m=1
R$1409 \$332 \$355 VSS|vss 4 rppd l=1.2 ps=0 b=0 m=1
R$1410 \$333 \$358 VSS|vss 4 rppd l=1.2 ps=0 b=0 m=1
R$1411 \$335 \$359 VSS|vss 4 rppd l=1.2 ps=0 b=0 m=1
R$1412 \$336 \$360 VSS|vss 4 rppd l=1.2 ps=0 b=0 m=1
R$1413 \$337 \$361 VSS|vss 4 rppd l=1.2 ps=0 b=0 m=1
R$1414 \$338 \$362 VSS|vss 4 rppd l=1.2 ps=0 b=0 m=1
R$1415 \$339 \$363 VSS|vss 4 rppd l=1.2 ps=0 b=0 m=1
R$1416 \$340 \$364 VSS|vss 4 rppd l=1.2 ps=0 b=0 m=1
R$1417 \$341 \$366 VSS|vss 4 rppd l=1.2 ps=0 b=0 m=1
R$1418 \$343 \$368 VSS|vss 4 rppd l=1.2 ps=0 b=0 m=1
R$1419 \$344 \$371 VSS|vss 4 rppd l=1.2 ps=0 b=0 m=1
R$1420 \$346 \$372 VSS|vss 4 rppd l=1.2 ps=0 b=0 m=1
R$1421 \$347 \$381 VSS|vss 4 rppd l=1.2 ps=0 b=0 m=1
R$1422 \$348 \$382 VSS|vss 4 rppd l=1.2 ps=0 b=0 m=1
R$1423 \$349 \$383 VSS|vss 4 rppd l=1.2 ps=0 b=0 m=1
R$1424 \$350 \$384 VSS|vss 4 rppd l=1.2 ps=0 b=0 m=1
R$1425 \$351 \$385 VSS|vss 4 rppd l=1.2 ps=0 b=0 m=1
R$1426 \$354 \$386 VSS|vss 4 rppd l=1.2 ps=0 b=0 m=1
R$1427 \$355 \$387 VSS|vss 4 rppd l=1.2 ps=0 b=0 m=1
R$1428 \$358 \$388 VSS|vss 4 rppd l=1.2 ps=0 b=0 m=1
R$1429 \$359 \$389 VSS|vss 4 rppd l=1.2 ps=0 b=0 m=1
R$1430 \$360 \$390 VSS|vss 4 rppd l=1.2 ps=0 b=0 m=1
R$1431 \$361 \$391 VSS|vss 4 rppd l=1.2 ps=0 b=0 m=1
R$1432 \$362 \$392 VSS|vss 4 rppd l=1.2 ps=0 b=0 m=1
R$1433 \$363 \$393 VSS|vss 4 rppd l=1.2 ps=0 b=0 m=1
R$1434 \$364 \$394 VSS|vss 4 rppd l=1.2 ps=0 b=0 m=1
R$1435 \$366 \$395 VSS|vss 4 rppd l=1.2 ps=0 b=0 m=1
R$1436 \$368 \$396 VSS|vss 4 rppd l=1.2 ps=0 b=0 m=1
R$1437 \$371 \$397 VSS|vss 4 rppd l=1.2 ps=0 b=0 m=1
R$1438 \$372 \$398 VSS|vss 4 rppd l=1.2 ps=0 b=0 m=1
R$1439 \$381 \$403 VSS|vss 4 rppd l=1.2 ps=0 b=0 m=1
R$1440 \$382 \$404 VSS|vss 4 rppd l=1.2 ps=0 b=0 m=1
R$1441 \$383 \$405 VSS|vss 4 rppd l=1.2 ps=0 b=0 m=1
R$1442 \$384 \$406 VSS|vss 4 rppd l=1.2 ps=0 b=0 m=1
R$1443 \$385 \$407 VSS|vss 4 rppd l=1.2 ps=0 b=0 m=1
R$1444 \$386 \$409 VSS|vss 4 rppd l=1.2 ps=0 b=0 m=1
R$1445 \$387 \$410 VSS|vss 4 rppd l=1.2 ps=0 b=0 m=1
R$1446 \$388 \$412 VSS|vss 4 rppd l=1.2 ps=0 b=0 m=1
R$1447 \$389 \$413 VSS|vss 4 rppd l=1.2 ps=0 b=0 m=1
R$1448 \$390 \$414 VSS|vss 4 rppd l=1.2 ps=0 b=0 m=1
R$1449 \$391 \$415 VSS|vss 4 rppd l=1.2 ps=0 b=0 m=1
R$1450 \$392 \$416 VSS|vss 4 rppd l=1.2 ps=0 b=0 m=1
R$1451 \$393 \$417 VSS|vss 4 rppd l=1.2 ps=0 b=0 m=1
R$1452 \$394 \$418 VSS|vss 4 rppd l=1.2 ps=0 b=0 m=1
R$1453 \$395 \$420 VSS|vss 4 rppd l=1.2 ps=0 b=0 m=1
R$1454 \$396 \$421 VSS|vss 4 rppd l=1.2 ps=0 b=0 m=1
R$1455 \$397 \$423 VSS|vss 4 rppd l=1.2 ps=0 b=0 m=1
R$1456 \$398 \$424 VSS|vss 4 rppd l=1.2 ps=0 b=0 m=1
R$1457 \$403 \$429 VSS|vss 4 rppd l=1.2 ps=0 b=0 m=1
R$1458 \$404 \$430 VSS|vss 4 rppd l=1.2 ps=0 b=0 m=1
R$1459 \$405 \$431 VSS|vss 4 rppd l=1.2 ps=0 b=0 m=1
R$1460 \$406 \$432 VSS|vss 4 rppd l=1.2 ps=0 b=0 m=1
R$1461 \$407 \$433 VSS|vss 4 rppd l=1.2 ps=0 b=0 m=1
R$1462 \$409 \$434 VSS|vss 4 rppd l=1.2 ps=0 b=0 m=1
R$1463 \$410 \$436 VSS|vss 4 rppd l=1.2 ps=0 b=0 m=1
R$1464 \$412 \$437 VSS|vss 4 rppd l=1.2 ps=0 b=0 m=1
R$1465 \$413 \$439 VSS|vss 4 rppd l=1.2 ps=0 b=0 m=1
R$1466 \$414 \$440 VSS|vss 4 rppd l=1.2 ps=0 b=0 m=1
R$1467 \$415 \$441 VSS|vss 4 rppd l=1.2 ps=0 b=0 m=1
R$1468 \$416 \$442 VSS|vss 4 rppd l=1.2 ps=0 b=0 m=1
R$1469 \$417 \$443 VSS|vss 4 rppd l=1.2 ps=0 b=0 m=1
R$1470 \$418 \$444 VSS|vss 4 rppd l=1.2 ps=0 b=0 m=1
R$1471 \$420 \$445 VSS|vss 4 rppd l=1.2 ps=0 b=0 m=1
R$1472 \$421 \$447 VSS|vss 4 rppd l=1.2 ps=0 b=0 m=1
R$1473 \$423 \$448 VSS|vss 4 rppd l=1.2 ps=0 b=0 m=1
R$1474 \$424 \$450 VSS|vss 4 rppd l=1.2 ps=0 b=0 m=1
R$1475 \$429 \$455 VSS|vss 4 rppd l=1.2 ps=0 b=0 m=1
R$1476 \$430 \$456 VSS|vss 4 rppd l=1.2 ps=0 b=0 m=1
R$1477 \$431 \$457 VSS|vss 4 rppd l=1.2 ps=0 b=0 m=1
R$1478 \$432 \$458 VSS|vss 4 rppd l=1.2 ps=0 b=0 m=1
R$1479 \$433 \$459 VSS|vss 4 rppd l=1.2 ps=0 b=0 m=1
R$1480 \$434 \$460 VSS|vss 4 rppd l=1.2 ps=0 b=0 m=1
R$1481 \$436 \$461 VSS|vss 4 rppd l=1.2 ps=0 b=0 m=1
R$1482 \$437 \$462 VSS|vss 4 rppd l=1.2 ps=0 b=0 m=1
R$1483 \$439 \$463 VSS|vss 4 rppd l=1.2 ps=0 b=0 m=1
R$1484 \$440 \$464 VSS|vss 4 rppd l=1.2 ps=0 b=0 m=1
R$1485 \$441 \$465 VSS|vss 4 rppd l=1.2 ps=0 b=0 m=1
R$1486 \$442 \$466 VSS|vss 4 rppd l=1.2 ps=0 b=0 m=1
R$1487 \$443 \$467 VSS|vss 4 rppd l=1.2 ps=0 b=0 m=1
R$1488 \$444 \$468 VSS|vss 4 rppd l=1.2 ps=0 b=0 m=1
R$1489 \$445 \$469 VSS|vss 4 rppd l=1.2 ps=0 b=0 m=1
R$1490 \$447 \$470 VSS|vss 4 rppd l=1.2 ps=0 b=0 m=1
R$1491 \$448 \$471 VSS|vss 4 rppd l=1.2 ps=0 b=0 m=1
R$1492 \$450 \$472 VSS|vss 4 rppd l=1.2 ps=0 b=0 m=1
R$1493 \$455 \$477 VSS|vss 4 rppd l=1.2 ps=0 b=0 m=1
R$1494 \$456 \$478 VSS|vss 4 rppd l=1.2 ps=0 b=0 m=1
R$1495 \$457 \$479 VSS|vss 4 rppd l=1.2 ps=0 b=0 m=1
R$1496 \$458 \$480 VSS|vss 4 rppd l=1.2 ps=0 b=0 m=1
R$1497 \$459 \$481 VSS|vss 4 rppd l=1.2 ps=0 b=0 m=1
R$1498 \$460 \$482 VSS|vss 4 rppd l=1.2 ps=0 b=0 m=1
R$1499 \$461 \$483 VSS|vss 4 rppd l=1.2 ps=0 b=0 m=1
R$1500 \$462 \$484 VSS|vss 4 rppd l=1.2 ps=0 b=0 m=1
R$1501 \$463 \$485 VSS|vss 4 rppd l=1.2 ps=0 b=0 m=1
R$1502 \$464 \$486 VSS|vss 4 rppd l=1.2 ps=0 b=0 m=1
R$1503 \$465 \$487 VSS|vss 4 rppd l=1.2 ps=0 b=0 m=1
R$1504 \$466 \$488 VSS|vss 4 rppd l=1.2 ps=0 b=0 m=1
R$1505 \$467 \$489 VSS|vss 4 rppd l=1.2 ps=0 b=0 m=1
R$1506 \$468 \$490 VSS|vss 4 rppd l=1.2 ps=0 b=0 m=1
R$1507 \$469 \$491 VSS|vss 4 rppd l=1.2 ps=0 b=0 m=1
R$1508 \$470 \$492 VSS|vss 4 rppd l=1.2 ps=0 b=0 m=1
R$1509 \$471 \$493 VSS|vss 4 rppd l=1.2 ps=0 b=0 m=1
R$1510 \$472 \$494 VSS|vss 4 rppd l=1.2 ps=0 b=0 m=1
R$1511 \$477 \$495 VSS|vss 4 rppd l=1.2 ps=0 b=0 m=1
R$1512 \$478 \$496 VSS|vss 4 rppd l=1.2 ps=0 b=0 m=1
R$1513 \$479 \$497 VSS|vss 4 rppd l=1.2 ps=0 b=0 m=1
R$1514 \$480 \$498 VSS|vss 4 rppd l=1.2 ps=0 b=0 m=1
R$1515 \$481 \$499 VSS|vss 4 rppd l=1.2 ps=0 b=0 m=1
R$1516 \$482 \$503 VSS|vss 4 rppd l=1.2 ps=0 b=0 m=1
R$1517 \$483 \$504 VSS|vss 4 rppd l=1.2 ps=0 b=0 m=1
R$1518 \$484 \$508 VSS|vss 4 rppd l=1.2 ps=0 b=0 m=1
R$1519 \$485 \$509 VSS|vss 4 rppd l=1.2 ps=0 b=0 m=1
R$1520 \$486 \$510 VSS|vss 4 rppd l=1.2 ps=0 b=0 m=1
R$1521 \$487 \$511 VSS|vss 4 rppd l=1.2 ps=0 b=0 m=1
R$1522 \$488 \$512 VSS|vss 4 rppd l=1.2 ps=0 b=0 m=1
R$1523 \$489 \$513 VSS|vss 4 rppd l=1.2 ps=0 b=0 m=1
R$1524 \$490 \$514 VSS|vss 4 rppd l=1.2 ps=0 b=0 m=1
R$1525 \$491 \$518 VSS|vss 4 rppd l=1.2 ps=0 b=0 m=1
R$1526 \$492 \$519 VSS|vss 4 rppd l=1.2 ps=0 b=0 m=1
R$1527 \$493 \$523 VSS|vss 4 rppd l=1.2 ps=0 b=0 m=1
R$1528 \$494 \$524 VSS|vss 4 rppd l=1.2 ps=0 b=0 m=1
R$1529 \$495 \$533 VSS|vss 4 rppd l=1.2 ps=0 b=0 m=1
R$1530 \$496 \$534 VSS|vss 4 rppd l=1.2 ps=0 b=0 m=1
R$1531 \$497 \$535 VSS|vss 4 rppd l=1.2 ps=0 b=0 m=1
R$1532 \$498 \$536 VSS|vss 4 rppd l=1.2 ps=0 b=0 m=1
R$1533 \$499 \$537 VSS|vss 4 rppd l=1.2 ps=0 b=0 m=1
R$1534 \$503 \$538 VSS|vss 4 rppd l=1.2 ps=0 b=0 m=1
R$1535 \$504 \$540 VSS|vss 4 rppd l=1.2 ps=0 b=0 m=1
R$1536 \$508 \$541 VSS|vss 4 rppd l=1.2 ps=0 b=0 m=1
R$1537 \$509 \$543 VSS|vss 4 rppd l=1.2 ps=0 b=0 m=1
R$1538 \$510 \$544 VSS|vss 4 rppd l=1.2 ps=0 b=0 m=1
R$1539 \$511 \$545 VSS|vss 4 rppd l=1.2 ps=0 b=0 m=1
R$1540 \$512 \$546 VSS|vss 4 rppd l=1.2 ps=0 b=0 m=1
R$1541 \$513 \$547 VSS|vss 4 rppd l=1.2 ps=0 b=0 m=1
R$1542 \$514 \$548 VSS|vss 4 rppd l=1.2 ps=0 b=0 m=1
R$1543 \$518 \$549 VSS|vss 4 rppd l=1.2 ps=0 b=0 m=1
R$1544 \$519 \$551 VSS|vss 4 rppd l=1.2 ps=0 b=0 m=1
R$1545 \$523 \$552 VSS|vss 4 rppd l=1.2 ps=0 b=0 m=1
R$1546 \$524 \$554 VSS|vss 4 rppd l=1.2 ps=0 b=0 m=1
R$1547 \$533 \$563 VSS|vss 4 rppd l=1.2 ps=0 b=0 m=1
R$1548 \$534 \$564 VSS|vss 4 rppd l=1.2 ps=0 b=0 m=1
R$1549 \$535 \$565 VSS|vss 4 rppd l=1.2 ps=0 b=0 m=1
R$1550 \$536 \$566 VSS|vss 4 rppd l=1.2 ps=0 b=0 m=1
R$1551 \$537 \$567 VSS|vss 4 rppd l=1.2 ps=0 b=0 m=1
R$1552 \$538 \$568 VSS|vss 4 rppd l=1.2 ps=0 b=0 m=1
R$1553 \$540 \$569 VSS|vss 4 rppd l=1.2 ps=0 b=0 m=1
R$1554 \$541 \$570 VSS|vss 4 rppd l=1.2 ps=0 b=0 m=1
R$1555 \$543 \$571 VSS|vss 4 rppd l=1.2 ps=0 b=0 m=1
R$1556 \$544 \$572 VSS|vss 4 rppd l=1.2 ps=0 b=0 m=1
R$1557 \$545 \$573 VSS|vss 4 rppd l=1.2 ps=0 b=0 m=1
R$1558 \$546 \$574 VSS|vss 4 rppd l=1.2 ps=0 b=0 m=1
R$1559 \$547 \$575 VSS|vss 4 rppd l=1.2 ps=0 b=0 m=1
R$1560 \$548 \$576 VSS|vss 4 rppd l=1.2 ps=0 b=0 m=1
R$1561 \$549 \$577 VSS|vss 4 rppd l=1.2 ps=0 b=0 m=1
R$1562 \$551 \$578 VSS|vss 4 rppd l=1.2 ps=0 b=0 m=1
R$1563 \$552 \$579 VSS|vss 4 rppd l=1.2 ps=0 b=0 m=1
R$1564 \$554 \$588 VSS|vss 4 rppd l=1.2 ps=0 b=0 m=1
R$1565 \$563 \$589 VSS|vss 4 rppd l=1.2 ps=0 b=0 m=1
R$1566 \$564 \$590 VSS|vss 4 rppd l=1.2 ps=0 b=0 m=1
R$1567 \$565 \$605 VSS|vss 4 rppd l=1.2 ps=0 b=0 m=1
R$1568 \$566 \$591 VSS|vss 4 rppd l=1.2 ps=0 b=0 m=1
R$1569 \$567 \$592 VSS|vss 4 rppd l=1.2 ps=0 b=0 m=1
R$1570 \$568 \$593 VSS|vss 4 rppd l=1.2 ps=0 b=0 m=1
R$1571 \$569 \$594 VSS|vss 4 rppd l=1.2 ps=0 b=0 m=1
R$1572 \$570 \$595 VSS|vss 4 rppd l=1.2 ps=0 b=0 m=1
R$1573 \$571 VREF|vref VSS|vss 4 rppd l=1.2 ps=0 b=0 m=1
R$1574 \$572 \$597 VSS|vss 4 rppd l=1.2 ps=0 b=0 m=1
R$1575 \$573 \$598 VSS|vss 4 rppd l=1.2 ps=0 b=0 m=1
R$1576 \$574 \$599 VSS|vss 4 rppd l=1.2 ps=0 b=0 m=1
R$1577 \$575 \$600 VSS|vss 4 rppd l=1.2 ps=0 b=0 m=1
R$1578 \$576 \$601 VSS|vss 4 rppd l=1.2 ps=0 b=0 m=1
R$1579 \$577 \$602 VSS|vss 4 rppd l=1.2 ps=0 b=0 m=1
R$1580 \$578 \$603 VSS|vss 4 rppd l=1.2 ps=0 b=0 m=1
R$1581 \$579 \$604 VSS|vss 4 rppd l=1.2 ps=0 b=0 m=1
R$1582 \$588 VREF|vref VSS|vss 4 rppd l=1.2 ps=0 b=0 m=1
R$1583 \$589 \$614 VSS|vss 4 rppd l=1.2 ps=0 b=0 m=1
R$1584 \$590 \$615 VSS|vss 4 rppd l=1.2 ps=0 b=0 m=1
R$1585 \$605 \$616 VSS|vss 4 rppd l=1.2 ps=0 b=0 m=1
R$1586 \$591 \$617 VSS|vss 4 rppd l=1.2 ps=0 b=0 m=1
R$1587 \$592 \$618 VSS|vss 4 rppd l=1.2 ps=0 b=0 m=1
R$1588 \$593 \$620 VSS|vss 4 rppd l=1.2 ps=0 b=0 m=1
R$1589 \$594 \$621 VSS|vss 4 rppd l=1.2 ps=0 b=0 m=1
R$1590 \$595 \$623 VSS|vss 4 rppd l=1.2 ps=0 b=0 m=1
R$1591 \$597 \$624 VSS|vss 4 rppd l=1.2 ps=0 b=0 m=1
R$1592 \$598 \$625 VSS|vss 4 rppd l=1.2 ps=0 b=0 m=1
R$1593 \$599 \$626 VSS|vss 4 rppd l=1.2 ps=0 b=0 m=1
R$1594 \$600 \$627 VSS|vss 4 rppd l=1.2 ps=0 b=0 m=1
R$1595 \$601 \$628 VSS|vss 4 rppd l=1.2 ps=0 b=0 m=1
R$1596 \$602 \$630 VSS|vss 4 rppd l=1.2 ps=0 b=0 m=1
R$1597 \$603 \$631 VSS|vss 4 rppd l=1.2 ps=0 b=0 m=1
R$1598 \$604 \$633 VSS|vss 4 rppd l=1.2 ps=0 b=0 m=1
R$1599 \$614 \$634 VSS|vss 4 rppd l=1.2 ps=0 b=0 m=1
R$1600 \$615 \$635 VSS|vss 4 rppd l=1.2 ps=0 b=0 m=1
R$1601 \$616 \$636 VSS|vss 4 rppd l=1.2 ps=0 b=0 m=1
R$1602 \$617 \$637 VSS|vss 4 rppd l=1.2 ps=0 b=0 m=1
R$1603 \$618 \$639 VSS|vss 4 rppd l=1.2 ps=0 b=0 m=1
R$1604 \$620 \$640 VSS|vss 4 rppd l=1.2 ps=0 b=0 m=1
R$1605 \$621 \$644 VSS|vss 4 rppd l=1.2 ps=0 b=0 m=1
R$1606 \$623 \$645 VSS|vss 4 rppd l=1.2 ps=0 b=0 m=1
R$1607 \$624 \$648 VSS|vss 4 rppd l=1.2 ps=0 b=0 m=1
R$1608 \$625 \$649 VSS|vss 4 rppd l=1.2 ps=0 b=0 m=1
R$1609 \$626 \$650 VSS|vss 4 rppd l=1.2 ps=0 b=0 m=1
R$1610 \$627 \$651 VSS|vss 4 rppd l=1.2 ps=0 b=0 m=1
R$1611 \$628 \$653 VSS|vss 4 rppd l=1.2 ps=0 b=0 m=1
R$1612 \$630 \$654 VSS|vss 4 rppd l=1.2 ps=0 b=0 m=1
R$1613 \$631 \$658 VSS|vss 4 rppd l=1.2 ps=0 b=0 m=1
R$1614 \$633 \$659 VSS|vss 4 rppd l=1.2 ps=0 b=0 m=1
R$1615 \$634 \$666 VSS|vss 4 rppd l=1.2 ps=0 b=0 m=1
R$1616 \$635 \$667 VSS|vss 4 rppd l=1.2 ps=0 b=0 m=1
R$1617 \$636 \$668 VSS|vss 4 rppd l=1.2 ps=0 b=0 m=1
R$1618 \$637 \$669 VSS|vss 4 rppd l=1.2 ps=0 b=0 m=1
R$1619 \$639 \$670 VSS|vss 4 rppd l=1.2 ps=0 b=0 m=1
R$1620 \$640 \$671 VSS|vss 4 rppd l=1.2 ps=0 b=0 m=1
R$1621 \$644 \$672 VSS|vss 4 rppd l=1.2 ps=0 b=0 m=1
R$1622 \$645 \$673 VSS|vss 4 rppd l=1.2 ps=0 b=0 m=1
R$1623 \$648 \$674 VSS|vss 4 rppd l=1.2 ps=0 b=0 m=1
R$1624 \$649 \$675 VSS|vss 4 rppd l=1.2 ps=0 b=0 m=1
R$1625 \$650 \$676 VSS|vss 4 rppd l=1.2 ps=0 b=0 m=1
R$1626 \$651 \$677 VSS|vss 4 rppd l=1.2 ps=0 b=0 m=1
R$1627 \$653 \$678 VSS|vss 4 rppd l=1.2 ps=0 b=0 m=1
R$1628 \$654 \$679 VSS|vss 4 rppd l=1.2 ps=0 b=0 m=1
R$1629 \$658 \$680 VSS|vss 4 rppd l=1.2 ps=0 b=0 m=1
R$1630 \$659 \$681 VSS|vss 4 rppd l=1.2 ps=0 b=0 m=1
R$1631 \$666 \$682 VSS|vss 4 rppd l=1.2 ps=0 b=0 m=1
R$1632 \$667 \$683 VSS|vss 4 rppd l=1.2 ps=0 b=0 m=1
R$1633 \$668 \$684 VSS|vss 4 rppd l=1.2 ps=0 b=0 m=1
R$1634 \$669 \$685 VSS|vss 4 rppd l=1.2 ps=0 b=0 m=1
R$1635 \$670 \$687 VSS|vss 4 rppd l=1.2 ps=0 b=0 m=1
R$1636 \$671 \$688 VSS|vss 4 rppd l=1.2 ps=0 b=0 m=1
R$1637 \$672 \$690 VSS|vss 4 rppd l=1.2 ps=0 b=0 m=1
R$1638 \$673 \$691 VSS|vss 4 rppd l=1.2 ps=0 b=0 m=1
R$1639 \$674 \$692 VSS|vss 4 rppd l=1.2 ps=0 b=0 m=1
R$1640 \$675 \$693 VSS|vss 4 rppd l=1.2 ps=0 b=0 m=1
R$1641 \$676 \$694 VSS|vss 4 rppd l=1.2 ps=0 b=0 m=1
R$1642 \$677 \$695 VSS|vss 4 rppd l=1.2 ps=0 b=0 m=1
R$1643 \$678 \$696 VSS|vss 4 rppd l=1.2 ps=0 b=0 m=1
R$1644 \$679 \$698 VSS|vss 4 rppd l=1.2 ps=0 b=0 m=1
R$1645 \$680 \$699 VSS|vss 4 rppd l=1.2 ps=0 b=0 m=1
R$1646 \$681 \$701 VSS|vss 4 rppd l=1.2 ps=0 b=0 m=1
R$1647 \$682 \$706 VSS|vss 4 rppd l=1.2 ps=0 b=0 m=1
R$1648 \$683 \$707 VSS|vss 4 rppd l=1.2 ps=0 b=0 m=1
R$1649 \$684 \$708 VSS|vss 4 rppd l=1.2 ps=0 b=0 m=1
R$1650 \$685 \$709 VSS|vss 4 rppd l=1.2 ps=0 b=0 m=1
R$1651 \$687 \$710 VSS|vss 4 rppd l=1.2 ps=0 b=0 m=1
R$1652 \$688 \$712 VSS|vss 4 rppd l=1.2 ps=0 b=0 m=1
R$1653 \$690 \$713 VSS|vss 4 rppd l=1.2 ps=0 b=0 m=1
R$1654 \$691 \$715 VSS|vss 4 rppd l=1.2 ps=0 b=0 m=1
R$1655 \$692 \$716 VSS|vss 4 rppd l=1.2 ps=0 b=0 m=1
R$1656 \$693 \$717 VSS|vss 4 rppd l=1.2 ps=0 b=0 m=1
R$1657 \$694 \$718 VSS|vss 4 rppd l=1.2 ps=0 b=0 m=1
R$1658 \$695 \$719 VSS|vss 4 rppd l=1.2 ps=0 b=0 m=1
R$1659 \$696 \$720 VSS|vss 4 rppd l=1.2 ps=0 b=0 m=1
R$1660 \$698 \$722 VSS|vss 4 rppd l=1.2 ps=0 b=0 m=1
R$1661 \$699 \$723 VSS|vss 4 rppd l=1.2 ps=0 b=0 m=1
R$1662 \$701 \$725 VSS|vss 4 rppd l=1.2 ps=0 b=0 m=1
R$1663 \$706 \$726 VSS|vss 4 rppd l=1.2 ps=0 b=0 m=1
R$1664 \$707 \$727 VSS|vss 4 rppd l=1.2 ps=0 b=0 m=1
R$1665 \$708 \$728 VSS|vss 4 rppd l=1.2 ps=0 b=0 m=1
R$1666 \$709 \$729 VSS|vss 4 rppd l=1.2 ps=0 b=0 m=1
R$1667 \$710 \$730 VSS|vss 4 rppd l=1.2 ps=0 b=0 m=1
R$1668 \$712 \$732 VSS|vss 4 rppd l=1.2 ps=0 b=0 m=1
R$1669 \$713 \$735 VSS|vss 4 rppd l=1.2 ps=0 b=0 m=1
R$1670 \$715 \$752 VSS|vss 4 rppd l=1.2 ps=0 b=0 m=1
R$1671 \$716 \$737 VSS|vss 4 rppd l=1.2 ps=0 b=0 m=1
R$1672 \$717 \$738 VSS|vss 4 rppd l=1.2 ps=0 b=0 m=1
R$1673 \$718 \$739 VSS|vss 4 rppd l=1.2 ps=0 b=0 m=1
R$1674 \$719 \$740 VSS|vss 4 rppd l=1.2 ps=0 b=0 m=1
R$1675 \$720 \$741 VSS|vss 4 rppd l=1.2 ps=0 b=0 m=1
R$1676 \$722 \$743 VSS|vss 4 rppd l=1.2 ps=0 b=0 m=1
R$1677 \$723 \$746 VSS|vss 4 rppd l=1.2 ps=0 b=0 m=1
R$1678 \$725 \$747 VSS|vss 4 rppd l=1.2 ps=0 b=0 m=1
R$1679 \$726 \$758 VSS|vss 4 rppd l=1.2 ps=0 b=0 m=1
R$1680 \$727 \$759 VSS|vss 4 rppd l=1.2 ps=0 b=0 m=1
R$1681 \$728 \$760 VSS|vss 4 rppd l=1.2 ps=0 b=0 m=1
R$1682 \$729 \$761 VSS|vss 4 rppd l=1.2 ps=0 b=0 m=1
R$1683 \$730 \$762 VSS|vss 4 rppd l=1.2 ps=0 b=0 m=1
R$1684 \$732 \$763 VSS|vss 4 rppd l=1.2 ps=0 b=0 m=1
R$1685 \$735 \$764 VSS|vss 4 rppd l=1.2 ps=0 b=0 m=1
R$1686 \$752 \$765 VSS|vss 4 rppd l=1.2 ps=0 b=0 m=1
R$1687 \$737 \$766 VSS|vss 4 rppd l=1.2 ps=0 b=0 m=1
R$1688 \$738 \$767 VSS|vss 4 rppd l=1.2 ps=0 b=0 m=1
R$1689 \$739 \$768 VSS|vss 4 rppd l=1.2 ps=0 b=0 m=1
R$1690 \$740 \$769 VSS|vss 4 rppd l=1.2 ps=0 b=0 m=1
R$1691 \$741 \$770 VSS|vss 4 rppd l=1.2 ps=0 b=0 m=1
R$1692 \$743 \$771 VSS|vss 4 rppd l=1.2 ps=0 b=0 m=1
R$1693 \$746 \$772 VSS|vss 4 rppd l=1.2 ps=0 b=0 m=1
R$1694 \$747 \$773 VSS|vss 4 rppd l=1.2 ps=0 b=0 m=1
R$1695 \$758 \$774 VSS|vss 4 rppd l=1.2 ps=0 b=0 m=1
R$1696 \$759 \$775 VSS|vss 4 rppd l=1.2 ps=0 b=0 m=1
R$1697 \$760 \$776 VSS|vss 4 rppd l=1.2 ps=0 b=0 m=1
R$1698 \$761 \$777 VSS|vss 4 rppd l=1.2 ps=0 b=0 m=1
R$1699 \$762 \$778 VSS|vss 4 rppd l=1.2 ps=0 b=0 m=1
R$1700 \$763 \$780 VSS|vss 4 rppd l=1.2 ps=0 b=0 m=1
R$1701 \$764 \$782 VSS|vss 4 rppd l=1.2 ps=0 b=0 m=1
R$1702 \$765 \$784 VSS|vss 4 rppd l=1.2 ps=0 b=0 m=1
R$1703 \$766 \$786 VSS|vss 4 rppd l=1.2 ps=0 b=0 m=1
R$1704 \$767 \$787 VSS|vss 4 rppd l=1.2 ps=0 b=0 m=1
R$1705 \$768 \$788 VSS|vss 4 rppd l=1.2 ps=0 b=0 m=1
R$1706 \$769 \$789 VSS|vss 4 rppd l=1.2 ps=0 b=0 m=1
R$1707 \$770 \$791 VSS|vss 4 rppd l=1.2 ps=0 b=0 m=1
R$1708 \$771 \$792 VSS|vss 4 rppd l=1.2 ps=0 b=0 m=1
R$1709 \$772 \$795 VSS|vss 4 rppd l=1.2 ps=0 b=0 m=1
R$1710 \$773 \$796 VSS|vss 4 rppd l=1.2 ps=0 b=0 m=1
R$1711 \$774 \$802 VSS|vss 4 rppd l=1.2 ps=0 b=0 m=1
R$1712 \$775 \$803 VSS|vss 4 rppd l=1.2 ps=0 b=0 m=1
R$1713 \$776 \$804 VSS|vss 4 rppd l=1.2 ps=0 b=0 m=1
R$1714 \$777 \$805 VSS|vss 4 rppd l=1.2 ps=0 b=0 m=1
R$1715 \$778 \$806 VSS|vss 4 rppd l=1.2 ps=0 b=0 m=1
R$1716 \$780 \$808 VSS|vss 4 rppd l=1.2 ps=0 b=0 m=1
R$1717 \$782 \$809 VSS|vss 4 rppd l=1.2 ps=0 b=0 m=1
R$1718 \$784 \$811 VSS|vss 4 rppd l=1.2 ps=0 b=0 m=1
R$1719 \$786 \$812 VSS|vss 4 rppd l=1.2 ps=0 b=0 m=1
R$1720 \$787 \$813 VSS|vss 4 rppd l=1.2 ps=0 b=0 m=1
R$1721 \$788 \$814 VSS|vss 4 rppd l=1.2 ps=0 b=0 m=1
R$1722 \$789 \$815 VSS|vss 4 rppd l=1.2 ps=0 b=0 m=1
R$1723 \$791 \$816 VSS|vss 4 rppd l=1.2 ps=0 b=0 m=1
R$1724 \$792 \$818 VSS|vss 4 rppd l=1.2 ps=0 b=0 m=1
R$1725 \$795 \$819 VSS|vss 4 rppd l=1.2 ps=0 b=0 m=1
R$1726 \$796 \$821 VSS|vss 4 rppd l=1.2 ps=0 b=0 m=1
R$1727 \$802 \$822 VSS|vss 4 rppd l=1.2 ps=0 b=0 m=1
R$1728 \$803 \$823 VSS|vss 4 rppd l=1.2 ps=0 b=0 m=1
R$1729 \$804 \$824 VSS|vss 4 rppd l=1.2 ps=0 b=0 m=1
R$1730 \$805 \$845 VSS|vss 4 rppd l=1.2 ps=0 b=0 m=1
R$1731 \$806 \$825 VSS|vss 4 rppd l=1.2 ps=0 b=0 m=1
R$1732 \$808 \$827 VSS|vss 4 rppd l=1.2 ps=0 b=0 m=1
R$1733 \$809 \$830 VSS|vss 4 rppd l=1.2 ps=0 b=0 m=1
R$1734 \$811 \$831 VSS|vss 4 rppd l=1.2 ps=0 b=0 m=1
R$1735 \$812 \$833 VSS|vss 4 rppd l=1.2 ps=0 b=0 m=1
R$1736 \$813 \$834 VSS|vss 4 rppd l=1.2 ps=0 b=0 m=1
R$1737 \$814 \$835 VSS|vss 4 rppd l=1.2 ps=0 b=0 m=1
R$1738 \$815 \$836 VSS|vss 4 rppd l=1.2 ps=0 b=0 m=1
R$1739 \$816 \$838 VSS|vss 4 rppd l=1.2 ps=0 b=0 m=1
R$1740 \$818 \$839 VSS|vss 4 rppd l=1.2 ps=0 b=0 m=1
R$1741 \$819 \$841 VSS|vss 4 rppd l=1.2 ps=0 b=0 m=1
R$1742 \$821 \$843 VSS|vss 4 rppd l=1.2 ps=0 b=0 m=1
R$1743 \$822 \$850 VSS|vss 4 rppd l=1.2 ps=0 b=0 m=1
R$1744 \$823 \$851 VSS|vss 4 rppd l=1.2 ps=0 b=0 m=1
R$1745 \$824 \$852 VSS|vss 4 rppd l=1.2 ps=0 b=0 m=1
R$1746 \$845 \$853 VSS|vss 4 rppd l=1.2 ps=0 b=0 m=1
R$1747 \$825 \$854 VSS|vss 4 rppd l=1.2 ps=0 b=0 m=1
R$1748 \$827 \$855 VSS|vss 4 rppd l=1.2 ps=0 b=0 m=1
R$1749 \$830 \$856 VSS|vss 4 rppd l=1.2 ps=0 b=0 m=1
R$1750 \$831 \$857 VSS|vss 4 rppd l=1.2 ps=0 b=0 m=1
R$1751 \$833 \$858 VSS|vss 4 rppd l=1.2 ps=0 b=0 m=1
R$1752 \$834 \$859 VSS|vss 4 rppd l=1.2 ps=0 b=0 m=1
R$1753 \$835 \$860 VSS|vss 4 rppd l=1.2 ps=0 b=0 m=1
R$1754 \$836 \$861 VSS|vss 4 rppd l=1.2 ps=0 b=0 m=1
R$1755 \$838 \$862 VSS|vss 4 rppd l=1.2 ps=0 b=0 m=1
R$1756 \$839 \$863 VSS|vss 4 rppd l=1.2 ps=0 b=0 m=1
R$1757 \$841 \$864 VSS|vss 4 rppd l=1.2 ps=0 b=0 m=1
R$1758 \$843 \$865 VSS|vss 4 rppd l=1.2 ps=0 b=0 m=1
R$1759 \$850 \$870 VSS|vss 4 rppd l=1.2 ps=0 b=0 m=1
R$1760 \$851 \$871 VSS|vss 4 rppd l=1.2 ps=0 b=0 m=1
R$1761 \$852 \$885 VSS|vss 4 rppd l=1.2 ps=0 b=0 m=1
R$1762 \$853 \$872 VSS|vss 4 rppd l=1.2 ps=0 b=0 m=1
R$1763 \$854 \$873 VSS|vss 4 rppd l=1.2 ps=0 b=0 m=1
R$1764 \$855 \$874 VSS|vss 4 rppd l=1.2 ps=0 b=0 m=1
R$1765 \$856 \$875 VSS|vss 4 rppd l=1.2 ps=0 b=0 m=1
R$1766 \$857 \$876 VSS|vss 4 rppd l=1.2 ps=0 b=0 m=1
R$1767 \$858 \$877 VSS|vss 4 rppd l=1.2 ps=0 b=0 m=1
R$1768 \$859 \$878 VSS|vss 4 rppd l=1.2 ps=0 b=0 m=1
R$1769 \$860 \$879 VSS|vss 4 rppd l=1.2 ps=0 b=0 m=1
R$1770 \$861 \$880 VSS|vss 4 rppd l=1.2 ps=0 b=0 m=1
R$1771 \$862 \$881 VSS|vss 4 rppd l=1.2 ps=0 b=0 m=1
R$1772 \$863 \$882 VSS|vss 4 rppd l=1.2 ps=0 b=0 m=1
R$1773 \$864 \$883 VSS|vss 4 rppd l=1.2 ps=0 b=0 m=1
R$1774 \$865 \$884 VSS|vss 4 rppd l=1.2 ps=0 b=0 m=1
R$1775 \$870 \$894 VSS|vss 4 rppd l=1.2 ps=0 b=0 m=1
R$1776 \$871 \$895 VSS|vss 4 rppd l=1.2 ps=0 b=0 m=1
R$1777 \$885 \$896 VSS|vss 4 rppd l=1.2 ps=0 b=0 m=1
R$1778 \$872 \$897 VSS|vss 4 rppd l=1.2 ps=0 b=0 m=1
R$1779 \$873 \$898 VSS|vss 4 rppd l=1.2 ps=0 b=0 m=1
R$1780 \$874 \$899 VSS|vss 4 rppd l=1.2 ps=0 b=0 m=1
R$1781 \$875 \$900 VSS|vss 4 rppd l=1.2 ps=0 b=0 m=1
R$1782 \$876 \$901 VSS|vss 4 rppd l=1.2 ps=0 b=0 m=1
R$1783 \$877 \$902 VSS|vss 4 rppd l=1.2 ps=0 b=0 m=1
R$1784 \$878 \$903 VSS|vss 4 rppd l=1.2 ps=0 b=0 m=1
R$1785 \$879 \$904 VSS|vss 4 rppd l=1.2 ps=0 b=0 m=1
R$1786 \$880 \$905 VSS|vss 4 rppd l=1.2 ps=0 b=0 m=1
R$1787 \$881 \$906 VSS|vss 4 rppd l=1.2 ps=0 b=0 m=1
R$1788 \$882 \$907 VSS|vss 4 rppd l=1.2 ps=0 b=0 m=1
R$1789 \$883 \$908 VSS|vss 4 rppd l=1.2 ps=0 b=0 m=1
R$1790 \$884 \$909 VSS|vss 4 rppd l=1.2 ps=0 b=0 m=1
R$1791 \$894 \$910 VSS|vss 4 rppd l=1.2 ps=0 b=0 m=1
R$1792 \$895 \$911 VSS|vss 4 rppd l=1.2 ps=0 b=0 m=1
R$1793 \$896 \$912 VSS|vss 4 rppd l=1.2 ps=0 b=0 m=1
R$1794 \$897 \$913 VSS|vss 4 rppd l=1.2 ps=0 b=0 m=1
R$1795 \$898 \$915 VSS|vss 4 rppd l=1.2 ps=0 b=0 m=1
R$1796 \$899 \$916 VSS|vss 4 rppd l=1.2 ps=0 b=0 m=1
R$1797 \$900 \$919 VSS|vss 4 rppd l=1.2 ps=0 b=0 m=1
R$1798 \$901 \$920 VSS|vss 4 rppd l=1.2 ps=0 b=0 m=1
R$1799 \$902 \$922 VSS|vss 4 rppd l=1.2 ps=0 b=0 m=1
R$1800 \$903 \$923 VSS|vss 4 rppd l=1.2 ps=0 b=0 m=1
R$1801 \$904 \$924 VSS|vss 4 rppd l=1.2 ps=0 b=0 m=1
R$1802 \$905 \$925 VSS|vss 4 rppd l=1.2 ps=0 b=0 m=1
R$1803 \$906 \$926 VSS|vss 4 rppd l=1.2 ps=0 b=0 m=1
R$1804 \$907 \$928 VSS|vss 4 rppd l=1.2 ps=0 b=0 m=1
R$1805 \$908 \$930 VSS|vss 4 rppd l=1.2 ps=0 b=0 m=1
R$1806 \$909 \$932 VSS|vss 4 rppd l=1.2 ps=0 b=0 m=1
R$1807 \$910 \$942 VSS|vss 4 rppd l=1.2 ps=0 b=0 m=1
R$1808 \$911 \$943 VSS|vss 4 rppd l=1.2 ps=0 b=0 m=1
R$1809 \$912 \$944 VSS|vss 4 rppd l=1.2 ps=0 b=0 m=1
R$1810 \$913 \$945 VSS|vss 4 rppd l=1.2 ps=0 b=0 m=1
R$1811 \$915 \$946 VSS|vss 4 rppd l=1.2 ps=0 b=0 m=1
R$1812 \$916 \$947 VSS|vss 4 rppd l=1.2 ps=0 b=0 m=1
R$1813 \$919 \$948 VSS|vss 4 rppd l=1.2 ps=0 b=0 m=1
R$1814 \$920 \$949 VSS|vss 4 rppd l=1.2 ps=0 b=0 m=1
R$1815 \$922 \$950 VSS|vss 4 rppd l=1.2 ps=0 b=0 m=1
R$1816 \$923 \$951 VSS|vss 4 rppd l=1.2 ps=0 b=0 m=1
R$1817 \$924 \$952 VSS|vss 4 rppd l=1.2 ps=0 b=0 m=1
R$1818 \$925 \$953 VSS|vss 4 rppd l=1.2 ps=0 b=0 m=1
R$1819 \$926 \$954 VSS|vss 4 rppd l=1.2 ps=0 b=0 m=1
R$1820 \$928 \$955 VSS|vss 4 rppd l=1.2 ps=0 b=0 m=1
R$1821 \$930 \$956 VSS|vss 4 rppd l=1.2 ps=0 b=0 m=1
R$1822 \$932 \$957 VSS|vss 4 rppd l=1.2 ps=0 b=0 m=1
R$1823 \$942 \$958 VSS|vss 4 rppd l=1.2 ps=0 b=0 m=1
R$1824 \$943 \$979 VSS|vss 4 rppd l=1.2 ps=0 b=0 m=1
R$1825 \$944 \$959 VSS|vss 4 rppd l=1.2 ps=0 b=0 m=1
R$1826 \$945 \$960 VSS|vss 4 rppd l=1.2 ps=0 b=0 m=1
R$1827 \$946 \$961 VSS|vss 4 rppd l=1.2 ps=0 b=0 m=1
R$1828 \$947 \$980 VSS|vss 4 rppd l=1.2 ps=0 b=0 m=1
R$1829 \$948 \$965 VSS|vss 4 rppd l=1.2 ps=0 b=0 m=1
R$1830 \$949 \$981 VSS|vss 4 rppd l=1.2 ps=0 b=0 m=1
R$1831 \$950 \$982 VSS|vss 4 rppd l=1.2 ps=0 b=0 m=1
R$1832 \$951 \$968 VSS|vss 4 rppd l=1.2 ps=0 b=0 m=1
R$1833 \$952 \$969 VSS|vss 4 rppd l=1.2 ps=0 b=0 m=1
R$1834 \$953 \$983 VSS|vss 4 rppd l=1.2 ps=0 b=0 m=1
R$1835 \$954 \$971 VSS|vss 4 rppd l=1.2 ps=0 b=0 m=1
R$1836 \$955 \$972 VSS|vss 4 rppd l=1.2 ps=0 b=0 m=1
R$1837 \$956 \$975 VSS|vss 4 rppd l=1.2 ps=0 b=0 m=1
R$1838 \$957 \$976 VSS|vss 4 rppd l=1.2 ps=0 b=0 m=1
R$1839 \$958 \$992 VSS|vss 4 rppd l=1.2 ps=0 b=0 m=1
R$1840 \$979 \$993 VSS|vss 4 rppd l=1.2 ps=0 b=0 m=1
R$1841 \$959 \$994 VSS|vss 4 rppd l=1.2 ps=0 b=0 m=1
R$1842 \$960 \$995 VSS|vss 4 rppd l=1.2 ps=0 b=0 m=1
R$1843 \$961 \$996 VSS|vss 4 rppd l=1.2 ps=0 b=0 m=1
R$1844 \$980 \$998 VSS|vss 4 rppd l=1.2 ps=0 b=0 m=1
R$1845 \$965 \$999 VSS|vss 4 rppd l=1.2 ps=0 b=0 m=1
R$1846 \$981 \$1001 VSS|vss 4 rppd l=1.2 ps=0 b=0 m=1
R$1847 \$982 \$1002 VSS|vss 4 rppd l=1.2 ps=0 b=0 m=1
R$1848 \$968 \$1003 VSS|vss 4 rppd l=1.2 ps=0 b=0 m=1
R$1849 \$969 \$1004 VSS|vss 4 rppd l=1.2 ps=0 b=0 m=1
R$1850 \$983 \$1005 VSS|vss 4 rppd l=1.2 ps=0 b=0 m=1
R$1851 \$971 \$1006 VSS|vss 4 rppd l=1.2 ps=0 b=0 m=1
R$1852 \$972 \$1008 VSS|vss 4 rppd l=1.2 ps=0 b=0 m=1
R$1853 \$975 \$1009 VSS|vss 4 rppd l=1.2 ps=0 b=0 m=1
R$1854 \$976 \$1011 VSS|vss 4 rppd l=1.2 ps=0 b=0 m=1
R$1855 \$992 \$1012 VSS|vss 4 rppd l=1.2 ps=0 b=0 m=1
R$1856 \$993 \$1013 VSS|vss 4 rppd l=1.2 ps=0 b=0 m=1
R$1857 \$994 \$1014 VSS|vss 4 rppd l=1.2 ps=0 b=0 m=1
R$1858 \$995 \$1015 VSS|vss 4 rppd l=1.2 ps=0 b=0 m=1
R$1859 \$996 \$1017 VSS|vss 4 rppd l=1.2 ps=0 b=0 m=1
R$1860 \$998 \$1018 VSS|vss 4 rppd l=1.2 ps=0 b=0 m=1
R$1861 \$999 \$1022 VSS|vss 4 rppd l=1.2 ps=0 b=0 m=1
R$1862 \$1001 \$1023 VSS|vss 4 rppd l=1.2 ps=0 b=0 m=1
R$1863 \$1002 \$1027 VSS|vss 4 rppd l=1.2 ps=0 b=0 m=1
R$1864 \$1003 \$1028 VSS|vss 4 rppd l=1.2 ps=0 b=0 m=1
R$1865 \$1004 \$1029 VSS|vss 4 rppd l=1.2 ps=0 b=0 m=1
R$1866 \$1005 \$1030 VSS|vss 4 rppd l=1.2 ps=0 b=0 m=1
R$1867 \$1006 \$1031 VSS|vss 4 rppd l=1.2 ps=0 b=0 m=1
R$1868 \$1008 \$1033 VSS|vss 4 rppd l=1.2 ps=0 b=0 m=1
R$1869 \$1009 \$1037 VSS|vss 4 rppd l=1.2 ps=0 b=0 m=1
R$1870 \$1011 \$1038 VSS|vss 4 rppd l=1.2 ps=0 b=0 m=1
R$1871 \$1012 \$1060 VSS|vss 4 rppd l=1.2 ps=0 b=0 m=1
R$1872 \$1013 \$1042 VSS|vss 4 rppd l=1.2 ps=0 b=0 m=1
R$1873 \$1014 \$1043 VSS|vss 4 rppd l=1.2 ps=0 b=0 m=1
R$1874 \$1015 \$1061 VSS|vss 4 rppd l=1.2 ps=0 b=0 m=1
R$1875 \$1017 \$1044 VSS|vss 4 rppd l=1.2 ps=0 b=0 m=1
R$1876 \$1018 \$1046 VSS|vss 4 rppd l=1.2 ps=0 b=0 m=1
R$1877 \$1022 \$1062 VSS|vss 4 rppd l=1.2 ps=0 b=0 m=1
R$1878 \$1023 \$1048 VSS|vss 4 rppd l=1.2 ps=0 b=0 m=1
R$1879 \$1027 \$1050 VSS|vss 4 rppd l=1.2 ps=0 b=0 m=1
R$1880 \$1028 \$1051 VSS|vss 4 rppd l=1.2 ps=0 b=0 m=1
R$1881 \$1029 \$1063 VSS|vss 4 rppd l=1.2 ps=0 b=0 m=1
R$1882 \$1030 \$1052 VSS|vss 4 rppd l=1.2 ps=0 b=0 m=1
R$1883 \$1031 \$1053 VSS|vss 4 rppd l=1.2 ps=0 b=0 m=1
R$1884 \$1033 \$1055 VSS|vss 4 rppd l=1.2 ps=0 b=0 m=1
R$1885 \$1037 \$1056 VSS|vss 4 rppd l=1.2 ps=0 b=0 m=1
R$1886 \$1038 \$1057 VSS|vss 4 rppd l=1.2 ps=0 b=0 m=1
R$1887 \$1060 \$1068 VSS|vss 4 rppd l=1.2 ps=0 b=0 m=1
R$1888 \$1042 \$1069 VSS|vss 4 rppd l=1.2 ps=0 b=0 m=1
R$1889 \$1043 \$1070 VSS|vss 4 rppd l=1.2 ps=0 b=0 m=1
R$1890 \$1061 \$1071 VSS|vss 4 rppd l=1.2 ps=0 b=0 m=1
R$1891 \$1044 \$1072 VSS|vss 4 rppd l=1.2 ps=0 b=0 m=1
R$1892 \$1046 \$1073 VSS|vss 4 rppd l=1.2 ps=0 b=0 m=1
R$1893 \$1062 \$1074 VSS|vss 4 rppd l=1.2 ps=0 b=0 m=1
R$1894 \$1048 \$1075 VSS|vss 4 rppd l=1.2 ps=0 b=0 m=1
R$1895 \$1050 \$1076 VSS|vss 4 rppd l=1.2 ps=0 b=0 m=1
R$1896 \$1051 \$1077 VSS|vss 4 rppd l=1.2 ps=0 b=0 m=1
R$1897 \$1063 \$1078 VSS|vss 4 rppd l=1.2 ps=0 b=0 m=1
R$1898 \$1052 \$1079 VSS|vss 4 rppd l=1.2 ps=0 b=0 m=1
R$1899 \$1053 \$1080 VSS|vss 4 rppd l=1.2 ps=0 b=0 m=1
R$1900 \$1055 \$1081 VSS|vss 4 rppd l=1.2 ps=0 b=0 m=1
R$1901 \$1056 \$1082 VSS|vss 4 rppd l=1.2 ps=0 b=0 m=1
R$1902 \$1057 \$1083 VSS|vss 4 rppd l=1.2 ps=0 b=0 m=1
R$1903 \$1068 \$1092 VSS|vss 4 rppd l=1.2 ps=0 b=0 m=1
R$1904 \$1069 \$1093 VSS|vss 4 rppd l=1.2 ps=0 b=0 m=1
R$1905 \$1070 \$1094 VSS|vss 4 rppd l=1.2 ps=0 b=0 m=1
R$1906 \$1071 \$1095 VSS|vss 4 rppd l=1.2 ps=0 b=0 m=1
R$1907 \$1072 \$1096 VSS|vss 4 rppd l=1.2 ps=0 b=0 m=1
R$1908 \$1073 \$1098 VSS|vss 4 rppd l=1.2 ps=0 b=0 m=1
R$1909 \$1074 \$1099 VSS|vss 4 rppd l=1.2 ps=0 b=0 m=1
R$1910 \$1075 \$1101 VSS|vss 4 rppd l=1.2 ps=0 b=0 m=1
R$1911 \$1076 \$1102 VSS|vss 4 rppd l=1.2 ps=0 b=0 m=1
R$1912 \$1077 \$1103 VSS|vss 4 rppd l=1.2 ps=0 b=0 m=1
R$1913 \$1078 \$1104 VSS|vss 4 rppd l=1.2 ps=0 b=0 m=1
R$1914 \$1079 \$1105 VSS|vss 4 rppd l=1.2 ps=0 b=0 m=1
R$1915 \$1080 \$1106 VSS|vss 4 rppd l=1.2 ps=0 b=0 m=1
R$1916 \$1081 \$1108 VSS|vss 4 rppd l=1.2 ps=0 b=0 m=1
R$1917 \$1082 \$1109 VSS|vss 4 rppd l=1.2 ps=0 b=0 m=1
R$1918 \$1083 \$1111 VSS|vss 4 rppd l=1.2 ps=0 b=0 m=1
R$1919 \$1092 \$1112 VSS|vss 4 rppd l=1.2 ps=0 b=0 m=1
R$1920 \$1093 \$1113 VSS|vss 4 rppd l=1.2 ps=0 b=0 m=1
R$1921 \$1094 \$1114 VSS|vss 4 rppd l=1.2 ps=0 b=0 m=1
R$1922 \$1095 \$1115 VSS|vss 4 rppd l=1.2 ps=0 b=0 m=1
R$1923 \$1096 \$1117 VSS|vss 4 rppd l=1.2 ps=0 b=0 m=1
R$1924 \$1098 \$1118 VSS|vss 4 rppd l=1.2 ps=0 b=0 m=1
R$1925 \$1099 \$1122 VSS|vss 4 rppd l=1.2 ps=0 b=0 m=1
R$1926 \$1101 \$1123 VSS|vss 4 rppd l=1.2 ps=0 b=0 m=1
R$1927 \$1102 \$1126 VSS|vss 4 rppd l=1.2 ps=0 b=0 m=1
R$1928 \$1103 \$1127 VSS|vss 4 rppd l=1.2 ps=0 b=0 m=1
R$1929 \$1104 \$1128 VSS|vss 4 rppd l=1.2 ps=0 b=0 m=1
R$1930 \$1105 \$1129 VSS|vss 4 rppd l=1.2 ps=0 b=0 m=1
R$1931 \$1106 \$1131 VSS|vss 4 rppd l=1.2 ps=0 b=0 m=1
R$1932 \$1108 \$1132 VSS|vss 4 rppd l=1.2 ps=0 b=0 m=1
R$1933 \$1109 \$1136 VSS|vss 4 rppd l=1.2 ps=0 b=0 m=1
R$1934 \$1111 \$1137 VSS|vss 4 rppd l=1.2 ps=0 b=0 m=1
R$1935 \$1112 \$1148 VSS|vss 4 rppd l=1.2 ps=0 b=0 m=1
R$1936 \$1113 \$1149 VSS|vss 4 rppd l=1.2 ps=0 b=0 m=1
R$1937 \$1114 \$1150 VSS|vss 4 rppd l=1.2 ps=0 b=0 m=1
R$1938 \$1115 \$1151 VSS|vss 4 rppd l=1.2 ps=0 b=0 m=1
R$1939 \$1117 \$1152 VSS|vss 4 rppd l=1.2 ps=0 b=0 m=1
R$1940 \$1118 \$1153 VSS|vss 4 rppd l=1.2 ps=0 b=0 m=1
R$1941 \$1122 \$1154 VSS|vss 4 rppd l=1.2 ps=0 b=0 m=1
R$1942 \$1123 \$1155 VSS|vss 4 rppd l=1.2 ps=0 b=0 m=1
R$1943 \$1126 \$1156 VSS|vss 4 rppd l=1.2 ps=0 b=0 m=1
R$1944 \$1127 \$1157 VSS|vss 4 rppd l=1.2 ps=0 b=0 m=1
R$1945 \$1128 \$1158 VSS|vss 4 rppd l=1.2 ps=0 b=0 m=1
R$1946 \$1129 \$1159 VSS|vss 4 rppd l=1.2 ps=0 b=0 m=1
R$1947 \$1131 \$1160 VSS|vss 4 rppd l=1.2 ps=0 b=0 m=1
R$1948 \$1132 \$1161 VSS|vss 4 rppd l=1.2 ps=0 b=0 m=1
R$1949 \$1136 \$1162 VSS|vss 4 rppd l=1.2 ps=0 b=0 m=1
R$1950 \$1137 \$1163 VSS|vss 4 rppd l=1.2 ps=0 b=0 m=1
R$1951 \$1148 \$1164 VSS|vss 4 rppd l=1.2 ps=0 b=0 m=1
R$1952 \$1149 \$1165 VSS|vss 4 rppd l=1.2 ps=0 b=0 m=1
R$1953 \$1150 \$1166 VSS|vss 4 rppd l=1.2 ps=0 b=0 m=1
R$1954 \$1151 \$1167 VSS|vss 4 rppd l=1.2 ps=0 b=0 m=1
R$1955 \$1152 \$1169 VSS|vss 4 rppd l=1.2 ps=0 b=0 m=1
R$1956 \$1153 \$1170 VSS|vss 4 rppd l=1.2 ps=0 b=0 m=1
R$1957 \$1154 \$1173 VSS|vss 4 rppd l=1.2 ps=0 b=0 m=1
R$1958 \$1155 \$1174 VSS|vss 4 rppd l=1.2 ps=0 b=0 m=1
R$1959 \$1156 \$1176 VSS|vss 4 rppd l=1.2 ps=0 b=0 m=1
R$1960 \$1157 \$1177 VSS|vss 4 rppd l=1.2 ps=0 b=0 m=1
R$1961 \$1158 \$1178 VSS|vss 4 rppd l=1.2 ps=0 b=0 m=1
R$1962 \$1159 \$1179 VSS|vss 4 rppd l=1.2 ps=0 b=0 m=1
R$1963 \$1160 \$1181 VSS|vss 4 rppd l=1.2 ps=0 b=0 m=1
R$1964 \$1161 \$1182 VSS|vss 4 rppd l=1.2 ps=0 b=0 m=1
R$1965 \$1162 \$1185 VSS|vss 4 rppd l=1.2 ps=0 b=0 m=1
R$1966 \$1163 \$1186 VSS|vss 4 rppd l=1.2 ps=0 b=0 m=1
R$1967 \$1164 \$1192 VSS|vss 4 rppd l=1.2 ps=0 b=0 m=1
R$1968 \$1165 \$1193 VSS|vss 4 rppd l=1.2 ps=0 b=0 m=1
R$1969 \$1166 \$1194 VSS|vss 4 rppd l=1.2 ps=0 b=0 m=1
R$1970 \$1167 \$1195 VSS|vss 4 rppd l=1.2 ps=0 b=0 m=1
R$1971 \$1169 \$1196 VSS|vss 4 rppd l=1.2 ps=0 b=0 m=1
R$1972 \$1170 \$1198 VSS|vss 4 rppd l=1.2 ps=0 b=0 m=1
R$1973 \$1173 \$1199 VSS|vss 4 rppd l=1.2 ps=0 b=0 m=1
R$1974 \$1174 \$1201 VSS|vss 4 rppd l=1.2 ps=0 b=0 m=1
R$1975 \$1176 \$1202 VSS|vss 4 rppd l=1.2 ps=0 b=0 m=1
R$1976 \$1177 \$1203 VSS|vss 4 rppd l=1.2 ps=0 b=0 m=1
R$1977 \$1178 \$1204 VSS|vss 4 rppd l=1.2 ps=0 b=0 m=1
R$1978 \$1179 \$1205 VSS|vss 4 rppd l=1.2 ps=0 b=0 m=1
R$1979 \$1181 \$1206 VSS|vss 4 rppd l=1.2 ps=0 b=0 m=1
R$1980 \$1182 \$1208 VSS|vss 4 rppd l=1.2 ps=0 b=0 m=1
R$1981 \$1185 \$1209 VSS|vss 4 rppd l=1.2 ps=0 b=0 m=1
R$1982 \$1186 \$1211 VSS|vss 4 rppd l=1.2 ps=0 b=0 m=1
R$1983 \$1192 \$1212 VSS|vss 4 rppd l=1.2 ps=0 b=0 m=1
R$1984 \$1193 \$1213 VSS|vss 4 rppd l=1.2 ps=0 b=0 m=1
R$1985 \$1194 \$1214 VSS|vss 4 rppd l=1.2 ps=0 b=0 m=1
R$1986 \$1195 \$1215 VSS|vss 4 rppd l=1.2 ps=0 b=0 m=1
R$1987 \$1196 \$1216 VSS|vss 4 rppd l=1.2 ps=0 b=0 m=1
R$1988 \$1198 \$1218 VSS|vss 4 rppd l=1.2 ps=0 b=0 m=1
R$1989 \$1199 \$1221 VSS|vss 4 rppd l=1.2 ps=0 b=0 m=1
R$1990 \$1201 \$1222 VSS|vss 4 rppd l=1.2 ps=0 b=0 m=1
R$1991 \$1202 \$1224 VSS|vss 4 rppd l=1.2 ps=0 b=0 m=1
R$1992 \$1203 \$1237 VSS|vss 4 rppd l=1.2 ps=0 b=0 m=1
R$1993 \$1204 \$1225 VSS|vss 4 rppd l=1.2 ps=0 b=0 m=1
R$1994 \$1205 \$1226 VSS|vss 4 rppd l=1.2 ps=0 b=0 m=1
R$1995 \$1206 \$1228 VSS|vss 4 rppd l=1.2 ps=0 b=0 m=1
R$1996 \$1208 \$1229 VSS|vss 4 rppd l=1.2 ps=0 b=0 m=1
R$1997 \$1209 \$1231 VSS|vss 4 rppd l=1.2 ps=0 b=0 m=1
R$1998 \$1211 \$1233 VSS|vss 4 rppd l=1.2 ps=0 b=0 m=1
R$1999 \$1212 \$1240 VSS|vss 4 rppd l=1.2 ps=0 b=0 m=1
R$2000 \$1213 \$1241 VSS|vss 4 rppd l=1.2 ps=0 b=0 m=1
R$2001 \$1214 \$1242 VSS|vss 4 rppd l=1.2 ps=0 b=0 m=1
R$2002 \$1215 \$1243 VSS|vss 4 rppd l=1.2 ps=0 b=0 m=1
R$2003 \$1216 \$1244 VSS|vss 4 rppd l=1.2 ps=0 b=0 m=1
R$2004 \$1218 \$1245 VSS|vss 4 rppd l=1.2 ps=0 b=0 m=1
R$2005 \$1221 \$1246 VSS|vss 4 rppd l=1.2 ps=0 b=0 m=1
R$2006 \$1222 \$1247 VSS|vss 4 rppd l=1.2 ps=0 b=0 m=1
R$2007 \$1224 \$1248 VSS|vss 4 rppd l=1.2 ps=0 b=0 m=1
R$2008 \$1237 \$1249 VSS|vss 4 rppd l=1.2 ps=0 b=0 m=1
R$2009 \$1225 \$1250 VSS|vss 4 rppd l=1.2 ps=0 b=0 m=1
R$2010 \$1226 \$1251 VSS|vss 4 rppd l=1.2 ps=0 b=0 m=1
R$2011 \$1228 \$1252 VSS|vss 4 rppd l=1.2 ps=0 b=0 m=1
R$2012 \$1229 \$1253 VSS|vss 4 rppd l=1.2 ps=0 b=0 m=1
R$2013 \$1231 \$1254 VSS|vss 4 rppd l=1.2 ps=0 b=0 m=1
R$2014 \$1233 \$1255 VSS|vss 4 rppd l=1.2 ps=0 b=0 m=1
R$2015 \$1240 \$1260 VSS|vss 4 rppd l=1.2 ps=0 b=0 m=1
R$2016 \$1241 \$1261 VSS|vss 4 rppd l=1.2 ps=0 b=0 m=1
R$2017 \$1242 \$1262 VSS|vss 4 rppd l=1.2 ps=0 b=0 m=1
R$2018 \$1243 \$1263 VSS|vss 4 rppd l=1.2 ps=0 b=0 m=1
R$2019 \$1244 \$1264 VSS|vss 4 rppd l=1.2 ps=0 b=0 m=1
R$2020 \$1245 \$1265 VSS|vss 4 rppd l=1.2 ps=0 b=0 m=1
R$2021 \$1246 \$1266 VSS|vss 4 rppd l=1.2 ps=0 b=0 m=1
R$2022 \$1247 \$1267 VSS|vss 4 rppd l=1.2 ps=0 b=0 m=1
R$2023 \$1248 \$1268 VSS|vss 4 rppd l=1.2 ps=0 b=0 m=1
R$2024 \$1249 \$1269 VSS|vss 4 rppd l=1.2 ps=0 b=0 m=1
R$2025 \$1250 \$1270 VSS|vss 4 rppd l=1.2 ps=0 b=0 m=1
R$2026 \$1251 \$1271 VSS|vss 4 rppd l=1.2 ps=0 b=0 m=1
R$2027 \$1252 \$1272 VSS|vss 4 rppd l=1.2 ps=0 b=0 m=1
R$2028 \$1253 \$1273 VSS|vss 4 rppd l=1.2 ps=0 b=0 m=1
R$2029 \$1254 \$1274 VSS|vss 4 rppd l=1.2 ps=0 b=0 m=1
R$2030 \$1255 \$1275 VSS|vss 4 rppd l=1.2 ps=0 b=0 m=1
R$2031 \$1260 \$1284 VSS|vss 4 rppd l=1.2 ps=0 b=0 m=1
R$2032 \$1261 \$1285 VSS|vss 4 rppd l=1.2 ps=0 b=0 m=1
R$2033 \$1262 \$1286 VSS|vss 4 rppd l=1.2 ps=0 b=0 m=1
R$2034 \$1263 \$1287 VSS|vss 4 rppd l=1.2 ps=0 b=0 m=1
R$2035 \$1264 \$1288 VSS|vss 4 rppd l=1.2 ps=0 b=0 m=1
R$2036 \$1265 \$1290 VSS|vss 4 rppd l=1.2 ps=0 b=0 m=1
R$2037 \$1266 \$1291 VSS|vss 4 rppd l=1.2 ps=0 b=0 m=1
R$2038 \$1267 \$1293 VSS|vss 4 rppd l=1.2 ps=0 b=0 m=1
R$2039 \$1268 \$1294 VSS|vss 4 rppd l=1.2 ps=0 b=0 m=1
R$2040 \$1269 \$1295 VSS|vss 4 rppd l=1.2 ps=0 b=0 m=1
R$2041 \$1270 \$1296 VSS|vss 4 rppd l=1.2 ps=0 b=0 m=1
R$2042 \$1271 \$1297 VSS|vss 4 rppd l=1.2 ps=0 b=0 m=1
R$2043 \$1272 \$1298 VSS|vss 4 rppd l=1.2 ps=0 b=0 m=1
R$2044 \$1273 \$1300 VSS|vss 4 rppd l=1.2 ps=0 b=0 m=1
R$2045 \$1274 \$1301 VSS|vss 4 rppd l=1.2 ps=0 b=0 m=1
R$2046 \$1275 \$1303 VSS|vss 4 rppd l=1.2 ps=0 b=0 m=1
R$2047 \$1284 \$1312 VSS|vss 4 rppd l=1.2 ps=0 b=0 m=1
R$2048 \$1285 \$1313 VSS|vss 4 rppd l=1.2 ps=0 b=0 m=1
R$2049 \$1286 \$1314 VSS|vss 4 rppd l=1.2 ps=0 b=0 m=1
R$2050 \$1287 \$1315 VSS|vss 4 rppd l=1.2 ps=0 b=0 m=1
R$2051 \$1288 \$1316 VSS|vss 4 rppd l=1.2 ps=0 b=0 m=1
R$2052 \$1290 \$1317 VSS|vss 4 rppd l=1.2 ps=0 b=0 m=1
R$2053 \$1291 \$1319 VSS|vss 4 rppd l=1.2 ps=0 b=0 m=1
R$2054 \$1293 \$1320 VSS|vss 4 rppd l=1.2 ps=0 b=0 m=1
R$2055 \$1294 \$1322 VSS|vss 4 rppd l=1.2 ps=0 b=0 m=1
R$2056 \$1295 \$1323 VSS|vss 4 rppd l=1.2 ps=0 b=0 m=1
R$2057 \$1296 \$1324 VSS|vss 4 rppd l=1.2 ps=0 b=0 m=1
R$2058 \$1297 \$1325 VSS|vss 4 rppd l=1.2 ps=0 b=0 m=1
R$2059 \$1298 \$1326 VSS|vss 4 rppd l=1.2 ps=0 b=0 m=1
R$2060 \$1300 \$1327 VSS|vss 4 rppd l=1.2 ps=0 b=0 m=1
R$2061 \$1301 \$1329 VSS|vss 4 rppd l=1.2 ps=0 b=0 m=1
R$2062 \$1303 \$1330 VSS|vss 4 rppd l=1.2 ps=0 b=0 m=1
R$2063 \$1312 \$1340 VSS|vss 4 rppd l=1.2 ps=0 b=0 m=1
R$2064 \$1313 \$1341 VSS|vss 4 rppd l=1.2 ps=0 b=0 m=1
R$2065 \$1314 \$1342 VSS|vss 4 rppd l=1.2 ps=0 b=0 m=1
R$2066 \$1315 \$1343 VSS|vss 4 rppd l=1.2 ps=0 b=0 m=1
R$2067 \$1316 \$1344 VSS|vss 4 rppd l=1.2 ps=0 b=0 m=1
R$2068 \$1317 \$1345 VSS|vss 4 rppd l=1.2 ps=0 b=0 m=1
R$2069 \$1319 \$1346 VSS|vss 4 rppd l=1.2 ps=0 b=0 m=1
R$2070 \$1320 \$1347 VSS|vss 4 rppd l=1.2 ps=0 b=0 m=1
R$2071 \$1322 \$1348 VSS|vss 4 rppd l=1.2 ps=0 b=0 m=1
R$2072 \$1323 \$1349 VSS|vss 4 rppd l=1.2 ps=0 b=0 m=1
R$2073 \$1324 \$1350 VSS|vss 4 rppd l=1.2 ps=0 b=0 m=1
R$2074 \$1325 \$1351 VSS|vss 4 rppd l=1.2 ps=0 b=0 m=1
R$2075 \$1326 \$1352 VSS|vss 4 rppd l=1.2 ps=0 b=0 m=1
R$2076 \$1327 \$1353 VSS|vss 4 rppd l=1.2 ps=0 b=0 m=1
R$2077 \$1329 \$1354 VSS|vss 4 rppd l=1.2 ps=0 b=0 m=1
R$2078 \$1330 \$1355 VSS|vss 4 rppd l=1.2 ps=0 b=0 m=1
R$2079 \$1340 \$1364 VSS|vss 4 rppd l=1.2 ps=0 b=0 m=1
R$2080 \$1341 \$1365 VSS|vss 4 rppd l=1.2 ps=0 b=0 m=1
R$2081 \$1342 \$1366 VSS|vss 4 rppd l=1.2 ps=0 b=0 m=1
R$2082 \$1343 \$1367 VSS|vss 4 rppd l=1.2 ps=0 b=0 m=1
R$2083 \$1344 \$1368 VSS|vss 4 rppd l=1.2 ps=0 b=0 m=1
R$2084 \$1345 \$1369 VSS|vss 4 rppd l=1.2 ps=0 b=0 m=1
R$2085 \$1346 \$1370 VSS|vss 4 rppd l=1.2 ps=0 b=0 m=1
R$2086 \$1347 \$1371 VSS|vss 4 rppd l=1.2 ps=0 b=0 m=1
R$2087 \$1348 \$1372 VSS|vss 4 rppd l=1.2 ps=0 b=0 m=1
R$2088 \$1349 \$1373 VSS|vss 4 rppd l=1.2 ps=0 b=0 m=1
R$2089 \$1350 \$1374 VSS|vss 4 rppd l=1.2 ps=0 b=0 m=1
R$2090 \$1351 \$1375 VSS|vss 4 rppd l=1.2 ps=0 b=0 m=1
R$2091 \$1352 \$1376 VSS|vss 4 rppd l=1.2 ps=0 b=0 m=1
R$2092 \$1353 \$1377 VSS|vss 4 rppd l=1.2 ps=0 b=0 m=1
R$2093 \$1354 \$1378 VSS|vss 4 rppd l=1.2 ps=0 b=0 m=1
R$2094 \$1355 \$1379 VSS|vss 4 rppd l=1.2 ps=0 b=0 m=1
R$2095 \$1364 \$1388 VSS|vss 4 rppd l=1.2 ps=0 b=0 m=1
R$2096 \$1365 \$1389 VSS|vss 4 rppd l=1.2 ps=0 b=0 m=1
R$2097 \$1366 \$1390 VSS|vss 4 rppd l=1.2 ps=0 b=0 m=1
R$2098 \$1367 \$1391 VSS|vss 4 rppd l=1.2 ps=0 b=0 m=1
R$2099 \$1368 \$1392 VSS|vss 4 rppd l=1.2 ps=0 b=0 m=1
R$2100 \$1369 \$1394 VSS|vss 4 rppd l=1.2 ps=0 b=0 m=1
R$2101 \$1370 \$1395 VSS|vss 4 rppd l=1.2 ps=0 b=0 m=1
R$2102 \$1371 \$1397 VSS|vss 4 rppd l=1.2 ps=0 b=0 m=1
R$2103 \$1372 \$1398 VSS|vss 4 rppd l=1.2 ps=0 b=0 m=1
R$2104 \$1373 \$1399 VSS|vss 4 rppd l=1.2 ps=0 b=0 m=1
R$2105 \$1374 \$1400 VSS|vss 4 rppd l=1.2 ps=0 b=0 m=1
R$2106 \$1375 \$1401 VSS|vss 4 rppd l=1.2 ps=0 b=0 m=1
R$2107 \$1376 \$1402 VSS|vss 4 rppd l=1.2 ps=0 b=0 m=1
R$2108 \$1377 \$1404 VSS|vss 4 rppd l=1.2 ps=0 b=0 m=1
R$2109 \$1378 \$1405 VSS|vss 4 rppd l=1.2 ps=0 b=0 m=1
R$2110 \$1379 \$1407 VSS|vss 4 rppd l=1.2 ps=0 b=0 m=1
R$2111 \$1388 \$1416 VSS|vss 4 rppd l=1.2 ps=0 b=0 m=1
R$2112 \$1389 \$1417 VSS|vss 4 rppd l=1.2 ps=0 b=0 m=1
R$2113 \$1390 \$1418 VSS|vss 4 rppd l=1.2 ps=0 b=0 m=1
R$2114 \$1391 \$1419 VSS|vss 4 rppd l=1.2 ps=0 b=0 m=1
R$2115 \$1392 \$1420 VSS|vss 4 rppd l=1.2 ps=0 b=0 m=1
R$2116 \$1394 \$1421 VSS|vss 4 rppd l=1.2 ps=0 b=0 m=1
R$2117 \$1395 \$1423 VSS|vss 4 rppd l=1.2 ps=0 b=0 m=1
R$2118 \$1397 \$1424 VSS|vss 4 rppd l=1.2 ps=0 b=0 m=1
R$2119 \$1398 \$1426 VSS|vss 4 rppd l=1.2 ps=0 b=0 m=1
R$2120 \$1399 \$1427 VSS|vss 4 rppd l=1.2 ps=0 b=0 m=1
R$2121 \$1400 \$1428 VSS|vss 4 rppd l=1.2 ps=0 b=0 m=1
R$2122 \$1401 \$1429 VSS|vss 4 rppd l=1.2 ps=0 b=0 m=1
R$2123 \$1402 \$1430 VSS|vss 4 rppd l=1.2 ps=0 b=0 m=1
R$2124 \$1404 \$1431 VSS|vss 4 rppd l=1.2 ps=0 b=0 m=1
R$2125 \$1405 \$1433 VSS|vss 4 rppd l=1.2 ps=0 b=0 m=1
R$2126 \$1407 \$1434 VSS|vss 4 rppd l=1.2 ps=0 b=0 m=1
R$2127 \$1416 \$1440 VSS|vss 4 rppd l=1.2 ps=0 b=0 m=1
R$2128 \$1417 \$1441 VSS|vss 4 rppd l=1.2 ps=0 b=0 m=1
R$2129 \$1418 \$1442 VSS|vss 4 rppd l=1.2 ps=0 b=0 m=1
R$2130 \$1419 \$1455 VSS|vss 4 rppd l=1.2 ps=0 b=0 m=1
R$2131 \$1420 \$1443 VSS|vss 4 rppd l=1.2 ps=0 b=0 m=1
R$2132 \$1421 \$1444 VSS|vss 4 rppd l=1.2 ps=0 b=0 m=1
R$2133 \$1423 \$1445 VSS|vss 4 rppd l=1.2 ps=0 b=0 m=1
R$2134 \$1424 \$1446 VSS|vss 4 rppd l=1.2 ps=0 b=0 m=1
R$2135 \$1426 \$1447 VSS|vss 4 rppd l=1.2 ps=0 b=0 m=1
R$2136 \$1427 \$1448 VSS|vss 4 rppd l=1.2 ps=0 b=0 m=1
R$2137 \$1428 \$1449 VSS|vss 4 rppd l=1.2 ps=0 b=0 m=1
R$2138 \$1429 \$1450 VSS|vss 4 rppd l=1.2 ps=0 b=0 m=1
R$2139 \$1430 \$1451 VSS|vss 4 rppd l=1.2 ps=0 b=0 m=1
R$2140 \$1431 \$1452 VSS|vss 4 rppd l=1.2 ps=0 b=0 m=1
R$2141 \$1433 \$1453 VSS|vss 4 rppd l=1.2 ps=0 b=0 m=1
R$2142 \$1434 \$1454 VSS|vss 4 rppd l=1.2 ps=0 b=0 m=1
R$2143 \$1440 \$1460 VSS|vss 4 rppd l=1.2 ps=0 b=0 m=1
R$2144 \$1441 \$1461 VSS|vss 4 rppd l=1.2 ps=0 b=0 m=1
R$2145 \$1442 \$1462 VSS|vss 4 rppd l=1.2 ps=0 b=0 m=1
R$2146 \$1455 \$1463 VSS|vss 4 rppd l=1.2 ps=0 b=0 m=1
R$2147 \$1443 \$1464 VSS|vss 4 rppd l=1.2 ps=0 b=0 m=1
R$2148 \$1444 \$1465 VSS|vss 4 rppd l=1.2 ps=0 b=0 m=1
R$2149 \$1445 \$1466 VSS|vss 4 rppd l=1.2 ps=0 b=0 m=1
R$2150 \$1446 \$1467 VSS|vss 4 rppd l=1.2 ps=0 b=0 m=1
R$2151 \$1447 \$1468 VSS|vss 4 rppd l=1.2 ps=0 b=0 m=1
R$2152 \$1448 \$1469 VSS|vss 4 rppd l=1.2 ps=0 b=0 m=1
R$2153 \$1449 \$1470 VSS|vss 4 rppd l=1.2 ps=0 b=0 m=1
R$2154 \$1450 \$1471 VSS|vss 4 rppd l=1.2 ps=0 b=0 m=1
R$2155 \$1451 \$1472 VSS|vss 4 rppd l=1.2 ps=0 b=0 m=1
R$2156 \$1452 \$1473 VSS|vss 4 rppd l=1.2 ps=0 b=0 m=1
R$2157 \$1453 \$1474 VSS|vss 4 rppd l=1.2 ps=0 b=0 m=1
R$2158 \$1454 \$1475 VSS|vss 4 rppd l=1.2 ps=0 b=0 m=1
R$2159 \$1460 \$1476 VSS|vss 4 rppd l=1.2 ps=0 b=0 m=1
R$2160 \$1461 \$1477 VSS|vss 4 rppd l=1.2 ps=0 b=0 m=1
R$2161 \$1462 \$1478 VSS|vss 4 rppd l=1.2 ps=0 b=0 m=1
R$2162 \$1463 \$1479 VSS|vss 4 rppd l=1.2 ps=0 b=0 m=1
R$2163 \$1464 \$1480 VSS|vss 4 rppd l=1.2 ps=0 b=0 m=1
R$2164 \$1465 \$1483 VSS|vss 4 rppd l=1.2 ps=0 b=0 m=1
R$2165 \$1466 \$1484 VSS|vss 4 rppd l=1.2 ps=0 b=0 m=1
R$2166 \$1467 \$1487 VSS|vss 4 rppd l=1.2 ps=0 b=0 m=1
R$2167 \$1468 \$1488 VSS|vss 4 rppd l=1.2 ps=0 b=0 m=1
R$2168 \$1469 \$1489 VSS|vss 4 rppd l=1.2 ps=0 b=0 m=1
R$2169 \$1470 \$1490 VSS|vss 4 rppd l=1.2 ps=0 b=0 m=1
R$2170 \$1471 \$1491 VSS|vss 4 rppd l=1.2 ps=0 b=0 m=1
R$2171 \$1472 \$1492 VSS|vss 4 rppd l=1.2 ps=0 b=0 m=1
R$2172 \$1473 \$1494 VSS|vss 4 rppd l=1.2 ps=0 b=0 m=1
R$2173 \$1474 \$1496 VSS|vss 4 rppd l=1.2 ps=0 b=0 m=1
R$2174 \$1475 \$1499 VSS|vss 4 rppd l=1.2 ps=0 b=0 m=1
R$2175 \$1476 \$1504 VSS|vss 4 rppd l=1.2 ps=0 b=0 m=1
R$2176 \$1477 \$1505 VSS|vss 4 rppd l=1.2 ps=0 b=0 m=1
R$2177 \$1478 \$1506 VSS|vss 4 rppd l=1.2 ps=0 b=0 m=1
R$2178 \$1479 \$1507 VSS|vss 4 rppd l=1.2 ps=0 b=0 m=1
R$2179 \$1480 \$1508 VSS|vss 4 rppd l=1.2 ps=0 b=0 m=1
R$2180 \$1483 \$1509 VSS|vss 4 rppd l=1.2 ps=0 b=0 m=1
R$2181 \$1484 \$1511 VSS|vss 4 rppd l=1.2 ps=0 b=0 m=1
R$2182 \$1487 \$1512 VSS|vss 4 rppd l=1.2 ps=0 b=0 m=1
R$2183 \$1488 \$1514 VSS|vss 4 rppd l=1.2 ps=0 b=0 m=1
R$2184 \$1489 \$1515 VSS|vss 4 rppd l=1.2 ps=0 b=0 m=1
R$2185 \$1490 \$1516 VSS|vss 4 rppd l=1.2 ps=0 b=0 m=1
R$2186 \$1491 \$1517 VSS|vss 4 rppd l=1.2 ps=0 b=0 m=1
R$2187 \$1492 \$1518 VSS|vss 4 rppd l=1.2 ps=0 b=0 m=1
R$2188 \$1494 \$1519 VSS|vss 4 rppd l=1.2 ps=0 b=0 m=1
R$2189 \$1496 \$1521 VSS|vss 4 rppd l=1.2 ps=0 b=0 m=1
R$2190 \$1499 \$1522 VSS|vss 4 rppd l=1.2 ps=0 b=0 m=1
R$2191 \$1504 \$1532 VSS|vss 4 rppd l=1.2 ps=0 b=0 m=1
R$2192 \$1505 \$1533 VSS|vss 4 rppd l=1.2 ps=0 b=0 m=1
R$2193 \$1506 \$1534 VSS|vss 4 rppd l=1.2 ps=0 b=0 m=1
R$2194 \$1507 \$1535 VSS|vss 4 rppd l=1.2 ps=0 b=0 m=1
R$2195 \$1508 \$1536 VSS|vss 4 rppd l=1.2 ps=0 b=0 m=1
R$2196 \$1509 \$1537 VSS|vss 4 rppd l=1.2 ps=0 b=0 m=1
R$2197 \$1511 \$1538 VSS|vss 4 rppd l=1.2 ps=0 b=0 m=1
R$2198 \$1512 \$1539 VSS|vss 4 rppd l=1.2 ps=0 b=0 m=1
R$2199 \$1514 \$1540 VSS|vss 4 rppd l=1.2 ps=0 b=0 m=1
R$2200 \$1515 \$1541 VSS|vss 4 rppd l=1.2 ps=0 b=0 m=1
R$2201 \$1516 \$1542 VSS|vss 4 rppd l=1.2 ps=0 b=0 m=1
R$2202 \$1517 \$1543 VSS|vss 4 rppd l=1.2 ps=0 b=0 m=1
R$2203 \$1518 \$1544 VSS|vss 4 rppd l=1.2 ps=0 b=0 m=1
R$2204 \$1519 \$1545 VSS|vss 4 rppd l=1.2 ps=0 b=0 m=1
R$2205 \$1521 \$1546 VSS|vss 4 rppd l=1.2 ps=0 b=0 m=1
R$2206 \$1522 \$1547 VSS|vss 4 rppd l=1.2 ps=0 b=0 m=1
R$2207 \$1532 \$1556 VSS|vss 4 rppd l=1.2 ps=0 b=0 m=1
R$2208 \$1533 \$1557 VSS|vss 4 rppd l=1.2 ps=0 b=0 m=1
R$2209 \$1534 \$1558 VSS|vss 4 rppd l=1.2 ps=0 b=0 m=1
R$2210 \$1535 \$1559 VSS|vss 4 rppd l=1.2 ps=0 b=0 m=1
R$2211 \$1536 \$1560 VSS|vss 4 rppd l=1.2 ps=0 b=0 m=1
R$2212 \$1537 \$1561 VSS|vss 4 rppd l=1.2 ps=0 b=0 m=1
R$2213 \$1538 \$1562 VSS|vss 4 rppd l=1.2 ps=0 b=0 m=1
R$2214 \$1539 \$1563 VSS|vss 4 rppd l=1.2 ps=0 b=0 m=1
R$2215 \$1540 \$1564 VSS|vss 4 rppd l=1.2 ps=0 b=0 m=1
R$2216 \$1541 \$1565 VSS|vss 4 rppd l=1.2 ps=0 b=0 m=1
R$2217 \$1542 \$1566 VSS|vss 4 rppd l=1.2 ps=0 b=0 m=1
R$2218 \$1543 \$1567 VSS|vss 4 rppd l=1.2 ps=0 b=0 m=1
R$2219 \$1544 \$1568 VSS|vss 4 rppd l=1.2 ps=0 b=0 m=1
R$2220 \$1545 \$1569 VSS|vss 4 rppd l=1.2 ps=0 b=0 m=1
R$2221 \$1546 \$1570 VSS|vss 4 rppd l=1.2 ps=0 b=0 m=1
R$2222 \$1547 \$1571 VSS|vss 4 rppd l=1.2 ps=0 b=0 m=1
R$2223 \$1556 \$1576 VSS|vss 4 rppd l=1.2 ps=0 b=0 m=1
R$2224 \$1557 \$1577 VSS|vss 4 rppd l=1.2 ps=0 b=0 m=1
R$2225 \$1558 \$1578 VSS|vss 4 rppd l=1.2 ps=0 b=0 m=1
R$2226 \$1559 \$1579 VSS|vss 4 rppd l=1.2 ps=0 b=0 m=1
R$2227 \$1560 \$1580 VSS|vss 4 rppd l=1.2 ps=0 b=0 m=1
R$2228 \$1561 \$1582 VSS|vss 4 rppd l=1.2 ps=0 b=0 m=1
R$2229 \$1562 \$1583 VSS|vss 4 rppd l=1.2 ps=0 b=0 m=1
R$2230 \$1563 \$1585 VSS|vss 4 rppd l=1.2 ps=0 b=0 m=1
R$2231 \$1564 \$1586 VSS|vss 4 rppd l=1.2 ps=0 b=0 m=1
R$2232 \$1565 \$1587 VSS|vss 4 rppd l=1.2 ps=0 b=0 m=1
R$2233 \$1566 \$1588 VSS|vss 4 rppd l=1.2 ps=0 b=0 m=1
R$2234 \$1567 \$1589 VSS|vss 4 rppd l=1.2 ps=0 b=0 m=1
R$2235 \$1568 \$1590 VSS|vss 4 rppd l=1.2 ps=0 b=0 m=1
R$2236 \$1569 \$1592 VSS|vss 4 rppd l=1.2 ps=0 b=0 m=1
R$2237 \$1570 \$1593 VSS|vss 4 rppd l=1.2 ps=0 b=0 m=1
R$2238 \$1571 \$1595 VSS|vss 4 rppd l=1.2 ps=0 b=0 m=1
R$2239 \$1576 \$1596 VSS|vss 4 rppd l=1.2 ps=0 b=0 m=1
R$2240 \$1577 \$1597 VSS|vss 4 rppd l=1.2 ps=0 b=0 m=1
R$2241 \$1578 \$1598 VSS|vss 4 rppd l=1.2 ps=0 b=0 m=1
R$2242 \$1579 \$1599 VSS|vss 4 rppd l=1.2 ps=0 b=0 m=1
R$2243 \$1580 \$1601 VSS|vss 4 rppd l=1.2 ps=0 b=0 m=1
R$2244 \$1582 \$1602 VSS|vss 4 rppd l=1.2 ps=0 b=0 m=1
R$2245 \$1583 \$1605 VSS|vss 4 rppd l=1.2 ps=0 b=0 m=1
R$2246 \$1585 \$1606 VSS|vss 4 rppd l=1.2 ps=0 b=0 m=1
R$2247 \$1586 \$1608 VSS|vss 4 rppd l=1.2 ps=0 b=0 m=1
R$2248 \$1587 \$1609 VSS|vss 4 rppd l=1.2 ps=0 b=0 m=1
R$2249 \$1588 \$1610 VSS|vss 4 rppd l=1.2 ps=0 b=0 m=1
R$2250 \$1589 \$1611 VSS|vss 4 rppd l=1.2 ps=0 b=0 m=1
R$2251 \$1590 \$1612 VSS|vss 4 rppd l=1.2 ps=0 b=0 m=1
R$2252 \$1592 \$1614 VSS|vss 4 rppd l=1.2 ps=0 b=0 m=1
R$2253 \$1593 \$1617 VSS|vss 4 rppd l=1.2 ps=0 b=0 m=1
R$2254 \$1595 \$1618 VSS|vss 4 rppd l=1.2 ps=0 b=0 m=1
R$2255 \$1596 \$1624 VSS|vss 4 rppd l=1.2 ps=0 b=0 m=1
R$2256 \$1597 \$1625 VSS|vss 4 rppd l=1.2 ps=0 b=0 m=1
R$2257 \$1598 \$1626 VSS|vss 4 rppd l=1.2 ps=0 b=0 m=1
R$2258 \$1599 \$1627 VSS|vss 4 rppd l=1.2 ps=0 b=0 m=1
R$2259 \$1601 \$1628 VSS|vss 4 rppd l=1.2 ps=0 b=0 m=1
R$2260 \$1602 \$1629 VSS|vss 4 rppd l=1.2 ps=0 b=0 m=1
R$2261 \$1605 \$1630 VSS|vss 4 rppd l=1.2 ps=0 b=0 m=1
R$2262 \$1606 \$1631 VSS|vss 4 rppd l=1.2 ps=0 b=0 m=1
R$2263 \$1608 \$1632 VSS|vss 4 rppd l=1.2 ps=0 b=0 m=1
R$2264 \$1609 \$1633 VSS|vss 4 rppd l=1.2 ps=0 b=0 m=1
R$2265 \$1610 \$1634 VSS|vss 4 rppd l=1.2 ps=0 b=0 m=1
R$2266 \$1611 \$1635 VSS|vss 4 rppd l=1.2 ps=0 b=0 m=1
R$2267 \$1612 \$1636 VSS|vss 4 rppd l=1.2 ps=0 b=0 m=1
R$2268 \$1614 \$1637 VSS|vss 4 rppd l=1.2 ps=0 b=0 m=1
R$2269 \$1617 \$1638 VSS|vss 4 rppd l=1.2 ps=0 b=0 m=1
R$2270 \$1618 \$1639 VSS|vss 4 rppd l=1.2 ps=0 b=0 m=1
R$2271 \$1624 \$1644 VSS|vss 4 rppd l=1.2 ps=0 b=0 m=1
R$2272 \$1625 \$1645 VSS|vss 4 rppd l=1.2 ps=0 b=0 m=1
R$2273 \$1626 \$1646 VSS|vss 4 rppd l=1.2 ps=0 b=0 m=1
R$2274 \$1627 \$1647 VSS|vss 4 rppd l=1.2 ps=0 b=0 m=1
R$2275 \$1628 \$1648 VSS|vss 4 rppd l=1.2 ps=0 b=0 m=1
R$2276 \$1629 \$1649 VSS|vss 4 rppd l=1.2 ps=0 b=0 m=1
R$2277 \$1630 \$1650 VSS|vss 4 rppd l=1.2 ps=0 b=0 m=1
R$2278 \$1631 \$1651 VSS|vss 4 rppd l=1.2 ps=0 b=0 m=1
R$2279 \$1632 \$1652 VSS|vss 4 rppd l=1.2 ps=0 b=0 m=1
R$2280 \$1633 \$1653 VSS|vss 4 rppd l=1.2 ps=0 b=0 m=1
R$2281 \$1634 \$1654 VSS|vss 4 rppd l=1.2 ps=0 b=0 m=1
R$2282 \$1635 \$1662 VSS|vss 4 rppd l=1.2 ps=0 b=0 m=1
R$2283 \$1636 \$1655 VSS|vss 4 rppd l=1.2 ps=0 b=0 m=1
R$2284 \$1637 \$1656 VSS|vss 4 rppd l=1.2 ps=0 b=0 m=1
R$2285 \$1638 \$1657 VSS|vss 4 rppd l=1.2 ps=0 b=0 m=1
R$2286 \$1639 \$1658 VSS|vss 4 rppd l=1.2 ps=0 b=0 m=1
R$2287 \$1644 \$1665 VSS|vss 4 rppd l=1.2 ps=0 b=0 m=1
R$2288 \$1645 \$1665 VSS|vss 4 rppd l=1.2 ps=0 b=0 m=1
R$2289 \$1646 \$1666 VSS|vss 4 rppd l=1.2 ps=0 b=0 m=1
R$2290 \$1647 \$1666 VSS|vss 4 rppd l=1.2 ps=0 b=0 m=1
R$2291 \$1648 \$1667 VSS|vss 4 rppd l=1.2 ps=0 b=0 m=1
R$2292 \$1649 \$1667 VSS|vss 4 rppd l=1.2 ps=0 b=0 m=1
R$2293 \$1650 \$1668 VSS|vss 4 rppd l=1.2 ps=0 b=0 m=1
R$2294 \$1651 \$1668 VSS|vss 4 rppd l=1.2 ps=0 b=0 m=1
R$2295 \$1652 \$1669 VSS|vss 4 rppd l=1.2 ps=0 b=0 m=1
R$2296 \$1653 \$1669 VSS|vss 4 rppd l=1.2 ps=0 b=0 m=1
R$2297 \$1654 \$1661 VSS|vss 4 rppd l=1.2 ps=0 b=0 m=1
R$2298 \$1662 \$1661 VSS|vss 4 rppd l=1.2 ps=0 b=0 m=1
R$2299 \$1655 \$1670 VSS|vss 4 rppd l=1.2 ps=0 b=0 m=1
R$2300 \$1656 \$1670 VSS|vss 4 rppd l=1.2 ps=0 b=0 m=1
R$2301 \$1657 \$1671 VSS|vss 4 rppd l=1.2 ps=0 b=0 m=1
R$2302 \$1658 \$1671 VSS|vss 4 rppd l=1.2 ps=0 b=0 m=1
R$2303 ISENSE|isense \$1709 VSS|vss 2 rppd l=38.35 ps=0 b=0 m=1
R$2304 \$1674 \$1709 VSS|vss 2 rppd l=38.35 ps=0 b=0 m=1
R$2305 \$1674 \$1710 VSS|vss 2 rppd l=38.35 ps=0 b=0 m=1
R$2306 \$1675 \$1710 VSS|vss 2 rppd l=38.35 ps=0 b=0 m=1
R$2307 \$1675 \$1711 VSS|vss 2 rppd l=38.35 ps=0 b=0 m=1
R$2308 \$1676 \$1711 VSS|vss 2 rppd l=38.35 ps=0 b=0 m=1
R$2309 \$1676 \$1712 VSS|vss 2 rppd l=38.35 ps=0 b=0 m=1
R$2310 \$1677 \$1712 VSS|vss 2 rppd l=38.35 ps=0 b=0 m=1
R$2311 \$1677 \$1713 VSS|vss 2 rppd l=38.35 ps=0 b=0 m=1
R$2312 icmp|inp \$1713 VSS|vss 2 rppd l=38.35 ps=0 b=0 m=1
R$2313 icmp|inp \$1714 VSS|vss 2 rppd l=38.35 ps=0 b=0 m=1
R$2314 \$1678 \$1714 VSS|vss 2 rppd l=38.35 ps=0 b=0 m=1
R$2315 \$1678 \$1715 VSS|vss 2 rppd l=38.35 ps=0 b=0 m=1
R$2316 \$1679 \$1715 VSS|vss 2 rppd l=38.35 ps=0 b=0 m=1
R$2317 \$1679 \$1716 VSS|vss 2 rppd l=38.35 ps=0 b=0 m=1
R$2318 \$1680 \$1716 VSS|vss 2 rppd l=38.35 ps=0 b=0 m=1
R$2319 \$1680 \$1717 VSS|vss 2 rppd l=38.35 ps=0 b=0 m=1
R$2320 \$1681 \$1717 VSS|vss 2 rppd l=38.35 ps=0 b=0 m=1
R$2321 \$1681 \$1718 VSS|vss 2 rppd l=38.35 ps=0 b=0 m=1
R$2322 VSS|vss \$1718 VSS|vss 2 rppd l=38.35 ps=0 b=0 m=1
Cext_1 \$100 \$101 127.349a
Cext_2 \$100 \$111 130.175a
Cext_3 \$100 \$112 130.175a
Cext_4 \$100 \$35 21.4379a
Cext_5 \$100 \$37 7.13122a
Cext_6 \$100 \$39 4.58402a
Cext_7 \$100 \$41 3.11572a
Cext_8 \$100 \$43 2.10552a
Cext_9 \$100 \$45 1.54964a
Cext_10 \$100 \$47 1.17974a
Cext_11 \$100 \$49 0.837144a
Cext_12 \$100 \$67 131.536a
Cext_13 \$100 \$69 8.58503a
Cext_14 \$100 \$71 5.83606a
Cext_15 \$100 \$73 3.76228a
Cext_16 \$100 \$75 2.60655a
Cext_17 \$100 \$77 1.7981a
Cext_18 \$100 \$79 1.34685a
Cext_19 \$100 \$81 0.943525a
Cext_20 \$100 VDD|vdd 4.00216a
Cext_21 \$100 VSS|vss 139.071a
Cext_22 \$100 VSUBS 2.81006f
Cext_23 \$1000 \$1001 0.179323a
Cext_24 \$1000 \$1021 227.572a
Cext_25 \$1000 \$1065 98.5952a
Cext_26 \$1000 \$1142 1.46644a
Cext_27 \$1000 \$1278 27.2011a
Cext_28 \$1000 \$35 0.496172a
Cext_29 \$1000 \$37 82.9986a
Cext_30 \$1000 \$39 47.1389a
Cext_31 \$1000 \$41 0.329802a
Cext_32 \$1000 \$67 2.30683a
Cext_33 \$1000 \$69 115.665a
Cext_34 \$1000 \$71 7.5941a
Cext_35 \$1000 \$73 3.82035a
Cext_36 \$1000 \$75 1.52179a
Cext_37 \$1000 \$77 1.0724a
Cext_38 \$1000 \$886 0.110044a
Cext_39 \$1000 \$917 5.42703a
Cext_40 \$1000 \$936 7.41179a
Cext_41 \$1000 \$986 788.061a
Cext_42 \$1000 \$999 2.46853a
Cext_43 \$1000 IOVDD|vdda 5.1897a
Cext_44 \$1000 VSUBS 167.598a
Cext_45 \$1001 \$1023 254.864a
Cext_46 \$1001 \$1047 0.360462a
Cext_47 \$1001 \$1278 5.60736a
Cext_48 \$1001 \$35 23.4429a
Cext_49 \$1001 \$39 0.251943a
Cext_50 \$1001 \$41 0.282145a
Cext_51 \$1001 \$43 0.494517a
Cext_52 \$1001 \$45 20.9159a
Cext_53 \$1001 \$67 110.011a
Cext_54 \$1001 \$77 0.107779a
Cext_55 \$1001 \$888 52.4402a
Cext_56 \$1001 \$917 8.93332a
Cext_57 \$1001 \$966 3.25406a
Cext_58 \$1001 \$981 225.319a
Cext_59 \$1001 \$987 102.889a
Cext_60 \$1001 VSS|vss 66.2132a
Cext_61 \$1001 VSUBS 818.365a
Cext_62 \$1002 \$1003 45.0654a
Cext_63 \$1002 \$1027 130.128a
Cext_64 \$1002 \$982 130.128a
Cext_65 \$1002 VDD|vdd 0.592094a
Cext_66 \$1002 VSS|vss 25.1792a
Cext_67 \$1002 VSUBS 659.267a
Cext_68 \$1003 \$1004 45.0654a
Cext_69 \$1003 \$1028 130.175a
Cext_70 \$1003 \$968 130.175a
Cext_71 \$1003 VSS|vss 5.452a
Cext_72 \$1003 VSUBS 634.529a
Cext_73 \$1004 \$1005 45.0654a
Cext_74 \$1004 \$1029 130.175a
Cext_75 \$1004 \$969 130.175a
Cext_76 \$1004 VSUBS 634.529a
Cext_77 \$1005 \$1006 45.8951a
Cext_78 \$1005 \$1030 130.175a
Cext_79 \$1005 \$983 130.175a
Cext_80 \$1005 VSS|vss 0.428128a
Cext_81 \$1005 VSUBS 634.529a
Cext_82 \$1006 \$1007 2.46853a
Cext_83 \$1006 \$1031 225.319a
Cext_84 \$1006 \$1032 102.889a
Cext_85 \$1006 \$51 22.8071a
Cext_86 \$1006 \$83 105.489a
Cext_87 \$1006 \$890 0.270358a
Cext_88 \$1006 \$970 0.360462a
Cext_89 \$1006 \$971 254.864a
Cext_90 \$1006 VSS|vss 61.1015a
Cext_91 \$1006 VSUBS 793.935a
Cext_92 \$1007 \$1008 0.179323a
Cext_93 \$1007 \$1032 227.572a
Cext_94 \$1007 \$1066 98.5952a
Cext_95 \$1007 \$1144 1.46644a
Cext_96 \$1007 \$1280 27.2011a
Cext_97 \$1007 \$51 0.496172a
Cext_98 \$1007 \$53 82.9986a
Cext_99 \$1007 \$55 47.1389a
Cext_100 \$1007 \$57 0.329802a
Cext_101 \$1007 \$83 2.30683a
Cext_102 \$1007 \$85 115.665a
Cext_103 \$1007 \$87 7.5941a
Cext_104 \$1007 \$89 3.82035a
Cext_105 \$1007 \$890 12.3042a
Cext_106 \$1007 \$91 1.52179a
Cext_107 \$1007 \$93 1.0724a
Cext_108 \$1007 \$938 7.41179a
Cext_109 \$1007 \$988 788.061a
Cext_110 \$1007 VSUBS 167.598a
Cext_111 \$1008 \$1033 254.864a
Cext_112 \$1008 \$1054 0.360462a
Cext_113 \$1008 \$1280 5.60736a
Cext_114 \$1008 \$51 23.4429a
Cext_115 \$1008 \$55 0.251943a
Cext_116 \$1008 \$57 0.282145a
Cext_117 \$1008 \$59 0.494517a
Cext_118 \$1008 \$61 20.9159a
Cext_119 \$1008 \$83 110.011a
Cext_120 \$1008 \$890 9.79229a
Cext_121 \$1008 \$929 0.270358a
Cext_122 \$1008 \$93 0.107779a
Cext_123 \$1008 \$972 225.319a
Cext_124 \$1008 \$973 3.25406a
Cext_125 \$1008 \$989 102.889a
Cext_126 \$1008 VSS|vss 66.2132a
Cext_127 \$1008 VSUBS 818.365a
Cext_128 \$1009 \$1010 2.46853a
Cext_129 \$1009 \$1036 102.889a
Cext_130 \$1009 \$1037 225.319a
Cext_131 \$1009 \$1309 5.04708a
Cext_132 \$1009 \$51 22.8071a
Cext_133 \$1009 \$55 0.500702a
Cext_134 \$1009 \$57 0.115752a
Cext_135 \$1009 \$59 0.481837a
Cext_136 \$1009 \$61 20.9928a
Cext_137 \$1009 \$83 105.489a
Cext_138 \$1009 \$929 13.7915a
Cext_139 \$1009 \$973 0.179323a
Cext_140 \$1009 \$974 0.360462a
Cext_141 \$1009 \$975 254.864a
Cext_142 \$1009 IOVDD|vdda 11.6291a
Cext_143 \$1009 VSS|vss 60.9228a
Cext_144 \$1009 VSUBS 810.925a
Cext_145 \$101 \$113 130.175a
Cext_146 \$101 \$114 225.226a
Cext_147 \$101 \$115 102.928a
Cext_148 \$101 \$35 39.2381a
Cext_149 \$101 \$37 16.6189a
Cext_150 \$101 \$39 10.0058a
Cext_151 \$101 \$41 4.74982a
Cext_152 \$101 \$43 3.02226a
Cext_153 \$101 \$45 2.0536a
Cext_154 \$101 \$47 1.38254a
Cext_155 \$101 \$49 0.995999a
Cext_156 \$101 \$67 316.612a
Cext_157 \$101 \$69 21.6723a
Cext_158 \$101 \$71 11.4687a
Cext_159 \$101 \$73 5.65121a
Cext_160 \$101 \$75 3.83514a
Cext_161 \$101 \$77 2.83592a
Cext_162 \$101 \$79 1.57839a
Cext_163 \$101 \$81 1.12243a
Cext_164 \$101 VSS|vss 8.77077a
Cext_165 \$101 VSUBS 3.11198f
Cext_166 \$1010 \$1011 0.179323a
Cext_167 \$1010 \$1036 227.572a
Cext_168 \$1010 \$1067 98.5952a
Cext_169 \$1010 \$1146 1.46644a
Cext_170 \$1010 \$1282 27.2011a
Cext_171 \$1010 \$51 0.496172a
Cext_172 \$1010 \$53 82.9986a
Cext_173 \$1010 \$55 47.1389a
Cext_174 \$1010 \$57 0.329802a
Cext_175 \$1010 \$83 2.30683a
Cext_176 \$1010 \$85 115.665a
Cext_177 \$1010 \$87 7.5941a
Cext_178 \$1010 \$89 3.82035a
Cext_179 \$1010 \$890 0.110044a
Cext_180 \$1010 \$91 1.52179a
Cext_181 \$1010 \$929 5.42703a
Cext_182 \$1010 \$93 1.0724a
Cext_183 \$1010 \$940 7.41179a
Cext_184 \$1010 \$990 788.061a
Cext_185 \$1010 IOVDD|vdda 5.1897a
Cext_186 \$1010 VSS|vss 5.67282a
Cext_187 \$1010 VSUBS 167.598a
Cext_188 \$1011 \$1038 254.864a
Cext_189 \$1011 \$1058 0.360462a
Cext_190 \$1011 \$1282 5.60736a
Cext_191 \$1011 \$51 23.4429a
Cext_192 \$1011 \$55 0.251943a
Cext_193 \$1011 \$57 0.282145a
Cext_194 \$1011 \$59 0.494517a
Cext_195 \$1011 \$61 20.9159a
Cext_196 \$1011 \$83 110.011a
Cext_197 \$1011 \$892 52.4402a
Cext_198 \$1011 \$929 8.93332a
Cext_199 \$1011 \$93 0.107779a
Cext_200 \$1011 \$976 225.319a
Cext_201 \$1011 \$977 3.25406a
Cext_202 \$1011 \$991 102.889a
Cext_203 \$1011 VSS|vss 75.4228a
Cext_204 \$1011 VSUBS 818.365a
Cext_205 \$1012 \$1013 45.0654a
Cext_206 \$1012 \$1060 130.175a
Cext_207 \$1012 \$992 130.175a
Cext_208 \$1012 VDD|vdd 7.74075a
Cext_209 \$1012 VSS|vss 1.71997a
Cext_210 \$1012 VSUBS 659.267a
Cext_211 \$1013 \$1014 45.0654a
Cext_212 \$1013 \$1042 130.175a
Cext_213 \$1013 \$993 130.175a
Cext_214 \$1013 VDD|vdd 0.968272a
Cext_215 \$1013 VSUBS 634.529a
Cext_216 \$1014 \$1015 45.0654a
Cext_217 \$1014 \$1043 130.175a
Cext_218 \$1014 \$994 130.175a
Cext_219 \$1014 VSUBS 634.529a
Cext_220 \$1015 \$1017 46.4004a
Cext_221 \$1015 \$1061 130.175a
Cext_222 \$1015 \$995 130.175a
Cext_223 \$1015 VSS|vss 0.378729a
Cext_224 \$1015 VSUBS 634.529a
Cext_225 \$1016 \$1017 114.006a
Cext_226 \$1016 \$1018 0.182933a
Cext_227 \$1016 \$1044 0.360462a
Cext_228 \$1016 \$1064 108.267a
Cext_229 \$1016 \$1276 14.2573a
Cext_230 \$1016 \$35 134.708a
Cext_231 \$1016 \$37 19.3729a
Cext_232 \$1016 \$39 1.18572a
Cext_233 \$1016 \$67 69.9941a
Cext_234 \$1016 \$69 117.46a
Cext_235 \$1016 \$71 32.765a
Cext_236 \$1016 \$73 32.5775a
Cext_237 \$1016 \$75 35.6349a
Cext_238 \$1016 \$77 45.7852a
Cext_239 \$1016 \$886 4.79504a
Cext_240 \$1016 \$961 0.360462a
Cext_241 \$1016 \$962 42.153a
Cext_242 \$1016 \$984 18.2111a
Cext_243 \$1016 \$996 102.889a
Cext_244 \$1016 \$997 227.572a
Cext_245 \$1016 VSS|vss 0.378848a
Cext_246 \$1016 VSUBS 255.476a
Cext_247 \$1017 \$1044 254.864a
Cext_248 \$1017 \$1064 0.360462a
Cext_249 \$1017 \$35 68.8031a
Cext_250 \$1017 \$67 64.1221a
Cext_251 \$1017 \$69 0.155901a
Cext_252 \$1017 \$886 0.12478a
Cext_253 \$1017 \$996 225.319a
Cext_254 \$1017 VSS|vss 66.2906a
Cext_255 \$1017 VSUBS 799.746a
Cext_256 \$1018 \$1020 2.46853a
Cext_257 \$1018 \$1045 102.889a
Cext_258 \$1018 \$1046 225.319a
Cext_259 \$1018 \$1276 5.04708a
Cext_260 \$1018 \$35 68.8428a
Cext_261 \$1018 \$41 0.115752a
Cext_262 \$1018 \$43 0.481837a
Cext_263 \$1018 \$45 20.8391a
Cext_264 \$1018 \$67 58.9193a
Cext_265 \$1018 \$69 0.343978a
Cext_266 \$1018 \$886 14.1087a
Cext_267 \$1018 \$917 0.270358a
Cext_268 \$1018 \$985 0.360462a
Cext_269 \$1018 \$998 254.864a
Cext_270 \$1018 VSS|vss 60.9228a
Cext_271 \$1018 VSUBS 811.534a
Cext_272 \$1019 \$1020 788.061a
Cext_273 \$1019 \$1045 18.2111a
Cext_274 \$1019 \$1085 86.2689a
Cext_275 \$1019 \$1098 2.88751a
Cext_276 \$1019 \$1099 0.179323a
Cext_277 \$1019 \$1119 99.1454a
Cext_278 \$1019 \$1120 7.41179a
Cext_279 \$1019 \$1305 439.985a
Cext_280 \$1019 \$35 0.564032a
Cext_281 \$1019 \$37 53.8155a
Cext_282 \$1019 \$39 45.938a
Cext_283 \$1019 \$41 47.4094a
Cext_284 \$1019 \$45 0.104586a
Cext_285 \$1019 \$67 1.96577a
Cext_286 \$1019 \$69 68.8353a
Cext_287 \$1019 \$71 65.2142a
Cext_288 \$1019 \$73 3.38836a
Cext_289 \$1019 \$75 1.54387a
Cext_290 \$1019 \$77 0.997221a
Cext_291 \$1019 \$886 40.4783a
Cext_292 \$1019 \$917 20.5839a
Cext_293 \$1019 \$963 99.1454a
Cext_294 \$1019 \$985 0.250757a
Cext_295 \$1019 VSUBS 215.409a
Cext_296 \$102 \$116 239.132a
Cext_297 \$102 \$117 102.928a
Cext_298 \$102 \$118 241.699a
Cext_299 \$102 \$135 64.5855a
Cext_300 \$102 \$136 5.62808a
Cext_301 \$102 \$137 5.58536a
Cext_302 \$102 \$163 2.68012a
Cext_303 \$102 \$164 2.63597a
Cext_304 \$102 \$166 2.67468a
Cext_305 \$102 \$190 0.131941a
Cext_306 \$102 \$191 1.4857a
Cext_307 \$102 \$192 1.5425a
Cext_308 \$102 \$221 1.30495a
Cext_309 \$102 \$35 101.529a
Cext_310 \$102 \$37 64.0061a
Cext_311 \$102 \$39 49.4736a
Cext_312 \$102 \$41 46.6626a
Cext_313 \$102 \$43 50.1167a
Cext_314 \$102 \$45 179.87a
Cext_315 \$102 \$47 1.5668a
Cext_316 \$102 \$49 1.14035a
Cext_317 \$102 \$67 432.346a
Cext_318 \$102 \$69 67.2409a
Cext_319 \$102 \$71 48.7753a
Cext_320 \$102 \$73 44.0149a
Cext_321 \$102 \$75 44.4799a
Cext_322 \$102 \$77 41.0245a
Cext_323 \$102 \$79 3.34937a
Cext_324 \$102 \$81 1.28499a
Cext_325 \$102 IOVDD|vdda 27.2029a
Cext_326 \$102 VSS|vss 17.836a
Cext_327 \$102 VSUBS 4.2106f
Cext_328 \$1020 \$1022 0.179323a
Cext_329 \$1020 \$1045 227.572a
Cext_330 \$1020 \$1085 98.5952a
Cext_331 \$1020 \$1171 1.46644a
Cext_332 \$1020 \$1305 27.0741a
Cext_333 \$1020 \$35 2.95962a
Cext_334 \$1020 \$37 91.1126a
Cext_335 \$1020 \$39 1.18748a
Cext_336 \$1020 \$41 0.476813a
Cext_337 \$1020 \$69 106.511a
Cext_338 \$1020 \$71 53.5455a
Cext_339 \$1020 \$73 3.67334a
Cext_340 \$1020 \$75 1.52179a
Cext_341 \$1020 \$77 1.0724a
Cext_342 \$1020 \$886 5.83491a
Cext_343 \$1020 \$917 9.13424a
Cext_344 \$1020 \$963 7.41179a
Cext_345 \$1020 VSUBS 168.166a
Cext_346 \$1021 \$1022 114.006a
Cext_347 \$1021 \$1023 0.182933a
Cext_348 \$1021 \$1062 0.360462a
Cext_349 \$1021 \$1065 108.267a
Cext_350 \$1021 \$1278 14.2573a
Cext_351 \$1021 \$35 134.561a
Cext_352 \$1021 \$37 19.3729a
Cext_353 \$1021 \$39 1.18572a
Cext_354 \$1021 \$67 69.8469a
Cext_355 \$1021 \$69 117.46a
Cext_356 \$1021 \$71 32.765a
Cext_357 \$1021 \$73 32.5775a
Cext_358 \$1021 \$75 35.6349a
Cext_359 \$1021 \$77 45.7852a
Cext_360 \$1021 \$917 6.74989a
Cext_361 \$1021 \$964 42.153a
Cext_362 \$1021 \$965 0.360462a
Cext_363 \$1021 \$986 18.2111a
Cext_364 \$1021 \$999 102.889a
Cext_365 \$1021 IOVDD|vdda 41.0575a
Cext_366 \$1021 VSS|vss 0.378848a
Cext_367 \$1021 VSUBS 255.202a
Cext_368 \$1022 \$1062 254.864a
Cext_369 \$1022 \$1065 0.360462a
Cext_370 \$1022 \$1305 5.60736a
Cext_371 \$1022 \$35 68.8031a
Cext_372 \$1022 \$39 0.105966a
Cext_373 \$1022 \$41 0.282145a
Cext_374 \$1022 \$43 0.494517a
Cext_375 \$1022 \$45 20.9159a
Cext_376 \$1022 \$67 64.1221a
Cext_377 \$1022 \$69 0.155901a
Cext_378 \$1022 \$917 24.0706a
Cext_379 \$1022 \$999 225.319a
Cext_380 \$1022 IOVDD|vdda 13.0646a
Cext_381 \$1022 VSS|vss 66.2132a
Cext_382 \$1022 VSUBS 817.279a
Cext_383 \$1023 \$1025 2.46853a
Cext_384 \$1023 \$1047 102.889a
Cext_385 \$1023 \$1048 225.319a
Cext_386 \$1023 \$1278 5.04708a
Cext_387 \$1023 \$35 68.8428a
Cext_388 \$1023 \$41 0.115752a
Cext_389 \$1023 \$43 0.481837a
Cext_390 \$1023 \$45 20.8391a
Cext_391 \$1023 \$67 58.9193a
Cext_392 \$1023 \$69 0.343978a
Cext_393 \$1023 \$888 13.341a
Cext_394 \$1023 \$917 18.1165a
Cext_395 \$1023 \$987 0.360462a
Cext_396 \$1023 VSS|vss 60.9228a
Cext_397 \$1023 VSUBS 811.534a
Cext_398 \$1024 \$1025 788.061a
Cext_399 \$1024 \$1047 18.2111a
Cext_400 \$1024 \$1087 86.2689a
Cext_401 \$1024 \$1101 2.88751a
Cext_402 \$1024 \$1124 99.1454a
Cext_403 \$1024 \$1125 7.41179a
Cext_404 \$1024 \$1307 439.985a
Cext_405 \$1024 \$35 0.564032a
Cext_406 \$1024 \$37 53.8155a
Cext_407 \$1024 \$39 45.938a
Cext_408 \$1024 \$41 47.4094a
Cext_409 \$1024 \$45 0.104586a
Cext_410 \$1024 \$67 1.96577a
Cext_411 \$1024 \$69 68.8353a
Cext_412 \$1024 \$71 65.2142a
Cext_413 \$1024 \$73 3.38836a
Cext_414 \$1024 \$75 1.54387a
Cext_415 \$1024 \$77 0.997221a
Cext_416 \$1024 \$886 37.5623a
Cext_417 \$1024 \$888 3.83144a
Cext_418 \$1024 \$917 30.6036a
Cext_419 \$1024 \$966 99.1454a
Cext_420 \$1024 \$987 0.250757a
Cext_421 \$1024 VREF|vref 0.742539a
Cext_422 \$1024 VSUBS 215.406a
Cext_423 \$1025 \$1047 227.572a
Cext_424 \$1025 \$1087 98.5952a
Cext_425 \$1025 \$1175 1.46644a
Cext_426 \$1025 \$1307 27.0741a
Cext_427 \$1025 \$35 2.86905a
Cext_428 \$1025 \$37 91.1126a
Cext_429 \$1025 \$39 1.18748a
Cext_430 \$1025 \$41 0.476813a
Cext_431 \$1025 \$69 106.511a
Cext_432 \$1025 \$71 53.4686a
Cext_433 \$1025 \$73 3.56498a
Cext_434 \$1025 \$75 1.52179a
Cext_435 \$1025 \$77 1.0724a
Cext_436 \$1025 \$886 3.07213a
Cext_437 \$1025 \$888 1.96875a
Cext_438 \$1025 \$917 33.29a
Cext_439 \$1025 \$966 7.41179a
Cext_440 \$1025 VREF|vref 0.489684a
Cext_441 \$1025 VSUBS 167.788a
Cext_442 \$1027 \$1028 45.0654a
Cext_443 \$1027 \$1050 130.128a
Cext_444 \$1027 VDD|vdd 0.592094a
Cext_445 \$1027 VSS|vss 25.1792a
Cext_446 \$1027 VSUBS 659.267a
Cext_447 \$1028 \$1029 45.0654a
Cext_448 \$1028 \$1051 130.175a
Cext_449 \$1028 VSS|vss 5.452a
Cext_450 \$1028 VSUBS 634.529a
Cext_451 \$1029 \$1030 45.0654a
Cext_452 \$1029 \$1063 130.175a
Cext_453 \$1029 VSUBS 634.529a
Cext_454 \$103 \$119 239.132a
Cext_455 \$103 \$120 147.947a
Cext_456 \$103 \$139 64.5855a
Cext_457 \$103 \$140 5.62808a
Cext_458 \$103 \$141 6.06004a
Cext_459 \$103 \$167 2.68012a
Cext_460 \$103 \$168 2.63597a
Cext_461 \$103 \$169 2.90199a
Cext_462 \$103 \$195 0.131941a
Cext_463 \$103 \$196 1.4857a
Cext_464 \$103 \$197 1.6736a
Cext_465 \$103 \$225 1.30495a
Cext_466 \$103 \$35 76.5241a
Cext_467 \$103 \$37 63.1547a
Cext_468 \$103 \$39 49.246a
Cext_469 \$103 \$41 46.5873a
Cext_470 \$103 \$43 47.3348a
Cext_471 \$103 \$45 178.998a
Cext_472 \$103 \$47 1.79162a
Cext_473 \$103 \$49 1.40345a
Cext_474 \$103 \$67 273.735a
Cext_475 \$103 \$69 65.3165a
Cext_476 \$103 \$71 48.1728a
Cext_477 \$103 \$73 43.7063a
Cext_478 \$103 \$75 41.0209a
Cext_479 \$103 \$77 39.3302a
Cext_480 \$103 \$79 2.76873a
Cext_481 \$103 \$81 6.47863a
Cext_482 \$103 VSS|vss 9.06528a
Cext_483 \$103 VSUBS 4.01055f
Cext_484 \$1030 \$1031 46.4004a
Cext_485 \$1030 \$1052 130.175a
Cext_486 \$1030 VSS|vss 0.378729a
Cext_487 \$1030 VSUBS 634.529a
Cext_488 \$1031 \$1032 114.006a
Cext_489 \$1031 \$1053 254.864a
Cext_490 \$1031 \$1066 0.360462a
Cext_491 \$1031 \$51 68.8031a
Cext_492 \$1031 \$83 64.1221a
Cext_493 \$1031 \$85 0.155901a
Cext_494 \$1031 \$890 0.12478a
Cext_495 \$1031 VSS|vss 66.2906a
Cext_496 \$1031 VSUBS 799.746a
Cext_497 \$1032 \$1033 0.182933a
Cext_498 \$1032 \$1053 0.360462a
Cext_499 \$1032 \$1066 108.267a
Cext_500 \$1032 \$1280 14.2573a
Cext_501 \$1032 \$51 134.708a
Cext_502 \$1032 \$53 19.3729a
Cext_503 \$1032 \$55 1.18572a
Cext_504 \$1032 \$83 69.9941a
Cext_505 \$1032 \$85 117.46a
Cext_506 \$1032 \$87 32.765a
Cext_507 \$1032 \$89 32.5775a
Cext_508 \$1032 \$890 4.79504a
Cext_509 \$1032 \$91 35.6349a
Cext_510 \$1032 \$93 45.7852a
Cext_511 \$1032 \$970 42.153a
Cext_512 \$1032 \$971 0.360462a
Cext_513 \$1032 \$988 18.2111a
Cext_514 \$1032 VSS|vss 0.378848a
Cext_515 \$1032 VSUBS 255.476a
Cext_516 \$1033 \$1035 2.46853a
Cext_517 \$1033 \$1054 102.889a
Cext_518 \$1033 \$1055 225.319a
Cext_519 \$1033 \$1280 5.04708a
Cext_520 \$1033 \$51 68.8428a
Cext_521 \$1033 \$57 0.115752a
Cext_522 \$1033 \$59 0.481837a
Cext_523 \$1033 \$61 20.8391a
Cext_524 \$1033 \$83 58.9193a
Cext_525 \$1033 \$85 0.343978a
Cext_526 \$1033 \$890 14.1087a
Cext_527 \$1033 \$929 0.270358a
Cext_528 \$1033 \$989 0.360462a
Cext_529 \$1033 VSS|vss 60.9228a
Cext_530 \$1033 VSUBS 811.534a
Cext_531 \$1034 \$1035 788.061a
Cext_532 \$1034 \$1054 18.2111a
Cext_533 \$1034 \$1089 86.2689a
Cext_534 \$1034 \$1108 2.88751a
Cext_535 \$1034 \$1109 0.179323a
Cext_536 \$1034 \$1133 99.1454a
Cext_537 \$1034 \$1134 7.41179a
Cext_538 \$1034 \$1309 439.985a
Cext_539 \$1034 \$51 0.564032a
Cext_540 \$1034 \$53 53.8155a
Cext_541 \$1034 \$55 45.938a
Cext_542 \$1034 \$57 47.4094a
Cext_543 \$1034 \$61 0.104586a
Cext_544 \$1034 \$83 1.96577a
Cext_545 \$1034 \$85 68.8353a
Cext_546 \$1034 \$87 65.2142a
Cext_547 \$1034 \$89 3.38836a
Cext_548 \$1034 \$890 40.4783a
Cext_549 \$1034 \$91 1.54387a
Cext_550 \$1034 \$929 20.5839a
Cext_551 \$1034 \$93 0.997221a
Cext_552 \$1034 \$973 99.1454a
Cext_553 \$1034 \$989 0.250757a
Cext_554 \$1034 VSUBS 215.409a
Cext_555 \$1035 \$1037 0.179323a
Cext_556 \$1035 \$1054 227.572a
Cext_557 \$1035 \$1089 98.5952a
Cext_558 \$1035 \$1183 1.46644a
Cext_559 \$1035 \$1309 27.0741a
Cext_560 \$1035 \$51 2.95962a
Cext_561 \$1035 \$53 91.1126a
Cext_562 \$1035 \$55 1.18748a
Cext_563 \$1035 \$57 0.476813a
Cext_564 \$1035 \$85 106.511a
Cext_565 \$1035 \$87 53.5455a
Cext_566 \$1035 \$89 3.67334a
Cext_567 \$1035 \$890 5.83491a
Cext_568 \$1035 \$91 1.52179a
Cext_569 \$1035 \$929 9.13424a
Cext_570 \$1035 \$93 1.0724a
Cext_571 \$1035 \$973 7.41179a
Cext_572 \$1035 VSUBS 168.166a
Cext_573 \$1036 \$1037 114.006a
Cext_574 \$1036 \$1038 0.182933a
Cext_575 \$1036 \$1056 0.360462a
Cext_576 \$1036 \$1067 108.267a
Cext_577 \$1036 \$1282 14.2573a
Cext_578 \$1036 \$51 134.561a
Cext_579 \$1036 \$53 19.3729a
Cext_580 \$1036 \$55 1.18572a
Cext_581 \$1036 \$83 69.8469a
Cext_582 \$1036 \$85 117.46a
Cext_583 \$1036 \$87 32.765a
Cext_584 \$1036 \$89 32.5775a
Cext_585 \$1036 \$91 35.6349a
Cext_586 \$1036 \$929 6.74989a
Cext_587 \$1036 \$93 45.7852a
Cext_588 \$1036 \$974 42.153a
Cext_589 \$1036 \$975 0.360462a
Cext_590 \$1036 \$990 18.2111a
Cext_591 \$1036 IOVDD|vdda 41.0575a
Cext_592 \$1036 VSS|vss 3.4989a
Cext_593 \$1036 VSUBS 255.202a
Cext_594 \$1037 \$1056 254.864a
Cext_595 \$1037 \$1067 0.360462a
Cext_596 \$1037 \$1309 5.60736a
Cext_597 \$1037 \$51 68.8031a
Cext_598 \$1037 \$55 0.105966a
Cext_599 \$1037 \$57 0.282145a
Cext_600 \$1037 \$59 0.494517a
Cext_601 \$1037 \$61 20.9159a
Cext_602 \$1037 \$83 64.1221a
Cext_603 \$1037 \$85 0.155901a
Cext_604 \$1037 \$929 24.0706a
Cext_605 \$1037 IOVDD|vdda 13.0646a
Cext_606 \$1037 VSS|vss 66.2132a
Cext_607 \$1037 VSUBS 817.279a
Cext_608 \$1038 \$1040 2.46853a
Cext_609 \$1038 \$1057 225.319a
Cext_610 \$1038 \$1058 102.889a
Cext_611 \$1038 \$1282 5.04708a
Cext_612 \$1038 \$51 68.8428a
Cext_613 \$1038 \$57 0.115752a
Cext_614 \$1038 \$59 0.481837a
Cext_615 \$1038 \$61 20.8391a
Cext_616 \$1038 \$83 58.9193a
Cext_617 \$1038 \$85 0.343978a
Cext_618 \$1038 \$892 13.341a
Cext_619 \$1038 \$929 18.1165a
Cext_620 \$1038 \$991 0.360462a
Cext_621 \$1038 VSS|vss 69.9251a
Cext_622 \$1038 VSUBS 811.534a
Cext_623 \$1039 \$1040 788.061a
Cext_624 \$1039 \$1058 18.2111a
Cext_625 \$1039 \$1091 86.2689a
Cext_626 \$1039 \$1111 2.88751a
Cext_627 \$1039 \$1138 99.1454a
Cext_628 \$1039 \$1139 7.41179a
Cext_629 \$1039 \$1311 439.985a
Cext_630 \$1039 \$51 0.564032a
Cext_631 \$1039 \$53 53.8155a
Cext_632 \$1039 \$55 45.938a
Cext_633 \$1039 \$57 47.4094a
Cext_634 \$1039 \$61 0.104586a
Cext_635 \$1039 \$83 1.96577a
Cext_636 \$1039 \$85 68.8353a
Cext_637 \$1039 \$87 65.2142a
Cext_638 \$1039 \$89 3.38836a
Cext_639 \$1039 \$890 37.5623a
Cext_640 \$1039 \$892 3.83144a
Cext_641 \$1039 \$91 1.54387a
Cext_642 \$1039 \$929 30.6036a
Cext_643 \$1039 \$93 0.997221a
Cext_644 \$1039 \$977 99.1454a
Cext_645 \$1039 \$991 0.250757a
Cext_646 \$1039 VREF|vref 0.742539a
Cext_647 \$1039 VSUBS 215.406a
Cext_648 \$1040 \$1058 227.572a
Cext_649 \$1040 \$1091 98.5952a
Cext_650 \$1040 \$1187 1.46644a
Cext_651 \$1040 \$1311 27.0741a
Cext_652 \$1040 \$51 2.86905a
Cext_653 \$1040 \$53 91.1126a
Cext_654 \$1040 \$55 1.18748a
Cext_655 \$1040 \$57 0.476813a
Cext_656 \$1040 \$85 106.511a
Cext_657 \$1040 \$87 53.4686a
Cext_658 \$1040 \$89 3.56498a
Cext_659 \$1040 \$890 3.07213a
Cext_660 \$1040 \$892 1.96875a
Cext_661 \$1040 \$91 1.52179a
Cext_662 \$1040 \$929 33.29a
Cext_663 \$1040 \$93 1.0724a
Cext_664 \$1040 \$977 7.41179a
Cext_665 \$1040 VREF|vref 0.489684a
Cext_666 \$1040 VSUBS 167.788a
Cext_667 \$1042 \$1043 45.0654a
Cext_668 \$1042 \$1060 45.0654a
Cext_669 \$1042 \$1069 130.175a
Cext_670 \$1042 VDD|vdd 0.968272a
Cext_671 \$1042 VSUBS 634.529a
Cext_672 \$1043 \$1061 45.0654a
Cext_673 \$1043 \$1070 130.175a
Cext_674 \$1043 VSUBS 634.529a
Cext_675 \$1044 \$1061 45.8951a
Cext_676 \$1044 \$1064 113.058a
Cext_677 \$1044 \$1072 225.319a
Cext_678 \$1044 \$35 22.6915a
Cext_679 \$1044 \$67 105.489a
Cext_680 \$1044 \$886 0.12478a
Cext_681 \$1044 VSS|vss 61.1015a
Cext_682 \$1044 VSUBS 793.257a
Cext_683 \$1045 \$1046 114.006a
Cext_684 \$1045 \$1062 0.182933a
Cext_685 \$1045 \$1073 0.360462a
Cext_686 \$1045 \$1085 108.267a
Cext_687 \$1045 \$1305 14.2573a
Cext_688 \$1045 \$35 123.657a
Cext_689 \$1045 \$37 65.6459a
Cext_690 \$1045 \$39 0.62262a
Cext_691 \$1045 \$67 80.1821a
Cext_692 \$1045 \$69 70.7638a
Cext_693 \$1045 \$71 33.8269a
Cext_694 \$1045 \$73 32.5775a
Cext_695 \$1045 \$75 35.6349a
Cext_696 \$1045 \$77 45.7852a
Cext_697 \$1045 \$886 7.38709a
Cext_698 \$1045 \$917 4.79504a
Cext_699 \$1045 \$985 42.153a
Cext_700 \$1045 \$998 0.360462a
Cext_701 \$1045 VSS|vss 0.378848a
Cext_702 \$1045 VSUBS 255.747a
Cext_703 \$1046 \$1064 0.182933a
Cext_704 \$1046 \$1073 254.864a
Cext_705 \$1046 \$1085 0.360462a
Cext_706 \$1046 \$1276 5.60736a
Cext_707 \$1046 \$35 23.2117a
Cext_708 \$1046 \$37 0.145978a
Cext_709 \$1046 \$39 0.105966a
Cext_710 \$1046 \$41 0.282145a
Cext_711 \$1046 \$43 0.494517a
Cext_712 \$1046 \$45 20.7622a
Cext_713 \$1046 \$67 110.011a
Cext_714 \$1046 \$886 25.0459a
Cext_715 \$1046 \$917 0.12478a
Cext_716 \$1046 VSS|vss 66.2132a
Cext_717 \$1046 VSUBS 817.162a
Cext_718 \$1047 \$1048 114.006a
Cext_719 \$1047 \$1075 0.360462a
Cext_720 \$1047 \$1087 108.267a
Cext_721 \$1047 \$1307 14.2573a
Cext_722 \$1047 \$35 123.657a
Cext_723 \$1047 \$37 65.6459a
Cext_724 \$1047 \$39 0.62262a
Cext_725 \$1047 \$67 80.1821a
Cext_726 \$1047 \$69 70.7638a
Cext_727 \$1047 \$71 33.8269a
Cext_728 \$1047 \$73 32.5775a
Cext_729 \$1047 \$75 35.6349a
Cext_730 \$1047 \$77 45.7852a
Cext_731 \$1047 \$886 0.407507a
Cext_732 \$1047 \$888 1.70754a
Cext_733 \$1047 \$917 56.4208a
Cext_734 \$1047 \$987 42.153a
Cext_735 \$1047 VREF|vref 0.182933a
Cext_736 \$1047 VSS|vss 0.378848a
Cext_737 \$1047 VSUBS 255.747a
Cext_738 \$1048 \$1065 0.182933a
Cext_739 \$1048 \$1075 254.864a
Cext_740 \$1048 \$1087 0.360462a
Cext_741 \$1048 \$1278 5.60736a
Cext_742 \$1048 \$35 23.2117a
Cext_743 \$1048 \$37 0.145978a
Cext_744 \$1048 \$39 0.105966a
Cext_745 \$1048 \$41 0.282145a
Cext_746 \$1048 \$43 0.494517a
Cext_747 \$1048 \$45 20.7622a
Cext_748 \$1048 \$67 110.011a
Cext_749 \$1048 \$888 6.93899a
Cext_750 \$1048 \$917 89.0536a
Cext_751 \$1048 VSS|vss 66.2132a
Cext_752 \$1048 VSUBS 817.162a
Cext_753 \$1049 \$47 103.615a
Cext_754 \$1049 \$49 4.08768a
Cext_755 \$1049 \$79 104.998a
Cext_756 \$1049 \$81 53.422a
Cext_757 \$1049 \$886 99.7133a
Cext_758 \$1049 \$888 0.122259a
Cext_759 \$1049 \$917 289.051a
Cext_760 \$1049 \$967 7.41179a
Cext_761 \$1049 inn|out|vth_soft 159.491a
Cext_762 \$1049 VREF|vref 13.4453a
Cext_763 \$1049 VSS|vss 3.70217a
Cext_764 \$1049 VSUBS 266.643a
Cext_765 \$1050 \$1051 45.0654a
Cext_766 \$1050 \$1076 130.128a
Cext_767 \$1050 VDD|vdd 0.592094a
Cext_768 \$1050 VSS|vss 25.1792a
Cext_769 \$1050 VSUBS 659.267a
Cext_770 \$1051 \$1063 45.0654a
Cext_771 \$1051 \$1077 130.175a
Cext_772 \$1051 VSS|vss 5.452a
Cext_773 \$1051 VSUBS 634.529a
Cext_774 \$1052 \$1053 45.8951a
Cext_775 \$1052 \$1063 45.0654a
Cext_776 \$1052 \$1079 130.175a
Cext_777 \$1052 VSS|vss 0.428128a
Cext_778 \$1052 VSUBS 634.529a
Cext_779 \$1053 \$1066 113.058a
Cext_780 \$1053 \$1080 225.319a
Cext_781 \$1053 \$51 22.6915a
Cext_782 \$1053 \$83 105.489a
Cext_783 \$1053 \$890 0.12478a
Cext_784 \$1053 VSS|vss 61.1015a
Cext_785 \$1053 VSUBS 793.257a
Cext_786 \$1054 \$1055 114.006a
Cext_787 \$1054 \$1056 0.182933a
Cext_788 \$1054 \$1081 0.360462a
Cext_789 \$1054 \$1089 108.267a
Cext_790 \$1054 \$1309 14.2573a
Cext_791 \$1054 \$51 123.657a
Cext_792 \$1054 \$53 65.6459a
Cext_793 \$1054 \$55 0.62262a
Cext_794 \$1054 \$83 80.1821a
Cext_795 \$1054 \$85 70.7638a
Cext_796 \$1054 \$87 33.8269a
Cext_797 \$1054 \$89 32.5775a
Cext_798 \$1054 \$890 7.38709a
Cext_799 \$1054 \$91 35.6349a
Cext_800 \$1054 \$929 4.79504a
Cext_801 \$1054 \$93 45.7852a
Cext_802 \$1054 \$989 42.153a
Cext_803 \$1054 VSS|vss 0.378848a
Cext_804 \$1054 VSUBS 255.747a
Cext_805 \$1055 \$1066 0.182933a
Cext_806 \$1055 \$1081 254.864a
Cext_807 \$1055 \$1089 0.360462a
Cext_808 \$1055 \$1280 5.60736a
Cext_809 \$1055 \$51 23.2117a
Cext_810 \$1055 \$53 0.145978a
Cext_811 \$1055 \$55 0.105966a
Cext_812 \$1055 \$57 0.282145a
Cext_813 \$1055 \$59 0.494517a
Cext_814 \$1055 \$61 20.7622a
Cext_815 \$1055 \$83 110.011a
Cext_816 \$1055 \$890 25.0459a
Cext_817 \$1055 \$929 0.12478a
Cext_818 \$1055 VSS|vss 66.2132a
Cext_819 \$1055 VSUBS 817.162a
Cext_820 \$1056 \$1067 113.058a
Cext_821 \$1056 \$1082 225.319a
Cext_822 \$1056 \$1309 5.04708a
Cext_823 \$1056 \$51 22.6915a
Cext_824 \$1056 \$53 0.404672a
Cext_825 \$1056 \$57 0.115752a
Cext_826 \$1056 \$59 0.481837a
Cext_827 \$1056 \$61 20.8391a
Cext_828 \$1056 \$83 105.489a
Cext_829 \$1056 \$929 87.1134a
Cext_830 \$1056 IOVDD|vdda 11.5102a
Cext_831 \$1056 VSS|vss 60.9228a
Cext_832 \$1056 VSUBS 810.376a
Cext_833 \$1057 \$1058 114.006a
Cext_834 \$1057 \$1067 0.182933a
Cext_835 \$1057 \$1083 254.864a
Cext_836 \$1057 \$1091 0.360462a
Cext_837 \$1057 \$1282 5.60736a
Cext_838 \$1057 \$51 23.2117a
Cext_839 \$1057 \$53 0.145978a
Cext_840 \$1057 \$55 0.105966a
Cext_841 \$1057 \$57 0.282145a
Cext_842 \$1057 \$59 0.494517a
Cext_843 \$1057 \$61 20.7622a
Cext_844 \$1057 \$83 110.011a
Cext_845 \$1057 \$892 6.93899a
Cext_846 \$1057 \$929 89.0536a
Cext_847 \$1057 VSS|vss 75.4228a
Cext_848 \$1057 VSUBS 817.162a
Cext_849 \$1058 \$1083 0.360462a
Cext_850 \$1058 \$1091 108.267a
Cext_851 \$1058 \$1311 14.2573a
Cext_852 \$1058 \$51 123.657a
Cext_853 \$1058 \$53 65.6459a
Cext_854 \$1058 \$55 0.62262a
Cext_855 \$1058 \$83 80.1821a
Cext_856 \$1058 \$85 70.7638a
Cext_857 \$1058 \$87 33.8269a
Cext_858 \$1058 \$89 32.5775a
Cext_859 \$1058 \$890 0.407507a
Cext_860 \$1058 \$892 1.70754a
Cext_861 \$1058 \$91 35.6349a
Cext_862 \$1058 \$929 56.4208a
Cext_863 \$1058 \$93 45.7852a
Cext_864 \$1058 \$991 42.153a
Cext_865 \$1058 VREF|vref 0.182933a
Cext_866 \$1058 VSS|vss 0.378848a
Cext_867 \$1058 VSUBS 255.747a
Cext_868 \$1059 \$63 103.615a
Cext_869 \$1059 \$65 4.08768a
Cext_870 \$1059 \$890 99.7133a
Cext_871 \$1059 \$892 0.122259a
Cext_872 \$1059 \$929 289.051a
Cext_873 \$1059 \$95 104.998a
Cext_874 \$1059 \$97 53.422a
Cext_875 \$1059 \$978 7.41179a
Cext_876 \$1059 inn|out|vth_hard 159.491a
Cext_877 \$1059 VREF|vref 13.4453a
Cext_878 \$1059 VSS|vss 3.91071a
Cext_879 \$1059 VSUBS 265.303a
Cext_880 \$106 \$107 127.349a
Cext_881 \$106 \$121 130.175a
Cext_882 \$106 \$122 130.175a
Cext_883 \$106 \$51 21.4379a
Cext_884 \$106 \$53 7.13122a
Cext_885 \$106 \$55 4.58402a
Cext_886 \$106 \$57 3.11572a
Cext_887 \$106 \$59 2.10552a
Cext_888 \$106 \$61 1.54964a
Cext_889 \$106 \$63 1.17974a
Cext_890 \$106 \$65 0.837144a
Cext_891 \$106 \$83 131.536a
Cext_892 \$106 \$85 8.58503a
Cext_893 \$106 \$87 5.83606a
Cext_894 \$106 \$89 3.76228a
Cext_895 \$106 \$91 2.60655a
Cext_896 \$106 \$93 1.7981a
Cext_897 \$106 \$95 1.34685a
Cext_898 \$106 \$97 0.943525a
Cext_899 \$106 VSS|vss 161.195a
Cext_900 \$106 VSUBS 2.81006f
Cext_901 \$1060 \$1068 130.175a
Cext_902 \$1060 VDD|vdd 7.74075a
Cext_903 \$1060 VSS|vss 1.71997a
Cext_904 \$1060 VSUBS 659.267a
Cext_905 \$1061 \$1071 130.175a
Cext_906 \$1061 VSS|vss 0.428128a
Cext_907 \$1061 VSUBS 634.529a
Cext_908 \$1062 \$1065 113.058a
Cext_909 \$1062 \$1074 225.319a
Cext_910 \$1062 \$1305 5.04708a
Cext_911 \$1062 \$35 22.6915a
Cext_912 \$1062 \$37 0.404672a
Cext_913 \$1062 \$41 0.115752a
Cext_914 \$1062 \$43 0.481837a
Cext_915 \$1062 \$45 20.8391a
Cext_916 \$1062 \$67 105.489a
Cext_917 \$1062 \$917 87.1134a
Cext_918 \$1062 IOVDD|vdda 11.5102a
Cext_919 \$1062 VSS|vss 60.9228a
Cext_920 \$1062 VSUBS 810.376a
Cext_921 \$1063 \$1078 130.175a
Cext_922 \$1063 VSUBS 634.529a
Cext_923 \$1064 \$1072 102.889a
Cext_924 \$1064 \$1084 0.250757a
Cext_925 \$1064 \$1096 0.360462a
Cext_926 \$1064 \$1116 42.153a
Cext_927 \$1064 \$1276 14.2234a
Cext_928 \$1064 \$35 123.657a
Cext_929 \$1064 \$37 65.4666a
Cext_930 \$1064 \$41 0.62262a
Cext_931 \$1064 \$67 80.1249a
Cext_932 \$1064 \$69 70.7638a
Cext_933 \$1064 \$71 31.3588a
Cext_934 \$1064 \$73 36.0823a
Cext_935 \$1064 \$75 35.6349a
Cext_936 \$1064 \$77 45.8508a
Cext_937 \$1064 \$886 5.29954a
Cext_938 \$1064 \$984 86.2689a
Cext_939 \$1064 \$997 98.5952a
Cext_940 \$1064 VSS|vss 0.335662a
Cext_941 \$1064 VSUBS 257.974a
Cext_942 \$1065 \$1074 102.889a
Cext_943 \$1065 \$1086 0.250757a
Cext_944 \$1065 \$1099 0.360462a
Cext_945 \$1065 \$1121 42.153a
Cext_946 \$1065 \$1278 14.2234a
Cext_947 \$1065 \$35 123.51a
Cext_948 \$1065 \$37 65.4666a
Cext_949 \$1065 \$41 0.62262a
Cext_950 \$1065 \$67 79.8622a
Cext_951 \$1065 \$69 70.7638a
Cext_952 \$1065 \$71 31.3588a
Cext_953 \$1065 \$73 36.0823a
Cext_954 \$1065 \$75 35.6349a
Cext_955 \$1065 \$77 45.8508a
Cext_956 \$1065 \$886 11.0812a
Cext_957 \$1065 \$917 99.1182a
Cext_958 \$1065 \$986 86.2689a
Cext_959 \$1065 IOVDD|vdda 37.4382a
Cext_960 \$1065 VSS|vss 0.162917a
Cext_961 \$1065 VSUBS 257.609a
Cext_962 \$1066 \$1080 102.889a
Cext_963 \$1066 \$1088 0.250757a
Cext_964 \$1066 \$1106 0.360462a
Cext_965 \$1066 \$1130 42.153a
Cext_966 \$1066 \$1280 14.2234a
Cext_967 \$1066 \$51 123.657a
Cext_968 \$1066 \$53 65.4666a
Cext_969 \$1066 \$57 0.62262a
Cext_970 \$1066 \$83 80.1249a
Cext_971 \$1066 \$85 70.7638a
Cext_972 \$1066 \$87 31.3588a
Cext_973 \$1066 \$89 36.0823a
Cext_974 \$1066 \$890 5.29954a
Cext_975 \$1066 \$91 35.6349a
Cext_976 \$1066 \$93 45.8508a
Cext_977 \$1066 \$988 86.2689a
Cext_978 \$1066 VSS|vss 0.335662a
Cext_979 \$1066 VSUBS 257.974a
Cext_980 \$1067 \$1082 102.889a
Cext_981 \$1067 \$1090 0.250757a
Cext_982 \$1067 \$1109 0.360462a
Cext_983 \$1067 \$1135 42.153a
Cext_984 \$1067 \$1282 14.2234a
Cext_985 \$1067 \$51 123.51a
Cext_986 \$1067 \$53 65.4666a
Cext_987 \$1067 \$57 0.62262a
Cext_988 \$1067 \$83 79.8622a
Cext_989 \$1067 \$85 70.7638a
Cext_990 \$1067 \$87 31.3588a
Cext_991 \$1067 \$89 36.0823a
Cext_992 \$1067 \$890 11.0812a
Cext_993 \$1067 \$91 35.6349a
Cext_994 \$1067 \$929 99.1182a
Cext_995 \$1067 \$93 45.8508a
Cext_996 \$1067 \$990 86.2689a
Cext_997 \$1067 IOVDD|vdda 37.4382a
Cext_998 \$1067 VSS|vss 3.83386a
Cext_999 \$1067 VSUBS 257.609a
Cext_1000 \$1068 \$1069 45.0654a
Cext_1001 \$1068 \$1092 130.175a
Cext_1002 \$1068 VDD|vdd 7.74075a
Cext_1003 \$1068 VSS|vss 1.71997a
Cext_1004 \$1068 VSUBS 659.267a
Cext_1005 \$1069 \$1070 45.0654a
Cext_1006 \$1069 \$1093 130.175a
Cext_1007 \$1069 VDD|vdd 0.968272a
Cext_1008 \$1069 VSUBS 634.529a
Cext_1009 \$107 \$123 130.175a
Cext_1010 \$107 \$124 102.928a
Cext_1011 \$107 \$125 225.226a
Cext_1012 \$107 \$51 39.2381a
Cext_1013 \$107 \$53 16.6189a
Cext_1014 \$107 \$55 10.0058a
Cext_1015 \$107 \$57 4.74982a
Cext_1016 \$107 \$59 3.02226a
Cext_1017 \$107 \$61 2.0536a
Cext_1018 \$107 \$63 1.38254a
Cext_1019 \$107 \$65 0.995999a
Cext_1020 \$107 \$83 316.612a
Cext_1021 \$107 \$85 21.6723a
Cext_1022 \$107 \$87 11.4687a
Cext_1023 \$107 \$89 5.65121a
Cext_1024 \$107 \$91 3.83514a
Cext_1025 \$107 \$93 2.83592a
Cext_1026 \$107 \$95 1.57839a
Cext_1027 \$107 \$97 1.12243a
Cext_1028 \$107 VSS|vss 8.77077a
Cext_1029 \$107 VSUBS 3.11198f
Cext_1030 \$1070 \$1071 45.0654a
Cext_1031 \$1070 \$1094 130.175a
Cext_1032 \$1070 VSUBS 634.529a
Cext_1033 \$1071 \$1072 46.4004a
Cext_1034 \$1071 \$1095 130.175a
Cext_1035 \$1071 VSS|vss 0.378729a
Cext_1036 \$1071 VSUBS 634.529a
Cext_1037 \$1072 \$1096 254.864a
Cext_1038 \$1072 \$1116 0.360462a
Cext_1039 \$1072 \$35 69.0342a
Cext_1040 \$1072 \$67 64.2241a
Cext_1041 \$1072 \$73 0.182934a
Cext_1042 \$1072 \$77 0.107779a
Cext_1043 \$1072 \$886 0.270358a
Cext_1044 \$1072 \$984 2.88751a
Cext_1045 \$1072 VSS|vss 66.2906a
Cext_1046 \$1072 VSUBS 801.109a
Cext_1047 \$1073 \$1085 113.058a
Cext_1048 \$1073 \$1098 225.319a
Cext_1049 \$1073 \$1276 5.04708a
Cext_1050 \$1073 \$35 68.7272a
Cext_1051 \$1073 \$41 0.115752a
Cext_1052 \$1073 \$43 0.481837a
Cext_1053 \$1073 \$45 20.9928a
Cext_1054 \$1073 \$67 58.9193a
Cext_1055 \$1073 \$73 0.343978a
Cext_1056 \$1073 \$886 93.1851a
Cext_1057 \$1073 \$984 0.179323a
Cext_1058 \$1073 VSS|vss 60.9228a
Cext_1059 \$1073 VSUBS 810.856a
Cext_1060 \$1074 \$1085 0.182933a
Cext_1061 \$1074 \$1099 254.864a
Cext_1062 \$1074 \$1121 0.360462a
Cext_1063 \$1074 \$1305 5.60736a
Cext_1064 \$1074 \$35 69.0342a
Cext_1065 \$1074 \$39 0.105966a
Cext_1066 \$1074 \$41 0.282145a
Cext_1067 \$1074 \$43 0.494517a
Cext_1068 \$1074 \$45 20.7622a
Cext_1069 \$1074 \$67 64.2241a
Cext_1070 \$1074 \$73 0.182934a
Cext_1071 \$1074 \$77 0.107779a
Cext_1072 \$1074 \$886 96.1586a
Cext_1073 \$1074 \$917 56.7895a
Cext_1074 \$1074 \$986 2.88751a
Cext_1075 \$1074 IOVDD|vdda 13.2807a
Cext_1076 \$1074 VSS|vss 66.2132a
Cext_1077 \$1074 VSUBS 818.643a
Cext_1078 \$1075 \$1087 113.058a
Cext_1079 \$1075 \$1101 225.319a
Cext_1080 \$1075 \$1278 5.04708a
Cext_1081 \$1075 \$35 68.7272a
Cext_1082 \$1075 \$41 0.115752a
Cext_1083 \$1075 \$43 0.481837a
Cext_1084 \$1075 \$45 20.9928a
Cext_1085 \$1075 \$67 58.9193a
Cext_1086 \$1075 \$73 0.343978a
Cext_1087 \$1075 \$886 87.9554a
Cext_1088 \$1075 \$917 52.0765a
Cext_1089 \$1075 \$986 0.179323a
Cext_1090 \$1075 VSS|vss 60.9228a
Cext_1091 \$1075 VSUBS 810.856a
Cext_1092 \$1076 \$1077 45.0654a
Cext_1093 \$1076 \$1102 130.128a
Cext_1094 \$1076 VDD|vdd 0.592094a
Cext_1095 \$1076 VSS|vss 25.1792a
Cext_1096 \$1076 VSUBS 659.267a
Cext_1097 \$1077 \$1078 45.0654a
Cext_1098 \$1077 \$1103 130.175a
Cext_1099 \$1077 VSS|vss 5.452a
Cext_1100 \$1077 VSUBS 634.529a
Cext_1101 \$1078 \$1079 45.0654a
Cext_1102 \$1078 \$1104 130.175a
Cext_1103 \$1078 VSUBS 634.529a
Cext_1104 \$1079 \$1080 46.4004a
Cext_1105 \$1079 \$1105 130.175a
Cext_1106 \$1079 VSS|vss 0.378729a
Cext_1107 \$1079 VSUBS 634.529a
Cext_1108 \$108 \$126 239.132a
Cext_1109 \$108 \$127 241.699a
Cext_1110 \$108 \$128 102.928a
Cext_1111 \$108 \$147 5.62808a
Cext_1112 \$108 \$148 64.5855a
Cext_1113 \$108 \$149 5.58536a
Cext_1114 \$108 \$176 2.68012a
Cext_1115 \$108 \$177 2.63597a
Cext_1116 \$108 \$179 2.67468a
Cext_1117 \$108 \$205 0.131941a
Cext_1118 \$108 \$206 1.4857a
Cext_1119 \$108 \$207 1.5425a
Cext_1120 \$108 \$235 1.30495a
Cext_1121 \$108 \$51 101.529a
Cext_1122 \$108 \$53 64.0061a
Cext_1123 \$108 \$55 49.4736a
Cext_1124 \$108 \$57 46.6626a
Cext_1125 \$108 \$59 50.1167a
Cext_1126 \$108 \$61 179.87a
Cext_1127 \$108 \$63 1.5668a
Cext_1128 \$108 \$65 1.14035a
Cext_1129 \$108 \$83 432.346a
Cext_1130 \$108 \$85 67.2409a
Cext_1131 \$108 \$87 48.7753a
Cext_1132 \$108 \$89 44.0149a
Cext_1133 \$108 \$91 44.4799a
Cext_1134 \$108 \$93 41.0245a
Cext_1135 \$108 \$95 3.34937a
Cext_1136 \$108 \$97 1.28499a
Cext_1137 \$108 IOVDD|vdda 27.2029a
Cext_1138 \$108 VSS|vss 17.836a
Cext_1139 \$108 VSUBS 4.2106f
Cext_1140 \$1080 \$1106 254.864a
Cext_1141 \$1080 \$1130 0.360462a
Cext_1142 \$1080 \$51 69.0342a
Cext_1143 \$1080 \$83 64.2241a
Cext_1144 \$1080 \$89 0.182934a
Cext_1145 \$1080 \$890 0.270358a
Cext_1146 \$1080 \$93 0.107779a
Cext_1147 \$1080 \$988 2.88751a
Cext_1148 \$1080 VSS|vss 66.2906a
Cext_1149 \$1080 VSUBS 801.109a
Cext_1150 \$1081 \$1089 113.058a
Cext_1151 \$1081 \$1108 225.319a
Cext_1152 \$1081 \$1280 5.04708a
Cext_1153 \$1081 \$51 68.7272a
Cext_1154 \$1081 \$57 0.115752a
Cext_1155 \$1081 \$59 0.481837a
Cext_1156 \$1081 \$61 20.9928a
Cext_1157 \$1081 \$83 58.9193a
Cext_1158 \$1081 \$89 0.343978a
Cext_1159 \$1081 \$890 93.1851a
Cext_1160 \$1081 \$988 0.179323a
Cext_1161 \$1081 VSS|vss 60.9228a
Cext_1162 \$1081 VSUBS 810.856a
Cext_1163 \$1082 \$1089 0.182933a
Cext_1164 \$1082 \$1109 254.864a
Cext_1165 \$1082 \$1135 0.360462a
Cext_1166 \$1082 \$1309 5.60736a
Cext_1167 \$1082 \$51 69.0342a
Cext_1168 \$1082 \$55 0.105966a
Cext_1169 \$1082 \$57 0.282145a
Cext_1170 \$1082 \$59 0.494517a
Cext_1171 \$1082 \$61 20.7622a
Cext_1172 \$1082 \$83 64.2241a
Cext_1173 \$1082 \$89 0.182934a
Cext_1174 \$1082 \$890 96.1586a
Cext_1175 \$1082 \$929 56.7895a
Cext_1176 \$1082 \$93 0.107779a
Cext_1177 \$1082 \$990 2.88751a
Cext_1178 \$1082 IOVDD|vdda 13.2807a
Cext_1179 \$1082 VSS|vss 66.2132a
Cext_1180 \$1082 VSUBS 818.643a
Cext_1181 \$1083 \$1091 113.058a
Cext_1182 \$1083 \$1111 225.319a
Cext_1183 \$1083 \$1282 5.04708a
Cext_1184 \$1083 \$51 68.7272a
Cext_1185 \$1083 \$57 0.115752a
Cext_1186 \$1083 \$59 0.481837a
Cext_1187 \$1083 \$61 20.9928a
Cext_1188 \$1083 \$83 58.9193a
Cext_1189 \$1083 \$89 0.343978a
Cext_1190 \$1083 \$890 87.9554a
Cext_1191 \$1083 \$929 52.0765a
Cext_1192 \$1083 \$990 0.179323a
Cext_1193 \$1083 VSS|vss 69.9251a
Cext_1194 \$1083 VSUBS 810.856a
Cext_1195 \$1084 \$1097 1.55447f
Cext_1196 \$1084 \$1116 15.578a
Cext_1197 \$1084 \$1140 29.1901a
Cext_1198 \$1084 \$1168 15.464a
Cext_1199 \$1084 \$1197 223.573a
Cext_1200 \$1084 \$1217 17.8937a
Cext_1201 \$1084 \$1256 75.7894a
Cext_1202 \$1084 \$1264 2.78109a
Cext_1203 \$1084 \$1265 0.179323a
Cext_1204 \$1084 \$1276 3.09053f
Cext_1205 \$1084 \$1289 7.41179a
Cext_1206 \$1084 \$35 2.39761a
Cext_1207 \$1084 \$37 93.4626a
Cext_1208 \$1084 \$39 14.3029a
Cext_1209 \$1084 \$41 58.4605a
Cext_1210 \$1084 \$43 1.18748a
Cext_1211 \$1084 \$69 66.567a
Cext_1212 \$1084 \$71 10.0948a
Cext_1213 \$1084 \$73 47.9782a
Cext_1214 \$1084 \$75 48.4845a
Cext_1215 \$1084 \$77 0.959093a
Cext_1216 \$1084 \$984 99.1454a
Cext_1217 \$1084 VSUBS 253.222a
Cext_1218 \$1085 \$1098 102.889a
Cext_1219 \$1085 \$1118 0.360462a
Cext_1220 \$1085 \$1119 0.250757a
Cext_1221 \$1085 \$1141 42.153a
Cext_1222 \$1085 \$1305 14.2234a
Cext_1223 \$1085 \$35 134.681a
Cext_1224 \$1085 \$37 19.3729a
Cext_1225 \$1085 \$41 1.41124a
Cext_1226 \$1085 \$67 69.8608a
Cext_1227 \$1085 \$69 117.28a
Cext_1228 \$1085 \$71 31.3588a
Cext_1229 \$1085 \$73 34.4538a
Cext_1230 \$1085 \$75 35.6349a
Cext_1231 \$1085 \$77 45.8508a
Cext_1232 \$1085 \$886 100.881a
Cext_1233 \$1085 VSS|vss 0.27808a
Cext_1234 \$1085 VSUBS 257.605a
Cext_1235 \$1086 \$1100 1.55447f
Cext_1236 \$1086 \$1121 15.578a
Cext_1237 \$1086 \$1142 29.1901a
Cext_1238 \$1086 \$1172 15.464a
Cext_1239 \$1086 \$1200 223.573a
Cext_1240 \$1086 \$1220 17.8937a
Cext_1241 \$1086 \$1257 75.7894a
Cext_1242 \$1086 \$1266 2.78109a
Cext_1243 \$1086 \$1267 0.179323a
Cext_1244 \$1086 \$1278 3.09053f
Cext_1245 \$1086 \$1292 7.41179a
Cext_1246 \$1086 \$35 2.39761a
Cext_1247 \$1086 \$37 93.4626a
Cext_1248 \$1086 \$39 14.3029a
Cext_1249 \$1086 \$41 58.4605a
Cext_1250 \$1086 \$43 1.18748a
Cext_1251 \$1086 \$69 66.567a
Cext_1252 \$1086 \$71 10.0948a
Cext_1253 \$1086 \$73 47.9782a
Cext_1254 \$1086 \$75 48.4845a
Cext_1255 \$1086 \$77 0.959093a
Cext_1256 \$1086 \$886 18.243a
Cext_1257 \$1086 \$917 0.26986a
Cext_1258 \$1086 \$986 99.1454a
Cext_1259 \$1086 IOVDD|vdda 10.7759a
Cext_1260 \$1086 VSUBS 253.222a
Cext_1261 \$1087 \$1101 102.889a
Cext_1262 \$1087 \$1123 0.360462a
Cext_1263 \$1087 \$1124 0.250757a
Cext_1264 \$1087 \$1143 42.153a
Cext_1265 \$1087 \$1307 14.2234a
Cext_1266 \$1087 \$35 134.681a
Cext_1267 \$1087 \$37 19.3729a
Cext_1268 \$1087 \$41 1.41124a
Cext_1269 \$1087 \$67 69.8608a
Cext_1270 \$1087 \$69 117.28a
Cext_1271 \$1087 \$71 31.3588a
Cext_1272 \$1087 \$73 34.4538a
Cext_1273 \$1087 \$75 35.6349a
Cext_1274 \$1087 \$77 45.8508a
Cext_1275 \$1087 \$886 100.881a
Cext_1276 \$1087 \$917 26.3789a
Cext_1277 \$1087 VREF|vref 0.182933a
Cext_1278 \$1087 VSS|vss 0.27808a
Cext_1279 \$1087 VSUBS 257.605a
Cext_1280 \$1088 \$1107 1.55447f
Cext_1281 \$1088 \$1130 15.578a
Cext_1282 \$1088 \$1144 29.1901a
Cext_1283 \$1088 \$1180 15.464a
Cext_1284 \$1088 \$1207 223.573a
Cext_1285 \$1088 \$1227 17.8937a
Cext_1286 \$1088 \$1258 75.7894a
Cext_1287 \$1088 \$1272 2.78109a
Cext_1288 \$1088 \$1273 0.179323a
Cext_1289 \$1088 \$1280 3.09053f
Cext_1290 \$1088 \$1299 7.41179a
Cext_1291 \$1088 \$51 2.39761a
Cext_1292 \$1088 \$53 93.4626a
Cext_1293 \$1088 \$55 14.3029a
Cext_1294 \$1088 \$57 58.4605a
Cext_1295 \$1088 \$59 1.18748a
Cext_1296 \$1088 \$85 66.567a
Cext_1297 \$1088 \$87 10.0948a
Cext_1298 \$1088 \$89 47.9782a
Cext_1299 \$1088 \$91 48.4845a
Cext_1300 \$1088 \$93 0.959093a
Cext_1301 \$1088 \$988 99.1454a
Cext_1302 \$1088 VSUBS 253.222a
Cext_1303 \$1089 \$1108 102.889a
Cext_1304 \$1089 \$1132 0.360462a
Cext_1305 \$1089 \$1133 0.250757a
Cext_1306 \$1089 \$1145 42.153a
Cext_1307 \$1089 \$1309 14.2234a
Cext_1308 \$1089 \$51 134.681a
Cext_1309 \$1089 \$53 19.3729a
Cext_1310 \$1089 \$57 1.41124a
Cext_1311 \$1089 \$83 69.8608a
Cext_1312 \$1089 \$85 117.28a
Cext_1313 \$1089 \$87 31.3588a
Cext_1314 \$1089 \$89 34.4538a
Cext_1315 \$1089 \$890 100.881a
Cext_1316 \$1089 \$91 35.6349a
Cext_1317 \$1089 \$93 45.8508a
Cext_1318 \$1089 VSS|vss 0.27808a
Cext_1319 \$1089 VSUBS 257.605a
Cext_1320 \$109 \$129 239.132a
Cext_1321 \$109 \$130 147.947a
Cext_1322 \$109 \$151 64.5855a
Cext_1323 \$109 \$152 5.62808a
Cext_1324 \$109 \$153 6.06004a
Cext_1325 \$109 \$180 2.68012a
Cext_1326 \$109 \$181 2.63597a
Cext_1327 \$109 \$182 2.90199a
Cext_1328 \$109 \$210 0.131941a
Cext_1329 \$109 \$211 1.4857a
Cext_1330 \$109 \$212 1.6736a
Cext_1331 \$109 \$240 1.30495a
Cext_1332 \$109 \$51 76.5241a
Cext_1333 \$109 \$53 63.1547a
Cext_1334 \$109 \$55 49.246a
Cext_1335 \$109 \$57 46.5873a
Cext_1336 \$109 \$59 47.3348a
Cext_1337 \$109 \$61 178.998a
Cext_1338 \$109 \$63 1.79162a
Cext_1339 \$109 \$65 1.40345a
Cext_1340 \$109 \$83 273.735a
Cext_1341 \$109 \$85 65.3165a
Cext_1342 \$109 \$87 48.1728a
Cext_1343 \$109 \$89 43.7063a
Cext_1344 \$109 \$91 41.0209a
Cext_1345 \$109 \$93 39.3302a
Cext_1346 \$109 \$95 2.76873a
Cext_1347 \$109 \$97 6.47863a
Cext_1348 \$109 VSS|vss 43.3529a
Cext_1349 \$109 VSUBS 4.01055f
Cext_1350 \$1090 \$1110 1.55447f
Cext_1351 \$1090 \$1135 15.578a
Cext_1352 \$1090 \$1146 29.1901a
Cext_1353 \$1090 \$1184 15.464a
Cext_1354 \$1090 \$1210 223.573a
Cext_1355 \$1090 \$1232 17.8937a
Cext_1356 \$1090 \$1259 75.7894a
Cext_1357 \$1090 \$1274 2.78109a
Cext_1358 \$1090 \$1275 0.179323a
Cext_1359 \$1090 \$1282 3.09053f
Cext_1360 \$1090 \$1302 7.41179a
Cext_1361 \$1090 \$51 2.39761a
Cext_1362 \$1090 \$53 93.4626a
Cext_1363 \$1090 \$55 14.3029a
Cext_1364 \$1090 \$57 58.4605a
Cext_1365 \$1090 \$59 1.18748a
Cext_1366 \$1090 \$85 66.567a
Cext_1367 \$1090 \$87 10.0948a
Cext_1368 \$1090 \$89 47.9782a
Cext_1369 \$1090 \$890 18.243a
Cext_1370 \$1090 \$91 48.4845a
Cext_1371 \$1090 \$929 0.26986a
Cext_1372 \$1090 \$93 0.959093a
Cext_1373 \$1090 \$990 99.1454a
Cext_1374 \$1090 IOVDD|vdda 10.7759a
Cext_1375 \$1090 VSS|vss 27.1233a
Cext_1376 \$1090 VSUBS 253.222a
Cext_1377 \$1091 \$1111 102.889a
Cext_1378 \$1091 \$1137 0.360462a
Cext_1379 \$1091 \$1138 0.250757a
Cext_1380 \$1091 \$1147 42.153a
Cext_1381 \$1091 \$1311 14.2234a
Cext_1382 \$1091 \$51 134.681a
Cext_1383 \$1091 \$53 19.3729a
Cext_1384 \$1091 \$57 1.41124a
Cext_1385 \$1091 \$83 69.8608a
Cext_1386 \$1091 \$85 117.28a
Cext_1387 \$1091 \$87 31.3588a
Cext_1388 \$1091 \$89 34.4538a
Cext_1389 \$1091 \$890 100.881a
Cext_1390 \$1091 \$91 35.6349a
Cext_1391 \$1091 \$929 26.3789a
Cext_1392 \$1091 \$93 45.8508a
Cext_1393 \$1091 VREF|vref 0.182933a
Cext_1394 \$1091 VSS|vss 0.27808a
Cext_1395 \$1091 VSUBS 257.605a
Cext_1396 \$1092 \$1093 45.0654a
Cext_1397 \$1092 \$1112 130.175a
Cext_1398 \$1092 VDD|vdd 7.74075a
Cext_1399 \$1092 VSS|vss 1.71997a
Cext_1400 \$1092 VSUBS 659.267a
Cext_1401 \$1093 \$1094 45.0654a
Cext_1402 \$1093 \$1113 130.175a
Cext_1403 \$1093 VDD|vdd 0.968272a
Cext_1404 \$1093 VSUBS 634.529a
Cext_1405 \$1094 \$1095 45.0654a
Cext_1406 \$1094 \$1114 130.175a
Cext_1407 \$1094 VSUBS 634.529a
Cext_1408 \$1095 \$1096 45.8951a
Cext_1409 \$1095 \$1115 130.175a
Cext_1410 \$1095 VSS|vss 0.428128a
Cext_1411 \$1095 VSUBS 634.529a
Cext_1412 \$1096 \$1097 2.16563a
Cext_1413 \$1096 \$1116 102.889a
Cext_1414 \$1096 \$1117 225.319a
Cext_1415 \$1096 \$35 22.8071a
Cext_1416 \$1096 \$67 105.694a
Cext_1417 \$1096 VSS|vss 61.1015a
Cext_1418 \$1096 VSUBS 794.068a
Cext_1419 \$1097 \$1098 0.179323a
Cext_1420 \$1097 \$1116 83.8393a
Cext_1421 \$1097 \$1140 783.202a
Cext_1422 \$1097 \$1168 15.7815a
Cext_1423 \$1097 \$1197 99.1454a
Cext_1424 \$1097 \$1217 0.250757a
Cext_1425 \$1097 \$1276 22.7487a
Cext_1426 \$1097 \$35 0.564032a
Cext_1427 \$1097 \$37 51.1437a
Cext_1428 \$1097 \$39 46.0291a
Cext_1429 \$1097 \$41 47.4094a
Cext_1430 \$1097 \$43 0.104586a
Cext_1431 \$1097 \$67 1.96577a
Cext_1432 \$1097 \$69 66.0871a
Cext_1433 \$1097 \$71 62.2724a
Cext_1434 \$1097 \$73 3.41995a
Cext_1435 \$1097 \$75 1.69678a
Cext_1436 \$1097 \$77 0.98091a
Cext_1437 \$1097 \$984 7.41179a
Cext_1438 \$1097 VSUBS 196.18a
Cext_1439 \$1098 \$1118 254.864a
Cext_1440 \$1098 \$1141 0.360462a
Cext_1441 \$1098 \$1276 5.60736a
Cext_1442 \$1098 \$35 23.4429a
Cext_1443 \$1098 \$39 0.105966a
Cext_1444 \$1098 \$41 0.428122a
Cext_1445 \$1098 \$43 0.494517a
Cext_1446 \$1098 \$45 20.9159a
Cext_1447 \$1098 \$67 110.113a
Cext_1448 \$1098 \$77 0.107779a
Cext_1449 \$1098 \$886 52.4402a
Cext_1450 \$1098 VSS|vss 66.2132a
Cext_1451 \$1098 VSUBS 818.454a
Cext_1452 \$1099 \$1100 2.16563a
Cext_1453 \$1099 \$1121 102.889a
Cext_1454 \$1099 \$1122 225.319a
Cext_1455 \$1099 \$1305 5.04708a
Cext_1456 \$1099 \$35 22.8071a
Cext_1457 \$1099 \$41 0.772242a
Cext_1458 \$1099 \$43 0.481837a
Cext_1459 \$1099 \$45 20.9928a
Cext_1460 \$1099 \$67 105.694a
Cext_1461 \$1099 \$886 48.561a
Cext_1462 \$1099 IOVDD|vdda 11.6291a
Cext_1463 \$1099 VSS|vss 60.9228a
Cext_1464 \$1099 VSUBS 810.857a
Cext_1465 \$1100 \$1101 0.179323a
Cext_1466 \$1100 \$1121 83.8393a
Cext_1467 \$1100 \$1142 783.202a
Cext_1468 \$1100 \$1172 15.7815a
Cext_1469 \$1100 \$1200 99.1454a
Cext_1470 \$1100 \$1220 0.250757a
Cext_1471 \$1100 \$1278 22.7487a
Cext_1472 \$1100 \$35 0.564032a
Cext_1473 \$1100 \$37 51.1437a
Cext_1474 \$1100 \$39 46.0291a
Cext_1475 \$1100 \$41 47.4094a
Cext_1476 \$1100 \$43 0.104586a
Cext_1477 \$1100 \$67 1.96577a
Cext_1478 \$1100 \$69 66.0871a
Cext_1479 \$1100 \$71 62.2724a
Cext_1480 \$1100 \$73 3.41995a
Cext_1481 \$1100 \$75 1.69678a
Cext_1482 \$1100 \$77 0.98091a
Cext_1483 \$1100 \$886 7.3663a
Cext_1484 \$1100 \$986 7.41179a
Cext_1485 \$1100 IOVDD|vdda 7.32478a
Cext_1486 \$1100 VSUBS 196.18a
Cext_1487 \$1101 \$1123 254.864a
Cext_1488 \$1101 \$1143 0.360462a
Cext_1489 \$1101 \$1278 5.60736a
Cext_1490 \$1101 \$35 23.4429a
Cext_1491 \$1101 \$39 0.105966a
Cext_1492 \$1101 \$41 0.428122a
Cext_1493 \$1101 \$43 0.494517a
Cext_1494 \$1101 \$45 20.9159a
Cext_1495 \$1101 \$67 110.113a
Cext_1496 \$1101 \$77 0.107779a
Cext_1497 \$1101 \$886 52.4402a
Cext_1498 \$1101 VSS|vss 66.2132a
Cext_1499 \$1101 VSUBS 818.454a
Cext_1500 \$1102 \$1103 45.0654a
Cext_1501 \$1102 \$1126 130.128a
Cext_1502 \$1102 VDD|vdd 0.592094a
Cext_1503 \$1102 VSS|vss 25.1792a
Cext_1504 \$1102 VSUBS 659.267a
Cext_1505 \$1103 \$1104 45.0654a
Cext_1506 \$1103 \$1127 130.175a
Cext_1507 \$1103 VSS|vss 5.452a
Cext_1508 \$1103 VSUBS 634.529a
Cext_1509 \$1104 \$1105 45.0654a
Cext_1510 \$1104 \$1128 130.175a
Cext_1511 \$1104 VSUBS 634.529a
Cext_1512 \$1105 \$1106 45.8951a
Cext_1513 \$1105 \$1129 130.175a
Cext_1514 \$1105 VSS|vss 0.428128a
Cext_1515 \$1105 VSUBS 634.529a
Cext_1516 \$1106 \$1107 2.16563a
Cext_1517 \$1106 \$1130 102.889a
Cext_1518 \$1106 \$1131 225.319a
Cext_1519 \$1106 \$51 22.8071a
Cext_1520 \$1106 \$83 105.694a
Cext_1521 \$1106 VSS|vss 61.1015a
Cext_1522 \$1106 VSUBS 794.068a
Cext_1523 \$1107 \$1108 0.179323a
Cext_1524 \$1107 \$1130 83.8393a
Cext_1525 \$1107 \$1144 783.202a
Cext_1526 \$1107 \$1180 15.7815a
Cext_1527 \$1107 \$1207 99.1454a
Cext_1528 \$1107 \$1227 0.250757a
Cext_1529 \$1107 \$1280 22.7487a
Cext_1530 \$1107 \$51 0.564032a
Cext_1531 \$1107 \$53 51.1437a
Cext_1532 \$1107 \$55 46.0291a
Cext_1533 \$1107 \$57 47.4094a
Cext_1534 \$1107 \$59 0.104586a
Cext_1535 \$1107 \$83 1.96577a
Cext_1536 \$1107 \$85 66.0871a
Cext_1537 \$1107 \$87 62.2724a
Cext_1538 \$1107 \$89 3.41995a
Cext_1539 \$1107 \$91 1.69678a
Cext_1540 \$1107 \$93 0.98091a
Cext_1541 \$1107 \$988 7.41179a
Cext_1542 \$1107 VSUBS 196.18a
Cext_1543 \$1108 \$1132 254.864a
Cext_1544 \$1108 \$1145 0.360462a
Cext_1545 \$1108 \$1280 5.60736a
Cext_1546 \$1108 \$51 23.4429a
Cext_1547 \$1108 \$55 0.105966a
Cext_1548 \$1108 \$57 0.428122a
Cext_1549 \$1108 \$59 0.494517a
Cext_1550 \$1108 \$61 20.9159a
Cext_1551 \$1108 \$83 110.113a
Cext_1552 \$1108 \$890 52.4402a
Cext_1553 \$1108 \$93 0.107779a
Cext_1554 \$1108 VSS|vss 66.2132a
Cext_1555 \$1108 VSUBS 818.454a
Cext_1556 \$1109 \$1110 2.16563a
Cext_1557 \$1109 \$1135 102.889a
Cext_1558 \$1109 \$1136 225.319a
Cext_1559 \$1109 \$1309 5.04708a
Cext_1560 \$1109 \$51 22.8071a
Cext_1561 \$1109 \$57 0.772242a
Cext_1562 \$1109 \$59 0.481837a
Cext_1563 \$1109 \$61 20.9928a
Cext_1564 \$1109 \$83 105.694a
Cext_1565 \$1109 \$890 48.561a
Cext_1566 \$1109 IOVDD|vdda 11.6291a
Cext_1567 \$1109 VSS|vss 60.9228a
Cext_1568 \$1109 VSUBS 810.857a
Cext_1569 \$111 \$112 45.0654a
Cext_1570 \$111 \$155 130.175a
Cext_1571 \$111 \$67 3.81687a
Cext_1572 \$111 VDD|vdd 0.968272a
Cext_1573 \$111 VSS|vss 46.8074a
Cext_1574 \$111 VSUBS 634.529a
Cext_1575 \$1110 \$1111 0.179323a
Cext_1576 \$1110 \$1135 83.8393a
Cext_1577 \$1110 \$1146 783.202a
Cext_1578 \$1110 \$1184 15.7815a
Cext_1579 \$1110 \$1210 99.1454a
Cext_1580 \$1110 \$1232 0.250757a
Cext_1581 \$1110 \$1282 22.7487a
Cext_1582 \$1110 \$51 0.564032a
Cext_1583 \$1110 \$53 51.1437a
Cext_1584 \$1110 \$55 46.0291a
Cext_1585 \$1110 \$57 47.4094a
Cext_1586 \$1110 \$59 0.104586a
Cext_1587 \$1110 \$83 1.96577a
Cext_1588 \$1110 \$85 66.0871a
Cext_1589 \$1110 \$87 62.2724a
Cext_1590 \$1110 \$89 3.41995a
Cext_1591 \$1110 \$890 7.3663a
Cext_1592 \$1110 \$91 1.69678a
Cext_1593 \$1110 \$93 0.98091a
Cext_1594 \$1110 \$990 7.41179a
Cext_1595 \$1110 IOVDD|vdda 7.32478a
Cext_1596 \$1110 VSS|vss 11.762a
Cext_1597 \$1110 VSUBS 196.18a
Cext_1598 \$1111 \$1137 254.864a
Cext_1599 \$1111 \$1147 0.360462a
Cext_1600 \$1111 \$1282 5.60736a
Cext_1601 \$1111 \$51 23.4429a
Cext_1602 \$1111 \$55 0.105966a
Cext_1603 \$1111 \$57 0.428122a
Cext_1604 \$1111 \$59 0.494517a
Cext_1605 \$1111 \$61 20.9159a
Cext_1606 \$1111 \$83 110.113a
Cext_1607 \$1111 \$890 52.4402a
Cext_1608 \$1111 \$93 0.107779a
Cext_1609 \$1111 VSS|vss 75.3227a
Cext_1610 \$1111 VSUBS 818.454a
Cext_1611 \$1112 \$1113 45.0654a
Cext_1612 \$1112 \$1148 130.175a
Cext_1613 \$1112 VDD|vdd 7.74075a
Cext_1614 \$1112 VSS|vss 1.71997a
Cext_1615 \$1112 VSUBS 659.267a
Cext_1616 \$1113 \$1114 45.0654a
Cext_1617 \$1113 \$1149 130.175a
Cext_1618 \$1113 VDD|vdd 0.968272a
Cext_1619 \$1113 VSUBS 634.529a
Cext_1620 \$1114 \$1115 45.0654a
Cext_1621 \$1114 \$1150 130.175a
Cext_1622 \$1114 VSUBS 634.529a
Cext_1623 \$1115 \$1117 46.4004a
Cext_1624 \$1115 \$1151 130.175a
Cext_1625 \$1115 VSS|vss 0.378729a
Cext_1626 \$1115 VSUBS 634.529a
Cext_1627 \$1116 \$1117 114.006a
Cext_1628 \$1116 \$1118 0.182933a
Cext_1629 \$1116 \$1140 98.5952a
Cext_1630 \$1116 \$1152 0.360462a
Cext_1631 \$1116 \$1168 108.267a
Cext_1632 \$1116 \$1276 11.8276a
Cext_1633 \$1116 \$35 134.708a
Cext_1634 \$1116 \$37 19.3729a
Cext_1635 \$1116 \$41 1.18572a
Cext_1636 \$1116 \$67 69.9941a
Cext_1637 \$1116 \$69 117.28a
Cext_1638 \$1116 \$71 31.3588a
Cext_1639 \$1116 \$73 34.4538a
Cext_1640 \$1116 \$75 35.6349a
Cext_1641 \$1116 \$77 45.7852a
Cext_1642 \$1116 VSS|vss 0.378848a
Cext_1643 \$1116 VSUBS 257.682a
Cext_1644 \$1117 \$1152 254.864a
Cext_1645 \$1117 \$1168 0.360462a
Cext_1646 \$1117 \$35 68.8031a
Cext_1647 \$1117 \$67 64.1221a
Cext_1648 \$1117 \$69 0.155901a
Cext_1649 \$1117 VSS|vss 66.2906a
Cext_1650 \$1117 VSUBS 799.746a
Cext_1651 \$1118 \$1120 2.16563a
Cext_1652 \$1118 \$1141 102.889a
Cext_1653 \$1118 \$1153 225.319a
Cext_1654 \$1118 \$1276 5.04708a
Cext_1655 \$1118 \$35 68.8428a
Cext_1656 \$1118 \$41 0.115752a
Cext_1657 \$1118 \$43 0.481837a
Cext_1658 \$1118 \$45 20.8391a
Cext_1659 \$1118 \$67 59.1234a
Cext_1660 \$1118 \$69 0.343978a
Cext_1661 \$1118 \$886 13.341a
Cext_1662 \$1118 VSS|vss 60.9228a
Cext_1663 \$1118 VSUBS 811.667a
Cext_1664 \$1119 \$1120 1.55447f
Cext_1665 \$1119 \$1141 15.578a
Cext_1666 \$1119 \$1171 29.1901a
Cext_1667 \$1119 \$1188 15.464a
Cext_1668 \$1119 \$1219 223.573a
Cext_1669 \$1119 \$1235 17.8937a
Cext_1670 \$1119 \$1277 75.7894a
Cext_1671 \$1119 \$1290 2.78109a
Cext_1672 \$1119 \$1291 0.179323a
Cext_1673 \$1119 \$1305 3.09053f
Cext_1674 \$1119 \$1318 7.41179a
Cext_1675 \$1119 \$35 0.604961a
Cext_1676 \$1119 \$37 88.8335a
Cext_1677 \$1119 \$39 7.30318a
Cext_1678 \$1119 \$41 46.0291a
Cext_1679 \$1119 \$43 47.2301a
Cext_1680 \$1119 \$67 1.69277a
Cext_1681 \$1119 \$69 71.8939a
Cext_1682 \$1119 \$71 18.5253a
Cext_1683 \$1119 \$73 62.4106a
Cext_1684 \$1119 \$75 2.44188a
Cext_1685 \$1119 \$77 0.959093a
Cext_1686 \$1119 \$886 4.18484a
Cext_1687 \$1119 VSUBS 249.361a
Cext_1688 \$112 \$113 45.0654a
Cext_1689 \$112 \$131 130.175a
Cext_1690 \$112 \$67 7.68982a
Cext_1691 \$112 VSUBS 634.529a
Cext_1692 \$1120 \$1122 0.179323a
Cext_1693 \$1120 \$1141 83.8393a
Cext_1694 \$1120 \$1171 783.202a
Cext_1695 \$1120 \$1188 15.7815a
Cext_1696 \$1120 \$1219 99.1454a
Cext_1697 \$1120 \$1235 0.250757a
Cext_1698 \$1120 \$1305 22.7487a
Cext_1699 \$1120 \$35 2.65407a
Cext_1700 \$1120 \$37 56.2993a
Cext_1701 \$1120 \$39 56.2856a
Cext_1702 \$1120 \$41 1.18748a
Cext_1703 \$1120 \$43 0.13075a
Cext_1704 \$1120 \$69 60.0621a
Cext_1705 \$1120 \$71 50.2205a
Cext_1706 \$1120 \$73 49.6419a
Cext_1707 \$1120 \$75 1.67062a
Cext_1708 \$1120 \$77 0.98091a
Cext_1709 \$1120 \$886 2.34017a
Cext_1710 \$1120 VSUBS 198.38a
Cext_1711 \$1121 \$1122 114.006a
Cext_1712 \$1121 \$1123 0.182933a
Cext_1713 \$1121 \$1142 98.5952a
Cext_1714 \$1121 \$1154 0.360462a
Cext_1715 \$1121 \$1172 108.267a
Cext_1716 \$1121 \$1278 11.8276a
Cext_1717 \$1121 \$35 134.561a
Cext_1718 \$1121 \$37 19.3729a
Cext_1719 \$1121 \$41 1.18572a
Cext_1720 \$1121 \$67 69.8469a
Cext_1721 \$1121 \$69 117.28a
Cext_1722 \$1121 \$71 31.3588a
Cext_1723 \$1121 \$73 34.4538a
Cext_1724 \$1121 \$75 35.6349a
Cext_1725 \$1121 \$77 45.7852a
Cext_1726 \$1121 \$886 9.31416a
Cext_1727 \$1121 IOVDD|vdda 40.7078a
Cext_1728 \$1121 VSS|vss 0.378848a
Cext_1729 \$1121 VSUBS 257.408a
Cext_1730 \$1122 \$1154 254.864a
Cext_1731 \$1122 \$1172 0.360462a
Cext_1732 \$1122 \$1305 5.60736a
Cext_1733 \$1122 \$35 68.8031a
Cext_1734 \$1122 \$39 0.105966a
Cext_1735 \$1122 \$41 0.282145a
Cext_1736 \$1122 \$43 0.494517a
Cext_1737 \$1122 \$45 20.9159a
Cext_1738 \$1122 \$67 64.1221a
Cext_1739 \$1122 \$69 0.155901a
Cext_1740 \$1122 \$886 14.0521a
Cext_1741 \$1122 IOVDD|vdda 13.0646a
Cext_1742 \$1122 VSS|vss 66.2132a
Cext_1743 \$1122 VSUBS 817.169a
Cext_1744 \$1123 \$1125 2.16563a
Cext_1745 \$1123 \$1143 102.889a
Cext_1746 \$1123 \$1155 225.319a
Cext_1747 \$1123 \$1278 5.04708a
Cext_1748 \$1123 \$35 68.8428a
Cext_1749 \$1123 \$41 0.115752a
Cext_1750 \$1123 \$43 0.481837a
Cext_1751 \$1123 \$45 20.8391a
Cext_1752 \$1123 \$67 59.1234a
Cext_1753 \$1123 \$69 0.343978a
Cext_1754 \$1123 \$886 13.341a
Cext_1755 \$1123 VSS|vss 60.9228a
Cext_1756 \$1123 VSUBS 811.667a
Cext_1757 \$1124 \$1125 1.55447f
Cext_1758 \$1124 \$1143 15.578a
Cext_1759 \$1124 \$1175 29.1901a
Cext_1760 \$1124 \$1189 15.464a
Cext_1761 \$1124 \$1223 223.573a
Cext_1762 \$1124 \$1236 17.8937a
Cext_1763 \$1124 \$1279 75.7894a
Cext_1764 \$1124 \$1293 2.78109a
Cext_1765 \$1124 \$1307 3.09053f
Cext_1766 \$1124 \$1321 7.41179a
Cext_1767 \$1124 \$35 0.604961a
Cext_1768 \$1124 \$37 88.8335a
Cext_1769 \$1124 \$39 7.30318a
Cext_1770 \$1124 \$41 46.0291a
Cext_1771 \$1124 \$43 47.2301a
Cext_1772 \$1124 \$67 1.69277a
Cext_1773 \$1124 \$69 72.1568a
Cext_1774 \$1124 \$71 18.5253a
Cext_1775 \$1124 \$73 62.4106a
Cext_1776 \$1124 \$75 2.44188a
Cext_1777 \$1124 \$77 0.959093a
Cext_1778 \$1124 \$886 4.18484a
Cext_1779 \$1124 VREF|vref 1.65635a
Cext_1780 \$1124 VSUBS 249.72a
Cext_1781 \$1125 \$1143 83.8393a
Cext_1782 \$1125 \$1175 783.202a
Cext_1783 \$1125 \$1189 15.7815a
Cext_1784 \$1125 \$1223 99.1454a
Cext_1785 \$1125 \$1236 0.250757a
Cext_1786 \$1125 \$1307 22.7487a
Cext_1787 \$1125 \$35 2.65407a
Cext_1788 \$1125 \$37 56.2993a
Cext_1789 \$1125 \$39 56.2856a
Cext_1790 \$1125 \$41 1.18748a
Cext_1791 \$1125 \$43 0.13075a
Cext_1792 \$1125 \$69 60.0621a
Cext_1793 \$1125 \$71 50.2205a
Cext_1794 \$1125 \$73 49.6419a
Cext_1795 \$1125 \$75 1.67062a
Cext_1796 \$1125 \$77 0.98091a
Cext_1797 \$1125 \$886 2.34017a
Cext_1798 \$1125 VREF|vref 0.898171a
Cext_1799 \$1125 VSUBS 198.47a
Cext_1800 \$1126 \$1127 45.0654a
Cext_1801 \$1126 \$1156 130.128a
Cext_1802 \$1126 VDD|vdd 0.592094a
Cext_1803 \$1126 VSS|vss 25.1792a
Cext_1804 \$1126 VSUBS 659.267a
Cext_1805 \$1127 \$1128 45.0654a
Cext_1806 \$1127 \$1157 130.175a
Cext_1807 \$1127 VSS|vss 5.452a
Cext_1808 \$1127 VSUBS 634.529a
Cext_1809 \$1128 \$1129 45.0654a
Cext_1810 \$1128 \$1158 130.175a
Cext_1811 \$1128 VSUBS 634.529a
Cext_1812 \$1129 \$1131 46.4004a
Cext_1813 \$1129 \$1159 130.175a
Cext_1814 \$1129 VSS|vss 0.378729a
Cext_1815 \$1129 VSUBS 634.529a
Cext_1816 \$113 \$114 46.4004a
Cext_1817 \$113 \$132 130.175a
Cext_1818 \$113 \$67 7.68982a
Cext_1819 \$113 VSS|vss 0.378729a
Cext_1820 \$113 VSUBS 634.529a
Cext_1821 \$1130 \$1131 114.006a
Cext_1822 \$1130 \$1132 0.182933a
Cext_1823 \$1130 \$1144 98.5952a
Cext_1824 \$1130 \$1160 0.360462a
Cext_1825 \$1130 \$1180 108.267a
Cext_1826 \$1130 \$1280 11.8276a
Cext_1827 \$1130 \$51 134.708a
Cext_1828 \$1130 \$53 19.3729a
Cext_1829 \$1130 \$57 1.18572a
Cext_1830 \$1130 \$83 69.9941a
Cext_1831 \$1130 \$85 117.28a
Cext_1832 \$1130 \$87 31.3588a
Cext_1833 \$1130 \$89 34.4538a
Cext_1834 \$1130 \$91 35.6349a
Cext_1835 \$1130 \$93 45.7852a
Cext_1836 \$1130 VSS|vss 0.378848a
Cext_1837 \$1130 VSUBS 257.682a
Cext_1838 \$1131 \$1160 254.864a
Cext_1839 \$1131 \$1180 0.360462a
Cext_1840 \$1131 \$51 68.8031a
Cext_1841 \$1131 \$83 64.1221a
Cext_1842 \$1131 \$85 0.155901a
Cext_1843 \$1131 VSS|vss 66.2906a
Cext_1844 \$1131 VSUBS 799.746a
Cext_1845 \$1132 \$1134 2.16563a
Cext_1846 \$1132 \$1145 102.889a
Cext_1847 \$1132 \$1161 225.319a
Cext_1848 \$1132 \$1280 5.04708a
Cext_1849 \$1132 \$51 68.8428a
Cext_1850 \$1132 \$57 0.115752a
Cext_1851 \$1132 \$59 0.481837a
Cext_1852 \$1132 \$61 20.8391a
Cext_1853 \$1132 \$83 59.1234a
Cext_1854 \$1132 \$85 0.343978a
Cext_1855 \$1132 \$890 13.341a
Cext_1856 \$1132 VSS|vss 60.9228a
Cext_1857 \$1132 VSUBS 811.667a
Cext_1858 \$1133 \$1134 1.55447f
Cext_1859 \$1133 \$1145 15.578a
Cext_1860 \$1133 \$1183 29.1901a
Cext_1861 \$1133 \$1190 15.464a
Cext_1862 \$1133 \$1230 223.573a
Cext_1863 \$1133 \$1238 17.8937a
Cext_1864 \$1133 \$1281 75.7894a
Cext_1865 \$1133 \$1300 2.78109a
Cext_1866 \$1133 \$1301 0.179323a
Cext_1867 \$1133 \$1309 3.09053f
Cext_1868 \$1133 \$1328 7.41179a
Cext_1869 \$1133 \$51 0.604961a
Cext_1870 \$1133 \$53 88.8335a
Cext_1871 \$1133 \$55 7.30318a
Cext_1872 \$1133 \$57 46.0291a
Cext_1873 \$1133 \$59 47.2301a
Cext_1874 \$1133 \$83 1.69277a
Cext_1875 \$1133 \$85 71.8939a
Cext_1876 \$1133 \$87 18.5253a
Cext_1877 \$1133 \$89 62.4106a
Cext_1878 \$1133 \$890 4.18484a
Cext_1879 \$1133 \$91 2.44188a
Cext_1880 \$1133 \$93 0.959093a
Cext_1881 \$1133 VSUBS 249.361a
Cext_1882 \$1134 \$1136 0.179323a
Cext_1883 \$1134 \$1145 83.8393a
Cext_1884 \$1134 \$1183 783.202a
Cext_1885 \$1134 \$1190 15.7815a
Cext_1886 \$1134 \$1230 99.1454a
Cext_1887 \$1134 \$1238 0.250757a
Cext_1888 \$1134 \$1309 22.7487a
Cext_1889 \$1134 \$51 2.65407a
Cext_1890 \$1134 \$53 56.2993a
Cext_1891 \$1134 \$55 56.2856a
Cext_1892 \$1134 \$57 1.18748a
Cext_1893 \$1134 \$59 0.13075a
Cext_1894 \$1134 \$85 60.0621a
Cext_1895 \$1134 \$87 50.2205a
Cext_1896 \$1134 \$89 49.6419a
Cext_1897 \$1134 \$890 2.34017a
Cext_1898 \$1134 \$91 1.67062a
Cext_1899 \$1134 \$93 0.98091a
Cext_1900 \$1134 VSUBS 198.38a
Cext_1901 \$1135 \$1136 114.006a
Cext_1902 \$1135 \$1137 0.182933a
Cext_1903 \$1135 \$1146 98.5952a
Cext_1904 \$1135 \$1162 0.360462a
Cext_1905 \$1135 \$1184 108.267a
Cext_1906 \$1135 \$1282 11.8276a
Cext_1907 \$1135 \$51 134.561a
Cext_1908 \$1135 \$53 19.3729a
Cext_1909 \$1135 \$57 1.18572a
Cext_1910 \$1135 \$83 69.8469a
Cext_1911 \$1135 \$85 117.28a
Cext_1912 \$1135 \$87 31.3588a
Cext_1913 \$1135 \$89 34.4538a
Cext_1914 \$1135 \$890 9.31416a
Cext_1915 \$1135 \$91 35.6349a
Cext_1916 \$1135 \$93 45.7852a
Cext_1917 \$1135 IOVDD|vdda 40.7078a
Cext_1918 \$1135 VSS|vss 3.57468a
Cext_1919 \$1135 VSUBS 257.408a
Cext_1920 \$1136 \$1162 254.864a
Cext_1921 \$1136 \$1184 0.360462a
Cext_1922 \$1136 \$1309 5.60736a
Cext_1923 \$1136 \$51 68.8031a
Cext_1924 \$1136 \$55 0.105966a
Cext_1925 \$1136 \$57 0.282145a
Cext_1926 \$1136 \$59 0.494517a
Cext_1927 \$1136 \$61 20.9159a
Cext_1928 \$1136 \$83 64.1221a
Cext_1929 \$1136 \$85 0.155901a
Cext_1930 \$1136 \$890 14.0521a
Cext_1931 \$1136 IOVDD|vdda 13.0646a
Cext_1932 \$1136 VSS|vss 66.2132a
Cext_1933 \$1136 VSUBS 817.169a
Cext_1934 \$1137 \$1139 2.16563a
Cext_1935 \$1137 \$1147 102.889a
Cext_1936 \$1137 \$1163 225.319a
Cext_1937 \$1137 \$1282 5.04708a
Cext_1938 \$1137 \$51 68.8428a
Cext_1939 \$1137 \$57 0.115752a
Cext_1940 \$1137 \$59 0.481837a
Cext_1941 \$1137 \$61 20.8391a
Cext_1942 \$1137 \$83 59.1234a
Cext_1943 \$1137 \$85 0.343978a
Cext_1944 \$1137 \$890 13.341a
Cext_1945 \$1137 VSS|vss 69.9251a
Cext_1946 \$1137 VSUBS 811.667a
Cext_1947 \$1138 \$1139 1.55447f
Cext_1948 \$1138 \$1147 15.578a
Cext_1949 \$1138 \$1187 29.1901a
Cext_1950 \$1138 \$1191 15.464a
Cext_1951 \$1138 \$1234 223.573a
Cext_1952 \$1138 \$1239 17.8937a
Cext_1953 \$1138 \$1283 75.7894a
Cext_1954 \$1138 \$1303 2.78109a
Cext_1955 \$1138 \$1311 3.09053f
Cext_1956 \$1138 \$1331 7.41179a
Cext_1957 \$1138 \$51 0.604961a
Cext_1958 \$1138 \$53 88.8335a
Cext_1959 \$1138 \$55 7.30318a
Cext_1960 \$1138 \$57 46.0291a
Cext_1961 \$1138 \$59 47.2301a
Cext_1962 \$1138 \$83 1.69277a
Cext_1963 \$1138 \$85 72.1568a
Cext_1964 \$1138 \$87 18.5253a
Cext_1965 \$1138 \$89 62.4106a
Cext_1966 \$1138 \$890 4.18484a
Cext_1967 \$1138 \$91 2.44188a
Cext_1968 \$1138 \$93 0.959093a
Cext_1969 \$1138 VREF|vref 1.65635a
Cext_1970 \$1138 VSUBS 249.72a
Cext_1971 \$1139 \$1147 83.8393a
Cext_1972 \$1139 \$1187 783.202a
Cext_1973 \$1139 \$1191 15.7815a
Cext_1974 \$1139 \$1234 99.1454a
Cext_1975 \$1139 \$1239 0.250757a
Cext_1976 \$1139 \$1311 22.7487a
Cext_1977 \$1139 \$51 2.65407a
Cext_1978 \$1139 \$53 56.2993a
Cext_1979 \$1139 \$55 56.2856a
Cext_1980 \$1139 \$57 1.18748a
Cext_1981 \$1139 \$59 0.13075a
Cext_1982 \$1139 \$85 60.0621a
Cext_1983 \$1139 \$87 50.2205a
Cext_1984 \$1139 \$89 49.6419a
Cext_1985 \$1139 \$890 2.34017a
Cext_1986 \$1139 \$91 1.67062a
Cext_1987 \$1139 \$93 0.98091a
Cext_1988 \$1139 VREF|vref 0.898171a
Cext_1989 \$1139 VSUBS 198.47a
Cext_1990 \$114 \$115 114.006a
Cext_1991 \$114 \$133 254.77a
Cext_1992 \$114 \$162 0.360462a
Cext_1993 \$114 \$35 68.8031a
Cext_1994 \$114 \$67 73.9822a
Cext_1995 \$114 \$69 0.155901a
Cext_1996 \$114 VSS|vss 65.1705a
Cext_1997 \$114 VSUBS 800.515a
Cext_1998 \$1140 \$1168 227.572a
Cext_1999 \$1140 \$1169 3.25406a
Cext_2000 \$1140 \$1170 0.179323a
Cext_2001 \$1140 \$1197 7.41179a
Cext_2002 \$1140 \$1276 22.3756a
Cext_2003 \$1140 \$35 3.05553a
Cext_2004 \$1140 \$37 90.8871a
Cext_2005 \$1140 \$39 1.18748a
Cext_2006 \$1140 \$41 0.476813a
Cext_2007 \$1140 \$69 106.353a
Cext_2008 \$1140 \$71 53.5342a
Cext_2009 \$1140 \$73 3.67334a
Cext_2010 \$1140 \$75 1.61371a
Cext_2011 \$1140 \$77 1.13718a
Cext_2012 \$1140 \$997 1.46644a
Cext_2013 \$1140 VSUBS 168.265a
Cext_2014 \$1141 \$1153 114.006a
Cext_2015 \$1141 \$1154 0.182933a
Cext_2016 \$1141 \$1170 0.360462a
Cext_2017 \$1141 \$1171 98.5952a
Cext_2018 \$1141 \$1188 108.267a
Cext_2019 \$1141 \$1305 11.8276a
Cext_2020 \$1141 \$35 123.657a
Cext_2021 \$1141 \$37 65.4666a
Cext_2022 \$1141 \$41 0.62262a
Cext_2023 \$1141 \$67 80.1821a
Cext_2024 \$1141 \$69 70.7638a
Cext_2025 \$1141 \$71 31.3588a
Cext_2026 \$1141 \$73 35.8568a
Cext_2027 \$1141 \$75 35.6349a
Cext_2028 \$1141 \$77 45.7852a
Cext_2029 \$1141 \$886 1.46516a
Cext_2030 \$1141 VSS|vss 0.378848a
Cext_2031 \$1141 VSUBS 257.776a
Cext_2032 \$1142 \$1172 227.572a
Cext_2033 \$1142 \$1173 3.25406a
Cext_2034 \$1142 \$1174 0.179323a
Cext_2035 \$1142 \$1200 7.41179a
Cext_2036 \$1142 \$1278 22.3756a
Cext_2037 \$1142 \$35 3.05553a
Cext_2038 \$1142 \$37 90.8871a
Cext_2039 \$1142 \$39 1.18748a
Cext_2040 \$1142 \$41 0.476813a
Cext_2041 \$1142 \$69 106.353a
Cext_2042 \$1142 \$71 53.5342a
Cext_2043 \$1142 \$73 3.67334a
Cext_2044 \$1142 \$75 1.61371a
Cext_2045 \$1142 \$77 1.13718a
Cext_2046 \$1142 \$886 0.945254a
Cext_2047 \$1142 IOVDD|vdda 4.94332a
Cext_2048 \$1142 VSUBS 168.265a
Cext_2049 \$1143 \$1155 114.006a
Cext_2050 \$1143 \$1174 0.360462a
Cext_2051 \$1143 \$1175 98.5952a
Cext_2052 \$1143 \$1189 108.267a
Cext_2053 \$1143 \$1307 11.8276a
Cext_2054 \$1143 \$35 123.657a
Cext_2055 \$1143 \$37 65.4666a
Cext_2056 \$1143 \$41 0.62262a
Cext_2057 \$1143 \$67 80.1821a
Cext_2058 \$1143 \$69 70.7638a
Cext_2059 \$1143 \$71 31.3588a
Cext_2060 \$1143 \$73 35.8568a
Cext_2061 \$1143 \$75 35.6349a
Cext_2062 \$1143 \$77 45.7852a
Cext_2063 \$1143 \$886 1.46516a
Cext_2064 \$1143 VREF|vref 0.182933a
Cext_2065 \$1143 VSS|vss 0.378848a
Cext_2066 \$1143 VSUBS 257.776a
Cext_2067 \$1144 \$1180 227.572a
Cext_2068 \$1144 \$1181 3.25406a
Cext_2069 \$1144 \$1182 0.179323a
Cext_2070 \$1144 \$1207 7.41179a
Cext_2071 \$1144 \$1280 22.3756a
Cext_2072 \$1144 \$51 3.05553a
Cext_2073 \$1144 \$53 90.8871a
Cext_2074 \$1144 \$55 1.18748a
Cext_2075 \$1144 \$57 0.476813a
Cext_2076 \$1144 \$85 106.353a
Cext_2077 \$1144 \$87 53.5342a
Cext_2078 \$1144 \$89 3.67334a
Cext_2079 \$1144 \$91 1.61371a
Cext_2080 \$1144 \$93 1.13718a
Cext_2081 \$1144 VSUBS 168.265a
Cext_2082 \$1145 \$1161 114.006a
Cext_2083 \$1145 \$1162 0.182933a
Cext_2084 \$1145 \$1182 0.360462a
Cext_2085 \$1145 \$1183 98.5952a
Cext_2086 \$1145 \$1190 108.267a
Cext_2087 \$1145 \$1309 11.8276a
Cext_2088 \$1145 \$51 123.657a
Cext_2089 \$1145 \$53 65.4666a
Cext_2090 \$1145 \$57 0.62262a
Cext_2091 \$1145 \$83 80.1821a
Cext_2092 \$1145 \$85 70.7638a
Cext_2093 \$1145 \$87 31.3588a
Cext_2094 \$1145 \$89 35.8568a
Cext_2095 \$1145 \$890 1.46516a
Cext_2096 \$1145 \$91 35.6349a
Cext_2097 \$1145 \$93 45.7852a
Cext_2098 \$1145 VSS|vss 0.378848a
Cext_2099 \$1145 VSUBS 257.776a
Cext_2100 \$1146 \$1184 227.572a
Cext_2101 \$1146 \$1185 3.25406a
Cext_2102 \$1146 \$1186 0.179323a
Cext_2103 \$1146 \$1210 7.41179a
Cext_2104 \$1146 \$1282 22.3756a
Cext_2105 \$1146 \$51 3.05553a
Cext_2106 \$1146 \$53 90.8871a
Cext_2107 \$1146 \$55 1.18748a
Cext_2108 \$1146 \$57 0.476813a
Cext_2109 \$1146 \$85 106.353a
Cext_2110 \$1146 \$87 53.5342a
Cext_2111 \$1146 \$89 3.67334a
Cext_2112 \$1146 \$890 0.945254a
Cext_2113 \$1146 \$91 1.61371a
Cext_2114 \$1146 \$93 1.13718a
Cext_2115 \$1146 IOVDD|vdda 4.94332a
Cext_2116 \$1146 VSS|vss 4.87167a
Cext_2117 \$1146 VSUBS 168.265a
Cext_2118 \$1147 \$1163 114.006a
Cext_2119 \$1147 \$1186 0.360462a
Cext_2120 \$1147 \$1187 98.5952a
Cext_2121 \$1147 \$1191 108.267a
Cext_2122 \$1147 \$1311 11.8276a
Cext_2123 \$1147 \$51 123.657a
Cext_2124 \$1147 \$53 65.4666a
Cext_2125 \$1147 \$57 0.62262a
Cext_2126 \$1147 \$83 80.1821a
Cext_2127 \$1147 \$85 70.7638a
Cext_2128 \$1147 \$87 31.3588a
Cext_2129 \$1147 \$89 35.8568a
Cext_2130 \$1147 \$890 1.46516a
Cext_2131 \$1147 \$91 35.6349a
Cext_2132 \$1147 \$93 45.7852a
Cext_2133 \$1147 VREF|vref 0.182933a
Cext_2134 \$1147 VSS|vss 0.378848a
Cext_2135 \$1147 VSUBS 257.776a
Cext_2136 \$1148 \$1149 45.0654a
Cext_2137 \$1148 \$1164 130.175a
Cext_2138 \$1148 VDD|vdd 7.74075a
Cext_2139 \$1148 VSS|vss 1.71997a
Cext_2140 \$1148 VSUBS 659.267a
Cext_2141 \$1149 \$1150 45.0654a
Cext_2142 \$1149 \$1165 130.175a
Cext_2143 \$1149 VDD|vdd 0.968272a
Cext_2144 \$1149 VSUBS 634.529a
Cext_2145 \$115 \$116 0.709993a
Cext_2146 \$115 \$133 0.360462a
Cext_2147 \$115 \$134 98.5952a
Cext_2148 \$115 \$162 108.267a
Cext_2149 \$115 \$35 136.376a
Cext_2150 \$115 \$37 20.0466a
Cext_2151 \$115 \$39 0.507346a
Cext_2152 \$115 \$41 1.90541a
Cext_2153 \$115 \$43 0.112844a
Cext_2154 \$115 \$67 74.9792a
Cext_2155 \$115 \$69 120.227a
Cext_2156 \$115 \$71 33.5145a
Cext_2157 \$115 \$73 34.5648a
Cext_2158 \$115 \$75 37.5036a
Cext_2159 \$115 \$77 46.2298a
Cext_2160 \$115 VSS|vss 0.378848a
Cext_2161 \$115 VSUBS 323.96a
Cext_2162 \$1150 \$1151 45.0654a
Cext_2163 \$1150 \$1166 130.175a
Cext_2164 \$1150 VSUBS 634.529a
Cext_2165 \$1151 \$1152 45.8951a
Cext_2166 \$1151 \$1167 130.175a
Cext_2167 \$1151 VSS|vss 0.428128a
Cext_2168 \$1151 VSUBS 634.529a
Cext_2169 \$1152 \$1168 113.058a
Cext_2170 \$1152 \$1169 225.319a
Cext_2171 \$1152 \$35 22.6915a
Cext_2172 \$1152 \$67 105.489a
Cext_2173 \$1152 VSS|vss 61.1015a
Cext_2174 \$1152 VSUBS 793.257a
Cext_2175 \$1153 \$1168 0.182933a
Cext_2176 \$1153 \$1170 254.864a
Cext_2177 \$1153 \$1188 0.360462a
Cext_2178 \$1153 \$1276 5.60736a
Cext_2179 \$1153 \$35 23.2117a
Cext_2180 \$1153 \$37 0.145978a
Cext_2181 \$1153 \$39 0.105966a
Cext_2182 \$1153 \$41 0.282145a
Cext_2183 \$1153 \$43 0.494517a
Cext_2184 \$1153 \$45 20.7622a
Cext_2185 \$1153 \$67 110.011a
Cext_2186 \$1153 \$886 6.93899a
Cext_2187 \$1153 VSS|vss 66.2132a
Cext_2188 \$1153 VSUBS 817.162a
Cext_2189 \$1154 \$1172 113.058a
Cext_2190 \$1154 \$1173 225.319a
Cext_2191 \$1154 \$1305 5.04708a
Cext_2192 \$1154 \$35 22.6915a
Cext_2193 \$1154 \$37 0.404672a
Cext_2194 \$1154 \$41 0.115752a
Cext_2195 \$1154 \$43 0.481837a
Cext_2196 \$1154 \$45 20.8391a
Cext_2197 \$1154 \$67 105.489a
Cext_2198 \$1154 \$886 6.58496a
Cext_2199 \$1154 IOVDD|vdda 11.5102a
Cext_2200 \$1154 VSS|vss 60.9228a
Cext_2201 \$1154 VSUBS 810.376a
Cext_2202 \$1155 \$1172 0.182933a
Cext_2203 \$1155 \$1174 254.864a
Cext_2204 \$1155 \$1189 0.360462a
Cext_2205 \$1155 \$1278 5.60736a
Cext_2206 \$1155 \$35 23.2117a
Cext_2207 \$1155 \$37 0.145978a
Cext_2208 \$1155 \$39 0.105966a
Cext_2209 \$1155 \$41 0.282145a
Cext_2210 \$1155 \$43 0.494517a
Cext_2211 \$1155 \$45 20.7622a
Cext_2212 \$1155 \$67 110.011a
Cext_2213 \$1155 \$886 6.93899a
Cext_2214 \$1155 VSS|vss 66.2132a
Cext_2215 \$1155 VSUBS 817.162a
Cext_2216 \$1156 \$1157 45.0654a
Cext_2217 \$1156 \$1176 130.128a
Cext_2218 \$1156 VDD|vdd 0.592094a
Cext_2219 \$1156 VSS|vss 25.1792a
Cext_2220 \$1156 VSUBS 659.267a
Cext_2221 \$1157 \$1158 45.0654a
Cext_2222 \$1157 \$1177 130.175a
Cext_2223 \$1157 VSS|vss 5.452a
Cext_2224 \$1157 VSUBS 634.529a
Cext_2225 \$1158 \$1159 45.0654a
Cext_2226 \$1158 \$1178 130.175a
Cext_2227 \$1158 VSUBS 634.529a
Cext_2228 \$1159 \$1160 45.8951a
Cext_2229 \$1159 \$1179 130.175a
Cext_2230 \$1159 VSS|vss 0.428128a
Cext_2231 \$1159 VSUBS 634.529a
Cext_2232 \$116 \$135 102.928a
Cext_2233 \$116 \$136 225.319a
Cext_2234 \$116 \$35 69.5346a
Cext_2235 \$116 \$37 0.283978a
Cext_2236 \$116 \$39 0.209713a
Cext_2237 \$116 \$41 0.276252a
Cext_2238 \$116 \$43 0.481837a
Cext_2239 \$116 \$45 20.8391a
Cext_2240 \$116 \$67 68.2327a
Cext_2241 \$116 \$69 0.679713a
Cext_2242 \$116 \$71 0.242834a
Cext_2243 \$116 \$73 0.182729a
Cext_2244 \$116 \$75 0.262546a
Cext_2245 \$116 \$77 0.172446a
Cext_2246 \$116 VSS|vss 59.9275a
Cext_2247 \$116 VSUBS 844.801a
Cext_2248 \$1160 \$1180 113.058a
Cext_2249 \$1160 \$1181 225.319a
Cext_2250 \$1160 \$51 22.6915a
Cext_2251 \$1160 \$83 105.489a
Cext_2252 \$1160 VSS|vss 61.1015a
Cext_2253 \$1160 VSUBS 793.257a
Cext_2254 \$1161 \$1180 0.182933a
Cext_2255 \$1161 \$1182 254.864a
Cext_2256 \$1161 \$1190 0.360462a
Cext_2257 \$1161 \$1280 5.60736a
Cext_2258 \$1161 \$51 23.2117a
Cext_2259 \$1161 \$53 0.145978a
Cext_2260 \$1161 \$55 0.105966a
Cext_2261 \$1161 \$57 0.282145a
Cext_2262 \$1161 \$59 0.494517a
Cext_2263 \$1161 \$61 20.7622a
Cext_2264 \$1161 \$83 110.011a
Cext_2265 \$1161 \$890 6.93899a
Cext_2266 \$1161 VSS|vss 66.2132a
Cext_2267 \$1161 VSUBS 817.162a
Cext_2268 \$1162 \$1184 113.058a
Cext_2269 \$1162 \$1185 225.319a
Cext_2270 \$1162 \$1309 5.04708a
Cext_2271 \$1162 \$51 22.6915a
Cext_2272 \$1162 \$53 0.404672a
Cext_2273 \$1162 \$57 0.115752a
Cext_2274 \$1162 \$59 0.481837a
Cext_2275 \$1162 \$61 20.8391a
Cext_2276 \$1162 \$83 105.489a
Cext_2277 \$1162 \$890 6.58496a
Cext_2278 \$1162 IOVDD|vdda 11.5102a
Cext_2279 \$1162 VSS|vss 60.9228a
Cext_2280 \$1162 VSUBS 810.376a
Cext_2281 \$1163 \$1184 0.182933a
Cext_2282 \$1163 \$1186 254.864a
Cext_2283 \$1163 \$1191 0.360462a
Cext_2284 \$1163 \$1282 5.60736a
Cext_2285 \$1163 \$51 23.2117a
Cext_2286 \$1163 \$53 0.145978a
Cext_2287 \$1163 \$55 0.105966a
Cext_2288 \$1163 \$57 0.282145a
Cext_2289 \$1163 \$59 0.494517a
Cext_2290 \$1163 \$61 20.7622a
Cext_2291 \$1163 \$83 110.011a
Cext_2292 \$1163 \$890 6.93899a
Cext_2293 \$1163 VSS|vss 75.4228a
Cext_2294 \$1163 VSUBS 817.162a
Cext_2295 \$1164 \$1165 45.0654a
Cext_2296 \$1164 \$1192 130.175a
Cext_2297 \$1164 VDD|vdd 7.74075a
Cext_2298 \$1164 VSS|vss 1.71997a
Cext_2299 \$1164 VSUBS 659.267a
Cext_2300 \$1165 \$1166 45.0654a
Cext_2301 \$1165 \$1193 130.175a
Cext_2302 \$1165 VDD|vdd 0.968272a
Cext_2303 \$1165 VSUBS 634.529a
Cext_2304 \$1166 \$1167 45.0654a
Cext_2305 \$1166 \$1194 130.175a
Cext_2306 \$1166 VSUBS 634.529a
Cext_2307 \$1167 \$1169 46.4004a
Cext_2308 \$1167 \$1195 130.175a
Cext_2309 \$1167 VSS|vss 0.378729a
Cext_2310 \$1167 VSUBS 634.529a
Cext_2311 \$1168 \$1169 102.889a
Cext_2312 \$1168 \$1196 0.360462a
Cext_2313 \$1168 \$1217 42.153a
Cext_2314 \$1168 \$1276 11.7937a
Cext_2315 \$1168 \$35 123.657a
Cext_2316 \$1168 \$37 65.6459a
Cext_2317 \$1168 \$39 0.62262a
Cext_2318 \$1168 \$67 80.1249a
Cext_2319 \$1168 \$69 70.7638a
Cext_2320 \$1168 \$71 33.8269a
Cext_2321 \$1168 \$73 32.5775a
Cext_2322 \$1168 \$75 35.6349a
Cext_2323 \$1168 \$77 45.8508a
Cext_2324 \$1168 VSS|vss 0.335662a
Cext_2325 \$1168 VSUBS 255.945a
Cext_2326 \$1169 \$1196 254.864a
Cext_2327 \$1169 \$1217 0.360462a
Cext_2328 \$1169 \$35 69.0342a
Cext_2329 \$1169 \$67 64.1221a
Cext_2330 \$1169 \$71 0.168339a
Cext_2331 \$1169 \$77 0.107779a
Cext_2332 \$1169 VSS|vss 66.2906a
Cext_2333 \$1169 VSUBS 800.931a
Cext_2334 \$117 \$118 114.006a
Cext_2335 \$117 \$119 0.709993a
Cext_2336 \$117 \$137 0.360462a
Cext_2337 \$117 \$138 98.5952a
Cext_2338 \$117 \$165 108.267a
Cext_2339 \$117 \$35 136.623a
Cext_2340 \$117 \$37 20.1129a
Cext_2341 \$117 \$39 0.556279a
Cext_2342 \$117 \$41 0.342825a
Cext_2343 \$117 \$43 0.112844a
Cext_2344 \$117 \$67 74.9602a
Cext_2345 \$117 \$69 120.408a
Cext_2346 \$117 \$71 33.5711a
Cext_2347 \$117 \$73 34.6074a
Cext_2348 \$117 \$75 37.5367a
Cext_2349 \$117 \$77 46.2298a
Cext_2350 \$117 IOVDD|vdda 40.9857a
Cext_2351 \$117 VSS|vss 0.378848a
Cext_2352 \$117 VSUBS 324.405a
Cext_2353 \$1170 \$1188 113.058a
Cext_2354 \$1170 \$1198 225.319a
Cext_2355 \$1170 \$1276 5.04708a
Cext_2356 \$1170 \$35 68.7272a
Cext_2357 \$1170 \$41 0.115752a
Cext_2358 \$1170 \$43 0.481837a
Cext_2359 \$1170 \$45 20.9928a
Cext_2360 \$1170 \$67 58.9193a
Cext_2361 \$1170 \$71 0.343978a
Cext_2362 \$1170 \$886 3.31256a
Cext_2363 \$1170 VSS|vss 60.9228a
Cext_2364 \$1170 VSUBS 810.856a
Cext_2365 \$1171 \$1188 227.572a
Cext_2366 \$1171 \$1198 3.25406a
Cext_2367 \$1171 \$1199 0.179323a
Cext_2368 \$1171 \$1219 7.41179a
Cext_2369 \$1171 \$1305 22.3756a
Cext_2370 \$1171 \$35 0.592076a
Cext_2371 \$1171 \$37 82.9986a
Cext_2372 \$1171 \$39 47.2301a
Cext_2373 \$1171 \$41 0.329802a
Cext_2374 \$1171 \$67 2.30683a
Cext_2375 \$1171 \$69 115.383a
Cext_2376 \$1171 \$71 7.49159a
Cext_2377 \$1171 \$73 3.82035a
Cext_2378 \$1171 \$75 1.61371a
Cext_2379 \$1171 \$77 1.13718a
Cext_2380 \$1171 \$886 0.365616a
Cext_2381 \$1171 VSUBS 167.596a
Cext_2382 \$1172 \$1173 102.889a
Cext_2383 \$1172 \$1199 0.360462a
Cext_2384 \$1172 \$1220 42.153a
Cext_2385 \$1172 \$1278 11.7937a
Cext_2386 \$1172 \$35 123.51a
Cext_2387 \$1172 \$37 65.6459a
Cext_2388 \$1172 \$39 0.62262a
Cext_2389 \$1172 \$67 79.9778a
Cext_2390 \$1172 \$69 70.7638a
Cext_2391 \$1172 \$71 33.8269a
Cext_2392 \$1172 \$73 32.5775a
Cext_2393 \$1172 \$75 35.6349a
Cext_2394 \$1172 \$77 45.8508a
Cext_2395 \$1172 \$886 0.435916a
Cext_2396 \$1172 IOVDD|vdda 41.3232a
Cext_2397 \$1172 VSS|vss 0.335662a
Cext_2398 \$1172 VSUBS 255.671a
Cext_2399 \$1173 \$1188 0.182933a
Cext_2400 \$1173 \$1199 254.864a
Cext_2401 \$1173 \$1220 0.360462a
Cext_2402 \$1173 \$1305 5.60736a
Cext_2403 \$1173 \$35 69.0342a
Cext_2404 \$1173 \$39 0.105966a
Cext_2405 \$1173 \$41 0.282145a
Cext_2406 \$1173 \$43 0.494517a
Cext_2407 \$1173 \$45 20.7622a
Cext_2408 \$1173 \$67 64.1221a
Cext_2409 \$1173 \$71 0.168339a
Cext_2410 \$1173 \$77 0.107779a
Cext_2411 \$1173 \$886 3.55951a
Cext_2412 \$1173 IOVDD|vdda 13.2807a
Cext_2413 \$1173 VSS|vss 66.2132a
Cext_2414 \$1173 VSUBS 818.465a
Cext_2415 \$1174 \$1189 113.058a
Cext_2416 \$1174 \$1201 225.319a
Cext_2417 \$1174 \$1278 5.04708a
Cext_2418 \$1174 \$35 68.7272a
Cext_2419 \$1174 \$41 0.115752a
Cext_2420 \$1174 \$43 0.481837a
Cext_2421 \$1174 \$45 20.9928a
Cext_2422 \$1174 \$67 58.9193a
Cext_2423 \$1174 \$71 0.343978a
Cext_2424 \$1174 \$886 3.31256a
Cext_2425 \$1174 VSS|vss 60.9228a
Cext_2426 \$1174 VSUBS 810.856a
Cext_2427 \$1175 \$1189 227.572a
Cext_2428 \$1175 \$1201 3.25406a
Cext_2429 \$1175 \$1223 7.41179a
Cext_2430 \$1175 \$1307 22.3756a
Cext_2431 \$1175 \$35 0.592076a
Cext_2432 \$1175 \$37 82.9986a
Cext_2433 \$1175 \$39 47.2301a
Cext_2434 \$1175 \$41 0.329802a
Cext_2435 \$1175 \$67 2.30683a
Cext_2436 \$1175 \$69 115.493a
Cext_2437 \$1175 \$71 7.49159a
Cext_2438 \$1175 \$73 3.82035a
Cext_2439 \$1175 \$75 1.61371a
Cext_2440 \$1175 \$77 1.13718a
Cext_2441 \$1175 \$886 0.365616a
Cext_2442 \$1175 VREF|vref 0.489684a
Cext_2443 \$1175 VSUBS 167.619a
Cext_2444 \$1176 \$1177 45.0654a
Cext_2445 \$1176 \$1202 130.128a
Cext_2446 \$1176 VDD|vdd 0.592094a
Cext_2447 \$1176 VSS|vss 25.1792a
Cext_2448 \$1176 VSUBS 659.267a
Cext_2449 \$1177 \$1178 45.0654a
Cext_2450 \$1177 \$1203 130.175a
Cext_2451 \$1177 VSS|vss 5.452a
Cext_2452 \$1177 VSUBS 634.529a
Cext_2453 \$1178 \$1179 45.0654a
Cext_2454 \$1178 \$1204 130.175a
Cext_2455 \$1178 VSUBS 634.529a
Cext_2456 \$1179 \$1181 46.4004a
Cext_2457 \$1179 \$1205 130.175a
Cext_2458 \$1179 VSS|vss 0.378729a
Cext_2459 \$1179 VSUBS 634.529a
Cext_2460 \$118 \$137 254.864a
Cext_2461 \$118 \$165 0.360462a
Cext_2462 \$118 \$35 68.8031a
Cext_2463 \$118 \$37 0.177599a
Cext_2464 \$118 \$39 0.258003a
Cext_2465 \$118 \$41 0.405131a
Cext_2466 \$118 \$43 0.710075a
Cext_2467 \$118 \$45 21.0936a
Cext_2468 \$118 \$67 73.9822a
Cext_2469 \$118 \$69 0.155901a
Cext_2470 \$118 IOVDD|vdda 13.0646a
Cext_2471 \$118 VSS|vss 65.1705a
Cext_2472 \$118 VSUBS 819.437a
Cext_2473 \$1180 \$1181 102.889a
Cext_2474 \$1180 \$1206 0.360462a
Cext_2475 \$1180 \$1227 42.153a
Cext_2476 \$1180 \$1280 11.7937a
Cext_2477 \$1180 \$51 123.657a
Cext_2478 \$1180 \$53 65.6459a
Cext_2479 \$1180 \$55 0.62262a
Cext_2480 \$1180 \$83 80.1249a
Cext_2481 \$1180 \$85 70.7638a
Cext_2482 \$1180 \$87 33.8269a
Cext_2483 \$1180 \$89 32.5775a
Cext_2484 \$1180 \$91 35.6349a
Cext_2485 \$1180 \$93 45.8508a
Cext_2486 \$1180 VSS|vss 0.335662a
Cext_2487 \$1180 VSUBS 255.945a
Cext_2488 \$1181 \$1206 254.864a
Cext_2489 \$1181 \$1227 0.360462a
Cext_2490 \$1181 \$51 69.0342a
Cext_2491 \$1181 \$83 64.1221a
Cext_2492 \$1181 \$87 0.168339a
Cext_2493 \$1181 \$93 0.107779a
Cext_2494 \$1181 VSS|vss 66.2906a
Cext_2495 \$1181 VSUBS 800.931a
Cext_2496 \$1182 \$1190 113.058a
Cext_2497 \$1182 \$1208 225.319a
Cext_2498 \$1182 \$1280 5.04708a
Cext_2499 \$1182 \$51 68.7272a
Cext_2500 \$1182 \$57 0.115752a
Cext_2501 \$1182 \$59 0.481837a
Cext_2502 \$1182 \$61 20.9928a
Cext_2503 \$1182 \$83 58.9193a
Cext_2504 \$1182 \$87 0.343978a
Cext_2505 \$1182 \$890 3.31256a
Cext_2506 \$1182 VSS|vss 60.9228a
Cext_2507 \$1182 VSUBS 810.856a
Cext_2508 \$1183 \$1190 227.572a
Cext_2509 \$1183 \$1208 3.25406a
Cext_2510 \$1183 \$1209 0.179323a
Cext_2511 \$1183 \$1230 7.41179a
Cext_2512 \$1183 \$1309 22.3756a
Cext_2513 \$1183 \$51 0.592076a
Cext_2514 \$1183 \$53 82.9986a
Cext_2515 \$1183 \$55 47.2301a
Cext_2516 \$1183 \$57 0.329802a
Cext_2517 \$1183 \$83 2.30683a
Cext_2518 \$1183 \$85 115.383a
Cext_2519 \$1183 \$87 7.49159a
Cext_2520 \$1183 \$89 3.82035a
Cext_2521 \$1183 \$890 0.365616a
Cext_2522 \$1183 \$91 1.61371a
Cext_2523 \$1183 \$93 1.13718a
Cext_2524 \$1183 VSUBS 167.596a
Cext_2525 \$1184 \$1185 102.889a
Cext_2526 \$1184 \$1209 0.360462a
Cext_2527 \$1184 \$1232 42.153a
Cext_2528 \$1184 \$1282 11.7937a
Cext_2529 \$1184 \$51 123.51a
Cext_2530 \$1184 \$53 65.6459a
Cext_2531 \$1184 \$55 0.62262a
Cext_2532 \$1184 \$83 79.9778a
Cext_2533 \$1184 \$85 70.7638a
Cext_2534 \$1184 \$87 33.8269a
Cext_2535 \$1184 \$89 32.5775a
Cext_2536 \$1184 \$890 0.435916a
Cext_2537 \$1184 \$91 35.6349a
Cext_2538 \$1184 \$93 45.8508a
Cext_2539 \$1184 IOVDD|vdda 41.3232a
Cext_2540 \$1184 VSS|vss 2.91903a
Cext_2541 \$1184 VSUBS 255.671a
Cext_2542 \$1185 \$1190 0.182933a
Cext_2543 \$1185 \$1209 254.864a
Cext_2544 \$1185 \$1232 0.360462a
Cext_2545 \$1185 \$1309 5.60736a
Cext_2546 \$1185 \$51 69.0342a
Cext_2547 \$1185 \$55 0.105966a
Cext_2548 \$1185 \$57 0.282145a
Cext_2549 \$1185 \$59 0.494517a
Cext_2550 \$1185 \$61 20.7622a
Cext_2551 \$1185 \$83 64.1221a
Cext_2552 \$1185 \$87 0.168339a
Cext_2553 \$1185 \$890 3.55951a
Cext_2554 \$1185 \$93 0.107779a
Cext_2555 \$1185 IOVDD|vdda 13.2807a
Cext_2556 \$1185 VSS|vss 66.2132a
Cext_2557 \$1185 VSUBS 818.465a
Cext_2558 \$1186 \$1191 113.058a
Cext_2559 \$1186 \$1211 225.319a
Cext_2560 \$1186 \$1282 5.04708a
Cext_2561 \$1186 \$51 68.7272a
Cext_2562 \$1186 \$57 0.115752a
Cext_2563 \$1186 \$59 0.481837a
Cext_2564 \$1186 \$61 20.9928a
Cext_2565 \$1186 \$83 58.9193a
Cext_2566 \$1186 \$87 0.343978a
Cext_2567 \$1186 \$890 3.31256a
Cext_2568 \$1186 VSS|vss 69.9251a
Cext_2569 \$1186 VSUBS 810.856a
Cext_2570 \$1187 \$1191 227.572a
Cext_2571 \$1187 \$1211 3.25406a
Cext_2572 \$1187 \$1234 7.41179a
Cext_2573 \$1187 \$1311 22.3756a
Cext_2574 \$1187 \$51 0.592076a
Cext_2575 \$1187 \$53 82.9986a
Cext_2576 \$1187 \$55 47.2301a
Cext_2577 \$1187 \$57 0.329802a
Cext_2578 \$1187 \$83 2.30683a
Cext_2579 \$1187 \$85 115.493a
Cext_2580 \$1187 \$87 7.49159a
Cext_2581 \$1187 \$89 3.82035a
Cext_2582 \$1187 \$890 0.365616a
Cext_2583 \$1187 \$91 1.61371a
Cext_2584 \$1187 \$93 1.13718a
Cext_2585 \$1187 VREF|vref 0.489684a
Cext_2586 \$1187 VSUBS 167.619a
Cext_2587 \$1188 \$1198 102.889a
Cext_2588 \$1188 \$1218 0.360462a
Cext_2589 \$1188 \$1235 42.153a
Cext_2590 \$1188 \$1305 11.7937a
Cext_2591 \$1188 \$35 134.708a
Cext_2592 \$1188 \$37 19.3729a
Cext_2593 \$1188 \$39 1.18572a
Cext_2594 \$1188 \$67 69.937a
Cext_2595 \$1188 \$69 117.46a
Cext_2596 \$1188 \$71 32.765a
Cext_2597 \$1188 \$73 32.5775a
Cext_2598 \$1188 \$75 35.6349a
Cext_2599 \$1188 \$77 45.8508a
Cext_2600 \$1188 \$886 0.257855a
Cext_2601 \$1188 VSS|vss 0.335662a
Cext_2602 \$1188 VSUBS 255.562a
Cext_2603 \$1189 \$1201 102.889a
Cext_2604 \$1189 \$1222 0.360462a
Cext_2605 \$1189 \$1236 42.153a
Cext_2606 \$1189 \$1307 11.7937a
Cext_2607 \$1189 \$35 134.708a
Cext_2608 \$1189 \$37 19.3729a
Cext_2609 \$1189 \$39 1.18572a
Cext_2610 \$1189 \$67 69.937a
Cext_2611 \$1189 \$69 117.46a
Cext_2612 \$1189 \$71 32.765a
Cext_2613 \$1189 \$73 32.5775a
Cext_2614 \$1189 \$75 35.6349a
Cext_2615 \$1189 \$77 45.8508a
Cext_2616 \$1189 \$886 0.257855a
Cext_2617 \$1189 VREF|vref 0.182933a
Cext_2618 \$1189 VSS|vss 0.335662a
Cext_2619 \$1189 VSUBS 255.562a
Cext_2620 \$119 \$139 102.928a
Cext_2621 \$119 \$140 225.319a
Cext_2622 \$119 \$35 69.5346a
Cext_2623 \$119 \$37 0.283978a
Cext_2624 \$119 \$39 0.209713a
Cext_2625 \$119 \$41 0.276252a
Cext_2626 \$119 \$43 0.481837a
Cext_2627 \$119 \$45 20.8391a
Cext_2628 \$119 \$67 68.2327a
Cext_2629 \$119 \$69 0.679713a
Cext_2630 \$119 \$71 0.242834a
Cext_2631 \$119 \$73 0.182729a
Cext_2632 \$119 \$75 0.262546a
Cext_2633 \$119 \$77 0.172446a
Cext_2634 \$119 VSS|vss 59.9275a
Cext_2635 \$119 VSUBS 844.801a
Cext_2636 \$1190 \$1208 102.889a
Cext_2637 \$1190 \$1229 0.360462a
Cext_2638 \$1190 \$1238 42.153a
Cext_2639 \$1190 \$1309 11.7937a
Cext_2640 \$1190 \$51 134.708a
Cext_2641 \$1190 \$53 19.3729a
Cext_2642 \$1190 \$55 1.18572a
Cext_2643 \$1190 \$83 69.937a
Cext_2644 \$1190 \$85 117.46a
Cext_2645 \$1190 \$87 32.765a
Cext_2646 \$1190 \$89 32.5775a
Cext_2647 \$1190 \$890 0.257855a
Cext_2648 \$1190 \$91 35.6349a
Cext_2649 \$1190 \$93 45.8508a
Cext_2650 \$1190 VSS|vss 0.335662a
Cext_2651 \$1190 VSUBS 255.562a
Cext_2652 \$1191 \$1211 102.889a
Cext_2653 \$1191 \$1233 0.360462a
Cext_2654 \$1191 \$1239 42.153a
Cext_2655 \$1191 \$1311 11.7937a
Cext_2656 \$1191 \$51 134.708a
Cext_2657 \$1191 \$53 19.3729a
Cext_2658 \$1191 \$55 1.18572a
Cext_2659 \$1191 \$83 69.937a
Cext_2660 \$1191 \$85 117.46a
Cext_2661 \$1191 \$87 32.765a
Cext_2662 \$1191 \$89 32.5775a
Cext_2663 \$1191 \$890 0.257855a
Cext_2664 \$1191 \$91 35.6349a
Cext_2665 \$1191 \$93 45.8508a
Cext_2666 \$1191 VREF|vref 0.182933a
Cext_2667 \$1191 VSS|vss 0.335662a
Cext_2668 \$1191 VSUBS 255.562a
Cext_2669 \$1192 \$1193 45.0654a
Cext_2670 \$1192 \$1212 130.175a
Cext_2671 \$1192 VDD|vdd 7.74075a
Cext_2672 \$1192 VSS|vss 1.71997a
Cext_2673 \$1192 VSUBS 659.267a
Cext_2674 \$1193 \$1194 45.0654a
Cext_2675 \$1193 \$1213 130.175a
Cext_2676 \$1193 VDD|vdd 0.968272a
Cext_2677 \$1193 VSUBS 634.529a
Cext_2678 \$1194 \$1195 45.0654a
Cext_2679 \$1194 \$1214 130.175a
Cext_2680 \$1194 VSUBS 634.529a
Cext_2681 \$1195 \$1196 45.8951a
Cext_2682 \$1195 \$1215 130.175a
Cext_2683 \$1195 VSS|vss 0.428128a
Cext_2684 \$1195 VSUBS 634.529a
Cext_2685 \$1196 \$1197 2.46853a
Cext_2686 \$1196 \$1216 225.319a
Cext_2687 \$1196 \$1217 102.889a
Cext_2688 \$1196 \$35 22.8071a
Cext_2689 \$1196 \$67 105.489a
Cext_2690 \$1196 VSS|vss 61.1015a
Cext_2691 \$1196 VSUBS 793.935a
Cext_2692 \$1197 \$1198 0.179323a
Cext_2693 \$1197 \$1217 230.002a
Cext_2694 \$1197 \$1256 98.5952a
Cext_2695 \$1197 \$1276 22.3417a
Cext_2696 \$1197 \$1332 1.46644a
Cext_2697 \$1197 \$35 0.496172a
Cext_2698 \$1197 \$37 82.9986a
Cext_2699 \$1197 \$39 47.3198a
Cext_2700 \$1197 \$43 0.329802a
Cext_2701 \$1197 \$67 2.30683a
Cext_2702 \$1197 \$69 118.358a
Cext_2703 \$1197 \$71 7.5941a
Cext_2704 \$1197 \$73 3.34353a
Cext_2705 \$1197 \$75 1.9986a
Cext_2706 \$1197 \$77 1.0724a
Cext_2707 \$1197 VSUBS 177.197a
Cext_2708 \$1198 \$1218 254.864a
Cext_2709 \$1198 \$1235 0.360462a
Cext_2710 \$1198 \$1276 5.60736a
Cext_2711 \$1198 \$35 23.4429a
Cext_2712 \$1198 \$39 0.251943a
Cext_2713 \$1198 \$41 0.282145a
Cext_2714 \$1198 \$43 0.494517a
Cext_2715 \$1198 \$45 20.9159a
Cext_2716 \$1198 \$67 110.011a
Cext_2717 \$1198 \$77 0.107779a
Cext_2718 \$1198 \$886 0.410988a
Cext_2719 \$1198 VSS|vss 66.2132a
Cext_2720 \$1198 VSUBS 818.365a
Cext_2721 \$1199 \$1200 2.46853a
Cext_2722 \$1199 \$1220 102.889a
Cext_2723 \$1199 \$1221 225.319a
Cext_2724 \$1199 \$1305 5.04708a
Cext_2725 \$1199 \$35 22.8071a
Cext_2726 \$1199 \$39 0.500702a
Cext_2727 \$1199 \$41 0.115752a
Cext_2728 \$1199 \$43 0.481837a
Cext_2729 \$1199 \$45 20.9928a
Cext_2730 \$1199 \$67 105.489a
Cext_2731 \$1199 \$886 0.410988a
Cext_2732 \$1199 IOVDD|vdda 11.6291a
Cext_2733 \$1199 VSS|vss 60.9228a
Cext_2734 \$1199 VSUBS 810.925a
Cext_2735 \$120 \$141 130.175a
Cext_2736 \$120 \$37 0.177599a
Cext_2737 \$120 \$39 0.258003a
Cext_2738 \$120 \$41 0.405131a
Cext_2739 \$120 \$43 0.710075a
Cext_2740 \$120 \$45 21.1432a
Cext_2741 \$120 \$67 7.56443a
Cext_2742 \$120 VSS|vss 2.2008a
Cext_2743 \$120 VSUBS 676a
Cext_2744 \$1200 \$1201 0.179323a
Cext_2745 \$1200 \$1220 230.002a
Cext_2746 \$1200 \$1257 98.5952a
Cext_2747 \$1200 \$1278 22.3417a
Cext_2748 \$1200 \$1334 1.46644a
Cext_2749 \$1200 \$35 0.496172a
Cext_2750 \$1200 \$37 82.9986a
Cext_2751 \$1200 \$39 47.3198a
Cext_2752 \$1200 \$43 0.329802a
Cext_2753 \$1200 \$67 2.30683a
Cext_2754 \$1200 \$69 118.358a
Cext_2755 \$1200 \$71 7.5941a
Cext_2756 \$1200 \$73 3.34353a
Cext_2757 \$1200 \$75 1.9986a
Cext_2758 \$1200 \$77 1.0724a
Cext_2759 \$1200 IOVDD|vdda 5.22317a
Cext_2760 \$1200 VSUBS 177.197a
Cext_2761 \$1201 \$1222 254.864a
Cext_2762 \$1201 \$1236 0.360462a
Cext_2763 \$1201 \$1278 5.60736a
Cext_2764 \$1201 \$35 23.4429a
Cext_2765 \$1201 \$39 0.251943a
Cext_2766 \$1201 \$41 0.282145a
Cext_2767 \$1201 \$43 0.494517a
Cext_2768 \$1201 \$45 20.9159a
Cext_2769 \$1201 \$67 110.011a
Cext_2770 \$1201 \$77 0.107779a
Cext_2771 \$1201 \$886 0.410988a
Cext_2772 \$1201 VSS|vss 66.2132a
Cext_2773 \$1201 VSUBS 818.365a
Cext_2774 \$1202 \$1203 45.0654a
Cext_2775 \$1202 \$1224 130.128a
Cext_2776 \$1202 VDD|vdd 0.592094a
Cext_2777 \$1202 VSS|vss 25.1792a
Cext_2778 \$1202 VSUBS 659.267a
Cext_2779 \$1203 \$1204 45.0654a
Cext_2780 \$1203 \$1237 130.175a
Cext_2781 \$1203 VSS|vss 5.452a
Cext_2782 \$1203 VSUBS 634.529a
Cext_2783 \$1204 \$1205 45.0654a
Cext_2784 \$1204 \$1225 130.175a
Cext_2785 \$1204 VSUBS 634.529a
Cext_2786 \$1205 \$1206 45.8951a
Cext_2787 \$1205 \$1226 130.175a
Cext_2788 \$1205 VSS|vss 0.428128a
Cext_2789 \$1205 VSUBS 634.529a
Cext_2790 \$1206 \$1207 2.46853a
Cext_2791 \$1206 \$1227 102.889a
Cext_2792 \$1206 \$1228 225.319a
Cext_2793 \$1206 \$51 22.8071a
Cext_2794 \$1206 \$83 105.489a
Cext_2795 \$1206 VSS|vss 61.1015a
Cext_2796 \$1206 VSUBS 793.935a
Cext_2797 \$1207 \$1208 0.179323a
Cext_2798 \$1207 \$1227 230.002a
Cext_2799 \$1207 \$1258 98.5952a
Cext_2800 \$1207 \$1280 22.3417a
Cext_2801 \$1207 \$1336 1.46644a
Cext_2802 \$1207 \$51 0.496172a
Cext_2803 \$1207 \$53 82.9986a
Cext_2804 \$1207 \$55 47.3198a
Cext_2805 \$1207 \$59 0.329802a
Cext_2806 \$1207 \$83 2.30683a
Cext_2807 \$1207 \$85 118.358a
Cext_2808 \$1207 \$87 7.5941a
Cext_2809 \$1207 \$89 3.34353a
Cext_2810 \$1207 \$91 1.9986a
Cext_2811 \$1207 \$93 1.0724a
Cext_2812 \$1207 VSUBS 177.197a
Cext_2813 \$1208 \$1229 254.864a
Cext_2814 \$1208 \$1238 0.360462a
Cext_2815 \$1208 \$1280 5.60736a
Cext_2816 \$1208 \$51 23.4429a
Cext_2817 \$1208 \$55 0.251943a
Cext_2818 \$1208 \$57 0.282145a
Cext_2819 \$1208 \$59 0.494517a
Cext_2820 \$1208 \$61 20.9159a
Cext_2821 \$1208 \$83 110.011a
Cext_2822 \$1208 \$890 0.410988a
Cext_2823 \$1208 \$93 0.107779a
Cext_2824 \$1208 VSS|vss 66.2132a
Cext_2825 \$1208 VSUBS 818.365a
Cext_2826 \$1209 \$1210 2.46853a
Cext_2827 \$1209 \$1231 225.319a
Cext_2828 \$1209 \$1232 102.889a
Cext_2829 \$1209 \$1309 5.04708a
Cext_2830 \$1209 \$51 22.8071a
Cext_2831 \$1209 \$55 0.500702a
Cext_2832 \$1209 \$57 0.115752a
Cext_2833 \$1209 \$59 0.481837a
Cext_2834 \$1209 \$61 20.9928a
Cext_2835 \$1209 \$83 105.489a
Cext_2836 \$1209 \$890 0.410988a
Cext_2837 \$1209 IOVDD|vdda 11.6291a
Cext_2838 \$1209 VSS|vss 60.9228a
Cext_2839 \$1209 VSUBS 810.925a
Cext_2840 \$121 \$122 45.0654a
Cext_2841 \$121 \$143 130.175a
Cext_2842 \$121 \$83 3.81687a
Cext_2843 \$121 VSS|vss 52.2594a
Cext_2844 \$121 VSUBS 634.529a
Cext_2845 \$1210 \$1211 0.179323a
Cext_2846 \$1210 \$1232 230.002a
Cext_2847 \$1210 \$1259 98.5952a
Cext_2848 \$1210 \$1282 22.3417a
Cext_2849 \$1210 \$1338 1.46644a
Cext_2850 \$1210 \$51 0.496172a
Cext_2851 \$1210 \$53 82.9986a
Cext_2852 \$1210 \$55 47.3198a
Cext_2853 \$1210 \$59 0.329802a
Cext_2854 \$1210 \$83 2.30683a
Cext_2855 \$1210 \$85 118.358a
Cext_2856 \$1210 \$87 7.5941a
Cext_2857 \$1210 \$89 3.34353a
Cext_2858 \$1210 \$91 1.9986a
Cext_2859 \$1210 \$93 1.0724a
Cext_2860 \$1210 IOVDD|vdda 5.22317a
Cext_2861 \$1210 VSS|vss 5.69375a
Cext_2862 \$1210 VSUBS 177.197a
Cext_2863 \$1211 \$1233 254.864a
Cext_2864 \$1211 \$1239 0.360462a
Cext_2865 \$1211 \$1282 5.60736a
Cext_2866 \$1211 \$51 23.4429a
Cext_2867 \$1211 \$55 0.251943a
Cext_2868 \$1211 \$57 0.282145a
Cext_2869 \$1211 \$59 0.494517a
Cext_2870 \$1211 \$61 20.9159a
Cext_2871 \$1211 \$83 110.011a
Cext_2872 \$1211 \$890 0.410988a
Cext_2873 \$1211 \$93 0.107779a
Cext_2874 \$1211 VSS|vss 75.4228a
Cext_2875 \$1211 VSUBS 818.365a
Cext_2876 \$1212 \$1213 45.0654a
Cext_2877 \$1212 \$1240 130.175a
Cext_2878 \$1212 VDD|vdd 7.74075a
Cext_2879 \$1212 VSS|vss 1.71997a
Cext_2880 \$1212 VSUBS 659.267a
Cext_2881 \$1213 \$1214 45.0654a
Cext_2882 \$1213 \$1241 130.175a
Cext_2883 \$1213 VDD|vdd 0.968272a
Cext_2884 \$1213 VSUBS 634.529a
Cext_2885 \$1214 \$1215 45.0654a
Cext_2886 \$1214 \$1242 130.175a
Cext_2887 \$1214 VSUBS 634.529a
Cext_2888 \$1215 \$1216 46.4004a
Cext_2889 \$1215 \$1243 130.175a
Cext_2890 \$1215 VSS|vss 0.378729a
Cext_2891 \$1215 VSUBS 634.529a
Cext_2892 \$1216 \$1217 114.006a
Cext_2893 \$1216 \$1244 254.864a
Cext_2894 \$1216 \$1256 0.360462a
Cext_2895 \$1216 \$35 68.8031a
Cext_2896 \$1216 \$67 64.1221a
Cext_2897 \$1216 \$69 0.155901a
Cext_2898 \$1216 VSS|vss 66.2906a
Cext_2899 \$1216 VSUBS 799.746a
Cext_2900 \$1217 \$1218 0.182933a
Cext_2901 \$1217 \$1244 0.360462a
Cext_2902 \$1217 \$1256 108.267a
Cext_2903 \$1217 \$1276 11.8276a
Cext_2904 \$1217 \$35 134.708a
Cext_2905 \$1217 \$37 19.3729a
Cext_2906 \$1217 \$39 1.40263a
Cext_2907 \$1217 \$67 69.9941a
Cext_2908 \$1217 \$69 117.46a
Cext_2909 \$1217 \$71 32.765a
Cext_2910 \$1217 \$73 32.5775a
Cext_2911 \$1217 \$75 35.6349a
Cext_2912 \$1217 \$77 45.7852a
Cext_2913 \$1217 VSS|vss 0.378848a
Cext_2914 \$1217 VSUBS 255.577a
Cext_2915 \$1218 \$1219 2.46853a
Cext_2916 \$1218 \$1235 102.889a
Cext_2917 \$1218 \$1245 225.319a
Cext_2918 \$1218 \$1276 5.04708a
Cext_2919 \$1218 \$35 68.8428a
Cext_2920 \$1218 \$41 0.115752a
Cext_2921 \$1218 \$43 0.481837a
Cext_2922 \$1218 \$45 20.8391a
Cext_2923 \$1218 \$67 58.9193a
Cext_2924 \$1218 \$69 0.343978a
Cext_2925 \$1218 VSS|vss 60.9228a
Cext_2926 \$1218 VSUBS 811.534a
Cext_2927 \$1219 \$1221 0.179323a
Cext_2928 \$1219 \$1235 230.002a
Cext_2929 \$1219 \$1277 98.5952a
Cext_2930 \$1219 \$1305 22.3417a
Cext_2931 \$1219 \$1357 1.46644a
Cext_2932 \$1219 \$35 2.95962a
Cext_2933 \$1219 \$37 93.8054a
Cext_2934 \$1219 \$39 1.18748a
Cext_2935 \$1219 \$43 0.476813a
Cext_2936 \$1219 \$69 106.511a
Cext_2937 \$1219 \$71 53.7264a
Cext_2938 \$1219 \$73 3.34353a
Cext_2939 \$1219 \$75 1.85159a
Cext_2940 \$1219 \$77 1.0724a
Cext_2941 \$1219 VSUBS 177.904a
Cext_2942 \$122 \$123 45.0654a
Cext_2943 \$122 \$144 130.175a
Cext_2944 \$122 \$83 7.68982a
Cext_2945 \$122 VSUBS 634.529a
Cext_2946 \$1220 \$1221 114.006a
Cext_2947 \$1220 \$1222 0.182933a
Cext_2948 \$1220 \$1246 0.360462a
Cext_2949 \$1220 \$1257 108.267a
Cext_2950 \$1220 \$1278 11.8276a
Cext_2951 \$1220 \$35 134.561a
Cext_2952 \$1220 \$37 19.3729a
Cext_2953 \$1220 \$39 1.40263a
Cext_2954 \$1220 \$67 69.8469a
Cext_2955 \$1220 \$69 117.46a
Cext_2956 \$1220 \$71 32.765a
Cext_2957 \$1220 \$73 32.5775a
Cext_2958 \$1220 \$75 35.6349a
Cext_2959 \$1220 \$77 45.7852a
Cext_2960 \$1220 IOVDD|vdda 41.4191a
Cext_2961 \$1220 VSS|vss 0.378848a
Cext_2962 \$1220 VSUBS 255.303a
Cext_2963 \$1221 \$1246 254.864a
Cext_2964 \$1221 \$1257 0.360462a
Cext_2965 \$1221 \$1305 5.60736a
Cext_2966 \$1221 \$35 68.8031a
Cext_2967 \$1221 \$39 0.105966a
Cext_2968 \$1221 \$41 0.282145a
Cext_2969 \$1221 \$43 0.494517a
Cext_2970 \$1221 \$45 20.9159a
Cext_2971 \$1221 \$67 64.1221a
Cext_2972 \$1221 \$69 0.155901a
Cext_2973 \$1221 IOVDD|vdda 13.0646a
Cext_2974 \$1221 VSS|vss 66.2132a
Cext_2975 \$1221 VSUBS 817.279a
Cext_2976 \$1222 \$1223 2.46853a
Cext_2977 \$1222 \$1236 102.889a
Cext_2978 \$1222 \$1247 225.319a
Cext_2979 \$1222 \$1278 5.04708a
Cext_2980 \$1222 \$35 68.8428a
Cext_2981 \$1222 \$41 0.115752a
Cext_2982 \$1222 \$43 0.481837a
Cext_2983 \$1222 \$45 20.8391a
Cext_2984 \$1222 \$67 58.9193a
Cext_2985 \$1222 \$69 0.343978a
Cext_2986 \$1222 VSS|vss 60.9228a
Cext_2987 \$1222 VSUBS 811.534a
Cext_2988 \$1223 \$1236 230.002a
Cext_2989 \$1223 \$1279 98.5952a
Cext_2990 \$1223 \$1307 22.3417a
Cext_2991 \$1223 \$1359 1.46644a
Cext_2992 \$1223 \$35 2.95962a
Cext_2993 \$1223 \$37 93.8054a
Cext_2994 \$1223 \$39 1.18748a
Cext_2995 \$1223 \$43 0.476813a
Cext_2996 \$1223 \$69 106.511a
Cext_2997 \$1223 \$71 53.7264a
Cext_2998 \$1223 \$73 3.34353a
Cext_2999 \$1223 \$75 1.85159a
Cext_3000 \$1223 \$77 1.0724a
Cext_3001 \$1223 VREF|vref 0.489684a
Cext_3002 \$1223 VSUBS 177.904a
Cext_3003 \$1224 \$1237 45.0654a
Cext_3004 \$1224 \$1248 130.128a
Cext_3005 \$1224 VDD|vdd 0.592094a
Cext_3006 \$1224 VSS|vss 25.1792a
Cext_3007 \$1224 VSUBS 659.267a
Cext_3008 \$1225 \$1226 45.0654a
Cext_3009 \$1225 \$1237 45.0654a
Cext_3010 \$1225 \$1250 130.175a
Cext_3011 \$1225 VSUBS 634.529a
Cext_3012 \$1226 \$1228 46.4004a
Cext_3013 \$1226 \$1251 130.175a
Cext_3014 \$1226 VSS|vss 0.378729a
Cext_3015 \$1226 VSUBS 634.529a
Cext_3016 \$1227 \$1228 114.006a
Cext_3017 \$1227 \$1229 0.182933a
Cext_3018 \$1227 \$1252 0.360462a
Cext_3019 \$1227 \$1258 108.267a
Cext_3020 \$1227 \$1280 11.8276a
Cext_3021 \$1227 \$51 134.708a
Cext_3022 \$1227 \$53 19.3729a
Cext_3023 \$1227 \$55 1.40263a
Cext_3024 \$1227 \$83 69.9941a
Cext_3025 \$1227 \$85 117.46a
Cext_3026 \$1227 \$87 32.765a
Cext_3027 \$1227 \$89 32.5775a
Cext_3028 \$1227 \$91 35.6349a
Cext_3029 \$1227 \$93 45.7852a
Cext_3030 \$1227 VSS|vss 0.378848a
Cext_3031 \$1227 VSUBS 255.577a
Cext_3032 \$1228 \$1252 254.864a
Cext_3033 \$1228 \$1258 0.360462a
Cext_3034 \$1228 \$51 68.8031a
Cext_3035 \$1228 \$83 64.1221a
Cext_3036 \$1228 \$85 0.155901a
Cext_3037 \$1228 VSS|vss 66.2906a
Cext_3038 \$1228 VSUBS 799.746a
Cext_3039 \$1229 \$1230 2.46853a
Cext_3040 \$1229 \$1238 102.889a
Cext_3041 \$1229 \$1253 225.319a
Cext_3042 \$1229 \$1280 5.04708a
Cext_3043 \$1229 \$51 68.8428a
Cext_3044 \$1229 \$57 0.115752a
Cext_3045 \$1229 \$59 0.481837a
Cext_3046 \$1229 \$61 20.8391a
Cext_3047 \$1229 \$83 58.9193a
Cext_3048 \$1229 \$85 0.343978a
Cext_3049 \$1229 VSS|vss 60.9228a
Cext_3050 \$1229 VSUBS 811.534a
Cext_3051 \$123 \$125 46.4004a
Cext_3052 \$123 \$156 130.175a
Cext_3053 \$123 \$83 7.68982a
Cext_3054 \$123 VSS|vss 0.378729a
Cext_3055 \$123 VSUBS 634.529a
Cext_3056 \$1230 \$1231 0.179323a
Cext_3057 \$1230 \$1238 230.002a
Cext_3058 \$1230 \$1281 98.5952a
Cext_3059 \$1230 \$1309 22.3417a
Cext_3060 \$1230 \$1361 1.46644a
Cext_3061 \$1230 \$51 2.95962a
Cext_3062 \$1230 \$53 93.8054a
Cext_3063 \$1230 \$55 1.18748a
Cext_3064 \$1230 \$59 0.476813a
Cext_3065 \$1230 \$85 106.511a
Cext_3066 \$1230 \$87 53.7264a
Cext_3067 \$1230 \$89 3.34353a
Cext_3068 \$1230 \$91 1.85159a
Cext_3069 \$1230 \$93 1.0724a
Cext_3070 \$1230 VSUBS 177.904a
Cext_3071 \$1231 \$1232 114.006a
Cext_3072 \$1231 \$1254 254.864a
Cext_3073 \$1231 \$1259 0.360462a
Cext_3074 \$1231 \$1309 5.60736a
Cext_3075 \$1231 \$51 68.8031a
Cext_3076 \$1231 \$55 0.105966a
Cext_3077 \$1231 \$57 0.282145a
Cext_3078 \$1231 \$59 0.494517a
Cext_3079 \$1231 \$61 20.9159a
Cext_3080 \$1231 \$83 64.1221a
Cext_3081 \$1231 \$85 0.155901a
Cext_3082 \$1231 IOVDD|vdda 13.0646a
Cext_3083 \$1231 VSS|vss 66.2132a
Cext_3084 \$1231 VSUBS 817.279a
Cext_3085 \$1232 \$1233 0.182933a
Cext_3086 \$1232 \$1254 0.360462a
Cext_3087 \$1232 \$1259 108.267a
Cext_3088 \$1232 \$1282 11.8276a
Cext_3089 \$1232 \$51 134.561a
Cext_3090 \$1232 \$53 19.3729a
Cext_3091 \$1232 \$55 1.40263a
Cext_3092 \$1232 \$83 69.8469a
Cext_3093 \$1232 \$85 117.46a
Cext_3094 \$1232 \$87 32.765a
Cext_3095 \$1232 \$89 32.5775a
Cext_3096 \$1232 \$91 35.6349a
Cext_3097 \$1232 \$93 45.7852a
Cext_3098 \$1232 IOVDD|vdda 41.4191a
Cext_3099 \$1232 VSS|vss 3.54327a
Cext_3100 \$1232 VSUBS 255.303a
Cext_3101 \$1233 \$1234 2.46853a
Cext_3102 \$1233 \$1239 102.889a
Cext_3103 \$1233 \$1255 225.319a
Cext_3104 \$1233 \$1282 5.04708a
Cext_3105 \$1233 \$51 68.8428a
Cext_3106 \$1233 \$57 0.115752a
Cext_3107 \$1233 \$59 0.481837a
Cext_3108 \$1233 \$61 20.8391a
Cext_3109 \$1233 \$83 58.9193a
Cext_3110 \$1233 \$85 0.343978a
Cext_3111 \$1233 VSS|vss 69.9251a
Cext_3112 \$1233 VSUBS 811.534a
Cext_3113 \$1234 \$1239 230.002a
Cext_3114 \$1234 \$1283 98.5952a
Cext_3115 \$1234 \$1311 22.3417a
Cext_3116 \$1234 \$1363 1.46644a
Cext_3117 \$1234 \$51 2.95962a
Cext_3118 \$1234 \$53 93.8054a
Cext_3119 \$1234 \$55 1.18748a
Cext_3120 \$1234 \$59 0.476813a
Cext_3121 \$1234 \$85 106.511a
Cext_3122 \$1234 \$87 53.7264a
Cext_3123 \$1234 \$89 3.34353a
Cext_3124 \$1234 \$91 1.85159a
Cext_3125 \$1234 \$93 1.0724a
Cext_3126 \$1234 VREF|vref 0.489684a
Cext_3127 \$1234 VSUBS 177.904a
Cext_3128 \$1235 \$1245 114.006a
Cext_3129 \$1235 \$1246 0.182933a
Cext_3130 \$1235 \$1265 0.360462a
Cext_3131 \$1235 \$1277 108.267a
Cext_3132 \$1235 \$1305 11.8276a
Cext_3133 \$1235 \$35 123.657a
Cext_3134 \$1235 \$37 65.6459a
Cext_3135 \$1235 \$39 0.62262a
Cext_3136 \$1235 \$67 80.1821a
Cext_3137 \$1235 \$69 70.7638a
Cext_3138 \$1235 \$71 34.0438a
Cext_3139 \$1235 \$73 32.5775a
Cext_3140 \$1235 \$75 35.6349a
Cext_3141 \$1235 \$77 45.7852a
Cext_3142 \$1235 VSS|vss 0.378848a
Cext_3143 \$1235 VSUBS 255.847a
Cext_3144 \$1236 \$1247 114.006a
Cext_3145 \$1236 \$1267 0.360462a
Cext_3146 \$1236 \$1279 108.267a
Cext_3147 \$1236 \$1307 11.8276a
Cext_3148 \$1236 \$35 123.657a
Cext_3149 \$1236 \$37 65.6459a
Cext_3150 \$1236 \$39 0.62262a
Cext_3151 \$1236 \$67 80.1821a
Cext_3152 \$1236 \$69 70.7638a
Cext_3153 \$1236 \$71 34.0438a
Cext_3154 \$1236 \$73 32.5775a
Cext_3155 \$1236 \$75 35.6349a
Cext_3156 \$1236 \$77 45.7852a
Cext_3157 \$1236 VREF|vref 0.182933a
Cext_3158 \$1236 VSS|vss 0.378848a
Cext_3159 \$1236 VSUBS 255.847a
Cext_3160 \$1237 \$1249 130.175a
Cext_3161 \$1237 VSS|vss 5.452a
Cext_3162 \$1237 VSUBS 634.529a
Cext_3163 \$1238 \$1253 114.006a
Cext_3164 \$1238 \$1254 0.182933a
Cext_3165 \$1238 \$1273 0.360462a
Cext_3166 \$1238 \$1281 108.267a
Cext_3167 \$1238 \$1309 11.8276a
Cext_3168 \$1238 \$51 123.657a
Cext_3169 \$1238 \$53 65.6459a
Cext_3170 \$1238 \$55 0.62262a
Cext_3171 \$1238 \$83 80.1821a
Cext_3172 \$1238 \$85 70.7638a
Cext_3173 \$1238 \$87 34.0438a
Cext_3174 \$1238 \$89 32.5775a
Cext_3175 \$1238 \$91 35.6349a
Cext_3176 \$1238 \$93 45.7852a
Cext_3177 \$1238 VSS|vss 0.378848a
Cext_3178 \$1238 VSUBS 255.847a
Cext_3179 \$1239 \$1255 114.006a
Cext_3180 \$1239 \$1275 0.360462a
Cext_3181 \$1239 \$1283 108.267a
Cext_3182 \$1239 \$1311 11.8276a
Cext_3183 \$1239 \$51 123.657a
Cext_3184 \$1239 \$53 65.6459a
Cext_3185 \$1239 \$55 0.62262a
Cext_3186 \$1239 \$83 80.1821a
Cext_3187 \$1239 \$85 70.7638a
Cext_3188 \$1239 \$87 34.0438a
Cext_3189 \$1239 \$89 32.5775a
Cext_3190 \$1239 \$91 35.6349a
Cext_3191 \$1239 \$93 45.7852a
Cext_3192 \$1239 VREF|vref 0.182933a
Cext_3193 \$1239 VSS|vss 0.378848a
Cext_3194 \$1239 VSUBS 255.847a
Cext_3195 \$124 \$125 114.006a
Cext_3196 \$124 \$126 0.709993a
Cext_3197 \$124 \$145 0.360462a
Cext_3198 \$124 \$146 98.5952a
Cext_3199 \$124 \$175 108.267a
Cext_3200 \$124 \$51 136.376a
Cext_3201 \$124 \$53 20.0466a
Cext_3202 \$124 \$55 0.507346a
Cext_3203 \$124 \$57 1.90541a
Cext_3204 \$124 \$59 0.112844a
Cext_3205 \$124 \$83 74.9792a
Cext_3206 \$124 \$85 120.227a
Cext_3207 \$124 \$87 33.5145a
Cext_3208 \$124 \$89 34.5648a
Cext_3209 \$124 \$91 37.5036a
Cext_3210 \$124 \$93 46.2298a
Cext_3211 \$124 VSS|vss 0.378848a
Cext_3212 \$124 VSUBS 323.96a
Cext_3213 \$1240 \$1241 45.0654a
Cext_3214 \$1240 \$1260 130.175a
Cext_3215 \$1240 VDD|vdd 7.74075a
Cext_3216 \$1240 VSS|vss 1.71997a
Cext_3217 \$1240 VSUBS 659.267a
Cext_3218 \$1241 \$1242 45.0654a
Cext_3219 \$1241 \$1261 130.175a
Cext_3220 \$1241 VDD|vdd 0.968272a
Cext_3221 \$1241 VSUBS 634.529a
Cext_3222 \$1242 \$1243 45.0654a
Cext_3223 \$1242 \$1262 130.175a
Cext_3224 \$1242 VSUBS 634.529a
Cext_3225 \$1243 \$1244 45.8951a
Cext_3226 \$1243 \$1263 130.175a
Cext_3227 \$1243 VSS|vss 0.428128a
Cext_3228 \$1243 VSUBS 634.529a
Cext_3229 \$1244 \$1256 113.058a
Cext_3230 \$1244 \$1264 225.319a
Cext_3231 \$1244 \$35 22.6915a
Cext_3232 \$1244 \$67 105.489a
Cext_3233 \$1244 VSS|vss 61.1015a
Cext_3234 \$1244 VSUBS 793.257a
Cext_3235 \$1245 \$1256 0.182933a
Cext_3236 \$1245 \$1265 254.864a
Cext_3237 \$1245 \$1276 5.60736a
Cext_3238 \$1245 \$1277 0.360462a
Cext_3239 \$1245 \$35 23.2117a
Cext_3240 \$1245 \$37 0.145978a
Cext_3241 \$1245 \$39 0.105966a
Cext_3242 \$1245 \$41 0.282145a
Cext_3243 \$1245 \$43 0.494517a
Cext_3244 \$1245 \$45 20.7622a
Cext_3245 \$1245 \$67 110.011a
Cext_3246 \$1245 VSS|vss 66.2132a
Cext_3247 \$1245 VSUBS 817.162a
Cext_3248 \$1246 \$1257 113.058a
Cext_3249 \$1246 \$1266 225.319a
Cext_3250 \$1246 \$1305 5.04708a
Cext_3251 \$1246 \$35 22.6915a
Cext_3252 \$1246 \$37 0.404672a
Cext_3253 \$1246 \$41 0.115752a
Cext_3254 \$1246 \$43 0.481837a
Cext_3255 \$1246 \$45 20.8391a
Cext_3256 \$1246 \$67 105.489a
Cext_3257 \$1246 IOVDD|vdda 11.5102a
Cext_3258 \$1246 VSS|vss 60.9228a
Cext_3259 \$1246 VSUBS 810.376a
Cext_3260 \$1247 \$1257 0.182933a
Cext_3261 \$1247 \$1267 254.864a
Cext_3262 \$1247 \$1278 5.60736a
Cext_3263 \$1247 \$1279 0.360462a
Cext_3264 \$1247 \$35 23.2117a
Cext_3265 \$1247 \$37 0.145978a
Cext_3266 \$1247 \$39 0.105966a
Cext_3267 \$1247 \$41 0.282145a
Cext_3268 \$1247 \$43 0.494517a
Cext_3269 \$1247 \$45 20.7622a
Cext_3270 \$1247 \$67 110.011a
Cext_3271 \$1247 VSS|vss 66.2132a
Cext_3272 \$1247 VSUBS 817.162a
Cext_3273 \$1248 \$1249 45.0654a
Cext_3274 \$1248 \$1268 130.128a
Cext_3275 \$1248 VDD|vdd 0.592094a
Cext_3276 \$1248 VSS|vss 25.1792a
Cext_3277 \$1248 VSUBS 659.267a
Cext_3278 \$1249 \$1250 45.0654a
Cext_3279 \$1249 \$1269 130.175a
Cext_3280 \$1249 VSS|vss 5.452a
Cext_3281 \$1249 VSUBS 634.529a
Cext_3282 \$125 \$145 254.77a
Cext_3283 \$125 \$175 0.360462a
Cext_3284 \$125 \$51 68.8031a
Cext_3285 \$125 \$83 73.9822a
Cext_3286 \$125 \$85 0.155901a
Cext_3287 \$125 VSS|vss 65.1705a
Cext_3288 \$125 VSUBS 800.515a
Cext_3289 \$1250 \$1251 45.0654a
Cext_3290 \$1250 \$1270 130.175a
Cext_3291 \$1250 VSUBS 634.529a
Cext_3292 \$1251 \$1252 45.8951a
Cext_3293 \$1251 \$1271 130.175a
Cext_3294 \$1251 VSS|vss 0.428128a
Cext_3295 \$1251 VSUBS 634.529a
Cext_3296 \$1252 \$1258 113.058a
Cext_3297 \$1252 \$1272 225.319a
Cext_3298 \$1252 \$51 22.6915a
Cext_3299 \$1252 \$83 105.489a
Cext_3300 \$1252 VSS|vss 61.1015a
Cext_3301 \$1252 VSUBS 793.257a
Cext_3302 \$1253 \$1258 0.182933a
Cext_3303 \$1253 \$1273 254.864a
Cext_3304 \$1253 \$1280 5.60736a
Cext_3305 \$1253 \$1281 0.360462a
Cext_3306 \$1253 \$51 23.2117a
Cext_3307 \$1253 \$53 0.145978a
Cext_3308 \$1253 \$55 0.105966a
Cext_3309 \$1253 \$57 0.282145a
Cext_3310 \$1253 \$59 0.494517a
Cext_3311 \$1253 \$61 20.7622a
Cext_3312 \$1253 \$83 110.011a
Cext_3313 \$1253 VSS|vss 66.2132a
Cext_3314 \$1253 VSUBS 817.162a
Cext_3315 \$1254 \$1259 113.058a
Cext_3316 \$1254 \$1274 225.319a
Cext_3317 \$1254 \$1309 5.04708a
Cext_3318 \$1254 \$51 22.6915a
Cext_3319 \$1254 \$53 0.404672a
Cext_3320 \$1254 \$57 0.115752a
Cext_3321 \$1254 \$59 0.481837a
Cext_3322 \$1254 \$61 20.8391a
Cext_3323 \$1254 \$83 105.489a
Cext_3324 \$1254 IOVDD|vdda 11.5102a
Cext_3325 \$1254 VSS|vss 60.9228a
Cext_3326 \$1254 VSUBS 810.376a
Cext_3327 \$1255 \$1259 0.182933a
Cext_3328 \$1255 \$1275 254.864a
Cext_3329 \$1255 \$1282 5.60736a
Cext_3330 \$1255 \$1283 0.360462a
Cext_3331 \$1255 \$51 23.2117a
Cext_3332 \$1255 \$53 0.145978a
Cext_3333 \$1255 \$55 0.105966a
Cext_3334 \$1255 \$57 0.282145a
Cext_3335 \$1255 \$59 0.494517a
Cext_3336 \$1255 \$61 20.7622a
Cext_3337 \$1255 \$83 110.011a
Cext_3338 \$1255 VSS|vss 75.4228a
Cext_3339 \$1255 VSUBS 817.162a
Cext_3340 \$1256 \$1264 102.889a
Cext_3341 \$1256 \$1276 11.9077a
Cext_3342 \$1256 \$1288 0.360462a
Cext_3343 \$1256 \$1304 42.153a
Cext_3344 \$1256 \$35 123.657a
Cext_3345 \$1256 \$37 65.5562a
Cext_3346 \$1256 \$43 0.62262a
Cext_3347 \$1256 \$67 80.1249a
Cext_3348 \$1256 \$69 70.7638a
Cext_3349 \$1256 \$71 31.3588a
Cext_3350 \$1256 \$73 32.5775a
Cext_3351 \$1256 \$75 39.7349a
Cext_3352 \$1256 \$77 45.8508a
Cext_3353 \$1256 VSS|vss 0.335662a
Cext_3354 \$1256 VSUBS 259.405a
Cext_3355 \$1257 \$1266 102.889a
Cext_3356 \$1257 \$1278 11.9077a
Cext_3357 \$1257 \$1291 0.360462a
Cext_3358 \$1257 \$1306 42.153a
Cext_3359 \$1257 \$35 123.51a
Cext_3360 \$1257 \$37 65.5562a
Cext_3361 \$1257 \$43 0.62262a
Cext_3362 \$1257 \$67 79.9778a
Cext_3363 \$1257 \$69 70.7638a
Cext_3364 \$1257 \$71 31.3588a
Cext_3365 \$1257 \$73 32.5775a
Cext_3366 \$1257 \$75 39.7349a
Cext_3367 \$1257 \$77 45.8508a
Cext_3368 \$1257 IOVDD|vdda 41.6223a
Cext_3369 \$1257 VSS|vss 0.335662a
Cext_3370 \$1257 VSUBS 259.131a
Cext_3371 \$1258 \$1272 102.889a
Cext_3372 \$1258 \$1280 11.9077a
Cext_3373 \$1258 \$1298 0.360462a
Cext_3374 \$1258 \$1308 42.153a
Cext_3375 \$1258 \$51 123.657a
Cext_3376 \$1258 \$53 65.5562a
Cext_3377 \$1258 \$59 0.62262a
Cext_3378 \$1258 \$83 80.1249a
Cext_3379 \$1258 \$85 70.7638a
Cext_3380 \$1258 \$87 31.3588a
Cext_3381 \$1258 \$89 32.5775a
Cext_3382 \$1258 \$91 39.7349a
Cext_3383 \$1258 \$93 45.8508a
Cext_3384 \$1258 VSS|vss 0.335662a
Cext_3385 \$1258 VSUBS 259.405a
Cext_3386 \$1259 \$1274 102.889a
Cext_3387 \$1259 \$1282 11.9077a
Cext_3388 \$1259 \$1301 0.360462a
Cext_3389 \$1259 \$1310 42.153a
Cext_3390 \$1259 \$51 123.51a
Cext_3391 \$1259 \$53 65.5562a
Cext_3392 \$1259 \$59 0.62262a
Cext_3393 \$1259 \$83 79.9778a
Cext_3394 \$1259 \$85 70.7638a
Cext_3395 \$1259 \$87 31.3588a
Cext_3396 \$1259 \$89 32.5775a
Cext_3397 \$1259 \$91 39.7349a
Cext_3398 \$1259 \$93 45.8508a
Cext_3399 \$1259 IOVDD|vdda 41.6223a
Cext_3400 \$1259 VSS|vss 3.903a
Cext_3401 \$1259 VSUBS 259.131a
Cext_3402 \$126 \$147 225.319a
Cext_3403 \$126 \$148 102.928a
Cext_3404 \$126 \$51 69.5346a
Cext_3405 \$126 \$53 0.283978a
Cext_3406 \$126 \$55 0.209713a
Cext_3407 \$126 \$57 0.276252a
Cext_3408 \$126 \$59 0.481837a
Cext_3409 \$126 \$61 20.8391a
Cext_3410 \$126 \$83 68.2327a
Cext_3411 \$126 \$85 0.679713a
Cext_3412 \$126 \$87 0.242834a
Cext_3413 \$126 \$89 0.182729a
Cext_3414 \$126 \$91 0.262546a
Cext_3415 \$126 \$93 0.172446a
Cext_3416 \$126 VSS|vss 59.9275a
Cext_3417 \$126 VSUBS 844.801a
Cext_3418 \$1260 \$1261 45.0654a
Cext_3419 \$1260 \$1284 130.175a
Cext_3420 \$1260 VDD|vdd 7.74075a
Cext_3421 \$1260 VSS|vss 1.71997a
Cext_3422 \$1260 VSUBS 659.267a
Cext_3423 \$1261 \$1262 45.0654a
Cext_3424 \$1261 \$1285 130.175a
Cext_3425 \$1261 VDD|vdd 0.968272a
Cext_3426 \$1261 VSUBS 634.529a
Cext_3427 \$1262 \$1263 45.0654a
Cext_3428 \$1262 \$1286 130.175a
Cext_3429 \$1262 VSUBS 634.529a
Cext_3430 \$1263 \$1264 46.4004a
Cext_3431 \$1263 \$1287 130.175a
Cext_3432 \$1263 VSS|vss 0.378729a
Cext_3433 \$1263 VSUBS 634.529a
Cext_3434 \$1264 \$1288 254.864a
Cext_3435 \$1264 \$1304 0.360462a
Cext_3436 \$1264 \$35 69.0342a
Cext_3437 \$1264 \$67 64.2241a
Cext_3438 \$1264 \$75 0.2003a
Cext_3439 \$1264 \$77 0.107779a
Cext_3440 \$1264 VSS|vss 66.2906a
Cext_3441 \$1264 VSUBS 801.371a
Cext_3442 \$1265 \$1276 5.04708a
Cext_3443 \$1265 \$1277 113.058a
Cext_3444 \$1265 \$1290 225.319a
Cext_3445 \$1265 \$35 68.7272a
Cext_3446 \$1265 \$41 0.115752a
Cext_3447 \$1265 \$43 0.481837a
Cext_3448 \$1265 \$45 20.9928a
Cext_3449 \$1265 \$67 58.9193a
Cext_3450 \$1265 \$75 0.343978a
Cext_3451 \$1265 VSS|vss 60.9228a
Cext_3452 \$1265 VSUBS 810.856a
Cext_3453 \$1266 \$1277 0.182933a
Cext_3454 \$1266 \$1291 254.864a
Cext_3455 \$1266 \$1305 5.60736a
Cext_3456 \$1266 \$1306 0.360462a
Cext_3457 \$1266 \$35 69.0342a
Cext_3458 \$1266 \$39 0.105966a
Cext_3459 \$1266 \$41 0.282145a
Cext_3460 \$1266 \$43 0.494517a
Cext_3461 \$1266 \$45 20.7622a
Cext_3462 \$1266 \$67 64.2241a
Cext_3463 \$1266 \$75 0.2003a
Cext_3464 \$1266 \$77 0.107779a
Cext_3465 \$1266 IOVDD|vdda 13.2807a
Cext_3466 \$1266 VSS|vss 66.2132a
Cext_3467 \$1266 VSUBS 818.905a
Cext_3468 \$1267 \$1278 5.04708a
Cext_3469 \$1267 \$1279 113.058a
Cext_3470 \$1267 \$1293 225.319a
Cext_3471 \$1267 \$35 68.7272a
Cext_3472 \$1267 \$41 0.115752a
Cext_3473 \$1267 \$43 0.481837a
Cext_3474 \$1267 \$45 20.9928a
Cext_3475 \$1267 \$67 58.9193a
Cext_3476 \$1267 \$75 0.343978a
Cext_3477 \$1267 VSS|vss 60.9228a
Cext_3478 \$1267 VSUBS 810.856a
Cext_3479 \$1268 \$1269 45.0654a
Cext_3480 \$1268 \$1294 130.128a
Cext_3481 \$1268 VDD|vdd 0.592094a
Cext_3482 \$1268 VSS|vss 25.1792a
Cext_3483 \$1268 VSUBS 659.267a
Cext_3484 \$1269 \$1270 45.0654a
Cext_3485 \$1269 \$1295 130.175a
Cext_3486 \$1269 VSS|vss 5.452a
Cext_3487 \$1269 VSUBS 634.529a
Cext_3488 \$127 \$128 114.006a
Cext_3489 \$127 \$149 254.864a
Cext_3490 \$127 \$178 0.360462a
Cext_3491 \$127 \$51 68.8031a
Cext_3492 \$127 \$53 0.177599a
Cext_3493 \$127 \$55 0.258003a
Cext_3494 \$127 \$57 0.405131a
Cext_3495 \$127 \$59 0.710075a
Cext_3496 \$127 \$61 21.0936a
Cext_3497 \$127 \$83 73.9822a
Cext_3498 \$127 \$85 0.155901a
Cext_3499 \$127 IOVDD|vdda 13.0646a
Cext_3500 \$127 VSS|vss 65.1705a
Cext_3501 \$127 VSUBS 819.437a
Cext_3502 \$1270 \$1271 45.0654a
Cext_3503 \$1270 \$1296 130.175a
Cext_3504 \$1270 VSUBS 634.529a
Cext_3505 \$1271 \$1272 46.4004a
Cext_3506 \$1271 \$1297 130.175a
Cext_3507 \$1271 VSS|vss 0.378729a
Cext_3508 \$1271 VSUBS 634.529a
Cext_3509 \$1272 \$1298 254.864a
Cext_3510 \$1272 \$1308 0.360462a
Cext_3511 \$1272 \$51 69.0342a
Cext_3512 \$1272 \$83 64.2241a
Cext_3513 \$1272 \$91 0.2003a
Cext_3514 \$1272 \$93 0.107779a
Cext_3515 \$1272 VSS|vss 66.2906a
Cext_3516 \$1272 VSUBS 801.371a
Cext_3517 \$1273 \$1280 5.04708a
Cext_3518 \$1273 \$1281 113.058a
Cext_3519 \$1273 \$1300 225.319a
Cext_3520 \$1273 \$51 68.7272a
Cext_3521 \$1273 \$57 0.115752a
Cext_3522 \$1273 \$59 0.481837a
Cext_3523 \$1273 \$61 20.9928a
Cext_3524 \$1273 \$83 58.9193a
Cext_3525 \$1273 \$91 0.343978a
Cext_3526 \$1273 VSS|vss 60.9228a
Cext_3527 \$1273 VSUBS 810.856a
Cext_3528 \$1274 \$1281 0.182933a
Cext_3529 \$1274 \$1301 254.864a
Cext_3530 \$1274 \$1309 5.60736a
Cext_3531 \$1274 \$1310 0.360462a
Cext_3532 \$1274 \$51 69.0342a
Cext_3533 \$1274 \$55 0.105966a
Cext_3534 \$1274 \$57 0.282145a
Cext_3535 \$1274 \$59 0.494517a
Cext_3536 \$1274 \$61 20.7622a
Cext_3537 \$1274 \$83 64.2241a
Cext_3538 \$1274 \$91 0.2003a
Cext_3539 \$1274 \$93 0.107779a
Cext_3540 \$1274 IOVDD|vdda 13.2807a
Cext_3541 \$1274 VSS|vss 66.2132a
Cext_3542 \$1274 VSUBS 818.905a
Cext_3543 \$1275 \$1282 5.04708a
Cext_3544 \$1275 \$1283 113.058a
Cext_3545 \$1275 \$1303 225.319a
Cext_3546 \$1275 \$51 68.7272a
Cext_3547 \$1275 \$57 0.115752a
Cext_3548 \$1275 \$59 0.481837a
Cext_3549 \$1275 \$61 20.9928a
Cext_3550 \$1275 \$83 58.9193a
Cext_3551 \$1275 \$91 0.343978a
Cext_3552 \$1275 VSS|vss 69.9251a
Cext_3553 \$1275 VSUBS 810.856a
Cext_3554 \$1276 \$1289 98.5952a
Cext_3555 \$1276 \$1304 0.227961a
Cext_3556 \$1276 \$35 0.621099a
Cext_3557 \$1276 \$37 467.302a
Cext_3558 \$1276 \$39 144.162a
Cext_3559 \$1276 \$41 76.1959a
Cext_3560 \$1276 \$43 87.5174a
Cext_3561 \$1276 \$45 73.2375a
Cext_3562 \$1276 \$67 1.47148a
Cext_3563 \$1276 \$69 86.3031a
Cext_3564 \$1276 \$71 25.0801a
Cext_3565 \$1276 \$73 18.1328a
Cext_3566 \$1276 \$75 63.9361a
Cext_3567 \$1276 \$77 0.92396a
Cext_3568 \$1276 \$886 371.403a
Cext_3569 \$1276 \$898 1.86362a
Cext_3570 \$1276 \$899 5.5583a
Cext_3571 \$1276 \$914 68.5912a
Cext_3572 \$1276 \$916 5.04708a
Cext_3573 \$1276 \$934 140.765a
Cext_3574 \$1276 \$947 5.60736a
Cext_3575 \$1276 \$962 15.5752a
Cext_3576 \$1276 \$980 5.04708a
Cext_3577 \$1276 \$984 439.985a
Cext_3578 \$1276 \$997 27.2011a
Cext_3579 \$1276 \$998 5.60736a
Cext_3580 \$1276 VSS|vss 0.88514a
Cext_3581 \$1276 VSUBS 877.443a
Cext_3582 \$1277 \$1290 102.889a
Cext_3583 \$1277 \$1305 11.9077a
Cext_3584 \$1277 \$1317 0.360462a
Cext_3585 \$1277 \$1333 42.153a
Cext_3586 \$1277 \$35 134.708a
Cext_3587 \$1277 \$37 19.3729a
Cext_3588 \$1277 \$43 1.18572a
Cext_3589 \$1277 \$67 69.937a
Cext_3590 \$1277 \$69 117.37a
Cext_3591 \$1277 \$71 31.3588a
Cext_3592 \$1277 \$73 32.5775a
Cext_3593 \$1277 \$75 37.9814a
Cext_3594 \$1277 \$77 45.8508a
Cext_3595 \$1277 VSS|vss 0.335662a
Cext_3596 \$1277 VSUBS 259.376a
Cext_3597 \$1278 \$1292 98.5952a
Cext_3598 \$1278 \$1306 0.227961a
Cext_3599 \$1278 \$35 0.496879a
Cext_3600 \$1278 \$37 467.302a
Cext_3601 \$1278 \$39 144.162a
Cext_3602 \$1278 \$41 76.1224a
Cext_3603 \$1278 \$43 87.4727a
Cext_3604 \$1278 \$45 73.1186a
Cext_3605 \$1278 \$67 1.47148a
Cext_3606 \$1278 \$69 86.191a
Cext_3607 \$1278 \$71 24.9962a
Cext_3608 \$1278 \$73 18.0464a
Cext_3609 \$1278 \$75 63.8448a
Cext_3610 \$1278 \$77 0.769967a
Cext_3611 \$1278 \$886 42.2305a
Cext_3612 \$1278 \$888 257.409a
Cext_3613 \$1278 \$900 1.86362a
Cext_3614 \$1278 \$901 5.5583a
Cext_3615 \$1278 \$917 37.4007a
Cext_3616 \$1278 \$918 68.5912a
Cext_3617 \$1278 \$920 5.04708a
Cext_3618 \$1278 \$936 140.765a
Cext_3619 \$1278 \$949 5.60736a
Cext_3620 \$1278 \$964 15.5752a
Cext_3621 \$1278 \$981 5.04708a
Cext_3622 \$1278 \$986 439.985a
Cext_3623 \$1278 IOVDD|vdda 11.2787a
Cext_3624 \$1278 VSS|vss 0.774497a
Cext_3625 \$1278 VSUBS 877.092a
Cext_3626 \$1279 \$1293 102.889a
Cext_3627 \$1279 \$1307 11.9077a
Cext_3628 \$1279 \$1320 0.360462a
Cext_3629 \$1279 \$1335 42.153a
Cext_3630 \$1279 \$35 134.708a
Cext_3631 \$1279 \$37 19.3729a
Cext_3632 \$1279 \$43 1.18572a
Cext_3633 \$1279 \$67 69.937a
Cext_3634 \$1279 \$69 117.37a
Cext_3635 \$1279 \$71 31.3588a
Cext_3636 \$1279 \$73 32.5775a
Cext_3637 \$1279 \$75 37.9814a
Cext_3638 \$1279 \$77 45.8508a
Cext_3639 \$1279 VREF|vref 0.182933a
Cext_3640 \$1279 VSS|vss 0.335662a
Cext_3641 \$1279 VSUBS 259.376a
Cext_3642 \$128 \$129 0.709993a
Cext_3643 \$128 \$149 0.360462a
Cext_3644 \$128 \$150 98.5952a
Cext_3645 \$128 \$178 108.267a
Cext_3646 \$128 \$51 136.623a
Cext_3647 \$128 \$53 20.1129a
Cext_3648 \$128 \$55 0.556279a
Cext_3649 \$128 \$57 0.342825a
Cext_3650 \$128 \$59 0.112844a
Cext_3651 \$128 \$83 74.9602a
Cext_3652 \$128 \$85 120.408a
Cext_3653 \$128 \$87 33.5711a
Cext_3654 \$128 \$89 34.6074a
Cext_3655 \$128 \$91 37.5367a
Cext_3656 \$128 \$93 46.2298a
Cext_3657 \$128 IOVDD|vdda 40.9857a
Cext_3658 \$128 VSS|vss 5.56679a
Cext_3659 \$128 VSUBS 324.405a
Cext_3660 \$1280 \$1299 98.5952a
Cext_3661 \$1280 \$1308 0.227961a
Cext_3662 \$1280 \$51 0.621099a
Cext_3663 \$1280 \$53 467.302a
Cext_3664 \$1280 \$55 144.162a
Cext_3665 \$1280 \$57 76.1959a
Cext_3666 \$1280 \$59 87.5174a
Cext_3667 \$1280 \$61 73.2375a
Cext_3668 \$1280 \$83 1.47148a
Cext_3669 \$1280 \$85 86.3031a
Cext_3670 \$1280 \$87 25.0801a
Cext_3671 \$1280 \$89 18.1328a
Cext_3672 \$1280 \$890 371.403a
Cext_3673 \$1280 \$906 1.86362a
Cext_3674 \$1280 \$907 5.5583a
Cext_3675 \$1280 \$91 63.9361a
Cext_3676 \$1280 \$927 68.5912a
Cext_3677 \$1280 \$928 5.04708a
Cext_3678 \$1280 \$93 0.92396a
Cext_3679 \$1280 \$938 140.765a
Cext_3680 \$1280 \$955 5.60736a
Cext_3681 \$1280 \$970 15.5752a
Cext_3682 \$1280 \$972 5.04708a
Cext_3683 \$1280 \$988 439.985a
Cext_3684 \$1280 VSS|vss 0.88514a
Cext_3685 \$1280 VSUBS 877.443a
Cext_3686 \$1281 \$1300 102.889a
Cext_3687 \$1281 \$1309 11.9077a
Cext_3688 \$1281 \$1327 0.360462a
Cext_3689 \$1281 \$1337 42.153a
Cext_3690 \$1281 \$51 134.708a
Cext_3691 \$1281 \$53 19.3729a
Cext_3692 \$1281 \$59 1.18572a
Cext_3693 \$1281 \$83 69.937a
Cext_3694 \$1281 \$85 117.37a
Cext_3695 \$1281 \$87 31.3588a
Cext_3696 \$1281 \$89 32.5775a
Cext_3697 \$1281 \$91 37.9814a
Cext_3698 \$1281 \$93 45.8508a
Cext_3699 \$1281 VSS|vss 0.335662a
Cext_3700 \$1281 VSUBS 259.376a
Cext_3701 \$1282 \$1302 98.5952a
Cext_3702 \$1282 \$1310 0.227961a
Cext_3703 \$1282 \$51 0.496879a
Cext_3704 \$1282 \$53 467.302a
Cext_3705 \$1282 \$55 144.162a
Cext_3706 \$1282 \$57 76.1224a
Cext_3707 \$1282 \$59 87.4727a
Cext_3708 \$1282 \$61 73.1186a
Cext_3709 \$1282 \$83 1.47148a
Cext_3710 \$1282 \$85 86.191a
Cext_3711 \$1282 \$87 24.9962a
Cext_3712 \$1282 \$89 18.0464a
Cext_3713 \$1282 \$890 42.2305a
Cext_3714 \$1282 \$892 257.409a
Cext_3715 \$1282 \$908 1.86362a
Cext_3716 \$1282 \$909 5.5583a
Cext_3717 \$1282 \$91 63.8448a
Cext_3718 \$1282 \$929 37.4007a
Cext_3719 \$1282 \$93 0.769967a
Cext_3720 \$1282 \$931 68.5912a
Cext_3721 \$1282 \$932 5.04708a
Cext_3722 \$1282 \$940 140.765a
Cext_3723 \$1282 \$957 5.60736a
Cext_3724 \$1282 \$974 15.5752a
Cext_3725 \$1282 \$976 5.04708a
Cext_3726 \$1282 \$990 439.985a
Cext_3727 \$1282 IOVDD|vdda 11.2787a
Cext_3728 \$1282 VSS|vss 160.07a
Cext_3729 \$1282 VSUBS 877.092a
Cext_3730 \$1283 \$1303 102.889a
Cext_3731 \$1283 \$1311 11.9077a
Cext_3732 \$1283 \$1330 0.360462a
Cext_3733 \$1283 \$1339 42.153a
Cext_3734 \$1283 \$51 134.708a
Cext_3735 \$1283 \$53 19.3729a
Cext_3736 \$1283 \$59 1.18572a
Cext_3737 \$1283 \$83 69.937a
Cext_3738 \$1283 \$85 117.37a
Cext_3739 \$1283 \$87 31.3588a
Cext_3740 \$1283 \$89 32.5775a
Cext_3741 \$1283 \$91 37.9814a
Cext_3742 \$1283 \$93 45.8508a
Cext_3743 \$1283 VREF|vref 0.182933a
Cext_3744 \$1283 VSS|vss 0.335662a
Cext_3745 \$1283 VSUBS 259.376a
Cext_3746 \$1284 \$1285 45.0654a
Cext_3747 \$1284 \$1312 130.175a
Cext_3748 \$1284 VDD|vdd 7.74075a
Cext_3749 \$1284 VSS|vss 1.71997a
Cext_3750 \$1284 VSUBS 659.267a
Cext_3751 \$1285 \$1286 45.0654a
Cext_3752 \$1285 \$1313 130.175a
Cext_3753 \$1285 VDD|vdd 0.968272a
Cext_3754 \$1285 VSUBS 634.529a
Cext_3755 \$1286 \$1287 45.0654a
Cext_3756 \$1286 \$1314 130.175a
Cext_3757 \$1286 VSUBS 634.529a
Cext_3758 \$1287 \$1288 45.8951a
Cext_3759 \$1287 \$1315 130.175a
Cext_3760 \$1287 VSS|vss 0.428128a
Cext_3761 \$1287 VSUBS 634.529a
Cext_3762 \$1288 \$1289 2.00331a
Cext_3763 \$1288 \$1304 102.889a
Cext_3764 \$1288 \$1316 225.319a
Cext_3765 \$1288 \$35 22.8071a
Cext_3766 \$1288 \$67 105.694a
Cext_3767 \$1288 VSS|vss 61.1015a
Cext_3768 \$1288 VSUBS 794.296a
Cext_3769 \$1289 \$1290 4.9228a
Cext_3770 \$1289 \$1304 77.0039a
Cext_3771 \$1289 \$1317 4.41896a
Cext_3772 \$1289 \$1332 226.002a
Cext_3773 \$1289 \$1345 4.94574a
Cext_3774 \$1289 \$1356 19.1082a
Cext_3775 \$1289 \$1369 4.41896a
Cext_3776 \$1289 \$1380 1.5569f
Cext_3777 \$1289 \$1393 31.6191a
Cext_3778 \$1289 \$1394 4.94574a
Cext_3779 \$1289 \$1408 16.6785a
Cext_3780 \$1289 \$1421 4.41896a
Cext_3781 \$1289 \$1444 4.94574a
Cext_3782 \$1289 \$1456 16.7925a
Cext_3783 \$1289 \$1465 4.41896a
Cext_3784 \$1289 \$1481 99.1454a
Cext_3785 \$1289 \$1500 0.250757a
Cext_3786 \$1289 \$35 0.604961a
Cext_3787 \$1289 \$37 159.637a
Cext_3788 \$1289 \$39 45.965a
Cext_3789 \$1289 \$41 66.3225a
Cext_3790 \$1289 \$43 59.1797a
Cext_3791 \$1289 \$45 6.75111a
Cext_3792 \$1289 \$67 1.69277a
Cext_3793 \$1289 \$69 76.5245a
Cext_3794 \$1289 \$71 20.8844a
Cext_3795 \$1289 \$73 64.7697a
Cext_3796 \$1289 \$75 2.44188a
Cext_3797 \$1289 \$77 0.959093a
Cext_3798 \$1289 VSUBS 505.962a
Cext_3799 \$129 \$151 102.928a
Cext_3800 \$129 \$152 225.319a
Cext_3801 \$129 \$51 69.5346a
Cext_3802 \$129 \$53 0.283978a
Cext_3803 \$129 \$55 0.209713a
Cext_3804 \$129 \$57 0.276252a
Cext_3805 \$129 \$59 0.481837a
Cext_3806 \$129 \$61 20.8391a
Cext_3807 \$129 \$83 68.2327a
Cext_3808 \$129 \$85 0.679713a
Cext_3809 \$129 \$87 0.242834a
Cext_3810 \$129 \$89 0.182729a
Cext_3811 \$129 \$91 0.262546a
Cext_3812 \$129 \$93 0.172446a
Cext_3813 \$129 VSS|vss 68.9298a
Cext_3814 \$129 VSUBS 844.801a
Cext_3815 \$1290 \$1317 254.864a
Cext_3816 \$1290 \$1333 0.360462a
Cext_3817 \$1290 \$35 23.4429a
Cext_3818 \$1290 \$39 0.105966a
Cext_3819 \$1290 \$41 0.282145a
Cext_3820 \$1290 \$43 0.640494a
Cext_3821 \$1290 \$45 20.9159a
Cext_3822 \$1290 \$67 110.113a
Cext_3823 \$1290 \$77 0.107779a
Cext_3824 \$1290 VSS|vss 66.2132a
Cext_3825 \$1290 VSUBS 818.851a
Cext_3826 \$1291 \$1292 2.00331a
Cext_3827 \$1291 \$1305 5.04708a
Cext_3828 \$1291 \$1306 102.889a
Cext_3829 \$1291 \$1319 225.319a
Cext_3830 \$1291 \$35 22.8071a
Cext_3831 \$1291 \$41 0.115752a
Cext_3832 \$1291 \$43 1.32073a
Cext_3833 \$1291 \$45 20.9928a
Cext_3834 \$1291 \$67 105.694a
Cext_3835 \$1291 IOVDD|vdda 11.6291a
Cext_3836 \$1291 VSS|vss 60.9228a
Cext_3837 \$1291 VSUBS 810.735a
Cext_3838 \$1292 \$1293 4.9228a
Cext_3839 \$1292 \$1306 77.0039a
Cext_3840 \$1292 \$1320 4.41896a
Cext_3841 \$1292 \$1334 226.002a
Cext_3842 \$1292 \$1347 4.94574a
Cext_3843 \$1292 \$1358 19.1082a
Cext_3844 \$1292 \$1371 4.41896a
Cext_3845 \$1292 \$1382 1.5569f
Cext_3846 \$1292 \$1396 31.6191a
Cext_3847 \$1292 \$1397 4.94574a
Cext_3848 \$1292 \$1410 16.6785a
Cext_3849 \$1292 \$1424 4.41896a
Cext_3850 \$1292 \$1446 4.94574a
Cext_3851 \$1292 \$1457 16.7925a
Cext_3852 \$1292 \$1467 4.41896a
Cext_3853 \$1292 \$1485 99.1454a
Cext_3854 \$1292 \$1501 0.250757a
Cext_3855 \$1292 \$35 0.604961a
Cext_3856 \$1292 \$37 159.637a
Cext_3857 \$1292 \$39 45.965a
Cext_3858 \$1292 \$41 66.3225a
Cext_3859 \$1292 \$43 59.1797a
Cext_3860 \$1292 \$45 6.75111a
Cext_3861 \$1292 \$67 1.69277a
Cext_3862 \$1292 \$69 76.5245a
Cext_3863 \$1292 \$71 20.8844a
Cext_3864 \$1292 \$73 64.7697a
Cext_3865 \$1292 \$75 2.44188a
Cext_3866 \$1292 \$77 0.959093a
Cext_3867 \$1292 IOVDD|vdda 10.9581a
Cext_3868 \$1292 VSUBS 505.962a
Cext_3869 \$1293 \$1320 254.864a
Cext_3870 \$1293 \$1335 0.360462a
Cext_3871 \$1293 \$35 23.4429a
Cext_3872 \$1293 \$39 0.105966a
Cext_3873 \$1293 \$41 0.282145a
Cext_3874 \$1293 \$43 0.640494a
Cext_3875 \$1293 \$45 20.9159a
Cext_3876 \$1293 \$67 110.113a
Cext_3877 \$1293 \$77 0.107779a
Cext_3878 \$1293 VSS|vss 66.2132a
Cext_3879 \$1293 VSUBS 818.851a
Cext_3880 \$1294 \$1295 45.0654a
Cext_3881 \$1294 \$1322 130.128a
Cext_3882 \$1294 VDD|vdd 0.592094a
Cext_3883 \$1294 VSS|vss 25.1792a
Cext_3884 \$1294 VSUBS 659.267a
Cext_3885 \$1295 \$1296 45.0654a
Cext_3886 \$1295 \$1323 130.175a
Cext_3887 \$1295 VSS|vss 5.452a
Cext_3888 \$1295 VSUBS 634.529a
Cext_3889 \$1296 \$1297 45.0654a
Cext_3890 \$1296 \$1324 130.175a
Cext_3891 \$1296 VSUBS 634.529a
Cext_3892 \$1297 \$1298 45.8951a
Cext_3893 \$1297 \$1325 130.175a
Cext_3894 \$1297 VSS|vss 0.428128a
Cext_3895 \$1297 VSUBS 634.529a
Cext_3896 \$1298 \$1299 2.00331a
Cext_3897 \$1298 \$1308 102.889a
Cext_3898 \$1298 \$1326 225.319a
Cext_3899 \$1298 \$51 22.8071a
Cext_3900 \$1298 \$83 105.694a
Cext_3901 \$1298 VSS|vss 61.1015a
Cext_3902 \$1298 VSUBS 794.296a
Cext_3903 \$1299 \$1300 4.9228a
Cext_3904 \$1299 \$1308 77.0039a
Cext_3905 \$1299 \$1327 4.41896a
Cext_3906 \$1299 \$1336 226.002a
Cext_3907 \$1299 \$1353 4.94574a
Cext_3908 \$1299 \$1360 19.1082a
Cext_3909 \$1299 \$1377 4.41896a
Cext_3910 \$1299 \$1384 1.5569f
Cext_3911 \$1299 \$1403 31.6191a
Cext_3912 \$1299 \$1404 4.94574a
Cext_3913 \$1299 \$1412 16.6785a
Cext_3914 \$1299 \$1431 4.41896a
Cext_3915 \$1299 \$1452 4.94574a
Cext_3916 \$1299 \$1458 16.7925a
Cext_3917 \$1299 \$1473 4.41896a
Cext_3918 \$1299 \$1493 99.1454a
Cext_3919 \$1299 \$1502 0.250757a
Cext_3920 \$1299 \$51 0.604961a
Cext_3921 \$1299 \$53 159.637a
Cext_3922 \$1299 \$55 45.965a
Cext_3923 \$1299 \$57 66.3225a
Cext_3924 \$1299 \$59 59.1797a
Cext_3925 \$1299 \$61 6.75111a
Cext_3926 \$1299 \$83 1.69277a
Cext_3927 \$1299 \$85 76.5245a
Cext_3928 \$1299 \$87 20.8844a
Cext_3929 \$1299 \$89 64.7697a
Cext_3930 \$1299 \$91 2.44188a
Cext_3931 \$1299 \$93 0.959093a
Cext_3932 \$1299 VSUBS 505.962a
Cext_3933 \$130 \$153 130.175a
Cext_3934 \$130 \$53 0.177599a
Cext_3935 \$130 \$55 0.258003a
Cext_3936 \$130 \$57 0.405131a
Cext_3937 \$130 \$59 0.710075a
Cext_3938 \$130 \$61 21.1432a
Cext_3939 \$130 \$83 7.56443a
Cext_3940 \$130 VSS|vss 2.2008a
Cext_3941 \$130 VSUBS 676a
Cext_3942 \$1300 \$1327 254.864a
Cext_3943 \$1300 \$1337 0.360462a
Cext_3944 \$1300 \$51 23.4429a
Cext_3945 \$1300 \$55 0.105966a
Cext_3946 \$1300 \$57 0.282145a
Cext_3947 \$1300 \$59 0.640494a
Cext_3948 \$1300 \$61 20.9159a
Cext_3949 \$1300 \$83 110.113a
Cext_3950 \$1300 \$93 0.107779a
Cext_3951 \$1300 VSS|vss 66.2132a
Cext_3952 \$1300 VSUBS 818.851a
Cext_3953 \$1301 \$1302 2.00331a
Cext_3954 \$1301 \$1309 5.04708a
Cext_3955 \$1301 \$1310 102.889a
Cext_3956 \$1301 \$1329 225.319a
Cext_3957 \$1301 \$51 22.8071a
Cext_3958 \$1301 \$57 0.115752a
Cext_3959 \$1301 \$59 1.32073a
Cext_3960 \$1301 \$61 20.9928a
Cext_3961 \$1301 \$83 105.694a
Cext_3962 \$1301 IOVDD|vdda 11.6291a
Cext_3963 \$1301 VSS|vss 60.9228a
Cext_3964 \$1301 VSUBS 810.735a
Cext_3965 \$1302 \$1303 4.9228a
Cext_3966 \$1302 \$1310 77.0039a
Cext_3967 \$1302 \$1330 4.41896a
Cext_3968 \$1302 \$1338 226.002a
Cext_3969 \$1302 \$1355 4.94574a
Cext_3970 \$1302 \$1362 19.1082a
Cext_3971 \$1302 \$1379 4.41896a
Cext_3972 \$1302 \$1386 1.5569f
Cext_3973 \$1302 \$1406 31.6191a
Cext_3974 \$1302 \$1407 4.94574a
Cext_3975 \$1302 \$1414 16.6785a
Cext_3976 \$1302 \$1434 4.41896a
Cext_3977 \$1302 \$1454 4.94574a
Cext_3978 \$1302 \$1459 16.7925a
Cext_3979 \$1302 \$1475 4.41896a
Cext_3980 \$1302 \$1497 99.1454a
Cext_3981 \$1302 \$1503 0.250757a
Cext_3982 \$1302 \$51 0.604961a
Cext_3983 \$1302 \$53 159.637a
Cext_3984 \$1302 \$55 45.965a
Cext_3985 \$1302 \$57 66.3225a
Cext_3986 \$1302 \$59 59.1797a
Cext_3987 \$1302 \$61 6.75111a
Cext_3988 \$1302 \$83 1.69277a
Cext_3989 \$1302 \$85 76.5245a
Cext_3990 \$1302 \$87 20.8844a
Cext_3991 \$1302 \$89 64.7697a
Cext_3992 \$1302 \$91 2.44188a
Cext_3993 \$1302 \$93 0.959093a
Cext_3994 \$1302 IOVDD|vdda 10.9581a
Cext_3995 \$1302 VSS|vss 70.4812a
Cext_3996 \$1302 VSUBS 505.962a
Cext_3997 \$1303 \$1330 254.864a
Cext_3998 \$1303 \$1339 0.360462a
Cext_3999 \$1303 \$51 23.4429a
Cext_4000 \$1303 \$55 0.105966a
Cext_4001 \$1303 \$57 0.282145a
Cext_4002 \$1303 \$59 0.640494a
Cext_4003 \$1303 \$61 20.9159a
Cext_4004 \$1303 \$83 110.113a
Cext_4005 \$1303 \$93 0.107779a
Cext_4006 \$1303 VSS|vss 75.3227a
Cext_4007 \$1303 VSUBS 818.851a
Cext_4008 \$1304 \$1316 114.006a
Cext_4009 \$1304 \$1317 0.182933a
Cext_4010 \$1304 \$1332 98.5952a
Cext_4011 \$1304 \$1344 0.360462a
Cext_4012 \$1304 \$1356 108.267a
Cext_4013 \$1304 \$35 134.708a
Cext_4014 \$1304 \$37 19.3729a
Cext_4015 \$1304 \$43 1.32172a
Cext_4016 \$1304 \$67 69.9941a
Cext_4017 \$1304 \$69 117.37a
Cext_4018 \$1304 \$71 31.3588a
Cext_4019 \$1304 \$73 32.5775a
Cext_4020 \$1304 \$75 37.9814a
Cext_4021 \$1304 \$77 45.7852a
Cext_4022 \$1304 VSS|vss 0.378848a
Cext_4023 \$1304 VSUBS 259.29a
Cext_4024 \$1305 \$1318 98.5952a
Cext_4025 \$1305 \$1333 0.227961a
Cext_4026 \$1305 \$35 2.17385a
Cext_4027 \$1305 \$37 470.75a
Cext_4028 \$1305 \$39 150.081a
Cext_4029 \$1305 \$41 84.9076a
Cext_4030 \$1305 \$43 105.656a
Cext_4031 \$1305 \$45 24.9829a
Cext_4032 \$1305 \$69 81.8461a
Cext_4033 \$1305 \$71 18.0277a
Cext_4034 \$1305 \$73 7.9638a
Cext_4035 \$1305 \$75 48.4427a
Cext_4036 \$1305 \$77 49.139a
Cext_4037 \$1305 \$886 37.8111a
Cext_4038 \$1305 \$916 1.86362a
Cext_4039 \$1305 \$917 313.089a
Cext_4040 \$1305 \$919 5.5583a
Cext_4041 \$1305 \$935 68.5912a
Cext_4042 \$1305 \$948 5.04708a
Cext_4043 \$1305 \$963 140.765a
Cext_4044 \$1305 \$965 5.60736a
Cext_4045 \$1305 \$985 15.5752a
Cext_4046 \$1305 \$999 5.04708a
Cext_4047 \$1305 VSS|vss 0.774497a
Cext_4048 \$1305 VSUBS 879.339a
Cext_4049 \$1306 \$1319 114.006a
Cext_4050 \$1306 \$1320 0.182933a
Cext_4051 \$1306 \$1334 98.5952a
Cext_4052 \$1306 \$1346 0.360462a
Cext_4053 \$1306 \$1358 108.267a
Cext_4054 \$1306 \$35 134.561a
Cext_4055 \$1306 \$37 19.3729a
Cext_4056 \$1306 \$43 1.32172a
Cext_4057 \$1306 \$67 69.8469a
Cext_4058 \$1306 \$69 117.37a
Cext_4059 \$1306 \$71 31.3588a
Cext_4060 \$1306 \$73 32.5775a
Cext_4061 \$1306 \$75 37.9814a
Cext_4062 \$1306 \$77 45.7852a
Cext_4063 \$1306 IOVDD|vdda 41.6693a
Cext_4064 \$1306 VSS|vss 0.378848a
Cext_4065 \$1306 VSUBS 259.016a
Cext_4066 \$1307 \$1321 98.5952a
Cext_4067 \$1307 \$1335 0.227961a
Cext_4068 \$1307 \$35 2.17385a
Cext_4069 \$1307 \$37 471.589a
Cext_4070 \$1307 \$39 150.394a
Cext_4071 \$1307 \$41 85.5942a
Cext_4072 \$1307 \$43 106.074a
Cext_4073 \$1307 \$45 26.6874a
Cext_4074 \$1307 \$69 83.7357a
Cext_4075 \$1307 \$71 18.0277a
Cext_4076 \$1307 \$73 7.9638a
Cext_4077 \$1307 \$75 48.4427a
Cext_4078 \$1307 \$77 49.139a
Cext_4079 \$1307 \$886 37.7146a
Cext_4080 \$1307 \$888 39.4453a
Cext_4081 \$1307 \$917 37.3042a
Cext_4082 \$1307 \$920 1.86362a
Cext_4083 \$1307 \$921 199.41a
Cext_4084 \$1307 \$937 68.5912a
Cext_4085 \$1307 \$966 140.638a
Cext_4086 \$1307 \$987 15.5752a
Cext_4087 \$1307 VREF|vref 359.861a
Cext_4088 \$1307 VSUBS 691.37a
Cext_4089 \$1308 \$1326 114.006a
Cext_4090 \$1308 \$1327 0.182933a
Cext_4091 \$1308 \$1336 98.5952a
Cext_4092 \$1308 \$1352 0.360462a
Cext_4093 \$1308 \$1360 108.267a
Cext_4094 \$1308 \$51 134.708a
Cext_4095 \$1308 \$53 19.3729a
Cext_4096 \$1308 \$59 1.32172a
Cext_4097 \$1308 \$83 69.9941a
Cext_4098 \$1308 \$85 117.37a
Cext_4099 \$1308 \$87 31.3588a
Cext_4100 \$1308 \$89 32.5775a
Cext_4101 \$1308 \$91 37.9814a
Cext_4102 \$1308 \$93 45.7852a
Cext_4103 \$1308 VSS|vss 0.378848a
Cext_4104 \$1308 VSUBS 259.29a
Cext_4105 \$1309 \$1328 98.5952a
Cext_4106 \$1309 \$1337 0.227961a
Cext_4107 \$1309 \$51 2.17385a
Cext_4108 \$1309 \$53 470.75a
Cext_4109 \$1309 \$55 150.081a
Cext_4110 \$1309 \$57 84.9076a
Cext_4111 \$1309 \$59 105.656a
Cext_4112 \$1309 \$61 24.9829a
Cext_4113 \$1309 \$85 81.8461a
Cext_4114 \$1309 \$87 18.0277a
Cext_4115 \$1309 \$89 7.9638a
Cext_4116 \$1309 \$890 37.8111a
Cext_4117 \$1309 \$91 48.4427a
Cext_4118 \$1309 \$928 1.86362a
Cext_4119 \$1309 \$929 313.089a
Cext_4120 \$1309 \$93 49.139a
Cext_4121 \$1309 \$930 5.5583a
Cext_4122 \$1309 \$939 68.5912a
Cext_4123 \$1309 \$956 5.04708a
Cext_4124 \$1309 \$973 140.765a
Cext_4125 \$1309 \$975 5.60736a
Cext_4126 \$1309 \$989 15.5752a
Cext_4127 \$1309 VSS|vss 0.774497a
Cext_4128 \$1309 VSUBS 879.339a
Cext_4129 \$131 \$132 45.0654a
Cext_4130 \$131 \$155 45.0654a
Cext_4131 \$131 \$159 130.175a
Cext_4132 \$131 \$67 4.40063a
Cext_4133 \$131 VSUBS 634.529a
Cext_4134 \$1310 \$1329 114.006a
Cext_4135 \$1310 \$1330 0.182933a
Cext_4136 \$1310 \$1338 98.5952a
Cext_4137 \$1310 \$1354 0.360462a
Cext_4138 \$1310 \$1362 108.267a
Cext_4139 \$1310 \$51 134.561a
Cext_4140 \$1310 \$53 19.3729a
Cext_4141 \$1310 \$59 1.32172a
Cext_4142 \$1310 \$83 69.8469a
Cext_4143 \$1310 \$85 117.37a
Cext_4144 \$1310 \$87 31.3588a
Cext_4145 \$1310 \$89 32.5775a
Cext_4146 \$1310 \$91 37.9814a
Cext_4147 \$1310 \$93 45.7852a
Cext_4148 \$1310 IOVDD|vdda 41.6693a
Cext_4149 \$1310 VSS|vss 4.23237a
Cext_4150 \$1310 VSUBS 259.016a
Cext_4151 \$1311 \$1331 98.5952a
Cext_4152 \$1311 \$1339 0.227961a
Cext_4153 \$1311 \$51 2.17385a
Cext_4154 \$1311 \$53 471.589a
Cext_4155 \$1311 \$55 150.394a
Cext_4156 \$1311 \$57 85.5942a
Cext_4157 \$1311 \$59 106.074a
Cext_4158 \$1311 \$61 26.6874a
Cext_4159 \$1311 \$85 83.7357a
Cext_4160 \$1311 \$87 18.0277a
Cext_4161 \$1311 \$89 7.9638a
Cext_4162 \$1311 \$890 37.7146a
Cext_4163 \$1311 \$892 39.4453a
Cext_4164 \$1311 \$91 48.4427a
Cext_4165 \$1311 \$929 37.3042a
Cext_4166 \$1311 \$93 49.139a
Cext_4167 \$1311 \$932 1.86362a
Cext_4168 \$1311 \$933 199.41a
Cext_4169 \$1311 \$941 68.5912a
Cext_4170 \$1311 \$977 140.638a
Cext_4171 \$1311 \$991 15.5752a
Cext_4172 \$1311 VREF|vref 359.861a
Cext_4173 \$1311 VSUBS 691.37a
Cext_4174 \$1312 \$1313 45.0654a
Cext_4175 \$1312 \$1340 130.175a
Cext_4176 \$1312 VDD|vdd 7.74075a
Cext_4177 \$1312 VSS|vss 1.71997a
Cext_4178 \$1312 VSUBS 659.267a
Cext_4179 \$1313 \$1314 45.0654a
Cext_4180 \$1313 \$1341 130.175a
Cext_4181 \$1313 VDD|vdd 0.968272a
Cext_4182 \$1313 VSUBS 634.529a
Cext_4183 \$1314 \$1315 45.0654a
Cext_4184 \$1314 \$1342 130.175a
Cext_4185 \$1314 VSUBS 634.529a
Cext_4186 \$1315 \$1316 46.4004a
Cext_4187 \$1315 \$1343 130.175a
Cext_4188 \$1315 VSS|vss 0.378729a
Cext_4189 \$1315 VSUBS 634.529a
Cext_4190 \$1316 \$1344 254.864a
Cext_4191 \$1316 \$1356 0.360462a
Cext_4192 \$1316 \$35 68.8031a
Cext_4193 \$1316 \$67 64.1221a
Cext_4194 \$1316 \$69 0.155901a
Cext_4195 \$1316 VSS|vss 66.2906a
Cext_4196 \$1316 VSUBS 799.746a
Cext_4197 \$1317 \$1318 2.00331a
Cext_4198 \$1317 \$1333 102.889a
Cext_4199 \$1317 \$1345 225.319a
Cext_4200 \$1317 \$35 68.8428a
Cext_4201 \$1317 \$41 0.115752a
Cext_4202 \$1317 \$43 0.481837a
Cext_4203 \$1317 \$45 20.8391a
Cext_4204 \$1317 \$67 59.1234a
Cext_4205 \$1317 \$69 0.343978a
Cext_4206 \$1317 VSS|vss 60.9228a
Cext_4207 \$1317 VSUBS 811.895a
Cext_4208 \$1318 \$1319 4.9228a
Cext_4209 \$1318 \$1333 77.0039a
Cext_4210 \$1318 \$1346 4.41896a
Cext_4211 \$1318 \$1357 226.002a
Cext_4212 \$1318 \$1370 4.94574a
Cext_4213 \$1318 \$1381 19.1082a
Cext_4214 \$1318 \$1395 4.41896a
Cext_4215 \$1318 \$1409 1.5569f
Cext_4216 \$1318 \$1422 31.6191a
Cext_4217 \$1318 \$1423 4.94574a
Cext_4218 \$1318 \$1436 16.6785a
Cext_4219 \$1318 \$1445 4.41896a
Cext_4220 \$1318 \$1466 4.94574a
Cext_4221 \$1318 \$1482 16.7925a
Cext_4222 \$1318 \$1484 4.41896a
Cext_4223 \$1318 \$1510 99.1454a
Cext_4224 \$1318 \$1525 0.250757a
Cext_4225 \$1318 \$35 2.39761a
Cext_4226 \$1318 \$37 164.064a
Cext_4227 \$1318 \$39 52.9648a
Cext_4228 \$1318 \$41 84.2145a
Cext_4229 \$1318 \$43 13.1371a
Cext_4230 \$1318 \$45 6.75111a
Cext_4231 \$1318 \$69 71.1976a
Cext_4232 \$1318 \$71 12.4538a
Cext_4233 \$1318 \$73 47.9782a
Cext_4234 \$1318 \$75 48.4845a
Cext_4235 \$1318 \$77 0.959093a
Cext_4236 \$1318 VSUBS 507.242a
Cext_4237 \$1319 \$1346 254.864a
Cext_4238 \$1319 \$1358 0.360462a
Cext_4239 \$1319 \$35 68.8031a
Cext_4240 \$1319 \$39 0.105966a
Cext_4241 \$1319 \$41 0.282145a
Cext_4242 \$1319 \$43 0.494517a
Cext_4243 \$1319 \$45 20.9159a
Cext_4244 \$1319 \$67 64.1221a
Cext_4245 \$1319 \$69 0.155901a
Cext_4246 \$1319 IOVDD|vdda 13.0646a
Cext_4247 \$1319 VSS|vss 66.2132a
Cext_4248 \$1319 VSUBS 817.28a
Cext_4249 \$132 \$133 45.8951a
Cext_4250 \$132 \$160 130.175a
Cext_4251 \$132 \$67 4.40063a
Cext_4252 \$132 VSS|vss 0.428128a
Cext_4253 \$132 VSUBS 634.529a
Cext_4254 \$1320 \$1321 2.00331a
Cext_4255 \$1320 \$1335 102.889a
Cext_4256 \$1320 \$1347 225.319a
Cext_4257 \$1320 \$35 68.8428a
Cext_4258 \$1320 \$41 0.115752a
Cext_4259 \$1320 \$43 0.481837a
Cext_4260 \$1320 \$45 20.8391a
Cext_4261 \$1320 \$67 59.1234a
Cext_4262 \$1320 \$69 0.343978a
Cext_4263 \$1320 VSS|vss 60.9228a
Cext_4264 \$1320 VSUBS 811.895a
Cext_4265 \$1321 \$1335 77.0039a
Cext_4266 \$1321 \$1359 226.002a
Cext_4267 \$1321 \$1383 19.1082a
Cext_4268 \$1321 \$1411 1.5569f
Cext_4269 \$1321 \$1425 31.6191a
Cext_4270 \$1321 \$1437 16.6785a
Cext_4271 \$1321 \$1486 16.7925a
Cext_4272 \$1321 \$1513 99.1454a
Cext_4273 \$1321 \$1527 0.250757a
Cext_4274 \$1321 \$35 2.39761a
Cext_4275 \$1321 \$37 164.408a
Cext_4276 \$1321 \$39 53.2723a
Cext_4277 \$1321 \$41 84.4002a
Cext_4278 \$1321 \$43 13.8418a
Cext_4279 \$1321 \$45 7.75874a
Cext_4280 \$1321 \$69 71.5481a
Cext_4281 \$1321 \$71 12.4538a
Cext_4282 \$1321 \$73 47.9782a
Cext_4283 \$1321 \$75 48.4845a
Cext_4284 \$1321 \$77 0.959093a
Cext_4285 \$1321 VREF|vref 156.937a
Cext_4286 \$1321 VSUBS 429.732a
Cext_4287 \$1322 \$1323 45.0654a
Cext_4288 \$1322 \$1348 130.128a
Cext_4289 \$1322 VDD|vdd 0.592094a
Cext_4290 \$1322 VSS|vss 25.1792a
Cext_4291 \$1322 VSUBS 659.267a
Cext_4292 \$1323 \$1324 45.0654a
Cext_4293 \$1323 \$1349 130.175a
Cext_4294 \$1323 VSS|vss 5.452a
Cext_4295 \$1323 VSUBS 634.529a
Cext_4296 \$1324 \$1325 45.0654a
Cext_4297 \$1324 \$1350 130.175a
Cext_4298 \$1324 VSUBS 634.529a
Cext_4299 \$1325 \$1326 46.4004a
Cext_4300 \$1325 \$1351 130.175a
Cext_4301 \$1325 VSS|vss 0.378729a
Cext_4302 \$1325 VSUBS 634.529a
Cext_4303 \$1326 \$1352 254.864a
Cext_4304 \$1326 \$1360 0.360462a
Cext_4305 \$1326 \$51 68.8031a
Cext_4306 \$1326 \$83 64.1221a
Cext_4307 \$1326 \$85 0.155901a
Cext_4308 \$1326 VSS|vss 66.2906a
Cext_4309 \$1326 VSUBS 799.746a
Cext_4310 \$1327 \$1328 2.00331a
Cext_4311 \$1327 \$1337 102.889a
Cext_4312 \$1327 \$1353 225.319a
Cext_4313 \$1327 \$51 68.8428a
Cext_4314 \$1327 \$57 0.115752a
Cext_4315 \$1327 \$59 0.481837a
Cext_4316 \$1327 \$61 20.8391a
Cext_4317 \$1327 \$83 59.1234a
Cext_4318 \$1327 \$85 0.343978a
Cext_4319 \$1327 VSS|vss 60.9228a
Cext_4320 \$1327 VSUBS 811.895a
Cext_4321 \$1328 \$1329 4.9228a
Cext_4322 \$1328 \$1337 77.0039a
Cext_4323 \$1328 \$1354 4.41896a
Cext_4324 \$1328 \$1361 226.002a
Cext_4325 \$1328 \$1378 4.94574a
Cext_4326 \$1328 \$1385 19.1082a
Cext_4327 \$1328 \$1405 4.41896a
Cext_4328 \$1328 \$1413 1.5569f
Cext_4329 \$1328 \$1432 31.6191a
Cext_4330 \$1328 \$1433 4.94574a
Cext_4331 \$1328 \$1438 16.6785a
Cext_4332 \$1328 \$1453 4.41896a
Cext_4333 \$1328 \$1474 4.94574a
Cext_4334 \$1328 \$1495 16.7925a
Cext_4335 \$1328 \$1496 4.41896a
Cext_4336 \$1328 \$1520 99.1454a
Cext_4337 \$1328 \$1529 0.250757a
Cext_4338 \$1328 \$51 2.39761a
Cext_4339 \$1328 \$53 164.064a
Cext_4340 \$1328 \$55 52.9648a
Cext_4341 \$1328 \$57 84.2145a
Cext_4342 \$1328 \$59 13.1371a
Cext_4343 \$1328 \$61 6.75111a
Cext_4344 \$1328 \$85 71.1976a
Cext_4345 \$1328 \$87 12.4538a
Cext_4346 \$1328 \$89 47.9782a
Cext_4347 \$1328 \$91 48.4845a
Cext_4348 \$1328 \$93 0.959093a
Cext_4349 \$1328 VSUBS 507.242a
Cext_4350 \$1329 \$1354 254.864a
Cext_4351 \$1329 \$1362 0.360462a
Cext_4352 \$1329 \$51 68.8031a
Cext_4353 \$1329 \$55 0.105966a
Cext_4354 \$1329 \$57 0.282145a
Cext_4355 \$1329 \$59 0.494517a
Cext_4356 \$1329 \$61 20.9159a
Cext_4357 \$1329 \$83 64.1221a
Cext_4358 \$1329 \$85 0.155901a
Cext_4359 \$1329 IOVDD|vdda 13.0646a
Cext_4360 \$1329 VSS|vss 66.2132a
Cext_4361 \$1329 VSUBS 817.28a
Cext_4362 \$133 \$161 225.319a
Cext_4363 \$133 \$162 113.058a
Cext_4364 \$133 \$35 22.6915a
Cext_4365 \$133 \$67 110.208a
Cext_4366 \$133 VSS|vss 61.1015a
Cext_4367 \$133 VSUBS 793.257a
Cext_4368 \$1330 \$1331 2.00331a
Cext_4369 \$1330 \$1339 102.889a
Cext_4370 \$1330 \$1355 225.319a
Cext_4371 \$1330 \$51 68.8428a
Cext_4372 \$1330 \$57 0.115752a
Cext_4373 \$1330 \$59 0.481837a
Cext_4374 \$1330 \$61 20.8391a
Cext_4375 \$1330 \$83 59.1234a
Cext_4376 \$1330 \$85 0.343978a
Cext_4377 \$1330 VSS|vss 69.9251a
Cext_4378 \$1330 VSUBS 811.895a
Cext_4379 \$1331 \$1339 77.0039a
Cext_4380 \$1331 \$1363 226.002a
Cext_4381 \$1331 \$1387 19.1082a
Cext_4382 \$1331 \$1415 1.5569f
Cext_4383 \$1331 \$1435 31.6191a
Cext_4384 \$1331 \$1439 16.6785a
Cext_4385 \$1331 \$1498 16.7925a
Cext_4386 \$1331 \$1523 99.1454a
Cext_4387 \$1331 \$1531 0.250757a
Cext_4388 \$1331 \$51 2.39761a
Cext_4389 \$1331 \$53 164.408a
Cext_4390 \$1331 \$55 53.2723a
Cext_4391 \$1331 \$57 84.4002a
Cext_4392 \$1331 \$59 13.8418a
Cext_4393 \$1331 \$61 7.75874a
Cext_4394 \$1331 \$85 71.5481a
Cext_4395 \$1331 \$87 12.4538a
Cext_4396 \$1331 \$89 47.9782a
Cext_4397 \$1331 \$91 48.4845a
Cext_4398 \$1331 \$93 0.959093a
Cext_4399 \$1331 VREF|vref 156.937a
Cext_4400 \$1331 VSUBS 429.732a
Cext_4401 \$1332 \$1356 230.002a
Cext_4402 \$1332 \$1368 3.25406a
Cext_4403 \$1332 \$1369 0.179323a
Cext_4404 \$1332 \$1380 99.1454a
Cext_4405 \$1332 \$1393 7.41179a
Cext_4406 \$1332 \$35 3.05553a
Cext_4407 \$1332 \$37 93.95a
Cext_4408 \$1332 \$39 1.18748a
Cext_4409 \$1332 \$43 0.476813a
Cext_4410 \$1332 \$69 106.353a
Cext_4411 \$1332 \$71 53.6239a
Cext_4412 \$1332 \$73 3.34353a
Cext_4413 \$1332 \$75 1.94351a
Cext_4414 \$1332 \$77 1.13718a
Cext_4415 \$1332 VSUBS 177.911a
Cext_4416 \$1333 \$1345 114.006a
Cext_4417 \$1333 \$1346 0.182933a
Cext_4418 \$1333 \$1357 98.5952a
Cext_4419 \$1333 \$1369 0.360462a
Cext_4420 \$1333 \$1381 108.267a
Cext_4421 \$1333 \$35 123.657a
Cext_4422 \$1333 \$37 65.5562a
Cext_4423 \$1333 \$43 0.62262a
Cext_4424 \$1333 \$67 80.1821a
Cext_4425 \$1333 \$69 70.7638a
Cext_4426 \$1333 \$71 31.3588a
Cext_4427 \$1333 \$73 32.5775a
Cext_4428 \$1333 \$75 39.8709a
Cext_4429 \$1333 \$77 45.7852a
Cext_4430 \$1333 VSS|vss 0.378848a
Cext_4431 \$1333 VSUBS 259.207a
Cext_4432 \$1334 \$1358 230.002a
Cext_4433 \$1334 \$1370 3.25406a
Cext_4434 \$1334 \$1371 0.179323a
Cext_4435 \$1334 \$1382 99.1454a
Cext_4436 \$1334 \$1396 7.41179a
Cext_4437 \$1334 \$35 3.05553a
Cext_4438 \$1334 \$37 93.95a
Cext_4439 \$1334 \$39 1.18748a
Cext_4440 \$1334 \$43 0.476813a
Cext_4441 \$1334 \$69 106.353a
Cext_4442 \$1334 \$71 53.6239a
Cext_4443 \$1334 \$73 3.34353a
Cext_4444 \$1334 \$75 1.94351a
Cext_4445 \$1334 \$77 1.13718a
Cext_4446 \$1334 IOVDD|vdda 5.40532a
Cext_4447 \$1334 VSUBS 177.911a
Cext_4448 \$1335 \$1347 114.006a
Cext_4449 \$1335 \$1359 98.5952a
Cext_4450 \$1335 \$1371 0.360462a
Cext_4451 \$1335 \$1383 108.267a
Cext_4452 \$1335 \$35 123.657a
Cext_4453 \$1335 \$37 65.5562a
Cext_4454 \$1335 \$43 0.62262a
Cext_4455 \$1335 \$67 80.1821a
Cext_4456 \$1335 \$69 70.7638a
Cext_4457 \$1335 \$71 31.3588a
Cext_4458 \$1335 \$73 32.5775a
Cext_4459 \$1335 \$75 39.8709a
Cext_4460 \$1335 \$77 45.7852a
Cext_4461 \$1335 VREF|vref 0.182933a
Cext_4462 \$1335 VSS|vss 0.378848a
Cext_4463 \$1335 VSUBS 259.207a
Cext_4464 \$1336 \$1360 230.002a
Cext_4465 \$1336 \$1376 3.25406a
Cext_4466 \$1336 \$1377 0.179323a
Cext_4467 \$1336 \$1384 99.1454a
Cext_4468 \$1336 \$1403 7.41179a
Cext_4469 \$1336 \$51 3.05553a
Cext_4470 \$1336 \$53 93.95a
Cext_4471 \$1336 \$55 1.18748a
Cext_4472 \$1336 \$59 0.476813a
Cext_4473 \$1336 \$85 106.353a
Cext_4474 \$1336 \$87 53.6239a
Cext_4475 \$1336 \$89 3.34353a
Cext_4476 \$1336 \$91 1.94351a
Cext_4477 \$1336 \$93 1.13718a
Cext_4478 \$1336 VSUBS 177.911a
Cext_4479 \$1337 \$1353 114.006a
Cext_4480 \$1337 \$1354 0.182933a
Cext_4481 \$1337 \$1361 98.5952a
Cext_4482 \$1337 \$1377 0.360462a
Cext_4483 \$1337 \$1385 108.267a
Cext_4484 \$1337 \$51 123.657a
Cext_4485 \$1337 \$53 65.5562a
Cext_4486 \$1337 \$59 0.62262a
Cext_4487 \$1337 \$83 80.1821a
Cext_4488 \$1337 \$85 70.7638a
Cext_4489 \$1337 \$87 31.3588a
Cext_4490 \$1337 \$89 32.5775a
Cext_4491 \$1337 \$91 39.8709a
Cext_4492 \$1337 \$93 45.7852a
Cext_4493 \$1337 VSS|vss 0.378848a
Cext_4494 \$1337 VSUBS 259.207a
Cext_4495 \$1338 \$1362 230.002a
Cext_4496 \$1338 \$1378 3.25406a
Cext_4497 \$1338 \$1379 0.179323a
Cext_4498 \$1338 \$1386 99.1454a
Cext_4499 \$1338 \$1406 7.41179a
Cext_4500 \$1338 \$51 3.05553a
Cext_4501 \$1338 \$53 93.95a
Cext_4502 \$1338 \$55 1.18748a
Cext_4503 \$1338 \$59 0.476813a
Cext_4504 \$1338 \$85 106.353a
Cext_4505 \$1338 \$87 53.6239a
Cext_4506 \$1338 \$89 3.34353a
Cext_4507 \$1338 \$91 1.94351a
Cext_4508 \$1338 \$93 1.13718a
Cext_4509 \$1338 IOVDD|vdda 5.40532a
Cext_4510 \$1338 VSS|vss 6.21589a
Cext_4511 \$1338 VSUBS 177.911a
Cext_4512 \$1339 \$1355 114.006a
Cext_4513 \$1339 \$1363 98.5952a
Cext_4514 \$1339 \$1379 0.360462a
Cext_4515 \$1339 \$1387 108.267a
Cext_4516 \$1339 \$51 123.657a
Cext_4517 \$1339 \$53 65.5562a
Cext_4518 \$1339 \$59 0.62262a
Cext_4519 \$1339 \$83 80.1821a
Cext_4520 \$1339 \$85 70.7638a
Cext_4521 \$1339 \$87 31.3588a
Cext_4522 \$1339 \$89 32.5775a
Cext_4523 \$1339 \$91 39.8709a
Cext_4524 \$1339 \$93 45.7852a
Cext_4525 \$1339 VREF|vref 0.182933a
Cext_4526 \$1339 VSS|vss 0.378848a
Cext_4527 \$1339 VSUBS 259.207a
Cext_4528 \$134 \$136 1.85779a
Cext_4529 \$134 \$161 3.25406a
Cext_4530 \$134 \$162 231.736a
Cext_4531 \$134 \$163 1.44306a
Cext_4532 \$134 \$188 99.1454a
Cext_4533 \$134 \$189 7.41179a
Cext_4534 \$134 \$35 3.05553a
Cext_4535 \$134 \$37 103.932a
Cext_4536 \$134 \$39 4.04423a
Cext_4537 \$134 \$41 1.62297a
Cext_4538 \$134 \$43 0.919893a
Cext_4539 \$134 \$45 0.703335a
Cext_4540 \$134 \$67 1.00326a
Cext_4541 \$134 \$69 106.353a
Cext_4542 \$134 \$71 53.8929a
Cext_4543 \$134 \$73 4.01016a
Cext_4544 \$134 \$75 1.61371a
Cext_4545 \$134 \$77 1.13718a
Cext_4546 \$134 VSUBS 230.078a
Cext_4547 \$1340 \$1341 45.0654a
Cext_4548 \$1340 \$1364 130.175a
Cext_4549 \$1340 VDD|vdd 7.74075a
Cext_4550 \$1340 VSS|vss 1.71997a
Cext_4551 \$1340 VSUBS 659.267a
Cext_4552 \$1341 \$1342 45.0654a
Cext_4553 \$1341 \$1365 130.175a
Cext_4554 \$1341 VDD|vdd 0.968272a
Cext_4555 \$1341 VSUBS 634.529a
Cext_4556 \$1342 \$1343 45.0654a
Cext_4557 \$1342 \$1366 130.175a
Cext_4558 \$1342 VSUBS 634.529a
Cext_4559 \$1343 \$1344 45.8951a
Cext_4560 \$1343 \$1367 130.175a
Cext_4561 \$1343 VSS|vss 0.428128a
Cext_4562 \$1343 VSUBS 634.529a
Cext_4563 \$1344 \$1356 113.058a
Cext_4564 \$1344 \$1368 225.319a
Cext_4565 \$1344 \$35 22.6915a
Cext_4566 \$1344 \$67 105.489a
Cext_4567 \$1344 VSS|vss 61.1015a
Cext_4568 \$1344 VSUBS 793.257a
Cext_4569 \$1345 \$1356 0.182933a
Cext_4570 \$1345 \$1369 254.864a
Cext_4571 \$1345 \$1381 0.360462a
Cext_4572 \$1345 \$35 23.2117a
Cext_4573 \$1345 \$37 0.145978a
Cext_4574 \$1345 \$39 0.105966a
Cext_4575 \$1345 \$41 0.282145a
Cext_4576 \$1345 \$43 0.494517a
Cext_4577 \$1345 \$45 20.7622a
Cext_4578 \$1345 \$67 110.011a
Cext_4579 \$1345 VSS|vss 66.2132a
Cext_4580 \$1345 VSUBS 817.35a
Cext_4581 \$1346 \$1358 113.058a
Cext_4582 \$1346 \$1370 225.319a
Cext_4583 \$1346 \$35 22.6915a
Cext_4584 \$1346 \$37 0.404672a
Cext_4585 \$1346 \$41 0.115752a
Cext_4586 \$1346 \$43 0.481837a
Cext_4587 \$1346 \$45 20.8391a
Cext_4588 \$1346 \$67 105.489a
Cext_4589 \$1346 IOVDD|vdda 11.5102a
Cext_4590 \$1346 VSS|vss 60.9228a
Cext_4591 \$1346 VSUBS 810.376a
Cext_4592 \$1347 \$1358 0.182933a
Cext_4593 \$1347 \$1371 254.864a
Cext_4594 \$1347 \$1383 0.360462a
Cext_4595 \$1347 \$35 23.2117a
Cext_4596 \$1347 \$37 0.145978a
Cext_4597 \$1347 \$39 0.105966a
Cext_4598 \$1347 \$41 0.282145a
Cext_4599 \$1347 \$43 0.494517a
Cext_4600 \$1347 \$45 20.7622a
Cext_4601 \$1347 \$67 110.011a
Cext_4602 \$1347 VSS|vss 66.2132a
Cext_4603 \$1347 VSUBS 817.35a
Cext_4604 \$1348 \$1349 45.0654a
Cext_4605 \$1348 \$1372 130.128a
Cext_4606 \$1348 VDD|vdd 0.592094a
Cext_4607 \$1348 VSS|vss 25.1792a
Cext_4608 \$1348 VSUBS 659.267a
Cext_4609 \$1349 \$1350 45.0654a
Cext_4610 \$1349 \$1373 130.175a
Cext_4611 \$1349 VSS|vss 5.452a
Cext_4612 \$1349 VSUBS 634.529a
Cext_4613 \$135 \$136 114.006a
Cext_4614 \$135 \$137 0.709993a
Cext_4615 \$135 \$163 0.360462a
Cext_4616 \$135 \$164 98.5952a
Cext_4617 \$135 \$190 108.267a
Cext_4618 \$135 \$35 123.256a
Cext_4619 \$135 \$37 66.5956a
Cext_4620 \$135 \$39 0.280546a
Cext_4621 \$135 \$41 0.131796a
Cext_4622 \$135 \$43 0.112844a
Cext_4623 \$135 \$67 80.1395a
Cext_4624 \$135 \$69 70.312a
Cext_4625 \$135 \$71 30.8484a
Cext_4626 \$135 \$73 31.8692a
Cext_4627 \$135 \$75 34.9266a
Cext_4628 \$135 \$77 45.0769a
Cext_4629 \$135 VSS|vss 0.378848a
Cext_4630 \$135 VSUBS 289.954a
Cext_4631 \$1350 \$1351 45.0654a
Cext_4632 \$1350 \$1374 130.175a
Cext_4633 \$1350 VSUBS 634.529a
Cext_4634 \$1351 \$1352 45.8951a
Cext_4635 \$1351 \$1375 130.175a
Cext_4636 \$1351 VSS|vss 0.428128a
Cext_4637 \$1351 VSUBS 634.529a
Cext_4638 \$1352 \$1360 113.058a
Cext_4639 \$1352 \$1376 225.319a
Cext_4640 \$1352 \$51 22.6915a
Cext_4641 \$1352 \$83 105.489a
Cext_4642 \$1352 VSS|vss 61.1015a
Cext_4643 \$1352 VSUBS 793.257a
Cext_4644 \$1353 \$1360 0.182933a
Cext_4645 \$1353 \$1377 254.864a
Cext_4646 \$1353 \$1385 0.360462a
Cext_4647 \$1353 \$51 23.2117a
Cext_4648 \$1353 \$53 0.145978a
Cext_4649 \$1353 \$55 0.105966a
Cext_4650 \$1353 \$57 0.282145a
Cext_4651 \$1353 \$59 0.494517a
Cext_4652 \$1353 \$61 20.7622a
Cext_4653 \$1353 \$83 110.011a
Cext_4654 \$1353 VSS|vss 66.2132a
Cext_4655 \$1353 VSUBS 817.35a
Cext_4656 \$1354 \$1362 113.058a
Cext_4657 \$1354 \$1378 225.319a
Cext_4658 \$1354 \$51 22.6915a
Cext_4659 \$1354 \$53 0.404672a
Cext_4660 \$1354 \$57 0.115752a
Cext_4661 \$1354 \$59 0.481837a
Cext_4662 \$1354 \$61 20.8391a
Cext_4663 \$1354 \$83 105.489a
Cext_4664 \$1354 IOVDD|vdda 11.5102a
Cext_4665 \$1354 VSS|vss 60.9228a
Cext_4666 \$1354 VSUBS 810.376a
Cext_4667 \$1355 \$1362 0.182933a
Cext_4668 \$1355 \$1379 254.864a
Cext_4669 \$1355 \$1387 0.360462a
Cext_4670 \$1355 \$51 23.2117a
Cext_4671 \$1355 \$53 0.145978a
Cext_4672 \$1355 \$55 0.105966a
Cext_4673 \$1355 \$57 0.282145a
Cext_4674 \$1355 \$59 0.494517a
Cext_4675 \$1355 \$61 20.7622a
Cext_4676 \$1355 \$83 110.011a
Cext_4677 \$1355 VSS|vss 75.4228a
Cext_4678 \$1355 VSUBS 817.35a
Cext_4679 \$1356 \$1368 102.889a
Cext_4680 \$1356 \$1380 0.250757a
Cext_4681 \$1356 \$1392 0.360462a
Cext_4682 \$1356 \$1408 42.153a
Cext_4683 \$1356 \$35 123.657a
Cext_4684 \$1356 \$37 65.6459a
Cext_4685 \$1356 \$39 0.62262a
Cext_4686 \$1356 \$67 80.1249a
Cext_4687 \$1356 \$69 70.7638a
Cext_4688 \$1356 \$71 34.0438a
Cext_4689 \$1356 \$73 32.5775a
Cext_4690 \$1356 \$75 35.6349a
Cext_4691 \$1356 \$77 45.8508a
Cext_4692 \$1356 VSS|vss 0.335662a
Cext_4693 \$1356 VSUBS 256.045a
Cext_4694 \$1357 \$1381 230.002a
Cext_4695 \$1357 \$1394 3.25406a
Cext_4696 \$1357 \$1395 0.179323a
Cext_4697 \$1357 \$1409 99.1454a
Cext_4698 \$1357 \$1422 7.41179a
Cext_4699 \$1357 \$35 0.592076a
Cext_4700 \$1357 \$37 82.9986a
Cext_4701 \$1357 \$39 47.3198a
Cext_4702 \$1357 \$43 0.329802a
Cext_4703 \$1357 \$67 2.30683a
Cext_4704 \$1357 \$69 118.446a
Cext_4705 \$1357 \$71 7.49159a
Cext_4706 \$1357 \$73 3.34353a
Cext_4707 \$1357 \$75 2.09052a
Cext_4708 \$1357 \$77 1.13718a
Cext_4709 \$1357 VSUBS 177.242a
Cext_4710 \$1358 \$1370 102.889a
Cext_4711 \$1358 \$1382 0.250757a
Cext_4712 \$1358 \$1395 0.360462a
Cext_4713 \$1358 \$1410 42.153a
Cext_4714 \$1358 \$35 123.51a
Cext_4715 \$1358 \$37 65.6459a
Cext_4716 \$1358 \$39 0.62262a
Cext_4717 \$1358 \$67 79.9778a
Cext_4718 \$1358 \$69 70.7638a
Cext_4719 \$1358 \$71 34.0438a
Cext_4720 \$1358 \$73 32.5775a
Cext_4721 \$1358 \$75 35.6349a
Cext_4722 \$1358 \$77 45.8508a
Cext_4723 \$1358 IOVDD|vdda 41.5542a
Cext_4724 \$1358 VSS|vss 0.335662a
Cext_4725 \$1358 VSUBS 255.771a
Cext_4726 \$1359 \$1383 230.002a
Cext_4727 \$1359 \$1397 3.25406a
Cext_4728 \$1359 \$1411 99.1454a
Cext_4729 \$1359 \$1425 7.41179a
Cext_4730 \$1359 \$35 0.592076a
Cext_4731 \$1359 \$37 82.9986a
Cext_4732 \$1359 \$39 47.3198a
Cext_4733 \$1359 \$43 0.329802a
Cext_4734 \$1359 \$67 2.30683a
Cext_4735 \$1359 \$69 118.556a
Cext_4736 \$1359 \$71 7.49159a
Cext_4737 \$1359 \$73 3.34353a
Cext_4738 \$1359 \$75 2.09052a
Cext_4739 \$1359 \$77 1.13718a
Cext_4740 \$1359 VREF|vref 0.489684a
Cext_4741 \$1359 VSUBS 177.31a
Cext_4742 \$136 \$162 0.182933a
Cext_4743 \$136 \$163 254.864a
Cext_4744 \$136 \$190 0.360462a
Cext_4745 \$136 \$35 23.2117a
Cext_4746 \$136 \$37 0.145978a
Cext_4747 \$136 \$39 0.105966a
Cext_4748 \$136 \$41 0.282145a
Cext_4749 \$136 \$43 0.494517a
Cext_4750 \$136 \$45 20.7622a
Cext_4751 \$136 \$67 114.799a
Cext_4752 \$136 VSS|vss 66.2132a
Cext_4753 \$136 VSUBS 817.643a
Cext_4754 \$1360 \$1376 102.889a
Cext_4755 \$1360 \$1384 0.250757a
Cext_4756 \$1360 \$1402 0.360462a
Cext_4757 \$1360 \$1412 42.153a
Cext_4758 \$1360 \$51 123.657a
Cext_4759 \$1360 \$53 65.6459a
Cext_4760 \$1360 \$55 0.62262a
Cext_4761 \$1360 \$83 80.1249a
Cext_4762 \$1360 \$85 70.7638a
Cext_4763 \$1360 \$87 34.0438a
Cext_4764 \$1360 \$89 32.5775a
Cext_4765 \$1360 \$91 35.6349a
Cext_4766 \$1360 \$93 45.8508a
Cext_4767 \$1360 VSS|vss 0.335662a
Cext_4768 \$1360 VSUBS 256.045a
Cext_4769 \$1361 \$1385 230.002a
Cext_4770 \$1361 \$1404 3.25406a
Cext_4771 \$1361 \$1405 0.179323a
Cext_4772 \$1361 \$1413 99.1454a
Cext_4773 \$1361 \$1432 7.41179a
Cext_4774 \$1361 \$51 0.592076a
Cext_4775 \$1361 \$53 82.9986a
Cext_4776 \$1361 \$55 47.3198a
Cext_4777 \$1361 \$59 0.329802a
Cext_4778 \$1361 \$83 2.30683a
Cext_4779 \$1361 \$85 118.446a
Cext_4780 \$1361 \$87 7.49159a
Cext_4781 \$1361 \$89 3.34353a
Cext_4782 \$1361 \$91 2.09052a
Cext_4783 \$1361 \$93 1.13718a
Cext_4784 \$1361 VSUBS 177.242a
Cext_4785 \$1362 \$1378 102.889a
Cext_4786 \$1362 \$1386 0.250757a
Cext_4787 \$1362 \$1405 0.360462a
Cext_4788 \$1362 \$1414 42.153a
Cext_4789 \$1362 \$51 123.51a
Cext_4790 \$1362 \$53 65.6459a
Cext_4791 \$1362 \$55 0.62262a
Cext_4792 \$1362 \$83 79.9778a
Cext_4793 \$1362 \$85 70.7638a
Cext_4794 \$1362 \$87 34.0438a
Cext_4795 \$1362 \$89 32.5775a
Cext_4796 \$1362 \$91 35.6349a
Cext_4797 \$1362 \$93 45.8508a
Cext_4798 \$1362 IOVDD|vdda 41.5542a
Cext_4799 \$1362 VSS|vss 3.78628a
Cext_4800 \$1362 VSUBS 255.771a
Cext_4801 \$1363 \$1387 230.002a
Cext_4802 \$1363 \$1407 3.25406a
Cext_4803 \$1363 \$1415 99.1454a
Cext_4804 \$1363 \$1435 7.41179a
Cext_4805 \$1363 \$51 0.592076a
Cext_4806 \$1363 \$53 82.9986a
Cext_4807 \$1363 \$55 47.3198a
Cext_4808 \$1363 \$59 0.329802a
Cext_4809 \$1363 \$83 2.30683a
Cext_4810 \$1363 \$85 118.556a
Cext_4811 \$1363 \$87 7.49159a
Cext_4812 \$1363 \$89 3.34353a
Cext_4813 \$1363 \$91 2.09052a
Cext_4814 \$1363 \$93 1.13718a
Cext_4815 \$1363 VREF|vref 0.489684a
Cext_4816 \$1363 VSUBS 177.31a
Cext_4817 \$1364 \$1365 45.0654a
Cext_4818 \$1364 \$1388 130.175a
Cext_4819 \$1364 VDD|vdd 7.74075a
Cext_4820 \$1364 VSS|vss 1.71997a
Cext_4821 \$1364 VSUBS 659.267a
Cext_4822 \$1365 \$1366 45.0654a
Cext_4823 \$1365 \$1389 130.175a
Cext_4824 \$1365 VDD|vdd 0.968272a
Cext_4825 \$1365 VSUBS 634.529a
Cext_4826 \$1366 \$1367 45.0654a
Cext_4827 \$1366 \$1390 130.175a
Cext_4828 \$1366 VSUBS 634.529a
Cext_4829 \$1367 \$1368 46.4004a
Cext_4830 \$1367 \$1391 130.175a
Cext_4831 \$1367 VSS|vss 0.378729a
Cext_4832 \$1367 VSUBS 634.529a
Cext_4833 \$1368 \$1392 254.864a
Cext_4834 \$1368 \$1408 0.360462a
Cext_4835 \$1368 \$35 69.0342a
Cext_4836 \$1368 \$67 64.1221a
Cext_4837 \$1368 \$71 0.168339a
Cext_4838 \$1368 \$77 0.107779a
Cext_4839 \$1368 VSS|vss 66.2906a
Cext_4840 \$1368 VSUBS 800.931a
Cext_4841 \$1369 \$1381 113.058a
Cext_4842 \$1369 \$1394 225.319a
Cext_4843 \$1369 \$35 68.7272a
Cext_4844 \$1369 \$41 0.115752a
Cext_4845 \$1369 \$43 0.481837a
Cext_4846 \$1369 \$45 20.9928a
Cext_4847 \$1369 \$67 58.9193a
Cext_4848 \$1369 \$71 0.343978a
Cext_4849 \$1369 VSS|vss 60.9228a
Cext_4850 \$1369 VSUBS 810.856a
Cext_4851 \$137 \$165 113.058a
Cext_4852 \$137 \$166 225.319a
Cext_4853 \$137 \$35 22.6915a
Cext_4854 \$137 \$37 0.404672a
Cext_4855 \$137 \$41 0.115752a
Cext_4856 \$137 \$43 0.481837a
Cext_4857 \$137 \$45 20.8391a
Cext_4858 \$137 \$67 110.208a
Cext_4859 \$137 IOVDD|vdda 11.5102a
Cext_4860 \$137 VSS|vss 60.9228a
Cext_4861 \$137 VSUBS 810.657a
Cext_4862 \$1370 \$1381 0.182933a
Cext_4863 \$1370 \$1395 254.864a
Cext_4864 \$1370 \$1410 0.360462a
Cext_4865 \$1370 \$35 69.0342a
Cext_4866 \$1370 \$39 0.105966a
Cext_4867 \$1370 \$41 0.282145a
Cext_4868 \$1370 \$43 0.494517a
Cext_4869 \$1370 \$45 20.7622a
Cext_4870 \$1370 \$67 64.1221a
Cext_4871 \$1370 \$71 0.168339a
Cext_4872 \$1370 \$77 0.107779a
Cext_4873 \$1370 IOVDD|vdda 13.2807a
Cext_4874 \$1370 VSS|vss 66.2132a
Cext_4875 \$1370 VSUBS 818.653a
Cext_4876 \$1371 \$1383 113.058a
Cext_4877 \$1371 \$1397 225.319a
Cext_4878 \$1371 \$35 68.7272a
Cext_4879 \$1371 \$41 0.115752a
Cext_4880 \$1371 \$43 0.481837a
Cext_4881 \$1371 \$45 20.9928a
Cext_4882 \$1371 \$67 58.9193a
Cext_4883 \$1371 \$71 0.343978a
Cext_4884 \$1371 VSS|vss 60.9228a
Cext_4885 \$1371 VSUBS 810.856a
Cext_4886 \$1372 \$1373 45.0654a
Cext_4887 \$1372 \$1398 130.128a
Cext_4888 \$1372 VDD|vdd 0.592094a
Cext_4889 \$1372 VSS|vss 25.1792a
Cext_4890 \$1372 VSUBS 659.267a
Cext_4891 \$1373 \$1374 45.0654a
Cext_4892 \$1373 \$1399 130.175a
Cext_4893 \$1373 VSS|vss 5.452a
Cext_4894 \$1373 VSUBS 634.529a
Cext_4895 \$1374 \$1375 45.0654a
Cext_4896 \$1374 \$1400 130.175a
Cext_4897 \$1374 VSUBS 634.529a
Cext_4898 \$1375 \$1376 46.4004a
Cext_4899 \$1375 \$1401 130.175a
Cext_4900 \$1375 VSS|vss 0.378729a
Cext_4901 \$1375 VSUBS 634.529a
Cext_4902 \$1376 \$1402 254.864a
Cext_4903 \$1376 \$1412 0.360462a
Cext_4904 \$1376 \$51 69.0342a
Cext_4905 \$1376 \$83 64.1221a
Cext_4906 \$1376 \$87 0.168339a
Cext_4907 \$1376 \$93 0.107779a
Cext_4908 \$1376 VSS|vss 66.2906a
Cext_4909 \$1376 VSUBS 800.931a
Cext_4910 \$1377 \$1385 113.058a
Cext_4911 \$1377 \$1404 225.319a
Cext_4912 \$1377 \$51 68.7272a
Cext_4913 \$1377 \$57 0.115752a
Cext_4914 \$1377 \$59 0.481837a
Cext_4915 \$1377 \$61 20.9928a
Cext_4916 \$1377 \$83 58.9193a
Cext_4917 \$1377 \$87 0.343978a
Cext_4918 \$1377 VSS|vss 60.9228a
Cext_4919 \$1377 VSUBS 810.856a
Cext_4920 \$1378 \$1385 0.182933a
Cext_4921 \$1378 \$1405 254.864a
Cext_4922 \$1378 \$1414 0.360462a
Cext_4923 \$1378 \$51 69.0342a
Cext_4924 \$1378 \$55 0.105966a
Cext_4925 \$1378 \$57 0.282145a
Cext_4926 \$1378 \$59 0.494517a
Cext_4927 \$1378 \$61 20.7622a
Cext_4928 \$1378 \$83 64.1221a
Cext_4929 \$1378 \$87 0.168339a
Cext_4930 \$1378 \$93 0.107779a
Cext_4931 \$1378 IOVDD|vdda 13.2807a
Cext_4932 \$1378 VSS|vss 66.2132a
Cext_4933 \$1378 VSUBS 818.653a
Cext_4934 \$1379 \$1387 113.058a
Cext_4935 \$1379 \$1407 225.319a
Cext_4936 \$1379 \$51 68.7272a
Cext_4937 \$1379 \$57 0.115752a
Cext_4938 \$1379 \$59 0.481837a
Cext_4939 \$1379 \$61 20.9928a
Cext_4940 \$1379 \$83 58.9193a
Cext_4941 \$1379 \$87 0.343978a
Cext_4942 \$1379 VSS|vss 69.9251a
Cext_4943 \$1379 VSUBS 810.856a
Cext_4944 \$138 \$140 1.85779a
Cext_4945 \$138 \$165 231.736a
Cext_4946 \$138 \$166 3.25406a
Cext_4947 \$138 \$167 1.44306a
Cext_4948 \$138 \$193 99.1454a
Cext_4949 \$138 \$194 7.41179a
Cext_4950 \$138 \$35 3.05553a
Cext_4951 \$138 \$37 103.932a
Cext_4952 \$138 \$39 4.04423a
Cext_4953 \$138 \$41 1.62297a
Cext_4954 \$138 \$43 0.919893a
Cext_4955 \$138 \$45 0.703335a
Cext_4956 \$138 \$67 1.00326a
Cext_4957 \$138 \$69 106.353a
Cext_4958 \$138 \$71 53.8929a
Cext_4959 \$138 \$73 3.34353a
Cext_4960 \$138 \$75 1.61371a
Cext_4961 \$138 \$77 1.13718a
Cext_4962 \$138 IOVDD|vdda 5.6517a
Cext_4963 \$138 VSUBS 230.16a
Cext_4964 \$1380 \$1393 783.202a
Cext_4965 \$1380 \$1408 15.7815a
Cext_4966 \$1380 \$1456 83.8393a
Cext_4967 \$1380 \$1464 2.88751a
Cext_4968 \$1380 \$1465 0.179323a
Cext_4969 \$1380 \$1481 7.41179a
Cext_4970 \$1380 \$35 2.65407a
Cext_4971 \$1380 \$37 56.4353a
Cext_4972 \$1380 \$39 56.2856a
Cext_4973 \$1380 \$41 1.18748a
Cext_4974 \$1380 \$43 0.13075a
Cext_4975 \$1380 \$69 60.0621a
Cext_4976 \$1380 \$71 50.2205a
Cext_4977 \$1380 \$73 49.6419a
Cext_4978 \$1380 \$75 1.67062a
Cext_4979 \$1380 \$77 0.98091a
Cext_4980 \$1380 VSUBS 198.211a
Cext_4981 \$1381 \$1394 102.889a
Cext_4982 \$1381 \$1409 0.250757a
Cext_4983 \$1381 \$1421 0.360462a
Cext_4984 \$1381 \$1436 42.153a
Cext_4985 \$1381 \$35 134.708a
Cext_4986 \$1381 \$37 19.3729a
Cext_4987 \$1381 \$39 1.40263a
Cext_4988 \$1381 \$67 69.937a
Cext_4989 \$1381 \$69 117.46a
Cext_4990 \$1381 \$71 32.765a
Cext_4991 \$1381 \$73 32.5775a
Cext_4992 \$1381 \$75 35.6349a
Cext_4993 \$1381 \$77 45.8508a
Cext_4994 \$1381 VSS|vss 0.335662a
Cext_4995 \$1381 VSUBS 255.662a
Cext_4996 \$1382 \$1396 783.202a
Cext_4997 \$1382 \$1410 15.7815a
Cext_4998 \$1382 \$1457 83.8393a
Cext_4999 \$1382 \$1466 2.88751a
Cext_5000 \$1382 \$1467 0.179323a
Cext_5001 \$1382 \$1485 7.41179a
Cext_5002 \$1382 \$35 2.65407a
Cext_5003 \$1382 \$37 56.4353a
Cext_5004 \$1382 \$39 56.2856a
Cext_5005 \$1382 \$41 1.18748a
Cext_5006 \$1382 \$43 0.13075a
Cext_5007 \$1382 \$69 60.0621a
Cext_5008 \$1382 \$71 50.2205a
Cext_5009 \$1382 \$73 49.6419a
Cext_5010 \$1382 \$75 1.67062a
Cext_5011 \$1382 \$77 0.98091a
Cext_5012 \$1382 IOVDD|vdda 7.50694a
Cext_5013 \$1382 VSUBS 198.211a
Cext_5014 \$1383 \$1397 102.889a
Cext_5015 \$1383 \$1411 0.250757a
Cext_5016 \$1383 \$1424 0.360462a
Cext_5017 \$1383 \$1437 42.153a
Cext_5018 \$1383 \$35 134.708a
Cext_5019 \$1383 \$37 19.3729a
Cext_5020 \$1383 \$39 1.40263a
Cext_5021 \$1383 \$67 69.937a
Cext_5022 \$1383 \$69 117.46a
Cext_5023 \$1383 \$71 32.765a
Cext_5024 \$1383 \$73 32.5775a
Cext_5025 \$1383 \$75 35.6349a
Cext_5026 \$1383 \$77 45.8508a
Cext_5027 \$1383 VREF|vref 0.182933a
Cext_5028 \$1383 VSS|vss 0.335662a
Cext_5029 \$1383 VSUBS 255.662a
Cext_5030 \$1384 \$1403 783.202a
Cext_5031 \$1384 \$1412 15.7815a
Cext_5032 \$1384 \$1458 83.8393a
Cext_5033 \$1384 \$1472 2.88751a
Cext_5034 \$1384 \$1473 0.179323a
Cext_5035 \$1384 \$1493 7.41179a
Cext_5036 \$1384 \$51 2.65407a
Cext_5037 \$1384 \$53 56.4353a
Cext_5038 \$1384 \$55 56.2856a
Cext_5039 \$1384 \$57 1.18748a
Cext_5040 \$1384 \$59 0.13075a
Cext_5041 \$1384 \$85 60.0621a
Cext_5042 \$1384 \$87 50.2205a
Cext_5043 \$1384 \$89 49.6419a
Cext_5044 \$1384 \$91 1.67062a
Cext_5045 \$1384 \$93 0.98091a
Cext_5046 \$1384 VSUBS 198.211a
Cext_5047 \$1385 \$1404 102.889a
Cext_5048 \$1385 \$1413 0.250757a
Cext_5049 \$1385 \$1431 0.360462a
Cext_5050 \$1385 \$1438 42.153a
Cext_5051 \$1385 \$51 134.708a
Cext_5052 \$1385 \$53 19.3729a
Cext_5053 \$1385 \$55 1.40263a
Cext_5054 \$1385 \$83 69.937a
Cext_5055 \$1385 \$85 117.46a
Cext_5056 \$1385 \$87 32.765a
Cext_5057 \$1385 \$89 32.5775a
Cext_5058 \$1385 \$91 35.6349a
Cext_5059 \$1385 \$93 45.8508a
Cext_5060 \$1385 VSS|vss 0.335662a
Cext_5061 \$1385 VSUBS 255.662a
Cext_5062 \$1386 \$1406 783.202a
Cext_5063 \$1386 \$1414 15.7815a
Cext_5064 \$1386 \$1459 83.8393a
Cext_5065 \$1386 \$1474 2.88751a
Cext_5066 \$1386 \$1475 0.179323a
Cext_5067 \$1386 \$1497 7.41179a
Cext_5068 \$1386 \$51 2.65407a
Cext_5069 \$1386 \$53 56.4353a
Cext_5070 \$1386 \$55 56.2856a
Cext_5071 \$1386 \$57 1.18748a
Cext_5072 \$1386 \$59 0.13075a
Cext_5073 \$1386 \$85 60.0621a
Cext_5074 \$1386 \$87 50.2205a
Cext_5075 \$1386 \$89 49.6419a
Cext_5076 \$1386 \$91 1.67062a
Cext_5077 \$1386 \$93 0.98091a
Cext_5078 \$1386 IOVDD|vdda 7.50694a
Cext_5079 \$1386 VSS|vss 12.2841a
Cext_5080 \$1386 VSUBS 198.211a
Cext_5081 \$1387 \$1407 102.889a
Cext_5082 \$1387 \$1415 0.250757a
Cext_5083 \$1387 \$1434 0.360462a
Cext_5084 \$1387 \$1439 42.153a
Cext_5085 \$1387 \$51 134.708a
Cext_5086 \$1387 \$53 19.3729a
Cext_5087 \$1387 \$55 1.40263a
Cext_5088 \$1387 \$83 69.937a
Cext_5089 \$1387 \$85 117.46a
Cext_5090 \$1387 \$87 32.765a
Cext_5091 \$1387 \$89 32.5775a
Cext_5092 \$1387 \$91 35.6349a
Cext_5093 \$1387 \$93 45.8508a
Cext_5094 \$1387 VREF|vref 0.182933a
Cext_5095 \$1387 VSS|vss 0.335662a
Cext_5096 \$1387 VSUBS 255.662a
Cext_5097 \$1388 \$1389 45.0654a
Cext_5098 \$1388 \$1416 130.175a
Cext_5099 \$1388 VDD|vdd 7.74075a
Cext_5100 \$1388 VSS|vss 1.71997a
Cext_5101 \$1388 VSUBS 659.267a
Cext_5102 \$1389 \$1390 45.0654a
Cext_5103 \$1389 \$1417 130.175a
Cext_5104 \$1389 VDD|vdd 0.968272a
Cext_5105 \$1389 VSUBS 634.529a
Cext_5106 \$139 \$140 114.006a
Cext_5107 \$139 \$141 0.709993a
Cext_5108 \$139 \$167 0.360462a
Cext_5109 \$139 \$168 98.5952a
Cext_5110 \$139 \$195 108.267a
Cext_5111 \$139 \$35 123.256a
Cext_5112 \$139 \$37 66.5956a
Cext_5113 \$139 \$39 0.280546a
Cext_5114 \$139 \$41 0.131796a
Cext_5115 \$139 \$43 0.112844a
Cext_5116 \$139 \$67 80.1395a
Cext_5117 \$139 \$69 70.312a
Cext_5118 \$139 \$71 30.8484a
Cext_5119 \$139 \$73 31.8692a
Cext_5120 \$139 \$75 34.9266a
Cext_5121 \$139 \$77 45.0769a
Cext_5122 \$139 VSS|vss 0.378848a
Cext_5123 \$139 VSUBS 289.954a
Cext_5124 \$1390 \$1391 45.0654a
Cext_5125 \$1390 \$1418 130.175a
Cext_5126 \$1390 VSUBS 634.529a
Cext_5127 \$1391 \$1392 45.8951a
Cext_5128 \$1391 \$1419 130.175a
Cext_5129 \$1391 VSS|vss 0.428128a
Cext_5130 \$1391 VSUBS 634.529a
Cext_5131 \$1392 \$1393 2.46853a
Cext_5132 \$1392 \$1408 102.889a
Cext_5133 \$1392 \$1420 225.319a
Cext_5134 \$1392 \$35 22.8071a
Cext_5135 \$1392 \$67 105.489a
Cext_5136 \$1392 VSS|vss 61.1015a
Cext_5137 \$1392 VSUBS 793.935a
Cext_5138 \$1393 \$1394 0.179323a
Cext_5139 \$1393 \$1408 227.572a
Cext_5140 \$1393 \$1456 98.5952a
Cext_5141 \$1393 \$1524 1.46644a
Cext_5142 \$1393 \$35 0.496172a
Cext_5143 \$1393 \$37 82.9986a
Cext_5144 \$1393 \$39 47.2301a
Cext_5145 \$1393 \$41 0.329802a
Cext_5146 \$1393 \$67 2.30683a
Cext_5147 \$1393 \$69 115.584a
Cext_5148 \$1393 \$71 7.5941a
Cext_5149 \$1393 \$73 3.82035a
Cext_5150 \$1393 \$75 1.52179a
Cext_5151 \$1393 \$77 1.0724a
Cext_5152 \$1393 VSUBS 167.416a
Cext_5153 \$1394 \$1421 254.864a
Cext_5154 \$1394 \$1436 0.360462a
Cext_5155 \$1394 \$35 23.4429a
Cext_5156 \$1394 \$39 0.251943a
Cext_5157 \$1394 \$41 0.282145a
Cext_5158 \$1394 \$43 0.494517a
Cext_5159 \$1394 \$45 20.9159a
Cext_5160 \$1394 \$67 110.011a
Cext_5161 \$1394 \$77 0.107779a
Cext_5162 \$1394 VSS|vss 66.2132a
Cext_5163 \$1394 VSUBS 818.553a
Cext_5164 \$1395 \$1396 2.46853a
Cext_5165 \$1395 \$1410 102.889a
Cext_5166 \$1395 \$1423 225.319a
Cext_5167 \$1395 \$35 22.8071a
Cext_5168 \$1395 \$39 0.500702a
Cext_5169 \$1395 \$41 0.115752a
Cext_5170 \$1395 \$43 0.481837a
Cext_5171 \$1395 \$45 20.9928a
Cext_5172 \$1395 \$67 105.489a
Cext_5173 \$1395 IOVDD|vdda 11.6291a
Cext_5174 \$1395 VSS|vss 60.9228a
Cext_5175 \$1395 VSUBS 810.925a
Cext_5176 \$1396 \$1397 0.179323a
Cext_5177 \$1396 \$1410 227.572a
Cext_5178 \$1396 \$1457 98.5952a
Cext_5179 \$1396 \$1526 1.46644a
Cext_5180 \$1396 \$35 0.496172a
Cext_5181 \$1396 \$37 82.9986a
Cext_5182 \$1396 \$39 47.2301a
Cext_5183 \$1396 \$41 0.329802a
Cext_5184 \$1396 \$67 2.30683a
Cext_5185 \$1396 \$69 115.584a
Cext_5186 \$1396 \$71 7.5941a
Cext_5187 \$1396 \$73 3.82035a
Cext_5188 \$1396 \$75 1.52179a
Cext_5189 \$1396 \$77 1.0724a
Cext_5190 \$1396 IOVDD|vdda 5.12547a
Cext_5191 \$1396 VSUBS 167.416a
Cext_5192 \$1397 \$1424 254.864a
Cext_5193 \$1397 \$1437 0.360462a
Cext_5194 \$1397 \$35 23.4429a
Cext_5195 \$1397 \$39 0.251943a
Cext_5196 \$1397 \$41 0.282145a
Cext_5197 \$1397 \$43 0.494517a
Cext_5198 \$1397 \$45 20.9159a
Cext_5199 \$1397 \$67 110.011a
Cext_5200 \$1397 \$77 0.107779a
Cext_5201 \$1397 VSS|vss 66.2132a
Cext_5202 \$1397 VSUBS 818.553a
Cext_5203 \$1398 \$1399 45.0654a
Cext_5204 \$1398 \$1426 130.128a
Cext_5205 \$1398 VDD|vdd 0.592094a
Cext_5206 \$1398 VSS|vss 25.1792a
Cext_5207 \$1398 VSUBS 659.267a
Cext_5208 \$1399 \$1400 45.0654a
Cext_5209 \$1399 \$1427 130.175a
Cext_5210 \$1399 VSS|vss 5.452a
Cext_5211 \$1399 VSUBS 634.529a
Cext_5212 \$140 \$165 0.182933a
Cext_5213 \$140 \$167 254.864a
Cext_5214 \$140 \$195 0.360462a
Cext_5215 \$140 \$35 23.2117a
Cext_5216 \$140 \$37 0.145978a
Cext_5217 \$140 \$39 0.105966a
Cext_5218 \$140 \$41 0.282145a
Cext_5219 \$140 \$43 0.494517a
Cext_5220 \$140 \$45 20.7622a
Cext_5221 \$140 \$67 114.799a
Cext_5222 \$140 VSS|vss 66.2132a
Cext_5223 \$140 VSUBS 817.643a
Cext_5224 \$1400 \$1401 45.0654a
Cext_5225 \$1400 \$1428 130.175a
Cext_5226 \$1400 VSUBS 634.529a
Cext_5227 \$1401 \$1402 45.8951a
Cext_5228 \$1401 \$1429 130.175a
Cext_5229 \$1401 VSS|vss 0.428128a
Cext_5230 \$1401 VSUBS 634.529a
Cext_5231 \$1402 \$1403 2.46853a
Cext_5232 \$1402 \$1412 102.889a
Cext_5233 \$1402 \$1430 225.319a
Cext_5234 \$1402 \$51 22.8071a
Cext_5235 \$1402 \$83 105.489a
Cext_5236 \$1402 VSS|vss 61.1015a
Cext_5237 \$1402 VSUBS 793.935a
Cext_5238 \$1403 \$1404 0.179323a
Cext_5239 \$1403 \$1412 227.572a
Cext_5240 \$1403 \$1458 98.5952a
Cext_5241 \$1403 \$1528 1.46644a
Cext_5242 \$1403 \$51 0.496172a
Cext_5243 \$1403 \$53 82.9986a
Cext_5244 \$1403 \$55 47.2301a
Cext_5245 \$1403 \$57 0.329802a
Cext_5246 \$1403 \$83 2.30683a
Cext_5247 \$1403 \$85 115.584a
Cext_5248 \$1403 \$87 7.5941a
Cext_5249 \$1403 \$89 3.82035a
Cext_5250 \$1403 \$91 1.52179a
Cext_5251 \$1403 \$93 1.0724a
Cext_5252 \$1403 VSUBS 167.416a
Cext_5253 \$1404 \$1431 254.864a
Cext_5254 \$1404 \$1438 0.360462a
Cext_5255 \$1404 \$51 23.4429a
Cext_5256 \$1404 \$55 0.251943a
Cext_5257 \$1404 \$57 0.282145a
Cext_5258 \$1404 \$59 0.494517a
Cext_5259 \$1404 \$61 20.9159a
Cext_5260 \$1404 \$83 110.011a
Cext_5261 \$1404 \$93 0.107779a
Cext_5262 \$1404 VSS|vss 66.2132a
Cext_5263 \$1404 VSUBS 818.553a
Cext_5264 \$1405 \$1406 2.46853a
Cext_5265 \$1405 \$1414 102.889a
Cext_5266 \$1405 \$1433 225.319a
Cext_5267 \$1405 \$51 22.8071a
Cext_5268 \$1405 \$55 0.500702a
Cext_5269 \$1405 \$57 0.115752a
Cext_5270 \$1405 \$59 0.481837a
Cext_5271 \$1405 \$61 20.9928a
Cext_5272 \$1405 \$83 105.489a
Cext_5273 \$1405 IOVDD|vdda 11.6291a
Cext_5274 \$1405 VSS|vss 60.9228a
Cext_5275 \$1405 VSUBS 810.925a
Cext_5276 \$1406 \$1407 0.179323a
Cext_5277 \$1406 \$1414 227.572a
Cext_5278 \$1406 \$1459 98.5952a
Cext_5279 \$1406 \$1530 1.46644a
Cext_5280 \$1406 \$51 0.496172a
Cext_5281 \$1406 \$53 82.9986a
Cext_5282 \$1406 \$55 47.2301a
Cext_5283 \$1406 \$57 0.329802a
Cext_5284 \$1406 \$83 2.30683a
Cext_5285 \$1406 \$85 115.584a
Cext_5286 \$1406 \$87 7.5941a
Cext_5287 \$1406 \$89 3.82035a
Cext_5288 \$1406 \$91 1.52179a
Cext_5289 \$1406 \$93 1.0724a
Cext_5290 \$1406 IOVDD|vdda 5.12547a
Cext_5291 \$1406 VSS|vss 5.39382a
Cext_5292 \$1406 VSUBS 167.416a
Cext_5293 \$1407 \$1434 254.864a
Cext_5294 \$1407 \$1439 0.360462a
Cext_5295 \$1407 \$51 23.4429a
Cext_5296 \$1407 \$55 0.251943a
Cext_5297 \$1407 \$57 0.282145a
Cext_5298 \$1407 \$59 0.494517a
Cext_5299 \$1407 \$61 20.9159a
Cext_5300 \$1407 \$83 110.011a
Cext_5301 \$1407 \$93 0.107779a
Cext_5302 \$1407 VSS|vss 75.4228a
Cext_5303 \$1407 VSUBS 818.553a
Cext_5304 \$1408 \$1420 114.006a
Cext_5305 \$1408 \$1421 0.182933a
Cext_5306 \$1408 \$1443 0.360462a
Cext_5307 \$1408 \$1456 108.267a
Cext_5308 \$1408 \$35 134.708a
Cext_5309 \$1408 \$37 19.3729a
Cext_5310 \$1408 \$39 1.32172a
Cext_5311 \$1408 \$67 69.9941a
Cext_5312 \$1408 \$69 117.46a
Cext_5313 \$1408 \$71 32.765a
Cext_5314 \$1408 \$73 32.5775a
Cext_5315 \$1408 \$75 35.6349a
Cext_5316 \$1408 \$77 45.7852a
Cext_5317 \$1408 VSS|vss 0.378848a
Cext_5318 \$1408 VSUBS 255.476a
Cext_5319 \$1409 \$1422 783.202a
Cext_5320 \$1409 \$1436 15.7815a
Cext_5321 \$1409 \$1482 83.8393a
Cext_5322 \$1409 \$1483 2.88751a
Cext_5323 \$1409 \$1484 0.179323a
Cext_5324 \$1409 \$1510 7.41179a
Cext_5325 \$1409 \$35 0.564032a
Cext_5326 \$1409 \$37 51.1437a
Cext_5327 \$1409 \$39 46.0291a
Cext_5328 \$1409 \$41 47.4094a
Cext_5329 \$1409 \$43 0.104586a
Cext_5330 \$1409 \$67 1.96577a
Cext_5331 \$1409 \$69 66.2231a
Cext_5332 \$1409 \$71 62.2724a
Cext_5333 \$1409 \$73 3.41995a
Cext_5334 \$1409 \$75 1.69678a
Cext_5335 \$1409 \$77 0.98091a
Cext_5336 \$1409 VSUBS 196.011a
Cext_5337 \$141 \$169 130.175a
Cext_5338 \$141 \$37 0.404672a
Cext_5339 \$141 \$41 0.115752a
Cext_5340 \$141 \$43 0.481837a
Cext_5341 \$141 \$45 20.9895a
Cext_5342 \$141 \$67 4.25617a
Cext_5343 \$141 VSS|vss 2.2008a
Cext_5344 \$141 VSUBS 675.619a
Cext_5345 \$1410 \$1423 114.006a
Cext_5346 \$1410 \$1424 0.182933a
Cext_5347 \$1410 \$1445 0.360462a
Cext_5348 \$1410 \$1457 108.267a
Cext_5349 \$1410 \$35 134.561a
Cext_5350 \$1410 \$37 19.3729a
Cext_5351 \$1410 \$39 1.32172a
Cext_5352 \$1410 \$67 69.8469a
Cext_5353 \$1410 \$69 117.46a
Cext_5354 \$1410 \$71 32.765a
Cext_5355 \$1410 \$73 32.5775a
Cext_5356 \$1410 \$75 35.6349a
Cext_5357 \$1410 \$77 45.7852a
Cext_5358 \$1410 IOVDD|vdda 41.3703a
Cext_5359 \$1410 VSS|vss 0.378848a
Cext_5360 \$1410 VSUBS 255.202a
Cext_5361 \$1411 \$1425 783.202a
Cext_5362 \$1411 \$1437 15.7815a
Cext_5363 \$1411 \$1486 83.8393a
Cext_5364 \$1411 \$1487 2.88751a
Cext_5365 \$1411 \$1513 7.41179a
Cext_5366 \$1411 \$35 0.564032a
Cext_5367 \$1411 \$37 51.1437a
Cext_5368 \$1411 \$39 46.0291a
Cext_5369 \$1411 \$41 47.4094a
Cext_5370 \$1411 \$43 0.104586a
Cext_5371 \$1411 \$67 1.96577a
Cext_5372 \$1411 \$69 66.2231a
Cext_5373 \$1411 \$71 62.2724a
Cext_5374 \$1411 \$73 3.41995a
Cext_5375 \$1411 \$75 1.69678a
Cext_5376 \$1411 \$77 0.98091a
Cext_5377 \$1411 VREF|vref 0.898171a
Cext_5378 \$1411 VSUBS 196.19a
Cext_5379 \$1412 \$1430 114.006a
Cext_5380 \$1412 \$1431 0.182933a
Cext_5381 \$1412 \$1451 0.360462a
Cext_5382 \$1412 \$1458 108.267a
Cext_5383 \$1412 \$51 134.708a
Cext_5384 \$1412 \$53 19.3729a
Cext_5385 \$1412 \$55 1.32172a
Cext_5386 \$1412 \$83 69.9941a
Cext_5387 \$1412 \$85 117.46a
Cext_5388 \$1412 \$87 32.765a
Cext_5389 \$1412 \$89 32.5775a
Cext_5390 \$1412 \$91 35.6349a
Cext_5391 \$1412 \$93 45.7852a
Cext_5392 \$1412 VSS|vss 0.378848a
Cext_5393 \$1412 VSUBS 255.476a
Cext_5394 \$1413 \$1432 783.202a
Cext_5395 \$1413 \$1438 15.7815a
Cext_5396 \$1413 \$1494 2.88751a
Cext_5397 \$1413 \$1495 83.8393a
Cext_5398 \$1413 \$1496 0.179323a
Cext_5399 \$1413 \$1520 7.41179a
Cext_5400 \$1413 \$51 0.564032a
Cext_5401 \$1413 \$53 51.1437a
Cext_5402 \$1413 \$55 46.0291a
Cext_5403 \$1413 \$57 47.4094a
Cext_5404 \$1413 \$59 0.104586a
Cext_5405 \$1413 \$83 1.96577a
Cext_5406 \$1413 \$85 66.2231a
Cext_5407 \$1413 \$87 62.2724a
Cext_5408 \$1413 \$89 3.41995a
Cext_5409 \$1413 \$91 1.69678a
Cext_5410 \$1413 \$93 0.98091a
Cext_5411 \$1413 VSUBS 196.011a
Cext_5412 \$1414 \$1433 114.006a
Cext_5413 \$1414 \$1434 0.182933a
Cext_5414 \$1414 \$1453 0.360462a
Cext_5415 \$1414 \$1459 108.267a
Cext_5416 \$1414 \$51 134.561a
Cext_5417 \$1414 \$53 19.3729a
Cext_5418 \$1414 \$55 1.32172a
Cext_5419 \$1414 \$83 69.8469a
Cext_5420 \$1414 \$85 117.46a
Cext_5421 \$1414 \$87 32.765a
Cext_5422 \$1414 \$89 32.5775a
Cext_5423 \$1414 \$91 35.6349a
Cext_5424 \$1414 \$93 45.7852a
Cext_5425 \$1414 IOVDD|vdda 41.3703a
Cext_5426 \$1414 VSS|vss 3.2484a
Cext_5427 \$1414 VSUBS 255.202a
Cext_5428 \$1415 \$1435 783.202a
Cext_5429 \$1415 \$1439 15.7815a
Cext_5430 \$1415 \$1498 83.8393a
Cext_5431 \$1415 \$1499 2.88751a
Cext_5432 \$1415 \$1523 7.41179a
Cext_5433 \$1415 \$51 0.564032a
Cext_5434 \$1415 \$53 51.1437a
Cext_5435 \$1415 \$55 46.0291a
Cext_5436 \$1415 \$57 47.4094a
Cext_5437 \$1415 \$59 0.104586a
Cext_5438 \$1415 \$83 1.96577a
Cext_5439 \$1415 \$85 66.2231a
Cext_5440 \$1415 \$87 62.2724a
Cext_5441 \$1415 \$89 3.41995a
Cext_5442 \$1415 \$91 1.69678a
Cext_5443 \$1415 \$93 0.98091a
Cext_5444 \$1415 VREF|vref 0.898171a
Cext_5445 \$1415 VSUBS 196.19a
Cext_5446 \$1416 \$1417 45.0654a
Cext_5447 \$1416 \$1440 130.175a
Cext_5448 \$1416 VDD|vdd 7.74075a
Cext_5449 \$1416 VSS|vss 1.71997a
Cext_5450 \$1416 VSUBS 659.267a
Cext_5451 \$1417 \$1418 45.0654a
Cext_5452 \$1417 \$1441 130.175a
Cext_5453 \$1417 VDD|vdd 0.968272a
Cext_5454 \$1417 VSUBS 634.529a
Cext_5455 \$1418 \$1419 45.0654a
Cext_5456 \$1418 \$1442 130.175a
Cext_5457 \$1418 VSUBS 634.529a
Cext_5458 \$1419 \$1420 46.4004a
Cext_5459 \$1419 \$1455 130.175a
Cext_5460 \$1419 VSS|vss 0.378729a
Cext_5461 \$1419 VSUBS 634.529a
Cext_5462 \$142 \$143 45.0654a
Cext_5463 \$142 \$170 130.058a
Cext_5464 \$142 VDD|vdd 0.592094a
Cext_5465 \$142 VSS|vss 156.555a
Cext_5466 \$142 VSUBS 659.267a
Cext_5467 \$1420 \$1443 254.864a
Cext_5468 \$1420 \$1456 0.360462a
Cext_5469 \$1420 \$35 68.8031a
Cext_5470 \$1420 \$67 64.1221a
Cext_5471 \$1420 \$69 0.155901a
Cext_5472 \$1420 VSS|vss 66.2906a
Cext_5473 \$1420 VSUBS 799.746a
Cext_5474 \$1421 \$1422 2.46853a
Cext_5475 \$1421 \$1436 102.889a
Cext_5476 \$1421 \$1444 225.319a
Cext_5477 \$1421 \$35 68.8428a
Cext_5478 \$1421 \$41 0.115752a
Cext_5479 \$1421 \$43 0.481837a
Cext_5480 \$1421 \$45 20.8391a
Cext_5481 \$1421 \$67 58.9193a
Cext_5482 \$1421 \$69 0.343978a
Cext_5483 \$1421 VSS|vss 60.9228a
Cext_5484 \$1421 VSUBS 811.534a
Cext_5485 \$1422 \$1423 0.179323a
Cext_5486 \$1422 \$1436 227.572a
Cext_5487 \$1422 \$1482 98.5952a
Cext_5488 \$1422 \$1549 1.46644a
Cext_5489 \$1422 \$35 2.95962a
Cext_5490 \$1422 \$37 91.0317a
Cext_5491 \$1422 \$39 1.18748a
Cext_5492 \$1422 \$41 0.476813a
Cext_5493 \$1422 \$69 106.511a
Cext_5494 \$1422 \$71 53.6367a
Cext_5495 \$1422 \$73 3.67334a
Cext_5496 \$1422 \$75 1.52179a
Cext_5497 \$1422 \$77 1.0724a
Cext_5498 \$1422 VSUBS 168.123a
Cext_5499 \$1423 \$1445 254.864a
Cext_5500 \$1423 \$1457 0.360462a
Cext_5501 \$1423 \$35 68.8031a
Cext_5502 \$1423 \$39 0.105966a
Cext_5503 \$1423 \$41 0.282145a
Cext_5504 \$1423 \$43 0.494517a
Cext_5505 \$1423 \$45 20.9159a
Cext_5506 \$1423 \$67 64.1221a
Cext_5507 \$1423 \$69 0.155901a
Cext_5508 \$1423 IOVDD|vdda 13.0646a
Cext_5509 \$1423 VSS|vss 66.2132a
Cext_5510 \$1423 VSUBS 817.468a
Cext_5511 \$1424 \$1425 2.46853a
Cext_5512 \$1424 \$1437 102.889a
Cext_5513 \$1424 \$1446 225.319a
Cext_5514 \$1424 \$35 68.8428a
Cext_5515 \$1424 \$41 0.115752a
Cext_5516 \$1424 \$43 0.481837a
Cext_5517 \$1424 \$45 20.8391a
Cext_5518 \$1424 \$67 58.9193a
Cext_5519 \$1424 \$69 0.343978a
Cext_5520 \$1424 VSS|vss 60.9228a
Cext_5521 \$1424 VSUBS 811.534a
Cext_5522 \$1425 \$1437 227.572a
Cext_5523 \$1425 \$1486 98.5952a
Cext_5524 \$1425 \$1551 1.46644a
Cext_5525 \$1425 \$35 2.95962a
Cext_5526 \$1425 \$37 91.0317a
Cext_5527 \$1425 \$39 1.18748a
Cext_5528 \$1425 \$41 0.476813a
Cext_5529 \$1425 \$69 106.511a
Cext_5530 \$1425 \$71 53.6367a
Cext_5531 \$1425 \$73 3.67334a
Cext_5532 \$1425 \$75 1.52179a
Cext_5533 \$1425 \$77 1.0724a
Cext_5534 \$1425 VREF|vref 0.489684a
Cext_5535 \$1425 VSUBS 168.123a
Cext_5536 \$1426 \$1427 45.0654a
Cext_5537 \$1426 \$1447 130.128a
Cext_5538 \$1426 VDD|vdd 0.592094a
Cext_5539 \$1426 VSS|vss 25.1792a
Cext_5540 \$1426 VSUBS 659.267a
Cext_5541 \$1427 \$1428 45.0654a
Cext_5542 \$1427 \$1448 130.175a
Cext_5543 \$1427 VSS|vss 5.452a
Cext_5544 \$1427 VSUBS 634.529a
Cext_5545 \$1428 \$1429 45.0654a
Cext_5546 \$1428 \$1449 130.175a
Cext_5547 \$1428 VSUBS 634.529a
Cext_5548 \$1429 \$1430 46.4004a
Cext_5549 \$1429 \$1450 130.175a
Cext_5550 \$1429 VSS|vss 0.378729a
Cext_5551 \$1429 VSUBS 634.529a
Cext_5552 \$143 \$144 45.0654a
Cext_5553 \$143 \$171 130.175a
Cext_5554 \$143 \$83 2.08919a
Cext_5555 \$143 VSS|vss 5.452a
Cext_5556 \$143 VSUBS 634.529a
Cext_5557 \$1430 \$1451 254.864a
Cext_5558 \$1430 \$1458 0.360462a
Cext_5559 \$1430 \$51 68.8031a
Cext_5560 \$1430 \$83 64.1221a
Cext_5561 \$1430 \$85 0.155901a
Cext_5562 \$1430 VSS|vss 66.2906a
Cext_5563 \$1430 VSUBS 799.746a
Cext_5564 \$1431 \$1432 2.46853a
Cext_5565 \$1431 \$1438 102.889a
Cext_5566 \$1431 \$1452 225.319a
Cext_5567 \$1431 \$51 68.8428a
Cext_5568 \$1431 \$57 0.115752a
Cext_5569 \$1431 \$59 0.481837a
Cext_5570 \$1431 \$61 20.8391a
Cext_5571 \$1431 \$83 58.9193a
Cext_5572 \$1431 \$85 0.343978a
Cext_5573 \$1431 VSS|vss 60.9228a
Cext_5574 \$1431 VSUBS 811.534a
Cext_5575 \$1432 \$1433 0.179323a
Cext_5576 \$1432 \$1438 227.572a
Cext_5577 \$1432 \$1495 98.5952a
Cext_5578 \$1432 \$1553 1.46644a
Cext_5579 \$1432 \$51 2.95962a
Cext_5580 \$1432 \$53 91.0317a
Cext_5581 \$1432 \$55 1.18748a
Cext_5582 \$1432 \$57 0.476813a
Cext_5583 \$1432 \$85 106.511a
Cext_5584 \$1432 \$87 53.6367a
Cext_5585 \$1432 \$89 3.67334a
Cext_5586 \$1432 \$91 1.52179a
Cext_5587 \$1432 \$93 1.0724a
Cext_5588 \$1432 VSUBS 168.123a
Cext_5589 \$1433 \$1453 254.864a
Cext_5590 \$1433 \$1459 0.360462a
Cext_5591 \$1433 \$51 68.8031a
Cext_5592 \$1433 \$55 0.105966a
Cext_5593 \$1433 \$57 0.282145a
Cext_5594 \$1433 \$59 0.494517a
Cext_5595 \$1433 \$61 20.9159a
Cext_5596 \$1433 \$83 64.1221a
Cext_5597 \$1433 \$85 0.155901a
Cext_5598 \$1433 IOVDD|vdda 13.0646a
Cext_5599 \$1433 VSS|vss 66.2132a
Cext_5600 \$1433 VSUBS 817.468a
Cext_5601 \$1434 \$1435 2.46853a
Cext_5602 \$1434 \$1439 102.889a
Cext_5603 \$1434 \$1454 225.319a
Cext_5604 \$1434 \$51 68.8428a
Cext_5605 \$1434 \$57 0.115752a
Cext_5606 \$1434 \$59 0.481837a
Cext_5607 \$1434 \$61 20.8391a
Cext_5608 \$1434 \$83 58.9193a
Cext_5609 \$1434 \$85 0.343978a
Cext_5610 \$1434 VSS|vss 69.9251a
Cext_5611 \$1434 VSUBS 811.534a
Cext_5612 \$1435 \$1439 227.572a
Cext_5613 \$1435 \$1498 98.5952a
Cext_5614 \$1435 \$1555 1.46644a
Cext_5615 \$1435 \$51 2.95962a
Cext_5616 \$1435 \$53 91.0317a
Cext_5617 \$1435 \$55 1.18748a
Cext_5618 \$1435 \$57 0.476813a
Cext_5619 \$1435 \$85 106.511a
Cext_5620 \$1435 \$87 53.6367a
Cext_5621 \$1435 \$89 3.67334a
Cext_5622 \$1435 \$91 1.52179a
Cext_5623 \$1435 \$93 1.0724a
Cext_5624 \$1435 VREF|vref 0.489684a
Cext_5625 \$1435 VSUBS 168.123a
Cext_5626 \$1436 \$1444 114.006a
Cext_5627 \$1436 \$1445 0.182933a
Cext_5628 \$1436 \$1465 0.360462a
Cext_5629 \$1436 \$1482 108.267a
Cext_5630 \$1436 \$35 123.657a
Cext_5631 \$1436 \$37 65.6459a
Cext_5632 \$1436 \$39 0.62262a
Cext_5633 \$1436 \$67 80.1821a
Cext_5634 \$1436 \$69 70.7638a
Cext_5635 \$1436 \$71 33.9629a
Cext_5636 \$1436 \$73 32.5775a
Cext_5637 \$1436 \$75 35.6349a
Cext_5638 \$1436 \$77 45.7852a
Cext_5639 \$1436 VSS|vss 0.378848a
Cext_5640 \$1436 VSUBS 255.747a
Cext_5641 \$1437 \$1446 114.006a
Cext_5642 \$1437 \$1467 0.360462a
Cext_5643 \$1437 \$1486 108.267a
Cext_5644 \$1437 \$35 123.657a
Cext_5645 \$1437 \$37 65.6459a
Cext_5646 \$1437 \$39 0.62262a
Cext_5647 \$1437 \$67 80.1821a
Cext_5648 \$1437 \$69 70.7638a
Cext_5649 \$1437 \$71 33.9629a
Cext_5650 \$1437 \$73 32.5775a
Cext_5651 \$1437 \$75 35.6349a
Cext_5652 \$1437 \$77 45.7852a
Cext_5653 \$1437 VREF|vref 0.182933a
Cext_5654 \$1437 VSS|vss 0.378848a
Cext_5655 \$1437 VSUBS 255.747a
Cext_5656 \$1438 \$1452 114.006a
Cext_5657 \$1438 \$1453 0.182933a
Cext_5658 \$1438 \$1473 0.360462a
Cext_5659 \$1438 \$1495 108.267a
Cext_5660 \$1438 \$51 123.657a
Cext_5661 \$1438 \$53 65.6459a
Cext_5662 \$1438 \$55 0.62262a
Cext_5663 \$1438 \$83 80.1821a
Cext_5664 \$1438 \$85 70.7638a
Cext_5665 \$1438 \$87 33.9629a
Cext_5666 \$1438 \$89 32.5775a
Cext_5667 \$1438 \$91 35.6349a
Cext_5668 \$1438 \$93 45.7852a
Cext_5669 \$1438 VSS|vss 0.378848a
Cext_5670 \$1438 VSUBS 255.747a
Cext_5671 \$1439 \$1454 114.006a
Cext_5672 \$1439 \$1475 0.360462a
Cext_5673 \$1439 \$1498 108.267a
Cext_5674 \$1439 \$51 123.657a
Cext_5675 \$1439 \$53 65.6459a
Cext_5676 \$1439 \$55 0.62262a
Cext_5677 \$1439 \$83 80.1821a
Cext_5678 \$1439 \$85 70.7638a
Cext_5679 \$1439 \$87 33.9629a
Cext_5680 \$1439 \$89 32.5775a
Cext_5681 \$1439 \$91 35.6349a
Cext_5682 \$1439 \$93 45.7852a
Cext_5683 \$1439 VREF|vref 0.182933a
Cext_5684 \$1439 VSS|vss 0.378848a
Cext_5685 \$1439 VSUBS 255.747a
Cext_5686 \$144 \$156 45.0654a
Cext_5687 \$144 \$172 130.175a
Cext_5688 \$144 \$83 4.40063a
Cext_5689 \$144 VSUBS 634.529a
Cext_5690 \$1440 \$1441 45.0654a
Cext_5691 \$1440 \$1460 130.175a
Cext_5692 \$1440 VDD|vdd 7.74075a
Cext_5693 \$1440 VSS|vss 1.71997a
Cext_5694 \$1440 VSUBS 659.267a
Cext_5695 \$1441 \$1442 45.0654a
Cext_5696 \$1441 \$1461 130.175a
Cext_5697 \$1441 VDD|vdd 0.968272a
Cext_5698 \$1441 VSUBS 634.529a
Cext_5699 \$1442 \$1455 45.0654a
Cext_5700 \$1442 \$1462 130.175a
Cext_5701 \$1442 VSUBS 634.529a
Cext_5702 \$1443 \$1455 45.8951a
Cext_5703 \$1443 \$1456 113.058a
Cext_5704 \$1443 \$1464 225.319a
Cext_5705 \$1443 \$35 22.6915a
Cext_5706 \$1443 \$67 105.489a
Cext_5707 \$1443 VSS|vss 61.1015a
Cext_5708 \$1443 VSUBS 793.257a
Cext_5709 \$1444 \$1456 0.182933a
Cext_5710 \$1444 \$1465 254.864a
Cext_5711 \$1444 \$1482 0.360462a
Cext_5712 \$1444 \$35 23.2117a
Cext_5713 \$1444 \$37 0.145978a
Cext_5714 \$1444 \$39 0.105966a
Cext_5715 \$1444 \$41 0.282145a
Cext_5716 \$1444 \$43 0.494517a
Cext_5717 \$1444 \$45 20.7622a
Cext_5718 \$1444 \$67 110.011a
Cext_5719 \$1444 VSS|vss 66.2132a
Cext_5720 \$1444 VSUBS 817.35a
Cext_5721 \$1445 \$1457 113.058a
Cext_5722 \$1445 \$1466 225.319a
Cext_5723 \$1445 \$35 22.6915a
Cext_5724 \$1445 \$37 0.404672a
Cext_5725 \$1445 \$41 0.115752a
Cext_5726 \$1445 \$43 0.481837a
Cext_5727 \$1445 \$45 20.8391a
Cext_5728 \$1445 \$67 105.489a
Cext_5729 \$1445 IOVDD|vdda 11.5102a
Cext_5730 \$1445 VSS|vss 60.9228a
Cext_5731 \$1445 VSUBS 810.376a
Cext_5732 \$1446 \$1457 0.182933a
Cext_5733 \$1446 \$1467 254.864a
Cext_5734 \$1446 \$1486 0.360462a
Cext_5735 \$1446 \$35 23.2117a
Cext_5736 \$1446 \$37 0.145978a
Cext_5737 \$1446 \$39 0.105966a
Cext_5738 \$1446 \$41 0.282145a
Cext_5739 \$1446 \$43 0.494517a
Cext_5740 \$1446 \$45 20.7622a
Cext_5741 \$1446 \$67 110.011a
Cext_5742 \$1446 VSS|vss 66.2132a
Cext_5743 \$1446 VSUBS 817.35a
Cext_5744 \$1447 \$1448 45.0654a
Cext_5745 \$1447 \$1468 130.128a
Cext_5746 \$1447 VDD|vdd 0.592094a
Cext_5747 \$1447 VSS|vss 25.1792a
Cext_5748 \$1447 VSUBS 659.267a
Cext_5749 \$1448 \$1449 45.0654a
Cext_5750 \$1448 \$1469 130.175a
Cext_5751 \$1448 VSS|vss 5.452a
Cext_5752 \$1448 VSUBS 634.529a
Cext_5753 \$1449 \$1450 45.0654a
Cext_5754 \$1449 \$1470 130.175a
Cext_5755 \$1449 VSUBS 634.529a
Cext_5756 \$145 \$156 45.8951a
Cext_5757 \$145 \$174 225.319a
Cext_5758 \$145 \$175 113.058a
Cext_5759 \$145 \$51 22.6915a
Cext_5760 \$145 \$83 110.208a
Cext_5761 \$145 VSS|vss 61.1015a
Cext_5762 \$145 VSUBS 793.257a
Cext_5763 \$1450 \$1451 45.8951a
Cext_5764 \$1450 \$1471 130.175a
Cext_5765 \$1450 VSS|vss 0.428128a
Cext_5766 \$1450 VSUBS 634.529a
Cext_5767 \$1451 \$1458 113.058a
Cext_5768 \$1451 \$1472 225.319a
Cext_5769 \$1451 \$51 22.6915a
Cext_5770 \$1451 \$83 105.489a
Cext_5771 \$1451 VSS|vss 61.1015a
Cext_5772 \$1451 VSUBS 793.257a
Cext_5773 \$1452 \$1458 0.182933a
Cext_5774 \$1452 \$1473 254.864a
Cext_5775 \$1452 \$1495 0.360462a
Cext_5776 \$1452 \$51 23.2117a
Cext_5777 \$1452 \$53 0.145978a
Cext_5778 \$1452 \$55 0.105966a
Cext_5779 \$1452 \$57 0.282145a
Cext_5780 \$1452 \$59 0.494517a
Cext_5781 \$1452 \$61 20.7622a
Cext_5782 \$1452 \$83 110.011a
Cext_5783 \$1452 VSS|vss 66.2132a
Cext_5784 \$1452 VSUBS 817.35a
Cext_5785 \$1453 \$1459 113.058a
Cext_5786 \$1453 \$1474 225.319a
Cext_5787 \$1453 \$51 22.6915a
Cext_5788 \$1453 \$53 0.404672a
Cext_5789 \$1453 \$57 0.115752a
Cext_5790 \$1453 \$59 0.481837a
Cext_5791 \$1453 \$61 20.8391a
Cext_5792 \$1453 \$83 105.489a
Cext_5793 \$1453 IOVDD|vdda 11.5102a
Cext_5794 \$1453 VSS|vss 60.9228a
Cext_5795 \$1453 VSUBS 810.376a
Cext_5796 \$1454 \$1459 0.182933a
Cext_5797 \$1454 \$1475 254.864a
Cext_5798 \$1454 \$1498 0.360462a
Cext_5799 \$1454 \$51 23.2117a
Cext_5800 \$1454 \$53 0.145978a
Cext_5801 \$1454 \$55 0.105966a
Cext_5802 \$1454 \$57 0.282145a
Cext_5803 \$1454 \$59 0.494517a
Cext_5804 \$1454 \$61 20.7622a
Cext_5805 \$1454 \$83 110.011a
Cext_5806 \$1454 VSS|vss 75.4228a
Cext_5807 \$1454 VSUBS 817.35a
Cext_5808 \$1455 \$1463 130.175a
Cext_5809 \$1455 VSS|vss 0.428128a
Cext_5810 \$1455 VSUBS 634.529a
Cext_5811 \$1456 \$1464 102.889a
Cext_5812 \$1456 \$1480 0.360462a
Cext_5813 \$1456 \$1500 42.153a
Cext_5814 \$1456 \$35 123.657a
Cext_5815 \$1456 \$37 65.4666a
Cext_5816 \$1456 \$41 0.62262a
Cext_5817 \$1456 \$67 80.1249a
Cext_5818 \$1456 \$69 70.7638a
Cext_5819 \$1456 \$71 31.3588a
Cext_5820 \$1456 \$73 36.0014a
Cext_5821 \$1456 \$75 35.6349a
Cext_5822 \$1456 \$77 45.8508a
Cext_5823 \$1456 VSS|vss 0.335662a
Cext_5824 \$1456 VSUBS 257.974a
Cext_5825 \$1457 \$1466 102.889a
Cext_5826 \$1457 \$1484 0.360462a
Cext_5827 \$1457 \$1501 42.153a
Cext_5828 \$1457 \$35 123.51a
Cext_5829 \$1457 \$37 65.4666a
Cext_5830 \$1457 \$41 0.62262a
Cext_5831 \$1457 \$67 79.9778a
Cext_5832 \$1457 \$69 70.7638a
Cext_5833 \$1457 \$71 31.3588a
Cext_5834 \$1457 \$73 36.0014a
Cext_5835 \$1457 \$75 35.6349a
Cext_5836 \$1457 \$77 45.8508a
Cext_5837 \$1457 IOVDD|vdda 41.5734a
Cext_5838 \$1457 VSS|vss 0.335662a
Cext_5839 \$1457 VSUBS 257.7a
Cext_5840 \$1458 \$1472 102.889a
Cext_5841 \$1458 \$1492 0.360462a
Cext_5842 \$1458 \$1502 42.153a
Cext_5843 \$1458 \$51 123.657a
Cext_5844 \$1458 \$53 65.4666a
Cext_5845 \$1458 \$57 0.62262a
Cext_5846 \$1458 \$83 80.1249a
Cext_5847 \$1458 \$85 70.7638a
Cext_5848 \$1458 \$87 31.3588a
Cext_5849 \$1458 \$89 36.0014a
Cext_5850 \$1458 \$91 35.6349a
Cext_5851 \$1458 \$93 45.8508a
Cext_5852 \$1458 VSS|vss 0.335662a
Cext_5853 \$1458 VSUBS 257.974a
Cext_5854 \$1459 \$1474 102.889a
Cext_5855 \$1459 \$1496 0.360462a
Cext_5856 \$1459 \$1503 42.153a
Cext_5857 \$1459 \$51 123.51a
Cext_5858 \$1459 \$53 65.4666a
Cext_5859 \$1459 \$57 0.62262a
Cext_5860 \$1459 \$83 79.9778a
Cext_5861 \$1459 \$85 70.7638a
Cext_5862 \$1459 \$87 31.3588a
Cext_5863 \$1459 \$89 36.0014a
Cext_5864 \$1459 \$91 35.6349a
Cext_5865 \$1459 \$93 45.8508a
Cext_5866 \$1459 IOVDD|vdda 41.5734a
Cext_5867 \$1459 VSS|vss 3.81768a
Cext_5868 \$1459 VSUBS 257.7a
Cext_5869 \$146 \$147 1.85779a
Cext_5870 \$146 \$174 3.25406a
Cext_5871 \$146 \$175 231.736a
Cext_5872 \$146 \$176 1.44306a
Cext_5873 \$146 \$203 99.1454a
Cext_5874 \$146 \$204 7.41179a
Cext_5875 \$146 \$51 3.05553a
Cext_5876 \$146 \$53 103.932a
Cext_5877 \$146 \$55 4.04423a
Cext_5878 \$146 \$57 1.62297a
Cext_5879 \$146 \$59 0.919893a
Cext_5880 \$146 \$61 0.703335a
Cext_5881 \$146 \$83 1.00326a
Cext_5882 \$146 \$85 106.353a
Cext_5883 \$146 \$87 53.8929a
Cext_5884 \$146 \$89 4.01016a
Cext_5885 \$146 \$91 1.61371a
Cext_5886 \$146 \$93 1.13718a
Cext_5887 \$146 VSUBS 230.078a
Cext_5888 \$1460 \$1461 45.0654a
Cext_5889 \$1460 \$1476 130.175a
Cext_5890 \$1460 VDD|vdd 7.74075a
Cext_5891 \$1460 VSS|vss 1.71997a
Cext_5892 \$1460 VSUBS 659.267a
Cext_5893 \$1461 \$1462 45.0654a
Cext_5894 \$1461 \$1477 130.175a
Cext_5895 \$1461 VDD|vdd 0.968272a
Cext_5896 \$1461 VSUBS 634.529a
Cext_5897 \$1462 \$1463 45.0654a
Cext_5898 \$1462 \$1478 130.175a
Cext_5899 \$1462 VSUBS 634.529a
Cext_5900 \$1463 \$1464 46.4004a
Cext_5901 \$1463 \$1479 130.175a
Cext_5902 \$1463 VSS|vss 0.378729a
Cext_5903 \$1463 VSUBS 634.529a
Cext_5904 \$1464 \$1480 254.864a
Cext_5905 \$1464 \$1500 0.360462a
Cext_5906 \$1464 \$35 69.0342a
Cext_5907 \$1464 \$67 64.2241a
Cext_5908 \$1464 \$73 0.182934a
Cext_5909 \$1464 \$77 0.107779a
Cext_5910 \$1464 VSS|vss 66.2906a
Cext_5911 \$1464 VSUBS 801.109a
Cext_5912 \$1465 \$1482 113.058a
Cext_5913 \$1465 \$1483 225.319a
Cext_5914 \$1465 \$35 68.7272a
Cext_5915 \$1465 \$41 0.115752a
Cext_5916 \$1465 \$43 0.481837a
Cext_5917 \$1465 \$45 20.9928a
Cext_5918 \$1465 \$67 58.9193a
Cext_5919 \$1465 \$73 0.343978a
Cext_5920 \$1465 VSS|vss 60.9228a
Cext_5921 \$1465 VSUBS 810.856a
Cext_5922 \$1466 \$1482 0.182933a
Cext_5923 \$1466 \$1484 254.864a
Cext_5924 \$1466 \$1501 0.360462a
Cext_5925 \$1466 \$35 69.0342a
Cext_5926 \$1466 \$39 0.105966a
Cext_5927 \$1466 \$41 0.282145a
Cext_5928 \$1466 \$43 0.494517a
Cext_5929 \$1466 \$45 20.7622a
Cext_5930 \$1466 \$67 64.2241a
Cext_5931 \$1466 \$73 0.182934a
Cext_5932 \$1466 \$77 0.107779a
Cext_5933 \$1466 IOVDD|vdda 13.2807a
Cext_5934 \$1466 VSS|vss 66.2132a
Cext_5935 \$1466 VSUBS 818.832a
Cext_5936 \$1467 \$1486 113.058a
Cext_5937 \$1467 \$1487 225.319a
Cext_5938 \$1467 \$35 68.7272a
Cext_5939 \$1467 \$41 0.115752a
Cext_5940 \$1467 \$43 0.481837a
Cext_5941 \$1467 \$45 20.9928a
Cext_5942 \$1467 \$67 58.9193a
Cext_5943 \$1467 \$73 0.343978a
Cext_5944 \$1467 VSS|vss 60.9228a
Cext_5945 \$1467 VSUBS 810.856a
Cext_5946 \$1468 \$1469 45.0654a
Cext_5947 \$1468 \$1488 130.128a
Cext_5948 \$1468 VDD|vdd 0.592094a
Cext_5949 \$1468 VSS|vss 25.1792a
Cext_5950 \$1468 VSUBS 659.267a
Cext_5951 \$1469 \$1470 45.0654a
Cext_5952 \$1469 \$1489 130.175a
Cext_5953 \$1469 VSS|vss 5.452a
Cext_5954 \$1469 VSUBS 634.529a
Cext_5955 \$147 \$148 114.006a
Cext_5956 \$147 \$175 0.182933a
Cext_5957 \$147 \$176 254.864a
Cext_5958 \$147 \$205 0.360462a
Cext_5959 \$147 \$51 23.2117a
Cext_5960 \$147 \$53 0.145978a
Cext_5961 \$147 \$55 0.105966a
Cext_5962 \$147 \$57 0.282145a
Cext_5963 \$147 \$59 0.494517a
Cext_5964 \$147 \$61 20.7622a
Cext_5965 \$147 \$83 114.799a
Cext_5966 \$147 VSS|vss 66.2132a
Cext_5967 \$147 VSUBS 817.643a
Cext_5968 \$1470 \$1471 45.0654a
Cext_5969 \$1470 \$1490 130.175a
Cext_5970 \$1470 VSUBS 634.529a
Cext_5971 \$1471 \$1472 46.4004a
Cext_5972 \$1471 \$1491 130.175a
Cext_5973 \$1471 VSS|vss 0.378729a
Cext_5974 \$1471 VSUBS 634.529a
Cext_5975 \$1472 \$1492 254.864a
Cext_5976 \$1472 \$1502 0.360462a
Cext_5977 \$1472 \$51 69.0342a
Cext_5978 \$1472 \$83 64.2241a
Cext_5979 \$1472 \$89 0.182934a
Cext_5980 \$1472 \$93 0.107779a
Cext_5981 \$1472 VSS|vss 66.2906a
Cext_5982 \$1472 VSUBS 801.109a
Cext_5983 \$1473 \$1494 225.319a
Cext_5984 \$1473 \$1495 113.058a
Cext_5985 \$1473 \$51 68.7272a
Cext_5986 \$1473 \$57 0.115752a
Cext_5987 \$1473 \$59 0.481837a
Cext_5988 \$1473 \$61 20.9928a
Cext_5989 \$1473 \$83 58.9193a
Cext_5990 \$1473 \$89 0.343978a
Cext_5991 \$1473 VSS|vss 60.9228a
Cext_5992 \$1473 VSUBS 810.856a
Cext_5993 \$1474 \$1495 0.182933a
Cext_5994 \$1474 \$1496 254.864a
Cext_5995 \$1474 \$1503 0.360462a
Cext_5996 \$1474 \$51 69.0342a
Cext_5997 \$1474 \$55 0.105966a
Cext_5998 \$1474 \$57 0.282145a
Cext_5999 \$1474 \$59 0.494517a
Cext_6000 \$1474 \$61 20.7622a
Cext_6001 \$1474 \$83 64.2241a
Cext_6002 \$1474 \$89 0.182934a
Cext_6003 \$1474 \$93 0.107779a
Cext_6004 \$1474 IOVDD|vdda 13.2807a
Cext_6005 \$1474 VSS|vss 66.2132a
Cext_6006 \$1474 VSUBS 818.832a
Cext_6007 \$1475 \$1498 113.058a
Cext_6008 \$1475 \$1499 225.319a
Cext_6009 \$1475 \$51 68.7272a
Cext_6010 \$1475 \$57 0.115752a
Cext_6011 \$1475 \$59 0.481837a
Cext_6012 \$1475 \$61 20.9928a
Cext_6013 \$1475 \$83 58.9193a
Cext_6014 \$1475 \$89 0.343978a
Cext_6015 \$1475 VSS|vss 69.9251a
Cext_6016 \$1475 VSUBS 810.856a
Cext_6017 \$1476 \$1477 45.0654a
Cext_6018 \$1476 \$1504 130.175a
Cext_6019 \$1476 VDD|vdd 7.74075a
Cext_6020 \$1476 VSS|vss 1.71997a
Cext_6021 \$1476 VSUBS 659.267a
Cext_6022 \$1477 \$1478 45.0654a
Cext_6023 \$1477 \$1505 130.175a
Cext_6024 \$1477 VDD|vdd 0.968272a
Cext_6025 \$1477 VSUBS 634.529a
Cext_6026 \$1478 \$1479 45.0654a
Cext_6027 \$1478 \$1506 130.175a
Cext_6028 \$1478 VSUBS 634.529a
Cext_6029 \$1479 \$1480 45.8951a
Cext_6030 \$1479 \$1507 130.175a
Cext_6031 \$1479 VSS|vss 0.428128a
Cext_6032 \$1479 VSUBS 634.529a
Cext_6033 \$148 \$149 0.709993a
Cext_6034 \$148 \$176 0.360462a
Cext_6035 \$148 \$177 98.5952a
Cext_6036 \$148 \$205 108.267a
Cext_6037 \$148 \$51 123.256a
Cext_6038 \$148 \$53 66.5956a
Cext_6039 \$148 \$55 0.280546a
Cext_6040 \$148 \$57 0.131796a
Cext_6041 \$148 \$59 0.112844a
Cext_6042 \$148 \$83 80.1395a
Cext_6043 \$148 \$85 70.312a
Cext_6044 \$148 \$87 30.8484a
Cext_6045 \$148 \$89 31.8692a
Cext_6046 \$148 \$91 34.9266a
Cext_6047 \$148 \$93 45.0769a
Cext_6048 \$148 VSS|vss 0.378848a
Cext_6049 \$148 VSUBS 289.954a
Cext_6050 \$1480 \$1481 2.16563a
Cext_6051 \$1480 \$1500 102.889a
Cext_6052 \$1480 \$1508 225.319a
Cext_6053 \$1480 \$35 22.8071a
Cext_6054 \$1480 \$67 105.694a
Cext_6055 \$1480 VSS|vss 61.1015a
Cext_6056 \$1480 VSUBS 794.068a
Cext_6057 \$1481 \$1483 4.40425a
Cext_6058 \$1481 \$1500 86.9579a
Cext_6059 \$1481 \$1509 3.88628a
Cext_6060 \$1481 \$1524 789.439a
Cext_6061 \$1481 \$1537 4.39525a
Cext_6062 \$1481 \$1548 18.9a
Cext_6063 \$1481 \$1561 3.88628a
Cext_6064 \$1481 \$1581 99.1454a
Cext_6065 \$1481 \$1600 0.250757a
Cext_6066 \$1481 \$1667 1.28787a
Cext_6067 \$1481 \$35 0.564032a
Cext_6068 \$1481 \$37 74.0819a
Cext_6069 \$1481 \$39 56.1301a
Cext_6070 \$1481 \$41 53.1802a
Cext_6071 \$1481 \$43 3.23549a
Cext_6072 \$1481 \$45 1.94547a
Cext_6073 \$1481 \$67 1.96577a
Cext_6074 \$1481 \$69 71.1115a
Cext_6075 \$1481 \$71 67.4298a
Cext_6076 \$1481 \$73 3.41995a
Cext_6077 \$1481 \$75 1.56603a
Cext_6078 \$1481 \$77 0.98091a
Cext_6079 \$1481 VSUBS 321.376a
Cext_6080 \$1482 \$1483 102.889a
Cext_6081 \$1482 \$1509 0.360462a
Cext_6082 \$1482 \$1525 42.153a
Cext_6083 \$1482 \$35 134.708a
Cext_6084 \$1482 \$37 19.3729a
Cext_6085 \$1482 \$41 1.33033a
Cext_6086 \$1482 \$67 69.937a
Cext_6087 \$1482 \$69 117.28a
Cext_6088 \$1482 \$71 31.3588a
Cext_6089 \$1482 \$73 34.4538a
Cext_6090 \$1482 \$75 35.6349a
Cext_6091 \$1482 \$77 45.8508a
Cext_6092 \$1482 VSS|vss 0.335662a
Cext_6093 \$1482 VSUBS 257.767a
Cext_6094 \$1483 \$1509 254.864a
Cext_6095 \$1483 \$1525 0.360462a
Cext_6096 \$1483 \$35 23.4429a
Cext_6097 \$1483 \$39 0.105966a
Cext_6098 \$1483 \$41 0.428122a
Cext_6099 \$1483 \$43 0.494517a
Cext_6100 \$1483 \$45 20.9159a
Cext_6101 \$1483 \$67 110.113a
Cext_6102 \$1483 \$77 0.107779a
Cext_6103 \$1483 VSS|vss 66.2132a
Cext_6104 \$1483 VSUBS 818.85a
Cext_6105 \$1484 \$1485 2.16563a
Cext_6106 \$1484 \$1501 102.889a
Cext_6107 \$1484 \$1511 225.319a
Cext_6108 \$1484 \$35 22.8071a
Cext_6109 \$1484 \$41 0.772242a
Cext_6110 \$1484 \$43 0.481837a
Cext_6111 \$1484 \$45 20.9928a
Cext_6112 \$1484 \$67 105.694a
Cext_6113 \$1484 IOVDD|vdda 11.6291a
Cext_6114 \$1484 VSS|vss 60.9228a
Cext_6115 \$1484 VSUBS 810.857a
Cext_6116 \$1485 \$1487 4.40425a
Cext_6117 \$1485 \$1501 86.9579a
Cext_6118 \$1485 \$1512 3.88628a
Cext_6119 \$1485 \$1526 789.439a
Cext_6120 \$1485 \$1539 4.39525a
Cext_6121 \$1485 \$1550 18.9a
Cext_6122 \$1485 \$1563 3.88628a
Cext_6123 \$1485 \$1584 99.1454a
Cext_6124 \$1485 \$1604 0.250757a
Cext_6125 \$1485 \$1668 1.28787a
Cext_6126 \$1485 \$35 0.564032a
Cext_6127 \$1485 \$37 74.0819a
Cext_6128 \$1485 \$39 56.1301a
Cext_6129 \$1485 \$41 53.1802a
Cext_6130 \$1485 \$43 3.23549a
Cext_6131 \$1485 \$45 1.94547a
Cext_6132 \$1485 \$67 1.96577a
Cext_6133 \$1485 \$69 71.1115a
Cext_6134 \$1485 \$71 67.4298a
Cext_6135 \$1485 \$73 3.41995a
Cext_6136 \$1485 \$75 1.56603a
Cext_6137 \$1485 \$77 0.98091a
Cext_6138 \$1485 IOVDD|vdda 7.75332a
Cext_6139 \$1485 VSUBS 321.376a
Cext_6140 \$1486 \$1487 102.889a
Cext_6141 \$1486 \$1512 0.360462a
Cext_6142 \$1486 \$1527 42.153a
Cext_6143 \$1486 \$35 134.708a
Cext_6144 \$1486 \$37 19.3729a
Cext_6145 \$1486 \$41 1.33033a
Cext_6146 \$1486 \$67 69.937a
Cext_6147 \$1486 \$69 117.28a
Cext_6148 \$1486 \$71 31.3588a
Cext_6149 \$1486 \$73 34.4538a
Cext_6150 \$1486 \$75 35.6349a
Cext_6151 \$1486 \$77 45.8508a
Cext_6152 \$1486 VREF|vref 0.182933a
Cext_6153 \$1486 VSS|vss 0.335662a
Cext_6154 \$1486 VSUBS 257.767a
Cext_6155 \$1487 \$1512 254.864a
Cext_6156 \$1487 \$1527 0.360462a
Cext_6157 \$1487 \$35 23.4429a
Cext_6158 \$1487 \$39 0.105966a
Cext_6159 \$1487 \$41 0.428122a
Cext_6160 \$1487 \$43 0.494517a
Cext_6161 \$1487 \$45 20.9159a
Cext_6162 \$1487 \$67 110.113a
Cext_6163 \$1487 \$77 0.107779a
Cext_6164 \$1487 VSS|vss 66.2132a
Cext_6165 \$1487 VSUBS 818.85a
Cext_6166 \$1488 \$1489 45.0654a
Cext_6167 \$1488 \$1514 130.128a
Cext_6168 \$1488 VDD|vdd 0.592094a
Cext_6169 \$1488 VSS|vss 25.1792a
Cext_6170 \$1488 VSUBS 659.267a
Cext_6171 \$1489 \$1490 45.0654a
Cext_6172 \$1489 \$1515 130.175a
Cext_6173 \$1489 VSS|vss 5.452a
Cext_6174 \$1489 VSUBS 634.529a
Cext_6175 \$149 \$178 113.058a
Cext_6176 \$149 \$179 225.319a
Cext_6177 \$149 \$51 22.6915a
Cext_6178 \$149 \$53 0.404672a
Cext_6179 \$149 \$57 0.115752a
Cext_6180 \$149 \$59 0.481837a
Cext_6181 \$149 \$61 20.8391a
Cext_6182 \$149 \$83 110.208a
Cext_6183 \$149 IOVDD|vdda 11.5102a
Cext_6184 \$149 VSS|vss 60.9228a
Cext_6185 \$149 VSUBS 810.657a
Cext_6186 \$1490 \$1491 45.0654a
Cext_6187 \$1490 \$1516 130.175a
Cext_6188 \$1490 VSUBS 634.529a
Cext_6189 \$1491 \$1492 45.8951a
Cext_6190 \$1491 \$1517 130.175a
Cext_6191 \$1491 VSS|vss 0.428128a
Cext_6192 \$1491 VSUBS 634.529a
Cext_6193 \$1492 \$1493 2.16563a
Cext_6194 \$1492 \$1502 102.889a
Cext_6195 \$1492 \$1518 225.319a
Cext_6196 \$1492 \$51 22.8071a
Cext_6197 \$1492 \$83 105.694a
Cext_6198 \$1492 VSS|vss 61.1015a
Cext_6199 \$1492 VSUBS 794.068a
Cext_6200 \$1493 \$1494 4.40425a
Cext_6201 \$1493 \$1502 86.9579a
Cext_6202 \$1493 \$1519 3.88628a
Cext_6203 \$1493 \$1528 789.439a
Cext_6204 \$1493 \$1545 4.39525a
Cext_6205 \$1493 \$1552 18.9a
Cext_6206 \$1493 \$1569 3.88628a
Cext_6207 \$1493 \$1591 99.1454a
Cext_6208 \$1493 \$1613 0.250757a
Cext_6209 \$1493 \$1670 1.28787a
Cext_6210 \$1493 \$51 0.564032a
Cext_6211 \$1493 \$53 74.0819a
Cext_6212 \$1493 \$55 56.1301a
Cext_6213 \$1493 \$57 53.1802a
Cext_6214 \$1493 \$59 3.23549a
Cext_6215 \$1493 \$61 1.94547a
Cext_6216 \$1493 \$83 1.96577a
Cext_6217 \$1493 \$85 71.1115a
Cext_6218 \$1493 \$87 67.4298a
Cext_6219 \$1493 \$89 3.41995a
Cext_6220 \$1493 \$91 1.56603a
Cext_6221 \$1493 \$93 0.98091a
Cext_6222 \$1493 VSUBS 321.376a
Cext_6223 \$1494 \$1495 102.889a
Cext_6224 \$1494 \$1519 254.864a
Cext_6225 \$1494 \$1529 0.360462a
Cext_6226 \$1494 \$51 23.4429a
Cext_6227 \$1494 \$55 0.105966a
Cext_6228 \$1494 \$57 0.428122a
Cext_6229 \$1494 \$59 0.494517a
Cext_6230 \$1494 \$61 20.9159a
Cext_6231 \$1494 \$83 110.113a
Cext_6232 \$1494 \$93 0.107779a
Cext_6233 \$1494 VSS|vss 66.2132a
Cext_6234 \$1494 VSUBS 818.85a
Cext_6235 \$1495 \$1519 0.360462a
Cext_6236 \$1495 \$1529 42.153a
Cext_6237 \$1495 \$51 134.708a
Cext_6238 \$1495 \$53 19.3729a
Cext_6239 \$1495 \$57 1.33033a
Cext_6240 \$1495 \$83 69.937a
Cext_6241 \$1495 \$85 117.28a
Cext_6242 \$1495 \$87 31.3588a
Cext_6243 \$1495 \$89 34.4538a
Cext_6244 \$1495 \$91 35.6349a
Cext_6245 \$1495 \$93 45.8508a
Cext_6246 \$1495 VSS|vss 0.335662a
Cext_6247 \$1495 VSUBS 257.767a
Cext_6248 \$1496 \$1497 2.16563a
Cext_6249 \$1496 \$1503 102.889a
Cext_6250 \$1496 \$1521 225.319a
Cext_6251 \$1496 \$51 22.8071a
Cext_6252 \$1496 \$57 0.772242a
Cext_6253 \$1496 \$59 0.481837a
Cext_6254 \$1496 \$61 20.9928a
Cext_6255 \$1496 \$83 105.694a
Cext_6256 \$1496 IOVDD|vdda 11.6291a
Cext_6257 \$1496 VSS|vss 60.9228a
Cext_6258 \$1496 VSUBS 810.857a
Cext_6259 \$1497 \$1499 4.40425a
Cext_6260 \$1497 \$1503 86.9579a
Cext_6261 \$1497 \$1522 3.88628a
Cext_6262 \$1497 \$1530 789.439a
Cext_6263 \$1497 \$1547 4.39525a
Cext_6264 \$1497 \$1554 18.9a
Cext_6265 \$1497 \$1571 3.88628a
Cext_6266 \$1497 \$1594 99.1454a
Cext_6267 \$1497 \$1616 0.250757a
Cext_6268 \$1497 \$1671 1.28787a
Cext_6269 \$1497 \$51 0.564032a
Cext_6270 \$1497 \$53 74.0819a
Cext_6271 \$1497 \$55 56.1301a
Cext_6272 \$1497 \$57 53.1802a
Cext_6273 \$1497 \$59 3.23549a
Cext_6274 \$1497 \$61 1.94547a
Cext_6275 \$1497 \$83 1.96577a
Cext_6276 \$1497 \$85 71.1115a
Cext_6277 \$1497 \$87 67.4298a
Cext_6278 \$1497 \$89 3.41995a
Cext_6279 \$1497 \$91 1.56603a
Cext_6280 \$1497 \$93 0.98091a
Cext_6281 \$1497 IOVDD|vdda 7.75332a
Cext_6282 \$1497 VSS|vss 29.8407a
Cext_6283 \$1497 VSUBS 321.376a
Cext_6284 \$1498 \$1499 102.889a
Cext_6285 \$1498 \$1522 0.360462a
Cext_6286 \$1498 \$1531 42.153a
Cext_6287 \$1498 \$51 134.708a
Cext_6288 \$1498 \$53 19.3729a
Cext_6289 \$1498 \$57 1.33033a
Cext_6290 \$1498 \$83 69.937a
Cext_6291 \$1498 \$85 117.28a
Cext_6292 \$1498 \$87 31.3588a
Cext_6293 \$1498 \$89 34.4538a
Cext_6294 \$1498 \$91 35.6349a
Cext_6295 \$1498 \$93 45.8508a
Cext_6296 \$1498 VREF|vref 0.182933a
Cext_6297 \$1498 VSS|vss 0.335662a
Cext_6298 \$1498 VSUBS 257.767a
Cext_6299 \$1499 \$1522 254.864a
Cext_6300 \$1499 \$1531 0.360462a
Cext_6301 \$1499 \$51 23.4429a
Cext_6302 \$1499 \$55 0.105966a
Cext_6303 \$1499 \$57 0.428122a
Cext_6304 \$1499 \$59 0.494517a
Cext_6305 \$1499 \$61 20.9159a
Cext_6306 \$1499 \$83 110.113a
Cext_6307 \$1499 \$93 0.107779a
Cext_6308 \$1499 VSS|vss 75.3227a
Cext_6309 \$1499 VSUBS 818.85a
Cext_6310 \$150 \$152 1.85779a
Cext_6311 \$150 \$178 231.736a
Cext_6312 \$150 \$179 3.25406a
Cext_6313 \$150 \$180 1.44306a
Cext_6314 \$150 \$208 99.1454a
Cext_6315 \$150 \$209 7.41179a
Cext_6316 \$150 \$51 3.05553a
Cext_6317 \$150 \$53 103.932a
Cext_6318 \$150 \$55 4.04423a
Cext_6319 \$150 \$57 1.62297a
Cext_6320 \$150 \$59 0.919893a
Cext_6321 \$150 \$61 0.703335a
Cext_6322 \$150 \$83 1.00326a
Cext_6323 \$150 \$85 106.353a
Cext_6324 \$150 \$87 53.8929a
Cext_6325 \$150 \$89 3.34353a
Cext_6326 \$150 \$91 1.61371a
Cext_6327 \$150 \$93 1.13718a
Cext_6328 \$150 IOVDD|vdda 5.6517a
Cext_6329 \$150 VSS|vss 13.0104a
Cext_6330 \$150 VSUBS 230.16a
Cext_6331 \$1500 \$1508 114.006a
Cext_6332 \$1500 \$1509 0.182933a
Cext_6333 \$1500 \$1524 98.5952a
Cext_6334 \$1500 \$1536 0.360462a
Cext_6335 \$1500 \$1548 108.267a
Cext_6336 \$1500 \$35 134.708a
Cext_6337 \$1500 \$37 19.3729a
Cext_6338 \$1500 \$41 1.4801a
Cext_6339 \$1500 \$67 69.9941a
Cext_6340 \$1500 \$69 117.28a
Cext_6341 \$1500 \$71 31.3588a
Cext_6342 \$1500 \$73 34.4538a
Cext_6343 \$1500 \$75 35.6349a
Cext_6344 \$1500 \$77 45.7852a
Cext_6345 \$1500 VSS|vss 0.378848a
Cext_6346 \$1500 VSUBS 257.682a
Cext_6347 \$1501 \$1511 114.006a
Cext_6348 \$1501 \$1512 0.182933a
Cext_6349 \$1501 \$1526 98.5952a
Cext_6350 \$1501 \$1538 0.360462a
Cext_6351 \$1501 \$1550 108.267a
Cext_6352 \$1501 \$35 134.561a
Cext_6353 \$1501 \$37 19.3729a
Cext_6354 \$1501 \$41 1.4801a
Cext_6355 \$1501 \$67 69.8469a
Cext_6356 \$1501 \$69 117.28a
Cext_6357 \$1501 \$71 31.3588a
Cext_6358 \$1501 \$73 34.4538a
Cext_6359 \$1501 \$75 35.6349a
Cext_6360 \$1501 \$77 45.7852a
Cext_6361 \$1501 IOVDD|vdda 41.6526a
Cext_6362 \$1501 VSS|vss 0.378848a
Cext_6363 \$1501 VSUBS 257.408a
Cext_6364 \$1502 \$1518 114.006a
Cext_6365 \$1502 \$1519 0.182933a
Cext_6366 \$1502 \$1528 98.5952a
Cext_6367 \$1502 \$1544 0.360462a
Cext_6368 \$1502 \$1552 108.267a
Cext_6369 \$1502 \$51 134.708a
Cext_6370 \$1502 \$53 19.3729a
Cext_6371 \$1502 \$57 1.4801a
Cext_6372 \$1502 \$83 69.9941a
Cext_6373 \$1502 \$85 117.28a
Cext_6374 \$1502 \$87 31.3588a
Cext_6375 \$1502 \$89 34.4538a
Cext_6376 \$1502 \$91 35.6349a
Cext_6377 \$1502 \$93 45.7852a
Cext_6378 \$1502 VSS|vss 0.378848a
Cext_6379 \$1502 VSUBS 257.682a
Cext_6380 \$1503 \$1521 114.006a
Cext_6381 \$1503 \$1522 0.182933a
Cext_6382 \$1503 \$1530 98.5952a
Cext_6383 \$1503 \$1546 0.360462a
Cext_6384 \$1503 \$1554 108.267a
Cext_6385 \$1503 \$51 134.561a
Cext_6386 \$1503 \$53 19.3729a
Cext_6387 \$1503 \$57 1.4801a
Cext_6388 \$1503 \$83 69.8469a
Cext_6389 \$1503 \$85 117.28a
Cext_6390 \$1503 \$87 31.3588a
Cext_6391 \$1503 \$89 34.4538a
Cext_6392 \$1503 \$91 35.6349a
Cext_6393 \$1503 \$93 45.7852a
Cext_6394 \$1503 IOVDD|vdda 41.6526a
Cext_6395 \$1503 VSS|vss 4.34731a
Cext_6396 \$1503 VSUBS 257.408a
Cext_6397 \$1504 \$1505 45.0654a
Cext_6398 \$1504 \$1532 130.175a
Cext_6399 \$1504 VDD|vdd 7.74075a
Cext_6400 \$1504 VSS|vss 1.71997a
Cext_6401 \$1504 VSUBS 659.267a
Cext_6402 \$1505 \$1506 45.0654a
Cext_6403 \$1505 \$1533 130.175a
Cext_6404 \$1505 VDD|vdd 0.968272a
Cext_6405 \$1505 VSUBS 634.529a
Cext_6406 \$1506 \$1507 45.0654a
Cext_6407 \$1506 \$1534 130.175a
Cext_6408 \$1506 VSUBS 634.529a
Cext_6409 \$1507 \$1508 46.4004a
Cext_6410 \$1507 \$1535 130.175a
Cext_6411 \$1507 VSS|vss 0.378729a
Cext_6412 \$1507 VSUBS 634.529a
Cext_6413 \$1508 \$1536 254.864a
Cext_6414 \$1508 \$1548 0.360462a
Cext_6415 \$1508 \$35 68.8031a
Cext_6416 \$1508 \$67 64.1221a
Cext_6417 \$1508 \$69 0.155901a
Cext_6418 \$1508 VSS|vss 66.2906a
Cext_6419 \$1508 VSUBS 799.746a
Cext_6420 \$1509 \$1510 2.16563a
Cext_6421 \$1509 \$1525 102.889a
Cext_6422 \$1509 \$1537 225.319a
Cext_6423 \$1509 \$35 68.8428a
Cext_6424 \$1509 \$41 0.115752a
Cext_6425 \$1509 \$43 0.481837a
Cext_6426 \$1509 \$45 20.8391a
Cext_6427 \$1509 \$67 59.1234a
Cext_6428 \$1509 \$69 0.343978a
Cext_6429 \$1509 VSS|vss 60.9228a
Cext_6430 \$1509 VSUBS 811.9a
Cext_6431 \$151 \$152 114.006a
Cext_6432 \$151 \$153 0.709993a
Cext_6433 \$151 \$180 0.360462a
Cext_6434 \$151 \$181 98.5952a
Cext_6435 \$151 \$210 108.267a
Cext_6436 \$151 \$51 123.256a
Cext_6437 \$151 \$53 66.5956a
Cext_6438 \$151 \$55 0.280546a
Cext_6439 \$151 \$57 0.131796a
Cext_6440 \$151 \$59 0.112844a
Cext_6441 \$151 \$83 80.1395a
Cext_6442 \$151 \$85 70.312a
Cext_6443 \$151 \$87 30.8484a
Cext_6444 \$151 \$89 31.8692a
Cext_6445 \$151 \$91 34.9266a
Cext_6446 \$151 \$93 45.0769a
Cext_6447 \$151 VSS|vss 0.378848a
Cext_6448 \$151 VSUBS 289.954a
Cext_6449 \$1510 \$1511 4.40425a
Cext_6450 \$1510 \$1525 86.9579a
Cext_6451 \$1510 \$1538 3.88628a
Cext_6452 \$1510 \$1549 789.439a
Cext_6453 \$1510 \$1562 4.39525a
Cext_6454 \$1510 \$1572 18.9a
Cext_6455 \$1510 \$1583 3.88628a
Cext_6456 \$1510 \$1603 99.1454a
Cext_6457 \$1510 \$1620 0.250757a
Cext_6458 \$1510 \$35 2.65407a
Cext_6459 \$1510 \$37 79.3734a
Cext_6460 \$1510 \$39 73.3394a
Cext_6461 \$1510 \$41 6.95821a
Cext_6462 \$1510 \$43 3.23549a
Cext_6463 \$1510 \$45 1.94547a
Cext_6464 \$1510 \$69 64.9505a
Cext_6465 \$1510 \$71 50.2205a
Cext_6466 \$1510 \$73 49.6419a
Cext_6467 \$1510 \$75 1.56603a
Cext_6468 \$1510 \$77 0.98091a
Cext_6469 \$1510 VSUBS 322.083a
Cext_6470 \$1511 \$1538 254.864a
Cext_6471 \$1511 \$1550 0.360462a
Cext_6472 \$1511 \$35 68.8031a
Cext_6473 \$1511 \$39 0.105966a
Cext_6474 \$1511 \$41 0.282145a
Cext_6475 \$1511 \$43 0.494517a
Cext_6476 \$1511 \$45 20.9159a
Cext_6477 \$1511 \$67 64.1221a
Cext_6478 \$1511 \$69 0.155901a
Cext_6479 \$1511 IOVDD|vdda 13.0646a
Cext_6480 \$1511 VSS|vss 66.2132a
Cext_6481 \$1511 VSUBS 817.565a
Cext_6482 \$1512 \$1513 2.16563a
Cext_6483 \$1512 \$1527 102.889a
Cext_6484 \$1512 \$1539 225.319a
Cext_6485 \$1512 \$35 68.8428a
Cext_6486 \$1512 \$41 0.115752a
Cext_6487 \$1512 \$43 0.481837a
Cext_6488 \$1512 \$45 20.8391a
Cext_6489 \$1512 \$67 59.1234a
Cext_6490 \$1512 \$69 0.343978a
Cext_6491 \$1512 VSS|vss 60.9228a
Cext_6492 \$1512 VSUBS 811.9a
Cext_6493 \$1513 \$1527 86.9579a
Cext_6494 \$1513 \$1551 789.439a
Cext_6495 \$1513 \$1573 18.9a
Cext_6496 \$1513 \$1607 99.1454a
Cext_6497 \$1513 \$1621 0.250757a
Cext_6498 \$1513 \$35 2.65407a
Cext_6499 \$1513 \$37 79.4807a
Cext_6500 \$1513 \$39 73.4036a
Cext_6501 \$1513 \$41 7.26359a
Cext_6502 \$1513 \$43 3.75257a
Cext_6503 \$1513 \$45 2.32694a
Cext_6504 \$1513 \$69 64.9505a
Cext_6505 \$1513 \$71 50.2205a
Cext_6506 \$1513 \$73 49.6419a
Cext_6507 \$1513 \$75 1.56603a
Cext_6508 \$1513 \$77 0.98091a
Cext_6509 \$1513 VREF|vref 67.7318a
Cext_6510 \$1513 VSUBS 292.056a
Cext_6511 \$1514 \$1515 45.0654a
Cext_6512 \$1514 \$1540 130.128a
Cext_6513 \$1514 VDD|vdd 0.592094a
Cext_6514 \$1514 VSS|vss 25.1792a
Cext_6515 \$1514 VSUBS 659.267a
Cext_6516 \$1515 \$1516 45.0654a
Cext_6517 \$1515 \$1541 130.175a
Cext_6518 \$1515 VSS|vss 5.452a
Cext_6519 \$1515 VSUBS 634.529a
Cext_6520 \$1516 \$1517 45.0654a
Cext_6521 \$1516 \$1542 130.175a
Cext_6522 \$1516 VSUBS 634.529a
Cext_6523 \$1517 \$1518 46.4004a
Cext_6524 \$1517 \$1543 130.175a
Cext_6525 \$1517 VSS|vss 0.378729a
Cext_6526 \$1517 VSUBS 634.529a
Cext_6527 \$1518 \$1544 254.864a
Cext_6528 \$1518 \$1552 0.360462a
Cext_6529 \$1518 \$51 68.8031a
Cext_6530 \$1518 \$83 64.1221a
Cext_6531 \$1518 \$85 0.155901a
Cext_6532 \$1518 VSS|vss 66.2906a
Cext_6533 \$1518 VSUBS 799.746a
Cext_6534 \$1519 \$1520 2.16563a
Cext_6535 \$1519 \$1529 102.889a
Cext_6536 \$1519 \$1545 225.319a
Cext_6537 \$1519 \$51 68.8428a
Cext_6538 \$1519 \$57 0.115752a
Cext_6539 \$1519 \$59 0.481837a
Cext_6540 \$1519 \$61 20.8391a
Cext_6541 \$1519 \$83 59.1234a
Cext_6542 \$1519 \$85 0.343978a
Cext_6543 \$1519 VSS|vss 60.9228a
Cext_6544 \$1519 VSUBS 811.9a
Cext_6545 \$152 \$178 0.182933a
Cext_6546 \$152 \$180 254.864a
Cext_6547 \$152 \$210 0.360462a
Cext_6548 \$152 \$51 23.2117a
Cext_6549 \$152 \$53 0.145978a
Cext_6550 \$152 \$55 0.105966a
Cext_6551 \$152 \$57 0.282145a
Cext_6552 \$152 \$59 0.494517a
Cext_6553 \$152 \$61 20.7622a
Cext_6554 \$152 \$83 114.799a
Cext_6555 \$152 VSS|vss 75.4228a
Cext_6556 \$152 VSUBS 817.643a
Cext_6557 \$1520 \$1521 4.40425a
Cext_6558 \$1520 \$1529 86.9579a
Cext_6559 \$1520 \$1546 3.88628a
Cext_6560 \$1520 \$1553 789.439a
Cext_6561 \$1520 \$1570 4.39525a
Cext_6562 \$1520 \$1574 18.9a
Cext_6563 \$1520 \$1593 3.88628a
Cext_6564 \$1520 \$1615 99.1454a
Cext_6565 \$1520 \$1622 0.250757a
Cext_6566 \$1520 \$51 2.65407a
Cext_6567 \$1520 \$53 79.3734a
Cext_6568 \$1520 \$55 73.3394a
Cext_6569 \$1520 \$57 6.95821a
Cext_6570 \$1520 \$59 3.23549a
Cext_6571 \$1520 \$61 1.94547a
Cext_6572 \$1520 \$85 64.9505a
Cext_6573 \$1520 \$87 50.2205a
Cext_6574 \$1520 \$89 49.6419a
Cext_6575 \$1520 \$91 1.56603a
Cext_6576 \$1520 \$93 0.98091a
Cext_6577 \$1520 VSUBS 322.083a
Cext_6578 \$1521 \$1546 254.864a
Cext_6579 \$1521 \$1554 0.360462a
Cext_6580 \$1521 \$51 68.8031a
Cext_6581 \$1521 \$55 0.105966a
Cext_6582 \$1521 \$57 0.282145a
Cext_6583 \$1521 \$59 0.494517a
Cext_6584 \$1521 \$61 20.9159a
Cext_6585 \$1521 \$83 64.1221a
Cext_6586 \$1521 \$85 0.155901a
Cext_6587 \$1521 IOVDD|vdda 13.0646a
Cext_6588 \$1521 VSS|vss 66.2132a
Cext_6589 \$1521 VSUBS 817.565a
Cext_6590 \$1522 \$1523 2.16563a
Cext_6591 \$1522 \$1531 102.889a
Cext_6592 \$1522 \$1547 225.319a
Cext_6593 \$1522 \$51 68.8428a
Cext_6594 \$1522 \$57 0.115752a
Cext_6595 \$1522 \$59 0.481837a
Cext_6596 \$1522 \$61 20.8391a
Cext_6597 \$1522 \$83 59.1234a
Cext_6598 \$1522 \$85 0.343978a
Cext_6599 \$1522 VSS|vss 69.9251a
Cext_6600 \$1522 VSUBS 811.9a
Cext_6601 \$1523 \$1531 86.9579a
Cext_6602 \$1523 \$1555 789.439a
Cext_6603 \$1523 \$1575 18.9a
Cext_6604 \$1523 \$1619 99.1454a
Cext_6605 \$1523 \$1623 0.250757a
Cext_6606 \$1523 \$51 2.65407a
Cext_6607 \$1523 \$53 79.4807a
Cext_6608 \$1523 \$55 73.4036a
Cext_6609 \$1523 \$57 7.26359a
Cext_6610 \$1523 \$59 3.75257a
Cext_6611 \$1523 \$61 2.32694a
Cext_6612 \$1523 \$85 64.9505a
Cext_6613 \$1523 \$87 50.2205a
Cext_6614 \$1523 \$89 49.6419a
Cext_6615 \$1523 \$91 1.56603a
Cext_6616 \$1523 \$93 0.98091a
Cext_6617 \$1523 VREF|vref 67.7318a
Cext_6618 \$1523 VSUBS 292.056a
Cext_6619 \$1524 \$1548 227.572a
Cext_6620 \$1524 \$1560 3.25406a
Cext_6621 \$1524 \$1561 0.179323a
Cext_6622 \$1524 \$1581 7.41179a
Cext_6623 \$1524 \$35 3.05553a
Cext_6624 \$1524 \$37 91.1815a
Cext_6625 \$1524 \$39 1.18748a
Cext_6626 \$1524 \$41 0.476813a
Cext_6627 \$1524 \$69 106.353a
Cext_6628 \$1524 \$71 53.5342a
Cext_6629 \$1524 \$73 3.67334a
Cext_6630 \$1524 \$75 1.61371a
Cext_6631 \$1524 \$77 1.13718a
Cext_6632 \$1524 VSUBS 168.567a
Cext_6633 \$1525 \$1537 114.006a
Cext_6634 \$1525 \$1538 0.182933a
Cext_6635 \$1525 \$1549 98.5952a
Cext_6636 \$1525 \$1561 0.360462a
Cext_6637 \$1525 \$1572 108.267a
Cext_6638 \$1525 \$35 123.657a
Cext_6639 \$1525 \$37 65.4666a
Cext_6640 \$1525 \$41 0.62262a
Cext_6641 \$1525 \$67 80.1821a
Cext_6642 \$1525 \$69 70.7638a
Cext_6643 \$1525 \$71 31.3588a
Cext_6644 \$1525 \$73 36.1512a
Cext_6645 \$1525 \$75 35.6349a
Cext_6646 \$1525 \$77 45.7852a
Cext_6647 \$1525 VSS|vss 0.378848a
Cext_6648 \$1525 VSUBS 257.776a
Cext_6649 \$1526 \$1550 227.572a
Cext_6650 \$1526 \$1562 3.25406a
Cext_6651 \$1526 \$1563 0.179323a
Cext_6652 \$1526 \$1584 7.41179a
Cext_6653 \$1526 \$35 3.05553a
Cext_6654 \$1526 \$37 91.1815a
Cext_6655 \$1526 \$39 1.18748a
Cext_6656 \$1526 \$41 0.476813a
Cext_6657 \$1526 \$69 106.353a
Cext_6658 \$1526 \$71 53.5342a
Cext_6659 \$1526 \$73 3.67334a
Cext_6660 \$1526 \$75 1.61371a
Cext_6661 \$1526 \$77 1.13718a
Cext_6662 \$1526 IOVDD|vdda 5.37185a
Cext_6663 \$1526 VSUBS 168.567a
Cext_6664 \$1527 \$1539 114.006a
Cext_6665 \$1527 \$1551 98.5952a
Cext_6666 \$1527 \$1563 0.360462a
Cext_6667 \$1527 \$1573 108.267a
Cext_6668 \$1527 \$35 123.657a
Cext_6669 \$1527 \$37 65.4666a
Cext_6670 \$1527 \$41 0.62262a
Cext_6671 \$1527 \$67 80.1821a
Cext_6672 \$1527 \$69 70.7638a
Cext_6673 \$1527 \$71 31.3588a
Cext_6674 \$1527 \$73 36.1512a
Cext_6675 \$1527 \$75 35.6349a
Cext_6676 \$1527 \$77 45.7852a
Cext_6677 \$1527 VREF|vref 0.182933a
Cext_6678 \$1527 VSS|vss 0.378848a
Cext_6679 \$1527 VSUBS 257.776a
Cext_6680 \$1528 \$1552 227.572a
Cext_6681 \$1528 \$1568 3.25406a
Cext_6682 \$1528 \$1569 0.179323a
Cext_6683 \$1528 \$1591 7.41179a
Cext_6684 \$1528 \$51 3.05553a
Cext_6685 \$1528 \$53 91.1815a
Cext_6686 \$1528 \$55 1.18748a
Cext_6687 \$1528 \$57 0.476813a
Cext_6688 \$1528 \$85 106.353a
Cext_6689 \$1528 \$87 53.5342a
Cext_6690 \$1528 \$89 3.67334a
Cext_6691 \$1528 \$91 1.61371a
Cext_6692 \$1528 \$93 1.13718a
Cext_6693 \$1528 VSUBS 168.567a
Cext_6694 \$1529 \$1545 114.006a
Cext_6695 \$1529 \$1546 0.182933a
Cext_6696 \$1529 \$1553 98.5952a
Cext_6697 \$1529 \$1569 0.360462a
Cext_6698 \$1529 \$1574 108.267a
Cext_6699 \$1529 \$51 123.657a
Cext_6700 \$1529 \$53 65.4666a
Cext_6701 \$1529 \$57 0.62262a
Cext_6702 \$1529 \$83 80.1821a
Cext_6703 \$1529 \$85 70.7638a
Cext_6704 \$1529 \$87 31.3588a
Cext_6705 \$1529 \$89 36.1512a
Cext_6706 \$1529 \$91 35.6349a
Cext_6707 \$1529 \$93 45.7852a
Cext_6708 \$1529 VSS|vss 0.378848a
Cext_6709 \$1529 VSUBS 257.776a
Cext_6710 \$153 \$182 130.175a
Cext_6711 \$153 \$53 0.404672a
Cext_6712 \$153 \$57 0.115752a
Cext_6713 \$153 \$59 0.481837a
Cext_6714 \$153 \$61 20.9895a
Cext_6715 \$153 \$83 4.25617a
Cext_6716 \$153 VSS|vss 2.2008a
Cext_6717 \$153 VSUBS 675.619a
Cext_6718 \$1530 \$1554 227.572a
Cext_6719 \$1530 \$1570 3.25406a
Cext_6720 \$1530 \$1571 0.179323a
Cext_6721 \$1530 \$1594 7.41179a
Cext_6722 \$1530 \$51 3.05553a
Cext_6723 \$1530 \$53 91.1815a
Cext_6724 \$1530 \$55 1.18748a
Cext_6725 \$1530 \$57 0.476813a
Cext_6726 \$1530 \$85 106.353a
Cext_6727 \$1530 \$87 53.5342a
Cext_6728 \$1530 \$89 3.67334a
Cext_6729 \$1530 \$91 1.61371a
Cext_6730 \$1530 \$93 1.13718a
Cext_6731 \$1530 IOVDD|vdda 5.37185a
Cext_6732 \$1530 VSS|vss 6.14473a
Cext_6733 \$1530 VSUBS 168.567a
Cext_6734 \$1531 \$1547 114.006a
Cext_6735 \$1531 \$1555 98.5952a
Cext_6736 \$1531 \$1571 0.360462a
Cext_6737 \$1531 \$1575 108.267a
Cext_6738 \$1531 \$51 123.657a
Cext_6739 \$1531 \$53 65.4666a
Cext_6740 \$1531 \$57 0.62262a
Cext_6741 \$1531 \$83 80.1821a
Cext_6742 \$1531 \$85 70.7638a
Cext_6743 \$1531 \$87 31.3588a
Cext_6744 \$1531 \$89 36.1512a
Cext_6745 \$1531 \$91 35.6349a
Cext_6746 \$1531 \$93 45.7852a
Cext_6747 \$1531 VREF|vref 0.182933a
Cext_6748 \$1531 VSS|vss 0.378848a
Cext_6749 \$1531 VSUBS 257.776a
Cext_6750 \$1532 \$1533 45.0654a
Cext_6751 \$1532 \$1556 130.175a
Cext_6752 \$1532 VDD|vdd 7.74075a
Cext_6753 \$1532 VSS|vss 1.71997a
Cext_6754 \$1532 VSUBS 659.267a
Cext_6755 \$1533 \$1534 45.0654a
Cext_6756 \$1533 \$1557 130.175a
Cext_6757 \$1533 VDD|vdd 0.968272a
Cext_6758 \$1533 VSUBS 634.529a
Cext_6759 \$1534 \$1535 45.0654a
Cext_6760 \$1534 \$1558 130.175a
Cext_6761 \$1534 VSUBS 634.529a
Cext_6762 \$1535 \$1536 45.8951a
Cext_6763 \$1535 \$1559 130.175a
Cext_6764 \$1535 VSS|vss 0.428128a
Cext_6765 \$1535 VSUBS 634.529a
Cext_6766 \$1536 \$1548 113.058a
Cext_6767 \$1536 \$1560 225.319a
Cext_6768 \$1536 \$35 22.6915a
Cext_6769 \$1536 \$67 105.489a
Cext_6770 \$1536 VSS|vss 61.1015a
Cext_6771 \$1536 VSUBS 793.257a
Cext_6772 \$1537 \$1548 0.182933a
Cext_6773 \$1537 \$1561 254.864a
Cext_6774 \$1537 \$1572 0.360462a
Cext_6775 \$1537 \$35 23.2117a
Cext_6776 \$1537 \$37 0.145978a
Cext_6777 \$1537 \$39 0.105966a
Cext_6778 \$1537 \$41 0.282145a
Cext_6779 \$1537 \$43 0.494517a
Cext_6780 \$1537 \$45 20.7622a
Cext_6781 \$1537 \$67 110.011a
Cext_6782 \$1537 VSS|vss 66.2132a
Cext_6783 \$1537 VSUBS 817.562a
Cext_6784 \$1538 \$1550 113.058a
Cext_6785 \$1538 \$1562 225.319a
Cext_6786 \$1538 \$35 22.6915a
Cext_6787 \$1538 \$37 0.404672a
Cext_6788 \$1538 \$41 0.115752a
Cext_6789 \$1538 \$43 0.481837a
Cext_6790 \$1538 \$45 20.8391a
Cext_6791 \$1538 \$67 105.489a
Cext_6792 \$1538 IOVDD|vdda 11.5102a
Cext_6793 \$1538 VSS|vss 60.9228a
Cext_6794 \$1538 VSUBS 810.61a
Cext_6795 \$1539 \$1550 0.182933a
Cext_6796 \$1539 \$1563 254.864a
Cext_6797 \$1539 \$1573 0.360462a
Cext_6798 \$1539 \$35 23.2117a
Cext_6799 \$1539 \$37 0.145978a
Cext_6800 \$1539 \$39 0.105966a
Cext_6801 \$1539 \$41 0.282145a
Cext_6802 \$1539 \$43 0.494517a
Cext_6803 \$1539 \$45 20.7622a
Cext_6804 \$1539 \$67 110.011a
Cext_6805 \$1539 VSS|vss 66.2132a
Cext_6806 \$1539 VSUBS 817.562a
Cext_6807 \$154 \$155 45.0654a
Cext_6808 \$154 \$157 130.105a
Cext_6809 \$154 VDD|vdd 7.74075a
Cext_6810 \$154 VSS|vss 133.217a
Cext_6811 \$154 VSUBS 659.267a
Cext_6812 \$1540 \$1541 45.0654a
Cext_6813 \$1540 \$1564 130.128a
Cext_6814 \$1540 VDD|vdd 0.592094a
Cext_6815 \$1540 VSS|vss 25.1792a
Cext_6816 \$1540 VSUBS 659.267a
Cext_6817 \$1541 \$1542 45.0654a
Cext_6818 \$1541 \$1565 130.175a
Cext_6819 \$1541 VSS|vss 5.452a
Cext_6820 \$1541 VSUBS 634.529a
Cext_6821 \$1542 \$1543 45.0654a
Cext_6822 \$1542 \$1566 130.175a
Cext_6823 \$1542 VSUBS 634.529a
Cext_6824 \$1543 \$1544 45.8951a
Cext_6825 \$1543 \$1567 130.175a
Cext_6826 \$1543 VSS|vss 0.428128a
Cext_6827 \$1543 VSUBS 634.529a
Cext_6828 \$1544 \$1552 113.058a
Cext_6829 \$1544 \$1568 225.319a
Cext_6830 \$1544 \$51 22.6915a
Cext_6831 \$1544 \$83 105.489a
Cext_6832 \$1544 VSS|vss 61.1015a
Cext_6833 \$1544 VSUBS 793.257a
Cext_6834 \$1545 \$1552 0.182933a
Cext_6835 \$1545 \$1569 254.864a
Cext_6836 \$1545 \$1574 0.360462a
Cext_6837 \$1545 \$51 23.2117a
Cext_6838 \$1545 \$53 0.145978a
Cext_6839 \$1545 \$55 0.105966a
Cext_6840 \$1545 \$57 0.282145a
Cext_6841 \$1545 \$59 0.494517a
Cext_6842 \$1545 \$61 20.7622a
Cext_6843 \$1545 \$83 110.011a
Cext_6844 \$1545 VSS|vss 66.2132a
Cext_6845 \$1545 VSUBS 817.562a
Cext_6846 \$1546 \$1554 113.058a
Cext_6847 \$1546 \$1570 225.319a
Cext_6848 \$1546 \$51 22.6915a
Cext_6849 \$1546 \$53 0.404672a
Cext_6850 \$1546 \$57 0.115752a
Cext_6851 \$1546 \$59 0.481837a
Cext_6852 \$1546 \$61 20.8391a
Cext_6853 \$1546 \$83 105.489a
Cext_6854 \$1546 IOVDD|vdda 11.5102a
Cext_6855 \$1546 VSS|vss 60.9228a
Cext_6856 \$1546 VSUBS 810.61a
Cext_6857 \$1547 \$1554 0.182933a
Cext_6858 \$1547 \$1571 254.864a
Cext_6859 \$1547 \$1575 0.360462a
Cext_6860 \$1547 \$51 23.2117a
Cext_6861 \$1547 \$53 0.145978a
Cext_6862 \$1547 \$55 0.105966a
Cext_6863 \$1547 \$57 0.282145a
Cext_6864 \$1547 \$59 0.494517a
Cext_6865 \$1547 \$61 20.7622a
Cext_6866 \$1547 \$83 110.011a
Cext_6867 \$1547 VSS|vss 75.4228a
Cext_6868 \$1547 VSUBS 817.562a
Cext_6869 \$1548 \$1560 102.889a
Cext_6870 \$1548 \$1580 0.360462a
Cext_6871 \$1548 \$1600 42.153a
Cext_6872 \$1548 \$35 123.657a
Cext_6873 \$1548 \$37 65.6459a
Cext_6874 \$1548 \$39 0.62262a
Cext_6875 \$1548 \$67 80.1249a
Cext_6876 \$1548 \$69 70.7638a
Cext_6877 \$1548 \$71 33.9629a
Cext_6878 \$1548 \$73 32.5775a
Cext_6879 \$1548 \$75 35.6349a
Cext_6880 \$1548 \$77 45.8508a
Cext_6881 \$1548 VSS|vss 0.335662a
Cext_6882 \$1548 VSUBS 255.945a
Cext_6883 \$1549 \$1572 227.572a
Cext_6884 \$1549 \$1582 3.25406a
Cext_6885 \$1549 \$1583 0.179323a
Cext_6886 \$1549 \$1603 7.41179a
Cext_6887 \$1549 \$35 0.592076a
Cext_6888 \$1549 \$37 82.9986a
Cext_6889 \$1549 \$39 47.2301a
Cext_6890 \$1549 \$41 0.329802a
Cext_6891 \$1549 \$67 2.30683a
Cext_6892 \$1549 \$69 115.677a
Cext_6893 \$1549 \$71 7.49159a
Cext_6894 \$1549 \$73 3.82035a
Cext_6895 \$1549 \$75 1.61371a
Cext_6896 \$1549 \$77 1.13718a
Cext_6897 \$1549 VSUBS 167.898a
Cext_6898 \$155 \$158 130.175a
Cext_6899 \$155 \$67 2.08919a
Cext_6900 \$155 VDD|vdd 0.968272a
Cext_6901 \$155 VSUBS 634.529a
Cext_6902 \$1550 \$1562 102.889a
Cext_6903 \$1550 \$1583 0.360462a
Cext_6904 \$1550 \$1604 42.153a
Cext_6905 \$1550 \$35 123.51a
Cext_6906 \$1550 \$37 65.6459a
Cext_6907 \$1550 \$39 0.62262a
Cext_6908 \$1550 \$67 79.9778a
Cext_6909 \$1550 \$69 70.7638a
Cext_6910 \$1550 \$71 33.9629a
Cext_6911 \$1550 \$73 32.5775a
Cext_6912 \$1550 \$75 35.6349a
Cext_6913 \$1550 \$77 45.8508a
Cext_6914 \$1550 IOVDD|vdda 41.5375a
Cext_6915 \$1550 VSS|vss 0.335662a
Cext_6916 \$1550 VSUBS 255.671a
Cext_6917 \$1551 \$1573 227.572a
Cext_6918 \$1551 \$1585 3.25406a
Cext_6919 \$1551 \$1607 7.41179a
Cext_6920 \$1551 \$35 0.592076a
Cext_6921 \$1551 \$37 82.9986a
Cext_6922 \$1551 \$39 47.2301a
Cext_6923 \$1551 \$41 0.329802a
Cext_6924 \$1551 \$67 2.30683a
Cext_6925 \$1551 \$69 115.788a
Cext_6926 \$1551 \$71 7.49159a
Cext_6927 \$1551 \$73 3.82035a
Cext_6928 \$1551 \$75 1.61371a
Cext_6929 \$1551 \$77 1.13718a
Cext_6930 \$1551 VREF|vref 0.489684a
Cext_6931 \$1551 VSUBS 167.921a
Cext_6932 \$1552 \$1568 102.889a
Cext_6933 \$1552 \$1590 0.360462a
Cext_6934 \$1552 \$1613 42.153a
Cext_6935 \$1552 \$51 123.657a
Cext_6936 \$1552 \$53 65.6459a
Cext_6937 \$1552 \$55 0.62262a
Cext_6938 \$1552 \$83 80.1249a
Cext_6939 \$1552 \$85 70.7638a
Cext_6940 \$1552 \$87 33.9629a
Cext_6941 \$1552 \$89 32.5775a
Cext_6942 \$1552 \$91 35.6349a
Cext_6943 \$1552 \$93 45.8508a
Cext_6944 \$1552 VSS|vss 0.335662a
Cext_6945 \$1552 VSUBS 255.945a
Cext_6946 \$1553 \$1574 227.572a
Cext_6947 \$1553 \$1592 3.25406a
Cext_6948 \$1553 \$1593 0.179323a
Cext_6949 \$1553 \$1615 7.41179a
Cext_6950 \$1553 \$51 0.592076a
Cext_6951 \$1553 \$53 82.9986a
Cext_6952 \$1553 \$55 47.2301a
Cext_6953 \$1553 \$57 0.329802a
Cext_6954 \$1553 \$83 2.30683a
Cext_6955 \$1553 \$85 115.677a
Cext_6956 \$1553 \$87 7.49159a
Cext_6957 \$1553 \$89 3.82035a
Cext_6958 \$1553 \$91 1.61371a
Cext_6959 \$1553 \$93 1.13718a
Cext_6960 \$1553 VSUBS 167.898a
Cext_6961 \$1554 \$1570 102.889a
Cext_6962 \$1554 \$1593 0.360462a
Cext_6963 \$1554 \$1616 42.153a
Cext_6964 \$1554 \$51 123.51a
Cext_6965 \$1554 \$53 65.6459a
Cext_6966 \$1554 \$55 0.62262a
Cext_6967 \$1554 \$83 79.9778a
Cext_6968 \$1554 \$85 70.7638a
Cext_6969 \$1554 \$87 33.9629a
Cext_6970 \$1554 \$89 32.5775a
Cext_6971 \$1554 \$91 35.6349a
Cext_6972 \$1554 \$93 45.8508a
Cext_6973 \$1554 IOVDD|vdda 41.5375a
Cext_6974 \$1554 VSS|vss 3.69166a
Cext_6975 \$1554 VSUBS 255.671a
Cext_6976 \$1555 \$1575 227.572a
Cext_6977 \$1555 \$1595 3.25406a
Cext_6978 \$1555 \$1619 7.41179a
Cext_6979 \$1555 \$51 0.592076a
Cext_6980 \$1555 \$53 82.9986a
Cext_6981 \$1555 \$55 47.2301a
Cext_6982 \$1555 \$57 0.329802a
Cext_6983 \$1555 \$83 2.30683a
Cext_6984 \$1555 \$85 115.788a
Cext_6985 \$1555 \$87 7.49159a
Cext_6986 \$1555 \$89 3.82035a
Cext_6987 \$1555 \$91 1.61371a
Cext_6988 \$1555 \$93 1.13718a
Cext_6989 \$1555 VREF|vref 0.489684a
Cext_6990 \$1555 VSUBS 167.921a
Cext_6991 \$1556 \$1557 45.0654a
Cext_6992 \$1556 \$1576 130.175a
Cext_6993 \$1556 VDD|vdd 7.74075a
Cext_6994 \$1556 VSS|vss 1.71997a
Cext_6995 \$1556 VSUBS 659.267a
Cext_6996 \$1557 \$1558 45.0654a
Cext_6997 \$1557 \$1577 130.175a
Cext_6998 \$1557 VDD|vdd 0.968272a
Cext_6999 \$1557 VSUBS 634.529a
Cext_7000 \$1558 \$1559 45.0654a
Cext_7001 \$1558 \$1578 130.175a
Cext_7002 \$1558 VSUBS 634.529a
Cext_7003 \$1559 \$1560 46.4004a
Cext_7004 \$1559 \$1579 130.175a
Cext_7005 \$1559 VSS|vss 0.378729a
Cext_7006 \$1559 VSUBS 634.529a
Cext_7007 \$156 \$173 130.175a
Cext_7008 \$156 \$83 4.40063a
Cext_7009 \$156 VSS|vss 0.428128a
Cext_7010 \$156 VSUBS 634.529a
Cext_7011 \$1560 \$1580 254.864a
Cext_7012 \$1560 \$1600 0.360462a
Cext_7013 \$1560 \$35 69.0342a
Cext_7014 \$1560 \$67 64.1221a
Cext_7015 \$1560 \$71 0.168339a
Cext_7016 \$1560 \$77 0.107779a
Cext_7017 \$1560 VSS|vss 66.2906a
Cext_7018 \$1560 VSUBS 800.931a
Cext_7019 \$1561 \$1572 113.058a
Cext_7020 \$1561 \$1582 225.319a
Cext_7021 \$1561 \$35 68.7272a
Cext_7022 \$1561 \$41 0.115752a
Cext_7023 \$1561 \$43 0.481837a
Cext_7024 \$1561 \$45 20.9928a
Cext_7025 \$1561 \$67 58.9193a
Cext_7026 \$1561 \$71 0.343978a
Cext_7027 \$1561 VSS|vss 60.9228a
Cext_7028 \$1561 VSUBS 811.09a
Cext_7029 \$1562 \$1572 0.182933a
Cext_7030 \$1562 \$1583 254.864a
Cext_7031 \$1562 \$1604 0.360462a
Cext_7032 \$1562 \$35 69.0342a
Cext_7033 \$1562 \$39 0.105966a
Cext_7034 \$1562 \$41 0.282145a
Cext_7035 \$1562 \$43 0.494517a
Cext_7036 \$1562 \$45 20.7622a
Cext_7037 \$1562 \$67 64.1221a
Cext_7038 \$1562 \$71 0.168339a
Cext_7039 \$1562 \$77 0.107779a
Cext_7040 \$1562 IOVDD|vdda 13.2807a
Cext_7041 \$1562 VSS|vss 66.2132a
Cext_7042 \$1562 VSUBS 818.865a
Cext_7043 \$1563 \$1573 113.058a
Cext_7044 \$1563 \$1585 225.319a
Cext_7045 \$1563 \$35 68.7272a
Cext_7046 \$1563 \$41 0.115752a
Cext_7047 \$1563 \$43 0.481837a
Cext_7048 \$1563 \$45 20.9928a
Cext_7049 \$1563 \$67 58.9193a
Cext_7050 \$1563 \$71 0.343978a
Cext_7051 \$1563 VSS|vss 60.9228a
Cext_7052 \$1563 VSUBS 811.09a
Cext_7053 \$1564 \$1565 45.0654a
Cext_7054 \$1564 \$1586 130.128a
Cext_7055 \$1564 VDD|vdd 0.592094a
Cext_7056 \$1564 VSS|vss 25.1792a
Cext_7057 \$1564 VSUBS 659.267a
Cext_7058 \$1565 \$1566 45.0654a
Cext_7059 \$1565 \$1587 130.175a
Cext_7060 \$1565 VSS|vss 5.452a
Cext_7061 \$1565 VSUBS 634.529a
Cext_7062 \$1566 \$1567 45.0654a
Cext_7063 \$1566 \$1588 130.175a
Cext_7064 \$1566 VSUBS 634.529a
Cext_7065 \$1567 \$1568 46.4004a
Cext_7066 \$1567 \$1589 130.175a
Cext_7067 \$1567 VSS|vss 0.378729a
Cext_7068 \$1567 VSUBS 634.529a
Cext_7069 \$1568 \$1590 254.864a
Cext_7070 \$1568 \$1613 0.360462a
Cext_7071 \$1568 \$51 69.0342a
Cext_7072 \$1568 \$83 64.1221a
Cext_7073 \$1568 \$87 0.168339a
Cext_7074 \$1568 \$93 0.107779a
Cext_7075 \$1568 VSS|vss 66.2906a
Cext_7076 \$1568 VSUBS 800.931a
Cext_7077 \$1569 \$1574 113.058a
Cext_7078 \$1569 \$1592 225.319a
Cext_7079 \$1569 \$51 68.7272a
Cext_7080 \$1569 \$57 0.115752a
Cext_7081 \$1569 \$59 0.481837a
Cext_7082 \$1569 \$61 20.9928a
Cext_7083 \$1569 \$83 58.9193a
Cext_7084 \$1569 \$87 0.343978a
Cext_7085 \$1569 VSS|vss 60.9228a
Cext_7086 \$1569 VSUBS 811.09a
Cext_7087 \$157 \$158 45.0654a
Cext_7088 \$157 \$183 130.105a
Cext_7089 \$157 VDD|vdd 7.74075a
Cext_7090 \$157 VSS|vss 2.19464a
Cext_7091 \$157 VSUBS 659.267a
Cext_7092 \$1570 \$1574 0.182933a
Cext_7093 \$1570 \$1593 254.864a
Cext_7094 \$1570 \$1616 0.360462a
Cext_7095 \$1570 \$51 69.0342a
Cext_7096 \$1570 \$55 0.105966a
Cext_7097 \$1570 \$57 0.282145a
Cext_7098 \$1570 \$59 0.494517a
Cext_7099 \$1570 \$61 20.7622a
Cext_7100 \$1570 \$83 64.1221a
Cext_7101 \$1570 \$87 0.168339a
Cext_7102 \$1570 \$93 0.107779a
Cext_7103 \$1570 IOVDD|vdda 13.2807a
Cext_7104 \$1570 VSS|vss 66.2132a
Cext_7105 \$1570 VSUBS 818.865a
Cext_7106 \$1571 \$1575 113.058a
Cext_7107 \$1571 \$1595 225.319a
Cext_7108 \$1571 \$51 68.7272a
Cext_7109 \$1571 \$57 0.115752a
Cext_7110 \$1571 \$59 0.481837a
Cext_7111 \$1571 \$61 20.9928a
Cext_7112 \$1571 \$83 58.9193a
Cext_7113 \$1571 \$87 0.343978a
Cext_7114 \$1571 VSS|vss 69.9251a
Cext_7115 \$1571 VSUBS 811.09a
Cext_7116 \$1572 \$1582 102.889a
Cext_7117 \$1572 \$1602 0.360462a
Cext_7118 \$1572 \$1620 42.153a
Cext_7119 \$1572 \$35 134.708a
Cext_7120 \$1572 \$37 19.3729a
Cext_7121 \$1572 \$39 1.32172a
Cext_7122 \$1572 \$67 69.937a
Cext_7123 \$1572 \$69 117.46a
Cext_7124 \$1572 \$71 32.765a
Cext_7125 \$1572 \$73 32.5775a
Cext_7126 \$1572 \$75 35.6349a
Cext_7127 \$1572 \$77 45.8508a
Cext_7128 \$1572 VSS|vss 0.335662a
Cext_7129 \$1572 VSUBS 255.562a
Cext_7130 \$1573 \$1585 102.889a
Cext_7131 \$1573 \$1606 0.360462a
Cext_7132 \$1573 \$1621 42.153a
Cext_7133 \$1573 \$35 134.708a
Cext_7134 \$1573 \$37 19.3729a
Cext_7135 \$1573 \$39 1.32172a
Cext_7136 \$1573 \$67 69.937a
Cext_7137 \$1573 \$69 117.46a
Cext_7138 \$1573 \$71 32.765a
Cext_7139 \$1573 \$73 32.5775a
Cext_7140 \$1573 \$75 35.6349a
Cext_7141 \$1573 \$77 45.8508a
Cext_7142 \$1573 VREF|vref 0.182933a
Cext_7143 \$1573 VSS|vss 0.335662a
Cext_7144 \$1573 VSUBS 255.562a
Cext_7145 \$1574 \$1592 102.889a
Cext_7146 \$1574 \$1614 0.360462a
Cext_7147 \$1574 \$1622 42.153a
Cext_7148 \$1574 \$51 134.708a
Cext_7149 \$1574 \$53 19.3729a
Cext_7150 \$1574 \$55 1.32172a
Cext_7151 \$1574 \$83 69.937a
Cext_7152 \$1574 \$85 117.46a
Cext_7153 \$1574 \$87 32.765a
Cext_7154 \$1574 \$89 32.5775a
Cext_7155 \$1574 \$91 35.6349a
Cext_7156 \$1574 \$93 45.8508a
Cext_7157 \$1574 VSS|vss 0.335662a
Cext_7158 \$1574 VSUBS 255.562a
Cext_7159 \$1575 \$1595 102.889a
Cext_7160 \$1575 \$1618 0.360462a
Cext_7161 \$1575 \$1623 42.153a
Cext_7162 \$1575 \$51 134.708a
Cext_7163 \$1575 \$53 19.3729a
Cext_7164 \$1575 \$55 1.32172a
Cext_7165 \$1575 \$83 69.937a
Cext_7166 \$1575 \$85 117.46a
Cext_7167 \$1575 \$87 32.765a
Cext_7168 \$1575 \$89 32.5775a
Cext_7169 \$1575 \$91 35.6349a
Cext_7170 \$1575 \$93 45.8508a
Cext_7171 \$1575 VREF|vref 0.182933a
Cext_7172 \$1575 VSS|vss 0.335662a
Cext_7173 \$1575 VSUBS 255.562a
Cext_7174 \$1576 \$1577 45.0654a
Cext_7175 \$1576 \$1596 130.175a
Cext_7176 \$1576 VDD|vdd 7.74075a
Cext_7177 \$1576 VSS|vss 1.71997a
Cext_7178 \$1576 VSUBS 659.267a
Cext_7179 \$1577 \$1578 45.0654a
Cext_7180 \$1577 \$1597 130.175a
Cext_7181 \$1577 VDD|vdd 0.968272a
Cext_7182 \$1577 VSUBS 634.529a
Cext_7183 \$1578 \$1579 45.0654a
Cext_7184 \$1578 \$1598 130.175a
Cext_7185 \$1578 VSUBS 634.529a
Cext_7186 \$1579 \$1580 45.8951a
Cext_7187 \$1579 \$1599 130.175a
Cext_7188 \$1579 VSS|vss 0.428128a
Cext_7189 \$1579 VSUBS 634.529a
Cext_7190 \$158 \$159 45.0654a
Cext_7191 \$158 \$184 130.175a
Cext_7192 \$158 \$67 1.3178a
Cext_7193 \$158 VDD|vdd 0.968272a
Cext_7194 \$158 VSUBS 634.529a
Cext_7195 \$1580 \$1581 2.46853a
Cext_7196 \$1580 \$1600 102.889a
Cext_7197 \$1580 \$1601 225.319a
Cext_7198 \$1580 \$1667 1.4857a
Cext_7199 \$1580 \$35 22.8071a
Cext_7200 \$1580 \$67 105.489a
Cext_7201 \$1580 VSS|vss 61.1015a
Cext_7202 \$1580 VSUBS 793.935a
Cext_7203 \$1581 \$1582 1.90002a
Cext_7204 \$1581 \$1600 231.736a
Cext_7205 \$1581 \$1602 1.85779a
Cext_7206 \$1581 \$1640 98.5952a
Cext_7207 \$1581 \$1667 2.56813a
Cext_7208 \$1581 \$35 0.496172a
Cext_7209 \$1581 \$37 87.7995a
Cext_7210 \$1581 \$39 50.1631a
Cext_7211 \$1581 \$41 1.42579a
Cext_7212 \$1581 \$43 0.869717a
Cext_7213 \$1581 \$45 0.664971a
Cext_7214 \$1581 \$67 2.30683a
Cext_7215 \$1581 \$69 122.935a
Cext_7216 \$1581 \$71 7.5941a
Cext_7217 \$1581 \$73 3.34353a
Cext_7218 \$1581 \$75 1.52179a
Cext_7219 \$1581 \$77 1.0724a
Cext_7220 \$1581 VSUBS 226.974a
Cext_7221 \$1582 \$1602 254.864a
Cext_7222 \$1582 \$1620 0.360462a
Cext_7223 \$1582 \$1667 1.5425a
Cext_7224 \$1582 \$35 23.4429a
Cext_7225 \$1582 \$39 0.251943a
Cext_7226 \$1582 \$41 0.282145a
Cext_7227 \$1582 \$43 0.494517a
Cext_7228 \$1582 \$45 20.9159a
Cext_7229 \$1582 \$67 110.011a
Cext_7230 \$1582 \$77 0.107779a
Cext_7231 \$1582 VSS|vss 66.2132a
Cext_7232 \$1582 VSUBS 818.846a
Cext_7233 \$1583 \$1584 2.46853a
Cext_7234 \$1583 \$1604 102.889a
Cext_7235 \$1583 \$1605 225.319a
Cext_7236 \$1583 \$1668 1.4857a
Cext_7237 \$1583 \$35 22.8071a
Cext_7238 \$1583 \$39 0.500702a
Cext_7239 \$1583 \$41 0.115752a
Cext_7240 \$1583 \$43 0.481837a
Cext_7241 \$1583 \$45 20.9928a
Cext_7242 \$1583 \$67 105.489a
Cext_7243 \$1583 IOVDD|vdda 11.6291a
Cext_7244 \$1583 VSS|vss 60.9228a
Cext_7245 \$1583 VSUBS 811.159a
Cext_7246 \$1584 \$1585 1.90002a
Cext_7247 \$1584 \$1604 231.736a
Cext_7248 \$1584 \$1606 1.85779a
Cext_7249 \$1584 \$1641 98.5952a
Cext_7250 \$1584 \$1668 2.56813a
Cext_7251 \$1584 \$35 0.496172a
Cext_7252 \$1584 \$37 87.7995a
Cext_7253 \$1584 \$39 50.1631a
Cext_7254 \$1584 \$41 1.42579a
Cext_7255 \$1584 \$43 0.869717a
Cext_7256 \$1584 \$45 0.664971a
Cext_7257 \$1584 \$67 2.30683a
Cext_7258 \$1584 \$69 122.935a
Cext_7259 \$1584 \$71 7.5941a
Cext_7260 \$1584 \$73 3.34353a
Cext_7261 \$1584 \$75 1.52179a
Cext_7262 \$1584 \$77 1.0724a
Cext_7263 \$1584 IOVDD|vdda 5.6517a
Cext_7264 \$1584 VSUBS 226.974a
Cext_7265 \$1585 \$1606 254.864a
Cext_7266 \$1585 \$1621 0.360462a
Cext_7267 \$1585 \$1668 1.5425a
Cext_7268 \$1585 \$35 23.4429a
Cext_7269 \$1585 \$39 0.251943a
Cext_7270 \$1585 \$41 0.282145a
Cext_7271 \$1585 \$43 0.494517a
Cext_7272 \$1585 \$45 20.9159a
Cext_7273 \$1585 \$67 110.011a
Cext_7274 \$1585 \$77 0.107779a
Cext_7275 \$1585 VSS|vss 66.2132a
Cext_7276 \$1585 VSUBS 818.846a
Cext_7277 \$1586 \$1587 45.0654a
Cext_7278 \$1586 \$1608 130.128a
Cext_7279 \$1586 VDD|vdd 0.592094a
Cext_7280 \$1586 VSS|vss 25.1792a
Cext_7281 \$1586 VSUBS 659.267a
Cext_7282 \$1587 \$1588 45.0654a
Cext_7283 \$1587 \$1609 130.175a
Cext_7284 \$1587 VSS|vss 5.452a
Cext_7285 \$1587 VSUBS 634.529a
Cext_7286 \$1588 \$1589 45.0654a
Cext_7287 \$1588 \$1610 130.175a
Cext_7288 \$1588 VSUBS 634.529a
Cext_7289 \$1589 \$1590 45.8951a
Cext_7290 \$1589 \$1611 130.175a
Cext_7291 \$1589 VSS|vss 0.428128a
Cext_7292 \$1589 VSUBS 634.529a
Cext_7293 \$159 \$160 45.0654a
Cext_7294 \$159 \$185 130.175a
Cext_7295 \$159 \$67 2.77579a
Cext_7296 \$159 VSUBS 634.529a
Cext_7297 \$1590 \$1591 2.46853a
Cext_7298 \$1590 \$1612 225.319a
Cext_7299 \$1590 \$1613 102.889a
Cext_7300 \$1590 \$1670 1.4857a
Cext_7301 \$1590 \$51 22.8071a
Cext_7302 \$1590 \$83 105.489a
Cext_7303 \$1590 VSS|vss 61.1015a
Cext_7304 \$1590 VSUBS 793.935a
Cext_7305 \$1591 \$1592 1.90002a
Cext_7306 \$1591 \$1613 231.736a
Cext_7307 \$1591 \$1614 1.85779a
Cext_7308 \$1591 \$1642 98.5952a
Cext_7309 \$1591 \$1670 2.56813a
Cext_7310 \$1591 \$51 0.496172a
Cext_7311 \$1591 \$53 87.7995a
Cext_7312 \$1591 \$55 50.1631a
Cext_7313 \$1591 \$57 1.42579a
Cext_7314 \$1591 \$59 0.869717a
Cext_7315 \$1591 \$61 0.664971a
Cext_7316 \$1591 \$83 2.30683a
Cext_7317 \$1591 \$85 122.935a
Cext_7318 \$1591 \$87 7.5941a
Cext_7319 \$1591 \$89 3.34353a
Cext_7320 \$1591 \$91 1.52179a
Cext_7321 \$1591 \$93 1.0724a
Cext_7322 \$1591 VSUBS 226.974a
Cext_7323 \$1592 \$1614 254.864a
Cext_7324 \$1592 \$1622 0.360462a
Cext_7325 \$1592 \$1670 1.5425a
Cext_7326 \$1592 \$51 23.4429a
Cext_7327 \$1592 \$55 0.251943a
Cext_7328 \$1592 \$57 0.282145a
Cext_7329 \$1592 \$59 0.494517a
Cext_7330 \$1592 \$61 20.9159a
Cext_7331 \$1592 \$83 110.011a
Cext_7332 \$1592 \$93 0.107779a
Cext_7333 \$1592 VSS|vss 66.2132a
Cext_7334 \$1592 VSUBS 818.846a
Cext_7335 \$1593 \$1594 2.46853a
Cext_7336 \$1593 \$1616 102.889a
Cext_7337 \$1593 \$1617 225.319a
Cext_7338 \$1593 \$1671 1.4857a
Cext_7339 \$1593 \$51 22.8071a
Cext_7340 \$1593 \$55 0.500702a
Cext_7341 \$1593 \$57 0.115752a
Cext_7342 \$1593 \$59 0.481837a
Cext_7343 \$1593 \$61 20.9928a
Cext_7344 \$1593 \$83 105.489a
Cext_7345 \$1593 IOVDD|vdda 11.6291a
Cext_7346 \$1593 VSS|vss 60.9228a
Cext_7347 \$1593 VSUBS 811.159a
Cext_7348 \$1594 \$1595 1.90002a
Cext_7349 \$1594 \$1616 231.736a
Cext_7350 \$1594 \$1618 1.85779a
Cext_7351 \$1594 \$1643 98.5952a
Cext_7352 \$1594 \$1671 2.56813a
Cext_7353 \$1594 \$51 0.496172a
Cext_7354 \$1594 \$53 87.7995a
Cext_7355 \$1594 \$55 50.1631a
Cext_7356 \$1594 \$57 1.42579a
Cext_7357 \$1594 \$59 0.869717a
Cext_7358 \$1594 \$61 0.664971a
Cext_7359 \$1594 \$83 2.30683a
Cext_7360 \$1594 \$85 122.935a
Cext_7361 \$1594 \$87 7.5941a
Cext_7362 \$1594 \$89 3.34353a
Cext_7363 \$1594 \$91 1.52179a
Cext_7364 \$1594 \$93 1.0724a
Cext_7365 \$1594 IOVDD|vdda 5.6517a
Cext_7366 \$1594 VSS|vss 12.9468a
Cext_7367 \$1594 VSUBS 226.974a
Cext_7368 \$1595 \$1618 254.864a
Cext_7369 \$1595 \$1623 0.360462a
Cext_7370 \$1595 \$1671 1.5425a
Cext_7371 \$1595 \$51 23.4429a
Cext_7372 \$1595 \$55 0.251943a
Cext_7373 \$1595 \$57 0.282145a
Cext_7374 \$1595 \$59 0.494517a
Cext_7375 \$1595 \$61 20.9159a
Cext_7376 \$1595 \$83 110.011a
Cext_7377 \$1595 \$93 0.107779a
Cext_7378 \$1595 VSS|vss 75.4228a
Cext_7379 \$1595 VSUBS 818.846a
Cext_7380 \$1596 \$1597 45.0654a
Cext_7381 \$1596 \$1624 130.175a
Cext_7382 \$1596 VDD|vdd 7.74075a
Cext_7383 \$1596 VSS|vss 1.71997a
Cext_7384 \$1596 VSUBS 659.267a
Cext_7385 \$1597 \$1598 45.0654a
Cext_7386 \$1597 \$1625 130.175a
Cext_7387 \$1597 VDD|vdd 0.968272a
Cext_7388 \$1597 VSUBS 634.529a
Cext_7389 \$1598 \$1599 45.0654a
Cext_7390 \$1598 \$1626 130.175a
Cext_7391 \$1598 VSUBS 634.529a
Cext_7392 \$1599 \$1601 46.4004a
Cext_7393 \$1599 \$1627 130.175a
Cext_7394 \$1599 VSS|vss 0.378729a
Cext_7395 \$1599 VSUBS 634.529a
Cext_7396 \$160 \$161 46.4004a
Cext_7397 \$160 \$186 130.175a
Cext_7398 \$160 \$67 2.77579a
Cext_7399 \$160 VSS|vss 0.378729a
Cext_7400 \$160 VSUBS 634.529a
Cext_7401 \$1600 \$1601 114.006a
Cext_7402 \$1600 \$1602 0.182933a
Cext_7403 \$1600 \$1628 0.360462a
Cext_7404 \$1600 \$1640 108.267a
Cext_7405 \$1600 \$1667 0.126951a
Cext_7406 \$1600 \$35 134.708a
Cext_7407 \$1600 \$37 19.3729a
Cext_7408 \$1600 \$39 1.63847a
Cext_7409 \$1600 \$67 69.9941a
Cext_7410 \$1600 \$69 117.46a
Cext_7411 \$1600 \$71 32.765a
Cext_7412 \$1600 \$73 32.5775a
Cext_7413 \$1600 \$75 35.6349a
Cext_7414 \$1600 \$77 45.7852a
Cext_7415 \$1600 VSS|vss 0.378848a
Cext_7416 \$1600 VSUBS 255.879a
Cext_7417 \$1601 \$1628 254.864a
Cext_7418 \$1601 \$1640 0.360462a
Cext_7419 \$1601 \$1667 2.67626a
Cext_7420 \$1601 \$35 68.8031a
Cext_7421 \$1601 \$67 64.1221a
Cext_7422 \$1601 \$69 0.155901a
Cext_7423 \$1601 VSS|vss 66.2906a
Cext_7424 \$1601 VSUBS 799.746a
Cext_7425 \$1602 \$1603 2.46853a
Cext_7426 \$1602 \$1620 102.889a
Cext_7427 \$1602 \$1629 225.319a
Cext_7428 \$1602 \$1667 2.67468a
Cext_7429 \$1602 \$35 68.8428a
Cext_7430 \$1602 \$41 0.115752a
Cext_7431 \$1602 \$43 0.481837a
Cext_7432 \$1602 \$45 20.8391a
Cext_7433 \$1602 \$67 58.9193a
Cext_7434 \$1602 \$69 0.343978a
Cext_7435 \$1602 VSS|vss 60.9228a
Cext_7436 \$1602 VSUBS 811.815a
Cext_7437 \$1603 \$1605 1.90002a
Cext_7438 \$1603 \$1620 231.736a
Cext_7439 \$1603 \$1630 1.85779a
Cext_7440 \$1603 \$1659 98.5952a
Cext_7441 \$1603 \$35 2.95962a
Cext_7442 \$1603 \$37 103.882a
Cext_7443 \$1603 \$39 3.76182a
Cext_7444 \$1603 \$41 1.42579a
Cext_7445 \$1603 \$43 0.869717a
Cext_7446 \$1603 \$45 0.664971a
Cext_7447 \$1603 \$69 106.511a
Cext_7448 \$1603 \$71 53.9954a
Cext_7449 \$1603 \$73 3.34353a
Cext_7450 \$1603 \$75 1.52179a
Cext_7451 \$1603 \$77 1.0724a
Cext_7452 \$1603 VSUBS 228.585a
Cext_7453 \$1604 \$1605 114.006a
Cext_7454 \$1604 \$1606 0.182933a
Cext_7455 \$1604 \$1630 0.360462a
Cext_7456 \$1604 \$1641 108.267a
Cext_7457 \$1604 \$1668 0.126951a
Cext_7458 \$1604 \$35 134.561a
Cext_7459 \$1604 \$37 19.3729a
Cext_7460 \$1604 \$39 1.63847a
Cext_7461 \$1604 \$67 69.8469a
Cext_7462 \$1604 \$69 117.46a
Cext_7463 \$1604 \$71 32.765a
Cext_7464 \$1604 \$73 32.5775a
Cext_7465 \$1604 \$75 35.6349a
Cext_7466 \$1604 \$77 45.7852a
Cext_7467 \$1604 IOVDD|vdda 41.6334a
Cext_7468 \$1604 VSS|vss 0.378848a
Cext_7469 \$1604 VSUBS 255.605a
Cext_7470 \$1605 \$1630 254.864a
Cext_7471 \$1605 \$1641 0.360462a
Cext_7472 \$1605 \$1668 2.67626a
Cext_7473 \$1605 \$35 68.8031a
Cext_7474 \$1605 \$39 0.105966a
Cext_7475 \$1605 \$41 0.282145a
Cext_7476 \$1605 \$43 0.494517a
Cext_7477 \$1605 \$45 20.9159a
Cext_7478 \$1605 \$67 64.1221a
Cext_7479 \$1605 \$69 0.155901a
Cext_7480 \$1605 IOVDD|vdda 13.0646a
Cext_7481 \$1605 VSS|vss 66.2132a
Cext_7482 \$1605 VSUBS 817.761a
Cext_7483 \$1606 \$1607 2.46853a
Cext_7484 \$1606 \$1621 102.889a
Cext_7485 \$1606 \$1631 225.319a
Cext_7486 \$1606 \$1668 2.67468a
Cext_7487 \$1606 \$35 68.8428a
Cext_7488 \$1606 \$41 0.115752a
Cext_7489 \$1606 \$43 0.481837a
Cext_7490 \$1606 \$45 20.8391a
Cext_7491 \$1606 \$67 58.9193a
Cext_7492 \$1606 \$69 0.343978a
Cext_7493 \$1606 VSS|vss 60.9228a
Cext_7494 \$1606 VSUBS 811.815a
Cext_7495 \$1607 \$1621 231.736a
Cext_7496 \$1607 \$1660 98.5952a
Cext_7497 \$1607 \$35 2.95962a
Cext_7498 \$1607 \$37 103.882a
Cext_7499 \$1607 \$39 3.85958a
Cext_7500 \$1607 \$41 1.69123a
Cext_7501 \$1607 \$43 1.06485a
Cext_7502 \$1607 \$45 0.814163a
Cext_7503 \$1607 \$69 106.511a
Cext_7504 \$1607 \$71 53.9954a
Cext_7505 \$1607 \$73 3.34353a
Cext_7506 \$1607 \$75 1.52179a
Cext_7507 \$1607 \$77 1.0724a
Cext_7508 \$1607 VREF|vref 12.7505a
Cext_7509 \$1607 VSUBS 217.655a
Cext_7510 \$1608 \$1609 45.0654a
Cext_7511 \$1608 \$1632 130.128a
Cext_7512 \$1608 VDD|vdd 0.592094a
Cext_7513 \$1608 VSS|vss 25.1792a
Cext_7514 \$1608 VSUBS 659.267a
Cext_7515 \$1609 \$1610 45.0654a
Cext_7516 \$1609 \$1633 130.175a
Cext_7517 \$1609 VSS|vss 5.452a
Cext_7518 \$1609 VSUBS 634.529a
Cext_7519 \$161 \$162 102.889a
Cext_7520 \$161 \$187 254.864a
Cext_7521 \$161 \$217 0.360462a
Cext_7522 \$161 \$35 69.0342a
Cext_7523 \$161 \$67 66.8204a
Cext_7524 \$161 \$71 0.168339a
Cext_7525 \$161 \$77 0.107779a
Cext_7526 \$161 VSS|vss 66.2906a
Cext_7527 \$161 VSUBS 800.931a
Cext_7528 \$1610 \$1611 45.0654a
Cext_7529 \$1610 \$1634 130.175a
Cext_7530 \$1610 VSUBS 634.529a
Cext_7531 \$1611 \$1612 46.4004a
Cext_7532 \$1611 \$1635 130.175a
Cext_7533 \$1611 VSS|vss 0.378729a
Cext_7534 \$1611 VSUBS 634.529a
Cext_7535 \$1612 \$1613 114.006a
Cext_7536 \$1612 \$1636 254.864a
Cext_7537 \$1612 \$1642 0.360462a
Cext_7538 \$1612 \$1670 2.67626a
Cext_7539 \$1612 \$51 68.8031a
Cext_7540 \$1612 \$83 64.1221a
Cext_7541 \$1612 \$85 0.155901a
Cext_7542 \$1612 VSS|vss 66.2906a
Cext_7543 \$1612 VSUBS 799.746a
Cext_7544 \$1613 \$1614 0.182933a
Cext_7545 \$1613 \$1636 0.360462a
Cext_7546 \$1613 \$1642 108.267a
Cext_7547 \$1613 \$1670 0.126951a
Cext_7548 \$1613 \$51 134.708a
Cext_7549 \$1613 \$53 19.3729a
Cext_7550 \$1613 \$55 1.63847a
Cext_7551 \$1613 \$83 69.9941a
Cext_7552 \$1613 \$85 117.46a
Cext_7553 \$1613 \$87 32.765a
Cext_7554 \$1613 \$89 32.5775a
Cext_7555 \$1613 \$91 35.6349a
Cext_7556 \$1613 \$93 45.7852a
Cext_7557 \$1613 VSS|vss 0.378848a
Cext_7558 \$1613 VSUBS 255.879a
Cext_7559 \$1614 \$1615 2.46853a
Cext_7560 \$1614 \$1622 102.889a
Cext_7561 \$1614 \$1637 225.319a
Cext_7562 \$1614 \$1670 2.67468a
Cext_7563 \$1614 \$51 68.8428a
Cext_7564 \$1614 \$57 0.115752a
Cext_7565 \$1614 \$59 0.481837a
Cext_7566 \$1614 \$61 20.8391a
Cext_7567 \$1614 \$83 58.9193a
Cext_7568 \$1614 \$85 0.343978a
Cext_7569 \$1614 VSS|vss 60.9228a
Cext_7570 \$1614 VSUBS 811.815a
Cext_7571 \$1615 \$1617 1.90002a
Cext_7572 \$1615 \$1622 231.736a
Cext_7573 \$1615 \$1638 1.85779a
Cext_7574 \$1615 \$1663 98.5952a
Cext_7575 \$1615 \$51 2.95962a
Cext_7576 \$1615 \$53 103.882a
Cext_7577 \$1615 \$55 3.76182a
Cext_7578 \$1615 \$57 1.42579a
Cext_7579 \$1615 \$59 0.869717a
Cext_7580 \$1615 \$61 0.664971a
Cext_7581 \$1615 \$85 106.511a
Cext_7582 \$1615 \$87 53.9954a
Cext_7583 \$1615 \$89 3.34353a
Cext_7584 \$1615 \$91 1.52179a
Cext_7585 \$1615 \$93 1.0724a
Cext_7586 \$1615 VSUBS 228.585a
Cext_7587 \$1616 \$1617 114.006a
Cext_7588 \$1616 \$1618 0.182933a
Cext_7589 \$1616 \$1638 0.360462a
Cext_7590 \$1616 \$1643 108.267a
Cext_7591 \$1616 \$1671 0.126951a
Cext_7592 \$1616 \$51 134.561a
Cext_7593 \$1616 \$53 19.3729a
Cext_7594 \$1616 \$55 1.63847a
Cext_7595 \$1616 \$83 69.8469a
Cext_7596 \$1616 \$85 117.46a
Cext_7597 \$1616 \$87 32.765a
Cext_7598 \$1616 \$89 32.5775a
Cext_7599 \$1616 \$91 35.6349a
Cext_7600 \$1616 \$93 45.7852a
Cext_7601 \$1616 IOVDD|vdda 41.6334a
Cext_7602 \$1616 VSS|vss 4.18542a
Cext_7603 \$1616 VSUBS 255.605a
Cext_7604 \$1617 \$1638 254.864a
Cext_7605 \$1617 \$1643 0.360462a
Cext_7606 \$1617 \$1671 2.67626a
Cext_7607 \$1617 \$51 68.8031a
Cext_7608 \$1617 \$55 0.105966a
Cext_7609 \$1617 \$57 0.282145a
Cext_7610 \$1617 \$59 0.494517a
Cext_7611 \$1617 \$61 20.9159a
Cext_7612 \$1617 \$83 64.1221a
Cext_7613 \$1617 \$85 0.155901a
Cext_7614 \$1617 IOVDD|vdda 13.0646a
Cext_7615 \$1617 VSS|vss 66.2132a
Cext_7616 \$1617 VSUBS 817.761a
Cext_7617 \$1618 \$1619 2.46853a
Cext_7618 \$1618 \$1623 102.889a
Cext_7619 \$1618 \$1639 225.319a
Cext_7620 \$1618 \$1671 2.67468a
Cext_7621 \$1618 \$51 68.8428a
Cext_7622 \$1618 \$57 0.115752a
Cext_7623 \$1618 \$59 0.481837a
Cext_7624 \$1618 \$61 20.8391a
Cext_7625 \$1618 \$83 58.9193a
Cext_7626 \$1618 \$85 0.343978a
Cext_7627 \$1618 VSS|vss 69.9251a
Cext_7628 \$1618 VSUBS 811.815a
Cext_7629 \$1619 \$1623 231.736a
Cext_7630 \$1619 \$1664 98.5952a
Cext_7631 \$1619 \$51 2.95962a
Cext_7632 \$1619 \$53 103.882a
Cext_7633 \$1619 \$55 3.85958a
Cext_7634 \$1619 \$57 1.69123a
Cext_7635 \$1619 \$59 1.06485a
Cext_7636 \$1619 \$61 0.814163a
Cext_7637 \$1619 \$85 106.511a
Cext_7638 \$1619 \$87 53.9954a
Cext_7639 \$1619 \$89 3.34353a
Cext_7640 \$1619 \$91 1.52179a
Cext_7641 \$1619 \$93 1.0724a
Cext_7642 \$1619 VREF|vref 12.7505a
Cext_7643 \$1619 VSUBS 217.655a
Cext_7644 \$162 \$187 0.360462a
Cext_7645 \$162 \$188 0.250757a
Cext_7646 \$162 \$217 42.153a
Cext_7647 \$162 \$35 123.657a
Cext_7648 \$162 \$37 65.6459a
Cext_7649 \$162 \$39 0.62262a
Cext_7650 \$162 \$67 80.7075a
Cext_7651 \$162 \$69 70.7638a
Cext_7652 \$162 \$71 34.2797a
Cext_7653 \$162 \$73 32.5775a
Cext_7654 \$162 \$75 35.6349a
Cext_7655 \$162 \$77 45.8508a
Cext_7656 \$162 VSS|vss 0.335662a
Cext_7657 \$162 VSUBS 256.348a
Cext_7658 \$1620 \$1629 114.006a
Cext_7659 \$1620 \$1630 0.182933a
Cext_7660 \$1620 \$1649 0.360462a
Cext_7661 \$1620 \$1659 108.267a
Cext_7662 \$1620 \$35 123.657a
Cext_7663 \$1620 \$37 65.6459a
Cext_7664 \$1620 \$39 0.62262a
Cext_7665 \$1620 \$67 80.1821a
Cext_7666 \$1620 \$69 70.7638a
Cext_7667 \$1620 \$71 34.2797a
Cext_7668 \$1620 \$73 32.5775a
Cext_7669 \$1620 \$75 35.6349a
Cext_7670 \$1620 \$77 45.7852a
Cext_7671 \$1620 VSS|vss 0.378848a
Cext_7672 \$1620 VSUBS 256.15a
Cext_7673 \$1621 \$1631 114.006a
Cext_7674 \$1621 \$1651 0.360462a
Cext_7675 \$1621 \$1660 108.267a
Cext_7676 \$1621 \$35 123.657a
Cext_7677 \$1621 \$37 65.6459a
Cext_7678 \$1621 \$39 0.62262a
Cext_7679 \$1621 \$67 80.1821a
Cext_7680 \$1621 \$69 70.7638a
Cext_7681 \$1621 \$71 34.2797a
Cext_7682 \$1621 \$73 32.5775a
Cext_7683 \$1621 \$75 35.6349a
Cext_7684 \$1621 \$77 45.7852a
Cext_7685 \$1621 VREF|vref 0.182933a
Cext_7686 \$1621 VSS|vss 0.378848a
Cext_7687 \$1621 VSUBS 256.15a
Cext_7688 \$1622 \$1637 114.006a
Cext_7689 \$1622 \$1638 0.182933a
Cext_7690 \$1622 \$1656 0.360462a
Cext_7691 \$1622 \$1663 108.267a
Cext_7692 \$1622 \$51 123.657a
Cext_7693 \$1622 \$53 65.6459a
Cext_7694 \$1622 \$55 0.62262a
Cext_7695 \$1622 \$83 80.1821a
Cext_7696 \$1622 \$85 70.7638a
Cext_7697 \$1622 \$87 34.2797a
Cext_7698 \$1622 \$89 32.5775a
Cext_7699 \$1622 \$91 35.6349a
Cext_7700 \$1622 \$93 45.7852a
Cext_7701 \$1622 VSS|vss 0.378848a
Cext_7702 \$1622 VSUBS 256.15a
Cext_7703 \$1623 \$1639 114.006a
Cext_7704 \$1623 \$1658 0.360462a
Cext_7705 \$1623 \$1664 108.267a
Cext_7706 \$1623 \$51 123.657a
Cext_7707 \$1623 \$53 65.6459a
Cext_7708 \$1623 \$55 0.62262a
Cext_7709 \$1623 \$83 80.1821a
Cext_7710 \$1623 \$85 70.7638a
Cext_7711 \$1623 \$87 34.2797a
Cext_7712 \$1623 \$89 32.5775a
Cext_7713 \$1623 \$91 35.6349a
Cext_7714 \$1623 \$93 45.7852a
Cext_7715 \$1623 VREF|vref 0.182933a
Cext_7716 \$1623 VSS|vss 0.378848a
Cext_7717 \$1623 VSUBS 256.15a
Cext_7718 \$1624 \$1625 45.0654a
Cext_7719 \$1624 \$1644 130.175a
Cext_7720 \$1624 VDD|vdd 7.74075a
Cext_7721 \$1624 VSS|vss 1.71997a
Cext_7722 \$1624 VSUBS 659.267a
Cext_7723 \$1625 \$1626 45.0654a
Cext_7724 \$1625 \$1645 130.175a
Cext_7725 \$1625 VDD|vdd 0.968272a
Cext_7726 \$1625 VSUBS 634.529a
Cext_7727 \$1626 \$1627 45.0654a
Cext_7728 \$1626 \$1646 130.175a
Cext_7729 \$1626 VSUBS 634.529a
Cext_7730 \$1627 \$1628 45.8951a
Cext_7731 \$1627 \$1647 130.175a
Cext_7732 \$1627 VSS|vss 0.428128a
Cext_7733 \$1627 VSUBS 634.529a
Cext_7734 \$1628 \$1640 113.058a
Cext_7735 \$1628 \$1648 225.319a
Cext_7736 \$1628 \$1667 5.61422a
Cext_7737 \$1628 \$35 22.6915a
Cext_7738 \$1628 \$67 105.489a
Cext_7739 \$1628 VSS|vss 61.1015a
Cext_7740 \$1628 VSUBS 793.257a
Cext_7741 \$1629 \$1640 0.897729a
Cext_7742 \$1629 \$1649 254.864a
Cext_7743 \$1629 \$1659 0.360462a
Cext_7744 \$1629 \$1667 5.58536a
Cext_7745 \$1629 \$35 23.2117a
Cext_7746 \$1629 \$37 0.145978a
Cext_7747 \$1629 \$39 0.105966a
Cext_7748 \$1629 \$41 0.282145a
Cext_7749 \$1629 \$43 0.494517a
Cext_7750 \$1629 \$45 20.7622a
Cext_7751 \$1629 \$67 110.011a
Cext_7752 \$1629 VSS|vss 66.2132a
Cext_7753 \$1629 VSUBS 817.643a
Cext_7754 \$163 \$190 113.058a
Cext_7755 \$163 \$191 225.319a
Cext_7756 \$163 \$35 68.7272a
Cext_7757 \$163 \$41 0.115752a
Cext_7758 \$163 \$43 0.481837a
Cext_7759 \$163 \$45 20.9928a
Cext_7760 \$163 \$67 61.4215a
Cext_7761 \$163 \$71 0.343978a
Cext_7762 \$163 VSS|vss 60.9228a
Cext_7763 \$163 VSUBS 811.137a
Cext_7764 \$1630 \$1641 113.058a
Cext_7765 \$1630 \$1650 225.319a
Cext_7766 \$1630 \$1668 5.61422a
Cext_7767 \$1630 \$35 22.6915a
Cext_7768 \$1630 \$37 0.404672a
Cext_7769 \$1630 \$41 0.115752a
Cext_7770 \$1630 \$43 0.481837a
Cext_7771 \$1630 \$45 20.8391a
Cext_7772 \$1630 \$67 105.489a
Cext_7773 \$1630 IOVDD|vdda 11.5102a
Cext_7774 \$1630 VSS|vss 60.9228a
Cext_7775 \$1630 VSUBS 810.657a
Cext_7776 \$1631 \$1641 0.897729a
Cext_7777 \$1631 \$1651 254.864a
Cext_7778 \$1631 \$1660 0.360462a
Cext_7779 \$1631 \$1668 5.58536a
Cext_7780 \$1631 \$35 23.2117a
Cext_7781 \$1631 \$37 0.145978a
Cext_7782 \$1631 \$39 0.105966a
Cext_7783 \$1631 \$41 0.282145a
Cext_7784 \$1631 \$43 0.494517a
Cext_7785 \$1631 \$45 20.7622a
Cext_7786 \$1631 \$67 110.011a
Cext_7787 \$1631 VSS|vss 66.2132a
Cext_7788 \$1631 VSUBS 817.643a
Cext_7789 \$1632 \$1633 45.0654a
Cext_7790 \$1632 \$1652 130.128a
Cext_7791 \$1632 VDD|vdd 0.592094a
Cext_7792 \$1632 VSS|vss 25.1792a
Cext_7793 \$1632 VSUBS 659.267a
Cext_7794 \$1633 \$1634 45.0654a
Cext_7795 \$1633 \$1653 130.175a
Cext_7796 \$1633 VSS|vss 5.452a
Cext_7797 \$1633 VSUBS 634.529a
Cext_7798 \$1634 \$1635 45.0654a
Cext_7799 \$1634 \$1654 130.175a
Cext_7800 \$1634 VSUBS 634.529a
Cext_7801 \$1635 \$1636 45.8951a
Cext_7802 \$1635 \$1662 130.175a
Cext_7803 \$1635 VSS|vss 0.428128a
Cext_7804 \$1635 VSUBS 634.529a
Cext_7805 \$1636 \$1642 113.058a
Cext_7806 \$1636 \$1655 225.319a
Cext_7807 \$1636 \$1670 5.61422a
Cext_7808 \$1636 \$51 22.6915a
Cext_7809 \$1636 \$83 105.489a
Cext_7810 \$1636 VSS|vss 61.1015a
Cext_7811 \$1636 VSUBS 793.257a
Cext_7812 \$1637 \$1642 0.897729a
Cext_7813 \$1637 \$1656 254.864a
Cext_7814 \$1637 \$1663 0.360462a
Cext_7815 \$1637 \$1670 5.58536a
Cext_7816 \$1637 \$51 23.2117a
Cext_7817 \$1637 \$53 0.145978a
Cext_7818 \$1637 \$55 0.105966a
Cext_7819 \$1637 \$57 0.282145a
Cext_7820 \$1637 \$59 0.494517a
Cext_7821 \$1637 \$61 20.7622a
Cext_7822 \$1637 \$83 110.011a
Cext_7823 \$1637 VSS|vss 66.2132a
Cext_7824 \$1637 VSUBS 817.643a
Cext_7825 \$1638 \$1643 113.058a
Cext_7826 \$1638 \$1657 225.319a
Cext_7827 \$1638 \$1671 5.61422a
Cext_7828 \$1638 \$51 22.6915a
Cext_7829 \$1638 \$53 0.404672a
Cext_7830 \$1638 \$57 0.115752a
Cext_7831 \$1638 \$59 0.481837a
Cext_7832 \$1638 \$61 20.8391a
Cext_7833 \$1638 \$83 105.489a
Cext_7834 \$1638 IOVDD|vdda 11.5102a
Cext_7835 \$1638 VSS|vss 60.9228a
Cext_7836 \$1638 VSUBS 810.657a
Cext_7837 \$1639 \$1643 0.897729a
Cext_7838 \$1639 \$1658 254.864a
Cext_7839 \$1639 \$1664 0.360462a
Cext_7840 \$1639 \$1671 5.58536a
Cext_7841 \$1639 \$51 23.2117a
Cext_7842 \$1639 \$53 0.145978a
Cext_7843 \$1639 \$55 0.105966a
Cext_7844 \$1639 \$57 0.282145a
Cext_7845 \$1639 \$59 0.494517a
Cext_7846 \$1639 \$61 20.7622a
Cext_7847 \$1639 \$83 110.011a
Cext_7848 \$1639 VSS|vss 75.4228a
Cext_7849 \$1639 VSUBS 817.643a
Cext_7850 \$164 \$166 1.85779a
Cext_7851 \$164 \$190 231.736a
Cext_7852 \$164 \$191 3.25406a
Cext_7853 \$164 \$192 1.44306a
Cext_7854 \$164 \$220 7.41179a
Cext_7855 \$164 \$221 99.1454a
Cext_7856 \$164 \$35 0.592076a
Cext_7857 \$164 \$37 87.8495a
Cext_7858 \$164 \$39 50.4455a
Cext_7859 \$164 \$41 1.62297a
Cext_7860 \$164 \$43 0.919893a
Cext_7861 \$164 \$45 0.703335a
Cext_7862 \$164 \$67 2.80805a
Cext_7863 \$164 \$69 122.879a
Cext_7864 \$164 \$71 7.49159a
Cext_7865 \$164 \$73 3.34353a
Cext_7866 \$164 \$75 1.61371a
Cext_7867 \$164 \$77 1.13718a
Cext_7868 \$164 VSUBS 228.379a
Cext_7869 \$1640 \$1648 102.928a
Cext_7870 \$1640 \$1667 62.273a
Cext_7871 \$1640 \$35 120.591a
Cext_7872 \$1640 \$37 66.3132a
Cext_7873 \$1640 \$39 0.236929a
Cext_7874 \$1640 \$41 0.11468a
Cext_7875 \$1640 \$67 78.5106a
Cext_7876 \$1640 \$69 68.9966a
Cext_7877 \$1640 \$71 29.5916a
Cext_7878 \$1640 \$73 30.8103a
Cext_7879 \$1640 \$75 33.8677a
Cext_7880 \$1640 \$77 44.0836a
Cext_7881 \$1640 VSS|vss 10.0487a
Cext_7882 \$1640 VSUBS 299.381a
Cext_7883 \$1641 \$1650 102.928a
Cext_7884 \$1641 \$1668 62.273a
Cext_7885 \$1641 \$35 120.444a
Cext_7886 \$1641 \$37 66.3132a
Cext_7887 \$1641 \$39 0.236929a
Cext_7888 \$1641 \$41 0.11468a
Cext_7889 \$1641 \$67 78.4613a
Cext_7890 \$1641 \$69 68.9966a
Cext_7891 \$1641 \$71 29.5916a
Cext_7892 \$1641 \$73 30.8103a
Cext_7893 \$1641 \$75 33.8677a
Cext_7894 \$1641 \$77 44.0836a
Cext_7895 \$1641 IOVDD|vdda 40.336a
Cext_7896 \$1641 VSS|vss 10.0435a
Cext_7897 \$1641 VSUBS 299.2a
Cext_7898 \$1642 \$1655 102.928a
Cext_7899 \$1642 \$1670 62.273a
Cext_7900 \$1642 \$51 120.591a
Cext_7901 \$1642 \$53 66.3132a
Cext_7902 \$1642 \$55 0.236929a
Cext_7903 \$1642 \$57 0.11468a
Cext_7904 \$1642 \$83 78.5106a
Cext_7905 \$1642 \$85 68.9966a
Cext_7906 \$1642 \$87 29.5916a
Cext_7907 \$1642 \$89 30.8103a
Cext_7908 \$1642 \$91 33.8677a
Cext_7909 \$1642 \$93 44.0836a
Cext_7910 \$1642 VSS|vss 10.0487a
Cext_7911 \$1642 VSUBS 299.381a
Cext_7912 \$1643 \$1657 102.928a
Cext_7913 \$1643 \$1671 62.273a
Cext_7914 \$1643 \$51 120.444a
Cext_7915 \$1643 \$53 66.3132a
Cext_7916 \$1643 \$55 0.236929a
Cext_7917 \$1643 \$57 0.11468a
Cext_7918 \$1643 \$83 78.4613a
Cext_7919 \$1643 \$85 68.9966a
Cext_7920 \$1643 \$87 29.5916a
Cext_7921 \$1643 \$89 30.8103a
Cext_7922 \$1643 \$91 33.8677a
Cext_7923 \$1643 \$93 44.0836a
Cext_7924 \$1643 IOVDD|vdda 40.336a
Cext_7925 \$1643 VSS|vss 15.1198a
Cext_7926 \$1643 VSUBS 299.2a
Cext_7927 \$1644 \$1645 45.0654a
Cext_7928 \$1644 \$1665 130.175a
Cext_7929 \$1644 VDD|vdd 7.74075a
Cext_7930 \$1644 VREF|vref 2.77579a
Cext_7931 \$1644 VSS|vss 1.71997a
Cext_7932 \$1644 VSUBS 659.267a
Cext_7933 \$1645 \$1646 45.0654a
Cext_7934 \$1645 \$1665 130.175a
Cext_7935 \$1645 VDD|vdd 0.968272a
Cext_7936 \$1645 VREF|vref 2.77579a
Cext_7937 \$1645 VSUBS 634.529a
Cext_7938 \$1646 \$1647 45.0654a
Cext_7939 \$1646 \$1666 130.175a
Cext_7940 \$1646 VREF|vref 2.77579a
Cext_7941 \$1646 VSUBS 634.529a
Cext_7942 \$1647 \$1648 46.4004a
Cext_7943 \$1647 \$1666 130.175a
Cext_7944 \$1647 VREF|vref 2.77579a
Cext_7945 \$1647 VSS|vss 0.378729a
Cext_7946 \$1647 VSUBS 634.529a
Cext_7947 \$1648 \$1667 238.705a
Cext_7948 \$1648 \$35 69.2187a
Cext_7949 \$1648 \$67 55.8013a
Cext_7950 \$1648 \$75 0.248622a
Cext_7951 \$1648 \$77 0.355669a
Cext_7952 \$1648 VREF|vref 2.60695a
Cext_7953 \$1648 VSS|vss 79.5865a
Cext_7954 \$1648 VSUBS 829.678a
Cext_7955 \$1649 \$1659 113.058a
Cext_7956 \$1649 \$1667 241.699a
Cext_7957 \$1649 \$35 68.7272a
Cext_7958 \$1649 \$37 0.177599a
Cext_7959 \$1649 \$39 0.258003a
Cext_7960 \$1649 \$41 0.405131a
Cext_7961 \$1649 \$43 0.710075a
Cext_7962 \$1649 \$45 21.0936a
Cext_7963 \$1649 \$67 58.9193a
Cext_7964 \$1649 VREF|vref 2.59332a
Cext_7965 \$1649 VSS|vss 61.3325a
Cext_7966 \$1649 VSUBS 812.282a
Cext_7967 \$165 \$166 102.889a
Cext_7968 \$165 \$192 0.360462a
Cext_7969 \$165 \$193 0.250757a
Cext_7970 \$165 \$223 42.153a
Cext_7971 \$165 \$35 123.51a
Cext_7972 \$165 \$37 65.6459a
Cext_7973 \$165 \$39 0.62262a
Cext_7974 \$165 \$67 80.552a
Cext_7975 \$165 \$69 70.7638a
Cext_7976 \$165 \$71 34.2797a
Cext_7977 \$165 \$73 32.5775a
Cext_7978 \$165 \$75 35.6349a
Cext_7979 \$165 \$77 45.8508a
Cext_7980 \$165 IOVDD|vdda 41.6774a
Cext_7981 \$165 VSS|vss 0.335662a
Cext_7982 \$165 VSUBS 256.073a
Cext_7983 \$1650 \$1659 0.897729a
Cext_7984 \$1650 \$1668 238.705a
Cext_7985 \$1650 \$35 69.2187a
Cext_7986 \$1650 \$39 0.105966a
Cext_7987 \$1650 \$41 0.282145a
Cext_7988 \$1650 \$43 0.494517a
Cext_7989 \$1650 \$45 20.7622a
Cext_7990 \$1650 \$67 55.8013a
Cext_7991 \$1650 \$75 0.248622a
Cext_7992 \$1650 \$77 0.355669a
Cext_7993 \$1650 IOVDD|vdda 13.5175a
Cext_7994 \$1650 VREF|vref 2.60695a
Cext_7995 \$1650 VSS|vss 79.509a
Cext_7996 \$1650 VSUBS 847.693a
Cext_7997 \$1651 \$1660 113.058a
Cext_7998 \$1651 \$1668 241.699a
Cext_7999 \$1651 \$35 68.7272a
Cext_8000 \$1651 \$37 0.177599a
Cext_8001 \$1651 \$39 0.258003a
Cext_8002 \$1651 \$41 0.405131a
Cext_8003 \$1651 \$43 0.710075a
Cext_8004 \$1651 \$45 21.0936a
Cext_8005 \$1651 \$67 58.9193a
Cext_8006 \$1651 VREF|vref 2.59332a
Cext_8007 \$1651 VSS|vss 61.3325a
Cext_8008 \$1651 VSUBS 812.282a
Cext_8009 \$1652 \$1653 45.0654a
Cext_8010 \$1652 \$1669 130.128a
Cext_8011 \$1652 VDD|vdd 0.592094a
Cext_8012 \$1652 VREF|vref 2.76177a
Cext_8013 \$1652 VSS|vss 25.1792a
Cext_8014 \$1652 VSUBS 659.267a
Cext_8015 \$1653 \$1654 45.0654a
Cext_8016 \$1653 \$1669 130.175a
Cext_8017 \$1653 VREF|vref 2.77579a
Cext_8018 \$1653 VSS|vss 5.452a
Cext_8019 \$1653 VSUBS 634.529a
Cext_8020 \$1654 \$1661 130.175a
Cext_8021 \$1654 \$1662 45.0654a
Cext_8022 \$1654 VREF|vref 2.77579a
Cext_8023 \$1654 VSUBS 634.529a
Cext_8024 \$1655 \$1662 46.4004a
Cext_8025 \$1655 \$1670 238.705a
Cext_8026 \$1655 \$51 69.2187a
Cext_8027 \$1655 \$83 55.8013a
Cext_8028 \$1655 \$91 0.248622a
Cext_8029 \$1655 \$93 0.355669a
Cext_8030 \$1655 VREF|vref 2.60695a
Cext_8031 \$1655 VSS|vss 79.5865a
Cext_8032 \$1655 VSUBS 829.678a
Cext_8033 \$1656 \$1663 113.058a
Cext_8034 \$1656 \$1670 241.699a
Cext_8035 \$1656 \$51 68.7272a
Cext_8036 \$1656 \$53 0.177599a
Cext_8037 \$1656 \$55 0.258003a
Cext_8038 \$1656 \$57 0.405131a
Cext_8039 \$1656 \$59 0.710075a
Cext_8040 \$1656 \$61 21.0936a
Cext_8041 \$1656 \$83 58.9193a
Cext_8042 \$1656 VREF|vref 2.59332a
Cext_8043 \$1656 VSS|vss 61.3325a
Cext_8044 \$1656 VSUBS 812.282a
Cext_8045 \$1657 \$1663 0.897729a
Cext_8046 \$1657 \$1671 238.705a
Cext_8047 \$1657 \$51 69.2187a
Cext_8048 \$1657 \$55 0.105966a
Cext_8049 \$1657 \$57 0.282145a
Cext_8050 \$1657 \$59 0.494517a
Cext_8051 \$1657 \$61 20.7622a
Cext_8052 \$1657 \$83 55.8013a
Cext_8053 \$1657 \$91 0.248622a
Cext_8054 \$1657 \$93 0.355669a
Cext_8055 \$1657 IOVDD|vdda 13.5175a
Cext_8056 \$1657 VREF|vref 2.60695a
Cext_8057 \$1657 VSS|vss 79.509a
Cext_8058 \$1657 VSUBS 847.693a
Cext_8059 \$1658 \$1664 113.058a
Cext_8060 \$1658 \$1671 241.699a
Cext_8061 \$1658 \$51 68.7272a
Cext_8062 \$1658 \$53 0.177599a
Cext_8063 \$1658 \$55 0.258003a
Cext_8064 \$1658 \$57 0.405131a
Cext_8065 \$1658 \$59 0.710075a
Cext_8066 \$1658 \$61 21.0936a
Cext_8067 \$1658 \$83 58.9193a
Cext_8068 \$1658 VREF|vref 2.59332a
Cext_8069 \$1658 VSS|vss 70.6322a
Cext_8070 \$1658 VSUBS 812.282a
Cext_8071 \$1659 \$1667 102.928a
Cext_8072 \$1659 \$35 129.611a
Cext_8073 \$1659 \$37 19.6816a
Cext_8074 \$1659 \$39 0.236929a
Cext_8075 \$1659 \$41 0.11468a
Cext_8076 \$1659 \$67 70.0005a
Cext_8077 \$1659 \$69 116.051a
Cext_8078 \$1659 \$71 29.5916a
Cext_8079 \$1659 \$73 30.8103a
Cext_8080 \$1659 \$75 33.8677a
Cext_8081 \$1659 \$77 44.0836a
Cext_8082 \$1659 VREF|vref 0.575921a
Cext_8083 \$1659 VSS|vss 14.527a
Cext_8084 \$1659 VSUBS 341.083a
Cext_8085 \$166 \$190 0.182933a
Cext_8086 \$166 \$192 254.864a
Cext_8087 \$166 \$223 0.360462a
Cext_8088 \$166 \$35 69.0342a
Cext_8089 \$166 \$39 0.105966a
Cext_8090 \$166 \$41 0.282145a
Cext_8091 \$166 \$43 0.494517a
Cext_8092 \$166 \$45 20.7622a
Cext_8093 \$166 \$67 66.8204a
Cext_8094 \$166 \$71 0.168339a
Cext_8095 \$166 \$77 0.107779a
Cext_8096 \$166 IOVDD|vdda 13.2807a
Cext_8097 \$166 VSS|vss 66.2132a
Cext_8098 \$166 VSUBS 818.946a
Cext_8099 \$1660 \$1668 102.928a
Cext_8100 \$1660 \$35 129.611a
Cext_8101 \$1660 \$37 19.7132a
Cext_8102 \$1660 \$39 0.263254a
Cext_8103 \$1660 \$41 0.136931a
Cext_8104 \$1660 \$43 0.117241a
Cext_8105 \$1660 \$45 0.101498a
Cext_8106 \$1660 \$67 70.0005a
Cext_8107 \$1660 \$69 116.051a
Cext_8108 \$1660 \$71 29.5916a
Cext_8109 \$1660 \$73 30.8103a
Cext_8110 \$1660 \$75 33.8677a
Cext_8111 \$1660 \$77 44.0836a
Cext_8112 \$1660 VREF|vref 1.47365a
Cext_8113 \$1660 VSS|vss 14.527a
Cext_8114 \$1660 VSUBS 341.219a
Cext_8115 \$1661 \$1662 130.175a
Cext_8116 \$1661 \$1669 127.349a
Cext_8117 \$1661 \$1670 135.987a
Cext_8118 \$1661 icmp|inp 0.884502a
Cext_8119 \$1661 VREF|vref 49.7617a
Cext_8120 \$1661 VSS|vss 331.041a
Cext_8121 \$1661 VSUBS 2.6074f
Cext_8122 \$1662 VREF|vref 2.77579a
Cext_8123 \$1662 VSS|vss 0.378729a
Cext_8124 \$1662 VSUBS 634.529a
Cext_8125 \$1663 \$1670 102.928a
Cext_8126 \$1663 \$51 129.611a
Cext_8127 \$1663 \$53 19.6816a
Cext_8128 \$1663 \$55 0.236929a
Cext_8129 \$1663 \$57 0.11468a
Cext_8130 \$1663 \$83 70.0005a
Cext_8131 \$1663 \$85 116.051a
Cext_8132 \$1663 \$87 29.5916a
Cext_8133 \$1663 \$89 30.8103a
Cext_8134 \$1663 \$91 33.8677a
Cext_8135 \$1663 \$93 44.0836a
Cext_8136 \$1663 VREF|vref 0.575921a
Cext_8137 \$1663 VSS|vss 14.527a
Cext_8138 \$1663 VSUBS 341.083a
Cext_8139 \$1664 \$1671 102.928a
Cext_8140 \$1664 \$51 129.611a
Cext_8141 \$1664 \$53 19.7132a
Cext_8142 \$1664 \$55 0.263254a
Cext_8143 \$1664 \$57 0.136931a
Cext_8144 \$1664 \$59 0.117241a
Cext_8145 \$1664 \$61 0.101498a
Cext_8146 \$1664 \$83 70.0005a
Cext_8147 \$1664 \$85 116.051a
Cext_8148 \$1664 \$87 29.5916a
Cext_8149 \$1664 \$89 30.8103a
Cext_8150 \$1664 \$91 33.8677a
Cext_8151 \$1664 \$93 44.0836a
Cext_8152 \$1664 VREF|vref 1.47365a
Cext_8153 \$1664 VSS|vss 14.527a
Cext_8154 \$1664 VSUBS 341.219a
Cext_8155 \$1665 \$1666 127.349a
Cext_8156 \$1665 VDD|vdd 34.2278a
Cext_8157 \$1665 VREF|vref 49.7617a
Cext_8158 \$1665 VSS|vss 355.581a
Cext_8159 \$1665 VSUBS 2.68668f
Cext_8160 \$1666 \$1667 135.987a
Cext_8161 \$1666 VREF|vref 49.7617a
Cext_8162 \$1666 VSS|vss 353.598a
Cext_8163 \$1666 VSUBS 2.6074f
Cext_8164 \$1667 \$35 32.3019a
Cext_8165 \$1667 \$37 7.36192a
Cext_8166 \$1667 \$39 4.68257a
Cext_8167 \$1667 \$41 4.21737a
Cext_8168 \$1667 \$43 4.21737a
Cext_8169 \$1667 \$45 4.21737a
Cext_8170 \$1667 \$67 105.654a
Cext_8171 \$1667 \$69 4.66662a
Cext_8172 \$1667 \$71 3.12109a
Cext_8173 \$1667 \$73 3.12109a
Cext_8174 \$1667 \$75 3.36971a
Cext_8175 \$1667 \$77 3.47676a
Cext_8176 \$1667 icmp|inp 4.68685a
Cext_8177 \$1667 VREF|vref 52.1308a
Cext_8178 \$1667 VSS|vss 648.159a
Cext_8179 \$1667 VSUBS 4.05527f
Cext_8180 \$1668 \$35 32.2722a
Cext_8181 \$1668 \$37 7.76536a
Cext_8182 \$1668 \$39 5.2608a
Cext_8183 \$1668 \$41 5.10746a
Cext_8184 \$1668 \$43 5.7301a
Cext_8185 \$1668 \$45 27.6875a
Cext_8186 \$1668 \$67 105.654a
Cext_8187 \$1668 \$69 4.66662a
Cext_8188 \$1668 \$71 3.12109a
Cext_8189 \$1668 \$73 3.12109a
Cext_8190 \$1668 \$75 3.36971a
Cext_8191 \$1668 \$77 3.47676a
Cext_8192 \$1668 icmp|inp 5.76655a
Cext_8193 \$1668 IOVDD|vdda 66.5631a
Cext_8194 \$1668 VREF|vref 52.09a
Cext_8195 \$1668 VSS|vss 647.992a
Cext_8196 \$1668 VSUBS 4.13292f
Cext_8197 \$1669 icmp|inp 0.787206a
Cext_8198 \$1669 VDD|vdd 1.96201a
Cext_8199 \$1669 VREF|vref 49.5875a
Cext_8200 \$1669 VSS|vss 427.916a
Cext_8201 \$1669 VSUBS 2.68668f
Cext_8202 \$167 \$195 113.058a
Cext_8203 \$167 \$196 225.319a
Cext_8204 \$167 \$35 68.7272a
Cext_8205 \$167 \$41 0.115752a
Cext_8206 \$167 \$43 0.481837a
Cext_8207 \$167 \$45 20.9928a
Cext_8208 \$167 \$67 61.4215a
Cext_8209 \$167 \$71 0.343978a
Cext_8210 \$167 VSS|vss 60.9228a
Cext_8211 \$167 VSUBS 811.137a
Cext_8212 \$1670 \$51 32.3019a
Cext_8213 \$1670 \$53 7.36192a
Cext_8214 \$1670 \$55 4.68257a
Cext_8215 \$1670 \$57 4.21737a
Cext_8216 \$1670 \$59 4.21737a
Cext_8217 \$1670 \$61 4.21737a
Cext_8218 \$1670 \$83 105.654a
Cext_8219 \$1670 \$85 4.66662a
Cext_8220 \$1670 \$87 3.12109a
Cext_8221 \$1670 \$89 3.12109a
Cext_8222 \$1670 \$91 3.36971a
Cext_8223 \$1670 \$93 3.47676a
Cext_8224 \$1670 icmp|inp 2.31023a
Cext_8225 \$1670 inn|out|vth_hard 0.211686a
Cext_8226 \$1670 VREF|vref 52.096a
Cext_8227 \$1670 VSS|vss 620.033a
Cext_8228 \$1670 VSUBS 4.06287f
Cext_8229 \$1671 \$51 32.2722a
Cext_8230 \$1671 \$53 7.76536a
Cext_8231 \$1671 \$55 5.2608a
Cext_8232 \$1671 \$57 5.08949a
Cext_8233 \$1671 \$59 5.7301a
Cext_8234 \$1671 \$61 27.6875a
Cext_8235 \$1671 \$83 105.654a
Cext_8236 \$1671 \$85 4.66662a
Cext_8237 \$1671 \$87 3.12109a
Cext_8238 \$1671 \$89 3.12109a
Cext_8239 \$1671 \$91 3.36971a
Cext_8240 \$1671 \$93 3.47676a
Cext_8241 \$1671 icmp|inp 2.23027a
Cext_8242 \$1671 inn|out|vth_hard 0.483854a
Cext_8243 \$1671 IOVDD|vdda 65.6032a
Cext_8244 \$1671 VREF|vref 51.9565a
Cext_8245 \$1671 VSS|vss 701.041a
Cext_8246 \$1671 VSUBS 4.14052f
Cext_8247 \$1674 \$1675 40.4982a
Cext_8248 \$1674 ISENSE|isense 45.3539a
Cext_8249 \$1674 VDD|vdd 8.91134a
Cext_8250 \$1674 VREF|vref 4.3426a
Cext_8251 \$1674 VSS|vss 49.964a
Cext_8252 \$1674 VSUBS 843.742a
Cext_8253 \$1675 \$1676 40.5436a
Cext_8254 \$1675 ISENSE|isense 0.254819a
Cext_8255 \$1675 VDD|vdd 2.04304a
Cext_8256 \$1675 VREF|vref 4.3426a
Cext_8257 \$1675 VSS|vss 49.964a
Cext_8258 \$1675 VSUBS 843.742a
Cext_8259 \$1676 \$1677 40.4982a
Cext_8260 \$1676 VREF|vref 4.3426a
Cext_8261 \$1676 VSS|vss 49.964a
Cext_8262 \$1676 VSUBS 843.742a
Cext_8263 \$1677 icmp|inp 42.2264a
Cext_8264 \$1677 VREF|vref 4.3426a
Cext_8265 \$1677 VSS|vss 49.964a
Cext_8266 \$1677 VSUBS 843.742a
Cext_8267 \$1678 \$1679 40.4982a
Cext_8268 \$1678 icmp|inp 64.4374a
Cext_8269 \$1678 VREF|vref 4.25297a
Cext_8270 \$1678 VSS|vss 49.8027a
Cext_8271 \$1678 VSUBS 843.742a
Cext_8272 \$1679 \$1680 40.5436a
Cext_8273 \$1679 icmp|inp 22.2474a
Cext_8274 \$1679 VREF|vref 4.3426a
Cext_8275 \$1679 VSS|vss 49.964a
Cext_8276 \$1679 VSUBS 843.742a
Cext_8277 \$168 \$169 1.85779a
Cext_8278 \$168 \$195 231.736a
Cext_8279 \$168 \$196 3.25406a
Cext_8280 \$168 \$197 1.44306a
Cext_8281 \$168 \$225 99.1454a
Cext_8282 \$168 \$226 7.41179a
Cext_8283 \$168 \$35 0.592076a
Cext_8284 \$168 \$37 87.8495a
Cext_8285 \$168 \$39 50.4455a
Cext_8286 \$168 \$41 1.62297a
Cext_8287 \$168 \$43 0.919893a
Cext_8288 \$168 \$45 0.703335a
Cext_8289 \$168 \$67 2.80805a
Cext_8290 \$168 \$69 122.879a
Cext_8291 \$168 \$71 7.49159a
Cext_8292 \$168 \$73 3.34353a
Cext_8293 \$168 \$75 1.61371a
Cext_8294 \$168 \$77 1.13718a
Cext_8295 \$168 VSUBS 228.379a
Cext_8296 \$1680 \$1681 40.5436a
Cext_8297 \$1680 icmp|inp 22.2474a
Cext_8298 \$1680 VREF|vref 4.3426a
Cext_8299 \$1680 VSS|vss 49.964a
Cext_8300 \$1680 VSUBS 843.742a
Cext_8301 \$1681 icmp|inp 22.2474a
Cext_8302 \$1681 VREF|vref 4.22925a
Cext_8303 \$1681 VSS|vss 91.3594a
Cext_8304 \$1681 VSUBS 843.742a
Cext_8305 \$1688 \$1689 246.275a
Cext_8306 \$1688 \$1691 1.54816f
Cext_8307 \$1688 \$1692 0.220836a
Cext_8308 \$1688 \$1693 0.477749a
Cext_8309 \$1688 \$1706 56.8023a
Cext_8310 \$1688 clk 2.71185a
Cext_8311 \$1688 cmp_soft|q 2.21203f
Cext_8312 \$1688 icmp|inp 0.291079a
Cext_8313 \$1688 inn|out|vth_soft 38.7355a
Cext_8314 \$1688 qb$1 125.516a
Cext_8315 \$1688 VDD|vdd 169.075a
Cext_8316 \$1688 VSS|vss 657.352a
Cext_8317 \$1688 VSUBS 1.5204f
Cext_8318 \$1689 \$1691 3.21001f
Cext_8319 \$1689 \$1692 3.77995f
Cext_8320 \$1689 \$1693 156.871a
Cext_8321 \$1689 \$1694 1.41682a
Cext_8322 \$1689 \$1695 1.54733f
Cext_8323 \$1689 clk 844.394a
Cext_8324 \$1689 cmp_soft|q 103.608a
Cext_8325 \$1689 icmp|inp 59.2075a
Cext_8326 \$1689 inn|out|vth_soft 84.1503a
Cext_8327 \$1689 qb$1 3.15405f
Cext_8328 \$1689 VDD|vdd 1.17983f
Cext_8329 \$1689 VSS|vss 611.073a
Cext_8330 \$1689 VSUBS 3.14604f
Cext_8331 \$169 \$195 0.182933a
Cext_8332 \$169 \$197 130.175a
Cext_8333 \$169 \$39 0.105966a
Cext_8334 \$169 \$41 0.282145a
Cext_8335 \$169 \$43 0.494517a
Cext_8336 \$169 \$45 20.9126a
Cext_8337 \$169 \$67 2.68467a
Cext_8338 \$169 VSS|vss 2.2008a
Cext_8339 \$169 VSUBS 676a
Cext_8340 \$1690 \$1697 246.275a
Cext_8341 \$1690 \$1698 3.21001f
Cext_8342 \$1690 \$1699 3.77995f
Cext_8343 \$1690 \$1700 156.871a
Cext_8344 \$1690 \$1701 1.41682a
Cext_8345 \$1690 \$1702 1.54733f
Cext_8346 \$1690 clk|cmp_clk_n 844.394a
Cext_8347 \$1690 cmp_hard|q 103.608a
Cext_8348 \$1690 icmp|inp 58.6254a
Cext_8349 \$1690 inn|out|vth_hard 87.4788a
Cext_8350 \$1690 qb$1 3.15405f
Cext_8351 \$1690 VDD|vdd 1.17983f
Cext_8352 \$1690 VSS|vss 611.073a
Cext_8353 \$1690 VSUBS 3.14604f
Cext_8354 \$1691 \$1692 156.649a
Cext_8355 \$1691 \$1693 3.7799f
Cext_8356 \$1691 \$1694 0.395782a
Cext_8357 \$1691 \$1695 246.275a
Cext_8358 \$1691 clk 818.154a
Cext_8359 \$1691 cmp_soft|q 3.15902f
Cext_8360 \$1691 icmp|inp 84.3748a
Cext_8361 \$1691 inn|out|vth_soft 56.9153a
Cext_8362 \$1691 qb$1 98.6693a
Cext_8363 \$1691 VDD|vdd 1.17998f
Cext_8364 \$1691 VSS|vss 610.927a
Cext_8365 \$1691 VSUBS 3.14031f
Cext_8366 \$1692 \$1693 2.00043f
Cext_8367 \$1692 \$1694 729.113a
Cext_8368 \$1692 \$1695 0.477749a
Cext_8369 \$1692 clk 2.6857f
Cext_8370 \$1692 cmp_soft|q 91.3942a
Cext_8371 \$1692 icmp|inp 252.45a
Cext_8372 \$1692 inn|out|vth_soft 192.99a
Cext_8373 \$1692 qb$1 106.183a
Cext_8374 \$1692 VDD|vdd 449.032a
Cext_8375 \$1692 VSS|vss 131.656a
Cext_8376 \$1692 VSUBS 1.85431f
Cext_8377 \$1693 \$1694 728.871a
Cext_8378 \$1693 \$1695 0.220836a
Cext_8379 \$1693 clk 2.65961f
Cext_8380 \$1693 cmp_soft|q 93.7882a
Cext_8381 \$1693 icmp|inp 191.795a
Cext_8382 \$1693 inn|out|vth_soft 252.313a
Cext_8383 \$1693 qb$1 103.7a
Cext_8384 \$1693 VDD|vdd 449.319a
Cext_8385 \$1693 VSS|vss 131.521a
Cext_8386 \$1693 VSUBS 1.85427f
Cext_8387 \$1694 clk 328.154a
Cext_8388 \$1694 icmp|inp 252.281a
Cext_8389 \$1694 inn|out|vth_soft 252.281a
Cext_8390 \$1694 qb$1 139.89a
Cext_8391 \$1694 VDD|vdd 0.809057a
Cext_8392 \$1694 VSS|vss 1.61127f
Cext_8393 \$1694 VSUBS 639.177a
Cext_8394 \$1695 \$1707 56.8023a
Cext_8395 \$1695 clk 2.71185a
Cext_8396 \$1695 cmp_soft|q 611.384a
Cext_8397 \$1695 icmp|inp 38.9458a
Cext_8398 \$1695 qb$1 1.71865f
Cext_8399 \$1695 VDD|vdd 169.075a
Cext_8400 \$1695 VSS|vss 657.36a
Cext_8401 \$1695 VSUBS 1.52272f
Cext_8402 \$1697 \$1698 1.54816f
Cext_8403 \$1697 \$1699 0.220836a
Cext_8404 \$1697 \$1700 0.477749a
Cext_8405 \$1697 \$1705 56.8023a
Cext_8406 \$1697 clk|cmp_clk_n 2.71185a
Cext_8407 \$1697 cmp_hard|q 2.21203f
Cext_8408 \$1697 inn|out|vth_hard 40.4972a
Cext_8409 \$1697 qb$1 125.516a
Cext_8410 \$1697 VDD|vdd 169.075a
Cext_8411 \$1697 VSS|vss 657.228a
Cext_8412 \$1697 VSUBS 1.5204f
Cext_8413 \$1698 \$1699 156.649a
Cext_8414 \$1698 \$1700 3.7799f
Cext_8415 \$1698 \$1701 0.395782a
Cext_8416 \$1698 \$1702 246.275a
Cext_8417 \$1698 clk|cmp_clk_n 818.154a
Cext_8418 \$1698 cmp_hard|q 3.15902f
Cext_8419 \$1698 icmp|inp 83.7926a
Cext_8420 \$1698 inn|out|vth_hard 60.2437a
Cext_8421 \$1698 qb$1 98.6693a
Cext_8422 \$1698 VDD|vdd 1.17998f
Cext_8423 \$1698 VSS|vss 611.073a
Cext_8424 \$1698 VSUBS 3.14031f
Cext_8425 \$1699 \$1700 2.00043f
Cext_8426 \$1699 \$1701 729.113a
Cext_8427 \$1699 \$1702 0.477749a
Cext_8428 \$1699 clk|cmp_clk_n 2.6857f
Cext_8429 \$1699 cmp_hard|q 91.3942a
Cext_8430 \$1699 icmp|inp 252.45a
Cext_8431 \$1699 inn|out|vth_hard 195.669a
Cext_8432 \$1699 qb$1 106.183a
Cext_8433 \$1699 VDD|vdd 449.032a
Cext_8434 \$1699 VSS|vss 131.656a
Cext_8435 \$1699 VSUBS 1.85431f
Cext_8436 \$170 \$171 45.0654a
Cext_8437 \$170 \$198 130.058a
Cext_8438 \$170 VDD|vdd 0.592094a
Cext_8439 \$170 VSS|vss 25.5791a
Cext_8440 \$170 VSUBS 659.267a
Cext_8441 \$1700 \$1701 728.871a
Cext_8442 \$1700 \$1702 0.220836a
Cext_8443 \$1700 clk|cmp_clk_n 2.65961f
Cext_8444 \$1700 cmp_hard|q 93.7882a
Cext_8445 \$1700 icmp|inp 191.795a
Cext_8446 \$1700 inn|out|vth_hard 254.992a
Cext_8447 \$1700 qb$1 103.7a
Cext_8448 \$1700 VDD|vdd 449.319a
Cext_8449 \$1700 VSS|vss 131.521a
Cext_8450 \$1700 VSUBS 1.85427f
Cext_8451 \$1701 clk|cmp_clk_n 328.154a
Cext_8452 \$1701 icmp|inp 252.281a
Cext_8453 \$1701 inn|out|vth_hard 254.424a
Cext_8454 \$1701 qb$1 139.89a
Cext_8455 \$1701 VDD|vdd 0.809057a
Cext_8456 \$1701 VSS|vss 1.61127f
Cext_8457 \$1701 VSUBS 639.177a
Cext_8458 \$1702 \$1708 56.8023a
Cext_8459 \$1702 clk|cmp_clk_n 2.71185a
Cext_8460 \$1702 cmp_hard|q 611.384a
Cext_8461 \$1702 icmp|inp 38.6548a
Cext_8462 \$1702 inn|out|vth_hard 1.76174a
Cext_8463 \$1702 qb$1 1.71865f
Cext_8464 \$1702 VDD|vdd 169.075a
Cext_8465 \$1702 VSS|vss 657.36a
Cext_8466 \$1702 VSUBS 1.52272f
Cext_8467 \$1705 cmp_hard|q 450.453a
Cext_8468 \$1705 qb$1 44.9322a
Cext_8469 \$1705 VDD|vdd 526.91a
Cext_8470 \$1705 VSS|vss 5.77687a
Cext_8471 \$1705 VSUBS 303.389a
Cext_8472 \$1706 cmp_soft|q 450.453a
Cext_8473 \$1706 qb$1 44.9322a
Cext_8474 \$1706 VDD|vdd 527.79a
Cext_8475 \$1706 VSS|vss 5.77687a
Cext_8476 \$1706 VSUBS 303.389a
Cext_8477 \$1707 cmp_soft|q 47.3027a
Cext_8478 \$1707 qb$1 444.833a
Cext_8479 \$1707 VDD|vdd 526.91a
Cext_8480 \$1707 VSS|vss 5.77687a
Cext_8481 \$1707 VSUBS 303.611a
Cext_8482 \$1708 cmp_hard|q 47.3027a
Cext_8483 \$1708 qb$1 444.833a
Cext_8484 \$1708 VDD|vdd 526.91a
Cext_8485 \$1708 VSS|vss 5.77687a
Cext_8486 \$1708 VSUBS 303.611a
Cext_8487 \$1709 \$1710 40.5436a
Cext_8488 \$1709 IOVDD|vdda 6.07411a
Cext_8489 \$1709 VDD|vdd 32.8375a
Cext_8490 \$1709 VSS|vss 53.5149a
Cext_8491 \$1709 VSUBS 855.282a
Cext_8492 \$171 \$172 45.0654a
Cext_8493 \$171 \$199 130.175a
Cext_8494 \$171 \$83 1.3178a
Cext_8495 \$171 VSS|vss 5.452a
Cext_8496 \$171 VSUBS 634.529a
Cext_8497 \$1710 \$1711 40.5436a
Cext_8498 \$1710 IOVDD|vdda 6.13182a
Cext_8499 \$1710 VDD|vdd 5.10912a
Cext_8500 \$1710 VSS|vss 50.3295a
Cext_8501 \$1710 VSUBS 835.036a
Cext_8502 \$1711 \$1712 40.5436a
Cext_8503 \$1711 IOVDD|vdda 6.13182a
Cext_8504 \$1711 VDD|vdd 0.138636a
Cext_8505 \$1711 VSS|vss 50.3295a
Cext_8506 \$1711 VSUBS 835.036a
Cext_8507 \$1712 \$1713 40.5436a
Cext_8508 \$1712 IOVDD|vdda 6.13182a
Cext_8509 \$1712 VSS|vss 50.3295a
Cext_8510 \$1712 VSUBS 835.036a
Cext_8511 \$1713 \$1714 40.5436a
Cext_8512 \$1713 IOVDD|vdda 6.13182a
Cext_8513 \$1713 VSS|vss 50.3295a
Cext_8514 \$1713 VSUBS 835.036a
Cext_8515 \$1714 \$1715 40.5436a
Cext_8516 \$1714 IOVDD|vdda 6.13182a
Cext_8517 \$1714 VSS|vss 50.3295a
Cext_8518 \$1714 VSUBS 835.036a
Cext_8519 \$1715 \$1716 40.5436a
Cext_8520 \$1715 IOVDD|vdda 6.13182a
Cext_8521 \$1715 VSS|vss 50.3295a
Cext_8522 \$1715 VSUBS 835.036a
Cext_8523 \$1716 \$1717 40.5436a
Cext_8524 \$1716 IOVDD|vdda 6.13182a
Cext_8525 \$1716 VSS|vss 50.3295a
Cext_8526 \$1716 VSUBS 835.036a
Cext_8527 \$1717 \$1718 40.5436a
Cext_8528 \$1717 IOVDD|vdda 6.13182a
Cext_8529 \$1717 VSS|vss 50.3295a
Cext_8530 \$1717 VSUBS 835.036a
Cext_8531 \$1718 IOVDD|vdda 6.13182a
Cext_8532 \$1718 VSS|vss 50.3295a
Cext_8533 \$1718 VSUBS 856.671a
Cext_8534 \$172 \$173 45.0654a
Cext_8535 \$172 \$200 130.175a
Cext_8536 \$172 \$83 2.77579a
Cext_8537 \$172 VSUBS 634.529a
Cext_8538 \$173 \$174 46.4004a
Cext_8539 \$173 \$201 130.175a
Cext_8540 \$173 \$83 2.77579a
Cext_8541 \$173 VSS|vss 0.378729a
Cext_8542 \$173 VSUBS 634.529a
Cext_8543 \$174 \$175 102.889a
Cext_8544 \$174 \$202 254.864a
Cext_8545 \$174 \$232 0.360462a
Cext_8546 \$174 \$51 69.0342a
Cext_8547 \$174 \$83 66.8204a
Cext_8548 \$174 \$87 0.168339a
Cext_8549 \$174 \$93 0.107779a
Cext_8550 \$174 VSS|vss 66.2906a
Cext_8551 \$174 VSUBS 800.931a
Cext_8552 \$175 \$202 0.360462a
Cext_8553 \$175 \$203 0.250757a
Cext_8554 \$175 \$232 42.153a
Cext_8555 \$175 \$51 123.657a
Cext_8556 \$175 \$53 65.6459a
Cext_8557 \$175 \$55 0.62262a
Cext_8558 \$175 \$83 80.7075a
Cext_8559 \$175 \$85 70.7638a
Cext_8560 \$175 \$87 34.2797a
Cext_8561 \$175 \$89 32.5775a
Cext_8562 \$175 \$91 35.6349a
Cext_8563 \$175 \$93 45.8508a
Cext_8564 \$175 VSS|vss 0.335662a
Cext_8565 \$175 VSUBS 256.348a
Cext_8566 \$176 \$205 113.058a
Cext_8567 \$176 \$206 225.319a
Cext_8568 \$176 \$51 68.7272a
Cext_8569 \$176 \$57 0.115752a
Cext_8570 \$176 \$59 0.481837a
Cext_8571 \$176 \$61 20.9928a
Cext_8572 \$176 \$83 61.4215a
Cext_8573 \$176 \$87 0.343978a
Cext_8574 \$176 VSS|vss 60.9228a
Cext_8575 \$176 VSUBS 811.137a
Cext_8576 \$177 \$179 1.85779a
Cext_8577 \$177 \$205 231.736a
Cext_8578 \$177 \$206 3.25406a
Cext_8579 \$177 \$207 1.44306a
Cext_8580 \$177 \$235 99.1454a
Cext_8581 \$177 \$236 7.41179a
Cext_8582 \$177 \$51 0.592076a
Cext_8583 \$177 \$53 87.8495a
Cext_8584 \$177 \$55 50.4455a
Cext_8585 \$177 \$57 1.62297a
Cext_8586 \$177 \$59 0.919893a
Cext_8587 \$177 \$61 0.703335a
Cext_8588 \$177 \$83 2.80805a
Cext_8589 \$177 \$85 122.879a
Cext_8590 \$177 \$87 7.49159a
Cext_8591 \$177 \$89 3.34353a
Cext_8592 \$177 \$91 1.61371a
Cext_8593 \$177 \$93 1.13718a
Cext_8594 \$177 VSUBS 228.379a
Cext_8595 \$178 \$179 102.889a
Cext_8596 \$178 \$207 0.360462a
Cext_8597 \$178 \$208 0.250757a
Cext_8598 \$178 \$237 42.153a
Cext_8599 \$178 \$51 123.51a
Cext_8600 \$178 \$53 65.6459a
Cext_8601 \$178 \$55 0.62262a
Cext_8602 \$178 \$83 80.552a
Cext_8603 \$178 \$85 70.7638a
Cext_8604 \$178 \$87 34.2797a
Cext_8605 \$178 \$89 32.5775a
Cext_8606 \$178 \$91 35.6349a
Cext_8607 \$178 \$93 45.8508a
Cext_8608 \$178 IOVDD|vdda 41.6774a
Cext_8609 \$178 VSS|vss 4.14223a
Cext_8610 \$178 VSUBS 256.073a
Cext_8611 \$179 \$205 0.182933a
Cext_8612 \$179 \$207 254.864a
Cext_8613 \$179 \$237 0.360462a
Cext_8614 \$179 \$51 69.0342a
Cext_8615 \$179 \$55 0.105966a
Cext_8616 \$179 \$57 0.282145a
Cext_8617 \$179 \$59 0.494517a
Cext_8618 \$179 \$61 20.7622a
Cext_8619 \$179 \$83 66.8204a
Cext_8620 \$179 \$87 0.168339a
Cext_8621 \$179 \$93 0.107779a
Cext_8622 \$179 IOVDD|vdda 13.2807a
Cext_8623 \$179 VSS|vss 66.2132a
Cext_8624 \$179 VSUBS 818.946a
Cext_8625 \$18 \$34 192.404a
Cext_8626 \$18 \$35 6.84421a
Cext_8627 \$18 \$66 52.8067a
Cext_8628 \$18 d0|dac_soft[0] 211.632a
Cext_8629 \$18 d1|dac_soft[1] 13.2435a
Cext_8630 \$18 d7|dac_soft[7] 1.18751a
Cext_8631 \$18 IOVDD|vdda 0.413187a
Cext_8632 \$18 VDD|vdd 473.719a
Cext_8633 \$18 VSS|vss 298.029a
Cext_8634 \$18 VSUBS 574.268a
Cext_8635 \$180 \$210 113.058a
Cext_8636 \$180 \$211 225.319a
Cext_8637 \$180 \$51 68.7272a
Cext_8638 \$180 \$57 0.115752a
Cext_8639 \$180 \$59 0.481837a
Cext_8640 \$180 \$61 20.9928a
Cext_8641 \$180 \$83 61.4215a
Cext_8642 \$180 \$87 0.343978a
Cext_8643 \$180 VSS|vss 69.9251a
Cext_8644 \$180 VSUBS 811.137a
Cext_8645 \$181 \$182 1.85779a
Cext_8646 \$181 \$210 231.736a
Cext_8647 \$181 \$211 3.25406a
Cext_8648 \$181 \$212 1.44306a
Cext_8649 \$181 \$240 99.1454a
Cext_8650 \$181 \$241 7.41179a
Cext_8651 \$181 \$51 0.592076a
Cext_8652 \$181 \$53 87.8495a
Cext_8653 \$181 \$55 50.4455a
Cext_8654 \$181 \$57 1.62297a
Cext_8655 \$181 \$59 0.919893a
Cext_8656 \$181 \$61 0.703335a
Cext_8657 \$181 \$83 2.80805a
Cext_8658 \$181 \$85 122.879a
Cext_8659 \$181 \$87 7.49159a
Cext_8660 \$181 \$89 3.34353a
Cext_8661 \$181 \$91 1.61371a
Cext_8662 \$181 \$93 1.13718a
Cext_8663 \$181 VSUBS 228.379a
Cext_8664 \$182 \$210 0.182933a
Cext_8665 \$182 \$212 130.175a
Cext_8666 \$182 \$55 0.105966a
Cext_8667 \$182 \$57 0.282145a
Cext_8668 \$182 \$59 0.494517a
Cext_8669 \$182 \$61 20.9126a
Cext_8670 \$182 \$83 2.68467a
Cext_8671 \$182 VSS|vss 2.2008a
Cext_8672 \$182 VSUBS 676a
Cext_8673 \$183 \$184 45.0654a
Cext_8674 \$183 \$213 130.105a
Cext_8675 \$183 VDD|vdd 7.74075a
Cext_8676 \$183 VSS|vss 1.71997a
Cext_8677 \$183 VSUBS 659.267a
Cext_8678 \$184 \$185 45.0654a
Cext_8679 \$184 \$214 130.175a
Cext_8680 \$184 VDD|vdd 0.968272a
Cext_8681 \$184 VSUBS 634.529a
Cext_8682 \$185 \$186 45.0654a
Cext_8683 \$185 \$215 130.175a
Cext_8684 \$185 VSUBS 634.529a
Cext_8685 \$186 \$187 45.8951a
Cext_8686 \$186 \$216 130.175a
Cext_8687 \$186 VSS|vss 0.428128a
Cext_8688 \$186 VSUBS 634.529a
Cext_8689 \$187 \$189 2.46853a
Cext_8690 \$187 \$217 102.889a
Cext_8691 \$187 \$218 225.319a
Cext_8692 \$187 \$35 22.8071a
Cext_8693 \$187 \$67 105.489a
Cext_8694 \$187 VSS|vss 61.1015a
Cext_8695 \$187 VSUBS 793.935a
Cext_8696 \$188 \$189 789.439a
Cext_8697 \$188 \$191 4.39525a
Cext_8698 \$188 \$217 18.9a
Cext_8699 \$188 \$219 3.88628a
Cext_8700 \$188 \$252 4.39525a
Cext_8701 \$188 \$265 86.9579a
Cext_8702 \$188 \$273 2.88751a
Cext_8703 \$188 \$274 3.32751a
Cext_8704 \$188 \$287 99.1454a
Cext_8705 \$188 \$300 7.41179a
Cext_8706 \$188 \$35 2.65407a
Cext_8707 \$188 \$37 79.2662a
Cext_8708 \$188 \$39 73.3394a
Cext_8709 \$188 \$41 7.1267a
Cext_8710 \$188 \$43 3.42755a
Cext_8711 \$188 \$45 1.99452a
Cext_8712 \$188 \$69 64.9505a
Cext_8713 \$188 \$71 50.2205a
Cext_8714 \$188 \$73 49.6419a
Cext_8715 \$188 \$75 1.56603a
Cext_8716 \$188 \$77 0.98091a
Cext_8717 \$188 VSUBS 322.817a
Cext_8718 \$189 \$191 0.179323a
Cext_8719 \$189 \$217 227.572a
Cext_8720 \$189 \$265 98.5952a
Cext_8721 \$189 \$35 0.496172a
Cext_8722 \$189 \$352 1.46644a
Cext_8723 \$189 \$37 82.9986a
Cext_8724 \$189 \$39 47.2301a
Cext_8725 \$189 \$41 0.329802a
Cext_8726 \$189 \$67 2.30683a
Cext_8727 \$189 \$69 115.734a
Cext_8728 \$189 \$71 7.5941a
Cext_8729 \$189 \$73 3.82035a
Cext_8730 \$189 \$75 1.52179a
Cext_8731 \$189 \$77 1.0724a
Cext_8732 \$189 VSUBS 167.719a
Cext_8733 \$19 \$36 192.35a
Cext_8734 \$19 \$37 6.84421a
Cext_8735 \$19 \$68 52.8067a
Cext_8736 \$19 d1|dac_soft[1] 211.484a
Cext_8737 \$19 d2|dac_soft[2] 13.2435a
Cext_8738 \$19 d7|dac_soft[7] 1.18751a
Cext_8739 \$19 IOVDD|vdda 0.413187a
Cext_8740 \$19 VDD|vdd 483.58a
Cext_8741 \$19 VSS|vss 297.731a
Cext_8742 \$19 VSUBS 568.901a
Cext_8743 \$190 \$191 102.889a
Cext_8744 \$190 \$219 0.360462a
Cext_8745 \$190 \$221 0.250757a
Cext_8746 \$190 \$243 42.153a
Cext_8747 \$190 \$35 134.708a
Cext_8748 \$190 \$37 19.3729a
Cext_8749 \$190 \$39 1.63847a
Cext_8750 \$190 \$67 70.1661a
Cext_8751 \$190 \$69 117.46a
Cext_8752 \$190 \$71 32.765a
Cext_8753 \$190 \$73 32.5775a
Cext_8754 \$190 \$75 35.6349a
Cext_8755 \$190 \$77 45.8508a
Cext_8756 \$190 VSS|vss 0.335662a
Cext_8757 \$190 VSUBS 255.964a
Cext_8758 \$191 \$219 254.864a
Cext_8759 \$191 \$243 0.360462a
Cext_8760 \$191 \$35 23.4429a
Cext_8761 \$191 \$39 0.251943a
Cext_8762 \$191 \$41 0.282145a
Cext_8763 \$191 \$43 0.494517a
Cext_8764 \$191 \$45 20.9159a
Cext_8765 \$191 \$67 110.011a
Cext_8766 \$191 \$77 0.107779a
Cext_8767 \$191 VSS|vss 66.2132a
Cext_8768 \$191 VSUBS 818.765a
Cext_8769 \$192 \$194 2.46853a
Cext_8770 \$192 \$222 225.319a
Cext_8771 \$192 \$223 102.889a
Cext_8772 \$192 \$35 22.8071a
Cext_8773 \$192 \$39 0.500702a
Cext_8774 \$192 \$41 0.115752a
Cext_8775 \$192 \$43 0.481837a
Cext_8776 \$192 \$45 20.9928a
Cext_8777 \$192 \$67 105.489a
Cext_8778 \$192 IOVDD|vdda 11.6291a
Cext_8779 \$192 VSS|vss 60.9228a
Cext_8780 \$192 VSUBS 811.206a
Cext_8781 \$193 \$194 789.439a
Cext_8782 \$193 \$196 4.39525a
Cext_8783 \$193 \$223 18.9a
Cext_8784 \$193 \$224 3.88628a
Cext_8785 \$193 \$254 4.39525a
Cext_8786 \$193 \$266 86.9579a
Cext_8787 \$193 \$275 2.88751a
Cext_8788 \$193 \$276 3.32751a
Cext_8789 \$193 \$289 99.1454a
Cext_8790 \$193 \$303 7.41179a
Cext_8791 \$193 \$35 2.65407a
Cext_8792 \$193 \$37 79.2662a
Cext_8793 \$193 \$39 73.3394a
Cext_8794 \$193 \$41 7.1267a
Cext_8795 \$193 \$43 3.42755a
Cext_8796 \$193 \$45 1.99452a
Cext_8797 \$193 \$69 64.9505a
Cext_8798 \$193 \$71 50.2205a
Cext_8799 \$193 \$73 49.6419a
Cext_8800 \$193 \$75 1.56603a
Cext_8801 \$193 \$77 0.98091a
Cext_8802 \$193 IOVDD|vdda 7.75332a
Cext_8803 \$193 VSUBS 322.817a
Cext_8804 \$194 \$196 0.179323a
Cext_8805 \$194 \$223 227.572a
Cext_8806 \$194 \$266 98.5952a
Cext_8807 \$194 \$35 0.496172a
Cext_8808 \$194 \$356 1.46644a
Cext_8809 \$194 \$37 82.9986a
Cext_8810 \$194 \$39 47.2301a
Cext_8811 \$194 \$41 0.329802a
Cext_8812 \$194 \$67 2.30683a
Cext_8813 \$194 \$69 115.734a
Cext_8814 \$194 \$71 7.5941a
Cext_8815 \$194 \$73 3.82035a
Cext_8816 \$194 \$75 1.52179a
Cext_8817 \$194 \$77 1.0724a
Cext_8818 \$194 IOVDD|vdda 5.37185a
Cext_8819 \$194 VSUBS 167.719a
Cext_8820 \$195 \$196 102.889a
Cext_8821 \$195 \$224 0.360462a
Cext_8822 \$195 \$225 0.250757a
Cext_8823 \$195 \$244 42.153a
Cext_8824 \$195 \$35 134.708a
Cext_8825 \$195 \$37 19.3729a
Cext_8826 \$195 \$39 1.63847a
Cext_8827 \$195 \$67 70.1661a
Cext_8828 \$195 \$69 117.46a
Cext_8829 \$195 \$71 32.765a
Cext_8830 \$195 \$73 32.5775a
Cext_8831 \$195 \$75 35.6349a
Cext_8832 \$195 \$77 45.8508a
Cext_8833 \$195 VSS|vss 0.335662a
Cext_8834 \$195 VSUBS 255.964a
Cext_8835 \$196 \$224 254.864a
Cext_8836 \$196 \$244 0.360462a
Cext_8837 \$196 \$35 23.4429a
Cext_8838 \$196 \$39 0.251943a
Cext_8839 \$196 \$41 0.282145a
Cext_8840 \$196 \$43 0.494517a
Cext_8841 \$196 \$45 20.9159a
Cext_8842 \$196 \$67 110.011a
Cext_8843 \$196 \$77 0.107779a
Cext_8844 \$196 VSS|vss 66.2132a
Cext_8845 \$196 VSUBS 818.765a
Cext_8846 \$197 \$227 130.175a
Cext_8847 \$197 \$39 0.500702a
Cext_8848 \$197 \$41 0.115752a
Cext_8849 \$197 \$43 0.481837a
Cext_8850 \$197 \$45 21.1432a
Cext_8851 \$197 VSS|vss 2.2008a
Cext_8852 \$197 VSUBS 675.49a
Cext_8853 \$198 \$199 45.0654a
Cext_8854 \$198 \$228 130.058a
Cext_8855 \$198 VDD|vdd 0.592094a
Cext_8856 \$198 VSS|vss 25.1044a
Cext_8857 \$198 VSUBS 659.267a
Cext_8858 \$199 \$200 45.0654a
Cext_8859 \$199 \$229 130.175a
Cext_8860 \$199 VSS|vss 5.452a
Cext_8861 \$199 VSUBS 634.529a
Cext_8862 \$20 \$38 192.35a
Cext_8863 \$20 \$39 6.84421a
Cext_8864 \$20 \$70 52.8067a
Cext_8865 \$20 d2|dac_soft[2] 211.484a
Cext_8866 \$20 d3|dac_soft[3] 13.2435a
Cext_8867 \$20 d7|dac_soft[7] 1.18751a
Cext_8868 \$20 IOVDD|vdda 0.413187a
Cext_8869 \$20 VDD|vdd 483.58a
Cext_8870 \$20 VSS|vss 297.731a
Cext_8871 \$20 VSUBS 568.901a
Cext_8872 \$200 \$201 45.0654a
Cext_8873 \$200 \$230 130.175a
Cext_8874 \$200 VSUBS 634.529a
Cext_8875 \$201 \$202 45.8951a
Cext_8876 \$201 \$231 130.175a
Cext_8877 \$201 VSS|vss 0.428128a
Cext_8878 \$201 VSUBS 634.529a
Cext_8879 \$202 \$204 2.46853a
Cext_8880 \$202 \$232 102.889a
Cext_8881 \$202 \$233 225.319a
Cext_8882 \$202 \$51 22.8071a
Cext_8883 \$202 \$83 105.489a
Cext_8884 \$202 VSS|vss 61.1015a
Cext_8885 \$202 VSUBS 793.935a
Cext_8886 \$203 \$204 789.439a
Cext_8887 \$203 \$206 4.39525a
Cext_8888 \$203 \$232 18.9a
Cext_8889 \$203 \$234 3.88628a
Cext_8890 \$203 \$261 4.39525a
Cext_8891 \$203 \$267 86.9579a
Cext_8892 \$203 \$282 2.88751a
Cext_8893 \$203 \$283 3.32751a
Cext_8894 \$203 \$291 99.1454a
Cext_8895 \$203 \$311 7.41179a
Cext_8896 \$203 \$51 2.65407a
Cext_8897 \$203 \$53 79.2662a
Cext_8898 \$203 \$55 73.3394a
Cext_8899 \$203 \$57 7.1267a
Cext_8900 \$203 \$59 3.42755a
Cext_8901 \$203 \$61 1.99452a
Cext_8902 \$203 \$85 64.9505a
Cext_8903 \$203 \$87 50.2205a
Cext_8904 \$203 \$89 49.6419a
Cext_8905 \$203 \$91 1.56603a
Cext_8906 \$203 \$93 0.98091a
Cext_8907 \$203 VSUBS 322.817a
Cext_8908 \$204 \$206 0.179323a
Cext_8909 \$204 \$232 227.572a
Cext_8910 \$204 \$267 98.5952a
Cext_8911 \$204 \$365 1.46644a
Cext_8912 \$204 \$51 0.496172a
Cext_8913 \$204 \$53 82.9986a
Cext_8914 \$204 \$55 47.2301a
Cext_8915 \$204 \$57 0.329802a
Cext_8916 \$204 \$83 2.30683a
Cext_8917 \$204 \$85 115.734a
Cext_8918 \$204 \$87 7.5941a
Cext_8919 \$204 \$89 3.82035a
Cext_8920 \$204 \$91 1.52179a
Cext_8921 \$204 \$93 1.0724a
Cext_8922 \$204 VSUBS 167.719a
Cext_8923 \$205 \$206 102.889a
Cext_8924 \$205 \$234 0.360462a
Cext_8925 \$205 \$235 0.250757a
Cext_8926 \$205 \$245 42.153a
Cext_8927 \$205 \$51 134.708a
Cext_8928 \$205 \$53 19.3729a
Cext_8929 \$205 \$55 1.63847a
Cext_8930 \$205 \$83 70.1661a
Cext_8931 \$205 \$85 117.46a
Cext_8932 \$205 \$87 32.765a
Cext_8933 \$205 \$89 32.5775a
Cext_8934 \$205 \$91 35.6349a
Cext_8935 \$205 \$93 45.8508a
Cext_8936 \$205 VSS|vss 0.335662a
Cext_8937 \$205 VSUBS 255.964a
Cext_8938 \$206 \$234 254.864a
Cext_8939 \$206 \$245 0.360462a
Cext_8940 \$206 \$51 23.4429a
Cext_8941 \$206 \$55 0.251943a
Cext_8942 \$206 \$57 0.282145a
Cext_8943 \$206 \$59 0.494517a
Cext_8944 \$206 \$61 20.9159a
Cext_8945 \$206 \$83 110.011a
Cext_8946 \$206 \$93 0.107779a
Cext_8947 \$206 VSS|vss 66.2132a
Cext_8948 \$206 VSUBS 818.765a
Cext_8949 \$207 \$209 2.46853a
Cext_8950 \$207 \$237 102.889a
Cext_8951 \$207 \$238 225.319a
Cext_8952 \$207 \$51 22.8071a
Cext_8953 \$207 \$55 0.500702a
Cext_8954 \$207 \$57 0.115752a
Cext_8955 \$207 \$59 0.481837a
Cext_8956 \$207 \$61 20.9928a
Cext_8957 \$207 \$83 105.489a
Cext_8958 \$207 IOVDD|vdda 11.6291a
Cext_8959 \$207 VSS|vss 60.9228a
Cext_8960 \$207 VSUBS 811.206a
Cext_8961 \$208 \$209 789.439a
Cext_8962 \$208 \$211 4.39525a
Cext_8963 \$208 \$237 18.9a
Cext_8964 \$208 \$239 3.88628a
Cext_8965 \$208 \$263 4.39525a
Cext_8966 \$208 \$268 86.9579a
Cext_8967 \$208 \$284 2.88751a
Cext_8968 \$208 \$285 3.32751a
Cext_8969 \$208 \$293 99.1454a
Cext_8970 \$208 \$314 7.41179a
Cext_8971 \$208 \$51 2.65407a
Cext_8972 \$208 \$53 79.2662a
Cext_8973 \$208 \$55 73.3394a
Cext_8974 \$208 \$57 7.1267a
Cext_8975 \$208 \$59 3.42755a
Cext_8976 \$208 \$61 1.99452a
Cext_8977 \$208 \$85 64.9505a
Cext_8978 \$208 \$87 50.2205a
Cext_8979 \$208 \$89 49.6419a
Cext_8980 \$208 \$91 1.56603a
Cext_8981 \$208 \$93 0.98091a
Cext_8982 \$208 IOVDD|vdda 7.75332a
Cext_8983 \$208 VSS|vss 29.7358a
Cext_8984 \$208 VSUBS 322.817a
Cext_8985 \$209 \$211 0.179323a
Cext_8986 \$209 \$237 227.572a
Cext_8987 \$209 \$268 98.5952a
Cext_8988 \$209 \$369 1.46644a
Cext_8989 \$209 \$51 0.496172a
Cext_8990 \$209 \$53 82.9986a
Cext_8991 \$209 \$55 47.2301a
Cext_8992 \$209 \$57 0.329802a
Cext_8993 \$209 \$83 2.30683a
Cext_8994 \$209 \$85 115.734a
Cext_8995 \$209 \$87 7.5941a
Cext_8996 \$209 \$89 3.82035a
Cext_8997 \$209 \$91 1.52179a
Cext_8998 \$209 \$93 1.0724a
Cext_8999 \$209 IOVDD|vdda 5.37185a
Cext_9000 \$209 VSS|vss 6.14473a
Cext_9001 \$209 VSUBS 167.719a
Cext_9002 \$21 \$40 192.35a
Cext_9003 \$21 \$41 6.84421a
Cext_9004 \$21 \$72 52.8067a
Cext_9005 \$21 d3|dac_soft[3] 211.484a
Cext_9006 \$21 d4|dac_soft[4] 13.2435a
Cext_9007 \$21 d7|dac_soft[7] 1.18751a
Cext_9008 \$21 IOVDD|vdda 0.413187a
Cext_9009 \$21 VDD|vdd 483.58a
Cext_9010 \$21 VSS|vss 297.731a
Cext_9011 \$21 VSUBS 568.901a
Cext_9012 \$210 \$211 102.889a
Cext_9013 \$210 \$239 0.360462a
Cext_9014 \$210 \$240 0.250757a
Cext_9015 \$210 \$246 42.153a
Cext_9016 \$210 \$51 134.708a
Cext_9017 \$210 \$53 19.3729a
Cext_9018 \$210 \$55 1.63847a
Cext_9019 \$210 \$83 70.1661a
Cext_9020 \$210 \$85 117.46a
Cext_9021 \$210 \$87 32.765a
Cext_9022 \$210 \$89 32.5775a
Cext_9023 \$210 \$91 35.6349a
Cext_9024 \$210 \$93 45.8508a
Cext_9025 \$210 VSS|vss 0.335662a
Cext_9026 \$210 VSUBS 255.964a
Cext_9027 \$211 \$239 254.864a
Cext_9028 \$211 \$246 0.360462a
Cext_9029 \$211 \$51 23.4429a
Cext_9030 \$211 \$55 0.251943a
Cext_9031 \$211 \$57 0.282145a
Cext_9032 \$211 \$59 0.494517a
Cext_9033 \$211 \$61 20.9159a
Cext_9034 \$211 \$83 110.011a
Cext_9035 \$211 \$93 0.107779a
Cext_9036 \$211 VSS|vss 75.4228a
Cext_9037 \$211 VSUBS 818.765a
Cext_9038 \$212 \$242 130.175a
Cext_9039 \$212 \$55 0.500702a
Cext_9040 \$212 \$57 0.115752a
Cext_9041 \$212 \$59 0.481837a
Cext_9042 \$212 \$61 21.1432a
Cext_9043 \$212 VSS|vss 2.2008a
Cext_9044 \$212 VSUBS 675.49a
Cext_9045 \$213 \$214 45.0654a
Cext_9046 \$213 \$247 130.175a
Cext_9047 \$213 VDD|vdd 7.74075a
Cext_9048 \$213 VSS|vss 1.71997a
Cext_9049 \$213 VSUBS 659.267a
Cext_9050 \$214 \$215 45.0654a
Cext_9051 \$214 \$248 130.175a
Cext_9052 \$214 VDD|vdd 0.968272a
Cext_9053 \$214 VSUBS 634.529a
Cext_9054 \$215 \$216 45.0654a
Cext_9055 \$215 \$249 130.175a
Cext_9056 \$215 VSUBS 634.529a
Cext_9057 \$216 \$218 46.4004a
Cext_9058 \$216 \$250 130.175a
Cext_9059 \$216 VSS|vss 0.378729a
Cext_9060 \$216 VSUBS 634.529a
Cext_9061 \$217 \$218 114.006a
Cext_9062 \$217 \$219 0.182933a
Cext_9063 \$217 \$251 0.360462a
Cext_9064 \$217 \$265 108.267a
Cext_9065 \$217 \$35 134.708a
Cext_9066 \$217 \$37 19.3729a
Cext_9067 \$217 \$39 1.32172a
Cext_9068 \$217 \$67 69.9941a
Cext_9069 \$217 \$69 117.46a
Cext_9070 \$217 \$71 32.765a
Cext_9071 \$217 \$73 32.5775a
Cext_9072 \$217 \$75 35.6349a
Cext_9073 \$217 \$77 45.7852a
Cext_9074 \$217 VSS|vss 0.378848a
Cext_9075 \$217 VSUBS 255.476a
Cext_9076 \$218 \$251 254.864a
Cext_9077 \$218 \$265 0.360462a
Cext_9078 \$218 \$35 68.8031a
Cext_9079 \$218 \$67 64.1221a
Cext_9080 \$218 \$69 0.155901a
Cext_9081 \$218 VSS|vss 66.2906a
Cext_9082 \$218 VSUBS 799.746a
Cext_9083 \$219 \$220 2.46853a
Cext_9084 \$219 \$243 102.889a
Cext_9085 \$219 \$252 225.319a
Cext_9086 \$219 \$35 68.8428a
Cext_9087 \$219 \$41 0.115752a
Cext_9088 \$219 \$43 0.481837a
Cext_9089 \$219 \$45 20.8391a
Cext_9090 \$219 \$67 58.9193a
Cext_9091 \$219 \$69 0.343978a
Cext_9092 \$219 VSS|vss 60.9228a
Cext_9093 \$219 VSUBS 811.768a
Cext_9094 \$22 \$42 192.35a
Cext_9095 \$22 \$43 6.84421a
Cext_9096 \$22 \$74 52.8067a
Cext_9097 \$22 d4|dac_soft[4] 211.484a
Cext_9098 \$22 d5|dac_soft[5] 13.2435a
Cext_9099 \$22 d7|dac_soft[7] 1.18751a
Cext_9100 \$22 IOVDD|vdda 0.413187a
Cext_9101 \$22 VDD|vdd 483.58a
Cext_9102 \$22 VSS|vss 297.731a
Cext_9103 \$22 VSUBS 568.901a
Cext_9104 \$220 \$221 789.439a
Cext_9105 \$220 \$222 0.179323a
Cext_9106 \$220 \$243 227.572a
Cext_9107 \$220 \$288 98.5952a
Cext_9108 \$220 \$35 2.95962a
Cext_9109 \$220 \$37 91.1815a
Cext_9110 \$220 \$374 1.46644a
Cext_9111 \$220 \$39 1.18748a
Cext_9112 \$220 \$41 0.476813a
Cext_9113 \$220 \$69 106.511a
Cext_9114 \$220 \$71 53.6367a
Cext_9115 \$220 \$73 3.67334a
Cext_9116 \$220 \$75 1.52179a
Cext_9117 \$220 \$77 1.0724a
Cext_9118 \$220 VSUBS 168.425a
Cext_9119 \$221 \$222 4.39525a
Cext_9120 \$221 \$243 18.9a
Cext_9121 \$221 \$253 3.88628a
Cext_9122 \$221 \$275 4.39525a
Cext_9123 \$221 \$288 86.9579a
Cext_9124 \$221 \$301 2.88751a
Cext_9125 \$221 \$302 3.32751a
Cext_9126 \$221 \$318 99.1454a
Cext_9127 \$221 \$331 7.41179a
Cext_9128 \$221 \$35 0.564032a
Cext_9129 \$221 \$37 73.9747a
Cext_9130 \$221 \$39 56.1301a
Cext_9131 \$221 \$41 53.3486a
Cext_9132 \$221 \$43 3.42755a
Cext_9133 \$221 \$45 1.99452a
Cext_9134 \$221 \$67 1.96577a
Cext_9135 \$221 \$69 71.1115a
Cext_9136 \$221 \$71 67.4298a
Cext_9137 \$221 \$73 3.41995a
Cext_9138 \$221 \$75 1.56603a
Cext_9139 \$221 \$77 0.98091a
Cext_9140 \$221 VSUBS 322.081a
Cext_9141 \$222 \$223 114.006a
Cext_9142 \$222 \$253 254.864a
Cext_9143 \$222 \$266 0.360462a
Cext_9144 \$222 \$35 68.8031a
Cext_9145 \$222 \$39 0.105966a
Cext_9146 \$222 \$41 0.282145a
Cext_9147 \$222 \$43 0.494517a
Cext_9148 \$222 \$45 20.9159a
Cext_9149 \$222 \$67 64.1221a
Cext_9150 \$222 \$69 0.155901a
Cext_9151 \$222 IOVDD|vdda 13.0646a
Cext_9152 \$222 VSS|vss 66.2132a
Cext_9153 \$222 VSUBS 817.68a
Cext_9154 \$223 \$224 0.182933a
Cext_9155 \$223 \$253 0.360462a
Cext_9156 \$223 \$266 108.267a
Cext_9157 \$223 \$35 134.561a
Cext_9158 \$223 \$37 19.3729a
Cext_9159 \$223 \$39 1.32172a
Cext_9160 \$223 \$67 69.8469a
Cext_9161 \$223 \$69 117.46a
Cext_9162 \$223 \$71 32.765a
Cext_9163 \$223 \$73 32.5775a
Cext_9164 \$223 \$75 35.6349a
Cext_9165 \$223 \$77 45.7852a
Cext_9166 \$223 IOVDD|vdda 41.4935a
Cext_9167 \$223 VSS|vss 0.378848a
Cext_9168 \$223 VSUBS 255.202a
Cext_9169 \$224 \$226 2.46853a
Cext_9170 \$224 \$244 102.889a
Cext_9171 \$224 \$254 225.319a
Cext_9172 \$224 \$35 68.8428a
Cext_9173 \$224 \$41 0.115752a
Cext_9174 \$224 \$43 0.481837a
Cext_9175 \$224 \$45 20.8391a
Cext_9176 \$224 \$67 58.9193a
Cext_9177 \$224 \$69 0.343978a
Cext_9178 \$224 VSS|vss 60.9228a
Cext_9179 \$224 VSUBS 811.768a
Cext_9180 \$225 \$226 789.439a
Cext_9181 \$225 \$227 2.31908a
Cext_9182 \$225 \$244 18.9a
Cext_9183 \$225 \$255 2.31908a
Cext_9184 \$225 \$277 2.31908a
Cext_9185 \$225 \$290 86.9579a
Cext_9186 \$225 \$304 2.88751a
Cext_9187 \$225 \$305 1.76031a
Cext_9188 \$225 \$320 99.1454a
Cext_9189 \$225 \$334 7.41179a
Cext_9190 \$225 \$35 0.564032a
Cext_9191 \$225 \$37 74.1355a
Cext_9192 \$225 \$39 56.2264a
Cext_9193 \$225 \$41 53.5593a
Cext_9194 \$225 \$43 3.42755a
Cext_9195 \$225 \$45 1.99452a
Cext_9196 \$225 \$67 1.96577a
Cext_9197 \$225 \$69 71.1115a
Cext_9198 \$225 \$71 67.4298a
Cext_9199 \$225 \$73 3.41995a
Cext_9200 \$225 \$75 1.56603a
Cext_9201 \$225 \$77 0.98091a
Cext_9202 \$225 VSUBS 322.89a
Cext_9203 \$226 \$227 0.179323a
Cext_9204 \$226 \$244 227.572a
Cext_9205 \$226 \$290 98.5952a
Cext_9206 \$226 \$35 2.95962a
Cext_9207 \$226 \$37 91.1815a
Cext_9208 \$226 \$376 1.46644a
Cext_9209 \$226 \$39 1.18748a
Cext_9210 \$226 \$41 0.476813a
Cext_9211 \$226 \$69 106.511a
Cext_9212 \$226 \$71 53.6367a
Cext_9213 \$226 \$73 3.67334a
Cext_9214 \$226 \$75 1.52179a
Cext_9215 \$226 \$77 1.0724a
Cext_9216 \$226 VSUBS 168.425a
Cext_9217 \$227 \$255 130.175a
Cext_9218 \$227 \$39 0.105966a
Cext_9219 \$227 \$41 0.282145a
Cext_9220 \$227 \$43 0.494517a
Cext_9221 \$227 \$45 21.0663a
Cext_9222 \$227 VSS|vss 2.2008a
Cext_9223 \$227 VSUBS 676a
Cext_9224 \$228 \$229 45.0654a
Cext_9225 \$228 \$256 130.128a
Cext_9226 \$228 VDD|vdd 0.592094a
Cext_9227 \$228 VSS|vss 25.1044a
Cext_9228 \$228 VSUBS 659.267a
Cext_9229 \$229 \$230 45.0654a
Cext_9230 \$229 \$257 130.175a
Cext_9231 \$229 VSS|vss 5.452a
Cext_9232 \$229 VSUBS 634.529a
Cext_9233 \$23 \$44 192.35a
Cext_9234 \$23 \$45 6.84421a
Cext_9235 \$23 \$76 52.8067a
Cext_9236 \$23 d5|dac_soft[5] 211.484a
Cext_9237 \$23 d6|dac_soft[6] 13.2435a
Cext_9238 \$23 d7|dac_soft[7] 1.18751a
Cext_9239 \$23 IOVDD|vdda 0.413187a
Cext_9240 \$23 VDD|vdd 483.58a
Cext_9241 \$23 VSS|vss 297.731a
Cext_9242 \$23 VSUBS 568.901a
Cext_9243 \$230 \$231 45.0654a
Cext_9244 \$230 \$258 130.175a
Cext_9245 \$230 VSUBS 634.529a
Cext_9246 \$231 \$233 46.4004a
Cext_9247 \$231 \$259 130.175a
Cext_9248 \$231 VSS|vss 0.378729a
Cext_9249 \$231 VSUBS 634.529a
Cext_9250 \$232 \$233 114.006a
Cext_9251 \$232 \$234 0.182933a
Cext_9252 \$232 \$260 0.360462a
Cext_9253 \$232 \$267 108.267a
Cext_9254 \$232 \$51 134.708a
Cext_9255 \$232 \$53 19.3729a
Cext_9256 \$232 \$55 1.32172a
Cext_9257 \$232 \$83 69.9941a
Cext_9258 \$232 \$85 117.46a
Cext_9259 \$232 \$87 32.765a
Cext_9260 \$232 \$89 32.5775a
Cext_9261 \$232 \$91 35.6349a
Cext_9262 \$232 \$93 45.7852a
Cext_9263 \$232 VSS|vss 0.378848a
Cext_9264 \$232 VSUBS 255.476a
Cext_9265 \$233 \$260 254.864a
Cext_9266 \$233 \$267 0.360462a
Cext_9267 \$233 \$51 68.8031a
Cext_9268 \$233 \$83 64.1221a
Cext_9269 \$233 \$85 0.155901a
Cext_9270 \$233 VSS|vss 66.2906a
Cext_9271 \$233 VSUBS 799.746a
Cext_9272 \$234 \$236 2.46853a
Cext_9273 \$234 \$245 102.889a
Cext_9274 \$234 \$261 225.319a
Cext_9275 \$234 \$51 68.8428a
Cext_9276 \$234 \$57 0.115752a
Cext_9277 \$234 \$59 0.481837a
Cext_9278 \$234 \$61 20.8391a
Cext_9279 \$234 \$83 58.9193a
Cext_9280 \$234 \$85 0.343978a
Cext_9281 \$234 VSS|vss 60.9228a
Cext_9282 \$234 VSUBS 811.768a
Cext_9283 \$235 \$236 789.439a
Cext_9284 \$235 \$238 4.39525a
Cext_9285 \$235 \$245 18.9a
Cext_9286 \$235 \$262 3.88628a
Cext_9287 \$235 \$284 4.39525a
Cext_9288 \$235 \$292 86.9579a
Cext_9289 \$235 \$312 2.88751a
Cext_9290 \$235 \$313 3.32751a
Cext_9291 \$235 \$322 99.1454a
Cext_9292 \$235 \$342 7.41179a
Cext_9293 \$235 \$51 0.564032a
Cext_9294 \$235 \$53 73.9747a
Cext_9295 \$235 \$55 56.1301a
Cext_9296 \$235 \$57 53.3486a
Cext_9297 \$235 \$59 3.42755a
Cext_9298 \$235 \$61 1.99452a
Cext_9299 \$235 \$83 1.96577a
Cext_9300 \$235 \$85 71.1115a
Cext_9301 \$235 \$87 67.4298a
Cext_9302 \$235 \$89 3.41995a
Cext_9303 \$235 \$91 1.56603a
Cext_9304 \$235 \$93 0.98091a
Cext_9305 \$235 VSUBS 322.081a
Cext_9306 \$236 \$238 0.179323a
Cext_9307 \$236 \$245 227.572a
Cext_9308 \$236 \$292 98.5952a
Cext_9309 \$236 \$378 1.46644a
Cext_9310 \$236 \$51 2.95962a
Cext_9311 \$236 \$53 91.1815a
Cext_9312 \$236 \$55 1.18748a
Cext_9313 \$236 \$57 0.476813a
Cext_9314 \$236 \$85 106.511a
Cext_9315 \$236 \$87 53.6367a
Cext_9316 \$236 \$89 3.67334a
Cext_9317 \$236 \$91 1.52179a
Cext_9318 \$236 \$93 1.0724a
Cext_9319 \$236 VSUBS 168.425a
Cext_9320 \$237 \$238 114.006a
Cext_9321 \$237 \$239 0.182933a
Cext_9322 \$237 \$262 0.360462a
Cext_9323 \$237 \$268 108.267a
Cext_9324 \$237 \$51 134.561a
Cext_9325 \$237 \$53 19.3729a
Cext_9326 \$237 \$55 1.32172a
Cext_9327 \$237 \$83 69.8469a
Cext_9328 \$237 \$85 117.46a
Cext_9329 \$237 \$87 32.765a
Cext_9330 \$237 \$89 32.5775a
Cext_9331 \$237 \$91 35.6349a
Cext_9332 \$237 \$93 45.7852a
Cext_9333 \$237 IOVDD|vdda 41.4935a
Cext_9334 \$237 VSS|vss 3.73485a
Cext_9335 \$237 VSUBS 255.202a
Cext_9336 \$238 \$262 254.864a
Cext_9337 \$238 \$268 0.360462a
Cext_9338 \$238 \$51 68.8031a
Cext_9339 \$238 \$55 0.105966a
Cext_9340 \$238 \$57 0.282145a
Cext_9341 \$238 \$59 0.494517a
Cext_9342 \$238 \$61 20.9159a
Cext_9343 \$238 \$83 64.1221a
Cext_9344 \$238 \$85 0.155901a
Cext_9345 \$238 IOVDD|vdda 13.0646a
Cext_9346 \$238 VSS|vss 66.2132a
Cext_9347 \$238 VSUBS 817.68a
Cext_9348 \$239 \$241 2.46853a
Cext_9349 \$239 \$246 102.889a
Cext_9350 \$239 \$263 225.319a
Cext_9351 \$239 \$51 68.8428a
Cext_9352 \$239 \$57 0.115752a
Cext_9353 \$239 \$59 0.481837a
Cext_9354 \$239 \$61 20.8391a
Cext_9355 \$239 \$83 58.9193a
Cext_9356 \$239 \$85 0.343978a
Cext_9357 \$239 VSS|vss 69.9251a
Cext_9358 \$239 VSUBS 811.768a
Cext_9359 \$24 \$46 192.35a
Cext_9360 \$24 \$47 6.84421a
Cext_9361 \$24 \$78 52.8067a
Cext_9362 \$24 d6|dac_soft[6] 211.484a
Cext_9363 \$24 d7|dac_soft[7] 14.4311a
Cext_9364 \$24 IOVDD|vdda 0.413187a
Cext_9365 \$24 VDD|vdd 483.58a
Cext_9366 \$24 VSS|vss 297.731a
Cext_9367 \$24 VSUBS 568.901a
Cext_9368 \$240 \$241 789.439a
Cext_9369 \$240 \$242 2.31908a
Cext_9370 \$240 \$246 18.9a
Cext_9371 \$240 \$264 2.31908a
Cext_9372 \$240 \$286 2.31908a
Cext_9373 \$240 \$294 86.9579a
Cext_9374 \$240 \$315 2.88751a
Cext_9375 \$240 \$316 1.76031a
Cext_9376 \$240 \$324 99.1454a
Cext_9377 \$240 \$345 7.41179a
Cext_9378 \$240 \$51 0.564032a
Cext_9379 \$240 \$53 74.1355a
Cext_9380 \$240 \$55 56.2264a
Cext_9381 \$240 \$57 53.5593a
Cext_9382 \$240 \$59 3.42755a
Cext_9383 \$240 \$61 1.99452a
Cext_9384 \$240 \$83 1.96577a
Cext_9385 \$240 \$85 71.1115a
Cext_9386 \$240 \$87 67.4298a
Cext_9387 \$240 \$89 3.41995a
Cext_9388 \$240 \$91 1.56603a
Cext_9389 \$240 \$93 0.98091a
Cext_9390 \$240 VSUBS 322.89a
Cext_9391 \$241 \$242 0.179323a
Cext_9392 \$241 \$246 227.572a
Cext_9393 \$241 \$294 98.5952a
Cext_9394 \$241 \$380 1.46644a
Cext_9395 \$241 \$51 2.95962a
Cext_9396 \$241 \$53 91.1815a
Cext_9397 \$241 \$55 1.18748a
Cext_9398 \$241 \$57 0.476813a
Cext_9399 \$241 \$85 106.511a
Cext_9400 \$241 \$87 53.6367a
Cext_9401 \$241 \$89 3.67334a
Cext_9402 \$241 \$91 1.52179a
Cext_9403 \$241 \$93 1.0724a
Cext_9404 \$241 VSUBS 168.425a
Cext_9405 \$242 \$264 130.175a
Cext_9406 \$242 \$55 0.105966a
Cext_9407 \$242 \$57 0.282145a
Cext_9408 \$242 \$59 0.494517a
Cext_9409 \$242 \$61 21.0663a
Cext_9410 \$242 VSS|vss 2.2008a
Cext_9411 \$242 VSUBS 676a
Cext_9412 \$243 \$252 114.006a
Cext_9413 \$243 \$253 0.182933a
Cext_9414 \$243 \$274 0.360462a
Cext_9415 \$243 \$288 108.267a
Cext_9416 \$243 \$35 123.657a
Cext_9417 \$243 \$37 65.6459a
Cext_9418 \$243 \$39 0.62262a
Cext_9419 \$243 \$67 80.1821a
Cext_9420 \$243 \$69 70.7638a
Cext_9421 \$243 \$71 33.9629a
Cext_9422 \$243 \$73 32.5775a
Cext_9423 \$243 \$75 35.6349a
Cext_9424 \$243 \$77 45.7852a
Cext_9425 \$243 VSS|vss 0.378848a
Cext_9426 \$243 VSUBS 255.747a
Cext_9427 \$244 \$254 114.006a
Cext_9428 \$244 \$255 0.182933a
Cext_9429 \$244 \$276 0.360462a
Cext_9430 \$244 \$290 108.267a
Cext_9431 \$244 \$35 123.657a
Cext_9432 \$244 \$37 65.6459a
Cext_9433 \$244 \$39 0.62262a
Cext_9434 \$244 \$67 80.1821a
Cext_9435 \$244 \$69 70.7638a
Cext_9436 \$244 \$71 33.9629a
Cext_9437 \$244 \$73 32.5775a
Cext_9438 \$244 \$75 35.6349a
Cext_9439 \$244 \$77 45.7852a
Cext_9440 \$244 VSS|vss 0.378848a
Cext_9441 \$244 VSUBS 255.747a
Cext_9442 \$245 \$261 114.006a
Cext_9443 \$245 \$262 0.182933a
Cext_9444 \$245 \$283 0.360462a
Cext_9445 \$245 \$292 108.267a
Cext_9446 \$245 \$51 123.657a
Cext_9447 \$245 \$53 65.6459a
Cext_9448 \$245 \$55 0.62262a
Cext_9449 \$245 \$83 80.1821a
Cext_9450 \$245 \$85 70.7638a
Cext_9451 \$245 \$87 33.9629a
Cext_9452 \$245 \$89 32.5775a
Cext_9453 \$245 \$91 35.6349a
Cext_9454 \$245 \$93 45.7852a
Cext_9455 \$245 VSS|vss 0.378848a
Cext_9456 \$245 VSUBS 255.747a
Cext_9457 \$246 \$263 114.006a
Cext_9458 \$246 \$264 0.182933a
Cext_9459 \$246 \$285 0.360462a
Cext_9460 \$246 \$294 108.267a
Cext_9461 \$246 \$51 123.657a
Cext_9462 \$246 \$53 65.6459a
Cext_9463 \$246 \$55 0.62262a
Cext_9464 \$246 \$83 80.1821a
Cext_9465 \$246 \$85 70.7638a
Cext_9466 \$246 \$87 33.9629a
Cext_9467 \$246 \$89 32.5775a
Cext_9468 \$246 \$91 35.6349a
Cext_9469 \$246 \$93 45.7852a
Cext_9470 \$246 VSS|vss 0.378848a
Cext_9471 \$246 VSUBS 255.747a
Cext_9472 \$247 \$248 45.0654a
Cext_9473 \$247 \$269 130.175a
Cext_9474 \$247 VDD|vdd 7.74075a
Cext_9475 \$247 VSS|vss 1.71997a
Cext_9476 \$247 VSUBS 659.267a
Cext_9477 \$248 \$249 45.0654a
Cext_9478 \$248 \$270 130.175a
Cext_9479 \$248 VDD|vdd 0.968272a
Cext_9480 \$248 VSUBS 634.529a
Cext_9481 \$249 \$250 45.0654a
Cext_9482 \$249 \$271 130.175a
Cext_9483 \$249 VSUBS 634.529a
Cext_9484 \$25 \$48 192.35a
Cext_9485 \$25 \$49 6.84421a
Cext_9486 \$25 \$80 52.8067a
Cext_9487 \$25 d7|dac_soft[7] 211.651a
Cext_9488 \$25 IOVDD|vdda 18.2335a
Cext_9489 \$25 VDD|vdd 483.483a
Cext_9490 \$25 VSS|vss 297.718a
Cext_9491 \$25 VSUBS 569.215a
Cext_9492 \$250 \$251 45.8951a
Cext_9493 \$250 \$272 130.175a
Cext_9494 \$250 VSS|vss 0.428128a
Cext_9495 \$250 VSUBS 634.529a
Cext_9496 \$251 \$265 113.058a
Cext_9497 \$251 \$273 225.319a
Cext_9498 \$251 \$35 22.6915a
Cext_9499 \$251 \$67 105.489a
Cext_9500 \$251 VSS|vss 61.1015a
Cext_9501 \$251 VSUBS 793.257a
Cext_9502 \$252 \$265 0.182933a
Cext_9503 \$252 \$274 254.864a
Cext_9504 \$252 \$288 0.360462a
Cext_9505 \$252 \$35 23.2117a
Cext_9506 \$252 \$37 0.145978a
Cext_9507 \$252 \$39 0.105966a
Cext_9508 \$252 \$41 0.282145a
Cext_9509 \$252 \$43 0.494517a
Cext_9510 \$252 \$45 20.7622a
Cext_9511 \$252 \$67 110.011a
Cext_9512 \$252 VSS|vss 66.2132a
Cext_9513 \$252 VSUBS 817.562a
Cext_9514 \$253 \$266 113.058a
Cext_9515 \$253 \$275 225.319a
Cext_9516 \$253 \$35 22.6915a
Cext_9517 \$253 \$37 0.404672a
Cext_9518 \$253 \$41 0.115752a
Cext_9519 \$253 \$43 0.481837a
Cext_9520 \$253 \$45 20.8391a
Cext_9521 \$253 \$67 105.489a
Cext_9522 \$253 IOVDD|vdda 11.5102a
Cext_9523 \$253 VSS|vss 60.9228a
Cext_9524 \$253 VSUBS 810.61a
Cext_9525 \$254 \$266 0.182933a
Cext_9526 \$254 \$276 254.864a
Cext_9527 \$254 \$290 0.360462a
Cext_9528 \$254 \$35 23.2117a
Cext_9529 \$254 \$37 0.145978a
Cext_9530 \$254 \$39 0.105966a
Cext_9531 \$254 \$41 0.282145a
Cext_9532 \$254 \$43 0.494517a
Cext_9533 \$254 \$45 20.7622a
Cext_9534 \$254 \$67 110.011a
Cext_9535 \$254 VSS|vss 66.2132a
Cext_9536 \$254 VSUBS 817.562a
Cext_9537 \$255 \$277 130.175a
Cext_9538 \$255 \$37 0.404672a
Cext_9539 \$255 \$41 0.115752a
Cext_9540 \$255 \$43 0.481837a
Cext_9541 \$255 \$45 20.9895a
Cext_9542 \$255 VSS|vss 2.2008a
Cext_9543 \$255 VSUBS 675.619a
Cext_9544 \$256 \$257 45.0654a
Cext_9545 \$256 \$278 130.128a
Cext_9546 \$256 VDD|vdd 0.592094a
Cext_9547 \$256 VSS|vss 25.1792a
Cext_9548 \$256 VSUBS 659.267a
Cext_9549 \$257 \$258 45.0654a
Cext_9550 \$257 \$279 130.175a
Cext_9551 \$257 VSS|vss 5.452a
Cext_9552 \$257 VSUBS 634.529a
Cext_9553 \$258 \$259 45.0654a
Cext_9554 \$258 \$280 130.175a
Cext_9555 \$258 VSUBS 634.529a
Cext_9556 \$259 \$260 45.8951a
Cext_9557 \$259 \$281 130.175a
Cext_9558 \$259 VSS|vss 0.428128a
Cext_9559 \$259 VSUBS 634.529a
Cext_9560 \$26 \$50 192.404a
Cext_9561 \$26 \$51 6.84421a
Cext_9562 \$26 \$82 52.8067a
Cext_9563 \$26 d0|dac_hard[0] 211.632a
Cext_9564 \$26 d1|dac_hard[1] 13.2435a
Cext_9565 \$26 IOVDD|vdda 0.413187a
Cext_9566 \$26 VDD|vdd 470.956a
Cext_9567 \$26 VSS|vss 305.116a
Cext_9568 \$26 VSUBS 574.268a
Cext_9569 \$260 \$267 113.058a
Cext_9570 \$260 \$282 225.319a
Cext_9571 \$260 \$51 22.6915a
Cext_9572 \$260 \$83 105.489a
Cext_9573 \$260 VSS|vss 61.1015a
Cext_9574 \$260 VSUBS 793.257a
Cext_9575 \$261 \$267 0.182933a
Cext_9576 \$261 \$283 254.864a
Cext_9577 \$261 \$292 0.360462a
Cext_9578 \$261 \$51 23.2117a
Cext_9579 \$261 \$53 0.145978a
Cext_9580 \$261 \$55 0.105966a
Cext_9581 \$261 \$57 0.282145a
Cext_9582 \$261 \$59 0.494517a
Cext_9583 \$261 \$61 20.7622a
Cext_9584 \$261 \$83 110.011a
Cext_9585 \$261 VSS|vss 66.2132a
Cext_9586 \$261 VSUBS 817.562a
Cext_9587 \$262 \$268 113.058a
Cext_9588 \$262 \$284 225.319a
Cext_9589 \$262 \$51 22.6915a
Cext_9590 \$262 \$53 0.404672a
Cext_9591 \$262 \$57 0.115752a
Cext_9592 \$262 \$59 0.481837a
Cext_9593 \$262 \$61 20.8391a
Cext_9594 \$262 \$83 105.489a
Cext_9595 \$262 IOVDD|vdda 11.5102a
Cext_9596 \$262 VSS|vss 60.9228a
Cext_9597 \$262 VSUBS 810.61a
Cext_9598 \$263 \$268 0.182933a
Cext_9599 \$263 \$285 254.864a
Cext_9600 \$263 \$294 0.360462a
Cext_9601 \$263 \$51 23.2117a
Cext_9602 \$263 \$53 0.145978a
Cext_9603 \$263 \$55 0.105966a
Cext_9604 \$263 \$57 0.282145a
Cext_9605 \$263 \$59 0.494517a
Cext_9606 \$263 \$61 20.7622a
Cext_9607 \$263 \$83 110.011a
Cext_9608 \$263 VSS|vss 75.4228a
Cext_9609 \$263 VSUBS 817.562a
Cext_9610 \$264 \$286 130.175a
Cext_9611 \$264 \$53 0.404672a
Cext_9612 \$264 \$57 0.115752a
Cext_9613 \$264 \$59 0.481837a
Cext_9614 \$264 \$61 20.9895a
Cext_9615 \$264 VSS|vss 2.2008a
Cext_9616 \$264 VSUBS 675.619a
Cext_9617 \$265 \$273 102.889a
Cext_9618 \$265 \$287 0.250757a
Cext_9619 \$265 \$299 0.360462a
Cext_9620 \$265 \$317 42.153a
Cext_9621 \$265 \$35 123.657a
Cext_9622 \$265 \$37 65.4666a
Cext_9623 \$265 \$41 0.62262a
Cext_9624 \$265 \$67 80.1249a
Cext_9625 \$265 \$69 70.7638a
Cext_9626 \$265 \$71 31.3588a
Cext_9627 \$265 \$73 36.1512a
Cext_9628 \$265 \$75 35.6349a
Cext_9629 \$265 \$77 45.8508a
Cext_9630 \$265 VSS|vss 0.335662a
Cext_9631 \$265 VSUBS 257.974a
Cext_9632 \$266 \$275 102.889a
Cext_9633 \$266 \$289 0.250757a
Cext_9634 \$266 \$302 0.360462a
Cext_9635 \$266 \$319 42.153a
Cext_9636 \$266 \$35 123.51a
Cext_9637 \$266 \$37 65.4666a
Cext_9638 \$266 \$41 0.62262a
Cext_9639 \$266 \$67 79.9778a
Cext_9640 \$266 \$69 70.7638a
Cext_9641 \$266 \$71 31.3588a
Cext_9642 \$266 \$73 36.1512a
Cext_9643 \$266 \$75 35.6349a
Cext_9644 \$266 \$77 45.8508a
Cext_9645 \$266 IOVDD|vdda 41.6966a
Cext_9646 \$266 VSS|vss 0.335662a
Cext_9647 \$266 VSUBS 257.7a
Cext_9648 \$267 \$282 102.889a
Cext_9649 \$267 \$291 0.250757a
Cext_9650 \$267 \$310 0.360462a
Cext_9651 \$267 \$321 42.153a
Cext_9652 \$267 \$51 123.657a
Cext_9653 \$267 \$53 65.4666a
Cext_9654 \$267 \$57 0.62262a
Cext_9655 \$267 \$83 80.1249a
Cext_9656 \$267 \$85 70.7638a
Cext_9657 \$267 \$87 31.3588a
Cext_9658 \$267 \$89 36.1512a
Cext_9659 \$267 \$91 35.6349a
Cext_9660 \$267 \$93 45.8508a
Cext_9661 \$267 VSS|vss 0.335662a
Cext_9662 \$267 VSUBS 257.974a
Cext_9663 \$268 \$284 102.889a
Cext_9664 \$268 \$293 0.250757a
Cext_9665 \$268 \$313 0.360462a
Cext_9666 \$268 \$323 42.153a
Cext_9667 \$268 \$51 123.51a
Cext_9668 \$268 \$53 65.4666a
Cext_9669 \$268 \$57 0.62262a
Cext_9670 \$268 \$83 79.9778a
Cext_9671 \$268 \$85 70.7638a
Cext_9672 \$268 \$87 31.3588a
Cext_9673 \$268 \$89 36.1512a
Cext_9674 \$268 \$91 35.6349a
Cext_9675 \$268 \$93 45.8508a
Cext_9676 \$268 IOVDD|vdda 41.6966a
Cext_9677 \$268 VSS|vss 4.30412a
Cext_9678 \$268 VSUBS 257.7a
Cext_9679 \$269 \$270 45.0654a
Cext_9680 \$269 \$295 130.175a
Cext_9681 \$269 VDD|vdd 7.74075a
Cext_9682 \$269 VSS|vss 1.71997a
Cext_9683 \$269 VSUBS 659.267a
Cext_9684 \$27 \$52 192.35a
Cext_9685 \$27 \$53 6.84421a
Cext_9686 \$27 \$84 52.8067a
Cext_9687 \$27 d1|dac_hard[1] 211.484a
Cext_9688 \$27 d2|dac_hard[2] 13.2435a
Cext_9689 \$27 IOVDD|vdda 0.413187a
Cext_9690 \$27 VDD|vdd 483.58a
Cext_9691 \$27 VSS|vss 297.731a
Cext_9692 \$27 VSUBS 568.901a
Cext_9693 \$270 \$271 45.0654a
Cext_9694 \$270 \$296 130.175a
Cext_9695 \$270 VDD|vdd 0.968272a
Cext_9696 \$270 VSUBS 634.529a
Cext_9697 \$271 \$272 45.0654a
Cext_9698 \$271 \$297 130.175a
Cext_9699 \$271 VSUBS 634.529a
Cext_9700 \$272 \$273 46.4004a
Cext_9701 \$272 \$298 130.175a
Cext_9702 \$272 VSS|vss 0.378729a
Cext_9703 \$272 VSUBS 634.529a
Cext_9704 \$273 \$299 254.864a
Cext_9705 \$273 \$317 0.360462a
Cext_9706 \$273 \$35 69.0342a
Cext_9707 \$273 \$67 64.2241a
Cext_9708 \$273 \$73 0.182934a
Cext_9709 \$273 \$77 0.107779a
Cext_9710 \$273 VSS|vss 66.2906a
Cext_9711 \$273 VSUBS 801.109a
Cext_9712 \$274 \$288 113.058a
Cext_9713 \$274 \$301 225.319a
Cext_9714 \$274 \$35 68.7272a
Cext_9715 \$274 \$41 0.115752a
Cext_9716 \$274 \$43 0.481837a
Cext_9717 \$274 \$45 20.9928a
Cext_9718 \$274 \$67 58.9193a
Cext_9719 \$274 \$73 0.343978a
Cext_9720 \$274 VSS|vss 60.9228a
Cext_9721 \$274 VSUBS 811.086a
Cext_9722 \$275 \$288 0.182933a
Cext_9723 \$275 \$302 254.864a
Cext_9724 \$275 \$319 0.360462a
Cext_9725 \$275 \$35 69.0342a
Cext_9726 \$275 \$39 0.105966a
Cext_9727 \$275 \$41 0.282145a
Cext_9728 \$275 \$43 0.494517a
Cext_9729 \$275 \$45 20.7622a
Cext_9730 \$275 \$67 64.2241a
Cext_9731 \$275 \$73 0.182934a
Cext_9732 \$275 \$77 0.107779a
Cext_9733 \$275 IOVDD|vdda 13.2807a
Cext_9734 \$275 VSS|vss 66.2132a
Cext_9735 \$275 VSUBS 819.044a
Cext_9736 \$276 \$290 113.058a
Cext_9737 \$276 \$304 225.319a
Cext_9738 \$276 \$35 68.7272a
Cext_9739 \$276 \$41 0.115752a
Cext_9740 \$276 \$43 0.481837a
Cext_9741 \$276 \$45 20.9928a
Cext_9742 \$276 \$67 58.9193a
Cext_9743 \$276 \$73 0.343978a
Cext_9744 \$276 VSS|vss 60.9228a
Cext_9745 \$276 VSUBS 811.086a
Cext_9746 \$277 \$290 0.182933a
Cext_9747 \$277 \$305 130.175a
Cext_9748 \$277 \$39 0.105966a
Cext_9749 \$277 \$41 0.282145a
Cext_9750 \$277 \$43 0.494517a
Cext_9751 \$277 \$45 20.9126a
Cext_9752 \$277 VSS|vss 2.2008a
Cext_9753 \$277 VSUBS 676a
Cext_9754 \$278 \$279 45.0654a
Cext_9755 \$278 \$306 130.128a
Cext_9756 \$278 VDD|vdd 0.592094a
Cext_9757 \$278 VSS|vss 25.1792a
Cext_9758 \$278 VSUBS 659.267a
Cext_9759 \$279 \$280 45.0654a
Cext_9760 \$279 \$307 130.175a
Cext_9761 \$279 VSS|vss 5.452a
Cext_9762 \$279 VSUBS 634.529a
Cext_9763 \$28 \$54 192.35a
Cext_9764 \$28 \$55 6.84421a
Cext_9765 \$28 \$86 52.8067a
Cext_9766 \$28 d2|dac_hard[2] 211.667a
Cext_9767 \$28 d3|dac_hard[3] 13.2435a
Cext_9768 \$28 IOVDD|vdda 0.413187a
Cext_9769 \$28 VDD|vdd 483.58a
Cext_9770 \$28 VSS|vss 297.731a
Cext_9771 \$28 VSUBS 568.901a
Cext_9772 \$280 \$281 45.0654a
Cext_9773 \$280 \$308 130.175a
Cext_9774 \$280 VSUBS 634.529a
Cext_9775 \$281 \$282 46.4004a
Cext_9776 \$281 \$309 130.175a
Cext_9777 \$281 VSS|vss 0.378729a
Cext_9778 \$281 VSUBS 634.529a
Cext_9779 \$282 \$310 254.864a
Cext_9780 \$282 \$321 0.360462a
Cext_9781 \$282 \$51 69.0342a
Cext_9782 \$282 \$83 64.2241a
Cext_9783 \$282 \$89 0.182934a
Cext_9784 \$282 \$93 0.107779a
Cext_9785 \$282 VSS|vss 66.2906a
Cext_9786 \$282 VSUBS 801.109a
Cext_9787 \$283 \$292 113.058a
Cext_9788 \$283 \$312 225.319a
Cext_9789 \$283 \$51 68.7272a
Cext_9790 \$283 \$57 0.115752a
Cext_9791 \$283 \$59 0.481837a
Cext_9792 \$283 \$61 20.9928a
Cext_9793 \$283 \$83 58.9193a
Cext_9794 \$283 \$89 0.343978a
Cext_9795 \$283 VSS|vss 60.9228a
Cext_9796 \$283 VSUBS 811.086a
Cext_9797 \$284 \$292 0.182933a
Cext_9798 \$284 \$313 254.864a
Cext_9799 \$284 \$323 0.360462a
Cext_9800 \$284 \$51 69.0342a
Cext_9801 \$284 \$55 0.105966a
Cext_9802 \$284 \$57 0.282145a
Cext_9803 \$284 \$59 0.494517a
Cext_9804 \$284 \$61 20.7622a
Cext_9805 \$284 \$83 64.2241a
Cext_9806 \$284 \$89 0.182934a
Cext_9807 \$284 \$93 0.107779a
Cext_9808 \$284 IOVDD|vdda 13.2807a
Cext_9809 \$284 VSS|vss 66.2132a
Cext_9810 \$284 VSUBS 819.044a
Cext_9811 \$285 \$294 113.058a
Cext_9812 \$285 \$315 225.319a
Cext_9813 \$285 \$51 68.7272a
Cext_9814 \$285 \$57 0.115752a
Cext_9815 \$285 \$59 0.481837a
Cext_9816 \$285 \$61 20.9928a
Cext_9817 \$285 \$83 58.9193a
Cext_9818 \$285 \$89 0.343978a
Cext_9819 \$285 VSS|vss 69.9251a
Cext_9820 \$285 VSUBS 811.086a
Cext_9821 \$286 \$294 0.182933a
Cext_9822 \$286 \$316 130.175a
Cext_9823 \$286 \$55 0.105966a
Cext_9824 \$286 \$57 0.282145a
Cext_9825 \$286 \$59 0.494517a
Cext_9826 \$286 \$61 20.9126a
Cext_9827 \$286 VSS|vss 2.2008a
Cext_9828 \$286 VSUBS 676a
Cext_9829 \$287 \$300 1.5569f
Cext_9830 \$287 \$301 4.94574a
Cext_9831 \$287 \$317 16.7925a
Cext_9832 \$287 \$330 4.41896a
Cext_9833 \$287 \$35 2.39761a
Cext_9834 \$287 \$352 31.6191a
Cext_9835 \$287 \$354 4.94574a
Cext_9836 \$287 \$37 164.219a
Cext_9837 \$287 \$373 16.6785a
Cext_9838 \$287 \$386 4.41896a
Cext_9839 \$287 \$39 52.8623a
Cext_9840 \$287 \$408 226.002a
Cext_9841 \$287 \$409 4.94574a
Cext_9842 \$287 \$41 84.2145a
Cext_9843 \$287 \$425 19.1082a
Cext_9844 \$287 \$43 13.3005a
Cext_9845 \$287 \$434 4.41896a
Cext_9846 \$287 \$45 6.93824a
Cext_9847 \$287 \$460 4.94574a
Cext_9848 \$287 \$473 77.0039a
Cext_9849 \$287 \$481 2.78109a
Cext_9850 \$287 \$482 3.72181a
Cext_9851 \$287 \$500 98.5952a
Cext_9852 \$287 \$501 7.41179a
Cext_9853 \$287 \$69 71.2852a
Cext_9854 \$287 \$71 12.4538a
Cext_9855 \$287 \$73 47.9782a
Cext_9856 \$287 \$75 48.4845a
Cext_9857 \$287 \$77 0.959093a
Cext_9858 \$287 VSUBS 507.892a
Cext_9859 \$288 \$301 102.889a
Cext_9860 \$288 \$318 0.250757a
Cext_9861 \$288 \$330 0.360462a
Cext_9862 \$288 \$35 134.708a
Cext_9863 \$288 \$353 42.153a
Cext_9864 \$288 \$37 19.3729a
Cext_9865 \$288 \$41 1.4801a
Cext_9866 \$288 \$67 69.937a
Cext_9867 \$288 \$69 117.28a
Cext_9868 \$288 \$71 31.3588a
Cext_9869 \$288 \$73 34.4538a
Cext_9870 \$288 \$75 35.6349a
Cext_9871 \$288 \$77 45.8508a
Cext_9872 \$288 VSS|vss 0.335662a
Cext_9873 \$288 VSUBS 257.767a
Cext_9874 \$289 \$303 1.5569f
Cext_9875 \$289 \$304 4.94574a
Cext_9876 \$289 \$319 16.7925a
Cext_9877 \$289 \$333 4.41896a
Cext_9878 \$289 \$35 2.39761a
Cext_9879 \$289 \$356 31.6191a
Cext_9880 \$289 \$358 4.94574a
Cext_9881 \$289 \$37 164.219a
Cext_9882 \$289 \$375 16.6785a
Cext_9883 \$289 \$388 4.41896a
Cext_9884 \$289 \$39 52.8623a
Cext_9885 \$289 \$41 84.2145a
Cext_9886 \$289 \$411 226.002a
Cext_9887 \$289 \$412 4.94574a
Cext_9888 \$289 \$426 19.1082a
Cext_9889 \$289 \$43 13.3005a
Cext_9890 \$289 \$437 4.41896a
Cext_9891 \$289 \$45 6.93824a
Cext_9892 \$289 \$462 4.94574a
Cext_9893 \$289 \$474 77.0039a
Cext_9894 \$289 \$483 2.78109a
Cext_9895 \$289 \$484 3.72181a
Cext_9896 \$289 \$505 98.5952a
Cext_9897 \$289 \$506 7.41179a
Cext_9898 \$289 \$69 71.2852a
Cext_9899 \$289 \$71 12.4538a
Cext_9900 \$289 \$73 47.9782a
Cext_9901 \$289 \$75 48.4845a
Cext_9902 \$289 \$77 0.959093a
Cext_9903 \$289 IOVDD|vdda 10.9581a
Cext_9904 \$289 VSUBS 507.892a
Cext_9905 \$29 \$56 192.35a
Cext_9906 \$29 \$57 6.84421a
Cext_9907 \$29 \$88 52.8067a
Cext_9908 \$29 d3|dac_hard[3] 211.98a
Cext_9909 \$29 d4|dac_hard[4] 13.2435a
Cext_9910 \$29 IOVDD|vdda 0.413187a
Cext_9911 \$29 VDD|vdd 483.58a
Cext_9912 \$29 VSS|vss 297.731a
Cext_9913 \$29 VSUBS 568.901a
Cext_9914 \$290 \$304 102.889a
Cext_9915 \$290 \$320 0.250757a
Cext_9916 \$290 \$333 0.360462a
Cext_9917 \$290 \$35 134.708a
Cext_9918 \$290 \$357 42.153a
Cext_9919 \$290 \$37 19.3729a
Cext_9920 \$290 \$41 1.4801a
Cext_9921 \$290 \$67 69.937a
Cext_9922 \$290 \$69 117.28a
Cext_9923 \$290 \$71 31.3588a
Cext_9924 \$290 \$73 34.4538a
Cext_9925 \$290 \$75 35.6349a
Cext_9926 \$290 \$77 45.8508a
Cext_9927 \$290 VSS|vss 0.335662a
Cext_9928 \$290 VSUBS 257.767a
Cext_9929 \$291 \$311 1.5569f
Cext_9930 \$291 \$312 4.94574a
Cext_9931 \$291 \$321 16.7925a
Cext_9932 \$291 \$341 4.41896a
Cext_9933 \$291 \$365 31.6191a
Cext_9934 \$291 \$366 4.94574a
Cext_9935 \$291 \$377 16.6785a
Cext_9936 \$291 \$395 4.41896a
Cext_9937 \$291 \$419 226.002a
Cext_9938 \$291 \$420 4.94574a
Cext_9939 \$291 \$427 19.1082a
Cext_9940 \$291 \$445 4.41896a
Cext_9941 \$291 \$469 4.94574a
Cext_9942 \$291 \$475 77.0039a
Cext_9943 \$291 \$490 2.78109a
Cext_9944 \$291 \$491 3.72181a
Cext_9945 \$291 \$51 2.39761a
Cext_9946 \$291 \$515 98.5952a
Cext_9947 \$291 \$516 7.41179a
Cext_9948 \$291 \$53 164.219a
Cext_9949 \$291 \$55 52.8623a
Cext_9950 \$291 \$57 84.2145a
Cext_9951 \$291 \$59 13.3005a
Cext_9952 \$291 \$61 6.93824a
Cext_9953 \$291 \$85 71.2852a
Cext_9954 \$291 \$87 12.4538a
Cext_9955 \$291 \$89 47.9782a
Cext_9956 \$291 \$91 48.4845a
Cext_9957 \$291 \$93 0.959093a
Cext_9958 \$291 VSUBS 507.892a
Cext_9959 \$292 \$312 102.889a
Cext_9960 \$292 \$322 0.250757a
Cext_9961 \$292 \$341 0.360462a
Cext_9962 \$292 \$367 42.153a
Cext_9963 \$292 \$51 134.708a
Cext_9964 \$292 \$53 19.3729a
Cext_9965 \$292 \$57 1.4801a
Cext_9966 \$292 \$83 69.937a
Cext_9967 \$292 \$85 117.28a
Cext_9968 \$292 \$87 31.3588a
Cext_9969 \$292 \$89 34.4538a
Cext_9970 \$292 \$91 35.6349a
Cext_9971 \$292 \$93 45.8508a
Cext_9972 \$292 VSS|vss 0.335662a
Cext_9973 \$292 VSUBS 257.767a
Cext_9974 \$293 \$314 1.5569f
Cext_9975 \$293 \$315 4.94574a
Cext_9976 \$293 \$323 16.7925a
Cext_9977 \$293 \$344 4.41896a
Cext_9978 \$293 \$369 31.6191a
Cext_9979 \$293 \$371 4.94574a
Cext_9980 \$293 \$379 16.6785a
Cext_9981 \$293 \$397 4.41896a
Cext_9982 \$293 \$422 226.002a
Cext_9983 \$293 \$423 4.94574a
Cext_9984 \$293 \$428 19.1082a
Cext_9985 \$293 \$448 4.41896a
Cext_9986 \$293 \$471 4.94574a
Cext_9987 \$293 \$476 77.0039a
Cext_9988 \$293 \$492 2.78109a
Cext_9989 \$293 \$493 3.72181a
Cext_9990 \$293 \$51 2.39761a
Cext_9991 \$293 \$520 98.5952a
Cext_9992 \$293 \$521 7.41179a
Cext_9993 \$293 \$53 164.219a
Cext_9994 \$293 \$55 52.8623a
Cext_9995 \$293 \$57 84.2145a
Cext_9996 \$293 \$59 13.3005a
Cext_9997 \$293 \$61 6.93824a
Cext_9998 \$293 \$85 71.2852a
Cext_9999 \$293 \$87 12.4538a
Cext_10000 \$293 \$89 47.9782a
Cext_10001 \$293 \$91 48.4845a
Cext_10002 \$293 \$93 0.959093a
Cext_10003 \$293 IOVDD|vdda 10.9581a
Cext_10004 \$293 VSS|vss 70.3525a
Cext_10005 \$293 VSUBS 507.892a
Cext_10006 \$294 \$315 102.889a
Cext_10007 \$294 \$324 0.250757a
Cext_10008 \$294 \$344 0.360462a
Cext_10009 \$294 \$370 42.153a
Cext_10010 \$294 \$51 134.708a
Cext_10011 \$294 \$53 19.3729a
Cext_10012 \$294 \$57 1.4801a
Cext_10013 \$294 \$83 69.937a
Cext_10014 \$294 \$85 117.28a
Cext_10015 \$294 \$87 31.3588a
Cext_10016 \$294 \$89 34.4538a
Cext_10017 \$294 \$91 35.6349a
Cext_10018 \$294 \$93 45.8508a
Cext_10019 \$294 VSS|vss 0.335662a
Cext_10020 \$294 VSUBS 257.767a
Cext_10021 \$295 \$296 45.0654a
Cext_10022 \$295 \$325 130.175a
Cext_10023 \$295 VDD|vdd 7.74075a
Cext_10024 \$295 VSS|vss 1.71997a
Cext_10025 \$295 VSUBS 659.267a
Cext_10026 \$296 \$297 45.0654a
Cext_10027 \$296 \$326 130.175a
Cext_10028 \$296 VDD|vdd 0.968272a
Cext_10029 \$296 VSUBS 634.529a
Cext_10030 \$297 \$298 45.0654a
Cext_10031 \$297 \$327 130.175a
Cext_10032 \$297 VSUBS 634.529a
Cext_10033 \$298 \$299 45.8951a
Cext_10034 \$298 \$328 130.175a
Cext_10035 \$298 VSS|vss 0.428128a
Cext_10036 \$298 VSUBS 634.529a
Cext_10037 \$299 \$300 2.16563a
Cext_10038 \$299 \$317 102.889a
Cext_10039 \$299 \$329 225.319a
Cext_10040 \$299 \$35 22.8071a
Cext_10041 \$299 \$67 105.694a
Cext_10042 \$299 VSS|vss 61.1015a
Cext_10043 \$299 VSUBS 794.068a
Cext_10044 \$30 \$58 192.35a
Cext_10045 \$30 \$59 6.84421a
Cext_10046 \$30 \$90 52.8067a
Cext_10047 \$30 d4|dac_hard[4] 212.192a
Cext_10048 \$30 d5|dac_hard[5] 13.2435a
Cext_10049 \$30 IOVDD|vdda 0.413187a
Cext_10050 \$30 VDD|vdd 483.58a
Cext_10051 \$30 VSS|vss 297.731a
Cext_10052 \$30 VSUBS 568.901a
Cext_10053 \$300 \$301 0.179323a
Cext_10054 \$300 \$317 83.8393a
Cext_10055 \$300 \$35 0.564032a
Cext_10056 \$300 \$352 783.202a
Cext_10057 \$300 \$37 51.1437a
Cext_10058 \$300 \$373 15.7815a
Cext_10059 \$300 \$39 46.0291a
Cext_10060 \$300 \$408 99.1454a
Cext_10061 \$300 \$41 47.4094a
Cext_10062 \$300 \$425 0.250757a
Cext_10063 \$300 \$43 0.104586a
Cext_10064 \$300 \$67 1.96577a
Cext_10065 \$300 \$69 66.2231a
Cext_10066 \$300 \$71 62.2724a
Cext_10067 \$300 \$73 3.41995a
Cext_10068 \$300 \$75 1.69678a
Cext_10069 \$300 \$77 0.98091a
Cext_10070 \$300 VSUBS 196.18a
Cext_10071 \$301 \$330 254.864a
Cext_10072 \$301 \$35 23.4429a
Cext_10073 \$301 \$353 0.360462a
Cext_10074 \$301 \$39 0.105966a
Cext_10075 \$301 \$41 0.428122a
Cext_10076 \$301 \$43 0.494517a
Cext_10077 \$301 \$45 20.9159a
Cext_10078 \$301 \$67 110.113a
Cext_10079 \$301 \$77 0.107779a
Cext_10080 \$301 VSS|vss 66.2132a
Cext_10081 \$301 VSUBS 818.565a
Cext_10082 \$302 \$303 2.16563a
Cext_10083 \$302 \$319 102.889a
Cext_10084 \$302 \$332 225.319a
Cext_10085 \$302 \$35 22.8071a
Cext_10086 \$302 \$41 0.772242a
Cext_10087 \$302 \$43 0.481837a
Cext_10088 \$302 \$45 20.9928a
Cext_10089 \$302 \$67 105.694a
Cext_10090 \$302 IOVDD|vdda 11.6291a
Cext_10091 \$302 VSS|vss 60.9228a
Cext_10092 \$302 VSUBS 811.087a
Cext_10093 \$303 \$304 0.179323a
Cext_10094 \$303 \$319 83.8393a
Cext_10095 \$303 \$35 0.564032a
Cext_10096 \$303 \$356 783.202a
Cext_10097 \$303 \$37 51.1437a
Cext_10098 \$303 \$375 15.7815a
Cext_10099 \$303 \$39 46.0291a
Cext_10100 \$303 \$41 47.4094a
Cext_10101 \$303 \$411 99.1454a
Cext_10102 \$303 \$426 0.250757a
Cext_10103 \$303 \$43 0.104586a
Cext_10104 \$303 \$67 1.96577a
Cext_10105 \$303 \$69 66.2231a
Cext_10106 \$303 \$71 62.2724a
Cext_10107 \$303 \$73 3.41995a
Cext_10108 \$303 \$75 1.69678a
Cext_10109 \$303 \$77 0.98091a
Cext_10110 \$303 IOVDD|vdda 7.50694a
Cext_10111 \$303 VSUBS 196.18a
Cext_10112 \$304 \$333 254.864a
Cext_10113 \$304 \$35 23.4429a
Cext_10114 \$304 \$357 0.360462a
Cext_10115 \$304 \$39 0.105966a
Cext_10116 \$304 \$41 0.428122a
Cext_10117 \$304 \$43 0.494517a
Cext_10118 \$304 \$45 20.9159a
Cext_10119 \$304 \$67 110.113a
Cext_10120 \$304 \$77 0.107779a
Cext_10121 \$304 VSS|vss 66.2132a
Cext_10122 \$304 VSUBS 818.565a
Cext_10123 \$305 \$335 130.175a
Cext_10124 \$305 \$41 0.772242a
Cext_10125 \$305 \$43 0.481837a
Cext_10126 \$305 \$45 21.1432a
Cext_10127 \$305 VSS|vss 2.2008a
Cext_10128 \$305 VSUBS 675.289a
Cext_10129 \$306 \$307 45.0654a
Cext_10130 \$306 \$336 130.128a
Cext_10131 \$306 VDD|vdd 0.592094a
Cext_10132 \$306 VSS|vss 25.1792a
Cext_10133 \$306 VSUBS 659.267a
Cext_10134 \$307 \$308 45.0654a
Cext_10135 \$307 \$337 130.175a
Cext_10136 \$307 VSS|vss 5.452a
Cext_10137 \$307 VSUBS 634.529a
Cext_10138 \$308 \$309 45.0654a
Cext_10139 \$308 \$338 130.175a
Cext_10140 \$308 VSUBS 634.529a
Cext_10141 \$309 \$310 45.8951a
Cext_10142 \$309 \$339 130.175a
Cext_10143 \$309 VSS|vss 0.428128a
Cext_10144 \$309 VSUBS 634.529a
Cext_10145 \$31 \$60 192.35a
Cext_10146 \$31 \$61 6.84421a
Cext_10147 \$31 \$92 52.8067a
Cext_10148 \$31 d5|dac_hard[5] 212.304a
Cext_10149 \$31 d6|dac_hard[6] 13.2435a
Cext_10150 \$31 IOVDD|vdda 0.413187a
Cext_10151 \$31 VDD|vdd 483.58a
Cext_10152 \$31 VSS|vss 297.731a
Cext_10153 \$31 VSUBS 568.901a
Cext_10154 \$310 \$311 2.16563a
Cext_10155 \$310 \$321 102.889a
Cext_10156 \$310 \$340 225.319a
Cext_10157 \$310 \$51 22.8071a
Cext_10158 \$310 \$83 105.694a
Cext_10159 \$310 VSS|vss 61.1015a
Cext_10160 \$310 VSUBS 794.068a
Cext_10161 \$311 \$312 0.179323a
Cext_10162 \$311 \$321 83.8393a
Cext_10163 \$311 \$365 783.202a
Cext_10164 \$311 \$377 15.7815a
Cext_10165 \$311 \$419 99.1454a
Cext_10166 \$311 \$427 0.250757a
Cext_10167 \$311 \$51 0.564032a
Cext_10168 \$311 \$53 51.1437a
Cext_10169 \$311 \$55 46.0291a
Cext_10170 \$311 \$57 47.4094a
Cext_10171 \$311 \$59 0.104586a
Cext_10172 \$311 \$83 1.96577a
Cext_10173 \$311 \$85 66.2231a
Cext_10174 \$311 \$87 62.2724a
Cext_10175 \$311 \$89 3.41995a
Cext_10176 \$311 \$91 1.69678a
Cext_10177 \$311 \$93 0.98091a
Cext_10178 \$311 VSUBS 196.18a
Cext_10179 \$312 \$341 254.864a
Cext_10180 \$312 \$367 0.360462a
Cext_10181 \$312 \$51 23.4429a
Cext_10182 \$312 \$55 0.105966a
Cext_10183 \$312 \$57 0.428122a
Cext_10184 \$312 \$59 0.494517a
Cext_10185 \$312 \$61 20.9159a
Cext_10186 \$312 \$83 110.113a
Cext_10187 \$312 \$93 0.107779a
Cext_10188 \$312 VSS|vss 66.2132a
Cext_10189 \$312 VSUBS 818.565a
Cext_10190 \$313 \$314 2.16563a
Cext_10191 \$313 \$323 102.889a
Cext_10192 \$313 \$343 225.319a
Cext_10193 \$313 \$51 22.8071a
Cext_10194 \$313 \$57 0.772242a
Cext_10195 \$313 \$59 0.481837a
Cext_10196 \$313 \$61 20.9928a
Cext_10197 \$313 \$83 105.694a
Cext_10198 \$313 IOVDD|vdda 11.6291a
Cext_10199 \$313 VSS|vss 60.9228a
Cext_10200 \$313 VSUBS 811.087a
Cext_10201 \$314 \$315 0.179323a
Cext_10202 \$314 \$323 83.8393a
Cext_10203 \$314 \$369 783.202a
Cext_10204 \$314 \$379 15.7815a
Cext_10205 \$314 \$422 99.1454a
Cext_10206 \$314 \$428 0.250757a
Cext_10207 \$314 \$51 0.564032a
Cext_10208 \$314 \$53 51.1437a
Cext_10209 \$314 \$55 46.0291a
Cext_10210 \$314 \$57 47.4094a
Cext_10211 \$314 \$59 0.104586a
Cext_10212 \$314 \$83 1.96577a
Cext_10213 \$314 \$85 66.2231a
Cext_10214 \$314 \$87 62.2724a
Cext_10215 \$314 \$89 3.41995a
Cext_10216 \$314 \$91 1.69678a
Cext_10217 \$314 \$93 0.98091a
Cext_10218 \$314 IOVDD|vdda 7.50694a
Cext_10219 \$314 VSS|vss 12.2841a
Cext_10220 \$314 VSUBS 196.18a
Cext_10221 \$315 \$344 254.864a
Cext_10222 \$315 \$370 0.360462a
Cext_10223 \$315 \$51 23.4429a
Cext_10224 \$315 \$55 0.105966a
Cext_10225 \$315 \$57 0.428122a
Cext_10226 \$315 \$59 0.494517a
Cext_10227 \$315 \$61 20.9159a
Cext_10228 \$315 \$83 110.113a
Cext_10229 \$315 \$93 0.107779a
Cext_10230 \$315 VSS|vss 75.3227a
Cext_10231 \$315 VSUBS 818.565a
Cext_10232 \$316 \$346 130.175a
Cext_10233 \$316 \$57 0.772242a
Cext_10234 \$316 \$59 0.481837a
Cext_10235 \$316 \$61 21.1432a
Cext_10236 \$316 VSS|vss 2.2008a
Cext_10237 \$316 VSUBS 675.289a
Cext_10238 \$317 \$329 114.006a
Cext_10239 \$317 \$330 0.182933a
Cext_10240 \$317 \$35 134.708a
Cext_10241 \$317 \$351 0.360462a
Cext_10242 \$317 \$352 98.5952a
Cext_10243 \$317 \$37 19.3729a
Cext_10244 \$317 \$373 108.267a
Cext_10245 \$317 \$41 1.33033a
Cext_10246 \$317 \$67 69.9941a
Cext_10247 \$317 \$69 117.28a
Cext_10248 \$317 \$71 31.3588a
Cext_10249 \$317 \$73 34.4538a
Cext_10250 \$317 \$75 35.6349a
Cext_10251 \$317 \$77 45.7852a
Cext_10252 \$317 VSS|vss 0.378848a
Cext_10253 \$317 VSUBS 257.682a
Cext_10254 \$318 \$331 1.5569f
Cext_10255 \$318 \$332 4.94574a
Cext_10256 \$318 \$35 0.604961a
Cext_10257 \$318 \$353 16.7925a
Cext_10258 \$318 \$355 4.41896a
Cext_10259 \$318 \$37 159.388a
Cext_10260 \$318 \$374 31.6191a
Cext_10261 \$318 \$387 4.94574a
Cext_10262 \$318 \$39 45.8625a
Cext_10263 \$318 \$399 16.6785a
Cext_10264 \$318 \$41 66.3225a
Cext_10265 \$318 \$410 4.41896a
Cext_10266 \$318 \$43 59.3431a
Cext_10267 \$318 \$435 226.002a
Cext_10268 \$318 \$436 4.94574a
Cext_10269 \$318 \$45 6.93824a
Cext_10270 \$318 \$451 19.1082a
Cext_10271 \$318 \$461 4.41896a
Cext_10272 \$318 \$483 4.94574a
Cext_10273 \$318 \$502 77.0039a
Cext_10274 \$318 \$503 2.78109a
Cext_10275 \$318 \$504 3.72181a
Cext_10276 \$318 \$526 98.5952a
Cext_10277 \$318 \$539 7.41179a
Cext_10278 \$318 \$67 1.69277a
Cext_10279 \$318 \$69 76.6121a
Cext_10280 \$318 \$71 20.8844a
Cext_10281 \$318 \$73 64.7697a
Cext_10282 \$318 \$75 2.44188a
Cext_10283 \$318 \$77 0.959093a
Cext_10284 \$318 VSUBS 506.612a
Cext_10285 \$319 \$332 114.006a
Cext_10286 \$319 \$333 0.182933a
Cext_10287 \$319 \$35 134.561a
Cext_10288 \$319 \$355 0.360462a
Cext_10289 \$319 \$356 98.5952a
Cext_10290 \$319 \$37 19.3729a
Cext_10291 \$319 \$375 108.267a
Cext_10292 \$319 \$41 1.33033a
Cext_10293 \$319 \$67 69.8469a
Cext_10294 \$319 \$69 117.28a
Cext_10295 \$319 \$71 31.3588a
Cext_10296 \$319 \$73 34.4538a
Cext_10297 \$319 \$75 35.6349a
Cext_10298 \$319 \$77 45.7852a
Cext_10299 \$319 IOVDD|vdda 41.5294a
Cext_10300 \$319 VSS|vss 0.378848a
Cext_10301 \$319 VSUBS 257.408a
Cext_10302 \$32 \$62 192.35a
Cext_10303 \$32 \$63 6.84421a
Cext_10304 \$32 \$94 52.8067a
Cext_10305 \$32 d6|dac_hard[6] 212.196a
Cext_10306 \$32 d7|dac_hard[7] 13.2435a
Cext_10307 \$32 IOVDD|vdda 0.413187a
Cext_10308 \$32 VDD|vdd 483.58a
Cext_10309 \$32 VSS|vss 297.731a
Cext_10310 \$32 VSUBS 568.901a
Cext_10311 \$320 \$334 1.5569f
Cext_10312 \$320 \$335 2.77042a
Cext_10313 \$320 \$35 0.604961a
Cext_10314 \$320 \$357 16.7925a
Cext_10315 \$320 \$359 2.77042a
Cext_10316 \$320 \$37 159.388a
Cext_10317 \$320 \$376 31.6191a
Cext_10318 \$320 \$389 2.77042a
Cext_10319 \$320 \$39 46.1701a
Cext_10320 \$320 \$400 16.6785a
Cext_10321 \$320 \$41 66.5083a
Cext_10322 \$320 \$413 2.77042a
Cext_10323 \$320 \$43 59.7517a
Cext_10324 \$320 \$438 226.002a
Cext_10325 \$320 \$439 2.77042a
Cext_10326 \$320 \$45 6.93824a
Cext_10327 \$320 \$452 19.1082a
Cext_10328 \$320 \$463 2.77042a
Cext_10329 \$320 \$485 2.77042a
Cext_10330 \$320 \$507 77.0039a
Cext_10331 \$320 \$508 2.78109a
Cext_10332 \$320 \$509 2.07326a
Cext_10333 \$320 \$528 98.5952a
Cext_10334 \$320 \$542 7.41179a
Cext_10335 \$320 \$67 1.69277a
Cext_10336 \$320 \$69 76.6121a
Cext_10337 \$320 \$71 20.8844a
Cext_10338 \$320 \$73 64.7697a
Cext_10339 \$320 \$75 2.44188a
Cext_10340 \$320 \$77 0.959093a
Cext_10341 \$320 VSUBS 508.084a
Cext_10342 \$321 \$340 114.006a
Cext_10343 \$321 \$341 0.182933a
Cext_10344 \$321 \$364 0.360462a
Cext_10345 \$321 \$365 98.5952a
Cext_10346 \$321 \$377 108.267a
Cext_10347 \$321 \$51 134.708a
Cext_10348 \$321 \$53 19.3729a
Cext_10349 \$321 \$57 1.33033a
Cext_10350 \$321 \$83 69.9941a
Cext_10351 \$321 \$85 117.28a
Cext_10352 \$321 \$87 31.3588a
Cext_10353 \$321 \$89 34.4538a
Cext_10354 \$321 \$91 35.6349a
Cext_10355 \$321 \$93 45.7852a
Cext_10356 \$321 VSS|vss 0.378848a
Cext_10357 \$321 VSUBS 257.682a
Cext_10358 \$322 \$342 1.5569f
Cext_10359 \$322 \$343 4.94574a
Cext_10360 \$322 \$367 16.7925a
Cext_10361 \$322 \$368 4.41896a
Cext_10362 \$322 \$378 31.6191a
Cext_10363 \$322 \$396 4.94574a
Cext_10364 \$322 \$401 16.6785a
Cext_10365 \$322 \$421 4.41896a
Cext_10366 \$322 \$446 226.002a
Cext_10367 \$322 \$447 4.94574a
Cext_10368 \$322 \$453 19.1082a
Cext_10369 \$322 \$470 4.41896a
Cext_10370 \$322 \$492 4.94574a
Cext_10371 \$322 \$51 0.604961a
Cext_10372 \$322 \$517 77.0039a
Cext_10373 \$322 \$518 2.78109a
Cext_10374 \$322 \$519 3.72181a
Cext_10375 \$322 \$53 159.388a
Cext_10376 \$322 \$530 98.5952a
Cext_10377 \$322 \$55 45.8625a
Cext_10378 \$322 \$550 7.41179a
Cext_10379 \$322 \$57 66.3225a
Cext_10380 \$322 \$59 59.3431a
Cext_10381 \$322 \$61 6.93824a
Cext_10382 \$322 \$83 1.69277a
Cext_10383 \$322 \$85 76.6121a
Cext_10384 \$322 \$87 20.8844a
Cext_10385 \$322 \$89 64.7697a
Cext_10386 \$322 \$91 2.44188a
Cext_10387 \$322 \$93 0.959093a
Cext_10388 \$322 VSUBS 506.612a
Cext_10389 \$323 \$343 114.006a
Cext_10390 \$323 \$344 0.182933a
Cext_10391 \$323 \$368 0.360462a
Cext_10392 \$323 \$369 98.5952a
Cext_10393 \$323 \$379 108.267a
Cext_10394 \$323 \$51 134.561a
Cext_10395 \$323 \$53 19.3729a
Cext_10396 \$323 \$57 1.33033a
Cext_10397 \$323 \$83 69.8469a
Cext_10398 \$323 \$85 117.28a
Cext_10399 \$323 \$87 31.3588a
Cext_10400 \$323 \$89 34.4538a
Cext_10401 \$323 \$91 35.6349a
Cext_10402 \$323 \$93 45.7852a
Cext_10403 \$323 IOVDD|vdda 41.5294a
Cext_10404 \$323 VSS|vss 3.86087a
Cext_10405 \$323 VSUBS 257.408a
Cext_10406 \$324 \$345 1.5569f
Cext_10407 \$324 \$346 2.77042a
Cext_10408 \$324 \$370 16.7925a
Cext_10409 \$324 \$372 2.77042a
Cext_10410 \$324 \$380 31.6191a
Cext_10411 \$324 \$398 2.77042a
Cext_10412 \$324 \$402 16.6785a
Cext_10413 \$324 \$424 2.77042a
Cext_10414 \$324 \$449 226.002a
Cext_10415 \$324 \$450 2.77042a
Cext_10416 \$324 \$454 19.1082a
Cext_10417 \$324 \$472 2.77042a
Cext_10418 \$324 \$494 2.77042a
Cext_10419 \$324 \$51 0.604961a
Cext_10420 \$324 \$522 77.0039a
Cext_10421 \$324 \$523 2.78109a
Cext_10422 \$324 \$524 2.07326a
Cext_10423 \$324 \$53 159.388a
Cext_10424 \$324 \$532 98.5952a
Cext_10425 \$324 \$55 46.1701a
Cext_10426 \$324 \$553 7.41179a
Cext_10427 \$324 \$57 66.5083a
Cext_10428 \$324 \$59 59.7517a
Cext_10429 \$324 \$61 6.93824a
Cext_10430 \$324 \$83 1.69277a
Cext_10431 \$324 \$85 76.6121a
Cext_10432 \$324 \$87 20.8844a
Cext_10433 \$324 \$89 64.7697a
Cext_10434 \$324 \$91 2.44188a
Cext_10435 \$324 \$93 0.959093a
Cext_10436 \$324 VSUBS 508.084a
Cext_10437 \$325 \$326 45.0654a
Cext_10438 \$325 \$347 130.175a
Cext_10439 \$325 VDD|vdd 7.74075a
Cext_10440 \$325 VSS|vss 1.71997a
Cext_10441 \$325 VSUBS 659.267a
Cext_10442 \$326 \$327 45.0654a
Cext_10443 \$326 \$348 130.175a
Cext_10444 \$326 VDD|vdd 0.968272a
Cext_10445 \$326 VSUBS 634.529a
Cext_10446 \$327 \$328 45.0654a
Cext_10447 \$327 \$349 130.175a
Cext_10448 \$327 VSUBS 634.529a
Cext_10449 \$328 \$329 46.4004a
Cext_10450 \$328 \$350 130.175a
Cext_10451 \$328 VSS|vss 0.378729a
Cext_10452 \$328 VSUBS 634.529a
Cext_10453 \$329 \$35 68.8031a
Cext_10454 \$329 \$351 254.864a
Cext_10455 \$329 \$373 0.360462a
Cext_10456 \$329 \$67 64.1221a
Cext_10457 \$329 \$69 0.155901a
Cext_10458 \$329 VSS|vss 66.2906a
Cext_10459 \$329 VSUBS 799.746a
Cext_10460 \$33 \$64 192.35a
Cext_10461 \$33 \$65 6.84421a
Cext_10462 \$33 \$96 52.8067a
Cext_10463 \$33 d7|dac_hard[7] 212.737a
Cext_10464 \$33 IOVDD|vdda 18.2335a
Cext_10465 \$33 VDD|vdd 483.483a
Cext_10466 \$33 VSS|vss 297.718a
Cext_10467 \$33 VSUBS 569.215a
Cext_10468 \$330 \$331 2.16563a
Cext_10469 \$330 \$35 68.8428a
Cext_10470 \$330 \$353 102.889a
Cext_10471 \$330 \$354 225.319a
Cext_10472 \$330 \$41 0.115752a
Cext_10473 \$330 \$43 0.481837a
Cext_10474 \$330 \$45 20.8391a
Cext_10475 \$330 \$67 59.1234a
Cext_10476 \$330 \$69 0.343978a
Cext_10477 \$330 VSS|vss 60.9228a
Cext_10478 \$330 VSUBS 811.667a
Cext_10479 \$331 \$332 0.179323a
Cext_10480 \$331 \$35 2.65407a
Cext_10481 \$331 \$353 83.8393a
Cext_10482 \$331 \$37 56.4353a
Cext_10483 \$331 \$374 783.202a
Cext_10484 \$331 \$39 56.2856a
Cext_10485 \$331 \$399 15.7815a
Cext_10486 \$331 \$41 1.18748a
Cext_10487 \$331 \$43 0.13075a
Cext_10488 \$331 \$435 99.1454a
Cext_10489 \$331 \$451 0.250757a
Cext_10490 \$331 \$69 60.0621a
Cext_10491 \$331 \$71 50.2205a
Cext_10492 \$331 \$73 49.6419a
Cext_10493 \$331 \$75 1.67062a
Cext_10494 \$331 \$77 0.98091a
Cext_10495 \$331 VSUBS 198.38a
Cext_10496 \$332 \$35 68.8031a
Cext_10497 \$332 \$355 254.864a
Cext_10498 \$332 \$375 0.360462a
Cext_10499 \$332 \$39 0.105966a
Cext_10500 \$332 \$41 0.282145a
Cext_10501 \$332 \$43 0.494517a
Cext_10502 \$332 \$45 20.9159a
Cext_10503 \$332 \$67 64.1221a
Cext_10504 \$332 \$69 0.155901a
Cext_10505 \$332 IOVDD|vdda 13.0646a
Cext_10506 \$332 VSS|vss 66.2132a
Cext_10507 \$332 VSUBS 817.28a
Cext_10508 \$333 \$334 2.16563a
Cext_10509 \$333 \$35 68.8428a
Cext_10510 \$333 \$357 102.889a
Cext_10511 \$333 \$358 225.319a
Cext_10512 \$333 \$41 0.115752a
Cext_10513 \$333 \$43 0.481837a
Cext_10514 \$333 \$45 20.8391a
Cext_10515 \$333 \$67 59.1234a
Cext_10516 \$333 \$69 0.343978a
Cext_10517 \$333 VSS|vss 60.9228a
Cext_10518 \$333 VSUBS 811.667a
Cext_10519 \$334 \$335 0.179323a
Cext_10520 \$334 \$35 2.65407a
Cext_10521 \$334 \$357 83.8393a
Cext_10522 \$334 \$37 56.4353a
Cext_10523 \$334 \$376 783.202a
Cext_10524 \$334 \$39 56.2856a
Cext_10525 \$334 \$400 15.7815a
Cext_10526 \$334 \$41 1.18748a
Cext_10527 \$334 \$43 0.13075a
Cext_10528 \$334 \$438 99.1454a
Cext_10529 \$334 \$452 0.250757a
Cext_10530 \$334 \$69 60.0621a
Cext_10531 \$334 \$71 50.2205a
Cext_10532 \$334 \$73 49.6419a
Cext_10533 \$334 \$75 1.67062a
Cext_10534 \$334 \$77 0.98091a
Cext_10535 \$334 VSUBS 198.447a
Cext_10536 \$335 \$359 130.175a
Cext_10537 \$335 \$39 0.105966a
Cext_10538 \$335 \$41 0.282145a
Cext_10539 \$335 \$43 0.494517a
Cext_10540 \$335 \$45 21.0663a
Cext_10541 \$335 VSS|vss 2.2008a
Cext_10542 \$335 VSUBS 676a
Cext_10543 \$336 \$337 45.0654a
Cext_10544 \$336 \$360 130.128a
Cext_10545 \$336 VDD|vdd 0.592094a
Cext_10546 \$336 VSS|vss 25.1792a
Cext_10547 \$336 VSUBS 659.267a
Cext_10548 \$337 \$338 45.0654a
Cext_10549 \$337 \$361 130.175a
Cext_10550 \$337 VSS|vss 5.452a
Cext_10551 \$337 VSUBS 634.529a
Cext_10552 \$338 \$339 45.0654a
Cext_10553 \$338 \$362 130.175a
Cext_10554 \$338 VSUBS 634.529a
Cext_10555 \$339 \$340 46.4004a
Cext_10556 \$339 \$363 130.175a
Cext_10557 \$339 VSS|vss 0.378729a
Cext_10558 \$339 VSUBS 634.529a
Cext_10559 \$34 \$35 602.158a
Cext_10560 \$34 \$36 2.13277a
Cext_10561 \$34 \$49 2.67777a
Cext_10562 \$34 \$66 902.785a
Cext_10563 \$34 \$67 0.237316a
Cext_10564 \$34 d0|dac_soft[0] 130.648a
Cext_10565 \$34 d7|dac_soft[7] 14.8234a
Cext_10566 \$34 IOVDD|vdda 173.948a
Cext_10567 \$34 VDD|vdd 12.6254a
Cext_10568 \$34 VSS|vss 485.754a
Cext_10569 \$34 VSUBS 1.54024f
Cext_10570 \$340 \$364 254.864a
Cext_10571 \$340 \$377 0.360462a
Cext_10572 \$340 \$51 68.8031a
Cext_10573 \$340 \$83 64.1221a
Cext_10574 \$340 \$85 0.155901a
Cext_10575 \$340 VSS|vss 66.2906a
Cext_10576 \$340 VSUBS 799.746a
Cext_10577 \$341 \$342 2.16563a
Cext_10578 \$341 \$366 225.319a
Cext_10579 \$341 \$367 102.889a
Cext_10580 \$341 \$51 68.8428a
Cext_10581 \$341 \$57 0.115752a
Cext_10582 \$341 \$59 0.481837a
Cext_10583 \$341 \$61 20.8391a
Cext_10584 \$341 \$83 59.1234a
Cext_10585 \$341 \$85 0.343978a
Cext_10586 \$341 VSS|vss 60.9228a
Cext_10587 \$341 VSUBS 811.667a
Cext_10588 \$342 \$343 0.179323a
Cext_10589 \$342 \$367 83.8393a
Cext_10590 \$342 \$378 783.202a
Cext_10591 \$342 \$401 15.7815a
Cext_10592 \$342 \$446 99.1454a
Cext_10593 \$342 \$453 0.250757a
Cext_10594 \$342 \$51 2.65407a
Cext_10595 \$342 \$53 56.4353a
Cext_10596 \$342 \$55 56.2856a
Cext_10597 \$342 \$57 1.18748a
Cext_10598 \$342 \$59 0.13075a
Cext_10599 \$342 \$85 60.0621a
Cext_10600 \$342 \$87 50.2205a
Cext_10601 \$342 \$89 49.6419a
Cext_10602 \$342 \$91 1.67062a
Cext_10603 \$342 \$93 0.98091a
Cext_10604 \$342 VSUBS 198.38a
Cext_10605 \$343 \$368 254.864a
Cext_10606 \$343 \$379 0.360462a
Cext_10607 \$343 \$51 68.8031a
Cext_10608 \$343 \$55 0.105966a
Cext_10609 \$343 \$57 0.282145a
Cext_10610 \$343 \$59 0.494517a
Cext_10611 \$343 \$61 20.9159a
Cext_10612 \$343 \$83 64.1221a
Cext_10613 \$343 \$85 0.155901a
Cext_10614 \$343 IOVDD|vdda 13.0646a
Cext_10615 \$343 VSS|vss 66.2132a
Cext_10616 \$343 VSUBS 817.28a
Cext_10617 \$344 \$345 2.16563a
Cext_10618 \$344 \$370 102.889a
Cext_10619 \$344 \$371 225.319a
Cext_10620 \$344 \$51 68.8428a
Cext_10621 \$344 \$57 0.115752a
Cext_10622 \$344 \$59 0.481837a
Cext_10623 \$344 \$61 20.8391a
Cext_10624 \$344 \$83 59.1234a
Cext_10625 \$344 \$85 0.343978a
Cext_10626 \$344 VSS|vss 69.9251a
Cext_10627 \$344 VSUBS 811.667a
Cext_10628 \$345 \$346 0.179323a
Cext_10629 \$345 \$370 83.8393a
Cext_10630 \$345 \$380 783.202a
Cext_10631 \$345 \$402 15.7815a
Cext_10632 \$345 \$449 99.1454a
Cext_10633 \$345 \$454 0.250757a
Cext_10634 \$345 \$51 2.65407a
Cext_10635 \$345 \$53 56.4353a
Cext_10636 \$345 \$55 56.2856a
Cext_10637 \$345 \$57 1.18748a
Cext_10638 \$345 \$59 0.13075a
Cext_10639 \$345 \$85 60.0621a
Cext_10640 \$345 \$87 50.2205a
Cext_10641 \$345 \$89 49.6419a
Cext_10642 \$345 \$91 1.67062a
Cext_10643 \$345 \$93 0.98091a
Cext_10644 \$345 VSUBS 198.447a
Cext_10645 \$346 \$372 130.175a
Cext_10646 \$346 \$55 0.105966a
Cext_10647 \$346 \$57 0.282145a
Cext_10648 \$346 \$59 0.494517a
Cext_10649 \$346 \$61 21.0663a
Cext_10650 \$346 VSS|vss 2.2008a
Cext_10651 \$346 VSUBS 676a
Cext_10652 \$347 \$348 45.0654a
Cext_10653 \$347 \$381 130.175a
Cext_10654 \$347 VDD|vdd 7.74075a
Cext_10655 \$347 VSS|vss 1.71997a
Cext_10656 \$347 VSUBS 659.267a
Cext_10657 \$348 \$349 45.0654a
Cext_10658 \$348 \$382 130.175a
Cext_10659 \$348 VDD|vdd 0.968272a
Cext_10660 \$348 VSUBS 634.529a
Cext_10661 \$349 \$350 45.0654a
Cext_10662 \$349 \$383 130.175a
Cext_10663 \$349 VSUBS 634.529a
Cext_10664 \$35 \$351 22.6915a
Cext_10665 \$35 \$352 3.05553a
Cext_10666 \$35 \$353 123.657a
Cext_10667 \$35 \$354 23.2117a
Cext_10668 \$35 \$355 22.6915a
Cext_10669 \$35 \$356 3.05553a
Cext_10670 \$35 \$357 123.657a
Cext_10671 \$35 \$358 23.2117a
Cext_10672 \$35 \$36 41.8224a
Cext_10673 \$35 \$37 62.7514a
Cext_10674 \$35 \$373 123.657a
Cext_10675 \$35 \$374 0.592076a
Cext_10676 \$35 \$375 123.51a
Cext_10677 \$35 \$376 0.592076a
Cext_10678 \$35 \$385 69.0342a
Cext_10679 \$35 \$386 68.7272a
Cext_10680 \$35 \$387 69.0342a
Cext_10681 \$35 \$388 68.7272a
Cext_10682 \$35 \$39 41.5709a
Cext_10683 \$35 \$399 134.708a
Cext_10684 \$35 \$400 134.708a
Cext_10685 \$35 \$407 22.8071a
Cext_10686 \$35 \$408 0.496172a
Cext_10687 \$35 \$409 23.4429a
Cext_10688 \$35 \$41 38.4696a
Cext_10689 \$35 \$410 22.8071a
Cext_10690 \$35 \$411 0.496172a
Cext_10691 \$35 \$412 23.4429a
Cext_10692 \$35 \$425 134.708a
Cext_10693 \$35 \$426 134.561a
Cext_10694 \$35 \$43 34.7033a
Cext_10695 \$35 \$433 68.8031a
Cext_10696 \$35 \$434 68.8428a
Cext_10697 \$35 \$435 2.95962a
Cext_10698 \$35 \$436 68.8031a
Cext_10699 \$35 \$437 68.8428a
Cext_10700 \$35 \$438 2.95962a
Cext_10701 \$35 \$45 49.4131a
Cext_10702 \$35 \$451 123.657a
Cext_10703 \$35 \$452 123.657a
Cext_10704 \$35 \$459 22.6915a
Cext_10705 \$35 \$460 23.2117a
Cext_10706 \$35 \$461 22.6915a
Cext_10707 \$35 \$462 23.2117a
Cext_10708 \$35 \$47 24.7948a
Cext_10709 \$35 \$473 123.657a
Cext_10710 \$35 \$474 123.51a
Cext_10711 \$35 \$481 69.0342a
Cext_10712 \$35 \$482 68.7272a
Cext_10713 \$35 \$483 69.0342a
Cext_10714 \$35 \$484 68.7272a
Cext_10715 \$35 \$49 47.4821a
Cext_10716 \$35 \$499 22.8071a
Cext_10717 \$35 \$500 2.17385a
Cext_10718 \$35 \$501 0.604961a
Cext_10719 \$35 \$502 134.708a
Cext_10720 \$35 \$503 23.4429a
Cext_10721 \$35 \$504 22.8071a
Cext_10722 \$35 \$505 2.17385a
Cext_10723 \$35 \$506 0.604961a
Cext_10724 \$35 \$507 134.708a
Cext_10725 \$35 \$508 23.4429a
Cext_10726 \$35 \$525 134.708a
Cext_10727 \$35 \$526 0.621099a
Cext_10728 \$35 \$527 134.561a
Cext_10729 \$35 \$528 0.621099a
Cext_10730 \$35 \$537 68.8031a
Cext_10731 \$35 \$538 68.8428a
Cext_10732 \$35 \$539 2.39761a
Cext_10733 \$35 \$540 68.8031a
Cext_10734 \$35 \$541 68.8428a
Cext_10735 \$35 \$542 2.39761a
Cext_10736 \$35 \$555 3.05553a
Cext_10737 \$35 \$556 123.657a
Cext_10738 \$35 \$557 3.05553a
Cext_10739 \$35 \$558 123.657a
Cext_10740 \$35 \$567 22.6915a
Cext_10741 \$35 \$568 23.2117a
Cext_10742 \$35 \$569 22.6915a
Cext_10743 \$35 \$570 23.2117a
Cext_10744 \$35 \$580 123.657a
Cext_10745 \$35 \$581 0.592076a
Cext_10746 \$35 \$582 123.51a
Cext_10747 \$35 \$583 0.592076a
Cext_10748 \$35 \$592 69.0342a
Cext_10749 \$35 \$593 68.7272a
Cext_10750 \$35 \$594 69.0342a
Cext_10751 \$35 \$595 68.7272a
Cext_10752 \$35 \$606 2.65407a
Cext_10753 \$35 \$607 134.708a
Cext_10754 \$35 \$608 2.65407a
Cext_10755 \$35 \$609 134.708a
Cext_10756 \$35 \$618 22.8071a
Cext_10757 \$35 \$619 0.496172a
Cext_10758 \$35 \$620 23.4429a
Cext_10759 \$35 \$621 22.8071a
Cext_10760 \$35 \$622 0.496172a
Cext_10761 \$35 \$623 23.4429a
Cext_10762 \$35 \$638 134.708a
Cext_10763 \$35 \$639 68.8031a
Cext_10764 \$35 \$640 68.8428a
Cext_10765 \$35 \$641 2.95962a
Cext_10766 \$35 \$642 0.564032a
Cext_10767 \$35 \$643 134.561a
Cext_10768 \$35 \$644 68.8031a
Cext_10769 \$35 \$645 68.8428a
Cext_10770 \$35 \$646 0.564032a
Cext_10771 \$35 \$647 2.95962a
Cext_10772 \$35 \$66 69.1586a
Cext_10773 \$35 \$662 123.657a
Cext_10774 \$35 \$663 123.657a
Cext_10775 \$35 \$67 37.0303f
Cext_10776 \$35 \$670 22.6915a
Cext_10777 \$35 \$671 23.2117a
Cext_10778 \$35 \$672 22.6915a
Cext_10779 \$35 \$673 23.2117a
Cext_10780 \$35 \$68 10.2105a
Cext_10781 \$35 \$686 123.657a
Cext_10782 \$35 \$687 69.0342a
Cext_10783 \$35 \$688 68.7272a
Cext_10784 \$35 \$689 123.51a
Cext_10785 \$35 \$69 16.2891f
Cext_10786 \$35 \$690 69.0342a
Cext_10787 \$35 \$691 68.7272a
Cext_10788 \$35 \$702 134.708a
Cext_10789 \$35 \$703 134.708a
Cext_10790 \$35 \$71 90.8917a
Cext_10791 \$35 \$710 22.8071a
Cext_10792 \$35 \$711 0.564032a
Cext_10793 \$35 \$712 23.4429a
Cext_10794 \$35 \$713 22.8071a
Cext_10795 \$35 \$714 0.564032a
Cext_10796 \$35 \$715 23.4429a
Cext_10797 \$35 \$73 117.534a
Cext_10798 \$35 \$730 68.8031a
Cext_10799 \$35 \$731 134.708a
Cext_10800 \$35 \$732 68.8428a
Cext_10801 \$35 \$733 2.65407a
Cext_10802 \$35 \$734 134.561a
Cext_10803 \$35 \$735 68.8031a
Cext_10804 \$35 \$736 2.65407a
Cext_10805 \$35 \$749 3.05553a
Cext_10806 \$35 \$75 187.009a
Cext_10807 \$35 \$750 123.657a
Cext_10808 \$35 \$751 3.05553a
Cext_10809 \$35 \$752 68.8428a
Cext_10810 \$35 \$753 123.657a
Cext_10811 \$35 \$762 22.6915a
Cext_10812 \$35 \$763 23.2117a
Cext_10813 \$35 \$764 22.6915a
Cext_10814 \$35 \$765 23.2117a
Cext_10815 \$35 \$77 72.5365f
Cext_10816 \$35 \$778 69.0342a
Cext_10817 \$35 \$779 123.657a
Cext_10818 \$35 \$780 68.7272a
Cext_10819 \$35 \$781 0.592076a
Cext_10820 \$35 \$782 69.0342a
Cext_10821 \$35 \$783 123.51a
Cext_10822 \$35 \$784 68.7272a
Cext_10823 \$35 \$785 0.592076a
Cext_10824 \$35 \$79 24.6843a
Cext_10825 \$35 \$798 134.708a
Cext_10826 \$35 \$799 134.708a
Cext_10827 \$35 \$806 22.8071a
Cext_10828 \$35 \$807 0.496172a
Cext_10829 \$35 \$808 23.4429a
Cext_10830 \$35 \$809 22.8071a
Cext_10831 \$35 \$81 26.1111a
Cext_10832 \$35 \$810 0.496172a
Cext_10833 \$35 \$811 23.4429a
Cext_10834 \$35 \$825 68.8031a
Cext_10835 \$35 \$826 134.708a
Cext_10836 \$35 \$827 68.8428a
Cext_10837 \$35 \$828 2.95962a
Cext_10838 \$35 \$829 134.561a
Cext_10839 \$35 \$830 68.8031a
Cext_10840 \$35 \$831 68.8428a
Cext_10841 \$35 \$832 2.95962a
Cext_10842 \$35 \$846 123.657a
Cext_10843 \$35 \$847 123.657a
Cext_10844 \$35 \$854 22.6915a
Cext_10845 \$35 \$855 23.2117a
Cext_10846 \$35 \$856 22.6915a
Cext_10847 \$35 \$857 23.2117a
Cext_10848 \$35 \$866 123.657a
Cext_10849 \$35 \$867 123.51a
Cext_10850 \$35 \$873 69.0342a
Cext_10851 \$35 \$874 68.7272a
Cext_10852 \$35 \$875 69.0342a
Cext_10853 \$35 \$876 68.7272a
Cext_10854 \$35 \$886 138.583a
Cext_10855 \$35 \$887 134.708a
Cext_10856 \$35 \$888 54.4046a
Cext_10857 \$35 \$889 134.708a
Cext_10858 \$35 \$898 22.8071a
Cext_10859 \$35 \$899 23.4429a
Cext_10860 \$35 \$900 22.8071a
Cext_10861 \$35 \$901 23.4429a
Cext_10862 \$35 \$914 134.708a
Cext_10863 \$35 \$915 68.8031a
Cext_10864 \$35 \$916 68.8428a
Cext_10865 \$35 \$917 71.5528a
Cext_10866 \$35 \$918 134.561a
Cext_10867 \$35 \$919 68.8031a
Cext_10868 \$35 \$920 68.8428a
Cext_10869 \$35 \$921 3.26094a
Cext_10870 \$35 \$934 3.05553a
Cext_10871 \$35 \$935 123.657a
Cext_10872 \$35 \$936 3.05553a
Cext_10873 \$35 \$937 123.657a
Cext_10874 \$35 \$946 22.6915a
Cext_10875 \$35 \$947 23.2117a
Cext_10876 \$35 \$948 22.6915a
Cext_10877 \$35 \$949 23.2117a
Cext_10878 \$35 \$961 69.0342a
Cext_10879 \$35 \$962 123.657a
Cext_10880 \$35 \$963 0.592076a
Cext_10881 \$35 \$964 123.51a
Cext_10882 \$35 \$965 69.0342a
Cext_10883 \$35 \$966 0.479522a
Cext_10884 \$35 \$980 68.7272a
Cext_10885 \$35 \$981 68.7272a
Cext_10886 \$35 \$984 2.65407a
Cext_10887 \$35 \$985 134.708a
Cext_10888 \$35 \$986 2.65407a
Cext_10889 \$35 \$987 134.681a
Cext_10890 \$35 \$996 22.8071a
Cext_10891 \$35 \$997 0.496172a
Cext_10892 \$35 \$998 23.4429a
Cext_10893 \$35 \$999 22.8071a
Cext_10894 \$35 d1|dac_soft[1] 28.2212a
Cext_10895 \$35 d7|dac_soft[7] 6.69708a
Cext_10896 \$35 IOVDD|vdda 1.5277f
Cext_10897 \$35 VDD|vdd 5.43972a
Cext_10898 \$35 VREF|vref 8.82156a
Cext_10899 \$35 VSS|vss 639.642a
Cext_10900 \$35 VSUBS 58.6328f
Cext_10901 \$350 \$351 45.8951a
Cext_10902 \$350 \$384 130.175a
Cext_10903 \$350 VSS|vss 0.428128a
Cext_10904 \$350 VSUBS 634.529a
Cext_10905 \$351 \$373 113.058a
Cext_10906 \$351 \$385 225.319a
Cext_10907 \$351 \$67 105.489a
Cext_10908 \$351 VSS|vss 61.1015a
Cext_10909 \$351 VSUBS 793.257a
Cext_10910 \$352 \$37 91.0317a
Cext_10911 \$352 \$373 227.572a
Cext_10912 \$352 \$385 3.25406a
Cext_10913 \$352 \$386 0.179323a
Cext_10914 \$352 \$39 1.18748a
Cext_10915 \$352 \$408 7.41179a
Cext_10916 \$352 \$41 0.476813a
Cext_10917 \$352 \$69 106.353a
Cext_10918 \$352 \$71 53.5342a
Cext_10919 \$352 \$73 3.67334a
Cext_10920 \$352 \$75 1.61371a
Cext_10921 \$352 \$77 1.13718a
Cext_10922 \$352 VSUBS 168.265a
Cext_10923 \$353 \$354 114.006a
Cext_10924 \$353 \$355 0.182933a
Cext_10925 \$353 \$37 65.4666a
Cext_10926 \$353 \$374 98.5952a
Cext_10927 \$353 \$386 0.360462a
Cext_10928 \$353 \$399 108.267a
Cext_10929 \$353 \$41 0.62262a
Cext_10930 \$353 \$67 80.1821a
Cext_10931 \$353 \$69 70.7638a
Cext_10932 \$353 \$71 31.3588a
Cext_10933 \$353 \$73 36.0014a
Cext_10934 \$353 \$75 35.6349a
Cext_10935 \$353 \$77 45.7852a
Cext_10936 \$353 VSS|vss 0.378848a
Cext_10937 \$353 VSUBS 257.776a
Cext_10938 \$354 \$37 0.145978a
Cext_10939 \$354 \$373 0.182933a
Cext_10940 \$354 \$386 254.864a
Cext_10941 \$354 \$39 0.105966a
Cext_10942 \$354 \$399 0.360462a
Cext_10943 \$354 \$41 0.282145a
Cext_10944 \$354 \$43 0.494517a
Cext_10945 \$354 \$45 20.7622a
Cext_10946 \$354 \$67 110.011a
Cext_10947 \$354 VSS|vss 66.2132a
Cext_10948 \$354 VSUBS 817.35a
Cext_10949 \$355 \$37 0.404672a
Cext_10950 \$355 \$375 113.058a
Cext_10951 \$355 \$387 225.319a
Cext_10952 \$355 \$41 0.115752a
Cext_10953 \$355 \$43 0.481837a
Cext_10954 \$355 \$45 20.8391a
Cext_10955 \$355 \$67 105.489a
Cext_10956 \$355 IOVDD|vdda 11.5102a
Cext_10957 \$355 VSS|vss 60.9228a
Cext_10958 \$355 VSUBS 810.376a
Cext_10959 \$356 \$37 91.0317a
Cext_10960 \$356 \$375 227.572a
Cext_10961 \$356 \$387 3.25406a
Cext_10962 \$356 \$388 0.179323a
Cext_10963 \$356 \$39 1.18748a
Cext_10964 \$356 \$41 0.476813a
Cext_10965 \$356 \$411 7.41179a
Cext_10966 \$356 \$69 106.353a
Cext_10967 \$356 \$71 53.5342a
Cext_10968 \$356 \$73 3.67334a
Cext_10969 \$356 \$75 1.61371a
Cext_10970 \$356 \$77 1.13718a
Cext_10971 \$356 IOVDD|vdda 5.12547a
Cext_10972 \$356 VSUBS 168.265a
Cext_10973 \$357 \$358 114.006a
Cext_10974 \$357 \$359 0.182933a
Cext_10975 \$357 \$37 65.4666a
Cext_10976 \$357 \$376 98.5952a
Cext_10977 \$357 \$388 0.360462a
Cext_10978 \$357 \$400 108.267a
Cext_10979 \$357 \$41 0.62262a
Cext_10980 \$357 \$67 80.1821a
Cext_10981 \$357 \$69 70.7638a
Cext_10982 \$357 \$71 31.3588a
Cext_10983 \$357 \$73 36.0014a
Cext_10984 \$357 \$75 35.6349a
Cext_10985 \$357 \$77 45.7852a
Cext_10986 \$357 VSS|vss 0.378848a
Cext_10987 \$357 VSUBS 257.776a
Cext_10988 \$358 \$37 0.145978a
Cext_10989 \$358 \$375 0.182933a
Cext_10990 \$358 \$388 254.864a
Cext_10991 \$358 \$39 0.105966a
Cext_10992 \$358 \$400 0.360462a
Cext_10993 \$358 \$41 0.282145a
Cext_10994 \$358 \$43 0.494517a
Cext_10995 \$358 \$45 20.7622a
Cext_10996 \$358 \$67 110.011a
Cext_10997 \$358 VSS|vss 66.2132a
Cext_10998 \$358 VSUBS 817.35a
Cext_10999 \$359 \$37 0.404672a
Cext_11000 \$359 \$389 130.175a
Cext_11001 \$359 \$41 0.115752a
Cext_11002 \$359 \$43 0.481837a
Cext_11003 \$359 \$45 20.9895a
Cext_11004 \$359 VSS|vss 2.2008a
Cext_11005 \$359 VSUBS 675.619a
Cext_11006 \$36 \$37 602.158a
Cext_11007 \$36 \$38 2.13277a
Cext_11008 \$36 \$47 0.110435a
Cext_11009 \$36 \$49 24.0132a
Cext_11010 \$36 \$67 29.0633a
Cext_11011 \$36 \$68 902.785a
Cext_11012 \$36 \$69 0.237316a
Cext_11013 \$36 \$81 0.127512a
Cext_11014 \$36 d1|dac_soft[1] 130.648a
Cext_11015 \$36 d7|dac_soft[7] 14.8234a
Cext_11016 \$36 IOVDD|vdda 173.852a
Cext_11017 \$36 VDD|vdd 10.4718a
Cext_11018 \$36 VSS|vss 446.394a
Cext_11019 \$36 VSUBS 1.50594f
Cext_11020 \$360 \$361 45.0654a
Cext_11021 \$360 \$390 130.128a
Cext_11022 \$360 VDD|vdd 0.592094a
Cext_11023 \$360 VSS|vss 25.1792a
Cext_11024 \$360 VSUBS 659.267a
Cext_11025 \$361 \$362 45.0654a
Cext_11026 \$361 \$391 130.175a
Cext_11027 \$361 VSS|vss 5.452a
Cext_11028 \$361 VSUBS 634.529a
Cext_11029 \$362 \$363 45.0654a
Cext_11030 \$362 \$392 130.175a
Cext_11031 \$362 VSUBS 634.529a
Cext_11032 \$363 \$364 45.8951a
Cext_11033 \$363 \$393 130.175a
Cext_11034 \$363 VSS|vss 0.428128a
Cext_11035 \$363 VSUBS 634.529a
Cext_11036 \$364 \$377 113.058a
Cext_11037 \$364 \$394 225.319a
Cext_11038 \$364 \$51 22.6915a
Cext_11039 \$364 \$83 105.489a
Cext_11040 \$364 VSS|vss 61.1015a
Cext_11041 \$364 VSUBS 793.257a
Cext_11042 \$365 \$377 227.572a
Cext_11043 \$365 \$394 3.25406a
Cext_11044 \$365 \$395 0.179323a
Cext_11045 \$365 \$419 7.41179a
Cext_11046 \$365 \$51 3.05553a
Cext_11047 \$365 \$53 91.0317a
Cext_11048 \$365 \$55 1.18748a
Cext_11049 \$365 \$57 0.476813a
Cext_11050 \$365 \$85 106.353a
Cext_11051 \$365 \$87 53.5342a
Cext_11052 \$365 \$89 3.67334a
Cext_11053 \$365 \$91 1.61371a
Cext_11054 \$365 \$93 1.13718a
Cext_11055 \$365 VSUBS 168.265a
Cext_11056 \$366 \$367 114.006a
Cext_11057 \$366 \$377 0.182933a
Cext_11058 \$366 \$395 254.864a
Cext_11059 \$366 \$401 0.360462a
Cext_11060 \$366 \$51 23.2117a
Cext_11061 \$366 \$53 0.145978a
Cext_11062 \$366 \$55 0.105966a
Cext_11063 \$366 \$57 0.282145a
Cext_11064 \$366 \$59 0.494517a
Cext_11065 \$366 \$61 20.7622a
Cext_11066 \$366 \$83 110.011a
Cext_11067 \$366 VSS|vss 66.2132a
Cext_11068 \$366 VSUBS 817.35a
Cext_11069 \$367 \$368 0.182933a
Cext_11070 \$367 \$378 98.5952a
Cext_11071 \$367 \$395 0.360462a
Cext_11072 \$367 \$401 108.267a
Cext_11073 \$367 \$51 123.657a
Cext_11074 \$367 \$53 65.4666a
Cext_11075 \$367 \$57 0.62262a
Cext_11076 \$367 \$83 80.1821a
Cext_11077 \$367 \$85 70.7638a
Cext_11078 \$367 \$87 31.3588a
Cext_11079 \$367 \$89 36.0014a
Cext_11080 \$367 \$91 35.6349a
Cext_11081 \$367 \$93 45.7852a
Cext_11082 \$367 VSS|vss 0.378848a
Cext_11083 \$367 VSUBS 257.776a
Cext_11084 \$368 \$379 113.058a
Cext_11085 \$368 \$396 225.319a
Cext_11086 \$368 \$51 22.6915a
Cext_11087 \$368 \$53 0.404672a
Cext_11088 \$368 \$57 0.115752a
Cext_11089 \$368 \$59 0.481837a
Cext_11090 \$368 \$61 20.8391a
Cext_11091 \$368 \$83 105.489a
Cext_11092 \$368 IOVDD|vdda 11.5102a
Cext_11093 \$368 VSS|vss 60.9228a
Cext_11094 \$368 VSUBS 810.376a
Cext_11095 \$369 \$379 227.572a
Cext_11096 \$369 \$396 3.25406a
Cext_11097 \$369 \$397 0.179323a
Cext_11098 \$369 \$422 7.41179a
Cext_11099 \$369 \$51 3.05553a
Cext_11100 \$369 \$53 91.0317a
Cext_11101 \$369 \$55 1.18748a
Cext_11102 \$369 \$57 0.476813a
Cext_11103 \$369 \$85 106.353a
Cext_11104 \$369 \$87 53.5342a
Cext_11105 \$369 \$89 3.67334a
Cext_11106 \$369 \$91 1.61371a
Cext_11107 \$369 \$93 1.13718a
Cext_11108 \$369 IOVDD|vdda 5.12547a
Cext_11109 \$369 VSS|vss 5.39382a
Cext_11110 \$369 VSUBS 168.265a
Cext_11111 \$37 \$373 65.6459a
Cext_11112 \$37 \$374 82.9986a
Cext_11113 \$37 \$375 65.6459a
Cext_11114 \$37 \$376 82.9986a
Cext_11115 \$37 \$38 41.8224a
Cext_11116 \$37 \$39 74.5733f
Cext_11117 \$37 \$399 19.3729a
Cext_11118 \$37 \$400 19.3729a
Cext_11119 \$37 \$408 82.9986a
Cext_11120 \$37 \$41 904.336a
Cext_11121 \$37 \$411 82.9986a
Cext_11122 \$37 \$425 19.3729a
Cext_11123 \$37 \$426 19.3729a
Cext_11124 \$37 \$43 472.358a
Cext_11125 \$37 \$435 93.95a
Cext_11126 \$37 \$438 93.95a
Cext_11127 \$37 \$45 272.318a
Cext_11128 \$37 \$451 65.6459a
Cext_11129 \$37 \$452 65.6459a
Cext_11130 \$37 \$460 0.145978a
Cext_11131 \$37 \$461 0.404672a
Cext_11132 \$37 \$462 0.145978a
Cext_11133 \$37 \$463 0.404672a
Cext_11134 \$37 \$47 32.0065a
Cext_11135 \$37 \$473 65.5562a
Cext_11136 \$37 \$474 65.5562a
Cext_11137 \$37 \$49 53.223a
Cext_11138 \$37 \$500 471.14a
Cext_11139 \$37 \$501 88.8335a
Cext_11140 \$37 \$502 19.3729a
Cext_11141 \$37 \$505 471.14a
Cext_11142 \$37 \$506 88.8335a
Cext_11143 \$37 \$507 19.3729a
Cext_11144 \$37 \$525 19.3729a
Cext_11145 \$37 \$526 466.74a
Cext_11146 \$37 \$527 19.3729a
Cext_11147 \$37 \$528 467.612a
Cext_11148 \$37 \$539 93.4626a
Cext_11149 \$37 \$542 93.4626a
Cext_11150 \$37 \$555 93.8054a
Cext_11151 \$37 \$556 65.5562a
Cext_11152 \$37 \$557 93.8054a
Cext_11153 \$37 \$558 65.5562a
Cext_11154 \$37 \$568 0.145978a
Cext_11155 \$37 \$569 0.404672a
Cext_11156 \$37 \$570 0.145978a
Cext_11157 \$37 \$571 0.404672a
Cext_11158 \$37 \$580 65.6459a
Cext_11159 \$37 \$581 82.9986a
Cext_11160 \$37 \$582 65.6459a
Cext_11161 \$37 \$583 82.9986a
Cext_11162 \$37 \$606 56.2993a
Cext_11163 \$37 \$607 19.3729a
Cext_11164 \$37 \$608 56.2993a
Cext_11165 \$37 \$609 19.3729a
Cext_11166 \$37 \$619 82.9986a
Cext_11167 \$37 \$622 82.9986a
Cext_11168 \$37 \$638 19.3729a
Cext_11169 \$37 \$641 90.8871a
Cext_11170 \$37 \$642 51.1437a
Cext_11171 \$37 \$643 19.3729a
Cext_11172 \$37 \$646 51.1437a
Cext_11173 \$37 \$647 90.8871a
Cext_11174 \$37 \$662 65.6459a
Cext_11175 \$37 \$663 65.6459a
Cext_11176 \$37 \$67 226.516a
Cext_11177 \$37 \$671 0.145978a
Cext_11178 \$37 \$672 0.404672a
Cext_11179 \$37 \$673 0.145978a
Cext_11180 \$37 \$68 69.1586a
Cext_11181 \$37 \$686 65.4666a
Cext_11182 \$37 \$689 65.4666a
Cext_11183 \$37 \$69 28.1882f
Cext_11184 \$37 \$70 10.2105a
Cext_11185 \$37 \$702 19.3729a
Cext_11186 \$37 \$703 19.3729a
Cext_11187 \$37 \$71 17.3248f
Cext_11188 \$37 \$711 53.9723a
Cext_11189 \$37 \$714 53.9723a
Cext_11190 \$37 \$73 571.193a
Cext_11191 \$37 \$731 19.3729a
Cext_11192 \$37 \$733 59.1279a
Cext_11193 \$37 \$734 19.3729a
Cext_11194 \$37 \$736 59.1279a
Cext_11195 \$37 \$749 91.1126a
Cext_11196 \$37 \$75 305.201a
Cext_11197 \$37 \$750 65.4666a
Cext_11198 \$37 \$751 91.1126a
Cext_11199 \$37 \$753 65.4666a
Cext_11200 \$37 \$763 0.145978a
Cext_11201 \$37 \$764 0.404672a
Cext_11202 \$37 \$765 0.145978a
Cext_11203 \$37 \$77 189.12a
Cext_11204 \$37 \$779 65.6459a
Cext_11205 \$37 \$781 82.9986a
Cext_11206 \$37 \$783 65.6459a
Cext_11207 \$37 \$785 82.9986a
Cext_11208 \$37 \$79 30.4252a
Cext_11209 \$37 \$798 19.3729a
Cext_11210 \$37 \$799 19.3729a
Cext_11211 \$37 \$807 82.9075a
Cext_11212 \$37 \$81 31.852a
Cext_11213 \$37 \$810 82.9075a
Cext_11214 \$37 \$826 19.3729a
Cext_11215 \$37 \$828 96.6471a
Cext_11216 \$37 \$829 19.3729a
Cext_11217 \$37 \$832 96.6471a
Cext_11218 \$37 \$846 65.5547a
Cext_11219 \$37 \$847 65.5547a
Cext_11220 \$37 \$855 0.145978a
Cext_11221 \$37 \$856 0.404672a
Cext_11222 \$37 \$857 0.145978a
Cext_11223 \$37 \$866 65.7176a
Cext_11224 \$37 \$867 65.7176a
Cext_11225 \$37 \$886 188.337a
Cext_11226 \$37 \$887 19.3729a
Cext_11227 \$37 \$888 117.411a
Cext_11228 \$37 \$889 19.3729a
Cext_11229 \$37 \$914 19.3729a
Cext_11230 \$37 \$917 158.912a
Cext_11231 \$37 \$918 19.3729a
Cext_11232 \$37 \$921 80.0464a
Cext_11233 \$37 \$934 96.6471a
Cext_11234 \$37 \$935 65.7176a
Cext_11235 \$37 \$936 96.6471a
Cext_11236 \$37 \$937 65.7176a
Cext_11237 \$37 \$947 0.145978a
Cext_11238 \$37 \$948 0.404672a
Cext_11239 \$37 \$949 0.145978a
Cext_11240 \$37 \$962 65.5547a
Cext_11241 \$37 \$963 82.9075a
Cext_11242 \$37 \$964 65.5547a
Cext_11243 \$37 \$966 82.8783a
Cext_11244 \$37 \$984 59.1279a
Cext_11245 \$37 \$985 19.3729a
Cext_11246 \$37 \$986 59.1279a
Cext_11247 \$37 \$987 19.3729a
Cext_11248 \$37 \$997 82.9986a
Cext_11249 \$37 d2|dac_soft[2] 28.2212a
Cext_11250 \$37 d7|dac_soft[7] 6.69708a
Cext_11251 \$37 IOVDD|vdda 867.402a
Cext_11252 \$37 VDD|vdd 5.43972a
Cext_11253 \$37 VREF|vref 47.4125a
Cext_11254 \$37 VSS|vss 439.84a
Cext_11255 \$37 VSUBS 38.3067f
Cext_11256 \$370 \$371 114.006a
Cext_11257 \$370 \$372 0.182933a
Cext_11258 \$370 \$380 98.5952a
Cext_11259 \$370 \$397 0.360462a
Cext_11260 \$370 \$402 108.267a
Cext_11261 \$370 \$51 123.657a
Cext_11262 \$370 \$53 65.4666a
Cext_11263 \$370 \$57 0.62262a
Cext_11264 \$370 \$83 80.1821a
Cext_11265 \$370 \$85 70.7638a
Cext_11266 \$370 \$87 31.3588a
Cext_11267 \$370 \$89 36.0014a
Cext_11268 \$370 \$91 35.6349a
Cext_11269 \$370 \$93 45.7852a
Cext_11270 \$370 VSS|vss 0.378848a
Cext_11271 \$370 VSUBS 257.776a
Cext_11272 \$371 \$379 0.182933a
Cext_11273 \$371 \$397 254.864a
Cext_11274 \$371 \$402 0.360462a
Cext_11275 \$371 \$51 23.2117a
Cext_11276 \$371 \$53 0.145978a
Cext_11277 \$371 \$55 0.105966a
Cext_11278 \$371 \$57 0.282145a
Cext_11279 \$371 \$59 0.494517a
Cext_11280 \$371 \$61 20.7622a
Cext_11281 \$371 \$83 110.011a
Cext_11282 \$371 VSS|vss 75.4228a
Cext_11283 \$371 VSUBS 817.35a
Cext_11284 \$372 \$398 130.175a
Cext_11285 \$372 \$53 0.404672a
Cext_11286 \$372 \$57 0.115752a
Cext_11287 \$372 \$59 0.481837a
Cext_11288 \$372 \$61 20.9895a
Cext_11289 \$372 VSS|vss 2.2008a
Cext_11290 \$372 VSUBS 675.619a
Cext_11291 \$373 \$385 102.889a
Cext_11292 \$373 \$39 0.62262a
Cext_11293 \$373 \$407 0.360462a
Cext_11294 \$373 \$425 42.153a
Cext_11295 \$373 \$67 80.1249a
Cext_11296 \$373 \$69 70.7638a
Cext_11297 \$373 \$71 33.9629a
Cext_11298 \$373 \$73 32.5775a
Cext_11299 \$373 \$75 35.6349a
Cext_11300 \$373 \$77 45.8508a
Cext_11301 \$373 VSS|vss 0.335662a
Cext_11302 \$373 VSUBS 255.945a
Cext_11303 \$374 \$39 47.2301a
Cext_11304 \$374 \$399 227.572a
Cext_11305 \$374 \$409 3.25406a
Cext_11306 \$374 \$41 0.329802a
Cext_11307 \$374 \$410 0.179323a
Cext_11308 \$374 \$435 7.41179a
Cext_11309 \$374 \$67 2.30683a
Cext_11310 \$374 \$69 115.527a
Cext_11311 \$374 \$71 7.49159a
Cext_11312 \$374 \$73 3.82035a
Cext_11313 \$374 \$75 1.61371a
Cext_11314 \$374 \$77 1.13718a
Cext_11315 \$374 VSUBS 167.596a
Cext_11316 \$375 \$387 102.889a
Cext_11317 \$375 \$39 0.62262a
Cext_11318 \$375 \$410 0.360462a
Cext_11319 \$375 \$426 42.153a
Cext_11320 \$375 \$67 79.9778a
Cext_11321 \$375 \$69 70.7638a
Cext_11322 \$375 \$71 33.9629a
Cext_11323 \$375 \$73 32.5775a
Cext_11324 \$375 \$75 35.6349a
Cext_11325 \$375 \$77 45.8508a
Cext_11326 \$375 IOVDD|vdda 41.4143a
Cext_11327 \$375 VSS|vss 0.335662a
Cext_11328 \$375 VSUBS 255.671a
Cext_11329 \$376 \$39 47.2301a
Cext_11330 \$376 \$400 227.572a
Cext_11331 \$376 \$41 0.329802a
Cext_11332 \$376 \$412 3.25406a
Cext_11333 \$376 \$413 0.179323a
Cext_11334 \$376 \$438 7.41179a
Cext_11335 \$376 \$67 2.30683a
Cext_11336 \$376 \$69 115.527a
Cext_11337 \$376 \$71 7.49159a
Cext_11338 \$376 \$73 3.82035a
Cext_11339 \$376 \$75 1.61371a
Cext_11340 \$376 \$77 1.13718a
Cext_11341 \$376 VSUBS 167.596a
Cext_11342 \$377 \$394 102.889a
Cext_11343 \$377 \$418 0.360462a
Cext_11344 \$377 \$427 42.153a
Cext_11345 \$377 \$51 123.657a
Cext_11346 \$377 \$53 65.6459a
Cext_11347 \$377 \$55 0.62262a
Cext_11348 \$377 \$83 80.1249a
Cext_11349 \$377 \$85 70.7638a
Cext_11350 \$377 \$87 33.9629a
Cext_11351 \$377 \$89 32.5775a
Cext_11352 \$377 \$91 35.6349a
Cext_11353 \$377 \$93 45.8508a
Cext_11354 \$377 VSS|vss 0.335662a
Cext_11355 \$377 VSUBS 255.945a
Cext_11356 \$378 \$401 227.572a
Cext_11357 \$378 \$420 3.25406a
Cext_11358 \$378 \$421 0.179323a
Cext_11359 \$378 \$446 7.41179a
Cext_11360 \$378 \$51 0.592076a
Cext_11361 \$378 \$53 82.9986a
Cext_11362 \$378 \$55 47.2301a
Cext_11363 \$378 \$57 0.329802a
Cext_11364 \$378 \$83 2.30683a
Cext_11365 \$378 \$85 115.527a
Cext_11366 \$378 \$87 7.49159a
Cext_11367 \$378 \$89 3.82035a
Cext_11368 \$378 \$91 1.61371a
Cext_11369 \$378 \$93 1.13718a
Cext_11370 \$378 VSUBS 167.596a
Cext_11371 \$379 \$396 102.889a
Cext_11372 \$379 \$421 0.360462a
Cext_11373 \$379 \$428 42.153a
Cext_11374 \$379 \$51 123.51a
Cext_11375 \$379 \$53 65.6459a
Cext_11376 \$379 \$55 0.62262a
Cext_11377 \$379 \$83 79.9778a
Cext_11378 \$379 \$85 70.7638a
Cext_11379 \$379 \$87 33.9629a
Cext_11380 \$379 \$89 32.5775a
Cext_11381 \$379 \$91 35.6349a
Cext_11382 \$379 \$93 45.8508a
Cext_11383 \$379 IOVDD|vdda 41.4143a
Cext_11384 \$379 VSS|vss 3.20522a
Cext_11385 \$379 VSUBS 255.671a
Cext_11386 \$38 \$39 602.158a
Cext_11387 \$38 \$40 2.13277a
Cext_11388 \$38 \$47 0.110435a
Cext_11389 \$38 \$49 24.0132a
Cext_11390 \$38 \$69 29.0633a
Cext_11391 \$38 \$70 902.785a
Cext_11392 \$38 \$71 0.237316a
Cext_11393 \$38 \$81 0.127512a
Cext_11394 \$38 d2|dac_soft[2] 130.648a
Cext_11395 \$38 d7|dac_soft[7] 14.8234a
Cext_11396 \$38 IOVDD|vdda 173.852a
Cext_11397 \$38 VDD|vdd 10.4718a
Cext_11398 \$38 VSS|vss 446.394a
Cext_11399 \$38 VSUBS 1.50594f
Cext_11400 \$380 \$402 227.572a
Cext_11401 \$380 \$423 3.25406a
Cext_11402 \$380 \$424 0.179323a
Cext_11403 \$380 \$449 7.41179a
Cext_11404 \$380 \$51 0.592076a
Cext_11405 \$380 \$53 82.9986a
Cext_11406 \$380 \$55 47.2301a
Cext_11407 \$380 \$57 0.329802a
Cext_11408 \$380 \$83 2.30683a
Cext_11409 \$380 \$85 115.527a
Cext_11410 \$380 \$87 7.49159a
Cext_11411 \$380 \$89 3.82035a
Cext_11412 \$380 \$91 1.61371a
Cext_11413 \$380 \$93 1.13718a
Cext_11414 \$380 VSUBS 167.596a
Cext_11415 \$381 \$382 45.0654a
Cext_11416 \$381 \$403 130.175a
Cext_11417 \$381 VDD|vdd 7.74075a
Cext_11418 \$381 VSS|vss 1.71997a
Cext_11419 \$381 VSUBS 659.267a
Cext_11420 \$382 \$383 45.0654a
Cext_11421 \$382 \$404 130.175a
Cext_11422 \$382 VDD|vdd 0.968272a
Cext_11423 \$382 VSUBS 634.529a
Cext_11424 \$383 \$384 45.0654a
Cext_11425 \$383 \$405 130.175a
Cext_11426 \$383 VSUBS 634.529a
Cext_11427 \$384 \$385 46.4004a
Cext_11428 \$384 \$406 130.175a
Cext_11429 \$384 VSS|vss 0.378729a
Cext_11430 \$384 VSUBS 634.529a
Cext_11431 \$385 \$407 254.864a
Cext_11432 \$385 \$425 0.360462a
Cext_11433 \$385 \$67 64.1221a
Cext_11434 \$385 \$71 0.168339a
Cext_11435 \$385 \$77 0.107779a
Cext_11436 \$385 VSS|vss 66.2906a
Cext_11437 \$385 VSUBS 800.931a
Cext_11438 \$386 \$399 113.058a
Cext_11439 \$386 \$409 225.319a
Cext_11440 \$386 \$41 0.115752a
Cext_11441 \$386 \$43 0.481837a
Cext_11442 \$386 \$45 20.9928a
Cext_11443 \$386 \$67 58.9193a
Cext_11444 \$386 \$71 0.343978a
Cext_11445 \$386 VSS|vss 60.9228a
Cext_11446 \$386 VSUBS 810.856a
Cext_11447 \$387 \$39 0.105966a
Cext_11448 \$387 \$399 0.182933a
Cext_11449 \$387 \$41 0.282145a
Cext_11450 \$387 \$410 254.864a
Cext_11451 \$387 \$426 0.360462a
Cext_11452 \$387 \$43 0.494517a
Cext_11453 \$387 \$45 20.7622a
Cext_11454 \$387 \$67 64.1221a
Cext_11455 \$387 \$71 0.168339a
Cext_11456 \$387 \$77 0.107779a
Cext_11457 \$387 IOVDD|vdda 13.2807a
Cext_11458 \$387 VSS|vss 66.2132a
Cext_11459 \$387 VSUBS 818.653a
Cext_11460 \$388 \$400 113.058a
Cext_11461 \$388 \$41 0.115752a
Cext_11462 \$388 \$412 225.319a
Cext_11463 \$388 \$43 0.481837a
Cext_11464 \$388 \$45 20.9928a
Cext_11465 \$388 \$67 58.9193a
Cext_11466 \$388 \$71 0.343978a
Cext_11467 \$388 VSS|vss 60.9228a
Cext_11468 \$388 VSUBS 810.856a
Cext_11469 \$389 \$39 0.105966a
Cext_11470 \$389 \$400 0.182933a
Cext_11471 \$389 \$41 0.282145a
Cext_11472 \$389 \$413 130.175a
Cext_11473 \$389 \$43 0.494517a
Cext_11474 \$389 \$45 20.9126a
Cext_11475 \$389 VSS|vss 2.2008a
Cext_11476 \$389 VSUBS 676a
Cext_11477 \$39 \$399 1.32172a
Cext_11478 \$39 \$40 41.8224a
Cext_11479 \$39 \$400 1.32172a
Cext_11480 \$39 \$408 47.3198a
Cext_11481 \$39 \$409 0.251943a
Cext_11482 \$39 \$41 74.0909f
Cext_11483 \$39 \$410 0.500702a
Cext_11484 \$39 \$411 47.3198a
Cext_11485 \$39 \$412 0.251943a
Cext_11486 \$39 \$413 0.500702a
Cext_11487 \$39 \$425 1.40263a
Cext_11488 \$39 \$426 1.40263a
Cext_11489 \$39 \$43 357.758a
Cext_11490 \$39 \$435 1.18748a
Cext_11491 \$39 \$436 0.105966a
Cext_11492 \$39 \$438 1.18748a
Cext_11493 \$39 \$439 0.105966a
Cext_11494 \$39 \$45 213.866a
Cext_11495 \$39 \$451 0.62262a
Cext_11496 \$39 \$452 0.62262a
Cext_11497 \$39 \$460 0.105966a
Cext_11498 \$39 \$462 0.105966a
Cext_11499 \$39 \$47 32.2651a
Cext_11500 \$39 \$483 0.105966a
Cext_11501 \$39 \$485 0.105966a
Cext_11502 \$39 \$49 53.223a
Cext_11503 \$39 \$500 150.036a
Cext_11504 \$39 \$501 7.30318a
Cext_11505 \$39 \$503 0.105966a
Cext_11506 \$39 \$505 150.036a
Cext_11507 \$39 \$506 7.30318a
Cext_11508 \$39 \$508 0.105966a
Cext_11509 \$39 \$526 144.117a
Cext_11510 \$39 \$528 144.386a
Cext_11511 \$39 \$539 14.3029a
Cext_11512 \$39 \$540 0.105966a
Cext_11513 \$39 \$542 14.3029a
Cext_11514 \$39 \$543 0.105966a
Cext_11515 \$39 \$555 1.18748a
Cext_11516 \$39 \$557 1.18748a
Cext_11517 \$39 \$568 0.105966a
Cext_11518 \$39 \$570 0.105966a
Cext_11519 \$39 \$580 0.62262a
Cext_11520 \$39 \$581 47.3198a
Cext_11521 \$39 \$582 0.62262a
Cext_11522 \$39 \$583 47.3198a
Cext_11523 \$39 \$594 0.105966a
Cext_11524 \$39 \$606 56.2856a
Cext_11525 \$39 \$607 1.40263a
Cext_11526 \$39 \$608 56.2856a
Cext_11527 \$39 \$609 1.40263a
Cext_11528 \$39 \$619 47.2301a
Cext_11529 \$39 \$620 0.251943a
Cext_11530 \$39 \$621 0.500702a
Cext_11531 \$39 \$622 47.2301a
Cext_11532 \$39 \$623 0.251943a
Cext_11533 \$39 \$638 1.18572a
Cext_11534 \$39 \$641 1.18748a
Cext_11535 \$39 \$642 46.0291a
Cext_11536 \$39 \$643 1.18572a
Cext_11537 \$39 \$644 0.105966a
Cext_11538 \$39 \$646 46.0291a
Cext_11539 \$39 \$647 1.18748a
Cext_11540 \$39 \$662 0.62262a
Cext_11541 \$39 \$663 0.62262a
Cext_11542 \$39 \$67 92.0201a
Cext_11543 \$39 \$671 0.105966a
Cext_11544 \$39 \$673 0.105966a
Cext_11545 \$39 \$69 1.18746f
Cext_11546 \$39 \$690 0.105966a
Cext_11547 \$39 \$70 69.1586a
Cext_11548 \$39 \$71 19.6578f
Cext_11549 \$39 \$711 45.938a
Cext_11550 \$39 \$712 0.105966a
Cext_11551 \$39 \$714 45.938a
Cext_11552 \$39 \$715 0.105966a
Cext_11553 \$39 \$72 10.2105a
Cext_11554 \$39 \$73 16.3032f
Cext_11555 \$39 \$733 59.2756a
Cext_11556 \$39 \$735 0.105966a
Cext_11557 \$39 \$736 59.2756a
Cext_11558 \$39 \$749 1.18748a
Cext_11559 \$39 \$75 63.0815a
Cext_11560 \$39 \$751 1.18748a
Cext_11561 \$39 \$763 0.105966a
Cext_11562 \$39 \$765 0.105966a
Cext_11563 \$39 \$77 66.9619a
Cext_11564 \$39 \$779 0.62262a
Cext_11565 \$39 \$781 47.1389a
Cext_11566 \$39 \$782 0.105966a
Cext_11567 \$39 \$783 0.62262a
Cext_11568 \$39 \$785 47.1389a
Cext_11569 \$39 \$79 30.7374a
Cext_11570 \$39 \$798 1.18572a
Cext_11571 \$39 \$799 1.18572a
Cext_11572 \$39 \$807 47.4812a
Cext_11573 \$39 \$808 0.251943a
Cext_11574 \$39 \$809 0.500702a
Cext_11575 \$39 \$81 31.852a
Cext_11576 \$39 \$810 47.4812a
Cext_11577 \$39 \$811 0.251943a
Cext_11578 \$39 \$826 1.55928a
Cext_11579 \$39 \$828 1.18748a
Cext_11580 \$39 \$829 1.55928a
Cext_11581 \$39 \$830 0.105966a
Cext_11582 \$39 \$832 1.18748a
Cext_11583 \$39 \$846 0.62262a
Cext_11584 \$39 \$847 0.62262a
Cext_11585 \$39 \$855 0.105966a
Cext_11586 \$39 \$857 0.105966a
Cext_11587 \$39 \$875 0.105966a
Cext_11588 \$39 \$886 122.7a
Cext_11589 \$39 \$888 66.7447a
Cext_11590 \$39 \$899 0.105966a
Cext_11591 \$39 \$901 0.105966a
Cext_11592 \$39 \$917 94.3332a
Cext_11593 \$39 \$919 0.105966a
Cext_11594 \$39 \$921 28.0853a
Cext_11595 \$39 \$934 1.18748a
Cext_11596 \$39 \$936 1.18748a
Cext_11597 \$39 \$947 0.105966a
Cext_11598 \$39 \$949 0.105966a
Cext_11599 \$39 \$962 0.62262a
Cext_11600 \$39 \$963 47.4812a
Cext_11601 \$39 \$964 0.62262a
Cext_11602 \$39 \$965 0.105966a
Cext_11603 \$39 \$966 47.4812a
Cext_11604 \$39 \$984 59.2756a
Cext_11605 \$39 \$985 1.55928a
Cext_11606 \$39 \$986 59.2756a
Cext_11607 \$39 \$987 1.55928a
Cext_11608 \$39 \$997 47.1389a
Cext_11609 \$39 \$998 0.251943a
Cext_11610 \$39 \$999 0.500702a
Cext_11611 \$39 d3|dac_soft[3] 28.2212a
Cext_11612 \$39 d7|dac_soft[7] 6.69708a
Cext_11613 \$39 IOVDD|vdda 829.383a
Cext_11614 \$39 VDD|vdd 5.43972a
Cext_11615 \$39 VREF|vref 49.4261a
Cext_11616 \$39 VSS|vss 439.635a
Cext_11617 \$39 VSUBS 23.2523f
Cext_11618 \$390 \$391 45.0654a
Cext_11619 \$390 \$414 130.128a
Cext_11620 \$390 VDD|vdd 0.592094a
Cext_11621 \$390 VSS|vss 25.1792a
Cext_11622 \$390 VSUBS 659.267a
Cext_11623 \$391 \$392 45.0654a
Cext_11624 \$391 \$415 130.175a
Cext_11625 \$391 VSS|vss 5.452a
Cext_11626 \$391 VSUBS 634.529a
Cext_11627 \$392 \$393 45.0654a
Cext_11628 \$392 \$416 130.175a
Cext_11629 \$392 VSUBS 634.529a
Cext_11630 \$393 \$394 46.4004a
Cext_11631 \$393 \$417 130.175a
Cext_11632 \$393 VSS|vss 0.378729a
Cext_11633 \$393 VSUBS 634.529a
Cext_11634 \$394 \$418 254.864a
Cext_11635 \$394 \$427 0.360462a
Cext_11636 \$394 \$51 69.0342a
Cext_11637 \$394 \$83 64.1221a
Cext_11638 \$394 \$87 0.168339a
Cext_11639 \$394 \$93 0.107779a
Cext_11640 \$394 VSS|vss 66.2906a
Cext_11641 \$394 VSUBS 800.931a
Cext_11642 \$395 \$401 113.058a
Cext_11643 \$395 \$420 225.319a
Cext_11644 \$395 \$51 68.7272a
Cext_11645 \$395 \$57 0.115752a
Cext_11646 \$395 \$59 0.481837a
Cext_11647 \$395 \$61 20.9928a
Cext_11648 \$395 \$83 58.9193a
Cext_11649 \$395 \$87 0.343978a
Cext_11650 \$395 VSS|vss 60.9228a
Cext_11651 \$395 VSUBS 810.856a
Cext_11652 \$396 \$401 0.182933a
Cext_11653 \$396 \$421 254.864a
Cext_11654 \$396 \$428 0.360462a
Cext_11655 \$396 \$51 69.0342a
Cext_11656 \$396 \$55 0.105966a
Cext_11657 \$396 \$57 0.282145a
Cext_11658 \$396 \$59 0.494517a
Cext_11659 \$396 \$61 20.7622a
Cext_11660 \$396 \$83 64.1221a
Cext_11661 \$396 \$87 0.168339a
Cext_11662 \$396 \$93 0.107779a
Cext_11663 \$396 IOVDD|vdda 13.2807a
Cext_11664 \$396 VSS|vss 66.2132a
Cext_11665 \$396 VSUBS 818.653a
Cext_11666 \$397 \$402 113.058a
Cext_11667 \$397 \$423 225.319a
Cext_11668 \$397 \$51 68.7272a
Cext_11669 \$397 \$57 0.115752a
Cext_11670 \$397 \$59 0.481837a
Cext_11671 \$397 \$61 20.9928a
Cext_11672 \$397 \$83 58.9193a
Cext_11673 \$397 \$87 0.343978a
Cext_11674 \$397 VSS|vss 69.9251a
Cext_11675 \$397 VSUBS 810.856a
Cext_11676 \$398 \$402 0.182933a
Cext_11677 \$398 \$424 130.175a
Cext_11678 \$398 \$55 0.105966a
Cext_11679 \$398 \$57 0.282145a
Cext_11680 \$398 \$59 0.494517a
Cext_11681 \$398 \$61 20.9126a
Cext_11682 \$398 VSS|vss 2.2008a
Cext_11683 \$398 VSUBS 676a
Cext_11684 \$399 \$409 102.889a
Cext_11685 \$399 \$434 0.360462a
Cext_11686 \$399 \$451 42.153a
Cext_11687 \$399 \$67 69.937a
Cext_11688 \$399 \$69 117.46a
Cext_11689 \$399 \$71 32.765a
Cext_11690 \$399 \$73 32.5775a
Cext_11691 \$399 \$75 35.6349a
Cext_11692 \$399 \$77 45.8508a
Cext_11693 \$399 VSS|vss 0.335662a
Cext_11694 \$399 VSUBS 255.562a
Cext_11695 \$40 \$41 618.43a
Cext_11696 \$40 \$42 2.13277a
Cext_11697 \$40 \$49 23.8673a
Cext_11698 \$40 \$71 29.0633a
Cext_11699 \$40 \$72 902.785a
Cext_11700 \$40 \$73 0.237316a
Cext_11701 \$40 d3|dac_soft[3] 130.648a
Cext_11702 \$40 d7|dac_soft[7] 14.8234a
Cext_11703 \$40 IOVDD|vdda 173.439a
Cext_11704 \$40 VDD|vdd 10.4718a
Cext_11705 \$40 VSS|vss 446.383a
Cext_11706 \$40 VSUBS 1.50222f
Cext_11707 \$400 \$412 102.889a
Cext_11708 \$400 \$437 0.360462a
Cext_11709 \$400 \$452 42.153a
Cext_11710 \$400 \$67 69.937a
Cext_11711 \$400 \$69 117.46a
Cext_11712 \$400 \$71 32.765a
Cext_11713 \$400 \$73 32.5775a
Cext_11714 \$400 \$75 35.6349a
Cext_11715 \$400 \$77 45.8508a
Cext_11716 \$400 VSS|vss 0.335662a
Cext_11717 \$400 VSUBS 255.562a
Cext_11718 \$401 \$420 102.889a
Cext_11719 \$401 \$445 0.360462a
Cext_11720 \$401 \$453 42.153a
Cext_11721 \$401 \$51 134.708a
Cext_11722 \$401 \$53 19.3729a
Cext_11723 \$401 \$55 1.32172a
Cext_11724 \$401 \$83 69.937a
Cext_11725 \$401 \$85 117.46a
Cext_11726 \$401 \$87 32.765a
Cext_11727 \$401 \$89 32.5775a
Cext_11728 \$401 \$91 35.6349a
Cext_11729 \$401 \$93 45.8508a
Cext_11730 \$401 VSS|vss 0.335662a
Cext_11731 \$401 VSUBS 255.562a
Cext_11732 \$402 \$423 102.889a
Cext_11733 \$402 \$448 0.360462a
Cext_11734 \$402 \$454 42.153a
Cext_11735 \$402 \$51 134.708a
Cext_11736 \$402 \$53 19.3729a
Cext_11737 \$402 \$55 1.32172a
Cext_11738 \$402 \$83 69.937a
Cext_11739 \$402 \$85 117.46a
Cext_11740 \$402 \$87 32.765a
Cext_11741 \$402 \$89 32.5775a
Cext_11742 \$402 \$91 35.6349a
Cext_11743 \$402 \$93 45.8508a
Cext_11744 \$402 VSS|vss 0.335662a
Cext_11745 \$402 VSUBS 255.562a
Cext_11746 \$403 \$404 45.0654a
Cext_11747 \$403 \$429 130.175a
Cext_11748 \$403 VDD|vdd 7.74075a
Cext_11749 \$403 VSS|vss 1.71997a
Cext_11750 \$403 VSUBS 659.267a
Cext_11751 \$404 \$405 45.0654a
Cext_11752 \$404 \$430 130.175a
Cext_11753 \$404 VDD|vdd 0.968272a
Cext_11754 \$404 VSUBS 634.529a
Cext_11755 \$405 \$406 45.0654a
Cext_11756 \$405 \$431 130.175a
Cext_11757 \$405 VSUBS 634.529a
Cext_11758 \$406 \$407 45.8951a
Cext_11759 \$406 \$432 130.175a
Cext_11760 \$406 VSS|vss 0.428128a
Cext_11761 \$406 VSUBS 634.529a
Cext_11762 \$407 \$408 2.46853a
Cext_11763 \$407 \$425 102.889a
Cext_11764 \$407 \$433 225.319a
Cext_11765 \$407 \$67 105.489a
Cext_11766 \$407 VSS|vss 61.1015a
Cext_11767 \$407 VSUBS 793.935a
Cext_11768 \$408 \$409 0.179323a
Cext_11769 \$408 \$425 230.002a
Cext_11770 \$408 \$43 0.329802a
Cext_11771 \$408 \$473 98.5952a
Cext_11772 \$408 \$555 1.46644a
Cext_11773 \$408 \$67 2.30683a
Cext_11774 \$408 \$69 118.502a
Cext_11775 \$408 \$71 7.5941a
Cext_11776 \$408 \$73 3.34353a
Cext_11777 \$408 \$75 1.9986a
Cext_11778 \$408 \$77 1.0724a
Cext_11779 \$408 VSUBS 177.197a
Cext_11780 \$409 \$41 0.282145a
Cext_11781 \$409 \$43 0.494517a
Cext_11782 \$409 \$434 254.864a
Cext_11783 \$409 \$45 20.9159a
Cext_11784 \$409 \$451 0.360462a
Cext_11785 \$409 \$67 110.011a
Cext_11786 \$409 \$77 0.107779a
Cext_11787 \$409 VSS|vss 66.2132a
Cext_11788 \$409 VSUBS 818.553a
Cext_11789 \$41 \$410 0.115752a
Cext_11790 \$41 \$412 0.282145a
Cext_11791 \$41 \$413 0.115752a
Cext_11792 \$41 \$42 41.8224a
Cext_11793 \$41 \$43 74.3958f
Cext_11794 \$41 \$434 0.115752a
Cext_11795 \$41 \$436 0.282145a
Cext_11796 \$41 \$437 0.115752a
Cext_11797 \$41 \$439 0.282145a
Cext_11798 \$41 \$45 217.383a
Cext_11799 \$41 \$460 0.282145a
Cext_11800 \$41 \$461 0.115752a
Cext_11801 \$41 \$462 0.282145a
Cext_11802 \$41 \$463 0.115752a
Cext_11803 \$41 \$47 35.1546a
Cext_11804 \$41 \$482 0.115752a
Cext_11805 \$41 \$483 0.282145a
Cext_11806 \$41 \$484 0.115752a
Cext_11807 \$41 \$485 0.282145a
Cext_11808 \$41 \$49 70.1227a
Cext_11809 \$41 \$500 84.9076a
Cext_11810 \$41 \$501 46.0291a
Cext_11811 \$41 \$503 0.282145a
Cext_11812 \$41 \$504 0.115752a
Cext_11813 \$41 \$505 84.9076a
Cext_11814 \$41 \$506 46.0291a
Cext_11815 \$41 \$508 0.282145a
Cext_11816 \$41 \$509 0.115752a
Cext_11817 \$41 \$526 76.2695a
Cext_11818 \$41 \$528 77.0051a
Cext_11819 \$41 \$538 0.115752a
Cext_11820 \$41 \$539 58.4605a
Cext_11821 \$41 \$540 0.282145a
Cext_11822 \$41 \$541 0.115752a
Cext_11823 \$41 \$542 58.4605a
Cext_11824 \$41 \$543 0.282145a
Cext_11825 \$41 \$568 0.282145a
Cext_11826 \$41 \$569 0.115752a
Cext_11827 \$41 \$570 0.282145a
Cext_11828 \$41 \$571 0.115752a
Cext_11829 \$41 \$593 0.115752a
Cext_11830 \$41 \$594 0.282145a
Cext_11831 \$41 \$595 0.115752a
Cext_11832 \$41 \$606 1.18748a
Cext_11833 \$41 \$608 1.18748a
Cext_11834 \$41 \$619 0.329802a
Cext_11835 \$41 \$620 0.282145a
Cext_11836 \$41 \$621 0.115752a
Cext_11837 \$41 \$622 0.329802a
Cext_11838 \$41 \$623 0.282145a
Cext_11839 \$41 \$640 0.115752a
Cext_11840 \$41 \$641 0.476813a
Cext_11841 \$41 \$642 47.4094a
Cext_11842 \$41 \$644 0.282145a
Cext_11843 \$41 \$645 0.115752a
Cext_11844 \$41 \$646 47.4094a
Cext_11845 \$41 \$647 0.476813a
Cext_11846 \$41 \$67 82.7723a
Cext_11847 \$41 \$671 0.282145a
Cext_11848 \$41 \$672 0.115752a
Cext_11849 \$41 \$673 0.282145a
Cext_11850 \$41 \$686 0.62262a
Cext_11851 \$41 \$688 0.115752a
Cext_11852 \$41 \$689 0.62262a
Cext_11853 \$41 \$69 567.892a
Cext_11854 \$41 \$690 0.282145a
Cext_11855 \$41 \$691 0.115752a
Cext_11856 \$41 \$702 1.18572a
Cext_11857 \$41 \$703 1.18572a
Cext_11858 \$41 \$71 199.749a
Cext_11859 \$41 \$711 47.4094a
Cext_11860 \$41 \$712 0.428122a
Cext_11861 \$41 \$713 0.772242a
Cext_11862 \$41 \$714 47.4094a
Cext_11863 \$41 \$715 0.428122a
Cext_11864 \$41 \$72 71.3084a
Cext_11865 \$41 \$73 18.2102f
Cext_11866 \$41 \$731 1.41124a
Cext_11867 \$41 \$732 0.115752a
Cext_11868 \$41 \$733 1.18748a
Cext_11869 \$41 \$734 1.41124a
Cext_11870 \$41 \$735 0.282145a
Cext_11871 \$41 \$736 1.18748a
Cext_11872 \$41 \$74 10.2105a
Cext_11873 \$41 \$749 0.476813a
Cext_11874 \$41 \$75 16.296f
Cext_11875 \$41 \$750 0.62262a
Cext_11876 \$41 \$751 0.476813a
Cext_11877 \$41 \$752 0.115752a
Cext_11878 \$41 \$753 0.62262a
Cext_11879 \$41 \$763 0.282145a
Cext_11880 \$41 \$764 0.115752a
Cext_11881 \$41 \$765 0.282145a
Cext_11882 \$41 \$77 110.405a
Cext_11883 \$41 \$780 0.115752a
Cext_11884 \$41 \$781 0.329802a
Cext_11885 \$41 \$782 0.282145a
Cext_11886 \$41 \$784 0.115752a
Cext_11887 \$41 \$785 0.329802a
Cext_11888 \$41 \$79 34.7189a
Cext_11889 \$41 \$808 0.282145a
Cext_11890 \$41 \$809 0.115752a
Cext_11891 \$41 \$81 37.1134a
Cext_11892 \$41 \$811 0.282145a
Cext_11893 \$41 \$827 0.115752a
Cext_11894 \$41 \$830 0.282145a
Cext_11895 \$41 \$831 0.115752a
Cext_11896 \$41 \$855 0.282145a
Cext_11897 \$41 \$856 0.115752a
Cext_11898 \$41 \$857 0.282145a
Cext_11899 \$41 \$874 0.115752a
Cext_11900 \$41 \$875 0.282145a
Cext_11901 \$41 \$876 0.115752a
Cext_11902 \$41 \$886 129.534a
Cext_11903 \$41 \$888 52.0892a
Cext_11904 \$41 \$899 0.282145a
Cext_11905 \$41 \$900 0.115752a
Cext_11906 \$41 \$901 0.282145a
Cext_11907 \$41 \$916 0.115752a
Cext_11908 \$41 \$917 70.8019a
Cext_11909 \$41 \$919 0.282145a
Cext_11910 \$41 \$920 0.115752a
Cext_11911 \$41 \$921 24.7244a
Cext_11912 \$41 \$947 0.282145a
Cext_11913 \$41 \$948 0.115752a
Cext_11914 \$41 \$949 0.282145a
Cext_11915 \$41 \$965 0.282145a
Cext_11916 \$41 \$980 0.115752a
Cext_11917 \$41 \$981 0.115752a
Cext_11918 \$41 \$984 1.18748a
Cext_11919 \$41 \$986 1.18748a
Cext_11920 \$41 \$997 0.329802a
Cext_11921 \$41 \$998 0.282145a
Cext_11922 \$41 \$999 0.115752a
Cext_11923 \$41 d4|dac_soft[4] 28.2212a
Cext_11924 \$41 d7|dac_soft[7] 6.69708a
Cext_11925 \$41 IOVDD|vdda 871.115a
Cext_11926 \$41 VDD|vdd 5.43972a
Cext_11927 \$41 VREF|vref 67.873a
Cext_11928 \$41 VSS|vss 439.635a
Cext_11929 \$41 VSUBS 18.5368f
Cext_11930 \$410 \$411 2.46853a
Cext_11931 \$410 \$426 102.889a
Cext_11932 \$410 \$43 0.481837a
Cext_11933 \$410 \$436 225.319a
Cext_11934 \$410 \$45 20.9928a
Cext_11935 \$410 \$67 105.489a
Cext_11936 \$410 IOVDD|vdda 11.6291a
Cext_11937 \$410 VSS|vss 60.9228a
Cext_11938 \$410 VSUBS 810.925a
Cext_11939 \$411 \$412 0.179323a
Cext_11940 \$411 \$426 230.002a
Cext_11941 \$411 \$43 0.329802a
Cext_11942 \$411 \$474 98.5952a
Cext_11943 \$411 \$557 1.46644a
Cext_11944 \$411 \$67 2.30683a
Cext_11945 \$411 \$69 118.502a
Cext_11946 \$411 \$71 7.5941a
Cext_11947 \$411 \$73 3.34353a
Cext_11948 \$411 \$75 1.9986a
Cext_11949 \$411 \$77 1.0724a
Cext_11950 \$411 IOVDD|vdda 5.40532a
Cext_11951 \$411 VSUBS 177.197a
Cext_11952 \$412 \$43 0.494517a
Cext_11953 \$412 \$437 254.864a
Cext_11954 \$412 \$45 20.9159a
Cext_11955 \$412 \$452 0.360462a
Cext_11956 \$412 \$67 110.011a
Cext_11957 \$412 \$77 0.107779a
Cext_11958 \$412 VSS|vss 66.2132a
Cext_11959 \$412 VSUBS 818.553a
Cext_11960 \$413 \$43 0.481837a
Cext_11961 \$413 \$439 130.175a
Cext_11962 \$413 \$45 21.1432a
Cext_11963 \$413 VSS|vss 2.2008a
Cext_11964 \$413 VSUBS 675.49a
Cext_11965 \$414 \$415 45.0654a
Cext_11966 \$414 \$440 130.128a
Cext_11967 \$414 VDD|vdd 0.592094a
Cext_11968 \$414 VSS|vss 25.1792a
Cext_11969 \$414 VSUBS 659.267a
Cext_11970 \$415 \$416 45.0654a
Cext_11971 \$415 \$441 130.175a
Cext_11972 \$415 VSS|vss 5.452a
Cext_11973 \$415 VSUBS 634.529a
Cext_11974 \$416 \$417 45.0654a
Cext_11975 \$416 \$442 130.175a
Cext_11976 \$416 VSUBS 634.529a
Cext_11977 \$417 \$418 45.8951a
Cext_11978 \$417 \$443 130.175a
Cext_11979 \$417 VSS|vss 0.428128a
Cext_11980 \$417 VSUBS 634.529a
Cext_11981 \$418 \$419 2.46853a
Cext_11982 \$418 \$427 102.889a
Cext_11983 \$418 \$444 225.319a
Cext_11984 \$418 \$51 22.8071a
Cext_11985 \$418 \$83 105.489a
Cext_11986 \$418 VSS|vss 61.1015a
Cext_11987 \$418 VSUBS 793.935a
Cext_11988 \$419 \$420 0.179323a
Cext_11989 \$419 \$427 230.002a
Cext_11990 \$419 \$475 98.5952a
Cext_11991 \$419 \$51 0.496172a
Cext_11992 \$419 \$53 82.9986a
Cext_11993 \$419 \$55 47.3198a
Cext_11994 \$419 \$559 1.46644a
Cext_11995 \$419 \$59 0.329802a
Cext_11996 \$419 \$83 2.30683a
Cext_11997 \$419 \$85 118.502a
Cext_11998 \$419 \$87 7.5941a
Cext_11999 \$419 \$89 3.34353a
Cext_12000 \$419 \$91 1.9986a
Cext_12001 \$419 \$93 1.0724a
Cext_12002 \$419 VSUBS 177.197a
Cext_12003 \$42 \$43 602.158a
Cext_12004 \$42 \$44 2.13277a
Cext_12005 \$42 \$47 0.110435a
Cext_12006 \$42 \$49 24.0132a
Cext_12007 \$42 \$73 29.0633a
Cext_12008 \$42 \$74 902.785a
Cext_12009 \$42 \$75 0.237316a
Cext_12010 \$42 \$81 0.127512a
Cext_12011 \$42 d4|dac_soft[4] 130.648a
Cext_12012 \$42 d7|dac_soft[7] 14.8234a
Cext_12013 \$42 IOVDD|vdda 173.852a
Cext_12014 \$42 VDD|vdd 10.4718a
Cext_12015 \$42 VSS|vss 446.394a
Cext_12016 \$42 VSUBS 1.50594f
Cext_12017 \$420 \$445 254.864a
Cext_12018 \$420 \$453 0.360462a
Cext_12019 \$420 \$51 23.4429a
Cext_12020 \$420 \$55 0.251943a
Cext_12021 \$420 \$57 0.282145a
Cext_12022 \$420 \$59 0.494517a
Cext_12023 \$420 \$61 20.9159a
Cext_12024 \$420 \$83 110.011a
Cext_12025 \$420 \$93 0.107779a
Cext_12026 \$420 VSS|vss 66.2132a
Cext_12027 \$420 VSUBS 818.553a
Cext_12028 \$421 \$422 2.46853a
Cext_12029 \$421 \$428 102.889a
Cext_12030 \$421 \$447 225.319a
Cext_12031 \$421 \$51 22.8071a
Cext_12032 \$421 \$55 0.500702a
Cext_12033 \$421 \$57 0.115752a
Cext_12034 \$421 \$59 0.481837a
Cext_12035 \$421 \$61 20.9928a
Cext_12036 \$421 \$83 105.489a
Cext_12037 \$421 IOVDD|vdda 11.6291a
Cext_12038 \$421 VSS|vss 60.9228a
Cext_12039 \$421 VSUBS 810.925a
Cext_12040 \$422 \$423 0.179323a
Cext_12041 \$422 \$428 230.002a
Cext_12042 \$422 \$476 98.5952a
Cext_12043 \$422 \$51 0.496172a
Cext_12044 \$422 \$53 82.9986a
Cext_12045 \$422 \$55 47.3198a
Cext_12046 \$422 \$561 1.46644a
Cext_12047 \$422 \$59 0.329802a
Cext_12048 \$422 \$83 2.30683a
Cext_12049 \$422 \$85 118.502a
Cext_12050 \$422 \$87 7.5941a
Cext_12051 \$422 \$89 3.34353a
Cext_12052 \$422 \$91 1.9986a
Cext_12053 \$422 \$93 1.0724a
Cext_12054 \$422 IOVDD|vdda 5.40532a
Cext_12055 \$422 VSS|vss 6.21589a
Cext_12056 \$422 VSUBS 177.197a
Cext_12057 \$423 \$448 254.864a
Cext_12058 \$423 \$454 0.360462a
Cext_12059 \$423 \$51 23.4429a
Cext_12060 \$423 \$55 0.251943a
Cext_12061 \$423 \$57 0.282145a
Cext_12062 \$423 \$59 0.494517a
Cext_12063 \$423 \$61 20.9159a
Cext_12064 \$423 \$83 110.011a
Cext_12065 \$423 \$93 0.107779a
Cext_12066 \$423 VSS|vss 75.4228a
Cext_12067 \$423 VSUBS 818.553a
Cext_12068 \$424 \$450 130.175a
Cext_12069 \$424 \$55 0.500702a
Cext_12070 \$424 \$57 0.115752a
Cext_12071 \$424 \$59 0.481837a
Cext_12072 \$424 \$61 21.1432a
Cext_12073 \$424 VSS|vss 2.2008a
Cext_12074 \$424 VSUBS 675.49a
Cext_12075 \$425 \$433 114.006a
Cext_12076 \$425 \$434 0.182933a
Cext_12077 \$425 \$459 0.360462a
Cext_12078 \$425 \$473 108.267a
Cext_12079 \$425 \$67 69.9941a
Cext_12080 \$425 \$69 117.46a
Cext_12081 \$425 \$71 32.765a
Cext_12082 \$425 \$73 32.5775a
Cext_12083 \$425 \$75 35.6349a
Cext_12084 \$425 \$77 45.7852a
Cext_12085 \$425 VSS|vss 0.378848a
Cext_12086 \$425 VSUBS 255.577a
Cext_12087 \$426 \$436 114.006a
Cext_12088 \$426 \$437 0.182933a
Cext_12089 \$426 \$461 0.360462a
Cext_12090 \$426 \$474 108.267a
Cext_12091 \$426 \$67 69.8469a
Cext_12092 \$426 \$69 117.46a
Cext_12093 \$426 \$71 32.765a
Cext_12094 \$426 \$73 32.5775a
Cext_12095 \$426 \$75 35.6349a
Cext_12096 \$426 \$77 45.7852a
Cext_12097 \$426 IOVDD|vdda 41.5102a
Cext_12098 \$426 VSS|vss 0.378848a
Cext_12099 \$426 VSUBS 255.303a
Cext_12100 \$427 \$444 114.006a
Cext_12101 \$427 \$445 0.182933a
Cext_12102 \$427 \$468 0.360462a
Cext_12103 \$427 \$475 108.267a
Cext_12104 \$427 \$51 134.708a
Cext_12105 \$427 \$53 19.3729a
Cext_12106 \$427 \$55 1.40263a
Cext_12107 \$427 \$83 69.9941a
Cext_12108 \$427 \$85 117.46a
Cext_12109 \$427 \$87 32.765a
Cext_12110 \$427 \$89 32.5775a
Cext_12111 \$427 \$91 35.6349a
Cext_12112 \$427 \$93 45.7852a
Cext_12113 \$427 VSS|vss 0.378848a
Cext_12114 \$427 VSUBS 255.577a
Cext_12115 \$428 \$447 114.006a
Cext_12116 \$428 \$448 0.182933a
Cext_12117 \$428 \$470 0.360462a
Cext_12118 \$428 \$476 108.267a
Cext_12119 \$428 \$51 134.561a
Cext_12120 \$428 \$53 19.3729a
Cext_12121 \$428 \$55 1.40263a
Cext_12122 \$428 \$83 69.8469a
Cext_12123 \$428 \$85 117.46a
Cext_12124 \$428 \$87 32.765a
Cext_12125 \$428 \$89 32.5775a
Cext_12126 \$428 \$91 35.6349a
Cext_12127 \$428 \$93 45.7852a
Cext_12128 \$428 IOVDD|vdda 41.5102a
Cext_12129 \$428 VSS|vss 3.82947a
Cext_12130 \$428 VSUBS 255.303a
Cext_12131 \$429 \$430 45.0654a
Cext_12132 \$429 \$455 130.175a
Cext_12133 \$429 VDD|vdd 7.74075a
Cext_12134 \$429 VSS|vss 1.71997a
Cext_12135 \$429 VSUBS 659.267a
Cext_12136 \$43 \$434 0.481837a
Cext_12137 \$43 \$435 0.476813a
Cext_12138 \$43 \$436 0.494517a
Cext_12139 \$43 \$437 0.481837a
Cext_12140 \$43 \$438 0.476813a
Cext_12141 \$43 \$439 0.494517a
Cext_12142 \$43 \$44 41.8224a
Cext_12143 \$43 \$45 74.9121f
Cext_12144 \$43 \$460 0.494517a
Cext_12145 \$43 \$461 0.481837a
Cext_12146 \$43 \$462 0.494517a
Cext_12147 \$43 \$463 0.481837a
Cext_12148 \$43 \$47 34.1898a
Cext_12149 \$43 \$473 0.62262a
Cext_12150 \$43 \$474 0.62262a
Cext_12151 \$43 \$482 0.481837a
Cext_12152 \$43 \$483 0.494517a
Cext_12153 \$43 \$484 0.481837a
Cext_12154 \$43 \$485 0.494517a
Cext_12155 \$43 \$49 54.5069a
Cext_12156 \$43 \$500 105.656a
Cext_12157 \$43 \$501 47.2301a
Cext_12158 \$43 \$502 1.32172a
Cext_12159 \$43 \$503 0.640494a
Cext_12160 \$43 \$504 1.32073a
Cext_12161 \$43 \$505 105.656a
Cext_12162 \$43 \$506 47.2301a
Cext_12163 \$43 \$507 1.32172a
Cext_12164 \$43 \$508 0.640494a
Cext_12165 \$43 \$509 1.32073a
Cext_12166 \$43 \$525 1.18572a
Cext_12167 \$43 \$526 87.5622a
Cext_12168 \$43 \$527 1.18572a
Cext_12169 \$43 \$528 88.0101a
Cext_12170 \$43 \$538 0.481837a
Cext_12171 \$43 \$539 1.18748a
Cext_12172 \$43 \$540 0.494517a
Cext_12173 \$43 \$541 0.481837a
Cext_12174 \$43 \$542 1.18748a
Cext_12175 \$43 \$543 0.494517a
Cext_12176 \$43 \$555 0.476813a
Cext_12177 \$43 \$556 0.62262a
Cext_12178 \$43 \$557 0.476813a
Cext_12179 \$43 \$558 0.62262a
Cext_12180 \$43 \$568 0.494517a
Cext_12181 \$43 \$569 0.481837a
Cext_12182 \$43 \$570 0.494517a
Cext_12183 \$43 \$571 0.481837a
Cext_12184 \$43 \$581 0.329802a
Cext_12185 \$43 \$583 0.329802a
Cext_12186 \$43 \$593 0.481837a
Cext_12187 \$43 \$594 0.494517a
Cext_12188 \$43 \$595 0.481837a
Cext_12189 \$43 \$606 0.13075a
Cext_12190 \$43 \$608 0.13075a
Cext_12191 \$43 \$620 0.494517a
Cext_12192 \$43 \$621 0.481837a
Cext_12193 \$43 \$623 0.494517a
Cext_12194 \$43 \$640 0.481837a
Cext_12195 \$43 \$642 0.104586a
Cext_12196 \$43 \$644 0.494517a
Cext_12197 \$43 \$645 0.481837a
Cext_12198 \$43 \$646 0.104586a
Cext_12199 \$43 \$67 78.0199a
Cext_12200 \$43 \$671 0.494517a
Cext_12201 \$43 \$672 0.481837a
Cext_12202 \$43 \$673 0.494517a
Cext_12203 \$43 \$688 0.481837a
Cext_12204 \$43 \$69 303.212a
Cext_12205 \$43 \$690 0.494517a
Cext_12206 \$43 \$691 0.481837a
Cext_12207 \$43 \$71 58.8468a
Cext_12208 \$43 \$712 0.494517a
Cext_12209 \$43 \$713 0.481837a
Cext_12210 \$43 \$715 0.494517a
Cext_12211 \$43 \$73 128.789a
Cext_12212 \$43 \$732 0.481837a
Cext_12213 \$43 \$735 0.494517a
Cext_12214 \$43 \$74 69.1586a
Cext_12215 \$43 \$75 17.6611f
Cext_12216 \$43 \$752 0.481837a
Cext_12217 \$43 \$76 10.2105a
Cext_12218 \$43 \$763 0.494517a
Cext_12219 \$43 \$764 0.481837a
Cext_12220 \$43 \$765 0.494517a
Cext_12221 \$43 \$77 16.2804f
Cext_12222 \$43 \$780 0.481837a
Cext_12223 \$43 \$782 0.494517a
Cext_12224 \$43 \$784 0.481837a
Cext_12225 \$43 \$79 34.4904a
Cext_12226 \$43 \$808 0.494517a
Cext_12227 \$43 \$809 0.481837a
Cext_12228 \$43 \$81 33.6191a
Cext_12229 \$43 \$811 0.494517a
Cext_12230 \$43 \$827 0.481837a
Cext_12231 \$43 \$830 0.494517a
Cext_12232 \$43 \$831 0.481837a
Cext_12233 \$43 \$855 0.494517a
Cext_12234 \$43 \$856 0.481837a
Cext_12235 \$43 \$857 0.494517a
Cext_12236 \$43 \$874 0.481837a
Cext_12237 \$43 \$875 0.494517a
Cext_12238 \$43 \$876 0.481837a
Cext_12239 \$43 \$886 95.519a
Cext_12240 \$43 \$888 48.5172a
Cext_12241 \$43 \$899 0.494517a
Cext_12242 \$43 \$900 0.367718a
Cext_12243 \$43 \$901 0.494517a
Cext_12244 \$43 \$916 0.481837a
Cext_12245 \$43 \$917 65.5646a
Cext_12246 \$43 \$919 0.494517a
Cext_12247 \$43 \$920 0.481837a
Cext_12248 \$43 \$921 22.7237a
Cext_12249 \$43 \$947 0.494517a
Cext_12250 \$43 \$948 0.481837a
Cext_12251 \$43 \$949 0.494517a
Cext_12252 \$43 \$965 0.494517a
Cext_12253 \$43 \$980 0.481837a
Cext_12254 \$43 \$981 0.481837a
Cext_12255 \$43 \$998 0.494517a
Cext_12256 \$43 \$999 0.481837a
Cext_12257 \$43 d5|dac_soft[5] 28.2212a
Cext_12258 \$43 d7|dac_soft[7] 6.69708a
Cext_12259 \$43 IOVDD|vdda 803.852a
Cext_12260 \$43 VDD|vdd 5.43972a
Cext_12261 \$43 VREF|vref 105.154a
Cext_12262 \$43 VSS|vss 439.635a
Cext_12263 \$43 VSUBS 15.4497f
Cext_12264 \$430 \$431 45.0654a
Cext_12265 \$430 \$456 130.175a
Cext_12266 \$430 VDD|vdd 0.968272a
Cext_12267 \$430 VSUBS 634.529a
Cext_12268 \$431 \$432 45.0654a
Cext_12269 \$431 \$457 130.175a
Cext_12270 \$431 VSUBS 634.529a
Cext_12271 \$432 \$433 46.4004a
Cext_12272 \$432 \$458 130.175a
Cext_12273 \$432 VSS|vss 0.378729a
Cext_12274 \$432 VSUBS 634.529a
Cext_12275 \$433 \$459 254.864a
Cext_12276 \$433 \$473 0.360462a
Cext_12277 \$433 \$67 64.1221a
Cext_12278 \$433 \$69 0.155901a
Cext_12279 \$433 VSS|vss 66.2906a
Cext_12280 \$433 VSUBS 799.746a
Cext_12281 \$434 \$435 2.46853a
Cext_12282 \$434 \$45 20.8391a
Cext_12283 \$434 \$451 102.889a
Cext_12284 \$434 \$460 225.319a
Cext_12285 \$434 \$67 58.9193a
Cext_12286 \$434 \$69 0.343978a
Cext_12287 \$434 VSS|vss 60.9228a
Cext_12288 \$434 VSUBS 811.534a
Cext_12289 \$435 \$436 0.179323a
Cext_12290 \$435 \$451 230.002a
Cext_12291 \$435 \$502 98.5952a
Cext_12292 \$435 \$581 1.46644a
Cext_12293 \$435 \$69 106.511a
Cext_12294 \$435 \$71 53.7264a
Cext_12295 \$435 \$73 3.34353a
Cext_12296 \$435 \$75 1.85159a
Cext_12297 \$435 \$77 1.0724a
Cext_12298 \$435 VSUBS 177.904a
Cext_12299 \$436 \$45 20.9159a
Cext_12300 \$436 \$461 254.864a
Cext_12301 \$436 \$474 0.360462a
Cext_12302 \$436 \$67 64.1221a
Cext_12303 \$436 \$69 0.155901a
Cext_12304 \$436 IOVDD|vdda 13.0646a
Cext_12305 \$436 VSS|vss 66.2132a
Cext_12306 \$436 VSUBS 817.468a
Cext_12307 \$437 \$438 2.46853a
Cext_12308 \$437 \$45 20.8391a
Cext_12309 \$437 \$452 102.889a
Cext_12310 \$437 \$462 225.319a
Cext_12311 \$437 \$67 58.9193a
Cext_12312 \$437 \$69 0.343978a
Cext_12313 \$437 VSS|vss 60.9228a
Cext_12314 \$437 VSUBS 811.534a
Cext_12315 \$438 \$439 0.179323a
Cext_12316 \$438 \$452 230.002a
Cext_12317 \$438 \$507 98.5952a
Cext_12318 \$438 \$583 1.46644a
Cext_12319 \$438 \$69 106.511a
Cext_12320 \$438 \$71 53.7264a
Cext_12321 \$438 \$73 3.34353a
Cext_12322 \$438 \$75 1.85159a
Cext_12323 \$438 \$77 1.0724a
Cext_12324 \$438 VSUBS 177.904a
Cext_12325 \$439 \$45 21.0663a
Cext_12326 \$439 \$463 130.175a
Cext_12327 \$439 VSS|vss 2.2008a
Cext_12328 \$439 VSUBS 676a
Cext_12329 \$44 \$45 602.411a
Cext_12330 \$44 \$46 2.13277a
Cext_12331 \$44 \$47 0.107981a
Cext_12332 \$44 \$49 24.0099a
Cext_12333 \$44 \$75 29.0633a
Cext_12334 \$44 \$76 902.785a
Cext_12335 \$44 \$77 0.237316a
Cext_12336 \$44 \$81 0.124678a
Cext_12337 \$44 d5|dac_soft[5] 130.648a
Cext_12338 \$44 d7|dac_soft[7] 14.8234a
Cext_12339 \$44 IOVDD|vdda 173.811a
Cext_12340 \$44 VDD|vdd 10.4718a
Cext_12341 \$44 VSS|vss 446.394a
Cext_12342 \$44 VSUBS 1.50594f
Cext_12343 \$440 \$441 45.0654a
Cext_12344 \$440 \$464 130.128a
Cext_12345 \$440 VDD|vdd 0.592094a
Cext_12346 \$440 VSS|vss 25.1792a
Cext_12347 \$440 VSUBS 659.267a
Cext_12348 \$441 \$442 45.0654a
Cext_12349 \$441 \$465 130.175a
Cext_12350 \$441 VSS|vss 5.452a
Cext_12351 \$441 VSUBS 634.529a
Cext_12352 \$442 \$443 45.0654a
Cext_12353 \$442 \$466 130.175a
Cext_12354 \$442 VSUBS 634.529a
Cext_12355 \$443 \$444 46.4004a
Cext_12356 \$443 \$467 130.175a
Cext_12357 \$443 VSS|vss 0.378729a
Cext_12358 \$443 VSUBS 634.529a
Cext_12359 \$444 \$468 254.864a
Cext_12360 \$444 \$475 0.360462a
Cext_12361 \$444 \$51 68.8031a
Cext_12362 \$444 \$83 64.1221a
Cext_12363 \$444 \$85 0.155901a
Cext_12364 \$444 VSS|vss 66.2906a
Cext_12365 \$444 VSUBS 799.746a
Cext_12366 \$445 \$446 2.46853a
Cext_12367 \$445 \$453 102.889a
Cext_12368 \$445 \$469 225.319a
Cext_12369 \$445 \$51 68.8428a
Cext_12370 \$445 \$57 0.115752a
Cext_12371 \$445 \$59 0.481837a
Cext_12372 \$445 \$61 20.8391a
Cext_12373 \$445 \$83 58.9193a
Cext_12374 \$445 \$85 0.343978a
Cext_12375 \$445 VSS|vss 60.9228a
Cext_12376 \$445 VSUBS 811.534a
Cext_12377 \$446 \$447 0.179323a
Cext_12378 \$446 \$453 230.002a
Cext_12379 \$446 \$51 2.95962a
Cext_12380 \$446 \$517 98.5952a
Cext_12381 \$446 \$53 93.95a
Cext_12382 \$446 \$55 1.18748a
Cext_12383 \$446 \$585 1.46644a
Cext_12384 \$446 \$59 0.476813a
Cext_12385 \$446 \$85 106.511a
Cext_12386 \$446 \$87 53.7264a
Cext_12387 \$446 \$89 3.34353a
Cext_12388 \$446 \$91 1.85159a
Cext_12389 \$446 \$93 1.0724a
Cext_12390 \$446 VSUBS 177.904a
Cext_12391 \$447 \$470 254.864a
Cext_12392 \$447 \$476 0.360462a
Cext_12393 \$447 \$51 68.8031a
Cext_12394 \$447 \$55 0.105966a
Cext_12395 \$447 \$57 0.282145a
Cext_12396 \$447 \$59 0.494517a
Cext_12397 \$447 \$61 20.9159a
Cext_12398 \$447 \$83 64.1221a
Cext_12399 \$447 \$85 0.155901a
Cext_12400 \$447 IOVDD|vdda 13.0646a
Cext_12401 \$447 VSS|vss 66.2132a
Cext_12402 \$447 VSUBS 817.468a
Cext_12403 \$448 \$449 2.46853a
Cext_12404 \$448 \$454 102.889a
Cext_12405 \$448 \$471 225.319a
Cext_12406 \$448 \$51 68.8428a
Cext_12407 \$448 \$57 0.115752a
Cext_12408 \$448 \$59 0.481837a
Cext_12409 \$448 \$61 20.8391a
Cext_12410 \$448 \$83 58.9193a
Cext_12411 \$448 \$85 0.343978a
Cext_12412 \$448 VSS|vss 69.9251a
Cext_12413 \$448 VSUBS 811.534a
Cext_12414 \$449 \$450 0.179323a
Cext_12415 \$449 \$454 230.002a
Cext_12416 \$449 \$51 2.95962a
Cext_12417 \$449 \$522 98.5952a
Cext_12418 \$449 \$53 93.95a
Cext_12419 \$449 \$55 1.18748a
Cext_12420 \$449 \$587 1.46644a
Cext_12421 \$449 \$59 0.476813a
Cext_12422 \$449 \$85 106.511a
Cext_12423 \$449 \$87 53.7264a
Cext_12424 \$449 \$89 3.34353a
Cext_12425 \$449 \$91 1.85159a
Cext_12426 \$449 \$93 1.0724a
Cext_12427 \$449 VSUBS 177.904a
Cext_12428 \$45 \$46 41.8224a
Cext_12429 \$45 \$460 20.7622a
Cext_12430 \$45 \$461 20.8391a
Cext_12431 \$45 \$462 20.7622a
Cext_12432 \$45 \$463 20.9895a
Cext_12433 \$45 \$47 34.3134a
Cext_12434 \$45 \$482 20.9928a
Cext_12435 \$45 \$483 20.7622a
Cext_12436 \$45 \$484 20.9928a
Cext_12437 \$45 \$485 20.9126a
Cext_12438 \$45 \$49 53.121a
Cext_12439 \$45 \$500 25.3297a
Cext_12440 \$45 \$503 20.9159a
Cext_12441 \$45 \$504 20.9928a
Cext_12442 \$45 \$505 25.3297a
Cext_12443 \$45 \$508 20.9159a
Cext_12444 \$45 \$509 21.1432a
Cext_12445 \$45 \$526 73.5447a
Cext_12446 \$45 \$528 75.17a
Cext_12447 \$45 \$538 20.8391a
Cext_12448 \$45 \$540 20.9159a
Cext_12449 \$45 \$541 20.8391a
Cext_12450 \$45 \$543 21.0663a
Cext_12451 \$45 \$568 20.7622a
Cext_12452 \$45 \$569 20.8391a
Cext_12453 \$45 \$570 20.7622a
Cext_12454 \$45 \$571 20.9895a
Cext_12455 \$45 \$593 20.9928a
Cext_12456 \$45 \$594 20.7622a
Cext_12457 \$45 \$595 20.9928a
Cext_12458 \$45 \$620 20.9159a
Cext_12459 \$45 \$621 20.9928a
Cext_12460 \$45 \$623 20.9159a
Cext_12461 \$45 \$640 20.8391a
Cext_12462 \$45 \$644 20.9159a
Cext_12463 \$45 \$645 20.8391a
Cext_12464 \$45 \$67 121.073a
Cext_12465 \$45 \$671 20.7622a
Cext_12466 \$45 \$672 20.8391a
Cext_12467 \$45 \$673 20.7622a
Cext_12468 \$45 \$688 20.9928a
Cext_12469 \$45 \$69 188.936a
Cext_12470 \$45 \$690 20.7622a
Cext_12471 \$45 \$691 20.9928a
Cext_12472 \$45 \$71 64.4319a
Cext_12473 \$45 \$711 0.104586a
Cext_12474 \$45 \$712 20.9159a
Cext_12475 \$45 \$713 20.9928a
Cext_12476 \$45 \$714 0.104586a
Cext_12477 \$45 \$715 20.9159a
Cext_12478 \$45 \$73 70.3718a
Cext_12479 \$45 \$732 20.8391a
Cext_12480 \$45 \$733 0.13075a
Cext_12481 \$45 \$735 20.9159a
Cext_12482 \$45 \$736 0.13075a
Cext_12483 \$45 \$75 131.194a
Cext_12484 \$45 \$752 20.8391a
Cext_12485 \$45 \$76 69.1586a
Cext_12486 \$45 \$763 20.7622a
Cext_12487 \$45 \$764 20.8391a
Cext_12488 \$45 \$765 20.7622a
Cext_12489 \$45 \$77 17.7643f
Cext_12490 \$45 \$78 10.2105a
Cext_12491 \$45 \$780 20.9928a
Cext_12492 \$45 \$782 20.7622a
Cext_12493 \$45 \$784 20.9928a
Cext_12494 \$45 \$79 16.2154f
Cext_12495 \$45 \$807 0.329802a
Cext_12496 \$45 \$808 20.9159a
Cext_12497 \$45 \$809 20.9928a
Cext_12498 \$45 \$81 32.1598a
Cext_12499 \$45 \$810 0.329802a
Cext_12500 \$45 \$811 20.9159a
Cext_12501 \$45 \$827 20.8391a
Cext_12502 \$45 \$828 0.476813a
Cext_12503 \$45 \$830 20.9159a
Cext_12504 \$45 \$831 20.8391a
Cext_12505 \$45 \$832 0.476813a
Cext_12506 \$45 \$855 20.7622a
Cext_12507 \$45 \$856 20.8391a
Cext_12508 \$45 \$857 20.7622a
Cext_12509 \$45 \$866 0.62262a
Cext_12510 \$45 \$867 0.62262a
Cext_12511 \$45 \$874 20.9928a
Cext_12512 \$45 \$875 20.7622a
Cext_12513 \$45 \$876 20.9928a
Cext_12514 \$45 \$886 167.689a
Cext_12515 \$45 \$887 1.40263a
Cext_12516 \$45 \$888 119.51a
Cext_12517 \$45 \$889 1.40263a
Cext_12518 \$45 \$899 21.0619a
Cext_12519 \$45 \$900 22.5002a
Cext_12520 \$45 \$901 21.0619a
Cext_12521 \$45 \$914 1.40263a
Cext_12522 \$45 \$916 20.8391a
Cext_12523 \$45 \$917 124.328a
Cext_12524 \$45 \$918 1.40263a
Cext_12525 \$45 \$919 20.9159a
Cext_12526 \$45 \$920 20.8391a
Cext_12527 \$45 \$921 79.422a
Cext_12528 \$45 \$934 0.476813a
Cext_12529 \$45 \$935 0.62262a
Cext_12530 \$45 \$936 0.476813a
Cext_12531 \$45 \$937 0.62262a
Cext_12532 \$45 \$947 20.7622a
Cext_12533 \$45 \$948 20.8391a
Cext_12534 \$45 \$949 20.7622a
Cext_12535 \$45 \$963 0.329802a
Cext_12536 \$45 \$965 20.7622a
Cext_12537 \$45 \$966 0.329802a
Cext_12538 \$45 \$980 20.9928a
Cext_12539 \$45 \$981 20.9928a
Cext_12540 \$45 \$984 0.13075a
Cext_12541 \$45 \$986 0.13075a
Cext_12542 \$45 \$998 20.9159a
Cext_12543 \$45 \$999 20.9928a
Cext_12544 \$45 d6|dac_soft[6] 28.2212a
Cext_12545 \$45 d7|dac_soft[7] 6.69708a
Cext_12546 \$45 IOVDD|vdda 811.762a
Cext_12547 \$45 VDD|vdd 5.43972a
Cext_12548 \$45 VREF|vref 2.28972f
Cext_12549 \$45 VSS|vss 1.99036f
Cext_12550 \$45 VSUBS 24.5239f
Cext_12551 \$450 \$472 130.175a
Cext_12552 \$450 \$55 0.105966a
Cext_12553 \$450 \$57 0.282145a
Cext_12554 \$450 \$59 0.494517a
Cext_12555 \$450 \$61 21.0663a
Cext_12556 \$450 VSS|vss 2.2008a
Cext_12557 \$450 VSUBS 676a
Cext_12558 \$451 \$460 114.006a
Cext_12559 \$451 \$461 0.182933a
Cext_12560 \$451 \$482 0.360462a
Cext_12561 \$451 \$502 108.267a
Cext_12562 \$451 \$67 80.1821a
Cext_12563 \$451 \$69 70.7638a
Cext_12564 \$451 \$71 34.0438a
Cext_12565 \$451 \$73 32.5775a
Cext_12566 \$451 \$75 35.6349a
Cext_12567 \$451 \$77 45.7852a
Cext_12568 \$451 VSS|vss 0.378848a
Cext_12569 \$451 VSUBS 255.847a
Cext_12570 \$452 \$462 114.006a
Cext_12571 \$452 \$463 0.182933a
Cext_12572 \$452 \$484 0.360462a
Cext_12573 \$452 \$507 108.267a
Cext_12574 \$452 \$67 80.1821a
Cext_12575 \$452 \$69 70.7638a
Cext_12576 \$452 \$71 34.0438a
Cext_12577 \$452 \$73 32.5775a
Cext_12578 \$452 \$75 35.6349a
Cext_12579 \$452 \$77 45.7852a
Cext_12580 \$452 VSS|vss 0.378848a
Cext_12581 \$452 VSUBS 255.847a
Cext_12582 \$453 \$469 114.006a
Cext_12583 \$453 \$470 0.182933a
Cext_12584 \$453 \$491 0.360462a
Cext_12585 \$453 \$51 123.657a
Cext_12586 \$453 \$517 108.267a
Cext_12587 \$453 \$53 65.6459a
Cext_12588 \$453 \$55 0.62262a
Cext_12589 \$453 \$83 80.1821a
Cext_12590 \$453 \$85 70.7638a
Cext_12591 \$453 \$87 34.0438a
Cext_12592 \$453 \$89 32.5775a
Cext_12593 \$453 \$91 35.6349a
Cext_12594 \$453 \$93 45.7852a
Cext_12595 \$453 VSS|vss 0.378848a
Cext_12596 \$453 VSUBS 255.847a
Cext_12597 \$454 \$471 114.006a
Cext_12598 \$454 \$472 0.182933a
Cext_12599 \$454 \$493 0.360462a
Cext_12600 \$454 \$51 123.657a
Cext_12601 \$454 \$522 108.267a
Cext_12602 \$454 \$53 65.6459a
Cext_12603 \$454 \$55 0.62262a
Cext_12604 \$454 \$83 80.1821a
Cext_12605 \$454 \$85 70.7638a
Cext_12606 \$454 \$87 34.0438a
Cext_12607 \$454 \$89 32.5775a
Cext_12608 \$454 \$91 35.6349a
Cext_12609 \$454 \$93 45.7852a
Cext_12610 \$454 VSS|vss 0.378848a
Cext_12611 \$454 VSUBS 255.847a
Cext_12612 \$455 \$456 45.0654a
Cext_12613 \$455 \$477 130.175a
Cext_12614 \$455 VDD|vdd 7.74075a
Cext_12615 \$455 VSS|vss 1.71997a
Cext_12616 \$455 VSUBS 659.267a
Cext_12617 \$456 \$457 45.0654a
Cext_12618 \$456 \$478 130.175a
Cext_12619 \$456 VDD|vdd 0.968272a
Cext_12620 \$456 VSUBS 634.529a
Cext_12621 \$457 \$458 45.0654a
Cext_12622 \$457 \$479 130.175a
Cext_12623 \$457 VSUBS 634.529a
Cext_12624 \$458 \$459 45.8951a
Cext_12625 \$458 \$480 130.175a
Cext_12626 \$458 VSS|vss 0.428128a
Cext_12627 \$458 VSUBS 634.529a
Cext_12628 \$459 \$473 113.058a
Cext_12629 \$459 \$481 225.319a
Cext_12630 \$459 \$67 105.489a
Cext_12631 \$459 VSS|vss 61.1015a
Cext_12632 \$459 VSUBS 793.257a
Cext_12633 \$46 \$47 615.803a
Cext_12634 \$46 \$48 2.13277a
Cext_12635 \$46 \$49 23.8673a
Cext_12636 \$46 \$77 29.0633a
Cext_12637 \$46 \$78 902.785a
Cext_12638 \$46 \$79 0.237316a
Cext_12639 \$46 d6|dac_soft[6] 130.648a
Cext_12640 \$46 d7|dac_soft[7] 14.8234a
Cext_12641 \$46 IOVDD|vdda 173.611a
Cext_12642 \$46 VDD|vdd 10.4718a
Cext_12643 \$46 VSS|vss 446.394a
Cext_12644 \$46 VSUBS 1.50398f
Cext_12645 \$460 \$473 0.182933a
Cext_12646 \$460 \$482 254.864a
Cext_12647 \$460 \$502 0.360462a
Cext_12648 \$460 \$67 110.011a
Cext_12649 \$460 VSS|vss 66.2132a
Cext_12650 \$460 VSUBS 817.35a
Cext_12651 \$461 \$474 113.058a
Cext_12652 \$461 \$483 225.319a
Cext_12653 \$461 \$67 105.489a
Cext_12654 \$461 IOVDD|vdda 11.5102a
Cext_12655 \$461 VSS|vss 60.9228a
Cext_12656 \$461 VSUBS 810.376a
Cext_12657 \$462 \$474 0.182933a
Cext_12658 \$462 \$484 254.864a
Cext_12659 \$462 \$507 0.360462a
Cext_12660 \$462 \$67 110.011a
Cext_12661 \$462 VSS|vss 66.2132a
Cext_12662 \$462 VSUBS 817.35a
Cext_12663 \$463 \$485 130.175a
Cext_12664 \$463 VSS|vss 2.2008a
Cext_12665 \$463 VSUBS 675.619a
Cext_12666 \$464 \$465 45.0654a
Cext_12667 \$464 \$486 130.128a
Cext_12668 \$464 VDD|vdd 0.592094a
Cext_12669 \$464 VSS|vss 25.1792a
Cext_12670 \$464 VSUBS 659.267a
Cext_12671 \$465 \$466 45.0654a
Cext_12672 \$465 \$487 130.175a
Cext_12673 \$465 VSS|vss 5.452a
Cext_12674 \$465 VSUBS 634.529a
Cext_12675 \$466 \$467 45.0654a
Cext_12676 \$466 \$488 130.175a
Cext_12677 \$466 VSUBS 634.529a
Cext_12678 \$467 \$468 45.8951a
Cext_12679 \$467 \$489 130.175a
Cext_12680 \$467 VSS|vss 0.428128a
Cext_12681 \$467 VSUBS 634.529a
Cext_12682 \$468 \$475 113.058a
Cext_12683 \$468 \$490 225.319a
Cext_12684 \$468 \$51 22.6915a
Cext_12685 \$468 \$83 105.489a
Cext_12686 \$468 VSS|vss 61.1015a
Cext_12687 \$468 VSUBS 793.257a
Cext_12688 \$469 \$475 0.182933a
Cext_12689 \$469 \$491 254.864a
Cext_12690 \$469 \$51 23.2117a
Cext_12691 \$469 \$517 0.360462a
Cext_12692 \$469 \$53 0.145978a
Cext_12693 \$469 \$55 0.105966a
Cext_12694 \$469 \$57 0.282145a
Cext_12695 \$469 \$59 0.494517a
Cext_12696 \$469 \$61 20.7622a
Cext_12697 \$469 \$83 110.011a
Cext_12698 \$469 VSS|vss 66.2132a
Cext_12699 \$469 VSUBS 817.35a
Cext_12700 \$47 \$48 41.9328a
Cext_12701 \$47 \$49 12.4248f
Cext_12702 \$47 \$67 39.1669a
Cext_12703 \$47 \$69 30.4252a
Cext_12704 \$47 \$71 29.7164a
Cext_12705 \$47 \$73 32.7474a
Cext_12706 \$47 \$75 31.8487a
Cext_12707 \$47 \$77 92.0373a
Cext_12708 \$47 \$78 69.1586a
Cext_12709 \$47 \$79 17.9138f
Cext_12710 \$47 \$80 10.2105a
Cext_12711 \$47 \$81 16.2531f
Cext_12712 \$47 \$886 19.9349a
Cext_12713 \$47 \$888 19.9526a
Cext_12714 \$47 \$917 66.583a
Cext_12715 \$47 \$921 70.0248a
Cext_12716 \$47 \$967 88.258a
Cext_12717 \$47 d7|dac_soft[7] 34.9183a
Cext_12718 \$47 inn|out|vth_soft 46.3925a
Cext_12719 \$47 IOVDD|vdda 808.928a
Cext_12720 \$47 VDD|vdd 5.43972a
Cext_12721 \$47 VREF|vref 2.18901a
Cext_12722 \$47 VSS|vss 431.178a
Cext_12723 \$47 VSUBS 6.34423f
Cext_12724 \$470 \$476 113.058a
Cext_12725 \$470 \$492 225.319a
Cext_12726 \$470 \$51 22.6915a
Cext_12727 \$470 \$53 0.404672a
Cext_12728 \$470 \$57 0.115752a
Cext_12729 \$470 \$59 0.481837a
Cext_12730 \$470 \$61 20.8391a
Cext_12731 \$470 \$83 105.489a
Cext_12732 \$470 IOVDD|vdda 11.5102a
Cext_12733 \$470 VSS|vss 60.9228a
Cext_12734 \$470 VSUBS 810.376a
Cext_12735 \$471 \$476 0.182933a
Cext_12736 \$471 \$493 254.864a
Cext_12737 \$471 \$51 23.2117a
Cext_12738 \$471 \$522 0.360462a
Cext_12739 \$471 \$53 0.145978a
Cext_12740 \$471 \$55 0.105966a
Cext_12741 \$471 \$57 0.282145a
Cext_12742 \$471 \$59 0.494517a
Cext_12743 \$471 \$61 20.7622a
Cext_12744 \$471 \$83 110.011a
Cext_12745 \$471 VSS|vss 75.4228a
Cext_12746 \$471 VSUBS 817.35a
Cext_12747 \$472 \$494 130.175a
Cext_12748 \$472 \$53 0.404672a
Cext_12749 \$472 \$57 0.115752a
Cext_12750 \$472 \$59 0.481837a
Cext_12751 \$472 \$61 20.9895a
Cext_12752 \$472 VSS|vss 2.2008a
Cext_12753 \$472 VSUBS 675.619a
Cext_12754 \$473 \$481 102.889a
Cext_12755 \$473 \$499 0.360462a
Cext_12756 \$473 \$500 0.227961a
Cext_12757 \$473 \$525 42.153a
Cext_12758 \$473 \$67 80.1249a
Cext_12759 \$473 \$69 70.7638a
Cext_12760 \$473 \$71 31.3588a
Cext_12761 \$473 \$73 32.5775a
Cext_12762 \$473 \$75 39.8709a
Cext_12763 \$473 \$77 45.8508a
Cext_12764 \$473 VSS|vss 0.335662a
Cext_12765 \$473 VSUBS 259.405a
Cext_12766 \$474 \$483 102.889a
Cext_12767 \$474 \$504 0.360462a
Cext_12768 \$474 \$505 0.227961a
Cext_12769 \$474 \$527 42.153a
Cext_12770 \$474 \$67 79.9778a
Cext_12771 \$474 \$69 70.7638a
Cext_12772 \$474 \$71 31.3588a
Cext_12773 \$474 \$73 32.5775a
Cext_12774 \$474 \$75 39.8709a
Cext_12775 \$474 \$77 45.8508a
Cext_12776 \$474 IOVDD|vdda 41.7133a
Cext_12777 \$474 VSS|vss 0.335662a
Cext_12778 \$474 VSUBS 259.131a
Cext_12779 \$475 \$490 102.889a
Cext_12780 \$475 \$51 123.657a
Cext_12781 \$475 \$514 0.360462a
Cext_12782 \$475 \$515 0.227961a
Cext_12783 \$475 \$529 42.153a
Cext_12784 \$475 \$53 65.5562a
Cext_12785 \$475 \$59 0.62262a
Cext_12786 \$475 \$83 80.1249a
Cext_12787 \$475 \$85 70.7638a
Cext_12788 \$475 \$87 31.3588a
Cext_12789 \$475 \$89 32.5775a
Cext_12790 \$475 \$91 39.8709a
Cext_12791 \$475 \$93 45.8508a
Cext_12792 \$475 VSS|vss 0.335662a
Cext_12793 \$475 VSUBS 259.405a
Cext_12794 \$476 \$492 102.889a
Cext_12795 \$476 \$51 123.51a
Cext_12796 \$476 \$519 0.360462a
Cext_12797 \$476 \$520 0.227961a
Cext_12798 \$476 \$53 65.5562a
Cext_12799 \$476 \$531 42.153a
Cext_12800 \$476 \$59 0.62262a
Cext_12801 \$476 \$83 79.9778a
Cext_12802 \$476 \$85 70.7638a
Cext_12803 \$476 \$87 31.3588a
Cext_12804 \$476 \$89 32.5775a
Cext_12805 \$476 \$91 39.8709a
Cext_12806 \$476 \$93 45.8508a
Cext_12807 \$476 IOVDD|vdda 41.7133a
Cext_12808 \$476 VSS|vss 4.18919a
Cext_12809 \$476 VSUBS 259.131a
Cext_12810 \$477 \$478 45.0654a
Cext_12811 \$477 \$495 130.175a
Cext_12812 \$477 VDD|vdd 7.74075a
Cext_12813 \$477 VSS|vss 1.71997a
Cext_12814 \$477 VSUBS 659.267a
Cext_12815 \$478 \$479 45.0654a
Cext_12816 \$478 \$496 130.175a
Cext_12817 \$478 VDD|vdd 0.968272a
Cext_12818 \$478 VSUBS 634.529a
Cext_12819 \$479 \$480 45.0654a
Cext_12820 \$479 \$497 130.175a
Cext_12821 \$479 VSUBS 634.529a
Cext_12822 \$48 \$49 626.171a
Cext_12823 \$48 \$79 29.0633a
Cext_12824 \$48 \$80 902.785a
Cext_12825 \$48 \$81 0.364827a
Cext_12826 \$48 d7|dac_soft[7] 130.648a
Cext_12827 \$48 IOVDD|vdda 189.175a
Cext_12828 \$48 VDD|vdd 10.4718a
Cext_12829 \$48 VSS|vss 446.394a
Cext_12830 \$48 VSUBS 1.51254f
Cext_12831 \$480 \$481 46.4004a
Cext_12832 \$480 \$498 130.175a
Cext_12833 \$480 VSS|vss 0.378729a
Cext_12834 \$480 VSUBS 634.529a
Cext_12835 \$481 \$499 254.864a
Cext_12836 \$481 \$525 0.360462a
Cext_12837 \$481 \$67 64.2241a
Cext_12838 \$481 \$75 0.2003a
Cext_12839 \$481 \$77 0.107779a
Cext_12840 \$481 VSS|vss 66.2906a
Cext_12841 \$481 VSUBS 801.371a
Cext_12842 \$482 \$502 113.058a
Cext_12843 \$482 \$503 225.319a
Cext_12844 \$482 \$67 58.9193a
Cext_12845 \$482 \$75 0.343978a
Cext_12846 \$482 VSS|vss 60.9228a
Cext_12847 \$482 VSUBS 810.856a
Cext_12848 \$483 \$502 0.182933a
Cext_12849 \$483 \$504 254.864a
Cext_12850 \$483 \$527 0.360462a
Cext_12851 \$483 \$67 64.2241a
Cext_12852 \$483 \$75 0.2003a
Cext_12853 \$483 \$77 0.107779a
Cext_12854 \$483 IOVDD|vdda 13.2807a
Cext_12855 \$483 VSS|vss 66.2132a
Cext_12856 \$483 VSUBS 819.093a
Cext_12857 \$484 \$507 113.058a
Cext_12858 \$484 \$508 225.319a
Cext_12859 \$484 \$67 58.9193a
Cext_12860 \$484 \$75 0.343978a
Cext_12861 \$484 VSS|vss 60.9228a
Cext_12862 \$484 VSUBS 810.856a
Cext_12863 \$485 \$507 0.182933a
Cext_12864 \$485 \$509 130.105a
Cext_12865 \$485 VSS|vss 2.2008a
Cext_12866 \$485 VSUBS 676a
Cext_12867 \$486 \$487 45.0654a
Cext_12868 \$486 \$510 130.128a
Cext_12869 \$486 VDD|vdd 0.592094a
Cext_12870 \$486 VSS|vss 25.1792a
Cext_12871 \$486 VSUBS 659.267a
Cext_12872 \$487 \$488 45.0654a
Cext_12873 \$487 \$511 130.175a
Cext_12874 \$487 VSS|vss 5.452a
Cext_12875 \$487 VSUBS 634.529a
Cext_12876 \$488 \$489 45.0654a
Cext_12877 \$488 \$512 130.175a
Cext_12878 \$488 VSUBS 634.529a
Cext_12879 \$489 \$490 46.4004a
Cext_12880 \$489 \$513 130.175a
Cext_12881 \$489 VSS|vss 0.378729a
Cext_12882 \$489 VSUBS 634.529a
Cext_12883 \$49 \$67 47.9029a
Cext_12884 \$49 \$68 4.13612a
Cext_12885 \$49 \$69 39.1611a
Cext_12886 \$49 \$70 4.13612a
Cext_12887 \$49 \$71 38.4523a
Cext_12888 \$49 \$72 4.13612a
Cext_12889 \$49 \$73 41.1711a
Cext_12890 \$49 \$74 4.13612a
Cext_12891 \$49 \$75 39.4319a
Cext_12892 \$49 \$76 4.13612a
Cext_12893 \$49 \$77 51.9933a
Cext_12894 \$49 \$78 4.13612a
Cext_12895 \$49 \$79 130.01a
Cext_12896 \$49 \$80 73.2948a
Cext_12897 \$49 \$81 16.9737f
Cext_12898 \$49 \$886 0.241453a
Cext_12899 \$49 \$888 2.49735a
Cext_12900 \$49 \$917 1.08006a
Cext_12901 \$49 \$921 0.448823a
Cext_12902 \$49 \$967 50.1975a
Cext_12903 \$49 inn|out|vth_soft 60.9684a
Cext_12904 \$49 IOVDD|vdda 1.12107f
Cext_12905 \$49 VDD|vdd 5.43972a
Cext_12906 \$49 VREF|vref 1.29505a
Cext_12907 \$49 VSS|vss 1.98117f
Cext_12908 \$49 VSUBS 7.75299f
Cext_12909 \$490 \$51 69.0342a
Cext_12910 \$490 \$514 254.864a
Cext_12911 \$490 \$529 0.360462a
Cext_12912 \$490 \$83 64.2241a
Cext_12913 \$490 \$91 0.2003a
Cext_12914 \$490 \$93 0.107779a
Cext_12915 \$490 VSS|vss 66.2906a
Cext_12916 \$490 VSUBS 801.371a
Cext_12917 \$491 \$51 68.7272a
Cext_12918 \$491 \$517 113.058a
Cext_12919 \$491 \$518 225.319a
Cext_12920 \$491 \$57 0.115752a
Cext_12921 \$491 \$59 0.481837a
Cext_12922 \$491 \$61 20.9928a
Cext_12923 \$491 \$83 58.9193a
Cext_12924 \$491 \$91 0.343978a
Cext_12925 \$491 VSS|vss 60.9228a
Cext_12926 \$491 VSUBS 810.856a
Cext_12927 \$492 \$51 69.0342a
Cext_12928 \$492 \$517 0.182933a
Cext_12929 \$492 \$519 254.864a
Cext_12930 \$492 \$531 0.360462a
Cext_12931 \$492 \$55 0.105966a
Cext_12932 \$492 \$57 0.282145a
Cext_12933 \$492 \$59 0.494517a
Cext_12934 \$492 \$61 20.7622a
Cext_12935 \$492 \$83 64.2241a
Cext_12936 \$492 \$91 0.2003a
Cext_12937 \$492 \$93 0.107779a
Cext_12938 \$492 IOVDD|vdda 13.2807a
Cext_12939 \$492 VSS|vss 66.2132a
Cext_12940 \$492 VSUBS 819.093a
Cext_12941 \$493 \$51 68.7272a
Cext_12942 \$493 \$522 113.058a
Cext_12943 \$493 \$523 225.319a
Cext_12944 \$493 \$57 0.115752a
Cext_12945 \$493 \$59 0.481837a
Cext_12946 \$493 \$61 20.9928a
Cext_12947 \$493 \$83 58.9193a
Cext_12948 \$493 \$91 0.343978a
Cext_12949 \$493 VSS|vss 69.9251a
Cext_12950 \$493 VSUBS 810.856a
Cext_12951 \$494 \$522 0.182933a
Cext_12952 \$494 \$524 130.105a
Cext_12953 \$494 \$55 0.105966a
Cext_12954 \$494 \$57 0.282145a
Cext_12955 \$494 \$59 0.494517a
Cext_12956 \$494 \$61 20.9126a
Cext_12957 \$494 VSS|vss 2.2008a
Cext_12958 \$494 VSUBS 676a
Cext_12959 \$495 \$496 45.0654a
Cext_12960 \$495 \$533 130.175a
Cext_12961 \$495 VDD|vdd 7.74075a
Cext_12962 \$495 VSS|vss 1.71997a
Cext_12963 \$495 VSUBS 659.267a
Cext_12964 \$496 \$497 45.0654a
Cext_12965 \$496 \$534 130.175a
Cext_12966 \$496 VDD|vdd 0.968272a
Cext_12967 \$496 VSUBS 634.529a
Cext_12968 \$497 \$498 45.0654a
Cext_12969 \$497 \$535 130.175a
Cext_12970 \$497 VSUBS 634.529a
Cext_12971 \$498 \$499 45.8951a
Cext_12972 \$498 \$536 130.175a
Cext_12973 \$498 VSS|vss 0.428128a
Cext_12974 \$498 VSUBS 634.529a
Cext_12975 \$499 \$501 2.00331a
Cext_12976 \$499 \$525 102.889a
Cext_12977 \$499 \$537 225.319a
Cext_12978 \$499 \$67 105.694a
Cext_12979 \$499 VSS|vss 61.1015a
Cext_12980 \$499 VSUBS 794.296a
Cext_12981 \$50 \$51 602.158a
Cext_12982 \$50 \$52 2.13277a
Cext_12983 \$50 \$65 2.67777a
Cext_12984 \$50 \$82 902.785a
Cext_12985 \$50 \$83 0.237316a
Cext_12986 \$50 d0|dac_hard[0] 130.648a
Cext_12987 \$50 IOVDD|vdda 173.948a
Cext_12988 \$50 VDD|vdd 10.5882a
Cext_12989 \$50 VSS|vss 503.765a
Cext_12990 \$50 VSUBS 1.54476f
Cext_12991 \$500 \$501 3.0905f
Cext_12992 \$500 \$503 5.60736a
Cext_12993 \$500 \$525 11.9416a
Cext_12994 \$500 \$538 5.04708a
Cext_12995 \$500 \$555 22.3756a
Cext_12996 \$500 \$568 5.60736a
Cext_12997 \$500 \$580 11.7937a
Cext_12998 \$500 \$593 5.04708a
Cext_12999 \$500 \$606 22.7826a
Cext_13000 \$500 \$619 22.3417a
Cext_13001 \$500 \$620 5.60736a
Cext_13002 \$500 \$638 11.8276a
Cext_13003 \$500 \$640 5.04708a
Cext_13004 \$500 \$671 5.60736a
Cext_13005 \$500 \$686 11.7937a
Cext_13006 \$500 \$688 5.04708a
Cext_13007 \$500 \$69 81.9637a
Cext_13008 \$500 \$71 18.0277a
Cext_13009 \$500 \$711 439.952a
Cext_13010 \$500 \$712 5.60736a
Cext_13011 \$500 \$73 7.9638a
Cext_13012 \$500 \$731 14.2573a
Cext_13013 \$500 \$732 5.04708a
Cext_13014 \$500 \$749 27.235a
Cext_13015 \$500 \$75 48.4427a
Cext_13016 \$500 \$763 5.60736a
Cext_13017 \$500 \$77 49.139a
Cext_13018 \$500 \$779 14.2234a
Cext_13019 \$500 \$780 5.04708a
Cext_13020 \$500 \$807 140.731a
Cext_13021 \$500 \$808 5.60736a
Cext_13022 \$500 \$826 15.6091a
Cext_13023 \$500 \$827 5.04708a
Cext_13024 \$500 \$855 5.60736a
Cext_13025 \$500 \$866 68.5573a
Cext_13026 \$500 \$873 2.6225a
Cext_13027 \$500 \$874 4.2052a
Cext_13028 \$500 \$886 136.817a
Cext_13029 \$500 VSS|vss 0.88514a
Cext_13030 \$500 VSUBS 879.908a
Cext_13031 \$501 \$503 0.179323a
Cext_13032 \$501 \$525 75.7894a
Cext_13033 \$501 \$555 223.573a
Cext_13034 \$501 \$580 17.8937a
Cext_13035 \$501 \$606 1.55447f
Cext_13036 \$501 \$619 29.1901a
Cext_13037 \$501 \$638 15.464a
Cext_13038 \$501 \$67 1.69277a
Cext_13039 \$501 \$686 15.578a
Cext_13040 \$501 \$69 71.8063a
Cext_13041 \$501 \$71 18.5253a
Cext_13042 \$501 \$711 99.1454a
Cext_13043 \$501 \$73 62.4106a
Cext_13044 \$501 \$731 0.250757a
Cext_13045 \$501 \$75 2.44188a
Cext_13046 \$501 \$77 0.959093a
Cext_13047 \$501 VSUBS 249.512a
Cext_13048 \$502 \$503 102.889a
Cext_13049 \$502 \$526 0.227961a
Cext_13050 \$502 \$538 0.360462a
Cext_13051 \$502 \$556 42.153a
Cext_13052 \$502 \$67 69.937a
Cext_13053 \$502 \$69 117.37a
Cext_13054 \$502 \$71 31.3588a
Cext_13055 \$502 \$73 32.5775a
Cext_13056 \$502 \$75 37.9814a
Cext_13057 \$502 \$77 45.8508a
Cext_13058 \$502 VSS|vss 0.335662a
Cext_13059 \$502 VSUBS 259.376a
Cext_13060 \$503 \$538 254.864a
Cext_13061 \$503 \$556 0.360462a
Cext_13062 \$503 \$67 110.113a
Cext_13063 \$503 \$77 0.107779a
Cext_13064 \$503 VSS|vss 66.2132a
Cext_13065 \$503 VSUBS 818.74a
Cext_13066 \$504 \$506 2.00331a
Cext_13067 \$504 \$527 102.889a
Cext_13068 \$504 \$540 225.319a
Cext_13069 \$504 \$67 105.694a
Cext_13070 \$504 IOVDD|vdda 11.6291a
Cext_13071 \$504 VSS|vss 60.9228a
Cext_13072 \$504 VSUBS 810.735a
Cext_13073 \$505 \$506 3.0905f
Cext_13074 \$505 \$508 5.60736a
Cext_13075 \$505 \$527 11.9416a
Cext_13076 \$505 \$541 5.04708a
Cext_13077 \$505 \$557 22.3756a
Cext_13078 \$505 \$570 5.60736a
Cext_13079 \$505 \$582 11.7937a
Cext_13080 \$505 \$595 5.04708a
Cext_13081 \$505 \$608 22.7826a
Cext_13082 \$505 \$622 22.3417a
Cext_13083 \$505 \$623 5.60736a
Cext_13084 \$505 \$643 11.8276a
Cext_13085 \$505 \$645 5.04708a
Cext_13086 \$505 \$673 5.60736a
Cext_13087 \$505 \$689 11.7937a
Cext_13088 \$505 \$69 81.9637a
Cext_13089 \$505 \$691 5.04708a
Cext_13090 \$505 \$71 18.0277a
Cext_13091 \$505 \$714 439.952a
Cext_13092 \$505 \$715 5.60736a
Cext_13093 \$505 \$73 7.9638a
Cext_13094 \$505 \$734 14.2573a
Cext_13095 \$505 \$75 48.4427a
Cext_13096 \$505 \$751 27.235a
Cext_13097 \$505 \$752 5.04708a
Cext_13098 \$505 \$765 5.60736a
Cext_13099 \$505 \$77 49.139a
Cext_13100 \$505 \$783 14.2234a
Cext_13101 \$505 \$784 5.04708a
Cext_13102 \$505 \$810 140.731a
Cext_13103 \$505 \$811 5.60736a
Cext_13104 \$505 \$829 15.6091a
Cext_13105 \$505 \$831 5.04708a
Cext_13106 \$505 \$857 5.60736a
Cext_13107 \$505 \$867 68.5573a
Cext_13108 \$505 \$875 2.6225a
Cext_13109 \$505 \$876 4.2052a
Cext_13110 \$505 \$888 136.817a
Cext_13111 \$505 IOVDD|vdda 14.2205a
Cext_13112 \$505 VSS|vss 0.88514a
Cext_13113 \$505 VSUBS 879.908a
Cext_13114 \$506 \$508 0.179323a
Cext_13115 \$506 \$527 75.7894a
Cext_13116 \$506 \$557 223.573a
Cext_13117 \$506 \$582 17.8937a
Cext_13118 \$506 \$608 1.55447f
Cext_13119 \$506 \$622 29.1901a
Cext_13120 \$506 \$643 15.464a
Cext_13121 \$506 \$67 1.69277a
Cext_13122 \$506 \$689 15.578a
Cext_13123 \$506 \$69 71.8063a
Cext_13124 \$506 \$71 18.5253a
Cext_13125 \$506 \$714 99.1454a
Cext_13126 \$506 \$73 62.4106a
Cext_13127 \$506 \$734 0.250757a
Cext_13128 \$506 \$75 2.44188a
Cext_13129 \$506 \$77 0.959093a
Cext_13130 \$506 IOVDD|vdda 10.7759a
Cext_13131 \$506 VSUBS 249.512a
Cext_13132 \$507 \$508 102.889a
Cext_13133 \$507 \$528 0.227961a
Cext_13134 \$507 \$541 0.360462a
Cext_13135 \$507 \$558 42.153a
Cext_13136 \$507 \$67 69.937a
Cext_13137 \$507 \$69 117.37a
Cext_13138 \$507 \$71 31.3588a
Cext_13139 \$507 \$73 32.5775a
Cext_13140 \$507 \$75 37.9814a
Cext_13141 \$507 \$77 45.8508a
Cext_13142 \$507 VSS|vss 0.335662a
Cext_13143 \$507 VSUBS 259.376a
Cext_13144 \$508 \$541 254.864a
Cext_13145 \$508 \$558 0.360462a
Cext_13146 \$508 \$67 110.113a
Cext_13147 \$508 \$77 0.107779a
Cext_13148 \$508 VSS|vss 66.2132a
Cext_13149 \$508 VSUBS 818.74a
Cext_13150 \$509 \$543 130.105a
Cext_13151 \$509 VSS|vss 2.2008a
Cext_13152 \$509 VSUBS 674.939a
Cext_13153 \$51 \$514 22.8071a
Cext_13154 \$51 \$515 2.17385a
Cext_13155 \$51 \$516 0.604961a
Cext_13156 \$51 \$517 134.708a
Cext_13157 \$51 \$518 23.4429a
Cext_13158 \$51 \$519 22.8071a
Cext_13159 \$51 \$52 41.8224a
Cext_13160 \$51 \$520 2.17385a
Cext_13161 \$51 \$521 0.604961a
Cext_13162 \$51 \$522 134.708a
Cext_13163 \$51 \$523 23.4429a
Cext_13164 \$51 \$529 134.708a
Cext_13165 \$51 \$53 62.7514a
Cext_13166 \$51 \$530 0.621099a
Cext_13167 \$51 \$531 134.561a
Cext_13168 \$51 \$532 0.621099a
Cext_13169 \$51 \$548 68.8031a
Cext_13170 \$51 \$549 68.8428a
Cext_13171 \$51 \$55 41.5709a
Cext_13172 \$51 \$550 2.39761a
Cext_13173 \$51 \$551 68.8031a
Cext_13174 \$51 \$552 68.8428a
Cext_13175 \$51 \$553 2.39761a
Cext_13176 \$51 \$559 3.05553a
Cext_13177 \$51 \$560 123.657a
Cext_13178 \$51 \$561 3.05553a
Cext_13179 \$51 \$562 123.657a
Cext_13180 \$51 \$57 38.4357a
Cext_13181 \$51 \$576 22.6915a
Cext_13182 \$51 \$577 23.2117a
Cext_13183 \$51 \$578 22.6915a
Cext_13184 \$51 \$579 23.2117a
Cext_13185 \$51 \$584 123.657a
Cext_13186 \$51 \$585 0.592076a
Cext_13187 \$51 \$586 123.51a
Cext_13188 \$51 \$587 0.592076a
Cext_13189 \$51 \$59 34.7033a
Cext_13190 \$51 \$601 69.0342a
Cext_13191 \$51 \$602 68.7272a
Cext_13192 \$51 \$603 69.0342a
Cext_13193 \$51 \$604 68.7272a
Cext_13194 \$51 \$61 49.4131a
Cext_13195 \$51 \$610 2.65407a
Cext_13196 \$51 \$611 134.708a
Cext_13197 \$51 \$612 2.65407a
Cext_13198 \$51 \$613 134.708a
Cext_13199 \$51 \$628 22.8071a
Cext_13200 \$51 \$629 0.496172a
Cext_13201 \$51 \$63 24.7948a
Cext_13202 \$51 \$630 23.4429a
Cext_13203 \$51 \$631 22.8071a
Cext_13204 \$51 \$632 0.496172a
Cext_13205 \$51 \$633 23.4429a
Cext_13206 \$51 \$65 47.4821a
Cext_13207 \$51 \$652 134.708a
Cext_13208 \$51 \$653 68.8031a
Cext_13209 \$51 \$654 68.8428a
Cext_13210 \$51 \$655 0.564032a
Cext_13211 \$51 \$656 2.95962a
Cext_13212 \$51 \$657 134.561a
Cext_13213 \$51 \$658 68.8031a
Cext_13214 \$51 \$659 68.8428a
Cext_13215 \$51 \$660 0.564032a
Cext_13216 \$51 \$661 2.95962a
Cext_13217 \$51 \$664 123.657a
Cext_13218 \$51 \$665 123.657a
Cext_13219 \$51 \$678 22.6915a
Cext_13220 \$51 \$679 23.2117a
Cext_13221 \$51 \$680 22.6915a
Cext_13222 \$51 \$681 23.2117a
Cext_13223 \$51 \$696 69.0342a
Cext_13224 \$51 \$697 123.657a
Cext_13225 \$51 \$698 68.7272a
Cext_13226 \$51 \$699 69.0342a
Cext_13227 \$51 \$700 123.51a
Cext_13228 \$51 \$701 68.7272a
Cext_13229 \$51 \$704 134.708a
Cext_13230 \$51 \$705 134.708a
Cext_13231 \$51 \$720 22.8071a
Cext_13232 \$51 \$721 0.564032a
Cext_13233 \$51 \$722 23.4429a
Cext_13234 \$51 \$723 22.8071a
Cext_13235 \$51 \$724 0.564032a
Cext_13236 \$51 \$725 23.4429a
Cext_13237 \$51 \$741 68.8031a
Cext_13238 \$51 \$742 134.708a
Cext_13239 \$51 \$743 68.8428a
Cext_13240 \$51 \$744 2.65407a
Cext_13241 \$51 \$745 134.561a
Cext_13242 \$51 \$746 68.8031a
Cext_13243 \$51 \$747 68.8428a
Cext_13244 \$51 \$748 2.65407a
Cext_13245 \$51 \$754 3.05553a
Cext_13246 \$51 \$755 123.657a
Cext_13247 \$51 \$756 3.05553a
Cext_13248 \$51 \$757 123.657a
Cext_13249 \$51 \$770 22.6915a
Cext_13250 \$51 \$771 23.2117a
Cext_13251 \$51 \$772 22.6915a
Cext_13252 \$51 \$773 23.2117a
Cext_13253 \$51 \$790 123.657a
Cext_13254 \$51 \$791 69.0342a
Cext_13255 \$51 \$792 68.7272a
Cext_13256 \$51 \$793 0.592076a
Cext_13257 \$51 \$794 123.51a
Cext_13258 \$51 \$795 69.0342a
Cext_13259 \$51 \$796 68.7272a
Cext_13260 \$51 \$797 0.592076a
Cext_13261 \$51 \$800 134.708a
Cext_13262 \$51 \$801 134.708a
Cext_13263 \$51 \$816 22.8071a
Cext_13264 \$51 \$817 0.496172a
Cext_13265 \$51 \$818 23.4429a
Cext_13266 \$51 \$819 22.8071a
Cext_13267 \$51 \$82 69.1586a
Cext_13268 \$51 \$820 0.496172a
Cext_13269 \$51 \$821 23.4429a
Cext_13270 \$51 \$83 37.0303f
Cext_13271 \$51 \$837 134.708a
Cext_13272 \$51 \$838 68.8031a
Cext_13273 \$51 \$839 68.8428a
Cext_13274 \$51 \$84 10.2105a
Cext_13275 \$51 \$840 2.95962a
Cext_13276 \$51 \$841 68.8031a
Cext_13277 \$51 \$842 134.561a
Cext_13278 \$51 \$843 68.8428a
Cext_13279 \$51 \$844 2.95962a
Cext_13280 \$51 \$848 123.657a
Cext_13281 \$51 \$849 123.657a
Cext_13282 \$51 \$85 16.2891f
Cext_13283 \$51 \$862 22.6915a
Cext_13284 \$51 \$863 23.2117a
Cext_13285 \$51 \$864 22.6915a
Cext_13286 \$51 \$865 23.2117a
Cext_13287 \$51 \$868 123.657a
Cext_13288 \$51 \$869 123.51a
Cext_13289 \$51 \$87 90.8917a
Cext_13290 \$51 \$881 69.0342a
Cext_13291 \$51 \$882 68.7272a
Cext_13292 \$51 \$883 69.0342a
Cext_13293 \$51 \$884 68.7272a
Cext_13294 \$51 \$89 117.534a
Cext_13295 \$51 \$890 138.583a
Cext_13296 \$51 \$891 134.708a
Cext_13297 \$51 \$892 54.4046a
Cext_13298 \$51 \$893 134.708a
Cext_13299 \$51 \$906 22.8071a
Cext_13300 \$51 \$907 23.4429a
Cext_13301 \$51 \$908 22.8071a
Cext_13302 \$51 \$909 23.4429a
Cext_13303 \$51 \$91 187.009a
Cext_13304 \$51 \$926 68.8031a
Cext_13305 \$51 \$927 134.708a
Cext_13306 \$51 \$928 68.8428a
Cext_13307 \$51 \$929 71.5528a
Cext_13308 \$51 \$93 72.5365f
Cext_13309 \$51 \$930 68.8031a
Cext_13310 \$51 \$931 134.561a
Cext_13311 \$51 \$932 68.8428a
Cext_13312 \$51 \$933 3.26094a
Cext_13313 \$51 \$938 3.05553a
Cext_13314 \$51 \$939 123.657a
Cext_13315 \$51 \$940 3.05553a
Cext_13316 \$51 \$941 123.657a
Cext_13317 \$51 \$95 24.6843a
Cext_13318 \$51 \$954 22.6915a
Cext_13319 \$51 \$955 23.2117a
Cext_13320 \$51 \$956 22.6915a
Cext_13321 \$51 \$957 23.2117a
Cext_13322 \$51 \$97 26.1111a
Cext_13323 \$51 \$970 123.657a
Cext_13324 \$51 \$971 69.0342a
Cext_13325 \$51 \$972 68.7272a
Cext_13326 \$51 \$973 0.592076a
Cext_13327 \$51 \$974 123.51a
Cext_13328 \$51 \$975 69.0342a
Cext_13329 \$51 \$976 68.7272a
Cext_13330 \$51 \$977 0.479522a
Cext_13331 \$51 \$988 2.65407a
Cext_13332 \$51 \$989 134.708a
Cext_13333 \$51 \$990 2.65407a
Cext_13334 \$51 \$991 134.681a
Cext_13335 \$51 d1|dac_hard[1] 28.2212a
Cext_13336 \$51 IOVDD|vdda 1.52738f
Cext_13337 \$51 VDD|vdd 5.43972a
Cext_13338 \$51 VREF|vref 8.82156a
Cext_13339 \$51 VSS|vss 699.413a
Cext_13340 \$51 VSUBS 58.6345f
Cext_13341 \$510 \$511 45.0654a
Cext_13342 \$510 \$544 130.128a
Cext_13343 \$510 VDD|vdd 0.592094a
Cext_13344 \$510 VSS|vss 25.1792a
Cext_13345 \$510 VSUBS 659.267a
Cext_13346 \$511 \$512 45.0654a
Cext_13347 \$511 \$545 130.175a
Cext_13348 \$511 VSS|vss 5.452a
Cext_13349 \$511 VSUBS 634.529a
Cext_13350 \$512 \$513 45.0654a
Cext_13351 \$512 \$546 130.175a
Cext_13352 \$512 VSUBS 634.529a
Cext_13353 \$513 \$514 45.8951a
Cext_13354 \$513 \$547 130.175a
Cext_13355 \$513 VSS|vss 0.428128a
Cext_13356 \$513 VSUBS 634.529a
Cext_13357 \$514 \$516 2.00331a
Cext_13358 \$514 \$529 102.889a
Cext_13359 \$514 \$548 225.319a
Cext_13360 \$514 \$83 105.694a
Cext_13361 \$514 VSS|vss 61.1015a
Cext_13362 \$514 VSUBS 794.296a
Cext_13363 \$515 \$516 3.0905f
Cext_13364 \$515 \$518 5.60736a
Cext_13365 \$515 \$529 11.9416a
Cext_13366 \$515 \$53 471.14a
Cext_13367 \$515 \$549 5.04708a
Cext_13368 \$515 \$55 150.036a
Cext_13369 \$515 \$559 22.3756a
Cext_13370 \$515 \$57 84.9076a
Cext_13371 \$515 \$577 5.60736a
Cext_13372 \$515 \$584 11.7937a
Cext_13373 \$515 \$59 105.656a
Cext_13374 \$515 \$602 5.04708a
Cext_13375 \$515 \$61 25.3297a
Cext_13376 \$515 \$610 22.7826a
Cext_13377 \$515 \$629 22.3417a
Cext_13378 \$515 \$630 5.60736a
Cext_13379 \$515 \$652 11.8276a
Cext_13380 \$515 \$654 5.04708a
Cext_13381 \$515 \$679 5.60736a
Cext_13382 \$515 \$697 11.7937a
Cext_13383 \$515 \$698 5.04708a
Cext_13384 \$515 \$721 439.952a
Cext_13385 \$515 \$722 5.60736a
Cext_13386 \$515 \$742 14.2573a
Cext_13387 \$515 \$743 5.04708a
Cext_13388 \$515 \$754 27.235a
Cext_13389 \$515 \$771 5.60736a
Cext_13390 \$515 \$790 14.2234a
Cext_13391 \$515 \$792 5.04708a
Cext_13392 \$515 \$817 140.731a
Cext_13393 \$515 \$818 5.60736a
Cext_13394 \$515 \$837 15.6091a
Cext_13395 \$515 \$839 5.04708a
Cext_13396 \$515 \$85 81.9637a
Cext_13397 \$515 \$863 5.60736a
Cext_13398 \$515 \$868 68.5573a
Cext_13399 \$515 \$87 18.0277a
Cext_13400 \$515 \$881 2.6225a
Cext_13401 \$515 \$882 4.2052a
Cext_13402 \$515 \$89 7.9638a
Cext_13403 \$515 \$890 136.817a
Cext_13404 \$515 \$91 48.4427a
Cext_13405 \$515 \$93 49.139a
Cext_13406 \$515 VSS|vss 0.88514a
Cext_13407 \$515 VSUBS 879.908a
Cext_13408 \$516 \$518 0.179323a
Cext_13409 \$516 \$529 75.7894a
Cext_13410 \$516 \$53 88.8335a
Cext_13411 \$516 \$55 7.30318a
Cext_13412 \$516 \$559 223.573a
Cext_13413 \$516 \$57 46.0291a
Cext_13414 \$516 \$584 17.8937a
Cext_13415 \$516 \$59 47.2301a
Cext_13416 \$516 \$610 1.55447f
Cext_13417 \$516 \$629 29.1901a
Cext_13418 \$516 \$652 15.464a
Cext_13419 \$516 \$697 15.578a
Cext_13420 \$516 \$721 99.1454a
Cext_13421 \$516 \$742 0.250757a
Cext_13422 \$516 \$83 1.69277a
Cext_13423 \$516 \$85 71.8063a
Cext_13424 \$516 \$87 18.5253a
Cext_13425 \$516 \$89 62.4106a
Cext_13426 \$516 \$91 2.44188a
Cext_13427 \$516 \$93 0.959093a
Cext_13428 \$516 VSUBS 249.512a
Cext_13429 \$517 \$518 102.889a
Cext_13430 \$517 \$53 19.3729a
Cext_13431 \$517 \$530 0.227961a
Cext_13432 \$517 \$549 0.360462a
Cext_13433 \$517 \$560 42.153a
Cext_13434 \$517 \$59 1.32172a
Cext_13435 \$517 \$83 69.937a
Cext_13436 \$517 \$85 117.37a
Cext_13437 \$517 \$87 31.3588a
Cext_13438 \$517 \$89 32.5775a
Cext_13439 \$517 \$91 37.9814a
Cext_13440 \$517 \$93 45.8508a
Cext_13441 \$517 VSS|vss 0.335662a
Cext_13442 \$517 VSUBS 259.376a
Cext_13443 \$518 \$549 254.864a
Cext_13444 \$518 \$55 0.105966a
Cext_13445 \$518 \$560 0.360462a
Cext_13446 \$518 \$57 0.282145a
Cext_13447 \$518 \$59 0.640494a
Cext_13448 \$518 \$61 20.9159a
Cext_13449 \$518 \$83 110.113a
Cext_13450 \$518 \$93 0.107779a
Cext_13451 \$518 VSS|vss 66.2132a
Cext_13452 \$518 VSUBS 818.74a
Cext_13453 \$519 \$521 2.00331a
Cext_13454 \$519 \$531 102.889a
Cext_13455 \$519 \$551 225.319a
Cext_13456 \$519 \$57 0.115752a
Cext_13457 \$519 \$59 1.32073a
Cext_13458 \$519 \$61 20.9928a
Cext_13459 \$519 \$83 105.694a
Cext_13460 \$519 IOVDD|vdda 11.6291a
Cext_13461 \$519 VSS|vss 60.9228a
Cext_13462 \$519 VSUBS 810.735a
Cext_13463 \$52 \$53 602.158a
Cext_13464 \$52 \$54 2.13277a
Cext_13465 \$52 \$63 0.110435a
Cext_13466 \$52 \$65 24.0132a
Cext_13467 \$52 \$83 29.0633a
Cext_13468 \$52 \$84 902.785a
Cext_13469 \$52 \$85 0.237316a
Cext_13470 \$52 \$97 0.127512a
Cext_13471 \$52 d1|dac_hard[1] 130.648a
Cext_13472 \$52 IOVDD|vdda 173.852a
Cext_13473 \$52 VDD|vdd 10.4718a
Cext_13474 \$52 VSS|vss 446.394a
Cext_13475 \$52 VSUBS 1.51046f
Cext_13476 \$520 \$521 3.0905f
Cext_13477 \$520 \$523 5.60736a
Cext_13478 \$520 \$53 471.14a
Cext_13479 \$520 \$531 11.9416a
Cext_13480 \$520 \$55 150.036a
Cext_13481 \$520 \$552 5.04708a
Cext_13482 \$520 \$561 22.3756a
Cext_13483 \$520 \$57 84.9076a
Cext_13484 \$520 \$579 5.60736a
Cext_13485 \$520 \$586 11.7937a
Cext_13486 \$520 \$59 105.656a
Cext_13487 \$520 \$604 5.04708a
Cext_13488 \$520 \$61 25.3297a
Cext_13489 \$520 \$612 22.7826a
Cext_13490 \$520 \$632 22.3417a
Cext_13491 \$520 \$633 5.60736a
Cext_13492 \$520 \$657 11.8276a
Cext_13493 \$520 \$659 5.04708a
Cext_13494 \$520 \$681 5.60736a
Cext_13495 \$520 \$700 11.7937a
Cext_13496 \$520 \$701 5.04708a
Cext_13497 \$520 \$724 439.952a
Cext_13498 \$520 \$725 5.60736a
Cext_13499 \$520 \$745 14.2573a
Cext_13500 \$520 \$747 5.04708a
Cext_13501 \$520 \$756 27.235a
Cext_13502 \$520 \$773 5.60736a
Cext_13503 \$520 \$794 14.2234a
Cext_13504 \$520 \$796 5.04708a
Cext_13505 \$520 \$820 140.731a
Cext_13506 \$520 \$821 5.60736a
Cext_13507 \$520 \$842 15.6091a
Cext_13508 \$520 \$843 5.04708a
Cext_13509 \$520 \$85 81.9637a
Cext_13510 \$520 \$865 5.60736a
Cext_13511 \$520 \$869 68.5573a
Cext_13512 \$520 \$87 18.0277a
Cext_13513 \$520 \$883 2.6225a
Cext_13514 \$520 \$884 4.2052a
Cext_13515 \$520 \$89 7.9638a
Cext_13516 \$520 \$892 136.817a
Cext_13517 \$520 \$91 48.4427a
Cext_13518 \$520 \$93 49.139a
Cext_13519 \$520 IOVDD|vdda 14.2205a
Cext_13520 \$520 VSS|vss 179.405a
Cext_13521 \$520 VSUBS 879.908a
Cext_13522 \$521 \$523 0.179323a
Cext_13523 \$521 \$53 88.8335a
Cext_13524 \$521 \$531 75.7894a
Cext_13525 \$521 \$55 7.30318a
Cext_13526 \$521 \$561 223.573a
Cext_13527 \$521 \$57 46.0291a
Cext_13528 \$521 \$586 17.8937a
Cext_13529 \$521 \$59 47.2301a
Cext_13530 \$521 \$612 1.55447f
Cext_13531 \$521 \$632 29.1901a
Cext_13532 \$521 \$657 15.464a
Cext_13533 \$521 \$700 15.578a
Cext_13534 \$521 \$724 99.1454a
Cext_13535 \$521 \$745 0.250757a
Cext_13536 \$521 \$83 1.69277a
Cext_13537 \$521 \$85 71.8063a
Cext_13538 \$521 \$87 18.5253a
Cext_13539 \$521 \$89 62.4106a
Cext_13540 \$521 \$91 2.44188a
Cext_13541 \$521 \$93 0.959093a
Cext_13542 \$521 IOVDD|vdda 10.7759a
Cext_13543 \$521 VSS|vss 27.1233a
Cext_13544 \$521 VSUBS 249.512a
Cext_13545 \$522 \$523 102.889a
Cext_13546 \$522 \$53 19.3729a
Cext_13547 \$522 \$532 0.227961a
Cext_13548 \$522 \$552 0.360462a
Cext_13549 \$522 \$562 42.153a
Cext_13550 \$522 \$59 1.32172a
Cext_13551 \$522 \$83 69.937a
Cext_13552 \$522 \$85 117.37a
Cext_13553 \$522 \$87 31.3588a
Cext_13554 \$522 \$89 32.5775a
Cext_13555 \$522 \$91 37.9814a
Cext_13556 \$522 \$93 45.8508a
Cext_13557 \$522 VSS|vss 0.335662a
Cext_13558 \$522 VSUBS 259.376a
Cext_13559 \$523 \$55 0.105966a
Cext_13560 \$523 \$552 254.864a
Cext_13561 \$523 \$562 0.360462a
Cext_13562 \$523 \$57 0.282145a
Cext_13563 \$523 \$59 0.640494a
Cext_13564 \$523 \$61 20.9159a
Cext_13565 \$523 \$83 110.113a
Cext_13566 \$523 \$93 0.107779a
Cext_13567 \$523 VSS|vss 75.3227a
Cext_13568 \$523 VSUBS 818.74a
Cext_13569 \$524 \$554 130.105a
Cext_13570 \$524 \$57 0.115752a
Cext_13571 \$524 \$59 1.32073a
Cext_13572 \$524 \$61 21.1432a
Cext_13573 \$524 VSS|vss 2.2008a
Cext_13574 \$524 VSUBS 674.939a
Cext_13575 \$525 \$537 114.006a
Cext_13576 \$525 \$538 0.182933a
Cext_13577 \$525 \$555 98.5952a
Cext_13578 \$525 \$567 0.360462a
Cext_13579 \$525 \$580 108.267a
Cext_13580 \$525 \$67 69.9941a
Cext_13581 \$525 \$69 117.37a
Cext_13582 \$525 \$71 31.3588a
Cext_13583 \$525 \$73 32.5775a
Cext_13584 \$525 \$75 37.9814a
Cext_13585 \$525 \$77 45.7852a
Cext_13586 \$525 VSS|vss 0.378848a
Cext_13587 \$525 VSUBS 259.29a
Cext_13588 \$526 \$539 3.0905f
Cext_13589 \$526 \$540 5.60736a
Cext_13590 \$526 \$556 11.9416a
Cext_13591 \$526 \$569 5.04708a
Cext_13592 \$526 \$581 22.3756a
Cext_13593 \$526 \$594 5.60736a
Cext_13594 \$526 \$607 11.7937a
Cext_13595 \$526 \$621 5.04708a
Cext_13596 \$526 \$641 22.3417a
Cext_13597 \$526 \$642 22.7826a
Cext_13598 \$526 \$644 5.60736a
Cext_13599 \$526 \$662 11.8276a
Cext_13600 \$526 \$67 1.47148a
Cext_13601 \$526 \$672 5.04708a
Cext_13602 \$526 \$69 86.4404a
Cext_13603 \$526 \$690 5.60736a
Cext_13604 \$526 \$702 11.7937a
Cext_13605 \$526 \$71 25.0801a
Cext_13606 \$526 \$713 5.04708a
Cext_13607 \$526 \$73 18.1933a
Cext_13608 \$526 \$733 439.952a
Cext_13609 \$526 \$735 5.60736a
Cext_13610 \$526 \$75 63.9361a
Cext_13611 \$526 \$750 14.2573a
Cext_13612 \$526 \$764 5.04708a
Cext_13613 \$526 \$77 0.92396a
Cext_13614 \$526 \$781 27.235a
Cext_13615 \$526 \$782 5.60736a
Cext_13616 \$526 \$798 14.2234a
Cext_13617 \$526 \$809 5.04708a
Cext_13618 \$526 \$828 140.731a
Cext_13619 \$526 \$830 5.60736a
Cext_13620 \$526 \$846 15.6091a
Cext_13621 \$526 \$856 5.04708a
Cext_13622 \$526 \$875 5.60736a
Cext_13623 \$526 \$887 68.5573a
Cext_13624 \$526 \$899 2.6225a
Cext_13625 \$526 \$900 4.2052a
Cext_13626 \$526 \$917 136.817a
Cext_13627 \$526 VSS|vss 0.88514a
Cext_13628 \$526 VSUBS 878.295a
Cext_13629 \$527 \$540 114.006a
Cext_13630 \$527 \$541 0.182933a
Cext_13631 \$527 \$557 98.5952a
Cext_13632 \$527 \$569 0.360462a
Cext_13633 \$527 \$582 108.267a
Cext_13634 \$527 \$67 69.8469a
Cext_13635 \$527 \$69 117.37a
Cext_13636 \$527 \$71 31.3588a
Cext_13637 \$527 \$73 32.5775a
Cext_13638 \$527 \$75 37.9814a
Cext_13639 \$527 \$77 45.7852a
Cext_13640 \$527 IOVDD|vdda 41.5782a
Cext_13641 \$527 VSS|vss 0.378848a
Cext_13642 \$527 VSUBS 259.016a
Cext_13643 \$528 \$542 3.0905f
Cext_13644 \$528 \$543 3.28995a
Cext_13645 \$528 \$558 11.9416a
Cext_13646 \$528 \$571 3.28995a
Cext_13647 \$528 \$583 22.3756a
Cext_13648 \$528 \$609 11.7937a
Cext_13649 \$528 \$646 22.7826a
Cext_13650 \$528 \$647 22.3417a
Cext_13651 \$528 \$663 11.8276a
Cext_13652 \$528 \$67 1.47148a
Cext_13653 \$528 \$69 87.9835a
Cext_13654 \$528 \$703 11.7937a
Cext_13655 \$528 \$71 25.0801a
Cext_13656 \$528 \$73 18.1933a
Cext_13657 \$528 \$736 439.952a
Cext_13658 \$528 \$75 63.9361a
Cext_13659 \$528 \$753 14.2573a
Cext_13660 \$528 \$77 0.92396a
Cext_13661 \$528 \$785 27.235a
Cext_13662 \$528 \$799 14.2234a
Cext_13663 \$528 \$832 140.731a
Cext_13664 \$528 \$847 15.6091a
Cext_13665 \$528 \$888 0.29053a
Cext_13666 \$528 \$889 68.5573a
Cext_13667 \$528 \$901 2.6225a
Cext_13668 \$528 \$921 136.817a
Cext_13669 \$528 VREF|vref 302.684a
Cext_13670 \$528 VSUBS 724.254a
Cext_13671 \$529 \$53 19.3729a
Cext_13672 \$529 \$548 114.006a
Cext_13673 \$529 \$549 0.182933a
Cext_13674 \$529 \$559 98.5952a
Cext_13675 \$529 \$576 0.360462a
Cext_13676 \$529 \$584 108.267a
Cext_13677 \$529 \$59 1.18572a
Cext_13678 \$529 \$83 69.9941a
Cext_13679 \$529 \$85 117.37a
Cext_13680 \$529 \$87 31.3588a
Cext_13681 \$529 \$89 32.5775a
Cext_13682 \$529 \$91 37.9814a
Cext_13683 \$529 \$93 45.7852a
Cext_13684 \$529 VSS|vss 0.378848a
Cext_13685 \$529 VSUBS 259.29a
Cext_13686 \$53 \$530 466.74a
Cext_13687 \$53 \$531 19.3729a
Cext_13688 \$53 \$532 467.612a
Cext_13689 \$53 \$54 41.8224a
Cext_13690 \$53 \$55 74.5733f
Cext_13691 \$53 \$550 93.4626a
Cext_13692 \$53 \$553 93.4626a
Cext_13693 \$53 \$559 93.8054a
Cext_13694 \$53 \$560 65.5562a
Cext_13695 \$53 \$561 93.8054a
Cext_13696 \$53 \$562 65.5562a
Cext_13697 \$53 \$57 904.302a
Cext_13698 \$53 \$577 0.145978a
Cext_13699 \$53 \$578 0.404672a
Cext_13700 \$53 \$579 0.145978a
Cext_13701 \$53 \$584 65.6459a
Cext_13702 \$53 \$585 82.9986a
Cext_13703 \$53 \$586 65.6459a
Cext_13704 \$53 \$587 82.9986a
Cext_13705 \$53 \$588 0.404672a
Cext_13706 \$53 \$59 472.358a
Cext_13707 \$53 \$61 272.318a
Cext_13708 \$53 \$610 56.2993a
Cext_13709 \$53 \$611 19.3729a
Cext_13710 \$53 \$612 56.2993a
Cext_13711 \$53 \$613 19.3729a
Cext_13712 \$53 \$629 82.9986a
Cext_13713 \$53 \$63 32.0065a
Cext_13714 \$53 \$632 82.9986a
Cext_13715 \$53 \$65 53.223a
Cext_13716 \$53 \$652 19.3729a
Cext_13717 \$53 \$655 51.1437a
Cext_13718 \$53 \$656 90.8871a
Cext_13719 \$53 \$657 19.3729a
Cext_13720 \$53 \$660 51.1437a
Cext_13721 \$53 \$661 90.8871a
Cext_13722 \$53 \$664 65.6459a
Cext_13723 \$53 \$665 65.6459a
Cext_13724 \$53 \$679 0.145978a
Cext_13725 \$53 \$680 0.404672a
Cext_13726 \$53 \$681 0.145978a
Cext_13727 \$53 \$697 65.4666a
Cext_13728 \$53 \$700 65.4666a
Cext_13729 \$53 \$704 19.3729a
Cext_13730 \$53 \$705 19.3729a
Cext_13731 \$53 \$721 53.9723a
Cext_13732 \$53 \$724 53.9723a
Cext_13733 \$53 \$742 19.3729a
Cext_13734 \$53 \$744 59.1279a
Cext_13735 \$53 \$745 19.3729a
Cext_13736 \$53 \$748 59.1279a
Cext_13737 \$53 \$754 91.1126a
Cext_13738 \$53 \$755 65.4666a
Cext_13739 \$53 \$756 91.1126a
Cext_13740 \$53 \$757 65.4666a
Cext_13741 \$53 \$771 0.145978a
Cext_13742 \$53 \$772 0.404672a
Cext_13743 \$53 \$773 0.145978a
Cext_13744 \$53 \$790 65.6459a
Cext_13745 \$53 \$793 82.9986a
Cext_13746 \$53 \$794 65.6459a
Cext_13747 \$53 \$797 82.9986a
Cext_13748 \$53 \$800 19.3729a
Cext_13749 \$53 \$801 19.3729a
Cext_13750 \$53 \$817 82.9075a
Cext_13751 \$53 \$820 82.9075a
Cext_13752 \$53 \$83 226.516a
Cext_13753 \$53 \$837 19.3729a
Cext_13754 \$53 \$84 69.1586a
Cext_13755 \$53 \$840 96.6471a
Cext_13756 \$53 \$842 19.3729a
Cext_13757 \$53 \$844 96.6471a
Cext_13758 \$53 \$848 65.5547a
Cext_13759 \$53 \$849 65.5547a
Cext_13760 \$53 \$85 28.1882f
Cext_13761 \$53 \$86 10.2105a
Cext_13762 \$53 \$863 0.145978a
Cext_13763 \$53 \$864 0.404672a
Cext_13764 \$53 \$865 0.145978a
Cext_13765 \$53 \$868 65.7176a
Cext_13766 \$53 \$869 65.7176a
Cext_13767 \$53 \$87 17.3248f
Cext_13768 \$53 \$89 571.193a
Cext_13769 \$53 \$890 188.337a
Cext_13770 \$53 \$891 19.3729a
Cext_13771 \$53 \$892 117.411a
Cext_13772 \$53 \$893 19.3729a
Cext_13773 \$53 \$91 305.201a
Cext_13774 \$53 \$927 19.3729a
Cext_13775 \$53 \$929 158.912a
Cext_13776 \$53 \$93 189.12a
Cext_13777 \$53 \$931 19.3729a
Cext_13778 \$53 \$933 80.0464a
Cext_13779 \$53 \$938 96.6471a
Cext_13780 \$53 \$939 65.7176a
Cext_13781 \$53 \$940 96.6471a
Cext_13782 \$53 \$941 65.7176a
Cext_13783 \$53 \$95 30.4252a
Cext_13784 \$53 \$955 0.145978a
Cext_13785 \$53 \$956 0.404672a
Cext_13786 \$53 \$957 0.145978a
Cext_13787 \$53 \$97 31.852a
Cext_13788 \$53 \$970 65.5547a
Cext_13789 \$53 \$973 82.9075a
Cext_13790 \$53 \$974 65.5547a
Cext_13791 \$53 \$977 82.8783a
Cext_13792 \$53 \$988 59.1279a
Cext_13793 \$53 \$989 19.3729a
Cext_13794 \$53 \$990 59.1279a
Cext_13795 \$53 \$991 19.3729a
Cext_13796 \$53 d2|dac_hard[2] 28.2212a
Cext_13797 \$53 IOVDD|vdda 867.085a
Cext_13798 \$53 VDD|vdd 5.43972a
Cext_13799 \$53 VREF|vref 47.4125a
Cext_13800 \$53 VSS|vss 769.461a
Cext_13801 \$53 VSUBS 38.3085f
Cext_13802 \$530 \$55 144.117a
Cext_13803 \$530 \$550 3.0905f
Cext_13804 \$530 \$551 5.60736a
Cext_13805 \$530 \$560 11.9416a
Cext_13806 \$530 \$57 76.2695a
Cext_13807 \$530 \$578 5.04708a
Cext_13808 \$530 \$585 22.3756a
Cext_13809 \$530 \$59 87.5622a
Cext_13810 \$530 \$603 5.60736a
Cext_13811 \$530 \$61 73.5447a
Cext_13812 \$530 \$611 11.7937a
Cext_13813 \$530 \$631 5.04708a
Cext_13814 \$530 \$655 22.7826a
Cext_13815 \$530 \$656 22.3417a
Cext_13816 \$530 \$658 5.60736a
Cext_13817 \$530 \$664 11.8276a
Cext_13818 \$530 \$680 5.04708a
Cext_13819 \$530 \$699 5.60736a
Cext_13820 \$530 \$704 11.7937a
Cext_13821 \$530 \$723 5.04708a
Cext_13822 \$530 \$744 439.952a
Cext_13823 \$530 \$746 5.60736a
Cext_13824 \$530 \$755 14.2573a
Cext_13825 \$530 \$772 5.04708a
Cext_13826 \$530 \$793 27.235a
Cext_13827 \$530 \$795 5.60736a
Cext_13828 \$530 \$800 14.2234a
Cext_13829 \$530 \$819 5.04708a
Cext_13830 \$530 \$83 1.47148a
Cext_13831 \$530 \$840 140.731a
Cext_13832 \$530 \$841 5.60736a
Cext_13833 \$530 \$848 15.6091a
Cext_13834 \$530 \$85 86.4404a
Cext_13835 \$530 \$864 5.04708a
Cext_13836 \$530 \$87 25.0801a
Cext_13837 \$530 \$883 5.60736a
Cext_13838 \$530 \$89 18.1933a
Cext_13839 \$530 \$891 68.5573a
Cext_13840 \$530 \$907 2.6225a
Cext_13841 \$530 \$908 4.2052a
Cext_13842 \$530 \$91 63.9361a
Cext_13843 \$530 \$929 136.817a
Cext_13844 \$530 \$93 0.92396a
Cext_13845 \$530 VSS|vss 0.88514a
Cext_13846 \$530 VSUBS 878.295a
Cext_13847 \$531 \$551 114.006a
Cext_13848 \$531 \$552 0.182933a
Cext_13849 \$531 \$561 98.5952a
Cext_13850 \$531 \$578 0.360462a
Cext_13851 \$531 \$586 108.267a
Cext_13852 \$531 \$59 1.18572a
Cext_13853 \$531 \$83 69.8469a
Cext_13854 \$531 \$85 117.37a
Cext_13855 \$531 \$87 31.3588a
Cext_13856 \$531 \$89 32.5775a
Cext_13857 \$531 \$91 37.9814a
Cext_13858 \$531 \$93 45.7852a
Cext_13859 \$531 IOVDD|vdda 41.5782a
Cext_13860 \$531 VSS|vss 3.94618a
Cext_13861 \$531 VSUBS 259.016a
Cext_13862 \$532 \$55 144.386a
Cext_13863 \$532 \$553 3.0905f
Cext_13864 \$532 \$554 3.28995a
Cext_13865 \$532 \$562 11.9416a
Cext_13866 \$532 \$57 77.0051a
Cext_13867 \$532 \$587 22.3756a
Cext_13868 \$532 \$588 3.28995a
Cext_13869 \$532 \$59 88.0101a
Cext_13870 \$532 \$61 75.17a
Cext_13871 \$532 \$613 11.7937a
Cext_13872 \$532 \$660 22.7826a
Cext_13873 \$532 \$661 22.3417a
Cext_13874 \$532 \$665 11.8276a
Cext_13875 \$532 \$705 11.7937a
Cext_13876 \$532 \$748 439.952a
Cext_13877 \$532 \$757 14.2573a
Cext_13878 \$532 \$797 27.235a
Cext_13879 \$532 \$801 14.2234a
Cext_13880 \$532 \$83 1.47148a
Cext_13881 \$532 \$844 140.731a
Cext_13882 \$532 \$849 15.6091a
Cext_13883 \$532 \$85 87.9835a
Cext_13884 \$532 \$87 25.0801a
Cext_13885 \$532 \$89 18.1933a
Cext_13886 \$532 \$892 0.29053a
Cext_13887 \$532 \$893 68.5573a
Cext_13888 \$532 \$909 2.6225a
Cext_13889 \$532 \$91 63.9361a
Cext_13890 \$532 \$93 0.92396a
Cext_13891 \$532 \$933 136.817a
Cext_13892 \$532 VREF|vref 302.684a
Cext_13893 \$532 VSUBS 724.254a
Cext_13894 \$533 \$534 45.0654a
Cext_13895 \$533 \$563 130.175a
Cext_13896 \$533 VDD|vdd 7.74075a
Cext_13897 \$533 VSS|vss 1.71997a
Cext_13898 \$533 VSUBS 659.267a
Cext_13899 \$534 \$535 45.0654a
Cext_13900 \$534 \$564 130.175a
Cext_13901 \$534 VDD|vdd 0.968272a
Cext_13902 \$534 VSUBS 634.529a
Cext_13903 \$535 \$536 45.0654a
Cext_13904 \$535 \$565 130.175a
Cext_13905 \$535 VSUBS 634.529a
Cext_13906 \$536 \$537 46.4004a
Cext_13907 \$536 \$566 130.175a
Cext_13908 \$536 VSS|vss 0.378729a
Cext_13909 \$536 VSUBS 634.529a
Cext_13910 \$537 \$567 254.864a
Cext_13911 \$537 \$580 0.360462a
Cext_13912 \$537 \$67 64.1221a
Cext_13913 \$537 \$69 0.155901a
Cext_13914 \$537 VSS|vss 66.2906a
Cext_13915 \$537 VSUBS 799.746a
Cext_13916 \$538 \$539 2.00331a
Cext_13917 \$538 \$556 102.889a
Cext_13918 \$538 \$568 225.319a
Cext_13919 \$538 \$67 59.1234a
Cext_13920 \$538 \$69 0.343978a
Cext_13921 \$538 VSS|vss 60.9228a
Cext_13922 \$538 VSUBS 811.895a
Cext_13923 \$539 \$540 0.179323a
Cext_13924 \$539 \$556 75.7894a
Cext_13925 \$539 \$581 223.573a
Cext_13926 \$539 \$607 17.8937a
Cext_13927 \$539 \$641 29.1901a
Cext_13928 \$539 \$642 1.55447f
Cext_13929 \$539 \$662 15.464a
Cext_13930 \$539 \$69 66.4794a
Cext_13931 \$539 \$702 15.578a
Cext_13932 \$539 \$71 10.0948a
Cext_13933 \$539 \$73 47.9782a
Cext_13934 \$539 \$733 99.1454a
Cext_13935 \$539 \$75 48.4845a
Cext_13936 \$539 \$750 0.250757a
Cext_13937 \$539 \$77 0.959093a
Cext_13938 \$539 VSUBS 253.372a
Cext_13939 \$54 \$55 602.158a
Cext_13940 \$54 \$56 2.13277a
Cext_13941 \$54 \$63 0.110435a
Cext_13942 \$54 \$65 24.0132a
Cext_13943 \$54 \$85 29.0633a
Cext_13944 \$54 \$86 902.785a
Cext_13945 \$54 \$87 0.237316a
Cext_13946 \$54 \$97 0.127512a
Cext_13947 \$54 d2|dac_hard[2] 130.648a
Cext_13948 \$54 IOVDD|vdda 173.852a
Cext_13949 \$54 VDD|vdd 10.4718a
Cext_13950 \$54 VSS|vss 446.394a
Cext_13951 \$54 VSUBS 1.51046f
Cext_13952 \$540 \$569 254.864a
Cext_13953 \$540 \$582 0.360462a
Cext_13954 \$540 \$67 64.1221a
Cext_13955 \$540 \$69 0.155901a
Cext_13956 \$540 IOVDD|vdda 13.0646a
Cext_13957 \$540 VSS|vss 66.2132a
Cext_13958 \$540 VSUBS 817.169a
Cext_13959 \$541 \$542 2.00331a
Cext_13960 \$541 \$558 102.889a
Cext_13961 \$541 \$570 225.319a
Cext_13962 \$541 \$67 59.1234a
Cext_13963 \$541 \$69 0.343978a
Cext_13964 \$541 VSS|vss 60.9228a
Cext_13965 \$541 VSUBS 811.895a
Cext_13966 \$542 \$543 0.179323a
Cext_13967 \$542 \$558 75.7894a
Cext_13968 \$542 \$583 223.573a
Cext_13969 \$542 \$609 17.8937a
Cext_13970 \$542 \$646 1.55447f
Cext_13971 \$542 \$647 29.1901a
Cext_13972 \$542 \$663 15.464a
Cext_13973 \$542 \$69 66.7423a
Cext_13974 \$542 \$703 15.578a
Cext_13975 \$542 \$71 10.0948a
Cext_13976 \$542 \$73 47.9782a
Cext_13977 \$542 \$736 99.1454a
Cext_13978 \$542 \$75 48.4845a
Cext_13979 \$542 \$753 0.250757a
Cext_13980 \$542 \$77 0.959093a
Cext_13981 \$542 VREF|vref 1.1526a
Cext_13982 \$542 VSUBS 253.619a
Cext_13983 \$543 \$571 130.105a
Cext_13984 \$543 VREF|vref 0.474677a
Cext_13985 \$543 VSS|vss 2.2008a
Cext_13986 \$543 VSUBS 676a
Cext_13987 \$544 \$545 45.0654a
Cext_13988 \$544 \$572 130.128a
Cext_13989 \$544 VDD|vdd 0.592094a
Cext_13990 \$544 VSS|vss 25.1792a
Cext_13991 \$544 VSUBS 659.267a
Cext_13992 \$545 \$546 45.0654a
Cext_13993 \$545 \$573 130.175a
Cext_13994 \$545 VSS|vss 5.452a
Cext_13995 \$545 VSUBS 634.529a
Cext_13996 \$546 \$547 45.0654a
Cext_13997 \$546 \$574 130.175a
Cext_13998 \$546 VSUBS 634.529a
Cext_13999 \$547 \$548 46.4004a
Cext_14000 \$547 \$575 130.175a
Cext_14001 \$547 VSS|vss 0.378729a
Cext_14002 \$547 VSUBS 634.529a
Cext_14003 \$548 \$576 254.864a
Cext_14004 \$548 \$584 0.360462a
Cext_14005 \$548 \$83 64.1221a
Cext_14006 \$548 \$85 0.155901a
Cext_14007 \$548 VSS|vss 66.2906a
Cext_14008 \$548 VSUBS 799.746a
Cext_14009 \$549 \$550 2.00331a
Cext_14010 \$549 \$560 102.889a
Cext_14011 \$549 \$57 0.115752a
Cext_14012 \$549 \$577 225.319a
Cext_14013 \$549 \$59 0.481837a
Cext_14014 \$549 \$61 20.8391a
Cext_14015 \$549 \$83 59.1234a
Cext_14016 \$549 \$85 0.343978a
Cext_14017 \$549 VSS|vss 60.9228a
Cext_14018 \$549 VSUBS 811.895a
Cext_14019 \$55 \$550 14.3029a
Cext_14020 \$55 \$551 0.105966a
Cext_14021 \$55 \$553 14.3029a
Cext_14022 \$55 \$554 0.105966a
Cext_14023 \$55 \$559 1.18748a
Cext_14024 \$55 \$56 41.8224a
Cext_14025 \$55 \$561 1.18748a
Cext_14026 \$55 \$57 74.0908f
Cext_14027 \$55 \$577 0.105966a
Cext_14028 \$55 \$579 0.105966a
Cext_14029 \$55 \$584 0.62262a
Cext_14030 \$55 \$585 47.3198a
Cext_14031 \$55 \$586 0.62262a
Cext_14032 \$55 \$587 47.3198a
Cext_14033 \$55 \$59 357.758a
Cext_14034 \$55 \$603 0.105966a
Cext_14035 \$55 \$61 213.866a
Cext_14036 \$55 \$610 56.2856a
Cext_14037 \$55 \$611 1.40263a
Cext_14038 \$55 \$612 56.2856a
Cext_14039 \$55 \$613 1.40263a
Cext_14040 \$55 \$629 47.2301a
Cext_14041 \$55 \$63 32.2651a
Cext_14042 \$55 \$630 0.251943a
Cext_14043 \$55 \$631 0.500702a
Cext_14044 \$55 \$632 47.2301a
Cext_14045 \$55 \$633 0.251943a
Cext_14046 \$55 \$65 53.223a
Cext_14047 \$55 \$652 1.18572a
Cext_14048 \$55 \$655 46.0291a
Cext_14049 \$55 \$656 1.18748a
Cext_14050 \$55 \$657 1.18572a
Cext_14051 \$55 \$658 0.105966a
Cext_14052 \$55 \$660 46.0291a
Cext_14053 \$55 \$661 1.18748a
Cext_14054 \$55 \$664 0.62262a
Cext_14055 \$55 \$665 0.62262a
Cext_14056 \$55 \$679 0.105966a
Cext_14057 \$55 \$681 0.105966a
Cext_14058 \$55 \$699 0.105966a
Cext_14059 \$55 \$721 45.938a
Cext_14060 \$55 \$722 0.105966a
Cext_14061 \$55 \$724 45.938a
Cext_14062 \$55 \$725 0.105966a
Cext_14063 \$55 \$744 59.2756a
Cext_14064 \$55 \$746 0.105966a
Cext_14065 \$55 \$748 59.2756a
Cext_14066 \$55 \$754 1.18748a
Cext_14067 \$55 \$756 1.18748a
Cext_14068 \$55 \$771 0.105966a
Cext_14069 \$55 \$773 0.105966a
Cext_14070 \$55 \$790 0.62262a
Cext_14071 \$55 \$793 47.1389a
Cext_14072 \$55 \$794 0.62262a
Cext_14073 \$55 \$795 0.105966a
Cext_14074 \$55 \$797 47.1389a
Cext_14075 \$55 \$800 1.18572a
Cext_14076 \$55 \$801 1.18572a
Cext_14077 \$55 \$817 47.4812a
Cext_14078 \$55 \$818 0.251943a
Cext_14079 \$55 \$819 0.500702a
Cext_14080 \$55 \$820 47.4812a
Cext_14081 \$55 \$821 0.251943a
Cext_14082 \$55 \$83 92.0201a
Cext_14083 \$55 \$837 1.55928a
Cext_14084 \$55 \$840 1.18748a
Cext_14085 \$55 \$841 0.105966a
Cext_14086 \$55 \$842 1.55928a
Cext_14087 \$55 \$844 1.18748a
Cext_14088 \$55 \$848 0.62262a
Cext_14089 \$55 \$849 0.62262a
Cext_14090 \$55 \$85 1.18746f
Cext_14091 \$55 \$86 69.1586a
Cext_14092 \$55 \$863 0.105966a
Cext_14093 \$55 \$865 0.105966a
Cext_14094 \$55 \$87 19.6578f
Cext_14095 \$55 \$88 10.2105a
Cext_14096 \$55 \$883 0.105966a
Cext_14097 \$55 \$89 16.3032f
Cext_14098 \$55 \$890 122.567a
Cext_14099 \$55 \$892 66.7447a
Cext_14100 \$55 \$907 0.105966a
Cext_14101 \$55 \$909 0.105966a
Cext_14102 \$55 \$91 63.0815a
Cext_14103 \$55 \$929 94.3332a
Cext_14104 \$55 \$93 66.9619a
Cext_14105 \$55 \$930 0.105966a
Cext_14106 \$55 \$933 28.0853a
Cext_14107 \$55 \$938 1.18748a
Cext_14108 \$55 \$940 1.18748a
Cext_14109 \$55 \$95 30.7374a
Cext_14110 \$55 \$955 0.105966a
Cext_14111 \$55 \$957 0.105966a
Cext_14112 \$55 \$97 31.852a
Cext_14113 \$55 \$970 0.62262a
Cext_14114 \$55 \$973 47.4812a
Cext_14115 \$55 \$974 0.62262a
Cext_14116 \$55 \$975 0.105966a
Cext_14117 \$55 \$977 47.4812a
Cext_14118 \$55 \$988 59.2756a
Cext_14119 \$55 \$989 1.55928a
Cext_14120 \$55 \$990 59.2756a
Cext_14121 \$55 \$991 1.55928a
Cext_14122 \$55 d3|dac_hard[3] 28.2212a
Cext_14123 \$55 IOVDD|vdda 783.731a
Cext_14124 \$55 VDD|vdd 5.43972a
Cext_14125 \$55 VREF|vref 49.4261a
Cext_14126 \$55 VSS|vss 1.06298f
Cext_14127 \$55 VSUBS 23.2541f
Cext_14128 \$550 \$551 0.179323a
Cext_14129 \$550 \$560 75.7894a
Cext_14130 \$550 \$57 58.4605a
Cext_14131 \$550 \$585 223.573a
Cext_14132 \$550 \$59 1.18748a
Cext_14133 \$550 \$611 17.8937a
Cext_14134 \$550 \$655 1.55447f
Cext_14135 \$550 \$656 29.1901a
Cext_14136 \$550 \$664 15.464a
Cext_14137 \$550 \$704 15.578a
Cext_14138 \$550 \$744 99.1454a
Cext_14139 \$550 \$755 0.250757a
Cext_14140 \$550 \$85 66.4794a
Cext_14141 \$550 \$87 10.0948a
Cext_14142 \$550 \$89 47.9782a
Cext_14143 \$550 \$91 48.4845a
Cext_14144 \$550 \$93 0.959093a
Cext_14145 \$550 VSUBS 253.372a
Cext_14146 \$551 \$57 0.282145a
Cext_14147 \$551 \$578 254.864a
Cext_14148 \$551 \$586 0.360462a
Cext_14149 \$551 \$59 0.494517a
Cext_14150 \$551 \$61 20.9159a
Cext_14151 \$551 \$83 64.1221a
Cext_14152 \$551 \$85 0.155901a
Cext_14153 \$551 IOVDD|vdda 13.0646a
Cext_14154 \$551 VSS|vss 66.2132a
Cext_14155 \$551 VSUBS 817.169a
Cext_14156 \$552 \$553 2.00331a
Cext_14157 \$552 \$562 102.889a
Cext_14158 \$552 \$57 0.115752a
Cext_14159 \$552 \$579 225.319a
Cext_14160 \$552 \$59 0.481837a
Cext_14161 \$552 \$61 20.8391a
Cext_14162 \$552 \$83 59.1234a
Cext_14163 \$552 \$85 0.343978a
Cext_14164 \$552 VSS|vss 69.9251a
Cext_14165 \$552 VSUBS 811.895a
Cext_14166 \$553 \$554 0.179323a
Cext_14167 \$553 \$562 75.7894a
Cext_14168 \$553 \$57 58.4605a
Cext_14169 \$553 \$587 223.573a
Cext_14170 \$553 \$59 1.18748a
Cext_14171 \$553 \$613 17.8937a
Cext_14172 \$553 \$660 1.55447f
Cext_14173 \$553 \$661 29.1901a
Cext_14174 \$553 \$665 15.464a
Cext_14175 \$553 \$705 15.578a
Cext_14176 \$553 \$748 99.1454a
Cext_14177 \$553 \$757 0.250757a
Cext_14178 \$553 \$85 66.7423a
Cext_14179 \$553 \$87 10.0948a
Cext_14180 \$553 \$89 47.9782a
Cext_14181 \$553 \$91 48.4845a
Cext_14182 \$553 \$93 0.959093a
Cext_14183 \$553 VREF|vref 1.1526a
Cext_14184 \$553 VSUBS 253.619a
Cext_14185 \$554 \$57 0.282145a
Cext_14186 \$554 \$588 130.105a
Cext_14187 \$554 \$59 0.494517a
Cext_14188 \$554 \$61 21.0663a
Cext_14189 \$554 VREF|vref 0.474677a
Cext_14190 \$554 VSS|vss 2.2008a
Cext_14191 \$554 VSUBS 676a
Cext_14192 \$555 \$580 230.002a
Cext_14193 \$555 \$592 3.25406a
Cext_14194 \$555 \$593 0.179323a
Cext_14195 \$555 \$606 99.1454a
Cext_14196 \$555 \$619 7.41179a
Cext_14197 \$555 \$69 106.353a
Cext_14198 \$555 \$71 53.6239a
Cext_14199 \$555 \$73 3.34353a
Cext_14200 \$555 \$75 1.94351a
Cext_14201 \$555 \$77 1.13718a
Cext_14202 \$555 VSUBS 177.911a
Cext_14203 \$556 \$568 114.006a
Cext_14204 \$556 \$569 0.182933a
Cext_14205 \$556 \$581 98.5952a
Cext_14206 \$556 \$593 0.360462a
Cext_14207 \$556 \$607 108.267a
Cext_14208 \$556 \$67 80.1821a
Cext_14209 \$556 \$69 70.7638a
Cext_14210 \$556 \$71 31.3588a
Cext_14211 \$556 \$73 32.5775a
Cext_14212 \$556 \$75 39.7349a
Cext_14213 \$556 \$77 45.7852a
Cext_14214 \$556 VSS|vss 0.378848a
Cext_14215 \$556 VSUBS 259.207a
Cext_14216 \$557 \$582 230.002a
Cext_14217 \$557 \$594 3.25406a
Cext_14218 \$557 \$595 0.179323a
Cext_14219 \$557 \$608 99.1454a
Cext_14220 \$557 \$622 7.41179a
Cext_14221 \$557 \$69 106.353a
Cext_14222 \$557 \$71 53.6239a
Cext_14223 \$557 \$73 3.34353a
Cext_14224 \$557 \$75 1.94351a
Cext_14225 \$557 \$77 1.13718a
Cext_14226 \$557 IOVDD|vdda 5.22317a
Cext_14227 \$557 VSUBS 177.911a
Cext_14228 \$558 \$570 114.006a
Cext_14229 \$558 \$571 0.182933a
Cext_14230 \$558 \$583 98.5952a
Cext_14231 \$558 \$595 0.360462a
Cext_14232 \$558 \$609 108.267a
Cext_14233 \$558 \$67 80.1821a
Cext_14234 \$558 \$69 70.7638a
Cext_14235 \$558 \$71 31.3588a
Cext_14236 \$558 \$73 32.5775a
Cext_14237 \$558 \$75 39.7349a
Cext_14238 \$558 \$77 45.7852a
Cext_14239 \$558 VSS|vss 0.378848a
Cext_14240 \$558 VSUBS 259.207a
Cext_14241 \$559 \$584 230.002a
Cext_14242 \$559 \$59 0.476813a
Cext_14243 \$559 \$601 3.25406a
Cext_14244 \$559 \$602 0.179323a
Cext_14245 \$559 \$610 99.1454a
Cext_14246 \$559 \$629 7.41179a
Cext_14247 \$559 \$85 106.353a
Cext_14248 \$559 \$87 53.6239a
Cext_14249 \$559 \$89 3.34353a
Cext_14250 \$559 \$91 1.94351a
Cext_14251 \$559 \$93 1.13718a
Cext_14252 \$559 VSUBS 177.911a
Cext_14253 \$56 \$57 618.43a
Cext_14254 \$56 \$58 2.13277a
Cext_14255 \$56 \$65 23.8673a
Cext_14256 \$56 \$87 29.0633a
Cext_14257 \$56 \$88 902.785a
Cext_14258 \$56 \$89 0.237316a
Cext_14259 \$56 d3|dac_hard[3] 130.648a
Cext_14260 \$56 IOVDD|vdda 173.439a
Cext_14261 \$56 VDD|vdd 10.4718a
Cext_14262 \$56 VSS|vss 446.383a
Cext_14263 \$56 VSUBS 1.50674f
Cext_14264 \$560 \$577 114.006a
Cext_14265 \$560 \$578 0.182933a
Cext_14266 \$560 \$585 98.5952a
Cext_14267 \$560 \$59 0.62262a
Cext_14268 \$560 \$602 0.360462a
Cext_14269 \$560 \$611 108.267a
Cext_14270 \$560 \$83 80.1821a
Cext_14271 \$560 \$85 70.7638a
Cext_14272 \$560 \$87 31.3588a
Cext_14273 \$560 \$89 32.5775a
Cext_14274 \$560 \$91 39.7349a
Cext_14275 \$560 \$93 45.7852a
Cext_14276 \$560 VSS|vss 0.378848a
Cext_14277 \$560 VSUBS 259.207a
Cext_14278 \$561 \$586 230.002a
Cext_14279 \$561 \$59 0.476813a
Cext_14280 \$561 \$603 3.25406a
Cext_14281 \$561 \$604 0.179323a
Cext_14282 \$561 \$612 99.1454a
Cext_14283 \$561 \$632 7.41179a
Cext_14284 \$561 \$85 106.353a
Cext_14285 \$561 \$87 53.6239a
Cext_14286 \$561 \$89 3.34353a
Cext_14287 \$561 \$91 1.94351a
Cext_14288 \$561 \$93 1.13718a
Cext_14289 \$561 IOVDD|vdda 5.22317a
Cext_14290 \$561 VSS|vss 5.69375a
Cext_14291 \$561 VSUBS 177.911a
Cext_14292 \$562 \$579 114.006a
Cext_14293 \$562 \$587 98.5952a
Cext_14294 \$562 \$588 0.182933a
Cext_14295 \$562 \$59 0.62262a
Cext_14296 \$562 \$604 0.360462a
Cext_14297 \$562 \$613 108.267a
Cext_14298 \$562 \$83 80.1821a
Cext_14299 \$562 \$85 70.7638a
Cext_14300 \$562 \$87 31.3588a
Cext_14301 \$562 \$89 32.5775a
Cext_14302 \$562 \$91 39.7349a
Cext_14303 \$562 \$93 45.7852a
Cext_14304 \$562 VSS|vss 0.378848a
Cext_14305 \$562 VSUBS 259.207a
Cext_14306 \$563 \$564 45.0654a
Cext_14307 \$563 \$589 130.175a
Cext_14308 \$563 VDD|vdd 7.74075a
Cext_14309 \$563 VSS|vss 1.71997a
Cext_14310 \$563 VSUBS 659.267a
Cext_14311 \$564 \$565 45.0654a
Cext_14312 \$564 \$590 130.175a
Cext_14313 \$564 VDD|vdd 0.968272a
Cext_14314 \$564 VSUBS 634.529a
Cext_14315 \$565 \$566 45.0654a
Cext_14316 \$565 \$605 130.175a
Cext_14317 \$565 VSUBS 634.529a
Cext_14318 \$566 \$567 45.8951a
Cext_14319 \$566 \$591 130.175a
Cext_14320 \$566 VSS|vss 0.428128a
Cext_14321 \$566 VSUBS 634.529a
Cext_14322 \$567 \$580 113.058a
Cext_14323 \$567 \$592 225.319a
Cext_14324 \$567 \$67 105.489a
Cext_14325 \$567 VSS|vss 61.1015a
Cext_14326 \$567 VSUBS 793.257a
Cext_14327 \$568 \$580 0.182933a
Cext_14328 \$568 \$593 254.864a
Cext_14329 \$568 \$607 0.360462a
Cext_14330 \$568 \$67 110.011a
Cext_14331 \$568 VSS|vss 66.2132a
Cext_14332 \$568 VSUBS 817.162a
Cext_14333 \$569 \$582 113.058a
Cext_14334 \$569 \$594 225.319a
Cext_14335 \$569 \$67 105.489a
Cext_14336 \$569 IOVDD|vdda 11.5102a
Cext_14337 \$569 VSS|vss 60.9228a
Cext_14338 \$569 VSUBS 810.376a
Cext_14339 \$57 \$577 0.282145a
Cext_14340 \$57 \$578 0.115752a
Cext_14341 \$57 \$579 0.282145a
Cext_14342 \$57 \$58 41.8224a
Cext_14343 \$57 \$588 0.115752a
Cext_14344 \$57 \$59 74.3958f
Cext_14345 \$57 \$602 0.115752a
Cext_14346 \$57 \$603 0.282145a
Cext_14347 \$57 \$604 0.115752a
Cext_14348 \$57 \$61 217.383a
Cext_14349 \$57 \$610 1.18748a
Cext_14350 \$57 \$612 1.18748a
Cext_14351 \$57 \$629 0.329802a
Cext_14352 \$57 \$63 35.1546a
Cext_14353 \$57 \$630 0.282145a
Cext_14354 \$57 \$631 0.115752a
Cext_14355 \$57 \$632 0.329802a
Cext_14356 \$57 \$633 0.282145a
Cext_14357 \$57 \$65 70.1227a
Cext_14358 \$57 \$654 0.115752a
Cext_14359 \$57 \$655 47.4094a
Cext_14360 \$57 \$656 0.476813a
Cext_14361 \$57 \$658 0.282145a
Cext_14362 \$57 \$659 0.115752a
Cext_14363 \$57 \$660 47.4094a
Cext_14364 \$57 \$661 0.476813a
Cext_14365 \$57 \$679 0.282145a
Cext_14366 \$57 \$680 0.115752a
Cext_14367 \$57 \$681 0.282145a
Cext_14368 \$57 \$697 0.62262a
Cext_14369 \$57 \$698 0.115752a
Cext_14370 \$57 \$699 0.282145a
Cext_14371 \$57 \$700 0.62262a
Cext_14372 \$57 \$701 0.115752a
Cext_14373 \$57 \$704 1.18572a
Cext_14374 \$57 \$705 1.18572a
Cext_14375 \$57 \$721 47.4094a
Cext_14376 \$57 \$722 0.428122a
Cext_14377 \$57 \$723 0.772242a
Cext_14378 \$57 \$724 47.4094a
Cext_14379 \$57 \$725 0.428122a
Cext_14380 \$57 \$742 1.41124a
Cext_14381 \$57 \$743 0.115752a
Cext_14382 \$57 \$744 1.18748a
Cext_14383 \$57 \$745 1.41124a
Cext_14384 \$57 \$746 0.282145a
Cext_14385 \$57 \$747 0.115752a
Cext_14386 \$57 \$748 1.18748a
Cext_14387 \$57 \$754 0.476813a
Cext_14388 \$57 \$755 0.62262a
Cext_14389 \$57 \$756 0.476813a
Cext_14390 \$57 \$757 0.62262a
Cext_14391 \$57 \$771 0.282145a
Cext_14392 \$57 \$772 0.115752a
Cext_14393 \$57 \$773 0.282145a
Cext_14394 \$57 \$792 0.115752a
Cext_14395 \$57 \$793 0.329802a
Cext_14396 \$57 \$795 0.282145a
Cext_14397 \$57 \$796 0.115752a
Cext_14398 \$57 \$797 0.329802a
Cext_14399 \$57 \$818 0.282145a
Cext_14400 \$57 \$819 0.115752a
Cext_14401 \$57 \$821 0.282145a
Cext_14402 \$57 \$83 82.7723a
Cext_14403 \$57 \$839 0.115752a
Cext_14404 \$57 \$841 0.282145a
Cext_14405 \$57 \$843 0.115752a
Cext_14406 \$57 \$85 567.858a
Cext_14407 \$57 \$863 0.282145a
Cext_14408 \$57 \$864 0.115752a
Cext_14409 \$57 \$865 0.282145a
Cext_14410 \$57 \$87 199.715a
Cext_14411 \$57 \$88 71.3084a
Cext_14412 \$57 \$882 0.115752a
Cext_14413 \$57 \$883 0.282145a
Cext_14414 \$57 \$884 0.115752a
Cext_14415 \$57 \$89 18.2101f
Cext_14416 \$57 \$890 129.534a
Cext_14417 \$57 \$892 52.0892a
Cext_14418 \$57 \$90 10.2105a
Cext_14419 \$57 \$907 0.282145a
Cext_14420 \$57 \$908 0.115752a
Cext_14421 \$57 \$909 0.282145a
Cext_14422 \$57 \$91 16.296f
Cext_14423 \$57 \$928 0.115752a
Cext_14424 \$57 \$929 70.8019a
Cext_14425 \$57 \$93 110.405a
Cext_14426 \$57 \$930 0.282145a
Cext_14427 \$57 \$932 0.115752a
Cext_14428 \$57 \$933 24.7244a
Cext_14429 \$57 \$95 34.7189a
Cext_14430 \$57 \$955 0.282145a
Cext_14431 \$57 \$956 0.115752a
Cext_14432 \$57 \$957 0.282145a
Cext_14433 \$57 \$97 37.1134a
Cext_14434 \$57 \$972 0.115752a
Cext_14435 \$57 \$975 0.282145a
Cext_14436 \$57 \$976 0.115752a
Cext_14437 \$57 \$988 1.18748a
Cext_14438 \$57 \$990 1.18748a
Cext_14439 \$57 d4|dac_hard[4] 28.2212a
Cext_14440 \$57 IOVDD|vdda 830.258a
Cext_14441 \$57 VDD|vdd 5.43972a
Cext_14442 \$57 VREF|vref 67.8624a
Cext_14443 \$57 VSS|vss 809.998a
Cext_14444 \$57 VSUBS 18.5386f
Cext_14445 \$570 \$582 0.182933a
Cext_14446 \$570 \$595 254.864a
Cext_14447 \$570 \$609 0.360462a
Cext_14448 \$570 \$67 110.011a
Cext_14449 \$570 VSS|vss 66.2132a
Cext_14450 \$570 VSUBS 817.162a
Cext_14451 \$571 VREF|vref 131.497a
Cext_14452 \$571 VSS|vss 2.2008a
Cext_14453 \$571 VSUBS 675.619a
Cext_14454 \$572 \$573 45.0654a
Cext_14455 \$572 \$597 130.128a
Cext_14456 \$572 VDD|vdd 0.592094a
Cext_14457 \$572 VSS|vss 25.1792a
Cext_14458 \$572 VSUBS 659.267a
Cext_14459 \$573 \$574 45.0654a
Cext_14460 \$573 \$598 130.175a
Cext_14461 \$573 VSS|vss 5.452a
Cext_14462 \$573 VSUBS 634.529a
Cext_14463 \$574 \$575 45.0654a
Cext_14464 \$574 \$599 130.175a
Cext_14465 \$574 VSUBS 634.529a
Cext_14466 \$575 \$576 45.8951a
Cext_14467 \$575 \$600 130.175a
Cext_14468 \$575 VSS|vss 0.428128a
Cext_14469 \$575 VSUBS 634.529a
Cext_14470 \$576 \$584 113.058a
Cext_14471 \$576 \$601 225.319a
Cext_14472 \$576 \$83 105.489a
Cext_14473 \$576 VSS|vss 61.1015a
Cext_14474 \$576 VSUBS 793.257a
Cext_14475 \$577 \$584 0.182933a
Cext_14476 \$577 \$59 0.494517a
Cext_14477 \$577 \$602 254.864a
Cext_14478 \$577 \$61 20.7622a
Cext_14479 \$577 \$611 0.360462a
Cext_14480 \$577 \$83 110.011a
Cext_14481 \$577 VSS|vss 66.2132a
Cext_14482 \$577 VSUBS 817.162a
Cext_14483 \$578 \$586 113.058a
Cext_14484 \$578 \$59 0.481837a
Cext_14485 \$578 \$603 225.319a
Cext_14486 \$578 \$61 20.8391a
Cext_14487 \$578 \$83 105.489a
Cext_14488 \$578 IOVDD|vdda 11.5102a
Cext_14489 \$578 VSS|vss 60.9228a
Cext_14490 \$578 VSUBS 810.376a
Cext_14491 \$579 \$586 0.182933a
Cext_14492 \$579 \$59 0.494517a
Cext_14493 \$579 \$604 254.864a
Cext_14494 \$579 \$61 20.7622a
Cext_14495 \$579 \$613 0.360462a
Cext_14496 \$579 \$83 110.011a
Cext_14497 \$579 VSS|vss 75.4228a
Cext_14498 \$579 VSUBS 817.162a
Cext_14499 \$58 \$59 602.158a
Cext_14500 \$58 \$60 2.13277a
Cext_14501 \$58 \$63 0.110435a
Cext_14502 \$58 \$65 24.0132a
Cext_14503 \$58 \$89 29.0633a
Cext_14504 \$58 \$90 902.785a
Cext_14505 \$58 \$91 0.237316a
Cext_14506 \$58 \$97 0.127512a
Cext_14507 \$58 d4|dac_hard[4] 130.648a
Cext_14508 \$58 IOVDD|vdda 173.852a
Cext_14509 \$58 VDD|vdd 10.4718a
Cext_14510 \$58 VSS|vss 446.394a
Cext_14511 \$58 VSUBS 1.51046f
Cext_14512 \$580 \$592 102.889a
Cext_14513 \$580 \$606 0.250757a
Cext_14514 \$580 \$618 0.360462a
Cext_14515 \$580 \$638 42.153a
Cext_14516 \$580 \$67 80.1249a
Cext_14517 \$580 \$69 70.7638a
Cext_14518 \$580 \$71 34.0438a
Cext_14519 \$580 \$73 32.5775a
Cext_14520 \$580 \$75 35.6349a
Cext_14521 \$580 \$77 45.8508a
Cext_14522 \$580 VSS|vss 0.335662a
Cext_14523 \$580 VSUBS 256.045a
Cext_14524 \$581 \$607 230.002a
Cext_14525 \$581 \$620 3.25406a
Cext_14526 \$581 \$621 0.179323a
Cext_14527 \$581 \$641 7.41179a
Cext_14528 \$581 \$642 99.1454a
Cext_14529 \$581 \$67 2.30683a
Cext_14530 \$581 \$69 118.301a
Cext_14531 \$581 \$71 7.49159a
Cext_14532 \$581 \$73 3.34353a
Cext_14533 \$581 \$75 2.09052a
Cext_14534 \$581 \$77 1.13718a
Cext_14535 \$581 VSUBS 177.242a
Cext_14536 \$582 \$594 102.889a
Cext_14537 \$582 \$608 0.250757a
Cext_14538 \$582 \$621 0.360462a
Cext_14539 \$582 \$643 42.153a
Cext_14540 \$582 \$67 79.9778a
Cext_14541 \$582 \$69 70.7638a
Cext_14542 \$582 \$71 34.0438a
Cext_14543 \$582 \$73 32.5775a
Cext_14544 \$582 \$75 35.6349a
Cext_14545 \$582 \$77 45.8508a
Cext_14546 \$582 IOVDD|vdda 41.4632a
Cext_14547 \$582 VSS|vss 0.335662a
Cext_14548 \$582 VSUBS 255.771a
Cext_14549 \$583 \$609 230.002a
Cext_14550 \$583 \$623 3.25406a
Cext_14551 \$583 \$646 99.1454a
Cext_14552 \$583 \$647 7.41179a
Cext_14553 \$583 \$67 2.30683a
Cext_14554 \$583 \$69 118.301a
Cext_14555 \$583 \$71 7.49159a
Cext_14556 \$583 \$73 3.34353a
Cext_14557 \$583 \$75 2.09052a
Cext_14558 \$583 \$77 1.13718a
Cext_14559 \$583 VREF|vref 0.310361a
Cext_14560 \$583 VSUBS 177.242a
Cext_14561 \$584 \$601 102.889a
Cext_14562 \$584 \$610 0.250757a
Cext_14563 \$584 \$628 0.360462a
Cext_14564 \$584 \$652 42.153a
Cext_14565 \$584 \$83 80.1249a
Cext_14566 \$584 \$85 70.7638a
Cext_14567 \$584 \$87 34.0438a
Cext_14568 \$584 \$89 32.5775a
Cext_14569 \$584 \$91 35.6349a
Cext_14570 \$584 \$93 45.8508a
Cext_14571 \$584 VSS|vss 0.335662a
Cext_14572 \$584 VSUBS 256.045a
Cext_14573 \$585 \$59 0.329802a
Cext_14574 \$585 \$611 230.002a
Cext_14575 \$585 \$630 3.25406a
Cext_14576 \$585 \$631 0.179323a
Cext_14577 \$585 \$655 99.1454a
Cext_14578 \$585 \$656 7.41179a
Cext_14579 \$585 \$83 2.30683a
Cext_14580 \$585 \$85 118.301a
Cext_14581 \$585 \$87 7.49159a
Cext_14582 \$585 \$89 3.34353a
Cext_14583 \$585 \$91 2.09052a
Cext_14584 \$585 \$93 1.13718a
Cext_14585 \$585 VSUBS 177.242a
Cext_14586 \$586 \$603 102.889a
Cext_14587 \$586 \$612 0.250757a
Cext_14588 \$586 \$631 0.360462a
Cext_14589 \$586 \$657 42.153a
Cext_14590 \$586 \$83 79.9778a
Cext_14591 \$586 \$85 70.7638a
Cext_14592 \$586 \$87 34.0438a
Cext_14593 \$586 \$89 32.5775a
Cext_14594 \$586 \$91 35.6349a
Cext_14595 \$586 \$93 45.8508a
Cext_14596 \$586 IOVDD|vdda 41.4632a
Cext_14597 \$586 VSS|vss 3.50009a
Cext_14598 \$586 VSUBS 255.771a
Cext_14599 \$587 \$59 0.329802a
Cext_14600 \$587 \$613 230.002a
Cext_14601 \$587 \$633 3.25406a
Cext_14602 \$587 \$660 99.1454a
Cext_14603 \$587 \$661 7.41179a
Cext_14604 \$587 \$83 2.30683a
Cext_14605 \$587 \$85 118.301a
Cext_14606 \$587 \$87 7.49159a
Cext_14607 \$587 \$89 3.34353a
Cext_14608 \$587 \$91 2.09052a
Cext_14609 \$587 \$93 1.13718a
Cext_14610 \$587 VREF|vref 0.310361a
Cext_14611 \$587 VSUBS 177.242a
Cext_14612 \$588 \$59 0.481837a
Cext_14613 \$588 \$61 20.9895a
Cext_14614 \$588 VREF|vref 131.497a
Cext_14615 \$588 VSS|vss 2.2008a
Cext_14616 \$588 VSUBS 675.619a
Cext_14617 \$589 \$590 45.0654a
Cext_14618 \$589 \$614 130.175a
Cext_14619 \$589 VDD|vdd 7.74075a
Cext_14620 \$589 VSS|vss 1.71997a
Cext_14621 \$589 VSUBS 659.267a
Cext_14622 \$59 \$60 41.8224a
Cext_14623 \$59 \$602 0.481837a
Cext_14624 \$59 \$603 0.494517a
Cext_14625 \$59 \$604 0.481837a
Cext_14626 \$59 \$61 74.9121f
Cext_14627 \$59 \$610 0.13075a
Cext_14628 \$59 \$612 0.13075a
Cext_14629 \$59 \$63 34.1898a
Cext_14630 \$59 \$630 0.494517a
Cext_14631 \$59 \$631 0.481837a
Cext_14632 \$59 \$633 0.494517a
Cext_14633 \$59 \$65 54.5069a
Cext_14634 \$59 \$654 0.481837a
Cext_14635 \$59 \$655 0.104586a
Cext_14636 \$59 \$658 0.494517a
Cext_14637 \$59 \$659 0.481837a
Cext_14638 \$59 \$660 0.104586a
Cext_14639 \$59 \$679 0.494517a
Cext_14640 \$59 \$680 0.481837a
Cext_14641 \$59 \$681 0.494517a
Cext_14642 \$59 \$698 0.481837a
Cext_14643 \$59 \$699 0.494517a
Cext_14644 \$59 \$701 0.481837a
Cext_14645 \$59 \$722 0.494517a
Cext_14646 \$59 \$723 0.481837a
Cext_14647 \$59 \$725 0.494517a
Cext_14648 \$59 \$743 0.481837a
Cext_14649 \$59 \$746 0.494517a
Cext_14650 \$59 \$747 0.481837a
Cext_14651 \$59 \$771 0.494517a
Cext_14652 \$59 \$772 0.481837a
Cext_14653 \$59 \$773 0.494517a
Cext_14654 \$59 \$792 0.481837a
Cext_14655 \$59 \$795 0.494517a
Cext_14656 \$59 \$796 0.481837a
Cext_14657 \$59 \$818 0.494517a
Cext_14658 \$59 \$819 0.481837a
Cext_14659 \$59 \$821 0.494517a
Cext_14660 \$59 \$83 78.0199a
Cext_14661 \$59 \$839 0.481837a
Cext_14662 \$59 \$841 0.494517a
Cext_14663 \$59 \$843 0.481837a
Cext_14664 \$59 \$85 303.212a
Cext_14665 \$59 \$863 0.494517a
Cext_14666 \$59 \$864 0.481837a
Cext_14667 \$59 \$865 0.494517a
Cext_14668 \$59 \$87 58.8468a
Cext_14669 \$59 \$882 0.481837a
Cext_14670 \$59 \$883 0.494517a
Cext_14671 \$59 \$884 0.481837a
Cext_14672 \$59 \$89 128.789a
Cext_14673 \$59 \$890 95.519a
Cext_14674 \$59 \$892 48.5172a
Cext_14675 \$59 \$90 69.1586a
Cext_14676 \$59 \$907 0.494517a
Cext_14677 \$59 \$908 0.367718a
Cext_14678 \$59 \$909 0.494517a
Cext_14679 \$59 \$91 17.6611f
Cext_14680 \$59 \$92 10.2105a
Cext_14681 \$59 \$928 0.481837a
Cext_14682 \$59 \$929 65.5646a
Cext_14683 \$59 \$93 16.2804f
Cext_14684 \$59 \$930 0.494517a
Cext_14685 \$59 \$932 0.481837a
Cext_14686 \$59 \$933 22.7237a
Cext_14687 \$59 \$95 34.4904a
Cext_14688 \$59 \$955 0.494517a
Cext_14689 \$59 \$956 0.481837a
Cext_14690 \$59 \$957 0.494517a
Cext_14691 \$59 \$97 33.6191a
Cext_14692 \$59 \$972 0.481837a
Cext_14693 \$59 \$975 0.494517a
Cext_14694 \$59 \$976 0.481837a
Cext_14695 \$59 d5|dac_hard[5] 28.2212a
Cext_14696 \$59 IOVDD|vdda 767.581a
Cext_14697 \$59 VDD|vdd 5.43972a
Cext_14698 \$59 VREF|vref 105.154a
Cext_14699 \$59 VSS|vss 728.645a
Cext_14700 \$59 VSUBS 15.4514f
Cext_14701 \$590 \$605 45.0654a
Cext_14702 \$590 \$615 130.175a
Cext_14703 \$590 VDD|vdd 0.968272a
Cext_14704 \$590 VSUBS 634.529a
Cext_14705 \$591 \$592 46.4004a
Cext_14706 \$591 \$605 45.0654a
Cext_14707 \$591 \$617 130.175a
Cext_14708 \$591 VSS|vss 0.378729a
Cext_14709 \$591 VSUBS 634.529a
Cext_14710 \$592 \$618 254.864a
Cext_14711 \$592 \$638 0.360462a
Cext_14712 \$592 \$67 64.1221a
Cext_14713 \$592 \$71 0.168339a
Cext_14714 \$592 \$77 0.107779a
Cext_14715 \$592 VSS|vss 66.2906a
Cext_14716 \$592 VSUBS 800.931a
Cext_14717 \$593 \$607 113.058a
Cext_14718 \$593 \$620 225.319a
Cext_14719 \$593 \$67 58.9193a
Cext_14720 \$593 \$71 0.343978a
Cext_14721 \$593 VSS|vss 60.9228a
Cext_14722 \$593 VSUBS 810.856a
Cext_14723 \$594 \$607 0.182933a
Cext_14724 \$594 \$621 254.864a
Cext_14725 \$594 \$643 0.360462a
Cext_14726 \$594 \$67 64.1221a
Cext_14727 \$594 \$71 0.168339a
Cext_14728 \$594 \$77 0.107779a
Cext_14729 \$594 IOVDD|vdda 13.2807a
Cext_14730 \$594 VSS|vss 66.2132a
Cext_14731 \$594 VSUBS 818.465a
Cext_14732 \$595 \$609 113.058a
Cext_14733 \$595 \$623 225.319a
Cext_14734 \$595 \$67 58.9193a
Cext_14735 \$595 \$71 0.343978a
Cext_14736 \$595 VSS|vss 60.9228a
Cext_14737 \$595 VSUBS 810.856a
Cext_14738 \$597 \$598 45.0654a
Cext_14739 \$597 \$624 130.128a
Cext_14740 \$597 VDD|vdd 0.592094a
Cext_14741 \$597 VSS|vss 25.1792a
Cext_14742 \$597 VSUBS 659.267a
Cext_14743 \$598 \$599 45.0654a
Cext_14744 \$598 \$625 130.175a
Cext_14745 \$598 VSS|vss 5.452a
Cext_14746 \$598 VSUBS 634.529a
Cext_14747 \$599 \$600 45.0654a
Cext_14748 \$599 \$626 130.175a
Cext_14749 \$599 VSUBS 634.529a
Cext_14750 \$60 \$61 602.411a
Cext_14751 \$60 \$62 2.13277a
Cext_14752 \$60 \$63 0.107981a
Cext_14753 \$60 \$65 24.0099a
Cext_14754 \$60 \$91 29.0633a
Cext_14755 \$60 \$92 902.785a
Cext_14756 \$60 \$93 0.237316a
Cext_14757 \$60 \$97 0.124678a
Cext_14758 \$60 d5|dac_hard[5] 130.648a
Cext_14759 \$60 IOVDD|vdda 173.811a
Cext_14760 \$60 VDD|vdd 10.4718a
Cext_14761 \$60 VSS|vss 446.394a
Cext_14762 \$60 VSUBS 1.51046f
Cext_14763 \$600 \$601 46.4004a
Cext_14764 \$600 \$627 130.175a
Cext_14765 \$600 VSS|vss 0.378729a
Cext_14766 \$600 VSUBS 634.529a
Cext_14767 \$601 \$628 254.864a
Cext_14768 \$601 \$652 0.360462a
Cext_14769 \$601 \$83 64.1221a
Cext_14770 \$601 \$87 0.168339a
Cext_14771 \$601 \$93 0.107779a
Cext_14772 \$601 VSS|vss 66.2906a
Cext_14773 \$601 VSUBS 800.931a
Cext_14774 \$602 \$61 20.9928a
Cext_14775 \$602 \$611 113.058a
Cext_14776 \$602 \$630 225.319a
Cext_14777 \$602 \$83 58.9193a
Cext_14778 \$602 \$87 0.343978a
Cext_14779 \$602 VSS|vss 60.9228a
Cext_14780 \$602 VSUBS 810.856a
Cext_14781 \$603 \$61 20.7622a
Cext_14782 \$603 \$611 0.182933a
Cext_14783 \$603 \$631 254.864a
Cext_14784 \$603 \$657 0.360462a
Cext_14785 \$603 \$83 64.1221a
Cext_14786 \$603 \$87 0.168339a
Cext_14787 \$603 \$93 0.107779a
Cext_14788 \$603 IOVDD|vdda 13.2807a
Cext_14789 \$603 VSS|vss 66.2132a
Cext_14790 \$603 VSUBS 818.465a
Cext_14791 \$604 \$61 20.9928a
Cext_14792 \$604 \$613 113.058a
Cext_14793 \$604 \$633 225.319a
Cext_14794 \$604 \$83 58.9193a
Cext_14795 \$604 \$87 0.343978a
Cext_14796 \$604 VSS|vss 69.9251a
Cext_14797 \$604 VSUBS 810.856a
Cext_14798 \$605 \$616 130.175a
Cext_14799 \$605 VSUBS 634.529a
Cext_14800 \$606 \$619 783.202a
Cext_14801 \$606 \$638 15.7815a
Cext_14802 \$606 \$686 83.8393a
Cext_14803 \$606 \$687 2.88751a
Cext_14804 \$606 \$688 0.179323a
Cext_14805 \$606 \$69 60.0621a
Cext_14806 \$606 \$71 50.2205a
Cext_14807 \$606 \$711 7.41179a
Cext_14808 \$606 \$73 49.6419a
Cext_14809 \$606 \$75 1.67062a
Cext_14810 \$606 \$77 0.98091a
Cext_14811 \$606 VSUBS 198.211a
Cext_14812 \$607 \$620 102.889a
Cext_14813 \$607 \$640 0.360462a
Cext_14814 \$607 \$642 0.250757a
Cext_14815 \$607 \$662 42.153a
Cext_14816 \$607 \$67 69.937a
Cext_14817 \$607 \$69 117.46a
Cext_14818 \$607 \$71 32.765a
Cext_14819 \$607 \$73 32.5775a
Cext_14820 \$607 \$75 35.6349a
Cext_14821 \$607 \$77 45.8508a
Cext_14822 \$607 VSS|vss 0.335662a
Cext_14823 \$607 VSUBS 255.662a
Cext_14824 \$608 \$622 783.202a
Cext_14825 \$608 \$643 15.7815a
Cext_14826 \$608 \$689 83.8393a
Cext_14827 \$608 \$69 60.0621a
Cext_14828 \$608 \$690 2.88751a
Cext_14829 \$608 \$691 0.179323a
Cext_14830 \$608 \$71 50.2205a
Cext_14831 \$608 \$714 7.41179a
Cext_14832 \$608 \$73 49.6419a
Cext_14833 \$608 \$75 1.67062a
Cext_14834 \$608 \$77 0.98091a
Cext_14835 \$608 IOVDD|vdda 7.32478a
Cext_14836 \$608 VSUBS 198.211a
Cext_14837 \$609 \$623 102.889a
Cext_14838 \$609 \$645 0.360462a
Cext_14839 \$609 \$646 0.250757a
Cext_14840 \$609 \$663 42.153a
Cext_14841 \$609 \$67 69.937a
Cext_14842 \$609 \$69 117.46a
Cext_14843 \$609 \$71 32.765a
Cext_14844 \$609 \$73 32.5775a
Cext_14845 \$609 \$75 35.6349a
Cext_14846 \$609 \$77 45.8508a
Cext_14847 \$609 VREF|vref 0.182933a
Cext_14848 \$609 VSS|vss 0.335662a
Cext_14849 \$609 VSUBS 255.662a
Cext_14850 \$61 \$62 41.8224a
Cext_14851 \$61 \$63 34.3134a
Cext_14852 \$61 \$630 20.9159a
Cext_14853 \$61 \$631 20.9928a
Cext_14854 \$61 \$633 20.9159a
Cext_14855 \$61 \$65 53.121a
Cext_14856 \$61 \$654 20.8391a
Cext_14857 \$61 \$658 20.9159a
Cext_14858 \$61 \$659 20.8391a
Cext_14859 \$61 \$679 20.7622a
Cext_14860 \$61 \$680 20.8391a
Cext_14861 \$61 \$681 20.7622a
Cext_14862 \$61 \$698 20.9928a
Cext_14863 \$61 \$699 20.7622a
Cext_14864 \$61 \$701 20.9928a
Cext_14865 \$61 \$721 0.104586a
Cext_14866 \$61 \$722 20.9159a
Cext_14867 \$61 \$723 20.9928a
Cext_14868 \$61 \$724 0.104586a
Cext_14869 \$61 \$725 20.9159a
Cext_14870 \$61 \$743 20.8391a
Cext_14871 \$61 \$744 0.13075a
Cext_14872 \$61 \$746 20.9159a
Cext_14873 \$61 \$747 20.8391a
Cext_14874 \$61 \$748 0.13075a
Cext_14875 \$61 \$771 20.7622a
Cext_14876 \$61 \$772 20.8391a
Cext_14877 \$61 \$773 20.7622a
Cext_14878 \$61 \$792 20.9928a
Cext_14879 \$61 \$795 20.7622a
Cext_14880 \$61 \$796 20.9928a
Cext_14881 \$61 \$817 0.329802a
Cext_14882 \$61 \$818 20.9159a
Cext_14883 \$61 \$819 20.9928a
Cext_14884 \$61 \$820 0.329802a
Cext_14885 \$61 \$821 20.9159a
Cext_14886 \$61 \$83 121.073a
Cext_14887 \$61 \$839 20.8391a
Cext_14888 \$61 \$840 0.476813a
Cext_14889 \$61 \$841 20.9159a
Cext_14890 \$61 \$843 20.8391a
Cext_14891 \$61 \$844 0.476813a
Cext_14892 \$61 \$85 188.936a
Cext_14893 \$61 \$863 20.7622a
Cext_14894 \$61 \$864 20.8391a
Cext_14895 \$61 \$865 20.7622a
Cext_14896 \$61 \$868 0.62262a
Cext_14897 \$61 \$869 0.62262a
Cext_14898 \$61 \$87 64.4319a
Cext_14899 \$61 \$882 20.9928a
Cext_14900 \$61 \$883 20.7622a
Cext_14901 \$61 \$884 20.9928a
Cext_14902 \$61 \$89 70.3718a
Cext_14903 \$61 \$890 167.689a
Cext_14904 \$61 \$891 1.40263a
Cext_14905 \$61 \$892 119.432a
Cext_14906 \$61 \$893 1.40263a
Cext_14907 \$61 \$907 21.0619a
Cext_14908 \$61 \$908 22.5002a
Cext_14909 \$61 \$909 21.0619a
Cext_14910 \$61 \$91 131.194a
Cext_14911 \$61 \$92 69.1586a
Cext_14912 \$61 \$927 1.40263a
Cext_14913 \$61 \$928 20.8391a
Cext_14914 \$61 \$929 124.328a
Cext_14915 \$61 \$93 17.7643f
Cext_14916 \$61 \$930 20.9159a
Cext_14917 \$61 \$931 1.40263a
Cext_14918 \$61 \$932 20.8391a
Cext_14919 \$61 \$933 79.422a
Cext_14920 \$61 \$938 0.476813a
Cext_14921 \$61 \$939 0.62262a
Cext_14922 \$61 \$94 10.2105a
Cext_14923 \$61 \$940 0.476813a
Cext_14924 \$61 \$941 0.62262a
Cext_14925 \$61 \$95 16.2154f
Cext_14926 \$61 \$955 20.7622a
Cext_14927 \$61 \$956 20.8391a
Cext_14928 \$61 \$957 20.7622a
Cext_14929 \$61 \$97 32.1598a
Cext_14930 \$61 \$972 20.9928a
Cext_14931 \$61 \$973 0.329802a
Cext_14932 \$61 \$975 20.7622a
Cext_14933 \$61 \$976 20.9928a
Cext_14934 \$61 \$977 0.329802a
Cext_14935 \$61 \$988 0.13075a
Cext_14936 \$61 \$990 0.13075a
Cext_14937 \$61 d6|dac_hard[6] 28.2212a
Cext_14938 \$61 IOVDD|vdda 779.86a
Cext_14939 \$61 VDD|vdd 5.43972a
Cext_14940 \$61 VREF|vref 2.28972f
Cext_14941 \$61 VSS|vss 2.25501f
Cext_14942 \$61 VSUBS 24.5257f
Cext_14943 \$610 \$629 783.202a
Cext_14944 \$610 \$652 15.7815a
Cext_14945 \$610 \$696 2.88751a
Cext_14946 \$610 \$697 83.8393a
Cext_14947 \$610 \$698 0.179323a
Cext_14948 \$610 \$721 7.41179a
Cext_14949 \$610 \$85 60.0621a
Cext_14950 \$610 \$87 50.2205a
Cext_14951 \$610 \$89 49.6419a
Cext_14952 \$610 \$91 1.67062a
Cext_14953 \$610 \$93 0.98091a
Cext_14954 \$610 VSUBS 198.211a
Cext_14955 \$611 \$630 102.889a
Cext_14956 \$611 \$654 0.360462a
Cext_14957 \$611 \$655 0.250757a
Cext_14958 \$611 \$664 42.153a
Cext_14959 \$611 \$83 69.937a
Cext_14960 \$611 \$85 117.46a
Cext_14961 \$611 \$87 32.765a
Cext_14962 \$611 \$89 32.5775a
Cext_14963 \$611 \$91 35.6349a
Cext_14964 \$611 \$93 45.8508a
Cext_14965 \$611 VSS|vss 0.335662a
Cext_14966 \$611 VSUBS 255.662a
Cext_14967 \$612 \$632 783.202a
Cext_14968 \$612 \$657 15.7815a
Cext_14969 \$612 \$699 2.88751a
Cext_14970 \$612 \$700 83.8393a
Cext_14971 \$612 \$701 0.179323a
Cext_14972 \$612 \$724 7.41179a
Cext_14973 \$612 \$85 60.0621a
Cext_14974 \$612 \$87 50.2205a
Cext_14975 \$612 \$89 49.6419a
Cext_14976 \$612 \$91 1.67062a
Cext_14977 \$612 \$93 0.98091a
Cext_14978 \$612 IOVDD|vdda 7.32478a
Cext_14979 \$612 VSS|vss 11.762a
Cext_14980 \$612 VSUBS 198.211a
Cext_14981 \$613 \$633 102.889a
Cext_14982 \$613 \$659 0.360462a
Cext_14983 \$613 \$660 0.250757a
Cext_14984 \$613 \$665 42.153a
Cext_14985 \$613 \$83 69.937a
Cext_14986 \$613 \$85 117.46a
Cext_14987 \$613 \$87 32.765a
Cext_14988 \$613 \$89 32.5775a
Cext_14989 \$613 \$91 35.6349a
Cext_14990 \$613 \$93 45.8508a
Cext_14991 \$613 VREF|vref 0.182933a
Cext_14992 \$613 VSS|vss 0.335662a
Cext_14993 \$613 VSUBS 255.662a
Cext_14994 \$614 \$615 45.0654a
Cext_14995 \$614 \$634 130.175a
Cext_14996 \$614 VDD|vdd 7.74075a
Cext_14997 \$614 VSS|vss 1.71997a
Cext_14998 \$614 VSUBS 659.267a
Cext_14999 \$615 \$616 45.0654a
Cext_15000 \$615 \$635 130.175a
Cext_15001 \$615 VDD|vdd 0.968272a
Cext_15002 \$615 VSUBS 634.529a
Cext_15003 \$616 \$617 45.0654a
Cext_15004 \$616 \$636 130.175a
Cext_15005 \$616 VSUBS 634.529a
Cext_15006 \$617 \$618 45.8951a
Cext_15007 \$617 \$637 130.175a
Cext_15008 \$617 VSS|vss 0.428128a
Cext_15009 \$617 VSUBS 634.529a
Cext_15010 \$618 \$619 2.46853a
Cext_15011 \$618 \$638 102.889a
Cext_15012 \$618 \$639 225.319a
Cext_15013 \$618 \$67 105.489a
Cext_15014 \$618 VSS|vss 61.1015a
Cext_15015 \$618 VSUBS 793.935a
Cext_15016 \$619 \$620 0.179323a
Cext_15017 \$619 \$638 227.572a
Cext_15018 \$619 \$67 2.30683a
Cext_15019 \$619 \$686 98.5952a
Cext_15020 \$619 \$69 115.44a
Cext_15021 \$619 \$71 7.5941a
Cext_15022 \$619 \$73 3.82035a
Cext_15023 \$619 \$749 1.46644a
Cext_15024 \$619 \$75 1.52179a
Cext_15025 \$619 \$77 1.0724a
Cext_15026 \$619 VSUBS 167.416a
Cext_15027 \$62 \$63 615.803a
Cext_15028 \$62 \$64 2.13277a
Cext_15029 \$62 \$65 23.8673a
Cext_15030 \$62 \$93 29.0633a
Cext_15031 \$62 \$94 902.785a
Cext_15032 \$62 \$95 0.237316a
Cext_15033 \$62 d6|dac_hard[6] 144.188a
Cext_15034 \$62 IOVDD|vdda 173.611a
Cext_15035 \$62 VDD|vdd 10.4718a
Cext_15036 \$62 VSS|vss 446.394a
Cext_15037 \$62 VSUBS 1.50667f
Cext_15038 \$620 \$640 254.864a
Cext_15039 \$620 \$662 0.360462a
Cext_15040 \$620 \$67 110.011a
Cext_15041 \$620 \$77 0.107779a
Cext_15042 \$620 VSS|vss 66.2132a
Cext_15043 \$620 VSUBS 818.365a
Cext_15044 \$621 \$622 2.46853a
Cext_15045 \$621 \$643 102.889a
Cext_15046 \$621 \$644 225.319a
Cext_15047 \$621 \$67 105.489a
Cext_15048 \$621 IOVDD|vdda 11.6291a
Cext_15049 \$621 VSS|vss 60.9228a
Cext_15050 \$621 VSUBS 810.925a
Cext_15051 \$622 \$623 0.179323a
Cext_15052 \$622 \$643 227.572a
Cext_15053 \$622 \$67 2.30683a
Cext_15054 \$622 \$689 98.5952a
Cext_15055 \$622 \$69 115.44a
Cext_15056 \$622 \$71 7.5941a
Cext_15057 \$622 \$73 3.82035a
Cext_15058 \$622 \$75 1.52179a
Cext_15059 \$622 \$751 1.46644a
Cext_15060 \$622 \$77 1.0724a
Cext_15061 \$622 IOVDD|vdda 4.94332a
Cext_15062 \$622 VSUBS 167.416a
Cext_15063 \$623 \$645 254.864a
Cext_15064 \$623 \$663 0.360462a
Cext_15065 \$623 \$67 110.011a
Cext_15066 \$623 \$77 0.107779a
Cext_15067 \$623 VSS|vss 66.2132a
Cext_15068 \$623 VSUBS 818.365a
Cext_15069 \$624 \$625 45.0654a
Cext_15070 \$624 \$648 130.128a
Cext_15071 \$624 VDD|vdd 0.592094a
Cext_15072 \$624 VSS|vss 25.1792a
Cext_15073 \$624 VSUBS 659.267a
Cext_15074 \$625 \$626 45.0654a
Cext_15075 \$625 \$649 130.175a
Cext_15076 \$625 VSS|vss 5.452a
Cext_15077 \$625 VSUBS 634.529a
Cext_15078 \$626 \$627 45.0654a
Cext_15079 \$626 \$650 130.175a
Cext_15080 \$626 VSUBS 634.529a
Cext_15081 \$627 \$628 45.8951a
Cext_15082 \$627 \$651 130.175a
Cext_15083 \$627 VSS|vss 0.428128a
Cext_15084 \$627 VSUBS 634.529a
Cext_15085 \$628 \$629 2.46853a
Cext_15086 \$628 \$652 102.889a
Cext_15087 \$628 \$653 225.319a
Cext_15088 \$628 \$83 105.489a
Cext_15089 \$628 VSS|vss 61.1015a
Cext_15090 \$628 VSUBS 793.935a
Cext_15091 \$629 \$630 0.179323a
Cext_15092 \$629 \$652 227.572a
Cext_15093 \$629 \$697 98.5952a
Cext_15094 \$629 \$754 1.46644a
Cext_15095 \$629 \$83 2.30683a
Cext_15096 \$629 \$85 115.44a
Cext_15097 \$629 \$87 7.5941a
Cext_15098 \$629 \$89 3.82035a
Cext_15099 \$629 \$91 1.52179a
Cext_15100 \$629 \$93 1.0724a
Cext_15101 \$629 VSUBS 167.416a
Cext_15102 \$63 \$64 41.9328a
Cext_15103 \$63 \$65 12.4248f
Cext_15104 \$63 \$83 39.1669a
Cext_15105 \$63 \$85 30.4252a
Cext_15106 \$63 \$87 29.7164a
Cext_15107 \$63 \$89 32.7474a
Cext_15108 \$63 \$890 19.9349a
Cext_15109 \$63 \$892 19.9526a
Cext_15110 \$63 \$91 31.8487a
Cext_15111 \$63 \$929 66.583a
Cext_15112 \$63 \$93 92.0373a
Cext_15113 \$63 \$933 70.0248a
Cext_15114 \$63 \$94 69.1586a
Cext_15115 \$63 \$95 17.9138f
Cext_15116 \$63 \$96 10.2105a
Cext_15117 \$63 \$97 16.2531f
Cext_15118 \$63 \$978 88.258a
Cext_15119 \$63 d6|dac_hard[6] 6.05956a
Cext_15120 \$63 d7|dac_hard[7] 28.2212a
Cext_15121 \$63 inn|out|vth_hard 46.3925a
Cext_15122 \$63 IOVDD|vdda 808.612a
Cext_15123 \$63 VDD|vdd 5.43972a
Cext_15124 \$63 VREF|vref 2.18901a
Cext_15125 \$63 VSS|vss 475.448a
Cext_15126 \$63 VSUBS 6.34488f
Cext_15127 \$630 \$654 254.864a
Cext_15128 \$630 \$664 0.360462a
Cext_15129 \$630 \$83 110.011a
Cext_15130 \$630 \$93 0.107779a
Cext_15131 \$630 VSS|vss 66.2132a
Cext_15132 \$630 VSUBS 818.365a
Cext_15133 \$631 \$632 2.46853a
Cext_15134 \$631 \$657 102.889a
Cext_15135 \$631 \$658 225.319a
Cext_15136 \$631 \$83 105.489a
Cext_15137 \$631 IOVDD|vdda 11.6291a
Cext_15138 \$631 VSS|vss 60.9228a
Cext_15139 \$631 VSUBS 810.925a
Cext_15140 \$632 \$633 0.179323a
Cext_15141 \$632 \$657 227.572a
Cext_15142 \$632 \$700 98.5952a
Cext_15143 \$632 \$756 1.46644a
Cext_15144 \$632 \$83 2.30683a
Cext_15145 \$632 \$85 115.44a
Cext_15146 \$632 \$87 7.5941a
Cext_15147 \$632 \$89 3.82035a
Cext_15148 \$632 \$91 1.52179a
Cext_15149 \$632 \$93 1.0724a
Cext_15150 \$632 IOVDD|vdda 4.94332a
Cext_15151 \$632 VSS|vss 4.87167a
Cext_15152 \$632 VSUBS 167.416a
Cext_15153 \$633 \$659 254.864a
Cext_15154 \$633 \$665 0.360462a
Cext_15155 \$633 \$83 110.011a
Cext_15156 \$633 \$93 0.107779a
Cext_15157 \$633 VSS|vss 75.4228a
Cext_15158 \$633 VSUBS 818.365a
Cext_15159 \$634 \$635 45.0654a
Cext_15160 \$634 \$666 130.175a
Cext_15161 \$634 VDD|vdd 7.74075a
Cext_15162 \$634 VSS|vss 1.71997a
Cext_15163 \$634 VSUBS 659.267a
Cext_15164 \$635 \$636 45.0654a
Cext_15165 \$635 \$667 130.175a
Cext_15166 \$635 VDD|vdd 0.968272a
Cext_15167 \$635 VSUBS 634.529a
Cext_15168 \$636 \$637 45.0654a
Cext_15169 \$636 \$668 130.175a
Cext_15170 \$636 VSUBS 634.529a
Cext_15171 \$637 \$639 46.4004a
Cext_15172 \$637 \$669 130.175a
Cext_15173 \$637 VSS|vss 0.378729a
Cext_15174 \$637 VSUBS 634.529a
Cext_15175 \$638 \$639 114.006a
Cext_15176 \$638 \$640 0.182933a
Cext_15177 \$638 \$67 69.9941a
Cext_15178 \$638 \$670 0.360462a
Cext_15179 \$638 \$686 108.267a
Cext_15180 \$638 \$69 117.46a
Cext_15181 \$638 \$71 32.765a
Cext_15182 \$638 \$73 32.5775a
Cext_15183 \$638 \$75 35.6349a
Cext_15184 \$638 \$77 45.7852a
Cext_15185 \$638 VSS|vss 0.378848a
Cext_15186 \$638 VSUBS 255.476a
Cext_15187 \$639 \$67 64.1221a
Cext_15188 \$639 \$670 254.864a
Cext_15189 \$639 \$686 0.360462a
Cext_15190 \$639 \$69 0.155901a
Cext_15191 \$639 VSS|vss 66.2906a
Cext_15192 \$639 VSUBS 799.746a
Cext_15193 \$64 \$65 626.171a
Cext_15194 \$64 \$95 29.0633a
Cext_15195 \$64 \$96 902.785a
Cext_15196 \$64 \$97 0.364827a
Cext_15197 \$64 d7|dac_hard[7] 145.471a
Cext_15198 \$64 IOVDD|vdda 189.175a
Cext_15199 \$64 VDD|vdd 10.4718a
Cext_15200 \$64 VSS|vss 446.394a
Cext_15201 \$64 VSUBS 1.50802f
Cext_15202 \$640 \$641 2.46853a
Cext_15203 \$640 \$662 102.889a
Cext_15204 \$640 \$67 58.9193a
Cext_15205 \$640 \$671 225.319a
Cext_15206 \$640 \$69 0.343978a
Cext_15207 \$640 VSS|vss 60.9228a
Cext_15208 \$640 VSUBS 811.534a
Cext_15209 \$641 \$642 783.202a
Cext_15210 \$641 \$644 0.179323a
Cext_15211 \$641 \$662 227.572a
Cext_15212 \$641 \$69 106.511a
Cext_15213 \$641 \$702 98.5952a
Cext_15214 \$641 \$71 53.6367a
Cext_15215 \$641 \$73 3.67334a
Cext_15216 \$641 \$75 1.52179a
Cext_15217 \$641 \$77 1.0724a
Cext_15218 \$641 \$781 1.46644a
Cext_15219 \$641 VSUBS 168.123a
Cext_15220 \$642 \$662 15.7815a
Cext_15221 \$642 \$67 1.96577a
Cext_15222 \$642 \$69 66.0871a
Cext_15223 \$642 \$702 83.8393a
Cext_15224 \$642 \$71 62.2724a
Cext_15225 \$642 \$712 2.88751a
Cext_15226 \$642 \$713 0.179323a
Cext_15227 \$642 \$73 3.41995a
Cext_15228 \$642 \$733 7.41179a
Cext_15229 \$642 \$75 1.69678a
Cext_15230 \$642 \$77 0.98091a
Cext_15231 \$642 VSUBS 196.011a
Cext_15232 \$643 \$644 114.006a
Cext_15233 \$643 \$645 0.182933a
Cext_15234 \$643 \$67 69.8469a
Cext_15235 \$643 \$672 0.360462a
Cext_15236 \$643 \$689 108.267a
Cext_15237 \$643 \$69 117.46a
Cext_15238 \$643 \$71 32.765a
Cext_15239 \$643 \$73 32.5775a
Cext_15240 \$643 \$75 35.6349a
Cext_15241 \$643 \$77 45.7852a
Cext_15242 \$643 IOVDD|vdda 41.2792a
Cext_15243 \$643 VSS|vss 0.378848a
Cext_15244 \$643 VSUBS 255.202a
Cext_15245 \$644 \$67 64.1221a
Cext_15246 \$644 \$672 254.864a
Cext_15247 \$644 \$689 0.360462a
Cext_15248 \$644 \$69 0.155901a
Cext_15249 \$644 IOVDD|vdda 13.0646a
Cext_15250 \$644 VSS|vss 66.2132a
Cext_15251 \$644 VSUBS 817.279a
Cext_15252 \$645 \$647 2.46853a
Cext_15253 \$645 \$663 102.889a
Cext_15254 \$645 \$67 58.9193a
Cext_15255 \$645 \$673 225.319a
Cext_15256 \$645 \$69 0.343978a
Cext_15257 \$645 VSS|vss 60.9228a
Cext_15258 \$645 VSUBS 811.534a
Cext_15259 \$646 \$647 783.202a
Cext_15260 \$646 \$663 15.7815a
Cext_15261 \$646 \$67 1.96577a
Cext_15262 \$646 \$69 66.0871a
Cext_15263 \$646 \$703 83.8393a
Cext_15264 \$646 \$71 62.2724a
Cext_15265 \$646 \$715 2.88751a
Cext_15266 \$646 \$73 3.41995a
Cext_15267 \$646 \$736 7.41179a
Cext_15268 \$646 \$75 1.69678a
Cext_15269 \$646 \$77 0.98091a
Cext_15270 \$646 VREF|vref 0.898171a
Cext_15271 \$646 VSUBS 196.19a
Cext_15272 \$647 \$663 227.572a
Cext_15273 \$647 \$69 106.511a
Cext_15274 \$647 \$703 98.5952a
Cext_15275 \$647 \$71 53.6367a
Cext_15276 \$647 \$73 3.67334a
Cext_15277 \$647 \$75 1.52179a
Cext_15278 \$647 \$77 1.0724a
Cext_15279 \$647 \$785 1.46644a
Cext_15280 \$647 VREF|vref 0.489684a
Cext_15281 \$647 VSUBS 168.123a
Cext_15282 \$648 \$649 45.0654a
Cext_15283 \$648 \$674 130.128a
Cext_15284 \$648 VDD|vdd 0.592094a
Cext_15285 \$648 VSS|vss 25.1792a
Cext_15286 \$648 VSUBS 659.267a
Cext_15287 \$649 \$650 45.0654a
Cext_15288 \$649 \$675 130.175a
Cext_15289 \$649 VSS|vss 5.452a
Cext_15290 \$649 VSUBS 634.529a
Cext_15291 \$65 \$83 47.9029a
Cext_15292 \$65 \$84 4.13612a
Cext_15293 \$65 \$85 39.1611a
Cext_15294 \$65 \$86 4.13612a
Cext_15295 \$65 \$87 38.4523a
Cext_15296 \$65 \$88 4.13612a
Cext_15297 \$65 \$89 41.1711a
Cext_15298 \$65 \$890 0.241453a
Cext_15299 \$65 \$892 2.49735a
Cext_15300 \$65 \$90 4.13612a
Cext_15301 \$65 \$91 39.4319a
Cext_15302 \$65 \$92 4.13612a
Cext_15303 \$65 \$929 1.08006a
Cext_15304 \$65 \$93 51.9933a
Cext_15305 \$65 \$933 0.448823a
Cext_15306 \$65 \$94 4.13612a
Cext_15307 \$65 \$95 130.01a
Cext_15308 \$65 \$96 73.2948a
Cext_15309 \$65 \$97 16.9737f
Cext_15310 \$65 \$978 50.1975a
Cext_15311 \$65 d7|dac_hard[7] 6.69708a
Cext_15312 \$65 inn|out|vth_hard 60.9684a
Cext_15313 \$65 IOVDD|vdda 1.12076f
Cext_15314 \$65 VDD|vdd 5.43972a
Cext_15315 \$65 VREF|vref 1.29505a
Cext_15316 \$65 VSS|vss 2.30107f
Cext_15317 \$65 VSUBS 7.75037f
Cext_15318 \$650 \$651 45.0654a
Cext_15319 \$650 \$676 130.175a
Cext_15320 \$650 VSUBS 634.529a
Cext_15321 \$651 \$653 46.4004a
Cext_15322 \$651 \$677 130.175a
Cext_15323 \$651 VSS|vss 0.378729a
Cext_15324 \$651 VSUBS 634.529a
Cext_15325 \$652 \$653 114.006a
Cext_15326 \$652 \$654 0.182933a
Cext_15327 \$652 \$678 0.360462a
Cext_15328 \$652 \$697 108.267a
Cext_15329 \$652 \$83 69.9941a
Cext_15330 \$652 \$85 117.46a
Cext_15331 \$652 \$87 32.765a
Cext_15332 \$652 \$89 32.5775a
Cext_15333 \$652 \$91 35.6349a
Cext_15334 \$652 \$93 45.7852a
Cext_15335 \$652 VSS|vss 0.378848a
Cext_15336 \$652 VSUBS 255.476a
Cext_15337 \$653 \$678 254.864a
Cext_15338 \$653 \$697 0.360462a
Cext_15339 \$653 \$83 64.1221a
Cext_15340 \$653 \$85 0.155901a
Cext_15341 \$653 VSS|vss 66.2906a
Cext_15342 \$653 VSUBS 799.746a
Cext_15343 \$654 \$656 2.46853a
Cext_15344 \$654 \$664 102.889a
Cext_15345 \$654 \$679 225.319a
Cext_15346 \$654 \$83 58.9193a
Cext_15347 \$654 \$85 0.343978a
Cext_15348 \$654 VSS|vss 60.9228a
Cext_15349 \$654 VSUBS 811.534a
Cext_15350 \$655 \$656 783.202a
Cext_15351 \$655 \$664 15.7815a
Cext_15352 \$655 \$704 83.8393a
Cext_15353 \$655 \$722 2.88751a
Cext_15354 \$655 \$723 0.179323a
Cext_15355 \$655 \$744 7.41179a
Cext_15356 \$655 \$83 1.96577a
Cext_15357 \$655 \$85 66.0871a
Cext_15358 \$655 \$87 62.2724a
Cext_15359 \$655 \$89 3.41995a
Cext_15360 \$655 \$91 1.69678a
Cext_15361 \$655 \$93 0.98091a
Cext_15362 \$655 VSUBS 196.011a
Cext_15363 \$656 \$658 0.179323a
Cext_15364 \$656 \$664 227.572a
Cext_15365 \$656 \$704 98.5952a
Cext_15366 \$656 \$793 1.46644a
Cext_15367 \$656 \$85 106.511a
Cext_15368 \$656 \$87 53.6367a
Cext_15369 \$656 \$89 3.67334a
Cext_15370 \$656 \$91 1.52179a
Cext_15371 \$656 \$93 1.0724a
Cext_15372 \$656 VSUBS 168.123a
Cext_15373 \$657 \$658 114.006a
Cext_15374 \$657 \$659 0.182933a
Cext_15375 \$657 \$680 0.360462a
Cext_15376 \$657 \$700 108.267a
Cext_15377 \$657 \$83 69.8469a
Cext_15378 \$657 \$85 117.46a
Cext_15379 \$657 \$87 32.765a
Cext_15380 \$657 \$89 32.5775a
Cext_15381 \$657 \$91 35.6349a
Cext_15382 \$657 \$93 45.7852a
Cext_15383 \$657 IOVDD|vdda 41.2792a
Cext_15384 \$657 VSS|vss 2.96221a
Cext_15385 \$657 VSUBS 255.202a
Cext_15386 \$658 \$680 254.864a
Cext_15387 \$658 \$700 0.360462a
Cext_15388 \$658 \$83 64.1221a
Cext_15389 \$658 \$85 0.155901a
Cext_15390 \$658 IOVDD|vdda 13.0646a
Cext_15391 \$658 VSS|vss 66.2132a
Cext_15392 \$658 VSUBS 817.279a
Cext_15393 \$659 \$661 2.46853a
Cext_15394 \$659 \$665 102.889a
Cext_15395 \$659 \$681 225.319a
Cext_15396 \$659 \$83 58.9193a
Cext_15397 \$659 \$85 0.343978a
Cext_15398 \$659 VSS|vss 69.9251a
Cext_15399 \$659 VSUBS 811.534a
Cext_15400 \$66 d0|dac_soft[0] 26.065a
Cext_15401 \$66 IOVDD|vdda 50.2951a
Cext_15402 \$66 VDD|vdd 1.92335a
Cext_15403 \$66 VSS|vss 240.804a
Cext_15404 \$66 VSUBS 445.356a
Cext_15405 \$660 \$661 783.202a
Cext_15406 \$660 \$665 15.7815a
Cext_15407 \$660 \$705 83.8393a
Cext_15408 \$660 \$725 2.88751a
Cext_15409 \$660 \$748 7.41179a
Cext_15410 \$660 \$83 1.96577a
Cext_15411 \$660 \$85 66.0871a
Cext_15412 \$660 \$87 62.2724a
Cext_15413 \$660 \$89 3.41995a
Cext_15414 \$660 \$91 1.69678a
Cext_15415 \$660 \$93 0.98091a
Cext_15416 \$660 VREF|vref 0.898171a
Cext_15417 \$660 VSUBS 196.19a
Cext_15418 \$661 \$665 227.572a
Cext_15419 \$661 \$705 98.5952a
Cext_15420 \$661 \$797 1.46644a
Cext_15421 \$661 \$85 106.511a
Cext_15422 \$661 \$87 53.6367a
Cext_15423 \$661 \$89 3.67334a
Cext_15424 \$661 \$91 1.52179a
Cext_15425 \$661 \$93 1.0724a
Cext_15426 \$661 VREF|vref 0.489684a
Cext_15427 \$661 VSUBS 168.123a
Cext_15428 \$662 \$67 80.1821a
Cext_15429 \$662 \$671 114.006a
Cext_15430 \$662 \$672 0.182933a
Cext_15431 \$662 \$688 0.360462a
Cext_15432 \$662 \$69 70.7638a
Cext_15433 \$662 \$702 108.267a
Cext_15434 \$662 \$71 33.8269a
Cext_15435 \$662 \$73 32.5775a
Cext_15436 \$662 \$75 35.6349a
Cext_15437 \$662 \$77 45.7852a
Cext_15438 \$662 VSS|vss 0.378848a
Cext_15439 \$662 VSUBS 255.747a
Cext_15440 \$663 \$67 80.1821a
Cext_15441 \$663 \$673 114.006a
Cext_15442 \$663 \$69 70.7638a
Cext_15443 \$663 \$691 0.360462a
Cext_15444 \$663 \$703 108.267a
Cext_15445 \$663 \$71 33.8269a
Cext_15446 \$663 \$73 32.5775a
Cext_15447 \$663 \$75 35.6349a
Cext_15448 \$663 \$77 45.7852a
Cext_15449 \$663 VREF|vref 0.182933a
Cext_15450 \$663 VSS|vss 0.378848a
Cext_15451 \$663 VSUBS 255.747a
Cext_15452 \$664 \$679 114.006a
Cext_15453 \$664 \$680 0.182933a
Cext_15454 \$664 \$698 0.360462a
Cext_15455 \$664 \$704 108.267a
Cext_15456 \$664 \$83 80.1821a
Cext_15457 \$664 \$85 70.7638a
Cext_15458 \$664 \$87 33.8269a
Cext_15459 \$664 \$89 32.5775a
Cext_15460 \$664 \$91 35.6349a
Cext_15461 \$664 \$93 45.7852a
Cext_15462 \$664 VSS|vss 0.378848a
Cext_15463 \$664 VSUBS 255.747a
Cext_15464 \$665 \$681 114.006a
Cext_15465 \$665 \$701 0.360462a
Cext_15466 \$665 \$705 108.267a
Cext_15467 \$665 \$83 80.1821a
Cext_15468 \$665 \$85 70.7638a
Cext_15469 \$665 \$87 33.8269a
Cext_15470 \$665 \$89 32.5775a
Cext_15471 \$665 \$91 35.6349a
Cext_15472 \$665 \$93 45.7852a
Cext_15473 \$665 VREF|vref 0.182933a
Cext_15474 \$665 VSS|vss 0.378848a
Cext_15475 \$665 VSUBS 255.747a
Cext_15476 \$666 \$667 45.0654a
Cext_15477 \$666 \$682 130.175a
Cext_15478 \$666 VDD|vdd 7.74075a
Cext_15479 \$666 VSS|vss 1.71997a
Cext_15480 \$666 VSUBS 659.267a
Cext_15481 \$667 \$668 45.0654a
Cext_15482 \$667 \$683 130.175a
Cext_15483 \$667 VDD|vdd 0.968272a
Cext_15484 \$667 VSUBS 634.529a
Cext_15485 \$668 \$669 45.0654a
Cext_15486 \$668 \$684 130.175a
Cext_15487 \$668 VSUBS 634.529a
Cext_15488 \$669 \$670 45.8951a
Cext_15489 \$669 \$685 130.175a
Cext_15490 \$669 VSS|vss 0.428128a
Cext_15491 \$669 VSUBS 634.529a
Cext_15492 \$67 \$670 105.489a
Cext_15493 \$67 \$671 110.011a
Cext_15494 \$67 \$672 105.489a
Cext_15495 \$67 \$673 110.011a
Cext_15496 \$67 \$68 40.4127a
Cext_15497 \$67 \$686 80.1249a
Cext_15498 \$67 \$687 64.2241a
Cext_15499 \$67 \$688 58.9193a
Cext_15500 \$67 \$689 79.9778a
Cext_15501 \$67 \$69 124.876a
Cext_15502 \$67 \$690 64.2241a
Cext_15503 \$67 \$691 58.9193a
Cext_15504 \$67 \$702 69.937a
Cext_15505 \$67 \$703 69.937a
Cext_15506 \$67 \$71 105.118a
Cext_15507 \$67 \$710 105.694a
Cext_15508 \$67 \$711 1.96577a
Cext_15509 \$67 \$712 110.113a
Cext_15510 \$67 \$713 105.694a
Cext_15511 \$67 \$714 1.96577a
Cext_15512 \$67 \$715 110.113a
Cext_15513 \$67 \$73 114.695a
Cext_15514 \$67 \$730 64.1221a
Cext_15515 \$67 \$731 69.9941a
Cext_15516 \$67 \$732 59.1234a
Cext_15517 \$67 \$734 69.8469a
Cext_15518 \$67 \$735 64.1221a
Cext_15519 \$67 \$75 143.312a
Cext_15520 \$67 \$750 80.1821a
Cext_15521 \$67 \$752 59.1234a
Cext_15522 \$67 \$753 80.1821a
Cext_15523 \$67 \$762 105.489a
Cext_15524 \$67 \$763 110.011a
Cext_15525 \$67 \$764 105.489a
Cext_15526 \$67 \$765 110.011a
Cext_15527 \$67 \$77 214.508a
Cext_15528 \$67 \$778 64.1221a
Cext_15529 \$67 \$779 80.1249a
Cext_15530 \$67 \$780 58.9193a
Cext_15531 \$67 \$781 2.30683a
Cext_15532 \$67 \$782 64.1221a
Cext_15533 \$67 \$783 79.9778a
Cext_15534 \$67 \$784 58.9193a
Cext_15535 \$67 \$785 2.30683a
Cext_15536 \$67 \$79 39.1669a
Cext_15537 \$67 \$798 69.937a
Cext_15538 \$67 \$799 69.937a
Cext_15539 \$67 \$806 105.489a
Cext_15540 \$67 \$807 2.30683a
Cext_15541 \$67 \$808 110.011a
Cext_15542 \$67 \$809 105.489a
Cext_15543 \$67 \$81 40.4662a
Cext_15544 \$67 \$810 2.30683a
Cext_15545 \$67 \$811 110.011a
Cext_15546 \$67 \$825 64.1221a
Cext_15547 \$67 \$826 69.9941a
Cext_15548 \$67 \$827 58.9193a
Cext_15549 \$67 \$829 69.8469a
Cext_15550 \$67 \$830 64.1221a
Cext_15551 \$67 \$831 58.9193a
Cext_15552 \$67 \$846 80.1821a
Cext_15553 \$67 \$847 80.1821a
Cext_15554 \$67 \$854 105.489a
Cext_15555 \$67 \$855 110.011a
Cext_15556 \$67 \$856 105.489a
Cext_15557 \$67 \$857 110.011a
Cext_15558 \$67 \$866 80.1249a
Cext_15559 \$67 \$867 79.9778a
Cext_15560 \$67 \$873 64.2241a
Cext_15561 \$67 \$874 58.9193a
Cext_15562 \$67 \$875 64.2241a
Cext_15563 \$67 \$876 58.9193a
Cext_15564 \$67 \$886 110.712a
Cext_15565 \$67 \$887 69.937a
Cext_15566 \$67 \$888 45.402a
Cext_15567 \$67 \$889 69.937a
Cext_15568 \$67 \$898 105.694a
Cext_15569 \$67 \$899 110.113a
Cext_15570 \$67 \$900 105.694a
Cext_15571 \$67 \$901 110.113a
Cext_15572 \$67 \$914 69.9941a
Cext_15573 \$67 \$915 64.1221a
Cext_15574 \$67 \$916 59.1234a
Cext_15575 \$67 \$917 71.2006a
Cext_15576 \$67 \$918 69.8469a
Cext_15577 \$67 \$919 64.1221a
Cext_15578 \$67 \$920 59.1234a
Cext_15579 \$67 \$921 2.56563a
Cext_15580 \$67 \$935 80.1821a
Cext_15581 \$67 \$937 80.1821a
Cext_15582 \$67 \$946 105.489a
Cext_15583 \$67 \$947 110.011a
Cext_15584 \$67 \$948 105.489a
Cext_15585 \$67 \$949 110.011a
Cext_15586 \$67 \$961 64.1221a
Cext_15587 \$67 \$962 80.1249a
Cext_15588 \$67 \$963 2.30683a
Cext_15589 \$67 \$964 79.9778a
Cext_15590 \$67 \$965 64.1221a
Cext_15591 \$67 \$966 2.30683a
Cext_15592 \$67 \$980 58.9193a
Cext_15593 \$67 \$981 58.9193a
Cext_15594 \$67 \$985 69.937a
Cext_15595 \$67 \$987 69.8608a
Cext_15596 \$67 \$996 105.489a
Cext_15597 \$67 \$997 2.30683a
Cext_15598 \$67 \$998 110.011a
Cext_15599 \$67 \$999 105.489a
Cext_15600 \$67 d1|dac_soft[1] 1.21055a
Cext_15601 \$67 IOVDD|vdda 804.037a
Cext_15602 \$67 VREF|vref 6.09655a
Cext_15603 \$67 VSS|vss 30.0549f
Cext_15604 \$67 VSUBS 61.1991f
Cext_15605 \$670 \$686 113.058a
Cext_15606 \$670 \$687 225.319a
Cext_15607 \$670 VSS|vss 61.1015a
Cext_15608 \$670 VSUBS 793.257a
Cext_15609 \$671 \$686 0.182933a
Cext_15610 \$671 \$688 254.864a
Cext_15611 \$671 \$702 0.360462a
Cext_15612 \$671 VSS|vss 66.2132a
Cext_15613 \$671 VSUBS 817.162a
Cext_15614 \$672 \$689 113.058a
Cext_15615 \$672 \$690 225.319a
Cext_15616 \$672 IOVDD|vdda 11.5102a
Cext_15617 \$672 VSS|vss 60.9228a
Cext_15618 \$672 VSUBS 810.376a
Cext_15619 \$673 \$689 0.182933a
Cext_15620 \$673 \$691 254.864a
Cext_15621 \$673 \$703 0.360462a
Cext_15622 \$673 VSS|vss 66.2132a
Cext_15623 \$673 VSUBS 817.162a
Cext_15624 \$674 \$675 45.0654a
Cext_15625 \$674 \$692 130.128a
Cext_15626 \$674 VDD|vdd 0.592094a
Cext_15627 \$674 VSS|vss 25.1792a
Cext_15628 \$674 VSUBS 659.267a
Cext_15629 \$675 \$676 45.0654a
Cext_15630 \$675 \$693 130.175a
Cext_15631 \$675 VSS|vss 5.452a
Cext_15632 \$675 VSUBS 634.529a
Cext_15633 \$676 \$677 45.0654a
Cext_15634 \$676 \$694 130.175a
Cext_15635 \$676 VSUBS 634.529a
Cext_15636 \$677 \$678 45.8951a
Cext_15637 \$677 \$695 130.175a
Cext_15638 \$677 VSS|vss 0.428128a
Cext_15639 \$677 VSUBS 634.529a
Cext_15640 \$678 \$696 225.319a
Cext_15641 \$678 \$697 113.058a
Cext_15642 \$678 \$83 105.489a
Cext_15643 \$678 VSS|vss 61.1015a
Cext_15644 \$678 VSUBS 793.257a
Cext_15645 \$679 \$697 0.182933a
Cext_15646 \$679 \$698 254.864a
Cext_15647 \$679 \$704 0.360462a
Cext_15648 \$679 \$83 110.011a
Cext_15649 \$679 VSS|vss 66.2132a
Cext_15650 \$679 VSUBS 817.162a
Cext_15651 \$68 d1|dac_soft[1] 26.065a
Cext_15652 \$68 IOVDD|vdda 50.2951a
Cext_15653 \$68 VSS|vss 219.335a
Cext_15654 \$68 VSUBS 421.882a
Cext_15655 \$680 \$699 225.319a
Cext_15656 \$680 \$700 113.058a
Cext_15657 \$680 \$83 105.489a
Cext_15658 \$680 IOVDD|vdda 11.5102a
Cext_15659 \$680 VSS|vss 60.9228a
Cext_15660 \$680 VSUBS 810.376a
Cext_15661 \$681 \$700 0.182933a
Cext_15662 \$681 \$701 254.864a
Cext_15663 \$681 \$705 0.360462a
Cext_15664 \$681 \$83 110.011a
Cext_15665 \$681 VSS|vss 75.4228a
Cext_15666 \$681 VSUBS 817.162a
Cext_15667 \$682 \$683 45.0654a
Cext_15668 \$682 \$706 130.175a
Cext_15669 \$682 VDD|vdd 7.74075a
Cext_15670 \$682 VSS|vss 1.71997a
Cext_15671 \$682 VSUBS 659.267a
Cext_15672 \$683 \$684 45.0654a
Cext_15673 \$683 \$707 130.175a
Cext_15674 \$683 VDD|vdd 0.968272a
Cext_15675 \$683 VSUBS 634.529a
Cext_15676 \$684 \$685 45.0654a
Cext_15677 \$684 \$708 130.175a
Cext_15678 \$684 VSUBS 634.529a
Cext_15679 \$685 \$687 46.4004a
Cext_15680 \$685 \$709 130.175a
Cext_15681 \$685 VSS|vss 0.378729a
Cext_15682 \$685 VSUBS 634.529a
Cext_15683 \$686 \$687 102.889a
Cext_15684 \$686 \$69 70.7638a
Cext_15685 \$686 \$71 31.3588a
Cext_15686 \$686 \$710 0.360462a
Cext_15687 \$686 \$73 35.8568a
Cext_15688 \$686 \$731 42.153a
Cext_15689 \$686 \$75 35.6349a
Cext_15690 \$686 \$77 45.8508a
Cext_15691 \$686 VSS|vss 0.335662a
Cext_15692 \$686 VSUBS 257.974a
Cext_15693 \$687 \$710 254.864a
Cext_15694 \$687 \$73 0.182934a
Cext_15695 \$687 \$731 0.360462a
Cext_15696 \$687 \$77 0.107779a
Cext_15697 \$687 VSS|vss 66.2906a
Cext_15698 \$687 VSUBS 801.109a
Cext_15699 \$688 \$702 113.058a
Cext_15700 \$688 \$712 225.319a
Cext_15701 \$688 \$73 0.343978a
Cext_15702 \$688 VSS|vss 60.9228a
Cext_15703 \$688 VSUBS 810.856a
Cext_15704 \$689 \$69 70.7638a
Cext_15705 \$689 \$690 102.889a
Cext_15706 \$689 \$71 31.3588a
Cext_15707 \$689 \$713 0.360462a
Cext_15708 \$689 \$73 35.8568a
Cext_15709 \$689 \$734 42.153a
Cext_15710 \$689 \$75 35.6349a
Cext_15711 \$689 \$77 45.8508a
Cext_15712 \$689 IOVDD|vdda 41.4823a
Cext_15713 \$689 VSS|vss 0.335662a
Cext_15714 \$689 VSUBS 257.7a
Cext_15715 \$69 \$70 40.4127a
Cext_15716 \$69 \$702 117.28a
Cext_15717 \$69 \$703 117.28a
Cext_15718 \$69 \$71 74.2602f
Cext_15719 \$69 \$711 68.9157a
Cext_15720 \$69 \$714 68.9157a
Cext_15721 \$69 \$73 904.638a
Cext_15722 \$69 \$730 0.155901a
Cext_15723 \$69 \$731 117.28a
Cext_15724 \$69 \$732 0.343978a
Cext_15725 \$69 \$733 62.8907a
Cext_15726 \$69 \$734 117.28a
Cext_15727 \$69 \$735 0.155901a
Cext_15728 \$69 \$736 62.8907a
Cext_15729 \$69 \$749 106.353a
Cext_15730 \$69 \$75 472.136a
Cext_15731 \$69 \$750 70.7638a
Cext_15732 \$69 \$751 106.353a
Cext_15733 \$69 \$752 0.343978a
Cext_15734 \$69 \$753 70.7638a
Cext_15735 \$69 \$77 271.683a
Cext_15736 \$69 \$779 70.7638a
Cext_15737 \$69 \$781 115.608a
Cext_15738 \$69 \$783 70.7638a
Cext_15739 \$69 \$785 115.719a
Cext_15740 \$69 \$79 30.4252a
Cext_15741 \$69 \$798 117.46a
Cext_15742 \$69 \$799 117.46a
Cext_15743 \$69 \$807 121.2a
Cext_15744 \$69 \$81 31.7245a
Cext_15745 \$69 \$810 121.2a
Cext_15746 \$69 \$825 0.155901a
Cext_15747 \$69 \$826 117.368a
Cext_15748 \$69 \$827 0.343978a
Cext_15749 \$69 \$828 106.42a
Cext_15750 \$69 \$829 117.368a
Cext_15751 \$69 \$830 0.155901a
Cext_15752 \$69 \$831 0.343978a
Cext_15753 \$69 \$832 106.42a
Cext_15754 \$69 \$846 70.7638a
Cext_15755 \$69 \$847 70.7638a
Cext_15756 \$69 \$866 70.7638a
Cext_15757 \$69 \$867 70.7638a
Cext_15758 \$69 \$886 124.989a
Cext_15759 \$69 \$887 117.531a
Cext_15760 \$69 \$888 62.7415a
Cext_15761 \$69 \$889 117.531a
Cext_15762 \$69 \$914 117.531a
Cext_15763 \$69 \$915 0.155901a
Cext_15764 \$69 \$916 0.343978a
Cext_15765 \$69 \$917 81.4508a
Cext_15766 \$69 \$918 117.531a
Cext_15767 \$69 \$919 0.155901a
Cext_15768 \$69 \$920 0.343978a
Cext_15769 \$69 \$921 22.6196a
Cext_15770 \$69 \$934 106.262a
Cext_15771 \$69 \$935 70.7638a
Cext_15772 \$69 \$936 106.262a
Cext_15773 \$69 \$937 70.7638a
Cext_15774 \$69 \$962 70.7638a
Cext_15775 \$69 \$963 121.143a
Cext_15776 \$69 \$964 70.7638a
Cext_15777 \$69 \$966 121.253a
Cext_15778 \$69 \$984 62.8907a
Cext_15779 \$69 \$985 117.368a
Cext_15780 \$69 \$986 62.8907a
Cext_15781 \$69 \$987 117.368a
Cext_15782 \$69 \$997 115.665a
Cext_15783 \$69 d2|dac_soft[2] 1.21055a
Cext_15784 \$69 IOVDD|vdda 609.921a
Cext_15785 \$69 VREF|vref 25.954a
Cext_15786 \$69 VSS|vss 146.528a
Cext_15787 \$69 VSUBS 36.7611f
Cext_15788 \$690 \$702 0.182933a
Cext_15789 \$690 \$713 254.864a
Cext_15790 \$690 \$73 0.182934a
Cext_15791 \$690 \$734 0.360462a
Cext_15792 \$690 \$77 0.107779a
Cext_15793 \$690 IOVDD|vdda 13.2807a
Cext_15794 \$690 VSS|vss 66.2132a
Cext_15795 \$690 VSUBS 818.643a
Cext_15796 \$691 \$703 113.058a
Cext_15797 \$691 \$715 225.319a
Cext_15798 \$691 \$73 0.343978a
Cext_15799 \$691 VSS|vss 60.9228a
Cext_15800 \$691 VSUBS 810.856a
Cext_15801 \$692 \$693 45.0654a
Cext_15802 \$692 \$716 130.128a
Cext_15803 \$692 VDD|vdd 0.592094a
Cext_15804 \$692 VSS|vss 25.1792a
Cext_15805 \$692 VSUBS 659.267a
Cext_15806 \$693 \$694 45.0654a
Cext_15807 \$693 \$717 130.175a
Cext_15808 \$693 VSS|vss 5.452a
Cext_15809 \$693 VSUBS 634.529a
Cext_15810 \$694 \$695 45.0654a
Cext_15811 \$694 \$718 130.175a
Cext_15812 \$694 VSUBS 634.529a
Cext_15813 \$695 \$696 46.4004a
Cext_15814 \$695 \$719 130.175a
Cext_15815 \$695 VSS|vss 0.378729a
Cext_15816 \$695 VSUBS 634.529a
Cext_15817 \$696 \$697 102.889a
Cext_15818 \$696 \$720 254.864a
Cext_15819 \$696 \$742 0.360462a
Cext_15820 \$696 \$83 64.2241a
Cext_15821 \$696 \$89 0.182934a
Cext_15822 \$696 \$93 0.107779a
Cext_15823 \$696 VSS|vss 66.2906a
Cext_15824 \$696 VSUBS 801.109a
Cext_15825 \$697 \$720 0.360462a
Cext_15826 \$697 \$742 42.153a
Cext_15827 \$697 \$83 80.1249a
Cext_15828 \$697 \$85 70.7638a
Cext_15829 \$697 \$87 31.3588a
Cext_15830 \$697 \$89 35.8568a
Cext_15831 \$697 \$91 35.6349a
Cext_15832 \$697 \$93 45.8508a
Cext_15833 \$697 VSS|vss 0.335662a
Cext_15834 \$697 VSUBS 257.974a
Cext_15835 \$698 \$704 113.058a
Cext_15836 \$698 \$722 225.319a
Cext_15837 \$698 \$83 58.9193a
Cext_15838 \$698 \$89 0.343978a
Cext_15839 \$698 VSS|vss 60.9228a
Cext_15840 \$698 VSUBS 810.856a
Cext_15841 \$699 \$700 102.889a
Cext_15842 \$699 \$704 0.182933a
Cext_15843 \$699 \$723 254.864a
Cext_15844 \$699 \$745 0.360462a
Cext_15845 \$699 \$83 64.2241a
Cext_15846 \$699 \$89 0.182934a
Cext_15847 \$699 \$93 0.107779a
Cext_15848 \$699 IOVDD|vdda 13.2807a
Cext_15849 \$699 VSS|vss 66.2132a
Cext_15850 \$699 VSUBS 818.643a
Cext_15851 \$70 d2|dac_soft[2] 26.065a
Cext_15852 \$70 IOVDD|vdda 50.2951a
Cext_15853 \$70 VSS|vss 219.335a
Cext_15854 \$70 VSUBS 421.882a
Cext_15855 \$700 \$723 0.360462a
Cext_15856 \$700 \$745 42.153a
Cext_15857 \$700 \$83 79.9778a
Cext_15858 \$700 \$85 70.7638a
Cext_15859 \$700 \$87 31.3588a
Cext_15860 \$700 \$89 35.8568a
Cext_15861 \$700 \$91 35.6349a
Cext_15862 \$700 \$93 45.8508a
Cext_15863 \$700 IOVDD|vdda 41.4823a
Cext_15864 \$700 VSS|vss 3.53149a
Cext_15865 \$700 VSUBS 257.7a
Cext_15866 \$701 \$705 113.058a
Cext_15867 \$701 \$725 225.319a
Cext_15868 \$701 \$83 58.9193a
Cext_15869 \$701 \$89 0.343978a
Cext_15870 \$701 VSS|vss 69.9251a
Cext_15871 \$701 VSUBS 810.856a
Cext_15872 \$702 \$71 31.3588a
Cext_15873 \$702 \$712 102.889a
Cext_15874 \$702 \$73 34.4538a
Cext_15875 \$702 \$732 0.360462a
Cext_15876 \$702 \$75 35.6349a
Cext_15877 \$702 \$750 42.153a
Cext_15878 \$702 \$77 45.8508a
Cext_15879 \$702 VSS|vss 0.335662a
Cext_15880 \$702 VSUBS 257.767a
Cext_15881 \$703 \$71 31.3588a
Cext_15882 \$703 \$715 102.889a
Cext_15883 \$703 \$73 34.4538a
Cext_15884 \$703 \$75 35.6349a
Cext_15885 \$703 \$752 0.360462a
Cext_15886 \$703 \$753 42.153a
Cext_15887 \$703 \$77 45.8508a
Cext_15888 \$703 VREF|vref 0.182933a
Cext_15889 \$703 VSS|vss 0.335662a
Cext_15890 \$703 VSUBS 257.767a
Cext_15891 \$704 \$722 102.889a
Cext_15892 \$704 \$743 0.360462a
Cext_15893 \$704 \$755 42.153a
Cext_15894 \$704 \$83 69.937a
Cext_15895 \$704 \$85 117.28a
Cext_15896 \$704 \$87 31.3588a
Cext_15897 \$704 \$89 34.4538a
Cext_15898 \$704 \$91 35.6349a
Cext_15899 \$704 \$93 45.8508a
Cext_15900 \$704 VSS|vss 0.335662a
Cext_15901 \$704 VSUBS 257.767a
Cext_15902 \$705 \$725 102.889a
Cext_15903 \$705 \$747 0.360462a
Cext_15904 \$705 \$757 42.153a
Cext_15905 \$705 \$83 69.937a
Cext_15906 \$705 \$85 117.28a
Cext_15907 \$705 \$87 31.3588a
Cext_15908 \$705 \$89 34.4538a
Cext_15909 \$705 \$91 35.6349a
Cext_15910 \$705 \$93 45.8508a
Cext_15911 \$705 VREF|vref 0.182933a
Cext_15912 \$705 VSS|vss 0.335662a
Cext_15913 \$705 VSUBS 257.767a
Cext_15914 \$706 \$707 45.0654a
Cext_15915 \$706 \$726 130.175a
Cext_15916 \$706 VDD|vdd 7.74075a
Cext_15917 \$706 VSS|vss 1.71997a
Cext_15918 \$706 VSUBS 659.267a
Cext_15919 \$707 \$708 45.0654a
Cext_15920 \$707 \$727 130.175a
Cext_15921 \$707 VDD|vdd 0.968272a
Cext_15922 \$707 VSUBS 634.529a
Cext_15923 \$708 \$709 45.0654a
Cext_15924 \$708 \$728 130.175a
Cext_15925 \$708 VSUBS 634.529a
Cext_15926 \$709 \$710 45.8951a
Cext_15927 \$709 \$729 130.175a
Cext_15928 \$709 VSS|vss 0.428128a
Cext_15929 \$709 VSUBS 634.529a
Cext_15930 \$71 \$711 65.2624a
Cext_15931 \$71 \$714 65.2624a
Cext_15932 \$71 \$72 40.4127a
Cext_15933 \$71 \$73 73.7808f
Cext_15934 \$71 \$731 31.3588a
Cext_15935 \$71 \$733 50.1293a
Cext_15936 \$71 \$734 31.3588a
Cext_15937 \$71 \$736 50.1293a
Cext_15938 \$71 \$749 53.443a
Cext_15939 \$71 \$75 357.012a
Cext_15940 \$71 \$750 31.3588a
Cext_15941 \$71 \$751 53.443a
Cext_15942 \$71 \$753 31.3588a
Cext_15943 \$71 \$77 213.03a
Cext_15944 \$71 \$778 0.168339a
Cext_15945 \$71 \$779 33.8269a
Cext_15946 \$71 \$780 0.343978a
Cext_15947 \$71 \$781 7.49159a
Cext_15948 \$71 \$782 0.168339a
Cext_15949 \$71 \$783 33.8269a
Cext_15950 \$71 \$784 0.343978a
Cext_15951 \$71 \$785 7.49159a
Cext_15952 \$71 \$79 29.7164a
Cext_15953 \$71 \$798 32.765a
Cext_15954 \$71 \$799 32.765a
Cext_15955 \$71 \$807 7.5941a
Cext_15956 \$71 \$81 31.0156a
Cext_15957 \$71 \$810 7.5941a
Cext_15958 \$71 \$826 32.765a
Cext_15959 \$71 \$828 53.8878a
Cext_15960 \$71 \$829 32.765a
Cext_15961 \$71 \$832 53.8878a
Cext_15962 \$71 \$846 34.2005a
Cext_15963 \$71 \$847 34.2005a
Cext_15964 \$71 \$866 31.3588a
Cext_15965 \$71 \$867 31.3588a
Cext_15966 \$71 \$886 73.6874a
Cext_15967 \$71 \$887 31.3588a
Cext_15968 \$71 \$888 38.574a
Cext_15969 \$71 \$889 31.3588a
Cext_15970 \$71 \$914 31.3588a
Cext_15971 \$71 \$917 51.1792a
Cext_15972 \$71 \$918 31.3588a
Cext_15973 \$71 \$921 2.83833a
Cext_15974 \$71 \$934 53.7853a
Cext_15975 \$71 \$935 31.3588a
Cext_15976 \$71 \$936 53.7853a
Cext_15977 \$71 \$937 31.3588a
Cext_15978 \$71 \$961 0.168339a
Cext_15979 \$71 \$962 34.2005a
Cext_15980 \$71 \$963 7.49159a
Cext_15981 \$71 \$964 34.2005a
Cext_15982 \$71 \$965 0.168339a
Cext_15983 \$71 \$966 7.41471a
Cext_15984 \$71 \$980 0.343978a
Cext_15985 \$71 \$981 0.343978a
Cext_15986 \$71 \$984 50.1293a
Cext_15987 \$71 \$985 32.765a
Cext_15988 \$71 \$986 50.1293a
Cext_15989 \$71 \$987 32.765a
Cext_15990 \$71 \$997 7.5941a
Cext_15991 \$71 d3|dac_soft[3] 1.21055a
Cext_15992 \$71 IOVDD|vdda 619.712a
Cext_15993 \$71 VREF|vref 13.5214a
Cext_15994 \$71 VSS|vss 145.849a
Cext_15995 \$71 VSUBS 22.2141f
Cext_15996 \$710 \$711 2.16563a
Cext_15997 \$710 \$730 225.319a
Cext_15998 \$710 \$731 102.889a
Cext_15999 \$710 VSS|vss 61.1015a
Cext_16000 \$710 VSUBS 794.068a
Cext_16001 \$711 \$712 0.179323a
Cext_16002 \$711 \$73 3.41995a
Cext_16003 \$711 \$731 86.2689a
Cext_16004 \$711 \$749 788.061a
Cext_16005 \$711 \$75 1.56603a
Cext_16006 \$711 \$77 1.11166a
Cext_16007 \$711 \$779 18.2111a
Cext_16008 \$711 \$807 99.1454a
Cext_16009 \$711 \$826 0.250757a
Cext_16010 \$711 VSUBS 215.818a
Cext_16011 \$712 \$732 254.864a
Cext_16012 \$712 \$750 0.360462a
Cext_16013 \$712 \$77 0.107779a
Cext_16014 \$712 VSS|vss 66.2132a
Cext_16015 \$712 VSUBS 818.454a
Cext_16016 \$713 \$714 2.16563a
Cext_16017 \$713 \$734 102.889a
Cext_16018 \$713 \$735 225.319a
Cext_16019 \$713 IOVDD|vdda 11.6291a
Cext_16020 \$713 VSS|vss 60.9228a
Cext_16021 \$713 VSUBS 810.857a
Cext_16022 \$714 \$715 0.179323a
Cext_16023 \$714 \$73 3.41995a
Cext_16024 \$714 \$734 86.2689a
Cext_16025 \$714 \$75 1.56603a
Cext_16026 \$714 \$751 788.061a
Cext_16027 \$714 \$77 1.11166a
Cext_16028 \$714 \$783 18.2111a
Cext_16029 \$714 \$810 99.1454a
Cext_16030 \$714 \$829 0.250757a
Cext_16031 \$714 IOVDD|vdda 7.57116a
Cext_16032 \$714 VSUBS 215.818a
Cext_16033 \$715 \$752 254.864a
Cext_16034 \$715 \$753 0.360462a
Cext_16035 \$715 \$77 0.107779a
Cext_16036 \$715 VSS|vss 66.2132a
Cext_16037 \$715 VSUBS 818.454a
Cext_16038 \$716 \$717 45.0654a
Cext_16039 \$716 \$737 130.128a
Cext_16040 \$716 VDD|vdd 0.592094a
Cext_16041 \$716 VSS|vss 25.1792a
Cext_16042 \$716 VSUBS 659.267a
Cext_16043 \$717 \$718 45.0654a
Cext_16044 \$717 \$738 130.175a
Cext_16045 \$717 VSS|vss 5.452a
Cext_16046 \$717 VSUBS 634.529a
Cext_16047 \$718 \$719 45.0654a
Cext_16048 \$718 \$739 130.175a
Cext_16049 \$718 VSUBS 634.529a
Cext_16050 \$719 \$720 45.8951a
Cext_16051 \$719 \$740 130.175a
Cext_16052 \$719 VSS|vss 0.428128a
Cext_16053 \$719 VSUBS 634.529a
Cext_16054 \$72 d3|dac_soft[3] 26.065a
Cext_16055 \$72 IOVDD|vdda 50.2951a
Cext_16056 \$72 VSS|vss 219.322a
Cext_16057 \$72 VSUBS 420.808a
Cext_16058 \$720 \$721 2.16563a
Cext_16059 \$720 \$741 225.319a
Cext_16060 \$720 \$742 102.889a
Cext_16061 \$720 \$83 105.694a
Cext_16062 \$720 VSS|vss 61.1015a
Cext_16063 \$720 VSUBS 794.068a
Cext_16064 \$721 \$722 0.179323a
Cext_16065 \$721 \$742 86.2689a
Cext_16066 \$721 \$754 788.061a
Cext_16067 \$721 \$790 18.2111a
Cext_16068 \$721 \$817 99.1454a
Cext_16069 \$721 \$83 1.96577a
Cext_16070 \$721 \$837 0.250757a
Cext_16071 \$721 \$85 68.9157a
Cext_16072 \$721 \$87 65.2624a
Cext_16073 \$721 \$89 3.41995a
Cext_16074 \$721 \$91 1.56603a
Cext_16075 \$721 \$93 1.11166a
Cext_16076 \$721 VSUBS 215.818a
Cext_16077 \$722 \$743 254.864a
Cext_16078 \$722 \$755 0.360462a
Cext_16079 \$722 \$83 110.113a
Cext_16080 \$722 \$93 0.107779a
Cext_16081 \$722 VSS|vss 66.2132a
Cext_16082 \$722 VSUBS 818.454a
Cext_16083 \$723 \$724 2.16563a
Cext_16084 \$723 \$745 102.889a
Cext_16085 \$723 \$746 225.319a
Cext_16086 \$723 \$83 105.694a
Cext_16087 \$723 IOVDD|vdda 11.6291a
Cext_16088 \$723 VSS|vss 60.9228a
Cext_16089 \$723 VSUBS 810.857a
Cext_16090 \$724 \$725 0.179323a
Cext_16091 \$724 \$745 86.2689a
Cext_16092 \$724 \$756 788.061a
Cext_16093 \$724 \$794 18.2111a
Cext_16094 \$724 \$820 99.1454a
Cext_16095 \$724 \$83 1.96577a
Cext_16096 \$724 \$842 0.250757a
Cext_16097 \$724 \$85 68.9157a
Cext_16098 \$724 \$87 65.2624a
Cext_16099 \$724 \$89 3.41995a
Cext_16100 \$724 \$91 1.56603a
Cext_16101 \$724 \$93 1.11166a
Cext_16102 \$724 IOVDD|vdda 7.57116a
Cext_16103 \$724 VSS|vss 12.5631a
Cext_16104 \$724 VSUBS 215.818a
Cext_16105 \$725 \$747 254.864a
Cext_16106 \$725 \$757 0.360462a
Cext_16107 \$725 \$83 110.113a
Cext_16108 \$725 \$93 0.107779a
Cext_16109 \$725 VSS|vss 75.3227a
Cext_16110 \$725 VSUBS 818.454a
Cext_16111 \$726 \$727 45.0654a
Cext_16112 \$726 \$758 130.175a
Cext_16113 \$726 VDD|vdd 7.74075a
Cext_16114 \$726 VSS|vss 1.71997a
Cext_16115 \$726 VSUBS 659.267a
Cext_16116 \$727 \$728 45.0654a
Cext_16117 \$727 \$759 130.175a
Cext_16118 \$727 VDD|vdd 0.968272a
Cext_16119 \$727 VSUBS 634.529a
Cext_16120 \$728 \$729 45.0654a
Cext_16121 \$728 \$760 130.175a
Cext_16122 \$728 VSUBS 634.529a
Cext_16123 \$729 \$730 46.4004a
Cext_16124 \$729 \$761 130.175a
Cext_16125 \$729 VSS|vss 0.378729a
Cext_16126 \$729 VSUBS 634.529a
Cext_16127 \$73 \$731 34.4538a
Cext_16128 \$73 \$733 49.6419a
Cext_16129 \$73 \$734 34.4538a
Cext_16130 \$73 \$736 49.6419a
Cext_16131 \$73 \$74 40.4127a
Cext_16132 \$73 \$749 3.67334a
Cext_16133 \$73 \$75 74.0955f
Cext_16134 \$73 \$750 36.0823a
Cext_16135 \$73 \$751 3.67334a
Cext_16136 \$73 \$753 36.0823a
Cext_16137 \$73 \$77 226.641a
Cext_16138 \$73 \$779 32.5775a
Cext_16139 \$73 \$781 3.82035a
Cext_16140 \$73 \$783 32.5775a
Cext_16141 \$73 \$785 3.82035a
Cext_16142 \$73 \$79 33.4967a
Cext_16143 \$73 \$798 32.5775a
Cext_16144 \$73 \$799 32.5775a
Cext_16145 \$73 \$807 3.34353a
Cext_16146 \$73 \$81 33.7344a
Cext_16147 \$73 \$810 3.34353a
Cext_16148 \$73 \$826 32.5775a
Cext_16149 \$73 \$828 3.34353a
Cext_16150 \$73 \$829 32.5775a
Cext_16151 \$73 \$832 3.34353a
Cext_16152 \$73 \$846 32.5775a
Cext_16153 \$73 \$847 32.5775a
Cext_16154 \$73 \$866 32.5775a
Cext_16155 \$73 \$867 32.5775a
Cext_16156 \$73 \$886 96.4288a
Cext_16157 \$73 \$887 32.5775a
Cext_16158 \$73 \$888 23.2418a
Cext_16159 \$73 \$889 32.5775a
Cext_16160 \$73 \$914 32.5775a
Cext_16161 \$73 \$917 38.1888a
Cext_16162 \$73 \$918 32.5775a
Cext_16163 \$73 \$921 2.18131a
Cext_16164 \$73 \$934 3.34353a
Cext_16165 \$73 \$935 32.5775a
Cext_16166 \$73 \$936 3.34353a
Cext_16167 \$73 \$937 32.5775a
Cext_16168 \$73 \$962 32.5775a
Cext_16169 \$73 \$963 3.34353a
Cext_16170 \$73 \$964 32.5775a
Cext_16171 \$73 \$966 3.2971a
Cext_16172 \$73 \$984 49.6419a
Cext_16173 \$73 \$985 32.5775a
Cext_16174 \$73 \$986 49.6419a
Cext_16175 \$73 \$987 32.5775a
Cext_16176 \$73 \$997 3.82035a
Cext_16177 \$73 d4|dac_soft[4] 1.21055a
Cext_16178 \$73 IOVDD|vdda 623.742a
Cext_16179 \$73 VREF|vref 8.07618a
Cext_16180 \$73 VSS|vss 145.677a
Cext_16181 \$73 VSUBS 17.4479f
Cext_16182 \$730 \$731 114.006a
Cext_16183 \$730 \$762 254.864a
Cext_16184 \$730 \$779 0.360462a
Cext_16185 \$730 VSS|vss 66.2906a
Cext_16186 \$730 VSUBS 799.746a
Cext_16187 \$731 \$732 0.182933a
Cext_16188 \$731 \$749 98.5952a
Cext_16189 \$731 \$75 35.6349a
Cext_16190 \$731 \$762 0.360462a
Cext_16191 \$731 \$77 45.7852a
Cext_16192 \$731 \$779 108.267a
Cext_16193 \$731 VSS|vss 0.378848a
Cext_16194 \$731 VSUBS 257.682a
Cext_16195 \$732 \$733 2.16563a
Cext_16196 \$732 \$750 102.889a
Cext_16197 \$732 \$763 225.319a
Cext_16198 \$732 VSS|vss 60.9228a
Cext_16199 \$732 VSUBS 811.667a
Cext_16200 \$733 \$735 0.179323a
Cext_16201 \$733 \$75 1.56603a
Cext_16202 \$733 \$750 86.2689a
Cext_16203 \$733 \$77 1.0855a
Cext_16204 \$733 \$781 788.061a
Cext_16205 \$733 \$798 18.2111a
Cext_16206 \$733 \$828 99.1454a
Cext_16207 \$733 \$846 0.250757a
Cext_16208 \$733 VSUBS 218.017a
Cext_16209 \$734 \$735 114.006a
Cext_16210 \$734 \$75 35.6349a
Cext_16211 \$734 \$751 98.5952a
Cext_16212 \$734 \$752 0.182933a
Cext_16213 \$734 \$764 0.360462a
Cext_16214 \$734 \$77 45.7852a
Cext_16215 \$734 \$783 108.267a
Cext_16216 \$734 IOVDD|vdda 41.5615a
Cext_16217 \$734 VSS|vss 0.378848a
Cext_16218 \$734 VSUBS 257.408a
Cext_16219 \$735 \$764 254.864a
Cext_16220 \$735 \$783 0.360462a
Cext_16221 \$735 IOVDD|vdda 13.0646a
Cext_16222 \$735 VSS|vss 66.2132a
Cext_16223 \$735 VSUBS 817.169a
Cext_16224 \$736 \$75 1.56603a
Cext_16225 \$736 \$752 2.16563a
Cext_16226 \$736 \$753 86.2689a
Cext_16227 \$736 \$77 1.0855a
Cext_16228 \$736 \$785 788.061a
Cext_16229 \$736 \$799 18.2111a
Cext_16230 \$736 \$832 99.1454a
Cext_16231 \$736 \$847 0.250757a
Cext_16232 \$736 VREF|vref 0.898171a
Cext_16233 \$736 VSUBS 218.086a
Cext_16234 \$737 \$738 45.0654a
Cext_16235 \$737 \$766 130.128a
Cext_16236 \$737 VDD|vdd 0.592094a
Cext_16237 \$737 VSS|vss 25.1792a
Cext_16238 \$737 VSUBS 659.267a
Cext_16239 \$738 \$739 45.0654a
Cext_16240 \$738 \$767 130.175a
Cext_16241 \$738 VSS|vss 5.452a
Cext_16242 \$738 VSUBS 634.529a
Cext_16243 \$739 \$740 45.0654a
Cext_16244 \$739 \$768 130.175a
Cext_16245 \$739 VSUBS 634.529a
Cext_16246 \$74 d4|dac_soft[4] 26.065a
Cext_16247 \$74 IOVDD|vdda 50.2951a
Cext_16248 \$74 VSS|vss 219.335a
Cext_16249 \$74 VSUBS 421.882a
Cext_16250 \$740 \$741 46.4004a
Cext_16251 \$740 \$769 130.175a
Cext_16252 \$740 VSS|vss 0.378729a
Cext_16253 \$740 VSUBS 634.529a
Cext_16254 \$741 \$742 114.006a
Cext_16255 \$741 \$770 254.864a
Cext_16256 \$741 \$790 0.360462a
Cext_16257 \$741 \$83 64.1221a
Cext_16258 \$741 \$85 0.155901a
Cext_16259 \$741 VSS|vss 66.2906a
Cext_16260 \$741 VSUBS 799.746a
Cext_16261 \$742 \$743 0.182933a
Cext_16262 \$742 \$754 98.5952a
Cext_16263 \$742 \$770 0.360462a
Cext_16264 \$742 \$790 108.267a
Cext_16265 \$742 \$83 69.9941a
Cext_16266 \$742 \$85 117.28a
Cext_16267 \$742 \$87 31.3588a
Cext_16268 \$742 \$89 34.4538a
Cext_16269 \$742 \$91 35.6349a
Cext_16270 \$742 \$93 45.7852a
Cext_16271 \$742 VSS|vss 0.378848a
Cext_16272 \$742 VSUBS 257.682a
Cext_16273 \$743 \$744 2.16563a
Cext_16274 \$743 \$755 102.889a
Cext_16275 \$743 \$771 225.319a
Cext_16276 \$743 \$83 59.1234a
Cext_16277 \$743 \$85 0.343978a
Cext_16278 \$743 VSS|vss 60.9228a
Cext_16279 \$743 VSUBS 811.667a
Cext_16280 \$744 \$746 0.179323a
Cext_16281 \$744 \$755 86.2689a
Cext_16282 \$744 \$793 788.061a
Cext_16283 \$744 \$800 18.2111a
Cext_16284 \$744 \$840 99.1454a
Cext_16285 \$744 \$848 0.250757a
Cext_16286 \$744 \$85 62.8907a
Cext_16287 \$744 \$87 50.1293a
Cext_16288 \$744 \$89 49.6419a
Cext_16289 \$744 \$91 1.56603a
Cext_16290 \$744 \$93 1.0855a
Cext_16291 \$744 VSUBS 218.017a
Cext_16292 \$745 \$746 114.006a
Cext_16293 \$745 \$747 0.182933a
Cext_16294 \$745 \$756 98.5952a
Cext_16295 \$745 \$772 0.360462a
Cext_16296 \$745 \$794 108.267a
Cext_16297 \$745 \$83 69.8469a
Cext_16298 \$745 \$85 117.28a
Cext_16299 \$745 \$87 31.3588a
Cext_16300 \$745 \$89 34.4538a
Cext_16301 \$745 \$91 35.6349a
Cext_16302 \$745 \$93 45.7852a
Cext_16303 \$745 IOVDD|vdda 41.5615a
Cext_16304 \$745 VSS|vss 4.11136a
Cext_16305 \$745 VSUBS 257.408a
Cext_16306 \$746 \$772 254.864a
Cext_16307 \$746 \$794 0.360462a
Cext_16308 \$746 \$83 64.1221a
Cext_16309 \$746 \$85 0.155901a
Cext_16310 \$746 IOVDD|vdda 13.0646a
Cext_16311 \$746 VSS|vss 66.2132a
Cext_16312 \$746 VSUBS 817.169a
Cext_16313 \$747 \$748 2.16563a
Cext_16314 \$747 \$757 102.889a
Cext_16315 \$747 \$773 225.319a
Cext_16316 \$747 \$83 59.1234a
Cext_16317 \$747 \$85 0.343978a
Cext_16318 \$747 VSS|vss 69.9251a
Cext_16319 \$747 VSUBS 811.667a
Cext_16320 \$748 \$757 86.2689a
Cext_16321 \$748 \$797 788.061a
Cext_16322 \$748 \$801 18.2111a
Cext_16323 \$748 \$844 99.1454a
Cext_16324 \$748 \$849 0.250757a
Cext_16325 \$748 \$85 62.8907a
Cext_16326 \$748 \$87 50.1293a
Cext_16327 \$748 \$89 49.6419a
Cext_16328 \$748 \$91 1.56603a
Cext_16329 \$748 \$93 1.0855a
Cext_16330 \$748 VREF|vref 0.898171a
Cext_16331 \$748 VSUBS 218.086a
Cext_16332 \$749 \$75 1.61371a
Cext_16333 \$749 \$77 1.13718a
Cext_16334 \$749 \$778 3.25406a
Cext_16335 \$749 \$779 227.572a
Cext_16336 \$749 \$780 0.179323a
Cext_16337 \$749 \$807 7.41179a
Cext_16338 \$749 VSUBS 168.446a
Cext_16339 \$75 \$750 35.6349a
Cext_16340 \$75 \$751 1.61371a
Cext_16341 \$75 \$753 35.6349a
Cext_16342 \$75 \$76 40.4127a
Cext_16343 \$75 \$77 74.5787f
Cext_16344 \$75 \$779 35.6349a
Cext_16345 \$75 \$781 1.61371a
Cext_16346 \$75 \$783 35.6349a
Cext_16347 \$75 \$785 1.61371a
Cext_16348 \$75 \$79 32.8143a
Cext_16349 \$75 \$798 35.6349a
Cext_16350 \$75 \$799 35.6349a
Cext_16351 \$75 \$807 1.52179a
Cext_16352 \$75 \$81 32.7446a
Cext_16353 \$75 \$810 1.52179a
Cext_16354 \$75 \$826 35.6349a
Cext_16355 \$75 \$828 1.52179a
Cext_16356 \$75 \$829 35.6349a
Cext_16357 \$75 \$832 1.52179a
Cext_16358 \$75 \$846 35.6349a
Cext_16359 \$75 \$847 35.6349a
Cext_16360 \$75 \$866 35.6349a
Cext_16361 \$75 \$867 35.6349a
Cext_16362 \$75 \$886 57.5347a
Cext_16363 \$75 \$887 35.6349a
Cext_16364 \$75 \$888 22.4365a
Cext_16365 \$75 \$889 35.6349a
Cext_16366 \$75 \$914 35.6349a
Cext_16367 \$75 \$917 33.4754a
Cext_16368 \$75 \$918 35.6349a
Cext_16369 \$75 \$921 1.77555a
Cext_16370 \$75 \$934 1.61371a
Cext_16371 \$75 \$935 35.6349a
Cext_16372 \$75 \$936 1.61371a
Cext_16373 \$75 \$937 35.6349a
Cext_16374 \$75 \$962 35.6349a
Cext_16375 \$75 \$963 1.61371a
Cext_16376 \$75 \$964 35.6349a
Cext_16377 \$75 \$966 1.49115a
Cext_16378 \$75 \$984 1.56603a
Cext_16379 \$75 \$985 35.6349a
Cext_16380 \$75 \$986 1.56603a
Cext_16381 \$75 \$987 35.6349a
Cext_16382 \$75 \$997 1.52179a
Cext_16383 \$75 d5|dac_soft[5] 1.21055a
Cext_16384 \$75 IOVDD|vdda 636.538a
Cext_16385 \$75 VREF|vref 4.6364a
Cext_16386 \$75 VSS|vss 145.677a
Cext_16387 \$75 VSUBS 14.4753f
Cext_16388 \$750 \$763 114.006a
Cext_16389 \$750 \$764 0.182933a
Cext_16390 \$750 \$77 45.7852a
Cext_16391 \$750 \$780 0.360462a
Cext_16392 \$750 \$781 98.5952a
Cext_16393 \$750 \$798 108.267a
Cext_16394 \$750 VSS|vss 0.378848a
Cext_16395 \$750 VSUBS 257.776a
Cext_16396 \$751 \$77 1.13718a
Cext_16397 \$751 \$782 3.25406a
Cext_16398 \$751 \$783 227.572a
Cext_16399 \$751 \$784 0.179323a
Cext_16400 \$751 \$810 7.41179a
Cext_16401 \$751 IOVDD|vdda 5.1897a
Cext_16402 \$751 VSUBS 168.446a
Cext_16403 \$752 \$753 102.889a
Cext_16404 \$752 \$765 225.319a
Cext_16405 \$752 VSS|vss 60.9228a
Cext_16406 \$752 VSUBS 811.667a
Cext_16407 \$753 \$765 114.006a
Cext_16408 \$753 \$77 45.7852a
Cext_16409 \$753 \$784 0.360462a
Cext_16410 \$753 \$785 98.5952a
Cext_16411 \$753 \$799 108.267a
Cext_16412 \$753 VREF|vref 0.182933a
Cext_16413 \$753 VSS|vss 0.378848a
Cext_16414 \$753 VSUBS 257.776a
Cext_16415 \$754 \$790 227.572a
Cext_16416 \$754 \$791 3.25406a
Cext_16417 \$754 \$792 0.179323a
Cext_16418 \$754 \$817 7.41179a
Cext_16419 \$754 \$85 106.353a
Cext_16420 \$754 \$87 53.443a
Cext_16421 \$754 \$89 3.67334a
Cext_16422 \$754 \$91 1.61371a
Cext_16423 \$754 \$93 1.13718a
Cext_16424 \$754 VSUBS 168.446a
Cext_16425 \$755 \$771 114.006a
Cext_16426 \$755 \$772 0.182933a
Cext_16427 \$755 \$792 0.360462a
Cext_16428 \$755 \$793 98.5952a
Cext_16429 \$755 \$800 108.267a
Cext_16430 \$755 \$83 80.1821a
Cext_16431 \$755 \$85 70.7638a
Cext_16432 \$755 \$87 31.3588a
Cext_16433 \$755 \$89 36.0823a
Cext_16434 \$755 \$91 35.6349a
Cext_16435 \$755 \$93 45.7852a
Cext_16436 \$755 VSS|vss 0.378848a
Cext_16437 \$755 VSUBS 257.776a
Cext_16438 \$756 \$794 227.572a
Cext_16439 \$756 \$795 3.25406a
Cext_16440 \$756 \$796 0.179323a
Cext_16441 \$756 \$820 7.41179a
Cext_16442 \$756 \$85 106.353a
Cext_16443 \$756 \$87 53.443a
Cext_16444 \$756 \$89 3.67334a
Cext_16445 \$756 \$91 1.61371a
Cext_16446 \$756 \$93 1.13718a
Cext_16447 \$756 IOVDD|vdda 5.1897a
Cext_16448 \$756 VSS|vss 5.67282a
Cext_16449 \$756 VSUBS 168.446a
Cext_16450 \$757 \$773 114.006a
Cext_16451 \$757 \$796 0.360462a
Cext_16452 \$757 \$797 98.5952a
Cext_16453 \$757 \$801 108.267a
Cext_16454 \$757 \$83 80.1821a
Cext_16455 \$757 \$85 70.7638a
Cext_16456 \$757 \$87 31.3588a
Cext_16457 \$757 \$89 36.0823a
Cext_16458 \$757 \$91 35.6349a
Cext_16459 \$757 \$93 45.7852a
Cext_16460 \$757 VREF|vref 0.182933a
Cext_16461 \$757 VSS|vss 0.378848a
Cext_16462 \$757 VSUBS 257.776a
Cext_16463 \$758 \$759 45.0654a
Cext_16464 \$758 \$774 130.175a
Cext_16465 \$758 VDD|vdd 7.74075a
Cext_16466 \$758 VSS|vss 1.71997a
Cext_16467 \$758 VSUBS 659.267a
Cext_16468 \$759 \$760 45.0654a
Cext_16469 \$759 \$775 130.175a
Cext_16470 \$759 VDD|vdd 0.968272a
Cext_16471 \$759 VSUBS 634.529a
Cext_16472 \$76 d5|dac_soft[5] 26.065a
Cext_16473 \$76 IOVDD|vdda 50.2951a
Cext_16474 \$76 VSS|vss 219.335a
Cext_16475 \$76 VSUBS 421.882a
Cext_16476 \$760 \$761 45.0654a
Cext_16477 \$760 \$776 130.175a
Cext_16478 \$760 VSUBS 634.529a
Cext_16479 \$761 \$762 45.8951a
Cext_16480 \$761 \$777 130.175a
Cext_16481 \$761 VSS|vss 0.428128a
Cext_16482 \$761 VSUBS 634.529a
Cext_16483 \$762 \$778 225.319a
Cext_16484 \$762 \$779 113.058a
Cext_16485 \$762 VSS|vss 61.1015a
Cext_16486 \$762 VSUBS 793.257a
Cext_16487 \$763 \$779 0.182933a
Cext_16488 \$763 \$780 254.864a
Cext_16489 \$763 \$798 0.360462a
Cext_16490 \$763 VSS|vss 66.2132a
Cext_16491 \$763 VSUBS 817.162a
Cext_16492 \$764 \$782 225.319a
Cext_16493 \$764 \$783 113.058a
Cext_16494 \$764 IOVDD|vdda 11.5102a
Cext_16495 \$764 VSS|vss 60.9228a
Cext_16496 \$764 VSUBS 810.376a
Cext_16497 \$765 \$783 0.182933a
Cext_16498 \$765 \$784 254.864a
Cext_16499 \$765 \$799 0.360462a
Cext_16500 \$765 VSS|vss 66.2132a
Cext_16501 \$765 VSUBS 817.162a
Cext_16502 \$766 \$767 45.0654a
Cext_16503 \$766 \$786 130.128a
Cext_16504 \$766 VDD|vdd 0.592094a
Cext_16505 \$766 VSS|vss 25.1792a
Cext_16506 \$766 VSUBS 659.267a
Cext_16507 \$767 \$768 45.0654a
Cext_16508 \$767 \$787 130.175a
Cext_16509 \$767 VSS|vss 5.452a
Cext_16510 \$767 VSUBS 634.529a
Cext_16511 \$768 \$769 45.0654a
Cext_16512 \$768 \$788 130.175a
Cext_16513 \$768 VSUBS 634.529a
Cext_16514 \$769 \$770 45.8951a
Cext_16515 \$769 \$789 130.175a
Cext_16516 \$769 VSS|vss 0.428128a
Cext_16517 \$769 VSUBS 634.529a
Cext_16518 \$77 \$778 0.107779a
Cext_16519 \$77 \$779 45.8508a
Cext_16520 \$77 \$78 40.4127a
Cext_16521 \$77 \$781 1.13718a
Cext_16522 \$77 \$782 0.107779a
Cext_16523 \$77 \$783 45.8508a
Cext_16524 \$77 \$785 1.13718a
Cext_16525 \$77 \$79 35.0401a
Cext_16526 \$77 \$798 45.8508a
Cext_16527 \$77 \$799 45.8508a
Cext_16528 \$77 \$807 1.54922a
Cext_16529 \$77 \$808 0.107779a
Cext_16530 \$77 \$81 33.4076a
Cext_16531 \$77 \$810 1.54922a
Cext_16532 \$77 \$811 0.107779a
Cext_16533 \$77 \$826 45.7852a
Cext_16534 \$77 \$828 1.40221a
Cext_16535 \$77 \$829 45.7852a
Cext_16536 \$77 \$832 1.40221a
Cext_16537 \$77 \$846 45.7852a
Cext_16538 \$77 \$847 45.7852a
Cext_16539 \$77 \$866 50.9884a
Cext_16540 \$77 \$867 50.9884a
Cext_16541 \$77 \$873 0.329088a
Cext_16542 \$77 \$874 0.343978a
Cext_16543 \$77 \$875 0.329088a
Cext_16544 \$77 \$876 0.343978a
Cext_16545 \$77 \$886 106.986a
Cext_16546 \$77 \$887 48.6674a
Cext_16547 \$77 \$888 76.911a
Cext_16548 \$77 \$889 48.6674a
Cext_16549 \$77 \$899 0.107779a
Cext_16550 \$77 \$901 0.107779a
Cext_16551 \$77 \$914 48.6018a
Cext_16552 \$77 \$917 93.7799a
Cext_16553 \$77 \$918 48.6018a
Cext_16554 \$77 \$921 63.198a
Cext_16555 \$77 \$934 1.46698a
Cext_16556 \$77 \$935 50.9228a
Cext_16557 \$77 \$936 1.46698a
Cext_16558 \$77 \$937 50.9228a
Cext_16559 \$77 \$961 0.107779a
Cext_16560 \$77 \$962 45.8508a
Cext_16561 \$77 \$963 1.61399a
Cext_16562 \$77 \$964 45.8508a
Cext_16563 \$77 \$965 0.107779a
Cext_16564 \$77 \$966 1.52763a
Cext_16565 \$77 \$984 1.0855a
Cext_16566 \$77 \$985 45.8508a
Cext_16567 \$77 \$986 0.992855a
Cext_16568 \$77 \$987 45.8508a
Cext_16569 \$77 \$997 1.0724a
Cext_16570 \$77 \$998 0.107779a
Cext_16571 \$77 d6|dac_soft[6] 1.21055a
Cext_16572 \$77 IOVDD|vdda 673.393a
Cext_16573 \$77 VREF|vref 4.49475a
Cext_16574 \$77 VSS|vss 145.677a
Cext_16575 \$77 VSUBS 13.4063f
Cext_16576 \$770 \$790 113.058a
Cext_16577 \$770 \$791 225.319a
Cext_16578 \$770 \$83 105.489a
Cext_16579 \$770 VSS|vss 61.1015a
Cext_16580 \$770 VSUBS 793.257a
Cext_16581 \$771 \$790 0.182933a
Cext_16582 \$771 \$792 254.864a
Cext_16583 \$771 \$800 0.360462a
Cext_16584 \$771 \$83 110.011a
Cext_16585 \$771 VSS|vss 66.2132a
Cext_16586 \$771 VSUBS 817.162a
Cext_16587 \$772 \$794 113.058a
Cext_16588 \$772 \$795 225.319a
Cext_16589 \$772 \$83 105.489a
Cext_16590 \$772 IOVDD|vdda 11.5102a
Cext_16591 \$772 VSS|vss 60.9228a
Cext_16592 \$772 VSUBS 810.376a
Cext_16593 \$773 \$794 0.182933a
Cext_16594 \$773 \$796 254.864a
Cext_16595 \$773 \$801 0.360462a
Cext_16596 \$773 \$83 110.011a
Cext_16597 \$773 VSS|vss 75.4228a
Cext_16598 \$773 VSUBS 817.162a
Cext_16599 \$774 \$775 45.0654a
Cext_16600 \$774 \$802 130.175a
Cext_16601 \$774 VDD|vdd 7.74075a
Cext_16602 \$774 VSS|vss 1.71997a
Cext_16603 \$774 VSUBS 659.267a
Cext_16604 \$775 \$776 45.0654a
Cext_16605 \$775 \$803 130.175a
Cext_16606 \$775 VDD|vdd 0.968272a
Cext_16607 \$775 VSUBS 634.529a
Cext_16608 \$776 \$777 45.0654a
Cext_16609 \$776 \$804 130.175a
Cext_16610 \$776 VSUBS 634.529a
Cext_16611 \$777 \$778 46.4004a
Cext_16612 \$777 \$805 130.175a
Cext_16613 \$777 VSS|vss 0.378729a
Cext_16614 \$777 VSUBS 634.529a
Cext_16615 \$778 \$779 102.889a
Cext_16616 \$778 \$806 254.864a
Cext_16617 \$778 \$826 0.360462a
Cext_16618 \$778 VSS|vss 66.2906a
Cext_16619 \$778 VSUBS 800.931a
Cext_16620 \$779 \$806 0.360462a
Cext_16621 \$779 \$826 42.153a
Cext_16622 \$779 VSS|vss 0.335662a
Cext_16623 \$779 VSUBS 255.945a
Cext_16624 \$78 d6|dac_soft[6] 26.065a
Cext_16625 \$78 IOVDD|vdda 50.2951a
Cext_16626 \$78 VSS|vss 219.335a
Cext_16627 \$78 VSUBS 421.882a
Cext_16628 \$780 \$798 113.058a
Cext_16629 \$780 \$808 225.319a
Cext_16630 \$780 VSS|vss 60.9228a
Cext_16631 \$780 VSUBS 810.856a
Cext_16632 \$781 \$798 227.572a
Cext_16633 \$781 \$808 3.25406a
Cext_16634 \$781 \$809 0.179323a
Cext_16635 \$781 \$828 7.41179a
Cext_16636 \$781 VSUBS 167.777a
Cext_16637 \$782 \$783 102.889a
Cext_16638 \$782 \$798 0.182933a
Cext_16639 \$782 \$809 254.864a
Cext_16640 \$782 \$829 0.360462a
Cext_16641 \$782 IOVDD|vdda 13.2807a
Cext_16642 \$782 VSS|vss 66.2132a
Cext_16643 \$782 VSUBS 818.465a
Cext_16644 \$783 \$809 0.360462a
Cext_16645 \$783 \$829 42.153a
Cext_16646 \$783 IOVDD|vdda 41.4464a
Cext_16647 \$783 VSS|vss 0.335662a
Cext_16648 \$783 VSUBS 255.671a
Cext_16649 \$784 \$799 113.058a
Cext_16650 \$784 \$811 225.319a
Cext_16651 \$784 VSS|vss 60.9228a
Cext_16652 \$784 VSUBS 810.856a
Cext_16653 \$785 \$799 227.572a
Cext_16654 \$785 \$811 3.25406a
Cext_16655 \$785 \$832 7.41179a
Cext_16656 \$785 VREF|vref 0.489684a
Cext_16657 \$785 VSUBS 167.8a
Cext_16658 \$786 \$787 45.0654a
Cext_16659 \$786 \$812 130.128a
Cext_16660 \$786 VDD|vdd 0.592094a
Cext_16661 \$786 VSS|vss 25.1792a
Cext_16662 \$786 VSUBS 659.267a
Cext_16663 \$787 \$788 45.0654a
Cext_16664 \$787 \$813 130.175a
Cext_16665 \$787 VSS|vss 5.452a
Cext_16666 \$787 VSUBS 634.529a
Cext_16667 \$788 \$789 45.0654a
Cext_16668 \$788 \$814 130.175a
Cext_16669 \$788 VSUBS 634.529a
Cext_16670 \$789 \$791 46.4004a
Cext_16671 \$789 \$815 130.175a
Cext_16672 \$789 VSS|vss 0.378729a
Cext_16673 \$789 VSUBS 634.529a
Cext_16674 \$79 \$80 40.4127a
Cext_16675 \$79 \$81 12.3209f
Cext_16676 \$79 \$886 103.146a
Cext_16677 \$79 \$888 108.293a
Cext_16678 \$79 \$917 60.8307a
Cext_16679 \$79 \$921 61.8196a
Cext_16680 \$79 \$967 120.443a
Cext_16681 \$79 d7|dac_soft[7] 1.21055a
Cext_16682 \$79 inn|out|vth_soft 46.2792a
Cext_16683 \$79 IOVDD|vdda 449.202a
Cext_16684 \$79 VREF|vref 7.67109a
Cext_16685 \$79 VSS|vss 136.505a
Cext_16686 \$79 VSUBS 5.32416f
Cext_16687 \$790 \$791 102.889a
Cext_16688 \$790 \$816 0.360462a
Cext_16689 \$790 \$83 80.1249a
Cext_16690 \$790 \$837 42.153a
Cext_16691 \$790 \$85 70.7638a
Cext_16692 \$790 \$87 33.8269a
Cext_16693 \$790 \$89 32.5775a
Cext_16694 \$790 \$91 35.6349a
Cext_16695 \$790 \$93 45.8508a
Cext_16696 \$790 VSS|vss 0.335662a
Cext_16697 \$790 VSUBS 255.945a
Cext_16698 \$791 \$816 254.864a
Cext_16699 \$791 \$83 64.1221a
Cext_16700 \$791 \$837 0.360462a
Cext_16701 \$791 \$87 0.168339a
Cext_16702 \$791 \$93 0.107779a
Cext_16703 \$791 VSS|vss 66.2906a
Cext_16704 \$791 VSUBS 800.931a
Cext_16705 \$792 \$800 113.058a
Cext_16706 \$792 \$818 225.319a
Cext_16707 \$792 \$83 58.9193a
Cext_16708 \$792 \$87 0.343978a
Cext_16709 \$792 VSS|vss 60.9228a
Cext_16710 \$792 VSUBS 810.856a
Cext_16711 \$793 \$800 227.572a
Cext_16712 \$793 \$818 3.25406a
Cext_16713 \$793 \$819 0.179323a
Cext_16714 \$793 \$83 2.30683a
Cext_16715 \$793 \$840 7.41179a
Cext_16716 \$793 \$85 115.608a
Cext_16717 \$793 \$87 7.49159a
Cext_16718 \$793 \$89 3.82035a
Cext_16719 \$793 \$91 1.61371a
Cext_16720 \$793 \$93 1.13718a
Cext_16721 \$793 VSUBS 167.777a
Cext_16722 \$794 \$795 102.889a
Cext_16723 \$794 \$819 0.360462a
Cext_16724 \$794 \$83 79.9778a
Cext_16725 \$794 \$842 42.153a
Cext_16726 \$794 \$85 70.7638a
Cext_16727 \$794 \$87 33.8269a
Cext_16728 \$794 \$89 32.5775a
Cext_16729 \$794 \$91 35.6349a
Cext_16730 \$794 \$93 45.8508a
Cext_16731 \$794 IOVDD|vdda 41.4464a
Cext_16732 \$794 VSS|vss 3.45571a
Cext_16733 \$794 VSUBS 255.671a
Cext_16734 \$795 \$800 0.182933a
Cext_16735 \$795 \$819 254.864a
Cext_16736 \$795 \$83 64.1221a
Cext_16737 \$795 \$842 0.360462a
Cext_16738 \$795 \$87 0.168339a
Cext_16739 \$795 \$93 0.107779a
Cext_16740 \$795 IOVDD|vdda 13.2807a
Cext_16741 \$795 VSS|vss 66.2132a
Cext_16742 \$795 VSUBS 818.465a
Cext_16743 \$796 \$801 113.058a
Cext_16744 \$796 \$821 225.319a
Cext_16745 \$796 \$83 58.9193a
Cext_16746 \$796 \$87 0.343978a
Cext_16747 \$796 VSS|vss 69.9251a
Cext_16748 \$796 VSUBS 810.856a
Cext_16749 \$797 \$801 227.572a
Cext_16750 \$797 \$821 3.25406a
Cext_16751 \$797 \$83 2.30683a
Cext_16752 \$797 \$844 7.41179a
Cext_16753 \$797 \$85 115.719a
Cext_16754 \$797 \$87 7.49159a
Cext_16755 \$797 \$89 3.82035a
Cext_16756 \$797 \$91 1.61371a
Cext_16757 \$797 \$93 1.13718a
Cext_16758 \$797 VREF|vref 0.489684a
Cext_16759 \$797 VSUBS 167.8a
Cext_16760 \$798 \$808 102.889a
Cext_16761 \$798 \$827 0.360462a
Cext_16762 \$798 \$846 42.153a
Cext_16763 \$798 VSS|vss 0.335662a
Cext_16764 \$798 VSUBS 255.562a
Cext_16765 \$799 \$811 102.889a
Cext_16766 \$799 \$831 0.360462a
Cext_16767 \$799 \$847 42.153a
Cext_16768 \$799 VREF|vref 0.182933a
Cext_16769 \$799 VSS|vss 0.335662a
Cext_16770 \$799 VSUBS 255.562a
Cext_16771 \$80 d7|dac_soft[7] 26.065a
Cext_16772 \$80 IOVDD|vdda 52.9251a
Cext_16773 \$80 VSS|vss 219.335a
Cext_16774 \$80 VSUBS 421.882a
Cext_16775 \$800 \$818 102.889a
Cext_16776 \$800 \$83 69.937a
Cext_16777 \$800 \$839 0.360462a
Cext_16778 \$800 \$848 42.153a
Cext_16779 \$800 \$85 117.46a
Cext_16780 \$800 \$87 32.765a
Cext_16781 \$800 \$89 32.5775a
Cext_16782 \$800 \$91 35.6349a
Cext_16783 \$800 \$93 45.8508a
Cext_16784 \$800 VSS|vss 0.335662a
Cext_16785 \$800 VSUBS 255.562a
Cext_16786 \$801 \$821 102.889a
Cext_16787 \$801 \$83 69.937a
Cext_16788 \$801 \$843 0.360462a
Cext_16789 \$801 \$849 42.153a
Cext_16790 \$801 \$85 117.46a
Cext_16791 \$801 \$87 32.765a
Cext_16792 \$801 \$89 32.5775a
Cext_16793 \$801 \$91 35.6349a
Cext_16794 \$801 \$93 45.8508a
Cext_16795 \$801 VREF|vref 0.182933a
Cext_16796 \$801 VSS|vss 0.335662a
Cext_16797 \$801 VSUBS 255.562a
Cext_16798 \$802 \$803 45.0654a
Cext_16799 \$802 \$822 130.175a
Cext_16800 \$802 VDD|vdd 7.74075a
Cext_16801 \$802 VSS|vss 1.71997a
Cext_16802 \$802 VSUBS 659.267a
Cext_16803 \$803 \$804 45.0654a
Cext_16804 \$803 \$823 130.175a
Cext_16805 \$803 VDD|vdd 0.968272a
Cext_16806 \$803 VSUBS 634.529a
Cext_16807 \$804 \$805 45.0654a
Cext_16808 \$804 \$824 130.175a
Cext_16809 \$804 VSUBS 634.529a
Cext_16810 \$805 \$806 45.8951a
Cext_16811 \$805 \$845 130.175a
Cext_16812 \$805 VSS|vss 0.428128a
Cext_16813 \$805 VSUBS 634.529a
Cext_16814 \$806 \$807 2.46853a
Cext_16815 \$806 \$825 225.319a
Cext_16816 \$806 \$826 102.889a
Cext_16817 \$806 VSS|vss 61.1015a
Cext_16818 \$806 VSUBS 793.935a
Cext_16819 \$807 \$808 0.179323a
Cext_16820 \$807 \$826 231.353a
Cext_16821 \$807 \$866 98.5952a
Cext_16822 \$807 \$934 1.46644a
Cext_16823 \$807 VSUBS 186.085a
Cext_16824 \$808 \$827 254.864a
Cext_16825 \$808 \$846 0.360462a
Cext_16826 \$808 VSS|vss 66.2132a
Cext_16827 \$808 VSUBS 818.365a
Cext_16828 \$809 \$810 2.46853a
Cext_16829 \$809 \$829 102.889a
Cext_16830 \$809 \$830 225.319a
Cext_16831 \$809 IOVDD|vdda 11.6291a
Cext_16832 \$809 VSS|vss 60.9228a
Cext_16833 \$809 VSUBS 810.925a
Cext_16834 \$81 \$886 10.3679a
Cext_16835 \$81 \$888 19.9052a
Cext_16836 \$81 \$917 21.1877a
Cext_16837 \$81 \$921 18.9757a
Cext_16838 \$81 \$967 7.31221a
Cext_16839 \$81 inn|out|vth_soft 69.5127a
Cext_16840 \$81 IOVDD|vdda 558.243a
Cext_16841 \$81 VREF|vref 7.96331a
Cext_16842 \$81 VSS|vss 4.68473f
Cext_16843 \$81 VSUBS 3.83873f
Cext_16844 \$810 \$811 0.179323a
Cext_16845 \$810 \$829 231.353a
Cext_16846 \$810 \$867 98.5952a
Cext_16847 \$810 \$936 1.46644a
Cext_16848 \$810 IOVDD|vdda 5.46954a
Cext_16849 \$810 VSUBS 186.085a
Cext_16850 \$811 \$831 254.864a
Cext_16851 \$811 \$847 0.360462a
Cext_16852 \$811 VSS|vss 66.2132a
Cext_16853 \$811 VSUBS 818.365a
Cext_16854 \$812 \$813 45.0654a
Cext_16855 \$812 \$833 130.128a
Cext_16856 \$812 VDD|vdd 0.592094a
Cext_16857 \$812 VSS|vss 25.1792a
Cext_16858 \$812 VSUBS 659.267a
Cext_16859 \$813 \$814 45.0654a
Cext_16860 \$813 \$834 130.175a
Cext_16861 \$813 VSS|vss 5.452a
Cext_16862 \$813 VSUBS 634.529a
Cext_16863 \$814 \$815 45.0654a
Cext_16864 \$814 \$835 130.175a
Cext_16865 \$814 VSUBS 634.529a
Cext_16866 \$815 \$816 45.8951a
Cext_16867 \$815 \$836 130.175a
Cext_16868 \$815 VSS|vss 0.428128a
Cext_16869 \$815 VSUBS 634.529a
Cext_16870 \$816 \$817 2.46853a
Cext_16871 \$816 \$83 105.489a
Cext_16872 \$816 \$837 102.889a
Cext_16873 \$816 \$838 225.319a
Cext_16874 \$816 VSS|vss 61.1015a
Cext_16875 \$816 VSUBS 793.935a
Cext_16876 \$817 \$818 0.179323a
Cext_16877 \$817 \$83 2.30683a
Cext_16878 \$817 \$837 231.353a
Cext_16879 \$817 \$85 121.2a
Cext_16880 \$817 \$868 98.5952a
Cext_16881 \$817 \$87 7.5941a
Cext_16882 \$817 \$89 3.34353a
Cext_16883 \$817 \$91 1.52179a
Cext_16884 \$817 \$93 1.54922a
Cext_16885 \$817 \$938 1.46644a
Cext_16886 \$817 VSUBS 186.085a
Cext_16887 \$818 \$83 110.011a
Cext_16888 \$818 \$839 254.864a
Cext_16889 \$818 \$848 0.360462a
Cext_16890 \$818 \$93 0.107779a
Cext_16891 \$818 VSS|vss 66.2132a
Cext_16892 \$818 VSUBS 818.365a
Cext_16893 \$819 \$820 2.46853a
Cext_16894 \$819 \$83 105.489a
Cext_16895 \$819 \$841 225.319a
Cext_16896 \$819 \$842 102.889a
Cext_16897 \$819 IOVDD|vdda 11.6291a
Cext_16898 \$819 VSS|vss 60.9228a
Cext_16899 \$819 VSUBS 810.925a
Cext_16900 \$82 d0|dac_hard[0] 26.065a
Cext_16901 \$82 IOVDD|vdda 50.2951a
Cext_16902 \$82 VDD|vdd 0.412117a
Cext_16903 \$82 VSS|vss 247.646a
Cext_16904 \$82 VSUBS 445.356a
Cext_16905 \$820 \$821 0.179323a
Cext_16906 \$820 \$83 2.30683a
Cext_16907 \$820 \$842 231.353a
Cext_16908 \$820 \$85 121.2a
Cext_16909 \$820 \$869 98.5952a
Cext_16910 \$820 \$87 7.5941a
Cext_16911 \$820 \$89 3.34353a
Cext_16912 \$820 \$91 1.52179a
Cext_16913 \$820 \$93 1.54922a
Cext_16914 \$820 \$940 1.46644a
Cext_16915 \$820 IOVDD|vdda 5.46954a
Cext_16916 \$820 VSS|vss 6.36441a
Cext_16917 \$820 VSUBS 186.085a
Cext_16918 \$821 \$83 110.011a
Cext_16919 \$821 \$843 254.864a
Cext_16920 \$821 \$849 0.360462a
Cext_16921 \$821 \$93 0.107779a
Cext_16922 \$821 VSS|vss 75.4228a
Cext_16923 \$821 VSUBS 818.365a
Cext_16924 \$822 \$823 45.0654a
Cext_16925 \$822 \$850 130.175a
Cext_16926 \$822 VDD|vdd 7.74075a
Cext_16927 \$822 VSS|vss 1.71997a
Cext_16928 \$822 VSUBS 659.267a
Cext_16929 \$823 \$824 45.0654a
Cext_16930 \$823 \$851 130.175a
Cext_16931 \$823 VDD|vdd 0.968272a
Cext_16932 \$823 VSUBS 634.529a
Cext_16933 \$824 \$845 45.0654a
Cext_16934 \$824 \$852 130.175a
Cext_16935 \$824 VSUBS 634.529a
Cext_16936 \$825 \$826 114.006a
Cext_16937 \$825 \$845 46.4004a
Cext_16938 \$825 \$854 254.864a
Cext_16939 \$825 \$866 0.360462a
Cext_16940 \$825 VSS|vss 66.2906a
Cext_16941 \$825 VSUBS 799.746a
Cext_16942 \$826 \$827 0.182933a
Cext_16943 \$826 \$854 0.360462a
Cext_16944 \$826 \$866 108.267a
Cext_16945 \$826 VSS|vss 0.378848a
Cext_16946 \$826 VSUBS 255.758a
Cext_16947 \$827 \$828 2.46853a
Cext_16948 \$827 \$846 102.889a
Cext_16949 \$827 \$855 225.319a
Cext_16950 \$827 VSS|vss 60.9228a
Cext_16951 \$827 VSUBS 811.534a
Cext_16952 \$828 \$830 0.179323a
Cext_16953 \$828 \$846 231.353a
Cext_16954 \$828 \$887 98.5952a
Cext_16955 \$828 \$963 1.46644a
Cext_16956 \$828 VSUBS 186.792a
Cext_16957 \$829 \$830 114.006a
Cext_16958 \$829 \$831 0.182933a
Cext_16959 \$829 \$856 0.360462a
Cext_16960 \$829 \$867 108.267a
Cext_16961 \$829 IOVDD|vdda 41.5423a
Cext_16962 \$829 VSS|vss 0.378848a
Cext_16963 \$829 VSUBS 255.484a
Cext_16964 \$83 \$837 69.9941a
Cext_16965 \$83 \$838 64.1221a
Cext_16966 \$83 \$839 58.9193a
Cext_16967 \$83 \$84 40.4127a
Cext_16968 \$83 \$841 64.1221a
Cext_16969 \$83 \$842 69.8469a
Cext_16970 \$83 \$843 58.9193a
Cext_16971 \$83 \$848 80.1821a
Cext_16972 \$83 \$849 80.1821a
Cext_16973 \$83 \$85 124.876a
Cext_16974 \$83 \$862 105.489a
Cext_16975 \$83 \$863 110.011a
Cext_16976 \$83 \$864 105.489a
Cext_16977 \$83 \$865 110.011a
Cext_16978 \$83 \$868 80.1249a
Cext_16979 \$83 \$869 79.9778a
Cext_16980 \$83 \$87 105.118a
Cext_16981 \$83 \$881 64.2241a
Cext_16982 \$83 \$882 58.9193a
Cext_16983 \$83 \$883 64.2241a
Cext_16984 \$83 \$884 58.9193a
Cext_16985 \$83 \$89 114.695a
Cext_16986 \$83 \$890 110.712a
Cext_16987 \$83 \$891 69.937a
Cext_16988 \$83 \$892 45.402a
Cext_16989 \$83 \$893 69.937a
Cext_16990 \$83 \$906 105.694a
Cext_16991 \$83 \$907 110.113a
Cext_16992 \$83 \$908 105.694a
Cext_16993 \$83 \$909 110.113a
Cext_16994 \$83 \$91 143.312a
Cext_16995 \$83 \$926 64.1221a
Cext_16996 \$83 \$927 69.9941a
Cext_16997 \$83 \$928 59.1234a
Cext_16998 \$83 \$929 71.2006a
Cext_16999 \$83 \$93 214.508a
Cext_17000 \$83 \$930 64.1221a
Cext_17001 \$83 \$931 69.8469a
Cext_17002 \$83 \$932 59.1234a
Cext_17003 \$83 \$933 2.56563a
Cext_17004 \$83 \$939 80.1821a
Cext_17005 \$83 \$941 80.1821a
Cext_17006 \$83 \$95 39.1669a
Cext_17007 \$83 \$954 105.489a
Cext_17008 \$83 \$955 110.011a
Cext_17009 \$83 \$956 105.489a
Cext_17010 \$83 \$957 110.011a
Cext_17011 \$83 \$97 40.4662a
Cext_17012 \$83 \$970 80.1249a
Cext_17013 \$83 \$971 64.1221a
Cext_17014 \$83 \$972 58.9193a
Cext_17015 \$83 \$973 2.30683a
Cext_17016 \$83 \$974 79.9778a
Cext_17017 \$83 \$975 64.1221a
Cext_17018 \$83 \$976 58.9193a
Cext_17019 \$83 \$977 2.30683a
Cext_17020 \$83 \$989 69.937a
Cext_17021 \$83 \$991 69.8608a
Cext_17022 \$83 d1|dac_hard[1] 1.21055a
Cext_17023 \$83 IOVDD|vdda 803.72a
Cext_17024 \$83 VREF|vref 6.23834a
Cext_17025 \$83 VSS|vss 30.1563f
Cext_17026 \$83 VSUBS 61.1989f
Cext_17027 \$830 \$856 254.864a
Cext_17028 \$830 \$867 0.360462a
Cext_17029 \$830 IOVDD|vdda 13.0646a
Cext_17030 \$830 VSS|vss 66.2132a
Cext_17031 \$830 VSUBS 817.279a
Cext_17032 \$831 \$832 2.46853a
Cext_17033 \$831 \$847 102.889a
Cext_17034 \$831 \$857 225.319a
Cext_17035 \$831 VSS|vss 60.9228a
Cext_17036 \$831 VSUBS 811.534a
Cext_17037 \$832 \$847 231.353a
Cext_17038 \$832 \$889 98.5952a
Cext_17039 \$832 \$966 1.46644a
Cext_17040 \$832 VREF|vref 0.489684a
Cext_17041 \$832 VSUBS 186.792a
Cext_17042 \$833 \$834 45.0654a
Cext_17043 \$833 \$858 130.128a
Cext_17044 \$833 VDD|vdd 0.592094a
Cext_17045 \$833 VSS|vss 25.1792a
Cext_17046 \$833 VSUBS 659.267a
Cext_17047 \$834 \$835 45.0654a
Cext_17048 \$834 \$859 130.175a
Cext_17049 \$834 VSS|vss 5.452a
Cext_17050 \$834 VSUBS 634.529a
Cext_17051 \$835 \$836 45.0654a
Cext_17052 \$835 \$860 130.175a
Cext_17053 \$835 VSUBS 634.529a
Cext_17054 \$836 \$838 46.4004a
Cext_17055 \$836 \$861 130.175a
Cext_17056 \$836 VSS|vss 0.378729a
Cext_17057 \$836 VSUBS 634.529a
Cext_17058 \$837 \$838 114.006a
Cext_17059 \$837 \$839 0.182933a
Cext_17060 \$837 \$85 117.368a
Cext_17061 \$837 \$862 0.360462a
Cext_17062 \$837 \$868 108.267a
Cext_17063 \$837 \$87 32.765a
Cext_17064 \$837 \$89 32.5775a
Cext_17065 \$837 \$91 35.6349a
Cext_17066 \$837 \$93 45.7852a
Cext_17067 \$837 VSS|vss 0.378848a
Cext_17068 \$837 VSUBS 255.758a
Cext_17069 \$838 \$85 0.155901a
Cext_17070 \$838 \$862 254.864a
Cext_17071 \$838 \$868 0.360462a
Cext_17072 \$838 VSS|vss 66.2906a
Cext_17073 \$838 VSUBS 799.746a
Cext_17074 \$839 \$840 2.46853a
Cext_17075 \$839 \$848 102.889a
Cext_17076 \$839 \$85 0.343978a
Cext_17077 \$839 \$863 225.319a
Cext_17078 \$839 VSS|vss 60.9228a
Cext_17079 \$839 VSUBS 811.534a
Cext_17080 \$84 d1|dac_hard[1] 26.065a
Cext_17081 \$84 IOVDD|vdda 50.2951a
Cext_17082 \$84 VSS|vss 219.335a
Cext_17083 \$84 VSUBS 421.882a
Cext_17084 \$840 \$841 0.179323a
Cext_17085 \$840 \$848 231.353a
Cext_17086 \$840 \$85 106.42a
Cext_17087 \$840 \$87 53.8878a
Cext_17088 \$840 \$89 3.34353a
Cext_17089 \$840 \$891 98.5952a
Cext_17090 \$840 \$91 1.52179a
Cext_17091 \$840 \$93 1.40221a
Cext_17092 \$840 \$973 1.46644a
Cext_17093 \$840 VSUBS 186.792a
Cext_17094 \$841 \$842 114.006a
Cext_17095 \$841 \$85 0.155901a
Cext_17096 \$841 \$864 254.864a
Cext_17097 \$841 \$869 0.360462a
Cext_17098 \$841 IOVDD|vdda 13.0646a
Cext_17099 \$841 VSS|vss 66.2132a
Cext_17100 \$841 VSUBS 817.279a
Cext_17101 \$842 \$843 0.182933a
Cext_17102 \$842 \$85 117.368a
Cext_17103 \$842 \$864 0.360462a
Cext_17104 \$842 \$869 108.267a
Cext_17105 \$842 \$87 32.765a
Cext_17106 \$842 \$89 32.5775a
Cext_17107 \$842 \$91 35.6349a
Cext_17108 \$842 \$93 45.7852a
Cext_17109 \$842 IOVDD|vdda 41.5423a
Cext_17110 \$842 VSS|vss 3.94946a
Cext_17111 \$842 VSUBS 255.484a
Cext_17112 \$843 \$844 2.46853a
Cext_17113 \$843 \$849 102.889a
Cext_17114 \$843 \$85 0.343978a
Cext_17115 \$843 \$865 225.319a
Cext_17116 \$843 VSS|vss 69.9251a
Cext_17117 \$843 VSUBS 811.534a
Cext_17118 \$844 \$849 231.353a
Cext_17119 \$844 \$85 106.42a
Cext_17120 \$844 \$87 53.8878a
Cext_17121 \$844 \$89 3.34353a
Cext_17122 \$844 \$893 98.5952a
Cext_17123 \$844 \$91 1.52179a
Cext_17124 \$844 \$93 1.40221a
Cext_17125 \$844 \$977 1.46644a
Cext_17126 \$844 VREF|vref 0.489684a
Cext_17127 \$844 VSUBS 186.792a
Cext_17128 \$845 \$853 130.175a
Cext_17129 \$845 VSS|vss 0.378729a
Cext_17130 \$845 VSUBS 634.529a
Cext_17131 \$846 \$855 114.006a
Cext_17132 \$846 \$856 0.182933a
Cext_17133 \$846 \$874 0.360462a
Cext_17134 \$846 \$887 108.267a
Cext_17135 \$846 VSS|vss 0.378848a
Cext_17136 \$846 VSUBS 256.029a
Cext_17137 \$847 \$857 114.006a
Cext_17138 \$847 \$876 0.360462a
Cext_17139 \$847 \$889 108.267a
Cext_17140 \$847 VREF|vref 0.182933a
Cext_17141 \$847 VSS|vss 0.378848a
Cext_17142 \$847 VSUBS 256.029a
Cext_17143 \$848 \$85 70.7638a
Cext_17144 \$848 \$863 114.006a
Cext_17145 \$848 \$864 0.182933a
Cext_17146 \$848 \$87 34.2005a
Cext_17147 \$848 \$882 0.360462a
Cext_17148 \$848 \$89 32.5775a
Cext_17149 \$848 \$891 108.267a
Cext_17150 \$848 \$91 35.6349a
Cext_17151 \$848 \$93 45.7852a
Cext_17152 \$848 VSS|vss 0.378848a
Cext_17153 \$848 VSUBS 256.029a
Cext_17154 \$849 \$85 70.7638a
Cext_17155 \$849 \$865 114.006a
Cext_17156 \$849 \$87 34.2005a
Cext_17157 \$849 \$884 0.360462a
Cext_17158 \$849 \$89 32.5775a
Cext_17159 \$849 \$893 108.267a
Cext_17160 \$849 \$91 35.6349a
Cext_17161 \$849 \$93 45.7852a
Cext_17162 \$849 VREF|vref 0.182933a
Cext_17163 \$849 VSS|vss 0.378848a
Cext_17164 \$849 VSUBS 256.029a
Cext_17165 \$85 \$86 40.4127a
Cext_17166 \$85 \$868 70.7638a
Cext_17167 \$85 \$869 70.7638a
Cext_17168 \$85 \$87 74.2602f
Cext_17169 \$85 \$89 904.638a
Cext_17170 \$85 \$890 124.989a
Cext_17171 \$85 \$891 117.531a
Cext_17172 \$85 \$892 62.7415a
Cext_17173 \$85 \$893 117.531a
Cext_17174 \$85 \$91 472.136a
Cext_17175 \$85 \$926 0.155901a
Cext_17176 \$85 \$927 117.531a
Cext_17177 \$85 \$928 0.343978a
Cext_17178 \$85 \$929 81.4508a
Cext_17179 \$85 \$93 271.683a
Cext_17180 \$85 \$930 0.155901a
Cext_17181 \$85 \$931 117.531a
Cext_17182 \$85 \$932 0.343978a
Cext_17183 \$85 \$933 22.6196a
Cext_17184 \$85 \$938 106.262a
Cext_17185 \$85 \$939 70.7638a
Cext_17186 \$85 \$940 106.262a
Cext_17187 \$85 \$941 70.7638a
Cext_17188 \$85 \$95 30.4252a
Cext_17189 \$85 \$97 31.7245a
Cext_17190 \$85 \$970 70.7638a
Cext_17191 \$85 \$973 121.143a
Cext_17192 \$85 \$974 70.7638a
Cext_17193 \$85 \$977 121.253a
Cext_17194 \$85 \$988 62.8907a
Cext_17195 \$85 \$989 117.368a
Cext_17196 \$85 \$990 62.8907a
Cext_17197 \$85 \$991 117.368a
Cext_17198 \$85 d2|dac_hard[2] 1.21055a
Cext_17199 \$85 IOVDD|vdda 609.604a
Cext_17200 \$85 VREF|vref 25.954a
Cext_17201 \$85 VSS|vss 343.583a
Cext_17202 \$85 VSUBS 36.7609f
Cext_17203 \$850 \$851 45.0654a
Cext_17204 \$850 \$870 130.175a
Cext_17205 \$850 VDD|vdd 7.74075a
Cext_17206 \$850 VSS|vss 1.71997a
Cext_17207 \$850 VSUBS 659.267a
Cext_17208 \$851 \$852 45.0654a
Cext_17209 \$851 \$871 130.175a
Cext_17210 \$851 VDD|vdd 0.968272a
Cext_17211 \$851 VSUBS 634.529a
Cext_17212 \$852 \$853 45.0654a
Cext_17213 \$852 \$885 130.175a
Cext_17214 \$852 VSUBS 634.529a
Cext_17215 \$853 \$854 45.8951a
Cext_17216 \$853 \$872 130.175a
Cext_17217 \$853 VSS|vss 0.428128a
Cext_17218 \$853 VSUBS 634.529a
Cext_17219 \$854 \$866 113.058a
Cext_17220 \$854 \$873 225.319a
Cext_17221 \$854 VSS|vss 61.1015a
Cext_17222 \$854 VSUBS 793.257a
Cext_17223 \$855 \$866 0.182933a
Cext_17224 \$855 \$874 254.864a
Cext_17225 \$855 \$887 0.360462a
Cext_17226 \$855 VSS|vss 66.2132a
Cext_17227 \$855 VSUBS 817.162a
Cext_17228 \$856 \$867 113.058a
Cext_17229 \$856 \$875 225.319a
Cext_17230 \$856 IOVDD|vdda 11.5102a
Cext_17231 \$856 VSS|vss 60.9228a
Cext_17232 \$856 VSUBS 810.376a
Cext_17233 \$857 \$867 0.182933a
Cext_17234 \$857 \$876 254.864a
Cext_17235 \$857 \$889 0.360462a
Cext_17236 \$857 VSS|vss 66.2132a
Cext_17237 \$857 VSUBS 817.162a
Cext_17238 \$858 \$859 45.0654a
Cext_17239 \$858 \$877 130.128a
Cext_17240 \$858 VDD|vdd 0.592094a
Cext_17241 \$858 VSS|vss 25.1792a
Cext_17242 \$858 VSUBS 659.267a
Cext_17243 \$859 \$860 45.0654a
Cext_17244 \$859 \$878 130.175a
Cext_17245 \$859 VSS|vss 5.452a
Cext_17246 \$859 VSUBS 634.529a
Cext_17247 \$86 d2|dac_hard[2] 26.065a
Cext_17248 \$86 IOVDD|vdda 50.2951a
Cext_17249 \$86 VSS|vss 219.335a
Cext_17250 \$86 VSUBS 421.882a
Cext_17251 \$860 \$861 45.0654a
Cext_17252 \$860 \$879 130.175a
Cext_17253 \$860 VSUBS 634.529a
Cext_17254 \$861 \$862 45.8951a
Cext_17255 \$861 \$880 130.175a
Cext_17256 \$861 VSS|vss 0.428128a
Cext_17257 \$861 VSUBS 634.529a
Cext_17258 \$862 \$868 113.058a
Cext_17259 \$862 \$881 225.319a
Cext_17260 \$862 VSS|vss 61.1015a
Cext_17261 \$862 VSUBS 793.257a
Cext_17262 \$863 \$868 0.182933a
Cext_17263 \$863 \$882 254.864a
Cext_17264 \$863 \$891 0.360462a
Cext_17265 \$863 VSS|vss 66.2132a
Cext_17266 \$863 VSUBS 817.162a
Cext_17267 \$864 \$869 113.058a
Cext_17268 \$864 \$883 225.319a
Cext_17269 \$864 IOVDD|vdda 11.5102a
Cext_17270 \$864 VSS|vss 60.9228a
Cext_17271 \$864 VSUBS 810.376a
Cext_17272 \$865 \$869 0.182933a
Cext_17273 \$865 \$884 254.864a
Cext_17274 \$865 \$893 0.360462a
Cext_17275 \$865 VSS|vss 75.4228a
Cext_17276 \$865 VSUBS 817.162a
Cext_17277 \$866 \$873 102.889a
Cext_17278 \$866 \$886 0.11398a
Cext_17279 \$866 \$898 0.360462a
Cext_17280 \$866 \$914 42.153a
Cext_17281 \$866 VSS|vss 0.335662a
Cext_17282 \$866 VSUBS 260.57a
Cext_17283 \$867 \$875 102.889a
Cext_17284 \$867 \$888 0.11398a
Cext_17285 \$867 \$900 0.360462a
Cext_17286 \$867 \$918 42.153a
Cext_17287 \$867 IOVDD|vdda 41.7454a
Cext_17288 \$867 VSS|vss 0.335662a
Cext_17289 \$867 VSUBS 260.296a
Cext_17290 \$868 \$87 31.3588a
Cext_17291 \$868 \$881 102.889a
Cext_17292 \$868 \$89 32.5775a
Cext_17293 \$868 \$890 0.11398a
Cext_17294 \$868 \$906 0.360462a
Cext_17295 \$868 \$91 35.6349a
Cext_17296 \$868 \$927 42.153a
Cext_17297 \$868 \$93 50.9884a
Cext_17298 \$868 VSS|vss 0.335662a
Cext_17299 \$868 VSUBS 260.57a
Cext_17300 \$869 \$87 31.3588a
Cext_17301 \$869 \$883 102.889a
Cext_17302 \$869 \$89 32.5775a
Cext_17303 \$869 \$892 0.11398a
Cext_17304 \$869 \$908 0.360462a
Cext_17305 \$869 \$91 35.6349a
Cext_17306 \$869 \$93 50.9884a
Cext_17307 \$869 \$931 42.153a
Cext_17308 \$869 IOVDD|vdda 41.7454a
Cext_17309 \$869 VSS|vss 4.30919a
Cext_17310 \$869 VSUBS 260.296a
Cext_17311 \$87 \$88 40.4127a
Cext_17312 \$87 \$89 73.7808f
Cext_17313 \$87 \$890 73.6874a
Cext_17314 \$87 \$891 31.3588a
Cext_17315 \$87 \$892 38.574a
Cext_17316 \$87 \$893 31.3588a
Cext_17317 \$87 \$91 357.012a
Cext_17318 \$87 \$927 31.3588a
Cext_17319 \$87 \$929 51.1792a
Cext_17320 \$87 \$93 213.03a
Cext_17321 \$87 \$931 31.3588a
Cext_17322 \$87 \$933 2.83833a
Cext_17323 \$87 \$938 53.7853a
Cext_17324 \$87 \$939 31.3588a
Cext_17325 \$87 \$940 53.7853a
Cext_17326 \$87 \$941 31.3588a
Cext_17327 \$87 \$95 29.7164a
Cext_17328 \$87 \$97 31.0156a
Cext_17329 \$87 \$970 34.2005a
Cext_17330 \$87 \$971 0.168339a
Cext_17331 \$87 \$972 0.343978a
Cext_17332 \$87 \$973 7.49159a
Cext_17333 \$87 \$974 34.2005a
Cext_17334 \$87 \$975 0.168339a
Cext_17335 \$87 \$976 0.343978a
Cext_17336 \$87 \$977 7.41471a
Cext_17337 \$87 \$988 50.1293a
Cext_17338 \$87 \$989 32.765a
Cext_17339 \$87 \$990 50.1293a
Cext_17340 \$87 \$991 32.765a
Cext_17341 \$87 d3|dac_hard[3] 1.21055a
Cext_17342 \$87 IOVDD|vdda 619.395a
Cext_17343 \$87 VREF|vref 13.5214a
Cext_17344 \$87 VSS|vss 299.6a
Cext_17345 \$87 VSUBS 22.2139f
Cext_17346 \$870 \$871 45.0654a
Cext_17347 \$870 \$894 130.175a
Cext_17348 \$870 VDD|vdd 7.74075a
Cext_17349 \$870 VSS|vss 1.71997a
Cext_17350 \$870 VSUBS 659.267a
Cext_17351 \$871 \$885 45.0654a
Cext_17352 \$871 \$895 130.175a
Cext_17353 \$871 VDD|vdd 0.968272a
Cext_17354 \$871 VSUBS 634.529a
Cext_17355 \$872 \$873 46.4004a
Cext_17356 \$872 \$885 45.0654a
Cext_17357 \$872 \$897 130.175a
Cext_17358 \$872 VSS|vss 0.378729a
Cext_17359 \$872 VSUBS 634.529a
Cext_17360 \$873 \$898 254.864a
Cext_17361 \$873 \$914 0.360462a
Cext_17362 \$873 VSS|vss 66.2906a
Cext_17363 \$873 VSUBS 801.518a
Cext_17364 \$874 \$887 113.058a
Cext_17365 \$874 \$899 225.319a
Cext_17366 \$874 VSS|vss 61.1015a
Cext_17367 \$874 VSUBS 810.856a
Cext_17368 \$875 \$887 0.182933a
Cext_17369 \$875 \$900 254.864a
Cext_17370 \$875 \$918 0.360462a
Cext_17371 \$875 IOVDD|vdda 13.2807a
Cext_17372 \$875 VSS|vss 66.2132a
Cext_17373 \$875 VSUBS 819.052a
Cext_17374 \$876 \$888 2.51453a
Cext_17375 \$876 \$889 113.058a
Cext_17376 \$876 \$901 225.319a
Cext_17377 \$876 VSS|vss 61.1015a
Cext_17378 \$876 VSUBS 810.856a
Cext_17379 \$877 \$878 45.0654a
Cext_17380 \$877 \$902 130.128a
Cext_17381 \$877 VDD|vdd 0.592094a
Cext_17382 \$877 VSS|vss 25.1792a
Cext_17383 \$877 VSUBS 659.267a
Cext_17384 \$878 \$879 45.0654a
Cext_17385 \$878 \$903 130.175a
Cext_17386 \$878 VSS|vss 5.452a
Cext_17387 \$878 VSUBS 634.529a
Cext_17388 \$879 \$880 45.0654a
Cext_17389 \$879 \$904 130.175a
Cext_17390 \$879 VSUBS 634.529a
Cext_17391 \$88 d3|dac_hard[3] 26.065a
Cext_17392 \$88 IOVDD|vdda 50.2951a
Cext_17393 \$88 VSS|vss 219.322a
Cext_17394 \$88 VSUBS 420.808a
Cext_17395 \$880 \$881 46.4004a
Cext_17396 \$880 \$905 130.175a
Cext_17397 \$880 VSS|vss 0.378729a
Cext_17398 \$880 VSUBS 634.529a
Cext_17399 \$881 \$906 254.864a
Cext_17400 \$881 \$927 0.360462a
Cext_17401 \$881 \$93 0.329088a
Cext_17402 \$881 VSS|vss 66.2906a
Cext_17403 \$881 VSUBS 801.518a
Cext_17404 \$882 \$891 113.058a
Cext_17405 \$882 \$907 225.319a
Cext_17406 \$882 \$93 0.343978a
Cext_17407 \$882 VSS|vss 61.1015a
Cext_17408 \$882 VSUBS 810.856a
Cext_17409 \$883 \$891 0.182933a
Cext_17410 \$883 \$908 254.864a
Cext_17411 \$883 \$93 0.329088a
Cext_17412 \$883 \$931 0.360462a
Cext_17413 \$883 IOVDD|vdda 13.2807a
Cext_17414 \$883 VSS|vss 66.2132a
Cext_17415 \$883 VSUBS 819.052a
Cext_17416 \$884 \$892 2.51453a
Cext_17417 \$884 \$893 113.058a
Cext_17418 \$884 \$909 225.319a
Cext_17419 \$884 \$93 0.343978a
Cext_17420 \$884 VSS|vss 70.1038a
Cext_17421 \$884 VSUBS 810.856a
Cext_17422 \$885 \$896 130.175a
Cext_17423 \$885 VSUBS 634.529a
Cext_17424 \$886 \$898 0.270358a
Cext_17425 \$886 \$899 5.10374a
Cext_17426 \$886 \$914 5.85567a
Cext_17427 \$886 \$915 0.12478a
Cext_17428 \$886 \$916 5.22971a
Cext_17429 \$886 \$917 1.32494f
Cext_17430 \$886 \$934 13.259a
Cext_17431 \$886 \$946 0.12478a
Cext_17432 \$886 \$947 5.15932a
Cext_17433 \$886 \$961 0.270358a
Cext_17434 \$886 \$962 5.30763a
Cext_17435 \$886 \$963 0.511071a
Cext_17436 \$886 \$980 7.74424a
Cext_17437 \$886 \$984 38.1962a
Cext_17438 \$886 \$985 0.376802a
Cext_17439 \$886 \$986 13.2696a
Cext_17440 \$886 \$996 0.270358a
Cext_17441 \$886 \$997 12.3042a
Cext_17442 \$886 \$998 9.79229a
Cext_17443 \$886 inn|out|vth_soft 31.5299a
Cext_17444 \$886 IOVDD|vdda 75.1497a
Cext_17445 \$886 VREF|vref 243.547a
Cext_17446 \$886 VSS|vss 86.0855a
Cext_17447 \$886 VSUBS 2.38693f
Cext_17448 \$887 \$899 102.889a
Cext_17449 \$887 \$916 0.360462a
Cext_17450 \$887 \$917 0.11398a
Cext_17451 \$887 \$935 42.153a
Cext_17452 \$887 VSS|vss 0.335662a
Cext_17453 \$887 VSUBS 260.72a
Cext_17454 \$888 \$889 0.434092a
Cext_17455 \$888 \$900 0.270358a
Cext_17456 \$888 \$901 9.73672a
Cext_17457 \$888 \$917 233.277a
Cext_17458 \$888 \$918 5.85567a
Cext_17459 \$888 \$919 0.12478a
Cext_17460 \$888 \$920 14.1087a
Cext_17461 \$888 \$921 410.429a
Cext_17462 \$888 \$936 13.259a
Cext_17463 \$888 \$937 7.859a
Cext_17464 \$888 \$948 0.12478a
Cext_17465 \$888 \$949 25.0459a
Cext_17466 \$888 \$964 5.30763a
Cext_17467 \$888 \$965 0.270358a
Cext_17468 \$888 \$966 41.3023a
Cext_17469 \$888 \$967 289.051a
Cext_17470 \$888 \$981 93.1851a
Cext_17471 \$888 \$987 100.807a
Cext_17472 \$888 inn|out|vth_soft 0.667918a
Cext_17473 \$888 IOVDD|vdda 4.51712a
Cext_17474 \$888 VREF|vref 224.472a
Cext_17475 \$888 VSS|vss 45.8104a
Cext_17476 \$888 VSUBS 1.222f
Cext_17477 \$889 \$901 102.889a
Cext_17478 \$889 \$920 0.360462a
Cext_17479 \$889 \$921 0.11398a
Cext_17480 \$889 \$937 42.153a
Cext_17481 \$889 VREF|vref 0.182933a
Cext_17482 \$889 VSS|vss 0.335662a
Cext_17483 \$889 VSUBS 260.72a
Cext_17484 \$89 \$890 96.4288a
Cext_17485 \$89 \$891 32.5775a
Cext_17486 \$89 \$892 23.2418a
Cext_17487 \$89 \$893 32.5775a
Cext_17488 \$89 \$90 40.4127a
Cext_17489 \$89 \$91 74.0955f
Cext_17490 \$89 \$927 32.5775a
Cext_17491 \$89 \$929 38.1888a
Cext_17492 \$89 \$93 226.641a
Cext_17493 \$89 \$931 32.5775a
Cext_17494 \$89 \$933 2.18131a
Cext_17495 \$89 \$938 3.34353a
Cext_17496 \$89 \$939 32.5775a
Cext_17497 \$89 \$940 3.34353a
Cext_17498 \$89 \$941 32.5775a
Cext_17499 \$89 \$95 33.4967a
Cext_17500 \$89 \$97 33.7344a
Cext_17501 \$89 \$970 32.5775a
Cext_17502 \$89 \$973 3.34353a
Cext_17503 \$89 \$974 32.5775a
Cext_17504 \$89 \$977 3.2971a
Cext_17505 \$89 \$988 49.6419a
Cext_17506 \$89 \$989 32.5775a
Cext_17507 \$89 \$990 49.6419a
Cext_17508 \$89 \$991 32.5775a
Cext_17509 \$89 d4|dac_hard[4] 1.21055a
Cext_17510 \$89 IOVDD|vdda 623.426a
Cext_17511 \$89 VREF|vref 8.07618a
Cext_17512 \$89 VSS|vss 268.621a
Cext_17513 \$89 VSUBS 17.4477f
Cext_17514 \$890 \$906 0.270358a
Cext_17515 \$890 \$907 5.10374a
Cext_17516 \$890 \$91 57.5347a
Cext_17517 \$890 \$926 0.12478a
Cext_17518 \$890 \$927 5.85567a
Cext_17519 \$890 \$928 5.22971a
Cext_17520 \$890 \$929 1.32494f
Cext_17521 \$890 \$93 106.986a
Cext_17522 \$890 \$938 13.259a
Cext_17523 \$890 \$95 103.146a
Cext_17524 \$890 \$954 0.12478a
Cext_17525 \$890 \$955 5.15932a
Cext_17526 \$890 \$97 10.3679a
Cext_17527 \$890 \$970 5.30763a
Cext_17528 \$890 \$971 0.270358a
Cext_17529 \$890 \$972 7.74424a
Cext_17530 \$890 \$973 0.511071a
Cext_17531 \$890 \$988 38.1962a
Cext_17532 \$890 \$989 0.376802a
Cext_17533 \$890 \$990 13.2696a
Cext_17534 \$890 inn|out|vth_hard 31.5299a
Cext_17535 \$890 IOVDD|vdda 74.8331a
Cext_17536 \$890 VREF|vref 243.547a
Cext_17537 \$890 VSS|vss 160.919a
Cext_17538 \$890 VSUBS 2.38652f
Cext_17539 \$891 \$907 102.889a
Cext_17540 \$891 \$91 35.6349a
Cext_17541 \$891 \$928 0.360462a
Cext_17542 \$891 \$929 0.11398a
Cext_17543 \$891 \$93 48.6674a
Cext_17544 \$891 \$939 42.153a
Cext_17545 \$891 VSS|vss 0.335662a
Cext_17546 \$891 VSUBS 260.72a
Cext_17547 \$892 \$893 0.434092a
Cext_17548 \$892 \$908 0.270358a
Cext_17549 \$892 \$909 9.73672a
Cext_17550 \$892 \$91 22.4365a
Cext_17551 \$892 \$929 233.277a
Cext_17552 \$892 \$93 76.911a
Cext_17553 \$892 \$930 0.12478a
Cext_17554 \$892 \$931 5.85567a
Cext_17555 \$892 \$932 14.1087a
Cext_17556 \$892 \$933 410.429a
Cext_17557 \$892 \$940 13.259a
Cext_17558 \$892 \$941 7.859a
Cext_17559 \$892 \$95 108.293a
Cext_17560 \$892 \$956 0.12478a
Cext_17561 \$892 \$957 25.0459a
Cext_17562 \$892 \$97 19.9052a
Cext_17563 \$892 \$974 5.30763a
Cext_17564 \$892 \$975 0.270358a
Cext_17565 \$892 \$976 93.1851a
Cext_17566 \$892 \$977 41.3023a
Cext_17567 \$892 \$978 289.051a
Cext_17568 \$892 \$991 100.807a
Cext_17569 \$892 inn|out|vth_hard 0.667918a
Cext_17570 \$892 IOVDD|vdda 4.20052a
Cext_17571 \$892 VREF|vref 224.472a
Cext_17572 \$892 VSS|vss 210.298a
Cext_17573 \$892 VSUBS 1.2217f
Cext_17574 \$893 \$909 102.889a
Cext_17575 \$893 \$91 35.6349a
Cext_17576 \$893 \$93 48.6674a
Cext_17577 \$893 \$932 0.360462a
Cext_17578 \$893 \$933 0.11398a
Cext_17579 \$893 \$941 42.153a
Cext_17580 \$893 VREF|vref 0.182933a
Cext_17581 \$893 VSS|vss 0.335662a
Cext_17582 \$893 VSUBS 260.72a
Cext_17583 \$894 \$895 45.0654a
Cext_17584 \$894 \$910 130.175a
Cext_17585 \$894 VDD|vdd 7.74075a
Cext_17586 \$894 VSS|vss 1.71997a
Cext_17587 \$894 VSUBS 659.267a
Cext_17588 \$895 \$896 45.0654a
Cext_17589 \$895 \$911 130.175a
Cext_17590 \$895 VDD|vdd 0.968272a
Cext_17591 \$895 VSUBS 634.529a
Cext_17592 \$896 \$897 45.0654a
Cext_17593 \$896 \$912 130.175a
Cext_17594 \$896 VSUBS 634.529a
Cext_17595 \$897 \$898 45.8951a
Cext_17596 \$897 \$913 130.175a
Cext_17597 \$897 VSS|vss 0.428128a
Cext_17598 \$897 VSUBS 634.529a
Cext_17599 \$898 \$914 102.889a
Cext_17600 \$898 \$915 225.319a
Cext_17601 \$898 VSS|vss 61.1015a
Cext_17602 \$898 VSUBS 794.421a
Cext_17603 \$899 \$916 254.864a
Cext_17604 \$899 \$935 0.360462a
Cext_17605 \$899 VSS|vss 66.231a
Cext_17606 \$899 VSUBS 818.917a
Cext_17607 \$90 d4|dac_hard[4] 26.065a
Cext_17608 \$90 IOVDD|vdda 50.2951a
Cext_17609 \$90 VSS|vss 219.335a
Cext_17610 \$90 VSUBS 421.882a
Cext_17611 \$900 \$918 102.889a
Cext_17612 \$900 \$919 225.319a
Cext_17613 \$900 IOVDD|vdda 11.6291a
Cext_17614 \$900 VSS|vss 61.1015a
Cext_17615 \$900 VSUBS 810.142a
Cext_17616 \$901 \$920 254.864a
Cext_17617 \$901 \$937 0.360462a
Cext_17618 \$901 VSS|vss 66.231a
Cext_17619 \$901 VSUBS 818.917a
Cext_17620 \$902 \$903 45.0654a
Cext_17621 \$902 \$922 130.128a
Cext_17622 \$902 VDD|vdd 0.592094a
Cext_17623 \$902 VSS|vss 25.1792a
Cext_17624 \$902 VSUBS 659.267a
Cext_17625 \$903 \$904 45.0654a
Cext_17626 \$903 \$923 130.175a
Cext_17627 \$903 VSS|vss 5.452a
Cext_17628 \$903 VSUBS 634.529a
Cext_17629 \$904 \$905 45.0654a
Cext_17630 \$904 \$924 130.175a
Cext_17631 \$904 VSUBS 634.529a
Cext_17632 \$905 \$906 45.8951a
Cext_17633 \$905 \$925 130.175a
Cext_17634 \$905 VSS|vss 0.428128a
Cext_17635 \$905 VSUBS 634.529a
Cext_17636 \$906 \$926 225.319a
Cext_17637 \$906 \$927 102.889a
Cext_17638 \$906 VSS|vss 61.1015a
Cext_17639 \$906 VSUBS 794.421a
Cext_17640 \$907 \$928 254.864a
Cext_17641 \$907 \$93 0.107779a
Cext_17642 \$907 \$939 0.360462a
Cext_17643 \$907 VSS|vss 66.231a
Cext_17644 \$907 VSUBS 818.917a
Cext_17645 \$908 \$930 225.319a
Cext_17646 \$908 \$931 102.889a
Cext_17647 \$908 IOVDD|vdda 11.6291a
Cext_17648 \$908 VSS|vss 61.1015a
Cext_17649 \$908 VSUBS 810.142a
Cext_17650 \$909 \$93 0.107779a
Cext_17651 \$909 \$932 254.864a
Cext_17652 \$909 \$941 0.360462a
Cext_17653 \$909 VSS|vss 75.3406a
Cext_17654 \$909 VSUBS 818.917a
Cext_17655 \$91 \$92 40.4127a
Cext_17656 \$91 \$927 35.6349a
Cext_17657 \$91 \$929 33.4754a
Cext_17658 \$91 \$93 74.5787f
Cext_17659 \$91 \$931 35.6349a
Cext_17660 \$91 \$933 1.77555a
Cext_17661 \$91 \$938 1.61371a
Cext_17662 \$91 \$939 35.6349a
Cext_17663 \$91 \$940 1.61371a
Cext_17664 \$91 \$941 35.6349a
Cext_17665 \$91 \$95 32.8143a
Cext_17666 \$91 \$97 32.7446a
Cext_17667 \$91 \$970 35.6349a
Cext_17668 \$91 \$973 1.61371a
Cext_17669 \$91 \$974 35.6349a
Cext_17670 \$91 \$977 1.49115a
Cext_17671 \$91 \$988 1.56603a
Cext_17672 \$91 \$989 35.6349a
Cext_17673 \$91 \$990 1.56603a
Cext_17674 \$91 \$991 35.6349a
Cext_17675 \$91 d5|dac_hard[5] 1.21055a
Cext_17676 \$91 IOVDD|vdda 636.222a
Cext_17677 \$91 VREF|vref 4.6364a
Cext_17678 \$91 VSS|vss 253.401a
Cext_17679 \$91 VSUBS 14.4751f
Cext_17680 \$910 \$911 45.0654a
Cext_17681 \$910 \$942 130.175a
Cext_17682 \$910 VDD|vdd 7.74075a
Cext_17683 \$910 VSS|vss 1.71997a
Cext_17684 \$910 VSUBS 659.267a
Cext_17685 \$911 \$912 45.0654a
Cext_17686 \$911 \$943 130.175a
Cext_17687 \$911 VDD|vdd 0.968272a
Cext_17688 \$911 VSUBS 634.529a
Cext_17689 \$912 \$913 45.0654a
Cext_17690 \$912 \$944 130.175a
Cext_17691 \$912 VSUBS 634.529a
Cext_17692 \$913 \$915 46.4004a
Cext_17693 \$913 \$945 130.175a
Cext_17694 \$913 VSS|vss 0.378729a
Cext_17695 \$913 VSUBS 634.529a
Cext_17696 \$914 \$915 114.006a
Cext_17697 \$914 \$916 0.182933a
Cext_17698 \$914 \$934 98.5952a
Cext_17699 \$914 \$946 0.360462a
Cext_17700 \$914 \$962 108.267a
Cext_17701 \$914 VSS|vss 0.378848a
Cext_17702 \$914 VSUBS 260.634a
Cext_17703 \$915 \$946 254.864a
Cext_17704 \$915 \$962 0.360462a
Cext_17705 \$915 VSS|vss 66.2906a
Cext_17706 \$915 VSUBS 799.746a
Cext_17707 \$916 \$917 0.270358a
Cext_17708 \$916 \$935 102.889a
Cext_17709 \$916 \$947 225.319a
Cext_17710 \$916 VSS|vss 60.9228a
Cext_17711 \$916 VSUBS 812.02a
Cext_17712 \$917 \$919 5.10374a
Cext_17713 \$917 \$935 5.85567a
Cext_17714 \$917 \$936 0.486691a
Cext_17715 \$917 \$947 0.12478a
Cext_17716 \$917 \$948 7.68595a
Cext_17717 \$917 \$963 13.259a
Cext_17718 \$917 \$964 0.361165a
Cext_17719 \$917 \$965 9.66016a
Cext_17720 \$917 \$966 0.808881a
Cext_17721 \$917 \$967 0.122259a
Cext_17722 \$917 \$980 0.12478a
Cext_17723 \$917 \$985 5.30763a
Cext_17724 \$917 \$986 40.3598a
Cext_17725 \$917 \$987 0.357977a
Cext_17726 \$917 \$998 0.270358a
Cext_17727 \$917 \$999 13.7915a
Cext_17728 \$917 inn|out|vth_soft 27.2034a
Cext_17729 \$917 IOVDD|vdda 75.1497a
Cext_17730 \$917 VREF|vref 225.182a
Cext_17731 \$917 VSS|vss 59.059a
Cext_17732 \$917 VSUBS 1.5161f
Cext_17733 \$918 \$919 114.006a
Cext_17734 \$918 \$920 0.182933a
Cext_17735 \$918 \$936 98.5952a
Cext_17736 \$918 \$948 0.360462a
Cext_17737 \$918 \$964 108.267a
Cext_17738 \$918 IOVDD|vdda 41.7014a
Cext_17739 \$918 VSS|vss 0.378848a
Cext_17740 \$918 VSUBS 260.36a
Cext_17741 \$919 \$948 254.864a
Cext_17742 \$919 \$964 0.360462a
Cext_17743 \$919 IOVDD|vdda 13.0646a
Cext_17744 \$919 VSS|vss 66.231a
Cext_17745 \$919 VSUBS 817.169a
Cext_17746 \$92 d5|dac_hard[5] 26.065a
Cext_17747 \$92 IOVDD|vdda 50.2951a
Cext_17748 \$92 VSS|vss 219.335a
Cext_17749 \$92 VSUBS 421.882a
Cext_17750 \$920 \$921 0.270358a
Cext_17751 \$920 \$937 102.889a
Cext_17752 \$920 \$949 225.319a
Cext_17753 \$920 VSS|vss 60.9228a
Cext_17754 \$920 VSUBS 812.02a
Cext_17755 \$921 \$937 5.85567a
Cext_17756 \$921 \$949 0.12478a
Cext_17757 \$921 \$967 99.7133a
Cext_17758 \$921 inn|out|vth_soft 0.105401a
Cext_17759 \$921 VREF|vref 283.683a
Cext_17760 \$921 VSS|vss 23.6975a
Cext_17761 \$921 VSUBS 639.217a
Cext_17762 \$922 \$923 45.0654a
Cext_17763 \$922 \$950 130.128a
Cext_17764 \$922 VDD|vdd 0.592094a
Cext_17765 \$922 VSS|vss 25.1792a
Cext_17766 \$922 VSUBS 659.267a
Cext_17767 \$923 \$924 45.0654a
Cext_17768 \$923 \$951 130.175a
Cext_17769 \$923 VSS|vss 5.452a
Cext_17770 \$923 VSUBS 634.529a
Cext_17771 \$924 \$925 45.0654a
Cext_17772 \$924 \$952 130.175a
Cext_17773 \$924 VSUBS 634.529a
Cext_17774 \$925 \$926 46.4004a
Cext_17775 \$925 \$953 130.175a
Cext_17776 \$925 VSS|vss 0.378729a
Cext_17777 \$925 VSUBS 634.529a
Cext_17778 \$926 \$927 114.006a
Cext_17779 \$926 \$954 254.864a
Cext_17780 \$926 \$970 0.360462a
Cext_17781 \$926 VSS|vss 66.2906a
Cext_17782 \$926 VSUBS 799.746a
Cext_17783 \$927 \$928 0.182933a
Cext_17784 \$927 \$93 48.6018a
Cext_17785 \$927 \$938 98.5952a
Cext_17786 \$927 \$954 0.360462a
Cext_17787 \$927 \$970 108.267a
Cext_17788 \$927 VSS|vss 0.378848a
Cext_17789 \$927 VSUBS 260.634a
Cext_17790 \$928 \$929 0.270358a
Cext_17791 \$928 \$939 102.889a
Cext_17792 \$928 \$955 225.319a
Cext_17793 \$928 VSS|vss 60.9228a
Cext_17794 \$928 VSUBS 812.02a
Cext_17795 \$929 \$93 93.7799a
Cext_17796 \$929 \$930 5.10374a
Cext_17797 \$929 \$939 5.85567a
Cext_17798 \$929 \$940 0.486691a
Cext_17799 \$929 \$95 60.8307a
Cext_17800 \$929 \$955 0.12478a
Cext_17801 \$929 \$956 7.68595a
Cext_17802 \$929 \$97 21.1877a
Cext_17803 \$929 \$972 0.12478a
Cext_17804 \$929 \$973 13.259a
Cext_17805 \$929 \$974 0.361165a
Cext_17806 \$929 \$975 9.66016a
Cext_17807 \$929 \$977 0.808881a
Cext_17808 \$929 \$978 0.122259a
Cext_17809 \$929 \$989 5.30763a
Cext_17810 \$929 \$990 40.3598a
Cext_17811 \$929 \$991 0.357977a
Cext_17812 \$929 inn|out|vth_hard 27.2034a
Cext_17813 \$929 IOVDD|vdda 74.8331a
Cext_17814 \$929 VREF|vref 225.182a
Cext_17815 \$929 VSS|vss 133.063a
Cext_17816 \$929 VSUBS 1.5161f
Cext_17817 \$93 \$931 48.6018a
Cext_17818 \$93 \$933 63.198a
Cext_17819 \$93 \$938 1.46698a
Cext_17820 \$93 \$939 50.9228a
Cext_17821 \$93 \$94 40.4127a
Cext_17822 \$93 \$940 1.46698a
Cext_17823 \$93 \$941 50.9228a
Cext_17824 \$93 \$95 35.0401a
Cext_17825 \$93 \$97 33.4076a
Cext_17826 \$93 \$970 45.8508a
Cext_17827 \$93 \$971 0.107779a
Cext_17828 \$93 \$973 1.61399a
Cext_17829 \$93 \$974 45.8508a
Cext_17830 \$93 \$975 0.107779a
Cext_17831 \$93 \$977 1.52763a
Cext_17832 \$93 \$988 1.0855a
Cext_17833 \$93 \$989 45.8508a
Cext_17834 \$93 \$990 0.992855a
Cext_17835 \$93 \$991 45.8508a
Cext_17836 \$93 d6|dac_hard[6] 1.21055a
Cext_17837 \$93 IOVDD|vdda 673.076a
Cext_17838 \$93 VREF|vref 4.49475a
Cext_17839 \$93 VSS|vss 240.539a
Cext_17840 \$93 VSUBS 13.4061f
Cext_17841 \$930 \$931 114.006a
Cext_17842 \$930 \$956 254.864a
Cext_17843 \$930 \$974 0.360462a
Cext_17844 \$930 IOVDD|vdda 13.0646a
Cext_17845 \$930 VSS|vss 66.231a
Cext_17846 \$930 VSUBS 817.169a
Cext_17847 \$931 \$932 0.182933a
Cext_17848 \$931 \$940 98.5952a
Cext_17849 \$931 \$956 0.360462a
Cext_17850 \$931 \$974 108.267a
Cext_17851 \$931 IOVDD|vdda 41.7014a
Cext_17852 \$931 VSS|vss 4.35237a
Cext_17853 \$931 VSUBS 260.36a
Cext_17854 \$932 \$933 0.270358a
Cext_17855 \$932 \$941 102.889a
Cext_17856 \$932 \$957 225.319a
Cext_17857 \$932 VSS|vss 69.9251a
Cext_17858 \$932 VSUBS 812.02a
Cext_17859 \$933 \$941 5.85567a
Cext_17860 \$933 \$95 61.8196a
Cext_17861 \$933 \$957 0.12478a
Cext_17862 \$933 \$97 18.9757a
Cext_17863 \$933 \$978 99.7133a
Cext_17864 \$933 inn|out|vth_hard 0.105401a
Cext_17865 \$933 VREF|vref 283.683a
Cext_17866 \$933 VSS|vss 23.6975a
Cext_17867 \$933 VSUBS 638.515a
Cext_17868 \$934 \$961 3.25406a
Cext_17869 \$934 \$962 231.353a
Cext_17870 \$934 \$980 0.179323a
Cext_17871 \$934 \$984 99.1454a
Cext_17872 \$934 \$997 7.41179a
Cext_17873 \$934 VSUBS 186.866a
Cext_17874 \$935 \$947 114.006a
Cext_17875 \$935 \$948 0.182933a
Cext_17876 \$935 \$963 98.5952a
Cext_17877 \$935 \$980 0.360462a
Cext_17878 \$935 \$985 108.267a
Cext_17879 \$935 VSS|vss 0.378848a
Cext_17880 \$935 VSUBS 260.372a
Cext_17881 \$936 \$964 231.353a
Cext_17882 \$936 \$965 3.25406a
Cext_17883 \$936 \$981 0.179323a
Cext_17884 \$936 \$986 99.1454a
Cext_17885 \$936 IOVDD|vdda 5.46954a
Cext_17886 \$936 VSUBS 186.866a
Cext_17887 \$937 \$949 114.006a
Cext_17888 \$937 \$966 98.5952a
Cext_17889 \$937 \$981 0.360462a
Cext_17890 \$937 \$987 108.267a
Cext_17891 \$937 VREF|vref 0.182933a
Cext_17892 \$937 VSS|vss 0.378848a
Cext_17893 \$937 VSUBS 260.372a
Cext_17894 \$938 \$970 231.353a
Cext_17895 \$938 \$971 3.25406a
Cext_17896 \$938 \$972 0.179323a
Cext_17897 \$938 \$988 99.1454a
Cext_17898 \$938 VSUBS 186.866a
Cext_17899 \$939 \$955 114.006a
Cext_17900 \$939 \$956 0.182933a
Cext_17901 \$939 \$972 0.360462a
Cext_17902 \$939 \$973 98.5952a
Cext_17903 \$939 \$989 108.267a
Cext_17904 \$939 VSS|vss 0.378848a
Cext_17905 \$939 VSUBS 260.372a
Cext_17906 \$94 d6|dac_hard[6] 26.065a
Cext_17907 \$94 IOVDD|vdda 50.2951a
Cext_17908 \$94 VSS|vss 219.335a
Cext_17909 \$94 VSUBS 421.882a
Cext_17910 \$940 \$974 231.353a
Cext_17911 \$940 \$975 3.25406a
Cext_17912 \$940 \$976 0.179323a
Cext_17913 \$940 \$990 99.1454a
Cext_17914 \$940 IOVDD|vdda 5.46954a
Cext_17915 \$940 VSS|vss 6.36441a
Cext_17916 \$940 VSUBS 186.866a
Cext_17917 \$941 \$957 114.006a
Cext_17918 \$941 \$976 0.360462a
Cext_17919 \$941 \$977 98.5952a
Cext_17920 \$941 \$991 108.267a
Cext_17921 \$941 VREF|vref 0.182933a
Cext_17922 \$941 VSS|vss 0.378848a
Cext_17923 \$941 VSUBS 260.372a
Cext_17924 \$942 \$943 45.0654a
Cext_17925 \$942 \$958 130.175a
Cext_17926 \$942 VDD|vdd 7.74075a
Cext_17927 \$942 VSS|vss 1.71997a
Cext_17928 \$942 VSUBS 659.267a
Cext_17929 \$943 \$944 45.0654a
Cext_17930 \$943 \$979 130.175a
Cext_17931 \$943 VDD|vdd 0.968272a
Cext_17932 \$943 VSUBS 634.529a
Cext_17933 \$944 \$945 45.0654a
Cext_17934 \$944 \$959 130.175a
Cext_17935 \$944 VSUBS 634.529a
Cext_17936 \$945 \$946 45.8951a
Cext_17937 \$945 \$960 130.175a
Cext_17938 \$945 VSS|vss 0.428128a
Cext_17939 \$945 VSUBS 634.529a
Cext_17940 \$946 \$961 225.319a
Cext_17941 \$946 \$962 113.058a
Cext_17942 \$946 VSS|vss 61.1015a
Cext_17943 \$946 VSUBS 793.257a
Cext_17944 \$947 \$962 0.182933a
Cext_17945 \$947 \$980 254.864a
Cext_17946 \$947 \$985 0.360462a
Cext_17947 \$947 VSS|vss 66.2132a
Cext_17948 \$947 VSUBS 817.162a
Cext_17949 \$948 \$964 113.058a
Cext_17950 \$948 \$965 225.319a
Cext_17951 \$948 IOVDD|vdda 11.5102a
Cext_17952 \$948 VSS|vss 60.9228a
Cext_17953 \$948 VSUBS 810.376a
Cext_17954 \$949 \$964 0.182933a
Cext_17955 \$949 \$981 254.864a
Cext_17956 \$949 \$987 0.360462a
Cext_17957 \$949 VSS|vss 66.2132a
Cext_17958 \$949 VSUBS 817.162a
Cext_17959 \$95 \$96 40.4127a
Cext_17960 \$95 \$97 12.3209f
Cext_17961 \$95 \$978 120.443a
Cext_17962 \$95 d7|dac_hard[7] 1.21055a
Cext_17963 \$95 inn|out|vth_hard 46.2792a
Cext_17964 \$95 IOVDD|vdda 448.886a
Cext_17965 \$95 VREF|vref 7.67109a
Cext_17966 \$95 VSS|vss 180.776a
Cext_17967 \$95 VSUBS 5.32394f
Cext_17968 \$950 \$951 45.0654a
Cext_17969 \$950 \$982 130.128a
Cext_17970 \$950 VDD|vdd 0.592094a
Cext_17971 \$950 VSS|vss 25.1792a
Cext_17972 \$950 VSUBS 659.267a
Cext_17973 \$951 \$952 45.0654a
Cext_17974 \$951 \$968 130.175a
Cext_17975 \$951 VSS|vss 5.452a
Cext_17976 \$951 VSUBS 634.529a
Cext_17977 \$952 \$953 45.0654a
Cext_17978 \$952 \$969 130.175a
Cext_17979 \$952 VSUBS 634.529a
Cext_17980 \$953 \$954 45.8951a
Cext_17981 \$953 \$983 130.175a
Cext_17982 \$953 VSS|vss 0.428128a
Cext_17983 \$953 VSUBS 634.529a
Cext_17984 \$954 \$970 113.058a
Cext_17985 \$954 \$971 225.319a
Cext_17986 \$954 VSS|vss 61.1015a
Cext_17987 \$954 VSUBS 793.257a
Cext_17988 \$955 \$970 0.182933a
Cext_17989 \$955 \$972 254.864a
Cext_17990 \$955 \$989 0.360462a
Cext_17991 \$955 VSS|vss 66.2132a
Cext_17992 \$955 VSUBS 817.162a
Cext_17993 \$956 \$974 113.058a
Cext_17994 \$956 \$975 225.319a
Cext_17995 \$956 IOVDD|vdda 11.5102a
Cext_17996 \$956 VSS|vss 60.9228a
Cext_17997 \$956 VSUBS 810.376a
Cext_17998 \$957 \$974 0.182933a
Cext_17999 \$957 \$976 254.864a
Cext_18000 \$957 \$991 0.360462a
Cext_18001 \$957 VSS|vss 75.4228a
Cext_18002 \$957 VSUBS 817.162a
Cext_18003 \$958 \$979 45.0654a
Cext_18004 \$958 \$992 130.175a
Cext_18005 \$958 VDD|vdd 7.74075a
Cext_18006 \$958 VSS|vss 1.71997a
Cext_18007 \$958 VSUBS 659.267a
Cext_18008 \$959 \$960 45.0654a
Cext_18009 \$959 \$979 45.0654a
Cext_18010 \$959 \$994 130.175a
Cext_18011 \$959 VSUBS 634.529a
Cext_18012 \$96 d7|dac_hard[7] 26.065a
Cext_18013 \$96 IOVDD|vdda 52.9251a
Cext_18014 \$96 VSS|vss 219.335a
Cext_18015 \$96 VSUBS 421.882a
Cext_18016 \$960 \$961 46.4004a
Cext_18017 \$960 \$995 130.175a
Cext_18018 \$960 VSS|vss 0.378729a
Cext_18019 \$960 VSUBS 634.529a
Cext_18020 \$961 \$962 102.889a
Cext_18021 \$961 \$996 254.864a
Cext_18022 \$961 VSS|vss 66.2906a
Cext_18023 \$961 VSUBS 800.931a
Cext_18024 \$962 \$984 0.250757a
Cext_18025 \$962 \$996 0.360462a
Cext_18026 \$962 VSS|vss 0.335662a
Cext_18027 \$962 VSUBS 256.227a
Cext_18028 \$963 \$985 231.353a
Cext_18029 \$963 \$998 3.25406a
Cext_18030 \$963 \$999 0.179323a
Cext_18031 \$963 VSUBS 186.197a
Cext_18032 \$964 \$965 102.889a
Cext_18033 \$964 \$986 0.250757a
Cext_18034 \$964 \$999 0.360462a
Cext_18035 \$964 IOVDD|vdda 41.5864a
Cext_18036 \$964 VSS|vss 0.335662a
Cext_18037 \$964 VSUBS 255.953a
Cext_18038 \$965 \$985 0.182933a
Cext_18039 \$965 \$999 254.864a
Cext_18040 \$965 IOVDD|vdda 13.2807a
Cext_18041 \$965 VSS|vss 66.2132a
Cext_18042 \$965 VSUBS 818.465a
Cext_18043 \$966 \$987 231.353a
Cext_18044 \$966 VREF|vref 0.358646a
Cext_18045 \$966 VSUBS 185.998a
Cext_18046 \$967 inn|out|vth_soft 100.634a
Cext_18047 \$967 VREF|vref 13.4193a
Cext_18048 \$967 VSS|vss 3.64558a
Cext_18049 \$967 VSUBS 266.595a
Cext_18050 \$968 \$969 45.0654a
Cext_18051 \$968 \$982 45.0654a
Cext_18052 \$968 VSS|vss 5.452a
Cext_18053 \$968 VSUBS 634.529a
Cext_18054 \$969 \$983 45.0654a
Cext_18055 \$969 VSUBS 634.529a
Cext_18056 \$97 \$978 7.31221a
Cext_18057 \$97 inn|out|vth_hard 69.5127a
Cext_18058 \$97 IOVDD|vdda 557.926a
Cext_18059 \$97 VREF|vref 7.96331a
Cext_18060 \$97 VSS|vss 4.72976f
Cext_18061 \$97 VSUBS 3.83851f
Cext_18062 \$970 \$971 102.889a
Cext_18063 \$970 \$988 0.250757a
Cext_18064 \$970 VSS|vss 0.335662a
Cext_18065 \$970 VSUBS 256.227a
Cext_18066 \$971 \$983 46.4004a
Cext_18067 \$971 VSS|vss 66.2906a
Cext_18068 \$971 VSUBS 800.931a
Cext_18069 \$972 \$989 113.058a
Cext_18070 \$972 VSS|vss 60.9228a
Cext_18071 \$972 VSUBS 810.856a
Cext_18072 \$973 \$989 231.353a
Cext_18073 \$973 VSUBS 186.197a
Cext_18074 \$974 \$975 102.889a
Cext_18075 \$974 \$990 0.250757a
Cext_18076 \$974 IOVDD|vdda 41.5864a
Cext_18077 \$974 VSS|vss 3.90628a
Cext_18078 \$974 VSUBS 255.953a
Cext_18079 \$975 \$989 0.182933a
Cext_18080 \$975 IOVDD|vdda 13.2807a
Cext_18081 \$975 VSS|vss 66.2132a
Cext_18082 \$975 VSUBS 818.465a
Cext_18083 \$976 \$991 113.058a
Cext_18084 \$976 VSS|vss 69.9251a
Cext_18085 \$976 VSUBS 810.856a
Cext_18086 \$977 \$991 231.353a
Cext_18087 \$977 VREF|vref 0.358646a
Cext_18088 \$977 VSUBS 185.998a
Cext_18089 \$978 inn|out|vth_hard 100.634a
Cext_18090 \$978 VREF|vref 13.4193a
Cext_18091 \$978 VSS|vss 3.85412a
Cext_18092 \$978 VSUBS 265.255a
Cext_18093 \$979 \$993 130.175a
Cext_18094 \$979 VDD|vdd 0.968272a
Cext_18095 \$979 VSUBS 634.529a
Cext_18096 \$980 \$985 113.058a
Cext_18097 \$980 \$998 225.319a
Cext_18098 \$980 VSS|vss 60.9228a
Cext_18099 \$980 VSUBS 810.856a
Cext_18100 \$981 \$987 113.058a
Cext_18101 \$981 VSS|vss 60.9228a
Cext_18102 \$981 VSUBS 810.856a
Cext_18103 \$982 VDD|vdd 0.592094a
Cext_18104 \$982 VSS|vss 25.1792a
Cext_18105 \$982 VSUBS 659.267a
Cext_18106 \$983 VSS|vss 0.378729a
Cext_18107 \$983 VSUBS 634.529a
Cext_18108 \$984 \$997 788.061a
Cext_18109 \$984 VSUBS 217.78a
Cext_18110 \$985 \$998 102.889a
Cext_18111 \$985 VSS|vss 0.335662a
Cext_18112 \$985 VSUBS 255.844a
Cext_18113 \$986 IOVDD|vdda 7.39205a
Cext_18114 \$986 VSUBS 217.78a
Cext_18115 \$987 VREF|vref 0.182933a
Cext_18116 \$987 VSS|vss 0.27808a
Cext_18117 \$987 VSUBS 255.681a
Cext_18118 \$988 VSUBS 217.78a
Cext_18119 \$989 VSS|vss 0.335662a
Cext_18120 \$989 VSUBS 255.844a
Cext_18121 \$990 IOVDD|vdda 7.39205a
Cext_18122 \$990 VSS|vss 12.2489a
Cext_18123 \$990 VSUBS 217.78a
Cext_18124 \$991 VREF|vref 0.182933a
Cext_18125 \$991 VSS|vss 0.27808a
Cext_18126 \$991 VSUBS 255.681a
Cext_18127 \$992 \$993 45.0654a
Cext_18128 \$992 VDD|vdd 7.74075a
Cext_18129 \$992 VSS|vss 1.71997a
Cext_18130 \$992 VSUBS 659.267a
Cext_18131 \$993 \$994 45.0654a
Cext_18132 \$993 VDD|vdd 0.968272a
Cext_18133 \$993 VSUBS 634.529a
Cext_18134 \$994 \$995 45.0654a
Cext_18135 \$994 VSUBS 634.529a
Cext_18136 \$995 \$996 45.8951a
Cext_18137 \$995 VSS|vss 0.428128a
Cext_18138 \$995 VSUBS 634.529a
Cext_18139 \$996 \$997 2.46853a
Cext_18140 \$996 VSS|vss 61.1015a
Cext_18141 \$996 VSUBS 793.935a
Cext_18142 \$997 \$998 0.179323a
Cext_18143 \$997 VSUBS 167.598a
Cext_18144 \$998 VSS|vss 66.2132a
Cext_18145 \$998 VSUBS 818.365a
Cext_18146 \$999 IOVDD|vdda 11.6291a
Cext_18147 \$999 VSS|vss 60.9228a
Cext_18148 \$999 VSUBS 810.925a
Cext_18149 clk clk|cmp_clk_n 107.926a
Cext_18150 clk cmp_hard|q 1.46326f
Cext_18151 clk cmp_soft|q 1.13822f
Cext_18152 clk icmp|inp 151.372a
Cext_18153 clk inn|out|vth_soft 147.301a
Cext_18154 clk qb$1 111.369a
Cext_18155 clk|cmp_clk_n cmp_hard|q 167.222a
Cext_18156 clk|cmp_clk_n cmp_soft|q 183.515a
Cext_18157 clk|cmp_clk_n icmp|inp 147.301a
Cext_18158 clk|cmp_clk_n inn|out|vth_hard 156.302a
Cext_18159 clk|cmp_clk_n qb$1 111.369a
Cext_18160 cmp_hard|q cmp_soft|q 1.5031f
Cext_18161 cmp_hard|q icmp|inp 36.7772a
Cext_18162 cmp_hard|q inn|out|vth_hard 16.487a
Cext_18163 cmp_hard|q qb$1 3.19306f
Cext_18164 cmp_soft|q icmp|inp 37.0683a
Cext_18165 cmp_soft|q inn|out|vth_soft 14.1894a
Cext_18166 cmp_soft|q qb$1 3.19306f
Cext_18167 d0|dac_hard[0] d1|dac_hard[1] 11.2997f
Cext_18168 d0|dac_hard[0] d2|dac_hard[2] 0.782726a
Cext_18169 d0|dac_hard[0] d3|dac_hard[3] 0.461202a
Cext_18170 d0|dac_hard[0] d4|dac_hard[4] 0.324438a
Cext_18171 d0|dac_hard[0] d5|dac_hard[5] 0.257013a
Cext_18172 d0|dac_hard[0] d6|dac_hard[6] 0.133525a
Cext_18173 d0|dac_hard[0] d7|dac_hard[7] 0.133525a
Cext_18174 d0|dac_soft[0] d1|dac_soft[1] 1.77306f
Cext_18175 d0|dac_soft[0] d2|dac_soft[2] 28.9143a
Cext_18176 d0|dac_soft[0] d3|dac_soft[3] 28.9429a
Cext_18177 d0|dac_soft[0] d4|dac_soft[4] 28.9779a
Cext_18178 d0|dac_soft[0] d5|dac_soft[5] 29.2944a
Cext_18179 d0|dac_soft[0] d6|dac_soft[6] 29.5484a
Cext_18180 d0|dac_soft[0] d7|dac_soft[7] 45.4414a
Cext_18181 d1|dac_hard[1] d2|dac_hard[2] 10.4588f
Cext_18182 d1|dac_hard[1] d3|dac_hard[3] 0.80202a
Cext_18183 d1|dac_hard[1] d4|dac_hard[4] 0.480497a
Cext_18184 d1|dac_hard[1] d5|dac_hard[5] 0.343732a
Cext_18185 d1|dac_hard[1] d6|dac_hard[6] 0.276308a
Cext_18186 d1|dac_hard[1] d7|dac_hard[7] 0.15282a
Cext_18187 d1|dac_soft[1] d2|dac_soft[2] 2.60664f
Cext_18188 d1|dac_soft[1] d3|dac_soft[3] 28.8416a
Cext_18189 d1|dac_soft[1] d4|dac_soft[4] 28.8766a
Cext_18190 d1|dac_soft[1] d5|dac_soft[5] 29.1931a
Cext_18191 d1|dac_soft[1] d6|dac_soft[6] 29.4471a
Cext_18192 d1|dac_soft[1] d7|dac_soft[7] 45.3401a
Cext_18193 d2|dac_hard[2] d3|dac_hard[3] 9.61794f
Cext_18194 d2|dac_hard[2] d4|dac_hard[4] 0.825399a
Cext_18195 d2|dac_hard[2] d5|dac_hard[5] 0.503876a
Cext_18196 d2|dac_hard[2] d6|dac_hard[6] 0.367111a
Cext_18197 d2|dac_hard[2] d7|dac_hard[7] 0.299687a
Cext_18198 d2|dac_soft[2] d3|dac_soft[3] 3.44033f
Cext_18199 d2|dac_soft[2] d4|dac_soft[4] 28.8766a
Cext_18200 d2|dac_soft[2] d5|dac_soft[5] 29.1931a
Cext_18201 d2|dac_soft[2] d6|dac_soft[6] 29.4471a
Cext_18202 d2|dac_soft[2] d7|dac_soft[7] 45.3401a
Cext_18203 d3|dac_hard[3] d4|dac_hard[4] 8.77702f
Cext_18204 d3|dac_hard[3] d5|dac_hard[5] 0.853931a
Cext_18205 d3|dac_hard[3] d6|dac_hard[6] 0.532408a
Cext_18206 d3|dac_hard[3] d7|dac_hard[7] 0.395643a
Cext_18207 d3|dac_soft[3] d4|dac_soft[4] 4.27402f
Cext_18208 d3|dac_soft[3] d5|dac_soft[5] 29.1931a
Cext_18209 d3|dac_soft[3] d6|dac_soft[6] 29.4471a
Cext_18210 d3|dac_soft[3] d7|dac_soft[7] 45.3401a
Cext_18211 d4|dac_hard[4] d5|dac_hard[5] 7.93636f
Cext_18212 d4|dac_hard[4] d6|dac_hard[6] 0.88896a
Cext_18213 d4|dac_hard[4] d7|dac_hard[7] 0.567437a
Cext_18214 d4|dac_soft[4] d5|dac_soft[5] 5.10799f
Cext_18215 d4|dac_soft[4] d6|dac_soft[6] 29.4471a
Cext_18216 d4|dac_soft[4] d7|dac_soft[7] 45.3401a
Cext_18217 d5|dac_hard[5] d6|dac_hard[6] 7.09587f
Cext_18218 d5|dac_hard[5] d7|dac_hard[7] 1.20548a
Cext_18219 d5|dac_soft[5] d6|dac_soft[6] 5.9419f
Cext_18220 d5|dac_soft[5] d7|dac_soft[7] 45.3401a
Cext_18221 d6|dac_hard[6] d7|dac_hard[7] 6.25545f
Cext_18222 d6|dac_soft[6] d7|dac_soft[7] 6.79145f
Cext_18223 icmp|inp inn|out|vth_hard 1.50264f
Cext_18224 icmp|inp inn|out|vth_soft 829.681a
Cext_18225 icmp|inp qb$1 185.541a
Cext_18226 inn|out|vth_hard qb$1 102.551a
Cext_18227 inn|out|vth_soft qb$1 100.253a
Cext_18228 IOVDD|vdda clk 513.317a
Cext_18229 IOVDD|vdda clk|cmp_clk_n 81.8988a
Cext_18230 IOVDD|vdda cmp_hard|q 0.140429a
Cext_18231 IOVDD|vdda cmp_soft|q 306.084a
Cext_18232 IOVDD|vdda d1|dac_hard[1] 0.123243a
Cext_18233 IOVDD|vdda d2|dac_hard[2] 0.161692a
Cext_18234 IOVDD|vdda d3|dac_hard[3] 0.221022a
Cext_18235 IOVDD|vdda d4|dac_hard[4] 0.319126a
Cext_18236 IOVDD|vdda d5|dac_hard[5] 0.49701a
Cext_18237 IOVDD|vdda d6|dac_hard[6] 0.968416a
Cext_18238 IOVDD|vdda d7|dac_hard[7] 47.5451a
Cext_18239 IOVDD|vdda d7|dac_soft[7] 33.6928a
Cext_18240 IOVDD|vdda icmp|inp 118.42a
Cext_18241 IOVDD|vdda inn|out|vth_hard 76.1758a
Cext_18242 IOVDD|vdda VDD|vdd 6.953f
Cext_18243 IOVDD|vdda VREF|vref 157.658a
Cext_18244 IOVDD|vdda VSS|vss 3.73343f
Cext_18245 IOVDD|vdda VSUBS 50.8446f
Cext_18246 ISENSE|isense VDD|vdd 34.6019a
Cext_18247 ISENSE|isense VREF|vref 27.3363a
Cext_18248 ISENSE|isense VSS|vss 85.8393a
Cext_18249 ISENSE|isense VSUBS 960.443a
Cext_18250 VDD|vdd clk 604.38a
Cext_18251 VDD|vdd clk|cmp_clk_n 509.992a
Cext_18252 VDD|vdd cmp_hard|q 71.1634a
Cext_18253 VDD|vdd cmp_soft|q 199.555a
Cext_18254 VDD|vdd d0|dac_hard[0] 59.0637a
Cext_18255 VDD|vdd d0|dac_soft[0] 64.7131a
Cext_18256 VDD|vdd d1|dac_hard[1] 54.6949a
Cext_18257 VDD|vdd d1|dac_soft[1] 54.8182a
Cext_18258 VDD|vdd d2|dac_hard[2] 55.155a
Cext_18259 VDD|vdd d2|dac_soft[2] 54.8566a
Cext_18260 VDD|vdd d3|dac_hard[3] 55.6389a
Cext_18261 VDD|vdd d3|dac_soft[3] 54.916a
Cext_18262 VDD|vdd d4|dac_hard[4] 57.0271a
Cext_18263 VDD|vdd d4|dac_soft[4] 55.0141a
Cext_18264 VDD|vdd d5|dac_hard[5] 57.3271a
Cext_18265 VDD|vdd d5|dac_soft[5] 55.1919a
Cext_18266 VDD|vdd d6|dac_hard[6] 57.1891a
Cext_18267 VDD|vdd d6|dac_soft[6] 55.6634a
Cext_18268 VDD|vdd d7|dac_hard[7] 57.7392a
Cext_18269 VDD|vdd d7|dac_soft[7] 91.868a
Cext_18270 VDD|vdd icmp|inp 70.0072a
Cext_18271 VDD|vdd inn|out|vth_soft 77.6818a
Cext_18272 VDD|vdd qb$1 13.3682a
Cext_18273 VDD|vdd VREF|vref 156.396a
Cext_18274 VDD|vdd VSS|vss 24.7818f
Cext_18275 VDD|vdd VSUBS 56.925f
Cext_18276 VREF|vref icmp|inp 2.75298f
Cext_18277 VREF|vref inn|out|vth_hard 26.3375a
Cext_18278 VREF|vref inn|out|vth_soft 83.7979a
Cext_18279 VREF|vref VSS|vss 1.75385f
Cext_18280 VREF|vref VSUBS 90.0933f
Cext_18281 VSS|vss clk 704.252a
Cext_18282 VSS|vss clk|cmp_clk_n 1.08434f
Cext_18283 VSS|vss cmp_hard|q 894.892a
Cext_18284 VSS|vss cmp_soft|q 957.554a
Cext_18285 VSS|vss d0|dac_hard[0] 6.75433f
Cext_18286 VSS|vss d0|dac_soft[0] 1.40841f
Cext_18287 VSS|vss d1|dac_hard[1] 610.322a
Cext_18288 VSS|vss d1|dac_soft[1] 708.861a
Cext_18289 VSS|vss d2|dac_hard[2] 594.12a
Cext_18290 VSS|vss d2|dac_soft[2] 639.943a
Cext_18291 VSS|vss d3|dac_hard[3] 585.486a
Cext_18292 VSS|vss d3|dac_soft[3] 606.689a
Cext_18293 VSS|vss d4|dac_hard[4] 582.659a
Cext_18294 VSS|vss d4|dac_soft[4] 588.971a
Cext_18295 VSS|vss d5|dac_hard[5] 585.532a
Cext_18296 VSS|vss d5|dac_soft[5] 581.015a
Cext_18297 VSS|vss d6|dac_hard[6] 589.85a
Cext_18298 VSS|vss d6|dac_soft[6] 582.472a
Cext_18299 VSS|vss d7|dac_hard[7] 776.155a
Cext_18300 VSS|vss d7|dac_soft[7] 794.706a
Cext_18301 VSS|vss icmp|inp 1.33536f
Cext_18302 VSS|vss inn|out|vth_hard 740.643a
Cext_18303 VSS|vss inn|out|vth_soft 667.856a
Cext_18304 VSS|vss qb$1 1.34474f
Cext_18305 VSS|vss VSUBS 325.768f
Cext_18306 VSUBS clk 11.0233f
Cext_18307 VSUBS clk|cmp_clk_n 8.06337f
Cext_18308 VSUBS cmp_hard|q 5.31928f
Cext_18309 VSUBS cmp_soft|q 9.25597f
Cext_18310 VSUBS d0|dac_hard[0] 2.77039f
Cext_18311 VSUBS d0|dac_soft[0] 1.7182f
Cext_18312 VSUBS d1|dac_hard[1] 2.47234f
Cext_18313 VSUBS d1|dac_soft[1] 1.76123f
Cext_18314 VSUBS d2|dac_hard[2] 2.37297f
Cext_18315 VSUBS d2|dac_soft[2] 1.79667f
Cext_18316 VSUBS d3|dac_hard[3] 2.27098f
Cext_18317 VSUBS d3|dac_soft[3] 1.82908f
Cext_18318 VSUBS d4|dac_hard[4] 2.16815f
Cext_18319 VSUBS d4|dac_soft[4] 1.85909f
Cext_18320 VSUBS d5|dac_hard[5] 2.0642f
Cext_18321 VSUBS d5|dac_soft[5] 1.88615f
Cext_18322 VSUBS d6|dac_hard[6] 1.95817f
Cext_18323 VSUBS d6|dac_soft[6] 1.90962f
Cext_18324 VSUBS d7|dac_hard[7] 2.98932f
Cext_18325 VSUBS d7|dac_soft[7] 3.26844f
Cext_18326 VSUBS icmp|inp 16.7608f
Cext_18327 VSUBS inn|out|vth_hard 9.67324f
Cext_18328 VSUBS inn|out|vth_soft 8.52703f
Cext_18329 VSUBS qb$1 6.12466f
.ENDS g1_trip
