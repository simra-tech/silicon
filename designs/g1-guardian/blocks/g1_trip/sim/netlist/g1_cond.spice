** sch_path: /work/designs/g1-guardian/blocks/g1_trip/schematic/g1_cond.sch
.subckt g1_cond isense icmp vss
*.ipin isense
*.opin icmp
*.iopin vss
XRC0 isense c0 sub! rppd w=2u l=76.7u m=1 b=0 mm_ok=1
XRC1 c0 c1 sub! rppd w=2u l=76.7u m=1 b=0 mm_ok=1
XRC2 c1 c2 sub! rppd w=2u l=76.7u m=1 b=0 mm_ok=1
XRC3 c2 c3 sub! rppd w=2u l=76.7u m=1 b=0 mm_ok=1
XRC4 c3 icmp sub! rppd w=2u l=76.7u m=1 b=0 mm_ok=1
XRC5 icmp c5 sub! rppd w=2u l=76.7u m=1 b=0 mm_ok=1
XRC6 c5 c6 sub! rppd w=2u l=76.7u m=1 b=0 mm_ok=1
XRC7 c6 c7 sub! rppd w=2u l=76.7u m=1 b=0 mm_ok=1
XRC8 c7 c8 sub! rppd w=2u l=76.7u m=1 b=0 mm_ok=1
XRC9 c8 vss sub! rppd w=2u l=76.7u m=1 b=0 mm_ok=1
XCH icmp vss cap_cmim w=26u l=26u m=1 mm_ok=1
.ends
