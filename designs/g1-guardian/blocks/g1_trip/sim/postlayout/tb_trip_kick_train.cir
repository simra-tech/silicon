* G1_TRIP post-layout: continuous 5 MHz strobe train (21 soft + 21 hard strobes) through the macro, DAC
* codes soft @@SCODE@@, hard @@HCODE@@ (reset defaults 153, 254). ISENSE is an ideal source set so that
* icmp (= ISENSE/2) sits @@UD@@ LSB (VREF/530) below the DC threshold of the comparator under test (@@COND@@),
* i.e. the decision is low unless kickback moves the effective threshold by more than 1 LSB.
* vth_soft, vth_hard, icmp, clock and outputs are written with wrdata; kick_train.py samples them at the
* strobe edges (soft: cmp_clk rising at 20n+k*200n; hard: cmp_clk falling = cmp_clk_n rising at 120n+k*200n).
.param VDD=@@VDD@@ VREF=1.04
.lib /foss/pdks/ihp-sg13g2/libs.tech/ngspice/models/cornerMOSlv.lib @@MOS@@
.lib /foss/pdks/ihp-sg13g2/libs.tech/ngspice/models/cornerMOShv.lib @@MOS@@
.lib /foss/pdks/ihp-sg13g2/libs.tech/ngspice/models/cornerRES.lib res_typ
.lib /foss/pdks/ihp-sg13g2/libs.tech/ngspice/models/cornerCAP.lib cap_typ
.temp @@TEMP@@
.option rshunt=1e12 gmin=1e-13
.include @@NET@@
Vdd vdd 0 dc {VDD}
Vdda vdda 0 dc 3.3
Vref vref 0 dc {VREF}
Visense isense 0 pwl(0 1.5 1 1.5)
Vclk cmp_clk 0 pulse(0 {VDD} 20n 0.2n 0.2n 99.8n 200n)
* soft code @@SCODE@@ (s0 LSB; reset default 0x99 = 153)
Vs0 s0 0 dc @@S0@@
Vs1 s1 0 dc @@S1@@
Vs2 s2 0 dc @@S2@@
Vs3 s3 0 dc @@S3@@
Vs4 s4 0 dc @@S4@@
Vs5 s5 0 dc @@S5@@
Vs6 s6 0 dc @@S6@@
Vs7 s7 0 dc @@S7@@
* hard code @@HCODE@@ (reset default 0xFE = 254)
Vh0 h0 0 dc @@H0@@
Vh1 h1 0 dc @@H1@@
Vh2 h2 0 dc @@H2@@
Vh3 h3 0 dc @@H3@@
Vh4 h4 0 dc @@H4@@
Vh5 h5 0 dc @@H5@@
Vh6 h6 0 dc @@H6@@
Vh7 h7 0 dc @@H7@@
X1 isense vref cmp_clk s0 s1 s2 s3 s4 s5 s6 s7 h0 h1 h2 h3 h4 h5 h6 h7 cmp_soft cmp_hard vdd vdda 0 g1_trip
Cq cmp_soft 0 10f
Cqh cmp_hard 0 10f
.control
set filetype=ascii
op
let vs0 = v(x1.vth_@@COND@@)
let vis = 2*(vs0 - (@@UD@@)*1.04/530)
set svis = $&vis
alter @Visense[pwl] = [ 0 $svis 1 $svis ]
op
echo "DC vth_soft=" $&v(x1.vth_soft) " vth_hard=" $&v(x1.vth_hard) " icmp=" $&v(x1.icmp) " isense=" $svis
tran 0.1n @@TSTOP@@
wrdata @@OUT@@ v(x1.vth_soft) v(x1.vth_hard) v(x1.icmp) v(cmp_clk) v(cmp_soft) v(cmp_hard)
.endc
.end
