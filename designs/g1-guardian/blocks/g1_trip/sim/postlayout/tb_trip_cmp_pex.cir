* G1_TRIP post-layout: soft comparator decision delay vs overdrive through the macro.  Soft DAC at
* code 128 (vth_soft = VREF*383/530), ISENSE steps from 2*(vth-od) to 2*(vth+od) 1 ns after the first
* strobe so that icmp (the ISENSE/2 node, 25 kOhm || 1 pF in the layout) has settled before the
* second strobe, whose decision delay to cmp_soft = 0.6 V is measured.
.param VDD=@@VDD@@ VREF=1.04
.lib /foss/pdks/ihp-sg13g2/libs.tech/ngspice/models/cornerMOSlv.lib @@MOS@@
.lib /foss/pdks/ihp-sg13g2/libs.tech/ngspice/models/cornerMOShv.lib @@MOS@@
.lib /foss/pdks/ihp-sg13g2/libs.tech/ngspice/models/cornerRES.lib res_typ
.lib /foss/pdks/ihp-sg13g2/libs.tech/ngspice/models/cornerCAP.lib cap_typ
.temp @@TEMP@@
.option rshunt=1e12 gmin=1e-13
.include postlayout/g1_trip_pex.spice
Vdd vdd 0 dc {VDD}
Vdda vdda 0 dc 3.3
Vref vref 0 dc {VREF}
Visense isense 0 pwl(0 1.5 21n 1.5 22n 1.5)
* rising edges at 20 ns and 20 ns + T
Vclk cmp_clk 0 pulse(0 {VDD} 20n 0.2n 0.2n @@THALF@@ @@TPER@@)
Vs0 s0 0 dc 0
Vs1 s1 0 dc 0
Vs2 s2 0 dc 0
Vs3 s3 0 dc 0
Vs4 s4 0 dc 0
Vs5 s5 0 dc 0
Vs6 s6 0 dc 0
Vs7 s7 0 dc {VDD}
Vh0 h0 0 dc 0
Vh1 h1 0 dc 0
Vh2 h2 0 dc 0
Vh3 h3 0 dc 0
Vh4 h4 0 dc 0
Vh5 h5 0 dc 0
Vh6 h6 0 dc 0
Vh7 h7 0 dc {VDD}
X1 isense vref cmp_clk s0 s1 s2 s3 s4 s5 s6 s7 h0 h1 h2 h3 h4 h5 h6 h7 cmp_soft cmp_hard vdd vdda 0 g1_trip
Cq cmp_soft 0 10f
Cqh cmp_hard 0 10f
.control
set filetype=ascii
op
let vth0 = v(x1.vth_soft)
set svth = $&vth0
echo "VTH code128 =" $svth
foreach od 0.05 0.005 0.001
  let vlo = 2*($svth - $od)
  let vhi = 2*($svth + $od)
  set svlo = $&vlo
  set svhi = $&vhi
  alter @Visense[pwl] = [ 0 $svlo 21n $svlo 22n $svhi ]
  tran 0.05n @@TEND@@
  meas tran icmp_1 find v(x1.icmp) at=20n
  meas tran icmp_25 find v(x1.icmp) at=25n
  meas tran icmp_40 find v(x1.icmp) at=40n
  meas tran icmp_70 find v(x1.icmp) at=70n
  meas tran vth_25 find v(x1.vth_soft) at=25n
  meas tran vth_40 find v(x1.vth_soft) at=40n
  meas tran vth_70 find v(x1.vth_soft) at=70n
  meas tran icmp_min min v(x1.icmp) from=20n to=40n
  meas tran icmp_max max v(x1.icmp) from=20n to=40n
  meas tran vth_min min v(x1.vth_soft) from=20n to=40n
  meas tran vth_max max v(x1.vth_soft) from=20n to=40n
  meas tran icmp_pre find v(x1.icmp) at=@@T2@@
  meas tran vth_pre find v(x1.vth_soft) at=@@T2@@
  meas tran q1 find v(cmp_soft) at=60n
  meas tran tq when v(cmp_soft)=0.6 rise=1 from=@@T2@@
  let td = (tq - @@T2@@)*1e9
  meas tran qmid find v(cmp_soft) at=@@T2@@
  meas tran qend find v(cmp_soft) at=@@TEND@@
  let odeff = (icmp_pre - vth_pre)*1e3
  let od1 = (icmp_1 - vth_pre)*1e3
  echo "DELAY od=" $od " od1_mV=" $&od1 " q_after_strobe1=" $&q1 " od_eff_mV=" $&odeff " td_ns=" $&td " q_before=" $&qmid " q_end=" $&qend
  echo "KICK od=" $od " icmp 25/40/70ns=" $&icmp_25 $&icmp_40 $&icmp_70 " min/max(20-40ns)=" $&icmp_min $&icmp_max " vth 25/40/70ns=" $&vth_25 $&vth_40 $&vth_70 " min/max=" $&vth_min $&vth_max
end
.endc
.end
