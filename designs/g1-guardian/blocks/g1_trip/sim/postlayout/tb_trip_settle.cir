* G1_TRIP post-layout settling (clock static low: soft comparator in reset, hard comparator evaluating;
* no strobe kicks): (1) hard DAC code step 254 -> 200 at 100 ns (h1, h2, h4, h5 fall in 0.2 ns): time for
* vth_hard to stay within 1 LSB (VREF/530) of its value at 2.9 us; (2) ISENSE ramp in 100 ns at 3 us from
* 1.0 V to 2*(vth_hard + 10 LSB) (a fault 10 LSB above the code-200 threshold): time for icmp to cross
* vth_hard and to stay within 1 LSB of its value at 5.9 us; (3) the same ramp at 9 us to 2.2 V (icmp 1.1 V).
.param VDD=@@VDD@@ VREF=1.04
.lib /foss/pdks/ihp-sg13g2/libs.tech/ngspice/models/cornerMOSlv.lib @@MOS@@
.lib /foss/pdks/ihp-sg13g2/libs.tech/ngspice/models/cornerMOShv.lib @@MOS@@
.lib /foss/pdks/ihp-sg13g2/libs.tech/ngspice/models/cornerRES.lib res_typ
.lib /foss/pdks/ihp-sg13g2/libs.tech/ngspice/models/cornerCAP.lib cap_typ
.temp @@TEMP@@
.option rshunt=1e12 gmin=1e-13
.include @@NET@@
.param LSB={VREF/530} VF={2*(VREF*(255+200)/530 + 10*VREF/530)}
Vdd vdd 0 dc {VDD}
Vdda vdda 0 dc 3.3
Vref vref 0 dc {VREF}
Visense isense 0 pwl(0 1.0 3u 1.0 3.1u {VF} 6u {VF} 6.1u 1.0 9u 1.0 9.1u 2.2)
Vclk cmp_clk 0 dc 0
* soft 0x99
Vs0 s0 0 dc {VDD}
Vs1 s1 0 dc 0
Vs2 s2 0 dc 0
Vs3 s3 0 dc {VDD}
Vs4 s4 0 dc {VDD}
Vs5 s5 0 dc 0
Vs6 s6 0 dc 0
Vs7 s7 0 dc {VDD}
* hard 254 -> 200 at 100 ns
Vh0 h0 0 dc 0
Vh1 h1 0 pwl(0 {VDD} 100n {VDD} 100.2n 0)
Vh2 h2 0 pwl(0 {VDD} 100n {VDD} 100.2n 0)
Vh3 h3 0 dc {VDD}
Vh4 h4 0 pwl(0 {VDD} 100n {VDD} 100.2n 0)
Vh5 h5 0 pwl(0 {VDD} 100n {VDD} 100.2n 0)
Vh6 h6 0 dc {VDD}
Vh7 h7 0 dc {VDD}
X1 isense vref cmp_clk s0 s1 s2 s3 s4 s5 s6 s7 h0 h1 h2 h3 h4 h5 h6 h7 cmp_soft cmp_hard vdd vdda 0 g1_trip
.control
tran 1n 12u 0 0.5n
meas tran vfin find v(x1.vth_hard) at=2.9u
let lsb = 1.04/530
let vhi = vfin + lsb
meas tran tdac when v(x1.vth_hard)=vhi cross=last from=100n to=2.9u
let tdac_ns = (tdac - 100n)*1e9
meas tran ifin find v(x1.icmp) at=5.9u
let ilo = ifin - lsb
meas tran tis when v(x1.icmp)=ilo cross=last from=3u to=5.9u
let tis_ns = (tis - 3u)*1e9
let dv = v(x1.icmp) - v(x1.vth_hard)
meas tran tx1 when dv=0 rise=1 from=3u to=5.9u
let tx1_ns = (tx1 - 3u)*1e9
meas tran tx2 when dv=0 rise=1 from=9u to=12u
let tx2_ns = (tx2 - 9u)*1e9
echo "SETTLE dac254to200_within1LSB_ns=" $&tdac_ns " vth_hard_final=" $&vfin " icmp_step_within1LSB_ns=" $&tis_ns " icmp_final=" $&ifin " cross_10LSB_fault_ns=" $&tx1_ns " cross_2.2V_fault_ns=" $&tx2_ns
.endc
.end
