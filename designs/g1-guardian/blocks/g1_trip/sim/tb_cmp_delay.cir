* G1_TRIP comparator: decision delay vs overdrive; 1 kOhm / 1 pF source on both inputs
.param VDD=@@VDD@@ VCM=@@VCM@@
.lib /foss/pdks/ihp-sg13g2/libs.tech/ngspice/models/cornerMOSlv.lib @@MOS@@
.lib /foss/pdks/ihp-sg13g2/libs.tech/ngspice/models/cornerRES.lib res_typ
.lib /foss/pdks/ihp-sg13g2/libs.tech/ngspice/models/cornerCAP.lib cap_typ
.temp @@TEMP@@
.include netlist/g1_cmp.spice
Vdd vdd 0 dc {VDD}
Vcm inn0 0 dc {VCM}
Vod inp0 inn0 pwl(0 -0.01 @@TFLIP@@ -0.01 @@TFLIP1@@ 0.01)
Rsp inp0 inp 1k
Rsn inn0 inn 1k
Cp inp 0 1p
Cn inn 0 1p
* rising edges at 20 ns and 20 ns + T
Vclk clk 0 pulse(0 {VDD} 20n 0.2n 0.2n @@THALF@@ @@TPER@@)
X1 inp inn clk q qb vdd 0 g1_cmp
Cq q 0 10f
Cqb qb 0 10f
.control
set filetype=ascii
foreach od 0.001 0.002 0.005 0.01 0.02 0.05 0.1 0.2
  alter @Vod[pwl] = [ 0 -$od @@TFLIP@@ -$od @@TFLIP1@@ $od ]
  tran 0.05n @@TEND@@
  meas tran tq when v(q)=0.6 rise=1 from=@@T2@@
  meas tran tqb when v(qb)=0.6 fall=1 from=@@T2@@
  let td = (tq - @@T2@@)*1e9
  let idd = -i(vdd)
  meas tran iavg avg idd from=@@T2@@ to=@@TEND@@
  meas tran qend find v(q) at=@@TEND@@
  meas tran qmid find v(q) at=@@T2@@
  meas tran xnmin min v(x1.xn) from=@@T2@@ to=@@TEND@@
  meas tran ynmin min v(x1.yn) from=@@T2@@ to=@@TEND@@
  let iu = iavg*1e6
  echo "DELAY od=" $od " td_ns=" $&td " q_before=" $&qmid " q_end=" $&qend " iavg_uA=" $&iu " xn_min=" $&xnmin " yn_min=" $&ynmin
end
.endc
.end
