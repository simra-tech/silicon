* G1_TRIP comparator offset MC: 0.5 mV staircase over +/-16 mV, one step per 10 MHz strobe
.param VDD=1.2 VCM=@@VCM@@
.lib /foss/pdks/ihp-sg13g2/libs.tech/ngspice/models/cornerMOSlv.lib mos_tt_mismatch
.lib /foss/pdks/ihp-sg13g2/libs.tech/ngspice/models/cornerRES.lib res_typ
.lib /foss/pdks/ihp-sg13g2/libs.tech/ngspice/models/cornerCAP.lib cap_typ
.temp @@TEMP@@
.include netlist/g1_cmp.spice
Vdd vdd 0 dc {VDD}
Vcm inn0 0 dc {VCM}
Vod inp0 inn0 pwl(@@PWL@@)
Rsp inp0 inp 1k
Rsn inn0 inn 1k
Cp inp 0 1p
Cn inn 0 1p
Vclk clk 0 pulse(0 {VDD} 20n 0.2n 0.2n 50n 100n)
X1 inp inn clk q qb vdd 0 g1_cmp
Cq q 0 10f
Cqb qb 0 10f
.control
set filetype=ascii
set rndseed=@@SEED@@
let n = @@N@@
let i = 0
while i < n
  reset
  tran 0.5n 6.55u
  meas tran tflip when v(q)=0.6 rise=1 from=30n
  let k = floor((tflip - 20e-9)/100e-9 + 0.5)
  let vos = -(-0.016 + 0.0005*k) + 0.00025
  echo "MC" $&i " k=" $&k " vos_V=" $&vos
  let i = i + 1
end
.endc
.end
