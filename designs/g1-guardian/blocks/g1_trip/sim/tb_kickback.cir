* G1_TRIP kickback: real source (G1_SENSE output through the conditioning divider) and real DAC tap,
* both comparators clocked (soft on cmp_clk, hard on its inverse), 10 MHz. Soft threshold code 153
* (30.0 mV shunt), shunt input set @@VSH@@ so the soft comparator sits at/near its threshold.
.param VDDA=3.3 VDD=1.2 VREF=1.04
.lib /foss/pdks/ihp-sg13g2/libs.tech/ngspice/models/cornerMOSlv.lib mos_tt
.lib /foss/pdks/ihp-sg13g2/libs.tech/ngspice/models/cornerMOShv.lib mos_tt
.lib /foss/pdks/ihp-sg13g2/libs.tech/ngspice/models/cornerRES.lib res_typ
.lib /foss/pdks/ihp-sg13g2/libs.tech/ngspice/models/cornerCAP.lib cap_typ
.temp 27
* the off switches leave the mux tree nodes floating at DC: give the solver a 1 TOhm path per node
.option rshunt=1e12 gmin=1e-13
.include ../../g1_sense/sim/netlist/g1_sense.spice
.include netlist/g1_trip.spice
Vdda vdda 0 dc {VDDA}
Vdd vdd 0 dc {VDD}
Vref vref 0 dc {VREF}
Iib vdda iptat dc 4.13u
Vsh shp 0 dc @@VSH@@
XS shp 0 vref iptat isense vped vref_buf vdda 0 g1_sense
CL isense 0 300f
* soft code 153 = 1001 1001b (30.0 mV) ; hard code 254 = 1111 1110b (49.8 mV)
Vs0 s0 0 dc 1.2
Vs1 s1 0 dc 0
Vs2 s2 0 dc 0
Vs3 s3 0 dc 1.2
Vs4 s4 0 dc 1.2
Vs5 s5 0 dc 0
Vs6 s6 0 dc 0
Vs7 s7 0 dc 1.2
Vh0 h0 0 dc 0
Vh1 h1 0 dc 1.2
Vh2 h2 0 dc 1.2
Vh3 h3 0 dc 1.2
Vh4 h4 0 dc 1.2
Vh5 h5 0 dc 1.2
Vh6 h6 0 dc 1.2
Vh7 h7 0 dc 1.2
Vclk clk 0 pulse(0 1.2 20n 0.2n 0.2n 50n 100n)
XT isense vref_buf clk s0 s1 s2 s3 s4 s5 s6 s7 h0 h1 h2 h3 h4 h5 h6 h7 cmp_soft cmp_hard vdd vdda 0 g1_trip
Cs cmp_soft 0 10f
Ch cmp_hard 0 10f
* keep only the nodes of interest (the full 1200-device transient exhausts the output memory)
.save v(xt.icmp) v(xt.vth_soft) v(xt.vth_hard) v(cmp_soft) v(cmp_hard) v(isense)
.control
set filetype=ascii
op
let ic0 = v(xt.icmp)
let vs0 = v(xt.vth_soft)
let vh0 = v(xt.vth_hard)
echo "QUIET icmp=" $&ic0 " vth_soft=" $&vs0 " vth_hard=" $&vh0 " isense=" $&v(isense)
* op-plot vectors are not visible from the tran plot: carry the quiet values over as shell variables
set sic0 = $&ic0
set svs0 = $&vs0
set svh0 = $&vh0
tran 0.2n 1.52u
let dic = v(xt.icmp) - $sic0
let dvs = v(xt.vth_soft) - $svs0
let dvh = v(xt.vth_hard) - $svh0
meas tran icmax max dic from=0.5u to=1.5u
meas tran icmin min dic from=0.5u to=1.5u
meas tran icavg avg dic from=0.5u to=1.5u
meas tran vsmax max dvs from=0.5u to=1.5u
meas tran vsmin min dvs from=0.5u to=1.5u
meas tran vsavg avg dvs from=0.5u to=1.5u
meas tran vhmax max dvh from=0.5u to=1.5u
meas tran vhmin min dvh from=0.5u to=1.5u
meas tran vhavg avg dvh from=0.5u to=1.5u
let e1=icmax*1e3
let e2=icmin*1e3
let e3=icavg*1e3
let e4=vsmax*1e3
let e5=vsmin*1e3
let e6=vsavg*1e3
let e7=vhmax*1e3
let e8=vhmin*1e3
let e9=vhavg*1e3
echo "KICK icmp mV: max=" $&e1 " min=" $&e2 " avg=" $&e3
echo "KICK vth_soft mV: max=" $&e4 " min=" $&e5 " avg=" $&e6
echo "KICK vth_hard mV: max=" $&e7 " min=" $&e8 " avg=" $&e9
* decisions in the last 1 us (count of high samples of cmp_soft at 10 MHz)
meas tran softavg avg v(cmp_soft) from=0.5u to=1.5u
meas tran hardavg avg v(cmp_hard) from=0.5u to=1.5u
echo "DECISION avg cmp_soft=" $&softavg " avg cmp_hard=" $&hardavg
.endc
.end
