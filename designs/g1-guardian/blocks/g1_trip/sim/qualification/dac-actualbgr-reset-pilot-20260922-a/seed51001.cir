* G1_TRIP kickback: real source (G1_SENSE output through the conditioning divider) and real DAC tap,
* both comparators clocked (soft on cmp_clk, hard on its inverse), 10 MHz. Soft threshold code 153
* (30.0 mV shunt), shunt input set .025 so the soft comparator sits at/near its threshold.
.param VDDA=3.3 VDD=1.2 VREF=1.04
.lib /foss/pdks/ihp-sg13g2/libs.tech/ngspice/models/cornerMOSlv.lib mos_tt_mismatch
.lib /foss/pdks/ihp-sg13g2/libs.tech/ngspice/models/cornerMOShv.lib mos_tt_mismatch
.lib /foss/pdks/ihp-sg13g2/libs.tech/ngspice/models/cornerRES.lib res_typ_mismatch
.lib /foss/pdks/ihp-sg13g2/libs.tech/ngspice/models/cornerCAP.lib cap_typ_mismatch
.temp 25
* the off switches leave the mux tree nodes floating at DC: give the solver a 1 TOhm path per node
.option rshunt=1e12 gmin=1e-13
.include qualification/dac-actualbgr-reset-pilot-20260922-a/sense.spice
.include qualification/dac-actualbgr-reset-pilot-20260922-a/trip.spice
Vdda vdda 0 dc {VDDA}
Vdd vdd 0 dc {VDD}
Vsh shp 0 dc .025
XS shp 0 vref iptat isense vped vref_buf vdda 0 g1_sense
CL isense 0 300f
* soft code 153 = 1001 1001b (30.0 mV) ; hard code 254 = 1111 1110b (49.8 mV)
Vs0 s0 0 dc 1.2
Vs1 s1 0 dc 0
Vs2 s2 0 dc 0
Vs3 s3 0 dc 1.2
Vs4 s4 0 dc 1.2
Vs5 s5 0 dc 0
Vs6 s6 0 dc 0
Vs7 s7 0 dc 1.2
Vh0 h0 0 dc 0
Vh1 h1 0 dc 1.2
Vh2 h2 0 dc 1.2
Vh3 h3 0 dc 1.2
Vh4 h4 0 dc 1.2
Vh5 h5 0 dc 1.2
Vh6 h6 0 dc 1.2
Vh7 h7 0 dc 1.2
Vclk clk 0 dc 0
XT isense vref_buf clk s0 s1 s2 s3 s4 s5 s6 s7 h0 h1 h2 h3 h4 h5 h6 h7 cmp_soft cmp_hard vdd vdda 0 g1_trip
Cs cmp_soft 0 10f
Ch cmp_hard 0 10f
* keep only the nodes of interest (the full 1200-device transient exhausts the output memory)
.save v(vref_buf) i(vdda) v(xt.icmp) v(xt.vth_soft) v(xt.vth_hard) v(cmp_soft) v(cmp_hard) v(isense)
.lib /foss/pdks/ihp-sg13g2/libs.tech/ngspice/models/cornerHBT.lib hbt_typ_mismatch
.include qualification/dac-actualbgr-reset-pilot-20260922-a/bgr.spice
Vr4 r4 0 0
Xbgr vdda 0 r4 vref iptat pbias pcasc vbe dvbe g1_bgr
.global sub!
Vsub sub! 0 0
.option gmin=1e-15 abstol=1e-14 reltol=1e-5 vntol=1e-7
.option gmin=1e-15 reltol=1e-5 vntol=1e-7 abstol=1e-14
.control
set num_threads=1
set numdgt=15
setseed 51001
reset
set temp=25.0
alter Vs0 dc=0
alter Vh0 dc=0
alter Vs1 dc=0
alter Vh1 dc=0
alter Vs2 dc=0
alter Vh2 dc=0
alter Vs3 dc=0
alter Vh3 dc=0
alter Vs4 dc=0
alter Vh4 dc=0
alter Vs5 dc=0
alter Vh5 dc=0
alter Vs6 dc=0
alter Vh6 dc=0
alter Vs7 dc=0
alter Vh7 dc=0
op
echo ROW 0 25.0 0 $&v(xt.vth_soft) $&v(xt.vth_hard) $&v(vref_buf) $&v(isense) $&i(vdda)
alter Vs0 dc=1.2
alter Vh0 dc=1.2
alter Vs1 dc=1.2
alter Vh1 dc=1.2
alter Vs2 dc=1.2
alter Vh2 dc=1.2
alter Vs3 dc=1.2
alter Vh3 dc=1.2
alter Vs4 dc=1.2
alter Vh4 dc=1.2
alter Vs5 dc=1.2
alter Vh5 dc=1.2
alter Vs6 dc=1.2
alter Vh6 dc=1.2
alter Vs7 dc=0
alter Vh7 dc=0
op
echo ROW 0 25.0 127 $&v(xt.vth_soft) $&v(xt.vth_hard) $&v(vref_buf) $&v(isense) $&i(vdda)
alter Vs0 dc=1.2
alter Vh0 dc=1.2
alter Vs1 dc=1.2
alter Vh1 dc=1.2
alter Vs2 dc=1.2
alter Vh2 dc=1.2
alter Vs3 dc=1.2
alter Vh3 dc=1.2
alter Vs4 dc=1.2
alter Vh4 dc=1.2
alter Vs5 dc=1.2
alter Vh5 dc=1.2
alter Vs6 dc=1.2
alter Vh6 dc=1.2
alter Vs7 dc=1.2
alter Vh7 dc=1.2
op
echo ROW 0 25.0 255 $&v(xt.vth_soft) $&v(xt.vth_hard) $&v(vref_buf) $&v(isense) $&i(vdda)
echo FINGERPRINT 0
print @n.xt.xdacs.xms7_0a.nsg13_hv_nmos[w]
print @n.xt.xdacs.xms7_0a.nsg13_hv_nmos[l]
print @n.xt.xdacs.xms7_0a.nsg13_hv_nmos[delvto]
print @n.xt.xdacs.xms7_0a.nsg13_hv_nmos[factuo]
print @n.xt.xdach.xms7_0b.nsg13_hv_nmos[w]
print @n.xt.xdach.xms7_0b.nsg13_hv_nmos[l]
print @n.xt.xdach.xms7_0b.nsg13_hv_nmos[delvto]
print @n.xt.xdach.xms7_0b.nsg13_hv_nmos[factuo]
print @n.xt.xcs.xm1.nsg13_lv_nmos[w]
print @n.xt.xcs.xm1.nsg13_lv_nmos[l]
print @n.xt.xcs.xm1.nsg13_lv_nmos[delvto]
print @n.xt.xcs.xm1.nsg13_lv_nmos[factuo]
print @n.xt.xch.xm1.nsg13_lv_nmos[w]
print @n.xt.xch.xm1.nsg13_lv_nmos[l]
print @n.xt.xch.xm1.nsg13_lv_nmos[delvto]
print @n.xt.xch.xm1.nsg13_lv_nmos[factuo]
print @n.xs.xref.xm1.nsg13_hv_pmos[w]
print @n.xs.xref.xm1.nsg13_hv_pmos[l]
print @n.xs.xref.xm1.nsg13_hv_pmos[delvto]
print @n.xs.xref.xm1.nsg13_hv_pmos[factuo]
print @n.xt.xdacs.xru0.nr1[nsmm_rsh]
print @n.xt.xdacs.xru0.nr1[nsmm_w]
print @n.xt.xdacs.xru0.nr1[nsmm_l]
print @n.xbgr.xm34.nsg13_hv_nmos[w]
print @n.xbgr.xm34.nsg13_hv_nmos[l]
print @n.xbgr.xm34.nsg13_hv_nmos[delvto]
print @n.xbgr.xm34.nsg13_hv_nmos[factuo]
print @n.xbgr.xr16.nr1[nsmm_rsh]
print @n.xbgr.xr16.nr1[nsmm_w]
print @n.xbgr.xr16.nr1[nsmm_l]
print @q.xbgr.xq56.qnpn13g2[area]
set temp=125.0
alter Vs0 dc=0
alter Vh0 dc=0
alter Vs1 dc=0
alter Vh1 dc=0
alter Vs2 dc=0
alter Vh2 dc=0
alter Vs3 dc=0
alter Vh3 dc=0
alter Vs4 dc=0
alter Vh4 dc=0
alter Vs5 dc=0
alter Vh5 dc=0
alter Vs6 dc=0
alter Vh6 dc=0
alter Vs7 dc=0
alter Vh7 dc=0
op
echo ROW 1 125.0 0 $&v(xt.vth_soft) $&v(xt.vth_hard) $&v(vref_buf) $&v(isense) $&i(vdda)
alter Vs0 dc=1.2
alter Vh0 dc=1.2
alter Vs1 dc=1.2
alter Vh1 dc=1.2
alter Vs2 dc=1.2
alter Vh2 dc=1.2
alter Vs3 dc=1.2
alter Vh3 dc=1.2
alter Vs4 dc=1.2
alter Vh4 dc=1.2
alter Vs5 dc=1.2
alter Vh5 dc=1.2
alter Vs6 dc=1.2
alter Vh6 dc=1.2
alter Vs7 dc=0
alter Vh7 dc=0
op
echo ROW 1 125.0 127 $&v(xt.vth_soft) $&v(xt.vth_hard) $&v(vref_buf) $&v(isense) $&i(vdda)
alter Vs0 dc=1.2
alter Vh0 dc=1.2
alter Vs1 dc=1.2
alter Vh1 dc=1.2
alter Vs2 dc=1.2
alter Vh2 dc=1.2
alter Vs3 dc=1.2
alter Vh3 dc=1.2
alter Vs4 dc=1.2
alter Vh4 dc=1.2
alter Vs5 dc=1.2
alter Vh5 dc=1.2
alter Vs6 dc=1.2
alter Vh6 dc=1.2
alter Vs7 dc=1.2
alter Vh7 dc=1.2
op
echo ROW 1 125.0 255 $&v(xt.vth_soft) $&v(xt.vth_hard) $&v(vref_buf) $&v(isense) $&i(vdda)
echo FINGERPRINT 1
print @n.xt.xdacs.xms7_0a.nsg13_hv_nmos[w]
print @n.xt.xdacs.xms7_0a.nsg13_hv_nmos[l]
print @n.xt.xdacs.xms7_0a.nsg13_hv_nmos[delvto]
print @n.xt.xdacs.xms7_0a.nsg13_hv_nmos[factuo]
print @n.xt.xdach.xms7_0b.nsg13_hv_nmos[w]
print @n.xt.xdach.xms7_0b.nsg13_hv_nmos[l]
print @n.xt.xdach.xms7_0b.nsg13_hv_nmos[delvto]
print @n.xt.xdach.xms7_0b.nsg13_hv_nmos[factuo]
print @n.xt.xcs.xm1.nsg13_lv_nmos[w]
print @n.xt.xcs.xm1.nsg13_lv_nmos[l]
print @n.xt.xcs.xm1.nsg13_lv_nmos[delvto]
print @n.xt.xcs.xm1.nsg13_lv_nmos[factuo]
print @n.xt.xch.xm1.nsg13_lv_nmos[w]
print @n.xt.xch.xm1.nsg13_lv_nmos[l]
print @n.xt.xch.xm1.nsg13_lv_nmos[delvto]
print @n.xt.xch.xm1.nsg13_lv_nmos[factuo]
print @n.xs.xref.xm1.nsg13_hv_pmos[w]
print @n.xs.xref.xm1.nsg13_hv_pmos[l]
print @n.xs.xref.xm1.nsg13_hv_pmos[delvto]
print @n.xs.xref.xm1.nsg13_hv_pmos[factuo]
print @n.xt.xdacs.xru0.nr1[nsmm_rsh]
print @n.xt.xdacs.xru0.nr1[nsmm_w]
print @n.xt.xdacs.xru0.nr1[nsmm_l]
print @n.xbgr.xm34.nsg13_hv_nmos[w]
print @n.xbgr.xm34.nsg13_hv_nmos[l]
print @n.xbgr.xm34.nsg13_hv_nmos[delvto]
print @n.xbgr.xm34.nsg13_hv_nmos[factuo]
print @n.xbgr.xr16.nr1[nsmm_rsh]
print @n.xbgr.xr16.nr1[nsmm_w]
print @n.xbgr.xr16.nr1[nsmm_l]
print @q.xbgr.xq56.qnpn13g2[area]
set temp=25.0
alter Vs0 dc=0
alter Vh0 dc=0
alter Vs1 dc=0
alter Vh1 dc=0
alter Vs2 dc=0
alter Vh2 dc=0
alter Vs3 dc=0
alter Vh3 dc=0
alter Vs4 dc=0
alter Vh4 dc=0
alter Vs5 dc=0
alter Vh5 dc=0
alter Vs6 dc=0
alter Vh6 dc=0
alter Vs7 dc=0
alter Vh7 dc=0
op
echo ROW 2 25.0 0 $&v(xt.vth_soft) $&v(xt.vth_hard) $&v(vref_buf) $&v(isense) $&i(vdda)
alter Vs0 dc=1.2
alter Vh0 dc=1.2
alter Vs1 dc=1.2
alter Vh1 dc=1.2
alter Vs2 dc=1.2
alter Vh2 dc=1.2
alter Vs3 dc=1.2
alter Vh3 dc=1.2
alter Vs4 dc=1.2
alter Vh4 dc=1.2
alter Vs5 dc=1.2
alter Vh5 dc=1.2
alter Vs6 dc=1.2
alter Vh6 dc=1.2
alter Vs7 dc=0
alter Vh7 dc=0
op
echo ROW 2 25.0 127 $&v(xt.vth_soft) $&v(xt.vth_hard) $&v(vref_buf) $&v(isense) $&i(vdda)
alter Vs0 dc=1.2
alter Vh0 dc=1.2
alter Vs1 dc=1.2
alter Vh1 dc=1.2
alter Vs2 dc=1.2
alter Vh2 dc=1.2
alter Vs3 dc=1.2
alter Vh3 dc=1.2
alter Vs4 dc=1.2
alter Vh4 dc=1.2
alter Vs5 dc=1.2
alter Vh5 dc=1.2
alter Vs6 dc=1.2
alter Vh6 dc=1.2
alter Vs7 dc=1.2
alter Vh7 dc=1.2
op
echo ROW 2 25.0 255 $&v(xt.vth_soft) $&v(xt.vth_hard) $&v(vref_buf) $&v(isense) $&i(vdda)
echo FINGERPRINT 2
print @n.xt.xdacs.xms7_0a.nsg13_hv_nmos[w]
print @n.xt.xdacs.xms7_0a.nsg13_hv_nmos[l]
print @n.xt.xdacs.xms7_0a.nsg13_hv_nmos[delvto]
print @n.xt.xdacs.xms7_0a.nsg13_hv_nmos[factuo]
print @n.xt.xdach.xms7_0b.nsg13_hv_nmos[w]
print @n.xt.xdach.xms7_0b.nsg13_hv_nmos[l]
print @n.xt.xdach.xms7_0b.nsg13_hv_nmos[delvto]
print @n.xt.xdach.xms7_0b.nsg13_hv_nmos[factuo]
print @n.xt.xcs.xm1.nsg13_lv_nmos[w]
print @n.xt.xcs.xm1.nsg13_lv_nmos[l]
print @n.xt.xcs.xm1.nsg13_lv_nmos[delvto]
print @n.xt.xcs.xm1.nsg13_lv_nmos[factuo]
print @n.xt.xch.xm1.nsg13_lv_nmos[w]
print @n.xt.xch.xm1.nsg13_lv_nmos[l]
print @n.xt.xch.xm1.nsg13_lv_nmos[delvto]
print @n.xt.xch.xm1.nsg13_lv_nmos[factuo]
print @n.xs.xref.xm1.nsg13_hv_pmos[w]
print @n.xs.xref.xm1.nsg13_hv_pmos[l]
print @n.xs.xref.xm1.nsg13_hv_pmos[delvto]
print @n.xs.xref.xm1.nsg13_hv_pmos[factuo]
print @n.xt.xdacs.xru0.nr1[nsmm_rsh]
print @n.xt.xdacs.xru0.nr1[nsmm_w]
print @n.xt.xdacs.xru0.nr1[nsmm_l]
print @n.xbgr.xm34.nsg13_hv_nmos[w]
print @n.xbgr.xm34.nsg13_hv_nmos[l]
print @n.xbgr.xm34.nsg13_hv_nmos[delvto]
print @n.xbgr.xm34.nsg13_hv_nmos[factuo]
print @n.xbgr.xr16.nr1[nsmm_rsh]
print @n.xbgr.xr16.nr1[nsmm_w]
print @n.xbgr.xr16.nr1[nsmm_l]
print @q.xbgr.xq56.qnpn13g2[area]
echo QUALIFICATION_END
quit 0
.endc
.end
