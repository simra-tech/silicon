* Existing standalone revision1 comparator CC-PEX; no macro routes. Explicit per-finger mismatch flags.
.subckt g1_cmp inp inn clk q qb vdd vss
XM1 n11 inn n11 vss sg13_lv_nmos w=6u l=0.13u ng=1 m=1 mm_ok=1
XM2 vss n10 n9 vss sg13_lv_nmos w=4u l=0.13u ng=1 m=1 mm_ok=1
XM3 n11 n4 n10 vss sg13_lv_nmos w=3u l=0.13u ng=1 m=1 mm_ok=1
XM4 n4 n10 n7 vss sg13_lv_nmos w=3u l=0.13u ng=1 m=1 mm_ok=1
XM5 q qb vss vss sg13_lv_nmos w=1.5u l=0.13u ng=1 m=1 mm_ok=1
XM6 n12 inp n11 vss sg13_lv_nmos w=6u l=0.34u ng=1 m=1 mm_ok=1
XM7 n11 inp n12 vss sg13_lv_nmos w=6u l=0.34u ng=1 m=1 mm_ok=1
XM8 n12 inn n7 vss sg13_lv_nmos w=6u l=0.34u ng=1 m=1 mm_ok=1
XM9 n7 inn n12 vss sg13_lv_nmos w=6u l=0.34u ng=1 m=1 mm_ok=1
XM10 q n13 vss vss sg13_lv_nmos w=1.5u l=0.13u ng=1 m=1 mm_ok=1
XM11 vss n9 qb vss sg13_lv_nmos w=1.5u l=0.13u ng=1 m=1 mm_ok=1
XM12 n12 clk vss vss sg13_lv_nmos w=4u l=0.13u ng=1 m=1 mm_ok=1
XM13 vss clk n12 vss sg13_lv_nmos w=4u l=0.13u ng=1 m=1 mm_ok=1
XM14 n12 clk vss vss sg13_lv_nmos w=4u l=0.13u ng=1 m=1 mm_ok=1
XM15 vss clk n12 vss sg13_lv_nmos w=4u l=0.13u ng=1 m=1 mm_ok=1
XM16 vss q qb vss sg13_lv_nmos w=1.5u l=0.13u ng=1 m=1 mm_ok=1
XM17 n13 n4 vss vss sg13_lv_nmos w=4u l=0.13u ng=1 m=1 mm_ok=1
XM18 n7 inp n7 vss sg13_lv_nmos w=6u l=0.13u ng=1 m=1 mm_ok=1
XM19 n4 clk vdd vdd sg13_lv_pmos w=6u l=0.13u ng=1 m=1 mm_ok=1
XM20 vdd clk n10 vdd sg13_lv_pmos w=6u l=0.13u ng=1 m=1 mm_ok=1
XM21 q qb n16 vdd sg13_lv_pmos w=4u l=0.13u ng=1 m=1 mm_ok=1
XM22 n16 n13 vdd vdd sg13_lv_pmos w=4u l=0.13u ng=1 m=1 mm_ok=1
XM23 vdd n10 n9 vdd sg13_lv_pmos w=1u l=0.13u ng=1 m=1 mm_ok=1
XM24 n4 n10 vdd vdd sg13_lv_pmos w=3u l=0.13u ng=1 m=1 mm_ok=1
XM25 n14 q qb vdd sg13_lv_pmos w=4u l=0.13u ng=1 m=1 mm_ok=1
XM26 vdd n9 n14 vdd sg13_lv_pmos w=4u l=0.13u ng=1 m=1 mm_ok=1
XM27 vdd n4 n10 vdd sg13_lv_pmos w=3u l=0.13u ng=1 m=1 mm_ok=1
XM28 n13 n4 vdd vdd sg13_lv_pmos w=1u l=0.13u ng=1 m=1 mm_ok=1
XM29 vdd clk n11 vdd sg13_lv_pmos w=3u l=0.13u ng=1 m=1 mm_ok=1
XM30 n7 clk vdd vdd sg13_lv_pmos w=3u l=0.13u ng=1 m=1 mm_ok=1
Cext_1 n10 n11 3.77995f
Cext_2 n10 n12 1.41682a
Cext_3 n10 n13 246.275a
Cext_4 n10 n4 3.21001f
Cext_5 n10 n7 156.871a
Cext_6 n10 n9 1.54733f
Cext_7 n10 clk 844.394a
Cext_8 n10 inn 84.1503a
Cext_9 n10 inp 58.6254a
Cext_10 n10 q 103.289a
Cext_11 n10 qb 3.15405f
Cext_12 n10 vdd 1.17983f
Cext_13 n10 vss 611.073a
Cext_14 n10 vss 3.14604f
Cext_15 n11 n12 729.113a
Cext_16 n11 n13 0.220836a
Cext_17 n11 n4 156.649a
Cext_18 n11 n7 2.00043f
Cext_19 n11 n9 0.477749a
Cext_20 n11 clk 2.6857f
Cext_21 n11 inn 192.99a
Cext_22 n11 inp 252.45a
Cext_23 n11 q 91.3942a
Cext_24 n11 qb 106.183a
Cext_25 n11 vdd 449.032a
Cext_26 n11 vss 131.656a
Cext_27 n11 vss 1.85431f
Cext_28 n12 n4 0.395782a
Cext_29 n12 n7 728.871a
Cext_30 n12 clk 328.154a
Cext_31 n12 inn 252.281a
Cext_32 n12 inp 252.281a
Cext_33 n12 qb 139.89a
Cext_34 n12 vdd 0.809057a
Cext_35 n12 vss 1.61127f
Cext_36 n12 vss 639.177a
Cext_37 n13 n16 56.8023a
Cext_38 n13 n4 1.54816f
Cext_39 n13 n7 0.477749a
Cext_40 n13 clk 2.71185a
Cext_41 n13 inn 38.5686a
Cext_42 n13 q 2.20678f
Cext_43 n13 qb 125.516a
Cext_44 n13 vdd 169.075a
Cext_45 n13 vss 657.36a
Cext_46 n13 vss 1.52267f
Cext_47 n14 n9 56.8023a
Cext_48 n14 q 47.3027a
Cext_49 n14 qb 444.833a
Cext_50 n14 vdd 526.91a
Cext_51 n14 vss 5.77687a
Cext_52 n14 vss 303.611a
Cext_53 n16 q 447.573a
Cext_54 n16 qb 44.9322a
Cext_55 n16 vdd 526.91a
Cext_56 n16 vss 5.77687a
Cext_57 n16 vss 303.389a
Cext_58 n4 n7 3.7799f
Cext_59 n4 n9 246.275a
Cext_60 n4 clk 818.154a
Cext_61 n4 inn 56.9153a
Cext_62 n4 inp 83.7926a
Cext_63 n4 q 3.15872f
Cext_64 n4 qb 98.6693a
Cext_65 n4 vdd 1.17998f
Cext_66 n4 vss 611.073a
Cext_67 n4 vss 3.14031f
Cext_68 n7 n9 0.220836a
Cext_69 n7 clk 2.65961f
Cext_70 n7 inn 252.313a
Cext_71 n7 inp 191.795a
Cext_72 n7 q 93.7882a
Cext_73 n7 qb 103.7a
Cext_74 n7 vdd 449.319a
Cext_75 n7 vss 131.521a
Cext_76 n7 vss 1.85427f
Cext_77 n9 clk 2.71185a
Cext_78 n9 inp 38.4879a
Cext_79 n9 q 611.384a
Cext_80 n9 qb 1.71865f
Cext_81 n9 vdd 169.075a
Cext_82 n9 vss 657.36a
Cext_83 n9 vss 1.52272f
Cext_84 clk inn 147.301a
Cext_85 clk inp 147.301a
Cext_86 clk q 122.062a
Cext_87 clk qb 111.369a
Cext_88 clk vdd 309.641a
Cext_89 clk vss 543.797a
Cext_90 inn inp 9.13663a
Cext_91 inn q 14.1894a
Cext_92 inn qb 99.9954a
Cext_93 inn vss 285.446a
Cext_94 inp q 36.5193a
Cext_95 inp qb 92.6249a
Cext_96 inp vss 285.042a
Cext_97 q qb 3.18755f
Cext_98 q vdd 26.079a
Cext_99 q vss 668.308a
Cext_100 qb vdd 3.80895a
Cext_101 qb vss 672.159a
Cext_102 vdd vss 803.932a
Cext_103 vss clk 5.45277f
Cext_104 vss inn 2.63413f
Cext_105 vss inp 2.63052f
Cext_106 vss q 3.05852f
Cext_107 vss qb 3.06249f
Cext_108 vss vdd 4.66908f
Cext_109 vss vss 9.76962f
.ends
