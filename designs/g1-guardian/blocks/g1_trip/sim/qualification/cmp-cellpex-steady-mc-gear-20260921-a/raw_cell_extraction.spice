*********************************************************
*** NGSPICE file created by KLayout-PEX 0.3.12
*** -----------------------------------------------------
***     Extraction Engine: KPEX/2.5D
***     Technology: ihp_sg13g2
***     Date: 2026-09-19 10:57:52
*********************************************************

.SUBCKT g1_cmp clk inn inp q qb vdd vss
M$1 \$11 inn \$11 vss sg13_lv_nmos L=0.13U W=6U AS=2.04P AD=2.04P PS=12.68U
+ PD=12.68U rfmode=0
M$2 vss \$10 \$9 vss sg13_lv_nmos L=0.13U W=4U AS=1.36P AD=1.36P PS=8.68U
+ PD=8.68U rfmode=0
M$3 \$11 \$4 \$10 vss sg13_lv_nmos L=0.13U W=3U AS=1.02P AD=1.02P PS=6.68U
+ PD=6.68U rfmode=0
M$4 \$4 \$10 \$7 vss sg13_lv_nmos L=0.13U W=3U AS=1.02P AD=1.02P PS=6.68U
+ PD=6.68U rfmode=0
M$5 q qb vss vss sg13_lv_nmos L=0.13U W=1.5U AS=0.51P AD=0.51P PS=3.68U
+ PD=3.68U rfmode=0
M$6 \$12 inp \$11 vss sg13_lv_nmos L=0.34U W=6U AS=2.04P AD=1.14P PS=12.68U
+ PD=6.38U rfmode=0
M$7 \$11 inp \$12 vss sg13_lv_nmos L=0.34U W=6U AS=1.14P AD=2.04P PS=6.38U
+ PD=12.68U rfmode=0
M$8 \$12 inn \$7 vss sg13_lv_nmos L=0.34U W=6U AS=2.04P AD=1.14P PS=12.68U
+ PD=6.38U rfmode=0
M$9 \$7 inn \$12 vss sg13_lv_nmos L=0.34U W=6U AS=1.14P AD=2.04P PS=6.38U
+ PD=12.68U rfmode=0
M$10 q \$13 vss vss sg13_lv_nmos L=0.13U W=1.5U AS=0.51P AD=0.51P PS=3.68U
+ PD=3.68U rfmode=0
M$11 vss \$9 qb vss sg13_lv_nmos L=0.13U W=1.5U AS=0.51P AD=0.51P PS=3.68U
+ PD=3.68U rfmode=0
M$12 \$12 clk vss vss sg13_lv_nmos L=0.13U W=4U AS=1.36P AD=0.76P PS=8.68U
+ PD=4.38U rfmode=0
M$13 vss clk \$12 vss sg13_lv_nmos L=0.13U W=4U AS=0.76P AD=0.76P PS=4.38U
+ PD=4.38U rfmode=0
M$14 \$12 clk vss vss sg13_lv_nmos L=0.13U W=4U AS=0.76P AD=0.76P PS=4.38U
+ PD=4.38U rfmode=0
M$15 vss clk \$12 vss sg13_lv_nmos L=0.13U W=4U AS=0.76P AD=1.36P PS=4.38U
+ PD=8.68U rfmode=0
M$16 vss q qb vss sg13_lv_nmos L=0.13U W=1.5U AS=0.51P AD=0.51P PS=3.68U
+ PD=3.68U rfmode=0
M$17 \$13 \$4 vss vss sg13_lv_nmos L=0.13U W=4U AS=1.36P AD=1.36P PS=8.68U
+ PD=8.68U rfmode=0
M$18 \$7 inp \$7 vss sg13_lv_nmos L=0.13U W=6U AS=2.04P AD=2.04P PS=12.68U
+ PD=12.68U rfmode=0
M$19 \$4 clk vdd vdd sg13_lv_pmos L=0.13U W=6U AS=2.04P AD=2.04P PS=12.68U
+ PD=12.68U rfmode=0
M$20 vdd clk \$10 vdd sg13_lv_pmos L=0.13U W=6U AS=2.04P AD=2.04P PS=12.68U
+ PD=12.68U rfmode=0
M$21 q qb \$16 vdd sg13_lv_pmos L=0.13U W=4U AS=1.36P AD=1.36P PS=8.68U
+ PD=8.68U rfmode=0
M$22 \$16 \$13 vdd vdd sg13_lv_pmos L=0.13U W=4U AS=1.36P AD=1.36P PS=8.68U
+ PD=8.68U rfmode=0
M$23 vdd \$10 \$9 vdd sg13_lv_pmos L=0.13U W=1U AS=0.34P AD=0.34P PS=2.68U
+ PD=2.68U rfmode=0
M$24 \$4 \$10 vdd vdd sg13_lv_pmos L=0.13U W=3U AS=1.02P AD=1.02P PS=6.68U
+ PD=6.68U rfmode=0
M$25 \$14 q qb vdd sg13_lv_pmos L=0.13U W=4U AS=1.36P AD=1.36P PS=8.68U
+ PD=8.68U rfmode=0
M$26 vdd \$9 \$14 vdd sg13_lv_pmos L=0.13U W=4U AS=1.36P AD=1.36P PS=8.68U
+ PD=8.68U rfmode=0
M$27 vdd \$4 \$10 vdd sg13_lv_pmos L=0.13U W=3U AS=1.02P AD=1.02P PS=6.68U
+ PD=6.68U rfmode=0
M$28 \$13 \$4 vdd vdd sg13_lv_pmos L=0.13U W=1U AS=0.34P AD=0.34P PS=2.68U
+ PD=2.68U rfmode=0
M$29 vdd clk \$11 vdd sg13_lv_pmos L=0.13U W=3U AS=1.02P AD=1.02P PS=6.68U
+ PD=6.68U rfmode=0
M$30 \$7 clk vdd vdd sg13_lv_pmos L=0.13U W=3U AS=1.02P AD=1.02P PS=6.68U
+ PD=6.68U rfmode=0
Cext_1 \$10 \$11 3.77995f
Cext_2 \$10 \$12 1.41682a
Cext_3 \$10 \$13 246.275a
Cext_4 \$10 \$4 3.21001f
Cext_5 \$10 \$7 156.871a
Cext_6 \$10 \$9 1.54733f
Cext_7 \$10 clk 844.394a
Cext_8 \$10 inn 84.1503a
Cext_9 \$10 inp 58.6254a
Cext_10 \$10 q 103.289a
Cext_11 \$10 qb 3.15405f
Cext_12 \$10 vdd 1.17983f
Cext_13 \$10 vss 611.073a
Cext_14 \$10 VSUBS 3.14604f
Cext_15 \$11 \$12 729.113a
Cext_16 \$11 \$13 0.220836a
Cext_17 \$11 \$4 156.649a
Cext_18 \$11 \$7 2.00043f
Cext_19 \$11 \$9 0.477749a
Cext_20 \$11 clk 2.6857f
Cext_21 \$11 inn 192.99a
Cext_22 \$11 inp 252.45a
Cext_23 \$11 q 91.3942a
Cext_24 \$11 qb 106.183a
Cext_25 \$11 vdd 449.032a
Cext_26 \$11 vss 131.656a
Cext_27 \$11 VSUBS 1.85431f
Cext_28 \$12 \$4 0.395782a
Cext_29 \$12 \$7 728.871a
Cext_30 \$12 clk 328.154a
Cext_31 \$12 inn 252.281a
Cext_32 \$12 inp 252.281a
Cext_33 \$12 qb 139.89a
Cext_34 \$12 vdd 0.809057a
Cext_35 \$12 vss 1.61127f
Cext_36 \$12 VSUBS 639.177a
Cext_37 \$13 \$16 56.8023a
Cext_38 \$13 \$4 1.54816f
Cext_39 \$13 \$7 0.477749a
Cext_40 \$13 clk 2.71185a
Cext_41 \$13 inn 38.5686a
Cext_42 \$13 q 2.20678f
Cext_43 \$13 qb 125.516a
Cext_44 \$13 vdd 169.075a
Cext_45 \$13 vss 657.36a
Cext_46 \$13 VSUBS 1.52267f
Cext_47 \$14 \$9 56.8023a
Cext_48 \$14 q 47.3027a
Cext_49 \$14 qb 444.833a
Cext_50 \$14 vdd 526.91a
Cext_51 \$14 vss 5.77687a
Cext_52 \$14 VSUBS 303.611a
Cext_53 \$16 q 447.573a
Cext_54 \$16 qb 44.9322a
Cext_55 \$16 vdd 526.91a
Cext_56 \$16 vss 5.77687a
Cext_57 \$16 VSUBS 303.389a
Cext_58 \$4 \$7 3.7799f
Cext_59 \$4 \$9 246.275a
Cext_60 \$4 clk 818.154a
Cext_61 \$4 inn 56.9153a
Cext_62 \$4 inp 83.7926a
Cext_63 \$4 q 3.15872f
Cext_64 \$4 qb 98.6693a
Cext_65 \$4 vdd 1.17998f
Cext_66 \$4 vss 611.073a
Cext_67 \$4 VSUBS 3.14031f
Cext_68 \$7 \$9 0.220836a
Cext_69 \$7 clk 2.65961f
Cext_70 \$7 inn 252.313a
Cext_71 \$7 inp 191.795a
Cext_72 \$7 q 93.7882a
Cext_73 \$7 qb 103.7a
Cext_74 \$7 vdd 449.319a
Cext_75 \$7 vss 131.521a
Cext_76 \$7 VSUBS 1.85427f
Cext_77 \$9 clk 2.71185a
Cext_78 \$9 inp 38.4879a
Cext_79 \$9 q 611.384a
Cext_80 \$9 qb 1.71865f
Cext_81 \$9 vdd 169.075a
Cext_82 \$9 vss 657.36a
Cext_83 \$9 VSUBS 1.52272f
Cext_84 clk inn 147.301a
Cext_85 clk inp 147.301a
Cext_86 clk q 122.062a
Cext_87 clk qb 111.369a
Cext_88 clk vdd 309.641a
Cext_89 clk vss 543.797a
Cext_90 inn inp 9.13663a
Cext_91 inn q 14.1894a
Cext_92 inn qb 99.9954a
Cext_93 inn vss 285.446a
Cext_94 inp q 36.5193a
Cext_95 inp qb 92.6249a
Cext_96 inp vss 285.042a
Cext_97 q qb 3.18755f
Cext_98 q vdd 26.079a
Cext_99 q vss 668.308a
Cext_100 qb vdd 3.80895a
Cext_101 qb vss 672.159a
Cext_102 vdd vss 803.932a
Cext_103 VSUBS clk 5.45277f
Cext_104 VSUBS inn 2.63413f
Cext_105 VSUBS inp 2.63052f
Cext_106 VSUBS q 3.05852f
Cext_107 VSUBS qb 3.06249f
Cext_108 VSUBS vdd 4.66908f
Cext_109 VSUBS vss 9.76962f
.ENDS g1_cmp
