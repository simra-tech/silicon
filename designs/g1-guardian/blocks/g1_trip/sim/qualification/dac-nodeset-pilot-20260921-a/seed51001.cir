* G1_TRIP kickback: real source (G1_SENSE output through the conditioning divider) and real DAC tap,
* both comparators clocked (soft on cmp_clk, hard on its inverse), 10 MHz. Soft threshold code 153
* (30.0 mV shunt), shunt input set .025 so the soft comparator sits at/near its threshold.
.param VDDA=3.3 VDD=1.2 VREF=1.04
.lib /foss/pdks/ihp-sg13g2/libs.tech/ngspice/models/cornerMOSlv.lib mos_tt_mismatch
.lib /foss/pdks/ihp-sg13g2/libs.tech/ngspice/models/cornerMOShv.lib mos_tt_mismatch
.lib /foss/pdks/ihp-sg13g2/libs.tech/ngspice/models/cornerRES.lib res_typ_mismatch
.lib /foss/pdks/ihp-sg13g2/libs.tech/ngspice/models/cornerCAP.lib cap_typ
.temp 25
* the off switches leave the mux tree nodes floating at DC: give the solver a 1 TOhm path per node
.option rshunt=1e12 gmin=1e-13
.include qualification/dac-nodeset-pilot-20260921-a/sense.spice
.include qualification/dac-nodeset-pilot-20260921-a/trip.spice
Vdda vdda 0 dc {VDDA}
Vdd vdd 0 dc {VDD}
Vref vref 0 dc {VREF}
Iib vdda iptat dc 4.13u
Vsh shp 0 dc .025
XS shp 0 vref iptat isense vped vref_buf vdda 0 g1_sense
CL isense 0 300f
* soft code 153 = 1001 1001b (30.0 mV) ; hard code 254 = 1111 1110b (49.8 mV)
Bs0 s0 0 V=1.2*(floor((v(code)+0.1)/1)-2*floor((v(code)+0.1)/2))
Bs1 s1 0 V=1.2*(floor((v(code)+0.1)/2)-2*floor((v(code)+0.1)/4))
Bs2 s2 0 V=1.2*(floor((v(code)+0.1)/4)-2*floor((v(code)+0.1)/8))
Bs3 s3 0 V=1.2*(floor((v(code)+0.1)/8)-2*floor((v(code)+0.1)/16))
Bs4 s4 0 V=1.2*(floor((v(code)+0.1)/16)-2*floor((v(code)+0.1)/32))
Bs5 s5 0 V=1.2*(floor((v(code)+0.1)/32)-2*floor((v(code)+0.1)/64))
Bs6 s6 0 V=1.2*(floor((v(code)+0.1)/64)-2*floor((v(code)+0.1)/128))
Bs7 s7 0 V=1.2*(floor((v(code)+0.1)/128)-2*floor((v(code)+0.1)/256))
Bh0 h0 0 V=1.2*(floor((v(code)+0.1)/1)-2*floor((v(code)+0.1)/2))
Bh1 h1 0 V=1.2*(floor((v(code)+0.1)/2)-2*floor((v(code)+0.1)/4))
Bh2 h2 0 V=1.2*(floor((v(code)+0.1)/4)-2*floor((v(code)+0.1)/8))
Bh3 h3 0 V=1.2*(floor((v(code)+0.1)/8)-2*floor((v(code)+0.1)/16))
Bh4 h4 0 V=1.2*(floor((v(code)+0.1)/16)-2*floor((v(code)+0.1)/32))
Bh5 h5 0 V=1.2*(floor((v(code)+0.1)/32)-2*floor((v(code)+0.1)/64))
Bh6 h6 0 V=1.2*(floor((v(code)+0.1)/64)-2*floor((v(code)+0.1)/128))
Bh7 h7 0 V=1.2*(floor((v(code)+0.1)/128)-2*floor((v(code)+0.1)/256))
Vclk clk 0 dc 0
XT isense vref_buf clk s0 s1 s2 s3 s4 s5 s6 s7 h0 h1 h2 h3 h4 h5 h6 h7 cmp_soft cmp_hard vdd vdda 0 g1_trip
Cs cmp_soft 0 10f
Ch cmp_hard 0 10f
* keep only the nodes of interest (the full 1200-device transient exhausts the output memory)
.save v(vref_buf) i(vdda) v(xt.icmp) v(xt.vth_soft) v(xt.vth_hard) v(cmp_soft) v(cmp_hard) v(isense)
.nodeset v(vref_buf)={VREF} v(vped)=1.000755 v(isense)=1.000755 v(xs.vp)=0.047 v(xs.vn)=0.047 v(xs.iptat)=0.76
+ v(xs.xref.out1)={VDDA-0.79} v(xs.xbuf.out1)={VDDA-0.79} v(xs.xota.out1)={VDDA-0.79} v(xs.xref.mir)={VDDA-0.79} v(xs.xbuf.mir)={VDDA-0.79} v(xs.xota.mir)={VDDA-0.79}
+ v(xs.xref.tail)=1.65 v(xs.xbuf.tail)=1.65 v(xs.xota.tail)=1.6 v(xs.xref.fn)=0.2 v(xs.xref.fp)=0.2 v(xs.xbuf.fn)=0.2 v(xs.xbuf.fp)=0.2 v(xs.xota.fn)=0.2 v(xs.xota.fp)=0.2
.option itl1=400 itl2=200
Vcode code 0 0
.nodeset v(xt.xdacs.s0)=0.0019622641509434
.nodeset v(xt.xdacs.s1)=0.00392452830188679
.nodeset v(xt.xdacs.s2)=0.00588679245283019
.nodeset v(xt.xdacs.s3)=0.00784905660377359
.nodeset v(xt.xdacs.s4)=0.00981132075471698
.nodeset v(xt.xdacs.s5)=0.0117735849056604
.nodeset v(xt.xdacs.s6)=0.0137358490566038
.nodeset v(xt.xdacs.s7)=0.0156981132075472
.nodeset v(xt.xdacs.s8)=0.0176603773584906
.nodeset v(xt.xdacs.s9)=0.019622641509434
.nodeset v(xt.xdacs.s10)=0.0215849056603774
.nodeset v(xt.xdacs.s11)=0.0235471698113208
.nodeset v(xt.xdacs.s12)=0.0255094339622642
.nodeset v(xt.xdacs.s13)=0.0274716981132075
.nodeset v(xt.xdacs.s14)=0.0294339622641509
.nodeset v(xt.xdacs.s15)=0.0313962264150943
.nodeset v(xt.xdacs.s16)=0.0333584905660377
.nodeset v(xt.xdacs.s17)=0.0353207547169811
.nodeset v(xt.xdacs.s18)=0.0372830188679245
.nodeset v(xt.xdacs.s19)=0.0392452830188679
.nodeset v(xt.xdacs.s20)=0.0412075471698113
.nodeset v(xt.xdacs.s21)=0.0431698113207547
.nodeset v(xt.xdacs.s22)=0.0451320754716981
.nodeset v(xt.xdacs.s23)=0.0470943396226415
.nodeset v(xt.xdacs.s24)=0.0490566037735849
.nodeset v(xt.xdacs.s25)=0.0510188679245283
.nodeset v(xt.xdacs.s26)=0.0529811320754717
.nodeset v(xt.xdacs.s27)=0.0549433962264151
.nodeset v(xt.xdacs.s28)=0.0569056603773585
.nodeset v(xt.xdacs.s29)=0.0588679245283019
.nodeset v(xt.xdacs.s30)=0.0608301886792453
.nodeset v(xt.xdacs.s31)=0.0627924528301887
.nodeset v(xt.xdacs.s32)=0.0647547169811321
.nodeset v(xt.xdacs.s33)=0.0667169811320755
.nodeset v(xt.xdacs.s34)=0.0686792452830189
.nodeset v(xt.xdacs.s35)=0.0706415094339623
.nodeset v(xt.xdacs.s36)=0.0726037735849057
.nodeset v(xt.xdacs.s37)=0.0745660377358491
.nodeset v(xt.xdacs.s38)=0.0765283018867925
.nodeset v(xt.xdacs.s39)=0.0784905660377359
.nodeset v(xt.xdacs.s40)=0.0804528301886792
.nodeset v(xt.xdacs.s41)=0.0824150943396226
.nodeset v(xt.xdacs.s42)=0.084377358490566
.nodeset v(xt.xdacs.s43)=0.0863396226415094
.nodeset v(xt.xdacs.s44)=0.0883018867924528
.nodeset v(xt.xdacs.s45)=0.0902641509433962
.nodeset v(xt.xdacs.s46)=0.0922264150943396
.nodeset v(xt.xdacs.s47)=0.094188679245283
.nodeset v(xt.xdacs.s48)=0.0961509433962264
.nodeset v(xt.xdacs.s49)=0.0981132075471698
.nodeset v(xt.xdacs.s50)=0.100075471698113
.nodeset v(xt.xdacs.s51)=0.102037735849057
.nodeset v(xt.xdacs.s52)=0.104
.nodeset v(xt.xdacs.s53)=0.105962264150943
.nodeset v(xt.xdacs.s54)=0.107924528301887
.nodeset v(xt.xdacs.s55)=0.10988679245283
.nodeset v(xt.xdacs.s56)=0.111849056603774
.nodeset v(xt.xdacs.s57)=0.113811320754717
.nodeset v(xt.xdacs.s58)=0.11577358490566
.nodeset v(xt.xdacs.s59)=0.117735849056604
.nodeset v(xt.xdacs.s60)=0.119698113207547
.nodeset v(xt.xdacs.s61)=0.121660377358491
.nodeset v(xt.xdacs.s62)=0.123622641509434
.nodeset v(xt.xdacs.s63)=0.125584905660377
.nodeset v(xt.xdacs.s64)=0.127547169811321
.nodeset v(xt.xdacs.s65)=0.129509433962264
.nodeset v(xt.xdacs.s66)=0.131471698113208
.nodeset v(xt.xdacs.s67)=0.133433962264151
.nodeset v(xt.xdacs.s68)=0.135396226415094
.nodeset v(xt.xdacs.s69)=0.137358490566038
.nodeset v(xt.xdacs.s70)=0.139320754716981
.nodeset v(xt.xdacs.s71)=0.141283018867925
.nodeset v(xt.xdacs.s72)=0.143245283018868
.nodeset v(xt.xdacs.s73)=0.145207547169811
.nodeset v(xt.xdacs.s74)=0.147169811320755
.nodeset v(xt.xdacs.s75)=0.149132075471698
.nodeset v(xt.xdacs.s76)=0.151094339622642
.nodeset v(xt.xdacs.s77)=0.153056603773585
.nodeset v(xt.xdacs.s78)=0.155018867924528
.nodeset v(xt.xdacs.s79)=0.156981132075472
.nodeset v(xt.xdacs.s80)=0.158943396226415
.nodeset v(xt.xdacs.s81)=0.160905660377358
.nodeset v(xt.xdacs.s82)=0.162867924528302
.nodeset v(xt.xdacs.s83)=0.164830188679245
.nodeset v(xt.xdacs.s84)=0.166792452830189
.nodeset v(xt.xdacs.s85)=0.168754716981132
.nodeset v(xt.xdacs.s86)=0.170716981132075
.nodeset v(xt.xdacs.s87)=0.172679245283019
.nodeset v(xt.xdacs.s88)=0.174641509433962
.nodeset v(xt.xdacs.s89)=0.176603773584906
.nodeset v(xt.xdacs.s90)=0.178566037735849
.nodeset v(xt.xdacs.s91)=0.180528301886792
.nodeset v(xt.xdacs.s92)=0.182490566037736
.nodeset v(xt.xdacs.s93)=0.184452830188679
.nodeset v(xt.xdacs.s94)=0.186415094339623
.nodeset v(xt.xdacs.s95)=0.188377358490566
.nodeset v(xt.xdacs.s96)=0.190339622641509
.nodeset v(xt.xdacs.s97)=0.192301886792453
.nodeset v(xt.xdacs.s98)=0.194264150943396
.nodeset v(xt.xdacs.s99)=0.19622641509434
.nodeset v(xt.xdacs.s100)=0.198188679245283
.nodeset v(xt.xdacs.s101)=0.200150943396226
.nodeset v(xt.xdacs.s102)=0.20211320754717
.nodeset v(xt.xdacs.s103)=0.204075471698113
.nodeset v(xt.xdacs.s104)=0.206037735849057
.nodeset v(xt.xdacs.s105)=0.208
.nodeset v(xt.xdacs.s106)=0.209962264150943
.nodeset v(xt.xdacs.s107)=0.211924528301887
.nodeset v(xt.xdacs.s108)=0.21388679245283
.nodeset v(xt.xdacs.s109)=0.215849056603774
.nodeset v(xt.xdacs.s110)=0.217811320754717
.nodeset v(xt.xdacs.s111)=0.21977358490566
.nodeset v(xt.xdacs.s112)=0.221735849056604
.nodeset v(xt.xdacs.s113)=0.223698113207547
.nodeset v(xt.xdacs.s114)=0.225660377358491
.nodeset v(xt.xdacs.s115)=0.227622641509434
.nodeset v(xt.xdacs.s116)=0.229584905660377
.nodeset v(xt.xdacs.s117)=0.231547169811321
.nodeset v(xt.xdacs.s118)=0.233509433962264
.nodeset v(xt.xdacs.s119)=0.235471698113208
.nodeset v(xt.xdacs.s120)=0.237433962264151
.nodeset v(xt.xdacs.s121)=0.239396226415094
.nodeset v(xt.xdacs.s122)=0.241358490566038
.nodeset v(xt.xdacs.s123)=0.243320754716981
.nodeset v(xt.xdacs.s124)=0.245283018867925
.nodeset v(xt.xdacs.s125)=0.247245283018868
.nodeset v(xt.xdacs.s126)=0.249207547169811
.nodeset v(xt.xdacs.s127)=0.251169811320755
.nodeset v(xt.xdacs.s128)=0.253132075471698
.nodeset v(xt.xdacs.s129)=0.255094339622642
.nodeset v(xt.xdacs.s130)=0.257056603773585
.nodeset v(xt.xdacs.s131)=0.259018867924528
.nodeset v(xt.xdacs.s132)=0.260981132075472
.nodeset v(xt.xdacs.s133)=0.262943396226415
.nodeset v(xt.xdacs.s134)=0.264905660377359
.nodeset v(xt.xdacs.s135)=0.266867924528302
.nodeset v(xt.xdacs.s136)=0.268830188679245
.nodeset v(xt.xdacs.s137)=0.270792452830189
.nodeset v(xt.xdacs.s138)=0.272754716981132
.nodeset v(xt.xdacs.s139)=0.274716981132075
.nodeset v(xt.xdacs.s140)=0.276679245283019
.nodeset v(xt.xdacs.s141)=0.278641509433962
.nodeset v(xt.xdacs.s142)=0.280603773584906
.nodeset v(xt.xdacs.s143)=0.282566037735849
.nodeset v(xt.xdacs.s144)=0.284528301886792
.nodeset v(xt.xdacs.s145)=0.286490566037736
.nodeset v(xt.xdacs.s146)=0.288452830188679
.nodeset v(xt.xdacs.s147)=0.290415094339623
.nodeset v(xt.xdacs.s148)=0.292377358490566
.nodeset v(xt.xdacs.s149)=0.294339622641509
.nodeset v(xt.xdacs.s150)=0.296301886792453
.nodeset v(xt.xdacs.s151)=0.298264150943396
.nodeset v(xt.xdacs.s152)=0.30022641509434
.nodeset v(xt.xdacs.s153)=0.302188679245283
.nodeset v(xt.xdacs.s154)=0.304150943396226
.nodeset v(xt.xdacs.s155)=0.30611320754717
.nodeset v(xt.xdacs.s156)=0.308075471698113
.nodeset v(xt.xdacs.s157)=0.310037735849057
.nodeset v(xt.xdacs.s158)=0.312
.nodeset v(xt.xdacs.s159)=0.313962264150943
.nodeset v(xt.xdacs.s160)=0.315924528301887
.nodeset v(xt.xdacs.s161)=0.31788679245283
.nodeset v(xt.xdacs.s162)=0.319849056603774
.nodeset v(xt.xdacs.s163)=0.321811320754717
.nodeset v(xt.xdacs.s164)=0.32377358490566
.nodeset v(xt.xdacs.s165)=0.325735849056604
.nodeset v(xt.xdacs.s166)=0.327698113207547
.nodeset v(xt.xdacs.s167)=0.329660377358491
.nodeset v(xt.xdacs.s168)=0.331622641509434
.nodeset v(xt.xdacs.s169)=0.333584905660377
.nodeset v(xt.xdacs.s170)=0.335547169811321
.nodeset v(xt.xdacs.s171)=0.337509433962264
.nodeset v(xt.xdacs.s172)=0.339471698113208
.nodeset v(xt.xdacs.s173)=0.341433962264151
.nodeset v(xt.xdacs.s174)=0.343396226415094
.nodeset v(xt.xdacs.s175)=0.345358490566038
.nodeset v(xt.xdacs.s176)=0.347320754716981
.nodeset v(xt.xdacs.s177)=0.349283018867925
.nodeset v(xt.xdacs.s178)=0.351245283018868
.nodeset v(xt.xdacs.s179)=0.353207547169811
.nodeset v(xt.xdacs.s180)=0.355169811320755
.nodeset v(xt.xdacs.s181)=0.357132075471698
.nodeset v(xt.xdacs.s182)=0.359094339622641
.nodeset v(xt.xdacs.s183)=0.361056603773585
.nodeset v(xt.xdacs.s184)=0.363018867924528
.nodeset v(xt.xdacs.s185)=0.364981132075472
.nodeset v(xt.xdacs.s186)=0.366943396226415
.nodeset v(xt.xdacs.s187)=0.368905660377359
.nodeset v(xt.xdacs.s188)=0.370867924528302
.nodeset v(xt.xdacs.s189)=0.372830188679245
.nodeset v(xt.xdacs.s190)=0.374792452830189
.nodeset v(xt.xdacs.s191)=0.376754716981132
.nodeset v(xt.xdacs.s192)=0.378716981132075
.nodeset v(xt.xdacs.s193)=0.380679245283019
.nodeset v(xt.xdacs.s194)=0.382641509433962
.nodeset v(xt.xdacs.s195)=0.384603773584906
.nodeset v(xt.xdacs.s196)=0.386566037735849
.nodeset v(xt.xdacs.s197)=0.388528301886792
.nodeset v(xt.xdacs.s198)=0.390490566037736
.nodeset v(xt.xdacs.s199)=0.392452830188679
.nodeset v(xt.xdacs.s200)=0.394415094339623
.nodeset v(xt.xdacs.s201)=0.396377358490566
.nodeset v(xt.xdacs.s202)=0.398339622641509
.nodeset v(xt.xdacs.s203)=0.400301886792453
.nodeset v(xt.xdacs.s204)=0.402264150943396
.nodeset v(xt.xdacs.s205)=0.40422641509434
.nodeset v(xt.xdacs.s206)=0.406188679245283
.nodeset v(xt.xdacs.s207)=0.408150943396226
.nodeset v(xt.xdacs.s208)=0.41011320754717
.nodeset v(xt.xdacs.s209)=0.412075471698113
.nodeset v(xt.xdacs.s210)=0.414037735849057
.nodeset v(xt.xdacs.s211)=0.416
.nodeset v(xt.xdacs.s212)=0.417962264150943
.nodeset v(xt.xdacs.s213)=0.419924528301887
.nodeset v(xt.xdacs.s214)=0.42188679245283
.nodeset v(xt.xdacs.s215)=0.423849056603774
.nodeset v(xt.xdacs.s216)=0.425811320754717
.nodeset v(xt.xdacs.s217)=0.42777358490566
.nodeset v(xt.xdacs.s218)=0.429735849056604
.nodeset v(xt.xdacs.s219)=0.431698113207547
.nodeset v(xt.xdacs.s220)=0.433660377358491
.nodeset v(xt.xdacs.s221)=0.435622641509434
.nodeset v(xt.xdacs.s222)=0.437584905660377
.nodeset v(xt.xdacs.s223)=0.439547169811321
.nodeset v(xt.xdacs.s224)=0.441509433962264
.nodeset v(xt.xdacs.s225)=0.443471698113208
.nodeset v(xt.xdacs.s226)=0.445433962264151
.nodeset v(xt.xdacs.s227)=0.447396226415094
.nodeset v(xt.xdacs.s228)=0.449358490566038
.nodeset v(xt.xdacs.s229)=0.451320754716981
.nodeset v(xt.xdacs.s230)=0.453283018867925
.nodeset v(xt.xdacs.s231)=0.455245283018868
.nodeset v(xt.xdacs.s232)=0.457207547169811
.nodeset v(xt.xdacs.s233)=0.459169811320755
.nodeset v(xt.xdacs.s234)=0.461132075471698
.nodeset v(xt.xdacs.s235)=0.463094339622642
.nodeset v(xt.xdacs.s236)=0.465056603773585
.nodeset v(xt.xdacs.s237)=0.467018867924528
.nodeset v(xt.xdacs.s238)=0.468981132075472
.nodeset v(xt.xdacs.s239)=0.470943396226415
.nodeset v(xt.xdacs.s240)=0.472905660377359
.nodeset v(xt.xdacs.s241)=0.474867924528302
.nodeset v(xt.xdacs.s242)=0.476830188679245
.nodeset v(xt.xdacs.s243)=0.478792452830189
.nodeset v(xt.xdacs.s244)=0.480754716981132
.nodeset v(xt.xdacs.s245)=0.482716981132075
.nodeset v(xt.xdacs.s246)=0.484679245283019
.nodeset v(xt.xdacs.s247)=0.486641509433962
.nodeset v(xt.xdacs.s248)=0.488603773584906
.nodeset v(xt.xdacs.s249)=0.490566037735849
.nodeset v(xt.xdacs.s250)=0.492528301886792
.nodeset v(xt.xdacs.s251)=0.494490566037736
.nodeset v(xt.xdacs.s252)=0.496452830188679
.nodeset v(xt.xdacs.s253)=0.498415094339623
.nodeset v(xt.xdacs.s254)=0.500377358490566
.nodeset v(xt.xdacs.s255)=0.502339622641509
.nodeset v(xt.xdacs.s256)=0.504301886792453
.nodeset v(xt.xdacs.s257)=0.506264150943396
.nodeset v(xt.xdacs.s258)=0.50822641509434
.nodeset v(xt.xdacs.s259)=0.510188679245283
.nodeset v(xt.xdacs.s260)=0.512150943396226
.nodeset v(xt.xdacs.s261)=0.51411320754717
.nodeset v(xt.xdacs.s262)=0.516075471698113
.nodeset v(xt.xdacs.s263)=0.518037735849057
.nodeset v(xt.xdacs.s264)=0.52
.nodeset v(xt.xdacs.s265)=0.521962264150943
.nodeset v(xt.xdacs.s266)=0.523924528301887
.nodeset v(xt.xdacs.s267)=0.52588679245283
.nodeset v(xt.xdacs.s268)=0.527849056603774
.nodeset v(xt.xdacs.s269)=0.529811320754717
.nodeset v(xt.xdacs.s270)=0.53177358490566
.nodeset v(xt.xdacs.s271)=0.533735849056604
.nodeset v(xt.xdacs.s272)=0.535698113207547
.nodeset v(xt.xdacs.s273)=0.537660377358491
.nodeset v(xt.xdacs.s274)=0.539622641509434
.nodeset v(xt.xdacs.s275)=0.541584905660377
.nodeset v(xt.xdacs.s276)=0.543547169811321
.nodeset v(xt.xdacs.s277)=0.545509433962264
.nodeset v(xt.xdacs.s278)=0.547471698113208
.nodeset v(xt.xdacs.s279)=0.549433962264151
.nodeset v(xt.xdacs.s280)=0.551396226415094
.nodeset v(xt.xdacs.s281)=0.553358490566038
.nodeset v(xt.xdacs.s282)=0.555320754716981
.nodeset v(xt.xdacs.s283)=0.557283018867925
.nodeset v(xt.xdacs.s284)=0.559245283018868
.nodeset v(xt.xdacs.s285)=0.561207547169811
.nodeset v(xt.xdacs.s286)=0.563169811320755
.nodeset v(xt.xdacs.s287)=0.565132075471698
.nodeset v(xt.xdacs.s288)=0.567094339622642
.nodeset v(xt.xdacs.s289)=0.569056603773585
.nodeset v(xt.xdacs.s290)=0.571018867924528
.nodeset v(xt.xdacs.s291)=0.572981132075472
.nodeset v(xt.xdacs.s292)=0.574943396226415
.nodeset v(xt.xdacs.s293)=0.576905660377358
.nodeset v(xt.xdacs.s294)=0.578867924528302
.nodeset v(xt.xdacs.s295)=0.580830188679245
.nodeset v(xt.xdacs.s296)=0.582792452830189
.nodeset v(xt.xdacs.s297)=0.584754716981132
.nodeset v(xt.xdacs.s298)=0.586716981132075
.nodeset v(xt.xdacs.s299)=0.588679245283019
.nodeset v(xt.xdacs.s300)=0.590641509433962
.nodeset v(xt.xdacs.s301)=0.592603773584906
.nodeset v(xt.xdacs.s302)=0.594566037735849
.nodeset v(xt.xdacs.s303)=0.596528301886793
.nodeset v(xt.xdacs.s304)=0.598490566037736
.nodeset v(xt.xdacs.s305)=0.600452830188679
.nodeset v(xt.xdacs.s306)=0.602415094339623
.nodeset v(xt.xdacs.s307)=0.604377358490566
.nodeset v(xt.xdacs.s308)=0.606339622641509
.nodeset v(xt.xdacs.s309)=0.608301886792453
.nodeset v(xt.xdacs.s310)=0.610264150943396
.nodeset v(xt.xdacs.s311)=0.61222641509434
.nodeset v(xt.xdacs.s312)=0.614188679245283
.nodeset v(xt.xdacs.s313)=0.616150943396226
.nodeset v(xt.xdacs.s314)=0.61811320754717
.nodeset v(xt.xdacs.s315)=0.620075471698113
.nodeset v(xt.xdacs.s316)=0.622037735849057
.nodeset v(xt.xdacs.s317)=0.624
.nodeset v(xt.xdacs.s318)=0.625962264150943
.nodeset v(xt.xdacs.s319)=0.627924528301887
.nodeset v(xt.xdacs.s320)=0.62988679245283
.nodeset v(xt.xdacs.s321)=0.631849056603774
.nodeset v(xt.xdacs.s322)=0.633811320754717
.nodeset v(xt.xdacs.s323)=0.63577358490566
.nodeset v(xt.xdacs.s324)=0.637735849056604
.nodeset v(xt.xdacs.s325)=0.639698113207547
.nodeset v(xt.xdacs.s326)=0.641660377358491
.nodeset v(xt.xdacs.s327)=0.643622641509434
.nodeset v(xt.xdacs.s328)=0.645584905660377
.nodeset v(xt.xdacs.s329)=0.647547169811321
.nodeset v(xt.xdacs.s330)=0.649509433962264
.nodeset v(xt.xdacs.s331)=0.651471698113208
.nodeset v(xt.xdacs.s332)=0.653433962264151
.nodeset v(xt.xdacs.s333)=0.655396226415094
.nodeset v(xt.xdacs.s334)=0.657358490566038
.nodeset v(xt.xdacs.s335)=0.659320754716981
.nodeset v(xt.xdacs.s336)=0.661283018867925
.nodeset v(xt.xdacs.s337)=0.663245283018868
.nodeset v(xt.xdacs.s338)=0.665207547169811
.nodeset v(xt.xdacs.s339)=0.667169811320755
.nodeset v(xt.xdacs.s340)=0.669132075471698
.nodeset v(xt.xdacs.s341)=0.671094339622642
.nodeset v(xt.xdacs.s342)=0.673056603773585
.nodeset v(xt.xdacs.s343)=0.675018867924528
.nodeset v(xt.xdacs.s344)=0.676981132075472
.nodeset v(xt.xdacs.s345)=0.678943396226415
.nodeset v(xt.xdacs.s346)=0.680905660377358
.nodeset v(xt.xdacs.s347)=0.682867924528302
.nodeset v(xt.xdacs.s348)=0.684830188679245
.nodeset v(xt.xdacs.s349)=0.686792452830189
.nodeset v(xt.xdacs.s350)=0.688754716981132
.nodeset v(xt.xdacs.s351)=0.690716981132076
.nodeset v(xt.xdacs.s352)=0.692679245283019
.nodeset v(xt.xdacs.s353)=0.694641509433962
.nodeset v(xt.xdacs.s354)=0.696603773584906
.nodeset v(xt.xdacs.s355)=0.698566037735849
.nodeset v(xt.xdacs.s356)=0.700528301886792
.nodeset v(xt.xdacs.s357)=0.702490566037736
.nodeset v(xt.xdacs.s358)=0.704452830188679
.nodeset v(xt.xdacs.s359)=0.706415094339623
.nodeset v(xt.xdacs.s360)=0.708377358490566
.nodeset v(xt.xdacs.s361)=0.71033962264151
.nodeset v(xt.xdacs.s362)=0.712301886792453
.nodeset v(xt.xdacs.s363)=0.714264150943396
.nodeset v(xt.xdacs.s364)=0.71622641509434
.nodeset v(xt.xdacs.s365)=0.718188679245283
.nodeset v(xt.xdacs.s366)=0.720150943396226
.nodeset v(xt.xdacs.s367)=0.72211320754717
.nodeset v(xt.xdacs.s368)=0.724075471698113
.nodeset v(xt.xdacs.s369)=0.726037735849057
.nodeset v(xt.xdacs.s370)=0.728
.nodeset v(xt.xdacs.s371)=0.729962264150943
.nodeset v(xt.xdacs.s372)=0.731924528301887
.nodeset v(xt.xdacs.s373)=0.73388679245283
.nodeset v(xt.xdacs.s374)=0.735849056603774
.nodeset v(xt.xdacs.s375)=0.737811320754717
.nodeset v(xt.xdacs.s376)=0.73977358490566
.nodeset v(xt.xdacs.s377)=0.741735849056604
.nodeset v(xt.xdacs.s378)=0.743698113207547
.nodeset v(xt.xdacs.s379)=0.745660377358491
.nodeset v(xt.xdacs.s380)=0.747622641509434
.nodeset v(xt.xdacs.s381)=0.749584905660377
.nodeset v(xt.xdacs.s382)=0.751547169811321
.nodeset v(xt.xdacs.s383)=0.753509433962264
.nodeset v(xt.xdacs.s384)=0.755471698113208
.nodeset v(xt.xdacs.s385)=0.757433962264151
.nodeset v(xt.xdacs.s386)=0.759396226415094
.nodeset v(xt.xdacs.s387)=0.761358490566038
.nodeset v(xt.xdacs.s388)=0.763320754716981
.nodeset v(xt.xdacs.s389)=0.765283018867925
.nodeset v(xt.xdacs.s390)=0.767245283018868
.nodeset v(xt.xdacs.s391)=0.769207547169811
.nodeset v(xt.xdacs.s392)=0.771169811320755
.nodeset v(xt.xdacs.s393)=0.773132075471698
.nodeset v(xt.xdacs.s394)=0.775094339622642
.nodeset v(xt.xdacs.s395)=0.777056603773585
.nodeset v(xt.xdacs.s396)=0.779018867924528
.nodeset v(xt.xdacs.s397)=0.780981132075472
.nodeset v(xt.xdacs.s398)=0.782943396226415
.nodeset v(xt.xdacs.s399)=0.784905660377359
.nodeset v(xt.xdacs.s400)=0.786867924528302
.nodeset v(xt.xdacs.s401)=0.788830188679245
.nodeset v(xt.xdacs.s402)=0.790792452830189
.nodeset v(xt.xdacs.s403)=0.792754716981132
.nodeset v(xt.xdacs.s404)=0.794716981132075
.nodeset v(xt.xdacs.s405)=0.796679245283019
.nodeset v(xt.xdacs.s406)=0.798641509433962
.nodeset v(xt.xdacs.s407)=0.800603773584906
.nodeset v(xt.xdacs.s408)=0.802566037735849
.nodeset v(xt.xdacs.s409)=0.804528301886792
.nodeset v(xt.xdacs.s410)=0.806490566037736
.nodeset v(xt.xdacs.s411)=0.808452830188679
.nodeset v(xt.xdacs.s412)=0.810415094339623
.nodeset v(xt.xdacs.s413)=0.812377358490566
.nodeset v(xt.xdacs.s414)=0.814339622641509
.nodeset v(xt.xdacs.s415)=0.816301886792453
.nodeset v(xt.xdacs.s416)=0.818264150943396
.nodeset v(xt.xdacs.s417)=0.82022641509434
.nodeset v(xt.xdacs.s418)=0.822188679245283
.nodeset v(xt.xdacs.s419)=0.824150943396226
.nodeset v(xt.xdacs.s420)=0.82611320754717
.nodeset v(xt.xdacs.s421)=0.828075471698113
.nodeset v(xt.xdacs.s422)=0.830037735849057
.nodeset v(xt.xdacs.s423)=0.832
.nodeset v(xt.xdacs.s424)=0.833962264150943
.nodeset v(xt.xdacs.s425)=0.835924528301887
.nodeset v(xt.xdacs.s426)=0.83788679245283
.nodeset v(xt.xdacs.s427)=0.839849056603774
.nodeset v(xt.xdacs.s428)=0.841811320754717
.nodeset v(xt.xdacs.s429)=0.84377358490566
.nodeset v(xt.xdacs.s430)=0.845735849056604
.nodeset v(xt.xdacs.s431)=0.847698113207547
.nodeset v(xt.xdacs.s432)=0.849660377358491
.nodeset v(xt.xdacs.s433)=0.851622641509434
.nodeset v(xt.xdacs.s434)=0.853584905660377
.nodeset v(xt.xdacs.s435)=0.855547169811321
.nodeset v(xt.xdacs.s436)=0.857509433962264
.nodeset v(xt.xdacs.s437)=0.859471698113208
.nodeset v(xt.xdacs.s438)=0.861433962264151
.nodeset v(xt.xdacs.s439)=0.863396226415094
.nodeset v(xt.xdacs.s440)=0.865358490566038
.nodeset v(xt.xdacs.s441)=0.867320754716981
.nodeset v(xt.xdacs.s442)=0.869283018867925
.nodeset v(xt.xdacs.s443)=0.871245283018868
.nodeset v(xt.xdacs.s444)=0.873207547169811
.nodeset v(xt.xdacs.s445)=0.875169811320755
.nodeset v(xt.xdacs.s446)=0.877132075471698
.nodeset v(xt.xdacs.s447)=0.879094339622641
.nodeset v(xt.xdacs.s448)=0.881056603773585
.nodeset v(xt.xdacs.s449)=0.883018867924528
.nodeset v(xt.xdacs.s450)=0.884981132075472
.nodeset v(xt.xdacs.s451)=0.886943396226415
.nodeset v(xt.xdacs.s452)=0.888905660377359
.nodeset v(xt.xdacs.s453)=0.890867924528302
.nodeset v(xt.xdacs.s454)=0.892830188679245
.nodeset v(xt.xdacs.s455)=0.894792452830189
.nodeset v(xt.xdacs.s456)=0.896754716981132
.nodeset v(xt.xdacs.s457)=0.898716981132075
.nodeset v(xt.xdacs.s458)=0.900679245283019
.nodeset v(xt.xdacs.s459)=0.902641509433962
.nodeset v(xt.xdacs.s460)=0.904603773584906
.nodeset v(xt.xdacs.s461)=0.906566037735849
.nodeset v(xt.xdacs.s462)=0.908528301886793
.nodeset v(xt.xdacs.s463)=0.910490566037736
.nodeset v(xt.xdacs.s464)=0.912452830188679
.nodeset v(xt.xdacs.s465)=0.914415094339623
.nodeset v(xt.xdacs.s466)=0.916377358490566
.nodeset v(xt.xdacs.s467)=0.918339622641509
.nodeset v(xt.xdacs.s468)=0.920301886792453
.nodeset v(xt.xdacs.s469)=0.922264150943396
.nodeset v(xt.xdacs.s470)=0.92422641509434
.nodeset v(xt.xdacs.s471)=0.926188679245283
.nodeset v(xt.xdacs.s472)=0.928150943396226
.nodeset v(xt.xdacs.s473)=0.93011320754717
.nodeset v(xt.xdacs.s474)=0.932075471698113
.nodeset v(xt.xdacs.s475)=0.934037735849057
.nodeset v(xt.xdacs.s476)=0.936
.nodeset v(xt.xdacs.s477)=0.937962264150943
.nodeset v(xt.xdacs.s478)=0.939924528301887
.nodeset v(xt.xdacs.s479)=0.94188679245283
.nodeset v(xt.xdacs.s480)=0.943849056603774
.nodeset v(xt.xdacs.s481)=0.945811320754717
.nodeset v(xt.xdacs.s482)=0.94777358490566
.nodeset v(xt.xdacs.s483)=0.949735849056604
.nodeset v(xt.xdacs.s484)=0.951698113207547
.nodeset v(xt.xdacs.s485)=0.953660377358491
.nodeset v(xt.xdacs.s486)=0.955622641509434
.nodeset v(xt.xdacs.s487)=0.957584905660377
.nodeset v(xt.xdacs.s488)=0.959547169811321
.nodeset v(xt.xdacs.s489)=0.961509433962264
.nodeset v(xt.xdacs.s490)=0.963471698113208
.nodeset v(xt.xdacs.s491)=0.965433962264151
.nodeset v(xt.xdacs.s492)=0.967396226415094
.nodeset v(xt.xdacs.s493)=0.969358490566038
.nodeset v(xt.xdacs.s494)=0.971320754716981
.nodeset v(xt.xdacs.s495)=0.973283018867925
.nodeset v(xt.xdacs.s496)=0.975245283018868
.nodeset v(xt.xdacs.s497)=0.977207547169812
.nodeset v(xt.xdacs.s498)=0.979169811320755
.nodeset v(xt.xdacs.s499)=0.981132075471698
.nodeset v(xt.xdacs.s500)=0.983094339622641
.nodeset v(xt.xdacs.s501)=0.985056603773585
.nodeset v(xt.xdacs.s502)=0.987018867924528
.nodeset v(xt.xdacs.s503)=0.988981132075472
.nodeset v(xt.xdacs.s504)=0.990943396226415
.nodeset v(xt.xdacs.s505)=0.992905660377359
.nodeset v(xt.xdacs.s506)=0.994867924528302
.nodeset v(xt.xdacs.s507)=0.996830188679245
.nodeset v(xt.xdacs.s508)=0.998792452830189
.nodeset v(xt.xdacs.s509)=1.00075471698113
.nodeset v(xt.xdacs.s510)=1.00271698113208
.nodeset v(xt.xdacs.s511)=1.00467924528302
.nodeset v(xt.xdacs.s512)=1.00664150943396
.nodeset v(xt.xdacs.s513)=1.00860377358491
.nodeset v(xt.xdacs.s514)=1.01056603773585
.nodeset v(xt.xdacs.s515)=1.01252830188679
.nodeset v(xt.xdacs.s516)=1.01449056603774
.nodeset v(xt.xdacs.s517)=1.01645283018868
.nodeset v(xt.xdacs.s518)=1.01841509433962
.nodeset v(xt.xdacs.s519)=1.02037735849057
.nodeset v(xt.xdacs.s520)=1.02233962264151
.nodeset v(xt.xdacs.s521)=1.02430188679245
.nodeset v(xt.xdacs.s522)=1.0262641509434
.nodeset v(xt.xdacs.s523)=1.02822641509434
.nodeset v(xt.xdacs.s524)=1.03018867924528
.nodeset v(xt.xdacs.s525)=1.03215094339623
.nodeset v(xt.xdacs.s526)=1.03411320754717
.nodeset v(xt.xdacs.s527)=1.03607547169811
.nodeset v(xt.xdacs.s528)=1.03803773584906
.nodeset v(xt.xdacs.dh0)=0
.nodeset v(xt.xdacs.dhn0)=3.3
.nodeset v(xt.xdacs.xlu0.n)=0
.nodeset v(xt.xdacs.xlu0.nb)=3.3
.nodeset v(xt.xdacs.xlu0.ab)=1.2
.nodeset v(xt.xdacs.dh1)=0
.nodeset v(xt.xdacs.dhn1)=3.3
.nodeset v(xt.xdacs.xlu1.n)=0
.nodeset v(xt.xdacs.xlu1.nb)=3.3
.nodeset v(xt.xdacs.xlu1.ab)=1.2
.nodeset v(xt.xdacs.dh2)=0
.nodeset v(xt.xdacs.dhn2)=3.3
.nodeset v(xt.xdacs.xlu2.n)=0
.nodeset v(xt.xdacs.xlu2.nb)=3.3
.nodeset v(xt.xdacs.xlu2.ab)=1.2
.nodeset v(xt.xdacs.dh3)=0
.nodeset v(xt.xdacs.dhn3)=3.3
.nodeset v(xt.xdacs.xlu3.n)=0
.nodeset v(xt.xdacs.xlu3.nb)=3.3
.nodeset v(xt.xdacs.xlu3.ab)=1.2
.nodeset v(xt.xdacs.dh4)=0
.nodeset v(xt.xdacs.dhn4)=3.3
.nodeset v(xt.xdacs.xlu4.n)=0
.nodeset v(xt.xdacs.xlu4.nb)=3.3
.nodeset v(xt.xdacs.xlu4.ab)=1.2
.nodeset v(xt.xdacs.dh5)=0
.nodeset v(xt.xdacs.dhn5)=3.3
.nodeset v(xt.xdacs.xlu5.n)=0
.nodeset v(xt.xdacs.xlu5.nb)=3.3
.nodeset v(xt.xdacs.xlu5.ab)=1.2
.nodeset v(xt.xdacs.dh6)=0
.nodeset v(xt.xdacs.dhn6)=3.3
.nodeset v(xt.xdacs.xlu6.n)=0
.nodeset v(xt.xdacs.xlu6.nb)=3.3
.nodeset v(xt.xdacs.xlu6.ab)=1.2
.nodeset v(xt.xdacs.dh7)=0
.nodeset v(xt.xdacs.dhn7)=3.3
.nodeset v(xt.xdacs.xlu7.n)=0
.nodeset v(xt.xdacs.xlu7.nb)=3.3
.nodeset v(xt.xdacs.xlu7.ab)=1.2
.nodeset v(xt.xdach.s0)=0.0019622641509434
.nodeset v(xt.xdach.s1)=0.00392452830188679
.nodeset v(xt.xdach.s2)=0.00588679245283019
.nodeset v(xt.xdach.s3)=0.00784905660377359
.nodeset v(xt.xdach.s4)=0.00981132075471698
.nodeset v(xt.xdach.s5)=0.0117735849056604
.nodeset v(xt.xdach.s6)=0.0137358490566038
.nodeset v(xt.xdach.s7)=0.0156981132075472
.nodeset v(xt.xdach.s8)=0.0176603773584906
.nodeset v(xt.xdach.s9)=0.019622641509434
.nodeset v(xt.xdach.s10)=0.0215849056603774
.nodeset v(xt.xdach.s11)=0.0235471698113208
.nodeset v(xt.xdach.s12)=0.0255094339622642
.nodeset v(xt.xdach.s13)=0.0274716981132075
.nodeset v(xt.xdach.s14)=0.0294339622641509
.nodeset v(xt.xdach.s15)=0.0313962264150943
.nodeset v(xt.xdach.s16)=0.0333584905660377
.nodeset v(xt.xdach.s17)=0.0353207547169811
.nodeset v(xt.xdach.s18)=0.0372830188679245
.nodeset v(xt.xdach.s19)=0.0392452830188679
.nodeset v(xt.xdach.s20)=0.0412075471698113
.nodeset v(xt.xdach.s21)=0.0431698113207547
.nodeset v(xt.xdach.s22)=0.0451320754716981
.nodeset v(xt.xdach.s23)=0.0470943396226415
.nodeset v(xt.xdach.s24)=0.0490566037735849
.nodeset v(xt.xdach.s25)=0.0510188679245283
.nodeset v(xt.xdach.s26)=0.0529811320754717
.nodeset v(xt.xdach.s27)=0.0549433962264151
.nodeset v(xt.xdach.s28)=0.0569056603773585
.nodeset v(xt.xdach.s29)=0.0588679245283019
.nodeset v(xt.xdach.s30)=0.0608301886792453
.nodeset v(xt.xdach.s31)=0.0627924528301887
.nodeset v(xt.xdach.s32)=0.0647547169811321
.nodeset v(xt.xdach.s33)=0.0667169811320755
.nodeset v(xt.xdach.s34)=0.0686792452830189
.nodeset v(xt.xdach.s35)=0.0706415094339623
.nodeset v(xt.xdach.s36)=0.0726037735849057
.nodeset v(xt.xdach.s37)=0.0745660377358491
.nodeset v(xt.xdach.s38)=0.0765283018867925
.nodeset v(xt.xdach.s39)=0.0784905660377359
.nodeset v(xt.xdach.s40)=0.0804528301886792
.nodeset v(xt.xdach.s41)=0.0824150943396226
.nodeset v(xt.xdach.s42)=0.084377358490566
.nodeset v(xt.xdach.s43)=0.0863396226415094
.nodeset v(xt.xdach.s44)=0.0883018867924528
.nodeset v(xt.xdach.s45)=0.0902641509433962
.nodeset v(xt.xdach.s46)=0.0922264150943396
.nodeset v(xt.xdach.s47)=0.094188679245283
.nodeset v(xt.xdach.s48)=0.0961509433962264
.nodeset v(xt.xdach.s49)=0.0981132075471698
.nodeset v(xt.xdach.s50)=0.100075471698113
.nodeset v(xt.xdach.s51)=0.102037735849057
.nodeset v(xt.xdach.s52)=0.104
.nodeset v(xt.xdach.s53)=0.105962264150943
.nodeset v(xt.xdach.s54)=0.107924528301887
.nodeset v(xt.xdach.s55)=0.10988679245283
.nodeset v(xt.xdach.s56)=0.111849056603774
.nodeset v(xt.xdach.s57)=0.113811320754717
.nodeset v(xt.xdach.s58)=0.11577358490566
.nodeset v(xt.xdach.s59)=0.117735849056604
.nodeset v(xt.xdach.s60)=0.119698113207547
.nodeset v(xt.xdach.s61)=0.121660377358491
.nodeset v(xt.xdach.s62)=0.123622641509434
.nodeset v(xt.xdach.s63)=0.125584905660377
.nodeset v(xt.xdach.s64)=0.127547169811321
.nodeset v(xt.xdach.s65)=0.129509433962264
.nodeset v(xt.xdach.s66)=0.131471698113208
.nodeset v(xt.xdach.s67)=0.133433962264151
.nodeset v(xt.xdach.s68)=0.135396226415094
.nodeset v(xt.xdach.s69)=0.137358490566038
.nodeset v(xt.xdach.s70)=0.139320754716981
.nodeset v(xt.xdach.s71)=0.141283018867925
.nodeset v(xt.xdach.s72)=0.143245283018868
.nodeset v(xt.xdach.s73)=0.145207547169811
.nodeset v(xt.xdach.s74)=0.147169811320755
.nodeset v(xt.xdach.s75)=0.149132075471698
.nodeset v(xt.xdach.s76)=0.151094339622642
.nodeset v(xt.xdach.s77)=0.153056603773585
.nodeset v(xt.xdach.s78)=0.155018867924528
.nodeset v(xt.xdach.s79)=0.156981132075472
.nodeset v(xt.xdach.s80)=0.158943396226415
.nodeset v(xt.xdach.s81)=0.160905660377358
.nodeset v(xt.xdach.s82)=0.162867924528302
.nodeset v(xt.xdach.s83)=0.164830188679245
.nodeset v(xt.xdach.s84)=0.166792452830189
.nodeset v(xt.xdach.s85)=0.168754716981132
.nodeset v(xt.xdach.s86)=0.170716981132075
.nodeset v(xt.xdach.s87)=0.172679245283019
.nodeset v(xt.xdach.s88)=0.174641509433962
.nodeset v(xt.xdach.s89)=0.176603773584906
.nodeset v(xt.xdach.s90)=0.178566037735849
.nodeset v(xt.xdach.s91)=0.180528301886792
.nodeset v(xt.xdach.s92)=0.182490566037736
.nodeset v(xt.xdach.s93)=0.184452830188679
.nodeset v(xt.xdach.s94)=0.186415094339623
.nodeset v(xt.xdach.s95)=0.188377358490566
.nodeset v(xt.xdach.s96)=0.190339622641509
.nodeset v(xt.xdach.s97)=0.192301886792453
.nodeset v(xt.xdach.s98)=0.194264150943396
.nodeset v(xt.xdach.s99)=0.19622641509434
.nodeset v(xt.xdach.s100)=0.198188679245283
.nodeset v(xt.xdach.s101)=0.200150943396226
.nodeset v(xt.xdach.s102)=0.20211320754717
.nodeset v(xt.xdach.s103)=0.204075471698113
.nodeset v(xt.xdach.s104)=0.206037735849057
.nodeset v(xt.xdach.s105)=0.208
.nodeset v(xt.xdach.s106)=0.209962264150943
.nodeset v(xt.xdach.s107)=0.211924528301887
.nodeset v(xt.xdach.s108)=0.21388679245283
.nodeset v(xt.xdach.s109)=0.215849056603774
.nodeset v(xt.xdach.s110)=0.217811320754717
.nodeset v(xt.xdach.s111)=0.21977358490566
.nodeset v(xt.xdach.s112)=0.221735849056604
.nodeset v(xt.xdach.s113)=0.223698113207547
.nodeset v(xt.xdach.s114)=0.225660377358491
.nodeset v(xt.xdach.s115)=0.227622641509434
.nodeset v(xt.xdach.s116)=0.229584905660377
.nodeset v(xt.xdach.s117)=0.231547169811321
.nodeset v(xt.xdach.s118)=0.233509433962264
.nodeset v(xt.xdach.s119)=0.235471698113208
.nodeset v(xt.xdach.s120)=0.237433962264151
.nodeset v(xt.xdach.s121)=0.239396226415094
.nodeset v(xt.xdach.s122)=0.241358490566038
.nodeset v(xt.xdach.s123)=0.243320754716981
.nodeset v(xt.xdach.s124)=0.245283018867925
.nodeset v(xt.xdach.s125)=0.247245283018868
.nodeset v(xt.xdach.s126)=0.249207547169811
.nodeset v(xt.xdach.s127)=0.251169811320755
.nodeset v(xt.xdach.s128)=0.253132075471698
.nodeset v(xt.xdach.s129)=0.255094339622642
.nodeset v(xt.xdach.s130)=0.257056603773585
.nodeset v(xt.xdach.s131)=0.259018867924528
.nodeset v(xt.xdach.s132)=0.260981132075472
.nodeset v(xt.xdach.s133)=0.262943396226415
.nodeset v(xt.xdach.s134)=0.264905660377359
.nodeset v(xt.xdach.s135)=0.266867924528302
.nodeset v(xt.xdach.s136)=0.268830188679245
.nodeset v(xt.xdach.s137)=0.270792452830189
.nodeset v(xt.xdach.s138)=0.272754716981132
.nodeset v(xt.xdach.s139)=0.274716981132075
.nodeset v(xt.xdach.s140)=0.276679245283019
.nodeset v(xt.xdach.s141)=0.278641509433962
.nodeset v(xt.xdach.s142)=0.280603773584906
.nodeset v(xt.xdach.s143)=0.282566037735849
.nodeset v(xt.xdach.s144)=0.284528301886792
.nodeset v(xt.xdach.s145)=0.286490566037736
.nodeset v(xt.xdach.s146)=0.288452830188679
.nodeset v(xt.xdach.s147)=0.290415094339623
.nodeset v(xt.xdach.s148)=0.292377358490566
.nodeset v(xt.xdach.s149)=0.294339622641509
.nodeset v(xt.xdach.s150)=0.296301886792453
.nodeset v(xt.xdach.s151)=0.298264150943396
.nodeset v(xt.xdach.s152)=0.30022641509434
.nodeset v(xt.xdach.s153)=0.302188679245283
.nodeset v(xt.xdach.s154)=0.304150943396226
.nodeset v(xt.xdach.s155)=0.30611320754717
.nodeset v(xt.xdach.s156)=0.308075471698113
.nodeset v(xt.xdach.s157)=0.310037735849057
.nodeset v(xt.xdach.s158)=0.312
.nodeset v(xt.xdach.s159)=0.313962264150943
.nodeset v(xt.xdach.s160)=0.315924528301887
.nodeset v(xt.xdach.s161)=0.31788679245283
.nodeset v(xt.xdach.s162)=0.319849056603774
.nodeset v(xt.xdach.s163)=0.321811320754717
.nodeset v(xt.xdach.s164)=0.32377358490566
.nodeset v(xt.xdach.s165)=0.325735849056604
.nodeset v(xt.xdach.s166)=0.327698113207547
.nodeset v(xt.xdach.s167)=0.329660377358491
.nodeset v(xt.xdach.s168)=0.331622641509434
.nodeset v(xt.xdach.s169)=0.333584905660377
.nodeset v(xt.xdach.s170)=0.335547169811321
.nodeset v(xt.xdach.s171)=0.337509433962264
.nodeset v(xt.xdach.s172)=0.339471698113208
.nodeset v(xt.xdach.s173)=0.341433962264151
.nodeset v(xt.xdach.s174)=0.343396226415094
.nodeset v(xt.xdach.s175)=0.345358490566038
.nodeset v(xt.xdach.s176)=0.347320754716981
.nodeset v(xt.xdach.s177)=0.349283018867925
.nodeset v(xt.xdach.s178)=0.351245283018868
.nodeset v(xt.xdach.s179)=0.353207547169811
.nodeset v(xt.xdach.s180)=0.355169811320755
.nodeset v(xt.xdach.s181)=0.357132075471698
.nodeset v(xt.xdach.s182)=0.359094339622641
.nodeset v(xt.xdach.s183)=0.361056603773585
.nodeset v(xt.xdach.s184)=0.363018867924528
.nodeset v(xt.xdach.s185)=0.364981132075472
.nodeset v(xt.xdach.s186)=0.366943396226415
.nodeset v(xt.xdach.s187)=0.368905660377359
.nodeset v(xt.xdach.s188)=0.370867924528302
.nodeset v(xt.xdach.s189)=0.372830188679245
.nodeset v(xt.xdach.s190)=0.374792452830189
.nodeset v(xt.xdach.s191)=0.376754716981132
.nodeset v(xt.xdach.s192)=0.378716981132075
.nodeset v(xt.xdach.s193)=0.380679245283019
.nodeset v(xt.xdach.s194)=0.382641509433962
.nodeset v(xt.xdach.s195)=0.384603773584906
.nodeset v(xt.xdach.s196)=0.386566037735849
.nodeset v(xt.xdach.s197)=0.388528301886792
.nodeset v(xt.xdach.s198)=0.390490566037736
.nodeset v(xt.xdach.s199)=0.392452830188679
.nodeset v(xt.xdach.s200)=0.394415094339623
.nodeset v(xt.xdach.s201)=0.396377358490566
.nodeset v(xt.xdach.s202)=0.398339622641509
.nodeset v(xt.xdach.s203)=0.400301886792453
.nodeset v(xt.xdach.s204)=0.402264150943396
.nodeset v(xt.xdach.s205)=0.40422641509434
.nodeset v(xt.xdach.s206)=0.406188679245283
.nodeset v(xt.xdach.s207)=0.408150943396226
.nodeset v(xt.xdach.s208)=0.41011320754717
.nodeset v(xt.xdach.s209)=0.412075471698113
.nodeset v(xt.xdach.s210)=0.414037735849057
.nodeset v(xt.xdach.s211)=0.416
.nodeset v(xt.xdach.s212)=0.417962264150943
.nodeset v(xt.xdach.s213)=0.419924528301887
.nodeset v(xt.xdach.s214)=0.42188679245283
.nodeset v(xt.xdach.s215)=0.423849056603774
.nodeset v(xt.xdach.s216)=0.425811320754717
.nodeset v(xt.xdach.s217)=0.42777358490566
.nodeset v(xt.xdach.s218)=0.429735849056604
.nodeset v(xt.xdach.s219)=0.431698113207547
.nodeset v(xt.xdach.s220)=0.433660377358491
.nodeset v(xt.xdach.s221)=0.435622641509434
.nodeset v(xt.xdach.s222)=0.437584905660377
.nodeset v(xt.xdach.s223)=0.439547169811321
.nodeset v(xt.xdach.s224)=0.441509433962264
.nodeset v(xt.xdach.s225)=0.443471698113208
.nodeset v(xt.xdach.s226)=0.445433962264151
.nodeset v(xt.xdach.s227)=0.447396226415094
.nodeset v(xt.xdach.s228)=0.449358490566038
.nodeset v(xt.xdach.s229)=0.451320754716981
.nodeset v(xt.xdach.s230)=0.453283018867925
.nodeset v(xt.xdach.s231)=0.455245283018868
.nodeset v(xt.xdach.s232)=0.457207547169811
.nodeset v(xt.xdach.s233)=0.459169811320755
.nodeset v(xt.xdach.s234)=0.461132075471698
.nodeset v(xt.xdach.s235)=0.463094339622642
.nodeset v(xt.xdach.s236)=0.465056603773585
.nodeset v(xt.xdach.s237)=0.467018867924528
.nodeset v(xt.xdach.s238)=0.468981132075472
.nodeset v(xt.xdach.s239)=0.470943396226415
.nodeset v(xt.xdach.s240)=0.472905660377359
.nodeset v(xt.xdach.s241)=0.474867924528302
.nodeset v(xt.xdach.s242)=0.476830188679245
.nodeset v(xt.xdach.s243)=0.478792452830189
.nodeset v(xt.xdach.s244)=0.480754716981132
.nodeset v(xt.xdach.s245)=0.482716981132075
.nodeset v(xt.xdach.s246)=0.484679245283019
.nodeset v(xt.xdach.s247)=0.486641509433962
.nodeset v(xt.xdach.s248)=0.488603773584906
.nodeset v(xt.xdach.s249)=0.490566037735849
.nodeset v(xt.xdach.s250)=0.492528301886792
.nodeset v(xt.xdach.s251)=0.494490566037736
.nodeset v(xt.xdach.s252)=0.496452830188679
.nodeset v(xt.xdach.s253)=0.498415094339623
.nodeset v(xt.xdach.s254)=0.500377358490566
.nodeset v(xt.xdach.s255)=0.502339622641509
.nodeset v(xt.xdach.s256)=0.504301886792453
.nodeset v(xt.xdach.s257)=0.506264150943396
.nodeset v(xt.xdach.s258)=0.50822641509434
.nodeset v(xt.xdach.s259)=0.510188679245283
.nodeset v(xt.xdach.s260)=0.512150943396226
.nodeset v(xt.xdach.s261)=0.51411320754717
.nodeset v(xt.xdach.s262)=0.516075471698113
.nodeset v(xt.xdach.s263)=0.518037735849057
.nodeset v(xt.xdach.s264)=0.52
.nodeset v(xt.xdach.s265)=0.521962264150943
.nodeset v(xt.xdach.s266)=0.523924528301887
.nodeset v(xt.xdach.s267)=0.52588679245283
.nodeset v(xt.xdach.s268)=0.527849056603774
.nodeset v(xt.xdach.s269)=0.529811320754717
.nodeset v(xt.xdach.s270)=0.53177358490566
.nodeset v(xt.xdach.s271)=0.533735849056604
.nodeset v(xt.xdach.s272)=0.535698113207547
.nodeset v(xt.xdach.s273)=0.537660377358491
.nodeset v(xt.xdach.s274)=0.539622641509434
.nodeset v(xt.xdach.s275)=0.541584905660377
.nodeset v(xt.xdach.s276)=0.543547169811321
.nodeset v(xt.xdach.s277)=0.545509433962264
.nodeset v(xt.xdach.s278)=0.547471698113208
.nodeset v(xt.xdach.s279)=0.549433962264151
.nodeset v(xt.xdach.s280)=0.551396226415094
.nodeset v(xt.xdach.s281)=0.553358490566038
.nodeset v(xt.xdach.s282)=0.555320754716981
.nodeset v(xt.xdach.s283)=0.557283018867925
.nodeset v(xt.xdach.s284)=0.559245283018868
.nodeset v(xt.xdach.s285)=0.561207547169811
.nodeset v(xt.xdach.s286)=0.563169811320755
.nodeset v(xt.xdach.s287)=0.565132075471698
.nodeset v(xt.xdach.s288)=0.567094339622642
.nodeset v(xt.xdach.s289)=0.569056603773585
.nodeset v(xt.xdach.s290)=0.571018867924528
.nodeset v(xt.xdach.s291)=0.572981132075472
.nodeset v(xt.xdach.s292)=0.574943396226415
.nodeset v(xt.xdach.s293)=0.576905660377358
.nodeset v(xt.xdach.s294)=0.578867924528302
.nodeset v(xt.xdach.s295)=0.580830188679245
.nodeset v(xt.xdach.s296)=0.582792452830189
.nodeset v(xt.xdach.s297)=0.584754716981132
.nodeset v(xt.xdach.s298)=0.586716981132075
.nodeset v(xt.xdach.s299)=0.588679245283019
.nodeset v(xt.xdach.s300)=0.590641509433962
.nodeset v(xt.xdach.s301)=0.592603773584906
.nodeset v(xt.xdach.s302)=0.594566037735849
.nodeset v(xt.xdach.s303)=0.596528301886793
.nodeset v(xt.xdach.s304)=0.598490566037736
.nodeset v(xt.xdach.s305)=0.600452830188679
.nodeset v(xt.xdach.s306)=0.602415094339623
.nodeset v(xt.xdach.s307)=0.604377358490566
.nodeset v(xt.xdach.s308)=0.606339622641509
.nodeset v(xt.xdach.s309)=0.608301886792453
.nodeset v(xt.xdach.s310)=0.610264150943396
.nodeset v(xt.xdach.s311)=0.61222641509434
.nodeset v(xt.xdach.s312)=0.614188679245283
.nodeset v(xt.xdach.s313)=0.616150943396226
.nodeset v(xt.xdach.s314)=0.61811320754717
.nodeset v(xt.xdach.s315)=0.620075471698113
.nodeset v(xt.xdach.s316)=0.622037735849057
.nodeset v(xt.xdach.s317)=0.624
.nodeset v(xt.xdach.s318)=0.625962264150943
.nodeset v(xt.xdach.s319)=0.627924528301887
.nodeset v(xt.xdach.s320)=0.62988679245283
.nodeset v(xt.xdach.s321)=0.631849056603774
.nodeset v(xt.xdach.s322)=0.633811320754717
.nodeset v(xt.xdach.s323)=0.63577358490566
.nodeset v(xt.xdach.s324)=0.637735849056604
.nodeset v(xt.xdach.s325)=0.639698113207547
.nodeset v(xt.xdach.s326)=0.641660377358491
.nodeset v(xt.xdach.s327)=0.643622641509434
.nodeset v(xt.xdach.s328)=0.645584905660377
.nodeset v(xt.xdach.s329)=0.647547169811321
.nodeset v(xt.xdach.s330)=0.649509433962264
.nodeset v(xt.xdach.s331)=0.651471698113208
.nodeset v(xt.xdach.s332)=0.653433962264151
.nodeset v(xt.xdach.s333)=0.655396226415094
.nodeset v(xt.xdach.s334)=0.657358490566038
.nodeset v(xt.xdach.s335)=0.659320754716981
.nodeset v(xt.xdach.s336)=0.661283018867925
.nodeset v(xt.xdach.s337)=0.663245283018868
.nodeset v(xt.xdach.s338)=0.665207547169811
.nodeset v(xt.xdach.s339)=0.667169811320755
.nodeset v(xt.xdach.s340)=0.669132075471698
.nodeset v(xt.xdach.s341)=0.671094339622642
.nodeset v(xt.xdach.s342)=0.673056603773585
.nodeset v(xt.xdach.s343)=0.675018867924528
.nodeset v(xt.xdach.s344)=0.676981132075472
.nodeset v(xt.xdach.s345)=0.678943396226415
.nodeset v(xt.xdach.s346)=0.680905660377358
.nodeset v(xt.xdach.s347)=0.682867924528302
.nodeset v(xt.xdach.s348)=0.684830188679245
.nodeset v(xt.xdach.s349)=0.686792452830189
.nodeset v(xt.xdach.s350)=0.688754716981132
.nodeset v(xt.xdach.s351)=0.690716981132076
.nodeset v(xt.xdach.s352)=0.692679245283019
.nodeset v(xt.xdach.s353)=0.694641509433962
.nodeset v(xt.xdach.s354)=0.696603773584906
.nodeset v(xt.xdach.s355)=0.698566037735849
.nodeset v(xt.xdach.s356)=0.700528301886792
.nodeset v(xt.xdach.s357)=0.702490566037736
.nodeset v(xt.xdach.s358)=0.704452830188679
.nodeset v(xt.xdach.s359)=0.706415094339623
.nodeset v(xt.xdach.s360)=0.708377358490566
.nodeset v(xt.xdach.s361)=0.71033962264151
.nodeset v(xt.xdach.s362)=0.712301886792453
.nodeset v(xt.xdach.s363)=0.714264150943396
.nodeset v(xt.xdach.s364)=0.71622641509434
.nodeset v(xt.xdach.s365)=0.718188679245283
.nodeset v(xt.xdach.s366)=0.720150943396226
.nodeset v(xt.xdach.s367)=0.72211320754717
.nodeset v(xt.xdach.s368)=0.724075471698113
.nodeset v(xt.xdach.s369)=0.726037735849057
.nodeset v(xt.xdach.s370)=0.728
.nodeset v(xt.xdach.s371)=0.729962264150943
.nodeset v(xt.xdach.s372)=0.731924528301887
.nodeset v(xt.xdach.s373)=0.73388679245283
.nodeset v(xt.xdach.s374)=0.735849056603774
.nodeset v(xt.xdach.s375)=0.737811320754717
.nodeset v(xt.xdach.s376)=0.73977358490566
.nodeset v(xt.xdach.s377)=0.741735849056604
.nodeset v(xt.xdach.s378)=0.743698113207547
.nodeset v(xt.xdach.s379)=0.745660377358491
.nodeset v(xt.xdach.s380)=0.747622641509434
.nodeset v(xt.xdach.s381)=0.749584905660377
.nodeset v(xt.xdach.s382)=0.751547169811321
.nodeset v(xt.xdach.s383)=0.753509433962264
.nodeset v(xt.xdach.s384)=0.755471698113208
.nodeset v(xt.xdach.s385)=0.757433962264151
.nodeset v(xt.xdach.s386)=0.759396226415094
.nodeset v(xt.xdach.s387)=0.761358490566038
.nodeset v(xt.xdach.s388)=0.763320754716981
.nodeset v(xt.xdach.s389)=0.765283018867925
.nodeset v(xt.xdach.s390)=0.767245283018868
.nodeset v(xt.xdach.s391)=0.769207547169811
.nodeset v(xt.xdach.s392)=0.771169811320755
.nodeset v(xt.xdach.s393)=0.773132075471698
.nodeset v(xt.xdach.s394)=0.775094339622642
.nodeset v(xt.xdach.s395)=0.777056603773585
.nodeset v(xt.xdach.s396)=0.779018867924528
.nodeset v(xt.xdach.s397)=0.780981132075472
.nodeset v(xt.xdach.s398)=0.782943396226415
.nodeset v(xt.xdach.s399)=0.784905660377359
.nodeset v(xt.xdach.s400)=0.786867924528302
.nodeset v(xt.xdach.s401)=0.788830188679245
.nodeset v(xt.xdach.s402)=0.790792452830189
.nodeset v(xt.xdach.s403)=0.792754716981132
.nodeset v(xt.xdach.s404)=0.794716981132075
.nodeset v(xt.xdach.s405)=0.796679245283019
.nodeset v(xt.xdach.s406)=0.798641509433962
.nodeset v(xt.xdach.s407)=0.800603773584906
.nodeset v(xt.xdach.s408)=0.802566037735849
.nodeset v(xt.xdach.s409)=0.804528301886792
.nodeset v(xt.xdach.s410)=0.806490566037736
.nodeset v(xt.xdach.s411)=0.808452830188679
.nodeset v(xt.xdach.s412)=0.810415094339623
.nodeset v(xt.xdach.s413)=0.812377358490566
.nodeset v(xt.xdach.s414)=0.814339622641509
.nodeset v(xt.xdach.s415)=0.816301886792453
.nodeset v(xt.xdach.s416)=0.818264150943396
.nodeset v(xt.xdach.s417)=0.82022641509434
.nodeset v(xt.xdach.s418)=0.822188679245283
.nodeset v(xt.xdach.s419)=0.824150943396226
.nodeset v(xt.xdach.s420)=0.82611320754717
.nodeset v(xt.xdach.s421)=0.828075471698113
.nodeset v(xt.xdach.s422)=0.830037735849057
.nodeset v(xt.xdach.s423)=0.832
.nodeset v(xt.xdach.s424)=0.833962264150943
.nodeset v(xt.xdach.s425)=0.835924528301887
.nodeset v(xt.xdach.s426)=0.83788679245283
.nodeset v(xt.xdach.s427)=0.839849056603774
.nodeset v(xt.xdach.s428)=0.841811320754717
.nodeset v(xt.xdach.s429)=0.84377358490566
.nodeset v(xt.xdach.s430)=0.845735849056604
.nodeset v(xt.xdach.s431)=0.847698113207547
.nodeset v(xt.xdach.s432)=0.849660377358491
.nodeset v(xt.xdach.s433)=0.851622641509434
.nodeset v(xt.xdach.s434)=0.853584905660377
.nodeset v(xt.xdach.s435)=0.855547169811321
.nodeset v(xt.xdach.s436)=0.857509433962264
.nodeset v(xt.xdach.s437)=0.859471698113208
.nodeset v(xt.xdach.s438)=0.861433962264151
.nodeset v(xt.xdach.s439)=0.863396226415094
.nodeset v(xt.xdach.s440)=0.865358490566038
.nodeset v(xt.xdach.s441)=0.867320754716981
.nodeset v(xt.xdach.s442)=0.869283018867925
.nodeset v(xt.xdach.s443)=0.871245283018868
.nodeset v(xt.xdach.s444)=0.873207547169811
.nodeset v(xt.xdach.s445)=0.875169811320755
.nodeset v(xt.xdach.s446)=0.877132075471698
.nodeset v(xt.xdach.s447)=0.879094339622641
.nodeset v(xt.xdach.s448)=0.881056603773585
.nodeset v(xt.xdach.s449)=0.883018867924528
.nodeset v(xt.xdach.s450)=0.884981132075472
.nodeset v(xt.xdach.s451)=0.886943396226415
.nodeset v(xt.xdach.s452)=0.888905660377359
.nodeset v(xt.xdach.s453)=0.890867924528302
.nodeset v(xt.xdach.s454)=0.892830188679245
.nodeset v(xt.xdach.s455)=0.894792452830189
.nodeset v(xt.xdach.s456)=0.896754716981132
.nodeset v(xt.xdach.s457)=0.898716981132075
.nodeset v(xt.xdach.s458)=0.900679245283019
.nodeset v(xt.xdach.s459)=0.902641509433962
.nodeset v(xt.xdach.s460)=0.904603773584906
.nodeset v(xt.xdach.s461)=0.906566037735849
.nodeset v(xt.xdach.s462)=0.908528301886793
.nodeset v(xt.xdach.s463)=0.910490566037736
.nodeset v(xt.xdach.s464)=0.912452830188679
.nodeset v(xt.xdach.s465)=0.914415094339623
.nodeset v(xt.xdach.s466)=0.916377358490566
.nodeset v(xt.xdach.s467)=0.918339622641509
.nodeset v(xt.xdach.s468)=0.920301886792453
.nodeset v(xt.xdach.s469)=0.922264150943396
.nodeset v(xt.xdach.s470)=0.92422641509434
.nodeset v(xt.xdach.s471)=0.926188679245283
.nodeset v(xt.xdach.s472)=0.928150943396226
.nodeset v(xt.xdach.s473)=0.93011320754717
.nodeset v(xt.xdach.s474)=0.932075471698113
.nodeset v(xt.xdach.s475)=0.934037735849057
.nodeset v(xt.xdach.s476)=0.936
.nodeset v(xt.xdach.s477)=0.937962264150943
.nodeset v(xt.xdach.s478)=0.939924528301887
.nodeset v(xt.xdach.s479)=0.94188679245283
.nodeset v(xt.xdach.s480)=0.943849056603774
.nodeset v(xt.xdach.s481)=0.945811320754717
.nodeset v(xt.xdach.s482)=0.94777358490566
.nodeset v(xt.xdach.s483)=0.949735849056604
.nodeset v(xt.xdach.s484)=0.951698113207547
.nodeset v(xt.xdach.s485)=0.953660377358491
.nodeset v(xt.xdach.s486)=0.955622641509434
.nodeset v(xt.xdach.s487)=0.957584905660377
.nodeset v(xt.xdach.s488)=0.959547169811321
.nodeset v(xt.xdach.s489)=0.961509433962264
.nodeset v(xt.xdach.s490)=0.963471698113208
.nodeset v(xt.xdach.s491)=0.965433962264151
.nodeset v(xt.xdach.s492)=0.967396226415094
.nodeset v(xt.xdach.s493)=0.969358490566038
.nodeset v(xt.xdach.s494)=0.971320754716981
.nodeset v(xt.xdach.s495)=0.973283018867925
.nodeset v(xt.xdach.s496)=0.975245283018868
.nodeset v(xt.xdach.s497)=0.977207547169812
.nodeset v(xt.xdach.s498)=0.979169811320755
.nodeset v(xt.xdach.s499)=0.981132075471698
.nodeset v(xt.xdach.s500)=0.983094339622641
.nodeset v(xt.xdach.s501)=0.985056603773585
.nodeset v(xt.xdach.s502)=0.987018867924528
.nodeset v(xt.xdach.s503)=0.988981132075472
.nodeset v(xt.xdach.s504)=0.990943396226415
.nodeset v(xt.xdach.s505)=0.992905660377359
.nodeset v(xt.xdach.s506)=0.994867924528302
.nodeset v(xt.xdach.s507)=0.996830188679245
.nodeset v(xt.xdach.s508)=0.998792452830189
.nodeset v(xt.xdach.s509)=1.00075471698113
.nodeset v(xt.xdach.s510)=1.00271698113208
.nodeset v(xt.xdach.s511)=1.00467924528302
.nodeset v(xt.xdach.s512)=1.00664150943396
.nodeset v(xt.xdach.s513)=1.00860377358491
.nodeset v(xt.xdach.s514)=1.01056603773585
.nodeset v(xt.xdach.s515)=1.01252830188679
.nodeset v(xt.xdach.s516)=1.01449056603774
.nodeset v(xt.xdach.s517)=1.01645283018868
.nodeset v(xt.xdach.s518)=1.01841509433962
.nodeset v(xt.xdach.s519)=1.02037735849057
.nodeset v(xt.xdach.s520)=1.02233962264151
.nodeset v(xt.xdach.s521)=1.02430188679245
.nodeset v(xt.xdach.s522)=1.0262641509434
.nodeset v(xt.xdach.s523)=1.02822641509434
.nodeset v(xt.xdach.s524)=1.03018867924528
.nodeset v(xt.xdach.s525)=1.03215094339623
.nodeset v(xt.xdach.s526)=1.03411320754717
.nodeset v(xt.xdach.s527)=1.03607547169811
.nodeset v(xt.xdach.s528)=1.03803773584906
.nodeset v(xt.xdach.dh0)=0
.nodeset v(xt.xdach.dhn0)=3.3
.nodeset v(xt.xdach.xlu0.n)=0
.nodeset v(xt.xdach.xlu0.nb)=3.3
.nodeset v(xt.xdach.xlu0.ab)=1.2
.nodeset v(xt.xdach.dh1)=0
.nodeset v(xt.xdach.dhn1)=3.3
.nodeset v(xt.xdach.xlu1.n)=0
.nodeset v(xt.xdach.xlu1.nb)=3.3
.nodeset v(xt.xdach.xlu1.ab)=1.2
.nodeset v(xt.xdach.dh2)=0
.nodeset v(xt.xdach.dhn2)=3.3
.nodeset v(xt.xdach.xlu2.n)=0
.nodeset v(xt.xdach.xlu2.nb)=3.3
.nodeset v(xt.xdach.xlu2.ab)=1.2
.nodeset v(xt.xdach.dh3)=0
.nodeset v(xt.xdach.dhn3)=3.3
.nodeset v(xt.xdach.xlu3.n)=0
.nodeset v(xt.xdach.xlu3.nb)=3.3
.nodeset v(xt.xdach.xlu3.ab)=1.2
.nodeset v(xt.xdach.dh4)=0
.nodeset v(xt.xdach.dhn4)=3.3
.nodeset v(xt.xdach.xlu4.n)=0
.nodeset v(xt.xdach.xlu4.nb)=3.3
.nodeset v(xt.xdach.xlu4.ab)=1.2
.nodeset v(xt.xdach.dh5)=0
.nodeset v(xt.xdach.dhn5)=3.3
.nodeset v(xt.xdach.xlu5.n)=0
.nodeset v(xt.xdach.xlu5.nb)=3.3
.nodeset v(xt.xdach.xlu5.ab)=1.2
.nodeset v(xt.xdach.dh6)=0
.nodeset v(xt.xdach.dhn6)=3.3
.nodeset v(xt.xdach.xlu6.n)=0
.nodeset v(xt.xdach.xlu6.nb)=3.3
.nodeset v(xt.xdach.xlu6.ab)=1.2
.nodeset v(xt.xdach.dh7)=0
.nodeset v(xt.xdach.dhn7)=3.3
.nodeset v(xt.xdach.xlu7.n)=0
.nodeset v(xt.xdach.xlu7.nb)=3.3
.nodeset v(xt.xdach.xlu7.ab)=1.2
.control
set num_threads=1
set numdgt=15
setseed 51001
reset
set temp=25.0
alter Iib dc=4.10248042645344e-06
dc Vcode 0 255 1
set wr_singlescale
set wr_vecnames
wrdata qualification/dac-nodeset-pilot-20260921-a/seed51001_t0.dat v(xt.vth_soft) v(xt.vth_hard) v(vref_buf) v(isense) i(vdda)
echo FINGERPRINT 0
print @n.xt.xdacs.xms7_0a.nsg13_hv_nmos[w]
print @n.xt.xdacs.xms7_0a.nsg13_hv_nmos[l]
print @n.xt.xdacs.xms7_0a.nsg13_hv_nmos[delvto]
print @n.xt.xdacs.xms7_0a.nsg13_hv_nmos[factuo]
print @n.xt.xdach.xms7_0b.nsg13_hv_nmos[w]
print @n.xt.xdach.xms7_0b.nsg13_hv_nmos[l]
print @n.xt.xdach.xms7_0b.nsg13_hv_nmos[delvto]
print @n.xt.xdach.xms7_0b.nsg13_hv_nmos[factuo]
print @n.xt.xcs.xm1.nsg13_lv_nmos[w]
print @n.xt.xcs.xm1.nsg13_lv_nmos[l]
print @n.xt.xcs.xm1.nsg13_lv_nmos[delvto]
print @n.xt.xcs.xm1.nsg13_lv_nmos[factuo]
print @n.xt.xch.xm1.nsg13_lv_nmos[w]
print @n.xt.xch.xm1.nsg13_lv_nmos[l]
print @n.xt.xch.xm1.nsg13_lv_nmos[delvto]
print @n.xt.xch.xm1.nsg13_lv_nmos[factuo]
print @n.xs.xref.xm1.nsg13_hv_pmos[w]
print @n.xs.xref.xm1.nsg13_hv_pmos[l]
print @n.xs.xref.xm1.nsg13_hv_pmos[delvto]
print @n.xs.xref.xm1.nsg13_hv_pmos[factuo]
print @n.xt.xdacs.xru0.nr1[nsmm_rsh]
print @n.xt.xdacs.xru0.nr1[nsmm_w]
print @n.xt.xdacs.xru0.nr1[nsmm_l]
echo QUALIFICATION_END
quit 0
.endc
.end
