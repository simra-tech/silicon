* G1_TRIP kickback: real source (G1_SENSE output through the conditioning divider) and real DAC tap,
* both comparators clocked (soft on cmp_clk, hard on its inverse), 10 MHz. Soft threshold code 153
* (30.0 mV shunt), shunt input set .025 so the soft comparator sits at/near its threshold.
.param VDDA=3.3 VDD=1.2 VREF=1.04
.lib /foss/pdks/ihp-sg13g2/libs.tech/ngspice/models/cornerMOSlv.lib mos_tt_mismatch
.lib /foss/pdks/ihp-sg13g2/libs.tech/ngspice/models/cornerMOShv.lib mos_tt_mismatch
.lib /foss/pdks/ihp-sg13g2/libs.tech/ngspice/models/cornerRES.lib res_typ_mismatch
.lib /foss/pdks/ihp-sg13g2/libs.tech/ngspice/models/cornerCAP.lib cap_typ
.temp 25
* the off switches leave the mux tree nodes floating at DC: give the solver a 1 TOhm path per node
.option rshunt=1e12 gmin=1e-13
.include qualification/dac-full-pilot-20260921-a/sense.spice
.include qualification/dac-full-pilot-20260921-a/trip.spice
Vdda vdda 0 dc {VDDA}
Vdd vdd 0 dc {VDD}
Vref vref 0 dc {VREF}
Iib vdda iptat dc 4.13u
Vsh shp 0 dc .025
XS shp 0 vref iptat isense vped vref_buf vdda 0 g1_sense
CL isense 0 300f
* soft code 153 = 1001 1001b (30.0 mV) ; hard code 254 = 1111 1110b (49.8 mV)
Vs0 s0 0 dc 1.2
Vs1 s1 0 dc 0
Vs2 s2 0 dc 0
Vs3 s3 0 dc 1.2
Vs4 s4 0 dc 1.2
Vs5 s5 0 dc 0
Vs6 s6 0 dc 0
Vs7 s7 0 dc 1.2
Vh0 h0 0 dc 0
Vh1 h1 0 dc 1.2
Vh2 h2 0 dc 1.2
Vh3 h3 0 dc 1.2
Vh4 h4 0 dc 1.2
Vh5 h5 0 dc 1.2
Vh6 h6 0 dc 1.2
Vh7 h7 0 dc 1.2
Vclk clk 0 dc 0
XT isense vref_buf clk s0 s1 s2 s3 s4 s5 s6 s7 h0 h1 h2 h3 h4 h5 h6 h7 cmp_soft cmp_hard vdd vdda 0 g1_trip
Cs cmp_soft 0 10f
Ch cmp_hard 0 10f
* keep only the nodes of interest (the full 1200-device transient exhausts the output memory)
.save v(xt.icmp) v(xt.vth_soft) v(xt.vth_hard) v(cmp_soft) v(cmp_hard) v(isense)
.control
set num_threads=1
set numdgt=15
setseed 51001
reset
set temp=25.0
alter Iib dc=4.10248042645344e-06
alter Vs0 dc=0
alter Vh0 dc=0
alter Vs1 dc=0
alter Vh1 dc=0
alter Vs2 dc=0
alter Vh2 dc=0
alter Vs3 dc=0
alter Vh3 dc=0
alter Vs4 dc=0
alter Vh4 dc=0
alter Vs5 dc=0
alter Vh5 dc=0
alter Vs6 dc=0
alter Vh6 dc=0
alter Vs7 dc=0
alter Vh7 dc=0
op
echo ROW 0 25.0 0 $&v(xt.vth_soft) $&v(xt.vth_hard) $&v(vref_buf) $&v(isense) $&i(vdda)
alter Vs0 dc=1.2
alter Vh0 dc=1.2
alter Vs1 dc=0
alter Vh1 dc=0
alter Vs2 dc=0
alter Vh2 dc=0
alter Vs3 dc=0
alter Vh3 dc=0
alter Vs4 dc=0
alter Vh4 dc=0
alter Vs5 dc=0
alter Vh5 dc=0
alter Vs6 dc=0
alter Vh6 dc=0
alter Vs7 dc=0
alter Vh7 dc=0
op
echo ROW 0 25.0 1 $&v(xt.vth_soft) $&v(xt.vth_hard) $&v(vref_buf) $&v(isense) $&i(vdda)
alter Vs0 dc=0
alter Vh0 dc=0
alter Vs1 dc=1.2
alter Vh1 dc=1.2
alter Vs2 dc=0
alter Vh2 dc=0
alter Vs3 dc=0
alter Vh3 dc=0
alter Vs4 dc=0
alter Vh4 dc=0
alter Vs5 dc=0
alter Vh5 dc=0
alter Vs6 dc=0
alter Vh6 dc=0
alter Vs7 dc=0
alter Vh7 dc=0
op
echo ROW 0 25.0 2 $&v(xt.vth_soft) $&v(xt.vth_hard) $&v(vref_buf) $&v(isense) $&i(vdda)
alter Vs0 dc=1.2
alter Vh0 dc=1.2
alter Vs1 dc=1.2
alter Vh1 dc=1.2
alter Vs2 dc=0
alter Vh2 dc=0
alter Vs3 dc=0
alter Vh3 dc=0
alter Vs4 dc=0
alter Vh4 dc=0
alter Vs5 dc=0
alter Vh5 dc=0
alter Vs6 dc=0
alter Vh6 dc=0
alter Vs7 dc=0
alter Vh7 dc=0
op
echo ROW 0 25.0 3 $&v(xt.vth_soft) $&v(xt.vth_hard) $&v(vref_buf) $&v(isense) $&i(vdda)
alter Vs0 dc=0
alter Vh0 dc=0
alter Vs1 dc=0
alter Vh1 dc=0
alter Vs2 dc=1.2
alter Vh2 dc=1.2
alter Vs3 dc=0
alter Vh3 dc=0
alter Vs4 dc=0
alter Vh4 dc=0
alter Vs5 dc=0
alter Vh5 dc=0
alter Vs6 dc=0
alter Vh6 dc=0
alter Vs7 dc=0
alter Vh7 dc=0
op
echo ROW 0 25.0 4 $&v(xt.vth_soft) $&v(xt.vth_hard) $&v(vref_buf) $&v(isense) $&i(vdda)
alter Vs0 dc=1.2
alter Vh0 dc=1.2
alter Vs1 dc=0
alter Vh1 dc=0
alter Vs2 dc=1.2
alter Vh2 dc=1.2
alter Vs3 dc=0
alter Vh3 dc=0
alter Vs4 dc=0
alter Vh4 dc=0
alter Vs5 dc=0
alter Vh5 dc=0
alter Vs6 dc=0
alter Vh6 dc=0
alter Vs7 dc=0
alter Vh7 dc=0
op
echo ROW 0 25.0 5 $&v(xt.vth_soft) $&v(xt.vth_hard) $&v(vref_buf) $&v(isense) $&i(vdda)
alter Vs0 dc=0
alter Vh0 dc=0
alter Vs1 dc=1.2
alter Vh1 dc=1.2
alter Vs2 dc=1.2
alter Vh2 dc=1.2
alter Vs3 dc=0
alter Vh3 dc=0
alter Vs4 dc=0
alter Vh4 dc=0
alter Vs5 dc=0
alter Vh5 dc=0
alter Vs6 dc=0
alter Vh6 dc=0
alter Vs7 dc=0
alter Vh7 dc=0
op
echo ROW 0 25.0 6 $&v(xt.vth_soft) $&v(xt.vth_hard) $&v(vref_buf) $&v(isense) $&i(vdda)
alter Vs0 dc=1.2
alter Vh0 dc=1.2
alter Vs1 dc=1.2
alter Vh1 dc=1.2
alter Vs2 dc=1.2
alter Vh2 dc=1.2
alter Vs3 dc=0
alter Vh3 dc=0
alter Vs4 dc=0
alter Vh4 dc=0
alter Vs5 dc=0
alter Vh5 dc=0
alter Vs6 dc=0
alter Vh6 dc=0
alter Vs7 dc=0
alter Vh7 dc=0
op
echo ROW 0 25.0 7 $&v(xt.vth_soft) $&v(xt.vth_hard) $&v(vref_buf) $&v(isense) $&i(vdda)
alter Vs0 dc=0
alter Vh0 dc=0
alter Vs1 dc=0
alter Vh1 dc=0
alter Vs2 dc=0
alter Vh2 dc=0
alter Vs3 dc=1.2
alter Vh3 dc=1.2
alter Vs4 dc=0
alter Vh4 dc=0
alter Vs5 dc=0
alter Vh5 dc=0
alter Vs6 dc=0
alter Vh6 dc=0
alter Vs7 dc=0
alter Vh7 dc=0
op
echo ROW 0 25.0 8 $&v(xt.vth_soft) $&v(xt.vth_hard) $&v(vref_buf) $&v(isense) $&i(vdda)
alter Vs0 dc=1.2
alter Vh0 dc=1.2
alter Vs1 dc=0
alter Vh1 dc=0
alter Vs2 dc=0
alter Vh2 dc=0
alter Vs3 dc=1.2
alter Vh3 dc=1.2
alter Vs4 dc=0
alter Vh4 dc=0
alter Vs5 dc=0
alter Vh5 dc=0
alter Vs6 dc=0
alter Vh6 dc=0
alter Vs7 dc=0
alter Vh7 dc=0
op
echo ROW 0 25.0 9 $&v(xt.vth_soft) $&v(xt.vth_hard) $&v(vref_buf) $&v(isense) $&i(vdda)
alter Vs0 dc=0
alter Vh0 dc=0
alter Vs1 dc=1.2
alter Vh1 dc=1.2
alter Vs2 dc=0
alter Vh2 dc=0
alter Vs3 dc=1.2
alter Vh3 dc=1.2
alter Vs4 dc=0
alter Vh4 dc=0
alter Vs5 dc=0
alter Vh5 dc=0
alter Vs6 dc=0
alter Vh6 dc=0
alter Vs7 dc=0
alter Vh7 dc=0
op
echo ROW 0 25.0 10 $&v(xt.vth_soft) $&v(xt.vth_hard) $&v(vref_buf) $&v(isense) $&i(vdda)
alter Vs0 dc=1.2
alter Vh0 dc=1.2
alter Vs1 dc=1.2
alter Vh1 dc=1.2
alter Vs2 dc=0
alter Vh2 dc=0
alter Vs3 dc=1.2
alter Vh3 dc=1.2
alter Vs4 dc=0
alter Vh4 dc=0
alter Vs5 dc=0
alter Vh5 dc=0
alter Vs6 dc=0
alter Vh6 dc=0
alter Vs7 dc=0
alter Vh7 dc=0
op
echo ROW 0 25.0 11 $&v(xt.vth_soft) $&v(xt.vth_hard) $&v(vref_buf) $&v(isense) $&i(vdda)
alter Vs0 dc=0
alter Vh0 dc=0
alter Vs1 dc=0
alter Vh1 dc=0
alter Vs2 dc=1.2
alter Vh2 dc=1.2
alter Vs3 dc=1.2
alter Vh3 dc=1.2
alter Vs4 dc=0
alter Vh4 dc=0
alter Vs5 dc=0
alter Vh5 dc=0
alter Vs6 dc=0
alter Vh6 dc=0
alter Vs7 dc=0
alter Vh7 dc=0
op
echo ROW 0 25.0 12 $&v(xt.vth_soft) $&v(xt.vth_hard) $&v(vref_buf) $&v(isense) $&i(vdda)
alter Vs0 dc=1.2
alter Vh0 dc=1.2
alter Vs1 dc=0
alter Vh1 dc=0
alter Vs2 dc=1.2
alter Vh2 dc=1.2
alter Vs3 dc=1.2
alter Vh3 dc=1.2
alter Vs4 dc=0
alter Vh4 dc=0
alter Vs5 dc=0
alter Vh5 dc=0
alter Vs6 dc=0
alter Vh6 dc=0
alter Vs7 dc=0
alter Vh7 dc=0
op
echo ROW 0 25.0 13 $&v(xt.vth_soft) $&v(xt.vth_hard) $&v(vref_buf) $&v(isense) $&i(vdda)
alter Vs0 dc=0
alter Vh0 dc=0
alter Vs1 dc=1.2
alter Vh1 dc=1.2
alter Vs2 dc=1.2
alter Vh2 dc=1.2
alter Vs3 dc=1.2
alter Vh3 dc=1.2
alter Vs4 dc=0
alter Vh4 dc=0
alter Vs5 dc=0
alter Vh5 dc=0
alter Vs6 dc=0
alter Vh6 dc=0
alter Vs7 dc=0
alter Vh7 dc=0
op
echo ROW 0 25.0 14 $&v(xt.vth_soft) $&v(xt.vth_hard) $&v(vref_buf) $&v(isense) $&i(vdda)
alter Vs0 dc=1.2
alter Vh0 dc=1.2
alter Vs1 dc=1.2
alter Vh1 dc=1.2
alter Vs2 dc=1.2
alter Vh2 dc=1.2
alter Vs3 dc=1.2
alter Vh3 dc=1.2
alter Vs4 dc=0
alter Vh4 dc=0
alter Vs5 dc=0
alter Vh5 dc=0
alter Vs6 dc=0
alter Vh6 dc=0
alter Vs7 dc=0
alter Vh7 dc=0
op
echo ROW 0 25.0 15 $&v(xt.vth_soft) $&v(xt.vth_hard) $&v(vref_buf) $&v(isense) $&i(vdda)
alter Vs0 dc=0
alter Vh0 dc=0
alter Vs1 dc=0
alter Vh1 dc=0
alter Vs2 dc=0
alter Vh2 dc=0
alter Vs3 dc=0
alter Vh3 dc=0
alter Vs4 dc=1.2
alter Vh4 dc=1.2
alter Vs5 dc=0
alter Vh5 dc=0
alter Vs6 dc=0
alter Vh6 dc=0
alter Vs7 dc=0
alter Vh7 dc=0
op
echo ROW 0 25.0 16 $&v(xt.vth_soft) $&v(xt.vth_hard) $&v(vref_buf) $&v(isense) $&i(vdda)
alter Vs0 dc=1.2
alter Vh0 dc=1.2
alter Vs1 dc=0
alter Vh1 dc=0
alter Vs2 dc=0
alter Vh2 dc=0
alter Vs3 dc=0
alter Vh3 dc=0
alter Vs4 dc=1.2
alter Vh4 dc=1.2
alter Vs5 dc=0
alter Vh5 dc=0
alter Vs6 dc=0
alter Vh6 dc=0
alter Vs7 dc=0
alter Vh7 dc=0
op
echo ROW 0 25.0 17 $&v(xt.vth_soft) $&v(xt.vth_hard) $&v(vref_buf) $&v(isense) $&i(vdda)
alter Vs0 dc=0
alter Vh0 dc=0
alter Vs1 dc=1.2
alter Vh1 dc=1.2
alter Vs2 dc=0
alter Vh2 dc=0
alter Vs3 dc=0
alter Vh3 dc=0
alter Vs4 dc=1.2
alter Vh4 dc=1.2
alter Vs5 dc=0
alter Vh5 dc=0
alter Vs6 dc=0
alter Vh6 dc=0
alter Vs7 dc=0
alter Vh7 dc=0
op
echo ROW 0 25.0 18 $&v(xt.vth_soft) $&v(xt.vth_hard) $&v(vref_buf) $&v(isense) $&i(vdda)
alter Vs0 dc=1.2
alter Vh0 dc=1.2
alter Vs1 dc=1.2
alter Vh1 dc=1.2
alter Vs2 dc=0
alter Vh2 dc=0
alter Vs3 dc=0
alter Vh3 dc=0
alter Vs4 dc=1.2
alter Vh4 dc=1.2
alter Vs5 dc=0
alter Vh5 dc=0
alter Vs6 dc=0
alter Vh6 dc=0
alter Vs7 dc=0
alter Vh7 dc=0
op
echo ROW 0 25.0 19 $&v(xt.vth_soft) $&v(xt.vth_hard) $&v(vref_buf) $&v(isense) $&i(vdda)
alter Vs0 dc=0
alter Vh0 dc=0
alter Vs1 dc=0
alter Vh1 dc=0
alter Vs2 dc=1.2
alter Vh2 dc=1.2
alter Vs3 dc=0
alter Vh3 dc=0
alter Vs4 dc=1.2
alter Vh4 dc=1.2
alter Vs5 dc=0
alter Vh5 dc=0
alter Vs6 dc=0
alter Vh6 dc=0
alter Vs7 dc=0
alter Vh7 dc=0
op
echo ROW 0 25.0 20 $&v(xt.vth_soft) $&v(xt.vth_hard) $&v(vref_buf) $&v(isense) $&i(vdda)
alter Vs0 dc=1.2
alter Vh0 dc=1.2
alter Vs1 dc=0
alter Vh1 dc=0
alter Vs2 dc=1.2
alter Vh2 dc=1.2
alter Vs3 dc=0
alter Vh3 dc=0
alter Vs4 dc=1.2
alter Vh4 dc=1.2
alter Vs5 dc=0
alter Vh5 dc=0
alter Vs6 dc=0
alter Vh6 dc=0
alter Vs7 dc=0
alter Vh7 dc=0
op
echo ROW 0 25.0 21 $&v(xt.vth_soft) $&v(xt.vth_hard) $&v(vref_buf) $&v(isense) $&i(vdda)
alter Vs0 dc=0
alter Vh0 dc=0
alter Vs1 dc=1.2
alter Vh1 dc=1.2
alter Vs2 dc=1.2
alter Vh2 dc=1.2
alter Vs3 dc=0
alter Vh3 dc=0
alter Vs4 dc=1.2
alter Vh4 dc=1.2
alter Vs5 dc=0
alter Vh5 dc=0
alter Vs6 dc=0
alter Vh6 dc=0
alter Vs7 dc=0
alter Vh7 dc=0
op
echo ROW 0 25.0 22 $&v(xt.vth_soft) $&v(xt.vth_hard) $&v(vref_buf) $&v(isense) $&i(vdda)
alter Vs0 dc=1.2
alter Vh0 dc=1.2
alter Vs1 dc=1.2
alter Vh1 dc=1.2
alter Vs2 dc=1.2
alter Vh2 dc=1.2
alter Vs3 dc=0
alter Vh3 dc=0
alter Vs4 dc=1.2
alter Vh4 dc=1.2
alter Vs5 dc=0
alter Vh5 dc=0
alter Vs6 dc=0
alter Vh6 dc=0
alter Vs7 dc=0
alter Vh7 dc=0
op
echo ROW 0 25.0 23 $&v(xt.vth_soft) $&v(xt.vth_hard) $&v(vref_buf) $&v(isense) $&i(vdda)
alter Vs0 dc=0
alter Vh0 dc=0
alter Vs1 dc=0
alter Vh1 dc=0
alter Vs2 dc=0
alter Vh2 dc=0
alter Vs3 dc=1.2
alter Vh3 dc=1.2
alter Vs4 dc=1.2
alter Vh4 dc=1.2
alter Vs5 dc=0
alter Vh5 dc=0
alter Vs6 dc=0
alter Vh6 dc=0
alter Vs7 dc=0
alter Vh7 dc=0
op
echo ROW 0 25.0 24 $&v(xt.vth_soft) $&v(xt.vth_hard) $&v(vref_buf) $&v(isense) $&i(vdda)
alter Vs0 dc=1.2
alter Vh0 dc=1.2
alter Vs1 dc=0
alter Vh1 dc=0
alter Vs2 dc=0
alter Vh2 dc=0
alter Vs3 dc=1.2
alter Vh3 dc=1.2
alter Vs4 dc=1.2
alter Vh4 dc=1.2
alter Vs5 dc=0
alter Vh5 dc=0
alter Vs6 dc=0
alter Vh6 dc=0
alter Vs7 dc=0
alter Vh7 dc=0
op
echo ROW 0 25.0 25 $&v(xt.vth_soft) $&v(xt.vth_hard) $&v(vref_buf) $&v(isense) $&i(vdda)
alter Vs0 dc=0
alter Vh0 dc=0
alter Vs1 dc=1.2
alter Vh1 dc=1.2
alter Vs2 dc=0
alter Vh2 dc=0
alter Vs3 dc=1.2
alter Vh3 dc=1.2
alter Vs4 dc=1.2
alter Vh4 dc=1.2
alter Vs5 dc=0
alter Vh5 dc=0
alter Vs6 dc=0
alter Vh6 dc=0
alter Vs7 dc=0
alter Vh7 dc=0
op
echo ROW 0 25.0 26 $&v(xt.vth_soft) $&v(xt.vth_hard) $&v(vref_buf) $&v(isense) $&i(vdda)
alter Vs0 dc=1.2
alter Vh0 dc=1.2
alter Vs1 dc=1.2
alter Vh1 dc=1.2
alter Vs2 dc=0
alter Vh2 dc=0
alter Vs3 dc=1.2
alter Vh3 dc=1.2
alter Vs4 dc=1.2
alter Vh4 dc=1.2
alter Vs5 dc=0
alter Vh5 dc=0
alter Vs6 dc=0
alter Vh6 dc=0
alter Vs7 dc=0
alter Vh7 dc=0
op
echo ROW 0 25.0 27 $&v(xt.vth_soft) $&v(xt.vth_hard) $&v(vref_buf) $&v(isense) $&i(vdda)
alter Vs0 dc=0
alter Vh0 dc=0
alter Vs1 dc=0
alter Vh1 dc=0
alter Vs2 dc=1.2
alter Vh2 dc=1.2
alter Vs3 dc=1.2
alter Vh3 dc=1.2
alter Vs4 dc=1.2
alter Vh4 dc=1.2
alter Vs5 dc=0
alter Vh5 dc=0
alter Vs6 dc=0
alter Vh6 dc=0
alter Vs7 dc=0
alter Vh7 dc=0
op
echo ROW 0 25.0 28 $&v(xt.vth_soft) $&v(xt.vth_hard) $&v(vref_buf) $&v(isense) $&i(vdda)
alter Vs0 dc=1.2
alter Vh0 dc=1.2
alter Vs1 dc=0
alter Vh1 dc=0
alter Vs2 dc=1.2
alter Vh2 dc=1.2
alter Vs3 dc=1.2
alter Vh3 dc=1.2
alter Vs4 dc=1.2
alter Vh4 dc=1.2
alter Vs5 dc=0
alter Vh5 dc=0
alter Vs6 dc=0
alter Vh6 dc=0
alter Vs7 dc=0
alter Vh7 dc=0
op
echo ROW 0 25.0 29 $&v(xt.vth_soft) $&v(xt.vth_hard) $&v(vref_buf) $&v(isense) $&i(vdda)
alter Vs0 dc=0
alter Vh0 dc=0
alter Vs1 dc=1.2
alter Vh1 dc=1.2
alter Vs2 dc=1.2
alter Vh2 dc=1.2
alter Vs3 dc=1.2
alter Vh3 dc=1.2
alter Vs4 dc=1.2
alter Vh4 dc=1.2
alter Vs5 dc=0
alter Vh5 dc=0
alter Vs6 dc=0
alter Vh6 dc=0
alter Vs7 dc=0
alter Vh7 dc=0
op
echo ROW 0 25.0 30 $&v(xt.vth_soft) $&v(xt.vth_hard) $&v(vref_buf) $&v(isense) $&i(vdda)
alter Vs0 dc=1.2
alter Vh0 dc=1.2
alter Vs1 dc=1.2
alter Vh1 dc=1.2
alter Vs2 dc=1.2
alter Vh2 dc=1.2
alter Vs3 dc=1.2
alter Vh3 dc=1.2
alter Vs4 dc=1.2
alter Vh4 dc=1.2
alter Vs5 dc=0
alter Vh5 dc=0
alter Vs6 dc=0
alter Vh6 dc=0
alter Vs7 dc=0
alter Vh7 dc=0
op
echo ROW 0 25.0 31 $&v(xt.vth_soft) $&v(xt.vth_hard) $&v(vref_buf) $&v(isense) $&i(vdda)
alter Vs0 dc=0
alter Vh0 dc=0
alter Vs1 dc=0
alter Vh1 dc=0
alter Vs2 dc=0
alter Vh2 dc=0
alter Vs3 dc=0
alter Vh3 dc=0
alter Vs4 dc=0
alter Vh4 dc=0
alter Vs5 dc=1.2
alter Vh5 dc=1.2
alter Vs6 dc=0
alter Vh6 dc=0
alter Vs7 dc=0
alter Vh7 dc=0
op
echo ROW 0 25.0 32 $&v(xt.vth_soft) $&v(xt.vth_hard) $&v(vref_buf) $&v(isense) $&i(vdda)
alter Vs0 dc=1.2
alter Vh0 dc=1.2
alter Vs1 dc=0
alter Vh1 dc=0
alter Vs2 dc=0
alter Vh2 dc=0
alter Vs3 dc=0
alter Vh3 dc=0
alter Vs4 dc=0
alter Vh4 dc=0
alter Vs5 dc=1.2
alter Vh5 dc=1.2
alter Vs6 dc=0
alter Vh6 dc=0
alter Vs7 dc=0
alter Vh7 dc=0
op
echo ROW 0 25.0 33 $&v(xt.vth_soft) $&v(xt.vth_hard) $&v(vref_buf) $&v(isense) $&i(vdda)
alter Vs0 dc=0
alter Vh0 dc=0
alter Vs1 dc=1.2
alter Vh1 dc=1.2
alter Vs2 dc=0
alter Vh2 dc=0
alter Vs3 dc=0
alter Vh3 dc=0
alter Vs4 dc=0
alter Vh4 dc=0
alter Vs5 dc=1.2
alter Vh5 dc=1.2
alter Vs6 dc=0
alter Vh6 dc=0
alter Vs7 dc=0
alter Vh7 dc=0
op
echo ROW 0 25.0 34 $&v(xt.vth_soft) $&v(xt.vth_hard) $&v(vref_buf) $&v(isense) $&i(vdda)
alter Vs0 dc=1.2
alter Vh0 dc=1.2
alter Vs1 dc=1.2
alter Vh1 dc=1.2
alter Vs2 dc=0
alter Vh2 dc=0
alter Vs3 dc=0
alter Vh3 dc=0
alter Vs4 dc=0
alter Vh4 dc=0
alter Vs5 dc=1.2
alter Vh5 dc=1.2
alter Vs6 dc=0
alter Vh6 dc=0
alter Vs7 dc=0
alter Vh7 dc=0
op
echo ROW 0 25.0 35 $&v(xt.vth_soft) $&v(xt.vth_hard) $&v(vref_buf) $&v(isense) $&i(vdda)
alter Vs0 dc=0
alter Vh0 dc=0
alter Vs1 dc=0
alter Vh1 dc=0
alter Vs2 dc=1.2
alter Vh2 dc=1.2
alter Vs3 dc=0
alter Vh3 dc=0
alter Vs4 dc=0
alter Vh4 dc=0
alter Vs5 dc=1.2
alter Vh5 dc=1.2
alter Vs6 dc=0
alter Vh6 dc=0
alter Vs7 dc=0
alter Vh7 dc=0
op
echo ROW 0 25.0 36 $&v(xt.vth_soft) $&v(xt.vth_hard) $&v(vref_buf) $&v(isense) $&i(vdda)
alter Vs0 dc=1.2
alter Vh0 dc=1.2
alter Vs1 dc=0
alter Vh1 dc=0
alter Vs2 dc=1.2
alter Vh2 dc=1.2
alter Vs3 dc=0
alter Vh3 dc=0
alter Vs4 dc=0
alter Vh4 dc=0
alter Vs5 dc=1.2
alter Vh5 dc=1.2
alter Vs6 dc=0
alter Vh6 dc=0
alter Vs7 dc=0
alter Vh7 dc=0
op
echo ROW 0 25.0 37 $&v(xt.vth_soft) $&v(xt.vth_hard) $&v(vref_buf) $&v(isense) $&i(vdda)
alter Vs0 dc=0
alter Vh0 dc=0
alter Vs1 dc=1.2
alter Vh1 dc=1.2
alter Vs2 dc=1.2
alter Vh2 dc=1.2
alter Vs3 dc=0
alter Vh3 dc=0
alter Vs4 dc=0
alter Vh4 dc=0
alter Vs5 dc=1.2
alter Vh5 dc=1.2
alter Vs6 dc=0
alter Vh6 dc=0
alter Vs7 dc=0
alter Vh7 dc=0
op
echo ROW 0 25.0 38 $&v(xt.vth_soft) $&v(xt.vth_hard) $&v(vref_buf) $&v(isense) $&i(vdda)
alter Vs0 dc=1.2
alter Vh0 dc=1.2
alter Vs1 dc=1.2
alter Vh1 dc=1.2
alter Vs2 dc=1.2
alter Vh2 dc=1.2
alter Vs3 dc=0
alter Vh3 dc=0
alter Vs4 dc=0
alter Vh4 dc=0
alter Vs5 dc=1.2
alter Vh5 dc=1.2
alter Vs6 dc=0
alter Vh6 dc=0
alter Vs7 dc=0
alter Vh7 dc=0
op
echo ROW 0 25.0 39 $&v(xt.vth_soft) $&v(xt.vth_hard) $&v(vref_buf) $&v(isense) $&i(vdda)
alter Vs0 dc=0
alter Vh0 dc=0
alter Vs1 dc=0
alter Vh1 dc=0
alter Vs2 dc=0
alter Vh2 dc=0
alter Vs3 dc=1.2
alter Vh3 dc=1.2
alter Vs4 dc=0
alter Vh4 dc=0
alter Vs5 dc=1.2
alter Vh5 dc=1.2
alter Vs6 dc=0
alter Vh6 dc=0
alter Vs7 dc=0
alter Vh7 dc=0
op
echo ROW 0 25.0 40 $&v(xt.vth_soft) $&v(xt.vth_hard) $&v(vref_buf) $&v(isense) $&i(vdda)
alter Vs0 dc=1.2
alter Vh0 dc=1.2
alter Vs1 dc=0
alter Vh1 dc=0
alter Vs2 dc=0
alter Vh2 dc=0
alter Vs3 dc=1.2
alter Vh3 dc=1.2
alter Vs4 dc=0
alter Vh4 dc=0
alter Vs5 dc=1.2
alter Vh5 dc=1.2
alter Vs6 dc=0
alter Vh6 dc=0
alter Vs7 dc=0
alter Vh7 dc=0
op
echo ROW 0 25.0 41 $&v(xt.vth_soft) $&v(xt.vth_hard) $&v(vref_buf) $&v(isense) $&i(vdda)
alter Vs0 dc=0
alter Vh0 dc=0
alter Vs1 dc=1.2
alter Vh1 dc=1.2
alter Vs2 dc=0
alter Vh2 dc=0
alter Vs3 dc=1.2
alter Vh3 dc=1.2
alter Vs4 dc=0
alter Vh4 dc=0
alter Vs5 dc=1.2
alter Vh5 dc=1.2
alter Vs6 dc=0
alter Vh6 dc=0
alter Vs7 dc=0
alter Vh7 dc=0
op
echo ROW 0 25.0 42 $&v(xt.vth_soft) $&v(xt.vth_hard) $&v(vref_buf) $&v(isense) $&i(vdda)
alter Vs0 dc=1.2
alter Vh0 dc=1.2
alter Vs1 dc=1.2
alter Vh1 dc=1.2
alter Vs2 dc=0
alter Vh2 dc=0
alter Vs3 dc=1.2
alter Vh3 dc=1.2
alter Vs4 dc=0
alter Vh4 dc=0
alter Vs5 dc=1.2
alter Vh5 dc=1.2
alter Vs6 dc=0
alter Vh6 dc=0
alter Vs7 dc=0
alter Vh7 dc=0
op
echo ROW 0 25.0 43 $&v(xt.vth_soft) $&v(xt.vth_hard) $&v(vref_buf) $&v(isense) $&i(vdda)
alter Vs0 dc=0
alter Vh0 dc=0
alter Vs1 dc=0
alter Vh1 dc=0
alter Vs2 dc=1.2
alter Vh2 dc=1.2
alter Vs3 dc=1.2
alter Vh3 dc=1.2
alter Vs4 dc=0
alter Vh4 dc=0
alter Vs5 dc=1.2
alter Vh5 dc=1.2
alter Vs6 dc=0
alter Vh6 dc=0
alter Vs7 dc=0
alter Vh7 dc=0
op
echo ROW 0 25.0 44 $&v(xt.vth_soft) $&v(xt.vth_hard) $&v(vref_buf) $&v(isense) $&i(vdda)
alter Vs0 dc=1.2
alter Vh0 dc=1.2
alter Vs1 dc=0
alter Vh1 dc=0
alter Vs2 dc=1.2
alter Vh2 dc=1.2
alter Vs3 dc=1.2
alter Vh3 dc=1.2
alter Vs4 dc=0
alter Vh4 dc=0
alter Vs5 dc=1.2
alter Vh5 dc=1.2
alter Vs6 dc=0
alter Vh6 dc=0
alter Vs7 dc=0
alter Vh7 dc=0
op
echo ROW 0 25.0 45 $&v(xt.vth_soft) $&v(xt.vth_hard) $&v(vref_buf) $&v(isense) $&i(vdda)
alter Vs0 dc=0
alter Vh0 dc=0
alter Vs1 dc=1.2
alter Vh1 dc=1.2
alter Vs2 dc=1.2
alter Vh2 dc=1.2
alter Vs3 dc=1.2
alter Vh3 dc=1.2
alter Vs4 dc=0
alter Vh4 dc=0
alter Vs5 dc=1.2
alter Vh5 dc=1.2
alter Vs6 dc=0
alter Vh6 dc=0
alter Vs7 dc=0
alter Vh7 dc=0
op
echo ROW 0 25.0 46 $&v(xt.vth_soft) $&v(xt.vth_hard) $&v(vref_buf) $&v(isense) $&i(vdda)
alter Vs0 dc=1.2
alter Vh0 dc=1.2
alter Vs1 dc=1.2
alter Vh1 dc=1.2
alter Vs2 dc=1.2
alter Vh2 dc=1.2
alter Vs3 dc=1.2
alter Vh3 dc=1.2
alter Vs4 dc=0
alter Vh4 dc=0
alter Vs5 dc=1.2
alter Vh5 dc=1.2
alter Vs6 dc=0
alter Vh6 dc=0
alter Vs7 dc=0
alter Vh7 dc=0
op
echo ROW 0 25.0 47 $&v(xt.vth_soft) $&v(xt.vth_hard) $&v(vref_buf) $&v(isense) $&i(vdda)
alter Vs0 dc=0
alter Vh0 dc=0
alter Vs1 dc=0
alter Vh1 dc=0
alter Vs2 dc=0
alter Vh2 dc=0
alter Vs3 dc=0
alter Vh3 dc=0
alter Vs4 dc=1.2
alter Vh4 dc=1.2
alter Vs5 dc=1.2
alter Vh5 dc=1.2
alter Vs6 dc=0
alter Vh6 dc=0
alter Vs7 dc=0
alter Vh7 dc=0
op
echo ROW 0 25.0 48 $&v(xt.vth_soft) $&v(xt.vth_hard) $&v(vref_buf) $&v(isense) $&i(vdda)
alter Vs0 dc=1.2
alter Vh0 dc=1.2
alter Vs1 dc=0
alter Vh1 dc=0
alter Vs2 dc=0
alter Vh2 dc=0
alter Vs3 dc=0
alter Vh3 dc=0
alter Vs4 dc=1.2
alter Vh4 dc=1.2
alter Vs5 dc=1.2
alter Vh5 dc=1.2
alter Vs6 dc=0
alter Vh6 dc=0
alter Vs7 dc=0
alter Vh7 dc=0
op
echo ROW 0 25.0 49 $&v(xt.vth_soft) $&v(xt.vth_hard) $&v(vref_buf) $&v(isense) $&i(vdda)
alter Vs0 dc=0
alter Vh0 dc=0
alter Vs1 dc=1.2
alter Vh1 dc=1.2
alter Vs2 dc=0
alter Vh2 dc=0
alter Vs3 dc=0
alter Vh3 dc=0
alter Vs4 dc=1.2
alter Vh4 dc=1.2
alter Vs5 dc=1.2
alter Vh5 dc=1.2
alter Vs6 dc=0
alter Vh6 dc=0
alter Vs7 dc=0
alter Vh7 dc=0
op
echo ROW 0 25.0 50 $&v(xt.vth_soft) $&v(xt.vth_hard) $&v(vref_buf) $&v(isense) $&i(vdda)
alter Vs0 dc=1.2
alter Vh0 dc=1.2
alter Vs1 dc=1.2
alter Vh1 dc=1.2
alter Vs2 dc=0
alter Vh2 dc=0
alter Vs3 dc=0
alter Vh3 dc=0
alter Vs4 dc=1.2
alter Vh4 dc=1.2
alter Vs5 dc=1.2
alter Vh5 dc=1.2
alter Vs6 dc=0
alter Vh6 dc=0
alter Vs7 dc=0
alter Vh7 dc=0
op
echo ROW 0 25.0 51 $&v(xt.vth_soft) $&v(xt.vth_hard) $&v(vref_buf) $&v(isense) $&i(vdda)
alter Vs0 dc=0
alter Vh0 dc=0
alter Vs1 dc=0
alter Vh1 dc=0
alter Vs2 dc=1.2
alter Vh2 dc=1.2
alter Vs3 dc=0
alter Vh3 dc=0
alter Vs4 dc=1.2
alter Vh4 dc=1.2
alter Vs5 dc=1.2
alter Vh5 dc=1.2
alter Vs6 dc=0
alter Vh6 dc=0
alter Vs7 dc=0
alter Vh7 dc=0
op
echo ROW 0 25.0 52 $&v(xt.vth_soft) $&v(xt.vth_hard) $&v(vref_buf) $&v(isense) $&i(vdda)
alter Vs0 dc=1.2
alter Vh0 dc=1.2
alter Vs1 dc=0
alter Vh1 dc=0
alter Vs2 dc=1.2
alter Vh2 dc=1.2
alter Vs3 dc=0
alter Vh3 dc=0
alter Vs4 dc=1.2
alter Vh4 dc=1.2
alter Vs5 dc=1.2
alter Vh5 dc=1.2
alter Vs6 dc=0
alter Vh6 dc=0
alter Vs7 dc=0
alter Vh7 dc=0
op
echo ROW 0 25.0 53 $&v(xt.vth_soft) $&v(xt.vth_hard) $&v(vref_buf) $&v(isense) $&i(vdda)
alter Vs0 dc=0
alter Vh0 dc=0
alter Vs1 dc=1.2
alter Vh1 dc=1.2
alter Vs2 dc=1.2
alter Vh2 dc=1.2
alter Vs3 dc=0
alter Vh3 dc=0
alter Vs4 dc=1.2
alter Vh4 dc=1.2
alter Vs5 dc=1.2
alter Vh5 dc=1.2
alter Vs6 dc=0
alter Vh6 dc=0
alter Vs7 dc=0
alter Vh7 dc=0
op
echo ROW 0 25.0 54 $&v(xt.vth_soft) $&v(xt.vth_hard) $&v(vref_buf) $&v(isense) $&i(vdda)
alter Vs0 dc=1.2
alter Vh0 dc=1.2
alter Vs1 dc=1.2
alter Vh1 dc=1.2
alter Vs2 dc=1.2
alter Vh2 dc=1.2
alter Vs3 dc=0
alter Vh3 dc=0
alter Vs4 dc=1.2
alter Vh4 dc=1.2
alter Vs5 dc=1.2
alter Vh5 dc=1.2
alter Vs6 dc=0
alter Vh6 dc=0
alter Vs7 dc=0
alter Vh7 dc=0
op
echo ROW 0 25.0 55 $&v(xt.vth_soft) $&v(xt.vth_hard) $&v(vref_buf) $&v(isense) $&i(vdda)
alter Vs0 dc=0
alter Vh0 dc=0
alter Vs1 dc=0
alter Vh1 dc=0
alter Vs2 dc=0
alter Vh2 dc=0
alter Vs3 dc=1.2
alter Vh3 dc=1.2
alter Vs4 dc=1.2
alter Vh4 dc=1.2
alter Vs5 dc=1.2
alter Vh5 dc=1.2
alter Vs6 dc=0
alter Vh6 dc=0
alter Vs7 dc=0
alter Vh7 dc=0
op
echo ROW 0 25.0 56 $&v(xt.vth_soft) $&v(xt.vth_hard) $&v(vref_buf) $&v(isense) $&i(vdda)
alter Vs0 dc=1.2
alter Vh0 dc=1.2
alter Vs1 dc=0
alter Vh1 dc=0
alter Vs2 dc=0
alter Vh2 dc=0
alter Vs3 dc=1.2
alter Vh3 dc=1.2
alter Vs4 dc=1.2
alter Vh4 dc=1.2
alter Vs5 dc=1.2
alter Vh5 dc=1.2
alter Vs6 dc=0
alter Vh6 dc=0
alter Vs7 dc=0
alter Vh7 dc=0
op
echo ROW 0 25.0 57 $&v(xt.vth_soft) $&v(xt.vth_hard) $&v(vref_buf) $&v(isense) $&i(vdda)
alter Vs0 dc=0
alter Vh0 dc=0
alter Vs1 dc=1.2
alter Vh1 dc=1.2
alter Vs2 dc=0
alter Vh2 dc=0
alter Vs3 dc=1.2
alter Vh3 dc=1.2
alter Vs4 dc=1.2
alter Vh4 dc=1.2
alter Vs5 dc=1.2
alter Vh5 dc=1.2
alter Vs6 dc=0
alter Vh6 dc=0
alter Vs7 dc=0
alter Vh7 dc=0
op
echo ROW 0 25.0 58 $&v(xt.vth_soft) $&v(xt.vth_hard) $&v(vref_buf) $&v(isense) $&i(vdda)
alter Vs0 dc=1.2
alter Vh0 dc=1.2
alter Vs1 dc=1.2
alter Vh1 dc=1.2
alter Vs2 dc=0
alter Vh2 dc=0
alter Vs3 dc=1.2
alter Vh3 dc=1.2
alter Vs4 dc=1.2
alter Vh4 dc=1.2
alter Vs5 dc=1.2
alter Vh5 dc=1.2
alter Vs6 dc=0
alter Vh6 dc=0
alter Vs7 dc=0
alter Vh7 dc=0
op
echo ROW 0 25.0 59 $&v(xt.vth_soft) $&v(xt.vth_hard) $&v(vref_buf) $&v(isense) $&i(vdda)
alter Vs0 dc=0
alter Vh0 dc=0
alter Vs1 dc=0
alter Vh1 dc=0
alter Vs2 dc=1.2
alter Vh2 dc=1.2
alter Vs3 dc=1.2
alter Vh3 dc=1.2
alter Vs4 dc=1.2
alter Vh4 dc=1.2
alter Vs5 dc=1.2
alter Vh5 dc=1.2
alter Vs6 dc=0
alter Vh6 dc=0
alter Vs7 dc=0
alter Vh7 dc=0
op
echo ROW 0 25.0 60 $&v(xt.vth_soft) $&v(xt.vth_hard) $&v(vref_buf) $&v(isense) $&i(vdda)
alter Vs0 dc=1.2
alter Vh0 dc=1.2
alter Vs1 dc=0
alter Vh1 dc=0
alter Vs2 dc=1.2
alter Vh2 dc=1.2
alter Vs3 dc=1.2
alter Vh3 dc=1.2
alter Vs4 dc=1.2
alter Vh4 dc=1.2
alter Vs5 dc=1.2
alter Vh5 dc=1.2
alter Vs6 dc=0
alter Vh6 dc=0
alter Vs7 dc=0
alter Vh7 dc=0
op
echo ROW 0 25.0 61 $&v(xt.vth_soft) $&v(xt.vth_hard) $&v(vref_buf) $&v(isense) $&i(vdda)
alter Vs0 dc=0
alter Vh0 dc=0
alter Vs1 dc=1.2
alter Vh1 dc=1.2
alter Vs2 dc=1.2
alter Vh2 dc=1.2
alter Vs3 dc=1.2
alter Vh3 dc=1.2
alter Vs4 dc=1.2
alter Vh4 dc=1.2
alter Vs5 dc=1.2
alter Vh5 dc=1.2
alter Vs6 dc=0
alter Vh6 dc=0
alter Vs7 dc=0
alter Vh7 dc=0
op
echo ROW 0 25.0 62 $&v(xt.vth_soft) $&v(xt.vth_hard) $&v(vref_buf) $&v(isense) $&i(vdda)
alter Vs0 dc=1.2
alter Vh0 dc=1.2
alter Vs1 dc=1.2
alter Vh1 dc=1.2
alter Vs2 dc=1.2
alter Vh2 dc=1.2
alter Vs3 dc=1.2
alter Vh3 dc=1.2
alter Vs4 dc=1.2
alter Vh4 dc=1.2
alter Vs5 dc=1.2
alter Vh5 dc=1.2
alter Vs6 dc=0
alter Vh6 dc=0
alter Vs7 dc=0
alter Vh7 dc=0
op
echo ROW 0 25.0 63 $&v(xt.vth_soft) $&v(xt.vth_hard) $&v(vref_buf) $&v(isense) $&i(vdda)
alter Vs0 dc=0
alter Vh0 dc=0
alter Vs1 dc=0
alter Vh1 dc=0
alter Vs2 dc=0
alter Vh2 dc=0
alter Vs3 dc=0
alter Vh3 dc=0
alter Vs4 dc=0
alter Vh4 dc=0
alter Vs5 dc=0
alter Vh5 dc=0
alter Vs6 dc=1.2
alter Vh6 dc=1.2
alter Vs7 dc=0
alter Vh7 dc=0
op
echo ROW 0 25.0 64 $&v(xt.vth_soft) $&v(xt.vth_hard) $&v(vref_buf) $&v(isense) $&i(vdda)
alter Vs0 dc=1.2
alter Vh0 dc=1.2
alter Vs1 dc=0
alter Vh1 dc=0
alter Vs2 dc=0
alter Vh2 dc=0
alter Vs3 dc=0
alter Vh3 dc=0
alter Vs4 dc=0
alter Vh4 dc=0
alter Vs5 dc=0
alter Vh5 dc=0
alter Vs6 dc=1.2
alter Vh6 dc=1.2
alter Vs7 dc=0
alter Vh7 dc=0
op
echo ROW 0 25.0 65 $&v(xt.vth_soft) $&v(xt.vth_hard) $&v(vref_buf) $&v(isense) $&i(vdda)
alter Vs0 dc=0
alter Vh0 dc=0
alter Vs1 dc=1.2
alter Vh1 dc=1.2
alter Vs2 dc=0
alter Vh2 dc=0
alter Vs3 dc=0
alter Vh3 dc=0
alter Vs4 dc=0
alter Vh4 dc=0
alter Vs5 dc=0
alter Vh5 dc=0
alter Vs6 dc=1.2
alter Vh6 dc=1.2
alter Vs7 dc=0
alter Vh7 dc=0
op
echo ROW 0 25.0 66 $&v(xt.vth_soft) $&v(xt.vth_hard) $&v(vref_buf) $&v(isense) $&i(vdda)
alter Vs0 dc=1.2
alter Vh0 dc=1.2
alter Vs1 dc=1.2
alter Vh1 dc=1.2
alter Vs2 dc=0
alter Vh2 dc=0
alter Vs3 dc=0
alter Vh3 dc=0
alter Vs4 dc=0
alter Vh4 dc=0
alter Vs5 dc=0
alter Vh5 dc=0
alter Vs6 dc=1.2
alter Vh6 dc=1.2
alter Vs7 dc=0
alter Vh7 dc=0
op
echo ROW 0 25.0 67 $&v(xt.vth_soft) $&v(xt.vth_hard) $&v(vref_buf) $&v(isense) $&i(vdda)
alter Vs0 dc=0
alter Vh0 dc=0
alter Vs1 dc=0
alter Vh1 dc=0
alter Vs2 dc=1.2
alter Vh2 dc=1.2
alter Vs3 dc=0
alter Vh3 dc=0
alter Vs4 dc=0
alter Vh4 dc=0
alter Vs5 dc=0
alter Vh5 dc=0
alter Vs6 dc=1.2
alter Vh6 dc=1.2
alter Vs7 dc=0
alter Vh7 dc=0
op
echo ROW 0 25.0 68 $&v(xt.vth_soft) $&v(xt.vth_hard) $&v(vref_buf) $&v(isense) $&i(vdda)
alter Vs0 dc=1.2
alter Vh0 dc=1.2
alter Vs1 dc=0
alter Vh1 dc=0
alter Vs2 dc=1.2
alter Vh2 dc=1.2
alter Vs3 dc=0
alter Vh3 dc=0
alter Vs4 dc=0
alter Vh4 dc=0
alter Vs5 dc=0
alter Vh5 dc=0
alter Vs6 dc=1.2
alter Vh6 dc=1.2
alter Vs7 dc=0
alter Vh7 dc=0
op
echo ROW 0 25.0 69 $&v(xt.vth_soft) $&v(xt.vth_hard) $&v(vref_buf) $&v(isense) $&i(vdda)
alter Vs0 dc=0
alter Vh0 dc=0
alter Vs1 dc=1.2
alter Vh1 dc=1.2
alter Vs2 dc=1.2
alter Vh2 dc=1.2
alter Vs3 dc=0
alter Vh3 dc=0
alter Vs4 dc=0
alter Vh4 dc=0
alter Vs5 dc=0
alter Vh5 dc=0
alter Vs6 dc=1.2
alter Vh6 dc=1.2
alter Vs7 dc=0
alter Vh7 dc=0
op
echo ROW 0 25.0 70 $&v(xt.vth_soft) $&v(xt.vth_hard) $&v(vref_buf) $&v(isense) $&i(vdda)
alter Vs0 dc=1.2
alter Vh0 dc=1.2
alter Vs1 dc=1.2
alter Vh1 dc=1.2
alter Vs2 dc=1.2
alter Vh2 dc=1.2
alter Vs3 dc=0
alter Vh3 dc=0
alter Vs4 dc=0
alter Vh4 dc=0
alter Vs5 dc=0
alter Vh5 dc=0
alter Vs6 dc=1.2
alter Vh6 dc=1.2
alter Vs7 dc=0
alter Vh7 dc=0
op
echo ROW 0 25.0 71 $&v(xt.vth_soft) $&v(xt.vth_hard) $&v(vref_buf) $&v(isense) $&i(vdda)
alter Vs0 dc=0
alter Vh0 dc=0
alter Vs1 dc=0
alter Vh1 dc=0
alter Vs2 dc=0
alter Vh2 dc=0
alter Vs3 dc=1.2
alter Vh3 dc=1.2
alter Vs4 dc=0
alter Vh4 dc=0
alter Vs5 dc=0
alter Vh5 dc=0
alter Vs6 dc=1.2
alter Vh6 dc=1.2
alter Vs7 dc=0
alter Vh7 dc=0
op
echo ROW 0 25.0 72 $&v(xt.vth_soft) $&v(xt.vth_hard) $&v(vref_buf) $&v(isense) $&i(vdda)
alter Vs0 dc=1.2
alter Vh0 dc=1.2
alter Vs1 dc=0
alter Vh1 dc=0
alter Vs2 dc=0
alter Vh2 dc=0
alter Vs3 dc=1.2
alter Vh3 dc=1.2
alter Vs4 dc=0
alter Vh4 dc=0
alter Vs5 dc=0
alter Vh5 dc=0
alter Vs6 dc=1.2
alter Vh6 dc=1.2
alter Vs7 dc=0
alter Vh7 dc=0
op
echo ROW 0 25.0 73 $&v(xt.vth_soft) $&v(xt.vth_hard) $&v(vref_buf) $&v(isense) $&i(vdda)
alter Vs0 dc=0
alter Vh0 dc=0
alter Vs1 dc=1.2
alter Vh1 dc=1.2
alter Vs2 dc=0
alter Vh2 dc=0
alter Vs3 dc=1.2
alter Vh3 dc=1.2
alter Vs4 dc=0
alter Vh4 dc=0
alter Vs5 dc=0
alter Vh5 dc=0
alter Vs6 dc=1.2
alter Vh6 dc=1.2
alter Vs7 dc=0
alter Vh7 dc=0
op
echo ROW 0 25.0 74 $&v(xt.vth_soft) $&v(xt.vth_hard) $&v(vref_buf) $&v(isense) $&i(vdda)
alter Vs0 dc=1.2
alter Vh0 dc=1.2
alter Vs1 dc=1.2
alter Vh1 dc=1.2
alter Vs2 dc=0
alter Vh2 dc=0
alter Vs3 dc=1.2
alter Vh3 dc=1.2
alter Vs4 dc=0
alter Vh4 dc=0
alter Vs5 dc=0
alter Vh5 dc=0
alter Vs6 dc=1.2
alter Vh6 dc=1.2
alter Vs7 dc=0
alter Vh7 dc=0
op
echo ROW 0 25.0 75 $&v(xt.vth_soft) $&v(xt.vth_hard) $&v(vref_buf) $&v(isense) $&i(vdda)
alter Vs0 dc=0
alter Vh0 dc=0
alter Vs1 dc=0
alter Vh1 dc=0
alter Vs2 dc=1.2
alter Vh2 dc=1.2
alter Vs3 dc=1.2
alter Vh3 dc=1.2
alter Vs4 dc=0
alter Vh4 dc=0
alter Vs5 dc=0
alter Vh5 dc=0
alter Vs6 dc=1.2
alter Vh6 dc=1.2
alter Vs7 dc=0
alter Vh7 dc=0
op
echo ROW 0 25.0 76 $&v(xt.vth_soft) $&v(xt.vth_hard) $&v(vref_buf) $&v(isense) $&i(vdda)
alter Vs0 dc=1.2
alter Vh0 dc=1.2
alter Vs1 dc=0
alter Vh1 dc=0
alter Vs2 dc=1.2
alter Vh2 dc=1.2
alter Vs3 dc=1.2
alter Vh3 dc=1.2
alter Vs4 dc=0
alter Vh4 dc=0
alter Vs5 dc=0
alter Vh5 dc=0
alter Vs6 dc=1.2
alter Vh6 dc=1.2
alter Vs7 dc=0
alter Vh7 dc=0
op
echo ROW 0 25.0 77 $&v(xt.vth_soft) $&v(xt.vth_hard) $&v(vref_buf) $&v(isense) $&i(vdda)
alter Vs0 dc=0
alter Vh0 dc=0
alter Vs1 dc=1.2
alter Vh1 dc=1.2
alter Vs2 dc=1.2
alter Vh2 dc=1.2
alter Vs3 dc=1.2
alter Vh3 dc=1.2
alter Vs4 dc=0
alter Vh4 dc=0
alter Vs5 dc=0
alter Vh5 dc=0
alter Vs6 dc=1.2
alter Vh6 dc=1.2
alter Vs7 dc=0
alter Vh7 dc=0
op
echo ROW 0 25.0 78 $&v(xt.vth_soft) $&v(xt.vth_hard) $&v(vref_buf) $&v(isense) $&i(vdda)
alter Vs0 dc=1.2
alter Vh0 dc=1.2
alter Vs1 dc=1.2
alter Vh1 dc=1.2
alter Vs2 dc=1.2
alter Vh2 dc=1.2
alter Vs3 dc=1.2
alter Vh3 dc=1.2
alter Vs4 dc=0
alter Vh4 dc=0
alter Vs5 dc=0
alter Vh5 dc=0
alter Vs6 dc=1.2
alter Vh6 dc=1.2
alter Vs7 dc=0
alter Vh7 dc=0
op
echo ROW 0 25.0 79 $&v(xt.vth_soft) $&v(xt.vth_hard) $&v(vref_buf) $&v(isense) $&i(vdda)
alter Vs0 dc=0
alter Vh0 dc=0
alter Vs1 dc=0
alter Vh1 dc=0
alter Vs2 dc=0
alter Vh2 dc=0
alter Vs3 dc=0
alter Vh3 dc=0
alter Vs4 dc=1.2
alter Vh4 dc=1.2
alter Vs5 dc=0
alter Vh5 dc=0
alter Vs6 dc=1.2
alter Vh6 dc=1.2
alter Vs7 dc=0
alter Vh7 dc=0
op
echo ROW 0 25.0 80 $&v(xt.vth_soft) $&v(xt.vth_hard) $&v(vref_buf) $&v(isense) $&i(vdda)
alter Vs0 dc=1.2
alter Vh0 dc=1.2
alter Vs1 dc=0
alter Vh1 dc=0
alter Vs2 dc=0
alter Vh2 dc=0
alter Vs3 dc=0
alter Vh3 dc=0
alter Vs4 dc=1.2
alter Vh4 dc=1.2
alter Vs5 dc=0
alter Vh5 dc=0
alter Vs6 dc=1.2
alter Vh6 dc=1.2
alter Vs7 dc=0
alter Vh7 dc=0
op
echo ROW 0 25.0 81 $&v(xt.vth_soft) $&v(xt.vth_hard) $&v(vref_buf) $&v(isense) $&i(vdda)
alter Vs0 dc=0
alter Vh0 dc=0
alter Vs1 dc=1.2
alter Vh1 dc=1.2
alter Vs2 dc=0
alter Vh2 dc=0
alter Vs3 dc=0
alter Vh3 dc=0
alter Vs4 dc=1.2
alter Vh4 dc=1.2
alter Vs5 dc=0
alter Vh5 dc=0
alter Vs6 dc=1.2
alter Vh6 dc=1.2
alter Vs7 dc=0
alter Vh7 dc=0
op
echo ROW 0 25.0 82 $&v(xt.vth_soft) $&v(xt.vth_hard) $&v(vref_buf) $&v(isense) $&i(vdda)
alter Vs0 dc=1.2
alter Vh0 dc=1.2
alter Vs1 dc=1.2
alter Vh1 dc=1.2
alter Vs2 dc=0
alter Vh2 dc=0
alter Vs3 dc=0
alter Vh3 dc=0
alter Vs4 dc=1.2
alter Vh4 dc=1.2
alter Vs5 dc=0
alter Vh5 dc=0
alter Vs6 dc=1.2
alter Vh6 dc=1.2
alter Vs7 dc=0
alter Vh7 dc=0
op
echo ROW 0 25.0 83 $&v(xt.vth_soft) $&v(xt.vth_hard) $&v(vref_buf) $&v(isense) $&i(vdda)
alter Vs0 dc=0
alter Vh0 dc=0
alter Vs1 dc=0
alter Vh1 dc=0
alter Vs2 dc=1.2
alter Vh2 dc=1.2
alter Vs3 dc=0
alter Vh3 dc=0
alter Vs4 dc=1.2
alter Vh4 dc=1.2
alter Vs5 dc=0
alter Vh5 dc=0
alter Vs6 dc=1.2
alter Vh6 dc=1.2
alter Vs7 dc=0
alter Vh7 dc=0
op
echo ROW 0 25.0 84 $&v(xt.vth_soft) $&v(xt.vth_hard) $&v(vref_buf) $&v(isense) $&i(vdda)
alter Vs0 dc=1.2
alter Vh0 dc=1.2
alter Vs1 dc=0
alter Vh1 dc=0
alter Vs2 dc=1.2
alter Vh2 dc=1.2
alter Vs3 dc=0
alter Vh3 dc=0
alter Vs4 dc=1.2
alter Vh4 dc=1.2
alter Vs5 dc=0
alter Vh5 dc=0
alter Vs6 dc=1.2
alter Vh6 dc=1.2
alter Vs7 dc=0
alter Vh7 dc=0
op
echo ROW 0 25.0 85 $&v(xt.vth_soft) $&v(xt.vth_hard) $&v(vref_buf) $&v(isense) $&i(vdda)
alter Vs0 dc=0
alter Vh0 dc=0
alter Vs1 dc=1.2
alter Vh1 dc=1.2
alter Vs2 dc=1.2
alter Vh2 dc=1.2
alter Vs3 dc=0
alter Vh3 dc=0
alter Vs4 dc=1.2
alter Vh4 dc=1.2
alter Vs5 dc=0
alter Vh5 dc=0
alter Vs6 dc=1.2
alter Vh6 dc=1.2
alter Vs7 dc=0
alter Vh7 dc=0
op
echo ROW 0 25.0 86 $&v(xt.vth_soft) $&v(xt.vth_hard) $&v(vref_buf) $&v(isense) $&i(vdda)
alter Vs0 dc=1.2
alter Vh0 dc=1.2
alter Vs1 dc=1.2
alter Vh1 dc=1.2
alter Vs2 dc=1.2
alter Vh2 dc=1.2
alter Vs3 dc=0
alter Vh3 dc=0
alter Vs4 dc=1.2
alter Vh4 dc=1.2
alter Vs5 dc=0
alter Vh5 dc=0
alter Vs6 dc=1.2
alter Vh6 dc=1.2
alter Vs7 dc=0
alter Vh7 dc=0
op
echo ROW 0 25.0 87 $&v(xt.vth_soft) $&v(xt.vth_hard) $&v(vref_buf) $&v(isense) $&i(vdda)
alter Vs0 dc=0
alter Vh0 dc=0
alter Vs1 dc=0
alter Vh1 dc=0
alter Vs2 dc=0
alter Vh2 dc=0
alter Vs3 dc=1.2
alter Vh3 dc=1.2
alter Vs4 dc=1.2
alter Vh4 dc=1.2
alter Vs5 dc=0
alter Vh5 dc=0
alter Vs6 dc=1.2
alter Vh6 dc=1.2
alter Vs7 dc=0
alter Vh7 dc=0
op
echo ROW 0 25.0 88 $&v(xt.vth_soft) $&v(xt.vth_hard) $&v(vref_buf) $&v(isense) $&i(vdda)
alter Vs0 dc=1.2
alter Vh0 dc=1.2
alter Vs1 dc=0
alter Vh1 dc=0
alter Vs2 dc=0
alter Vh2 dc=0
alter Vs3 dc=1.2
alter Vh3 dc=1.2
alter Vs4 dc=1.2
alter Vh4 dc=1.2
alter Vs5 dc=0
alter Vh5 dc=0
alter Vs6 dc=1.2
alter Vh6 dc=1.2
alter Vs7 dc=0
alter Vh7 dc=0
op
echo ROW 0 25.0 89 $&v(xt.vth_soft) $&v(xt.vth_hard) $&v(vref_buf) $&v(isense) $&i(vdda)
alter Vs0 dc=0
alter Vh0 dc=0
alter Vs1 dc=1.2
alter Vh1 dc=1.2
alter Vs2 dc=0
alter Vh2 dc=0
alter Vs3 dc=1.2
alter Vh3 dc=1.2
alter Vs4 dc=1.2
alter Vh4 dc=1.2
alter Vs5 dc=0
alter Vh5 dc=0
alter Vs6 dc=1.2
alter Vh6 dc=1.2
alter Vs7 dc=0
alter Vh7 dc=0
op
echo ROW 0 25.0 90 $&v(xt.vth_soft) $&v(xt.vth_hard) $&v(vref_buf) $&v(isense) $&i(vdda)
alter Vs0 dc=1.2
alter Vh0 dc=1.2
alter Vs1 dc=1.2
alter Vh1 dc=1.2
alter Vs2 dc=0
alter Vh2 dc=0
alter Vs3 dc=1.2
alter Vh3 dc=1.2
alter Vs4 dc=1.2
alter Vh4 dc=1.2
alter Vs5 dc=0
alter Vh5 dc=0
alter Vs6 dc=1.2
alter Vh6 dc=1.2
alter Vs7 dc=0
alter Vh7 dc=0
op
echo ROW 0 25.0 91 $&v(xt.vth_soft) $&v(xt.vth_hard) $&v(vref_buf) $&v(isense) $&i(vdda)
alter Vs0 dc=0
alter Vh0 dc=0
alter Vs1 dc=0
alter Vh1 dc=0
alter Vs2 dc=1.2
alter Vh2 dc=1.2
alter Vs3 dc=1.2
alter Vh3 dc=1.2
alter Vs4 dc=1.2
alter Vh4 dc=1.2
alter Vs5 dc=0
alter Vh5 dc=0
alter Vs6 dc=1.2
alter Vh6 dc=1.2
alter Vs7 dc=0
alter Vh7 dc=0
op
echo ROW 0 25.0 92 $&v(xt.vth_soft) $&v(xt.vth_hard) $&v(vref_buf) $&v(isense) $&i(vdda)
alter Vs0 dc=1.2
alter Vh0 dc=1.2
alter Vs1 dc=0
alter Vh1 dc=0
alter Vs2 dc=1.2
alter Vh2 dc=1.2
alter Vs3 dc=1.2
alter Vh3 dc=1.2
alter Vs4 dc=1.2
alter Vh4 dc=1.2
alter Vs5 dc=0
alter Vh5 dc=0
alter Vs6 dc=1.2
alter Vh6 dc=1.2
alter Vs7 dc=0
alter Vh7 dc=0
op
echo ROW 0 25.0 93 $&v(xt.vth_soft) $&v(xt.vth_hard) $&v(vref_buf) $&v(isense) $&i(vdda)
alter Vs0 dc=0
alter Vh0 dc=0
alter Vs1 dc=1.2
alter Vh1 dc=1.2
alter Vs2 dc=1.2
alter Vh2 dc=1.2
alter Vs3 dc=1.2
alter Vh3 dc=1.2
alter Vs4 dc=1.2
alter Vh4 dc=1.2
alter Vs5 dc=0
alter Vh5 dc=0
alter Vs6 dc=1.2
alter Vh6 dc=1.2
alter Vs7 dc=0
alter Vh7 dc=0
op
echo ROW 0 25.0 94 $&v(xt.vth_soft) $&v(xt.vth_hard) $&v(vref_buf) $&v(isense) $&i(vdda)
alter Vs0 dc=1.2
alter Vh0 dc=1.2
alter Vs1 dc=1.2
alter Vh1 dc=1.2
alter Vs2 dc=1.2
alter Vh2 dc=1.2
alter Vs3 dc=1.2
alter Vh3 dc=1.2
alter Vs4 dc=1.2
alter Vh4 dc=1.2
alter Vs5 dc=0
alter Vh5 dc=0
alter Vs6 dc=1.2
alter Vh6 dc=1.2
alter Vs7 dc=0
alter Vh7 dc=0
op
echo ROW 0 25.0 95 $&v(xt.vth_soft) $&v(xt.vth_hard) $&v(vref_buf) $&v(isense) $&i(vdda)
alter Vs0 dc=0
alter Vh0 dc=0
alter Vs1 dc=0
alter Vh1 dc=0
alter Vs2 dc=0
alter Vh2 dc=0
alter Vs3 dc=0
alter Vh3 dc=0
alter Vs4 dc=0
alter Vh4 dc=0
alter Vs5 dc=1.2
alter Vh5 dc=1.2
alter Vs6 dc=1.2
alter Vh6 dc=1.2
alter Vs7 dc=0
alter Vh7 dc=0
op
echo ROW 0 25.0 96 $&v(xt.vth_soft) $&v(xt.vth_hard) $&v(vref_buf) $&v(isense) $&i(vdda)
alter Vs0 dc=1.2
alter Vh0 dc=1.2
alter Vs1 dc=0
alter Vh1 dc=0
alter Vs2 dc=0
alter Vh2 dc=0
alter Vs3 dc=0
alter Vh3 dc=0
alter Vs4 dc=0
alter Vh4 dc=0
alter Vs5 dc=1.2
alter Vh5 dc=1.2
alter Vs6 dc=1.2
alter Vh6 dc=1.2
alter Vs7 dc=0
alter Vh7 dc=0
op
echo ROW 0 25.0 97 $&v(xt.vth_soft) $&v(xt.vth_hard) $&v(vref_buf) $&v(isense) $&i(vdda)
alter Vs0 dc=0
alter Vh0 dc=0
alter Vs1 dc=1.2
alter Vh1 dc=1.2
alter Vs2 dc=0
alter Vh2 dc=0
alter Vs3 dc=0
alter Vh3 dc=0
alter Vs4 dc=0
alter Vh4 dc=0
alter Vs5 dc=1.2
alter Vh5 dc=1.2
alter Vs6 dc=1.2
alter Vh6 dc=1.2
alter Vs7 dc=0
alter Vh7 dc=0
op
echo ROW 0 25.0 98 $&v(xt.vth_soft) $&v(xt.vth_hard) $&v(vref_buf) $&v(isense) $&i(vdda)
alter Vs0 dc=1.2
alter Vh0 dc=1.2
alter Vs1 dc=1.2
alter Vh1 dc=1.2
alter Vs2 dc=0
alter Vh2 dc=0
alter Vs3 dc=0
alter Vh3 dc=0
alter Vs4 dc=0
alter Vh4 dc=0
alter Vs5 dc=1.2
alter Vh5 dc=1.2
alter Vs6 dc=1.2
alter Vh6 dc=1.2
alter Vs7 dc=0
alter Vh7 dc=0
op
echo ROW 0 25.0 99 $&v(xt.vth_soft) $&v(xt.vth_hard) $&v(vref_buf) $&v(isense) $&i(vdda)
alter Vs0 dc=0
alter Vh0 dc=0
alter Vs1 dc=0
alter Vh1 dc=0
alter Vs2 dc=1.2
alter Vh2 dc=1.2
alter Vs3 dc=0
alter Vh3 dc=0
alter Vs4 dc=0
alter Vh4 dc=0
alter Vs5 dc=1.2
alter Vh5 dc=1.2
alter Vs6 dc=1.2
alter Vh6 dc=1.2
alter Vs7 dc=0
alter Vh7 dc=0
op
echo ROW 0 25.0 100 $&v(xt.vth_soft) $&v(xt.vth_hard) $&v(vref_buf) $&v(isense) $&i(vdda)
alter Vs0 dc=1.2
alter Vh0 dc=1.2
alter Vs1 dc=0
alter Vh1 dc=0
alter Vs2 dc=1.2
alter Vh2 dc=1.2
alter Vs3 dc=0
alter Vh3 dc=0
alter Vs4 dc=0
alter Vh4 dc=0
alter Vs5 dc=1.2
alter Vh5 dc=1.2
alter Vs6 dc=1.2
alter Vh6 dc=1.2
alter Vs7 dc=0
alter Vh7 dc=0
op
echo ROW 0 25.0 101 $&v(xt.vth_soft) $&v(xt.vth_hard) $&v(vref_buf) $&v(isense) $&i(vdda)
alter Vs0 dc=0
alter Vh0 dc=0
alter Vs1 dc=1.2
alter Vh1 dc=1.2
alter Vs2 dc=1.2
alter Vh2 dc=1.2
alter Vs3 dc=0
alter Vh3 dc=0
alter Vs4 dc=0
alter Vh4 dc=0
alter Vs5 dc=1.2
alter Vh5 dc=1.2
alter Vs6 dc=1.2
alter Vh6 dc=1.2
alter Vs7 dc=0
alter Vh7 dc=0
op
echo ROW 0 25.0 102 $&v(xt.vth_soft) $&v(xt.vth_hard) $&v(vref_buf) $&v(isense) $&i(vdda)
alter Vs0 dc=1.2
alter Vh0 dc=1.2
alter Vs1 dc=1.2
alter Vh1 dc=1.2
alter Vs2 dc=1.2
alter Vh2 dc=1.2
alter Vs3 dc=0
alter Vh3 dc=0
alter Vs4 dc=0
alter Vh4 dc=0
alter Vs5 dc=1.2
alter Vh5 dc=1.2
alter Vs6 dc=1.2
alter Vh6 dc=1.2
alter Vs7 dc=0
alter Vh7 dc=0
op
echo ROW 0 25.0 103 $&v(xt.vth_soft) $&v(xt.vth_hard) $&v(vref_buf) $&v(isense) $&i(vdda)
alter Vs0 dc=0
alter Vh0 dc=0
alter Vs1 dc=0
alter Vh1 dc=0
alter Vs2 dc=0
alter Vh2 dc=0
alter Vs3 dc=1.2
alter Vh3 dc=1.2
alter Vs4 dc=0
alter Vh4 dc=0
alter Vs5 dc=1.2
alter Vh5 dc=1.2
alter Vs6 dc=1.2
alter Vh6 dc=1.2
alter Vs7 dc=0
alter Vh7 dc=0
op
echo ROW 0 25.0 104 $&v(xt.vth_soft) $&v(xt.vth_hard) $&v(vref_buf) $&v(isense) $&i(vdda)
alter Vs0 dc=1.2
alter Vh0 dc=1.2
alter Vs1 dc=0
alter Vh1 dc=0
alter Vs2 dc=0
alter Vh2 dc=0
alter Vs3 dc=1.2
alter Vh3 dc=1.2
alter Vs4 dc=0
alter Vh4 dc=0
alter Vs5 dc=1.2
alter Vh5 dc=1.2
alter Vs6 dc=1.2
alter Vh6 dc=1.2
alter Vs7 dc=0
alter Vh7 dc=0
op
echo ROW 0 25.0 105 $&v(xt.vth_soft) $&v(xt.vth_hard) $&v(vref_buf) $&v(isense) $&i(vdda)
alter Vs0 dc=0
alter Vh0 dc=0
alter Vs1 dc=1.2
alter Vh1 dc=1.2
alter Vs2 dc=0
alter Vh2 dc=0
alter Vs3 dc=1.2
alter Vh3 dc=1.2
alter Vs4 dc=0
alter Vh4 dc=0
alter Vs5 dc=1.2
alter Vh5 dc=1.2
alter Vs6 dc=1.2
alter Vh6 dc=1.2
alter Vs7 dc=0
alter Vh7 dc=0
op
echo ROW 0 25.0 106 $&v(xt.vth_soft) $&v(xt.vth_hard) $&v(vref_buf) $&v(isense) $&i(vdda)
alter Vs0 dc=1.2
alter Vh0 dc=1.2
alter Vs1 dc=1.2
alter Vh1 dc=1.2
alter Vs2 dc=0
alter Vh2 dc=0
alter Vs3 dc=1.2
alter Vh3 dc=1.2
alter Vs4 dc=0
alter Vh4 dc=0
alter Vs5 dc=1.2
alter Vh5 dc=1.2
alter Vs6 dc=1.2
alter Vh6 dc=1.2
alter Vs7 dc=0
alter Vh7 dc=0
op
echo ROW 0 25.0 107 $&v(xt.vth_soft) $&v(xt.vth_hard) $&v(vref_buf) $&v(isense) $&i(vdda)
alter Vs0 dc=0
alter Vh0 dc=0
alter Vs1 dc=0
alter Vh1 dc=0
alter Vs2 dc=1.2
alter Vh2 dc=1.2
alter Vs3 dc=1.2
alter Vh3 dc=1.2
alter Vs4 dc=0
alter Vh4 dc=0
alter Vs5 dc=1.2
alter Vh5 dc=1.2
alter Vs6 dc=1.2
alter Vh6 dc=1.2
alter Vs7 dc=0
alter Vh7 dc=0
op
echo ROW 0 25.0 108 $&v(xt.vth_soft) $&v(xt.vth_hard) $&v(vref_buf) $&v(isense) $&i(vdda)
alter Vs0 dc=1.2
alter Vh0 dc=1.2
alter Vs1 dc=0
alter Vh1 dc=0
alter Vs2 dc=1.2
alter Vh2 dc=1.2
alter Vs3 dc=1.2
alter Vh3 dc=1.2
alter Vs4 dc=0
alter Vh4 dc=0
alter Vs5 dc=1.2
alter Vh5 dc=1.2
alter Vs6 dc=1.2
alter Vh6 dc=1.2
alter Vs7 dc=0
alter Vh7 dc=0
op
echo ROW 0 25.0 109 $&v(xt.vth_soft) $&v(xt.vth_hard) $&v(vref_buf) $&v(isense) $&i(vdda)
alter Vs0 dc=0
alter Vh0 dc=0
alter Vs1 dc=1.2
alter Vh1 dc=1.2
alter Vs2 dc=1.2
alter Vh2 dc=1.2
alter Vs3 dc=1.2
alter Vh3 dc=1.2
alter Vs4 dc=0
alter Vh4 dc=0
alter Vs5 dc=1.2
alter Vh5 dc=1.2
alter Vs6 dc=1.2
alter Vh6 dc=1.2
alter Vs7 dc=0
alter Vh7 dc=0
op
echo ROW 0 25.0 110 $&v(xt.vth_soft) $&v(xt.vth_hard) $&v(vref_buf) $&v(isense) $&i(vdda)
alter Vs0 dc=1.2
alter Vh0 dc=1.2
alter Vs1 dc=1.2
alter Vh1 dc=1.2
alter Vs2 dc=1.2
alter Vh2 dc=1.2
alter Vs3 dc=1.2
alter Vh3 dc=1.2
alter Vs4 dc=0
alter Vh4 dc=0
alter Vs5 dc=1.2
alter Vh5 dc=1.2
alter Vs6 dc=1.2
alter Vh6 dc=1.2
alter Vs7 dc=0
alter Vh7 dc=0
op
echo ROW 0 25.0 111 $&v(xt.vth_soft) $&v(xt.vth_hard) $&v(vref_buf) $&v(isense) $&i(vdda)
alter Vs0 dc=0
alter Vh0 dc=0
alter Vs1 dc=0
alter Vh1 dc=0
alter Vs2 dc=0
alter Vh2 dc=0
alter Vs3 dc=0
alter Vh3 dc=0
alter Vs4 dc=1.2
alter Vh4 dc=1.2
alter Vs5 dc=1.2
alter Vh5 dc=1.2
alter Vs6 dc=1.2
alter Vh6 dc=1.2
alter Vs7 dc=0
alter Vh7 dc=0
op
echo ROW 0 25.0 112 $&v(xt.vth_soft) $&v(xt.vth_hard) $&v(vref_buf) $&v(isense) $&i(vdda)
alter Vs0 dc=1.2
alter Vh0 dc=1.2
alter Vs1 dc=0
alter Vh1 dc=0
alter Vs2 dc=0
alter Vh2 dc=0
alter Vs3 dc=0
alter Vh3 dc=0
alter Vs4 dc=1.2
alter Vh4 dc=1.2
alter Vs5 dc=1.2
alter Vh5 dc=1.2
alter Vs6 dc=1.2
alter Vh6 dc=1.2
alter Vs7 dc=0
alter Vh7 dc=0
op
echo ROW 0 25.0 113 $&v(xt.vth_soft) $&v(xt.vth_hard) $&v(vref_buf) $&v(isense) $&i(vdda)
alter Vs0 dc=0
alter Vh0 dc=0
alter Vs1 dc=1.2
alter Vh1 dc=1.2
alter Vs2 dc=0
alter Vh2 dc=0
alter Vs3 dc=0
alter Vh3 dc=0
alter Vs4 dc=1.2
alter Vh4 dc=1.2
alter Vs5 dc=1.2
alter Vh5 dc=1.2
alter Vs6 dc=1.2
alter Vh6 dc=1.2
alter Vs7 dc=0
alter Vh7 dc=0
op
echo ROW 0 25.0 114 $&v(xt.vth_soft) $&v(xt.vth_hard) $&v(vref_buf) $&v(isense) $&i(vdda)
alter Vs0 dc=1.2
alter Vh0 dc=1.2
alter Vs1 dc=1.2
alter Vh1 dc=1.2
alter Vs2 dc=0
alter Vh2 dc=0
alter Vs3 dc=0
alter Vh3 dc=0
alter Vs4 dc=1.2
alter Vh4 dc=1.2
alter Vs5 dc=1.2
alter Vh5 dc=1.2
alter Vs6 dc=1.2
alter Vh6 dc=1.2
alter Vs7 dc=0
alter Vh7 dc=0
op
echo ROW 0 25.0 115 $&v(xt.vth_soft) $&v(xt.vth_hard) $&v(vref_buf) $&v(isense) $&i(vdda)
alter Vs0 dc=0
alter Vh0 dc=0
alter Vs1 dc=0
alter Vh1 dc=0
alter Vs2 dc=1.2
alter Vh2 dc=1.2
alter Vs3 dc=0
alter Vh3 dc=0
alter Vs4 dc=1.2
alter Vh4 dc=1.2
alter Vs5 dc=1.2
alter Vh5 dc=1.2
alter Vs6 dc=1.2
alter Vh6 dc=1.2
alter Vs7 dc=0
alter Vh7 dc=0
op
echo ROW 0 25.0 116 $&v(xt.vth_soft) $&v(xt.vth_hard) $&v(vref_buf) $&v(isense) $&i(vdda)
alter Vs0 dc=1.2
alter Vh0 dc=1.2
alter Vs1 dc=0
alter Vh1 dc=0
alter Vs2 dc=1.2
alter Vh2 dc=1.2
alter Vs3 dc=0
alter Vh3 dc=0
alter Vs4 dc=1.2
alter Vh4 dc=1.2
alter Vs5 dc=1.2
alter Vh5 dc=1.2
alter Vs6 dc=1.2
alter Vh6 dc=1.2
alter Vs7 dc=0
alter Vh7 dc=0
op
echo ROW 0 25.0 117 $&v(xt.vth_soft) $&v(xt.vth_hard) $&v(vref_buf) $&v(isense) $&i(vdda)
alter Vs0 dc=0
alter Vh0 dc=0
alter Vs1 dc=1.2
alter Vh1 dc=1.2
alter Vs2 dc=1.2
alter Vh2 dc=1.2
alter Vs3 dc=0
alter Vh3 dc=0
alter Vs4 dc=1.2
alter Vh4 dc=1.2
alter Vs5 dc=1.2
alter Vh5 dc=1.2
alter Vs6 dc=1.2
alter Vh6 dc=1.2
alter Vs7 dc=0
alter Vh7 dc=0
op
echo ROW 0 25.0 118 $&v(xt.vth_soft) $&v(xt.vth_hard) $&v(vref_buf) $&v(isense) $&i(vdda)
alter Vs0 dc=1.2
alter Vh0 dc=1.2
alter Vs1 dc=1.2
alter Vh1 dc=1.2
alter Vs2 dc=1.2
alter Vh2 dc=1.2
alter Vs3 dc=0
alter Vh3 dc=0
alter Vs4 dc=1.2
alter Vh4 dc=1.2
alter Vs5 dc=1.2
alter Vh5 dc=1.2
alter Vs6 dc=1.2
alter Vh6 dc=1.2
alter Vs7 dc=0
alter Vh7 dc=0
op
echo ROW 0 25.0 119 $&v(xt.vth_soft) $&v(xt.vth_hard) $&v(vref_buf) $&v(isense) $&i(vdda)
alter Vs0 dc=0
alter Vh0 dc=0
alter Vs1 dc=0
alter Vh1 dc=0
alter Vs2 dc=0
alter Vh2 dc=0
alter Vs3 dc=1.2
alter Vh3 dc=1.2
alter Vs4 dc=1.2
alter Vh4 dc=1.2
alter Vs5 dc=1.2
alter Vh5 dc=1.2
alter Vs6 dc=1.2
alter Vh6 dc=1.2
alter Vs7 dc=0
alter Vh7 dc=0
op
echo ROW 0 25.0 120 $&v(xt.vth_soft) $&v(xt.vth_hard) $&v(vref_buf) $&v(isense) $&i(vdda)
alter Vs0 dc=1.2
alter Vh0 dc=1.2
alter Vs1 dc=0
alter Vh1 dc=0
alter Vs2 dc=0
alter Vh2 dc=0
alter Vs3 dc=1.2
alter Vh3 dc=1.2
alter Vs4 dc=1.2
alter Vh4 dc=1.2
alter Vs5 dc=1.2
alter Vh5 dc=1.2
alter Vs6 dc=1.2
alter Vh6 dc=1.2
alter Vs7 dc=0
alter Vh7 dc=0
op
echo ROW 0 25.0 121 $&v(xt.vth_soft) $&v(xt.vth_hard) $&v(vref_buf) $&v(isense) $&i(vdda)
alter Vs0 dc=0
alter Vh0 dc=0
alter Vs1 dc=1.2
alter Vh1 dc=1.2
alter Vs2 dc=0
alter Vh2 dc=0
alter Vs3 dc=1.2
alter Vh3 dc=1.2
alter Vs4 dc=1.2
alter Vh4 dc=1.2
alter Vs5 dc=1.2
alter Vh5 dc=1.2
alter Vs6 dc=1.2
alter Vh6 dc=1.2
alter Vs7 dc=0
alter Vh7 dc=0
op
echo ROW 0 25.0 122 $&v(xt.vth_soft) $&v(xt.vth_hard) $&v(vref_buf) $&v(isense) $&i(vdda)
alter Vs0 dc=1.2
alter Vh0 dc=1.2
alter Vs1 dc=1.2
alter Vh1 dc=1.2
alter Vs2 dc=0
alter Vh2 dc=0
alter Vs3 dc=1.2
alter Vh3 dc=1.2
alter Vs4 dc=1.2
alter Vh4 dc=1.2
alter Vs5 dc=1.2
alter Vh5 dc=1.2
alter Vs6 dc=1.2
alter Vh6 dc=1.2
alter Vs7 dc=0
alter Vh7 dc=0
op
echo ROW 0 25.0 123 $&v(xt.vth_soft) $&v(xt.vth_hard) $&v(vref_buf) $&v(isense) $&i(vdda)
alter Vs0 dc=0
alter Vh0 dc=0
alter Vs1 dc=0
alter Vh1 dc=0
alter Vs2 dc=1.2
alter Vh2 dc=1.2
alter Vs3 dc=1.2
alter Vh3 dc=1.2
alter Vs4 dc=1.2
alter Vh4 dc=1.2
alter Vs5 dc=1.2
alter Vh5 dc=1.2
alter Vs6 dc=1.2
alter Vh6 dc=1.2
alter Vs7 dc=0
alter Vh7 dc=0
op
echo ROW 0 25.0 124 $&v(xt.vth_soft) $&v(xt.vth_hard) $&v(vref_buf) $&v(isense) $&i(vdda)
alter Vs0 dc=1.2
alter Vh0 dc=1.2
alter Vs1 dc=0
alter Vh1 dc=0
alter Vs2 dc=1.2
alter Vh2 dc=1.2
alter Vs3 dc=1.2
alter Vh3 dc=1.2
alter Vs4 dc=1.2
alter Vh4 dc=1.2
alter Vs5 dc=1.2
alter Vh5 dc=1.2
alter Vs6 dc=1.2
alter Vh6 dc=1.2
alter Vs7 dc=0
alter Vh7 dc=0
op
echo ROW 0 25.0 125 $&v(xt.vth_soft) $&v(xt.vth_hard) $&v(vref_buf) $&v(isense) $&i(vdda)
alter Vs0 dc=0
alter Vh0 dc=0
alter Vs1 dc=1.2
alter Vh1 dc=1.2
alter Vs2 dc=1.2
alter Vh2 dc=1.2
alter Vs3 dc=1.2
alter Vh3 dc=1.2
alter Vs4 dc=1.2
alter Vh4 dc=1.2
alter Vs5 dc=1.2
alter Vh5 dc=1.2
alter Vs6 dc=1.2
alter Vh6 dc=1.2
alter Vs7 dc=0
alter Vh7 dc=0
op
echo ROW 0 25.0 126 $&v(xt.vth_soft) $&v(xt.vth_hard) $&v(vref_buf) $&v(isense) $&i(vdda)
alter Vs0 dc=1.2
alter Vh0 dc=1.2
alter Vs1 dc=1.2
alter Vh1 dc=1.2
alter Vs2 dc=1.2
alter Vh2 dc=1.2
alter Vs3 dc=1.2
alter Vh3 dc=1.2
alter Vs4 dc=1.2
alter Vh4 dc=1.2
alter Vs5 dc=1.2
alter Vh5 dc=1.2
alter Vs6 dc=1.2
alter Vh6 dc=1.2
alter Vs7 dc=0
alter Vh7 dc=0
op
echo ROW 0 25.0 127 $&v(xt.vth_soft) $&v(xt.vth_hard) $&v(vref_buf) $&v(isense) $&i(vdda)
alter Vs0 dc=0
alter Vh0 dc=0
alter Vs1 dc=0
alter Vh1 dc=0
alter Vs2 dc=0
alter Vh2 dc=0
alter Vs3 dc=0
alter Vh3 dc=0
alter Vs4 dc=0
alter Vh4 dc=0
alter Vs5 dc=0
alter Vh5 dc=0
alter Vs6 dc=0
alter Vh6 dc=0
alter Vs7 dc=1.2
alter Vh7 dc=1.2
op
echo ROW 0 25.0 128 $&v(xt.vth_soft) $&v(xt.vth_hard) $&v(vref_buf) $&v(isense) $&i(vdda)
alter Vs0 dc=1.2
alter Vh0 dc=1.2
alter Vs1 dc=0
alter Vh1 dc=0
alter Vs2 dc=0
alter Vh2 dc=0
alter Vs3 dc=0
alter Vh3 dc=0
alter Vs4 dc=0
alter Vh4 dc=0
alter Vs5 dc=0
alter Vh5 dc=0
alter Vs6 dc=0
alter Vh6 dc=0
alter Vs7 dc=1.2
alter Vh7 dc=1.2
op
echo ROW 0 25.0 129 $&v(xt.vth_soft) $&v(xt.vth_hard) $&v(vref_buf) $&v(isense) $&i(vdda)
alter Vs0 dc=0
alter Vh0 dc=0
alter Vs1 dc=1.2
alter Vh1 dc=1.2
alter Vs2 dc=0
alter Vh2 dc=0
alter Vs3 dc=0
alter Vh3 dc=0
alter Vs4 dc=0
alter Vh4 dc=0
alter Vs5 dc=0
alter Vh5 dc=0
alter Vs6 dc=0
alter Vh6 dc=0
alter Vs7 dc=1.2
alter Vh7 dc=1.2
op
echo ROW 0 25.0 130 $&v(xt.vth_soft) $&v(xt.vth_hard) $&v(vref_buf) $&v(isense) $&i(vdda)
alter Vs0 dc=1.2
alter Vh0 dc=1.2
alter Vs1 dc=1.2
alter Vh1 dc=1.2
alter Vs2 dc=0
alter Vh2 dc=0
alter Vs3 dc=0
alter Vh3 dc=0
alter Vs4 dc=0
alter Vh4 dc=0
alter Vs5 dc=0
alter Vh5 dc=0
alter Vs6 dc=0
alter Vh6 dc=0
alter Vs7 dc=1.2
alter Vh7 dc=1.2
op
echo ROW 0 25.0 131 $&v(xt.vth_soft) $&v(xt.vth_hard) $&v(vref_buf) $&v(isense) $&i(vdda)
alter Vs0 dc=0
alter Vh0 dc=0
alter Vs1 dc=0
alter Vh1 dc=0
alter Vs2 dc=1.2
alter Vh2 dc=1.2
alter Vs3 dc=0
alter Vh3 dc=0
alter Vs4 dc=0
alter Vh4 dc=0
alter Vs5 dc=0
alter Vh5 dc=0
alter Vs6 dc=0
alter Vh6 dc=0
alter Vs7 dc=1.2
alter Vh7 dc=1.2
op
echo ROW 0 25.0 132 $&v(xt.vth_soft) $&v(xt.vth_hard) $&v(vref_buf) $&v(isense) $&i(vdda)
alter Vs0 dc=1.2
alter Vh0 dc=1.2
alter Vs1 dc=0
alter Vh1 dc=0
alter Vs2 dc=1.2
alter Vh2 dc=1.2
alter Vs3 dc=0
alter Vh3 dc=0
alter Vs4 dc=0
alter Vh4 dc=0
alter Vs5 dc=0
alter Vh5 dc=0
alter Vs6 dc=0
alter Vh6 dc=0
alter Vs7 dc=1.2
alter Vh7 dc=1.2
op
echo ROW 0 25.0 133 $&v(xt.vth_soft) $&v(xt.vth_hard) $&v(vref_buf) $&v(isense) $&i(vdda)
alter Vs0 dc=0
alter Vh0 dc=0
alter Vs1 dc=1.2
alter Vh1 dc=1.2
alter Vs2 dc=1.2
alter Vh2 dc=1.2
alter Vs3 dc=0
alter Vh3 dc=0
alter Vs4 dc=0
alter Vh4 dc=0
alter Vs5 dc=0
alter Vh5 dc=0
alter Vs6 dc=0
alter Vh6 dc=0
alter Vs7 dc=1.2
alter Vh7 dc=1.2
op
echo ROW 0 25.0 134 $&v(xt.vth_soft) $&v(xt.vth_hard) $&v(vref_buf) $&v(isense) $&i(vdda)
alter Vs0 dc=1.2
alter Vh0 dc=1.2
alter Vs1 dc=1.2
alter Vh1 dc=1.2
alter Vs2 dc=1.2
alter Vh2 dc=1.2
alter Vs3 dc=0
alter Vh3 dc=0
alter Vs4 dc=0
alter Vh4 dc=0
alter Vs5 dc=0
alter Vh5 dc=0
alter Vs6 dc=0
alter Vh6 dc=0
alter Vs7 dc=1.2
alter Vh7 dc=1.2
op
echo ROW 0 25.0 135 $&v(xt.vth_soft) $&v(xt.vth_hard) $&v(vref_buf) $&v(isense) $&i(vdda)
alter Vs0 dc=0
alter Vh0 dc=0
alter Vs1 dc=0
alter Vh1 dc=0
alter Vs2 dc=0
alter Vh2 dc=0
alter Vs3 dc=1.2
alter Vh3 dc=1.2
alter Vs4 dc=0
alter Vh4 dc=0
alter Vs5 dc=0
alter Vh5 dc=0
alter Vs6 dc=0
alter Vh6 dc=0
alter Vs7 dc=1.2
alter Vh7 dc=1.2
op
echo ROW 0 25.0 136 $&v(xt.vth_soft) $&v(xt.vth_hard) $&v(vref_buf) $&v(isense) $&i(vdda)
alter Vs0 dc=1.2
alter Vh0 dc=1.2
alter Vs1 dc=0
alter Vh1 dc=0
alter Vs2 dc=0
alter Vh2 dc=0
alter Vs3 dc=1.2
alter Vh3 dc=1.2
alter Vs4 dc=0
alter Vh4 dc=0
alter Vs5 dc=0
alter Vh5 dc=0
alter Vs6 dc=0
alter Vh6 dc=0
alter Vs7 dc=1.2
alter Vh7 dc=1.2
op
echo ROW 0 25.0 137 $&v(xt.vth_soft) $&v(xt.vth_hard) $&v(vref_buf) $&v(isense) $&i(vdda)
alter Vs0 dc=0
alter Vh0 dc=0
alter Vs1 dc=1.2
alter Vh1 dc=1.2
alter Vs2 dc=0
alter Vh2 dc=0
alter Vs3 dc=1.2
alter Vh3 dc=1.2
alter Vs4 dc=0
alter Vh4 dc=0
alter Vs5 dc=0
alter Vh5 dc=0
alter Vs6 dc=0
alter Vh6 dc=0
alter Vs7 dc=1.2
alter Vh7 dc=1.2
op
echo ROW 0 25.0 138 $&v(xt.vth_soft) $&v(xt.vth_hard) $&v(vref_buf) $&v(isense) $&i(vdda)
alter Vs0 dc=1.2
alter Vh0 dc=1.2
alter Vs1 dc=1.2
alter Vh1 dc=1.2
alter Vs2 dc=0
alter Vh2 dc=0
alter Vs3 dc=1.2
alter Vh3 dc=1.2
alter Vs4 dc=0
alter Vh4 dc=0
alter Vs5 dc=0
alter Vh5 dc=0
alter Vs6 dc=0
alter Vh6 dc=0
alter Vs7 dc=1.2
alter Vh7 dc=1.2
op
echo ROW 0 25.0 139 $&v(xt.vth_soft) $&v(xt.vth_hard) $&v(vref_buf) $&v(isense) $&i(vdda)
alter Vs0 dc=0
alter Vh0 dc=0
alter Vs1 dc=0
alter Vh1 dc=0
alter Vs2 dc=1.2
alter Vh2 dc=1.2
alter Vs3 dc=1.2
alter Vh3 dc=1.2
alter Vs4 dc=0
alter Vh4 dc=0
alter Vs5 dc=0
alter Vh5 dc=0
alter Vs6 dc=0
alter Vh6 dc=0
alter Vs7 dc=1.2
alter Vh7 dc=1.2
op
echo ROW 0 25.0 140 $&v(xt.vth_soft) $&v(xt.vth_hard) $&v(vref_buf) $&v(isense) $&i(vdda)
alter Vs0 dc=1.2
alter Vh0 dc=1.2
alter Vs1 dc=0
alter Vh1 dc=0
alter Vs2 dc=1.2
alter Vh2 dc=1.2
alter Vs3 dc=1.2
alter Vh3 dc=1.2
alter Vs4 dc=0
alter Vh4 dc=0
alter Vs5 dc=0
alter Vh5 dc=0
alter Vs6 dc=0
alter Vh6 dc=0
alter Vs7 dc=1.2
alter Vh7 dc=1.2
op
echo ROW 0 25.0 141 $&v(xt.vth_soft) $&v(xt.vth_hard) $&v(vref_buf) $&v(isense) $&i(vdda)
alter Vs0 dc=0
alter Vh0 dc=0
alter Vs1 dc=1.2
alter Vh1 dc=1.2
alter Vs2 dc=1.2
alter Vh2 dc=1.2
alter Vs3 dc=1.2
alter Vh3 dc=1.2
alter Vs4 dc=0
alter Vh4 dc=0
alter Vs5 dc=0
alter Vh5 dc=0
alter Vs6 dc=0
alter Vh6 dc=0
alter Vs7 dc=1.2
alter Vh7 dc=1.2
op
echo ROW 0 25.0 142 $&v(xt.vth_soft) $&v(xt.vth_hard) $&v(vref_buf) $&v(isense) $&i(vdda)
alter Vs0 dc=1.2
alter Vh0 dc=1.2
alter Vs1 dc=1.2
alter Vh1 dc=1.2
alter Vs2 dc=1.2
alter Vh2 dc=1.2
alter Vs3 dc=1.2
alter Vh3 dc=1.2
alter Vs4 dc=0
alter Vh4 dc=0
alter Vs5 dc=0
alter Vh5 dc=0
alter Vs6 dc=0
alter Vh6 dc=0
alter Vs7 dc=1.2
alter Vh7 dc=1.2
op
echo ROW 0 25.0 143 $&v(xt.vth_soft) $&v(xt.vth_hard) $&v(vref_buf) $&v(isense) $&i(vdda)
alter Vs0 dc=0
alter Vh0 dc=0
alter Vs1 dc=0
alter Vh1 dc=0
alter Vs2 dc=0
alter Vh2 dc=0
alter Vs3 dc=0
alter Vh3 dc=0
alter Vs4 dc=1.2
alter Vh4 dc=1.2
alter Vs5 dc=0
alter Vh5 dc=0
alter Vs6 dc=0
alter Vh6 dc=0
alter Vs7 dc=1.2
alter Vh7 dc=1.2
op
echo ROW 0 25.0 144 $&v(xt.vth_soft) $&v(xt.vth_hard) $&v(vref_buf) $&v(isense) $&i(vdda)
alter Vs0 dc=1.2
alter Vh0 dc=1.2
alter Vs1 dc=0
alter Vh1 dc=0
alter Vs2 dc=0
alter Vh2 dc=0
alter Vs3 dc=0
alter Vh3 dc=0
alter Vs4 dc=1.2
alter Vh4 dc=1.2
alter Vs5 dc=0
alter Vh5 dc=0
alter Vs6 dc=0
alter Vh6 dc=0
alter Vs7 dc=1.2
alter Vh7 dc=1.2
op
echo ROW 0 25.0 145 $&v(xt.vth_soft) $&v(xt.vth_hard) $&v(vref_buf) $&v(isense) $&i(vdda)
alter Vs0 dc=0
alter Vh0 dc=0
alter Vs1 dc=1.2
alter Vh1 dc=1.2
alter Vs2 dc=0
alter Vh2 dc=0
alter Vs3 dc=0
alter Vh3 dc=0
alter Vs4 dc=1.2
alter Vh4 dc=1.2
alter Vs5 dc=0
alter Vh5 dc=0
alter Vs6 dc=0
alter Vh6 dc=0
alter Vs7 dc=1.2
alter Vh7 dc=1.2
op
echo ROW 0 25.0 146 $&v(xt.vth_soft) $&v(xt.vth_hard) $&v(vref_buf) $&v(isense) $&i(vdda)
alter Vs0 dc=1.2
alter Vh0 dc=1.2
alter Vs1 dc=1.2
alter Vh1 dc=1.2
alter Vs2 dc=0
alter Vh2 dc=0
alter Vs3 dc=0
alter Vh3 dc=0
alter Vs4 dc=1.2
alter Vh4 dc=1.2
alter Vs5 dc=0
alter Vh5 dc=0
alter Vs6 dc=0
alter Vh6 dc=0
alter Vs7 dc=1.2
alter Vh7 dc=1.2
op
echo ROW 0 25.0 147 $&v(xt.vth_soft) $&v(xt.vth_hard) $&v(vref_buf) $&v(isense) $&i(vdda)
alter Vs0 dc=0
alter Vh0 dc=0
alter Vs1 dc=0
alter Vh1 dc=0
alter Vs2 dc=1.2
alter Vh2 dc=1.2
alter Vs3 dc=0
alter Vh3 dc=0
alter Vs4 dc=1.2
alter Vh4 dc=1.2
alter Vs5 dc=0
alter Vh5 dc=0
alter Vs6 dc=0
alter Vh6 dc=0
alter Vs7 dc=1.2
alter Vh7 dc=1.2
op
echo ROW 0 25.0 148 $&v(xt.vth_soft) $&v(xt.vth_hard) $&v(vref_buf) $&v(isense) $&i(vdda)
alter Vs0 dc=1.2
alter Vh0 dc=1.2
alter Vs1 dc=0
alter Vh1 dc=0
alter Vs2 dc=1.2
alter Vh2 dc=1.2
alter Vs3 dc=0
alter Vh3 dc=0
alter Vs4 dc=1.2
alter Vh4 dc=1.2
alter Vs5 dc=0
alter Vh5 dc=0
alter Vs6 dc=0
alter Vh6 dc=0
alter Vs7 dc=1.2
alter Vh7 dc=1.2
op
echo ROW 0 25.0 149 $&v(xt.vth_soft) $&v(xt.vth_hard) $&v(vref_buf) $&v(isense) $&i(vdda)
alter Vs0 dc=0
alter Vh0 dc=0
alter Vs1 dc=1.2
alter Vh1 dc=1.2
alter Vs2 dc=1.2
alter Vh2 dc=1.2
alter Vs3 dc=0
alter Vh3 dc=0
alter Vs4 dc=1.2
alter Vh4 dc=1.2
alter Vs5 dc=0
alter Vh5 dc=0
alter Vs6 dc=0
alter Vh6 dc=0
alter Vs7 dc=1.2
alter Vh7 dc=1.2
op
echo ROW 0 25.0 150 $&v(xt.vth_soft) $&v(xt.vth_hard) $&v(vref_buf) $&v(isense) $&i(vdda)
alter Vs0 dc=1.2
alter Vh0 dc=1.2
alter Vs1 dc=1.2
alter Vh1 dc=1.2
alter Vs2 dc=1.2
alter Vh2 dc=1.2
alter Vs3 dc=0
alter Vh3 dc=0
alter Vs4 dc=1.2
alter Vh4 dc=1.2
alter Vs5 dc=0
alter Vh5 dc=0
alter Vs6 dc=0
alter Vh6 dc=0
alter Vs7 dc=1.2
alter Vh7 dc=1.2
op
echo ROW 0 25.0 151 $&v(xt.vth_soft) $&v(xt.vth_hard) $&v(vref_buf) $&v(isense) $&i(vdda)
alter Vs0 dc=0
alter Vh0 dc=0
alter Vs1 dc=0
alter Vh1 dc=0
alter Vs2 dc=0
alter Vh2 dc=0
alter Vs3 dc=1.2
alter Vh3 dc=1.2
alter Vs4 dc=1.2
alter Vh4 dc=1.2
alter Vs5 dc=0
alter Vh5 dc=0
alter Vs6 dc=0
alter Vh6 dc=0
alter Vs7 dc=1.2
alter Vh7 dc=1.2
op
echo ROW 0 25.0 152 $&v(xt.vth_soft) $&v(xt.vth_hard) $&v(vref_buf) $&v(isense) $&i(vdda)
alter Vs0 dc=1.2
alter Vh0 dc=1.2
alter Vs1 dc=0
alter Vh1 dc=0
alter Vs2 dc=0
alter Vh2 dc=0
alter Vs3 dc=1.2
alter Vh3 dc=1.2
alter Vs4 dc=1.2
alter Vh4 dc=1.2
alter Vs5 dc=0
alter Vh5 dc=0
alter Vs6 dc=0
alter Vh6 dc=0
alter Vs7 dc=1.2
alter Vh7 dc=1.2
op
echo ROW 0 25.0 153 $&v(xt.vth_soft) $&v(xt.vth_hard) $&v(vref_buf) $&v(isense) $&i(vdda)
alter Vs0 dc=0
alter Vh0 dc=0
alter Vs1 dc=1.2
alter Vh1 dc=1.2
alter Vs2 dc=0
alter Vh2 dc=0
alter Vs3 dc=1.2
alter Vh3 dc=1.2
alter Vs4 dc=1.2
alter Vh4 dc=1.2
alter Vs5 dc=0
alter Vh5 dc=0
alter Vs6 dc=0
alter Vh6 dc=0
alter Vs7 dc=1.2
alter Vh7 dc=1.2
op
echo ROW 0 25.0 154 $&v(xt.vth_soft) $&v(xt.vth_hard) $&v(vref_buf) $&v(isense) $&i(vdda)
alter Vs0 dc=1.2
alter Vh0 dc=1.2
alter Vs1 dc=1.2
alter Vh1 dc=1.2
alter Vs2 dc=0
alter Vh2 dc=0
alter Vs3 dc=1.2
alter Vh3 dc=1.2
alter Vs4 dc=1.2
alter Vh4 dc=1.2
alter Vs5 dc=0
alter Vh5 dc=0
alter Vs6 dc=0
alter Vh6 dc=0
alter Vs7 dc=1.2
alter Vh7 dc=1.2
op
echo ROW 0 25.0 155 $&v(xt.vth_soft) $&v(xt.vth_hard) $&v(vref_buf) $&v(isense) $&i(vdda)
alter Vs0 dc=0
alter Vh0 dc=0
alter Vs1 dc=0
alter Vh1 dc=0
alter Vs2 dc=1.2
alter Vh2 dc=1.2
alter Vs3 dc=1.2
alter Vh3 dc=1.2
alter Vs4 dc=1.2
alter Vh4 dc=1.2
alter Vs5 dc=0
alter Vh5 dc=0
alter Vs6 dc=0
alter Vh6 dc=0
alter Vs7 dc=1.2
alter Vh7 dc=1.2
op
echo ROW 0 25.0 156 $&v(xt.vth_soft) $&v(xt.vth_hard) $&v(vref_buf) $&v(isense) $&i(vdda)
alter Vs0 dc=1.2
alter Vh0 dc=1.2
alter Vs1 dc=0
alter Vh1 dc=0
alter Vs2 dc=1.2
alter Vh2 dc=1.2
alter Vs3 dc=1.2
alter Vh3 dc=1.2
alter Vs4 dc=1.2
alter Vh4 dc=1.2
alter Vs5 dc=0
alter Vh5 dc=0
alter Vs6 dc=0
alter Vh6 dc=0
alter Vs7 dc=1.2
alter Vh7 dc=1.2
op
echo ROW 0 25.0 157 $&v(xt.vth_soft) $&v(xt.vth_hard) $&v(vref_buf) $&v(isense) $&i(vdda)
alter Vs0 dc=0
alter Vh0 dc=0
alter Vs1 dc=1.2
alter Vh1 dc=1.2
alter Vs2 dc=1.2
alter Vh2 dc=1.2
alter Vs3 dc=1.2
alter Vh3 dc=1.2
alter Vs4 dc=1.2
alter Vh4 dc=1.2
alter Vs5 dc=0
alter Vh5 dc=0
alter Vs6 dc=0
alter Vh6 dc=0
alter Vs7 dc=1.2
alter Vh7 dc=1.2
op
echo ROW 0 25.0 158 $&v(xt.vth_soft) $&v(xt.vth_hard) $&v(vref_buf) $&v(isense) $&i(vdda)
alter Vs0 dc=1.2
alter Vh0 dc=1.2
alter Vs1 dc=1.2
alter Vh1 dc=1.2
alter Vs2 dc=1.2
alter Vh2 dc=1.2
alter Vs3 dc=1.2
alter Vh3 dc=1.2
alter Vs4 dc=1.2
alter Vh4 dc=1.2
alter Vs5 dc=0
alter Vh5 dc=0
alter Vs6 dc=0
alter Vh6 dc=0
alter Vs7 dc=1.2
alter Vh7 dc=1.2
op
echo ROW 0 25.0 159 $&v(xt.vth_soft) $&v(xt.vth_hard) $&v(vref_buf) $&v(isense) $&i(vdda)
alter Vs0 dc=0
alter Vh0 dc=0
alter Vs1 dc=0
alter Vh1 dc=0
alter Vs2 dc=0
alter Vh2 dc=0
alter Vs3 dc=0
alter Vh3 dc=0
alter Vs4 dc=0
alter Vh4 dc=0
alter Vs5 dc=1.2
alter Vh5 dc=1.2
alter Vs6 dc=0
alter Vh6 dc=0
alter Vs7 dc=1.2
alter Vh7 dc=1.2
op
echo ROW 0 25.0 160 $&v(xt.vth_soft) $&v(xt.vth_hard) $&v(vref_buf) $&v(isense) $&i(vdda)
alter Vs0 dc=1.2
alter Vh0 dc=1.2
alter Vs1 dc=0
alter Vh1 dc=0
alter Vs2 dc=0
alter Vh2 dc=0
alter Vs3 dc=0
alter Vh3 dc=0
alter Vs4 dc=0
alter Vh4 dc=0
alter Vs5 dc=1.2
alter Vh5 dc=1.2
alter Vs6 dc=0
alter Vh6 dc=0
alter Vs7 dc=1.2
alter Vh7 dc=1.2
op
echo ROW 0 25.0 161 $&v(xt.vth_soft) $&v(xt.vth_hard) $&v(vref_buf) $&v(isense) $&i(vdda)
alter Vs0 dc=0
alter Vh0 dc=0
alter Vs1 dc=1.2
alter Vh1 dc=1.2
alter Vs2 dc=0
alter Vh2 dc=0
alter Vs3 dc=0
alter Vh3 dc=0
alter Vs4 dc=0
alter Vh4 dc=0
alter Vs5 dc=1.2
alter Vh5 dc=1.2
alter Vs6 dc=0
alter Vh6 dc=0
alter Vs7 dc=1.2
alter Vh7 dc=1.2
op
echo ROW 0 25.0 162 $&v(xt.vth_soft) $&v(xt.vth_hard) $&v(vref_buf) $&v(isense) $&i(vdda)
alter Vs0 dc=1.2
alter Vh0 dc=1.2
alter Vs1 dc=1.2
alter Vh1 dc=1.2
alter Vs2 dc=0
alter Vh2 dc=0
alter Vs3 dc=0
alter Vh3 dc=0
alter Vs4 dc=0
alter Vh4 dc=0
alter Vs5 dc=1.2
alter Vh5 dc=1.2
alter Vs6 dc=0
alter Vh6 dc=0
alter Vs7 dc=1.2
alter Vh7 dc=1.2
op
echo ROW 0 25.0 163 $&v(xt.vth_soft) $&v(xt.vth_hard) $&v(vref_buf) $&v(isense) $&i(vdda)
alter Vs0 dc=0
alter Vh0 dc=0
alter Vs1 dc=0
alter Vh1 dc=0
alter Vs2 dc=1.2
alter Vh2 dc=1.2
alter Vs3 dc=0
alter Vh3 dc=0
alter Vs4 dc=0
alter Vh4 dc=0
alter Vs5 dc=1.2
alter Vh5 dc=1.2
alter Vs6 dc=0
alter Vh6 dc=0
alter Vs7 dc=1.2
alter Vh7 dc=1.2
op
echo ROW 0 25.0 164 $&v(xt.vth_soft) $&v(xt.vth_hard) $&v(vref_buf) $&v(isense) $&i(vdda)
alter Vs0 dc=1.2
alter Vh0 dc=1.2
alter Vs1 dc=0
alter Vh1 dc=0
alter Vs2 dc=1.2
alter Vh2 dc=1.2
alter Vs3 dc=0
alter Vh3 dc=0
alter Vs4 dc=0
alter Vh4 dc=0
alter Vs5 dc=1.2
alter Vh5 dc=1.2
alter Vs6 dc=0
alter Vh6 dc=0
alter Vs7 dc=1.2
alter Vh7 dc=1.2
op
echo ROW 0 25.0 165 $&v(xt.vth_soft) $&v(xt.vth_hard) $&v(vref_buf) $&v(isense) $&i(vdda)
alter Vs0 dc=0
alter Vh0 dc=0
alter Vs1 dc=1.2
alter Vh1 dc=1.2
alter Vs2 dc=1.2
alter Vh2 dc=1.2
alter Vs3 dc=0
alter Vh3 dc=0
alter Vs4 dc=0
alter Vh4 dc=0
alter Vs5 dc=1.2
alter Vh5 dc=1.2
alter Vs6 dc=0
alter Vh6 dc=0
alter Vs7 dc=1.2
alter Vh7 dc=1.2
op
echo ROW 0 25.0 166 $&v(xt.vth_soft) $&v(xt.vth_hard) $&v(vref_buf) $&v(isense) $&i(vdda)
alter Vs0 dc=1.2
alter Vh0 dc=1.2
alter Vs1 dc=1.2
alter Vh1 dc=1.2
alter Vs2 dc=1.2
alter Vh2 dc=1.2
alter Vs3 dc=0
alter Vh3 dc=0
alter Vs4 dc=0
alter Vh4 dc=0
alter Vs5 dc=1.2
alter Vh5 dc=1.2
alter Vs6 dc=0
alter Vh6 dc=0
alter Vs7 dc=1.2
alter Vh7 dc=1.2
op
echo ROW 0 25.0 167 $&v(xt.vth_soft) $&v(xt.vth_hard) $&v(vref_buf) $&v(isense) $&i(vdda)
alter Vs0 dc=0
alter Vh0 dc=0
alter Vs1 dc=0
alter Vh1 dc=0
alter Vs2 dc=0
alter Vh2 dc=0
alter Vs3 dc=1.2
alter Vh3 dc=1.2
alter Vs4 dc=0
alter Vh4 dc=0
alter Vs5 dc=1.2
alter Vh5 dc=1.2
alter Vs6 dc=0
alter Vh6 dc=0
alter Vs7 dc=1.2
alter Vh7 dc=1.2
op
echo ROW 0 25.0 168 $&v(xt.vth_soft) $&v(xt.vth_hard) $&v(vref_buf) $&v(isense) $&i(vdda)
alter Vs0 dc=1.2
alter Vh0 dc=1.2
alter Vs1 dc=0
alter Vh1 dc=0
alter Vs2 dc=0
alter Vh2 dc=0
alter Vs3 dc=1.2
alter Vh3 dc=1.2
alter Vs4 dc=0
alter Vh4 dc=0
alter Vs5 dc=1.2
alter Vh5 dc=1.2
alter Vs6 dc=0
alter Vh6 dc=0
alter Vs7 dc=1.2
alter Vh7 dc=1.2
op
echo ROW 0 25.0 169 $&v(xt.vth_soft) $&v(xt.vth_hard) $&v(vref_buf) $&v(isense) $&i(vdda)
alter Vs0 dc=0
alter Vh0 dc=0
alter Vs1 dc=1.2
alter Vh1 dc=1.2
alter Vs2 dc=0
alter Vh2 dc=0
alter Vs3 dc=1.2
alter Vh3 dc=1.2
alter Vs4 dc=0
alter Vh4 dc=0
alter Vs5 dc=1.2
alter Vh5 dc=1.2
alter Vs6 dc=0
alter Vh6 dc=0
alter Vs7 dc=1.2
alter Vh7 dc=1.2
op
echo ROW 0 25.0 170 $&v(xt.vth_soft) $&v(xt.vth_hard) $&v(vref_buf) $&v(isense) $&i(vdda)
alter Vs0 dc=1.2
alter Vh0 dc=1.2
alter Vs1 dc=1.2
alter Vh1 dc=1.2
alter Vs2 dc=0
alter Vh2 dc=0
alter Vs3 dc=1.2
alter Vh3 dc=1.2
alter Vs4 dc=0
alter Vh4 dc=0
alter Vs5 dc=1.2
alter Vh5 dc=1.2
alter Vs6 dc=0
alter Vh6 dc=0
alter Vs7 dc=1.2
alter Vh7 dc=1.2
op
echo ROW 0 25.0 171 $&v(xt.vth_soft) $&v(xt.vth_hard) $&v(vref_buf) $&v(isense) $&i(vdda)
alter Vs0 dc=0
alter Vh0 dc=0
alter Vs1 dc=0
alter Vh1 dc=0
alter Vs2 dc=1.2
alter Vh2 dc=1.2
alter Vs3 dc=1.2
alter Vh3 dc=1.2
alter Vs4 dc=0
alter Vh4 dc=0
alter Vs5 dc=1.2
alter Vh5 dc=1.2
alter Vs6 dc=0
alter Vh6 dc=0
alter Vs7 dc=1.2
alter Vh7 dc=1.2
op
echo ROW 0 25.0 172 $&v(xt.vth_soft) $&v(xt.vth_hard) $&v(vref_buf) $&v(isense) $&i(vdda)
alter Vs0 dc=1.2
alter Vh0 dc=1.2
alter Vs1 dc=0
alter Vh1 dc=0
alter Vs2 dc=1.2
alter Vh2 dc=1.2
alter Vs3 dc=1.2
alter Vh3 dc=1.2
alter Vs4 dc=0
alter Vh4 dc=0
alter Vs5 dc=1.2
alter Vh5 dc=1.2
alter Vs6 dc=0
alter Vh6 dc=0
alter Vs7 dc=1.2
alter Vh7 dc=1.2
op
echo ROW 0 25.0 173 $&v(xt.vth_soft) $&v(xt.vth_hard) $&v(vref_buf) $&v(isense) $&i(vdda)
alter Vs0 dc=0
alter Vh0 dc=0
alter Vs1 dc=1.2
alter Vh1 dc=1.2
alter Vs2 dc=1.2
alter Vh2 dc=1.2
alter Vs3 dc=1.2
alter Vh3 dc=1.2
alter Vs4 dc=0
alter Vh4 dc=0
alter Vs5 dc=1.2
alter Vh5 dc=1.2
alter Vs6 dc=0
alter Vh6 dc=0
alter Vs7 dc=1.2
alter Vh7 dc=1.2
op
echo ROW 0 25.0 174 $&v(xt.vth_soft) $&v(xt.vth_hard) $&v(vref_buf) $&v(isense) $&i(vdda)
alter Vs0 dc=1.2
alter Vh0 dc=1.2
alter Vs1 dc=1.2
alter Vh1 dc=1.2
alter Vs2 dc=1.2
alter Vh2 dc=1.2
alter Vs3 dc=1.2
alter Vh3 dc=1.2
alter Vs4 dc=0
alter Vh4 dc=0
alter Vs5 dc=1.2
alter Vh5 dc=1.2
alter Vs6 dc=0
alter Vh6 dc=0
alter Vs7 dc=1.2
alter Vh7 dc=1.2
op
echo ROW 0 25.0 175 $&v(xt.vth_soft) $&v(xt.vth_hard) $&v(vref_buf) $&v(isense) $&i(vdda)
alter Vs0 dc=0
alter Vh0 dc=0
alter Vs1 dc=0
alter Vh1 dc=0
alter Vs2 dc=0
alter Vh2 dc=0
alter Vs3 dc=0
alter Vh3 dc=0
alter Vs4 dc=1.2
alter Vh4 dc=1.2
alter Vs5 dc=1.2
alter Vh5 dc=1.2
alter Vs6 dc=0
alter Vh6 dc=0
alter Vs7 dc=1.2
alter Vh7 dc=1.2
op
echo ROW 0 25.0 176 $&v(xt.vth_soft) $&v(xt.vth_hard) $&v(vref_buf) $&v(isense) $&i(vdda)
alter Vs0 dc=1.2
alter Vh0 dc=1.2
alter Vs1 dc=0
alter Vh1 dc=0
alter Vs2 dc=0
alter Vh2 dc=0
alter Vs3 dc=0
alter Vh3 dc=0
alter Vs4 dc=1.2
alter Vh4 dc=1.2
alter Vs5 dc=1.2
alter Vh5 dc=1.2
alter Vs6 dc=0
alter Vh6 dc=0
alter Vs7 dc=1.2
alter Vh7 dc=1.2
op
echo ROW 0 25.0 177 $&v(xt.vth_soft) $&v(xt.vth_hard) $&v(vref_buf) $&v(isense) $&i(vdda)
alter Vs0 dc=0
alter Vh0 dc=0
alter Vs1 dc=1.2
alter Vh1 dc=1.2
alter Vs2 dc=0
alter Vh2 dc=0
alter Vs3 dc=0
alter Vh3 dc=0
alter Vs4 dc=1.2
alter Vh4 dc=1.2
alter Vs5 dc=1.2
alter Vh5 dc=1.2
alter Vs6 dc=0
alter Vh6 dc=0
alter Vs7 dc=1.2
alter Vh7 dc=1.2
op
echo ROW 0 25.0 178 $&v(xt.vth_soft) $&v(xt.vth_hard) $&v(vref_buf) $&v(isense) $&i(vdda)
alter Vs0 dc=1.2
alter Vh0 dc=1.2
alter Vs1 dc=1.2
alter Vh1 dc=1.2
alter Vs2 dc=0
alter Vh2 dc=0
alter Vs3 dc=0
alter Vh3 dc=0
alter Vs4 dc=1.2
alter Vh4 dc=1.2
alter Vs5 dc=1.2
alter Vh5 dc=1.2
alter Vs6 dc=0
alter Vh6 dc=0
alter Vs7 dc=1.2
alter Vh7 dc=1.2
op
echo ROW 0 25.0 179 $&v(xt.vth_soft) $&v(xt.vth_hard) $&v(vref_buf) $&v(isense) $&i(vdda)
alter Vs0 dc=0
alter Vh0 dc=0
alter Vs1 dc=0
alter Vh1 dc=0
alter Vs2 dc=1.2
alter Vh2 dc=1.2
alter Vs3 dc=0
alter Vh3 dc=0
alter Vs4 dc=1.2
alter Vh4 dc=1.2
alter Vs5 dc=1.2
alter Vh5 dc=1.2
alter Vs6 dc=0
alter Vh6 dc=0
alter Vs7 dc=1.2
alter Vh7 dc=1.2
op
echo ROW 0 25.0 180 $&v(xt.vth_soft) $&v(xt.vth_hard) $&v(vref_buf) $&v(isense) $&i(vdda)
alter Vs0 dc=1.2
alter Vh0 dc=1.2
alter Vs1 dc=0
alter Vh1 dc=0
alter Vs2 dc=1.2
alter Vh2 dc=1.2
alter Vs3 dc=0
alter Vh3 dc=0
alter Vs4 dc=1.2
alter Vh4 dc=1.2
alter Vs5 dc=1.2
alter Vh5 dc=1.2
alter Vs6 dc=0
alter Vh6 dc=0
alter Vs7 dc=1.2
alter Vh7 dc=1.2
op
echo ROW 0 25.0 181 $&v(xt.vth_soft) $&v(xt.vth_hard) $&v(vref_buf) $&v(isense) $&i(vdda)
alter Vs0 dc=0
alter Vh0 dc=0
alter Vs1 dc=1.2
alter Vh1 dc=1.2
alter Vs2 dc=1.2
alter Vh2 dc=1.2
alter Vs3 dc=0
alter Vh3 dc=0
alter Vs4 dc=1.2
alter Vh4 dc=1.2
alter Vs5 dc=1.2
alter Vh5 dc=1.2
alter Vs6 dc=0
alter Vh6 dc=0
alter Vs7 dc=1.2
alter Vh7 dc=1.2
op
echo ROW 0 25.0 182 $&v(xt.vth_soft) $&v(xt.vth_hard) $&v(vref_buf) $&v(isense) $&i(vdda)
alter Vs0 dc=1.2
alter Vh0 dc=1.2
alter Vs1 dc=1.2
alter Vh1 dc=1.2
alter Vs2 dc=1.2
alter Vh2 dc=1.2
alter Vs3 dc=0
alter Vh3 dc=0
alter Vs4 dc=1.2
alter Vh4 dc=1.2
alter Vs5 dc=1.2
alter Vh5 dc=1.2
alter Vs6 dc=0
alter Vh6 dc=0
alter Vs7 dc=1.2
alter Vh7 dc=1.2
op
echo ROW 0 25.0 183 $&v(xt.vth_soft) $&v(xt.vth_hard) $&v(vref_buf) $&v(isense) $&i(vdda)
alter Vs0 dc=0
alter Vh0 dc=0
alter Vs1 dc=0
alter Vh1 dc=0
alter Vs2 dc=0
alter Vh2 dc=0
alter Vs3 dc=1.2
alter Vh3 dc=1.2
alter Vs4 dc=1.2
alter Vh4 dc=1.2
alter Vs5 dc=1.2
alter Vh5 dc=1.2
alter Vs6 dc=0
alter Vh6 dc=0
alter Vs7 dc=1.2
alter Vh7 dc=1.2
op
echo ROW 0 25.0 184 $&v(xt.vth_soft) $&v(xt.vth_hard) $&v(vref_buf) $&v(isense) $&i(vdda)
alter Vs0 dc=1.2
alter Vh0 dc=1.2
alter Vs1 dc=0
alter Vh1 dc=0
alter Vs2 dc=0
alter Vh2 dc=0
alter Vs3 dc=1.2
alter Vh3 dc=1.2
alter Vs4 dc=1.2
alter Vh4 dc=1.2
alter Vs5 dc=1.2
alter Vh5 dc=1.2
alter Vs6 dc=0
alter Vh6 dc=0
alter Vs7 dc=1.2
alter Vh7 dc=1.2
op
echo ROW 0 25.0 185 $&v(xt.vth_soft) $&v(xt.vth_hard) $&v(vref_buf) $&v(isense) $&i(vdda)
alter Vs0 dc=0
alter Vh0 dc=0
alter Vs1 dc=1.2
alter Vh1 dc=1.2
alter Vs2 dc=0
alter Vh2 dc=0
alter Vs3 dc=1.2
alter Vh3 dc=1.2
alter Vs4 dc=1.2
alter Vh4 dc=1.2
alter Vs5 dc=1.2
alter Vh5 dc=1.2
alter Vs6 dc=0
alter Vh6 dc=0
alter Vs7 dc=1.2
alter Vh7 dc=1.2
op
echo ROW 0 25.0 186 $&v(xt.vth_soft) $&v(xt.vth_hard) $&v(vref_buf) $&v(isense) $&i(vdda)
alter Vs0 dc=1.2
alter Vh0 dc=1.2
alter Vs1 dc=1.2
alter Vh1 dc=1.2
alter Vs2 dc=0
alter Vh2 dc=0
alter Vs3 dc=1.2
alter Vh3 dc=1.2
alter Vs4 dc=1.2
alter Vh4 dc=1.2
alter Vs5 dc=1.2
alter Vh5 dc=1.2
alter Vs6 dc=0
alter Vh6 dc=0
alter Vs7 dc=1.2
alter Vh7 dc=1.2
op
echo ROW 0 25.0 187 $&v(xt.vth_soft) $&v(xt.vth_hard) $&v(vref_buf) $&v(isense) $&i(vdda)
alter Vs0 dc=0
alter Vh0 dc=0
alter Vs1 dc=0
alter Vh1 dc=0
alter Vs2 dc=1.2
alter Vh2 dc=1.2
alter Vs3 dc=1.2
alter Vh3 dc=1.2
alter Vs4 dc=1.2
alter Vh4 dc=1.2
alter Vs5 dc=1.2
alter Vh5 dc=1.2
alter Vs6 dc=0
alter Vh6 dc=0
alter Vs7 dc=1.2
alter Vh7 dc=1.2
op
echo ROW 0 25.0 188 $&v(xt.vth_soft) $&v(xt.vth_hard) $&v(vref_buf) $&v(isense) $&i(vdda)
alter Vs0 dc=1.2
alter Vh0 dc=1.2
alter Vs1 dc=0
alter Vh1 dc=0
alter Vs2 dc=1.2
alter Vh2 dc=1.2
alter Vs3 dc=1.2
alter Vh3 dc=1.2
alter Vs4 dc=1.2
alter Vh4 dc=1.2
alter Vs5 dc=1.2
alter Vh5 dc=1.2
alter Vs6 dc=0
alter Vh6 dc=0
alter Vs7 dc=1.2
alter Vh7 dc=1.2
op
echo ROW 0 25.0 189 $&v(xt.vth_soft) $&v(xt.vth_hard) $&v(vref_buf) $&v(isense) $&i(vdda)
alter Vs0 dc=0
alter Vh0 dc=0
alter Vs1 dc=1.2
alter Vh1 dc=1.2
alter Vs2 dc=1.2
alter Vh2 dc=1.2
alter Vs3 dc=1.2
alter Vh3 dc=1.2
alter Vs4 dc=1.2
alter Vh4 dc=1.2
alter Vs5 dc=1.2
alter Vh5 dc=1.2
alter Vs6 dc=0
alter Vh6 dc=0
alter Vs7 dc=1.2
alter Vh7 dc=1.2
op
echo ROW 0 25.0 190 $&v(xt.vth_soft) $&v(xt.vth_hard) $&v(vref_buf) $&v(isense) $&i(vdda)
alter Vs0 dc=1.2
alter Vh0 dc=1.2
alter Vs1 dc=1.2
alter Vh1 dc=1.2
alter Vs2 dc=1.2
alter Vh2 dc=1.2
alter Vs3 dc=1.2
alter Vh3 dc=1.2
alter Vs4 dc=1.2
alter Vh4 dc=1.2
alter Vs5 dc=1.2
alter Vh5 dc=1.2
alter Vs6 dc=0
alter Vh6 dc=0
alter Vs7 dc=1.2
alter Vh7 dc=1.2
op
echo ROW 0 25.0 191 $&v(xt.vth_soft) $&v(xt.vth_hard) $&v(vref_buf) $&v(isense) $&i(vdda)
alter Vs0 dc=0
alter Vh0 dc=0
alter Vs1 dc=0
alter Vh1 dc=0
alter Vs2 dc=0
alter Vh2 dc=0
alter Vs3 dc=0
alter Vh3 dc=0
alter Vs4 dc=0
alter Vh4 dc=0
alter Vs5 dc=0
alter Vh5 dc=0
alter Vs6 dc=1.2
alter Vh6 dc=1.2
alter Vs7 dc=1.2
alter Vh7 dc=1.2
op
echo ROW 0 25.0 192 $&v(xt.vth_soft) $&v(xt.vth_hard) $&v(vref_buf) $&v(isense) $&i(vdda)
alter Vs0 dc=1.2
alter Vh0 dc=1.2
alter Vs1 dc=0
alter Vh1 dc=0
alter Vs2 dc=0
alter Vh2 dc=0
alter Vs3 dc=0
alter Vh3 dc=0
alter Vs4 dc=0
alter Vh4 dc=0
alter Vs5 dc=0
alter Vh5 dc=0
alter Vs6 dc=1.2
alter Vh6 dc=1.2
alter Vs7 dc=1.2
alter Vh7 dc=1.2
op
echo ROW 0 25.0 193 $&v(xt.vth_soft) $&v(xt.vth_hard) $&v(vref_buf) $&v(isense) $&i(vdda)
alter Vs0 dc=0
alter Vh0 dc=0
alter Vs1 dc=1.2
alter Vh1 dc=1.2
alter Vs2 dc=0
alter Vh2 dc=0
alter Vs3 dc=0
alter Vh3 dc=0
alter Vs4 dc=0
alter Vh4 dc=0
alter Vs5 dc=0
alter Vh5 dc=0
alter Vs6 dc=1.2
alter Vh6 dc=1.2
alter Vs7 dc=1.2
alter Vh7 dc=1.2
op
echo ROW 0 25.0 194 $&v(xt.vth_soft) $&v(xt.vth_hard) $&v(vref_buf) $&v(isense) $&i(vdda)
alter Vs0 dc=1.2
alter Vh0 dc=1.2
alter Vs1 dc=1.2
alter Vh1 dc=1.2
alter Vs2 dc=0
alter Vh2 dc=0
alter Vs3 dc=0
alter Vh3 dc=0
alter Vs4 dc=0
alter Vh4 dc=0
alter Vs5 dc=0
alter Vh5 dc=0
alter Vs6 dc=1.2
alter Vh6 dc=1.2
alter Vs7 dc=1.2
alter Vh7 dc=1.2
op
echo ROW 0 25.0 195 $&v(xt.vth_soft) $&v(xt.vth_hard) $&v(vref_buf) $&v(isense) $&i(vdda)
alter Vs0 dc=0
alter Vh0 dc=0
alter Vs1 dc=0
alter Vh1 dc=0
alter Vs2 dc=1.2
alter Vh2 dc=1.2
alter Vs3 dc=0
alter Vh3 dc=0
alter Vs4 dc=0
alter Vh4 dc=0
alter Vs5 dc=0
alter Vh5 dc=0
alter Vs6 dc=1.2
alter Vh6 dc=1.2
alter Vs7 dc=1.2
alter Vh7 dc=1.2
op
echo ROW 0 25.0 196 $&v(xt.vth_soft) $&v(xt.vth_hard) $&v(vref_buf) $&v(isense) $&i(vdda)
alter Vs0 dc=1.2
alter Vh0 dc=1.2
alter Vs1 dc=0
alter Vh1 dc=0
alter Vs2 dc=1.2
alter Vh2 dc=1.2
alter Vs3 dc=0
alter Vh3 dc=0
alter Vs4 dc=0
alter Vh4 dc=0
alter Vs5 dc=0
alter Vh5 dc=0
alter Vs6 dc=1.2
alter Vh6 dc=1.2
alter Vs7 dc=1.2
alter Vh7 dc=1.2
op
echo ROW 0 25.0 197 $&v(xt.vth_soft) $&v(xt.vth_hard) $&v(vref_buf) $&v(isense) $&i(vdda)
alter Vs0 dc=0
alter Vh0 dc=0
alter Vs1 dc=1.2
alter Vh1 dc=1.2
alter Vs2 dc=1.2
alter Vh2 dc=1.2
alter Vs3 dc=0
alter Vh3 dc=0
alter Vs4 dc=0
alter Vh4 dc=0
alter Vs5 dc=0
alter Vh5 dc=0
alter Vs6 dc=1.2
alter Vh6 dc=1.2
alter Vs7 dc=1.2
alter Vh7 dc=1.2
op
echo ROW 0 25.0 198 $&v(xt.vth_soft) $&v(xt.vth_hard) $&v(vref_buf) $&v(isense) $&i(vdda)
alter Vs0 dc=1.2
alter Vh0 dc=1.2
alter Vs1 dc=1.2
alter Vh1 dc=1.2
alter Vs2 dc=1.2
alter Vh2 dc=1.2
alter Vs3 dc=0
alter Vh3 dc=0
alter Vs4 dc=0
alter Vh4 dc=0
alter Vs5 dc=0
alter Vh5 dc=0
alter Vs6 dc=1.2
alter Vh6 dc=1.2
alter Vs7 dc=1.2
alter Vh7 dc=1.2
op
echo ROW 0 25.0 199 $&v(xt.vth_soft) $&v(xt.vth_hard) $&v(vref_buf) $&v(isense) $&i(vdda)
alter Vs0 dc=0
alter Vh0 dc=0
alter Vs1 dc=0
alter Vh1 dc=0
alter Vs2 dc=0
alter Vh2 dc=0
alter Vs3 dc=1.2
alter Vh3 dc=1.2
alter Vs4 dc=0
alter Vh4 dc=0
alter Vs5 dc=0
alter Vh5 dc=0
alter Vs6 dc=1.2
alter Vh6 dc=1.2
alter Vs7 dc=1.2
alter Vh7 dc=1.2
op
echo ROW 0 25.0 200 $&v(xt.vth_soft) $&v(xt.vth_hard) $&v(vref_buf) $&v(isense) $&i(vdda)
alter Vs0 dc=1.2
alter Vh0 dc=1.2
alter Vs1 dc=0
alter Vh1 dc=0
alter Vs2 dc=0
alter Vh2 dc=0
alter Vs3 dc=1.2
alter Vh3 dc=1.2
alter Vs4 dc=0
alter Vh4 dc=0
alter Vs5 dc=0
alter Vh5 dc=0
alter Vs6 dc=1.2
alter Vh6 dc=1.2
alter Vs7 dc=1.2
alter Vh7 dc=1.2
op
echo ROW 0 25.0 201 $&v(xt.vth_soft) $&v(xt.vth_hard) $&v(vref_buf) $&v(isense) $&i(vdda)
alter Vs0 dc=0
alter Vh0 dc=0
alter Vs1 dc=1.2
alter Vh1 dc=1.2
alter Vs2 dc=0
alter Vh2 dc=0
alter Vs3 dc=1.2
alter Vh3 dc=1.2
alter Vs4 dc=0
alter Vh4 dc=0
alter Vs5 dc=0
alter Vh5 dc=0
alter Vs6 dc=1.2
alter Vh6 dc=1.2
alter Vs7 dc=1.2
alter Vh7 dc=1.2
op
echo ROW 0 25.0 202 $&v(xt.vth_soft) $&v(xt.vth_hard) $&v(vref_buf) $&v(isense) $&i(vdda)
alter Vs0 dc=1.2
alter Vh0 dc=1.2
alter Vs1 dc=1.2
alter Vh1 dc=1.2
alter Vs2 dc=0
alter Vh2 dc=0
alter Vs3 dc=1.2
alter Vh3 dc=1.2
alter Vs4 dc=0
alter Vh4 dc=0
alter Vs5 dc=0
alter Vh5 dc=0
alter Vs6 dc=1.2
alter Vh6 dc=1.2
alter Vs7 dc=1.2
alter Vh7 dc=1.2
op
echo ROW 0 25.0 203 $&v(xt.vth_soft) $&v(xt.vth_hard) $&v(vref_buf) $&v(isense) $&i(vdda)
alter Vs0 dc=0
alter Vh0 dc=0
alter Vs1 dc=0
alter Vh1 dc=0
alter Vs2 dc=1.2
alter Vh2 dc=1.2
alter Vs3 dc=1.2
alter Vh3 dc=1.2
alter Vs4 dc=0
alter Vh4 dc=0
alter Vs5 dc=0
alter Vh5 dc=0
alter Vs6 dc=1.2
alter Vh6 dc=1.2
alter Vs7 dc=1.2
alter Vh7 dc=1.2
op
echo ROW 0 25.0 204 $&v(xt.vth_soft) $&v(xt.vth_hard) $&v(vref_buf) $&v(isense) $&i(vdda)
alter Vs0 dc=1.2
alter Vh0 dc=1.2
alter Vs1 dc=0
alter Vh1 dc=0
alter Vs2 dc=1.2
alter Vh2 dc=1.2
alter Vs3 dc=1.2
alter Vh3 dc=1.2
alter Vs4 dc=0
alter Vh4 dc=0
alter Vs5 dc=0
alter Vh5 dc=0
alter Vs6 dc=1.2
alter Vh6 dc=1.2
alter Vs7 dc=1.2
alter Vh7 dc=1.2
op
echo ROW 0 25.0 205 $&v(xt.vth_soft) $&v(xt.vth_hard) $&v(vref_buf) $&v(isense) $&i(vdda)
alter Vs0 dc=0
alter Vh0 dc=0
alter Vs1 dc=1.2
alter Vh1 dc=1.2
alter Vs2 dc=1.2
alter Vh2 dc=1.2
alter Vs3 dc=1.2
alter Vh3 dc=1.2
alter Vs4 dc=0
alter Vh4 dc=0
alter Vs5 dc=0
alter Vh5 dc=0
alter Vs6 dc=1.2
alter Vh6 dc=1.2
alter Vs7 dc=1.2
alter Vh7 dc=1.2
op
echo ROW 0 25.0 206 $&v(xt.vth_soft) $&v(xt.vth_hard) $&v(vref_buf) $&v(isense) $&i(vdda)
alter Vs0 dc=1.2
alter Vh0 dc=1.2
alter Vs1 dc=1.2
alter Vh1 dc=1.2
alter Vs2 dc=1.2
alter Vh2 dc=1.2
alter Vs3 dc=1.2
alter Vh3 dc=1.2
alter Vs4 dc=0
alter Vh4 dc=0
alter Vs5 dc=0
alter Vh5 dc=0
alter Vs6 dc=1.2
alter Vh6 dc=1.2
alter Vs7 dc=1.2
alter Vh7 dc=1.2
op
echo ROW 0 25.0 207 $&v(xt.vth_soft) $&v(xt.vth_hard) $&v(vref_buf) $&v(isense) $&i(vdda)
alter Vs0 dc=0
alter Vh0 dc=0
alter Vs1 dc=0
alter Vh1 dc=0
alter Vs2 dc=0
alter Vh2 dc=0
alter Vs3 dc=0
alter Vh3 dc=0
alter Vs4 dc=1.2
alter Vh4 dc=1.2
alter Vs5 dc=0
alter Vh5 dc=0
alter Vs6 dc=1.2
alter Vh6 dc=1.2
alter Vs7 dc=1.2
alter Vh7 dc=1.2
op
echo ROW 0 25.0 208 $&v(xt.vth_soft) $&v(xt.vth_hard) $&v(vref_buf) $&v(isense) $&i(vdda)
alter Vs0 dc=1.2
alter Vh0 dc=1.2
alter Vs1 dc=0
alter Vh1 dc=0
alter Vs2 dc=0
alter Vh2 dc=0
alter Vs3 dc=0
alter Vh3 dc=0
alter Vs4 dc=1.2
alter Vh4 dc=1.2
alter Vs5 dc=0
alter Vh5 dc=0
alter Vs6 dc=1.2
alter Vh6 dc=1.2
alter Vs7 dc=1.2
alter Vh7 dc=1.2
op
echo ROW 0 25.0 209 $&v(xt.vth_soft) $&v(xt.vth_hard) $&v(vref_buf) $&v(isense) $&i(vdda)
alter Vs0 dc=0
alter Vh0 dc=0
alter Vs1 dc=1.2
alter Vh1 dc=1.2
alter Vs2 dc=0
alter Vh2 dc=0
alter Vs3 dc=0
alter Vh3 dc=0
alter Vs4 dc=1.2
alter Vh4 dc=1.2
alter Vs5 dc=0
alter Vh5 dc=0
alter Vs6 dc=1.2
alter Vh6 dc=1.2
alter Vs7 dc=1.2
alter Vh7 dc=1.2
op
echo ROW 0 25.0 210 $&v(xt.vth_soft) $&v(xt.vth_hard) $&v(vref_buf) $&v(isense) $&i(vdda)
alter Vs0 dc=1.2
alter Vh0 dc=1.2
alter Vs1 dc=1.2
alter Vh1 dc=1.2
alter Vs2 dc=0
alter Vh2 dc=0
alter Vs3 dc=0
alter Vh3 dc=0
alter Vs4 dc=1.2
alter Vh4 dc=1.2
alter Vs5 dc=0
alter Vh5 dc=0
alter Vs6 dc=1.2
alter Vh6 dc=1.2
alter Vs7 dc=1.2
alter Vh7 dc=1.2
op
echo ROW 0 25.0 211 $&v(xt.vth_soft) $&v(xt.vth_hard) $&v(vref_buf) $&v(isense) $&i(vdda)
alter Vs0 dc=0
alter Vh0 dc=0
alter Vs1 dc=0
alter Vh1 dc=0
alter Vs2 dc=1.2
alter Vh2 dc=1.2
alter Vs3 dc=0
alter Vh3 dc=0
alter Vs4 dc=1.2
alter Vh4 dc=1.2
alter Vs5 dc=0
alter Vh5 dc=0
alter Vs6 dc=1.2
alter Vh6 dc=1.2
alter Vs7 dc=1.2
alter Vh7 dc=1.2
op
echo ROW 0 25.0 212 $&v(xt.vth_soft) $&v(xt.vth_hard) $&v(vref_buf) $&v(isense) $&i(vdda)
alter Vs0 dc=1.2
alter Vh0 dc=1.2
alter Vs1 dc=0
alter Vh1 dc=0
alter Vs2 dc=1.2
alter Vh2 dc=1.2
alter Vs3 dc=0
alter Vh3 dc=0
alter Vs4 dc=1.2
alter Vh4 dc=1.2
alter Vs5 dc=0
alter Vh5 dc=0
alter Vs6 dc=1.2
alter Vh6 dc=1.2
alter Vs7 dc=1.2
alter Vh7 dc=1.2
op
echo ROW 0 25.0 213 $&v(xt.vth_soft) $&v(xt.vth_hard) $&v(vref_buf) $&v(isense) $&i(vdda)
alter Vs0 dc=0
alter Vh0 dc=0
alter Vs1 dc=1.2
alter Vh1 dc=1.2
alter Vs2 dc=1.2
alter Vh2 dc=1.2
alter Vs3 dc=0
alter Vh3 dc=0
alter Vs4 dc=1.2
alter Vh4 dc=1.2
alter Vs5 dc=0
alter Vh5 dc=0
alter Vs6 dc=1.2
alter Vh6 dc=1.2
alter Vs7 dc=1.2
alter Vh7 dc=1.2
op
echo ROW 0 25.0 214 $&v(xt.vth_soft) $&v(xt.vth_hard) $&v(vref_buf) $&v(isense) $&i(vdda)
alter Vs0 dc=1.2
alter Vh0 dc=1.2
alter Vs1 dc=1.2
alter Vh1 dc=1.2
alter Vs2 dc=1.2
alter Vh2 dc=1.2
alter Vs3 dc=0
alter Vh3 dc=0
alter Vs4 dc=1.2
alter Vh4 dc=1.2
alter Vs5 dc=0
alter Vh5 dc=0
alter Vs6 dc=1.2
alter Vh6 dc=1.2
alter Vs7 dc=1.2
alter Vh7 dc=1.2
op
echo ROW 0 25.0 215 $&v(xt.vth_soft) $&v(xt.vth_hard) $&v(vref_buf) $&v(isense) $&i(vdda)
alter Vs0 dc=0
alter Vh0 dc=0
alter Vs1 dc=0
alter Vh1 dc=0
alter Vs2 dc=0
alter Vh2 dc=0
alter Vs3 dc=1.2
alter Vh3 dc=1.2
alter Vs4 dc=1.2
alter Vh4 dc=1.2
alter Vs5 dc=0
alter Vh5 dc=0
alter Vs6 dc=1.2
alter Vh6 dc=1.2
alter Vs7 dc=1.2
alter Vh7 dc=1.2
op
echo ROW 0 25.0 216 $&v(xt.vth_soft) $&v(xt.vth_hard) $&v(vref_buf) $&v(isense) $&i(vdda)
alter Vs0 dc=1.2
alter Vh0 dc=1.2
alter Vs1 dc=0
alter Vh1 dc=0
alter Vs2 dc=0
alter Vh2 dc=0
alter Vs3 dc=1.2
alter Vh3 dc=1.2
alter Vs4 dc=1.2
alter Vh4 dc=1.2
alter Vs5 dc=0
alter Vh5 dc=0
alter Vs6 dc=1.2
alter Vh6 dc=1.2
alter Vs7 dc=1.2
alter Vh7 dc=1.2
op
echo ROW 0 25.0 217 $&v(xt.vth_soft) $&v(xt.vth_hard) $&v(vref_buf) $&v(isense) $&i(vdda)
alter Vs0 dc=0
alter Vh0 dc=0
alter Vs1 dc=1.2
alter Vh1 dc=1.2
alter Vs2 dc=0
alter Vh2 dc=0
alter Vs3 dc=1.2
alter Vh3 dc=1.2
alter Vs4 dc=1.2
alter Vh4 dc=1.2
alter Vs5 dc=0
alter Vh5 dc=0
alter Vs6 dc=1.2
alter Vh6 dc=1.2
alter Vs7 dc=1.2
alter Vh7 dc=1.2
op
echo ROW 0 25.0 218 $&v(xt.vth_soft) $&v(xt.vth_hard) $&v(vref_buf) $&v(isense) $&i(vdda)
alter Vs0 dc=1.2
alter Vh0 dc=1.2
alter Vs1 dc=1.2
alter Vh1 dc=1.2
alter Vs2 dc=0
alter Vh2 dc=0
alter Vs3 dc=1.2
alter Vh3 dc=1.2
alter Vs4 dc=1.2
alter Vh4 dc=1.2
alter Vs5 dc=0
alter Vh5 dc=0
alter Vs6 dc=1.2
alter Vh6 dc=1.2
alter Vs7 dc=1.2
alter Vh7 dc=1.2
op
echo ROW 0 25.0 219 $&v(xt.vth_soft) $&v(xt.vth_hard) $&v(vref_buf) $&v(isense) $&i(vdda)
alter Vs0 dc=0
alter Vh0 dc=0
alter Vs1 dc=0
alter Vh1 dc=0
alter Vs2 dc=1.2
alter Vh2 dc=1.2
alter Vs3 dc=1.2
alter Vh3 dc=1.2
alter Vs4 dc=1.2
alter Vh4 dc=1.2
alter Vs5 dc=0
alter Vh5 dc=0
alter Vs6 dc=1.2
alter Vh6 dc=1.2
alter Vs7 dc=1.2
alter Vh7 dc=1.2
op
echo ROW 0 25.0 220 $&v(xt.vth_soft) $&v(xt.vth_hard) $&v(vref_buf) $&v(isense) $&i(vdda)
alter Vs0 dc=1.2
alter Vh0 dc=1.2
alter Vs1 dc=0
alter Vh1 dc=0
alter Vs2 dc=1.2
alter Vh2 dc=1.2
alter Vs3 dc=1.2
alter Vh3 dc=1.2
alter Vs4 dc=1.2
alter Vh4 dc=1.2
alter Vs5 dc=0
alter Vh5 dc=0
alter Vs6 dc=1.2
alter Vh6 dc=1.2
alter Vs7 dc=1.2
alter Vh7 dc=1.2
op
echo ROW 0 25.0 221 $&v(xt.vth_soft) $&v(xt.vth_hard) $&v(vref_buf) $&v(isense) $&i(vdda)
alter Vs0 dc=0
alter Vh0 dc=0
alter Vs1 dc=1.2
alter Vh1 dc=1.2
alter Vs2 dc=1.2
alter Vh2 dc=1.2
alter Vs3 dc=1.2
alter Vh3 dc=1.2
alter Vs4 dc=1.2
alter Vh4 dc=1.2
alter Vs5 dc=0
alter Vh5 dc=0
alter Vs6 dc=1.2
alter Vh6 dc=1.2
alter Vs7 dc=1.2
alter Vh7 dc=1.2
op
echo ROW 0 25.0 222 $&v(xt.vth_soft) $&v(xt.vth_hard) $&v(vref_buf) $&v(isense) $&i(vdda)
alter Vs0 dc=1.2
alter Vh0 dc=1.2
alter Vs1 dc=1.2
alter Vh1 dc=1.2
alter Vs2 dc=1.2
alter Vh2 dc=1.2
alter Vs3 dc=1.2
alter Vh3 dc=1.2
alter Vs4 dc=1.2
alter Vh4 dc=1.2
alter Vs5 dc=0
alter Vh5 dc=0
alter Vs6 dc=1.2
alter Vh6 dc=1.2
alter Vs7 dc=1.2
alter Vh7 dc=1.2
op
echo ROW 0 25.0 223 $&v(xt.vth_soft) $&v(xt.vth_hard) $&v(vref_buf) $&v(isense) $&i(vdda)
alter Vs0 dc=0
alter Vh0 dc=0
alter Vs1 dc=0
alter Vh1 dc=0
alter Vs2 dc=0
alter Vh2 dc=0
alter Vs3 dc=0
alter Vh3 dc=0
alter Vs4 dc=0
alter Vh4 dc=0
alter Vs5 dc=1.2
alter Vh5 dc=1.2
alter Vs6 dc=1.2
alter Vh6 dc=1.2
alter Vs7 dc=1.2
alter Vh7 dc=1.2
op
echo ROW 0 25.0 224 $&v(xt.vth_soft) $&v(xt.vth_hard) $&v(vref_buf) $&v(isense) $&i(vdda)
alter Vs0 dc=1.2
alter Vh0 dc=1.2
alter Vs1 dc=0
alter Vh1 dc=0
alter Vs2 dc=0
alter Vh2 dc=0
alter Vs3 dc=0
alter Vh3 dc=0
alter Vs4 dc=0
alter Vh4 dc=0
alter Vs5 dc=1.2
alter Vh5 dc=1.2
alter Vs6 dc=1.2
alter Vh6 dc=1.2
alter Vs7 dc=1.2
alter Vh7 dc=1.2
op
echo ROW 0 25.0 225 $&v(xt.vth_soft) $&v(xt.vth_hard) $&v(vref_buf) $&v(isense) $&i(vdda)
alter Vs0 dc=0
alter Vh0 dc=0
alter Vs1 dc=1.2
alter Vh1 dc=1.2
alter Vs2 dc=0
alter Vh2 dc=0
alter Vs3 dc=0
alter Vh3 dc=0
alter Vs4 dc=0
alter Vh4 dc=0
alter Vs5 dc=1.2
alter Vh5 dc=1.2
alter Vs6 dc=1.2
alter Vh6 dc=1.2
alter Vs7 dc=1.2
alter Vh7 dc=1.2
op
echo ROW 0 25.0 226 $&v(xt.vth_soft) $&v(xt.vth_hard) $&v(vref_buf) $&v(isense) $&i(vdda)
alter Vs0 dc=1.2
alter Vh0 dc=1.2
alter Vs1 dc=1.2
alter Vh1 dc=1.2
alter Vs2 dc=0
alter Vh2 dc=0
alter Vs3 dc=0
alter Vh3 dc=0
alter Vs4 dc=0
alter Vh4 dc=0
alter Vs5 dc=1.2
alter Vh5 dc=1.2
alter Vs6 dc=1.2
alter Vh6 dc=1.2
alter Vs7 dc=1.2
alter Vh7 dc=1.2
op
echo ROW 0 25.0 227 $&v(xt.vth_soft) $&v(xt.vth_hard) $&v(vref_buf) $&v(isense) $&i(vdda)
alter Vs0 dc=0
alter Vh0 dc=0
alter Vs1 dc=0
alter Vh1 dc=0
alter Vs2 dc=1.2
alter Vh2 dc=1.2
alter Vs3 dc=0
alter Vh3 dc=0
alter Vs4 dc=0
alter Vh4 dc=0
alter Vs5 dc=1.2
alter Vh5 dc=1.2
alter Vs6 dc=1.2
alter Vh6 dc=1.2
alter Vs7 dc=1.2
alter Vh7 dc=1.2
op
echo ROW 0 25.0 228 $&v(xt.vth_soft) $&v(xt.vth_hard) $&v(vref_buf) $&v(isense) $&i(vdda)
alter Vs0 dc=1.2
alter Vh0 dc=1.2
alter Vs1 dc=0
alter Vh1 dc=0
alter Vs2 dc=1.2
alter Vh2 dc=1.2
alter Vs3 dc=0
alter Vh3 dc=0
alter Vs4 dc=0
alter Vh4 dc=0
alter Vs5 dc=1.2
alter Vh5 dc=1.2
alter Vs6 dc=1.2
alter Vh6 dc=1.2
alter Vs7 dc=1.2
alter Vh7 dc=1.2
op
echo ROW 0 25.0 229 $&v(xt.vth_soft) $&v(xt.vth_hard) $&v(vref_buf) $&v(isense) $&i(vdda)
alter Vs0 dc=0
alter Vh0 dc=0
alter Vs1 dc=1.2
alter Vh1 dc=1.2
alter Vs2 dc=1.2
alter Vh2 dc=1.2
alter Vs3 dc=0
alter Vh3 dc=0
alter Vs4 dc=0
alter Vh4 dc=0
alter Vs5 dc=1.2
alter Vh5 dc=1.2
alter Vs6 dc=1.2
alter Vh6 dc=1.2
alter Vs7 dc=1.2
alter Vh7 dc=1.2
op
echo ROW 0 25.0 230 $&v(xt.vth_soft) $&v(xt.vth_hard) $&v(vref_buf) $&v(isense) $&i(vdda)
alter Vs0 dc=1.2
alter Vh0 dc=1.2
alter Vs1 dc=1.2
alter Vh1 dc=1.2
alter Vs2 dc=1.2
alter Vh2 dc=1.2
alter Vs3 dc=0
alter Vh3 dc=0
alter Vs4 dc=0
alter Vh4 dc=0
alter Vs5 dc=1.2
alter Vh5 dc=1.2
alter Vs6 dc=1.2
alter Vh6 dc=1.2
alter Vs7 dc=1.2
alter Vh7 dc=1.2
op
echo ROW 0 25.0 231 $&v(xt.vth_soft) $&v(xt.vth_hard) $&v(vref_buf) $&v(isense) $&i(vdda)
alter Vs0 dc=0
alter Vh0 dc=0
alter Vs1 dc=0
alter Vh1 dc=0
alter Vs2 dc=0
alter Vh2 dc=0
alter Vs3 dc=1.2
alter Vh3 dc=1.2
alter Vs4 dc=0
alter Vh4 dc=0
alter Vs5 dc=1.2
alter Vh5 dc=1.2
alter Vs6 dc=1.2
alter Vh6 dc=1.2
alter Vs7 dc=1.2
alter Vh7 dc=1.2
op
echo ROW 0 25.0 232 $&v(xt.vth_soft) $&v(xt.vth_hard) $&v(vref_buf) $&v(isense) $&i(vdda)
alter Vs0 dc=1.2
alter Vh0 dc=1.2
alter Vs1 dc=0
alter Vh1 dc=0
alter Vs2 dc=0
alter Vh2 dc=0
alter Vs3 dc=1.2
alter Vh3 dc=1.2
alter Vs4 dc=0
alter Vh4 dc=0
alter Vs5 dc=1.2
alter Vh5 dc=1.2
alter Vs6 dc=1.2
alter Vh6 dc=1.2
alter Vs7 dc=1.2
alter Vh7 dc=1.2
op
echo ROW 0 25.0 233 $&v(xt.vth_soft) $&v(xt.vth_hard) $&v(vref_buf) $&v(isense) $&i(vdda)
alter Vs0 dc=0
alter Vh0 dc=0
alter Vs1 dc=1.2
alter Vh1 dc=1.2
alter Vs2 dc=0
alter Vh2 dc=0
alter Vs3 dc=1.2
alter Vh3 dc=1.2
alter Vs4 dc=0
alter Vh4 dc=0
alter Vs5 dc=1.2
alter Vh5 dc=1.2
alter Vs6 dc=1.2
alter Vh6 dc=1.2
alter Vs7 dc=1.2
alter Vh7 dc=1.2
op
echo ROW 0 25.0 234 $&v(xt.vth_soft) $&v(xt.vth_hard) $&v(vref_buf) $&v(isense) $&i(vdda)
alter Vs0 dc=1.2
alter Vh0 dc=1.2
alter Vs1 dc=1.2
alter Vh1 dc=1.2
alter Vs2 dc=0
alter Vh2 dc=0
alter Vs3 dc=1.2
alter Vh3 dc=1.2
alter Vs4 dc=0
alter Vh4 dc=0
alter Vs5 dc=1.2
alter Vh5 dc=1.2
alter Vs6 dc=1.2
alter Vh6 dc=1.2
alter Vs7 dc=1.2
alter Vh7 dc=1.2
op
echo ROW 0 25.0 235 $&v(xt.vth_soft) $&v(xt.vth_hard) $&v(vref_buf) $&v(isense) $&i(vdda)
alter Vs0 dc=0
alter Vh0 dc=0
alter Vs1 dc=0
alter Vh1 dc=0
alter Vs2 dc=1.2
alter Vh2 dc=1.2
alter Vs3 dc=1.2
alter Vh3 dc=1.2
alter Vs4 dc=0
alter Vh4 dc=0
alter Vs5 dc=1.2
alter Vh5 dc=1.2
alter Vs6 dc=1.2
alter Vh6 dc=1.2
alter Vs7 dc=1.2
alter Vh7 dc=1.2
op
echo ROW 0 25.0 236 $&v(xt.vth_soft) $&v(xt.vth_hard) $&v(vref_buf) $&v(isense) $&i(vdda)
alter Vs0 dc=1.2
alter Vh0 dc=1.2
alter Vs1 dc=0
alter Vh1 dc=0
alter Vs2 dc=1.2
alter Vh2 dc=1.2
alter Vs3 dc=1.2
alter Vh3 dc=1.2
alter Vs4 dc=0
alter Vh4 dc=0
alter Vs5 dc=1.2
alter Vh5 dc=1.2
alter Vs6 dc=1.2
alter Vh6 dc=1.2
alter Vs7 dc=1.2
alter Vh7 dc=1.2
op
echo ROW 0 25.0 237 $&v(xt.vth_soft) $&v(xt.vth_hard) $&v(vref_buf) $&v(isense) $&i(vdda)
alter Vs0 dc=0
alter Vh0 dc=0
alter Vs1 dc=1.2
alter Vh1 dc=1.2
alter Vs2 dc=1.2
alter Vh2 dc=1.2
alter Vs3 dc=1.2
alter Vh3 dc=1.2
alter Vs4 dc=0
alter Vh4 dc=0
alter Vs5 dc=1.2
alter Vh5 dc=1.2
alter Vs6 dc=1.2
alter Vh6 dc=1.2
alter Vs7 dc=1.2
alter Vh7 dc=1.2
op
echo ROW 0 25.0 238 $&v(xt.vth_soft) $&v(xt.vth_hard) $&v(vref_buf) $&v(isense) $&i(vdda)
alter Vs0 dc=1.2
alter Vh0 dc=1.2
alter Vs1 dc=1.2
alter Vh1 dc=1.2
alter Vs2 dc=1.2
alter Vh2 dc=1.2
alter Vs3 dc=1.2
alter Vh3 dc=1.2
alter Vs4 dc=0
alter Vh4 dc=0
alter Vs5 dc=1.2
alter Vh5 dc=1.2
alter Vs6 dc=1.2
alter Vh6 dc=1.2
alter Vs7 dc=1.2
alter Vh7 dc=1.2
op
echo ROW 0 25.0 239 $&v(xt.vth_soft) $&v(xt.vth_hard) $&v(vref_buf) $&v(isense) $&i(vdda)
alter Vs0 dc=0
alter Vh0 dc=0
alter Vs1 dc=0
alter Vh1 dc=0
alter Vs2 dc=0
alter Vh2 dc=0
alter Vs3 dc=0
alter Vh3 dc=0
alter Vs4 dc=1.2
alter Vh4 dc=1.2
alter Vs5 dc=1.2
alter Vh5 dc=1.2
alter Vs6 dc=1.2
alter Vh6 dc=1.2
alter Vs7 dc=1.2
alter Vh7 dc=1.2
op
echo ROW 0 25.0 240 $&v(xt.vth_soft) $&v(xt.vth_hard) $&v(vref_buf) $&v(isense) $&i(vdda)
alter Vs0 dc=1.2
alter Vh0 dc=1.2
alter Vs1 dc=0
alter Vh1 dc=0
alter Vs2 dc=0
alter Vh2 dc=0
alter Vs3 dc=0
alter Vh3 dc=0
alter Vs4 dc=1.2
alter Vh4 dc=1.2
alter Vs5 dc=1.2
alter Vh5 dc=1.2
alter Vs6 dc=1.2
alter Vh6 dc=1.2
alter Vs7 dc=1.2
alter Vh7 dc=1.2
op
echo ROW 0 25.0 241 $&v(xt.vth_soft) $&v(xt.vth_hard) $&v(vref_buf) $&v(isense) $&i(vdda)
alter Vs0 dc=0
alter Vh0 dc=0
alter Vs1 dc=1.2
alter Vh1 dc=1.2
alter Vs2 dc=0
alter Vh2 dc=0
alter Vs3 dc=0
alter Vh3 dc=0
alter Vs4 dc=1.2
alter Vh4 dc=1.2
alter Vs5 dc=1.2
alter Vh5 dc=1.2
alter Vs6 dc=1.2
alter Vh6 dc=1.2
alter Vs7 dc=1.2
alter Vh7 dc=1.2
op
echo ROW 0 25.0 242 $&v(xt.vth_soft) $&v(xt.vth_hard) $&v(vref_buf) $&v(isense) $&i(vdda)
alter Vs0 dc=1.2
alter Vh0 dc=1.2
alter Vs1 dc=1.2
alter Vh1 dc=1.2
alter Vs2 dc=0
alter Vh2 dc=0
alter Vs3 dc=0
alter Vh3 dc=0
alter Vs4 dc=1.2
alter Vh4 dc=1.2
alter Vs5 dc=1.2
alter Vh5 dc=1.2
alter Vs6 dc=1.2
alter Vh6 dc=1.2
alter Vs7 dc=1.2
alter Vh7 dc=1.2
op
echo ROW 0 25.0 243 $&v(xt.vth_soft) $&v(xt.vth_hard) $&v(vref_buf) $&v(isense) $&i(vdda)
alter Vs0 dc=0
alter Vh0 dc=0
alter Vs1 dc=0
alter Vh1 dc=0
alter Vs2 dc=1.2
alter Vh2 dc=1.2
alter Vs3 dc=0
alter Vh3 dc=0
alter Vs4 dc=1.2
alter Vh4 dc=1.2
alter Vs5 dc=1.2
alter Vh5 dc=1.2
alter Vs6 dc=1.2
alter Vh6 dc=1.2
alter Vs7 dc=1.2
alter Vh7 dc=1.2
op
echo ROW 0 25.0 244 $&v(xt.vth_soft) $&v(xt.vth_hard) $&v(vref_buf) $&v(isense) $&i(vdda)
alter Vs0 dc=1.2
alter Vh0 dc=1.2
alter Vs1 dc=0
alter Vh1 dc=0
alter Vs2 dc=1.2
alter Vh2 dc=1.2
alter Vs3 dc=0
alter Vh3 dc=0
alter Vs4 dc=1.2
alter Vh4 dc=1.2
alter Vs5 dc=1.2
alter Vh5 dc=1.2
alter Vs6 dc=1.2
alter Vh6 dc=1.2
alter Vs7 dc=1.2
alter Vh7 dc=1.2
op
echo ROW 0 25.0 245 $&v(xt.vth_soft) $&v(xt.vth_hard) $&v(vref_buf) $&v(isense) $&i(vdda)
alter Vs0 dc=0
alter Vh0 dc=0
alter Vs1 dc=1.2
alter Vh1 dc=1.2
alter Vs2 dc=1.2
alter Vh2 dc=1.2
alter Vs3 dc=0
alter Vh3 dc=0
alter Vs4 dc=1.2
alter Vh4 dc=1.2
alter Vs5 dc=1.2
alter Vh5 dc=1.2
alter Vs6 dc=1.2
alter Vh6 dc=1.2
alter Vs7 dc=1.2
alter Vh7 dc=1.2
op
echo ROW 0 25.0 246 $&v(xt.vth_soft) $&v(xt.vth_hard) $&v(vref_buf) $&v(isense) $&i(vdda)
alter Vs0 dc=1.2
alter Vh0 dc=1.2
alter Vs1 dc=1.2
alter Vh1 dc=1.2
alter Vs2 dc=1.2
alter Vh2 dc=1.2
alter Vs3 dc=0
alter Vh3 dc=0
alter Vs4 dc=1.2
alter Vh4 dc=1.2
alter Vs5 dc=1.2
alter Vh5 dc=1.2
alter Vs6 dc=1.2
alter Vh6 dc=1.2
alter Vs7 dc=1.2
alter Vh7 dc=1.2
op
echo ROW 0 25.0 247 $&v(xt.vth_soft) $&v(xt.vth_hard) $&v(vref_buf) $&v(isense) $&i(vdda)
alter Vs0 dc=0
alter Vh0 dc=0
alter Vs1 dc=0
alter Vh1 dc=0
alter Vs2 dc=0
alter Vh2 dc=0
alter Vs3 dc=1.2
alter Vh3 dc=1.2
alter Vs4 dc=1.2
alter Vh4 dc=1.2
alter Vs5 dc=1.2
alter Vh5 dc=1.2
alter Vs6 dc=1.2
alter Vh6 dc=1.2
alter Vs7 dc=1.2
alter Vh7 dc=1.2
op
echo ROW 0 25.0 248 $&v(xt.vth_soft) $&v(xt.vth_hard) $&v(vref_buf) $&v(isense) $&i(vdda)
alter Vs0 dc=1.2
alter Vh0 dc=1.2
alter Vs1 dc=0
alter Vh1 dc=0
alter Vs2 dc=0
alter Vh2 dc=0
alter Vs3 dc=1.2
alter Vh3 dc=1.2
alter Vs4 dc=1.2
alter Vh4 dc=1.2
alter Vs5 dc=1.2
alter Vh5 dc=1.2
alter Vs6 dc=1.2
alter Vh6 dc=1.2
alter Vs7 dc=1.2
alter Vh7 dc=1.2
op
echo ROW 0 25.0 249 $&v(xt.vth_soft) $&v(xt.vth_hard) $&v(vref_buf) $&v(isense) $&i(vdda)
alter Vs0 dc=0
alter Vh0 dc=0
alter Vs1 dc=1.2
alter Vh1 dc=1.2
alter Vs2 dc=0
alter Vh2 dc=0
alter Vs3 dc=1.2
alter Vh3 dc=1.2
alter Vs4 dc=1.2
alter Vh4 dc=1.2
alter Vs5 dc=1.2
alter Vh5 dc=1.2
alter Vs6 dc=1.2
alter Vh6 dc=1.2
alter Vs7 dc=1.2
alter Vh7 dc=1.2
op
echo ROW 0 25.0 250 $&v(xt.vth_soft) $&v(xt.vth_hard) $&v(vref_buf) $&v(isense) $&i(vdda)
alter Vs0 dc=1.2
alter Vh0 dc=1.2
alter Vs1 dc=1.2
alter Vh1 dc=1.2
alter Vs2 dc=0
alter Vh2 dc=0
alter Vs3 dc=1.2
alter Vh3 dc=1.2
alter Vs4 dc=1.2
alter Vh4 dc=1.2
alter Vs5 dc=1.2
alter Vh5 dc=1.2
alter Vs6 dc=1.2
alter Vh6 dc=1.2
alter Vs7 dc=1.2
alter Vh7 dc=1.2
op
echo ROW 0 25.0 251 $&v(xt.vth_soft) $&v(xt.vth_hard) $&v(vref_buf) $&v(isense) $&i(vdda)
alter Vs0 dc=0
alter Vh0 dc=0
alter Vs1 dc=0
alter Vh1 dc=0
alter Vs2 dc=1.2
alter Vh2 dc=1.2
alter Vs3 dc=1.2
alter Vh3 dc=1.2
alter Vs4 dc=1.2
alter Vh4 dc=1.2
alter Vs5 dc=1.2
alter Vh5 dc=1.2
alter Vs6 dc=1.2
alter Vh6 dc=1.2
alter Vs7 dc=1.2
alter Vh7 dc=1.2
op
echo ROW 0 25.0 252 $&v(xt.vth_soft) $&v(xt.vth_hard) $&v(vref_buf) $&v(isense) $&i(vdda)
alter Vs0 dc=1.2
alter Vh0 dc=1.2
alter Vs1 dc=0
alter Vh1 dc=0
alter Vs2 dc=1.2
alter Vh2 dc=1.2
alter Vs3 dc=1.2
alter Vh3 dc=1.2
alter Vs4 dc=1.2
alter Vh4 dc=1.2
alter Vs5 dc=1.2
alter Vh5 dc=1.2
alter Vs6 dc=1.2
alter Vh6 dc=1.2
alter Vs7 dc=1.2
alter Vh7 dc=1.2
op
echo ROW 0 25.0 253 $&v(xt.vth_soft) $&v(xt.vth_hard) $&v(vref_buf) $&v(isense) $&i(vdda)
alter Vs0 dc=0
alter Vh0 dc=0
alter Vs1 dc=1.2
alter Vh1 dc=1.2
alter Vs2 dc=1.2
alter Vh2 dc=1.2
alter Vs3 dc=1.2
alter Vh3 dc=1.2
alter Vs4 dc=1.2
alter Vh4 dc=1.2
alter Vs5 dc=1.2
alter Vh5 dc=1.2
alter Vs6 dc=1.2
alter Vh6 dc=1.2
alter Vs7 dc=1.2
alter Vh7 dc=1.2
op
echo ROW 0 25.0 254 $&v(xt.vth_soft) $&v(xt.vth_hard) $&v(vref_buf) $&v(isense) $&i(vdda)
alter Vs0 dc=1.2
alter Vh0 dc=1.2
alter Vs1 dc=1.2
alter Vh1 dc=1.2
alter Vs2 dc=1.2
alter Vh2 dc=1.2
alter Vs3 dc=1.2
alter Vh3 dc=1.2
alter Vs4 dc=1.2
alter Vh4 dc=1.2
alter Vs5 dc=1.2
alter Vh5 dc=1.2
alter Vs6 dc=1.2
alter Vh6 dc=1.2
alter Vs7 dc=1.2
alter Vh7 dc=1.2
op
echo ROW 0 25.0 255 $&v(xt.vth_soft) $&v(xt.vth_hard) $&v(vref_buf) $&v(isense) $&i(vdda)
echo FINGERPRINT 0
print @n.xt.xdacs.xms7_0a.nsg13_hv_nmos[w]
print @n.xt.xdacs.xms7_0a.nsg13_hv_nmos[l]
print @n.xt.xdacs.xms7_0a.nsg13_hv_nmos[delvto]
print @n.xt.xdacs.xms7_0a.nsg13_hv_nmos[factuo]
print @n.xt.xdach.xms7_0b.nsg13_hv_nmos[w]
print @n.xt.xdach.xms7_0b.nsg13_hv_nmos[l]
print @n.xt.xdach.xms7_0b.nsg13_hv_nmos[delvto]
print @n.xt.xdach.xms7_0b.nsg13_hv_nmos[factuo]
print @n.xt.xcs.xm1.nsg13_lv_nmos[w]
print @n.xt.xcs.xm1.nsg13_lv_nmos[l]
print @n.xt.xcs.xm1.nsg13_lv_nmos[delvto]
print @n.xt.xcs.xm1.nsg13_lv_nmos[factuo]
print @n.xt.xch.xm1.nsg13_lv_nmos[w]
print @n.xt.xch.xm1.nsg13_lv_nmos[l]
print @n.xt.xch.xm1.nsg13_lv_nmos[delvto]
print @n.xt.xch.xm1.nsg13_lv_nmos[factuo]
print @n.xs.xref.xm1.nsg13_hv_pmos[w]
print @n.xs.xref.xm1.nsg13_hv_pmos[l]
print @n.xs.xref.xm1.nsg13_hv_pmos[delvto]
print @n.xs.xref.xm1.nsg13_hv_pmos[factuo]
print @n.xt.xdacs.xru0.nr1[nsmm_rsh]
print @n.xt.xdacs.xru0.nr1[nsmm_w]
print @n.xt.xdacs.xru0.nr1[nsmm_l]
set temp=125.0
alter Iib dc=5.478459103781443e-06
alter Vs0 dc=0
alter Vh0 dc=0
alter Vs1 dc=0
alter Vh1 dc=0
alter Vs2 dc=0
alter Vh2 dc=0
alter Vs3 dc=0
alter Vh3 dc=0
alter Vs4 dc=0
alter Vh4 dc=0
alter Vs5 dc=0
alter Vh5 dc=0
alter Vs6 dc=0
alter Vh6 dc=0
alter Vs7 dc=0
alter Vh7 dc=0
op
echo ROW 1 125.0 0 $&v(xt.vth_soft) $&v(xt.vth_hard) $&v(vref_buf) $&v(isense) $&i(vdda)
alter Vs0 dc=1.2
alter Vh0 dc=1.2
alter Vs1 dc=0
alter Vh1 dc=0
alter Vs2 dc=0
alter Vh2 dc=0
alter Vs3 dc=0
alter Vh3 dc=0
alter Vs4 dc=0
alter Vh4 dc=0
alter Vs5 dc=0
alter Vh5 dc=0
alter Vs6 dc=0
alter Vh6 dc=0
alter Vs7 dc=0
alter Vh7 dc=0
op
echo ROW 1 125.0 1 $&v(xt.vth_soft) $&v(xt.vth_hard) $&v(vref_buf) $&v(isense) $&i(vdda)
alter Vs0 dc=0
alter Vh0 dc=0
alter Vs1 dc=1.2
alter Vh1 dc=1.2
alter Vs2 dc=0
alter Vh2 dc=0
alter Vs3 dc=0
alter Vh3 dc=0
alter Vs4 dc=0
alter Vh4 dc=0
alter Vs5 dc=0
alter Vh5 dc=0
alter Vs6 dc=0
alter Vh6 dc=0
alter Vs7 dc=0
alter Vh7 dc=0
op
echo ROW 1 125.0 2 $&v(xt.vth_soft) $&v(xt.vth_hard) $&v(vref_buf) $&v(isense) $&i(vdda)
alter Vs0 dc=1.2
alter Vh0 dc=1.2
alter Vs1 dc=1.2
alter Vh1 dc=1.2
alter Vs2 dc=0
alter Vh2 dc=0
alter Vs3 dc=0
alter Vh3 dc=0
alter Vs4 dc=0
alter Vh4 dc=0
alter Vs5 dc=0
alter Vh5 dc=0
alter Vs6 dc=0
alter Vh6 dc=0
alter Vs7 dc=0
alter Vh7 dc=0
op
echo ROW 1 125.0 3 $&v(xt.vth_soft) $&v(xt.vth_hard) $&v(vref_buf) $&v(isense) $&i(vdda)
alter Vs0 dc=0
alter Vh0 dc=0
alter Vs1 dc=0
alter Vh1 dc=0
alter Vs2 dc=1.2
alter Vh2 dc=1.2
alter Vs3 dc=0
alter Vh3 dc=0
alter Vs4 dc=0
alter Vh4 dc=0
alter Vs5 dc=0
alter Vh5 dc=0
alter Vs6 dc=0
alter Vh6 dc=0
alter Vs7 dc=0
alter Vh7 dc=0
op
echo ROW 1 125.0 4 $&v(xt.vth_soft) $&v(xt.vth_hard) $&v(vref_buf) $&v(isense) $&i(vdda)
alter Vs0 dc=1.2
alter Vh0 dc=1.2
alter Vs1 dc=0
alter Vh1 dc=0
alter Vs2 dc=1.2
alter Vh2 dc=1.2
alter Vs3 dc=0
alter Vh3 dc=0
alter Vs4 dc=0
alter Vh4 dc=0
alter Vs5 dc=0
alter Vh5 dc=0
alter Vs6 dc=0
alter Vh6 dc=0
alter Vs7 dc=0
alter Vh7 dc=0
op
echo ROW 1 125.0 5 $&v(xt.vth_soft) $&v(xt.vth_hard) $&v(vref_buf) $&v(isense) $&i(vdda)
alter Vs0 dc=0
alter Vh0 dc=0
alter Vs1 dc=1.2
alter Vh1 dc=1.2
alter Vs2 dc=1.2
alter Vh2 dc=1.2
alter Vs3 dc=0
alter Vh3 dc=0
alter Vs4 dc=0
alter Vh4 dc=0
alter Vs5 dc=0
alter Vh5 dc=0
alter Vs6 dc=0
alter Vh6 dc=0
alter Vs7 dc=0
alter Vh7 dc=0
op
echo ROW 1 125.0 6 $&v(xt.vth_soft) $&v(xt.vth_hard) $&v(vref_buf) $&v(isense) $&i(vdda)
alter Vs0 dc=1.2
alter Vh0 dc=1.2
alter Vs1 dc=1.2
alter Vh1 dc=1.2
alter Vs2 dc=1.2
alter Vh2 dc=1.2
alter Vs3 dc=0
alter Vh3 dc=0
alter Vs4 dc=0
alter Vh4 dc=0
alter Vs5 dc=0
alter Vh5 dc=0
alter Vs6 dc=0
alter Vh6 dc=0
alter Vs7 dc=0
alter Vh7 dc=0
op
echo ROW 1 125.0 7 $&v(xt.vth_soft) $&v(xt.vth_hard) $&v(vref_buf) $&v(isense) $&i(vdda)
alter Vs0 dc=0
alter Vh0 dc=0
alter Vs1 dc=0
alter Vh1 dc=0
alter Vs2 dc=0
alter Vh2 dc=0
alter Vs3 dc=1.2
alter Vh3 dc=1.2
alter Vs4 dc=0
alter Vh4 dc=0
alter Vs5 dc=0
alter Vh5 dc=0
alter Vs6 dc=0
alter Vh6 dc=0
alter Vs7 dc=0
alter Vh7 dc=0
op
echo ROW 1 125.0 8 $&v(xt.vth_soft) $&v(xt.vth_hard) $&v(vref_buf) $&v(isense) $&i(vdda)
alter Vs0 dc=1.2
alter Vh0 dc=1.2
alter Vs1 dc=0
alter Vh1 dc=0
alter Vs2 dc=0
alter Vh2 dc=0
alter Vs3 dc=1.2
alter Vh3 dc=1.2
alter Vs4 dc=0
alter Vh4 dc=0
alter Vs5 dc=0
alter Vh5 dc=0
alter Vs6 dc=0
alter Vh6 dc=0
alter Vs7 dc=0
alter Vh7 dc=0
op
echo ROW 1 125.0 9 $&v(xt.vth_soft) $&v(xt.vth_hard) $&v(vref_buf) $&v(isense) $&i(vdda)
alter Vs0 dc=0
alter Vh0 dc=0
alter Vs1 dc=1.2
alter Vh1 dc=1.2
alter Vs2 dc=0
alter Vh2 dc=0
alter Vs3 dc=1.2
alter Vh3 dc=1.2
alter Vs4 dc=0
alter Vh4 dc=0
alter Vs5 dc=0
alter Vh5 dc=0
alter Vs6 dc=0
alter Vh6 dc=0
alter Vs7 dc=0
alter Vh7 dc=0
op
echo ROW 1 125.0 10 $&v(xt.vth_soft) $&v(xt.vth_hard) $&v(vref_buf) $&v(isense) $&i(vdda)
alter Vs0 dc=1.2
alter Vh0 dc=1.2
alter Vs1 dc=1.2
alter Vh1 dc=1.2
alter Vs2 dc=0
alter Vh2 dc=0
alter Vs3 dc=1.2
alter Vh3 dc=1.2
alter Vs4 dc=0
alter Vh4 dc=0
alter Vs5 dc=0
alter Vh5 dc=0
alter Vs6 dc=0
alter Vh6 dc=0
alter Vs7 dc=0
alter Vh7 dc=0
op
echo ROW 1 125.0 11 $&v(xt.vth_soft) $&v(xt.vth_hard) $&v(vref_buf) $&v(isense) $&i(vdda)
alter Vs0 dc=0
alter Vh0 dc=0
alter Vs1 dc=0
alter Vh1 dc=0
alter Vs2 dc=1.2
alter Vh2 dc=1.2
alter Vs3 dc=1.2
alter Vh3 dc=1.2
alter Vs4 dc=0
alter Vh4 dc=0
alter Vs5 dc=0
alter Vh5 dc=0
alter Vs6 dc=0
alter Vh6 dc=0
alter Vs7 dc=0
alter Vh7 dc=0
op
echo ROW 1 125.0 12 $&v(xt.vth_soft) $&v(xt.vth_hard) $&v(vref_buf) $&v(isense) $&i(vdda)
alter Vs0 dc=1.2
alter Vh0 dc=1.2
alter Vs1 dc=0
alter Vh1 dc=0
alter Vs2 dc=1.2
alter Vh2 dc=1.2
alter Vs3 dc=1.2
alter Vh3 dc=1.2
alter Vs4 dc=0
alter Vh4 dc=0
alter Vs5 dc=0
alter Vh5 dc=0
alter Vs6 dc=0
alter Vh6 dc=0
alter Vs7 dc=0
alter Vh7 dc=0
op
echo ROW 1 125.0 13 $&v(xt.vth_soft) $&v(xt.vth_hard) $&v(vref_buf) $&v(isense) $&i(vdda)
alter Vs0 dc=0
alter Vh0 dc=0
alter Vs1 dc=1.2
alter Vh1 dc=1.2
alter Vs2 dc=1.2
alter Vh2 dc=1.2
alter Vs3 dc=1.2
alter Vh3 dc=1.2
alter Vs4 dc=0
alter Vh4 dc=0
alter Vs5 dc=0
alter Vh5 dc=0
alter Vs6 dc=0
alter Vh6 dc=0
alter Vs7 dc=0
alter Vh7 dc=0
op
echo ROW 1 125.0 14 $&v(xt.vth_soft) $&v(xt.vth_hard) $&v(vref_buf) $&v(isense) $&i(vdda)
alter Vs0 dc=1.2
alter Vh0 dc=1.2
alter Vs1 dc=1.2
alter Vh1 dc=1.2
alter Vs2 dc=1.2
alter Vh2 dc=1.2
alter Vs3 dc=1.2
alter Vh3 dc=1.2
alter Vs4 dc=0
alter Vh4 dc=0
alter Vs5 dc=0
alter Vh5 dc=0
alter Vs6 dc=0
alter Vh6 dc=0
alter Vs7 dc=0
alter Vh7 dc=0
op
echo ROW 1 125.0 15 $&v(xt.vth_soft) $&v(xt.vth_hard) $&v(vref_buf) $&v(isense) $&i(vdda)
alter Vs0 dc=0
alter Vh0 dc=0
alter Vs1 dc=0
alter Vh1 dc=0
alter Vs2 dc=0
alter Vh2 dc=0
alter Vs3 dc=0
alter Vh3 dc=0
alter Vs4 dc=1.2
alter Vh4 dc=1.2
alter Vs5 dc=0
alter Vh5 dc=0
alter Vs6 dc=0
alter Vh6 dc=0
alter Vs7 dc=0
alter Vh7 dc=0
op
echo ROW 1 125.0 16 $&v(xt.vth_soft) $&v(xt.vth_hard) $&v(vref_buf) $&v(isense) $&i(vdda)
alter Vs0 dc=1.2
alter Vh0 dc=1.2
alter Vs1 dc=0
alter Vh1 dc=0
alter Vs2 dc=0
alter Vh2 dc=0
alter Vs3 dc=0
alter Vh3 dc=0
alter Vs4 dc=1.2
alter Vh4 dc=1.2
alter Vs5 dc=0
alter Vh5 dc=0
alter Vs6 dc=0
alter Vh6 dc=0
alter Vs7 dc=0
alter Vh7 dc=0
op
echo ROW 1 125.0 17 $&v(xt.vth_soft) $&v(xt.vth_hard) $&v(vref_buf) $&v(isense) $&i(vdda)
alter Vs0 dc=0
alter Vh0 dc=0
alter Vs1 dc=1.2
alter Vh1 dc=1.2
alter Vs2 dc=0
alter Vh2 dc=0
alter Vs3 dc=0
alter Vh3 dc=0
alter Vs4 dc=1.2
alter Vh4 dc=1.2
alter Vs5 dc=0
alter Vh5 dc=0
alter Vs6 dc=0
alter Vh6 dc=0
alter Vs7 dc=0
alter Vh7 dc=0
op
echo ROW 1 125.0 18 $&v(xt.vth_soft) $&v(xt.vth_hard) $&v(vref_buf) $&v(isense) $&i(vdda)
alter Vs0 dc=1.2
alter Vh0 dc=1.2
alter Vs1 dc=1.2
alter Vh1 dc=1.2
alter Vs2 dc=0
alter Vh2 dc=0
alter Vs3 dc=0
alter Vh3 dc=0
alter Vs4 dc=1.2
alter Vh4 dc=1.2
alter Vs5 dc=0
alter Vh5 dc=0
alter Vs6 dc=0
alter Vh6 dc=0
alter Vs7 dc=0
alter Vh7 dc=0
op
echo ROW 1 125.0 19 $&v(xt.vth_soft) $&v(xt.vth_hard) $&v(vref_buf) $&v(isense) $&i(vdda)
alter Vs0 dc=0
alter Vh0 dc=0
alter Vs1 dc=0
alter Vh1 dc=0
alter Vs2 dc=1.2
alter Vh2 dc=1.2
alter Vs3 dc=0
alter Vh3 dc=0
alter Vs4 dc=1.2
alter Vh4 dc=1.2
alter Vs5 dc=0
alter Vh5 dc=0
alter Vs6 dc=0
alter Vh6 dc=0
alter Vs7 dc=0
alter Vh7 dc=0
op
echo ROW 1 125.0 20 $&v(xt.vth_soft) $&v(xt.vth_hard) $&v(vref_buf) $&v(isense) $&i(vdda)
alter Vs0 dc=1.2
alter Vh0 dc=1.2
alter Vs1 dc=0
alter Vh1 dc=0
alter Vs2 dc=1.2
alter Vh2 dc=1.2
alter Vs3 dc=0
alter Vh3 dc=0
alter Vs4 dc=1.2
alter Vh4 dc=1.2
alter Vs5 dc=0
alter Vh5 dc=0
alter Vs6 dc=0
alter Vh6 dc=0
alter Vs7 dc=0
alter Vh7 dc=0
op
echo ROW 1 125.0 21 $&v(xt.vth_soft) $&v(xt.vth_hard) $&v(vref_buf) $&v(isense) $&i(vdda)
alter Vs0 dc=0
alter Vh0 dc=0
alter Vs1 dc=1.2
alter Vh1 dc=1.2
alter Vs2 dc=1.2
alter Vh2 dc=1.2
alter Vs3 dc=0
alter Vh3 dc=0
alter Vs4 dc=1.2
alter Vh4 dc=1.2
alter Vs5 dc=0
alter Vh5 dc=0
alter Vs6 dc=0
alter Vh6 dc=0
alter Vs7 dc=0
alter Vh7 dc=0
op
echo ROW 1 125.0 22 $&v(xt.vth_soft) $&v(xt.vth_hard) $&v(vref_buf) $&v(isense) $&i(vdda)
alter Vs0 dc=1.2
alter Vh0 dc=1.2
alter Vs1 dc=1.2
alter Vh1 dc=1.2
alter Vs2 dc=1.2
alter Vh2 dc=1.2
alter Vs3 dc=0
alter Vh3 dc=0
alter Vs4 dc=1.2
alter Vh4 dc=1.2
alter Vs5 dc=0
alter Vh5 dc=0
alter Vs6 dc=0
alter Vh6 dc=0
alter Vs7 dc=0
alter Vh7 dc=0
op
echo ROW 1 125.0 23 $&v(xt.vth_soft) $&v(xt.vth_hard) $&v(vref_buf) $&v(isense) $&i(vdda)
alter Vs0 dc=0
alter Vh0 dc=0
alter Vs1 dc=0
alter Vh1 dc=0
alter Vs2 dc=0
alter Vh2 dc=0
alter Vs3 dc=1.2
alter Vh3 dc=1.2
alter Vs4 dc=1.2
alter Vh4 dc=1.2
alter Vs5 dc=0
alter Vh5 dc=0
alter Vs6 dc=0
alter Vh6 dc=0
alter Vs7 dc=0
alter Vh7 dc=0
op
echo ROW 1 125.0 24 $&v(xt.vth_soft) $&v(xt.vth_hard) $&v(vref_buf) $&v(isense) $&i(vdda)
alter Vs0 dc=1.2
alter Vh0 dc=1.2
alter Vs1 dc=0
alter Vh1 dc=0
alter Vs2 dc=0
alter Vh2 dc=0
alter Vs3 dc=1.2
alter Vh3 dc=1.2
alter Vs4 dc=1.2
alter Vh4 dc=1.2
alter Vs5 dc=0
alter Vh5 dc=0
alter Vs6 dc=0
alter Vh6 dc=0
alter Vs7 dc=0
alter Vh7 dc=0
op
echo ROW 1 125.0 25 $&v(xt.vth_soft) $&v(xt.vth_hard) $&v(vref_buf) $&v(isense) $&i(vdda)
alter Vs0 dc=0
alter Vh0 dc=0
alter Vs1 dc=1.2
alter Vh1 dc=1.2
alter Vs2 dc=0
alter Vh2 dc=0
alter Vs3 dc=1.2
alter Vh3 dc=1.2
alter Vs4 dc=1.2
alter Vh4 dc=1.2
alter Vs5 dc=0
alter Vh5 dc=0
alter Vs6 dc=0
alter Vh6 dc=0
alter Vs7 dc=0
alter Vh7 dc=0
op
echo ROW 1 125.0 26 $&v(xt.vth_soft) $&v(xt.vth_hard) $&v(vref_buf) $&v(isense) $&i(vdda)
alter Vs0 dc=1.2
alter Vh0 dc=1.2
alter Vs1 dc=1.2
alter Vh1 dc=1.2
alter Vs2 dc=0
alter Vh2 dc=0
alter Vs3 dc=1.2
alter Vh3 dc=1.2
alter Vs4 dc=1.2
alter Vh4 dc=1.2
alter Vs5 dc=0
alter Vh5 dc=0
alter Vs6 dc=0
alter Vh6 dc=0
alter Vs7 dc=0
alter Vh7 dc=0
op
echo ROW 1 125.0 27 $&v(xt.vth_soft) $&v(xt.vth_hard) $&v(vref_buf) $&v(isense) $&i(vdda)
alter Vs0 dc=0
alter Vh0 dc=0
alter Vs1 dc=0
alter Vh1 dc=0
alter Vs2 dc=1.2
alter Vh2 dc=1.2
alter Vs3 dc=1.2
alter Vh3 dc=1.2
alter Vs4 dc=1.2
alter Vh4 dc=1.2
alter Vs5 dc=0
alter Vh5 dc=0
alter Vs6 dc=0
alter Vh6 dc=0
alter Vs7 dc=0
alter Vh7 dc=0
op
echo ROW 1 125.0 28 $&v(xt.vth_soft) $&v(xt.vth_hard) $&v(vref_buf) $&v(isense) $&i(vdda)
alter Vs0 dc=1.2
alter Vh0 dc=1.2
alter Vs1 dc=0
alter Vh1 dc=0
alter Vs2 dc=1.2
alter Vh2 dc=1.2
alter Vs3 dc=1.2
alter Vh3 dc=1.2
alter Vs4 dc=1.2
alter Vh4 dc=1.2
alter Vs5 dc=0
alter Vh5 dc=0
alter Vs6 dc=0
alter Vh6 dc=0
alter Vs7 dc=0
alter Vh7 dc=0
op
echo ROW 1 125.0 29 $&v(xt.vth_soft) $&v(xt.vth_hard) $&v(vref_buf) $&v(isense) $&i(vdda)
alter Vs0 dc=0
alter Vh0 dc=0
alter Vs1 dc=1.2
alter Vh1 dc=1.2
alter Vs2 dc=1.2
alter Vh2 dc=1.2
alter Vs3 dc=1.2
alter Vh3 dc=1.2
alter Vs4 dc=1.2
alter Vh4 dc=1.2
alter Vs5 dc=0
alter Vh5 dc=0
alter Vs6 dc=0
alter Vh6 dc=0
alter Vs7 dc=0
alter Vh7 dc=0
op
echo ROW 1 125.0 30 $&v(xt.vth_soft) $&v(xt.vth_hard) $&v(vref_buf) $&v(isense) $&i(vdda)
alter Vs0 dc=1.2
alter Vh0 dc=1.2
alter Vs1 dc=1.2
alter Vh1 dc=1.2
alter Vs2 dc=1.2
alter Vh2 dc=1.2
alter Vs3 dc=1.2
alter Vh3 dc=1.2
alter Vs4 dc=1.2
alter Vh4 dc=1.2
alter Vs5 dc=0
alter Vh5 dc=0
alter Vs6 dc=0
alter Vh6 dc=0
alter Vs7 dc=0
alter Vh7 dc=0
op
echo ROW 1 125.0 31 $&v(xt.vth_soft) $&v(xt.vth_hard) $&v(vref_buf) $&v(isense) $&i(vdda)
alter Vs0 dc=0
alter Vh0 dc=0
alter Vs1 dc=0
alter Vh1 dc=0
alter Vs2 dc=0
alter Vh2 dc=0
alter Vs3 dc=0
alter Vh3 dc=0
alter Vs4 dc=0
alter Vh4 dc=0
alter Vs5 dc=1.2
alter Vh5 dc=1.2
alter Vs6 dc=0
alter Vh6 dc=0
alter Vs7 dc=0
alter Vh7 dc=0
op
echo ROW 1 125.0 32 $&v(xt.vth_soft) $&v(xt.vth_hard) $&v(vref_buf) $&v(isense) $&i(vdda)
alter Vs0 dc=1.2
alter Vh0 dc=1.2
alter Vs1 dc=0
alter Vh1 dc=0
alter Vs2 dc=0
alter Vh2 dc=0
alter Vs3 dc=0
alter Vh3 dc=0
alter Vs4 dc=0
alter Vh4 dc=0
alter Vs5 dc=1.2
alter Vh5 dc=1.2
alter Vs6 dc=0
alter Vh6 dc=0
alter Vs7 dc=0
alter Vh7 dc=0
op
echo ROW 1 125.0 33 $&v(xt.vth_soft) $&v(xt.vth_hard) $&v(vref_buf) $&v(isense) $&i(vdda)
alter Vs0 dc=0
alter Vh0 dc=0
alter Vs1 dc=1.2
alter Vh1 dc=1.2
alter Vs2 dc=0
alter Vh2 dc=0
alter Vs3 dc=0
alter Vh3 dc=0
alter Vs4 dc=0
alter Vh4 dc=0
alter Vs5 dc=1.2
alter Vh5 dc=1.2
alter Vs6 dc=0
alter Vh6 dc=0
alter Vs7 dc=0
alter Vh7 dc=0
op
echo ROW 1 125.0 34 $&v(xt.vth_soft) $&v(xt.vth_hard) $&v(vref_buf) $&v(isense) $&i(vdda)
alter Vs0 dc=1.2
alter Vh0 dc=1.2
alter Vs1 dc=1.2
alter Vh1 dc=1.2
alter Vs2 dc=0
alter Vh2 dc=0
alter Vs3 dc=0
alter Vh3 dc=0
alter Vs4 dc=0
alter Vh4 dc=0
alter Vs5 dc=1.2
alter Vh5 dc=1.2
alter Vs6 dc=0
alter Vh6 dc=0
alter Vs7 dc=0
alter Vh7 dc=0
op
echo ROW 1 125.0 35 $&v(xt.vth_soft) $&v(xt.vth_hard) $&v(vref_buf) $&v(isense) $&i(vdda)
alter Vs0 dc=0
alter Vh0 dc=0
alter Vs1 dc=0
alter Vh1 dc=0
alter Vs2 dc=1.2
alter Vh2 dc=1.2
alter Vs3 dc=0
alter Vh3 dc=0
alter Vs4 dc=0
alter Vh4 dc=0
alter Vs5 dc=1.2
alter Vh5 dc=1.2
alter Vs6 dc=0
alter Vh6 dc=0
alter Vs7 dc=0
alter Vh7 dc=0
op
echo ROW 1 125.0 36 $&v(xt.vth_soft) $&v(xt.vth_hard) $&v(vref_buf) $&v(isense) $&i(vdda)
alter Vs0 dc=1.2
alter Vh0 dc=1.2
alter Vs1 dc=0
alter Vh1 dc=0
alter Vs2 dc=1.2
alter Vh2 dc=1.2
alter Vs3 dc=0
alter Vh3 dc=0
alter Vs4 dc=0
alter Vh4 dc=0
alter Vs5 dc=1.2
alter Vh5 dc=1.2
alter Vs6 dc=0
alter Vh6 dc=0
alter Vs7 dc=0
alter Vh7 dc=0
op
echo ROW 1 125.0 37 $&v(xt.vth_soft) $&v(xt.vth_hard) $&v(vref_buf) $&v(isense) $&i(vdda)
alter Vs0 dc=0
alter Vh0 dc=0
alter Vs1 dc=1.2
alter Vh1 dc=1.2
alter Vs2 dc=1.2
alter Vh2 dc=1.2
alter Vs3 dc=0
alter Vh3 dc=0
alter Vs4 dc=0
alter Vh4 dc=0
alter Vs5 dc=1.2
alter Vh5 dc=1.2
alter Vs6 dc=0
alter Vh6 dc=0
alter Vs7 dc=0
alter Vh7 dc=0
op
echo ROW 1 125.0 38 $&v(xt.vth_soft) $&v(xt.vth_hard) $&v(vref_buf) $&v(isense) $&i(vdda)
alter Vs0 dc=1.2
alter Vh0 dc=1.2
alter Vs1 dc=1.2
alter Vh1 dc=1.2
alter Vs2 dc=1.2
alter Vh2 dc=1.2
alter Vs3 dc=0
alter Vh3 dc=0
alter Vs4 dc=0
alter Vh4 dc=0
alter Vs5 dc=1.2
alter Vh5 dc=1.2
alter Vs6 dc=0
alter Vh6 dc=0
alter Vs7 dc=0
alter Vh7 dc=0
op
echo ROW 1 125.0 39 $&v(xt.vth_soft) $&v(xt.vth_hard) $&v(vref_buf) $&v(isense) $&i(vdda)
alter Vs0 dc=0
alter Vh0 dc=0
alter Vs1 dc=0
alter Vh1 dc=0
alter Vs2 dc=0
alter Vh2 dc=0
alter Vs3 dc=1.2
alter Vh3 dc=1.2
alter Vs4 dc=0
alter Vh4 dc=0
alter Vs5 dc=1.2
alter Vh5 dc=1.2
alter Vs6 dc=0
alter Vh6 dc=0
alter Vs7 dc=0
alter Vh7 dc=0
op
echo ROW 1 125.0 40 $&v(xt.vth_soft) $&v(xt.vth_hard) $&v(vref_buf) $&v(isense) $&i(vdda)
alter Vs0 dc=1.2
alter Vh0 dc=1.2
alter Vs1 dc=0
alter Vh1 dc=0
alter Vs2 dc=0
alter Vh2 dc=0
alter Vs3 dc=1.2
alter Vh3 dc=1.2
alter Vs4 dc=0
alter Vh4 dc=0
alter Vs5 dc=1.2
alter Vh5 dc=1.2
alter Vs6 dc=0
alter Vh6 dc=0
alter Vs7 dc=0
alter Vh7 dc=0
op
echo ROW 1 125.0 41 $&v(xt.vth_soft) $&v(xt.vth_hard) $&v(vref_buf) $&v(isense) $&i(vdda)
alter Vs0 dc=0
alter Vh0 dc=0
alter Vs1 dc=1.2
alter Vh1 dc=1.2
alter Vs2 dc=0
alter Vh2 dc=0
alter Vs3 dc=1.2
alter Vh3 dc=1.2
alter Vs4 dc=0
alter Vh4 dc=0
alter Vs5 dc=1.2
alter Vh5 dc=1.2
alter Vs6 dc=0
alter Vh6 dc=0
alter Vs7 dc=0
alter Vh7 dc=0
op
echo ROW 1 125.0 42 $&v(xt.vth_soft) $&v(xt.vth_hard) $&v(vref_buf) $&v(isense) $&i(vdda)
alter Vs0 dc=1.2
alter Vh0 dc=1.2
alter Vs1 dc=1.2
alter Vh1 dc=1.2
alter Vs2 dc=0
alter Vh2 dc=0
alter Vs3 dc=1.2
alter Vh3 dc=1.2
alter Vs4 dc=0
alter Vh4 dc=0
alter Vs5 dc=1.2
alter Vh5 dc=1.2
alter Vs6 dc=0
alter Vh6 dc=0
alter Vs7 dc=0
alter Vh7 dc=0
op
echo ROW 1 125.0 43 $&v(xt.vth_soft) $&v(xt.vth_hard) $&v(vref_buf) $&v(isense) $&i(vdda)
alter Vs0 dc=0
alter Vh0 dc=0
alter Vs1 dc=0
alter Vh1 dc=0
alter Vs2 dc=1.2
alter Vh2 dc=1.2
alter Vs3 dc=1.2
alter Vh3 dc=1.2
alter Vs4 dc=0
alter Vh4 dc=0
alter Vs5 dc=1.2
alter Vh5 dc=1.2
alter Vs6 dc=0
alter Vh6 dc=0
alter Vs7 dc=0
alter Vh7 dc=0
op
echo ROW 1 125.0 44 $&v(xt.vth_soft) $&v(xt.vth_hard) $&v(vref_buf) $&v(isense) $&i(vdda)
alter Vs0 dc=1.2
alter Vh0 dc=1.2
alter Vs1 dc=0
alter Vh1 dc=0
alter Vs2 dc=1.2
alter Vh2 dc=1.2
alter Vs3 dc=1.2
alter Vh3 dc=1.2
alter Vs4 dc=0
alter Vh4 dc=0
alter Vs5 dc=1.2
alter Vh5 dc=1.2
alter Vs6 dc=0
alter Vh6 dc=0
alter Vs7 dc=0
alter Vh7 dc=0
op
echo ROW 1 125.0 45 $&v(xt.vth_soft) $&v(xt.vth_hard) $&v(vref_buf) $&v(isense) $&i(vdda)
alter Vs0 dc=0
alter Vh0 dc=0
alter Vs1 dc=1.2
alter Vh1 dc=1.2
alter Vs2 dc=1.2
alter Vh2 dc=1.2
alter Vs3 dc=1.2
alter Vh3 dc=1.2
alter Vs4 dc=0
alter Vh4 dc=0
alter Vs5 dc=1.2
alter Vh5 dc=1.2
alter Vs6 dc=0
alter Vh6 dc=0
alter Vs7 dc=0
alter Vh7 dc=0
op
echo ROW 1 125.0 46 $&v(xt.vth_soft) $&v(xt.vth_hard) $&v(vref_buf) $&v(isense) $&i(vdda)
alter Vs0 dc=1.2
alter Vh0 dc=1.2
alter Vs1 dc=1.2
alter Vh1 dc=1.2
alter Vs2 dc=1.2
alter Vh2 dc=1.2
alter Vs3 dc=1.2
alter Vh3 dc=1.2
alter Vs4 dc=0
alter Vh4 dc=0
alter Vs5 dc=1.2
alter Vh5 dc=1.2
alter Vs6 dc=0
alter Vh6 dc=0
alter Vs7 dc=0
alter Vh7 dc=0
op
echo ROW 1 125.0 47 $&v(xt.vth_soft) $&v(xt.vth_hard) $&v(vref_buf) $&v(isense) $&i(vdda)
alter Vs0 dc=0
alter Vh0 dc=0
alter Vs1 dc=0
alter Vh1 dc=0
alter Vs2 dc=0
alter Vh2 dc=0
alter Vs3 dc=0
alter Vh3 dc=0
alter Vs4 dc=1.2
alter Vh4 dc=1.2
alter Vs5 dc=1.2
alter Vh5 dc=1.2
alter Vs6 dc=0
alter Vh6 dc=0
alter Vs7 dc=0
alter Vh7 dc=0
op
echo ROW 1 125.0 48 $&v(xt.vth_soft) $&v(xt.vth_hard) $&v(vref_buf) $&v(isense) $&i(vdda)
alter Vs0 dc=1.2
alter Vh0 dc=1.2
alter Vs1 dc=0
alter Vh1 dc=0
alter Vs2 dc=0
alter Vh2 dc=0
alter Vs3 dc=0
alter Vh3 dc=0
alter Vs4 dc=1.2
alter Vh4 dc=1.2
alter Vs5 dc=1.2
alter Vh5 dc=1.2
alter Vs6 dc=0
alter Vh6 dc=0
alter Vs7 dc=0
alter Vh7 dc=0
op
echo ROW 1 125.0 49 $&v(xt.vth_soft) $&v(xt.vth_hard) $&v(vref_buf) $&v(isense) $&i(vdda)
alter Vs0 dc=0
alter Vh0 dc=0
alter Vs1 dc=1.2
alter Vh1 dc=1.2
alter Vs2 dc=0
alter Vh2 dc=0
alter Vs3 dc=0
alter Vh3 dc=0
alter Vs4 dc=1.2
alter Vh4 dc=1.2
alter Vs5 dc=1.2
alter Vh5 dc=1.2
alter Vs6 dc=0
alter Vh6 dc=0
alter Vs7 dc=0
alter Vh7 dc=0
op
echo ROW 1 125.0 50 $&v(xt.vth_soft) $&v(xt.vth_hard) $&v(vref_buf) $&v(isense) $&i(vdda)
alter Vs0 dc=1.2
alter Vh0 dc=1.2
alter Vs1 dc=1.2
alter Vh1 dc=1.2
alter Vs2 dc=0
alter Vh2 dc=0
alter Vs3 dc=0
alter Vh3 dc=0
alter Vs4 dc=1.2
alter Vh4 dc=1.2
alter Vs5 dc=1.2
alter Vh5 dc=1.2
alter Vs6 dc=0
alter Vh6 dc=0
alter Vs7 dc=0
alter Vh7 dc=0
op
echo ROW 1 125.0 51 $&v(xt.vth_soft) $&v(xt.vth_hard) $&v(vref_buf) $&v(isense) $&i(vdda)
alter Vs0 dc=0
alter Vh0 dc=0
alter Vs1 dc=0
alter Vh1 dc=0
alter Vs2 dc=1.2
alter Vh2 dc=1.2
alter Vs3 dc=0
alter Vh3 dc=0
alter Vs4 dc=1.2
alter Vh4 dc=1.2
alter Vs5 dc=1.2
alter Vh5 dc=1.2
alter Vs6 dc=0
alter Vh6 dc=0
alter Vs7 dc=0
alter Vh7 dc=0
op
echo ROW 1 125.0 52 $&v(xt.vth_soft) $&v(xt.vth_hard) $&v(vref_buf) $&v(isense) $&i(vdda)
alter Vs0 dc=1.2
alter Vh0 dc=1.2
alter Vs1 dc=0
alter Vh1 dc=0
alter Vs2 dc=1.2
alter Vh2 dc=1.2
alter Vs3 dc=0
alter Vh3 dc=0
alter Vs4 dc=1.2
alter Vh4 dc=1.2
alter Vs5 dc=1.2
alter Vh5 dc=1.2
alter Vs6 dc=0
alter Vh6 dc=0
alter Vs7 dc=0
alter Vh7 dc=0
op
echo ROW 1 125.0 53 $&v(xt.vth_soft) $&v(xt.vth_hard) $&v(vref_buf) $&v(isense) $&i(vdda)
alter Vs0 dc=0
alter Vh0 dc=0
alter Vs1 dc=1.2
alter Vh1 dc=1.2
alter Vs2 dc=1.2
alter Vh2 dc=1.2
alter Vs3 dc=0
alter Vh3 dc=0
alter Vs4 dc=1.2
alter Vh4 dc=1.2
alter Vs5 dc=1.2
alter Vh5 dc=1.2
alter Vs6 dc=0
alter Vh6 dc=0
alter Vs7 dc=0
alter Vh7 dc=0
op
echo ROW 1 125.0 54 $&v(xt.vth_soft) $&v(xt.vth_hard) $&v(vref_buf) $&v(isense) $&i(vdda)
alter Vs0 dc=1.2
alter Vh0 dc=1.2
alter Vs1 dc=1.2
alter Vh1 dc=1.2
alter Vs2 dc=1.2
alter Vh2 dc=1.2
alter Vs3 dc=0
alter Vh3 dc=0
alter Vs4 dc=1.2
alter Vh4 dc=1.2
alter Vs5 dc=1.2
alter Vh5 dc=1.2
alter Vs6 dc=0
alter Vh6 dc=0
alter Vs7 dc=0
alter Vh7 dc=0
op
echo ROW 1 125.0 55 $&v(xt.vth_soft) $&v(xt.vth_hard) $&v(vref_buf) $&v(isense) $&i(vdda)
alter Vs0 dc=0
alter Vh0 dc=0
alter Vs1 dc=0
alter Vh1 dc=0
alter Vs2 dc=0
alter Vh2 dc=0
alter Vs3 dc=1.2
alter Vh3 dc=1.2
alter Vs4 dc=1.2
alter Vh4 dc=1.2
alter Vs5 dc=1.2
alter Vh5 dc=1.2
alter Vs6 dc=0
alter Vh6 dc=0
alter Vs7 dc=0
alter Vh7 dc=0
op
echo ROW 1 125.0 56 $&v(xt.vth_soft) $&v(xt.vth_hard) $&v(vref_buf) $&v(isense) $&i(vdda)
alter Vs0 dc=1.2
alter Vh0 dc=1.2
alter Vs1 dc=0
alter Vh1 dc=0
alter Vs2 dc=0
alter Vh2 dc=0
alter Vs3 dc=1.2
alter Vh3 dc=1.2
alter Vs4 dc=1.2
alter Vh4 dc=1.2
alter Vs5 dc=1.2
alter Vh5 dc=1.2
alter Vs6 dc=0
alter Vh6 dc=0
alter Vs7 dc=0
alter Vh7 dc=0
op
echo ROW 1 125.0 57 $&v(xt.vth_soft) $&v(xt.vth_hard) $&v(vref_buf) $&v(isense) $&i(vdda)
alter Vs0 dc=0
alter Vh0 dc=0
alter Vs1 dc=1.2
alter Vh1 dc=1.2
alter Vs2 dc=0
alter Vh2 dc=0
alter Vs3 dc=1.2
alter Vh3 dc=1.2
alter Vs4 dc=1.2
alter Vh4 dc=1.2
alter Vs5 dc=1.2
alter Vh5 dc=1.2
alter Vs6 dc=0
alter Vh6 dc=0
alter Vs7 dc=0
alter Vh7 dc=0
op
echo ROW 1 125.0 58 $&v(xt.vth_soft) $&v(xt.vth_hard) $&v(vref_buf) $&v(isense) $&i(vdda)
alter Vs0 dc=1.2
alter Vh0 dc=1.2
alter Vs1 dc=1.2
alter Vh1 dc=1.2
alter Vs2 dc=0
alter Vh2 dc=0
alter Vs3 dc=1.2
alter Vh3 dc=1.2
alter Vs4 dc=1.2
alter Vh4 dc=1.2
alter Vs5 dc=1.2
alter Vh5 dc=1.2
alter Vs6 dc=0
alter Vh6 dc=0
alter Vs7 dc=0
alter Vh7 dc=0
op
echo ROW 1 125.0 59 $&v(xt.vth_soft) $&v(xt.vth_hard) $&v(vref_buf) $&v(isense) $&i(vdda)
alter Vs0 dc=0
alter Vh0 dc=0
alter Vs1 dc=0
alter Vh1 dc=0
alter Vs2 dc=1.2
alter Vh2 dc=1.2
alter Vs3 dc=1.2
alter Vh3 dc=1.2
alter Vs4 dc=1.2
alter Vh4 dc=1.2
alter Vs5 dc=1.2
alter Vh5 dc=1.2
alter Vs6 dc=0
alter Vh6 dc=0
alter Vs7 dc=0
alter Vh7 dc=0
op
echo ROW 1 125.0 60 $&v(xt.vth_soft) $&v(xt.vth_hard) $&v(vref_buf) $&v(isense) $&i(vdda)
alter Vs0 dc=1.2
alter Vh0 dc=1.2
alter Vs1 dc=0
alter Vh1 dc=0
alter Vs2 dc=1.2
alter Vh2 dc=1.2
alter Vs3 dc=1.2
alter Vh3 dc=1.2
alter Vs4 dc=1.2
alter Vh4 dc=1.2
alter Vs5 dc=1.2
alter Vh5 dc=1.2
alter Vs6 dc=0
alter Vh6 dc=0
alter Vs7 dc=0
alter Vh7 dc=0
op
echo ROW 1 125.0 61 $&v(xt.vth_soft) $&v(xt.vth_hard) $&v(vref_buf) $&v(isense) $&i(vdda)
alter Vs0 dc=0
alter Vh0 dc=0
alter Vs1 dc=1.2
alter Vh1 dc=1.2
alter Vs2 dc=1.2
alter Vh2 dc=1.2
alter Vs3 dc=1.2
alter Vh3 dc=1.2
alter Vs4 dc=1.2
alter Vh4 dc=1.2
alter Vs5 dc=1.2
alter Vh5 dc=1.2
alter Vs6 dc=0
alter Vh6 dc=0
alter Vs7 dc=0
alter Vh7 dc=0
op
echo ROW 1 125.0 62 $&v(xt.vth_soft) $&v(xt.vth_hard) $&v(vref_buf) $&v(isense) $&i(vdda)
alter Vs0 dc=1.2
alter Vh0 dc=1.2
alter Vs1 dc=1.2
alter Vh1 dc=1.2
alter Vs2 dc=1.2
alter Vh2 dc=1.2
alter Vs3 dc=1.2
alter Vh3 dc=1.2
alter Vs4 dc=1.2
alter Vh4 dc=1.2
alter Vs5 dc=1.2
alter Vh5 dc=1.2
alter Vs6 dc=0
alter Vh6 dc=0
alter Vs7 dc=0
alter Vh7 dc=0
op
echo ROW 1 125.0 63 $&v(xt.vth_soft) $&v(xt.vth_hard) $&v(vref_buf) $&v(isense) $&i(vdda)
alter Vs0 dc=0
alter Vh0 dc=0
alter Vs1 dc=0
alter Vh1 dc=0
alter Vs2 dc=0
alter Vh2 dc=0
alter Vs3 dc=0
alter Vh3 dc=0
alter Vs4 dc=0
alter Vh4 dc=0
alter Vs5 dc=0
alter Vh5 dc=0
alter Vs6 dc=1.2
alter Vh6 dc=1.2
alter Vs7 dc=0
alter Vh7 dc=0
op
echo ROW 1 125.0 64 $&v(xt.vth_soft) $&v(xt.vth_hard) $&v(vref_buf) $&v(isense) $&i(vdda)
alter Vs0 dc=1.2
alter Vh0 dc=1.2
alter Vs1 dc=0
alter Vh1 dc=0
alter Vs2 dc=0
alter Vh2 dc=0
alter Vs3 dc=0
alter Vh3 dc=0
alter Vs4 dc=0
alter Vh4 dc=0
alter Vs5 dc=0
alter Vh5 dc=0
alter Vs6 dc=1.2
alter Vh6 dc=1.2
alter Vs7 dc=0
alter Vh7 dc=0
op
echo ROW 1 125.0 65 $&v(xt.vth_soft) $&v(xt.vth_hard) $&v(vref_buf) $&v(isense) $&i(vdda)
alter Vs0 dc=0
alter Vh0 dc=0
alter Vs1 dc=1.2
alter Vh1 dc=1.2
alter Vs2 dc=0
alter Vh2 dc=0
alter Vs3 dc=0
alter Vh3 dc=0
alter Vs4 dc=0
alter Vh4 dc=0
alter Vs5 dc=0
alter Vh5 dc=0
alter Vs6 dc=1.2
alter Vh6 dc=1.2
alter Vs7 dc=0
alter Vh7 dc=0
op
echo ROW 1 125.0 66 $&v(xt.vth_soft) $&v(xt.vth_hard) $&v(vref_buf) $&v(isense) $&i(vdda)
alter Vs0 dc=1.2
alter Vh0 dc=1.2
alter Vs1 dc=1.2
alter Vh1 dc=1.2
alter Vs2 dc=0
alter Vh2 dc=0
alter Vs3 dc=0
alter Vh3 dc=0
alter Vs4 dc=0
alter Vh4 dc=0
alter Vs5 dc=0
alter Vh5 dc=0
alter Vs6 dc=1.2
alter Vh6 dc=1.2
alter Vs7 dc=0
alter Vh7 dc=0
op
echo ROW 1 125.0 67 $&v(xt.vth_soft) $&v(xt.vth_hard) $&v(vref_buf) $&v(isense) $&i(vdda)
alter Vs0 dc=0
alter Vh0 dc=0
alter Vs1 dc=0
alter Vh1 dc=0
alter Vs2 dc=1.2
alter Vh2 dc=1.2
alter Vs3 dc=0
alter Vh3 dc=0
alter Vs4 dc=0
alter Vh4 dc=0
alter Vs5 dc=0
alter Vh5 dc=0
alter Vs6 dc=1.2
alter Vh6 dc=1.2
alter Vs7 dc=0
alter Vh7 dc=0
op
echo ROW 1 125.0 68 $&v(xt.vth_soft) $&v(xt.vth_hard) $&v(vref_buf) $&v(isense) $&i(vdda)
alter Vs0 dc=1.2
alter Vh0 dc=1.2
alter Vs1 dc=0
alter Vh1 dc=0
alter Vs2 dc=1.2
alter Vh2 dc=1.2
alter Vs3 dc=0
alter Vh3 dc=0
alter Vs4 dc=0
alter Vh4 dc=0
alter Vs5 dc=0
alter Vh5 dc=0
alter Vs6 dc=1.2
alter Vh6 dc=1.2
alter Vs7 dc=0
alter Vh7 dc=0
op
echo ROW 1 125.0 69 $&v(xt.vth_soft) $&v(xt.vth_hard) $&v(vref_buf) $&v(isense) $&i(vdda)
alter Vs0 dc=0
alter Vh0 dc=0
alter Vs1 dc=1.2
alter Vh1 dc=1.2
alter Vs2 dc=1.2
alter Vh2 dc=1.2
alter Vs3 dc=0
alter Vh3 dc=0
alter Vs4 dc=0
alter Vh4 dc=0
alter Vs5 dc=0
alter Vh5 dc=0
alter Vs6 dc=1.2
alter Vh6 dc=1.2
alter Vs7 dc=0
alter Vh7 dc=0
op
echo ROW 1 125.0 70 $&v(xt.vth_soft) $&v(xt.vth_hard) $&v(vref_buf) $&v(isense) $&i(vdda)
alter Vs0 dc=1.2
alter Vh0 dc=1.2
alter Vs1 dc=1.2
alter Vh1 dc=1.2
alter Vs2 dc=1.2
alter Vh2 dc=1.2
alter Vs3 dc=0
alter Vh3 dc=0
alter Vs4 dc=0
alter Vh4 dc=0
alter Vs5 dc=0
alter Vh5 dc=0
alter Vs6 dc=1.2
alter Vh6 dc=1.2
alter Vs7 dc=0
alter Vh7 dc=0
op
echo ROW 1 125.0 71 $&v(xt.vth_soft) $&v(xt.vth_hard) $&v(vref_buf) $&v(isense) $&i(vdda)
alter Vs0 dc=0
alter Vh0 dc=0
alter Vs1 dc=0
alter Vh1 dc=0
alter Vs2 dc=0
alter Vh2 dc=0
alter Vs3 dc=1.2
alter Vh3 dc=1.2
alter Vs4 dc=0
alter Vh4 dc=0
alter Vs5 dc=0
alter Vh5 dc=0
alter Vs6 dc=1.2
alter Vh6 dc=1.2
alter Vs7 dc=0
alter Vh7 dc=0
op
echo ROW 1 125.0 72 $&v(xt.vth_soft) $&v(xt.vth_hard) $&v(vref_buf) $&v(isense) $&i(vdda)
alter Vs0 dc=1.2
alter Vh0 dc=1.2
alter Vs1 dc=0
alter Vh1 dc=0
alter Vs2 dc=0
alter Vh2 dc=0
alter Vs3 dc=1.2
alter Vh3 dc=1.2
alter Vs4 dc=0
alter Vh4 dc=0
alter Vs5 dc=0
alter Vh5 dc=0
alter Vs6 dc=1.2
alter Vh6 dc=1.2
alter Vs7 dc=0
alter Vh7 dc=0
op
echo ROW 1 125.0 73 $&v(xt.vth_soft) $&v(xt.vth_hard) $&v(vref_buf) $&v(isense) $&i(vdda)
alter Vs0 dc=0
alter Vh0 dc=0
alter Vs1 dc=1.2
alter Vh1 dc=1.2
alter Vs2 dc=0
alter Vh2 dc=0
alter Vs3 dc=1.2
alter Vh3 dc=1.2
alter Vs4 dc=0
alter Vh4 dc=0
alter Vs5 dc=0
alter Vh5 dc=0
alter Vs6 dc=1.2
alter Vh6 dc=1.2
alter Vs7 dc=0
alter Vh7 dc=0
op
echo ROW 1 125.0 74 $&v(xt.vth_soft) $&v(xt.vth_hard) $&v(vref_buf) $&v(isense) $&i(vdda)
alter Vs0 dc=1.2
alter Vh0 dc=1.2
alter Vs1 dc=1.2
alter Vh1 dc=1.2
alter Vs2 dc=0
alter Vh2 dc=0
alter Vs3 dc=1.2
alter Vh3 dc=1.2
alter Vs4 dc=0
alter Vh4 dc=0
alter Vs5 dc=0
alter Vh5 dc=0
alter Vs6 dc=1.2
alter Vh6 dc=1.2
alter Vs7 dc=0
alter Vh7 dc=0
op
echo ROW 1 125.0 75 $&v(xt.vth_soft) $&v(xt.vth_hard) $&v(vref_buf) $&v(isense) $&i(vdda)
alter Vs0 dc=0
alter Vh0 dc=0
alter Vs1 dc=0
alter Vh1 dc=0
alter Vs2 dc=1.2
alter Vh2 dc=1.2
alter Vs3 dc=1.2
alter Vh3 dc=1.2
alter Vs4 dc=0
alter Vh4 dc=0
alter Vs5 dc=0
alter Vh5 dc=0
alter Vs6 dc=1.2
alter Vh6 dc=1.2
alter Vs7 dc=0
alter Vh7 dc=0
op
echo ROW 1 125.0 76 $&v(xt.vth_soft) $&v(xt.vth_hard) $&v(vref_buf) $&v(isense) $&i(vdda)
alter Vs0 dc=1.2
alter Vh0 dc=1.2
alter Vs1 dc=0
alter Vh1 dc=0
alter Vs2 dc=1.2
alter Vh2 dc=1.2
alter Vs3 dc=1.2
alter Vh3 dc=1.2
alter Vs4 dc=0
alter Vh4 dc=0
alter Vs5 dc=0
alter Vh5 dc=0
alter Vs6 dc=1.2
alter Vh6 dc=1.2
alter Vs7 dc=0
alter Vh7 dc=0
op
echo ROW 1 125.0 77 $&v(xt.vth_soft) $&v(xt.vth_hard) $&v(vref_buf) $&v(isense) $&i(vdda)
alter Vs0 dc=0
alter Vh0 dc=0
alter Vs1 dc=1.2
alter Vh1 dc=1.2
alter Vs2 dc=1.2
alter Vh2 dc=1.2
alter Vs3 dc=1.2
alter Vh3 dc=1.2
alter Vs4 dc=0
alter Vh4 dc=0
alter Vs5 dc=0
alter Vh5 dc=0
alter Vs6 dc=1.2
alter Vh6 dc=1.2
alter Vs7 dc=0
alter Vh7 dc=0
op
echo ROW 1 125.0 78 $&v(xt.vth_soft) $&v(xt.vth_hard) $&v(vref_buf) $&v(isense) $&i(vdda)
alter Vs0 dc=1.2
alter Vh0 dc=1.2
alter Vs1 dc=1.2
alter Vh1 dc=1.2
alter Vs2 dc=1.2
alter Vh2 dc=1.2
alter Vs3 dc=1.2
alter Vh3 dc=1.2
alter Vs4 dc=0
alter Vh4 dc=0
alter Vs5 dc=0
alter Vh5 dc=0
alter Vs6 dc=1.2
alter Vh6 dc=1.2
alter Vs7 dc=0
alter Vh7 dc=0
op
echo ROW 1 125.0 79 $&v(xt.vth_soft) $&v(xt.vth_hard) $&v(vref_buf) $&v(isense) $&i(vdda)
alter Vs0 dc=0
alter Vh0 dc=0
alter Vs1 dc=0
alter Vh1 dc=0
alter Vs2 dc=0
alter Vh2 dc=0
alter Vs3 dc=0
alter Vh3 dc=0
alter Vs4 dc=1.2
alter Vh4 dc=1.2
alter Vs5 dc=0
alter Vh5 dc=0
alter Vs6 dc=1.2
alter Vh6 dc=1.2
alter Vs7 dc=0
alter Vh7 dc=0
op
echo ROW 1 125.0 80 $&v(xt.vth_soft) $&v(xt.vth_hard) $&v(vref_buf) $&v(isense) $&i(vdda)
alter Vs0 dc=1.2
alter Vh0 dc=1.2
alter Vs1 dc=0
alter Vh1 dc=0
alter Vs2 dc=0
alter Vh2 dc=0
alter Vs3 dc=0
alter Vh3 dc=0
alter Vs4 dc=1.2
alter Vh4 dc=1.2
alter Vs5 dc=0
alter Vh5 dc=0
alter Vs6 dc=1.2
alter Vh6 dc=1.2
alter Vs7 dc=0
alter Vh7 dc=0
op
echo ROW 1 125.0 81 $&v(xt.vth_soft) $&v(xt.vth_hard) $&v(vref_buf) $&v(isense) $&i(vdda)
alter Vs0 dc=0
alter Vh0 dc=0
alter Vs1 dc=1.2
alter Vh1 dc=1.2
alter Vs2 dc=0
alter Vh2 dc=0
alter Vs3 dc=0
alter Vh3 dc=0
alter Vs4 dc=1.2
alter Vh4 dc=1.2
alter Vs5 dc=0
alter Vh5 dc=0
alter Vs6 dc=1.2
alter Vh6 dc=1.2
alter Vs7 dc=0
alter Vh7 dc=0
op
echo ROW 1 125.0 82 $&v(xt.vth_soft) $&v(xt.vth_hard) $&v(vref_buf) $&v(isense) $&i(vdda)
alter Vs0 dc=1.2
alter Vh0 dc=1.2
alter Vs1 dc=1.2
alter Vh1 dc=1.2
alter Vs2 dc=0
alter Vh2 dc=0
alter Vs3 dc=0
alter Vh3 dc=0
alter Vs4 dc=1.2
alter Vh4 dc=1.2
alter Vs5 dc=0
alter Vh5 dc=0
alter Vs6 dc=1.2
alter Vh6 dc=1.2
alter Vs7 dc=0
alter Vh7 dc=0
op
echo ROW 1 125.0 83 $&v(xt.vth_soft) $&v(xt.vth_hard) $&v(vref_buf) $&v(isense) $&i(vdda)
alter Vs0 dc=0
alter Vh0 dc=0
alter Vs1 dc=0
alter Vh1 dc=0
alter Vs2 dc=1.2
alter Vh2 dc=1.2
alter Vs3 dc=0
alter Vh3 dc=0
alter Vs4 dc=1.2
alter Vh4 dc=1.2
alter Vs5 dc=0
alter Vh5 dc=0
alter Vs6 dc=1.2
alter Vh6 dc=1.2
alter Vs7 dc=0
alter Vh7 dc=0
op
echo ROW 1 125.0 84 $&v(xt.vth_soft) $&v(xt.vth_hard) $&v(vref_buf) $&v(isense) $&i(vdda)
alter Vs0 dc=1.2
alter Vh0 dc=1.2
alter Vs1 dc=0
alter Vh1 dc=0
alter Vs2 dc=1.2
alter Vh2 dc=1.2
alter Vs3 dc=0
alter Vh3 dc=0
alter Vs4 dc=1.2
alter Vh4 dc=1.2
alter Vs5 dc=0
alter Vh5 dc=0
alter Vs6 dc=1.2
alter Vh6 dc=1.2
alter Vs7 dc=0
alter Vh7 dc=0
op
echo ROW 1 125.0 85 $&v(xt.vth_soft) $&v(xt.vth_hard) $&v(vref_buf) $&v(isense) $&i(vdda)
alter Vs0 dc=0
alter Vh0 dc=0
alter Vs1 dc=1.2
alter Vh1 dc=1.2
alter Vs2 dc=1.2
alter Vh2 dc=1.2
alter Vs3 dc=0
alter Vh3 dc=0
alter Vs4 dc=1.2
alter Vh4 dc=1.2
alter Vs5 dc=0
alter Vh5 dc=0
alter Vs6 dc=1.2
alter Vh6 dc=1.2
alter Vs7 dc=0
alter Vh7 dc=0
op
echo ROW 1 125.0 86 $&v(xt.vth_soft) $&v(xt.vth_hard) $&v(vref_buf) $&v(isense) $&i(vdda)
alter Vs0 dc=1.2
alter Vh0 dc=1.2
alter Vs1 dc=1.2
alter Vh1 dc=1.2
alter Vs2 dc=1.2
alter Vh2 dc=1.2
alter Vs3 dc=0
alter Vh3 dc=0
alter Vs4 dc=1.2
alter Vh4 dc=1.2
alter Vs5 dc=0
alter Vh5 dc=0
alter Vs6 dc=1.2
alter Vh6 dc=1.2
alter Vs7 dc=0
alter Vh7 dc=0
op
echo ROW 1 125.0 87 $&v(xt.vth_soft) $&v(xt.vth_hard) $&v(vref_buf) $&v(isense) $&i(vdda)
alter Vs0 dc=0
alter Vh0 dc=0
alter Vs1 dc=0
alter Vh1 dc=0
alter Vs2 dc=0
alter Vh2 dc=0
alter Vs3 dc=1.2
alter Vh3 dc=1.2
alter Vs4 dc=1.2
alter Vh4 dc=1.2
alter Vs5 dc=0
alter Vh5 dc=0
alter Vs6 dc=1.2
alter Vh6 dc=1.2
alter Vs7 dc=0
alter Vh7 dc=0
op
echo ROW 1 125.0 88 $&v(xt.vth_soft) $&v(xt.vth_hard) $&v(vref_buf) $&v(isense) $&i(vdda)
alter Vs0 dc=1.2
alter Vh0 dc=1.2
alter Vs1 dc=0
alter Vh1 dc=0
alter Vs2 dc=0
alter Vh2 dc=0
alter Vs3 dc=1.2
alter Vh3 dc=1.2
alter Vs4 dc=1.2
alter Vh4 dc=1.2
alter Vs5 dc=0
alter Vh5 dc=0
alter Vs6 dc=1.2
alter Vh6 dc=1.2
alter Vs7 dc=0
alter Vh7 dc=0
op
echo ROW 1 125.0 89 $&v(xt.vth_soft) $&v(xt.vth_hard) $&v(vref_buf) $&v(isense) $&i(vdda)
alter Vs0 dc=0
alter Vh0 dc=0
alter Vs1 dc=1.2
alter Vh1 dc=1.2
alter Vs2 dc=0
alter Vh2 dc=0
alter Vs3 dc=1.2
alter Vh3 dc=1.2
alter Vs4 dc=1.2
alter Vh4 dc=1.2
alter Vs5 dc=0
alter Vh5 dc=0
alter Vs6 dc=1.2
alter Vh6 dc=1.2
alter Vs7 dc=0
alter Vh7 dc=0
op
echo ROW 1 125.0 90 $&v(xt.vth_soft) $&v(xt.vth_hard) $&v(vref_buf) $&v(isense) $&i(vdda)
alter Vs0 dc=1.2
alter Vh0 dc=1.2
alter Vs1 dc=1.2
alter Vh1 dc=1.2
alter Vs2 dc=0
alter Vh2 dc=0
alter Vs3 dc=1.2
alter Vh3 dc=1.2
alter Vs4 dc=1.2
alter Vh4 dc=1.2
alter Vs5 dc=0
alter Vh5 dc=0
alter Vs6 dc=1.2
alter Vh6 dc=1.2
alter Vs7 dc=0
alter Vh7 dc=0
op
echo ROW 1 125.0 91 $&v(xt.vth_soft) $&v(xt.vth_hard) $&v(vref_buf) $&v(isense) $&i(vdda)
alter Vs0 dc=0
alter Vh0 dc=0
alter Vs1 dc=0
alter Vh1 dc=0
alter Vs2 dc=1.2
alter Vh2 dc=1.2
alter Vs3 dc=1.2
alter Vh3 dc=1.2
alter Vs4 dc=1.2
alter Vh4 dc=1.2
alter Vs5 dc=0
alter Vh5 dc=0
alter Vs6 dc=1.2
alter Vh6 dc=1.2
alter Vs7 dc=0
alter Vh7 dc=0
op
echo ROW 1 125.0 92 $&v(xt.vth_soft) $&v(xt.vth_hard) $&v(vref_buf) $&v(isense) $&i(vdda)
alter Vs0 dc=1.2
alter Vh0 dc=1.2
alter Vs1 dc=0
alter Vh1 dc=0
alter Vs2 dc=1.2
alter Vh2 dc=1.2
alter Vs3 dc=1.2
alter Vh3 dc=1.2
alter Vs4 dc=1.2
alter Vh4 dc=1.2
alter Vs5 dc=0
alter Vh5 dc=0
alter Vs6 dc=1.2
alter Vh6 dc=1.2
alter Vs7 dc=0
alter Vh7 dc=0
op
echo ROW 1 125.0 93 $&v(xt.vth_soft) $&v(xt.vth_hard) $&v(vref_buf) $&v(isense) $&i(vdda)
alter Vs0 dc=0
alter Vh0 dc=0
alter Vs1 dc=1.2
alter Vh1 dc=1.2
alter Vs2 dc=1.2
alter Vh2 dc=1.2
alter Vs3 dc=1.2
alter Vh3 dc=1.2
alter Vs4 dc=1.2
alter Vh4 dc=1.2
alter Vs5 dc=0
alter Vh5 dc=0
alter Vs6 dc=1.2
alter Vh6 dc=1.2
alter Vs7 dc=0
alter Vh7 dc=0
op
echo ROW 1 125.0 94 $&v(xt.vth_soft) $&v(xt.vth_hard) $&v(vref_buf) $&v(isense) $&i(vdda)
alter Vs0 dc=1.2
alter Vh0 dc=1.2
alter Vs1 dc=1.2
alter Vh1 dc=1.2
alter Vs2 dc=1.2
alter Vh2 dc=1.2
alter Vs3 dc=1.2
alter Vh3 dc=1.2
alter Vs4 dc=1.2
alter Vh4 dc=1.2
alter Vs5 dc=0
alter Vh5 dc=0
alter Vs6 dc=1.2
alter Vh6 dc=1.2
alter Vs7 dc=0
alter Vh7 dc=0
op
echo ROW 1 125.0 95 $&v(xt.vth_soft) $&v(xt.vth_hard) $&v(vref_buf) $&v(isense) $&i(vdda)
alter Vs0 dc=0
alter Vh0 dc=0
alter Vs1 dc=0
alter Vh1 dc=0
alter Vs2 dc=0
alter Vh2 dc=0
alter Vs3 dc=0
alter Vh3 dc=0
alter Vs4 dc=0
alter Vh4 dc=0
alter Vs5 dc=1.2
alter Vh5 dc=1.2
alter Vs6 dc=1.2
alter Vh6 dc=1.2
alter Vs7 dc=0
alter Vh7 dc=0
op
echo ROW 1 125.0 96 $&v(xt.vth_soft) $&v(xt.vth_hard) $&v(vref_buf) $&v(isense) $&i(vdda)
alter Vs0 dc=1.2
alter Vh0 dc=1.2
alter Vs1 dc=0
alter Vh1 dc=0
alter Vs2 dc=0
alter Vh2 dc=0
alter Vs3 dc=0
alter Vh3 dc=0
alter Vs4 dc=0
alter Vh4 dc=0
alter Vs5 dc=1.2
alter Vh5 dc=1.2
alter Vs6 dc=1.2
alter Vh6 dc=1.2
alter Vs7 dc=0
alter Vh7 dc=0
op
echo ROW 1 125.0 97 $&v(xt.vth_soft) $&v(xt.vth_hard) $&v(vref_buf) $&v(isense) $&i(vdda)
alter Vs0 dc=0
alter Vh0 dc=0
alter Vs1 dc=1.2
alter Vh1 dc=1.2
alter Vs2 dc=0
alter Vh2 dc=0
alter Vs3 dc=0
alter Vh3 dc=0
alter Vs4 dc=0
alter Vh4 dc=0
alter Vs5 dc=1.2
alter Vh5 dc=1.2
alter Vs6 dc=1.2
alter Vh6 dc=1.2
alter Vs7 dc=0
alter Vh7 dc=0
op
echo ROW 1 125.0 98 $&v(xt.vth_soft) $&v(xt.vth_hard) $&v(vref_buf) $&v(isense) $&i(vdda)
alter Vs0 dc=1.2
alter Vh0 dc=1.2
alter Vs1 dc=1.2
alter Vh1 dc=1.2
alter Vs2 dc=0
alter Vh2 dc=0
alter Vs3 dc=0
alter Vh3 dc=0
alter Vs4 dc=0
alter Vh4 dc=0
alter Vs5 dc=1.2
alter Vh5 dc=1.2
alter Vs6 dc=1.2
alter Vh6 dc=1.2
alter Vs7 dc=0
alter Vh7 dc=0
op
echo ROW 1 125.0 99 $&v(xt.vth_soft) $&v(xt.vth_hard) $&v(vref_buf) $&v(isense) $&i(vdda)
alter Vs0 dc=0
alter Vh0 dc=0
alter Vs1 dc=0
alter Vh1 dc=0
alter Vs2 dc=1.2
alter Vh2 dc=1.2
alter Vs3 dc=0
alter Vh3 dc=0
alter Vs4 dc=0
alter Vh4 dc=0
alter Vs5 dc=1.2
alter Vh5 dc=1.2
alter Vs6 dc=1.2
alter Vh6 dc=1.2
alter Vs7 dc=0
alter Vh7 dc=0
op
echo ROW 1 125.0 100 $&v(xt.vth_soft) $&v(xt.vth_hard) $&v(vref_buf) $&v(isense) $&i(vdda)
alter Vs0 dc=1.2
alter Vh0 dc=1.2
alter Vs1 dc=0
alter Vh1 dc=0
alter Vs2 dc=1.2
alter Vh2 dc=1.2
alter Vs3 dc=0
alter Vh3 dc=0
alter Vs4 dc=0
alter Vh4 dc=0
alter Vs5 dc=1.2
alter Vh5 dc=1.2
alter Vs6 dc=1.2
alter Vh6 dc=1.2
alter Vs7 dc=0
alter Vh7 dc=0
op
echo ROW 1 125.0 101 $&v(xt.vth_soft) $&v(xt.vth_hard) $&v(vref_buf) $&v(isense) $&i(vdda)
alter Vs0 dc=0
alter Vh0 dc=0
alter Vs1 dc=1.2
alter Vh1 dc=1.2
alter Vs2 dc=1.2
alter Vh2 dc=1.2
alter Vs3 dc=0
alter Vh3 dc=0
alter Vs4 dc=0
alter Vh4 dc=0
alter Vs5 dc=1.2
alter Vh5 dc=1.2
alter Vs6 dc=1.2
alter Vh6 dc=1.2
alter Vs7 dc=0
alter Vh7 dc=0
op
echo ROW 1 125.0 102 $&v(xt.vth_soft) $&v(xt.vth_hard) $&v(vref_buf) $&v(isense) $&i(vdda)
alter Vs0 dc=1.2
alter Vh0 dc=1.2
alter Vs1 dc=1.2
alter Vh1 dc=1.2
alter Vs2 dc=1.2
alter Vh2 dc=1.2
alter Vs3 dc=0
alter Vh3 dc=0
alter Vs4 dc=0
alter Vh4 dc=0
alter Vs5 dc=1.2
alter Vh5 dc=1.2
alter Vs6 dc=1.2
alter Vh6 dc=1.2
alter Vs7 dc=0
alter Vh7 dc=0
op
echo ROW 1 125.0 103 $&v(xt.vth_soft) $&v(xt.vth_hard) $&v(vref_buf) $&v(isense) $&i(vdda)
alter Vs0 dc=0
alter Vh0 dc=0
alter Vs1 dc=0
alter Vh1 dc=0
alter Vs2 dc=0
alter Vh2 dc=0
alter Vs3 dc=1.2
alter Vh3 dc=1.2
alter Vs4 dc=0
alter Vh4 dc=0
alter Vs5 dc=1.2
alter Vh5 dc=1.2
alter Vs6 dc=1.2
alter Vh6 dc=1.2
alter Vs7 dc=0
alter Vh7 dc=0
op
echo ROW 1 125.0 104 $&v(xt.vth_soft) $&v(xt.vth_hard) $&v(vref_buf) $&v(isense) $&i(vdda)
alter Vs0 dc=1.2
alter Vh0 dc=1.2
alter Vs1 dc=0
alter Vh1 dc=0
alter Vs2 dc=0
alter Vh2 dc=0
alter Vs3 dc=1.2
alter Vh3 dc=1.2
alter Vs4 dc=0
alter Vh4 dc=0
alter Vs5 dc=1.2
alter Vh5 dc=1.2
alter Vs6 dc=1.2
alter Vh6 dc=1.2
alter Vs7 dc=0
alter Vh7 dc=0
op
echo ROW 1 125.0 105 $&v(xt.vth_soft) $&v(xt.vth_hard) $&v(vref_buf) $&v(isense) $&i(vdda)
alter Vs0 dc=0
alter Vh0 dc=0
alter Vs1 dc=1.2
alter Vh1 dc=1.2
alter Vs2 dc=0
alter Vh2 dc=0
alter Vs3 dc=1.2
alter Vh3 dc=1.2
alter Vs4 dc=0
alter Vh4 dc=0
alter Vs5 dc=1.2
alter Vh5 dc=1.2
alter Vs6 dc=1.2
alter Vh6 dc=1.2
alter Vs7 dc=0
alter Vh7 dc=0
op
echo ROW 1 125.0 106 $&v(xt.vth_soft) $&v(xt.vth_hard) $&v(vref_buf) $&v(isense) $&i(vdda)
alter Vs0 dc=1.2
alter Vh0 dc=1.2
alter Vs1 dc=1.2
alter Vh1 dc=1.2
alter Vs2 dc=0
alter Vh2 dc=0
alter Vs3 dc=1.2
alter Vh3 dc=1.2
alter Vs4 dc=0
alter Vh4 dc=0
alter Vs5 dc=1.2
alter Vh5 dc=1.2
alter Vs6 dc=1.2
alter Vh6 dc=1.2
alter Vs7 dc=0
alter Vh7 dc=0
op
echo ROW 1 125.0 107 $&v(xt.vth_soft) $&v(xt.vth_hard) $&v(vref_buf) $&v(isense) $&i(vdda)
alter Vs0 dc=0
alter Vh0 dc=0
alter Vs1 dc=0
alter Vh1 dc=0
alter Vs2 dc=1.2
alter Vh2 dc=1.2
alter Vs3 dc=1.2
alter Vh3 dc=1.2
alter Vs4 dc=0
alter Vh4 dc=0
alter Vs5 dc=1.2
alter Vh5 dc=1.2
alter Vs6 dc=1.2
alter Vh6 dc=1.2
alter Vs7 dc=0
alter Vh7 dc=0
op
echo ROW 1 125.0 108 $&v(xt.vth_soft) $&v(xt.vth_hard) $&v(vref_buf) $&v(isense) $&i(vdda)
alter Vs0 dc=1.2
alter Vh0 dc=1.2
alter Vs1 dc=0
alter Vh1 dc=0
alter Vs2 dc=1.2
alter Vh2 dc=1.2
alter Vs3 dc=1.2
alter Vh3 dc=1.2
alter Vs4 dc=0
alter Vh4 dc=0
alter Vs5 dc=1.2
alter Vh5 dc=1.2
alter Vs6 dc=1.2
alter Vh6 dc=1.2
alter Vs7 dc=0
alter Vh7 dc=0
op
echo ROW 1 125.0 109 $&v(xt.vth_soft) $&v(xt.vth_hard) $&v(vref_buf) $&v(isense) $&i(vdda)
alter Vs0 dc=0
alter Vh0 dc=0
alter Vs1 dc=1.2
alter Vh1 dc=1.2
alter Vs2 dc=1.2
alter Vh2 dc=1.2
alter Vs3 dc=1.2
alter Vh3 dc=1.2
alter Vs4 dc=0
alter Vh4 dc=0
alter Vs5 dc=1.2
alter Vh5 dc=1.2
alter Vs6 dc=1.2
alter Vh6 dc=1.2
alter Vs7 dc=0
alter Vh7 dc=0
op
echo ROW 1 125.0 110 $&v(xt.vth_soft) $&v(xt.vth_hard) $&v(vref_buf) $&v(isense) $&i(vdda)
alter Vs0 dc=1.2
alter Vh0 dc=1.2
alter Vs1 dc=1.2
alter Vh1 dc=1.2
alter Vs2 dc=1.2
alter Vh2 dc=1.2
alter Vs3 dc=1.2
alter Vh3 dc=1.2
alter Vs4 dc=0
alter Vh4 dc=0
alter Vs5 dc=1.2
alter Vh5 dc=1.2
alter Vs6 dc=1.2
alter Vh6 dc=1.2
alter Vs7 dc=0
alter Vh7 dc=0
op
echo ROW 1 125.0 111 $&v(xt.vth_soft) $&v(xt.vth_hard) $&v(vref_buf) $&v(isense) $&i(vdda)
alter Vs0 dc=0
alter Vh0 dc=0
alter Vs1 dc=0
alter Vh1 dc=0
alter Vs2 dc=0
alter Vh2 dc=0
alter Vs3 dc=0
alter Vh3 dc=0
alter Vs4 dc=1.2
alter Vh4 dc=1.2
alter Vs5 dc=1.2
alter Vh5 dc=1.2
alter Vs6 dc=1.2
alter Vh6 dc=1.2
alter Vs7 dc=0
alter Vh7 dc=0
op
echo ROW 1 125.0 112 $&v(xt.vth_soft) $&v(xt.vth_hard) $&v(vref_buf) $&v(isense) $&i(vdda)
alter Vs0 dc=1.2
alter Vh0 dc=1.2
alter Vs1 dc=0
alter Vh1 dc=0
alter Vs2 dc=0
alter Vh2 dc=0
alter Vs3 dc=0
alter Vh3 dc=0
alter Vs4 dc=1.2
alter Vh4 dc=1.2
alter Vs5 dc=1.2
alter Vh5 dc=1.2
alter Vs6 dc=1.2
alter Vh6 dc=1.2
alter Vs7 dc=0
alter Vh7 dc=0
op
echo ROW 1 125.0 113 $&v(xt.vth_soft) $&v(xt.vth_hard) $&v(vref_buf) $&v(isense) $&i(vdda)
alter Vs0 dc=0
alter Vh0 dc=0
alter Vs1 dc=1.2
alter Vh1 dc=1.2
alter Vs2 dc=0
alter Vh2 dc=0
alter Vs3 dc=0
alter Vh3 dc=0
alter Vs4 dc=1.2
alter Vh4 dc=1.2
alter Vs5 dc=1.2
alter Vh5 dc=1.2
alter Vs6 dc=1.2
alter Vh6 dc=1.2
alter Vs7 dc=0
alter Vh7 dc=0
op
echo ROW 1 125.0 114 $&v(xt.vth_soft) $&v(xt.vth_hard) $&v(vref_buf) $&v(isense) $&i(vdda)
alter Vs0 dc=1.2
alter Vh0 dc=1.2
alter Vs1 dc=1.2
alter Vh1 dc=1.2
alter Vs2 dc=0
alter Vh2 dc=0
alter Vs3 dc=0
alter Vh3 dc=0
alter Vs4 dc=1.2
alter Vh4 dc=1.2
alter Vs5 dc=1.2
alter Vh5 dc=1.2
alter Vs6 dc=1.2
alter Vh6 dc=1.2
alter Vs7 dc=0
alter Vh7 dc=0
op
echo ROW 1 125.0 115 $&v(xt.vth_soft) $&v(xt.vth_hard) $&v(vref_buf) $&v(isense) $&i(vdda)
alter Vs0 dc=0
alter Vh0 dc=0
alter Vs1 dc=0
alter Vh1 dc=0
alter Vs2 dc=1.2
alter Vh2 dc=1.2
alter Vs3 dc=0
alter Vh3 dc=0
alter Vs4 dc=1.2
alter Vh4 dc=1.2
alter Vs5 dc=1.2
alter Vh5 dc=1.2
alter Vs6 dc=1.2
alter Vh6 dc=1.2
alter Vs7 dc=0
alter Vh7 dc=0
op
echo ROW 1 125.0 116 $&v(xt.vth_soft) $&v(xt.vth_hard) $&v(vref_buf) $&v(isense) $&i(vdda)
alter Vs0 dc=1.2
alter Vh0 dc=1.2
alter Vs1 dc=0
alter Vh1 dc=0
alter Vs2 dc=1.2
alter Vh2 dc=1.2
alter Vs3 dc=0
alter Vh3 dc=0
alter Vs4 dc=1.2
alter Vh4 dc=1.2
alter Vs5 dc=1.2
alter Vh5 dc=1.2
alter Vs6 dc=1.2
alter Vh6 dc=1.2
alter Vs7 dc=0
alter Vh7 dc=0
op
echo ROW 1 125.0 117 $&v(xt.vth_soft) $&v(xt.vth_hard) $&v(vref_buf) $&v(isense) $&i(vdda)
alter Vs0 dc=0
alter Vh0 dc=0
alter Vs1 dc=1.2
alter Vh1 dc=1.2
alter Vs2 dc=1.2
alter Vh2 dc=1.2
alter Vs3 dc=0
alter Vh3 dc=0
alter Vs4 dc=1.2
alter Vh4 dc=1.2
alter Vs5 dc=1.2
alter Vh5 dc=1.2
alter Vs6 dc=1.2
alter Vh6 dc=1.2
alter Vs7 dc=0
alter Vh7 dc=0
op
echo ROW 1 125.0 118 $&v(xt.vth_soft) $&v(xt.vth_hard) $&v(vref_buf) $&v(isense) $&i(vdda)
alter Vs0 dc=1.2
alter Vh0 dc=1.2
alter Vs1 dc=1.2
alter Vh1 dc=1.2
alter Vs2 dc=1.2
alter Vh2 dc=1.2
alter Vs3 dc=0
alter Vh3 dc=0
alter Vs4 dc=1.2
alter Vh4 dc=1.2
alter Vs5 dc=1.2
alter Vh5 dc=1.2
alter Vs6 dc=1.2
alter Vh6 dc=1.2
alter Vs7 dc=0
alter Vh7 dc=0
op
echo ROW 1 125.0 119 $&v(xt.vth_soft) $&v(xt.vth_hard) $&v(vref_buf) $&v(isense) $&i(vdda)
alter Vs0 dc=0
alter Vh0 dc=0
alter Vs1 dc=0
alter Vh1 dc=0
alter Vs2 dc=0
alter Vh2 dc=0
alter Vs3 dc=1.2
alter Vh3 dc=1.2
alter Vs4 dc=1.2
alter Vh4 dc=1.2
alter Vs5 dc=1.2
alter Vh5 dc=1.2
alter Vs6 dc=1.2
alter Vh6 dc=1.2
alter Vs7 dc=0
alter Vh7 dc=0
op
echo ROW 1 125.0 120 $&v(xt.vth_soft) $&v(xt.vth_hard) $&v(vref_buf) $&v(isense) $&i(vdda)
alter Vs0 dc=1.2
alter Vh0 dc=1.2
alter Vs1 dc=0
alter Vh1 dc=0
alter Vs2 dc=0
alter Vh2 dc=0
alter Vs3 dc=1.2
alter Vh3 dc=1.2
alter Vs4 dc=1.2
alter Vh4 dc=1.2
alter Vs5 dc=1.2
alter Vh5 dc=1.2
alter Vs6 dc=1.2
alter Vh6 dc=1.2
alter Vs7 dc=0
alter Vh7 dc=0
op
echo ROW 1 125.0 121 $&v(xt.vth_soft) $&v(xt.vth_hard) $&v(vref_buf) $&v(isense) $&i(vdda)
alter Vs0 dc=0
alter Vh0 dc=0
alter Vs1 dc=1.2
alter Vh1 dc=1.2
alter Vs2 dc=0
alter Vh2 dc=0
alter Vs3 dc=1.2
alter Vh3 dc=1.2
alter Vs4 dc=1.2
alter Vh4 dc=1.2
alter Vs5 dc=1.2
alter Vh5 dc=1.2
alter Vs6 dc=1.2
alter Vh6 dc=1.2
alter Vs7 dc=0
alter Vh7 dc=0
op
echo ROW 1 125.0 122 $&v(xt.vth_soft) $&v(xt.vth_hard) $&v(vref_buf) $&v(isense) $&i(vdda)
alter Vs0 dc=1.2
alter Vh0 dc=1.2
alter Vs1 dc=1.2
alter Vh1 dc=1.2
alter Vs2 dc=0
alter Vh2 dc=0
alter Vs3 dc=1.2
alter Vh3 dc=1.2
alter Vs4 dc=1.2
alter Vh4 dc=1.2
alter Vs5 dc=1.2
alter Vh5 dc=1.2
alter Vs6 dc=1.2
alter Vh6 dc=1.2
alter Vs7 dc=0
alter Vh7 dc=0
op
echo ROW 1 125.0 123 $&v(xt.vth_soft) $&v(xt.vth_hard) $&v(vref_buf) $&v(isense) $&i(vdda)
alter Vs0 dc=0
alter Vh0 dc=0
alter Vs1 dc=0
alter Vh1 dc=0
alter Vs2 dc=1.2
alter Vh2 dc=1.2
alter Vs3 dc=1.2
alter Vh3 dc=1.2
alter Vs4 dc=1.2
alter Vh4 dc=1.2
alter Vs5 dc=1.2
alter Vh5 dc=1.2
alter Vs6 dc=1.2
alter Vh6 dc=1.2
alter Vs7 dc=0
alter Vh7 dc=0
op
echo ROW 1 125.0 124 $&v(xt.vth_soft) $&v(xt.vth_hard) $&v(vref_buf) $&v(isense) $&i(vdda)
alter Vs0 dc=1.2
alter Vh0 dc=1.2
alter Vs1 dc=0
alter Vh1 dc=0
alter Vs2 dc=1.2
alter Vh2 dc=1.2
alter Vs3 dc=1.2
alter Vh3 dc=1.2
alter Vs4 dc=1.2
alter Vh4 dc=1.2
alter Vs5 dc=1.2
alter Vh5 dc=1.2
alter Vs6 dc=1.2
alter Vh6 dc=1.2
alter Vs7 dc=0
alter Vh7 dc=0
op
echo ROW 1 125.0 125 $&v(xt.vth_soft) $&v(xt.vth_hard) $&v(vref_buf) $&v(isense) $&i(vdda)
alter Vs0 dc=0
alter Vh0 dc=0
alter Vs1 dc=1.2
alter Vh1 dc=1.2
alter Vs2 dc=1.2
alter Vh2 dc=1.2
alter Vs3 dc=1.2
alter Vh3 dc=1.2
alter Vs4 dc=1.2
alter Vh4 dc=1.2
alter Vs5 dc=1.2
alter Vh5 dc=1.2
alter Vs6 dc=1.2
alter Vh6 dc=1.2
alter Vs7 dc=0
alter Vh7 dc=0
op
echo ROW 1 125.0 126 $&v(xt.vth_soft) $&v(xt.vth_hard) $&v(vref_buf) $&v(isense) $&i(vdda)
alter Vs0 dc=1.2
alter Vh0 dc=1.2
alter Vs1 dc=1.2
alter Vh1 dc=1.2
alter Vs2 dc=1.2
alter Vh2 dc=1.2
alter Vs3 dc=1.2
alter Vh3 dc=1.2
alter Vs4 dc=1.2
alter Vh4 dc=1.2
alter Vs5 dc=1.2
alter Vh5 dc=1.2
alter Vs6 dc=1.2
alter Vh6 dc=1.2
alter Vs7 dc=0
alter Vh7 dc=0
op
echo ROW 1 125.0 127 $&v(xt.vth_soft) $&v(xt.vth_hard) $&v(vref_buf) $&v(isense) $&i(vdda)
alter Vs0 dc=0
alter Vh0 dc=0
alter Vs1 dc=0
alter Vh1 dc=0
alter Vs2 dc=0
alter Vh2 dc=0
alter Vs3 dc=0
alter Vh3 dc=0
alter Vs4 dc=0
alter Vh4 dc=0
alter Vs5 dc=0
alter Vh5 dc=0
alter Vs6 dc=0
alter Vh6 dc=0
alter Vs7 dc=1.2
alter Vh7 dc=1.2
op
echo ROW 1 125.0 128 $&v(xt.vth_soft) $&v(xt.vth_hard) $&v(vref_buf) $&v(isense) $&i(vdda)
alter Vs0 dc=1.2
alter Vh0 dc=1.2
alter Vs1 dc=0
alter Vh1 dc=0
alter Vs2 dc=0
alter Vh2 dc=0
alter Vs3 dc=0
alter Vh3 dc=0
alter Vs4 dc=0
alter Vh4 dc=0
alter Vs5 dc=0
alter Vh5 dc=0
alter Vs6 dc=0
alter Vh6 dc=0
alter Vs7 dc=1.2
alter Vh7 dc=1.2
op
echo ROW 1 125.0 129 $&v(xt.vth_soft) $&v(xt.vth_hard) $&v(vref_buf) $&v(isense) $&i(vdda)
alter Vs0 dc=0
alter Vh0 dc=0
alter Vs1 dc=1.2
alter Vh1 dc=1.2
alter Vs2 dc=0
alter Vh2 dc=0
alter Vs3 dc=0
alter Vh3 dc=0
alter Vs4 dc=0
alter Vh4 dc=0
alter Vs5 dc=0
alter Vh5 dc=0
alter Vs6 dc=0
alter Vh6 dc=0
alter Vs7 dc=1.2
alter Vh7 dc=1.2
op
echo ROW 1 125.0 130 $&v(xt.vth_soft) $&v(xt.vth_hard) $&v(vref_buf) $&v(isense) $&i(vdda)
alter Vs0 dc=1.2
alter Vh0 dc=1.2
alter Vs1 dc=1.2
alter Vh1 dc=1.2
alter Vs2 dc=0
alter Vh2 dc=0
alter Vs3 dc=0
alter Vh3 dc=0
alter Vs4 dc=0
alter Vh4 dc=0
alter Vs5 dc=0
alter Vh5 dc=0
alter Vs6 dc=0
alter Vh6 dc=0
alter Vs7 dc=1.2
alter Vh7 dc=1.2
op
echo ROW 1 125.0 131 $&v(xt.vth_soft) $&v(xt.vth_hard) $&v(vref_buf) $&v(isense) $&i(vdda)
alter Vs0 dc=0
alter Vh0 dc=0
alter Vs1 dc=0
alter Vh1 dc=0
alter Vs2 dc=1.2
alter Vh2 dc=1.2
alter Vs3 dc=0
alter Vh3 dc=0
alter Vs4 dc=0
alter Vh4 dc=0
alter Vs5 dc=0
alter Vh5 dc=0
alter Vs6 dc=0
alter Vh6 dc=0
alter Vs7 dc=1.2
alter Vh7 dc=1.2
op
echo ROW 1 125.0 132 $&v(xt.vth_soft) $&v(xt.vth_hard) $&v(vref_buf) $&v(isense) $&i(vdda)
alter Vs0 dc=1.2
alter Vh0 dc=1.2
alter Vs1 dc=0
alter Vh1 dc=0
alter Vs2 dc=1.2
alter Vh2 dc=1.2
alter Vs3 dc=0
alter Vh3 dc=0
alter Vs4 dc=0
alter Vh4 dc=0
alter Vs5 dc=0
alter Vh5 dc=0
alter Vs6 dc=0
alter Vh6 dc=0
alter Vs7 dc=1.2
alter Vh7 dc=1.2
op
echo ROW 1 125.0 133 $&v(xt.vth_soft) $&v(xt.vth_hard) $&v(vref_buf) $&v(isense) $&i(vdda)
alter Vs0 dc=0
alter Vh0 dc=0
alter Vs1 dc=1.2
alter Vh1 dc=1.2
alter Vs2 dc=1.2
alter Vh2 dc=1.2
alter Vs3 dc=0
alter Vh3 dc=0
alter Vs4 dc=0
alter Vh4 dc=0
alter Vs5 dc=0
alter Vh5 dc=0
alter Vs6 dc=0
alter Vh6 dc=0
alter Vs7 dc=1.2
alter Vh7 dc=1.2
op
echo ROW 1 125.0 134 $&v(xt.vth_soft) $&v(xt.vth_hard) $&v(vref_buf) $&v(isense) $&i(vdda)
alter Vs0 dc=1.2
alter Vh0 dc=1.2
alter Vs1 dc=1.2
alter Vh1 dc=1.2
alter Vs2 dc=1.2
alter Vh2 dc=1.2
alter Vs3 dc=0
alter Vh3 dc=0
alter Vs4 dc=0
alter Vh4 dc=0
alter Vs5 dc=0
alter Vh5 dc=0
alter Vs6 dc=0
alter Vh6 dc=0
alter Vs7 dc=1.2
alter Vh7 dc=1.2
op
echo ROW 1 125.0 135 $&v(xt.vth_soft) $&v(xt.vth_hard) $&v(vref_buf) $&v(isense) $&i(vdda)
alter Vs0 dc=0
alter Vh0 dc=0
alter Vs1 dc=0
alter Vh1 dc=0
alter Vs2 dc=0
alter Vh2 dc=0
alter Vs3 dc=1.2
alter Vh3 dc=1.2
alter Vs4 dc=0
alter Vh4 dc=0
alter Vs5 dc=0
alter Vh5 dc=0
alter Vs6 dc=0
alter Vh6 dc=0
alter Vs7 dc=1.2
alter Vh7 dc=1.2
op
echo ROW 1 125.0 136 $&v(xt.vth_soft) $&v(xt.vth_hard) $&v(vref_buf) $&v(isense) $&i(vdda)
alter Vs0 dc=1.2
alter Vh0 dc=1.2
alter Vs1 dc=0
alter Vh1 dc=0
alter Vs2 dc=0
alter Vh2 dc=0
alter Vs3 dc=1.2
alter Vh3 dc=1.2
alter Vs4 dc=0
alter Vh4 dc=0
alter Vs5 dc=0
alter Vh5 dc=0
alter Vs6 dc=0
alter Vh6 dc=0
alter Vs7 dc=1.2
alter Vh7 dc=1.2
op
echo ROW 1 125.0 137 $&v(xt.vth_soft) $&v(xt.vth_hard) $&v(vref_buf) $&v(isense) $&i(vdda)
alter Vs0 dc=0
alter Vh0 dc=0
alter Vs1 dc=1.2
alter Vh1 dc=1.2
alter Vs2 dc=0
alter Vh2 dc=0
alter Vs3 dc=1.2
alter Vh3 dc=1.2
alter Vs4 dc=0
alter Vh4 dc=0
alter Vs5 dc=0
alter Vh5 dc=0
alter Vs6 dc=0
alter Vh6 dc=0
alter Vs7 dc=1.2
alter Vh7 dc=1.2
op
echo ROW 1 125.0 138 $&v(xt.vth_soft) $&v(xt.vth_hard) $&v(vref_buf) $&v(isense) $&i(vdda)
alter Vs0 dc=1.2
alter Vh0 dc=1.2
alter Vs1 dc=1.2
alter Vh1 dc=1.2
alter Vs2 dc=0
alter Vh2 dc=0
alter Vs3 dc=1.2
alter Vh3 dc=1.2
alter Vs4 dc=0
alter Vh4 dc=0
alter Vs5 dc=0
alter Vh5 dc=0
alter Vs6 dc=0
alter Vh6 dc=0
alter Vs7 dc=1.2
alter Vh7 dc=1.2
op
echo ROW 1 125.0 139 $&v(xt.vth_soft) $&v(xt.vth_hard) $&v(vref_buf) $&v(isense) $&i(vdda)
alter Vs0 dc=0
alter Vh0 dc=0
alter Vs1 dc=0
alter Vh1 dc=0
alter Vs2 dc=1.2
alter Vh2 dc=1.2
alter Vs3 dc=1.2
alter Vh3 dc=1.2
alter Vs4 dc=0
alter Vh4 dc=0
alter Vs5 dc=0
alter Vh5 dc=0
alter Vs6 dc=0
alter Vh6 dc=0
alter Vs7 dc=1.2
alter Vh7 dc=1.2
op
echo ROW 1 125.0 140 $&v(xt.vth_soft) $&v(xt.vth_hard) $&v(vref_buf) $&v(isense) $&i(vdda)
alter Vs0 dc=1.2
alter Vh0 dc=1.2
alter Vs1 dc=0
alter Vh1 dc=0
alter Vs2 dc=1.2
alter Vh2 dc=1.2
alter Vs3 dc=1.2
alter Vh3 dc=1.2
alter Vs4 dc=0
alter Vh4 dc=0
alter Vs5 dc=0
alter Vh5 dc=0
alter Vs6 dc=0
alter Vh6 dc=0
alter Vs7 dc=1.2
alter Vh7 dc=1.2
op
echo ROW 1 125.0 141 $&v(xt.vth_soft) $&v(xt.vth_hard) $&v(vref_buf) $&v(isense) $&i(vdda)
alter Vs0 dc=0
alter Vh0 dc=0
alter Vs1 dc=1.2
alter Vh1 dc=1.2
alter Vs2 dc=1.2
alter Vh2 dc=1.2
alter Vs3 dc=1.2
alter Vh3 dc=1.2
alter Vs4 dc=0
alter Vh4 dc=0
alter Vs5 dc=0
alter Vh5 dc=0
alter Vs6 dc=0
alter Vh6 dc=0
alter Vs7 dc=1.2
alter Vh7 dc=1.2
op
echo ROW 1 125.0 142 $&v(xt.vth_soft) $&v(xt.vth_hard) $&v(vref_buf) $&v(isense) $&i(vdda)
alter Vs0 dc=1.2
alter Vh0 dc=1.2
alter Vs1 dc=1.2
alter Vh1 dc=1.2
alter Vs2 dc=1.2
alter Vh2 dc=1.2
alter Vs3 dc=1.2
alter Vh3 dc=1.2
alter Vs4 dc=0
alter Vh4 dc=0
alter Vs5 dc=0
alter Vh5 dc=0
alter Vs6 dc=0
alter Vh6 dc=0
alter Vs7 dc=1.2
alter Vh7 dc=1.2
op
echo ROW 1 125.0 143 $&v(xt.vth_soft) $&v(xt.vth_hard) $&v(vref_buf) $&v(isense) $&i(vdda)
alter Vs0 dc=0
alter Vh0 dc=0
alter Vs1 dc=0
alter Vh1 dc=0
alter Vs2 dc=0
alter Vh2 dc=0
alter Vs3 dc=0
alter Vh3 dc=0
alter Vs4 dc=1.2
alter Vh4 dc=1.2
alter Vs5 dc=0
alter Vh5 dc=0
alter Vs6 dc=0
alter Vh6 dc=0
alter Vs7 dc=1.2
alter Vh7 dc=1.2
op
echo ROW 1 125.0 144 $&v(xt.vth_soft) $&v(xt.vth_hard) $&v(vref_buf) $&v(isense) $&i(vdda)
alter Vs0 dc=1.2
alter Vh0 dc=1.2
alter Vs1 dc=0
alter Vh1 dc=0
alter Vs2 dc=0
alter Vh2 dc=0
alter Vs3 dc=0
alter Vh3 dc=0
alter Vs4 dc=1.2
alter Vh4 dc=1.2
alter Vs5 dc=0
alter Vh5 dc=0
alter Vs6 dc=0
alter Vh6 dc=0
alter Vs7 dc=1.2
alter Vh7 dc=1.2
op
echo ROW 1 125.0 145 $&v(xt.vth_soft) $&v(xt.vth_hard) $&v(vref_buf) $&v(isense) $&i(vdda)
alter Vs0 dc=0
alter Vh0 dc=0
alter Vs1 dc=1.2
alter Vh1 dc=1.2
alter Vs2 dc=0
alter Vh2 dc=0
alter Vs3 dc=0
alter Vh3 dc=0
alter Vs4 dc=1.2
alter Vh4 dc=1.2
alter Vs5 dc=0
alter Vh5 dc=0
alter Vs6 dc=0
alter Vh6 dc=0
alter Vs7 dc=1.2
alter Vh7 dc=1.2
op
echo ROW 1 125.0 146 $&v(xt.vth_soft) $&v(xt.vth_hard) $&v(vref_buf) $&v(isense) $&i(vdda)
alter Vs0 dc=1.2
alter Vh0 dc=1.2
alter Vs1 dc=1.2
alter Vh1 dc=1.2
alter Vs2 dc=0
alter Vh2 dc=0
alter Vs3 dc=0
alter Vh3 dc=0
alter Vs4 dc=1.2
alter Vh4 dc=1.2
alter Vs5 dc=0
alter Vh5 dc=0
alter Vs6 dc=0
alter Vh6 dc=0
alter Vs7 dc=1.2
alter Vh7 dc=1.2
op
echo ROW 1 125.0 147 $&v(xt.vth_soft) $&v(xt.vth_hard) $&v(vref_buf) $&v(isense) $&i(vdda)
alter Vs0 dc=0
alter Vh0 dc=0
alter Vs1 dc=0
alter Vh1 dc=0
alter Vs2 dc=1.2
alter Vh2 dc=1.2
alter Vs3 dc=0
alter Vh3 dc=0
alter Vs4 dc=1.2
alter Vh4 dc=1.2
alter Vs5 dc=0
alter Vh5 dc=0
alter Vs6 dc=0
alter Vh6 dc=0
alter Vs7 dc=1.2
alter Vh7 dc=1.2
op
echo ROW 1 125.0 148 $&v(xt.vth_soft) $&v(xt.vth_hard) $&v(vref_buf) $&v(isense) $&i(vdda)
alter Vs0 dc=1.2
alter Vh0 dc=1.2
alter Vs1 dc=0
alter Vh1 dc=0
alter Vs2 dc=1.2
alter Vh2 dc=1.2
alter Vs3 dc=0
alter Vh3 dc=0
alter Vs4 dc=1.2
alter Vh4 dc=1.2
alter Vs5 dc=0
alter Vh5 dc=0
alter Vs6 dc=0
alter Vh6 dc=0
alter Vs7 dc=1.2
alter Vh7 dc=1.2
op
echo ROW 1 125.0 149 $&v(xt.vth_soft) $&v(xt.vth_hard) $&v(vref_buf) $&v(isense) $&i(vdda)
alter Vs0 dc=0
alter Vh0 dc=0
alter Vs1 dc=1.2
alter Vh1 dc=1.2
alter Vs2 dc=1.2
alter Vh2 dc=1.2
alter Vs3 dc=0
alter Vh3 dc=0
alter Vs4 dc=1.2
alter Vh4 dc=1.2
alter Vs5 dc=0
alter Vh5 dc=0
alter Vs6 dc=0
alter Vh6 dc=0
alter Vs7 dc=1.2
alter Vh7 dc=1.2
op
echo ROW 1 125.0 150 $&v(xt.vth_soft) $&v(xt.vth_hard) $&v(vref_buf) $&v(isense) $&i(vdda)
alter Vs0 dc=1.2
alter Vh0 dc=1.2
alter Vs1 dc=1.2
alter Vh1 dc=1.2
alter Vs2 dc=1.2
alter Vh2 dc=1.2
alter Vs3 dc=0
alter Vh3 dc=0
alter Vs4 dc=1.2
alter Vh4 dc=1.2
alter Vs5 dc=0
alter Vh5 dc=0
alter Vs6 dc=0
alter Vh6 dc=0
alter Vs7 dc=1.2
alter Vh7 dc=1.2
op
echo ROW 1 125.0 151 $&v(xt.vth_soft) $&v(xt.vth_hard) $&v(vref_buf) $&v(isense) $&i(vdda)
alter Vs0 dc=0
alter Vh0 dc=0
alter Vs1 dc=0
alter Vh1 dc=0
alter Vs2 dc=0
alter Vh2 dc=0
alter Vs3 dc=1.2
alter Vh3 dc=1.2
alter Vs4 dc=1.2
alter Vh4 dc=1.2
alter Vs5 dc=0
alter Vh5 dc=0
alter Vs6 dc=0
alter Vh6 dc=0
alter Vs7 dc=1.2
alter Vh7 dc=1.2
op
echo ROW 1 125.0 152 $&v(xt.vth_soft) $&v(xt.vth_hard) $&v(vref_buf) $&v(isense) $&i(vdda)
alter Vs0 dc=1.2
alter Vh0 dc=1.2
alter Vs1 dc=0
alter Vh1 dc=0
alter Vs2 dc=0
alter Vh2 dc=0
alter Vs3 dc=1.2
alter Vh3 dc=1.2
alter Vs4 dc=1.2
alter Vh4 dc=1.2
alter Vs5 dc=0
alter Vh5 dc=0
alter Vs6 dc=0
alter Vh6 dc=0
alter Vs7 dc=1.2
alter Vh7 dc=1.2
op
echo ROW 1 125.0 153 $&v(xt.vth_soft) $&v(xt.vth_hard) $&v(vref_buf) $&v(isense) $&i(vdda)
alter Vs0 dc=0
alter Vh0 dc=0
alter Vs1 dc=1.2
alter Vh1 dc=1.2
alter Vs2 dc=0
alter Vh2 dc=0
alter Vs3 dc=1.2
alter Vh3 dc=1.2
alter Vs4 dc=1.2
alter Vh4 dc=1.2
alter Vs5 dc=0
alter Vh5 dc=0
alter Vs6 dc=0
alter Vh6 dc=0
alter Vs7 dc=1.2
alter Vh7 dc=1.2
op
echo ROW 1 125.0 154 $&v(xt.vth_soft) $&v(xt.vth_hard) $&v(vref_buf) $&v(isense) $&i(vdda)
alter Vs0 dc=1.2
alter Vh0 dc=1.2
alter Vs1 dc=1.2
alter Vh1 dc=1.2
alter Vs2 dc=0
alter Vh2 dc=0
alter Vs3 dc=1.2
alter Vh3 dc=1.2
alter Vs4 dc=1.2
alter Vh4 dc=1.2
alter Vs5 dc=0
alter Vh5 dc=0
alter Vs6 dc=0
alter Vh6 dc=0
alter Vs7 dc=1.2
alter Vh7 dc=1.2
op
echo ROW 1 125.0 155 $&v(xt.vth_soft) $&v(xt.vth_hard) $&v(vref_buf) $&v(isense) $&i(vdda)
alter Vs0 dc=0
alter Vh0 dc=0
alter Vs1 dc=0
alter Vh1 dc=0
alter Vs2 dc=1.2
alter Vh2 dc=1.2
alter Vs3 dc=1.2
alter Vh3 dc=1.2
alter Vs4 dc=1.2
alter Vh4 dc=1.2
alter Vs5 dc=0
alter Vh5 dc=0
alter Vs6 dc=0
alter Vh6 dc=0
alter Vs7 dc=1.2
alter Vh7 dc=1.2
op
echo ROW 1 125.0 156 $&v(xt.vth_soft) $&v(xt.vth_hard) $&v(vref_buf) $&v(isense) $&i(vdda)
alter Vs0 dc=1.2
alter Vh0 dc=1.2
alter Vs1 dc=0
alter Vh1 dc=0
alter Vs2 dc=1.2
alter Vh2 dc=1.2
alter Vs3 dc=1.2
alter Vh3 dc=1.2
alter Vs4 dc=1.2
alter Vh4 dc=1.2
alter Vs5 dc=0
alter Vh5 dc=0
alter Vs6 dc=0
alter Vh6 dc=0
alter Vs7 dc=1.2
alter Vh7 dc=1.2
op
echo ROW 1 125.0 157 $&v(xt.vth_soft) $&v(xt.vth_hard) $&v(vref_buf) $&v(isense) $&i(vdda)
alter Vs0 dc=0
alter Vh0 dc=0
alter Vs1 dc=1.2
alter Vh1 dc=1.2
alter Vs2 dc=1.2
alter Vh2 dc=1.2
alter Vs3 dc=1.2
alter Vh3 dc=1.2
alter Vs4 dc=1.2
alter Vh4 dc=1.2
alter Vs5 dc=0
alter Vh5 dc=0
alter Vs6 dc=0
alter Vh6 dc=0
alter Vs7 dc=1.2
alter Vh7 dc=1.2
op
echo ROW 1 125.0 158 $&v(xt.vth_soft) $&v(xt.vth_hard) $&v(vref_buf) $&v(isense) $&i(vdda)
alter Vs0 dc=1.2
alter Vh0 dc=1.2
alter Vs1 dc=1.2
alter Vh1 dc=1.2
alter Vs2 dc=1.2
alter Vh2 dc=1.2
alter Vs3 dc=1.2
alter Vh3 dc=1.2
alter Vs4 dc=1.2
alter Vh4 dc=1.2
alter Vs5 dc=0
alter Vh5 dc=0
alter Vs6 dc=0
alter Vh6 dc=0
alter Vs7 dc=1.2
alter Vh7 dc=1.2
op
echo ROW 1 125.0 159 $&v(xt.vth_soft) $&v(xt.vth_hard) $&v(vref_buf) $&v(isense) $&i(vdda)
alter Vs0 dc=0
alter Vh0 dc=0
alter Vs1 dc=0
alter Vh1 dc=0
alter Vs2 dc=0
alter Vh2 dc=0
alter Vs3 dc=0
alter Vh3 dc=0
alter Vs4 dc=0
alter Vh4 dc=0
alter Vs5 dc=1.2
alter Vh5 dc=1.2
alter Vs6 dc=0
alter Vh6 dc=0
alter Vs7 dc=1.2
alter Vh7 dc=1.2
op
echo ROW 1 125.0 160 $&v(xt.vth_soft) $&v(xt.vth_hard) $&v(vref_buf) $&v(isense) $&i(vdda)
alter Vs0 dc=1.2
alter Vh0 dc=1.2
alter Vs1 dc=0
alter Vh1 dc=0
alter Vs2 dc=0
alter Vh2 dc=0
alter Vs3 dc=0
alter Vh3 dc=0
alter Vs4 dc=0
alter Vh4 dc=0
alter Vs5 dc=1.2
alter Vh5 dc=1.2
alter Vs6 dc=0
alter Vh6 dc=0
alter Vs7 dc=1.2
alter Vh7 dc=1.2
op
echo ROW 1 125.0 161 $&v(xt.vth_soft) $&v(xt.vth_hard) $&v(vref_buf) $&v(isense) $&i(vdda)
alter Vs0 dc=0
alter Vh0 dc=0
alter Vs1 dc=1.2
alter Vh1 dc=1.2
alter Vs2 dc=0
alter Vh2 dc=0
alter Vs3 dc=0
alter Vh3 dc=0
alter Vs4 dc=0
alter Vh4 dc=0
alter Vs5 dc=1.2
alter Vh5 dc=1.2
alter Vs6 dc=0
alter Vh6 dc=0
alter Vs7 dc=1.2
alter Vh7 dc=1.2
op
echo ROW 1 125.0 162 $&v(xt.vth_soft) $&v(xt.vth_hard) $&v(vref_buf) $&v(isense) $&i(vdda)
alter Vs0 dc=1.2
alter Vh0 dc=1.2
alter Vs1 dc=1.2
alter Vh1 dc=1.2
alter Vs2 dc=0
alter Vh2 dc=0
alter Vs3 dc=0
alter Vh3 dc=0
alter Vs4 dc=0
alter Vh4 dc=0
alter Vs5 dc=1.2
alter Vh5 dc=1.2
alter Vs6 dc=0
alter Vh6 dc=0
alter Vs7 dc=1.2
alter Vh7 dc=1.2
op
echo ROW 1 125.0 163 $&v(xt.vth_soft) $&v(xt.vth_hard) $&v(vref_buf) $&v(isense) $&i(vdda)
alter Vs0 dc=0
alter Vh0 dc=0
alter Vs1 dc=0
alter Vh1 dc=0
alter Vs2 dc=1.2
alter Vh2 dc=1.2
alter Vs3 dc=0
alter Vh3 dc=0
alter Vs4 dc=0
alter Vh4 dc=0
alter Vs5 dc=1.2
alter Vh5 dc=1.2
alter Vs6 dc=0
alter Vh6 dc=0
alter Vs7 dc=1.2
alter Vh7 dc=1.2
op
echo ROW 1 125.0 164 $&v(xt.vth_soft) $&v(xt.vth_hard) $&v(vref_buf) $&v(isense) $&i(vdda)
alter Vs0 dc=1.2
alter Vh0 dc=1.2
alter Vs1 dc=0
alter Vh1 dc=0
alter Vs2 dc=1.2
alter Vh2 dc=1.2
alter Vs3 dc=0
alter Vh3 dc=0
alter Vs4 dc=0
alter Vh4 dc=0
alter Vs5 dc=1.2
alter Vh5 dc=1.2
alter Vs6 dc=0
alter Vh6 dc=0
alter Vs7 dc=1.2
alter Vh7 dc=1.2
op
echo ROW 1 125.0 165 $&v(xt.vth_soft) $&v(xt.vth_hard) $&v(vref_buf) $&v(isense) $&i(vdda)
alter Vs0 dc=0
alter Vh0 dc=0
alter Vs1 dc=1.2
alter Vh1 dc=1.2
alter Vs2 dc=1.2
alter Vh2 dc=1.2
alter Vs3 dc=0
alter Vh3 dc=0
alter Vs4 dc=0
alter Vh4 dc=0
alter Vs5 dc=1.2
alter Vh5 dc=1.2
alter Vs6 dc=0
alter Vh6 dc=0
alter Vs7 dc=1.2
alter Vh7 dc=1.2
op
echo ROW 1 125.0 166 $&v(xt.vth_soft) $&v(xt.vth_hard) $&v(vref_buf) $&v(isense) $&i(vdda)
alter Vs0 dc=1.2
alter Vh0 dc=1.2
alter Vs1 dc=1.2
alter Vh1 dc=1.2
alter Vs2 dc=1.2
alter Vh2 dc=1.2
alter Vs3 dc=0
alter Vh3 dc=0
alter Vs4 dc=0
alter Vh4 dc=0
alter Vs5 dc=1.2
alter Vh5 dc=1.2
alter Vs6 dc=0
alter Vh6 dc=0
alter Vs7 dc=1.2
alter Vh7 dc=1.2
op
echo ROW 1 125.0 167 $&v(xt.vth_soft) $&v(xt.vth_hard) $&v(vref_buf) $&v(isense) $&i(vdda)
alter Vs0 dc=0
alter Vh0 dc=0
alter Vs1 dc=0
alter Vh1 dc=0
alter Vs2 dc=0
alter Vh2 dc=0
alter Vs3 dc=1.2
alter Vh3 dc=1.2
alter Vs4 dc=0
alter Vh4 dc=0
alter Vs5 dc=1.2
alter Vh5 dc=1.2
alter Vs6 dc=0
alter Vh6 dc=0
alter Vs7 dc=1.2
alter Vh7 dc=1.2
op
echo ROW 1 125.0 168 $&v(xt.vth_soft) $&v(xt.vth_hard) $&v(vref_buf) $&v(isense) $&i(vdda)
alter Vs0 dc=1.2
alter Vh0 dc=1.2
alter Vs1 dc=0
alter Vh1 dc=0
alter Vs2 dc=0
alter Vh2 dc=0
alter Vs3 dc=1.2
alter Vh3 dc=1.2
alter Vs4 dc=0
alter Vh4 dc=0
alter Vs5 dc=1.2
alter Vh5 dc=1.2
alter Vs6 dc=0
alter Vh6 dc=0
alter Vs7 dc=1.2
alter Vh7 dc=1.2
op
echo ROW 1 125.0 169 $&v(xt.vth_soft) $&v(xt.vth_hard) $&v(vref_buf) $&v(isense) $&i(vdda)
alter Vs0 dc=0
alter Vh0 dc=0
alter Vs1 dc=1.2
alter Vh1 dc=1.2
alter Vs2 dc=0
alter Vh2 dc=0
alter Vs3 dc=1.2
alter Vh3 dc=1.2
alter Vs4 dc=0
alter Vh4 dc=0
alter Vs5 dc=1.2
alter Vh5 dc=1.2
alter Vs6 dc=0
alter Vh6 dc=0
alter Vs7 dc=1.2
alter Vh7 dc=1.2
op
echo ROW 1 125.0 170 $&v(xt.vth_soft) $&v(xt.vth_hard) $&v(vref_buf) $&v(isense) $&i(vdda)
alter Vs0 dc=1.2
alter Vh0 dc=1.2
alter Vs1 dc=1.2
alter Vh1 dc=1.2
alter Vs2 dc=0
alter Vh2 dc=0
alter Vs3 dc=1.2
alter Vh3 dc=1.2
alter Vs4 dc=0
alter Vh4 dc=0
alter Vs5 dc=1.2
alter Vh5 dc=1.2
alter Vs6 dc=0
alter Vh6 dc=0
alter Vs7 dc=1.2
alter Vh7 dc=1.2
op
echo ROW 1 125.0 171 $&v(xt.vth_soft) $&v(xt.vth_hard) $&v(vref_buf) $&v(isense) $&i(vdda)
alter Vs0 dc=0
alter Vh0 dc=0
alter Vs1 dc=0
alter Vh1 dc=0
alter Vs2 dc=1.2
alter Vh2 dc=1.2
alter Vs3 dc=1.2
alter Vh3 dc=1.2
alter Vs4 dc=0
alter Vh4 dc=0
alter Vs5 dc=1.2
alter Vh5 dc=1.2
alter Vs6 dc=0
alter Vh6 dc=0
alter Vs7 dc=1.2
alter Vh7 dc=1.2
op
echo ROW 1 125.0 172 $&v(xt.vth_soft) $&v(xt.vth_hard) $&v(vref_buf) $&v(isense) $&i(vdda)
alter Vs0 dc=1.2
alter Vh0 dc=1.2
alter Vs1 dc=0
alter Vh1 dc=0
alter Vs2 dc=1.2
alter Vh2 dc=1.2
alter Vs3 dc=1.2
alter Vh3 dc=1.2
alter Vs4 dc=0
alter Vh4 dc=0
alter Vs5 dc=1.2
alter Vh5 dc=1.2
alter Vs6 dc=0
alter Vh6 dc=0
alter Vs7 dc=1.2
alter Vh7 dc=1.2
op
echo ROW 1 125.0 173 $&v(xt.vth_soft) $&v(xt.vth_hard) $&v(vref_buf) $&v(isense) $&i(vdda)
alter Vs0 dc=0
alter Vh0 dc=0
alter Vs1 dc=1.2
alter Vh1 dc=1.2
alter Vs2 dc=1.2
alter Vh2 dc=1.2
alter Vs3 dc=1.2
alter Vh3 dc=1.2
alter Vs4 dc=0
alter Vh4 dc=0
alter Vs5 dc=1.2
alter Vh5 dc=1.2
alter Vs6 dc=0
alter Vh6 dc=0
alter Vs7 dc=1.2
alter Vh7 dc=1.2
op
echo ROW 1 125.0 174 $&v(xt.vth_soft) $&v(xt.vth_hard) $&v(vref_buf) $&v(isense) $&i(vdda)
alter Vs0 dc=1.2
alter Vh0 dc=1.2
alter Vs1 dc=1.2
alter Vh1 dc=1.2
alter Vs2 dc=1.2
alter Vh2 dc=1.2
alter Vs3 dc=1.2
alter Vh3 dc=1.2
alter Vs4 dc=0
alter Vh4 dc=0
alter Vs5 dc=1.2
alter Vh5 dc=1.2
alter Vs6 dc=0
alter Vh6 dc=0
alter Vs7 dc=1.2
alter Vh7 dc=1.2
op
echo ROW 1 125.0 175 $&v(xt.vth_soft) $&v(xt.vth_hard) $&v(vref_buf) $&v(isense) $&i(vdda)
alter Vs0 dc=0
alter Vh0 dc=0
alter Vs1 dc=0
alter Vh1 dc=0
alter Vs2 dc=0
alter Vh2 dc=0
alter Vs3 dc=0
alter Vh3 dc=0
alter Vs4 dc=1.2
alter Vh4 dc=1.2
alter Vs5 dc=1.2
alter Vh5 dc=1.2
alter Vs6 dc=0
alter Vh6 dc=0
alter Vs7 dc=1.2
alter Vh7 dc=1.2
op
echo ROW 1 125.0 176 $&v(xt.vth_soft) $&v(xt.vth_hard) $&v(vref_buf) $&v(isense) $&i(vdda)
alter Vs0 dc=1.2
alter Vh0 dc=1.2
alter Vs1 dc=0
alter Vh1 dc=0
alter Vs2 dc=0
alter Vh2 dc=0
alter Vs3 dc=0
alter Vh3 dc=0
alter Vs4 dc=1.2
alter Vh4 dc=1.2
alter Vs5 dc=1.2
alter Vh5 dc=1.2
alter Vs6 dc=0
alter Vh6 dc=0
alter Vs7 dc=1.2
alter Vh7 dc=1.2
op
echo ROW 1 125.0 177 $&v(xt.vth_soft) $&v(xt.vth_hard) $&v(vref_buf) $&v(isense) $&i(vdda)
alter Vs0 dc=0
alter Vh0 dc=0
alter Vs1 dc=1.2
alter Vh1 dc=1.2
alter Vs2 dc=0
alter Vh2 dc=0
alter Vs3 dc=0
alter Vh3 dc=0
alter Vs4 dc=1.2
alter Vh4 dc=1.2
alter Vs5 dc=1.2
alter Vh5 dc=1.2
alter Vs6 dc=0
alter Vh6 dc=0
alter Vs7 dc=1.2
alter Vh7 dc=1.2
op
echo ROW 1 125.0 178 $&v(xt.vth_soft) $&v(xt.vth_hard) $&v(vref_buf) $&v(isense) $&i(vdda)
alter Vs0 dc=1.2
alter Vh0 dc=1.2
alter Vs1 dc=1.2
alter Vh1 dc=1.2
alter Vs2 dc=0
alter Vh2 dc=0
alter Vs3 dc=0
alter Vh3 dc=0
alter Vs4 dc=1.2
alter Vh4 dc=1.2
alter Vs5 dc=1.2
alter Vh5 dc=1.2
alter Vs6 dc=0
alter Vh6 dc=0
alter Vs7 dc=1.2
alter Vh7 dc=1.2
op
echo ROW 1 125.0 179 $&v(xt.vth_soft) $&v(xt.vth_hard) $&v(vref_buf) $&v(isense) $&i(vdda)
alter Vs0 dc=0
alter Vh0 dc=0
alter Vs1 dc=0
alter Vh1 dc=0
alter Vs2 dc=1.2
alter Vh2 dc=1.2
alter Vs3 dc=0
alter Vh3 dc=0
alter Vs4 dc=1.2
alter Vh4 dc=1.2
alter Vs5 dc=1.2
alter Vh5 dc=1.2
alter Vs6 dc=0
alter Vh6 dc=0
alter Vs7 dc=1.2
alter Vh7 dc=1.2
op
echo ROW 1 125.0 180 $&v(xt.vth_soft) $&v(xt.vth_hard) $&v(vref_buf) $&v(isense) $&i(vdda)
alter Vs0 dc=1.2
alter Vh0 dc=1.2
alter Vs1 dc=0
alter Vh1 dc=0
alter Vs2 dc=1.2
alter Vh2 dc=1.2
alter Vs3 dc=0
alter Vh3 dc=0
alter Vs4 dc=1.2
alter Vh4 dc=1.2
alter Vs5 dc=1.2
alter Vh5 dc=1.2
alter Vs6 dc=0
alter Vh6 dc=0
alter Vs7 dc=1.2
alter Vh7 dc=1.2
op
echo ROW 1 125.0 181 $&v(xt.vth_soft) $&v(xt.vth_hard) $&v(vref_buf) $&v(isense) $&i(vdda)
alter Vs0 dc=0
alter Vh0 dc=0
alter Vs1 dc=1.2
alter Vh1 dc=1.2
alter Vs2 dc=1.2
alter Vh2 dc=1.2
alter Vs3 dc=0
alter Vh3 dc=0
alter Vs4 dc=1.2
alter Vh4 dc=1.2
alter Vs5 dc=1.2
alter Vh5 dc=1.2
alter Vs6 dc=0
alter Vh6 dc=0
alter Vs7 dc=1.2
alter Vh7 dc=1.2
op
echo ROW 1 125.0 182 $&v(xt.vth_soft) $&v(xt.vth_hard) $&v(vref_buf) $&v(isense) $&i(vdda)
alter Vs0 dc=1.2
alter Vh0 dc=1.2
alter Vs1 dc=1.2
alter Vh1 dc=1.2
alter Vs2 dc=1.2
alter Vh2 dc=1.2
alter Vs3 dc=0
alter Vh3 dc=0
alter Vs4 dc=1.2
alter Vh4 dc=1.2
alter Vs5 dc=1.2
alter Vh5 dc=1.2
alter Vs6 dc=0
alter Vh6 dc=0
alter Vs7 dc=1.2
alter Vh7 dc=1.2
op
echo ROW 1 125.0 183 $&v(xt.vth_soft) $&v(xt.vth_hard) $&v(vref_buf) $&v(isense) $&i(vdda)
alter Vs0 dc=0
alter Vh0 dc=0
alter Vs1 dc=0
alter Vh1 dc=0
alter Vs2 dc=0
alter Vh2 dc=0
alter Vs3 dc=1.2
alter Vh3 dc=1.2
alter Vs4 dc=1.2
alter Vh4 dc=1.2
alter Vs5 dc=1.2
alter Vh5 dc=1.2
alter Vs6 dc=0
alter Vh6 dc=0
alter Vs7 dc=1.2
alter Vh7 dc=1.2
op
echo ROW 1 125.0 184 $&v(xt.vth_soft) $&v(xt.vth_hard) $&v(vref_buf) $&v(isense) $&i(vdda)
alter Vs0 dc=1.2
alter Vh0 dc=1.2
alter Vs1 dc=0
alter Vh1 dc=0
alter Vs2 dc=0
alter Vh2 dc=0
alter Vs3 dc=1.2
alter Vh3 dc=1.2
alter Vs4 dc=1.2
alter Vh4 dc=1.2
alter Vs5 dc=1.2
alter Vh5 dc=1.2
alter Vs6 dc=0
alter Vh6 dc=0
alter Vs7 dc=1.2
alter Vh7 dc=1.2
op
echo ROW 1 125.0 185 $&v(xt.vth_soft) $&v(xt.vth_hard) $&v(vref_buf) $&v(isense) $&i(vdda)
alter Vs0 dc=0
alter Vh0 dc=0
alter Vs1 dc=1.2
alter Vh1 dc=1.2
alter Vs2 dc=0
alter Vh2 dc=0
alter Vs3 dc=1.2
alter Vh3 dc=1.2
alter Vs4 dc=1.2
alter Vh4 dc=1.2
alter Vs5 dc=1.2
alter Vh5 dc=1.2
alter Vs6 dc=0
alter Vh6 dc=0
alter Vs7 dc=1.2
alter Vh7 dc=1.2
op
echo ROW 1 125.0 186 $&v(xt.vth_soft) $&v(xt.vth_hard) $&v(vref_buf) $&v(isense) $&i(vdda)
alter Vs0 dc=1.2
alter Vh0 dc=1.2
alter Vs1 dc=1.2
alter Vh1 dc=1.2
alter Vs2 dc=0
alter Vh2 dc=0
alter Vs3 dc=1.2
alter Vh3 dc=1.2
alter Vs4 dc=1.2
alter Vh4 dc=1.2
alter Vs5 dc=1.2
alter Vh5 dc=1.2
alter Vs6 dc=0
alter Vh6 dc=0
alter Vs7 dc=1.2
alter Vh7 dc=1.2
op
echo ROW 1 125.0 187 $&v(xt.vth_soft) $&v(xt.vth_hard) $&v(vref_buf) $&v(isense) $&i(vdda)
alter Vs0 dc=0
alter Vh0 dc=0
alter Vs1 dc=0
alter Vh1 dc=0
alter Vs2 dc=1.2
alter Vh2 dc=1.2
alter Vs3 dc=1.2
alter Vh3 dc=1.2
alter Vs4 dc=1.2
alter Vh4 dc=1.2
alter Vs5 dc=1.2
alter Vh5 dc=1.2
alter Vs6 dc=0
alter Vh6 dc=0
alter Vs7 dc=1.2
alter Vh7 dc=1.2
op
echo ROW 1 125.0 188 $&v(xt.vth_soft) $&v(xt.vth_hard) $&v(vref_buf) $&v(isense) $&i(vdda)
alter Vs0 dc=1.2
alter Vh0 dc=1.2
alter Vs1 dc=0
alter Vh1 dc=0
alter Vs2 dc=1.2
alter Vh2 dc=1.2
alter Vs3 dc=1.2
alter Vh3 dc=1.2
alter Vs4 dc=1.2
alter Vh4 dc=1.2
alter Vs5 dc=1.2
alter Vh5 dc=1.2
alter Vs6 dc=0
alter Vh6 dc=0
alter Vs7 dc=1.2
alter Vh7 dc=1.2
op
echo ROW 1 125.0 189 $&v(xt.vth_soft) $&v(xt.vth_hard) $&v(vref_buf) $&v(isense) $&i(vdda)
alter Vs0 dc=0
alter Vh0 dc=0
alter Vs1 dc=1.2
alter Vh1 dc=1.2
alter Vs2 dc=1.2
alter Vh2 dc=1.2
alter Vs3 dc=1.2
alter Vh3 dc=1.2
alter Vs4 dc=1.2
alter Vh4 dc=1.2
alter Vs5 dc=1.2
alter Vh5 dc=1.2
alter Vs6 dc=0
alter Vh6 dc=0
alter Vs7 dc=1.2
alter Vh7 dc=1.2
op
echo ROW 1 125.0 190 $&v(xt.vth_soft) $&v(xt.vth_hard) $&v(vref_buf) $&v(isense) $&i(vdda)
alter Vs0 dc=1.2
alter Vh0 dc=1.2
alter Vs1 dc=1.2
alter Vh1 dc=1.2
alter Vs2 dc=1.2
alter Vh2 dc=1.2
alter Vs3 dc=1.2
alter Vh3 dc=1.2
alter Vs4 dc=1.2
alter Vh4 dc=1.2
alter Vs5 dc=1.2
alter Vh5 dc=1.2
alter Vs6 dc=0
alter Vh6 dc=0
alter Vs7 dc=1.2
alter Vh7 dc=1.2
op
echo ROW 1 125.0 191 $&v(xt.vth_soft) $&v(xt.vth_hard) $&v(vref_buf) $&v(isense) $&i(vdda)
alter Vs0 dc=0
alter Vh0 dc=0
alter Vs1 dc=0
alter Vh1 dc=0
alter Vs2 dc=0
alter Vh2 dc=0
alter Vs3 dc=0
alter Vh3 dc=0
alter Vs4 dc=0
alter Vh4 dc=0
alter Vs5 dc=0
alter Vh5 dc=0
alter Vs6 dc=1.2
alter Vh6 dc=1.2
alter Vs7 dc=1.2
alter Vh7 dc=1.2
op
echo ROW 1 125.0 192 $&v(xt.vth_soft) $&v(xt.vth_hard) $&v(vref_buf) $&v(isense) $&i(vdda)
alter Vs0 dc=1.2
alter Vh0 dc=1.2
alter Vs1 dc=0
alter Vh1 dc=0
alter Vs2 dc=0
alter Vh2 dc=0
alter Vs3 dc=0
alter Vh3 dc=0
alter Vs4 dc=0
alter Vh4 dc=0
alter Vs5 dc=0
alter Vh5 dc=0
alter Vs6 dc=1.2
alter Vh6 dc=1.2
alter Vs7 dc=1.2
alter Vh7 dc=1.2
op
echo ROW 1 125.0 193 $&v(xt.vth_soft) $&v(xt.vth_hard) $&v(vref_buf) $&v(isense) $&i(vdda)
alter Vs0 dc=0
alter Vh0 dc=0
alter Vs1 dc=1.2
alter Vh1 dc=1.2
alter Vs2 dc=0
alter Vh2 dc=0
alter Vs3 dc=0
alter Vh3 dc=0
alter Vs4 dc=0
alter Vh4 dc=0
alter Vs5 dc=0
alter Vh5 dc=0
alter Vs6 dc=1.2
alter Vh6 dc=1.2
alter Vs7 dc=1.2
alter Vh7 dc=1.2
op
echo ROW 1 125.0 194 $&v(xt.vth_soft) $&v(xt.vth_hard) $&v(vref_buf) $&v(isense) $&i(vdda)
alter Vs0 dc=1.2
alter Vh0 dc=1.2
alter Vs1 dc=1.2
alter Vh1 dc=1.2
alter Vs2 dc=0
alter Vh2 dc=0
alter Vs3 dc=0
alter Vh3 dc=0
alter Vs4 dc=0
alter Vh4 dc=0
alter Vs5 dc=0
alter Vh5 dc=0
alter Vs6 dc=1.2
alter Vh6 dc=1.2
alter Vs7 dc=1.2
alter Vh7 dc=1.2
op
echo ROW 1 125.0 195 $&v(xt.vth_soft) $&v(xt.vth_hard) $&v(vref_buf) $&v(isense) $&i(vdda)
alter Vs0 dc=0
alter Vh0 dc=0
alter Vs1 dc=0
alter Vh1 dc=0
alter Vs2 dc=1.2
alter Vh2 dc=1.2
alter Vs3 dc=0
alter Vh3 dc=0
alter Vs4 dc=0
alter Vh4 dc=0
alter Vs5 dc=0
alter Vh5 dc=0
alter Vs6 dc=1.2
alter Vh6 dc=1.2
alter Vs7 dc=1.2
alter Vh7 dc=1.2
op
echo ROW 1 125.0 196 $&v(xt.vth_soft) $&v(xt.vth_hard) $&v(vref_buf) $&v(isense) $&i(vdda)
alter Vs0 dc=1.2
alter Vh0 dc=1.2
alter Vs1 dc=0
alter Vh1 dc=0
alter Vs2 dc=1.2
alter Vh2 dc=1.2
alter Vs3 dc=0
alter Vh3 dc=0
alter Vs4 dc=0
alter Vh4 dc=0
alter Vs5 dc=0
alter Vh5 dc=0
alter Vs6 dc=1.2
alter Vh6 dc=1.2
alter Vs7 dc=1.2
alter Vh7 dc=1.2
op
echo ROW 1 125.0 197 $&v(xt.vth_soft) $&v(xt.vth_hard) $&v(vref_buf) $&v(isense) $&i(vdda)
alter Vs0 dc=0
alter Vh0 dc=0
alter Vs1 dc=1.2
alter Vh1 dc=1.2
alter Vs2 dc=1.2
alter Vh2 dc=1.2
alter Vs3 dc=0
alter Vh3 dc=0
alter Vs4 dc=0
alter Vh4 dc=0
alter Vs5 dc=0
alter Vh5 dc=0
alter Vs6 dc=1.2
alter Vh6 dc=1.2
alter Vs7 dc=1.2
alter Vh7 dc=1.2
op
echo ROW 1 125.0 198 $&v(xt.vth_soft) $&v(xt.vth_hard) $&v(vref_buf) $&v(isense) $&i(vdda)
alter Vs0 dc=1.2
alter Vh0 dc=1.2
alter Vs1 dc=1.2
alter Vh1 dc=1.2
alter Vs2 dc=1.2
alter Vh2 dc=1.2
alter Vs3 dc=0
alter Vh3 dc=0
alter Vs4 dc=0
alter Vh4 dc=0
alter Vs5 dc=0
alter Vh5 dc=0
alter Vs6 dc=1.2
alter Vh6 dc=1.2
alter Vs7 dc=1.2
alter Vh7 dc=1.2
op
echo ROW 1 125.0 199 $&v(xt.vth_soft) $&v(xt.vth_hard) $&v(vref_buf) $&v(isense) $&i(vdda)
alter Vs0 dc=0
alter Vh0 dc=0
alter Vs1 dc=0
alter Vh1 dc=0
alter Vs2 dc=0
alter Vh2 dc=0
alter Vs3 dc=1.2
alter Vh3 dc=1.2
alter Vs4 dc=0
alter Vh4 dc=0
alter Vs5 dc=0
alter Vh5 dc=0
alter Vs6 dc=1.2
alter Vh6 dc=1.2
alter Vs7 dc=1.2
alter Vh7 dc=1.2
op
echo ROW 1 125.0 200 $&v(xt.vth_soft) $&v(xt.vth_hard) $&v(vref_buf) $&v(isense) $&i(vdda)
alter Vs0 dc=1.2
alter Vh0 dc=1.2
alter Vs1 dc=0
alter Vh1 dc=0
alter Vs2 dc=0
alter Vh2 dc=0
alter Vs3 dc=1.2
alter Vh3 dc=1.2
alter Vs4 dc=0
alter Vh4 dc=0
alter Vs5 dc=0
alter Vh5 dc=0
alter Vs6 dc=1.2
alter Vh6 dc=1.2
alter Vs7 dc=1.2
alter Vh7 dc=1.2
op
echo ROW 1 125.0 201 $&v(xt.vth_soft) $&v(xt.vth_hard) $&v(vref_buf) $&v(isense) $&i(vdda)
alter Vs0 dc=0
alter Vh0 dc=0
alter Vs1 dc=1.2
alter Vh1 dc=1.2
alter Vs2 dc=0
alter Vh2 dc=0
alter Vs3 dc=1.2
alter Vh3 dc=1.2
alter Vs4 dc=0
alter Vh4 dc=0
alter Vs5 dc=0
alter Vh5 dc=0
alter Vs6 dc=1.2
alter Vh6 dc=1.2
alter Vs7 dc=1.2
alter Vh7 dc=1.2
op
echo ROW 1 125.0 202 $&v(xt.vth_soft) $&v(xt.vth_hard) $&v(vref_buf) $&v(isense) $&i(vdda)
alter Vs0 dc=1.2
alter Vh0 dc=1.2
alter Vs1 dc=1.2
alter Vh1 dc=1.2
alter Vs2 dc=0
alter Vh2 dc=0
alter Vs3 dc=1.2
alter Vh3 dc=1.2
alter Vs4 dc=0
alter Vh4 dc=0
alter Vs5 dc=0
alter Vh5 dc=0
alter Vs6 dc=1.2
alter Vh6 dc=1.2
alter Vs7 dc=1.2
alter Vh7 dc=1.2
op
echo ROW 1 125.0 203 $&v(xt.vth_soft) $&v(xt.vth_hard) $&v(vref_buf) $&v(isense) $&i(vdda)
alter Vs0 dc=0
alter Vh0 dc=0
alter Vs1 dc=0
alter Vh1 dc=0
alter Vs2 dc=1.2
alter Vh2 dc=1.2
alter Vs3 dc=1.2
alter Vh3 dc=1.2
alter Vs4 dc=0
alter Vh4 dc=0
alter Vs5 dc=0
alter Vh5 dc=0
alter Vs6 dc=1.2
alter Vh6 dc=1.2
alter Vs7 dc=1.2
alter Vh7 dc=1.2
op
echo ROW 1 125.0 204 $&v(xt.vth_soft) $&v(xt.vth_hard) $&v(vref_buf) $&v(isense) $&i(vdda)
alter Vs0 dc=1.2
alter Vh0 dc=1.2
alter Vs1 dc=0
alter Vh1 dc=0
alter Vs2 dc=1.2
alter Vh2 dc=1.2
alter Vs3 dc=1.2
alter Vh3 dc=1.2
alter Vs4 dc=0
alter Vh4 dc=0
alter Vs5 dc=0
alter Vh5 dc=0
alter Vs6 dc=1.2
alter Vh6 dc=1.2
alter Vs7 dc=1.2
alter Vh7 dc=1.2
op
echo ROW 1 125.0 205 $&v(xt.vth_soft) $&v(xt.vth_hard) $&v(vref_buf) $&v(isense) $&i(vdda)
alter Vs0 dc=0
alter Vh0 dc=0
alter Vs1 dc=1.2
alter Vh1 dc=1.2
alter Vs2 dc=1.2
alter Vh2 dc=1.2
alter Vs3 dc=1.2
alter Vh3 dc=1.2
alter Vs4 dc=0
alter Vh4 dc=0
alter Vs5 dc=0
alter Vh5 dc=0
alter Vs6 dc=1.2
alter Vh6 dc=1.2
alter Vs7 dc=1.2
alter Vh7 dc=1.2
op
echo ROW 1 125.0 206 $&v(xt.vth_soft) $&v(xt.vth_hard) $&v(vref_buf) $&v(isense) $&i(vdda)
alter Vs0 dc=1.2
alter Vh0 dc=1.2
alter Vs1 dc=1.2
alter Vh1 dc=1.2
alter Vs2 dc=1.2
alter Vh2 dc=1.2
alter Vs3 dc=1.2
alter Vh3 dc=1.2
alter Vs4 dc=0
alter Vh4 dc=0
alter Vs5 dc=0
alter Vh5 dc=0
alter Vs6 dc=1.2
alter Vh6 dc=1.2
alter Vs7 dc=1.2
alter Vh7 dc=1.2
op
echo ROW 1 125.0 207 $&v(xt.vth_soft) $&v(xt.vth_hard) $&v(vref_buf) $&v(isense) $&i(vdda)
alter Vs0 dc=0
alter Vh0 dc=0
alter Vs1 dc=0
alter Vh1 dc=0
alter Vs2 dc=0
alter Vh2 dc=0
alter Vs3 dc=0
alter Vh3 dc=0
alter Vs4 dc=1.2
alter Vh4 dc=1.2
alter Vs5 dc=0
alter Vh5 dc=0
alter Vs6 dc=1.2
alter Vh6 dc=1.2
alter Vs7 dc=1.2
alter Vh7 dc=1.2
op
echo ROW 1 125.0 208 $&v(xt.vth_soft) $&v(xt.vth_hard) $&v(vref_buf) $&v(isense) $&i(vdda)
alter Vs0 dc=1.2
alter Vh0 dc=1.2
alter Vs1 dc=0
alter Vh1 dc=0
alter Vs2 dc=0
alter Vh2 dc=0
alter Vs3 dc=0
alter Vh3 dc=0
alter Vs4 dc=1.2
alter Vh4 dc=1.2
alter Vs5 dc=0
alter Vh5 dc=0
alter Vs6 dc=1.2
alter Vh6 dc=1.2
alter Vs7 dc=1.2
alter Vh7 dc=1.2
op
echo ROW 1 125.0 209 $&v(xt.vth_soft) $&v(xt.vth_hard) $&v(vref_buf) $&v(isense) $&i(vdda)
alter Vs0 dc=0
alter Vh0 dc=0
alter Vs1 dc=1.2
alter Vh1 dc=1.2
alter Vs2 dc=0
alter Vh2 dc=0
alter Vs3 dc=0
alter Vh3 dc=0
alter Vs4 dc=1.2
alter Vh4 dc=1.2
alter Vs5 dc=0
alter Vh5 dc=0
alter Vs6 dc=1.2
alter Vh6 dc=1.2
alter Vs7 dc=1.2
alter Vh7 dc=1.2
op
echo ROW 1 125.0 210 $&v(xt.vth_soft) $&v(xt.vth_hard) $&v(vref_buf) $&v(isense) $&i(vdda)
alter Vs0 dc=1.2
alter Vh0 dc=1.2
alter Vs1 dc=1.2
alter Vh1 dc=1.2
alter Vs2 dc=0
alter Vh2 dc=0
alter Vs3 dc=0
alter Vh3 dc=0
alter Vs4 dc=1.2
alter Vh4 dc=1.2
alter Vs5 dc=0
alter Vh5 dc=0
alter Vs6 dc=1.2
alter Vh6 dc=1.2
alter Vs7 dc=1.2
alter Vh7 dc=1.2
op
echo ROW 1 125.0 211 $&v(xt.vth_soft) $&v(xt.vth_hard) $&v(vref_buf) $&v(isense) $&i(vdda)
alter Vs0 dc=0
alter Vh0 dc=0
alter Vs1 dc=0
alter Vh1 dc=0
alter Vs2 dc=1.2
alter Vh2 dc=1.2
alter Vs3 dc=0
alter Vh3 dc=0
alter Vs4 dc=1.2
alter Vh4 dc=1.2
alter Vs5 dc=0
alter Vh5 dc=0
alter Vs6 dc=1.2
alter Vh6 dc=1.2
alter Vs7 dc=1.2
alter Vh7 dc=1.2
op
echo ROW 1 125.0 212 $&v(xt.vth_soft) $&v(xt.vth_hard) $&v(vref_buf) $&v(isense) $&i(vdda)
alter Vs0 dc=1.2
alter Vh0 dc=1.2
alter Vs1 dc=0
alter Vh1 dc=0
alter Vs2 dc=1.2
alter Vh2 dc=1.2
alter Vs3 dc=0
alter Vh3 dc=0
alter Vs4 dc=1.2
alter Vh4 dc=1.2
alter Vs5 dc=0
alter Vh5 dc=0
alter Vs6 dc=1.2
alter Vh6 dc=1.2
alter Vs7 dc=1.2
alter Vh7 dc=1.2
op
echo ROW 1 125.0 213 $&v(xt.vth_soft) $&v(xt.vth_hard) $&v(vref_buf) $&v(isense) $&i(vdda)
alter Vs0 dc=0
alter Vh0 dc=0
alter Vs1 dc=1.2
alter Vh1 dc=1.2
alter Vs2 dc=1.2
alter Vh2 dc=1.2
alter Vs3 dc=0
alter Vh3 dc=0
alter Vs4 dc=1.2
alter Vh4 dc=1.2
alter Vs5 dc=0
alter Vh5 dc=0
alter Vs6 dc=1.2
alter Vh6 dc=1.2
alter Vs7 dc=1.2
alter Vh7 dc=1.2
op
echo ROW 1 125.0 214 $&v(xt.vth_soft) $&v(xt.vth_hard) $&v(vref_buf) $&v(isense) $&i(vdda)
alter Vs0 dc=1.2
alter Vh0 dc=1.2
alter Vs1 dc=1.2
alter Vh1 dc=1.2
alter Vs2 dc=1.2
alter Vh2 dc=1.2
alter Vs3 dc=0
alter Vh3 dc=0
alter Vs4 dc=1.2
alter Vh4 dc=1.2
alter Vs5 dc=0
alter Vh5 dc=0
alter Vs6 dc=1.2
alter Vh6 dc=1.2
alter Vs7 dc=1.2
alter Vh7 dc=1.2
op
echo ROW 1 125.0 215 $&v(xt.vth_soft) $&v(xt.vth_hard) $&v(vref_buf) $&v(isense) $&i(vdda)
alter Vs0 dc=0
alter Vh0 dc=0
alter Vs1 dc=0
alter Vh1 dc=0
alter Vs2 dc=0
alter Vh2 dc=0
alter Vs3 dc=1.2
alter Vh3 dc=1.2
alter Vs4 dc=1.2
alter Vh4 dc=1.2
alter Vs5 dc=0
alter Vh5 dc=0
alter Vs6 dc=1.2
alter Vh6 dc=1.2
alter Vs7 dc=1.2
alter Vh7 dc=1.2
op
echo ROW 1 125.0 216 $&v(xt.vth_soft) $&v(xt.vth_hard) $&v(vref_buf) $&v(isense) $&i(vdda)
alter Vs0 dc=1.2
alter Vh0 dc=1.2
alter Vs1 dc=0
alter Vh1 dc=0
alter Vs2 dc=0
alter Vh2 dc=0
alter Vs3 dc=1.2
alter Vh3 dc=1.2
alter Vs4 dc=1.2
alter Vh4 dc=1.2
alter Vs5 dc=0
alter Vh5 dc=0
alter Vs6 dc=1.2
alter Vh6 dc=1.2
alter Vs7 dc=1.2
alter Vh7 dc=1.2
op
echo ROW 1 125.0 217 $&v(xt.vth_soft) $&v(xt.vth_hard) $&v(vref_buf) $&v(isense) $&i(vdda)
alter Vs0 dc=0
alter Vh0 dc=0
alter Vs1 dc=1.2
alter Vh1 dc=1.2
alter Vs2 dc=0
alter Vh2 dc=0
alter Vs3 dc=1.2
alter Vh3 dc=1.2
alter Vs4 dc=1.2
alter Vh4 dc=1.2
alter Vs5 dc=0
alter Vh5 dc=0
alter Vs6 dc=1.2
alter Vh6 dc=1.2
alter Vs7 dc=1.2
alter Vh7 dc=1.2
op
echo ROW 1 125.0 218 $&v(xt.vth_soft) $&v(xt.vth_hard) $&v(vref_buf) $&v(isense) $&i(vdda)
alter Vs0 dc=1.2
alter Vh0 dc=1.2
alter Vs1 dc=1.2
alter Vh1 dc=1.2
alter Vs2 dc=0
alter Vh2 dc=0
alter Vs3 dc=1.2
alter Vh3 dc=1.2
alter Vs4 dc=1.2
alter Vh4 dc=1.2
alter Vs5 dc=0
alter Vh5 dc=0
alter Vs6 dc=1.2
alter Vh6 dc=1.2
alter Vs7 dc=1.2
alter Vh7 dc=1.2
op
echo ROW 1 125.0 219 $&v(xt.vth_soft) $&v(xt.vth_hard) $&v(vref_buf) $&v(isense) $&i(vdda)
alter Vs0 dc=0
alter Vh0 dc=0
alter Vs1 dc=0
alter Vh1 dc=0
alter Vs2 dc=1.2
alter Vh2 dc=1.2
alter Vs3 dc=1.2
alter Vh3 dc=1.2
alter Vs4 dc=1.2
alter Vh4 dc=1.2
alter Vs5 dc=0
alter Vh5 dc=0
alter Vs6 dc=1.2
alter Vh6 dc=1.2
alter Vs7 dc=1.2
alter Vh7 dc=1.2
op
echo ROW 1 125.0 220 $&v(xt.vth_soft) $&v(xt.vth_hard) $&v(vref_buf) $&v(isense) $&i(vdda)
alter Vs0 dc=1.2
alter Vh0 dc=1.2
alter Vs1 dc=0
alter Vh1 dc=0
alter Vs2 dc=1.2
alter Vh2 dc=1.2
alter Vs3 dc=1.2
alter Vh3 dc=1.2
alter Vs4 dc=1.2
alter Vh4 dc=1.2
alter Vs5 dc=0
alter Vh5 dc=0
alter Vs6 dc=1.2
alter Vh6 dc=1.2
alter Vs7 dc=1.2
alter Vh7 dc=1.2
op
echo ROW 1 125.0 221 $&v(xt.vth_soft) $&v(xt.vth_hard) $&v(vref_buf) $&v(isense) $&i(vdda)
alter Vs0 dc=0
alter Vh0 dc=0
alter Vs1 dc=1.2
alter Vh1 dc=1.2
alter Vs2 dc=1.2
alter Vh2 dc=1.2
alter Vs3 dc=1.2
alter Vh3 dc=1.2
alter Vs4 dc=1.2
alter Vh4 dc=1.2
alter Vs5 dc=0
alter Vh5 dc=0
alter Vs6 dc=1.2
alter Vh6 dc=1.2
alter Vs7 dc=1.2
alter Vh7 dc=1.2
op
echo ROW 1 125.0 222 $&v(xt.vth_soft) $&v(xt.vth_hard) $&v(vref_buf) $&v(isense) $&i(vdda)
alter Vs0 dc=1.2
alter Vh0 dc=1.2
alter Vs1 dc=1.2
alter Vh1 dc=1.2
alter Vs2 dc=1.2
alter Vh2 dc=1.2
alter Vs3 dc=1.2
alter Vh3 dc=1.2
alter Vs4 dc=1.2
alter Vh4 dc=1.2
alter Vs5 dc=0
alter Vh5 dc=0
alter Vs6 dc=1.2
alter Vh6 dc=1.2
alter Vs7 dc=1.2
alter Vh7 dc=1.2
op
echo ROW 1 125.0 223 $&v(xt.vth_soft) $&v(xt.vth_hard) $&v(vref_buf) $&v(isense) $&i(vdda)
alter Vs0 dc=0
alter Vh0 dc=0
alter Vs1 dc=0
alter Vh1 dc=0
alter Vs2 dc=0
alter Vh2 dc=0
alter Vs3 dc=0
alter Vh3 dc=0
alter Vs4 dc=0
alter Vh4 dc=0
alter Vs5 dc=1.2
alter Vh5 dc=1.2
alter Vs6 dc=1.2
alter Vh6 dc=1.2
alter Vs7 dc=1.2
alter Vh7 dc=1.2
op
echo ROW 1 125.0 224 $&v(xt.vth_soft) $&v(xt.vth_hard) $&v(vref_buf) $&v(isense) $&i(vdda)
alter Vs0 dc=1.2
alter Vh0 dc=1.2
alter Vs1 dc=0
alter Vh1 dc=0
alter Vs2 dc=0
alter Vh2 dc=0
alter Vs3 dc=0
alter Vh3 dc=0
alter Vs4 dc=0
alter Vh4 dc=0
alter Vs5 dc=1.2
alter Vh5 dc=1.2
alter Vs6 dc=1.2
alter Vh6 dc=1.2
alter Vs7 dc=1.2
alter Vh7 dc=1.2
op
echo ROW 1 125.0 225 $&v(xt.vth_soft) $&v(xt.vth_hard) $&v(vref_buf) $&v(isense) $&i(vdda)
alter Vs0 dc=0
alter Vh0 dc=0
alter Vs1 dc=1.2
alter Vh1 dc=1.2
alter Vs2 dc=0
alter Vh2 dc=0
alter Vs3 dc=0
alter Vh3 dc=0
alter Vs4 dc=0
alter Vh4 dc=0
alter Vs5 dc=1.2
alter Vh5 dc=1.2
alter Vs6 dc=1.2
alter Vh6 dc=1.2
alter Vs7 dc=1.2
alter Vh7 dc=1.2
op
echo ROW 1 125.0 226 $&v(xt.vth_soft) $&v(xt.vth_hard) $&v(vref_buf) $&v(isense) $&i(vdda)
alter Vs0 dc=1.2
alter Vh0 dc=1.2
alter Vs1 dc=1.2
alter Vh1 dc=1.2
alter Vs2 dc=0
alter Vh2 dc=0
alter Vs3 dc=0
alter Vh3 dc=0
alter Vs4 dc=0
alter Vh4 dc=0
alter Vs5 dc=1.2
alter Vh5 dc=1.2
alter Vs6 dc=1.2
alter Vh6 dc=1.2
alter Vs7 dc=1.2
alter Vh7 dc=1.2
op
echo ROW 1 125.0 227 $&v(xt.vth_soft) $&v(xt.vth_hard) $&v(vref_buf) $&v(isense) $&i(vdda)
alter Vs0 dc=0
alter Vh0 dc=0
alter Vs1 dc=0
alter Vh1 dc=0
alter Vs2 dc=1.2
alter Vh2 dc=1.2
alter Vs3 dc=0
alter Vh3 dc=0
alter Vs4 dc=0
alter Vh4 dc=0
alter Vs5 dc=1.2
alter Vh5 dc=1.2
alter Vs6 dc=1.2
alter Vh6 dc=1.2
alter Vs7 dc=1.2
alter Vh7 dc=1.2
op
echo ROW 1 125.0 228 $&v(xt.vth_soft) $&v(xt.vth_hard) $&v(vref_buf) $&v(isense) $&i(vdda)
alter Vs0 dc=1.2
alter Vh0 dc=1.2
alter Vs1 dc=0
alter Vh1 dc=0
alter Vs2 dc=1.2
alter Vh2 dc=1.2
alter Vs3 dc=0
alter Vh3 dc=0
alter Vs4 dc=0
alter Vh4 dc=0
alter Vs5 dc=1.2
alter Vh5 dc=1.2
alter Vs6 dc=1.2
alter Vh6 dc=1.2
alter Vs7 dc=1.2
alter Vh7 dc=1.2
op
echo ROW 1 125.0 229 $&v(xt.vth_soft) $&v(xt.vth_hard) $&v(vref_buf) $&v(isense) $&i(vdda)
alter Vs0 dc=0
alter Vh0 dc=0
alter Vs1 dc=1.2
alter Vh1 dc=1.2
alter Vs2 dc=1.2
alter Vh2 dc=1.2
alter Vs3 dc=0
alter Vh3 dc=0
alter Vs4 dc=0
alter Vh4 dc=0
alter Vs5 dc=1.2
alter Vh5 dc=1.2
alter Vs6 dc=1.2
alter Vh6 dc=1.2
alter Vs7 dc=1.2
alter Vh7 dc=1.2
op
echo ROW 1 125.0 230 $&v(xt.vth_soft) $&v(xt.vth_hard) $&v(vref_buf) $&v(isense) $&i(vdda)
alter Vs0 dc=1.2
alter Vh0 dc=1.2
alter Vs1 dc=1.2
alter Vh1 dc=1.2
alter Vs2 dc=1.2
alter Vh2 dc=1.2
alter Vs3 dc=0
alter Vh3 dc=0
alter Vs4 dc=0
alter Vh4 dc=0
alter Vs5 dc=1.2
alter Vh5 dc=1.2
alter Vs6 dc=1.2
alter Vh6 dc=1.2
alter Vs7 dc=1.2
alter Vh7 dc=1.2
op
echo ROW 1 125.0 231 $&v(xt.vth_soft) $&v(xt.vth_hard) $&v(vref_buf) $&v(isense) $&i(vdda)
alter Vs0 dc=0
alter Vh0 dc=0
alter Vs1 dc=0
alter Vh1 dc=0
alter Vs2 dc=0
alter Vh2 dc=0
alter Vs3 dc=1.2
alter Vh3 dc=1.2
alter Vs4 dc=0
alter Vh4 dc=0
alter Vs5 dc=1.2
alter Vh5 dc=1.2
alter Vs6 dc=1.2
alter Vh6 dc=1.2
alter Vs7 dc=1.2
alter Vh7 dc=1.2
op
echo ROW 1 125.0 232 $&v(xt.vth_soft) $&v(xt.vth_hard) $&v(vref_buf) $&v(isense) $&i(vdda)
alter Vs0 dc=1.2
alter Vh0 dc=1.2
alter Vs1 dc=0
alter Vh1 dc=0
alter Vs2 dc=0
alter Vh2 dc=0
alter Vs3 dc=1.2
alter Vh3 dc=1.2
alter Vs4 dc=0
alter Vh4 dc=0
alter Vs5 dc=1.2
alter Vh5 dc=1.2
alter Vs6 dc=1.2
alter Vh6 dc=1.2
alter Vs7 dc=1.2
alter Vh7 dc=1.2
op
echo ROW 1 125.0 233 $&v(xt.vth_soft) $&v(xt.vth_hard) $&v(vref_buf) $&v(isense) $&i(vdda)
alter Vs0 dc=0
alter Vh0 dc=0
alter Vs1 dc=1.2
alter Vh1 dc=1.2
alter Vs2 dc=0
alter Vh2 dc=0
alter Vs3 dc=1.2
alter Vh3 dc=1.2
alter Vs4 dc=0
alter Vh4 dc=0
alter Vs5 dc=1.2
alter Vh5 dc=1.2
alter Vs6 dc=1.2
alter Vh6 dc=1.2
alter Vs7 dc=1.2
alter Vh7 dc=1.2
op
echo ROW 1 125.0 234 $&v(xt.vth_soft) $&v(xt.vth_hard) $&v(vref_buf) $&v(isense) $&i(vdda)
alter Vs0 dc=1.2
alter Vh0 dc=1.2
alter Vs1 dc=1.2
alter Vh1 dc=1.2
alter Vs2 dc=0
alter Vh2 dc=0
alter Vs3 dc=1.2
alter Vh3 dc=1.2
alter Vs4 dc=0
alter Vh4 dc=0
alter Vs5 dc=1.2
alter Vh5 dc=1.2
alter Vs6 dc=1.2
alter Vh6 dc=1.2
alter Vs7 dc=1.2
alter Vh7 dc=1.2
op
echo ROW 1 125.0 235 $&v(xt.vth_soft) $&v(xt.vth_hard) $&v(vref_buf) $&v(isense) $&i(vdda)
alter Vs0 dc=0
alter Vh0 dc=0
alter Vs1 dc=0
alter Vh1 dc=0
alter Vs2 dc=1.2
alter Vh2 dc=1.2
alter Vs3 dc=1.2
alter Vh3 dc=1.2
alter Vs4 dc=0
alter Vh4 dc=0
alter Vs5 dc=1.2
alter Vh5 dc=1.2
alter Vs6 dc=1.2
alter Vh6 dc=1.2
alter Vs7 dc=1.2
alter Vh7 dc=1.2
op
echo ROW 1 125.0 236 $&v(xt.vth_soft) $&v(xt.vth_hard) $&v(vref_buf) $&v(isense) $&i(vdda)
alter Vs0 dc=1.2
alter Vh0 dc=1.2
alter Vs1 dc=0
alter Vh1 dc=0
alter Vs2 dc=1.2
alter Vh2 dc=1.2
alter Vs3 dc=1.2
alter Vh3 dc=1.2
alter Vs4 dc=0
alter Vh4 dc=0
alter Vs5 dc=1.2
alter Vh5 dc=1.2
alter Vs6 dc=1.2
alter Vh6 dc=1.2
alter Vs7 dc=1.2
alter Vh7 dc=1.2
op
echo ROW 1 125.0 237 $&v(xt.vth_soft) $&v(xt.vth_hard) $&v(vref_buf) $&v(isense) $&i(vdda)
alter Vs0 dc=0
alter Vh0 dc=0
alter Vs1 dc=1.2
alter Vh1 dc=1.2
alter Vs2 dc=1.2
alter Vh2 dc=1.2
alter Vs3 dc=1.2
alter Vh3 dc=1.2
alter Vs4 dc=0
alter Vh4 dc=0
alter Vs5 dc=1.2
alter Vh5 dc=1.2
alter Vs6 dc=1.2
alter Vh6 dc=1.2
alter Vs7 dc=1.2
alter Vh7 dc=1.2
op
echo ROW 1 125.0 238 $&v(xt.vth_soft) $&v(xt.vth_hard) $&v(vref_buf) $&v(isense) $&i(vdda)
alter Vs0 dc=1.2
alter Vh0 dc=1.2
alter Vs1 dc=1.2
alter Vh1 dc=1.2
alter Vs2 dc=1.2
alter Vh2 dc=1.2
alter Vs3 dc=1.2
alter Vh3 dc=1.2
alter Vs4 dc=0
alter Vh4 dc=0
alter Vs5 dc=1.2
alter Vh5 dc=1.2
alter Vs6 dc=1.2
alter Vh6 dc=1.2
alter Vs7 dc=1.2
alter Vh7 dc=1.2
op
echo ROW 1 125.0 239 $&v(xt.vth_soft) $&v(xt.vth_hard) $&v(vref_buf) $&v(isense) $&i(vdda)
alter Vs0 dc=0
alter Vh0 dc=0
alter Vs1 dc=0
alter Vh1 dc=0
alter Vs2 dc=0
alter Vh2 dc=0
alter Vs3 dc=0
alter Vh3 dc=0
alter Vs4 dc=1.2
alter Vh4 dc=1.2
alter Vs5 dc=1.2
alter Vh5 dc=1.2
alter Vs6 dc=1.2
alter Vh6 dc=1.2
alter Vs7 dc=1.2
alter Vh7 dc=1.2
op
echo ROW 1 125.0 240 $&v(xt.vth_soft) $&v(xt.vth_hard) $&v(vref_buf) $&v(isense) $&i(vdda)
alter Vs0 dc=1.2
alter Vh0 dc=1.2
alter Vs1 dc=0
alter Vh1 dc=0
alter Vs2 dc=0
alter Vh2 dc=0
alter Vs3 dc=0
alter Vh3 dc=0
alter Vs4 dc=1.2
alter Vh4 dc=1.2
alter Vs5 dc=1.2
alter Vh5 dc=1.2
alter Vs6 dc=1.2
alter Vh6 dc=1.2
alter Vs7 dc=1.2
alter Vh7 dc=1.2
op
echo ROW 1 125.0 241 $&v(xt.vth_soft) $&v(xt.vth_hard) $&v(vref_buf) $&v(isense) $&i(vdda)
alter Vs0 dc=0
alter Vh0 dc=0
alter Vs1 dc=1.2
alter Vh1 dc=1.2
alter Vs2 dc=0
alter Vh2 dc=0
alter Vs3 dc=0
alter Vh3 dc=0
alter Vs4 dc=1.2
alter Vh4 dc=1.2
alter Vs5 dc=1.2
alter Vh5 dc=1.2
alter Vs6 dc=1.2
alter Vh6 dc=1.2
alter Vs7 dc=1.2
alter Vh7 dc=1.2
op
echo ROW 1 125.0 242 $&v(xt.vth_soft) $&v(xt.vth_hard) $&v(vref_buf) $&v(isense) $&i(vdda)
alter Vs0 dc=1.2
alter Vh0 dc=1.2
alter Vs1 dc=1.2
alter Vh1 dc=1.2
alter Vs2 dc=0
alter Vh2 dc=0
alter Vs3 dc=0
alter Vh3 dc=0
alter Vs4 dc=1.2
alter Vh4 dc=1.2
alter Vs5 dc=1.2
alter Vh5 dc=1.2
alter Vs6 dc=1.2
alter Vh6 dc=1.2
alter Vs7 dc=1.2
alter Vh7 dc=1.2
op
echo ROW 1 125.0 243 $&v(xt.vth_soft) $&v(xt.vth_hard) $&v(vref_buf) $&v(isense) $&i(vdda)
alter Vs0 dc=0
alter Vh0 dc=0
alter Vs1 dc=0
alter Vh1 dc=0
alter Vs2 dc=1.2
alter Vh2 dc=1.2
alter Vs3 dc=0
alter Vh3 dc=0
alter Vs4 dc=1.2
alter Vh4 dc=1.2
alter Vs5 dc=1.2
alter Vh5 dc=1.2
alter Vs6 dc=1.2
alter Vh6 dc=1.2
alter Vs7 dc=1.2
alter Vh7 dc=1.2
op
echo ROW 1 125.0 244 $&v(xt.vth_soft) $&v(xt.vth_hard) $&v(vref_buf) $&v(isense) $&i(vdda)
alter Vs0 dc=1.2
alter Vh0 dc=1.2
alter Vs1 dc=0
alter Vh1 dc=0
alter Vs2 dc=1.2
alter Vh2 dc=1.2
alter Vs3 dc=0
alter Vh3 dc=0
alter Vs4 dc=1.2
alter Vh4 dc=1.2
alter Vs5 dc=1.2
alter Vh5 dc=1.2
alter Vs6 dc=1.2
alter Vh6 dc=1.2
alter Vs7 dc=1.2
alter Vh7 dc=1.2
op
echo ROW 1 125.0 245 $&v(xt.vth_soft) $&v(xt.vth_hard) $&v(vref_buf) $&v(isense) $&i(vdda)
alter Vs0 dc=0
alter Vh0 dc=0
alter Vs1 dc=1.2
alter Vh1 dc=1.2
alter Vs2 dc=1.2
alter Vh2 dc=1.2
alter Vs3 dc=0
alter Vh3 dc=0
alter Vs4 dc=1.2
alter Vh4 dc=1.2
alter Vs5 dc=1.2
alter Vh5 dc=1.2
alter Vs6 dc=1.2
alter Vh6 dc=1.2
alter Vs7 dc=1.2
alter Vh7 dc=1.2
op
echo ROW 1 125.0 246 $&v(xt.vth_soft) $&v(xt.vth_hard) $&v(vref_buf) $&v(isense) $&i(vdda)
alter Vs0 dc=1.2
alter Vh0 dc=1.2
alter Vs1 dc=1.2
alter Vh1 dc=1.2
alter Vs2 dc=1.2
alter Vh2 dc=1.2
alter Vs3 dc=0
alter Vh3 dc=0
alter Vs4 dc=1.2
alter Vh4 dc=1.2
alter Vs5 dc=1.2
alter Vh5 dc=1.2
alter Vs6 dc=1.2
alter Vh6 dc=1.2
alter Vs7 dc=1.2
alter Vh7 dc=1.2
op
echo ROW 1 125.0 247 $&v(xt.vth_soft) $&v(xt.vth_hard) $&v(vref_buf) $&v(isense) $&i(vdda)
alter Vs0 dc=0
alter Vh0 dc=0
alter Vs1 dc=0
alter Vh1 dc=0
alter Vs2 dc=0
alter Vh2 dc=0
alter Vs3 dc=1.2
alter Vh3 dc=1.2
alter Vs4 dc=1.2
alter Vh4 dc=1.2
alter Vs5 dc=1.2
alter Vh5 dc=1.2
alter Vs6 dc=1.2
alter Vh6 dc=1.2
alter Vs7 dc=1.2
alter Vh7 dc=1.2
op
echo ROW 1 125.0 248 $&v(xt.vth_soft) $&v(xt.vth_hard) $&v(vref_buf) $&v(isense) $&i(vdda)
alter Vs0 dc=1.2
alter Vh0 dc=1.2
alter Vs1 dc=0
alter Vh1 dc=0
alter Vs2 dc=0
alter Vh2 dc=0
alter Vs3 dc=1.2
alter Vh3 dc=1.2
alter Vs4 dc=1.2
alter Vh4 dc=1.2
alter Vs5 dc=1.2
alter Vh5 dc=1.2
alter Vs6 dc=1.2
alter Vh6 dc=1.2
alter Vs7 dc=1.2
alter Vh7 dc=1.2
op
echo ROW 1 125.0 249 $&v(xt.vth_soft) $&v(xt.vth_hard) $&v(vref_buf) $&v(isense) $&i(vdda)
alter Vs0 dc=0
alter Vh0 dc=0
alter Vs1 dc=1.2
alter Vh1 dc=1.2
alter Vs2 dc=0
alter Vh2 dc=0
alter Vs3 dc=1.2
alter Vh3 dc=1.2
alter Vs4 dc=1.2
alter Vh4 dc=1.2
alter Vs5 dc=1.2
alter Vh5 dc=1.2
alter Vs6 dc=1.2
alter Vh6 dc=1.2
alter Vs7 dc=1.2
alter Vh7 dc=1.2
op
echo ROW 1 125.0 250 $&v(xt.vth_soft) $&v(xt.vth_hard) $&v(vref_buf) $&v(isense) $&i(vdda)
alter Vs0 dc=1.2
alter Vh0 dc=1.2
alter Vs1 dc=1.2
alter Vh1 dc=1.2
alter Vs2 dc=0
alter Vh2 dc=0
alter Vs3 dc=1.2
alter Vh3 dc=1.2
alter Vs4 dc=1.2
alter Vh4 dc=1.2
alter Vs5 dc=1.2
alter Vh5 dc=1.2
alter Vs6 dc=1.2
alter Vh6 dc=1.2
alter Vs7 dc=1.2
alter Vh7 dc=1.2
op
echo ROW 1 125.0 251 $&v(xt.vth_soft) $&v(xt.vth_hard) $&v(vref_buf) $&v(isense) $&i(vdda)
alter Vs0 dc=0
alter Vh0 dc=0
alter Vs1 dc=0
alter Vh1 dc=0
alter Vs2 dc=1.2
alter Vh2 dc=1.2
alter Vs3 dc=1.2
alter Vh3 dc=1.2
alter Vs4 dc=1.2
alter Vh4 dc=1.2
alter Vs5 dc=1.2
alter Vh5 dc=1.2
alter Vs6 dc=1.2
alter Vh6 dc=1.2
alter Vs7 dc=1.2
alter Vh7 dc=1.2
op
echo ROW 1 125.0 252 $&v(xt.vth_soft) $&v(xt.vth_hard) $&v(vref_buf) $&v(isense) $&i(vdda)
alter Vs0 dc=1.2
alter Vh0 dc=1.2
alter Vs1 dc=0
alter Vh1 dc=0
alter Vs2 dc=1.2
alter Vh2 dc=1.2
alter Vs3 dc=1.2
alter Vh3 dc=1.2
alter Vs4 dc=1.2
alter Vh4 dc=1.2
alter Vs5 dc=1.2
alter Vh5 dc=1.2
alter Vs6 dc=1.2
alter Vh6 dc=1.2
alter Vs7 dc=1.2
alter Vh7 dc=1.2
op
echo ROW 1 125.0 253 $&v(xt.vth_soft) $&v(xt.vth_hard) $&v(vref_buf) $&v(isense) $&i(vdda)
alter Vs0 dc=0
alter Vh0 dc=0
alter Vs1 dc=1.2
alter Vh1 dc=1.2
alter Vs2 dc=1.2
alter Vh2 dc=1.2
alter Vs3 dc=1.2
alter Vh3 dc=1.2
alter Vs4 dc=1.2
alter Vh4 dc=1.2
alter Vs5 dc=1.2
alter Vh5 dc=1.2
alter Vs6 dc=1.2
alter Vh6 dc=1.2
alter Vs7 dc=1.2
alter Vh7 dc=1.2
op
echo ROW 1 125.0 254 $&v(xt.vth_soft) $&v(xt.vth_hard) $&v(vref_buf) $&v(isense) $&i(vdda)
alter Vs0 dc=1.2
alter Vh0 dc=1.2
alter Vs1 dc=1.2
alter Vh1 dc=1.2
alter Vs2 dc=1.2
alter Vh2 dc=1.2
alter Vs3 dc=1.2
alter Vh3 dc=1.2
alter Vs4 dc=1.2
alter Vh4 dc=1.2
alter Vs5 dc=1.2
alter Vh5 dc=1.2
alter Vs6 dc=1.2
alter Vh6 dc=1.2
alter Vs7 dc=1.2
alter Vh7 dc=1.2
op
echo ROW 1 125.0 255 $&v(xt.vth_soft) $&v(xt.vth_hard) $&v(vref_buf) $&v(isense) $&i(vdda)
echo FINGERPRINT 1
print @n.xt.xdacs.xms7_0a.nsg13_hv_nmos[w]
print @n.xt.xdacs.xms7_0a.nsg13_hv_nmos[l]
print @n.xt.xdacs.xms7_0a.nsg13_hv_nmos[delvto]
print @n.xt.xdacs.xms7_0a.nsg13_hv_nmos[factuo]
print @n.xt.xdach.xms7_0b.nsg13_hv_nmos[w]
print @n.xt.xdach.xms7_0b.nsg13_hv_nmos[l]
print @n.xt.xdach.xms7_0b.nsg13_hv_nmos[delvto]
print @n.xt.xdach.xms7_0b.nsg13_hv_nmos[factuo]
print @n.xt.xcs.xm1.nsg13_lv_nmos[w]
print @n.xt.xcs.xm1.nsg13_lv_nmos[l]
print @n.xt.xcs.xm1.nsg13_lv_nmos[delvto]
print @n.xt.xcs.xm1.nsg13_lv_nmos[factuo]
print @n.xt.xch.xm1.nsg13_lv_nmos[w]
print @n.xt.xch.xm1.nsg13_lv_nmos[l]
print @n.xt.xch.xm1.nsg13_lv_nmos[delvto]
print @n.xt.xch.xm1.nsg13_lv_nmos[factuo]
print @n.xs.xref.xm1.nsg13_hv_pmos[w]
print @n.xs.xref.xm1.nsg13_hv_pmos[l]
print @n.xs.xref.xm1.nsg13_hv_pmos[delvto]
print @n.xs.xref.xm1.nsg13_hv_pmos[factuo]
print @n.xt.xdacs.xru0.nr1[nsmm_rsh]
print @n.xt.xdacs.xru0.nr1[nsmm_w]
print @n.xt.xdacs.xru0.nr1[nsmm_l]
set temp=25.0
alter Iib dc=4.10248042645344e-06
alter Vs0 dc=0
alter Vh0 dc=0
alter Vs1 dc=0
alter Vh1 dc=0
alter Vs2 dc=0
alter Vh2 dc=0
alter Vs3 dc=0
alter Vh3 dc=0
alter Vs4 dc=0
alter Vh4 dc=0
alter Vs5 dc=0
alter Vh5 dc=0
alter Vs6 dc=0
alter Vh6 dc=0
alter Vs7 dc=0
alter Vh7 dc=0
op
echo ROW 2 25.0 0 $&v(xt.vth_soft) $&v(xt.vth_hard) $&v(vref_buf) $&v(isense) $&i(vdda)
alter Vs0 dc=1.2
alter Vh0 dc=1.2
alter Vs1 dc=0
alter Vh1 dc=0
alter Vs2 dc=0
alter Vh2 dc=0
alter Vs3 dc=0
alter Vh3 dc=0
alter Vs4 dc=0
alter Vh4 dc=0
alter Vs5 dc=0
alter Vh5 dc=0
alter Vs6 dc=0
alter Vh6 dc=0
alter Vs7 dc=0
alter Vh7 dc=0
op
echo ROW 2 25.0 1 $&v(xt.vth_soft) $&v(xt.vth_hard) $&v(vref_buf) $&v(isense) $&i(vdda)
alter Vs0 dc=0
alter Vh0 dc=0
alter Vs1 dc=1.2
alter Vh1 dc=1.2
alter Vs2 dc=0
alter Vh2 dc=0
alter Vs3 dc=0
alter Vh3 dc=0
alter Vs4 dc=0
alter Vh4 dc=0
alter Vs5 dc=0
alter Vh5 dc=0
alter Vs6 dc=0
alter Vh6 dc=0
alter Vs7 dc=0
alter Vh7 dc=0
op
echo ROW 2 25.0 2 $&v(xt.vth_soft) $&v(xt.vth_hard) $&v(vref_buf) $&v(isense) $&i(vdda)
alter Vs0 dc=1.2
alter Vh0 dc=1.2
alter Vs1 dc=1.2
alter Vh1 dc=1.2
alter Vs2 dc=0
alter Vh2 dc=0
alter Vs3 dc=0
alter Vh3 dc=0
alter Vs4 dc=0
alter Vh4 dc=0
alter Vs5 dc=0
alter Vh5 dc=0
alter Vs6 dc=0
alter Vh6 dc=0
alter Vs7 dc=0
alter Vh7 dc=0
op
echo ROW 2 25.0 3 $&v(xt.vth_soft) $&v(xt.vth_hard) $&v(vref_buf) $&v(isense) $&i(vdda)
alter Vs0 dc=0
alter Vh0 dc=0
alter Vs1 dc=0
alter Vh1 dc=0
alter Vs2 dc=1.2
alter Vh2 dc=1.2
alter Vs3 dc=0
alter Vh3 dc=0
alter Vs4 dc=0
alter Vh4 dc=0
alter Vs5 dc=0
alter Vh5 dc=0
alter Vs6 dc=0
alter Vh6 dc=0
alter Vs7 dc=0
alter Vh7 dc=0
op
echo ROW 2 25.0 4 $&v(xt.vth_soft) $&v(xt.vth_hard) $&v(vref_buf) $&v(isense) $&i(vdda)
alter Vs0 dc=1.2
alter Vh0 dc=1.2
alter Vs1 dc=0
alter Vh1 dc=0
alter Vs2 dc=1.2
alter Vh2 dc=1.2
alter Vs3 dc=0
alter Vh3 dc=0
alter Vs4 dc=0
alter Vh4 dc=0
alter Vs5 dc=0
alter Vh5 dc=0
alter Vs6 dc=0
alter Vh6 dc=0
alter Vs7 dc=0
alter Vh7 dc=0
op
echo ROW 2 25.0 5 $&v(xt.vth_soft) $&v(xt.vth_hard) $&v(vref_buf) $&v(isense) $&i(vdda)
alter Vs0 dc=0
alter Vh0 dc=0
alter Vs1 dc=1.2
alter Vh1 dc=1.2
alter Vs2 dc=1.2
alter Vh2 dc=1.2
alter Vs3 dc=0
alter Vh3 dc=0
alter Vs4 dc=0
alter Vh4 dc=0
alter Vs5 dc=0
alter Vh5 dc=0
alter Vs6 dc=0
alter Vh6 dc=0
alter Vs7 dc=0
alter Vh7 dc=0
op
echo ROW 2 25.0 6 $&v(xt.vth_soft) $&v(xt.vth_hard) $&v(vref_buf) $&v(isense) $&i(vdda)
alter Vs0 dc=1.2
alter Vh0 dc=1.2
alter Vs1 dc=1.2
alter Vh1 dc=1.2
alter Vs2 dc=1.2
alter Vh2 dc=1.2
alter Vs3 dc=0
alter Vh3 dc=0
alter Vs4 dc=0
alter Vh4 dc=0
alter Vs5 dc=0
alter Vh5 dc=0
alter Vs6 dc=0
alter Vh6 dc=0
alter Vs7 dc=0
alter Vh7 dc=0
op
echo ROW 2 25.0 7 $&v(xt.vth_soft) $&v(xt.vth_hard) $&v(vref_buf) $&v(isense) $&i(vdda)
alter Vs0 dc=0
alter Vh0 dc=0
alter Vs1 dc=0
alter Vh1 dc=0
alter Vs2 dc=0
alter Vh2 dc=0
alter Vs3 dc=1.2
alter Vh3 dc=1.2
alter Vs4 dc=0
alter Vh4 dc=0
alter Vs5 dc=0
alter Vh5 dc=0
alter Vs6 dc=0
alter Vh6 dc=0
alter Vs7 dc=0
alter Vh7 dc=0
op
echo ROW 2 25.0 8 $&v(xt.vth_soft) $&v(xt.vth_hard) $&v(vref_buf) $&v(isense) $&i(vdda)
alter Vs0 dc=1.2
alter Vh0 dc=1.2
alter Vs1 dc=0
alter Vh1 dc=0
alter Vs2 dc=0
alter Vh2 dc=0
alter Vs3 dc=1.2
alter Vh3 dc=1.2
alter Vs4 dc=0
alter Vh4 dc=0
alter Vs5 dc=0
alter Vh5 dc=0
alter Vs6 dc=0
alter Vh6 dc=0
alter Vs7 dc=0
alter Vh7 dc=0
op
echo ROW 2 25.0 9 $&v(xt.vth_soft) $&v(xt.vth_hard) $&v(vref_buf) $&v(isense) $&i(vdda)
alter Vs0 dc=0
alter Vh0 dc=0
alter Vs1 dc=1.2
alter Vh1 dc=1.2
alter Vs2 dc=0
alter Vh2 dc=0
alter Vs3 dc=1.2
alter Vh3 dc=1.2
alter Vs4 dc=0
alter Vh4 dc=0
alter Vs5 dc=0
alter Vh5 dc=0
alter Vs6 dc=0
alter Vh6 dc=0
alter Vs7 dc=0
alter Vh7 dc=0
op
echo ROW 2 25.0 10 $&v(xt.vth_soft) $&v(xt.vth_hard) $&v(vref_buf) $&v(isense) $&i(vdda)
alter Vs0 dc=1.2
alter Vh0 dc=1.2
alter Vs1 dc=1.2
alter Vh1 dc=1.2
alter Vs2 dc=0
alter Vh2 dc=0
alter Vs3 dc=1.2
alter Vh3 dc=1.2
alter Vs4 dc=0
alter Vh4 dc=0
alter Vs5 dc=0
alter Vh5 dc=0
alter Vs6 dc=0
alter Vh6 dc=0
alter Vs7 dc=0
alter Vh7 dc=0
op
echo ROW 2 25.0 11 $&v(xt.vth_soft) $&v(xt.vth_hard) $&v(vref_buf) $&v(isense) $&i(vdda)
alter Vs0 dc=0
alter Vh0 dc=0
alter Vs1 dc=0
alter Vh1 dc=0
alter Vs2 dc=1.2
alter Vh2 dc=1.2
alter Vs3 dc=1.2
alter Vh3 dc=1.2
alter Vs4 dc=0
alter Vh4 dc=0
alter Vs5 dc=0
alter Vh5 dc=0
alter Vs6 dc=0
alter Vh6 dc=0
alter Vs7 dc=0
alter Vh7 dc=0
op
echo ROW 2 25.0 12 $&v(xt.vth_soft) $&v(xt.vth_hard) $&v(vref_buf) $&v(isense) $&i(vdda)
alter Vs0 dc=1.2
alter Vh0 dc=1.2
alter Vs1 dc=0
alter Vh1 dc=0
alter Vs2 dc=1.2
alter Vh2 dc=1.2
alter Vs3 dc=1.2
alter Vh3 dc=1.2
alter Vs4 dc=0
alter Vh4 dc=0
alter Vs5 dc=0
alter Vh5 dc=0
alter Vs6 dc=0
alter Vh6 dc=0
alter Vs7 dc=0
alter Vh7 dc=0
op
echo ROW 2 25.0 13 $&v(xt.vth_soft) $&v(xt.vth_hard) $&v(vref_buf) $&v(isense) $&i(vdda)
alter Vs0 dc=0
alter Vh0 dc=0
alter Vs1 dc=1.2
alter Vh1 dc=1.2
alter Vs2 dc=1.2
alter Vh2 dc=1.2
alter Vs3 dc=1.2
alter Vh3 dc=1.2
alter Vs4 dc=0
alter Vh4 dc=0
alter Vs5 dc=0
alter Vh5 dc=0
alter Vs6 dc=0
alter Vh6 dc=0
alter Vs7 dc=0
alter Vh7 dc=0
op
echo ROW 2 25.0 14 $&v(xt.vth_soft) $&v(xt.vth_hard) $&v(vref_buf) $&v(isense) $&i(vdda)
alter Vs0 dc=1.2
alter Vh0 dc=1.2
alter Vs1 dc=1.2
alter Vh1 dc=1.2
alter Vs2 dc=1.2
alter Vh2 dc=1.2
alter Vs3 dc=1.2
alter Vh3 dc=1.2
alter Vs4 dc=0
alter Vh4 dc=0
alter Vs5 dc=0
alter Vh5 dc=0
alter Vs6 dc=0
alter Vh6 dc=0
alter Vs7 dc=0
alter Vh7 dc=0
op
echo ROW 2 25.0 15 $&v(xt.vth_soft) $&v(xt.vth_hard) $&v(vref_buf) $&v(isense) $&i(vdda)
alter Vs0 dc=0
alter Vh0 dc=0
alter Vs1 dc=0
alter Vh1 dc=0
alter Vs2 dc=0
alter Vh2 dc=0
alter Vs3 dc=0
alter Vh3 dc=0
alter Vs4 dc=1.2
alter Vh4 dc=1.2
alter Vs5 dc=0
alter Vh5 dc=0
alter Vs6 dc=0
alter Vh6 dc=0
alter Vs7 dc=0
alter Vh7 dc=0
op
echo ROW 2 25.0 16 $&v(xt.vth_soft) $&v(xt.vth_hard) $&v(vref_buf) $&v(isense) $&i(vdda)
alter Vs0 dc=1.2
alter Vh0 dc=1.2
alter Vs1 dc=0
alter Vh1 dc=0
alter Vs2 dc=0
alter Vh2 dc=0
alter Vs3 dc=0
alter Vh3 dc=0
alter Vs4 dc=1.2
alter Vh4 dc=1.2
alter Vs5 dc=0
alter Vh5 dc=0
alter Vs6 dc=0
alter Vh6 dc=0
alter Vs7 dc=0
alter Vh7 dc=0
op
echo ROW 2 25.0 17 $&v(xt.vth_soft) $&v(xt.vth_hard) $&v(vref_buf) $&v(isense) $&i(vdda)
alter Vs0 dc=0
alter Vh0 dc=0
alter Vs1 dc=1.2
alter Vh1 dc=1.2
alter Vs2 dc=0
alter Vh2 dc=0
alter Vs3 dc=0
alter Vh3 dc=0
alter Vs4 dc=1.2
alter Vh4 dc=1.2
alter Vs5 dc=0
alter Vh5 dc=0
alter Vs6 dc=0
alter Vh6 dc=0
alter Vs7 dc=0
alter Vh7 dc=0
op
echo ROW 2 25.0 18 $&v(xt.vth_soft) $&v(xt.vth_hard) $&v(vref_buf) $&v(isense) $&i(vdda)
alter Vs0 dc=1.2
alter Vh0 dc=1.2
alter Vs1 dc=1.2
alter Vh1 dc=1.2
alter Vs2 dc=0
alter Vh2 dc=0
alter Vs3 dc=0
alter Vh3 dc=0
alter Vs4 dc=1.2
alter Vh4 dc=1.2
alter Vs5 dc=0
alter Vh5 dc=0
alter Vs6 dc=0
alter Vh6 dc=0
alter Vs7 dc=0
alter Vh7 dc=0
op
echo ROW 2 25.0 19 $&v(xt.vth_soft) $&v(xt.vth_hard) $&v(vref_buf) $&v(isense) $&i(vdda)
alter Vs0 dc=0
alter Vh0 dc=0
alter Vs1 dc=0
alter Vh1 dc=0
alter Vs2 dc=1.2
alter Vh2 dc=1.2
alter Vs3 dc=0
alter Vh3 dc=0
alter Vs4 dc=1.2
alter Vh4 dc=1.2
alter Vs5 dc=0
alter Vh5 dc=0
alter Vs6 dc=0
alter Vh6 dc=0
alter Vs7 dc=0
alter Vh7 dc=0
op
echo ROW 2 25.0 20 $&v(xt.vth_soft) $&v(xt.vth_hard) $&v(vref_buf) $&v(isense) $&i(vdda)
alter Vs0 dc=1.2
alter Vh0 dc=1.2
alter Vs1 dc=0
alter Vh1 dc=0
alter Vs2 dc=1.2
alter Vh2 dc=1.2
alter Vs3 dc=0
alter Vh3 dc=0
alter Vs4 dc=1.2
alter Vh4 dc=1.2
alter Vs5 dc=0
alter Vh5 dc=0
alter Vs6 dc=0
alter Vh6 dc=0
alter Vs7 dc=0
alter Vh7 dc=0
op
echo ROW 2 25.0 21 $&v(xt.vth_soft) $&v(xt.vth_hard) $&v(vref_buf) $&v(isense) $&i(vdda)
alter Vs0 dc=0
alter Vh0 dc=0
alter Vs1 dc=1.2
alter Vh1 dc=1.2
alter Vs2 dc=1.2
alter Vh2 dc=1.2
alter Vs3 dc=0
alter Vh3 dc=0
alter Vs4 dc=1.2
alter Vh4 dc=1.2
alter Vs5 dc=0
alter Vh5 dc=0
alter Vs6 dc=0
alter Vh6 dc=0
alter Vs7 dc=0
alter Vh7 dc=0
op
echo ROW 2 25.0 22 $&v(xt.vth_soft) $&v(xt.vth_hard) $&v(vref_buf) $&v(isense) $&i(vdda)
alter Vs0 dc=1.2
alter Vh0 dc=1.2
alter Vs1 dc=1.2
alter Vh1 dc=1.2
alter Vs2 dc=1.2
alter Vh2 dc=1.2
alter Vs3 dc=0
alter Vh3 dc=0
alter Vs4 dc=1.2
alter Vh4 dc=1.2
alter Vs5 dc=0
alter Vh5 dc=0
alter Vs6 dc=0
alter Vh6 dc=0
alter Vs7 dc=0
alter Vh7 dc=0
op
echo ROW 2 25.0 23 $&v(xt.vth_soft) $&v(xt.vth_hard) $&v(vref_buf) $&v(isense) $&i(vdda)
alter Vs0 dc=0
alter Vh0 dc=0
alter Vs1 dc=0
alter Vh1 dc=0
alter Vs2 dc=0
alter Vh2 dc=0
alter Vs3 dc=1.2
alter Vh3 dc=1.2
alter Vs4 dc=1.2
alter Vh4 dc=1.2
alter Vs5 dc=0
alter Vh5 dc=0
alter Vs6 dc=0
alter Vh6 dc=0
alter Vs7 dc=0
alter Vh7 dc=0
op
echo ROW 2 25.0 24 $&v(xt.vth_soft) $&v(xt.vth_hard) $&v(vref_buf) $&v(isense) $&i(vdda)
alter Vs0 dc=1.2
alter Vh0 dc=1.2
alter Vs1 dc=0
alter Vh1 dc=0
alter Vs2 dc=0
alter Vh2 dc=0
alter Vs3 dc=1.2
alter Vh3 dc=1.2
alter Vs4 dc=1.2
alter Vh4 dc=1.2
alter Vs5 dc=0
alter Vh5 dc=0
alter Vs6 dc=0
alter Vh6 dc=0
alter Vs7 dc=0
alter Vh7 dc=0
op
echo ROW 2 25.0 25 $&v(xt.vth_soft) $&v(xt.vth_hard) $&v(vref_buf) $&v(isense) $&i(vdda)
alter Vs0 dc=0
alter Vh0 dc=0
alter Vs1 dc=1.2
alter Vh1 dc=1.2
alter Vs2 dc=0
alter Vh2 dc=0
alter Vs3 dc=1.2
alter Vh3 dc=1.2
alter Vs4 dc=1.2
alter Vh4 dc=1.2
alter Vs5 dc=0
alter Vh5 dc=0
alter Vs6 dc=0
alter Vh6 dc=0
alter Vs7 dc=0
alter Vh7 dc=0
op
echo ROW 2 25.0 26 $&v(xt.vth_soft) $&v(xt.vth_hard) $&v(vref_buf) $&v(isense) $&i(vdda)
alter Vs0 dc=1.2
alter Vh0 dc=1.2
alter Vs1 dc=1.2
alter Vh1 dc=1.2
alter Vs2 dc=0
alter Vh2 dc=0
alter Vs3 dc=1.2
alter Vh3 dc=1.2
alter Vs4 dc=1.2
alter Vh4 dc=1.2
alter Vs5 dc=0
alter Vh5 dc=0
alter Vs6 dc=0
alter Vh6 dc=0
alter Vs7 dc=0
alter Vh7 dc=0
op
echo ROW 2 25.0 27 $&v(xt.vth_soft) $&v(xt.vth_hard) $&v(vref_buf) $&v(isense) $&i(vdda)
alter Vs0 dc=0
alter Vh0 dc=0
alter Vs1 dc=0
alter Vh1 dc=0
alter Vs2 dc=1.2
alter Vh2 dc=1.2
alter Vs3 dc=1.2
alter Vh3 dc=1.2
alter Vs4 dc=1.2
alter Vh4 dc=1.2
alter Vs5 dc=0
alter Vh5 dc=0
alter Vs6 dc=0
alter Vh6 dc=0
alter Vs7 dc=0
alter Vh7 dc=0
op
echo ROW 2 25.0 28 $&v(xt.vth_soft) $&v(xt.vth_hard) $&v(vref_buf) $&v(isense) $&i(vdda)
alter Vs0 dc=1.2
alter Vh0 dc=1.2
alter Vs1 dc=0
alter Vh1 dc=0
alter Vs2 dc=1.2
alter Vh2 dc=1.2
alter Vs3 dc=1.2
alter Vh3 dc=1.2
alter Vs4 dc=1.2
alter Vh4 dc=1.2
alter Vs5 dc=0
alter Vh5 dc=0
alter Vs6 dc=0
alter Vh6 dc=0
alter Vs7 dc=0
alter Vh7 dc=0
op
echo ROW 2 25.0 29 $&v(xt.vth_soft) $&v(xt.vth_hard) $&v(vref_buf) $&v(isense) $&i(vdda)
alter Vs0 dc=0
alter Vh0 dc=0
alter Vs1 dc=1.2
alter Vh1 dc=1.2
alter Vs2 dc=1.2
alter Vh2 dc=1.2
alter Vs3 dc=1.2
alter Vh3 dc=1.2
alter Vs4 dc=1.2
alter Vh4 dc=1.2
alter Vs5 dc=0
alter Vh5 dc=0
alter Vs6 dc=0
alter Vh6 dc=0
alter Vs7 dc=0
alter Vh7 dc=0
op
echo ROW 2 25.0 30 $&v(xt.vth_soft) $&v(xt.vth_hard) $&v(vref_buf) $&v(isense) $&i(vdda)
alter Vs0 dc=1.2
alter Vh0 dc=1.2
alter Vs1 dc=1.2
alter Vh1 dc=1.2
alter Vs2 dc=1.2
alter Vh2 dc=1.2
alter Vs3 dc=1.2
alter Vh3 dc=1.2
alter Vs4 dc=1.2
alter Vh4 dc=1.2
alter Vs5 dc=0
alter Vh5 dc=0
alter Vs6 dc=0
alter Vh6 dc=0
alter Vs7 dc=0
alter Vh7 dc=0
op
echo ROW 2 25.0 31 $&v(xt.vth_soft) $&v(xt.vth_hard) $&v(vref_buf) $&v(isense) $&i(vdda)
alter Vs0 dc=0
alter Vh0 dc=0
alter Vs1 dc=0
alter Vh1 dc=0
alter Vs2 dc=0
alter Vh2 dc=0
alter Vs3 dc=0
alter Vh3 dc=0
alter Vs4 dc=0
alter Vh4 dc=0
alter Vs5 dc=1.2
alter Vh5 dc=1.2
alter Vs6 dc=0
alter Vh6 dc=0
alter Vs7 dc=0
alter Vh7 dc=0
op
echo ROW 2 25.0 32 $&v(xt.vth_soft) $&v(xt.vth_hard) $&v(vref_buf) $&v(isense) $&i(vdda)
alter Vs0 dc=1.2
alter Vh0 dc=1.2
alter Vs1 dc=0
alter Vh1 dc=0
alter Vs2 dc=0
alter Vh2 dc=0
alter Vs3 dc=0
alter Vh3 dc=0
alter Vs4 dc=0
alter Vh4 dc=0
alter Vs5 dc=1.2
alter Vh5 dc=1.2
alter Vs6 dc=0
alter Vh6 dc=0
alter Vs7 dc=0
alter Vh7 dc=0
op
echo ROW 2 25.0 33 $&v(xt.vth_soft) $&v(xt.vth_hard) $&v(vref_buf) $&v(isense) $&i(vdda)
alter Vs0 dc=0
alter Vh0 dc=0
alter Vs1 dc=1.2
alter Vh1 dc=1.2
alter Vs2 dc=0
alter Vh2 dc=0
alter Vs3 dc=0
alter Vh3 dc=0
alter Vs4 dc=0
alter Vh4 dc=0
alter Vs5 dc=1.2
alter Vh5 dc=1.2
alter Vs6 dc=0
alter Vh6 dc=0
alter Vs7 dc=0
alter Vh7 dc=0
op
echo ROW 2 25.0 34 $&v(xt.vth_soft) $&v(xt.vth_hard) $&v(vref_buf) $&v(isense) $&i(vdda)
alter Vs0 dc=1.2
alter Vh0 dc=1.2
alter Vs1 dc=1.2
alter Vh1 dc=1.2
alter Vs2 dc=0
alter Vh2 dc=0
alter Vs3 dc=0
alter Vh3 dc=0
alter Vs4 dc=0
alter Vh4 dc=0
alter Vs5 dc=1.2
alter Vh5 dc=1.2
alter Vs6 dc=0
alter Vh6 dc=0
alter Vs7 dc=0
alter Vh7 dc=0
op
echo ROW 2 25.0 35 $&v(xt.vth_soft) $&v(xt.vth_hard) $&v(vref_buf) $&v(isense) $&i(vdda)
alter Vs0 dc=0
alter Vh0 dc=0
alter Vs1 dc=0
alter Vh1 dc=0
alter Vs2 dc=1.2
alter Vh2 dc=1.2
alter Vs3 dc=0
alter Vh3 dc=0
alter Vs4 dc=0
alter Vh4 dc=0
alter Vs5 dc=1.2
alter Vh5 dc=1.2
alter Vs6 dc=0
alter Vh6 dc=0
alter Vs7 dc=0
alter Vh7 dc=0
op
echo ROW 2 25.0 36 $&v(xt.vth_soft) $&v(xt.vth_hard) $&v(vref_buf) $&v(isense) $&i(vdda)
alter Vs0 dc=1.2
alter Vh0 dc=1.2
alter Vs1 dc=0
alter Vh1 dc=0
alter Vs2 dc=1.2
alter Vh2 dc=1.2
alter Vs3 dc=0
alter Vh3 dc=0
alter Vs4 dc=0
alter Vh4 dc=0
alter Vs5 dc=1.2
alter Vh5 dc=1.2
alter Vs6 dc=0
alter Vh6 dc=0
alter Vs7 dc=0
alter Vh7 dc=0
op
echo ROW 2 25.0 37 $&v(xt.vth_soft) $&v(xt.vth_hard) $&v(vref_buf) $&v(isense) $&i(vdda)
alter Vs0 dc=0
alter Vh0 dc=0
alter Vs1 dc=1.2
alter Vh1 dc=1.2
alter Vs2 dc=1.2
alter Vh2 dc=1.2
alter Vs3 dc=0
alter Vh3 dc=0
alter Vs4 dc=0
alter Vh4 dc=0
alter Vs5 dc=1.2
alter Vh5 dc=1.2
alter Vs6 dc=0
alter Vh6 dc=0
alter Vs7 dc=0
alter Vh7 dc=0
op
echo ROW 2 25.0 38 $&v(xt.vth_soft) $&v(xt.vth_hard) $&v(vref_buf) $&v(isense) $&i(vdda)
alter Vs0 dc=1.2
alter Vh0 dc=1.2
alter Vs1 dc=1.2
alter Vh1 dc=1.2
alter Vs2 dc=1.2
alter Vh2 dc=1.2
alter Vs3 dc=0
alter Vh3 dc=0
alter Vs4 dc=0
alter Vh4 dc=0
alter Vs5 dc=1.2
alter Vh5 dc=1.2
alter Vs6 dc=0
alter Vh6 dc=0
alter Vs7 dc=0
alter Vh7 dc=0
op
echo ROW 2 25.0 39 $&v(xt.vth_soft) $&v(xt.vth_hard) $&v(vref_buf) $&v(isense) $&i(vdda)
alter Vs0 dc=0
alter Vh0 dc=0
alter Vs1 dc=0
alter Vh1 dc=0
alter Vs2 dc=0
alter Vh2 dc=0
alter Vs3 dc=1.2
alter Vh3 dc=1.2
alter Vs4 dc=0
alter Vh4 dc=0
alter Vs5 dc=1.2
alter Vh5 dc=1.2
alter Vs6 dc=0
alter Vh6 dc=0
alter Vs7 dc=0
alter Vh7 dc=0
op
echo ROW 2 25.0 40 $&v(xt.vth_soft) $&v(xt.vth_hard) $&v(vref_buf) $&v(isense) $&i(vdda)
alter Vs0 dc=1.2
alter Vh0 dc=1.2
alter Vs1 dc=0
alter Vh1 dc=0
alter Vs2 dc=0
alter Vh2 dc=0
alter Vs3 dc=1.2
alter Vh3 dc=1.2
alter Vs4 dc=0
alter Vh4 dc=0
alter Vs5 dc=1.2
alter Vh5 dc=1.2
alter Vs6 dc=0
alter Vh6 dc=0
alter Vs7 dc=0
alter Vh7 dc=0
op
echo ROW 2 25.0 41 $&v(xt.vth_soft) $&v(xt.vth_hard) $&v(vref_buf) $&v(isense) $&i(vdda)
alter Vs0 dc=0
alter Vh0 dc=0
alter Vs1 dc=1.2
alter Vh1 dc=1.2
alter Vs2 dc=0
alter Vh2 dc=0
alter Vs3 dc=1.2
alter Vh3 dc=1.2
alter Vs4 dc=0
alter Vh4 dc=0
alter Vs5 dc=1.2
alter Vh5 dc=1.2
alter Vs6 dc=0
alter Vh6 dc=0
alter Vs7 dc=0
alter Vh7 dc=0
op
echo ROW 2 25.0 42 $&v(xt.vth_soft) $&v(xt.vth_hard) $&v(vref_buf) $&v(isense) $&i(vdda)
alter Vs0 dc=1.2
alter Vh0 dc=1.2
alter Vs1 dc=1.2
alter Vh1 dc=1.2
alter Vs2 dc=0
alter Vh2 dc=0
alter Vs3 dc=1.2
alter Vh3 dc=1.2
alter Vs4 dc=0
alter Vh4 dc=0
alter Vs5 dc=1.2
alter Vh5 dc=1.2
alter Vs6 dc=0
alter Vh6 dc=0
alter Vs7 dc=0
alter Vh7 dc=0
op
echo ROW 2 25.0 43 $&v(xt.vth_soft) $&v(xt.vth_hard) $&v(vref_buf) $&v(isense) $&i(vdda)
alter Vs0 dc=0
alter Vh0 dc=0
alter Vs1 dc=0
alter Vh1 dc=0
alter Vs2 dc=1.2
alter Vh2 dc=1.2
alter Vs3 dc=1.2
alter Vh3 dc=1.2
alter Vs4 dc=0
alter Vh4 dc=0
alter Vs5 dc=1.2
alter Vh5 dc=1.2
alter Vs6 dc=0
alter Vh6 dc=0
alter Vs7 dc=0
alter Vh7 dc=0
op
echo ROW 2 25.0 44 $&v(xt.vth_soft) $&v(xt.vth_hard) $&v(vref_buf) $&v(isense) $&i(vdda)
alter Vs0 dc=1.2
alter Vh0 dc=1.2
alter Vs1 dc=0
alter Vh1 dc=0
alter Vs2 dc=1.2
alter Vh2 dc=1.2
alter Vs3 dc=1.2
alter Vh3 dc=1.2
alter Vs4 dc=0
alter Vh4 dc=0
alter Vs5 dc=1.2
alter Vh5 dc=1.2
alter Vs6 dc=0
alter Vh6 dc=0
alter Vs7 dc=0
alter Vh7 dc=0
op
echo ROW 2 25.0 45 $&v(xt.vth_soft) $&v(xt.vth_hard) $&v(vref_buf) $&v(isense) $&i(vdda)
alter Vs0 dc=0
alter Vh0 dc=0
alter Vs1 dc=1.2
alter Vh1 dc=1.2
alter Vs2 dc=1.2
alter Vh2 dc=1.2
alter Vs3 dc=1.2
alter Vh3 dc=1.2
alter Vs4 dc=0
alter Vh4 dc=0
alter Vs5 dc=1.2
alter Vh5 dc=1.2
alter Vs6 dc=0
alter Vh6 dc=0
alter Vs7 dc=0
alter Vh7 dc=0
op
echo ROW 2 25.0 46 $&v(xt.vth_soft) $&v(xt.vth_hard) $&v(vref_buf) $&v(isense) $&i(vdda)
alter Vs0 dc=1.2
alter Vh0 dc=1.2
alter Vs1 dc=1.2
alter Vh1 dc=1.2
alter Vs2 dc=1.2
alter Vh2 dc=1.2
alter Vs3 dc=1.2
alter Vh3 dc=1.2
alter Vs4 dc=0
alter Vh4 dc=0
alter Vs5 dc=1.2
alter Vh5 dc=1.2
alter Vs6 dc=0
alter Vh6 dc=0
alter Vs7 dc=0
alter Vh7 dc=0
op
echo ROW 2 25.0 47 $&v(xt.vth_soft) $&v(xt.vth_hard) $&v(vref_buf) $&v(isense) $&i(vdda)
alter Vs0 dc=0
alter Vh0 dc=0
alter Vs1 dc=0
alter Vh1 dc=0
alter Vs2 dc=0
alter Vh2 dc=0
alter Vs3 dc=0
alter Vh3 dc=0
alter Vs4 dc=1.2
alter Vh4 dc=1.2
alter Vs5 dc=1.2
alter Vh5 dc=1.2
alter Vs6 dc=0
alter Vh6 dc=0
alter Vs7 dc=0
alter Vh7 dc=0
op
echo ROW 2 25.0 48 $&v(xt.vth_soft) $&v(xt.vth_hard) $&v(vref_buf) $&v(isense) $&i(vdda)
alter Vs0 dc=1.2
alter Vh0 dc=1.2
alter Vs1 dc=0
alter Vh1 dc=0
alter Vs2 dc=0
alter Vh2 dc=0
alter Vs3 dc=0
alter Vh3 dc=0
alter Vs4 dc=1.2
alter Vh4 dc=1.2
alter Vs5 dc=1.2
alter Vh5 dc=1.2
alter Vs6 dc=0
alter Vh6 dc=0
alter Vs7 dc=0
alter Vh7 dc=0
op
echo ROW 2 25.0 49 $&v(xt.vth_soft) $&v(xt.vth_hard) $&v(vref_buf) $&v(isense) $&i(vdda)
alter Vs0 dc=0
alter Vh0 dc=0
alter Vs1 dc=1.2
alter Vh1 dc=1.2
alter Vs2 dc=0
alter Vh2 dc=0
alter Vs3 dc=0
alter Vh3 dc=0
alter Vs4 dc=1.2
alter Vh4 dc=1.2
alter Vs5 dc=1.2
alter Vh5 dc=1.2
alter Vs6 dc=0
alter Vh6 dc=0
alter Vs7 dc=0
alter Vh7 dc=0
op
echo ROW 2 25.0 50 $&v(xt.vth_soft) $&v(xt.vth_hard) $&v(vref_buf) $&v(isense) $&i(vdda)
alter Vs0 dc=1.2
alter Vh0 dc=1.2
alter Vs1 dc=1.2
alter Vh1 dc=1.2
alter Vs2 dc=0
alter Vh2 dc=0
alter Vs3 dc=0
alter Vh3 dc=0
alter Vs4 dc=1.2
alter Vh4 dc=1.2
alter Vs5 dc=1.2
alter Vh5 dc=1.2
alter Vs6 dc=0
alter Vh6 dc=0
alter Vs7 dc=0
alter Vh7 dc=0
op
echo ROW 2 25.0 51 $&v(xt.vth_soft) $&v(xt.vth_hard) $&v(vref_buf) $&v(isense) $&i(vdda)
alter Vs0 dc=0
alter Vh0 dc=0
alter Vs1 dc=0
alter Vh1 dc=0
alter Vs2 dc=1.2
alter Vh2 dc=1.2
alter Vs3 dc=0
alter Vh3 dc=0
alter Vs4 dc=1.2
alter Vh4 dc=1.2
alter Vs5 dc=1.2
alter Vh5 dc=1.2
alter Vs6 dc=0
alter Vh6 dc=0
alter Vs7 dc=0
alter Vh7 dc=0
op
echo ROW 2 25.0 52 $&v(xt.vth_soft) $&v(xt.vth_hard) $&v(vref_buf) $&v(isense) $&i(vdda)
alter Vs0 dc=1.2
alter Vh0 dc=1.2
alter Vs1 dc=0
alter Vh1 dc=0
alter Vs2 dc=1.2
alter Vh2 dc=1.2
alter Vs3 dc=0
alter Vh3 dc=0
alter Vs4 dc=1.2
alter Vh4 dc=1.2
alter Vs5 dc=1.2
alter Vh5 dc=1.2
alter Vs6 dc=0
alter Vh6 dc=0
alter Vs7 dc=0
alter Vh7 dc=0
op
echo ROW 2 25.0 53 $&v(xt.vth_soft) $&v(xt.vth_hard) $&v(vref_buf) $&v(isense) $&i(vdda)
alter Vs0 dc=0
alter Vh0 dc=0
alter Vs1 dc=1.2
alter Vh1 dc=1.2
alter Vs2 dc=1.2
alter Vh2 dc=1.2
alter Vs3 dc=0
alter Vh3 dc=0
alter Vs4 dc=1.2
alter Vh4 dc=1.2
alter Vs5 dc=1.2
alter Vh5 dc=1.2
alter Vs6 dc=0
alter Vh6 dc=0
alter Vs7 dc=0
alter Vh7 dc=0
op
echo ROW 2 25.0 54 $&v(xt.vth_soft) $&v(xt.vth_hard) $&v(vref_buf) $&v(isense) $&i(vdda)
alter Vs0 dc=1.2
alter Vh0 dc=1.2
alter Vs1 dc=1.2
alter Vh1 dc=1.2
alter Vs2 dc=1.2
alter Vh2 dc=1.2
alter Vs3 dc=0
alter Vh3 dc=0
alter Vs4 dc=1.2
alter Vh4 dc=1.2
alter Vs5 dc=1.2
alter Vh5 dc=1.2
alter Vs6 dc=0
alter Vh6 dc=0
alter Vs7 dc=0
alter Vh7 dc=0
op
echo ROW 2 25.0 55 $&v(xt.vth_soft) $&v(xt.vth_hard) $&v(vref_buf) $&v(isense) $&i(vdda)
alter Vs0 dc=0
alter Vh0 dc=0
alter Vs1 dc=0
alter Vh1 dc=0
alter Vs2 dc=0
alter Vh2 dc=0
alter Vs3 dc=1.2
alter Vh3 dc=1.2
alter Vs4 dc=1.2
alter Vh4 dc=1.2
alter Vs5 dc=1.2
alter Vh5 dc=1.2
alter Vs6 dc=0
alter Vh6 dc=0
alter Vs7 dc=0
alter Vh7 dc=0
op
echo ROW 2 25.0 56 $&v(xt.vth_soft) $&v(xt.vth_hard) $&v(vref_buf) $&v(isense) $&i(vdda)
alter Vs0 dc=1.2
alter Vh0 dc=1.2
alter Vs1 dc=0
alter Vh1 dc=0
alter Vs2 dc=0
alter Vh2 dc=0
alter Vs3 dc=1.2
alter Vh3 dc=1.2
alter Vs4 dc=1.2
alter Vh4 dc=1.2
alter Vs5 dc=1.2
alter Vh5 dc=1.2
alter Vs6 dc=0
alter Vh6 dc=0
alter Vs7 dc=0
alter Vh7 dc=0
op
echo ROW 2 25.0 57 $&v(xt.vth_soft) $&v(xt.vth_hard) $&v(vref_buf) $&v(isense) $&i(vdda)
alter Vs0 dc=0
alter Vh0 dc=0
alter Vs1 dc=1.2
alter Vh1 dc=1.2
alter Vs2 dc=0
alter Vh2 dc=0
alter Vs3 dc=1.2
alter Vh3 dc=1.2
alter Vs4 dc=1.2
alter Vh4 dc=1.2
alter Vs5 dc=1.2
alter Vh5 dc=1.2
alter Vs6 dc=0
alter Vh6 dc=0
alter Vs7 dc=0
alter Vh7 dc=0
op
echo ROW 2 25.0 58 $&v(xt.vth_soft) $&v(xt.vth_hard) $&v(vref_buf) $&v(isense) $&i(vdda)
alter Vs0 dc=1.2
alter Vh0 dc=1.2
alter Vs1 dc=1.2
alter Vh1 dc=1.2
alter Vs2 dc=0
alter Vh2 dc=0
alter Vs3 dc=1.2
alter Vh3 dc=1.2
alter Vs4 dc=1.2
alter Vh4 dc=1.2
alter Vs5 dc=1.2
alter Vh5 dc=1.2
alter Vs6 dc=0
alter Vh6 dc=0
alter Vs7 dc=0
alter Vh7 dc=0
op
echo ROW 2 25.0 59 $&v(xt.vth_soft) $&v(xt.vth_hard) $&v(vref_buf) $&v(isense) $&i(vdda)
alter Vs0 dc=0
alter Vh0 dc=0
alter Vs1 dc=0
alter Vh1 dc=0
alter Vs2 dc=1.2
alter Vh2 dc=1.2
alter Vs3 dc=1.2
alter Vh3 dc=1.2
alter Vs4 dc=1.2
alter Vh4 dc=1.2
alter Vs5 dc=1.2
alter Vh5 dc=1.2
alter Vs6 dc=0
alter Vh6 dc=0
alter Vs7 dc=0
alter Vh7 dc=0
op
echo ROW 2 25.0 60 $&v(xt.vth_soft) $&v(xt.vth_hard) $&v(vref_buf) $&v(isense) $&i(vdda)
alter Vs0 dc=1.2
alter Vh0 dc=1.2
alter Vs1 dc=0
alter Vh1 dc=0
alter Vs2 dc=1.2
alter Vh2 dc=1.2
alter Vs3 dc=1.2
alter Vh3 dc=1.2
alter Vs4 dc=1.2
alter Vh4 dc=1.2
alter Vs5 dc=1.2
alter Vh5 dc=1.2
alter Vs6 dc=0
alter Vh6 dc=0
alter Vs7 dc=0
alter Vh7 dc=0
op
echo ROW 2 25.0 61 $&v(xt.vth_soft) $&v(xt.vth_hard) $&v(vref_buf) $&v(isense) $&i(vdda)
alter Vs0 dc=0
alter Vh0 dc=0
alter Vs1 dc=1.2
alter Vh1 dc=1.2
alter Vs2 dc=1.2
alter Vh2 dc=1.2
alter Vs3 dc=1.2
alter Vh3 dc=1.2
alter Vs4 dc=1.2
alter Vh4 dc=1.2
alter Vs5 dc=1.2
alter Vh5 dc=1.2
alter Vs6 dc=0
alter Vh6 dc=0
alter Vs7 dc=0
alter Vh7 dc=0
op
echo ROW 2 25.0 62 $&v(xt.vth_soft) $&v(xt.vth_hard) $&v(vref_buf) $&v(isense) $&i(vdda)
alter Vs0 dc=1.2
alter Vh0 dc=1.2
alter Vs1 dc=1.2
alter Vh1 dc=1.2
alter Vs2 dc=1.2
alter Vh2 dc=1.2
alter Vs3 dc=1.2
alter Vh3 dc=1.2
alter Vs4 dc=1.2
alter Vh4 dc=1.2
alter Vs5 dc=1.2
alter Vh5 dc=1.2
alter Vs6 dc=0
alter Vh6 dc=0
alter Vs7 dc=0
alter Vh7 dc=0
op
echo ROW 2 25.0 63 $&v(xt.vth_soft) $&v(xt.vth_hard) $&v(vref_buf) $&v(isense) $&i(vdda)
alter Vs0 dc=0
alter Vh0 dc=0
alter Vs1 dc=0
alter Vh1 dc=0
alter Vs2 dc=0
alter Vh2 dc=0
alter Vs3 dc=0
alter Vh3 dc=0
alter Vs4 dc=0
alter Vh4 dc=0
alter Vs5 dc=0
alter Vh5 dc=0
alter Vs6 dc=1.2
alter Vh6 dc=1.2
alter Vs7 dc=0
alter Vh7 dc=0
op
echo ROW 2 25.0 64 $&v(xt.vth_soft) $&v(xt.vth_hard) $&v(vref_buf) $&v(isense) $&i(vdda)
alter Vs0 dc=1.2
alter Vh0 dc=1.2
alter Vs1 dc=0
alter Vh1 dc=0
alter Vs2 dc=0
alter Vh2 dc=0
alter Vs3 dc=0
alter Vh3 dc=0
alter Vs4 dc=0
alter Vh4 dc=0
alter Vs5 dc=0
alter Vh5 dc=0
alter Vs6 dc=1.2
alter Vh6 dc=1.2
alter Vs7 dc=0
alter Vh7 dc=0
op
echo ROW 2 25.0 65 $&v(xt.vth_soft) $&v(xt.vth_hard) $&v(vref_buf) $&v(isense) $&i(vdda)
alter Vs0 dc=0
alter Vh0 dc=0
alter Vs1 dc=1.2
alter Vh1 dc=1.2
alter Vs2 dc=0
alter Vh2 dc=0
alter Vs3 dc=0
alter Vh3 dc=0
alter Vs4 dc=0
alter Vh4 dc=0
alter Vs5 dc=0
alter Vh5 dc=0
alter Vs6 dc=1.2
alter Vh6 dc=1.2
alter Vs7 dc=0
alter Vh7 dc=0
op
echo ROW 2 25.0 66 $&v(xt.vth_soft) $&v(xt.vth_hard) $&v(vref_buf) $&v(isense) $&i(vdda)
alter Vs0 dc=1.2
alter Vh0 dc=1.2
alter Vs1 dc=1.2
alter Vh1 dc=1.2
alter Vs2 dc=0
alter Vh2 dc=0
alter Vs3 dc=0
alter Vh3 dc=0
alter Vs4 dc=0
alter Vh4 dc=0
alter Vs5 dc=0
alter Vh5 dc=0
alter Vs6 dc=1.2
alter Vh6 dc=1.2
alter Vs7 dc=0
alter Vh7 dc=0
op
echo ROW 2 25.0 67 $&v(xt.vth_soft) $&v(xt.vth_hard) $&v(vref_buf) $&v(isense) $&i(vdda)
alter Vs0 dc=0
alter Vh0 dc=0
alter Vs1 dc=0
alter Vh1 dc=0
alter Vs2 dc=1.2
alter Vh2 dc=1.2
alter Vs3 dc=0
alter Vh3 dc=0
alter Vs4 dc=0
alter Vh4 dc=0
alter Vs5 dc=0
alter Vh5 dc=0
alter Vs6 dc=1.2
alter Vh6 dc=1.2
alter Vs7 dc=0
alter Vh7 dc=0
op
echo ROW 2 25.0 68 $&v(xt.vth_soft) $&v(xt.vth_hard) $&v(vref_buf) $&v(isense) $&i(vdda)
alter Vs0 dc=1.2
alter Vh0 dc=1.2
alter Vs1 dc=0
alter Vh1 dc=0
alter Vs2 dc=1.2
alter Vh2 dc=1.2
alter Vs3 dc=0
alter Vh3 dc=0
alter Vs4 dc=0
alter Vh4 dc=0
alter Vs5 dc=0
alter Vh5 dc=0
alter Vs6 dc=1.2
alter Vh6 dc=1.2
alter Vs7 dc=0
alter Vh7 dc=0
op
echo ROW 2 25.0 69 $&v(xt.vth_soft) $&v(xt.vth_hard) $&v(vref_buf) $&v(isense) $&i(vdda)
alter Vs0 dc=0
alter Vh0 dc=0
alter Vs1 dc=1.2
alter Vh1 dc=1.2
alter Vs2 dc=1.2
alter Vh2 dc=1.2
alter Vs3 dc=0
alter Vh3 dc=0
alter Vs4 dc=0
alter Vh4 dc=0
alter Vs5 dc=0
alter Vh5 dc=0
alter Vs6 dc=1.2
alter Vh6 dc=1.2
alter Vs7 dc=0
alter Vh7 dc=0
op
echo ROW 2 25.0 70 $&v(xt.vth_soft) $&v(xt.vth_hard) $&v(vref_buf) $&v(isense) $&i(vdda)
alter Vs0 dc=1.2
alter Vh0 dc=1.2
alter Vs1 dc=1.2
alter Vh1 dc=1.2
alter Vs2 dc=1.2
alter Vh2 dc=1.2
alter Vs3 dc=0
alter Vh3 dc=0
alter Vs4 dc=0
alter Vh4 dc=0
alter Vs5 dc=0
alter Vh5 dc=0
alter Vs6 dc=1.2
alter Vh6 dc=1.2
alter Vs7 dc=0
alter Vh7 dc=0
op
echo ROW 2 25.0 71 $&v(xt.vth_soft) $&v(xt.vth_hard) $&v(vref_buf) $&v(isense) $&i(vdda)
alter Vs0 dc=0
alter Vh0 dc=0
alter Vs1 dc=0
alter Vh1 dc=0
alter Vs2 dc=0
alter Vh2 dc=0
alter Vs3 dc=1.2
alter Vh3 dc=1.2
alter Vs4 dc=0
alter Vh4 dc=0
alter Vs5 dc=0
alter Vh5 dc=0
alter Vs6 dc=1.2
alter Vh6 dc=1.2
alter Vs7 dc=0
alter Vh7 dc=0
op
echo ROW 2 25.0 72 $&v(xt.vth_soft) $&v(xt.vth_hard) $&v(vref_buf) $&v(isense) $&i(vdda)
alter Vs0 dc=1.2
alter Vh0 dc=1.2
alter Vs1 dc=0
alter Vh1 dc=0
alter Vs2 dc=0
alter Vh2 dc=0
alter Vs3 dc=1.2
alter Vh3 dc=1.2
alter Vs4 dc=0
alter Vh4 dc=0
alter Vs5 dc=0
alter Vh5 dc=0
alter Vs6 dc=1.2
alter Vh6 dc=1.2
alter Vs7 dc=0
alter Vh7 dc=0
op
echo ROW 2 25.0 73 $&v(xt.vth_soft) $&v(xt.vth_hard) $&v(vref_buf) $&v(isense) $&i(vdda)
alter Vs0 dc=0
alter Vh0 dc=0
alter Vs1 dc=1.2
alter Vh1 dc=1.2
alter Vs2 dc=0
alter Vh2 dc=0
alter Vs3 dc=1.2
alter Vh3 dc=1.2
alter Vs4 dc=0
alter Vh4 dc=0
alter Vs5 dc=0
alter Vh5 dc=0
alter Vs6 dc=1.2
alter Vh6 dc=1.2
alter Vs7 dc=0
alter Vh7 dc=0
op
echo ROW 2 25.0 74 $&v(xt.vth_soft) $&v(xt.vth_hard) $&v(vref_buf) $&v(isense) $&i(vdda)
alter Vs0 dc=1.2
alter Vh0 dc=1.2
alter Vs1 dc=1.2
alter Vh1 dc=1.2
alter Vs2 dc=0
alter Vh2 dc=0
alter Vs3 dc=1.2
alter Vh3 dc=1.2
alter Vs4 dc=0
alter Vh4 dc=0
alter Vs5 dc=0
alter Vh5 dc=0
alter Vs6 dc=1.2
alter Vh6 dc=1.2
alter Vs7 dc=0
alter Vh7 dc=0
op
echo ROW 2 25.0 75 $&v(xt.vth_soft) $&v(xt.vth_hard) $&v(vref_buf) $&v(isense) $&i(vdda)
alter Vs0 dc=0
alter Vh0 dc=0
alter Vs1 dc=0
alter Vh1 dc=0
alter Vs2 dc=1.2
alter Vh2 dc=1.2
alter Vs3 dc=1.2
alter Vh3 dc=1.2
alter Vs4 dc=0
alter Vh4 dc=0
alter Vs5 dc=0
alter Vh5 dc=0
alter Vs6 dc=1.2
alter Vh6 dc=1.2
alter Vs7 dc=0
alter Vh7 dc=0
op
echo ROW 2 25.0 76 $&v(xt.vth_soft) $&v(xt.vth_hard) $&v(vref_buf) $&v(isense) $&i(vdda)
alter Vs0 dc=1.2
alter Vh0 dc=1.2
alter Vs1 dc=0
alter Vh1 dc=0
alter Vs2 dc=1.2
alter Vh2 dc=1.2
alter Vs3 dc=1.2
alter Vh3 dc=1.2
alter Vs4 dc=0
alter Vh4 dc=0
alter Vs5 dc=0
alter Vh5 dc=0
alter Vs6 dc=1.2
alter Vh6 dc=1.2
alter Vs7 dc=0
alter Vh7 dc=0
op
echo ROW 2 25.0 77 $&v(xt.vth_soft) $&v(xt.vth_hard) $&v(vref_buf) $&v(isense) $&i(vdda)
alter Vs0 dc=0
alter Vh0 dc=0
alter Vs1 dc=1.2
alter Vh1 dc=1.2
alter Vs2 dc=1.2
alter Vh2 dc=1.2
alter Vs3 dc=1.2
alter Vh3 dc=1.2
alter Vs4 dc=0
alter Vh4 dc=0
alter Vs5 dc=0
alter Vh5 dc=0
alter Vs6 dc=1.2
alter Vh6 dc=1.2
alter Vs7 dc=0
alter Vh7 dc=0
op
echo ROW 2 25.0 78 $&v(xt.vth_soft) $&v(xt.vth_hard) $&v(vref_buf) $&v(isense) $&i(vdda)
alter Vs0 dc=1.2
alter Vh0 dc=1.2
alter Vs1 dc=1.2
alter Vh1 dc=1.2
alter Vs2 dc=1.2
alter Vh2 dc=1.2
alter Vs3 dc=1.2
alter Vh3 dc=1.2
alter Vs4 dc=0
alter Vh4 dc=0
alter Vs5 dc=0
alter Vh5 dc=0
alter Vs6 dc=1.2
alter Vh6 dc=1.2
alter Vs7 dc=0
alter Vh7 dc=0
op
echo ROW 2 25.0 79 $&v(xt.vth_soft) $&v(xt.vth_hard) $&v(vref_buf) $&v(isense) $&i(vdda)
alter Vs0 dc=0
alter Vh0 dc=0
alter Vs1 dc=0
alter Vh1 dc=0
alter Vs2 dc=0
alter Vh2 dc=0
alter Vs3 dc=0
alter Vh3 dc=0
alter Vs4 dc=1.2
alter Vh4 dc=1.2
alter Vs5 dc=0
alter Vh5 dc=0
alter Vs6 dc=1.2
alter Vh6 dc=1.2
alter Vs7 dc=0
alter Vh7 dc=0
op
echo ROW 2 25.0 80 $&v(xt.vth_soft) $&v(xt.vth_hard) $&v(vref_buf) $&v(isense) $&i(vdda)
alter Vs0 dc=1.2
alter Vh0 dc=1.2
alter Vs1 dc=0
alter Vh1 dc=0
alter Vs2 dc=0
alter Vh2 dc=0
alter Vs3 dc=0
alter Vh3 dc=0
alter Vs4 dc=1.2
alter Vh4 dc=1.2
alter Vs5 dc=0
alter Vh5 dc=0
alter Vs6 dc=1.2
alter Vh6 dc=1.2
alter Vs7 dc=0
alter Vh7 dc=0
op
echo ROW 2 25.0 81 $&v(xt.vth_soft) $&v(xt.vth_hard) $&v(vref_buf) $&v(isense) $&i(vdda)
alter Vs0 dc=0
alter Vh0 dc=0
alter Vs1 dc=1.2
alter Vh1 dc=1.2
alter Vs2 dc=0
alter Vh2 dc=0
alter Vs3 dc=0
alter Vh3 dc=0
alter Vs4 dc=1.2
alter Vh4 dc=1.2
alter Vs5 dc=0
alter Vh5 dc=0
alter Vs6 dc=1.2
alter Vh6 dc=1.2
alter Vs7 dc=0
alter Vh7 dc=0
op
echo ROW 2 25.0 82 $&v(xt.vth_soft) $&v(xt.vth_hard) $&v(vref_buf) $&v(isense) $&i(vdda)
alter Vs0 dc=1.2
alter Vh0 dc=1.2
alter Vs1 dc=1.2
alter Vh1 dc=1.2
alter Vs2 dc=0
alter Vh2 dc=0
alter Vs3 dc=0
alter Vh3 dc=0
alter Vs4 dc=1.2
alter Vh4 dc=1.2
alter Vs5 dc=0
alter Vh5 dc=0
alter Vs6 dc=1.2
alter Vh6 dc=1.2
alter Vs7 dc=0
alter Vh7 dc=0
op
echo ROW 2 25.0 83 $&v(xt.vth_soft) $&v(xt.vth_hard) $&v(vref_buf) $&v(isense) $&i(vdda)
alter Vs0 dc=0
alter Vh0 dc=0
alter Vs1 dc=0
alter Vh1 dc=0
alter Vs2 dc=1.2
alter Vh2 dc=1.2
alter Vs3 dc=0
alter Vh3 dc=0
alter Vs4 dc=1.2
alter Vh4 dc=1.2
alter Vs5 dc=0
alter Vh5 dc=0
alter Vs6 dc=1.2
alter Vh6 dc=1.2
alter Vs7 dc=0
alter Vh7 dc=0
op
echo ROW 2 25.0 84 $&v(xt.vth_soft) $&v(xt.vth_hard) $&v(vref_buf) $&v(isense) $&i(vdda)
alter Vs0 dc=1.2
alter Vh0 dc=1.2
alter Vs1 dc=0
alter Vh1 dc=0
alter Vs2 dc=1.2
alter Vh2 dc=1.2
alter Vs3 dc=0
alter Vh3 dc=0
alter Vs4 dc=1.2
alter Vh4 dc=1.2
alter Vs5 dc=0
alter Vh5 dc=0
alter Vs6 dc=1.2
alter Vh6 dc=1.2
alter Vs7 dc=0
alter Vh7 dc=0
op
echo ROW 2 25.0 85 $&v(xt.vth_soft) $&v(xt.vth_hard) $&v(vref_buf) $&v(isense) $&i(vdda)
alter Vs0 dc=0
alter Vh0 dc=0
alter Vs1 dc=1.2
alter Vh1 dc=1.2
alter Vs2 dc=1.2
alter Vh2 dc=1.2
alter Vs3 dc=0
alter Vh3 dc=0
alter Vs4 dc=1.2
alter Vh4 dc=1.2
alter Vs5 dc=0
alter Vh5 dc=0
alter Vs6 dc=1.2
alter Vh6 dc=1.2
alter Vs7 dc=0
alter Vh7 dc=0
op
echo ROW 2 25.0 86 $&v(xt.vth_soft) $&v(xt.vth_hard) $&v(vref_buf) $&v(isense) $&i(vdda)
alter Vs0 dc=1.2
alter Vh0 dc=1.2
alter Vs1 dc=1.2
alter Vh1 dc=1.2
alter Vs2 dc=1.2
alter Vh2 dc=1.2
alter Vs3 dc=0
alter Vh3 dc=0
alter Vs4 dc=1.2
alter Vh4 dc=1.2
alter Vs5 dc=0
alter Vh5 dc=0
alter Vs6 dc=1.2
alter Vh6 dc=1.2
alter Vs7 dc=0
alter Vh7 dc=0
op
echo ROW 2 25.0 87 $&v(xt.vth_soft) $&v(xt.vth_hard) $&v(vref_buf) $&v(isense) $&i(vdda)
alter Vs0 dc=0
alter Vh0 dc=0
alter Vs1 dc=0
alter Vh1 dc=0
alter Vs2 dc=0
alter Vh2 dc=0
alter Vs3 dc=1.2
alter Vh3 dc=1.2
alter Vs4 dc=1.2
alter Vh4 dc=1.2
alter Vs5 dc=0
alter Vh5 dc=0
alter Vs6 dc=1.2
alter Vh6 dc=1.2
alter Vs7 dc=0
alter Vh7 dc=0
op
echo ROW 2 25.0 88 $&v(xt.vth_soft) $&v(xt.vth_hard) $&v(vref_buf) $&v(isense) $&i(vdda)
alter Vs0 dc=1.2
alter Vh0 dc=1.2
alter Vs1 dc=0
alter Vh1 dc=0
alter Vs2 dc=0
alter Vh2 dc=0
alter Vs3 dc=1.2
alter Vh3 dc=1.2
alter Vs4 dc=1.2
alter Vh4 dc=1.2
alter Vs5 dc=0
alter Vh5 dc=0
alter Vs6 dc=1.2
alter Vh6 dc=1.2
alter Vs7 dc=0
alter Vh7 dc=0
op
echo ROW 2 25.0 89 $&v(xt.vth_soft) $&v(xt.vth_hard) $&v(vref_buf) $&v(isense) $&i(vdda)
alter Vs0 dc=0
alter Vh0 dc=0
alter Vs1 dc=1.2
alter Vh1 dc=1.2
alter Vs2 dc=0
alter Vh2 dc=0
alter Vs3 dc=1.2
alter Vh3 dc=1.2
alter Vs4 dc=1.2
alter Vh4 dc=1.2
alter Vs5 dc=0
alter Vh5 dc=0
alter Vs6 dc=1.2
alter Vh6 dc=1.2
alter Vs7 dc=0
alter Vh7 dc=0
op
echo ROW 2 25.0 90 $&v(xt.vth_soft) $&v(xt.vth_hard) $&v(vref_buf) $&v(isense) $&i(vdda)
alter Vs0 dc=1.2
alter Vh0 dc=1.2
alter Vs1 dc=1.2
alter Vh1 dc=1.2
alter Vs2 dc=0
alter Vh2 dc=0
alter Vs3 dc=1.2
alter Vh3 dc=1.2
alter Vs4 dc=1.2
alter Vh4 dc=1.2
alter Vs5 dc=0
alter Vh5 dc=0
alter Vs6 dc=1.2
alter Vh6 dc=1.2
alter Vs7 dc=0
alter Vh7 dc=0
op
echo ROW 2 25.0 91 $&v(xt.vth_soft) $&v(xt.vth_hard) $&v(vref_buf) $&v(isense) $&i(vdda)
alter Vs0 dc=0
alter Vh0 dc=0
alter Vs1 dc=0
alter Vh1 dc=0
alter Vs2 dc=1.2
alter Vh2 dc=1.2
alter Vs3 dc=1.2
alter Vh3 dc=1.2
alter Vs4 dc=1.2
alter Vh4 dc=1.2
alter Vs5 dc=0
alter Vh5 dc=0
alter Vs6 dc=1.2
alter Vh6 dc=1.2
alter Vs7 dc=0
alter Vh7 dc=0
op
echo ROW 2 25.0 92 $&v(xt.vth_soft) $&v(xt.vth_hard) $&v(vref_buf) $&v(isense) $&i(vdda)
alter Vs0 dc=1.2
alter Vh0 dc=1.2
alter Vs1 dc=0
alter Vh1 dc=0
alter Vs2 dc=1.2
alter Vh2 dc=1.2
alter Vs3 dc=1.2
alter Vh3 dc=1.2
alter Vs4 dc=1.2
alter Vh4 dc=1.2
alter Vs5 dc=0
alter Vh5 dc=0
alter Vs6 dc=1.2
alter Vh6 dc=1.2
alter Vs7 dc=0
alter Vh7 dc=0
op
echo ROW 2 25.0 93 $&v(xt.vth_soft) $&v(xt.vth_hard) $&v(vref_buf) $&v(isense) $&i(vdda)
alter Vs0 dc=0
alter Vh0 dc=0
alter Vs1 dc=1.2
alter Vh1 dc=1.2
alter Vs2 dc=1.2
alter Vh2 dc=1.2
alter Vs3 dc=1.2
alter Vh3 dc=1.2
alter Vs4 dc=1.2
alter Vh4 dc=1.2
alter Vs5 dc=0
alter Vh5 dc=0
alter Vs6 dc=1.2
alter Vh6 dc=1.2
alter Vs7 dc=0
alter Vh7 dc=0
op
echo ROW 2 25.0 94 $&v(xt.vth_soft) $&v(xt.vth_hard) $&v(vref_buf) $&v(isense) $&i(vdda)
alter Vs0 dc=1.2
alter Vh0 dc=1.2
alter Vs1 dc=1.2
alter Vh1 dc=1.2
alter Vs2 dc=1.2
alter Vh2 dc=1.2
alter Vs3 dc=1.2
alter Vh3 dc=1.2
alter Vs4 dc=1.2
alter Vh4 dc=1.2
alter Vs5 dc=0
alter Vh5 dc=0
alter Vs6 dc=1.2
alter Vh6 dc=1.2
alter Vs7 dc=0
alter Vh7 dc=0
op
echo ROW 2 25.0 95 $&v(xt.vth_soft) $&v(xt.vth_hard) $&v(vref_buf) $&v(isense) $&i(vdda)
alter Vs0 dc=0
alter Vh0 dc=0
alter Vs1 dc=0
alter Vh1 dc=0
alter Vs2 dc=0
alter Vh2 dc=0
alter Vs3 dc=0
alter Vh3 dc=0
alter Vs4 dc=0
alter Vh4 dc=0
alter Vs5 dc=1.2
alter Vh5 dc=1.2
alter Vs6 dc=1.2
alter Vh6 dc=1.2
alter Vs7 dc=0
alter Vh7 dc=0
op
echo ROW 2 25.0 96 $&v(xt.vth_soft) $&v(xt.vth_hard) $&v(vref_buf) $&v(isense) $&i(vdda)
alter Vs0 dc=1.2
alter Vh0 dc=1.2
alter Vs1 dc=0
alter Vh1 dc=0
alter Vs2 dc=0
alter Vh2 dc=0
alter Vs3 dc=0
alter Vh3 dc=0
alter Vs4 dc=0
alter Vh4 dc=0
alter Vs5 dc=1.2
alter Vh5 dc=1.2
alter Vs6 dc=1.2
alter Vh6 dc=1.2
alter Vs7 dc=0
alter Vh7 dc=0
op
echo ROW 2 25.0 97 $&v(xt.vth_soft) $&v(xt.vth_hard) $&v(vref_buf) $&v(isense) $&i(vdda)
alter Vs0 dc=0
alter Vh0 dc=0
alter Vs1 dc=1.2
alter Vh1 dc=1.2
alter Vs2 dc=0
alter Vh2 dc=0
alter Vs3 dc=0
alter Vh3 dc=0
alter Vs4 dc=0
alter Vh4 dc=0
alter Vs5 dc=1.2
alter Vh5 dc=1.2
alter Vs6 dc=1.2
alter Vh6 dc=1.2
alter Vs7 dc=0
alter Vh7 dc=0
op
echo ROW 2 25.0 98 $&v(xt.vth_soft) $&v(xt.vth_hard) $&v(vref_buf) $&v(isense) $&i(vdda)
alter Vs0 dc=1.2
alter Vh0 dc=1.2
alter Vs1 dc=1.2
alter Vh1 dc=1.2
alter Vs2 dc=0
alter Vh2 dc=0
alter Vs3 dc=0
alter Vh3 dc=0
alter Vs4 dc=0
alter Vh4 dc=0
alter Vs5 dc=1.2
alter Vh5 dc=1.2
alter Vs6 dc=1.2
alter Vh6 dc=1.2
alter Vs7 dc=0
alter Vh7 dc=0
op
echo ROW 2 25.0 99 $&v(xt.vth_soft) $&v(xt.vth_hard) $&v(vref_buf) $&v(isense) $&i(vdda)
alter Vs0 dc=0
alter Vh0 dc=0
alter Vs1 dc=0
alter Vh1 dc=0
alter Vs2 dc=1.2
alter Vh2 dc=1.2
alter Vs3 dc=0
alter Vh3 dc=0
alter Vs4 dc=0
alter Vh4 dc=0
alter Vs5 dc=1.2
alter Vh5 dc=1.2
alter Vs6 dc=1.2
alter Vh6 dc=1.2
alter Vs7 dc=0
alter Vh7 dc=0
op
echo ROW 2 25.0 100 $&v(xt.vth_soft) $&v(xt.vth_hard) $&v(vref_buf) $&v(isense) $&i(vdda)
alter Vs0 dc=1.2
alter Vh0 dc=1.2
alter Vs1 dc=0
alter Vh1 dc=0
alter Vs2 dc=1.2
alter Vh2 dc=1.2
alter Vs3 dc=0
alter Vh3 dc=0
alter Vs4 dc=0
alter Vh4 dc=0
alter Vs5 dc=1.2
alter Vh5 dc=1.2
alter Vs6 dc=1.2
alter Vh6 dc=1.2
alter Vs7 dc=0
alter Vh7 dc=0
op
echo ROW 2 25.0 101 $&v(xt.vth_soft) $&v(xt.vth_hard) $&v(vref_buf) $&v(isense) $&i(vdda)
alter Vs0 dc=0
alter Vh0 dc=0
alter Vs1 dc=1.2
alter Vh1 dc=1.2
alter Vs2 dc=1.2
alter Vh2 dc=1.2
alter Vs3 dc=0
alter Vh3 dc=0
alter Vs4 dc=0
alter Vh4 dc=0
alter Vs5 dc=1.2
alter Vh5 dc=1.2
alter Vs6 dc=1.2
alter Vh6 dc=1.2
alter Vs7 dc=0
alter Vh7 dc=0
op
echo ROW 2 25.0 102 $&v(xt.vth_soft) $&v(xt.vth_hard) $&v(vref_buf) $&v(isense) $&i(vdda)
alter Vs0 dc=1.2
alter Vh0 dc=1.2
alter Vs1 dc=1.2
alter Vh1 dc=1.2
alter Vs2 dc=1.2
alter Vh2 dc=1.2
alter Vs3 dc=0
alter Vh3 dc=0
alter Vs4 dc=0
alter Vh4 dc=0
alter Vs5 dc=1.2
alter Vh5 dc=1.2
alter Vs6 dc=1.2
alter Vh6 dc=1.2
alter Vs7 dc=0
alter Vh7 dc=0
op
echo ROW 2 25.0 103 $&v(xt.vth_soft) $&v(xt.vth_hard) $&v(vref_buf) $&v(isense) $&i(vdda)
alter Vs0 dc=0
alter Vh0 dc=0
alter Vs1 dc=0
alter Vh1 dc=0
alter Vs2 dc=0
alter Vh2 dc=0
alter Vs3 dc=1.2
alter Vh3 dc=1.2
alter Vs4 dc=0
alter Vh4 dc=0
alter Vs5 dc=1.2
alter Vh5 dc=1.2
alter Vs6 dc=1.2
alter Vh6 dc=1.2
alter Vs7 dc=0
alter Vh7 dc=0
op
echo ROW 2 25.0 104 $&v(xt.vth_soft) $&v(xt.vth_hard) $&v(vref_buf) $&v(isense) $&i(vdda)
alter Vs0 dc=1.2
alter Vh0 dc=1.2
alter Vs1 dc=0
alter Vh1 dc=0
alter Vs2 dc=0
alter Vh2 dc=0
alter Vs3 dc=1.2
alter Vh3 dc=1.2
alter Vs4 dc=0
alter Vh4 dc=0
alter Vs5 dc=1.2
alter Vh5 dc=1.2
alter Vs6 dc=1.2
alter Vh6 dc=1.2
alter Vs7 dc=0
alter Vh7 dc=0
op
echo ROW 2 25.0 105 $&v(xt.vth_soft) $&v(xt.vth_hard) $&v(vref_buf) $&v(isense) $&i(vdda)
alter Vs0 dc=0
alter Vh0 dc=0
alter Vs1 dc=1.2
alter Vh1 dc=1.2
alter Vs2 dc=0
alter Vh2 dc=0
alter Vs3 dc=1.2
alter Vh3 dc=1.2
alter Vs4 dc=0
alter Vh4 dc=0
alter Vs5 dc=1.2
alter Vh5 dc=1.2
alter Vs6 dc=1.2
alter Vh6 dc=1.2
alter Vs7 dc=0
alter Vh7 dc=0
op
echo ROW 2 25.0 106 $&v(xt.vth_soft) $&v(xt.vth_hard) $&v(vref_buf) $&v(isense) $&i(vdda)
alter Vs0 dc=1.2
alter Vh0 dc=1.2
alter Vs1 dc=1.2
alter Vh1 dc=1.2
alter Vs2 dc=0
alter Vh2 dc=0
alter Vs3 dc=1.2
alter Vh3 dc=1.2
alter Vs4 dc=0
alter Vh4 dc=0
alter Vs5 dc=1.2
alter Vh5 dc=1.2
alter Vs6 dc=1.2
alter Vh6 dc=1.2
alter Vs7 dc=0
alter Vh7 dc=0
op
echo ROW 2 25.0 107 $&v(xt.vth_soft) $&v(xt.vth_hard) $&v(vref_buf) $&v(isense) $&i(vdda)
alter Vs0 dc=0
alter Vh0 dc=0
alter Vs1 dc=0
alter Vh1 dc=0
alter Vs2 dc=1.2
alter Vh2 dc=1.2
alter Vs3 dc=1.2
alter Vh3 dc=1.2
alter Vs4 dc=0
alter Vh4 dc=0
alter Vs5 dc=1.2
alter Vh5 dc=1.2
alter Vs6 dc=1.2
alter Vh6 dc=1.2
alter Vs7 dc=0
alter Vh7 dc=0
op
echo ROW 2 25.0 108 $&v(xt.vth_soft) $&v(xt.vth_hard) $&v(vref_buf) $&v(isense) $&i(vdda)
alter Vs0 dc=1.2
alter Vh0 dc=1.2
alter Vs1 dc=0
alter Vh1 dc=0
alter Vs2 dc=1.2
alter Vh2 dc=1.2
alter Vs3 dc=1.2
alter Vh3 dc=1.2
alter Vs4 dc=0
alter Vh4 dc=0
alter Vs5 dc=1.2
alter Vh5 dc=1.2
alter Vs6 dc=1.2
alter Vh6 dc=1.2
alter Vs7 dc=0
alter Vh7 dc=0
op
echo ROW 2 25.0 109 $&v(xt.vth_soft) $&v(xt.vth_hard) $&v(vref_buf) $&v(isense) $&i(vdda)
alter Vs0 dc=0
alter Vh0 dc=0
alter Vs1 dc=1.2
alter Vh1 dc=1.2
alter Vs2 dc=1.2
alter Vh2 dc=1.2
alter Vs3 dc=1.2
alter Vh3 dc=1.2
alter Vs4 dc=0
alter Vh4 dc=0
alter Vs5 dc=1.2
alter Vh5 dc=1.2
alter Vs6 dc=1.2
alter Vh6 dc=1.2
alter Vs7 dc=0
alter Vh7 dc=0
op
echo ROW 2 25.0 110 $&v(xt.vth_soft) $&v(xt.vth_hard) $&v(vref_buf) $&v(isense) $&i(vdda)
alter Vs0 dc=1.2
alter Vh0 dc=1.2
alter Vs1 dc=1.2
alter Vh1 dc=1.2
alter Vs2 dc=1.2
alter Vh2 dc=1.2
alter Vs3 dc=1.2
alter Vh3 dc=1.2
alter Vs4 dc=0
alter Vh4 dc=0
alter Vs5 dc=1.2
alter Vh5 dc=1.2
alter Vs6 dc=1.2
alter Vh6 dc=1.2
alter Vs7 dc=0
alter Vh7 dc=0
op
echo ROW 2 25.0 111 $&v(xt.vth_soft) $&v(xt.vth_hard) $&v(vref_buf) $&v(isense) $&i(vdda)
alter Vs0 dc=0
alter Vh0 dc=0
alter Vs1 dc=0
alter Vh1 dc=0
alter Vs2 dc=0
alter Vh2 dc=0
alter Vs3 dc=0
alter Vh3 dc=0
alter Vs4 dc=1.2
alter Vh4 dc=1.2
alter Vs5 dc=1.2
alter Vh5 dc=1.2
alter Vs6 dc=1.2
alter Vh6 dc=1.2
alter Vs7 dc=0
alter Vh7 dc=0
op
echo ROW 2 25.0 112 $&v(xt.vth_soft) $&v(xt.vth_hard) $&v(vref_buf) $&v(isense) $&i(vdda)
alter Vs0 dc=1.2
alter Vh0 dc=1.2
alter Vs1 dc=0
alter Vh1 dc=0
alter Vs2 dc=0
alter Vh2 dc=0
alter Vs3 dc=0
alter Vh3 dc=0
alter Vs4 dc=1.2
alter Vh4 dc=1.2
alter Vs5 dc=1.2
alter Vh5 dc=1.2
alter Vs6 dc=1.2
alter Vh6 dc=1.2
alter Vs7 dc=0
alter Vh7 dc=0
op
echo ROW 2 25.0 113 $&v(xt.vth_soft) $&v(xt.vth_hard) $&v(vref_buf) $&v(isense) $&i(vdda)
alter Vs0 dc=0
alter Vh0 dc=0
alter Vs1 dc=1.2
alter Vh1 dc=1.2
alter Vs2 dc=0
alter Vh2 dc=0
alter Vs3 dc=0
alter Vh3 dc=0
alter Vs4 dc=1.2
alter Vh4 dc=1.2
alter Vs5 dc=1.2
alter Vh5 dc=1.2
alter Vs6 dc=1.2
alter Vh6 dc=1.2
alter Vs7 dc=0
alter Vh7 dc=0
op
echo ROW 2 25.0 114 $&v(xt.vth_soft) $&v(xt.vth_hard) $&v(vref_buf) $&v(isense) $&i(vdda)
alter Vs0 dc=1.2
alter Vh0 dc=1.2
alter Vs1 dc=1.2
alter Vh1 dc=1.2
alter Vs2 dc=0
alter Vh2 dc=0
alter Vs3 dc=0
alter Vh3 dc=0
alter Vs4 dc=1.2
alter Vh4 dc=1.2
alter Vs5 dc=1.2
alter Vh5 dc=1.2
alter Vs6 dc=1.2
alter Vh6 dc=1.2
alter Vs7 dc=0
alter Vh7 dc=0
op
echo ROW 2 25.0 115 $&v(xt.vth_soft) $&v(xt.vth_hard) $&v(vref_buf) $&v(isense) $&i(vdda)
alter Vs0 dc=0
alter Vh0 dc=0
alter Vs1 dc=0
alter Vh1 dc=0
alter Vs2 dc=1.2
alter Vh2 dc=1.2
alter Vs3 dc=0
alter Vh3 dc=0
alter Vs4 dc=1.2
alter Vh4 dc=1.2
alter Vs5 dc=1.2
alter Vh5 dc=1.2
alter Vs6 dc=1.2
alter Vh6 dc=1.2
alter Vs7 dc=0
alter Vh7 dc=0
op
echo ROW 2 25.0 116 $&v(xt.vth_soft) $&v(xt.vth_hard) $&v(vref_buf) $&v(isense) $&i(vdda)
alter Vs0 dc=1.2
alter Vh0 dc=1.2
alter Vs1 dc=0
alter Vh1 dc=0
alter Vs2 dc=1.2
alter Vh2 dc=1.2
alter Vs3 dc=0
alter Vh3 dc=0
alter Vs4 dc=1.2
alter Vh4 dc=1.2
alter Vs5 dc=1.2
alter Vh5 dc=1.2
alter Vs6 dc=1.2
alter Vh6 dc=1.2
alter Vs7 dc=0
alter Vh7 dc=0
op
echo ROW 2 25.0 117 $&v(xt.vth_soft) $&v(xt.vth_hard) $&v(vref_buf) $&v(isense) $&i(vdda)
alter Vs0 dc=0
alter Vh0 dc=0
alter Vs1 dc=1.2
alter Vh1 dc=1.2
alter Vs2 dc=1.2
alter Vh2 dc=1.2
alter Vs3 dc=0
alter Vh3 dc=0
alter Vs4 dc=1.2
alter Vh4 dc=1.2
alter Vs5 dc=1.2
alter Vh5 dc=1.2
alter Vs6 dc=1.2
alter Vh6 dc=1.2
alter Vs7 dc=0
alter Vh7 dc=0
op
echo ROW 2 25.0 118 $&v(xt.vth_soft) $&v(xt.vth_hard) $&v(vref_buf) $&v(isense) $&i(vdda)
alter Vs0 dc=1.2
alter Vh0 dc=1.2
alter Vs1 dc=1.2
alter Vh1 dc=1.2
alter Vs2 dc=1.2
alter Vh2 dc=1.2
alter Vs3 dc=0
alter Vh3 dc=0
alter Vs4 dc=1.2
alter Vh4 dc=1.2
alter Vs5 dc=1.2
alter Vh5 dc=1.2
alter Vs6 dc=1.2
alter Vh6 dc=1.2
alter Vs7 dc=0
alter Vh7 dc=0
op
echo ROW 2 25.0 119 $&v(xt.vth_soft) $&v(xt.vth_hard) $&v(vref_buf) $&v(isense) $&i(vdda)
alter Vs0 dc=0
alter Vh0 dc=0
alter Vs1 dc=0
alter Vh1 dc=0
alter Vs2 dc=0
alter Vh2 dc=0
alter Vs3 dc=1.2
alter Vh3 dc=1.2
alter Vs4 dc=1.2
alter Vh4 dc=1.2
alter Vs5 dc=1.2
alter Vh5 dc=1.2
alter Vs6 dc=1.2
alter Vh6 dc=1.2
alter Vs7 dc=0
alter Vh7 dc=0
op
echo ROW 2 25.0 120 $&v(xt.vth_soft) $&v(xt.vth_hard) $&v(vref_buf) $&v(isense) $&i(vdda)
alter Vs0 dc=1.2
alter Vh0 dc=1.2
alter Vs1 dc=0
alter Vh1 dc=0
alter Vs2 dc=0
alter Vh2 dc=0
alter Vs3 dc=1.2
alter Vh3 dc=1.2
alter Vs4 dc=1.2
alter Vh4 dc=1.2
alter Vs5 dc=1.2
alter Vh5 dc=1.2
alter Vs6 dc=1.2
alter Vh6 dc=1.2
alter Vs7 dc=0
alter Vh7 dc=0
op
echo ROW 2 25.0 121 $&v(xt.vth_soft) $&v(xt.vth_hard) $&v(vref_buf) $&v(isense) $&i(vdda)
alter Vs0 dc=0
alter Vh0 dc=0
alter Vs1 dc=1.2
alter Vh1 dc=1.2
alter Vs2 dc=0
alter Vh2 dc=0
alter Vs3 dc=1.2
alter Vh3 dc=1.2
alter Vs4 dc=1.2
alter Vh4 dc=1.2
alter Vs5 dc=1.2
alter Vh5 dc=1.2
alter Vs6 dc=1.2
alter Vh6 dc=1.2
alter Vs7 dc=0
alter Vh7 dc=0
op
echo ROW 2 25.0 122 $&v(xt.vth_soft) $&v(xt.vth_hard) $&v(vref_buf) $&v(isense) $&i(vdda)
alter Vs0 dc=1.2
alter Vh0 dc=1.2
alter Vs1 dc=1.2
alter Vh1 dc=1.2
alter Vs2 dc=0
alter Vh2 dc=0
alter Vs3 dc=1.2
alter Vh3 dc=1.2
alter Vs4 dc=1.2
alter Vh4 dc=1.2
alter Vs5 dc=1.2
alter Vh5 dc=1.2
alter Vs6 dc=1.2
alter Vh6 dc=1.2
alter Vs7 dc=0
alter Vh7 dc=0
op
echo ROW 2 25.0 123 $&v(xt.vth_soft) $&v(xt.vth_hard) $&v(vref_buf) $&v(isense) $&i(vdda)
alter Vs0 dc=0
alter Vh0 dc=0
alter Vs1 dc=0
alter Vh1 dc=0
alter Vs2 dc=1.2
alter Vh2 dc=1.2
alter Vs3 dc=1.2
alter Vh3 dc=1.2
alter Vs4 dc=1.2
alter Vh4 dc=1.2
alter Vs5 dc=1.2
alter Vh5 dc=1.2
alter Vs6 dc=1.2
alter Vh6 dc=1.2
alter Vs7 dc=0
alter Vh7 dc=0
op
echo ROW 2 25.0 124 $&v(xt.vth_soft) $&v(xt.vth_hard) $&v(vref_buf) $&v(isense) $&i(vdda)
alter Vs0 dc=1.2
alter Vh0 dc=1.2
alter Vs1 dc=0
alter Vh1 dc=0
alter Vs2 dc=1.2
alter Vh2 dc=1.2
alter Vs3 dc=1.2
alter Vh3 dc=1.2
alter Vs4 dc=1.2
alter Vh4 dc=1.2
alter Vs5 dc=1.2
alter Vh5 dc=1.2
alter Vs6 dc=1.2
alter Vh6 dc=1.2
alter Vs7 dc=0
alter Vh7 dc=0
op
echo ROW 2 25.0 125 $&v(xt.vth_soft) $&v(xt.vth_hard) $&v(vref_buf) $&v(isense) $&i(vdda)
alter Vs0 dc=0
alter Vh0 dc=0
alter Vs1 dc=1.2
alter Vh1 dc=1.2
alter Vs2 dc=1.2
alter Vh2 dc=1.2
alter Vs3 dc=1.2
alter Vh3 dc=1.2
alter Vs4 dc=1.2
alter Vh4 dc=1.2
alter Vs5 dc=1.2
alter Vh5 dc=1.2
alter Vs6 dc=1.2
alter Vh6 dc=1.2
alter Vs7 dc=0
alter Vh7 dc=0
op
echo ROW 2 25.0 126 $&v(xt.vth_soft) $&v(xt.vth_hard) $&v(vref_buf) $&v(isense) $&i(vdda)
alter Vs0 dc=1.2
alter Vh0 dc=1.2
alter Vs1 dc=1.2
alter Vh1 dc=1.2
alter Vs2 dc=1.2
alter Vh2 dc=1.2
alter Vs3 dc=1.2
alter Vh3 dc=1.2
alter Vs4 dc=1.2
alter Vh4 dc=1.2
alter Vs5 dc=1.2
alter Vh5 dc=1.2
alter Vs6 dc=1.2
alter Vh6 dc=1.2
alter Vs7 dc=0
alter Vh7 dc=0
op
echo ROW 2 25.0 127 $&v(xt.vth_soft) $&v(xt.vth_hard) $&v(vref_buf) $&v(isense) $&i(vdda)
alter Vs0 dc=0
alter Vh0 dc=0
alter Vs1 dc=0
alter Vh1 dc=0
alter Vs2 dc=0
alter Vh2 dc=0
alter Vs3 dc=0
alter Vh3 dc=0
alter Vs4 dc=0
alter Vh4 dc=0
alter Vs5 dc=0
alter Vh5 dc=0
alter Vs6 dc=0
alter Vh6 dc=0
alter Vs7 dc=1.2
alter Vh7 dc=1.2
op
echo ROW 2 25.0 128 $&v(xt.vth_soft) $&v(xt.vth_hard) $&v(vref_buf) $&v(isense) $&i(vdda)
alter Vs0 dc=1.2
alter Vh0 dc=1.2
alter Vs1 dc=0
alter Vh1 dc=0
alter Vs2 dc=0
alter Vh2 dc=0
alter Vs3 dc=0
alter Vh3 dc=0
alter Vs4 dc=0
alter Vh4 dc=0
alter Vs5 dc=0
alter Vh5 dc=0
alter Vs6 dc=0
alter Vh6 dc=0
alter Vs7 dc=1.2
alter Vh7 dc=1.2
op
echo ROW 2 25.0 129 $&v(xt.vth_soft) $&v(xt.vth_hard) $&v(vref_buf) $&v(isense) $&i(vdda)
alter Vs0 dc=0
alter Vh0 dc=0
alter Vs1 dc=1.2
alter Vh1 dc=1.2
alter Vs2 dc=0
alter Vh2 dc=0
alter Vs3 dc=0
alter Vh3 dc=0
alter Vs4 dc=0
alter Vh4 dc=0
alter Vs5 dc=0
alter Vh5 dc=0
alter Vs6 dc=0
alter Vh6 dc=0
alter Vs7 dc=1.2
alter Vh7 dc=1.2
op
echo ROW 2 25.0 130 $&v(xt.vth_soft) $&v(xt.vth_hard) $&v(vref_buf) $&v(isense) $&i(vdda)
alter Vs0 dc=1.2
alter Vh0 dc=1.2
alter Vs1 dc=1.2
alter Vh1 dc=1.2
alter Vs2 dc=0
alter Vh2 dc=0
alter Vs3 dc=0
alter Vh3 dc=0
alter Vs4 dc=0
alter Vh4 dc=0
alter Vs5 dc=0
alter Vh5 dc=0
alter Vs6 dc=0
alter Vh6 dc=0
alter Vs7 dc=1.2
alter Vh7 dc=1.2
op
echo ROW 2 25.0 131 $&v(xt.vth_soft) $&v(xt.vth_hard) $&v(vref_buf) $&v(isense) $&i(vdda)
alter Vs0 dc=0
alter Vh0 dc=0
alter Vs1 dc=0
alter Vh1 dc=0
alter Vs2 dc=1.2
alter Vh2 dc=1.2
alter Vs3 dc=0
alter Vh3 dc=0
alter Vs4 dc=0
alter Vh4 dc=0
alter Vs5 dc=0
alter Vh5 dc=0
alter Vs6 dc=0
alter Vh6 dc=0
alter Vs7 dc=1.2
alter Vh7 dc=1.2
op
echo ROW 2 25.0 132 $&v(xt.vth_soft) $&v(xt.vth_hard) $&v(vref_buf) $&v(isense) $&i(vdda)
alter Vs0 dc=1.2
alter Vh0 dc=1.2
alter Vs1 dc=0
alter Vh1 dc=0
alter Vs2 dc=1.2
alter Vh2 dc=1.2
alter Vs3 dc=0
alter Vh3 dc=0
alter Vs4 dc=0
alter Vh4 dc=0
alter Vs5 dc=0
alter Vh5 dc=0
alter Vs6 dc=0
alter Vh6 dc=0
alter Vs7 dc=1.2
alter Vh7 dc=1.2
op
echo ROW 2 25.0 133 $&v(xt.vth_soft) $&v(xt.vth_hard) $&v(vref_buf) $&v(isense) $&i(vdda)
alter Vs0 dc=0
alter Vh0 dc=0
alter Vs1 dc=1.2
alter Vh1 dc=1.2
alter Vs2 dc=1.2
alter Vh2 dc=1.2
alter Vs3 dc=0
alter Vh3 dc=0
alter Vs4 dc=0
alter Vh4 dc=0
alter Vs5 dc=0
alter Vh5 dc=0
alter Vs6 dc=0
alter Vh6 dc=0
alter Vs7 dc=1.2
alter Vh7 dc=1.2
op
echo ROW 2 25.0 134 $&v(xt.vth_soft) $&v(xt.vth_hard) $&v(vref_buf) $&v(isense) $&i(vdda)
alter Vs0 dc=1.2
alter Vh0 dc=1.2
alter Vs1 dc=1.2
alter Vh1 dc=1.2
alter Vs2 dc=1.2
alter Vh2 dc=1.2
alter Vs3 dc=0
alter Vh3 dc=0
alter Vs4 dc=0
alter Vh4 dc=0
alter Vs5 dc=0
alter Vh5 dc=0
alter Vs6 dc=0
alter Vh6 dc=0
alter Vs7 dc=1.2
alter Vh7 dc=1.2
op
echo ROW 2 25.0 135 $&v(xt.vth_soft) $&v(xt.vth_hard) $&v(vref_buf) $&v(isense) $&i(vdda)
alter Vs0 dc=0
alter Vh0 dc=0
alter Vs1 dc=0
alter Vh1 dc=0
alter Vs2 dc=0
alter Vh2 dc=0
alter Vs3 dc=1.2
alter Vh3 dc=1.2
alter Vs4 dc=0
alter Vh4 dc=0
alter Vs5 dc=0
alter Vh5 dc=0
alter Vs6 dc=0
alter Vh6 dc=0
alter Vs7 dc=1.2
alter Vh7 dc=1.2
op
echo ROW 2 25.0 136 $&v(xt.vth_soft) $&v(xt.vth_hard) $&v(vref_buf) $&v(isense) $&i(vdda)
alter Vs0 dc=1.2
alter Vh0 dc=1.2
alter Vs1 dc=0
alter Vh1 dc=0
alter Vs2 dc=0
alter Vh2 dc=0
alter Vs3 dc=1.2
alter Vh3 dc=1.2
alter Vs4 dc=0
alter Vh4 dc=0
alter Vs5 dc=0
alter Vh5 dc=0
alter Vs6 dc=0
alter Vh6 dc=0
alter Vs7 dc=1.2
alter Vh7 dc=1.2
op
echo ROW 2 25.0 137 $&v(xt.vth_soft) $&v(xt.vth_hard) $&v(vref_buf) $&v(isense) $&i(vdda)
alter Vs0 dc=0
alter Vh0 dc=0
alter Vs1 dc=1.2
alter Vh1 dc=1.2
alter Vs2 dc=0
alter Vh2 dc=0
alter Vs3 dc=1.2
alter Vh3 dc=1.2
alter Vs4 dc=0
alter Vh4 dc=0
alter Vs5 dc=0
alter Vh5 dc=0
alter Vs6 dc=0
alter Vh6 dc=0
alter Vs7 dc=1.2
alter Vh7 dc=1.2
op
echo ROW 2 25.0 138 $&v(xt.vth_soft) $&v(xt.vth_hard) $&v(vref_buf) $&v(isense) $&i(vdda)
alter Vs0 dc=1.2
alter Vh0 dc=1.2
alter Vs1 dc=1.2
alter Vh1 dc=1.2
alter Vs2 dc=0
alter Vh2 dc=0
alter Vs3 dc=1.2
alter Vh3 dc=1.2
alter Vs4 dc=0
alter Vh4 dc=0
alter Vs5 dc=0
alter Vh5 dc=0
alter Vs6 dc=0
alter Vh6 dc=0
alter Vs7 dc=1.2
alter Vh7 dc=1.2
op
echo ROW 2 25.0 139 $&v(xt.vth_soft) $&v(xt.vth_hard) $&v(vref_buf) $&v(isense) $&i(vdda)
alter Vs0 dc=0
alter Vh0 dc=0
alter Vs1 dc=0
alter Vh1 dc=0
alter Vs2 dc=1.2
alter Vh2 dc=1.2
alter Vs3 dc=1.2
alter Vh3 dc=1.2
alter Vs4 dc=0
alter Vh4 dc=0
alter Vs5 dc=0
alter Vh5 dc=0
alter Vs6 dc=0
alter Vh6 dc=0
alter Vs7 dc=1.2
alter Vh7 dc=1.2
op
echo ROW 2 25.0 140 $&v(xt.vth_soft) $&v(xt.vth_hard) $&v(vref_buf) $&v(isense) $&i(vdda)
alter Vs0 dc=1.2
alter Vh0 dc=1.2
alter Vs1 dc=0
alter Vh1 dc=0
alter Vs2 dc=1.2
alter Vh2 dc=1.2
alter Vs3 dc=1.2
alter Vh3 dc=1.2
alter Vs4 dc=0
alter Vh4 dc=0
alter Vs5 dc=0
alter Vh5 dc=0
alter Vs6 dc=0
alter Vh6 dc=0
alter Vs7 dc=1.2
alter Vh7 dc=1.2
op
echo ROW 2 25.0 141 $&v(xt.vth_soft) $&v(xt.vth_hard) $&v(vref_buf) $&v(isense) $&i(vdda)
alter Vs0 dc=0
alter Vh0 dc=0
alter Vs1 dc=1.2
alter Vh1 dc=1.2
alter Vs2 dc=1.2
alter Vh2 dc=1.2
alter Vs3 dc=1.2
alter Vh3 dc=1.2
alter Vs4 dc=0
alter Vh4 dc=0
alter Vs5 dc=0
alter Vh5 dc=0
alter Vs6 dc=0
alter Vh6 dc=0
alter Vs7 dc=1.2
alter Vh7 dc=1.2
op
echo ROW 2 25.0 142 $&v(xt.vth_soft) $&v(xt.vth_hard) $&v(vref_buf) $&v(isense) $&i(vdda)
alter Vs0 dc=1.2
alter Vh0 dc=1.2
alter Vs1 dc=1.2
alter Vh1 dc=1.2
alter Vs2 dc=1.2
alter Vh2 dc=1.2
alter Vs3 dc=1.2
alter Vh3 dc=1.2
alter Vs4 dc=0
alter Vh4 dc=0
alter Vs5 dc=0
alter Vh5 dc=0
alter Vs6 dc=0
alter Vh6 dc=0
alter Vs7 dc=1.2
alter Vh7 dc=1.2
op
echo ROW 2 25.0 143 $&v(xt.vth_soft) $&v(xt.vth_hard) $&v(vref_buf) $&v(isense) $&i(vdda)
alter Vs0 dc=0
alter Vh0 dc=0
alter Vs1 dc=0
alter Vh1 dc=0
alter Vs2 dc=0
alter Vh2 dc=0
alter Vs3 dc=0
alter Vh3 dc=0
alter Vs4 dc=1.2
alter Vh4 dc=1.2
alter Vs5 dc=0
alter Vh5 dc=0
alter Vs6 dc=0
alter Vh6 dc=0
alter Vs7 dc=1.2
alter Vh7 dc=1.2
op
echo ROW 2 25.0 144 $&v(xt.vth_soft) $&v(xt.vth_hard) $&v(vref_buf) $&v(isense) $&i(vdda)
alter Vs0 dc=1.2
alter Vh0 dc=1.2
alter Vs1 dc=0
alter Vh1 dc=0
alter Vs2 dc=0
alter Vh2 dc=0
alter Vs3 dc=0
alter Vh3 dc=0
alter Vs4 dc=1.2
alter Vh4 dc=1.2
alter Vs5 dc=0
alter Vh5 dc=0
alter Vs6 dc=0
alter Vh6 dc=0
alter Vs7 dc=1.2
alter Vh7 dc=1.2
op
echo ROW 2 25.0 145 $&v(xt.vth_soft) $&v(xt.vth_hard) $&v(vref_buf) $&v(isense) $&i(vdda)
alter Vs0 dc=0
alter Vh0 dc=0
alter Vs1 dc=1.2
alter Vh1 dc=1.2
alter Vs2 dc=0
alter Vh2 dc=0
alter Vs3 dc=0
alter Vh3 dc=0
alter Vs4 dc=1.2
alter Vh4 dc=1.2
alter Vs5 dc=0
alter Vh5 dc=0
alter Vs6 dc=0
alter Vh6 dc=0
alter Vs7 dc=1.2
alter Vh7 dc=1.2
op
echo ROW 2 25.0 146 $&v(xt.vth_soft) $&v(xt.vth_hard) $&v(vref_buf) $&v(isense) $&i(vdda)
alter Vs0 dc=1.2
alter Vh0 dc=1.2
alter Vs1 dc=1.2
alter Vh1 dc=1.2
alter Vs2 dc=0
alter Vh2 dc=0
alter Vs3 dc=0
alter Vh3 dc=0
alter Vs4 dc=1.2
alter Vh4 dc=1.2
alter Vs5 dc=0
alter Vh5 dc=0
alter Vs6 dc=0
alter Vh6 dc=0
alter Vs7 dc=1.2
alter Vh7 dc=1.2
op
echo ROW 2 25.0 147 $&v(xt.vth_soft) $&v(xt.vth_hard) $&v(vref_buf) $&v(isense) $&i(vdda)
alter Vs0 dc=0
alter Vh0 dc=0
alter Vs1 dc=0
alter Vh1 dc=0
alter Vs2 dc=1.2
alter Vh2 dc=1.2
alter Vs3 dc=0
alter Vh3 dc=0
alter Vs4 dc=1.2
alter Vh4 dc=1.2
alter Vs5 dc=0
alter Vh5 dc=0
alter Vs6 dc=0
alter Vh6 dc=0
alter Vs7 dc=1.2
alter Vh7 dc=1.2
op
echo ROW 2 25.0 148 $&v(xt.vth_soft) $&v(xt.vth_hard) $&v(vref_buf) $&v(isense) $&i(vdda)
alter Vs0 dc=1.2
alter Vh0 dc=1.2
alter Vs1 dc=0
alter Vh1 dc=0
alter Vs2 dc=1.2
alter Vh2 dc=1.2
alter Vs3 dc=0
alter Vh3 dc=0
alter Vs4 dc=1.2
alter Vh4 dc=1.2
alter Vs5 dc=0
alter Vh5 dc=0
alter Vs6 dc=0
alter Vh6 dc=0
alter Vs7 dc=1.2
alter Vh7 dc=1.2
op
echo ROW 2 25.0 149 $&v(xt.vth_soft) $&v(xt.vth_hard) $&v(vref_buf) $&v(isense) $&i(vdda)
alter Vs0 dc=0
alter Vh0 dc=0
alter Vs1 dc=1.2
alter Vh1 dc=1.2
alter Vs2 dc=1.2
alter Vh2 dc=1.2
alter Vs3 dc=0
alter Vh3 dc=0
alter Vs4 dc=1.2
alter Vh4 dc=1.2
alter Vs5 dc=0
alter Vh5 dc=0
alter Vs6 dc=0
alter Vh6 dc=0
alter Vs7 dc=1.2
alter Vh7 dc=1.2
op
echo ROW 2 25.0 150 $&v(xt.vth_soft) $&v(xt.vth_hard) $&v(vref_buf) $&v(isense) $&i(vdda)
alter Vs0 dc=1.2
alter Vh0 dc=1.2
alter Vs1 dc=1.2
alter Vh1 dc=1.2
alter Vs2 dc=1.2
alter Vh2 dc=1.2
alter Vs3 dc=0
alter Vh3 dc=0
alter Vs4 dc=1.2
alter Vh4 dc=1.2
alter Vs5 dc=0
alter Vh5 dc=0
alter Vs6 dc=0
alter Vh6 dc=0
alter Vs7 dc=1.2
alter Vh7 dc=1.2
op
echo ROW 2 25.0 151 $&v(xt.vth_soft) $&v(xt.vth_hard) $&v(vref_buf) $&v(isense) $&i(vdda)
alter Vs0 dc=0
alter Vh0 dc=0
alter Vs1 dc=0
alter Vh1 dc=0
alter Vs2 dc=0
alter Vh2 dc=0
alter Vs3 dc=1.2
alter Vh3 dc=1.2
alter Vs4 dc=1.2
alter Vh4 dc=1.2
alter Vs5 dc=0
alter Vh5 dc=0
alter Vs6 dc=0
alter Vh6 dc=0
alter Vs7 dc=1.2
alter Vh7 dc=1.2
op
echo ROW 2 25.0 152 $&v(xt.vth_soft) $&v(xt.vth_hard) $&v(vref_buf) $&v(isense) $&i(vdda)
alter Vs0 dc=1.2
alter Vh0 dc=1.2
alter Vs1 dc=0
alter Vh1 dc=0
alter Vs2 dc=0
alter Vh2 dc=0
alter Vs3 dc=1.2
alter Vh3 dc=1.2
alter Vs4 dc=1.2
alter Vh4 dc=1.2
alter Vs5 dc=0
alter Vh5 dc=0
alter Vs6 dc=0
alter Vh6 dc=0
alter Vs7 dc=1.2
alter Vh7 dc=1.2
op
echo ROW 2 25.0 153 $&v(xt.vth_soft) $&v(xt.vth_hard) $&v(vref_buf) $&v(isense) $&i(vdda)
alter Vs0 dc=0
alter Vh0 dc=0
alter Vs1 dc=1.2
alter Vh1 dc=1.2
alter Vs2 dc=0
alter Vh2 dc=0
alter Vs3 dc=1.2
alter Vh3 dc=1.2
alter Vs4 dc=1.2
alter Vh4 dc=1.2
alter Vs5 dc=0
alter Vh5 dc=0
alter Vs6 dc=0
alter Vh6 dc=0
alter Vs7 dc=1.2
alter Vh7 dc=1.2
op
echo ROW 2 25.0 154 $&v(xt.vth_soft) $&v(xt.vth_hard) $&v(vref_buf) $&v(isense) $&i(vdda)
alter Vs0 dc=1.2
alter Vh0 dc=1.2
alter Vs1 dc=1.2
alter Vh1 dc=1.2
alter Vs2 dc=0
alter Vh2 dc=0
alter Vs3 dc=1.2
alter Vh3 dc=1.2
alter Vs4 dc=1.2
alter Vh4 dc=1.2
alter Vs5 dc=0
alter Vh5 dc=0
alter Vs6 dc=0
alter Vh6 dc=0
alter Vs7 dc=1.2
alter Vh7 dc=1.2
op
echo ROW 2 25.0 155 $&v(xt.vth_soft) $&v(xt.vth_hard) $&v(vref_buf) $&v(isense) $&i(vdda)
alter Vs0 dc=0
alter Vh0 dc=0
alter Vs1 dc=0
alter Vh1 dc=0
alter Vs2 dc=1.2
alter Vh2 dc=1.2
alter Vs3 dc=1.2
alter Vh3 dc=1.2
alter Vs4 dc=1.2
alter Vh4 dc=1.2
alter Vs5 dc=0
alter Vh5 dc=0
alter Vs6 dc=0
alter Vh6 dc=0
alter Vs7 dc=1.2
alter Vh7 dc=1.2
op
echo ROW 2 25.0 156 $&v(xt.vth_soft) $&v(xt.vth_hard) $&v(vref_buf) $&v(isense) $&i(vdda)
alter Vs0 dc=1.2
alter Vh0 dc=1.2
alter Vs1 dc=0
alter Vh1 dc=0
alter Vs2 dc=1.2
alter Vh2 dc=1.2
alter Vs3 dc=1.2
alter Vh3 dc=1.2
alter Vs4 dc=1.2
alter Vh4 dc=1.2
alter Vs5 dc=0
alter Vh5 dc=0
alter Vs6 dc=0
alter Vh6 dc=0
alter Vs7 dc=1.2
alter Vh7 dc=1.2
op
echo ROW 2 25.0 157 $&v(xt.vth_soft) $&v(xt.vth_hard) $&v(vref_buf) $&v(isense) $&i(vdda)
alter Vs0 dc=0
alter Vh0 dc=0
alter Vs1 dc=1.2
alter Vh1 dc=1.2
alter Vs2 dc=1.2
alter Vh2 dc=1.2
alter Vs3 dc=1.2
alter Vh3 dc=1.2
alter Vs4 dc=1.2
alter Vh4 dc=1.2
alter Vs5 dc=0
alter Vh5 dc=0
alter Vs6 dc=0
alter Vh6 dc=0
alter Vs7 dc=1.2
alter Vh7 dc=1.2
op
echo ROW 2 25.0 158 $&v(xt.vth_soft) $&v(xt.vth_hard) $&v(vref_buf) $&v(isense) $&i(vdda)
alter Vs0 dc=1.2
alter Vh0 dc=1.2
alter Vs1 dc=1.2
alter Vh1 dc=1.2
alter Vs2 dc=1.2
alter Vh2 dc=1.2
alter Vs3 dc=1.2
alter Vh3 dc=1.2
alter Vs4 dc=1.2
alter Vh4 dc=1.2
alter Vs5 dc=0
alter Vh5 dc=0
alter Vs6 dc=0
alter Vh6 dc=0
alter Vs7 dc=1.2
alter Vh7 dc=1.2
op
echo ROW 2 25.0 159 $&v(xt.vth_soft) $&v(xt.vth_hard) $&v(vref_buf) $&v(isense) $&i(vdda)
alter Vs0 dc=0
alter Vh0 dc=0
alter Vs1 dc=0
alter Vh1 dc=0
alter Vs2 dc=0
alter Vh2 dc=0
alter Vs3 dc=0
alter Vh3 dc=0
alter Vs4 dc=0
alter Vh4 dc=0
alter Vs5 dc=1.2
alter Vh5 dc=1.2
alter Vs6 dc=0
alter Vh6 dc=0
alter Vs7 dc=1.2
alter Vh7 dc=1.2
op
echo ROW 2 25.0 160 $&v(xt.vth_soft) $&v(xt.vth_hard) $&v(vref_buf) $&v(isense) $&i(vdda)
alter Vs0 dc=1.2
alter Vh0 dc=1.2
alter Vs1 dc=0
alter Vh1 dc=0
alter Vs2 dc=0
alter Vh2 dc=0
alter Vs3 dc=0
alter Vh3 dc=0
alter Vs4 dc=0
alter Vh4 dc=0
alter Vs5 dc=1.2
alter Vh5 dc=1.2
alter Vs6 dc=0
alter Vh6 dc=0
alter Vs7 dc=1.2
alter Vh7 dc=1.2
op
echo ROW 2 25.0 161 $&v(xt.vth_soft) $&v(xt.vth_hard) $&v(vref_buf) $&v(isense) $&i(vdda)
alter Vs0 dc=0
alter Vh0 dc=0
alter Vs1 dc=1.2
alter Vh1 dc=1.2
alter Vs2 dc=0
alter Vh2 dc=0
alter Vs3 dc=0
alter Vh3 dc=0
alter Vs4 dc=0
alter Vh4 dc=0
alter Vs5 dc=1.2
alter Vh5 dc=1.2
alter Vs6 dc=0
alter Vh6 dc=0
alter Vs7 dc=1.2
alter Vh7 dc=1.2
op
echo ROW 2 25.0 162 $&v(xt.vth_soft) $&v(xt.vth_hard) $&v(vref_buf) $&v(isense) $&i(vdda)
alter Vs0 dc=1.2
alter Vh0 dc=1.2
alter Vs1 dc=1.2
alter Vh1 dc=1.2
alter Vs2 dc=0
alter Vh2 dc=0
alter Vs3 dc=0
alter Vh3 dc=0
alter Vs4 dc=0
alter Vh4 dc=0
alter Vs5 dc=1.2
alter Vh5 dc=1.2
alter Vs6 dc=0
alter Vh6 dc=0
alter Vs7 dc=1.2
alter Vh7 dc=1.2
op
echo ROW 2 25.0 163 $&v(xt.vth_soft) $&v(xt.vth_hard) $&v(vref_buf) $&v(isense) $&i(vdda)
alter Vs0 dc=0
alter Vh0 dc=0
alter Vs1 dc=0
alter Vh1 dc=0
alter Vs2 dc=1.2
alter Vh2 dc=1.2
alter Vs3 dc=0
alter Vh3 dc=0
alter Vs4 dc=0
alter Vh4 dc=0
alter Vs5 dc=1.2
alter Vh5 dc=1.2
alter Vs6 dc=0
alter Vh6 dc=0
alter Vs7 dc=1.2
alter Vh7 dc=1.2
op
echo ROW 2 25.0 164 $&v(xt.vth_soft) $&v(xt.vth_hard) $&v(vref_buf) $&v(isense) $&i(vdda)
alter Vs0 dc=1.2
alter Vh0 dc=1.2
alter Vs1 dc=0
alter Vh1 dc=0
alter Vs2 dc=1.2
alter Vh2 dc=1.2
alter Vs3 dc=0
alter Vh3 dc=0
alter Vs4 dc=0
alter Vh4 dc=0
alter Vs5 dc=1.2
alter Vh5 dc=1.2
alter Vs6 dc=0
alter Vh6 dc=0
alter Vs7 dc=1.2
alter Vh7 dc=1.2
op
echo ROW 2 25.0 165 $&v(xt.vth_soft) $&v(xt.vth_hard) $&v(vref_buf) $&v(isense) $&i(vdda)
alter Vs0 dc=0
alter Vh0 dc=0
alter Vs1 dc=1.2
alter Vh1 dc=1.2
alter Vs2 dc=1.2
alter Vh2 dc=1.2
alter Vs3 dc=0
alter Vh3 dc=0
alter Vs4 dc=0
alter Vh4 dc=0
alter Vs5 dc=1.2
alter Vh5 dc=1.2
alter Vs6 dc=0
alter Vh6 dc=0
alter Vs7 dc=1.2
alter Vh7 dc=1.2
op
echo ROW 2 25.0 166 $&v(xt.vth_soft) $&v(xt.vth_hard) $&v(vref_buf) $&v(isense) $&i(vdda)
alter Vs0 dc=1.2
alter Vh0 dc=1.2
alter Vs1 dc=1.2
alter Vh1 dc=1.2
alter Vs2 dc=1.2
alter Vh2 dc=1.2
alter Vs3 dc=0
alter Vh3 dc=0
alter Vs4 dc=0
alter Vh4 dc=0
alter Vs5 dc=1.2
alter Vh5 dc=1.2
alter Vs6 dc=0
alter Vh6 dc=0
alter Vs7 dc=1.2
alter Vh7 dc=1.2
op
echo ROW 2 25.0 167 $&v(xt.vth_soft) $&v(xt.vth_hard) $&v(vref_buf) $&v(isense) $&i(vdda)
alter Vs0 dc=0
alter Vh0 dc=0
alter Vs1 dc=0
alter Vh1 dc=0
alter Vs2 dc=0
alter Vh2 dc=0
alter Vs3 dc=1.2
alter Vh3 dc=1.2
alter Vs4 dc=0
alter Vh4 dc=0
alter Vs5 dc=1.2
alter Vh5 dc=1.2
alter Vs6 dc=0
alter Vh6 dc=0
alter Vs7 dc=1.2
alter Vh7 dc=1.2
op
echo ROW 2 25.0 168 $&v(xt.vth_soft) $&v(xt.vth_hard) $&v(vref_buf) $&v(isense) $&i(vdda)
alter Vs0 dc=1.2
alter Vh0 dc=1.2
alter Vs1 dc=0
alter Vh1 dc=0
alter Vs2 dc=0
alter Vh2 dc=0
alter Vs3 dc=1.2
alter Vh3 dc=1.2
alter Vs4 dc=0
alter Vh4 dc=0
alter Vs5 dc=1.2
alter Vh5 dc=1.2
alter Vs6 dc=0
alter Vh6 dc=0
alter Vs7 dc=1.2
alter Vh7 dc=1.2
op
echo ROW 2 25.0 169 $&v(xt.vth_soft) $&v(xt.vth_hard) $&v(vref_buf) $&v(isense) $&i(vdda)
alter Vs0 dc=0
alter Vh0 dc=0
alter Vs1 dc=1.2
alter Vh1 dc=1.2
alter Vs2 dc=0
alter Vh2 dc=0
alter Vs3 dc=1.2
alter Vh3 dc=1.2
alter Vs4 dc=0
alter Vh4 dc=0
alter Vs5 dc=1.2
alter Vh5 dc=1.2
alter Vs6 dc=0
alter Vh6 dc=0
alter Vs7 dc=1.2
alter Vh7 dc=1.2
op
echo ROW 2 25.0 170 $&v(xt.vth_soft) $&v(xt.vth_hard) $&v(vref_buf) $&v(isense) $&i(vdda)
alter Vs0 dc=1.2
alter Vh0 dc=1.2
alter Vs1 dc=1.2
alter Vh1 dc=1.2
alter Vs2 dc=0
alter Vh2 dc=0
alter Vs3 dc=1.2
alter Vh3 dc=1.2
alter Vs4 dc=0
alter Vh4 dc=0
alter Vs5 dc=1.2
alter Vh5 dc=1.2
alter Vs6 dc=0
alter Vh6 dc=0
alter Vs7 dc=1.2
alter Vh7 dc=1.2
op
echo ROW 2 25.0 171 $&v(xt.vth_soft) $&v(xt.vth_hard) $&v(vref_buf) $&v(isense) $&i(vdda)
alter Vs0 dc=0
alter Vh0 dc=0
alter Vs1 dc=0
alter Vh1 dc=0
alter Vs2 dc=1.2
alter Vh2 dc=1.2
alter Vs3 dc=1.2
alter Vh3 dc=1.2
alter Vs4 dc=0
alter Vh4 dc=0
alter Vs5 dc=1.2
alter Vh5 dc=1.2
alter Vs6 dc=0
alter Vh6 dc=0
alter Vs7 dc=1.2
alter Vh7 dc=1.2
op
echo ROW 2 25.0 172 $&v(xt.vth_soft) $&v(xt.vth_hard) $&v(vref_buf) $&v(isense) $&i(vdda)
alter Vs0 dc=1.2
alter Vh0 dc=1.2
alter Vs1 dc=0
alter Vh1 dc=0
alter Vs2 dc=1.2
alter Vh2 dc=1.2
alter Vs3 dc=1.2
alter Vh3 dc=1.2
alter Vs4 dc=0
alter Vh4 dc=0
alter Vs5 dc=1.2
alter Vh5 dc=1.2
alter Vs6 dc=0
alter Vh6 dc=0
alter Vs7 dc=1.2
alter Vh7 dc=1.2
op
echo ROW 2 25.0 173 $&v(xt.vth_soft) $&v(xt.vth_hard) $&v(vref_buf) $&v(isense) $&i(vdda)
alter Vs0 dc=0
alter Vh0 dc=0
alter Vs1 dc=1.2
alter Vh1 dc=1.2
alter Vs2 dc=1.2
alter Vh2 dc=1.2
alter Vs3 dc=1.2
alter Vh3 dc=1.2
alter Vs4 dc=0
alter Vh4 dc=0
alter Vs5 dc=1.2
alter Vh5 dc=1.2
alter Vs6 dc=0
alter Vh6 dc=0
alter Vs7 dc=1.2
alter Vh7 dc=1.2
op
echo ROW 2 25.0 174 $&v(xt.vth_soft) $&v(xt.vth_hard) $&v(vref_buf) $&v(isense) $&i(vdda)
alter Vs0 dc=1.2
alter Vh0 dc=1.2
alter Vs1 dc=1.2
alter Vh1 dc=1.2
alter Vs2 dc=1.2
alter Vh2 dc=1.2
alter Vs3 dc=1.2
alter Vh3 dc=1.2
alter Vs4 dc=0
alter Vh4 dc=0
alter Vs5 dc=1.2
alter Vh5 dc=1.2
alter Vs6 dc=0
alter Vh6 dc=0
alter Vs7 dc=1.2
alter Vh7 dc=1.2
op
echo ROW 2 25.0 175 $&v(xt.vth_soft) $&v(xt.vth_hard) $&v(vref_buf) $&v(isense) $&i(vdda)
alter Vs0 dc=0
alter Vh0 dc=0
alter Vs1 dc=0
alter Vh1 dc=0
alter Vs2 dc=0
alter Vh2 dc=0
alter Vs3 dc=0
alter Vh3 dc=0
alter Vs4 dc=1.2
alter Vh4 dc=1.2
alter Vs5 dc=1.2
alter Vh5 dc=1.2
alter Vs6 dc=0
alter Vh6 dc=0
alter Vs7 dc=1.2
alter Vh7 dc=1.2
op
echo ROW 2 25.0 176 $&v(xt.vth_soft) $&v(xt.vth_hard) $&v(vref_buf) $&v(isense) $&i(vdda)
alter Vs0 dc=1.2
alter Vh0 dc=1.2
alter Vs1 dc=0
alter Vh1 dc=0
alter Vs2 dc=0
alter Vh2 dc=0
alter Vs3 dc=0
alter Vh3 dc=0
alter Vs4 dc=1.2
alter Vh4 dc=1.2
alter Vs5 dc=1.2
alter Vh5 dc=1.2
alter Vs6 dc=0
alter Vh6 dc=0
alter Vs7 dc=1.2
alter Vh7 dc=1.2
op
echo ROW 2 25.0 177 $&v(xt.vth_soft) $&v(xt.vth_hard) $&v(vref_buf) $&v(isense) $&i(vdda)
alter Vs0 dc=0
alter Vh0 dc=0
alter Vs1 dc=1.2
alter Vh1 dc=1.2
alter Vs2 dc=0
alter Vh2 dc=0
alter Vs3 dc=0
alter Vh3 dc=0
alter Vs4 dc=1.2
alter Vh4 dc=1.2
alter Vs5 dc=1.2
alter Vh5 dc=1.2
alter Vs6 dc=0
alter Vh6 dc=0
alter Vs7 dc=1.2
alter Vh7 dc=1.2
op
echo ROW 2 25.0 178 $&v(xt.vth_soft) $&v(xt.vth_hard) $&v(vref_buf) $&v(isense) $&i(vdda)
alter Vs0 dc=1.2
alter Vh0 dc=1.2
alter Vs1 dc=1.2
alter Vh1 dc=1.2
alter Vs2 dc=0
alter Vh2 dc=0
alter Vs3 dc=0
alter Vh3 dc=0
alter Vs4 dc=1.2
alter Vh4 dc=1.2
alter Vs5 dc=1.2
alter Vh5 dc=1.2
alter Vs6 dc=0
alter Vh6 dc=0
alter Vs7 dc=1.2
alter Vh7 dc=1.2
op
echo ROW 2 25.0 179 $&v(xt.vth_soft) $&v(xt.vth_hard) $&v(vref_buf) $&v(isense) $&i(vdda)
alter Vs0 dc=0
alter Vh0 dc=0
alter Vs1 dc=0
alter Vh1 dc=0
alter Vs2 dc=1.2
alter Vh2 dc=1.2
alter Vs3 dc=0
alter Vh3 dc=0
alter Vs4 dc=1.2
alter Vh4 dc=1.2
alter Vs5 dc=1.2
alter Vh5 dc=1.2
alter Vs6 dc=0
alter Vh6 dc=0
alter Vs7 dc=1.2
alter Vh7 dc=1.2
op
echo ROW 2 25.0 180 $&v(xt.vth_soft) $&v(xt.vth_hard) $&v(vref_buf) $&v(isense) $&i(vdda)
alter Vs0 dc=1.2
alter Vh0 dc=1.2
alter Vs1 dc=0
alter Vh1 dc=0
alter Vs2 dc=1.2
alter Vh2 dc=1.2
alter Vs3 dc=0
alter Vh3 dc=0
alter Vs4 dc=1.2
alter Vh4 dc=1.2
alter Vs5 dc=1.2
alter Vh5 dc=1.2
alter Vs6 dc=0
alter Vh6 dc=0
alter Vs7 dc=1.2
alter Vh7 dc=1.2
op
echo ROW 2 25.0 181 $&v(xt.vth_soft) $&v(xt.vth_hard) $&v(vref_buf) $&v(isense) $&i(vdda)
alter Vs0 dc=0
alter Vh0 dc=0
alter Vs1 dc=1.2
alter Vh1 dc=1.2
alter Vs2 dc=1.2
alter Vh2 dc=1.2
alter Vs3 dc=0
alter Vh3 dc=0
alter Vs4 dc=1.2
alter Vh4 dc=1.2
alter Vs5 dc=1.2
alter Vh5 dc=1.2
alter Vs6 dc=0
alter Vh6 dc=0
alter Vs7 dc=1.2
alter Vh7 dc=1.2
op
echo ROW 2 25.0 182 $&v(xt.vth_soft) $&v(xt.vth_hard) $&v(vref_buf) $&v(isense) $&i(vdda)
alter Vs0 dc=1.2
alter Vh0 dc=1.2
alter Vs1 dc=1.2
alter Vh1 dc=1.2
alter Vs2 dc=1.2
alter Vh2 dc=1.2
alter Vs3 dc=0
alter Vh3 dc=0
alter Vs4 dc=1.2
alter Vh4 dc=1.2
alter Vs5 dc=1.2
alter Vh5 dc=1.2
alter Vs6 dc=0
alter Vh6 dc=0
alter Vs7 dc=1.2
alter Vh7 dc=1.2
op
echo ROW 2 25.0 183 $&v(xt.vth_soft) $&v(xt.vth_hard) $&v(vref_buf) $&v(isense) $&i(vdda)
alter Vs0 dc=0
alter Vh0 dc=0
alter Vs1 dc=0
alter Vh1 dc=0
alter Vs2 dc=0
alter Vh2 dc=0
alter Vs3 dc=1.2
alter Vh3 dc=1.2
alter Vs4 dc=1.2
alter Vh4 dc=1.2
alter Vs5 dc=1.2
alter Vh5 dc=1.2
alter Vs6 dc=0
alter Vh6 dc=0
alter Vs7 dc=1.2
alter Vh7 dc=1.2
op
echo ROW 2 25.0 184 $&v(xt.vth_soft) $&v(xt.vth_hard) $&v(vref_buf) $&v(isense) $&i(vdda)
alter Vs0 dc=1.2
alter Vh0 dc=1.2
alter Vs1 dc=0
alter Vh1 dc=0
alter Vs2 dc=0
alter Vh2 dc=0
alter Vs3 dc=1.2
alter Vh3 dc=1.2
alter Vs4 dc=1.2
alter Vh4 dc=1.2
alter Vs5 dc=1.2
alter Vh5 dc=1.2
alter Vs6 dc=0
alter Vh6 dc=0
alter Vs7 dc=1.2
alter Vh7 dc=1.2
op
echo ROW 2 25.0 185 $&v(xt.vth_soft) $&v(xt.vth_hard) $&v(vref_buf) $&v(isense) $&i(vdda)
alter Vs0 dc=0
alter Vh0 dc=0
alter Vs1 dc=1.2
alter Vh1 dc=1.2
alter Vs2 dc=0
alter Vh2 dc=0
alter Vs3 dc=1.2
alter Vh3 dc=1.2
alter Vs4 dc=1.2
alter Vh4 dc=1.2
alter Vs5 dc=1.2
alter Vh5 dc=1.2
alter Vs6 dc=0
alter Vh6 dc=0
alter Vs7 dc=1.2
alter Vh7 dc=1.2
op
echo ROW 2 25.0 186 $&v(xt.vth_soft) $&v(xt.vth_hard) $&v(vref_buf) $&v(isense) $&i(vdda)
alter Vs0 dc=1.2
alter Vh0 dc=1.2
alter Vs1 dc=1.2
alter Vh1 dc=1.2
alter Vs2 dc=0
alter Vh2 dc=0
alter Vs3 dc=1.2
alter Vh3 dc=1.2
alter Vs4 dc=1.2
alter Vh4 dc=1.2
alter Vs5 dc=1.2
alter Vh5 dc=1.2
alter Vs6 dc=0
alter Vh6 dc=0
alter Vs7 dc=1.2
alter Vh7 dc=1.2
op
echo ROW 2 25.0 187 $&v(xt.vth_soft) $&v(xt.vth_hard) $&v(vref_buf) $&v(isense) $&i(vdda)
alter Vs0 dc=0
alter Vh0 dc=0
alter Vs1 dc=0
alter Vh1 dc=0
alter Vs2 dc=1.2
alter Vh2 dc=1.2
alter Vs3 dc=1.2
alter Vh3 dc=1.2
alter Vs4 dc=1.2
alter Vh4 dc=1.2
alter Vs5 dc=1.2
alter Vh5 dc=1.2
alter Vs6 dc=0
alter Vh6 dc=0
alter Vs7 dc=1.2
alter Vh7 dc=1.2
op
echo ROW 2 25.0 188 $&v(xt.vth_soft) $&v(xt.vth_hard) $&v(vref_buf) $&v(isense) $&i(vdda)
alter Vs0 dc=1.2
alter Vh0 dc=1.2
alter Vs1 dc=0
alter Vh1 dc=0
alter Vs2 dc=1.2
alter Vh2 dc=1.2
alter Vs3 dc=1.2
alter Vh3 dc=1.2
alter Vs4 dc=1.2
alter Vh4 dc=1.2
alter Vs5 dc=1.2
alter Vh5 dc=1.2
alter Vs6 dc=0
alter Vh6 dc=0
alter Vs7 dc=1.2
alter Vh7 dc=1.2
op
echo ROW 2 25.0 189 $&v(xt.vth_soft) $&v(xt.vth_hard) $&v(vref_buf) $&v(isense) $&i(vdda)
alter Vs0 dc=0
alter Vh0 dc=0
alter Vs1 dc=1.2
alter Vh1 dc=1.2
alter Vs2 dc=1.2
alter Vh2 dc=1.2
alter Vs3 dc=1.2
alter Vh3 dc=1.2
alter Vs4 dc=1.2
alter Vh4 dc=1.2
alter Vs5 dc=1.2
alter Vh5 dc=1.2
alter Vs6 dc=0
alter Vh6 dc=0
alter Vs7 dc=1.2
alter Vh7 dc=1.2
op
echo ROW 2 25.0 190 $&v(xt.vth_soft) $&v(xt.vth_hard) $&v(vref_buf) $&v(isense) $&i(vdda)
alter Vs0 dc=1.2
alter Vh0 dc=1.2
alter Vs1 dc=1.2
alter Vh1 dc=1.2
alter Vs2 dc=1.2
alter Vh2 dc=1.2
alter Vs3 dc=1.2
alter Vh3 dc=1.2
alter Vs4 dc=1.2
alter Vh4 dc=1.2
alter Vs5 dc=1.2
alter Vh5 dc=1.2
alter Vs6 dc=0
alter Vh6 dc=0
alter Vs7 dc=1.2
alter Vh7 dc=1.2
op
echo ROW 2 25.0 191 $&v(xt.vth_soft) $&v(xt.vth_hard) $&v(vref_buf) $&v(isense) $&i(vdda)
alter Vs0 dc=0
alter Vh0 dc=0
alter Vs1 dc=0
alter Vh1 dc=0
alter Vs2 dc=0
alter Vh2 dc=0
alter Vs3 dc=0
alter Vh3 dc=0
alter Vs4 dc=0
alter Vh4 dc=0
alter Vs5 dc=0
alter Vh5 dc=0
alter Vs6 dc=1.2
alter Vh6 dc=1.2
alter Vs7 dc=1.2
alter Vh7 dc=1.2
op
echo ROW 2 25.0 192 $&v(xt.vth_soft) $&v(xt.vth_hard) $&v(vref_buf) $&v(isense) $&i(vdda)
alter Vs0 dc=1.2
alter Vh0 dc=1.2
alter Vs1 dc=0
alter Vh1 dc=0
alter Vs2 dc=0
alter Vh2 dc=0
alter Vs3 dc=0
alter Vh3 dc=0
alter Vs4 dc=0
alter Vh4 dc=0
alter Vs5 dc=0
alter Vh5 dc=0
alter Vs6 dc=1.2
alter Vh6 dc=1.2
alter Vs7 dc=1.2
alter Vh7 dc=1.2
op
echo ROW 2 25.0 193 $&v(xt.vth_soft) $&v(xt.vth_hard) $&v(vref_buf) $&v(isense) $&i(vdda)
alter Vs0 dc=0
alter Vh0 dc=0
alter Vs1 dc=1.2
alter Vh1 dc=1.2
alter Vs2 dc=0
alter Vh2 dc=0
alter Vs3 dc=0
alter Vh3 dc=0
alter Vs4 dc=0
alter Vh4 dc=0
alter Vs5 dc=0
alter Vh5 dc=0
alter Vs6 dc=1.2
alter Vh6 dc=1.2
alter Vs7 dc=1.2
alter Vh7 dc=1.2
op
echo ROW 2 25.0 194 $&v(xt.vth_soft) $&v(xt.vth_hard) $&v(vref_buf) $&v(isense) $&i(vdda)
alter Vs0 dc=1.2
alter Vh0 dc=1.2
alter Vs1 dc=1.2
alter Vh1 dc=1.2
alter Vs2 dc=0
alter Vh2 dc=0
alter Vs3 dc=0
alter Vh3 dc=0
alter Vs4 dc=0
alter Vh4 dc=0
alter Vs5 dc=0
alter Vh5 dc=0
alter Vs6 dc=1.2
alter Vh6 dc=1.2
alter Vs7 dc=1.2
alter Vh7 dc=1.2
op
echo ROW 2 25.0 195 $&v(xt.vth_soft) $&v(xt.vth_hard) $&v(vref_buf) $&v(isense) $&i(vdda)
alter Vs0 dc=0
alter Vh0 dc=0
alter Vs1 dc=0
alter Vh1 dc=0
alter Vs2 dc=1.2
alter Vh2 dc=1.2
alter Vs3 dc=0
alter Vh3 dc=0
alter Vs4 dc=0
alter Vh4 dc=0
alter Vs5 dc=0
alter Vh5 dc=0
alter Vs6 dc=1.2
alter Vh6 dc=1.2
alter Vs7 dc=1.2
alter Vh7 dc=1.2
op
echo ROW 2 25.0 196 $&v(xt.vth_soft) $&v(xt.vth_hard) $&v(vref_buf) $&v(isense) $&i(vdda)
alter Vs0 dc=1.2
alter Vh0 dc=1.2
alter Vs1 dc=0
alter Vh1 dc=0
alter Vs2 dc=1.2
alter Vh2 dc=1.2
alter Vs3 dc=0
alter Vh3 dc=0
alter Vs4 dc=0
alter Vh4 dc=0
alter Vs5 dc=0
alter Vh5 dc=0
alter Vs6 dc=1.2
alter Vh6 dc=1.2
alter Vs7 dc=1.2
alter Vh7 dc=1.2
op
echo ROW 2 25.0 197 $&v(xt.vth_soft) $&v(xt.vth_hard) $&v(vref_buf) $&v(isense) $&i(vdda)
alter Vs0 dc=0
alter Vh0 dc=0
alter Vs1 dc=1.2
alter Vh1 dc=1.2
alter Vs2 dc=1.2
alter Vh2 dc=1.2
alter Vs3 dc=0
alter Vh3 dc=0
alter Vs4 dc=0
alter Vh4 dc=0
alter Vs5 dc=0
alter Vh5 dc=0
alter Vs6 dc=1.2
alter Vh6 dc=1.2
alter Vs7 dc=1.2
alter Vh7 dc=1.2
op
echo ROW 2 25.0 198 $&v(xt.vth_soft) $&v(xt.vth_hard) $&v(vref_buf) $&v(isense) $&i(vdda)
alter Vs0 dc=1.2
alter Vh0 dc=1.2
alter Vs1 dc=1.2
alter Vh1 dc=1.2
alter Vs2 dc=1.2
alter Vh2 dc=1.2
alter Vs3 dc=0
alter Vh3 dc=0
alter Vs4 dc=0
alter Vh4 dc=0
alter Vs5 dc=0
alter Vh5 dc=0
alter Vs6 dc=1.2
alter Vh6 dc=1.2
alter Vs7 dc=1.2
alter Vh7 dc=1.2
op
echo ROW 2 25.0 199 $&v(xt.vth_soft) $&v(xt.vth_hard) $&v(vref_buf) $&v(isense) $&i(vdda)
alter Vs0 dc=0
alter Vh0 dc=0
alter Vs1 dc=0
alter Vh1 dc=0
alter Vs2 dc=0
alter Vh2 dc=0
alter Vs3 dc=1.2
alter Vh3 dc=1.2
alter Vs4 dc=0
alter Vh4 dc=0
alter Vs5 dc=0
alter Vh5 dc=0
alter Vs6 dc=1.2
alter Vh6 dc=1.2
alter Vs7 dc=1.2
alter Vh7 dc=1.2
op
echo ROW 2 25.0 200 $&v(xt.vth_soft) $&v(xt.vth_hard) $&v(vref_buf) $&v(isense) $&i(vdda)
alter Vs0 dc=1.2
alter Vh0 dc=1.2
alter Vs1 dc=0
alter Vh1 dc=0
alter Vs2 dc=0
alter Vh2 dc=0
alter Vs3 dc=1.2
alter Vh3 dc=1.2
alter Vs4 dc=0
alter Vh4 dc=0
alter Vs5 dc=0
alter Vh5 dc=0
alter Vs6 dc=1.2
alter Vh6 dc=1.2
alter Vs7 dc=1.2
alter Vh7 dc=1.2
op
echo ROW 2 25.0 201 $&v(xt.vth_soft) $&v(xt.vth_hard) $&v(vref_buf) $&v(isense) $&i(vdda)
alter Vs0 dc=0
alter Vh0 dc=0
alter Vs1 dc=1.2
alter Vh1 dc=1.2
alter Vs2 dc=0
alter Vh2 dc=0
alter Vs3 dc=1.2
alter Vh3 dc=1.2
alter Vs4 dc=0
alter Vh4 dc=0
alter Vs5 dc=0
alter Vh5 dc=0
alter Vs6 dc=1.2
alter Vh6 dc=1.2
alter Vs7 dc=1.2
alter Vh7 dc=1.2
op
echo ROW 2 25.0 202 $&v(xt.vth_soft) $&v(xt.vth_hard) $&v(vref_buf) $&v(isense) $&i(vdda)
alter Vs0 dc=1.2
alter Vh0 dc=1.2
alter Vs1 dc=1.2
alter Vh1 dc=1.2
alter Vs2 dc=0
alter Vh2 dc=0
alter Vs3 dc=1.2
alter Vh3 dc=1.2
alter Vs4 dc=0
alter Vh4 dc=0
alter Vs5 dc=0
alter Vh5 dc=0
alter Vs6 dc=1.2
alter Vh6 dc=1.2
alter Vs7 dc=1.2
alter Vh7 dc=1.2
op
echo ROW 2 25.0 203 $&v(xt.vth_soft) $&v(xt.vth_hard) $&v(vref_buf) $&v(isense) $&i(vdda)
alter Vs0 dc=0
alter Vh0 dc=0
alter Vs1 dc=0
alter Vh1 dc=0
alter Vs2 dc=1.2
alter Vh2 dc=1.2
alter Vs3 dc=1.2
alter Vh3 dc=1.2
alter Vs4 dc=0
alter Vh4 dc=0
alter Vs5 dc=0
alter Vh5 dc=0
alter Vs6 dc=1.2
alter Vh6 dc=1.2
alter Vs7 dc=1.2
alter Vh7 dc=1.2
op
echo ROW 2 25.0 204 $&v(xt.vth_soft) $&v(xt.vth_hard) $&v(vref_buf) $&v(isense) $&i(vdda)
alter Vs0 dc=1.2
alter Vh0 dc=1.2
alter Vs1 dc=0
alter Vh1 dc=0
alter Vs2 dc=1.2
alter Vh2 dc=1.2
alter Vs3 dc=1.2
alter Vh3 dc=1.2
alter Vs4 dc=0
alter Vh4 dc=0
alter Vs5 dc=0
alter Vh5 dc=0
alter Vs6 dc=1.2
alter Vh6 dc=1.2
alter Vs7 dc=1.2
alter Vh7 dc=1.2
op
echo ROW 2 25.0 205 $&v(xt.vth_soft) $&v(xt.vth_hard) $&v(vref_buf) $&v(isense) $&i(vdda)
alter Vs0 dc=0
alter Vh0 dc=0
alter Vs1 dc=1.2
alter Vh1 dc=1.2
alter Vs2 dc=1.2
alter Vh2 dc=1.2
alter Vs3 dc=1.2
alter Vh3 dc=1.2
alter Vs4 dc=0
alter Vh4 dc=0
alter Vs5 dc=0
alter Vh5 dc=0
alter Vs6 dc=1.2
alter Vh6 dc=1.2
alter Vs7 dc=1.2
alter Vh7 dc=1.2
op
echo ROW 2 25.0 206 $&v(xt.vth_soft) $&v(xt.vth_hard) $&v(vref_buf) $&v(isense) $&i(vdda)
alter Vs0 dc=1.2
alter Vh0 dc=1.2
alter Vs1 dc=1.2
alter Vh1 dc=1.2
alter Vs2 dc=1.2
alter Vh2 dc=1.2
alter Vs3 dc=1.2
alter Vh3 dc=1.2
alter Vs4 dc=0
alter Vh4 dc=0
alter Vs5 dc=0
alter Vh5 dc=0
alter Vs6 dc=1.2
alter Vh6 dc=1.2
alter Vs7 dc=1.2
alter Vh7 dc=1.2
op
echo ROW 2 25.0 207 $&v(xt.vth_soft) $&v(xt.vth_hard) $&v(vref_buf) $&v(isense) $&i(vdda)
alter Vs0 dc=0
alter Vh0 dc=0
alter Vs1 dc=0
alter Vh1 dc=0
alter Vs2 dc=0
alter Vh2 dc=0
alter Vs3 dc=0
alter Vh3 dc=0
alter Vs4 dc=1.2
alter Vh4 dc=1.2
alter Vs5 dc=0
alter Vh5 dc=0
alter Vs6 dc=1.2
alter Vh6 dc=1.2
alter Vs7 dc=1.2
alter Vh7 dc=1.2
op
echo ROW 2 25.0 208 $&v(xt.vth_soft) $&v(xt.vth_hard) $&v(vref_buf) $&v(isense) $&i(vdda)
alter Vs0 dc=1.2
alter Vh0 dc=1.2
alter Vs1 dc=0
alter Vh1 dc=0
alter Vs2 dc=0
alter Vh2 dc=0
alter Vs3 dc=0
alter Vh3 dc=0
alter Vs4 dc=1.2
alter Vh4 dc=1.2
alter Vs5 dc=0
alter Vh5 dc=0
alter Vs6 dc=1.2
alter Vh6 dc=1.2
alter Vs7 dc=1.2
alter Vh7 dc=1.2
op
echo ROW 2 25.0 209 $&v(xt.vth_soft) $&v(xt.vth_hard) $&v(vref_buf) $&v(isense) $&i(vdda)
alter Vs0 dc=0
alter Vh0 dc=0
alter Vs1 dc=1.2
alter Vh1 dc=1.2
alter Vs2 dc=0
alter Vh2 dc=0
alter Vs3 dc=0
alter Vh3 dc=0
alter Vs4 dc=1.2
alter Vh4 dc=1.2
alter Vs5 dc=0
alter Vh5 dc=0
alter Vs6 dc=1.2
alter Vh6 dc=1.2
alter Vs7 dc=1.2
alter Vh7 dc=1.2
op
echo ROW 2 25.0 210 $&v(xt.vth_soft) $&v(xt.vth_hard) $&v(vref_buf) $&v(isense) $&i(vdda)
alter Vs0 dc=1.2
alter Vh0 dc=1.2
alter Vs1 dc=1.2
alter Vh1 dc=1.2
alter Vs2 dc=0
alter Vh2 dc=0
alter Vs3 dc=0
alter Vh3 dc=0
alter Vs4 dc=1.2
alter Vh4 dc=1.2
alter Vs5 dc=0
alter Vh5 dc=0
alter Vs6 dc=1.2
alter Vh6 dc=1.2
alter Vs7 dc=1.2
alter Vh7 dc=1.2
op
echo ROW 2 25.0 211 $&v(xt.vth_soft) $&v(xt.vth_hard) $&v(vref_buf) $&v(isense) $&i(vdda)
alter Vs0 dc=0
alter Vh0 dc=0
alter Vs1 dc=0
alter Vh1 dc=0
alter Vs2 dc=1.2
alter Vh2 dc=1.2
alter Vs3 dc=0
alter Vh3 dc=0
alter Vs4 dc=1.2
alter Vh4 dc=1.2
alter Vs5 dc=0
alter Vh5 dc=0
alter Vs6 dc=1.2
alter Vh6 dc=1.2
alter Vs7 dc=1.2
alter Vh7 dc=1.2
op
echo ROW 2 25.0 212 $&v(xt.vth_soft) $&v(xt.vth_hard) $&v(vref_buf) $&v(isense) $&i(vdda)
alter Vs0 dc=1.2
alter Vh0 dc=1.2
alter Vs1 dc=0
alter Vh1 dc=0
alter Vs2 dc=1.2
alter Vh2 dc=1.2
alter Vs3 dc=0
alter Vh3 dc=0
alter Vs4 dc=1.2
alter Vh4 dc=1.2
alter Vs5 dc=0
alter Vh5 dc=0
alter Vs6 dc=1.2
alter Vh6 dc=1.2
alter Vs7 dc=1.2
alter Vh7 dc=1.2
op
echo ROW 2 25.0 213 $&v(xt.vth_soft) $&v(xt.vth_hard) $&v(vref_buf) $&v(isense) $&i(vdda)
alter Vs0 dc=0
alter Vh0 dc=0
alter Vs1 dc=1.2
alter Vh1 dc=1.2
alter Vs2 dc=1.2
alter Vh2 dc=1.2
alter Vs3 dc=0
alter Vh3 dc=0
alter Vs4 dc=1.2
alter Vh4 dc=1.2
alter Vs5 dc=0
alter Vh5 dc=0
alter Vs6 dc=1.2
alter Vh6 dc=1.2
alter Vs7 dc=1.2
alter Vh7 dc=1.2
op
echo ROW 2 25.0 214 $&v(xt.vth_soft) $&v(xt.vth_hard) $&v(vref_buf) $&v(isense) $&i(vdda)
alter Vs0 dc=1.2
alter Vh0 dc=1.2
alter Vs1 dc=1.2
alter Vh1 dc=1.2
alter Vs2 dc=1.2
alter Vh2 dc=1.2
alter Vs3 dc=0
alter Vh3 dc=0
alter Vs4 dc=1.2
alter Vh4 dc=1.2
alter Vs5 dc=0
alter Vh5 dc=0
alter Vs6 dc=1.2
alter Vh6 dc=1.2
alter Vs7 dc=1.2
alter Vh7 dc=1.2
op
echo ROW 2 25.0 215 $&v(xt.vth_soft) $&v(xt.vth_hard) $&v(vref_buf) $&v(isense) $&i(vdda)
alter Vs0 dc=0
alter Vh0 dc=0
alter Vs1 dc=0
alter Vh1 dc=0
alter Vs2 dc=0
alter Vh2 dc=0
alter Vs3 dc=1.2
alter Vh3 dc=1.2
alter Vs4 dc=1.2
alter Vh4 dc=1.2
alter Vs5 dc=0
alter Vh5 dc=0
alter Vs6 dc=1.2
alter Vh6 dc=1.2
alter Vs7 dc=1.2
alter Vh7 dc=1.2
op
echo ROW 2 25.0 216 $&v(xt.vth_soft) $&v(xt.vth_hard) $&v(vref_buf) $&v(isense) $&i(vdda)
alter Vs0 dc=1.2
alter Vh0 dc=1.2
alter Vs1 dc=0
alter Vh1 dc=0
alter Vs2 dc=0
alter Vh2 dc=0
alter Vs3 dc=1.2
alter Vh3 dc=1.2
alter Vs4 dc=1.2
alter Vh4 dc=1.2
alter Vs5 dc=0
alter Vh5 dc=0
alter Vs6 dc=1.2
alter Vh6 dc=1.2
alter Vs7 dc=1.2
alter Vh7 dc=1.2
op
echo ROW 2 25.0 217 $&v(xt.vth_soft) $&v(xt.vth_hard) $&v(vref_buf) $&v(isense) $&i(vdda)
alter Vs0 dc=0
alter Vh0 dc=0
alter Vs1 dc=1.2
alter Vh1 dc=1.2
alter Vs2 dc=0
alter Vh2 dc=0
alter Vs3 dc=1.2
alter Vh3 dc=1.2
alter Vs4 dc=1.2
alter Vh4 dc=1.2
alter Vs5 dc=0
alter Vh5 dc=0
alter Vs6 dc=1.2
alter Vh6 dc=1.2
alter Vs7 dc=1.2
alter Vh7 dc=1.2
op
echo ROW 2 25.0 218 $&v(xt.vth_soft) $&v(xt.vth_hard) $&v(vref_buf) $&v(isense) $&i(vdda)
alter Vs0 dc=1.2
alter Vh0 dc=1.2
alter Vs1 dc=1.2
alter Vh1 dc=1.2
alter Vs2 dc=0
alter Vh2 dc=0
alter Vs3 dc=1.2
alter Vh3 dc=1.2
alter Vs4 dc=1.2
alter Vh4 dc=1.2
alter Vs5 dc=0
alter Vh5 dc=0
alter Vs6 dc=1.2
alter Vh6 dc=1.2
alter Vs7 dc=1.2
alter Vh7 dc=1.2
op
echo ROW 2 25.0 219 $&v(xt.vth_soft) $&v(xt.vth_hard) $&v(vref_buf) $&v(isense) $&i(vdda)
alter Vs0 dc=0
alter Vh0 dc=0
alter Vs1 dc=0
alter Vh1 dc=0
alter Vs2 dc=1.2
alter Vh2 dc=1.2
alter Vs3 dc=1.2
alter Vh3 dc=1.2
alter Vs4 dc=1.2
alter Vh4 dc=1.2
alter Vs5 dc=0
alter Vh5 dc=0
alter Vs6 dc=1.2
alter Vh6 dc=1.2
alter Vs7 dc=1.2
alter Vh7 dc=1.2
op
echo ROW 2 25.0 220 $&v(xt.vth_soft) $&v(xt.vth_hard) $&v(vref_buf) $&v(isense) $&i(vdda)
alter Vs0 dc=1.2
alter Vh0 dc=1.2
alter Vs1 dc=0
alter Vh1 dc=0
alter Vs2 dc=1.2
alter Vh2 dc=1.2
alter Vs3 dc=1.2
alter Vh3 dc=1.2
alter Vs4 dc=1.2
alter Vh4 dc=1.2
alter Vs5 dc=0
alter Vh5 dc=0
alter Vs6 dc=1.2
alter Vh6 dc=1.2
alter Vs7 dc=1.2
alter Vh7 dc=1.2
op
echo ROW 2 25.0 221 $&v(xt.vth_soft) $&v(xt.vth_hard) $&v(vref_buf) $&v(isense) $&i(vdda)
alter Vs0 dc=0
alter Vh0 dc=0
alter Vs1 dc=1.2
alter Vh1 dc=1.2
alter Vs2 dc=1.2
alter Vh2 dc=1.2
alter Vs3 dc=1.2
alter Vh3 dc=1.2
alter Vs4 dc=1.2
alter Vh4 dc=1.2
alter Vs5 dc=0
alter Vh5 dc=0
alter Vs6 dc=1.2
alter Vh6 dc=1.2
alter Vs7 dc=1.2
alter Vh7 dc=1.2
op
echo ROW 2 25.0 222 $&v(xt.vth_soft) $&v(xt.vth_hard) $&v(vref_buf) $&v(isense) $&i(vdda)
alter Vs0 dc=1.2
alter Vh0 dc=1.2
alter Vs1 dc=1.2
alter Vh1 dc=1.2
alter Vs2 dc=1.2
alter Vh2 dc=1.2
alter Vs3 dc=1.2
alter Vh3 dc=1.2
alter Vs4 dc=1.2
alter Vh4 dc=1.2
alter Vs5 dc=0
alter Vh5 dc=0
alter Vs6 dc=1.2
alter Vh6 dc=1.2
alter Vs7 dc=1.2
alter Vh7 dc=1.2
op
echo ROW 2 25.0 223 $&v(xt.vth_soft) $&v(xt.vth_hard) $&v(vref_buf) $&v(isense) $&i(vdda)
alter Vs0 dc=0
alter Vh0 dc=0
alter Vs1 dc=0
alter Vh1 dc=0
alter Vs2 dc=0
alter Vh2 dc=0
alter Vs3 dc=0
alter Vh3 dc=0
alter Vs4 dc=0
alter Vh4 dc=0
alter Vs5 dc=1.2
alter Vh5 dc=1.2
alter Vs6 dc=1.2
alter Vh6 dc=1.2
alter Vs7 dc=1.2
alter Vh7 dc=1.2
op
echo ROW 2 25.0 224 $&v(xt.vth_soft) $&v(xt.vth_hard) $&v(vref_buf) $&v(isense) $&i(vdda)
alter Vs0 dc=1.2
alter Vh0 dc=1.2
alter Vs1 dc=0
alter Vh1 dc=0
alter Vs2 dc=0
alter Vh2 dc=0
alter Vs3 dc=0
alter Vh3 dc=0
alter Vs4 dc=0
alter Vh4 dc=0
alter Vs5 dc=1.2
alter Vh5 dc=1.2
alter Vs6 dc=1.2
alter Vh6 dc=1.2
alter Vs7 dc=1.2
alter Vh7 dc=1.2
op
echo ROW 2 25.0 225 $&v(xt.vth_soft) $&v(xt.vth_hard) $&v(vref_buf) $&v(isense) $&i(vdda)
alter Vs0 dc=0
alter Vh0 dc=0
alter Vs1 dc=1.2
alter Vh1 dc=1.2
alter Vs2 dc=0
alter Vh2 dc=0
alter Vs3 dc=0
alter Vh3 dc=0
alter Vs4 dc=0
alter Vh4 dc=0
alter Vs5 dc=1.2
alter Vh5 dc=1.2
alter Vs6 dc=1.2
alter Vh6 dc=1.2
alter Vs7 dc=1.2
alter Vh7 dc=1.2
op
echo ROW 2 25.0 226 $&v(xt.vth_soft) $&v(xt.vth_hard) $&v(vref_buf) $&v(isense) $&i(vdda)
alter Vs0 dc=1.2
alter Vh0 dc=1.2
alter Vs1 dc=1.2
alter Vh1 dc=1.2
alter Vs2 dc=0
alter Vh2 dc=0
alter Vs3 dc=0
alter Vh3 dc=0
alter Vs4 dc=0
alter Vh4 dc=0
alter Vs5 dc=1.2
alter Vh5 dc=1.2
alter Vs6 dc=1.2
alter Vh6 dc=1.2
alter Vs7 dc=1.2
alter Vh7 dc=1.2
op
echo ROW 2 25.0 227 $&v(xt.vth_soft) $&v(xt.vth_hard) $&v(vref_buf) $&v(isense) $&i(vdda)
alter Vs0 dc=0
alter Vh0 dc=0
alter Vs1 dc=0
alter Vh1 dc=0
alter Vs2 dc=1.2
alter Vh2 dc=1.2
alter Vs3 dc=0
alter Vh3 dc=0
alter Vs4 dc=0
alter Vh4 dc=0
alter Vs5 dc=1.2
alter Vh5 dc=1.2
alter Vs6 dc=1.2
alter Vh6 dc=1.2
alter Vs7 dc=1.2
alter Vh7 dc=1.2
op
echo ROW 2 25.0 228 $&v(xt.vth_soft) $&v(xt.vth_hard) $&v(vref_buf) $&v(isense) $&i(vdda)
alter Vs0 dc=1.2
alter Vh0 dc=1.2
alter Vs1 dc=0
alter Vh1 dc=0
alter Vs2 dc=1.2
alter Vh2 dc=1.2
alter Vs3 dc=0
alter Vh3 dc=0
alter Vs4 dc=0
alter Vh4 dc=0
alter Vs5 dc=1.2
alter Vh5 dc=1.2
alter Vs6 dc=1.2
alter Vh6 dc=1.2
alter Vs7 dc=1.2
alter Vh7 dc=1.2
op
echo ROW 2 25.0 229 $&v(xt.vth_soft) $&v(xt.vth_hard) $&v(vref_buf) $&v(isense) $&i(vdda)
alter Vs0 dc=0
alter Vh0 dc=0
alter Vs1 dc=1.2
alter Vh1 dc=1.2
alter Vs2 dc=1.2
alter Vh2 dc=1.2
alter Vs3 dc=0
alter Vh3 dc=0
alter Vs4 dc=0
alter Vh4 dc=0
alter Vs5 dc=1.2
alter Vh5 dc=1.2
alter Vs6 dc=1.2
alter Vh6 dc=1.2
alter Vs7 dc=1.2
alter Vh7 dc=1.2
op
echo ROW 2 25.0 230 $&v(xt.vth_soft) $&v(xt.vth_hard) $&v(vref_buf) $&v(isense) $&i(vdda)
alter Vs0 dc=1.2
alter Vh0 dc=1.2
alter Vs1 dc=1.2
alter Vh1 dc=1.2
alter Vs2 dc=1.2
alter Vh2 dc=1.2
alter Vs3 dc=0
alter Vh3 dc=0
alter Vs4 dc=0
alter Vh4 dc=0
alter Vs5 dc=1.2
alter Vh5 dc=1.2
alter Vs6 dc=1.2
alter Vh6 dc=1.2
alter Vs7 dc=1.2
alter Vh7 dc=1.2
op
echo ROW 2 25.0 231 $&v(xt.vth_soft) $&v(xt.vth_hard) $&v(vref_buf) $&v(isense) $&i(vdda)
alter Vs0 dc=0
alter Vh0 dc=0
alter Vs1 dc=0
alter Vh1 dc=0
alter Vs2 dc=0
alter Vh2 dc=0
alter Vs3 dc=1.2
alter Vh3 dc=1.2
alter Vs4 dc=0
alter Vh4 dc=0
alter Vs5 dc=1.2
alter Vh5 dc=1.2
alter Vs6 dc=1.2
alter Vh6 dc=1.2
alter Vs7 dc=1.2
alter Vh7 dc=1.2
op
echo ROW 2 25.0 232 $&v(xt.vth_soft) $&v(xt.vth_hard) $&v(vref_buf) $&v(isense) $&i(vdda)
alter Vs0 dc=1.2
alter Vh0 dc=1.2
alter Vs1 dc=0
alter Vh1 dc=0
alter Vs2 dc=0
alter Vh2 dc=0
alter Vs3 dc=1.2
alter Vh3 dc=1.2
alter Vs4 dc=0
alter Vh4 dc=0
alter Vs5 dc=1.2
alter Vh5 dc=1.2
alter Vs6 dc=1.2
alter Vh6 dc=1.2
alter Vs7 dc=1.2
alter Vh7 dc=1.2
op
echo ROW 2 25.0 233 $&v(xt.vth_soft) $&v(xt.vth_hard) $&v(vref_buf) $&v(isense) $&i(vdda)
alter Vs0 dc=0
alter Vh0 dc=0
alter Vs1 dc=1.2
alter Vh1 dc=1.2
alter Vs2 dc=0
alter Vh2 dc=0
alter Vs3 dc=1.2
alter Vh3 dc=1.2
alter Vs4 dc=0
alter Vh4 dc=0
alter Vs5 dc=1.2
alter Vh5 dc=1.2
alter Vs6 dc=1.2
alter Vh6 dc=1.2
alter Vs7 dc=1.2
alter Vh7 dc=1.2
op
echo ROW 2 25.0 234 $&v(xt.vth_soft) $&v(xt.vth_hard) $&v(vref_buf) $&v(isense) $&i(vdda)
alter Vs0 dc=1.2
alter Vh0 dc=1.2
alter Vs1 dc=1.2
alter Vh1 dc=1.2
alter Vs2 dc=0
alter Vh2 dc=0
alter Vs3 dc=1.2
alter Vh3 dc=1.2
alter Vs4 dc=0
alter Vh4 dc=0
alter Vs5 dc=1.2
alter Vh5 dc=1.2
alter Vs6 dc=1.2
alter Vh6 dc=1.2
alter Vs7 dc=1.2
alter Vh7 dc=1.2
op
echo ROW 2 25.0 235 $&v(xt.vth_soft) $&v(xt.vth_hard) $&v(vref_buf) $&v(isense) $&i(vdda)
alter Vs0 dc=0
alter Vh0 dc=0
alter Vs1 dc=0
alter Vh1 dc=0
alter Vs2 dc=1.2
alter Vh2 dc=1.2
alter Vs3 dc=1.2
alter Vh3 dc=1.2
alter Vs4 dc=0
alter Vh4 dc=0
alter Vs5 dc=1.2
alter Vh5 dc=1.2
alter Vs6 dc=1.2
alter Vh6 dc=1.2
alter Vs7 dc=1.2
alter Vh7 dc=1.2
op
echo ROW 2 25.0 236 $&v(xt.vth_soft) $&v(xt.vth_hard) $&v(vref_buf) $&v(isense) $&i(vdda)
alter Vs0 dc=1.2
alter Vh0 dc=1.2
alter Vs1 dc=0
alter Vh1 dc=0
alter Vs2 dc=1.2
alter Vh2 dc=1.2
alter Vs3 dc=1.2
alter Vh3 dc=1.2
alter Vs4 dc=0
alter Vh4 dc=0
alter Vs5 dc=1.2
alter Vh5 dc=1.2
alter Vs6 dc=1.2
alter Vh6 dc=1.2
alter Vs7 dc=1.2
alter Vh7 dc=1.2
op
echo ROW 2 25.0 237 $&v(xt.vth_soft) $&v(xt.vth_hard) $&v(vref_buf) $&v(isense) $&i(vdda)
alter Vs0 dc=0
alter Vh0 dc=0
alter Vs1 dc=1.2
alter Vh1 dc=1.2
alter Vs2 dc=1.2
alter Vh2 dc=1.2
alter Vs3 dc=1.2
alter Vh3 dc=1.2
alter Vs4 dc=0
alter Vh4 dc=0
alter Vs5 dc=1.2
alter Vh5 dc=1.2
alter Vs6 dc=1.2
alter Vh6 dc=1.2
alter Vs7 dc=1.2
alter Vh7 dc=1.2
op
echo ROW 2 25.0 238 $&v(xt.vth_soft) $&v(xt.vth_hard) $&v(vref_buf) $&v(isense) $&i(vdda)
alter Vs0 dc=1.2
alter Vh0 dc=1.2
alter Vs1 dc=1.2
alter Vh1 dc=1.2
alter Vs2 dc=1.2
alter Vh2 dc=1.2
alter Vs3 dc=1.2
alter Vh3 dc=1.2
alter Vs4 dc=0
alter Vh4 dc=0
alter Vs5 dc=1.2
alter Vh5 dc=1.2
alter Vs6 dc=1.2
alter Vh6 dc=1.2
alter Vs7 dc=1.2
alter Vh7 dc=1.2
op
echo ROW 2 25.0 239 $&v(xt.vth_soft) $&v(xt.vth_hard) $&v(vref_buf) $&v(isense) $&i(vdda)
alter Vs0 dc=0
alter Vh0 dc=0
alter Vs1 dc=0
alter Vh1 dc=0
alter Vs2 dc=0
alter Vh2 dc=0
alter Vs3 dc=0
alter Vh3 dc=0
alter Vs4 dc=1.2
alter Vh4 dc=1.2
alter Vs5 dc=1.2
alter Vh5 dc=1.2
alter Vs6 dc=1.2
alter Vh6 dc=1.2
alter Vs7 dc=1.2
alter Vh7 dc=1.2
op
echo ROW 2 25.0 240 $&v(xt.vth_soft) $&v(xt.vth_hard) $&v(vref_buf) $&v(isense) $&i(vdda)
alter Vs0 dc=1.2
alter Vh0 dc=1.2
alter Vs1 dc=0
alter Vh1 dc=0
alter Vs2 dc=0
alter Vh2 dc=0
alter Vs3 dc=0
alter Vh3 dc=0
alter Vs4 dc=1.2
alter Vh4 dc=1.2
alter Vs5 dc=1.2
alter Vh5 dc=1.2
alter Vs6 dc=1.2
alter Vh6 dc=1.2
alter Vs7 dc=1.2
alter Vh7 dc=1.2
op
echo ROW 2 25.0 241 $&v(xt.vth_soft) $&v(xt.vth_hard) $&v(vref_buf) $&v(isense) $&i(vdda)
alter Vs0 dc=0
alter Vh0 dc=0
alter Vs1 dc=1.2
alter Vh1 dc=1.2
alter Vs2 dc=0
alter Vh2 dc=0
alter Vs3 dc=0
alter Vh3 dc=0
alter Vs4 dc=1.2
alter Vh4 dc=1.2
alter Vs5 dc=1.2
alter Vh5 dc=1.2
alter Vs6 dc=1.2
alter Vh6 dc=1.2
alter Vs7 dc=1.2
alter Vh7 dc=1.2
op
echo ROW 2 25.0 242 $&v(xt.vth_soft) $&v(xt.vth_hard) $&v(vref_buf) $&v(isense) $&i(vdda)
alter Vs0 dc=1.2
alter Vh0 dc=1.2
alter Vs1 dc=1.2
alter Vh1 dc=1.2
alter Vs2 dc=0
alter Vh2 dc=0
alter Vs3 dc=0
alter Vh3 dc=0
alter Vs4 dc=1.2
alter Vh4 dc=1.2
alter Vs5 dc=1.2
alter Vh5 dc=1.2
alter Vs6 dc=1.2
alter Vh6 dc=1.2
alter Vs7 dc=1.2
alter Vh7 dc=1.2
op
echo ROW 2 25.0 243 $&v(xt.vth_soft) $&v(xt.vth_hard) $&v(vref_buf) $&v(isense) $&i(vdda)
alter Vs0 dc=0
alter Vh0 dc=0
alter Vs1 dc=0
alter Vh1 dc=0
alter Vs2 dc=1.2
alter Vh2 dc=1.2
alter Vs3 dc=0
alter Vh3 dc=0
alter Vs4 dc=1.2
alter Vh4 dc=1.2
alter Vs5 dc=1.2
alter Vh5 dc=1.2
alter Vs6 dc=1.2
alter Vh6 dc=1.2
alter Vs7 dc=1.2
alter Vh7 dc=1.2
op
echo ROW 2 25.0 244 $&v(xt.vth_soft) $&v(xt.vth_hard) $&v(vref_buf) $&v(isense) $&i(vdda)
alter Vs0 dc=1.2
alter Vh0 dc=1.2
alter Vs1 dc=0
alter Vh1 dc=0
alter Vs2 dc=1.2
alter Vh2 dc=1.2
alter Vs3 dc=0
alter Vh3 dc=0
alter Vs4 dc=1.2
alter Vh4 dc=1.2
alter Vs5 dc=1.2
alter Vh5 dc=1.2
alter Vs6 dc=1.2
alter Vh6 dc=1.2
alter Vs7 dc=1.2
alter Vh7 dc=1.2
op
echo ROW 2 25.0 245 $&v(xt.vth_soft) $&v(xt.vth_hard) $&v(vref_buf) $&v(isense) $&i(vdda)
alter Vs0 dc=0
alter Vh0 dc=0
alter Vs1 dc=1.2
alter Vh1 dc=1.2
alter Vs2 dc=1.2
alter Vh2 dc=1.2
alter Vs3 dc=0
alter Vh3 dc=0
alter Vs4 dc=1.2
alter Vh4 dc=1.2
alter Vs5 dc=1.2
alter Vh5 dc=1.2
alter Vs6 dc=1.2
alter Vh6 dc=1.2
alter Vs7 dc=1.2
alter Vh7 dc=1.2
op
echo ROW 2 25.0 246 $&v(xt.vth_soft) $&v(xt.vth_hard) $&v(vref_buf) $&v(isense) $&i(vdda)
alter Vs0 dc=1.2
alter Vh0 dc=1.2
alter Vs1 dc=1.2
alter Vh1 dc=1.2
alter Vs2 dc=1.2
alter Vh2 dc=1.2
alter Vs3 dc=0
alter Vh3 dc=0
alter Vs4 dc=1.2
alter Vh4 dc=1.2
alter Vs5 dc=1.2
alter Vh5 dc=1.2
alter Vs6 dc=1.2
alter Vh6 dc=1.2
alter Vs7 dc=1.2
alter Vh7 dc=1.2
op
echo ROW 2 25.0 247 $&v(xt.vth_soft) $&v(xt.vth_hard) $&v(vref_buf) $&v(isense) $&i(vdda)
alter Vs0 dc=0
alter Vh0 dc=0
alter Vs1 dc=0
alter Vh1 dc=0
alter Vs2 dc=0
alter Vh2 dc=0
alter Vs3 dc=1.2
alter Vh3 dc=1.2
alter Vs4 dc=1.2
alter Vh4 dc=1.2
alter Vs5 dc=1.2
alter Vh5 dc=1.2
alter Vs6 dc=1.2
alter Vh6 dc=1.2
alter Vs7 dc=1.2
alter Vh7 dc=1.2
op
echo ROW 2 25.0 248 $&v(xt.vth_soft) $&v(xt.vth_hard) $&v(vref_buf) $&v(isense) $&i(vdda)
alter Vs0 dc=1.2
alter Vh0 dc=1.2
alter Vs1 dc=0
alter Vh1 dc=0
alter Vs2 dc=0
alter Vh2 dc=0
alter Vs3 dc=1.2
alter Vh3 dc=1.2
alter Vs4 dc=1.2
alter Vh4 dc=1.2
alter Vs5 dc=1.2
alter Vh5 dc=1.2
alter Vs6 dc=1.2
alter Vh6 dc=1.2
alter Vs7 dc=1.2
alter Vh7 dc=1.2
op
echo ROW 2 25.0 249 $&v(xt.vth_soft) $&v(xt.vth_hard) $&v(vref_buf) $&v(isense) $&i(vdda)
alter Vs0 dc=0
alter Vh0 dc=0
alter Vs1 dc=1.2
alter Vh1 dc=1.2
alter Vs2 dc=0
alter Vh2 dc=0
alter Vs3 dc=1.2
alter Vh3 dc=1.2
alter Vs4 dc=1.2
alter Vh4 dc=1.2
alter Vs5 dc=1.2
alter Vh5 dc=1.2
alter Vs6 dc=1.2
alter Vh6 dc=1.2
alter Vs7 dc=1.2
alter Vh7 dc=1.2
op
echo ROW 2 25.0 250 $&v(xt.vth_soft) $&v(xt.vth_hard) $&v(vref_buf) $&v(isense) $&i(vdda)
alter Vs0 dc=1.2
alter Vh0 dc=1.2
alter Vs1 dc=1.2
alter Vh1 dc=1.2
alter Vs2 dc=0
alter Vh2 dc=0
alter Vs3 dc=1.2
alter Vh3 dc=1.2
alter Vs4 dc=1.2
alter Vh4 dc=1.2
alter Vs5 dc=1.2
alter Vh5 dc=1.2
alter Vs6 dc=1.2
alter Vh6 dc=1.2
alter Vs7 dc=1.2
alter Vh7 dc=1.2
op
echo ROW 2 25.0 251 $&v(xt.vth_soft) $&v(xt.vth_hard) $&v(vref_buf) $&v(isense) $&i(vdda)
alter Vs0 dc=0
alter Vh0 dc=0
alter Vs1 dc=0
alter Vh1 dc=0
alter Vs2 dc=1.2
alter Vh2 dc=1.2
alter Vs3 dc=1.2
alter Vh3 dc=1.2
alter Vs4 dc=1.2
alter Vh4 dc=1.2
alter Vs5 dc=1.2
alter Vh5 dc=1.2
alter Vs6 dc=1.2
alter Vh6 dc=1.2
alter Vs7 dc=1.2
alter Vh7 dc=1.2
op
echo ROW 2 25.0 252 $&v(xt.vth_soft) $&v(xt.vth_hard) $&v(vref_buf) $&v(isense) $&i(vdda)
alter Vs0 dc=1.2
alter Vh0 dc=1.2
alter Vs1 dc=0
alter Vh1 dc=0
alter Vs2 dc=1.2
alter Vh2 dc=1.2
alter Vs3 dc=1.2
alter Vh3 dc=1.2
alter Vs4 dc=1.2
alter Vh4 dc=1.2
alter Vs5 dc=1.2
alter Vh5 dc=1.2
alter Vs6 dc=1.2
alter Vh6 dc=1.2
alter Vs7 dc=1.2
alter Vh7 dc=1.2
op
echo ROW 2 25.0 253 $&v(xt.vth_soft) $&v(xt.vth_hard) $&v(vref_buf) $&v(isense) $&i(vdda)
alter Vs0 dc=0
alter Vh0 dc=0
alter Vs1 dc=1.2
alter Vh1 dc=1.2
alter Vs2 dc=1.2
alter Vh2 dc=1.2
alter Vs3 dc=1.2
alter Vh3 dc=1.2
alter Vs4 dc=1.2
alter Vh4 dc=1.2
alter Vs5 dc=1.2
alter Vh5 dc=1.2
alter Vs6 dc=1.2
alter Vh6 dc=1.2
alter Vs7 dc=1.2
alter Vh7 dc=1.2
op
echo ROW 2 25.0 254 $&v(xt.vth_soft) $&v(xt.vth_hard) $&v(vref_buf) $&v(isense) $&i(vdda)
alter Vs0 dc=1.2
alter Vh0 dc=1.2
alter Vs1 dc=1.2
alter Vh1 dc=1.2
alter Vs2 dc=1.2
alter Vh2 dc=1.2
alter Vs3 dc=1.2
alter Vh3 dc=1.2
alter Vs4 dc=1.2
alter Vh4 dc=1.2
alter Vs5 dc=1.2
alter Vh5 dc=1.2
alter Vs6 dc=1.2
alter Vh6 dc=1.2
alter Vs7 dc=1.2
alter Vh7 dc=1.2
op
echo ROW 2 25.0 255 $&v(xt.vth_soft) $&v(xt.vth_hard) $&v(vref_buf) $&v(isense) $&i(vdda)
echo FINGERPRINT 2
print @n.xt.xdacs.xms7_0a.nsg13_hv_nmos[w]
print @n.xt.xdacs.xms7_0a.nsg13_hv_nmos[l]
print @n.xt.xdacs.xms7_0a.nsg13_hv_nmos[delvto]
print @n.xt.xdacs.xms7_0a.nsg13_hv_nmos[factuo]
print @n.xt.xdach.xms7_0b.nsg13_hv_nmos[w]
print @n.xt.xdach.xms7_0b.nsg13_hv_nmos[l]
print @n.xt.xdach.xms7_0b.nsg13_hv_nmos[delvto]
print @n.xt.xdach.xms7_0b.nsg13_hv_nmos[factuo]
print @n.xt.xcs.xm1.nsg13_lv_nmos[w]
print @n.xt.xcs.xm1.nsg13_lv_nmos[l]
print @n.xt.xcs.xm1.nsg13_lv_nmos[delvto]
print @n.xt.xcs.xm1.nsg13_lv_nmos[factuo]
print @n.xt.xch.xm1.nsg13_lv_nmos[w]
print @n.xt.xch.xm1.nsg13_lv_nmos[l]
print @n.xt.xch.xm1.nsg13_lv_nmos[delvto]
print @n.xt.xch.xm1.nsg13_lv_nmos[factuo]
print @n.xs.xref.xm1.nsg13_hv_pmos[w]
print @n.xs.xref.xm1.nsg13_hv_pmos[l]
print @n.xs.xref.xm1.nsg13_hv_pmos[delvto]
print @n.xs.xref.xm1.nsg13_hv_pmos[factuo]
print @n.xt.xdacs.xru0.nr1[nsmm_rsh]
print @n.xt.xdacs.xru0.nr1[nsmm_w]
print @n.xt.xdacs.xru0.nr1[nsmm_l]
echo QUALIFICATION_END
quit 0
.endc
.end
