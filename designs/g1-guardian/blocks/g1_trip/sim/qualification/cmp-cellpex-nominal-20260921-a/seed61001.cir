* Fine symmetric comparator staircase
.lib /foss/pdks/ihp-sg13g2/libs.tech/ngspice/models/cornerMOSlv.lib mos_tt
.temp 25
.include qualification/cmp-cellpex-nominal-20260921-a/cmp.spice
Vdd vdd 0 1.2
Vcm cm 0 .75
Vod od 0 pwl(0 -0.002 9.9e-08 -0.002 1e-07 -0.00195 1.99e-07 -0.00195 2e-07 -0.0019 2.99e-07 -0.0019 3e-07 -0.00185 3.99e-07 -0.00185 4e-07 -0.0018 4.99e-07 -0.0018 5e-07 -0.00175 5.99e-07 -0.00175 6e-07 -0.0017 6.99e-07 -0.0017 7e-07 -0.00165 7.99e-07 -0.00165 8e-07 -0.0016 8.99e-07 -0.0016 9e-07 -0.00155 9.99e-07 -0.00155 1e-06 -0.0015 1.099e-06 -0.0015 1.1e-06 -0.00145 1.199e-06 -0.00145 1.2e-06 -0.0014 1.299e-06 -0.0014 1.3e-06 -0.00135 1.399e-06 -0.00135 1.4e-06 -0.0013 1.499e-06 -0.0013 1.5e-06 -0.00125 1.599e-06 -0.00125 1.6e-06 -0.0012 1.699e-06 -0.0012 1.7e-06 -0.00115 1.799e-06 -0.00115 1.8e-06 -0.0011 1.899e-06 -0.0011 1.9e-06 -0.00105 1.999e-06 -0.00105 2e-06 -0.001 2.099e-06 -0.001 2.1e-06 -0.00095 2.199e-06 -0.00095 2.2e-06 -0.0009 2.299e-06 -0.0009 2.3e-06 -0.00085 2.399e-06 -0.00085 2.4e-06 -0.0008 2.499e-06 -0.0008 2.5e-06 -0.00075 2.599e-06 -0.00075 2.6e-06 -0.0007 2.699e-06 -0.0007 2.7e-06 -0.00065 2.799e-06 -0.00065 2.8e-06 -0.0006 2.899e-06 -0.0006 2.9e-06 -0.00055 2.999e-06 -0.00055 3e-06 -0.0005 3.099e-06 -0.0005 3.1e-06 -0.00045 3.199e-06 -0.00045 3.2e-06 -0.0004 3.299e-06 -0.0004 3.3e-06 -0.00035 3.399e-06 -0.00035 3.4e-06 -0.0003 3.499e-06 -0.0003 3.5e-06 -0.00025 3.599e-06 -0.00025 3.6e-06 -0.0002 3.699e-06 -0.0002 3.7e-06 -0.00015 3.799e-06 -0.00015 3.8e-06 -9.99999999999999e-05 3.899e-06 -9.99999999999999e-05 3.9e-06 -4.99999999999998e-05 3.999e-06 -4.99999999999998e-05 4e-06 0 4.099e-06 0 4.1e-06 5.00000000000003e-05 4.199e-06 5.00000000000003e-05 4.2e-06 0.0001 4.299e-06 0.0001 4.3e-06 0.00015 4.399e-06 0.00015 4.4e-06 0.0002 4.499e-06 0.0002 4.5e-06 0.00025 4.599e-06 0.00025 4.6e-06 0.0003 4.699e-06 0.0003 4.7e-06 0.00035 4.799e-06 0.00035 4.8e-06 0.0004 4.899e-06 0.0004 4.9e-06 0.00045 4.999e-06 0.00045 5e-06 0.0005 5.099e-06 0.0005 5.1e-06 0.00055 5.199e-06 0.00055 5.2e-06 0.0006 5.299e-06 0.0006 5.3e-06 0.00065 5.399e-06 0.00065 5.4e-06 0.0007 5.499e-06 0.0007 5.5e-06 0.00075 5.599e-06 0.00075 5.6e-06 0.0008 5.699e-06 0.0008 5.7e-06 0.00085 5.799e-06 0.00085 5.8e-06 0.0009 5.899e-06 0.0009 5.9e-06 0.00095 5.999e-06 0.00095 6e-06 0.001 6.099e-06 0.001 6.1e-06 0.00105 6.199e-06 0.00105 6.2e-06 0.0011 6.299e-06 0.0011 6.3e-06 0.00115 6.399e-06 0.00115 6.4e-06 0.0012 6.499e-06 0.0012 6.5e-06 0.00125 6.599e-06 0.00125 6.6e-06 0.0013 6.699e-06 0.0013 6.7e-06 0.00135 6.799e-06 0.00135 6.8e-06 0.0014 6.899e-06 0.0014 6.9e-06 0.00145 6.999e-06 0.00145 7e-06 0.0015 7.099e-06 0.0015 7.1e-06 0.00155 7.199e-06 0.00155 7.2e-06 0.0016 7.299e-06 0.0016 7.3e-06 0.00165 7.399e-06 0.00165 7.4e-06 0.0017 7.499e-06 0.0017 7.5e-06 0.00175 7.599e-06 0.00175 7.6e-06 0.0018 7.699e-06 0.0018 7.7e-06 0.00185 7.799e-06 0.00185 7.8e-06 0.0019 7.899e-06 0.0019 7.9e-06 0.00195 7.999e-06 0.00195 8e-06 0.002)
Ep inp0 0 value={v(cm)+v(od)/2}
En inn0 0 value={v(cm)-v(od)/2}
Rp inp0 inp 1000
Rn inn0 inn 1000
Cp inp 0 1p
Cn inn 0 1p
Vclk clk 0 pulse(0 1.2 20n .2n .2n 50n 100n)
X1 inp inn clk q qb vdd 0 g1_cmp
Cq q 0 10f
Cqb qb 0 10f
.save v(q) v(qb) v(inp) v(inn) v(clk)
.option reltol=1e-5 vntol=1e-7 abstol=1e-14 method=trap
.control
set num_threads=1
set numdgt=15
setseed 61001
reset
set temp=25.0
alter Vcm dc=0.75
tran .2n 8.09e-06 0 0.2n
set wr_singlescale
set wr_vecnames
wrdata qualification/cmp-cellpex-nominal-20260921-a/seed61001_t0_cm0.75.dat v(q) v(qb) v(inp) v(inn) v(clk)
echo FINGERPRINT seed61001_t0_cm0.75
print @n.x1.xm6.nsg13_lv_nmos[w]
print @n.x1.xm6.nsg13_lv_nmos[l]
print @n.x1.xm6.nsg13_lv_nmos[delvto]
print @n.x1.xm6.nsg13_lv_nmos[factuo]
print @n.x1.xm7.nsg13_lv_nmos[w]
print @n.x1.xm7.nsg13_lv_nmos[l]
print @n.x1.xm7.nsg13_lv_nmos[delvto]
print @n.x1.xm7.nsg13_lv_nmos[factuo]
print @n.x1.xm8.nsg13_lv_nmos[w]
print @n.x1.xm8.nsg13_lv_nmos[l]
print @n.x1.xm8.nsg13_lv_nmos[delvto]
print @n.x1.xm8.nsg13_lv_nmos[factuo]
print @n.x1.xm9.nsg13_lv_nmos[w]
print @n.x1.xm9.nsg13_lv_nmos[l]
print @n.x1.xm9.nsg13_lv_nmos[delvto]
print @n.x1.xm9.nsg13_lv_nmos[factuo]
print @n.x1.xm12.nsg13_lv_nmos[w]
print @n.x1.xm12.nsg13_lv_nmos[l]
print @n.x1.xm12.nsg13_lv_nmos[delvto]
print @n.x1.xm12.nsg13_lv_nmos[factuo]
print @n.x1.xm13.nsg13_lv_nmos[w]
print @n.x1.xm13.nsg13_lv_nmos[l]
print @n.x1.xm13.nsg13_lv_nmos[delvto]
print @n.x1.xm13.nsg13_lv_nmos[factuo]
print @n.x1.xm14.nsg13_lv_nmos[w]
print @n.x1.xm14.nsg13_lv_nmos[l]
print @n.x1.xm14.nsg13_lv_nmos[delvto]
print @n.x1.xm14.nsg13_lv_nmos[factuo]
print @n.x1.xm15.nsg13_lv_nmos[w]
print @n.x1.xm15.nsg13_lv_nmos[l]
print @n.x1.xm15.nsg13_lv_nmos[delvto]
print @n.x1.xm15.nsg13_lv_nmos[factuo]
echo QUALIFICATION_END
quit 0
.endc
.end
