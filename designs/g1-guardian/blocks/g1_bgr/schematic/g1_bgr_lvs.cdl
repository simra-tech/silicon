* G1_BGR LVS reference netlist, generated by make_lvs_cdl.py from xschem/g1_bgr.spice (frozen schematic).
* Format conversion only, plus 9 dummy HBTs tied to vss (see the docstring of make_lvs_cdl.py).
.subckt g1_bgr vdd vss r4 vref iptat pbias pcasc vbe dvbe
MMP1 d1 pbias vdd vdd sg13_hv_pmos w=10u l=4u ng=1 m=1
MMC1 n1 pcasc d1 d1 sg13_hv_pmos w=10u l=4u ng=1 m=1
MMP2 d2 pbias vdd vdd sg13_hv_pmos w=10u l=4u ng=1 m=1
MMC2 pbias pcasc d2 d2 sg13_hv_pmos w=10u l=4u ng=1 m=1
RRB pbias pcasc vss rppd w=1u l=500u m=1 b=0
MMNC1 n1 vb2 vbe vss sg13_hv_nmos w=20u l=1u ng=1 m=1
MMNC2 pcasc vb2 c2 vss sg13_hv_nmos w=20u l=1u ng=1 m=1
MMP5 d5 pbias vdd vdd sg13_hv_pmos w=10u l=4u ng=1 m=1
MMC5 vb2 pcasc d5 d5 sg13_hv_pmos w=10u l=4u ng=1 m=1
RRX vb2 vd1 vss rppd w=1u l=192u m=1 b=0
QQD1 vd1 vd1 vd2 vss npn13G2 le=900n we=70n Nx=1
QQD2 vd2 vd2 vss vss npn13G2 le=900n we=70n Nx=1
QQ1 vbe vbe vss vss npn13G2 le=900n we=70n Nx=1
QQ1B vbe b1b vss vss npn13G2 le=900n we=70n Nx=1
QQ2A c2 vbe dvbe vss npn13G2 le=900n we=70n Nx=1
QQ2B c2 vbe dvbe vss npn13G2 le=900n we=70n Nx=1
QQ2C c2 vbe dvbe vss npn13G2 le=900n we=70n Nx=1
QQ2D c2 vbe dvbe vss npn13G2 le=900n we=70n Nx=1
QQ2E c2 vbe dvbe vss npn13G2 le=900n we=70n Nx=1
QQ2F c2 vbe dvbe vss npn13G2 le=900n we=70n Nx=1
QQ2G c2 vbe dvbe vss npn13G2 le=900n we=70n Nx=1
QQ2H c2 vbe dvbe vss npn13G2 le=900n we=70n Nx=1
RR1 dvbe vss vss rppd w=1u l=51.5u m=1 b=0
MMP3 d3 pbias vdd vdd sg13_hv_pmos w=10u l=4u ng=1 m=1
MMC3 vref pcasc d3 d3 sg13_hv_pmos w=10u l=4u ng=1 m=1
RR2 vref vbe3 vss rppd w=1u l=315u m=1 b=0
QQ3 vbe3 vbe3 vss vss npn13G2 le=900n we=70n Nx=1
MMP4 d4 pbias vdd vdd sg13_hv_pmos w=10u l=4u ng=1 m=1
MMC4 iptat pcasc d4 d4 sg13_hv_pmos w=10u l=4u ng=1 m=1
MMPS det pbias vdd vdd sg13_hv_pmos w=10u l=4u ng=1 m=1
RRDET det vss vss rhigh w=0.5u l=735u m=1 b=0
MMNI kick det vss vss sg13_hv_nmos w=1u l=0.5u ng=1 m=1
MMPI kick det vdd vdd sg13_hv_pmos w=2u l=0.5u ng=1 m=1
MMKFB pbias kick vss vss sg13_hv_nmos w=1u l=4u ng=1 m=1
MMSW1 vbe r4 b1b vss sg13_hv_nmos w=2u l=0.5u ng=1 m=1
MMSW2 b1b r4n vss vss sg13_hv_nmos w=1u l=0.5u ng=1 m=1
MMNI2 r4n r4 vss vss sg13_hv_nmos w=1u l=0.5u ng=1 m=1
MMPI2 r4n r4 vdd vdd sg13_hv_pmos w=2u l=0.5u ng=1 m=1
QDUM1 vss vss vss vss npn13G2 le=900n we=70n Nx=1
QDUM2 vss vss vss vss npn13G2 le=900n we=70n Nx=1
QDUM3 vss vss vss vss npn13G2 le=900n we=70n Nx=1
QDUM4 vss vss vss vss npn13G2 le=900n we=70n Nx=1
QDUM5 vss vss vss vss npn13G2 le=900n we=70n Nx=1
QDUM6 vss vss vss vss npn13G2 le=900n we=70n Nx=1
QDUM7 vss vss vss vss npn13G2 le=900n we=70n Nx=1
QDUM8 vss vss vss vss npn13G2 le=900n we=70n Nx=1
QDUM9 vss vss vss vss npn13G2 le=900n we=70n Nx=1
.ends
