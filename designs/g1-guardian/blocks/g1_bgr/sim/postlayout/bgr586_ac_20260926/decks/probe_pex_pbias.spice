* G1_BGR bgr586 post-layout netlist: kpex 2.5D extraction (--mode CC) of layout/coordinated_supply_followup_20260923/evidence/supply-20260923-r1/candidate/bank.gds (sha256 e3ecfc62...), reformatted for ngspice
* by sim/postlayout/make_pex_netlist.py (see its docstring; no circuit content changed).
* source: reports/pex/cc_bgr586_20260924/g1_bgr_k25d_pex_netlist.spice; see sim/postlayout/README_bgr586_pex.md
.subckt g1_bgr vdd vss r4 vref iptat pbias pcasc vbe dvbe
XR1 n_I43 vref vss rppd w=1u l=53.465u b=0 m=1
XR2 n_I42 n_17 vss rppd w=1u l=53.465u b=0 m=1
XR3 n_I42 n_17 vss rppd w=1u l=53.465u b=0 m=1
XR4 n_I42 n_I39 vss rppd w=1u l=53.465u b=0 m=1
XR5 n_I29 n_I39 vss rppd w=1u l=53.465u b=0 m=1
XR6 n_I29 n_I39 vss rppd w=1u l=53.465u b=0 m=1
XR7 n_I43 vref vss rppd w=1u l=53.465u b=0 m=1
XR8 n_I43 vref vss rppd w=1u l=53.465u b=0 m=1
XR9 n_I29 n_I36 vss rppd w=1u l=53.465u b=0 m=1
XR10 n_I29 n_I36 vss rppd w=1u l=53.465u b=0 m=1
XR11 n_I43 n_I36 vss rppd w=1u l=53.465u b=0 m=1
XR12 n_I43 n_I36 vss rppd w=1u l=53.465u b=0 m=1
XR13 n_I29 n_I39 vss rppd w=1u l=53.465u b=0 m=1
XR14 n_I42 n_I39 vss rppd w=1u l=53.465u b=0 m=1
XR15 n_I43 n_I36 vss rppd w=1u l=53.465u b=0 m=1
XR16 n_I29 n_I39 vss rppd w=1u l=53.465u b=0 m=1
XR17 n_I43 vref vss rppd w=1u l=53.465u b=0 m=1
XR18 n_I29 n_I36 vss rppd w=1u l=53.465u b=0 m=1
XR19 n_I29 n_I36 vss rppd w=1u l=53.465u b=0 m=1
XR20 n_I42 n_17 vss rppd w=1u l=53.465u b=0 m=1
XR21 n_I43 n_I36 vss rppd w=1u l=53.465u b=0 m=1
XR22 n_I42 n_I39 vss rppd w=1u l=53.465u b=0 m=1
XR23 n_I42 n_I39 vss rppd w=1u l=53.465u b=0 m=1
XR24 n_I42 n_17 vss rppd w=1u l=53.465u b=0 m=1
XR25 vss n_I31 vss rhigh w=0.5u l=49u b=0 m=1
XR26 n_I17 n_I33 vss rhigh w=0.5u l=49u b=0 m=1
XR27 n_I16 n_I33 vss rhigh w=0.5u l=49u b=0 m=1
XR28 n_I19 n_I32 vss rhigh w=0.5u l=49u b=0 m=1
XR29 n_I15 n_I32 vss rhigh w=0.5u l=49u b=0 m=1
XR30 n_I16 n_I28 vss rhigh w=0.5u l=49u b=0 m=1
XR31 n_I15 n_10 vss rhigh w=0.5u l=49u b=0 m=1
XR32 n_I17 n_I31 vss rhigh w=0.5u l=49u b=0 m=1
XR33 n_I19 n_I25 vss rhigh w=0.5u l=49u b=0 m=1
XR34 n_I22 n_I27 vss rhigh w=0.5u l=49u b=0 m=1
XR35 n_I22 n_I28 vss rhigh w=0.5u l=49u b=0 m=1
XR36 n_I20 n_I25 vss rhigh w=0.5u l=49u b=0 m=1
XR37 n_I21 n_I26 vss rhigh w=0.5u l=49u b=0 m=1
XR38 n_I20 n_I26 vss rhigh w=0.5u l=49u b=0 m=1
XR39 n_I21 n_I27 vss rhigh w=0.5u l=49u b=0 m=1
XR40 vss dvbe vss rppd w=1u l=51.5u b=0 m=1
XR41 vss dvbe vss rppd w=1u l=51.5u b=0 m=1
XR42 vss dvbe vss rppd w=1u l=51.5u b=0 m=1
XR43 vss dvbe vss rppd w=1u l=51.5u b=0 m=1
XR44 vss dvbe vss rppd w=1u l=51.5u b=0 m=1
XR45 vss dvbe vss rppd w=1u l=51.5u b=0 m=1
XR46 vss dvbe vss rppd w=1u l=51.5u b=0 m=1
XR47 vss dvbe vss rppd w=1u l=51.5u b=0 m=1
XR48 vss dvbe vss rppd w=1u l=51.5u b=0 m=1
XR49 vss dvbe vss rppd w=1u l=51.5u b=0 m=1
XR50 vss dvbe vss rppd w=1u l=51.5u b=0 m=1
XR51 vss dvbe vss rppd w=1u l=51.5u b=0 m=1
XR52 vss dvbe vss rppd w=1u l=51.5u b=0 m=1
XR53 vss dvbe vss rppd w=1u l=51.5u b=0 m=1
XR54 vss dvbe vss rppd w=1u l=51.5u b=0 m=1
XR55 vss dvbe vss rppd w=1u l=51.5u b=0 m=1
XR56 vss dvbe vss rppd w=1u l=51.5u b=0 m=1
XR57 vss dvbe vss rppd w=1u l=51.5u b=0 m=1
XR58 vss dvbe vss rppd w=1u l=51.5u b=0 m=1
XR59 vss dvbe vss rppd w=1u l=51.5u b=0 m=1
XR60 vss dvbe vss rppd w=1u l=51.5u b=0 m=1
XR61 vss dvbe vss rppd w=1u l=51.5u b=0 m=1
XR62 vss dvbe vss rppd w=1u l=51.5u b=0 m=1
XR63 vss dvbe vss rppd w=1u l=51.5u b=0 m=1
XR64 n_I13 n_16 vss rppd w=1u l=48u b=0 m=1
XR65 n_I13 n_16 vss rppd w=1u l=48u b=0 m=1
XR66 n_I13 n_I24 vss rppd w=1u l=48u b=0 m=1
XR67 n_I14 n_18 vss rppd w=1u l=48u b=0 m=1
XR68 n_I13 n_16 vss rppd w=1u l=48u b=0 m=1
XR69 n_I14 n_18 vss rppd w=1u l=48u b=0 m=1
XR70 n_I14 n_18 vss rppd w=1u l=48u b=0 m=1
XR71 n_I14 n_18 vss rppd w=1u l=48u b=0 m=1
XR72 n_I13 n_16 vss rppd w=1u l=48u b=0 m=1
XR73 n_I14 n_18 vss rppd w=1u l=48u b=0 m=1
XR74 n_I14 n_18 vss rppd w=1u l=48u b=0 m=1
XR75 n_I14 n_18 vss rppd w=1u l=48u b=0 m=1
XR76 n_I13 n_16 vss rppd w=1u l=48u b=0 m=1
XR77 n_I14 n_I24 vss rppd w=1u l=48u b=0 m=1
XR78 n_I14 n_I24 vss rppd w=1u l=48u b=0 m=1
XR79 n_I14 n_I24 vss rppd w=1u l=48u b=0 m=1
XR80 n_I14 n_I24 vss rppd w=1u l=48u b=0 m=1
XR81 n_I14 n_I24 vss rppd w=1u l=48u b=0 m=1
XR82 n_I14 n_I24 vss rppd w=1u l=48u b=0 m=1
XR83 n_I14 n_I24 vss rppd w=1u l=48u b=0 m=1
XR84 n_I14 n_I24 vss rppd w=1u l=48u b=0 m=1
XR85 n_I14 n_I24 vss rppd w=1u l=48u b=0 m=1
XR86 n_I14 n_I24 vss rppd w=1u l=48u b=0 m=1
XR87 n_I14 n_I24 vss rppd w=1u l=48u b=0 m=1
XR88 n_I14 n_I24 vss rppd w=1u l=48u b=0 m=1
XR89 n_I14 n_I24 vss rppd w=1u l=48u b=0 m=1
XR90 n_I14 n_I24 vss rppd w=1u l=48u b=0 m=1
XR91 n_I13 n_I24 vss rppd w=1u l=48u b=0 m=1
XR92 n_I14 n_I24 vss rppd w=1u l=48u b=0 m=1
XR93 n_I13 n_I24 vss rppd w=1u l=48u b=0 m=1
XR94 n_I14 n_18 vss rppd w=1u l=48u b=0 m=1
XR95 n_I14 n_I24 vss rppd w=1u l=48u b=0 m=1
XR96 n_I14 n_I24 vss rppd w=1u l=48u b=0 m=1
XR97 n_I13 n_I24 vss rppd w=1u l=48u b=0 m=1
XR98 n_I13 n_16 vss rppd w=1u l=48u b=0 m=1
XR99 n_I14 n_18 vss rppd w=1u l=48u b=0 m=1
XR100 n_I13 n_I24 vss rppd w=1u l=48u b=0 m=1
XR101 n_I13 n_16 vss rppd w=1u l=48u b=0 m=1
XR102 n_I14 n_18 vss rppd w=1u l=48u b=0 m=1
XR103 n_I13 n_16 vss rppd w=1u l=48u b=0 m=1
XR104 n_I14 n_I24 vss rppd w=1u l=48u b=0 m=1
XR105 n_I13 n_I24 vss rppd w=1u l=48u b=0 m=1
XR106 n_I13 n_16 vss rppd w=1u l=48u b=0 m=1
XR107 n_I13 n_I24 vss rppd w=1u l=48u b=0 m=1
XR108 n_I13 n_I24 vss rppd w=1u l=48u b=0 m=1
XR109 n_I13 n_16 vss rppd w=1u l=48u b=0 m=1
XR110 n_I13 n_I24 vss rppd w=1u l=48u b=0 m=1
XR111 n_I14 n_18 vss rppd w=1u l=48u b=0 m=1
XR112 n_I13 n_16 vss rppd w=1u l=48u b=0 m=1
XR113 n_I13 n_I24 vss rppd w=1u l=48u b=0 m=1
XR114 n_I13 n_I24 vss rppd w=1u l=48u b=0 m=1
XR115 n_I13 n_16 vss rppd w=1u l=48u b=0 m=1
XR116 n_I13 n_I24 vss rppd w=1u l=48u b=0 m=1
XR117 n_I13 n_I24 vss rppd w=1u l=48u b=0 m=1
XR118 n_I14 n_18 vss rppd w=1u l=48u b=0 m=1
XR119 n_I13 n_16 vss rppd w=1u l=48u b=0 m=1
XR120 n_I13 n_16 vss rppd w=1u l=48u b=0 m=1
XR121 n_I13 n_16 vss rppd w=1u l=48u b=0 m=1
XR122 n_I13 n_16 vss rppd w=1u l=48u b=0 m=1
XR123 n_I14 n_18 vss rppd w=1u l=48u b=0 m=1
XR124 n_I14 n_18 vss rppd w=1u l=48u b=0 m=1
XR125 n_I13 n_16 vss rppd w=1u l=48u b=0 m=1
XR126 n_I14 n_18 vss rppd w=1u l=48u b=0 m=1
XR127 n_I13 n_I24 vss rppd w=1u l=48u b=0 m=1
XR128 n_I14 n_18 vss rppd w=1u l=48u b=0 m=1
XR129 n_I14 n_18 vss rppd w=1u l=48u b=0 m=1
XR130 n_I14 n_18 vss rppd w=1u l=48u b=0 m=1
XR131 n_I14 n_18 vss rppd w=1u l=48u b=0 m=1
XR132 n_I14 n_18 vss rppd w=1u l=48u b=0 m=1
XR133 n_I14 n_18 vss rppd w=1u l=48u b=0 m=1
XR134 n_I14 n_18 vss rppd w=1u l=48u b=0 m=1
XR135 n_I13 n_I24 vss rppd w=1u l=48u b=0 m=1
XR136 n_I14 n_18 vss rppd w=1u l=48u b=0 m=1
XR137 n_I13 n_I24 vss rppd w=1u l=48u b=0 m=1
XR138 n_I13 n_I24 vss rppd w=1u l=48u b=0 m=1
XR139 n_I13 n_I24 vss rppd w=1u l=48u b=0 m=1
XR140 n_I13 n_I24 vss rppd w=1u l=48u b=0 m=1
XR141 n_I13 n_I24 vss rppd w=1u l=48u b=0 m=1
XR142 n_I13 n_I24 vss rppd w=1u l=48u b=0 m=1
XR143 n_I13 n_I24 vss rppd w=1u l=48u b=0 m=1
XR144 n_I14 n_I24 vss rppd w=1u l=48u b=0 m=1
XR145 n_I13 n_16 vss rppd w=1u l=48u b=0 m=1
XR146 n_I13 n_I24 vss rppd w=1u l=48u b=0 m=1
XR147 n_I13 n_16 vss rppd w=1u l=48u b=0 m=1
XR148 n_I14 n_18 vss rppd w=1u l=48u b=0 m=1
XR149 n_I13 n_16 vss rppd w=1u l=48u b=0 m=1
XR150 n_I13 n_16 vss rppd w=1u l=48u b=0 m=1
XR151 n_I13 n_16 vss rppd w=1u l=48u b=0 m=1
XR152 n_I13 n_16 vss rppd w=1u l=48u b=0 m=1
XR153 n_I13 n_16 vss rppd w=1u l=48u b=0 m=1
XR154 n_I14 n_I24 vss rppd w=1u l=48u b=0 m=1
XR155 n_I14 n_I24 vss rppd w=1u l=48u b=0 m=1
XR156 n_I13 n_I24 vss rppd w=1u l=48u b=0 m=1
XR157 n_I14 n_I24 vss rppd w=1u l=48u b=0 m=1
XR158 n_I14 n_I24 vss rppd w=1u l=48u b=0 m=1
XR159 n_I14 n_I24 vss rppd w=1u l=48u b=0 m=1
XR160 n_I40 pbias vss rppd w=1u l=50u b=0 m=1
XR161 n_I40 n_I34 vss rppd w=1u l=50u b=0 m=1
XR162 n_I40 n_I34 vss rppd w=1u l=50u b=0 m=1
XR163 n_I40 n_I34 vss rppd w=1u l=50u b=0 m=1
XR164 n_I40 n_I34 vss rppd w=1u l=50u b=0 m=1
XR165 n_I40 n_I34 vss rppd w=1u l=50u b=0 m=1
XR166 n_I41 n_I34 vss rppd w=1u l=50u b=0 m=1
XR167 n_I41 n_I34 vss rppd w=1u l=50u b=0 m=1
XR168 n_I41 n_I34 vss rppd w=1u l=50u b=0 m=1
XR169 n_I41 n_I34 vss rppd w=1u l=50u b=0 m=1
XR170 n_I40 pbias vss rppd w=1u l=50u b=0 m=1
XR171 n_I41 n_I34 vss rppd w=1u l=50u b=0 m=1
XR172 n_I41 n_I34 vss rppd w=1u l=50u b=0 m=1
XR173 n_I41 n_I34 vss rppd w=1u l=50u b=0 m=1
XR174 n_I41 n_I34 vss rppd w=1u l=50u b=0 m=1
XR175 n_I41 n_I35 vss rppd w=1u l=50u b=0 m=1
XR176 n_I41 n_I34 vss rppd w=1u l=50u b=0 m=1
XR177 n_I41 n_I35 vss rppd w=1u l=50u b=0 m=1
XR178 n_I40 pbias vss rppd w=1u l=50u b=0 m=1
XR179 n_I40 pbias vss rppd w=1u l=50u b=0 m=1
XR180 n_I40 pbias vss rppd w=1u l=50u b=0 m=1
XR181 n_I41 n_I34 vss rppd w=1u l=50u b=0 m=1
XR182 n_I41 n_I35 vss rppd w=1u l=50u b=0 m=1
XR183 n_I41 n_I35 vss rppd w=1u l=50u b=0 m=1
XR184 n_I41 n_I35 vss rppd w=1u l=50u b=0 m=1
XR185 n_I18 n_I37 vss rppd w=1u l=50u b=0 m=1
XR186 n_I18 n_I37 vss rppd w=1u l=50u b=0 m=1
XR187 n_I41 n_I34 vss rppd w=1u l=50u b=0 m=1
XR188 n_I41 n_I34 vss rppd w=1u l=50u b=0 m=1
XR189 n_I30 n_I35 vss rppd w=1u l=50u b=0 m=1
XR190 n_I30 n_I35 vss rppd w=1u l=50u b=0 m=1
XR191 n_I30 n_I35 vss rppd w=1u l=50u b=0 m=1
XR192 n_I30 n_I35 vss rppd w=1u l=50u b=0 m=1
XR193 n_I30 n_I35 vss rppd w=1u l=50u b=0 m=1
XR194 n_I40 n_I34 vss rppd w=1u l=50u b=0 m=1
XR195 n_I18 n_I37 vss rppd w=1u l=50u b=0 m=1
XR196 n_I18 n_I37 vss rppd w=1u l=50u b=0 m=1
XR197 n_I18 n_I37 vss rppd w=1u l=50u b=0 m=1
XR198 n_I18 n_I37 vss rppd w=1u l=50u b=0 m=1
XR199 n_I18 n_I37 vss rppd w=1u l=50u b=0 m=1
XR200 n_I18 n_I37 vss rppd w=1u l=50u b=0 m=1
XR201 n_I18 n_I37 vss rppd w=1u l=50u b=0 m=1
XR202 n_I18 n_I37 vss rppd w=1u l=50u b=0 m=1
XR203 n_I18 n_I37 vss rppd w=1u l=50u b=0 m=1
XR204 n_I18 n_I37 vss rppd w=1u l=50u b=0 m=1
XR205 n_I41 n_I35 vss rppd w=1u l=50u b=0 m=1
XR206 n_I30 n_I35 vss rppd w=1u l=50u b=0 m=1
XR207 n_I30 n_I35 vss rppd w=1u l=50u b=0 m=1
XR208 n_I30 n_I35 vss rppd w=1u l=50u b=0 m=1
XR209 n_I23 n_I38 vss rppd w=1u l=50u b=0 m=1
XR210 n_I23 n_I38 vss rppd w=1u l=50u b=0 m=1
XR211 n_I23 n_I38 vss rppd w=1u l=50u b=0 m=1
XR212 n_I23 n_I38 vss rppd w=1u l=50u b=0 m=1
XR213 n_I23 n_I38 vss rppd w=1u l=50u b=0 m=1
XR214 n_I23 n_I38 vss rppd w=1u l=50u b=0 m=1
XR215 n_I23 n_I38 vss rppd w=1u l=50u b=0 m=1
XR216 n_I23 n_I38 vss rppd w=1u l=50u b=0 m=1
XR217 n_I23 n_I38 vss rppd w=1u l=50u b=0 m=1
XR218 n_I23 n_I38 vss rppd w=1u l=50u b=0 m=1
XR219 n_I23 n_I38 vss rppd w=1u l=50u b=0 m=1
XR220 n_I40 pbias vss rppd w=1u l=50u b=0 m=1
XR221 n_I23 n_I38 vss rppd w=1u l=50u b=0 m=1
XR222 n_I18 n_I38 vss rppd w=1u l=50u b=0 m=1
XR223 n_I18 n_I38 vss rppd w=1u l=50u b=0 m=1
XR224 n_I18 n_I37 vss rppd w=1u l=50u b=0 m=1
XR225 n_I30 n_I35 vss rppd w=1u l=50u b=0 m=1
XR226 n_I30 n_I35 vss rppd w=1u l=50u b=0 m=1
XR227 n_I30 n_I35 vss rppd w=1u l=50u b=0 m=1
XR228 n_I41 n_I34 vss rppd w=1u l=50u b=0 m=1
XR229 n_I41 n_I35 vss rppd w=1u l=50u b=0 m=1
XR230 n_I41 n_I35 vss rppd w=1u l=50u b=0 m=1
XR231 n_I18 n_I37 vss rppd w=1u l=50u b=0 m=1
XR232 n_I18 n_I38 vss rppd w=1u l=50u b=0 m=1
XR233 n_I40 pbias vss rppd w=1u l=50u b=0 m=1
XR234 n_I40 pbias vss rppd w=1u l=50u b=0 m=1
XR235 n_I40 pbias vss rppd w=1u l=50u b=0 m=1
XR236 n_I40 pbias vss rppd w=1u l=50u b=0 m=1
XR237 n_I40 pbias vss rppd w=1u l=50u b=0 m=1
XR238 n_I18 n_I38 vss rppd w=1u l=50u b=0 m=1
XR239 n_I18 n_I38 vss rppd w=1u l=50u b=0 m=1
XR240 n_I18 n_I38 vss rppd w=1u l=50u b=0 m=1
XR241 n_I18 n_I38 vss rppd w=1u l=50u b=0 m=1
XR242 n_I18 n_I38 vss rppd w=1u l=50u b=0 m=1
XR243 n_I18 n_I38 vss rppd w=1u l=50u b=0 m=1
XR244 n_I18 n_I37 vss rppd w=1u l=50u b=0 m=1
XR245 n_I30 n_I35 vss rppd w=1u l=50u b=0 m=1
XR246 n_I18 n_I38 vss rppd w=1u l=50u b=0 m=1
XR247 n_I18 n_I38 vss rppd w=1u l=50u b=0 m=1
XR248 n_I30 n_I35 vss rppd w=1u l=50u b=0 m=1
XR249 n_I40 pbias vss rppd w=1u l=50u b=0 m=1
XR250 n_I40 pbias vss rppd w=1u l=50u b=0 m=1
XR251 n_I30 n_I35 vss rppd w=1u l=50u b=0 m=1
XR252 n_I41 n_I34 vss rppd w=1u l=50u b=0 m=1
XR253 n_I41 n_I35 vss rppd w=1u l=50u b=0 m=1
XR254 n_I18 n_I37 vss rppd w=1u l=50u b=0 m=1
XR255 n_I18 n_I37 vss rppd w=1u l=50u b=0 m=1
XR256 n_I18 n_I38 vss rppd w=1u l=50u b=0 m=1
XR257 n_I23 n_I38 vss rppd w=1u l=50u b=0 m=1
XR258 n_I18 n_I38 vss rppd w=1u l=50u b=0 m=1
XR259 n_I40 pbias vss rppd w=1u l=50u b=0 m=1
XR260 n_I30 n_I35 vss rppd w=1u l=50u b=0 m=1
XR261 n_I18 n_I38 vss rppd w=1u l=50u b=0 m=1
XR262 n_I18 n_I38 vss rppd w=1u l=50u b=0 m=1
XR263 n_I30 n_I35 vss rppd w=1u l=50u b=0 m=1
XR264 n_I18 n_I38 vss rppd w=1u l=50u b=0 m=1
XR265 n_I41 n_I35 vss rppd w=1u l=50u b=0 m=1
XR266 n_I18 n_I38 vss rppd w=1u l=50u b=0 m=1
XR267 n_I18 n_I38 vss rppd w=1u l=50u b=0 m=1
XR268 n_I18 n_I38 vss rppd w=1u l=50u b=0 m=1
XR269 n_I18 n_I38 vss rppd w=1u l=50u b=0 m=1
XR270 n_I18 n_I38 vss rppd w=1u l=50u b=0 m=1
XR271 n_I18 n_I38 vss rppd w=1u l=50u b=0 m=1
XR272 n_I18 n_I37 vss rppd w=1u l=50u b=0 m=1
XR273 n_I41 n_I34 vss rppd w=1u l=50u b=0 m=1
XR274 n_I18 n_I38 vss rppd w=1u l=50u b=0 m=1
XR275 n_I23 n_I38 vss rppd w=1u l=50u b=0 m=1
XR276 n_I23 n_I38 vss rppd w=1u l=50u b=0 m=1
XR277 n_I23 n_I38 vss rppd w=1u l=50u b=0 m=1
XR278 n_I30 n_I35 vss rppd w=1u l=50u b=0 m=1
XR279 n_I23 n_I38 vss rppd w=1u l=50u b=0 m=1
XR280 n_I23 n_I38 vss rppd w=1u l=50u b=0 m=1
XR281 n_I23 n_I38 vss rppd w=1u l=50u b=0 m=1
XR282 n_I30 n_I35 vss rppd w=1u l=50u b=0 m=1
XR283 n_I40 pbias vss rppd w=1u l=50u b=0 m=1
XR284 n_I23 n_I38 vss rppd w=1u l=50u b=0 m=1
XR285 n_I23 n_I38 vss rppd w=1u l=50u b=0 m=1
XR286 n_I23 n_I38 vss rppd w=1u l=50u b=0 m=1
XR287 n_I40 pbias vss rppd w=1u l=50u b=0 m=1
XR288 n_I40 pbias vss rppd w=1u l=50u b=0 m=1
XR289 n_I23 n_I38 vss rppd w=1u l=50u b=0 m=1
XR290 n_I40 pbias vss rppd w=1u l=50u b=0 m=1
XR291 n_I23 n_I38 vss rppd w=1u l=50u b=0 m=1
XR292 n_I41 n_I35 vss rppd w=1u l=50u b=0 m=1
XR293 n_I40 n_I34 vss rppd w=1u l=50u b=0 m=1
XR294 n_I30 n_I35 vss rppd w=1u l=50u b=0 m=1
XR295 n_I41 n_I34 vss rppd w=1u l=50u b=0 m=1
XR296 n_I41 n_I35 vss rppd w=1u l=50u b=0 m=1
XR297 n_I41 n_I34 vss rppd w=1u l=50u b=0 m=1
XR298 n_I40 n_I34 vss rppd w=1u l=50u b=0 m=1
XR299 n_I30 n_I37 vss rppd w=1u l=50u b=0 m=1
XR300 n_I18 n_I37 vss rppd w=1u l=50u b=0 m=1
XR301 n_I30 n_I37 vss rppd w=1u l=50u b=0 m=1
XR302 n_I40 n_I34 vss rppd w=1u l=50u b=0 m=1
XR303 n_I23 pcasc vss rppd w=1u l=50u b=0 m=1
XR304 n_I23 pcasc vss rppd w=1u l=50u b=0 m=1
XR305 n_I30 n_I37 vss rppd w=1u l=50u b=0 m=1
XR306 n_I23 pcasc vss rppd w=1u l=50u b=0 m=1
XR307 n_I23 pcasc vss rppd w=1u l=50u b=0 m=1
XR308 n_I23 pcasc vss rppd w=1u l=50u b=0 m=1
XR309 n_I30 n_I37 vss rppd w=1u l=50u b=0 m=1
XR310 n_I30 n_I35 vss rppd w=1u l=50u b=0 m=1
XR311 n_I41 n_I35 vss rppd w=1u l=50u b=0 m=1
XR312 n_I30 n_I35 vss rppd w=1u l=50u b=0 m=1
XR313 n_I41 n_I34 vss rppd w=1u l=50u b=0 m=1
XR314 n_I30 n_I35 vss rppd w=1u l=50u b=0 m=1
XR315 n_I41 n_I34 vss rppd w=1u l=50u b=0 m=1
XR316 n_I18 n_I37 vss rppd w=1u l=50u b=0 m=1
XR317 n_I41 n_I35 vss rppd w=1u l=50u b=0 m=1
XR318 n_I40 n_I34 vss rppd w=1u l=50u b=0 m=1
XR319 n_I40 n_I34 vss rppd w=1u l=50u b=0 m=1
XR320 n_I41 n_I35 vss rppd w=1u l=50u b=0 m=1
XR321 n_I40 n_I34 vss rppd w=1u l=50u b=0 m=1
XR322 n_I30 n_I35 vss rppd w=1u l=50u b=0 m=1
XR323 n_I40 n_I34 vss rppd w=1u l=50u b=0 m=1
XR324 n_I41 n_I35 vss rppd w=1u l=50u b=0 m=1
XR325 n_I40 n_I34 vss rppd w=1u l=50u b=0 m=1
XR326 n_I18 n_I37 vss rppd w=1u l=50u b=0 m=1
XR327 n_I18 n_I37 vss rppd w=1u l=50u b=0 m=1
XR328 n_I18 n_I37 vss rppd w=1u l=50u b=0 m=1
XR329 n_I41 n_I34 vss rppd w=1u l=50u b=0 m=1
XR330 n_I18 n_I37 vss rppd w=1u l=50u b=0 m=1
XR331 n_I41 n_I34 vss rppd w=1u l=50u b=0 m=1
XR332 n_I30 n_I35 vss rppd w=1u l=50u b=0 m=1
XR333 n_I41 n_I34 vss rppd w=1u l=50u b=0 m=1
XR334 n_I41 n_I34 vss rppd w=1u l=50u b=0 m=1
XR335 n_I23 pcasc vss rppd w=1u l=50u b=0 m=1
XR336 n_I40 pbias vss rppd w=1u l=50u b=0 m=1
XR337 n_I30 n_I37 vss rppd w=1u l=50u b=0 m=1
XR338 n_I23 pcasc vss rppd w=1u l=50u b=0 m=1
XR339 n_I40 n_I34 vss rppd w=1u l=50u b=0 m=1
XR340 n_I30 n_I37 vss rppd w=1u l=50u b=0 m=1
XR341 n_I23 pcasc vss rppd w=1u l=50u b=0 m=1
XR342 n_I30 n_I37 vss rppd w=1u l=50u b=0 m=1
XR343 n_I23 pcasc vss rppd w=1u l=50u b=0 m=1
XR344 n_I30 n_I37 vss rppd w=1u l=50u b=0 m=1
XR345 n_I23 pcasc vss rppd w=1u l=50u b=0 m=1
XR346 n_I41 n_I35 vss rppd w=1u l=50u b=0 m=1
XR347 n_I41 n_I35 vss rppd w=1u l=50u b=0 m=1
XR348 n_I41 n_I35 vss rppd w=1u l=50u b=0 m=1
XR349 n_I41 n_I35 vss rppd w=1u l=50u b=0 m=1
XR350 n_I41 n_I35 vss rppd w=1u l=50u b=0 m=1
XR351 n_I41 n_I35 vss rppd w=1u l=50u b=0 m=1
XR352 n_I23 pcasc vss rppd w=1u l=50u b=0 m=1
XR353 n_I23 pcasc vss rppd w=1u l=50u b=0 m=1
XR354 n_I41 n_I34 vss rppd w=1u l=50u b=0 m=1
XR355 n_I23 pcasc vss rppd w=1u l=50u b=0 m=1
XR356 n_I23 pcasc vss rppd w=1u l=50u b=0 m=1
XR357 n_I23 pcasc vss rppd w=1u l=50u b=0 m=1
XR358 n_I23 pcasc vss rppd w=1u l=50u b=0 m=1
XR359 n_I23 pcasc vss rppd w=1u l=50u b=0 m=1
XR360 n_I30 n_I37 vss rppd w=1u l=50u b=0 m=1
XR361 n_I41 n_I35 vss rppd w=1u l=50u b=0 m=1
XR362 n_I41 n_I35 vss rppd w=1u l=50u b=0 m=1
XR363 n_I23 pcasc vss rppd w=1u l=50u b=0 m=1
XR364 n_I40 n_I34 vss rppd w=1u l=50u b=0 m=1
XR365 n_I23 pcasc vss rppd w=1u l=50u b=0 m=1
XR366 n_I30 n_I37 vss rppd w=1u l=50u b=0 m=1
XR367 n_I40 n_I34 vss rppd w=1u l=50u b=0 m=1
XR368 n_I30 n_I37 vss rppd w=1u l=50u b=0 m=1
XR369 n_I30 n_I37 vss rppd w=1u l=50u b=0 m=1
XR370 n_I30 n_I37 vss rppd w=1u l=50u b=0 m=1
XR371 n_I40 n_I34 vss rppd w=1u l=50u b=0 m=1
XR372 n_I40 n_I34 vss rppd w=1u l=50u b=0 m=1
XR373 n_I23 pcasc vss rppd w=1u l=50u b=0 m=1
XR374 n_I23 pcasc vss rppd w=1u l=50u b=0 m=1
XR375 n_I40 pbias vss rppd w=1u l=50u b=0 m=1
XR376 n_I18 n_I38 vss rppd w=1u l=50u b=0 m=1
XR377 n_I40 pbias vss rppd w=1u l=50u b=0 m=1
XR378 n_I40 pbias vss rppd w=1u l=50u b=0 m=1
XR379 n_I40 pbias vss rppd w=1u l=50u b=0 m=1
XR380 n_I40 pbias vss rppd w=1u l=50u b=0 m=1
XR381 n_I30 n_I37 vss rppd w=1u l=50u b=0 m=1
XR382 n_I40 n_I34 vss rppd w=1u l=50u b=0 m=1
XR383 n_I40 n_I34 vss rppd w=1u l=50u b=0 m=1
XR384 n_I40 n_I34 vss rppd w=1u l=50u b=0 m=1
XR385 n_I40 n_I34 vss rppd w=1u l=50u b=0 m=1
XR386 n_I30 n_I37 vss rppd w=1u l=50u b=0 m=1
XR387 n_I30 n_I37 vss rppd w=1u l=50u b=0 m=1
XR388 n_I30 n_I37 vss rppd w=1u l=50u b=0 m=1
XR389 n_I40 n_I34 vss rppd w=1u l=50u b=0 m=1
XR390 n_I30 n_I37 vss rppd w=1u l=50u b=0 m=1
XR391 n_I30 n_I37 vss rppd w=1u l=50u b=0 m=1
XR392 n_I30 n_I37 vss rppd w=1u l=50u b=0 m=1
XR393 n_I30 n_I37 vss rppd w=1u l=50u b=0 m=1
XR394 n_I23 pcasc vss rppd w=1u l=50u b=0 m=1
XR395 n_I30 n_I37 vss rppd w=1u l=50u b=0 m=1
XR396 n_I30 n_I37 vss rppd w=1u l=50u b=0 m=1
XR397 n_I23 pcasc vss rppd w=1u l=50u b=0 m=1
XR398 n_I23 pcasc vss rppd w=1u l=50u b=0 m=1
XR399 n_I30 n_I37 vss rppd w=1u l=50u b=0 m=1
XM400 n_I11 r4 vdd vdd sg13_hv_pmos l=0.5u w=2u as=0.68p ad=0.68p ps=4.68u pd=4.68u rfmode=0
XM401 vbe r4 n_20 vss sg13_hv_nmos l=0.5u w=2u as=0.68p ad=0.68p ps=4.68u pd=4.68u rfmode=0
XM402 iptat pcasc n_I6 n_I6 sg13_hv_pmos l=4u w=10u as=3.4p ad=3.4p ps=20.68u pd=20.68u rfmode=0
XM403 n_I10 n_10 vdd vdd sg13_hv_pmos l=0.5u w=2u as=0.68p ad=0.68p ps=4.68u pd=4.68u rfmode=0
XM404 n_I7 pcasc n_I4 n_I4 sg13_hv_pmos l=4u w=10u as=3.4p ad=3.4p ps=20.68u pd=20.68u rfmode=0
XM405 n_I7 pcasc n_I4 n_I4 sg13_hv_pmos l=4u w=10u as=3.4p ad=3.4p ps=20.68u pd=20.68u rfmode=0
XM406 n_I7 pcasc n_I4 n_I4 sg13_hv_pmos l=4u w=10u as=3.4p ad=3.4p ps=20.68u pd=20.68u rfmode=0
XM407 n_I7 pcasc n_I4 n_I4 sg13_hv_pmos l=4u w=10u as=3.4p ad=3.4p ps=20.68u pd=20.68u rfmode=0
XM408 n_I7 pcasc n_I4 n_I4 sg13_hv_pmos l=4u w=10u as=3.4p ad=3.4p ps=20.68u pd=20.68u rfmode=0
XM409 n_I7 pcasc n_I4 n_I4 sg13_hv_pmos l=4u w=10u as=3.4p ad=3.4p ps=20.68u pd=20.68u rfmode=0
XM410 n_I7 pcasc n_I4 n_I4 sg13_hv_pmos l=4u w=10u as=3.4p ad=3.4p ps=20.68u pd=20.68u rfmode=0
XM411 n_I7 pcasc n_I4 n_I4 sg13_hv_pmos l=4u w=10u as=3.4p ad=3.4p ps=20.68u pd=20.68u rfmode=0
XM412 n_I7 pcasc n_I4 n_I4 sg13_hv_pmos l=4u w=10u as=3.4p ad=3.4p ps=20.68u pd=20.68u rfmode=0
XM413 n_I7 pcasc n_I4 n_I4 sg13_hv_pmos l=4u w=10u as=3.4p ad=3.4p ps=20.68u pd=20.68u rfmode=0
XM414 n_I7 pcasc n_I4 n_I4 sg13_hv_pmos l=4u w=10u as=3.4p ad=3.4p ps=20.68u pd=20.68u rfmode=0
XM415 n_I7 pcasc n_I4 n_I4 sg13_hv_pmos l=4u w=10u as=3.4p ad=3.4p ps=20.68u pd=20.68u rfmode=0
XM416 n_I7 pcasc n_I4 n_I4 sg13_hv_pmos l=4u w=10u as=3.4p ad=3.4p ps=20.68u pd=20.68u rfmode=0
XM417 n_I7 pcasc n_I4 n_I4 sg13_hv_pmos l=4u w=10u as=3.4p ad=3.4p ps=20.68u pd=20.68u rfmode=0
XM418 n_I7 pcasc n_I4 n_I4 sg13_hv_pmos l=4u w=10u as=3.4p ad=3.4p ps=20.68u pd=20.68u rfmode=0
XM419 n_I7 pcasc n_I4 n_I4 sg13_hv_pmos l=4u w=10u as=3.4p ad=3.4p ps=20.68u pd=20.68u rfmode=0
XM420 n_I7 pcasc n_I4 n_I4 sg13_hv_pmos l=4u w=10u as=3.4p ad=3.4p ps=20.68u pd=20.68u rfmode=0
XM421 n_I7 pcasc n_I4 n_I4 sg13_hv_pmos l=4u w=10u as=3.4p ad=3.4p ps=20.68u pd=20.68u rfmode=0
XM422 n_I7 pcasc n_I4 n_I4 sg13_hv_pmos l=4u w=10u as=3.4p ad=3.4p ps=20.68u pd=20.68u rfmode=0
XM423 n_I7 pcasc n_I4 n_I4 sg13_hv_pmos l=4u w=10u as=3.4p ad=3.4p ps=20.68u pd=20.68u rfmode=0
XM424 n_I7 pcasc n_I4 n_I4 sg13_hv_pmos l=4u w=10u as=3.4p ad=3.4p ps=20.68u pd=20.68u rfmode=0
XM425 n_I7 pcasc n_I4 n_I4 sg13_hv_pmos l=4u w=10u as=3.4p ad=3.4p ps=20.68u pd=20.68u rfmode=0
XM426 n_I7 pcasc n_I4 n_I4 sg13_hv_pmos l=4u w=10u as=3.4p ad=3.4p ps=20.68u pd=20.68u rfmode=0
XM427 n_I7 pcasc n_I4 n_I4 sg13_hv_pmos l=4u w=10u as=3.4p ad=3.4p ps=20.68u pd=20.68u rfmode=0
XM428 n_20 n_I11 vss vss sg13_hv_nmos l=0.6u w=1u as=0.34p ad=0.34p ps=2.68u pd=2.68u rfmode=0
XM429 vref pcasc n_I5 n_I5 sg13_hv_pmos l=4u w=10u as=3.4p ad=3.4p ps=20.68u pd=20.68u rfmode=0
XM430 vref pcasc n_I5 n_I5 sg13_hv_pmos l=4u w=10u as=3.4p ad=3.4p ps=20.68u pd=20.68u rfmode=0
XM431 vref pcasc n_I5 n_I5 sg13_hv_pmos l=4u w=10u as=3.4p ad=3.4p ps=20.68u pd=20.68u rfmode=0
XM432 vref pcasc n_I5 n_I5 sg13_hv_pmos l=4u w=10u as=3.4p ad=3.4p ps=20.68u pd=20.68u rfmode=0
XM433 pbias n_I10 vss vss sg13_hv_nmos l=4u w=1u as=0.34p ad=0.34p ps=2.68u pd=2.68u rfmode=0
XM434 n_I10 n_10 vss vss sg13_hv_nmos l=0.6u w=1u as=0.34p ad=0.34p ps=2.68u pd=2.68u rfmode=0
XM435 n_I11 r4 vss vss sg13_hv_nmos l=0.5u w=1u as=0.34p ad=0.34p ps=2.68u pd=2.68u rfmode=0
XM436 vbe n_16 n_I7 vss sg13_hv_nmos l=1u w=10u as=3.4p ad=3.4p ps=20.68u pd=20.68u rfmode=0
XM437 vbe n_16 n_I7 vss sg13_hv_nmos l=1u w=10u as=3.4p ad=3.4p ps=20.68u pd=20.68u rfmode=0
XM438 vbe n_16 n_I7 vss sg13_hv_nmos l=1u w=10u as=3.4p ad=3.4p ps=20.68u pd=20.68u rfmode=0
XM439 vbe n_16 n_I7 vss sg13_hv_nmos l=1u w=10u as=3.4p ad=3.4p ps=20.68u pd=20.68u rfmode=0
XM440 vbe n_16 n_I7 vss sg13_hv_nmos l=1u w=10u as=3.4p ad=3.4p ps=20.68u pd=20.68u rfmode=0
XM441 vbe n_16 n_I7 vss sg13_hv_nmos l=1u w=10u as=3.4p ad=3.4p ps=20.68u pd=20.68u rfmode=0
XM442 vbe n_16 n_I7 vss sg13_hv_nmos l=1u w=10u as=3.4p ad=3.4p ps=20.68u pd=20.68u rfmode=0
XM443 vbe n_16 n_I7 vss sg13_hv_nmos l=1u w=10u as=3.4p ad=3.4p ps=20.68u pd=20.68u rfmode=0
XM444 vbe n_16 n_I7 vss sg13_hv_nmos l=1u w=10u as=3.4p ad=3.4p ps=20.68u pd=20.68u rfmode=0
XM445 vbe n_16 n_I7 vss sg13_hv_nmos l=1u w=10u as=3.4p ad=3.4p ps=20.68u pd=20.68u rfmode=0
XM446 vbe n_16 n_I7 vss sg13_hv_nmos l=1u w=10u as=3.4p ad=3.4p ps=20.68u pd=20.68u rfmode=0
XM447 vbe n_16 n_I7 vss sg13_hv_nmos l=1u w=10u as=3.4p ad=3.4p ps=20.68u pd=20.68u rfmode=0
XM448 vbe n_16 n_I7 vss sg13_hv_nmos l=1u w=10u as=3.4p ad=3.4p ps=20.68u pd=20.68u rfmode=0
XM449 vbe n_16 n_I7 vss sg13_hv_nmos l=1u w=10u as=3.4p ad=3.4p ps=20.68u pd=20.68u rfmode=0
XM450 vbe n_16 n_I7 vss sg13_hv_nmos l=1u w=10u as=3.4p ad=3.4p ps=20.68u pd=20.68u rfmode=0
XM451 vbe n_16 n_I7 vss sg13_hv_nmos l=1u w=10u as=3.4p ad=3.4p ps=20.68u pd=20.68u rfmode=0
XM452 vbe n_16 n_I7 vss sg13_hv_nmos l=1u w=10u as=3.4p ad=3.4p ps=20.68u pd=20.68u rfmode=0
XM453 vbe n_16 n_I7 vss sg13_hv_nmos l=1u w=10u as=3.4p ad=3.4p ps=20.68u pd=20.68u rfmode=0
XM454 vbe n_16 n_I7 vss sg13_hv_nmos l=1u w=10u as=3.4p ad=3.4p ps=20.68u pd=20.68u rfmode=0
XM455 vbe n_16 n_I7 vss sg13_hv_nmos l=1u w=10u as=3.4p ad=3.4p ps=20.68u pd=20.68u rfmode=0
XM456 vbe n_16 n_I7 vss sg13_hv_nmos l=1u w=10u as=3.4p ad=3.4p ps=20.68u pd=20.68u rfmode=0
XM457 vbe n_16 n_I7 vss sg13_hv_nmos l=1u w=10u as=3.4p ad=3.4p ps=20.68u pd=20.68u rfmode=0
XM458 vbe n_16 n_I7 vss sg13_hv_nmos l=1u w=10u as=3.4p ad=3.4p ps=20.68u pd=20.68u rfmode=0
XM459 vbe n_16 n_I7 vss sg13_hv_nmos l=1u w=10u as=3.4p ad=3.4p ps=20.68u pd=20.68u rfmode=0
XM460 n_I5 gate_probe vdd vdd sg13_hv_pmos l=4u w=5u as=1.7p ad=1.7p ps=10.68u pd=10.68u rfmode=0
XM461 n_I5 gate_probe vdd vdd sg13_hv_pmos l=4u w=5u as=1.7p ad=1.7p ps=10.68u pd=10.68u rfmode=0
XM462 n_I5 gate_probe vdd vdd sg13_hv_pmos l=4u w=5u as=1.7p ad=1.7p ps=10.68u pd=10.68u rfmode=0
XM463 n_I5 gate_probe vdd vdd sg13_hv_pmos l=4u w=5u as=1.7p ad=1.7p ps=10.68u pd=10.68u rfmode=0
XM464 n_I5 gate_probe vdd vdd sg13_hv_pmos l=4u w=5u as=1.7p ad=1.7p ps=10.68u pd=10.68u rfmode=0
XM465 n_I5 gate_probe vdd vdd sg13_hv_pmos l=4u w=5u as=1.7p ad=1.7p ps=10.68u pd=10.68u rfmode=0
XM466 n_I5 gate_probe vdd vdd sg13_hv_pmos l=4u w=5u as=1.7p ad=1.7p ps=10.68u pd=10.68u rfmode=0
XM467 n_I5 gate_probe vdd vdd sg13_hv_pmos l=4u w=5u as=1.7p ad=1.7p ps=10.68u pd=10.68u rfmode=0
XM468 n_I6 gate_probe vdd vdd sg13_hv_pmos l=4u w=5u as=1.7p ad=1.7p ps=10.68u pd=10.68u rfmode=0
XM469 n_I6 gate_probe vdd vdd sg13_hv_pmos l=4u w=5u as=1.7p ad=1.7p ps=10.68u pd=10.68u rfmode=0
XM470 n_10 gate_probe vdd vdd sg13_hv_pmos l=4u w=5u as=1.7p ad=1.7p ps=10.68u pd=10.68u rfmode=0
XM471 n_10 gate_probe vdd vdd sg13_hv_pmos l=4u w=5u as=1.7p ad=1.7p ps=10.68u pd=10.68u rfmode=0
XM472 n_I7 n_16 vbe vss sg13_hv_nmos l=1u w=10u as=3.4p ad=3.4p ps=20.68u pd=20.68u rfmode=0
XM473 n_I7 n_16 vbe vss sg13_hv_nmos l=1u w=10u as=3.4p ad=3.4p ps=20.68u pd=20.68u rfmode=0
XM474 n_I7 n_16 vbe vss sg13_hv_nmos l=1u w=10u as=3.4p ad=3.4p ps=20.68u pd=20.68u rfmode=0
XM475 n_I7 n_16 vbe vss sg13_hv_nmos l=1u w=10u as=3.4p ad=3.4p ps=20.68u pd=20.68u rfmode=0
XM476 n_I7 n_16 vbe vss sg13_hv_nmos l=1u w=10u as=3.4p ad=3.4p ps=20.68u pd=20.68u rfmode=0
XM477 n_I7 n_16 vbe vss sg13_hv_nmos l=1u w=10u as=3.4p ad=3.4p ps=20.68u pd=20.68u rfmode=0
XM478 n_I7 n_16 vbe vss sg13_hv_nmos l=1u w=10u as=3.4p ad=3.4p ps=20.68u pd=20.68u rfmode=0
XM479 n_I7 n_16 vbe vss sg13_hv_nmos l=1u w=10u as=3.4p ad=3.4p ps=20.68u pd=20.68u rfmode=0
XM480 n_I7 n_16 vbe vss sg13_hv_nmos l=1u w=10u as=3.4p ad=3.4p ps=20.68u pd=20.68u rfmode=0
XM481 n_I7 n_16 vbe vss sg13_hv_nmos l=1u w=10u as=3.4p ad=3.4p ps=20.68u pd=20.68u rfmode=0
XM482 n_I7 n_16 vbe vss sg13_hv_nmos l=1u w=10u as=3.4p ad=3.4p ps=20.68u pd=20.68u rfmode=0
XM483 n_I7 n_16 vbe vss sg13_hv_nmos l=1u w=10u as=3.4p ad=3.4p ps=20.68u pd=20.68u rfmode=0
XM484 n_I7 n_16 vbe vss sg13_hv_nmos l=1u w=10u as=3.4p ad=3.4p ps=20.68u pd=20.68u rfmode=0
XM485 n_I7 n_16 vbe vss sg13_hv_nmos l=1u w=10u as=3.4p ad=3.4p ps=20.68u pd=20.68u rfmode=0
XM486 n_I7 n_16 vbe vss sg13_hv_nmos l=1u w=10u as=3.4p ad=3.4p ps=20.68u pd=20.68u rfmode=0
XM487 n_I7 n_16 vbe vss sg13_hv_nmos l=1u w=10u as=3.4p ad=3.4p ps=20.68u pd=20.68u rfmode=0
XM488 n_I7 n_16 vbe vss sg13_hv_nmos l=1u w=10u as=3.4p ad=3.4p ps=20.68u pd=20.68u rfmode=0
XM489 n_I7 n_16 vbe vss sg13_hv_nmos l=1u w=10u as=3.4p ad=3.4p ps=20.68u pd=20.68u rfmode=0
XM490 n_I7 n_16 vbe vss sg13_hv_nmos l=1u w=10u as=3.4p ad=3.4p ps=20.68u pd=20.68u rfmode=0
XM491 n_I7 n_16 vbe vss sg13_hv_nmos l=1u w=10u as=3.4p ad=3.4p ps=20.68u pd=20.68u rfmode=0
XM492 n_I7 n_16 vbe vss sg13_hv_nmos l=1u w=10u as=3.4p ad=3.4p ps=20.68u pd=20.68u rfmode=0
XM493 n_I7 n_16 vbe vss sg13_hv_nmos l=1u w=10u as=3.4p ad=3.4p ps=20.68u pd=20.68u rfmode=0
XM494 n_I7 n_16 vbe vss sg13_hv_nmos l=1u w=10u as=3.4p ad=3.4p ps=20.68u pd=20.68u rfmode=0
XM495 n_I7 n_16 vbe vss sg13_hv_nmos l=1u w=10u as=3.4p ad=3.4p ps=20.68u pd=20.68u rfmode=0
XM496 pcasc n_16 n_21 vss sg13_hv_nmos l=1u w=10u as=3.4p ad=3.4p ps=20.68u pd=20.68u rfmode=0
XM497 pcasc n_16 n_21 vss sg13_hv_nmos l=1u w=10u as=3.4p ad=3.4p ps=20.68u pd=20.68u rfmode=0
XM498 pcasc n_16 n_21 vss sg13_hv_nmos l=1u w=10u as=3.4p ad=3.4p ps=20.68u pd=20.68u rfmode=0
XM499 pcasc n_16 n_21 vss sg13_hv_nmos l=1u w=10u as=3.4p ad=3.4p ps=20.68u pd=20.68u rfmode=0
XM500 pcasc n_16 n_21 vss sg13_hv_nmos l=1u w=10u as=3.4p ad=3.4p ps=20.68u pd=20.68u rfmode=0
XM501 pcasc n_16 n_21 vss sg13_hv_nmos l=1u w=10u as=3.4p ad=3.4p ps=20.68u pd=20.68u rfmode=0
XM502 pcasc n_16 n_21 vss sg13_hv_nmos l=1u w=10u as=3.4p ad=3.4p ps=20.68u pd=20.68u rfmode=0
XM503 pcasc n_16 n_21 vss sg13_hv_nmos l=1u w=10u as=3.4p ad=3.4p ps=20.68u pd=20.68u rfmode=0
XM504 pcasc n_16 n_21 vss sg13_hv_nmos l=1u w=10u as=3.4p ad=3.4p ps=20.68u pd=20.68u rfmode=0
XM505 pcasc n_16 n_21 vss sg13_hv_nmos l=1u w=10u as=3.4p ad=3.4p ps=20.68u pd=20.68u rfmode=0
XM506 pcasc n_16 n_21 vss sg13_hv_nmos l=1u w=10u as=3.4p ad=3.4p ps=20.68u pd=20.68u rfmode=0
XM507 pcasc n_16 n_21 vss sg13_hv_nmos l=1u w=10u as=3.4p ad=3.4p ps=20.68u pd=20.68u rfmode=0
XM508 pcasc n_16 n_21 vss sg13_hv_nmos l=1u w=10u as=3.4p ad=3.4p ps=20.68u pd=20.68u rfmode=0
XM509 pcasc n_16 n_21 vss sg13_hv_nmos l=1u w=10u as=3.4p ad=3.4p ps=20.68u pd=20.68u rfmode=0
XM510 pcasc n_16 n_21 vss sg13_hv_nmos l=1u w=10u as=3.4p ad=3.4p ps=20.68u pd=20.68u rfmode=0
XM511 pcasc n_16 n_21 vss sg13_hv_nmos l=1u w=10u as=3.4p ad=3.4p ps=20.68u pd=20.68u rfmode=0
XM512 pcasc n_16 n_21 vss sg13_hv_nmos l=1u w=10u as=3.4p ad=3.4p ps=20.68u pd=20.68u rfmode=0
XM513 pcasc n_16 n_21 vss sg13_hv_nmos l=1u w=10u as=3.4p ad=3.4p ps=20.68u pd=20.68u rfmode=0
XM514 pcasc n_16 n_21 vss sg13_hv_nmos l=1u w=10u as=3.4p ad=3.4p ps=20.68u pd=20.68u rfmode=0
XM515 pcasc n_16 n_21 vss sg13_hv_nmos l=1u w=10u as=3.4p ad=3.4p ps=20.68u pd=20.68u rfmode=0
XM516 pcasc n_16 n_21 vss sg13_hv_nmos l=1u w=10u as=3.4p ad=3.4p ps=20.68u pd=20.68u rfmode=0
XM517 pcasc n_16 n_21 vss sg13_hv_nmos l=1u w=10u as=3.4p ad=3.4p ps=20.68u pd=20.68u rfmode=0
XM518 pcasc n_16 n_21 vss sg13_hv_nmos l=1u w=10u as=3.4p ad=3.4p ps=20.68u pd=20.68u rfmode=0
XM519 pcasc n_16 n_21 vss sg13_hv_nmos l=1u w=10u as=3.4p ad=3.4p ps=20.68u pd=20.68u rfmode=0
XM520 n_16 pcasc n_I8 n_I8 sg13_hv_pmos l=4u w=10u as=3.4p ad=3.4p ps=20.68u pd=20.68u rfmode=0
XM521 n_16 pcasc n_I8 n_I8 sg13_hv_pmos l=4u w=10u as=3.4p ad=3.4p ps=20.68u pd=20.68u rfmode=0
XM522 n_16 pcasc n_I8 n_I8 sg13_hv_pmos l=4u w=10u as=3.4p ad=3.4p ps=20.68u pd=20.68u rfmode=0
XM523 n_16 pcasc n_I8 n_I8 sg13_hv_pmos l=4u w=10u as=3.4p ad=3.4p ps=20.68u pd=20.68u rfmode=0
XM524 n_16 pcasc n_I8 n_I8 sg13_hv_pmos l=4u w=10u as=3.4p ad=3.4p ps=20.68u pd=20.68u rfmode=0
XM525 n_16 pcasc n_I8 n_I8 sg13_hv_pmos l=4u w=10u as=3.4p ad=3.4p ps=20.68u pd=20.68u rfmode=0
XM526 n_16 pcasc n_I8 n_I8 sg13_hv_pmos l=4u w=10u as=3.4p ad=3.4p ps=20.68u pd=20.68u rfmode=0
XM527 n_16 pcasc n_I8 n_I8 sg13_hv_pmos l=4u w=10u as=3.4p ad=3.4p ps=20.68u pd=20.68u rfmode=0
XM528 n_16 pcasc n_I8 n_I8 sg13_hv_pmos l=4u w=10u as=3.4p ad=3.4p ps=20.68u pd=20.68u rfmode=0
XM529 n_16 pcasc n_I8 n_I8 sg13_hv_pmos l=4u w=10u as=3.4p ad=3.4p ps=20.68u pd=20.68u rfmode=0
XM530 n_16 pcasc n_I8 n_I8 sg13_hv_pmos l=4u w=10u as=3.4p ad=3.4p ps=20.68u pd=20.68u rfmode=0
XM531 n_16 pcasc n_I8 n_I8 sg13_hv_pmos l=4u w=10u as=3.4p ad=3.4p ps=20.68u pd=20.68u rfmode=0
XM532 n_16 pcasc n_I8 n_I8 sg13_hv_pmos l=4u w=10u as=3.4p ad=3.4p ps=20.68u pd=20.68u rfmode=0
XM533 n_16 pcasc n_I8 n_I8 sg13_hv_pmos l=4u w=10u as=3.4p ad=3.4p ps=20.68u pd=20.68u rfmode=0
XM534 n_16 pcasc n_I8 n_I8 sg13_hv_pmos l=4u w=10u as=3.4p ad=3.4p ps=20.68u pd=20.68u rfmode=0
XM535 n_16 pcasc n_I8 n_I8 sg13_hv_pmos l=4u w=10u as=3.4p ad=3.4p ps=20.68u pd=20.68u rfmode=0
XM536 n_16 pcasc n_I8 n_I8 sg13_hv_pmos l=4u w=10u as=3.4p ad=3.4p ps=20.68u pd=20.68u rfmode=0
XM537 n_16 pcasc n_I8 n_I8 sg13_hv_pmos l=4u w=10u as=3.4p ad=3.4p ps=20.68u pd=20.68u rfmode=0
XM538 n_16 pcasc n_I8 n_I8 sg13_hv_pmos l=4u w=10u as=3.4p ad=3.4p ps=20.68u pd=20.68u rfmode=0
XM539 n_16 pcasc n_I8 n_I8 sg13_hv_pmos l=4u w=10u as=3.4p ad=3.4p ps=20.68u pd=20.68u rfmode=0
XM540 n_16 pcasc n_I8 n_I8 sg13_hv_pmos l=4u w=10u as=3.4p ad=3.4p ps=20.68u pd=20.68u rfmode=0
XM541 n_16 pcasc n_I8 n_I8 sg13_hv_pmos l=4u w=10u as=3.4p ad=3.4p ps=20.68u pd=20.68u rfmode=0
XM542 n_16 pcasc n_I8 n_I8 sg13_hv_pmos l=4u w=10u as=3.4p ad=3.4p ps=20.68u pd=20.68u rfmode=0
XM543 n_16 pcasc n_I8 n_I8 sg13_hv_pmos l=4u w=10u as=3.4p ad=3.4p ps=20.68u pd=20.68u rfmode=0
XM544 pbias pcasc n_I9 n_I9 sg13_hv_pmos l=4u w=10u as=3.4p ad=3.4p ps=20.68u pd=20.68u rfmode=0
XM545 pbias pcasc n_I9 n_I9 sg13_hv_pmos l=4u w=10u as=3.4p ad=3.4p ps=20.68u pd=20.68u rfmode=0
XM546 pbias pcasc n_I9 n_I9 sg13_hv_pmos l=4u w=10u as=3.4p ad=3.4p ps=20.68u pd=20.68u rfmode=0
XM547 pbias pcasc n_I9 n_I9 sg13_hv_pmos l=4u w=10u as=3.4p ad=3.4p ps=20.68u pd=20.68u rfmode=0
XM548 pbias pcasc n_I9 n_I9 sg13_hv_pmos l=4u w=10u as=3.4p ad=3.4p ps=20.68u pd=20.68u rfmode=0
XM549 pbias pcasc n_I9 n_I9 sg13_hv_pmos l=4u w=10u as=3.4p ad=3.4p ps=20.68u pd=20.68u rfmode=0
XM550 pbias pcasc n_I9 n_I9 sg13_hv_pmos l=4u w=10u as=3.4p ad=3.4p ps=20.68u pd=20.68u rfmode=0
XM551 pbias pcasc n_I9 n_I9 sg13_hv_pmos l=4u w=10u as=3.4p ad=3.4p ps=20.68u pd=20.68u rfmode=0
XM552 pbias pcasc n_I9 n_I9 sg13_hv_pmos l=4u w=10u as=3.4p ad=3.4p ps=20.68u pd=20.68u rfmode=0
XM553 pbias pcasc n_I9 n_I9 sg13_hv_pmos l=4u w=10u as=3.4p ad=3.4p ps=20.68u pd=20.68u rfmode=0
XM554 pbias pcasc n_I9 n_I9 sg13_hv_pmos l=4u w=10u as=3.4p ad=3.4p ps=20.68u pd=20.68u rfmode=0
XM555 pbias pcasc n_I9 n_I9 sg13_hv_pmos l=4u w=10u as=3.4p ad=3.4p ps=20.68u pd=20.68u rfmode=0
XM556 pbias pcasc n_I9 n_I9 sg13_hv_pmos l=4u w=10u as=3.4p ad=3.4p ps=20.68u pd=20.68u rfmode=0
XM557 pbias pcasc n_I9 n_I9 sg13_hv_pmos l=4u w=10u as=3.4p ad=3.4p ps=20.68u pd=20.68u rfmode=0
XM558 pbias pcasc n_I9 n_I9 sg13_hv_pmos l=4u w=10u as=3.4p ad=3.4p ps=20.68u pd=20.68u rfmode=0
XM559 pbias pcasc n_I9 n_I9 sg13_hv_pmos l=4u w=10u as=3.4p ad=3.4p ps=20.68u pd=20.68u rfmode=0
XM560 pbias pcasc n_I9 n_I9 sg13_hv_pmos l=4u w=10u as=3.4p ad=3.4p ps=20.68u pd=20.68u rfmode=0
XM561 pbias pcasc n_I9 n_I9 sg13_hv_pmos l=4u w=10u as=3.4p ad=3.4p ps=20.68u pd=20.68u rfmode=0
XM562 pbias pcasc n_I9 n_I9 sg13_hv_pmos l=4u w=10u as=3.4p ad=3.4p ps=20.68u pd=20.68u rfmode=0
XM563 pbias pcasc n_I9 n_I9 sg13_hv_pmos l=4u w=10u as=3.4p ad=3.4p ps=20.68u pd=20.68u rfmode=0
XM564 pbias pcasc n_I9 n_I9 sg13_hv_pmos l=4u w=10u as=3.4p ad=3.4p ps=20.68u pd=20.68u rfmode=0
XM565 pbias pcasc n_I9 n_I9 sg13_hv_pmos l=4u w=10u as=3.4p ad=3.4p ps=20.68u pd=20.68u rfmode=0
XM566 pbias pcasc n_I9 n_I9 sg13_hv_pmos l=4u w=10u as=3.4p ad=3.4p ps=20.68u pd=20.68u rfmode=0
XM567 pbias pcasc n_I9 n_I9 sg13_hv_pmos l=4u w=10u as=3.4p ad=3.4p ps=20.68u pd=20.68u rfmode=0
XM568 n_I4 gate_probe vdd vdd sg13_hv_pmos l=4u w=5u as=1.7p ad=1.7p ps=10.68u pd=10.68u rfmode=0
XM569 n_I4 gate_probe vdd vdd sg13_hv_pmos l=4u w=5u as=1.7p ad=1.7p ps=10.68u pd=10.68u rfmode=0
XM570 n_I4 gate_probe vdd vdd sg13_hv_pmos l=4u w=5u as=1.7p ad=1.7p ps=10.68u pd=10.68u rfmode=0
XM571 n_I4 gate_probe vdd vdd sg13_hv_pmos l=4u w=5u as=1.7p ad=1.7p ps=10.68u pd=10.68u rfmode=0
XM572 n_I4 gate_probe vdd vdd sg13_hv_pmos l=4u w=5u as=1.7p ad=1.7p ps=10.68u pd=10.68u rfmode=0
XM573 n_I4 gate_probe vdd vdd sg13_hv_pmos l=4u w=5u as=1.7p ad=1.7p ps=10.68u pd=10.68u rfmode=0
XM574 n_I4 gate_probe vdd vdd sg13_hv_pmos l=4u w=5u as=1.7p ad=1.7p ps=10.68u pd=10.68u rfmode=0
XM575 n_I4 gate_probe vdd vdd sg13_hv_pmos l=4u w=5u as=1.7p ad=1.7p ps=10.68u pd=10.68u rfmode=0
XM576 n_I4 gate_probe vdd vdd sg13_hv_pmos l=4u w=5u as=1.7p ad=1.7p ps=10.68u pd=10.68u rfmode=0
XM577 n_I4 gate_probe vdd vdd sg13_hv_pmos l=4u w=5u as=1.7p ad=1.7p ps=10.68u pd=10.68u rfmode=0
XM578 n_I4 gate_probe vdd vdd sg13_hv_pmos l=4u w=5u as=1.7p ad=1.7p ps=10.68u pd=10.68u rfmode=0
XM579 n_I4 gate_probe vdd vdd sg13_hv_pmos l=4u w=5u as=1.7p ad=1.7p ps=10.68u pd=10.68u rfmode=0
XM580 n_I4 gate_probe vdd vdd sg13_hv_pmos l=4u w=5u as=1.7p ad=1.7p ps=10.68u pd=10.68u rfmode=0
XM581 n_I4 gate_probe vdd vdd sg13_hv_pmos l=4u w=5u as=1.7p ad=1.7p ps=10.68u pd=10.68u rfmode=0
XM582 n_I4 gate_probe vdd vdd sg13_hv_pmos l=4u w=5u as=1.7p ad=1.7p ps=10.68u pd=10.68u rfmode=0
XM583 n_I4 gate_probe vdd vdd sg13_hv_pmos l=4u w=5u as=1.7p ad=1.7p ps=10.68u pd=10.68u rfmode=0
XM584 n_I4 gate_probe vdd vdd sg13_hv_pmos l=4u w=5u as=1.7p ad=1.7p ps=10.68u pd=10.68u rfmode=0
XM585 n_I4 gate_probe vdd vdd sg13_hv_pmos l=4u w=5u as=1.7p ad=1.7p ps=10.68u pd=10.68u rfmode=0
XM586 n_I4 gate_probe vdd vdd sg13_hv_pmos l=4u w=5u as=1.7p ad=1.7p ps=10.68u pd=10.68u rfmode=0
XM587 n_I4 gate_probe vdd vdd sg13_hv_pmos l=4u w=5u as=1.7p ad=1.7p ps=10.68u pd=10.68u rfmode=0
XM588 n_I4 gate_probe vdd vdd sg13_hv_pmos l=4u w=5u as=1.7p ad=1.7p ps=10.68u pd=10.68u rfmode=0
XM589 n_I4 gate_probe vdd vdd sg13_hv_pmos l=4u w=5u as=1.7p ad=1.7p ps=10.68u pd=10.68u rfmode=0
XM590 n_I4 gate_probe vdd vdd sg13_hv_pmos l=4u w=5u as=1.7p ad=1.7p ps=10.68u pd=10.68u rfmode=0
XM591 n_I4 gate_probe vdd vdd sg13_hv_pmos l=4u w=5u as=1.7p ad=1.7p ps=10.68u pd=10.68u rfmode=0
XM592 n_I4 gate_probe vdd vdd sg13_hv_pmos l=4u w=5u as=1.7p ad=1.7p ps=10.68u pd=10.68u rfmode=0
XM593 n_I4 gate_probe vdd vdd sg13_hv_pmos l=4u w=5u as=1.7p ad=1.7p ps=10.68u pd=10.68u rfmode=0
XM594 n_I4 gate_probe vdd vdd sg13_hv_pmos l=4u w=5u as=1.7p ad=1.7p ps=10.68u pd=10.68u rfmode=0
XM595 n_I4 gate_probe vdd vdd sg13_hv_pmos l=4u w=5u as=1.7p ad=1.7p ps=10.68u pd=10.68u rfmode=0
XM596 n_I4 gate_probe vdd vdd sg13_hv_pmos l=4u w=5u as=1.7p ad=1.7p ps=10.68u pd=10.68u rfmode=0
XM597 n_I4 gate_probe vdd vdd sg13_hv_pmos l=4u w=5u as=1.7p ad=1.7p ps=10.68u pd=10.68u rfmode=0
XM598 n_I4 gate_probe vdd vdd sg13_hv_pmos l=4u w=5u as=1.7p ad=1.7p ps=10.68u pd=10.68u rfmode=0
XM599 n_I4 gate_probe vdd vdd sg13_hv_pmos l=4u w=5u as=1.7p ad=1.7p ps=10.68u pd=10.68u rfmode=0
XM600 n_I4 gate_probe vdd vdd sg13_hv_pmos l=4u w=5u as=1.7p ad=1.7p ps=10.68u pd=10.68u rfmode=0
XM601 n_I4 gate_probe vdd vdd sg13_hv_pmos l=4u w=5u as=1.7p ad=1.7p ps=10.68u pd=10.68u rfmode=0
XM602 n_I4 gate_probe vdd vdd sg13_hv_pmos l=4u w=5u as=1.7p ad=1.7p ps=10.68u pd=10.68u rfmode=0
XM603 n_I4 gate_probe vdd vdd sg13_hv_pmos l=4u w=5u as=1.7p ad=1.7p ps=10.68u pd=10.68u rfmode=0
XM604 n_I4 gate_probe vdd vdd sg13_hv_pmos l=4u w=5u as=1.7p ad=1.7p ps=10.68u pd=10.68u rfmode=0
XM605 n_I4 gate_probe vdd vdd sg13_hv_pmos l=4u w=5u as=1.7p ad=1.7p ps=10.68u pd=10.68u rfmode=0
XM606 n_I4 gate_probe vdd vdd sg13_hv_pmos l=4u w=5u as=1.7p ad=1.7p ps=10.68u pd=10.68u rfmode=0
XM607 n_I4 gate_probe vdd vdd sg13_hv_pmos l=4u w=5u as=1.7p ad=1.7p ps=10.68u pd=10.68u rfmode=0
XM608 n_I4 gate_probe vdd vdd sg13_hv_pmos l=4u w=5u as=1.7p ad=1.7p ps=10.68u pd=10.68u rfmode=0
XM609 n_I4 gate_probe vdd vdd sg13_hv_pmos l=4u w=5u as=1.7p ad=1.7p ps=10.68u pd=10.68u rfmode=0
XM610 n_I4 gate_probe vdd vdd sg13_hv_pmos l=4u w=5u as=1.7p ad=1.7p ps=10.68u pd=10.68u rfmode=0
XM611 n_I4 gate_probe vdd vdd sg13_hv_pmos l=4u w=5u as=1.7p ad=1.7p ps=10.68u pd=10.68u rfmode=0
XM612 n_I4 gate_probe vdd vdd sg13_hv_pmos l=4u w=5u as=1.7p ad=1.7p ps=10.68u pd=10.68u rfmode=0
XM613 n_I4 gate_probe vdd vdd sg13_hv_pmos l=4u w=5u as=1.7p ad=1.7p ps=10.68u pd=10.68u rfmode=0
XM614 n_I4 gate_probe vdd vdd sg13_hv_pmos l=4u w=5u as=1.7p ad=1.7p ps=10.68u pd=10.68u rfmode=0
XM615 n_I4 gate_probe vdd vdd sg13_hv_pmos l=4u w=5u as=1.7p ad=1.7p ps=10.68u pd=10.68u rfmode=0
XM616 n_I9 gate_probe vdd vdd sg13_hv_pmos l=4u w=5u as=1.7p ad=1.7p ps=10.68u pd=10.68u rfmode=0
XM617 n_I9 gate_probe vdd vdd sg13_hv_pmos l=4u w=5u as=1.7p ad=1.7p ps=10.68u pd=10.68u rfmode=0
XM618 n_I9 gate_probe vdd vdd sg13_hv_pmos l=4u w=5u as=1.7p ad=1.7p ps=10.68u pd=10.68u rfmode=0
XM619 n_I9 gate_probe vdd vdd sg13_hv_pmos l=4u w=5u as=1.7p ad=1.7p ps=10.68u pd=10.68u rfmode=0
XM620 n_I9 gate_probe vdd vdd sg13_hv_pmos l=4u w=5u as=1.7p ad=1.7p ps=10.68u pd=10.68u rfmode=0
XM621 n_I9 gate_probe vdd vdd sg13_hv_pmos l=4u w=5u as=1.7p ad=1.7p ps=10.68u pd=10.68u rfmode=0
XM622 n_I9 gate_probe vdd vdd sg13_hv_pmos l=4u w=5u as=1.7p ad=1.7p ps=10.68u pd=10.68u rfmode=0
XM623 n_I9 gate_probe vdd vdd sg13_hv_pmos l=4u w=5u as=1.7p ad=1.7p ps=10.68u pd=10.68u rfmode=0
XM624 n_I9 gate_probe vdd vdd sg13_hv_pmos l=4u w=5u as=1.7p ad=1.7p ps=10.68u pd=10.68u rfmode=0
XM625 n_I9 gate_probe vdd vdd sg13_hv_pmos l=4u w=5u as=1.7p ad=1.7p ps=10.68u pd=10.68u rfmode=0
XM626 n_I9 gate_probe vdd vdd sg13_hv_pmos l=4u w=5u as=1.7p ad=1.7p ps=10.68u pd=10.68u rfmode=0
XM627 n_I9 gate_probe vdd vdd sg13_hv_pmos l=4u w=5u as=1.7p ad=1.7p ps=10.68u pd=10.68u rfmode=0
XM628 n_I9 gate_probe vdd vdd sg13_hv_pmos l=4u w=5u as=1.7p ad=1.7p ps=10.68u pd=10.68u rfmode=0
XM629 n_I9 gate_probe vdd vdd sg13_hv_pmos l=4u w=5u as=1.7p ad=1.7p ps=10.68u pd=10.68u rfmode=0
XM630 n_I9 gate_probe vdd vdd sg13_hv_pmos l=4u w=5u as=1.7p ad=1.7p ps=10.68u pd=10.68u rfmode=0
XM631 n_I9 gate_probe vdd vdd sg13_hv_pmos l=4u w=5u as=1.7p ad=1.7p ps=10.68u pd=10.68u rfmode=0
XM632 n_I9 gate_probe vdd vdd sg13_hv_pmos l=4u w=5u as=1.7p ad=1.7p ps=10.68u pd=10.68u rfmode=0
XM633 n_I9 gate_probe vdd vdd sg13_hv_pmos l=4u w=5u as=1.7p ad=1.7p ps=10.68u pd=10.68u rfmode=0
XM634 n_I9 gate_probe vdd vdd sg13_hv_pmos l=4u w=5u as=1.7p ad=1.7p ps=10.68u pd=10.68u rfmode=0
XM635 n_I9 gate_probe vdd vdd sg13_hv_pmos l=4u w=5u as=1.7p ad=1.7p ps=10.68u pd=10.68u rfmode=0
XM636 n_I9 gate_probe vdd vdd sg13_hv_pmos l=4u w=5u as=1.7p ad=1.7p ps=10.68u pd=10.68u rfmode=0
XM637 n_I9 gate_probe vdd vdd sg13_hv_pmos l=4u w=5u as=1.7p ad=1.7p ps=10.68u pd=10.68u rfmode=0
XM638 n_I9 gate_probe vdd vdd sg13_hv_pmos l=4u w=5u as=1.7p ad=1.7p ps=10.68u pd=10.68u rfmode=0
XM639 n_I9 gate_probe vdd vdd sg13_hv_pmos l=4u w=5u as=1.7p ad=1.7p ps=10.68u pd=10.68u rfmode=0
XM640 n_I9 gate_probe vdd vdd sg13_hv_pmos l=4u w=5u as=1.7p ad=1.7p ps=10.68u pd=10.68u rfmode=0
XM641 n_I9 gate_probe vdd vdd sg13_hv_pmos l=4u w=5u as=1.7p ad=1.7p ps=10.68u pd=10.68u rfmode=0
XM642 n_I9 gate_probe vdd vdd sg13_hv_pmos l=4u w=5u as=1.7p ad=1.7p ps=10.68u pd=10.68u rfmode=0
XM643 n_I9 gate_probe vdd vdd sg13_hv_pmos l=4u w=5u as=1.7p ad=1.7p ps=10.68u pd=10.68u rfmode=0
XM644 n_I9 gate_probe vdd vdd sg13_hv_pmos l=4u w=5u as=1.7p ad=1.7p ps=10.68u pd=10.68u rfmode=0
XM645 n_I9 gate_probe vdd vdd sg13_hv_pmos l=4u w=5u as=1.7p ad=1.7p ps=10.68u pd=10.68u rfmode=0
XM646 n_I9 gate_probe vdd vdd sg13_hv_pmos l=4u w=5u as=1.7p ad=1.7p ps=10.68u pd=10.68u rfmode=0
XM647 n_I9 gate_probe vdd vdd sg13_hv_pmos l=4u w=5u as=1.7p ad=1.7p ps=10.68u pd=10.68u rfmode=0
XM648 n_I9 gate_probe vdd vdd sg13_hv_pmos l=4u w=5u as=1.7p ad=1.7p ps=10.68u pd=10.68u rfmode=0
XM649 n_I9 gate_probe vdd vdd sg13_hv_pmos l=4u w=5u as=1.7p ad=1.7p ps=10.68u pd=10.68u rfmode=0
XM650 n_I9 gate_probe vdd vdd sg13_hv_pmos l=4u w=5u as=1.7p ad=1.7p ps=10.68u pd=10.68u rfmode=0
XM651 n_I9 gate_probe vdd vdd sg13_hv_pmos l=4u w=5u as=1.7p ad=1.7p ps=10.68u pd=10.68u rfmode=0
XM652 n_I9 gate_probe vdd vdd sg13_hv_pmos l=4u w=5u as=1.7p ad=1.7p ps=10.68u pd=10.68u rfmode=0
XM653 n_I9 gate_probe vdd vdd sg13_hv_pmos l=4u w=5u as=1.7p ad=1.7p ps=10.68u pd=10.68u rfmode=0
XM654 n_I9 gate_probe vdd vdd sg13_hv_pmos l=4u w=5u as=1.7p ad=1.7p ps=10.68u pd=10.68u rfmode=0
XM655 n_I9 gate_probe vdd vdd sg13_hv_pmos l=4u w=5u as=1.7p ad=1.7p ps=10.68u pd=10.68u rfmode=0
XM656 n_I9 gate_probe vdd vdd sg13_hv_pmos l=4u w=5u as=1.7p ad=1.7p ps=10.68u pd=10.68u rfmode=0
XM657 n_I9 gate_probe vdd vdd sg13_hv_pmos l=4u w=5u as=1.7p ad=1.7p ps=10.68u pd=10.68u rfmode=0
XM658 n_I9 gate_probe vdd vdd sg13_hv_pmos l=4u w=5u as=1.7p ad=1.7p ps=10.68u pd=10.68u rfmode=0
XM659 n_I9 gate_probe vdd vdd sg13_hv_pmos l=4u w=5u as=1.7p ad=1.7p ps=10.68u pd=10.68u rfmode=0
XM660 n_I9 gate_probe vdd vdd sg13_hv_pmos l=4u w=5u as=1.7p ad=1.7p ps=10.68u pd=10.68u rfmode=0
XM661 n_I9 gate_probe vdd vdd sg13_hv_pmos l=4u w=5u as=1.7p ad=1.7p ps=10.68u pd=10.68u rfmode=0
XM662 n_I9 gate_probe vdd vdd sg13_hv_pmos l=4u w=5u as=1.7p ad=1.7p ps=10.68u pd=10.68u rfmode=0
XM663 n_I9 gate_probe vdd vdd sg13_hv_pmos l=4u w=5u as=1.7p ad=1.7p ps=10.68u pd=10.68u rfmode=0
XM664 n_I8 gate_probe vdd vdd sg13_hv_pmos l=4u w=5u as=1.7p ad=1.7p ps=10.68u pd=10.68u rfmode=0
XM665 n_I8 gate_probe vdd vdd sg13_hv_pmos l=4u w=5u as=1.7p ad=1.7p ps=10.68u pd=10.68u rfmode=0
XM666 n_I8 gate_probe vdd vdd sg13_hv_pmos l=4u w=5u as=1.7p ad=1.7p ps=10.68u pd=10.68u rfmode=0
XM667 n_I8 gate_probe vdd vdd sg13_hv_pmos l=4u w=5u as=1.7p ad=1.7p ps=10.68u pd=10.68u rfmode=0
XM668 n_I8 gate_probe vdd vdd sg13_hv_pmos l=4u w=5u as=1.7p ad=1.7p ps=10.68u pd=10.68u rfmode=0
XM669 n_I8 gate_probe vdd vdd sg13_hv_pmos l=4u w=5u as=1.7p ad=1.7p ps=10.68u pd=10.68u rfmode=0
XM670 n_I8 gate_probe vdd vdd sg13_hv_pmos l=4u w=5u as=1.7p ad=1.7p ps=10.68u pd=10.68u rfmode=0
XM671 n_I8 gate_probe vdd vdd sg13_hv_pmos l=4u w=5u as=1.7p ad=1.7p ps=10.68u pd=10.68u rfmode=0
XM672 n_I8 gate_probe vdd vdd sg13_hv_pmos l=4u w=5u as=1.7p ad=1.7p ps=10.68u pd=10.68u rfmode=0
XM673 n_I8 gate_probe vdd vdd sg13_hv_pmos l=4u w=5u as=1.7p ad=1.7p ps=10.68u pd=10.68u rfmode=0
XM674 n_I8 gate_probe vdd vdd sg13_hv_pmos l=4u w=5u as=1.7p ad=1.7p ps=10.68u pd=10.68u rfmode=0
XM675 n_I8 gate_probe vdd vdd sg13_hv_pmos l=4u w=5u as=1.7p ad=1.7p ps=10.68u pd=10.68u rfmode=0
XM676 n_I8 gate_probe vdd vdd sg13_hv_pmos l=4u w=5u as=1.7p ad=1.7p ps=10.68u pd=10.68u rfmode=0
XM677 n_I8 gate_probe vdd vdd sg13_hv_pmos l=4u w=5u as=1.7p ad=1.7p ps=10.68u pd=10.68u rfmode=0
XM678 n_I8 gate_probe vdd vdd sg13_hv_pmos l=4u w=5u as=1.7p ad=1.7p ps=10.68u pd=10.68u rfmode=0
XM679 n_I8 gate_probe vdd vdd sg13_hv_pmos l=4u w=5u as=1.7p ad=1.7p ps=10.68u pd=10.68u rfmode=0
XM680 n_I8 gate_probe vdd vdd sg13_hv_pmos l=4u w=5u as=1.7p ad=1.7p ps=10.68u pd=10.68u rfmode=0
XM681 n_I8 gate_probe vdd vdd sg13_hv_pmos l=4u w=5u as=1.7p ad=1.7p ps=10.68u pd=10.68u rfmode=0
XM682 n_I8 gate_probe vdd vdd sg13_hv_pmos l=4u w=5u as=1.7p ad=1.7p ps=10.68u pd=10.68u rfmode=0
XM683 n_I8 gate_probe vdd vdd sg13_hv_pmos l=4u w=5u as=1.7p ad=1.7p ps=10.68u pd=10.68u rfmode=0
XM684 n_I8 gate_probe vdd vdd sg13_hv_pmos l=4u w=5u as=1.7p ad=1.7p ps=10.68u pd=10.68u rfmode=0
XM685 n_I8 gate_probe vdd vdd sg13_hv_pmos l=4u w=5u as=1.7p ad=1.7p ps=10.68u pd=10.68u rfmode=0
XM686 n_I8 gate_probe vdd vdd sg13_hv_pmos l=4u w=5u as=1.7p ad=1.7p ps=10.68u pd=10.68u rfmode=0
XM687 n_I8 gate_probe vdd vdd sg13_hv_pmos l=4u w=5u as=1.7p ad=1.7p ps=10.68u pd=10.68u rfmode=0
XM688 n_I8 gate_probe vdd vdd sg13_hv_pmos l=4u w=5u as=1.7p ad=1.7p ps=10.68u pd=10.68u rfmode=0
XM689 n_I8 gate_probe vdd vdd sg13_hv_pmos l=4u w=5u as=1.7p ad=1.7p ps=10.68u pd=10.68u rfmode=0
XM690 n_I8 gate_probe vdd vdd sg13_hv_pmos l=4u w=5u as=1.7p ad=1.7p ps=10.68u pd=10.68u rfmode=0
XM691 n_I8 gate_probe vdd vdd sg13_hv_pmos l=4u w=5u as=1.7p ad=1.7p ps=10.68u pd=10.68u rfmode=0
XM692 n_I8 gate_probe vdd vdd sg13_hv_pmos l=4u w=5u as=1.7p ad=1.7p ps=10.68u pd=10.68u rfmode=0
XM693 n_I8 gate_probe vdd vdd sg13_hv_pmos l=4u w=5u as=1.7p ad=1.7p ps=10.68u pd=10.68u rfmode=0
XM694 n_I8 gate_probe vdd vdd sg13_hv_pmos l=4u w=5u as=1.7p ad=1.7p ps=10.68u pd=10.68u rfmode=0
XM695 n_I8 gate_probe vdd vdd sg13_hv_pmos l=4u w=5u as=1.7p ad=1.7p ps=10.68u pd=10.68u rfmode=0
XM696 n_I8 gate_probe vdd vdd sg13_hv_pmos l=4u w=5u as=1.7p ad=1.7p ps=10.68u pd=10.68u rfmode=0
XM697 n_I8 gate_probe vdd vdd sg13_hv_pmos l=4u w=5u as=1.7p ad=1.7p ps=10.68u pd=10.68u rfmode=0
XM698 n_I8 gate_probe vdd vdd sg13_hv_pmos l=4u w=5u as=1.7p ad=1.7p ps=10.68u pd=10.68u rfmode=0
XM699 n_I8 gate_probe vdd vdd sg13_hv_pmos l=4u w=5u as=1.7p ad=1.7p ps=10.68u pd=10.68u rfmode=0
XM700 n_I8 gate_probe vdd vdd sg13_hv_pmos l=4u w=5u as=1.7p ad=1.7p ps=10.68u pd=10.68u rfmode=0
XM701 n_I8 gate_probe vdd vdd sg13_hv_pmos l=4u w=5u as=1.7p ad=1.7p ps=10.68u pd=10.68u rfmode=0
XM702 n_I8 gate_probe vdd vdd sg13_hv_pmos l=4u w=5u as=1.7p ad=1.7p ps=10.68u pd=10.68u rfmode=0
XM703 n_I8 gate_probe vdd vdd sg13_hv_pmos l=4u w=5u as=1.7p ad=1.7p ps=10.68u pd=10.68u rfmode=0
XM704 n_I8 gate_probe vdd vdd sg13_hv_pmos l=4u w=5u as=1.7p ad=1.7p ps=10.68u pd=10.68u rfmode=0
XM705 n_I8 gate_probe vdd vdd sg13_hv_pmos l=4u w=5u as=1.7p ad=1.7p ps=10.68u pd=10.68u rfmode=0
XM706 n_I8 gate_probe vdd vdd sg13_hv_pmos l=4u w=5u as=1.7p ad=1.7p ps=10.68u pd=10.68u rfmode=0
XM707 n_I8 gate_probe vdd vdd sg13_hv_pmos l=4u w=5u as=1.7p ad=1.7p ps=10.68u pd=10.68u rfmode=0
XM708 n_I8 gate_probe vdd vdd sg13_hv_pmos l=4u w=5u as=1.7p ad=1.7p ps=10.68u pd=10.68u rfmode=0
XM709 n_I8 gate_probe vdd vdd sg13_hv_pmos l=4u w=5u as=1.7p ad=1.7p ps=10.68u pd=10.68u rfmode=0
XM710 n_I8 gate_probe vdd vdd sg13_hv_pmos l=4u w=5u as=1.7p ad=1.7p ps=10.68u pd=10.68u rfmode=0
XM711 n_I8 gate_probe vdd vdd sg13_hv_pmos l=4u w=5u as=1.7p ad=1.7p ps=10.68u pd=10.68u rfmode=0
XM712 n_21 n_16 pcasc vss sg13_hv_nmos l=1u w=10u as=3.4p ad=3.4p ps=20.68u pd=20.68u rfmode=0
XM713 n_21 n_16 pcasc vss sg13_hv_nmos l=1u w=10u as=3.4p ad=3.4p ps=20.68u pd=20.68u rfmode=0
XM714 n_21 n_16 pcasc vss sg13_hv_nmos l=1u w=10u as=3.4p ad=3.4p ps=20.68u pd=20.68u rfmode=0
XM715 n_21 n_16 pcasc vss sg13_hv_nmos l=1u w=10u as=3.4p ad=3.4p ps=20.68u pd=20.68u rfmode=0
XM716 n_21 n_16 pcasc vss sg13_hv_nmos l=1u w=10u as=3.4p ad=3.4p ps=20.68u pd=20.68u rfmode=0
XM717 n_21 n_16 pcasc vss sg13_hv_nmos l=1u w=10u as=3.4p ad=3.4p ps=20.68u pd=20.68u rfmode=0
XM718 n_21 n_16 pcasc vss sg13_hv_nmos l=1u w=10u as=3.4p ad=3.4p ps=20.68u pd=20.68u rfmode=0
XM719 n_21 n_16 pcasc vss sg13_hv_nmos l=1u w=10u as=3.4p ad=3.4p ps=20.68u pd=20.68u rfmode=0
XM720 n_21 n_16 pcasc vss sg13_hv_nmos l=1u w=10u as=3.4p ad=3.4p ps=20.68u pd=20.68u rfmode=0
XM721 n_21 n_16 pcasc vss sg13_hv_nmos l=1u w=10u as=3.4p ad=3.4p ps=20.68u pd=20.68u rfmode=0
XM722 n_21 n_16 pcasc vss sg13_hv_nmos l=1u w=10u as=3.4p ad=3.4p ps=20.68u pd=20.68u rfmode=0
XM723 n_21 n_16 pcasc vss sg13_hv_nmos l=1u w=10u as=3.4p ad=3.4p ps=20.68u pd=20.68u rfmode=0
XM724 n_21 n_16 pcasc vss sg13_hv_nmos l=1u w=10u as=3.4p ad=3.4p ps=20.68u pd=20.68u rfmode=0
XM725 n_21 n_16 pcasc vss sg13_hv_nmos l=1u w=10u as=3.4p ad=3.4p ps=20.68u pd=20.68u rfmode=0
XM726 n_21 n_16 pcasc vss sg13_hv_nmos l=1u w=10u as=3.4p ad=3.4p ps=20.68u pd=20.68u rfmode=0
XM727 n_21 n_16 pcasc vss sg13_hv_nmos l=1u w=10u as=3.4p ad=3.4p ps=20.68u pd=20.68u rfmode=0
XM728 n_21 n_16 pcasc vss sg13_hv_nmos l=1u w=10u as=3.4p ad=3.4p ps=20.68u pd=20.68u rfmode=0
XM729 n_21 n_16 pcasc vss sg13_hv_nmos l=1u w=10u as=3.4p ad=3.4p ps=20.68u pd=20.68u rfmode=0
XM730 n_21 n_16 pcasc vss sg13_hv_nmos l=1u w=10u as=3.4p ad=3.4p ps=20.68u pd=20.68u rfmode=0
XM731 n_21 n_16 pcasc vss sg13_hv_nmos l=1u w=10u as=3.4p ad=3.4p ps=20.68u pd=20.68u rfmode=0
XM732 n_21 n_16 pcasc vss sg13_hv_nmos l=1u w=10u as=3.4p ad=3.4p ps=20.68u pd=20.68u rfmode=0
XM733 n_21 n_16 pcasc vss sg13_hv_nmos l=1u w=10u as=3.4p ad=3.4p ps=20.68u pd=20.68u rfmode=0
XM734 n_21 n_16 pcasc vss sg13_hv_nmos l=1u w=10u as=3.4p ad=3.4p ps=20.68u pd=20.68u rfmode=0
XM735 n_21 n_16 pcasc vss sg13_hv_nmos l=1u w=10u as=3.4p ad=3.4p ps=20.68u pd=20.68u rfmode=0
XQ736 n_I12 n_I12 vss vss npn13G2 we=0.07u le=0.9u Nx=1 m=1
XQ737 n_I12 n_I12 vss vss npn13G2 we=0.07u le=0.9u Nx=1 m=1
XQ738 n_I12 n_I12 vss vss npn13G2 we=0.07u le=0.9u Nx=1 m=1
XQ739 n_I12 n_I12 vss vss npn13G2 we=0.07u le=0.9u Nx=1 m=1
XQ740 n_I12 n_I12 vss vss npn13G2 we=0.07u le=0.9u Nx=1 m=1
XQ741 n_I12 n_I12 vss vss npn13G2 we=0.07u le=0.9u Nx=1 m=1
XQ742 n_I12 n_I12 vss vss npn13G2 we=0.07u le=0.9u Nx=1 m=1
XQ743 n_I12 n_I12 vss vss npn13G2 we=0.07u le=0.9u Nx=1 m=1
XQ744 n_I12 n_I12 vss vss npn13G2 we=0.07u le=0.9u Nx=1 m=1
XQ745 n_I12 n_I12 vss vss npn13G2 we=0.07u le=0.9u Nx=1 m=1
XQ746 n_I12 n_I12 vss vss npn13G2 we=0.07u le=0.9u Nx=1 m=1
XQ747 n_I12 n_I12 vss vss npn13G2 we=0.07u le=0.9u Nx=1 m=1
XQ748 n_I12 n_I12 vss vss npn13G2 we=0.07u le=0.9u Nx=1 m=1
XQ749 n_I12 n_I12 vss vss npn13G2 we=0.07u le=0.9u Nx=1 m=1
XQ750 n_I12 n_I12 vss vss npn13G2 we=0.07u le=0.9u Nx=1 m=1
XQ751 n_I12 n_I12 vss vss npn13G2 we=0.07u le=0.9u Nx=1 m=1
XQ752 n_I12 n_I12 vss vss npn13G2 we=0.07u le=0.9u Nx=1 m=1
XQ753 n_I12 n_I12 vss vss npn13G2 we=0.07u le=0.9u Nx=1 m=1
XQ754 n_I12 n_I12 vss vss npn13G2 we=0.07u le=0.9u Nx=1 m=1
XQ755 n_I12 n_I12 vss vss npn13G2 we=0.07u le=0.9u Nx=1 m=1
XQ756 n_I12 n_I12 vss vss npn13G2 we=0.07u le=0.9u Nx=1 m=1
XQ757 n_I12 n_I12 vss vss npn13G2 we=0.07u le=0.9u Nx=1 m=1
XQ758 n_I12 n_I12 vss vss npn13G2 we=0.07u le=0.9u Nx=1 m=1
XQ759 n_I12 n_I12 vss vss npn13G2 we=0.07u le=0.9u Nx=1 m=1
XQ760 vbe vbe vss vss npn13G2 we=0.07u le=0.9u Nx=1 m=1
XQ761 vbe vbe vss vss npn13G2 we=0.07u le=0.9u Nx=1 m=1
XQ762 vbe vbe vss vss npn13G2 we=0.07u le=0.9u Nx=1 m=1
XQ763 vbe vbe vss vss npn13G2 we=0.07u le=0.9u Nx=1 m=1
XQ764 vbe vbe vss vss npn13G2 we=0.07u le=0.9u Nx=1 m=1
XQ765 vbe vbe vss vss npn13G2 we=0.07u le=0.9u Nx=1 m=1
XQ766 vbe vbe vss vss npn13G2 we=0.07u le=0.9u Nx=1 m=1
XQ767 vbe vbe vss vss npn13G2 we=0.07u le=0.9u Nx=1 m=1
XQ768 vbe vbe vss vss npn13G2 we=0.07u le=0.9u Nx=1 m=1
XQ769 vbe vbe vss vss npn13G2 we=0.07u le=0.9u Nx=1 m=1
XQ770 vbe vbe vss vss npn13G2 we=0.07u le=0.9u Nx=1 m=1
XQ771 vbe vbe vss vss npn13G2 we=0.07u le=0.9u Nx=1 m=1
XQ772 vbe vbe vss vss npn13G2 we=0.07u le=0.9u Nx=1 m=1
XQ773 vbe vbe vss vss npn13G2 we=0.07u le=0.9u Nx=1 m=1
XQ774 vbe vbe vss vss npn13G2 we=0.07u le=0.9u Nx=1 m=1
XQ775 vbe vbe vss vss npn13G2 we=0.07u le=0.9u Nx=1 m=1
XQ776 vbe vbe vss vss npn13G2 we=0.07u le=0.9u Nx=1 m=1
XQ777 vbe vbe vss vss npn13G2 we=0.07u le=0.9u Nx=1 m=1
XQ778 vbe vbe vss vss npn13G2 we=0.07u le=0.9u Nx=1 m=1
XQ779 vbe vbe vss vss npn13G2 we=0.07u le=0.9u Nx=1 m=1
XQ780 vbe vbe vss vss npn13G2 we=0.07u le=0.9u Nx=1 m=1
XQ781 vbe vbe vss vss npn13G2 we=0.07u le=0.9u Nx=1 m=1
XQ782 vbe vbe vss vss npn13G2 we=0.07u le=0.9u Nx=1 m=1
XQ783 vbe vbe vss vss npn13G2 we=0.07u le=0.9u Nx=1 m=1
XQ784 vbe n_20 vss vss npn13G2 we=0.07u le=0.9u Nx=1 m=1
XQ785 vbe n_20 vss vss npn13G2 we=0.07u le=0.9u Nx=1 m=1
XQ786 vbe n_20 vss vss npn13G2 we=0.07u le=0.9u Nx=1 m=1
XQ787 vbe n_20 vss vss npn13G2 we=0.07u le=0.9u Nx=1 m=1
XQ788 vbe n_20 vss vss npn13G2 we=0.07u le=0.9u Nx=1 m=1
XQ789 vbe n_20 vss vss npn13G2 we=0.07u le=0.9u Nx=1 m=1
XQ790 vbe n_20 vss vss npn13G2 we=0.07u le=0.9u Nx=1 m=1
XQ791 vbe n_20 vss vss npn13G2 we=0.07u le=0.9u Nx=1 m=1
XQ792 vbe n_20 vss vss npn13G2 we=0.07u le=0.9u Nx=1 m=1
XQ793 vbe n_20 vss vss npn13G2 we=0.07u le=0.9u Nx=1 m=1
XQ794 vbe n_20 vss vss npn13G2 we=0.07u le=0.9u Nx=1 m=1
XQ795 vbe n_20 vss vss npn13G2 we=0.07u le=0.9u Nx=1 m=1
XQ796 vbe n_20 vss vss npn13G2 we=0.07u le=0.9u Nx=1 m=1
XQ797 vbe n_20 vss vss npn13G2 we=0.07u le=0.9u Nx=1 m=1
XQ798 vbe n_20 vss vss npn13G2 we=0.07u le=0.9u Nx=1 m=1
XQ799 vbe n_20 vss vss npn13G2 we=0.07u le=0.9u Nx=1 m=1
XQ800 vbe n_20 vss vss npn13G2 we=0.07u le=0.9u Nx=1 m=1
XQ801 vbe n_20 vss vss npn13G2 we=0.07u le=0.9u Nx=1 m=1
XQ802 vbe n_20 vss vss npn13G2 we=0.07u le=0.9u Nx=1 m=1
XQ803 vbe n_20 vss vss npn13G2 we=0.07u le=0.9u Nx=1 m=1
XQ804 vbe n_20 vss vss npn13G2 we=0.07u le=0.9u Nx=1 m=1
XQ805 vbe n_20 vss vss npn13G2 we=0.07u le=0.9u Nx=1 m=1
XQ806 vbe n_20 vss vss npn13G2 we=0.07u le=0.9u Nx=1 m=1
XQ807 vbe n_20 vss vss npn13G2 we=0.07u le=0.9u Nx=1 m=1
XQ808 n_21 vbe dvbe vss npn13G2 we=0.07u le=0.9u Nx=1 m=1
XQ809 n_21 vbe dvbe vss npn13G2 we=0.07u le=0.9u Nx=1 m=1
XQ810 n_21 vbe dvbe vss npn13G2 we=0.07u le=0.9u Nx=1 m=1
XQ811 n_21 vbe dvbe vss npn13G2 we=0.07u le=0.9u Nx=1 m=1
XQ812 n_21 vbe dvbe vss npn13G2 we=0.07u le=0.9u Nx=1 m=1
XQ813 n_21 vbe dvbe vss npn13G2 we=0.07u le=0.9u Nx=1 m=1
XQ814 n_21 vbe dvbe vss npn13G2 we=0.07u le=0.9u Nx=1 m=1
XQ815 n_21 vbe dvbe vss npn13G2 we=0.07u le=0.9u Nx=1 m=1
XQ816 n_21 vbe dvbe vss npn13G2 we=0.07u le=0.9u Nx=1 m=1
XQ817 n_21 vbe dvbe vss npn13G2 we=0.07u le=0.9u Nx=1 m=1
XQ818 n_21 vbe dvbe vss npn13G2 we=0.07u le=0.9u Nx=1 m=1
XQ819 n_21 vbe dvbe vss npn13G2 we=0.07u le=0.9u Nx=1 m=1
XQ820 n_21 vbe dvbe vss npn13G2 we=0.07u le=0.9u Nx=1 m=1
XQ821 n_21 vbe dvbe vss npn13G2 we=0.07u le=0.9u Nx=1 m=1
XQ822 n_21 vbe dvbe vss npn13G2 we=0.07u le=0.9u Nx=1 m=1
XQ823 n_21 vbe dvbe vss npn13G2 we=0.07u le=0.9u Nx=1 m=1
XQ824 n_21 vbe dvbe vss npn13G2 we=0.07u le=0.9u Nx=1 m=1
XQ825 n_21 vbe dvbe vss npn13G2 we=0.07u le=0.9u Nx=1 m=1
XQ826 n_21 vbe dvbe vss npn13G2 we=0.07u le=0.9u Nx=1 m=1
XQ827 n_21 vbe dvbe vss npn13G2 we=0.07u le=0.9u Nx=1 m=1
XQ828 n_21 vbe dvbe vss npn13G2 we=0.07u le=0.9u Nx=1 m=1
XQ829 n_21 vbe dvbe vss npn13G2 we=0.07u le=0.9u Nx=1 m=1
XQ830 n_21 vbe dvbe vss npn13G2 we=0.07u le=0.9u Nx=1 m=1
XQ831 n_21 vbe dvbe vss npn13G2 we=0.07u le=0.9u Nx=1 m=1
XQ832 n_21 vbe dvbe vss npn13G2 we=0.07u le=0.9u Nx=1 m=1
XQ833 n_21 vbe dvbe vss npn13G2 we=0.07u le=0.9u Nx=1 m=1
XQ834 n_21 vbe dvbe vss npn13G2 we=0.07u le=0.9u Nx=1 m=1
XQ835 n_21 vbe dvbe vss npn13G2 we=0.07u le=0.9u Nx=1 m=1
XQ836 n_21 vbe dvbe vss npn13G2 we=0.07u le=0.9u Nx=1 m=1
XQ837 n_21 vbe dvbe vss npn13G2 we=0.07u le=0.9u Nx=1 m=1
XQ838 n_21 vbe dvbe vss npn13G2 we=0.07u le=0.9u Nx=1 m=1
XQ839 n_21 vbe dvbe vss npn13G2 we=0.07u le=0.9u Nx=1 m=1
XQ840 n_21 vbe dvbe vss npn13G2 we=0.07u le=0.9u Nx=1 m=1
XQ841 n_21 vbe dvbe vss npn13G2 we=0.07u le=0.9u Nx=1 m=1
XQ842 n_21 vbe dvbe vss npn13G2 we=0.07u le=0.9u Nx=1 m=1
XQ843 n_21 vbe dvbe vss npn13G2 we=0.07u le=0.9u Nx=1 m=1
XQ844 n_21 vbe dvbe vss npn13G2 we=0.07u le=0.9u Nx=1 m=1
XQ845 n_21 vbe dvbe vss npn13G2 we=0.07u le=0.9u Nx=1 m=1
XQ846 n_21 vbe dvbe vss npn13G2 we=0.07u le=0.9u Nx=1 m=1
XQ847 n_21 vbe dvbe vss npn13G2 we=0.07u le=0.9u Nx=1 m=1
XQ848 n_21 vbe dvbe vss npn13G2 we=0.07u le=0.9u Nx=1 m=1
XQ849 n_21 vbe dvbe vss npn13G2 we=0.07u le=0.9u Nx=1 m=1
XQ850 n_21 vbe dvbe vss npn13G2 we=0.07u le=0.9u Nx=1 m=1
XQ851 n_21 vbe dvbe vss npn13G2 we=0.07u le=0.9u Nx=1 m=1
XQ852 n_21 vbe dvbe vss npn13G2 we=0.07u le=0.9u Nx=1 m=1
XQ853 n_21 vbe dvbe vss npn13G2 we=0.07u le=0.9u Nx=1 m=1
XQ854 n_21 vbe dvbe vss npn13G2 we=0.07u le=0.9u Nx=1 m=1
XQ855 n_21 vbe dvbe vss npn13G2 we=0.07u le=0.9u Nx=1 m=1
XQ856 n_21 vbe dvbe vss npn13G2 we=0.07u le=0.9u Nx=1 m=1
XQ857 n_21 vbe dvbe vss npn13G2 we=0.07u le=0.9u Nx=1 m=1
XQ858 n_21 vbe dvbe vss npn13G2 we=0.07u le=0.9u Nx=1 m=1
XQ859 n_21 vbe dvbe vss npn13G2 we=0.07u le=0.9u Nx=1 m=1
XQ860 n_21 vbe dvbe vss npn13G2 we=0.07u le=0.9u Nx=1 m=1
XQ861 n_21 vbe dvbe vss npn13G2 we=0.07u le=0.9u Nx=1 m=1
XQ862 n_21 vbe dvbe vss npn13G2 we=0.07u le=0.9u Nx=1 m=1
XQ863 n_21 vbe dvbe vss npn13G2 we=0.07u le=0.9u Nx=1 m=1
XQ864 n_21 vbe dvbe vss npn13G2 we=0.07u le=0.9u Nx=1 m=1
XQ865 n_21 vbe dvbe vss npn13G2 we=0.07u le=0.9u Nx=1 m=1
XQ866 n_21 vbe dvbe vss npn13G2 we=0.07u le=0.9u Nx=1 m=1
XQ867 n_21 vbe dvbe vss npn13G2 we=0.07u le=0.9u Nx=1 m=1
XQ868 n_21 vbe dvbe vss npn13G2 we=0.07u le=0.9u Nx=1 m=1
XQ869 n_21 vbe dvbe vss npn13G2 we=0.07u le=0.9u Nx=1 m=1
XQ870 n_21 vbe dvbe vss npn13G2 we=0.07u le=0.9u Nx=1 m=1
XQ871 n_21 vbe dvbe vss npn13G2 we=0.07u le=0.9u Nx=1 m=1
XQ872 n_21 vbe dvbe vss npn13G2 we=0.07u le=0.9u Nx=1 m=1
XQ873 n_21 vbe dvbe vss npn13G2 we=0.07u le=0.9u Nx=1 m=1
XQ874 n_21 vbe dvbe vss npn13G2 we=0.07u le=0.9u Nx=1 m=1
XQ875 n_21 vbe dvbe vss npn13G2 we=0.07u le=0.9u Nx=1 m=1
XQ876 n_21 vbe dvbe vss npn13G2 we=0.07u le=0.9u Nx=1 m=1
XQ877 n_21 vbe dvbe vss npn13G2 we=0.07u le=0.9u Nx=1 m=1
XQ878 n_21 vbe dvbe vss npn13G2 we=0.07u le=0.9u Nx=1 m=1
XQ879 n_21 vbe dvbe vss npn13G2 we=0.07u le=0.9u Nx=1 m=1
XQ880 n_21 vbe dvbe vss npn13G2 we=0.07u le=0.9u Nx=1 m=1
XQ881 n_21 vbe dvbe vss npn13G2 we=0.07u le=0.9u Nx=1 m=1
XQ882 n_21 vbe dvbe vss npn13G2 we=0.07u le=0.9u Nx=1 m=1
XQ883 n_21 vbe dvbe vss npn13G2 we=0.07u le=0.9u Nx=1 m=1
XQ884 n_21 vbe dvbe vss npn13G2 we=0.07u le=0.9u Nx=1 m=1
XQ885 n_21 vbe dvbe vss npn13G2 we=0.07u le=0.9u Nx=1 m=1
XQ886 n_21 vbe dvbe vss npn13G2 we=0.07u le=0.9u Nx=1 m=1
XQ887 n_21 vbe dvbe vss npn13G2 we=0.07u le=0.9u Nx=1 m=1
XQ888 n_21 vbe dvbe vss npn13G2 we=0.07u le=0.9u Nx=1 m=1
XQ889 n_21 vbe dvbe vss npn13G2 we=0.07u le=0.9u Nx=1 m=1
XQ890 n_21 vbe dvbe vss npn13G2 we=0.07u le=0.9u Nx=1 m=1
XQ891 n_21 vbe dvbe vss npn13G2 we=0.07u le=0.9u Nx=1 m=1
XQ892 n_21 vbe dvbe vss npn13G2 we=0.07u le=0.9u Nx=1 m=1
XQ893 n_21 vbe dvbe vss npn13G2 we=0.07u le=0.9u Nx=1 m=1
XQ894 n_21 vbe dvbe vss npn13G2 we=0.07u le=0.9u Nx=1 m=1
XQ895 n_21 vbe dvbe vss npn13G2 we=0.07u le=0.9u Nx=1 m=1
XQ896 n_21 vbe dvbe vss npn13G2 we=0.07u le=0.9u Nx=1 m=1
XQ897 n_21 vbe dvbe vss npn13G2 we=0.07u le=0.9u Nx=1 m=1
XQ898 n_21 vbe dvbe vss npn13G2 we=0.07u le=0.9u Nx=1 m=1
XQ899 n_21 vbe dvbe vss npn13G2 we=0.07u le=0.9u Nx=1 m=1
XQ900 n_21 vbe dvbe vss npn13G2 we=0.07u le=0.9u Nx=1 m=1
XQ901 n_21 vbe dvbe vss npn13G2 we=0.07u le=0.9u Nx=1 m=1
XQ902 n_21 vbe dvbe vss npn13G2 we=0.07u le=0.9u Nx=1 m=1
XQ903 n_21 vbe dvbe vss npn13G2 we=0.07u le=0.9u Nx=1 m=1
XQ904 n_21 vbe dvbe vss npn13G2 we=0.07u le=0.9u Nx=1 m=1
XQ905 n_21 vbe dvbe vss npn13G2 we=0.07u le=0.9u Nx=1 m=1
XQ906 n_21 vbe dvbe vss npn13G2 we=0.07u le=0.9u Nx=1 m=1
XQ907 n_21 vbe dvbe vss npn13G2 we=0.07u le=0.9u Nx=1 m=1
XQ908 n_21 vbe dvbe vss npn13G2 we=0.07u le=0.9u Nx=1 m=1
XQ909 n_21 vbe dvbe vss npn13G2 we=0.07u le=0.9u Nx=1 m=1
XQ910 n_21 vbe dvbe vss npn13G2 we=0.07u le=0.9u Nx=1 m=1
XQ911 n_21 vbe dvbe vss npn13G2 we=0.07u le=0.9u Nx=1 m=1
XQ912 n_21 vbe dvbe vss npn13G2 we=0.07u le=0.9u Nx=1 m=1
XQ913 n_21 vbe dvbe vss npn13G2 we=0.07u le=0.9u Nx=1 m=1
XQ914 n_21 vbe dvbe vss npn13G2 we=0.07u le=0.9u Nx=1 m=1
XQ915 n_21 vbe dvbe vss npn13G2 we=0.07u le=0.9u Nx=1 m=1
XQ916 n_21 vbe dvbe vss npn13G2 we=0.07u le=0.9u Nx=1 m=1
XQ917 n_21 vbe dvbe vss npn13G2 we=0.07u le=0.9u Nx=1 m=1
XQ918 n_21 vbe dvbe vss npn13G2 we=0.07u le=0.9u Nx=1 m=1
XQ919 n_21 vbe dvbe vss npn13G2 we=0.07u le=0.9u Nx=1 m=1
XQ920 n_21 vbe dvbe vss npn13G2 we=0.07u le=0.9u Nx=1 m=1
XQ921 n_21 vbe dvbe vss npn13G2 we=0.07u le=0.9u Nx=1 m=1
XQ922 n_21 vbe dvbe vss npn13G2 we=0.07u le=0.9u Nx=1 m=1
XQ923 n_21 vbe dvbe vss npn13G2 we=0.07u le=0.9u Nx=1 m=1
XQ924 n_21 vbe dvbe vss npn13G2 we=0.07u le=0.9u Nx=1 m=1
XQ925 n_21 vbe dvbe vss npn13G2 we=0.07u le=0.9u Nx=1 m=1
XQ926 n_21 vbe dvbe vss npn13G2 we=0.07u le=0.9u Nx=1 m=1
XQ927 n_21 vbe dvbe vss npn13G2 we=0.07u le=0.9u Nx=1 m=1
XQ928 n_21 vbe dvbe vss npn13G2 we=0.07u le=0.9u Nx=1 m=1
XQ929 n_21 vbe dvbe vss npn13G2 we=0.07u le=0.9u Nx=1 m=1
XQ930 n_21 vbe dvbe vss npn13G2 we=0.07u le=0.9u Nx=1 m=1
XQ931 n_21 vbe dvbe vss npn13G2 we=0.07u le=0.9u Nx=1 m=1
XQ932 n_21 vbe dvbe vss npn13G2 we=0.07u le=0.9u Nx=1 m=1
XQ933 n_21 vbe dvbe vss npn13G2 we=0.07u le=0.9u Nx=1 m=1
XQ934 n_21 vbe dvbe vss npn13G2 we=0.07u le=0.9u Nx=1 m=1
XQ935 n_21 vbe dvbe vss npn13G2 we=0.07u le=0.9u Nx=1 m=1
XQ936 n_21 vbe dvbe vss npn13G2 we=0.07u le=0.9u Nx=1 m=1
XQ937 n_21 vbe dvbe vss npn13G2 we=0.07u le=0.9u Nx=1 m=1
XQ938 n_21 vbe dvbe vss npn13G2 we=0.07u le=0.9u Nx=1 m=1
XQ939 n_21 vbe dvbe vss npn13G2 we=0.07u le=0.9u Nx=1 m=1
XQ940 n_21 vbe dvbe vss npn13G2 we=0.07u le=0.9u Nx=1 m=1
XQ941 n_21 vbe dvbe vss npn13G2 we=0.07u le=0.9u Nx=1 m=1
XQ942 n_21 vbe dvbe vss npn13G2 we=0.07u le=0.9u Nx=1 m=1
XQ943 n_21 vbe dvbe vss npn13G2 we=0.07u le=0.9u Nx=1 m=1
XQ944 n_21 vbe dvbe vss npn13G2 we=0.07u le=0.9u Nx=1 m=1
XQ945 n_21 vbe dvbe vss npn13G2 we=0.07u le=0.9u Nx=1 m=1
XQ946 n_21 vbe dvbe vss npn13G2 we=0.07u le=0.9u Nx=1 m=1
XQ947 n_21 vbe dvbe vss npn13G2 we=0.07u le=0.9u Nx=1 m=1
XQ948 n_21 vbe dvbe vss npn13G2 we=0.07u le=0.9u Nx=1 m=1
XQ949 n_21 vbe dvbe vss npn13G2 we=0.07u le=0.9u Nx=1 m=1
XQ950 n_21 vbe dvbe vss npn13G2 we=0.07u le=0.9u Nx=1 m=1
XQ951 n_21 vbe dvbe vss npn13G2 we=0.07u le=0.9u Nx=1 m=1
XQ952 n_21 vbe dvbe vss npn13G2 we=0.07u le=0.9u Nx=1 m=1
XQ953 n_21 vbe dvbe vss npn13G2 we=0.07u le=0.9u Nx=1 m=1
XQ954 n_21 vbe dvbe vss npn13G2 we=0.07u le=0.9u Nx=1 m=1
XQ955 n_21 vbe dvbe vss npn13G2 we=0.07u le=0.9u Nx=1 m=1
XQ956 n_21 vbe dvbe vss npn13G2 we=0.07u le=0.9u Nx=1 m=1
XQ957 n_21 vbe dvbe vss npn13G2 we=0.07u le=0.9u Nx=1 m=1
XQ958 n_21 vbe dvbe vss npn13G2 we=0.07u le=0.9u Nx=1 m=1
XQ959 n_21 vbe dvbe vss npn13G2 we=0.07u le=0.9u Nx=1 m=1
XQ960 n_21 vbe dvbe vss npn13G2 we=0.07u le=0.9u Nx=1 m=1
XQ961 n_21 vbe dvbe vss npn13G2 we=0.07u le=0.9u Nx=1 m=1
XQ962 n_21 vbe dvbe vss npn13G2 we=0.07u le=0.9u Nx=1 m=1
XQ963 n_21 vbe dvbe vss npn13G2 we=0.07u le=0.9u Nx=1 m=1
XQ964 n_21 vbe dvbe vss npn13G2 we=0.07u le=0.9u Nx=1 m=1
XQ965 n_21 vbe dvbe vss npn13G2 we=0.07u le=0.9u Nx=1 m=1
XQ966 n_21 vbe dvbe vss npn13G2 we=0.07u le=0.9u Nx=1 m=1
XQ967 n_21 vbe dvbe vss npn13G2 we=0.07u le=0.9u Nx=1 m=1
XQ968 n_21 vbe dvbe vss npn13G2 we=0.07u le=0.9u Nx=1 m=1
XQ969 n_21 vbe dvbe vss npn13G2 we=0.07u le=0.9u Nx=1 m=1
XQ970 n_21 vbe dvbe vss npn13G2 we=0.07u le=0.9u Nx=1 m=1
XQ971 n_21 vbe dvbe vss npn13G2 we=0.07u le=0.9u Nx=1 m=1
XQ972 n_21 vbe dvbe vss npn13G2 we=0.07u le=0.9u Nx=1 m=1
XQ973 n_21 vbe dvbe vss npn13G2 we=0.07u le=0.9u Nx=1 m=1
XQ974 n_21 vbe dvbe vss npn13G2 we=0.07u le=0.9u Nx=1 m=1
XQ975 n_21 vbe dvbe vss npn13G2 we=0.07u le=0.9u Nx=1 m=1
XQ976 n_21 vbe dvbe vss npn13G2 we=0.07u le=0.9u Nx=1 m=1
XQ977 n_21 vbe dvbe vss npn13G2 we=0.07u le=0.9u Nx=1 m=1
XQ978 n_21 vbe dvbe vss npn13G2 we=0.07u le=0.9u Nx=1 m=1
XQ979 n_21 vbe dvbe vss npn13G2 we=0.07u le=0.9u Nx=1 m=1
XQ980 n_21 vbe dvbe vss npn13G2 we=0.07u le=0.9u Nx=1 m=1
XQ981 n_21 vbe dvbe vss npn13G2 we=0.07u le=0.9u Nx=1 m=1
XQ982 n_21 vbe dvbe vss npn13G2 we=0.07u le=0.9u Nx=1 m=1
XQ983 n_21 vbe dvbe vss npn13G2 we=0.07u le=0.9u Nx=1 m=1
XQ984 n_21 vbe dvbe vss npn13G2 we=0.07u le=0.9u Nx=1 m=1
XQ985 n_21 vbe dvbe vss npn13G2 we=0.07u le=0.9u Nx=1 m=1
XQ986 n_21 vbe dvbe vss npn13G2 we=0.07u le=0.9u Nx=1 m=1
XQ987 n_21 vbe dvbe vss npn13G2 we=0.07u le=0.9u Nx=1 m=1
XQ988 n_21 vbe dvbe vss npn13G2 we=0.07u le=0.9u Nx=1 m=1
XQ989 n_21 vbe dvbe vss npn13G2 we=0.07u le=0.9u Nx=1 m=1
XQ990 n_21 vbe dvbe vss npn13G2 we=0.07u le=0.9u Nx=1 m=1
XQ991 n_21 vbe dvbe vss npn13G2 we=0.07u le=0.9u Nx=1 m=1
XQ992 n_21 vbe dvbe vss npn13G2 we=0.07u le=0.9u Nx=1 m=1
XQ993 n_21 vbe dvbe vss npn13G2 we=0.07u le=0.9u Nx=1 m=1
XQ994 n_21 vbe dvbe vss npn13G2 we=0.07u le=0.9u Nx=1 m=1
XQ995 n_21 vbe dvbe vss npn13G2 we=0.07u le=0.9u Nx=1 m=1
XQ996 n_21 vbe dvbe vss npn13G2 we=0.07u le=0.9u Nx=1 m=1
XQ997 n_21 vbe dvbe vss npn13G2 we=0.07u le=0.9u Nx=1 m=1
XQ998 n_21 vbe dvbe vss npn13G2 we=0.07u le=0.9u Nx=1 m=1
XQ999 n_21 vbe dvbe vss npn13G2 we=0.07u le=0.9u Nx=1 m=1
XQ1000 n_18 n_18 n_I12 vss npn13G2 we=0.07u le=0.9u Nx=1 m=1
XQ1001 n_18 n_18 n_I12 vss npn13G2 we=0.07u le=0.9u Nx=1 m=1
XQ1002 n_18 n_18 n_I12 vss npn13G2 we=0.07u le=0.9u Nx=1 m=1
XQ1003 n_18 n_18 n_I12 vss npn13G2 we=0.07u le=0.9u Nx=1 m=1
XQ1004 n_18 n_18 n_I12 vss npn13G2 we=0.07u le=0.9u Nx=1 m=1
XQ1005 n_18 n_18 n_I12 vss npn13G2 we=0.07u le=0.9u Nx=1 m=1
XQ1006 n_18 n_18 n_I12 vss npn13G2 we=0.07u le=0.9u Nx=1 m=1
XQ1007 n_18 n_18 n_I12 vss npn13G2 we=0.07u le=0.9u Nx=1 m=1
XQ1008 n_18 n_18 n_I12 vss npn13G2 we=0.07u le=0.9u Nx=1 m=1
XQ1009 n_18 n_18 n_I12 vss npn13G2 we=0.07u le=0.9u Nx=1 m=1
XQ1010 n_18 n_18 n_I12 vss npn13G2 we=0.07u le=0.9u Nx=1 m=1
XQ1011 n_18 n_18 n_I12 vss npn13G2 we=0.07u le=0.9u Nx=1 m=1
XQ1012 n_18 n_18 n_I12 vss npn13G2 we=0.07u le=0.9u Nx=1 m=1
XQ1013 n_18 n_18 n_I12 vss npn13G2 we=0.07u le=0.9u Nx=1 m=1
XQ1014 n_18 n_18 n_I12 vss npn13G2 we=0.07u le=0.9u Nx=1 m=1
XQ1015 n_18 n_18 n_I12 vss npn13G2 we=0.07u le=0.9u Nx=1 m=1
XQ1016 n_18 n_18 n_I12 vss npn13G2 we=0.07u le=0.9u Nx=1 m=1
XQ1017 n_18 n_18 n_I12 vss npn13G2 we=0.07u le=0.9u Nx=1 m=1
XQ1018 n_18 n_18 n_I12 vss npn13G2 we=0.07u le=0.9u Nx=1 m=1
XQ1019 n_18 n_18 n_I12 vss npn13G2 we=0.07u le=0.9u Nx=1 m=1
XQ1020 n_18 n_18 n_I12 vss npn13G2 we=0.07u le=0.9u Nx=1 m=1
XQ1021 n_18 n_18 n_I12 vss npn13G2 we=0.07u le=0.9u Nx=1 m=1
XQ1022 n_18 n_18 n_I12 vss npn13G2 we=0.07u le=0.9u Nx=1 m=1
XQ1023 n_18 n_18 n_I12 vss npn13G2 we=0.07u le=0.9u Nx=1 m=1
XQ1024 n_17 n_17 vss vss npn13G2 we=0.07u le=0.9u Nx=1 m=1
XQ1025 n_17 n_17 vss vss npn13G2 we=0.07u le=0.9u Nx=1 m=1
XQ1026 n_17 n_17 vss vss npn13G2 we=0.07u le=0.9u Nx=1 m=1
XQ1027 n_17 n_17 vss vss npn13G2 we=0.07u le=0.9u Nx=1 m=1
XQ1028 vss vss vss vss npn13G2 we=0.07u le=0.9u Nx=1 m=1
XQ1029 vss vss vss vss npn13G2 we=0.07u le=0.9u Nx=1 m=1
XQ1030 vss vss vss vss npn13G2 we=0.07u le=0.9u Nx=1 m=1
XQ1031 vss vss vss vss npn13G2 we=0.07u le=0.9u Nx=1 m=1
XQ1032 vss vss vss vss npn13G2 we=0.07u le=0.9u Nx=1 m=1
XQ1033 vss vss vss vss npn13G2 we=0.07u le=0.9u Nx=1 m=1
XQ1034 vss vss vss vss npn13G2 we=0.07u le=0.9u Nx=1 m=1
XQ1035 vss vss vss vss npn13G2 we=0.07u le=0.9u Nx=1 m=1
XQ1036 vss vss vss vss npn13G2 we=0.07u le=0.9u Nx=1 m=1
Cext_1 n_10 n_16 191.942e-18
Cext_2 n_10 n_17 40.7278e-18
Cext_3 n_10 n_18 40.7278e-18
Cext_4 n_10 n_20 3.05926f
Cext_5 n_10 n_21 326.618e-18
Cext_6 n_10 n_I10 6.16273f
Cext_7 n_10 n_I11 118.452e-18
Cext_8 n_10 n_I13 893.226e-18
Cext_9 n_10 n_I14 890.661e-18
Cext_10 n_10 n_I15 856.268e-18
Cext_11 n_10 n_I16 209.738e-18
Cext_12 n_10 n_I17 125.387e-18
Cext_13 n_10 n_I18 898.53e-18
Cext_14 n_10 n_I19 77.8746e-18
Cext_15 n_10 n_I20 41.5452e-18
Cext_16 n_10 n_I21 41.5452e-18
Cext_17 n_10 n_I22 41.5452e-18
Cext_18 n_10 n_I23 889.999e-18
Cext_19 n_10 n_I24 43.2931e-18
Cext_20 n_10 n_I25 40.7278e-18
Cext_21 n_10 n_I26 40.7278e-18
Cext_22 n_10 n_I27 40.7278e-18
Cext_23 n_10 n_I28 915.176e-18
Cext_24 n_10 n_I29 183.84e-18
Cext_25 n_10 n_I30 887.691e-18
Cext_26 n_10 n_I31 41.0193e-18
Cext_27 n_10 n_I32 40.7278e-18
Cext_28 n_10 n_I33 40.7278e-18
Cext_29 n_10 n_I34 40.7278e-18
Cext_30 n_10 n_I35 40.7278e-18
Cext_31 n_10 n_I36 40.7278e-18
Cext_32 n_10 n_I37 40.7278e-18
Cext_33 n_10 n_I38 40.7278e-18
Cext_34 n_10 n_I39 40.7278e-18
Cext_35 n_10 n_I4 589.018e-18
Cext_36 n_10 n_I40 888.145e-18
Cext_37 n_10 n_I41 888.145e-18
Cext_38 n_10 n_I42 186.129e-18
Cext_39 n_10 n_I43 181.274e-18
Cext_40 n_10 n_I5 376.586e-18
Cext_41 n_10 n_I6 17.9973f
Cext_42 n_10 n_I7 1.61002f
Cext_43 n_10 n_I8 29.8077f
Cext_44 n_10 n_I9 356.235e-18
Cext_45 n_10 dvbe 29.0809f
Cext_46 n_10 iptat 31.4822f
Cext_47 n_10 pbias 14.6563f
Cext_48 n_10 pcasc 2.12112f
Cext_49 n_10 r4 119.797e-18
Cext_50 n_10 vbe 373.259e-18
Cext_51 n_10 vdd 1.30919f
Cext_52 n_10 vref 263.625e-18
Cext_53 n_10 vss 36.448f
Cext_54 n_10 vss 19.1084f
Cext_55 n_16 n_17 23.3837f
Cext_56 n_16 n_18 2.6627f
Cext_57 n_16 n_20 183.243e-18
Cext_58 n_16 n_21 34.3118f
Cext_59 n_16 n_I10 132.418e-18
Cext_60 n_16 n_I11 22.8189f
Cext_61 n_16 n_I13 59.7112f
Cext_62 n_16 n_I14 882.731e-18
Cext_63 n_16 n_I18 756.834e-18
Cext_64 n_16 n_I19 36.3176e-18
Cext_65 n_16 n_I20 63.0695e-18
Cext_66 n_16 n_I21 63.0695e-18
Cext_67 n_16 n_I22 63.0695e-18
Cext_68 n_16 n_I23 1.00867f
Cext_69 n_16 n_I24 1.67735f
Cext_70 n_16 n_I25 63.0695e-18
Cext_71 n_16 n_I26 63.0695e-18
Cext_72 n_16 n_I27 63.0695e-18
Cext_73 n_16 n_I28 73.6882e-18
Cext_74 n_16 n_I29 335.5e-18
Cext_75 n_16 n_I30 756.834e-18
Cext_76 n_16 n_I31 78.7302e-18
Cext_77 n_16 n_I32 76.4959e-18
Cext_78 n_16 n_I33 76.4959e-18
Cext_79 n_16 n_I34 1.67479f
Cext_80 n_16 n_I35 1.67479f
Cext_81 n_16 n_I36 1.08734f
Cext_82 n_16 n_I37 1.67479f
Cext_83 n_16 n_I38 1.67479f
Cext_84 n_16 n_I39 684.986e-18
Cext_85 n_16 n_I4 555.833e-18
Cext_86 n_16 n_I40 756.834e-18
Cext_87 n_16 n_I41 756.834e-18
Cext_88 n_16 n_I42 154.587e-18
Cext_89 n_16 n_I43 401.457e-18
Cext_90 n_16 n_I5 141.065e-18
Cext_91 n_16 n_I6 117.974e-18
Cext_92 n_16 n_I7 42.9558f
Cext_93 n_16 n_I8 4.39943f
Cext_94 n_16 n_I9 388.444e-18
Cext_95 n_16 dvbe 2.72797f
Cext_96 n_16 iptat 103.63e-18
Cext_97 n_16 pbias 1.56674f
Cext_98 n_16 pcasc 120.187f
Cext_99 n_16 r4 96.2748e-18
Cext_100 n_16 vbe 115.042f
Cext_101 n_16 vdd 1.15736f
Cext_102 n_16 vref 3.75457f
Cext_103 n_16 vss 24.5836f
Cext_104 n_16 vss 269.168f
Cext_105 n_17 n_18 33.2823f
Cext_106 n_17 n_20 113.629e-18
Cext_107 n_17 n_21 150.216e-18
Cext_108 n_17 n_I12 168.775e-18
Cext_109 n_17 n_I13 759.002e-18
Cext_110 n_17 n_I14 874.26e-18
Cext_111 n_17 n_I18 756.834e-18
Cext_112 n_17 n_I19 36.3176e-18
Cext_113 n_17 n_I20 63.0695e-18
Cext_114 n_17 n_I21 63.0695e-18
Cext_115 n_17 n_I22 63.5377e-18
Cext_116 n_17 n_I23 758.889e-18
Cext_117 n_17 n_I24 1.67735f
Cext_118 n_17 n_I25 63.0695e-18
Cext_119 n_17 n_I26 63.0695e-18
Cext_120 n_17 n_I27 63.0695e-18
Cext_121 n_17 n_I28 807.834e-18
Cext_122 n_17 n_I29 126.139e-18
Cext_123 n_17 n_I30 1.18461f
Cext_124 n_17 n_I31 329.469e-18
Cext_125 n_17 n_I32 76.7874e-18
Cext_126 n_17 n_I33 76.4959e-18
Cext_127 n_17 n_I34 1.67479f
Cext_128 n_17 n_I35 3.74075f
Cext_129 n_17 n_I36 264.577e-18
Cext_130 n_17 n_I37 1.658f
Cext_131 n_17 n_I38 1.67479f
Cext_132 n_17 n_I39 2.35392f
Cext_133 n_17 n_I40 756.834e-18
Cext_134 n_17 n_I41 756.834e-18
Cext_135 n_17 n_I42 8.56556f
Cext_136 n_17 n_I43 143.472e-18
Cext_137 n_17 dvbe 5.73703f
Cext_138 n_17 pbias 839.254e-18
Cext_139 n_17 pcasc 813.368e-18
Cext_140 n_17 vbe 34.7419f
Cext_141 n_17 vref 185.762e-18
Cext_142 n_17 vss 35.2222f
Cext_143 n_17 vss 17.7974f
Cext_144 n_18 n_20 170.156e-18
Cext_145 n_18 n_21 284.29e-18
Cext_146 n_18 n_I12 22.8033f
Cext_147 n_18 n_I13 1.82203f
Cext_148 n_18 n_I14 54.721f
Cext_149 n_18 n_I18 756.834e-18
Cext_150 n_18 n_I19 36.3176e-18
Cext_151 n_18 n_I20 63.0695e-18
Cext_152 n_18 n_I21 63.0695e-18
Cext_153 n_18 n_I22 63.0695e-18
Cext_154 n_18 n_I23 1.15308f
Cext_155 n_18 n_I24 3.49155f
Cext_156 n_18 n_I25 63.0695e-18
Cext_157 n_18 n_I26 63.0695e-18
Cext_158 n_18 n_I27 63.0695e-18
Cext_159 n_18 n_I28 73.6882e-18
Cext_160 n_18 n_I29 126.139e-18
Cext_161 n_18 n_I30 1.48596f
Cext_162 n_18 n_I31 76.4959e-18
Cext_163 n_18 n_I32 76.4959e-18
Cext_164 n_18 n_I33 76.4959e-18
Cext_165 n_18 n_I34 1.67479f
Cext_166 n_18 n_I35 3.7996f
Cext_167 n_18 n_I36 281.365e-18
Cext_168 n_18 n_I37 2.35364f
Cext_169 n_18 n_I38 1.67479f
Cext_170 n_18 n_I39 279.131e-18
Cext_171 n_18 n_I40 756.834e-18
Cext_172 n_18 n_I41 756.834e-18
Cext_173 n_18 n_I42 130.196e-18
Cext_174 n_18 n_I43 143.434e-18
Cext_175 n_18 n_I8 21.2243e-18
Cext_176 n_18 dvbe 1.12938f
Cext_177 n_18 pbias 841.382e-18
Cext_178 n_18 pcasc 2.22576f
Cext_179 n_18 vbe 47.3715f
Cext_180 n_18 vref 23.5874f
Cext_181 n_18 vss 48.2669f
Cext_182 n_18 vss 52.5139f
Cext_183 n_20 n_21 61.0441f
Cext_184 n_20 n_I10 99.8272e-18
Cext_185 n_20 n_I11 284.902e-18
Cext_186 n_20 n_I12 26.2663f
Cext_187 n_20 n_I24 112.23e-18
Cext_188 n_20 n_I35 36.3207e-18
Cext_189 n_20 n_I38 97.6862e-18
Cext_190 n_20 n_I4 336.486e-18
Cext_191 n_20 n_I5 451.021e-18
Cext_192 n_20 n_I6 196.597e-18
Cext_193 n_20 n_I7 85.4314e-18
Cext_194 n_20 n_I8 117.964e-18
Cext_195 n_20 n_I9 2.40873f
Cext_196 n_20 dvbe 1.03498f
Cext_197 n_20 iptat 68.1341e-18
Cext_198 n_20 pbias 375.483e-18
Cext_199 n_20 pcasc 2.92748f
Cext_200 n_20 r4 452.651e-18
Cext_201 n_20 vbe 32.5727f
Cext_202 n_20 vdd 96.7085e-18
Cext_203 n_20 vref 102.619e-18
Cext_204 n_20 vss 21.8519f
Cext_205 n_20 vss 51.908f
Cext_206 n_21 n_I10 250.331e-18
Cext_207 n_21 n_I11 249.78e-18
Cext_208 n_21 n_I12 1.41576f
Cext_209 n_21 n_I35 0.625476e-18
Cext_210 n_21 n_I4 39.375f
Cext_211 n_21 n_I5 352.759e-18
Cext_212 n_21 n_I6 196.388e-18
Cext_213 n_21 n_I7 28.8289f
Cext_214 n_21 n_I8 1.30249f
Cext_215 n_21 n_I9 694.157e-18
Cext_216 n_21 dvbe 470.177f
Cext_217 n_21 iptat 193.988e-18
Cext_218 n_21 pbias 2.0122f
Cext_219 n_21 pcasc 21.4941f
Cext_220 n_21 r4 250.561e-18
Cext_221 n_21 vbe 51.3262f
Cext_222 n_21 vdd 1.54112f
Cext_223 n_21 vref 270.144e-18
Cext_224 n_21 vss 69.3008f
Cext_225 n_21 vss 199.399f
Cext_226 n_I10 n_I11 115.349e-18
Cext_227 n_I10 n_I4 68.0852e-18
Cext_228 n_I10 n_I5 99.4772e-18
Cext_229 n_I10 n_I6 86.3165e-18
Cext_230 n_I10 n_I7 23.7237f
Cext_231 n_I10 n_I8 71.7411e-18
Cext_232 n_I10 n_I9 185.06e-18
Cext_233 n_I10 iptat 31.1399f
Cext_234 n_I10 pbias 8.60406f
Cext_235 n_I10 pcasc 1.81713f
Cext_236 n_I10 r4 218.653e-18
Cext_237 n_I10 vbe 251.06e-18
Cext_238 n_I10 vdd 314.681e-18
Cext_239 n_I10 vref 156.598e-18
Cext_240 n_I10 vss 705.052e-18
Cext_241 n_I10 vss 5.66451f
Cext_242 n_I11 n_I4 75.9573e-18
Cext_243 n_I11 n_I5 73.1883e-18
Cext_244 n_I11 n_I6 67.557e-18
Cext_245 n_I11 n_I7 69.8449e-18
Cext_246 n_I11 n_I8 112.275e-18
Cext_247 n_I11 n_I9 146.47e-18
Cext_248 n_I11 iptat 31.5292e-18
Cext_249 n_I11 pbias 156.257e-18
Cext_250 n_I11 pcasc 280.672e-18
Cext_251 n_I11 r4 38.1925f
Cext_252 n_I11 vbe 9.40501f
Cext_253 n_I11 vdd 370.71e-18
Cext_254 n_I11 vref 122.297e-18
Cext_255 n_I11 vss 5.32712f
Cext_256 n_I11 vss 4.71029f
Cext_257 n_I12 n_I4 1.69452e-18
Cext_258 n_I12 n_I8 0.666798e-18
Cext_259 n_I12 dvbe 46.6986f
Cext_260 n_I12 pcasc 2.08803e-18
Cext_261 n_I12 vbe 28.7136f
Cext_262 n_I12 vss 159.209f
Cext_263 n_I12 vss 44.6981f
Cext_264 n_I13 n_I14 4.37523f
Cext_265 n_I13 n_I15 907.134e-18
Cext_266 n_I13 n_I16 916.42e-18
Cext_267 n_I13 n_I17 916.42e-18
Cext_268 n_I13 n_I18 1.63839f
Cext_269 n_I13 n_I19 952.738e-18
Cext_270 n_I13 n_I20 979.49e-18
Cext_271 n_I13 n_I21 979.49e-18
Cext_272 n_I13 n_I22 979.49e-18
Cext_273 n_I13 n_I23 2.45327f
Cext_274 n_I13 n_I24 121.512f
Cext_275 n_I13 n_I25 895.029e-18
Cext_276 n_I13 n_I26 895.029e-18
Cext_277 n_I13 n_I27 876.457e-18
Cext_278 n_I13 n_I28 897.865e-18
Cext_279 n_I13 n_I29 1.49644f
Cext_280 n_I13 n_I30 2.17157f
Cext_281 n_I13 n_I31 909.273e-18
Cext_282 n_I13 n_I32 908.456e-18
Cext_283 n_I13 n_I33 908.456e-18
Cext_284 n_I13 n_I34 3.00291f
Cext_285 n_I13 n_I35 2.50674f
Cext_286 n_I13 n_I36 1.76322f
Cext_287 n_I13 n_I37 3.27919f
Cext_288 n_I13 n_I38 2.51181f
Cext_289 n_I13 n_I39 1.37796f
Cext_290 n_I13 n_I40 1.90092f
Cext_291 n_I13 n_I41 24.8992f
Cext_292 n_I13 n_I42 1.02678f
Cext_293 n_I13 n_I43 24.2101f
Cext_294 n_I13 dvbe 3.56038f
Cext_295 n_I13 pbias 878.777e-18
Cext_296 n_I13 pcasc 1.18822f
Cext_297 n_I13 vref 1.02225f
Cext_298 n_I13 vss 10.0374f
Cext_299 n_I13 vss 51.2211f
Cext_300 n_I14 n_I15 899.378e-18
Cext_301 n_I14 n_I16 917.951e-18
Cext_302 n_I14 n_I17 917.951e-18
Cext_303 n_I14 n_I18 1.63063f
Cext_304 n_I14 n_I19 954.268e-18
Cext_305 n_I14 n_I20 981.02e-18
Cext_306 n_I14 n_I21 981.02e-18
Cext_307 n_I14 n_I22 981.02e-18
Cext_308 n_I14 n_I23 3.17924f
Cext_309 n_I14 n_I24 121.758f
Cext_310 n_I14 n_I25 895.029e-18
Cext_311 n_I14 n_I26 895.029e-18
Cext_312 n_I14 n_I27 885.743e-18
Cext_313 n_I14 n_I28 905.648e-18
Cext_314 n_I14 n_I29 958.099e-18
Cext_315 n_I14 n_I30 1.94139f
Cext_316 n_I14 n_I31 910.69e-18
Cext_317 n_I14 n_I32 908.456e-18
Cext_318 n_I14 n_I33 908.456e-18
Cext_319 n_I14 n_I34 3.88426f
Cext_320 n_I14 n_I35 2.48996f
Cext_321 n_I14 n_I36 1.11366f
Cext_322 n_I14 n_I37 3.09365f
Cext_323 n_I14 n_I38 2.50931f
Cext_324 n_I14 n_I39 1.09475f
Cext_325 n_I14 n_I40 2.5746f
Cext_326 n_I14 n_I41 1.77994f
Cext_327 n_I14 n_I42 23.9297f
Cext_328 n_I14 n_I43 998.622e-18
Cext_329 n_I14 dvbe 2.33846f
Cext_330 n_I14 pbias 25.321f
Cext_331 n_I14 pcasc 1.52785f
Cext_332 n_I14 vref 897.779e-18
Cext_333 n_I14 vss 9.73048f
Cext_334 n_I14 vss 52.7905f
Cext_335 n_I15 n_I16 356.004e-18
Cext_336 n_I15 n_I17 76.7874e-18
Cext_337 n_I15 n_I18 1.07817f
Cext_338 n_I15 n_I19 22.6321f
Cext_339 n_I15 n_I20 2.58187e-18
Cext_340 n_I15 n_I21 1.08906e-18
Cext_341 n_I15 n_I22 0.586568e-18
Cext_342 n_I15 n_I23 23.9061f
Cext_343 n_I15 n_I29 152.992e-18
Cext_344 n_I15 n_I30 925.647e-18
Cext_345 n_I15 n_I40 920.516e-18
Cext_346 n_I15 n_I41 901.944e-18
Cext_347 n_I15 n_I42 230.624e-18
Cext_348 n_I15 n_I43 155.557e-18
Cext_349 n_I15 dvbe 1.0614f
Cext_350 n_I15 vss 1.48707f
Cext_351 n_I15 vss 5.74844f
Cext_352 n_I16 n_I17 23.2068f
Cext_353 n_I16 n_I18 1.0745f
Cext_354 n_I16 n_I19 426.689e-18
Cext_355 n_I16 n_I20 162.118e-18
Cext_356 n_I16 n_I21 162.118e-18
Cext_357 n_I16 n_I22 22.4678f
Cext_358 n_I16 n_I23 1.0745f
Cext_359 n_I16 n_I24 32.0848e-18
Cext_360 n_I16 n_I28 0.543717e-18
Cext_361 n_I16 n_I29 154.705e-18
Cext_362 n_I16 n_I30 925.647e-18
Cext_363 n_I16 n_I40 920.516e-18
Cext_364 n_I16 n_I41 920.516e-18
Cext_365 n_I16 n_I42 178.048e-18
Cext_366 n_I16 n_I43 155.557e-18
Cext_367 n_I16 dvbe 1.10615f
Cext_368 n_I16 vss 1.37061f
Cext_369 n_I16 vss 6.1045f
Cext_370 n_I17 n_I18 1.0745f
Cext_371 n_I17 n_I19 120.668e-18
Cext_372 n_I17 n_I20 158.802e-18
Cext_373 n_I17 n_I21 158.802e-18
Cext_374 n_I17 n_I22 162.245e-18
Cext_375 n_I17 n_I23 1.0745f
Cext_376 n_I17 n_I24 22.9772f
Cext_377 n_I17 n_I28 1.0095e-18
Cext_378 n_I17 n_I29 157.053e-18
Cext_379 n_I17 n_I30 925.647e-18
Cext_380 n_I17 n_I33 0.500866e-18
Cext_381 n_I17 n_I40 920.516e-18
Cext_382 n_I17 n_I41 920.516e-18
Cext_383 n_I17 n_I42 155.557e-18
Cext_384 n_I17 n_I43 155.557e-18
Cext_385 n_I17 dvbe 1.10889f
Cext_386 n_I17 vss 1.36869f
Cext_387 n_I17 vss 6.07826f
Cext_388 n_I18 n_I19 1.04214f
Cext_389 n_I18 n_I20 1.00134f
Cext_390 n_I18 n_I21 998.209e-18
Cext_391 n_I18 n_I22 998e-18
Cext_392 n_I18 n_I23 26.3184f
Cext_393 n_I18 n_I24 998e-18
Cext_394 n_I18 n_I25 998e-18
Cext_395 n_I18 n_I26 998e-18
Cext_396 n_I18 n_I27 990.498e-18
Cext_397 n_I18 n_I28 998e-18
Cext_398 n_I18 n_I29 1.14623f
Cext_399 n_I18 n_I30 3.20723f
Cext_400 n_I18 n_I31 998e-18
Cext_401 n_I18 n_I32 998e-18
Cext_402 n_I18 n_I33 998e-18
Cext_403 n_I18 n_I34 983.612e-18
Cext_404 n_I18 n_I35 4.97877f
Cext_405 n_I18 n_I36 756.834e-18
Cext_406 n_I18 n_I37 88.0657f
Cext_407 n_I18 n_I38 85.7797f
Cext_408 n_I18 n_I39 756.834e-18
Cext_409 n_I18 n_I40 1.64622f
Cext_410 n_I18 n_I41 1.94923f
Cext_411 n_I18 n_I42 910.327e-18
Cext_412 n_I18 n_I43 905.066e-18
Cext_413 n_I18 dvbe 31.4486f
Cext_414 n_I18 pbias 756.834e-18
Cext_415 n_I18 pcasc 756.834e-18
Cext_416 n_I18 vref 897.779e-18
Cext_417 n_I18 vss 11.6782f
Cext_418 n_I18 vss 40.3082f
Cext_419 n_I19 n_I20 22.7363f
Cext_420 n_I19 n_I21 45.9118e-18
Cext_421 n_I19 n_I22 44.7376e-18
Cext_422 n_I19 n_I23 1.05022f
Cext_423 n_I19 n_I24 43.881e-18
Cext_424 n_I19 n_I25 6.88717f
Cext_425 n_I19 n_I26 36.3176e-18
Cext_426 n_I19 n_I27 36.3176e-18
Cext_427 n_I19 n_I28 43.881e-18
Cext_428 n_I19 n_I29 196.873e-18
Cext_429 n_I19 n_I30 961.964e-18
Cext_430 n_I19 n_I31 43.881e-18
Cext_431 n_I19 n_I32 36.3176e-18
Cext_432 n_I19 n_I33 43.881e-18
Cext_433 n_I19 n_I34 36.3176e-18
Cext_434 n_I19 n_I35 36.3176e-18
Cext_435 n_I19 n_I36 36.3176e-18
Cext_436 n_I19 n_I37 36.3176e-18
Cext_437 n_I19 n_I38 36.3176e-18
Cext_438 n_I19 n_I39 36.3176e-18
Cext_439 n_I19 n_I40 956.834e-18
Cext_440 n_I19 n_I41 956.834e-18
Cext_441 n_I19 n_I42 199.179e-18
Cext_442 n_I19 n_I43 191.875e-18
Cext_443 n_I19 dvbe 1.13625f
Cext_444 n_I19 pbias 36.3176e-18
Cext_445 n_I19 pcasc 36.3176e-18
Cext_446 n_I19 vref 42.1903e-18
Cext_447 n_I19 vss 958.024e-18
Cext_448 n_I19 vss 7.00266f
Cext_449 n_I20 n_I21 22.8021f
Cext_450 n_I20 n_I22 83.7854e-18
Cext_451 n_I20 n_I23 1.0042f
Cext_452 n_I20 n_I24 84.8092e-18
Cext_453 n_I20 n_I25 11.0723f
Cext_454 n_I20 n_I26 6.58863f
Cext_455 n_I20 n_I27 63.0695e-18
Cext_456 n_I20 n_I28 82.3059e-18
Cext_457 n_I20 n_I29 235.298e-18
Cext_458 n_I20 n_I30 988.716e-18
Cext_459 n_I20 n_I31 82.3059e-18
Cext_460 n_I20 n_I32 70.633e-18
Cext_461 n_I20 n_I33 82.3059e-18
Cext_462 n_I20 n_I34 63.0695e-18
Cext_463 n_I20 n_I35 63.0695e-18
Cext_464 n_I20 n_I36 63.0695e-18
Cext_465 n_I20 n_I37 63.0695e-18
Cext_466 n_I20 n_I38 63.0695e-18
Cext_467 n_I20 n_I39 63.0695e-18
Cext_468 n_I20 n_I40 983.586e-18
Cext_469 n_I20 n_I41 983.586e-18
Cext_470 n_I20 n_I42 218.56e-18
Cext_471 n_I20 n_I43 218.627e-18
Cext_472 n_I20 dvbe 1.34748f
Cext_473 n_I20 pbias 63.0695e-18
Cext_474 n_I20 pcasc 63.0695e-18
Cext_475 n_I20 vref 74.815e-18
Cext_476 n_I20 vss 430.763e-18
Cext_477 n_I20 vss 6.0304f
Cext_478 n_I21 n_I22 22.8021f
Cext_479 n_I21 n_I23 1.00134f
Cext_480 n_I21 n_I24 89.3447e-18
Cext_481 n_I21 n_I25 82.6376e-18
Cext_482 n_I21 n_I26 10.5491f
Cext_483 n_I21 n_I27 6.42572f
Cext_484 n_I21 n_I28 82.3059e-18
Cext_485 n_I21 n_I29 235.715e-18
Cext_486 n_I21 n_I30 988.716e-18
Cext_487 n_I21 n_I31 82.3059e-18
Cext_488 n_I21 n_I32 82.3059e-18
Cext_489 n_I21 n_I33 82.3059e-18
Cext_490 n_I21 n_I34 63.0695e-18
Cext_491 n_I21 n_I35 63.0695e-18
Cext_492 n_I21 n_I36 63.0695e-18
Cext_493 n_I21 n_I37 63.0695e-18
Cext_494 n_I21 n_I38 63.0695e-18
Cext_495 n_I21 n_I39 63.0695e-18
Cext_496 n_I21 n_I40 983.586e-18
Cext_497 n_I21 n_I41 983.586e-18
Cext_498 n_I21 n_I42 218.56e-18
Cext_499 n_I21 n_I43 218.627e-18
Cext_500 n_I21 dvbe 1.34872f
Cext_501 n_I21 pbias 63.0695e-18
Cext_502 n_I21 pcasc 63.0695e-18
Cext_503 n_I21 vref 74.815e-18
Cext_504 n_I21 vss 410.671e-18
Cext_505 n_I21 vss 6.02291f
Cext_506 n_I22 n_I23 998.209e-18
Cext_507 n_I22 n_I24 98.8178e-18
Cext_508 n_I22 n_I25 74.7424e-18
Cext_509 n_I22 n_I26 75.0741e-18
Cext_510 n_I22 n_I27 10.28f
Cext_511 n_I22 n_I28 7.41498f
Cext_512 n_I22 n_I29 239.413e-18
Cext_513 n_I22 n_I30 988.716e-18
Cext_514 n_I22 n_I31 74.7424e-18
Cext_515 n_I22 n_I32 74.7424e-18
Cext_516 n_I22 n_I33 74.7424e-18
Cext_517 n_I22 n_I34 63.0695e-18
Cext_518 n_I22 n_I35 63.0695e-18
Cext_519 n_I22 n_I36 63.0695e-18
Cext_520 n_I22 n_I37 63.0695e-18
Cext_521 n_I22 n_I38 63.0695e-18
Cext_522 n_I22 n_I39 63.0695e-18
Cext_523 n_I22 n_I40 983.586e-18
Cext_524 n_I22 n_I41 983.586e-18
Cext_525 n_I22 n_I42 219.649e-18
Cext_526 n_I22 n_I43 218.627e-18
Cext_527 n_I22 dvbe 1.33323f
Cext_528 n_I22 pbias 63.0695e-18
Cext_529 n_I22 pcasc 63.0695e-18
Cext_530 n_I22 vref 74.815e-18
Cext_531 n_I22 vss 406.711e-18
Cext_532 n_I22 vss 6.08636f
Cext_533 n_I23 n_I24 998e-18
Cext_534 n_I23 n_I25 997.556e-18
Cext_535 n_I23 n_I26 997.556e-18
Cext_536 n_I23 n_I27 997.556e-18
Cext_537 n_I23 n_I28 997.556e-18
Cext_538 n_I23 n_I29 1.26969f
Cext_539 n_I23 n_I30 2.68822f
Cext_540 n_I23 n_I31 997.556e-18
Cext_541 n_I23 n_I32 997.556e-18
Cext_542 n_I23 n_I33 997.556e-18
Cext_543 n_I23 n_I34 994.112e-18
Cext_544 n_I23 n_I35 1.70486f
Cext_545 n_I23 n_I36 926.845e-18
Cext_546 n_I23 n_I37 1.43424f
Cext_547 n_I23 n_I38 86.4594f
Cext_548 n_I23 n_I39 875.082e-18
Cext_549 n_I23 n_I40 2.12563f
Cext_550 n_I23 n_I41 3.06162f
Cext_551 n_I23 n_I42 1.01193f
Cext_552 n_I23 n_I43 1.51795f
Cext_553 n_I23 dvbe 2.39173f
Cext_554 n_I23 pbias 857.787e-18
Cext_555 n_I23 pcasc 59.7112f
Cext_556 n_I23 vref 1.86547f
Cext_557 n_I23 vss 11.6606f
Cext_558 n_I23 vss 41.5257f
Cext_559 n_I24 n_I25 1.74073f
Cext_560 n_I24 n_I26 1.74053f
Cext_561 n_I24 n_I27 1.74053f
Cext_562 n_I24 n_I28 1.74182f
Cext_563 n_I24 n_I29 24.7336f
Cext_564 n_I24 n_I30 4.08802f
Cext_565 n_I24 n_I31 1.74078f
Cext_566 n_I24 n_I32 1.74053f
Cext_567 n_I24 n_I33 1.74099f
Cext_568 n_I24 n_I34 6.97433f
Cext_569 n_I24 n_I35 1.6398f
Cext_570 n_I24 n_I36 1.74053f
Cext_571 n_I24 n_I37 4.21901f
Cext_572 n_I24 n_I38 1.70695f
Cext_573 n_I24 n_I39 1.74053f
Cext_574 n_I24 n_I40 5.84557f
Cext_575 n_I24 n_I41 3.46693f
Cext_576 n_I24 n_I42 1.86769f
Cext_577 n_I24 n_I43 1.86769f
Cext_578 n_I24 dvbe 939.7e-18
Cext_579 n_I24 pbias 3.50069f
Cext_580 n_I24 pcasc 1.67735f
Cext_581 n_I24 vref 1.99126f
Cext_582 n_I24 vss 545.197e-18
Cext_583 n_I24 vss 73.8631f
Cext_584 n_I25 n_I26 1.66396f
Cext_585 n_I25 n_I27 63.6936e-18
Cext_586 n_I25 n_I28 75.9047e-18
Cext_587 n_I25 n_I29 177.888e-18
Cext_588 n_I25 n_I30 992.694e-18
Cext_589 n_I25 n_I31 22.3906f
Cext_590 n_I25 n_I32 22.3738f
Cext_591 n_I25 n_I33 80.2097e-18
Cext_592 n_I25 n_I34 65.5729e-18
Cext_593 n_I25 n_I35 63.0695e-18
Cext_594 n_I25 n_I36 63.0695e-18
Cext_595 n_I25 n_I37 63.0695e-18
Cext_596 n_I25 n_I38 63.0695e-18
Cext_597 n_I25 n_I39 63.0695e-18
Cext_598 n_I25 n_I40 982.055e-18
Cext_599 n_I25 n_I41 983.586e-18
Cext_600 n_I25 n_I42 219.113e-18
Cext_601 n_I25 n_I43 225.329e-18
Cext_602 n_I25 dvbe 1.32019f
Cext_603 n_I25 pbias 63.0695e-18
Cext_604 n_I25 pcasc 63.0695e-18
Cext_605 n_I25 vref 74.815e-18
Cext_606 n_I25 vss 531.605e-18
Cext_607 n_I25 vss 8.51218f
Cext_608 n_I26 n_I27 23.9745f
Cext_609 n_I26 n_I28 75.4892e-18
Cext_610 n_I26 n_I29 177.051e-18
Cext_611 n_I26 n_I30 1.00647f
Cext_612 n_I26 n_I31 77.9374e-18
Cext_613 n_I26 n_I32 22.3876f
Cext_614 n_I26 n_I33 76.832e-18
Cext_615 n_I26 n_I34 76.1383e-18
Cext_616 n_I26 n_I35 70.1083e-18
Cext_617 n_I26 n_I36 63.0695e-18
Cext_618 n_I26 n_I37 65.5729e-18
Cext_619 n_I26 n_I38 63.0695e-18
Cext_620 n_I26 n_I39 63.0695e-18
Cext_621 n_I26 n_I40 982.055e-18
Cext_622 n_I26 n_I41 983.586e-18
Cext_623 n_I26 n_I42 219.113e-18
Cext_624 n_I26 n_I43 225.329e-18
Cext_625 n_I26 dvbe 1.30129f
Cext_626 n_I26 pbias 63.0695e-18
Cext_627 n_I26 pcasc 63.0695e-18
Cext_628 n_I26 vref 74.815e-18
Cext_629 n_I26 vss 430.691e-18
Cext_630 n_I26 vss 7.46921f
Cext_631 n_I27 n_I28 1.67446f
Cext_632 n_I27 n_I29 177.051e-18
Cext_633 n_I27 n_I30 23.7606f
Cext_634 n_I27 n_I31 77.6495e-18
Cext_635 n_I27 n_I32 77.9755e-18
Cext_636 n_I27 n_I33 76.7045e-18
Cext_637 n_I27 n_I34 94.052e-18
Cext_638 n_I27 n_I35 76.1383e-18
Cext_639 n_I27 n_I36 63.0695e-18
Cext_640 n_I27 n_I37 70.1083e-18
Cext_641 n_I27 n_I38 65.5729e-18
Cext_642 n_I27 n_I39 63.0695e-18
Cext_643 n_I27 n_I40 982.055e-18
Cext_644 n_I27 n_I41 983.586e-18
Cext_645 n_I27 n_I42 219.33e-18
Cext_646 n_I27 n_I43 225.329e-18
Cext_647 n_I27 dvbe 1.29356f
Cext_648 n_I27 pbias 63.0695e-18
Cext_649 n_I27 pcasc 63.0695e-18
Cext_650 n_I27 vref 74.815e-18
Cext_651 n_I27 vss 419.794e-18
Cext_652 n_I27 vss 7.45682f
Cext_653 n_I28 n_I29 22.5648f
Cext_654 n_I28 n_I30 1.00093f
Cext_655 n_I28 n_I31 898.526e-18
Cext_656 n_I28 n_I32 75.531e-18
Cext_657 n_I28 n_I33 22.3993f
Cext_658 n_I28 n_I34 75.2806e-18
Cext_659 n_I28 n_I35 75.2806e-18
Cext_660 n_I28 n_I36 75.2806e-18
Cext_661 n_I28 n_I37 75.2806e-18
Cext_662 n_I28 n_I38 75.2806e-18
Cext_663 n_I28 n_I39 109.392e-18
Cext_664 n_I28 n_I40 994.177e-18
Cext_665 n_I28 n_I41 995.708e-18
Cext_666 n_I28 n_I42 654.542e-18
Cext_667 n_I28 n_I43 237.451e-18
Cext_668 n_I28 dvbe 1.43627f
Cext_669 n_I28 pbias 73.6882e-18
Cext_670 n_I28 pcasc 73.6882e-18
Cext_671 n_I28 vref 86.7888e-18
Cext_672 n_I28 vss 536.195e-18
Cext_673 n_I28 vss 8.33852f
Cext_674 n_I29 n_I30 1.1027f
Cext_675 n_I29 n_I31 178.446e-18
Cext_676 n_I29 n_I32 177.051e-18
Cext_677 n_I29 n_I33 180.358e-18
Cext_678 n_I29 n_I34 177.051e-18
Cext_679 n_I29 n_I35 177.051e-18
Cext_680 n_I29 n_I36 13.2769f
Cext_681 n_I29 n_I37 177.051e-18
Cext_682 n_I29 n_I38 177.051e-18
Cext_683 n_I29 n_I39 12.8057f
Cext_684 n_I29 n_I40 1.04512f
Cext_685 n_I29 n_I41 1.03915f
Cext_686 n_I29 n_I42 910.356e-18
Cext_687 n_I29 n_I43 2.15886f
Cext_688 n_I29 dvbe 1.25778f
Cext_689 n_I29 pbias 126.139e-18
Cext_690 n_I29 pcasc 126.139e-18
Cext_691 n_I29 vref 150.169e-18
Cext_692 n_I29 vss 2.86823f
Cext_693 n_I29 vss 11.886f
Cext_694 n_I30 n_I31 1.00536f
Cext_695 n_I30 n_I32 1.00963f
Cext_696 n_I30 n_I33 1.00214f
Cext_697 n_I30 n_I34 24.4679f
Cext_698 n_I30 n_I35 90.4855f
Cext_699 n_I30 n_I36 759.306e-18
Cext_700 n_I30 n_I37 88.9141f
Cext_701 n_I30 n_I38 1.17563f
Cext_702 n_I30 n_I39 758.889e-18
Cext_703 n_I30 n_I40 2.47051f
Cext_704 n_I30 n_I41 1.6644f
Cext_705 n_I30 n_I42 907.43e-18
Cext_706 n_I30 n_I43 906.145e-18
Cext_707 n_I30 dvbe 8.26488f
Cext_708 n_I30 pbias 751.387e-18
Cext_709 n_I30 pcasc 1.92015f
Cext_710 n_I30 vref 897.779e-18
Cext_711 n_I30 vss 11.6252f
Cext_712 n_I30 vss 50.1686f
Cext_713 n_I31 n_I32 848.253e-18
Cext_714 n_I31 n_I33 23.2262f
Cext_715 n_I31 n_I34 77.3133e-18
Cext_716 n_I31 n_I35 77.3133e-18
Cext_717 n_I31 n_I36 77.3133e-18
Cext_718 n_I31 n_I37 77.3133e-18
Cext_719 n_I31 n_I38 77.3133e-18
Cext_720 n_I31 n_I39 109.078e-18
Cext_721 n_I31 n_I40 996.299e-18
Cext_722 n_I31 n_I41 997.829e-18
Cext_723 n_I31 n_I42 553.376e-18
Cext_724 n_I31 n_I43 239.573e-18
Cext_725 n_I31 dvbe 1.34424f
Cext_726 n_I31 pbias 78.7302e-18
Cext_727 n_I31 pcasc 78.7302e-18
Cext_728 n_I31 vref 90.9517e-18
Cext_729 n_I31 vss 635.237e-18
Cext_730 n_I31 vss 7.22834f
Cext_731 n_I32 n_I33 847.09e-18
Cext_732 n_I32 n_I34 83.5347e-18
Cext_733 n_I32 n_I35 78.9993e-18
Cext_734 n_I32 n_I36 76.4959e-18
Cext_735 n_I32 n_I37 76.4959e-18
Cext_736 n_I32 n_I38 76.4959e-18
Cext_737 n_I32 n_I39 76.4959e-18
Cext_738 n_I32 n_I40 995.481e-18
Cext_739 n_I32 n_I41 997.012e-18
Cext_740 n_I32 n_I42 232.974e-18
Cext_741 n_I32 n_I43 238.756e-18
Cext_742 n_I32 dvbe 1.29588f
Cext_743 n_I32 pbias 76.4959e-18
Cext_744 n_I32 pcasc 76.4959e-18
Cext_745 n_I32 vref 90.9517e-18
Cext_746 n_I32 vss 615.182e-18
Cext_747 n_I32 vss 6.87247f
Cext_748 n_I33 n_I34 76.4959e-18
Cext_749 n_I33 n_I35 76.4959e-18
Cext_750 n_I33 n_I36 76.4959e-18
Cext_751 n_I33 n_I37 76.4959e-18
Cext_752 n_I33 n_I38 76.4959e-18
Cext_753 n_I33 n_I39 76.4959e-18
Cext_754 n_I33 n_I40 995.481e-18
Cext_755 n_I33 n_I41 997.012e-18
Cext_756 n_I33 n_I42 239.488e-18
Cext_757 n_I33 n_I43 238.756e-18
Cext_758 n_I33 dvbe 1.33179f
Cext_759 n_I33 pbias 76.4959e-18
Cext_760 n_I33 pcasc 76.4959e-18
Cext_761 n_I33 vref 90.9517e-18
Cext_762 n_I33 vss 636.503e-18
Cext_763 n_I33 vss 7.16311f
Cext_764 n_I34 n_I35 27.3748f
Cext_765 n_I34 n_I36 1.73634f
Cext_766 n_I34 n_I37 4.16047f
Cext_767 n_I34 n_I38 1.74824f
Cext_768 n_I34 n_I39 1.73559f
Cext_769 n_I34 n_I40 96.5499f
Cext_770 n_I34 n_I41 97.5365f
Cext_771 n_I34 n_I42 1.83083f
Cext_772 n_I34 n_I43 1.83704f
Cext_773 n_I34 dvbe 920.459e-18
Cext_774 n_I34 pbias 3.39912f
Cext_775 n_I34 pcasc 1.64121f
Cext_776 n_I34 vref 1.9934f
Cext_777 n_I34 vss 586.256e-18
Cext_778 n_I34 vss 68.2831f
Cext_779 n_I35 n_I36 1.65397f
Cext_780 n_I35 n_I37 29.2921f
Cext_781 n_I35 n_I38 7.57095f
Cext_782 n_I35 n_I39 1.70333f
Cext_783 n_I35 n_I40 3.22328f
Cext_784 n_I35 n_I41 92.5274f
Cext_785 n_I35 n_I42 1.83083f
Cext_786 n_I35 n_I43 1.83704f
Cext_787 n_I35 dvbe 15.7345f
Cext_788 n_I35 pbias 2.53677f
Cext_789 n_I35 pcasc 1.658f
Cext_790 n_I35 vref 1.9933f
Cext_791 n_I35 vss 586.144e-18
Cext_792 n_I35 vss 68.4592f
Cext_793 n_I36 n_I37 1.6454f
Cext_794 n_I36 n_I38 24.4558f
Cext_795 n_I36 n_I39 25.2127f
Cext_796 n_I36 n_I40 1.13668f
Cext_797 n_I36 n_I41 1.04114f
Cext_798 n_I36 n_I42 446.21e-18
Cext_799 n_I36 n_I43 13.8142f
Cext_800 n_I36 dvbe 900.272e-18
Cext_801 n_I36 pbias 281.696e-18
Cext_802 n_I36 pcasc 295.12e-18
Cext_803 n_I36 vref 2.36258f
Cext_804 n_I36 vss 474.055e-18
Cext_805 n_I36 vss 15.0682f
Cext_806 n_I37 n_I38 28.8378f
Cext_807 n_I37 n_I39 1.68005f
Cext_808 n_I37 n_I40 4.02323f
Cext_809 n_I37 n_I41 2.67691f
Cext_810 n_I37 n_I42 1.83339f
Cext_811 n_I37 n_I43 1.83961f
Cext_812 n_I37 dvbe 919.322e-18
Cext_813 n_I37 pbias 1.67735f
Cext_814 n_I37 pcasc 3.65791f
Cext_815 n_I37 vref 1.97662f
Cext_816 n_I37 vss 586.256e-18
Cext_817 n_I37 vss 68.5293f
Cext_818 n_I38 n_I39 1.68626f
Cext_819 n_I38 n_I40 4.09651f
Cext_820 n_I38 n_I41 3.21711f
Cext_821 n_I38 n_I42 1.83339f
Cext_822 n_I38 n_I43 1.83961f
Cext_823 n_I38 dvbe 1.05952f
Cext_824 n_I38 pbias 3.68407f
Cext_825 n_I38 pcasc 1.67479f
Cext_826 n_I38 vref 1.9934f
Cext_827 n_I38 vss 586.256e-18
Cext_828 n_I38 vss 67.2269f
Cext_829 n_I39 n_I40 23.9631f
Cext_830 n_I39 n_I41 1.02876f
Cext_831 n_I39 n_I42 12.3043f
Cext_832 n_I39 n_I43 1.7025f
Cext_833 n_I39 dvbe 1.54071f
Cext_834 n_I39 pbias 281.365e-18
Cext_835 n_I39 pcasc 272.971e-18
Cext_836 n_I39 vref 331.7e-18
Cext_837 n_I39 vss 681.339e-18
Cext_838 n_I39 vss 14.7305f
Cext_839 n_I4 n_I5 6.02637f
Cext_840 n_I4 n_I6 519.889e-18
Cext_841 n_I4 n_I7 10.1287f
Cext_842 n_I4 n_I8 4.99222f
Cext_843 n_I4 n_I9 51.2247f
Cext_844 n_I4 iptat 38.4802e-18
Cext_845 n_I4 pbias 36.0039f
Cext_846 n_I4 pcasc 24.845f
Cext_847 n_I4 r4 75.7629e-18
Cext_848 n_I4 vbe 1.4346f
Cext_849 n_I4 vdd 12.6016f
Cext_850 n_I4 vref 227.945e-18
Cext_851 n_I4 vss 2.60791f
Cext_852 n_I4 vss 74.7205f
Cext_853 n_I40 n_I41 26.5711f
Cext_854 n_I40 n_I42 997.915e-18
Cext_855 n_I40 n_I43 1.01266f
Cext_856 n_I40 dvbe 2.32266f
Cext_857 n_I40 pbias 62.1972f
Cext_858 n_I40 pcasc 756.834e-18
Cext_859 n_I40 vref 897.779e-18
Cext_860 n_I40 vss 11.6445f
Cext_861 n_I40 vss 52.6032f
Cext_862 n_I41 n_I42 894.107e-18
Cext_863 n_I41 n_I43 908.124e-18
Cext_864 n_I41 dvbe 2.33106f
Cext_865 n_I41 pbias 1.55798f
Cext_866 n_I41 pcasc 756.834e-18
Cext_867 n_I41 vref 897.779e-18
Cext_868 n_I41 vss 11.6252f
Cext_869 n_I41 vss 51.5676f
Cext_870 n_I42 n_I43 22.8035f
Cext_871 n_I42 dvbe 1.8513f
Cext_872 n_I42 pbias 166.977e-18
Cext_873 n_I42 pcasc 156.745e-18
Cext_874 n_I42 vref 153.535e-18
Cext_875 n_I42 vss 3.68044f
Cext_876 n_I42 vss 13.9312f
Cext_877 n_I43 dvbe 1.14918f
Cext_878 n_I43 pbias 150.785e-18
Cext_879 n_I43 pcasc 150.537e-18
Cext_880 n_I43 vref 6.85524f
Cext_881 n_I43 vss 2.86816f
Cext_882 n_I43 vss 14.254f
Cext_883 n_I5 n_I6 44.9442f
Cext_884 n_I5 n_I7 191.913e-18
Cext_885 n_I5 n_I8 625.99e-18
Cext_886 n_I5 n_I9 38.0482f
Cext_887 n_I5 iptat 62.4707e-18
Cext_888 n_I5 pbias 7.86205f
Cext_889 n_I5 pcasc 5.04344f
Cext_890 n_I5 r4 84.042e-18
Cext_891 n_I5 vbe 410.181e-18
Cext_892 n_I5 vdd 1.45875f
Cext_893 n_I5 vref 721.324e-18
Cext_894 n_I5 vss 176.767e-18
Cext_895 n_I5 vss 12.8838f
Cext_896 n_I6 n_I7 170.297e-18
Cext_897 n_I6 n_I8 29.9089f
Cext_898 n_I6 n_I9 317.637e-18
Cext_899 n_I6 iptat 119.263e-18
Cext_900 n_I6 pbias 2.63422f
Cext_901 n_I6 pcasc 2.41978f
Cext_902 n_I6 r4 79.7739e-18
Cext_903 n_I6 vbe 352.61e-18
Cext_904 n_I6 vdd 598.481e-18
Cext_905 n_I6 vref 258.773e-18
Cext_906 n_I6 vss 167.889e-18
Cext_907 n_I6 vss 5.7494f
Cext_908 n_I7 n_I8 4.99287f
Cext_909 n_I7 n_I9 4.00492f
Cext_910 n_I7 iptat 69.3888e-18
Cext_911 n_I7 pbias 45.2201f
Cext_912 n_I7 pcasc 64.7787f
Cext_913 n_I7 r4 70.5561e-18
Cext_914 n_I7 vbe 18.5273f
Cext_915 n_I7 vdd 3.16565f
Cext_916 n_I7 vref 216.96e-18
Cext_917 n_I7 vss 22.5627f
Cext_918 n_I7 vss 61.8186f
Cext_919 n_I8 n_I9 15.5283f
Cext_920 n_I8 iptat 55.1027e-18
Cext_921 n_I8 pbias 64.812f
Cext_922 n_I8 pcasc 26.5997f
Cext_923 n_I8 r4 71.994e-18
Cext_924 n_I8 vbe 1.27748f
Cext_925 n_I8 vdd 8.51386f
Cext_926 n_I8 vref 124.446e-18
Cext_927 n_I8 vss 389.485e-18
Cext_928 n_I8 vss 62.3613f
Cext_929 n_I9 iptat 141.225e-18
Cext_930 n_I9 pbias 55.3858f
Cext_931 n_I9 pcasc 19.6426f
Cext_932 n_I9 r4 150.757e-18
Cext_933 n_I9 vbe 842.81e-18
Cext_934 n_I9 vdd 9.93236f
Cext_935 n_I9 vref 276.79e-18
Cext_936 n_I9 vss 440.8e-18
Cext_937 n_I9 vss 68.5252f
Cext_938 dvbe pbias 912.084e-18
Cext_939 dvbe pcasc 912.084e-18
Cext_940 dvbe vbe 85.0231f
Cext_941 dvbe vref 1.11098f
Cext_942 dvbe vss 274.961f
Cext_943 iptat pbias 471.052e-18
Cext_944 iptat pcasc 1.81613f
Cext_945 iptat r4 32.7308e-18
Cext_946 iptat vbe 249.177e-18
Cext_947 iptat vdd 87.9917e-18
Cext_948 iptat vref 138.346e-18
Cext_949 iptat vss 75.6564e-18
Cext_950 pbias pcasc 102.754f
Cext_951 pbias r4 4.67987f
Cext_952 pbias vbe 842.094e-18
Cext_953 pbias vdd 200.088f
Cext_954 pbias vref 1.22851f
Cext_955 pbias vss 2.54694f
Cext_956 pcasc r4 31.003f
Cext_957 pcasc vbe 9.1441f
Cext_958 pcasc vdd 5.83032f
Cext_959 pcasc vref 10.7316f
Cext_960 pcasc vss 20.0683f
Cext_961 r4 vbe 1.38345f
Cext_962 r4 vdd 955.579e-18
Cext_963 r4 vref 120.97e-18
Cext_964 r4 vss 686.327e-18
Cext_965 vbe vdd 69.5003f
Cext_966 vbe vref 855.992e-18
Cext_967 vbe vss 299.981f
Cext_968 vdd vref 38.1519f
Cext_969 vdd vss 7.82197f
Cext_970 vref vss 40.574f
Cext_971 vss dvbe 179.558f
Cext_972 vss iptat 2.58552f
Cext_973 vss pbias 530.267f
Cext_974 vss pcasc 488.212f
Cext_975 vss r4 6.23488f
Cext_976 vss vbe 246.478f
Cext_977 vss vdd 164.146f
Cext_978 vss vref 25.9315f
Vprobe gate_probe pbias dc 0 ac {pv}
Iprobe vss gate_probe dc 0 ac {pi}
.ends g1_bgr
