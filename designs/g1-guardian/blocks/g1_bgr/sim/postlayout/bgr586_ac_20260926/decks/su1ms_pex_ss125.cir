* BGR 1 ms start-up (3.3 V), su1ms_pex_ss125
.lib /foss/pdks/ihp-sg13g2/libs.tech/ngspice/models/cornerHBT.lib hbt_wcs
.lib /foss/pdks/ihp-sg13g2/libs.tech/ngspice/models/cornerMOShv.lib mos_ss
.lib /foss/pdks/ihp-sg13g2/libs.tech/ngspice/models/cornerRES.lib res_wcs
.include ../../g1_bgr586_pex.spice
.option gmin=1e-15 abstol=1e-14 reltol=1e-5 vntol=1e-7
.temp 125
.global sub!
Vsub sub! 0 0
Vdd vdd 0 3.3
Vr4 r4 0 0
Xbgr vdd 0 r4 vref iptat pbias pcasc vbe dvbe g1_bgr
Vload iptat 0 1
Cload vref 0 1p
.control
set num_threads=1
set numdgt=15
set wr_singlescale
set wr_vecnames
alter @vdd[pwl] = [ 0 0 0.001 3.3 0.003 3.3 ]
tran 2e-06 0.003 uic
wrdata ${BULK}/bgr586_ac_20260926/su1ms_pex_ss125.dat v(vref) i(vload) i(vdd) v(pbias) v(pcasc)
op
echo DCREF
print v(vref) i(vload) i(vdd)
echo RUN_END
quit
.endc
.end
