* BGR local stability diagnostic (Tian two-injection), tian_pex_pcasc_ss125_current
.lib /foss/pdks/ihp-sg13g2/libs.tech/ngspice/models/cornerHBT.lib hbt_wcs
.lib /foss/pdks/ihp-sg13g2/libs.tech/ngspice/models/cornerMOShv.lib mos_ss
.lib /foss/pdks/ihp-sg13g2/libs.tech/ngspice/models/cornerRES.lib res_wcs
.include probe_pex_pcasc.spice
.option gmin=1e-15 abstol=1e-14 reltol=1e-5 vntol=1e-7
.temp 125
.global sub!
Vsub sub! 0 0
Vdd vdd 0 3.3
Vr4 r4 0 0
Xbgr vdd 0 r4 vref iptat pbias pcasc vbe dvbe g1_bgr
Vload iptat 0 1
Cload vref 0 1p
.param pv=0 pi=1
* nodeset from opdump_pex_ss125 (unmodified PEX op, same corner); numerical aid only
.nodeset v(dvbe)=7.409527689996212e-02
.nodeset v(pbias)=2.271970455761674e+00
.nodeset v(pcasc)=1.555375343256327e+00
.nodeset v(vbe)=5.887667673715881e-01
.nodeset v(vref)=1.048557158428876e+00
.nodeset v(xbgr.n_10)=3.256732624355710e+00
.nodeset v(xbgr.n_16)=1.453061936665165e+00
.nodeset v(xbgr.n_17)=5.889164332064276e-01
.nodeset v(xbgr.n_18)=1.177832100855764e+00
.nodeset v(xbgr.n_20)=1.565744662255518e-07
.nodeset v(xbgr.n_21)=6.603171023882954e-01
.nodeset v(xbgr.n_i4)=2.583736337205101e+00
.nodeset v(xbgr.n_i5)=2.583957288651253e+00
.nodeset v(xbgr.n_i6)=2.583929191995316e+00
.nodeset v(xbgr.n_i7)=6.174074036014865e-01
.nodeset v(xbgr.n_i8)=2.584240166852807e+00
.nodeset v(xbgr.n_i9)=2.589354665209175e+00
.nodeset v(xbgr.n_i10)=1.777399301810455e-07
.nodeset v(xbgr.n_i11)=3.299999973066445e+00
.nodeset v(xbgr.n_i12)=5.889157332997719e-01
.nodeset v(xbgr.n_i13)=1.384254455313614e+00
.nodeset v(xbgr.n_i14)=1.246639537407924e+00
.nodeset v(xbgr.n_i15)=3.039616072987752e+00
.nodeset v(xbgr.n_i16)=8.684587525728650e-01
.nodeset v(xbgr.n_i17)=4.342290777738194e-01
.nodeset v(xbgr.n_i18)=1.770353707006126e+00
.nodeset v(xbgr.n_i19)=2.605383416901466e+00
.nodeset v(xbgr.n_i20)=2.171151356561389e+00
.nodeset v(xbgr.n_i21)=1.736919892222257e+00
.nodeset v(xbgr.n_i22)=1.302689024141094e+00
.nodeset v(xbgr.n_i23)=1.627034781645731e+00
.nodeset v(xbgr.n_i24)=1.315446988894247e+00
.nodeset v(xbgr.n_i25)=2.388267312246922e+00
.nodeset v(xbgr.n_i26)=1.954035549875607e+00
.nodeset v(xbgr.n_i27)=1.519804383633697e+00
.nodeset v(xbgr.n_i28)=1.085573813776828e+00
.nodeset v(xbgr.n_i29)=8.187367124424592e-01
.nodeset v(xbgr.n_i30)=1.913672697135186e+00
.nodeset v(xbgr.n_i31)=2.171144642427412e-01
.nodeset v(xbgr.n_i32)=2.822499670492198e+00
.nodeset v(xbgr.n_i33)=6.513438405611437e-01
.nodeset v(xbgr.n_i34)=2.128651303750224e+00
.nodeset v(xbgr.n_i35)=1.985332216485243e+00
.nodeset v(xbgr.n_i36)=8.953435092453152e-01
.nodeset v(xbgr.n_i37)=1.842013193975126e+00
.nodeset v(xbgr.n_i38)=1.698694236229352e+00
.nodeset v(xbgr.n_i39)=7.421299341674232e-01
.nodeset v(xbgr.n_i40)=2.200310871663259e+00
.nodeset v(xbgr.n_i41)=2.056991752023960e+00
.nodeset v(xbgr.n_i42)=6.655231744216116e-01
.nodeset v(xbgr.n_i43)=9.719503245745882e-01
.nodeset v(xbgr.xq736.s1)=3.399639895749852e-08
.nodeset v(xbgr.xq736.t)=3.210022817240005e-02
.nodeset v(xbgr.xq737.s1)=3.399639895749852e-08
.nodeset v(xbgr.xq737.t)=3.210022817240005e-02
.nodeset v(xbgr.xq738.s1)=3.399639895749852e-08
.nodeset v(xbgr.xq738.t)=3.210022817240007e-02
.nodeset v(xbgr.xq739.s1)=3.399639895749852e-08
.nodeset v(xbgr.xq739.t)=3.210022817240009e-02
.nodeset v(xbgr.xq740.s1)=3.399639895749852e-08
.nodeset v(xbgr.xq740.t)=3.210022817240005e-02
.nodeset v(xbgr.xq741.s1)=3.399639895749852e-08
.nodeset v(xbgr.xq741.t)=3.210022817240006e-02
.nodeset v(xbgr.xq742.s1)=3.399639895749852e-08
.nodeset v(xbgr.xq742.t)=3.210022817240006e-02
.nodeset v(xbgr.xq743.s1)=3.399639895749852e-08
.nodeset v(xbgr.xq743.t)=3.210022817240006e-02
.nodeset v(xbgr.xq744.s1)=3.399639895749852e-08
.nodeset v(xbgr.xq744.t)=3.210022817240006e-02
.nodeset v(xbgr.xq745.s1)=3.399639895749852e-08
.nodeset v(xbgr.xq745.t)=3.210022817240005e-02
.nodeset v(xbgr.xq746.s1)=3.399639895749852e-08
.nodeset v(xbgr.xq746.t)=3.210022817240006e-02
.nodeset v(xbgr.xq747.s1)=3.399639895749852e-08
.nodeset v(xbgr.xq747.t)=3.210022817240006e-02
.nodeset v(xbgr.xq748.s1)=3.399639895749852e-08
.nodeset v(xbgr.xq748.t)=3.210022817240005e-02
.nodeset v(xbgr.xq749.s1)=3.399639895749852e-08
.nodeset v(xbgr.xq749.t)=3.210022817240005e-02
.nodeset v(xbgr.xq750.s1)=3.399639895749852e-08
.nodeset v(xbgr.xq750.t)=3.210022817240006e-02
.nodeset v(xbgr.xq751.s1)=3.399639895749852e-08
.nodeset v(xbgr.xq751.t)=3.210022817240007e-02
.nodeset v(xbgr.xq752.s1)=3.399639895749852e-08
.nodeset v(xbgr.xq752.t)=3.210022817240005e-02
.nodeset v(xbgr.xq753.s1)=3.399639895749852e-08
.nodeset v(xbgr.xq753.t)=3.210022817240005e-02
.nodeset v(xbgr.xq754.s1)=3.399639895749852e-08
.nodeset v(xbgr.xq754.t)=3.210022817240005e-02
.nodeset v(xbgr.xq755.s1)=3.399639895749853e-08
.nodeset v(xbgr.xq755.t)=3.210022817240024e-02
.nodeset v(xbgr.xq756.s1)=3.399639895749852e-08
.nodeset v(xbgr.xq756.t)=3.210022817240005e-02
.nodeset v(xbgr.xq757.s1)=3.399639895749852e-08
.nodeset v(xbgr.xq757.t)=3.210022817240009e-02
.nodeset v(xbgr.xq758.s1)=3.399639895749852e-08
.nodeset v(xbgr.xq758.t)=3.210022817240009e-02
.nodeset v(xbgr.xq759.s1)=3.399639895749852e-08
.nodeset v(xbgr.xq759.t)=3.210022817240006e-02
.nodeset v(xbgr.xq760.s1)=3.399597068895089e-08
.nodeset v(xbgr.xq760.t)=3.195912394524071e-02
.nodeset v(xbgr.xq761.s1)=3.399597068895079e-08
.nodeset v(xbgr.xq761.t)=3.195912394524075e-02
.nodeset v(xbgr.xq762.s1)=3.399597068895090e-08
.nodeset v(xbgr.xq762.t)=3.195912394524060e-02
.nodeset v(xbgr.xq763.s1)=3.399597068895090e-08
.nodeset v(xbgr.xq763.t)=3.195912394524061e-02
.nodeset v(xbgr.xq764.s1)=3.399597068895079e-08
.nodeset v(xbgr.xq764.t)=3.195912394524075e-02
.nodeset v(xbgr.xq765.s1)=3.399597068895089e-08
.nodeset v(xbgr.xq765.t)=3.195912394524072e-02
.nodeset v(xbgr.xq766.s1)=3.399597068895079e-08
.nodeset v(xbgr.xq766.t)=3.195912394524091e-02
.nodeset v(xbgr.xq767.s1)=3.399597068895090e-08
.nodeset v(xbgr.xq767.t)=3.195912394524060e-02
.nodeset v(xbgr.xq768.s1)=3.399597068895089e-08
.nodeset v(xbgr.xq768.t)=3.195912394524071e-02
.nodeset v(xbgr.xq769.s1)=3.399597068895079e-08
.nodeset v(xbgr.xq769.t)=3.195912394524075e-02
.nodeset v(xbgr.xq770.s1)=3.399597068895079e-08
.nodeset v(xbgr.xq770.t)=3.195912394524075e-02
.nodeset v(xbgr.xq771.s1)=3.399597068895088e-08
.nodeset v(xbgr.xq771.t)=3.195912394524066e-02
.nodeset v(xbgr.xq772.s1)=3.399597068895079e-08
.nodeset v(xbgr.xq772.t)=3.195912394524075e-02
.nodeset v(xbgr.xq773.s1)=3.399597068895089e-08
.nodeset v(xbgr.xq773.t)=3.195912394524071e-02
.nodeset v(xbgr.xq774.s1)=3.399597068895090e-08
.nodeset v(xbgr.xq774.t)=3.195912394524061e-02
.nodeset v(xbgr.xq775.s1)=3.399597068895089e-08
.nodeset v(xbgr.xq775.t)=3.195912394524072e-02
.nodeset v(xbgr.xq776.s1)=3.399597068895089e-08
.nodeset v(xbgr.xq776.t)=3.195912394524071e-02
.nodeset v(xbgr.xq777.s1)=3.399597068895079e-08
.nodeset v(xbgr.xq777.t)=3.195912394524075e-02
.nodeset v(xbgr.xq778.s1)=3.399597068895089e-08
.nodeset v(xbgr.xq778.t)=3.195912394524081e-02
.nodeset v(xbgr.xq779.s1)=3.399597068895089e-08
.nodeset v(xbgr.xq779.t)=3.195912394524060e-02
.nodeset v(xbgr.xq780.s1)=3.399597068895090e-08
.nodeset v(xbgr.xq780.t)=3.195912394524102e-02
.nodeset v(xbgr.xq781.s1)=3.399597068895079e-08
.nodeset v(xbgr.xq781.t)=3.195912394524091e-02
.nodeset v(xbgr.xq782.s1)=3.399597068895079e-08
.nodeset v(xbgr.xq782.t)=3.195912394524091e-02
.nodeset v(xbgr.xq783.s1)=3.399597068895089e-08
.nodeset v(xbgr.xq783.t)=3.195912394524072e-02
.nodeset v(xbgr.xq784.s1)=3.389891612387673e-08
.nodeset v(xbgr.xq784.t)=5.816079370388693e-07
.nodeset v(xbgr.xq785.s1)=3.389891612387673e-08
.nodeset v(xbgr.xq785.t)=5.816079370388693e-07
.nodeset v(xbgr.xq786.s1)=3.389891612387673e-08
.nodeset v(xbgr.xq786.t)=5.816079370388693e-07
.nodeset v(xbgr.xq787.s1)=3.389891612387673e-08
.nodeset v(xbgr.xq787.t)=5.816079370388693e-07
.nodeset v(xbgr.xq788.s1)=3.389891612387673e-08
.nodeset v(xbgr.xq788.t)=5.816079370388693e-07
.nodeset v(xbgr.xq789.s1)=3.389891612387673e-08
.nodeset v(xbgr.xq789.t)=5.816079370388689e-07
.nodeset v(xbgr.xq790.s1)=3.389891612387673e-08
.nodeset v(xbgr.xq790.t)=5.816079370388693e-07
.nodeset v(xbgr.xq791.s1)=3.389891612387673e-08
.nodeset v(xbgr.xq791.t)=5.816079370388689e-07
.nodeset v(xbgr.xq792.s1)=3.389891612387673e-08
.nodeset v(xbgr.xq792.t)=5.816079370388689e-07
.nodeset v(xbgr.xq793.s1)=3.389891612387673e-08
.nodeset v(xbgr.xq793.t)=5.816079370388689e-07
.nodeset v(xbgr.xq794.s1)=3.389891612387673e-08
.nodeset v(xbgr.xq794.t)=5.816079370388689e-07
.nodeset v(xbgr.xq795.s1)=3.389891612387673e-08
.nodeset v(xbgr.xq795.t)=5.816079370388693e-07
.nodeset v(xbgr.xq796.s1)=3.389891612387673e-08
.nodeset v(xbgr.xq796.t)=5.816079370388689e-07
.nodeset v(xbgr.xq797.s1)=3.389891612387673e-08
.nodeset v(xbgr.xq797.t)=5.816079370388689e-07
.nodeset v(xbgr.xq798.s1)=3.389891612387673e-08
.nodeset v(xbgr.xq798.t)=5.816079370388689e-07
.nodeset v(xbgr.xq799.s1)=3.389891612387673e-08
.nodeset v(xbgr.xq799.t)=5.816079370388689e-07
.nodeset v(xbgr.xq800.s1)=3.389891612387673e-08
.nodeset v(xbgr.xq800.t)=5.816079370388693e-07
.nodeset v(xbgr.xq801.s1)=3.389891612387673e-08
.nodeset v(xbgr.xq801.t)=5.816079370388689e-07
.nodeset v(xbgr.xq802.s1)=3.389891612387673e-08
.nodeset v(xbgr.xq802.t)=5.816079370388689e-07
.nodeset v(xbgr.xq803.s1)=3.389891612387673e-08
.nodeset v(xbgr.xq803.t)=5.816079370388689e-07
.nodeset v(xbgr.xq804.s1)=3.389891612387673e-08
.nodeset v(xbgr.xq804.t)=5.816079370388689e-07
.nodeset v(xbgr.xq805.s1)=3.389891612387673e-08
.nodeset v(xbgr.xq805.t)=5.816079370388693e-07
.nodeset v(xbgr.xq806.s1)=3.389891612387673e-08
.nodeset v(xbgr.xq806.t)=5.816079370388693e-07
.nodeset v(xbgr.xq807.s1)=3.389891612387673e-08
.nodeset v(xbgr.xq807.t)=5.816079370388693e-07
.nodeset v(xbgr.xq808.s1)=3.391111450190552e-08
.nodeset v(xbgr.xq808.t)=4.008723176288051e-03
.nodeset v(xbgr.xq809.s1)=3.391111450190552e-08
.nodeset v(xbgr.xq809.t)=4.008723176288051e-03
.nodeset v(xbgr.xq810.s1)=3.391111450190552e-08
.nodeset v(xbgr.xq810.t)=4.008723176288051e-03
.nodeset v(xbgr.xq811.s1)=3.391111450190552e-08
.nodeset v(xbgr.xq811.t)=4.008723176288051e-03
.nodeset v(xbgr.xq812.s1)=3.391111450190552e-08
.nodeset v(xbgr.xq812.t)=4.008723176288051e-03
.nodeset v(xbgr.xq813.s1)=3.391111450190552e-08
.nodeset v(xbgr.xq813.t)=4.008723176288051e-03
.nodeset v(xbgr.xq814.s1)=3.391111450190552e-08
.nodeset v(xbgr.xq814.t)=4.008723176288051e-03
.nodeset v(xbgr.xq815.s1)=3.391111450190552e-08
.nodeset v(xbgr.xq815.t)=4.008723176288051e-03
.nodeset v(xbgr.xq816.s1)=3.391111450190552e-08
.nodeset v(xbgr.xq816.t)=4.008723176288051e-03
.nodeset v(xbgr.xq817.s1)=3.391111450190552e-08
.nodeset v(xbgr.xq817.t)=4.008723176288085e-03
.nodeset v(xbgr.xq818.s1)=3.391111450190552e-08
.nodeset v(xbgr.xq818.t)=4.008723176288051e-03
.nodeset v(xbgr.xq819.s1)=3.391111450190552e-08
.nodeset v(xbgr.xq819.t)=4.008723176288051e-03
.nodeset v(xbgr.xq820.s1)=3.391111450190552e-08
.nodeset v(xbgr.xq820.t)=4.008723176288051e-03
.nodeset v(xbgr.xq821.s1)=3.391111450190552e-08
.nodeset v(xbgr.xq821.t)=4.008723176288051e-03
.nodeset v(xbgr.xq822.s1)=3.391111450190552e-08
.nodeset v(xbgr.xq822.t)=4.008723176288051e-03
.nodeset v(xbgr.xq823.s1)=3.391111450190552e-08
.nodeset v(xbgr.xq823.t)=4.008723176288051e-03
.nodeset v(xbgr.xq824.s1)=3.391111450190552e-08
.nodeset v(xbgr.xq824.t)=4.008723176288051e-03
.nodeset v(xbgr.xq825.s1)=3.391111450190552e-08
.nodeset v(xbgr.xq825.t)=4.008723176288051e-03
.nodeset v(xbgr.xq826.s1)=3.391111450190552e-08
.nodeset v(xbgr.xq826.t)=4.008723176288051e-03
.nodeset v(xbgr.xq827.s1)=3.391111450190552e-08
.nodeset v(xbgr.xq827.t)=4.008723176288051e-03
.nodeset v(xbgr.xq828.s1)=3.391111450190552e-08
.nodeset v(xbgr.xq828.t)=4.008723176288051e-03
.nodeset v(xbgr.xq829.s1)=3.391111450190552e-08
.nodeset v(xbgr.xq829.t)=4.008723176288051e-03
.nodeset v(xbgr.xq830.s1)=3.391111450190552e-08
.nodeset v(xbgr.xq830.t)=4.008723176288051e-03
.nodeset v(xbgr.xq831.s1)=3.391111450190552e-08
.nodeset v(xbgr.xq831.t)=4.008723176288051e-03
.nodeset v(xbgr.xq832.s1)=3.391111450190552e-08
.nodeset v(xbgr.xq832.t)=4.008723176288051e-03
.nodeset v(xbgr.xq833.s1)=3.391111450190552e-08
.nodeset v(xbgr.xq833.t)=4.008723176288051e-03
.nodeset v(xbgr.xq834.s1)=3.391111450190552e-08
.nodeset v(xbgr.xq834.t)=4.008723176288051e-03
.nodeset v(xbgr.xq835.s1)=3.391111450190552e-08
.nodeset v(xbgr.xq835.t)=4.008723176288051e-03
.nodeset v(xbgr.xq836.s1)=3.391111450190552e-08
.nodeset v(xbgr.xq836.t)=4.008723176288051e-03
.nodeset v(xbgr.xq837.s1)=3.391111450190552e-08
.nodeset v(xbgr.xq837.t)=4.008723176288051e-03
.nodeset v(xbgr.xq838.s1)=3.391111450190552e-08
.nodeset v(xbgr.xq838.t)=4.008723176288051e-03
.nodeset v(xbgr.xq839.s1)=3.391111450190552e-08
.nodeset v(xbgr.xq839.t)=4.008723176288051e-03
.nodeset v(xbgr.xq840.s1)=3.391111450190552e-08
.nodeset v(xbgr.xq840.t)=4.008723176288051e-03
.nodeset v(xbgr.xq841.s1)=3.391111450190552e-08
.nodeset v(xbgr.xq841.t)=4.008723176288051e-03
.nodeset v(xbgr.xq842.s1)=3.391111450190552e-08
.nodeset v(xbgr.xq842.t)=4.008723176288051e-03
.nodeset v(xbgr.xq843.s1)=3.391111450190552e-08
.nodeset v(xbgr.xq843.t)=4.008723176288051e-03
.nodeset v(xbgr.xq844.s1)=3.391111450190552e-08
.nodeset v(xbgr.xq844.t)=4.008723176288051e-03
.nodeset v(xbgr.xq845.s1)=3.391111450190552e-08
.nodeset v(xbgr.xq845.t)=4.008723176288051e-03
.nodeset v(xbgr.xq846.s1)=3.391111450190552e-08
.nodeset v(xbgr.xq846.t)=4.008723176288051e-03
.nodeset v(xbgr.xq847.s1)=3.391111450190552e-08
.nodeset v(xbgr.xq847.t)=4.008723176288051e-03
.nodeset v(xbgr.xq848.s1)=3.391111450190552e-08
.nodeset v(xbgr.xq848.t)=4.008723176288051e-03
.nodeset v(xbgr.xq849.s1)=3.391111450190552e-08
.nodeset v(xbgr.xq849.t)=4.008723176288051e-03
.nodeset v(xbgr.xq850.s1)=3.391111450190552e-08
.nodeset v(xbgr.xq850.t)=4.008723176288051e-03
.nodeset v(xbgr.xq851.s1)=3.391111450190552e-08
.nodeset v(xbgr.xq851.t)=4.008723176288051e-03
.nodeset v(xbgr.xq852.s1)=3.391111450190552e-08
.nodeset v(xbgr.xq852.t)=4.008723176288051e-03
.nodeset v(xbgr.xq853.s1)=3.391111450190552e-08
.nodeset v(xbgr.xq853.t)=4.008723176288051e-03
.nodeset v(xbgr.xq854.s1)=3.391111450190552e-08
.nodeset v(xbgr.xq854.t)=4.008723176288051e-03
.nodeset v(xbgr.xq855.s1)=3.391111450190552e-08
.nodeset v(xbgr.xq855.t)=4.008723176288051e-03
.nodeset v(xbgr.xq856.s1)=3.391111450190552e-08
.nodeset v(xbgr.xq856.t)=4.008723176288051e-03
.nodeset v(xbgr.xq857.s1)=3.391111450190552e-08
.nodeset v(xbgr.xq857.t)=4.008723176288051e-03
.nodeset v(xbgr.xq858.s1)=3.391111450190552e-08
.nodeset v(xbgr.xq858.t)=4.008723176288051e-03
.nodeset v(xbgr.xq859.s1)=3.391111450190552e-08
.nodeset v(xbgr.xq859.t)=4.008723176288051e-03
.nodeset v(xbgr.xq860.s1)=3.391111450190552e-08
.nodeset v(xbgr.xq860.t)=4.008723176288051e-03
.nodeset v(xbgr.xq861.s1)=3.391111450190552e-08
.nodeset v(xbgr.xq861.t)=4.008723176288051e-03
.nodeset v(xbgr.xq862.s1)=3.391111450190552e-08
.nodeset v(xbgr.xq862.t)=4.008723176288051e-03
.nodeset v(xbgr.xq863.s1)=3.391111450190552e-08
.nodeset v(xbgr.xq863.t)=4.008723176288051e-03
.nodeset v(xbgr.xq864.s1)=3.391111450190552e-08
.nodeset v(xbgr.xq864.t)=4.008723176288051e-03
.nodeset v(xbgr.xq865.s1)=3.391111450190552e-08
.nodeset v(xbgr.xq865.t)=4.008723176288051e-03
.nodeset v(xbgr.xq866.s1)=3.391111450190552e-08
.nodeset v(xbgr.xq866.t)=4.008723176288051e-03
.nodeset v(xbgr.xq867.s1)=3.391111450190552e-08
.nodeset v(xbgr.xq867.t)=4.008723176288051e-03
.nodeset v(xbgr.xq868.s1)=3.391111450190552e-08
.nodeset v(xbgr.xq868.t)=4.008723176288091e-03
.nodeset v(xbgr.xq869.s1)=3.391111450190552e-08
.nodeset v(xbgr.xq869.t)=4.008723176288051e-03
.nodeset v(xbgr.xq870.s1)=3.391111450190552e-08
.nodeset v(xbgr.xq870.t)=4.008723176288051e-03
.nodeset v(xbgr.xq871.s1)=3.391111450190552e-08
.nodeset v(xbgr.xq871.t)=4.008723176288051e-03
.nodeset v(xbgr.xq872.s1)=3.391111450190552e-08
.nodeset v(xbgr.xq872.t)=4.008723176288051e-03
.nodeset v(xbgr.xq873.s1)=3.391111450190552e-08
.nodeset v(xbgr.xq873.t)=4.008723176288051e-03
.nodeset v(xbgr.xq874.s1)=3.391111450190552e-08
.nodeset v(xbgr.xq874.t)=4.008723176288051e-03
.nodeset v(xbgr.xq875.s1)=3.391111450190552e-08
.nodeset v(xbgr.xq875.t)=4.008723176288051e-03
.nodeset v(xbgr.xq876.s1)=3.391111450190552e-08
.nodeset v(xbgr.xq876.t)=4.008723176288051e-03
.nodeset v(xbgr.xq877.s1)=3.391111450190552e-08
.nodeset v(xbgr.xq877.t)=4.008723176288051e-03
.nodeset v(xbgr.xq878.s1)=3.391111450190552e-08
.nodeset v(xbgr.xq878.t)=4.008723176288051e-03
.nodeset v(xbgr.xq879.s1)=3.391111450190552e-08
.nodeset v(xbgr.xq879.t)=4.008723176288051e-03
.nodeset v(xbgr.xq880.s1)=3.391111450190552e-08
.nodeset v(xbgr.xq880.t)=4.008723176288051e-03
.nodeset v(xbgr.xq881.s1)=3.391111450190552e-08
.nodeset v(xbgr.xq881.t)=4.008723176288051e-03
.nodeset v(xbgr.xq882.s1)=3.391111450190552e-08
.nodeset v(xbgr.xq882.t)=4.008723176288051e-03
.nodeset v(xbgr.xq883.s1)=3.391111450190552e-08
.nodeset v(xbgr.xq883.t)=4.008723176288051e-03
.nodeset v(xbgr.xq884.s1)=3.391111450190552e-08
.nodeset v(xbgr.xq884.t)=4.008723176288051e-03
.nodeset v(xbgr.xq885.s1)=3.391111450190552e-08
.nodeset v(xbgr.xq885.t)=4.008723176288051e-03
.nodeset v(xbgr.xq886.s1)=3.391111450190552e-08
.nodeset v(xbgr.xq886.t)=4.008723176288051e-03
.nodeset v(xbgr.xq887.s1)=3.391111450190552e-08
.nodeset v(xbgr.xq887.t)=4.008723176288051e-03
.nodeset v(xbgr.xq888.s1)=3.391111450190552e-08
.nodeset v(xbgr.xq888.t)=4.008723176288051e-03
.nodeset v(xbgr.xq889.s1)=3.391111450190552e-08
.nodeset v(xbgr.xq889.t)=4.008723176288051e-03
.nodeset v(xbgr.xq890.s1)=3.391111450190552e-08
.nodeset v(xbgr.xq890.t)=4.008723176288051e-03
.nodeset v(xbgr.xq891.s1)=3.391111450190552e-08
.nodeset v(xbgr.xq891.t)=4.008723176288051e-03
.nodeset v(xbgr.xq892.s1)=3.391111450190552e-08
.nodeset v(xbgr.xq892.t)=4.008723176288051e-03
.nodeset v(xbgr.xq893.s1)=3.391111450190552e-08
.nodeset v(xbgr.xq893.t)=4.008723176288051e-03
.nodeset v(xbgr.xq894.s1)=3.391111450190552e-08
.nodeset v(xbgr.xq894.t)=4.008723176288051e-03
.nodeset v(xbgr.xq895.s1)=3.391111450190552e-08
.nodeset v(xbgr.xq895.t)=4.008723176288051e-03
.nodeset v(xbgr.xq896.s1)=3.391111450190552e-08
.nodeset v(xbgr.xq896.t)=4.008723176288051e-03
.nodeset v(xbgr.xq897.s1)=3.391111450190552e-08
.nodeset v(xbgr.xq897.t)=4.008723176288051e-03
.nodeset v(xbgr.xq898.s1)=3.391111450190552e-08
.nodeset v(xbgr.xq898.t)=4.008723176288051e-03
.nodeset v(xbgr.xq899.s1)=3.391111450190552e-08
.nodeset v(xbgr.xq899.t)=4.008723176288051e-03
.nodeset v(xbgr.xq900.s1)=3.391111450190552e-08
.nodeset v(xbgr.xq900.t)=4.008723176288051e-03
.nodeset v(xbgr.xq901.s1)=3.391111450190552e-08
.nodeset v(xbgr.xq901.t)=4.008723176288051e-03
.nodeset v(xbgr.xq902.s1)=3.391111450190552e-08
.nodeset v(xbgr.xq902.t)=4.008723176288051e-03
.nodeset v(xbgr.xq903.s1)=3.391111450190552e-08
.nodeset v(xbgr.xq903.t)=4.008723176288051e-03
.nodeset v(xbgr.xq904.s1)=3.391111450190552e-08
.nodeset v(xbgr.xq904.t)=4.008723176288051e-03
.nodeset v(xbgr.xq905.s1)=3.391111450190552e-08
.nodeset v(xbgr.xq905.t)=4.008723176288051e-03
.nodeset v(xbgr.xq906.s1)=3.391111450190552e-08
.nodeset v(xbgr.xq906.t)=4.008723176288051e-03
.nodeset v(xbgr.xq907.s1)=3.391111450190552e-08
.nodeset v(xbgr.xq907.t)=4.008723176288051e-03
.nodeset v(xbgr.xq908.s1)=3.391111450190552e-08
.nodeset v(xbgr.xq908.t)=4.008723176288051e-03
.nodeset v(xbgr.xq909.s1)=3.391111450190552e-08
.nodeset v(xbgr.xq909.t)=4.008723176288051e-03
.nodeset v(xbgr.xq910.s1)=3.391111450190552e-08
.nodeset v(xbgr.xq910.t)=4.008723176288051e-03
.nodeset v(xbgr.xq911.s1)=3.391111450190552e-08
.nodeset v(xbgr.xq911.t)=4.008723176288051e-03
.nodeset v(xbgr.xq912.s1)=3.391111450190552e-08
.nodeset v(xbgr.xq912.t)=4.008723176288051e-03
.nodeset v(xbgr.xq913.s1)=3.391111450190552e-08
.nodeset v(xbgr.xq913.t)=4.008723176288051e-03
.nodeset v(xbgr.xq914.s1)=3.391111450190552e-08
.nodeset v(xbgr.xq914.t)=4.008723176288051e-03
.nodeset v(xbgr.xq915.s1)=3.391111450190552e-08
.nodeset v(xbgr.xq915.t)=4.008723176288051e-03
.nodeset v(xbgr.xq916.s1)=3.391111450190552e-08
.nodeset v(xbgr.xq916.t)=4.008723176288051e-03
.nodeset v(xbgr.xq917.s1)=3.391111450190552e-08
.nodeset v(xbgr.xq917.t)=4.008723176288051e-03
.nodeset v(xbgr.xq918.s1)=3.391111450190552e-08
.nodeset v(xbgr.xq918.t)=4.008723176288051e-03
.nodeset v(xbgr.xq919.s1)=3.391111450190552e-08
.nodeset v(xbgr.xq919.t)=4.008723176288051e-03
.nodeset v(xbgr.xq920.s1)=3.391111450190552e-08
.nodeset v(xbgr.xq920.t)=4.008723176288051e-03
.nodeset v(xbgr.xq921.s1)=3.391111450190552e-08
.nodeset v(xbgr.xq921.t)=4.008723176288051e-03
.nodeset v(xbgr.xq922.s1)=3.391111450190552e-08
.nodeset v(xbgr.xq922.t)=4.008723176288051e-03
.nodeset v(xbgr.xq923.s1)=3.391111450190552e-08
.nodeset v(xbgr.xq923.t)=4.008723176288051e-03
.nodeset v(xbgr.xq924.s1)=3.391111450190552e-08
.nodeset v(xbgr.xq924.t)=4.008723176288051e-03
.nodeset v(xbgr.xq925.s1)=3.391111450190552e-08
.nodeset v(xbgr.xq925.t)=4.008723176288051e-03
.nodeset v(xbgr.xq926.s1)=3.391111450190552e-08
.nodeset v(xbgr.xq926.t)=4.008723176288051e-03
.nodeset v(xbgr.xq927.s1)=3.391111450190552e-08
.nodeset v(xbgr.xq927.t)=4.008723176288051e-03
.nodeset v(xbgr.xq928.s1)=3.391111450190552e-08
.nodeset v(xbgr.xq928.t)=4.008723176288051e-03
.nodeset v(xbgr.xq929.s1)=3.391111450190552e-08
.nodeset v(xbgr.xq929.t)=4.008723176288051e-03
.nodeset v(xbgr.xq930.s1)=3.391111450190552e-08
.nodeset v(xbgr.xq930.t)=4.008723176288051e-03
.nodeset v(xbgr.xq931.s1)=3.391111450190552e-08
.nodeset v(xbgr.xq931.t)=4.008723176288051e-03
.nodeset v(xbgr.xq932.s1)=3.391111450190552e-08
.nodeset v(xbgr.xq932.t)=4.008723176288051e-03
.nodeset v(xbgr.xq933.s1)=3.391111450190552e-08
.nodeset v(xbgr.xq933.t)=4.008723176288051e-03
.nodeset v(xbgr.xq934.s1)=3.391111450190552e-08
.nodeset v(xbgr.xq934.t)=4.008723176288051e-03
.nodeset v(xbgr.xq935.s1)=3.391111450190552e-08
.nodeset v(xbgr.xq935.t)=4.008723176288051e-03
.nodeset v(xbgr.xq936.s1)=3.391111450190552e-08
.nodeset v(xbgr.xq936.t)=4.008723176288051e-03
.nodeset v(xbgr.xq937.s1)=3.391111450190552e-08
.nodeset v(xbgr.xq937.t)=4.008723176288051e-03
.nodeset v(xbgr.xq938.s1)=3.391111450190552e-08
.nodeset v(xbgr.xq938.t)=4.008723176288051e-03
.nodeset v(xbgr.xq939.s1)=3.391111450190552e-08
.nodeset v(xbgr.xq939.t)=4.008723176288051e-03
.nodeset v(xbgr.xq940.s1)=3.391111450190552e-08
.nodeset v(xbgr.xq940.t)=4.008723176288051e-03
.nodeset v(xbgr.xq941.s1)=3.391111450190552e-08
.nodeset v(xbgr.xq941.t)=4.008723176288051e-03
.nodeset v(xbgr.xq942.s1)=3.391111450190552e-08
.nodeset v(xbgr.xq942.t)=4.008723176288051e-03
.nodeset v(xbgr.xq943.s1)=3.391111450190552e-08
.nodeset v(xbgr.xq943.t)=4.008723176288051e-03
.nodeset v(xbgr.xq944.s1)=3.391111450190552e-08
.nodeset v(xbgr.xq944.t)=4.008723176288051e-03
.nodeset v(xbgr.xq945.s1)=3.391111450190552e-08
.nodeset v(xbgr.xq945.t)=4.008723176288051e-03
.nodeset v(xbgr.xq946.s1)=3.391111450190552e-08
.nodeset v(xbgr.xq946.t)=4.008723176288051e-03
.nodeset v(xbgr.xq947.s1)=3.391111450190552e-08
.nodeset v(xbgr.xq947.t)=4.008723176288051e-03
.nodeset v(xbgr.xq948.s1)=3.391111450190552e-08
.nodeset v(xbgr.xq948.t)=4.008723176288051e-03
.nodeset v(xbgr.xq949.s1)=3.391111450190552e-08
.nodeset v(xbgr.xq949.t)=4.008723176288051e-03
.nodeset v(xbgr.xq950.s1)=3.391111450190552e-08
.nodeset v(xbgr.xq950.t)=4.008723176288051e-03
.nodeset v(xbgr.xq951.s1)=3.391111450190552e-08
.nodeset v(xbgr.xq951.t)=4.008723176288051e-03
.nodeset v(xbgr.xq952.s1)=3.391111450190552e-08
.nodeset v(xbgr.xq952.t)=4.008723176288051e-03
.nodeset v(xbgr.xq953.s1)=3.391111450190552e-08
.nodeset v(xbgr.xq953.t)=4.008723176288051e-03
.nodeset v(xbgr.xq954.s1)=3.391111450190552e-08
.nodeset v(xbgr.xq954.t)=4.008723176288051e-03
.nodeset v(xbgr.xq955.s1)=3.391111450190552e-08
.nodeset v(xbgr.xq955.t)=4.008723176288051e-03
.nodeset v(xbgr.xq956.s1)=3.391111450190552e-08
.nodeset v(xbgr.xq956.t)=4.008723176288051e-03
.nodeset v(xbgr.xq957.s1)=3.391111450190552e-08
.nodeset v(xbgr.xq957.t)=4.008723176288051e-03
.nodeset v(xbgr.xq958.s1)=3.391111450190552e-08
.nodeset v(xbgr.xq958.t)=4.008723176288051e-03
.nodeset v(xbgr.xq959.s1)=3.391111450190552e-08
.nodeset v(xbgr.xq959.t)=4.008723176288051e-03
.nodeset v(xbgr.xq960.s1)=3.391111450190552e-08
.nodeset v(xbgr.xq960.t)=4.008723176288051e-03
.nodeset v(xbgr.xq961.s1)=3.391111450190552e-08
.nodeset v(xbgr.xq961.t)=4.008723176288051e-03
.nodeset v(xbgr.xq962.s1)=3.391111450190552e-08
.nodeset v(xbgr.xq962.t)=4.008723176288051e-03
.nodeset v(xbgr.xq963.s1)=3.391111450190552e-08
.nodeset v(xbgr.xq963.t)=4.008723176288051e-03
.nodeset v(xbgr.xq964.s1)=3.391111450190552e-08
.nodeset v(xbgr.xq964.t)=4.008723176288051e-03
.nodeset v(xbgr.xq965.s1)=3.391111450190552e-08
.nodeset v(xbgr.xq965.t)=4.008723176288051e-03
.nodeset v(xbgr.xq966.s1)=3.391111450190552e-08
.nodeset v(xbgr.xq966.t)=4.008723176288051e-03
.nodeset v(xbgr.xq967.s1)=3.391111450190552e-08
.nodeset v(xbgr.xq967.t)=4.008723176288051e-03
.nodeset v(xbgr.xq968.s1)=3.391111450190552e-08
.nodeset v(xbgr.xq968.t)=4.008723176288051e-03
.nodeset v(xbgr.xq969.s1)=3.391111450190552e-08
.nodeset v(xbgr.xq969.t)=4.008723176288051e-03
.nodeset v(xbgr.xq970.s1)=3.391111450190552e-08
.nodeset v(xbgr.xq970.t)=4.008723176288051e-03
.nodeset v(xbgr.xq971.s1)=3.391111450190552e-08
.nodeset v(xbgr.xq971.t)=4.008723176288051e-03
.nodeset v(xbgr.xq972.s1)=3.391111450190552e-08
.nodeset v(xbgr.xq972.t)=4.008723176288051e-03
.nodeset v(xbgr.xq973.s1)=3.391111450190552e-08
.nodeset v(xbgr.xq973.t)=4.008723176288051e-03
.nodeset v(xbgr.xq974.s1)=3.391111450190552e-08
.nodeset v(xbgr.xq974.t)=4.008723176288051e-03
.nodeset v(xbgr.xq975.s1)=3.391111450190552e-08
.nodeset v(xbgr.xq975.t)=4.008723176288051e-03
.nodeset v(xbgr.xq976.s1)=3.391111450190552e-08
.nodeset v(xbgr.xq976.t)=4.008723176288051e-03
.nodeset v(xbgr.xq977.s1)=3.391111450190552e-08
.nodeset v(xbgr.xq977.t)=4.008723176288051e-03
.nodeset v(xbgr.xq978.s1)=3.391111450190552e-08
.nodeset v(xbgr.xq978.t)=4.008723176288051e-03
.nodeset v(xbgr.xq979.s1)=3.391111450190552e-08
.nodeset v(xbgr.xq979.t)=4.008723176288051e-03
.nodeset v(xbgr.xq980.s1)=3.391111450190552e-08
.nodeset v(xbgr.xq980.t)=4.008723176288051e-03
.nodeset v(xbgr.xq981.s1)=3.391111450190552e-08
.nodeset v(xbgr.xq981.t)=4.008723176288051e-03
.nodeset v(xbgr.xq982.s1)=3.391111450190552e-08
.nodeset v(xbgr.xq982.t)=4.008723176288051e-03
.nodeset v(xbgr.xq983.s1)=3.391111450190552e-08
.nodeset v(xbgr.xq983.t)=4.008723176288051e-03
.nodeset v(xbgr.xq984.s1)=3.391111450190552e-08
.nodeset v(xbgr.xq984.t)=4.008723176288051e-03
.nodeset v(xbgr.xq985.s1)=3.391111450190552e-08
.nodeset v(xbgr.xq985.t)=4.008723176288051e-03
.nodeset v(xbgr.xq986.s1)=3.391111450190552e-08
.nodeset v(xbgr.xq986.t)=4.008723176288051e-03
.nodeset v(xbgr.xq987.s1)=3.391111450190552e-08
.nodeset v(xbgr.xq987.t)=4.008723176288051e-03
.nodeset v(xbgr.xq988.s1)=3.391111450190552e-08
.nodeset v(xbgr.xq988.t)=4.008723176288051e-03
.nodeset v(xbgr.xq989.s1)=3.391111450190552e-08
.nodeset v(xbgr.xq989.t)=4.008723176288051e-03
.nodeset v(xbgr.xq990.s1)=3.391111450190552e-08
.nodeset v(xbgr.xq990.t)=4.008723176288051e-03
.nodeset v(xbgr.xq991.s1)=3.391111450190552e-08
.nodeset v(xbgr.xq991.t)=4.008723176288051e-03
.nodeset v(xbgr.xq992.s1)=3.391111450190552e-08
.nodeset v(xbgr.xq992.t)=4.008723176288051e-03
.nodeset v(xbgr.xq993.s1)=3.391111450190552e-08
.nodeset v(xbgr.xq993.t)=4.008723176288051e-03
.nodeset v(xbgr.xq994.s1)=3.391111450190552e-08
.nodeset v(xbgr.xq994.t)=4.008723176288051e-03
.nodeset v(xbgr.xq995.s1)=3.391111450190552e-08
.nodeset v(xbgr.xq995.t)=4.008723176288051e-03
.nodeset v(xbgr.xq996.s1)=3.391111450190552e-08
.nodeset v(xbgr.xq996.t)=4.008723176288051e-03
.nodeset v(xbgr.xq997.s1)=3.391111450190552e-08
.nodeset v(xbgr.xq997.t)=4.008723176288051e-03
.nodeset v(xbgr.xq998.s1)=3.391111450190552e-08
.nodeset v(xbgr.xq998.t)=4.008723176288051e-03
.nodeset v(xbgr.xq999.s1)=3.391111450190552e-08
.nodeset v(xbgr.xq999.t)=4.008723176288051e-03
.nodeset v(xbgr.xq1000.s1)=3.399665152130072e-08
.nodeset v(xbgr.xq1000.t)=3.210139916916122e-02
.nodeset v(xbgr.xq1001.s1)=3.399665152130072e-08
.nodeset v(xbgr.xq1001.t)=3.210139916916144e-02
.nodeset v(xbgr.xq1002.s1)=3.399665152130072e-08
.nodeset v(xbgr.xq1002.t)=3.210139916916144e-02
.nodeset v(xbgr.xq1003.s1)=3.399665152130084e-08
.nodeset v(xbgr.xq1003.t)=3.210139916916135e-02
.nodeset v(xbgr.xq1004.s1)=3.399665152130072e-08
.nodeset v(xbgr.xq1004.t)=3.210139916916122e-02
.nodeset v(xbgr.xq1005.s1)=3.399665152130072e-08
.nodeset v(xbgr.xq1005.t)=3.210139916916144e-02
.nodeset v(xbgr.xq1006.s1)=3.399665152130072e-08
.nodeset v(xbgr.xq1006.t)=3.210139916916144e-02
.nodeset v(xbgr.xq1007.s1)=3.399665152130072e-08
.nodeset v(xbgr.xq1007.t)=3.210139916916144e-02
.nodeset v(xbgr.xq1008.s1)=3.399665152130072e-08
.nodeset v(xbgr.xq1008.t)=3.210139916916144e-02
.nodeset v(xbgr.xq1009.s1)=3.399665152130084e-08
.nodeset v(xbgr.xq1009.t)=3.210139916916163e-02
.nodeset v(xbgr.xq1010.s1)=3.399665152130072e-08
.nodeset v(xbgr.xq1010.t)=3.210139916916122e-02
.nodeset v(xbgr.xq1011.s1)=3.399665152130081e-08
.nodeset v(xbgr.xq1011.t)=3.210139916916144e-02
.nodeset v(xbgr.xq1012.s1)=3.399665152130072e-08
.nodeset v(xbgr.xq1012.t)=3.210139916916144e-02
.nodeset v(xbgr.xq1013.s1)=3.399665152130081e-08
.nodeset v(xbgr.xq1013.t)=3.210139916916099e-02
.nodeset v(xbgr.xq1014.s1)=3.399665152130072e-08
.nodeset v(xbgr.xq1014.t)=3.210139916916144e-02
.nodeset v(xbgr.xq1015.s1)=3.399665152130083e-08
.nodeset v(xbgr.xq1015.t)=3.210139916916169e-02
.nodeset v(xbgr.xq1016.s1)=3.399665152130072e-08
.nodeset v(xbgr.xq1016.t)=3.210139916916122e-02
.nodeset v(xbgr.xq1017.s1)=3.399665152130072e-08
.nodeset v(xbgr.xq1017.t)=3.210139916916122e-02
.nodeset v(xbgr.xq1018.s1)=3.399665152130072e-08
.nodeset v(xbgr.xq1018.t)=3.210139916916144e-02
.nodeset v(xbgr.xq1019.s1)=3.399665152130072e-08
.nodeset v(xbgr.xq1019.t)=3.210139916916144e-02
.nodeset v(xbgr.xq1020.s1)=3.399665152130083e-08
.nodeset v(xbgr.xq1020.t)=3.210139916916169e-02
.nodeset v(xbgr.xq1021.s1)=3.399665152130081e-08
.nodeset v(xbgr.xq1021.t)=3.210139916916122e-02
.nodeset v(xbgr.xq1022.s1)=3.399665152130081e-08
.nodeset v(xbgr.xq1022.t)=3.210139916916122e-02
.nodeset v(xbgr.xq1023.s1)=3.399665152130094e-08
.nodeset v(xbgr.xq1023.t)=3.210139916916099e-02
.nodeset v(xbgr.xq1024.s1)=3.399640097461879e-08
.nodeset v(xbgr.xq1024.t)=3.210089276170894e-02
.nodeset v(xbgr.xq1025.s1)=3.399640097461879e-08
.nodeset v(xbgr.xq1025.t)=3.210089276170894e-02
.nodeset v(xbgr.xq1026.s1)=3.399640097461988e-08
.nodeset v(xbgr.xq1026.t)=3.210089276170869e-02
.nodeset v(xbgr.xq1027.s1)=3.399640097461988e-08
.nodeset v(xbgr.xq1027.t)=3.210089276170869e-02
.nodeset v(xbgr.xq1028.s1)=0.000000000000000e+00
.nodeset v(xbgr.xq1028.t)=0.000000000000000e+00
.nodeset v(xbgr.xq1029.s1)=0.000000000000000e+00
.nodeset v(xbgr.xq1029.t)=0.000000000000000e+00
.nodeset v(xbgr.xq1030.s1)=0.000000000000000e+00
.nodeset v(xbgr.xq1030.t)=0.000000000000000e+00
.nodeset v(xbgr.xq1031.s1)=0.000000000000000e+00
.nodeset v(xbgr.xq1031.t)=0.000000000000000e+00
.nodeset v(xbgr.xq1032.s1)=0.000000000000000e+00
.nodeset v(xbgr.xq1032.t)=0.000000000000000e+00
.nodeset v(xbgr.xq1033.s1)=0.000000000000000e+00
.nodeset v(xbgr.xq1033.t)=0.000000000000000e+00
.nodeset v(xbgr.xq1034.s1)=0.000000000000000e+00
.nodeset v(xbgr.xq1034.t)=0.000000000000000e+00
.nodeset v(xbgr.xq1035.s1)=0.000000000000000e+00
.nodeset v(xbgr.xq1035.t)=0.000000000000000e+00
.nodeset v(xbgr.xq1036.s1)=0.000000000000000e+00
.nodeset v(xbgr.xq1036.t)=0.000000000000000e+00
.nodeset v(xbgr.xr1.dt)=0.000000000000000e+00
.nodeset v(xbgr.xr2.dt)=0.000000000000000e+00
.nodeset v(xbgr.xr3.dt)=0.000000000000000e+00
.nodeset v(xbgr.xr4.dt)=0.000000000000000e+00
.nodeset v(xbgr.xr5.dt)=0.000000000000000e+00
.nodeset v(xbgr.xr6.dt)=0.000000000000000e+00
.nodeset v(xbgr.xr7.dt)=0.000000000000000e+00
.nodeset v(xbgr.xr8.dt)=0.000000000000000e+00
.nodeset v(xbgr.xr9.dt)=0.000000000000000e+00
.nodeset v(xbgr.xr10.dt)=0.000000000000000e+00
.nodeset v(xbgr.xr11.dt)=0.000000000000000e+00
.nodeset v(xbgr.xr12.dt)=0.000000000000000e+00
.nodeset v(xbgr.xr13.dt)=0.000000000000000e+00
.nodeset v(xbgr.xr14.dt)=0.000000000000000e+00
.nodeset v(xbgr.xr15.dt)=0.000000000000000e+00
.nodeset v(xbgr.xr16.dt)=0.000000000000000e+00
.nodeset v(xbgr.xr17.dt)=0.000000000000000e+00
.nodeset v(xbgr.xr18.dt)=0.000000000000000e+00
.nodeset v(xbgr.xr19.dt)=0.000000000000000e+00
.nodeset v(xbgr.xr20.dt)=0.000000000000000e+00
.nodeset v(xbgr.xr21.dt)=0.000000000000000e+00
.nodeset v(xbgr.xr22.dt)=0.000000000000000e+00
.nodeset v(xbgr.xr23.dt)=0.000000000000000e+00
.nodeset v(xbgr.xr24.dt)=0.000000000000000e+00
.nodeset v(xbgr.xr25.dt)=0.000000000000000e+00
.nodeset v(xbgr.xr26.dt)=0.000000000000000e+00
.nodeset v(xbgr.xr27.dt)=0.000000000000000e+00
.nodeset v(xbgr.xr28.dt)=0.000000000000000e+00
.nodeset v(xbgr.xr29.dt)=0.000000000000000e+00
.nodeset v(xbgr.xr30.dt)=0.000000000000000e+00
.nodeset v(xbgr.xr31.dt)=0.000000000000000e+00
.nodeset v(xbgr.xr32.dt)=0.000000000000000e+00
.nodeset v(xbgr.xr33.dt)=0.000000000000000e+00
.nodeset v(xbgr.xr34.dt)=0.000000000000000e+00
.nodeset v(xbgr.xr35.dt)=0.000000000000000e+00
.nodeset v(xbgr.xr36.dt)=0.000000000000000e+00
.nodeset v(xbgr.xr37.dt)=0.000000000000000e+00
.nodeset v(xbgr.xr38.dt)=0.000000000000000e+00
.nodeset v(xbgr.xr39.dt)=0.000000000000000e+00
.nodeset v(xbgr.xr40.dt)=0.000000000000000e+00
.nodeset v(xbgr.xr41.dt)=0.000000000000000e+00
.nodeset v(xbgr.xr42.dt)=0.000000000000000e+00
.nodeset v(xbgr.xr43.dt)=0.000000000000000e+00
.nodeset v(xbgr.xr44.dt)=0.000000000000000e+00
.nodeset v(xbgr.xr45.dt)=0.000000000000000e+00
.nodeset v(xbgr.xr46.dt)=0.000000000000000e+00
.nodeset v(xbgr.xr47.dt)=0.000000000000000e+00
.nodeset v(xbgr.xr48.dt)=0.000000000000000e+00
.nodeset v(xbgr.xr49.dt)=0.000000000000000e+00
.nodeset v(xbgr.xr50.dt)=0.000000000000000e+00
.nodeset v(xbgr.xr51.dt)=0.000000000000000e+00
.nodeset v(xbgr.xr52.dt)=0.000000000000000e+00
.nodeset v(xbgr.xr53.dt)=0.000000000000000e+00
.nodeset v(xbgr.xr54.dt)=0.000000000000000e+00
.nodeset v(xbgr.xr55.dt)=0.000000000000000e+00
.nodeset v(xbgr.xr56.dt)=0.000000000000000e+00
.nodeset v(xbgr.xr57.dt)=0.000000000000000e+00
.nodeset v(xbgr.xr58.dt)=0.000000000000000e+00
.nodeset v(xbgr.xr59.dt)=0.000000000000000e+00
.nodeset v(xbgr.xr60.dt)=0.000000000000000e+00
.nodeset v(xbgr.xr61.dt)=0.000000000000000e+00
.nodeset v(xbgr.xr62.dt)=0.000000000000000e+00
.nodeset v(xbgr.xr63.dt)=0.000000000000000e+00
.nodeset v(xbgr.xr64.dt)=0.000000000000000e+00
.nodeset v(xbgr.xr65.dt)=0.000000000000000e+00
.nodeset v(xbgr.xr66.dt)=0.000000000000000e+00
.nodeset v(xbgr.xr67.dt)=0.000000000000000e+00
.nodeset v(xbgr.xr68.dt)=0.000000000000000e+00
.nodeset v(xbgr.xr69.dt)=0.000000000000000e+00
.nodeset v(xbgr.xr70.dt)=0.000000000000000e+00
.nodeset v(xbgr.xr71.dt)=0.000000000000000e+00
.nodeset v(xbgr.xr72.dt)=0.000000000000000e+00
.nodeset v(xbgr.xr73.dt)=0.000000000000000e+00
.nodeset v(xbgr.xr74.dt)=0.000000000000000e+00
.nodeset v(xbgr.xr75.dt)=0.000000000000000e+00
.nodeset v(xbgr.xr76.dt)=0.000000000000000e+00
.nodeset v(xbgr.xr77.dt)=0.000000000000000e+00
.nodeset v(xbgr.xr78.dt)=0.000000000000000e+00
.nodeset v(xbgr.xr79.dt)=0.000000000000000e+00
.nodeset v(xbgr.xr80.dt)=0.000000000000000e+00
.nodeset v(xbgr.xr81.dt)=0.000000000000000e+00
.nodeset v(xbgr.xr82.dt)=0.000000000000000e+00
.nodeset v(xbgr.xr83.dt)=0.000000000000000e+00
.nodeset v(xbgr.xr84.dt)=0.000000000000000e+00
.nodeset v(xbgr.xr85.dt)=0.000000000000000e+00
.nodeset v(xbgr.xr86.dt)=0.000000000000000e+00
.nodeset v(xbgr.xr87.dt)=0.000000000000000e+00
.nodeset v(xbgr.xr88.dt)=0.000000000000000e+00
.nodeset v(xbgr.xr89.dt)=0.000000000000000e+00
.nodeset v(xbgr.xr90.dt)=0.000000000000000e+00
.nodeset v(xbgr.xr91.dt)=0.000000000000000e+00
.nodeset v(xbgr.xr92.dt)=0.000000000000000e+00
.nodeset v(xbgr.xr93.dt)=0.000000000000000e+00
.nodeset v(xbgr.xr94.dt)=0.000000000000000e+00
.nodeset v(xbgr.xr95.dt)=0.000000000000000e+00
.nodeset v(xbgr.xr96.dt)=0.000000000000000e+00
.nodeset v(xbgr.xr97.dt)=0.000000000000000e+00
.nodeset v(xbgr.xr98.dt)=0.000000000000000e+00
.nodeset v(xbgr.xr99.dt)=0.000000000000000e+00
.nodeset v(xbgr.xr100.dt)=0.000000000000000e+00
.nodeset v(xbgr.xr101.dt)=0.000000000000000e+00
.nodeset v(xbgr.xr102.dt)=0.000000000000000e+00
.nodeset v(xbgr.xr103.dt)=0.000000000000000e+00
.nodeset v(xbgr.xr104.dt)=0.000000000000000e+00
.nodeset v(xbgr.xr105.dt)=0.000000000000000e+00
.nodeset v(xbgr.xr106.dt)=0.000000000000000e+00
.nodeset v(xbgr.xr107.dt)=0.000000000000000e+00
.nodeset v(xbgr.xr108.dt)=0.000000000000000e+00
.nodeset v(xbgr.xr109.dt)=0.000000000000000e+00
.nodeset v(xbgr.xr110.dt)=0.000000000000000e+00
.nodeset v(xbgr.xr111.dt)=0.000000000000000e+00
.nodeset v(xbgr.xr112.dt)=0.000000000000000e+00
.nodeset v(xbgr.xr113.dt)=0.000000000000000e+00
.nodeset v(xbgr.xr114.dt)=0.000000000000000e+00
.nodeset v(xbgr.xr115.dt)=0.000000000000000e+00
.nodeset v(xbgr.xr116.dt)=0.000000000000000e+00
.nodeset v(xbgr.xr117.dt)=0.000000000000000e+00
.nodeset v(xbgr.xr118.dt)=0.000000000000000e+00
.nodeset v(xbgr.xr119.dt)=0.000000000000000e+00
.nodeset v(xbgr.xr120.dt)=0.000000000000000e+00
.nodeset v(xbgr.xr121.dt)=0.000000000000000e+00
.nodeset v(xbgr.xr122.dt)=0.000000000000000e+00
.nodeset v(xbgr.xr123.dt)=0.000000000000000e+00
.nodeset v(xbgr.xr124.dt)=0.000000000000000e+00
.nodeset v(xbgr.xr125.dt)=0.000000000000000e+00
.nodeset v(xbgr.xr126.dt)=0.000000000000000e+00
.nodeset v(xbgr.xr127.dt)=0.000000000000000e+00
.nodeset v(xbgr.xr128.dt)=0.000000000000000e+00
.nodeset v(xbgr.xr129.dt)=0.000000000000000e+00
.nodeset v(xbgr.xr130.dt)=0.000000000000000e+00
.nodeset v(xbgr.xr131.dt)=0.000000000000000e+00
.nodeset v(xbgr.xr132.dt)=0.000000000000000e+00
.nodeset v(xbgr.xr133.dt)=0.000000000000000e+00
.nodeset v(xbgr.xr134.dt)=0.000000000000000e+00
.nodeset v(xbgr.xr135.dt)=0.000000000000000e+00
.nodeset v(xbgr.xr136.dt)=0.000000000000000e+00
.nodeset v(xbgr.xr137.dt)=0.000000000000000e+00
.nodeset v(xbgr.xr138.dt)=0.000000000000000e+00
.nodeset v(xbgr.xr139.dt)=0.000000000000000e+00
.nodeset v(xbgr.xr140.dt)=0.000000000000000e+00
.nodeset v(xbgr.xr141.dt)=0.000000000000000e+00
.nodeset v(xbgr.xr142.dt)=0.000000000000000e+00
.nodeset v(xbgr.xr143.dt)=0.000000000000000e+00
.nodeset v(xbgr.xr144.dt)=0.000000000000000e+00
.nodeset v(xbgr.xr145.dt)=0.000000000000000e+00
.nodeset v(xbgr.xr146.dt)=0.000000000000000e+00
.nodeset v(xbgr.xr147.dt)=0.000000000000000e+00
.nodeset v(xbgr.xr148.dt)=0.000000000000000e+00
.nodeset v(xbgr.xr149.dt)=0.000000000000000e+00
.nodeset v(xbgr.xr150.dt)=0.000000000000000e+00
.nodeset v(xbgr.xr151.dt)=0.000000000000000e+00
.nodeset v(xbgr.xr152.dt)=0.000000000000000e+00
.nodeset v(xbgr.xr153.dt)=0.000000000000000e+00
.nodeset v(xbgr.xr154.dt)=0.000000000000000e+00
.nodeset v(xbgr.xr155.dt)=0.000000000000000e+00
.nodeset v(xbgr.xr156.dt)=0.000000000000000e+00
.nodeset v(xbgr.xr157.dt)=0.000000000000000e+00
.nodeset v(xbgr.xr158.dt)=0.000000000000000e+00
.nodeset v(xbgr.xr159.dt)=0.000000000000000e+00
.nodeset v(xbgr.xr160.dt)=0.000000000000000e+00
.nodeset v(xbgr.xr161.dt)=0.000000000000000e+00
.nodeset v(xbgr.xr162.dt)=0.000000000000000e+00
.nodeset v(xbgr.xr163.dt)=0.000000000000000e+00
.nodeset v(xbgr.xr164.dt)=0.000000000000000e+00
.nodeset v(xbgr.xr165.dt)=0.000000000000000e+00
.nodeset v(xbgr.xr166.dt)=0.000000000000000e+00
.nodeset v(xbgr.xr167.dt)=0.000000000000000e+00
.nodeset v(xbgr.xr168.dt)=0.000000000000000e+00
.nodeset v(xbgr.xr169.dt)=0.000000000000000e+00
.nodeset v(xbgr.xr170.dt)=0.000000000000000e+00
.nodeset v(xbgr.xr171.dt)=0.000000000000000e+00
.nodeset v(xbgr.xr172.dt)=0.000000000000000e+00
.nodeset v(xbgr.xr173.dt)=0.000000000000000e+00
.nodeset v(xbgr.xr174.dt)=0.000000000000000e+00
.nodeset v(xbgr.xr175.dt)=0.000000000000000e+00
.nodeset v(xbgr.xr176.dt)=0.000000000000000e+00
.nodeset v(xbgr.xr177.dt)=0.000000000000000e+00
.nodeset v(xbgr.xr178.dt)=0.000000000000000e+00
.nodeset v(xbgr.xr179.dt)=0.000000000000000e+00
.nodeset v(xbgr.xr180.dt)=0.000000000000000e+00
.nodeset v(xbgr.xr181.dt)=0.000000000000000e+00
.nodeset v(xbgr.xr182.dt)=0.000000000000000e+00
.nodeset v(xbgr.xr183.dt)=0.000000000000000e+00
.nodeset v(xbgr.xr184.dt)=0.000000000000000e+00
.nodeset v(xbgr.xr185.dt)=0.000000000000000e+00
.nodeset v(xbgr.xr186.dt)=0.000000000000000e+00
.nodeset v(xbgr.xr187.dt)=0.000000000000000e+00
.nodeset v(xbgr.xr188.dt)=0.000000000000000e+00
.nodeset v(xbgr.xr189.dt)=0.000000000000000e+00
.nodeset v(xbgr.xr190.dt)=0.000000000000000e+00
.nodeset v(xbgr.xr191.dt)=0.000000000000000e+00
.nodeset v(xbgr.xr192.dt)=0.000000000000000e+00
.nodeset v(xbgr.xr193.dt)=0.000000000000000e+00
.nodeset v(xbgr.xr194.dt)=0.000000000000000e+00
.nodeset v(xbgr.xr195.dt)=0.000000000000000e+00
.nodeset v(xbgr.xr196.dt)=0.000000000000000e+00
.nodeset v(xbgr.xr197.dt)=0.000000000000000e+00
.nodeset v(xbgr.xr198.dt)=0.000000000000000e+00
.nodeset v(xbgr.xr199.dt)=0.000000000000000e+00
.nodeset v(xbgr.xr200.dt)=0.000000000000000e+00
.nodeset v(xbgr.xr201.dt)=0.000000000000000e+00
.nodeset v(xbgr.xr202.dt)=0.000000000000000e+00
.nodeset v(xbgr.xr203.dt)=0.000000000000000e+00
.nodeset v(xbgr.xr204.dt)=0.000000000000000e+00
.nodeset v(xbgr.xr205.dt)=0.000000000000000e+00
.nodeset v(xbgr.xr206.dt)=0.000000000000000e+00
.nodeset v(xbgr.xr207.dt)=0.000000000000000e+00
.nodeset v(xbgr.xr208.dt)=0.000000000000000e+00
.nodeset v(xbgr.xr209.dt)=0.000000000000000e+00
.nodeset v(xbgr.xr210.dt)=0.000000000000000e+00
.nodeset v(xbgr.xr211.dt)=0.000000000000000e+00
.nodeset v(xbgr.xr212.dt)=0.000000000000000e+00
.nodeset v(xbgr.xr213.dt)=0.000000000000000e+00
.nodeset v(xbgr.xr214.dt)=0.000000000000000e+00
.nodeset v(xbgr.xr215.dt)=0.000000000000000e+00
.nodeset v(xbgr.xr216.dt)=0.000000000000000e+00
.nodeset v(xbgr.xr217.dt)=0.000000000000000e+00
.nodeset v(xbgr.xr218.dt)=0.000000000000000e+00
.nodeset v(xbgr.xr219.dt)=0.000000000000000e+00
.nodeset v(xbgr.xr220.dt)=0.000000000000000e+00
.nodeset v(xbgr.xr221.dt)=0.000000000000000e+00
.nodeset v(xbgr.xr222.dt)=0.000000000000000e+00
.nodeset v(xbgr.xr223.dt)=0.000000000000000e+00
.nodeset v(xbgr.xr224.dt)=0.000000000000000e+00
.nodeset v(xbgr.xr225.dt)=0.000000000000000e+00
.nodeset v(xbgr.xr226.dt)=0.000000000000000e+00
.nodeset v(xbgr.xr227.dt)=0.000000000000000e+00
.nodeset v(xbgr.xr228.dt)=0.000000000000000e+00
.nodeset v(xbgr.xr229.dt)=0.000000000000000e+00
.nodeset v(xbgr.xr230.dt)=0.000000000000000e+00
.nodeset v(xbgr.xr231.dt)=0.000000000000000e+00
.nodeset v(xbgr.xr232.dt)=0.000000000000000e+00
.nodeset v(xbgr.xr233.dt)=0.000000000000000e+00
.nodeset v(xbgr.xr234.dt)=0.000000000000000e+00
.nodeset v(xbgr.xr235.dt)=0.000000000000000e+00
.nodeset v(xbgr.xr236.dt)=0.000000000000000e+00
.nodeset v(xbgr.xr237.dt)=0.000000000000000e+00
.nodeset v(xbgr.xr238.dt)=0.000000000000000e+00
.nodeset v(xbgr.xr239.dt)=0.000000000000000e+00
.nodeset v(xbgr.xr240.dt)=0.000000000000000e+00
.nodeset v(xbgr.xr241.dt)=0.000000000000000e+00
.nodeset v(xbgr.xr242.dt)=0.000000000000000e+00
.nodeset v(xbgr.xr243.dt)=0.000000000000000e+00
.nodeset v(xbgr.xr244.dt)=0.000000000000000e+00
.nodeset v(xbgr.xr245.dt)=0.000000000000000e+00
.nodeset v(xbgr.xr246.dt)=0.000000000000000e+00
.nodeset v(xbgr.xr247.dt)=0.000000000000000e+00
.nodeset v(xbgr.xr248.dt)=0.000000000000000e+00
.nodeset v(xbgr.xr249.dt)=0.000000000000000e+00
.nodeset v(xbgr.xr250.dt)=0.000000000000000e+00
.nodeset v(xbgr.xr251.dt)=0.000000000000000e+00
.nodeset v(xbgr.xr252.dt)=0.000000000000000e+00
.nodeset v(xbgr.xr253.dt)=0.000000000000000e+00
.nodeset v(xbgr.xr254.dt)=0.000000000000000e+00
.nodeset v(xbgr.xr255.dt)=0.000000000000000e+00
.nodeset v(xbgr.xr256.dt)=0.000000000000000e+00
.nodeset v(xbgr.xr257.dt)=0.000000000000000e+00
.nodeset v(xbgr.xr258.dt)=0.000000000000000e+00
.nodeset v(xbgr.xr259.dt)=0.000000000000000e+00
.nodeset v(xbgr.xr260.dt)=0.000000000000000e+00
.nodeset v(xbgr.xr261.dt)=0.000000000000000e+00
.nodeset v(xbgr.xr262.dt)=0.000000000000000e+00
.nodeset v(xbgr.xr263.dt)=0.000000000000000e+00
.nodeset v(xbgr.xr264.dt)=0.000000000000000e+00
.nodeset v(xbgr.xr265.dt)=0.000000000000000e+00
.nodeset v(xbgr.xr266.dt)=0.000000000000000e+00
.nodeset v(xbgr.xr267.dt)=0.000000000000000e+00
.nodeset v(xbgr.xr268.dt)=0.000000000000000e+00
.nodeset v(xbgr.xr269.dt)=0.000000000000000e+00
.nodeset v(xbgr.xr270.dt)=0.000000000000000e+00
.nodeset v(xbgr.xr271.dt)=0.000000000000000e+00
.nodeset v(xbgr.xr272.dt)=0.000000000000000e+00
.nodeset v(xbgr.xr273.dt)=0.000000000000000e+00
.nodeset v(xbgr.xr274.dt)=0.000000000000000e+00
.nodeset v(xbgr.xr275.dt)=0.000000000000000e+00
.nodeset v(xbgr.xr276.dt)=0.000000000000000e+00
.nodeset v(xbgr.xr277.dt)=0.000000000000000e+00
.nodeset v(xbgr.xr278.dt)=0.000000000000000e+00
.nodeset v(xbgr.xr279.dt)=0.000000000000000e+00
.nodeset v(xbgr.xr280.dt)=0.000000000000000e+00
.nodeset v(xbgr.xr281.dt)=0.000000000000000e+00
.nodeset v(xbgr.xr282.dt)=0.000000000000000e+00
.nodeset v(xbgr.xr283.dt)=0.000000000000000e+00
.nodeset v(xbgr.xr284.dt)=0.000000000000000e+00
.nodeset v(xbgr.xr285.dt)=0.000000000000000e+00
.nodeset v(xbgr.xr286.dt)=0.000000000000000e+00
.nodeset v(xbgr.xr287.dt)=0.000000000000000e+00
.nodeset v(xbgr.xr288.dt)=0.000000000000000e+00
.nodeset v(xbgr.xr289.dt)=0.000000000000000e+00
.nodeset v(xbgr.xr290.dt)=0.000000000000000e+00
.nodeset v(xbgr.xr291.dt)=0.000000000000000e+00
.nodeset v(xbgr.xr292.dt)=0.000000000000000e+00
.nodeset v(xbgr.xr293.dt)=0.000000000000000e+00
.nodeset v(xbgr.xr294.dt)=0.000000000000000e+00
.nodeset v(xbgr.xr295.dt)=0.000000000000000e+00
.nodeset v(xbgr.xr296.dt)=0.000000000000000e+00
.nodeset v(xbgr.xr297.dt)=0.000000000000000e+00
.nodeset v(xbgr.xr298.dt)=0.000000000000000e+00
.nodeset v(xbgr.xr299.dt)=0.000000000000000e+00
.nodeset v(xbgr.xr300.dt)=0.000000000000000e+00
.nodeset v(xbgr.xr301.dt)=0.000000000000000e+00
.nodeset v(xbgr.xr302.dt)=0.000000000000000e+00
.nodeset v(xbgr.xr303.dt)=0.000000000000000e+00
.nodeset v(xbgr.xr304.dt)=0.000000000000000e+00
.nodeset v(xbgr.xr305.dt)=0.000000000000000e+00
.nodeset v(xbgr.xr306.dt)=0.000000000000000e+00
.nodeset v(xbgr.xr307.dt)=0.000000000000000e+00
.nodeset v(xbgr.xr308.dt)=0.000000000000000e+00
.nodeset v(xbgr.xr309.dt)=0.000000000000000e+00
.nodeset v(xbgr.xr310.dt)=0.000000000000000e+00
.nodeset v(xbgr.xr311.dt)=0.000000000000000e+00
.nodeset v(xbgr.xr312.dt)=0.000000000000000e+00
.nodeset v(xbgr.xr313.dt)=0.000000000000000e+00
.nodeset v(xbgr.xr314.dt)=0.000000000000000e+00
.nodeset v(xbgr.xr315.dt)=0.000000000000000e+00
.nodeset v(xbgr.xr316.dt)=0.000000000000000e+00
.nodeset v(xbgr.xr317.dt)=0.000000000000000e+00
.nodeset v(xbgr.xr318.dt)=0.000000000000000e+00
.nodeset v(xbgr.xr319.dt)=0.000000000000000e+00
.nodeset v(xbgr.xr320.dt)=0.000000000000000e+00
.nodeset v(xbgr.xr321.dt)=0.000000000000000e+00
.nodeset v(xbgr.xr322.dt)=0.000000000000000e+00
.nodeset v(xbgr.xr323.dt)=0.000000000000000e+00
.nodeset v(xbgr.xr324.dt)=0.000000000000000e+00
.nodeset v(xbgr.xr325.dt)=0.000000000000000e+00
.nodeset v(xbgr.xr326.dt)=0.000000000000000e+00
.nodeset v(xbgr.xr327.dt)=0.000000000000000e+00
.nodeset v(xbgr.xr328.dt)=0.000000000000000e+00
.nodeset v(xbgr.xr329.dt)=0.000000000000000e+00
.nodeset v(xbgr.xr330.dt)=0.000000000000000e+00
.nodeset v(xbgr.xr331.dt)=0.000000000000000e+00
.nodeset v(xbgr.xr332.dt)=0.000000000000000e+00
.nodeset v(xbgr.xr333.dt)=0.000000000000000e+00
.nodeset v(xbgr.xr334.dt)=0.000000000000000e+00
.nodeset v(xbgr.xr335.dt)=0.000000000000000e+00
.nodeset v(xbgr.xr336.dt)=0.000000000000000e+00
.nodeset v(xbgr.xr337.dt)=0.000000000000000e+00
.nodeset v(xbgr.xr338.dt)=0.000000000000000e+00
.nodeset v(xbgr.xr339.dt)=0.000000000000000e+00
.nodeset v(xbgr.xr340.dt)=0.000000000000000e+00
.nodeset v(xbgr.xr341.dt)=0.000000000000000e+00
.nodeset v(xbgr.xr342.dt)=0.000000000000000e+00
.nodeset v(xbgr.xr343.dt)=0.000000000000000e+00
.nodeset v(xbgr.xr344.dt)=0.000000000000000e+00
.nodeset v(xbgr.xr345.dt)=0.000000000000000e+00
.nodeset v(xbgr.xr346.dt)=0.000000000000000e+00
.nodeset v(xbgr.xr347.dt)=0.000000000000000e+00
.nodeset v(xbgr.xr348.dt)=0.000000000000000e+00
.nodeset v(xbgr.xr349.dt)=0.000000000000000e+00
.nodeset v(xbgr.xr350.dt)=0.000000000000000e+00
.nodeset v(xbgr.xr351.dt)=0.000000000000000e+00
.nodeset v(xbgr.xr352.dt)=0.000000000000000e+00
.nodeset v(xbgr.xr353.dt)=0.000000000000000e+00
.nodeset v(xbgr.xr354.dt)=0.000000000000000e+00
.nodeset v(xbgr.xr355.dt)=0.000000000000000e+00
.nodeset v(xbgr.xr356.dt)=0.000000000000000e+00
.nodeset v(xbgr.xr357.dt)=0.000000000000000e+00
.nodeset v(xbgr.xr358.dt)=0.000000000000000e+00
.nodeset v(xbgr.xr359.dt)=0.000000000000000e+00
.nodeset v(xbgr.xr360.dt)=0.000000000000000e+00
.nodeset v(xbgr.xr361.dt)=0.000000000000000e+00
.nodeset v(xbgr.xr362.dt)=0.000000000000000e+00
.nodeset v(xbgr.xr363.dt)=0.000000000000000e+00
.nodeset v(xbgr.xr364.dt)=0.000000000000000e+00
.nodeset v(xbgr.xr365.dt)=0.000000000000000e+00
.nodeset v(xbgr.xr366.dt)=0.000000000000000e+00
.nodeset v(xbgr.xr367.dt)=0.000000000000000e+00
.nodeset v(xbgr.xr368.dt)=0.000000000000000e+00
.nodeset v(xbgr.xr369.dt)=0.000000000000000e+00
.nodeset v(xbgr.xr370.dt)=0.000000000000000e+00
.nodeset v(xbgr.xr371.dt)=0.000000000000000e+00
.nodeset v(xbgr.xr372.dt)=0.000000000000000e+00
.nodeset v(xbgr.xr373.dt)=0.000000000000000e+00
.nodeset v(xbgr.xr374.dt)=0.000000000000000e+00
.nodeset v(xbgr.xr375.dt)=0.000000000000000e+00
.nodeset v(xbgr.xr376.dt)=0.000000000000000e+00
.nodeset v(xbgr.xr377.dt)=0.000000000000000e+00
.nodeset v(xbgr.xr378.dt)=0.000000000000000e+00
.nodeset v(xbgr.xr379.dt)=0.000000000000000e+00
.nodeset v(xbgr.xr380.dt)=0.000000000000000e+00
.nodeset v(xbgr.xr381.dt)=0.000000000000000e+00
.nodeset v(xbgr.xr382.dt)=0.000000000000000e+00
.nodeset v(xbgr.xr383.dt)=0.000000000000000e+00
.nodeset v(xbgr.xr384.dt)=0.000000000000000e+00
.nodeset v(xbgr.xr385.dt)=0.000000000000000e+00
.nodeset v(xbgr.xr386.dt)=0.000000000000000e+00
.nodeset v(xbgr.xr387.dt)=0.000000000000000e+00
.nodeset v(xbgr.xr388.dt)=0.000000000000000e+00
.nodeset v(xbgr.xr389.dt)=0.000000000000000e+00
.nodeset v(xbgr.xr390.dt)=0.000000000000000e+00
.nodeset v(xbgr.xr391.dt)=0.000000000000000e+00
.nodeset v(xbgr.xr392.dt)=0.000000000000000e+00
.nodeset v(xbgr.xr393.dt)=0.000000000000000e+00
.nodeset v(xbgr.xr394.dt)=0.000000000000000e+00
.nodeset v(xbgr.xr395.dt)=0.000000000000000e+00
.nodeset v(xbgr.xr396.dt)=0.000000000000000e+00
.nodeset v(xbgr.xr397.dt)=0.000000000000000e+00
.nodeset v(xbgr.xr398.dt)=0.000000000000000e+00
.nodeset v(xbgr.xr399.dt)=0.000000000000000e+00
.nodeset v(xbgr.gate_probe)=1.555375343256327e+00
.control
set num_threads=1
set numdgt=15
set wr_singlescale
set wr_vecnames
op
print v(vref) v(pbias) v(pcasc)
ac dec 100 1 1g
let ifout=-i(v.xbgr.vprobe)
let ve=v(xbgr.gate_probe)
wrdata ${BULK}/bgr586_ac_20260926/tian_pex_pcasc_ss125_current_ns.dat real(ifout) imag(ifout) real(ve) imag(ve)
echo RUN_END
quit
.endc
.end
