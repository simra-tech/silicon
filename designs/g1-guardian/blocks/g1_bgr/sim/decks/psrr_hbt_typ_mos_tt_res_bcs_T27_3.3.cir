* G1_BGR testbench PSRR: hbt=hbt_typ mos=mos_tt res=res_bcs vdd=3.3 V
.lib /foss/pdks/ihp-sg13g2/libs.tech/ngspice/models/cornerHBT.lib hbt_typ
.lib /foss/pdks/ihp-sg13g2/libs.tech/ngspice/models/cornerMOShv.lib mos_tt
.lib /foss/pdks/ihp-sg13g2/libs.tech/ngspice/models/cornerRES.lib res_bcs
.include ../../xschem/g1_bgr.spice
.option gmin=1e-15 abstol=1e-14 reltol=1e-5 vntol=1e-7
.global sub!
Vsub sub! 0 dc 0
Vdd vdd 0 dc 3.3 ac 1
Vr4 r4 0 dc 0
Xbgr vdd 0 r4 vref iptat pbias pcasc vbe dvbe g1_bgr
* PTAT output leg sinks into a 1.0 V node (top of a DAC string stand-in)
Vload iptat 0 dc 1.0
Cload vref 0 1p
.control
option temp=27
op
ac dec 10 1 10meg
let psrr_db = db(v(vref))
meas ac psrr_dc find psrr_db at=1
meas ac psrr_1k find psrr_db at=1k
meas ac psrr_100k find psrr_db at=100k
meas ac psrr_1m find psrr_db at=1meg
.endc

.end
