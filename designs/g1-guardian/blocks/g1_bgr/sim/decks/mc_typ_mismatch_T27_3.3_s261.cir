* G1_BGR testbench Monte Carlo mismatch seed 262: hbt=hbt_typ_mismatch mos=mos_tt_mismatch res=res_typ_mismatch vdd=3.3 V
.lib /foss/pdks/ihp-sg13g2/libs.tech/ngspice/models/cornerHBT.lib hbt_typ_mismatch
.lib /foss/pdks/ihp-sg13g2/libs.tech/ngspice/models/cornerMOShv.lib mos_tt_mismatch
.lib /foss/pdks/ihp-sg13g2/libs.tech/ngspice/models/cornerRES.lib res_typ_mismatch
.include ../../xschem/g1_bgr.spice
.option gmin=1e-15 abstol=1e-14 reltol=1e-5 vntol=1e-7
.global sub!
Vsub sub! 0 dc 0
Vdd vdd 0 dc 3.3
Vr4 r4 0 dc 0
Xbgr vdd 0 r4 vref iptat pbias pcasc vbe dvbe g1_bgr
* PTAT output leg sinks into a 1.0 V node (top of a DAC string stand-in)
Vload iptat 0 dc 1.0
Cload vref 0 1p
.option seed=262
.control
option temp=27
op
let iptat = i(vload)
let vref = v(vref)
let dvbe = v(dvbe)
print vref iptat dvbe
.endc

.end
