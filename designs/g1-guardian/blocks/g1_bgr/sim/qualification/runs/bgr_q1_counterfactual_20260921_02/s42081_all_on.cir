* BGR fixed-draw Q1 counterfactual
.lib /foss/pdks/ihp-sg13g2/libs.tech/ngspice/models/cornerHBT.lib hbt_typ_mismatch
.lib /foss/pdks/ihp-sg13g2/libs.tech/ngspice/models/cornerMOShv.lib mos_tt_mismatch
.lib /foss/pdks/ihp-sg13g2/libs.tech/ngspice/models/cornerRES.lib res_typ_mismatch
.include bgr.spice
.option seed=42081 gmin=1e-15 abstol=1e-14 reltol=1e-5 vntol=1e-7
.global sub!
Vsub sub! 0 0
Vdd vdd 0 3.3
Vr4 r4 0 0
Xbgr vdd 0 r4 vref iptat pbias pcasc vbe dvbe g1_bgr
Vload iptat 0 1
Cload vref 0 1p
.control
set num_threads=1
set numdgt=15
set wr_singlescale
set wr_vecnames
op
echo FINGERPRINT_BEFORE
print @n.xbgr.xr1.nr1[nsmm_rsh]
print @n.xbgr.xr2.nr1[nsmm_rsh]
print @n.xbgr.xr3.nr1[nsmm_rsh]
print @n.xbgr.xr4.nr1[nsmm_rsh]
print @n.xbgr.xr5.nr1[nsmm_rsh]
print @n.xbgr.xr6.nr1[nsmm_rsh]
print @n.xbgr.xr7.nr1[nsmm_rsh]
print @n.xbgr.xr8.nr1[nsmm_rsh]
print @n.xbgr.xr9.nr1[nsmm_rsh]
print @n.xbgr.xr10.nr1[nsmm_rsh]
print @n.xbgr.xr11.nr1[nsmm_rsh]
print @n.xbgr.xr12.nr1[nsmm_rsh]
print @n.xbgr.xr13.nr1[nsmm_rsh]
print @n.xbgr.xr14.nr1[nsmm_rsh]
print @n.xbgr.xr15.nr1[nsmm_rsh]
print @n.xbgr.xr16.nr1[nsmm_rsh]
print @n.xbgr.xr17.nr1[nsmm_rsh]
print @n.xbgr.xr18.nr1[nsmm_rsh]
print @n.xbgr.xr19.nr1[nsmm_rsh]
print @n.xbgr.xr20.nr1[nsmm_rsh]
print @n.xbgr.xr21.nr1[nsmm_rsh]
print @n.xbgr.xr22.nr1[nsmm_rsh]
print @n.xbgr.xr23.nr1[nsmm_rsh]
print @n.xbgr.xr24.nr1[nsmm_rsh]
print @n.xbgr.xr25.nr1[nsmm_rsh]
print @n.xbgr.xr26.nr1[nsmm_rsh]
print @n.xbgr.xm27.nsg13_hv_pmos[delvto]
print @n.xbgr.xm28.nsg13_hv_pmos[delvto]
print @n.xbgr.xm29.nsg13_hv_nmos[delvto]
print @n.xbgr.xm30.nsg13_hv_nmos[delvto]
print @n.xbgr.xm31.nsg13_hv_nmos[delvto]
print @n.xbgr.xm32.nsg13_hv_nmos[delvto]
print @n.xbgr.xm33.nsg13_hv_nmos[delvto]
print @n.xbgr.xm34.nsg13_hv_nmos[delvto]
print @n.xbgr.xm35.nsg13_hv_nmos[delvto]
print @n.xbgr.xm36.nsg13_hv_nmos[delvto]
print @n.xbgr.xm37.nsg13_hv_nmos[delvto]
print @n.xbgr.xm38.nsg13_hv_pmos[delvto]
print @n.xbgr.xm39.nsg13_hv_pmos[delvto]
print @n.xbgr.xm40.nsg13_hv_pmos[delvto]
print @n.xbgr.xm41.nsg13_hv_pmos[delvto]
print @n.xbgr.xm42.nsg13_hv_pmos[delvto]
print @n.xbgr.xm43.nsg13_hv_pmos[delvto]
print @n.xbgr.xm44.nsg13_hv_pmos[delvto]
print @n.xbgr.xm45.nsg13_hv_pmos[delvto]
print @n.xbgr.xm46.nsg13_hv_pmos[delvto]
print @n.xbgr.xm47.nsg13_hv_pmos[delvto]
print @n.xbgr.xm48.nsg13_hv_pmos[delvto]
print @n.xbgr.xm49.nsg13_hv_pmos[delvto]
print @n.xbgr.xm50.nsg13_hv_pmos[delvto]
print @n.xbgr.xm51.nsg13_hv_pmos[delvto]
print @n.xbgr.xm52.nsg13_hv_pmos[delvto]
print @n.xbgr.xm53.nsg13_hv_pmos[delvto]
print @n.xbgr.xm54.nsg13_hv_pmos[delvto]
print @q.xbgr.xq55.qnpn13g2[area]
print @q.xbgr.xq56.qnpn13g2[area]
print @q.xbgr.xq57.qnpn13g2[area]
print @q.xbgr.xq58.qnpn13g2[area]
print @q.xbgr.xq59.qnpn13g2[area]
print @q.xbgr.xq60.qnpn13g2[area]
print @q.xbgr.xq61.qnpn13g2[area]
print @q.xbgr.xq62.qnpn13g2[area]
print @q.xbgr.xq63.qnpn13g2[area]
print @q.xbgr.xq64.qnpn13g2[area]
print @q.xbgr.xq65.qnpn13g2[area]
print @q.xbgr.xq66.qnpn13g2[area]
print @q.xbgr.xq67.qnpn13g2[area]
print @q.xbgr.xq68.qnpn13g2[area]
print @q.xbgr.xq69.qnpn13g2[area]
print @q.xbgr.xq70.qnpn13g2[area]
print @q.xbgr.xq71.qnpn13g2[area]
print @q.xbgr.xq72.qnpn13g2[area]
print @q.xbgr.xq73.qnpn13g2[area]
print @q.xbgr.xq74.qnpn13g2[area]
print @q.xbgr.xq75.qnpn13g2[area]
print @q.xbgr.xq76.qnpn13g2[area]
print @n.xbgr.xr77.nr1[nsmm_rsh]
print @n.xbgr.xr78.nr1[nsmm_rsh]
print @n.xbgr.xr79.nr1[nsmm_rsh]
print @n.xbgr.xr80.nr1[nsmm_rsh]
print @n.xbgr.xr81.nr1[nsmm_rsh]
print @n.xbgr.xr82.nr1[nsmm_rsh]
print @n.xbgr.xr83.nr1[nsmm_rsh]
print @n.xbgr.xr84.nr1[nsmm_rsh]
print @n.xbgr.xr85.nr1[nsmm_rsh]
print @n.xbgr.xr86.nr1[nsmm_rsh]
echo FINGERPRINT_AFTER_ALTER
print @n.xbgr.xr1.nr1[nsmm_rsh]
print @n.xbgr.xr2.nr1[nsmm_rsh]
print @n.xbgr.xr3.nr1[nsmm_rsh]
print @n.xbgr.xr4.nr1[nsmm_rsh]
print @n.xbgr.xr5.nr1[nsmm_rsh]
print @n.xbgr.xr6.nr1[nsmm_rsh]
print @n.xbgr.xr7.nr1[nsmm_rsh]
print @n.xbgr.xr8.nr1[nsmm_rsh]
print @n.xbgr.xr9.nr1[nsmm_rsh]
print @n.xbgr.xr10.nr1[nsmm_rsh]
print @n.xbgr.xr11.nr1[nsmm_rsh]
print @n.xbgr.xr12.nr1[nsmm_rsh]
print @n.xbgr.xr13.nr1[nsmm_rsh]
print @n.xbgr.xr14.nr1[nsmm_rsh]
print @n.xbgr.xr15.nr1[nsmm_rsh]
print @n.xbgr.xr16.nr1[nsmm_rsh]
print @n.xbgr.xr17.nr1[nsmm_rsh]
print @n.xbgr.xr18.nr1[nsmm_rsh]
print @n.xbgr.xr19.nr1[nsmm_rsh]
print @n.xbgr.xr20.nr1[nsmm_rsh]
print @n.xbgr.xr21.nr1[nsmm_rsh]
print @n.xbgr.xr22.nr1[nsmm_rsh]
print @n.xbgr.xr23.nr1[nsmm_rsh]
print @n.xbgr.xr24.nr1[nsmm_rsh]
print @n.xbgr.xr25.nr1[nsmm_rsh]
print @n.xbgr.xr26.nr1[nsmm_rsh]
print @n.xbgr.xm27.nsg13_hv_pmos[delvto]
print @n.xbgr.xm28.nsg13_hv_pmos[delvto]
print @n.xbgr.xm29.nsg13_hv_nmos[delvto]
print @n.xbgr.xm30.nsg13_hv_nmos[delvto]
print @n.xbgr.xm31.nsg13_hv_nmos[delvto]
print @n.xbgr.xm32.nsg13_hv_nmos[delvto]
print @n.xbgr.xm33.nsg13_hv_nmos[delvto]
print @n.xbgr.xm34.nsg13_hv_nmos[delvto]
print @n.xbgr.xm35.nsg13_hv_nmos[delvto]
print @n.xbgr.xm36.nsg13_hv_nmos[delvto]
print @n.xbgr.xm37.nsg13_hv_nmos[delvto]
print @n.xbgr.xm38.nsg13_hv_pmos[delvto]
print @n.xbgr.xm39.nsg13_hv_pmos[delvto]
print @n.xbgr.xm40.nsg13_hv_pmos[delvto]
print @n.xbgr.xm41.nsg13_hv_pmos[delvto]
print @n.xbgr.xm42.nsg13_hv_pmos[delvto]
print @n.xbgr.xm43.nsg13_hv_pmos[delvto]
print @n.xbgr.xm44.nsg13_hv_pmos[delvto]
print @n.xbgr.xm45.nsg13_hv_pmos[delvto]
print @n.xbgr.xm46.nsg13_hv_pmos[delvto]
print @n.xbgr.xm47.nsg13_hv_pmos[delvto]
print @n.xbgr.xm48.nsg13_hv_pmos[delvto]
print @n.xbgr.xm49.nsg13_hv_pmos[delvto]
print @n.xbgr.xm50.nsg13_hv_pmos[delvto]
print @n.xbgr.xm51.nsg13_hv_pmos[delvto]
print @n.xbgr.xm52.nsg13_hv_pmos[delvto]
print @n.xbgr.xm53.nsg13_hv_pmos[delvto]
print @n.xbgr.xm54.nsg13_hv_pmos[delvto]
print @q.xbgr.xq55.qnpn13g2[area]
print @q.xbgr.xq56.qnpn13g2[area]
print @q.xbgr.xq57.qnpn13g2[area]
print @q.xbgr.xq58.qnpn13g2[area]
print @q.xbgr.xq59.qnpn13g2[area]
print @q.xbgr.xq60.qnpn13g2[area]
print @q.xbgr.xq61.qnpn13g2[area]
print @q.xbgr.xq62.qnpn13g2[area]
print @q.xbgr.xq63.qnpn13g2[area]
print @q.xbgr.xq64.qnpn13g2[area]
print @q.xbgr.xq65.qnpn13g2[area]
print @q.xbgr.xq66.qnpn13g2[area]
print @q.xbgr.xq67.qnpn13g2[area]
print @q.xbgr.xq68.qnpn13g2[area]
print @q.xbgr.xq69.qnpn13g2[area]
print @q.xbgr.xq70.qnpn13g2[area]
print @q.xbgr.xq71.qnpn13g2[area]
print @q.xbgr.xq72.qnpn13g2[area]
print @q.xbgr.xq73.qnpn13g2[area]
print @q.xbgr.xq74.qnpn13g2[area]
print @q.xbgr.xq75.qnpn13g2[area]
print @q.xbgr.xq76.qnpn13g2[area]
print @n.xbgr.xr77.nr1[nsmm_rsh]
print @n.xbgr.xr78.nr1[nsmm_rsh]
print @n.xbgr.xr79.nr1[nsmm_rsh]
print @n.xbgr.xr80.nr1[nsmm_rsh]
print @n.xbgr.xr81.nr1[nsmm_rsh]
print @n.xbgr.xr82.nr1[nsmm_rsh]
print @n.xbgr.xr83.nr1[nsmm_rsh]
print @n.xbgr.xr84.nr1[nsmm_rsh]
print @n.xbgr.xr85.nr1[nsmm_rsh]
print @n.xbgr.xr86.nr1[nsmm_rsh]
dc temp -40 125 5
echo FINGERPRINT_AFTER_SWEEP
print @n.xbgr.xr1.nr1[nsmm_rsh]
print @n.xbgr.xr2.nr1[nsmm_rsh]
print @n.xbgr.xr3.nr1[nsmm_rsh]
print @n.xbgr.xr4.nr1[nsmm_rsh]
print @n.xbgr.xr5.nr1[nsmm_rsh]
print @n.xbgr.xr6.nr1[nsmm_rsh]
print @n.xbgr.xr7.nr1[nsmm_rsh]
print @n.xbgr.xr8.nr1[nsmm_rsh]
print @n.xbgr.xr9.nr1[nsmm_rsh]
print @n.xbgr.xr10.nr1[nsmm_rsh]
print @n.xbgr.xr11.nr1[nsmm_rsh]
print @n.xbgr.xr12.nr1[nsmm_rsh]
print @n.xbgr.xr13.nr1[nsmm_rsh]
print @n.xbgr.xr14.nr1[nsmm_rsh]
print @n.xbgr.xr15.nr1[nsmm_rsh]
print @n.xbgr.xr16.nr1[nsmm_rsh]
print @n.xbgr.xr17.nr1[nsmm_rsh]
print @n.xbgr.xr18.nr1[nsmm_rsh]
print @n.xbgr.xr19.nr1[nsmm_rsh]
print @n.xbgr.xr20.nr1[nsmm_rsh]
print @n.xbgr.xr21.nr1[nsmm_rsh]
print @n.xbgr.xr22.nr1[nsmm_rsh]
print @n.xbgr.xr23.nr1[nsmm_rsh]
print @n.xbgr.xr24.nr1[nsmm_rsh]
print @n.xbgr.xr25.nr1[nsmm_rsh]
print @n.xbgr.xr26.nr1[nsmm_rsh]
print @n.xbgr.xm27.nsg13_hv_pmos[delvto]
print @n.xbgr.xm28.nsg13_hv_pmos[delvto]
print @n.xbgr.xm29.nsg13_hv_nmos[delvto]
print @n.xbgr.xm30.nsg13_hv_nmos[delvto]
print @n.xbgr.xm31.nsg13_hv_nmos[delvto]
print @n.xbgr.xm32.nsg13_hv_nmos[delvto]
print @n.xbgr.xm33.nsg13_hv_nmos[delvto]
print @n.xbgr.xm34.nsg13_hv_nmos[delvto]
print @n.xbgr.xm35.nsg13_hv_nmos[delvto]
print @n.xbgr.xm36.nsg13_hv_nmos[delvto]
print @n.xbgr.xm37.nsg13_hv_nmos[delvto]
print @n.xbgr.xm38.nsg13_hv_pmos[delvto]
print @n.xbgr.xm39.nsg13_hv_pmos[delvto]
print @n.xbgr.xm40.nsg13_hv_pmos[delvto]
print @n.xbgr.xm41.nsg13_hv_pmos[delvto]
print @n.xbgr.xm42.nsg13_hv_pmos[delvto]
print @n.xbgr.xm43.nsg13_hv_pmos[delvto]
print @n.xbgr.xm44.nsg13_hv_pmos[delvto]
print @n.xbgr.xm45.nsg13_hv_pmos[delvto]
print @n.xbgr.xm46.nsg13_hv_pmos[delvto]
print @n.xbgr.xm47.nsg13_hv_pmos[delvto]
print @n.xbgr.xm48.nsg13_hv_pmos[delvto]
print @n.xbgr.xm49.nsg13_hv_pmos[delvto]
print @n.xbgr.xm50.nsg13_hv_pmos[delvto]
print @n.xbgr.xm51.nsg13_hv_pmos[delvto]
print @n.xbgr.xm52.nsg13_hv_pmos[delvto]
print @n.xbgr.xm53.nsg13_hv_pmos[delvto]
print @n.xbgr.xm54.nsg13_hv_pmos[delvto]
print @q.xbgr.xq55.qnpn13g2[area]
print @q.xbgr.xq56.qnpn13g2[area]
print @q.xbgr.xq57.qnpn13g2[area]
print @q.xbgr.xq58.qnpn13g2[area]
print @q.xbgr.xq59.qnpn13g2[area]
print @q.xbgr.xq60.qnpn13g2[area]
print @q.xbgr.xq61.qnpn13g2[area]
print @q.xbgr.xq62.qnpn13g2[area]
print @q.xbgr.xq63.qnpn13g2[area]
print @q.xbgr.xq64.qnpn13g2[area]
print @q.xbgr.xq65.qnpn13g2[area]
print @q.xbgr.xq66.qnpn13g2[area]
print @q.xbgr.xq67.qnpn13g2[area]
print @q.xbgr.xq68.qnpn13g2[area]
print @q.xbgr.xq69.qnpn13g2[area]
print @q.xbgr.xq70.qnpn13g2[area]
print @q.xbgr.xq71.qnpn13g2[area]
print @q.xbgr.xq72.qnpn13g2[area]
print @q.xbgr.xq73.qnpn13g2[area]
print @q.xbgr.xq74.qnpn13g2[area]
print @q.xbgr.xq75.qnpn13g2[area]
print @q.xbgr.xq76.qnpn13g2[area]
print @n.xbgr.xr77.nr1[nsmm_rsh]
print @n.xbgr.xr78.nr1[nsmm_rsh]
print @n.xbgr.xr79.nr1[nsmm_rsh]
print @n.xbgr.xr80.nr1[nsmm_rsh]
print @n.xbgr.xr81.nr1[nsmm_rsh]
print @n.xbgr.xr82.nr1[nsmm_rsh]
print @n.xbgr.xr83.nr1[nsmm_rsh]
print @n.xbgr.xr84.nr1[nsmm_rsh]
print @n.xbgr.xr85.nr1[nsmm_rsh]
print @n.xbgr.xr86.nr1[nsmm_rsh]
wrdata s42081_all_on.dat v(vref) i(vload) i(vdd) v(vbe) v(dvbe) v(pbias) v(pcasc) v(xbgr.c2) v(xbgr.vbe3) v(xbgr.vd1) v(xbgr.vd2)
quit
.endc
.end
