* Frozen loaded BGR stationary source-impedance fixture
.param VDDA=3.6 VDD=1.32 VREF=1.04
.lib /foss/pdks/ihp-sg13g2/libs.tech/ngspice/models/cornerMOSlv.lib mos_ff
.lib /foss/pdks/ihp-sg13g2/libs.tech/ngspice/models/cornerMOShv.lib mos_ff
.lib /foss/pdks/ihp-sg13g2/libs.tech/ngspice/models/cornerRES.lib res_bcs
.lib /foss/pdks/ihp-sg13g2/libs.tech/ngspice/models/cornerCAP.lib cap_bcs
.temp 125
* the off switches leave the mux tree nodes floating at DC: give the solver a 1 TOhm path per node
.option rshunt=1e12 gmin=1e-13
.include sense.spice
.include trip.spice
Vdda vdda 0 dc {VDDA}
Vdd vdd 0 dc {VDD}
Vsh shp 0 dc .025 ac 1
XS shp 0 vref iptat isense vped vref_buf vdda 0 g1_sense
CL isense 0 300f
* soft code 153 = 1001 1001b (30.0 mV) ; hard code 254 = 1111 1110b (49.8 mV)
Vs0 s0 0 dc 1.32
Vs1 s1 0 dc 0
Vs2 s2 0 dc 0
Vs3 s3 0 dc 1.32
Vs4 s4 0 dc 1.32
Vs5 s5 0 dc 0
Vs6 s6 0 dc 0
Vs7 s7 0 dc 1.32
Vh0 h0 0 dc 0
Vh1 h1 0 dc 1.32
Vh2 h2 0 dc 1.32
Vh3 h3 0 dc 1.32
Vh4 h4 0 dc 1.32
Vh5 h5 0 dc 1.32
Vh6 h6 0 dc 1.32
Vh7 h7 0 dc 1.32
Vclk clk 0 dc 0
XT isense vref_buf clk s0 s1 s2 s3 s4 s5 s6 s7 h0 h1 h2 h3 h4 h5 h6 h7 cmp_soft cmp_hard vdd vdda 0 g1_trip
Cs cmp_soft 0 10f
Ch cmp_hard 0 10f
* keep only the nodes of interest (the full 1200-device transient exhausts the output memory)
.lib /foss/pdks/ihp-sg13g2/libs.tech/ngspice/models/cornerHBT.lib hbt_bcs
.include bgr.spice
Vr4 r4 0 0
Xbgr bgr_supply 0 r4 bgr_vref bgr_iptat pbias pcasc vbe dvbe g1_bgr
.global sub!
Vsub sub! 0 0
.option gmin=1e-15 abstol=1e-14 reltol=1e-5 vntol=1e-7
.option gmin=1e-15 reltol=1e-5 vntol=1e-7 abstol=1e-14
.option klu

Vsupply vdda bgr_supply 0
Vsref bgr_vref vref 0
Vsptat bgr_iptat iptat 0
Iprobe 0 vref dc 0 ac 0
.save v(vref) v(iptat) v(vref_buf) v(isense) v(vped) v(pbias) v(pcasc) v(xt.icmp) v(xt.vth_soft) v(xt.vth_hard) i(vdda) i(vsupply) i(vsref) i(vsptat)
.control
set num_threads=1
set numdgt=15
set wr_vecnames
set wr_singlescale
op
wrdata shunt_op.dat v(vref) v(iptat) v(vref_buf) v(isense) v(vped) v(pbias) v(pcasc) v(xt.icmp) v(xt.vth_soft) v(xt.vth_hard) i(vdda) i(vsupply) i(vsref) i(vsptat)
ac dec 50 .1 100Meg
let r0 = real(v(vref))
let j0 = imag(v(vref))
let r1 = real(v(iptat))
let j1 = imag(v(iptat))
let r2 = real(v(vref_buf))
let j2 = imag(v(vref_buf))
let r3 = real(v(isense))
let j3 = imag(v(isense))
let r4 = real(v(vped))
let j4 = imag(v(vped))
let r5 = real(v(pbias))
let j5 = imag(v(pbias))
let r6 = real(v(pcasc))
let j6 = imag(v(pcasc))
let r7 = real(v(xt.icmp))
let j7 = imag(v(xt.icmp))
let r8 = real(v(xt.vth_soft))
let j8 = imag(v(xt.vth_soft))
let r9 = real(v(xt.vth_hard))
let j9 = imag(v(xt.vth_hard))
let r10 = real(i(vdda))
let j10 = imag(i(vdda))
let r11 = real(i(vsupply))
let j11 = imag(i(vsupply))
let r12 = real(i(vsref))
let j12 = imag(i(vsref))
let r13 = real(i(vsptat))
let j13 = imag(i(vsptat))
wrdata shunt_ac.dat r0 j0 r1 j1 r2 j2 r3 j3 r4 j4 r5 j5 r6 j6 r7 j7 r8 j8 r9 j9 r10 j10 r11 j11 r12 j12 r13 j13
quit
.endc
.end
