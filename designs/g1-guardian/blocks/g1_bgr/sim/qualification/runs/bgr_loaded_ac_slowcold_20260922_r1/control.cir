* Frozen loaded BGR stationary source-impedance fixture
.param VDDA=3.0 VDD=1.08 VREF=1.04
.lib /foss/pdks/ihp-sg13g2/libs.tech/ngspice/models/cornerMOSlv.lib mos_ss
.lib /foss/pdks/ihp-sg13g2/libs.tech/ngspice/models/cornerMOShv.lib mos_ss
.lib /foss/pdks/ihp-sg13g2/libs.tech/ngspice/models/cornerRES.lib res_wcs
.lib /foss/pdks/ihp-sg13g2/libs.tech/ngspice/models/cornerCAP.lib cap_wcs
.temp -40
* the off switches leave the mux tree nodes floating at DC: give the solver a 1 TOhm path per node
.option rshunt=1e12 gmin=1e-13
.include sense.spice
.include trip.spice
Vdda vdda 0 dc {VDDA}
Vdd vdd 0 dc {VDD}
Vsh shp 0 dc .025
XS shp 0 vref iptat isense vped vref_buf vdda 0 g1_sense
CL isense 0 300f
* soft code 153 = 1001 1001b (30.0 mV) ; hard code 254 = 1111 1110b (49.8 mV)
Vs0 s0 0 dc 1.08
Vs1 s1 0 dc 0
Vs2 s2 0 dc 0
Vs3 s3 0 dc 1.08
Vs4 s4 0 dc 1.08
Vs5 s5 0 dc 0
Vs6 s6 0 dc 0
Vs7 s7 0 dc 1.08
Vh0 h0 0 dc 0
Vh1 h1 0 dc 1.08
Vh2 h2 0 dc 1.08
Vh3 h3 0 dc 1.08
Vh4 h4 0 dc 1.08
Vh5 h5 0 dc 1.08
Vh6 h6 0 dc 1.08
Vh7 h7 0 dc 1.08
Vclk clk 0 dc 0
XT isense vref_buf clk s0 s1 s2 s3 s4 s5 s6 s7 h0 h1 h2 h3 h4 h5 h6 h7 cmp_soft cmp_hard vdd vdda 0 g1_trip
Cs cmp_soft 0 10f
Ch cmp_hard 0 10f
* keep only the nodes of interest (the full 1200-device transient exhausts the output memory)
.lib /foss/pdks/ihp-sg13g2/libs.tech/ngspice/models/cornerHBT.lib hbt_wcs
.include bgr.spice
Vr4 r4 0 0
Xbgr vdda 0 r4 vref iptat pbias pcasc vbe dvbe g1_bgr
.global sub!
Vsub sub! 0 0
.option gmin=1e-15 abstol=1e-14 reltol=1e-5 vntol=1e-7
.option gmin=1e-15 reltol=1e-5 vntol=1e-7 abstol=1e-14
.option klu
.save v(vref) v(iptat) v(vref_buf) v(isense) v(vped) v(pbias) v(pcasc) v(xt.icmp) v(xt.vth_soft) v(xt.vth_hard) i(vdda)
.control
set num_threads=1
set numdgt=15
set wr_vecnames
set wr_singlescale
op
wrdata control_op.dat v(vref) v(iptat) v(vref_buf) v(isense) v(vped) v(pbias) v(pcasc) v(xt.icmp) v(xt.vth_soft) v(xt.vth_hard) i(vdda)
quit
.endc
.end
