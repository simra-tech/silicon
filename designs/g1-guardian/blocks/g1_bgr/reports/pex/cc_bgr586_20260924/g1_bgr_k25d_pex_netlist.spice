*********************************************************
*** NGSPICE file created by KLayout-PEX 0.3.12
*** -----------------------------------------------------
***     Extraction Engine: KPEX/2.5D
***     Technology: ihp_sg13g2
***     Date: 2026-09-24 13:35:56
*********************************************************

.SUBCKT g1_bgr dvbe iptat pbias pcasc r4 vbe vdd vref vss
R$1 \$I43 vref vss 1 rppd l=53.465 ps=0 b=0 m=1
R$2 \$I42 \$17 vss 1 rppd l=53.465 ps=0 b=0 m=1
R$3 \$I42 \$17 vss 1 rppd l=53.465 ps=0 b=0 m=1
R$4 \$I42 \$I39 vss 1 rppd l=53.465 ps=0 b=0 m=1
R$5 \$I29 \$I39 vss 1 rppd l=53.465 ps=0 b=0 m=1
R$6 \$I29 \$I39 vss 1 rppd l=53.465 ps=0 b=0 m=1
R$7 \$I43 vref vss 1 rppd l=53.465 ps=0 b=0 m=1
R$8 \$I43 vref vss 1 rppd l=53.465 ps=0 b=0 m=1
R$9 \$I29 \$I36 vss 1 rppd l=53.465 ps=0 b=0 m=1
R$10 \$I29 \$I36 vss 1 rppd l=53.465 ps=0 b=0 m=1
R$11 \$I43 \$I36 vss 1 rppd l=53.465 ps=0 b=0 m=1
R$12 \$I43 \$I36 vss 1 rppd l=53.465 ps=0 b=0 m=1
R$13 \$I29 \$I39 vss 1 rppd l=53.465 ps=0 b=0 m=1
R$14 \$I42 \$I39 vss 1 rppd l=53.465 ps=0 b=0 m=1
R$15 \$I43 \$I36 vss 1 rppd l=53.465 ps=0 b=0 m=1
R$16 \$I29 \$I39 vss 1 rppd l=53.465 ps=0 b=0 m=1
R$17 \$I43 vref vss 1 rppd l=53.465 ps=0 b=0 m=1
R$18 \$I29 \$I36 vss 1 rppd l=53.465 ps=0 b=0 m=1
R$19 \$I29 \$I36 vss 1 rppd l=53.465 ps=0 b=0 m=1
R$20 \$I42 \$17 vss 1 rppd l=53.465 ps=0 b=0 m=1
R$21 \$I43 \$I36 vss 1 rppd l=53.465 ps=0 b=0 m=1
R$22 \$I42 \$I39 vss 1 rppd l=53.465 ps=0 b=0 m=1
R$23 \$I42 \$I39 vss 1 rppd l=53.465 ps=0 b=0 m=1
R$24 \$I42 \$17 vss 1 rppd l=53.465 ps=0 b=0 m=1
R$25 vss \$I31 vss 0.5 rhigh l=49 ps=0 b=0 m=1
R$26 \$I17 \$I33 vss 0.5 rhigh l=49 ps=0 b=0 m=1
R$27 \$I16 \$I33 vss 0.5 rhigh l=49 ps=0 b=0 m=1
R$28 \$I19 \$I32 vss 0.5 rhigh l=49 ps=0 b=0 m=1
R$29 \$I15 \$I32 vss 0.5 rhigh l=49 ps=0 b=0 m=1
R$30 \$I16 \$I28 vss 0.5 rhigh l=49 ps=0 b=0 m=1
R$31 \$I15 \$10 vss 0.5 rhigh l=49 ps=0 b=0 m=1
R$32 \$I17 \$I31 vss 0.5 rhigh l=49 ps=0 b=0 m=1
R$33 \$I19 \$I25 vss 0.5 rhigh l=49 ps=0 b=0 m=1
R$34 \$I22 \$I27 vss 0.5 rhigh l=49 ps=0 b=0 m=1
R$35 \$I22 \$I28 vss 0.5 rhigh l=49 ps=0 b=0 m=1
R$36 \$I20 \$I25 vss 0.5 rhigh l=49 ps=0 b=0 m=1
R$37 \$I21 \$I26 vss 0.5 rhigh l=49 ps=0 b=0 m=1
R$38 \$I20 \$I26 vss 0.5 rhigh l=49 ps=0 b=0 m=1
R$39 \$I21 \$I27 vss 0.5 rhigh l=49 ps=0 b=0 m=1
R$40 vss dvbe vss 1 rppd l=51.5 ps=0 b=0 m=1
R$41 vss dvbe vss 1 rppd l=51.5 ps=0 b=0 m=1
R$42 vss dvbe vss 1 rppd l=51.5 ps=0 b=0 m=1
R$43 vss dvbe vss 1 rppd l=51.5 ps=0 b=0 m=1
R$44 vss dvbe vss 1 rppd l=51.5 ps=0 b=0 m=1
R$45 vss dvbe vss 1 rppd l=51.5 ps=0 b=0 m=1
R$46 vss dvbe vss 1 rppd l=51.5 ps=0 b=0 m=1
R$47 vss dvbe vss 1 rppd l=51.5 ps=0 b=0 m=1
R$48 vss dvbe vss 1 rppd l=51.5 ps=0 b=0 m=1
R$49 vss dvbe vss 1 rppd l=51.5 ps=0 b=0 m=1
R$50 vss dvbe vss 1 rppd l=51.5 ps=0 b=0 m=1
R$51 vss dvbe vss 1 rppd l=51.5 ps=0 b=0 m=1
R$52 vss dvbe vss 1 rppd l=51.5 ps=0 b=0 m=1
R$53 vss dvbe vss 1 rppd l=51.5 ps=0 b=0 m=1
R$54 vss dvbe vss 1 rppd l=51.5 ps=0 b=0 m=1
R$55 vss dvbe vss 1 rppd l=51.5 ps=0 b=0 m=1
R$56 vss dvbe vss 1 rppd l=51.5 ps=0 b=0 m=1
R$57 vss dvbe vss 1 rppd l=51.5 ps=0 b=0 m=1
R$58 vss dvbe vss 1 rppd l=51.5 ps=0 b=0 m=1
R$59 vss dvbe vss 1 rppd l=51.5 ps=0 b=0 m=1
R$60 vss dvbe vss 1 rppd l=51.5 ps=0 b=0 m=1
R$61 vss dvbe vss 1 rppd l=51.5 ps=0 b=0 m=1
R$62 vss dvbe vss 1 rppd l=51.5 ps=0 b=0 m=1
R$63 vss dvbe vss 1 rppd l=51.5 ps=0 b=0 m=1
R$64 \$I13 \$16 vss 1 rppd l=48 ps=0 b=0 m=1
R$65 \$I13 \$16 vss 1 rppd l=48 ps=0 b=0 m=1
R$66 \$I13 \$I24 vss 1 rppd l=48 ps=0 b=0 m=1
R$67 \$I14 \$18 vss 1 rppd l=48 ps=0 b=0 m=1
R$68 \$I13 \$16 vss 1 rppd l=48 ps=0 b=0 m=1
R$69 \$I14 \$18 vss 1 rppd l=48 ps=0 b=0 m=1
R$70 \$I14 \$18 vss 1 rppd l=48 ps=0 b=0 m=1
R$71 \$I14 \$18 vss 1 rppd l=48 ps=0 b=0 m=1
R$72 \$I13 \$16 vss 1 rppd l=48 ps=0 b=0 m=1
R$73 \$I14 \$18 vss 1 rppd l=48 ps=0 b=0 m=1
R$74 \$I14 \$18 vss 1 rppd l=48 ps=0 b=0 m=1
R$75 \$I14 \$18 vss 1 rppd l=48 ps=0 b=0 m=1
R$76 \$I13 \$16 vss 1 rppd l=48 ps=0 b=0 m=1
R$77 \$I14 \$I24 vss 1 rppd l=48 ps=0 b=0 m=1
R$78 \$I14 \$I24 vss 1 rppd l=48 ps=0 b=0 m=1
R$79 \$I14 \$I24 vss 1 rppd l=48 ps=0 b=0 m=1
R$80 \$I14 \$I24 vss 1 rppd l=48 ps=0 b=0 m=1
R$81 \$I14 \$I24 vss 1 rppd l=48 ps=0 b=0 m=1
R$82 \$I14 \$I24 vss 1 rppd l=48 ps=0 b=0 m=1
R$83 \$I14 \$I24 vss 1 rppd l=48 ps=0 b=0 m=1
R$84 \$I14 \$I24 vss 1 rppd l=48 ps=0 b=0 m=1
R$85 \$I14 \$I24 vss 1 rppd l=48 ps=0 b=0 m=1
R$86 \$I14 \$I24 vss 1 rppd l=48 ps=0 b=0 m=1
R$87 \$I14 \$I24 vss 1 rppd l=48 ps=0 b=0 m=1
R$88 \$I14 \$I24 vss 1 rppd l=48 ps=0 b=0 m=1
R$89 \$I14 \$I24 vss 1 rppd l=48 ps=0 b=0 m=1
R$90 \$I14 \$I24 vss 1 rppd l=48 ps=0 b=0 m=1
R$91 \$I13 \$I24 vss 1 rppd l=48 ps=0 b=0 m=1
R$92 \$I14 \$I24 vss 1 rppd l=48 ps=0 b=0 m=1
R$93 \$I13 \$I24 vss 1 rppd l=48 ps=0 b=0 m=1
R$94 \$I14 \$18 vss 1 rppd l=48 ps=0 b=0 m=1
R$95 \$I14 \$I24 vss 1 rppd l=48 ps=0 b=0 m=1
R$96 \$I14 \$I24 vss 1 rppd l=48 ps=0 b=0 m=1
R$97 \$I13 \$I24 vss 1 rppd l=48 ps=0 b=0 m=1
R$98 \$I13 \$16 vss 1 rppd l=48 ps=0 b=0 m=1
R$99 \$I14 \$18 vss 1 rppd l=48 ps=0 b=0 m=1
R$100 \$I13 \$I24 vss 1 rppd l=48 ps=0 b=0 m=1
R$101 \$I13 \$16 vss 1 rppd l=48 ps=0 b=0 m=1
R$102 \$I14 \$18 vss 1 rppd l=48 ps=0 b=0 m=1
R$103 \$I13 \$16 vss 1 rppd l=48 ps=0 b=0 m=1
R$104 \$I14 \$I24 vss 1 rppd l=48 ps=0 b=0 m=1
R$105 \$I13 \$I24 vss 1 rppd l=48 ps=0 b=0 m=1
R$106 \$I13 \$16 vss 1 rppd l=48 ps=0 b=0 m=1
R$107 \$I13 \$I24 vss 1 rppd l=48 ps=0 b=0 m=1
R$108 \$I13 \$I24 vss 1 rppd l=48 ps=0 b=0 m=1
R$109 \$I13 \$16 vss 1 rppd l=48 ps=0 b=0 m=1
R$110 \$I13 \$I24 vss 1 rppd l=48 ps=0 b=0 m=1
R$111 \$I14 \$18 vss 1 rppd l=48 ps=0 b=0 m=1
R$112 \$I13 \$16 vss 1 rppd l=48 ps=0 b=0 m=1
R$113 \$I13 \$I24 vss 1 rppd l=48 ps=0 b=0 m=1
R$114 \$I13 \$I24 vss 1 rppd l=48 ps=0 b=0 m=1
R$115 \$I13 \$16 vss 1 rppd l=48 ps=0 b=0 m=1
R$116 \$I13 \$I24 vss 1 rppd l=48 ps=0 b=0 m=1
R$117 \$I13 \$I24 vss 1 rppd l=48 ps=0 b=0 m=1
R$118 \$I14 \$18 vss 1 rppd l=48 ps=0 b=0 m=1
R$119 \$I13 \$16 vss 1 rppd l=48 ps=0 b=0 m=1
R$120 \$I13 \$16 vss 1 rppd l=48 ps=0 b=0 m=1
R$121 \$I13 \$16 vss 1 rppd l=48 ps=0 b=0 m=1
R$122 \$I13 \$16 vss 1 rppd l=48 ps=0 b=0 m=1
R$123 \$I14 \$18 vss 1 rppd l=48 ps=0 b=0 m=1
R$124 \$I14 \$18 vss 1 rppd l=48 ps=0 b=0 m=1
R$125 \$I13 \$16 vss 1 rppd l=48 ps=0 b=0 m=1
R$126 \$I14 \$18 vss 1 rppd l=48 ps=0 b=0 m=1
R$127 \$I13 \$I24 vss 1 rppd l=48 ps=0 b=0 m=1
R$128 \$I14 \$18 vss 1 rppd l=48 ps=0 b=0 m=1
R$129 \$I14 \$18 vss 1 rppd l=48 ps=0 b=0 m=1
R$130 \$I14 \$18 vss 1 rppd l=48 ps=0 b=0 m=1
R$131 \$I14 \$18 vss 1 rppd l=48 ps=0 b=0 m=1
R$132 \$I14 \$18 vss 1 rppd l=48 ps=0 b=0 m=1
R$133 \$I14 \$18 vss 1 rppd l=48 ps=0 b=0 m=1
R$134 \$I14 \$18 vss 1 rppd l=48 ps=0 b=0 m=1
R$135 \$I13 \$I24 vss 1 rppd l=48 ps=0 b=0 m=1
R$136 \$I14 \$18 vss 1 rppd l=48 ps=0 b=0 m=1
R$137 \$I13 \$I24 vss 1 rppd l=48 ps=0 b=0 m=1
R$138 \$I13 \$I24 vss 1 rppd l=48 ps=0 b=0 m=1
R$139 \$I13 \$I24 vss 1 rppd l=48 ps=0 b=0 m=1
R$140 \$I13 \$I24 vss 1 rppd l=48 ps=0 b=0 m=1
R$141 \$I13 \$I24 vss 1 rppd l=48 ps=0 b=0 m=1
R$142 \$I13 \$I24 vss 1 rppd l=48 ps=0 b=0 m=1
R$143 \$I13 \$I24 vss 1 rppd l=48 ps=0 b=0 m=1
R$144 \$I14 \$I24 vss 1 rppd l=48 ps=0 b=0 m=1
R$145 \$I13 \$16 vss 1 rppd l=48 ps=0 b=0 m=1
R$146 \$I13 \$I24 vss 1 rppd l=48 ps=0 b=0 m=1
R$147 \$I13 \$16 vss 1 rppd l=48 ps=0 b=0 m=1
R$148 \$I14 \$18 vss 1 rppd l=48 ps=0 b=0 m=1
R$149 \$I13 \$16 vss 1 rppd l=48 ps=0 b=0 m=1
R$150 \$I13 \$16 vss 1 rppd l=48 ps=0 b=0 m=1
R$151 \$I13 \$16 vss 1 rppd l=48 ps=0 b=0 m=1
R$152 \$I13 \$16 vss 1 rppd l=48 ps=0 b=0 m=1
R$153 \$I13 \$16 vss 1 rppd l=48 ps=0 b=0 m=1
R$154 \$I14 \$I24 vss 1 rppd l=48 ps=0 b=0 m=1
R$155 \$I14 \$I24 vss 1 rppd l=48 ps=0 b=0 m=1
R$156 \$I13 \$I24 vss 1 rppd l=48 ps=0 b=0 m=1
R$157 \$I14 \$I24 vss 1 rppd l=48 ps=0 b=0 m=1
R$158 \$I14 \$I24 vss 1 rppd l=48 ps=0 b=0 m=1
R$159 \$I14 \$I24 vss 1 rppd l=48 ps=0 b=0 m=1
R$160 \$I40 pbias vss 1 rppd l=50 ps=0 b=0 m=1
R$161 \$I40 \$I34 vss 1 rppd l=50 ps=0 b=0 m=1
R$162 \$I40 \$I34 vss 1 rppd l=50 ps=0 b=0 m=1
R$163 \$I40 \$I34 vss 1 rppd l=50 ps=0 b=0 m=1
R$164 \$I40 \$I34 vss 1 rppd l=50 ps=0 b=0 m=1
R$165 \$I40 \$I34 vss 1 rppd l=50 ps=0 b=0 m=1
R$166 \$I41 \$I34 vss 1 rppd l=50 ps=0 b=0 m=1
R$167 \$I41 \$I34 vss 1 rppd l=50 ps=0 b=0 m=1
R$168 \$I41 \$I34 vss 1 rppd l=50 ps=0 b=0 m=1
R$169 \$I41 \$I34 vss 1 rppd l=50 ps=0 b=0 m=1
R$170 \$I40 pbias vss 1 rppd l=50 ps=0 b=0 m=1
R$171 \$I41 \$I34 vss 1 rppd l=50 ps=0 b=0 m=1
R$172 \$I41 \$I34 vss 1 rppd l=50 ps=0 b=0 m=1
R$173 \$I41 \$I34 vss 1 rppd l=50 ps=0 b=0 m=1
R$174 \$I41 \$I34 vss 1 rppd l=50 ps=0 b=0 m=1
R$175 \$I41 \$I35 vss 1 rppd l=50 ps=0 b=0 m=1
R$176 \$I41 \$I34 vss 1 rppd l=50 ps=0 b=0 m=1
R$177 \$I41 \$I35 vss 1 rppd l=50 ps=0 b=0 m=1
R$178 \$I40 pbias vss 1 rppd l=50 ps=0 b=0 m=1
R$179 \$I40 pbias vss 1 rppd l=50 ps=0 b=0 m=1
R$180 \$I40 pbias vss 1 rppd l=50 ps=0 b=0 m=1
R$181 \$I41 \$I34 vss 1 rppd l=50 ps=0 b=0 m=1
R$182 \$I41 \$I35 vss 1 rppd l=50 ps=0 b=0 m=1
R$183 \$I41 \$I35 vss 1 rppd l=50 ps=0 b=0 m=1
R$184 \$I41 \$I35 vss 1 rppd l=50 ps=0 b=0 m=1
R$185 \$I18 \$I37 vss 1 rppd l=50 ps=0 b=0 m=1
R$186 \$I18 \$I37 vss 1 rppd l=50 ps=0 b=0 m=1
R$187 \$I41 \$I34 vss 1 rppd l=50 ps=0 b=0 m=1
R$188 \$I41 \$I34 vss 1 rppd l=50 ps=0 b=0 m=1
R$189 \$I30 \$I35 vss 1 rppd l=50 ps=0 b=0 m=1
R$190 \$I30 \$I35 vss 1 rppd l=50 ps=0 b=0 m=1
R$191 \$I30 \$I35 vss 1 rppd l=50 ps=0 b=0 m=1
R$192 \$I30 \$I35 vss 1 rppd l=50 ps=0 b=0 m=1
R$193 \$I30 \$I35 vss 1 rppd l=50 ps=0 b=0 m=1
R$194 \$I40 \$I34 vss 1 rppd l=50 ps=0 b=0 m=1
R$195 \$I18 \$I37 vss 1 rppd l=50 ps=0 b=0 m=1
R$196 \$I18 \$I37 vss 1 rppd l=50 ps=0 b=0 m=1
R$197 \$I18 \$I37 vss 1 rppd l=50 ps=0 b=0 m=1
R$198 \$I18 \$I37 vss 1 rppd l=50 ps=0 b=0 m=1
R$199 \$I18 \$I37 vss 1 rppd l=50 ps=0 b=0 m=1
R$200 \$I18 \$I37 vss 1 rppd l=50 ps=0 b=0 m=1
R$201 \$I18 \$I37 vss 1 rppd l=50 ps=0 b=0 m=1
R$202 \$I18 \$I37 vss 1 rppd l=50 ps=0 b=0 m=1
R$203 \$I18 \$I37 vss 1 rppd l=50 ps=0 b=0 m=1
R$204 \$I18 \$I37 vss 1 rppd l=50 ps=0 b=0 m=1
R$205 \$I41 \$I35 vss 1 rppd l=50 ps=0 b=0 m=1
R$206 \$I30 \$I35 vss 1 rppd l=50 ps=0 b=0 m=1
R$207 \$I30 \$I35 vss 1 rppd l=50 ps=0 b=0 m=1
R$208 \$I30 \$I35 vss 1 rppd l=50 ps=0 b=0 m=1
R$209 \$I23 \$I38 vss 1 rppd l=50 ps=0 b=0 m=1
R$210 \$I23 \$I38 vss 1 rppd l=50 ps=0 b=0 m=1
R$211 \$I23 \$I38 vss 1 rppd l=50 ps=0 b=0 m=1
R$212 \$I23 \$I38 vss 1 rppd l=50 ps=0 b=0 m=1
R$213 \$I23 \$I38 vss 1 rppd l=50 ps=0 b=0 m=1
R$214 \$I23 \$I38 vss 1 rppd l=50 ps=0 b=0 m=1
R$215 \$I23 \$I38 vss 1 rppd l=50 ps=0 b=0 m=1
R$216 \$I23 \$I38 vss 1 rppd l=50 ps=0 b=0 m=1
R$217 \$I23 \$I38 vss 1 rppd l=50 ps=0 b=0 m=1
R$218 \$I23 \$I38 vss 1 rppd l=50 ps=0 b=0 m=1
R$219 \$I23 \$I38 vss 1 rppd l=50 ps=0 b=0 m=1
R$220 \$I40 pbias vss 1 rppd l=50 ps=0 b=0 m=1
R$221 \$I23 \$I38 vss 1 rppd l=50 ps=0 b=0 m=1
R$222 \$I18 \$I38 vss 1 rppd l=50 ps=0 b=0 m=1
R$223 \$I18 \$I38 vss 1 rppd l=50 ps=0 b=0 m=1
R$224 \$I18 \$I37 vss 1 rppd l=50 ps=0 b=0 m=1
R$225 \$I30 \$I35 vss 1 rppd l=50 ps=0 b=0 m=1
R$226 \$I30 \$I35 vss 1 rppd l=50 ps=0 b=0 m=1
R$227 \$I30 \$I35 vss 1 rppd l=50 ps=0 b=0 m=1
R$228 \$I41 \$I34 vss 1 rppd l=50 ps=0 b=0 m=1
R$229 \$I41 \$I35 vss 1 rppd l=50 ps=0 b=0 m=1
R$230 \$I41 \$I35 vss 1 rppd l=50 ps=0 b=0 m=1
R$231 \$I18 \$I37 vss 1 rppd l=50 ps=0 b=0 m=1
R$232 \$I18 \$I38 vss 1 rppd l=50 ps=0 b=0 m=1
R$233 \$I40 pbias vss 1 rppd l=50 ps=0 b=0 m=1
R$234 \$I40 pbias vss 1 rppd l=50 ps=0 b=0 m=1
R$235 \$I40 pbias vss 1 rppd l=50 ps=0 b=0 m=1
R$236 \$I40 pbias vss 1 rppd l=50 ps=0 b=0 m=1
R$237 \$I40 pbias vss 1 rppd l=50 ps=0 b=0 m=1
R$238 \$I18 \$I38 vss 1 rppd l=50 ps=0 b=0 m=1
R$239 \$I18 \$I38 vss 1 rppd l=50 ps=0 b=0 m=1
R$240 \$I18 \$I38 vss 1 rppd l=50 ps=0 b=0 m=1
R$241 \$I18 \$I38 vss 1 rppd l=50 ps=0 b=0 m=1
R$242 \$I18 \$I38 vss 1 rppd l=50 ps=0 b=0 m=1
R$243 \$I18 \$I38 vss 1 rppd l=50 ps=0 b=0 m=1
R$244 \$I18 \$I37 vss 1 rppd l=50 ps=0 b=0 m=1
R$245 \$I30 \$I35 vss 1 rppd l=50 ps=0 b=0 m=1
R$246 \$I18 \$I38 vss 1 rppd l=50 ps=0 b=0 m=1
R$247 \$I18 \$I38 vss 1 rppd l=50 ps=0 b=0 m=1
R$248 \$I30 \$I35 vss 1 rppd l=50 ps=0 b=0 m=1
R$249 \$I40 pbias vss 1 rppd l=50 ps=0 b=0 m=1
R$250 \$I40 pbias vss 1 rppd l=50 ps=0 b=0 m=1
R$251 \$I30 \$I35 vss 1 rppd l=50 ps=0 b=0 m=1
R$252 \$I41 \$I34 vss 1 rppd l=50 ps=0 b=0 m=1
R$253 \$I41 \$I35 vss 1 rppd l=50 ps=0 b=0 m=1
R$254 \$I18 \$I37 vss 1 rppd l=50 ps=0 b=0 m=1
R$255 \$I18 \$I37 vss 1 rppd l=50 ps=0 b=0 m=1
R$256 \$I18 \$I38 vss 1 rppd l=50 ps=0 b=0 m=1
R$257 \$I23 \$I38 vss 1 rppd l=50 ps=0 b=0 m=1
R$258 \$I18 \$I38 vss 1 rppd l=50 ps=0 b=0 m=1
R$259 \$I40 pbias vss 1 rppd l=50 ps=0 b=0 m=1
R$260 \$I30 \$I35 vss 1 rppd l=50 ps=0 b=0 m=1
R$261 \$I18 \$I38 vss 1 rppd l=50 ps=0 b=0 m=1
R$262 \$I18 \$I38 vss 1 rppd l=50 ps=0 b=0 m=1
R$263 \$I30 \$I35 vss 1 rppd l=50 ps=0 b=0 m=1
R$264 \$I18 \$I38 vss 1 rppd l=50 ps=0 b=0 m=1
R$265 \$I41 \$I35 vss 1 rppd l=50 ps=0 b=0 m=1
R$266 \$I18 \$I38 vss 1 rppd l=50 ps=0 b=0 m=1
R$267 \$I18 \$I38 vss 1 rppd l=50 ps=0 b=0 m=1
R$268 \$I18 \$I38 vss 1 rppd l=50 ps=0 b=0 m=1
R$269 \$I18 \$I38 vss 1 rppd l=50 ps=0 b=0 m=1
R$270 \$I18 \$I38 vss 1 rppd l=50 ps=0 b=0 m=1
R$271 \$I18 \$I38 vss 1 rppd l=50 ps=0 b=0 m=1
R$272 \$I18 \$I37 vss 1 rppd l=50 ps=0 b=0 m=1
R$273 \$I41 \$I34 vss 1 rppd l=50 ps=0 b=0 m=1
R$274 \$I18 \$I38 vss 1 rppd l=50 ps=0 b=0 m=1
R$275 \$I23 \$I38 vss 1 rppd l=50 ps=0 b=0 m=1
R$276 \$I23 \$I38 vss 1 rppd l=50 ps=0 b=0 m=1
R$277 \$I23 \$I38 vss 1 rppd l=50 ps=0 b=0 m=1
R$278 \$I30 \$I35 vss 1 rppd l=50 ps=0 b=0 m=1
R$279 \$I23 \$I38 vss 1 rppd l=50 ps=0 b=0 m=1
R$280 \$I23 \$I38 vss 1 rppd l=50 ps=0 b=0 m=1
R$281 \$I23 \$I38 vss 1 rppd l=50 ps=0 b=0 m=1
R$282 \$I30 \$I35 vss 1 rppd l=50 ps=0 b=0 m=1
R$283 \$I40 pbias vss 1 rppd l=50 ps=0 b=0 m=1
R$284 \$I23 \$I38 vss 1 rppd l=50 ps=0 b=0 m=1
R$285 \$I23 \$I38 vss 1 rppd l=50 ps=0 b=0 m=1
R$286 \$I23 \$I38 vss 1 rppd l=50 ps=0 b=0 m=1
R$287 \$I40 pbias vss 1 rppd l=50 ps=0 b=0 m=1
R$288 \$I40 pbias vss 1 rppd l=50 ps=0 b=0 m=1
R$289 \$I23 \$I38 vss 1 rppd l=50 ps=0 b=0 m=1
R$290 \$I40 pbias vss 1 rppd l=50 ps=0 b=0 m=1
R$291 \$I23 \$I38 vss 1 rppd l=50 ps=0 b=0 m=1
R$292 \$I41 \$I35 vss 1 rppd l=50 ps=0 b=0 m=1
R$293 \$I40 \$I34 vss 1 rppd l=50 ps=0 b=0 m=1
R$294 \$I30 \$I35 vss 1 rppd l=50 ps=0 b=0 m=1
R$295 \$I41 \$I34 vss 1 rppd l=50 ps=0 b=0 m=1
R$296 \$I41 \$I35 vss 1 rppd l=50 ps=0 b=0 m=1
R$297 \$I41 \$I34 vss 1 rppd l=50 ps=0 b=0 m=1
R$298 \$I40 \$I34 vss 1 rppd l=50 ps=0 b=0 m=1
R$299 \$I30 \$I37 vss 1 rppd l=50 ps=0 b=0 m=1
R$300 \$I18 \$I37 vss 1 rppd l=50 ps=0 b=0 m=1
R$301 \$I30 \$I37 vss 1 rppd l=50 ps=0 b=0 m=1
R$302 \$I40 \$I34 vss 1 rppd l=50 ps=0 b=0 m=1
R$303 \$I23 pcasc vss 1 rppd l=50 ps=0 b=0 m=1
R$304 \$I23 pcasc vss 1 rppd l=50 ps=0 b=0 m=1
R$305 \$I30 \$I37 vss 1 rppd l=50 ps=0 b=0 m=1
R$306 \$I23 pcasc vss 1 rppd l=50 ps=0 b=0 m=1
R$307 \$I23 pcasc vss 1 rppd l=50 ps=0 b=0 m=1
R$308 \$I23 pcasc vss 1 rppd l=50 ps=0 b=0 m=1
R$309 \$I30 \$I37 vss 1 rppd l=50 ps=0 b=0 m=1
R$310 \$I30 \$I35 vss 1 rppd l=50 ps=0 b=0 m=1
R$311 \$I41 \$I35 vss 1 rppd l=50 ps=0 b=0 m=1
R$312 \$I30 \$I35 vss 1 rppd l=50 ps=0 b=0 m=1
R$313 \$I41 \$I34 vss 1 rppd l=50 ps=0 b=0 m=1
R$314 \$I30 \$I35 vss 1 rppd l=50 ps=0 b=0 m=1
R$315 \$I41 \$I34 vss 1 rppd l=50 ps=0 b=0 m=1
R$316 \$I18 \$I37 vss 1 rppd l=50 ps=0 b=0 m=1
R$317 \$I41 \$I35 vss 1 rppd l=50 ps=0 b=0 m=1
R$318 \$I40 \$I34 vss 1 rppd l=50 ps=0 b=0 m=1
R$319 \$I40 \$I34 vss 1 rppd l=50 ps=0 b=0 m=1
R$320 \$I41 \$I35 vss 1 rppd l=50 ps=0 b=0 m=1
R$321 \$I40 \$I34 vss 1 rppd l=50 ps=0 b=0 m=1
R$322 \$I30 \$I35 vss 1 rppd l=50 ps=0 b=0 m=1
R$323 \$I40 \$I34 vss 1 rppd l=50 ps=0 b=0 m=1
R$324 \$I41 \$I35 vss 1 rppd l=50 ps=0 b=0 m=1
R$325 \$I40 \$I34 vss 1 rppd l=50 ps=0 b=0 m=1
R$326 \$I18 \$I37 vss 1 rppd l=50 ps=0 b=0 m=1
R$327 \$I18 \$I37 vss 1 rppd l=50 ps=0 b=0 m=1
R$328 \$I18 \$I37 vss 1 rppd l=50 ps=0 b=0 m=1
R$329 \$I41 \$I34 vss 1 rppd l=50 ps=0 b=0 m=1
R$330 \$I18 \$I37 vss 1 rppd l=50 ps=0 b=0 m=1
R$331 \$I41 \$I34 vss 1 rppd l=50 ps=0 b=0 m=1
R$332 \$I30 \$I35 vss 1 rppd l=50 ps=0 b=0 m=1
R$333 \$I41 \$I34 vss 1 rppd l=50 ps=0 b=0 m=1
R$334 \$I41 \$I34 vss 1 rppd l=50 ps=0 b=0 m=1
R$335 \$I23 pcasc vss 1 rppd l=50 ps=0 b=0 m=1
R$336 \$I40 pbias vss 1 rppd l=50 ps=0 b=0 m=1
R$337 \$I30 \$I37 vss 1 rppd l=50 ps=0 b=0 m=1
R$338 \$I23 pcasc vss 1 rppd l=50 ps=0 b=0 m=1
R$339 \$I40 \$I34 vss 1 rppd l=50 ps=0 b=0 m=1
R$340 \$I30 \$I37 vss 1 rppd l=50 ps=0 b=0 m=1
R$341 \$I23 pcasc vss 1 rppd l=50 ps=0 b=0 m=1
R$342 \$I30 \$I37 vss 1 rppd l=50 ps=0 b=0 m=1
R$343 \$I23 pcasc vss 1 rppd l=50 ps=0 b=0 m=1
R$344 \$I30 \$I37 vss 1 rppd l=50 ps=0 b=0 m=1
R$345 \$I23 pcasc vss 1 rppd l=50 ps=0 b=0 m=1
R$346 \$I41 \$I35 vss 1 rppd l=50 ps=0 b=0 m=1
R$347 \$I41 \$I35 vss 1 rppd l=50 ps=0 b=0 m=1
R$348 \$I41 \$I35 vss 1 rppd l=50 ps=0 b=0 m=1
R$349 \$I41 \$I35 vss 1 rppd l=50 ps=0 b=0 m=1
R$350 \$I41 \$I35 vss 1 rppd l=50 ps=0 b=0 m=1
R$351 \$I41 \$I35 vss 1 rppd l=50 ps=0 b=0 m=1
R$352 \$I23 pcasc vss 1 rppd l=50 ps=0 b=0 m=1
R$353 \$I23 pcasc vss 1 rppd l=50 ps=0 b=0 m=1
R$354 \$I41 \$I34 vss 1 rppd l=50 ps=0 b=0 m=1
R$355 \$I23 pcasc vss 1 rppd l=50 ps=0 b=0 m=1
R$356 \$I23 pcasc vss 1 rppd l=50 ps=0 b=0 m=1
R$357 \$I23 pcasc vss 1 rppd l=50 ps=0 b=0 m=1
R$358 \$I23 pcasc vss 1 rppd l=50 ps=0 b=0 m=1
R$359 \$I23 pcasc vss 1 rppd l=50 ps=0 b=0 m=1
R$360 \$I30 \$I37 vss 1 rppd l=50 ps=0 b=0 m=1
R$361 \$I41 \$I35 vss 1 rppd l=50 ps=0 b=0 m=1
R$362 \$I41 \$I35 vss 1 rppd l=50 ps=0 b=0 m=1
R$363 \$I23 pcasc vss 1 rppd l=50 ps=0 b=0 m=1
R$364 \$I40 \$I34 vss 1 rppd l=50 ps=0 b=0 m=1
R$365 \$I23 pcasc vss 1 rppd l=50 ps=0 b=0 m=1
R$366 \$I30 \$I37 vss 1 rppd l=50 ps=0 b=0 m=1
R$367 \$I40 \$I34 vss 1 rppd l=50 ps=0 b=0 m=1
R$368 \$I30 \$I37 vss 1 rppd l=50 ps=0 b=0 m=1
R$369 \$I30 \$I37 vss 1 rppd l=50 ps=0 b=0 m=1
R$370 \$I30 \$I37 vss 1 rppd l=50 ps=0 b=0 m=1
R$371 \$I40 \$I34 vss 1 rppd l=50 ps=0 b=0 m=1
R$372 \$I40 \$I34 vss 1 rppd l=50 ps=0 b=0 m=1
R$373 \$I23 pcasc vss 1 rppd l=50 ps=0 b=0 m=1
R$374 \$I23 pcasc vss 1 rppd l=50 ps=0 b=0 m=1
R$375 \$I40 pbias vss 1 rppd l=50 ps=0 b=0 m=1
R$376 \$I18 \$I38 vss 1 rppd l=50 ps=0 b=0 m=1
R$377 \$I40 pbias vss 1 rppd l=50 ps=0 b=0 m=1
R$378 \$I40 pbias vss 1 rppd l=50 ps=0 b=0 m=1
R$379 \$I40 pbias vss 1 rppd l=50 ps=0 b=0 m=1
R$380 \$I40 pbias vss 1 rppd l=50 ps=0 b=0 m=1
R$381 \$I30 \$I37 vss 1 rppd l=50 ps=0 b=0 m=1
R$382 \$I40 \$I34 vss 1 rppd l=50 ps=0 b=0 m=1
R$383 \$I40 \$I34 vss 1 rppd l=50 ps=0 b=0 m=1
R$384 \$I40 \$I34 vss 1 rppd l=50 ps=0 b=0 m=1
R$385 \$I40 \$I34 vss 1 rppd l=50 ps=0 b=0 m=1
R$386 \$I30 \$I37 vss 1 rppd l=50 ps=0 b=0 m=1
R$387 \$I30 \$I37 vss 1 rppd l=50 ps=0 b=0 m=1
R$388 \$I30 \$I37 vss 1 rppd l=50 ps=0 b=0 m=1
R$389 \$I40 \$I34 vss 1 rppd l=50 ps=0 b=0 m=1
R$390 \$I30 \$I37 vss 1 rppd l=50 ps=0 b=0 m=1
R$391 \$I30 \$I37 vss 1 rppd l=50 ps=0 b=0 m=1
R$392 \$I30 \$I37 vss 1 rppd l=50 ps=0 b=0 m=1
R$393 \$I30 \$I37 vss 1 rppd l=50 ps=0 b=0 m=1
R$394 \$I23 pcasc vss 1 rppd l=50 ps=0 b=0 m=1
R$395 \$I30 \$I37 vss 1 rppd l=50 ps=0 b=0 m=1
R$396 \$I30 \$I37 vss 1 rppd l=50 ps=0 b=0 m=1
R$397 \$I23 pcasc vss 1 rppd l=50 ps=0 b=0 m=1
R$398 \$I23 pcasc vss 1 rppd l=50 ps=0 b=0 m=1
R$399 \$I30 \$I37 vss 1 rppd l=50 ps=0 b=0 m=1
M$400 \$I11 r4 vdd vdd sg13_hv_pmos L=0.5U W=2U AS=0.68P AD=0.68P PS=4.68U
+ PD=4.68U rfmode=0
M$401 vbe r4 \$20 vss sg13_hv_nmos L=0.5U W=2U AS=0.68P AD=0.68P PS=4.68U
+ PD=4.68U rfmode=0
M$402 iptat pcasc \$I6 \$I6 sg13_hv_pmos L=4U W=10U AS=3.4P AD=3.4P PS=20.68U
+ PD=20.68U rfmode=0
M$403 \$I10 \$10 vdd vdd sg13_hv_pmos L=0.5U W=2U AS=0.68P AD=0.68P PS=4.68U
+ PD=4.68U rfmode=0
M$404 \$I7 pcasc \$I4 \$I4 sg13_hv_pmos L=4U W=10U AS=3.4P AD=3.4P PS=20.68U
+ PD=20.68U rfmode=0
M$405 \$I7 pcasc \$I4 \$I4 sg13_hv_pmos L=4U W=10U AS=3.4P AD=3.4P PS=20.68U
+ PD=20.68U rfmode=0
M$406 \$I7 pcasc \$I4 \$I4 sg13_hv_pmos L=4U W=10U AS=3.4P AD=3.4P PS=20.68U
+ PD=20.68U rfmode=0
M$407 \$I7 pcasc \$I4 \$I4 sg13_hv_pmos L=4U W=10U AS=3.4P AD=3.4P PS=20.68U
+ PD=20.68U rfmode=0
M$408 \$I7 pcasc \$I4 \$I4 sg13_hv_pmos L=4U W=10U AS=3.4P AD=3.4P PS=20.68U
+ PD=20.68U rfmode=0
M$409 \$I7 pcasc \$I4 \$I4 sg13_hv_pmos L=4U W=10U AS=3.4P AD=3.4P PS=20.68U
+ PD=20.68U rfmode=0
M$410 \$I7 pcasc \$I4 \$I4 sg13_hv_pmos L=4U W=10U AS=3.4P AD=3.4P PS=20.68U
+ PD=20.68U rfmode=0
M$411 \$I7 pcasc \$I4 \$I4 sg13_hv_pmos L=4U W=10U AS=3.4P AD=3.4P PS=20.68U
+ PD=20.68U rfmode=0
M$412 \$I7 pcasc \$I4 \$I4 sg13_hv_pmos L=4U W=10U AS=3.4P AD=3.4P PS=20.68U
+ PD=20.68U rfmode=0
M$413 \$I7 pcasc \$I4 \$I4 sg13_hv_pmos L=4U W=10U AS=3.4P AD=3.4P PS=20.68U
+ PD=20.68U rfmode=0
M$414 \$I7 pcasc \$I4 \$I4 sg13_hv_pmos L=4U W=10U AS=3.4P AD=3.4P PS=20.68U
+ PD=20.68U rfmode=0
M$415 \$I7 pcasc \$I4 \$I4 sg13_hv_pmos L=4U W=10U AS=3.4P AD=3.4P PS=20.68U
+ PD=20.68U rfmode=0
M$416 \$I7 pcasc \$I4 \$I4 sg13_hv_pmos L=4U W=10U AS=3.4P AD=3.4P PS=20.68U
+ PD=20.68U rfmode=0
M$417 \$I7 pcasc \$I4 \$I4 sg13_hv_pmos L=4U W=10U AS=3.4P AD=3.4P PS=20.68U
+ PD=20.68U rfmode=0
M$418 \$I7 pcasc \$I4 \$I4 sg13_hv_pmos L=4U W=10U AS=3.4P AD=3.4P PS=20.68U
+ PD=20.68U rfmode=0
M$419 \$I7 pcasc \$I4 \$I4 sg13_hv_pmos L=4U W=10U AS=3.4P AD=3.4P PS=20.68U
+ PD=20.68U rfmode=0
M$420 \$I7 pcasc \$I4 \$I4 sg13_hv_pmos L=4U W=10U AS=3.4P AD=3.4P PS=20.68U
+ PD=20.68U rfmode=0
M$421 \$I7 pcasc \$I4 \$I4 sg13_hv_pmos L=4U W=10U AS=3.4P AD=3.4P PS=20.68U
+ PD=20.68U rfmode=0
M$422 \$I7 pcasc \$I4 \$I4 sg13_hv_pmos L=4U W=10U AS=3.4P AD=3.4P PS=20.68U
+ PD=20.68U rfmode=0
M$423 \$I7 pcasc \$I4 \$I4 sg13_hv_pmos L=4U W=10U AS=3.4P AD=3.4P PS=20.68U
+ PD=20.68U rfmode=0
M$424 \$I7 pcasc \$I4 \$I4 sg13_hv_pmos L=4U W=10U AS=3.4P AD=3.4P PS=20.68U
+ PD=20.68U rfmode=0
M$425 \$I7 pcasc \$I4 \$I4 sg13_hv_pmos L=4U W=10U AS=3.4P AD=3.4P PS=20.68U
+ PD=20.68U rfmode=0
M$426 \$I7 pcasc \$I4 \$I4 sg13_hv_pmos L=4U W=10U AS=3.4P AD=3.4P PS=20.68U
+ PD=20.68U rfmode=0
M$427 \$I7 pcasc \$I4 \$I4 sg13_hv_pmos L=4U W=10U AS=3.4P AD=3.4P PS=20.68U
+ PD=20.68U rfmode=0
M$428 \$20 \$I11 vss vss sg13_hv_nmos L=0.6U W=1U AS=0.34P AD=0.34P PS=2.68U
+ PD=2.68U rfmode=0
M$429 vref pcasc \$I5 \$I5 sg13_hv_pmos L=4U W=10U AS=3.4P AD=3.4P PS=20.68U
+ PD=20.68U rfmode=0
M$430 vref pcasc \$I5 \$I5 sg13_hv_pmos L=4U W=10U AS=3.4P AD=3.4P PS=20.68U
+ PD=20.68U rfmode=0
M$431 vref pcasc \$I5 \$I5 sg13_hv_pmos L=4U W=10U AS=3.4P AD=3.4P PS=20.68U
+ PD=20.68U rfmode=0
M$432 vref pcasc \$I5 \$I5 sg13_hv_pmos L=4U W=10U AS=3.4P AD=3.4P PS=20.68U
+ PD=20.68U rfmode=0
M$433 pbias \$I10 vss vss sg13_hv_nmos L=4U W=1U AS=0.34P AD=0.34P PS=2.68U
+ PD=2.68U rfmode=0
M$434 \$I10 \$10 vss vss sg13_hv_nmos L=0.6U W=1U AS=0.34P AD=0.34P PS=2.68U
+ PD=2.68U rfmode=0
M$435 \$I11 r4 vss vss sg13_hv_nmos L=0.5U W=1U AS=0.34P AD=0.34P PS=2.68U
+ PD=2.68U rfmode=0
M$436 vbe \$16 \$I7 vss sg13_hv_nmos L=1U W=10U AS=3.4P AD=3.4P PS=20.68U
+ PD=20.68U rfmode=0
M$437 vbe \$16 \$I7 vss sg13_hv_nmos L=1U W=10U AS=3.4P AD=3.4P PS=20.68U
+ PD=20.68U rfmode=0
M$438 vbe \$16 \$I7 vss sg13_hv_nmos L=1U W=10U AS=3.4P AD=3.4P PS=20.68U
+ PD=20.68U rfmode=0
M$439 vbe \$16 \$I7 vss sg13_hv_nmos L=1U W=10U AS=3.4P AD=3.4P PS=20.68U
+ PD=20.68U rfmode=0
M$440 vbe \$16 \$I7 vss sg13_hv_nmos L=1U W=10U AS=3.4P AD=3.4P PS=20.68U
+ PD=20.68U rfmode=0
M$441 vbe \$16 \$I7 vss sg13_hv_nmos L=1U W=10U AS=3.4P AD=3.4P PS=20.68U
+ PD=20.68U rfmode=0
M$442 vbe \$16 \$I7 vss sg13_hv_nmos L=1U W=10U AS=3.4P AD=3.4P PS=20.68U
+ PD=20.68U rfmode=0
M$443 vbe \$16 \$I7 vss sg13_hv_nmos L=1U W=10U AS=3.4P AD=3.4P PS=20.68U
+ PD=20.68U rfmode=0
M$444 vbe \$16 \$I7 vss sg13_hv_nmos L=1U W=10U AS=3.4P AD=3.4P PS=20.68U
+ PD=20.68U rfmode=0
M$445 vbe \$16 \$I7 vss sg13_hv_nmos L=1U W=10U AS=3.4P AD=3.4P PS=20.68U
+ PD=20.68U rfmode=0
M$446 vbe \$16 \$I7 vss sg13_hv_nmos L=1U W=10U AS=3.4P AD=3.4P PS=20.68U
+ PD=20.68U rfmode=0
M$447 vbe \$16 \$I7 vss sg13_hv_nmos L=1U W=10U AS=3.4P AD=3.4P PS=20.68U
+ PD=20.68U rfmode=0
M$448 vbe \$16 \$I7 vss sg13_hv_nmos L=1U W=10U AS=3.4P AD=3.4P PS=20.68U
+ PD=20.68U rfmode=0
M$449 vbe \$16 \$I7 vss sg13_hv_nmos L=1U W=10U AS=3.4P AD=3.4P PS=20.68U
+ PD=20.68U rfmode=0
M$450 vbe \$16 \$I7 vss sg13_hv_nmos L=1U W=10U AS=3.4P AD=3.4P PS=20.68U
+ PD=20.68U rfmode=0
M$451 vbe \$16 \$I7 vss sg13_hv_nmos L=1U W=10U AS=3.4P AD=3.4P PS=20.68U
+ PD=20.68U rfmode=0
M$452 vbe \$16 \$I7 vss sg13_hv_nmos L=1U W=10U AS=3.4P AD=3.4P PS=20.68U
+ PD=20.68U rfmode=0
M$453 vbe \$16 \$I7 vss sg13_hv_nmos L=1U W=10U AS=3.4P AD=3.4P PS=20.68U
+ PD=20.68U rfmode=0
M$454 vbe \$16 \$I7 vss sg13_hv_nmos L=1U W=10U AS=3.4P AD=3.4P PS=20.68U
+ PD=20.68U rfmode=0
M$455 vbe \$16 \$I7 vss sg13_hv_nmos L=1U W=10U AS=3.4P AD=3.4P PS=20.68U
+ PD=20.68U rfmode=0
M$456 vbe \$16 \$I7 vss sg13_hv_nmos L=1U W=10U AS=3.4P AD=3.4P PS=20.68U
+ PD=20.68U rfmode=0
M$457 vbe \$16 \$I7 vss sg13_hv_nmos L=1U W=10U AS=3.4P AD=3.4P PS=20.68U
+ PD=20.68U rfmode=0
M$458 vbe \$16 \$I7 vss sg13_hv_nmos L=1U W=10U AS=3.4P AD=3.4P PS=20.68U
+ PD=20.68U rfmode=0
M$459 vbe \$16 \$I7 vss sg13_hv_nmos L=1U W=10U AS=3.4P AD=3.4P PS=20.68U
+ PD=20.68U rfmode=0
M$460 \$I5 pbias vdd vdd sg13_hv_pmos L=4U W=5U AS=1.7P AD=1.7P PS=10.68U
+ PD=10.68U rfmode=0
M$461 \$I5 pbias vdd vdd sg13_hv_pmos L=4U W=5U AS=1.7P AD=1.7P PS=10.68U
+ PD=10.68U rfmode=0
M$462 \$I5 pbias vdd vdd sg13_hv_pmos L=4U W=5U AS=1.7P AD=1.7P PS=10.68U
+ PD=10.68U rfmode=0
M$463 \$I5 pbias vdd vdd sg13_hv_pmos L=4U W=5U AS=1.7P AD=1.7P PS=10.68U
+ PD=10.68U rfmode=0
M$464 \$I5 pbias vdd vdd sg13_hv_pmos L=4U W=5U AS=1.7P AD=1.7P PS=10.68U
+ PD=10.68U rfmode=0
M$465 \$I5 pbias vdd vdd sg13_hv_pmos L=4U W=5U AS=1.7P AD=1.7P PS=10.68U
+ PD=10.68U rfmode=0
M$466 \$I5 pbias vdd vdd sg13_hv_pmos L=4U W=5U AS=1.7P AD=1.7P PS=10.68U
+ PD=10.68U rfmode=0
M$467 \$I5 pbias vdd vdd sg13_hv_pmos L=4U W=5U AS=1.7P AD=1.7P PS=10.68U
+ PD=10.68U rfmode=0
M$468 \$I6 pbias vdd vdd sg13_hv_pmos L=4U W=5U AS=1.7P AD=1.7P PS=10.68U
+ PD=10.68U rfmode=0
M$469 \$I6 pbias vdd vdd sg13_hv_pmos L=4U W=5U AS=1.7P AD=1.7P PS=10.68U
+ PD=10.68U rfmode=0
M$470 \$10 pbias vdd vdd sg13_hv_pmos L=4U W=5U AS=1.7P AD=1.7P PS=10.68U
+ PD=10.68U rfmode=0
M$471 \$10 pbias vdd vdd sg13_hv_pmos L=4U W=5U AS=1.7P AD=1.7P PS=10.68U
+ PD=10.68U rfmode=0
M$472 \$I7 \$16 vbe vss sg13_hv_nmos L=1U W=10U AS=3.4P AD=3.4P PS=20.68U
+ PD=20.68U rfmode=0
M$473 \$I7 \$16 vbe vss sg13_hv_nmos L=1U W=10U AS=3.4P AD=3.4P PS=20.68U
+ PD=20.68U rfmode=0
M$474 \$I7 \$16 vbe vss sg13_hv_nmos L=1U W=10U AS=3.4P AD=3.4P PS=20.68U
+ PD=20.68U rfmode=0
M$475 \$I7 \$16 vbe vss sg13_hv_nmos L=1U W=10U AS=3.4P AD=3.4P PS=20.68U
+ PD=20.68U rfmode=0
M$476 \$I7 \$16 vbe vss sg13_hv_nmos L=1U W=10U AS=3.4P AD=3.4P PS=20.68U
+ PD=20.68U rfmode=0
M$477 \$I7 \$16 vbe vss sg13_hv_nmos L=1U W=10U AS=3.4P AD=3.4P PS=20.68U
+ PD=20.68U rfmode=0
M$478 \$I7 \$16 vbe vss sg13_hv_nmos L=1U W=10U AS=3.4P AD=3.4P PS=20.68U
+ PD=20.68U rfmode=0
M$479 \$I7 \$16 vbe vss sg13_hv_nmos L=1U W=10U AS=3.4P AD=3.4P PS=20.68U
+ PD=20.68U rfmode=0
M$480 \$I7 \$16 vbe vss sg13_hv_nmos L=1U W=10U AS=3.4P AD=3.4P PS=20.68U
+ PD=20.68U rfmode=0
M$481 \$I7 \$16 vbe vss sg13_hv_nmos L=1U W=10U AS=3.4P AD=3.4P PS=20.68U
+ PD=20.68U rfmode=0
M$482 \$I7 \$16 vbe vss sg13_hv_nmos L=1U W=10U AS=3.4P AD=3.4P PS=20.68U
+ PD=20.68U rfmode=0
M$483 \$I7 \$16 vbe vss sg13_hv_nmos L=1U W=10U AS=3.4P AD=3.4P PS=20.68U
+ PD=20.68U rfmode=0
M$484 \$I7 \$16 vbe vss sg13_hv_nmos L=1U W=10U AS=3.4P AD=3.4P PS=20.68U
+ PD=20.68U rfmode=0
M$485 \$I7 \$16 vbe vss sg13_hv_nmos L=1U W=10U AS=3.4P AD=3.4P PS=20.68U
+ PD=20.68U rfmode=0
M$486 \$I7 \$16 vbe vss sg13_hv_nmos L=1U W=10U AS=3.4P AD=3.4P PS=20.68U
+ PD=20.68U rfmode=0
M$487 \$I7 \$16 vbe vss sg13_hv_nmos L=1U W=10U AS=3.4P AD=3.4P PS=20.68U
+ PD=20.68U rfmode=0
M$488 \$I7 \$16 vbe vss sg13_hv_nmos L=1U W=10U AS=3.4P AD=3.4P PS=20.68U
+ PD=20.68U rfmode=0
M$489 \$I7 \$16 vbe vss sg13_hv_nmos L=1U W=10U AS=3.4P AD=3.4P PS=20.68U
+ PD=20.68U rfmode=0
M$490 \$I7 \$16 vbe vss sg13_hv_nmos L=1U W=10U AS=3.4P AD=3.4P PS=20.68U
+ PD=20.68U rfmode=0
M$491 \$I7 \$16 vbe vss sg13_hv_nmos L=1U W=10U AS=3.4P AD=3.4P PS=20.68U
+ PD=20.68U rfmode=0
M$492 \$I7 \$16 vbe vss sg13_hv_nmos L=1U W=10U AS=3.4P AD=3.4P PS=20.68U
+ PD=20.68U rfmode=0
M$493 \$I7 \$16 vbe vss sg13_hv_nmos L=1U W=10U AS=3.4P AD=3.4P PS=20.68U
+ PD=20.68U rfmode=0
M$494 \$I7 \$16 vbe vss sg13_hv_nmos L=1U W=10U AS=3.4P AD=3.4P PS=20.68U
+ PD=20.68U rfmode=0
M$495 \$I7 \$16 vbe vss sg13_hv_nmos L=1U W=10U AS=3.4P AD=3.4P PS=20.68U
+ PD=20.68U rfmode=0
M$496 pcasc \$16 \$21 vss sg13_hv_nmos L=1U W=10U AS=3.4P AD=3.4P PS=20.68U
+ PD=20.68U rfmode=0
M$497 pcasc \$16 \$21 vss sg13_hv_nmos L=1U W=10U AS=3.4P AD=3.4P PS=20.68U
+ PD=20.68U rfmode=0
M$498 pcasc \$16 \$21 vss sg13_hv_nmos L=1U W=10U AS=3.4P AD=3.4P PS=20.68U
+ PD=20.68U rfmode=0
M$499 pcasc \$16 \$21 vss sg13_hv_nmos L=1U W=10U AS=3.4P AD=3.4P PS=20.68U
+ PD=20.68U rfmode=0
M$500 pcasc \$16 \$21 vss sg13_hv_nmos L=1U W=10U AS=3.4P AD=3.4P PS=20.68U
+ PD=20.68U rfmode=0
M$501 pcasc \$16 \$21 vss sg13_hv_nmos L=1U W=10U AS=3.4P AD=3.4P PS=20.68U
+ PD=20.68U rfmode=0
M$502 pcasc \$16 \$21 vss sg13_hv_nmos L=1U W=10U AS=3.4P AD=3.4P PS=20.68U
+ PD=20.68U rfmode=0
M$503 pcasc \$16 \$21 vss sg13_hv_nmos L=1U W=10U AS=3.4P AD=3.4P PS=20.68U
+ PD=20.68U rfmode=0
M$504 pcasc \$16 \$21 vss sg13_hv_nmos L=1U W=10U AS=3.4P AD=3.4P PS=20.68U
+ PD=20.68U rfmode=0
M$505 pcasc \$16 \$21 vss sg13_hv_nmos L=1U W=10U AS=3.4P AD=3.4P PS=20.68U
+ PD=20.68U rfmode=0
M$506 pcasc \$16 \$21 vss sg13_hv_nmos L=1U W=10U AS=3.4P AD=3.4P PS=20.68U
+ PD=20.68U rfmode=0
M$507 pcasc \$16 \$21 vss sg13_hv_nmos L=1U W=10U AS=3.4P AD=3.4P PS=20.68U
+ PD=20.68U rfmode=0
M$508 pcasc \$16 \$21 vss sg13_hv_nmos L=1U W=10U AS=3.4P AD=3.4P PS=20.68U
+ PD=20.68U rfmode=0
M$509 pcasc \$16 \$21 vss sg13_hv_nmos L=1U W=10U AS=3.4P AD=3.4P PS=20.68U
+ PD=20.68U rfmode=0
M$510 pcasc \$16 \$21 vss sg13_hv_nmos L=1U W=10U AS=3.4P AD=3.4P PS=20.68U
+ PD=20.68U rfmode=0
M$511 pcasc \$16 \$21 vss sg13_hv_nmos L=1U W=10U AS=3.4P AD=3.4P PS=20.68U
+ PD=20.68U rfmode=0
M$512 pcasc \$16 \$21 vss sg13_hv_nmos L=1U W=10U AS=3.4P AD=3.4P PS=20.68U
+ PD=20.68U rfmode=0
M$513 pcasc \$16 \$21 vss sg13_hv_nmos L=1U W=10U AS=3.4P AD=3.4P PS=20.68U
+ PD=20.68U rfmode=0
M$514 pcasc \$16 \$21 vss sg13_hv_nmos L=1U W=10U AS=3.4P AD=3.4P PS=20.68U
+ PD=20.68U rfmode=0
M$515 pcasc \$16 \$21 vss sg13_hv_nmos L=1U W=10U AS=3.4P AD=3.4P PS=20.68U
+ PD=20.68U rfmode=0
M$516 pcasc \$16 \$21 vss sg13_hv_nmos L=1U W=10U AS=3.4P AD=3.4P PS=20.68U
+ PD=20.68U rfmode=0
M$517 pcasc \$16 \$21 vss sg13_hv_nmos L=1U W=10U AS=3.4P AD=3.4P PS=20.68U
+ PD=20.68U rfmode=0
M$518 pcasc \$16 \$21 vss sg13_hv_nmos L=1U W=10U AS=3.4P AD=3.4P PS=20.68U
+ PD=20.68U rfmode=0
M$519 pcasc \$16 \$21 vss sg13_hv_nmos L=1U W=10U AS=3.4P AD=3.4P PS=20.68U
+ PD=20.68U rfmode=0
M$520 \$16 pcasc \$I8 \$I8 sg13_hv_pmos L=4U W=10U AS=3.4P AD=3.4P PS=20.68U
+ PD=20.68U rfmode=0
M$521 \$16 pcasc \$I8 \$I8 sg13_hv_pmos L=4U W=10U AS=3.4P AD=3.4P PS=20.68U
+ PD=20.68U rfmode=0
M$522 \$16 pcasc \$I8 \$I8 sg13_hv_pmos L=4U W=10U AS=3.4P AD=3.4P PS=20.68U
+ PD=20.68U rfmode=0
M$523 \$16 pcasc \$I8 \$I8 sg13_hv_pmos L=4U W=10U AS=3.4P AD=3.4P PS=20.68U
+ PD=20.68U rfmode=0
M$524 \$16 pcasc \$I8 \$I8 sg13_hv_pmos L=4U W=10U AS=3.4P AD=3.4P PS=20.68U
+ PD=20.68U rfmode=0
M$525 \$16 pcasc \$I8 \$I8 sg13_hv_pmos L=4U W=10U AS=3.4P AD=3.4P PS=20.68U
+ PD=20.68U rfmode=0
M$526 \$16 pcasc \$I8 \$I8 sg13_hv_pmos L=4U W=10U AS=3.4P AD=3.4P PS=20.68U
+ PD=20.68U rfmode=0
M$527 \$16 pcasc \$I8 \$I8 sg13_hv_pmos L=4U W=10U AS=3.4P AD=3.4P PS=20.68U
+ PD=20.68U rfmode=0
M$528 \$16 pcasc \$I8 \$I8 sg13_hv_pmos L=4U W=10U AS=3.4P AD=3.4P PS=20.68U
+ PD=20.68U rfmode=0
M$529 \$16 pcasc \$I8 \$I8 sg13_hv_pmos L=4U W=10U AS=3.4P AD=3.4P PS=20.68U
+ PD=20.68U rfmode=0
M$530 \$16 pcasc \$I8 \$I8 sg13_hv_pmos L=4U W=10U AS=3.4P AD=3.4P PS=20.68U
+ PD=20.68U rfmode=0
M$531 \$16 pcasc \$I8 \$I8 sg13_hv_pmos L=4U W=10U AS=3.4P AD=3.4P PS=20.68U
+ PD=20.68U rfmode=0
M$532 \$16 pcasc \$I8 \$I8 sg13_hv_pmos L=4U W=10U AS=3.4P AD=3.4P PS=20.68U
+ PD=20.68U rfmode=0
M$533 \$16 pcasc \$I8 \$I8 sg13_hv_pmos L=4U W=10U AS=3.4P AD=3.4P PS=20.68U
+ PD=20.68U rfmode=0
M$534 \$16 pcasc \$I8 \$I8 sg13_hv_pmos L=4U W=10U AS=3.4P AD=3.4P PS=20.68U
+ PD=20.68U rfmode=0
M$535 \$16 pcasc \$I8 \$I8 sg13_hv_pmos L=4U W=10U AS=3.4P AD=3.4P PS=20.68U
+ PD=20.68U rfmode=0
M$536 \$16 pcasc \$I8 \$I8 sg13_hv_pmos L=4U W=10U AS=3.4P AD=3.4P PS=20.68U
+ PD=20.68U rfmode=0
M$537 \$16 pcasc \$I8 \$I8 sg13_hv_pmos L=4U W=10U AS=3.4P AD=3.4P PS=20.68U
+ PD=20.68U rfmode=0
M$538 \$16 pcasc \$I8 \$I8 sg13_hv_pmos L=4U W=10U AS=3.4P AD=3.4P PS=20.68U
+ PD=20.68U rfmode=0
M$539 \$16 pcasc \$I8 \$I8 sg13_hv_pmos L=4U W=10U AS=3.4P AD=3.4P PS=20.68U
+ PD=20.68U rfmode=0
M$540 \$16 pcasc \$I8 \$I8 sg13_hv_pmos L=4U W=10U AS=3.4P AD=3.4P PS=20.68U
+ PD=20.68U rfmode=0
M$541 \$16 pcasc \$I8 \$I8 sg13_hv_pmos L=4U W=10U AS=3.4P AD=3.4P PS=20.68U
+ PD=20.68U rfmode=0
M$542 \$16 pcasc \$I8 \$I8 sg13_hv_pmos L=4U W=10U AS=3.4P AD=3.4P PS=20.68U
+ PD=20.68U rfmode=0
M$543 \$16 pcasc \$I8 \$I8 sg13_hv_pmos L=4U W=10U AS=3.4P AD=3.4P PS=20.68U
+ PD=20.68U rfmode=0
M$544 pbias pcasc \$I9 \$I9 sg13_hv_pmos L=4U W=10U AS=3.4P AD=3.4P PS=20.68U
+ PD=20.68U rfmode=0
M$545 pbias pcasc \$I9 \$I9 sg13_hv_pmos L=4U W=10U AS=3.4P AD=3.4P PS=20.68U
+ PD=20.68U rfmode=0
M$546 pbias pcasc \$I9 \$I9 sg13_hv_pmos L=4U W=10U AS=3.4P AD=3.4P PS=20.68U
+ PD=20.68U rfmode=0
M$547 pbias pcasc \$I9 \$I9 sg13_hv_pmos L=4U W=10U AS=3.4P AD=3.4P PS=20.68U
+ PD=20.68U rfmode=0
M$548 pbias pcasc \$I9 \$I9 sg13_hv_pmos L=4U W=10U AS=3.4P AD=3.4P PS=20.68U
+ PD=20.68U rfmode=0
M$549 pbias pcasc \$I9 \$I9 sg13_hv_pmos L=4U W=10U AS=3.4P AD=3.4P PS=20.68U
+ PD=20.68U rfmode=0
M$550 pbias pcasc \$I9 \$I9 sg13_hv_pmos L=4U W=10U AS=3.4P AD=3.4P PS=20.68U
+ PD=20.68U rfmode=0
M$551 pbias pcasc \$I9 \$I9 sg13_hv_pmos L=4U W=10U AS=3.4P AD=3.4P PS=20.68U
+ PD=20.68U rfmode=0
M$552 pbias pcasc \$I9 \$I9 sg13_hv_pmos L=4U W=10U AS=3.4P AD=3.4P PS=20.68U
+ PD=20.68U rfmode=0
M$553 pbias pcasc \$I9 \$I9 sg13_hv_pmos L=4U W=10U AS=3.4P AD=3.4P PS=20.68U
+ PD=20.68U rfmode=0
M$554 pbias pcasc \$I9 \$I9 sg13_hv_pmos L=4U W=10U AS=3.4P AD=3.4P PS=20.68U
+ PD=20.68U rfmode=0
M$555 pbias pcasc \$I9 \$I9 sg13_hv_pmos L=4U W=10U AS=3.4P AD=3.4P PS=20.68U
+ PD=20.68U rfmode=0
M$556 pbias pcasc \$I9 \$I9 sg13_hv_pmos L=4U W=10U AS=3.4P AD=3.4P PS=20.68U
+ PD=20.68U rfmode=0
M$557 pbias pcasc \$I9 \$I9 sg13_hv_pmos L=4U W=10U AS=3.4P AD=3.4P PS=20.68U
+ PD=20.68U rfmode=0
M$558 pbias pcasc \$I9 \$I9 sg13_hv_pmos L=4U W=10U AS=3.4P AD=3.4P PS=20.68U
+ PD=20.68U rfmode=0
M$559 pbias pcasc \$I9 \$I9 sg13_hv_pmos L=4U W=10U AS=3.4P AD=3.4P PS=20.68U
+ PD=20.68U rfmode=0
M$560 pbias pcasc \$I9 \$I9 sg13_hv_pmos L=4U W=10U AS=3.4P AD=3.4P PS=20.68U
+ PD=20.68U rfmode=0
M$561 pbias pcasc \$I9 \$I9 sg13_hv_pmos L=4U W=10U AS=3.4P AD=3.4P PS=20.68U
+ PD=20.68U rfmode=0
M$562 pbias pcasc \$I9 \$I9 sg13_hv_pmos L=4U W=10U AS=3.4P AD=3.4P PS=20.68U
+ PD=20.68U rfmode=0
M$563 pbias pcasc \$I9 \$I9 sg13_hv_pmos L=4U W=10U AS=3.4P AD=3.4P PS=20.68U
+ PD=20.68U rfmode=0
M$564 pbias pcasc \$I9 \$I9 sg13_hv_pmos L=4U W=10U AS=3.4P AD=3.4P PS=20.68U
+ PD=20.68U rfmode=0
M$565 pbias pcasc \$I9 \$I9 sg13_hv_pmos L=4U W=10U AS=3.4P AD=3.4P PS=20.68U
+ PD=20.68U rfmode=0
M$566 pbias pcasc \$I9 \$I9 sg13_hv_pmos L=4U W=10U AS=3.4P AD=3.4P PS=20.68U
+ PD=20.68U rfmode=0
M$567 pbias pcasc \$I9 \$I9 sg13_hv_pmos L=4U W=10U AS=3.4P AD=3.4P PS=20.68U
+ PD=20.68U rfmode=0
M$568 \$I4 pbias vdd vdd sg13_hv_pmos L=4U W=5U AS=1.7P AD=1.7P PS=10.68U
+ PD=10.68U rfmode=0
M$569 \$I4 pbias vdd vdd sg13_hv_pmos L=4U W=5U AS=1.7P AD=1.7P PS=10.68U
+ PD=10.68U rfmode=0
M$570 \$I4 pbias vdd vdd sg13_hv_pmos L=4U W=5U AS=1.7P AD=1.7P PS=10.68U
+ PD=10.68U rfmode=0
M$571 \$I4 pbias vdd vdd sg13_hv_pmos L=4U W=5U AS=1.7P AD=1.7P PS=10.68U
+ PD=10.68U rfmode=0
M$572 \$I4 pbias vdd vdd sg13_hv_pmos L=4U W=5U AS=1.7P AD=1.7P PS=10.68U
+ PD=10.68U rfmode=0
M$573 \$I4 pbias vdd vdd sg13_hv_pmos L=4U W=5U AS=1.7P AD=1.7P PS=10.68U
+ PD=10.68U rfmode=0
M$574 \$I4 pbias vdd vdd sg13_hv_pmos L=4U W=5U AS=1.7P AD=1.7P PS=10.68U
+ PD=10.68U rfmode=0
M$575 \$I4 pbias vdd vdd sg13_hv_pmos L=4U W=5U AS=1.7P AD=1.7P PS=10.68U
+ PD=10.68U rfmode=0
M$576 \$I4 pbias vdd vdd sg13_hv_pmos L=4U W=5U AS=1.7P AD=1.7P PS=10.68U
+ PD=10.68U rfmode=0
M$577 \$I4 pbias vdd vdd sg13_hv_pmos L=4U W=5U AS=1.7P AD=1.7P PS=10.68U
+ PD=10.68U rfmode=0
M$578 \$I4 pbias vdd vdd sg13_hv_pmos L=4U W=5U AS=1.7P AD=1.7P PS=10.68U
+ PD=10.68U rfmode=0
M$579 \$I4 pbias vdd vdd sg13_hv_pmos L=4U W=5U AS=1.7P AD=1.7P PS=10.68U
+ PD=10.68U rfmode=0
M$580 \$I4 pbias vdd vdd sg13_hv_pmos L=4U W=5U AS=1.7P AD=1.7P PS=10.68U
+ PD=10.68U rfmode=0
M$581 \$I4 pbias vdd vdd sg13_hv_pmos L=4U W=5U AS=1.7P AD=1.7P PS=10.68U
+ PD=10.68U rfmode=0
M$582 \$I4 pbias vdd vdd sg13_hv_pmos L=4U W=5U AS=1.7P AD=1.7P PS=10.68U
+ PD=10.68U rfmode=0
M$583 \$I4 pbias vdd vdd sg13_hv_pmos L=4U W=5U AS=1.7P AD=1.7P PS=10.68U
+ PD=10.68U rfmode=0
M$584 \$I4 pbias vdd vdd sg13_hv_pmos L=4U W=5U AS=1.7P AD=1.7P PS=10.68U
+ PD=10.68U rfmode=0
M$585 \$I4 pbias vdd vdd sg13_hv_pmos L=4U W=5U AS=1.7P AD=1.7P PS=10.68U
+ PD=10.68U rfmode=0
M$586 \$I4 pbias vdd vdd sg13_hv_pmos L=4U W=5U AS=1.7P AD=1.7P PS=10.68U
+ PD=10.68U rfmode=0
M$587 \$I4 pbias vdd vdd sg13_hv_pmos L=4U W=5U AS=1.7P AD=1.7P PS=10.68U
+ PD=10.68U rfmode=0
M$588 \$I4 pbias vdd vdd sg13_hv_pmos L=4U W=5U AS=1.7P AD=1.7P PS=10.68U
+ PD=10.68U rfmode=0
M$589 \$I4 pbias vdd vdd sg13_hv_pmos L=4U W=5U AS=1.7P AD=1.7P PS=10.68U
+ PD=10.68U rfmode=0
M$590 \$I4 pbias vdd vdd sg13_hv_pmos L=4U W=5U AS=1.7P AD=1.7P PS=10.68U
+ PD=10.68U rfmode=0
M$591 \$I4 pbias vdd vdd sg13_hv_pmos L=4U W=5U AS=1.7P AD=1.7P PS=10.68U
+ PD=10.68U rfmode=0
M$592 \$I4 pbias vdd vdd sg13_hv_pmos L=4U W=5U AS=1.7P AD=1.7P PS=10.68U
+ PD=10.68U rfmode=0
M$593 \$I4 pbias vdd vdd sg13_hv_pmos L=4U W=5U AS=1.7P AD=1.7P PS=10.68U
+ PD=10.68U rfmode=0
M$594 \$I4 pbias vdd vdd sg13_hv_pmos L=4U W=5U AS=1.7P AD=1.7P PS=10.68U
+ PD=10.68U rfmode=0
M$595 \$I4 pbias vdd vdd sg13_hv_pmos L=4U W=5U AS=1.7P AD=1.7P PS=10.68U
+ PD=10.68U rfmode=0
M$596 \$I4 pbias vdd vdd sg13_hv_pmos L=4U W=5U AS=1.7P AD=1.7P PS=10.68U
+ PD=10.68U rfmode=0
M$597 \$I4 pbias vdd vdd sg13_hv_pmos L=4U W=5U AS=1.7P AD=1.7P PS=10.68U
+ PD=10.68U rfmode=0
M$598 \$I4 pbias vdd vdd sg13_hv_pmos L=4U W=5U AS=1.7P AD=1.7P PS=10.68U
+ PD=10.68U rfmode=0
M$599 \$I4 pbias vdd vdd sg13_hv_pmos L=4U W=5U AS=1.7P AD=1.7P PS=10.68U
+ PD=10.68U rfmode=0
M$600 \$I4 pbias vdd vdd sg13_hv_pmos L=4U W=5U AS=1.7P AD=1.7P PS=10.68U
+ PD=10.68U rfmode=0
M$601 \$I4 pbias vdd vdd sg13_hv_pmos L=4U W=5U AS=1.7P AD=1.7P PS=10.68U
+ PD=10.68U rfmode=0
M$602 \$I4 pbias vdd vdd sg13_hv_pmos L=4U W=5U AS=1.7P AD=1.7P PS=10.68U
+ PD=10.68U rfmode=0
M$603 \$I4 pbias vdd vdd sg13_hv_pmos L=4U W=5U AS=1.7P AD=1.7P PS=10.68U
+ PD=10.68U rfmode=0
M$604 \$I4 pbias vdd vdd sg13_hv_pmos L=4U W=5U AS=1.7P AD=1.7P PS=10.68U
+ PD=10.68U rfmode=0
M$605 \$I4 pbias vdd vdd sg13_hv_pmos L=4U W=5U AS=1.7P AD=1.7P PS=10.68U
+ PD=10.68U rfmode=0
M$606 \$I4 pbias vdd vdd sg13_hv_pmos L=4U W=5U AS=1.7P AD=1.7P PS=10.68U
+ PD=10.68U rfmode=0
M$607 \$I4 pbias vdd vdd sg13_hv_pmos L=4U W=5U AS=1.7P AD=1.7P PS=10.68U
+ PD=10.68U rfmode=0
M$608 \$I4 pbias vdd vdd sg13_hv_pmos L=4U W=5U AS=1.7P AD=1.7P PS=10.68U
+ PD=10.68U rfmode=0
M$609 \$I4 pbias vdd vdd sg13_hv_pmos L=4U W=5U AS=1.7P AD=1.7P PS=10.68U
+ PD=10.68U rfmode=0
M$610 \$I4 pbias vdd vdd sg13_hv_pmos L=4U W=5U AS=1.7P AD=1.7P PS=10.68U
+ PD=10.68U rfmode=0
M$611 \$I4 pbias vdd vdd sg13_hv_pmos L=4U W=5U AS=1.7P AD=1.7P PS=10.68U
+ PD=10.68U rfmode=0
M$612 \$I4 pbias vdd vdd sg13_hv_pmos L=4U W=5U AS=1.7P AD=1.7P PS=10.68U
+ PD=10.68U rfmode=0
M$613 \$I4 pbias vdd vdd sg13_hv_pmos L=4U W=5U AS=1.7P AD=1.7P PS=10.68U
+ PD=10.68U rfmode=0
M$614 \$I4 pbias vdd vdd sg13_hv_pmos L=4U W=5U AS=1.7P AD=1.7P PS=10.68U
+ PD=10.68U rfmode=0
M$615 \$I4 pbias vdd vdd sg13_hv_pmos L=4U W=5U AS=1.7P AD=1.7P PS=10.68U
+ PD=10.68U rfmode=0
M$616 \$I9 pbias vdd vdd sg13_hv_pmos L=4U W=5U AS=1.7P AD=1.7P PS=10.68U
+ PD=10.68U rfmode=0
M$617 \$I9 pbias vdd vdd sg13_hv_pmos L=4U W=5U AS=1.7P AD=1.7P PS=10.68U
+ PD=10.68U rfmode=0
M$618 \$I9 pbias vdd vdd sg13_hv_pmos L=4U W=5U AS=1.7P AD=1.7P PS=10.68U
+ PD=10.68U rfmode=0
M$619 \$I9 pbias vdd vdd sg13_hv_pmos L=4U W=5U AS=1.7P AD=1.7P PS=10.68U
+ PD=10.68U rfmode=0
M$620 \$I9 pbias vdd vdd sg13_hv_pmos L=4U W=5U AS=1.7P AD=1.7P PS=10.68U
+ PD=10.68U rfmode=0
M$621 \$I9 pbias vdd vdd sg13_hv_pmos L=4U W=5U AS=1.7P AD=1.7P PS=10.68U
+ PD=10.68U rfmode=0
M$622 \$I9 pbias vdd vdd sg13_hv_pmos L=4U W=5U AS=1.7P AD=1.7P PS=10.68U
+ PD=10.68U rfmode=0
M$623 \$I9 pbias vdd vdd sg13_hv_pmos L=4U W=5U AS=1.7P AD=1.7P PS=10.68U
+ PD=10.68U rfmode=0
M$624 \$I9 pbias vdd vdd sg13_hv_pmos L=4U W=5U AS=1.7P AD=1.7P PS=10.68U
+ PD=10.68U rfmode=0
M$625 \$I9 pbias vdd vdd sg13_hv_pmos L=4U W=5U AS=1.7P AD=1.7P PS=10.68U
+ PD=10.68U rfmode=0
M$626 \$I9 pbias vdd vdd sg13_hv_pmos L=4U W=5U AS=1.7P AD=1.7P PS=10.68U
+ PD=10.68U rfmode=0
M$627 \$I9 pbias vdd vdd sg13_hv_pmos L=4U W=5U AS=1.7P AD=1.7P PS=10.68U
+ PD=10.68U rfmode=0
M$628 \$I9 pbias vdd vdd sg13_hv_pmos L=4U W=5U AS=1.7P AD=1.7P PS=10.68U
+ PD=10.68U rfmode=0
M$629 \$I9 pbias vdd vdd sg13_hv_pmos L=4U W=5U AS=1.7P AD=1.7P PS=10.68U
+ PD=10.68U rfmode=0
M$630 \$I9 pbias vdd vdd sg13_hv_pmos L=4U W=5U AS=1.7P AD=1.7P PS=10.68U
+ PD=10.68U rfmode=0
M$631 \$I9 pbias vdd vdd sg13_hv_pmos L=4U W=5U AS=1.7P AD=1.7P PS=10.68U
+ PD=10.68U rfmode=0
M$632 \$I9 pbias vdd vdd sg13_hv_pmos L=4U W=5U AS=1.7P AD=1.7P PS=10.68U
+ PD=10.68U rfmode=0
M$633 \$I9 pbias vdd vdd sg13_hv_pmos L=4U W=5U AS=1.7P AD=1.7P PS=10.68U
+ PD=10.68U rfmode=0
M$634 \$I9 pbias vdd vdd sg13_hv_pmos L=4U W=5U AS=1.7P AD=1.7P PS=10.68U
+ PD=10.68U rfmode=0
M$635 \$I9 pbias vdd vdd sg13_hv_pmos L=4U W=5U AS=1.7P AD=1.7P PS=10.68U
+ PD=10.68U rfmode=0
M$636 \$I9 pbias vdd vdd sg13_hv_pmos L=4U W=5U AS=1.7P AD=1.7P PS=10.68U
+ PD=10.68U rfmode=0
M$637 \$I9 pbias vdd vdd sg13_hv_pmos L=4U W=5U AS=1.7P AD=1.7P PS=10.68U
+ PD=10.68U rfmode=0
M$638 \$I9 pbias vdd vdd sg13_hv_pmos L=4U W=5U AS=1.7P AD=1.7P PS=10.68U
+ PD=10.68U rfmode=0
M$639 \$I9 pbias vdd vdd sg13_hv_pmos L=4U W=5U AS=1.7P AD=1.7P PS=10.68U
+ PD=10.68U rfmode=0
M$640 \$I9 pbias vdd vdd sg13_hv_pmos L=4U W=5U AS=1.7P AD=1.7P PS=10.68U
+ PD=10.68U rfmode=0
M$641 \$I9 pbias vdd vdd sg13_hv_pmos L=4U W=5U AS=1.7P AD=1.7P PS=10.68U
+ PD=10.68U rfmode=0
M$642 \$I9 pbias vdd vdd sg13_hv_pmos L=4U W=5U AS=1.7P AD=1.7P PS=10.68U
+ PD=10.68U rfmode=0
M$643 \$I9 pbias vdd vdd sg13_hv_pmos L=4U W=5U AS=1.7P AD=1.7P PS=10.68U
+ PD=10.68U rfmode=0
M$644 \$I9 pbias vdd vdd sg13_hv_pmos L=4U W=5U AS=1.7P AD=1.7P PS=10.68U
+ PD=10.68U rfmode=0
M$645 \$I9 pbias vdd vdd sg13_hv_pmos L=4U W=5U AS=1.7P AD=1.7P PS=10.68U
+ PD=10.68U rfmode=0
M$646 \$I9 pbias vdd vdd sg13_hv_pmos L=4U W=5U AS=1.7P AD=1.7P PS=10.68U
+ PD=10.68U rfmode=0
M$647 \$I9 pbias vdd vdd sg13_hv_pmos L=4U W=5U AS=1.7P AD=1.7P PS=10.68U
+ PD=10.68U rfmode=0
M$648 \$I9 pbias vdd vdd sg13_hv_pmos L=4U W=5U AS=1.7P AD=1.7P PS=10.68U
+ PD=10.68U rfmode=0
M$649 \$I9 pbias vdd vdd sg13_hv_pmos L=4U W=5U AS=1.7P AD=1.7P PS=10.68U
+ PD=10.68U rfmode=0
M$650 \$I9 pbias vdd vdd sg13_hv_pmos L=4U W=5U AS=1.7P AD=1.7P PS=10.68U
+ PD=10.68U rfmode=0
M$651 \$I9 pbias vdd vdd sg13_hv_pmos L=4U W=5U AS=1.7P AD=1.7P PS=10.68U
+ PD=10.68U rfmode=0
M$652 \$I9 pbias vdd vdd sg13_hv_pmos L=4U W=5U AS=1.7P AD=1.7P PS=10.68U
+ PD=10.68U rfmode=0
M$653 \$I9 pbias vdd vdd sg13_hv_pmos L=4U W=5U AS=1.7P AD=1.7P PS=10.68U
+ PD=10.68U rfmode=0
M$654 \$I9 pbias vdd vdd sg13_hv_pmos L=4U W=5U AS=1.7P AD=1.7P PS=10.68U
+ PD=10.68U rfmode=0
M$655 \$I9 pbias vdd vdd sg13_hv_pmos L=4U W=5U AS=1.7P AD=1.7P PS=10.68U
+ PD=10.68U rfmode=0
M$656 \$I9 pbias vdd vdd sg13_hv_pmos L=4U W=5U AS=1.7P AD=1.7P PS=10.68U
+ PD=10.68U rfmode=0
M$657 \$I9 pbias vdd vdd sg13_hv_pmos L=4U W=5U AS=1.7P AD=1.7P PS=10.68U
+ PD=10.68U rfmode=0
M$658 \$I9 pbias vdd vdd sg13_hv_pmos L=4U W=5U AS=1.7P AD=1.7P PS=10.68U
+ PD=10.68U rfmode=0
M$659 \$I9 pbias vdd vdd sg13_hv_pmos L=4U W=5U AS=1.7P AD=1.7P PS=10.68U
+ PD=10.68U rfmode=0
M$660 \$I9 pbias vdd vdd sg13_hv_pmos L=4U W=5U AS=1.7P AD=1.7P PS=10.68U
+ PD=10.68U rfmode=0
M$661 \$I9 pbias vdd vdd sg13_hv_pmos L=4U W=5U AS=1.7P AD=1.7P PS=10.68U
+ PD=10.68U rfmode=0
M$662 \$I9 pbias vdd vdd sg13_hv_pmos L=4U W=5U AS=1.7P AD=1.7P PS=10.68U
+ PD=10.68U rfmode=0
M$663 \$I9 pbias vdd vdd sg13_hv_pmos L=4U W=5U AS=1.7P AD=1.7P PS=10.68U
+ PD=10.68U rfmode=0
M$664 \$I8 pbias vdd vdd sg13_hv_pmos L=4U W=5U AS=1.7P AD=1.7P PS=10.68U
+ PD=10.68U rfmode=0
M$665 \$I8 pbias vdd vdd sg13_hv_pmos L=4U W=5U AS=1.7P AD=1.7P PS=10.68U
+ PD=10.68U rfmode=0
M$666 \$I8 pbias vdd vdd sg13_hv_pmos L=4U W=5U AS=1.7P AD=1.7P PS=10.68U
+ PD=10.68U rfmode=0
M$667 \$I8 pbias vdd vdd sg13_hv_pmos L=4U W=5U AS=1.7P AD=1.7P PS=10.68U
+ PD=10.68U rfmode=0
M$668 \$I8 pbias vdd vdd sg13_hv_pmos L=4U W=5U AS=1.7P AD=1.7P PS=10.68U
+ PD=10.68U rfmode=0
M$669 \$I8 pbias vdd vdd sg13_hv_pmos L=4U W=5U AS=1.7P AD=1.7P PS=10.68U
+ PD=10.68U rfmode=0
M$670 \$I8 pbias vdd vdd sg13_hv_pmos L=4U W=5U AS=1.7P AD=1.7P PS=10.68U
+ PD=10.68U rfmode=0
M$671 \$I8 pbias vdd vdd sg13_hv_pmos L=4U W=5U AS=1.7P AD=1.7P PS=10.68U
+ PD=10.68U rfmode=0
M$672 \$I8 pbias vdd vdd sg13_hv_pmos L=4U W=5U AS=1.7P AD=1.7P PS=10.68U
+ PD=10.68U rfmode=0
M$673 \$I8 pbias vdd vdd sg13_hv_pmos L=4U W=5U AS=1.7P AD=1.7P PS=10.68U
+ PD=10.68U rfmode=0
M$674 \$I8 pbias vdd vdd sg13_hv_pmos L=4U W=5U AS=1.7P AD=1.7P PS=10.68U
+ PD=10.68U rfmode=0
M$675 \$I8 pbias vdd vdd sg13_hv_pmos L=4U W=5U AS=1.7P AD=1.7P PS=10.68U
+ PD=10.68U rfmode=0
M$676 \$I8 pbias vdd vdd sg13_hv_pmos L=4U W=5U AS=1.7P AD=1.7P PS=10.68U
+ PD=10.68U rfmode=0
M$677 \$I8 pbias vdd vdd sg13_hv_pmos L=4U W=5U AS=1.7P AD=1.7P PS=10.68U
+ PD=10.68U rfmode=0
M$678 \$I8 pbias vdd vdd sg13_hv_pmos L=4U W=5U AS=1.7P AD=1.7P PS=10.68U
+ PD=10.68U rfmode=0
M$679 \$I8 pbias vdd vdd sg13_hv_pmos L=4U W=5U AS=1.7P AD=1.7P PS=10.68U
+ PD=10.68U rfmode=0
M$680 \$I8 pbias vdd vdd sg13_hv_pmos L=4U W=5U AS=1.7P AD=1.7P PS=10.68U
+ PD=10.68U rfmode=0
M$681 \$I8 pbias vdd vdd sg13_hv_pmos L=4U W=5U AS=1.7P AD=1.7P PS=10.68U
+ PD=10.68U rfmode=0
M$682 \$I8 pbias vdd vdd sg13_hv_pmos L=4U W=5U AS=1.7P AD=1.7P PS=10.68U
+ PD=10.68U rfmode=0
M$683 \$I8 pbias vdd vdd sg13_hv_pmos L=4U W=5U AS=1.7P AD=1.7P PS=10.68U
+ PD=10.68U rfmode=0
M$684 \$I8 pbias vdd vdd sg13_hv_pmos L=4U W=5U AS=1.7P AD=1.7P PS=10.68U
+ PD=10.68U rfmode=0
M$685 \$I8 pbias vdd vdd sg13_hv_pmos L=4U W=5U AS=1.7P AD=1.7P PS=10.68U
+ PD=10.68U rfmode=0
M$686 \$I8 pbias vdd vdd sg13_hv_pmos L=4U W=5U AS=1.7P AD=1.7P PS=10.68U
+ PD=10.68U rfmode=0
M$687 \$I8 pbias vdd vdd sg13_hv_pmos L=4U W=5U AS=1.7P AD=1.7P PS=10.68U
+ PD=10.68U rfmode=0
M$688 \$I8 pbias vdd vdd sg13_hv_pmos L=4U W=5U AS=1.7P AD=1.7P PS=10.68U
+ PD=10.68U rfmode=0
M$689 \$I8 pbias vdd vdd sg13_hv_pmos L=4U W=5U AS=1.7P AD=1.7P PS=10.68U
+ PD=10.68U rfmode=0
M$690 \$I8 pbias vdd vdd sg13_hv_pmos L=4U W=5U AS=1.7P AD=1.7P PS=10.68U
+ PD=10.68U rfmode=0
M$691 \$I8 pbias vdd vdd sg13_hv_pmos L=4U W=5U AS=1.7P AD=1.7P PS=10.68U
+ PD=10.68U rfmode=0
M$692 \$I8 pbias vdd vdd sg13_hv_pmos L=4U W=5U AS=1.7P AD=1.7P PS=10.68U
+ PD=10.68U rfmode=0
M$693 \$I8 pbias vdd vdd sg13_hv_pmos L=4U W=5U AS=1.7P AD=1.7P PS=10.68U
+ PD=10.68U rfmode=0
M$694 \$I8 pbias vdd vdd sg13_hv_pmos L=4U W=5U AS=1.7P AD=1.7P PS=10.68U
+ PD=10.68U rfmode=0
M$695 \$I8 pbias vdd vdd sg13_hv_pmos L=4U W=5U AS=1.7P AD=1.7P PS=10.68U
+ PD=10.68U rfmode=0
M$696 \$I8 pbias vdd vdd sg13_hv_pmos L=4U W=5U AS=1.7P AD=1.7P PS=10.68U
+ PD=10.68U rfmode=0
M$697 \$I8 pbias vdd vdd sg13_hv_pmos L=4U W=5U AS=1.7P AD=1.7P PS=10.68U
+ PD=10.68U rfmode=0
M$698 \$I8 pbias vdd vdd sg13_hv_pmos L=4U W=5U AS=1.7P AD=1.7P PS=10.68U
+ PD=10.68U rfmode=0
M$699 \$I8 pbias vdd vdd sg13_hv_pmos L=4U W=5U AS=1.7P AD=1.7P PS=10.68U
+ PD=10.68U rfmode=0
M$700 \$I8 pbias vdd vdd sg13_hv_pmos L=4U W=5U AS=1.7P AD=1.7P PS=10.68U
+ PD=10.68U rfmode=0
M$701 \$I8 pbias vdd vdd sg13_hv_pmos L=4U W=5U AS=1.7P AD=1.7P PS=10.68U
+ PD=10.68U rfmode=0
M$702 \$I8 pbias vdd vdd sg13_hv_pmos L=4U W=5U AS=1.7P AD=1.7P PS=10.68U
+ PD=10.68U rfmode=0
M$703 \$I8 pbias vdd vdd sg13_hv_pmos L=4U W=5U AS=1.7P AD=1.7P PS=10.68U
+ PD=10.68U rfmode=0
M$704 \$I8 pbias vdd vdd sg13_hv_pmos L=4U W=5U AS=1.7P AD=1.7P PS=10.68U
+ PD=10.68U rfmode=0
M$705 \$I8 pbias vdd vdd sg13_hv_pmos L=4U W=5U AS=1.7P AD=1.7P PS=10.68U
+ PD=10.68U rfmode=0
M$706 \$I8 pbias vdd vdd sg13_hv_pmos L=4U W=5U AS=1.7P AD=1.7P PS=10.68U
+ PD=10.68U rfmode=0
M$707 \$I8 pbias vdd vdd sg13_hv_pmos L=4U W=5U AS=1.7P AD=1.7P PS=10.68U
+ PD=10.68U rfmode=0
M$708 \$I8 pbias vdd vdd sg13_hv_pmos L=4U W=5U AS=1.7P AD=1.7P PS=10.68U
+ PD=10.68U rfmode=0
M$709 \$I8 pbias vdd vdd sg13_hv_pmos L=4U W=5U AS=1.7P AD=1.7P PS=10.68U
+ PD=10.68U rfmode=0
M$710 \$I8 pbias vdd vdd sg13_hv_pmos L=4U W=5U AS=1.7P AD=1.7P PS=10.68U
+ PD=10.68U rfmode=0
M$711 \$I8 pbias vdd vdd sg13_hv_pmos L=4U W=5U AS=1.7P AD=1.7P PS=10.68U
+ PD=10.68U rfmode=0
M$712 \$21 \$16 pcasc vss sg13_hv_nmos L=1U W=10U AS=3.4P AD=3.4P PS=20.68U
+ PD=20.68U rfmode=0
M$713 \$21 \$16 pcasc vss sg13_hv_nmos L=1U W=10U AS=3.4P AD=3.4P PS=20.68U
+ PD=20.68U rfmode=0
M$714 \$21 \$16 pcasc vss sg13_hv_nmos L=1U W=10U AS=3.4P AD=3.4P PS=20.68U
+ PD=20.68U rfmode=0
M$715 \$21 \$16 pcasc vss sg13_hv_nmos L=1U W=10U AS=3.4P AD=3.4P PS=20.68U
+ PD=20.68U rfmode=0
M$716 \$21 \$16 pcasc vss sg13_hv_nmos L=1U W=10U AS=3.4P AD=3.4P PS=20.68U
+ PD=20.68U rfmode=0
M$717 \$21 \$16 pcasc vss sg13_hv_nmos L=1U W=10U AS=3.4P AD=3.4P PS=20.68U
+ PD=20.68U rfmode=0
M$718 \$21 \$16 pcasc vss sg13_hv_nmos L=1U W=10U AS=3.4P AD=3.4P PS=20.68U
+ PD=20.68U rfmode=0
M$719 \$21 \$16 pcasc vss sg13_hv_nmos L=1U W=10U AS=3.4P AD=3.4P PS=20.68U
+ PD=20.68U rfmode=0
M$720 \$21 \$16 pcasc vss sg13_hv_nmos L=1U W=10U AS=3.4P AD=3.4P PS=20.68U
+ PD=20.68U rfmode=0
M$721 \$21 \$16 pcasc vss sg13_hv_nmos L=1U W=10U AS=3.4P AD=3.4P PS=20.68U
+ PD=20.68U rfmode=0
M$722 \$21 \$16 pcasc vss sg13_hv_nmos L=1U W=10U AS=3.4P AD=3.4P PS=20.68U
+ PD=20.68U rfmode=0
M$723 \$21 \$16 pcasc vss sg13_hv_nmos L=1U W=10U AS=3.4P AD=3.4P PS=20.68U
+ PD=20.68U rfmode=0
M$724 \$21 \$16 pcasc vss sg13_hv_nmos L=1U W=10U AS=3.4P AD=3.4P PS=20.68U
+ PD=20.68U rfmode=0
M$725 \$21 \$16 pcasc vss sg13_hv_nmos L=1U W=10U AS=3.4P AD=3.4P PS=20.68U
+ PD=20.68U rfmode=0
M$726 \$21 \$16 pcasc vss sg13_hv_nmos L=1U W=10U AS=3.4P AD=3.4P PS=20.68U
+ PD=20.68U rfmode=0
M$727 \$21 \$16 pcasc vss sg13_hv_nmos L=1U W=10U AS=3.4P AD=3.4P PS=20.68U
+ PD=20.68U rfmode=0
M$728 \$21 \$16 pcasc vss sg13_hv_nmos L=1U W=10U AS=3.4P AD=3.4P PS=20.68U
+ PD=20.68U rfmode=0
M$729 \$21 \$16 pcasc vss sg13_hv_nmos L=1U W=10U AS=3.4P AD=3.4P PS=20.68U
+ PD=20.68U rfmode=0
M$730 \$21 \$16 pcasc vss sg13_hv_nmos L=1U W=10U AS=3.4P AD=3.4P PS=20.68U
+ PD=20.68U rfmode=0
M$731 \$21 \$16 pcasc vss sg13_hv_nmos L=1U W=10U AS=3.4P AD=3.4P PS=20.68U
+ PD=20.68U rfmode=0
M$732 \$21 \$16 pcasc vss sg13_hv_nmos L=1U W=10U AS=3.4P AD=3.4P PS=20.68U
+ PD=20.68U rfmode=0
M$733 \$21 \$16 pcasc vss sg13_hv_nmos L=1U W=10U AS=3.4P AD=3.4P PS=20.68U
+ PD=20.68U rfmode=0
M$734 \$21 \$16 pcasc vss sg13_hv_nmos L=1U W=10U AS=3.4P AD=3.4P PS=20.68U
+ PD=20.68U rfmode=0
M$735 \$21 \$16 pcasc vss sg13_hv_nmos L=1U W=10U AS=3.4P AD=3.4P PS=20.68U
+ PD=20.68U rfmode=0
Q$736 \$I12 \$I12 vss vss npn13G2 we=0.07 le=0.9 Nx=1 m=1
Q$737 \$I12 \$I12 vss vss npn13G2 we=0.07 le=0.9 Nx=1 m=1
Q$738 \$I12 \$I12 vss vss npn13G2 we=0.07 le=0.9 Nx=1 m=1
Q$739 \$I12 \$I12 vss vss npn13G2 we=0.07 le=0.9 Nx=1 m=1
Q$740 \$I12 \$I12 vss vss npn13G2 we=0.07 le=0.9 Nx=1 m=1
Q$741 \$I12 \$I12 vss vss npn13G2 we=0.07 le=0.9 Nx=1 m=1
Q$742 \$I12 \$I12 vss vss npn13G2 we=0.07 le=0.9 Nx=1 m=1
Q$743 \$I12 \$I12 vss vss npn13G2 we=0.07 le=0.9 Nx=1 m=1
Q$744 \$I12 \$I12 vss vss npn13G2 we=0.07 le=0.9 Nx=1 m=1
Q$745 \$I12 \$I12 vss vss npn13G2 we=0.07 le=0.9 Nx=1 m=1
Q$746 \$I12 \$I12 vss vss npn13G2 we=0.07 le=0.9 Nx=1 m=1
Q$747 \$I12 \$I12 vss vss npn13G2 we=0.07 le=0.9 Nx=1 m=1
Q$748 \$I12 \$I12 vss vss npn13G2 we=0.07 le=0.9 Nx=1 m=1
Q$749 \$I12 \$I12 vss vss npn13G2 we=0.07 le=0.9 Nx=1 m=1
Q$750 \$I12 \$I12 vss vss npn13G2 we=0.07 le=0.9 Nx=1 m=1
Q$751 \$I12 \$I12 vss vss npn13G2 we=0.07 le=0.9 Nx=1 m=1
Q$752 \$I12 \$I12 vss vss npn13G2 we=0.07 le=0.9 Nx=1 m=1
Q$753 \$I12 \$I12 vss vss npn13G2 we=0.07 le=0.9 Nx=1 m=1
Q$754 \$I12 \$I12 vss vss npn13G2 we=0.07 le=0.9 Nx=1 m=1
Q$755 \$I12 \$I12 vss vss npn13G2 we=0.07 le=0.9 Nx=1 m=1
Q$756 \$I12 \$I12 vss vss npn13G2 we=0.07 le=0.9 Nx=1 m=1
Q$757 \$I12 \$I12 vss vss npn13G2 we=0.07 le=0.9 Nx=1 m=1
Q$758 \$I12 \$I12 vss vss npn13G2 we=0.07 le=0.9 Nx=1 m=1
Q$759 \$I12 \$I12 vss vss npn13G2 we=0.07 le=0.9 Nx=1 m=1
Q$760 vbe vbe vss vss npn13G2 we=0.07 le=0.9 Nx=1 m=1
Q$761 vbe vbe vss vss npn13G2 we=0.07 le=0.9 Nx=1 m=1
Q$762 vbe vbe vss vss npn13G2 we=0.07 le=0.9 Nx=1 m=1
Q$763 vbe vbe vss vss npn13G2 we=0.07 le=0.9 Nx=1 m=1
Q$764 vbe vbe vss vss npn13G2 we=0.07 le=0.9 Nx=1 m=1
Q$765 vbe vbe vss vss npn13G2 we=0.07 le=0.9 Nx=1 m=1
Q$766 vbe vbe vss vss npn13G2 we=0.07 le=0.9 Nx=1 m=1
Q$767 vbe vbe vss vss npn13G2 we=0.07 le=0.9 Nx=1 m=1
Q$768 vbe vbe vss vss npn13G2 we=0.07 le=0.9 Nx=1 m=1
Q$769 vbe vbe vss vss npn13G2 we=0.07 le=0.9 Nx=1 m=1
Q$770 vbe vbe vss vss npn13G2 we=0.07 le=0.9 Nx=1 m=1
Q$771 vbe vbe vss vss npn13G2 we=0.07 le=0.9 Nx=1 m=1
Q$772 vbe vbe vss vss npn13G2 we=0.07 le=0.9 Nx=1 m=1
Q$773 vbe vbe vss vss npn13G2 we=0.07 le=0.9 Nx=1 m=1
Q$774 vbe vbe vss vss npn13G2 we=0.07 le=0.9 Nx=1 m=1
Q$775 vbe vbe vss vss npn13G2 we=0.07 le=0.9 Nx=1 m=1
Q$776 vbe vbe vss vss npn13G2 we=0.07 le=0.9 Nx=1 m=1
Q$777 vbe vbe vss vss npn13G2 we=0.07 le=0.9 Nx=1 m=1
Q$778 vbe vbe vss vss npn13G2 we=0.07 le=0.9 Nx=1 m=1
Q$779 vbe vbe vss vss npn13G2 we=0.07 le=0.9 Nx=1 m=1
Q$780 vbe vbe vss vss npn13G2 we=0.07 le=0.9 Nx=1 m=1
Q$781 vbe vbe vss vss npn13G2 we=0.07 le=0.9 Nx=1 m=1
Q$782 vbe vbe vss vss npn13G2 we=0.07 le=0.9 Nx=1 m=1
Q$783 vbe vbe vss vss npn13G2 we=0.07 le=0.9 Nx=1 m=1
Q$784 vbe \$20 vss vss npn13G2 we=0.07 le=0.9 Nx=1 m=1
Q$785 vbe \$20 vss vss npn13G2 we=0.07 le=0.9 Nx=1 m=1
Q$786 vbe \$20 vss vss npn13G2 we=0.07 le=0.9 Nx=1 m=1
Q$787 vbe \$20 vss vss npn13G2 we=0.07 le=0.9 Nx=1 m=1
Q$788 vbe \$20 vss vss npn13G2 we=0.07 le=0.9 Nx=1 m=1
Q$789 vbe \$20 vss vss npn13G2 we=0.07 le=0.9 Nx=1 m=1
Q$790 vbe \$20 vss vss npn13G2 we=0.07 le=0.9 Nx=1 m=1
Q$791 vbe \$20 vss vss npn13G2 we=0.07 le=0.9 Nx=1 m=1
Q$792 vbe \$20 vss vss npn13G2 we=0.07 le=0.9 Nx=1 m=1
Q$793 vbe \$20 vss vss npn13G2 we=0.07 le=0.9 Nx=1 m=1
Q$794 vbe \$20 vss vss npn13G2 we=0.07 le=0.9 Nx=1 m=1
Q$795 vbe \$20 vss vss npn13G2 we=0.07 le=0.9 Nx=1 m=1
Q$796 vbe \$20 vss vss npn13G2 we=0.07 le=0.9 Nx=1 m=1
Q$797 vbe \$20 vss vss npn13G2 we=0.07 le=0.9 Nx=1 m=1
Q$798 vbe \$20 vss vss npn13G2 we=0.07 le=0.9 Nx=1 m=1
Q$799 vbe \$20 vss vss npn13G2 we=0.07 le=0.9 Nx=1 m=1
Q$800 vbe \$20 vss vss npn13G2 we=0.07 le=0.9 Nx=1 m=1
Q$801 vbe \$20 vss vss npn13G2 we=0.07 le=0.9 Nx=1 m=1
Q$802 vbe \$20 vss vss npn13G2 we=0.07 le=0.9 Nx=1 m=1
Q$803 vbe \$20 vss vss npn13G2 we=0.07 le=0.9 Nx=1 m=1
Q$804 vbe \$20 vss vss npn13G2 we=0.07 le=0.9 Nx=1 m=1
Q$805 vbe \$20 vss vss npn13G2 we=0.07 le=0.9 Nx=1 m=1
Q$806 vbe \$20 vss vss npn13G2 we=0.07 le=0.9 Nx=1 m=1
Q$807 vbe \$20 vss vss npn13G2 we=0.07 le=0.9 Nx=1 m=1
Q$808 \$21 vbe dvbe vss npn13G2 we=0.07 le=0.9 Nx=1 m=1
Q$809 \$21 vbe dvbe vss npn13G2 we=0.07 le=0.9 Nx=1 m=1
Q$810 \$21 vbe dvbe vss npn13G2 we=0.07 le=0.9 Nx=1 m=1
Q$811 \$21 vbe dvbe vss npn13G2 we=0.07 le=0.9 Nx=1 m=1
Q$812 \$21 vbe dvbe vss npn13G2 we=0.07 le=0.9 Nx=1 m=1
Q$813 \$21 vbe dvbe vss npn13G2 we=0.07 le=0.9 Nx=1 m=1
Q$814 \$21 vbe dvbe vss npn13G2 we=0.07 le=0.9 Nx=1 m=1
Q$815 \$21 vbe dvbe vss npn13G2 we=0.07 le=0.9 Nx=1 m=1
Q$816 \$21 vbe dvbe vss npn13G2 we=0.07 le=0.9 Nx=1 m=1
Q$817 \$21 vbe dvbe vss npn13G2 we=0.07 le=0.9 Nx=1 m=1
Q$818 \$21 vbe dvbe vss npn13G2 we=0.07 le=0.9 Nx=1 m=1
Q$819 \$21 vbe dvbe vss npn13G2 we=0.07 le=0.9 Nx=1 m=1
Q$820 \$21 vbe dvbe vss npn13G2 we=0.07 le=0.9 Nx=1 m=1
Q$821 \$21 vbe dvbe vss npn13G2 we=0.07 le=0.9 Nx=1 m=1
Q$822 \$21 vbe dvbe vss npn13G2 we=0.07 le=0.9 Nx=1 m=1
Q$823 \$21 vbe dvbe vss npn13G2 we=0.07 le=0.9 Nx=1 m=1
Q$824 \$21 vbe dvbe vss npn13G2 we=0.07 le=0.9 Nx=1 m=1
Q$825 \$21 vbe dvbe vss npn13G2 we=0.07 le=0.9 Nx=1 m=1
Q$826 \$21 vbe dvbe vss npn13G2 we=0.07 le=0.9 Nx=1 m=1
Q$827 \$21 vbe dvbe vss npn13G2 we=0.07 le=0.9 Nx=1 m=1
Q$828 \$21 vbe dvbe vss npn13G2 we=0.07 le=0.9 Nx=1 m=1
Q$829 \$21 vbe dvbe vss npn13G2 we=0.07 le=0.9 Nx=1 m=1
Q$830 \$21 vbe dvbe vss npn13G2 we=0.07 le=0.9 Nx=1 m=1
Q$831 \$21 vbe dvbe vss npn13G2 we=0.07 le=0.9 Nx=1 m=1
Q$832 \$21 vbe dvbe vss npn13G2 we=0.07 le=0.9 Nx=1 m=1
Q$833 \$21 vbe dvbe vss npn13G2 we=0.07 le=0.9 Nx=1 m=1
Q$834 \$21 vbe dvbe vss npn13G2 we=0.07 le=0.9 Nx=1 m=1
Q$835 \$21 vbe dvbe vss npn13G2 we=0.07 le=0.9 Nx=1 m=1
Q$836 \$21 vbe dvbe vss npn13G2 we=0.07 le=0.9 Nx=1 m=1
Q$837 \$21 vbe dvbe vss npn13G2 we=0.07 le=0.9 Nx=1 m=1
Q$838 \$21 vbe dvbe vss npn13G2 we=0.07 le=0.9 Nx=1 m=1
Q$839 \$21 vbe dvbe vss npn13G2 we=0.07 le=0.9 Nx=1 m=1
Q$840 \$21 vbe dvbe vss npn13G2 we=0.07 le=0.9 Nx=1 m=1
Q$841 \$21 vbe dvbe vss npn13G2 we=0.07 le=0.9 Nx=1 m=1
Q$842 \$21 vbe dvbe vss npn13G2 we=0.07 le=0.9 Nx=1 m=1
Q$843 \$21 vbe dvbe vss npn13G2 we=0.07 le=0.9 Nx=1 m=1
Q$844 \$21 vbe dvbe vss npn13G2 we=0.07 le=0.9 Nx=1 m=1
Q$845 \$21 vbe dvbe vss npn13G2 we=0.07 le=0.9 Nx=1 m=1
Q$846 \$21 vbe dvbe vss npn13G2 we=0.07 le=0.9 Nx=1 m=1
Q$847 \$21 vbe dvbe vss npn13G2 we=0.07 le=0.9 Nx=1 m=1
Q$848 \$21 vbe dvbe vss npn13G2 we=0.07 le=0.9 Nx=1 m=1
Q$849 \$21 vbe dvbe vss npn13G2 we=0.07 le=0.9 Nx=1 m=1
Q$850 \$21 vbe dvbe vss npn13G2 we=0.07 le=0.9 Nx=1 m=1
Q$851 \$21 vbe dvbe vss npn13G2 we=0.07 le=0.9 Nx=1 m=1
Q$852 \$21 vbe dvbe vss npn13G2 we=0.07 le=0.9 Nx=1 m=1
Q$853 \$21 vbe dvbe vss npn13G2 we=0.07 le=0.9 Nx=1 m=1
Q$854 \$21 vbe dvbe vss npn13G2 we=0.07 le=0.9 Nx=1 m=1
Q$855 \$21 vbe dvbe vss npn13G2 we=0.07 le=0.9 Nx=1 m=1
Q$856 \$21 vbe dvbe vss npn13G2 we=0.07 le=0.9 Nx=1 m=1
Q$857 \$21 vbe dvbe vss npn13G2 we=0.07 le=0.9 Nx=1 m=1
Q$858 \$21 vbe dvbe vss npn13G2 we=0.07 le=0.9 Nx=1 m=1
Q$859 \$21 vbe dvbe vss npn13G2 we=0.07 le=0.9 Nx=1 m=1
Q$860 \$21 vbe dvbe vss npn13G2 we=0.07 le=0.9 Nx=1 m=1
Q$861 \$21 vbe dvbe vss npn13G2 we=0.07 le=0.9 Nx=1 m=1
Q$862 \$21 vbe dvbe vss npn13G2 we=0.07 le=0.9 Nx=1 m=1
Q$863 \$21 vbe dvbe vss npn13G2 we=0.07 le=0.9 Nx=1 m=1
Q$864 \$21 vbe dvbe vss npn13G2 we=0.07 le=0.9 Nx=1 m=1
Q$865 \$21 vbe dvbe vss npn13G2 we=0.07 le=0.9 Nx=1 m=1
Q$866 \$21 vbe dvbe vss npn13G2 we=0.07 le=0.9 Nx=1 m=1
Q$867 \$21 vbe dvbe vss npn13G2 we=0.07 le=0.9 Nx=1 m=1
Q$868 \$21 vbe dvbe vss npn13G2 we=0.07 le=0.9 Nx=1 m=1
Q$869 \$21 vbe dvbe vss npn13G2 we=0.07 le=0.9 Nx=1 m=1
Q$870 \$21 vbe dvbe vss npn13G2 we=0.07 le=0.9 Nx=1 m=1
Q$871 \$21 vbe dvbe vss npn13G2 we=0.07 le=0.9 Nx=1 m=1
Q$872 \$21 vbe dvbe vss npn13G2 we=0.07 le=0.9 Nx=1 m=1
Q$873 \$21 vbe dvbe vss npn13G2 we=0.07 le=0.9 Nx=1 m=1
Q$874 \$21 vbe dvbe vss npn13G2 we=0.07 le=0.9 Nx=1 m=1
Q$875 \$21 vbe dvbe vss npn13G2 we=0.07 le=0.9 Nx=1 m=1
Q$876 \$21 vbe dvbe vss npn13G2 we=0.07 le=0.9 Nx=1 m=1
Q$877 \$21 vbe dvbe vss npn13G2 we=0.07 le=0.9 Nx=1 m=1
Q$878 \$21 vbe dvbe vss npn13G2 we=0.07 le=0.9 Nx=1 m=1
Q$879 \$21 vbe dvbe vss npn13G2 we=0.07 le=0.9 Nx=1 m=1
Q$880 \$21 vbe dvbe vss npn13G2 we=0.07 le=0.9 Nx=1 m=1
Q$881 \$21 vbe dvbe vss npn13G2 we=0.07 le=0.9 Nx=1 m=1
Q$882 \$21 vbe dvbe vss npn13G2 we=0.07 le=0.9 Nx=1 m=1
Q$883 \$21 vbe dvbe vss npn13G2 we=0.07 le=0.9 Nx=1 m=1
Q$884 \$21 vbe dvbe vss npn13G2 we=0.07 le=0.9 Nx=1 m=1
Q$885 \$21 vbe dvbe vss npn13G2 we=0.07 le=0.9 Nx=1 m=1
Q$886 \$21 vbe dvbe vss npn13G2 we=0.07 le=0.9 Nx=1 m=1
Q$887 \$21 vbe dvbe vss npn13G2 we=0.07 le=0.9 Nx=1 m=1
Q$888 \$21 vbe dvbe vss npn13G2 we=0.07 le=0.9 Nx=1 m=1
Q$889 \$21 vbe dvbe vss npn13G2 we=0.07 le=0.9 Nx=1 m=1
Q$890 \$21 vbe dvbe vss npn13G2 we=0.07 le=0.9 Nx=1 m=1
Q$891 \$21 vbe dvbe vss npn13G2 we=0.07 le=0.9 Nx=1 m=1
Q$892 \$21 vbe dvbe vss npn13G2 we=0.07 le=0.9 Nx=1 m=1
Q$893 \$21 vbe dvbe vss npn13G2 we=0.07 le=0.9 Nx=1 m=1
Q$894 \$21 vbe dvbe vss npn13G2 we=0.07 le=0.9 Nx=1 m=1
Q$895 \$21 vbe dvbe vss npn13G2 we=0.07 le=0.9 Nx=1 m=1
Q$896 \$21 vbe dvbe vss npn13G2 we=0.07 le=0.9 Nx=1 m=1
Q$897 \$21 vbe dvbe vss npn13G2 we=0.07 le=0.9 Nx=1 m=1
Q$898 \$21 vbe dvbe vss npn13G2 we=0.07 le=0.9 Nx=1 m=1
Q$899 \$21 vbe dvbe vss npn13G2 we=0.07 le=0.9 Nx=1 m=1
Q$900 \$21 vbe dvbe vss npn13G2 we=0.07 le=0.9 Nx=1 m=1
Q$901 \$21 vbe dvbe vss npn13G2 we=0.07 le=0.9 Nx=1 m=1
Q$902 \$21 vbe dvbe vss npn13G2 we=0.07 le=0.9 Nx=1 m=1
Q$903 \$21 vbe dvbe vss npn13G2 we=0.07 le=0.9 Nx=1 m=1
Q$904 \$21 vbe dvbe vss npn13G2 we=0.07 le=0.9 Nx=1 m=1
Q$905 \$21 vbe dvbe vss npn13G2 we=0.07 le=0.9 Nx=1 m=1
Q$906 \$21 vbe dvbe vss npn13G2 we=0.07 le=0.9 Nx=1 m=1
Q$907 \$21 vbe dvbe vss npn13G2 we=0.07 le=0.9 Nx=1 m=1
Q$908 \$21 vbe dvbe vss npn13G2 we=0.07 le=0.9 Nx=1 m=1
Q$909 \$21 vbe dvbe vss npn13G2 we=0.07 le=0.9 Nx=1 m=1
Q$910 \$21 vbe dvbe vss npn13G2 we=0.07 le=0.9 Nx=1 m=1
Q$911 \$21 vbe dvbe vss npn13G2 we=0.07 le=0.9 Nx=1 m=1
Q$912 \$21 vbe dvbe vss npn13G2 we=0.07 le=0.9 Nx=1 m=1
Q$913 \$21 vbe dvbe vss npn13G2 we=0.07 le=0.9 Nx=1 m=1
Q$914 \$21 vbe dvbe vss npn13G2 we=0.07 le=0.9 Nx=1 m=1
Q$915 \$21 vbe dvbe vss npn13G2 we=0.07 le=0.9 Nx=1 m=1
Q$916 \$21 vbe dvbe vss npn13G2 we=0.07 le=0.9 Nx=1 m=1
Q$917 \$21 vbe dvbe vss npn13G2 we=0.07 le=0.9 Nx=1 m=1
Q$918 \$21 vbe dvbe vss npn13G2 we=0.07 le=0.9 Nx=1 m=1
Q$919 \$21 vbe dvbe vss npn13G2 we=0.07 le=0.9 Nx=1 m=1
Q$920 \$21 vbe dvbe vss npn13G2 we=0.07 le=0.9 Nx=1 m=1
Q$921 \$21 vbe dvbe vss npn13G2 we=0.07 le=0.9 Nx=1 m=1
Q$922 \$21 vbe dvbe vss npn13G2 we=0.07 le=0.9 Nx=1 m=1
Q$923 \$21 vbe dvbe vss npn13G2 we=0.07 le=0.9 Nx=1 m=1
Q$924 \$21 vbe dvbe vss npn13G2 we=0.07 le=0.9 Nx=1 m=1
Q$925 \$21 vbe dvbe vss npn13G2 we=0.07 le=0.9 Nx=1 m=1
Q$926 \$21 vbe dvbe vss npn13G2 we=0.07 le=0.9 Nx=1 m=1
Q$927 \$21 vbe dvbe vss npn13G2 we=0.07 le=0.9 Nx=1 m=1
Q$928 \$21 vbe dvbe vss npn13G2 we=0.07 le=0.9 Nx=1 m=1
Q$929 \$21 vbe dvbe vss npn13G2 we=0.07 le=0.9 Nx=1 m=1
Q$930 \$21 vbe dvbe vss npn13G2 we=0.07 le=0.9 Nx=1 m=1
Q$931 \$21 vbe dvbe vss npn13G2 we=0.07 le=0.9 Nx=1 m=1
Q$932 \$21 vbe dvbe vss npn13G2 we=0.07 le=0.9 Nx=1 m=1
Q$933 \$21 vbe dvbe vss npn13G2 we=0.07 le=0.9 Nx=1 m=1
Q$934 \$21 vbe dvbe vss npn13G2 we=0.07 le=0.9 Nx=1 m=1
Q$935 \$21 vbe dvbe vss npn13G2 we=0.07 le=0.9 Nx=1 m=1
Q$936 \$21 vbe dvbe vss npn13G2 we=0.07 le=0.9 Nx=1 m=1
Q$937 \$21 vbe dvbe vss npn13G2 we=0.07 le=0.9 Nx=1 m=1
Q$938 \$21 vbe dvbe vss npn13G2 we=0.07 le=0.9 Nx=1 m=1
Q$939 \$21 vbe dvbe vss npn13G2 we=0.07 le=0.9 Nx=1 m=1
Q$940 \$21 vbe dvbe vss npn13G2 we=0.07 le=0.9 Nx=1 m=1
Q$941 \$21 vbe dvbe vss npn13G2 we=0.07 le=0.9 Nx=1 m=1
Q$942 \$21 vbe dvbe vss npn13G2 we=0.07 le=0.9 Nx=1 m=1
Q$943 \$21 vbe dvbe vss npn13G2 we=0.07 le=0.9 Nx=1 m=1
Q$944 \$21 vbe dvbe vss npn13G2 we=0.07 le=0.9 Nx=1 m=1
Q$945 \$21 vbe dvbe vss npn13G2 we=0.07 le=0.9 Nx=1 m=1
Q$946 \$21 vbe dvbe vss npn13G2 we=0.07 le=0.9 Nx=1 m=1
Q$947 \$21 vbe dvbe vss npn13G2 we=0.07 le=0.9 Nx=1 m=1
Q$948 \$21 vbe dvbe vss npn13G2 we=0.07 le=0.9 Nx=1 m=1
Q$949 \$21 vbe dvbe vss npn13G2 we=0.07 le=0.9 Nx=1 m=1
Q$950 \$21 vbe dvbe vss npn13G2 we=0.07 le=0.9 Nx=1 m=1
Q$951 \$21 vbe dvbe vss npn13G2 we=0.07 le=0.9 Nx=1 m=1
Q$952 \$21 vbe dvbe vss npn13G2 we=0.07 le=0.9 Nx=1 m=1
Q$953 \$21 vbe dvbe vss npn13G2 we=0.07 le=0.9 Nx=1 m=1
Q$954 \$21 vbe dvbe vss npn13G2 we=0.07 le=0.9 Nx=1 m=1
Q$955 \$21 vbe dvbe vss npn13G2 we=0.07 le=0.9 Nx=1 m=1
Q$956 \$21 vbe dvbe vss npn13G2 we=0.07 le=0.9 Nx=1 m=1
Q$957 \$21 vbe dvbe vss npn13G2 we=0.07 le=0.9 Nx=1 m=1
Q$958 \$21 vbe dvbe vss npn13G2 we=0.07 le=0.9 Nx=1 m=1
Q$959 \$21 vbe dvbe vss npn13G2 we=0.07 le=0.9 Nx=1 m=1
Q$960 \$21 vbe dvbe vss npn13G2 we=0.07 le=0.9 Nx=1 m=1
Q$961 \$21 vbe dvbe vss npn13G2 we=0.07 le=0.9 Nx=1 m=1
Q$962 \$21 vbe dvbe vss npn13G2 we=0.07 le=0.9 Nx=1 m=1
Q$963 \$21 vbe dvbe vss npn13G2 we=0.07 le=0.9 Nx=1 m=1
Q$964 \$21 vbe dvbe vss npn13G2 we=0.07 le=0.9 Nx=1 m=1
Q$965 \$21 vbe dvbe vss npn13G2 we=0.07 le=0.9 Nx=1 m=1
Q$966 \$21 vbe dvbe vss npn13G2 we=0.07 le=0.9 Nx=1 m=1
Q$967 \$21 vbe dvbe vss npn13G2 we=0.07 le=0.9 Nx=1 m=1
Q$968 \$21 vbe dvbe vss npn13G2 we=0.07 le=0.9 Nx=1 m=1
Q$969 \$21 vbe dvbe vss npn13G2 we=0.07 le=0.9 Nx=1 m=1
Q$970 \$21 vbe dvbe vss npn13G2 we=0.07 le=0.9 Nx=1 m=1
Q$971 \$21 vbe dvbe vss npn13G2 we=0.07 le=0.9 Nx=1 m=1
Q$972 \$21 vbe dvbe vss npn13G2 we=0.07 le=0.9 Nx=1 m=1
Q$973 \$21 vbe dvbe vss npn13G2 we=0.07 le=0.9 Nx=1 m=1
Q$974 \$21 vbe dvbe vss npn13G2 we=0.07 le=0.9 Nx=1 m=1
Q$975 \$21 vbe dvbe vss npn13G2 we=0.07 le=0.9 Nx=1 m=1
Q$976 \$21 vbe dvbe vss npn13G2 we=0.07 le=0.9 Nx=1 m=1
Q$977 \$21 vbe dvbe vss npn13G2 we=0.07 le=0.9 Nx=1 m=1
Q$978 \$21 vbe dvbe vss npn13G2 we=0.07 le=0.9 Nx=1 m=1
Q$979 \$21 vbe dvbe vss npn13G2 we=0.07 le=0.9 Nx=1 m=1
Q$980 \$21 vbe dvbe vss npn13G2 we=0.07 le=0.9 Nx=1 m=1
Q$981 \$21 vbe dvbe vss npn13G2 we=0.07 le=0.9 Nx=1 m=1
Q$982 \$21 vbe dvbe vss npn13G2 we=0.07 le=0.9 Nx=1 m=1
Q$983 \$21 vbe dvbe vss npn13G2 we=0.07 le=0.9 Nx=1 m=1
Q$984 \$21 vbe dvbe vss npn13G2 we=0.07 le=0.9 Nx=1 m=1
Q$985 \$21 vbe dvbe vss npn13G2 we=0.07 le=0.9 Nx=1 m=1
Q$986 \$21 vbe dvbe vss npn13G2 we=0.07 le=0.9 Nx=1 m=1
Q$987 \$21 vbe dvbe vss npn13G2 we=0.07 le=0.9 Nx=1 m=1
Q$988 \$21 vbe dvbe vss npn13G2 we=0.07 le=0.9 Nx=1 m=1
Q$989 \$21 vbe dvbe vss npn13G2 we=0.07 le=0.9 Nx=1 m=1
Q$990 \$21 vbe dvbe vss npn13G2 we=0.07 le=0.9 Nx=1 m=1
Q$991 \$21 vbe dvbe vss npn13G2 we=0.07 le=0.9 Nx=1 m=1
Q$992 \$21 vbe dvbe vss npn13G2 we=0.07 le=0.9 Nx=1 m=1
Q$993 \$21 vbe dvbe vss npn13G2 we=0.07 le=0.9 Nx=1 m=1
Q$994 \$21 vbe dvbe vss npn13G2 we=0.07 le=0.9 Nx=1 m=1
Q$995 \$21 vbe dvbe vss npn13G2 we=0.07 le=0.9 Nx=1 m=1
Q$996 \$21 vbe dvbe vss npn13G2 we=0.07 le=0.9 Nx=1 m=1
Q$997 \$21 vbe dvbe vss npn13G2 we=0.07 le=0.9 Nx=1 m=1
Q$998 \$21 vbe dvbe vss npn13G2 we=0.07 le=0.9 Nx=1 m=1
Q$999 \$21 vbe dvbe vss npn13G2 we=0.07 le=0.9 Nx=1 m=1
Q$1000 \$18 \$18 \$I12 vss npn13G2 we=0.07 le=0.9 Nx=1 m=1
Q$1001 \$18 \$18 \$I12 vss npn13G2 we=0.07 le=0.9 Nx=1 m=1
Q$1002 \$18 \$18 \$I12 vss npn13G2 we=0.07 le=0.9 Nx=1 m=1
Q$1003 \$18 \$18 \$I12 vss npn13G2 we=0.07 le=0.9 Nx=1 m=1
Q$1004 \$18 \$18 \$I12 vss npn13G2 we=0.07 le=0.9 Nx=1 m=1
Q$1005 \$18 \$18 \$I12 vss npn13G2 we=0.07 le=0.9 Nx=1 m=1
Q$1006 \$18 \$18 \$I12 vss npn13G2 we=0.07 le=0.9 Nx=1 m=1
Q$1007 \$18 \$18 \$I12 vss npn13G2 we=0.07 le=0.9 Nx=1 m=1
Q$1008 \$18 \$18 \$I12 vss npn13G2 we=0.07 le=0.9 Nx=1 m=1
Q$1009 \$18 \$18 \$I12 vss npn13G2 we=0.07 le=0.9 Nx=1 m=1
Q$1010 \$18 \$18 \$I12 vss npn13G2 we=0.07 le=0.9 Nx=1 m=1
Q$1011 \$18 \$18 \$I12 vss npn13G2 we=0.07 le=0.9 Nx=1 m=1
Q$1012 \$18 \$18 \$I12 vss npn13G2 we=0.07 le=0.9 Nx=1 m=1
Q$1013 \$18 \$18 \$I12 vss npn13G2 we=0.07 le=0.9 Nx=1 m=1
Q$1014 \$18 \$18 \$I12 vss npn13G2 we=0.07 le=0.9 Nx=1 m=1
Q$1015 \$18 \$18 \$I12 vss npn13G2 we=0.07 le=0.9 Nx=1 m=1
Q$1016 \$18 \$18 \$I12 vss npn13G2 we=0.07 le=0.9 Nx=1 m=1
Q$1017 \$18 \$18 \$I12 vss npn13G2 we=0.07 le=0.9 Nx=1 m=1
Q$1018 \$18 \$18 \$I12 vss npn13G2 we=0.07 le=0.9 Nx=1 m=1
Q$1019 \$18 \$18 \$I12 vss npn13G2 we=0.07 le=0.9 Nx=1 m=1
Q$1020 \$18 \$18 \$I12 vss npn13G2 we=0.07 le=0.9 Nx=1 m=1
Q$1021 \$18 \$18 \$I12 vss npn13G2 we=0.07 le=0.9 Nx=1 m=1
Q$1022 \$18 \$18 \$I12 vss npn13G2 we=0.07 le=0.9 Nx=1 m=1
Q$1023 \$18 \$18 \$I12 vss npn13G2 we=0.07 le=0.9 Nx=1 m=1
Q$1024 \$17 \$17 vss vss npn13G2 we=0.07 le=0.9 Nx=1 m=1
Q$1025 \$17 \$17 vss vss npn13G2 we=0.07 le=0.9 Nx=1 m=1
Q$1026 \$17 \$17 vss vss npn13G2 we=0.07 le=0.9 Nx=1 m=1
Q$1027 \$17 \$17 vss vss npn13G2 we=0.07 le=0.9 Nx=1 m=1
Q$1028 vss vss vss vss npn13G2 we=0.07 le=0.9 Nx=1 m=1
Q$1029 vss vss vss vss npn13G2 we=0.07 le=0.9 Nx=1 m=1
Q$1030 vss vss vss vss npn13G2 we=0.07 le=0.9 Nx=1 m=1
Q$1031 vss vss vss vss npn13G2 we=0.07 le=0.9 Nx=1 m=1
Q$1032 vss vss vss vss npn13G2 we=0.07 le=0.9 Nx=1 m=1
Q$1033 vss vss vss vss npn13G2 we=0.07 le=0.9 Nx=1 m=1
Q$1034 vss vss vss vss npn13G2 we=0.07 le=0.9 Nx=1 m=1
Q$1035 vss vss vss vss npn13G2 we=0.07 le=0.9 Nx=1 m=1
Q$1036 vss vss vss vss npn13G2 we=0.07 le=0.9 Nx=1 m=1
Cext_1 \$10 \$16 191.942a
Cext_2 \$10 \$17 40.7278a
Cext_3 \$10 \$18 40.7278a
Cext_4 \$10 \$20 3.05926f
Cext_5 \$10 \$21 326.618a
Cext_6 \$10 \$I10 6.16273f
Cext_7 \$10 \$I11 118.452a
Cext_8 \$10 \$I13 893.226a
Cext_9 \$10 \$I14 890.661a
Cext_10 \$10 \$I15 856.268a
Cext_11 \$10 \$I16 209.738a
Cext_12 \$10 \$I17 125.387a
Cext_13 \$10 \$I18 898.53a
Cext_14 \$10 \$I19 77.8746a
Cext_15 \$10 \$I20 41.5452a
Cext_16 \$10 \$I21 41.5452a
Cext_17 \$10 \$I22 41.5452a
Cext_18 \$10 \$I23 889.999a
Cext_19 \$10 \$I24 43.2931a
Cext_20 \$10 \$I25 40.7278a
Cext_21 \$10 \$I26 40.7278a
Cext_22 \$10 \$I27 40.7278a
Cext_23 \$10 \$I28 915.176a
Cext_24 \$10 \$I29 183.84a
Cext_25 \$10 \$I30 887.691a
Cext_26 \$10 \$I31 41.0193a
Cext_27 \$10 \$I32 40.7278a
Cext_28 \$10 \$I33 40.7278a
Cext_29 \$10 \$I34 40.7278a
Cext_30 \$10 \$I35 40.7278a
Cext_31 \$10 \$I36 40.7278a
Cext_32 \$10 \$I37 40.7278a
Cext_33 \$10 \$I38 40.7278a
Cext_34 \$10 \$I39 40.7278a
Cext_35 \$10 \$I4 589.018a
Cext_36 \$10 \$I40 888.145a
Cext_37 \$10 \$I41 888.145a
Cext_38 \$10 \$I42 186.129a
Cext_39 \$10 \$I43 181.274a
Cext_40 \$10 \$I5 376.586a
Cext_41 \$10 \$I6 17.9973f
Cext_42 \$10 \$I7 1.61002f
Cext_43 \$10 \$I8 29.8077f
Cext_44 \$10 \$I9 356.235a
Cext_45 \$10 dvbe 29.0809f
Cext_46 \$10 iptat 31.4822f
Cext_47 \$10 pbias 14.6563f
Cext_48 \$10 pcasc 2.12112f
Cext_49 \$10 r4 119.797a
Cext_50 \$10 vbe 373.259a
Cext_51 \$10 vdd 1.30919f
Cext_52 \$10 vref 263.625a
Cext_53 \$10 vss 36.448f
Cext_54 \$10 VSUBS 19.1084f
Cext_55 \$16 \$17 23.3837f
Cext_56 \$16 \$18 2.6627f
Cext_57 \$16 \$20 183.243a
Cext_58 \$16 \$21 34.3118f
Cext_59 \$16 \$I10 132.418a
Cext_60 \$16 \$I11 22.8189f
Cext_61 \$16 \$I13 59.7112f
Cext_62 \$16 \$I14 882.731a
Cext_63 \$16 \$I18 756.834a
Cext_64 \$16 \$I19 36.3176a
Cext_65 \$16 \$I20 63.0695a
Cext_66 \$16 \$I21 63.0695a
Cext_67 \$16 \$I22 63.0695a
Cext_68 \$16 \$I23 1.00867f
Cext_69 \$16 \$I24 1.67735f
Cext_70 \$16 \$I25 63.0695a
Cext_71 \$16 \$I26 63.0695a
Cext_72 \$16 \$I27 63.0695a
Cext_73 \$16 \$I28 73.6882a
Cext_74 \$16 \$I29 335.5a
Cext_75 \$16 \$I30 756.834a
Cext_76 \$16 \$I31 78.7302a
Cext_77 \$16 \$I32 76.4959a
Cext_78 \$16 \$I33 76.4959a
Cext_79 \$16 \$I34 1.67479f
Cext_80 \$16 \$I35 1.67479f
Cext_81 \$16 \$I36 1.08734f
Cext_82 \$16 \$I37 1.67479f
Cext_83 \$16 \$I38 1.67479f
Cext_84 \$16 \$I39 684.986a
Cext_85 \$16 \$I4 555.833a
Cext_86 \$16 \$I40 756.834a
Cext_87 \$16 \$I41 756.834a
Cext_88 \$16 \$I42 154.587a
Cext_89 \$16 \$I43 401.457a
Cext_90 \$16 \$I5 141.065a
Cext_91 \$16 \$I6 117.974a
Cext_92 \$16 \$I7 42.9558f
Cext_93 \$16 \$I8 4.39943f
Cext_94 \$16 \$I9 388.444a
Cext_95 \$16 dvbe 2.72797f
Cext_96 \$16 iptat 103.63a
Cext_97 \$16 pbias 1.56674f
Cext_98 \$16 pcasc 120.187f
Cext_99 \$16 r4 96.2748a
Cext_100 \$16 vbe 115.042f
Cext_101 \$16 vdd 1.15736f
Cext_102 \$16 vref 3.75457f
Cext_103 \$16 vss 24.5836f
Cext_104 \$16 VSUBS 269.168f
Cext_105 \$17 \$18 33.2823f
Cext_106 \$17 \$20 113.629a
Cext_107 \$17 \$21 150.216a
Cext_108 \$17 \$I12 168.775a
Cext_109 \$17 \$I13 759.002a
Cext_110 \$17 \$I14 874.26a
Cext_111 \$17 \$I18 756.834a
Cext_112 \$17 \$I19 36.3176a
Cext_113 \$17 \$I20 63.0695a
Cext_114 \$17 \$I21 63.0695a
Cext_115 \$17 \$I22 63.5377a
Cext_116 \$17 \$I23 758.889a
Cext_117 \$17 \$I24 1.67735f
Cext_118 \$17 \$I25 63.0695a
Cext_119 \$17 \$I26 63.0695a
Cext_120 \$17 \$I27 63.0695a
Cext_121 \$17 \$I28 807.834a
Cext_122 \$17 \$I29 126.139a
Cext_123 \$17 \$I30 1.18461f
Cext_124 \$17 \$I31 329.469a
Cext_125 \$17 \$I32 76.7874a
Cext_126 \$17 \$I33 76.4959a
Cext_127 \$17 \$I34 1.67479f
Cext_128 \$17 \$I35 3.74075f
Cext_129 \$17 \$I36 264.577a
Cext_130 \$17 \$I37 1.658f
Cext_131 \$17 \$I38 1.67479f
Cext_132 \$17 \$I39 2.35392f
Cext_133 \$17 \$I40 756.834a
Cext_134 \$17 \$I41 756.834a
Cext_135 \$17 \$I42 8.56556f
Cext_136 \$17 \$I43 143.472a
Cext_137 \$17 dvbe 5.73703f
Cext_138 \$17 pbias 839.254a
Cext_139 \$17 pcasc 813.368a
Cext_140 \$17 vbe 34.7419f
Cext_141 \$17 vref 185.762a
Cext_142 \$17 vss 35.2222f
Cext_143 \$17 VSUBS 17.7974f
Cext_144 \$18 \$20 170.156a
Cext_145 \$18 \$21 284.29a
Cext_146 \$18 \$I12 22.8033f
Cext_147 \$18 \$I13 1.82203f
Cext_148 \$18 \$I14 54.721f
Cext_149 \$18 \$I18 756.834a
Cext_150 \$18 \$I19 36.3176a
Cext_151 \$18 \$I20 63.0695a
Cext_152 \$18 \$I21 63.0695a
Cext_153 \$18 \$I22 63.0695a
Cext_154 \$18 \$I23 1.15308f
Cext_155 \$18 \$I24 3.49155f
Cext_156 \$18 \$I25 63.0695a
Cext_157 \$18 \$I26 63.0695a
Cext_158 \$18 \$I27 63.0695a
Cext_159 \$18 \$I28 73.6882a
Cext_160 \$18 \$I29 126.139a
Cext_161 \$18 \$I30 1.48596f
Cext_162 \$18 \$I31 76.4959a
Cext_163 \$18 \$I32 76.4959a
Cext_164 \$18 \$I33 76.4959a
Cext_165 \$18 \$I34 1.67479f
Cext_166 \$18 \$I35 3.7996f
Cext_167 \$18 \$I36 281.365a
Cext_168 \$18 \$I37 2.35364f
Cext_169 \$18 \$I38 1.67479f
Cext_170 \$18 \$I39 279.131a
Cext_171 \$18 \$I40 756.834a
Cext_172 \$18 \$I41 756.834a
Cext_173 \$18 \$I42 130.196a
Cext_174 \$18 \$I43 143.434a
Cext_175 \$18 \$I8 21.2243a
Cext_176 \$18 dvbe 1.12938f
Cext_177 \$18 pbias 841.382a
Cext_178 \$18 pcasc 2.22576f
Cext_179 \$18 vbe 47.3715f
Cext_180 \$18 vref 23.5874f
Cext_181 \$18 vss 48.2669f
Cext_182 \$18 VSUBS 52.5139f
Cext_183 \$20 \$21 61.0441f
Cext_184 \$20 \$I10 99.8272a
Cext_185 \$20 \$I11 284.902a
Cext_186 \$20 \$I12 26.2663f
Cext_187 \$20 \$I24 112.23a
Cext_188 \$20 \$I35 36.3207a
Cext_189 \$20 \$I38 97.6862a
Cext_190 \$20 \$I4 336.486a
Cext_191 \$20 \$I5 451.021a
Cext_192 \$20 \$I6 196.597a
Cext_193 \$20 \$I7 85.4314a
Cext_194 \$20 \$I8 117.964a
Cext_195 \$20 \$I9 2.40873f
Cext_196 \$20 dvbe 1.03498f
Cext_197 \$20 iptat 68.1341a
Cext_198 \$20 pbias 375.483a
Cext_199 \$20 pcasc 2.92748f
Cext_200 \$20 r4 452.651a
Cext_201 \$20 vbe 32.5727f
Cext_202 \$20 vdd 96.7085a
Cext_203 \$20 vref 102.619a
Cext_204 \$20 vss 21.8519f
Cext_205 \$20 VSUBS 51.908f
Cext_206 \$21 \$I10 250.331a
Cext_207 \$21 \$I11 249.78a
Cext_208 \$21 \$I12 1.41576f
Cext_209 \$21 \$I35 0.625476a
Cext_210 \$21 \$I4 39.375f
Cext_211 \$21 \$I5 352.759a
Cext_212 \$21 \$I6 196.388a
Cext_213 \$21 \$I7 28.8289f
Cext_214 \$21 \$I8 1.30249f
Cext_215 \$21 \$I9 694.157a
Cext_216 \$21 dvbe 470.177f
Cext_217 \$21 iptat 193.988a
Cext_218 \$21 pbias 2.0122f
Cext_219 \$21 pcasc 21.4941f
Cext_220 \$21 r4 250.561a
Cext_221 \$21 vbe 51.3262f
Cext_222 \$21 vdd 1.54112f
Cext_223 \$21 vref 270.144a
Cext_224 \$21 vss 69.3008f
Cext_225 \$21 VSUBS 199.399f
Cext_226 \$I10 \$I11 115.349a
Cext_227 \$I10 \$I4 68.0852a
Cext_228 \$I10 \$I5 99.4772a
Cext_229 \$I10 \$I6 86.3165a
Cext_230 \$I10 \$I7 23.7237f
Cext_231 \$I10 \$I8 71.7411a
Cext_232 \$I10 \$I9 185.06a
Cext_233 \$I10 iptat 31.1399f
Cext_234 \$I10 pbias 8.60406f
Cext_235 \$I10 pcasc 1.81713f
Cext_236 \$I10 r4 218.653a
Cext_237 \$I10 vbe 251.06a
Cext_238 \$I10 vdd 314.681a
Cext_239 \$I10 vref 156.598a
Cext_240 \$I10 vss 705.052a
Cext_241 \$I10 VSUBS 5.66451f
Cext_242 \$I11 \$I4 75.9573a
Cext_243 \$I11 \$I5 73.1883a
Cext_244 \$I11 \$I6 67.557a
Cext_245 \$I11 \$I7 69.8449a
Cext_246 \$I11 \$I8 112.275a
Cext_247 \$I11 \$I9 146.47a
Cext_248 \$I11 iptat 31.5292a
Cext_249 \$I11 pbias 156.257a
Cext_250 \$I11 pcasc 280.672a
Cext_251 \$I11 r4 38.1925f
Cext_252 \$I11 vbe 9.40501f
Cext_253 \$I11 vdd 370.71a
Cext_254 \$I11 vref 122.297a
Cext_255 \$I11 vss 5.32712f
Cext_256 \$I11 VSUBS 4.71029f
Cext_257 \$I12 \$I4 1.69452a
Cext_258 \$I12 \$I8 0.666798a
Cext_259 \$I12 dvbe 46.6986f
Cext_260 \$I12 pcasc 2.08803a
Cext_261 \$I12 vbe 28.7136f
Cext_262 \$I12 vss 159.209f
Cext_263 \$I12 VSUBS 44.6981f
Cext_264 \$I13 \$I14 4.37523f
Cext_265 \$I13 \$I15 907.134a
Cext_266 \$I13 \$I16 916.42a
Cext_267 \$I13 \$I17 916.42a
Cext_268 \$I13 \$I18 1.63839f
Cext_269 \$I13 \$I19 952.738a
Cext_270 \$I13 \$I20 979.49a
Cext_271 \$I13 \$I21 979.49a
Cext_272 \$I13 \$I22 979.49a
Cext_273 \$I13 \$I23 2.45327f
Cext_274 \$I13 \$I24 121.512f
Cext_275 \$I13 \$I25 895.029a
Cext_276 \$I13 \$I26 895.029a
Cext_277 \$I13 \$I27 876.457a
Cext_278 \$I13 \$I28 897.865a
Cext_279 \$I13 \$I29 1.49644f
Cext_280 \$I13 \$I30 2.17157f
Cext_281 \$I13 \$I31 909.273a
Cext_282 \$I13 \$I32 908.456a
Cext_283 \$I13 \$I33 908.456a
Cext_284 \$I13 \$I34 3.00291f
Cext_285 \$I13 \$I35 2.50674f
Cext_286 \$I13 \$I36 1.76322f
Cext_287 \$I13 \$I37 3.27919f
Cext_288 \$I13 \$I38 2.51181f
Cext_289 \$I13 \$I39 1.37796f
Cext_290 \$I13 \$I40 1.90092f
Cext_291 \$I13 \$I41 24.8992f
Cext_292 \$I13 \$I42 1.02678f
Cext_293 \$I13 \$I43 24.2101f
Cext_294 \$I13 dvbe 3.56038f
Cext_295 \$I13 pbias 878.777a
Cext_296 \$I13 pcasc 1.18822f
Cext_297 \$I13 vref 1.02225f
Cext_298 \$I13 vss 10.0374f
Cext_299 \$I13 VSUBS 51.2211f
Cext_300 \$I14 \$I15 899.378a
Cext_301 \$I14 \$I16 917.951a
Cext_302 \$I14 \$I17 917.951a
Cext_303 \$I14 \$I18 1.63063f
Cext_304 \$I14 \$I19 954.268a
Cext_305 \$I14 \$I20 981.02a
Cext_306 \$I14 \$I21 981.02a
Cext_307 \$I14 \$I22 981.02a
Cext_308 \$I14 \$I23 3.17924f
Cext_309 \$I14 \$I24 121.758f
Cext_310 \$I14 \$I25 895.029a
Cext_311 \$I14 \$I26 895.029a
Cext_312 \$I14 \$I27 885.743a
Cext_313 \$I14 \$I28 905.648a
Cext_314 \$I14 \$I29 958.099a
Cext_315 \$I14 \$I30 1.94139f
Cext_316 \$I14 \$I31 910.69a
Cext_317 \$I14 \$I32 908.456a
Cext_318 \$I14 \$I33 908.456a
Cext_319 \$I14 \$I34 3.88426f
Cext_320 \$I14 \$I35 2.48996f
Cext_321 \$I14 \$I36 1.11366f
Cext_322 \$I14 \$I37 3.09365f
Cext_323 \$I14 \$I38 2.50931f
Cext_324 \$I14 \$I39 1.09475f
Cext_325 \$I14 \$I40 2.5746f
Cext_326 \$I14 \$I41 1.77994f
Cext_327 \$I14 \$I42 23.9297f
Cext_328 \$I14 \$I43 998.622a
Cext_329 \$I14 dvbe 2.33846f
Cext_330 \$I14 pbias 25.321f
Cext_331 \$I14 pcasc 1.52785f
Cext_332 \$I14 vref 897.779a
Cext_333 \$I14 vss 9.73048f
Cext_334 \$I14 VSUBS 52.7905f
Cext_335 \$I15 \$I16 356.004a
Cext_336 \$I15 \$I17 76.7874a
Cext_337 \$I15 \$I18 1.07817f
Cext_338 \$I15 \$I19 22.6321f
Cext_339 \$I15 \$I20 2.58187a
Cext_340 \$I15 \$I21 1.08906a
Cext_341 \$I15 \$I22 0.586568a
Cext_342 \$I15 \$I23 23.9061f
Cext_343 \$I15 \$I29 152.992a
Cext_344 \$I15 \$I30 925.647a
Cext_345 \$I15 \$I40 920.516a
Cext_346 \$I15 \$I41 901.944a
Cext_347 \$I15 \$I42 230.624a
Cext_348 \$I15 \$I43 155.557a
Cext_349 \$I15 dvbe 1.0614f
Cext_350 \$I15 vss 1.48707f
Cext_351 \$I15 VSUBS 5.74844f
Cext_352 \$I16 \$I17 23.2068f
Cext_353 \$I16 \$I18 1.0745f
Cext_354 \$I16 \$I19 426.689a
Cext_355 \$I16 \$I20 162.118a
Cext_356 \$I16 \$I21 162.118a
Cext_357 \$I16 \$I22 22.4678f
Cext_358 \$I16 \$I23 1.0745f
Cext_359 \$I16 \$I24 32.0848a
Cext_360 \$I16 \$I28 0.543717a
Cext_361 \$I16 \$I29 154.705a
Cext_362 \$I16 \$I30 925.647a
Cext_363 \$I16 \$I40 920.516a
Cext_364 \$I16 \$I41 920.516a
Cext_365 \$I16 \$I42 178.048a
Cext_366 \$I16 \$I43 155.557a
Cext_367 \$I16 dvbe 1.10615f
Cext_368 \$I16 vss 1.37061f
Cext_369 \$I16 VSUBS 6.1045f
Cext_370 \$I17 \$I18 1.0745f
Cext_371 \$I17 \$I19 120.668a
Cext_372 \$I17 \$I20 158.802a
Cext_373 \$I17 \$I21 158.802a
Cext_374 \$I17 \$I22 162.245a
Cext_375 \$I17 \$I23 1.0745f
Cext_376 \$I17 \$I24 22.9772f
Cext_377 \$I17 \$I28 1.0095a
Cext_378 \$I17 \$I29 157.053a
Cext_379 \$I17 \$I30 925.647a
Cext_380 \$I17 \$I33 0.500866a
Cext_381 \$I17 \$I40 920.516a
Cext_382 \$I17 \$I41 920.516a
Cext_383 \$I17 \$I42 155.557a
Cext_384 \$I17 \$I43 155.557a
Cext_385 \$I17 dvbe 1.10889f
Cext_386 \$I17 vss 1.36869f
Cext_387 \$I17 VSUBS 6.07826f
Cext_388 \$I18 \$I19 1.04214f
Cext_389 \$I18 \$I20 1.00134f
Cext_390 \$I18 \$I21 998.209a
Cext_391 \$I18 \$I22 998a
Cext_392 \$I18 \$I23 26.3184f
Cext_393 \$I18 \$I24 998a
Cext_394 \$I18 \$I25 998a
Cext_395 \$I18 \$I26 998a
Cext_396 \$I18 \$I27 990.498a
Cext_397 \$I18 \$I28 998a
Cext_398 \$I18 \$I29 1.14623f
Cext_399 \$I18 \$I30 3.20723f
Cext_400 \$I18 \$I31 998a
Cext_401 \$I18 \$I32 998a
Cext_402 \$I18 \$I33 998a
Cext_403 \$I18 \$I34 983.612a
Cext_404 \$I18 \$I35 4.97877f
Cext_405 \$I18 \$I36 756.834a
Cext_406 \$I18 \$I37 88.0657f
Cext_407 \$I18 \$I38 85.7797f
Cext_408 \$I18 \$I39 756.834a
Cext_409 \$I18 \$I40 1.64622f
Cext_410 \$I18 \$I41 1.94923f
Cext_411 \$I18 \$I42 910.327a
Cext_412 \$I18 \$I43 905.066a
Cext_413 \$I18 dvbe 31.4486f
Cext_414 \$I18 pbias 756.834a
Cext_415 \$I18 pcasc 756.834a
Cext_416 \$I18 vref 897.779a
Cext_417 \$I18 vss 11.6782f
Cext_418 \$I18 VSUBS 40.3082f
Cext_419 \$I19 \$I20 22.7363f
Cext_420 \$I19 \$I21 45.9118a
Cext_421 \$I19 \$I22 44.7376a
Cext_422 \$I19 \$I23 1.05022f
Cext_423 \$I19 \$I24 43.881a
Cext_424 \$I19 \$I25 6.88717f
Cext_425 \$I19 \$I26 36.3176a
Cext_426 \$I19 \$I27 36.3176a
Cext_427 \$I19 \$I28 43.881a
Cext_428 \$I19 \$I29 196.873a
Cext_429 \$I19 \$I30 961.964a
Cext_430 \$I19 \$I31 43.881a
Cext_431 \$I19 \$I32 36.3176a
Cext_432 \$I19 \$I33 43.881a
Cext_433 \$I19 \$I34 36.3176a
Cext_434 \$I19 \$I35 36.3176a
Cext_435 \$I19 \$I36 36.3176a
Cext_436 \$I19 \$I37 36.3176a
Cext_437 \$I19 \$I38 36.3176a
Cext_438 \$I19 \$I39 36.3176a
Cext_439 \$I19 \$I40 956.834a
Cext_440 \$I19 \$I41 956.834a
Cext_441 \$I19 \$I42 199.179a
Cext_442 \$I19 \$I43 191.875a
Cext_443 \$I19 dvbe 1.13625f
Cext_444 \$I19 pbias 36.3176a
Cext_445 \$I19 pcasc 36.3176a
Cext_446 \$I19 vref 42.1903a
Cext_447 \$I19 vss 958.024a
Cext_448 \$I19 VSUBS 7.00266f
Cext_449 \$I20 \$I21 22.8021f
Cext_450 \$I20 \$I22 83.7854a
Cext_451 \$I20 \$I23 1.0042f
Cext_452 \$I20 \$I24 84.8092a
Cext_453 \$I20 \$I25 11.0723f
Cext_454 \$I20 \$I26 6.58863f
Cext_455 \$I20 \$I27 63.0695a
Cext_456 \$I20 \$I28 82.3059a
Cext_457 \$I20 \$I29 235.298a
Cext_458 \$I20 \$I30 988.716a
Cext_459 \$I20 \$I31 82.3059a
Cext_460 \$I20 \$I32 70.633a
Cext_461 \$I20 \$I33 82.3059a
Cext_462 \$I20 \$I34 63.0695a
Cext_463 \$I20 \$I35 63.0695a
Cext_464 \$I20 \$I36 63.0695a
Cext_465 \$I20 \$I37 63.0695a
Cext_466 \$I20 \$I38 63.0695a
Cext_467 \$I20 \$I39 63.0695a
Cext_468 \$I20 \$I40 983.586a
Cext_469 \$I20 \$I41 983.586a
Cext_470 \$I20 \$I42 218.56a
Cext_471 \$I20 \$I43 218.627a
Cext_472 \$I20 dvbe 1.34748f
Cext_473 \$I20 pbias 63.0695a
Cext_474 \$I20 pcasc 63.0695a
Cext_475 \$I20 vref 74.815a
Cext_476 \$I20 vss 430.763a
Cext_477 \$I20 VSUBS 6.0304f
Cext_478 \$I21 \$I22 22.8021f
Cext_479 \$I21 \$I23 1.00134f
Cext_480 \$I21 \$I24 89.3447a
Cext_481 \$I21 \$I25 82.6376a
Cext_482 \$I21 \$I26 10.5491f
Cext_483 \$I21 \$I27 6.42572f
Cext_484 \$I21 \$I28 82.3059a
Cext_485 \$I21 \$I29 235.715a
Cext_486 \$I21 \$I30 988.716a
Cext_487 \$I21 \$I31 82.3059a
Cext_488 \$I21 \$I32 82.3059a
Cext_489 \$I21 \$I33 82.3059a
Cext_490 \$I21 \$I34 63.0695a
Cext_491 \$I21 \$I35 63.0695a
Cext_492 \$I21 \$I36 63.0695a
Cext_493 \$I21 \$I37 63.0695a
Cext_494 \$I21 \$I38 63.0695a
Cext_495 \$I21 \$I39 63.0695a
Cext_496 \$I21 \$I40 983.586a
Cext_497 \$I21 \$I41 983.586a
Cext_498 \$I21 \$I42 218.56a
Cext_499 \$I21 \$I43 218.627a
Cext_500 \$I21 dvbe 1.34872f
Cext_501 \$I21 pbias 63.0695a
Cext_502 \$I21 pcasc 63.0695a
Cext_503 \$I21 vref 74.815a
Cext_504 \$I21 vss 410.671a
Cext_505 \$I21 VSUBS 6.02291f
Cext_506 \$I22 \$I23 998.209a
Cext_507 \$I22 \$I24 98.8178a
Cext_508 \$I22 \$I25 74.7424a
Cext_509 \$I22 \$I26 75.0741a
Cext_510 \$I22 \$I27 10.28f
Cext_511 \$I22 \$I28 7.41498f
Cext_512 \$I22 \$I29 239.413a
Cext_513 \$I22 \$I30 988.716a
Cext_514 \$I22 \$I31 74.7424a
Cext_515 \$I22 \$I32 74.7424a
Cext_516 \$I22 \$I33 74.7424a
Cext_517 \$I22 \$I34 63.0695a
Cext_518 \$I22 \$I35 63.0695a
Cext_519 \$I22 \$I36 63.0695a
Cext_520 \$I22 \$I37 63.0695a
Cext_521 \$I22 \$I38 63.0695a
Cext_522 \$I22 \$I39 63.0695a
Cext_523 \$I22 \$I40 983.586a
Cext_524 \$I22 \$I41 983.586a
Cext_525 \$I22 \$I42 219.649a
Cext_526 \$I22 \$I43 218.627a
Cext_527 \$I22 dvbe 1.33323f
Cext_528 \$I22 pbias 63.0695a
Cext_529 \$I22 pcasc 63.0695a
Cext_530 \$I22 vref 74.815a
Cext_531 \$I22 vss 406.711a
Cext_532 \$I22 VSUBS 6.08636f
Cext_533 \$I23 \$I24 998a
Cext_534 \$I23 \$I25 997.556a
Cext_535 \$I23 \$I26 997.556a
Cext_536 \$I23 \$I27 997.556a
Cext_537 \$I23 \$I28 997.556a
Cext_538 \$I23 \$I29 1.26969f
Cext_539 \$I23 \$I30 2.68822f
Cext_540 \$I23 \$I31 997.556a
Cext_541 \$I23 \$I32 997.556a
Cext_542 \$I23 \$I33 997.556a
Cext_543 \$I23 \$I34 994.112a
Cext_544 \$I23 \$I35 1.70486f
Cext_545 \$I23 \$I36 926.845a
Cext_546 \$I23 \$I37 1.43424f
Cext_547 \$I23 \$I38 86.4594f
Cext_548 \$I23 \$I39 875.082a
Cext_549 \$I23 \$I40 2.12563f
Cext_550 \$I23 \$I41 3.06162f
Cext_551 \$I23 \$I42 1.01193f
Cext_552 \$I23 \$I43 1.51795f
Cext_553 \$I23 dvbe 2.39173f
Cext_554 \$I23 pbias 857.787a
Cext_555 \$I23 pcasc 59.7112f
Cext_556 \$I23 vref 1.86547f
Cext_557 \$I23 vss 11.6606f
Cext_558 \$I23 VSUBS 41.5257f
Cext_559 \$I24 \$I25 1.74073f
Cext_560 \$I24 \$I26 1.74053f
Cext_561 \$I24 \$I27 1.74053f
Cext_562 \$I24 \$I28 1.74182f
Cext_563 \$I24 \$I29 24.7336f
Cext_564 \$I24 \$I30 4.08802f
Cext_565 \$I24 \$I31 1.74078f
Cext_566 \$I24 \$I32 1.74053f
Cext_567 \$I24 \$I33 1.74099f
Cext_568 \$I24 \$I34 6.97433f
Cext_569 \$I24 \$I35 1.6398f
Cext_570 \$I24 \$I36 1.74053f
Cext_571 \$I24 \$I37 4.21901f
Cext_572 \$I24 \$I38 1.70695f
Cext_573 \$I24 \$I39 1.74053f
Cext_574 \$I24 \$I40 5.84557f
Cext_575 \$I24 \$I41 3.46693f
Cext_576 \$I24 \$I42 1.86769f
Cext_577 \$I24 \$I43 1.86769f
Cext_578 \$I24 dvbe 939.7a
Cext_579 \$I24 pbias 3.50069f
Cext_580 \$I24 pcasc 1.67735f
Cext_581 \$I24 vref 1.99126f
Cext_582 \$I24 vss 545.197a
Cext_583 \$I24 VSUBS 73.8631f
Cext_584 \$I25 \$I26 1.66396f
Cext_585 \$I25 \$I27 63.6936a
Cext_586 \$I25 \$I28 75.9047a
Cext_587 \$I25 \$I29 177.888a
Cext_588 \$I25 \$I30 992.694a
Cext_589 \$I25 \$I31 22.3906f
Cext_590 \$I25 \$I32 22.3738f
Cext_591 \$I25 \$I33 80.2097a
Cext_592 \$I25 \$I34 65.5729a
Cext_593 \$I25 \$I35 63.0695a
Cext_594 \$I25 \$I36 63.0695a
Cext_595 \$I25 \$I37 63.0695a
Cext_596 \$I25 \$I38 63.0695a
Cext_597 \$I25 \$I39 63.0695a
Cext_598 \$I25 \$I40 982.055a
Cext_599 \$I25 \$I41 983.586a
Cext_600 \$I25 \$I42 219.113a
Cext_601 \$I25 \$I43 225.329a
Cext_602 \$I25 dvbe 1.32019f
Cext_603 \$I25 pbias 63.0695a
Cext_604 \$I25 pcasc 63.0695a
Cext_605 \$I25 vref 74.815a
Cext_606 \$I25 vss 531.605a
Cext_607 \$I25 VSUBS 8.51218f
Cext_608 \$I26 \$I27 23.9745f
Cext_609 \$I26 \$I28 75.4892a
Cext_610 \$I26 \$I29 177.051a
Cext_611 \$I26 \$I30 1.00647f
Cext_612 \$I26 \$I31 77.9374a
Cext_613 \$I26 \$I32 22.3876f
Cext_614 \$I26 \$I33 76.832a
Cext_615 \$I26 \$I34 76.1383a
Cext_616 \$I26 \$I35 70.1083a
Cext_617 \$I26 \$I36 63.0695a
Cext_618 \$I26 \$I37 65.5729a
Cext_619 \$I26 \$I38 63.0695a
Cext_620 \$I26 \$I39 63.0695a
Cext_621 \$I26 \$I40 982.055a
Cext_622 \$I26 \$I41 983.586a
Cext_623 \$I26 \$I42 219.113a
Cext_624 \$I26 \$I43 225.329a
Cext_625 \$I26 dvbe 1.30129f
Cext_626 \$I26 pbias 63.0695a
Cext_627 \$I26 pcasc 63.0695a
Cext_628 \$I26 vref 74.815a
Cext_629 \$I26 vss 430.691a
Cext_630 \$I26 VSUBS 7.46921f
Cext_631 \$I27 \$I28 1.67446f
Cext_632 \$I27 \$I29 177.051a
Cext_633 \$I27 \$I30 23.7606f
Cext_634 \$I27 \$I31 77.6495a
Cext_635 \$I27 \$I32 77.9755a
Cext_636 \$I27 \$I33 76.7045a
Cext_637 \$I27 \$I34 94.052a
Cext_638 \$I27 \$I35 76.1383a
Cext_639 \$I27 \$I36 63.0695a
Cext_640 \$I27 \$I37 70.1083a
Cext_641 \$I27 \$I38 65.5729a
Cext_642 \$I27 \$I39 63.0695a
Cext_643 \$I27 \$I40 982.055a
Cext_644 \$I27 \$I41 983.586a
Cext_645 \$I27 \$I42 219.33a
Cext_646 \$I27 \$I43 225.329a
Cext_647 \$I27 dvbe 1.29356f
Cext_648 \$I27 pbias 63.0695a
Cext_649 \$I27 pcasc 63.0695a
Cext_650 \$I27 vref 74.815a
Cext_651 \$I27 vss 419.794a
Cext_652 \$I27 VSUBS 7.45682f
Cext_653 \$I28 \$I29 22.5648f
Cext_654 \$I28 \$I30 1.00093f
Cext_655 \$I28 \$I31 898.526a
Cext_656 \$I28 \$I32 75.531a
Cext_657 \$I28 \$I33 22.3993f
Cext_658 \$I28 \$I34 75.2806a
Cext_659 \$I28 \$I35 75.2806a
Cext_660 \$I28 \$I36 75.2806a
Cext_661 \$I28 \$I37 75.2806a
Cext_662 \$I28 \$I38 75.2806a
Cext_663 \$I28 \$I39 109.392a
Cext_664 \$I28 \$I40 994.177a
Cext_665 \$I28 \$I41 995.708a
Cext_666 \$I28 \$I42 654.542a
Cext_667 \$I28 \$I43 237.451a
Cext_668 \$I28 dvbe 1.43627f
Cext_669 \$I28 pbias 73.6882a
Cext_670 \$I28 pcasc 73.6882a
Cext_671 \$I28 vref 86.7888a
Cext_672 \$I28 vss 536.195a
Cext_673 \$I28 VSUBS 8.33852f
Cext_674 \$I29 \$I30 1.1027f
Cext_675 \$I29 \$I31 178.446a
Cext_676 \$I29 \$I32 177.051a
Cext_677 \$I29 \$I33 180.358a
Cext_678 \$I29 \$I34 177.051a
Cext_679 \$I29 \$I35 177.051a
Cext_680 \$I29 \$I36 13.2769f
Cext_681 \$I29 \$I37 177.051a
Cext_682 \$I29 \$I38 177.051a
Cext_683 \$I29 \$I39 12.8057f
Cext_684 \$I29 \$I40 1.04512f
Cext_685 \$I29 \$I41 1.03915f
Cext_686 \$I29 \$I42 910.356a
Cext_687 \$I29 \$I43 2.15886f
Cext_688 \$I29 dvbe 1.25778f
Cext_689 \$I29 pbias 126.139a
Cext_690 \$I29 pcasc 126.139a
Cext_691 \$I29 vref 150.169a
Cext_692 \$I29 vss 2.86823f
Cext_693 \$I29 VSUBS 11.886f
Cext_694 \$I30 \$I31 1.00536f
Cext_695 \$I30 \$I32 1.00963f
Cext_696 \$I30 \$I33 1.00214f
Cext_697 \$I30 \$I34 24.4679f
Cext_698 \$I30 \$I35 90.4855f
Cext_699 \$I30 \$I36 759.306a
Cext_700 \$I30 \$I37 88.9141f
Cext_701 \$I30 \$I38 1.17563f
Cext_702 \$I30 \$I39 758.889a
Cext_703 \$I30 \$I40 2.47051f
Cext_704 \$I30 \$I41 1.6644f
Cext_705 \$I30 \$I42 907.43a
Cext_706 \$I30 \$I43 906.145a
Cext_707 \$I30 dvbe 8.26488f
Cext_708 \$I30 pbias 751.387a
Cext_709 \$I30 pcasc 1.92015f
Cext_710 \$I30 vref 897.779a
Cext_711 \$I30 vss 11.6252f
Cext_712 \$I30 VSUBS 50.1686f
Cext_713 \$I31 \$I32 848.253a
Cext_714 \$I31 \$I33 23.2262f
Cext_715 \$I31 \$I34 77.3133a
Cext_716 \$I31 \$I35 77.3133a
Cext_717 \$I31 \$I36 77.3133a
Cext_718 \$I31 \$I37 77.3133a
Cext_719 \$I31 \$I38 77.3133a
Cext_720 \$I31 \$I39 109.078a
Cext_721 \$I31 \$I40 996.299a
Cext_722 \$I31 \$I41 997.829a
Cext_723 \$I31 \$I42 553.376a
Cext_724 \$I31 \$I43 239.573a
Cext_725 \$I31 dvbe 1.34424f
Cext_726 \$I31 pbias 78.7302a
Cext_727 \$I31 pcasc 78.7302a
Cext_728 \$I31 vref 90.9517a
Cext_729 \$I31 vss 635.237a
Cext_730 \$I31 VSUBS 7.22834f
Cext_731 \$I32 \$I33 847.09a
Cext_732 \$I32 \$I34 83.5347a
Cext_733 \$I32 \$I35 78.9993a
Cext_734 \$I32 \$I36 76.4959a
Cext_735 \$I32 \$I37 76.4959a
Cext_736 \$I32 \$I38 76.4959a
Cext_737 \$I32 \$I39 76.4959a
Cext_738 \$I32 \$I40 995.481a
Cext_739 \$I32 \$I41 997.012a
Cext_740 \$I32 \$I42 232.974a
Cext_741 \$I32 \$I43 238.756a
Cext_742 \$I32 dvbe 1.29588f
Cext_743 \$I32 pbias 76.4959a
Cext_744 \$I32 pcasc 76.4959a
Cext_745 \$I32 vref 90.9517a
Cext_746 \$I32 vss 615.182a
Cext_747 \$I32 VSUBS 6.87247f
Cext_748 \$I33 \$I34 76.4959a
Cext_749 \$I33 \$I35 76.4959a
Cext_750 \$I33 \$I36 76.4959a
Cext_751 \$I33 \$I37 76.4959a
Cext_752 \$I33 \$I38 76.4959a
Cext_753 \$I33 \$I39 76.4959a
Cext_754 \$I33 \$I40 995.481a
Cext_755 \$I33 \$I41 997.012a
Cext_756 \$I33 \$I42 239.488a
Cext_757 \$I33 \$I43 238.756a
Cext_758 \$I33 dvbe 1.33179f
Cext_759 \$I33 pbias 76.4959a
Cext_760 \$I33 pcasc 76.4959a
Cext_761 \$I33 vref 90.9517a
Cext_762 \$I33 vss 636.503a
Cext_763 \$I33 VSUBS 7.16311f
Cext_764 \$I34 \$I35 27.3748f
Cext_765 \$I34 \$I36 1.73634f
Cext_766 \$I34 \$I37 4.16047f
Cext_767 \$I34 \$I38 1.74824f
Cext_768 \$I34 \$I39 1.73559f
Cext_769 \$I34 \$I40 96.5499f
Cext_770 \$I34 \$I41 97.5365f
Cext_771 \$I34 \$I42 1.83083f
Cext_772 \$I34 \$I43 1.83704f
Cext_773 \$I34 dvbe 920.459a
Cext_774 \$I34 pbias 3.39912f
Cext_775 \$I34 pcasc 1.64121f
Cext_776 \$I34 vref 1.9934f
Cext_777 \$I34 vss 586.256a
Cext_778 \$I34 VSUBS 68.2831f
Cext_779 \$I35 \$I36 1.65397f
Cext_780 \$I35 \$I37 29.2921f
Cext_781 \$I35 \$I38 7.57095f
Cext_782 \$I35 \$I39 1.70333f
Cext_783 \$I35 \$I40 3.22328f
Cext_784 \$I35 \$I41 92.5274f
Cext_785 \$I35 \$I42 1.83083f
Cext_786 \$I35 \$I43 1.83704f
Cext_787 \$I35 dvbe 15.7345f
Cext_788 \$I35 pbias 2.53677f
Cext_789 \$I35 pcasc 1.658f
Cext_790 \$I35 vref 1.9933f
Cext_791 \$I35 vss 586.144a
Cext_792 \$I35 VSUBS 68.4592f
Cext_793 \$I36 \$I37 1.6454f
Cext_794 \$I36 \$I38 24.4558f
Cext_795 \$I36 \$I39 25.2127f
Cext_796 \$I36 \$I40 1.13668f
Cext_797 \$I36 \$I41 1.04114f
Cext_798 \$I36 \$I42 446.21a
Cext_799 \$I36 \$I43 13.8142f
Cext_800 \$I36 dvbe 900.272a
Cext_801 \$I36 pbias 281.696a
Cext_802 \$I36 pcasc 295.12a
Cext_803 \$I36 vref 2.36258f
Cext_804 \$I36 vss 474.055a
Cext_805 \$I36 VSUBS 15.0682f
Cext_806 \$I37 \$I38 28.8378f
Cext_807 \$I37 \$I39 1.68005f
Cext_808 \$I37 \$I40 4.02323f
Cext_809 \$I37 \$I41 2.67691f
Cext_810 \$I37 \$I42 1.83339f
Cext_811 \$I37 \$I43 1.83961f
Cext_812 \$I37 dvbe 919.322a
Cext_813 \$I37 pbias 1.67735f
Cext_814 \$I37 pcasc 3.65791f
Cext_815 \$I37 vref 1.97662f
Cext_816 \$I37 vss 586.256a
Cext_817 \$I37 VSUBS 68.5293f
Cext_818 \$I38 \$I39 1.68626f
Cext_819 \$I38 \$I40 4.09651f
Cext_820 \$I38 \$I41 3.21711f
Cext_821 \$I38 \$I42 1.83339f
Cext_822 \$I38 \$I43 1.83961f
Cext_823 \$I38 dvbe 1.05952f
Cext_824 \$I38 pbias 3.68407f
Cext_825 \$I38 pcasc 1.67479f
Cext_826 \$I38 vref 1.9934f
Cext_827 \$I38 vss 586.256a
Cext_828 \$I38 VSUBS 67.2269f
Cext_829 \$I39 \$I40 23.9631f
Cext_830 \$I39 \$I41 1.02876f
Cext_831 \$I39 \$I42 12.3043f
Cext_832 \$I39 \$I43 1.7025f
Cext_833 \$I39 dvbe 1.54071f
Cext_834 \$I39 pbias 281.365a
Cext_835 \$I39 pcasc 272.971a
Cext_836 \$I39 vref 331.7a
Cext_837 \$I39 vss 681.339a
Cext_838 \$I39 VSUBS 14.7305f
Cext_839 \$I4 \$I5 6.02637f
Cext_840 \$I4 \$I6 519.889a
Cext_841 \$I4 \$I7 10.1287f
Cext_842 \$I4 \$I8 4.99222f
Cext_843 \$I4 \$I9 51.2247f
Cext_844 \$I4 iptat 38.4802a
Cext_845 \$I4 pbias 36.0039f
Cext_846 \$I4 pcasc 24.845f
Cext_847 \$I4 r4 75.7629a
Cext_848 \$I4 vbe 1.4346f
Cext_849 \$I4 vdd 12.6016f
Cext_850 \$I4 vref 227.945a
Cext_851 \$I4 vss 2.60791f
Cext_852 \$I4 VSUBS 74.7205f
Cext_853 \$I40 \$I41 26.5711f
Cext_854 \$I40 \$I42 997.915a
Cext_855 \$I40 \$I43 1.01266f
Cext_856 \$I40 dvbe 2.32266f
Cext_857 \$I40 pbias 62.1972f
Cext_858 \$I40 pcasc 756.834a
Cext_859 \$I40 vref 897.779a
Cext_860 \$I40 vss 11.6445f
Cext_861 \$I40 VSUBS 52.6032f
Cext_862 \$I41 \$I42 894.107a
Cext_863 \$I41 \$I43 908.124a
Cext_864 \$I41 dvbe 2.33106f
Cext_865 \$I41 pbias 1.55798f
Cext_866 \$I41 pcasc 756.834a
Cext_867 \$I41 vref 897.779a
Cext_868 \$I41 vss 11.6252f
Cext_869 \$I41 VSUBS 51.5676f
Cext_870 \$I42 \$I43 22.8035f
Cext_871 \$I42 dvbe 1.8513f
Cext_872 \$I42 pbias 166.977a
Cext_873 \$I42 pcasc 156.745a
Cext_874 \$I42 vref 153.535a
Cext_875 \$I42 vss 3.68044f
Cext_876 \$I42 VSUBS 13.9312f
Cext_877 \$I43 dvbe 1.14918f
Cext_878 \$I43 pbias 150.785a
Cext_879 \$I43 pcasc 150.537a
Cext_880 \$I43 vref 6.85524f
Cext_881 \$I43 vss 2.86816f
Cext_882 \$I43 VSUBS 14.254f
Cext_883 \$I5 \$I6 44.9442f
Cext_884 \$I5 \$I7 191.913a
Cext_885 \$I5 \$I8 625.99a
Cext_886 \$I5 \$I9 38.0482f
Cext_887 \$I5 iptat 62.4707a
Cext_888 \$I5 pbias 7.86205f
Cext_889 \$I5 pcasc 5.04344f
Cext_890 \$I5 r4 84.042a
Cext_891 \$I5 vbe 410.181a
Cext_892 \$I5 vdd 1.45875f
Cext_893 \$I5 vref 721.324a
Cext_894 \$I5 vss 176.767a
Cext_895 \$I5 VSUBS 12.8838f
Cext_896 \$I6 \$I7 170.297a
Cext_897 \$I6 \$I8 29.9089f
Cext_898 \$I6 \$I9 317.637a
Cext_899 \$I6 iptat 119.263a
Cext_900 \$I6 pbias 2.63422f
Cext_901 \$I6 pcasc 2.41978f
Cext_902 \$I6 r4 79.7739a
Cext_903 \$I6 vbe 352.61a
Cext_904 \$I6 vdd 598.481a
Cext_905 \$I6 vref 258.773a
Cext_906 \$I6 vss 167.889a
Cext_907 \$I6 VSUBS 5.7494f
Cext_908 \$I7 \$I8 4.99287f
Cext_909 \$I7 \$I9 4.00492f
Cext_910 \$I7 iptat 69.3888a
Cext_911 \$I7 pbias 45.2201f
Cext_912 \$I7 pcasc 64.7787f
Cext_913 \$I7 r4 70.5561a
Cext_914 \$I7 vbe 18.5273f
Cext_915 \$I7 vdd 3.16565f
Cext_916 \$I7 vref 216.96a
Cext_917 \$I7 vss 22.5627f
Cext_918 \$I7 VSUBS 61.8186f
Cext_919 \$I8 \$I9 15.5283f
Cext_920 \$I8 iptat 55.1027a
Cext_921 \$I8 pbias 64.812f
Cext_922 \$I8 pcasc 26.5997f
Cext_923 \$I8 r4 71.994a
Cext_924 \$I8 vbe 1.27748f
Cext_925 \$I8 vdd 8.51386f
Cext_926 \$I8 vref 124.446a
Cext_927 \$I8 vss 389.485a
Cext_928 \$I8 VSUBS 62.3613f
Cext_929 \$I9 iptat 141.225a
Cext_930 \$I9 pbias 55.3858f
Cext_931 \$I9 pcasc 19.6426f
Cext_932 \$I9 r4 150.757a
Cext_933 \$I9 vbe 842.81a
Cext_934 \$I9 vdd 9.93236f
Cext_935 \$I9 vref 276.79a
Cext_936 \$I9 vss 440.8a
Cext_937 \$I9 VSUBS 68.5252f
Cext_938 dvbe pbias 912.084a
Cext_939 dvbe pcasc 912.084a
Cext_940 dvbe vbe 85.0231f
Cext_941 dvbe vref 1.11098f
Cext_942 dvbe vss 274.961f
Cext_943 iptat pbias 471.052a
Cext_944 iptat pcasc 1.81613f
Cext_945 iptat r4 32.7308a
Cext_946 iptat vbe 249.177a
Cext_947 iptat vdd 87.9917a
Cext_948 iptat vref 138.346a
Cext_949 iptat vss 75.6564a
Cext_950 pbias pcasc 102.754f
Cext_951 pbias r4 4.67987f
Cext_952 pbias vbe 842.094a
Cext_953 pbias vdd 200.088f
Cext_954 pbias vref 1.22851f
Cext_955 pbias vss 2.54694f
Cext_956 pcasc r4 31.003f
Cext_957 pcasc vbe 9.1441f
Cext_958 pcasc vdd 5.83032f
Cext_959 pcasc vref 10.7316f
Cext_960 pcasc vss 20.0683f
Cext_961 r4 vbe 1.38345f
Cext_962 r4 vdd 955.579a
Cext_963 r4 vref 120.97a
Cext_964 r4 vss 686.327a
Cext_965 vbe vdd 69.5003f
Cext_966 vbe vref 855.992a
Cext_967 vbe vss 299.981f
Cext_968 vdd vref 38.1519f
Cext_969 vdd vss 7.82197f
Cext_970 vref vss 40.574f
Cext_971 VSUBS dvbe 179.558f
Cext_972 VSUBS iptat 2.58552f
Cext_973 VSUBS pbias 530.267f
Cext_974 VSUBS pcasc 488.212f
Cext_975 VSUBS r4 6.23488f
Cext_976 VSUBS vbe 246.478f
Cext_977 VSUBS vdd 164.146f
Cext_978 VSUBS vref 25.9315f
Cext_979 VSUBS vss 1.4031p
.ENDS g1_bgr
