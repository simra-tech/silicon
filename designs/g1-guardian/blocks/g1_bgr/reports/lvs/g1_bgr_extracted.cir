* Extracted by KLayout with SG13G2 LVS runset on : 19/09/2026 12:53

.SUBCKT g1_bgr b1b c2 d1 d2 d3 d4 d5 det dvbe iptat kick n1 pbias pcasc r4 r4n
+ vb2 vbe vbe3 vd1 vd2 vdd vref vss
R$6 vss det vss rhigh w=0.5u l=735u ps=0u b=0 m=1
R$16 vss dvbe vss rppd w=1u l=51.5u ps=0u b=0 m=1
R$21 vbe3 vref vss rppd w=1u l=315u ps=0u b=0 m=1
R$23 vd1 vb2 vss rppd w=1u l=192u ps=0u b=0 m=1
M$27 vdd det kick vdd sg13_hv_pmos L=0.5u W=2u AS=0.68p AD=0.68p PS=4.68u
+ PD=4.68u rfmode=0
M$28 vdd r4 r4n vdd sg13_hv_pmos L=0.5u W=2u AS=0.68p AD=0.68p PS=4.68u
+ PD=4.68u rfmode=0
M$29 b1b r4 vbe vss sg13_hv_nmos L=0.5u W=2u AS=0.68p AD=0.68p PS=4.68u
+ PD=4.68u rfmode=0
M$30 vss kick pbias vss sg13_hv_nmos L=4u W=1u AS=0.34p AD=0.34p PS=2.68u
+ PD=2.68u rfmode=0
M$31 vss det kick vss sg13_hv_nmos L=0.5u W=1u AS=0.34p AD=0.34p PS=2.68u
+ PD=2.68u rfmode=0
M$32 vss r4 r4n vss sg13_hv_nmos L=0.5u W=1u AS=0.34p AD=0.34p PS=2.68u
+ PD=2.68u rfmode=0
M$33 vss r4n b1b vss sg13_hv_nmos L=0.5u W=1u AS=0.34p AD=0.34p PS=2.68u
+ PD=2.68u rfmode=0
M$34 vbe vb2 n1 vss sg13_hv_nmos L=1u W=20u AS=6.8p AD=6.8p PS=41.36u PD=41.36u
+ rfmode=0
M$35 pcasc vb2 c2 vss sg13_hv_nmos L=1u W=20u AS=6.8p AD=6.8p PS=41.36u
+ PD=41.36u rfmode=0
M$38 vdd pbias d1 vdd sg13_hv_pmos L=4u W=10u AS=3.4p AD=3.4p PS=21.36u
+ PD=21.36u rfmode=0
M$39 vdd pbias d2 vdd sg13_hv_pmos L=4u W=10u AS=3.4p AD=3.4p PS=21.36u
+ PD=21.36u rfmode=0
M$40 vdd pbias d4 vdd sg13_hv_pmos L=4u W=10u AS=3.4p AD=3.4p PS=21.36u
+ PD=21.36u rfmode=0
M$41 vdd pbias d5 vdd sg13_hv_pmos L=4u W=10u AS=3.4p AD=3.4p PS=21.36u
+ PD=21.36u rfmode=0
M$42 vdd pbias det vdd sg13_hv_pmos L=4u W=10u AS=3.4p AD=3.4p PS=21.36u
+ PD=21.36u rfmode=0
M$43 vdd pbias d3 vdd sg13_hv_pmos L=4u W=10u AS=3.4p AD=3.4p PS=21.36u
+ PD=21.36u rfmode=0
M$50 d5 pcasc vb2 d5 sg13_hv_pmos L=4u W=10u AS=3.4p AD=3.4p PS=20.68u
+ PD=20.68u rfmode=0
M$51 d3 pcasc vref d3 sg13_hv_pmos L=4u W=10u AS=3.4p AD=3.4p PS=20.68u
+ PD=20.68u rfmode=0
M$52 d1 pcasc n1 d1 sg13_hv_pmos L=4u W=10u AS=3.4p AD=3.4p PS=20.68u PD=20.68u
+ rfmode=0
M$53 d4 pcasc iptat d4 sg13_hv_pmos L=4u W=10u AS=3.4p AD=3.4p PS=20.68u
+ PD=20.68u rfmode=0
M$54 d2 pcasc pbias d2 sg13_hv_pmos L=4u W=10u AS=3.4p AD=3.4p PS=20.68u
+ PD=20.68u rfmode=0
Q$55 vss vss vss vss npn13G2 we=70n le=900n Nx=1 m=9
Q$56 vbe vbe vss vss npn13G2 we=70n le=900n Nx=1 m=1
Q$60 vbe3 vbe3 vss vss npn13G2 we=70n le=900n Nx=1 m=1
Q$62 vd2 vd2 vss vss npn13G2 we=70n le=900n Nx=1 m=1
Q$67 vbe b1b vss vss npn13G2 we=70n le=900n Nx=1 m=1
Q$68 c2 vbe dvbe vss npn13G2 we=70n le=900n Nx=1 m=8
Q$75 vd1 vd1 vd2 vss npn13G2 we=70n le=900n Nx=1 m=1
R$78 pcasc pbias vss rppd w=1u l=500u ps=0u b=0 m=1
.ENDS g1_bgr
