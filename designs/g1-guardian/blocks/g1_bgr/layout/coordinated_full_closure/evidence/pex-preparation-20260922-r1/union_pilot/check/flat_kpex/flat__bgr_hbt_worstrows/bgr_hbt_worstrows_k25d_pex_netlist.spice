*********************************************************
*** NGSPICE file created by KLayout-PEX 0.3.12
*** -----------------------------------------------------
***     Extraction Engine: KPEX/2.5D
***     Technology: ihp_sg13g2
***     Date: 2026-09-22 22:17:34
*********************************************************

.SUBCKT bgr_hbt_worstrows c2 dvbe vbe vd1 vd2 vss
Q$1 c2 vbe dvbe vss npn13G2 we=0.07 le=0.9 Nx=1 m=1
Q$2 vd1 vd1 vd2 vss npn13G2 we=0.07 le=0.9 Nx=1 m=1
Q$3 vd1 vd1 vd2 vss npn13G2 we=0.07 le=0.9 Nx=1 m=1
Q$4 vd1 vd1 vd2 vss npn13G2 we=0.07 le=0.9 Nx=1 m=1
Q$5 vd1 vd1 vd2 vss npn13G2 we=0.07 le=0.9 Nx=1 m=1
Q$6 vd1 vd1 vd2 vss npn13G2 we=0.07 le=0.9 Nx=1 m=1
Q$7 vd1 vd1 vd2 vss npn13G2 we=0.07 le=0.9 Nx=1 m=1
Q$8 vd1 vd1 vd2 vss npn13G2 we=0.07 le=0.9 Nx=1 m=1
Q$9 vd1 vd1 vd2 vss npn13G2 we=0.07 le=0.9 Nx=1 m=1
Q$10 vd1 vd1 vd2 vss npn13G2 we=0.07 le=0.9 Nx=1 m=1
Q$11 vd1 vd1 vd2 vss npn13G2 we=0.07 le=0.9 Nx=1 m=1
Q$12 vd1 vd1 vd2 vss npn13G2 we=0.07 le=0.9 Nx=1 m=1
Q$13 vd1 vd1 vd2 vss npn13G2 we=0.07 le=0.9 Nx=1 m=1
Q$14 c2 vbe dvbe vss npn13G2 we=0.07 le=0.9 Nx=1 m=1
Q$15 c2 vbe dvbe vss npn13G2 we=0.07 le=0.9 Nx=1 m=1
Q$16 c2 vbe dvbe vss npn13G2 we=0.07 le=0.9 Nx=1 m=1
Q$17 c2 vbe dvbe vss npn13G2 we=0.07 le=0.9 Nx=1 m=1
Q$18 c2 vbe dvbe vss npn13G2 we=0.07 le=0.9 Nx=1 m=1
Q$19 c2 vbe dvbe vss npn13G2 we=0.07 le=0.9 Nx=1 m=1
Q$20 c2 vbe dvbe vss npn13G2 we=0.07 le=0.9 Nx=1 m=1
Q$21 c2 vbe dvbe vss npn13G2 we=0.07 le=0.9 Nx=1 m=1
Q$22 vd1 vd1 vd2 vss npn13G2 we=0.07 le=0.9 Nx=1 m=1
Q$23 vd1 vd1 vd2 vss npn13G2 we=0.07 le=0.9 Nx=1 m=1
Q$24 vd1 vd1 vd2 vss npn13G2 we=0.07 le=0.9 Nx=1 m=1
Q$25 vd1 vd1 vd2 vss npn13G2 we=0.07 le=0.9 Nx=1 m=1
Q$26 vd1 vd1 vd2 vss npn13G2 we=0.07 le=0.9 Nx=1 m=1
Q$27 vd1 vd1 vd2 vss npn13G2 we=0.07 le=0.9 Nx=1 m=1
Q$28 vd1 vd1 vd2 vss npn13G2 we=0.07 le=0.9 Nx=1 m=1
Q$29 vd1 vd1 vd2 vss npn13G2 we=0.07 le=0.9 Nx=1 m=1
Q$30 vd1 vd1 vd2 vss npn13G2 we=0.07 le=0.9 Nx=1 m=1
Q$31 vd1 vd1 vd2 vss npn13G2 we=0.07 le=0.9 Nx=1 m=1
Q$32 vd1 vd1 vd2 vss npn13G2 we=0.07 le=0.9 Nx=1 m=1
Q$33 vd1 vd1 vd2 vss npn13G2 we=0.07 le=0.9 Nx=1 m=1
Q$34 c2 vbe dvbe vss npn13G2 we=0.07 le=0.9 Nx=1 m=1
Cext_1 c2 dvbe 10.9621f
Cext_2 c2 vbe 299.481a
Cext_3 c2 vd1 86.9413a
Cext_4 c2 vd2 45.1513f
Cext_5 c2 vss 67.9752f
Cext_6 dvbe vbe 5.51158f
Cext_7 dvbe vd1 178.958a
Cext_8 dvbe vd2 46.4531f
Cext_9 dvbe vss 4.65641f
Cext_10 vbe vd1 50.3535f
Cext_11 vbe vd2 276.804a
Cext_12 vbe vss 2.84917f
Cext_13 vd1 vd2 18.8482f
Cext_14 vd1 vss 5.51553f
Cext_15 vd2 vss 11.4828f
Cext_16 VSUBS c2 10.5594f
Cext_17 VSUBS dvbe 17.8361f
Cext_18 VSUBS vbe 18.8123f
Cext_19 VSUBS vd1 28.3875f
Cext_20 VSUBS vd2 17.5393f
Cext_21 VSUBS vss 100.366f
.ENDS bgr_hbt_worstrows
