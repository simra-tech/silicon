* cell bgr_hbt_worstrows
* pin c2
* pin dvbe
* pin vbe
* pin vd1
* pin vd2
* pin vss
.SUBCKT bgr_hbt_worstrows 6 4 3 2 5 1
* net 1 vss
* net 2 vd1
* net 3 vbe
* net 4 dvbe
* net 5 vd2
* net 6 c2
* device instance $1 r0 *1 10.9,220.67 npn13G2
Q$1 6 3 4 1 npn13G2 we=0.07 le=0.9 Nx=1 m=1
* device instance $2 r0 *1 21.6,220.67 npn13G2
Q$2 2 2 5 1 npn13G2 we=0.07 le=0.9 Nx=1 m=1
* device instance $3 r0 *1 32.3,220.67 npn13G2
Q$3 2 2 5 1 npn13G2 we=0.07 le=0.9 Nx=1 m=1
* device instance $4 r0 *1 43,220.67 npn13G2
Q$4 2 2 5 1 npn13G2 we=0.07 le=0.9 Nx=1 m=1
* device instance $5 r0 *1 53.7,220.67 npn13G2
Q$5 2 2 5 1 npn13G2 we=0.07 le=0.9 Nx=1 m=1
* device instance $6 r0 *1 64.4,220.67 npn13G2
Q$6 2 2 5 1 npn13G2 we=0.07 le=0.9 Nx=1 m=1
* device instance $7 r0 *1 75.1,220.67 npn13G2
Q$7 2 2 5 1 npn13G2 we=0.07 le=0.9 Nx=1 m=1
* device instance $8 r0 *1 85.8,220.67 npn13G2
Q$8 2 2 5 1 npn13G2 we=0.07 le=0.9 Nx=1 m=1
* device instance $9 r0 *1 96.5,220.67 npn13G2
Q$9 2 2 5 1 npn13G2 we=0.07 le=0.9 Nx=1 m=1
* device instance $10 r0 *1 107.2,220.67 npn13G2
Q$10 2 2 5 1 npn13G2 we=0.07 le=0.9 Nx=1 m=1
* device instance $11 r0 *1 117.9,220.67 npn13G2
Q$11 2 2 5 1 npn13G2 we=0.07 le=0.9 Nx=1 m=1
* device instance $12 r0 *1 128.6,220.67 npn13G2
Q$12 2 2 5 1 npn13G2 we=0.07 le=0.9 Nx=1 m=1
* device instance $13 r0 *1 139.3,220.67 npn13G2
Q$13 2 2 5 1 npn13G2 we=0.07 le=0.9 Nx=1 m=1
* device instance $14 r0 *1 150,220.67 npn13G2
Q$14 6 3 4 1 npn13G2 we=0.07 le=0.9 Nx=1 m=1
* device instance $15 r0 *1 160.7,220.67 npn13G2
Q$15 6 3 4 1 npn13G2 we=0.07 le=0.9 Nx=1 m=1
* device instance $16 r0 *1 171.4,220.67 npn13G2
Q$16 6 3 4 1 npn13G2 we=0.07 le=0.9 Nx=1 m=1
* device instance $17 r0 *1 182.1,220.67 npn13G2
Q$17 6 3 4 1 npn13G2 we=0.07 le=0.9 Nx=1 m=1
* device instance $18 r0 *1 10.9,265.11 npn13G2
Q$18 6 3 4 1 npn13G2 we=0.07 le=0.9 Nx=1 m=1
* device instance $19 r0 *1 21.6,265.11 npn13G2
Q$19 6 3 4 1 npn13G2 we=0.07 le=0.9 Nx=1 m=1
* device instance $20 r0 *1 32.3,265.11 npn13G2
Q$20 6 3 4 1 npn13G2 we=0.07 le=0.9 Nx=1 m=1
* device instance $21 r0 *1 43,265.11 npn13G2
Q$21 6 3 4 1 npn13G2 we=0.07 le=0.9 Nx=1 m=1
* device instance $22 r0 *1 53.7,265.11 npn13G2
Q$22 2 2 5 1 npn13G2 we=0.07 le=0.9 Nx=1 m=1
* device instance $23 r0 *1 64.4,265.11 npn13G2
Q$23 2 2 5 1 npn13G2 we=0.07 le=0.9 Nx=1 m=1
* device instance $24 r0 *1 75.1,265.11 npn13G2
Q$24 2 2 5 1 npn13G2 we=0.07 le=0.9 Nx=1 m=1
* device instance $25 r0 *1 85.8,265.11 npn13G2
Q$25 2 2 5 1 npn13G2 we=0.07 le=0.9 Nx=1 m=1
* device instance $26 r0 *1 96.5,265.11 npn13G2
Q$26 2 2 5 1 npn13G2 we=0.07 le=0.9 Nx=1 m=1
* device instance $27 r0 *1 107.2,265.11 npn13G2
Q$27 2 2 5 1 npn13G2 we=0.07 le=0.9 Nx=1 m=1
* device instance $28 r0 *1 117.9,265.11 npn13G2
Q$28 2 2 5 1 npn13G2 we=0.07 le=0.9 Nx=1 m=1
* device instance $29 r0 *1 128.6,265.11 npn13G2
Q$29 2 2 5 1 npn13G2 we=0.07 le=0.9 Nx=1 m=1
* device instance $30 r0 *1 139.3,265.11 npn13G2
Q$30 2 2 5 1 npn13G2 we=0.07 le=0.9 Nx=1 m=1
* device instance $31 r0 *1 150,265.11 npn13G2
Q$31 2 2 5 1 npn13G2 we=0.07 le=0.9 Nx=1 m=1
* device instance $32 r0 *1 160.7,265.11 npn13G2
Q$32 2 2 5 1 npn13G2 we=0.07 le=0.9 Nx=1 m=1
* device instance $33 r0 *1 171.4,265.11 npn13G2
Q$33 2 2 5 1 npn13G2 we=0.07 le=0.9 Nx=1 m=1
* device instance $34 r0 *1 182.1,265.11 npn13G2
Q$34 6 3 4 1 npn13G2 we=0.07 le=0.9 Nx=1 m=1
.ENDS bgr_hbt_worstrows
