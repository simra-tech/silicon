* cell g1_bgr
* pin dvbe
* pin iptat
* pin pbias
* pin pcasc
* pin r4
* pin vbe
* pin vdd
* pin vref
* pin vss
.SUBCKT g1_bgr 9 48 36 35 43 40 52 38 1
* net 1 vss
* net 9 dvbe
* net 35 pcasc
* net 36 pbias
* net 38 vref
* net 40 vbe
* net 43 r4
* net 48 iptat
* net 52 vdd
* device instance $1 r0 *1 405.36,162.86 sg13_hv_nmos
M$1 40 43 47 1 sg13_hv_nmos L=0.5U W=2U AS=0.68P AD=0.68P PS=4.68U PD=4.68U
+ rfmode=0
* device instance $2 r0 *1 206.96,178.1 sg13_hv_nmos
M$2 36 54 1 1 sg13_hv_nmos L=4U W=1U AS=0.34P AD=0.34P PS=2.68U PD=2.68U
+ rfmode=0
* device instance $3 r0 *1 216.93,178.1 sg13_hv_nmos
M$3 54 8 1 1 sg13_hv_nmos L=0.6U W=1U AS=0.34P AD=0.34P PS=2.68U PD=2.68U
+ rfmode=0
* device instance $4 r0 *1 226.8,178.1 sg13_hv_nmos
M$4 55 43 1 1 sg13_hv_nmos L=0.5U W=1U AS=0.34P AD=0.34P PS=2.68U PD=2.68U
+ rfmode=0
* device instance $5 r0 *1 236.77,178.1 sg13_hv_nmos
M$5 47 55 1 1 sg13_hv_nmos L=0.6U W=1U AS=0.34P AD=0.34P PS=2.68U PD=2.68U
+ rfmode=0
* device instance $6 r0 *1 206.11,313.64 sg13_hv_nmos
M$6 46 45 40 1 sg13_hv_nmos L=1U W=10U AS=3.4P AD=3.4P PS=20.68U PD=20.68U
+ rfmode=0
* device instance $7 r0 *1 212.33,313.64 sg13_hv_nmos
M$7 46 45 40 1 sg13_hv_nmos L=1U W=10U AS=3.4P AD=3.4P PS=20.68U PD=20.68U
+ rfmode=0
* device instance $8 r0 *1 218.55,313.64 sg13_hv_nmos
M$8 46 45 40 1 sg13_hv_nmos L=1U W=10U AS=3.4P AD=3.4P PS=20.68U PD=20.68U
+ rfmode=0
* device instance $9 r0 *1 224.77,313.64 sg13_hv_nmos
M$9 46 45 40 1 sg13_hv_nmos L=1U W=10U AS=3.4P AD=3.4P PS=20.68U PD=20.68U
+ rfmode=0
* device instance $10 r0 *1 230.99,313.64 sg13_hv_nmos
M$10 46 45 40 1 sg13_hv_nmos L=1U W=10U AS=3.4P AD=3.4P PS=20.68U PD=20.68U
+ rfmode=0
* device instance $11 r0 *1 237.21,313.64 sg13_hv_nmos
M$11 46 45 40 1 sg13_hv_nmos L=1U W=10U AS=3.4P AD=3.4P PS=20.68U PD=20.68U
+ rfmode=0
* device instance $12 r0 *1 243.43,313.64 sg13_hv_nmos
M$12 46 45 40 1 sg13_hv_nmos L=1U W=10U AS=3.4P AD=3.4P PS=20.68U PD=20.68U
+ rfmode=0
* device instance $13 r0 *1 249.65,313.64 sg13_hv_nmos
M$13 46 45 40 1 sg13_hv_nmos L=1U W=10U AS=3.4P AD=3.4P PS=20.68U PD=20.68U
+ rfmode=0
* device instance $14 r0 *1 255.87,313.64 sg13_hv_nmos
M$14 46 45 40 1 sg13_hv_nmos L=1U W=10U AS=3.4P AD=3.4P PS=20.68U PD=20.68U
+ rfmode=0
* device instance $15 r0 *1 262.09,313.64 sg13_hv_nmos
M$15 46 45 40 1 sg13_hv_nmos L=1U W=10U AS=3.4P AD=3.4P PS=20.68U PD=20.68U
+ rfmode=0
* device instance $16 r0 *1 268.31,313.64 sg13_hv_nmos
M$16 46 45 40 1 sg13_hv_nmos L=1U W=10U AS=3.4P AD=3.4P PS=20.68U PD=20.68U
+ rfmode=0
* device instance $17 r0 *1 274.53,313.64 sg13_hv_nmos
M$17 46 45 40 1 sg13_hv_nmos L=1U W=10U AS=3.4P AD=3.4P PS=20.68U PD=20.68U
+ rfmode=0
* device instance $18 r0 *1 280.75,313.64 sg13_hv_nmos
M$18 53 45 35 1 sg13_hv_nmos L=1U W=10U AS=3.4P AD=3.4P PS=20.68U PD=20.68U
+ rfmode=0
* device instance $19 r0 *1 286.97,313.64 sg13_hv_nmos
M$19 53 45 35 1 sg13_hv_nmos L=1U W=10U AS=3.4P AD=3.4P PS=20.68U PD=20.68U
+ rfmode=0
* device instance $20 r0 *1 293.19,313.64 sg13_hv_nmos
M$20 53 45 35 1 sg13_hv_nmos L=1U W=10U AS=3.4P AD=3.4P PS=20.68U PD=20.68U
+ rfmode=0
* device instance $21 r0 *1 299.41,313.64 sg13_hv_nmos
M$21 53 45 35 1 sg13_hv_nmos L=1U W=10U AS=3.4P AD=3.4P PS=20.68U PD=20.68U
+ rfmode=0
* device instance $22 r0 *1 305.63,313.64 sg13_hv_nmos
M$22 53 45 35 1 sg13_hv_nmos L=1U W=10U AS=3.4P AD=3.4P PS=20.68U PD=20.68U
+ rfmode=0
* device instance $23 r0 *1 311.85,313.64 sg13_hv_nmos
M$23 53 45 35 1 sg13_hv_nmos L=1U W=10U AS=3.4P AD=3.4P PS=20.68U PD=20.68U
+ rfmode=0
* device instance $24 r0 *1 318.07,313.64 sg13_hv_nmos
M$24 53 45 35 1 sg13_hv_nmos L=1U W=10U AS=3.4P AD=3.4P PS=20.68U PD=20.68U
+ rfmode=0
* device instance $25 r0 *1 324.29,313.64 sg13_hv_nmos
M$25 53 45 35 1 sg13_hv_nmos L=1U W=10U AS=3.4P AD=3.4P PS=20.68U PD=20.68U
+ rfmode=0
* device instance $26 r0 *1 330.51,313.64 sg13_hv_nmos
M$26 53 45 35 1 sg13_hv_nmos L=1U W=10U AS=3.4P AD=3.4P PS=20.68U PD=20.68U
+ rfmode=0
* device instance $27 r0 *1 336.73,313.64 sg13_hv_nmos
M$27 53 45 35 1 sg13_hv_nmos L=1U W=10U AS=3.4P AD=3.4P PS=20.68U PD=20.68U
+ rfmode=0
* device instance $28 r0 *1 342.95,313.64 sg13_hv_nmos
M$28 53 45 35 1 sg13_hv_nmos L=1U W=10U AS=3.4P AD=3.4P PS=20.68U PD=20.68U
+ rfmode=0
* device instance $29 r0 *1 349.17,313.64 sg13_hv_nmos
M$29 53 45 35 1 sg13_hv_nmos L=1U W=10U AS=3.4P AD=3.4P PS=20.68U PD=20.68U
+ rfmode=0
* device instance $30 r0 *1 355.39,313.64 sg13_hv_nmos
M$30 40 45 46 1 sg13_hv_nmos L=1U W=10U AS=3.4P AD=3.4P PS=20.68U PD=20.68U
+ rfmode=0
* device instance $31 r0 *1 361.61,313.64 sg13_hv_nmos
M$31 40 45 46 1 sg13_hv_nmos L=1U W=10U AS=3.4P AD=3.4P PS=20.68U PD=20.68U
+ rfmode=0
* device instance $32 r0 *1 367.83,313.64 sg13_hv_nmos
M$32 40 45 46 1 sg13_hv_nmos L=1U W=10U AS=3.4P AD=3.4P PS=20.68U PD=20.68U
+ rfmode=0
* device instance $33 r0 *1 374.05,313.64 sg13_hv_nmos
M$33 40 45 46 1 sg13_hv_nmos L=1U W=10U AS=3.4P AD=3.4P PS=20.68U PD=20.68U
+ rfmode=0
* device instance $34 r0 *1 380.27,313.64 sg13_hv_nmos
M$34 40 45 46 1 sg13_hv_nmos L=1U W=10U AS=3.4P AD=3.4P PS=20.68U PD=20.68U
+ rfmode=0
* device instance $35 r0 *1 386.49,313.64 sg13_hv_nmos
M$35 40 45 46 1 sg13_hv_nmos L=1U W=10U AS=3.4P AD=3.4P PS=20.68U PD=20.68U
+ rfmode=0
* device instance $36 r0 *1 392.71,313.64 sg13_hv_nmos
M$36 40 45 46 1 sg13_hv_nmos L=1U W=10U AS=3.4P AD=3.4P PS=20.68U PD=20.68U
+ rfmode=0
* device instance $37 r0 *1 398.93,313.64 sg13_hv_nmos
M$37 40 45 46 1 sg13_hv_nmos L=1U W=10U AS=3.4P AD=3.4P PS=20.68U PD=20.68U
+ rfmode=0
* device instance $38 r0 *1 405.15,313.64 sg13_hv_nmos
M$38 40 45 46 1 sg13_hv_nmos L=1U W=10U AS=3.4P AD=3.4P PS=20.68U PD=20.68U
+ rfmode=0
* device instance $39 r0 *1 206.11,343.72 sg13_hv_nmos
M$39 40 45 46 1 sg13_hv_nmos L=1U W=10U AS=3.4P AD=3.4P PS=20.68U PD=20.68U
+ rfmode=0
* device instance $40 r0 *1 206.11,328.68 sg13_hv_nmos
M$40 40 45 46 1 sg13_hv_nmos L=1U W=10U AS=3.4P AD=3.4P PS=20.68U PD=20.68U
+ rfmode=0
* device instance $41 r0 *1 212.33,328.68 sg13_hv_nmos
M$41 40 45 46 1 sg13_hv_nmos L=1U W=10U AS=3.4P AD=3.4P PS=20.68U PD=20.68U
+ rfmode=0
* device instance $42 r0 *1 212.33,343.72 sg13_hv_nmos
M$42 40 45 46 1 sg13_hv_nmos L=1U W=10U AS=3.4P AD=3.4P PS=20.68U PD=20.68U
+ rfmode=0
* device instance $43 r0 *1 218.55,343.72 sg13_hv_nmos
M$43 40 45 46 1 sg13_hv_nmos L=1U W=10U AS=3.4P AD=3.4P PS=20.68U PD=20.68U
+ rfmode=0
* device instance $44 r0 *1 218.55,328.68 sg13_hv_nmos
M$44 40 45 46 1 sg13_hv_nmos L=1U W=10U AS=3.4P AD=3.4P PS=20.68U PD=20.68U
+ rfmode=0
* device instance $45 r0 *1 224.77,343.72 sg13_hv_nmos
M$45 40 45 46 1 sg13_hv_nmos L=1U W=10U AS=3.4P AD=3.4P PS=20.68U PD=20.68U
+ rfmode=0
* device instance $46 r0 *1 224.77,328.68 sg13_hv_nmos
M$46 35 45 53 1 sg13_hv_nmos L=1U W=10U AS=3.4P AD=3.4P PS=20.68U PD=20.68U
+ rfmode=0
* device instance $47 r0 *1 230.99,343.72 sg13_hv_nmos
M$47 40 45 46 1 sg13_hv_nmos L=1U W=10U AS=3.4P AD=3.4P PS=20.68U PD=20.68U
+ rfmode=0
* device instance $48 r0 *1 230.99,328.68 sg13_hv_nmos
M$48 35 45 53 1 sg13_hv_nmos L=1U W=10U AS=3.4P AD=3.4P PS=20.68U PD=20.68U
+ rfmode=0
* device instance $49 r0 *1 237.21,328.68 sg13_hv_nmos
M$49 35 45 53 1 sg13_hv_nmos L=1U W=10U AS=3.4P AD=3.4P PS=20.68U PD=20.68U
+ rfmode=0
* device instance $50 r0 *1 237.21,343.72 sg13_hv_nmos
M$50 40 45 46 1 sg13_hv_nmos L=1U W=10U AS=3.4P AD=3.4P PS=20.68U PD=20.68U
+ rfmode=0
* device instance $51 r0 *1 243.43,328.68 sg13_hv_nmos
M$51 35 45 53 1 sg13_hv_nmos L=1U W=10U AS=3.4P AD=3.4P PS=20.68U PD=20.68U
+ rfmode=0
* device instance $52 r0 *1 243.43,343.72 sg13_hv_nmos
M$52 40 45 46 1 sg13_hv_nmos L=1U W=10U AS=3.4P AD=3.4P PS=20.68U PD=20.68U
+ rfmode=0
* device instance $53 r0 *1 249.65,328.68 sg13_hv_nmos
M$53 35 45 53 1 sg13_hv_nmos L=1U W=10U AS=3.4P AD=3.4P PS=20.68U PD=20.68U
+ rfmode=0
* device instance $54 r0 *1 249.65,343.72 sg13_hv_nmos
M$54 40 45 46 1 sg13_hv_nmos L=1U W=10U AS=3.4P AD=3.4P PS=20.68U PD=20.68U
+ rfmode=0
* device instance $55 r0 *1 255.87,328.68 sg13_hv_nmos
M$55 35 45 53 1 sg13_hv_nmos L=1U W=10U AS=3.4P AD=3.4P PS=20.68U PD=20.68U
+ rfmode=0
* device instance $56 r0 *1 255.87,343.72 sg13_hv_nmos
M$56 40 45 46 1 sg13_hv_nmos L=1U W=10U AS=3.4P AD=3.4P PS=20.68U PD=20.68U
+ rfmode=0
* device instance $57 r0 *1 262.09,343.72 sg13_hv_nmos
M$57 53 45 35 1 sg13_hv_nmos L=1U W=10U AS=3.4P AD=3.4P PS=20.68U PD=20.68U
+ rfmode=0
* device instance $58 r0 *1 262.09,328.68 sg13_hv_nmos
M$58 35 45 53 1 sg13_hv_nmos L=1U W=10U AS=3.4P AD=3.4P PS=20.68U PD=20.68U
+ rfmode=0
* device instance $59 r0 *1 268.31,343.72 sg13_hv_nmos
M$59 53 45 35 1 sg13_hv_nmos L=1U W=10U AS=3.4P AD=3.4P PS=20.68U PD=20.68U
+ rfmode=0
* device instance $60 r0 *1 268.31,328.68 sg13_hv_nmos
M$60 35 45 53 1 sg13_hv_nmos L=1U W=10U AS=3.4P AD=3.4P PS=20.68U PD=20.68U
+ rfmode=0
* device instance $61 r0 *1 274.53,343.72 sg13_hv_nmos
M$61 53 45 35 1 sg13_hv_nmos L=1U W=10U AS=3.4P AD=3.4P PS=20.68U PD=20.68U
+ rfmode=0
* device instance $62 r0 *1 274.53,328.68 sg13_hv_nmos
M$62 35 45 53 1 sg13_hv_nmos L=1U W=10U AS=3.4P AD=3.4P PS=20.68U PD=20.68U
+ rfmode=0
* device instance $63 r0 *1 280.75,343.72 sg13_hv_nmos
M$63 53 45 35 1 sg13_hv_nmos L=1U W=10U AS=3.4P AD=3.4P PS=20.68U PD=20.68U
+ rfmode=0
* device instance $64 r0 *1 280.75,328.68 sg13_hv_nmos
M$64 35 45 53 1 sg13_hv_nmos L=1U W=10U AS=3.4P AD=3.4P PS=20.68U PD=20.68U
+ rfmode=0
* device instance $65 r0 *1 286.97,328.68 sg13_hv_nmos
M$65 35 45 53 1 sg13_hv_nmos L=1U W=10U AS=3.4P AD=3.4P PS=20.68U PD=20.68U
+ rfmode=0
* device instance $66 r0 *1 286.97,343.72 sg13_hv_nmos
M$66 53 45 35 1 sg13_hv_nmos L=1U W=10U AS=3.4P AD=3.4P PS=20.68U PD=20.68U
+ rfmode=0
* device instance $67 r0 *1 293.19,328.68 sg13_hv_nmos
M$67 35 45 53 1 sg13_hv_nmos L=1U W=10U AS=3.4P AD=3.4P PS=20.68U PD=20.68U
+ rfmode=0
* device instance $68 r0 *1 293.19,343.72 sg13_hv_nmos
M$68 53 45 35 1 sg13_hv_nmos L=1U W=10U AS=3.4P AD=3.4P PS=20.68U PD=20.68U
+ rfmode=0
* device instance $69 r0 *1 299.41,343.72 sg13_hv_nmos
M$69 53 45 35 1 sg13_hv_nmos L=1U W=10U AS=3.4P AD=3.4P PS=20.68U PD=20.68U
+ rfmode=0
* device instance $70 r0 *1 305.63,343.72 sg13_hv_nmos
M$70 53 45 35 1 sg13_hv_nmos L=1U W=10U AS=3.4P AD=3.4P PS=20.68U PD=20.68U
+ rfmode=0
* device instance $71 r0 *1 311.85,343.72 sg13_hv_nmos
M$71 53 45 35 1 sg13_hv_nmos L=1U W=10U AS=3.4P AD=3.4P PS=20.68U PD=20.68U
+ rfmode=0
* device instance $72 r0 *1 318.07,343.72 sg13_hv_nmos
M$72 53 45 35 1 sg13_hv_nmos L=1U W=10U AS=3.4P AD=3.4P PS=20.68U PD=20.68U
+ rfmode=0
* device instance $73 r0 *1 318.07,328.68 sg13_hv_nmos
M$73 35 45 53 1 sg13_hv_nmos L=1U W=10U AS=3.4P AD=3.4P PS=20.68U PD=20.68U
+ rfmode=0
* device instance $74 r0 *1 324.29,328.68 sg13_hv_nmos
M$74 35 45 53 1 sg13_hv_nmos L=1U W=10U AS=3.4P AD=3.4P PS=20.68U PD=20.68U
+ rfmode=0
* device instance $75 r0 *1 324.29,343.72 sg13_hv_nmos
M$75 53 45 35 1 sg13_hv_nmos L=1U W=10U AS=3.4P AD=3.4P PS=20.68U PD=20.68U
+ rfmode=0
* device instance $76 r0 *1 330.51,343.72 sg13_hv_nmos
M$76 53 45 35 1 sg13_hv_nmos L=1U W=10U AS=3.4P AD=3.4P PS=20.68U PD=20.68U
+ rfmode=0
* device instance $77 r0 *1 330.51,328.68 sg13_hv_nmos
M$77 35 45 53 1 sg13_hv_nmos L=1U W=10U AS=3.4P AD=3.4P PS=20.68U PD=20.68U
+ rfmode=0
* device instance $78 r0 *1 336.73,328.68 sg13_hv_nmos
M$78 35 45 53 1 sg13_hv_nmos L=1U W=10U AS=3.4P AD=3.4P PS=20.68U PD=20.68U
+ rfmode=0
* device instance $79 r0 *1 336.73,343.72 sg13_hv_nmos
M$79 46 45 40 1 sg13_hv_nmos L=1U W=10U AS=3.4P AD=3.4P PS=20.68U PD=20.68U
+ rfmode=0
* device instance $80 r0 *1 342.95,343.72 sg13_hv_nmos
M$80 46 45 40 1 sg13_hv_nmos L=1U W=10U AS=3.4P AD=3.4P PS=20.68U PD=20.68U
+ rfmode=0
* device instance $81 r0 *1 342.95,328.68 sg13_hv_nmos
M$81 35 45 53 1 sg13_hv_nmos L=1U W=10U AS=3.4P AD=3.4P PS=20.68U PD=20.68U
+ rfmode=0
* device instance $82 r0 *1 349.17,328.68 sg13_hv_nmos
M$82 35 45 53 1 sg13_hv_nmos L=1U W=10U AS=3.4P AD=3.4P PS=20.68U PD=20.68U
+ rfmode=0
* device instance $83 r0 *1 349.17,343.72 sg13_hv_nmos
M$83 46 45 40 1 sg13_hv_nmos L=1U W=10U AS=3.4P AD=3.4P PS=20.68U PD=20.68U
+ rfmode=0
* device instance $84 r0 *1 355.39,328.68 sg13_hv_nmos
M$84 35 45 53 1 sg13_hv_nmos L=1U W=10U AS=3.4P AD=3.4P PS=20.68U PD=20.68U
+ rfmode=0
* device instance $85 r0 *1 355.39,343.72 sg13_hv_nmos
M$85 46 45 40 1 sg13_hv_nmos L=1U W=10U AS=3.4P AD=3.4P PS=20.68U PD=20.68U
+ rfmode=0
* device instance $86 r0 *1 361.61,328.68 sg13_hv_nmos
M$86 35 45 53 1 sg13_hv_nmos L=1U W=10U AS=3.4P AD=3.4P PS=20.68U PD=20.68U
+ rfmode=0
* device instance $87 r0 *1 361.61,343.72 sg13_hv_nmos
M$87 46 45 40 1 sg13_hv_nmos L=1U W=10U AS=3.4P AD=3.4P PS=20.68U PD=20.68U
+ rfmode=0
* device instance $88 r0 *1 367.83,343.72 sg13_hv_nmos
M$88 46 45 40 1 sg13_hv_nmos L=1U W=10U AS=3.4P AD=3.4P PS=20.68U PD=20.68U
+ rfmode=0
* device instance $89 r0 *1 367.83,328.68 sg13_hv_nmos
M$89 35 45 53 1 sg13_hv_nmos L=1U W=10U AS=3.4P AD=3.4P PS=20.68U PD=20.68U
+ rfmode=0
* device instance $90 r0 *1 374.05,343.72 sg13_hv_nmos
M$90 46 45 40 1 sg13_hv_nmos L=1U W=10U AS=3.4P AD=3.4P PS=20.68U PD=20.68U
+ rfmode=0
* device instance $91 r0 *1 374.05,328.68 sg13_hv_nmos
M$91 35 45 53 1 sg13_hv_nmos L=1U W=10U AS=3.4P AD=3.4P PS=20.68U PD=20.68U
+ rfmode=0
* device instance $92 r0 *1 380.27,343.72 sg13_hv_nmos
M$92 46 45 40 1 sg13_hv_nmos L=1U W=10U AS=3.4P AD=3.4P PS=20.68U PD=20.68U
+ rfmode=0
* device instance $93 r0 *1 380.27,328.68 sg13_hv_nmos
M$93 35 45 53 1 sg13_hv_nmos L=1U W=10U AS=3.4P AD=3.4P PS=20.68U PD=20.68U
+ rfmode=0
* device instance $94 r0 *1 386.49,343.72 sg13_hv_nmos
M$94 46 45 40 1 sg13_hv_nmos L=1U W=10U AS=3.4P AD=3.4P PS=20.68U PD=20.68U
+ rfmode=0
* device instance $95 r0 *1 386.49,328.68 sg13_hv_nmos
M$95 35 45 53 1 sg13_hv_nmos L=1U W=10U AS=3.4P AD=3.4P PS=20.68U PD=20.68U
+ rfmode=0
* device instance $96 r0 *1 392.71,328.68 sg13_hv_nmos
M$96 40 45 46 1 sg13_hv_nmos L=1U W=10U AS=3.4P AD=3.4P PS=20.68U PD=20.68U
+ rfmode=0
* device instance $97 r0 *1 392.71,343.72 sg13_hv_nmos
M$97 46 45 40 1 sg13_hv_nmos L=1U W=10U AS=3.4P AD=3.4P PS=20.68U PD=20.68U
+ rfmode=0
* device instance $98 r0 *1 398.93,328.68 sg13_hv_nmos
M$98 40 45 46 1 sg13_hv_nmos L=1U W=10U AS=3.4P AD=3.4P PS=20.68U PD=20.68U
+ rfmode=0
* device instance $99 r0 *1 398.93,343.72 sg13_hv_nmos
M$99 46 45 40 1 sg13_hv_nmos L=1U W=10U AS=3.4P AD=3.4P PS=20.68U PD=20.68U
+ rfmode=0
* device instance $100 r0 *1 405.15,343.72 sg13_hv_nmos
M$100 46 45 40 1 sg13_hv_nmos L=1U W=10U AS=3.4P AD=3.4P PS=20.68U PD=20.68U
+ rfmode=0
* device instance $101 r0 *1 405.15,328.68 sg13_hv_nmos
M$101 40 45 46 1 sg13_hv_nmos L=1U W=10U AS=3.4P AD=3.4P PS=20.68U PD=20.68U
+ rfmode=0
* device instance $102 r0 *1 206.96,147.62 sg13_hv_pmos
M$102 45 35 44 44 sg13_hv_pmos L=4U W=10U AS=3.4P AD=3.4P PS=20.68U PD=20.68U
+ rfmode=0
* device instance $103 r0 *1 216.88,147.62 sg13_hv_pmos
M$103 45 35 44 44 sg13_hv_pmos L=4U W=10U AS=3.4P AD=3.4P PS=20.68U PD=20.68U
+ rfmode=0
* device instance $104 r0 *1 226.8,147.62 sg13_hv_pmos
M$104 45 35 44 44 sg13_hv_pmos L=4U W=10U AS=3.4P AD=3.4P PS=20.68U PD=20.68U
+ rfmode=0
* device instance $105 r0 *1 236.72,147.62 sg13_hv_pmos
M$105 45 35 44 44 sg13_hv_pmos L=4U W=10U AS=3.4P AD=3.4P PS=20.68U PD=20.68U
+ rfmode=0
* device instance $106 r0 *1 246.64,147.62 sg13_hv_pmos
M$106 45 35 44 44 sg13_hv_pmos L=4U W=10U AS=3.4P AD=3.4P PS=20.68U PD=20.68U
+ rfmode=0
* device instance $107 r0 *1 256.56,147.62 sg13_hv_pmos
M$107 45 35 44 44 sg13_hv_pmos L=4U W=10U AS=3.4P AD=3.4P PS=20.68U PD=20.68U
+ rfmode=0
* device instance $108 r0 *1 266.48,147.62 sg13_hv_pmos
M$108 45 35 44 44 sg13_hv_pmos L=4U W=10U AS=3.4P AD=3.4P PS=20.68U PD=20.68U
+ rfmode=0
* device instance $109 r0 *1 276.4,147.62 sg13_hv_pmos
M$109 45 35 44 44 sg13_hv_pmos L=4U W=10U AS=3.4P AD=3.4P PS=20.68U PD=20.68U
+ rfmode=0
* device instance $110 r0 *1 286.32,147.62 sg13_hv_pmos
M$110 45 35 44 44 sg13_hv_pmos L=4U W=10U AS=3.4P AD=3.4P PS=20.68U PD=20.68U
+ rfmode=0
* device instance $111 r0 *1 296.24,147.62 sg13_hv_pmos
M$111 45 35 44 44 sg13_hv_pmos L=4U W=10U AS=3.4P AD=3.4P PS=20.68U PD=20.68U
+ rfmode=0
* device instance $112 r0 *1 306.16,147.62 sg13_hv_pmos
M$112 45 35 44 44 sg13_hv_pmos L=4U W=10U AS=3.4P AD=3.4P PS=20.68U PD=20.68U
+ rfmode=0
* device instance $113 r0 *1 316.08,147.62 sg13_hv_pmos
M$113 45 35 44 44 sg13_hv_pmos L=4U W=10U AS=3.4P AD=3.4P PS=20.68U PD=20.68U
+ rfmode=0
* device instance $114 r0 *1 326,147.62 sg13_hv_pmos
M$114 46 35 42 42 sg13_hv_pmos L=4U W=10U AS=3.4P AD=3.4P PS=20.68U PD=20.68U
+ rfmode=0
* device instance $115 r0 *1 335.92,147.62 sg13_hv_pmos
M$115 46 35 42 42 sg13_hv_pmos L=4U W=10U AS=3.4P AD=3.4P PS=20.68U PD=20.68U
+ rfmode=0
* device instance $116 r0 *1 345.84,147.62 sg13_hv_pmos
M$116 46 35 42 42 sg13_hv_pmos L=4U W=10U AS=3.4P AD=3.4P PS=20.68U PD=20.68U
+ rfmode=0
* device instance $117 r0 *1 355.76,147.62 sg13_hv_pmos
M$117 46 35 42 42 sg13_hv_pmos L=4U W=10U AS=3.4P AD=3.4P PS=20.68U PD=20.68U
+ rfmode=0
* device instance $118 r0 *1 365.68,147.62 sg13_hv_pmos
M$118 46 35 42 42 sg13_hv_pmos L=4U W=10U AS=3.4P AD=3.4P PS=20.68U PD=20.68U
+ rfmode=0
* device instance $119 r0 *1 375.6,147.62 sg13_hv_pmos
M$119 46 35 42 42 sg13_hv_pmos L=4U W=10U AS=3.4P AD=3.4P PS=20.68U PD=20.68U
+ rfmode=0
* device instance $120 r0 *1 385.52,147.62 sg13_hv_pmos
M$120 46 35 42 42 sg13_hv_pmos L=4U W=10U AS=3.4P AD=3.4P PS=20.68U PD=20.68U
+ rfmode=0
* device instance $121 r0 *1 395.44,147.62 sg13_hv_pmos
M$121 46 35 42 42 sg13_hv_pmos L=4U W=10U AS=3.4P AD=3.4P PS=20.68U PD=20.68U
+ rfmode=0
* device instance $122 r0 *1 405.36,147.62 sg13_hv_pmos
M$122 46 35 42 42 sg13_hv_pmos L=4U W=10U AS=3.4P AD=3.4P PS=20.68U PD=20.68U
+ rfmode=0
* device instance $123 r0 *1 206.96,162.86 sg13_hv_pmos
M$123 46 35 42 42 sg13_hv_pmos L=4U W=10U AS=3.4P AD=3.4P PS=20.68U PD=20.68U
+ rfmode=0
* device instance $124 r0 *1 216.88,162.86 sg13_hv_pmos
M$124 46 35 42 42 sg13_hv_pmos L=4U W=10U AS=3.4P AD=3.4P PS=20.68U PD=20.68U
+ rfmode=0
* device instance $125 r0 *1 226.8,162.86 sg13_hv_pmos
M$125 46 35 42 42 sg13_hv_pmos L=4U W=10U AS=3.4P AD=3.4P PS=20.68U PD=20.68U
+ rfmode=0
* device instance $126 r0 *1 236.72,162.86 sg13_hv_pmos
M$126 36 35 49 49 sg13_hv_pmos L=4U W=10U AS=3.4P AD=3.4P PS=20.68U PD=20.68U
+ rfmode=0
* device instance $127 r0 *1 246.64,193.34 sg13_hv_pmos
M$127 38 35 50 50 sg13_hv_pmos L=4U W=10U AS=3.4P AD=3.4P PS=20.68U PD=20.68U
+ rfmode=0
* device instance $128 r0 *1 246.64,162.86 sg13_hv_pmos
M$128 36 35 49 49 sg13_hv_pmos L=4U W=10U AS=3.4P AD=3.4P PS=20.68U PD=20.68U
+ rfmode=0
* device instance $129 r0 *1 256.56,162.86 sg13_hv_pmos
M$129 36 35 49 49 sg13_hv_pmos L=4U W=10U AS=3.4P AD=3.4P PS=20.68U PD=20.68U
+ rfmode=0
* device instance $130 r0 *1 256.56,193.34 sg13_hv_pmos
M$130 38 35 50 50 sg13_hv_pmos L=4U W=10U AS=3.4P AD=3.4P PS=20.68U PD=20.68U
+ rfmode=0
* device instance $131 r0 *1 266.48,162.86 sg13_hv_pmos
M$131 36 35 49 49 sg13_hv_pmos L=4U W=10U AS=3.4P AD=3.4P PS=20.68U PD=20.68U
+ rfmode=0
* device instance $132 r0 *1 266.48,193.34 sg13_hv_pmos
M$132 36 35 49 49 sg13_hv_pmos L=4U W=10U AS=3.4P AD=3.4P PS=20.68U PD=20.68U
+ rfmode=0
* device instance $133 r0 *1 276.4,193.34 sg13_hv_pmos
M$133 36 35 49 49 sg13_hv_pmos L=4U W=10U AS=3.4P AD=3.4P PS=20.68U PD=20.68U
+ rfmode=0
* device instance $134 r0 *1 276.4,162.86 sg13_hv_pmos
M$134 36 35 49 49 sg13_hv_pmos L=4U W=10U AS=3.4P AD=3.4P PS=20.68U PD=20.68U
+ rfmode=0
* device instance $135 r0 *1 286.32,162.86 sg13_hv_pmos
M$135 36 35 49 49 sg13_hv_pmos L=4U W=10U AS=3.4P AD=3.4P PS=20.68U PD=20.68U
+ rfmode=0
* device instance $136 r0 *1 286.32,193.34 sg13_hv_pmos
M$136 36 35 49 49 sg13_hv_pmos L=4U W=10U AS=3.4P AD=3.4P PS=20.68U PD=20.68U
+ rfmode=0
* device instance $137 r0 *1 296.24,162.86 sg13_hv_pmos
M$137 36 35 49 49 sg13_hv_pmos L=4U W=10U AS=3.4P AD=3.4P PS=20.68U PD=20.68U
+ rfmode=0
* device instance $138 r0 *1 296.24,193.34 sg13_hv_pmos
M$138 36 35 49 49 sg13_hv_pmos L=4U W=10U AS=3.4P AD=3.4P PS=20.68U PD=20.68U
+ rfmode=0
* device instance $139 r0 *1 306.16,193.34 sg13_hv_pmos
M$139 36 35 49 49 sg13_hv_pmos L=4U W=10U AS=3.4P AD=3.4P PS=20.68U PD=20.68U
+ rfmode=0
* device instance $140 r0 *1 306.16,162.86 sg13_hv_pmos
M$140 36 35 49 49 sg13_hv_pmos L=4U W=10U AS=3.4P AD=3.4P PS=20.68U PD=20.68U
+ rfmode=0
* device instance $141 r0 *1 316.08,162.86 sg13_hv_pmos
M$141 36 35 49 49 sg13_hv_pmos L=4U W=10U AS=3.4P AD=3.4P PS=20.68U PD=20.68U
+ rfmode=0
* device instance $142 r0 *1 316.08,193.34 sg13_hv_pmos
M$142 36 35 49 49 sg13_hv_pmos L=4U W=10U AS=3.4P AD=3.4P PS=20.68U PD=20.68U
+ rfmode=0
* device instance $143 r0 *1 326,162.86 sg13_hv_pmos
M$143 36 35 49 49 sg13_hv_pmos L=4U W=10U AS=3.4P AD=3.4P PS=20.68U PD=20.68U
+ rfmode=0
* device instance $144 r0 *1 326,193.34 sg13_hv_pmos
M$144 36 35 49 49 sg13_hv_pmos L=4U W=10U AS=3.4P AD=3.4P PS=20.68U PD=20.68U
+ rfmode=0
* device instance $145 r0 *1 335.92,193.34 sg13_hv_pmos
M$145 36 35 49 49 sg13_hv_pmos L=4U W=10U AS=3.4P AD=3.4P PS=20.68U PD=20.68U
+ rfmode=0
* device instance $146 r0 *1 335.92,162.86 sg13_hv_pmos
M$146 36 35 49 49 sg13_hv_pmos L=4U W=10U AS=3.4P AD=3.4P PS=20.68U PD=20.68U
+ rfmode=0
* device instance $147 r0 *1 345.84,193.34 sg13_hv_pmos
M$147 36 35 49 49 sg13_hv_pmos L=4U W=10U AS=3.4P AD=3.4P PS=20.68U PD=20.68U
+ rfmode=0
* device instance $148 r0 *1 345.84,162.86 sg13_hv_pmos
M$148 36 35 49 49 sg13_hv_pmos L=4U W=10U AS=3.4P AD=3.4P PS=20.68U PD=20.68U
+ rfmode=0
* device instance $149 r0 *1 355.76,193.34 sg13_hv_pmos
M$149 36 35 49 49 sg13_hv_pmos L=4U W=10U AS=3.4P AD=3.4P PS=20.68U PD=20.68U
+ rfmode=0
* device instance $150 r0 *1 355.76,162.86 sg13_hv_pmos
M$150 38 35 50 50 sg13_hv_pmos L=4U W=10U AS=3.4P AD=3.4P PS=20.68U PD=20.68U
+ rfmode=0
* device instance $151 r0 *1 365.68,162.86 sg13_hv_pmos
M$151 38 35 50 50 sg13_hv_pmos L=4U W=10U AS=3.4P AD=3.4P PS=20.68U PD=20.68U
+ rfmode=0
* device instance $152 r0 *1 365.68,193.34 sg13_hv_pmos
M$152 36 35 49 49 sg13_hv_pmos L=4U W=10U AS=3.4P AD=3.4P PS=20.68U PD=20.68U
+ rfmode=0
* device instance $153 r0 *1 375.6,162.86 sg13_hv_pmos
M$153 48 35 51 51 sg13_hv_pmos L=4U W=10U AS=3.4P AD=3.4P PS=20.68U PD=20.68U
+ rfmode=0
* device instance $154 r0 *1 375.6,193.34 sg13_hv_pmos
M$154 36 35 49 49 sg13_hv_pmos L=4U W=10U AS=3.4P AD=3.4P PS=20.68U PD=20.68U
+ rfmode=0
* device instance $155 r0 *1 385.52,193.34 sg13_hv_pmos
M$155 46 35 42 42 sg13_hv_pmos L=4U W=10U AS=3.4P AD=3.4P PS=20.68U PD=20.68U
+ rfmode=0
* device instance $156 r0 *1 385.52,162.86 sg13_hv_pmos
M$156 54 8 52 52 sg13_hv_pmos L=0.5U W=2U AS=0.68P AD=0.68P PS=4.68U PD=4.68U
+ rfmode=0
* device instance $157 r0 *1 395.44,193.34 sg13_hv_pmos
M$157 46 35 42 42 sg13_hv_pmos L=4U W=10U AS=3.4P AD=3.4P PS=20.68U PD=20.68U
+ rfmode=0
* device instance $158 r0 *1 395.44,162.86 sg13_hv_pmos
M$158 55 43 52 52 sg13_hv_pmos L=0.5U W=2U AS=0.68P AD=0.68P PS=4.68U PD=4.68U
+ rfmode=0
* device instance $159 r0 *1 405.36,193.34 sg13_hv_pmos
M$159 46 35 42 42 sg13_hv_pmos L=4U W=10U AS=3.4P AD=3.4P PS=20.68U PD=20.68U
+ rfmode=0
* device instance $160 r0 *1 206.96,208.58 sg13_hv_pmos
M$160 46 35 42 42 sg13_hv_pmos L=4U W=10U AS=3.4P AD=3.4P PS=20.68U PD=20.68U
+ rfmode=0
* device instance $161 r0 *1 216.88,208.58 sg13_hv_pmos
M$161 46 35 42 42 sg13_hv_pmos L=4U W=10U AS=3.4P AD=3.4P PS=20.68U PD=20.68U
+ rfmode=0
* device instance $162 r0 *1 226.8,208.58 sg13_hv_pmos
M$162 46 35 42 42 sg13_hv_pmos L=4U W=10U AS=3.4P AD=3.4P PS=20.68U PD=20.68U
+ rfmode=0
* device instance $163 r0 *1 236.72,208.58 sg13_hv_pmos
M$163 46 35 42 42 sg13_hv_pmos L=4U W=10U AS=3.4P AD=3.4P PS=20.68U PD=20.68U
+ rfmode=0
* device instance $164 r0 *1 246.64,208.58 sg13_hv_pmos
M$164 46 35 42 42 sg13_hv_pmos L=4U W=10U AS=3.4P AD=3.4P PS=20.68U PD=20.68U
+ rfmode=0
* device instance $165 r0 *1 256.56,208.58 sg13_hv_pmos
M$165 46 35 42 42 sg13_hv_pmos L=4U W=10U AS=3.4P AD=3.4P PS=20.68U PD=20.68U
+ rfmode=0
* device instance $166 r0 *1 266.48,208.58 sg13_hv_pmos
M$166 46 35 42 42 sg13_hv_pmos L=4U W=10U AS=3.4P AD=3.4P PS=20.68U PD=20.68U
+ rfmode=0
* device instance $167 r0 *1 276.4,208.58 sg13_hv_pmos
M$167 46 35 42 42 sg13_hv_pmos L=4U W=10U AS=3.4P AD=3.4P PS=20.68U PD=20.68U
+ rfmode=0
* device instance $168 r0 *1 286.32,208.58 sg13_hv_pmos
M$168 46 35 42 42 sg13_hv_pmos L=4U W=10U AS=3.4P AD=3.4P PS=20.68U PD=20.68U
+ rfmode=0
* device instance $169 r0 *1 296.24,208.58 sg13_hv_pmos
M$169 45 35 44 44 sg13_hv_pmos L=4U W=10U AS=3.4P AD=3.4P PS=20.68U PD=20.68U
+ rfmode=0
* device instance $170 r0 *1 306.16,208.58 sg13_hv_pmos
M$170 45 35 44 44 sg13_hv_pmos L=4U W=10U AS=3.4P AD=3.4P PS=20.68U PD=20.68U
+ rfmode=0
* device instance $171 r0 *1 316.08,208.58 sg13_hv_pmos
M$171 45 35 44 44 sg13_hv_pmos L=4U W=10U AS=3.4P AD=3.4P PS=20.68U PD=20.68U
+ rfmode=0
* device instance $172 r0 *1 326,208.58 sg13_hv_pmos
M$172 45 35 44 44 sg13_hv_pmos L=4U W=10U AS=3.4P AD=3.4P PS=20.68U PD=20.68U
+ rfmode=0
* device instance $173 r0 *1 335.92,208.58 sg13_hv_pmos
M$173 45 35 44 44 sg13_hv_pmos L=4U W=10U AS=3.4P AD=3.4P PS=20.68U PD=20.68U
+ rfmode=0
* device instance $174 r0 *1 345.84,208.58 sg13_hv_pmos
M$174 45 35 44 44 sg13_hv_pmos L=4U W=10U AS=3.4P AD=3.4P PS=20.68U PD=20.68U
+ rfmode=0
* device instance $175 r0 *1 355.76,208.58 sg13_hv_pmos
M$175 45 35 44 44 sg13_hv_pmos L=4U W=10U AS=3.4P AD=3.4P PS=20.68U PD=20.68U
+ rfmode=0
* device instance $176 r0 *1 365.68,208.58 sg13_hv_pmos
M$176 45 35 44 44 sg13_hv_pmos L=4U W=10U AS=3.4P AD=3.4P PS=20.68U PD=20.68U
+ rfmode=0
* device instance $177 r0 *1 375.6,208.58 sg13_hv_pmos
M$177 45 35 44 44 sg13_hv_pmos L=4U W=10U AS=3.4P AD=3.4P PS=20.68U PD=20.68U
+ rfmode=0
* device instance $178 r0 *1 385.52,208.58 sg13_hv_pmos
M$178 45 35 44 44 sg13_hv_pmos L=4U W=10U AS=3.4P AD=3.4P PS=20.68U PD=20.68U
+ rfmode=0
* device instance $179 r0 *1 395.44,208.58 sg13_hv_pmos
M$179 45 35 44 44 sg13_hv_pmos L=4U W=10U AS=3.4P AD=3.4P PS=20.68U PD=20.68U
+ rfmode=0
* device instance $180 r0 *1 405.36,208.58 sg13_hv_pmos
M$180 45 35 44 44 sg13_hv_pmos L=4U W=10U AS=3.4P AD=3.4P PS=20.68U PD=20.68U
+ rfmode=0
* device instance $181 r0 *1 211.96,235.56 sg13_hv_pmos
M$181 49 36 52 52 sg13_hv_pmos L=4U W=5U AS=1.7P AD=1.7P PS=10.68U PD=10.68U
+ rfmode=0
* device instance $182 r0 *1 211.96,225.32 sg13_hv_pmos
M$182 42 36 52 52 sg13_hv_pmos L=4U W=5U AS=1.7P AD=1.7P PS=10.68U PD=10.68U
+ rfmode=0
* device instance $183 r0 *1 221.88,235.56 sg13_hv_pmos
M$183 49 36 52 52 sg13_hv_pmos L=4U W=5U AS=1.7P AD=1.7P PS=10.68U PD=10.68U
+ rfmode=0
* device instance $184 r0 *1 221.88,225.32 sg13_hv_pmos
M$184 42 36 52 52 sg13_hv_pmos L=4U W=5U AS=1.7P AD=1.7P PS=10.68U PD=10.68U
+ rfmode=0
* device instance $185 r0 *1 231.8,225.32 sg13_hv_pmos
M$185 42 36 52 52 sg13_hv_pmos L=4U W=5U AS=1.7P AD=1.7P PS=10.68U PD=10.68U
+ rfmode=0
* device instance $186 r0 *1 231.8,235.56 sg13_hv_pmos
M$186 49 36 52 52 sg13_hv_pmos L=4U W=5U AS=1.7P AD=1.7P PS=10.68U PD=10.68U
+ rfmode=0
* device instance $187 r0 *1 241.72,235.56 sg13_hv_pmos
M$187 49 36 52 52 sg13_hv_pmos L=4U W=5U AS=1.7P AD=1.7P PS=10.68U PD=10.68U
+ rfmode=0
* device instance $188 r0 *1 241.72,225.32 sg13_hv_pmos
M$188 42 36 52 52 sg13_hv_pmos L=4U W=5U AS=1.7P AD=1.7P PS=10.68U PD=10.68U
+ rfmode=0
* device instance $189 r0 *1 251.64,235.56 sg13_hv_pmos
M$189 44 36 52 52 sg13_hv_pmos L=4U W=5U AS=1.7P AD=1.7P PS=10.68U PD=10.68U
+ rfmode=0
* device instance $190 r0 *1 251.64,225.32 sg13_hv_pmos
M$190 42 36 52 52 sg13_hv_pmos L=4U W=5U AS=1.7P AD=1.7P PS=10.68U PD=10.68U
+ rfmode=0
* device instance $191 r0 *1 261.56,225.32 sg13_hv_pmos
M$191 42 36 52 52 sg13_hv_pmos L=4U W=5U AS=1.7P AD=1.7P PS=10.68U PD=10.68U
+ rfmode=0
* device instance $192 r0 *1 261.56,235.56 sg13_hv_pmos
M$192 44 36 52 52 sg13_hv_pmos L=4U W=5U AS=1.7P AD=1.7P PS=10.68U PD=10.68U
+ rfmode=0
* device instance $193 r0 *1 271.48,225.32 sg13_hv_pmos
M$193 42 36 52 52 sg13_hv_pmos L=4U W=5U AS=1.7P AD=1.7P PS=10.68U PD=10.68U
+ rfmode=0
* device instance $194 r0 *1 271.48,235.56 sg13_hv_pmos
M$194 44 36 52 52 sg13_hv_pmos L=4U W=5U AS=1.7P AD=1.7P PS=10.68U PD=10.68U
+ rfmode=0
* device instance $195 r0 *1 281.4,235.56 sg13_hv_pmos
M$195 44 36 52 52 sg13_hv_pmos L=4U W=5U AS=1.7P AD=1.7P PS=10.68U PD=10.68U
+ rfmode=0
* device instance $196 r0 *1 281.4,225.32 sg13_hv_pmos
M$196 42 36 52 52 sg13_hv_pmos L=4U W=5U AS=1.7P AD=1.7P PS=10.68U PD=10.68U
+ rfmode=0
* device instance $197 r0 *1 291.32,225.32 sg13_hv_pmos
M$197 42 36 52 52 sg13_hv_pmos L=4U W=5U AS=1.7P AD=1.7P PS=10.68U PD=10.68U
+ rfmode=0
* device instance $198 r0 *1 291.32,235.56 sg13_hv_pmos
M$198 44 36 52 52 sg13_hv_pmos L=4U W=5U AS=1.7P AD=1.7P PS=10.68U PD=10.68U
+ rfmode=0
* device instance $199 r0 *1 301.24,235.56 sg13_hv_pmos
M$199 44 36 52 52 sg13_hv_pmos L=4U W=5U AS=1.7P AD=1.7P PS=10.68U PD=10.68U
+ rfmode=0
* device instance $200 r0 *1 301.24,225.32 sg13_hv_pmos
M$200 42 36 52 52 sg13_hv_pmos L=4U W=5U AS=1.7P AD=1.7P PS=10.68U PD=10.68U
+ rfmode=0
* device instance $201 r0 *1 311.16,235.56 sg13_hv_pmos
M$201 44 36 52 52 sg13_hv_pmos L=4U W=5U AS=1.7P AD=1.7P PS=10.68U PD=10.68U
+ rfmode=0
* device instance $202 r0 *1 311.16,225.32 sg13_hv_pmos
M$202 42 36 52 52 sg13_hv_pmos L=4U W=5U AS=1.7P AD=1.7P PS=10.68U PD=10.68U
+ rfmode=0
* device instance $203 r0 *1 321.08,225.32 sg13_hv_pmos
M$203 42 36 52 52 sg13_hv_pmos L=4U W=5U AS=1.7P AD=1.7P PS=10.68U PD=10.68U
+ rfmode=0
* device instance $204 r0 *1 321.08,235.56 sg13_hv_pmos
M$204 44 36 52 52 sg13_hv_pmos L=4U W=5U AS=1.7P AD=1.7P PS=10.68U PD=10.68U
+ rfmode=0
* device instance $205 r0 *1 331,235.56 sg13_hv_pmos
M$205 44 36 52 52 sg13_hv_pmos L=4U W=5U AS=1.7P AD=1.7P PS=10.68U PD=10.68U
+ rfmode=0
* device instance $206 r0 *1 331,225.32 sg13_hv_pmos
M$206 49 36 52 52 sg13_hv_pmos L=4U W=5U AS=1.7P AD=1.7P PS=10.68U PD=10.68U
+ rfmode=0
* device instance $207 r0 *1 340.92,225.32 sg13_hv_pmos
M$207 49 36 52 52 sg13_hv_pmos L=4U W=5U AS=1.7P AD=1.7P PS=10.68U PD=10.68U
+ rfmode=0
* device instance $208 r0 *1 340.92,235.56 sg13_hv_pmos
M$208 44 36 52 52 sg13_hv_pmos L=4U W=5U AS=1.7P AD=1.7P PS=10.68U PD=10.68U
+ rfmode=0
* device instance $209 r0 *1 350.84,225.32 sg13_hv_pmos
M$209 49 36 52 52 sg13_hv_pmos L=4U W=5U AS=1.7P AD=1.7P PS=10.68U PD=10.68U
+ rfmode=0
* device instance $210 r0 *1 350.84,235.56 sg13_hv_pmos
M$210 44 36 52 52 sg13_hv_pmos L=4U W=5U AS=1.7P AD=1.7P PS=10.68U PD=10.68U
+ rfmode=0
* device instance $211 r0 *1 360.76,225.32 sg13_hv_pmos
M$211 49 36 52 52 sg13_hv_pmos L=4U W=5U AS=1.7P AD=1.7P PS=10.68U PD=10.68U
+ rfmode=0
* device instance $212 r0 *1 360.76,235.56 sg13_hv_pmos
M$212 44 36 52 52 sg13_hv_pmos L=4U W=5U AS=1.7P AD=1.7P PS=10.68U PD=10.68U
+ rfmode=0
* device instance $213 r0 *1 370.68,225.32 sg13_hv_pmos
M$213 49 36 52 52 sg13_hv_pmos L=4U W=5U AS=1.7P AD=1.7P PS=10.68U PD=10.68U
+ rfmode=0
* device instance $214 r0 *1 370.68,235.56 sg13_hv_pmos
M$214 44 36 52 52 sg13_hv_pmos L=4U W=5U AS=1.7P AD=1.7P PS=10.68U PD=10.68U
+ rfmode=0
* device instance $215 r0 *1 380.6,225.32 sg13_hv_pmos
M$215 49 36 52 52 sg13_hv_pmos L=4U W=5U AS=1.7P AD=1.7P PS=10.68U PD=10.68U
+ rfmode=0
* device instance $216 r0 *1 380.6,235.56 sg13_hv_pmos
M$216 44 36 52 52 sg13_hv_pmos L=4U W=5U AS=1.7P AD=1.7P PS=10.68U PD=10.68U
+ rfmode=0
* device instance $217 r0 *1 390.52,225.32 sg13_hv_pmos
M$217 49 36 52 52 sg13_hv_pmos L=4U W=5U AS=1.7P AD=1.7P PS=10.68U PD=10.68U
+ rfmode=0
* device instance $218 r0 *1 390.52,235.56 sg13_hv_pmos
M$218 44 36 52 52 sg13_hv_pmos L=4U W=5U AS=1.7P AD=1.7P PS=10.68U PD=10.68U
+ rfmode=0
* device instance $219 r0 *1 400.44,225.32 sg13_hv_pmos
M$219 49 36 52 52 sg13_hv_pmos L=4U W=5U AS=1.7P AD=1.7P PS=10.68U PD=10.68U
+ rfmode=0
* device instance $220 r0 *1 400.44,235.56 sg13_hv_pmos
M$220 44 36 52 52 sg13_hv_pmos L=4U W=5U AS=1.7P AD=1.7P PS=10.68U PD=10.68U
+ rfmode=0
* device instance $221 r0 *1 211.96,245.8 sg13_hv_pmos
M$221 44 36 52 52 sg13_hv_pmos L=4U W=5U AS=1.7P AD=1.7P PS=10.68U PD=10.68U
+ rfmode=0
* device instance $222 r0 *1 221.88,245.8 sg13_hv_pmos
M$222 44 36 52 52 sg13_hv_pmos L=4U W=5U AS=1.7P AD=1.7P PS=10.68U PD=10.68U
+ rfmode=0
* device instance $223 r0 *1 231.8,245.8 sg13_hv_pmos
M$223 44 36 52 52 sg13_hv_pmos L=4U W=5U AS=1.7P AD=1.7P PS=10.68U PD=10.68U
+ rfmode=0
* device instance $224 r0 *1 241.72,245.8 sg13_hv_pmos
M$224 44 36 52 52 sg13_hv_pmos L=4U W=5U AS=1.7P AD=1.7P PS=10.68U PD=10.68U
+ rfmode=0
* device instance $225 r0 *1 251.64,245.8 sg13_hv_pmos
M$225 44 36 52 52 sg13_hv_pmos L=4U W=5U AS=1.7P AD=1.7P PS=10.68U PD=10.68U
+ rfmode=0
* device instance $226 r0 *1 261.56,245.8 sg13_hv_pmos
M$226 44 36 52 52 sg13_hv_pmos L=4U W=5U AS=1.7P AD=1.7P PS=10.68U PD=10.68U
+ rfmode=0
* device instance $227 r0 *1 271.48,245.8 sg13_hv_pmos
M$227 44 36 52 52 sg13_hv_pmos L=4U W=5U AS=1.7P AD=1.7P PS=10.68U PD=10.68U
+ rfmode=0
* device instance $228 r0 *1 281.4,245.8 sg13_hv_pmos
M$228 44 36 52 52 sg13_hv_pmos L=4U W=5U AS=1.7P AD=1.7P PS=10.68U PD=10.68U
+ rfmode=0
* device instance $229 r0 *1 291.32,245.8 sg13_hv_pmos
M$229 49 36 52 52 sg13_hv_pmos L=4U W=5U AS=1.7P AD=1.7P PS=10.68U PD=10.68U
+ rfmode=0
* device instance $230 r0 *1 301.24,245.8 sg13_hv_pmos
M$230 49 36 52 52 sg13_hv_pmos L=4U W=5U AS=1.7P AD=1.7P PS=10.68U PD=10.68U
+ rfmode=0
* device instance $231 r0 *1 311.16,245.8 sg13_hv_pmos
M$231 49 36 52 52 sg13_hv_pmos L=4U W=5U AS=1.7P AD=1.7P PS=10.68U PD=10.68U
+ rfmode=0
* device instance $232 r0 *1 321.08,245.8 sg13_hv_pmos
M$232 49 36 52 52 sg13_hv_pmos L=4U W=5U AS=1.7P AD=1.7P PS=10.68U PD=10.68U
+ rfmode=0
* device instance $233 r0 *1 331,245.8 sg13_hv_pmos
M$233 49 36 52 52 sg13_hv_pmos L=4U W=5U AS=1.7P AD=1.7P PS=10.68U PD=10.68U
+ rfmode=0
* device instance $234 r0 *1 340.92,245.8 sg13_hv_pmos
M$234 49 36 52 52 sg13_hv_pmos L=4U W=5U AS=1.7P AD=1.7P PS=10.68U PD=10.68U
+ rfmode=0
* device instance $235 r0 *1 350.84,245.8 sg13_hv_pmos
M$235 49 36 52 52 sg13_hv_pmos L=4U W=5U AS=1.7P AD=1.7P PS=10.68U PD=10.68U
+ rfmode=0
* device instance $236 r0 *1 360.76,245.8 sg13_hv_pmos
M$236 49 36 52 52 sg13_hv_pmos L=4U W=5U AS=1.7P AD=1.7P PS=10.68U PD=10.68U
+ rfmode=0
* device instance $237 r0 *1 370.68,245.8 sg13_hv_pmos
M$237 49 36 52 52 sg13_hv_pmos L=4U W=5U AS=1.7P AD=1.7P PS=10.68U PD=10.68U
+ rfmode=0
* device instance $238 r0 *1 380.6,245.8 sg13_hv_pmos
M$238 49 36 52 52 sg13_hv_pmos L=4U W=5U AS=1.7P AD=1.7P PS=10.68U PD=10.68U
+ rfmode=0
* device instance $239 r0 *1 390.52,245.8 sg13_hv_pmos
M$239 49 36 52 52 sg13_hv_pmos L=4U W=5U AS=1.7P AD=1.7P PS=10.68U PD=10.68U
+ rfmode=0
* device instance $240 r0 *1 400.44,245.8 sg13_hv_pmos
M$240 49 36 52 52 sg13_hv_pmos L=4U W=5U AS=1.7P AD=1.7P PS=10.68U PD=10.68U
+ rfmode=0
* device instance $241 r0 *1 211.96,256.04 sg13_hv_pmos
M$241 42 36 52 52 sg13_hv_pmos L=4U W=5U AS=1.7P AD=1.7P PS=10.68U PD=10.68U
+ rfmode=0
* device instance $242 r0 *1 221.88,256.04 sg13_hv_pmos
M$242 42 36 52 52 sg13_hv_pmos L=4U W=5U AS=1.7P AD=1.7P PS=10.68U PD=10.68U
+ rfmode=0
* device instance $243 r0 *1 231.8,256.04 sg13_hv_pmos
M$243 42 36 52 52 sg13_hv_pmos L=4U W=5U AS=1.7P AD=1.7P PS=10.68U PD=10.68U
+ rfmode=0
* device instance $244 r0 *1 241.72,256.04 sg13_hv_pmos
M$244 42 36 52 52 sg13_hv_pmos L=4U W=5U AS=1.7P AD=1.7P PS=10.68U PD=10.68U
+ rfmode=0
* device instance $245 r0 *1 251.64,256.04 sg13_hv_pmos
M$245 42 36 52 52 sg13_hv_pmos L=4U W=5U AS=1.7P AD=1.7P PS=10.68U PD=10.68U
+ rfmode=0
* device instance $246 r0 *1 261.56,256.04 sg13_hv_pmos
M$246 42 36 52 52 sg13_hv_pmos L=4U W=5U AS=1.7P AD=1.7P PS=10.68U PD=10.68U
+ rfmode=0
* device instance $247 r0 *1 271.48,256.04 sg13_hv_pmos
M$247 42 36 52 52 sg13_hv_pmos L=4U W=5U AS=1.7P AD=1.7P PS=10.68U PD=10.68U
+ rfmode=0
* device instance $248 r0 *1 281.4,256.04 sg13_hv_pmos
M$248 42 36 52 52 sg13_hv_pmos L=4U W=5U AS=1.7P AD=1.7P PS=10.68U PD=10.68U
+ rfmode=0
* device instance $249 r0 *1 291.32,256.04 sg13_hv_pmos
M$249 42 36 52 52 sg13_hv_pmos L=4U W=5U AS=1.7P AD=1.7P PS=10.68U PD=10.68U
+ rfmode=0
* device instance $250 r0 *1 301.24,256.04 sg13_hv_pmos
M$250 42 36 52 52 sg13_hv_pmos L=4U W=5U AS=1.7P AD=1.7P PS=10.68U PD=10.68U
+ rfmode=0
* device instance $251 r0 *1 311.16,256.04 sg13_hv_pmos
M$251 42 36 52 52 sg13_hv_pmos L=4U W=5U AS=1.7P AD=1.7P PS=10.68U PD=10.68U
+ rfmode=0
* device instance $252 r0 *1 321.08,256.04 sg13_hv_pmos
M$252 42 36 52 52 sg13_hv_pmos L=4U W=5U AS=1.7P AD=1.7P PS=10.68U PD=10.68U
+ rfmode=0
* device instance $253 r0 *1 331,256.04 sg13_hv_pmos
M$253 50 36 52 52 sg13_hv_pmos L=4U W=5U AS=1.7P AD=1.7P PS=10.68U PD=10.68U
+ rfmode=0
* device instance $254 r0 *1 340.92,256.04 sg13_hv_pmos
M$254 50 36 52 52 sg13_hv_pmos L=4U W=5U AS=1.7P AD=1.7P PS=10.68U PD=10.68U
+ rfmode=0
* device instance $255 r0 *1 350.84,256.04 sg13_hv_pmos
M$255 50 36 52 52 sg13_hv_pmos L=4U W=5U AS=1.7P AD=1.7P PS=10.68U PD=10.68U
+ rfmode=0
* device instance $256 r0 *1 360.76,256.04 sg13_hv_pmos
M$256 50 36 52 52 sg13_hv_pmos L=4U W=5U AS=1.7P AD=1.7P PS=10.68U PD=10.68U
+ rfmode=0
* device instance $257 r0 *1 370.68,256.04 sg13_hv_pmos
M$257 51 36 52 52 sg13_hv_pmos L=4U W=5U AS=1.7P AD=1.7P PS=10.68U PD=10.68U
+ rfmode=0
* device instance $258 r0 *1 380.6,256.04 sg13_hv_pmos
M$258 8 36 52 52 sg13_hv_pmos L=4U W=5U AS=1.7P AD=1.7P PS=10.68U PD=10.68U
+ rfmode=0
* device instance $259 r0 *1 390.52,256.04 sg13_hv_pmos
M$259 51 36 52 52 sg13_hv_pmos L=4U W=5U AS=1.7P AD=1.7P PS=10.68U PD=10.68U
+ rfmode=0
* device instance $260 r0 *1 400.44,256.04 sg13_hv_pmos
M$260 8 36 52 52 sg13_hv_pmos L=4U W=5U AS=1.7P AD=1.7P PS=10.68U PD=10.68U
+ rfmode=0
* device instance $261 r0 *1 211.96,276.52 sg13_hv_pmos
M$261 49 36 52 52 sg13_hv_pmos L=4U W=5U AS=1.7P AD=1.7P PS=10.68U PD=10.68U
+ rfmode=0
* device instance $262 r0 *1 221.88,276.52 sg13_hv_pmos
M$262 49 36 52 52 sg13_hv_pmos L=4U W=5U AS=1.7P AD=1.7P PS=10.68U PD=10.68U
+ rfmode=0
* device instance $263 r0 *1 231.8,276.52 sg13_hv_pmos
M$263 49 36 52 52 sg13_hv_pmos L=4U W=5U AS=1.7P AD=1.7P PS=10.68U PD=10.68U
+ rfmode=0
* device instance $264 r0 *1 241.72,276.52 sg13_hv_pmos
M$264 49 36 52 52 sg13_hv_pmos L=4U W=5U AS=1.7P AD=1.7P PS=10.68U PD=10.68U
+ rfmode=0
* device instance $265 r0 *1 251.64,276.52 sg13_hv_pmos
M$265 49 36 52 52 sg13_hv_pmos L=4U W=5U AS=1.7P AD=1.7P PS=10.68U PD=10.68U
+ rfmode=0
* device instance $266 r0 *1 251.64,266.28 sg13_hv_pmos
M$266 50 36 52 52 sg13_hv_pmos L=4U W=5U AS=1.7P AD=1.7P PS=10.68U PD=10.68U
+ rfmode=0
* device instance $267 r0 *1 261.56,276.52 sg13_hv_pmos
M$267 49 36 52 52 sg13_hv_pmos L=4U W=5U AS=1.7P AD=1.7P PS=10.68U PD=10.68U
+ rfmode=0
* device instance $268 r0 *1 261.56,266.28 sg13_hv_pmos
M$268 50 36 52 52 sg13_hv_pmos L=4U W=5U AS=1.7P AD=1.7P PS=10.68U PD=10.68U
+ rfmode=0
* device instance $269 r0 *1 271.48,266.28 sg13_hv_pmos
M$269 50 36 52 52 sg13_hv_pmos L=4U W=5U AS=1.7P AD=1.7P PS=10.68U PD=10.68U
+ rfmode=0
* device instance $270 r0 *1 271.48,276.52 sg13_hv_pmos
M$270 49 36 52 52 sg13_hv_pmos L=4U W=5U AS=1.7P AD=1.7P PS=10.68U PD=10.68U
+ rfmode=0
* device instance $271 r0 *1 281.4,276.52 sg13_hv_pmos
M$271 49 36 52 52 sg13_hv_pmos L=4U W=5U AS=1.7P AD=1.7P PS=10.68U PD=10.68U
+ rfmode=0
* device instance $272 r0 *1 281.4,266.28 sg13_hv_pmos
M$272 50 36 52 52 sg13_hv_pmos L=4U W=5U AS=1.7P AD=1.7P PS=10.68U PD=10.68U
+ rfmode=0
* device instance $273 r0 *1 291.32,266.28 sg13_hv_pmos
M$273 42 36 52 52 sg13_hv_pmos L=4U W=5U AS=1.7P AD=1.7P PS=10.68U PD=10.68U
+ rfmode=0
* device instance $274 r0 *1 291.32,276.52 sg13_hv_pmos
M$274 49 36 52 52 sg13_hv_pmos L=4U W=5U AS=1.7P AD=1.7P PS=10.68U PD=10.68U
+ rfmode=0
* device instance $275 r0 *1 301.24,276.52 sg13_hv_pmos
M$275 49 36 52 52 sg13_hv_pmos L=4U W=5U AS=1.7P AD=1.7P PS=10.68U PD=10.68U
+ rfmode=0
* device instance $276 r0 *1 301.24,266.28 sg13_hv_pmos
M$276 42 36 52 52 sg13_hv_pmos L=4U W=5U AS=1.7P AD=1.7P PS=10.68U PD=10.68U
+ rfmode=0
* device instance $277 r0 *1 311.16,276.52 sg13_hv_pmos
M$277 49 36 52 52 sg13_hv_pmos L=4U W=5U AS=1.7P AD=1.7P PS=10.68U PD=10.68U
+ rfmode=0
* device instance $278 r0 *1 311.16,266.28 sg13_hv_pmos
M$278 42 36 52 52 sg13_hv_pmos L=4U W=5U AS=1.7P AD=1.7P PS=10.68U PD=10.68U
+ rfmode=0
* device instance $279 r0 *1 321.08,276.52 sg13_hv_pmos
M$279 49 36 52 52 sg13_hv_pmos L=4U W=5U AS=1.7P AD=1.7P PS=10.68U PD=10.68U
+ rfmode=0
* device instance $280 r0 *1 321.08,266.28 sg13_hv_pmos
M$280 42 36 52 52 sg13_hv_pmos L=4U W=5U AS=1.7P AD=1.7P PS=10.68U PD=10.68U
+ rfmode=0
* device instance $281 r0 *1 331,276.52 sg13_hv_pmos
M$281 44 36 52 52 sg13_hv_pmos L=4U W=5U AS=1.7P AD=1.7P PS=10.68U PD=10.68U
+ rfmode=0
* device instance $282 r0 *1 331,266.28 sg13_hv_pmos
M$282 42 36 52 52 sg13_hv_pmos L=4U W=5U AS=1.7P AD=1.7P PS=10.68U PD=10.68U
+ rfmode=0
* device instance $283 r0 *1 340.92,266.28 sg13_hv_pmos
M$283 42 36 52 52 sg13_hv_pmos L=4U W=5U AS=1.7P AD=1.7P PS=10.68U PD=10.68U
+ rfmode=0
* device instance $284 r0 *1 340.92,276.52 sg13_hv_pmos
M$284 44 36 52 52 sg13_hv_pmos L=4U W=5U AS=1.7P AD=1.7P PS=10.68U PD=10.68U
+ rfmode=0
* device instance $285 r0 *1 350.84,266.28 sg13_hv_pmos
M$285 42 36 52 52 sg13_hv_pmos L=4U W=5U AS=1.7P AD=1.7P PS=10.68U PD=10.68U
+ rfmode=0
* device instance $286 r0 *1 350.84,276.52 sg13_hv_pmos
M$286 44 36 52 52 sg13_hv_pmos L=4U W=5U AS=1.7P AD=1.7P PS=10.68U PD=10.68U
+ rfmode=0
* device instance $287 r0 *1 360.76,276.52 sg13_hv_pmos
M$287 44 36 52 52 sg13_hv_pmos L=4U W=5U AS=1.7P AD=1.7P PS=10.68U PD=10.68U
+ rfmode=0
* device instance $288 r0 *1 360.76,266.28 sg13_hv_pmos
M$288 42 36 52 52 sg13_hv_pmos L=4U W=5U AS=1.7P AD=1.7P PS=10.68U PD=10.68U
+ rfmode=0
* device instance $289 r0 *1 370.68,266.28 sg13_hv_pmos
M$289 42 36 52 52 sg13_hv_pmos L=4U W=5U AS=1.7P AD=1.7P PS=10.68U PD=10.68U
+ rfmode=0
* device instance $290 r0 *1 370.68,276.52 sg13_hv_pmos
M$290 44 36 52 52 sg13_hv_pmos L=4U W=5U AS=1.7P AD=1.7P PS=10.68U PD=10.68U
+ rfmode=0
* device instance $291 r0 *1 380.6,276.52 sg13_hv_pmos
M$291 44 36 52 52 sg13_hv_pmos L=4U W=5U AS=1.7P AD=1.7P PS=10.68U PD=10.68U
+ rfmode=0
* device instance $292 r0 *1 380.6,266.28 sg13_hv_pmos
M$292 42 36 52 52 sg13_hv_pmos L=4U W=5U AS=1.7P AD=1.7P PS=10.68U PD=10.68U
+ rfmode=0
* device instance $293 r0 *1 390.52,276.52 sg13_hv_pmos
M$293 44 36 52 52 sg13_hv_pmos L=4U W=5U AS=1.7P AD=1.7P PS=10.68U PD=10.68U
+ rfmode=0
* device instance $294 r0 *1 390.52,266.28 sg13_hv_pmos
M$294 42 36 52 52 sg13_hv_pmos L=4U W=5U AS=1.7P AD=1.7P PS=10.68U PD=10.68U
+ rfmode=0
* device instance $295 r0 *1 400.44,266.28 sg13_hv_pmos
M$295 42 36 52 52 sg13_hv_pmos L=4U W=5U AS=1.7P AD=1.7P PS=10.68U PD=10.68U
+ rfmode=0
* device instance $296 r0 *1 400.44,276.52 sg13_hv_pmos
M$296 44 36 52 52 sg13_hv_pmos L=4U W=5U AS=1.7P AD=1.7P PS=10.68U PD=10.68U
+ rfmode=0
* device instance $297 r0 *1 211.96,286.76 sg13_hv_pmos
M$297 44 36 52 52 sg13_hv_pmos L=4U W=5U AS=1.7P AD=1.7P PS=10.68U PD=10.68U
+ rfmode=0
* device instance $298 r0 *1 221.88,286.76 sg13_hv_pmos
M$298 44 36 52 52 sg13_hv_pmos L=4U W=5U AS=1.7P AD=1.7P PS=10.68U PD=10.68U
+ rfmode=0
* device instance $299 r0 *1 231.8,286.76 sg13_hv_pmos
M$299 44 36 52 52 sg13_hv_pmos L=4U W=5U AS=1.7P AD=1.7P PS=10.68U PD=10.68U
+ rfmode=0
* device instance $300 r0 *1 241.72,286.76 sg13_hv_pmos
M$300 44 36 52 52 sg13_hv_pmos L=4U W=5U AS=1.7P AD=1.7P PS=10.68U PD=10.68U
+ rfmode=0
* device instance $301 r0 *1 251.64,286.76 sg13_hv_pmos
M$301 44 36 52 52 sg13_hv_pmos L=4U W=5U AS=1.7P AD=1.7P PS=10.68U PD=10.68U
+ rfmode=0
* device instance $302 r0 *1 261.56,286.76 sg13_hv_pmos
M$302 44 36 52 52 sg13_hv_pmos L=4U W=5U AS=1.7P AD=1.7P PS=10.68U PD=10.68U
+ rfmode=0
* device instance $303 r0 *1 271.48,286.76 sg13_hv_pmos
M$303 44 36 52 52 sg13_hv_pmos L=4U W=5U AS=1.7P AD=1.7P PS=10.68U PD=10.68U
+ rfmode=0
* device instance $304 r0 *1 281.4,286.76 sg13_hv_pmos
M$304 44 36 52 52 sg13_hv_pmos L=4U W=5U AS=1.7P AD=1.7P PS=10.68U PD=10.68U
+ rfmode=0
* device instance $305 r0 *1 291.32,286.76 sg13_hv_pmos
M$305 44 36 52 52 sg13_hv_pmos L=4U W=5U AS=1.7P AD=1.7P PS=10.68U PD=10.68U
+ rfmode=0
* device instance $306 r0 *1 301.24,286.76 sg13_hv_pmos
M$306 44 36 52 52 sg13_hv_pmos L=4U W=5U AS=1.7P AD=1.7P PS=10.68U PD=10.68U
+ rfmode=0
* device instance $307 r0 *1 311.16,286.76 sg13_hv_pmos
M$307 44 36 52 52 sg13_hv_pmos L=4U W=5U AS=1.7P AD=1.7P PS=10.68U PD=10.68U
+ rfmode=0
* device instance $308 r0 *1 321.08,286.76 sg13_hv_pmos
M$308 44 36 52 52 sg13_hv_pmos L=4U W=5U AS=1.7P AD=1.7P PS=10.68U PD=10.68U
+ rfmode=0
* device instance $309 r0 *1 331,286.76 sg13_hv_pmos
M$309 44 36 52 52 sg13_hv_pmos L=4U W=5U AS=1.7P AD=1.7P PS=10.68U PD=10.68U
+ rfmode=0
* device instance $310 r0 *1 340.92,286.76 sg13_hv_pmos
M$310 44 36 52 52 sg13_hv_pmos L=4U W=5U AS=1.7P AD=1.7P PS=10.68U PD=10.68U
+ rfmode=0
* device instance $311 r0 *1 350.84,286.76 sg13_hv_pmos
M$311 44 36 52 52 sg13_hv_pmos L=4U W=5U AS=1.7P AD=1.7P PS=10.68U PD=10.68U
+ rfmode=0
* device instance $312 r0 *1 360.76,286.76 sg13_hv_pmos
M$312 44 36 52 52 sg13_hv_pmos L=4U W=5U AS=1.7P AD=1.7P PS=10.68U PD=10.68U
+ rfmode=0
* device instance $313 r0 *1 370.68,286.76 sg13_hv_pmos
M$313 49 36 52 52 sg13_hv_pmos L=4U W=5U AS=1.7P AD=1.7P PS=10.68U PD=10.68U
+ rfmode=0
* device instance $314 r0 *1 380.6,286.76 sg13_hv_pmos
M$314 49 36 52 52 sg13_hv_pmos L=4U W=5U AS=1.7P AD=1.7P PS=10.68U PD=10.68U
+ rfmode=0
* device instance $315 r0 *1 390.52,286.76 sg13_hv_pmos
M$315 49 36 52 52 sg13_hv_pmos L=4U W=5U AS=1.7P AD=1.7P PS=10.68U PD=10.68U
+ rfmode=0
* device instance $316 r0 *1 400.44,286.76 sg13_hv_pmos
M$316 49 36 52 52 sg13_hv_pmos L=4U W=5U AS=1.7P AD=1.7P PS=10.68U PD=10.68U
+ rfmode=0
* device instance $317 r0 *1 211.96,297 sg13_hv_pmos
M$317 49 36 52 52 sg13_hv_pmos L=4U W=5U AS=1.7P AD=1.7P PS=10.68U PD=10.68U
+ rfmode=0
* device instance $318 r0 *1 221.88,297 sg13_hv_pmos
M$318 49 36 52 52 sg13_hv_pmos L=4U W=5U AS=1.7P AD=1.7P PS=10.68U PD=10.68U
+ rfmode=0
* device instance $319 r0 *1 231.8,297 sg13_hv_pmos
M$319 49 36 52 52 sg13_hv_pmos L=4U W=5U AS=1.7P AD=1.7P PS=10.68U PD=10.68U
+ rfmode=0
* device instance $320 r0 *1 241.72,297 sg13_hv_pmos
M$320 49 36 52 52 sg13_hv_pmos L=4U W=5U AS=1.7P AD=1.7P PS=10.68U PD=10.68U
+ rfmode=0
* device instance $321 r0 *1 251.64,297 sg13_hv_pmos
M$321 49 36 52 52 sg13_hv_pmos L=4U W=5U AS=1.7P AD=1.7P PS=10.68U PD=10.68U
+ rfmode=0
* device instance $322 r0 *1 261.56,297 sg13_hv_pmos
M$322 49 36 52 52 sg13_hv_pmos L=4U W=5U AS=1.7P AD=1.7P PS=10.68U PD=10.68U
+ rfmode=0
* device instance $323 r0 *1 271.48,297 sg13_hv_pmos
M$323 49 36 52 52 sg13_hv_pmos L=4U W=5U AS=1.7P AD=1.7P PS=10.68U PD=10.68U
+ rfmode=0
* device instance $324 r0 *1 281.4,297 sg13_hv_pmos
M$324 49 36 52 52 sg13_hv_pmos L=4U W=5U AS=1.7P AD=1.7P PS=10.68U PD=10.68U
+ rfmode=0
* device instance $325 r0 *1 291.32,297 sg13_hv_pmos
M$325 42 36 52 52 sg13_hv_pmos L=4U W=5U AS=1.7P AD=1.7P PS=10.68U PD=10.68U
+ rfmode=0
* device instance $326 r0 *1 301.24,297 sg13_hv_pmos
M$326 42 36 52 52 sg13_hv_pmos L=4U W=5U AS=1.7P AD=1.7P PS=10.68U PD=10.68U
+ rfmode=0
* device instance $327 r0 *1 311.16,297 sg13_hv_pmos
M$327 42 36 52 52 sg13_hv_pmos L=4U W=5U AS=1.7P AD=1.7P PS=10.68U PD=10.68U
+ rfmode=0
* device instance $328 r0 *1 321.08,297 sg13_hv_pmos
M$328 42 36 52 52 sg13_hv_pmos L=4U W=5U AS=1.7P AD=1.7P PS=10.68U PD=10.68U
+ rfmode=0
* device instance $329 r0 *1 331,297 sg13_hv_pmos
M$329 42 36 52 52 sg13_hv_pmos L=4U W=5U AS=1.7P AD=1.7P PS=10.68U PD=10.68U
+ rfmode=0
* device instance $330 r0 *1 340.92,297 sg13_hv_pmos
M$330 42 36 52 52 sg13_hv_pmos L=4U W=5U AS=1.7P AD=1.7P PS=10.68U PD=10.68U
+ rfmode=0
* device instance $331 r0 *1 350.84,297 sg13_hv_pmos
M$331 42 36 52 52 sg13_hv_pmos L=4U W=5U AS=1.7P AD=1.7P PS=10.68U PD=10.68U
+ rfmode=0
* device instance $332 r0 *1 360.76,297 sg13_hv_pmos
M$332 42 36 52 52 sg13_hv_pmos L=4U W=5U AS=1.7P AD=1.7P PS=10.68U PD=10.68U
+ rfmode=0
* device instance $333 r0 *1 370.68,297 sg13_hv_pmos
M$333 42 36 52 52 sg13_hv_pmos L=4U W=5U AS=1.7P AD=1.7P PS=10.68U PD=10.68U
+ rfmode=0
* device instance $334 r0 *1 380.6,297 sg13_hv_pmos
M$334 42 36 52 52 sg13_hv_pmos L=4U W=5U AS=1.7P AD=1.7P PS=10.68U PD=10.68U
+ rfmode=0
* device instance $335 r0 *1 390.52,297 sg13_hv_pmos
M$335 42 36 52 52 sg13_hv_pmos L=4U W=5U AS=1.7P AD=1.7P PS=10.68U PD=10.68U
+ rfmode=0
* device instance $336 r0 *1 400.44,297 sg13_hv_pmos
M$336 42 36 52 52 sg13_hv_pmos L=4U W=5U AS=1.7P AD=1.7P PS=10.68U PD=10.68U
+ rfmode=0
* device instance $337 r0 *1 10.9,142.9 npn13G2
Q$337 40 40 1 1 npn13G2 we=0.07 le=0.9 Nx=1 m=1
* device instance $338 r0 *1 21.6,142.9 npn13G2
Q$338 40 40 1 1 npn13G2 we=0.07 le=0.9 Nx=1 m=1
* device instance $339 r0 *1 32.3,142.9 npn13G2
Q$339 40 40 1 1 npn13G2 we=0.07 le=0.9 Nx=1 m=1
* device instance $340 r0 *1 43,142.9 npn13G2
Q$340 40 40 1 1 npn13G2 we=0.07 le=0.9 Nx=1 m=1
* device instance $341 r0 *1 53.7,142.9 npn13G2
Q$341 40 40 1 1 npn13G2 we=0.07 le=0.9 Nx=1 m=1
* device instance $342 r0 *1 64.4,142.9 npn13G2
Q$342 40 40 1 1 npn13G2 we=0.07 le=0.9 Nx=1 m=1
* device instance $343 r0 *1 75.1,142.9 npn13G2
Q$343 40 40 1 1 npn13G2 we=0.07 le=0.9 Nx=1 m=1
* device instance $344 r0 *1 85.8,142.9 npn13G2
Q$344 40 40 1 1 npn13G2 we=0.07 le=0.9 Nx=1 m=1
* device instance $345 r0 *1 96.5,142.9 npn13G2
Q$345 40 40 1 1 npn13G2 we=0.07 le=0.9 Nx=1 m=1
* device instance $346 r0 *1 107.2,142.9 npn13G2
Q$346 40 40 1 1 npn13G2 we=0.07 le=0.9 Nx=1 m=1
* device instance $347 r0 *1 117.9,142.9 npn13G2
Q$347 40 40 1 1 npn13G2 we=0.07 le=0.9 Nx=1 m=1
* device instance $348 r0 *1 128.6,142.9 npn13G2
Q$348 40 40 1 1 npn13G2 we=0.07 le=0.9 Nx=1 m=1
* device instance $349 r0 *1 139.3,142.9 npn13G2
Q$349 41 41 1 1 npn13G2 we=0.07 le=0.9 Nx=1 m=1
* device instance $350 r0 *1 150,142.9 npn13G2
Q$350 41 41 1 1 npn13G2 we=0.07 le=0.9 Nx=1 m=1
* device instance $351 r0 *1 160.7,142.9 npn13G2
Q$351 41 41 1 1 npn13G2 we=0.07 le=0.9 Nx=1 m=1
* device instance $352 r0 *1 171.4,142.9 npn13G2
Q$352 41 41 1 1 npn13G2 we=0.07 le=0.9 Nx=1 m=1
* device instance $353 r0 *1 182.1,142.9 npn13G2
Q$353 41 41 1 1 npn13G2 we=0.07 le=0.9 Nx=1 m=1
* device instance $354 r0 *1 10.9,154.01 npn13G2
Q$354 41 41 1 1 npn13G2 we=0.07 le=0.9 Nx=1 m=1
* device instance $355 r0 *1 21.6,154.01 npn13G2
Q$355 41 41 1 1 npn13G2 we=0.07 le=0.9 Nx=1 m=1
* device instance $356 r0 *1 32.3,154.01 npn13G2
Q$356 41 41 1 1 npn13G2 we=0.07 le=0.9 Nx=1 m=1
* device instance $357 r0 *1 43,154.01 npn13G2
Q$357 41 41 1 1 npn13G2 we=0.07 le=0.9 Nx=1 m=1
* device instance $358 r0 *1 53.7,154.01 npn13G2
Q$358 41 41 1 1 npn13G2 we=0.07 le=0.9 Nx=1 m=1
* device instance $359 r0 *1 64.4,154.01 npn13G2
Q$359 41 41 1 1 npn13G2 we=0.07 le=0.9 Nx=1 m=1
* device instance $360 r0 *1 75.1,154.01 npn13G2
Q$360 41 41 1 1 npn13G2 we=0.07 le=0.9 Nx=1 m=1
* device instance $361 r0 *1 85.8,154.01 npn13G2
Q$361 40 47 1 1 npn13G2 we=0.07 le=0.9 Nx=1 m=1
* device instance $362 r0 *1 96.5,154.01 npn13G2
Q$362 40 47 1 1 npn13G2 we=0.07 le=0.9 Nx=1 m=1
* device instance $363 r0 *1 107.2,154.01 npn13G2
Q$363 40 47 1 1 npn13G2 we=0.07 le=0.9 Nx=1 m=1
* device instance $364 r0 *1 117.9,154.01 npn13G2
Q$364 40 47 1 1 npn13G2 we=0.07 le=0.9 Nx=1 m=1
* device instance $365 r0 *1 128.6,154.01 npn13G2
Q$365 40 47 1 1 npn13G2 we=0.07 le=0.9 Nx=1 m=1
* device instance $366 r0 *1 139.3,154.01 npn13G2
Q$366 40 47 1 1 npn13G2 we=0.07 le=0.9 Nx=1 m=1
* device instance $367 r0 *1 150,154.01 npn13G2
Q$367 40 47 1 1 npn13G2 we=0.07 le=0.9 Nx=1 m=1
* device instance $368 r0 *1 160.7,154.01 npn13G2
Q$368 40 47 1 1 npn13G2 we=0.07 le=0.9 Nx=1 m=1
* device instance $369 r0 *1 171.4,154.01 npn13G2
Q$369 40 47 1 1 npn13G2 we=0.07 le=0.9 Nx=1 m=1
* device instance $370 r0 *1 182.1,154.01 npn13G2
Q$370 40 47 1 1 npn13G2 we=0.07 le=0.9 Nx=1 m=1
* device instance $371 r0 *1 10.9,165.12 npn13G2
Q$371 40 47 1 1 npn13G2 we=0.07 le=0.9 Nx=1 m=1
* device instance $372 r0 *1 21.6,165.12 npn13G2
Q$372 40 47 1 1 npn13G2 we=0.07 le=0.9 Nx=1 m=1
* device instance $373 r0 *1 32.3,165.12 npn13G2
Q$373 53 40 9 1 npn13G2 we=0.07 le=0.9 Nx=1 m=1
* device instance $374 r0 *1 43,165.12 npn13G2
Q$374 53 40 9 1 npn13G2 we=0.07 le=0.9 Nx=1 m=1
* device instance $375 r0 *1 53.7,165.12 npn13G2
Q$375 53 40 9 1 npn13G2 we=0.07 le=0.9 Nx=1 m=1
* device instance $376 r0 *1 64.4,165.12 npn13G2
Q$376 53 40 9 1 npn13G2 we=0.07 le=0.9 Nx=1 m=1
* device instance $377 r0 *1 75.1,165.12 npn13G2
Q$377 53 40 9 1 npn13G2 we=0.07 le=0.9 Nx=1 m=1
* device instance $378 r0 *1 85.8,165.12 npn13G2
Q$378 53 40 9 1 npn13G2 we=0.07 le=0.9 Nx=1 m=1
* device instance $379 r0 *1 96.5,165.12 npn13G2
Q$379 53 40 9 1 npn13G2 we=0.07 le=0.9 Nx=1 m=1
* device instance $380 r0 *1 107.2,165.12 npn13G2
Q$380 53 40 9 1 npn13G2 we=0.07 le=0.9 Nx=1 m=1
* device instance $381 r0 *1 117.9,165.12 npn13G2
Q$381 53 40 9 1 npn13G2 we=0.07 le=0.9 Nx=1 m=1
* device instance $382 r0 *1 128.6,165.12 npn13G2
Q$382 53 40 9 1 npn13G2 we=0.07 le=0.9 Nx=1 m=1
* device instance $383 r0 *1 139.3,165.12 npn13G2
Q$383 53 40 9 1 npn13G2 we=0.07 le=0.9 Nx=1 m=1
* device instance $384 r0 *1 150,165.12 npn13G2
Q$384 53 40 9 1 npn13G2 we=0.07 le=0.9 Nx=1 m=1
* device instance $385 r0 *1 160.7,165.12 npn13G2
Q$385 53 40 9 1 npn13G2 we=0.07 le=0.9 Nx=1 m=1
* device instance $386 r0 *1 171.4,165.12 npn13G2
Q$386 53 40 9 1 npn13G2 we=0.07 le=0.9 Nx=1 m=1
* device instance $387 r0 *1 182.1,165.12 npn13G2
Q$387 53 40 9 1 npn13G2 we=0.07 le=0.9 Nx=1 m=1
* device instance $388 r0 *1 10.9,176.23 npn13G2
Q$388 53 40 9 1 npn13G2 we=0.07 le=0.9 Nx=1 m=1
* device instance $389 r0 *1 21.6,176.23 npn13G2
Q$389 53 40 9 1 npn13G2 we=0.07 le=0.9 Nx=1 m=1
* device instance $390 r0 *1 32.3,176.23 npn13G2
Q$390 53 40 9 1 npn13G2 we=0.07 le=0.9 Nx=1 m=1
* device instance $391 r0 *1 43,176.23 npn13G2
Q$391 53 40 9 1 npn13G2 we=0.07 le=0.9 Nx=1 m=1
* device instance $392 r0 *1 53.7,176.23 npn13G2
Q$392 53 40 9 1 npn13G2 we=0.07 le=0.9 Nx=1 m=1
* device instance $393 r0 *1 64.4,176.23 npn13G2
Q$393 53 40 9 1 npn13G2 we=0.07 le=0.9 Nx=1 m=1
* device instance $394 r0 *1 75.1,176.23 npn13G2
Q$394 53 40 9 1 npn13G2 we=0.07 le=0.9 Nx=1 m=1
* device instance $395 r0 *1 85.8,176.23 npn13G2
Q$395 53 40 9 1 npn13G2 we=0.07 le=0.9 Nx=1 m=1
* device instance $396 r0 *1 96.5,176.23 npn13G2
Q$396 53 40 9 1 npn13G2 we=0.07 le=0.9 Nx=1 m=1
* device instance $397 r0 *1 107.2,176.23 npn13G2
Q$397 53 40 9 1 npn13G2 we=0.07 le=0.9 Nx=1 m=1
* device instance $398 r0 *1 117.9,176.23 npn13G2
Q$398 53 40 9 1 npn13G2 we=0.07 le=0.9 Nx=1 m=1
* device instance $399 r0 *1 128.6,176.23 npn13G2
Q$399 53 40 9 1 npn13G2 we=0.07 le=0.9 Nx=1 m=1
* device instance $400 r0 *1 139.3,176.23 npn13G2
Q$400 53 40 9 1 npn13G2 we=0.07 le=0.9 Nx=1 m=1
* device instance $401 r0 *1 150,176.23 npn13G2
Q$401 53 40 9 1 npn13G2 we=0.07 le=0.9 Nx=1 m=1
* device instance $402 r0 *1 160.7,176.23 npn13G2
Q$402 53 40 9 1 npn13G2 we=0.07 le=0.9 Nx=1 m=1
* device instance $403 r0 *1 171.4,176.23 npn13G2
Q$403 53 40 9 1 npn13G2 we=0.07 le=0.9 Nx=1 m=1
* device instance $404 r0 *1 182.1,176.23 npn13G2
Q$404 53 40 9 1 npn13G2 we=0.07 le=0.9 Nx=1 m=1
* device instance $405 r0 *1 10.9,187.34 npn13G2
Q$405 53 40 9 1 npn13G2 we=0.07 le=0.9 Nx=1 m=1
* device instance $406 r0 *1 21.6,187.34 npn13G2
Q$406 53 40 9 1 npn13G2 we=0.07 le=0.9 Nx=1 m=1
* device instance $407 r0 *1 32.3,187.34 npn13G2
Q$407 53 40 9 1 npn13G2 we=0.07 le=0.9 Nx=1 m=1
* device instance $408 r0 *1 43,187.34 npn13G2
Q$408 53 40 9 1 npn13G2 we=0.07 le=0.9 Nx=1 m=1
* device instance $409 r0 *1 53.7,187.34 npn13G2
Q$409 53 40 9 1 npn13G2 we=0.07 le=0.9 Nx=1 m=1
* device instance $410 r0 *1 64.4,187.34 npn13G2
Q$410 53 40 9 1 npn13G2 we=0.07 le=0.9 Nx=1 m=1
* device instance $411 r0 *1 75.1,187.34 npn13G2
Q$411 53 40 9 1 npn13G2 we=0.07 le=0.9 Nx=1 m=1
* device instance $412 r0 *1 85.8,187.34 npn13G2
Q$412 53 40 9 1 npn13G2 we=0.07 le=0.9 Nx=1 m=1
* device instance $413 r0 *1 96.5,187.34 npn13G2
Q$413 53 40 9 1 npn13G2 we=0.07 le=0.9 Nx=1 m=1
* device instance $414 r0 *1 107.2,187.34 npn13G2
Q$414 53 40 9 1 npn13G2 we=0.07 le=0.9 Nx=1 m=1
* device instance $415 r0 *1 117.9,187.34 npn13G2
Q$415 53 40 9 1 npn13G2 we=0.07 le=0.9 Nx=1 m=1
* device instance $416 r0 *1 128.6,187.34 npn13G2
Q$416 53 40 9 1 npn13G2 we=0.07 le=0.9 Nx=1 m=1
* device instance $417 r0 *1 139.3,187.34 npn13G2
Q$417 53 40 9 1 npn13G2 we=0.07 le=0.9 Nx=1 m=1
* device instance $418 r0 *1 150,187.34 npn13G2
Q$418 53 40 9 1 npn13G2 we=0.07 le=0.9 Nx=1 m=1
* device instance $419 r0 *1 160.7,187.34 npn13G2
Q$419 53 40 9 1 npn13G2 we=0.07 le=0.9 Nx=1 m=1
* device instance $420 r0 *1 171.4,187.34 npn13G2
Q$420 53 40 9 1 npn13G2 we=0.07 le=0.9 Nx=1 m=1
* device instance $421 r0 *1 182.1,187.34 npn13G2
Q$421 53 40 9 1 npn13G2 we=0.07 le=0.9 Nx=1 m=1
* device instance $422 r0 *1 10.9,198.45 npn13G2
Q$422 53 40 9 1 npn13G2 we=0.07 le=0.9 Nx=1 m=1
* device instance $423 r0 *1 21.6,198.45 npn13G2
Q$423 53 40 9 1 npn13G2 we=0.07 le=0.9 Nx=1 m=1
* device instance $424 r0 *1 32.3,198.45 npn13G2
Q$424 53 40 9 1 npn13G2 we=0.07 le=0.9 Nx=1 m=1
* device instance $425 r0 *1 43,198.45 npn13G2
Q$425 53 40 9 1 npn13G2 we=0.07 le=0.9 Nx=1 m=1
* device instance $426 r0 *1 53.7,198.45 npn13G2
Q$426 53 40 9 1 npn13G2 we=0.07 le=0.9 Nx=1 m=1
* device instance $427 r0 *1 64.4,198.45 npn13G2
Q$427 53 40 9 1 npn13G2 we=0.07 le=0.9 Nx=1 m=1
* device instance $428 r0 *1 75.1,198.45 npn13G2
Q$428 53 40 9 1 npn13G2 we=0.07 le=0.9 Nx=1 m=1
* device instance $429 r0 *1 85.8,198.45 npn13G2
Q$429 53 40 9 1 npn13G2 we=0.07 le=0.9 Nx=1 m=1
* device instance $430 r0 *1 96.5,198.45 npn13G2
Q$430 53 40 9 1 npn13G2 we=0.07 le=0.9 Nx=1 m=1
* device instance $431 r0 *1 107.2,198.45 npn13G2
Q$431 53 40 9 1 npn13G2 we=0.07 le=0.9 Nx=1 m=1
* device instance $432 r0 *1 117.9,198.45 npn13G2
Q$432 53 40 9 1 npn13G2 we=0.07 le=0.9 Nx=1 m=1
* device instance $433 r0 *1 128.6,198.45 npn13G2
Q$433 53 40 9 1 npn13G2 we=0.07 le=0.9 Nx=1 m=1
* device instance $434 r0 *1 139.3,198.45 npn13G2
Q$434 53 40 9 1 npn13G2 we=0.07 le=0.9 Nx=1 m=1
* device instance $435 r0 *1 150,198.45 npn13G2
Q$435 53 40 9 1 npn13G2 we=0.07 le=0.9 Nx=1 m=1
* device instance $436 r0 *1 160.7,198.45 npn13G2
Q$436 53 40 9 1 npn13G2 we=0.07 le=0.9 Nx=1 m=1
* device instance $437 r0 *1 171.4,198.45 npn13G2
Q$437 53 40 9 1 npn13G2 we=0.07 le=0.9 Nx=1 m=1
* device instance $438 r0 *1 182.1,198.45 npn13G2
Q$438 53 40 9 1 npn13G2 we=0.07 le=0.9 Nx=1 m=1
* device instance $439 r0 *1 10.9,209.56 npn13G2
Q$439 53 40 9 1 npn13G2 we=0.07 le=0.9 Nx=1 m=1
* device instance $440 r0 *1 21.6,209.56 npn13G2
Q$440 53 40 9 1 npn13G2 we=0.07 le=0.9 Nx=1 m=1
* device instance $441 r0 *1 32.3,209.56 npn13G2
Q$441 53 40 9 1 npn13G2 we=0.07 le=0.9 Nx=1 m=1
* device instance $442 r0 *1 43,209.56 npn13G2
Q$442 53 40 9 1 npn13G2 we=0.07 le=0.9 Nx=1 m=1
* device instance $443 r0 *1 53.7,209.56 npn13G2
Q$443 53 40 9 1 npn13G2 we=0.07 le=0.9 Nx=1 m=1
* device instance $444 r0 *1 64.4,209.56 npn13G2
Q$444 53 40 9 1 npn13G2 we=0.07 le=0.9 Nx=1 m=1
* device instance $445 r0 *1 75.1,209.56 npn13G2
Q$445 53 40 9 1 npn13G2 we=0.07 le=0.9 Nx=1 m=1
* device instance $446 r0 *1 85.8,209.56 npn13G2
Q$446 53 40 9 1 npn13G2 we=0.07 le=0.9 Nx=1 m=1
* device instance $447 r0 *1 96.5,209.56 npn13G2
Q$447 53 40 9 1 npn13G2 we=0.07 le=0.9 Nx=1 m=1
* device instance $448 r0 *1 107.2,209.56 npn13G2
Q$448 53 40 9 1 npn13G2 we=0.07 le=0.9 Nx=1 m=1
* device instance $449 r0 *1 117.9,209.56 npn13G2
Q$449 53 40 9 1 npn13G2 we=0.07 le=0.9 Nx=1 m=1
* device instance $450 r0 *1 128.6,209.56 npn13G2
Q$450 53 40 9 1 npn13G2 we=0.07 le=0.9 Nx=1 m=1
* device instance $451 r0 *1 139.3,209.56 npn13G2
Q$451 53 40 9 1 npn13G2 we=0.07 le=0.9 Nx=1 m=1
* device instance $452 r0 *1 150,209.56 npn13G2
Q$452 53 40 9 1 npn13G2 we=0.07 le=0.9 Nx=1 m=1
* device instance $453 r0 *1 160.7,209.56 npn13G2
Q$453 53 40 9 1 npn13G2 we=0.07 le=0.9 Nx=1 m=1
* device instance $454 r0 *1 171.4,209.56 npn13G2
Q$454 53 40 9 1 npn13G2 we=0.07 le=0.9 Nx=1 m=1
* device instance $455 r0 *1 182.1,209.56 npn13G2
Q$455 53 40 9 1 npn13G2 we=0.07 le=0.9 Nx=1 m=1
* device instance $456 r0 *1 10.9,220.67 npn13G2
Q$456 53 40 9 1 npn13G2 we=0.07 le=0.9 Nx=1 m=1
* device instance $457 r0 *1 21.6,220.67 npn13G2
Q$457 39 39 41 1 npn13G2 we=0.07 le=0.9 Nx=1 m=1
* device instance $458 r0 *1 32.3,220.67 npn13G2
Q$458 39 39 41 1 npn13G2 we=0.07 le=0.9 Nx=1 m=1
* device instance $459 r0 *1 43,220.67 npn13G2
Q$459 39 39 41 1 npn13G2 we=0.07 le=0.9 Nx=1 m=1
* device instance $460 r0 *1 53.7,220.67 npn13G2
Q$460 39 39 41 1 npn13G2 we=0.07 le=0.9 Nx=1 m=1
* device instance $461 r0 *1 64.4,220.67 npn13G2
Q$461 39 39 41 1 npn13G2 we=0.07 le=0.9 Nx=1 m=1
* device instance $462 r0 *1 75.1,220.67 npn13G2
Q$462 39 39 41 1 npn13G2 we=0.07 le=0.9 Nx=1 m=1
* device instance $463 r0 *1 85.8,220.67 npn13G2
Q$463 39 39 41 1 npn13G2 we=0.07 le=0.9 Nx=1 m=1
* device instance $464 r0 *1 96.5,220.67 npn13G2
Q$464 39 39 41 1 npn13G2 we=0.07 le=0.9 Nx=1 m=1
* device instance $465 r0 *1 107.2,220.67 npn13G2
Q$465 39 39 41 1 npn13G2 we=0.07 le=0.9 Nx=1 m=1
* device instance $466 r0 *1 117.9,220.67 npn13G2
Q$466 39 39 41 1 npn13G2 we=0.07 le=0.9 Nx=1 m=1
* device instance $467 r0 *1 128.6,220.67 npn13G2
Q$467 39 39 41 1 npn13G2 we=0.07 le=0.9 Nx=1 m=1
* device instance $468 r0 *1 139.3,220.67 npn13G2
Q$468 39 39 41 1 npn13G2 we=0.07 le=0.9 Nx=1 m=1
* device instance $469 r0 *1 150,220.67 npn13G2
Q$469 53 40 9 1 npn13G2 we=0.07 le=0.9 Nx=1 m=1
* device instance $470 r0 *1 160.7,220.67 npn13G2
Q$470 53 40 9 1 npn13G2 we=0.07 le=0.9 Nx=1 m=1
* device instance $471 r0 *1 171.4,220.67 npn13G2
Q$471 53 40 9 1 npn13G2 we=0.07 le=0.9 Nx=1 m=1
* device instance $472 r0 *1 182.1,220.67 npn13G2
Q$472 53 40 9 1 npn13G2 we=0.07 le=0.9 Nx=1 m=1
* device instance $473 r0 *1 10.9,231.78 npn13G2
Q$473 53 40 9 1 npn13G2 we=0.07 le=0.9 Nx=1 m=1
* device instance $474 r0 *1 21.6,231.78 npn13G2
Q$474 53 40 9 1 npn13G2 we=0.07 le=0.9 Nx=1 m=1
* device instance $475 r0 *1 32.3,231.78 npn13G2
Q$475 53 40 9 1 npn13G2 we=0.07 le=0.9 Nx=1 m=1
* device instance $476 r0 *1 43,231.78 npn13G2
Q$476 53 40 9 1 npn13G2 we=0.07 le=0.9 Nx=1 m=1
* device instance $477 r0 *1 53.7,231.78 npn13G2
Q$477 53 40 9 1 npn13G2 we=0.07 le=0.9 Nx=1 m=1
* device instance $478 r0 *1 64.4,231.78 npn13G2
Q$478 53 40 9 1 npn13G2 we=0.07 le=0.9 Nx=1 m=1
* device instance $479 r0 *1 75.1,231.78 npn13G2
Q$479 53 40 9 1 npn13G2 we=0.07 le=0.9 Nx=1 m=1
* device instance $480 r0 *1 85.8,231.78 npn13G2
Q$480 53 40 9 1 npn13G2 we=0.07 le=0.9 Nx=1 m=1
* device instance $481 r0 *1 96.5,231.78 npn13G2
Q$481 37 37 1 1 npn13G2 we=0.07 le=0.9 Nx=1 m=1
* device instance $482 r0 *1 107.2,231.78 npn13G2
Q$482 37 37 1 1 npn13G2 we=0.07 le=0.9 Nx=1 m=1
* device instance $492 r0 *1 85.8,254 npn13G2
Q$492 37 37 1 1 npn13G2 we=0.07 le=0.9 Nx=1 m=1
* device instance $493 r0 *1 96.5,254 npn13G2
Q$493 37 37 1 1 npn13G2 we=0.07 le=0.9 Nx=1 m=1
* device instance $494 r0 *1 107.2,254 npn13G2
Q$494 53 40 9 1 npn13G2 we=0.07 le=0.9 Nx=1 m=1
* device instance $495 r0 *1 117.9,254 npn13G2
Q$495 53 40 9 1 npn13G2 we=0.07 le=0.9 Nx=1 m=1
* device instance $496 r0 *1 128.6,254 npn13G2
Q$496 53 40 9 1 npn13G2 we=0.07 le=0.9 Nx=1 m=1
* device instance $497 r0 *1 139.3,254 npn13G2
Q$497 53 40 9 1 npn13G2 we=0.07 le=0.9 Nx=1 m=1
* device instance $498 r0 *1 150,254 npn13G2
Q$498 53 40 9 1 npn13G2 we=0.07 le=0.9 Nx=1 m=1
* device instance $499 r0 *1 160.7,254 npn13G2
Q$499 53 40 9 1 npn13G2 we=0.07 le=0.9 Nx=1 m=1
* device instance $500 r0 *1 171.4,254 npn13G2
Q$500 53 40 9 1 npn13G2 we=0.07 le=0.9 Nx=1 m=1
* device instance $501 r0 *1 182.1,254 npn13G2
Q$501 53 40 9 1 npn13G2 we=0.07 le=0.9 Nx=1 m=1
* device instance $502 r0 *1 10.9,265.11 npn13G2
Q$502 53 40 9 1 npn13G2 we=0.07 le=0.9 Nx=1 m=1
* device instance $503 r0 *1 21.6,265.11 npn13G2
Q$503 53 40 9 1 npn13G2 we=0.07 le=0.9 Nx=1 m=1
* device instance $504 r0 *1 32.3,265.11 npn13G2
Q$504 53 40 9 1 npn13G2 we=0.07 le=0.9 Nx=1 m=1
* device instance $505 r0 *1 43,265.11 npn13G2
Q$505 53 40 9 1 npn13G2 we=0.07 le=0.9 Nx=1 m=1
* device instance $506 r0 *1 53.7,265.11 npn13G2
Q$506 39 39 41 1 npn13G2 we=0.07 le=0.9 Nx=1 m=1
* device instance $507 r0 *1 64.4,265.11 npn13G2
Q$507 39 39 41 1 npn13G2 we=0.07 le=0.9 Nx=1 m=1
* device instance $508 r0 *1 75.1,265.11 npn13G2
Q$508 39 39 41 1 npn13G2 we=0.07 le=0.9 Nx=1 m=1
* device instance $509 r0 *1 85.8,265.11 npn13G2
Q$509 39 39 41 1 npn13G2 we=0.07 le=0.9 Nx=1 m=1
* device instance $510 r0 *1 96.5,265.11 npn13G2
Q$510 39 39 41 1 npn13G2 we=0.07 le=0.9 Nx=1 m=1
* device instance $511 r0 *1 107.2,265.11 npn13G2
Q$511 39 39 41 1 npn13G2 we=0.07 le=0.9 Nx=1 m=1
* device instance $512 r0 *1 117.9,265.11 npn13G2
Q$512 39 39 41 1 npn13G2 we=0.07 le=0.9 Nx=1 m=1
* device instance $513 r0 *1 128.6,265.11 npn13G2
Q$513 39 39 41 1 npn13G2 we=0.07 le=0.9 Nx=1 m=1
* device instance $514 r0 *1 139.3,265.11 npn13G2
Q$514 39 39 41 1 npn13G2 we=0.07 le=0.9 Nx=1 m=1
* device instance $515 r0 *1 150,265.11 npn13G2
Q$515 39 39 41 1 npn13G2 we=0.07 le=0.9 Nx=1 m=1
* device instance $516 r0 *1 160.7,265.11 npn13G2
Q$516 39 39 41 1 npn13G2 we=0.07 le=0.9 Nx=1 m=1
* device instance $517 r0 *1 171.4,265.11 npn13G2
Q$517 39 39 41 1 npn13G2 we=0.07 le=0.9 Nx=1 m=1
* device instance $518 r0 *1 182.1,265.11 npn13G2
Q$518 53 40 9 1 npn13G2 we=0.07 le=0.9 Nx=1 m=1
* device instance $519 r0 *1 10.9,276.22 npn13G2
Q$519 53 40 9 1 npn13G2 we=0.07 le=0.9 Nx=1 m=1
* device instance $520 r0 *1 21.6,276.22 npn13G2
Q$520 53 40 9 1 npn13G2 we=0.07 le=0.9 Nx=1 m=1
* device instance $521 r0 *1 32.3,276.22 npn13G2
Q$521 53 40 9 1 npn13G2 we=0.07 le=0.9 Nx=1 m=1
* device instance $522 r0 *1 43,276.22 npn13G2
Q$522 53 40 9 1 npn13G2 we=0.07 le=0.9 Nx=1 m=1
* device instance $523 r0 *1 53.7,276.22 npn13G2
Q$523 53 40 9 1 npn13G2 we=0.07 le=0.9 Nx=1 m=1
* device instance $524 r0 *1 64.4,276.22 npn13G2
Q$524 53 40 9 1 npn13G2 we=0.07 le=0.9 Nx=1 m=1
* device instance $525 r0 *1 75.1,276.22 npn13G2
Q$525 53 40 9 1 npn13G2 we=0.07 le=0.9 Nx=1 m=1
* device instance $526 r0 *1 85.8,276.22 npn13G2
Q$526 53 40 9 1 npn13G2 we=0.07 le=0.9 Nx=1 m=1
* device instance $527 r0 *1 96.5,276.22 npn13G2
Q$527 53 40 9 1 npn13G2 we=0.07 le=0.9 Nx=1 m=1
* device instance $528 r0 *1 107.2,276.22 npn13G2
Q$528 53 40 9 1 npn13G2 we=0.07 le=0.9 Nx=1 m=1
* device instance $529 r0 *1 117.9,276.22 npn13G2
Q$529 53 40 9 1 npn13G2 we=0.07 le=0.9 Nx=1 m=1
* device instance $530 r0 *1 128.6,276.22 npn13G2
Q$530 53 40 9 1 npn13G2 we=0.07 le=0.9 Nx=1 m=1
* device instance $531 r0 *1 139.3,276.22 npn13G2
Q$531 53 40 9 1 npn13G2 we=0.07 le=0.9 Nx=1 m=1
* device instance $532 r0 *1 150,276.22 npn13G2
Q$532 53 40 9 1 npn13G2 we=0.07 le=0.9 Nx=1 m=1
* device instance $533 r0 *1 160.7,276.22 npn13G2
Q$533 53 40 9 1 npn13G2 we=0.07 le=0.9 Nx=1 m=1
* device instance $534 r0 *1 171.4,276.22 npn13G2
Q$534 53 40 9 1 npn13G2 we=0.07 le=0.9 Nx=1 m=1
* device instance $535 r0 *1 182.1,276.22 npn13G2
Q$535 53 40 9 1 npn13G2 we=0.07 le=0.9 Nx=1 m=1
* device instance $536 r0 *1 10.9,287.33 npn13G2
Q$536 53 40 9 1 npn13G2 we=0.07 le=0.9 Nx=1 m=1
* device instance $537 r0 *1 21.6,287.33 npn13G2
Q$537 53 40 9 1 npn13G2 we=0.07 le=0.9 Nx=1 m=1
* device instance $538 r0 *1 32.3,287.33 npn13G2
Q$538 53 40 9 1 npn13G2 we=0.07 le=0.9 Nx=1 m=1
* device instance $539 r0 *1 43,287.33 npn13G2
Q$539 53 40 9 1 npn13G2 we=0.07 le=0.9 Nx=1 m=1
* device instance $540 r0 *1 53.7,287.33 npn13G2
Q$540 53 40 9 1 npn13G2 we=0.07 le=0.9 Nx=1 m=1
* device instance $541 r0 *1 64.4,287.33 npn13G2
Q$541 53 40 9 1 npn13G2 we=0.07 le=0.9 Nx=1 m=1
* device instance $542 r0 *1 75.1,287.33 npn13G2
Q$542 53 40 9 1 npn13G2 we=0.07 le=0.9 Nx=1 m=1
* device instance $543 r0 *1 85.8,287.33 npn13G2
Q$543 53 40 9 1 npn13G2 we=0.07 le=0.9 Nx=1 m=1
* device instance $544 r0 *1 96.5,287.33 npn13G2
Q$544 53 40 9 1 npn13G2 we=0.07 le=0.9 Nx=1 m=1
* device instance $545 r0 *1 107.2,287.33 npn13G2
Q$545 53 40 9 1 npn13G2 we=0.07 le=0.9 Nx=1 m=1
* device instance $546 r0 *1 117.9,287.33 npn13G2
Q$546 53 40 9 1 npn13G2 we=0.07 le=0.9 Nx=1 m=1
* device instance $547 r0 *1 128.6,287.33 npn13G2
Q$547 53 40 9 1 npn13G2 we=0.07 le=0.9 Nx=1 m=1
* device instance $548 r0 *1 139.3,287.33 npn13G2
Q$548 53 40 9 1 npn13G2 we=0.07 le=0.9 Nx=1 m=1
* device instance $549 r0 *1 150,287.33 npn13G2
Q$549 53 40 9 1 npn13G2 we=0.07 le=0.9 Nx=1 m=1
* device instance $550 r0 *1 160.7,287.33 npn13G2
Q$550 53 40 9 1 npn13G2 we=0.07 le=0.9 Nx=1 m=1
* device instance $551 r0 *1 171.4,287.33 npn13G2
Q$551 53 40 9 1 npn13G2 we=0.07 le=0.9 Nx=1 m=1
* device instance $552 r0 *1 182.1,287.33 npn13G2
Q$552 53 40 9 1 npn13G2 we=0.07 le=0.9 Nx=1 m=1
* device instance $553 r0 *1 10.9,298.44 npn13G2
Q$553 53 40 9 1 npn13G2 we=0.07 le=0.9 Nx=1 m=1
* device instance $554 r0 *1 21.6,298.44 npn13G2
Q$554 53 40 9 1 npn13G2 we=0.07 le=0.9 Nx=1 m=1
* device instance $555 r0 *1 32.3,298.44 npn13G2
Q$555 53 40 9 1 npn13G2 we=0.07 le=0.9 Nx=1 m=1
* device instance $556 r0 *1 43,298.44 npn13G2
Q$556 53 40 9 1 npn13G2 we=0.07 le=0.9 Nx=1 m=1
* device instance $557 r0 *1 53.7,298.44 npn13G2
Q$557 53 40 9 1 npn13G2 we=0.07 le=0.9 Nx=1 m=1
* device instance $558 r0 *1 64.4,298.44 npn13G2
Q$558 53 40 9 1 npn13G2 we=0.07 le=0.9 Nx=1 m=1
* device instance $559 r0 *1 75.1,298.44 npn13G2
Q$559 53 40 9 1 npn13G2 we=0.07 le=0.9 Nx=1 m=1
* device instance $560 r0 *1 85.8,298.44 npn13G2
Q$560 53 40 9 1 npn13G2 we=0.07 le=0.9 Nx=1 m=1
* device instance $561 r0 *1 96.5,298.44 npn13G2
Q$561 53 40 9 1 npn13G2 we=0.07 le=0.9 Nx=1 m=1
* device instance $562 r0 *1 107.2,298.44 npn13G2
Q$562 53 40 9 1 npn13G2 we=0.07 le=0.9 Nx=1 m=1
* device instance $563 r0 *1 117.9,298.44 npn13G2
Q$563 53 40 9 1 npn13G2 we=0.07 le=0.9 Nx=1 m=1
* device instance $564 r0 *1 128.6,298.44 npn13G2
Q$564 53 40 9 1 npn13G2 we=0.07 le=0.9 Nx=1 m=1
* device instance $565 r0 *1 139.3,298.44 npn13G2
Q$565 53 40 9 1 npn13G2 we=0.07 le=0.9 Nx=1 m=1
* device instance $566 r0 *1 150,298.44 npn13G2
Q$566 53 40 9 1 npn13G2 we=0.07 le=0.9 Nx=1 m=1
* device instance $567 r0 *1 160.7,298.44 npn13G2
Q$567 53 40 9 1 npn13G2 we=0.07 le=0.9 Nx=1 m=1
* device instance $568 r0 *1 171.4,298.44 npn13G2
Q$568 53 40 9 1 npn13G2 we=0.07 le=0.9 Nx=1 m=1
* device instance $569 r0 *1 182.1,298.44 npn13G2
Q$569 53 40 9 1 npn13G2 we=0.07 le=0.9 Nx=1 m=1
* device instance $570 r0 *1 10.9,309.55 npn13G2
Q$570 53 40 9 1 npn13G2 we=0.07 le=0.9 Nx=1 m=1
* device instance $571 r0 *1 21.6,309.55 npn13G2
Q$571 53 40 9 1 npn13G2 we=0.07 le=0.9 Nx=1 m=1
* device instance $572 r0 *1 32.3,309.55 npn13G2
Q$572 53 40 9 1 npn13G2 we=0.07 le=0.9 Nx=1 m=1
* device instance $573 r0 *1 43,309.55 npn13G2
Q$573 53 40 9 1 npn13G2 we=0.07 le=0.9 Nx=1 m=1
* device instance $574 r0 *1 53.7,309.55 npn13G2
Q$574 53 40 9 1 npn13G2 we=0.07 le=0.9 Nx=1 m=1
* device instance $575 r0 *1 64.4,309.55 npn13G2
Q$575 53 40 9 1 npn13G2 we=0.07 le=0.9 Nx=1 m=1
* device instance $576 r0 *1 75.1,309.55 npn13G2
Q$576 53 40 9 1 npn13G2 we=0.07 le=0.9 Nx=1 m=1
* device instance $577 r0 *1 85.8,309.55 npn13G2
Q$577 53 40 9 1 npn13G2 we=0.07 le=0.9 Nx=1 m=1
* device instance $578 r0 *1 96.5,309.55 npn13G2
Q$578 53 40 9 1 npn13G2 we=0.07 le=0.9 Nx=1 m=1
* device instance $579 r0 *1 107.2,309.55 npn13G2
Q$579 53 40 9 1 npn13G2 we=0.07 le=0.9 Nx=1 m=1
* device instance $580 r0 *1 117.9,309.55 npn13G2
Q$580 53 40 9 1 npn13G2 we=0.07 le=0.9 Nx=1 m=1
* device instance $581 r0 *1 128.6,309.55 npn13G2
Q$581 53 40 9 1 npn13G2 we=0.07 le=0.9 Nx=1 m=1
* device instance $582 r0 *1 139.3,309.55 npn13G2
Q$582 53 40 9 1 npn13G2 we=0.07 le=0.9 Nx=1 m=1
* device instance $583 r0 *1 150,309.55 npn13G2
Q$583 53 40 9 1 npn13G2 we=0.07 le=0.9 Nx=1 m=1
* device instance $584 r0 *1 160.7,309.55 npn13G2
Q$584 53 40 9 1 npn13G2 we=0.07 le=0.9 Nx=1 m=1
* device instance $585 r0 *1 171.4,309.55 npn13G2
Q$585 53 40 9 1 npn13G2 we=0.07 le=0.9 Nx=1 m=1
* device instance $586 r0 *1 182.1,309.55 npn13G2
Q$586 53 40 9 1 npn13G2 we=0.07 le=0.9 Nx=1 m=1
* device instance $587 r0 *1 10.9,320.66 npn13G2
Q$587 53 40 9 1 npn13G2 we=0.07 le=0.9 Nx=1 m=1
* device instance $588 r0 *1 21.6,320.66 npn13G2
Q$588 53 40 9 1 npn13G2 we=0.07 le=0.9 Nx=1 m=1
* device instance $589 r0 *1 32.3,320.66 npn13G2
Q$589 53 40 9 1 npn13G2 we=0.07 le=0.9 Nx=1 m=1
* device instance $590 r0 *1 43,320.66 npn13G2
Q$590 53 40 9 1 npn13G2 we=0.07 le=0.9 Nx=1 m=1
* device instance $591 r0 *1 53.7,320.66 npn13G2
Q$591 53 40 9 1 npn13G2 we=0.07 le=0.9 Nx=1 m=1
* device instance $592 r0 *1 64.4,320.66 npn13G2
Q$592 53 40 9 1 npn13G2 we=0.07 le=0.9 Nx=1 m=1
* device instance $593 r0 *1 75.1,320.66 npn13G2
Q$593 53 40 9 1 npn13G2 we=0.07 le=0.9 Nx=1 m=1
* device instance $594 r0 *1 85.8,320.66 npn13G2
Q$594 53 40 9 1 npn13G2 we=0.07 le=0.9 Nx=1 m=1
* device instance $595 r0 *1 96.5,320.66 npn13G2
Q$595 53 40 9 1 npn13G2 we=0.07 le=0.9 Nx=1 m=1
* device instance $596 r0 *1 107.2,320.66 npn13G2
Q$596 53 40 9 1 npn13G2 we=0.07 le=0.9 Nx=1 m=1
* device instance $597 r0 *1 117.9,320.66 npn13G2
Q$597 53 40 9 1 npn13G2 we=0.07 le=0.9 Nx=1 m=1
* device instance $598 r0 *1 128.6,320.66 npn13G2
Q$598 53 40 9 1 npn13G2 we=0.07 le=0.9 Nx=1 m=1
* device instance $599 r0 *1 139.3,320.66 npn13G2
Q$599 53 40 9 1 npn13G2 we=0.07 le=0.9 Nx=1 m=1
* device instance $600 r0 *1 150,320.66 npn13G2
Q$600 53 40 9 1 npn13G2 we=0.07 le=0.9 Nx=1 m=1
* device instance $601 r0 *1 160.7,320.66 npn13G2
Q$601 53 40 9 1 npn13G2 we=0.07 le=0.9 Nx=1 m=1
* device instance $602 r0 *1 171.4,320.66 npn13G2
Q$602 40 47 1 1 npn13G2 we=0.07 le=0.9 Nx=1 m=1
* device instance $603 r0 *1 182.1,320.66 npn13G2
Q$603 40 47 1 1 npn13G2 we=0.07 le=0.9 Nx=1 m=1
* device instance $604 r0 *1 10.9,331.77 npn13G2
Q$604 40 47 1 1 npn13G2 we=0.07 le=0.9 Nx=1 m=1
* device instance $605 r0 *1 21.6,331.77 npn13G2
Q$605 40 47 1 1 npn13G2 we=0.07 le=0.9 Nx=1 m=1
* device instance $606 r0 *1 32.3,331.77 npn13G2
Q$606 40 47 1 1 npn13G2 we=0.07 le=0.9 Nx=1 m=1
* device instance $607 r0 *1 43,331.77 npn13G2
Q$607 40 47 1 1 npn13G2 we=0.07 le=0.9 Nx=1 m=1
* device instance $608 r0 *1 53.7,331.77 npn13G2
Q$608 40 47 1 1 npn13G2 we=0.07 le=0.9 Nx=1 m=1
* device instance $609 r0 *1 64.4,331.77 npn13G2
Q$609 40 47 1 1 npn13G2 we=0.07 le=0.9 Nx=1 m=1
* device instance $610 r0 *1 75.1,331.77 npn13G2
Q$610 40 47 1 1 npn13G2 we=0.07 le=0.9 Nx=1 m=1
* device instance $611 r0 *1 85.8,331.77 npn13G2
Q$611 40 47 1 1 npn13G2 we=0.07 le=0.9 Nx=1 m=1
* device instance $612 r0 *1 96.5,331.77 npn13G2
Q$612 40 47 1 1 npn13G2 we=0.07 le=0.9 Nx=1 m=1
* device instance $613 r0 *1 107.2,331.77 npn13G2
Q$613 40 47 1 1 npn13G2 we=0.07 le=0.9 Nx=1 m=1
* device instance $614 r0 *1 117.9,331.77 npn13G2
Q$614 41 41 1 1 npn13G2 we=0.07 le=0.9 Nx=1 m=1
* device instance $615 r0 *1 128.6,331.77 npn13G2
Q$615 41 41 1 1 npn13G2 we=0.07 le=0.9 Nx=1 m=1
* device instance $616 r0 *1 139.3,331.77 npn13G2
Q$616 41 41 1 1 npn13G2 we=0.07 le=0.9 Nx=1 m=1
* device instance $617 r0 *1 150,331.77 npn13G2
Q$617 41 41 1 1 npn13G2 we=0.07 le=0.9 Nx=1 m=1
* device instance $618 r0 *1 160.7,331.77 npn13G2
Q$618 41 41 1 1 npn13G2 we=0.07 le=0.9 Nx=1 m=1
* device instance $619 r0 *1 171.4,331.77 npn13G2
Q$619 41 41 1 1 npn13G2 we=0.07 le=0.9 Nx=1 m=1
* device instance $620 r0 *1 182.1,331.77 npn13G2
Q$620 41 41 1 1 npn13G2 we=0.07 le=0.9 Nx=1 m=1
* device instance $621 r0 *1 10.9,342.88 npn13G2
Q$621 41 41 1 1 npn13G2 we=0.07 le=0.9 Nx=1 m=1
* device instance $622 r0 *1 21.6,342.88 npn13G2
Q$622 41 41 1 1 npn13G2 we=0.07 le=0.9 Nx=1 m=1
* device instance $623 r0 *1 32.3,342.88 npn13G2
Q$623 41 41 1 1 npn13G2 we=0.07 le=0.9 Nx=1 m=1
* device instance $624 r0 *1 43,342.88 npn13G2
Q$624 41 41 1 1 npn13G2 we=0.07 le=0.9 Nx=1 m=1
* device instance $625 r0 *1 53.7,342.88 npn13G2
Q$625 41 41 1 1 npn13G2 we=0.07 le=0.9 Nx=1 m=1
* device instance $626 r0 *1 64.4,342.88 npn13G2
Q$626 40 40 1 1 npn13G2 we=0.07 le=0.9 Nx=1 m=1
* device instance $627 r0 *1 75.1,342.88 npn13G2
Q$627 40 40 1 1 npn13G2 we=0.07 le=0.9 Nx=1 m=1
* device instance $628 r0 *1 85.8,342.88 npn13G2
Q$628 40 40 1 1 npn13G2 we=0.07 le=0.9 Nx=1 m=1
* device instance $629 r0 *1 96.5,342.88 npn13G2
Q$629 40 40 1 1 npn13G2 we=0.07 le=0.9 Nx=1 m=1
* device instance $630 r0 *1 107.2,342.88 npn13G2
Q$630 40 40 1 1 npn13G2 we=0.07 le=0.9 Nx=1 m=1
* device instance $631 r0 *1 117.9,342.88 npn13G2
Q$631 40 40 1 1 npn13G2 we=0.07 le=0.9 Nx=1 m=1
* device instance $632 r0 *1 128.6,342.88 npn13G2
Q$632 40 40 1 1 npn13G2 we=0.07 le=0.9 Nx=1 m=1
* device instance $633 r0 *1 139.3,342.88 npn13G2
Q$633 40 40 1 1 npn13G2 we=0.07 le=0.9 Nx=1 m=1
* device instance $634 r0 *1 150,342.88 npn13G2
Q$634 40 40 1 1 npn13G2 we=0.07 le=0.9 Nx=1 m=1
* device instance $635 r0 *1 160.7,342.88 npn13G2
Q$635 40 40 1 1 npn13G2 we=0.07 le=0.9 Nx=1 m=1
* device instance $636 r0 *1 171.4,342.88 npn13G2
Q$636 40 40 1 1 npn13G2 we=0.07 le=0.9 Nx=1 m=1
* device instance $637 r0 *1 182.1,342.88 npn13G2
Q$637 40 40 1 1 npn13G2 we=0.07 le=0.9 Nx=1 m=1
* device instance $638 r0 *1 362.445,10.605 rppd
R$638 34 38 1 1 rppd l=53.465 ps=0 b=0 m=1
* device instance $639 r0 *1 364.345,10.605 rppd
R$639 34 38 1 1 rppd l=53.465 ps=0 b=0 m=1
* device instance $640 r0 *1 366.245,10.605 rppd
R$640 19 29 1 1 rppd l=53.465 ps=0 b=0 m=1
* device instance $641 r0 *1 368.145,10.605 rppd
R$641 19 29 1 1 rppd l=53.465 ps=0 b=0 m=1
* device instance $642 r0 *1 370.045,10.605 rppd
R$642 34 29 1 1 rppd l=53.465 ps=0 b=0 m=1
* device instance $643 r0 *1 371.945,10.605 rppd
R$643 34 29 1 1 rppd l=53.465 ps=0 b=0 m=1
* device instance $644 r0 *1 373.845,10.605 rppd
R$644 19 28 1 1 rppd l=53.465 ps=0 b=0 m=1
* device instance $645 r0 *1 375.745,10.605 rppd
R$645 19 28 1 1 rppd l=53.465 ps=0 b=0 m=1
* device instance $646 r0 *1 377.645,10.605 rppd
R$646 33 28 1 1 rppd l=53.465 ps=0 b=0 m=1
* device instance $647 r0 *1 379.545,10.605 rppd
R$647 33 28 1 1 rppd l=53.465 ps=0 b=0 m=1
* device instance $648 r0 *1 381.445,10.605 rppd
R$648 33 37 1 1 rppd l=53.465 ps=0 b=0 m=1
* device instance $649 r0 *1 383.345,10.605 rppd
R$649 33 37 1 1 rppd l=53.465 ps=0 b=0 m=1
* device instance $650 r0 *1 20.445,11.585 rppd
R$650 1 9 1 1 rppd l=51.5 ps=0 b=0 m=1
* device instance $651 r0 *1 22.345,11.585 rppd
R$651 1 9 1 1 rppd l=51.5 ps=0 b=0 m=1
* device instance $652 r0 *1 24.245,11.585 rppd
R$652 1 9 1 1 rppd l=51.5 ps=0 b=0 m=1
* device instance $653 r0 *1 26.145,11.585 rppd
R$653 1 9 1 1 rppd l=51.5 ps=0 b=0 m=1
* device instance $654 r0 *1 28.045,11.585 rppd
R$654 1 9 1 1 rppd l=51.5 ps=0 b=0 m=1
* device instance $655 r0 *1 29.945,11.585 rppd
R$655 1 9 1 1 rppd l=51.5 ps=0 b=0 m=1
* device instance $656 r0 *1 31.845,11.585 rppd
R$656 1 9 1 1 rppd l=51.5 ps=0 b=0 m=1
* device instance $657 r0 *1 33.745,11.585 rppd
R$657 1 9 1 1 rppd l=51.5 ps=0 b=0 m=1
* device instance $658 r0 *1 35.645,11.585 rppd
R$658 1 9 1 1 rppd l=51.5 ps=0 b=0 m=1
* device instance $659 r0 *1 37.545,11.585 rppd
R$659 1 9 1 1 rppd l=51.5 ps=0 b=0 m=1
* device instance $660 r0 *1 39.445,11.585 rppd
R$660 1 9 1 1 rppd l=51.5 ps=0 b=0 m=1
* device instance $661 r0 *1 41.345,11.585 rppd
R$661 1 9 1 1 rppd l=51.5 ps=0 b=0 m=1
* device instance $662 r0 *1 134.445,12.335 rppd
R$662 30 36 1 1 rppd l=50 ps=0 b=0 m=1
* device instance $663 r0 *1 136.345,12.335 rppd
R$663 30 36 1 1 rppd l=50 ps=0 b=0 m=1
* device instance $664 r0 *1 138.245,12.335 rppd
R$664 30 36 1 1 rppd l=50 ps=0 b=0 m=1
* device instance $665 r0 *1 140.145,12.335 rppd
R$665 30 36 1 1 rppd l=50 ps=0 b=0 m=1
* device instance $666 r0 *1 142.045,12.335 rppd
R$666 30 36 1 1 rppd l=50 ps=0 b=0 m=1
* device instance $667 r0 *1 143.945,12.335 rppd
R$667 30 36 1 1 rppd l=50 ps=0 b=0 m=1
* device instance $668 r0 *1 145.845,12.335 rppd
R$668 30 36 1 1 rppd l=50 ps=0 b=0 m=1
* device instance $669 r0 *1 147.745,12.335 rppd
R$669 30 36 1 1 rppd l=50 ps=0 b=0 m=1
* device instance $670 r0 *1 149.645,12.335 rppd
R$670 30 36 1 1 rppd l=50 ps=0 b=0 m=1
* device instance $671 r0 *1 151.545,12.335 rppd
R$671 30 36 1 1 rppd l=50 ps=0 b=0 m=1
* device instance $672 r0 *1 153.445,12.335 rppd
R$672 30 36 1 1 rppd l=50 ps=0 b=0 m=1
* device instance $673 r0 *1 155.345,12.335 rppd
R$673 30 36 1 1 rppd l=50 ps=0 b=0 m=1
* device instance $674 r0 *1 157.245,12.335 rppd
R$674 10 32 1 1 rppd l=50 ps=0 b=0 m=1
* device instance $675 r0 *1 159.145,12.335 rppd
R$675 10 32 1 1 rppd l=50 ps=0 b=0 m=1
* device instance $676 r0 *1 161.045,12.335 rppd
R$676 10 32 1 1 rppd l=50 ps=0 b=0 m=1
* device instance $677 r0 *1 162.945,12.335 rppd
R$677 10 32 1 1 rppd l=50 ps=0 b=0 m=1
* device instance $678 r0 *1 164.845,12.335 rppd
R$678 10 32 1 1 rppd l=50 ps=0 b=0 m=1
* device instance $679 r0 *1 166.745,12.335 rppd
R$679 10 32 1 1 rppd l=50 ps=0 b=0 m=1
* device instance $680 r0 *1 168.645,12.335 rppd
R$680 10 32 1 1 rppd l=50 ps=0 b=0 m=1
* device instance $681 r0 *1 170.545,12.335 rppd
R$681 10 32 1 1 rppd l=50 ps=0 b=0 m=1
* device instance $682 r0 *1 172.445,12.335 rppd
R$682 10 32 1 1 rppd l=50 ps=0 b=0 m=1
* device instance $683 r0 *1 174.345,12.335 rppd
R$683 10 32 1 1 rppd l=50 ps=0 b=0 m=1
* device instance $684 r0 *1 176.245,12.335 rppd
R$684 10 32 1 1 rppd l=50 ps=0 b=0 m=1
* device instance $685 r0 *1 178.145,12.335 rppd
R$685 10 32 1 1 rppd l=50 ps=0 b=0 m=1
* device instance $686 r0 *1 180.045,12.335 rppd
R$686 11 32 1 1 rppd l=50 ps=0 b=0 m=1
* device instance $687 r0 *1 181.945,12.335 rppd
R$687 11 32 1 1 rppd l=50 ps=0 b=0 m=1
* device instance $688 r0 *1 183.845,12.335 rppd
R$688 11 32 1 1 rppd l=50 ps=0 b=0 m=1
* device instance $689 r0 *1 185.745,12.335 rppd
R$689 11 32 1 1 rppd l=50 ps=0 b=0 m=1
* device instance $690 r0 *1 187.645,12.335 rppd
R$690 11 32 1 1 rppd l=50 ps=0 b=0 m=1
* device instance $691 r0 *1 189.545,12.335 rppd
R$691 11 32 1 1 rppd l=50 ps=0 b=0 m=1
* device instance $692 r0 *1 191.445,12.335 rppd
R$692 11 32 1 1 rppd l=50 ps=0 b=0 m=1
* device instance $693 r0 *1 193.345,12.335 rppd
R$693 11 32 1 1 rppd l=50 ps=0 b=0 m=1
* device instance $694 r0 *1 195.245,12.335 rppd
R$694 11 32 1 1 rppd l=50 ps=0 b=0 m=1
* device instance $695 r0 *1 197.145,12.335 rppd
R$695 11 32 1 1 rppd l=50 ps=0 b=0 m=1
* device instance $696 r0 *1 199.045,12.335 rppd
R$696 11 32 1 1 rppd l=50 ps=0 b=0 m=1
* device instance $697 r0 *1 200.945,12.335 rppd
R$697 11 32 1 1 rppd l=50 ps=0 b=0 m=1
* device instance $698 r0 *1 202.845,12.335 rppd
R$698 24 27 1 1 rppd l=50 ps=0 b=0 m=1
* device instance $699 r0 *1 204.745,12.335 rppd
R$699 24 27 1 1 rppd l=50 ps=0 b=0 m=1
* device instance $700 r0 *1 206.645,12.335 rppd
R$700 24 27 1 1 rppd l=50 ps=0 b=0 m=1
* device instance $701 r0 *1 208.545,12.335 rppd
R$701 24 27 1 1 rppd l=50 ps=0 b=0 m=1
* device instance $702 r0 *1 210.445,12.335 rppd
R$702 24 27 1 1 rppd l=50 ps=0 b=0 m=1
* device instance $703 r0 *1 212.345,12.335 rppd
R$703 24 27 1 1 rppd l=50 ps=0 b=0 m=1
* device instance $704 r0 *1 214.245,12.335 rppd
R$704 24 27 1 1 rppd l=50 ps=0 b=0 m=1
* device instance $705 r0 *1 216.145,12.335 rppd
R$705 24 27 1 1 rppd l=50 ps=0 b=0 m=1
* device instance $706 r0 *1 218.045,12.335 rppd
R$706 24 27 1 1 rppd l=50 ps=0 b=0 m=1
* device instance $707 r0 *1 219.945,12.335 rppd
R$707 24 27 1 1 rppd l=50 ps=0 b=0 m=1
* device instance $708 r0 *1 221.845,12.335 rppd
R$708 24 27 1 1 rppd l=50 ps=0 b=0 m=1
* device instance $709 r0 *1 223.745,12.335 rppd
R$709 24 27 1 1 rppd l=50 ps=0 b=0 m=1
* device instance $710 r0 *1 225.645,12.335 rppd
R$710 11 25 1 1 rppd l=50 ps=0 b=0 m=1
* device instance $711 r0 *1 227.545,12.335 rppd
R$711 11 25 1 1 rppd l=50 ps=0 b=0 m=1
* device instance $712 r0 *1 229.445,12.335 rppd
R$712 11 25 1 1 rppd l=50 ps=0 b=0 m=1
* device instance $713 r0 *1 231.345,12.335 rppd
R$713 11 25 1 1 rppd l=50 ps=0 b=0 m=1
* device instance $714 r0 *1 233.245,12.335 rppd
R$714 11 25 1 1 rppd l=50 ps=0 b=0 m=1
* device instance $715 r0 *1 235.145,12.335 rppd
R$715 11 25 1 1 rppd l=50 ps=0 b=0 m=1
* device instance $716 r0 *1 237.045,12.335 rppd
R$716 11 25 1 1 rppd l=50 ps=0 b=0 m=1
* device instance $717 r0 *1 238.945,12.335 rppd
R$717 11 25 1 1 rppd l=50 ps=0 b=0 m=1
* device instance $718 r0 *1 240.845,12.335 rppd
R$718 11 25 1 1 rppd l=50 ps=0 b=0 m=1
* device instance $719 r0 *1 242.745,12.335 rppd
R$719 11 25 1 1 rppd l=50 ps=0 b=0 m=1
* device instance $720 r0 *1 244.645,12.335 rppd
R$720 11 25 1 1 rppd l=50 ps=0 b=0 m=1
* device instance $721 r0 *1 246.545,12.335 rppd
R$721 11 25 1 1 rppd l=50 ps=0 b=0 m=1
* device instance $722 r0 *1 248.445,12.335 rppd
R$722 31 27 1 1 rppd l=50 ps=0 b=0 m=1
* device instance $723 r0 *1 250.345,12.335 rppd
R$723 31 27 1 1 rppd l=50 ps=0 b=0 m=1
* device instance $724 r0 *1 252.245,12.335 rppd
R$724 31 27 1 1 rppd l=50 ps=0 b=0 m=1
* device instance $725 r0 *1 254.145,12.335 rppd
R$725 31 27 1 1 rppd l=50 ps=0 b=0 m=1
* device instance $726 r0 *1 256.045,12.335 rppd
R$726 31 27 1 1 rppd l=50 ps=0 b=0 m=1
* device instance $727 r0 *1 257.945,12.335 rppd
R$727 31 27 1 1 rppd l=50 ps=0 b=0 m=1
* device instance $728 r0 *1 259.845,12.335 rppd
R$728 31 27 1 1 rppd l=50 ps=0 b=0 m=1
* device instance $729 r0 *1 261.745,12.335 rppd
R$729 31 27 1 1 rppd l=50 ps=0 b=0 m=1
* device instance $730 r0 *1 263.645,12.335 rppd
R$730 31 27 1 1 rppd l=50 ps=0 b=0 m=1
* device instance $731 r0 *1 265.545,12.335 rppd
R$731 31 27 1 1 rppd l=50 ps=0 b=0 m=1
* device instance $732 r0 *1 267.445,12.335 rppd
R$732 31 27 1 1 rppd l=50 ps=0 b=0 m=1
* device instance $733 r0 *1 269.345,12.335 rppd
R$733 31 27 1 1 rppd l=50 ps=0 b=0 m=1
* device instance $734 r0 *1 271.245,12.335 rppd
R$734 31 26 1 1 rppd l=50 ps=0 b=0 m=1
* device instance $735 r0 *1 273.145,12.335 rppd
R$735 31 26 1 1 rppd l=50 ps=0 b=0 m=1
* device instance $736 r0 *1 275.045,12.335 rppd
R$736 31 26 1 1 rppd l=50 ps=0 b=0 m=1
* device instance $737 r0 *1 276.945,12.335 rppd
R$737 31 26 1 1 rppd l=50 ps=0 b=0 m=1
* device instance $738 r0 *1 278.845,12.335 rppd
R$738 31 26 1 1 rppd l=50 ps=0 b=0 m=1
* device instance $739 r0 *1 280.745,12.335 rppd
R$739 31 26 1 1 rppd l=50 ps=0 b=0 m=1
* device instance $740 r0 *1 282.645,12.335 rppd
R$740 31 26 1 1 rppd l=50 ps=0 b=0 m=1
* device instance $741 r0 *1 284.545,12.335 rppd
R$741 31 26 1 1 rppd l=50 ps=0 b=0 m=1
* device instance $742 r0 *1 286.445,12.335 rppd
R$742 31 26 1 1 rppd l=50 ps=0 b=0 m=1
* device instance $743 r0 *1 288.345,12.335 rppd
R$743 31 26 1 1 rppd l=50 ps=0 b=0 m=1
* device instance $744 r0 *1 290.245,12.335 rppd
R$744 31 26 1 1 rppd l=50 ps=0 b=0 m=1
* device instance $745 r0 *1 292.145,12.335 rppd
R$745 31 26 1 1 rppd l=50 ps=0 b=0 m=1
* device instance $746 r0 *1 294.045,12.335 rppd
R$746 30 26 1 1 rppd l=50 ps=0 b=0 m=1
* device instance $747 r0 *1 295.945,12.335 rppd
R$747 30 26 1 1 rppd l=50 ps=0 b=0 m=1
* device instance $748 r0 *1 297.845,12.335 rppd
R$748 30 26 1 1 rppd l=50 ps=0 b=0 m=1
* device instance $749 r0 *1 299.745,12.335 rppd
R$749 30 26 1 1 rppd l=50 ps=0 b=0 m=1
* device instance $750 r0 *1 301.645,12.335 rppd
R$750 30 26 1 1 rppd l=50 ps=0 b=0 m=1
* device instance $751 r0 *1 303.545,12.335 rppd
R$751 30 26 1 1 rppd l=50 ps=0 b=0 m=1
* device instance $752 r0 *1 305.445,12.335 rppd
R$752 30 26 1 1 rppd l=50 ps=0 b=0 m=1
* device instance $753 r0 *1 307.345,12.335 rppd
R$753 30 26 1 1 rppd l=50 ps=0 b=0 m=1
* device instance $754 r0 *1 309.245,12.335 rppd
R$754 30 26 1 1 rppd l=50 ps=0 b=0 m=1
* device instance $755 r0 *1 311.145,12.335 rppd
R$755 30 26 1 1 rppd l=50 ps=0 b=0 m=1
* device instance $756 r0 *1 313.045,12.335 rppd
R$756 30 26 1 1 rppd l=50 ps=0 b=0 m=1
* device instance $757 r0 *1 314.945,12.335 rppd
R$757 30 26 1 1 rppd l=50 ps=0 b=0 m=1
* device instance $758 r0 *1 316.845,12.335 rppd
R$758 24 25 1 1 rppd l=50 ps=0 b=0 m=1
* device instance $759 r0 *1 318.745,12.335 rppd
R$759 24 25 1 1 rppd l=50 ps=0 b=0 m=1
* device instance $760 r0 *1 320.645,12.335 rppd
R$760 24 25 1 1 rppd l=50 ps=0 b=0 m=1
* device instance $761 r0 *1 322.545,12.335 rppd
R$761 24 25 1 1 rppd l=50 ps=0 b=0 m=1
* device instance $762 r0 *1 324.445,12.335 rppd
R$762 24 25 1 1 rppd l=50 ps=0 b=0 m=1
* device instance $763 r0 *1 326.345,12.335 rppd
R$763 24 25 1 1 rppd l=50 ps=0 b=0 m=1
* device instance $764 r0 *1 328.245,12.335 rppd
R$764 24 25 1 1 rppd l=50 ps=0 b=0 m=1
* device instance $765 r0 *1 330.145,12.335 rppd
R$765 24 25 1 1 rppd l=50 ps=0 b=0 m=1
* device instance $766 r0 *1 332.045,12.335 rppd
R$766 24 25 1 1 rppd l=50 ps=0 b=0 m=1
* device instance $767 r0 *1 333.945,12.335 rppd
R$767 24 25 1 1 rppd l=50 ps=0 b=0 m=1
* device instance $768 r0 *1 335.845,12.335 rppd
R$768 24 25 1 1 rppd l=50 ps=0 b=0 m=1
* device instance $769 r0 *1 337.745,12.335 rppd
R$769 24 25 1 1 rppd l=50 ps=0 b=0 m=1
* device instance $770 r0 *1 339.645,12.335 rppd
R$770 10 35 1 1 rppd l=50 ps=0 b=0 m=1
* device instance $771 r0 *1 341.545,12.335 rppd
R$771 10 35 1 1 rppd l=50 ps=0 b=0 m=1
* device instance $772 r0 *1 343.445,12.335 rppd
R$772 10 35 1 1 rppd l=50 ps=0 b=0 m=1
* device instance $773 r0 *1 345.345,12.335 rppd
R$773 10 35 1 1 rppd l=50 ps=0 b=0 m=1
* device instance $774 r0 *1 347.245,12.335 rppd
R$774 10 35 1 1 rppd l=50 ps=0 b=0 m=1
* device instance $775 r0 *1 349.145,12.335 rppd
R$775 10 35 1 1 rppd l=50 ps=0 b=0 m=1
* device instance $776 r0 *1 351.045,12.335 rppd
R$776 10 35 1 1 rppd l=50 ps=0 b=0 m=1
* device instance $777 r0 *1 352.945,12.335 rppd
R$777 10 35 1 1 rppd l=50 ps=0 b=0 m=1
* device instance $778 r0 *1 354.845,12.335 rppd
R$778 10 35 1 1 rppd l=50 ps=0 b=0 m=1
* device instance $779 r0 *1 356.745,12.335 rppd
R$779 10 35 1 1 rppd l=50 ps=0 b=0 m=1
* device instance $780 r0 *1 358.645,12.335 rppd
R$780 10 35 1 1 rppd l=50 ps=0 b=0 m=1
* device instance $781 r0 *1 360.545,12.335 rppd
R$781 10 35 1 1 rppd l=50 ps=0 b=0 m=1
* device instance $782 r0 *1 35.645,72.605 rppd
R$782 33 37 1 1 rppd l=53.465 ps=0 b=0 m=1
* device instance $783 r0 *1 37.545,72.605 rppd
R$783 33 37 1 1 rppd l=53.465 ps=0 b=0 m=1
* device instance $784 r0 *1 39.445,72.605 rppd
R$784 33 28 1 1 rppd l=53.465 ps=0 b=0 m=1
* device instance $785 r0 *1 41.345,72.605 rppd
R$785 33 28 1 1 rppd l=53.465 ps=0 b=0 m=1
* device instance $786 r0 *1 43.245,72.605 rppd
R$786 19 28 1 1 rppd l=53.465 ps=0 b=0 m=1
* device instance $787 r0 *1 43.245,13.335 rppd
R$787 2 45 1 1 rppd l=48 ps=0 b=0 m=1
* device instance $788 r0 *1 45.145,72.605 rppd
R$788 19 28 1 1 rppd l=53.465 ps=0 b=0 m=1
* device instance $789 r0 *1 45.145,13.335 rppd
R$789 2 45 1 1 rppd l=48 ps=0 b=0 m=1
* device instance $790 r0 *1 47.045,72.605 rppd
R$790 34 29 1 1 rppd l=53.465 ps=0 b=0 m=1
* device instance $791 r0 *1 47.045,13.335 rppd
R$791 2 45 1 1 rppd l=48 ps=0 b=0 m=1
* device instance $792 r0 *1 48.945,13.335 rppd
R$792 2 45 1 1 rppd l=48 ps=0 b=0 m=1
* device instance $793 r0 *1 48.945,72.605 rppd
R$793 34 29 1 1 rppd l=53.465 ps=0 b=0 m=1
* device instance $794 r0 *1 50.845,13.335 rppd
R$794 2 45 1 1 rppd l=48 ps=0 b=0 m=1
* device instance $795 r0 *1 50.845,72.605 rppd
R$795 19 29 1 1 rppd l=53.465 ps=0 b=0 m=1
* device instance $796 r0 *1 52.745,13.335 rppd
R$796 2 45 1 1 rppd l=48 ps=0 b=0 m=1
* device instance $797 r0 *1 52.745,72.605 rppd
R$797 19 29 1 1 rppd l=53.465 ps=0 b=0 m=1
* device instance $798 r0 *1 54.645,72.605 rppd
R$798 34 38 1 1 rppd l=53.465 ps=0 b=0 m=1
* device instance $799 r0 *1 54.645,13.335 rppd
R$799 2 45 1 1 rppd l=48 ps=0 b=0 m=1
* device instance $800 r0 *1 56.545,13.335 rppd
R$800 2 45 1 1 rppd l=48 ps=0 b=0 m=1
* device instance $801 r0 *1 56.545,72.605 rppd
R$801 34 38 1 1 rppd l=53.465 ps=0 b=0 m=1
* device instance $802 r0 *1 58.445,13.335 rppd
R$802 2 45 1 1 rppd l=48 ps=0 b=0 m=1
* device instance $803 r0 *1 60.345,13.335 rppd
R$803 2 45 1 1 rppd l=48 ps=0 b=0 m=1
* device instance $804 r0 *1 62.245,13.335 rppd
R$804 2 45 1 1 rppd l=48 ps=0 b=0 m=1
* device instance $805 r0 *1 64.145,13.335 rppd
R$805 2 45 1 1 rppd l=48 ps=0 b=0 m=1
* device instance $806 r0 *1 66.045,13.335 rppd
R$806 3 39 1 1 rppd l=48 ps=0 b=0 m=1
* device instance $807 r0 *1 67.945,13.335 rppd
R$807 3 39 1 1 rppd l=48 ps=0 b=0 m=1
* device instance $808 r0 *1 69.845,13.335 rppd
R$808 3 39 1 1 rppd l=48 ps=0 b=0 m=1
* device instance $809 r0 *1 71.745,13.335 rppd
R$809 3 39 1 1 rppd l=48 ps=0 b=0 m=1
* device instance $810 r0 *1 73.645,13.335 rppd
R$810 3 39 1 1 rppd l=48 ps=0 b=0 m=1
* device instance $811 r0 *1 75.545,13.335 rppd
R$811 3 39 1 1 rppd l=48 ps=0 b=0 m=1
* device instance $812 r0 *1 77.445,13.335 rppd
R$812 3 39 1 1 rppd l=48 ps=0 b=0 m=1
* device instance $813 r0 *1 79.345,13.335 rppd
R$813 3 39 1 1 rppd l=48 ps=0 b=0 m=1
* device instance $814 r0 *1 81.245,13.335 rppd
R$814 3 39 1 1 rppd l=48 ps=0 b=0 m=1
* device instance $815 r0 *1 83.145,13.335 rppd
R$815 3 39 1 1 rppd l=48 ps=0 b=0 m=1
* device instance $816 r0 *1 85.045,13.335 rppd
R$816 3 39 1 1 rppd l=48 ps=0 b=0 m=1
* device instance $817 r0 *1 86.945,13.335 rppd
R$817 3 39 1 1 rppd l=48 ps=0 b=0 m=1
* device instance $818 r0 *1 88.845,13.335 rppd
R$818 2 20 1 1 rppd l=48 ps=0 b=0 m=1
* device instance $819 r0 *1 90.745,13.335 rppd
R$819 2 20 1 1 rppd l=48 ps=0 b=0 m=1
* device instance $820 r0 *1 92.645,13.335 rppd
R$820 2 20 1 1 rppd l=48 ps=0 b=0 m=1
* device instance $821 r0 *1 94.545,13.335 rppd
R$821 2 20 1 1 rppd l=48 ps=0 b=0 m=1
* device instance $822 r0 *1 96.445,13.335 rppd
R$822 2 20 1 1 rppd l=48 ps=0 b=0 m=1
* device instance $823 r0 *1 98.345,13.335 rppd
R$823 2 20 1 1 rppd l=48 ps=0 b=0 m=1
* device instance $824 r0 *1 100.245,13.335 rppd
R$824 2 20 1 1 rppd l=48 ps=0 b=0 m=1
* device instance $825 r0 *1 102.145,13.335 rppd
R$825 2 20 1 1 rppd l=48 ps=0 b=0 m=1
* device instance $826 r0 *1 104.045,13.335 rppd
R$826 2 20 1 1 rppd l=48 ps=0 b=0 m=1
* device instance $827 r0 *1 105.945,13.335 rppd
R$827 2 20 1 1 rppd l=48 ps=0 b=0 m=1
* device instance $828 r0 *1 107.845,13.335 rppd
R$828 2 20 1 1 rppd l=48 ps=0 b=0 m=1
* device instance $829 r0 *1 109.745,13.335 rppd
R$829 2 20 1 1 rppd l=48 ps=0 b=0 m=1
* device instance $830 r0 *1 111.645,13.335 rppd
R$830 3 20 1 1 rppd l=48 ps=0 b=0 m=1
* device instance $831 r0 *1 113.545,13.335 rppd
R$831 3 20 1 1 rppd l=48 ps=0 b=0 m=1
* device instance $832 r0 *1 115.445,13.335 rppd
R$832 3 20 1 1 rppd l=48 ps=0 b=0 m=1
* device instance $833 r0 *1 117.345,13.335 rppd
R$833 3 20 1 1 rppd l=48 ps=0 b=0 m=1
* device instance $834 r0 *1 119.245,13.335 rppd
R$834 3 20 1 1 rppd l=48 ps=0 b=0 m=1
* device instance $835 r0 *1 121.145,13.335 rppd
R$835 3 20 1 1 rppd l=48 ps=0 b=0 m=1
* device instance $836 r0 *1 123.045,13.335 rppd
R$836 3 20 1 1 rppd l=48 ps=0 b=0 m=1
* device instance $837 r0 *1 124.945,13.335 rppd
R$837 3 20 1 1 rppd l=48 ps=0 b=0 m=1
* device instance $838 r0 *1 126.845,13.335 rppd
R$838 3 20 1 1 rppd l=48 ps=0 b=0 m=1
* device instance $839 r0 *1 128.745,13.335 rppd
R$839 3 20 1 1 rppd l=48 ps=0 b=0 m=1
* device instance $840 r0 *1 130.645,13.335 rppd
R$840 3 20 1 1 rppd l=48 ps=0 b=0 m=1
* device instance $841 r0 *1 132.545,13.335 rppd
R$841 3 20 1 1 rppd l=48 ps=0 b=0 m=1
* device instance $842 r0 *1 377.645,73.59 rppd
R$842 1 9 1 1 rppd l=51.5 ps=0 b=0 m=1
* device instance $843 r0 *1 379.545,73.59 rppd
R$843 1 9 1 1 rppd l=51.5 ps=0 b=0 m=1
* device instance $844 r0 *1 381.445,73.59 rppd
R$844 1 9 1 1 rppd l=51.5 ps=0 b=0 m=1
* device instance $845 r0 *1 383.345,73.59 rppd
R$845 1 9 1 1 rppd l=51.5 ps=0 b=0 m=1
* device instance $846 r0 *1 385.245,73.59 rppd
R$846 1 9 1 1 rppd l=51.5 ps=0 b=0 m=1
* device instance $847 r0 *1 387.145,73.59 rppd
R$847 1 9 1 1 rppd l=51.5 ps=0 b=0 m=1
* device instance $848 r0 *1 389.045,73.59 rppd
R$848 1 9 1 1 rppd l=51.5 ps=0 b=0 m=1
* device instance $849 r0 *1 390.945,73.59 rppd
R$849 1 9 1 1 rppd l=51.5 ps=0 b=0 m=1
* device instance $850 r0 *1 392.845,73.59 rppd
R$850 1 9 1 1 rppd l=51.5 ps=0 b=0 m=1
* device instance $851 r0 *1 394.745,73.59 rppd
R$851 1 9 1 1 rppd l=51.5 ps=0 b=0 m=1
* device instance $852 r0 *1 396.645,73.59 rppd
R$852 1 9 1 1 rppd l=51.5 ps=0 b=0 m=1
* device instance $853 r0 *1 398.545,73.59 rppd
R$853 1 9 1 1 rppd l=51.5 ps=0 b=0 m=1
* device instance $854 r0 *1 58.445,74.34 rppd
R$854 10 35 1 1 rppd l=50 ps=0 b=0 m=1
* device instance $855 r0 *1 60.345,74.34 rppd
R$855 10 35 1 1 rppd l=50 ps=0 b=0 m=1
* device instance $856 r0 *1 62.245,74.34 rppd
R$856 10 35 1 1 rppd l=50 ps=0 b=0 m=1
* device instance $857 r0 *1 64.145,74.34 rppd
R$857 10 35 1 1 rppd l=50 ps=0 b=0 m=1
* device instance $858 r0 *1 66.045,74.34 rppd
R$858 10 35 1 1 rppd l=50 ps=0 b=0 m=1
* device instance $859 r0 *1 67.945,74.34 rppd
R$859 10 35 1 1 rppd l=50 ps=0 b=0 m=1
* device instance $860 r0 *1 69.845,74.34 rppd
R$860 10 35 1 1 rppd l=50 ps=0 b=0 m=1
* device instance $861 r0 *1 71.745,74.34 rppd
R$861 10 35 1 1 rppd l=50 ps=0 b=0 m=1
* device instance $862 r0 *1 73.645,74.34 rppd
R$862 10 35 1 1 rppd l=50 ps=0 b=0 m=1
* device instance $863 r0 *1 75.545,74.34 rppd
R$863 10 35 1 1 rppd l=50 ps=0 b=0 m=1
* device instance $864 r0 *1 77.445,74.34 rppd
R$864 10 35 1 1 rppd l=50 ps=0 b=0 m=1
* device instance $865 r0 *1 79.345,74.34 rppd
R$865 10 35 1 1 rppd l=50 ps=0 b=0 m=1
* device instance $866 r0 *1 81.245,74.34 rppd
R$866 24 25 1 1 rppd l=50 ps=0 b=0 m=1
* device instance $867 r0 *1 83.145,74.34 rppd
R$867 24 25 1 1 rppd l=50 ps=0 b=0 m=1
* device instance $868 r0 *1 85.045,74.34 rppd
R$868 24 25 1 1 rppd l=50 ps=0 b=0 m=1
* device instance $869 r0 *1 86.945,74.34 rppd
R$869 24 25 1 1 rppd l=50 ps=0 b=0 m=1
* device instance $870 r0 *1 88.845,74.34 rppd
R$870 24 25 1 1 rppd l=50 ps=0 b=0 m=1
* device instance $871 r0 *1 90.745,74.34 rppd
R$871 24 25 1 1 rppd l=50 ps=0 b=0 m=1
* device instance $872 r0 *1 92.645,74.34 rppd
R$872 24 25 1 1 rppd l=50 ps=0 b=0 m=1
* device instance $873 r0 *1 94.545,74.34 rppd
R$873 24 25 1 1 rppd l=50 ps=0 b=0 m=1
* device instance $874 r0 *1 96.445,74.34 rppd
R$874 24 25 1 1 rppd l=50 ps=0 b=0 m=1
* device instance $875 r0 *1 98.345,74.34 rppd
R$875 24 25 1 1 rppd l=50 ps=0 b=0 m=1
* device instance $876 r0 *1 100.245,74.34 rppd
R$876 24 25 1 1 rppd l=50 ps=0 b=0 m=1
* device instance $877 r0 *1 102.145,74.34 rppd
R$877 24 25 1 1 rppd l=50 ps=0 b=0 m=1
* device instance $878 r0 *1 104.045,74.34 rppd
R$878 30 26 1 1 rppd l=50 ps=0 b=0 m=1
* device instance $879 r0 *1 105.945,74.34 rppd
R$879 30 26 1 1 rppd l=50 ps=0 b=0 m=1
* device instance $880 r0 *1 107.845,74.34 rppd
R$880 30 26 1 1 rppd l=50 ps=0 b=0 m=1
* device instance $881 r0 *1 109.745,74.34 rppd
R$881 30 26 1 1 rppd l=50 ps=0 b=0 m=1
* device instance $882 r0 *1 111.645,74.34 rppd
R$882 30 26 1 1 rppd l=50 ps=0 b=0 m=1
* device instance $883 r0 *1 113.545,74.34 rppd
R$883 30 26 1 1 rppd l=50 ps=0 b=0 m=1
* device instance $884 r0 *1 115.445,74.34 rppd
R$884 30 26 1 1 rppd l=50 ps=0 b=0 m=1
* device instance $885 r0 *1 117.345,74.34 rppd
R$885 30 26 1 1 rppd l=50 ps=0 b=0 m=1
* device instance $886 r0 *1 119.245,74.34 rppd
R$886 30 26 1 1 rppd l=50 ps=0 b=0 m=1
* device instance $887 r0 *1 121.145,74.34 rppd
R$887 30 26 1 1 rppd l=50 ps=0 b=0 m=1
* device instance $888 r0 *1 123.045,74.34 rppd
R$888 30 26 1 1 rppd l=50 ps=0 b=0 m=1
* device instance $889 r0 *1 124.945,74.34 rppd
R$889 30 26 1 1 rppd l=50 ps=0 b=0 m=1
* device instance $890 r0 *1 126.845,74.34 rppd
R$890 31 26 1 1 rppd l=50 ps=0 b=0 m=1
* device instance $891 r0 *1 128.745,74.34 rppd
R$891 31 26 1 1 rppd l=50 ps=0 b=0 m=1
* device instance $892 r0 *1 130.645,74.34 rppd
R$892 31 26 1 1 rppd l=50 ps=0 b=0 m=1
* device instance $893 r0 *1 132.545,74.34 rppd
R$893 31 26 1 1 rppd l=50 ps=0 b=0 m=1
* device instance $894 r0 *1 134.445,74.34 rppd
R$894 31 26 1 1 rppd l=50 ps=0 b=0 m=1
* device instance $895 r0 *1 136.345,74.34 rppd
R$895 31 26 1 1 rppd l=50 ps=0 b=0 m=1
* device instance $896 r0 *1 138.245,74.34 rppd
R$896 31 26 1 1 rppd l=50 ps=0 b=0 m=1
* device instance $897 r0 *1 140.145,74.34 rppd
R$897 31 26 1 1 rppd l=50 ps=0 b=0 m=1
* device instance $898 r0 *1 142.045,74.34 rppd
R$898 31 26 1 1 rppd l=50 ps=0 b=0 m=1
* device instance $899 r0 *1 143.945,74.34 rppd
R$899 31 26 1 1 rppd l=50 ps=0 b=0 m=1
* device instance $900 r0 *1 145.845,74.34 rppd
R$900 31 26 1 1 rppd l=50 ps=0 b=0 m=1
* device instance $901 r0 *1 147.745,74.34 rppd
R$901 31 26 1 1 rppd l=50 ps=0 b=0 m=1
* device instance $902 r0 *1 149.645,74.34 rppd
R$902 31 27 1 1 rppd l=50 ps=0 b=0 m=1
* device instance $903 r0 *1 151.545,74.34 rppd
R$903 31 27 1 1 rppd l=50 ps=0 b=0 m=1
* device instance $904 r0 *1 153.445,74.34 rppd
R$904 31 27 1 1 rppd l=50 ps=0 b=0 m=1
* device instance $905 r0 *1 155.345,74.34 rppd
R$905 31 27 1 1 rppd l=50 ps=0 b=0 m=1
* device instance $906 r0 *1 157.245,74.34 rppd
R$906 31 27 1 1 rppd l=50 ps=0 b=0 m=1
* device instance $907 r0 *1 159.145,74.34 rppd
R$907 31 27 1 1 rppd l=50 ps=0 b=0 m=1
* device instance $908 r0 *1 161.045,74.34 rppd
R$908 31 27 1 1 rppd l=50 ps=0 b=0 m=1
* device instance $909 r0 *1 162.945,74.34 rppd
R$909 31 27 1 1 rppd l=50 ps=0 b=0 m=1
* device instance $910 r0 *1 164.845,74.34 rppd
R$910 31 27 1 1 rppd l=50 ps=0 b=0 m=1
* device instance $911 r0 *1 166.745,74.34 rppd
R$911 31 27 1 1 rppd l=50 ps=0 b=0 m=1
* device instance $912 r0 *1 168.645,74.34 rppd
R$912 31 27 1 1 rppd l=50 ps=0 b=0 m=1
* device instance $913 r0 *1 170.545,74.34 rppd
R$913 31 27 1 1 rppd l=50 ps=0 b=0 m=1
* device instance $914 r0 *1 172.445,74.34 rppd
R$914 11 25 1 1 rppd l=50 ps=0 b=0 m=1
* device instance $915 r0 *1 174.345,74.34 rppd
R$915 11 25 1 1 rppd l=50 ps=0 b=0 m=1
* device instance $916 r0 *1 176.245,74.34 rppd
R$916 11 25 1 1 rppd l=50 ps=0 b=0 m=1
* device instance $917 r0 *1 178.145,74.34 rppd
R$917 11 25 1 1 rppd l=50 ps=0 b=0 m=1
* device instance $918 r0 *1 180.045,74.34 rppd
R$918 11 25 1 1 rppd l=50 ps=0 b=0 m=1
* device instance $919 r0 *1 181.945,74.34 rppd
R$919 11 25 1 1 rppd l=50 ps=0 b=0 m=1
* device instance $920 r0 *1 183.845,74.34 rppd
R$920 11 25 1 1 rppd l=50 ps=0 b=0 m=1
* device instance $921 r0 *1 185.745,74.34 rppd
R$921 11 25 1 1 rppd l=50 ps=0 b=0 m=1
* device instance $922 r0 *1 187.645,74.34 rppd
R$922 11 25 1 1 rppd l=50 ps=0 b=0 m=1
* device instance $923 r0 *1 189.545,74.34 rppd
R$923 11 25 1 1 rppd l=50 ps=0 b=0 m=1
* device instance $924 r0 *1 191.445,74.34 rppd
R$924 11 25 1 1 rppd l=50 ps=0 b=0 m=1
* device instance $925 r0 *1 193.345,74.34 rppd
R$925 11 25 1 1 rppd l=50 ps=0 b=0 m=1
* device instance $926 r0 *1 195.245,74.34 rppd
R$926 24 27 1 1 rppd l=50 ps=0 b=0 m=1
* device instance $927 r0 *1 197.145,74.34 rppd
R$927 24 27 1 1 rppd l=50 ps=0 b=0 m=1
* device instance $928 r0 *1 199.045,74.34 rppd
R$928 24 27 1 1 rppd l=50 ps=0 b=0 m=1
* device instance $929 r0 *1 200.945,74.34 rppd
R$929 24 27 1 1 rppd l=50 ps=0 b=0 m=1
* device instance $930 r0 *1 202.845,74.34 rppd
R$930 24 27 1 1 rppd l=50 ps=0 b=0 m=1
* device instance $931 r0 *1 204.745,74.34 rppd
R$931 24 27 1 1 rppd l=50 ps=0 b=0 m=1
* device instance $932 r0 *1 206.645,74.34 rppd
R$932 24 27 1 1 rppd l=50 ps=0 b=0 m=1
* device instance $933 r0 *1 208.545,74.34 rppd
R$933 24 27 1 1 rppd l=50 ps=0 b=0 m=1
* device instance $934 r0 *1 210.445,74.34 rppd
R$934 24 27 1 1 rppd l=50 ps=0 b=0 m=1
* device instance $935 r0 *1 212.345,74.34 rppd
R$935 24 27 1 1 rppd l=50 ps=0 b=0 m=1
* device instance $936 r0 *1 214.245,74.34 rppd
R$936 24 27 1 1 rppd l=50 ps=0 b=0 m=1
* device instance $937 r0 *1 216.145,74.34 rppd
R$937 24 27 1 1 rppd l=50 ps=0 b=0 m=1
* device instance $938 r0 *1 218.045,74.34 rppd
R$938 11 32 1 1 rppd l=50 ps=0 b=0 m=1
* device instance $939 r0 *1 219.945,74.34 rppd
R$939 11 32 1 1 rppd l=50 ps=0 b=0 m=1
* device instance $940 r0 *1 221.845,74.34 rppd
R$940 11 32 1 1 rppd l=50 ps=0 b=0 m=1
* device instance $941 r0 *1 223.745,74.34 rppd
R$941 11 32 1 1 rppd l=50 ps=0 b=0 m=1
* device instance $942 r0 *1 225.645,74.34 rppd
R$942 11 32 1 1 rppd l=50 ps=0 b=0 m=1
* device instance $943 r0 *1 227.545,74.34 rppd
R$943 11 32 1 1 rppd l=50 ps=0 b=0 m=1
* device instance $944 r0 *1 229.445,74.34 rppd
R$944 11 32 1 1 rppd l=50 ps=0 b=0 m=1
* device instance $945 r0 *1 231.345,74.34 rppd
R$945 11 32 1 1 rppd l=50 ps=0 b=0 m=1
* device instance $946 r0 *1 233.245,74.34 rppd
R$946 11 32 1 1 rppd l=50 ps=0 b=0 m=1
* device instance $947 r0 *1 235.145,74.34 rppd
R$947 11 32 1 1 rppd l=50 ps=0 b=0 m=1
* device instance $948 r0 *1 237.045,74.34 rppd
R$948 11 32 1 1 rppd l=50 ps=0 b=0 m=1
* device instance $949 r0 *1 238.945,74.34 rppd
R$949 11 32 1 1 rppd l=50 ps=0 b=0 m=1
* device instance $950 r0 *1 240.845,74.34 rppd
R$950 10 32 1 1 rppd l=50 ps=0 b=0 m=1
* device instance $951 r0 *1 242.745,74.34 rppd
R$951 10 32 1 1 rppd l=50 ps=0 b=0 m=1
* device instance $952 r0 *1 244.645,74.34 rppd
R$952 10 32 1 1 rppd l=50 ps=0 b=0 m=1
* device instance $953 r0 *1 246.545,74.34 rppd
R$953 10 32 1 1 rppd l=50 ps=0 b=0 m=1
* device instance $954 r0 *1 248.445,74.34 rppd
R$954 10 32 1 1 rppd l=50 ps=0 b=0 m=1
* device instance $955 r0 *1 250.345,74.34 rppd
R$955 10 32 1 1 rppd l=50 ps=0 b=0 m=1
* device instance $956 r0 *1 252.245,74.34 rppd
R$956 10 32 1 1 rppd l=50 ps=0 b=0 m=1
* device instance $957 r0 *1 254.145,74.34 rppd
R$957 10 32 1 1 rppd l=50 ps=0 b=0 m=1
* device instance $958 r0 *1 256.045,74.34 rppd
R$958 10 32 1 1 rppd l=50 ps=0 b=0 m=1
* device instance $959 r0 *1 257.945,74.34 rppd
R$959 10 32 1 1 rppd l=50 ps=0 b=0 m=1
* device instance $960 r0 *1 259.845,74.34 rppd
R$960 10 32 1 1 rppd l=50 ps=0 b=0 m=1
* device instance $961 r0 *1 261.745,74.34 rppd
R$961 10 32 1 1 rppd l=50 ps=0 b=0 m=1
* device instance $962 r0 *1 263.645,74.34 rppd
R$962 30 36 1 1 rppd l=50 ps=0 b=0 m=1
* device instance $963 r0 *1 265.545,74.34 rppd
R$963 30 36 1 1 rppd l=50 ps=0 b=0 m=1
* device instance $964 r0 *1 267.445,74.34 rppd
R$964 30 36 1 1 rppd l=50 ps=0 b=0 m=1
* device instance $965 r0 *1 269.345,74.34 rppd
R$965 30 36 1 1 rppd l=50 ps=0 b=0 m=1
* device instance $966 r0 *1 271.245,74.34 rppd
R$966 30 36 1 1 rppd l=50 ps=0 b=0 m=1
* device instance $967 r0 *1 273.145,74.34 rppd
R$967 30 36 1 1 rppd l=50 ps=0 b=0 m=1
* device instance $968 r0 *1 275.045,74.34 rppd
R$968 30 36 1 1 rppd l=50 ps=0 b=0 m=1
* device instance $969 r0 *1 276.945,74.34 rppd
R$969 30 36 1 1 rppd l=50 ps=0 b=0 m=1
* device instance $970 r0 *1 278.845,74.34 rppd
R$970 30 36 1 1 rppd l=50 ps=0 b=0 m=1
* device instance $971 r0 *1 280.745,74.34 rppd
R$971 30 36 1 1 rppd l=50 ps=0 b=0 m=1
* device instance $972 r0 *1 282.645,74.34 rppd
R$972 30 36 1 1 rppd l=50 ps=0 b=0 m=1
* device instance $973 r0 *1 284.545,74.34 rppd
R$973 30 36 1 1 rppd l=50 ps=0 b=0 m=1
* device instance $974 r0 *1 286.445,75.34 rppd
R$974 3 20 1 1 rppd l=48 ps=0 b=0 m=1
* device instance $975 r0 *1 288.345,75.34 rppd
R$975 3 20 1 1 rppd l=48 ps=0 b=0 m=1
* device instance $976 r0 *1 290.245,75.34 rppd
R$976 3 20 1 1 rppd l=48 ps=0 b=0 m=1
* device instance $977 r0 *1 292.145,75.34 rppd
R$977 3 20 1 1 rppd l=48 ps=0 b=0 m=1
* device instance $978 r0 *1 294.045,75.34 rppd
R$978 3 20 1 1 rppd l=48 ps=0 b=0 m=1
* device instance $979 r0 *1 295.945,75.34 rppd
R$979 3 20 1 1 rppd l=48 ps=0 b=0 m=1
* device instance $980 r0 *1 297.845,75.34 rppd
R$980 3 20 1 1 rppd l=48 ps=0 b=0 m=1
* device instance $981 r0 *1 299.745,75.34 rppd
R$981 3 20 1 1 rppd l=48 ps=0 b=0 m=1
* device instance $982 r0 *1 301.645,75.34 rppd
R$982 3 20 1 1 rppd l=48 ps=0 b=0 m=1
* device instance $983 r0 *1 303.545,75.34 rppd
R$983 3 20 1 1 rppd l=48 ps=0 b=0 m=1
* device instance $984 r0 *1 305.445,75.34 rppd
R$984 3 20 1 1 rppd l=48 ps=0 b=0 m=1
* device instance $985 r0 *1 307.345,75.34 rppd
R$985 3 20 1 1 rppd l=48 ps=0 b=0 m=1
* device instance $986 r0 *1 309.245,75.34 rppd
R$986 2 20 1 1 rppd l=48 ps=0 b=0 m=1
* device instance $987 r0 *1 311.145,75.34 rppd
R$987 2 20 1 1 rppd l=48 ps=0 b=0 m=1
* device instance $988 r0 *1 313.045,75.34 rppd
R$988 2 20 1 1 rppd l=48 ps=0 b=0 m=1
* device instance $989 r0 *1 314.945,75.34 rppd
R$989 2 20 1 1 rppd l=48 ps=0 b=0 m=1
* device instance $990 r0 *1 316.845,75.34 rppd
R$990 2 20 1 1 rppd l=48 ps=0 b=0 m=1
* device instance $991 r0 *1 318.745,75.34 rppd
R$991 2 20 1 1 rppd l=48 ps=0 b=0 m=1
* device instance $992 r0 *1 320.645,75.34 rppd
R$992 2 20 1 1 rppd l=48 ps=0 b=0 m=1
* device instance $993 r0 *1 322.545,75.34 rppd
R$993 2 20 1 1 rppd l=48 ps=0 b=0 m=1
* device instance $994 r0 *1 324.445,75.34 rppd
R$994 2 20 1 1 rppd l=48 ps=0 b=0 m=1
* device instance $995 r0 *1 326.345,75.34 rppd
R$995 2 20 1 1 rppd l=48 ps=0 b=0 m=1
* device instance $996 r0 *1 328.245,75.34 rppd
R$996 2 20 1 1 rppd l=48 ps=0 b=0 m=1
* device instance $997 r0 *1 330.145,75.34 rppd
R$997 2 20 1 1 rppd l=48 ps=0 b=0 m=1
* device instance $998 r0 *1 332.045,75.34 rppd
R$998 3 39 1 1 rppd l=48 ps=0 b=0 m=1
* device instance $999 r0 *1 333.945,75.34 rppd
R$999 3 39 1 1 rppd l=48 ps=0 b=0 m=1
* device instance $1000 r0 *1 335.845,75.34 rppd
R$1000 3 39 1 1 rppd l=48 ps=0 b=0 m=1
* device instance $1001 r0 *1 337.745,75.34 rppd
R$1001 3 39 1 1 rppd l=48 ps=0 b=0 m=1
* device instance $1002 r0 *1 339.645,75.34 rppd
R$1002 3 39 1 1 rppd l=48 ps=0 b=0 m=1
* device instance $1003 r0 *1 341.545,75.34 rppd
R$1003 3 39 1 1 rppd l=48 ps=0 b=0 m=1
* device instance $1004 r0 *1 343.445,75.34 rppd
R$1004 3 39 1 1 rppd l=48 ps=0 b=0 m=1
* device instance $1005 r0 *1 345.345,75.34 rppd
R$1005 3 39 1 1 rppd l=48 ps=0 b=0 m=1
* device instance $1006 r0 *1 347.245,75.34 rppd
R$1006 3 39 1 1 rppd l=48 ps=0 b=0 m=1
* device instance $1007 r0 *1 349.145,75.34 rppd
R$1007 3 39 1 1 rppd l=48 ps=0 b=0 m=1
* device instance $1008 r0 *1 351.045,75.34 rppd
R$1008 3 39 1 1 rppd l=48 ps=0 b=0 m=1
* device instance $1009 r0 *1 352.945,75.34 rppd
R$1009 3 39 1 1 rppd l=48 ps=0 b=0 m=1
* device instance $1010 r0 *1 354.845,75.34 rppd
R$1010 2 45 1 1 rppd l=48 ps=0 b=0 m=1
* device instance $1011 r0 *1 356.745,75.34 rppd
R$1011 2 45 1 1 rppd l=48 ps=0 b=0 m=1
* device instance $1012 r0 *1 358.645,75.34 rppd
R$1012 2 45 1 1 rppd l=48 ps=0 b=0 m=1
* device instance $1013 r0 *1 360.545,75.34 rppd
R$1013 2 45 1 1 rppd l=48 ps=0 b=0 m=1
* device instance $1014 r0 *1 362.445,75.34 rppd
R$1014 2 45 1 1 rppd l=48 ps=0 b=0 m=1
* device instance $1015 r0 *1 364.345,75.34 rppd
R$1015 2 45 1 1 rppd l=48 ps=0 b=0 m=1
* device instance $1016 r0 *1 366.245,75.34 rppd
R$1016 2 45 1 1 rppd l=48 ps=0 b=0 m=1
* device instance $1017 r0 *1 368.145,75.34 rppd
R$1017 2 45 1 1 rppd l=48 ps=0 b=0 m=1
* device instance $1018 r0 *1 370.045,75.34 rppd
R$1018 2 45 1 1 rppd l=48 ps=0 b=0 m=1
* device instance $1019 r0 *1 371.945,75.34 rppd
R$1019 2 45 1 1 rppd l=48 ps=0 b=0 m=1
* device instance $1020 r0 *1 373.845,75.34 rppd
R$1020 2 45 1 1 rppd l=48 ps=0 b=0 m=1
* device instance $1021 r0 *1 375.745,75.34 rppd
R$1021 2 45 1 1 rppd l=48 ps=0 b=0 m=1
* device instance $1022 r0 *1 385.495,12.835 rhigh
R$1022 1 21 1 0.5 rhigh l=49 ps=0 b=0 m=1
* device instance $1023 r0 *1 387.395,12.835 rhigh
R$1023 4 22 1 0.5 rhigh l=49 ps=0 b=0 m=1
* device instance $1024 r0 *1 389.295,12.835 rhigh
R$1024 5 22 1 0.5 rhigh l=49 ps=0 b=0 m=1
* device instance $1025 r0 *1 391.195,12.835 rhigh
R$1025 6 23 1 0.5 rhigh l=49 ps=0 b=0 m=1
* device instance $1026 r0 *1 393.095,12.835 rhigh
R$1026 7 23 1 0.5 rhigh l=49 ps=0 b=0 m=1
* device instance $1027 r0 *1 394.995,12.835 rhigh
R$1027 7 21 1 0.5 rhigh l=49 ps=0 b=0 m=1
* device instance $1028 r0 *1 396.895,12.835 rhigh
R$1028 6 18 1 0.5 rhigh l=49 ps=0 b=0 m=1
* device instance $1029 r0 *1 398.795,12.835 rhigh
R$1029 4 8 1 0.5 rhigh l=49 ps=0 b=0 m=1
* device instance $1030 r0 *1 20.695,74.835 rhigh
R$1030 5 12 1 0.5 rhigh l=49 ps=0 b=0 m=1
* device instance $1031 r0 *1 22.595,74.835 rhigh
R$1031 13 12 1 0.5 rhigh l=49 ps=0 b=0 m=1
* device instance $1032 r0 *1 24.495,74.835 rhigh
R$1032 13 14 1 0.5 rhigh l=49 ps=0 b=0 m=1
* device instance $1033 r0 *1 26.395,74.835 rhigh
R$1033 15 14 1 0.5 rhigh l=49 ps=0 b=0 m=1
* device instance $1034 r0 *1 28.295,74.835 rhigh
R$1034 15 16 1 0.5 rhigh l=49 ps=0 b=0 m=1
* device instance $1035 r0 *1 30.195,74.835 rhigh
R$1035 17 16 1 0.5 rhigh l=49 ps=0 b=0 m=1
* device instance $1036 r0 *1 32.095,74.835 rhigh
R$1036 17 18 1 0.5 rhigh l=49 ps=0 b=0 m=1
.ENDS g1_bgr
