* Extracted by KLayout with SG13G2 LVS runset on : 22/09/2026 22:17

.SUBCKT bgr_hbt_worstrows c2 dvbe vbe vd1 vd2 vss
Q$1 c2 vbe dvbe vss npn13G2 we=70n le=900n Nx=1 m=1
Q$2 vd1 vd1 vd2 vss npn13G2 we=70n le=900n Nx=1 m=1
Q$3 vd1 vd1 vd2 vss npn13G2 we=70n le=900n Nx=1 m=1
Q$4 vd1 vd1 vd2 vss npn13G2 we=70n le=900n Nx=1 m=1
Q$5 vd1 vd1 vd2 vss npn13G2 we=70n le=900n Nx=1 m=1
Q$6 vd1 vd1 vd2 vss npn13G2 we=70n le=900n Nx=1 m=1
Q$7 vd1 vd1 vd2 vss npn13G2 we=70n le=900n Nx=1 m=1
Q$8 vd1 vd1 vd2 vss npn13G2 we=70n le=900n Nx=1 m=1
Q$9 vd1 vd1 vd2 vss npn13G2 we=70n le=900n Nx=1 m=1
Q$10 vd1 vd1 vd2 vss npn13G2 we=70n le=900n Nx=1 m=1
Q$11 vd1 vd1 vd2 vss npn13G2 we=70n le=900n Nx=1 m=1
Q$12 vd1 vd1 vd2 vss npn13G2 we=70n le=900n Nx=1 m=1
Q$13 vd1 vd1 vd2 vss npn13G2 we=70n le=900n Nx=1 m=1
Q$14 c2 vbe dvbe vss npn13G2 we=70n le=900n Nx=1 m=1
Q$15 c2 vbe dvbe vss npn13G2 we=70n le=900n Nx=1 m=1
Q$16 c2 vbe dvbe vss npn13G2 we=70n le=900n Nx=1 m=1
Q$17 c2 vbe dvbe vss npn13G2 we=70n le=900n Nx=1 m=1
Q$18 c2 vbe dvbe vss npn13G2 we=70n le=900n Nx=1 m=1
Q$19 c2 vbe dvbe vss npn13G2 we=70n le=900n Nx=1 m=1
Q$20 c2 vbe dvbe vss npn13G2 we=70n le=900n Nx=1 m=1
Q$21 c2 vbe dvbe vss npn13G2 we=70n le=900n Nx=1 m=1
Q$22 vd1 vd1 vd2 vss npn13G2 we=70n le=900n Nx=1 m=1
Q$23 vd1 vd1 vd2 vss npn13G2 we=70n le=900n Nx=1 m=1
Q$24 vd1 vd1 vd2 vss npn13G2 we=70n le=900n Nx=1 m=1
Q$25 vd1 vd1 vd2 vss npn13G2 we=70n le=900n Nx=1 m=1
Q$26 vd1 vd1 vd2 vss npn13G2 we=70n le=900n Nx=1 m=1
Q$27 vd1 vd1 vd2 vss npn13G2 we=70n le=900n Nx=1 m=1
Q$28 vd1 vd1 vd2 vss npn13G2 we=70n le=900n Nx=1 m=1
Q$29 vd1 vd1 vd2 vss npn13G2 we=70n le=900n Nx=1 m=1
Q$30 vd1 vd1 vd2 vss npn13G2 we=70n le=900n Nx=1 m=1
Q$31 vd1 vd1 vd2 vss npn13G2 we=70n le=900n Nx=1 m=1
Q$32 vd1 vd1 vd2 vss npn13G2 we=70n le=900n Nx=1 m=1
Q$33 vd1 vd1 vd2 vss npn13G2 we=70n le=900n Nx=1 m=1
Q$34 c2 vbe dvbe vss npn13G2 we=70n le=900n Nx=1 m=1
.ENDS bgr_hbt_worstrows
