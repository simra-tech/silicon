* Extracted by KLayout with SG13G2 LVS runset on : 22/09/2026 22:20

.SUBCKT g1_bgr dvbe iptat pbias pcasc r4 vbe vdd vref vss
M$1 \$569 r4 vbe vss sg13_hv_nmos L=0.5u W=2u AS=0.68p AD=0.68p PS=4.68u
+ PD=4.68u rfmode=0
M$2 vss \$676 pbias vss sg13_hv_nmos L=4u W=1u AS=0.34p AD=0.34p PS=2.68u
+ PD=2.68u rfmode=0
M$3 vss \$11 \$676 vss sg13_hv_nmos L=0.6u W=1u AS=0.34p AD=0.34p PS=2.68u
+ PD=2.68u rfmode=0
M$4 vss r4 \$677 vss sg13_hv_nmos L=0.5u W=1u AS=0.34p AD=0.34p PS=2.68u
+ PD=2.68u rfmode=0
M$5 vss \$677 \$569 vss sg13_hv_nmos L=0.6u W=1u AS=0.34p AD=0.34p PS=2.68u
+ PD=2.68u rfmode=0
M$6 vbe \$441 \$444 vss sg13_hv_nmos L=1u W=10u AS=3.4p AD=3.4p PS=20.68u
+ PD=20.68u rfmode=0
M$7 vbe \$441 \$444 vss sg13_hv_nmos L=1u W=10u AS=3.4p AD=3.4p PS=20.68u
+ PD=20.68u rfmode=0
M$8 vbe \$441 \$444 vss sg13_hv_nmos L=1u W=10u AS=3.4p AD=3.4p PS=20.68u
+ PD=20.68u rfmode=0
M$9 vbe \$441 \$444 vss sg13_hv_nmos L=1u W=10u AS=3.4p AD=3.4p PS=20.68u
+ PD=20.68u rfmode=0
M$10 vbe \$441 \$444 vss sg13_hv_nmos L=1u W=10u AS=3.4p AD=3.4p PS=20.68u
+ PD=20.68u rfmode=0
M$11 vbe \$441 \$444 vss sg13_hv_nmos L=1u W=10u AS=3.4p AD=3.4p PS=20.68u
+ PD=20.68u rfmode=0
M$12 vbe \$441 \$444 vss sg13_hv_nmos L=1u W=10u AS=3.4p AD=3.4p PS=20.68u
+ PD=20.68u rfmode=0
M$13 vbe \$441 \$444 vss sg13_hv_nmos L=1u W=10u AS=3.4p AD=3.4p PS=20.68u
+ PD=20.68u rfmode=0
M$14 vbe \$441 \$444 vss sg13_hv_nmos L=1u W=10u AS=3.4p AD=3.4p PS=20.68u
+ PD=20.68u rfmode=0
M$15 vbe \$441 \$444 vss sg13_hv_nmos L=1u W=10u AS=3.4p AD=3.4p PS=20.68u
+ PD=20.68u rfmode=0
M$16 vbe \$441 \$444 vss sg13_hv_nmos L=1u W=10u AS=3.4p AD=3.4p PS=20.68u
+ PD=20.68u rfmode=0
M$17 vbe \$441 \$444 vss sg13_hv_nmos L=1u W=10u AS=3.4p AD=3.4p PS=20.68u
+ PD=20.68u rfmode=0
M$18 pcasc \$441 \$750 vss sg13_hv_nmos L=1u W=10u AS=3.4p AD=3.4p PS=20.68u
+ PD=20.68u rfmode=0
M$19 pcasc \$441 \$750 vss sg13_hv_nmos L=1u W=10u AS=3.4p AD=3.4p PS=20.68u
+ PD=20.68u rfmode=0
M$20 pcasc \$441 \$750 vss sg13_hv_nmos L=1u W=10u AS=3.4p AD=3.4p PS=20.68u
+ PD=20.68u rfmode=0
M$21 pcasc \$441 \$750 vss sg13_hv_nmos L=1u W=10u AS=3.4p AD=3.4p PS=20.68u
+ PD=20.68u rfmode=0
M$22 pcasc \$441 \$750 vss sg13_hv_nmos L=1u W=10u AS=3.4p AD=3.4p PS=20.68u
+ PD=20.68u rfmode=0
M$23 pcasc \$441 \$750 vss sg13_hv_nmos L=1u W=10u AS=3.4p AD=3.4p PS=20.68u
+ PD=20.68u rfmode=0
M$24 pcasc \$441 \$750 vss sg13_hv_nmos L=1u W=10u AS=3.4p AD=3.4p PS=20.68u
+ PD=20.68u rfmode=0
M$25 pcasc \$441 \$750 vss sg13_hv_nmos L=1u W=10u AS=3.4p AD=3.4p PS=20.68u
+ PD=20.68u rfmode=0
M$26 pcasc \$441 \$750 vss sg13_hv_nmos L=1u W=10u AS=3.4p AD=3.4p PS=20.68u
+ PD=20.68u rfmode=0
M$27 pcasc \$441 \$750 vss sg13_hv_nmos L=1u W=10u AS=3.4p AD=3.4p PS=20.68u
+ PD=20.68u rfmode=0
M$28 pcasc \$441 \$750 vss sg13_hv_nmos L=1u W=10u AS=3.4p AD=3.4p PS=20.68u
+ PD=20.68u rfmode=0
M$29 pcasc \$441 \$750 vss sg13_hv_nmos L=1u W=10u AS=3.4p AD=3.4p PS=20.68u
+ PD=20.68u rfmode=0
M$30 \$444 \$441 vbe vss sg13_hv_nmos L=1u W=10u AS=3.4p AD=3.4p PS=20.68u
+ PD=20.68u rfmode=0
M$31 \$444 \$441 vbe vss sg13_hv_nmos L=1u W=10u AS=3.4p AD=3.4p PS=20.68u
+ PD=20.68u rfmode=0
M$32 \$444 \$441 vbe vss sg13_hv_nmos L=1u W=10u AS=3.4p AD=3.4p PS=20.68u
+ PD=20.68u rfmode=0
M$33 \$444 \$441 vbe vss sg13_hv_nmos L=1u W=10u AS=3.4p AD=3.4p PS=20.68u
+ PD=20.68u rfmode=0
M$34 \$444 \$441 vbe vss sg13_hv_nmos L=1u W=10u AS=3.4p AD=3.4p PS=20.68u
+ PD=20.68u rfmode=0
M$35 \$444 \$441 vbe vss sg13_hv_nmos L=1u W=10u AS=3.4p AD=3.4p PS=20.68u
+ PD=20.68u rfmode=0
M$36 \$444 \$441 vbe vss sg13_hv_nmos L=1u W=10u AS=3.4p AD=3.4p PS=20.68u
+ PD=20.68u rfmode=0
M$37 \$444 \$441 vbe vss sg13_hv_nmos L=1u W=10u AS=3.4p AD=3.4p PS=20.68u
+ PD=20.68u rfmode=0
M$38 \$444 \$441 vbe vss sg13_hv_nmos L=1u W=10u AS=3.4p AD=3.4p PS=20.68u
+ PD=20.68u rfmode=0
M$39 \$444 \$441 vbe vss sg13_hv_nmos L=1u W=10u AS=3.4p AD=3.4p PS=20.68u
+ PD=20.68u rfmode=0
M$40 \$444 \$441 vbe vss sg13_hv_nmos L=1u W=10u AS=3.4p AD=3.4p PS=20.68u
+ PD=20.68u rfmode=0
M$41 \$444 \$441 vbe vss sg13_hv_nmos L=1u W=10u AS=3.4p AD=3.4p PS=20.68u
+ PD=20.68u rfmode=0
M$42 \$444 \$441 vbe vss sg13_hv_nmos L=1u W=10u AS=3.4p AD=3.4p PS=20.68u
+ PD=20.68u rfmode=0
M$43 \$444 \$441 vbe vss sg13_hv_nmos L=1u W=10u AS=3.4p AD=3.4p PS=20.68u
+ PD=20.68u rfmode=0
M$44 \$444 \$441 vbe vss sg13_hv_nmos L=1u W=10u AS=3.4p AD=3.4p PS=20.68u
+ PD=20.68u rfmode=0
M$45 \$444 \$441 vbe vss sg13_hv_nmos L=1u W=10u AS=3.4p AD=3.4p PS=20.68u
+ PD=20.68u rfmode=0
M$46 \$750 \$441 pcasc vss sg13_hv_nmos L=1u W=10u AS=3.4p AD=3.4p PS=20.68u
+ PD=20.68u rfmode=0
M$47 \$444 \$441 vbe vss sg13_hv_nmos L=1u W=10u AS=3.4p AD=3.4p PS=20.68u
+ PD=20.68u rfmode=0
M$48 \$750 \$441 pcasc vss sg13_hv_nmos L=1u W=10u AS=3.4p AD=3.4p PS=20.68u
+ PD=20.68u rfmode=0
M$49 \$750 \$441 pcasc vss sg13_hv_nmos L=1u W=10u AS=3.4p AD=3.4p PS=20.68u
+ PD=20.68u rfmode=0
M$50 \$444 \$441 vbe vss sg13_hv_nmos L=1u W=10u AS=3.4p AD=3.4p PS=20.68u
+ PD=20.68u rfmode=0
M$51 \$750 \$441 pcasc vss sg13_hv_nmos L=1u W=10u AS=3.4p AD=3.4p PS=20.68u
+ PD=20.68u rfmode=0
M$52 \$444 \$441 vbe vss sg13_hv_nmos L=1u W=10u AS=3.4p AD=3.4p PS=20.68u
+ PD=20.68u rfmode=0
M$53 \$750 \$441 pcasc vss sg13_hv_nmos L=1u W=10u AS=3.4p AD=3.4p PS=20.68u
+ PD=20.68u rfmode=0
M$54 \$444 \$441 vbe vss sg13_hv_nmos L=1u W=10u AS=3.4p AD=3.4p PS=20.68u
+ PD=20.68u rfmode=0
M$55 \$750 \$441 pcasc vss sg13_hv_nmos L=1u W=10u AS=3.4p AD=3.4p PS=20.68u
+ PD=20.68u rfmode=0
M$56 \$444 \$441 vbe vss sg13_hv_nmos L=1u W=10u AS=3.4p AD=3.4p PS=20.68u
+ PD=20.68u rfmode=0
M$57 pcasc \$441 \$750 vss sg13_hv_nmos L=1u W=10u AS=3.4p AD=3.4p PS=20.68u
+ PD=20.68u rfmode=0
M$58 \$750 \$441 pcasc vss sg13_hv_nmos L=1u W=10u AS=3.4p AD=3.4p PS=20.68u
+ PD=20.68u rfmode=0
M$59 pcasc \$441 \$750 vss sg13_hv_nmos L=1u W=10u AS=3.4p AD=3.4p PS=20.68u
+ PD=20.68u rfmode=0
M$60 \$750 \$441 pcasc vss sg13_hv_nmos L=1u W=10u AS=3.4p AD=3.4p PS=20.68u
+ PD=20.68u rfmode=0
M$61 pcasc \$441 \$750 vss sg13_hv_nmos L=1u W=10u AS=3.4p AD=3.4p PS=20.68u
+ PD=20.68u rfmode=0
M$62 \$750 \$441 pcasc vss sg13_hv_nmos L=1u W=10u AS=3.4p AD=3.4p PS=20.68u
+ PD=20.68u rfmode=0
M$63 pcasc \$441 \$750 vss sg13_hv_nmos L=1u W=10u AS=3.4p AD=3.4p PS=20.68u
+ PD=20.68u rfmode=0
M$64 \$750 \$441 pcasc vss sg13_hv_nmos L=1u W=10u AS=3.4p AD=3.4p PS=20.68u
+ PD=20.68u rfmode=0
M$65 \$750 \$441 pcasc vss sg13_hv_nmos L=1u W=10u AS=3.4p AD=3.4p PS=20.68u
+ PD=20.68u rfmode=0
M$66 pcasc \$441 \$750 vss sg13_hv_nmos L=1u W=10u AS=3.4p AD=3.4p PS=20.68u
+ PD=20.68u rfmode=0
M$67 \$750 \$441 pcasc vss sg13_hv_nmos L=1u W=10u AS=3.4p AD=3.4p PS=20.68u
+ PD=20.68u rfmode=0
M$68 pcasc \$441 \$750 vss sg13_hv_nmos L=1u W=10u AS=3.4p AD=3.4p PS=20.68u
+ PD=20.68u rfmode=0
M$69 pcasc \$441 \$750 vss sg13_hv_nmos L=1u W=10u AS=3.4p AD=3.4p PS=20.68u
+ PD=20.68u rfmode=0
M$70 pcasc \$441 \$750 vss sg13_hv_nmos L=1u W=10u AS=3.4p AD=3.4p PS=20.68u
+ PD=20.68u rfmode=0
M$71 pcasc \$441 \$750 vss sg13_hv_nmos L=1u W=10u AS=3.4p AD=3.4p PS=20.68u
+ PD=20.68u rfmode=0
M$72 pcasc \$441 \$750 vss sg13_hv_nmos L=1u W=10u AS=3.4p AD=3.4p PS=20.68u
+ PD=20.68u rfmode=0
M$73 \$750 \$441 pcasc vss sg13_hv_nmos L=1u W=10u AS=3.4p AD=3.4p PS=20.68u
+ PD=20.68u rfmode=0
M$74 \$750 \$441 pcasc vss sg13_hv_nmos L=1u W=10u AS=3.4p AD=3.4p PS=20.68u
+ PD=20.68u rfmode=0
M$75 pcasc \$441 \$750 vss sg13_hv_nmos L=1u W=10u AS=3.4p AD=3.4p PS=20.68u
+ PD=20.68u rfmode=0
M$76 pcasc \$441 \$750 vss sg13_hv_nmos L=1u W=10u AS=3.4p AD=3.4p PS=20.68u
+ PD=20.68u rfmode=0
M$77 \$750 \$441 pcasc vss sg13_hv_nmos L=1u W=10u AS=3.4p AD=3.4p PS=20.68u
+ PD=20.68u rfmode=0
M$78 \$750 \$441 pcasc vss sg13_hv_nmos L=1u W=10u AS=3.4p AD=3.4p PS=20.68u
+ PD=20.68u rfmode=0
M$79 vbe \$441 \$444 vss sg13_hv_nmos L=1u W=10u AS=3.4p AD=3.4p PS=20.68u
+ PD=20.68u rfmode=0
M$80 vbe \$441 \$444 vss sg13_hv_nmos L=1u W=10u AS=3.4p AD=3.4p PS=20.68u
+ PD=20.68u rfmode=0
M$81 \$750 \$441 pcasc vss sg13_hv_nmos L=1u W=10u AS=3.4p AD=3.4p PS=20.68u
+ PD=20.68u rfmode=0
M$82 \$750 \$441 pcasc vss sg13_hv_nmos L=1u W=10u AS=3.4p AD=3.4p PS=20.68u
+ PD=20.68u rfmode=0
M$83 vbe \$441 \$444 vss sg13_hv_nmos L=1u W=10u AS=3.4p AD=3.4p PS=20.68u
+ PD=20.68u rfmode=0
M$84 \$750 \$441 pcasc vss sg13_hv_nmos L=1u W=10u AS=3.4p AD=3.4p PS=20.68u
+ PD=20.68u rfmode=0
M$85 vbe \$441 \$444 vss sg13_hv_nmos L=1u W=10u AS=3.4p AD=3.4p PS=20.68u
+ PD=20.68u rfmode=0
M$86 \$750 \$441 pcasc vss sg13_hv_nmos L=1u W=10u AS=3.4p AD=3.4p PS=20.68u
+ PD=20.68u rfmode=0
M$87 vbe \$441 \$444 vss sg13_hv_nmos L=1u W=10u AS=3.4p AD=3.4p PS=20.68u
+ PD=20.68u rfmode=0
M$88 vbe \$441 \$444 vss sg13_hv_nmos L=1u W=10u AS=3.4p AD=3.4p PS=20.68u
+ PD=20.68u rfmode=0
M$89 \$750 \$441 pcasc vss sg13_hv_nmos L=1u W=10u AS=3.4p AD=3.4p PS=20.68u
+ PD=20.68u rfmode=0
M$90 vbe \$441 \$444 vss sg13_hv_nmos L=1u W=10u AS=3.4p AD=3.4p PS=20.68u
+ PD=20.68u rfmode=0
M$91 \$750 \$441 pcasc vss sg13_hv_nmos L=1u W=10u AS=3.4p AD=3.4p PS=20.68u
+ PD=20.68u rfmode=0
M$92 vbe \$441 \$444 vss sg13_hv_nmos L=1u W=10u AS=3.4p AD=3.4p PS=20.68u
+ PD=20.68u rfmode=0
M$93 \$750 \$441 pcasc vss sg13_hv_nmos L=1u W=10u AS=3.4p AD=3.4p PS=20.68u
+ PD=20.68u rfmode=0
M$94 vbe \$441 \$444 vss sg13_hv_nmos L=1u W=10u AS=3.4p AD=3.4p PS=20.68u
+ PD=20.68u rfmode=0
M$95 \$750 \$441 pcasc vss sg13_hv_nmos L=1u W=10u AS=3.4p AD=3.4p PS=20.68u
+ PD=20.68u rfmode=0
M$96 \$444 \$441 vbe vss sg13_hv_nmos L=1u W=10u AS=3.4p AD=3.4p PS=20.68u
+ PD=20.68u rfmode=0
M$97 vbe \$441 \$444 vss sg13_hv_nmos L=1u W=10u AS=3.4p AD=3.4p PS=20.68u
+ PD=20.68u rfmode=0
M$98 \$444 \$441 vbe vss sg13_hv_nmos L=1u W=10u AS=3.4p AD=3.4p PS=20.68u
+ PD=20.68u rfmode=0
M$99 vbe \$441 \$444 vss sg13_hv_nmos L=1u W=10u AS=3.4p AD=3.4p PS=20.68u
+ PD=20.68u rfmode=0
M$100 vbe \$441 \$444 vss sg13_hv_nmos L=1u W=10u AS=3.4p AD=3.4p PS=20.68u
+ PD=20.68u rfmode=0
M$101 \$444 \$441 vbe vss sg13_hv_nmos L=1u W=10u AS=3.4p AD=3.4p PS=20.68u
+ PD=20.68u rfmode=0
M$102 \$496 pcasc \$441 \$496 sg13_hv_pmos L=4u W=10u AS=3.4p AD=3.4p PS=20.68u
+ PD=20.68u rfmode=0
M$103 \$496 pcasc \$441 \$496 sg13_hv_pmos L=4u W=10u AS=3.4p AD=3.4p PS=20.68u
+ PD=20.68u rfmode=0
M$104 \$496 pcasc \$441 \$496 sg13_hv_pmos L=4u W=10u AS=3.4p AD=3.4p PS=20.68u
+ PD=20.68u rfmode=0
M$105 \$496 pcasc \$441 \$496 sg13_hv_pmos L=4u W=10u AS=3.4p AD=3.4p PS=20.68u
+ PD=20.68u rfmode=0
M$106 \$496 pcasc \$441 \$496 sg13_hv_pmos L=4u W=10u AS=3.4p AD=3.4p PS=20.68u
+ PD=20.68u rfmode=0
M$107 \$496 pcasc \$441 \$496 sg13_hv_pmos L=4u W=10u AS=3.4p AD=3.4p PS=20.68u
+ PD=20.68u rfmode=0
M$108 \$496 pcasc \$441 \$496 sg13_hv_pmos L=4u W=10u AS=3.4p AD=3.4p PS=20.68u
+ PD=20.68u rfmode=0
M$109 \$496 pcasc \$441 \$496 sg13_hv_pmos L=4u W=10u AS=3.4p AD=3.4p PS=20.68u
+ PD=20.68u rfmode=0
M$110 \$496 pcasc \$441 \$496 sg13_hv_pmos L=4u W=10u AS=3.4p AD=3.4p PS=20.68u
+ PD=20.68u rfmode=0
M$111 \$496 pcasc \$441 \$496 sg13_hv_pmos L=4u W=10u AS=3.4p AD=3.4p PS=20.68u
+ PD=20.68u rfmode=0
M$112 \$496 pcasc \$441 \$496 sg13_hv_pmos L=4u W=10u AS=3.4p AD=3.4p PS=20.68u
+ PD=20.68u rfmode=0
M$113 \$496 pcasc \$441 \$496 sg13_hv_pmos L=4u W=10u AS=3.4p AD=3.4p PS=20.68u
+ PD=20.68u rfmode=0
M$114 \$442 pcasc \$444 \$442 sg13_hv_pmos L=4u W=10u AS=3.4p AD=3.4p PS=20.68u
+ PD=20.68u rfmode=0
M$115 \$442 pcasc \$444 \$442 sg13_hv_pmos L=4u W=10u AS=3.4p AD=3.4p PS=20.68u
+ PD=20.68u rfmode=0
M$116 \$442 pcasc \$444 \$442 sg13_hv_pmos L=4u W=10u AS=3.4p AD=3.4p PS=20.68u
+ PD=20.68u rfmode=0
M$117 \$442 pcasc \$444 \$442 sg13_hv_pmos L=4u W=10u AS=3.4p AD=3.4p PS=20.68u
+ PD=20.68u rfmode=0
M$118 \$442 pcasc \$444 \$442 sg13_hv_pmos L=4u W=10u AS=3.4p AD=3.4p PS=20.68u
+ PD=20.68u rfmode=0
M$119 \$442 pcasc \$444 \$442 sg13_hv_pmos L=4u W=10u AS=3.4p AD=3.4p PS=20.68u
+ PD=20.68u rfmode=0
M$120 \$442 pcasc \$444 \$442 sg13_hv_pmos L=4u W=10u AS=3.4p AD=3.4p PS=20.68u
+ PD=20.68u rfmode=0
M$121 \$442 pcasc \$444 \$442 sg13_hv_pmos L=4u W=10u AS=3.4p AD=3.4p PS=20.68u
+ PD=20.68u rfmode=0
M$122 \$442 pcasc \$444 \$442 sg13_hv_pmos L=4u W=10u AS=3.4p AD=3.4p PS=20.68u
+ PD=20.68u rfmode=0
M$123 \$442 pcasc \$444 \$442 sg13_hv_pmos L=4u W=10u AS=3.4p AD=3.4p PS=20.68u
+ PD=20.68u rfmode=0
M$124 \$442 pcasc \$444 \$442 sg13_hv_pmos L=4u W=10u AS=3.4p AD=3.4p PS=20.68u
+ PD=20.68u rfmode=0
M$125 \$442 pcasc \$444 \$442 sg13_hv_pmos L=4u W=10u AS=3.4p AD=3.4p PS=20.68u
+ PD=20.68u rfmode=0
M$126 \$655 pcasc pbias \$655 sg13_hv_pmos L=4u W=10u AS=3.4p AD=3.4p PS=20.68u
+ PD=20.68u rfmode=0
M$127 \$656 pcasc vref \$656 sg13_hv_pmos L=4u W=10u AS=3.4p AD=3.4p PS=20.68u
+ PD=20.68u rfmode=0
M$128 \$655 pcasc pbias \$655 sg13_hv_pmos L=4u W=10u AS=3.4p AD=3.4p PS=20.68u
+ PD=20.68u rfmode=0
M$129 \$655 pcasc pbias \$655 sg13_hv_pmos L=4u W=10u AS=3.4p AD=3.4p PS=20.68u
+ PD=20.68u rfmode=0
M$130 \$656 pcasc vref \$656 sg13_hv_pmos L=4u W=10u AS=3.4p AD=3.4p PS=20.68u
+ PD=20.68u rfmode=0
M$131 \$655 pcasc pbias \$655 sg13_hv_pmos L=4u W=10u AS=3.4p AD=3.4p PS=20.68u
+ PD=20.68u rfmode=0
M$132 \$655 pcasc pbias \$655 sg13_hv_pmos L=4u W=10u AS=3.4p AD=3.4p PS=20.68u
+ PD=20.68u rfmode=0
M$133 \$655 pcasc pbias \$655 sg13_hv_pmos L=4u W=10u AS=3.4p AD=3.4p PS=20.68u
+ PD=20.68u rfmode=0
M$134 \$655 pcasc pbias \$655 sg13_hv_pmos L=4u W=10u AS=3.4p AD=3.4p PS=20.68u
+ PD=20.68u rfmode=0
M$135 \$655 pcasc pbias \$655 sg13_hv_pmos L=4u W=10u AS=3.4p AD=3.4p PS=20.68u
+ PD=20.68u rfmode=0
M$136 \$655 pcasc pbias \$655 sg13_hv_pmos L=4u W=10u AS=3.4p AD=3.4p PS=20.68u
+ PD=20.68u rfmode=0
M$137 \$655 pcasc pbias \$655 sg13_hv_pmos L=4u W=10u AS=3.4p AD=3.4p PS=20.68u
+ PD=20.68u rfmode=0
M$138 \$655 pcasc pbias \$655 sg13_hv_pmos L=4u W=10u AS=3.4p AD=3.4p PS=20.68u
+ PD=20.68u rfmode=0
M$139 \$655 pcasc pbias \$655 sg13_hv_pmos L=4u W=10u AS=3.4p AD=3.4p PS=20.68u
+ PD=20.68u rfmode=0
M$140 \$655 pcasc pbias \$655 sg13_hv_pmos L=4u W=10u AS=3.4p AD=3.4p PS=20.68u
+ PD=20.68u rfmode=0
M$141 \$655 pcasc pbias \$655 sg13_hv_pmos L=4u W=10u AS=3.4p AD=3.4p PS=20.68u
+ PD=20.68u rfmode=0
M$142 \$655 pcasc pbias \$655 sg13_hv_pmos L=4u W=10u AS=3.4p AD=3.4p PS=20.68u
+ PD=20.68u rfmode=0
M$143 \$655 pcasc pbias \$655 sg13_hv_pmos L=4u W=10u AS=3.4p AD=3.4p PS=20.68u
+ PD=20.68u rfmode=0
M$144 \$655 pcasc pbias \$655 sg13_hv_pmos L=4u W=10u AS=3.4p AD=3.4p PS=20.68u
+ PD=20.68u rfmode=0
M$145 \$655 pcasc pbias \$655 sg13_hv_pmos L=4u W=10u AS=3.4p AD=3.4p PS=20.68u
+ PD=20.68u rfmode=0
M$146 \$655 pcasc pbias \$655 sg13_hv_pmos L=4u W=10u AS=3.4p AD=3.4p PS=20.68u
+ PD=20.68u rfmode=0
M$147 \$655 pcasc pbias \$655 sg13_hv_pmos L=4u W=10u AS=3.4p AD=3.4p PS=20.68u
+ PD=20.68u rfmode=0
M$148 \$655 pcasc pbias \$655 sg13_hv_pmos L=4u W=10u AS=3.4p AD=3.4p PS=20.68u
+ PD=20.68u rfmode=0
M$149 \$655 pcasc pbias \$655 sg13_hv_pmos L=4u W=10u AS=3.4p AD=3.4p PS=20.68u
+ PD=20.68u rfmode=0
M$150 \$656 pcasc vref \$656 sg13_hv_pmos L=4u W=10u AS=3.4p AD=3.4p PS=20.68u
+ PD=20.68u rfmode=0
M$151 \$656 pcasc vref \$656 sg13_hv_pmos L=4u W=10u AS=3.4p AD=3.4p PS=20.68u
+ PD=20.68u rfmode=0
M$152 \$655 pcasc pbias \$655 sg13_hv_pmos L=4u W=10u AS=3.4p AD=3.4p PS=20.68u
+ PD=20.68u rfmode=0
M$153 \$657 pcasc iptat \$657 sg13_hv_pmos L=4u W=10u AS=3.4p AD=3.4p PS=20.68u
+ PD=20.68u rfmode=0
M$154 \$655 pcasc pbias \$655 sg13_hv_pmos L=4u W=10u AS=3.4p AD=3.4p PS=20.68u
+ PD=20.68u rfmode=0
M$155 \$442 pcasc \$444 \$442 sg13_hv_pmos L=4u W=10u AS=3.4p AD=3.4p PS=20.68u
+ PD=20.68u rfmode=0
M$156 vdd \$11 \$676 vdd sg13_hv_pmos L=0.5u W=2u AS=0.68p AD=0.68p PS=4.68u
+ PD=4.68u rfmode=0
M$157 \$442 pcasc \$444 \$442 sg13_hv_pmos L=4u W=10u AS=3.4p AD=3.4p PS=20.68u
+ PD=20.68u rfmode=0
M$158 vdd r4 \$677 vdd sg13_hv_pmos L=0.5u W=2u AS=0.68p AD=0.68p PS=4.68u
+ PD=4.68u rfmode=0
M$159 \$442 pcasc \$444 \$442 sg13_hv_pmos L=4u W=10u AS=3.4p AD=3.4p PS=20.68u
+ PD=20.68u rfmode=0
M$160 \$442 pcasc \$444 \$442 sg13_hv_pmos L=4u W=10u AS=3.4p AD=3.4p PS=20.68u
+ PD=20.68u rfmode=0
M$161 \$442 pcasc \$444 \$442 sg13_hv_pmos L=4u W=10u AS=3.4p AD=3.4p PS=20.68u
+ PD=20.68u rfmode=0
M$162 \$442 pcasc \$444 \$442 sg13_hv_pmos L=4u W=10u AS=3.4p AD=3.4p PS=20.68u
+ PD=20.68u rfmode=0
M$163 \$442 pcasc \$444 \$442 sg13_hv_pmos L=4u W=10u AS=3.4p AD=3.4p PS=20.68u
+ PD=20.68u rfmode=0
M$164 \$442 pcasc \$444 \$442 sg13_hv_pmos L=4u W=10u AS=3.4p AD=3.4p PS=20.68u
+ PD=20.68u rfmode=0
M$165 \$442 pcasc \$444 \$442 sg13_hv_pmos L=4u W=10u AS=3.4p AD=3.4p PS=20.68u
+ PD=20.68u rfmode=0
M$166 \$442 pcasc \$444 \$442 sg13_hv_pmos L=4u W=10u AS=3.4p AD=3.4p PS=20.68u
+ PD=20.68u rfmode=0
M$167 \$442 pcasc \$444 \$442 sg13_hv_pmos L=4u W=10u AS=3.4p AD=3.4p PS=20.68u
+ PD=20.68u rfmode=0
M$168 \$442 pcasc \$444 \$442 sg13_hv_pmos L=4u W=10u AS=3.4p AD=3.4p PS=20.68u
+ PD=20.68u rfmode=0
M$169 \$496 pcasc \$441 \$496 sg13_hv_pmos L=4u W=10u AS=3.4p AD=3.4p PS=20.68u
+ PD=20.68u rfmode=0
M$170 \$496 pcasc \$441 \$496 sg13_hv_pmos L=4u W=10u AS=3.4p AD=3.4p PS=20.68u
+ PD=20.68u rfmode=0
M$171 \$496 pcasc \$441 \$496 sg13_hv_pmos L=4u W=10u AS=3.4p AD=3.4p PS=20.68u
+ PD=20.68u rfmode=0
M$172 \$496 pcasc \$441 \$496 sg13_hv_pmos L=4u W=10u AS=3.4p AD=3.4p PS=20.68u
+ PD=20.68u rfmode=0
M$173 \$496 pcasc \$441 \$496 sg13_hv_pmos L=4u W=10u AS=3.4p AD=3.4p PS=20.68u
+ PD=20.68u rfmode=0
M$174 \$496 pcasc \$441 \$496 sg13_hv_pmos L=4u W=10u AS=3.4p AD=3.4p PS=20.68u
+ PD=20.68u rfmode=0
M$175 \$496 pcasc \$441 \$496 sg13_hv_pmos L=4u W=10u AS=3.4p AD=3.4p PS=20.68u
+ PD=20.68u rfmode=0
M$176 \$496 pcasc \$441 \$496 sg13_hv_pmos L=4u W=10u AS=3.4p AD=3.4p PS=20.68u
+ PD=20.68u rfmode=0
M$177 \$496 pcasc \$441 \$496 sg13_hv_pmos L=4u W=10u AS=3.4p AD=3.4p PS=20.68u
+ PD=20.68u rfmode=0
M$178 \$496 pcasc \$441 \$496 sg13_hv_pmos L=4u W=10u AS=3.4p AD=3.4p PS=20.68u
+ PD=20.68u rfmode=0
M$179 \$496 pcasc \$441 \$496 sg13_hv_pmos L=4u W=10u AS=3.4p AD=3.4p PS=20.68u
+ PD=20.68u rfmode=0
M$180 \$496 pcasc \$441 \$496 sg13_hv_pmos L=4u W=10u AS=3.4p AD=3.4p PS=20.68u
+ PD=20.68u rfmode=0
M$181 vdd pbias \$655 vdd sg13_hv_pmos L=4u W=5u AS=1.7p AD=1.7p PS=10.68u
+ PD=10.68u rfmode=0
M$182 vdd pbias \$442 vdd sg13_hv_pmos L=4u W=5u AS=1.7p AD=1.7p PS=10.68u
+ PD=10.68u rfmode=0
M$183 vdd pbias \$655 vdd sg13_hv_pmos L=4u W=5u AS=1.7p AD=1.7p PS=10.68u
+ PD=10.68u rfmode=0
M$184 vdd pbias \$442 vdd sg13_hv_pmos L=4u W=5u AS=1.7p AD=1.7p PS=10.68u
+ PD=10.68u rfmode=0
M$185 vdd pbias \$442 vdd sg13_hv_pmos L=4u W=5u AS=1.7p AD=1.7p PS=10.68u
+ PD=10.68u rfmode=0
M$186 vdd pbias \$655 vdd sg13_hv_pmos L=4u W=5u AS=1.7p AD=1.7p PS=10.68u
+ PD=10.68u rfmode=0
M$187 vdd pbias \$655 vdd sg13_hv_pmos L=4u W=5u AS=1.7p AD=1.7p PS=10.68u
+ PD=10.68u rfmode=0
M$188 vdd pbias \$442 vdd sg13_hv_pmos L=4u W=5u AS=1.7p AD=1.7p PS=10.68u
+ PD=10.68u rfmode=0
M$189 vdd pbias \$496 vdd sg13_hv_pmos L=4u W=5u AS=1.7p AD=1.7p PS=10.68u
+ PD=10.68u rfmode=0
M$190 vdd pbias \$442 vdd sg13_hv_pmos L=4u W=5u AS=1.7p AD=1.7p PS=10.68u
+ PD=10.68u rfmode=0
M$191 vdd pbias \$442 vdd sg13_hv_pmos L=4u W=5u AS=1.7p AD=1.7p PS=10.68u
+ PD=10.68u rfmode=0
M$192 vdd pbias \$496 vdd sg13_hv_pmos L=4u W=5u AS=1.7p AD=1.7p PS=10.68u
+ PD=10.68u rfmode=0
M$193 vdd pbias \$442 vdd sg13_hv_pmos L=4u W=5u AS=1.7p AD=1.7p PS=10.68u
+ PD=10.68u rfmode=0
M$194 vdd pbias \$496 vdd sg13_hv_pmos L=4u W=5u AS=1.7p AD=1.7p PS=10.68u
+ PD=10.68u rfmode=0
M$195 vdd pbias \$496 vdd sg13_hv_pmos L=4u W=5u AS=1.7p AD=1.7p PS=10.68u
+ PD=10.68u rfmode=0
M$196 vdd pbias \$442 vdd sg13_hv_pmos L=4u W=5u AS=1.7p AD=1.7p PS=10.68u
+ PD=10.68u rfmode=0
M$197 vdd pbias \$442 vdd sg13_hv_pmos L=4u W=5u AS=1.7p AD=1.7p PS=10.68u
+ PD=10.68u rfmode=0
M$198 vdd pbias \$496 vdd sg13_hv_pmos L=4u W=5u AS=1.7p AD=1.7p PS=10.68u
+ PD=10.68u rfmode=0
M$199 vdd pbias \$496 vdd sg13_hv_pmos L=4u W=5u AS=1.7p AD=1.7p PS=10.68u
+ PD=10.68u rfmode=0
M$200 vdd pbias \$442 vdd sg13_hv_pmos L=4u W=5u AS=1.7p AD=1.7p PS=10.68u
+ PD=10.68u rfmode=0
M$201 vdd pbias \$496 vdd sg13_hv_pmos L=4u W=5u AS=1.7p AD=1.7p PS=10.68u
+ PD=10.68u rfmode=0
M$202 vdd pbias \$442 vdd sg13_hv_pmos L=4u W=5u AS=1.7p AD=1.7p PS=10.68u
+ PD=10.68u rfmode=0
M$203 vdd pbias \$442 vdd sg13_hv_pmos L=4u W=5u AS=1.7p AD=1.7p PS=10.68u
+ PD=10.68u rfmode=0
M$204 vdd pbias \$496 vdd sg13_hv_pmos L=4u W=5u AS=1.7p AD=1.7p PS=10.68u
+ PD=10.68u rfmode=0
M$205 vdd pbias \$496 vdd sg13_hv_pmos L=4u W=5u AS=1.7p AD=1.7p PS=10.68u
+ PD=10.68u rfmode=0
M$206 vdd pbias \$655 vdd sg13_hv_pmos L=4u W=5u AS=1.7p AD=1.7p PS=10.68u
+ PD=10.68u rfmode=0
M$207 vdd pbias \$655 vdd sg13_hv_pmos L=4u W=5u AS=1.7p AD=1.7p PS=10.68u
+ PD=10.68u rfmode=0
M$208 vdd pbias \$496 vdd sg13_hv_pmos L=4u W=5u AS=1.7p AD=1.7p PS=10.68u
+ PD=10.68u rfmode=0
M$209 vdd pbias \$655 vdd sg13_hv_pmos L=4u W=5u AS=1.7p AD=1.7p PS=10.68u
+ PD=10.68u rfmode=0
M$210 vdd pbias \$496 vdd sg13_hv_pmos L=4u W=5u AS=1.7p AD=1.7p PS=10.68u
+ PD=10.68u rfmode=0
M$211 vdd pbias \$655 vdd sg13_hv_pmos L=4u W=5u AS=1.7p AD=1.7p PS=10.68u
+ PD=10.68u rfmode=0
M$212 vdd pbias \$496 vdd sg13_hv_pmos L=4u W=5u AS=1.7p AD=1.7p PS=10.68u
+ PD=10.68u rfmode=0
M$213 vdd pbias \$655 vdd sg13_hv_pmos L=4u W=5u AS=1.7p AD=1.7p PS=10.68u
+ PD=10.68u rfmode=0
M$214 vdd pbias \$496 vdd sg13_hv_pmos L=4u W=5u AS=1.7p AD=1.7p PS=10.68u
+ PD=10.68u rfmode=0
M$215 vdd pbias \$655 vdd sg13_hv_pmos L=4u W=5u AS=1.7p AD=1.7p PS=10.68u
+ PD=10.68u rfmode=0
M$216 vdd pbias \$496 vdd sg13_hv_pmos L=4u W=5u AS=1.7p AD=1.7p PS=10.68u
+ PD=10.68u rfmode=0
M$217 vdd pbias \$655 vdd sg13_hv_pmos L=4u W=5u AS=1.7p AD=1.7p PS=10.68u
+ PD=10.68u rfmode=0
M$218 vdd pbias \$496 vdd sg13_hv_pmos L=4u W=5u AS=1.7p AD=1.7p PS=10.68u
+ PD=10.68u rfmode=0
M$219 vdd pbias \$655 vdd sg13_hv_pmos L=4u W=5u AS=1.7p AD=1.7p PS=10.68u
+ PD=10.68u rfmode=0
M$220 vdd pbias \$496 vdd sg13_hv_pmos L=4u W=5u AS=1.7p AD=1.7p PS=10.68u
+ PD=10.68u rfmode=0
M$221 vdd pbias \$496 vdd sg13_hv_pmos L=4u W=5u AS=1.7p AD=1.7p PS=10.68u
+ PD=10.68u rfmode=0
M$222 vdd pbias \$496 vdd sg13_hv_pmos L=4u W=5u AS=1.7p AD=1.7p PS=10.68u
+ PD=10.68u rfmode=0
M$223 vdd pbias \$496 vdd sg13_hv_pmos L=4u W=5u AS=1.7p AD=1.7p PS=10.68u
+ PD=10.68u rfmode=0
M$224 vdd pbias \$496 vdd sg13_hv_pmos L=4u W=5u AS=1.7p AD=1.7p PS=10.68u
+ PD=10.68u rfmode=0
M$225 vdd pbias \$496 vdd sg13_hv_pmos L=4u W=5u AS=1.7p AD=1.7p PS=10.68u
+ PD=10.68u rfmode=0
M$226 vdd pbias \$496 vdd sg13_hv_pmos L=4u W=5u AS=1.7p AD=1.7p PS=10.68u
+ PD=10.68u rfmode=0
M$227 vdd pbias \$496 vdd sg13_hv_pmos L=4u W=5u AS=1.7p AD=1.7p PS=10.68u
+ PD=10.68u rfmode=0
M$228 vdd pbias \$496 vdd sg13_hv_pmos L=4u W=5u AS=1.7p AD=1.7p PS=10.68u
+ PD=10.68u rfmode=0
M$229 vdd pbias \$655 vdd sg13_hv_pmos L=4u W=5u AS=1.7p AD=1.7p PS=10.68u
+ PD=10.68u rfmode=0
M$230 vdd pbias \$655 vdd sg13_hv_pmos L=4u W=5u AS=1.7p AD=1.7p PS=10.68u
+ PD=10.68u rfmode=0
M$231 vdd pbias \$655 vdd sg13_hv_pmos L=4u W=5u AS=1.7p AD=1.7p PS=10.68u
+ PD=10.68u rfmode=0
M$232 vdd pbias \$655 vdd sg13_hv_pmos L=4u W=5u AS=1.7p AD=1.7p PS=10.68u
+ PD=10.68u rfmode=0
M$233 vdd pbias \$655 vdd sg13_hv_pmos L=4u W=5u AS=1.7p AD=1.7p PS=10.68u
+ PD=10.68u rfmode=0
M$234 vdd pbias \$655 vdd sg13_hv_pmos L=4u W=5u AS=1.7p AD=1.7p PS=10.68u
+ PD=10.68u rfmode=0
M$235 vdd pbias \$655 vdd sg13_hv_pmos L=4u W=5u AS=1.7p AD=1.7p PS=10.68u
+ PD=10.68u rfmode=0
M$236 vdd pbias \$655 vdd sg13_hv_pmos L=4u W=5u AS=1.7p AD=1.7p PS=10.68u
+ PD=10.68u rfmode=0
M$237 vdd pbias \$655 vdd sg13_hv_pmos L=4u W=5u AS=1.7p AD=1.7p PS=10.68u
+ PD=10.68u rfmode=0
M$238 vdd pbias \$655 vdd sg13_hv_pmos L=4u W=5u AS=1.7p AD=1.7p PS=10.68u
+ PD=10.68u rfmode=0
M$239 vdd pbias \$655 vdd sg13_hv_pmos L=4u W=5u AS=1.7p AD=1.7p PS=10.68u
+ PD=10.68u rfmode=0
M$240 vdd pbias \$655 vdd sg13_hv_pmos L=4u W=5u AS=1.7p AD=1.7p PS=10.68u
+ PD=10.68u rfmode=0
M$241 vdd pbias \$442 vdd sg13_hv_pmos L=4u W=5u AS=1.7p AD=1.7p PS=10.68u
+ PD=10.68u rfmode=0
M$242 vdd pbias \$442 vdd sg13_hv_pmos L=4u W=5u AS=1.7p AD=1.7p PS=10.68u
+ PD=10.68u rfmode=0
M$243 vdd pbias \$442 vdd sg13_hv_pmos L=4u W=5u AS=1.7p AD=1.7p PS=10.68u
+ PD=10.68u rfmode=0
M$244 vdd pbias \$442 vdd sg13_hv_pmos L=4u W=5u AS=1.7p AD=1.7p PS=10.68u
+ PD=10.68u rfmode=0
M$245 vdd pbias \$442 vdd sg13_hv_pmos L=4u W=5u AS=1.7p AD=1.7p PS=10.68u
+ PD=10.68u rfmode=0
M$246 vdd pbias \$442 vdd sg13_hv_pmos L=4u W=5u AS=1.7p AD=1.7p PS=10.68u
+ PD=10.68u rfmode=0
M$247 vdd pbias \$442 vdd sg13_hv_pmos L=4u W=5u AS=1.7p AD=1.7p PS=10.68u
+ PD=10.68u rfmode=0
M$248 vdd pbias \$442 vdd sg13_hv_pmos L=4u W=5u AS=1.7p AD=1.7p PS=10.68u
+ PD=10.68u rfmode=0
M$249 vdd pbias \$442 vdd sg13_hv_pmos L=4u W=5u AS=1.7p AD=1.7p PS=10.68u
+ PD=10.68u rfmode=0
M$250 vdd pbias \$442 vdd sg13_hv_pmos L=4u W=5u AS=1.7p AD=1.7p PS=10.68u
+ PD=10.68u rfmode=0
M$251 vdd pbias \$442 vdd sg13_hv_pmos L=4u W=5u AS=1.7p AD=1.7p PS=10.68u
+ PD=10.68u rfmode=0
M$252 vdd pbias \$442 vdd sg13_hv_pmos L=4u W=5u AS=1.7p AD=1.7p PS=10.68u
+ PD=10.68u rfmode=0
M$253 vdd pbias \$656 vdd sg13_hv_pmos L=4u W=5u AS=1.7p AD=1.7p PS=10.68u
+ PD=10.68u rfmode=0
M$254 vdd pbias \$656 vdd sg13_hv_pmos L=4u W=5u AS=1.7p AD=1.7p PS=10.68u
+ PD=10.68u rfmode=0
M$255 vdd pbias \$656 vdd sg13_hv_pmos L=4u W=5u AS=1.7p AD=1.7p PS=10.68u
+ PD=10.68u rfmode=0
M$256 vdd pbias \$656 vdd sg13_hv_pmos L=4u W=5u AS=1.7p AD=1.7p PS=10.68u
+ PD=10.68u rfmode=0
M$257 vdd pbias \$657 vdd sg13_hv_pmos L=4u W=5u AS=1.7p AD=1.7p PS=10.68u
+ PD=10.68u rfmode=0
M$258 vdd pbias \$11 vdd sg13_hv_pmos L=4u W=5u AS=1.7p AD=1.7p PS=10.68u
+ PD=10.68u rfmode=0
M$259 vdd pbias \$657 vdd sg13_hv_pmos L=4u W=5u AS=1.7p AD=1.7p PS=10.68u
+ PD=10.68u rfmode=0
M$260 vdd pbias \$11 vdd sg13_hv_pmos L=4u W=5u AS=1.7p AD=1.7p PS=10.68u
+ PD=10.68u rfmode=0
M$261 vdd pbias \$655 vdd sg13_hv_pmos L=4u W=5u AS=1.7p AD=1.7p PS=10.68u
+ PD=10.68u rfmode=0
M$262 vdd pbias \$655 vdd sg13_hv_pmos L=4u W=5u AS=1.7p AD=1.7p PS=10.68u
+ PD=10.68u rfmode=0
M$263 vdd pbias \$655 vdd sg13_hv_pmos L=4u W=5u AS=1.7p AD=1.7p PS=10.68u
+ PD=10.68u rfmode=0
M$264 vdd pbias \$655 vdd sg13_hv_pmos L=4u W=5u AS=1.7p AD=1.7p PS=10.68u
+ PD=10.68u rfmode=0
M$265 vdd pbias \$655 vdd sg13_hv_pmos L=4u W=5u AS=1.7p AD=1.7p PS=10.68u
+ PD=10.68u rfmode=0
M$266 vdd pbias \$656 vdd sg13_hv_pmos L=4u W=5u AS=1.7p AD=1.7p PS=10.68u
+ PD=10.68u rfmode=0
M$267 vdd pbias \$655 vdd sg13_hv_pmos L=4u W=5u AS=1.7p AD=1.7p PS=10.68u
+ PD=10.68u rfmode=0
M$268 vdd pbias \$656 vdd sg13_hv_pmos L=4u W=5u AS=1.7p AD=1.7p PS=10.68u
+ PD=10.68u rfmode=0
M$269 vdd pbias \$656 vdd sg13_hv_pmos L=4u W=5u AS=1.7p AD=1.7p PS=10.68u
+ PD=10.68u rfmode=0
M$270 vdd pbias \$655 vdd sg13_hv_pmos L=4u W=5u AS=1.7p AD=1.7p PS=10.68u
+ PD=10.68u rfmode=0
M$271 vdd pbias \$655 vdd sg13_hv_pmos L=4u W=5u AS=1.7p AD=1.7p PS=10.68u
+ PD=10.68u rfmode=0
M$272 vdd pbias \$656 vdd sg13_hv_pmos L=4u W=5u AS=1.7p AD=1.7p PS=10.68u
+ PD=10.68u rfmode=0
M$273 vdd pbias \$442 vdd sg13_hv_pmos L=4u W=5u AS=1.7p AD=1.7p PS=10.68u
+ PD=10.68u rfmode=0
M$274 vdd pbias \$655 vdd sg13_hv_pmos L=4u W=5u AS=1.7p AD=1.7p PS=10.68u
+ PD=10.68u rfmode=0
M$275 vdd pbias \$655 vdd sg13_hv_pmos L=4u W=5u AS=1.7p AD=1.7p PS=10.68u
+ PD=10.68u rfmode=0
M$276 vdd pbias \$442 vdd sg13_hv_pmos L=4u W=5u AS=1.7p AD=1.7p PS=10.68u
+ PD=10.68u rfmode=0
M$277 vdd pbias \$655 vdd sg13_hv_pmos L=4u W=5u AS=1.7p AD=1.7p PS=10.68u
+ PD=10.68u rfmode=0
M$278 vdd pbias \$442 vdd sg13_hv_pmos L=4u W=5u AS=1.7p AD=1.7p PS=10.68u
+ PD=10.68u rfmode=0
M$279 vdd pbias \$655 vdd sg13_hv_pmos L=4u W=5u AS=1.7p AD=1.7p PS=10.68u
+ PD=10.68u rfmode=0
M$280 vdd pbias \$442 vdd sg13_hv_pmos L=4u W=5u AS=1.7p AD=1.7p PS=10.68u
+ PD=10.68u rfmode=0
M$281 vdd pbias \$496 vdd sg13_hv_pmos L=4u W=5u AS=1.7p AD=1.7p PS=10.68u
+ PD=10.68u rfmode=0
M$282 vdd pbias \$442 vdd sg13_hv_pmos L=4u W=5u AS=1.7p AD=1.7p PS=10.68u
+ PD=10.68u rfmode=0
M$283 vdd pbias \$442 vdd sg13_hv_pmos L=4u W=5u AS=1.7p AD=1.7p PS=10.68u
+ PD=10.68u rfmode=0
M$284 vdd pbias \$496 vdd sg13_hv_pmos L=4u W=5u AS=1.7p AD=1.7p PS=10.68u
+ PD=10.68u rfmode=0
M$285 vdd pbias \$442 vdd sg13_hv_pmos L=4u W=5u AS=1.7p AD=1.7p PS=10.68u
+ PD=10.68u rfmode=0
M$286 vdd pbias \$496 vdd sg13_hv_pmos L=4u W=5u AS=1.7p AD=1.7p PS=10.68u
+ PD=10.68u rfmode=0
M$287 vdd pbias \$496 vdd sg13_hv_pmos L=4u W=5u AS=1.7p AD=1.7p PS=10.68u
+ PD=10.68u rfmode=0
M$288 vdd pbias \$442 vdd sg13_hv_pmos L=4u W=5u AS=1.7p AD=1.7p PS=10.68u
+ PD=10.68u rfmode=0
M$289 vdd pbias \$442 vdd sg13_hv_pmos L=4u W=5u AS=1.7p AD=1.7p PS=10.68u
+ PD=10.68u rfmode=0
M$290 vdd pbias \$496 vdd sg13_hv_pmos L=4u W=5u AS=1.7p AD=1.7p PS=10.68u
+ PD=10.68u rfmode=0
M$291 vdd pbias \$496 vdd sg13_hv_pmos L=4u W=5u AS=1.7p AD=1.7p PS=10.68u
+ PD=10.68u rfmode=0
M$292 vdd pbias \$442 vdd sg13_hv_pmos L=4u W=5u AS=1.7p AD=1.7p PS=10.68u
+ PD=10.68u rfmode=0
M$293 vdd pbias \$496 vdd sg13_hv_pmos L=4u W=5u AS=1.7p AD=1.7p PS=10.68u
+ PD=10.68u rfmode=0
M$294 vdd pbias \$442 vdd sg13_hv_pmos L=4u W=5u AS=1.7p AD=1.7p PS=10.68u
+ PD=10.68u rfmode=0
M$295 vdd pbias \$442 vdd sg13_hv_pmos L=4u W=5u AS=1.7p AD=1.7p PS=10.68u
+ PD=10.68u rfmode=0
M$296 vdd pbias \$496 vdd sg13_hv_pmos L=4u W=5u AS=1.7p AD=1.7p PS=10.68u
+ PD=10.68u rfmode=0
M$297 vdd pbias \$496 vdd sg13_hv_pmos L=4u W=5u AS=1.7p AD=1.7p PS=10.68u
+ PD=10.68u rfmode=0
M$298 vdd pbias \$496 vdd sg13_hv_pmos L=4u W=5u AS=1.7p AD=1.7p PS=10.68u
+ PD=10.68u rfmode=0
M$299 vdd pbias \$496 vdd sg13_hv_pmos L=4u W=5u AS=1.7p AD=1.7p PS=10.68u
+ PD=10.68u rfmode=0
M$300 vdd pbias \$496 vdd sg13_hv_pmos L=4u W=5u AS=1.7p AD=1.7p PS=10.68u
+ PD=10.68u rfmode=0
M$301 vdd pbias \$496 vdd sg13_hv_pmos L=4u W=5u AS=1.7p AD=1.7p PS=10.68u
+ PD=10.68u rfmode=0
M$302 vdd pbias \$496 vdd sg13_hv_pmos L=4u W=5u AS=1.7p AD=1.7p PS=10.68u
+ PD=10.68u rfmode=0
M$303 vdd pbias \$496 vdd sg13_hv_pmos L=4u W=5u AS=1.7p AD=1.7p PS=10.68u
+ PD=10.68u rfmode=0
M$304 vdd pbias \$496 vdd sg13_hv_pmos L=4u W=5u AS=1.7p AD=1.7p PS=10.68u
+ PD=10.68u rfmode=0
M$305 vdd pbias \$496 vdd sg13_hv_pmos L=4u W=5u AS=1.7p AD=1.7p PS=10.68u
+ PD=10.68u rfmode=0
M$306 vdd pbias \$496 vdd sg13_hv_pmos L=4u W=5u AS=1.7p AD=1.7p PS=10.68u
+ PD=10.68u rfmode=0
M$307 vdd pbias \$496 vdd sg13_hv_pmos L=4u W=5u AS=1.7p AD=1.7p PS=10.68u
+ PD=10.68u rfmode=0
M$308 vdd pbias \$496 vdd sg13_hv_pmos L=4u W=5u AS=1.7p AD=1.7p PS=10.68u
+ PD=10.68u rfmode=0
M$309 vdd pbias \$496 vdd sg13_hv_pmos L=4u W=5u AS=1.7p AD=1.7p PS=10.68u
+ PD=10.68u rfmode=0
M$310 vdd pbias \$496 vdd sg13_hv_pmos L=4u W=5u AS=1.7p AD=1.7p PS=10.68u
+ PD=10.68u rfmode=0
M$311 vdd pbias \$496 vdd sg13_hv_pmos L=4u W=5u AS=1.7p AD=1.7p PS=10.68u
+ PD=10.68u rfmode=0
M$312 vdd pbias \$496 vdd sg13_hv_pmos L=4u W=5u AS=1.7p AD=1.7p PS=10.68u
+ PD=10.68u rfmode=0
M$313 vdd pbias \$655 vdd sg13_hv_pmos L=4u W=5u AS=1.7p AD=1.7p PS=10.68u
+ PD=10.68u rfmode=0
M$314 vdd pbias \$655 vdd sg13_hv_pmos L=4u W=5u AS=1.7p AD=1.7p PS=10.68u
+ PD=10.68u rfmode=0
M$315 vdd pbias \$655 vdd sg13_hv_pmos L=4u W=5u AS=1.7p AD=1.7p PS=10.68u
+ PD=10.68u rfmode=0
M$316 vdd pbias \$655 vdd sg13_hv_pmos L=4u W=5u AS=1.7p AD=1.7p PS=10.68u
+ PD=10.68u rfmode=0
M$317 vdd pbias \$655 vdd sg13_hv_pmos L=4u W=5u AS=1.7p AD=1.7p PS=10.68u
+ PD=10.68u rfmode=0
M$318 vdd pbias \$655 vdd sg13_hv_pmos L=4u W=5u AS=1.7p AD=1.7p PS=10.68u
+ PD=10.68u rfmode=0
M$319 vdd pbias \$655 vdd sg13_hv_pmos L=4u W=5u AS=1.7p AD=1.7p PS=10.68u
+ PD=10.68u rfmode=0
M$320 vdd pbias \$655 vdd sg13_hv_pmos L=4u W=5u AS=1.7p AD=1.7p PS=10.68u
+ PD=10.68u rfmode=0
M$321 vdd pbias \$655 vdd sg13_hv_pmos L=4u W=5u AS=1.7p AD=1.7p PS=10.68u
+ PD=10.68u rfmode=0
M$322 vdd pbias \$655 vdd sg13_hv_pmos L=4u W=5u AS=1.7p AD=1.7p PS=10.68u
+ PD=10.68u rfmode=0
M$323 vdd pbias \$655 vdd sg13_hv_pmos L=4u W=5u AS=1.7p AD=1.7p PS=10.68u
+ PD=10.68u rfmode=0
M$324 vdd pbias \$655 vdd sg13_hv_pmos L=4u W=5u AS=1.7p AD=1.7p PS=10.68u
+ PD=10.68u rfmode=0
M$325 vdd pbias \$442 vdd sg13_hv_pmos L=4u W=5u AS=1.7p AD=1.7p PS=10.68u
+ PD=10.68u rfmode=0
M$326 vdd pbias \$442 vdd sg13_hv_pmos L=4u W=5u AS=1.7p AD=1.7p PS=10.68u
+ PD=10.68u rfmode=0
M$327 vdd pbias \$442 vdd sg13_hv_pmos L=4u W=5u AS=1.7p AD=1.7p PS=10.68u
+ PD=10.68u rfmode=0
M$328 vdd pbias \$442 vdd sg13_hv_pmos L=4u W=5u AS=1.7p AD=1.7p PS=10.68u
+ PD=10.68u rfmode=0
M$329 vdd pbias \$442 vdd sg13_hv_pmos L=4u W=5u AS=1.7p AD=1.7p PS=10.68u
+ PD=10.68u rfmode=0
M$330 vdd pbias \$442 vdd sg13_hv_pmos L=4u W=5u AS=1.7p AD=1.7p PS=10.68u
+ PD=10.68u rfmode=0
M$331 vdd pbias \$442 vdd sg13_hv_pmos L=4u W=5u AS=1.7p AD=1.7p PS=10.68u
+ PD=10.68u rfmode=0
M$332 vdd pbias \$442 vdd sg13_hv_pmos L=4u W=5u AS=1.7p AD=1.7p PS=10.68u
+ PD=10.68u rfmode=0
M$333 vdd pbias \$442 vdd sg13_hv_pmos L=4u W=5u AS=1.7p AD=1.7p PS=10.68u
+ PD=10.68u rfmode=0
M$334 vdd pbias \$442 vdd sg13_hv_pmos L=4u W=5u AS=1.7p AD=1.7p PS=10.68u
+ PD=10.68u rfmode=0
M$335 vdd pbias \$442 vdd sg13_hv_pmos L=4u W=5u AS=1.7p AD=1.7p PS=10.68u
+ PD=10.68u rfmode=0
M$336 vdd pbias \$442 vdd sg13_hv_pmos L=4u W=5u AS=1.7p AD=1.7p PS=10.68u
+ PD=10.68u rfmode=0
Q$337 vbe vbe vss vss npn13G2 we=70n le=900n Nx=1 m=1
Q$338 vbe vbe vss vss npn13G2 we=70n le=900n Nx=1 m=1
Q$339 vbe vbe vss vss npn13G2 we=70n le=900n Nx=1 m=1
Q$340 vbe vbe vss vss npn13G2 we=70n le=900n Nx=1 m=1
Q$341 vbe vbe vss vss npn13G2 we=70n le=900n Nx=1 m=1
Q$342 vbe vbe vss vss npn13G2 we=70n le=900n Nx=1 m=1
Q$343 vbe vbe vss vss npn13G2 we=70n le=900n Nx=1 m=1
Q$344 vbe vbe vss vss npn13G2 we=70n le=900n Nx=1 m=1
Q$345 vbe vbe vss vss npn13G2 we=70n le=900n Nx=1 m=1
Q$346 vbe vbe vss vss npn13G2 we=70n le=900n Nx=1 m=1
Q$347 vbe vbe vss vss npn13G2 we=70n le=900n Nx=1 m=1
Q$348 vbe vbe vss vss npn13G2 we=70n le=900n Nx=1 m=1
Q$349 \$440 \$440 vss vss npn13G2 we=70n le=900n Nx=1 m=1
Q$350 \$440 \$440 vss vss npn13G2 we=70n le=900n Nx=1 m=1
Q$351 \$440 \$440 vss vss npn13G2 we=70n le=900n Nx=1 m=1
Q$352 \$440 \$440 vss vss npn13G2 we=70n le=900n Nx=1 m=1
Q$353 \$440 \$440 vss vss npn13G2 we=70n le=900n Nx=1 m=1
Q$354 \$440 \$440 vss vss npn13G2 we=70n le=900n Nx=1 m=1
Q$355 \$440 \$440 vss vss npn13G2 we=70n le=900n Nx=1 m=1
Q$356 \$440 \$440 vss vss npn13G2 we=70n le=900n Nx=1 m=1
Q$357 \$440 \$440 vss vss npn13G2 we=70n le=900n Nx=1 m=1
Q$358 \$440 \$440 vss vss npn13G2 we=70n le=900n Nx=1 m=1
Q$359 \$440 \$440 vss vss npn13G2 we=70n le=900n Nx=1 m=1
Q$360 \$440 \$440 vss vss npn13G2 we=70n le=900n Nx=1 m=1
Q$361 vbe \$569 vss vss npn13G2 we=70n le=900n Nx=1 m=1
Q$362 vbe \$569 vss vss npn13G2 we=70n le=900n Nx=1 m=1
Q$363 vbe \$569 vss vss npn13G2 we=70n le=900n Nx=1 m=1
Q$364 vbe \$569 vss vss npn13G2 we=70n le=900n Nx=1 m=1
Q$365 vbe \$569 vss vss npn13G2 we=70n le=900n Nx=1 m=1
Q$366 vbe \$569 vss vss npn13G2 we=70n le=900n Nx=1 m=1
Q$367 vbe \$569 vss vss npn13G2 we=70n le=900n Nx=1 m=1
Q$368 vbe \$569 vss vss npn13G2 we=70n le=900n Nx=1 m=1
Q$369 vbe \$569 vss vss npn13G2 we=70n le=900n Nx=1 m=1
Q$370 vbe \$569 vss vss npn13G2 we=70n le=900n Nx=1 m=1
Q$371 vbe \$569 vss vss npn13G2 we=70n le=900n Nx=1 m=1
Q$372 vbe \$569 vss vss npn13G2 we=70n le=900n Nx=1 m=1
Q$373 \$750 vbe dvbe vss npn13G2 we=70n le=900n Nx=1 m=1
Q$374 \$750 vbe dvbe vss npn13G2 we=70n le=900n Nx=1 m=1
Q$375 \$750 vbe dvbe vss npn13G2 we=70n le=900n Nx=1 m=1
Q$376 \$750 vbe dvbe vss npn13G2 we=70n le=900n Nx=1 m=1
Q$377 \$750 vbe dvbe vss npn13G2 we=70n le=900n Nx=1 m=1
Q$378 \$750 vbe dvbe vss npn13G2 we=70n le=900n Nx=1 m=1
Q$379 \$750 vbe dvbe vss npn13G2 we=70n le=900n Nx=1 m=1
Q$380 \$750 vbe dvbe vss npn13G2 we=70n le=900n Nx=1 m=1
Q$381 \$750 vbe dvbe vss npn13G2 we=70n le=900n Nx=1 m=1
Q$382 \$750 vbe dvbe vss npn13G2 we=70n le=900n Nx=1 m=1
Q$383 \$750 vbe dvbe vss npn13G2 we=70n le=900n Nx=1 m=1
Q$384 \$750 vbe dvbe vss npn13G2 we=70n le=900n Nx=1 m=1
Q$385 \$750 vbe dvbe vss npn13G2 we=70n le=900n Nx=1 m=1
Q$386 \$750 vbe dvbe vss npn13G2 we=70n le=900n Nx=1 m=1
Q$387 \$750 vbe dvbe vss npn13G2 we=70n le=900n Nx=1 m=1
Q$388 \$750 vbe dvbe vss npn13G2 we=70n le=900n Nx=1 m=1
Q$389 \$750 vbe dvbe vss npn13G2 we=70n le=900n Nx=1 m=1
Q$390 \$750 vbe dvbe vss npn13G2 we=70n le=900n Nx=1 m=1
Q$391 \$750 vbe dvbe vss npn13G2 we=70n le=900n Nx=1 m=1
Q$392 \$750 vbe dvbe vss npn13G2 we=70n le=900n Nx=1 m=1
Q$393 \$750 vbe dvbe vss npn13G2 we=70n le=900n Nx=1 m=1
Q$394 \$750 vbe dvbe vss npn13G2 we=70n le=900n Nx=1 m=1
Q$395 \$750 vbe dvbe vss npn13G2 we=70n le=900n Nx=1 m=1
Q$396 \$750 vbe dvbe vss npn13G2 we=70n le=900n Nx=1 m=1
Q$397 \$750 vbe dvbe vss npn13G2 we=70n le=900n Nx=1 m=1
Q$398 \$750 vbe dvbe vss npn13G2 we=70n le=900n Nx=1 m=1
Q$399 \$750 vbe dvbe vss npn13G2 we=70n le=900n Nx=1 m=1
Q$400 \$750 vbe dvbe vss npn13G2 we=70n le=900n Nx=1 m=1
Q$401 \$750 vbe dvbe vss npn13G2 we=70n le=900n Nx=1 m=1
Q$402 \$750 vbe dvbe vss npn13G2 we=70n le=900n Nx=1 m=1
Q$403 \$750 vbe dvbe vss npn13G2 we=70n le=900n Nx=1 m=1
Q$404 \$750 vbe dvbe vss npn13G2 we=70n le=900n Nx=1 m=1
Q$405 \$750 vbe dvbe vss npn13G2 we=70n le=900n Nx=1 m=1
Q$406 \$750 vbe dvbe vss npn13G2 we=70n le=900n Nx=1 m=1
Q$407 \$750 vbe dvbe vss npn13G2 we=70n le=900n Nx=1 m=1
Q$408 \$750 vbe dvbe vss npn13G2 we=70n le=900n Nx=1 m=1
Q$409 \$750 vbe dvbe vss npn13G2 we=70n le=900n Nx=1 m=1
Q$410 \$750 vbe dvbe vss npn13G2 we=70n le=900n Nx=1 m=1
Q$411 \$750 vbe dvbe vss npn13G2 we=70n le=900n Nx=1 m=1
Q$412 \$750 vbe dvbe vss npn13G2 we=70n le=900n Nx=1 m=1
Q$413 \$750 vbe dvbe vss npn13G2 we=70n le=900n Nx=1 m=1
Q$414 \$750 vbe dvbe vss npn13G2 we=70n le=900n Nx=1 m=1
Q$415 \$750 vbe dvbe vss npn13G2 we=70n le=900n Nx=1 m=1
Q$416 \$750 vbe dvbe vss npn13G2 we=70n le=900n Nx=1 m=1
Q$417 \$750 vbe dvbe vss npn13G2 we=70n le=900n Nx=1 m=1
Q$418 \$750 vbe dvbe vss npn13G2 we=70n le=900n Nx=1 m=1
Q$419 \$750 vbe dvbe vss npn13G2 we=70n le=900n Nx=1 m=1
Q$420 \$750 vbe dvbe vss npn13G2 we=70n le=900n Nx=1 m=1
Q$421 \$750 vbe dvbe vss npn13G2 we=70n le=900n Nx=1 m=1
Q$422 \$750 vbe dvbe vss npn13G2 we=70n le=900n Nx=1 m=1
Q$423 \$750 vbe dvbe vss npn13G2 we=70n le=900n Nx=1 m=1
Q$424 \$750 vbe dvbe vss npn13G2 we=70n le=900n Nx=1 m=1
Q$425 \$750 vbe dvbe vss npn13G2 we=70n le=900n Nx=1 m=1
Q$426 \$750 vbe dvbe vss npn13G2 we=70n le=900n Nx=1 m=1
Q$427 \$750 vbe dvbe vss npn13G2 we=70n le=900n Nx=1 m=1
Q$428 \$750 vbe dvbe vss npn13G2 we=70n le=900n Nx=1 m=1
Q$429 \$750 vbe dvbe vss npn13G2 we=70n le=900n Nx=1 m=1
Q$430 \$750 vbe dvbe vss npn13G2 we=70n le=900n Nx=1 m=1
Q$431 \$750 vbe dvbe vss npn13G2 we=70n le=900n Nx=1 m=1
Q$432 \$750 vbe dvbe vss npn13G2 we=70n le=900n Nx=1 m=1
Q$433 \$750 vbe dvbe vss npn13G2 we=70n le=900n Nx=1 m=1
Q$434 \$750 vbe dvbe vss npn13G2 we=70n le=900n Nx=1 m=1
Q$435 \$750 vbe dvbe vss npn13G2 we=70n le=900n Nx=1 m=1
Q$436 \$750 vbe dvbe vss npn13G2 we=70n le=900n Nx=1 m=1
Q$437 \$750 vbe dvbe vss npn13G2 we=70n le=900n Nx=1 m=1
Q$438 \$750 vbe dvbe vss npn13G2 we=70n le=900n Nx=1 m=1
Q$439 \$750 vbe dvbe vss npn13G2 we=70n le=900n Nx=1 m=1
Q$440 \$750 vbe dvbe vss npn13G2 we=70n le=900n Nx=1 m=1
Q$441 \$750 vbe dvbe vss npn13G2 we=70n le=900n Nx=1 m=1
Q$442 \$750 vbe dvbe vss npn13G2 we=70n le=900n Nx=1 m=1
Q$443 \$750 vbe dvbe vss npn13G2 we=70n le=900n Nx=1 m=1
Q$444 \$750 vbe dvbe vss npn13G2 we=70n le=900n Nx=1 m=1
Q$445 \$750 vbe dvbe vss npn13G2 we=70n le=900n Nx=1 m=1
Q$446 \$750 vbe dvbe vss npn13G2 we=70n le=900n Nx=1 m=1
Q$447 \$750 vbe dvbe vss npn13G2 we=70n le=900n Nx=1 m=1
Q$448 \$750 vbe dvbe vss npn13G2 we=70n le=900n Nx=1 m=1
Q$449 \$750 vbe dvbe vss npn13G2 we=70n le=900n Nx=1 m=1
Q$450 \$750 vbe dvbe vss npn13G2 we=70n le=900n Nx=1 m=1
Q$451 \$750 vbe dvbe vss npn13G2 we=70n le=900n Nx=1 m=1
Q$452 \$750 vbe dvbe vss npn13G2 we=70n le=900n Nx=1 m=1
Q$453 \$750 vbe dvbe vss npn13G2 we=70n le=900n Nx=1 m=1
Q$454 \$750 vbe dvbe vss npn13G2 we=70n le=900n Nx=1 m=1
Q$455 \$750 vbe dvbe vss npn13G2 we=70n le=900n Nx=1 m=1
Q$456 \$750 vbe dvbe vss npn13G2 we=70n le=900n Nx=1 m=1
Q$457 \$236 \$236 \$440 vss npn13G2 we=70n le=900n Nx=1 m=1
Q$458 \$236 \$236 \$440 vss npn13G2 we=70n le=900n Nx=1 m=1
Q$459 \$236 \$236 \$440 vss npn13G2 we=70n le=900n Nx=1 m=1
Q$460 \$236 \$236 \$440 vss npn13G2 we=70n le=900n Nx=1 m=1
Q$461 \$236 \$236 \$440 vss npn13G2 we=70n le=900n Nx=1 m=1
Q$462 \$236 \$236 \$440 vss npn13G2 we=70n le=900n Nx=1 m=1
Q$463 \$236 \$236 \$440 vss npn13G2 we=70n le=900n Nx=1 m=1
Q$464 \$236 \$236 \$440 vss npn13G2 we=70n le=900n Nx=1 m=1
Q$465 \$236 \$236 \$440 vss npn13G2 we=70n le=900n Nx=1 m=1
Q$466 \$236 \$236 \$440 vss npn13G2 we=70n le=900n Nx=1 m=1
Q$467 \$236 \$236 \$440 vss npn13G2 we=70n le=900n Nx=1 m=1
Q$468 \$236 \$236 \$440 vss npn13G2 we=70n le=900n Nx=1 m=1
Q$469 \$750 vbe dvbe vss npn13G2 we=70n le=900n Nx=1 m=1
Q$470 \$750 vbe dvbe vss npn13G2 we=70n le=900n Nx=1 m=1
Q$471 \$750 vbe dvbe vss npn13G2 we=70n le=900n Nx=1 m=1
Q$472 \$750 vbe dvbe vss npn13G2 we=70n le=900n Nx=1 m=1
Q$473 \$750 vbe dvbe vss npn13G2 we=70n le=900n Nx=1 m=1
Q$474 \$750 vbe dvbe vss npn13G2 we=70n le=900n Nx=1 m=1
Q$475 \$750 vbe dvbe vss npn13G2 we=70n le=900n Nx=1 m=1
Q$476 \$750 vbe dvbe vss npn13G2 we=70n le=900n Nx=1 m=1
Q$477 \$750 vbe dvbe vss npn13G2 we=70n le=900n Nx=1 m=1
Q$478 \$750 vbe dvbe vss npn13G2 we=70n le=900n Nx=1 m=1
Q$479 \$750 vbe dvbe vss npn13G2 we=70n le=900n Nx=1 m=1
Q$480 \$750 vbe dvbe vss npn13G2 we=70n le=900n Nx=1 m=1
Q$481 \$233 \$233 vss vss npn13G2 we=70n le=900n Nx=1 m=1
Q$482 \$233 \$233 vss vss npn13G2 we=70n le=900n Nx=1 m=1
Q$492 \$233 \$233 vss vss npn13G2 we=70n le=900n Nx=1 m=1
Q$493 \$233 \$233 vss vss npn13G2 we=70n le=900n Nx=1 m=1
Q$494 \$750 vbe dvbe vss npn13G2 we=70n le=900n Nx=1 m=1
Q$495 \$750 vbe dvbe vss npn13G2 we=70n le=900n Nx=1 m=1
Q$496 \$750 vbe dvbe vss npn13G2 we=70n le=900n Nx=1 m=1
Q$497 \$750 vbe dvbe vss npn13G2 we=70n le=900n Nx=1 m=1
Q$498 \$750 vbe dvbe vss npn13G2 we=70n le=900n Nx=1 m=1
Q$499 \$750 vbe dvbe vss npn13G2 we=70n le=900n Nx=1 m=1
Q$500 \$750 vbe dvbe vss npn13G2 we=70n le=900n Nx=1 m=1
Q$501 \$750 vbe dvbe vss npn13G2 we=70n le=900n Nx=1 m=1
Q$502 \$750 vbe dvbe vss npn13G2 we=70n le=900n Nx=1 m=1
Q$503 \$750 vbe dvbe vss npn13G2 we=70n le=900n Nx=1 m=1
Q$504 \$750 vbe dvbe vss npn13G2 we=70n le=900n Nx=1 m=1
Q$505 \$750 vbe dvbe vss npn13G2 we=70n le=900n Nx=1 m=1
Q$506 \$236 \$236 \$440 vss npn13G2 we=70n le=900n Nx=1 m=1
Q$507 \$236 \$236 \$440 vss npn13G2 we=70n le=900n Nx=1 m=1
Q$508 \$236 \$236 \$440 vss npn13G2 we=70n le=900n Nx=1 m=1
Q$509 \$236 \$236 \$440 vss npn13G2 we=70n le=900n Nx=1 m=1
Q$510 \$236 \$236 \$440 vss npn13G2 we=70n le=900n Nx=1 m=1
Q$511 \$236 \$236 \$440 vss npn13G2 we=70n le=900n Nx=1 m=1
Q$512 \$236 \$236 \$440 vss npn13G2 we=70n le=900n Nx=1 m=1
Q$513 \$236 \$236 \$440 vss npn13G2 we=70n le=900n Nx=1 m=1
Q$514 \$236 \$236 \$440 vss npn13G2 we=70n le=900n Nx=1 m=1
Q$515 \$236 \$236 \$440 vss npn13G2 we=70n le=900n Nx=1 m=1
Q$516 \$236 \$236 \$440 vss npn13G2 we=70n le=900n Nx=1 m=1
Q$517 \$236 \$236 \$440 vss npn13G2 we=70n le=900n Nx=1 m=1
Q$518 \$750 vbe dvbe vss npn13G2 we=70n le=900n Nx=1 m=1
Q$519 \$750 vbe dvbe vss npn13G2 we=70n le=900n Nx=1 m=1
Q$520 \$750 vbe dvbe vss npn13G2 we=70n le=900n Nx=1 m=1
Q$521 \$750 vbe dvbe vss npn13G2 we=70n le=900n Nx=1 m=1
Q$522 \$750 vbe dvbe vss npn13G2 we=70n le=900n Nx=1 m=1
Q$523 \$750 vbe dvbe vss npn13G2 we=70n le=900n Nx=1 m=1
Q$524 \$750 vbe dvbe vss npn13G2 we=70n le=900n Nx=1 m=1
Q$525 \$750 vbe dvbe vss npn13G2 we=70n le=900n Nx=1 m=1
Q$526 \$750 vbe dvbe vss npn13G2 we=70n le=900n Nx=1 m=1
Q$527 \$750 vbe dvbe vss npn13G2 we=70n le=900n Nx=1 m=1
Q$528 \$750 vbe dvbe vss npn13G2 we=70n le=900n Nx=1 m=1
Q$529 \$750 vbe dvbe vss npn13G2 we=70n le=900n Nx=1 m=1
Q$530 \$750 vbe dvbe vss npn13G2 we=70n le=900n Nx=1 m=1
Q$531 \$750 vbe dvbe vss npn13G2 we=70n le=900n Nx=1 m=1
Q$532 \$750 vbe dvbe vss npn13G2 we=70n le=900n Nx=1 m=1
Q$533 \$750 vbe dvbe vss npn13G2 we=70n le=900n Nx=1 m=1
Q$534 \$750 vbe dvbe vss npn13G2 we=70n le=900n Nx=1 m=1
Q$535 \$750 vbe dvbe vss npn13G2 we=70n le=900n Nx=1 m=1
Q$536 \$750 vbe dvbe vss npn13G2 we=70n le=900n Nx=1 m=1
Q$537 \$750 vbe dvbe vss npn13G2 we=70n le=900n Nx=1 m=1
Q$538 \$750 vbe dvbe vss npn13G2 we=70n le=900n Nx=1 m=1
Q$539 \$750 vbe dvbe vss npn13G2 we=70n le=900n Nx=1 m=1
Q$540 \$750 vbe dvbe vss npn13G2 we=70n le=900n Nx=1 m=1
Q$541 \$750 vbe dvbe vss npn13G2 we=70n le=900n Nx=1 m=1
Q$542 \$750 vbe dvbe vss npn13G2 we=70n le=900n Nx=1 m=1
Q$543 \$750 vbe dvbe vss npn13G2 we=70n le=900n Nx=1 m=1
Q$544 \$750 vbe dvbe vss npn13G2 we=70n le=900n Nx=1 m=1
Q$545 \$750 vbe dvbe vss npn13G2 we=70n le=900n Nx=1 m=1
Q$546 \$750 vbe dvbe vss npn13G2 we=70n le=900n Nx=1 m=1
Q$547 \$750 vbe dvbe vss npn13G2 we=70n le=900n Nx=1 m=1
Q$548 \$750 vbe dvbe vss npn13G2 we=70n le=900n Nx=1 m=1
Q$549 \$750 vbe dvbe vss npn13G2 we=70n le=900n Nx=1 m=1
Q$550 \$750 vbe dvbe vss npn13G2 we=70n le=900n Nx=1 m=1
Q$551 \$750 vbe dvbe vss npn13G2 we=70n le=900n Nx=1 m=1
Q$552 \$750 vbe dvbe vss npn13G2 we=70n le=900n Nx=1 m=1
Q$553 \$750 vbe dvbe vss npn13G2 we=70n le=900n Nx=1 m=1
Q$554 \$750 vbe dvbe vss npn13G2 we=70n le=900n Nx=1 m=1
Q$555 \$750 vbe dvbe vss npn13G2 we=70n le=900n Nx=1 m=1
Q$556 \$750 vbe dvbe vss npn13G2 we=70n le=900n Nx=1 m=1
Q$557 \$750 vbe dvbe vss npn13G2 we=70n le=900n Nx=1 m=1
Q$558 \$750 vbe dvbe vss npn13G2 we=70n le=900n Nx=1 m=1
Q$559 \$750 vbe dvbe vss npn13G2 we=70n le=900n Nx=1 m=1
Q$560 \$750 vbe dvbe vss npn13G2 we=70n le=900n Nx=1 m=1
Q$561 \$750 vbe dvbe vss npn13G2 we=70n le=900n Nx=1 m=1
Q$562 \$750 vbe dvbe vss npn13G2 we=70n le=900n Nx=1 m=1
Q$563 \$750 vbe dvbe vss npn13G2 we=70n le=900n Nx=1 m=1
Q$564 \$750 vbe dvbe vss npn13G2 we=70n le=900n Nx=1 m=1
Q$565 \$750 vbe dvbe vss npn13G2 we=70n le=900n Nx=1 m=1
Q$566 \$750 vbe dvbe vss npn13G2 we=70n le=900n Nx=1 m=1
Q$567 \$750 vbe dvbe vss npn13G2 we=70n le=900n Nx=1 m=1
Q$568 \$750 vbe dvbe vss npn13G2 we=70n le=900n Nx=1 m=1
Q$569 \$750 vbe dvbe vss npn13G2 we=70n le=900n Nx=1 m=1
Q$570 \$750 vbe dvbe vss npn13G2 we=70n le=900n Nx=1 m=1
Q$571 \$750 vbe dvbe vss npn13G2 we=70n le=900n Nx=1 m=1
Q$572 \$750 vbe dvbe vss npn13G2 we=70n le=900n Nx=1 m=1
Q$573 \$750 vbe dvbe vss npn13G2 we=70n le=900n Nx=1 m=1
Q$574 \$750 vbe dvbe vss npn13G2 we=70n le=900n Nx=1 m=1
Q$575 \$750 vbe dvbe vss npn13G2 we=70n le=900n Nx=1 m=1
Q$576 \$750 vbe dvbe vss npn13G2 we=70n le=900n Nx=1 m=1
Q$577 \$750 vbe dvbe vss npn13G2 we=70n le=900n Nx=1 m=1
Q$578 \$750 vbe dvbe vss npn13G2 we=70n le=900n Nx=1 m=1
Q$579 \$750 vbe dvbe vss npn13G2 we=70n le=900n Nx=1 m=1
Q$580 \$750 vbe dvbe vss npn13G2 we=70n le=900n Nx=1 m=1
Q$581 \$750 vbe dvbe vss npn13G2 we=70n le=900n Nx=1 m=1
Q$582 \$750 vbe dvbe vss npn13G2 we=70n le=900n Nx=1 m=1
Q$583 \$750 vbe dvbe vss npn13G2 we=70n le=900n Nx=1 m=1
Q$584 \$750 vbe dvbe vss npn13G2 we=70n le=900n Nx=1 m=1
Q$585 \$750 vbe dvbe vss npn13G2 we=70n le=900n Nx=1 m=1
Q$586 \$750 vbe dvbe vss npn13G2 we=70n le=900n Nx=1 m=1
Q$587 \$750 vbe dvbe vss npn13G2 we=70n le=900n Nx=1 m=1
Q$588 \$750 vbe dvbe vss npn13G2 we=70n le=900n Nx=1 m=1
Q$589 \$750 vbe dvbe vss npn13G2 we=70n le=900n Nx=1 m=1
Q$590 \$750 vbe dvbe vss npn13G2 we=70n le=900n Nx=1 m=1
Q$591 \$750 vbe dvbe vss npn13G2 we=70n le=900n Nx=1 m=1
Q$592 \$750 vbe dvbe vss npn13G2 we=70n le=900n Nx=1 m=1
Q$593 \$750 vbe dvbe vss npn13G2 we=70n le=900n Nx=1 m=1
Q$594 \$750 vbe dvbe vss npn13G2 we=70n le=900n Nx=1 m=1
Q$595 \$750 vbe dvbe vss npn13G2 we=70n le=900n Nx=1 m=1
Q$596 \$750 vbe dvbe vss npn13G2 we=70n le=900n Nx=1 m=1
Q$597 \$750 vbe dvbe vss npn13G2 we=70n le=900n Nx=1 m=1
Q$598 \$750 vbe dvbe vss npn13G2 we=70n le=900n Nx=1 m=1
Q$599 \$750 vbe dvbe vss npn13G2 we=70n le=900n Nx=1 m=1
Q$600 \$750 vbe dvbe vss npn13G2 we=70n le=900n Nx=1 m=1
Q$601 \$750 vbe dvbe vss npn13G2 we=70n le=900n Nx=1 m=1
Q$602 vbe \$569 vss vss npn13G2 we=70n le=900n Nx=1 m=1
Q$603 vbe \$569 vss vss npn13G2 we=70n le=900n Nx=1 m=1
Q$604 vbe \$569 vss vss npn13G2 we=70n le=900n Nx=1 m=1
Q$605 vbe \$569 vss vss npn13G2 we=70n le=900n Nx=1 m=1
Q$606 vbe \$569 vss vss npn13G2 we=70n le=900n Nx=1 m=1
Q$607 vbe \$569 vss vss npn13G2 we=70n le=900n Nx=1 m=1
Q$608 vbe \$569 vss vss npn13G2 we=70n le=900n Nx=1 m=1
Q$609 vbe \$569 vss vss npn13G2 we=70n le=900n Nx=1 m=1
Q$610 vbe \$569 vss vss npn13G2 we=70n le=900n Nx=1 m=1
Q$611 vbe \$569 vss vss npn13G2 we=70n le=900n Nx=1 m=1
Q$612 vbe \$569 vss vss npn13G2 we=70n le=900n Nx=1 m=1
Q$613 vbe \$569 vss vss npn13G2 we=70n le=900n Nx=1 m=1
Q$614 \$440 \$440 vss vss npn13G2 we=70n le=900n Nx=1 m=1
Q$615 \$440 \$440 vss vss npn13G2 we=70n le=900n Nx=1 m=1
Q$616 \$440 \$440 vss vss npn13G2 we=70n le=900n Nx=1 m=1
Q$617 \$440 \$440 vss vss npn13G2 we=70n le=900n Nx=1 m=1
Q$618 \$440 \$440 vss vss npn13G2 we=70n le=900n Nx=1 m=1
Q$619 \$440 \$440 vss vss npn13G2 we=70n le=900n Nx=1 m=1
Q$620 \$440 \$440 vss vss npn13G2 we=70n le=900n Nx=1 m=1
Q$621 \$440 \$440 vss vss npn13G2 we=70n le=900n Nx=1 m=1
Q$622 \$440 \$440 vss vss npn13G2 we=70n le=900n Nx=1 m=1
Q$623 \$440 \$440 vss vss npn13G2 we=70n le=900n Nx=1 m=1
Q$624 \$440 \$440 vss vss npn13G2 we=70n le=900n Nx=1 m=1
Q$625 \$440 \$440 vss vss npn13G2 we=70n le=900n Nx=1 m=1
Q$626 vbe vbe vss vss npn13G2 we=70n le=900n Nx=1 m=1
Q$627 vbe vbe vss vss npn13G2 we=70n le=900n Nx=1 m=1
Q$628 vbe vbe vss vss npn13G2 we=70n le=900n Nx=1 m=1
Q$629 vbe vbe vss vss npn13G2 we=70n le=900n Nx=1 m=1
Q$630 vbe vbe vss vss npn13G2 we=70n le=900n Nx=1 m=1
Q$631 vbe vbe vss vss npn13G2 we=70n le=900n Nx=1 m=1
Q$632 vbe vbe vss vss npn13G2 we=70n le=900n Nx=1 m=1
Q$633 vbe vbe vss vss npn13G2 we=70n le=900n Nx=1 m=1
Q$634 vbe vbe vss vss npn13G2 we=70n le=900n Nx=1 m=1
Q$635 vbe vbe vss vss npn13G2 we=70n le=900n Nx=1 m=1
Q$636 vbe vbe vss vss npn13G2 we=70n le=900n Nx=1 m=1
Q$637 vbe vbe vss vss npn13G2 we=70n le=900n Nx=1 m=1
R$638 \$230 vref vss rppd w=1u l=53.465u ps=0u b=0 m=1
R$639 \$230 vref vss rppd w=1u l=53.465u ps=0u b=0 m=1
R$640 \$16 \$224 vss rppd w=1u l=53.465u ps=0u b=0 m=1
R$641 \$16 \$224 vss rppd w=1u l=53.465u ps=0u b=0 m=1
R$642 \$230 \$224 vss rppd w=1u l=53.465u ps=0u b=0 m=1
R$643 \$230 \$224 vss rppd w=1u l=53.465u ps=0u b=0 m=1
R$644 \$16 \$229 vss rppd w=1u l=53.465u ps=0u b=0 m=1
R$645 \$16 \$229 vss rppd w=1u l=53.465u ps=0u b=0 m=1
R$646 \$228 \$229 vss rppd w=1u l=53.465u ps=0u b=0 m=1
R$647 \$228 \$229 vss rppd w=1u l=53.465u ps=0u b=0 m=1
R$648 \$228 \$233 vss rppd w=1u l=53.465u ps=0u b=0 m=1
R$649 \$228 \$233 vss rppd w=1u l=53.465u ps=0u b=0 m=1
R$650 vss dvbe vss rppd w=1u l=51.5u ps=0u b=0 m=1
R$651 vss dvbe vss rppd w=1u l=51.5u ps=0u b=0 m=1
R$652 vss dvbe vss rppd w=1u l=51.5u ps=0u b=0 m=1
R$653 vss dvbe vss rppd w=1u l=51.5u ps=0u b=0 m=1
R$654 vss dvbe vss rppd w=1u l=51.5u ps=0u b=0 m=1
R$655 vss dvbe vss rppd w=1u l=51.5u ps=0u b=0 m=1
R$656 vss dvbe vss rppd w=1u l=51.5u ps=0u b=0 m=1
R$657 vss dvbe vss rppd w=1u l=51.5u ps=0u b=0 m=1
R$658 vss dvbe vss rppd w=1u l=51.5u ps=0u b=0 m=1
R$659 vss dvbe vss rppd w=1u l=51.5u ps=0u b=0 m=1
R$660 vss dvbe vss rppd w=1u l=51.5u ps=0u b=0 m=1
R$661 vss dvbe vss rppd w=1u l=51.5u ps=0u b=0 m=1
R$662 \$231 pbias vss rppd w=1u l=50u ps=0u b=0 m=1
R$663 \$231 pbias vss rppd w=1u l=50u ps=0u b=0 m=1
R$664 \$231 pbias vss rppd w=1u l=50u ps=0u b=0 m=1
R$665 \$231 pbias vss rppd w=1u l=50u ps=0u b=0 m=1
R$666 \$231 pbias vss rppd w=1u l=50u ps=0u b=0 m=1
R$667 \$231 pbias vss rppd w=1u l=50u ps=0u b=0 m=1
R$668 \$231 pbias vss rppd w=1u l=50u ps=0u b=0 m=1
R$669 \$231 pbias vss rppd w=1u l=50u ps=0u b=0 m=1
R$670 \$231 pbias vss rppd w=1u l=50u ps=0u b=0 m=1
R$671 \$231 pbias vss rppd w=1u l=50u ps=0u b=0 m=1
R$672 \$231 pbias vss rppd w=1u l=50u ps=0u b=0 m=1
R$673 \$231 pbias vss rppd w=1u l=50u ps=0u b=0 m=1
R$674 \$9 \$227 vss rppd w=1u l=50u ps=0u b=0 m=1
R$675 \$9 \$227 vss rppd w=1u l=50u ps=0u b=0 m=1
R$676 \$9 \$227 vss rppd w=1u l=50u ps=0u b=0 m=1
R$677 \$9 \$227 vss rppd w=1u l=50u ps=0u b=0 m=1
R$678 \$9 \$227 vss rppd w=1u l=50u ps=0u b=0 m=1
R$679 \$9 \$227 vss rppd w=1u l=50u ps=0u b=0 m=1
R$680 \$9 \$227 vss rppd w=1u l=50u ps=0u b=0 m=1
R$681 \$9 \$227 vss rppd w=1u l=50u ps=0u b=0 m=1
R$682 \$9 \$227 vss rppd w=1u l=50u ps=0u b=0 m=1
R$683 \$9 \$227 vss rppd w=1u l=50u ps=0u b=0 m=1
R$684 \$9 \$227 vss rppd w=1u l=50u ps=0u b=0 m=1
R$685 \$9 \$227 vss rppd w=1u l=50u ps=0u b=0 m=1
R$686 \$10 \$227 vss rppd w=1u l=50u ps=0u b=0 m=1
R$687 \$10 \$227 vss rppd w=1u l=50u ps=0u b=0 m=1
R$688 \$10 \$227 vss rppd w=1u l=50u ps=0u b=0 m=1
R$689 \$10 \$227 vss rppd w=1u l=50u ps=0u b=0 m=1
R$690 \$10 \$227 vss rppd w=1u l=50u ps=0u b=0 m=1
R$691 \$10 \$227 vss rppd w=1u l=50u ps=0u b=0 m=1
R$692 \$10 \$227 vss rppd w=1u l=50u ps=0u b=0 m=1
R$693 \$10 \$227 vss rppd w=1u l=50u ps=0u b=0 m=1
R$694 \$10 \$227 vss rppd w=1u l=50u ps=0u b=0 m=1
R$695 \$10 \$227 vss rppd w=1u l=50u ps=0u b=0 m=1
R$696 \$10 \$227 vss rppd w=1u l=50u ps=0u b=0 m=1
R$697 \$10 \$227 vss rppd w=1u l=50u ps=0u b=0 m=1
R$698 \$22 \$226 vss rppd w=1u l=50u ps=0u b=0 m=1
R$699 \$22 \$226 vss rppd w=1u l=50u ps=0u b=0 m=1
R$700 \$22 \$226 vss rppd w=1u l=50u ps=0u b=0 m=1
R$701 \$22 \$226 vss rppd w=1u l=50u ps=0u b=0 m=1
R$702 \$22 \$226 vss rppd w=1u l=50u ps=0u b=0 m=1
R$703 \$22 \$226 vss rppd w=1u l=50u ps=0u b=0 m=1
R$704 \$22 \$226 vss rppd w=1u l=50u ps=0u b=0 m=1
R$705 \$22 \$226 vss rppd w=1u l=50u ps=0u b=0 m=1
R$706 \$22 \$226 vss rppd w=1u l=50u ps=0u b=0 m=1
R$707 \$22 \$226 vss rppd w=1u l=50u ps=0u b=0 m=1
R$708 \$22 \$226 vss rppd w=1u l=50u ps=0u b=0 m=1
R$709 \$22 \$226 vss rppd w=1u l=50u ps=0u b=0 m=1
R$710 \$10 \$225 vss rppd w=1u l=50u ps=0u b=0 m=1
R$711 \$10 \$225 vss rppd w=1u l=50u ps=0u b=0 m=1
R$712 \$10 \$225 vss rppd w=1u l=50u ps=0u b=0 m=1
R$713 \$10 \$225 vss rppd w=1u l=50u ps=0u b=0 m=1
R$714 \$10 \$225 vss rppd w=1u l=50u ps=0u b=0 m=1
R$715 \$10 \$225 vss rppd w=1u l=50u ps=0u b=0 m=1
R$716 \$10 \$225 vss rppd w=1u l=50u ps=0u b=0 m=1
R$717 \$10 \$225 vss rppd w=1u l=50u ps=0u b=0 m=1
R$718 \$10 \$225 vss rppd w=1u l=50u ps=0u b=0 m=1
R$719 \$10 \$225 vss rppd w=1u l=50u ps=0u b=0 m=1
R$720 \$10 \$225 vss rppd w=1u l=50u ps=0u b=0 m=1
R$721 \$10 \$225 vss rppd w=1u l=50u ps=0u b=0 m=1
R$722 \$232 \$226 vss rppd w=1u l=50u ps=0u b=0 m=1
R$723 \$232 \$226 vss rppd w=1u l=50u ps=0u b=0 m=1
R$724 \$232 \$226 vss rppd w=1u l=50u ps=0u b=0 m=1
R$725 \$232 \$226 vss rppd w=1u l=50u ps=0u b=0 m=1
R$726 \$232 \$226 vss rppd w=1u l=50u ps=0u b=0 m=1
R$727 \$232 \$226 vss rppd w=1u l=50u ps=0u b=0 m=1
R$728 \$232 \$226 vss rppd w=1u l=50u ps=0u b=0 m=1
R$729 \$232 \$226 vss rppd w=1u l=50u ps=0u b=0 m=1
R$730 \$232 \$226 vss rppd w=1u l=50u ps=0u b=0 m=1
R$731 \$232 \$226 vss rppd w=1u l=50u ps=0u b=0 m=1
R$732 \$232 \$226 vss rppd w=1u l=50u ps=0u b=0 m=1
R$733 \$232 \$226 vss rppd w=1u l=50u ps=0u b=0 m=1
R$734 \$232 \$23 vss rppd w=1u l=50u ps=0u b=0 m=1
R$735 \$232 \$23 vss rppd w=1u l=50u ps=0u b=0 m=1
R$736 \$232 \$23 vss rppd w=1u l=50u ps=0u b=0 m=1
R$737 \$232 \$23 vss rppd w=1u l=50u ps=0u b=0 m=1
R$738 \$232 \$23 vss rppd w=1u l=50u ps=0u b=0 m=1
R$739 \$232 \$23 vss rppd w=1u l=50u ps=0u b=0 m=1
R$740 \$232 \$23 vss rppd w=1u l=50u ps=0u b=0 m=1
R$741 \$232 \$23 vss rppd w=1u l=50u ps=0u b=0 m=1
R$742 \$232 \$23 vss rppd w=1u l=50u ps=0u b=0 m=1
R$743 \$232 \$23 vss rppd w=1u l=50u ps=0u b=0 m=1
R$744 \$232 \$23 vss rppd w=1u l=50u ps=0u b=0 m=1
R$745 \$232 \$23 vss rppd w=1u l=50u ps=0u b=0 m=1
R$746 \$231 \$23 vss rppd w=1u l=50u ps=0u b=0 m=1
R$747 \$231 \$23 vss rppd w=1u l=50u ps=0u b=0 m=1
R$748 \$231 \$23 vss rppd w=1u l=50u ps=0u b=0 m=1
R$749 \$231 \$23 vss rppd w=1u l=50u ps=0u b=0 m=1
R$750 \$231 \$23 vss rppd w=1u l=50u ps=0u b=0 m=1
R$751 \$231 \$23 vss rppd w=1u l=50u ps=0u b=0 m=1
R$752 \$231 \$23 vss rppd w=1u l=50u ps=0u b=0 m=1
R$753 \$231 \$23 vss rppd w=1u l=50u ps=0u b=0 m=1
R$754 \$231 \$23 vss rppd w=1u l=50u ps=0u b=0 m=1
R$755 \$231 \$23 vss rppd w=1u l=50u ps=0u b=0 m=1
R$756 \$231 \$23 vss rppd w=1u l=50u ps=0u b=0 m=1
R$757 \$231 \$23 vss rppd w=1u l=50u ps=0u b=0 m=1
R$758 \$22 \$225 vss rppd w=1u l=50u ps=0u b=0 m=1
R$759 \$22 \$225 vss rppd w=1u l=50u ps=0u b=0 m=1
R$760 \$22 \$225 vss rppd w=1u l=50u ps=0u b=0 m=1
R$761 \$22 \$225 vss rppd w=1u l=50u ps=0u b=0 m=1
R$762 \$22 \$225 vss rppd w=1u l=50u ps=0u b=0 m=1
R$763 \$22 \$225 vss rppd w=1u l=50u ps=0u b=0 m=1
R$764 \$22 \$225 vss rppd w=1u l=50u ps=0u b=0 m=1
R$765 \$22 \$225 vss rppd w=1u l=50u ps=0u b=0 m=1
R$766 \$22 \$225 vss rppd w=1u l=50u ps=0u b=0 m=1
R$767 \$22 \$225 vss rppd w=1u l=50u ps=0u b=0 m=1
R$768 \$22 \$225 vss rppd w=1u l=50u ps=0u b=0 m=1
R$769 \$22 \$225 vss rppd w=1u l=50u ps=0u b=0 m=1
R$770 \$9 pcasc vss rppd w=1u l=50u ps=0u b=0 m=1
R$771 \$9 pcasc vss rppd w=1u l=50u ps=0u b=0 m=1
R$772 \$9 pcasc vss rppd w=1u l=50u ps=0u b=0 m=1
R$773 \$9 pcasc vss rppd w=1u l=50u ps=0u b=0 m=1
R$774 \$9 pcasc vss rppd w=1u l=50u ps=0u b=0 m=1
R$775 \$9 pcasc vss rppd w=1u l=50u ps=0u b=0 m=1
R$776 \$9 pcasc vss rppd w=1u l=50u ps=0u b=0 m=1
R$777 \$9 pcasc vss rppd w=1u l=50u ps=0u b=0 m=1
R$778 \$9 pcasc vss rppd w=1u l=50u ps=0u b=0 m=1
R$779 \$9 pcasc vss rppd w=1u l=50u ps=0u b=0 m=1
R$780 \$9 pcasc vss rppd w=1u l=50u ps=0u b=0 m=1
R$781 \$9 pcasc vss rppd w=1u l=50u ps=0u b=0 m=1
R$782 \$228 \$233 vss rppd w=1u l=53.465u ps=0u b=0 m=1
R$783 \$228 \$233 vss rppd w=1u l=53.465u ps=0u b=0 m=1
R$784 \$228 \$229 vss rppd w=1u l=53.465u ps=0u b=0 m=1
R$785 \$228 \$229 vss rppd w=1u l=53.465u ps=0u b=0 m=1
R$786 \$16 \$229 vss rppd w=1u l=53.465u ps=0u b=0 m=1
R$787 \$2 \$441 vss rppd w=1u l=48u ps=0u b=0 m=1
R$788 \$2 \$441 vss rppd w=1u l=48u ps=0u b=0 m=1
R$789 \$16 \$229 vss rppd w=1u l=53.465u ps=0u b=0 m=1
R$790 \$230 \$224 vss rppd w=1u l=53.465u ps=0u b=0 m=1
R$791 \$2 \$441 vss rppd w=1u l=48u ps=0u b=0 m=1
R$792 \$230 \$224 vss rppd w=1u l=53.465u ps=0u b=0 m=1
R$793 \$2 \$441 vss rppd w=1u l=48u ps=0u b=0 m=1
R$794 \$16 \$224 vss rppd w=1u l=53.465u ps=0u b=0 m=1
R$795 \$2 \$441 vss rppd w=1u l=48u ps=0u b=0 m=1
R$796 \$2 \$441 vss rppd w=1u l=48u ps=0u b=0 m=1
R$797 \$16 \$224 vss rppd w=1u l=53.465u ps=0u b=0 m=1
R$798 \$2 \$441 vss rppd w=1u l=48u ps=0u b=0 m=1
R$799 \$230 vref vss rppd w=1u l=53.465u ps=0u b=0 m=1
R$800 \$230 vref vss rppd w=1u l=53.465u ps=0u b=0 m=1
R$801 \$2 \$441 vss rppd w=1u l=48u ps=0u b=0 m=1
R$802 \$2 \$441 vss rppd w=1u l=48u ps=0u b=0 m=1
R$803 \$2 \$441 vss rppd w=1u l=48u ps=0u b=0 m=1
R$804 \$2 \$441 vss rppd w=1u l=48u ps=0u b=0 m=1
R$805 \$2 \$441 vss rppd w=1u l=48u ps=0u b=0 m=1
R$806 \$3 \$236 vss rppd w=1u l=48u ps=0u b=0 m=1
R$807 \$3 \$236 vss rppd w=1u l=48u ps=0u b=0 m=1
R$808 \$3 \$236 vss rppd w=1u l=48u ps=0u b=0 m=1
R$809 \$3 \$236 vss rppd w=1u l=48u ps=0u b=0 m=1
R$810 \$3 \$236 vss rppd w=1u l=48u ps=0u b=0 m=1
R$811 \$3 \$236 vss rppd w=1u l=48u ps=0u b=0 m=1
R$812 \$3 \$236 vss rppd w=1u l=48u ps=0u b=0 m=1
R$813 \$3 \$236 vss rppd w=1u l=48u ps=0u b=0 m=1
R$814 \$3 \$236 vss rppd w=1u l=48u ps=0u b=0 m=1
R$815 \$3 \$236 vss rppd w=1u l=48u ps=0u b=0 m=1
R$816 \$3 \$236 vss rppd w=1u l=48u ps=0u b=0 m=1
R$817 \$3 \$236 vss rppd w=1u l=48u ps=0u b=0 m=1
R$818 \$2 \$17 vss rppd w=1u l=48u ps=0u b=0 m=1
R$819 \$2 \$17 vss rppd w=1u l=48u ps=0u b=0 m=1
R$820 \$2 \$17 vss rppd w=1u l=48u ps=0u b=0 m=1
R$821 \$2 \$17 vss rppd w=1u l=48u ps=0u b=0 m=1
R$822 \$2 \$17 vss rppd w=1u l=48u ps=0u b=0 m=1
R$823 \$2 \$17 vss rppd w=1u l=48u ps=0u b=0 m=1
R$824 \$2 \$17 vss rppd w=1u l=48u ps=0u b=0 m=1
R$825 \$2 \$17 vss rppd w=1u l=48u ps=0u b=0 m=1
R$826 \$2 \$17 vss rppd w=1u l=48u ps=0u b=0 m=1
R$827 \$2 \$17 vss rppd w=1u l=48u ps=0u b=0 m=1
R$828 \$2 \$17 vss rppd w=1u l=48u ps=0u b=0 m=1
R$829 \$2 \$17 vss rppd w=1u l=48u ps=0u b=0 m=1
R$830 \$3 \$17 vss rppd w=1u l=48u ps=0u b=0 m=1
R$831 \$3 \$17 vss rppd w=1u l=48u ps=0u b=0 m=1
R$832 \$3 \$17 vss rppd w=1u l=48u ps=0u b=0 m=1
R$833 \$3 \$17 vss rppd w=1u l=48u ps=0u b=0 m=1
R$834 \$3 \$17 vss rppd w=1u l=48u ps=0u b=0 m=1
R$835 \$3 \$17 vss rppd w=1u l=48u ps=0u b=0 m=1
R$836 \$3 \$17 vss rppd w=1u l=48u ps=0u b=0 m=1
R$837 \$3 \$17 vss rppd w=1u l=48u ps=0u b=0 m=1
R$838 \$3 \$17 vss rppd w=1u l=48u ps=0u b=0 m=1
R$839 \$3 \$17 vss rppd w=1u l=48u ps=0u b=0 m=1
R$840 \$3 \$17 vss rppd w=1u l=48u ps=0u b=0 m=1
R$841 \$3 \$17 vss rppd w=1u l=48u ps=0u b=0 m=1
R$842 vss dvbe vss rppd w=1u l=51.5u ps=0u b=0 m=1
R$843 vss dvbe vss rppd w=1u l=51.5u ps=0u b=0 m=1
R$844 vss dvbe vss rppd w=1u l=51.5u ps=0u b=0 m=1
R$845 vss dvbe vss rppd w=1u l=51.5u ps=0u b=0 m=1
R$846 vss dvbe vss rppd w=1u l=51.5u ps=0u b=0 m=1
R$847 vss dvbe vss rppd w=1u l=51.5u ps=0u b=0 m=1
R$848 vss dvbe vss rppd w=1u l=51.5u ps=0u b=0 m=1
R$849 vss dvbe vss rppd w=1u l=51.5u ps=0u b=0 m=1
R$850 vss dvbe vss rppd w=1u l=51.5u ps=0u b=0 m=1
R$851 vss dvbe vss rppd w=1u l=51.5u ps=0u b=0 m=1
R$852 vss dvbe vss rppd w=1u l=51.5u ps=0u b=0 m=1
R$853 vss dvbe vss rppd w=1u l=51.5u ps=0u b=0 m=1
R$854 \$9 pcasc vss rppd w=1u l=50u ps=0u b=0 m=1
R$855 \$9 pcasc vss rppd w=1u l=50u ps=0u b=0 m=1
R$856 \$9 pcasc vss rppd w=1u l=50u ps=0u b=0 m=1
R$857 \$9 pcasc vss rppd w=1u l=50u ps=0u b=0 m=1
R$858 \$9 pcasc vss rppd w=1u l=50u ps=0u b=0 m=1
R$859 \$9 pcasc vss rppd w=1u l=50u ps=0u b=0 m=1
R$860 \$9 pcasc vss rppd w=1u l=50u ps=0u b=0 m=1
R$861 \$9 pcasc vss rppd w=1u l=50u ps=0u b=0 m=1
R$862 \$9 pcasc vss rppd w=1u l=50u ps=0u b=0 m=1
R$863 \$9 pcasc vss rppd w=1u l=50u ps=0u b=0 m=1
R$864 \$9 pcasc vss rppd w=1u l=50u ps=0u b=0 m=1
R$865 \$9 pcasc vss rppd w=1u l=50u ps=0u b=0 m=1
R$866 \$22 \$225 vss rppd w=1u l=50u ps=0u b=0 m=1
R$867 \$22 \$225 vss rppd w=1u l=50u ps=0u b=0 m=1
R$868 \$22 \$225 vss rppd w=1u l=50u ps=0u b=0 m=1
R$869 \$22 \$225 vss rppd w=1u l=50u ps=0u b=0 m=1
R$870 \$22 \$225 vss rppd w=1u l=50u ps=0u b=0 m=1
R$871 \$22 \$225 vss rppd w=1u l=50u ps=0u b=0 m=1
R$872 \$22 \$225 vss rppd w=1u l=50u ps=0u b=0 m=1
R$873 \$22 \$225 vss rppd w=1u l=50u ps=0u b=0 m=1
R$874 \$22 \$225 vss rppd w=1u l=50u ps=0u b=0 m=1
R$875 \$22 \$225 vss rppd w=1u l=50u ps=0u b=0 m=1
R$876 \$22 \$225 vss rppd w=1u l=50u ps=0u b=0 m=1
R$877 \$22 \$225 vss rppd w=1u l=50u ps=0u b=0 m=1
R$878 \$231 \$23 vss rppd w=1u l=50u ps=0u b=0 m=1
R$879 \$231 \$23 vss rppd w=1u l=50u ps=0u b=0 m=1
R$880 \$231 \$23 vss rppd w=1u l=50u ps=0u b=0 m=1
R$881 \$231 \$23 vss rppd w=1u l=50u ps=0u b=0 m=1
R$882 \$231 \$23 vss rppd w=1u l=50u ps=0u b=0 m=1
R$883 \$231 \$23 vss rppd w=1u l=50u ps=0u b=0 m=1
R$884 \$231 \$23 vss rppd w=1u l=50u ps=0u b=0 m=1
R$885 \$231 \$23 vss rppd w=1u l=50u ps=0u b=0 m=1
R$886 \$231 \$23 vss rppd w=1u l=50u ps=0u b=0 m=1
R$887 \$231 \$23 vss rppd w=1u l=50u ps=0u b=0 m=1
R$888 \$231 \$23 vss rppd w=1u l=50u ps=0u b=0 m=1
R$889 \$231 \$23 vss rppd w=1u l=50u ps=0u b=0 m=1
R$890 \$232 \$23 vss rppd w=1u l=50u ps=0u b=0 m=1
R$891 \$232 \$23 vss rppd w=1u l=50u ps=0u b=0 m=1
R$892 \$232 \$23 vss rppd w=1u l=50u ps=0u b=0 m=1
R$893 \$232 \$23 vss rppd w=1u l=50u ps=0u b=0 m=1
R$894 \$232 \$23 vss rppd w=1u l=50u ps=0u b=0 m=1
R$895 \$232 \$23 vss rppd w=1u l=50u ps=0u b=0 m=1
R$896 \$232 \$23 vss rppd w=1u l=50u ps=0u b=0 m=1
R$897 \$232 \$23 vss rppd w=1u l=50u ps=0u b=0 m=1
R$898 \$232 \$23 vss rppd w=1u l=50u ps=0u b=0 m=1
R$899 \$232 \$23 vss rppd w=1u l=50u ps=0u b=0 m=1
R$900 \$232 \$23 vss rppd w=1u l=50u ps=0u b=0 m=1
R$901 \$232 \$23 vss rppd w=1u l=50u ps=0u b=0 m=1
R$902 \$232 \$226 vss rppd w=1u l=50u ps=0u b=0 m=1
R$903 \$232 \$226 vss rppd w=1u l=50u ps=0u b=0 m=1
R$904 \$232 \$226 vss rppd w=1u l=50u ps=0u b=0 m=1
R$905 \$232 \$226 vss rppd w=1u l=50u ps=0u b=0 m=1
R$906 \$232 \$226 vss rppd w=1u l=50u ps=0u b=0 m=1
R$907 \$232 \$226 vss rppd w=1u l=50u ps=0u b=0 m=1
R$908 \$232 \$226 vss rppd w=1u l=50u ps=0u b=0 m=1
R$909 \$232 \$226 vss rppd w=1u l=50u ps=0u b=0 m=1
R$910 \$232 \$226 vss rppd w=1u l=50u ps=0u b=0 m=1
R$911 \$232 \$226 vss rppd w=1u l=50u ps=0u b=0 m=1
R$912 \$232 \$226 vss rppd w=1u l=50u ps=0u b=0 m=1
R$913 \$232 \$226 vss rppd w=1u l=50u ps=0u b=0 m=1
R$914 \$10 \$225 vss rppd w=1u l=50u ps=0u b=0 m=1
R$915 \$10 \$225 vss rppd w=1u l=50u ps=0u b=0 m=1
R$916 \$10 \$225 vss rppd w=1u l=50u ps=0u b=0 m=1
R$917 \$10 \$225 vss rppd w=1u l=50u ps=0u b=0 m=1
R$918 \$10 \$225 vss rppd w=1u l=50u ps=0u b=0 m=1
R$919 \$10 \$225 vss rppd w=1u l=50u ps=0u b=0 m=1
R$920 \$10 \$225 vss rppd w=1u l=50u ps=0u b=0 m=1
R$921 \$10 \$225 vss rppd w=1u l=50u ps=0u b=0 m=1
R$922 \$10 \$225 vss rppd w=1u l=50u ps=0u b=0 m=1
R$923 \$10 \$225 vss rppd w=1u l=50u ps=0u b=0 m=1
R$924 \$10 \$225 vss rppd w=1u l=50u ps=0u b=0 m=1
R$925 \$10 \$225 vss rppd w=1u l=50u ps=0u b=0 m=1
R$926 \$22 \$226 vss rppd w=1u l=50u ps=0u b=0 m=1
R$927 \$22 \$226 vss rppd w=1u l=50u ps=0u b=0 m=1
R$928 \$22 \$226 vss rppd w=1u l=50u ps=0u b=0 m=1
R$929 \$22 \$226 vss rppd w=1u l=50u ps=0u b=0 m=1
R$930 \$22 \$226 vss rppd w=1u l=50u ps=0u b=0 m=1
R$931 \$22 \$226 vss rppd w=1u l=50u ps=0u b=0 m=1
R$932 \$22 \$226 vss rppd w=1u l=50u ps=0u b=0 m=1
R$933 \$22 \$226 vss rppd w=1u l=50u ps=0u b=0 m=1
R$934 \$22 \$226 vss rppd w=1u l=50u ps=0u b=0 m=1
R$935 \$22 \$226 vss rppd w=1u l=50u ps=0u b=0 m=1
R$936 \$22 \$226 vss rppd w=1u l=50u ps=0u b=0 m=1
R$937 \$22 \$226 vss rppd w=1u l=50u ps=0u b=0 m=1
R$938 \$10 \$227 vss rppd w=1u l=50u ps=0u b=0 m=1
R$939 \$10 \$227 vss rppd w=1u l=50u ps=0u b=0 m=1
R$940 \$10 \$227 vss rppd w=1u l=50u ps=0u b=0 m=1
R$941 \$10 \$227 vss rppd w=1u l=50u ps=0u b=0 m=1
R$942 \$10 \$227 vss rppd w=1u l=50u ps=0u b=0 m=1
R$943 \$10 \$227 vss rppd w=1u l=50u ps=0u b=0 m=1
R$944 \$10 \$227 vss rppd w=1u l=50u ps=0u b=0 m=1
R$945 \$10 \$227 vss rppd w=1u l=50u ps=0u b=0 m=1
R$946 \$10 \$227 vss rppd w=1u l=50u ps=0u b=0 m=1
R$947 \$10 \$227 vss rppd w=1u l=50u ps=0u b=0 m=1
R$948 \$10 \$227 vss rppd w=1u l=50u ps=0u b=0 m=1
R$949 \$10 \$227 vss rppd w=1u l=50u ps=0u b=0 m=1
R$950 \$9 \$227 vss rppd w=1u l=50u ps=0u b=0 m=1
R$951 \$9 \$227 vss rppd w=1u l=50u ps=0u b=0 m=1
R$952 \$9 \$227 vss rppd w=1u l=50u ps=0u b=0 m=1
R$953 \$9 \$227 vss rppd w=1u l=50u ps=0u b=0 m=1
R$954 \$9 \$227 vss rppd w=1u l=50u ps=0u b=0 m=1
R$955 \$9 \$227 vss rppd w=1u l=50u ps=0u b=0 m=1
R$956 \$9 \$227 vss rppd w=1u l=50u ps=0u b=0 m=1
R$957 \$9 \$227 vss rppd w=1u l=50u ps=0u b=0 m=1
R$958 \$9 \$227 vss rppd w=1u l=50u ps=0u b=0 m=1
R$959 \$9 \$227 vss rppd w=1u l=50u ps=0u b=0 m=1
R$960 \$9 \$227 vss rppd w=1u l=50u ps=0u b=0 m=1
R$961 \$9 \$227 vss rppd w=1u l=50u ps=0u b=0 m=1
R$962 \$231 pbias vss rppd w=1u l=50u ps=0u b=0 m=1
R$963 \$231 pbias vss rppd w=1u l=50u ps=0u b=0 m=1
R$964 \$231 pbias vss rppd w=1u l=50u ps=0u b=0 m=1
R$965 \$231 pbias vss rppd w=1u l=50u ps=0u b=0 m=1
R$966 \$231 pbias vss rppd w=1u l=50u ps=0u b=0 m=1
R$967 \$231 pbias vss rppd w=1u l=50u ps=0u b=0 m=1
R$968 \$231 pbias vss rppd w=1u l=50u ps=0u b=0 m=1
R$969 \$231 pbias vss rppd w=1u l=50u ps=0u b=0 m=1
R$970 \$231 pbias vss rppd w=1u l=50u ps=0u b=0 m=1
R$971 \$231 pbias vss rppd w=1u l=50u ps=0u b=0 m=1
R$972 \$231 pbias vss rppd w=1u l=50u ps=0u b=0 m=1
R$973 \$231 pbias vss rppd w=1u l=50u ps=0u b=0 m=1
R$974 \$3 \$17 vss rppd w=1u l=48u ps=0u b=0 m=1
R$975 \$3 \$17 vss rppd w=1u l=48u ps=0u b=0 m=1
R$976 \$3 \$17 vss rppd w=1u l=48u ps=0u b=0 m=1
R$977 \$3 \$17 vss rppd w=1u l=48u ps=0u b=0 m=1
R$978 \$3 \$17 vss rppd w=1u l=48u ps=0u b=0 m=1
R$979 \$3 \$17 vss rppd w=1u l=48u ps=0u b=0 m=1
R$980 \$3 \$17 vss rppd w=1u l=48u ps=0u b=0 m=1
R$981 \$3 \$17 vss rppd w=1u l=48u ps=0u b=0 m=1
R$982 \$3 \$17 vss rppd w=1u l=48u ps=0u b=0 m=1
R$983 \$3 \$17 vss rppd w=1u l=48u ps=0u b=0 m=1
R$984 \$3 \$17 vss rppd w=1u l=48u ps=0u b=0 m=1
R$985 \$3 \$17 vss rppd w=1u l=48u ps=0u b=0 m=1
R$986 \$2 \$17 vss rppd w=1u l=48u ps=0u b=0 m=1
R$987 \$2 \$17 vss rppd w=1u l=48u ps=0u b=0 m=1
R$988 \$2 \$17 vss rppd w=1u l=48u ps=0u b=0 m=1
R$989 \$2 \$17 vss rppd w=1u l=48u ps=0u b=0 m=1
R$990 \$2 \$17 vss rppd w=1u l=48u ps=0u b=0 m=1
R$991 \$2 \$17 vss rppd w=1u l=48u ps=0u b=0 m=1
R$992 \$2 \$17 vss rppd w=1u l=48u ps=0u b=0 m=1
R$993 \$2 \$17 vss rppd w=1u l=48u ps=0u b=0 m=1
R$994 \$2 \$17 vss rppd w=1u l=48u ps=0u b=0 m=1
R$995 \$2 \$17 vss rppd w=1u l=48u ps=0u b=0 m=1
R$996 \$2 \$17 vss rppd w=1u l=48u ps=0u b=0 m=1
R$997 \$2 \$17 vss rppd w=1u l=48u ps=0u b=0 m=1
R$998 \$3 \$236 vss rppd w=1u l=48u ps=0u b=0 m=1
R$999 \$3 \$236 vss rppd w=1u l=48u ps=0u b=0 m=1
R$1000 \$3 \$236 vss rppd w=1u l=48u ps=0u b=0 m=1
R$1001 \$3 \$236 vss rppd w=1u l=48u ps=0u b=0 m=1
R$1002 \$3 \$236 vss rppd w=1u l=48u ps=0u b=0 m=1
R$1003 \$3 \$236 vss rppd w=1u l=48u ps=0u b=0 m=1
R$1004 \$3 \$236 vss rppd w=1u l=48u ps=0u b=0 m=1
R$1005 \$3 \$236 vss rppd w=1u l=48u ps=0u b=0 m=1
R$1006 \$3 \$236 vss rppd w=1u l=48u ps=0u b=0 m=1
R$1007 \$3 \$236 vss rppd w=1u l=48u ps=0u b=0 m=1
R$1008 \$3 \$236 vss rppd w=1u l=48u ps=0u b=0 m=1
R$1009 \$3 \$236 vss rppd w=1u l=48u ps=0u b=0 m=1
R$1010 \$2 \$441 vss rppd w=1u l=48u ps=0u b=0 m=1
R$1011 \$2 \$441 vss rppd w=1u l=48u ps=0u b=0 m=1
R$1012 \$2 \$441 vss rppd w=1u l=48u ps=0u b=0 m=1
R$1013 \$2 \$441 vss rppd w=1u l=48u ps=0u b=0 m=1
R$1014 \$2 \$441 vss rppd w=1u l=48u ps=0u b=0 m=1
R$1015 \$2 \$441 vss rppd w=1u l=48u ps=0u b=0 m=1
R$1016 \$2 \$441 vss rppd w=1u l=48u ps=0u b=0 m=1
R$1017 \$2 \$441 vss rppd w=1u l=48u ps=0u b=0 m=1
R$1018 \$2 \$441 vss rppd w=1u l=48u ps=0u b=0 m=1
R$1019 \$2 \$441 vss rppd w=1u l=48u ps=0u b=0 m=1
R$1020 \$2 \$441 vss rppd w=1u l=48u ps=0u b=0 m=1
R$1021 \$2 \$441 vss rppd w=1u l=48u ps=0u b=0 m=1
R$1022 vss \$18 vss rhigh w=0.5u l=49u ps=0u b=0 m=1
R$1023 \$4 \$19 vss rhigh w=0.5u l=49u ps=0u b=0 m=1
R$1024 \$5 \$19 vss rhigh w=0.5u l=49u ps=0u b=0 m=1
R$1025 \$6 \$20 vss rhigh w=0.5u l=49u ps=0u b=0 m=1
R$1026 \$7 \$20 vss rhigh w=0.5u l=49u ps=0u b=0 m=1
R$1027 \$7 \$18 vss rhigh w=0.5u l=49u ps=0u b=0 m=1
R$1028 \$6 \$15 vss rhigh w=0.5u l=49u ps=0u b=0 m=1
R$1029 \$4 \$11 vss rhigh w=0.5u l=49u ps=0u b=0 m=1
R$1030 \$5 \$437 vss rhigh w=0.5u l=49u ps=0u b=0 m=1
R$1031 \$12 \$437 vss rhigh w=0.5u l=49u ps=0u b=0 m=1
R$1032 \$12 \$438 vss rhigh w=0.5u l=49u ps=0u b=0 m=1
R$1033 \$13 \$438 vss rhigh w=0.5u l=49u ps=0u b=0 m=1
R$1034 \$13 \$21 vss rhigh w=0.5u l=49u ps=0u b=0 m=1
R$1035 \$14 \$21 vss rhigh w=0.5u l=49u ps=0u b=0 m=1
R$1036 \$14 \$15 vss rhigh w=0.5u l=49u ps=0u b=0 m=1
.ENDS g1_bgr
