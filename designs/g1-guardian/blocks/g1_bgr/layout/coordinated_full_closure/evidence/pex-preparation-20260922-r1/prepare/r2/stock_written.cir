* Extracted by KLayout with SG13G2 LVS runset on : 22/09/2026 21:50

.SUBCKT g1_bgr dvbe iptat pbias pcasc r4 vbe vdd vref vss
M$1 \$569 r4 vbe vss sg13_hv_nmos L=0.5u W=2u AS=0.68p AD=0.68p PS=4.68u
+ PD=4.68u rfmode=0
M$2 vss \$801 pbias vss sg13_hv_nmos L=4u W=1u AS=0.34p AD=0.34p PS=2.68u
+ PD=2.68u rfmode=0
M$3 vss \$8 \$801 vss sg13_hv_nmos L=0.6u W=1u AS=0.34p AD=0.34p PS=2.68u
+ PD=2.68u rfmode=0
M$4 vss r4 \$819 vss sg13_hv_nmos L=0.5u W=1u AS=0.34p AD=0.34p PS=2.68u
+ PD=2.68u rfmode=0
M$5 vss \$819 \$569 vss sg13_hv_nmos L=0.6u W=1u AS=0.34p AD=0.34p PS=2.68u
+ PD=2.68u rfmode=0
M$6 vbe \$444 \$445 vss sg13_hv_nmos L=1u W=10u AS=3.4p AD=3.4p PS=20.68u
+ PD=20.68u rfmode=0
M$7 vbe \$444 \$445 vss sg13_hv_nmos L=1u W=10u AS=3.4p AD=3.4p PS=20.68u
+ PD=20.68u rfmode=0
M$8 vbe \$444 \$445 vss sg13_hv_nmos L=1u W=10u AS=3.4p AD=3.4p PS=20.68u
+ PD=20.68u rfmode=0
M$9 vbe \$444 \$445 vss sg13_hv_nmos L=1u W=10u AS=3.4p AD=3.4p PS=20.68u
+ PD=20.68u rfmode=0
M$10 vbe \$444 \$445 vss sg13_hv_nmos L=1u W=10u AS=3.4p AD=3.4p PS=20.68u
+ PD=20.68u rfmode=0
M$11 vbe \$444 \$445 vss sg13_hv_nmos L=1u W=10u AS=3.4p AD=3.4p PS=20.68u
+ PD=20.68u rfmode=0
M$12 vbe \$444 \$445 vss sg13_hv_nmos L=1u W=10u AS=3.4p AD=3.4p PS=20.68u
+ PD=20.68u rfmode=0
M$13 vbe \$444 \$445 vss sg13_hv_nmos L=1u W=10u AS=3.4p AD=3.4p PS=20.68u
+ PD=20.68u rfmode=0
M$14 vbe \$444 \$445 vss sg13_hv_nmos L=1u W=10u AS=3.4p AD=3.4p PS=20.68u
+ PD=20.68u rfmode=0
M$15 vbe \$444 \$445 vss sg13_hv_nmos L=1u W=10u AS=3.4p AD=3.4p PS=20.68u
+ PD=20.68u rfmode=0
M$16 vbe \$444 \$445 vss sg13_hv_nmos L=1u W=10u AS=3.4p AD=3.4p PS=20.68u
+ PD=20.68u rfmode=0
M$17 vbe \$444 \$445 vss sg13_hv_nmos L=1u W=10u AS=3.4p AD=3.4p PS=20.68u
+ PD=20.68u rfmode=0
M$18 pcasc \$444 \$749 vss sg13_hv_nmos L=1u W=10u AS=3.4p AD=3.4p PS=20.68u
+ PD=20.68u rfmode=0
M$19 pcasc \$444 \$749 vss sg13_hv_nmos L=1u W=10u AS=3.4p AD=3.4p PS=20.68u
+ PD=20.68u rfmode=0
M$20 pcasc \$444 \$749 vss sg13_hv_nmos L=1u W=10u AS=3.4p AD=3.4p PS=20.68u
+ PD=20.68u rfmode=0
M$21 pcasc \$444 \$749 vss sg13_hv_nmos L=1u W=10u AS=3.4p AD=3.4p PS=20.68u
+ PD=20.68u rfmode=0
M$22 pcasc \$444 \$749 vss sg13_hv_nmos L=1u W=10u AS=3.4p AD=3.4p PS=20.68u
+ PD=20.68u rfmode=0
M$23 pcasc \$444 \$749 vss sg13_hv_nmos L=1u W=10u AS=3.4p AD=3.4p PS=20.68u
+ PD=20.68u rfmode=0
M$24 pcasc \$444 \$749 vss sg13_hv_nmos L=1u W=10u AS=3.4p AD=3.4p PS=20.68u
+ PD=20.68u rfmode=0
M$25 pcasc \$444 \$749 vss sg13_hv_nmos L=1u W=10u AS=3.4p AD=3.4p PS=20.68u
+ PD=20.68u rfmode=0
M$26 pcasc \$444 \$749 vss sg13_hv_nmos L=1u W=10u AS=3.4p AD=3.4p PS=20.68u
+ PD=20.68u rfmode=0
M$27 pcasc \$444 \$749 vss sg13_hv_nmos L=1u W=10u AS=3.4p AD=3.4p PS=20.68u
+ PD=20.68u rfmode=0
M$28 pcasc \$444 \$749 vss sg13_hv_nmos L=1u W=10u AS=3.4p AD=3.4p PS=20.68u
+ PD=20.68u rfmode=0
M$29 pcasc \$444 \$749 vss sg13_hv_nmos L=1u W=10u AS=3.4p AD=3.4p PS=20.68u
+ PD=20.68u rfmode=0
M$30 \$445 \$444 vbe vss sg13_hv_nmos L=1u W=10u AS=3.4p AD=3.4p PS=20.68u
+ PD=20.68u rfmode=0
M$31 \$445 \$444 vbe vss sg13_hv_nmos L=1u W=10u AS=3.4p AD=3.4p PS=20.68u
+ PD=20.68u rfmode=0
M$32 \$445 \$444 vbe vss sg13_hv_nmos L=1u W=10u AS=3.4p AD=3.4p PS=20.68u
+ PD=20.68u rfmode=0
M$33 \$445 \$444 vbe vss sg13_hv_nmos L=1u W=10u AS=3.4p AD=3.4p PS=20.68u
+ PD=20.68u rfmode=0
M$34 \$445 \$444 vbe vss sg13_hv_nmos L=1u W=10u AS=3.4p AD=3.4p PS=20.68u
+ PD=20.68u rfmode=0
M$35 \$445 \$444 vbe vss sg13_hv_nmos L=1u W=10u AS=3.4p AD=3.4p PS=20.68u
+ PD=20.68u rfmode=0
M$36 \$445 \$444 vbe vss sg13_hv_nmos L=1u W=10u AS=3.4p AD=3.4p PS=20.68u
+ PD=20.68u rfmode=0
M$37 \$445 \$444 vbe vss sg13_hv_nmos L=1u W=10u AS=3.4p AD=3.4p PS=20.68u
+ PD=20.68u rfmode=0
M$38 \$445 \$444 vbe vss sg13_hv_nmos L=1u W=10u AS=3.4p AD=3.4p PS=20.68u
+ PD=20.68u rfmode=0
M$39 \$445 \$444 vbe vss sg13_hv_nmos L=1u W=10u AS=3.4p AD=3.4p PS=20.68u
+ PD=20.68u rfmode=0
M$40 \$445 \$444 vbe vss sg13_hv_nmos L=1u W=10u AS=3.4p AD=3.4p PS=20.68u
+ PD=20.68u rfmode=0
M$41 \$445 \$444 vbe vss sg13_hv_nmos L=1u W=10u AS=3.4p AD=3.4p PS=20.68u
+ PD=20.68u rfmode=0
M$42 \$445 \$444 vbe vss sg13_hv_nmos L=1u W=10u AS=3.4p AD=3.4p PS=20.68u
+ PD=20.68u rfmode=0
M$43 \$445 \$444 vbe vss sg13_hv_nmos L=1u W=10u AS=3.4p AD=3.4p PS=20.68u
+ PD=20.68u rfmode=0
M$44 \$445 \$444 vbe vss sg13_hv_nmos L=1u W=10u AS=3.4p AD=3.4p PS=20.68u
+ PD=20.68u rfmode=0
M$45 \$445 \$444 vbe vss sg13_hv_nmos L=1u W=10u AS=3.4p AD=3.4p PS=20.68u
+ PD=20.68u rfmode=0
M$46 \$749 \$444 pcasc vss sg13_hv_nmos L=1u W=10u AS=3.4p AD=3.4p PS=20.68u
+ PD=20.68u rfmode=0
M$47 \$445 \$444 vbe vss sg13_hv_nmos L=1u W=10u AS=3.4p AD=3.4p PS=20.68u
+ PD=20.68u rfmode=0
M$48 \$749 \$444 pcasc vss sg13_hv_nmos L=1u W=10u AS=3.4p AD=3.4p PS=20.68u
+ PD=20.68u rfmode=0
M$49 \$749 \$444 pcasc vss sg13_hv_nmos L=1u W=10u AS=3.4p AD=3.4p PS=20.68u
+ PD=20.68u rfmode=0
M$50 \$445 \$444 vbe vss sg13_hv_nmos L=1u W=10u AS=3.4p AD=3.4p PS=20.68u
+ PD=20.68u rfmode=0
M$51 \$749 \$444 pcasc vss sg13_hv_nmos L=1u W=10u AS=3.4p AD=3.4p PS=20.68u
+ PD=20.68u rfmode=0
M$52 \$445 \$444 vbe vss sg13_hv_nmos L=1u W=10u AS=3.4p AD=3.4p PS=20.68u
+ PD=20.68u rfmode=0
M$53 \$749 \$444 pcasc vss sg13_hv_nmos L=1u W=10u AS=3.4p AD=3.4p PS=20.68u
+ PD=20.68u rfmode=0
M$54 \$445 \$444 vbe vss sg13_hv_nmos L=1u W=10u AS=3.4p AD=3.4p PS=20.68u
+ PD=20.68u rfmode=0
M$55 \$749 \$444 pcasc vss sg13_hv_nmos L=1u W=10u AS=3.4p AD=3.4p PS=20.68u
+ PD=20.68u rfmode=0
M$56 \$445 \$444 vbe vss sg13_hv_nmos L=1u W=10u AS=3.4p AD=3.4p PS=20.68u
+ PD=20.68u rfmode=0
M$57 pcasc \$444 \$749 vss sg13_hv_nmos L=1u W=10u AS=3.4p AD=3.4p PS=20.68u
+ PD=20.68u rfmode=0
M$58 \$749 \$444 pcasc vss sg13_hv_nmos L=1u W=10u AS=3.4p AD=3.4p PS=20.68u
+ PD=20.68u rfmode=0
M$59 pcasc \$444 \$749 vss sg13_hv_nmos L=1u W=10u AS=3.4p AD=3.4p PS=20.68u
+ PD=20.68u rfmode=0
M$60 \$749 \$444 pcasc vss sg13_hv_nmos L=1u W=10u AS=3.4p AD=3.4p PS=20.68u
+ PD=20.68u rfmode=0
M$61 pcasc \$444 \$749 vss sg13_hv_nmos L=1u W=10u AS=3.4p AD=3.4p PS=20.68u
+ PD=20.68u rfmode=0
M$62 \$749 \$444 pcasc vss sg13_hv_nmos L=1u W=10u AS=3.4p AD=3.4p PS=20.68u
+ PD=20.68u rfmode=0
M$63 pcasc \$444 \$749 vss sg13_hv_nmos L=1u W=10u AS=3.4p AD=3.4p PS=20.68u
+ PD=20.68u rfmode=0
M$64 \$749 \$444 pcasc vss sg13_hv_nmos L=1u W=10u AS=3.4p AD=3.4p PS=20.68u
+ PD=20.68u rfmode=0
M$65 \$749 \$444 pcasc vss sg13_hv_nmos L=1u W=10u AS=3.4p AD=3.4p PS=20.68u
+ PD=20.68u rfmode=0
M$66 pcasc \$444 \$749 vss sg13_hv_nmos L=1u W=10u AS=3.4p AD=3.4p PS=20.68u
+ PD=20.68u rfmode=0
M$67 \$749 \$444 pcasc vss sg13_hv_nmos L=1u W=10u AS=3.4p AD=3.4p PS=20.68u
+ PD=20.68u rfmode=0
M$68 pcasc \$444 \$749 vss sg13_hv_nmos L=1u W=10u AS=3.4p AD=3.4p PS=20.68u
+ PD=20.68u rfmode=0
M$69 pcasc \$444 \$749 vss sg13_hv_nmos L=1u W=10u AS=3.4p AD=3.4p PS=20.68u
+ PD=20.68u rfmode=0
M$70 pcasc \$444 \$749 vss sg13_hv_nmos L=1u W=10u AS=3.4p AD=3.4p PS=20.68u
+ PD=20.68u rfmode=0
M$71 pcasc \$444 \$749 vss sg13_hv_nmos L=1u W=10u AS=3.4p AD=3.4p PS=20.68u
+ PD=20.68u rfmode=0
M$72 pcasc \$444 \$749 vss sg13_hv_nmos L=1u W=10u AS=3.4p AD=3.4p PS=20.68u
+ PD=20.68u rfmode=0
M$73 \$749 \$444 pcasc vss sg13_hv_nmos L=1u W=10u AS=3.4p AD=3.4p PS=20.68u
+ PD=20.68u rfmode=0
M$74 \$749 \$444 pcasc vss sg13_hv_nmos L=1u W=10u AS=3.4p AD=3.4p PS=20.68u
+ PD=20.68u rfmode=0
M$75 pcasc \$444 \$749 vss sg13_hv_nmos L=1u W=10u AS=3.4p AD=3.4p PS=20.68u
+ PD=20.68u rfmode=0
M$76 pcasc \$444 \$749 vss sg13_hv_nmos L=1u W=10u AS=3.4p AD=3.4p PS=20.68u
+ PD=20.68u rfmode=0
M$77 \$749 \$444 pcasc vss sg13_hv_nmos L=1u W=10u AS=3.4p AD=3.4p PS=20.68u
+ PD=20.68u rfmode=0
M$78 \$749 \$444 pcasc vss sg13_hv_nmos L=1u W=10u AS=3.4p AD=3.4p PS=20.68u
+ PD=20.68u rfmode=0
M$79 vbe \$444 \$445 vss sg13_hv_nmos L=1u W=10u AS=3.4p AD=3.4p PS=20.68u
+ PD=20.68u rfmode=0
M$80 vbe \$444 \$445 vss sg13_hv_nmos L=1u W=10u AS=3.4p AD=3.4p PS=20.68u
+ PD=20.68u rfmode=0
M$81 \$749 \$444 pcasc vss sg13_hv_nmos L=1u W=10u AS=3.4p AD=3.4p PS=20.68u
+ PD=20.68u rfmode=0
M$82 \$749 \$444 pcasc vss sg13_hv_nmos L=1u W=10u AS=3.4p AD=3.4p PS=20.68u
+ PD=20.68u rfmode=0
M$83 vbe \$444 \$445 vss sg13_hv_nmos L=1u W=10u AS=3.4p AD=3.4p PS=20.68u
+ PD=20.68u rfmode=0
M$84 \$749 \$444 pcasc vss sg13_hv_nmos L=1u W=10u AS=3.4p AD=3.4p PS=20.68u
+ PD=20.68u rfmode=0
M$85 vbe \$444 \$445 vss sg13_hv_nmos L=1u W=10u AS=3.4p AD=3.4p PS=20.68u
+ PD=20.68u rfmode=0
M$86 \$749 \$444 pcasc vss sg13_hv_nmos L=1u W=10u AS=3.4p AD=3.4p PS=20.68u
+ PD=20.68u rfmode=0
M$87 vbe \$444 \$445 vss sg13_hv_nmos L=1u W=10u AS=3.4p AD=3.4p PS=20.68u
+ PD=20.68u rfmode=0
M$88 vbe \$444 \$445 vss sg13_hv_nmos L=1u W=10u AS=3.4p AD=3.4p PS=20.68u
+ PD=20.68u rfmode=0
M$89 \$749 \$444 pcasc vss sg13_hv_nmos L=1u W=10u AS=3.4p AD=3.4p PS=20.68u
+ PD=20.68u rfmode=0
M$90 vbe \$444 \$445 vss sg13_hv_nmos L=1u W=10u AS=3.4p AD=3.4p PS=20.68u
+ PD=20.68u rfmode=0
M$91 \$749 \$444 pcasc vss sg13_hv_nmos L=1u W=10u AS=3.4p AD=3.4p PS=20.68u
+ PD=20.68u rfmode=0
M$92 vbe \$444 \$445 vss sg13_hv_nmos L=1u W=10u AS=3.4p AD=3.4p PS=20.68u
+ PD=20.68u rfmode=0
M$93 \$749 \$444 pcasc vss sg13_hv_nmos L=1u W=10u AS=3.4p AD=3.4p PS=20.68u
+ PD=20.68u rfmode=0
M$94 vbe \$444 \$445 vss sg13_hv_nmos L=1u W=10u AS=3.4p AD=3.4p PS=20.68u
+ PD=20.68u rfmode=0
M$95 \$749 \$444 pcasc vss sg13_hv_nmos L=1u W=10u AS=3.4p AD=3.4p PS=20.68u
+ PD=20.68u rfmode=0
M$96 \$445 \$444 vbe vss sg13_hv_nmos L=1u W=10u AS=3.4p AD=3.4p PS=20.68u
+ PD=20.68u rfmode=0
M$97 vbe \$444 \$445 vss sg13_hv_nmos L=1u W=10u AS=3.4p AD=3.4p PS=20.68u
+ PD=20.68u rfmode=0
M$98 \$445 \$444 vbe vss sg13_hv_nmos L=1u W=10u AS=3.4p AD=3.4p PS=20.68u
+ PD=20.68u rfmode=0
M$99 vbe \$444 \$445 vss sg13_hv_nmos L=1u W=10u AS=3.4p AD=3.4p PS=20.68u
+ PD=20.68u rfmode=0
M$100 vbe \$444 \$445 vss sg13_hv_nmos L=1u W=10u AS=3.4p AD=3.4p PS=20.68u
+ PD=20.68u rfmode=0
M$101 \$445 \$444 vbe vss sg13_hv_nmos L=1u W=10u AS=3.4p AD=3.4p PS=20.68u
+ PD=20.68u rfmode=0
M$102 \$443 pcasc \$444 \$443 sg13_hv_pmos L=4u W=10u AS=3.4p AD=3.4p PS=20.68u
+ PD=20.68u rfmode=0
M$103 \$443 pcasc \$444 \$443 sg13_hv_pmos L=4u W=10u AS=3.4p AD=3.4p PS=20.68u
+ PD=20.68u rfmode=0
M$104 \$443 pcasc \$444 \$443 sg13_hv_pmos L=4u W=10u AS=3.4p AD=3.4p PS=20.68u
+ PD=20.68u rfmode=0
M$105 \$443 pcasc \$444 \$443 sg13_hv_pmos L=4u W=10u AS=3.4p AD=3.4p PS=20.68u
+ PD=20.68u rfmode=0
M$106 \$443 pcasc \$444 \$443 sg13_hv_pmos L=4u W=10u AS=3.4p AD=3.4p PS=20.68u
+ PD=20.68u rfmode=0
M$107 \$443 pcasc \$444 \$443 sg13_hv_pmos L=4u W=10u AS=3.4p AD=3.4p PS=20.68u
+ PD=20.68u rfmode=0
M$108 \$443 pcasc \$444 \$443 sg13_hv_pmos L=4u W=10u AS=3.4p AD=3.4p PS=20.68u
+ PD=20.68u rfmode=0
M$109 \$443 pcasc \$444 \$443 sg13_hv_pmos L=4u W=10u AS=3.4p AD=3.4p PS=20.68u
+ PD=20.68u rfmode=0
M$110 \$443 pcasc \$444 \$443 sg13_hv_pmos L=4u W=10u AS=3.4p AD=3.4p PS=20.68u
+ PD=20.68u rfmode=0
M$111 \$443 pcasc \$444 \$443 sg13_hv_pmos L=4u W=10u AS=3.4p AD=3.4p PS=20.68u
+ PD=20.68u rfmode=0
M$112 \$443 pcasc \$444 \$443 sg13_hv_pmos L=4u W=10u AS=3.4p AD=3.4p PS=20.68u
+ PD=20.68u rfmode=0
M$113 \$443 pcasc \$444 \$443 sg13_hv_pmos L=4u W=10u AS=3.4p AD=3.4p PS=20.68u
+ PD=20.68u rfmode=0
M$114 \$441 pcasc \$445 \$441 sg13_hv_pmos L=4u W=10u AS=3.4p AD=3.4p PS=20.68u
+ PD=20.68u rfmode=0
M$115 \$441 pcasc \$445 \$441 sg13_hv_pmos L=4u W=10u AS=3.4p AD=3.4p PS=20.68u
+ PD=20.68u rfmode=0
M$116 \$441 pcasc \$445 \$441 sg13_hv_pmos L=4u W=10u AS=3.4p AD=3.4p PS=20.68u
+ PD=20.68u rfmode=0
M$117 \$441 pcasc \$445 \$441 sg13_hv_pmos L=4u W=10u AS=3.4p AD=3.4p PS=20.68u
+ PD=20.68u rfmode=0
M$118 \$441 pcasc \$445 \$441 sg13_hv_pmos L=4u W=10u AS=3.4p AD=3.4p PS=20.68u
+ PD=20.68u rfmode=0
M$119 \$441 pcasc \$445 \$441 sg13_hv_pmos L=4u W=10u AS=3.4p AD=3.4p PS=20.68u
+ PD=20.68u rfmode=0
M$120 \$441 pcasc \$445 \$441 sg13_hv_pmos L=4u W=10u AS=3.4p AD=3.4p PS=20.68u
+ PD=20.68u rfmode=0
M$121 \$441 pcasc \$445 \$441 sg13_hv_pmos L=4u W=10u AS=3.4p AD=3.4p PS=20.68u
+ PD=20.68u rfmode=0
M$122 \$441 pcasc \$445 \$441 sg13_hv_pmos L=4u W=10u AS=3.4p AD=3.4p PS=20.68u
+ PD=20.68u rfmode=0
M$123 \$441 pcasc \$445 \$441 sg13_hv_pmos L=4u W=10u AS=3.4p AD=3.4p PS=20.68u
+ PD=20.68u rfmode=0
M$124 \$441 pcasc \$445 \$441 sg13_hv_pmos L=4u W=10u AS=3.4p AD=3.4p PS=20.68u
+ PD=20.68u rfmode=0
M$125 \$441 pcasc \$445 \$441 sg13_hv_pmos L=4u W=10u AS=3.4p AD=3.4p PS=20.68u
+ PD=20.68u rfmode=0
M$126 \$655 pcasc pbias \$655 sg13_hv_pmos L=4u W=10u AS=3.4p AD=3.4p PS=20.68u
+ PD=20.68u rfmode=0
M$127 \$656 pcasc vref \$656 sg13_hv_pmos L=4u W=10u AS=3.4p AD=3.4p PS=20.68u
+ PD=20.68u rfmode=0
M$128 \$655 pcasc pbias \$655 sg13_hv_pmos L=4u W=10u AS=3.4p AD=3.4p PS=20.68u
+ PD=20.68u rfmode=0
M$129 \$655 pcasc pbias \$655 sg13_hv_pmos L=4u W=10u AS=3.4p AD=3.4p PS=20.68u
+ PD=20.68u rfmode=0
M$130 \$656 pcasc vref \$656 sg13_hv_pmos L=4u W=10u AS=3.4p AD=3.4p PS=20.68u
+ PD=20.68u rfmode=0
M$131 \$655 pcasc pbias \$655 sg13_hv_pmos L=4u W=10u AS=3.4p AD=3.4p PS=20.68u
+ PD=20.68u rfmode=0
M$132 \$655 pcasc pbias \$655 sg13_hv_pmos L=4u W=10u AS=3.4p AD=3.4p PS=20.68u
+ PD=20.68u rfmode=0
M$133 \$655 pcasc pbias \$655 sg13_hv_pmos L=4u W=10u AS=3.4p AD=3.4p PS=20.68u
+ PD=20.68u rfmode=0
M$134 \$655 pcasc pbias \$655 sg13_hv_pmos L=4u W=10u AS=3.4p AD=3.4p PS=20.68u
+ PD=20.68u rfmode=0
M$135 \$655 pcasc pbias \$655 sg13_hv_pmos L=4u W=10u AS=3.4p AD=3.4p PS=20.68u
+ PD=20.68u rfmode=0
M$136 \$655 pcasc pbias \$655 sg13_hv_pmos L=4u W=10u AS=3.4p AD=3.4p PS=20.68u
+ PD=20.68u rfmode=0
M$137 \$655 pcasc pbias \$655 sg13_hv_pmos L=4u W=10u AS=3.4p AD=3.4p PS=20.68u
+ PD=20.68u rfmode=0
M$138 \$655 pcasc pbias \$655 sg13_hv_pmos L=4u W=10u AS=3.4p AD=3.4p PS=20.68u
+ PD=20.68u rfmode=0
M$139 \$655 pcasc pbias \$655 sg13_hv_pmos L=4u W=10u AS=3.4p AD=3.4p PS=20.68u
+ PD=20.68u rfmode=0
M$140 \$655 pcasc pbias \$655 sg13_hv_pmos L=4u W=10u AS=3.4p AD=3.4p PS=20.68u
+ PD=20.68u rfmode=0
M$141 \$655 pcasc pbias \$655 sg13_hv_pmos L=4u W=10u AS=3.4p AD=3.4p PS=20.68u
+ PD=20.68u rfmode=0
M$142 \$655 pcasc pbias \$655 sg13_hv_pmos L=4u W=10u AS=3.4p AD=3.4p PS=20.68u
+ PD=20.68u rfmode=0
M$143 \$655 pcasc pbias \$655 sg13_hv_pmos L=4u W=10u AS=3.4p AD=3.4p PS=20.68u
+ PD=20.68u rfmode=0
M$144 \$655 pcasc pbias \$655 sg13_hv_pmos L=4u W=10u AS=3.4p AD=3.4p PS=20.68u
+ PD=20.68u rfmode=0
M$145 \$655 pcasc pbias \$655 sg13_hv_pmos L=4u W=10u AS=3.4p AD=3.4p PS=20.68u
+ PD=20.68u rfmode=0
M$146 \$655 pcasc pbias \$655 sg13_hv_pmos L=4u W=10u AS=3.4p AD=3.4p PS=20.68u
+ PD=20.68u rfmode=0
M$147 \$655 pcasc pbias \$655 sg13_hv_pmos L=4u W=10u AS=3.4p AD=3.4p PS=20.68u
+ PD=20.68u rfmode=0
M$148 \$655 pcasc pbias \$655 sg13_hv_pmos L=4u W=10u AS=3.4p AD=3.4p PS=20.68u
+ PD=20.68u rfmode=0
M$149 \$655 pcasc pbias \$655 sg13_hv_pmos L=4u W=10u AS=3.4p AD=3.4p PS=20.68u
+ PD=20.68u rfmode=0
M$150 \$656 pcasc vref \$656 sg13_hv_pmos L=4u W=10u AS=3.4p AD=3.4p PS=20.68u
+ PD=20.68u rfmode=0
M$151 \$656 pcasc vref \$656 sg13_hv_pmos L=4u W=10u AS=3.4p AD=3.4p PS=20.68u
+ PD=20.68u rfmode=0
M$152 \$655 pcasc pbias \$655 sg13_hv_pmos L=4u W=10u AS=3.4p AD=3.4p PS=20.68u
+ PD=20.68u rfmode=0
M$153 \$657 pcasc iptat \$657 sg13_hv_pmos L=4u W=10u AS=3.4p AD=3.4p PS=20.68u
+ PD=20.68u rfmode=0
M$154 \$655 pcasc pbias \$655 sg13_hv_pmos L=4u W=10u AS=3.4p AD=3.4p PS=20.68u
+ PD=20.68u rfmode=0
M$155 \$441 pcasc \$445 \$441 sg13_hv_pmos L=4u W=10u AS=3.4p AD=3.4p PS=20.68u
+ PD=20.68u rfmode=0
M$156 vdd \$8 \$801 vdd sg13_hv_pmos L=0.5u W=2u AS=0.68p AD=0.68p PS=4.68u
+ PD=4.68u rfmode=0
M$157 \$441 pcasc \$445 \$441 sg13_hv_pmos L=4u W=10u AS=3.4p AD=3.4p PS=20.68u
+ PD=20.68u rfmode=0
M$158 vdd r4 \$819 vdd sg13_hv_pmos L=0.5u W=2u AS=0.68p AD=0.68p PS=4.68u
+ PD=4.68u rfmode=0
M$159 \$441 pcasc \$445 \$441 sg13_hv_pmos L=4u W=10u AS=3.4p AD=3.4p PS=20.68u
+ PD=20.68u rfmode=0
M$160 \$441 pcasc \$445 \$441 sg13_hv_pmos L=4u W=10u AS=3.4p AD=3.4p PS=20.68u
+ PD=20.68u rfmode=0
M$161 \$441 pcasc \$445 \$441 sg13_hv_pmos L=4u W=10u AS=3.4p AD=3.4p PS=20.68u
+ PD=20.68u rfmode=0
M$162 \$441 pcasc \$445 \$441 sg13_hv_pmos L=4u W=10u AS=3.4p AD=3.4p PS=20.68u
+ PD=20.68u rfmode=0
M$163 \$441 pcasc \$445 \$441 sg13_hv_pmos L=4u W=10u AS=3.4p AD=3.4p PS=20.68u
+ PD=20.68u rfmode=0
M$164 \$441 pcasc \$445 \$441 sg13_hv_pmos L=4u W=10u AS=3.4p AD=3.4p PS=20.68u
+ PD=20.68u rfmode=0
M$165 \$441 pcasc \$445 \$441 sg13_hv_pmos L=4u W=10u AS=3.4p AD=3.4p PS=20.68u
+ PD=20.68u rfmode=0
M$166 \$441 pcasc \$445 \$441 sg13_hv_pmos L=4u W=10u AS=3.4p AD=3.4p PS=20.68u
+ PD=20.68u rfmode=0
M$167 \$441 pcasc \$445 \$441 sg13_hv_pmos L=4u W=10u AS=3.4p AD=3.4p PS=20.68u
+ PD=20.68u rfmode=0
M$168 \$441 pcasc \$445 \$441 sg13_hv_pmos L=4u W=10u AS=3.4p AD=3.4p PS=20.68u
+ PD=20.68u rfmode=0
M$169 \$443 pcasc \$444 \$443 sg13_hv_pmos L=4u W=10u AS=3.4p AD=3.4p PS=20.68u
+ PD=20.68u rfmode=0
M$170 \$443 pcasc \$444 \$443 sg13_hv_pmos L=4u W=10u AS=3.4p AD=3.4p PS=20.68u
+ PD=20.68u rfmode=0
M$171 \$443 pcasc \$444 \$443 sg13_hv_pmos L=4u W=10u AS=3.4p AD=3.4p PS=20.68u
+ PD=20.68u rfmode=0
M$172 \$443 pcasc \$444 \$443 sg13_hv_pmos L=4u W=10u AS=3.4p AD=3.4p PS=20.68u
+ PD=20.68u rfmode=0
M$173 \$443 pcasc \$444 \$443 sg13_hv_pmos L=4u W=10u AS=3.4p AD=3.4p PS=20.68u
+ PD=20.68u rfmode=0
M$174 \$443 pcasc \$444 \$443 sg13_hv_pmos L=4u W=10u AS=3.4p AD=3.4p PS=20.68u
+ PD=20.68u rfmode=0
M$175 \$443 pcasc \$444 \$443 sg13_hv_pmos L=4u W=10u AS=3.4p AD=3.4p PS=20.68u
+ PD=20.68u rfmode=0
M$176 \$443 pcasc \$444 \$443 sg13_hv_pmos L=4u W=10u AS=3.4p AD=3.4p PS=20.68u
+ PD=20.68u rfmode=0
M$177 \$443 pcasc \$444 \$443 sg13_hv_pmos L=4u W=10u AS=3.4p AD=3.4p PS=20.68u
+ PD=20.68u rfmode=0
M$178 \$443 pcasc \$444 \$443 sg13_hv_pmos L=4u W=10u AS=3.4p AD=3.4p PS=20.68u
+ PD=20.68u rfmode=0
M$179 \$443 pcasc \$444 \$443 sg13_hv_pmos L=4u W=10u AS=3.4p AD=3.4p PS=20.68u
+ PD=20.68u rfmode=0
M$180 \$443 pcasc \$444 \$443 sg13_hv_pmos L=4u W=10u AS=3.4p AD=3.4p PS=20.68u
+ PD=20.68u rfmode=0
M$181 vdd pbias \$655 vdd sg13_hv_pmos L=4u W=5u AS=1.7p AD=1.7p PS=10.68u
+ PD=10.68u rfmode=0
M$182 vdd pbias \$441 vdd sg13_hv_pmos L=4u W=5u AS=1.7p AD=1.7p PS=10.68u
+ PD=10.68u rfmode=0
M$183 vdd pbias \$655 vdd sg13_hv_pmos L=4u W=5u AS=1.7p AD=1.7p PS=10.68u
+ PD=10.68u rfmode=0
M$184 vdd pbias \$441 vdd sg13_hv_pmos L=4u W=5u AS=1.7p AD=1.7p PS=10.68u
+ PD=10.68u rfmode=0
M$185 vdd pbias \$441 vdd sg13_hv_pmos L=4u W=5u AS=1.7p AD=1.7p PS=10.68u
+ PD=10.68u rfmode=0
M$186 vdd pbias \$655 vdd sg13_hv_pmos L=4u W=5u AS=1.7p AD=1.7p PS=10.68u
+ PD=10.68u rfmode=0
M$187 vdd pbias \$655 vdd sg13_hv_pmos L=4u W=5u AS=1.7p AD=1.7p PS=10.68u
+ PD=10.68u rfmode=0
M$188 vdd pbias \$441 vdd sg13_hv_pmos L=4u W=5u AS=1.7p AD=1.7p PS=10.68u
+ PD=10.68u rfmode=0
M$189 vdd pbias \$443 vdd sg13_hv_pmos L=4u W=5u AS=1.7p AD=1.7p PS=10.68u
+ PD=10.68u rfmode=0
M$190 vdd pbias \$441 vdd sg13_hv_pmos L=4u W=5u AS=1.7p AD=1.7p PS=10.68u
+ PD=10.68u rfmode=0
M$191 vdd pbias \$441 vdd sg13_hv_pmos L=4u W=5u AS=1.7p AD=1.7p PS=10.68u
+ PD=10.68u rfmode=0
M$192 vdd pbias \$443 vdd sg13_hv_pmos L=4u W=5u AS=1.7p AD=1.7p PS=10.68u
+ PD=10.68u rfmode=0
M$193 vdd pbias \$441 vdd sg13_hv_pmos L=4u W=5u AS=1.7p AD=1.7p PS=10.68u
+ PD=10.68u rfmode=0
M$194 vdd pbias \$443 vdd sg13_hv_pmos L=4u W=5u AS=1.7p AD=1.7p PS=10.68u
+ PD=10.68u rfmode=0
M$195 vdd pbias \$443 vdd sg13_hv_pmos L=4u W=5u AS=1.7p AD=1.7p PS=10.68u
+ PD=10.68u rfmode=0
M$196 vdd pbias \$441 vdd sg13_hv_pmos L=4u W=5u AS=1.7p AD=1.7p PS=10.68u
+ PD=10.68u rfmode=0
M$197 vdd pbias \$441 vdd sg13_hv_pmos L=4u W=5u AS=1.7p AD=1.7p PS=10.68u
+ PD=10.68u rfmode=0
M$198 vdd pbias \$443 vdd sg13_hv_pmos L=4u W=5u AS=1.7p AD=1.7p PS=10.68u
+ PD=10.68u rfmode=0
M$199 vdd pbias \$443 vdd sg13_hv_pmos L=4u W=5u AS=1.7p AD=1.7p PS=10.68u
+ PD=10.68u rfmode=0
M$200 vdd pbias \$441 vdd sg13_hv_pmos L=4u W=5u AS=1.7p AD=1.7p PS=10.68u
+ PD=10.68u rfmode=0
M$201 vdd pbias \$443 vdd sg13_hv_pmos L=4u W=5u AS=1.7p AD=1.7p PS=10.68u
+ PD=10.68u rfmode=0
M$202 vdd pbias \$441 vdd sg13_hv_pmos L=4u W=5u AS=1.7p AD=1.7p PS=10.68u
+ PD=10.68u rfmode=0
M$203 vdd pbias \$441 vdd sg13_hv_pmos L=4u W=5u AS=1.7p AD=1.7p PS=10.68u
+ PD=10.68u rfmode=0
M$204 vdd pbias \$443 vdd sg13_hv_pmos L=4u W=5u AS=1.7p AD=1.7p PS=10.68u
+ PD=10.68u rfmode=0
M$205 vdd pbias \$443 vdd sg13_hv_pmos L=4u W=5u AS=1.7p AD=1.7p PS=10.68u
+ PD=10.68u rfmode=0
M$206 vdd pbias \$655 vdd sg13_hv_pmos L=4u W=5u AS=1.7p AD=1.7p PS=10.68u
+ PD=10.68u rfmode=0
M$207 vdd pbias \$655 vdd sg13_hv_pmos L=4u W=5u AS=1.7p AD=1.7p PS=10.68u
+ PD=10.68u rfmode=0
M$208 vdd pbias \$443 vdd sg13_hv_pmos L=4u W=5u AS=1.7p AD=1.7p PS=10.68u
+ PD=10.68u rfmode=0
M$209 vdd pbias \$655 vdd sg13_hv_pmos L=4u W=5u AS=1.7p AD=1.7p PS=10.68u
+ PD=10.68u rfmode=0
M$210 vdd pbias \$443 vdd sg13_hv_pmos L=4u W=5u AS=1.7p AD=1.7p PS=10.68u
+ PD=10.68u rfmode=0
M$211 vdd pbias \$655 vdd sg13_hv_pmos L=4u W=5u AS=1.7p AD=1.7p PS=10.68u
+ PD=10.68u rfmode=0
M$212 vdd pbias \$443 vdd sg13_hv_pmos L=4u W=5u AS=1.7p AD=1.7p PS=10.68u
+ PD=10.68u rfmode=0
M$213 vdd pbias \$655 vdd sg13_hv_pmos L=4u W=5u AS=1.7p AD=1.7p PS=10.68u
+ PD=10.68u rfmode=0
M$214 vdd pbias \$443 vdd sg13_hv_pmos L=4u W=5u AS=1.7p AD=1.7p PS=10.68u
+ PD=10.68u rfmode=0
M$215 vdd pbias \$655 vdd sg13_hv_pmos L=4u W=5u AS=1.7p AD=1.7p PS=10.68u
+ PD=10.68u rfmode=0
M$216 vdd pbias \$443 vdd sg13_hv_pmos L=4u W=5u AS=1.7p AD=1.7p PS=10.68u
+ PD=10.68u rfmode=0
M$217 vdd pbias \$655 vdd sg13_hv_pmos L=4u W=5u AS=1.7p AD=1.7p PS=10.68u
+ PD=10.68u rfmode=0
M$218 vdd pbias \$443 vdd sg13_hv_pmos L=4u W=5u AS=1.7p AD=1.7p PS=10.68u
+ PD=10.68u rfmode=0
M$219 vdd pbias \$655 vdd sg13_hv_pmos L=4u W=5u AS=1.7p AD=1.7p PS=10.68u
+ PD=10.68u rfmode=0
M$220 vdd pbias \$443 vdd sg13_hv_pmos L=4u W=5u AS=1.7p AD=1.7p PS=10.68u
+ PD=10.68u rfmode=0
M$221 vdd pbias \$443 vdd sg13_hv_pmos L=4u W=5u AS=1.7p AD=1.7p PS=10.68u
+ PD=10.68u rfmode=0
M$222 vdd pbias \$443 vdd sg13_hv_pmos L=4u W=5u AS=1.7p AD=1.7p PS=10.68u
+ PD=10.68u rfmode=0
M$223 vdd pbias \$443 vdd sg13_hv_pmos L=4u W=5u AS=1.7p AD=1.7p PS=10.68u
+ PD=10.68u rfmode=0
M$224 vdd pbias \$443 vdd sg13_hv_pmos L=4u W=5u AS=1.7p AD=1.7p PS=10.68u
+ PD=10.68u rfmode=0
M$225 vdd pbias \$443 vdd sg13_hv_pmos L=4u W=5u AS=1.7p AD=1.7p PS=10.68u
+ PD=10.68u rfmode=0
M$226 vdd pbias \$443 vdd sg13_hv_pmos L=4u W=5u AS=1.7p AD=1.7p PS=10.68u
+ PD=10.68u rfmode=0
M$227 vdd pbias \$443 vdd sg13_hv_pmos L=4u W=5u AS=1.7p AD=1.7p PS=10.68u
+ PD=10.68u rfmode=0
M$228 vdd pbias \$443 vdd sg13_hv_pmos L=4u W=5u AS=1.7p AD=1.7p PS=10.68u
+ PD=10.68u rfmode=0
M$229 vdd pbias \$655 vdd sg13_hv_pmos L=4u W=5u AS=1.7p AD=1.7p PS=10.68u
+ PD=10.68u rfmode=0
M$230 vdd pbias \$655 vdd sg13_hv_pmos L=4u W=5u AS=1.7p AD=1.7p PS=10.68u
+ PD=10.68u rfmode=0
M$231 vdd pbias \$655 vdd sg13_hv_pmos L=4u W=5u AS=1.7p AD=1.7p PS=10.68u
+ PD=10.68u rfmode=0
M$232 vdd pbias \$655 vdd sg13_hv_pmos L=4u W=5u AS=1.7p AD=1.7p PS=10.68u
+ PD=10.68u rfmode=0
M$233 vdd pbias \$655 vdd sg13_hv_pmos L=4u W=5u AS=1.7p AD=1.7p PS=10.68u
+ PD=10.68u rfmode=0
M$234 vdd pbias \$655 vdd sg13_hv_pmos L=4u W=5u AS=1.7p AD=1.7p PS=10.68u
+ PD=10.68u rfmode=0
M$235 vdd pbias \$655 vdd sg13_hv_pmos L=4u W=5u AS=1.7p AD=1.7p PS=10.68u
+ PD=10.68u rfmode=0
M$236 vdd pbias \$655 vdd sg13_hv_pmos L=4u W=5u AS=1.7p AD=1.7p PS=10.68u
+ PD=10.68u rfmode=0
M$237 vdd pbias \$655 vdd sg13_hv_pmos L=4u W=5u AS=1.7p AD=1.7p PS=10.68u
+ PD=10.68u rfmode=0
M$238 vdd pbias \$655 vdd sg13_hv_pmos L=4u W=5u AS=1.7p AD=1.7p PS=10.68u
+ PD=10.68u rfmode=0
M$239 vdd pbias \$655 vdd sg13_hv_pmos L=4u W=5u AS=1.7p AD=1.7p PS=10.68u
+ PD=10.68u rfmode=0
M$240 vdd pbias \$655 vdd sg13_hv_pmos L=4u W=5u AS=1.7p AD=1.7p PS=10.68u
+ PD=10.68u rfmode=0
M$241 vdd pbias \$441 vdd sg13_hv_pmos L=4u W=5u AS=1.7p AD=1.7p PS=10.68u
+ PD=10.68u rfmode=0
M$242 vdd pbias \$441 vdd sg13_hv_pmos L=4u W=5u AS=1.7p AD=1.7p PS=10.68u
+ PD=10.68u rfmode=0
M$243 vdd pbias \$441 vdd sg13_hv_pmos L=4u W=5u AS=1.7p AD=1.7p PS=10.68u
+ PD=10.68u rfmode=0
M$244 vdd pbias \$441 vdd sg13_hv_pmos L=4u W=5u AS=1.7p AD=1.7p PS=10.68u
+ PD=10.68u rfmode=0
M$245 vdd pbias \$441 vdd sg13_hv_pmos L=4u W=5u AS=1.7p AD=1.7p PS=10.68u
+ PD=10.68u rfmode=0
M$246 vdd pbias \$441 vdd sg13_hv_pmos L=4u W=5u AS=1.7p AD=1.7p PS=10.68u
+ PD=10.68u rfmode=0
M$247 vdd pbias \$441 vdd sg13_hv_pmos L=4u W=5u AS=1.7p AD=1.7p PS=10.68u
+ PD=10.68u rfmode=0
M$248 vdd pbias \$441 vdd sg13_hv_pmos L=4u W=5u AS=1.7p AD=1.7p PS=10.68u
+ PD=10.68u rfmode=0
M$249 vdd pbias \$441 vdd sg13_hv_pmos L=4u W=5u AS=1.7p AD=1.7p PS=10.68u
+ PD=10.68u rfmode=0
M$250 vdd pbias \$441 vdd sg13_hv_pmos L=4u W=5u AS=1.7p AD=1.7p PS=10.68u
+ PD=10.68u rfmode=0
M$251 vdd pbias \$441 vdd sg13_hv_pmos L=4u W=5u AS=1.7p AD=1.7p PS=10.68u
+ PD=10.68u rfmode=0
M$252 vdd pbias \$441 vdd sg13_hv_pmos L=4u W=5u AS=1.7p AD=1.7p PS=10.68u
+ PD=10.68u rfmode=0
M$253 vdd pbias \$656 vdd sg13_hv_pmos L=4u W=5u AS=1.7p AD=1.7p PS=10.68u
+ PD=10.68u rfmode=0
M$254 vdd pbias \$656 vdd sg13_hv_pmos L=4u W=5u AS=1.7p AD=1.7p PS=10.68u
+ PD=10.68u rfmode=0
M$255 vdd pbias \$656 vdd sg13_hv_pmos L=4u W=5u AS=1.7p AD=1.7p PS=10.68u
+ PD=10.68u rfmode=0
M$256 vdd pbias \$656 vdd sg13_hv_pmos L=4u W=5u AS=1.7p AD=1.7p PS=10.68u
+ PD=10.68u rfmode=0
M$257 vdd pbias \$657 vdd sg13_hv_pmos L=4u W=5u AS=1.7p AD=1.7p PS=10.68u
+ PD=10.68u rfmode=0
M$258 vdd pbias \$8 vdd sg13_hv_pmos L=4u W=5u AS=1.7p AD=1.7p PS=10.68u
+ PD=10.68u rfmode=0
M$259 vdd pbias \$657 vdd sg13_hv_pmos L=4u W=5u AS=1.7p AD=1.7p PS=10.68u
+ PD=10.68u rfmode=0
M$260 vdd pbias \$8 vdd sg13_hv_pmos L=4u W=5u AS=1.7p AD=1.7p PS=10.68u
+ PD=10.68u rfmode=0
M$261 vdd pbias \$655 vdd sg13_hv_pmos L=4u W=5u AS=1.7p AD=1.7p PS=10.68u
+ PD=10.68u rfmode=0
M$262 vdd pbias \$655 vdd sg13_hv_pmos L=4u W=5u AS=1.7p AD=1.7p PS=10.68u
+ PD=10.68u rfmode=0
M$263 vdd pbias \$655 vdd sg13_hv_pmos L=4u W=5u AS=1.7p AD=1.7p PS=10.68u
+ PD=10.68u rfmode=0
M$264 vdd pbias \$655 vdd sg13_hv_pmos L=4u W=5u AS=1.7p AD=1.7p PS=10.68u
+ PD=10.68u rfmode=0
M$265 vdd pbias \$655 vdd sg13_hv_pmos L=4u W=5u AS=1.7p AD=1.7p PS=10.68u
+ PD=10.68u rfmode=0
M$266 vdd pbias \$656 vdd sg13_hv_pmos L=4u W=5u AS=1.7p AD=1.7p PS=10.68u
+ PD=10.68u rfmode=0
M$267 vdd pbias \$655 vdd sg13_hv_pmos L=4u W=5u AS=1.7p AD=1.7p PS=10.68u
+ PD=10.68u rfmode=0
M$268 vdd pbias \$656 vdd sg13_hv_pmos L=4u W=5u AS=1.7p AD=1.7p PS=10.68u
+ PD=10.68u rfmode=0
M$269 vdd pbias \$656 vdd sg13_hv_pmos L=4u W=5u AS=1.7p AD=1.7p PS=10.68u
+ PD=10.68u rfmode=0
M$270 vdd pbias \$655 vdd sg13_hv_pmos L=4u W=5u AS=1.7p AD=1.7p PS=10.68u
+ PD=10.68u rfmode=0
M$271 vdd pbias \$655 vdd sg13_hv_pmos L=4u W=5u AS=1.7p AD=1.7p PS=10.68u
+ PD=10.68u rfmode=0
M$272 vdd pbias \$656 vdd sg13_hv_pmos L=4u W=5u AS=1.7p AD=1.7p PS=10.68u
+ PD=10.68u rfmode=0
M$273 vdd pbias \$441 vdd sg13_hv_pmos L=4u W=5u AS=1.7p AD=1.7p PS=10.68u
+ PD=10.68u rfmode=0
M$274 vdd pbias \$655 vdd sg13_hv_pmos L=4u W=5u AS=1.7p AD=1.7p PS=10.68u
+ PD=10.68u rfmode=0
M$275 vdd pbias \$655 vdd sg13_hv_pmos L=4u W=5u AS=1.7p AD=1.7p PS=10.68u
+ PD=10.68u rfmode=0
M$276 vdd pbias \$441 vdd sg13_hv_pmos L=4u W=5u AS=1.7p AD=1.7p PS=10.68u
+ PD=10.68u rfmode=0
M$277 vdd pbias \$655 vdd sg13_hv_pmos L=4u W=5u AS=1.7p AD=1.7p PS=10.68u
+ PD=10.68u rfmode=0
M$278 vdd pbias \$441 vdd sg13_hv_pmos L=4u W=5u AS=1.7p AD=1.7p PS=10.68u
+ PD=10.68u rfmode=0
M$279 vdd pbias \$655 vdd sg13_hv_pmos L=4u W=5u AS=1.7p AD=1.7p PS=10.68u
+ PD=10.68u rfmode=0
M$280 vdd pbias \$441 vdd sg13_hv_pmos L=4u W=5u AS=1.7p AD=1.7p PS=10.68u
+ PD=10.68u rfmode=0
M$281 vdd pbias \$443 vdd sg13_hv_pmos L=4u W=5u AS=1.7p AD=1.7p PS=10.68u
+ PD=10.68u rfmode=0
M$282 vdd pbias \$441 vdd sg13_hv_pmos L=4u W=5u AS=1.7p AD=1.7p PS=10.68u
+ PD=10.68u rfmode=0
M$283 vdd pbias \$441 vdd sg13_hv_pmos L=4u W=5u AS=1.7p AD=1.7p PS=10.68u
+ PD=10.68u rfmode=0
M$284 vdd pbias \$443 vdd sg13_hv_pmos L=4u W=5u AS=1.7p AD=1.7p PS=10.68u
+ PD=10.68u rfmode=0
M$285 vdd pbias \$441 vdd sg13_hv_pmos L=4u W=5u AS=1.7p AD=1.7p PS=10.68u
+ PD=10.68u rfmode=0
M$286 vdd pbias \$443 vdd sg13_hv_pmos L=4u W=5u AS=1.7p AD=1.7p PS=10.68u
+ PD=10.68u rfmode=0
M$287 vdd pbias \$443 vdd sg13_hv_pmos L=4u W=5u AS=1.7p AD=1.7p PS=10.68u
+ PD=10.68u rfmode=0
M$288 vdd pbias \$441 vdd sg13_hv_pmos L=4u W=5u AS=1.7p AD=1.7p PS=10.68u
+ PD=10.68u rfmode=0
M$289 vdd pbias \$441 vdd sg13_hv_pmos L=4u W=5u AS=1.7p AD=1.7p PS=10.68u
+ PD=10.68u rfmode=0
M$290 vdd pbias \$443 vdd sg13_hv_pmos L=4u W=5u AS=1.7p AD=1.7p PS=10.68u
+ PD=10.68u rfmode=0
M$291 vdd pbias \$443 vdd sg13_hv_pmos L=4u W=5u AS=1.7p AD=1.7p PS=10.68u
+ PD=10.68u rfmode=0
M$292 vdd pbias \$441 vdd sg13_hv_pmos L=4u W=5u AS=1.7p AD=1.7p PS=10.68u
+ PD=10.68u rfmode=0
M$293 vdd pbias \$443 vdd sg13_hv_pmos L=4u W=5u AS=1.7p AD=1.7p PS=10.68u
+ PD=10.68u rfmode=0
M$294 vdd pbias \$441 vdd sg13_hv_pmos L=4u W=5u AS=1.7p AD=1.7p PS=10.68u
+ PD=10.68u rfmode=0
M$295 vdd pbias \$441 vdd sg13_hv_pmos L=4u W=5u AS=1.7p AD=1.7p PS=10.68u
+ PD=10.68u rfmode=0
M$296 vdd pbias \$443 vdd sg13_hv_pmos L=4u W=5u AS=1.7p AD=1.7p PS=10.68u
+ PD=10.68u rfmode=0
M$297 vdd pbias \$443 vdd sg13_hv_pmos L=4u W=5u AS=1.7p AD=1.7p PS=10.68u
+ PD=10.68u rfmode=0
M$298 vdd pbias \$443 vdd sg13_hv_pmos L=4u W=5u AS=1.7p AD=1.7p PS=10.68u
+ PD=10.68u rfmode=0
M$299 vdd pbias \$443 vdd sg13_hv_pmos L=4u W=5u AS=1.7p AD=1.7p PS=10.68u
+ PD=10.68u rfmode=0
M$300 vdd pbias \$443 vdd sg13_hv_pmos L=4u W=5u AS=1.7p AD=1.7p PS=10.68u
+ PD=10.68u rfmode=0
M$301 vdd pbias \$443 vdd sg13_hv_pmos L=4u W=5u AS=1.7p AD=1.7p PS=10.68u
+ PD=10.68u rfmode=0
M$302 vdd pbias \$443 vdd sg13_hv_pmos L=4u W=5u AS=1.7p AD=1.7p PS=10.68u
+ PD=10.68u rfmode=0
M$303 vdd pbias \$443 vdd sg13_hv_pmos L=4u W=5u AS=1.7p AD=1.7p PS=10.68u
+ PD=10.68u rfmode=0
M$304 vdd pbias \$443 vdd sg13_hv_pmos L=4u W=5u AS=1.7p AD=1.7p PS=10.68u
+ PD=10.68u rfmode=0
M$305 vdd pbias \$443 vdd sg13_hv_pmos L=4u W=5u AS=1.7p AD=1.7p PS=10.68u
+ PD=10.68u rfmode=0
M$306 vdd pbias \$443 vdd sg13_hv_pmos L=4u W=5u AS=1.7p AD=1.7p PS=10.68u
+ PD=10.68u rfmode=0
M$307 vdd pbias \$443 vdd sg13_hv_pmos L=4u W=5u AS=1.7p AD=1.7p PS=10.68u
+ PD=10.68u rfmode=0
M$308 vdd pbias \$443 vdd sg13_hv_pmos L=4u W=5u AS=1.7p AD=1.7p PS=10.68u
+ PD=10.68u rfmode=0
M$309 vdd pbias \$443 vdd sg13_hv_pmos L=4u W=5u AS=1.7p AD=1.7p PS=10.68u
+ PD=10.68u rfmode=0
M$310 vdd pbias \$443 vdd sg13_hv_pmos L=4u W=5u AS=1.7p AD=1.7p PS=10.68u
+ PD=10.68u rfmode=0
M$311 vdd pbias \$443 vdd sg13_hv_pmos L=4u W=5u AS=1.7p AD=1.7p PS=10.68u
+ PD=10.68u rfmode=0
M$312 vdd pbias \$443 vdd sg13_hv_pmos L=4u W=5u AS=1.7p AD=1.7p PS=10.68u
+ PD=10.68u rfmode=0
M$313 vdd pbias \$655 vdd sg13_hv_pmos L=4u W=5u AS=1.7p AD=1.7p PS=10.68u
+ PD=10.68u rfmode=0
M$314 vdd pbias \$655 vdd sg13_hv_pmos L=4u W=5u AS=1.7p AD=1.7p PS=10.68u
+ PD=10.68u rfmode=0
M$315 vdd pbias \$655 vdd sg13_hv_pmos L=4u W=5u AS=1.7p AD=1.7p PS=10.68u
+ PD=10.68u rfmode=0
M$316 vdd pbias \$655 vdd sg13_hv_pmos L=4u W=5u AS=1.7p AD=1.7p PS=10.68u
+ PD=10.68u rfmode=0
M$317 vdd pbias \$655 vdd sg13_hv_pmos L=4u W=5u AS=1.7p AD=1.7p PS=10.68u
+ PD=10.68u rfmode=0
M$318 vdd pbias \$655 vdd sg13_hv_pmos L=4u W=5u AS=1.7p AD=1.7p PS=10.68u
+ PD=10.68u rfmode=0
M$319 vdd pbias \$655 vdd sg13_hv_pmos L=4u W=5u AS=1.7p AD=1.7p PS=10.68u
+ PD=10.68u rfmode=0
M$320 vdd pbias \$655 vdd sg13_hv_pmos L=4u W=5u AS=1.7p AD=1.7p PS=10.68u
+ PD=10.68u rfmode=0
M$321 vdd pbias \$655 vdd sg13_hv_pmos L=4u W=5u AS=1.7p AD=1.7p PS=10.68u
+ PD=10.68u rfmode=0
M$322 vdd pbias \$655 vdd sg13_hv_pmos L=4u W=5u AS=1.7p AD=1.7p PS=10.68u
+ PD=10.68u rfmode=0
M$323 vdd pbias \$655 vdd sg13_hv_pmos L=4u W=5u AS=1.7p AD=1.7p PS=10.68u
+ PD=10.68u rfmode=0
M$324 vdd pbias \$655 vdd sg13_hv_pmos L=4u W=5u AS=1.7p AD=1.7p PS=10.68u
+ PD=10.68u rfmode=0
M$325 vdd pbias \$441 vdd sg13_hv_pmos L=4u W=5u AS=1.7p AD=1.7p PS=10.68u
+ PD=10.68u rfmode=0
M$326 vdd pbias \$441 vdd sg13_hv_pmos L=4u W=5u AS=1.7p AD=1.7p PS=10.68u
+ PD=10.68u rfmode=0
M$327 vdd pbias \$441 vdd sg13_hv_pmos L=4u W=5u AS=1.7p AD=1.7p PS=10.68u
+ PD=10.68u rfmode=0
M$328 vdd pbias \$441 vdd sg13_hv_pmos L=4u W=5u AS=1.7p AD=1.7p PS=10.68u
+ PD=10.68u rfmode=0
M$329 vdd pbias \$441 vdd sg13_hv_pmos L=4u W=5u AS=1.7p AD=1.7p PS=10.68u
+ PD=10.68u rfmode=0
M$330 vdd pbias \$441 vdd sg13_hv_pmos L=4u W=5u AS=1.7p AD=1.7p PS=10.68u
+ PD=10.68u rfmode=0
M$331 vdd pbias \$441 vdd sg13_hv_pmos L=4u W=5u AS=1.7p AD=1.7p PS=10.68u
+ PD=10.68u rfmode=0
M$332 vdd pbias \$441 vdd sg13_hv_pmos L=4u W=5u AS=1.7p AD=1.7p PS=10.68u
+ PD=10.68u rfmode=0
M$333 vdd pbias \$441 vdd sg13_hv_pmos L=4u W=5u AS=1.7p AD=1.7p PS=10.68u
+ PD=10.68u rfmode=0
M$334 vdd pbias \$441 vdd sg13_hv_pmos L=4u W=5u AS=1.7p AD=1.7p PS=10.68u
+ PD=10.68u rfmode=0
M$335 vdd pbias \$441 vdd sg13_hv_pmos L=4u W=5u AS=1.7p AD=1.7p PS=10.68u
+ PD=10.68u rfmode=0
M$336 vdd pbias \$441 vdd sg13_hv_pmos L=4u W=5u AS=1.7p AD=1.7p PS=10.68u
+ PD=10.68u rfmode=0
Q$337 vbe vbe vss vss npn13G2 we=70n le=900n Nx=1 m=1
Q$338 vbe vbe vss vss npn13G2 we=70n le=900n Nx=1 m=1
Q$339 vbe vbe vss vss npn13G2 we=70n le=900n Nx=1 m=1
Q$340 vbe vbe vss vss npn13G2 we=70n le=900n Nx=1 m=1
Q$341 vbe vbe vss vss npn13G2 we=70n le=900n Nx=1 m=1
Q$342 vbe vbe vss vss npn13G2 we=70n le=900n Nx=1 m=1
Q$343 vbe vbe vss vss npn13G2 we=70n le=900n Nx=1 m=1
Q$344 vbe vbe vss vss npn13G2 we=70n le=900n Nx=1 m=1
Q$345 vbe vbe vss vss npn13G2 we=70n le=900n Nx=1 m=1
Q$346 vbe vbe vss vss npn13G2 we=70n le=900n Nx=1 m=1
Q$347 vbe vbe vss vss npn13G2 we=70n le=900n Nx=1 m=1
Q$348 vbe vbe vss vss npn13G2 we=70n le=900n Nx=1 m=1
Q$349 \$440 \$440 vss vss npn13G2 we=70n le=900n Nx=1 m=1
Q$350 \$440 \$440 vss vss npn13G2 we=70n le=900n Nx=1 m=1
Q$351 \$440 \$440 vss vss npn13G2 we=70n le=900n Nx=1 m=1
Q$352 \$440 \$440 vss vss npn13G2 we=70n le=900n Nx=1 m=1
Q$353 \$440 \$440 vss vss npn13G2 we=70n le=900n Nx=1 m=1
Q$354 \$440 \$440 vss vss npn13G2 we=70n le=900n Nx=1 m=1
Q$355 \$440 \$440 vss vss npn13G2 we=70n le=900n Nx=1 m=1
Q$356 \$440 \$440 vss vss npn13G2 we=70n le=900n Nx=1 m=1
Q$357 \$440 \$440 vss vss npn13G2 we=70n le=900n Nx=1 m=1
Q$358 \$440 \$440 vss vss npn13G2 we=70n le=900n Nx=1 m=1
Q$359 \$440 \$440 vss vss npn13G2 we=70n le=900n Nx=1 m=1
Q$360 \$440 \$440 vss vss npn13G2 we=70n le=900n Nx=1 m=1
Q$361 vbe \$569 vss vss npn13G2 we=70n le=900n Nx=1 m=1
Q$362 vbe \$569 vss vss npn13G2 we=70n le=900n Nx=1 m=1
Q$363 vbe \$569 vss vss npn13G2 we=70n le=900n Nx=1 m=1
Q$364 vbe \$569 vss vss npn13G2 we=70n le=900n Nx=1 m=1
Q$365 vbe \$569 vss vss npn13G2 we=70n le=900n Nx=1 m=1
Q$366 vbe \$569 vss vss npn13G2 we=70n le=900n Nx=1 m=1
Q$367 vbe \$569 vss vss npn13G2 we=70n le=900n Nx=1 m=1
Q$368 vbe \$569 vss vss npn13G2 we=70n le=900n Nx=1 m=1
Q$369 vbe \$569 vss vss npn13G2 we=70n le=900n Nx=1 m=1
Q$370 vbe \$569 vss vss npn13G2 we=70n le=900n Nx=1 m=1
Q$371 vbe \$569 vss vss npn13G2 we=70n le=900n Nx=1 m=1
Q$372 vbe \$569 vss vss npn13G2 we=70n le=900n Nx=1 m=1
Q$373 \$749 vbe dvbe vss npn13G2 we=70n le=900n Nx=1 m=1
Q$374 \$749 vbe dvbe vss npn13G2 we=70n le=900n Nx=1 m=1
Q$375 \$749 vbe dvbe vss npn13G2 we=70n le=900n Nx=1 m=1
Q$376 \$749 vbe dvbe vss npn13G2 we=70n le=900n Nx=1 m=1
Q$377 \$749 vbe dvbe vss npn13G2 we=70n le=900n Nx=1 m=1
Q$378 \$749 vbe dvbe vss npn13G2 we=70n le=900n Nx=1 m=1
Q$379 \$749 vbe dvbe vss npn13G2 we=70n le=900n Nx=1 m=1
Q$380 \$749 vbe dvbe vss npn13G2 we=70n le=900n Nx=1 m=1
Q$381 \$749 vbe dvbe vss npn13G2 we=70n le=900n Nx=1 m=1
Q$382 \$749 vbe dvbe vss npn13G2 we=70n le=900n Nx=1 m=1
Q$383 \$749 vbe dvbe vss npn13G2 we=70n le=900n Nx=1 m=1
Q$384 \$749 vbe dvbe vss npn13G2 we=70n le=900n Nx=1 m=1
Q$385 \$749 vbe dvbe vss npn13G2 we=70n le=900n Nx=1 m=1
Q$386 \$749 vbe dvbe vss npn13G2 we=70n le=900n Nx=1 m=1
Q$387 \$749 vbe dvbe vss npn13G2 we=70n le=900n Nx=1 m=1
Q$388 \$749 vbe dvbe vss npn13G2 we=70n le=900n Nx=1 m=1
Q$389 \$749 vbe dvbe vss npn13G2 we=70n le=900n Nx=1 m=1
Q$390 \$749 vbe dvbe vss npn13G2 we=70n le=900n Nx=1 m=1
Q$391 \$749 vbe dvbe vss npn13G2 we=70n le=900n Nx=1 m=1
Q$392 \$749 vbe dvbe vss npn13G2 we=70n le=900n Nx=1 m=1
Q$393 \$749 vbe dvbe vss npn13G2 we=70n le=900n Nx=1 m=1
Q$394 \$749 vbe dvbe vss npn13G2 we=70n le=900n Nx=1 m=1
Q$395 \$749 vbe dvbe vss npn13G2 we=70n le=900n Nx=1 m=1
Q$396 \$749 vbe dvbe vss npn13G2 we=70n le=900n Nx=1 m=1
Q$397 \$749 vbe dvbe vss npn13G2 we=70n le=900n Nx=1 m=1
Q$398 \$749 vbe dvbe vss npn13G2 we=70n le=900n Nx=1 m=1
Q$399 \$749 vbe dvbe vss npn13G2 we=70n le=900n Nx=1 m=1
Q$400 \$749 vbe dvbe vss npn13G2 we=70n le=900n Nx=1 m=1
Q$401 \$749 vbe dvbe vss npn13G2 we=70n le=900n Nx=1 m=1
Q$402 \$749 vbe dvbe vss npn13G2 we=70n le=900n Nx=1 m=1
Q$403 \$749 vbe dvbe vss npn13G2 we=70n le=900n Nx=1 m=1
Q$404 \$749 vbe dvbe vss npn13G2 we=70n le=900n Nx=1 m=1
Q$405 \$749 vbe dvbe vss npn13G2 we=70n le=900n Nx=1 m=1
Q$406 \$749 vbe dvbe vss npn13G2 we=70n le=900n Nx=1 m=1
Q$407 \$749 vbe dvbe vss npn13G2 we=70n le=900n Nx=1 m=1
Q$408 \$749 vbe dvbe vss npn13G2 we=70n le=900n Nx=1 m=1
Q$409 \$749 vbe dvbe vss npn13G2 we=70n le=900n Nx=1 m=1
Q$410 \$749 vbe dvbe vss npn13G2 we=70n le=900n Nx=1 m=1
Q$411 \$749 vbe dvbe vss npn13G2 we=70n le=900n Nx=1 m=1
Q$412 \$749 vbe dvbe vss npn13G2 we=70n le=900n Nx=1 m=1
Q$413 \$749 vbe dvbe vss npn13G2 we=70n le=900n Nx=1 m=1
Q$414 \$749 vbe dvbe vss npn13G2 we=70n le=900n Nx=1 m=1
Q$415 \$749 vbe dvbe vss npn13G2 we=70n le=900n Nx=1 m=1
Q$416 \$749 vbe dvbe vss npn13G2 we=70n le=900n Nx=1 m=1
Q$417 \$749 vbe dvbe vss npn13G2 we=70n le=900n Nx=1 m=1
Q$418 \$749 vbe dvbe vss npn13G2 we=70n le=900n Nx=1 m=1
Q$419 \$749 vbe dvbe vss npn13G2 we=70n le=900n Nx=1 m=1
Q$420 \$749 vbe dvbe vss npn13G2 we=70n le=900n Nx=1 m=1
Q$421 \$749 vbe dvbe vss npn13G2 we=70n le=900n Nx=1 m=1
Q$422 \$749 vbe dvbe vss npn13G2 we=70n le=900n Nx=1 m=1
Q$423 \$749 vbe dvbe vss npn13G2 we=70n le=900n Nx=1 m=1
Q$424 \$749 vbe dvbe vss npn13G2 we=70n le=900n Nx=1 m=1
Q$425 \$749 vbe dvbe vss npn13G2 we=70n le=900n Nx=1 m=1
Q$426 \$749 vbe dvbe vss npn13G2 we=70n le=900n Nx=1 m=1
Q$427 \$749 vbe dvbe vss npn13G2 we=70n le=900n Nx=1 m=1
Q$428 \$749 vbe dvbe vss npn13G2 we=70n le=900n Nx=1 m=1
Q$429 \$749 vbe dvbe vss npn13G2 we=70n le=900n Nx=1 m=1
Q$430 \$749 vbe dvbe vss npn13G2 we=70n le=900n Nx=1 m=1
Q$431 \$749 vbe dvbe vss npn13G2 we=70n le=900n Nx=1 m=1
Q$432 \$749 vbe dvbe vss npn13G2 we=70n le=900n Nx=1 m=1
Q$433 \$749 vbe dvbe vss npn13G2 we=70n le=900n Nx=1 m=1
Q$434 \$749 vbe dvbe vss npn13G2 we=70n le=900n Nx=1 m=1
Q$435 \$749 vbe dvbe vss npn13G2 we=70n le=900n Nx=1 m=1
Q$436 \$749 vbe dvbe vss npn13G2 we=70n le=900n Nx=1 m=1
Q$437 \$749 vbe dvbe vss npn13G2 we=70n le=900n Nx=1 m=1
Q$438 \$749 vbe dvbe vss npn13G2 we=70n le=900n Nx=1 m=1
Q$439 \$749 vbe dvbe vss npn13G2 we=70n le=900n Nx=1 m=1
Q$440 \$749 vbe dvbe vss npn13G2 we=70n le=900n Nx=1 m=1
Q$441 \$749 vbe dvbe vss npn13G2 we=70n le=900n Nx=1 m=1
Q$442 \$749 vbe dvbe vss npn13G2 we=70n le=900n Nx=1 m=1
Q$443 \$749 vbe dvbe vss npn13G2 we=70n le=900n Nx=1 m=1
Q$444 \$749 vbe dvbe vss npn13G2 we=70n le=900n Nx=1 m=1
Q$445 \$749 vbe dvbe vss npn13G2 we=70n le=900n Nx=1 m=1
Q$446 \$749 vbe dvbe vss npn13G2 we=70n le=900n Nx=1 m=1
Q$447 \$749 vbe dvbe vss npn13G2 we=70n le=900n Nx=1 m=1
Q$448 \$749 vbe dvbe vss npn13G2 we=70n le=900n Nx=1 m=1
Q$449 \$749 vbe dvbe vss npn13G2 we=70n le=900n Nx=1 m=1
Q$450 \$749 vbe dvbe vss npn13G2 we=70n le=900n Nx=1 m=1
Q$451 \$749 vbe dvbe vss npn13G2 we=70n le=900n Nx=1 m=1
Q$452 \$749 vbe dvbe vss npn13G2 we=70n le=900n Nx=1 m=1
Q$453 \$749 vbe dvbe vss npn13G2 we=70n le=900n Nx=1 m=1
Q$454 \$749 vbe dvbe vss npn13G2 we=70n le=900n Nx=1 m=1
Q$455 \$749 vbe dvbe vss npn13G2 we=70n le=900n Nx=1 m=1
Q$456 \$749 vbe dvbe vss npn13G2 we=70n le=900n Nx=1 m=1
Q$457 \$239 \$239 \$440 vss npn13G2 we=70n le=900n Nx=1 m=1
Q$458 \$239 \$239 \$440 vss npn13G2 we=70n le=900n Nx=1 m=1
Q$459 \$239 \$239 \$440 vss npn13G2 we=70n le=900n Nx=1 m=1
Q$460 \$239 \$239 \$440 vss npn13G2 we=70n le=900n Nx=1 m=1
Q$461 \$239 \$239 \$440 vss npn13G2 we=70n le=900n Nx=1 m=1
Q$462 \$239 \$239 \$440 vss npn13G2 we=70n le=900n Nx=1 m=1
Q$463 \$239 \$239 \$440 vss npn13G2 we=70n le=900n Nx=1 m=1
Q$464 \$239 \$239 \$440 vss npn13G2 we=70n le=900n Nx=1 m=1
Q$465 \$239 \$239 \$440 vss npn13G2 we=70n le=900n Nx=1 m=1
Q$466 \$239 \$239 \$440 vss npn13G2 we=70n le=900n Nx=1 m=1
Q$467 \$239 \$239 \$440 vss npn13G2 we=70n le=900n Nx=1 m=1
Q$468 \$239 \$239 \$440 vss npn13G2 we=70n le=900n Nx=1 m=1
Q$469 \$749 vbe dvbe vss npn13G2 we=70n le=900n Nx=1 m=1
Q$470 \$749 vbe dvbe vss npn13G2 we=70n le=900n Nx=1 m=1
Q$471 \$749 vbe dvbe vss npn13G2 we=70n le=900n Nx=1 m=1
Q$472 \$749 vbe dvbe vss npn13G2 we=70n le=900n Nx=1 m=1
Q$473 \$749 vbe dvbe vss npn13G2 we=70n le=900n Nx=1 m=1
Q$474 \$749 vbe dvbe vss npn13G2 we=70n le=900n Nx=1 m=1
Q$475 \$749 vbe dvbe vss npn13G2 we=70n le=900n Nx=1 m=1
Q$476 \$749 vbe dvbe vss npn13G2 we=70n le=900n Nx=1 m=1
Q$477 \$749 vbe dvbe vss npn13G2 we=70n le=900n Nx=1 m=1
Q$478 \$749 vbe dvbe vss npn13G2 we=70n le=900n Nx=1 m=1
Q$479 \$749 vbe dvbe vss npn13G2 we=70n le=900n Nx=1 m=1
Q$480 \$749 vbe dvbe vss npn13G2 we=70n le=900n Nx=1 m=1
Q$481 \$237 \$237 vss vss npn13G2 we=70n le=900n Nx=1 m=1
Q$482 \$237 \$237 vss vss npn13G2 we=70n le=900n Nx=1 m=1
Q$492 \$237 \$237 vss vss npn13G2 we=70n le=900n Nx=1 m=1
Q$493 \$237 \$237 vss vss npn13G2 we=70n le=900n Nx=1 m=1
Q$494 \$749 vbe dvbe vss npn13G2 we=70n le=900n Nx=1 m=1
Q$495 \$749 vbe dvbe vss npn13G2 we=70n le=900n Nx=1 m=1
Q$496 \$749 vbe dvbe vss npn13G2 we=70n le=900n Nx=1 m=1
Q$497 \$749 vbe dvbe vss npn13G2 we=70n le=900n Nx=1 m=1
Q$498 \$749 vbe dvbe vss npn13G2 we=70n le=900n Nx=1 m=1
Q$499 \$749 vbe dvbe vss npn13G2 we=70n le=900n Nx=1 m=1
Q$500 \$749 vbe dvbe vss npn13G2 we=70n le=900n Nx=1 m=1
Q$501 \$749 vbe dvbe vss npn13G2 we=70n le=900n Nx=1 m=1
Q$502 \$749 vbe dvbe vss npn13G2 we=70n le=900n Nx=1 m=1
Q$503 \$749 vbe dvbe vss npn13G2 we=70n le=900n Nx=1 m=1
Q$504 \$749 vbe dvbe vss npn13G2 we=70n le=900n Nx=1 m=1
Q$505 \$749 vbe dvbe vss npn13G2 we=70n le=900n Nx=1 m=1
Q$506 \$239 \$239 \$440 vss npn13G2 we=70n le=900n Nx=1 m=1
Q$507 \$239 \$239 \$440 vss npn13G2 we=70n le=900n Nx=1 m=1
Q$508 \$239 \$239 \$440 vss npn13G2 we=70n le=900n Nx=1 m=1
Q$509 \$239 \$239 \$440 vss npn13G2 we=70n le=900n Nx=1 m=1
Q$510 \$239 \$239 \$440 vss npn13G2 we=70n le=900n Nx=1 m=1
Q$511 \$239 \$239 \$440 vss npn13G2 we=70n le=900n Nx=1 m=1
Q$512 \$239 \$239 \$440 vss npn13G2 we=70n le=900n Nx=1 m=1
Q$513 \$239 \$239 \$440 vss npn13G2 we=70n le=900n Nx=1 m=1
Q$514 \$239 \$239 \$440 vss npn13G2 we=70n le=900n Nx=1 m=1
Q$515 \$239 \$239 \$440 vss npn13G2 we=70n le=900n Nx=1 m=1
Q$516 \$239 \$239 \$440 vss npn13G2 we=70n le=900n Nx=1 m=1
Q$517 \$239 \$239 \$440 vss npn13G2 we=70n le=900n Nx=1 m=1
Q$518 \$749 vbe dvbe vss npn13G2 we=70n le=900n Nx=1 m=1
Q$519 \$749 vbe dvbe vss npn13G2 we=70n le=900n Nx=1 m=1
Q$520 \$749 vbe dvbe vss npn13G2 we=70n le=900n Nx=1 m=1
Q$521 \$749 vbe dvbe vss npn13G2 we=70n le=900n Nx=1 m=1
Q$522 \$749 vbe dvbe vss npn13G2 we=70n le=900n Nx=1 m=1
Q$523 \$749 vbe dvbe vss npn13G2 we=70n le=900n Nx=1 m=1
Q$524 \$749 vbe dvbe vss npn13G2 we=70n le=900n Nx=1 m=1
Q$525 \$749 vbe dvbe vss npn13G2 we=70n le=900n Nx=1 m=1
Q$526 \$749 vbe dvbe vss npn13G2 we=70n le=900n Nx=1 m=1
Q$527 \$749 vbe dvbe vss npn13G2 we=70n le=900n Nx=1 m=1
Q$528 \$749 vbe dvbe vss npn13G2 we=70n le=900n Nx=1 m=1
Q$529 \$749 vbe dvbe vss npn13G2 we=70n le=900n Nx=1 m=1
Q$530 \$749 vbe dvbe vss npn13G2 we=70n le=900n Nx=1 m=1
Q$531 \$749 vbe dvbe vss npn13G2 we=70n le=900n Nx=1 m=1
Q$532 \$749 vbe dvbe vss npn13G2 we=70n le=900n Nx=1 m=1
Q$533 \$749 vbe dvbe vss npn13G2 we=70n le=900n Nx=1 m=1
Q$534 \$749 vbe dvbe vss npn13G2 we=70n le=900n Nx=1 m=1
Q$535 \$749 vbe dvbe vss npn13G2 we=70n le=900n Nx=1 m=1
Q$536 \$749 vbe dvbe vss npn13G2 we=70n le=900n Nx=1 m=1
Q$537 \$749 vbe dvbe vss npn13G2 we=70n le=900n Nx=1 m=1
Q$538 \$749 vbe dvbe vss npn13G2 we=70n le=900n Nx=1 m=1
Q$539 \$749 vbe dvbe vss npn13G2 we=70n le=900n Nx=1 m=1
Q$540 \$749 vbe dvbe vss npn13G2 we=70n le=900n Nx=1 m=1
Q$541 \$749 vbe dvbe vss npn13G2 we=70n le=900n Nx=1 m=1
Q$542 \$749 vbe dvbe vss npn13G2 we=70n le=900n Nx=1 m=1
Q$543 \$749 vbe dvbe vss npn13G2 we=70n le=900n Nx=1 m=1
Q$544 \$749 vbe dvbe vss npn13G2 we=70n le=900n Nx=1 m=1
Q$545 \$749 vbe dvbe vss npn13G2 we=70n le=900n Nx=1 m=1
Q$546 \$749 vbe dvbe vss npn13G2 we=70n le=900n Nx=1 m=1
Q$547 \$749 vbe dvbe vss npn13G2 we=70n le=900n Nx=1 m=1
Q$548 \$749 vbe dvbe vss npn13G2 we=70n le=900n Nx=1 m=1
Q$549 \$749 vbe dvbe vss npn13G2 we=70n le=900n Nx=1 m=1
Q$550 \$749 vbe dvbe vss npn13G2 we=70n le=900n Nx=1 m=1
Q$551 \$749 vbe dvbe vss npn13G2 we=70n le=900n Nx=1 m=1
Q$552 \$749 vbe dvbe vss npn13G2 we=70n le=900n Nx=1 m=1
Q$553 \$749 vbe dvbe vss npn13G2 we=70n le=900n Nx=1 m=1
Q$554 \$749 vbe dvbe vss npn13G2 we=70n le=900n Nx=1 m=1
Q$555 \$749 vbe dvbe vss npn13G2 we=70n le=900n Nx=1 m=1
Q$556 \$749 vbe dvbe vss npn13G2 we=70n le=900n Nx=1 m=1
Q$557 \$749 vbe dvbe vss npn13G2 we=70n le=900n Nx=1 m=1
Q$558 \$749 vbe dvbe vss npn13G2 we=70n le=900n Nx=1 m=1
Q$559 \$749 vbe dvbe vss npn13G2 we=70n le=900n Nx=1 m=1
Q$560 \$749 vbe dvbe vss npn13G2 we=70n le=900n Nx=1 m=1
Q$561 \$749 vbe dvbe vss npn13G2 we=70n le=900n Nx=1 m=1
Q$562 \$749 vbe dvbe vss npn13G2 we=70n le=900n Nx=1 m=1
Q$563 \$749 vbe dvbe vss npn13G2 we=70n le=900n Nx=1 m=1
Q$564 \$749 vbe dvbe vss npn13G2 we=70n le=900n Nx=1 m=1
Q$565 \$749 vbe dvbe vss npn13G2 we=70n le=900n Nx=1 m=1
Q$566 \$749 vbe dvbe vss npn13G2 we=70n le=900n Nx=1 m=1
Q$567 \$749 vbe dvbe vss npn13G2 we=70n le=900n Nx=1 m=1
Q$568 \$749 vbe dvbe vss npn13G2 we=70n le=900n Nx=1 m=1
Q$569 \$749 vbe dvbe vss npn13G2 we=70n le=900n Nx=1 m=1
Q$570 \$749 vbe dvbe vss npn13G2 we=70n le=900n Nx=1 m=1
Q$571 \$749 vbe dvbe vss npn13G2 we=70n le=900n Nx=1 m=1
Q$572 \$749 vbe dvbe vss npn13G2 we=70n le=900n Nx=1 m=1
Q$573 \$749 vbe dvbe vss npn13G2 we=70n le=900n Nx=1 m=1
Q$574 \$749 vbe dvbe vss npn13G2 we=70n le=900n Nx=1 m=1
Q$575 \$749 vbe dvbe vss npn13G2 we=70n le=900n Nx=1 m=1
Q$576 \$749 vbe dvbe vss npn13G2 we=70n le=900n Nx=1 m=1
Q$577 \$749 vbe dvbe vss npn13G2 we=70n le=900n Nx=1 m=1
Q$578 \$749 vbe dvbe vss npn13G2 we=70n le=900n Nx=1 m=1
Q$579 \$749 vbe dvbe vss npn13G2 we=70n le=900n Nx=1 m=1
Q$580 \$749 vbe dvbe vss npn13G2 we=70n le=900n Nx=1 m=1
Q$581 \$749 vbe dvbe vss npn13G2 we=70n le=900n Nx=1 m=1
Q$582 \$749 vbe dvbe vss npn13G2 we=70n le=900n Nx=1 m=1
Q$583 \$749 vbe dvbe vss npn13G2 we=70n le=900n Nx=1 m=1
Q$584 \$749 vbe dvbe vss npn13G2 we=70n le=900n Nx=1 m=1
Q$585 \$749 vbe dvbe vss npn13G2 we=70n le=900n Nx=1 m=1
Q$586 \$749 vbe dvbe vss npn13G2 we=70n le=900n Nx=1 m=1
Q$587 \$749 vbe dvbe vss npn13G2 we=70n le=900n Nx=1 m=1
Q$588 \$749 vbe dvbe vss npn13G2 we=70n le=900n Nx=1 m=1
Q$589 \$749 vbe dvbe vss npn13G2 we=70n le=900n Nx=1 m=1
Q$590 \$749 vbe dvbe vss npn13G2 we=70n le=900n Nx=1 m=1
Q$591 \$749 vbe dvbe vss npn13G2 we=70n le=900n Nx=1 m=1
Q$592 \$749 vbe dvbe vss npn13G2 we=70n le=900n Nx=1 m=1
Q$593 \$749 vbe dvbe vss npn13G2 we=70n le=900n Nx=1 m=1
Q$594 \$749 vbe dvbe vss npn13G2 we=70n le=900n Nx=1 m=1
Q$595 \$749 vbe dvbe vss npn13G2 we=70n le=900n Nx=1 m=1
Q$596 \$749 vbe dvbe vss npn13G2 we=70n le=900n Nx=1 m=1
Q$597 \$749 vbe dvbe vss npn13G2 we=70n le=900n Nx=1 m=1
Q$598 \$749 vbe dvbe vss npn13G2 we=70n le=900n Nx=1 m=1
Q$599 \$749 vbe dvbe vss npn13G2 we=70n le=900n Nx=1 m=1
Q$600 \$749 vbe dvbe vss npn13G2 we=70n le=900n Nx=1 m=1
Q$601 \$749 vbe dvbe vss npn13G2 we=70n le=900n Nx=1 m=1
Q$602 vbe \$569 vss vss npn13G2 we=70n le=900n Nx=1 m=1
Q$603 vbe \$569 vss vss npn13G2 we=70n le=900n Nx=1 m=1
Q$604 vbe \$569 vss vss npn13G2 we=70n le=900n Nx=1 m=1
Q$605 vbe \$569 vss vss npn13G2 we=70n le=900n Nx=1 m=1
Q$606 vbe \$569 vss vss npn13G2 we=70n le=900n Nx=1 m=1
Q$607 vbe \$569 vss vss npn13G2 we=70n le=900n Nx=1 m=1
Q$608 vbe \$569 vss vss npn13G2 we=70n le=900n Nx=1 m=1
Q$609 vbe \$569 vss vss npn13G2 we=70n le=900n Nx=1 m=1
Q$610 vbe \$569 vss vss npn13G2 we=70n le=900n Nx=1 m=1
Q$611 vbe \$569 vss vss npn13G2 we=70n le=900n Nx=1 m=1
Q$612 vbe \$569 vss vss npn13G2 we=70n le=900n Nx=1 m=1
Q$613 vbe \$569 vss vss npn13G2 we=70n le=900n Nx=1 m=1
Q$614 \$440 \$440 vss vss npn13G2 we=70n le=900n Nx=1 m=1
Q$615 \$440 \$440 vss vss npn13G2 we=70n le=900n Nx=1 m=1
Q$616 \$440 \$440 vss vss npn13G2 we=70n le=900n Nx=1 m=1
Q$617 \$440 \$440 vss vss npn13G2 we=70n le=900n Nx=1 m=1
Q$618 \$440 \$440 vss vss npn13G2 we=70n le=900n Nx=1 m=1
Q$619 \$440 \$440 vss vss npn13G2 we=70n le=900n Nx=1 m=1
Q$620 \$440 \$440 vss vss npn13G2 we=70n le=900n Nx=1 m=1
Q$621 \$440 \$440 vss vss npn13G2 we=70n le=900n Nx=1 m=1
Q$622 \$440 \$440 vss vss npn13G2 we=70n le=900n Nx=1 m=1
Q$623 \$440 \$440 vss vss npn13G2 we=70n le=900n Nx=1 m=1
Q$624 \$440 \$440 vss vss npn13G2 we=70n le=900n Nx=1 m=1
Q$625 \$440 \$440 vss vss npn13G2 we=70n le=900n Nx=1 m=1
Q$626 vbe vbe vss vss npn13G2 we=70n le=900n Nx=1 m=1
Q$627 vbe vbe vss vss npn13G2 we=70n le=900n Nx=1 m=1
Q$628 vbe vbe vss vss npn13G2 we=70n le=900n Nx=1 m=1
Q$629 vbe vbe vss vss npn13G2 we=70n le=900n Nx=1 m=1
Q$630 vbe vbe vss vss npn13G2 we=70n le=900n Nx=1 m=1
Q$631 vbe vbe vss vss npn13G2 we=70n le=900n Nx=1 m=1
Q$632 vbe vbe vss vss npn13G2 we=70n le=900n Nx=1 m=1
Q$633 vbe vbe vss vss npn13G2 we=70n le=900n Nx=1 m=1
Q$634 vbe vbe vss vss npn13G2 we=70n le=900n Nx=1 m=1
Q$635 vbe vbe vss vss npn13G2 we=70n le=900n Nx=1 m=1
Q$636 vbe vbe vss vss npn13G2 we=70n le=900n Nx=1 m=1
Q$637 vbe vbe vss vss npn13G2 we=70n le=900n Nx=1 m=1
R$638 \$234 vref vss rppd w=1u l=53.465u ps=0u b=0 m=1
R$639 \$234 vref vss rppd w=1u l=53.465u ps=0u b=0 m=1
R$640 \$19 \$229 vss rppd w=1u l=53.465u ps=0u b=0 m=1
R$641 \$19 \$229 vss rppd w=1u l=53.465u ps=0u b=0 m=1
R$642 \$234 \$229 vss rppd w=1u l=53.465u ps=0u b=0 m=1
R$643 \$234 \$229 vss rppd w=1u l=53.465u ps=0u b=0 m=1
R$644 \$19 \$228 vss rppd w=1u l=53.465u ps=0u b=0 m=1
R$645 \$19 \$228 vss rppd w=1u l=53.465u ps=0u b=0 m=1
R$646 \$233 \$228 vss rppd w=1u l=53.465u ps=0u b=0 m=1
R$647 \$233 \$228 vss rppd w=1u l=53.465u ps=0u b=0 m=1
R$648 \$233 \$237 vss rppd w=1u l=53.465u ps=0u b=0 m=1
R$649 \$233 \$237 vss rppd w=1u l=53.465u ps=0u b=0 m=1
R$650 vss dvbe vss rppd w=1u l=51.5u ps=0u b=0 m=1
R$651 vss dvbe vss rppd w=1u l=51.5u ps=0u b=0 m=1
R$652 vss dvbe vss rppd w=1u l=51.5u ps=0u b=0 m=1
R$653 vss dvbe vss rppd w=1u l=51.5u ps=0u b=0 m=1
R$654 vss dvbe vss rppd w=1u l=51.5u ps=0u b=0 m=1
R$655 vss dvbe vss rppd w=1u l=51.5u ps=0u b=0 m=1
R$656 vss dvbe vss rppd w=1u l=51.5u ps=0u b=0 m=1
R$657 vss dvbe vss rppd w=1u l=51.5u ps=0u b=0 m=1
R$658 vss dvbe vss rppd w=1u l=51.5u ps=0u b=0 m=1
R$659 vss dvbe vss rppd w=1u l=51.5u ps=0u b=0 m=1
R$660 vss dvbe vss rppd w=1u l=51.5u ps=0u b=0 m=1
R$661 vss dvbe vss rppd w=1u l=51.5u ps=0u b=0 m=1
R$662 \$230 pbias vss rppd w=1u l=50u ps=0u b=0 m=1
R$663 \$230 pbias vss rppd w=1u l=50u ps=0u b=0 m=1
R$664 \$230 pbias vss rppd w=1u l=50u ps=0u b=0 m=1
R$665 \$230 pbias vss rppd w=1u l=50u ps=0u b=0 m=1
R$666 \$230 pbias vss rppd w=1u l=50u ps=0u b=0 m=1
R$667 \$230 pbias vss rppd w=1u l=50u ps=0u b=0 m=1
R$668 \$230 pbias vss rppd w=1u l=50u ps=0u b=0 m=1
R$669 \$230 pbias vss rppd w=1u l=50u ps=0u b=0 m=1
R$670 \$230 pbias vss rppd w=1u l=50u ps=0u b=0 m=1
R$671 \$230 pbias vss rppd w=1u l=50u ps=0u b=0 m=1
R$672 \$230 pbias vss rppd w=1u l=50u ps=0u b=0 m=1
R$673 \$230 pbias vss rppd w=1u l=50u ps=0u b=0 m=1
R$674 \$10 \$232 vss rppd w=1u l=50u ps=0u b=0 m=1
R$675 \$10 \$232 vss rppd w=1u l=50u ps=0u b=0 m=1
R$676 \$10 \$232 vss rppd w=1u l=50u ps=0u b=0 m=1
R$677 \$10 \$232 vss rppd w=1u l=50u ps=0u b=0 m=1
R$678 \$10 \$232 vss rppd w=1u l=50u ps=0u b=0 m=1
R$679 \$10 \$232 vss rppd w=1u l=50u ps=0u b=0 m=1
R$680 \$10 \$232 vss rppd w=1u l=50u ps=0u b=0 m=1
R$681 \$10 \$232 vss rppd w=1u l=50u ps=0u b=0 m=1
R$682 \$10 \$232 vss rppd w=1u l=50u ps=0u b=0 m=1
R$683 \$10 \$232 vss rppd w=1u l=50u ps=0u b=0 m=1
R$684 \$10 \$232 vss rppd w=1u l=50u ps=0u b=0 m=1
R$685 \$10 \$232 vss rppd w=1u l=50u ps=0u b=0 m=1
R$686 \$11 \$232 vss rppd w=1u l=50u ps=0u b=0 m=1
R$687 \$11 \$232 vss rppd w=1u l=50u ps=0u b=0 m=1
R$688 \$11 \$232 vss rppd w=1u l=50u ps=0u b=0 m=1
R$689 \$11 \$232 vss rppd w=1u l=50u ps=0u b=0 m=1
R$690 \$11 \$232 vss rppd w=1u l=50u ps=0u b=0 m=1
R$691 \$11 \$232 vss rppd w=1u l=50u ps=0u b=0 m=1
R$692 \$11 \$232 vss rppd w=1u l=50u ps=0u b=0 m=1
R$693 \$11 \$232 vss rppd w=1u l=50u ps=0u b=0 m=1
R$694 \$11 \$232 vss rppd w=1u l=50u ps=0u b=0 m=1
R$695 \$11 \$232 vss rppd w=1u l=50u ps=0u b=0 m=1
R$696 \$11 \$232 vss rppd w=1u l=50u ps=0u b=0 m=1
R$697 \$11 \$232 vss rppd w=1u l=50u ps=0u b=0 m=1
R$698 \$24 \$227 vss rppd w=1u l=50u ps=0u b=0 m=1
R$699 \$24 \$227 vss rppd w=1u l=50u ps=0u b=0 m=1
R$700 \$24 \$227 vss rppd w=1u l=50u ps=0u b=0 m=1
R$701 \$24 \$227 vss rppd w=1u l=50u ps=0u b=0 m=1
R$702 \$24 \$227 vss rppd w=1u l=50u ps=0u b=0 m=1
R$703 \$24 \$227 vss rppd w=1u l=50u ps=0u b=0 m=1
R$704 \$24 \$227 vss rppd w=1u l=50u ps=0u b=0 m=1
R$705 \$24 \$227 vss rppd w=1u l=50u ps=0u b=0 m=1
R$706 \$24 \$227 vss rppd w=1u l=50u ps=0u b=0 m=1
R$707 \$24 \$227 vss rppd w=1u l=50u ps=0u b=0 m=1
R$708 \$24 \$227 vss rppd w=1u l=50u ps=0u b=0 m=1
R$709 \$24 \$227 vss rppd w=1u l=50u ps=0u b=0 m=1
R$710 \$11 \$225 vss rppd w=1u l=50u ps=0u b=0 m=1
R$711 \$11 \$225 vss rppd w=1u l=50u ps=0u b=0 m=1
R$712 \$11 \$225 vss rppd w=1u l=50u ps=0u b=0 m=1
R$713 \$11 \$225 vss rppd w=1u l=50u ps=0u b=0 m=1
R$714 \$11 \$225 vss rppd w=1u l=50u ps=0u b=0 m=1
R$715 \$11 \$225 vss rppd w=1u l=50u ps=0u b=0 m=1
R$716 \$11 \$225 vss rppd w=1u l=50u ps=0u b=0 m=1
R$717 \$11 \$225 vss rppd w=1u l=50u ps=0u b=0 m=1
R$718 \$11 \$225 vss rppd w=1u l=50u ps=0u b=0 m=1
R$719 \$11 \$225 vss rppd w=1u l=50u ps=0u b=0 m=1
R$720 \$11 \$225 vss rppd w=1u l=50u ps=0u b=0 m=1
R$721 \$11 \$225 vss rppd w=1u l=50u ps=0u b=0 m=1
R$722 \$231 \$227 vss rppd w=1u l=50u ps=0u b=0 m=1
R$723 \$231 \$227 vss rppd w=1u l=50u ps=0u b=0 m=1
R$724 \$231 \$227 vss rppd w=1u l=50u ps=0u b=0 m=1
R$725 \$231 \$227 vss rppd w=1u l=50u ps=0u b=0 m=1
R$726 \$231 \$227 vss rppd w=1u l=50u ps=0u b=0 m=1
R$727 \$231 \$227 vss rppd w=1u l=50u ps=0u b=0 m=1
R$728 \$231 \$227 vss rppd w=1u l=50u ps=0u b=0 m=1
R$729 \$231 \$227 vss rppd w=1u l=50u ps=0u b=0 m=1
R$730 \$231 \$227 vss rppd w=1u l=50u ps=0u b=0 m=1
R$731 \$231 \$227 vss rppd w=1u l=50u ps=0u b=0 m=1
R$732 \$231 \$227 vss rppd w=1u l=50u ps=0u b=0 m=1
R$733 \$231 \$227 vss rppd w=1u l=50u ps=0u b=0 m=1
R$734 \$231 \$226 vss rppd w=1u l=50u ps=0u b=0 m=1
R$735 \$231 \$226 vss rppd w=1u l=50u ps=0u b=0 m=1
R$736 \$231 \$226 vss rppd w=1u l=50u ps=0u b=0 m=1
R$737 \$231 \$226 vss rppd w=1u l=50u ps=0u b=0 m=1
R$738 \$231 \$226 vss rppd w=1u l=50u ps=0u b=0 m=1
R$739 \$231 \$226 vss rppd w=1u l=50u ps=0u b=0 m=1
R$740 \$231 \$226 vss rppd w=1u l=50u ps=0u b=0 m=1
R$741 \$231 \$226 vss rppd w=1u l=50u ps=0u b=0 m=1
R$742 \$231 \$226 vss rppd w=1u l=50u ps=0u b=0 m=1
R$743 \$231 \$226 vss rppd w=1u l=50u ps=0u b=0 m=1
R$744 \$231 \$226 vss rppd w=1u l=50u ps=0u b=0 m=1
R$745 \$231 \$226 vss rppd w=1u l=50u ps=0u b=0 m=1
R$746 \$230 \$226 vss rppd w=1u l=50u ps=0u b=0 m=1
R$747 \$230 \$226 vss rppd w=1u l=50u ps=0u b=0 m=1
R$748 \$230 \$226 vss rppd w=1u l=50u ps=0u b=0 m=1
R$749 \$230 \$226 vss rppd w=1u l=50u ps=0u b=0 m=1
R$750 \$230 \$226 vss rppd w=1u l=50u ps=0u b=0 m=1
R$751 \$230 \$226 vss rppd w=1u l=50u ps=0u b=0 m=1
R$752 \$230 \$226 vss rppd w=1u l=50u ps=0u b=0 m=1
R$753 \$230 \$226 vss rppd w=1u l=50u ps=0u b=0 m=1
R$754 \$230 \$226 vss rppd w=1u l=50u ps=0u b=0 m=1
R$755 \$230 \$226 vss rppd w=1u l=50u ps=0u b=0 m=1
R$756 \$230 \$226 vss rppd w=1u l=50u ps=0u b=0 m=1
R$757 \$230 \$226 vss rppd w=1u l=50u ps=0u b=0 m=1
R$758 \$24 \$225 vss rppd w=1u l=50u ps=0u b=0 m=1
R$759 \$24 \$225 vss rppd w=1u l=50u ps=0u b=0 m=1
R$760 \$24 \$225 vss rppd w=1u l=50u ps=0u b=0 m=1
R$761 \$24 \$225 vss rppd w=1u l=50u ps=0u b=0 m=1
R$762 \$24 \$225 vss rppd w=1u l=50u ps=0u b=0 m=1
R$763 \$24 \$225 vss rppd w=1u l=50u ps=0u b=0 m=1
R$764 \$24 \$225 vss rppd w=1u l=50u ps=0u b=0 m=1
R$765 \$24 \$225 vss rppd w=1u l=50u ps=0u b=0 m=1
R$766 \$24 \$225 vss rppd w=1u l=50u ps=0u b=0 m=1
R$767 \$24 \$225 vss rppd w=1u l=50u ps=0u b=0 m=1
R$768 \$24 \$225 vss rppd w=1u l=50u ps=0u b=0 m=1
R$769 \$24 \$225 vss rppd w=1u l=50u ps=0u b=0 m=1
R$770 \$10 pcasc vss rppd w=1u l=50u ps=0u b=0 m=1
R$771 \$10 pcasc vss rppd w=1u l=50u ps=0u b=0 m=1
R$772 \$10 pcasc vss rppd w=1u l=50u ps=0u b=0 m=1
R$773 \$10 pcasc vss rppd w=1u l=50u ps=0u b=0 m=1
R$774 \$10 pcasc vss rppd w=1u l=50u ps=0u b=0 m=1
R$775 \$10 pcasc vss rppd w=1u l=50u ps=0u b=0 m=1
R$776 \$10 pcasc vss rppd w=1u l=50u ps=0u b=0 m=1
R$777 \$10 pcasc vss rppd w=1u l=50u ps=0u b=0 m=1
R$778 \$10 pcasc vss rppd w=1u l=50u ps=0u b=0 m=1
R$779 \$10 pcasc vss rppd w=1u l=50u ps=0u b=0 m=1
R$780 \$10 pcasc vss rppd w=1u l=50u ps=0u b=0 m=1
R$781 \$10 pcasc vss rppd w=1u l=50u ps=0u b=0 m=1
R$782 \$233 \$237 vss rppd w=1u l=53.465u ps=0u b=0 m=1
R$783 \$233 \$237 vss rppd w=1u l=53.465u ps=0u b=0 m=1
R$784 \$233 \$228 vss rppd w=1u l=53.465u ps=0u b=0 m=1
R$785 \$233 \$228 vss rppd w=1u l=53.465u ps=0u b=0 m=1
R$786 \$2 \$444 vss rppd w=1u l=48u ps=0u b=0 m=1
R$787 \$19 \$228 vss rppd w=1u l=53.465u ps=0u b=0 m=1
R$788 \$19 \$228 vss rppd w=1u l=53.465u ps=0u b=0 m=1
R$789 \$2 \$444 vss rppd w=1u l=48u ps=0u b=0 m=1
R$790 \$2 \$444 vss rppd w=1u l=48u ps=0u b=0 m=1
R$791 \$234 \$229 vss rppd w=1u l=53.465u ps=0u b=0 m=1
R$792 \$234 \$229 vss rppd w=1u l=53.465u ps=0u b=0 m=1
R$793 \$2 \$444 vss rppd w=1u l=48u ps=0u b=0 m=1
R$794 \$2 \$444 vss rppd w=1u l=48u ps=0u b=0 m=1
R$795 \$19 \$229 vss rppd w=1u l=53.465u ps=0u b=0 m=1
R$796 \$2 \$444 vss rppd w=1u l=48u ps=0u b=0 m=1
R$797 \$19 \$229 vss rppd w=1u l=53.465u ps=0u b=0 m=1
R$798 \$2 \$444 vss rppd w=1u l=48u ps=0u b=0 m=1
R$799 \$234 vref vss rppd w=1u l=53.465u ps=0u b=0 m=1
R$800 \$2 \$444 vss rppd w=1u l=48u ps=0u b=0 m=1
R$801 \$234 vref vss rppd w=1u l=53.465u ps=0u b=0 m=1
R$802 \$2 \$444 vss rppd w=1u l=48u ps=0u b=0 m=1
R$803 \$2 \$444 vss rppd w=1u l=48u ps=0u b=0 m=1
R$804 \$2 \$444 vss rppd w=1u l=48u ps=0u b=0 m=1
R$805 \$2 \$444 vss rppd w=1u l=48u ps=0u b=0 m=1
R$806 \$3 \$239 vss rppd w=1u l=48u ps=0u b=0 m=1
R$807 \$3 \$239 vss rppd w=1u l=48u ps=0u b=0 m=1
R$808 \$3 \$239 vss rppd w=1u l=48u ps=0u b=0 m=1
R$809 \$3 \$239 vss rppd w=1u l=48u ps=0u b=0 m=1
R$810 \$3 \$239 vss rppd w=1u l=48u ps=0u b=0 m=1
R$811 \$3 \$239 vss rppd w=1u l=48u ps=0u b=0 m=1
R$812 \$3 \$239 vss rppd w=1u l=48u ps=0u b=0 m=1
R$813 \$3 \$239 vss rppd w=1u l=48u ps=0u b=0 m=1
R$814 \$3 \$239 vss rppd w=1u l=48u ps=0u b=0 m=1
R$815 \$3 \$239 vss rppd w=1u l=48u ps=0u b=0 m=1
R$816 \$3 \$239 vss rppd w=1u l=48u ps=0u b=0 m=1
R$817 \$3 \$239 vss rppd w=1u l=48u ps=0u b=0 m=1
R$818 \$2 \$20 vss rppd w=1u l=48u ps=0u b=0 m=1
R$819 \$2 \$20 vss rppd w=1u l=48u ps=0u b=0 m=1
R$820 \$2 \$20 vss rppd w=1u l=48u ps=0u b=0 m=1
R$821 \$2 \$20 vss rppd w=1u l=48u ps=0u b=0 m=1
R$822 \$2 \$20 vss rppd w=1u l=48u ps=0u b=0 m=1
R$823 \$2 \$20 vss rppd w=1u l=48u ps=0u b=0 m=1
R$824 \$2 \$20 vss rppd w=1u l=48u ps=0u b=0 m=1
R$825 \$2 \$20 vss rppd w=1u l=48u ps=0u b=0 m=1
R$826 \$2 \$20 vss rppd w=1u l=48u ps=0u b=0 m=1
R$827 \$2 \$20 vss rppd w=1u l=48u ps=0u b=0 m=1
R$828 \$2 \$20 vss rppd w=1u l=48u ps=0u b=0 m=1
R$829 \$2 \$20 vss rppd w=1u l=48u ps=0u b=0 m=1
R$830 \$3 \$20 vss rppd w=1u l=48u ps=0u b=0 m=1
R$831 \$3 \$20 vss rppd w=1u l=48u ps=0u b=0 m=1
R$832 \$3 \$20 vss rppd w=1u l=48u ps=0u b=0 m=1
R$833 \$3 \$20 vss rppd w=1u l=48u ps=0u b=0 m=1
R$834 \$3 \$20 vss rppd w=1u l=48u ps=0u b=0 m=1
R$835 \$3 \$20 vss rppd w=1u l=48u ps=0u b=0 m=1
R$836 \$3 \$20 vss rppd w=1u l=48u ps=0u b=0 m=1
R$837 \$3 \$20 vss rppd w=1u l=48u ps=0u b=0 m=1
R$838 \$3 \$20 vss rppd w=1u l=48u ps=0u b=0 m=1
R$839 \$3 \$20 vss rppd w=1u l=48u ps=0u b=0 m=1
R$840 \$3 \$20 vss rppd w=1u l=48u ps=0u b=0 m=1
R$841 \$3 \$20 vss rppd w=1u l=48u ps=0u b=0 m=1
R$842 vss dvbe vss rppd w=1u l=51.5u ps=0u b=0 m=1
R$843 vss dvbe vss rppd w=1u l=51.5u ps=0u b=0 m=1
R$844 vss dvbe vss rppd w=1u l=51.5u ps=0u b=0 m=1
R$845 vss dvbe vss rppd w=1u l=51.5u ps=0u b=0 m=1
R$846 vss dvbe vss rppd w=1u l=51.5u ps=0u b=0 m=1
R$847 vss dvbe vss rppd w=1u l=51.5u ps=0u b=0 m=1
R$848 vss dvbe vss rppd w=1u l=51.5u ps=0u b=0 m=1
R$849 vss dvbe vss rppd w=1u l=51.5u ps=0u b=0 m=1
R$850 vss dvbe vss rppd w=1u l=51.5u ps=0u b=0 m=1
R$851 vss dvbe vss rppd w=1u l=51.5u ps=0u b=0 m=1
R$852 vss dvbe vss rppd w=1u l=51.5u ps=0u b=0 m=1
R$853 vss dvbe vss rppd w=1u l=51.5u ps=0u b=0 m=1
R$854 \$10 pcasc vss rppd w=1u l=50u ps=0u b=0 m=1
R$855 \$10 pcasc vss rppd w=1u l=50u ps=0u b=0 m=1
R$856 \$10 pcasc vss rppd w=1u l=50u ps=0u b=0 m=1
R$857 \$10 pcasc vss rppd w=1u l=50u ps=0u b=0 m=1
R$858 \$10 pcasc vss rppd w=1u l=50u ps=0u b=0 m=1
R$859 \$10 pcasc vss rppd w=1u l=50u ps=0u b=0 m=1
R$860 \$10 pcasc vss rppd w=1u l=50u ps=0u b=0 m=1
R$861 \$10 pcasc vss rppd w=1u l=50u ps=0u b=0 m=1
R$862 \$10 pcasc vss rppd w=1u l=50u ps=0u b=0 m=1
R$863 \$10 pcasc vss rppd w=1u l=50u ps=0u b=0 m=1
R$864 \$10 pcasc vss rppd w=1u l=50u ps=0u b=0 m=1
R$865 \$10 pcasc vss rppd w=1u l=50u ps=0u b=0 m=1
R$866 \$24 \$225 vss rppd w=1u l=50u ps=0u b=0 m=1
R$867 \$24 \$225 vss rppd w=1u l=50u ps=0u b=0 m=1
R$868 \$24 \$225 vss rppd w=1u l=50u ps=0u b=0 m=1
R$869 \$24 \$225 vss rppd w=1u l=50u ps=0u b=0 m=1
R$870 \$24 \$225 vss rppd w=1u l=50u ps=0u b=0 m=1
R$871 \$24 \$225 vss rppd w=1u l=50u ps=0u b=0 m=1
R$872 \$24 \$225 vss rppd w=1u l=50u ps=0u b=0 m=1
R$873 \$24 \$225 vss rppd w=1u l=50u ps=0u b=0 m=1
R$874 \$24 \$225 vss rppd w=1u l=50u ps=0u b=0 m=1
R$875 \$24 \$225 vss rppd w=1u l=50u ps=0u b=0 m=1
R$876 \$24 \$225 vss rppd w=1u l=50u ps=0u b=0 m=1
R$877 \$24 \$225 vss rppd w=1u l=50u ps=0u b=0 m=1
R$878 \$230 \$226 vss rppd w=1u l=50u ps=0u b=0 m=1
R$879 \$230 \$226 vss rppd w=1u l=50u ps=0u b=0 m=1
R$880 \$230 \$226 vss rppd w=1u l=50u ps=0u b=0 m=1
R$881 \$230 \$226 vss rppd w=1u l=50u ps=0u b=0 m=1
R$882 \$230 \$226 vss rppd w=1u l=50u ps=0u b=0 m=1
R$883 \$230 \$226 vss rppd w=1u l=50u ps=0u b=0 m=1
R$884 \$230 \$226 vss rppd w=1u l=50u ps=0u b=0 m=1
R$885 \$230 \$226 vss rppd w=1u l=50u ps=0u b=0 m=1
R$886 \$230 \$226 vss rppd w=1u l=50u ps=0u b=0 m=1
R$887 \$230 \$226 vss rppd w=1u l=50u ps=0u b=0 m=1
R$888 \$230 \$226 vss rppd w=1u l=50u ps=0u b=0 m=1
R$889 \$230 \$226 vss rppd w=1u l=50u ps=0u b=0 m=1
R$890 \$231 \$226 vss rppd w=1u l=50u ps=0u b=0 m=1
R$891 \$231 \$226 vss rppd w=1u l=50u ps=0u b=0 m=1
R$892 \$231 \$226 vss rppd w=1u l=50u ps=0u b=0 m=1
R$893 \$231 \$226 vss rppd w=1u l=50u ps=0u b=0 m=1
R$894 \$231 \$226 vss rppd w=1u l=50u ps=0u b=0 m=1
R$895 \$231 \$226 vss rppd w=1u l=50u ps=0u b=0 m=1
R$896 \$231 \$226 vss rppd w=1u l=50u ps=0u b=0 m=1
R$897 \$231 \$226 vss rppd w=1u l=50u ps=0u b=0 m=1
R$898 \$231 \$226 vss rppd w=1u l=50u ps=0u b=0 m=1
R$899 \$231 \$226 vss rppd w=1u l=50u ps=0u b=0 m=1
R$900 \$231 \$226 vss rppd w=1u l=50u ps=0u b=0 m=1
R$901 \$231 \$226 vss rppd w=1u l=50u ps=0u b=0 m=1
R$902 \$231 \$227 vss rppd w=1u l=50u ps=0u b=0 m=1
R$903 \$231 \$227 vss rppd w=1u l=50u ps=0u b=0 m=1
R$904 \$231 \$227 vss rppd w=1u l=50u ps=0u b=0 m=1
R$905 \$231 \$227 vss rppd w=1u l=50u ps=0u b=0 m=1
R$906 \$231 \$227 vss rppd w=1u l=50u ps=0u b=0 m=1
R$907 \$231 \$227 vss rppd w=1u l=50u ps=0u b=0 m=1
R$908 \$231 \$227 vss rppd w=1u l=50u ps=0u b=0 m=1
R$909 \$231 \$227 vss rppd w=1u l=50u ps=0u b=0 m=1
R$910 \$231 \$227 vss rppd w=1u l=50u ps=0u b=0 m=1
R$911 \$231 \$227 vss rppd w=1u l=50u ps=0u b=0 m=1
R$912 \$231 \$227 vss rppd w=1u l=50u ps=0u b=0 m=1
R$913 \$231 \$227 vss rppd w=1u l=50u ps=0u b=0 m=1
R$914 \$11 \$225 vss rppd w=1u l=50u ps=0u b=0 m=1
R$915 \$11 \$225 vss rppd w=1u l=50u ps=0u b=0 m=1
R$916 \$11 \$225 vss rppd w=1u l=50u ps=0u b=0 m=1
R$917 \$11 \$225 vss rppd w=1u l=50u ps=0u b=0 m=1
R$918 \$11 \$225 vss rppd w=1u l=50u ps=0u b=0 m=1
R$919 \$11 \$225 vss rppd w=1u l=50u ps=0u b=0 m=1
R$920 \$11 \$225 vss rppd w=1u l=50u ps=0u b=0 m=1
R$921 \$11 \$225 vss rppd w=1u l=50u ps=0u b=0 m=1
R$922 \$11 \$225 vss rppd w=1u l=50u ps=0u b=0 m=1
R$923 \$11 \$225 vss rppd w=1u l=50u ps=0u b=0 m=1
R$924 \$11 \$225 vss rppd w=1u l=50u ps=0u b=0 m=1
R$925 \$11 \$225 vss rppd w=1u l=50u ps=0u b=0 m=1
R$926 \$24 \$227 vss rppd w=1u l=50u ps=0u b=0 m=1
R$927 \$24 \$227 vss rppd w=1u l=50u ps=0u b=0 m=1
R$928 \$24 \$227 vss rppd w=1u l=50u ps=0u b=0 m=1
R$929 \$24 \$227 vss rppd w=1u l=50u ps=0u b=0 m=1
R$930 \$24 \$227 vss rppd w=1u l=50u ps=0u b=0 m=1
R$931 \$24 \$227 vss rppd w=1u l=50u ps=0u b=0 m=1
R$932 \$24 \$227 vss rppd w=1u l=50u ps=0u b=0 m=1
R$933 \$24 \$227 vss rppd w=1u l=50u ps=0u b=0 m=1
R$934 \$24 \$227 vss rppd w=1u l=50u ps=0u b=0 m=1
R$935 \$24 \$227 vss rppd w=1u l=50u ps=0u b=0 m=1
R$936 \$24 \$227 vss rppd w=1u l=50u ps=0u b=0 m=1
R$937 \$24 \$227 vss rppd w=1u l=50u ps=0u b=0 m=1
R$938 \$11 \$232 vss rppd w=1u l=50u ps=0u b=0 m=1
R$939 \$11 \$232 vss rppd w=1u l=50u ps=0u b=0 m=1
R$940 \$11 \$232 vss rppd w=1u l=50u ps=0u b=0 m=1
R$941 \$11 \$232 vss rppd w=1u l=50u ps=0u b=0 m=1
R$942 \$11 \$232 vss rppd w=1u l=50u ps=0u b=0 m=1
R$943 \$11 \$232 vss rppd w=1u l=50u ps=0u b=0 m=1
R$944 \$11 \$232 vss rppd w=1u l=50u ps=0u b=0 m=1
R$945 \$11 \$232 vss rppd w=1u l=50u ps=0u b=0 m=1
R$946 \$11 \$232 vss rppd w=1u l=50u ps=0u b=0 m=1
R$947 \$11 \$232 vss rppd w=1u l=50u ps=0u b=0 m=1
R$948 \$11 \$232 vss rppd w=1u l=50u ps=0u b=0 m=1
R$949 \$11 \$232 vss rppd w=1u l=50u ps=0u b=0 m=1
R$950 \$10 \$232 vss rppd w=1u l=50u ps=0u b=0 m=1
R$951 \$10 \$232 vss rppd w=1u l=50u ps=0u b=0 m=1
R$952 \$10 \$232 vss rppd w=1u l=50u ps=0u b=0 m=1
R$953 \$10 \$232 vss rppd w=1u l=50u ps=0u b=0 m=1
R$954 \$10 \$232 vss rppd w=1u l=50u ps=0u b=0 m=1
R$955 \$10 \$232 vss rppd w=1u l=50u ps=0u b=0 m=1
R$956 \$10 \$232 vss rppd w=1u l=50u ps=0u b=0 m=1
R$957 \$10 \$232 vss rppd w=1u l=50u ps=0u b=0 m=1
R$958 \$10 \$232 vss rppd w=1u l=50u ps=0u b=0 m=1
R$959 \$10 \$232 vss rppd w=1u l=50u ps=0u b=0 m=1
R$960 \$10 \$232 vss rppd w=1u l=50u ps=0u b=0 m=1
R$961 \$10 \$232 vss rppd w=1u l=50u ps=0u b=0 m=1
R$962 \$230 pbias vss rppd w=1u l=50u ps=0u b=0 m=1
R$963 \$230 pbias vss rppd w=1u l=50u ps=0u b=0 m=1
R$964 \$230 pbias vss rppd w=1u l=50u ps=0u b=0 m=1
R$965 \$230 pbias vss rppd w=1u l=50u ps=0u b=0 m=1
R$966 \$230 pbias vss rppd w=1u l=50u ps=0u b=0 m=1
R$967 \$230 pbias vss rppd w=1u l=50u ps=0u b=0 m=1
R$968 \$230 pbias vss rppd w=1u l=50u ps=0u b=0 m=1
R$969 \$230 pbias vss rppd w=1u l=50u ps=0u b=0 m=1
R$970 \$230 pbias vss rppd w=1u l=50u ps=0u b=0 m=1
R$971 \$230 pbias vss rppd w=1u l=50u ps=0u b=0 m=1
R$972 \$230 pbias vss rppd w=1u l=50u ps=0u b=0 m=1
R$973 \$230 pbias vss rppd w=1u l=50u ps=0u b=0 m=1
R$974 \$3 \$20 vss rppd w=1u l=48u ps=0u b=0 m=1
R$975 \$3 \$20 vss rppd w=1u l=48u ps=0u b=0 m=1
R$976 \$3 \$20 vss rppd w=1u l=48u ps=0u b=0 m=1
R$977 \$3 \$20 vss rppd w=1u l=48u ps=0u b=0 m=1
R$978 \$3 \$20 vss rppd w=1u l=48u ps=0u b=0 m=1
R$979 \$3 \$20 vss rppd w=1u l=48u ps=0u b=0 m=1
R$980 \$3 \$20 vss rppd w=1u l=48u ps=0u b=0 m=1
R$981 \$3 \$20 vss rppd w=1u l=48u ps=0u b=0 m=1
R$982 \$3 \$20 vss rppd w=1u l=48u ps=0u b=0 m=1
R$983 \$3 \$20 vss rppd w=1u l=48u ps=0u b=0 m=1
R$984 \$3 \$20 vss rppd w=1u l=48u ps=0u b=0 m=1
R$985 \$3 \$20 vss rppd w=1u l=48u ps=0u b=0 m=1
R$986 \$2 \$20 vss rppd w=1u l=48u ps=0u b=0 m=1
R$987 \$2 \$20 vss rppd w=1u l=48u ps=0u b=0 m=1
R$988 \$2 \$20 vss rppd w=1u l=48u ps=0u b=0 m=1
R$989 \$2 \$20 vss rppd w=1u l=48u ps=0u b=0 m=1
R$990 \$2 \$20 vss rppd w=1u l=48u ps=0u b=0 m=1
R$991 \$2 \$20 vss rppd w=1u l=48u ps=0u b=0 m=1
R$992 \$2 \$20 vss rppd w=1u l=48u ps=0u b=0 m=1
R$993 \$2 \$20 vss rppd w=1u l=48u ps=0u b=0 m=1
R$994 \$2 \$20 vss rppd w=1u l=48u ps=0u b=0 m=1
R$995 \$2 \$20 vss rppd w=1u l=48u ps=0u b=0 m=1
R$996 \$2 \$20 vss rppd w=1u l=48u ps=0u b=0 m=1
R$997 \$2 \$20 vss rppd w=1u l=48u ps=0u b=0 m=1
R$998 \$3 \$239 vss rppd w=1u l=48u ps=0u b=0 m=1
R$999 \$3 \$239 vss rppd w=1u l=48u ps=0u b=0 m=1
R$1000 \$3 \$239 vss rppd w=1u l=48u ps=0u b=0 m=1
R$1001 \$3 \$239 vss rppd w=1u l=48u ps=0u b=0 m=1
R$1002 \$3 \$239 vss rppd w=1u l=48u ps=0u b=0 m=1
R$1003 \$3 \$239 vss rppd w=1u l=48u ps=0u b=0 m=1
R$1004 \$3 \$239 vss rppd w=1u l=48u ps=0u b=0 m=1
R$1005 \$3 \$239 vss rppd w=1u l=48u ps=0u b=0 m=1
R$1006 \$3 \$239 vss rppd w=1u l=48u ps=0u b=0 m=1
R$1007 \$3 \$239 vss rppd w=1u l=48u ps=0u b=0 m=1
R$1008 \$3 \$239 vss rppd w=1u l=48u ps=0u b=0 m=1
R$1009 \$3 \$239 vss rppd w=1u l=48u ps=0u b=0 m=1
R$1010 \$2 \$444 vss rppd w=1u l=48u ps=0u b=0 m=1
R$1011 \$2 \$444 vss rppd w=1u l=48u ps=0u b=0 m=1
R$1012 \$2 \$444 vss rppd w=1u l=48u ps=0u b=0 m=1
R$1013 \$2 \$444 vss rppd w=1u l=48u ps=0u b=0 m=1
R$1014 \$2 \$444 vss rppd w=1u l=48u ps=0u b=0 m=1
R$1015 \$2 \$444 vss rppd w=1u l=48u ps=0u b=0 m=1
R$1016 \$2 \$444 vss rppd w=1u l=48u ps=0u b=0 m=1
R$1017 \$2 \$444 vss rppd w=1u l=48u ps=0u b=0 m=1
R$1018 \$2 \$444 vss rppd w=1u l=48u ps=0u b=0 m=1
R$1019 \$2 \$444 vss rppd w=1u l=48u ps=0u b=0 m=1
R$1020 \$2 \$444 vss rppd w=1u l=48u ps=0u b=0 m=1
R$1021 \$2 \$444 vss rppd w=1u l=48u ps=0u b=0 m=1
R$1022 vss \$21 vss rhigh w=0.5u l=49u ps=0u b=0 m=1
R$1023 \$4 \$22 vss rhigh w=0.5u l=49u ps=0u b=0 m=1
R$1024 \$5 \$22 vss rhigh w=0.5u l=49u ps=0u b=0 m=1
R$1025 \$6 \$23 vss rhigh w=0.5u l=49u ps=0u b=0 m=1
R$1026 \$7 \$23 vss rhigh w=0.5u l=49u ps=0u b=0 m=1
R$1027 \$7 \$21 vss rhigh w=0.5u l=49u ps=0u b=0 m=1
R$1028 \$6 \$18 vss rhigh w=0.5u l=49u ps=0u b=0 m=1
R$1029 \$4 \$8 vss rhigh w=0.5u l=49u ps=0u b=0 m=1
R$1030 \$5 \$12 vss rhigh w=0.5u l=49u ps=0u b=0 m=1
R$1031 \$13 \$12 vss rhigh w=0.5u l=49u ps=0u b=0 m=1
R$1032 \$13 \$14 vss rhigh w=0.5u l=49u ps=0u b=0 m=1
R$1033 \$15 \$14 vss rhigh w=0.5u l=49u ps=0u b=0 m=1
R$1034 \$15 \$16 vss rhigh w=0.5u l=49u ps=0u b=0 m=1
R$1035 \$17 \$16 vss rhigh w=0.5u l=49u ps=0u b=0 m=1
R$1036 \$17 \$18 vss rhigh w=0.5u l=49u ps=0u b=0 m=1
.ENDS g1_bgr
