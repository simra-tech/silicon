.subckt g1_bgr vdd vss r4 vref iptat pbias pcasc vbe dvbe
R1 vss n_23 vss rhigh w=0.5u l=49u b=0 m=1
R2 n_12 det vss rhigh w=0.5u l=49u b=0 m=1
R3 n_13 n_24 vss rhigh w=0.5u l=49u b=0 m=1
R4 n_14 n_24 vss rhigh w=0.5u l=49u b=0 m=1
R5 n_14 n_26 vss rhigh w=0.5u l=49u b=0 m=1
R6 n_15 n_26 vss rhigh w=0.5u l=49u b=0 m=1
R7 n_15 n_27 vss rhigh w=0.5u l=49u b=0 m=1
R8 n_16 n_27 vss rhigh w=0.5u l=49u b=0 m=1
R9 n_16 n_21 vss rhigh w=0.5u l=49u b=0 m=1
R10 n_12 n_25 vss rhigh w=0.5u l=49u b=0 m=1
R11 n_13 n_25 vss rhigh w=0.5u l=49u b=0 m=1
R12 n_17 n_22 vss rhigh w=0.5u l=49u b=0 m=1
R13 n_18 n_22 vss rhigh w=0.5u l=49u b=0 m=1
R14 n_18 n_23 vss rhigh w=0.5u l=49u b=0 m=1
R15 n_17 n_21 vss rhigh w=0.5u l=49u b=0 m=1
R16 vss dvbe vss rppd w=1u l=51.5u b=0 m=1
R17 n_7 vref vss rppd w=1u l=53.465u b=0 m=1
R18 n_2 n_36 vss rppd w=1u l=53.465u b=0 m=1
R19 n_7 n_36 vss rppd w=1u l=53.465u b=0 m=1
R20 n_2 n_37 vss rppd w=1u l=53.465u b=0 m=1
R21 n_8 n_37 vss rppd w=1u l=53.465u b=0 m=1
R22 n_8 vbe3 vss rppd w=1u l=53.465u b=0 m=1
R23 n_6 vb2 vss rppd w=1u l=48u b=0 m=1
R24 n_9 vd1 vss rppd w=1u l=48u b=0 m=1
R25 n_6 n_19 vss rppd w=1u l=48u b=0 m=1
R26 n_9 n_19 vss rppd w=1u l=48u b=0 m=1
M27 kick det vdd vdd sg13_hv_pmos l=0.5u w=2u as=0.68p ad=0.68p ps=4.68u pd=4.68u rfmode=0
M28 r4n r4 vdd vdd sg13_hv_pmos l=0.5u w=2u as=0.68p ad=0.68p ps=4.68u pd=4.68u rfmode=0
M29 vbe r4 b1b vss sg13_hv_nmos l=0.5u w=2u as=0.68p ad=0.68p ps=4.68u pd=4.68u rfmode=0
M30 pbias kick vss vss sg13_hv_nmos l=4u w=1u as=0.34p ad=0.34p ps=2.68u pd=2.68u rfmode=0
M31 kick det vss vss sg13_hv_nmos l=0.6u w=1u as=0.34p ad=0.34p ps=2.68u pd=2.68u rfmode=0
M32 r4n r4 vss vss sg13_hv_nmos l=0.5u w=1u as=0.34p ad=0.34p ps=2.68u pd=2.68u rfmode=0
M33 b1b r4n vss vss sg13_hv_nmos l=0.6u w=1u as=0.34p ad=0.34p ps=2.68u pd=2.68u rfmode=0
M34 n1 vb2 vbe vss sg13_hv_nmos l=1u w=10u as=3.4p ad=3.4p ps=20.68u pd=20.68u rfmode=0
M35 c2 vb2 pcasc vss sg13_hv_nmos l=1u w=10u as=3.4p ad=3.4p ps=20.68u pd=20.68u rfmode=0
M36 vbe vb2 n1 vss sg13_hv_nmos l=1u w=10u as=3.4p ad=3.4p ps=20.68u pd=20.68u rfmode=0
M37 pcasc vb2 c2 vss sg13_hv_nmos l=1u w=10u as=3.4p ad=3.4p ps=20.68u pd=20.68u rfmode=0
M38 d1 pbias vdd vdd sg13_hv_pmos l=4u w=5u as=1.7p ad=1.7p ps=10.68u pd=10.68u rfmode=0
M39 d2 pbias vdd vdd sg13_hv_pmos l=4u w=5u as=1.7p ad=1.7p ps=10.68u pd=10.68u rfmode=0
M40 d4 pbias vdd vdd sg13_hv_pmos l=4u w=5u as=1.7p ad=1.7p ps=10.68u pd=10.68u rfmode=0
M41 d5 pbias vdd vdd sg13_hv_pmos l=4u w=5u as=1.7p ad=1.7p ps=10.68u pd=10.68u rfmode=0
M42 det pbias vdd vdd sg13_hv_pmos l=4u w=5u as=1.7p ad=1.7p ps=10.68u pd=10.68u rfmode=0
M43 d3 pbias vdd vdd sg13_hv_pmos l=4u w=5u as=1.7p ad=1.7p ps=10.68u pd=10.68u rfmode=0
M44 d3 pbias vdd vdd sg13_hv_pmos l=4u w=5u as=1.7p ad=1.7p ps=10.68u pd=10.68u rfmode=0
M45 d5 pbias vdd vdd sg13_hv_pmos l=4u w=5u as=1.7p ad=1.7p ps=10.68u pd=10.68u rfmode=0
M46 d4 pbias vdd vdd sg13_hv_pmos l=4u w=5u as=1.7p ad=1.7p ps=10.68u pd=10.68u rfmode=0
M47 d2 pbias vdd vdd sg13_hv_pmos l=4u w=5u as=1.7p ad=1.7p ps=10.68u pd=10.68u rfmode=0
M48 d1 pbias vdd vdd sg13_hv_pmos l=4u w=5u as=1.7p ad=1.7p ps=10.68u pd=10.68u rfmode=0
M49 det pbias vdd vdd sg13_hv_pmos l=4u w=5u as=1.7p ad=1.7p ps=10.68u pd=10.68u rfmode=0
M50 vb2 pcasc d5 d5 sg13_hv_pmos l=4u w=10u as=3.4p ad=3.4p ps=20.68u pd=20.68u rfmode=0
M51 vref pcasc d3 d3 sg13_hv_pmos l=4u w=10u as=3.4p ad=3.4p ps=20.68u pd=20.68u rfmode=0
M52 n1 pcasc d1 d1 sg13_hv_pmos l=4u w=10u as=3.4p ad=3.4p ps=20.68u pd=20.68u rfmode=0
M53 iptat pcasc d4 d4 sg13_hv_pmos l=4u w=10u as=3.4p ad=3.4p ps=20.68u pd=20.68u rfmode=0
M54 pbias pcasc d2 d2 sg13_hv_pmos l=4u w=10u as=3.4p ad=3.4p ps=20.68u pd=20.68u rfmode=0
Q56 vbe vbe vss vss npn13G2 we=0.07u le=0.9u Nx=1 m=1
Q60 vbe3 vbe3 vss vss npn13G2 we=0.07u le=0.9u Nx=1 m=1
Q62 vd2 vd2 vss vss npn13G2 we=0.07u le=0.9u Nx=1 m=1
Q67 vbe b1b vss vss npn13G2 we=0.07u le=0.9u Nx=1 m=1
Q68 c2 vbe dvbe vss npn13G2 we=0.07u le=0.9u Nx=1 m=1
Q69 c2 vbe dvbe vss npn13G2 we=0.07u le=0.9u Nx=1 m=1
Q70 c2 vbe dvbe vss npn13G2 we=0.07u le=0.9u Nx=1 m=1
Q71 c2 vbe dvbe vss npn13G2 we=0.07u le=0.9u Nx=1 m=1
Q72 c2 vbe dvbe vss npn13G2 we=0.07u le=0.9u Nx=1 m=1
Q73 c2 vbe dvbe vss npn13G2 we=0.07u le=0.9u Nx=1 m=1
Q74 c2 vbe dvbe vss npn13G2 we=0.07u le=0.9u Nx=1 m=1
Q75 vd1 vd1 vd2 vss npn13G2 we=0.07u le=0.9u Nx=1 m=1
Q76 c2 vbe dvbe vss npn13G2 we=0.07u le=0.9u Nx=1 m=1
R77 n_4 pbias vss rppd w=1u l=50u b=0 m=1
R78 n_11 n_34 vss rppd w=1u l=50u b=0 m=1
R79 n_10 n_34 vss rppd w=1u l=50u b=0 m=1
R80 n_3 n_31 vss rppd w=1u l=50u b=0 m=1
R81 n_10 n_33 vss rppd w=1u l=50u b=0 m=1
R82 n_5 n_31 vss rppd w=1u l=50u b=0 m=1
R83 n_5 n_30 vss rppd w=1u l=50u b=0 m=1
R84 n_4 n_30 vss rppd w=1u l=50u b=0 m=1
R85 n_3 n_33 vss rppd w=1u l=50u b=0 m=1
R86 n_11 pcasc vss rppd w=1u l=50u b=0 m=1
R16_u2 vss dvbe vss rppd w=1u l=51.5u b=0 m=1
R16_u3 vss dvbe vss rppd w=1u l=51.5u b=0 m=1
R16_u4 vss dvbe vss rppd w=1u l=51.5u b=0 m=1
R16_u5 vss dvbe vss rppd w=1u l=51.5u b=0 m=1
R16_u6 vss dvbe vss rppd w=1u l=51.5u b=0 m=1
R16_u7 vss dvbe vss rppd w=1u l=51.5u b=0 m=1
R16_u8 vss dvbe vss rppd w=1u l=51.5u b=0 m=1
R16_u9 vss dvbe vss rppd w=1u l=51.5u b=0 m=1
R16_u10 vss dvbe vss rppd w=1u l=51.5u b=0 m=1
R16_u11 vss dvbe vss rppd w=1u l=51.5u b=0 m=1
R16_u12 vss dvbe vss rppd w=1u l=51.5u b=0 m=1
R16_u13 vss dvbe vss rppd w=1u l=51.5u b=0 m=1
R16_u14 vss dvbe vss rppd w=1u l=51.5u b=0 m=1
R16_u15 vss dvbe vss rppd w=1u l=51.5u b=0 m=1
R16_u16 vss dvbe vss rppd w=1u l=51.5u b=0 m=1
R16_u17 vss dvbe vss rppd w=1u l=51.5u b=0 m=1
R16_u18 vss dvbe vss rppd w=1u l=51.5u b=0 m=1
R16_u19 vss dvbe vss rppd w=1u l=51.5u b=0 m=1
R16_u20 vss dvbe vss rppd w=1u l=51.5u b=0 m=1
R16_u21 vss dvbe vss rppd w=1u l=51.5u b=0 m=1
R16_u22 vss dvbe vss rppd w=1u l=51.5u b=0 m=1
R16_u23 vss dvbe vss rppd w=1u l=51.5u b=0 m=1
R16_u24 vss dvbe vss rppd w=1u l=51.5u b=0 m=1
R17_u2 n_7 vref vss rppd w=1u l=53.465u b=0 m=1
R17_u3 n_7 vref vss rppd w=1u l=53.465u b=0 m=1
R17_u4 n_7 vref vss rppd w=1u l=53.465u b=0 m=1
R18_u2 n_2 n_36 vss rppd w=1u l=53.465u b=0 m=1
R18_u3 n_2 n_36 vss rppd w=1u l=53.465u b=0 m=1
R18_u4 n_2 n_36 vss rppd w=1u l=53.465u b=0 m=1
R19_u2 n_7 n_36 vss rppd w=1u l=53.465u b=0 m=1
R19_u3 n_7 n_36 vss rppd w=1u l=53.465u b=0 m=1
R19_u4 n_7 n_36 vss rppd w=1u l=53.465u b=0 m=1
R20_u2 n_2 n_37 vss rppd w=1u l=53.465u b=0 m=1
R20_u3 n_2 n_37 vss rppd w=1u l=53.465u b=0 m=1
R20_u4 n_2 n_37 vss rppd w=1u l=53.465u b=0 m=1
R21_u2 n_8 n_37 vss rppd w=1u l=53.465u b=0 m=1
R21_u3 n_8 n_37 vss rppd w=1u l=53.465u b=0 m=1
R21_u4 n_8 n_37 vss rppd w=1u l=53.465u b=0 m=1
R22_u2 n_8 vbe3 vss rppd w=1u l=53.465u b=0 m=1
R22_u3 n_8 vbe3 vss rppd w=1u l=53.465u b=0 m=1
R22_u4 n_8 vbe3 vss rppd w=1u l=53.465u b=0 m=1
R23_u2 n_6 vb2 vss rppd w=1u l=48u b=0 m=1
R23_u3 n_6 vb2 vss rppd w=1u l=48u b=0 m=1
R23_u4 n_6 vb2 vss rppd w=1u l=48u b=0 m=1
R23_u5 n_6 vb2 vss rppd w=1u l=48u b=0 m=1
R23_u6 n_6 vb2 vss rppd w=1u l=48u b=0 m=1
R23_u7 n_6 vb2 vss rppd w=1u l=48u b=0 m=1
R23_u8 n_6 vb2 vss rppd w=1u l=48u b=0 m=1
R23_u9 n_6 vb2 vss rppd w=1u l=48u b=0 m=1
R23_u10 n_6 vb2 vss rppd w=1u l=48u b=0 m=1
R23_u11 n_6 vb2 vss rppd w=1u l=48u b=0 m=1
R23_u12 n_6 vb2 vss rppd w=1u l=48u b=0 m=1
R23_u13 n_6 vb2 vss rppd w=1u l=48u b=0 m=1
R23_u14 n_6 vb2 vss rppd w=1u l=48u b=0 m=1
R23_u15 n_6 vb2 vss rppd w=1u l=48u b=0 m=1
R23_u16 n_6 vb2 vss rppd w=1u l=48u b=0 m=1
R23_u17 n_6 vb2 vss rppd w=1u l=48u b=0 m=1
R23_u18 n_6 vb2 vss rppd w=1u l=48u b=0 m=1
R23_u19 n_6 vb2 vss rppd w=1u l=48u b=0 m=1
R23_u20 n_6 vb2 vss rppd w=1u l=48u b=0 m=1
R23_u21 n_6 vb2 vss rppd w=1u l=48u b=0 m=1
R23_u22 n_6 vb2 vss rppd w=1u l=48u b=0 m=1
R23_u23 n_6 vb2 vss rppd w=1u l=48u b=0 m=1
R23_u24 n_6 vb2 vss rppd w=1u l=48u b=0 m=1
R24_u2 n_9 vd1 vss rppd w=1u l=48u b=0 m=1
R24_u3 n_9 vd1 vss rppd w=1u l=48u b=0 m=1
R24_u4 n_9 vd1 vss rppd w=1u l=48u b=0 m=1
R24_u5 n_9 vd1 vss rppd w=1u l=48u b=0 m=1
R24_u6 n_9 vd1 vss rppd w=1u l=48u b=0 m=1
R24_u7 n_9 vd1 vss rppd w=1u l=48u b=0 m=1
R24_u8 n_9 vd1 vss rppd w=1u l=48u b=0 m=1
R24_u9 n_9 vd1 vss rppd w=1u l=48u b=0 m=1
R24_u10 n_9 vd1 vss rppd w=1u l=48u b=0 m=1
R24_u11 n_9 vd1 vss rppd w=1u l=48u b=0 m=1
R24_u12 n_9 vd1 vss rppd w=1u l=48u b=0 m=1
R24_u13 n_9 vd1 vss rppd w=1u l=48u b=0 m=1
R24_u14 n_9 vd1 vss rppd w=1u l=48u b=0 m=1
R24_u15 n_9 vd1 vss rppd w=1u l=48u b=0 m=1
R24_u16 n_9 vd1 vss rppd w=1u l=48u b=0 m=1
R24_u17 n_9 vd1 vss rppd w=1u l=48u b=0 m=1
R24_u18 n_9 vd1 vss rppd w=1u l=48u b=0 m=1
R24_u19 n_9 vd1 vss rppd w=1u l=48u b=0 m=1
R24_u20 n_9 vd1 vss rppd w=1u l=48u b=0 m=1
R24_u21 n_9 vd1 vss rppd w=1u l=48u b=0 m=1
R24_u22 n_9 vd1 vss rppd w=1u l=48u b=0 m=1
R24_u23 n_9 vd1 vss rppd w=1u l=48u b=0 m=1
R24_u24 n_9 vd1 vss rppd w=1u l=48u b=0 m=1
R25_u2 n_6 n_19 vss rppd w=1u l=48u b=0 m=1
R25_u3 n_6 n_19 vss rppd w=1u l=48u b=0 m=1
R25_u4 n_6 n_19 vss rppd w=1u l=48u b=0 m=1
R25_u5 n_6 n_19 vss rppd w=1u l=48u b=0 m=1
R25_u6 n_6 n_19 vss rppd w=1u l=48u b=0 m=1
R25_u7 n_6 n_19 vss rppd w=1u l=48u b=0 m=1
R25_u8 n_6 n_19 vss rppd w=1u l=48u b=0 m=1
R25_u9 n_6 n_19 vss rppd w=1u l=48u b=0 m=1
R25_u10 n_6 n_19 vss rppd w=1u l=48u b=0 m=1
R25_u11 n_6 n_19 vss rppd w=1u l=48u b=0 m=1
R25_u12 n_6 n_19 vss rppd w=1u l=48u b=0 m=1
R25_u13 n_6 n_19 vss rppd w=1u l=48u b=0 m=1
R25_u14 n_6 n_19 vss rppd w=1u l=48u b=0 m=1
R25_u15 n_6 n_19 vss rppd w=1u l=48u b=0 m=1
R25_u16 n_6 n_19 vss rppd w=1u l=48u b=0 m=1
R25_u17 n_6 n_19 vss rppd w=1u l=48u b=0 m=1
R25_u18 n_6 n_19 vss rppd w=1u l=48u b=0 m=1
R25_u19 n_6 n_19 vss rppd w=1u l=48u b=0 m=1
R25_u20 n_6 n_19 vss rppd w=1u l=48u b=0 m=1
R25_u21 n_6 n_19 vss rppd w=1u l=48u b=0 m=1
R25_u22 n_6 n_19 vss rppd w=1u l=48u b=0 m=1
R25_u23 n_6 n_19 vss rppd w=1u l=48u b=0 m=1
R25_u24 n_6 n_19 vss rppd w=1u l=48u b=0 m=1
R26_u2 n_9 n_19 vss rppd w=1u l=48u b=0 m=1
R26_u3 n_9 n_19 vss rppd w=1u l=48u b=0 m=1
R26_u4 n_9 n_19 vss rppd w=1u l=48u b=0 m=1
R26_u5 n_9 n_19 vss rppd w=1u l=48u b=0 m=1
R26_u6 n_9 n_19 vss rppd w=1u l=48u b=0 m=1
R26_u7 n_9 n_19 vss rppd w=1u l=48u b=0 m=1
R26_u8 n_9 n_19 vss rppd w=1u l=48u b=0 m=1
R26_u9 n_9 n_19 vss rppd w=1u l=48u b=0 m=1
R26_u10 n_9 n_19 vss rppd w=1u l=48u b=0 m=1
R26_u11 n_9 n_19 vss rppd w=1u l=48u b=0 m=1
R26_u12 n_9 n_19 vss rppd w=1u l=48u b=0 m=1
R26_u13 n_9 n_19 vss rppd w=1u l=48u b=0 m=1
R26_u14 n_9 n_19 vss rppd w=1u l=48u b=0 m=1
R26_u15 n_9 n_19 vss rppd w=1u l=48u b=0 m=1
R26_u16 n_9 n_19 vss rppd w=1u l=48u b=0 m=1
R26_u17 n_9 n_19 vss rppd w=1u l=48u b=0 m=1
R26_u18 n_9 n_19 vss rppd w=1u l=48u b=0 m=1
R26_u19 n_9 n_19 vss rppd w=1u l=48u b=0 m=1
R26_u20 n_9 n_19 vss rppd w=1u l=48u b=0 m=1
R26_u21 n_9 n_19 vss rppd w=1u l=48u b=0 m=1
R26_u22 n_9 n_19 vss rppd w=1u l=48u b=0 m=1
R26_u23 n_9 n_19 vss rppd w=1u l=48u b=0 m=1
R26_u24 n_9 n_19 vss rppd w=1u l=48u b=0 m=1
M34_u2 n1 vb2 vbe vss sg13_hv_nmos l=1u w=10u as=3.4p ad=3.4p ps=20.68u pd=20.68u rfmode=0
M34_u3 n1 vb2 vbe vss sg13_hv_nmos l=1u w=10u as=3.4p ad=3.4p ps=20.68u pd=20.68u rfmode=0
M34_u4 n1 vb2 vbe vss sg13_hv_nmos l=1u w=10u as=3.4p ad=3.4p ps=20.68u pd=20.68u rfmode=0
M34_u5 n1 vb2 vbe vss sg13_hv_nmos l=1u w=10u as=3.4p ad=3.4p ps=20.68u pd=20.68u rfmode=0
M34_u6 n1 vb2 vbe vss sg13_hv_nmos l=1u w=10u as=3.4p ad=3.4p ps=20.68u pd=20.68u rfmode=0
M34_u7 n1 vb2 vbe vss sg13_hv_nmos l=1u w=10u as=3.4p ad=3.4p ps=20.68u pd=20.68u rfmode=0
M34_u8 n1 vb2 vbe vss sg13_hv_nmos l=1u w=10u as=3.4p ad=3.4p ps=20.68u pd=20.68u rfmode=0
M34_u9 n1 vb2 vbe vss sg13_hv_nmos l=1u w=10u as=3.4p ad=3.4p ps=20.68u pd=20.68u rfmode=0
M34_u10 n1 vb2 vbe vss sg13_hv_nmos l=1u w=10u as=3.4p ad=3.4p ps=20.68u pd=20.68u rfmode=0
M34_u11 n1 vb2 vbe vss sg13_hv_nmos l=1u w=10u as=3.4p ad=3.4p ps=20.68u pd=20.68u rfmode=0
M34_u12 n1 vb2 vbe vss sg13_hv_nmos l=1u w=10u as=3.4p ad=3.4p ps=20.68u pd=20.68u rfmode=0
M34_u13 n1 vb2 vbe vss sg13_hv_nmos l=1u w=10u as=3.4p ad=3.4p ps=20.68u pd=20.68u rfmode=0
M34_u14 n1 vb2 vbe vss sg13_hv_nmos l=1u w=10u as=3.4p ad=3.4p ps=20.68u pd=20.68u rfmode=0
M34_u15 n1 vb2 vbe vss sg13_hv_nmos l=1u w=10u as=3.4p ad=3.4p ps=20.68u pd=20.68u rfmode=0
M34_u16 n1 vb2 vbe vss sg13_hv_nmos l=1u w=10u as=3.4p ad=3.4p ps=20.68u pd=20.68u rfmode=0
M34_u17 n1 vb2 vbe vss sg13_hv_nmos l=1u w=10u as=3.4p ad=3.4p ps=20.68u pd=20.68u rfmode=0
M34_u18 n1 vb2 vbe vss sg13_hv_nmos l=1u w=10u as=3.4p ad=3.4p ps=20.68u pd=20.68u rfmode=0
M34_u19 n1 vb2 vbe vss sg13_hv_nmos l=1u w=10u as=3.4p ad=3.4p ps=20.68u pd=20.68u rfmode=0
M34_u20 n1 vb2 vbe vss sg13_hv_nmos l=1u w=10u as=3.4p ad=3.4p ps=20.68u pd=20.68u rfmode=0
M34_u21 n1 vb2 vbe vss sg13_hv_nmos l=1u w=10u as=3.4p ad=3.4p ps=20.68u pd=20.68u rfmode=0
M34_u22 n1 vb2 vbe vss sg13_hv_nmos l=1u w=10u as=3.4p ad=3.4p ps=20.68u pd=20.68u rfmode=0
M34_u23 n1 vb2 vbe vss sg13_hv_nmos l=1u w=10u as=3.4p ad=3.4p ps=20.68u pd=20.68u rfmode=0
M34_u24 n1 vb2 vbe vss sg13_hv_nmos l=1u w=10u as=3.4p ad=3.4p ps=20.68u pd=20.68u rfmode=0
M35_u2 c2 vb2 pcasc vss sg13_hv_nmos l=1u w=10u as=3.4p ad=3.4p ps=20.68u pd=20.68u rfmode=0
M35_u3 c2 vb2 pcasc vss sg13_hv_nmos l=1u w=10u as=3.4p ad=3.4p ps=20.68u pd=20.68u rfmode=0
M35_u4 c2 vb2 pcasc vss sg13_hv_nmos l=1u w=10u as=3.4p ad=3.4p ps=20.68u pd=20.68u rfmode=0
M35_u5 c2 vb2 pcasc vss sg13_hv_nmos l=1u w=10u as=3.4p ad=3.4p ps=20.68u pd=20.68u rfmode=0
M35_u6 c2 vb2 pcasc vss sg13_hv_nmos l=1u w=10u as=3.4p ad=3.4p ps=20.68u pd=20.68u rfmode=0
M35_u7 c2 vb2 pcasc vss sg13_hv_nmos l=1u w=10u as=3.4p ad=3.4p ps=20.68u pd=20.68u rfmode=0
M35_u8 c2 vb2 pcasc vss sg13_hv_nmos l=1u w=10u as=3.4p ad=3.4p ps=20.68u pd=20.68u rfmode=0
M35_u9 c2 vb2 pcasc vss sg13_hv_nmos l=1u w=10u as=3.4p ad=3.4p ps=20.68u pd=20.68u rfmode=0
M35_u10 c2 vb2 pcasc vss sg13_hv_nmos l=1u w=10u as=3.4p ad=3.4p ps=20.68u pd=20.68u rfmode=0
M35_u11 c2 vb2 pcasc vss sg13_hv_nmos l=1u w=10u as=3.4p ad=3.4p ps=20.68u pd=20.68u rfmode=0
M35_u12 c2 vb2 pcasc vss sg13_hv_nmos l=1u w=10u as=3.4p ad=3.4p ps=20.68u pd=20.68u rfmode=0
M35_u13 c2 vb2 pcasc vss sg13_hv_nmos l=1u w=10u as=3.4p ad=3.4p ps=20.68u pd=20.68u rfmode=0
M35_u14 c2 vb2 pcasc vss sg13_hv_nmos l=1u w=10u as=3.4p ad=3.4p ps=20.68u pd=20.68u rfmode=0
M35_u15 c2 vb2 pcasc vss sg13_hv_nmos l=1u w=10u as=3.4p ad=3.4p ps=20.68u pd=20.68u rfmode=0
M35_u16 c2 vb2 pcasc vss sg13_hv_nmos l=1u w=10u as=3.4p ad=3.4p ps=20.68u pd=20.68u rfmode=0
M35_u17 c2 vb2 pcasc vss sg13_hv_nmos l=1u w=10u as=3.4p ad=3.4p ps=20.68u pd=20.68u rfmode=0
M35_u18 c2 vb2 pcasc vss sg13_hv_nmos l=1u w=10u as=3.4p ad=3.4p ps=20.68u pd=20.68u rfmode=0
M35_u19 c2 vb2 pcasc vss sg13_hv_nmos l=1u w=10u as=3.4p ad=3.4p ps=20.68u pd=20.68u rfmode=0
M35_u20 c2 vb2 pcasc vss sg13_hv_nmos l=1u w=10u as=3.4p ad=3.4p ps=20.68u pd=20.68u rfmode=0
M35_u21 c2 vb2 pcasc vss sg13_hv_nmos l=1u w=10u as=3.4p ad=3.4p ps=20.68u pd=20.68u rfmode=0
M35_u22 c2 vb2 pcasc vss sg13_hv_nmos l=1u w=10u as=3.4p ad=3.4p ps=20.68u pd=20.68u rfmode=0
M35_u23 c2 vb2 pcasc vss sg13_hv_nmos l=1u w=10u as=3.4p ad=3.4p ps=20.68u pd=20.68u rfmode=0
M35_u24 c2 vb2 pcasc vss sg13_hv_nmos l=1u w=10u as=3.4p ad=3.4p ps=20.68u pd=20.68u rfmode=0
M36_u2 vbe vb2 n1 vss sg13_hv_nmos l=1u w=10u as=3.4p ad=3.4p ps=20.68u pd=20.68u rfmode=0
M36_u3 vbe vb2 n1 vss sg13_hv_nmos l=1u w=10u as=3.4p ad=3.4p ps=20.68u pd=20.68u rfmode=0
M36_u4 vbe vb2 n1 vss sg13_hv_nmos l=1u w=10u as=3.4p ad=3.4p ps=20.68u pd=20.68u rfmode=0
M36_u5 vbe vb2 n1 vss sg13_hv_nmos l=1u w=10u as=3.4p ad=3.4p ps=20.68u pd=20.68u rfmode=0
M36_u6 vbe vb2 n1 vss sg13_hv_nmos l=1u w=10u as=3.4p ad=3.4p ps=20.68u pd=20.68u rfmode=0
M36_u7 vbe vb2 n1 vss sg13_hv_nmos l=1u w=10u as=3.4p ad=3.4p ps=20.68u pd=20.68u rfmode=0
M36_u8 vbe vb2 n1 vss sg13_hv_nmos l=1u w=10u as=3.4p ad=3.4p ps=20.68u pd=20.68u rfmode=0
M36_u9 vbe vb2 n1 vss sg13_hv_nmos l=1u w=10u as=3.4p ad=3.4p ps=20.68u pd=20.68u rfmode=0
M36_u10 vbe vb2 n1 vss sg13_hv_nmos l=1u w=10u as=3.4p ad=3.4p ps=20.68u pd=20.68u rfmode=0
M36_u11 vbe vb2 n1 vss sg13_hv_nmos l=1u w=10u as=3.4p ad=3.4p ps=20.68u pd=20.68u rfmode=0
M36_u12 vbe vb2 n1 vss sg13_hv_nmos l=1u w=10u as=3.4p ad=3.4p ps=20.68u pd=20.68u rfmode=0
M36_u13 vbe vb2 n1 vss sg13_hv_nmos l=1u w=10u as=3.4p ad=3.4p ps=20.68u pd=20.68u rfmode=0
M36_u14 vbe vb2 n1 vss sg13_hv_nmos l=1u w=10u as=3.4p ad=3.4p ps=20.68u pd=20.68u rfmode=0
M36_u15 vbe vb2 n1 vss sg13_hv_nmos l=1u w=10u as=3.4p ad=3.4p ps=20.68u pd=20.68u rfmode=0
M36_u16 vbe vb2 n1 vss sg13_hv_nmos l=1u w=10u as=3.4p ad=3.4p ps=20.68u pd=20.68u rfmode=0
M36_u17 vbe vb2 n1 vss sg13_hv_nmos l=1u w=10u as=3.4p ad=3.4p ps=20.68u pd=20.68u rfmode=0
M36_u18 vbe vb2 n1 vss sg13_hv_nmos l=1u w=10u as=3.4p ad=3.4p ps=20.68u pd=20.68u rfmode=0
M36_u19 vbe vb2 n1 vss sg13_hv_nmos l=1u w=10u as=3.4p ad=3.4p ps=20.68u pd=20.68u rfmode=0
M36_u20 vbe vb2 n1 vss sg13_hv_nmos l=1u w=10u as=3.4p ad=3.4p ps=20.68u pd=20.68u rfmode=0
M36_u21 vbe vb2 n1 vss sg13_hv_nmos l=1u w=10u as=3.4p ad=3.4p ps=20.68u pd=20.68u rfmode=0
M36_u22 vbe vb2 n1 vss sg13_hv_nmos l=1u w=10u as=3.4p ad=3.4p ps=20.68u pd=20.68u rfmode=0
M36_u23 vbe vb2 n1 vss sg13_hv_nmos l=1u w=10u as=3.4p ad=3.4p ps=20.68u pd=20.68u rfmode=0
M36_u24 vbe vb2 n1 vss sg13_hv_nmos l=1u w=10u as=3.4p ad=3.4p ps=20.68u pd=20.68u rfmode=0
M37_u2 pcasc vb2 c2 vss sg13_hv_nmos l=1u w=10u as=3.4p ad=3.4p ps=20.68u pd=20.68u rfmode=0
M37_u3 pcasc vb2 c2 vss sg13_hv_nmos l=1u w=10u as=3.4p ad=3.4p ps=20.68u pd=20.68u rfmode=0
M37_u4 pcasc vb2 c2 vss sg13_hv_nmos l=1u w=10u as=3.4p ad=3.4p ps=20.68u pd=20.68u rfmode=0
M37_u5 pcasc vb2 c2 vss sg13_hv_nmos l=1u w=10u as=3.4p ad=3.4p ps=20.68u pd=20.68u rfmode=0
M37_u6 pcasc vb2 c2 vss sg13_hv_nmos l=1u w=10u as=3.4p ad=3.4p ps=20.68u pd=20.68u rfmode=0
M37_u7 pcasc vb2 c2 vss sg13_hv_nmos l=1u w=10u as=3.4p ad=3.4p ps=20.68u pd=20.68u rfmode=0
M37_u8 pcasc vb2 c2 vss sg13_hv_nmos l=1u w=10u as=3.4p ad=3.4p ps=20.68u pd=20.68u rfmode=0
M37_u9 pcasc vb2 c2 vss sg13_hv_nmos l=1u w=10u as=3.4p ad=3.4p ps=20.68u pd=20.68u rfmode=0
M37_u10 pcasc vb2 c2 vss sg13_hv_nmos l=1u w=10u as=3.4p ad=3.4p ps=20.68u pd=20.68u rfmode=0
M37_u11 pcasc vb2 c2 vss sg13_hv_nmos l=1u w=10u as=3.4p ad=3.4p ps=20.68u pd=20.68u rfmode=0
M37_u12 pcasc vb2 c2 vss sg13_hv_nmos l=1u w=10u as=3.4p ad=3.4p ps=20.68u pd=20.68u rfmode=0
M37_u13 pcasc vb2 c2 vss sg13_hv_nmos l=1u w=10u as=3.4p ad=3.4p ps=20.68u pd=20.68u rfmode=0
M37_u14 pcasc vb2 c2 vss sg13_hv_nmos l=1u w=10u as=3.4p ad=3.4p ps=20.68u pd=20.68u rfmode=0
M37_u15 pcasc vb2 c2 vss sg13_hv_nmos l=1u w=10u as=3.4p ad=3.4p ps=20.68u pd=20.68u rfmode=0
M37_u16 pcasc vb2 c2 vss sg13_hv_nmos l=1u w=10u as=3.4p ad=3.4p ps=20.68u pd=20.68u rfmode=0
M37_u17 pcasc vb2 c2 vss sg13_hv_nmos l=1u w=10u as=3.4p ad=3.4p ps=20.68u pd=20.68u rfmode=0
M37_u18 pcasc vb2 c2 vss sg13_hv_nmos l=1u w=10u as=3.4p ad=3.4p ps=20.68u pd=20.68u rfmode=0
M37_u19 pcasc vb2 c2 vss sg13_hv_nmos l=1u w=10u as=3.4p ad=3.4p ps=20.68u pd=20.68u rfmode=0
M37_u20 pcasc vb2 c2 vss sg13_hv_nmos l=1u w=10u as=3.4p ad=3.4p ps=20.68u pd=20.68u rfmode=0
M37_u21 pcasc vb2 c2 vss sg13_hv_nmos l=1u w=10u as=3.4p ad=3.4p ps=20.68u pd=20.68u rfmode=0
M37_u22 pcasc vb2 c2 vss sg13_hv_nmos l=1u w=10u as=3.4p ad=3.4p ps=20.68u pd=20.68u rfmode=0
M37_u23 pcasc vb2 c2 vss sg13_hv_nmos l=1u w=10u as=3.4p ad=3.4p ps=20.68u pd=20.68u rfmode=0
M37_u24 pcasc vb2 c2 vss sg13_hv_nmos l=1u w=10u as=3.4p ad=3.4p ps=20.68u pd=20.68u rfmode=0
M38_u2 d1 pbias vdd vdd sg13_hv_pmos l=4u w=5u as=1.7p ad=1.7p ps=10.68u pd=10.68u rfmode=0
M38_u3 d1 pbias vdd vdd sg13_hv_pmos l=4u w=5u as=1.7p ad=1.7p ps=10.68u pd=10.68u rfmode=0
M38_u4 d1 pbias vdd vdd sg13_hv_pmos l=4u w=5u as=1.7p ad=1.7p ps=10.68u pd=10.68u rfmode=0
M38_u5 d1 pbias vdd vdd sg13_hv_pmos l=4u w=5u as=1.7p ad=1.7p ps=10.68u pd=10.68u rfmode=0
M38_u6 d1 pbias vdd vdd sg13_hv_pmos l=4u w=5u as=1.7p ad=1.7p ps=10.68u pd=10.68u rfmode=0
M38_u7 d1 pbias vdd vdd sg13_hv_pmos l=4u w=5u as=1.7p ad=1.7p ps=10.68u pd=10.68u rfmode=0
M38_u8 d1 pbias vdd vdd sg13_hv_pmos l=4u w=5u as=1.7p ad=1.7p ps=10.68u pd=10.68u rfmode=0
M38_u9 d1 pbias vdd vdd sg13_hv_pmos l=4u w=5u as=1.7p ad=1.7p ps=10.68u pd=10.68u rfmode=0
M38_u10 d1 pbias vdd vdd sg13_hv_pmos l=4u w=5u as=1.7p ad=1.7p ps=10.68u pd=10.68u rfmode=0
M38_u11 d1 pbias vdd vdd sg13_hv_pmos l=4u w=5u as=1.7p ad=1.7p ps=10.68u pd=10.68u rfmode=0
M38_u12 d1 pbias vdd vdd sg13_hv_pmos l=4u w=5u as=1.7p ad=1.7p ps=10.68u pd=10.68u rfmode=0
M38_u13 d1 pbias vdd vdd sg13_hv_pmos l=4u w=5u as=1.7p ad=1.7p ps=10.68u pd=10.68u rfmode=0
M38_u14 d1 pbias vdd vdd sg13_hv_pmos l=4u w=5u as=1.7p ad=1.7p ps=10.68u pd=10.68u rfmode=0
M38_u15 d1 pbias vdd vdd sg13_hv_pmos l=4u w=5u as=1.7p ad=1.7p ps=10.68u pd=10.68u rfmode=0
M38_u16 d1 pbias vdd vdd sg13_hv_pmos l=4u w=5u as=1.7p ad=1.7p ps=10.68u pd=10.68u rfmode=0
M38_u17 d1 pbias vdd vdd sg13_hv_pmos l=4u w=5u as=1.7p ad=1.7p ps=10.68u pd=10.68u rfmode=0
M38_u18 d1 pbias vdd vdd sg13_hv_pmos l=4u w=5u as=1.7p ad=1.7p ps=10.68u pd=10.68u rfmode=0
M38_u19 d1 pbias vdd vdd sg13_hv_pmos l=4u w=5u as=1.7p ad=1.7p ps=10.68u pd=10.68u rfmode=0
M38_u20 d1 pbias vdd vdd sg13_hv_pmos l=4u w=5u as=1.7p ad=1.7p ps=10.68u pd=10.68u rfmode=0
M38_u21 d1 pbias vdd vdd sg13_hv_pmos l=4u w=5u as=1.7p ad=1.7p ps=10.68u pd=10.68u rfmode=0
M38_u22 d1 pbias vdd vdd sg13_hv_pmos l=4u w=5u as=1.7p ad=1.7p ps=10.68u pd=10.68u rfmode=0
M38_u23 d1 pbias vdd vdd sg13_hv_pmos l=4u w=5u as=1.7p ad=1.7p ps=10.68u pd=10.68u rfmode=0
M38_u24 d1 pbias vdd vdd sg13_hv_pmos l=4u w=5u as=1.7p ad=1.7p ps=10.68u pd=10.68u rfmode=0
M39_u2 d2 pbias vdd vdd sg13_hv_pmos l=4u w=5u as=1.7p ad=1.7p ps=10.68u pd=10.68u rfmode=0
M39_u3 d2 pbias vdd vdd sg13_hv_pmos l=4u w=5u as=1.7p ad=1.7p ps=10.68u pd=10.68u rfmode=0
M39_u4 d2 pbias vdd vdd sg13_hv_pmos l=4u w=5u as=1.7p ad=1.7p ps=10.68u pd=10.68u rfmode=0
M39_u5 d2 pbias vdd vdd sg13_hv_pmos l=4u w=5u as=1.7p ad=1.7p ps=10.68u pd=10.68u rfmode=0
M39_u6 d2 pbias vdd vdd sg13_hv_pmos l=4u w=5u as=1.7p ad=1.7p ps=10.68u pd=10.68u rfmode=0
M39_u7 d2 pbias vdd vdd sg13_hv_pmos l=4u w=5u as=1.7p ad=1.7p ps=10.68u pd=10.68u rfmode=0
M39_u8 d2 pbias vdd vdd sg13_hv_pmos l=4u w=5u as=1.7p ad=1.7p ps=10.68u pd=10.68u rfmode=0
M39_u9 d2 pbias vdd vdd sg13_hv_pmos l=4u w=5u as=1.7p ad=1.7p ps=10.68u pd=10.68u rfmode=0
M39_u10 d2 pbias vdd vdd sg13_hv_pmos l=4u w=5u as=1.7p ad=1.7p ps=10.68u pd=10.68u rfmode=0
M39_u11 d2 pbias vdd vdd sg13_hv_pmos l=4u w=5u as=1.7p ad=1.7p ps=10.68u pd=10.68u rfmode=0
M39_u12 d2 pbias vdd vdd sg13_hv_pmos l=4u w=5u as=1.7p ad=1.7p ps=10.68u pd=10.68u rfmode=0
M39_u13 d2 pbias vdd vdd sg13_hv_pmos l=4u w=5u as=1.7p ad=1.7p ps=10.68u pd=10.68u rfmode=0
M39_u14 d2 pbias vdd vdd sg13_hv_pmos l=4u w=5u as=1.7p ad=1.7p ps=10.68u pd=10.68u rfmode=0
M39_u15 d2 pbias vdd vdd sg13_hv_pmos l=4u w=5u as=1.7p ad=1.7p ps=10.68u pd=10.68u rfmode=0
M39_u16 d2 pbias vdd vdd sg13_hv_pmos l=4u w=5u as=1.7p ad=1.7p ps=10.68u pd=10.68u rfmode=0
M39_u17 d2 pbias vdd vdd sg13_hv_pmos l=4u w=5u as=1.7p ad=1.7p ps=10.68u pd=10.68u rfmode=0
M39_u18 d2 pbias vdd vdd sg13_hv_pmos l=4u w=5u as=1.7p ad=1.7p ps=10.68u pd=10.68u rfmode=0
M39_u19 d2 pbias vdd vdd sg13_hv_pmos l=4u w=5u as=1.7p ad=1.7p ps=10.68u pd=10.68u rfmode=0
M39_u20 d2 pbias vdd vdd sg13_hv_pmos l=4u w=5u as=1.7p ad=1.7p ps=10.68u pd=10.68u rfmode=0
M39_u21 d2 pbias vdd vdd sg13_hv_pmos l=4u w=5u as=1.7p ad=1.7p ps=10.68u pd=10.68u rfmode=0
M39_u22 d2 pbias vdd vdd sg13_hv_pmos l=4u w=5u as=1.7p ad=1.7p ps=10.68u pd=10.68u rfmode=0
M39_u23 d2 pbias vdd vdd sg13_hv_pmos l=4u w=5u as=1.7p ad=1.7p ps=10.68u pd=10.68u rfmode=0
M39_u24 d2 pbias vdd vdd sg13_hv_pmos l=4u w=5u as=1.7p ad=1.7p ps=10.68u pd=10.68u rfmode=0
M41_u2 d5 pbias vdd vdd sg13_hv_pmos l=4u w=5u as=1.7p ad=1.7p ps=10.68u pd=10.68u rfmode=0
M41_u3 d5 pbias vdd vdd sg13_hv_pmos l=4u w=5u as=1.7p ad=1.7p ps=10.68u pd=10.68u rfmode=0
M41_u4 d5 pbias vdd vdd sg13_hv_pmos l=4u w=5u as=1.7p ad=1.7p ps=10.68u pd=10.68u rfmode=0
M41_u5 d5 pbias vdd vdd sg13_hv_pmos l=4u w=5u as=1.7p ad=1.7p ps=10.68u pd=10.68u rfmode=0
M41_u6 d5 pbias vdd vdd sg13_hv_pmos l=4u w=5u as=1.7p ad=1.7p ps=10.68u pd=10.68u rfmode=0
M41_u7 d5 pbias vdd vdd sg13_hv_pmos l=4u w=5u as=1.7p ad=1.7p ps=10.68u pd=10.68u rfmode=0
M41_u8 d5 pbias vdd vdd sg13_hv_pmos l=4u w=5u as=1.7p ad=1.7p ps=10.68u pd=10.68u rfmode=0
M41_u9 d5 pbias vdd vdd sg13_hv_pmos l=4u w=5u as=1.7p ad=1.7p ps=10.68u pd=10.68u rfmode=0
M41_u10 d5 pbias vdd vdd sg13_hv_pmos l=4u w=5u as=1.7p ad=1.7p ps=10.68u pd=10.68u rfmode=0
M41_u11 d5 pbias vdd vdd sg13_hv_pmos l=4u w=5u as=1.7p ad=1.7p ps=10.68u pd=10.68u rfmode=0
M41_u12 d5 pbias vdd vdd sg13_hv_pmos l=4u w=5u as=1.7p ad=1.7p ps=10.68u pd=10.68u rfmode=0
M41_u13 d5 pbias vdd vdd sg13_hv_pmos l=4u w=5u as=1.7p ad=1.7p ps=10.68u pd=10.68u rfmode=0
M41_u14 d5 pbias vdd vdd sg13_hv_pmos l=4u w=5u as=1.7p ad=1.7p ps=10.68u pd=10.68u rfmode=0
M41_u15 d5 pbias vdd vdd sg13_hv_pmos l=4u w=5u as=1.7p ad=1.7p ps=10.68u pd=10.68u rfmode=0
M41_u16 d5 pbias vdd vdd sg13_hv_pmos l=4u w=5u as=1.7p ad=1.7p ps=10.68u pd=10.68u rfmode=0
M41_u17 d5 pbias vdd vdd sg13_hv_pmos l=4u w=5u as=1.7p ad=1.7p ps=10.68u pd=10.68u rfmode=0
M41_u18 d5 pbias vdd vdd sg13_hv_pmos l=4u w=5u as=1.7p ad=1.7p ps=10.68u pd=10.68u rfmode=0
M41_u19 d5 pbias vdd vdd sg13_hv_pmos l=4u w=5u as=1.7p ad=1.7p ps=10.68u pd=10.68u rfmode=0
M41_u20 d5 pbias vdd vdd sg13_hv_pmos l=4u w=5u as=1.7p ad=1.7p ps=10.68u pd=10.68u rfmode=0
M41_u21 d5 pbias vdd vdd sg13_hv_pmos l=4u w=5u as=1.7p ad=1.7p ps=10.68u pd=10.68u rfmode=0
M41_u22 d5 pbias vdd vdd sg13_hv_pmos l=4u w=5u as=1.7p ad=1.7p ps=10.68u pd=10.68u rfmode=0
M41_u23 d5 pbias vdd vdd sg13_hv_pmos l=4u w=5u as=1.7p ad=1.7p ps=10.68u pd=10.68u rfmode=0
M41_u24 d5 pbias vdd vdd sg13_hv_pmos l=4u w=5u as=1.7p ad=1.7p ps=10.68u pd=10.68u rfmode=0
M43_u2 d3 pbias vdd vdd sg13_hv_pmos l=4u w=5u as=1.7p ad=1.7p ps=10.68u pd=10.68u rfmode=0
M43_u3 d3 pbias vdd vdd sg13_hv_pmos l=4u w=5u as=1.7p ad=1.7p ps=10.68u pd=10.68u rfmode=0
M43_u4 d3 pbias vdd vdd sg13_hv_pmos l=4u w=5u as=1.7p ad=1.7p ps=10.68u pd=10.68u rfmode=0
M44_u2 d3 pbias vdd vdd sg13_hv_pmos l=4u w=5u as=1.7p ad=1.7p ps=10.68u pd=10.68u rfmode=0
M44_u3 d3 pbias vdd vdd sg13_hv_pmos l=4u w=5u as=1.7p ad=1.7p ps=10.68u pd=10.68u rfmode=0
M44_u4 d3 pbias vdd vdd sg13_hv_pmos l=4u w=5u as=1.7p ad=1.7p ps=10.68u pd=10.68u rfmode=0
M45_u2 d5 pbias vdd vdd sg13_hv_pmos l=4u w=5u as=1.7p ad=1.7p ps=10.68u pd=10.68u rfmode=0
M45_u3 d5 pbias vdd vdd sg13_hv_pmos l=4u w=5u as=1.7p ad=1.7p ps=10.68u pd=10.68u rfmode=0
M45_u4 d5 pbias vdd vdd sg13_hv_pmos l=4u w=5u as=1.7p ad=1.7p ps=10.68u pd=10.68u rfmode=0
M45_u5 d5 pbias vdd vdd sg13_hv_pmos l=4u w=5u as=1.7p ad=1.7p ps=10.68u pd=10.68u rfmode=0
M45_u6 d5 pbias vdd vdd sg13_hv_pmos l=4u w=5u as=1.7p ad=1.7p ps=10.68u pd=10.68u rfmode=0
M45_u7 d5 pbias vdd vdd sg13_hv_pmos l=4u w=5u as=1.7p ad=1.7p ps=10.68u pd=10.68u rfmode=0
M45_u8 d5 pbias vdd vdd sg13_hv_pmos l=4u w=5u as=1.7p ad=1.7p ps=10.68u pd=10.68u rfmode=0
M45_u9 d5 pbias vdd vdd sg13_hv_pmos l=4u w=5u as=1.7p ad=1.7p ps=10.68u pd=10.68u rfmode=0
M45_u10 d5 pbias vdd vdd sg13_hv_pmos l=4u w=5u as=1.7p ad=1.7p ps=10.68u pd=10.68u rfmode=0
M45_u11 d5 pbias vdd vdd sg13_hv_pmos l=4u w=5u as=1.7p ad=1.7p ps=10.68u pd=10.68u rfmode=0
M45_u12 d5 pbias vdd vdd sg13_hv_pmos l=4u w=5u as=1.7p ad=1.7p ps=10.68u pd=10.68u rfmode=0
M45_u13 d5 pbias vdd vdd sg13_hv_pmos l=4u w=5u as=1.7p ad=1.7p ps=10.68u pd=10.68u rfmode=0
M45_u14 d5 pbias vdd vdd sg13_hv_pmos l=4u w=5u as=1.7p ad=1.7p ps=10.68u pd=10.68u rfmode=0
M45_u15 d5 pbias vdd vdd sg13_hv_pmos l=4u w=5u as=1.7p ad=1.7p ps=10.68u pd=10.68u rfmode=0
M45_u16 d5 pbias vdd vdd sg13_hv_pmos l=4u w=5u as=1.7p ad=1.7p ps=10.68u pd=10.68u rfmode=0
M45_u17 d5 pbias vdd vdd sg13_hv_pmos l=4u w=5u as=1.7p ad=1.7p ps=10.68u pd=10.68u rfmode=0
M45_u18 d5 pbias vdd vdd sg13_hv_pmos l=4u w=5u as=1.7p ad=1.7p ps=10.68u pd=10.68u rfmode=0
M45_u19 d5 pbias vdd vdd sg13_hv_pmos l=4u w=5u as=1.7p ad=1.7p ps=10.68u pd=10.68u rfmode=0
M45_u20 d5 pbias vdd vdd sg13_hv_pmos l=4u w=5u as=1.7p ad=1.7p ps=10.68u pd=10.68u rfmode=0
M45_u21 d5 pbias vdd vdd sg13_hv_pmos l=4u w=5u as=1.7p ad=1.7p ps=10.68u pd=10.68u rfmode=0
M45_u22 d5 pbias vdd vdd sg13_hv_pmos l=4u w=5u as=1.7p ad=1.7p ps=10.68u pd=10.68u rfmode=0
M45_u23 d5 pbias vdd vdd sg13_hv_pmos l=4u w=5u as=1.7p ad=1.7p ps=10.68u pd=10.68u rfmode=0
M45_u24 d5 pbias vdd vdd sg13_hv_pmos l=4u w=5u as=1.7p ad=1.7p ps=10.68u pd=10.68u rfmode=0
M47_u2 d2 pbias vdd vdd sg13_hv_pmos l=4u w=5u as=1.7p ad=1.7p ps=10.68u pd=10.68u rfmode=0
M47_u3 d2 pbias vdd vdd sg13_hv_pmos l=4u w=5u as=1.7p ad=1.7p ps=10.68u pd=10.68u rfmode=0
M47_u4 d2 pbias vdd vdd sg13_hv_pmos l=4u w=5u as=1.7p ad=1.7p ps=10.68u pd=10.68u rfmode=0
M47_u5 d2 pbias vdd vdd sg13_hv_pmos l=4u w=5u as=1.7p ad=1.7p ps=10.68u pd=10.68u rfmode=0
M47_u6 d2 pbias vdd vdd sg13_hv_pmos l=4u w=5u as=1.7p ad=1.7p ps=10.68u pd=10.68u rfmode=0
M47_u7 d2 pbias vdd vdd sg13_hv_pmos l=4u w=5u as=1.7p ad=1.7p ps=10.68u pd=10.68u rfmode=0
M47_u8 d2 pbias vdd vdd sg13_hv_pmos l=4u w=5u as=1.7p ad=1.7p ps=10.68u pd=10.68u rfmode=0
M47_u9 d2 pbias vdd vdd sg13_hv_pmos l=4u w=5u as=1.7p ad=1.7p ps=10.68u pd=10.68u rfmode=0
M47_u10 d2 pbias vdd vdd sg13_hv_pmos l=4u w=5u as=1.7p ad=1.7p ps=10.68u pd=10.68u rfmode=0
M47_u11 d2 pbias vdd vdd sg13_hv_pmos l=4u w=5u as=1.7p ad=1.7p ps=10.68u pd=10.68u rfmode=0
M47_u12 d2 pbias vdd vdd sg13_hv_pmos l=4u w=5u as=1.7p ad=1.7p ps=10.68u pd=10.68u rfmode=0
M47_u13 d2 pbias vdd vdd sg13_hv_pmos l=4u w=5u as=1.7p ad=1.7p ps=10.68u pd=10.68u rfmode=0
M47_u14 d2 pbias vdd vdd sg13_hv_pmos l=4u w=5u as=1.7p ad=1.7p ps=10.68u pd=10.68u rfmode=0
M47_u15 d2 pbias vdd vdd sg13_hv_pmos l=4u w=5u as=1.7p ad=1.7p ps=10.68u pd=10.68u rfmode=0
M47_u16 d2 pbias vdd vdd sg13_hv_pmos l=4u w=5u as=1.7p ad=1.7p ps=10.68u pd=10.68u rfmode=0
M47_u17 d2 pbias vdd vdd sg13_hv_pmos l=4u w=5u as=1.7p ad=1.7p ps=10.68u pd=10.68u rfmode=0
M47_u18 d2 pbias vdd vdd sg13_hv_pmos l=4u w=5u as=1.7p ad=1.7p ps=10.68u pd=10.68u rfmode=0
M47_u19 d2 pbias vdd vdd sg13_hv_pmos l=4u w=5u as=1.7p ad=1.7p ps=10.68u pd=10.68u rfmode=0
M47_u20 d2 pbias vdd vdd sg13_hv_pmos l=4u w=5u as=1.7p ad=1.7p ps=10.68u pd=10.68u rfmode=0
M47_u21 d2 pbias vdd vdd sg13_hv_pmos l=4u w=5u as=1.7p ad=1.7p ps=10.68u pd=10.68u rfmode=0
M47_u22 d2 pbias vdd vdd sg13_hv_pmos l=4u w=5u as=1.7p ad=1.7p ps=10.68u pd=10.68u rfmode=0
M47_u23 d2 pbias vdd vdd sg13_hv_pmos l=4u w=5u as=1.7p ad=1.7p ps=10.68u pd=10.68u rfmode=0
M47_u24 d2 pbias vdd vdd sg13_hv_pmos l=4u w=5u as=1.7p ad=1.7p ps=10.68u pd=10.68u rfmode=0
M48_u2 d1 pbias vdd vdd sg13_hv_pmos l=4u w=5u as=1.7p ad=1.7p ps=10.68u pd=10.68u rfmode=0
M48_u3 d1 pbias vdd vdd sg13_hv_pmos l=4u w=5u as=1.7p ad=1.7p ps=10.68u pd=10.68u rfmode=0
M48_u4 d1 pbias vdd vdd sg13_hv_pmos l=4u w=5u as=1.7p ad=1.7p ps=10.68u pd=10.68u rfmode=0
M48_u5 d1 pbias vdd vdd sg13_hv_pmos l=4u w=5u as=1.7p ad=1.7p ps=10.68u pd=10.68u rfmode=0
M48_u6 d1 pbias vdd vdd sg13_hv_pmos l=4u w=5u as=1.7p ad=1.7p ps=10.68u pd=10.68u rfmode=0
M48_u7 d1 pbias vdd vdd sg13_hv_pmos l=4u w=5u as=1.7p ad=1.7p ps=10.68u pd=10.68u rfmode=0
M48_u8 d1 pbias vdd vdd sg13_hv_pmos l=4u w=5u as=1.7p ad=1.7p ps=10.68u pd=10.68u rfmode=0
M48_u9 d1 pbias vdd vdd sg13_hv_pmos l=4u w=5u as=1.7p ad=1.7p ps=10.68u pd=10.68u rfmode=0
M48_u10 d1 pbias vdd vdd sg13_hv_pmos l=4u w=5u as=1.7p ad=1.7p ps=10.68u pd=10.68u rfmode=0
M48_u11 d1 pbias vdd vdd sg13_hv_pmos l=4u w=5u as=1.7p ad=1.7p ps=10.68u pd=10.68u rfmode=0
M48_u12 d1 pbias vdd vdd sg13_hv_pmos l=4u w=5u as=1.7p ad=1.7p ps=10.68u pd=10.68u rfmode=0
M48_u13 d1 pbias vdd vdd sg13_hv_pmos l=4u w=5u as=1.7p ad=1.7p ps=10.68u pd=10.68u rfmode=0
M48_u14 d1 pbias vdd vdd sg13_hv_pmos l=4u w=5u as=1.7p ad=1.7p ps=10.68u pd=10.68u rfmode=0
M48_u15 d1 pbias vdd vdd sg13_hv_pmos l=4u w=5u as=1.7p ad=1.7p ps=10.68u pd=10.68u rfmode=0
M48_u16 d1 pbias vdd vdd sg13_hv_pmos l=4u w=5u as=1.7p ad=1.7p ps=10.68u pd=10.68u rfmode=0
M48_u17 d1 pbias vdd vdd sg13_hv_pmos l=4u w=5u as=1.7p ad=1.7p ps=10.68u pd=10.68u rfmode=0
M48_u18 d1 pbias vdd vdd sg13_hv_pmos l=4u w=5u as=1.7p ad=1.7p ps=10.68u pd=10.68u rfmode=0
M48_u19 d1 pbias vdd vdd sg13_hv_pmos l=4u w=5u as=1.7p ad=1.7p ps=10.68u pd=10.68u rfmode=0
M48_u20 d1 pbias vdd vdd sg13_hv_pmos l=4u w=5u as=1.7p ad=1.7p ps=10.68u pd=10.68u rfmode=0
M48_u21 d1 pbias vdd vdd sg13_hv_pmos l=4u w=5u as=1.7p ad=1.7p ps=10.68u pd=10.68u rfmode=0
M48_u22 d1 pbias vdd vdd sg13_hv_pmos l=4u w=5u as=1.7p ad=1.7p ps=10.68u pd=10.68u rfmode=0
M48_u23 d1 pbias vdd vdd sg13_hv_pmos l=4u w=5u as=1.7p ad=1.7p ps=10.68u pd=10.68u rfmode=0
M48_u24 d1 pbias vdd vdd sg13_hv_pmos l=4u w=5u as=1.7p ad=1.7p ps=10.68u pd=10.68u rfmode=0
M50_u2 vb2 pcasc d5 d5 sg13_hv_pmos l=4u w=10u as=3.4p ad=3.4p ps=20.68u pd=20.68u rfmode=0
M50_u3 vb2 pcasc d5 d5 sg13_hv_pmos l=4u w=10u as=3.4p ad=3.4p ps=20.68u pd=20.68u rfmode=0
M50_u4 vb2 pcasc d5 d5 sg13_hv_pmos l=4u w=10u as=3.4p ad=3.4p ps=20.68u pd=20.68u rfmode=0
M50_u5 vb2 pcasc d5 d5 sg13_hv_pmos l=4u w=10u as=3.4p ad=3.4p ps=20.68u pd=20.68u rfmode=0
M50_u6 vb2 pcasc d5 d5 sg13_hv_pmos l=4u w=10u as=3.4p ad=3.4p ps=20.68u pd=20.68u rfmode=0
M50_u7 vb2 pcasc d5 d5 sg13_hv_pmos l=4u w=10u as=3.4p ad=3.4p ps=20.68u pd=20.68u rfmode=0
M50_u8 vb2 pcasc d5 d5 sg13_hv_pmos l=4u w=10u as=3.4p ad=3.4p ps=20.68u pd=20.68u rfmode=0
M50_u9 vb2 pcasc d5 d5 sg13_hv_pmos l=4u w=10u as=3.4p ad=3.4p ps=20.68u pd=20.68u rfmode=0
M50_u10 vb2 pcasc d5 d5 sg13_hv_pmos l=4u w=10u as=3.4p ad=3.4p ps=20.68u pd=20.68u rfmode=0
M50_u11 vb2 pcasc d5 d5 sg13_hv_pmos l=4u w=10u as=3.4p ad=3.4p ps=20.68u pd=20.68u rfmode=0
M50_u12 vb2 pcasc d5 d5 sg13_hv_pmos l=4u w=10u as=3.4p ad=3.4p ps=20.68u pd=20.68u rfmode=0
M50_u13 vb2 pcasc d5 d5 sg13_hv_pmos l=4u w=10u as=3.4p ad=3.4p ps=20.68u pd=20.68u rfmode=0
M50_u14 vb2 pcasc d5 d5 sg13_hv_pmos l=4u w=10u as=3.4p ad=3.4p ps=20.68u pd=20.68u rfmode=0
M50_u15 vb2 pcasc d5 d5 sg13_hv_pmos l=4u w=10u as=3.4p ad=3.4p ps=20.68u pd=20.68u rfmode=0
M50_u16 vb2 pcasc d5 d5 sg13_hv_pmos l=4u w=10u as=3.4p ad=3.4p ps=20.68u pd=20.68u rfmode=0
M50_u17 vb2 pcasc d5 d5 sg13_hv_pmos l=4u w=10u as=3.4p ad=3.4p ps=20.68u pd=20.68u rfmode=0
M50_u18 vb2 pcasc d5 d5 sg13_hv_pmos l=4u w=10u as=3.4p ad=3.4p ps=20.68u pd=20.68u rfmode=0
M50_u19 vb2 pcasc d5 d5 sg13_hv_pmos l=4u w=10u as=3.4p ad=3.4p ps=20.68u pd=20.68u rfmode=0
M50_u20 vb2 pcasc d5 d5 sg13_hv_pmos l=4u w=10u as=3.4p ad=3.4p ps=20.68u pd=20.68u rfmode=0
M50_u21 vb2 pcasc d5 d5 sg13_hv_pmos l=4u w=10u as=3.4p ad=3.4p ps=20.68u pd=20.68u rfmode=0
M50_u22 vb2 pcasc d5 d5 sg13_hv_pmos l=4u w=10u as=3.4p ad=3.4p ps=20.68u pd=20.68u rfmode=0
M50_u23 vb2 pcasc d5 d5 sg13_hv_pmos l=4u w=10u as=3.4p ad=3.4p ps=20.68u pd=20.68u rfmode=0
M50_u24 vb2 pcasc d5 d5 sg13_hv_pmos l=4u w=10u as=3.4p ad=3.4p ps=20.68u pd=20.68u rfmode=0
M51_u2 vref pcasc d3 d3 sg13_hv_pmos l=4u w=10u as=3.4p ad=3.4p ps=20.68u pd=20.68u rfmode=0
M51_u3 vref pcasc d3 d3 sg13_hv_pmos l=4u w=10u as=3.4p ad=3.4p ps=20.68u pd=20.68u rfmode=0
M51_u4 vref pcasc d3 d3 sg13_hv_pmos l=4u w=10u as=3.4p ad=3.4p ps=20.68u pd=20.68u rfmode=0
M52_u2 n1 pcasc d1 d1 sg13_hv_pmos l=4u w=10u as=3.4p ad=3.4p ps=20.68u pd=20.68u rfmode=0
M52_u3 n1 pcasc d1 d1 sg13_hv_pmos l=4u w=10u as=3.4p ad=3.4p ps=20.68u pd=20.68u rfmode=0
M52_u4 n1 pcasc d1 d1 sg13_hv_pmos l=4u w=10u as=3.4p ad=3.4p ps=20.68u pd=20.68u rfmode=0
M52_u5 n1 pcasc d1 d1 sg13_hv_pmos l=4u w=10u as=3.4p ad=3.4p ps=20.68u pd=20.68u rfmode=0
M52_u6 n1 pcasc d1 d1 sg13_hv_pmos l=4u w=10u as=3.4p ad=3.4p ps=20.68u pd=20.68u rfmode=0
M52_u7 n1 pcasc d1 d1 sg13_hv_pmos l=4u w=10u as=3.4p ad=3.4p ps=20.68u pd=20.68u rfmode=0
M52_u8 n1 pcasc d1 d1 sg13_hv_pmos l=4u w=10u as=3.4p ad=3.4p ps=20.68u pd=20.68u rfmode=0
M52_u9 n1 pcasc d1 d1 sg13_hv_pmos l=4u w=10u as=3.4p ad=3.4p ps=20.68u pd=20.68u rfmode=0
M52_u10 n1 pcasc d1 d1 sg13_hv_pmos l=4u w=10u as=3.4p ad=3.4p ps=20.68u pd=20.68u rfmode=0
M52_u11 n1 pcasc d1 d1 sg13_hv_pmos l=4u w=10u as=3.4p ad=3.4p ps=20.68u pd=20.68u rfmode=0
M52_u12 n1 pcasc d1 d1 sg13_hv_pmos l=4u w=10u as=3.4p ad=3.4p ps=20.68u pd=20.68u rfmode=0
M52_u13 n1 pcasc d1 d1 sg13_hv_pmos l=4u w=10u as=3.4p ad=3.4p ps=20.68u pd=20.68u rfmode=0
M52_u14 n1 pcasc d1 d1 sg13_hv_pmos l=4u w=10u as=3.4p ad=3.4p ps=20.68u pd=20.68u rfmode=0
M52_u15 n1 pcasc d1 d1 sg13_hv_pmos l=4u w=10u as=3.4p ad=3.4p ps=20.68u pd=20.68u rfmode=0
M52_u16 n1 pcasc d1 d1 sg13_hv_pmos l=4u w=10u as=3.4p ad=3.4p ps=20.68u pd=20.68u rfmode=0
M52_u17 n1 pcasc d1 d1 sg13_hv_pmos l=4u w=10u as=3.4p ad=3.4p ps=20.68u pd=20.68u rfmode=0
M52_u18 n1 pcasc d1 d1 sg13_hv_pmos l=4u w=10u as=3.4p ad=3.4p ps=20.68u pd=20.68u rfmode=0
M52_u19 n1 pcasc d1 d1 sg13_hv_pmos l=4u w=10u as=3.4p ad=3.4p ps=20.68u pd=20.68u rfmode=0
M52_u20 n1 pcasc d1 d1 sg13_hv_pmos l=4u w=10u as=3.4p ad=3.4p ps=20.68u pd=20.68u rfmode=0
M52_u21 n1 pcasc d1 d1 sg13_hv_pmos l=4u w=10u as=3.4p ad=3.4p ps=20.68u pd=20.68u rfmode=0
M52_u22 n1 pcasc d1 d1 sg13_hv_pmos l=4u w=10u as=3.4p ad=3.4p ps=20.68u pd=20.68u rfmode=0
M52_u23 n1 pcasc d1 d1 sg13_hv_pmos l=4u w=10u as=3.4p ad=3.4p ps=20.68u pd=20.68u rfmode=0
M52_u24 n1 pcasc d1 d1 sg13_hv_pmos l=4u w=10u as=3.4p ad=3.4p ps=20.68u pd=20.68u rfmode=0
M54_u2 pbias pcasc d2 d2 sg13_hv_pmos l=4u w=10u as=3.4p ad=3.4p ps=20.68u pd=20.68u rfmode=0
M54_u3 pbias pcasc d2 d2 sg13_hv_pmos l=4u w=10u as=3.4p ad=3.4p ps=20.68u pd=20.68u rfmode=0
M54_u4 pbias pcasc d2 d2 sg13_hv_pmos l=4u w=10u as=3.4p ad=3.4p ps=20.68u pd=20.68u rfmode=0
M54_u5 pbias pcasc d2 d2 sg13_hv_pmos l=4u w=10u as=3.4p ad=3.4p ps=20.68u pd=20.68u rfmode=0
M54_u6 pbias pcasc d2 d2 sg13_hv_pmos l=4u w=10u as=3.4p ad=3.4p ps=20.68u pd=20.68u rfmode=0
M54_u7 pbias pcasc d2 d2 sg13_hv_pmos l=4u w=10u as=3.4p ad=3.4p ps=20.68u pd=20.68u rfmode=0
M54_u8 pbias pcasc d2 d2 sg13_hv_pmos l=4u w=10u as=3.4p ad=3.4p ps=20.68u pd=20.68u rfmode=0
M54_u9 pbias pcasc d2 d2 sg13_hv_pmos l=4u w=10u as=3.4p ad=3.4p ps=20.68u pd=20.68u rfmode=0
M54_u10 pbias pcasc d2 d2 sg13_hv_pmos l=4u w=10u as=3.4p ad=3.4p ps=20.68u pd=20.68u rfmode=0
M54_u11 pbias pcasc d2 d2 sg13_hv_pmos l=4u w=10u as=3.4p ad=3.4p ps=20.68u pd=20.68u rfmode=0
M54_u12 pbias pcasc d2 d2 sg13_hv_pmos l=4u w=10u as=3.4p ad=3.4p ps=20.68u pd=20.68u rfmode=0
M54_u13 pbias pcasc d2 d2 sg13_hv_pmos l=4u w=10u as=3.4p ad=3.4p ps=20.68u pd=20.68u rfmode=0
M54_u14 pbias pcasc d2 d2 sg13_hv_pmos l=4u w=10u as=3.4p ad=3.4p ps=20.68u pd=20.68u rfmode=0
M54_u15 pbias pcasc d2 d2 sg13_hv_pmos l=4u w=10u as=3.4p ad=3.4p ps=20.68u pd=20.68u rfmode=0
M54_u16 pbias pcasc d2 d2 sg13_hv_pmos l=4u w=10u as=3.4p ad=3.4p ps=20.68u pd=20.68u rfmode=0
M54_u17 pbias pcasc d2 d2 sg13_hv_pmos l=4u w=10u as=3.4p ad=3.4p ps=20.68u pd=20.68u rfmode=0
M54_u18 pbias pcasc d2 d2 sg13_hv_pmos l=4u w=10u as=3.4p ad=3.4p ps=20.68u pd=20.68u rfmode=0
M54_u19 pbias pcasc d2 d2 sg13_hv_pmos l=4u w=10u as=3.4p ad=3.4p ps=20.68u pd=20.68u rfmode=0
M54_u20 pbias pcasc d2 d2 sg13_hv_pmos l=4u w=10u as=3.4p ad=3.4p ps=20.68u pd=20.68u rfmode=0
M54_u21 pbias pcasc d2 d2 sg13_hv_pmos l=4u w=10u as=3.4p ad=3.4p ps=20.68u pd=20.68u rfmode=0
M54_u22 pbias pcasc d2 d2 sg13_hv_pmos l=4u w=10u as=3.4p ad=3.4p ps=20.68u pd=20.68u rfmode=0
M54_u23 pbias pcasc d2 d2 sg13_hv_pmos l=4u w=10u as=3.4p ad=3.4p ps=20.68u pd=20.68u rfmode=0
M54_u24 pbias pcasc d2 d2 sg13_hv_pmos l=4u w=10u as=3.4p ad=3.4p ps=20.68u pd=20.68u rfmode=0
Q56_u2 vbe vbe vss vss npn13G2 we=0.07u le=0.9u Nx=1 m=1
Q56_u3 vbe vbe vss vss npn13G2 we=0.07u le=0.9u Nx=1 m=1
Q56_u4 vbe vbe vss vss npn13G2 we=0.07u le=0.9u Nx=1 m=1
Q56_u5 vbe vbe vss vss npn13G2 we=0.07u le=0.9u Nx=1 m=1
Q56_u6 vbe vbe vss vss npn13G2 we=0.07u le=0.9u Nx=1 m=1
Q56_u7 vbe vbe vss vss npn13G2 we=0.07u le=0.9u Nx=1 m=1
Q56_u8 vbe vbe vss vss npn13G2 we=0.07u le=0.9u Nx=1 m=1
Q56_u9 vbe vbe vss vss npn13G2 we=0.07u le=0.9u Nx=1 m=1
Q56_u10 vbe vbe vss vss npn13G2 we=0.07u le=0.9u Nx=1 m=1
Q56_u11 vbe vbe vss vss npn13G2 we=0.07u le=0.9u Nx=1 m=1
Q56_u12 vbe vbe vss vss npn13G2 we=0.07u le=0.9u Nx=1 m=1
Q56_u13 vbe vbe vss vss npn13G2 we=0.07u le=0.9u Nx=1 m=1
Q56_u14 vbe vbe vss vss npn13G2 we=0.07u le=0.9u Nx=1 m=1
Q56_u15 vbe vbe vss vss npn13G2 we=0.07u le=0.9u Nx=1 m=1
Q56_u16 vbe vbe vss vss npn13G2 we=0.07u le=0.9u Nx=1 m=1
Q56_u17 vbe vbe vss vss npn13G2 we=0.07u le=0.9u Nx=1 m=1
Q56_u18 vbe vbe vss vss npn13G2 we=0.07u le=0.9u Nx=1 m=1
Q56_u19 vbe vbe vss vss npn13G2 we=0.07u le=0.9u Nx=1 m=1
Q56_u20 vbe vbe vss vss npn13G2 we=0.07u le=0.9u Nx=1 m=1
Q56_u21 vbe vbe vss vss npn13G2 we=0.07u le=0.9u Nx=1 m=1
Q56_u22 vbe vbe vss vss npn13G2 we=0.07u le=0.9u Nx=1 m=1
Q56_u23 vbe vbe vss vss npn13G2 we=0.07u le=0.9u Nx=1 m=1
Q56_u24 vbe vbe vss vss npn13G2 we=0.07u le=0.9u Nx=1 m=1
Q60_u2 vbe3 vbe3 vss vss npn13G2 we=0.07u le=0.9u Nx=1 m=1
Q60_u3 vbe3 vbe3 vss vss npn13G2 we=0.07u le=0.9u Nx=1 m=1
Q60_u4 vbe3 vbe3 vss vss npn13G2 we=0.07u le=0.9u Nx=1 m=1
Q62_u2 vd2 vd2 vss vss npn13G2 we=0.07u le=0.9u Nx=1 m=1
Q62_u3 vd2 vd2 vss vss npn13G2 we=0.07u le=0.9u Nx=1 m=1
Q62_u4 vd2 vd2 vss vss npn13G2 we=0.07u le=0.9u Nx=1 m=1
Q62_u5 vd2 vd2 vss vss npn13G2 we=0.07u le=0.9u Nx=1 m=1
Q62_u6 vd2 vd2 vss vss npn13G2 we=0.07u le=0.9u Nx=1 m=1
Q62_u7 vd2 vd2 vss vss npn13G2 we=0.07u le=0.9u Nx=1 m=1
Q62_u8 vd2 vd2 vss vss npn13G2 we=0.07u le=0.9u Nx=1 m=1
Q62_u9 vd2 vd2 vss vss npn13G2 we=0.07u le=0.9u Nx=1 m=1
Q62_u10 vd2 vd2 vss vss npn13G2 we=0.07u le=0.9u Nx=1 m=1
Q62_u11 vd2 vd2 vss vss npn13G2 we=0.07u le=0.9u Nx=1 m=1
Q62_u12 vd2 vd2 vss vss npn13G2 we=0.07u le=0.9u Nx=1 m=1
Q62_u13 vd2 vd2 vss vss npn13G2 we=0.07u le=0.9u Nx=1 m=1
Q62_u14 vd2 vd2 vss vss npn13G2 we=0.07u le=0.9u Nx=1 m=1
Q62_u15 vd2 vd2 vss vss npn13G2 we=0.07u le=0.9u Nx=1 m=1
Q62_u16 vd2 vd2 vss vss npn13G2 we=0.07u le=0.9u Nx=1 m=1
Q62_u17 vd2 vd2 vss vss npn13G2 we=0.07u le=0.9u Nx=1 m=1
Q62_u18 vd2 vd2 vss vss npn13G2 we=0.07u le=0.9u Nx=1 m=1
Q62_u19 vd2 vd2 vss vss npn13G2 we=0.07u le=0.9u Nx=1 m=1
Q62_u20 vd2 vd2 vss vss npn13G2 we=0.07u le=0.9u Nx=1 m=1
Q62_u21 vd2 vd2 vss vss npn13G2 we=0.07u le=0.9u Nx=1 m=1
Q62_u22 vd2 vd2 vss vss npn13G2 we=0.07u le=0.9u Nx=1 m=1
Q62_u23 vd2 vd2 vss vss npn13G2 we=0.07u le=0.9u Nx=1 m=1
Q62_u24 vd2 vd2 vss vss npn13G2 we=0.07u le=0.9u Nx=1 m=1
Q67_u2 vbe b1b vss vss npn13G2 we=0.07u le=0.9u Nx=1 m=1
Q67_u3 vbe b1b vss vss npn13G2 we=0.07u le=0.9u Nx=1 m=1
Q67_u4 vbe b1b vss vss npn13G2 we=0.07u le=0.9u Nx=1 m=1
Q67_u5 vbe b1b vss vss npn13G2 we=0.07u le=0.9u Nx=1 m=1
Q67_u6 vbe b1b vss vss npn13G2 we=0.07u le=0.9u Nx=1 m=1
Q67_u7 vbe b1b vss vss npn13G2 we=0.07u le=0.9u Nx=1 m=1
Q67_u8 vbe b1b vss vss npn13G2 we=0.07u le=0.9u Nx=1 m=1
Q67_u9 vbe b1b vss vss npn13G2 we=0.07u le=0.9u Nx=1 m=1
Q67_u10 vbe b1b vss vss npn13G2 we=0.07u le=0.9u Nx=1 m=1
Q67_u11 vbe b1b vss vss npn13G2 we=0.07u le=0.9u Nx=1 m=1
Q67_u12 vbe b1b vss vss npn13G2 we=0.07u le=0.9u Nx=1 m=1
Q67_u13 vbe b1b vss vss npn13G2 we=0.07u le=0.9u Nx=1 m=1
Q67_u14 vbe b1b vss vss npn13G2 we=0.07u le=0.9u Nx=1 m=1
Q67_u15 vbe b1b vss vss npn13G2 we=0.07u le=0.9u Nx=1 m=1
Q67_u16 vbe b1b vss vss npn13G2 we=0.07u le=0.9u Nx=1 m=1
Q67_u17 vbe b1b vss vss npn13G2 we=0.07u le=0.9u Nx=1 m=1
Q67_u18 vbe b1b vss vss npn13G2 we=0.07u le=0.9u Nx=1 m=1
Q67_u19 vbe b1b vss vss npn13G2 we=0.07u le=0.9u Nx=1 m=1
Q67_u20 vbe b1b vss vss npn13G2 we=0.07u le=0.9u Nx=1 m=1
Q67_u21 vbe b1b vss vss npn13G2 we=0.07u le=0.9u Nx=1 m=1
Q67_u22 vbe b1b vss vss npn13G2 we=0.07u le=0.9u Nx=1 m=1
Q67_u23 vbe b1b vss vss npn13G2 we=0.07u le=0.9u Nx=1 m=1
Q67_u24 vbe b1b vss vss npn13G2 we=0.07u le=0.9u Nx=1 m=1
Q68_u2 c2 vbe dvbe vss npn13G2 we=0.07u le=0.9u Nx=1 m=1
Q68_u3 c2 vbe dvbe vss npn13G2 we=0.07u le=0.9u Nx=1 m=1
Q68_u4 c2 vbe dvbe vss npn13G2 we=0.07u le=0.9u Nx=1 m=1
Q68_u5 c2 vbe dvbe vss npn13G2 we=0.07u le=0.9u Nx=1 m=1
Q68_u6 c2 vbe dvbe vss npn13G2 we=0.07u le=0.9u Nx=1 m=1
Q68_u7 c2 vbe dvbe vss npn13G2 we=0.07u le=0.9u Nx=1 m=1
Q68_u8 c2 vbe dvbe vss npn13G2 we=0.07u le=0.9u Nx=1 m=1
Q68_u9 c2 vbe dvbe vss npn13G2 we=0.07u le=0.9u Nx=1 m=1
Q68_u10 c2 vbe dvbe vss npn13G2 we=0.07u le=0.9u Nx=1 m=1
Q68_u11 c2 vbe dvbe vss npn13G2 we=0.07u le=0.9u Nx=1 m=1
Q68_u12 c2 vbe dvbe vss npn13G2 we=0.07u le=0.9u Nx=1 m=1
Q68_u13 c2 vbe dvbe vss npn13G2 we=0.07u le=0.9u Nx=1 m=1
Q68_u14 c2 vbe dvbe vss npn13G2 we=0.07u le=0.9u Nx=1 m=1
Q68_u15 c2 vbe dvbe vss npn13G2 we=0.07u le=0.9u Nx=1 m=1
Q68_u16 c2 vbe dvbe vss npn13G2 we=0.07u le=0.9u Nx=1 m=1
Q68_u17 c2 vbe dvbe vss npn13G2 we=0.07u le=0.9u Nx=1 m=1
Q68_u18 c2 vbe dvbe vss npn13G2 we=0.07u le=0.9u Nx=1 m=1
Q68_u19 c2 vbe dvbe vss npn13G2 we=0.07u le=0.9u Nx=1 m=1
Q68_u20 c2 vbe dvbe vss npn13G2 we=0.07u le=0.9u Nx=1 m=1
Q68_u21 c2 vbe dvbe vss npn13G2 we=0.07u le=0.9u Nx=1 m=1
Q68_u22 c2 vbe dvbe vss npn13G2 we=0.07u le=0.9u Nx=1 m=1
Q68_u23 c2 vbe dvbe vss npn13G2 we=0.07u le=0.9u Nx=1 m=1
Q68_u24 c2 vbe dvbe vss npn13G2 we=0.07u le=0.9u Nx=1 m=1
Q69_u2 c2 vbe dvbe vss npn13G2 we=0.07u le=0.9u Nx=1 m=1
Q69_u3 c2 vbe dvbe vss npn13G2 we=0.07u le=0.9u Nx=1 m=1
Q69_u4 c2 vbe dvbe vss npn13G2 we=0.07u le=0.9u Nx=1 m=1
Q69_u5 c2 vbe dvbe vss npn13G2 we=0.07u le=0.9u Nx=1 m=1
Q69_u6 c2 vbe dvbe vss npn13G2 we=0.07u le=0.9u Nx=1 m=1
Q69_u7 c2 vbe dvbe vss npn13G2 we=0.07u le=0.9u Nx=1 m=1
Q69_u8 c2 vbe dvbe vss npn13G2 we=0.07u le=0.9u Nx=1 m=1
Q69_u9 c2 vbe dvbe vss npn13G2 we=0.07u le=0.9u Nx=1 m=1
Q69_u10 c2 vbe dvbe vss npn13G2 we=0.07u le=0.9u Nx=1 m=1
Q69_u11 c2 vbe dvbe vss npn13G2 we=0.07u le=0.9u Nx=1 m=1
Q69_u12 c2 vbe dvbe vss npn13G2 we=0.07u le=0.9u Nx=1 m=1
Q69_u13 c2 vbe dvbe vss npn13G2 we=0.07u le=0.9u Nx=1 m=1
Q69_u14 c2 vbe dvbe vss npn13G2 we=0.07u le=0.9u Nx=1 m=1
Q69_u15 c2 vbe dvbe vss npn13G2 we=0.07u le=0.9u Nx=1 m=1
Q69_u16 c2 vbe dvbe vss npn13G2 we=0.07u le=0.9u Nx=1 m=1
Q69_u17 c2 vbe dvbe vss npn13G2 we=0.07u le=0.9u Nx=1 m=1
Q69_u18 c2 vbe dvbe vss npn13G2 we=0.07u le=0.9u Nx=1 m=1
Q69_u19 c2 vbe dvbe vss npn13G2 we=0.07u le=0.9u Nx=1 m=1
Q69_u20 c2 vbe dvbe vss npn13G2 we=0.07u le=0.9u Nx=1 m=1
Q69_u21 c2 vbe dvbe vss npn13G2 we=0.07u le=0.9u Nx=1 m=1
Q69_u22 c2 vbe dvbe vss npn13G2 we=0.07u le=0.9u Nx=1 m=1
Q69_u23 c2 vbe dvbe vss npn13G2 we=0.07u le=0.9u Nx=1 m=1
Q69_u24 c2 vbe dvbe vss npn13G2 we=0.07u le=0.9u Nx=1 m=1
Q70_u2 c2 vbe dvbe vss npn13G2 we=0.07u le=0.9u Nx=1 m=1
Q70_u3 c2 vbe dvbe vss npn13G2 we=0.07u le=0.9u Nx=1 m=1
Q70_u4 c2 vbe dvbe vss npn13G2 we=0.07u le=0.9u Nx=1 m=1
Q70_u5 c2 vbe dvbe vss npn13G2 we=0.07u le=0.9u Nx=1 m=1
Q70_u6 c2 vbe dvbe vss npn13G2 we=0.07u le=0.9u Nx=1 m=1
Q70_u7 c2 vbe dvbe vss npn13G2 we=0.07u le=0.9u Nx=1 m=1
Q70_u8 c2 vbe dvbe vss npn13G2 we=0.07u le=0.9u Nx=1 m=1
Q70_u9 c2 vbe dvbe vss npn13G2 we=0.07u le=0.9u Nx=1 m=1
Q70_u10 c2 vbe dvbe vss npn13G2 we=0.07u le=0.9u Nx=1 m=1
Q70_u11 c2 vbe dvbe vss npn13G2 we=0.07u le=0.9u Nx=1 m=1
Q70_u12 c2 vbe dvbe vss npn13G2 we=0.07u le=0.9u Nx=1 m=1
Q70_u13 c2 vbe dvbe vss npn13G2 we=0.07u le=0.9u Nx=1 m=1
Q70_u14 c2 vbe dvbe vss npn13G2 we=0.07u le=0.9u Nx=1 m=1
Q70_u15 c2 vbe dvbe vss npn13G2 we=0.07u le=0.9u Nx=1 m=1
Q70_u16 c2 vbe dvbe vss npn13G2 we=0.07u le=0.9u Nx=1 m=1
Q70_u17 c2 vbe dvbe vss npn13G2 we=0.07u le=0.9u Nx=1 m=1
Q70_u18 c2 vbe dvbe vss npn13G2 we=0.07u le=0.9u Nx=1 m=1
Q70_u19 c2 vbe dvbe vss npn13G2 we=0.07u le=0.9u Nx=1 m=1
Q70_u20 c2 vbe dvbe vss npn13G2 we=0.07u le=0.9u Nx=1 m=1
Q70_u21 c2 vbe dvbe vss npn13G2 we=0.07u le=0.9u Nx=1 m=1
Q70_u22 c2 vbe dvbe vss npn13G2 we=0.07u le=0.9u Nx=1 m=1
Q70_u23 c2 vbe dvbe vss npn13G2 we=0.07u le=0.9u Nx=1 m=1
Q70_u24 c2 vbe dvbe vss npn13G2 we=0.07u le=0.9u Nx=1 m=1
Q71_u2 c2 vbe dvbe vss npn13G2 we=0.07u le=0.9u Nx=1 m=1
Q71_u3 c2 vbe dvbe vss npn13G2 we=0.07u le=0.9u Nx=1 m=1
Q71_u4 c2 vbe dvbe vss npn13G2 we=0.07u le=0.9u Nx=1 m=1
Q71_u5 c2 vbe dvbe vss npn13G2 we=0.07u le=0.9u Nx=1 m=1
Q71_u6 c2 vbe dvbe vss npn13G2 we=0.07u le=0.9u Nx=1 m=1
Q71_u7 c2 vbe dvbe vss npn13G2 we=0.07u le=0.9u Nx=1 m=1
Q71_u8 c2 vbe dvbe vss npn13G2 we=0.07u le=0.9u Nx=1 m=1
Q71_u9 c2 vbe dvbe vss npn13G2 we=0.07u le=0.9u Nx=1 m=1
Q71_u10 c2 vbe dvbe vss npn13G2 we=0.07u le=0.9u Nx=1 m=1
Q71_u11 c2 vbe dvbe vss npn13G2 we=0.07u le=0.9u Nx=1 m=1
Q71_u12 c2 vbe dvbe vss npn13G2 we=0.07u le=0.9u Nx=1 m=1
Q71_u13 c2 vbe dvbe vss npn13G2 we=0.07u le=0.9u Nx=1 m=1
Q71_u14 c2 vbe dvbe vss npn13G2 we=0.07u le=0.9u Nx=1 m=1
Q71_u15 c2 vbe dvbe vss npn13G2 we=0.07u le=0.9u Nx=1 m=1
Q71_u16 c2 vbe dvbe vss npn13G2 we=0.07u le=0.9u Nx=1 m=1
Q71_u17 c2 vbe dvbe vss npn13G2 we=0.07u le=0.9u Nx=1 m=1
Q71_u18 c2 vbe dvbe vss npn13G2 we=0.07u le=0.9u Nx=1 m=1
Q71_u19 c2 vbe dvbe vss npn13G2 we=0.07u le=0.9u Nx=1 m=1
Q71_u20 c2 vbe dvbe vss npn13G2 we=0.07u le=0.9u Nx=1 m=1
Q71_u21 c2 vbe dvbe vss npn13G2 we=0.07u le=0.9u Nx=1 m=1
Q71_u22 c2 vbe dvbe vss npn13G2 we=0.07u le=0.9u Nx=1 m=1
Q71_u23 c2 vbe dvbe vss npn13G2 we=0.07u le=0.9u Nx=1 m=1
Q71_u24 c2 vbe dvbe vss npn13G2 we=0.07u le=0.9u Nx=1 m=1
Q72_u2 c2 vbe dvbe vss npn13G2 we=0.07u le=0.9u Nx=1 m=1
Q72_u3 c2 vbe dvbe vss npn13G2 we=0.07u le=0.9u Nx=1 m=1
Q72_u4 c2 vbe dvbe vss npn13G2 we=0.07u le=0.9u Nx=1 m=1
Q72_u5 c2 vbe dvbe vss npn13G2 we=0.07u le=0.9u Nx=1 m=1
Q72_u6 c2 vbe dvbe vss npn13G2 we=0.07u le=0.9u Nx=1 m=1
Q72_u7 c2 vbe dvbe vss npn13G2 we=0.07u le=0.9u Nx=1 m=1
Q72_u8 c2 vbe dvbe vss npn13G2 we=0.07u le=0.9u Nx=1 m=1
Q72_u9 c2 vbe dvbe vss npn13G2 we=0.07u le=0.9u Nx=1 m=1
Q72_u10 c2 vbe dvbe vss npn13G2 we=0.07u le=0.9u Nx=1 m=1
Q72_u11 c2 vbe dvbe vss npn13G2 we=0.07u le=0.9u Nx=1 m=1
Q72_u12 c2 vbe dvbe vss npn13G2 we=0.07u le=0.9u Nx=1 m=1
Q72_u13 c2 vbe dvbe vss npn13G2 we=0.07u le=0.9u Nx=1 m=1
Q72_u14 c2 vbe dvbe vss npn13G2 we=0.07u le=0.9u Nx=1 m=1
Q72_u15 c2 vbe dvbe vss npn13G2 we=0.07u le=0.9u Nx=1 m=1
Q72_u16 c2 vbe dvbe vss npn13G2 we=0.07u le=0.9u Nx=1 m=1
Q72_u17 c2 vbe dvbe vss npn13G2 we=0.07u le=0.9u Nx=1 m=1
Q72_u18 c2 vbe dvbe vss npn13G2 we=0.07u le=0.9u Nx=1 m=1
Q72_u19 c2 vbe dvbe vss npn13G2 we=0.07u le=0.9u Nx=1 m=1
Q72_u20 c2 vbe dvbe vss npn13G2 we=0.07u le=0.9u Nx=1 m=1
Q72_u21 c2 vbe dvbe vss npn13G2 we=0.07u le=0.9u Nx=1 m=1
Q72_u22 c2 vbe dvbe vss npn13G2 we=0.07u le=0.9u Nx=1 m=1
Q72_u23 c2 vbe dvbe vss npn13G2 we=0.07u le=0.9u Nx=1 m=1
Q72_u24 c2 vbe dvbe vss npn13G2 we=0.07u le=0.9u Nx=1 m=1
Q73_u2 c2 vbe dvbe vss npn13G2 we=0.07u le=0.9u Nx=1 m=1
Q73_u3 c2 vbe dvbe vss npn13G2 we=0.07u le=0.9u Nx=1 m=1
Q73_u4 c2 vbe dvbe vss npn13G2 we=0.07u le=0.9u Nx=1 m=1
Q73_u5 c2 vbe dvbe vss npn13G2 we=0.07u le=0.9u Nx=1 m=1
Q73_u6 c2 vbe dvbe vss npn13G2 we=0.07u le=0.9u Nx=1 m=1
Q73_u7 c2 vbe dvbe vss npn13G2 we=0.07u le=0.9u Nx=1 m=1
Q73_u8 c2 vbe dvbe vss npn13G2 we=0.07u le=0.9u Nx=1 m=1
Q73_u9 c2 vbe dvbe vss npn13G2 we=0.07u le=0.9u Nx=1 m=1
Q73_u10 c2 vbe dvbe vss npn13G2 we=0.07u le=0.9u Nx=1 m=1
Q73_u11 c2 vbe dvbe vss npn13G2 we=0.07u le=0.9u Nx=1 m=1
Q73_u12 c2 vbe dvbe vss npn13G2 we=0.07u le=0.9u Nx=1 m=1
Q73_u13 c2 vbe dvbe vss npn13G2 we=0.07u le=0.9u Nx=1 m=1
Q73_u14 c2 vbe dvbe vss npn13G2 we=0.07u le=0.9u Nx=1 m=1
Q73_u15 c2 vbe dvbe vss npn13G2 we=0.07u le=0.9u Nx=1 m=1
Q73_u16 c2 vbe dvbe vss npn13G2 we=0.07u le=0.9u Nx=1 m=1
Q73_u17 c2 vbe dvbe vss npn13G2 we=0.07u le=0.9u Nx=1 m=1
Q73_u18 c2 vbe dvbe vss npn13G2 we=0.07u le=0.9u Nx=1 m=1
Q73_u19 c2 vbe dvbe vss npn13G2 we=0.07u le=0.9u Nx=1 m=1
Q73_u20 c2 vbe dvbe vss npn13G2 we=0.07u le=0.9u Nx=1 m=1
Q73_u21 c2 vbe dvbe vss npn13G2 we=0.07u le=0.9u Nx=1 m=1
Q73_u22 c2 vbe dvbe vss npn13G2 we=0.07u le=0.9u Nx=1 m=1
Q73_u23 c2 vbe dvbe vss npn13G2 we=0.07u le=0.9u Nx=1 m=1
Q73_u24 c2 vbe dvbe vss npn13G2 we=0.07u le=0.9u Nx=1 m=1
Q74_u2 c2 vbe dvbe vss npn13G2 we=0.07u le=0.9u Nx=1 m=1
Q74_u3 c2 vbe dvbe vss npn13G2 we=0.07u le=0.9u Nx=1 m=1
Q74_u4 c2 vbe dvbe vss npn13G2 we=0.07u le=0.9u Nx=1 m=1
Q74_u5 c2 vbe dvbe vss npn13G2 we=0.07u le=0.9u Nx=1 m=1
Q74_u6 c2 vbe dvbe vss npn13G2 we=0.07u le=0.9u Nx=1 m=1
Q74_u7 c2 vbe dvbe vss npn13G2 we=0.07u le=0.9u Nx=1 m=1
Q74_u8 c2 vbe dvbe vss npn13G2 we=0.07u le=0.9u Nx=1 m=1
Q74_u9 c2 vbe dvbe vss npn13G2 we=0.07u le=0.9u Nx=1 m=1
Q74_u10 c2 vbe dvbe vss npn13G2 we=0.07u le=0.9u Nx=1 m=1
Q74_u11 c2 vbe dvbe vss npn13G2 we=0.07u le=0.9u Nx=1 m=1
Q74_u12 c2 vbe dvbe vss npn13G2 we=0.07u le=0.9u Nx=1 m=1
Q74_u13 c2 vbe dvbe vss npn13G2 we=0.07u le=0.9u Nx=1 m=1
Q74_u14 c2 vbe dvbe vss npn13G2 we=0.07u le=0.9u Nx=1 m=1
Q74_u15 c2 vbe dvbe vss npn13G2 we=0.07u le=0.9u Nx=1 m=1
Q74_u16 c2 vbe dvbe vss npn13G2 we=0.07u le=0.9u Nx=1 m=1
Q74_u17 c2 vbe dvbe vss npn13G2 we=0.07u le=0.9u Nx=1 m=1
Q74_u18 c2 vbe dvbe vss npn13G2 we=0.07u le=0.9u Nx=1 m=1
Q74_u19 c2 vbe dvbe vss npn13G2 we=0.07u le=0.9u Nx=1 m=1
Q74_u20 c2 vbe dvbe vss npn13G2 we=0.07u le=0.9u Nx=1 m=1
Q74_u21 c2 vbe dvbe vss npn13G2 we=0.07u le=0.9u Nx=1 m=1
Q74_u22 c2 vbe dvbe vss npn13G2 we=0.07u le=0.9u Nx=1 m=1
Q74_u23 c2 vbe dvbe vss npn13G2 we=0.07u le=0.9u Nx=1 m=1
Q74_u24 c2 vbe dvbe vss npn13G2 we=0.07u le=0.9u Nx=1 m=1
Q75_u2 vd1 vd1 vd2 vss npn13G2 we=0.07u le=0.9u Nx=1 m=1
Q75_u3 vd1 vd1 vd2 vss npn13G2 we=0.07u le=0.9u Nx=1 m=1
Q75_u4 vd1 vd1 vd2 vss npn13G2 we=0.07u le=0.9u Nx=1 m=1
Q75_u5 vd1 vd1 vd2 vss npn13G2 we=0.07u le=0.9u Nx=1 m=1
Q75_u6 vd1 vd1 vd2 vss npn13G2 we=0.07u le=0.9u Nx=1 m=1
Q75_u7 vd1 vd1 vd2 vss npn13G2 we=0.07u le=0.9u Nx=1 m=1
Q75_u8 vd1 vd1 vd2 vss npn13G2 we=0.07u le=0.9u Nx=1 m=1
Q75_u9 vd1 vd1 vd2 vss npn13G2 we=0.07u le=0.9u Nx=1 m=1
Q75_u10 vd1 vd1 vd2 vss npn13G2 we=0.07u le=0.9u Nx=1 m=1
Q75_u11 vd1 vd1 vd2 vss npn13G2 we=0.07u le=0.9u Nx=1 m=1
Q75_u12 vd1 vd1 vd2 vss npn13G2 we=0.07u le=0.9u Nx=1 m=1
Q75_u13 vd1 vd1 vd2 vss npn13G2 we=0.07u le=0.9u Nx=1 m=1
Q75_u14 vd1 vd1 vd2 vss npn13G2 we=0.07u le=0.9u Nx=1 m=1
Q75_u15 vd1 vd1 vd2 vss npn13G2 we=0.07u le=0.9u Nx=1 m=1
Q75_u16 vd1 vd1 vd2 vss npn13G2 we=0.07u le=0.9u Nx=1 m=1
Q75_u17 vd1 vd1 vd2 vss npn13G2 we=0.07u le=0.9u Nx=1 m=1
Q75_u18 vd1 vd1 vd2 vss npn13G2 we=0.07u le=0.9u Nx=1 m=1
Q75_u19 vd1 vd1 vd2 vss npn13G2 we=0.07u le=0.9u Nx=1 m=1
Q75_u20 vd1 vd1 vd2 vss npn13G2 we=0.07u le=0.9u Nx=1 m=1
Q75_u21 vd1 vd1 vd2 vss npn13G2 we=0.07u le=0.9u Nx=1 m=1
Q75_u22 vd1 vd1 vd2 vss npn13G2 we=0.07u le=0.9u Nx=1 m=1
Q75_u23 vd1 vd1 vd2 vss npn13G2 we=0.07u le=0.9u Nx=1 m=1
Q75_u24 vd1 vd1 vd2 vss npn13G2 we=0.07u le=0.9u Nx=1 m=1
Q76_u2 c2 vbe dvbe vss npn13G2 we=0.07u le=0.9u Nx=1 m=1
Q76_u3 c2 vbe dvbe vss npn13G2 we=0.07u le=0.9u Nx=1 m=1
Q76_u4 c2 vbe dvbe vss npn13G2 we=0.07u le=0.9u Nx=1 m=1
Q76_u5 c2 vbe dvbe vss npn13G2 we=0.07u le=0.9u Nx=1 m=1
Q76_u6 c2 vbe dvbe vss npn13G2 we=0.07u le=0.9u Nx=1 m=1
Q76_u7 c2 vbe dvbe vss npn13G2 we=0.07u le=0.9u Nx=1 m=1
Q76_u8 c2 vbe dvbe vss npn13G2 we=0.07u le=0.9u Nx=1 m=1
Q76_u9 c2 vbe dvbe vss npn13G2 we=0.07u le=0.9u Nx=1 m=1
Q76_u10 c2 vbe dvbe vss npn13G2 we=0.07u le=0.9u Nx=1 m=1
Q76_u11 c2 vbe dvbe vss npn13G2 we=0.07u le=0.9u Nx=1 m=1
Q76_u12 c2 vbe dvbe vss npn13G2 we=0.07u le=0.9u Nx=1 m=1
Q76_u13 c2 vbe dvbe vss npn13G2 we=0.07u le=0.9u Nx=1 m=1
Q76_u14 c2 vbe dvbe vss npn13G2 we=0.07u le=0.9u Nx=1 m=1
Q76_u15 c2 vbe dvbe vss npn13G2 we=0.07u le=0.9u Nx=1 m=1
Q76_u16 c2 vbe dvbe vss npn13G2 we=0.07u le=0.9u Nx=1 m=1
Q76_u17 c2 vbe dvbe vss npn13G2 we=0.07u le=0.9u Nx=1 m=1
Q76_u18 c2 vbe dvbe vss npn13G2 we=0.07u le=0.9u Nx=1 m=1
Q76_u19 c2 vbe dvbe vss npn13G2 we=0.07u le=0.9u Nx=1 m=1
Q76_u20 c2 vbe dvbe vss npn13G2 we=0.07u le=0.9u Nx=1 m=1
Q76_u21 c2 vbe dvbe vss npn13G2 we=0.07u le=0.9u Nx=1 m=1
Q76_u22 c2 vbe dvbe vss npn13G2 we=0.07u le=0.9u Nx=1 m=1
Q76_u23 c2 vbe dvbe vss npn13G2 we=0.07u le=0.9u Nx=1 m=1
Q76_u24 c2 vbe dvbe vss npn13G2 we=0.07u le=0.9u Nx=1 m=1
R77_u2 n_4 pbias vss rppd w=1u l=50u b=0 m=1
R77_u3 n_4 pbias vss rppd w=1u l=50u b=0 m=1
R77_u4 n_4 pbias vss rppd w=1u l=50u b=0 m=1
R77_u5 n_4 pbias vss rppd w=1u l=50u b=0 m=1
R77_u6 n_4 pbias vss rppd w=1u l=50u b=0 m=1
R77_u7 n_4 pbias vss rppd w=1u l=50u b=0 m=1
R77_u8 n_4 pbias vss rppd w=1u l=50u b=0 m=1
R77_u9 n_4 pbias vss rppd w=1u l=50u b=0 m=1
R77_u10 n_4 pbias vss rppd w=1u l=50u b=0 m=1
R77_u11 n_4 pbias vss rppd w=1u l=50u b=0 m=1
R77_u12 n_4 pbias vss rppd w=1u l=50u b=0 m=1
R77_u13 n_4 pbias vss rppd w=1u l=50u b=0 m=1
R77_u14 n_4 pbias vss rppd w=1u l=50u b=0 m=1
R77_u15 n_4 pbias vss rppd w=1u l=50u b=0 m=1
R77_u16 n_4 pbias vss rppd w=1u l=50u b=0 m=1
R77_u17 n_4 pbias vss rppd w=1u l=50u b=0 m=1
R77_u18 n_4 pbias vss rppd w=1u l=50u b=0 m=1
R77_u19 n_4 pbias vss rppd w=1u l=50u b=0 m=1
R77_u20 n_4 pbias vss rppd w=1u l=50u b=0 m=1
R77_u21 n_4 pbias vss rppd w=1u l=50u b=0 m=1
R77_u22 n_4 pbias vss rppd w=1u l=50u b=0 m=1
R77_u23 n_4 pbias vss rppd w=1u l=50u b=0 m=1
R77_u24 n_4 pbias vss rppd w=1u l=50u b=0 m=1
R78_u2 n_11 n_34 vss rppd w=1u l=50u b=0 m=1
R78_u3 n_11 n_34 vss rppd w=1u l=50u b=0 m=1
R78_u4 n_11 n_34 vss rppd w=1u l=50u b=0 m=1
R78_u5 n_11 n_34 vss rppd w=1u l=50u b=0 m=1
R78_u6 n_11 n_34 vss rppd w=1u l=50u b=0 m=1
R78_u7 n_11 n_34 vss rppd w=1u l=50u b=0 m=1
R78_u8 n_11 n_34 vss rppd w=1u l=50u b=0 m=1
R78_u9 n_11 n_34 vss rppd w=1u l=50u b=0 m=1
R78_u10 n_11 n_34 vss rppd w=1u l=50u b=0 m=1
R78_u11 n_11 n_34 vss rppd w=1u l=50u b=0 m=1
R78_u12 n_11 n_34 vss rppd w=1u l=50u b=0 m=1
R78_u13 n_11 n_34 vss rppd w=1u l=50u b=0 m=1
R78_u14 n_11 n_34 vss rppd w=1u l=50u b=0 m=1
R78_u15 n_11 n_34 vss rppd w=1u l=50u b=0 m=1
R78_u16 n_11 n_34 vss rppd w=1u l=50u b=0 m=1
R78_u17 n_11 n_34 vss rppd w=1u l=50u b=0 m=1
R78_u18 n_11 n_34 vss rppd w=1u l=50u b=0 m=1
R78_u19 n_11 n_34 vss rppd w=1u l=50u b=0 m=1
R78_u20 n_11 n_34 vss rppd w=1u l=50u b=0 m=1
R78_u21 n_11 n_34 vss rppd w=1u l=50u b=0 m=1
R78_u22 n_11 n_34 vss rppd w=1u l=50u b=0 m=1
R78_u23 n_11 n_34 vss rppd w=1u l=50u b=0 m=1
R78_u24 n_11 n_34 vss rppd w=1u l=50u b=0 m=1
R79_u2 n_10 n_34 vss rppd w=1u l=50u b=0 m=1
R79_u3 n_10 n_34 vss rppd w=1u l=50u b=0 m=1
R79_u4 n_10 n_34 vss rppd w=1u l=50u b=0 m=1
R79_u5 n_10 n_34 vss rppd w=1u l=50u b=0 m=1
R79_u6 n_10 n_34 vss rppd w=1u l=50u b=0 m=1
R79_u7 n_10 n_34 vss rppd w=1u l=50u b=0 m=1
R79_u8 n_10 n_34 vss rppd w=1u l=50u b=0 m=1
R79_u9 n_10 n_34 vss rppd w=1u l=50u b=0 m=1
R79_u10 n_10 n_34 vss rppd w=1u l=50u b=0 m=1
R79_u11 n_10 n_34 vss rppd w=1u l=50u b=0 m=1
R79_u12 n_10 n_34 vss rppd w=1u l=50u b=0 m=1
R79_u13 n_10 n_34 vss rppd w=1u l=50u b=0 m=1
R79_u14 n_10 n_34 vss rppd w=1u l=50u b=0 m=1
R79_u15 n_10 n_34 vss rppd w=1u l=50u b=0 m=1
R79_u16 n_10 n_34 vss rppd w=1u l=50u b=0 m=1
R79_u17 n_10 n_34 vss rppd w=1u l=50u b=0 m=1
R79_u18 n_10 n_34 vss rppd w=1u l=50u b=0 m=1
R79_u19 n_10 n_34 vss rppd w=1u l=50u b=0 m=1
R79_u20 n_10 n_34 vss rppd w=1u l=50u b=0 m=1
R79_u21 n_10 n_34 vss rppd w=1u l=50u b=0 m=1
R79_u22 n_10 n_34 vss rppd w=1u l=50u b=0 m=1
R79_u23 n_10 n_34 vss rppd w=1u l=50u b=0 m=1
R79_u24 n_10 n_34 vss rppd w=1u l=50u b=0 m=1
R80_u2 n_3 n_31 vss rppd w=1u l=50u b=0 m=1
R80_u3 n_3 n_31 vss rppd w=1u l=50u b=0 m=1
R80_u4 n_3 n_31 vss rppd w=1u l=50u b=0 m=1
R80_u5 n_3 n_31 vss rppd w=1u l=50u b=0 m=1
R80_u6 n_3 n_31 vss rppd w=1u l=50u b=0 m=1
R80_u7 n_3 n_31 vss rppd w=1u l=50u b=0 m=1
R80_u8 n_3 n_31 vss rppd w=1u l=50u b=0 m=1
R80_u9 n_3 n_31 vss rppd w=1u l=50u b=0 m=1
R80_u10 n_3 n_31 vss rppd w=1u l=50u b=0 m=1
R80_u11 n_3 n_31 vss rppd w=1u l=50u b=0 m=1
R80_u12 n_3 n_31 vss rppd w=1u l=50u b=0 m=1
R80_u13 n_3 n_31 vss rppd w=1u l=50u b=0 m=1
R80_u14 n_3 n_31 vss rppd w=1u l=50u b=0 m=1
R80_u15 n_3 n_31 vss rppd w=1u l=50u b=0 m=1
R80_u16 n_3 n_31 vss rppd w=1u l=50u b=0 m=1
R80_u17 n_3 n_31 vss rppd w=1u l=50u b=0 m=1
R80_u18 n_3 n_31 vss rppd w=1u l=50u b=0 m=1
R80_u19 n_3 n_31 vss rppd w=1u l=50u b=0 m=1
R80_u20 n_3 n_31 vss rppd w=1u l=50u b=0 m=1
R80_u21 n_3 n_31 vss rppd w=1u l=50u b=0 m=1
R80_u22 n_3 n_31 vss rppd w=1u l=50u b=0 m=1
R80_u23 n_3 n_31 vss rppd w=1u l=50u b=0 m=1
R80_u24 n_3 n_31 vss rppd w=1u l=50u b=0 m=1
R81_u2 n_10 n_33 vss rppd w=1u l=50u b=0 m=1
R81_u3 n_10 n_33 vss rppd w=1u l=50u b=0 m=1
R81_u4 n_10 n_33 vss rppd w=1u l=50u b=0 m=1
R81_u5 n_10 n_33 vss rppd w=1u l=50u b=0 m=1
R81_u6 n_10 n_33 vss rppd w=1u l=50u b=0 m=1
R81_u7 n_10 n_33 vss rppd w=1u l=50u b=0 m=1
R81_u8 n_10 n_33 vss rppd w=1u l=50u b=0 m=1
R81_u9 n_10 n_33 vss rppd w=1u l=50u b=0 m=1
R81_u10 n_10 n_33 vss rppd w=1u l=50u b=0 m=1
R81_u11 n_10 n_33 vss rppd w=1u l=50u b=0 m=1
R81_u12 n_10 n_33 vss rppd w=1u l=50u b=0 m=1
R81_u13 n_10 n_33 vss rppd w=1u l=50u b=0 m=1
R81_u14 n_10 n_33 vss rppd w=1u l=50u b=0 m=1
R81_u15 n_10 n_33 vss rppd w=1u l=50u b=0 m=1
R81_u16 n_10 n_33 vss rppd w=1u l=50u b=0 m=1
R81_u17 n_10 n_33 vss rppd w=1u l=50u b=0 m=1
R81_u18 n_10 n_33 vss rppd w=1u l=50u b=0 m=1
R81_u19 n_10 n_33 vss rppd w=1u l=50u b=0 m=1
R81_u20 n_10 n_33 vss rppd w=1u l=50u b=0 m=1
R81_u21 n_10 n_33 vss rppd w=1u l=50u b=0 m=1
R81_u22 n_10 n_33 vss rppd w=1u l=50u b=0 m=1
R81_u23 n_10 n_33 vss rppd w=1u l=50u b=0 m=1
R81_u24 n_10 n_33 vss rppd w=1u l=50u b=0 m=1
R82_u2 n_5 n_31 vss rppd w=1u l=50u b=0 m=1
R82_u3 n_5 n_31 vss rppd w=1u l=50u b=0 m=1
R82_u4 n_5 n_31 vss rppd w=1u l=50u b=0 m=1
R82_u5 n_5 n_31 vss rppd w=1u l=50u b=0 m=1
R82_u6 n_5 n_31 vss rppd w=1u l=50u b=0 m=1
R82_u7 n_5 n_31 vss rppd w=1u l=50u b=0 m=1
R82_u8 n_5 n_31 vss rppd w=1u l=50u b=0 m=1
R82_u9 n_5 n_31 vss rppd w=1u l=50u b=0 m=1
R82_u10 n_5 n_31 vss rppd w=1u l=50u b=0 m=1
R82_u11 n_5 n_31 vss rppd w=1u l=50u b=0 m=1
R82_u12 n_5 n_31 vss rppd w=1u l=50u b=0 m=1
R82_u13 n_5 n_31 vss rppd w=1u l=50u b=0 m=1
R82_u14 n_5 n_31 vss rppd w=1u l=50u b=0 m=1
R82_u15 n_5 n_31 vss rppd w=1u l=50u b=0 m=1
R82_u16 n_5 n_31 vss rppd w=1u l=50u b=0 m=1
R82_u17 n_5 n_31 vss rppd w=1u l=50u b=0 m=1
R82_u18 n_5 n_31 vss rppd w=1u l=50u b=0 m=1
R82_u19 n_5 n_31 vss rppd w=1u l=50u b=0 m=1
R82_u20 n_5 n_31 vss rppd w=1u l=50u b=0 m=1
R82_u21 n_5 n_31 vss rppd w=1u l=50u b=0 m=1
R82_u22 n_5 n_31 vss rppd w=1u l=50u b=0 m=1
R82_u23 n_5 n_31 vss rppd w=1u l=50u b=0 m=1
R82_u24 n_5 n_31 vss rppd w=1u l=50u b=0 m=1
R83_u2 n_5 n_30 vss rppd w=1u l=50u b=0 m=1
R83_u3 n_5 n_30 vss rppd w=1u l=50u b=0 m=1
R83_u4 n_5 n_30 vss rppd w=1u l=50u b=0 m=1
R83_u5 n_5 n_30 vss rppd w=1u l=50u b=0 m=1
R83_u6 n_5 n_30 vss rppd w=1u l=50u b=0 m=1
R83_u7 n_5 n_30 vss rppd w=1u l=50u b=0 m=1
R83_u8 n_5 n_30 vss rppd w=1u l=50u b=0 m=1
R83_u9 n_5 n_30 vss rppd w=1u l=50u b=0 m=1
R83_u10 n_5 n_30 vss rppd w=1u l=50u b=0 m=1
R83_u11 n_5 n_30 vss rppd w=1u l=50u b=0 m=1
R83_u12 n_5 n_30 vss rppd w=1u l=50u b=0 m=1
R83_u13 n_5 n_30 vss rppd w=1u l=50u b=0 m=1
R83_u14 n_5 n_30 vss rppd w=1u l=50u b=0 m=1
R83_u15 n_5 n_30 vss rppd w=1u l=50u b=0 m=1
R83_u16 n_5 n_30 vss rppd w=1u l=50u b=0 m=1
R83_u17 n_5 n_30 vss rppd w=1u l=50u b=0 m=1
R83_u18 n_5 n_30 vss rppd w=1u l=50u b=0 m=1
R83_u19 n_5 n_30 vss rppd w=1u l=50u b=0 m=1
R83_u20 n_5 n_30 vss rppd w=1u l=50u b=0 m=1
R83_u21 n_5 n_30 vss rppd w=1u l=50u b=0 m=1
R83_u22 n_5 n_30 vss rppd w=1u l=50u b=0 m=1
R83_u23 n_5 n_30 vss rppd w=1u l=50u b=0 m=1
R83_u24 n_5 n_30 vss rppd w=1u l=50u b=0 m=1
R84_u2 n_4 n_30 vss rppd w=1u l=50u b=0 m=1
R84_u3 n_4 n_30 vss rppd w=1u l=50u b=0 m=1
R84_u4 n_4 n_30 vss rppd w=1u l=50u b=0 m=1
R84_u5 n_4 n_30 vss rppd w=1u l=50u b=0 m=1
R84_u6 n_4 n_30 vss rppd w=1u l=50u b=0 m=1
R84_u7 n_4 n_30 vss rppd w=1u l=50u b=0 m=1
R84_u8 n_4 n_30 vss rppd w=1u l=50u b=0 m=1
R84_u9 n_4 n_30 vss rppd w=1u l=50u b=0 m=1
R84_u10 n_4 n_30 vss rppd w=1u l=50u b=0 m=1
R84_u11 n_4 n_30 vss rppd w=1u l=50u b=0 m=1
R84_u12 n_4 n_30 vss rppd w=1u l=50u b=0 m=1
R84_u13 n_4 n_30 vss rppd w=1u l=50u b=0 m=1
R84_u14 n_4 n_30 vss rppd w=1u l=50u b=0 m=1
R84_u15 n_4 n_30 vss rppd w=1u l=50u b=0 m=1
R84_u16 n_4 n_30 vss rppd w=1u l=50u b=0 m=1
R84_u17 n_4 n_30 vss rppd w=1u l=50u b=0 m=1
R84_u18 n_4 n_30 vss rppd w=1u l=50u b=0 m=1
R84_u19 n_4 n_30 vss rppd w=1u l=50u b=0 m=1
R84_u20 n_4 n_30 vss rppd w=1u l=50u b=0 m=1
R84_u21 n_4 n_30 vss rppd w=1u l=50u b=0 m=1
R84_u22 n_4 n_30 vss rppd w=1u l=50u b=0 m=1
R84_u23 n_4 n_30 vss rppd w=1u l=50u b=0 m=1
R84_u24 n_4 n_30 vss rppd w=1u l=50u b=0 m=1
R85_u2 n_3 n_33 vss rppd w=1u l=50u b=0 m=1
R85_u3 n_3 n_33 vss rppd w=1u l=50u b=0 m=1
R85_u4 n_3 n_33 vss rppd w=1u l=50u b=0 m=1
R85_u5 n_3 n_33 vss rppd w=1u l=50u b=0 m=1
R85_u6 n_3 n_33 vss rppd w=1u l=50u b=0 m=1
R85_u7 n_3 n_33 vss rppd w=1u l=50u b=0 m=1
R85_u8 n_3 n_33 vss rppd w=1u l=50u b=0 m=1
R85_u9 n_3 n_33 vss rppd w=1u l=50u b=0 m=1
R85_u10 n_3 n_33 vss rppd w=1u l=50u b=0 m=1
R85_u11 n_3 n_33 vss rppd w=1u l=50u b=0 m=1
R85_u12 n_3 n_33 vss rppd w=1u l=50u b=0 m=1
R85_u13 n_3 n_33 vss rppd w=1u l=50u b=0 m=1
R85_u14 n_3 n_33 vss rppd w=1u l=50u b=0 m=1
R85_u15 n_3 n_33 vss rppd w=1u l=50u b=0 m=1
R85_u16 n_3 n_33 vss rppd w=1u l=50u b=0 m=1
R85_u17 n_3 n_33 vss rppd w=1u l=50u b=0 m=1
R85_u18 n_3 n_33 vss rppd w=1u l=50u b=0 m=1
R85_u19 n_3 n_33 vss rppd w=1u l=50u b=0 m=1
R85_u20 n_3 n_33 vss rppd w=1u l=50u b=0 m=1
R85_u21 n_3 n_33 vss rppd w=1u l=50u b=0 m=1
R85_u22 n_3 n_33 vss rppd w=1u l=50u b=0 m=1
R85_u23 n_3 n_33 vss rppd w=1u l=50u b=0 m=1
R85_u24 n_3 n_33 vss rppd w=1u l=50u b=0 m=1
R86_u2 n_11 pcasc vss rppd w=1u l=50u b=0 m=1
R86_u3 n_11 pcasc vss rppd w=1u l=50u b=0 m=1
R86_u4 n_11 pcasc vss rppd w=1u l=50u b=0 m=1
R86_u5 n_11 pcasc vss rppd w=1u l=50u b=0 m=1
R86_u6 n_11 pcasc vss rppd w=1u l=50u b=0 m=1
R86_u7 n_11 pcasc vss rppd w=1u l=50u b=0 m=1
R86_u8 n_11 pcasc vss rppd w=1u l=50u b=0 m=1
R86_u9 n_11 pcasc vss rppd w=1u l=50u b=0 m=1
R86_u10 n_11 pcasc vss rppd w=1u l=50u b=0 m=1
R86_u11 n_11 pcasc vss rppd w=1u l=50u b=0 m=1
R86_u12 n_11 pcasc vss rppd w=1u l=50u b=0 m=1
R86_u13 n_11 pcasc vss rppd w=1u l=50u b=0 m=1
R86_u14 n_11 pcasc vss rppd w=1u l=50u b=0 m=1
R86_u15 n_11 pcasc vss rppd w=1u l=50u b=0 m=1
R86_u16 n_11 pcasc vss rppd w=1u l=50u b=0 m=1
R86_u17 n_11 pcasc vss rppd w=1u l=50u b=0 m=1
R86_u18 n_11 pcasc vss rppd w=1u l=50u b=0 m=1
R86_u19 n_11 pcasc vss rppd w=1u l=50u b=0 m=1
R86_u20 n_11 pcasc vss rppd w=1u l=50u b=0 m=1
R86_u21 n_11 pcasc vss rppd w=1u l=50u b=0 m=1
R86_u22 n_11 pcasc vss rppd w=1u l=50u b=0 m=1
R86_u23 n_11 pcasc vss rppd w=1u l=50u b=0 m=1
R86_u24 n_11 pcasc vss rppd w=1u l=50u b=0 m=1
.ends g1_bgr
