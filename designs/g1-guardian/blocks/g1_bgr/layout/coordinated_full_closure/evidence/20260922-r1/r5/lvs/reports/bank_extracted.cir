* Extracted by KLayout with SG13G2 LVS runset on : 22/09/2026 21:30

.SUBCKT g1_bgr dvbe iptat pbias pcasc r4 vbe vdd vref vss
R$1 \$8 vref vss rppd w=1u l=320.79u ps=0u b=0 m=4
R$25 vss \$3 vss rhigh w=0.5u l=735u ps=0u b=0 m=1
R$40 vss dvbe vss rppd w=1u l=51.5u ps=0u b=0 m=24
R$64 \$10 \$9 vss rppd w=1u l=192u ps=0u b=0 m=24
R$209 pcasc pbias vss rppd w=1u l=500u ps=0u b=0 m=24
M$400 vdd r4 \$I9 vdd sg13_hv_pmos L=0.5u W=2u AS=0.68p AD=0.68p PS=4.68u
+ PD=4.68u rfmode=0
M$401 \$12 r4 vbe vss sg13_hv_nmos L=0.5u W=2u AS=0.68p AD=0.68p PS=4.68u
+ PD=4.68u rfmode=0
M$402 \$I4 pcasc iptat \$I4 sg13_hv_pmos L=4u W=10u AS=3.4p AD=3.4p PS=20.68u
+ PD=20.68u rfmode=0
M$403 vdd \$3 \$I8 vdd sg13_hv_pmos L=0.5u W=2u AS=0.68p AD=0.68p PS=4.68u
+ PD=4.68u rfmode=0
M$404 \$I2 pcasc \$I5 \$I2 sg13_hv_pmos L=4u W=240u AS=81.6p AD=81.6p
+ PS=496.32u PD=496.32u rfmode=0
M$428 vss \$I9 \$12 vss sg13_hv_nmos L=0.6u W=1u AS=0.34p AD=0.34p PS=2.68u
+ PD=2.68u rfmode=0
M$429 \$I3 pcasc vref \$I3 sg13_hv_pmos L=4u W=40u AS=13.6p AD=13.6p PS=82.72u
+ PD=82.72u rfmode=0
M$433 vss \$I8 pbias vss sg13_hv_nmos L=4u W=1u AS=0.34p AD=0.34p PS=2.68u
+ PD=2.68u rfmode=0
M$434 vss \$3 \$I8 vss sg13_hv_nmos L=0.6u W=1u AS=0.34p AD=0.34p PS=2.68u
+ PD=2.68u rfmode=0
M$435 vss r4 \$I9 vss sg13_hv_nmos L=0.5u W=1u AS=0.34p AD=0.34p PS=2.68u
+ PD=2.68u rfmode=0
M$436 \$I5 \$9 vbe vss sg13_hv_nmos L=1u W=480u AS=163.2p AD=163.2p PS=992.64u
+ PD=992.64u rfmode=0
M$460 vdd pbias \$I3 vdd sg13_hv_pmos L=4u W=40u AS=13.6p AD=13.6p PS=85.44u
+ PD=85.44u rfmode=0
M$468 vdd pbias \$I4 vdd sg13_hv_pmos L=4u W=10u AS=3.4p AD=3.4p PS=21.36u
+ PD=21.36u rfmode=0
M$470 vdd pbias \$3 vdd sg13_hv_pmos L=4u W=10u AS=3.4p AD=3.4p PS=21.36u
+ PD=21.36u rfmode=0
M$496 \$13 \$9 pcasc vss sg13_hv_nmos L=1u W=480u AS=163.2p AD=163.2p
+ PS=992.64u PD=992.64u rfmode=0
M$520 \$I6 pcasc \$9 \$I6 sg13_hv_pmos L=4u W=240u AS=81.6p AD=81.6p PS=496.32u
+ PD=496.32u rfmode=0
M$544 \$I7 pcasc pbias \$I7 sg13_hv_pmos L=4u W=240u AS=81.6p AD=81.6p
+ PS=496.32u PD=496.32u rfmode=0
M$568 vdd pbias \$I2 vdd sg13_hv_pmos L=4u W=240u AS=81.6p AD=81.6p PS=512.64u
+ PD=512.64u rfmode=0
M$616 vdd pbias \$I7 vdd sg13_hv_pmos L=4u W=240u AS=81.6p AD=81.6p PS=512.64u
+ PD=512.64u rfmode=0
M$664 vdd pbias \$I6 vdd sg13_hv_pmos L=4u W=240u AS=81.6p AD=81.6p PS=512.64u
+ PD=512.64u rfmode=0
Q$736 \$I10 \$I10 vss vss npn13G2 we=70n le=900n Nx=1 m=24
Q$760 vbe vbe vss vss npn13G2 we=70n le=900n Nx=1 m=24
Q$784 vbe \$12 vss vss npn13G2 we=70n le=900n Nx=1 m=24
Q$808 \$13 vbe dvbe vss npn13G2 we=70n le=900n Nx=1 m=192
Q$1000 \$10 \$10 \$I10 vss npn13G2 we=70n le=900n Nx=1 m=24
Q$1024 \$8 \$8 vss vss npn13G2 we=70n le=900n Nx=1 m=4
Q$1028 vss vss vss vss npn13G2 we=70n le=900n Nx=1 m=9
.ENDS g1_bgr
