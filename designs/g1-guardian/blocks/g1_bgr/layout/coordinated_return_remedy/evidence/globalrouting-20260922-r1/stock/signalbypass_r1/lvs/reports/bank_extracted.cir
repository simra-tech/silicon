* Extracted by KLayout with SG13G2 LVS runset on : 23/09/2026 00:56

.SUBCKT g1_bgr dvbe iptat pbias pcasc r4 vbe vdd vref vss
R$1 \$16 vref vss rppd w=1u l=320.79u ps=0u b=0 m=4
R$25 vss \$10 vss rhigh w=0.5u l=735u ps=0u b=0 m=1
R$40 vss dvbe vss rppd w=1u l=51.5u ps=0u b=0 m=24
R$64 \$17 \$18 vss rppd w=1u l=192u ps=0u b=0 m=24
R$209 pcasc pbias vss rppd w=1u l=500u ps=0u b=0 m=24
M$400 vdd r4 \$I11 vdd sg13_hv_pmos L=0.5u W=2u AS=0.68p AD=0.68p PS=4.68u
+ PD=4.68u rfmode=0
M$401 \$20 r4 vbe vss sg13_hv_nmos L=0.5u W=2u AS=0.68p AD=0.68p PS=4.68u
+ PD=4.68u rfmode=0
M$402 \$I6 pcasc iptat \$I6 sg13_hv_pmos L=4u W=10u AS=3.4p AD=3.4p PS=20.68u
+ PD=20.68u rfmode=0
M$403 vdd \$10 \$I10 vdd sg13_hv_pmos L=0.5u W=2u AS=0.68p AD=0.68p PS=4.68u
+ PD=4.68u rfmode=0
M$404 \$I4 pcasc \$I7 \$I4 sg13_hv_pmos L=4u W=240u AS=81.6p AD=81.6p
+ PS=496.32u PD=496.32u rfmode=0
M$428 vss \$I11 \$20 vss sg13_hv_nmos L=0.6u W=1u AS=0.34p AD=0.34p PS=2.68u
+ PD=2.68u rfmode=0
M$429 \$I5 pcasc vref \$I5 sg13_hv_pmos L=4u W=40u AS=13.6p AD=13.6p PS=82.72u
+ PD=82.72u rfmode=0
M$433 vss \$I10 pbias vss sg13_hv_nmos L=4u W=1u AS=0.34p AD=0.34p PS=2.68u
+ PD=2.68u rfmode=0
M$434 vss \$10 \$I10 vss sg13_hv_nmos L=0.6u W=1u AS=0.34p AD=0.34p PS=2.68u
+ PD=2.68u rfmode=0
M$435 vss r4 \$I11 vss sg13_hv_nmos L=0.5u W=1u AS=0.34p AD=0.34p PS=2.68u
+ PD=2.68u rfmode=0
M$436 \$I7 \$18 vbe vss sg13_hv_nmos L=1u W=480u AS=163.2p AD=163.2p PS=992.64u
+ PD=992.64u rfmode=0
M$460 vdd pbias \$I5 vdd sg13_hv_pmos L=4u W=40u AS=13.6p AD=13.6p PS=85.44u
+ PD=85.44u rfmode=0
M$468 vdd pbias \$I6 vdd sg13_hv_pmos L=4u W=10u AS=3.4p AD=3.4p PS=21.36u
+ PD=21.36u rfmode=0
M$470 vdd pbias \$10 vdd sg13_hv_pmos L=4u W=10u AS=3.4p AD=3.4p PS=21.36u
+ PD=21.36u rfmode=0
M$496 \$21 \$18 pcasc vss sg13_hv_nmos L=1u W=480u AS=163.2p AD=163.2p
+ PS=992.64u PD=992.64u rfmode=0
M$520 \$I8 pcasc \$18 \$I8 sg13_hv_pmos L=4u W=240u AS=81.6p AD=81.6p
+ PS=496.32u PD=496.32u rfmode=0
M$544 \$I9 pcasc pbias \$I9 sg13_hv_pmos L=4u W=240u AS=81.6p AD=81.6p
+ PS=496.32u PD=496.32u rfmode=0
M$568 vdd pbias \$I4 vdd sg13_hv_pmos L=4u W=240u AS=81.6p AD=81.6p PS=512.64u
+ PD=512.64u rfmode=0
M$616 vdd pbias \$I9 vdd sg13_hv_pmos L=4u W=240u AS=81.6p AD=81.6p PS=512.64u
+ PD=512.64u rfmode=0
M$664 vdd pbias \$I8 vdd sg13_hv_pmos L=4u W=240u AS=81.6p AD=81.6p PS=512.64u
+ PD=512.64u rfmode=0
Q$736 \$I12 \$I12 vss vss npn13G2 we=70n le=900n Nx=1 m=24
Q$760 vbe vbe vss vss npn13G2 we=70n le=900n Nx=1 m=24
Q$784 vbe \$20 vss vss npn13G2 we=70n le=900n Nx=1 m=24
Q$808 \$21 vbe dvbe vss npn13G2 we=70n le=900n Nx=1 m=192
Q$1000 \$17 \$17 \$I12 vss npn13G2 we=70n le=900n Nx=1 m=24
Q$1024 \$16 \$16 vss vss npn13G2 we=70n le=900n Nx=1 m=4
Q$1028 vss vss vss vss npn13G2 we=70n le=900n Nx=1 m=9
.ENDS g1_bgr
