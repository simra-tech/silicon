* Extracted by KLayout with SG13G2 LVS runset on : 22/09/2026 23:31

.SUBCKT g1_bgr dvbe iptat pbias pcasc r4 vbe vdd vref vss
M$1 \$570 r4 vbe vss sg13_hv_nmos L=0.5u W=2u AS=0.68p AD=0.68p PS=4.68u
+ PD=4.68u rfmode=0
M$2 vss \$800 pbias vss sg13_hv_nmos L=4u W=1u AS=0.34p AD=0.34p PS=2.68u
+ PD=2.68u rfmode=0
M$3 vss \$10 \$800 vss sg13_hv_nmos L=0.6u W=1u AS=0.34p AD=0.34p PS=2.68u
+ PD=2.68u rfmode=0
M$4 vss r4 \$818 vss sg13_hv_nmos L=0.5u W=1u AS=0.34p AD=0.34p PS=2.68u
+ PD=2.68u rfmode=0
M$5 vss \$818 \$570 vss sg13_hv_nmos L=0.6u W=1u AS=0.34p AD=0.34p PS=2.68u
+ PD=2.68u rfmode=0
M$6 vbe \$235 \$445 vss sg13_hv_nmos L=1u W=480u AS=163.2p AD=163.2p PS=992.64u
+ PD=992.64u rfmode=0
M$18 pcasc \$235 \$748 vss sg13_hv_nmos L=1u W=480u AS=163.2p AD=163.2p
+ PS=992.64u PD=992.64u rfmode=0
M$102 \$497 pcasc \$235 \$497 sg13_hv_pmos L=4u W=240u AS=81.6p AD=81.6p
+ PS=496.32u PD=496.32u rfmode=0
M$114 \$442 pcasc \$445 \$442 sg13_hv_pmos L=4u W=240u AS=81.6p AD=81.6p
+ PS=496.32u PD=496.32u rfmode=0
M$126 \$656 pcasc pbias \$656 sg13_hv_pmos L=4u W=240u AS=81.6p AD=81.6p
+ PS=496.32u PD=496.32u rfmode=0
M$127 \$443 pcasc vref \$443 sg13_hv_pmos L=4u W=40u AS=13.6p AD=13.6p
+ PS=82.72u PD=82.72u rfmode=0
M$153 \$657 pcasc iptat \$657 sg13_hv_pmos L=4u W=10u AS=3.4p AD=3.4p PS=20.68u
+ PD=20.68u rfmode=0
M$156 vdd \$10 \$800 vdd sg13_hv_pmos L=0.5u W=2u AS=0.68p AD=0.68p PS=4.68u
+ PD=4.68u rfmode=0
M$158 vdd r4 \$818 vdd sg13_hv_pmos L=0.5u W=2u AS=0.68p AD=0.68p PS=4.68u
+ PD=4.68u rfmode=0
M$181 vdd pbias \$656 vdd sg13_hv_pmos L=4u W=240u AS=81.6p AD=81.6p PS=512.64u
+ PD=512.64u rfmode=0
M$182 vdd pbias \$442 vdd sg13_hv_pmos L=4u W=240u AS=81.6p AD=81.6p PS=512.64u
+ PD=512.64u rfmode=0
M$189 vdd pbias \$497 vdd sg13_hv_pmos L=4u W=240u AS=81.6p AD=81.6p PS=512.64u
+ PD=512.64u rfmode=0
M$253 vdd pbias \$443 vdd sg13_hv_pmos L=4u W=40u AS=13.6p AD=13.6p PS=85.44u
+ PD=85.44u rfmode=0
M$257 vdd pbias \$657 vdd sg13_hv_pmos L=4u W=10u AS=3.4p AD=3.4p PS=21.36u
+ PD=21.36u rfmode=0
M$258 vdd pbias \$10 vdd sg13_hv_pmos L=4u W=10u AS=3.4p AD=3.4p PS=21.36u
+ PD=21.36u rfmode=0
Q$337 vbe vbe vss vss npn13G2 we=70n le=900n Nx=1 m=24
Q$349 \$441 \$441 vss vss npn13G2 we=70n le=900n Nx=1 m=24
Q$361 vbe \$570 vss vss npn13G2 we=70n le=900n Nx=1 m=24
Q$373 \$748 vbe dvbe vss npn13G2 we=70n le=900n Nx=1 m=192
Q$457 \$237 \$237 \$441 vss npn13G2 we=70n le=900n Nx=1 m=24
Q$481 \$234 \$234 vss vss npn13G2 we=70n le=900n Nx=1 m=4
R$638 \$234 vref vss rppd w=1u l=320.79u ps=0u b=0 m=4
R$650 vss dvbe vss rppd w=1u l=51.5u ps=0u b=0 m=24
R$674 pcasc pbias vss rppd w=1u l=500u ps=0u b=0 m=24
R$830 \$237 \$235 vss rppd w=1u l=192u ps=0u b=0 m=24
R$1036 \$10 vss vss rhigh w=0.5u l=735u ps=0u b=0 m=1
.ENDS g1_bgr
