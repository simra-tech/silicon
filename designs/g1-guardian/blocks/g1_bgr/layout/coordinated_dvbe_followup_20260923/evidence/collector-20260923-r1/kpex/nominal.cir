* G1_BGR standalone capacitance-PEX qualification
.lib /foss/pdks/ihp-sg13g2/libs.tech/ngspice/models/cornerHBT.lib hbt_typ
.lib /foss/pdks/ihp-sg13g2/libs.tech/ngspice/models/cornerMOShv.lib mos_tt
.lib /foss/pdks/ihp-sg13g2/libs.tech/ngspice/models/cornerRES.lib res_typ
.include conditional_metal.spice
.option seed=44001 gmin=1e-15 abstol=1e-14 reltol=1e-5 vntol=1e-7
.global sub!
Vsub sub! 0 0
Vdd vdd 0 3.3
Vr4 r4 0 0
Xbgr vdd 0 r4 vref iptat pbias pcasc vbe dvbe g1_bgr
Vload iptat 0 1
Cload vref 0 1e-12
.control
set num_threads=1
set numdgt=15
set wr_singlescale
set wr_vecnames
op
echo RAW_CURRENT_LEDGER_BEGIN
print @n.xbgr.xr1.nr1[ibody]
print @n.xbgr.xr2.nr1[ibody]
print @n.xbgr.xr3.nr1[ibody]
print @n.xbgr.xr4.nr1[ibody]
print @n.xbgr.xr5.nr1[ibody]
print @n.xbgr.xr6.nr1[ibody]
print @n.xbgr.xr7.nr1[ibody]
print @n.xbgr.xr8.nr1[ibody]
print @n.xbgr.xr9.nr1[ibody]
print @n.xbgr.xr10.nr1[ibody]
print @n.xbgr.xr11.nr1[ibody]
print @n.xbgr.xr12.nr1[ibody]
print @n.xbgr.xr13.nr1[ibody]
print @n.xbgr.xr14.nr1[ibody]
print @n.xbgr.xr15.nr1[ibody]
print @n.xbgr.xr16.nr1[ibody]
print @n.xbgr.xr17.nr1[ibody]
print @n.xbgr.xr18.nr1[ibody]
print @n.xbgr.xr19.nr1[ibody]
print @n.xbgr.xr20.nr1[ibody]
print @n.xbgr.xr21.nr1[ibody]
print @n.xbgr.xr22.nr1[ibody]
print @n.xbgr.xr23.nr1[ibody]
print @n.xbgr.xr24.nr1[ibody]
print @n.xbgr.xr25.nr1[ibody]
print @n.xbgr.xr26.nr1[ibody]
print @n.xbgr.xm27.nsg13_hv_pmos[ide]
print @n.xbgr.xm27.nsg13_hv_pmos[ige]
print @n.xbgr.xm27.nsg13_hv_pmos[ise]
print @n.xbgr.xm27.nsg13_hv_pmos[ibe]
print @n.xbgr.xm27.nsg13_hv_pmos[ctype]
print @n.xbgr.xm28.nsg13_hv_pmos[ide]
print @n.xbgr.xm28.nsg13_hv_pmos[ige]
print @n.xbgr.xm28.nsg13_hv_pmos[ise]
print @n.xbgr.xm28.nsg13_hv_pmos[ibe]
print @n.xbgr.xm28.nsg13_hv_pmos[ctype]
print @n.xbgr.xm29.nsg13_hv_nmos[ide]
print @n.xbgr.xm29.nsg13_hv_nmos[ige]
print @n.xbgr.xm29.nsg13_hv_nmos[ise]
print @n.xbgr.xm29.nsg13_hv_nmos[ibe]
print @n.xbgr.xm29.nsg13_hv_nmos[ctype]
print @n.xbgr.xm30.nsg13_hv_nmos[ide]
print @n.xbgr.xm30.nsg13_hv_nmos[ige]
print @n.xbgr.xm30.nsg13_hv_nmos[ise]
print @n.xbgr.xm30.nsg13_hv_nmos[ibe]
print @n.xbgr.xm30.nsg13_hv_nmos[ctype]
print @n.xbgr.xm31.nsg13_hv_nmos[ide]
print @n.xbgr.xm31.nsg13_hv_nmos[ige]
print @n.xbgr.xm31.nsg13_hv_nmos[ise]
print @n.xbgr.xm31.nsg13_hv_nmos[ibe]
print @n.xbgr.xm31.nsg13_hv_nmos[ctype]
print @n.xbgr.xm32.nsg13_hv_nmos[ide]
print @n.xbgr.xm32.nsg13_hv_nmos[ige]
print @n.xbgr.xm32.nsg13_hv_nmos[ise]
print @n.xbgr.xm32.nsg13_hv_nmos[ibe]
print @n.xbgr.xm32.nsg13_hv_nmos[ctype]
print @n.xbgr.xm33.nsg13_hv_nmos[ide]
print @n.xbgr.xm33.nsg13_hv_nmos[ige]
print @n.xbgr.xm33.nsg13_hv_nmos[ise]
print @n.xbgr.xm33.nsg13_hv_nmos[ibe]
print @n.xbgr.xm33.nsg13_hv_nmos[ctype]
print @n.xbgr.xm34.nsg13_hv_nmos[ide]
print @n.xbgr.xm34.nsg13_hv_nmos[ige]
print @n.xbgr.xm34.nsg13_hv_nmos[ise]
print @n.xbgr.xm34.nsg13_hv_nmos[ibe]
print @n.xbgr.xm34.nsg13_hv_nmos[ctype]
print @n.xbgr.xm35.nsg13_hv_nmos[ide]
print @n.xbgr.xm35.nsg13_hv_nmos[ige]
print @n.xbgr.xm35.nsg13_hv_nmos[ise]
print @n.xbgr.xm35.nsg13_hv_nmos[ibe]
print @n.xbgr.xm35.nsg13_hv_nmos[ctype]
print @n.xbgr.xm36.nsg13_hv_nmos[ide]
print @n.xbgr.xm36.nsg13_hv_nmos[ige]
print @n.xbgr.xm36.nsg13_hv_nmos[ise]
print @n.xbgr.xm36.nsg13_hv_nmos[ibe]
print @n.xbgr.xm36.nsg13_hv_nmos[ctype]
print @n.xbgr.xm37.nsg13_hv_nmos[ide]
print @n.xbgr.xm37.nsg13_hv_nmos[ige]
print @n.xbgr.xm37.nsg13_hv_nmos[ise]
print @n.xbgr.xm37.nsg13_hv_nmos[ibe]
print @n.xbgr.xm37.nsg13_hv_nmos[ctype]
print @n.xbgr.xm38.nsg13_hv_pmos[ide]
print @n.xbgr.xm38.nsg13_hv_pmos[ige]
print @n.xbgr.xm38.nsg13_hv_pmos[ise]
print @n.xbgr.xm38.nsg13_hv_pmos[ibe]
print @n.xbgr.xm38.nsg13_hv_pmos[ctype]
print @n.xbgr.xm39.nsg13_hv_pmos[ide]
print @n.xbgr.xm39.nsg13_hv_pmos[ige]
print @n.xbgr.xm39.nsg13_hv_pmos[ise]
print @n.xbgr.xm39.nsg13_hv_pmos[ibe]
print @n.xbgr.xm39.nsg13_hv_pmos[ctype]
print @n.xbgr.xm40.nsg13_hv_pmos[ide]
print @n.xbgr.xm40.nsg13_hv_pmos[ige]
print @n.xbgr.xm40.nsg13_hv_pmos[ise]
print @n.xbgr.xm40.nsg13_hv_pmos[ibe]
print @n.xbgr.xm40.nsg13_hv_pmos[ctype]
print @n.xbgr.xm41.nsg13_hv_pmos[ide]
print @n.xbgr.xm41.nsg13_hv_pmos[ige]
print @n.xbgr.xm41.nsg13_hv_pmos[ise]
print @n.xbgr.xm41.nsg13_hv_pmos[ibe]
print @n.xbgr.xm41.nsg13_hv_pmos[ctype]
print @n.xbgr.xm42.nsg13_hv_pmos[ide]
print @n.xbgr.xm42.nsg13_hv_pmos[ige]
print @n.xbgr.xm42.nsg13_hv_pmos[ise]
print @n.xbgr.xm42.nsg13_hv_pmos[ibe]
print @n.xbgr.xm42.nsg13_hv_pmos[ctype]
print @n.xbgr.xm43.nsg13_hv_pmos[ide]
print @n.xbgr.xm43.nsg13_hv_pmos[ige]
print @n.xbgr.xm43.nsg13_hv_pmos[ise]
print @n.xbgr.xm43.nsg13_hv_pmos[ibe]
print @n.xbgr.xm43.nsg13_hv_pmos[ctype]
print @n.xbgr.xm44.nsg13_hv_pmos[ide]
print @n.xbgr.xm44.nsg13_hv_pmos[ige]
print @n.xbgr.xm44.nsg13_hv_pmos[ise]
print @n.xbgr.xm44.nsg13_hv_pmos[ibe]
print @n.xbgr.xm44.nsg13_hv_pmos[ctype]
print @n.xbgr.xm45.nsg13_hv_pmos[ide]
print @n.xbgr.xm45.nsg13_hv_pmos[ige]
print @n.xbgr.xm45.nsg13_hv_pmos[ise]
print @n.xbgr.xm45.nsg13_hv_pmos[ibe]
print @n.xbgr.xm45.nsg13_hv_pmos[ctype]
print @n.xbgr.xm46.nsg13_hv_pmos[ide]
print @n.xbgr.xm46.nsg13_hv_pmos[ige]
print @n.xbgr.xm46.nsg13_hv_pmos[ise]
print @n.xbgr.xm46.nsg13_hv_pmos[ibe]
print @n.xbgr.xm46.nsg13_hv_pmos[ctype]
print @n.xbgr.xm47.nsg13_hv_pmos[ide]
print @n.xbgr.xm47.nsg13_hv_pmos[ige]
print @n.xbgr.xm47.nsg13_hv_pmos[ise]
print @n.xbgr.xm47.nsg13_hv_pmos[ibe]
print @n.xbgr.xm47.nsg13_hv_pmos[ctype]
print @n.xbgr.xm48.nsg13_hv_pmos[ide]
print @n.xbgr.xm48.nsg13_hv_pmos[ige]
print @n.xbgr.xm48.nsg13_hv_pmos[ise]
print @n.xbgr.xm48.nsg13_hv_pmos[ibe]
print @n.xbgr.xm48.nsg13_hv_pmos[ctype]
print @n.xbgr.xm49.nsg13_hv_pmos[ide]
print @n.xbgr.xm49.nsg13_hv_pmos[ige]
print @n.xbgr.xm49.nsg13_hv_pmos[ise]
print @n.xbgr.xm49.nsg13_hv_pmos[ibe]
print @n.xbgr.xm49.nsg13_hv_pmos[ctype]
print @n.xbgr.xm50.nsg13_hv_pmos[ide]
print @n.xbgr.xm50.nsg13_hv_pmos[ige]
print @n.xbgr.xm50.nsg13_hv_pmos[ise]
print @n.xbgr.xm50.nsg13_hv_pmos[ibe]
print @n.xbgr.xm50.nsg13_hv_pmos[ctype]
print @n.xbgr.xm51.nsg13_hv_pmos[ide]
print @n.xbgr.xm51.nsg13_hv_pmos[ige]
print @n.xbgr.xm51.nsg13_hv_pmos[ise]
print @n.xbgr.xm51.nsg13_hv_pmos[ibe]
print @n.xbgr.xm51.nsg13_hv_pmos[ctype]
print @n.xbgr.xm52.nsg13_hv_pmos[ide]
print @n.xbgr.xm52.nsg13_hv_pmos[ige]
print @n.xbgr.xm52.nsg13_hv_pmos[ise]
print @n.xbgr.xm52.nsg13_hv_pmos[ibe]
print @n.xbgr.xm52.nsg13_hv_pmos[ctype]
print @n.xbgr.xm53.nsg13_hv_pmos[ide]
print @n.xbgr.xm53.nsg13_hv_pmos[ige]
print @n.xbgr.xm53.nsg13_hv_pmos[ise]
print @n.xbgr.xm53.nsg13_hv_pmos[ibe]
print @n.xbgr.xm53.nsg13_hv_pmos[ctype]
print @n.xbgr.xm54.nsg13_hv_pmos[ide]
print @n.xbgr.xm54.nsg13_hv_pmos[ige]
print @n.xbgr.xm54.nsg13_hv_pmos[ise]
print @n.xbgr.xm54.nsg13_hv_pmos[ibe]
print @n.xbgr.xm54.nsg13_hv_pmos[ctype]
print @q.xbgr.xq55.qnpn13g2[ic]
print @q.xbgr.xq55.qnpn13g2[ib]
print @q.xbgr.xq55.qnpn13g2[ie]
print @q.xbgr.xq55.qnpn13g2[is]
print @r.xbgr.xq55.rsub[i]
print @c.xbgr.xq55.csub[i]
print @q.xbgr.xq56.qnpn13g2[ic]
print @q.xbgr.xq56.qnpn13g2[ib]
print @q.xbgr.xq56.qnpn13g2[ie]
print @q.xbgr.xq56.qnpn13g2[is]
print @r.xbgr.xq56.rsub[i]
print @c.xbgr.xq56.csub[i]
print @q.xbgr.xq57.qnpn13g2[ic]
print @q.xbgr.xq57.qnpn13g2[ib]
print @q.xbgr.xq57.qnpn13g2[ie]
print @q.xbgr.xq57.qnpn13g2[is]
print @r.xbgr.xq57.rsub[i]
print @c.xbgr.xq57.csub[i]
print @q.xbgr.xq58.qnpn13g2[ic]
print @q.xbgr.xq58.qnpn13g2[ib]
print @q.xbgr.xq58.qnpn13g2[ie]
print @q.xbgr.xq58.qnpn13g2[is]
print @r.xbgr.xq58.rsub[i]
print @c.xbgr.xq58.csub[i]
print @q.xbgr.xq59.qnpn13g2[ic]
print @q.xbgr.xq59.qnpn13g2[ib]
print @q.xbgr.xq59.qnpn13g2[ie]
print @q.xbgr.xq59.qnpn13g2[is]
print @r.xbgr.xq59.rsub[i]
print @c.xbgr.xq59.csub[i]
print @q.xbgr.xq60.qnpn13g2[ic]
print @q.xbgr.xq60.qnpn13g2[ib]
print @q.xbgr.xq60.qnpn13g2[ie]
print @q.xbgr.xq60.qnpn13g2[is]
print @r.xbgr.xq60.rsub[i]
print @c.xbgr.xq60.csub[i]
print @q.xbgr.xq61.qnpn13g2[ic]
print @q.xbgr.xq61.qnpn13g2[ib]
print @q.xbgr.xq61.qnpn13g2[ie]
print @q.xbgr.xq61.qnpn13g2[is]
print @r.xbgr.xq61.rsub[i]
print @c.xbgr.xq61.csub[i]
print @q.xbgr.xq62.qnpn13g2[ic]
print @q.xbgr.xq62.qnpn13g2[ib]
print @q.xbgr.xq62.qnpn13g2[ie]
print @q.xbgr.xq62.qnpn13g2[is]
print @r.xbgr.xq62.rsub[i]
print @c.xbgr.xq62.csub[i]
print @q.xbgr.xq63.qnpn13g2[ic]
print @q.xbgr.xq63.qnpn13g2[ib]
print @q.xbgr.xq63.qnpn13g2[ie]
print @q.xbgr.xq63.qnpn13g2[is]
print @r.xbgr.xq63.rsub[i]
print @c.xbgr.xq63.csub[i]
print @q.xbgr.xq64.qnpn13g2[ic]
print @q.xbgr.xq64.qnpn13g2[ib]
print @q.xbgr.xq64.qnpn13g2[ie]
print @q.xbgr.xq64.qnpn13g2[is]
print @r.xbgr.xq64.rsub[i]
print @c.xbgr.xq64.csub[i]
print @q.xbgr.xq65.qnpn13g2[ic]
print @q.xbgr.xq65.qnpn13g2[ib]
print @q.xbgr.xq65.qnpn13g2[ie]
print @q.xbgr.xq65.qnpn13g2[is]
print @r.xbgr.xq65.rsub[i]
print @c.xbgr.xq65.csub[i]
print @q.xbgr.xq66.qnpn13g2[ic]
print @q.xbgr.xq66.qnpn13g2[ib]
print @q.xbgr.xq66.qnpn13g2[ie]
print @q.xbgr.xq66.qnpn13g2[is]
print @r.xbgr.xq66.rsub[i]
print @c.xbgr.xq66.csub[i]
print @q.xbgr.xq67.qnpn13g2[ic]
print @q.xbgr.xq67.qnpn13g2[ib]
print @q.xbgr.xq67.qnpn13g2[ie]
print @q.xbgr.xq67.qnpn13g2[is]
print @r.xbgr.xq67.rsub[i]
print @c.xbgr.xq67.csub[i]
print @q.xbgr.xq68.qnpn13g2[ic]
print @q.xbgr.xq68.qnpn13g2[ib]
print @q.xbgr.xq68.qnpn13g2[ie]
print @q.xbgr.xq68.qnpn13g2[is]
print @r.xbgr.xq68.rsub[i]
print @c.xbgr.xq68.csub[i]
print @q.xbgr.xq69.qnpn13g2[ic]
print @q.xbgr.xq69.qnpn13g2[ib]
print @q.xbgr.xq69.qnpn13g2[ie]
print @q.xbgr.xq69.qnpn13g2[is]
print @r.xbgr.xq69.rsub[i]
print @c.xbgr.xq69.csub[i]
print @q.xbgr.xq70.qnpn13g2[ic]
print @q.xbgr.xq70.qnpn13g2[ib]
print @q.xbgr.xq70.qnpn13g2[ie]
print @q.xbgr.xq70.qnpn13g2[is]
print @r.xbgr.xq70.rsub[i]
print @c.xbgr.xq70.csub[i]
print @q.xbgr.xq71.qnpn13g2[ic]
print @q.xbgr.xq71.qnpn13g2[ib]
print @q.xbgr.xq71.qnpn13g2[ie]
print @q.xbgr.xq71.qnpn13g2[is]
print @r.xbgr.xq71.rsub[i]
print @c.xbgr.xq71.csub[i]
print @q.xbgr.xq72.qnpn13g2[ic]
print @q.xbgr.xq72.qnpn13g2[ib]
print @q.xbgr.xq72.qnpn13g2[ie]
print @q.xbgr.xq72.qnpn13g2[is]
print @r.xbgr.xq72.rsub[i]
print @c.xbgr.xq72.csub[i]
print @q.xbgr.xq73.qnpn13g2[ic]
print @q.xbgr.xq73.qnpn13g2[ib]
print @q.xbgr.xq73.qnpn13g2[ie]
print @q.xbgr.xq73.qnpn13g2[is]
print @r.xbgr.xq73.rsub[i]
print @c.xbgr.xq73.csub[i]
print @q.xbgr.xq74.qnpn13g2[ic]
print @q.xbgr.xq74.qnpn13g2[ib]
print @q.xbgr.xq74.qnpn13g2[ie]
print @q.xbgr.xq74.qnpn13g2[is]
print @r.xbgr.xq74.rsub[i]
print @c.xbgr.xq74.csub[i]
print @q.xbgr.xq75.qnpn13g2[ic]
print @q.xbgr.xq75.qnpn13g2[ib]
print @q.xbgr.xq75.qnpn13g2[ie]
print @q.xbgr.xq75.qnpn13g2[is]
print @r.xbgr.xq75.rsub[i]
print @c.xbgr.xq75.csub[i]
print @q.xbgr.xq76.qnpn13g2[ic]
print @q.xbgr.xq76.qnpn13g2[ib]
print @q.xbgr.xq76.qnpn13g2[ie]
print @q.xbgr.xq76.qnpn13g2[is]
print @r.xbgr.xq76.rsub[i]
print @c.xbgr.xq76.csub[i]
print @n.xbgr.xr77.nr1[ibody]
print @n.xbgr.xr78.nr1[ibody]
print @n.xbgr.xr79.nr1[ibody]
print @n.xbgr.xr80.nr1[ibody]
print @n.xbgr.xr81.nr1[ibody]
print @n.xbgr.xr82.nr1[ibody]
print @n.xbgr.xr83.nr1[ibody]
print @n.xbgr.xr84.nr1[ibody]
print @n.xbgr.xr85.nr1[ibody]
print @n.xbgr.xr86.nr1[ibody]
print @n.xbgr.xr16_u2.nr1[ibody]
print @n.xbgr.xr16_u3.nr1[ibody]
print @n.xbgr.xr16_u4.nr1[ibody]
print @n.xbgr.xr16_u5.nr1[ibody]
print @n.xbgr.xr16_u6.nr1[ibody]
print @n.xbgr.xr16_u7.nr1[ibody]
print @n.xbgr.xr16_u8.nr1[ibody]
print @n.xbgr.xr16_u9.nr1[ibody]
print @n.xbgr.xr16_u10.nr1[ibody]
print @n.xbgr.xr16_u11.nr1[ibody]
print @n.xbgr.xr16_u12.nr1[ibody]
print @n.xbgr.xr16_u13.nr1[ibody]
print @n.xbgr.xr16_u14.nr1[ibody]
print @n.xbgr.xr16_u15.nr1[ibody]
print @n.xbgr.xr16_u16.nr1[ibody]
print @n.xbgr.xr16_u17.nr1[ibody]
print @n.xbgr.xr16_u18.nr1[ibody]
print @n.xbgr.xr16_u19.nr1[ibody]
print @n.xbgr.xr16_u20.nr1[ibody]
print @n.xbgr.xr16_u21.nr1[ibody]
print @n.xbgr.xr16_u22.nr1[ibody]
print @n.xbgr.xr16_u23.nr1[ibody]
print @n.xbgr.xr16_u24.nr1[ibody]
print @n.xbgr.xr17_u2.nr1[ibody]
print @n.xbgr.xr17_u3.nr1[ibody]
print @n.xbgr.xr17_u4.nr1[ibody]
print @n.xbgr.xr18_u2.nr1[ibody]
print @n.xbgr.xr18_u3.nr1[ibody]
print @n.xbgr.xr18_u4.nr1[ibody]
print @n.xbgr.xr19_u2.nr1[ibody]
print @n.xbgr.xr19_u3.nr1[ibody]
print @n.xbgr.xr19_u4.nr1[ibody]
print @n.xbgr.xr20_u2.nr1[ibody]
print @n.xbgr.xr20_u3.nr1[ibody]
print @n.xbgr.xr20_u4.nr1[ibody]
print @n.xbgr.xr21_u2.nr1[ibody]
print @n.xbgr.xr21_u3.nr1[ibody]
print @n.xbgr.xr21_u4.nr1[ibody]
print @n.xbgr.xr22_u2.nr1[ibody]
print @n.xbgr.xr22_u3.nr1[ibody]
print @n.xbgr.xr22_u4.nr1[ibody]
print @n.xbgr.xr23_u2.nr1[ibody]
print @n.xbgr.xr23_u3.nr1[ibody]
print @n.xbgr.xr23_u4.nr1[ibody]
print @n.xbgr.xr23_u5.nr1[ibody]
print @n.xbgr.xr23_u6.nr1[ibody]
print @n.xbgr.xr23_u7.nr1[ibody]
print @n.xbgr.xr23_u8.nr1[ibody]
print @n.xbgr.xr23_u9.nr1[ibody]
print @n.xbgr.xr23_u10.nr1[ibody]
print @n.xbgr.xr23_u11.nr1[ibody]
print @n.xbgr.xr23_u12.nr1[ibody]
print @n.xbgr.xr23_u13.nr1[ibody]
print @n.xbgr.xr23_u14.nr1[ibody]
print @n.xbgr.xr23_u15.nr1[ibody]
print @n.xbgr.xr23_u16.nr1[ibody]
print @n.xbgr.xr23_u17.nr1[ibody]
print @n.xbgr.xr23_u18.nr1[ibody]
print @n.xbgr.xr23_u19.nr1[ibody]
print @n.xbgr.xr23_u20.nr1[ibody]
print @n.xbgr.xr23_u21.nr1[ibody]
print @n.xbgr.xr23_u22.nr1[ibody]
print @n.xbgr.xr23_u23.nr1[ibody]
print @n.xbgr.xr23_u24.nr1[ibody]
print @n.xbgr.xr24_u2.nr1[ibody]
print @n.xbgr.xr24_u3.nr1[ibody]
print @n.xbgr.xr24_u4.nr1[ibody]
print @n.xbgr.xr24_u5.nr1[ibody]
print @n.xbgr.xr24_u6.nr1[ibody]
print @n.xbgr.xr24_u7.nr1[ibody]
print @n.xbgr.xr24_u8.nr1[ibody]
print @n.xbgr.xr24_u9.nr1[ibody]
print @n.xbgr.xr24_u10.nr1[ibody]
print @n.xbgr.xr24_u11.nr1[ibody]
print @n.xbgr.xr24_u12.nr1[ibody]
print @n.xbgr.xr24_u13.nr1[ibody]
print @n.xbgr.xr24_u14.nr1[ibody]
print @n.xbgr.xr24_u15.nr1[ibody]
print @n.xbgr.xr24_u16.nr1[ibody]
print @n.xbgr.xr24_u17.nr1[ibody]
print @n.xbgr.xr24_u18.nr1[ibody]
print @n.xbgr.xr24_u19.nr1[ibody]
print @n.xbgr.xr24_u20.nr1[ibody]
print @n.xbgr.xr24_u21.nr1[ibody]
print @n.xbgr.xr24_u22.nr1[ibody]
print @n.xbgr.xr24_u23.nr1[ibody]
print @n.xbgr.xr24_u24.nr1[ibody]
print @n.xbgr.xr25_u2.nr1[ibody]
print @n.xbgr.xr25_u3.nr1[ibody]
print @n.xbgr.xr25_u4.nr1[ibody]
print @n.xbgr.xr25_u5.nr1[ibody]
print @n.xbgr.xr25_u6.nr1[ibody]
print @n.xbgr.xr25_u7.nr1[ibody]
print @n.xbgr.xr25_u8.nr1[ibody]
print @n.xbgr.xr25_u9.nr1[ibody]
print @n.xbgr.xr25_u10.nr1[ibody]
print @n.xbgr.xr25_u11.nr1[ibody]
print @n.xbgr.xr25_u12.nr1[ibody]
print @n.xbgr.xr25_u13.nr1[ibody]
print @n.xbgr.xr25_u14.nr1[ibody]
print @n.xbgr.xr25_u15.nr1[ibody]
print @n.xbgr.xr25_u16.nr1[ibody]
print @n.xbgr.xr25_u17.nr1[ibody]
print @n.xbgr.xr25_u18.nr1[ibody]
print @n.xbgr.xr25_u19.nr1[ibody]
print @n.xbgr.xr25_u20.nr1[ibody]
print @n.xbgr.xr25_u21.nr1[ibody]
print @n.xbgr.xr25_u22.nr1[ibody]
print @n.xbgr.xr25_u23.nr1[ibody]
print @n.xbgr.xr25_u24.nr1[ibody]
print @n.xbgr.xr26_u2.nr1[ibody]
print @n.xbgr.xr26_u3.nr1[ibody]
print @n.xbgr.xr26_u4.nr1[ibody]
print @n.xbgr.xr26_u5.nr1[ibody]
print @n.xbgr.xr26_u6.nr1[ibody]
print @n.xbgr.xr26_u7.nr1[ibody]
print @n.xbgr.xr26_u8.nr1[ibody]
print @n.xbgr.xr26_u9.nr1[ibody]
print @n.xbgr.xr26_u10.nr1[ibody]
print @n.xbgr.xr26_u11.nr1[ibody]
print @n.xbgr.xr26_u12.nr1[ibody]
print @n.xbgr.xr26_u13.nr1[ibody]
print @n.xbgr.xr26_u14.nr1[ibody]
print @n.xbgr.xr26_u15.nr1[ibody]
print @n.xbgr.xr26_u16.nr1[ibody]
print @n.xbgr.xr26_u17.nr1[ibody]
print @n.xbgr.xr26_u18.nr1[ibody]
print @n.xbgr.xr26_u19.nr1[ibody]
print @n.xbgr.xr26_u20.nr1[ibody]
print @n.xbgr.xr26_u21.nr1[ibody]
print @n.xbgr.xr26_u22.nr1[ibody]
print @n.xbgr.xr26_u23.nr1[ibody]
print @n.xbgr.xr26_u24.nr1[ibody]
print @n.xbgr.xm34_u2.nsg13_hv_nmos[ide]
print @n.xbgr.xm34_u2.nsg13_hv_nmos[ige]
print @n.xbgr.xm34_u2.nsg13_hv_nmos[ise]
print @n.xbgr.xm34_u2.nsg13_hv_nmos[ibe]
print @n.xbgr.xm34_u2.nsg13_hv_nmos[ctype]
print @n.xbgr.xm34_u3.nsg13_hv_nmos[ide]
print @n.xbgr.xm34_u3.nsg13_hv_nmos[ige]
print @n.xbgr.xm34_u3.nsg13_hv_nmos[ise]
print @n.xbgr.xm34_u3.nsg13_hv_nmos[ibe]
print @n.xbgr.xm34_u3.nsg13_hv_nmos[ctype]
print @n.xbgr.xm34_u4.nsg13_hv_nmos[ide]
print @n.xbgr.xm34_u4.nsg13_hv_nmos[ige]
print @n.xbgr.xm34_u4.nsg13_hv_nmos[ise]
print @n.xbgr.xm34_u4.nsg13_hv_nmos[ibe]
print @n.xbgr.xm34_u4.nsg13_hv_nmos[ctype]
print @n.xbgr.xm34_u5.nsg13_hv_nmos[ide]
print @n.xbgr.xm34_u5.nsg13_hv_nmos[ige]
print @n.xbgr.xm34_u5.nsg13_hv_nmos[ise]
print @n.xbgr.xm34_u5.nsg13_hv_nmos[ibe]
print @n.xbgr.xm34_u5.nsg13_hv_nmos[ctype]
print @n.xbgr.xm34_u6.nsg13_hv_nmos[ide]
print @n.xbgr.xm34_u6.nsg13_hv_nmos[ige]
print @n.xbgr.xm34_u6.nsg13_hv_nmos[ise]
print @n.xbgr.xm34_u6.nsg13_hv_nmos[ibe]
print @n.xbgr.xm34_u6.nsg13_hv_nmos[ctype]
print @n.xbgr.xm34_u7.nsg13_hv_nmos[ide]
print @n.xbgr.xm34_u7.nsg13_hv_nmos[ige]
print @n.xbgr.xm34_u7.nsg13_hv_nmos[ise]
print @n.xbgr.xm34_u7.nsg13_hv_nmos[ibe]
print @n.xbgr.xm34_u7.nsg13_hv_nmos[ctype]
print @n.xbgr.xm34_u8.nsg13_hv_nmos[ide]
print @n.xbgr.xm34_u8.nsg13_hv_nmos[ige]
print @n.xbgr.xm34_u8.nsg13_hv_nmos[ise]
print @n.xbgr.xm34_u8.nsg13_hv_nmos[ibe]
print @n.xbgr.xm34_u8.nsg13_hv_nmos[ctype]
print @n.xbgr.xm34_u9.nsg13_hv_nmos[ide]
print @n.xbgr.xm34_u9.nsg13_hv_nmos[ige]
print @n.xbgr.xm34_u9.nsg13_hv_nmos[ise]
print @n.xbgr.xm34_u9.nsg13_hv_nmos[ibe]
print @n.xbgr.xm34_u9.nsg13_hv_nmos[ctype]
print @n.xbgr.xm34_u10.nsg13_hv_nmos[ide]
print @n.xbgr.xm34_u10.nsg13_hv_nmos[ige]
print @n.xbgr.xm34_u10.nsg13_hv_nmos[ise]
print @n.xbgr.xm34_u10.nsg13_hv_nmos[ibe]
print @n.xbgr.xm34_u10.nsg13_hv_nmos[ctype]
print @n.xbgr.xm34_u11.nsg13_hv_nmos[ide]
print @n.xbgr.xm34_u11.nsg13_hv_nmos[ige]
print @n.xbgr.xm34_u11.nsg13_hv_nmos[ise]
print @n.xbgr.xm34_u11.nsg13_hv_nmos[ibe]
print @n.xbgr.xm34_u11.nsg13_hv_nmos[ctype]
print @n.xbgr.xm34_u12.nsg13_hv_nmos[ide]
print @n.xbgr.xm34_u12.nsg13_hv_nmos[ige]
print @n.xbgr.xm34_u12.nsg13_hv_nmos[ise]
print @n.xbgr.xm34_u12.nsg13_hv_nmos[ibe]
print @n.xbgr.xm34_u12.nsg13_hv_nmos[ctype]
print @n.xbgr.xm34_u13.nsg13_hv_nmos[ide]
print @n.xbgr.xm34_u13.nsg13_hv_nmos[ige]
print @n.xbgr.xm34_u13.nsg13_hv_nmos[ise]
print @n.xbgr.xm34_u13.nsg13_hv_nmos[ibe]
print @n.xbgr.xm34_u13.nsg13_hv_nmos[ctype]
print @n.xbgr.xm34_u14.nsg13_hv_nmos[ide]
print @n.xbgr.xm34_u14.nsg13_hv_nmos[ige]
print @n.xbgr.xm34_u14.nsg13_hv_nmos[ise]
print @n.xbgr.xm34_u14.nsg13_hv_nmos[ibe]
print @n.xbgr.xm34_u14.nsg13_hv_nmos[ctype]
print @n.xbgr.xm34_u15.nsg13_hv_nmos[ide]
print @n.xbgr.xm34_u15.nsg13_hv_nmos[ige]
print @n.xbgr.xm34_u15.nsg13_hv_nmos[ise]
print @n.xbgr.xm34_u15.nsg13_hv_nmos[ibe]
print @n.xbgr.xm34_u15.nsg13_hv_nmos[ctype]
print @n.xbgr.xm34_u16.nsg13_hv_nmos[ide]
print @n.xbgr.xm34_u16.nsg13_hv_nmos[ige]
print @n.xbgr.xm34_u16.nsg13_hv_nmos[ise]
print @n.xbgr.xm34_u16.nsg13_hv_nmos[ibe]
print @n.xbgr.xm34_u16.nsg13_hv_nmos[ctype]
print @n.xbgr.xm34_u17.nsg13_hv_nmos[ide]
print @n.xbgr.xm34_u17.nsg13_hv_nmos[ige]
print @n.xbgr.xm34_u17.nsg13_hv_nmos[ise]
print @n.xbgr.xm34_u17.nsg13_hv_nmos[ibe]
print @n.xbgr.xm34_u17.nsg13_hv_nmos[ctype]
print @n.xbgr.xm34_u18.nsg13_hv_nmos[ide]
print @n.xbgr.xm34_u18.nsg13_hv_nmos[ige]
print @n.xbgr.xm34_u18.nsg13_hv_nmos[ise]
print @n.xbgr.xm34_u18.nsg13_hv_nmos[ibe]
print @n.xbgr.xm34_u18.nsg13_hv_nmos[ctype]
print @n.xbgr.xm34_u19.nsg13_hv_nmos[ide]
print @n.xbgr.xm34_u19.nsg13_hv_nmos[ige]
print @n.xbgr.xm34_u19.nsg13_hv_nmos[ise]
print @n.xbgr.xm34_u19.nsg13_hv_nmos[ibe]
print @n.xbgr.xm34_u19.nsg13_hv_nmos[ctype]
print @n.xbgr.xm34_u20.nsg13_hv_nmos[ide]
print @n.xbgr.xm34_u20.nsg13_hv_nmos[ige]
print @n.xbgr.xm34_u20.nsg13_hv_nmos[ise]
print @n.xbgr.xm34_u20.nsg13_hv_nmos[ibe]
print @n.xbgr.xm34_u20.nsg13_hv_nmos[ctype]
print @n.xbgr.xm34_u21.nsg13_hv_nmos[ide]
print @n.xbgr.xm34_u21.nsg13_hv_nmos[ige]
print @n.xbgr.xm34_u21.nsg13_hv_nmos[ise]
print @n.xbgr.xm34_u21.nsg13_hv_nmos[ibe]
print @n.xbgr.xm34_u21.nsg13_hv_nmos[ctype]
print @n.xbgr.xm34_u22.nsg13_hv_nmos[ide]
print @n.xbgr.xm34_u22.nsg13_hv_nmos[ige]
print @n.xbgr.xm34_u22.nsg13_hv_nmos[ise]
print @n.xbgr.xm34_u22.nsg13_hv_nmos[ibe]
print @n.xbgr.xm34_u22.nsg13_hv_nmos[ctype]
print @n.xbgr.xm34_u23.nsg13_hv_nmos[ide]
print @n.xbgr.xm34_u23.nsg13_hv_nmos[ige]
print @n.xbgr.xm34_u23.nsg13_hv_nmos[ise]
print @n.xbgr.xm34_u23.nsg13_hv_nmos[ibe]
print @n.xbgr.xm34_u23.nsg13_hv_nmos[ctype]
print @n.xbgr.xm34_u24.nsg13_hv_nmos[ide]
print @n.xbgr.xm34_u24.nsg13_hv_nmos[ige]
print @n.xbgr.xm34_u24.nsg13_hv_nmos[ise]
print @n.xbgr.xm34_u24.nsg13_hv_nmos[ibe]
print @n.xbgr.xm34_u24.nsg13_hv_nmos[ctype]
print @n.xbgr.xm35_u2.nsg13_hv_nmos[ide]
print @n.xbgr.xm35_u2.nsg13_hv_nmos[ige]
print @n.xbgr.xm35_u2.nsg13_hv_nmos[ise]
print @n.xbgr.xm35_u2.nsg13_hv_nmos[ibe]
print @n.xbgr.xm35_u2.nsg13_hv_nmos[ctype]
print @n.xbgr.xm35_u3.nsg13_hv_nmos[ide]
print @n.xbgr.xm35_u3.nsg13_hv_nmos[ige]
print @n.xbgr.xm35_u3.nsg13_hv_nmos[ise]
print @n.xbgr.xm35_u3.nsg13_hv_nmos[ibe]
print @n.xbgr.xm35_u3.nsg13_hv_nmos[ctype]
print @n.xbgr.xm35_u4.nsg13_hv_nmos[ide]
print @n.xbgr.xm35_u4.nsg13_hv_nmos[ige]
print @n.xbgr.xm35_u4.nsg13_hv_nmos[ise]
print @n.xbgr.xm35_u4.nsg13_hv_nmos[ibe]
print @n.xbgr.xm35_u4.nsg13_hv_nmos[ctype]
print @n.xbgr.xm35_u5.nsg13_hv_nmos[ide]
print @n.xbgr.xm35_u5.nsg13_hv_nmos[ige]
print @n.xbgr.xm35_u5.nsg13_hv_nmos[ise]
print @n.xbgr.xm35_u5.nsg13_hv_nmos[ibe]
print @n.xbgr.xm35_u5.nsg13_hv_nmos[ctype]
print @n.xbgr.xm35_u6.nsg13_hv_nmos[ide]
print @n.xbgr.xm35_u6.nsg13_hv_nmos[ige]
print @n.xbgr.xm35_u6.nsg13_hv_nmos[ise]
print @n.xbgr.xm35_u6.nsg13_hv_nmos[ibe]
print @n.xbgr.xm35_u6.nsg13_hv_nmos[ctype]
print @n.xbgr.xm35_u7.nsg13_hv_nmos[ide]
print @n.xbgr.xm35_u7.nsg13_hv_nmos[ige]
print @n.xbgr.xm35_u7.nsg13_hv_nmos[ise]
print @n.xbgr.xm35_u7.nsg13_hv_nmos[ibe]
print @n.xbgr.xm35_u7.nsg13_hv_nmos[ctype]
print @n.xbgr.xm35_u8.nsg13_hv_nmos[ide]
print @n.xbgr.xm35_u8.nsg13_hv_nmos[ige]
print @n.xbgr.xm35_u8.nsg13_hv_nmos[ise]
print @n.xbgr.xm35_u8.nsg13_hv_nmos[ibe]
print @n.xbgr.xm35_u8.nsg13_hv_nmos[ctype]
print @n.xbgr.xm35_u9.nsg13_hv_nmos[ide]
print @n.xbgr.xm35_u9.nsg13_hv_nmos[ige]
print @n.xbgr.xm35_u9.nsg13_hv_nmos[ise]
print @n.xbgr.xm35_u9.nsg13_hv_nmos[ibe]
print @n.xbgr.xm35_u9.nsg13_hv_nmos[ctype]
print @n.xbgr.xm35_u10.nsg13_hv_nmos[ide]
print @n.xbgr.xm35_u10.nsg13_hv_nmos[ige]
print @n.xbgr.xm35_u10.nsg13_hv_nmos[ise]
print @n.xbgr.xm35_u10.nsg13_hv_nmos[ibe]
print @n.xbgr.xm35_u10.nsg13_hv_nmos[ctype]
print @n.xbgr.xm35_u11.nsg13_hv_nmos[ide]
print @n.xbgr.xm35_u11.nsg13_hv_nmos[ige]
print @n.xbgr.xm35_u11.nsg13_hv_nmos[ise]
print @n.xbgr.xm35_u11.nsg13_hv_nmos[ibe]
print @n.xbgr.xm35_u11.nsg13_hv_nmos[ctype]
print @n.xbgr.xm35_u12.nsg13_hv_nmos[ide]
print @n.xbgr.xm35_u12.nsg13_hv_nmos[ige]
print @n.xbgr.xm35_u12.nsg13_hv_nmos[ise]
print @n.xbgr.xm35_u12.nsg13_hv_nmos[ibe]
print @n.xbgr.xm35_u12.nsg13_hv_nmos[ctype]
print @n.xbgr.xm35_u13.nsg13_hv_nmos[ide]
print @n.xbgr.xm35_u13.nsg13_hv_nmos[ige]
print @n.xbgr.xm35_u13.nsg13_hv_nmos[ise]
print @n.xbgr.xm35_u13.nsg13_hv_nmos[ibe]
print @n.xbgr.xm35_u13.nsg13_hv_nmos[ctype]
print @n.xbgr.xm35_u14.nsg13_hv_nmos[ide]
print @n.xbgr.xm35_u14.nsg13_hv_nmos[ige]
print @n.xbgr.xm35_u14.nsg13_hv_nmos[ise]
print @n.xbgr.xm35_u14.nsg13_hv_nmos[ibe]
print @n.xbgr.xm35_u14.nsg13_hv_nmos[ctype]
print @n.xbgr.xm35_u15.nsg13_hv_nmos[ide]
print @n.xbgr.xm35_u15.nsg13_hv_nmos[ige]
print @n.xbgr.xm35_u15.nsg13_hv_nmos[ise]
print @n.xbgr.xm35_u15.nsg13_hv_nmos[ibe]
print @n.xbgr.xm35_u15.nsg13_hv_nmos[ctype]
print @n.xbgr.xm35_u16.nsg13_hv_nmos[ide]
print @n.xbgr.xm35_u16.nsg13_hv_nmos[ige]
print @n.xbgr.xm35_u16.nsg13_hv_nmos[ise]
print @n.xbgr.xm35_u16.nsg13_hv_nmos[ibe]
print @n.xbgr.xm35_u16.nsg13_hv_nmos[ctype]
print @n.xbgr.xm35_u17.nsg13_hv_nmos[ide]
print @n.xbgr.xm35_u17.nsg13_hv_nmos[ige]
print @n.xbgr.xm35_u17.nsg13_hv_nmos[ise]
print @n.xbgr.xm35_u17.nsg13_hv_nmos[ibe]
print @n.xbgr.xm35_u17.nsg13_hv_nmos[ctype]
print @n.xbgr.xm35_u18.nsg13_hv_nmos[ide]
print @n.xbgr.xm35_u18.nsg13_hv_nmos[ige]
print @n.xbgr.xm35_u18.nsg13_hv_nmos[ise]
print @n.xbgr.xm35_u18.nsg13_hv_nmos[ibe]
print @n.xbgr.xm35_u18.nsg13_hv_nmos[ctype]
print @n.xbgr.xm35_u19.nsg13_hv_nmos[ide]
print @n.xbgr.xm35_u19.nsg13_hv_nmos[ige]
print @n.xbgr.xm35_u19.nsg13_hv_nmos[ise]
print @n.xbgr.xm35_u19.nsg13_hv_nmos[ibe]
print @n.xbgr.xm35_u19.nsg13_hv_nmos[ctype]
print @n.xbgr.xm35_u20.nsg13_hv_nmos[ide]
print @n.xbgr.xm35_u20.nsg13_hv_nmos[ige]
print @n.xbgr.xm35_u20.nsg13_hv_nmos[ise]
print @n.xbgr.xm35_u20.nsg13_hv_nmos[ibe]
print @n.xbgr.xm35_u20.nsg13_hv_nmos[ctype]
print @n.xbgr.xm35_u21.nsg13_hv_nmos[ide]
print @n.xbgr.xm35_u21.nsg13_hv_nmos[ige]
print @n.xbgr.xm35_u21.nsg13_hv_nmos[ise]
print @n.xbgr.xm35_u21.nsg13_hv_nmos[ibe]
print @n.xbgr.xm35_u21.nsg13_hv_nmos[ctype]
print @n.xbgr.xm35_u22.nsg13_hv_nmos[ide]
print @n.xbgr.xm35_u22.nsg13_hv_nmos[ige]
print @n.xbgr.xm35_u22.nsg13_hv_nmos[ise]
print @n.xbgr.xm35_u22.nsg13_hv_nmos[ibe]
print @n.xbgr.xm35_u22.nsg13_hv_nmos[ctype]
print @n.xbgr.xm35_u23.nsg13_hv_nmos[ide]
print @n.xbgr.xm35_u23.nsg13_hv_nmos[ige]
print @n.xbgr.xm35_u23.nsg13_hv_nmos[ise]
print @n.xbgr.xm35_u23.nsg13_hv_nmos[ibe]
print @n.xbgr.xm35_u23.nsg13_hv_nmos[ctype]
print @n.xbgr.xm35_u24.nsg13_hv_nmos[ide]
print @n.xbgr.xm35_u24.nsg13_hv_nmos[ige]
print @n.xbgr.xm35_u24.nsg13_hv_nmos[ise]
print @n.xbgr.xm35_u24.nsg13_hv_nmos[ibe]
print @n.xbgr.xm35_u24.nsg13_hv_nmos[ctype]
print @n.xbgr.xm36_u2.nsg13_hv_nmos[ide]
print @n.xbgr.xm36_u2.nsg13_hv_nmos[ige]
print @n.xbgr.xm36_u2.nsg13_hv_nmos[ise]
print @n.xbgr.xm36_u2.nsg13_hv_nmos[ibe]
print @n.xbgr.xm36_u2.nsg13_hv_nmos[ctype]
print @n.xbgr.xm36_u3.nsg13_hv_nmos[ide]
print @n.xbgr.xm36_u3.nsg13_hv_nmos[ige]
print @n.xbgr.xm36_u3.nsg13_hv_nmos[ise]
print @n.xbgr.xm36_u3.nsg13_hv_nmos[ibe]
print @n.xbgr.xm36_u3.nsg13_hv_nmos[ctype]
print @n.xbgr.xm36_u4.nsg13_hv_nmos[ide]
print @n.xbgr.xm36_u4.nsg13_hv_nmos[ige]
print @n.xbgr.xm36_u4.nsg13_hv_nmos[ise]
print @n.xbgr.xm36_u4.nsg13_hv_nmos[ibe]
print @n.xbgr.xm36_u4.nsg13_hv_nmos[ctype]
print @n.xbgr.xm36_u5.nsg13_hv_nmos[ide]
print @n.xbgr.xm36_u5.nsg13_hv_nmos[ige]
print @n.xbgr.xm36_u5.nsg13_hv_nmos[ise]
print @n.xbgr.xm36_u5.nsg13_hv_nmos[ibe]
print @n.xbgr.xm36_u5.nsg13_hv_nmos[ctype]
print @n.xbgr.xm36_u6.nsg13_hv_nmos[ide]
print @n.xbgr.xm36_u6.nsg13_hv_nmos[ige]
print @n.xbgr.xm36_u6.nsg13_hv_nmos[ise]
print @n.xbgr.xm36_u6.nsg13_hv_nmos[ibe]
print @n.xbgr.xm36_u6.nsg13_hv_nmos[ctype]
print @n.xbgr.xm36_u7.nsg13_hv_nmos[ide]
print @n.xbgr.xm36_u7.nsg13_hv_nmos[ige]
print @n.xbgr.xm36_u7.nsg13_hv_nmos[ise]
print @n.xbgr.xm36_u7.nsg13_hv_nmos[ibe]
print @n.xbgr.xm36_u7.nsg13_hv_nmos[ctype]
print @n.xbgr.xm36_u8.nsg13_hv_nmos[ide]
print @n.xbgr.xm36_u8.nsg13_hv_nmos[ige]
print @n.xbgr.xm36_u8.nsg13_hv_nmos[ise]
print @n.xbgr.xm36_u8.nsg13_hv_nmos[ibe]
print @n.xbgr.xm36_u8.nsg13_hv_nmos[ctype]
print @n.xbgr.xm36_u9.nsg13_hv_nmos[ide]
print @n.xbgr.xm36_u9.nsg13_hv_nmos[ige]
print @n.xbgr.xm36_u9.nsg13_hv_nmos[ise]
print @n.xbgr.xm36_u9.nsg13_hv_nmos[ibe]
print @n.xbgr.xm36_u9.nsg13_hv_nmos[ctype]
print @n.xbgr.xm36_u10.nsg13_hv_nmos[ide]
print @n.xbgr.xm36_u10.nsg13_hv_nmos[ige]
print @n.xbgr.xm36_u10.nsg13_hv_nmos[ise]
print @n.xbgr.xm36_u10.nsg13_hv_nmos[ibe]
print @n.xbgr.xm36_u10.nsg13_hv_nmos[ctype]
print @n.xbgr.xm36_u11.nsg13_hv_nmos[ide]
print @n.xbgr.xm36_u11.nsg13_hv_nmos[ige]
print @n.xbgr.xm36_u11.nsg13_hv_nmos[ise]
print @n.xbgr.xm36_u11.nsg13_hv_nmos[ibe]
print @n.xbgr.xm36_u11.nsg13_hv_nmos[ctype]
print @n.xbgr.xm36_u12.nsg13_hv_nmos[ide]
print @n.xbgr.xm36_u12.nsg13_hv_nmos[ige]
print @n.xbgr.xm36_u12.nsg13_hv_nmos[ise]
print @n.xbgr.xm36_u12.nsg13_hv_nmos[ibe]
print @n.xbgr.xm36_u12.nsg13_hv_nmos[ctype]
print @n.xbgr.xm36_u13.nsg13_hv_nmos[ide]
print @n.xbgr.xm36_u13.nsg13_hv_nmos[ige]
print @n.xbgr.xm36_u13.nsg13_hv_nmos[ise]
print @n.xbgr.xm36_u13.nsg13_hv_nmos[ibe]
print @n.xbgr.xm36_u13.nsg13_hv_nmos[ctype]
print @n.xbgr.xm36_u14.nsg13_hv_nmos[ide]
print @n.xbgr.xm36_u14.nsg13_hv_nmos[ige]
print @n.xbgr.xm36_u14.nsg13_hv_nmos[ise]
print @n.xbgr.xm36_u14.nsg13_hv_nmos[ibe]
print @n.xbgr.xm36_u14.nsg13_hv_nmos[ctype]
print @n.xbgr.xm36_u15.nsg13_hv_nmos[ide]
print @n.xbgr.xm36_u15.nsg13_hv_nmos[ige]
print @n.xbgr.xm36_u15.nsg13_hv_nmos[ise]
print @n.xbgr.xm36_u15.nsg13_hv_nmos[ibe]
print @n.xbgr.xm36_u15.nsg13_hv_nmos[ctype]
print @n.xbgr.xm36_u16.nsg13_hv_nmos[ide]
print @n.xbgr.xm36_u16.nsg13_hv_nmos[ige]
print @n.xbgr.xm36_u16.nsg13_hv_nmos[ise]
print @n.xbgr.xm36_u16.nsg13_hv_nmos[ibe]
print @n.xbgr.xm36_u16.nsg13_hv_nmos[ctype]
print @n.xbgr.xm36_u17.nsg13_hv_nmos[ide]
print @n.xbgr.xm36_u17.nsg13_hv_nmos[ige]
print @n.xbgr.xm36_u17.nsg13_hv_nmos[ise]
print @n.xbgr.xm36_u17.nsg13_hv_nmos[ibe]
print @n.xbgr.xm36_u17.nsg13_hv_nmos[ctype]
print @n.xbgr.xm36_u18.nsg13_hv_nmos[ide]
print @n.xbgr.xm36_u18.nsg13_hv_nmos[ige]
print @n.xbgr.xm36_u18.nsg13_hv_nmos[ise]
print @n.xbgr.xm36_u18.nsg13_hv_nmos[ibe]
print @n.xbgr.xm36_u18.nsg13_hv_nmos[ctype]
print @n.xbgr.xm36_u19.nsg13_hv_nmos[ide]
print @n.xbgr.xm36_u19.nsg13_hv_nmos[ige]
print @n.xbgr.xm36_u19.nsg13_hv_nmos[ise]
print @n.xbgr.xm36_u19.nsg13_hv_nmos[ibe]
print @n.xbgr.xm36_u19.nsg13_hv_nmos[ctype]
print @n.xbgr.xm36_u20.nsg13_hv_nmos[ide]
print @n.xbgr.xm36_u20.nsg13_hv_nmos[ige]
print @n.xbgr.xm36_u20.nsg13_hv_nmos[ise]
print @n.xbgr.xm36_u20.nsg13_hv_nmos[ibe]
print @n.xbgr.xm36_u20.nsg13_hv_nmos[ctype]
print @n.xbgr.xm36_u21.nsg13_hv_nmos[ide]
print @n.xbgr.xm36_u21.nsg13_hv_nmos[ige]
print @n.xbgr.xm36_u21.nsg13_hv_nmos[ise]
print @n.xbgr.xm36_u21.nsg13_hv_nmos[ibe]
print @n.xbgr.xm36_u21.nsg13_hv_nmos[ctype]
print @n.xbgr.xm36_u22.nsg13_hv_nmos[ide]
print @n.xbgr.xm36_u22.nsg13_hv_nmos[ige]
print @n.xbgr.xm36_u22.nsg13_hv_nmos[ise]
print @n.xbgr.xm36_u22.nsg13_hv_nmos[ibe]
print @n.xbgr.xm36_u22.nsg13_hv_nmos[ctype]
print @n.xbgr.xm36_u23.nsg13_hv_nmos[ide]
print @n.xbgr.xm36_u23.nsg13_hv_nmos[ige]
print @n.xbgr.xm36_u23.nsg13_hv_nmos[ise]
print @n.xbgr.xm36_u23.nsg13_hv_nmos[ibe]
print @n.xbgr.xm36_u23.nsg13_hv_nmos[ctype]
print @n.xbgr.xm36_u24.nsg13_hv_nmos[ide]
print @n.xbgr.xm36_u24.nsg13_hv_nmos[ige]
print @n.xbgr.xm36_u24.nsg13_hv_nmos[ise]
print @n.xbgr.xm36_u24.nsg13_hv_nmos[ibe]
print @n.xbgr.xm36_u24.nsg13_hv_nmos[ctype]
print @n.xbgr.xm37_u2.nsg13_hv_nmos[ide]
print @n.xbgr.xm37_u2.nsg13_hv_nmos[ige]
print @n.xbgr.xm37_u2.nsg13_hv_nmos[ise]
print @n.xbgr.xm37_u2.nsg13_hv_nmos[ibe]
print @n.xbgr.xm37_u2.nsg13_hv_nmos[ctype]
print @n.xbgr.xm37_u3.nsg13_hv_nmos[ide]
print @n.xbgr.xm37_u3.nsg13_hv_nmos[ige]
print @n.xbgr.xm37_u3.nsg13_hv_nmos[ise]
print @n.xbgr.xm37_u3.nsg13_hv_nmos[ibe]
print @n.xbgr.xm37_u3.nsg13_hv_nmos[ctype]
print @n.xbgr.xm37_u4.nsg13_hv_nmos[ide]
print @n.xbgr.xm37_u4.nsg13_hv_nmos[ige]
print @n.xbgr.xm37_u4.nsg13_hv_nmos[ise]
print @n.xbgr.xm37_u4.nsg13_hv_nmos[ibe]
print @n.xbgr.xm37_u4.nsg13_hv_nmos[ctype]
print @n.xbgr.xm37_u5.nsg13_hv_nmos[ide]
print @n.xbgr.xm37_u5.nsg13_hv_nmos[ige]
print @n.xbgr.xm37_u5.nsg13_hv_nmos[ise]
print @n.xbgr.xm37_u5.nsg13_hv_nmos[ibe]
print @n.xbgr.xm37_u5.nsg13_hv_nmos[ctype]
print @n.xbgr.xm37_u6.nsg13_hv_nmos[ide]
print @n.xbgr.xm37_u6.nsg13_hv_nmos[ige]
print @n.xbgr.xm37_u6.nsg13_hv_nmos[ise]
print @n.xbgr.xm37_u6.nsg13_hv_nmos[ibe]
print @n.xbgr.xm37_u6.nsg13_hv_nmos[ctype]
print @n.xbgr.xm37_u7.nsg13_hv_nmos[ide]
print @n.xbgr.xm37_u7.nsg13_hv_nmos[ige]
print @n.xbgr.xm37_u7.nsg13_hv_nmos[ise]
print @n.xbgr.xm37_u7.nsg13_hv_nmos[ibe]
print @n.xbgr.xm37_u7.nsg13_hv_nmos[ctype]
print @n.xbgr.xm37_u8.nsg13_hv_nmos[ide]
print @n.xbgr.xm37_u8.nsg13_hv_nmos[ige]
print @n.xbgr.xm37_u8.nsg13_hv_nmos[ise]
print @n.xbgr.xm37_u8.nsg13_hv_nmos[ibe]
print @n.xbgr.xm37_u8.nsg13_hv_nmos[ctype]
print @n.xbgr.xm37_u9.nsg13_hv_nmos[ide]
print @n.xbgr.xm37_u9.nsg13_hv_nmos[ige]
print @n.xbgr.xm37_u9.nsg13_hv_nmos[ise]
print @n.xbgr.xm37_u9.nsg13_hv_nmos[ibe]
print @n.xbgr.xm37_u9.nsg13_hv_nmos[ctype]
print @n.xbgr.xm37_u10.nsg13_hv_nmos[ide]
print @n.xbgr.xm37_u10.nsg13_hv_nmos[ige]
print @n.xbgr.xm37_u10.nsg13_hv_nmos[ise]
print @n.xbgr.xm37_u10.nsg13_hv_nmos[ibe]
print @n.xbgr.xm37_u10.nsg13_hv_nmos[ctype]
print @n.xbgr.xm37_u11.nsg13_hv_nmos[ide]
print @n.xbgr.xm37_u11.nsg13_hv_nmos[ige]
print @n.xbgr.xm37_u11.nsg13_hv_nmos[ise]
print @n.xbgr.xm37_u11.nsg13_hv_nmos[ibe]
print @n.xbgr.xm37_u11.nsg13_hv_nmos[ctype]
print @n.xbgr.xm37_u12.nsg13_hv_nmos[ide]
print @n.xbgr.xm37_u12.nsg13_hv_nmos[ige]
print @n.xbgr.xm37_u12.nsg13_hv_nmos[ise]
print @n.xbgr.xm37_u12.nsg13_hv_nmos[ibe]
print @n.xbgr.xm37_u12.nsg13_hv_nmos[ctype]
print @n.xbgr.xm37_u13.nsg13_hv_nmos[ide]
print @n.xbgr.xm37_u13.nsg13_hv_nmos[ige]
print @n.xbgr.xm37_u13.nsg13_hv_nmos[ise]
print @n.xbgr.xm37_u13.nsg13_hv_nmos[ibe]
print @n.xbgr.xm37_u13.nsg13_hv_nmos[ctype]
print @n.xbgr.xm37_u14.nsg13_hv_nmos[ide]
print @n.xbgr.xm37_u14.nsg13_hv_nmos[ige]
print @n.xbgr.xm37_u14.nsg13_hv_nmos[ise]
print @n.xbgr.xm37_u14.nsg13_hv_nmos[ibe]
print @n.xbgr.xm37_u14.nsg13_hv_nmos[ctype]
print @n.xbgr.xm37_u15.nsg13_hv_nmos[ide]
print @n.xbgr.xm37_u15.nsg13_hv_nmos[ige]
print @n.xbgr.xm37_u15.nsg13_hv_nmos[ise]
print @n.xbgr.xm37_u15.nsg13_hv_nmos[ibe]
print @n.xbgr.xm37_u15.nsg13_hv_nmos[ctype]
print @n.xbgr.xm37_u16.nsg13_hv_nmos[ide]
print @n.xbgr.xm37_u16.nsg13_hv_nmos[ige]
print @n.xbgr.xm37_u16.nsg13_hv_nmos[ise]
print @n.xbgr.xm37_u16.nsg13_hv_nmos[ibe]
print @n.xbgr.xm37_u16.nsg13_hv_nmos[ctype]
print @n.xbgr.xm37_u17.nsg13_hv_nmos[ide]
print @n.xbgr.xm37_u17.nsg13_hv_nmos[ige]
print @n.xbgr.xm37_u17.nsg13_hv_nmos[ise]
print @n.xbgr.xm37_u17.nsg13_hv_nmos[ibe]
print @n.xbgr.xm37_u17.nsg13_hv_nmos[ctype]
print @n.xbgr.xm37_u18.nsg13_hv_nmos[ide]
print @n.xbgr.xm37_u18.nsg13_hv_nmos[ige]
print @n.xbgr.xm37_u18.nsg13_hv_nmos[ise]
print @n.xbgr.xm37_u18.nsg13_hv_nmos[ibe]
print @n.xbgr.xm37_u18.nsg13_hv_nmos[ctype]
print @n.xbgr.xm37_u19.nsg13_hv_nmos[ide]
print @n.xbgr.xm37_u19.nsg13_hv_nmos[ige]
print @n.xbgr.xm37_u19.nsg13_hv_nmos[ise]
print @n.xbgr.xm37_u19.nsg13_hv_nmos[ibe]
print @n.xbgr.xm37_u19.nsg13_hv_nmos[ctype]
print @n.xbgr.xm37_u20.nsg13_hv_nmos[ide]
print @n.xbgr.xm37_u20.nsg13_hv_nmos[ige]
print @n.xbgr.xm37_u20.nsg13_hv_nmos[ise]
print @n.xbgr.xm37_u20.nsg13_hv_nmos[ibe]
print @n.xbgr.xm37_u20.nsg13_hv_nmos[ctype]
print @n.xbgr.xm37_u21.nsg13_hv_nmos[ide]
print @n.xbgr.xm37_u21.nsg13_hv_nmos[ige]
print @n.xbgr.xm37_u21.nsg13_hv_nmos[ise]
print @n.xbgr.xm37_u21.nsg13_hv_nmos[ibe]
print @n.xbgr.xm37_u21.nsg13_hv_nmos[ctype]
print @n.xbgr.xm37_u22.nsg13_hv_nmos[ide]
print @n.xbgr.xm37_u22.nsg13_hv_nmos[ige]
print @n.xbgr.xm37_u22.nsg13_hv_nmos[ise]
print @n.xbgr.xm37_u22.nsg13_hv_nmos[ibe]
print @n.xbgr.xm37_u22.nsg13_hv_nmos[ctype]
print @n.xbgr.xm37_u23.nsg13_hv_nmos[ide]
print @n.xbgr.xm37_u23.nsg13_hv_nmos[ige]
print @n.xbgr.xm37_u23.nsg13_hv_nmos[ise]
print @n.xbgr.xm37_u23.nsg13_hv_nmos[ibe]
print @n.xbgr.xm37_u23.nsg13_hv_nmos[ctype]
print @n.xbgr.xm37_u24.nsg13_hv_nmos[ide]
print @n.xbgr.xm37_u24.nsg13_hv_nmos[ige]
print @n.xbgr.xm37_u24.nsg13_hv_nmos[ise]
print @n.xbgr.xm37_u24.nsg13_hv_nmos[ibe]
print @n.xbgr.xm37_u24.nsg13_hv_nmos[ctype]
print @n.xbgr.xm38_u2.nsg13_hv_pmos[ide]
print @n.xbgr.xm38_u2.nsg13_hv_pmos[ige]
print @n.xbgr.xm38_u2.nsg13_hv_pmos[ise]
print @n.xbgr.xm38_u2.nsg13_hv_pmos[ibe]
print @n.xbgr.xm38_u2.nsg13_hv_pmos[ctype]
print @n.xbgr.xm38_u3.nsg13_hv_pmos[ide]
print @n.xbgr.xm38_u3.nsg13_hv_pmos[ige]
print @n.xbgr.xm38_u3.nsg13_hv_pmos[ise]
print @n.xbgr.xm38_u3.nsg13_hv_pmos[ibe]
print @n.xbgr.xm38_u3.nsg13_hv_pmos[ctype]
print @n.xbgr.xm38_u4.nsg13_hv_pmos[ide]
print @n.xbgr.xm38_u4.nsg13_hv_pmos[ige]
print @n.xbgr.xm38_u4.nsg13_hv_pmos[ise]
print @n.xbgr.xm38_u4.nsg13_hv_pmos[ibe]
print @n.xbgr.xm38_u4.nsg13_hv_pmos[ctype]
print @n.xbgr.xm38_u5.nsg13_hv_pmos[ide]
print @n.xbgr.xm38_u5.nsg13_hv_pmos[ige]
print @n.xbgr.xm38_u5.nsg13_hv_pmos[ise]
print @n.xbgr.xm38_u5.nsg13_hv_pmos[ibe]
print @n.xbgr.xm38_u5.nsg13_hv_pmos[ctype]
print @n.xbgr.xm38_u6.nsg13_hv_pmos[ide]
print @n.xbgr.xm38_u6.nsg13_hv_pmos[ige]
print @n.xbgr.xm38_u6.nsg13_hv_pmos[ise]
print @n.xbgr.xm38_u6.nsg13_hv_pmos[ibe]
print @n.xbgr.xm38_u6.nsg13_hv_pmos[ctype]
print @n.xbgr.xm38_u7.nsg13_hv_pmos[ide]
print @n.xbgr.xm38_u7.nsg13_hv_pmos[ige]
print @n.xbgr.xm38_u7.nsg13_hv_pmos[ise]
print @n.xbgr.xm38_u7.nsg13_hv_pmos[ibe]
print @n.xbgr.xm38_u7.nsg13_hv_pmos[ctype]
print @n.xbgr.xm38_u8.nsg13_hv_pmos[ide]
print @n.xbgr.xm38_u8.nsg13_hv_pmos[ige]
print @n.xbgr.xm38_u8.nsg13_hv_pmos[ise]
print @n.xbgr.xm38_u8.nsg13_hv_pmos[ibe]
print @n.xbgr.xm38_u8.nsg13_hv_pmos[ctype]
print @n.xbgr.xm38_u9.nsg13_hv_pmos[ide]
print @n.xbgr.xm38_u9.nsg13_hv_pmos[ige]
print @n.xbgr.xm38_u9.nsg13_hv_pmos[ise]
print @n.xbgr.xm38_u9.nsg13_hv_pmos[ibe]
print @n.xbgr.xm38_u9.nsg13_hv_pmos[ctype]
print @n.xbgr.xm38_u10.nsg13_hv_pmos[ide]
print @n.xbgr.xm38_u10.nsg13_hv_pmos[ige]
print @n.xbgr.xm38_u10.nsg13_hv_pmos[ise]
print @n.xbgr.xm38_u10.nsg13_hv_pmos[ibe]
print @n.xbgr.xm38_u10.nsg13_hv_pmos[ctype]
print @n.xbgr.xm38_u11.nsg13_hv_pmos[ide]
print @n.xbgr.xm38_u11.nsg13_hv_pmos[ige]
print @n.xbgr.xm38_u11.nsg13_hv_pmos[ise]
print @n.xbgr.xm38_u11.nsg13_hv_pmos[ibe]
print @n.xbgr.xm38_u11.nsg13_hv_pmos[ctype]
print @n.xbgr.xm38_u12.nsg13_hv_pmos[ide]
print @n.xbgr.xm38_u12.nsg13_hv_pmos[ige]
print @n.xbgr.xm38_u12.nsg13_hv_pmos[ise]
print @n.xbgr.xm38_u12.nsg13_hv_pmos[ibe]
print @n.xbgr.xm38_u12.nsg13_hv_pmos[ctype]
print @n.xbgr.xm38_u13.nsg13_hv_pmos[ide]
print @n.xbgr.xm38_u13.nsg13_hv_pmos[ige]
print @n.xbgr.xm38_u13.nsg13_hv_pmos[ise]
print @n.xbgr.xm38_u13.nsg13_hv_pmos[ibe]
print @n.xbgr.xm38_u13.nsg13_hv_pmos[ctype]
print @n.xbgr.xm38_u14.nsg13_hv_pmos[ide]
print @n.xbgr.xm38_u14.nsg13_hv_pmos[ige]
print @n.xbgr.xm38_u14.nsg13_hv_pmos[ise]
print @n.xbgr.xm38_u14.nsg13_hv_pmos[ibe]
print @n.xbgr.xm38_u14.nsg13_hv_pmos[ctype]
print @n.xbgr.xm38_u15.nsg13_hv_pmos[ide]
print @n.xbgr.xm38_u15.nsg13_hv_pmos[ige]
print @n.xbgr.xm38_u15.nsg13_hv_pmos[ise]
print @n.xbgr.xm38_u15.nsg13_hv_pmos[ibe]
print @n.xbgr.xm38_u15.nsg13_hv_pmos[ctype]
print @n.xbgr.xm38_u16.nsg13_hv_pmos[ide]
print @n.xbgr.xm38_u16.nsg13_hv_pmos[ige]
print @n.xbgr.xm38_u16.nsg13_hv_pmos[ise]
print @n.xbgr.xm38_u16.nsg13_hv_pmos[ibe]
print @n.xbgr.xm38_u16.nsg13_hv_pmos[ctype]
print @n.xbgr.xm38_u17.nsg13_hv_pmos[ide]
print @n.xbgr.xm38_u17.nsg13_hv_pmos[ige]
print @n.xbgr.xm38_u17.nsg13_hv_pmos[ise]
print @n.xbgr.xm38_u17.nsg13_hv_pmos[ibe]
print @n.xbgr.xm38_u17.nsg13_hv_pmos[ctype]
print @n.xbgr.xm38_u18.nsg13_hv_pmos[ide]
print @n.xbgr.xm38_u18.nsg13_hv_pmos[ige]
print @n.xbgr.xm38_u18.nsg13_hv_pmos[ise]
print @n.xbgr.xm38_u18.nsg13_hv_pmos[ibe]
print @n.xbgr.xm38_u18.nsg13_hv_pmos[ctype]
print @n.xbgr.xm38_u19.nsg13_hv_pmos[ide]
print @n.xbgr.xm38_u19.nsg13_hv_pmos[ige]
print @n.xbgr.xm38_u19.nsg13_hv_pmos[ise]
print @n.xbgr.xm38_u19.nsg13_hv_pmos[ibe]
print @n.xbgr.xm38_u19.nsg13_hv_pmos[ctype]
print @n.xbgr.xm38_u20.nsg13_hv_pmos[ide]
print @n.xbgr.xm38_u20.nsg13_hv_pmos[ige]
print @n.xbgr.xm38_u20.nsg13_hv_pmos[ise]
print @n.xbgr.xm38_u20.nsg13_hv_pmos[ibe]
print @n.xbgr.xm38_u20.nsg13_hv_pmos[ctype]
print @n.xbgr.xm38_u21.nsg13_hv_pmos[ide]
print @n.xbgr.xm38_u21.nsg13_hv_pmos[ige]
print @n.xbgr.xm38_u21.nsg13_hv_pmos[ise]
print @n.xbgr.xm38_u21.nsg13_hv_pmos[ibe]
print @n.xbgr.xm38_u21.nsg13_hv_pmos[ctype]
print @n.xbgr.xm38_u22.nsg13_hv_pmos[ide]
print @n.xbgr.xm38_u22.nsg13_hv_pmos[ige]
print @n.xbgr.xm38_u22.nsg13_hv_pmos[ise]
print @n.xbgr.xm38_u22.nsg13_hv_pmos[ibe]
print @n.xbgr.xm38_u22.nsg13_hv_pmos[ctype]
print @n.xbgr.xm38_u23.nsg13_hv_pmos[ide]
print @n.xbgr.xm38_u23.nsg13_hv_pmos[ige]
print @n.xbgr.xm38_u23.nsg13_hv_pmos[ise]
print @n.xbgr.xm38_u23.nsg13_hv_pmos[ibe]
print @n.xbgr.xm38_u23.nsg13_hv_pmos[ctype]
print @n.xbgr.xm38_u24.nsg13_hv_pmos[ide]
print @n.xbgr.xm38_u24.nsg13_hv_pmos[ige]
print @n.xbgr.xm38_u24.nsg13_hv_pmos[ise]
print @n.xbgr.xm38_u24.nsg13_hv_pmos[ibe]
print @n.xbgr.xm38_u24.nsg13_hv_pmos[ctype]
print @n.xbgr.xm39_u2.nsg13_hv_pmos[ide]
print @n.xbgr.xm39_u2.nsg13_hv_pmos[ige]
print @n.xbgr.xm39_u2.nsg13_hv_pmos[ise]
print @n.xbgr.xm39_u2.nsg13_hv_pmos[ibe]
print @n.xbgr.xm39_u2.nsg13_hv_pmos[ctype]
print @n.xbgr.xm39_u3.nsg13_hv_pmos[ide]
print @n.xbgr.xm39_u3.nsg13_hv_pmos[ige]
print @n.xbgr.xm39_u3.nsg13_hv_pmos[ise]
print @n.xbgr.xm39_u3.nsg13_hv_pmos[ibe]
print @n.xbgr.xm39_u3.nsg13_hv_pmos[ctype]
print @n.xbgr.xm39_u4.nsg13_hv_pmos[ide]
print @n.xbgr.xm39_u4.nsg13_hv_pmos[ige]
print @n.xbgr.xm39_u4.nsg13_hv_pmos[ise]
print @n.xbgr.xm39_u4.nsg13_hv_pmos[ibe]
print @n.xbgr.xm39_u4.nsg13_hv_pmos[ctype]
print @n.xbgr.xm39_u5.nsg13_hv_pmos[ide]
print @n.xbgr.xm39_u5.nsg13_hv_pmos[ige]
print @n.xbgr.xm39_u5.nsg13_hv_pmos[ise]
print @n.xbgr.xm39_u5.nsg13_hv_pmos[ibe]
print @n.xbgr.xm39_u5.nsg13_hv_pmos[ctype]
print @n.xbgr.xm39_u6.nsg13_hv_pmos[ide]
print @n.xbgr.xm39_u6.nsg13_hv_pmos[ige]
print @n.xbgr.xm39_u6.nsg13_hv_pmos[ise]
print @n.xbgr.xm39_u6.nsg13_hv_pmos[ibe]
print @n.xbgr.xm39_u6.nsg13_hv_pmos[ctype]
print @n.xbgr.xm39_u7.nsg13_hv_pmos[ide]
print @n.xbgr.xm39_u7.nsg13_hv_pmos[ige]
print @n.xbgr.xm39_u7.nsg13_hv_pmos[ise]
print @n.xbgr.xm39_u7.nsg13_hv_pmos[ibe]
print @n.xbgr.xm39_u7.nsg13_hv_pmos[ctype]
print @n.xbgr.xm39_u8.nsg13_hv_pmos[ide]
print @n.xbgr.xm39_u8.nsg13_hv_pmos[ige]
print @n.xbgr.xm39_u8.nsg13_hv_pmos[ise]
print @n.xbgr.xm39_u8.nsg13_hv_pmos[ibe]
print @n.xbgr.xm39_u8.nsg13_hv_pmos[ctype]
print @n.xbgr.xm39_u9.nsg13_hv_pmos[ide]
print @n.xbgr.xm39_u9.nsg13_hv_pmos[ige]
print @n.xbgr.xm39_u9.nsg13_hv_pmos[ise]
print @n.xbgr.xm39_u9.nsg13_hv_pmos[ibe]
print @n.xbgr.xm39_u9.nsg13_hv_pmos[ctype]
print @n.xbgr.xm39_u10.nsg13_hv_pmos[ide]
print @n.xbgr.xm39_u10.nsg13_hv_pmos[ige]
print @n.xbgr.xm39_u10.nsg13_hv_pmos[ise]
print @n.xbgr.xm39_u10.nsg13_hv_pmos[ibe]
print @n.xbgr.xm39_u10.nsg13_hv_pmos[ctype]
print @n.xbgr.xm39_u11.nsg13_hv_pmos[ide]
print @n.xbgr.xm39_u11.nsg13_hv_pmos[ige]
print @n.xbgr.xm39_u11.nsg13_hv_pmos[ise]
print @n.xbgr.xm39_u11.nsg13_hv_pmos[ibe]
print @n.xbgr.xm39_u11.nsg13_hv_pmos[ctype]
print @n.xbgr.xm39_u12.nsg13_hv_pmos[ide]
print @n.xbgr.xm39_u12.nsg13_hv_pmos[ige]
print @n.xbgr.xm39_u12.nsg13_hv_pmos[ise]
print @n.xbgr.xm39_u12.nsg13_hv_pmos[ibe]
print @n.xbgr.xm39_u12.nsg13_hv_pmos[ctype]
print @n.xbgr.xm39_u13.nsg13_hv_pmos[ide]
print @n.xbgr.xm39_u13.nsg13_hv_pmos[ige]
print @n.xbgr.xm39_u13.nsg13_hv_pmos[ise]
print @n.xbgr.xm39_u13.nsg13_hv_pmos[ibe]
print @n.xbgr.xm39_u13.nsg13_hv_pmos[ctype]
print @n.xbgr.xm39_u14.nsg13_hv_pmos[ide]
print @n.xbgr.xm39_u14.nsg13_hv_pmos[ige]
print @n.xbgr.xm39_u14.nsg13_hv_pmos[ise]
print @n.xbgr.xm39_u14.nsg13_hv_pmos[ibe]
print @n.xbgr.xm39_u14.nsg13_hv_pmos[ctype]
print @n.xbgr.xm39_u15.nsg13_hv_pmos[ide]
print @n.xbgr.xm39_u15.nsg13_hv_pmos[ige]
print @n.xbgr.xm39_u15.nsg13_hv_pmos[ise]
print @n.xbgr.xm39_u15.nsg13_hv_pmos[ibe]
print @n.xbgr.xm39_u15.nsg13_hv_pmos[ctype]
print @n.xbgr.xm39_u16.nsg13_hv_pmos[ide]
print @n.xbgr.xm39_u16.nsg13_hv_pmos[ige]
print @n.xbgr.xm39_u16.nsg13_hv_pmos[ise]
print @n.xbgr.xm39_u16.nsg13_hv_pmos[ibe]
print @n.xbgr.xm39_u16.nsg13_hv_pmos[ctype]
print @n.xbgr.xm39_u17.nsg13_hv_pmos[ide]
print @n.xbgr.xm39_u17.nsg13_hv_pmos[ige]
print @n.xbgr.xm39_u17.nsg13_hv_pmos[ise]
print @n.xbgr.xm39_u17.nsg13_hv_pmos[ibe]
print @n.xbgr.xm39_u17.nsg13_hv_pmos[ctype]
print @n.xbgr.xm39_u18.nsg13_hv_pmos[ide]
print @n.xbgr.xm39_u18.nsg13_hv_pmos[ige]
print @n.xbgr.xm39_u18.nsg13_hv_pmos[ise]
print @n.xbgr.xm39_u18.nsg13_hv_pmos[ibe]
print @n.xbgr.xm39_u18.nsg13_hv_pmos[ctype]
print @n.xbgr.xm39_u19.nsg13_hv_pmos[ide]
print @n.xbgr.xm39_u19.nsg13_hv_pmos[ige]
print @n.xbgr.xm39_u19.nsg13_hv_pmos[ise]
print @n.xbgr.xm39_u19.nsg13_hv_pmos[ibe]
print @n.xbgr.xm39_u19.nsg13_hv_pmos[ctype]
print @n.xbgr.xm39_u20.nsg13_hv_pmos[ide]
print @n.xbgr.xm39_u20.nsg13_hv_pmos[ige]
print @n.xbgr.xm39_u20.nsg13_hv_pmos[ise]
print @n.xbgr.xm39_u20.nsg13_hv_pmos[ibe]
print @n.xbgr.xm39_u20.nsg13_hv_pmos[ctype]
print @n.xbgr.xm39_u21.nsg13_hv_pmos[ide]
print @n.xbgr.xm39_u21.nsg13_hv_pmos[ige]
print @n.xbgr.xm39_u21.nsg13_hv_pmos[ise]
print @n.xbgr.xm39_u21.nsg13_hv_pmos[ibe]
print @n.xbgr.xm39_u21.nsg13_hv_pmos[ctype]
print @n.xbgr.xm39_u22.nsg13_hv_pmos[ide]
print @n.xbgr.xm39_u22.nsg13_hv_pmos[ige]
print @n.xbgr.xm39_u22.nsg13_hv_pmos[ise]
print @n.xbgr.xm39_u22.nsg13_hv_pmos[ibe]
print @n.xbgr.xm39_u22.nsg13_hv_pmos[ctype]
print @n.xbgr.xm39_u23.nsg13_hv_pmos[ide]
print @n.xbgr.xm39_u23.nsg13_hv_pmos[ige]
print @n.xbgr.xm39_u23.nsg13_hv_pmos[ise]
print @n.xbgr.xm39_u23.nsg13_hv_pmos[ibe]
print @n.xbgr.xm39_u23.nsg13_hv_pmos[ctype]
print @n.xbgr.xm39_u24.nsg13_hv_pmos[ide]
print @n.xbgr.xm39_u24.nsg13_hv_pmos[ige]
print @n.xbgr.xm39_u24.nsg13_hv_pmos[ise]
print @n.xbgr.xm39_u24.nsg13_hv_pmos[ibe]
print @n.xbgr.xm39_u24.nsg13_hv_pmos[ctype]
print @n.xbgr.xm41_u2.nsg13_hv_pmos[ide]
print @n.xbgr.xm41_u2.nsg13_hv_pmos[ige]
print @n.xbgr.xm41_u2.nsg13_hv_pmos[ise]
print @n.xbgr.xm41_u2.nsg13_hv_pmos[ibe]
print @n.xbgr.xm41_u2.nsg13_hv_pmos[ctype]
print @n.xbgr.xm41_u3.nsg13_hv_pmos[ide]
print @n.xbgr.xm41_u3.nsg13_hv_pmos[ige]
print @n.xbgr.xm41_u3.nsg13_hv_pmos[ise]
print @n.xbgr.xm41_u3.nsg13_hv_pmos[ibe]
print @n.xbgr.xm41_u3.nsg13_hv_pmos[ctype]
print @n.xbgr.xm41_u4.nsg13_hv_pmos[ide]
print @n.xbgr.xm41_u4.nsg13_hv_pmos[ige]
print @n.xbgr.xm41_u4.nsg13_hv_pmos[ise]
print @n.xbgr.xm41_u4.nsg13_hv_pmos[ibe]
print @n.xbgr.xm41_u4.nsg13_hv_pmos[ctype]
print @n.xbgr.xm41_u5.nsg13_hv_pmos[ide]
print @n.xbgr.xm41_u5.nsg13_hv_pmos[ige]
print @n.xbgr.xm41_u5.nsg13_hv_pmos[ise]
print @n.xbgr.xm41_u5.nsg13_hv_pmos[ibe]
print @n.xbgr.xm41_u5.nsg13_hv_pmos[ctype]
print @n.xbgr.xm41_u6.nsg13_hv_pmos[ide]
print @n.xbgr.xm41_u6.nsg13_hv_pmos[ige]
print @n.xbgr.xm41_u6.nsg13_hv_pmos[ise]
print @n.xbgr.xm41_u6.nsg13_hv_pmos[ibe]
print @n.xbgr.xm41_u6.nsg13_hv_pmos[ctype]
print @n.xbgr.xm41_u7.nsg13_hv_pmos[ide]
print @n.xbgr.xm41_u7.nsg13_hv_pmos[ige]
print @n.xbgr.xm41_u7.nsg13_hv_pmos[ise]
print @n.xbgr.xm41_u7.nsg13_hv_pmos[ibe]
print @n.xbgr.xm41_u7.nsg13_hv_pmos[ctype]
print @n.xbgr.xm41_u8.nsg13_hv_pmos[ide]
print @n.xbgr.xm41_u8.nsg13_hv_pmos[ige]
print @n.xbgr.xm41_u8.nsg13_hv_pmos[ise]
print @n.xbgr.xm41_u8.nsg13_hv_pmos[ibe]
print @n.xbgr.xm41_u8.nsg13_hv_pmos[ctype]
print @n.xbgr.xm41_u9.nsg13_hv_pmos[ide]
print @n.xbgr.xm41_u9.nsg13_hv_pmos[ige]
print @n.xbgr.xm41_u9.nsg13_hv_pmos[ise]
print @n.xbgr.xm41_u9.nsg13_hv_pmos[ibe]
print @n.xbgr.xm41_u9.nsg13_hv_pmos[ctype]
print @n.xbgr.xm41_u10.nsg13_hv_pmos[ide]
print @n.xbgr.xm41_u10.nsg13_hv_pmos[ige]
print @n.xbgr.xm41_u10.nsg13_hv_pmos[ise]
print @n.xbgr.xm41_u10.nsg13_hv_pmos[ibe]
print @n.xbgr.xm41_u10.nsg13_hv_pmos[ctype]
print @n.xbgr.xm41_u11.nsg13_hv_pmos[ide]
print @n.xbgr.xm41_u11.nsg13_hv_pmos[ige]
print @n.xbgr.xm41_u11.nsg13_hv_pmos[ise]
print @n.xbgr.xm41_u11.nsg13_hv_pmos[ibe]
print @n.xbgr.xm41_u11.nsg13_hv_pmos[ctype]
print @n.xbgr.xm41_u12.nsg13_hv_pmos[ide]
print @n.xbgr.xm41_u12.nsg13_hv_pmos[ige]
print @n.xbgr.xm41_u12.nsg13_hv_pmos[ise]
print @n.xbgr.xm41_u12.nsg13_hv_pmos[ibe]
print @n.xbgr.xm41_u12.nsg13_hv_pmos[ctype]
print @n.xbgr.xm41_u13.nsg13_hv_pmos[ide]
print @n.xbgr.xm41_u13.nsg13_hv_pmos[ige]
print @n.xbgr.xm41_u13.nsg13_hv_pmos[ise]
print @n.xbgr.xm41_u13.nsg13_hv_pmos[ibe]
print @n.xbgr.xm41_u13.nsg13_hv_pmos[ctype]
print @n.xbgr.xm41_u14.nsg13_hv_pmos[ide]
print @n.xbgr.xm41_u14.nsg13_hv_pmos[ige]
print @n.xbgr.xm41_u14.nsg13_hv_pmos[ise]
print @n.xbgr.xm41_u14.nsg13_hv_pmos[ibe]
print @n.xbgr.xm41_u14.nsg13_hv_pmos[ctype]
print @n.xbgr.xm41_u15.nsg13_hv_pmos[ide]
print @n.xbgr.xm41_u15.nsg13_hv_pmos[ige]
print @n.xbgr.xm41_u15.nsg13_hv_pmos[ise]
print @n.xbgr.xm41_u15.nsg13_hv_pmos[ibe]
print @n.xbgr.xm41_u15.nsg13_hv_pmos[ctype]
print @n.xbgr.xm41_u16.nsg13_hv_pmos[ide]
print @n.xbgr.xm41_u16.nsg13_hv_pmos[ige]
print @n.xbgr.xm41_u16.nsg13_hv_pmos[ise]
print @n.xbgr.xm41_u16.nsg13_hv_pmos[ibe]
print @n.xbgr.xm41_u16.nsg13_hv_pmos[ctype]
print @n.xbgr.xm41_u17.nsg13_hv_pmos[ide]
print @n.xbgr.xm41_u17.nsg13_hv_pmos[ige]
print @n.xbgr.xm41_u17.nsg13_hv_pmos[ise]
print @n.xbgr.xm41_u17.nsg13_hv_pmos[ibe]
print @n.xbgr.xm41_u17.nsg13_hv_pmos[ctype]
print @n.xbgr.xm41_u18.nsg13_hv_pmos[ide]
print @n.xbgr.xm41_u18.nsg13_hv_pmos[ige]
print @n.xbgr.xm41_u18.nsg13_hv_pmos[ise]
print @n.xbgr.xm41_u18.nsg13_hv_pmos[ibe]
print @n.xbgr.xm41_u18.nsg13_hv_pmos[ctype]
print @n.xbgr.xm41_u19.nsg13_hv_pmos[ide]
print @n.xbgr.xm41_u19.nsg13_hv_pmos[ige]
print @n.xbgr.xm41_u19.nsg13_hv_pmos[ise]
print @n.xbgr.xm41_u19.nsg13_hv_pmos[ibe]
print @n.xbgr.xm41_u19.nsg13_hv_pmos[ctype]
print @n.xbgr.xm41_u20.nsg13_hv_pmos[ide]
print @n.xbgr.xm41_u20.nsg13_hv_pmos[ige]
print @n.xbgr.xm41_u20.nsg13_hv_pmos[ise]
print @n.xbgr.xm41_u20.nsg13_hv_pmos[ibe]
print @n.xbgr.xm41_u20.nsg13_hv_pmos[ctype]
print @n.xbgr.xm41_u21.nsg13_hv_pmos[ide]
print @n.xbgr.xm41_u21.nsg13_hv_pmos[ige]
print @n.xbgr.xm41_u21.nsg13_hv_pmos[ise]
print @n.xbgr.xm41_u21.nsg13_hv_pmos[ibe]
print @n.xbgr.xm41_u21.nsg13_hv_pmos[ctype]
print @n.xbgr.xm41_u22.nsg13_hv_pmos[ide]
print @n.xbgr.xm41_u22.nsg13_hv_pmos[ige]
print @n.xbgr.xm41_u22.nsg13_hv_pmos[ise]
print @n.xbgr.xm41_u22.nsg13_hv_pmos[ibe]
print @n.xbgr.xm41_u22.nsg13_hv_pmos[ctype]
print @n.xbgr.xm41_u23.nsg13_hv_pmos[ide]
print @n.xbgr.xm41_u23.nsg13_hv_pmos[ige]
print @n.xbgr.xm41_u23.nsg13_hv_pmos[ise]
print @n.xbgr.xm41_u23.nsg13_hv_pmos[ibe]
print @n.xbgr.xm41_u23.nsg13_hv_pmos[ctype]
print @n.xbgr.xm41_u24.nsg13_hv_pmos[ide]
print @n.xbgr.xm41_u24.nsg13_hv_pmos[ige]
print @n.xbgr.xm41_u24.nsg13_hv_pmos[ise]
print @n.xbgr.xm41_u24.nsg13_hv_pmos[ibe]
print @n.xbgr.xm41_u24.nsg13_hv_pmos[ctype]
print @n.xbgr.xm43_u2.nsg13_hv_pmos[ide]
print @n.xbgr.xm43_u2.nsg13_hv_pmos[ige]
print @n.xbgr.xm43_u2.nsg13_hv_pmos[ise]
print @n.xbgr.xm43_u2.nsg13_hv_pmos[ibe]
print @n.xbgr.xm43_u2.nsg13_hv_pmos[ctype]
print @n.xbgr.xm43_u3.nsg13_hv_pmos[ide]
print @n.xbgr.xm43_u3.nsg13_hv_pmos[ige]
print @n.xbgr.xm43_u3.nsg13_hv_pmos[ise]
print @n.xbgr.xm43_u3.nsg13_hv_pmos[ibe]
print @n.xbgr.xm43_u3.nsg13_hv_pmos[ctype]
print @n.xbgr.xm43_u4.nsg13_hv_pmos[ide]
print @n.xbgr.xm43_u4.nsg13_hv_pmos[ige]
print @n.xbgr.xm43_u4.nsg13_hv_pmos[ise]
print @n.xbgr.xm43_u4.nsg13_hv_pmos[ibe]
print @n.xbgr.xm43_u4.nsg13_hv_pmos[ctype]
print @n.xbgr.xm44_u2.nsg13_hv_pmos[ide]
print @n.xbgr.xm44_u2.nsg13_hv_pmos[ige]
print @n.xbgr.xm44_u2.nsg13_hv_pmos[ise]
print @n.xbgr.xm44_u2.nsg13_hv_pmos[ibe]
print @n.xbgr.xm44_u2.nsg13_hv_pmos[ctype]
print @n.xbgr.xm44_u3.nsg13_hv_pmos[ide]
print @n.xbgr.xm44_u3.nsg13_hv_pmos[ige]
print @n.xbgr.xm44_u3.nsg13_hv_pmos[ise]
print @n.xbgr.xm44_u3.nsg13_hv_pmos[ibe]
print @n.xbgr.xm44_u3.nsg13_hv_pmos[ctype]
print @n.xbgr.xm44_u4.nsg13_hv_pmos[ide]
print @n.xbgr.xm44_u4.nsg13_hv_pmos[ige]
print @n.xbgr.xm44_u4.nsg13_hv_pmos[ise]
print @n.xbgr.xm44_u4.nsg13_hv_pmos[ibe]
print @n.xbgr.xm44_u4.nsg13_hv_pmos[ctype]
print @n.xbgr.xm45_u2.nsg13_hv_pmos[ide]
print @n.xbgr.xm45_u2.nsg13_hv_pmos[ige]
print @n.xbgr.xm45_u2.nsg13_hv_pmos[ise]
print @n.xbgr.xm45_u2.nsg13_hv_pmos[ibe]
print @n.xbgr.xm45_u2.nsg13_hv_pmos[ctype]
print @n.xbgr.xm45_u3.nsg13_hv_pmos[ide]
print @n.xbgr.xm45_u3.nsg13_hv_pmos[ige]
print @n.xbgr.xm45_u3.nsg13_hv_pmos[ise]
print @n.xbgr.xm45_u3.nsg13_hv_pmos[ibe]
print @n.xbgr.xm45_u3.nsg13_hv_pmos[ctype]
print @n.xbgr.xm45_u4.nsg13_hv_pmos[ide]
print @n.xbgr.xm45_u4.nsg13_hv_pmos[ige]
print @n.xbgr.xm45_u4.nsg13_hv_pmos[ise]
print @n.xbgr.xm45_u4.nsg13_hv_pmos[ibe]
print @n.xbgr.xm45_u4.nsg13_hv_pmos[ctype]
print @n.xbgr.xm45_u5.nsg13_hv_pmos[ide]
print @n.xbgr.xm45_u5.nsg13_hv_pmos[ige]
print @n.xbgr.xm45_u5.nsg13_hv_pmos[ise]
print @n.xbgr.xm45_u5.nsg13_hv_pmos[ibe]
print @n.xbgr.xm45_u5.nsg13_hv_pmos[ctype]
print @n.xbgr.xm45_u6.nsg13_hv_pmos[ide]
print @n.xbgr.xm45_u6.nsg13_hv_pmos[ige]
print @n.xbgr.xm45_u6.nsg13_hv_pmos[ise]
print @n.xbgr.xm45_u6.nsg13_hv_pmos[ibe]
print @n.xbgr.xm45_u6.nsg13_hv_pmos[ctype]
print @n.xbgr.xm45_u7.nsg13_hv_pmos[ide]
print @n.xbgr.xm45_u7.nsg13_hv_pmos[ige]
print @n.xbgr.xm45_u7.nsg13_hv_pmos[ise]
print @n.xbgr.xm45_u7.nsg13_hv_pmos[ibe]
print @n.xbgr.xm45_u7.nsg13_hv_pmos[ctype]
print @n.xbgr.xm45_u8.nsg13_hv_pmos[ide]
print @n.xbgr.xm45_u8.nsg13_hv_pmos[ige]
print @n.xbgr.xm45_u8.nsg13_hv_pmos[ise]
print @n.xbgr.xm45_u8.nsg13_hv_pmos[ibe]
print @n.xbgr.xm45_u8.nsg13_hv_pmos[ctype]
print @n.xbgr.xm45_u9.nsg13_hv_pmos[ide]
print @n.xbgr.xm45_u9.nsg13_hv_pmos[ige]
print @n.xbgr.xm45_u9.nsg13_hv_pmos[ise]
print @n.xbgr.xm45_u9.nsg13_hv_pmos[ibe]
print @n.xbgr.xm45_u9.nsg13_hv_pmos[ctype]
print @n.xbgr.xm45_u10.nsg13_hv_pmos[ide]
print @n.xbgr.xm45_u10.nsg13_hv_pmos[ige]
print @n.xbgr.xm45_u10.nsg13_hv_pmos[ise]
print @n.xbgr.xm45_u10.nsg13_hv_pmos[ibe]
print @n.xbgr.xm45_u10.nsg13_hv_pmos[ctype]
print @n.xbgr.xm45_u11.nsg13_hv_pmos[ide]
print @n.xbgr.xm45_u11.nsg13_hv_pmos[ige]
print @n.xbgr.xm45_u11.nsg13_hv_pmos[ise]
print @n.xbgr.xm45_u11.nsg13_hv_pmos[ibe]
print @n.xbgr.xm45_u11.nsg13_hv_pmos[ctype]
print @n.xbgr.xm45_u12.nsg13_hv_pmos[ide]
print @n.xbgr.xm45_u12.nsg13_hv_pmos[ige]
print @n.xbgr.xm45_u12.nsg13_hv_pmos[ise]
print @n.xbgr.xm45_u12.nsg13_hv_pmos[ibe]
print @n.xbgr.xm45_u12.nsg13_hv_pmos[ctype]
print @n.xbgr.xm45_u13.nsg13_hv_pmos[ide]
print @n.xbgr.xm45_u13.nsg13_hv_pmos[ige]
print @n.xbgr.xm45_u13.nsg13_hv_pmos[ise]
print @n.xbgr.xm45_u13.nsg13_hv_pmos[ibe]
print @n.xbgr.xm45_u13.nsg13_hv_pmos[ctype]
print @n.xbgr.xm45_u14.nsg13_hv_pmos[ide]
print @n.xbgr.xm45_u14.nsg13_hv_pmos[ige]
print @n.xbgr.xm45_u14.nsg13_hv_pmos[ise]
print @n.xbgr.xm45_u14.nsg13_hv_pmos[ibe]
print @n.xbgr.xm45_u14.nsg13_hv_pmos[ctype]
print @n.xbgr.xm45_u15.nsg13_hv_pmos[ide]
print @n.xbgr.xm45_u15.nsg13_hv_pmos[ige]
print @n.xbgr.xm45_u15.nsg13_hv_pmos[ise]
print @n.xbgr.xm45_u15.nsg13_hv_pmos[ibe]
print @n.xbgr.xm45_u15.nsg13_hv_pmos[ctype]
print @n.xbgr.xm45_u16.nsg13_hv_pmos[ide]
print @n.xbgr.xm45_u16.nsg13_hv_pmos[ige]
print @n.xbgr.xm45_u16.nsg13_hv_pmos[ise]
print @n.xbgr.xm45_u16.nsg13_hv_pmos[ibe]
print @n.xbgr.xm45_u16.nsg13_hv_pmos[ctype]
print @n.xbgr.xm45_u17.nsg13_hv_pmos[ide]
print @n.xbgr.xm45_u17.nsg13_hv_pmos[ige]
print @n.xbgr.xm45_u17.nsg13_hv_pmos[ise]
print @n.xbgr.xm45_u17.nsg13_hv_pmos[ibe]
print @n.xbgr.xm45_u17.nsg13_hv_pmos[ctype]
print @n.xbgr.xm45_u18.nsg13_hv_pmos[ide]
print @n.xbgr.xm45_u18.nsg13_hv_pmos[ige]
print @n.xbgr.xm45_u18.nsg13_hv_pmos[ise]
print @n.xbgr.xm45_u18.nsg13_hv_pmos[ibe]
print @n.xbgr.xm45_u18.nsg13_hv_pmos[ctype]
print @n.xbgr.xm45_u19.nsg13_hv_pmos[ide]
print @n.xbgr.xm45_u19.nsg13_hv_pmos[ige]
print @n.xbgr.xm45_u19.nsg13_hv_pmos[ise]
print @n.xbgr.xm45_u19.nsg13_hv_pmos[ibe]
print @n.xbgr.xm45_u19.nsg13_hv_pmos[ctype]
print @n.xbgr.xm45_u20.nsg13_hv_pmos[ide]
print @n.xbgr.xm45_u20.nsg13_hv_pmos[ige]
print @n.xbgr.xm45_u20.nsg13_hv_pmos[ise]
print @n.xbgr.xm45_u20.nsg13_hv_pmos[ibe]
print @n.xbgr.xm45_u20.nsg13_hv_pmos[ctype]
print @n.xbgr.xm45_u21.nsg13_hv_pmos[ide]
print @n.xbgr.xm45_u21.nsg13_hv_pmos[ige]
print @n.xbgr.xm45_u21.nsg13_hv_pmos[ise]
print @n.xbgr.xm45_u21.nsg13_hv_pmos[ibe]
print @n.xbgr.xm45_u21.nsg13_hv_pmos[ctype]
print @n.xbgr.xm45_u22.nsg13_hv_pmos[ide]
print @n.xbgr.xm45_u22.nsg13_hv_pmos[ige]
print @n.xbgr.xm45_u22.nsg13_hv_pmos[ise]
print @n.xbgr.xm45_u22.nsg13_hv_pmos[ibe]
print @n.xbgr.xm45_u22.nsg13_hv_pmos[ctype]
print @n.xbgr.xm45_u23.nsg13_hv_pmos[ide]
print @n.xbgr.xm45_u23.nsg13_hv_pmos[ige]
print @n.xbgr.xm45_u23.nsg13_hv_pmos[ise]
print @n.xbgr.xm45_u23.nsg13_hv_pmos[ibe]
print @n.xbgr.xm45_u23.nsg13_hv_pmos[ctype]
print @n.xbgr.xm45_u24.nsg13_hv_pmos[ide]
print @n.xbgr.xm45_u24.nsg13_hv_pmos[ige]
print @n.xbgr.xm45_u24.nsg13_hv_pmos[ise]
print @n.xbgr.xm45_u24.nsg13_hv_pmos[ibe]
print @n.xbgr.xm45_u24.nsg13_hv_pmos[ctype]
print @n.xbgr.xm47_u2.nsg13_hv_pmos[ide]
print @n.xbgr.xm47_u2.nsg13_hv_pmos[ige]
print @n.xbgr.xm47_u2.nsg13_hv_pmos[ise]
print @n.xbgr.xm47_u2.nsg13_hv_pmos[ibe]
print @n.xbgr.xm47_u2.nsg13_hv_pmos[ctype]
print @n.xbgr.xm47_u3.nsg13_hv_pmos[ide]
print @n.xbgr.xm47_u3.nsg13_hv_pmos[ige]
print @n.xbgr.xm47_u3.nsg13_hv_pmos[ise]
print @n.xbgr.xm47_u3.nsg13_hv_pmos[ibe]
print @n.xbgr.xm47_u3.nsg13_hv_pmos[ctype]
print @n.xbgr.xm47_u4.nsg13_hv_pmos[ide]
print @n.xbgr.xm47_u4.nsg13_hv_pmos[ige]
print @n.xbgr.xm47_u4.nsg13_hv_pmos[ise]
print @n.xbgr.xm47_u4.nsg13_hv_pmos[ibe]
print @n.xbgr.xm47_u4.nsg13_hv_pmos[ctype]
print @n.xbgr.xm47_u5.nsg13_hv_pmos[ide]
print @n.xbgr.xm47_u5.nsg13_hv_pmos[ige]
print @n.xbgr.xm47_u5.nsg13_hv_pmos[ise]
print @n.xbgr.xm47_u5.nsg13_hv_pmos[ibe]
print @n.xbgr.xm47_u5.nsg13_hv_pmos[ctype]
print @n.xbgr.xm47_u6.nsg13_hv_pmos[ide]
print @n.xbgr.xm47_u6.nsg13_hv_pmos[ige]
print @n.xbgr.xm47_u6.nsg13_hv_pmos[ise]
print @n.xbgr.xm47_u6.nsg13_hv_pmos[ibe]
print @n.xbgr.xm47_u6.nsg13_hv_pmos[ctype]
print @n.xbgr.xm47_u7.nsg13_hv_pmos[ide]
print @n.xbgr.xm47_u7.nsg13_hv_pmos[ige]
print @n.xbgr.xm47_u7.nsg13_hv_pmos[ise]
print @n.xbgr.xm47_u7.nsg13_hv_pmos[ibe]
print @n.xbgr.xm47_u7.nsg13_hv_pmos[ctype]
print @n.xbgr.xm47_u8.nsg13_hv_pmos[ide]
print @n.xbgr.xm47_u8.nsg13_hv_pmos[ige]
print @n.xbgr.xm47_u8.nsg13_hv_pmos[ise]
print @n.xbgr.xm47_u8.nsg13_hv_pmos[ibe]
print @n.xbgr.xm47_u8.nsg13_hv_pmos[ctype]
print @n.xbgr.xm47_u9.nsg13_hv_pmos[ide]
print @n.xbgr.xm47_u9.nsg13_hv_pmos[ige]
print @n.xbgr.xm47_u9.nsg13_hv_pmos[ise]
print @n.xbgr.xm47_u9.nsg13_hv_pmos[ibe]
print @n.xbgr.xm47_u9.nsg13_hv_pmos[ctype]
print @n.xbgr.xm47_u10.nsg13_hv_pmos[ide]
print @n.xbgr.xm47_u10.nsg13_hv_pmos[ige]
print @n.xbgr.xm47_u10.nsg13_hv_pmos[ise]
print @n.xbgr.xm47_u10.nsg13_hv_pmos[ibe]
print @n.xbgr.xm47_u10.nsg13_hv_pmos[ctype]
print @n.xbgr.xm47_u11.nsg13_hv_pmos[ide]
print @n.xbgr.xm47_u11.nsg13_hv_pmos[ige]
print @n.xbgr.xm47_u11.nsg13_hv_pmos[ise]
print @n.xbgr.xm47_u11.nsg13_hv_pmos[ibe]
print @n.xbgr.xm47_u11.nsg13_hv_pmos[ctype]
print @n.xbgr.xm47_u12.nsg13_hv_pmos[ide]
print @n.xbgr.xm47_u12.nsg13_hv_pmos[ige]
print @n.xbgr.xm47_u12.nsg13_hv_pmos[ise]
print @n.xbgr.xm47_u12.nsg13_hv_pmos[ibe]
print @n.xbgr.xm47_u12.nsg13_hv_pmos[ctype]
print @n.xbgr.xm47_u13.nsg13_hv_pmos[ide]
print @n.xbgr.xm47_u13.nsg13_hv_pmos[ige]
print @n.xbgr.xm47_u13.nsg13_hv_pmos[ise]
print @n.xbgr.xm47_u13.nsg13_hv_pmos[ibe]
print @n.xbgr.xm47_u13.nsg13_hv_pmos[ctype]
print @n.xbgr.xm47_u14.nsg13_hv_pmos[ide]
print @n.xbgr.xm47_u14.nsg13_hv_pmos[ige]
print @n.xbgr.xm47_u14.nsg13_hv_pmos[ise]
print @n.xbgr.xm47_u14.nsg13_hv_pmos[ibe]
print @n.xbgr.xm47_u14.nsg13_hv_pmos[ctype]
print @n.xbgr.xm47_u15.nsg13_hv_pmos[ide]
print @n.xbgr.xm47_u15.nsg13_hv_pmos[ige]
print @n.xbgr.xm47_u15.nsg13_hv_pmos[ise]
print @n.xbgr.xm47_u15.nsg13_hv_pmos[ibe]
print @n.xbgr.xm47_u15.nsg13_hv_pmos[ctype]
print @n.xbgr.xm47_u16.nsg13_hv_pmos[ide]
print @n.xbgr.xm47_u16.nsg13_hv_pmos[ige]
print @n.xbgr.xm47_u16.nsg13_hv_pmos[ise]
print @n.xbgr.xm47_u16.nsg13_hv_pmos[ibe]
print @n.xbgr.xm47_u16.nsg13_hv_pmos[ctype]
print @n.xbgr.xm47_u17.nsg13_hv_pmos[ide]
print @n.xbgr.xm47_u17.nsg13_hv_pmos[ige]
print @n.xbgr.xm47_u17.nsg13_hv_pmos[ise]
print @n.xbgr.xm47_u17.nsg13_hv_pmos[ibe]
print @n.xbgr.xm47_u17.nsg13_hv_pmos[ctype]
print @n.xbgr.xm47_u18.nsg13_hv_pmos[ide]
print @n.xbgr.xm47_u18.nsg13_hv_pmos[ige]
print @n.xbgr.xm47_u18.nsg13_hv_pmos[ise]
print @n.xbgr.xm47_u18.nsg13_hv_pmos[ibe]
print @n.xbgr.xm47_u18.nsg13_hv_pmos[ctype]
print @n.xbgr.xm47_u19.nsg13_hv_pmos[ide]
print @n.xbgr.xm47_u19.nsg13_hv_pmos[ige]
print @n.xbgr.xm47_u19.nsg13_hv_pmos[ise]
print @n.xbgr.xm47_u19.nsg13_hv_pmos[ibe]
print @n.xbgr.xm47_u19.nsg13_hv_pmos[ctype]
print @n.xbgr.xm47_u20.nsg13_hv_pmos[ide]
print @n.xbgr.xm47_u20.nsg13_hv_pmos[ige]
print @n.xbgr.xm47_u20.nsg13_hv_pmos[ise]
print @n.xbgr.xm47_u20.nsg13_hv_pmos[ibe]
print @n.xbgr.xm47_u20.nsg13_hv_pmos[ctype]
print @n.xbgr.xm47_u21.nsg13_hv_pmos[ide]
print @n.xbgr.xm47_u21.nsg13_hv_pmos[ige]
print @n.xbgr.xm47_u21.nsg13_hv_pmos[ise]
print @n.xbgr.xm47_u21.nsg13_hv_pmos[ibe]
print @n.xbgr.xm47_u21.nsg13_hv_pmos[ctype]
print @n.xbgr.xm47_u22.nsg13_hv_pmos[ide]
print @n.xbgr.xm47_u22.nsg13_hv_pmos[ige]
print @n.xbgr.xm47_u22.nsg13_hv_pmos[ise]
print @n.xbgr.xm47_u22.nsg13_hv_pmos[ibe]
print @n.xbgr.xm47_u22.nsg13_hv_pmos[ctype]
print @n.xbgr.xm47_u23.nsg13_hv_pmos[ide]
print @n.xbgr.xm47_u23.nsg13_hv_pmos[ige]
print @n.xbgr.xm47_u23.nsg13_hv_pmos[ise]
print @n.xbgr.xm47_u23.nsg13_hv_pmos[ibe]
print @n.xbgr.xm47_u23.nsg13_hv_pmos[ctype]
print @n.xbgr.xm47_u24.nsg13_hv_pmos[ide]
print @n.xbgr.xm47_u24.nsg13_hv_pmos[ige]
print @n.xbgr.xm47_u24.nsg13_hv_pmos[ise]
print @n.xbgr.xm47_u24.nsg13_hv_pmos[ibe]
print @n.xbgr.xm47_u24.nsg13_hv_pmos[ctype]
print @n.xbgr.xm48_u2.nsg13_hv_pmos[ide]
print @n.xbgr.xm48_u2.nsg13_hv_pmos[ige]
print @n.xbgr.xm48_u2.nsg13_hv_pmos[ise]
print @n.xbgr.xm48_u2.nsg13_hv_pmos[ibe]
print @n.xbgr.xm48_u2.nsg13_hv_pmos[ctype]
print @n.xbgr.xm48_u3.nsg13_hv_pmos[ide]
print @n.xbgr.xm48_u3.nsg13_hv_pmos[ige]
print @n.xbgr.xm48_u3.nsg13_hv_pmos[ise]
print @n.xbgr.xm48_u3.nsg13_hv_pmos[ibe]
print @n.xbgr.xm48_u3.nsg13_hv_pmos[ctype]
print @n.xbgr.xm48_u4.nsg13_hv_pmos[ide]
print @n.xbgr.xm48_u4.nsg13_hv_pmos[ige]
print @n.xbgr.xm48_u4.nsg13_hv_pmos[ise]
print @n.xbgr.xm48_u4.nsg13_hv_pmos[ibe]
print @n.xbgr.xm48_u4.nsg13_hv_pmos[ctype]
print @n.xbgr.xm48_u5.nsg13_hv_pmos[ide]
print @n.xbgr.xm48_u5.nsg13_hv_pmos[ige]
print @n.xbgr.xm48_u5.nsg13_hv_pmos[ise]
print @n.xbgr.xm48_u5.nsg13_hv_pmos[ibe]
print @n.xbgr.xm48_u5.nsg13_hv_pmos[ctype]
print @n.xbgr.xm48_u6.nsg13_hv_pmos[ide]
print @n.xbgr.xm48_u6.nsg13_hv_pmos[ige]
print @n.xbgr.xm48_u6.nsg13_hv_pmos[ise]
print @n.xbgr.xm48_u6.nsg13_hv_pmos[ibe]
print @n.xbgr.xm48_u6.nsg13_hv_pmos[ctype]
print @n.xbgr.xm48_u7.nsg13_hv_pmos[ide]
print @n.xbgr.xm48_u7.nsg13_hv_pmos[ige]
print @n.xbgr.xm48_u7.nsg13_hv_pmos[ise]
print @n.xbgr.xm48_u7.nsg13_hv_pmos[ibe]
print @n.xbgr.xm48_u7.nsg13_hv_pmos[ctype]
print @n.xbgr.xm48_u8.nsg13_hv_pmos[ide]
print @n.xbgr.xm48_u8.nsg13_hv_pmos[ige]
print @n.xbgr.xm48_u8.nsg13_hv_pmos[ise]
print @n.xbgr.xm48_u8.nsg13_hv_pmos[ibe]
print @n.xbgr.xm48_u8.nsg13_hv_pmos[ctype]
print @n.xbgr.xm48_u9.nsg13_hv_pmos[ide]
print @n.xbgr.xm48_u9.nsg13_hv_pmos[ige]
print @n.xbgr.xm48_u9.nsg13_hv_pmos[ise]
print @n.xbgr.xm48_u9.nsg13_hv_pmos[ibe]
print @n.xbgr.xm48_u9.nsg13_hv_pmos[ctype]
print @n.xbgr.xm48_u10.nsg13_hv_pmos[ide]
print @n.xbgr.xm48_u10.nsg13_hv_pmos[ige]
print @n.xbgr.xm48_u10.nsg13_hv_pmos[ise]
print @n.xbgr.xm48_u10.nsg13_hv_pmos[ibe]
print @n.xbgr.xm48_u10.nsg13_hv_pmos[ctype]
print @n.xbgr.xm48_u11.nsg13_hv_pmos[ide]
print @n.xbgr.xm48_u11.nsg13_hv_pmos[ige]
print @n.xbgr.xm48_u11.nsg13_hv_pmos[ise]
print @n.xbgr.xm48_u11.nsg13_hv_pmos[ibe]
print @n.xbgr.xm48_u11.nsg13_hv_pmos[ctype]
print @n.xbgr.xm48_u12.nsg13_hv_pmos[ide]
print @n.xbgr.xm48_u12.nsg13_hv_pmos[ige]
print @n.xbgr.xm48_u12.nsg13_hv_pmos[ise]
print @n.xbgr.xm48_u12.nsg13_hv_pmos[ibe]
print @n.xbgr.xm48_u12.nsg13_hv_pmos[ctype]
print @n.xbgr.xm48_u13.nsg13_hv_pmos[ide]
print @n.xbgr.xm48_u13.nsg13_hv_pmos[ige]
print @n.xbgr.xm48_u13.nsg13_hv_pmos[ise]
print @n.xbgr.xm48_u13.nsg13_hv_pmos[ibe]
print @n.xbgr.xm48_u13.nsg13_hv_pmos[ctype]
print @n.xbgr.xm48_u14.nsg13_hv_pmos[ide]
print @n.xbgr.xm48_u14.nsg13_hv_pmos[ige]
print @n.xbgr.xm48_u14.nsg13_hv_pmos[ise]
print @n.xbgr.xm48_u14.nsg13_hv_pmos[ibe]
print @n.xbgr.xm48_u14.nsg13_hv_pmos[ctype]
print @n.xbgr.xm48_u15.nsg13_hv_pmos[ide]
print @n.xbgr.xm48_u15.nsg13_hv_pmos[ige]
print @n.xbgr.xm48_u15.nsg13_hv_pmos[ise]
print @n.xbgr.xm48_u15.nsg13_hv_pmos[ibe]
print @n.xbgr.xm48_u15.nsg13_hv_pmos[ctype]
print @n.xbgr.xm48_u16.nsg13_hv_pmos[ide]
print @n.xbgr.xm48_u16.nsg13_hv_pmos[ige]
print @n.xbgr.xm48_u16.nsg13_hv_pmos[ise]
print @n.xbgr.xm48_u16.nsg13_hv_pmos[ibe]
print @n.xbgr.xm48_u16.nsg13_hv_pmos[ctype]
print @n.xbgr.xm48_u17.nsg13_hv_pmos[ide]
print @n.xbgr.xm48_u17.nsg13_hv_pmos[ige]
print @n.xbgr.xm48_u17.nsg13_hv_pmos[ise]
print @n.xbgr.xm48_u17.nsg13_hv_pmos[ibe]
print @n.xbgr.xm48_u17.nsg13_hv_pmos[ctype]
print @n.xbgr.xm48_u18.nsg13_hv_pmos[ide]
print @n.xbgr.xm48_u18.nsg13_hv_pmos[ige]
print @n.xbgr.xm48_u18.nsg13_hv_pmos[ise]
print @n.xbgr.xm48_u18.nsg13_hv_pmos[ibe]
print @n.xbgr.xm48_u18.nsg13_hv_pmos[ctype]
print @n.xbgr.xm48_u19.nsg13_hv_pmos[ide]
print @n.xbgr.xm48_u19.nsg13_hv_pmos[ige]
print @n.xbgr.xm48_u19.nsg13_hv_pmos[ise]
print @n.xbgr.xm48_u19.nsg13_hv_pmos[ibe]
print @n.xbgr.xm48_u19.nsg13_hv_pmos[ctype]
print @n.xbgr.xm48_u20.nsg13_hv_pmos[ide]
print @n.xbgr.xm48_u20.nsg13_hv_pmos[ige]
print @n.xbgr.xm48_u20.nsg13_hv_pmos[ise]
print @n.xbgr.xm48_u20.nsg13_hv_pmos[ibe]
print @n.xbgr.xm48_u20.nsg13_hv_pmos[ctype]
print @n.xbgr.xm48_u21.nsg13_hv_pmos[ide]
print @n.xbgr.xm48_u21.nsg13_hv_pmos[ige]
print @n.xbgr.xm48_u21.nsg13_hv_pmos[ise]
print @n.xbgr.xm48_u21.nsg13_hv_pmos[ibe]
print @n.xbgr.xm48_u21.nsg13_hv_pmos[ctype]
print @n.xbgr.xm48_u22.nsg13_hv_pmos[ide]
print @n.xbgr.xm48_u22.nsg13_hv_pmos[ige]
print @n.xbgr.xm48_u22.nsg13_hv_pmos[ise]
print @n.xbgr.xm48_u22.nsg13_hv_pmos[ibe]
print @n.xbgr.xm48_u22.nsg13_hv_pmos[ctype]
print @n.xbgr.xm48_u23.nsg13_hv_pmos[ide]
print @n.xbgr.xm48_u23.nsg13_hv_pmos[ige]
print @n.xbgr.xm48_u23.nsg13_hv_pmos[ise]
print @n.xbgr.xm48_u23.nsg13_hv_pmos[ibe]
print @n.xbgr.xm48_u23.nsg13_hv_pmos[ctype]
print @n.xbgr.xm48_u24.nsg13_hv_pmos[ide]
print @n.xbgr.xm48_u24.nsg13_hv_pmos[ige]
print @n.xbgr.xm48_u24.nsg13_hv_pmos[ise]
print @n.xbgr.xm48_u24.nsg13_hv_pmos[ibe]
print @n.xbgr.xm48_u24.nsg13_hv_pmos[ctype]
print @n.xbgr.xm50_u2.nsg13_hv_pmos[ide]
print @n.xbgr.xm50_u2.nsg13_hv_pmos[ige]
print @n.xbgr.xm50_u2.nsg13_hv_pmos[ise]
print @n.xbgr.xm50_u2.nsg13_hv_pmos[ibe]
print @n.xbgr.xm50_u2.nsg13_hv_pmos[ctype]
print @n.xbgr.xm50_u3.nsg13_hv_pmos[ide]
print @n.xbgr.xm50_u3.nsg13_hv_pmos[ige]
print @n.xbgr.xm50_u3.nsg13_hv_pmos[ise]
print @n.xbgr.xm50_u3.nsg13_hv_pmos[ibe]
print @n.xbgr.xm50_u3.nsg13_hv_pmos[ctype]
print @n.xbgr.xm50_u4.nsg13_hv_pmos[ide]
print @n.xbgr.xm50_u4.nsg13_hv_pmos[ige]
print @n.xbgr.xm50_u4.nsg13_hv_pmos[ise]
print @n.xbgr.xm50_u4.nsg13_hv_pmos[ibe]
print @n.xbgr.xm50_u4.nsg13_hv_pmos[ctype]
print @n.xbgr.xm50_u5.nsg13_hv_pmos[ide]
print @n.xbgr.xm50_u5.nsg13_hv_pmos[ige]
print @n.xbgr.xm50_u5.nsg13_hv_pmos[ise]
print @n.xbgr.xm50_u5.nsg13_hv_pmos[ibe]
print @n.xbgr.xm50_u5.nsg13_hv_pmos[ctype]
print @n.xbgr.xm50_u6.nsg13_hv_pmos[ide]
print @n.xbgr.xm50_u6.nsg13_hv_pmos[ige]
print @n.xbgr.xm50_u6.nsg13_hv_pmos[ise]
print @n.xbgr.xm50_u6.nsg13_hv_pmos[ibe]
print @n.xbgr.xm50_u6.nsg13_hv_pmos[ctype]
print @n.xbgr.xm50_u7.nsg13_hv_pmos[ide]
print @n.xbgr.xm50_u7.nsg13_hv_pmos[ige]
print @n.xbgr.xm50_u7.nsg13_hv_pmos[ise]
print @n.xbgr.xm50_u7.nsg13_hv_pmos[ibe]
print @n.xbgr.xm50_u7.nsg13_hv_pmos[ctype]
print @n.xbgr.xm50_u8.nsg13_hv_pmos[ide]
print @n.xbgr.xm50_u8.nsg13_hv_pmos[ige]
print @n.xbgr.xm50_u8.nsg13_hv_pmos[ise]
print @n.xbgr.xm50_u8.nsg13_hv_pmos[ibe]
print @n.xbgr.xm50_u8.nsg13_hv_pmos[ctype]
print @n.xbgr.xm50_u9.nsg13_hv_pmos[ide]
print @n.xbgr.xm50_u9.nsg13_hv_pmos[ige]
print @n.xbgr.xm50_u9.nsg13_hv_pmos[ise]
print @n.xbgr.xm50_u9.nsg13_hv_pmos[ibe]
print @n.xbgr.xm50_u9.nsg13_hv_pmos[ctype]
print @n.xbgr.xm50_u10.nsg13_hv_pmos[ide]
print @n.xbgr.xm50_u10.nsg13_hv_pmos[ige]
print @n.xbgr.xm50_u10.nsg13_hv_pmos[ise]
print @n.xbgr.xm50_u10.nsg13_hv_pmos[ibe]
print @n.xbgr.xm50_u10.nsg13_hv_pmos[ctype]
print @n.xbgr.xm50_u11.nsg13_hv_pmos[ide]
print @n.xbgr.xm50_u11.nsg13_hv_pmos[ige]
print @n.xbgr.xm50_u11.nsg13_hv_pmos[ise]
print @n.xbgr.xm50_u11.nsg13_hv_pmos[ibe]
print @n.xbgr.xm50_u11.nsg13_hv_pmos[ctype]
print @n.xbgr.xm50_u12.nsg13_hv_pmos[ide]
print @n.xbgr.xm50_u12.nsg13_hv_pmos[ige]
print @n.xbgr.xm50_u12.nsg13_hv_pmos[ise]
print @n.xbgr.xm50_u12.nsg13_hv_pmos[ibe]
print @n.xbgr.xm50_u12.nsg13_hv_pmos[ctype]
print @n.xbgr.xm50_u13.nsg13_hv_pmos[ide]
print @n.xbgr.xm50_u13.nsg13_hv_pmos[ige]
print @n.xbgr.xm50_u13.nsg13_hv_pmos[ise]
print @n.xbgr.xm50_u13.nsg13_hv_pmos[ibe]
print @n.xbgr.xm50_u13.nsg13_hv_pmos[ctype]
print @n.xbgr.xm50_u14.nsg13_hv_pmos[ide]
print @n.xbgr.xm50_u14.nsg13_hv_pmos[ige]
print @n.xbgr.xm50_u14.nsg13_hv_pmos[ise]
print @n.xbgr.xm50_u14.nsg13_hv_pmos[ibe]
print @n.xbgr.xm50_u14.nsg13_hv_pmos[ctype]
print @n.xbgr.xm50_u15.nsg13_hv_pmos[ide]
print @n.xbgr.xm50_u15.nsg13_hv_pmos[ige]
print @n.xbgr.xm50_u15.nsg13_hv_pmos[ise]
print @n.xbgr.xm50_u15.nsg13_hv_pmos[ibe]
print @n.xbgr.xm50_u15.nsg13_hv_pmos[ctype]
print @n.xbgr.xm50_u16.nsg13_hv_pmos[ide]
print @n.xbgr.xm50_u16.nsg13_hv_pmos[ige]
print @n.xbgr.xm50_u16.nsg13_hv_pmos[ise]
print @n.xbgr.xm50_u16.nsg13_hv_pmos[ibe]
print @n.xbgr.xm50_u16.nsg13_hv_pmos[ctype]
print @n.xbgr.xm50_u17.nsg13_hv_pmos[ide]
print @n.xbgr.xm50_u17.nsg13_hv_pmos[ige]
print @n.xbgr.xm50_u17.nsg13_hv_pmos[ise]
print @n.xbgr.xm50_u17.nsg13_hv_pmos[ibe]
print @n.xbgr.xm50_u17.nsg13_hv_pmos[ctype]
print @n.xbgr.xm50_u18.nsg13_hv_pmos[ide]
print @n.xbgr.xm50_u18.nsg13_hv_pmos[ige]
print @n.xbgr.xm50_u18.nsg13_hv_pmos[ise]
print @n.xbgr.xm50_u18.nsg13_hv_pmos[ibe]
print @n.xbgr.xm50_u18.nsg13_hv_pmos[ctype]
print @n.xbgr.xm50_u19.nsg13_hv_pmos[ide]
print @n.xbgr.xm50_u19.nsg13_hv_pmos[ige]
print @n.xbgr.xm50_u19.nsg13_hv_pmos[ise]
print @n.xbgr.xm50_u19.nsg13_hv_pmos[ibe]
print @n.xbgr.xm50_u19.nsg13_hv_pmos[ctype]
print @n.xbgr.xm50_u20.nsg13_hv_pmos[ide]
print @n.xbgr.xm50_u20.nsg13_hv_pmos[ige]
print @n.xbgr.xm50_u20.nsg13_hv_pmos[ise]
print @n.xbgr.xm50_u20.nsg13_hv_pmos[ibe]
print @n.xbgr.xm50_u20.nsg13_hv_pmos[ctype]
print @n.xbgr.xm50_u21.nsg13_hv_pmos[ide]
print @n.xbgr.xm50_u21.nsg13_hv_pmos[ige]
print @n.xbgr.xm50_u21.nsg13_hv_pmos[ise]
print @n.xbgr.xm50_u21.nsg13_hv_pmos[ibe]
print @n.xbgr.xm50_u21.nsg13_hv_pmos[ctype]
print @n.xbgr.xm50_u22.nsg13_hv_pmos[ide]
print @n.xbgr.xm50_u22.nsg13_hv_pmos[ige]
print @n.xbgr.xm50_u22.nsg13_hv_pmos[ise]
print @n.xbgr.xm50_u22.nsg13_hv_pmos[ibe]
print @n.xbgr.xm50_u22.nsg13_hv_pmos[ctype]
print @n.xbgr.xm50_u23.nsg13_hv_pmos[ide]
print @n.xbgr.xm50_u23.nsg13_hv_pmos[ige]
print @n.xbgr.xm50_u23.nsg13_hv_pmos[ise]
print @n.xbgr.xm50_u23.nsg13_hv_pmos[ibe]
print @n.xbgr.xm50_u23.nsg13_hv_pmos[ctype]
print @n.xbgr.xm50_u24.nsg13_hv_pmos[ide]
print @n.xbgr.xm50_u24.nsg13_hv_pmos[ige]
print @n.xbgr.xm50_u24.nsg13_hv_pmos[ise]
print @n.xbgr.xm50_u24.nsg13_hv_pmos[ibe]
print @n.xbgr.xm50_u24.nsg13_hv_pmos[ctype]
print @n.xbgr.xm51_u2.nsg13_hv_pmos[ide]
print @n.xbgr.xm51_u2.nsg13_hv_pmos[ige]
print @n.xbgr.xm51_u2.nsg13_hv_pmos[ise]
print @n.xbgr.xm51_u2.nsg13_hv_pmos[ibe]
print @n.xbgr.xm51_u2.nsg13_hv_pmos[ctype]
print @n.xbgr.xm51_u3.nsg13_hv_pmos[ide]
print @n.xbgr.xm51_u3.nsg13_hv_pmos[ige]
print @n.xbgr.xm51_u3.nsg13_hv_pmos[ise]
print @n.xbgr.xm51_u3.nsg13_hv_pmos[ibe]
print @n.xbgr.xm51_u3.nsg13_hv_pmos[ctype]
print @n.xbgr.xm51_u4.nsg13_hv_pmos[ide]
print @n.xbgr.xm51_u4.nsg13_hv_pmos[ige]
print @n.xbgr.xm51_u4.nsg13_hv_pmos[ise]
print @n.xbgr.xm51_u4.nsg13_hv_pmos[ibe]
print @n.xbgr.xm51_u4.nsg13_hv_pmos[ctype]
print @n.xbgr.xm52_u2.nsg13_hv_pmos[ide]
print @n.xbgr.xm52_u2.nsg13_hv_pmos[ige]
print @n.xbgr.xm52_u2.nsg13_hv_pmos[ise]
print @n.xbgr.xm52_u2.nsg13_hv_pmos[ibe]
print @n.xbgr.xm52_u2.nsg13_hv_pmos[ctype]
print @n.xbgr.xm52_u3.nsg13_hv_pmos[ide]
print @n.xbgr.xm52_u3.nsg13_hv_pmos[ige]
print @n.xbgr.xm52_u3.nsg13_hv_pmos[ise]
print @n.xbgr.xm52_u3.nsg13_hv_pmos[ibe]
print @n.xbgr.xm52_u3.nsg13_hv_pmos[ctype]
print @n.xbgr.xm52_u4.nsg13_hv_pmos[ide]
print @n.xbgr.xm52_u4.nsg13_hv_pmos[ige]
print @n.xbgr.xm52_u4.nsg13_hv_pmos[ise]
print @n.xbgr.xm52_u4.nsg13_hv_pmos[ibe]
print @n.xbgr.xm52_u4.nsg13_hv_pmos[ctype]
print @n.xbgr.xm52_u5.nsg13_hv_pmos[ide]
print @n.xbgr.xm52_u5.nsg13_hv_pmos[ige]
print @n.xbgr.xm52_u5.nsg13_hv_pmos[ise]
print @n.xbgr.xm52_u5.nsg13_hv_pmos[ibe]
print @n.xbgr.xm52_u5.nsg13_hv_pmos[ctype]
print @n.xbgr.xm52_u6.nsg13_hv_pmos[ide]
print @n.xbgr.xm52_u6.nsg13_hv_pmos[ige]
print @n.xbgr.xm52_u6.nsg13_hv_pmos[ise]
print @n.xbgr.xm52_u6.nsg13_hv_pmos[ibe]
print @n.xbgr.xm52_u6.nsg13_hv_pmos[ctype]
print @n.xbgr.xm52_u7.nsg13_hv_pmos[ide]
print @n.xbgr.xm52_u7.nsg13_hv_pmos[ige]
print @n.xbgr.xm52_u7.nsg13_hv_pmos[ise]
print @n.xbgr.xm52_u7.nsg13_hv_pmos[ibe]
print @n.xbgr.xm52_u7.nsg13_hv_pmos[ctype]
print @n.xbgr.xm52_u8.nsg13_hv_pmos[ide]
print @n.xbgr.xm52_u8.nsg13_hv_pmos[ige]
print @n.xbgr.xm52_u8.nsg13_hv_pmos[ise]
print @n.xbgr.xm52_u8.nsg13_hv_pmos[ibe]
print @n.xbgr.xm52_u8.nsg13_hv_pmos[ctype]
print @n.xbgr.xm52_u9.nsg13_hv_pmos[ide]
print @n.xbgr.xm52_u9.nsg13_hv_pmos[ige]
print @n.xbgr.xm52_u9.nsg13_hv_pmos[ise]
print @n.xbgr.xm52_u9.nsg13_hv_pmos[ibe]
print @n.xbgr.xm52_u9.nsg13_hv_pmos[ctype]
print @n.xbgr.xm52_u10.nsg13_hv_pmos[ide]
print @n.xbgr.xm52_u10.nsg13_hv_pmos[ige]
print @n.xbgr.xm52_u10.nsg13_hv_pmos[ise]
print @n.xbgr.xm52_u10.nsg13_hv_pmos[ibe]
print @n.xbgr.xm52_u10.nsg13_hv_pmos[ctype]
print @n.xbgr.xm52_u11.nsg13_hv_pmos[ide]
print @n.xbgr.xm52_u11.nsg13_hv_pmos[ige]
print @n.xbgr.xm52_u11.nsg13_hv_pmos[ise]
print @n.xbgr.xm52_u11.nsg13_hv_pmos[ibe]
print @n.xbgr.xm52_u11.nsg13_hv_pmos[ctype]
print @n.xbgr.xm52_u12.nsg13_hv_pmos[ide]
print @n.xbgr.xm52_u12.nsg13_hv_pmos[ige]
print @n.xbgr.xm52_u12.nsg13_hv_pmos[ise]
print @n.xbgr.xm52_u12.nsg13_hv_pmos[ibe]
print @n.xbgr.xm52_u12.nsg13_hv_pmos[ctype]
print @n.xbgr.xm52_u13.nsg13_hv_pmos[ide]
print @n.xbgr.xm52_u13.nsg13_hv_pmos[ige]
print @n.xbgr.xm52_u13.nsg13_hv_pmos[ise]
print @n.xbgr.xm52_u13.nsg13_hv_pmos[ibe]
print @n.xbgr.xm52_u13.nsg13_hv_pmos[ctype]
print @n.xbgr.xm52_u14.nsg13_hv_pmos[ide]
print @n.xbgr.xm52_u14.nsg13_hv_pmos[ige]
print @n.xbgr.xm52_u14.nsg13_hv_pmos[ise]
print @n.xbgr.xm52_u14.nsg13_hv_pmos[ibe]
print @n.xbgr.xm52_u14.nsg13_hv_pmos[ctype]
print @n.xbgr.xm52_u15.nsg13_hv_pmos[ide]
print @n.xbgr.xm52_u15.nsg13_hv_pmos[ige]
print @n.xbgr.xm52_u15.nsg13_hv_pmos[ise]
print @n.xbgr.xm52_u15.nsg13_hv_pmos[ibe]
print @n.xbgr.xm52_u15.nsg13_hv_pmos[ctype]
print @n.xbgr.xm52_u16.nsg13_hv_pmos[ide]
print @n.xbgr.xm52_u16.nsg13_hv_pmos[ige]
print @n.xbgr.xm52_u16.nsg13_hv_pmos[ise]
print @n.xbgr.xm52_u16.nsg13_hv_pmos[ibe]
print @n.xbgr.xm52_u16.nsg13_hv_pmos[ctype]
print @n.xbgr.xm52_u17.nsg13_hv_pmos[ide]
print @n.xbgr.xm52_u17.nsg13_hv_pmos[ige]
print @n.xbgr.xm52_u17.nsg13_hv_pmos[ise]
print @n.xbgr.xm52_u17.nsg13_hv_pmos[ibe]
print @n.xbgr.xm52_u17.nsg13_hv_pmos[ctype]
print @n.xbgr.xm52_u18.nsg13_hv_pmos[ide]
print @n.xbgr.xm52_u18.nsg13_hv_pmos[ige]
print @n.xbgr.xm52_u18.nsg13_hv_pmos[ise]
print @n.xbgr.xm52_u18.nsg13_hv_pmos[ibe]
print @n.xbgr.xm52_u18.nsg13_hv_pmos[ctype]
print @n.xbgr.xm52_u19.nsg13_hv_pmos[ide]
print @n.xbgr.xm52_u19.nsg13_hv_pmos[ige]
print @n.xbgr.xm52_u19.nsg13_hv_pmos[ise]
print @n.xbgr.xm52_u19.nsg13_hv_pmos[ibe]
print @n.xbgr.xm52_u19.nsg13_hv_pmos[ctype]
print @n.xbgr.xm52_u20.nsg13_hv_pmos[ide]
print @n.xbgr.xm52_u20.nsg13_hv_pmos[ige]
print @n.xbgr.xm52_u20.nsg13_hv_pmos[ise]
print @n.xbgr.xm52_u20.nsg13_hv_pmos[ibe]
print @n.xbgr.xm52_u20.nsg13_hv_pmos[ctype]
print @n.xbgr.xm52_u21.nsg13_hv_pmos[ide]
print @n.xbgr.xm52_u21.nsg13_hv_pmos[ige]
print @n.xbgr.xm52_u21.nsg13_hv_pmos[ise]
print @n.xbgr.xm52_u21.nsg13_hv_pmos[ibe]
print @n.xbgr.xm52_u21.nsg13_hv_pmos[ctype]
print @n.xbgr.xm52_u22.nsg13_hv_pmos[ide]
print @n.xbgr.xm52_u22.nsg13_hv_pmos[ige]
print @n.xbgr.xm52_u22.nsg13_hv_pmos[ise]
print @n.xbgr.xm52_u22.nsg13_hv_pmos[ibe]
print @n.xbgr.xm52_u22.nsg13_hv_pmos[ctype]
print @n.xbgr.xm52_u23.nsg13_hv_pmos[ide]
print @n.xbgr.xm52_u23.nsg13_hv_pmos[ige]
print @n.xbgr.xm52_u23.nsg13_hv_pmos[ise]
print @n.xbgr.xm52_u23.nsg13_hv_pmos[ibe]
print @n.xbgr.xm52_u23.nsg13_hv_pmos[ctype]
print @n.xbgr.xm52_u24.nsg13_hv_pmos[ide]
print @n.xbgr.xm52_u24.nsg13_hv_pmos[ige]
print @n.xbgr.xm52_u24.nsg13_hv_pmos[ise]
print @n.xbgr.xm52_u24.nsg13_hv_pmos[ibe]
print @n.xbgr.xm52_u24.nsg13_hv_pmos[ctype]
print @n.xbgr.xm54_u2.nsg13_hv_pmos[ide]
print @n.xbgr.xm54_u2.nsg13_hv_pmos[ige]
print @n.xbgr.xm54_u2.nsg13_hv_pmos[ise]
print @n.xbgr.xm54_u2.nsg13_hv_pmos[ibe]
print @n.xbgr.xm54_u2.nsg13_hv_pmos[ctype]
print @n.xbgr.xm54_u3.nsg13_hv_pmos[ide]
print @n.xbgr.xm54_u3.nsg13_hv_pmos[ige]
print @n.xbgr.xm54_u3.nsg13_hv_pmos[ise]
print @n.xbgr.xm54_u3.nsg13_hv_pmos[ibe]
print @n.xbgr.xm54_u3.nsg13_hv_pmos[ctype]
print @n.xbgr.xm54_u4.nsg13_hv_pmos[ide]
print @n.xbgr.xm54_u4.nsg13_hv_pmos[ige]
print @n.xbgr.xm54_u4.nsg13_hv_pmos[ise]
print @n.xbgr.xm54_u4.nsg13_hv_pmos[ibe]
print @n.xbgr.xm54_u4.nsg13_hv_pmos[ctype]
print @n.xbgr.xm54_u5.nsg13_hv_pmos[ide]
print @n.xbgr.xm54_u5.nsg13_hv_pmos[ige]
print @n.xbgr.xm54_u5.nsg13_hv_pmos[ise]
print @n.xbgr.xm54_u5.nsg13_hv_pmos[ibe]
print @n.xbgr.xm54_u5.nsg13_hv_pmos[ctype]
print @n.xbgr.xm54_u6.nsg13_hv_pmos[ide]
print @n.xbgr.xm54_u6.nsg13_hv_pmos[ige]
print @n.xbgr.xm54_u6.nsg13_hv_pmos[ise]
print @n.xbgr.xm54_u6.nsg13_hv_pmos[ibe]
print @n.xbgr.xm54_u6.nsg13_hv_pmos[ctype]
print @n.xbgr.xm54_u7.nsg13_hv_pmos[ide]
print @n.xbgr.xm54_u7.nsg13_hv_pmos[ige]
print @n.xbgr.xm54_u7.nsg13_hv_pmos[ise]
print @n.xbgr.xm54_u7.nsg13_hv_pmos[ibe]
print @n.xbgr.xm54_u7.nsg13_hv_pmos[ctype]
print @n.xbgr.xm54_u8.nsg13_hv_pmos[ide]
print @n.xbgr.xm54_u8.nsg13_hv_pmos[ige]
print @n.xbgr.xm54_u8.nsg13_hv_pmos[ise]
print @n.xbgr.xm54_u8.nsg13_hv_pmos[ibe]
print @n.xbgr.xm54_u8.nsg13_hv_pmos[ctype]
print @n.xbgr.xm54_u9.nsg13_hv_pmos[ide]
print @n.xbgr.xm54_u9.nsg13_hv_pmos[ige]
print @n.xbgr.xm54_u9.nsg13_hv_pmos[ise]
print @n.xbgr.xm54_u9.nsg13_hv_pmos[ibe]
print @n.xbgr.xm54_u9.nsg13_hv_pmos[ctype]
print @n.xbgr.xm54_u10.nsg13_hv_pmos[ide]
print @n.xbgr.xm54_u10.nsg13_hv_pmos[ige]
print @n.xbgr.xm54_u10.nsg13_hv_pmos[ise]
print @n.xbgr.xm54_u10.nsg13_hv_pmos[ibe]
print @n.xbgr.xm54_u10.nsg13_hv_pmos[ctype]
print @n.xbgr.xm54_u11.nsg13_hv_pmos[ide]
print @n.xbgr.xm54_u11.nsg13_hv_pmos[ige]
print @n.xbgr.xm54_u11.nsg13_hv_pmos[ise]
print @n.xbgr.xm54_u11.nsg13_hv_pmos[ibe]
print @n.xbgr.xm54_u11.nsg13_hv_pmos[ctype]
print @n.xbgr.xm54_u12.nsg13_hv_pmos[ide]
print @n.xbgr.xm54_u12.nsg13_hv_pmos[ige]
print @n.xbgr.xm54_u12.nsg13_hv_pmos[ise]
print @n.xbgr.xm54_u12.nsg13_hv_pmos[ibe]
print @n.xbgr.xm54_u12.nsg13_hv_pmos[ctype]
print @n.xbgr.xm54_u13.nsg13_hv_pmos[ide]
print @n.xbgr.xm54_u13.nsg13_hv_pmos[ige]
print @n.xbgr.xm54_u13.nsg13_hv_pmos[ise]
print @n.xbgr.xm54_u13.nsg13_hv_pmos[ibe]
print @n.xbgr.xm54_u13.nsg13_hv_pmos[ctype]
print @n.xbgr.xm54_u14.nsg13_hv_pmos[ide]
print @n.xbgr.xm54_u14.nsg13_hv_pmos[ige]
print @n.xbgr.xm54_u14.nsg13_hv_pmos[ise]
print @n.xbgr.xm54_u14.nsg13_hv_pmos[ibe]
print @n.xbgr.xm54_u14.nsg13_hv_pmos[ctype]
print @n.xbgr.xm54_u15.nsg13_hv_pmos[ide]
print @n.xbgr.xm54_u15.nsg13_hv_pmos[ige]
print @n.xbgr.xm54_u15.nsg13_hv_pmos[ise]
print @n.xbgr.xm54_u15.nsg13_hv_pmos[ibe]
print @n.xbgr.xm54_u15.nsg13_hv_pmos[ctype]
print @n.xbgr.xm54_u16.nsg13_hv_pmos[ide]
print @n.xbgr.xm54_u16.nsg13_hv_pmos[ige]
print @n.xbgr.xm54_u16.nsg13_hv_pmos[ise]
print @n.xbgr.xm54_u16.nsg13_hv_pmos[ibe]
print @n.xbgr.xm54_u16.nsg13_hv_pmos[ctype]
print @n.xbgr.xm54_u17.nsg13_hv_pmos[ide]
print @n.xbgr.xm54_u17.nsg13_hv_pmos[ige]
print @n.xbgr.xm54_u17.nsg13_hv_pmos[ise]
print @n.xbgr.xm54_u17.nsg13_hv_pmos[ibe]
print @n.xbgr.xm54_u17.nsg13_hv_pmos[ctype]
print @n.xbgr.xm54_u18.nsg13_hv_pmos[ide]
print @n.xbgr.xm54_u18.nsg13_hv_pmos[ige]
print @n.xbgr.xm54_u18.nsg13_hv_pmos[ise]
print @n.xbgr.xm54_u18.nsg13_hv_pmos[ibe]
print @n.xbgr.xm54_u18.nsg13_hv_pmos[ctype]
print @n.xbgr.xm54_u19.nsg13_hv_pmos[ide]
print @n.xbgr.xm54_u19.nsg13_hv_pmos[ige]
print @n.xbgr.xm54_u19.nsg13_hv_pmos[ise]
print @n.xbgr.xm54_u19.nsg13_hv_pmos[ibe]
print @n.xbgr.xm54_u19.nsg13_hv_pmos[ctype]
print @n.xbgr.xm54_u20.nsg13_hv_pmos[ide]
print @n.xbgr.xm54_u20.nsg13_hv_pmos[ige]
print @n.xbgr.xm54_u20.nsg13_hv_pmos[ise]
print @n.xbgr.xm54_u20.nsg13_hv_pmos[ibe]
print @n.xbgr.xm54_u20.nsg13_hv_pmos[ctype]
print @n.xbgr.xm54_u21.nsg13_hv_pmos[ide]
print @n.xbgr.xm54_u21.nsg13_hv_pmos[ige]
print @n.xbgr.xm54_u21.nsg13_hv_pmos[ise]
print @n.xbgr.xm54_u21.nsg13_hv_pmos[ibe]
print @n.xbgr.xm54_u21.nsg13_hv_pmos[ctype]
print @n.xbgr.xm54_u22.nsg13_hv_pmos[ide]
print @n.xbgr.xm54_u22.nsg13_hv_pmos[ige]
print @n.xbgr.xm54_u22.nsg13_hv_pmos[ise]
print @n.xbgr.xm54_u22.nsg13_hv_pmos[ibe]
print @n.xbgr.xm54_u22.nsg13_hv_pmos[ctype]
print @n.xbgr.xm54_u23.nsg13_hv_pmos[ide]
print @n.xbgr.xm54_u23.nsg13_hv_pmos[ige]
print @n.xbgr.xm54_u23.nsg13_hv_pmos[ise]
print @n.xbgr.xm54_u23.nsg13_hv_pmos[ibe]
print @n.xbgr.xm54_u23.nsg13_hv_pmos[ctype]
print @n.xbgr.xm54_u24.nsg13_hv_pmos[ide]
print @n.xbgr.xm54_u24.nsg13_hv_pmos[ige]
print @n.xbgr.xm54_u24.nsg13_hv_pmos[ise]
print @n.xbgr.xm54_u24.nsg13_hv_pmos[ibe]
print @n.xbgr.xm54_u24.nsg13_hv_pmos[ctype]
print @q.xbgr.xq56_u2.qnpn13g2[ic]
print @q.xbgr.xq56_u2.qnpn13g2[ib]
print @q.xbgr.xq56_u2.qnpn13g2[ie]
print @q.xbgr.xq56_u2.qnpn13g2[is]
print @r.xbgr.xq56_u2.rsub[i]
print @c.xbgr.xq56_u2.csub[i]
print @q.xbgr.xq56_u3.qnpn13g2[ic]
print @q.xbgr.xq56_u3.qnpn13g2[ib]
print @q.xbgr.xq56_u3.qnpn13g2[ie]
print @q.xbgr.xq56_u3.qnpn13g2[is]
print @r.xbgr.xq56_u3.rsub[i]
print @c.xbgr.xq56_u3.csub[i]
print @q.xbgr.xq56_u4.qnpn13g2[ic]
print @q.xbgr.xq56_u4.qnpn13g2[ib]
print @q.xbgr.xq56_u4.qnpn13g2[ie]
print @q.xbgr.xq56_u4.qnpn13g2[is]
print @r.xbgr.xq56_u4.rsub[i]
print @c.xbgr.xq56_u4.csub[i]
print @q.xbgr.xq56_u5.qnpn13g2[ic]
print @q.xbgr.xq56_u5.qnpn13g2[ib]
print @q.xbgr.xq56_u5.qnpn13g2[ie]
print @q.xbgr.xq56_u5.qnpn13g2[is]
print @r.xbgr.xq56_u5.rsub[i]
print @c.xbgr.xq56_u5.csub[i]
print @q.xbgr.xq56_u6.qnpn13g2[ic]
print @q.xbgr.xq56_u6.qnpn13g2[ib]
print @q.xbgr.xq56_u6.qnpn13g2[ie]
print @q.xbgr.xq56_u6.qnpn13g2[is]
print @r.xbgr.xq56_u6.rsub[i]
print @c.xbgr.xq56_u6.csub[i]
print @q.xbgr.xq56_u7.qnpn13g2[ic]
print @q.xbgr.xq56_u7.qnpn13g2[ib]
print @q.xbgr.xq56_u7.qnpn13g2[ie]
print @q.xbgr.xq56_u7.qnpn13g2[is]
print @r.xbgr.xq56_u7.rsub[i]
print @c.xbgr.xq56_u7.csub[i]
print @q.xbgr.xq56_u8.qnpn13g2[ic]
print @q.xbgr.xq56_u8.qnpn13g2[ib]
print @q.xbgr.xq56_u8.qnpn13g2[ie]
print @q.xbgr.xq56_u8.qnpn13g2[is]
print @r.xbgr.xq56_u8.rsub[i]
print @c.xbgr.xq56_u8.csub[i]
print @q.xbgr.xq56_u9.qnpn13g2[ic]
print @q.xbgr.xq56_u9.qnpn13g2[ib]
print @q.xbgr.xq56_u9.qnpn13g2[ie]
print @q.xbgr.xq56_u9.qnpn13g2[is]
print @r.xbgr.xq56_u9.rsub[i]
print @c.xbgr.xq56_u9.csub[i]
print @q.xbgr.xq56_u10.qnpn13g2[ic]
print @q.xbgr.xq56_u10.qnpn13g2[ib]
print @q.xbgr.xq56_u10.qnpn13g2[ie]
print @q.xbgr.xq56_u10.qnpn13g2[is]
print @r.xbgr.xq56_u10.rsub[i]
print @c.xbgr.xq56_u10.csub[i]
print @q.xbgr.xq56_u11.qnpn13g2[ic]
print @q.xbgr.xq56_u11.qnpn13g2[ib]
print @q.xbgr.xq56_u11.qnpn13g2[ie]
print @q.xbgr.xq56_u11.qnpn13g2[is]
print @r.xbgr.xq56_u11.rsub[i]
print @c.xbgr.xq56_u11.csub[i]
print @q.xbgr.xq56_u12.qnpn13g2[ic]
print @q.xbgr.xq56_u12.qnpn13g2[ib]
print @q.xbgr.xq56_u12.qnpn13g2[ie]
print @q.xbgr.xq56_u12.qnpn13g2[is]
print @r.xbgr.xq56_u12.rsub[i]
print @c.xbgr.xq56_u12.csub[i]
print @q.xbgr.xq56_u13.qnpn13g2[ic]
print @q.xbgr.xq56_u13.qnpn13g2[ib]
print @q.xbgr.xq56_u13.qnpn13g2[ie]
print @q.xbgr.xq56_u13.qnpn13g2[is]
print @r.xbgr.xq56_u13.rsub[i]
print @c.xbgr.xq56_u13.csub[i]
print @q.xbgr.xq56_u14.qnpn13g2[ic]
print @q.xbgr.xq56_u14.qnpn13g2[ib]
print @q.xbgr.xq56_u14.qnpn13g2[ie]
print @q.xbgr.xq56_u14.qnpn13g2[is]
print @r.xbgr.xq56_u14.rsub[i]
print @c.xbgr.xq56_u14.csub[i]
print @q.xbgr.xq56_u15.qnpn13g2[ic]
print @q.xbgr.xq56_u15.qnpn13g2[ib]
print @q.xbgr.xq56_u15.qnpn13g2[ie]
print @q.xbgr.xq56_u15.qnpn13g2[is]
print @r.xbgr.xq56_u15.rsub[i]
print @c.xbgr.xq56_u15.csub[i]
print @q.xbgr.xq56_u16.qnpn13g2[ic]
print @q.xbgr.xq56_u16.qnpn13g2[ib]
print @q.xbgr.xq56_u16.qnpn13g2[ie]
print @q.xbgr.xq56_u16.qnpn13g2[is]
print @r.xbgr.xq56_u16.rsub[i]
print @c.xbgr.xq56_u16.csub[i]
print @q.xbgr.xq56_u17.qnpn13g2[ic]
print @q.xbgr.xq56_u17.qnpn13g2[ib]
print @q.xbgr.xq56_u17.qnpn13g2[ie]
print @q.xbgr.xq56_u17.qnpn13g2[is]
print @r.xbgr.xq56_u17.rsub[i]
print @c.xbgr.xq56_u17.csub[i]
print @q.xbgr.xq56_u18.qnpn13g2[ic]
print @q.xbgr.xq56_u18.qnpn13g2[ib]
print @q.xbgr.xq56_u18.qnpn13g2[ie]
print @q.xbgr.xq56_u18.qnpn13g2[is]
print @r.xbgr.xq56_u18.rsub[i]
print @c.xbgr.xq56_u18.csub[i]
print @q.xbgr.xq56_u19.qnpn13g2[ic]
print @q.xbgr.xq56_u19.qnpn13g2[ib]
print @q.xbgr.xq56_u19.qnpn13g2[ie]
print @q.xbgr.xq56_u19.qnpn13g2[is]
print @r.xbgr.xq56_u19.rsub[i]
print @c.xbgr.xq56_u19.csub[i]
print @q.xbgr.xq56_u20.qnpn13g2[ic]
print @q.xbgr.xq56_u20.qnpn13g2[ib]
print @q.xbgr.xq56_u20.qnpn13g2[ie]
print @q.xbgr.xq56_u20.qnpn13g2[is]
print @r.xbgr.xq56_u20.rsub[i]
print @c.xbgr.xq56_u20.csub[i]
print @q.xbgr.xq56_u21.qnpn13g2[ic]
print @q.xbgr.xq56_u21.qnpn13g2[ib]
print @q.xbgr.xq56_u21.qnpn13g2[ie]
print @q.xbgr.xq56_u21.qnpn13g2[is]
print @r.xbgr.xq56_u21.rsub[i]
print @c.xbgr.xq56_u21.csub[i]
print @q.xbgr.xq56_u22.qnpn13g2[ic]
print @q.xbgr.xq56_u22.qnpn13g2[ib]
print @q.xbgr.xq56_u22.qnpn13g2[ie]
print @q.xbgr.xq56_u22.qnpn13g2[is]
print @r.xbgr.xq56_u22.rsub[i]
print @c.xbgr.xq56_u22.csub[i]
print @q.xbgr.xq56_u23.qnpn13g2[ic]
print @q.xbgr.xq56_u23.qnpn13g2[ib]
print @q.xbgr.xq56_u23.qnpn13g2[ie]
print @q.xbgr.xq56_u23.qnpn13g2[is]
print @r.xbgr.xq56_u23.rsub[i]
print @c.xbgr.xq56_u23.csub[i]
print @q.xbgr.xq56_u24.qnpn13g2[ic]
print @q.xbgr.xq56_u24.qnpn13g2[ib]
print @q.xbgr.xq56_u24.qnpn13g2[ie]
print @q.xbgr.xq56_u24.qnpn13g2[is]
print @r.xbgr.xq56_u24.rsub[i]
print @c.xbgr.xq56_u24.csub[i]
print @q.xbgr.xq60_u2.qnpn13g2[ic]
print @q.xbgr.xq60_u2.qnpn13g2[ib]
print @q.xbgr.xq60_u2.qnpn13g2[ie]
print @q.xbgr.xq60_u2.qnpn13g2[is]
print @r.xbgr.xq60_u2.rsub[i]
print @c.xbgr.xq60_u2.csub[i]
print @q.xbgr.xq60_u3.qnpn13g2[ic]
print @q.xbgr.xq60_u3.qnpn13g2[ib]
print @q.xbgr.xq60_u3.qnpn13g2[ie]
print @q.xbgr.xq60_u3.qnpn13g2[is]
print @r.xbgr.xq60_u3.rsub[i]
print @c.xbgr.xq60_u3.csub[i]
print @q.xbgr.xq60_u4.qnpn13g2[ic]
print @q.xbgr.xq60_u4.qnpn13g2[ib]
print @q.xbgr.xq60_u4.qnpn13g2[ie]
print @q.xbgr.xq60_u4.qnpn13g2[is]
print @r.xbgr.xq60_u4.rsub[i]
print @c.xbgr.xq60_u4.csub[i]
print @q.xbgr.xq62_u2.qnpn13g2[ic]
print @q.xbgr.xq62_u2.qnpn13g2[ib]
print @q.xbgr.xq62_u2.qnpn13g2[ie]
print @q.xbgr.xq62_u2.qnpn13g2[is]
print @r.xbgr.xq62_u2.rsub[i]
print @c.xbgr.xq62_u2.csub[i]
print @q.xbgr.xq62_u3.qnpn13g2[ic]
print @q.xbgr.xq62_u3.qnpn13g2[ib]
print @q.xbgr.xq62_u3.qnpn13g2[ie]
print @q.xbgr.xq62_u3.qnpn13g2[is]
print @r.xbgr.xq62_u3.rsub[i]
print @c.xbgr.xq62_u3.csub[i]
print @q.xbgr.xq62_u4.qnpn13g2[ic]
print @q.xbgr.xq62_u4.qnpn13g2[ib]
print @q.xbgr.xq62_u4.qnpn13g2[ie]
print @q.xbgr.xq62_u4.qnpn13g2[is]
print @r.xbgr.xq62_u4.rsub[i]
print @c.xbgr.xq62_u4.csub[i]
print @q.xbgr.xq62_u5.qnpn13g2[ic]
print @q.xbgr.xq62_u5.qnpn13g2[ib]
print @q.xbgr.xq62_u5.qnpn13g2[ie]
print @q.xbgr.xq62_u5.qnpn13g2[is]
print @r.xbgr.xq62_u5.rsub[i]
print @c.xbgr.xq62_u5.csub[i]
print @q.xbgr.xq62_u6.qnpn13g2[ic]
print @q.xbgr.xq62_u6.qnpn13g2[ib]
print @q.xbgr.xq62_u6.qnpn13g2[ie]
print @q.xbgr.xq62_u6.qnpn13g2[is]
print @r.xbgr.xq62_u6.rsub[i]
print @c.xbgr.xq62_u6.csub[i]
print @q.xbgr.xq62_u7.qnpn13g2[ic]
print @q.xbgr.xq62_u7.qnpn13g2[ib]
print @q.xbgr.xq62_u7.qnpn13g2[ie]
print @q.xbgr.xq62_u7.qnpn13g2[is]
print @r.xbgr.xq62_u7.rsub[i]
print @c.xbgr.xq62_u7.csub[i]
print @q.xbgr.xq62_u8.qnpn13g2[ic]
print @q.xbgr.xq62_u8.qnpn13g2[ib]
print @q.xbgr.xq62_u8.qnpn13g2[ie]
print @q.xbgr.xq62_u8.qnpn13g2[is]
print @r.xbgr.xq62_u8.rsub[i]
print @c.xbgr.xq62_u8.csub[i]
print @q.xbgr.xq62_u9.qnpn13g2[ic]
print @q.xbgr.xq62_u9.qnpn13g2[ib]
print @q.xbgr.xq62_u9.qnpn13g2[ie]
print @q.xbgr.xq62_u9.qnpn13g2[is]
print @r.xbgr.xq62_u9.rsub[i]
print @c.xbgr.xq62_u9.csub[i]
print @q.xbgr.xq62_u10.qnpn13g2[ic]
print @q.xbgr.xq62_u10.qnpn13g2[ib]
print @q.xbgr.xq62_u10.qnpn13g2[ie]
print @q.xbgr.xq62_u10.qnpn13g2[is]
print @r.xbgr.xq62_u10.rsub[i]
print @c.xbgr.xq62_u10.csub[i]
print @q.xbgr.xq62_u11.qnpn13g2[ic]
print @q.xbgr.xq62_u11.qnpn13g2[ib]
print @q.xbgr.xq62_u11.qnpn13g2[ie]
print @q.xbgr.xq62_u11.qnpn13g2[is]
print @r.xbgr.xq62_u11.rsub[i]
print @c.xbgr.xq62_u11.csub[i]
print @q.xbgr.xq62_u12.qnpn13g2[ic]
print @q.xbgr.xq62_u12.qnpn13g2[ib]
print @q.xbgr.xq62_u12.qnpn13g2[ie]
print @q.xbgr.xq62_u12.qnpn13g2[is]
print @r.xbgr.xq62_u12.rsub[i]
print @c.xbgr.xq62_u12.csub[i]
print @q.xbgr.xq62_u13.qnpn13g2[ic]
print @q.xbgr.xq62_u13.qnpn13g2[ib]
print @q.xbgr.xq62_u13.qnpn13g2[ie]
print @q.xbgr.xq62_u13.qnpn13g2[is]
print @r.xbgr.xq62_u13.rsub[i]
print @c.xbgr.xq62_u13.csub[i]
print @q.xbgr.xq62_u14.qnpn13g2[ic]
print @q.xbgr.xq62_u14.qnpn13g2[ib]
print @q.xbgr.xq62_u14.qnpn13g2[ie]
print @q.xbgr.xq62_u14.qnpn13g2[is]
print @r.xbgr.xq62_u14.rsub[i]
print @c.xbgr.xq62_u14.csub[i]
print @q.xbgr.xq62_u15.qnpn13g2[ic]
print @q.xbgr.xq62_u15.qnpn13g2[ib]
print @q.xbgr.xq62_u15.qnpn13g2[ie]
print @q.xbgr.xq62_u15.qnpn13g2[is]
print @r.xbgr.xq62_u15.rsub[i]
print @c.xbgr.xq62_u15.csub[i]
print @q.xbgr.xq62_u16.qnpn13g2[ic]
print @q.xbgr.xq62_u16.qnpn13g2[ib]
print @q.xbgr.xq62_u16.qnpn13g2[ie]
print @q.xbgr.xq62_u16.qnpn13g2[is]
print @r.xbgr.xq62_u16.rsub[i]
print @c.xbgr.xq62_u16.csub[i]
print @q.xbgr.xq62_u17.qnpn13g2[ic]
print @q.xbgr.xq62_u17.qnpn13g2[ib]
print @q.xbgr.xq62_u17.qnpn13g2[ie]
print @q.xbgr.xq62_u17.qnpn13g2[is]
print @r.xbgr.xq62_u17.rsub[i]
print @c.xbgr.xq62_u17.csub[i]
print @q.xbgr.xq62_u18.qnpn13g2[ic]
print @q.xbgr.xq62_u18.qnpn13g2[ib]
print @q.xbgr.xq62_u18.qnpn13g2[ie]
print @q.xbgr.xq62_u18.qnpn13g2[is]
print @r.xbgr.xq62_u18.rsub[i]
print @c.xbgr.xq62_u18.csub[i]
print @q.xbgr.xq62_u19.qnpn13g2[ic]
print @q.xbgr.xq62_u19.qnpn13g2[ib]
print @q.xbgr.xq62_u19.qnpn13g2[ie]
print @q.xbgr.xq62_u19.qnpn13g2[is]
print @r.xbgr.xq62_u19.rsub[i]
print @c.xbgr.xq62_u19.csub[i]
print @q.xbgr.xq62_u20.qnpn13g2[ic]
print @q.xbgr.xq62_u20.qnpn13g2[ib]
print @q.xbgr.xq62_u20.qnpn13g2[ie]
print @q.xbgr.xq62_u20.qnpn13g2[is]
print @r.xbgr.xq62_u20.rsub[i]
print @c.xbgr.xq62_u20.csub[i]
print @q.xbgr.xq62_u21.qnpn13g2[ic]
print @q.xbgr.xq62_u21.qnpn13g2[ib]
print @q.xbgr.xq62_u21.qnpn13g2[ie]
print @q.xbgr.xq62_u21.qnpn13g2[is]
print @r.xbgr.xq62_u21.rsub[i]
print @c.xbgr.xq62_u21.csub[i]
print @q.xbgr.xq62_u22.qnpn13g2[ic]
print @q.xbgr.xq62_u22.qnpn13g2[ib]
print @q.xbgr.xq62_u22.qnpn13g2[ie]
print @q.xbgr.xq62_u22.qnpn13g2[is]
print @r.xbgr.xq62_u22.rsub[i]
print @c.xbgr.xq62_u22.csub[i]
print @q.xbgr.xq62_u23.qnpn13g2[ic]
print @q.xbgr.xq62_u23.qnpn13g2[ib]
print @q.xbgr.xq62_u23.qnpn13g2[ie]
print @q.xbgr.xq62_u23.qnpn13g2[is]
print @r.xbgr.xq62_u23.rsub[i]
print @c.xbgr.xq62_u23.csub[i]
print @q.xbgr.xq62_u24.qnpn13g2[ic]
print @q.xbgr.xq62_u24.qnpn13g2[ib]
print @q.xbgr.xq62_u24.qnpn13g2[ie]
print @q.xbgr.xq62_u24.qnpn13g2[is]
print @r.xbgr.xq62_u24.rsub[i]
print @c.xbgr.xq62_u24.csub[i]
print @q.xbgr.xq67_u2.qnpn13g2[ic]
print @q.xbgr.xq67_u2.qnpn13g2[ib]
print @q.xbgr.xq67_u2.qnpn13g2[ie]
print @q.xbgr.xq67_u2.qnpn13g2[is]
print @r.xbgr.xq67_u2.rsub[i]
print @c.xbgr.xq67_u2.csub[i]
print @q.xbgr.xq67_u3.qnpn13g2[ic]
print @q.xbgr.xq67_u3.qnpn13g2[ib]
print @q.xbgr.xq67_u3.qnpn13g2[ie]
print @q.xbgr.xq67_u3.qnpn13g2[is]
print @r.xbgr.xq67_u3.rsub[i]
print @c.xbgr.xq67_u3.csub[i]
print @q.xbgr.xq67_u4.qnpn13g2[ic]
print @q.xbgr.xq67_u4.qnpn13g2[ib]
print @q.xbgr.xq67_u4.qnpn13g2[ie]
print @q.xbgr.xq67_u4.qnpn13g2[is]
print @r.xbgr.xq67_u4.rsub[i]
print @c.xbgr.xq67_u4.csub[i]
print @q.xbgr.xq67_u5.qnpn13g2[ic]
print @q.xbgr.xq67_u5.qnpn13g2[ib]
print @q.xbgr.xq67_u5.qnpn13g2[ie]
print @q.xbgr.xq67_u5.qnpn13g2[is]
print @r.xbgr.xq67_u5.rsub[i]
print @c.xbgr.xq67_u5.csub[i]
print @q.xbgr.xq67_u6.qnpn13g2[ic]
print @q.xbgr.xq67_u6.qnpn13g2[ib]
print @q.xbgr.xq67_u6.qnpn13g2[ie]
print @q.xbgr.xq67_u6.qnpn13g2[is]
print @r.xbgr.xq67_u6.rsub[i]
print @c.xbgr.xq67_u6.csub[i]
print @q.xbgr.xq67_u7.qnpn13g2[ic]
print @q.xbgr.xq67_u7.qnpn13g2[ib]
print @q.xbgr.xq67_u7.qnpn13g2[ie]
print @q.xbgr.xq67_u7.qnpn13g2[is]
print @r.xbgr.xq67_u7.rsub[i]
print @c.xbgr.xq67_u7.csub[i]
print @q.xbgr.xq67_u8.qnpn13g2[ic]
print @q.xbgr.xq67_u8.qnpn13g2[ib]
print @q.xbgr.xq67_u8.qnpn13g2[ie]
print @q.xbgr.xq67_u8.qnpn13g2[is]
print @r.xbgr.xq67_u8.rsub[i]
print @c.xbgr.xq67_u8.csub[i]
print @q.xbgr.xq67_u9.qnpn13g2[ic]
print @q.xbgr.xq67_u9.qnpn13g2[ib]
print @q.xbgr.xq67_u9.qnpn13g2[ie]
print @q.xbgr.xq67_u9.qnpn13g2[is]
print @r.xbgr.xq67_u9.rsub[i]
print @c.xbgr.xq67_u9.csub[i]
print @q.xbgr.xq67_u10.qnpn13g2[ic]
print @q.xbgr.xq67_u10.qnpn13g2[ib]
print @q.xbgr.xq67_u10.qnpn13g2[ie]
print @q.xbgr.xq67_u10.qnpn13g2[is]
print @r.xbgr.xq67_u10.rsub[i]
print @c.xbgr.xq67_u10.csub[i]
print @q.xbgr.xq67_u11.qnpn13g2[ic]
print @q.xbgr.xq67_u11.qnpn13g2[ib]
print @q.xbgr.xq67_u11.qnpn13g2[ie]
print @q.xbgr.xq67_u11.qnpn13g2[is]
print @r.xbgr.xq67_u11.rsub[i]
print @c.xbgr.xq67_u11.csub[i]
print @q.xbgr.xq67_u12.qnpn13g2[ic]
print @q.xbgr.xq67_u12.qnpn13g2[ib]
print @q.xbgr.xq67_u12.qnpn13g2[ie]
print @q.xbgr.xq67_u12.qnpn13g2[is]
print @r.xbgr.xq67_u12.rsub[i]
print @c.xbgr.xq67_u12.csub[i]
print @q.xbgr.xq67_u13.qnpn13g2[ic]
print @q.xbgr.xq67_u13.qnpn13g2[ib]
print @q.xbgr.xq67_u13.qnpn13g2[ie]
print @q.xbgr.xq67_u13.qnpn13g2[is]
print @r.xbgr.xq67_u13.rsub[i]
print @c.xbgr.xq67_u13.csub[i]
print @q.xbgr.xq67_u14.qnpn13g2[ic]
print @q.xbgr.xq67_u14.qnpn13g2[ib]
print @q.xbgr.xq67_u14.qnpn13g2[ie]
print @q.xbgr.xq67_u14.qnpn13g2[is]
print @r.xbgr.xq67_u14.rsub[i]
print @c.xbgr.xq67_u14.csub[i]
print @q.xbgr.xq67_u15.qnpn13g2[ic]
print @q.xbgr.xq67_u15.qnpn13g2[ib]
print @q.xbgr.xq67_u15.qnpn13g2[ie]
print @q.xbgr.xq67_u15.qnpn13g2[is]
print @r.xbgr.xq67_u15.rsub[i]
print @c.xbgr.xq67_u15.csub[i]
print @q.xbgr.xq67_u16.qnpn13g2[ic]
print @q.xbgr.xq67_u16.qnpn13g2[ib]
print @q.xbgr.xq67_u16.qnpn13g2[ie]
print @q.xbgr.xq67_u16.qnpn13g2[is]
print @r.xbgr.xq67_u16.rsub[i]
print @c.xbgr.xq67_u16.csub[i]
print @q.xbgr.xq67_u17.qnpn13g2[ic]
print @q.xbgr.xq67_u17.qnpn13g2[ib]
print @q.xbgr.xq67_u17.qnpn13g2[ie]
print @q.xbgr.xq67_u17.qnpn13g2[is]
print @r.xbgr.xq67_u17.rsub[i]
print @c.xbgr.xq67_u17.csub[i]
print @q.xbgr.xq67_u18.qnpn13g2[ic]
print @q.xbgr.xq67_u18.qnpn13g2[ib]
print @q.xbgr.xq67_u18.qnpn13g2[ie]
print @q.xbgr.xq67_u18.qnpn13g2[is]
print @r.xbgr.xq67_u18.rsub[i]
print @c.xbgr.xq67_u18.csub[i]
print @q.xbgr.xq67_u19.qnpn13g2[ic]
print @q.xbgr.xq67_u19.qnpn13g2[ib]
print @q.xbgr.xq67_u19.qnpn13g2[ie]
print @q.xbgr.xq67_u19.qnpn13g2[is]
print @r.xbgr.xq67_u19.rsub[i]
print @c.xbgr.xq67_u19.csub[i]
print @q.xbgr.xq67_u20.qnpn13g2[ic]
print @q.xbgr.xq67_u20.qnpn13g2[ib]
print @q.xbgr.xq67_u20.qnpn13g2[ie]
print @q.xbgr.xq67_u20.qnpn13g2[is]
print @r.xbgr.xq67_u20.rsub[i]
print @c.xbgr.xq67_u20.csub[i]
print @q.xbgr.xq67_u21.qnpn13g2[ic]
print @q.xbgr.xq67_u21.qnpn13g2[ib]
print @q.xbgr.xq67_u21.qnpn13g2[ie]
print @q.xbgr.xq67_u21.qnpn13g2[is]
print @r.xbgr.xq67_u21.rsub[i]
print @c.xbgr.xq67_u21.csub[i]
print @q.xbgr.xq67_u22.qnpn13g2[ic]
print @q.xbgr.xq67_u22.qnpn13g2[ib]
print @q.xbgr.xq67_u22.qnpn13g2[ie]
print @q.xbgr.xq67_u22.qnpn13g2[is]
print @r.xbgr.xq67_u22.rsub[i]
print @c.xbgr.xq67_u22.csub[i]
print @q.xbgr.xq67_u23.qnpn13g2[ic]
print @q.xbgr.xq67_u23.qnpn13g2[ib]
print @q.xbgr.xq67_u23.qnpn13g2[ie]
print @q.xbgr.xq67_u23.qnpn13g2[is]
print @r.xbgr.xq67_u23.rsub[i]
print @c.xbgr.xq67_u23.csub[i]
print @q.xbgr.xq67_u24.qnpn13g2[ic]
print @q.xbgr.xq67_u24.qnpn13g2[ib]
print @q.xbgr.xq67_u24.qnpn13g2[ie]
print @q.xbgr.xq67_u24.qnpn13g2[is]
print @r.xbgr.xq67_u24.rsub[i]
print @c.xbgr.xq67_u24.csub[i]
print @q.xbgr.xq68_u2.qnpn13g2[ic]
print @q.xbgr.xq68_u2.qnpn13g2[ib]
print @q.xbgr.xq68_u2.qnpn13g2[ie]
print @q.xbgr.xq68_u2.qnpn13g2[is]
print @r.xbgr.xq68_u2.rsub[i]
print @c.xbgr.xq68_u2.csub[i]
print @q.xbgr.xq68_u3.qnpn13g2[ic]
print @q.xbgr.xq68_u3.qnpn13g2[ib]
print @q.xbgr.xq68_u3.qnpn13g2[ie]
print @q.xbgr.xq68_u3.qnpn13g2[is]
print @r.xbgr.xq68_u3.rsub[i]
print @c.xbgr.xq68_u3.csub[i]
print @q.xbgr.xq68_u4.qnpn13g2[ic]
print @q.xbgr.xq68_u4.qnpn13g2[ib]
print @q.xbgr.xq68_u4.qnpn13g2[ie]
print @q.xbgr.xq68_u4.qnpn13g2[is]
print @r.xbgr.xq68_u4.rsub[i]
print @c.xbgr.xq68_u4.csub[i]
print @q.xbgr.xq68_u5.qnpn13g2[ic]
print @q.xbgr.xq68_u5.qnpn13g2[ib]
print @q.xbgr.xq68_u5.qnpn13g2[ie]
print @q.xbgr.xq68_u5.qnpn13g2[is]
print @r.xbgr.xq68_u5.rsub[i]
print @c.xbgr.xq68_u5.csub[i]
print @q.xbgr.xq68_u6.qnpn13g2[ic]
print @q.xbgr.xq68_u6.qnpn13g2[ib]
print @q.xbgr.xq68_u6.qnpn13g2[ie]
print @q.xbgr.xq68_u6.qnpn13g2[is]
print @r.xbgr.xq68_u6.rsub[i]
print @c.xbgr.xq68_u6.csub[i]
print @q.xbgr.xq68_u7.qnpn13g2[ic]
print @q.xbgr.xq68_u7.qnpn13g2[ib]
print @q.xbgr.xq68_u7.qnpn13g2[ie]
print @q.xbgr.xq68_u7.qnpn13g2[is]
print @r.xbgr.xq68_u7.rsub[i]
print @c.xbgr.xq68_u7.csub[i]
print @q.xbgr.xq68_u8.qnpn13g2[ic]
print @q.xbgr.xq68_u8.qnpn13g2[ib]
print @q.xbgr.xq68_u8.qnpn13g2[ie]
print @q.xbgr.xq68_u8.qnpn13g2[is]
print @r.xbgr.xq68_u8.rsub[i]
print @c.xbgr.xq68_u8.csub[i]
print @q.xbgr.xq68_u9.qnpn13g2[ic]
print @q.xbgr.xq68_u9.qnpn13g2[ib]
print @q.xbgr.xq68_u9.qnpn13g2[ie]
print @q.xbgr.xq68_u9.qnpn13g2[is]
print @r.xbgr.xq68_u9.rsub[i]
print @c.xbgr.xq68_u9.csub[i]
print @q.xbgr.xq68_u10.qnpn13g2[ic]
print @q.xbgr.xq68_u10.qnpn13g2[ib]
print @q.xbgr.xq68_u10.qnpn13g2[ie]
print @q.xbgr.xq68_u10.qnpn13g2[is]
print @r.xbgr.xq68_u10.rsub[i]
print @c.xbgr.xq68_u10.csub[i]
print @q.xbgr.xq68_u11.qnpn13g2[ic]
print @q.xbgr.xq68_u11.qnpn13g2[ib]
print @q.xbgr.xq68_u11.qnpn13g2[ie]
print @q.xbgr.xq68_u11.qnpn13g2[is]
print @r.xbgr.xq68_u11.rsub[i]
print @c.xbgr.xq68_u11.csub[i]
print @q.xbgr.xq68_u12.qnpn13g2[ic]
print @q.xbgr.xq68_u12.qnpn13g2[ib]
print @q.xbgr.xq68_u12.qnpn13g2[ie]
print @q.xbgr.xq68_u12.qnpn13g2[is]
print @r.xbgr.xq68_u12.rsub[i]
print @c.xbgr.xq68_u12.csub[i]
print @q.xbgr.xq68_u13.qnpn13g2[ic]
print @q.xbgr.xq68_u13.qnpn13g2[ib]
print @q.xbgr.xq68_u13.qnpn13g2[ie]
print @q.xbgr.xq68_u13.qnpn13g2[is]
print @r.xbgr.xq68_u13.rsub[i]
print @c.xbgr.xq68_u13.csub[i]
print @q.xbgr.xq68_u14.qnpn13g2[ic]
print @q.xbgr.xq68_u14.qnpn13g2[ib]
print @q.xbgr.xq68_u14.qnpn13g2[ie]
print @q.xbgr.xq68_u14.qnpn13g2[is]
print @r.xbgr.xq68_u14.rsub[i]
print @c.xbgr.xq68_u14.csub[i]
print @q.xbgr.xq68_u15.qnpn13g2[ic]
print @q.xbgr.xq68_u15.qnpn13g2[ib]
print @q.xbgr.xq68_u15.qnpn13g2[ie]
print @q.xbgr.xq68_u15.qnpn13g2[is]
print @r.xbgr.xq68_u15.rsub[i]
print @c.xbgr.xq68_u15.csub[i]
print @q.xbgr.xq68_u16.qnpn13g2[ic]
print @q.xbgr.xq68_u16.qnpn13g2[ib]
print @q.xbgr.xq68_u16.qnpn13g2[ie]
print @q.xbgr.xq68_u16.qnpn13g2[is]
print @r.xbgr.xq68_u16.rsub[i]
print @c.xbgr.xq68_u16.csub[i]
print @q.xbgr.xq68_u17.qnpn13g2[ic]
print @q.xbgr.xq68_u17.qnpn13g2[ib]
print @q.xbgr.xq68_u17.qnpn13g2[ie]
print @q.xbgr.xq68_u17.qnpn13g2[is]
print @r.xbgr.xq68_u17.rsub[i]
print @c.xbgr.xq68_u17.csub[i]
print @q.xbgr.xq68_u18.qnpn13g2[ic]
print @q.xbgr.xq68_u18.qnpn13g2[ib]
print @q.xbgr.xq68_u18.qnpn13g2[ie]
print @q.xbgr.xq68_u18.qnpn13g2[is]
print @r.xbgr.xq68_u18.rsub[i]
print @c.xbgr.xq68_u18.csub[i]
print @q.xbgr.xq68_u19.qnpn13g2[ic]
print @q.xbgr.xq68_u19.qnpn13g2[ib]
print @q.xbgr.xq68_u19.qnpn13g2[ie]
print @q.xbgr.xq68_u19.qnpn13g2[is]
print @r.xbgr.xq68_u19.rsub[i]
print @c.xbgr.xq68_u19.csub[i]
print @q.xbgr.xq68_u20.qnpn13g2[ic]
print @q.xbgr.xq68_u20.qnpn13g2[ib]
print @q.xbgr.xq68_u20.qnpn13g2[ie]
print @q.xbgr.xq68_u20.qnpn13g2[is]
print @r.xbgr.xq68_u20.rsub[i]
print @c.xbgr.xq68_u20.csub[i]
print @q.xbgr.xq68_u21.qnpn13g2[ic]
print @q.xbgr.xq68_u21.qnpn13g2[ib]
print @q.xbgr.xq68_u21.qnpn13g2[ie]
print @q.xbgr.xq68_u21.qnpn13g2[is]
print @r.xbgr.xq68_u21.rsub[i]
print @c.xbgr.xq68_u21.csub[i]
print @q.xbgr.xq68_u22.qnpn13g2[ic]
print @q.xbgr.xq68_u22.qnpn13g2[ib]
print @q.xbgr.xq68_u22.qnpn13g2[ie]
print @q.xbgr.xq68_u22.qnpn13g2[is]
print @r.xbgr.xq68_u22.rsub[i]
print @c.xbgr.xq68_u22.csub[i]
print @q.xbgr.xq68_u23.qnpn13g2[ic]
print @q.xbgr.xq68_u23.qnpn13g2[ib]
print @q.xbgr.xq68_u23.qnpn13g2[ie]
print @q.xbgr.xq68_u23.qnpn13g2[is]
print @r.xbgr.xq68_u23.rsub[i]
print @c.xbgr.xq68_u23.csub[i]
print @q.xbgr.xq68_u24.qnpn13g2[ic]
print @q.xbgr.xq68_u24.qnpn13g2[ib]
print @q.xbgr.xq68_u24.qnpn13g2[ie]
print @q.xbgr.xq68_u24.qnpn13g2[is]
print @r.xbgr.xq68_u24.rsub[i]
print @c.xbgr.xq68_u24.csub[i]
print @q.xbgr.xq69_u2.qnpn13g2[ic]
print @q.xbgr.xq69_u2.qnpn13g2[ib]
print @q.xbgr.xq69_u2.qnpn13g2[ie]
print @q.xbgr.xq69_u2.qnpn13g2[is]
print @r.xbgr.xq69_u2.rsub[i]
print @c.xbgr.xq69_u2.csub[i]
print @q.xbgr.xq69_u3.qnpn13g2[ic]
print @q.xbgr.xq69_u3.qnpn13g2[ib]
print @q.xbgr.xq69_u3.qnpn13g2[ie]
print @q.xbgr.xq69_u3.qnpn13g2[is]
print @r.xbgr.xq69_u3.rsub[i]
print @c.xbgr.xq69_u3.csub[i]
print @q.xbgr.xq69_u4.qnpn13g2[ic]
print @q.xbgr.xq69_u4.qnpn13g2[ib]
print @q.xbgr.xq69_u4.qnpn13g2[ie]
print @q.xbgr.xq69_u4.qnpn13g2[is]
print @r.xbgr.xq69_u4.rsub[i]
print @c.xbgr.xq69_u4.csub[i]
print @q.xbgr.xq69_u5.qnpn13g2[ic]
print @q.xbgr.xq69_u5.qnpn13g2[ib]
print @q.xbgr.xq69_u5.qnpn13g2[ie]
print @q.xbgr.xq69_u5.qnpn13g2[is]
print @r.xbgr.xq69_u5.rsub[i]
print @c.xbgr.xq69_u5.csub[i]
print @q.xbgr.xq69_u6.qnpn13g2[ic]
print @q.xbgr.xq69_u6.qnpn13g2[ib]
print @q.xbgr.xq69_u6.qnpn13g2[ie]
print @q.xbgr.xq69_u6.qnpn13g2[is]
print @r.xbgr.xq69_u6.rsub[i]
print @c.xbgr.xq69_u6.csub[i]
print @q.xbgr.xq69_u7.qnpn13g2[ic]
print @q.xbgr.xq69_u7.qnpn13g2[ib]
print @q.xbgr.xq69_u7.qnpn13g2[ie]
print @q.xbgr.xq69_u7.qnpn13g2[is]
print @r.xbgr.xq69_u7.rsub[i]
print @c.xbgr.xq69_u7.csub[i]
print @q.xbgr.xq69_u8.qnpn13g2[ic]
print @q.xbgr.xq69_u8.qnpn13g2[ib]
print @q.xbgr.xq69_u8.qnpn13g2[ie]
print @q.xbgr.xq69_u8.qnpn13g2[is]
print @r.xbgr.xq69_u8.rsub[i]
print @c.xbgr.xq69_u8.csub[i]
print @q.xbgr.xq69_u9.qnpn13g2[ic]
print @q.xbgr.xq69_u9.qnpn13g2[ib]
print @q.xbgr.xq69_u9.qnpn13g2[ie]
print @q.xbgr.xq69_u9.qnpn13g2[is]
print @r.xbgr.xq69_u9.rsub[i]
print @c.xbgr.xq69_u9.csub[i]
print @q.xbgr.xq69_u10.qnpn13g2[ic]
print @q.xbgr.xq69_u10.qnpn13g2[ib]
print @q.xbgr.xq69_u10.qnpn13g2[ie]
print @q.xbgr.xq69_u10.qnpn13g2[is]
print @r.xbgr.xq69_u10.rsub[i]
print @c.xbgr.xq69_u10.csub[i]
print @q.xbgr.xq69_u11.qnpn13g2[ic]
print @q.xbgr.xq69_u11.qnpn13g2[ib]
print @q.xbgr.xq69_u11.qnpn13g2[ie]
print @q.xbgr.xq69_u11.qnpn13g2[is]
print @r.xbgr.xq69_u11.rsub[i]
print @c.xbgr.xq69_u11.csub[i]
print @q.xbgr.xq69_u12.qnpn13g2[ic]
print @q.xbgr.xq69_u12.qnpn13g2[ib]
print @q.xbgr.xq69_u12.qnpn13g2[ie]
print @q.xbgr.xq69_u12.qnpn13g2[is]
print @r.xbgr.xq69_u12.rsub[i]
print @c.xbgr.xq69_u12.csub[i]
print @q.xbgr.xq69_u13.qnpn13g2[ic]
print @q.xbgr.xq69_u13.qnpn13g2[ib]
print @q.xbgr.xq69_u13.qnpn13g2[ie]
print @q.xbgr.xq69_u13.qnpn13g2[is]
print @r.xbgr.xq69_u13.rsub[i]
print @c.xbgr.xq69_u13.csub[i]
print @q.xbgr.xq69_u14.qnpn13g2[ic]
print @q.xbgr.xq69_u14.qnpn13g2[ib]
print @q.xbgr.xq69_u14.qnpn13g2[ie]
print @q.xbgr.xq69_u14.qnpn13g2[is]
print @r.xbgr.xq69_u14.rsub[i]
print @c.xbgr.xq69_u14.csub[i]
print @q.xbgr.xq69_u15.qnpn13g2[ic]
print @q.xbgr.xq69_u15.qnpn13g2[ib]
print @q.xbgr.xq69_u15.qnpn13g2[ie]
print @q.xbgr.xq69_u15.qnpn13g2[is]
print @r.xbgr.xq69_u15.rsub[i]
print @c.xbgr.xq69_u15.csub[i]
print @q.xbgr.xq69_u16.qnpn13g2[ic]
print @q.xbgr.xq69_u16.qnpn13g2[ib]
print @q.xbgr.xq69_u16.qnpn13g2[ie]
print @q.xbgr.xq69_u16.qnpn13g2[is]
print @r.xbgr.xq69_u16.rsub[i]
print @c.xbgr.xq69_u16.csub[i]
print @q.xbgr.xq69_u17.qnpn13g2[ic]
print @q.xbgr.xq69_u17.qnpn13g2[ib]
print @q.xbgr.xq69_u17.qnpn13g2[ie]
print @q.xbgr.xq69_u17.qnpn13g2[is]
print @r.xbgr.xq69_u17.rsub[i]
print @c.xbgr.xq69_u17.csub[i]
print @q.xbgr.xq69_u18.qnpn13g2[ic]
print @q.xbgr.xq69_u18.qnpn13g2[ib]
print @q.xbgr.xq69_u18.qnpn13g2[ie]
print @q.xbgr.xq69_u18.qnpn13g2[is]
print @r.xbgr.xq69_u18.rsub[i]
print @c.xbgr.xq69_u18.csub[i]
print @q.xbgr.xq69_u19.qnpn13g2[ic]
print @q.xbgr.xq69_u19.qnpn13g2[ib]
print @q.xbgr.xq69_u19.qnpn13g2[ie]
print @q.xbgr.xq69_u19.qnpn13g2[is]
print @r.xbgr.xq69_u19.rsub[i]
print @c.xbgr.xq69_u19.csub[i]
print @q.xbgr.xq69_u20.qnpn13g2[ic]
print @q.xbgr.xq69_u20.qnpn13g2[ib]
print @q.xbgr.xq69_u20.qnpn13g2[ie]
print @q.xbgr.xq69_u20.qnpn13g2[is]
print @r.xbgr.xq69_u20.rsub[i]
print @c.xbgr.xq69_u20.csub[i]
print @q.xbgr.xq69_u21.qnpn13g2[ic]
print @q.xbgr.xq69_u21.qnpn13g2[ib]
print @q.xbgr.xq69_u21.qnpn13g2[ie]
print @q.xbgr.xq69_u21.qnpn13g2[is]
print @r.xbgr.xq69_u21.rsub[i]
print @c.xbgr.xq69_u21.csub[i]
print @q.xbgr.xq69_u22.qnpn13g2[ic]
print @q.xbgr.xq69_u22.qnpn13g2[ib]
print @q.xbgr.xq69_u22.qnpn13g2[ie]
print @q.xbgr.xq69_u22.qnpn13g2[is]
print @r.xbgr.xq69_u22.rsub[i]
print @c.xbgr.xq69_u22.csub[i]
print @q.xbgr.xq69_u23.qnpn13g2[ic]
print @q.xbgr.xq69_u23.qnpn13g2[ib]
print @q.xbgr.xq69_u23.qnpn13g2[ie]
print @q.xbgr.xq69_u23.qnpn13g2[is]
print @r.xbgr.xq69_u23.rsub[i]
print @c.xbgr.xq69_u23.csub[i]
print @q.xbgr.xq69_u24.qnpn13g2[ic]
print @q.xbgr.xq69_u24.qnpn13g2[ib]
print @q.xbgr.xq69_u24.qnpn13g2[ie]
print @q.xbgr.xq69_u24.qnpn13g2[is]
print @r.xbgr.xq69_u24.rsub[i]
print @c.xbgr.xq69_u24.csub[i]
print @q.xbgr.xq70_u2.qnpn13g2[ic]
print @q.xbgr.xq70_u2.qnpn13g2[ib]
print @q.xbgr.xq70_u2.qnpn13g2[ie]
print @q.xbgr.xq70_u2.qnpn13g2[is]
print @r.xbgr.xq70_u2.rsub[i]
print @c.xbgr.xq70_u2.csub[i]
print @q.xbgr.xq70_u3.qnpn13g2[ic]
print @q.xbgr.xq70_u3.qnpn13g2[ib]
print @q.xbgr.xq70_u3.qnpn13g2[ie]
print @q.xbgr.xq70_u3.qnpn13g2[is]
print @r.xbgr.xq70_u3.rsub[i]
print @c.xbgr.xq70_u3.csub[i]
print @q.xbgr.xq70_u4.qnpn13g2[ic]
print @q.xbgr.xq70_u4.qnpn13g2[ib]
print @q.xbgr.xq70_u4.qnpn13g2[ie]
print @q.xbgr.xq70_u4.qnpn13g2[is]
print @r.xbgr.xq70_u4.rsub[i]
print @c.xbgr.xq70_u4.csub[i]
print @q.xbgr.xq70_u5.qnpn13g2[ic]
print @q.xbgr.xq70_u5.qnpn13g2[ib]
print @q.xbgr.xq70_u5.qnpn13g2[ie]
print @q.xbgr.xq70_u5.qnpn13g2[is]
print @r.xbgr.xq70_u5.rsub[i]
print @c.xbgr.xq70_u5.csub[i]
print @q.xbgr.xq70_u6.qnpn13g2[ic]
print @q.xbgr.xq70_u6.qnpn13g2[ib]
print @q.xbgr.xq70_u6.qnpn13g2[ie]
print @q.xbgr.xq70_u6.qnpn13g2[is]
print @r.xbgr.xq70_u6.rsub[i]
print @c.xbgr.xq70_u6.csub[i]
print @q.xbgr.xq70_u7.qnpn13g2[ic]
print @q.xbgr.xq70_u7.qnpn13g2[ib]
print @q.xbgr.xq70_u7.qnpn13g2[ie]
print @q.xbgr.xq70_u7.qnpn13g2[is]
print @r.xbgr.xq70_u7.rsub[i]
print @c.xbgr.xq70_u7.csub[i]
print @q.xbgr.xq70_u8.qnpn13g2[ic]
print @q.xbgr.xq70_u8.qnpn13g2[ib]
print @q.xbgr.xq70_u8.qnpn13g2[ie]
print @q.xbgr.xq70_u8.qnpn13g2[is]
print @r.xbgr.xq70_u8.rsub[i]
print @c.xbgr.xq70_u8.csub[i]
print @q.xbgr.xq70_u9.qnpn13g2[ic]
print @q.xbgr.xq70_u9.qnpn13g2[ib]
print @q.xbgr.xq70_u9.qnpn13g2[ie]
print @q.xbgr.xq70_u9.qnpn13g2[is]
print @r.xbgr.xq70_u9.rsub[i]
print @c.xbgr.xq70_u9.csub[i]
print @q.xbgr.xq70_u10.qnpn13g2[ic]
print @q.xbgr.xq70_u10.qnpn13g2[ib]
print @q.xbgr.xq70_u10.qnpn13g2[ie]
print @q.xbgr.xq70_u10.qnpn13g2[is]
print @r.xbgr.xq70_u10.rsub[i]
print @c.xbgr.xq70_u10.csub[i]
print @q.xbgr.xq70_u11.qnpn13g2[ic]
print @q.xbgr.xq70_u11.qnpn13g2[ib]
print @q.xbgr.xq70_u11.qnpn13g2[ie]
print @q.xbgr.xq70_u11.qnpn13g2[is]
print @r.xbgr.xq70_u11.rsub[i]
print @c.xbgr.xq70_u11.csub[i]
print @q.xbgr.xq70_u12.qnpn13g2[ic]
print @q.xbgr.xq70_u12.qnpn13g2[ib]
print @q.xbgr.xq70_u12.qnpn13g2[ie]
print @q.xbgr.xq70_u12.qnpn13g2[is]
print @r.xbgr.xq70_u12.rsub[i]
print @c.xbgr.xq70_u12.csub[i]
print @q.xbgr.xq70_u13.qnpn13g2[ic]
print @q.xbgr.xq70_u13.qnpn13g2[ib]
print @q.xbgr.xq70_u13.qnpn13g2[ie]
print @q.xbgr.xq70_u13.qnpn13g2[is]
print @r.xbgr.xq70_u13.rsub[i]
print @c.xbgr.xq70_u13.csub[i]
print @q.xbgr.xq70_u14.qnpn13g2[ic]
print @q.xbgr.xq70_u14.qnpn13g2[ib]
print @q.xbgr.xq70_u14.qnpn13g2[ie]
print @q.xbgr.xq70_u14.qnpn13g2[is]
print @r.xbgr.xq70_u14.rsub[i]
print @c.xbgr.xq70_u14.csub[i]
print @q.xbgr.xq70_u15.qnpn13g2[ic]
print @q.xbgr.xq70_u15.qnpn13g2[ib]
print @q.xbgr.xq70_u15.qnpn13g2[ie]
print @q.xbgr.xq70_u15.qnpn13g2[is]
print @r.xbgr.xq70_u15.rsub[i]
print @c.xbgr.xq70_u15.csub[i]
print @q.xbgr.xq70_u16.qnpn13g2[ic]
print @q.xbgr.xq70_u16.qnpn13g2[ib]
print @q.xbgr.xq70_u16.qnpn13g2[ie]
print @q.xbgr.xq70_u16.qnpn13g2[is]
print @r.xbgr.xq70_u16.rsub[i]
print @c.xbgr.xq70_u16.csub[i]
print @q.xbgr.xq70_u17.qnpn13g2[ic]
print @q.xbgr.xq70_u17.qnpn13g2[ib]
print @q.xbgr.xq70_u17.qnpn13g2[ie]
print @q.xbgr.xq70_u17.qnpn13g2[is]
print @r.xbgr.xq70_u17.rsub[i]
print @c.xbgr.xq70_u17.csub[i]
print @q.xbgr.xq70_u18.qnpn13g2[ic]
print @q.xbgr.xq70_u18.qnpn13g2[ib]
print @q.xbgr.xq70_u18.qnpn13g2[ie]
print @q.xbgr.xq70_u18.qnpn13g2[is]
print @r.xbgr.xq70_u18.rsub[i]
print @c.xbgr.xq70_u18.csub[i]
print @q.xbgr.xq70_u19.qnpn13g2[ic]
print @q.xbgr.xq70_u19.qnpn13g2[ib]
print @q.xbgr.xq70_u19.qnpn13g2[ie]
print @q.xbgr.xq70_u19.qnpn13g2[is]
print @r.xbgr.xq70_u19.rsub[i]
print @c.xbgr.xq70_u19.csub[i]
print @q.xbgr.xq70_u20.qnpn13g2[ic]
print @q.xbgr.xq70_u20.qnpn13g2[ib]
print @q.xbgr.xq70_u20.qnpn13g2[ie]
print @q.xbgr.xq70_u20.qnpn13g2[is]
print @r.xbgr.xq70_u20.rsub[i]
print @c.xbgr.xq70_u20.csub[i]
print @q.xbgr.xq70_u21.qnpn13g2[ic]
print @q.xbgr.xq70_u21.qnpn13g2[ib]
print @q.xbgr.xq70_u21.qnpn13g2[ie]
print @q.xbgr.xq70_u21.qnpn13g2[is]
print @r.xbgr.xq70_u21.rsub[i]
print @c.xbgr.xq70_u21.csub[i]
print @q.xbgr.xq70_u22.qnpn13g2[ic]
print @q.xbgr.xq70_u22.qnpn13g2[ib]
print @q.xbgr.xq70_u22.qnpn13g2[ie]
print @q.xbgr.xq70_u22.qnpn13g2[is]
print @r.xbgr.xq70_u22.rsub[i]
print @c.xbgr.xq70_u22.csub[i]
print @q.xbgr.xq70_u23.qnpn13g2[ic]
print @q.xbgr.xq70_u23.qnpn13g2[ib]
print @q.xbgr.xq70_u23.qnpn13g2[ie]
print @q.xbgr.xq70_u23.qnpn13g2[is]
print @r.xbgr.xq70_u23.rsub[i]
print @c.xbgr.xq70_u23.csub[i]
print @q.xbgr.xq70_u24.qnpn13g2[ic]
print @q.xbgr.xq70_u24.qnpn13g2[ib]
print @q.xbgr.xq70_u24.qnpn13g2[ie]
print @q.xbgr.xq70_u24.qnpn13g2[is]
print @r.xbgr.xq70_u24.rsub[i]
print @c.xbgr.xq70_u24.csub[i]
print @q.xbgr.xq71_u2.qnpn13g2[ic]
print @q.xbgr.xq71_u2.qnpn13g2[ib]
print @q.xbgr.xq71_u2.qnpn13g2[ie]
print @q.xbgr.xq71_u2.qnpn13g2[is]
print @r.xbgr.xq71_u2.rsub[i]
print @c.xbgr.xq71_u2.csub[i]
print @q.xbgr.xq71_u3.qnpn13g2[ic]
print @q.xbgr.xq71_u3.qnpn13g2[ib]
print @q.xbgr.xq71_u3.qnpn13g2[ie]
print @q.xbgr.xq71_u3.qnpn13g2[is]
print @r.xbgr.xq71_u3.rsub[i]
print @c.xbgr.xq71_u3.csub[i]
print @q.xbgr.xq71_u4.qnpn13g2[ic]
print @q.xbgr.xq71_u4.qnpn13g2[ib]
print @q.xbgr.xq71_u4.qnpn13g2[ie]
print @q.xbgr.xq71_u4.qnpn13g2[is]
print @r.xbgr.xq71_u4.rsub[i]
print @c.xbgr.xq71_u4.csub[i]
print @q.xbgr.xq71_u5.qnpn13g2[ic]
print @q.xbgr.xq71_u5.qnpn13g2[ib]
print @q.xbgr.xq71_u5.qnpn13g2[ie]
print @q.xbgr.xq71_u5.qnpn13g2[is]
print @r.xbgr.xq71_u5.rsub[i]
print @c.xbgr.xq71_u5.csub[i]
print @q.xbgr.xq71_u6.qnpn13g2[ic]
print @q.xbgr.xq71_u6.qnpn13g2[ib]
print @q.xbgr.xq71_u6.qnpn13g2[ie]
print @q.xbgr.xq71_u6.qnpn13g2[is]
print @r.xbgr.xq71_u6.rsub[i]
print @c.xbgr.xq71_u6.csub[i]
print @q.xbgr.xq71_u7.qnpn13g2[ic]
print @q.xbgr.xq71_u7.qnpn13g2[ib]
print @q.xbgr.xq71_u7.qnpn13g2[ie]
print @q.xbgr.xq71_u7.qnpn13g2[is]
print @r.xbgr.xq71_u7.rsub[i]
print @c.xbgr.xq71_u7.csub[i]
print @q.xbgr.xq71_u8.qnpn13g2[ic]
print @q.xbgr.xq71_u8.qnpn13g2[ib]
print @q.xbgr.xq71_u8.qnpn13g2[ie]
print @q.xbgr.xq71_u8.qnpn13g2[is]
print @r.xbgr.xq71_u8.rsub[i]
print @c.xbgr.xq71_u8.csub[i]
print @q.xbgr.xq71_u9.qnpn13g2[ic]
print @q.xbgr.xq71_u9.qnpn13g2[ib]
print @q.xbgr.xq71_u9.qnpn13g2[ie]
print @q.xbgr.xq71_u9.qnpn13g2[is]
print @r.xbgr.xq71_u9.rsub[i]
print @c.xbgr.xq71_u9.csub[i]
print @q.xbgr.xq71_u10.qnpn13g2[ic]
print @q.xbgr.xq71_u10.qnpn13g2[ib]
print @q.xbgr.xq71_u10.qnpn13g2[ie]
print @q.xbgr.xq71_u10.qnpn13g2[is]
print @r.xbgr.xq71_u10.rsub[i]
print @c.xbgr.xq71_u10.csub[i]
print @q.xbgr.xq71_u11.qnpn13g2[ic]
print @q.xbgr.xq71_u11.qnpn13g2[ib]
print @q.xbgr.xq71_u11.qnpn13g2[ie]
print @q.xbgr.xq71_u11.qnpn13g2[is]
print @r.xbgr.xq71_u11.rsub[i]
print @c.xbgr.xq71_u11.csub[i]
print @q.xbgr.xq71_u12.qnpn13g2[ic]
print @q.xbgr.xq71_u12.qnpn13g2[ib]
print @q.xbgr.xq71_u12.qnpn13g2[ie]
print @q.xbgr.xq71_u12.qnpn13g2[is]
print @r.xbgr.xq71_u12.rsub[i]
print @c.xbgr.xq71_u12.csub[i]
print @q.xbgr.xq71_u13.qnpn13g2[ic]
print @q.xbgr.xq71_u13.qnpn13g2[ib]
print @q.xbgr.xq71_u13.qnpn13g2[ie]
print @q.xbgr.xq71_u13.qnpn13g2[is]
print @r.xbgr.xq71_u13.rsub[i]
print @c.xbgr.xq71_u13.csub[i]
print @q.xbgr.xq71_u14.qnpn13g2[ic]
print @q.xbgr.xq71_u14.qnpn13g2[ib]
print @q.xbgr.xq71_u14.qnpn13g2[ie]
print @q.xbgr.xq71_u14.qnpn13g2[is]
print @r.xbgr.xq71_u14.rsub[i]
print @c.xbgr.xq71_u14.csub[i]
print @q.xbgr.xq71_u15.qnpn13g2[ic]
print @q.xbgr.xq71_u15.qnpn13g2[ib]
print @q.xbgr.xq71_u15.qnpn13g2[ie]
print @q.xbgr.xq71_u15.qnpn13g2[is]
print @r.xbgr.xq71_u15.rsub[i]
print @c.xbgr.xq71_u15.csub[i]
print @q.xbgr.xq71_u16.qnpn13g2[ic]
print @q.xbgr.xq71_u16.qnpn13g2[ib]
print @q.xbgr.xq71_u16.qnpn13g2[ie]
print @q.xbgr.xq71_u16.qnpn13g2[is]
print @r.xbgr.xq71_u16.rsub[i]
print @c.xbgr.xq71_u16.csub[i]
print @q.xbgr.xq71_u17.qnpn13g2[ic]
print @q.xbgr.xq71_u17.qnpn13g2[ib]
print @q.xbgr.xq71_u17.qnpn13g2[ie]
print @q.xbgr.xq71_u17.qnpn13g2[is]
print @r.xbgr.xq71_u17.rsub[i]
print @c.xbgr.xq71_u17.csub[i]
print @q.xbgr.xq71_u18.qnpn13g2[ic]
print @q.xbgr.xq71_u18.qnpn13g2[ib]
print @q.xbgr.xq71_u18.qnpn13g2[ie]
print @q.xbgr.xq71_u18.qnpn13g2[is]
print @r.xbgr.xq71_u18.rsub[i]
print @c.xbgr.xq71_u18.csub[i]
print @q.xbgr.xq71_u19.qnpn13g2[ic]
print @q.xbgr.xq71_u19.qnpn13g2[ib]
print @q.xbgr.xq71_u19.qnpn13g2[ie]
print @q.xbgr.xq71_u19.qnpn13g2[is]
print @r.xbgr.xq71_u19.rsub[i]
print @c.xbgr.xq71_u19.csub[i]
print @q.xbgr.xq71_u20.qnpn13g2[ic]
print @q.xbgr.xq71_u20.qnpn13g2[ib]
print @q.xbgr.xq71_u20.qnpn13g2[ie]
print @q.xbgr.xq71_u20.qnpn13g2[is]
print @r.xbgr.xq71_u20.rsub[i]
print @c.xbgr.xq71_u20.csub[i]
print @q.xbgr.xq71_u21.qnpn13g2[ic]
print @q.xbgr.xq71_u21.qnpn13g2[ib]
print @q.xbgr.xq71_u21.qnpn13g2[ie]
print @q.xbgr.xq71_u21.qnpn13g2[is]
print @r.xbgr.xq71_u21.rsub[i]
print @c.xbgr.xq71_u21.csub[i]
print @q.xbgr.xq71_u22.qnpn13g2[ic]
print @q.xbgr.xq71_u22.qnpn13g2[ib]
print @q.xbgr.xq71_u22.qnpn13g2[ie]
print @q.xbgr.xq71_u22.qnpn13g2[is]
print @r.xbgr.xq71_u22.rsub[i]
print @c.xbgr.xq71_u22.csub[i]
print @q.xbgr.xq71_u23.qnpn13g2[ic]
print @q.xbgr.xq71_u23.qnpn13g2[ib]
print @q.xbgr.xq71_u23.qnpn13g2[ie]
print @q.xbgr.xq71_u23.qnpn13g2[is]
print @r.xbgr.xq71_u23.rsub[i]
print @c.xbgr.xq71_u23.csub[i]
print @q.xbgr.xq71_u24.qnpn13g2[ic]
print @q.xbgr.xq71_u24.qnpn13g2[ib]
print @q.xbgr.xq71_u24.qnpn13g2[ie]
print @q.xbgr.xq71_u24.qnpn13g2[is]
print @r.xbgr.xq71_u24.rsub[i]
print @c.xbgr.xq71_u24.csub[i]
print @q.xbgr.xq72_u2.qnpn13g2[ic]
print @q.xbgr.xq72_u2.qnpn13g2[ib]
print @q.xbgr.xq72_u2.qnpn13g2[ie]
print @q.xbgr.xq72_u2.qnpn13g2[is]
print @r.xbgr.xq72_u2.rsub[i]
print @c.xbgr.xq72_u2.csub[i]
print @q.xbgr.xq72_u3.qnpn13g2[ic]
print @q.xbgr.xq72_u3.qnpn13g2[ib]
print @q.xbgr.xq72_u3.qnpn13g2[ie]
print @q.xbgr.xq72_u3.qnpn13g2[is]
print @r.xbgr.xq72_u3.rsub[i]
print @c.xbgr.xq72_u3.csub[i]
print @q.xbgr.xq72_u4.qnpn13g2[ic]
print @q.xbgr.xq72_u4.qnpn13g2[ib]
print @q.xbgr.xq72_u4.qnpn13g2[ie]
print @q.xbgr.xq72_u4.qnpn13g2[is]
print @r.xbgr.xq72_u4.rsub[i]
print @c.xbgr.xq72_u4.csub[i]
print @q.xbgr.xq72_u5.qnpn13g2[ic]
print @q.xbgr.xq72_u5.qnpn13g2[ib]
print @q.xbgr.xq72_u5.qnpn13g2[ie]
print @q.xbgr.xq72_u5.qnpn13g2[is]
print @r.xbgr.xq72_u5.rsub[i]
print @c.xbgr.xq72_u5.csub[i]
print @q.xbgr.xq72_u6.qnpn13g2[ic]
print @q.xbgr.xq72_u6.qnpn13g2[ib]
print @q.xbgr.xq72_u6.qnpn13g2[ie]
print @q.xbgr.xq72_u6.qnpn13g2[is]
print @r.xbgr.xq72_u6.rsub[i]
print @c.xbgr.xq72_u6.csub[i]
print @q.xbgr.xq72_u7.qnpn13g2[ic]
print @q.xbgr.xq72_u7.qnpn13g2[ib]
print @q.xbgr.xq72_u7.qnpn13g2[ie]
print @q.xbgr.xq72_u7.qnpn13g2[is]
print @r.xbgr.xq72_u7.rsub[i]
print @c.xbgr.xq72_u7.csub[i]
print @q.xbgr.xq72_u8.qnpn13g2[ic]
print @q.xbgr.xq72_u8.qnpn13g2[ib]
print @q.xbgr.xq72_u8.qnpn13g2[ie]
print @q.xbgr.xq72_u8.qnpn13g2[is]
print @r.xbgr.xq72_u8.rsub[i]
print @c.xbgr.xq72_u8.csub[i]
print @q.xbgr.xq72_u9.qnpn13g2[ic]
print @q.xbgr.xq72_u9.qnpn13g2[ib]
print @q.xbgr.xq72_u9.qnpn13g2[ie]
print @q.xbgr.xq72_u9.qnpn13g2[is]
print @r.xbgr.xq72_u9.rsub[i]
print @c.xbgr.xq72_u9.csub[i]
print @q.xbgr.xq72_u10.qnpn13g2[ic]
print @q.xbgr.xq72_u10.qnpn13g2[ib]
print @q.xbgr.xq72_u10.qnpn13g2[ie]
print @q.xbgr.xq72_u10.qnpn13g2[is]
print @r.xbgr.xq72_u10.rsub[i]
print @c.xbgr.xq72_u10.csub[i]
print @q.xbgr.xq72_u11.qnpn13g2[ic]
print @q.xbgr.xq72_u11.qnpn13g2[ib]
print @q.xbgr.xq72_u11.qnpn13g2[ie]
print @q.xbgr.xq72_u11.qnpn13g2[is]
print @r.xbgr.xq72_u11.rsub[i]
print @c.xbgr.xq72_u11.csub[i]
print @q.xbgr.xq72_u12.qnpn13g2[ic]
print @q.xbgr.xq72_u12.qnpn13g2[ib]
print @q.xbgr.xq72_u12.qnpn13g2[ie]
print @q.xbgr.xq72_u12.qnpn13g2[is]
print @r.xbgr.xq72_u12.rsub[i]
print @c.xbgr.xq72_u12.csub[i]
print @q.xbgr.xq72_u13.qnpn13g2[ic]
print @q.xbgr.xq72_u13.qnpn13g2[ib]
print @q.xbgr.xq72_u13.qnpn13g2[ie]
print @q.xbgr.xq72_u13.qnpn13g2[is]
print @r.xbgr.xq72_u13.rsub[i]
print @c.xbgr.xq72_u13.csub[i]
print @q.xbgr.xq72_u14.qnpn13g2[ic]
print @q.xbgr.xq72_u14.qnpn13g2[ib]
print @q.xbgr.xq72_u14.qnpn13g2[ie]
print @q.xbgr.xq72_u14.qnpn13g2[is]
print @r.xbgr.xq72_u14.rsub[i]
print @c.xbgr.xq72_u14.csub[i]
print @q.xbgr.xq72_u15.qnpn13g2[ic]
print @q.xbgr.xq72_u15.qnpn13g2[ib]
print @q.xbgr.xq72_u15.qnpn13g2[ie]
print @q.xbgr.xq72_u15.qnpn13g2[is]
print @r.xbgr.xq72_u15.rsub[i]
print @c.xbgr.xq72_u15.csub[i]
print @q.xbgr.xq72_u16.qnpn13g2[ic]
print @q.xbgr.xq72_u16.qnpn13g2[ib]
print @q.xbgr.xq72_u16.qnpn13g2[ie]
print @q.xbgr.xq72_u16.qnpn13g2[is]
print @r.xbgr.xq72_u16.rsub[i]
print @c.xbgr.xq72_u16.csub[i]
print @q.xbgr.xq72_u17.qnpn13g2[ic]
print @q.xbgr.xq72_u17.qnpn13g2[ib]
print @q.xbgr.xq72_u17.qnpn13g2[ie]
print @q.xbgr.xq72_u17.qnpn13g2[is]
print @r.xbgr.xq72_u17.rsub[i]
print @c.xbgr.xq72_u17.csub[i]
print @q.xbgr.xq72_u18.qnpn13g2[ic]
print @q.xbgr.xq72_u18.qnpn13g2[ib]
print @q.xbgr.xq72_u18.qnpn13g2[ie]
print @q.xbgr.xq72_u18.qnpn13g2[is]
print @r.xbgr.xq72_u18.rsub[i]
print @c.xbgr.xq72_u18.csub[i]
print @q.xbgr.xq72_u19.qnpn13g2[ic]
print @q.xbgr.xq72_u19.qnpn13g2[ib]
print @q.xbgr.xq72_u19.qnpn13g2[ie]
print @q.xbgr.xq72_u19.qnpn13g2[is]
print @r.xbgr.xq72_u19.rsub[i]
print @c.xbgr.xq72_u19.csub[i]
print @q.xbgr.xq72_u20.qnpn13g2[ic]
print @q.xbgr.xq72_u20.qnpn13g2[ib]
print @q.xbgr.xq72_u20.qnpn13g2[ie]
print @q.xbgr.xq72_u20.qnpn13g2[is]
print @r.xbgr.xq72_u20.rsub[i]
print @c.xbgr.xq72_u20.csub[i]
print @q.xbgr.xq72_u21.qnpn13g2[ic]
print @q.xbgr.xq72_u21.qnpn13g2[ib]
print @q.xbgr.xq72_u21.qnpn13g2[ie]
print @q.xbgr.xq72_u21.qnpn13g2[is]
print @r.xbgr.xq72_u21.rsub[i]
print @c.xbgr.xq72_u21.csub[i]
print @q.xbgr.xq72_u22.qnpn13g2[ic]
print @q.xbgr.xq72_u22.qnpn13g2[ib]
print @q.xbgr.xq72_u22.qnpn13g2[ie]
print @q.xbgr.xq72_u22.qnpn13g2[is]
print @r.xbgr.xq72_u22.rsub[i]
print @c.xbgr.xq72_u22.csub[i]
print @q.xbgr.xq72_u23.qnpn13g2[ic]
print @q.xbgr.xq72_u23.qnpn13g2[ib]
print @q.xbgr.xq72_u23.qnpn13g2[ie]
print @q.xbgr.xq72_u23.qnpn13g2[is]
print @r.xbgr.xq72_u23.rsub[i]
print @c.xbgr.xq72_u23.csub[i]
print @q.xbgr.xq72_u24.qnpn13g2[ic]
print @q.xbgr.xq72_u24.qnpn13g2[ib]
print @q.xbgr.xq72_u24.qnpn13g2[ie]
print @q.xbgr.xq72_u24.qnpn13g2[is]
print @r.xbgr.xq72_u24.rsub[i]
print @c.xbgr.xq72_u24.csub[i]
print @q.xbgr.xq73_u2.qnpn13g2[ic]
print @q.xbgr.xq73_u2.qnpn13g2[ib]
print @q.xbgr.xq73_u2.qnpn13g2[ie]
print @q.xbgr.xq73_u2.qnpn13g2[is]
print @r.xbgr.xq73_u2.rsub[i]
print @c.xbgr.xq73_u2.csub[i]
print @q.xbgr.xq73_u3.qnpn13g2[ic]
print @q.xbgr.xq73_u3.qnpn13g2[ib]
print @q.xbgr.xq73_u3.qnpn13g2[ie]
print @q.xbgr.xq73_u3.qnpn13g2[is]
print @r.xbgr.xq73_u3.rsub[i]
print @c.xbgr.xq73_u3.csub[i]
print @q.xbgr.xq73_u4.qnpn13g2[ic]
print @q.xbgr.xq73_u4.qnpn13g2[ib]
print @q.xbgr.xq73_u4.qnpn13g2[ie]
print @q.xbgr.xq73_u4.qnpn13g2[is]
print @r.xbgr.xq73_u4.rsub[i]
print @c.xbgr.xq73_u4.csub[i]
print @q.xbgr.xq73_u5.qnpn13g2[ic]
print @q.xbgr.xq73_u5.qnpn13g2[ib]
print @q.xbgr.xq73_u5.qnpn13g2[ie]
print @q.xbgr.xq73_u5.qnpn13g2[is]
print @r.xbgr.xq73_u5.rsub[i]
print @c.xbgr.xq73_u5.csub[i]
print @q.xbgr.xq73_u6.qnpn13g2[ic]
print @q.xbgr.xq73_u6.qnpn13g2[ib]
print @q.xbgr.xq73_u6.qnpn13g2[ie]
print @q.xbgr.xq73_u6.qnpn13g2[is]
print @r.xbgr.xq73_u6.rsub[i]
print @c.xbgr.xq73_u6.csub[i]
print @q.xbgr.xq73_u7.qnpn13g2[ic]
print @q.xbgr.xq73_u7.qnpn13g2[ib]
print @q.xbgr.xq73_u7.qnpn13g2[ie]
print @q.xbgr.xq73_u7.qnpn13g2[is]
print @r.xbgr.xq73_u7.rsub[i]
print @c.xbgr.xq73_u7.csub[i]
print @q.xbgr.xq73_u8.qnpn13g2[ic]
print @q.xbgr.xq73_u8.qnpn13g2[ib]
print @q.xbgr.xq73_u8.qnpn13g2[ie]
print @q.xbgr.xq73_u8.qnpn13g2[is]
print @r.xbgr.xq73_u8.rsub[i]
print @c.xbgr.xq73_u8.csub[i]
print @q.xbgr.xq73_u9.qnpn13g2[ic]
print @q.xbgr.xq73_u9.qnpn13g2[ib]
print @q.xbgr.xq73_u9.qnpn13g2[ie]
print @q.xbgr.xq73_u9.qnpn13g2[is]
print @r.xbgr.xq73_u9.rsub[i]
print @c.xbgr.xq73_u9.csub[i]
print @q.xbgr.xq73_u10.qnpn13g2[ic]
print @q.xbgr.xq73_u10.qnpn13g2[ib]
print @q.xbgr.xq73_u10.qnpn13g2[ie]
print @q.xbgr.xq73_u10.qnpn13g2[is]
print @r.xbgr.xq73_u10.rsub[i]
print @c.xbgr.xq73_u10.csub[i]
print @q.xbgr.xq73_u11.qnpn13g2[ic]
print @q.xbgr.xq73_u11.qnpn13g2[ib]
print @q.xbgr.xq73_u11.qnpn13g2[ie]
print @q.xbgr.xq73_u11.qnpn13g2[is]
print @r.xbgr.xq73_u11.rsub[i]
print @c.xbgr.xq73_u11.csub[i]
print @q.xbgr.xq73_u12.qnpn13g2[ic]
print @q.xbgr.xq73_u12.qnpn13g2[ib]
print @q.xbgr.xq73_u12.qnpn13g2[ie]
print @q.xbgr.xq73_u12.qnpn13g2[is]
print @r.xbgr.xq73_u12.rsub[i]
print @c.xbgr.xq73_u12.csub[i]
print @q.xbgr.xq73_u13.qnpn13g2[ic]
print @q.xbgr.xq73_u13.qnpn13g2[ib]
print @q.xbgr.xq73_u13.qnpn13g2[ie]
print @q.xbgr.xq73_u13.qnpn13g2[is]
print @r.xbgr.xq73_u13.rsub[i]
print @c.xbgr.xq73_u13.csub[i]
print @q.xbgr.xq73_u14.qnpn13g2[ic]
print @q.xbgr.xq73_u14.qnpn13g2[ib]
print @q.xbgr.xq73_u14.qnpn13g2[ie]
print @q.xbgr.xq73_u14.qnpn13g2[is]
print @r.xbgr.xq73_u14.rsub[i]
print @c.xbgr.xq73_u14.csub[i]
print @q.xbgr.xq73_u15.qnpn13g2[ic]
print @q.xbgr.xq73_u15.qnpn13g2[ib]
print @q.xbgr.xq73_u15.qnpn13g2[ie]
print @q.xbgr.xq73_u15.qnpn13g2[is]
print @r.xbgr.xq73_u15.rsub[i]
print @c.xbgr.xq73_u15.csub[i]
print @q.xbgr.xq73_u16.qnpn13g2[ic]
print @q.xbgr.xq73_u16.qnpn13g2[ib]
print @q.xbgr.xq73_u16.qnpn13g2[ie]
print @q.xbgr.xq73_u16.qnpn13g2[is]
print @r.xbgr.xq73_u16.rsub[i]
print @c.xbgr.xq73_u16.csub[i]
print @q.xbgr.xq73_u17.qnpn13g2[ic]
print @q.xbgr.xq73_u17.qnpn13g2[ib]
print @q.xbgr.xq73_u17.qnpn13g2[ie]
print @q.xbgr.xq73_u17.qnpn13g2[is]
print @r.xbgr.xq73_u17.rsub[i]
print @c.xbgr.xq73_u17.csub[i]
print @q.xbgr.xq73_u18.qnpn13g2[ic]
print @q.xbgr.xq73_u18.qnpn13g2[ib]
print @q.xbgr.xq73_u18.qnpn13g2[ie]
print @q.xbgr.xq73_u18.qnpn13g2[is]
print @r.xbgr.xq73_u18.rsub[i]
print @c.xbgr.xq73_u18.csub[i]
print @q.xbgr.xq73_u19.qnpn13g2[ic]
print @q.xbgr.xq73_u19.qnpn13g2[ib]
print @q.xbgr.xq73_u19.qnpn13g2[ie]
print @q.xbgr.xq73_u19.qnpn13g2[is]
print @r.xbgr.xq73_u19.rsub[i]
print @c.xbgr.xq73_u19.csub[i]
print @q.xbgr.xq73_u20.qnpn13g2[ic]
print @q.xbgr.xq73_u20.qnpn13g2[ib]
print @q.xbgr.xq73_u20.qnpn13g2[ie]
print @q.xbgr.xq73_u20.qnpn13g2[is]
print @r.xbgr.xq73_u20.rsub[i]
print @c.xbgr.xq73_u20.csub[i]
print @q.xbgr.xq73_u21.qnpn13g2[ic]
print @q.xbgr.xq73_u21.qnpn13g2[ib]
print @q.xbgr.xq73_u21.qnpn13g2[ie]
print @q.xbgr.xq73_u21.qnpn13g2[is]
print @r.xbgr.xq73_u21.rsub[i]
print @c.xbgr.xq73_u21.csub[i]
print @q.xbgr.xq73_u22.qnpn13g2[ic]
print @q.xbgr.xq73_u22.qnpn13g2[ib]
print @q.xbgr.xq73_u22.qnpn13g2[ie]
print @q.xbgr.xq73_u22.qnpn13g2[is]
print @r.xbgr.xq73_u22.rsub[i]
print @c.xbgr.xq73_u22.csub[i]
print @q.xbgr.xq73_u23.qnpn13g2[ic]
print @q.xbgr.xq73_u23.qnpn13g2[ib]
print @q.xbgr.xq73_u23.qnpn13g2[ie]
print @q.xbgr.xq73_u23.qnpn13g2[is]
print @r.xbgr.xq73_u23.rsub[i]
print @c.xbgr.xq73_u23.csub[i]
print @q.xbgr.xq73_u24.qnpn13g2[ic]
print @q.xbgr.xq73_u24.qnpn13g2[ib]
print @q.xbgr.xq73_u24.qnpn13g2[ie]
print @q.xbgr.xq73_u24.qnpn13g2[is]
print @r.xbgr.xq73_u24.rsub[i]
print @c.xbgr.xq73_u24.csub[i]
print @q.xbgr.xq74_u2.qnpn13g2[ic]
print @q.xbgr.xq74_u2.qnpn13g2[ib]
print @q.xbgr.xq74_u2.qnpn13g2[ie]
print @q.xbgr.xq74_u2.qnpn13g2[is]
print @r.xbgr.xq74_u2.rsub[i]
print @c.xbgr.xq74_u2.csub[i]
print @q.xbgr.xq74_u3.qnpn13g2[ic]
print @q.xbgr.xq74_u3.qnpn13g2[ib]
print @q.xbgr.xq74_u3.qnpn13g2[ie]
print @q.xbgr.xq74_u3.qnpn13g2[is]
print @r.xbgr.xq74_u3.rsub[i]
print @c.xbgr.xq74_u3.csub[i]
print @q.xbgr.xq74_u4.qnpn13g2[ic]
print @q.xbgr.xq74_u4.qnpn13g2[ib]
print @q.xbgr.xq74_u4.qnpn13g2[ie]
print @q.xbgr.xq74_u4.qnpn13g2[is]
print @r.xbgr.xq74_u4.rsub[i]
print @c.xbgr.xq74_u4.csub[i]
print @q.xbgr.xq74_u5.qnpn13g2[ic]
print @q.xbgr.xq74_u5.qnpn13g2[ib]
print @q.xbgr.xq74_u5.qnpn13g2[ie]
print @q.xbgr.xq74_u5.qnpn13g2[is]
print @r.xbgr.xq74_u5.rsub[i]
print @c.xbgr.xq74_u5.csub[i]
print @q.xbgr.xq74_u6.qnpn13g2[ic]
print @q.xbgr.xq74_u6.qnpn13g2[ib]
print @q.xbgr.xq74_u6.qnpn13g2[ie]
print @q.xbgr.xq74_u6.qnpn13g2[is]
print @r.xbgr.xq74_u6.rsub[i]
print @c.xbgr.xq74_u6.csub[i]
print @q.xbgr.xq74_u7.qnpn13g2[ic]
print @q.xbgr.xq74_u7.qnpn13g2[ib]
print @q.xbgr.xq74_u7.qnpn13g2[ie]
print @q.xbgr.xq74_u7.qnpn13g2[is]
print @r.xbgr.xq74_u7.rsub[i]
print @c.xbgr.xq74_u7.csub[i]
print @q.xbgr.xq74_u8.qnpn13g2[ic]
print @q.xbgr.xq74_u8.qnpn13g2[ib]
print @q.xbgr.xq74_u8.qnpn13g2[ie]
print @q.xbgr.xq74_u8.qnpn13g2[is]
print @r.xbgr.xq74_u8.rsub[i]
print @c.xbgr.xq74_u8.csub[i]
print @q.xbgr.xq74_u9.qnpn13g2[ic]
print @q.xbgr.xq74_u9.qnpn13g2[ib]
print @q.xbgr.xq74_u9.qnpn13g2[ie]
print @q.xbgr.xq74_u9.qnpn13g2[is]
print @r.xbgr.xq74_u9.rsub[i]
print @c.xbgr.xq74_u9.csub[i]
print @q.xbgr.xq74_u10.qnpn13g2[ic]
print @q.xbgr.xq74_u10.qnpn13g2[ib]
print @q.xbgr.xq74_u10.qnpn13g2[ie]
print @q.xbgr.xq74_u10.qnpn13g2[is]
print @r.xbgr.xq74_u10.rsub[i]
print @c.xbgr.xq74_u10.csub[i]
print @q.xbgr.xq74_u11.qnpn13g2[ic]
print @q.xbgr.xq74_u11.qnpn13g2[ib]
print @q.xbgr.xq74_u11.qnpn13g2[ie]
print @q.xbgr.xq74_u11.qnpn13g2[is]
print @r.xbgr.xq74_u11.rsub[i]
print @c.xbgr.xq74_u11.csub[i]
print @q.xbgr.xq74_u12.qnpn13g2[ic]
print @q.xbgr.xq74_u12.qnpn13g2[ib]
print @q.xbgr.xq74_u12.qnpn13g2[ie]
print @q.xbgr.xq74_u12.qnpn13g2[is]
print @r.xbgr.xq74_u12.rsub[i]
print @c.xbgr.xq74_u12.csub[i]
print @q.xbgr.xq74_u13.qnpn13g2[ic]
print @q.xbgr.xq74_u13.qnpn13g2[ib]
print @q.xbgr.xq74_u13.qnpn13g2[ie]
print @q.xbgr.xq74_u13.qnpn13g2[is]
print @r.xbgr.xq74_u13.rsub[i]
print @c.xbgr.xq74_u13.csub[i]
print @q.xbgr.xq74_u14.qnpn13g2[ic]
print @q.xbgr.xq74_u14.qnpn13g2[ib]
print @q.xbgr.xq74_u14.qnpn13g2[ie]
print @q.xbgr.xq74_u14.qnpn13g2[is]
print @r.xbgr.xq74_u14.rsub[i]
print @c.xbgr.xq74_u14.csub[i]
print @q.xbgr.xq74_u15.qnpn13g2[ic]
print @q.xbgr.xq74_u15.qnpn13g2[ib]
print @q.xbgr.xq74_u15.qnpn13g2[ie]
print @q.xbgr.xq74_u15.qnpn13g2[is]
print @r.xbgr.xq74_u15.rsub[i]
print @c.xbgr.xq74_u15.csub[i]
print @q.xbgr.xq74_u16.qnpn13g2[ic]
print @q.xbgr.xq74_u16.qnpn13g2[ib]
print @q.xbgr.xq74_u16.qnpn13g2[ie]
print @q.xbgr.xq74_u16.qnpn13g2[is]
print @r.xbgr.xq74_u16.rsub[i]
print @c.xbgr.xq74_u16.csub[i]
print @q.xbgr.xq74_u17.qnpn13g2[ic]
print @q.xbgr.xq74_u17.qnpn13g2[ib]
print @q.xbgr.xq74_u17.qnpn13g2[ie]
print @q.xbgr.xq74_u17.qnpn13g2[is]
print @r.xbgr.xq74_u17.rsub[i]
print @c.xbgr.xq74_u17.csub[i]
print @q.xbgr.xq74_u18.qnpn13g2[ic]
print @q.xbgr.xq74_u18.qnpn13g2[ib]
print @q.xbgr.xq74_u18.qnpn13g2[ie]
print @q.xbgr.xq74_u18.qnpn13g2[is]
print @r.xbgr.xq74_u18.rsub[i]
print @c.xbgr.xq74_u18.csub[i]
print @q.xbgr.xq74_u19.qnpn13g2[ic]
print @q.xbgr.xq74_u19.qnpn13g2[ib]
print @q.xbgr.xq74_u19.qnpn13g2[ie]
print @q.xbgr.xq74_u19.qnpn13g2[is]
print @r.xbgr.xq74_u19.rsub[i]
print @c.xbgr.xq74_u19.csub[i]
print @q.xbgr.xq74_u20.qnpn13g2[ic]
print @q.xbgr.xq74_u20.qnpn13g2[ib]
print @q.xbgr.xq74_u20.qnpn13g2[ie]
print @q.xbgr.xq74_u20.qnpn13g2[is]
print @r.xbgr.xq74_u20.rsub[i]
print @c.xbgr.xq74_u20.csub[i]
print @q.xbgr.xq74_u21.qnpn13g2[ic]
print @q.xbgr.xq74_u21.qnpn13g2[ib]
print @q.xbgr.xq74_u21.qnpn13g2[ie]
print @q.xbgr.xq74_u21.qnpn13g2[is]
print @r.xbgr.xq74_u21.rsub[i]
print @c.xbgr.xq74_u21.csub[i]
print @q.xbgr.xq74_u22.qnpn13g2[ic]
print @q.xbgr.xq74_u22.qnpn13g2[ib]
print @q.xbgr.xq74_u22.qnpn13g2[ie]
print @q.xbgr.xq74_u22.qnpn13g2[is]
print @r.xbgr.xq74_u22.rsub[i]
print @c.xbgr.xq74_u22.csub[i]
print @q.xbgr.xq74_u23.qnpn13g2[ic]
print @q.xbgr.xq74_u23.qnpn13g2[ib]
print @q.xbgr.xq74_u23.qnpn13g2[ie]
print @q.xbgr.xq74_u23.qnpn13g2[is]
print @r.xbgr.xq74_u23.rsub[i]
print @c.xbgr.xq74_u23.csub[i]
print @q.xbgr.xq74_u24.qnpn13g2[ic]
print @q.xbgr.xq74_u24.qnpn13g2[ib]
print @q.xbgr.xq74_u24.qnpn13g2[ie]
print @q.xbgr.xq74_u24.qnpn13g2[is]
print @r.xbgr.xq74_u24.rsub[i]
print @c.xbgr.xq74_u24.csub[i]
print @q.xbgr.xq75_u2.qnpn13g2[ic]
print @q.xbgr.xq75_u2.qnpn13g2[ib]
print @q.xbgr.xq75_u2.qnpn13g2[ie]
print @q.xbgr.xq75_u2.qnpn13g2[is]
print @r.xbgr.xq75_u2.rsub[i]
print @c.xbgr.xq75_u2.csub[i]
print @q.xbgr.xq75_u3.qnpn13g2[ic]
print @q.xbgr.xq75_u3.qnpn13g2[ib]
print @q.xbgr.xq75_u3.qnpn13g2[ie]
print @q.xbgr.xq75_u3.qnpn13g2[is]
print @r.xbgr.xq75_u3.rsub[i]
print @c.xbgr.xq75_u3.csub[i]
print @q.xbgr.xq75_u4.qnpn13g2[ic]
print @q.xbgr.xq75_u4.qnpn13g2[ib]
print @q.xbgr.xq75_u4.qnpn13g2[ie]
print @q.xbgr.xq75_u4.qnpn13g2[is]
print @r.xbgr.xq75_u4.rsub[i]
print @c.xbgr.xq75_u4.csub[i]
print @q.xbgr.xq75_u5.qnpn13g2[ic]
print @q.xbgr.xq75_u5.qnpn13g2[ib]
print @q.xbgr.xq75_u5.qnpn13g2[ie]
print @q.xbgr.xq75_u5.qnpn13g2[is]
print @r.xbgr.xq75_u5.rsub[i]
print @c.xbgr.xq75_u5.csub[i]
print @q.xbgr.xq75_u6.qnpn13g2[ic]
print @q.xbgr.xq75_u6.qnpn13g2[ib]
print @q.xbgr.xq75_u6.qnpn13g2[ie]
print @q.xbgr.xq75_u6.qnpn13g2[is]
print @r.xbgr.xq75_u6.rsub[i]
print @c.xbgr.xq75_u6.csub[i]
print @q.xbgr.xq75_u7.qnpn13g2[ic]
print @q.xbgr.xq75_u7.qnpn13g2[ib]
print @q.xbgr.xq75_u7.qnpn13g2[ie]
print @q.xbgr.xq75_u7.qnpn13g2[is]
print @r.xbgr.xq75_u7.rsub[i]
print @c.xbgr.xq75_u7.csub[i]
print @q.xbgr.xq75_u8.qnpn13g2[ic]
print @q.xbgr.xq75_u8.qnpn13g2[ib]
print @q.xbgr.xq75_u8.qnpn13g2[ie]
print @q.xbgr.xq75_u8.qnpn13g2[is]
print @r.xbgr.xq75_u8.rsub[i]
print @c.xbgr.xq75_u8.csub[i]
print @q.xbgr.xq75_u9.qnpn13g2[ic]
print @q.xbgr.xq75_u9.qnpn13g2[ib]
print @q.xbgr.xq75_u9.qnpn13g2[ie]
print @q.xbgr.xq75_u9.qnpn13g2[is]
print @r.xbgr.xq75_u9.rsub[i]
print @c.xbgr.xq75_u9.csub[i]
print @q.xbgr.xq75_u10.qnpn13g2[ic]
print @q.xbgr.xq75_u10.qnpn13g2[ib]
print @q.xbgr.xq75_u10.qnpn13g2[ie]
print @q.xbgr.xq75_u10.qnpn13g2[is]
print @r.xbgr.xq75_u10.rsub[i]
print @c.xbgr.xq75_u10.csub[i]
print @q.xbgr.xq75_u11.qnpn13g2[ic]
print @q.xbgr.xq75_u11.qnpn13g2[ib]
print @q.xbgr.xq75_u11.qnpn13g2[ie]
print @q.xbgr.xq75_u11.qnpn13g2[is]
print @r.xbgr.xq75_u11.rsub[i]
print @c.xbgr.xq75_u11.csub[i]
print @q.xbgr.xq75_u12.qnpn13g2[ic]
print @q.xbgr.xq75_u12.qnpn13g2[ib]
print @q.xbgr.xq75_u12.qnpn13g2[ie]
print @q.xbgr.xq75_u12.qnpn13g2[is]
print @r.xbgr.xq75_u12.rsub[i]
print @c.xbgr.xq75_u12.csub[i]
print @q.xbgr.xq75_u13.qnpn13g2[ic]
print @q.xbgr.xq75_u13.qnpn13g2[ib]
print @q.xbgr.xq75_u13.qnpn13g2[ie]
print @q.xbgr.xq75_u13.qnpn13g2[is]
print @r.xbgr.xq75_u13.rsub[i]
print @c.xbgr.xq75_u13.csub[i]
print @q.xbgr.xq75_u14.qnpn13g2[ic]
print @q.xbgr.xq75_u14.qnpn13g2[ib]
print @q.xbgr.xq75_u14.qnpn13g2[ie]
print @q.xbgr.xq75_u14.qnpn13g2[is]
print @r.xbgr.xq75_u14.rsub[i]
print @c.xbgr.xq75_u14.csub[i]
print @q.xbgr.xq75_u15.qnpn13g2[ic]
print @q.xbgr.xq75_u15.qnpn13g2[ib]
print @q.xbgr.xq75_u15.qnpn13g2[ie]
print @q.xbgr.xq75_u15.qnpn13g2[is]
print @r.xbgr.xq75_u15.rsub[i]
print @c.xbgr.xq75_u15.csub[i]
print @q.xbgr.xq75_u16.qnpn13g2[ic]
print @q.xbgr.xq75_u16.qnpn13g2[ib]
print @q.xbgr.xq75_u16.qnpn13g2[ie]
print @q.xbgr.xq75_u16.qnpn13g2[is]
print @r.xbgr.xq75_u16.rsub[i]
print @c.xbgr.xq75_u16.csub[i]
print @q.xbgr.xq75_u17.qnpn13g2[ic]
print @q.xbgr.xq75_u17.qnpn13g2[ib]
print @q.xbgr.xq75_u17.qnpn13g2[ie]
print @q.xbgr.xq75_u17.qnpn13g2[is]
print @r.xbgr.xq75_u17.rsub[i]
print @c.xbgr.xq75_u17.csub[i]
print @q.xbgr.xq75_u18.qnpn13g2[ic]
print @q.xbgr.xq75_u18.qnpn13g2[ib]
print @q.xbgr.xq75_u18.qnpn13g2[ie]
print @q.xbgr.xq75_u18.qnpn13g2[is]
print @r.xbgr.xq75_u18.rsub[i]
print @c.xbgr.xq75_u18.csub[i]
print @q.xbgr.xq75_u19.qnpn13g2[ic]
print @q.xbgr.xq75_u19.qnpn13g2[ib]
print @q.xbgr.xq75_u19.qnpn13g2[ie]
print @q.xbgr.xq75_u19.qnpn13g2[is]
print @r.xbgr.xq75_u19.rsub[i]
print @c.xbgr.xq75_u19.csub[i]
print @q.xbgr.xq75_u20.qnpn13g2[ic]
print @q.xbgr.xq75_u20.qnpn13g2[ib]
print @q.xbgr.xq75_u20.qnpn13g2[ie]
print @q.xbgr.xq75_u20.qnpn13g2[is]
print @r.xbgr.xq75_u20.rsub[i]
print @c.xbgr.xq75_u20.csub[i]
print @q.xbgr.xq75_u21.qnpn13g2[ic]
print @q.xbgr.xq75_u21.qnpn13g2[ib]
print @q.xbgr.xq75_u21.qnpn13g2[ie]
print @q.xbgr.xq75_u21.qnpn13g2[is]
print @r.xbgr.xq75_u21.rsub[i]
print @c.xbgr.xq75_u21.csub[i]
print @q.xbgr.xq75_u22.qnpn13g2[ic]
print @q.xbgr.xq75_u22.qnpn13g2[ib]
print @q.xbgr.xq75_u22.qnpn13g2[ie]
print @q.xbgr.xq75_u22.qnpn13g2[is]
print @r.xbgr.xq75_u22.rsub[i]
print @c.xbgr.xq75_u22.csub[i]
print @q.xbgr.xq75_u23.qnpn13g2[ic]
print @q.xbgr.xq75_u23.qnpn13g2[ib]
print @q.xbgr.xq75_u23.qnpn13g2[ie]
print @q.xbgr.xq75_u23.qnpn13g2[is]
print @r.xbgr.xq75_u23.rsub[i]
print @c.xbgr.xq75_u23.csub[i]
print @q.xbgr.xq75_u24.qnpn13g2[ic]
print @q.xbgr.xq75_u24.qnpn13g2[ib]
print @q.xbgr.xq75_u24.qnpn13g2[ie]
print @q.xbgr.xq75_u24.qnpn13g2[is]
print @r.xbgr.xq75_u24.rsub[i]
print @c.xbgr.xq75_u24.csub[i]
print @q.xbgr.xq76_u2.qnpn13g2[ic]
print @q.xbgr.xq76_u2.qnpn13g2[ib]
print @q.xbgr.xq76_u2.qnpn13g2[ie]
print @q.xbgr.xq76_u2.qnpn13g2[is]
print @r.xbgr.xq76_u2.rsub[i]
print @c.xbgr.xq76_u2.csub[i]
print @q.xbgr.xq76_u3.qnpn13g2[ic]
print @q.xbgr.xq76_u3.qnpn13g2[ib]
print @q.xbgr.xq76_u3.qnpn13g2[ie]
print @q.xbgr.xq76_u3.qnpn13g2[is]
print @r.xbgr.xq76_u3.rsub[i]
print @c.xbgr.xq76_u3.csub[i]
print @q.xbgr.xq76_u4.qnpn13g2[ic]
print @q.xbgr.xq76_u4.qnpn13g2[ib]
print @q.xbgr.xq76_u4.qnpn13g2[ie]
print @q.xbgr.xq76_u4.qnpn13g2[is]
print @r.xbgr.xq76_u4.rsub[i]
print @c.xbgr.xq76_u4.csub[i]
print @q.xbgr.xq76_u5.qnpn13g2[ic]
print @q.xbgr.xq76_u5.qnpn13g2[ib]
print @q.xbgr.xq76_u5.qnpn13g2[ie]
print @q.xbgr.xq76_u5.qnpn13g2[is]
print @r.xbgr.xq76_u5.rsub[i]
print @c.xbgr.xq76_u5.csub[i]
print @q.xbgr.xq76_u6.qnpn13g2[ic]
print @q.xbgr.xq76_u6.qnpn13g2[ib]
print @q.xbgr.xq76_u6.qnpn13g2[ie]
print @q.xbgr.xq76_u6.qnpn13g2[is]
print @r.xbgr.xq76_u6.rsub[i]
print @c.xbgr.xq76_u6.csub[i]
print @q.xbgr.xq76_u7.qnpn13g2[ic]
print @q.xbgr.xq76_u7.qnpn13g2[ib]
print @q.xbgr.xq76_u7.qnpn13g2[ie]
print @q.xbgr.xq76_u7.qnpn13g2[is]
print @r.xbgr.xq76_u7.rsub[i]
print @c.xbgr.xq76_u7.csub[i]
print @q.xbgr.xq76_u8.qnpn13g2[ic]
print @q.xbgr.xq76_u8.qnpn13g2[ib]
print @q.xbgr.xq76_u8.qnpn13g2[ie]
print @q.xbgr.xq76_u8.qnpn13g2[is]
print @r.xbgr.xq76_u8.rsub[i]
print @c.xbgr.xq76_u8.csub[i]
print @q.xbgr.xq76_u9.qnpn13g2[ic]
print @q.xbgr.xq76_u9.qnpn13g2[ib]
print @q.xbgr.xq76_u9.qnpn13g2[ie]
print @q.xbgr.xq76_u9.qnpn13g2[is]
print @r.xbgr.xq76_u9.rsub[i]
print @c.xbgr.xq76_u9.csub[i]
print @q.xbgr.xq76_u10.qnpn13g2[ic]
print @q.xbgr.xq76_u10.qnpn13g2[ib]
print @q.xbgr.xq76_u10.qnpn13g2[ie]
print @q.xbgr.xq76_u10.qnpn13g2[is]
print @r.xbgr.xq76_u10.rsub[i]
print @c.xbgr.xq76_u10.csub[i]
print @q.xbgr.xq76_u11.qnpn13g2[ic]
print @q.xbgr.xq76_u11.qnpn13g2[ib]
print @q.xbgr.xq76_u11.qnpn13g2[ie]
print @q.xbgr.xq76_u11.qnpn13g2[is]
print @r.xbgr.xq76_u11.rsub[i]
print @c.xbgr.xq76_u11.csub[i]
print @q.xbgr.xq76_u12.qnpn13g2[ic]
print @q.xbgr.xq76_u12.qnpn13g2[ib]
print @q.xbgr.xq76_u12.qnpn13g2[ie]
print @q.xbgr.xq76_u12.qnpn13g2[is]
print @r.xbgr.xq76_u12.rsub[i]
print @c.xbgr.xq76_u12.csub[i]
print @q.xbgr.xq76_u13.qnpn13g2[ic]
print @q.xbgr.xq76_u13.qnpn13g2[ib]
print @q.xbgr.xq76_u13.qnpn13g2[ie]
print @q.xbgr.xq76_u13.qnpn13g2[is]
print @r.xbgr.xq76_u13.rsub[i]
print @c.xbgr.xq76_u13.csub[i]
print @q.xbgr.xq76_u14.qnpn13g2[ic]
print @q.xbgr.xq76_u14.qnpn13g2[ib]
print @q.xbgr.xq76_u14.qnpn13g2[ie]
print @q.xbgr.xq76_u14.qnpn13g2[is]
print @r.xbgr.xq76_u14.rsub[i]
print @c.xbgr.xq76_u14.csub[i]
print @q.xbgr.xq76_u15.qnpn13g2[ic]
print @q.xbgr.xq76_u15.qnpn13g2[ib]
print @q.xbgr.xq76_u15.qnpn13g2[ie]
print @q.xbgr.xq76_u15.qnpn13g2[is]
print @r.xbgr.xq76_u15.rsub[i]
print @c.xbgr.xq76_u15.csub[i]
print @q.xbgr.xq76_u16.qnpn13g2[ic]
print @q.xbgr.xq76_u16.qnpn13g2[ib]
print @q.xbgr.xq76_u16.qnpn13g2[ie]
print @q.xbgr.xq76_u16.qnpn13g2[is]
print @r.xbgr.xq76_u16.rsub[i]
print @c.xbgr.xq76_u16.csub[i]
print @q.xbgr.xq76_u17.qnpn13g2[ic]
print @q.xbgr.xq76_u17.qnpn13g2[ib]
print @q.xbgr.xq76_u17.qnpn13g2[ie]
print @q.xbgr.xq76_u17.qnpn13g2[is]
print @r.xbgr.xq76_u17.rsub[i]
print @c.xbgr.xq76_u17.csub[i]
print @q.xbgr.xq76_u18.qnpn13g2[ic]
print @q.xbgr.xq76_u18.qnpn13g2[ib]
print @q.xbgr.xq76_u18.qnpn13g2[ie]
print @q.xbgr.xq76_u18.qnpn13g2[is]
print @r.xbgr.xq76_u18.rsub[i]
print @c.xbgr.xq76_u18.csub[i]
print @q.xbgr.xq76_u19.qnpn13g2[ic]
print @q.xbgr.xq76_u19.qnpn13g2[ib]
print @q.xbgr.xq76_u19.qnpn13g2[ie]
print @q.xbgr.xq76_u19.qnpn13g2[is]
print @r.xbgr.xq76_u19.rsub[i]
print @c.xbgr.xq76_u19.csub[i]
print @q.xbgr.xq76_u20.qnpn13g2[ic]
print @q.xbgr.xq76_u20.qnpn13g2[ib]
print @q.xbgr.xq76_u20.qnpn13g2[ie]
print @q.xbgr.xq76_u20.qnpn13g2[is]
print @r.xbgr.xq76_u20.rsub[i]
print @c.xbgr.xq76_u20.csub[i]
print @q.xbgr.xq76_u21.qnpn13g2[ic]
print @q.xbgr.xq76_u21.qnpn13g2[ib]
print @q.xbgr.xq76_u21.qnpn13g2[ie]
print @q.xbgr.xq76_u21.qnpn13g2[is]
print @r.xbgr.xq76_u21.rsub[i]
print @c.xbgr.xq76_u21.csub[i]
print @q.xbgr.xq76_u22.qnpn13g2[ic]
print @q.xbgr.xq76_u22.qnpn13g2[ib]
print @q.xbgr.xq76_u22.qnpn13g2[ie]
print @q.xbgr.xq76_u22.qnpn13g2[is]
print @r.xbgr.xq76_u22.rsub[i]
print @c.xbgr.xq76_u22.csub[i]
print @q.xbgr.xq76_u23.qnpn13g2[ic]
print @q.xbgr.xq76_u23.qnpn13g2[ib]
print @q.xbgr.xq76_u23.qnpn13g2[ie]
print @q.xbgr.xq76_u23.qnpn13g2[is]
print @r.xbgr.xq76_u23.rsub[i]
print @c.xbgr.xq76_u23.csub[i]
print @q.xbgr.xq76_u24.qnpn13g2[ic]
print @q.xbgr.xq76_u24.qnpn13g2[ib]
print @q.xbgr.xq76_u24.qnpn13g2[ie]
print @q.xbgr.xq76_u24.qnpn13g2[is]
print @r.xbgr.xq76_u24.rsub[i]
print @c.xbgr.xq76_u24.csub[i]
print @n.xbgr.xr77_u2.nr1[ibody]
print @n.xbgr.xr77_u3.nr1[ibody]
print @n.xbgr.xr77_u4.nr1[ibody]
print @n.xbgr.xr77_u5.nr1[ibody]
print @n.xbgr.xr77_u6.nr1[ibody]
print @n.xbgr.xr77_u7.nr1[ibody]
print @n.xbgr.xr77_u8.nr1[ibody]
print @n.xbgr.xr77_u9.nr1[ibody]
print @n.xbgr.xr77_u10.nr1[ibody]
print @n.xbgr.xr77_u11.nr1[ibody]
print @n.xbgr.xr77_u12.nr1[ibody]
print @n.xbgr.xr77_u13.nr1[ibody]
print @n.xbgr.xr77_u14.nr1[ibody]
print @n.xbgr.xr77_u15.nr1[ibody]
print @n.xbgr.xr77_u16.nr1[ibody]
print @n.xbgr.xr77_u17.nr1[ibody]
print @n.xbgr.xr77_u18.nr1[ibody]
print @n.xbgr.xr77_u19.nr1[ibody]
print @n.xbgr.xr77_u20.nr1[ibody]
print @n.xbgr.xr77_u21.nr1[ibody]
print @n.xbgr.xr77_u22.nr1[ibody]
print @n.xbgr.xr77_u23.nr1[ibody]
print @n.xbgr.xr77_u24.nr1[ibody]
print @n.xbgr.xr78_u2.nr1[ibody]
print @n.xbgr.xr78_u3.nr1[ibody]
print @n.xbgr.xr78_u4.nr1[ibody]
print @n.xbgr.xr78_u5.nr1[ibody]
print @n.xbgr.xr78_u6.nr1[ibody]
print @n.xbgr.xr78_u7.nr1[ibody]
print @n.xbgr.xr78_u8.nr1[ibody]
print @n.xbgr.xr78_u9.nr1[ibody]
print @n.xbgr.xr78_u10.nr1[ibody]
print @n.xbgr.xr78_u11.nr1[ibody]
print @n.xbgr.xr78_u12.nr1[ibody]
print @n.xbgr.xr78_u13.nr1[ibody]
print @n.xbgr.xr78_u14.nr1[ibody]
print @n.xbgr.xr78_u15.nr1[ibody]
print @n.xbgr.xr78_u16.nr1[ibody]
print @n.xbgr.xr78_u17.nr1[ibody]
print @n.xbgr.xr78_u18.nr1[ibody]
print @n.xbgr.xr78_u19.nr1[ibody]
print @n.xbgr.xr78_u20.nr1[ibody]
print @n.xbgr.xr78_u21.nr1[ibody]
print @n.xbgr.xr78_u22.nr1[ibody]
print @n.xbgr.xr78_u23.nr1[ibody]
print @n.xbgr.xr78_u24.nr1[ibody]
print @n.xbgr.xr79_u2.nr1[ibody]
print @n.xbgr.xr79_u3.nr1[ibody]
print @n.xbgr.xr79_u4.nr1[ibody]
print @n.xbgr.xr79_u5.nr1[ibody]
print @n.xbgr.xr79_u6.nr1[ibody]
print @n.xbgr.xr79_u7.nr1[ibody]
print @n.xbgr.xr79_u8.nr1[ibody]
print @n.xbgr.xr79_u9.nr1[ibody]
print @n.xbgr.xr79_u10.nr1[ibody]
print @n.xbgr.xr79_u11.nr1[ibody]
print @n.xbgr.xr79_u12.nr1[ibody]
print @n.xbgr.xr79_u13.nr1[ibody]
print @n.xbgr.xr79_u14.nr1[ibody]
print @n.xbgr.xr79_u15.nr1[ibody]
print @n.xbgr.xr79_u16.nr1[ibody]
print @n.xbgr.xr79_u17.nr1[ibody]
print @n.xbgr.xr79_u18.nr1[ibody]
print @n.xbgr.xr79_u19.nr1[ibody]
print @n.xbgr.xr79_u20.nr1[ibody]
print @n.xbgr.xr79_u21.nr1[ibody]
print @n.xbgr.xr79_u22.nr1[ibody]
print @n.xbgr.xr79_u23.nr1[ibody]
print @n.xbgr.xr79_u24.nr1[ibody]
print @n.xbgr.xr80_u2.nr1[ibody]
print @n.xbgr.xr80_u3.nr1[ibody]
print @n.xbgr.xr80_u4.nr1[ibody]
print @n.xbgr.xr80_u5.nr1[ibody]
print @n.xbgr.xr80_u6.nr1[ibody]
print @n.xbgr.xr80_u7.nr1[ibody]
print @n.xbgr.xr80_u8.nr1[ibody]
print @n.xbgr.xr80_u9.nr1[ibody]
print @n.xbgr.xr80_u10.nr1[ibody]
print @n.xbgr.xr80_u11.nr1[ibody]
print @n.xbgr.xr80_u12.nr1[ibody]
print @n.xbgr.xr80_u13.nr1[ibody]
print @n.xbgr.xr80_u14.nr1[ibody]
print @n.xbgr.xr80_u15.nr1[ibody]
print @n.xbgr.xr80_u16.nr1[ibody]
print @n.xbgr.xr80_u17.nr1[ibody]
print @n.xbgr.xr80_u18.nr1[ibody]
print @n.xbgr.xr80_u19.nr1[ibody]
print @n.xbgr.xr80_u20.nr1[ibody]
print @n.xbgr.xr80_u21.nr1[ibody]
print @n.xbgr.xr80_u22.nr1[ibody]
print @n.xbgr.xr80_u23.nr1[ibody]
print @n.xbgr.xr80_u24.nr1[ibody]
print @n.xbgr.xr81_u2.nr1[ibody]
print @n.xbgr.xr81_u3.nr1[ibody]
print @n.xbgr.xr81_u4.nr1[ibody]
print @n.xbgr.xr81_u5.nr1[ibody]
print @n.xbgr.xr81_u6.nr1[ibody]
print @n.xbgr.xr81_u7.nr1[ibody]
print @n.xbgr.xr81_u8.nr1[ibody]
print @n.xbgr.xr81_u9.nr1[ibody]
print @n.xbgr.xr81_u10.nr1[ibody]
print @n.xbgr.xr81_u11.nr1[ibody]
print @n.xbgr.xr81_u12.nr1[ibody]
print @n.xbgr.xr81_u13.nr1[ibody]
print @n.xbgr.xr81_u14.nr1[ibody]
print @n.xbgr.xr81_u15.nr1[ibody]
print @n.xbgr.xr81_u16.nr1[ibody]
print @n.xbgr.xr81_u17.nr1[ibody]
print @n.xbgr.xr81_u18.nr1[ibody]
print @n.xbgr.xr81_u19.nr1[ibody]
print @n.xbgr.xr81_u20.nr1[ibody]
print @n.xbgr.xr81_u21.nr1[ibody]
print @n.xbgr.xr81_u22.nr1[ibody]
print @n.xbgr.xr81_u23.nr1[ibody]
print @n.xbgr.xr81_u24.nr1[ibody]
print @n.xbgr.xr82_u2.nr1[ibody]
print @n.xbgr.xr82_u3.nr1[ibody]
print @n.xbgr.xr82_u4.nr1[ibody]
print @n.xbgr.xr82_u5.nr1[ibody]
print @n.xbgr.xr82_u6.nr1[ibody]
print @n.xbgr.xr82_u7.nr1[ibody]
print @n.xbgr.xr82_u8.nr1[ibody]
print @n.xbgr.xr82_u9.nr1[ibody]
print @n.xbgr.xr82_u10.nr1[ibody]
print @n.xbgr.xr82_u11.nr1[ibody]
print @n.xbgr.xr82_u12.nr1[ibody]
print @n.xbgr.xr82_u13.nr1[ibody]
print @n.xbgr.xr82_u14.nr1[ibody]
print @n.xbgr.xr82_u15.nr1[ibody]
print @n.xbgr.xr82_u16.nr1[ibody]
print @n.xbgr.xr82_u17.nr1[ibody]
print @n.xbgr.xr82_u18.nr1[ibody]
print @n.xbgr.xr82_u19.nr1[ibody]
print @n.xbgr.xr82_u20.nr1[ibody]
print @n.xbgr.xr82_u21.nr1[ibody]
print @n.xbgr.xr82_u22.nr1[ibody]
print @n.xbgr.xr82_u23.nr1[ibody]
print @n.xbgr.xr82_u24.nr1[ibody]
print @n.xbgr.xr83_u2.nr1[ibody]
print @n.xbgr.xr83_u3.nr1[ibody]
print @n.xbgr.xr83_u4.nr1[ibody]
print @n.xbgr.xr83_u5.nr1[ibody]
print @n.xbgr.xr83_u6.nr1[ibody]
print @n.xbgr.xr83_u7.nr1[ibody]
print @n.xbgr.xr83_u8.nr1[ibody]
print @n.xbgr.xr83_u9.nr1[ibody]
print @n.xbgr.xr83_u10.nr1[ibody]
print @n.xbgr.xr83_u11.nr1[ibody]
print @n.xbgr.xr83_u12.nr1[ibody]
print @n.xbgr.xr83_u13.nr1[ibody]
print @n.xbgr.xr83_u14.nr1[ibody]
print @n.xbgr.xr83_u15.nr1[ibody]
print @n.xbgr.xr83_u16.nr1[ibody]
print @n.xbgr.xr83_u17.nr1[ibody]
print @n.xbgr.xr83_u18.nr1[ibody]
print @n.xbgr.xr83_u19.nr1[ibody]
print @n.xbgr.xr83_u20.nr1[ibody]
print @n.xbgr.xr83_u21.nr1[ibody]
print @n.xbgr.xr83_u22.nr1[ibody]
print @n.xbgr.xr83_u23.nr1[ibody]
print @n.xbgr.xr83_u24.nr1[ibody]
print @n.xbgr.xr84_u2.nr1[ibody]
print @n.xbgr.xr84_u3.nr1[ibody]
print @n.xbgr.xr84_u4.nr1[ibody]
print @n.xbgr.xr84_u5.nr1[ibody]
print @n.xbgr.xr84_u6.nr1[ibody]
print @n.xbgr.xr84_u7.nr1[ibody]
print @n.xbgr.xr84_u8.nr1[ibody]
print @n.xbgr.xr84_u9.nr1[ibody]
print @n.xbgr.xr84_u10.nr1[ibody]
print @n.xbgr.xr84_u11.nr1[ibody]
print @n.xbgr.xr84_u12.nr1[ibody]
print @n.xbgr.xr84_u13.nr1[ibody]
print @n.xbgr.xr84_u14.nr1[ibody]
print @n.xbgr.xr84_u15.nr1[ibody]
print @n.xbgr.xr84_u16.nr1[ibody]
print @n.xbgr.xr84_u17.nr1[ibody]
print @n.xbgr.xr84_u18.nr1[ibody]
print @n.xbgr.xr84_u19.nr1[ibody]
print @n.xbgr.xr84_u20.nr1[ibody]
print @n.xbgr.xr84_u21.nr1[ibody]
print @n.xbgr.xr84_u22.nr1[ibody]
print @n.xbgr.xr84_u23.nr1[ibody]
print @n.xbgr.xr84_u24.nr1[ibody]
print @n.xbgr.xr85_u2.nr1[ibody]
print @n.xbgr.xr85_u3.nr1[ibody]
print @n.xbgr.xr85_u4.nr1[ibody]
print @n.xbgr.xr85_u5.nr1[ibody]
print @n.xbgr.xr85_u6.nr1[ibody]
print @n.xbgr.xr85_u7.nr1[ibody]
print @n.xbgr.xr85_u8.nr1[ibody]
print @n.xbgr.xr85_u9.nr1[ibody]
print @n.xbgr.xr85_u10.nr1[ibody]
print @n.xbgr.xr85_u11.nr1[ibody]
print @n.xbgr.xr85_u12.nr1[ibody]
print @n.xbgr.xr85_u13.nr1[ibody]
print @n.xbgr.xr85_u14.nr1[ibody]
print @n.xbgr.xr85_u15.nr1[ibody]
print @n.xbgr.xr85_u16.nr1[ibody]
print @n.xbgr.xr85_u17.nr1[ibody]
print @n.xbgr.xr85_u18.nr1[ibody]
print @n.xbgr.xr85_u19.nr1[ibody]
print @n.xbgr.xr85_u20.nr1[ibody]
print @n.xbgr.xr85_u21.nr1[ibody]
print @n.xbgr.xr85_u22.nr1[ibody]
print @n.xbgr.xr85_u23.nr1[ibody]
print @n.xbgr.xr85_u24.nr1[ibody]
print @n.xbgr.xr86_u2.nr1[ibody]
print @n.xbgr.xr86_u3.nr1[ibody]
print @n.xbgr.xr86_u4.nr1[ibody]
print @n.xbgr.xr86_u5.nr1[ibody]
print @n.xbgr.xr86_u6.nr1[ibody]
print @n.xbgr.xr86_u7.nr1[ibody]
print @n.xbgr.xr86_u8.nr1[ibody]
print @n.xbgr.xr86_u9.nr1[ibody]
print @n.xbgr.xr86_u10.nr1[ibody]
print @n.xbgr.xr86_u11.nr1[ibody]
print @n.xbgr.xr86_u12.nr1[ibody]
print @n.xbgr.xr86_u13.nr1[ibody]
print @n.xbgr.xr86_u14.nr1[ibody]
print @n.xbgr.xr86_u15.nr1[ibody]
print @n.xbgr.xr86_u16.nr1[ibody]
print @n.xbgr.xr86_u17.nr1[ibody]
print @n.xbgr.xr86_u18.nr1[ibody]
print @n.xbgr.xr86_u19.nr1[ibody]
print @n.xbgr.xr86_u20.nr1[ibody]
print @n.xbgr.xr86_u21.nr1[ibody]
print @n.xbgr.xr86_u22.nr1[ibody]
print @n.xbgr.xr86_u23.nr1[ibody]
print @n.xbgr.xr86_u24.nr1[ibody]
echo RAW_CURRENT_LEDGER_END
wrdata op_nodes.dat v(xbgr.b1b) v(xbgr.c2) v(xbgr.d1) v(xbgr.d2) v(xbgr.d3) v(xbgr.d4) v(xbgr.d5) v(xbgr.det) v(dvbe) v(iptat) v(xbgr.kick) v(xbgr.n1) v(xbgr.n_10) v(xbgr.n_11) v(xbgr.n_12) v(xbgr.n_13) v(xbgr.n_14) v(xbgr.n_15) v(xbgr.n_16) v(xbgr.n_17) v(xbgr.n_18) v(xbgr.n_19) v(xbgr.n_2) v(xbgr.n_21) v(xbgr.n_22) v(xbgr.n_23) v(xbgr.n_24) v(xbgr.n_25) v(xbgr.n_26) v(xbgr.n_27) v(xbgr.n_3) v(xbgr.n_30) v(xbgr.n_31) v(xbgr.n_33) v(xbgr.n_34) v(xbgr.n_36) v(xbgr.n_37) v(xbgr.n_4) v(xbgr.n_5) v(xbgr.n_6) v(xbgr.n_7) v(xbgr.n_8) v(xbgr.n_9) v(pbias) v(pcasc) v(r4) v(xbgr.r4n) v(xbgr.vb2) v(vbe) v(xbgr.vbe3) v(xbgr.vd1) v(xbgr.vd2) v(vdd) v(vref) v(vdd)-v(vdd) i(vdd) i(vload) i(vr4) i(vsub)
print @n.xbgr.xr1.nr1[nsmm_rsh]
print @n.xbgr.xr1.nr1[nsmm_w]
print @n.xbgr.xr1.nr1[nsmm_l]
print @n.xbgr.xr2.nr1[nsmm_rsh]
print @n.xbgr.xr2.nr1[nsmm_w]
print @n.xbgr.xr2.nr1[nsmm_l]
print @n.xbgr.xr3.nr1[nsmm_rsh]
print @n.xbgr.xr3.nr1[nsmm_w]
print @n.xbgr.xr3.nr1[nsmm_l]
print @n.xbgr.xr4.nr1[nsmm_rsh]
print @n.xbgr.xr4.nr1[nsmm_w]
print @n.xbgr.xr4.nr1[nsmm_l]
print @n.xbgr.xr5.nr1[nsmm_rsh]
print @n.xbgr.xr5.nr1[nsmm_w]
print @n.xbgr.xr5.nr1[nsmm_l]
print @n.xbgr.xr6.nr1[nsmm_rsh]
print @n.xbgr.xr6.nr1[nsmm_w]
print @n.xbgr.xr6.nr1[nsmm_l]
print @n.xbgr.xr7.nr1[nsmm_rsh]
print @n.xbgr.xr7.nr1[nsmm_w]
print @n.xbgr.xr7.nr1[nsmm_l]
print @n.xbgr.xr8.nr1[nsmm_rsh]
print @n.xbgr.xr8.nr1[nsmm_w]
print @n.xbgr.xr8.nr1[nsmm_l]
print @n.xbgr.xr9.nr1[nsmm_rsh]
print @n.xbgr.xr9.nr1[nsmm_w]
print @n.xbgr.xr9.nr1[nsmm_l]
print @n.xbgr.xr10.nr1[nsmm_rsh]
print @n.xbgr.xr10.nr1[nsmm_w]
print @n.xbgr.xr10.nr1[nsmm_l]
print @n.xbgr.xr11.nr1[nsmm_rsh]
print @n.xbgr.xr11.nr1[nsmm_w]
print @n.xbgr.xr11.nr1[nsmm_l]
print @n.xbgr.xr12.nr1[nsmm_rsh]
print @n.xbgr.xr12.nr1[nsmm_w]
print @n.xbgr.xr12.nr1[nsmm_l]
print @n.xbgr.xr13.nr1[nsmm_rsh]
print @n.xbgr.xr13.nr1[nsmm_w]
print @n.xbgr.xr13.nr1[nsmm_l]
print @n.xbgr.xr14.nr1[nsmm_rsh]
print @n.xbgr.xr14.nr1[nsmm_w]
print @n.xbgr.xr14.nr1[nsmm_l]
print @n.xbgr.xr15.nr1[nsmm_rsh]
print @n.xbgr.xr15.nr1[nsmm_w]
print @n.xbgr.xr15.nr1[nsmm_l]
print @n.xbgr.xr16.nr1[nsmm_rsh]
print @n.xbgr.xr16.nr1[nsmm_w]
print @n.xbgr.xr16.nr1[nsmm_l]
print @n.xbgr.xr17.nr1[nsmm_rsh]
print @n.xbgr.xr17.nr1[nsmm_w]
print @n.xbgr.xr17.nr1[nsmm_l]
print @n.xbgr.xr18.nr1[nsmm_rsh]
print @n.xbgr.xr18.nr1[nsmm_w]
print @n.xbgr.xr18.nr1[nsmm_l]
print @n.xbgr.xr19.nr1[nsmm_rsh]
print @n.xbgr.xr19.nr1[nsmm_w]
print @n.xbgr.xr19.nr1[nsmm_l]
print @n.xbgr.xr20.nr1[nsmm_rsh]
print @n.xbgr.xr20.nr1[nsmm_w]
print @n.xbgr.xr20.nr1[nsmm_l]
print @n.xbgr.xr21.nr1[nsmm_rsh]
print @n.xbgr.xr21.nr1[nsmm_w]
print @n.xbgr.xr21.nr1[nsmm_l]
print @n.xbgr.xr22.nr1[nsmm_rsh]
print @n.xbgr.xr22.nr1[nsmm_w]
print @n.xbgr.xr22.nr1[nsmm_l]
print @n.xbgr.xr23.nr1[nsmm_rsh]
print @n.xbgr.xr23.nr1[nsmm_w]
print @n.xbgr.xr23.nr1[nsmm_l]
print @n.xbgr.xr24.nr1[nsmm_rsh]
print @n.xbgr.xr24.nr1[nsmm_w]
print @n.xbgr.xr24.nr1[nsmm_l]
print @n.xbgr.xr25.nr1[nsmm_rsh]
print @n.xbgr.xr25.nr1[nsmm_w]
print @n.xbgr.xr25.nr1[nsmm_l]
print @n.xbgr.xr26.nr1[nsmm_rsh]
print @n.xbgr.xr26.nr1[nsmm_w]
print @n.xbgr.xr26.nr1[nsmm_l]
print @n.xbgr.xm27.nsg13_hv_pmos[w]
print @n.xbgr.xm27.nsg13_hv_pmos[l]
print @n.xbgr.xm27.nsg13_hv_pmos[delvto]
print @n.xbgr.xm27.nsg13_hv_pmos[factuo]
print @n.xbgr.xm28.nsg13_hv_pmos[w]
print @n.xbgr.xm28.nsg13_hv_pmos[l]
print @n.xbgr.xm28.nsg13_hv_pmos[delvto]
print @n.xbgr.xm28.nsg13_hv_pmos[factuo]
print @n.xbgr.xm29.nsg13_hv_nmos[w]
print @n.xbgr.xm29.nsg13_hv_nmos[l]
print @n.xbgr.xm29.nsg13_hv_nmos[delvto]
print @n.xbgr.xm29.nsg13_hv_nmos[factuo]
print @n.xbgr.xm30.nsg13_hv_nmos[w]
print @n.xbgr.xm30.nsg13_hv_nmos[l]
print @n.xbgr.xm30.nsg13_hv_nmos[delvto]
print @n.xbgr.xm30.nsg13_hv_nmos[factuo]
print @n.xbgr.xm31.nsg13_hv_nmos[w]
print @n.xbgr.xm31.nsg13_hv_nmos[l]
print @n.xbgr.xm31.nsg13_hv_nmos[delvto]
print @n.xbgr.xm31.nsg13_hv_nmos[factuo]
print @n.xbgr.xm32.nsg13_hv_nmos[w]
print @n.xbgr.xm32.nsg13_hv_nmos[l]
print @n.xbgr.xm32.nsg13_hv_nmos[delvto]
print @n.xbgr.xm32.nsg13_hv_nmos[factuo]
print @n.xbgr.xm33.nsg13_hv_nmos[w]
print @n.xbgr.xm33.nsg13_hv_nmos[l]
print @n.xbgr.xm33.nsg13_hv_nmos[delvto]
print @n.xbgr.xm33.nsg13_hv_nmos[factuo]
print @n.xbgr.xm34.nsg13_hv_nmos[w]
print @n.xbgr.xm34.nsg13_hv_nmos[l]
print @n.xbgr.xm34.nsg13_hv_nmos[delvto]
print @n.xbgr.xm34.nsg13_hv_nmos[factuo]
print @n.xbgr.xm35.nsg13_hv_nmos[w]
print @n.xbgr.xm35.nsg13_hv_nmos[l]
print @n.xbgr.xm35.nsg13_hv_nmos[delvto]
print @n.xbgr.xm35.nsg13_hv_nmos[factuo]
print @n.xbgr.xm36.nsg13_hv_nmos[w]
print @n.xbgr.xm36.nsg13_hv_nmos[l]
print @n.xbgr.xm36.nsg13_hv_nmos[delvto]
print @n.xbgr.xm36.nsg13_hv_nmos[factuo]
print @n.xbgr.xm37.nsg13_hv_nmos[w]
print @n.xbgr.xm37.nsg13_hv_nmos[l]
print @n.xbgr.xm37.nsg13_hv_nmos[delvto]
print @n.xbgr.xm37.nsg13_hv_nmos[factuo]
print @n.xbgr.xm38.nsg13_hv_pmos[w]
print @n.xbgr.xm38.nsg13_hv_pmos[l]
print @n.xbgr.xm38.nsg13_hv_pmos[delvto]
print @n.xbgr.xm38.nsg13_hv_pmos[factuo]
print @n.xbgr.xm39.nsg13_hv_pmos[w]
print @n.xbgr.xm39.nsg13_hv_pmos[l]
print @n.xbgr.xm39.nsg13_hv_pmos[delvto]
print @n.xbgr.xm39.nsg13_hv_pmos[factuo]
print @n.xbgr.xm40.nsg13_hv_pmos[w]
print @n.xbgr.xm40.nsg13_hv_pmos[l]
print @n.xbgr.xm40.nsg13_hv_pmos[delvto]
print @n.xbgr.xm40.nsg13_hv_pmos[factuo]
print @n.xbgr.xm41.nsg13_hv_pmos[w]
print @n.xbgr.xm41.nsg13_hv_pmos[l]
print @n.xbgr.xm41.nsg13_hv_pmos[delvto]
print @n.xbgr.xm41.nsg13_hv_pmos[factuo]
print @n.xbgr.xm42.nsg13_hv_pmos[w]
print @n.xbgr.xm42.nsg13_hv_pmos[l]
print @n.xbgr.xm42.nsg13_hv_pmos[delvto]
print @n.xbgr.xm42.nsg13_hv_pmos[factuo]
print @n.xbgr.xm43.nsg13_hv_pmos[w]
print @n.xbgr.xm43.nsg13_hv_pmos[l]
print @n.xbgr.xm43.nsg13_hv_pmos[delvto]
print @n.xbgr.xm43.nsg13_hv_pmos[factuo]
print @n.xbgr.xm44.nsg13_hv_pmos[w]
print @n.xbgr.xm44.nsg13_hv_pmos[l]
print @n.xbgr.xm44.nsg13_hv_pmos[delvto]
print @n.xbgr.xm44.nsg13_hv_pmos[factuo]
print @n.xbgr.xm45.nsg13_hv_pmos[w]
print @n.xbgr.xm45.nsg13_hv_pmos[l]
print @n.xbgr.xm45.nsg13_hv_pmos[delvto]
print @n.xbgr.xm45.nsg13_hv_pmos[factuo]
print @n.xbgr.xm46.nsg13_hv_pmos[w]
print @n.xbgr.xm46.nsg13_hv_pmos[l]
print @n.xbgr.xm46.nsg13_hv_pmos[delvto]
print @n.xbgr.xm46.nsg13_hv_pmos[factuo]
print @n.xbgr.xm47.nsg13_hv_pmos[w]
print @n.xbgr.xm47.nsg13_hv_pmos[l]
print @n.xbgr.xm47.nsg13_hv_pmos[delvto]
print @n.xbgr.xm47.nsg13_hv_pmos[factuo]
print @n.xbgr.xm48.nsg13_hv_pmos[w]
print @n.xbgr.xm48.nsg13_hv_pmos[l]
print @n.xbgr.xm48.nsg13_hv_pmos[delvto]
print @n.xbgr.xm48.nsg13_hv_pmos[factuo]
print @n.xbgr.xm49.nsg13_hv_pmos[w]
print @n.xbgr.xm49.nsg13_hv_pmos[l]
print @n.xbgr.xm49.nsg13_hv_pmos[delvto]
print @n.xbgr.xm49.nsg13_hv_pmos[factuo]
print @n.xbgr.xm50.nsg13_hv_pmos[w]
print @n.xbgr.xm50.nsg13_hv_pmos[l]
print @n.xbgr.xm50.nsg13_hv_pmos[delvto]
print @n.xbgr.xm50.nsg13_hv_pmos[factuo]
print @n.xbgr.xm51.nsg13_hv_pmos[w]
print @n.xbgr.xm51.nsg13_hv_pmos[l]
print @n.xbgr.xm51.nsg13_hv_pmos[delvto]
print @n.xbgr.xm51.nsg13_hv_pmos[factuo]
print @n.xbgr.xm52.nsg13_hv_pmos[w]
print @n.xbgr.xm52.nsg13_hv_pmos[l]
print @n.xbgr.xm52.nsg13_hv_pmos[delvto]
print @n.xbgr.xm52.nsg13_hv_pmos[factuo]
print @n.xbgr.xm53.nsg13_hv_pmos[w]
print @n.xbgr.xm53.nsg13_hv_pmos[l]
print @n.xbgr.xm53.nsg13_hv_pmos[delvto]
print @n.xbgr.xm53.nsg13_hv_pmos[factuo]
print @n.xbgr.xm54.nsg13_hv_pmos[w]
print @n.xbgr.xm54.nsg13_hv_pmos[l]
print @n.xbgr.xm54.nsg13_hv_pmos[delvto]
print @n.xbgr.xm54.nsg13_hv_pmos[factuo]
print @q.xbgr.xq55.qnpn13g2[area]
print @q.xbgr.xq56.qnpn13g2[area]
print @q.xbgr.xq57.qnpn13g2[area]
print @q.xbgr.xq58.qnpn13g2[area]
print @q.xbgr.xq59.qnpn13g2[area]
print @q.xbgr.xq60.qnpn13g2[area]
print @q.xbgr.xq61.qnpn13g2[area]
print @q.xbgr.xq62.qnpn13g2[area]
print @q.xbgr.xq63.qnpn13g2[area]
print @q.xbgr.xq64.qnpn13g2[area]
print @q.xbgr.xq65.qnpn13g2[area]
print @q.xbgr.xq66.qnpn13g2[area]
print @q.xbgr.xq67.qnpn13g2[area]
print @q.xbgr.xq68.qnpn13g2[area]
print @q.xbgr.xq69.qnpn13g2[area]
print @q.xbgr.xq70.qnpn13g2[area]
print @q.xbgr.xq71.qnpn13g2[area]
print @q.xbgr.xq72.qnpn13g2[area]
print @q.xbgr.xq73.qnpn13g2[area]
print @q.xbgr.xq74.qnpn13g2[area]
print @q.xbgr.xq75.qnpn13g2[area]
print @q.xbgr.xq76.qnpn13g2[area]
print @n.xbgr.xr77.nr1[nsmm_rsh]
print @n.xbgr.xr77.nr1[nsmm_w]
print @n.xbgr.xr77.nr1[nsmm_l]
print @n.xbgr.xr78.nr1[nsmm_rsh]
print @n.xbgr.xr78.nr1[nsmm_w]
print @n.xbgr.xr78.nr1[nsmm_l]
print @n.xbgr.xr79.nr1[nsmm_rsh]
print @n.xbgr.xr79.nr1[nsmm_w]
print @n.xbgr.xr79.nr1[nsmm_l]
print @n.xbgr.xr80.nr1[nsmm_rsh]
print @n.xbgr.xr80.nr1[nsmm_w]
print @n.xbgr.xr80.nr1[nsmm_l]
print @n.xbgr.xr81.nr1[nsmm_rsh]
print @n.xbgr.xr81.nr1[nsmm_w]
print @n.xbgr.xr81.nr1[nsmm_l]
print @n.xbgr.xr82.nr1[nsmm_rsh]
print @n.xbgr.xr82.nr1[nsmm_w]
print @n.xbgr.xr82.nr1[nsmm_l]
print @n.xbgr.xr83.nr1[nsmm_rsh]
print @n.xbgr.xr83.nr1[nsmm_w]
print @n.xbgr.xr83.nr1[nsmm_l]
print @n.xbgr.xr84.nr1[nsmm_rsh]
print @n.xbgr.xr84.nr1[nsmm_w]
print @n.xbgr.xr84.nr1[nsmm_l]
print @n.xbgr.xr85.nr1[nsmm_rsh]
print @n.xbgr.xr85.nr1[nsmm_w]
print @n.xbgr.xr85.nr1[nsmm_l]
print @n.xbgr.xr86.nr1[nsmm_rsh]
print @n.xbgr.xr86.nr1[nsmm_w]
print @n.xbgr.xr86.nr1[nsmm_l]
print @n.xbgr.xr16_u2.nr1[nsmm_rsh]
print @n.xbgr.xr16_u2.nr1[nsmm_w]
print @n.xbgr.xr16_u2.nr1[nsmm_l]
print @n.xbgr.xr16_u3.nr1[nsmm_rsh]
print @n.xbgr.xr16_u3.nr1[nsmm_w]
print @n.xbgr.xr16_u3.nr1[nsmm_l]
print @n.xbgr.xr16_u4.nr1[nsmm_rsh]
print @n.xbgr.xr16_u4.nr1[nsmm_w]
print @n.xbgr.xr16_u4.nr1[nsmm_l]
print @n.xbgr.xr16_u5.nr1[nsmm_rsh]
print @n.xbgr.xr16_u5.nr1[nsmm_w]
print @n.xbgr.xr16_u5.nr1[nsmm_l]
print @n.xbgr.xr16_u6.nr1[nsmm_rsh]
print @n.xbgr.xr16_u6.nr1[nsmm_w]
print @n.xbgr.xr16_u6.nr1[nsmm_l]
print @n.xbgr.xr16_u7.nr1[nsmm_rsh]
print @n.xbgr.xr16_u7.nr1[nsmm_w]
print @n.xbgr.xr16_u7.nr1[nsmm_l]
print @n.xbgr.xr16_u8.nr1[nsmm_rsh]
print @n.xbgr.xr16_u8.nr1[nsmm_w]
print @n.xbgr.xr16_u8.nr1[nsmm_l]
print @n.xbgr.xr16_u9.nr1[nsmm_rsh]
print @n.xbgr.xr16_u9.nr1[nsmm_w]
print @n.xbgr.xr16_u9.nr1[nsmm_l]
print @n.xbgr.xr16_u10.nr1[nsmm_rsh]
print @n.xbgr.xr16_u10.nr1[nsmm_w]
print @n.xbgr.xr16_u10.nr1[nsmm_l]
print @n.xbgr.xr16_u11.nr1[nsmm_rsh]
print @n.xbgr.xr16_u11.nr1[nsmm_w]
print @n.xbgr.xr16_u11.nr1[nsmm_l]
print @n.xbgr.xr16_u12.nr1[nsmm_rsh]
print @n.xbgr.xr16_u12.nr1[nsmm_w]
print @n.xbgr.xr16_u12.nr1[nsmm_l]
print @n.xbgr.xr16_u13.nr1[nsmm_rsh]
print @n.xbgr.xr16_u13.nr1[nsmm_w]
print @n.xbgr.xr16_u13.nr1[nsmm_l]
print @n.xbgr.xr16_u14.nr1[nsmm_rsh]
print @n.xbgr.xr16_u14.nr1[nsmm_w]
print @n.xbgr.xr16_u14.nr1[nsmm_l]
print @n.xbgr.xr16_u15.nr1[nsmm_rsh]
print @n.xbgr.xr16_u15.nr1[nsmm_w]
print @n.xbgr.xr16_u15.nr1[nsmm_l]
print @n.xbgr.xr16_u16.nr1[nsmm_rsh]
print @n.xbgr.xr16_u16.nr1[nsmm_w]
print @n.xbgr.xr16_u16.nr1[nsmm_l]
print @n.xbgr.xr16_u17.nr1[nsmm_rsh]
print @n.xbgr.xr16_u17.nr1[nsmm_w]
print @n.xbgr.xr16_u17.nr1[nsmm_l]
print @n.xbgr.xr16_u18.nr1[nsmm_rsh]
print @n.xbgr.xr16_u18.nr1[nsmm_w]
print @n.xbgr.xr16_u18.nr1[nsmm_l]
print @n.xbgr.xr16_u19.nr1[nsmm_rsh]
print @n.xbgr.xr16_u19.nr1[nsmm_w]
print @n.xbgr.xr16_u19.nr1[nsmm_l]
print @n.xbgr.xr16_u20.nr1[nsmm_rsh]
print @n.xbgr.xr16_u20.nr1[nsmm_w]
print @n.xbgr.xr16_u20.nr1[nsmm_l]
print @n.xbgr.xr16_u21.nr1[nsmm_rsh]
print @n.xbgr.xr16_u21.nr1[nsmm_w]
print @n.xbgr.xr16_u21.nr1[nsmm_l]
print @n.xbgr.xr16_u22.nr1[nsmm_rsh]
print @n.xbgr.xr16_u22.nr1[nsmm_w]
print @n.xbgr.xr16_u22.nr1[nsmm_l]
print @n.xbgr.xr16_u23.nr1[nsmm_rsh]
print @n.xbgr.xr16_u23.nr1[nsmm_w]
print @n.xbgr.xr16_u23.nr1[nsmm_l]
print @n.xbgr.xr16_u24.nr1[nsmm_rsh]
print @n.xbgr.xr16_u24.nr1[nsmm_w]
print @n.xbgr.xr16_u24.nr1[nsmm_l]
print @n.xbgr.xr17_u2.nr1[nsmm_rsh]
print @n.xbgr.xr17_u2.nr1[nsmm_w]
print @n.xbgr.xr17_u2.nr1[nsmm_l]
print @n.xbgr.xr17_u3.nr1[nsmm_rsh]
print @n.xbgr.xr17_u3.nr1[nsmm_w]
print @n.xbgr.xr17_u3.nr1[nsmm_l]
print @n.xbgr.xr17_u4.nr1[nsmm_rsh]
print @n.xbgr.xr17_u4.nr1[nsmm_w]
print @n.xbgr.xr17_u4.nr1[nsmm_l]
print @n.xbgr.xr18_u2.nr1[nsmm_rsh]
print @n.xbgr.xr18_u2.nr1[nsmm_w]
print @n.xbgr.xr18_u2.nr1[nsmm_l]
print @n.xbgr.xr18_u3.nr1[nsmm_rsh]
print @n.xbgr.xr18_u3.nr1[nsmm_w]
print @n.xbgr.xr18_u3.nr1[nsmm_l]
print @n.xbgr.xr18_u4.nr1[nsmm_rsh]
print @n.xbgr.xr18_u4.nr1[nsmm_w]
print @n.xbgr.xr18_u4.nr1[nsmm_l]
print @n.xbgr.xr19_u2.nr1[nsmm_rsh]
print @n.xbgr.xr19_u2.nr1[nsmm_w]
print @n.xbgr.xr19_u2.nr1[nsmm_l]
print @n.xbgr.xr19_u3.nr1[nsmm_rsh]
print @n.xbgr.xr19_u3.nr1[nsmm_w]
print @n.xbgr.xr19_u3.nr1[nsmm_l]
print @n.xbgr.xr19_u4.nr1[nsmm_rsh]
print @n.xbgr.xr19_u4.nr1[nsmm_w]
print @n.xbgr.xr19_u4.nr1[nsmm_l]
print @n.xbgr.xr20_u2.nr1[nsmm_rsh]
print @n.xbgr.xr20_u2.nr1[nsmm_w]
print @n.xbgr.xr20_u2.nr1[nsmm_l]
print @n.xbgr.xr20_u3.nr1[nsmm_rsh]
print @n.xbgr.xr20_u3.nr1[nsmm_w]
print @n.xbgr.xr20_u3.nr1[nsmm_l]
print @n.xbgr.xr20_u4.nr1[nsmm_rsh]
print @n.xbgr.xr20_u4.nr1[nsmm_w]
print @n.xbgr.xr20_u4.nr1[nsmm_l]
print @n.xbgr.xr21_u2.nr1[nsmm_rsh]
print @n.xbgr.xr21_u2.nr1[nsmm_w]
print @n.xbgr.xr21_u2.nr1[nsmm_l]
print @n.xbgr.xr21_u3.nr1[nsmm_rsh]
print @n.xbgr.xr21_u3.nr1[nsmm_w]
print @n.xbgr.xr21_u3.nr1[nsmm_l]
print @n.xbgr.xr21_u4.nr1[nsmm_rsh]
print @n.xbgr.xr21_u4.nr1[nsmm_w]
print @n.xbgr.xr21_u4.nr1[nsmm_l]
print @n.xbgr.xr22_u2.nr1[nsmm_rsh]
print @n.xbgr.xr22_u2.nr1[nsmm_w]
print @n.xbgr.xr22_u2.nr1[nsmm_l]
print @n.xbgr.xr22_u3.nr1[nsmm_rsh]
print @n.xbgr.xr22_u3.nr1[nsmm_w]
print @n.xbgr.xr22_u3.nr1[nsmm_l]
print @n.xbgr.xr22_u4.nr1[nsmm_rsh]
print @n.xbgr.xr22_u4.nr1[nsmm_w]
print @n.xbgr.xr22_u4.nr1[nsmm_l]
print @n.xbgr.xr23_u2.nr1[nsmm_rsh]
print @n.xbgr.xr23_u2.nr1[nsmm_w]
print @n.xbgr.xr23_u2.nr1[nsmm_l]
print @n.xbgr.xr23_u3.nr1[nsmm_rsh]
print @n.xbgr.xr23_u3.nr1[nsmm_w]
print @n.xbgr.xr23_u3.nr1[nsmm_l]
print @n.xbgr.xr23_u4.nr1[nsmm_rsh]
print @n.xbgr.xr23_u4.nr1[nsmm_w]
print @n.xbgr.xr23_u4.nr1[nsmm_l]
print @n.xbgr.xr23_u5.nr1[nsmm_rsh]
print @n.xbgr.xr23_u5.nr1[nsmm_w]
print @n.xbgr.xr23_u5.nr1[nsmm_l]
print @n.xbgr.xr23_u6.nr1[nsmm_rsh]
print @n.xbgr.xr23_u6.nr1[nsmm_w]
print @n.xbgr.xr23_u6.nr1[nsmm_l]
print @n.xbgr.xr23_u7.nr1[nsmm_rsh]
print @n.xbgr.xr23_u7.nr1[nsmm_w]
print @n.xbgr.xr23_u7.nr1[nsmm_l]
print @n.xbgr.xr23_u8.nr1[nsmm_rsh]
print @n.xbgr.xr23_u8.nr1[nsmm_w]
print @n.xbgr.xr23_u8.nr1[nsmm_l]
print @n.xbgr.xr23_u9.nr1[nsmm_rsh]
print @n.xbgr.xr23_u9.nr1[nsmm_w]
print @n.xbgr.xr23_u9.nr1[nsmm_l]
print @n.xbgr.xr23_u10.nr1[nsmm_rsh]
print @n.xbgr.xr23_u10.nr1[nsmm_w]
print @n.xbgr.xr23_u10.nr1[nsmm_l]
print @n.xbgr.xr23_u11.nr1[nsmm_rsh]
print @n.xbgr.xr23_u11.nr1[nsmm_w]
print @n.xbgr.xr23_u11.nr1[nsmm_l]
print @n.xbgr.xr23_u12.nr1[nsmm_rsh]
print @n.xbgr.xr23_u12.nr1[nsmm_w]
print @n.xbgr.xr23_u12.nr1[nsmm_l]
print @n.xbgr.xr23_u13.nr1[nsmm_rsh]
print @n.xbgr.xr23_u13.nr1[nsmm_w]
print @n.xbgr.xr23_u13.nr1[nsmm_l]
print @n.xbgr.xr23_u14.nr1[nsmm_rsh]
print @n.xbgr.xr23_u14.nr1[nsmm_w]
print @n.xbgr.xr23_u14.nr1[nsmm_l]
print @n.xbgr.xr23_u15.nr1[nsmm_rsh]
print @n.xbgr.xr23_u15.nr1[nsmm_w]
print @n.xbgr.xr23_u15.nr1[nsmm_l]
print @n.xbgr.xr23_u16.nr1[nsmm_rsh]
print @n.xbgr.xr23_u16.nr1[nsmm_w]
print @n.xbgr.xr23_u16.nr1[nsmm_l]
print @n.xbgr.xr23_u17.nr1[nsmm_rsh]
print @n.xbgr.xr23_u17.nr1[nsmm_w]
print @n.xbgr.xr23_u17.nr1[nsmm_l]
print @n.xbgr.xr23_u18.nr1[nsmm_rsh]
print @n.xbgr.xr23_u18.nr1[nsmm_w]
print @n.xbgr.xr23_u18.nr1[nsmm_l]
print @n.xbgr.xr23_u19.nr1[nsmm_rsh]
print @n.xbgr.xr23_u19.nr1[nsmm_w]
print @n.xbgr.xr23_u19.nr1[nsmm_l]
print @n.xbgr.xr23_u20.nr1[nsmm_rsh]
print @n.xbgr.xr23_u20.nr1[nsmm_w]
print @n.xbgr.xr23_u20.nr1[nsmm_l]
print @n.xbgr.xr23_u21.nr1[nsmm_rsh]
print @n.xbgr.xr23_u21.nr1[nsmm_w]
print @n.xbgr.xr23_u21.nr1[nsmm_l]
print @n.xbgr.xr23_u22.nr1[nsmm_rsh]
print @n.xbgr.xr23_u22.nr1[nsmm_w]
print @n.xbgr.xr23_u22.nr1[nsmm_l]
print @n.xbgr.xr23_u23.nr1[nsmm_rsh]
print @n.xbgr.xr23_u23.nr1[nsmm_w]
print @n.xbgr.xr23_u23.nr1[nsmm_l]
print @n.xbgr.xr23_u24.nr1[nsmm_rsh]
print @n.xbgr.xr23_u24.nr1[nsmm_w]
print @n.xbgr.xr23_u24.nr1[nsmm_l]
print @n.xbgr.xr24_u2.nr1[nsmm_rsh]
print @n.xbgr.xr24_u2.nr1[nsmm_w]
print @n.xbgr.xr24_u2.nr1[nsmm_l]
print @n.xbgr.xr24_u3.nr1[nsmm_rsh]
print @n.xbgr.xr24_u3.nr1[nsmm_w]
print @n.xbgr.xr24_u3.nr1[nsmm_l]
print @n.xbgr.xr24_u4.nr1[nsmm_rsh]
print @n.xbgr.xr24_u4.nr1[nsmm_w]
print @n.xbgr.xr24_u4.nr1[nsmm_l]
print @n.xbgr.xr24_u5.nr1[nsmm_rsh]
print @n.xbgr.xr24_u5.nr1[nsmm_w]
print @n.xbgr.xr24_u5.nr1[nsmm_l]
print @n.xbgr.xr24_u6.nr1[nsmm_rsh]
print @n.xbgr.xr24_u6.nr1[nsmm_w]
print @n.xbgr.xr24_u6.nr1[nsmm_l]
print @n.xbgr.xr24_u7.nr1[nsmm_rsh]
print @n.xbgr.xr24_u7.nr1[nsmm_w]
print @n.xbgr.xr24_u7.nr1[nsmm_l]
print @n.xbgr.xr24_u8.nr1[nsmm_rsh]
print @n.xbgr.xr24_u8.nr1[nsmm_w]
print @n.xbgr.xr24_u8.nr1[nsmm_l]
print @n.xbgr.xr24_u9.nr1[nsmm_rsh]
print @n.xbgr.xr24_u9.nr1[nsmm_w]
print @n.xbgr.xr24_u9.nr1[nsmm_l]
print @n.xbgr.xr24_u10.nr1[nsmm_rsh]
print @n.xbgr.xr24_u10.nr1[nsmm_w]
print @n.xbgr.xr24_u10.nr1[nsmm_l]
print @n.xbgr.xr24_u11.nr1[nsmm_rsh]
print @n.xbgr.xr24_u11.nr1[nsmm_w]
print @n.xbgr.xr24_u11.nr1[nsmm_l]
print @n.xbgr.xr24_u12.nr1[nsmm_rsh]
print @n.xbgr.xr24_u12.nr1[nsmm_w]
print @n.xbgr.xr24_u12.nr1[nsmm_l]
print @n.xbgr.xr24_u13.nr1[nsmm_rsh]
print @n.xbgr.xr24_u13.nr1[nsmm_w]
print @n.xbgr.xr24_u13.nr1[nsmm_l]
print @n.xbgr.xr24_u14.nr1[nsmm_rsh]
print @n.xbgr.xr24_u14.nr1[nsmm_w]
print @n.xbgr.xr24_u14.nr1[nsmm_l]
print @n.xbgr.xr24_u15.nr1[nsmm_rsh]
print @n.xbgr.xr24_u15.nr1[nsmm_w]
print @n.xbgr.xr24_u15.nr1[nsmm_l]
print @n.xbgr.xr24_u16.nr1[nsmm_rsh]
print @n.xbgr.xr24_u16.nr1[nsmm_w]
print @n.xbgr.xr24_u16.nr1[nsmm_l]
print @n.xbgr.xr24_u17.nr1[nsmm_rsh]
print @n.xbgr.xr24_u17.nr1[nsmm_w]
print @n.xbgr.xr24_u17.nr1[nsmm_l]
print @n.xbgr.xr24_u18.nr1[nsmm_rsh]
print @n.xbgr.xr24_u18.nr1[nsmm_w]
print @n.xbgr.xr24_u18.nr1[nsmm_l]
print @n.xbgr.xr24_u19.nr1[nsmm_rsh]
print @n.xbgr.xr24_u19.nr1[nsmm_w]
print @n.xbgr.xr24_u19.nr1[nsmm_l]
print @n.xbgr.xr24_u20.nr1[nsmm_rsh]
print @n.xbgr.xr24_u20.nr1[nsmm_w]
print @n.xbgr.xr24_u20.nr1[nsmm_l]
print @n.xbgr.xr24_u21.nr1[nsmm_rsh]
print @n.xbgr.xr24_u21.nr1[nsmm_w]
print @n.xbgr.xr24_u21.nr1[nsmm_l]
print @n.xbgr.xr24_u22.nr1[nsmm_rsh]
print @n.xbgr.xr24_u22.nr1[nsmm_w]
print @n.xbgr.xr24_u22.nr1[nsmm_l]
print @n.xbgr.xr24_u23.nr1[nsmm_rsh]
print @n.xbgr.xr24_u23.nr1[nsmm_w]
print @n.xbgr.xr24_u23.nr1[nsmm_l]
print @n.xbgr.xr24_u24.nr1[nsmm_rsh]
print @n.xbgr.xr24_u24.nr1[nsmm_w]
print @n.xbgr.xr24_u24.nr1[nsmm_l]
print @n.xbgr.xr25_u2.nr1[nsmm_rsh]
print @n.xbgr.xr25_u2.nr1[nsmm_w]
print @n.xbgr.xr25_u2.nr1[nsmm_l]
print @n.xbgr.xr25_u3.nr1[nsmm_rsh]
print @n.xbgr.xr25_u3.nr1[nsmm_w]
print @n.xbgr.xr25_u3.nr1[nsmm_l]
print @n.xbgr.xr25_u4.nr1[nsmm_rsh]
print @n.xbgr.xr25_u4.nr1[nsmm_w]
print @n.xbgr.xr25_u4.nr1[nsmm_l]
print @n.xbgr.xr25_u5.nr1[nsmm_rsh]
print @n.xbgr.xr25_u5.nr1[nsmm_w]
print @n.xbgr.xr25_u5.nr1[nsmm_l]
print @n.xbgr.xr25_u6.nr1[nsmm_rsh]
print @n.xbgr.xr25_u6.nr1[nsmm_w]
print @n.xbgr.xr25_u6.nr1[nsmm_l]
print @n.xbgr.xr25_u7.nr1[nsmm_rsh]
print @n.xbgr.xr25_u7.nr1[nsmm_w]
print @n.xbgr.xr25_u7.nr1[nsmm_l]
print @n.xbgr.xr25_u8.nr1[nsmm_rsh]
print @n.xbgr.xr25_u8.nr1[nsmm_w]
print @n.xbgr.xr25_u8.nr1[nsmm_l]
print @n.xbgr.xr25_u9.nr1[nsmm_rsh]
print @n.xbgr.xr25_u9.nr1[nsmm_w]
print @n.xbgr.xr25_u9.nr1[nsmm_l]
print @n.xbgr.xr25_u10.nr1[nsmm_rsh]
print @n.xbgr.xr25_u10.nr1[nsmm_w]
print @n.xbgr.xr25_u10.nr1[nsmm_l]
print @n.xbgr.xr25_u11.nr1[nsmm_rsh]
print @n.xbgr.xr25_u11.nr1[nsmm_w]
print @n.xbgr.xr25_u11.nr1[nsmm_l]
print @n.xbgr.xr25_u12.nr1[nsmm_rsh]
print @n.xbgr.xr25_u12.nr1[nsmm_w]
print @n.xbgr.xr25_u12.nr1[nsmm_l]
print @n.xbgr.xr25_u13.nr1[nsmm_rsh]
print @n.xbgr.xr25_u13.nr1[nsmm_w]
print @n.xbgr.xr25_u13.nr1[nsmm_l]
print @n.xbgr.xr25_u14.nr1[nsmm_rsh]
print @n.xbgr.xr25_u14.nr1[nsmm_w]
print @n.xbgr.xr25_u14.nr1[nsmm_l]
print @n.xbgr.xr25_u15.nr1[nsmm_rsh]
print @n.xbgr.xr25_u15.nr1[nsmm_w]
print @n.xbgr.xr25_u15.nr1[nsmm_l]
print @n.xbgr.xr25_u16.nr1[nsmm_rsh]
print @n.xbgr.xr25_u16.nr1[nsmm_w]
print @n.xbgr.xr25_u16.nr1[nsmm_l]
print @n.xbgr.xr25_u17.nr1[nsmm_rsh]
print @n.xbgr.xr25_u17.nr1[nsmm_w]
print @n.xbgr.xr25_u17.nr1[nsmm_l]
print @n.xbgr.xr25_u18.nr1[nsmm_rsh]
print @n.xbgr.xr25_u18.nr1[nsmm_w]
print @n.xbgr.xr25_u18.nr1[nsmm_l]
print @n.xbgr.xr25_u19.nr1[nsmm_rsh]
print @n.xbgr.xr25_u19.nr1[nsmm_w]
print @n.xbgr.xr25_u19.nr1[nsmm_l]
print @n.xbgr.xr25_u20.nr1[nsmm_rsh]
print @n.xbgr.xr25_u20.nr1[nsmm_w]
print @n.xbgr.xr25_u20.nr1[nsmm_l]
print @n.xbgr.xr25_u21.nr1[nsmm_rsh]
print @n.xbgr.xr25_u21.nr1[nsmm_w]
print @n.xbgr.xr25_u21.nr1[nsmm_l]
print @n.xbgr.xr25_u22.nr1[nsmm_rsh]
print @n.xbgr.xr25_u22.nr1[nsmm_w]
print @n.xbgr.xr25_u22.nr1[nsmm_l]
print @n.xbgr.xr25_u23.nr1[nsmm_rsh]
print @n.xbgr.xr25_u23.nr1[nsmm_w]
print @n.xbgr.xr25_u23.nr1[nsmm_l]
print @n.xbgr.xr25_u24.nr1[nsmm_rsh]
print @n.xbgr.xr25_u24.nr1[nsmm_w]
print @n.xbgr.xr25_u24.nr1[nsmm_l]
print @n.xbgr.xr26_u2.nr1[nsmm_rsh]
print @n.xbgr.xr26_u2.nr1[nsmm_w]
print @n.xbgr.xr26_u2.nr1[nsmm_l]
print @n.xbgr.xr26_u3.nr1[nsmm_rsh]
print @n.xbgr.xr26_u3.nr1[nsmm_w]
print @n.xbgr.xr26_u3.nr1[nsmm_l]
print @n.xbgr.xr26_u4.nr1[nsmm_rsh]
print @n.xbgr.xr26_u4.nr1[nsmm_w]
print @n.xbgr.xr26_u4.nr1[nsmm_l]
print @n.xbgr.xr26_u5.nr1[nsmm_rsh]
print @n.xbgr.xr26_u5.nr1[nsmm_w]
print @n.xbgr.xr26_u5.nr1[nsmm_l]
print @n.xbgr.xr26_u6.nr1[nsmm_rsh]
print @n.xbgr.xr26_u6.nr1[nsmm_w]
print @n.xbgr.xr26_u6.nr1[nsmm_l]
print @n.xbgr.xr26_u7.nr1[nsmm_rsh]
print @n.xbgr.xr26_u7.nr1[nsmm_w]
print @n.xbgr.xr26_u7.nr1[nsmm_l]
print @n.xbgr.xr26_u8.nr1[nsmm_rsh]
print @n.xbgr.xr26_u8.nr1[nsmm_w]
print @n.xbgr.xr26_u8.nr1[nsmm_l]
print @n.xbgr.xr26_u9.nr1[nsmm_rsh]
print @n.xbgr.xr26_u9.nr1[nsmm_w]
print @n.xbgr.xr26_u9.nr1[nsmm_l]
print @n.xbgr.xr26_u10.nr1[nsmm_rsh]
print @n.xbgr.xr26_u10.nr1[nsmm_w]
print @n.xbgr.xr26_u10.nr1[nsmm_l]
print @n.xbgr.xr26_u11.nr1[nsmm_rsh]
print @n.xbgr.xr26_u11.nr1[nsmm_w]
print @n.xbgr.xr26_u11.nr1[nsmm_l]
print @n.xbgr.xr26_u12.nr1[nsmm_rsh]
print @n.xbgr.xr26_u12.nr1[nsmm_w]
print @n.xbgr.xr26_u12.nr1[nsmm_l]
print @n.xbgr.xr26_u13.nr1[nsmm_rsh]
print @n.xbgr.xr26_u13.nr1[nsmm_w]
print @n.xbgr.xr26_u13.nr1[nsmm_l]
print @n.xbgr.xr26_u14.nr1[nsmm_rsh]
print @n.xbgr.xr26_u14.nr1[nsmm_w]
print @n.xbgr.xr26_u14.nr1[nsmm_l]
print @n.xbgr.xr26_u15.nr1[nsmm_rsh]
print @n.xbgr.xr26_u15.nr1[nsmm_w]
print @n.xbgr.xr26_u15.nr1[nsmm_l]
print @n.xbgr.xr26_u16.nr1[nsmm_rsh]
print @n.xbgr.xr26_u16.nr1[nsmm_w]
print @n.xbgr.xr26_u16.nr1[nsmm_l]
print @n.xbgr.xr26_u17.nr1[nsmm_rsh]
print @n.xbgr.xr26_u17.nr1[nsmm_w]
print @n.xbgr.xr26_u17.nr1[nsmm_l]
print @n.xbgr.xr26_u18.nr1[nsmm_rsh]
print @n.xbgr.xr26_u18.nr1[nsmm_w]
print @n.xbgr.xr26_u18.nr1[nsmm_l]
print @n.xbgr.xr26_u19.nr1[nsmm_rsh]
print @n.xbgr.xr26_u19.nr1[nsmm_w]
print @n.xbgr.xr26_u19.nr1[nsmm_l]
print @n.xbgr.xr26_u20.nr1[nsmm_rsh]
print @n.xbgr.xr26_u20.nr1[nsmm_w]
print @n.xbgr.xr26_u20.nr1[nsmm_l]
print @n.xbgr.xr26_u21.nr1[nsmm_rsh]
print @n.xbgr.xr26_u21.nr1[nsmm_w]
print @n.xbgr.xr26_u21.nr1[nsmm_l]
print @n.xbgr.xr26_u22.nr1[nsmm_rsh]
print @n.xbgr.xr26_u22.nr1[nsmm_w]
print @n.xbgr.xr26_u22.nr1[nsmm_l]
print @n.xbgr.xr26_u23.nr1[nsmm_rsh]
print @n.xbgr.xr26_u23.nr1[nsmm_w]
print @n.xbgr.xr26_u23.nr1[nsmm_l]
print @n.xbgr.xr26_u24.nr1[nsmm_rsh]
print @n.xbgr.xr26_u24.nr1[nsmm_w]
print @n.xbgr.xr26_u24.nr1[nsmm_l]
print @n.xbgr.xm34_u2.nsg13_hv_nmos[w]
print @n.xbgr.xm34_u2.nsg13_hv_nmos[l]
print @n.xbgr.xm34_u2.nsg13_hv_nmos[delvto]
print @n.xbgr.xm34_u2.nsg13_hv_nmos[factuo]
print @n.xbgr.xm34_u3.nsg13_hv_nmos[w]
print @n.xbgr.xm34_u3.nsg13_hv_nmos[l]
print @n.xbgr.xm34_u3.nsg13_hv_nmos[delvto]
print @n.xbgr.xm34_u3.nsg13_hv_nmos[factuo]
print @n.xbgr.xm34_u4.nsg13_hv_nmos[w]
print @n.xbgr.xm34_u4.nsg13_hv_nmos[l]
print @n.xbgr.xm34_u4.nsg13_hv_nmos[delvto]
print @n.xbgr.xm34_u4.nsg13_hv_nmos[factuo]
print @n.xbgr.xm34_u5.nsg13_hv_nmos[w]
print @n.xbgr.xm34_u5.nsg13_hv_nmos[l]
print @n.xbgr.xm34_u5.nsg13_hv_nmos[delvto]
print @n.xbgr.xm34_u5.nsg13_hv_nmos[factuo]
print @n.xbgr.xm34_u6.nsg13_hv_nmos[w]
print @n.xbgr.xm34_u6.nsg13_hv_nmos[l]
print @n.xbgr.xm34_u6.nsg13_hv_nmos[delvto]
print @n.xbgr.xm34_u6.nsg13_hv_nmos[factuo]
print @n.xbgr.xm34_u7.nsg13_hv_nmos[w]
print @n.xbgr.xm34_u7.nsg13_hv_nmos[l]
print @n.xbgr.xm34_u7.nsg13_hv_nmos[delvto]
print @n.xbgr.xm34_u7.nsg13_hv_nmos[factuo]
print @n.xbgr.xm34_u8.nsg13_hv_nmos[w]
print @n.xbgr.xm34_u8.nsg13_hv_nmos[l]
print @n.xbgr.xm34_u8.nsg13_hv_nmos[delvto]
print @n.xbgr.xm34_u8.nsg13_hv_nmos[factuo]
print @n.xbgr.xm34_u9.nsg13_hv_nmos[w]
print @n.xbgr.xm34_u9.nsg13_hv_nmos[l]
print @n.xbgr.xm34_u9.nsg13_hv_nmos[delvto]
print @n.xbgr.xm34_u9.nsg13_hv_nmos[factuo]
print @n.xbgr.xm34_u10.nsg13_hv_nmos[w]
print @n.xbgr.xm34_u10.nsg13_hv_nmos[l]
print @n.xbgr.xm34_u10.nsg13_hv_nmos[delvto]
print @n.xbgr.xm34_u10.nsg13_hv_nmos[factuo]
print @n.xbgr.xm34_u11.nsg13_hv_nmos[w]
print @n.xbgr.xm34_u11.nsg13_hv_nmos[l]
print @n.xbgr.xm34_u11.nsg13_hv_nmos[delvto]
print @n.xbgr.xm34_u11.nsg13_hv_nmos[factuo]
print @n.xbgr.xm34_u12.nsg13_hv_nmos[w]
print @n.xbgr.xm34_u12.nsg13_hv_nmos[l]
print @n.xbgr.xm34_u12.nsg13_hv_nmos[delvto]
print @n.xbgr.xm34_u12.nsg13_hv_nmos[factuo]
print @n.xbgr.xm34_u13.nsg13_hv_nmos[w]
print @n.xbgr.xm34_u13.nsg13_hv_nmos[l]
print @n.xbgr.xm34_u13.nsg13_hv_nmos[delvto]
print @n.xbgr.xm34_u13.nsg13_hv_nmos[factuo]
print @n.xbgr.xm34_u14.nsg13_hv_nmos[w]
print @n.xbgr.xm34_u14.nsg13_hv_nmos[l]
print @n.xbgr.xm34_u14.nsg13_hv_nmos[delvto]
print @n.xbgr.xm34_u14.nsg13_hv_nmos[factuo]
print @n.xbgr.xm34_u15.nsg13_hv_nmos[w]
print @n.xbgr.xm34_u15.nsg13_hv_nmos[l]
print @n.xbgr.xm34_u15.nsg13_hv_nmos[delvto]
print @n.xbgr.xm34_u15.nsg13_hv_nmos[factuo]
print @n.xbgr.xm34_u16.nsg13_hv_nmos[w]
print @n.xbgr.xm34_u16.nsg13_hv_nmos[l]
print @n.xbgr.xm34_u16.nsg13_hv_nmos[delvto]
print @n.xbgr.xm34_u16.nsg13_hv_nmos[factuo]
print @n.xbgr.xm34_u17.nsg13_hv_nmos[w]
print @n.xbgr.xm34_u17.nsg13_hv_nmos[l]
print @n.xbgr.xm34_u17.nsg13_hv_nmos[delvto]
print @n.xbgr.xm34_u17.nsg13_hv_nmos[factuo]
print @n.xbgr.xm34_u18.nsg13_hv_nmos[w]
print @n.xbgr.xm34_u18.nsg13_hv_nmos[l]
print @n.xbgr.xm34_u18.nsg13_hv_nmos[delvto]
print @n.xbgr.xm34_u18.nsg13_hv_nmos[factuo]
print @n.xbgr.xm34_u19.nsg13_hv_nmos[w]
print @n.xbgr.xm34_u19.nsg13_hv_nmos[l]
print @n.xbgr.xm34_u19.nsg13_hv_nmos[delvto]
print @n.xbgr.xm34_u19.nsg13_hv_nmos[factuo]
print @n.xbgr.xm34_u20.nsg13_hv_nmos[w]
print @n.xbgr.xm34_u20.nsg13_hv_nmos[l]
print @n.xbgr.xm34_u20.nsg13_hv_nmos[delvto]
print @n.xbgr.xm34_u20.nsg13_hv_nmos[factuo]
print @n.xbgr.xm34_u21.nsg13_hv_nmos[w]
print @n.xbgr.xm34_u21.nsg13_hv_nmos[l]
print @n.xbgr.xm34_u21.nsg13_hv_nmos[delvto]
print @n.xbgr.xm34_u21.nsg13_hv_nmos[factuo]
print @n.xbgr.xm34_u22.nsg13_hv_nmos[w]
print @n.xbgr.xm34_u22.nsg13_hv_nmos[l]
print @n.xbgr.xm34_u22.nsg13_hv_nmos[delvto]
print @n.xbgr.xm34_u22.nsg13_hv_nmos[factuo]
print @n.xbgr.xm34_u23.nsg13_hv_nmos[w]
print @n.xbgr.xm34_u23.nsg13_hv_nmos[l]
print @n.xbgr.xm34_u23.nsg13_hv_nmos[delvto]
print @n.xbgr.xm34_u23.nsg13_hv_nmos[factuo]
print @n.xbgr.xm34_u24.nsg13_hv_nmos[w]
print @n.xbgr.xm34_u24.nsg13_hv_nmos[l]
print @n.xbgr.xm34_u24.nsg13_hv_nmos[delvto]
print @n.xbgr.xm34_u24.nsg13_hv_nmos[factuo]
print @n.xbgr.xm35_u2.nsg13_hv_nmos[w]
print @n.xbgr.xm35_u2.nsg13_hv_nmos[l]
print @n.xbgr.xm35_u2.nsg13_hv_nmos[delvto]
print @n.xbgr.xm35_u2.nsg13_hv_nmos[factuo]
print @n.xbgr.xm35_u3.nsg13_hv_nmos[w]
print @n.xbgr.xm35_u3.nsg13_hv_nmos[l]
print @n.xbgr.xm35_u3.nsg13_hv_nmos[delvto]
print @n.xbgr.xm35_u3.nsg13_hv_nmos[factuo]
print @n.xbgr.xm35_u4.nsg13_hv_nmos[w]
print @n.xbgr.xm35_u4.nsg13_hv_nmos[l]
print @n.xbgr.xm35_u4.nsg13_hv_nmos[delvto]
print @n.xbgr.xm35_u4.nsg13_hv_nmos[factuo]
print @n.xbgr.xm35_u5.nsg13_hv_nmos[w]
print @n.xbgr.xm35_u5.nsg13_hv_nmos[l]
print @n.xbgr.xm35_u5.nsg13_hv_nmos[delvto]
print @n.xbgr.xm35_u5.nsg13_hv_nmos[factuo]
print @n.xbgr.xm35_u6.nsg13_hv_nmos[w]
print @n.xbgr.xm35_u6.nsg13_hv_nmos[l]
print @n.xbgr.xm35_u6.nsg13_hv_nmos[delvto]
print @n.xbgr.xm35_u6.nsg13_hv_nmos[factuo]
print @n.xbgr.xm35_u7.nsg13_hv_nmos[w]
print @n.xbgr.xm35_u7.nsg13_hv_nmos[l]
print @n.xbgr.xm35_u7.nsg13_hv_nmos[delvto]
print @n.xbgr.xm35_u7.nsg13_hv_nmos[factuo]
print @n.xbgr.xm35_u8.nsg13_hv_nmos[w]
print @n.xbgr.xm35_u8.nsg13_hv_nmos[l]
print @n.xbgr.xm35_u8.nsg13_hv_nmos[delvto]
print @n.xbgr.xm35_u8.nsg13_hv_nmos[factuo]
print @n.xbgr.xm35_u9.nsg13_hv_nmos[w]
print @n.xbgr.xm35_u9.nsg13_hv_nmos[l]
print @n.xbgr.xm35_u9.nsg13_hv_nmos[delvto]
print @n.xbgr.xm35_u9.nsg13_hv_nmos[factuo]
print @n.xbgr.xm35_u10.nsg13_hv_nmos[w]
print @n.xbgr.xm35_u10.nsg13_hv_nmos[l]
print @n.xbgr.xm35_u10.nsg13_hv_nmos[delvto]
print @n.xbgr.xm35_u10.nsg13_hv_nmos[factuo]
print @n.xbgr.xm35_u11.nsg13_hv_nmos[w]
print @n.xbgr.xm35_u11.nsg13_hv_nmos[l]
print @n.xbgr.xm35_u11.nsg13_hv_nmos[delvto]
print @n.xbgr.xm35_u11.nsg13_hv_nmos[factuo]
print @n.xbgr.xm35_u12.nsg13_hv_nmos[w]
print @n.xbgr.xm35_u12.nsg13_hv_nmos[l]
print @n.xbgr.xm35_u12.nsg13_hv_nmos[delvto]
print @n.xbgr.xm35_u12.nsg13_hv_nmos[factuo]
print @n.xbgr.xm35_u13.nsg13_hv_nmos[w]
print @n.xbgr.xm35_u13.nsg13_hv_nmos[l]
print @n.xbgr.xm35_u13.nsg13_hv_nmos[delvto]
print @n.xbgr.xm35_u13.nsg13_hv_nmos[factuo]
print @n.xbgr.xm35_u14.nsg13_hv_nmos[w]
print @n.xbgr.xm35_u14.nsg13_hv_nmos[l]
print @n.xbgr.xm35_u14.nsg13_hv_nmos[delvto]
print @n.xbgr.xm35_u14.nsg13_hv_nmos[factuo]
print @n.xbgr.xm35_u15.nsg13_hv_nmos[w]
print @n.xbgr.xm35_u15.nsg13_hv_nmos[l]
print @n.xbgr.xm35_u15.nsg13_hv_nmos[delvto]
print @n.xbgr.xm35_u15.nsg13_hv_nmos[factuo]
print @n.xbgr.xm35_u16.nsg13_hv_nmos[w]
print @n.xbgr.xm35_u16.nsg13_hv_nmos[l]
print @n.xbgr.xm35_u16.nsg13_hv_nmos[delvto]
print @n.xbgr.xm35_u16.nsg13_hv_nmos[factuo]
print @n.xbgr.xm35_u17.nsg13_hv_nmos[w]
print @n.xbgr.xm35_u17.nsg13_hv_nmos[l]
print @n.xbgr.xm35_u17.nsg13_hv_nmos[delvto]
print @n.xbgr.xm35_u17.nsg13_hv_nmos[factuo]
print @n.xbgr.xm35_u18.nsg13_hv_nmos[w]
print @n.xbgr.xm35_u18.nsg13_hv_nmos[l]
print @n.xbgr.xm35_u18.nsg13_hv_nmos[delvto]
print @n.xbgr.xm35_u18.nsg13_hv_nmos[factuo]
print @n.xbgr.xm35_u19.nsg13_hv_nmos[w]
print @n.xbgr.xm35_u19.nsg13_hv_nmos[l]
print @n.xbgr.xm35_u19.nsg13_hv_nmos[delvto]
print @n.xbgr.xm35_u19.nsg13_hv_nmos[factuo]
print @n.xbgr.xm35_u20.nsg13_hv_nmos[w]
print @n.xbgr.xm35_u20.nsg13_hv_nmos[l]
print @n.xbgr.xm35_u20.nsg13_hv_nmos[delvto]
print @n.xbgr.xm35_u20.nsg13_hv_nmos[factuo]
print @n.xbgr.xm35_u21.nsg13_hv_nmos[w]
print @n.xbgr.xm35_u21.nsg13_hv_nmos[l]
print @n.xbgr.xm35_u21.nsg13_hv_nmos[delvto]
print @n.xbgr.xm35_u21.nsg13_hv_nmos[factuo]
print @n.xbgr.xm35_u22.nsg13_hv_nmos[w]
print @n.xbgr.xm35_u22.nsg13_hv_nmos[l]
print @n.xbgr.xm35_u22.nsg13_hv_nmos[delvto]
print @n.xbgr.xm35_u22.nsg13_hv_nmos[factuo]
print @n.xbgr.xm35_u23.nsg13_hv_nmos[w]
print @n.xbgr.xm35_u23.nsg13_hv_nmos[l]
print @n.xbgr.xm35_u23.nsg13_hv_nmos[delvto]
print @n.xbgr.xm35_u23.nsg13_hv_nmos[factuo]
print @n.xbgr.xm35_u24.nsg13_hv_nmos[w]
print @n.xbgr.xm35_u24.nsg13_hv_nmos[l]
print @n.xbgr.xm35_u24.nsg13_hv_nmos[delvto]
print @n.xbgr.xm35_u24.nsg13_hv_nmos[factuo]
print @n.xbgr.xm36_u2.nsg13_hv_nmos[w]
print @n.xbgr.xm36_u2.nsg13_hv_nmos[l]
print @n.xbgr.xm36_u2.nsg13_hv_nmos[delvto]
print @n.xbgr.xm36_u2.nsg13_hv_nmos[factuo]
print @n.xbgr.xm36_u3.nsg13_hv_nmos[w]
print @n.xbgr.xm36_u3.nsg13_hv_nmos[l]
print @n.xbgr.xm36_u3.nsg13_hv_nmos[delvto]
print @n.xbgr.xm36_u3.nsg13_hv_nmos[factuo]
print @n.xbgr.xm36_u4.nsg13_hv_nmos[w]
print @n.xbgr.xm36_u4.nsg13_hv_nmos[l]
print @n.xbgr.xm36_u4.nsg13_hv_nmos[delvto]
print @n.xbgr.xm36_u4.nsg13_hv_nmos[factuo]
print @n.xbgr.xm36_u5.nsg13_hv_nmos[w]
print @n.xbgr.xm36_u5.nsg13_hv_nmos[l]
print @n.xbgr.xm36_u5.nsg13_hv_nmos[delvto]
print @n.xbgr.xm36_u5.nsg13_hv_nmos[factuo]
print @n.xbgr.xm36_u6.nsg13_hv_nmos[w]
print @n.xbgr.xm36_u6.nsg13_hv_nmos[l]
print @n.xbgr.xm36_u6.nsg13_hv_nmos[delvto]
print @n.xbgr.xm36_u6.nsg13_hv_nmos[factuo]
print @n.xbgr.xm36_u7.nsg13_hv_nmos[w]
print @n.xbgr.xm36_u7.nsg13_hv_nmos[l]
print @n.xbgr.xm36_u7.nsg13_hv_nmos[delvto]
print @n.xbgr.xm36_u7.nsg13_hv_nmos[factuo]
print @n.xbgr.xm36_u8.nsg13_hv_nmos[w]
print @n.xbgr.xm36_u8.nsg13_hv_nmos[l]
print @n.xbgr.xm36_u8.nsg13_hv_nmos[delvto]
print @n.xbgr.xm36_u8.nsg13_hv_nmos[factuo]
print @n.xbgr.xm36_u9.nsg13_hv_nmos[w]
print @n.xbgr.xm36_u9.nsg13_hv_nmos[l]
print @n.xbgr.xm36_u9.nsg13_hv_nmos[delvto]
print @n.xbgr.xm36_u9.nsg13_hv_nmos[factuo]
print @n.xbgr.xm36_u10.nsg13_hv_nmos[w]
print @n.xbgr.xm36_u10.nsg13_hv_nmos[l]
print @n.xbgr.xm36_u10.nsg13_hv_nmos[delvto]
print @n.xbgr.xm36_u10.nsg13_hv_nmos[factuo]
print @n.xbgr.xm36_u11.nsg13_hv_nmos[w]
print @n.xbgr.xm36_u11.nsg13_hv_nmos[l]
print @n.xbgr.xm36_u11.nsg13_hv_nmos[delvto]
print @n.xbgr.xm36_u11.nsg13_hv_nmos[factuo]
print @n.xbgr.xm36_u12.nsg13_hv_nmos[w]
print @n.xbgr.xm36_u12.nsg13_hv_nmos[l]
print @n.xbgr.xm36_u12.nsg13_hv_nmos[delvto]
print @n.xbgr.xm36_u12.nsg13_hv_nmos[factuo]
print @n.xbgr.xm36_u13.nsg13_hv_nmos[w]
print @n.xbgr.xm36_u13.nsg13_hv_nmos[l]
print @n.xbgr.xm36_u13.nsg13_hv_nmos[delvto]
print @n.xbgr.xm36_u13.nsg13_hv_nmos[factuo]
print @n.xbgr.xm36_u14.nsg13_hv_nmos[w]
print @n.xbgr.xm36_u14.nsg13_hv_nmos[l]
print @n.xbgr.xm36_u14.nsg13_hv_nmos[delvto]
print @n.xbgr.xm36_u14.nsg13_hv_nmos[factuo]
print @n.xbgr.xm36_u15.nsg13_hv_nmos[w]
print @n.xbgr.xm36_u15.nsg13_hv_nmos[l]
print @n.xbgr.xm36_u15.nsg13_hv_nmos[delvto]
print @n.xbgr.xm36_u15.nsg13_hv_nmos[factuo]
print @n.xbgr.xm36_u16.nsg13_hv_nmos[w]
print @n.xbgr.xm36_u16.nsg13_hv_nmos[l]
print @n.xbgr.xm36_u16.nsg13_hv_nmos[delvto]
print @n.xbgr.xm36_u16.nsg13_hv_nmos[factuo]
print @n.xbgr.xm36_u17.nsg13_hv_nmos[w]
print @n.xbgr.xm36_u17.nsg13_hv_nmos[l]
print @n.xbgr.xm36_u17.nsg13_hv_nmos[delvto]
print @n.xbgr.xm36_u17.nsg13_hv_nmos[factuo]
print @n.xbgr.xm36_u18.nsg13_hv_nmos[w]
print @n.xbgr.xm36_u18.nsg13_hv_nmos[l]
print @n.xbgr.xm36_u18.nsg13_hv_nmos[delvto]
print @n.xbgr.xm36_u18.nsg13_hv_nmos[factuo]
print @n.xbgr.xm36_u19.nsg13_hv_nmos[w]
print @n.xbgr.xm36_u19.nsg13_hv_nmos[l]
print @n.xbgr.xm36_u19.nsg13_hv_nmos[delvto]
print @n.xbgr.xm36_u19.nsg13_hv_nmos[factuo]
print @n.xbgr.xm36_u20.nsg13_hv_nmos[w]
print @n.xbgr.xm36_u20.nsg13_hv_nmos[l]
print @n.xbgr.xm36_u20.nsg13_hv_nmos[delvto]
print @n.xbgr.xm36_u20.nsg13_hv_nmos[factuo]
print @n.xbgr.xm36_u21.nsg13_hv_nmos[w]
print @n.xbgr.xm36_u21.nsg13_hv_nmos[l]
print @n.xbgr.xm36_u21.nsg13_hv_nmos[delvto]
print @n.xbgr.xm36_u21.nsg13_hv_nmos[factuo]
print @n.xbgr.xm36_u22.nsg13_hv_nmos[w]
print @n.xbgr.xm36_u22.nsg13_hv_nmos[l]
print @n.xbgr.xm36_u22.nsg13_hv_nmos[delvto]
print @n.xbgr.xm36_u22.nsg13_hv_nmos[factuo]
print @n.xbgr.xm36_u23.nsg13_hv_nmos[w]
print @n.xbgr.xm36_u23.nsg13_hv_nmos[l]
print @n.xbgr.xm36_u23.nsg13_hv_nmos[delvto]
print @n.xbgr.xm36_u23.nsg13_hv_nmos[factuo]
print @n.xbgr.xm36_u24.nsg13_hv_nmos[w]
print @n.xbgr.xm36_u24.nsg13_hv_nmos[l]
print @n.xbgr.xm36_u24.nsg13_hv_nmos[delvto]
print @n.xbgr.xm36_u24.nsg13_hv_nmos[factuo]
print @n.xbgr.xm37_u2.nsg13_hv_nmos[w]
print @n.xbgr.xm37_u2.nsg13_hv_nmos[l]
print @n.xbgr.xm37_u2.nsg13_hv_nmos[delvto]
print @n.xbgr.xm37_u2.nsg13_hv_nmos[factuo]
print @n.xbgr.xm37_u3.nsg13_hv_nmos[w]
print @n.xbgr.xm37_u3.nsg13_hv_nmos[l]
print @n.xbgr.xm37_u3.nsg13_hv_nmos[delvto]
print @n.xbgr.xm37_u3.nsg13_hv_nmos[factuo]
print @n.xbgr.xm37_u4.nsg13_hv_nmos[w]
print @n.xbgr.xm37_u4.nsg13_hv_nmos[l]
print @n.xbgr.xm37_u4.nsg13_hv_nmos[delvto]
print @n.xbgr.xm37_u4.nsg13_hv_nmos[factuo]
print @n.xbgr.xm37_u5.nsg13_hv_nmos[w]
print @n.xbgr.xm37_u5.nsg13_hv_nmos[l]
print @n.xbgr.xm37_u5.nsg13_hv_nmos[delvto]
print @n.xbgr.xm37_u5.nsg13_hv_nmos[factuo]
print @n.xbgr.xm37_u6.nsg13_hv_nmos[w]
print @n.xbgr.xm37_u6.nsg13_hv_nmos[l]
print @n.xbgr.xm37_u6.nsg13_hv_nmos[delvto]
print @n.xbgr.xm37_u6.nsg13_hv_nmos[factuo]
print @n.xbgr.xm37_u7.nsg13_hv_nmos[w]
print @n.xbgr.xm37_u7.nsg13_hv_nmos[l]
print @n.xbgr.xm37_u7.nsg13_hv_nmos[delvto]
print @n.xbgr.xm37_u7.nsg13_hv_nmos[factuo]
print @n.xbgr.xm37_u8.nsg13_hv_nmos[w]
print @n.xbgr.xm37_u8.nsg13_hv_nmos[l]
print @n.xbgr.xm37_u8.nsg13_hv_nmos[delvto]
print @n.xbgr.xm37_u8.nsg13_hv_nmos[factuo]
print @n.xbgr.xm37_u9.nsg13_hv_nmos[w]
print @n.xbgr.xm37_u9.nsg13_hv_nmos[l]
print @n.xbgr.xm37_u9.nsg13_hv_nmos[delvto]
print @n.xbgr.xm37_u9.nsg13_hv_nmos[factuo]
print @n.xbgr.xm37_u10.nsg13_hv_nmos[w]
print @n.xbgr.xm37_u10.nsg13_hv_nmos[l]
print @n.xbgr.xm37_u10.nsg13_hv_nmos[delvto]
print @n.xbgr.xm37_u10.nsg13_hv_nmos[factuo]
print @n.xbgr.xm37_u11.nsg13_hv_nmos[w]
print @n.xbgr.xm37_u11.nsg13_hv_nmos[l]
print @n.xbgr.xm37_u11.nsg13_hv_nmos[delvto]
print @n.xbgr.xm37_u11.nsg13_hv_nmos[factuo]
print @n.xbgr.xm37_u12.nsg13_hv_nmos[w]
print @n.xbgr.xm37_u12.nsg13_hv_nmos[l]
print @n.xbgr.xm37_u12.nsg13_hv_nmos[delvto]
print @n.xbgr.xm37_u12.nsg13_hv_nmos[factuo]
print @n.xbgr.xm37_u13.nsg13_hv_nmos[w]
print @n.xbgr.xm37_u13.nsg13_hv_nmos[l]
print @n.xbgr.xm37_u13.nsg13_hv_nmos[delvto]
print @n.xbgr.xm37_u13.nsg13_hv_nmos[factuo]
print @n.xbgr.xm37_u14.nsg13_hv_nmos[w]
print @n.xbgr.xm37_u14.nsg13_hv_nmos[l]
print @n.xbgr.xm37_u14.nsg13_hv_nmos[delvto]
print @n.xbgr.xm37_u14.nsg13_hv_nmos[factuo]
print @n.xbgr.xm37_u15.nsg13_hv_nmos[w]
print @n.xbgr.xm37_u15.nsg13_hv_nmos[l]
print @n.xbgr.xm37_u15.nsg13_hv_nmos[delvto]
print @n.xbgr.xm37_u15.nsg13_hv_nmos[factuo]
print @n.xbgr.xm37_u16.nsg13_hv_nmos[w]
print @n.xbgr.xm37_u16.nsg13_hv_nmos[l]
print @n.xbgr.xm37_u16.nsg13_hv_nmos[delvto]
print @n.xbgr.xm37_u16.nsg13_hv_nmos[factuo]
print @n.xbgr.xm37_u17.nsg13_hv_nmos[w]
print @n.xbgr.xm37_u17.nsg13_hv_nmos[l]
print @n.xbgr.xm37_u17.nsg13_hv_nmos[delvto]
print @n.xbgr.xm37_u17.nsg13_hv_nmos[factuo]
print @n.xbgr.xm37_u18.nsg13_hv_nmos[w]
print @n.xbgr.xm37_u18.nsg13_hv_nmos[l]
print @n.xbgr.xm37_u18.nsg13_hv_nmos[delvto]
print @n.xbgr.xm37_u18.nsg13_hv_nmos[factuo]
print @n.xbgr.xm37_u19.nsg13_hv_nmos[w]
print @n.xbgr.xm37_u19.nsg13_hv_nmos[l]
print @n.xbgr.xm37_u19.nsg13_hv_nmos[delvto]
print @n.xbgr.xm37_u19.nsg13_hv_nmos[factuo]
print @n.xbgr.xm37_u20.nsg13_hv_nmos[w]
print @n.xbgr.xm37_u20.nsg13_hv_nmos[l]
print @n.xbgr.xm37_u20.nsg13_hv_nmos[delvto]
print @n.xbgr.xm37_u20.nsg13_hv_nmos[factuo]
print @n.xbgr.xm37_u21.nsg13_hv_nmos[w]
print @n.xbgr.xm37_u21.nsg13_hv_nmos[l]
print @n.xbgr.xm37_u21.nsg13_hv_nmos[delvto]
print @n.xbgr.xm37_u21.nsg13_hv_nmos[factuo]
print @n.xbgr.xm37_u22.nsg13_hv_nmos[w]
print @n.xbgr.xm37_u22.nsg13_hv_nmos[l]
print @n.xbgr.xm37_u22.nsg13_hv_nmos[delvto]
print @n.xbgr.xm37_u22.nsg13_hv_nmos[factuo]
print @n.xbgr.xm37_u23.nsg13_hv_nmos[w]
print @n.xbgr.xm37_u23.nsg13_hv_nmos[l]
print @n.xbgr.xm37_u23.nsg13_hv_nmos[delvto]
print @n.xbgr.xm37_u23.nsg13_hv_nmos[factuo]
print @n.xbgr.xm37_u24.nsg13_hv_nmos[w]
print @n.xbgr.xm37_u24.nsg13_hv_nmos[l]
print @n.xbgr.xm37_u24.nsg13_hv_nmos[delvto]
print @n.xbgr.xm37_u24.nsg13_hv_nmos[factuo]
print @n.xbgr.xm38_u2.nsg13_hv_pmos[w]
print @n.xbgr.xm38_u2.nsg13_hv_pmos[l]
print @n.xbgr.xm38_u2.nsg13_hv_pmos[delvto]
print @n.xbgr.xm38_u2.nsg13_hv_pmos[factuo]
print @n.xbgr.xm38_u3.nsg13_hv_pmos[w]
print @n.xbgr.xm38_u3.nsg13_hv_pmos[l]
print @n.xbgr.xm38_u3.nsg13_hv_pmos[delvto]
print @n.xbgr.xm38_u3.nsg13_hv_pmos[factuo]
print @n.xbgr.xm38_u4.nsg13_hv_pmos[w]
print @n.xbgr.xm38_u4.nsg13_hv_pmos[l]
print @n.xbgr.xm38_u4.nsg13_hv_pmos[delvto]
print @n.xbgr.xm38_u4.nsg13_hv_pmos[factuo]
print @n.xbgr.xm38_u5.nsg13_hv_pmos[w]
print @n.xbgr.xm38_u5.nsg13_hv_pmos[l]
print @n.xbgr.xm38_u5.nsg13_hv_pmos[delvto]
print @n.xbgr.xm38_u5.nsg13_hv_pmos[factuo]
print @n.xbgr.xm38_u6.nsg13_hv_pmos[w]
print @n.xbgr.xm38_u6.nsg13_hv_pmos[l]
print @n.xbgr.xm38_u6.nsg13_hv_pmos[delvto]
print @n.xbgr.xm38_u6.nsg13_hv_pmos[factuo]
print @n.xbgr.xm38_u7.nsg13_hv_pmos[w]
print @n.xbgr.xm38_u7.nsg13_hv_pmos[l]
print @n.xbgr.xm38_u7.nsg13_hv_pmos[delvto]
print @n.xbgr.xm38_u7.nsg13_hv_pmos[factuo]
print @n.xbgr.xm38_u8.nsg13_hv_pmos[w]
print @n.xbgr.xm38_u8.nsg13_hv_pmos[l]
print @n.xbgr.xm38_u8.nsg13_hv_pmos[delvto]
print @n.xbgr.xm38_u8.nsg13_hv_pmos[factuo]
print @n.xbgr.xm38_u9.nsg13_hv_pmos[w]
print @n.xbgr.xm38_u9.nsg13_hv_pmos[l]
print @n.xbgr.xm38_u9.nsg13_hv_pmos[delvto]
print @n.xbgr.xm38_u9.nsg13_hv_pmos[factuo]
print @n.xbgr.xm38_u10.nsg13_hv_pmos[w]
print @n.xbgr.xm38_u10.nsg13_hv_pmos[l]
print @n.xbgr.xm38_u10.nsg13_hv_pmos[delvto]
print @n.xbgr.xm38_u10.nsg13_hv_pmos[factuo]
print @n.xbgr.xm38_u11.nsg13_hv_pmos[w]
print @n.xbgr.xm38_u11.nsg13_hv_pmos[l]
print @n.xbgr.xm38_u11.nsg13_hv_pmos[delvto]
print @n.xbgr.xm38_u11.nsg13_hv_pmos[factuo]
print @n.xbgr.xm38_u12.nsg13_hv_pmos[w]
print @n.xbgr.xm38_u12.nsg13_hv_pmos[l]
print @n.xbgr.xm38_u12.nsg13_hv_pmos[delvto]
print @n.xbgr.xm38_u12.nsg13_hv_pmos[factuo]
print @n.xbgr.xm38_u13.nsg13_hv_pmos[w]
print @n.xbgr.xm38_u13.nsg13_hv_pmos[l]
print @n.xbgr.xm38_u13.nsg13_hv_pmos[delvto]
print @n.xbgr.xm38_u13.nsg13_hv_pmos[factuo]
print @n.xbgr.xm38_u14.nsg13_hv_pmos[w]
print @n.xbgr.xm38_u14.nsg13_hv_pmos[l]
print @n.xbgr.xm38_u14.nsg13_hv_pmos[delvto]
print @n.xbgr.xm38_u14.nsg13_hv_pmos[factuo]
print @n.xbgr.xm38_u15.nsg13_hv_pmos[w]
print @n.xbgr.xm38_u15.nsg13_hv_pmos[l]
print @n.xbgr.xm38_u15.nsg13_hv_pmos[delvto]
print @n.xbgr.xm38_u15.nsg13_hv_pmos[factuo]
print @n.xbgr.xm38_u16.nsg13_hv_pmos[w]
print @n.xbgr.xm38_u16.nsg13_hv_pmos[l]
print @n.xbgr.xm38_u16.nsg13_hv_pmos[delvto]
print @n.xbgr.xm38_u16.nsg13_hv_pmos[factuo]
print @n.xbgr.xm38_u17.nsg13_hv_pmos[w]
print @n.xbgr.xm38_u17.nsg13_hv_pmos[l]
print @n.xbgr.xm38_u17.nsg13_hv_pmos[delvto]
print @n.xbgr.xm38_u17.nsg13_hv_pmos[factuo]
print @n.xbgr.xm38_u18.nsg13_hv_pmos[w]
print @n.xbgr.xm38_u18.nsg13_hv_pmos[l]
print @n.xbgr.xm38_u18.nsg13_hv_pmos[delvto]
print @n.xbgr.xm38_u18.nsg13_hv_pmos[factuo]
print @n.xbgr.xm38_u19.nsg13_hv_pmos[w]
print @n.xbgr.xm38_u19.nsg13_hv_pmos[l]
print @n.xbgr.xm38_u19.nsg13_hv_pmos[delvto]
print @n.xbgr.xm38_u19.nsg13_hv_pmos[factuo]
print @n.xbgr.xm38_u20.nsg13_hv_pmos[w]
print @n.xbgr.xm38_u20.nsg13_hv_pmos[l]
print @n.xbgr.xm38_u20.nsg13_hv_pmos[delvto]
print @n.xbgr.xm38_u20.nsg13_hv_pmos[factuo]
print @n.xbgr.xm38_u21.nsg13_hv_pmos[w]
print @n.xbgr.xm38_u21.nsg13_hv_pmos[l]
print @n.xbgr.xm38_u21.nsg13_hv_pmos[delvto]
print @n.xbgr.xm38_u21.nsg13_hv_pmos[factuo]
print @n.xbgr.xm38_u22.nsg13_hv_pmos[w]
print @n.xbgr.xm38_u22.nsg13_hv_pmos[l]
print @n.xbgr.xm38_u22.nsg13_hv_pmos[delvto]
print @n.xbgr.xm38_u22.nsg13_hv_pmos[factuo]
print @n.xbgr.xm38_u23.nsg13_hv_pmos[w]
print @n.xbgr.xm38_u23.nsg13_hv_pmos[l]
print @n.xbgr.xm38_u23.nsg13_hv_pmos[delvto]
print @n.xbgr.xm38_u23.nsg13_hv_pmos[factuo]
print @n.xbgr.xm38_u24.nsg13_hv_pmos[w]
print @n.xbgr.xm38_u24.nsg13_hv_pmos[l]
print @n.xbgr.xm38_u24.nsg13_hv_pmos[delvto]
print @n.xbgr.xm38_u24.nsg13_hv_pmos[factuo]
print @n.xbgr.xm39_u2.nsg13_hv_pmos[w]
print @n.xbgr.xm39_u2.nsg13_hv_pmos[l]
print @n.xbgr.xm39_u2.nsg13_hv_pmos[delvto]
print @n.xbgr.xm39_u2.nsg13_hv_pmos[factuo]
print @n.xbgr.xm39_u3.nsg13_hv_pmos[w]
print @n.xbgr.xm39_u3.nsg13_hv_pmos[l]
print @n.xbgr.xm39_u3.nsg13_hv_pmos[delvto]
print @n.xbgr.xm39_u3.nsg13_hv_pmos[factuo]
print @n.xbgr.xm39_u4.nsg13_hv_pmos[w]
print @n.xbgr.xm39_u4.nsg13_hv_pmos[l]
print @n.xbgr.xm39_u4.nsg13_hv_pmos[delvto]
print @n.xbgr.xm39_u4.nsg13_hv_pmos[factuo]
print @n.xbgr.xm39_u5.nsg13_hv_pmos[w]
print @n.xbgr.xm39_u5.nsg13_hv_pmos[l]
print @n.xbgr.xm39_u5.nsg13_hv_pmos[delvto]
print @n.xbgr.xm39_u5.nsg13_hv_pmos[factuo]
print @n.xbgr.xm39_u6.nsg13_hv_pmos[w]
print @n.xbgr.xm39_u6.nsg13_hv_pmos[l]
print @n.xbgr.xm39_u6.nsg13_hv_pmos[delvto]
print @n.xbgr.xm39_u6.nsg13_hv_pmos[factuo]
print @n.xbgr.xm39_u7.nsg13_hv_pmos[w]
print @n.xbgr.xm39_u7.nsg13_hv_pmos[l]
print @n.xbgr.xm39_u7.nsg13_hv_pmos[delvto]
print @n.xbgr.xm39_u7.nsg13_hv_pmos[factuo]
print @n.xbgr.xm39_u8.nsg13_hv_pmos[w]
print @n.xbgr.xm39_u8.nsg13_hv_pmos[l]
print @n.xbgr.xm39_u8.nsg13_hv_pmos[delvto]
print @n.xbgr.xm39_u8.nsg13_hv_pmos[factuo]
print @n.xbgr.xm39_u9.nsg13_hv_pmos[w]
print @n.xbgr.xm39_u9.nsg13_hv_pmos[l]
print @n.xbgr.xm39_u9.nsg13_hv_pmos[delvto]
print @n.xbgr.xm39_u9.nsg13_hv_pmos[factuo]
print @n.xbgr.xm39_u10.nsg13_hv_pmos[w]
print @n.xbgr.xm39_u10.nsg13_hv_pmos[l]
print @n.xbgr.xm39_u10.nsg13_hv_pmos[delvto]
print @n.xbgr.xm39_u10.nsg13_hv_pmos[factuo]
print @n.xbgr.xm39_u11.nsg13_hv_pmos[w]
print @n.xbgr.xm39_u11.nsg13_hv_pmos[l]
print @n.xbgr.xm39_u11.nsg13_hv_pmos[delvto]
print @n.xbgr.xm39_u11.nsg13_hv_pmos[factuo]
print @n.xbgr.xm39_u12.nsg13_hv_pmos[w]
print @n.xbgr.xm39_u12.nsg13_hv_pmos[l]
print @n.xbgr.xm39_u12.nsg13_hv_pmos[delvto]
print @n.xbgr.xm39_u12.nsg13_hv_pmos[factuo]
print @n.xbgr.xm39_u13.nsg13_hv_pmos[w]
print @n.xbgr.xm39_u13.nsg13_hv_pmos[l]
print @n.xbgr.xm39_u13.nsg13_hv_pmos[delvto]
print @n.xbgr.xm39_u13.nsg13_hv_pmos[factuo]
print @n.xbgr.xm39_u14.nsg13_hv_pmos[w]
print @n.xbgr.xm39_u14.nsg13_hv_pmos[l]
print @n.xbgr.xm39_u14.nsg13_hv_pmos[delvto]
print @n.xbgr.xm39_u14.nsg13_hv_pmos[factuo]
print @n.xbgr.xm39_u15.nsg13_hv_pmos[w]
print @n.xbgr.xm39_u15.nsg13_hv_pmos[l]
print @n.xbgr.xm39_u15.nsg13_hv_pmos[delvto]
print @n.xbgr.xm39_u15.nsg13_hv_pmos[factuo]
print @n.xbgr.xm39_u16.nsg13_hv_pmos[w]
print @n.xbgr.xm39_u16.nsg13_hv_pmos[l]
print @n.xbgr.xm39_u16.nsg13_hv_pmos[delvto]
print @n.xbgr.xm39_u16.nsg13_hv_pmos[factuo]
print @n.xbgr.xm39_u17.nsg13_hv_pmos[w]
print @n.xbgr.xm39_u17.nsg13_hv_pmos[l]
print @n.xbgr.xm39_u17.nsg13_hv_pmos[delvto]
print @n.xbgr.xm39_u17.nsg13_hv_pmos[factuo]
print @n.xbgr.xm39_u18.nsg13_hv_pmos[w]
print @n.xbgr.xm39_u18.nsg13_hv_pmos[l]
print @n.xbgr.xm39_u18.nsg13_hv_pmos[delvto]
print @n.xbgr.xm39_u18.nsg13_hv_pmos[factuo]
print @n.xbgr.xm39_u19.nsg13_hv_pmos[w]
print @n.xbgr.xm39_u19.nsg13_hv_pmos[l]
print @n.xbgr.xm39_u19.nsg13_hv_pmos[delvto]
print @n.xbgr.xm39_u19.nsg13_hv_pmos[factuo]
print @n.xbgr.xm39_u20.nsg13_hv_pmos[w]
print @n.xbgr.xm39_u20.nsg13_hv_pmos[l]
print @n.xbgr.xm39_u20.nsg13_hv_pmos[delvto]
print @n.xbgr.xm39_u20.nsg13_hv_pmos[factuo]
print @n.xbgr.xm39_u21.nsg13_hv_pmos[w]
print @n.xbgr.xm39_u21.nsg13_hv_pmos[l]
print @n.xbgr.xm39_u21.nsg13_hv_pmos[delvto]
print @n.xbgr.xm39_u21.nsg13_hv_pmos[factuo]
print @n.xbgr.xm39_u22.nsg13_hv_pmos[w]
print @n.xbgr.xm39_u22.nsg13_hv_pmos[l]
print @n.xbgr.xm39_u22.nsg13_hv_pmos[delvto]
print @n.xbgr.xm39_u22.nsg13_hv_pmos[factuo]
print @n.xbgr.xm39_u23.nsg13_hv_pmos[w]
print @n.xbgr.xm39_u23.nsg13_hv_pmos[l]
print @n.xbgr.xm39_u23.nsg13_hv_pmos[delvto]
print @n.xbgr.xm39_u23.nsg13_hv_pmos[factuo]
print @n.xbgr.xm39_u24.nsg13_hv_pmos[w]
print @n.xbgr.xm39_u24.nsg13_hv_pmos[l]
print @n.xbgr.xm39_u24.nsg13_hv_pmos[delvto]
print @n.xbgr.xm39_u24.nsg13_hv_pmos[factuo]
print @n.xbgr.xm41_u2.nsg13_hv_pmos[w]
print @n.xbgr.xm41_u2.nsg13_hv_pmos[l]
print @n.xbgr.xm41_u2.nsg13_hv_pmos[delvto]
print @n.xbgr.xm41_u2.nsg13_hv_pmos[factuo]
print @n.xbgr.xm41_u3.nsg13_hv_pmos[w]
print @n.xbgr.xm41_u3.nsg13_hv_pmos[l]
print @n.xbgr.xm41_u3.nsg13_hv_pmos[delvto]
print @n.xbgr.xm41_u3.nsg13_hv_pmos[factuo]
print @n.xbgr.xm41_u4.nsg13_hv_pmos[w]
print @n.xbgr.xm41_u4.nsg13_hv_pmos[l]
print @n.xbgr.xm41_u4.nsg13_hv_pmos[delvto]
print @n.xbgr.xm41_u4.nsg13_hv_pmos[factuo]
print @n.xbgr.xm41_u5.nsg13_hv_pmos[w]
print @n.xbgr.xm41_u5.nsg13_hv_pmos[l]
print @n.xbgr.xm41_u5.nsg13_hv_pmos[delvto]
print @n.xbgr.xm41_u5.nsg13_hv_pmos[factuo]
print @n.xbgr.xm41_u6.nsg13_hv_pmos[w]
print @n.xbgr.xm41_u6.nsg13_hv_pmos[l]
print @n.xbgr.xm41_u6.nsg13_hv_pmos[delvto]
print @n.xbgr.xm41_u6.nsg13_hv_pmos[factuo]
print @n.xbgr.xm41_u7.nsg13_hv_pmos[w]
print @n.xbgr.xm41_u7.nsg13_hv_pmos[l]
print @n.xbgr.xm41_u7.nsg13_hv_pmos[delvto]
print @n.xbgr.xm41_u7.nsg13_hv_pmos[factuo]
print @n.xbgr.xm41_u8.nsg13_hv_pmos[w]
print @n.xbgr.xm41_u8.nsg13_hv_pmos[l]
print @n.xbgr.xm41_u8.nsg13_hv_pmos[delvto]
print @n.xbgr.xm41_u8.nsg13_hv_pmos[factuo]
print @n.xbgr.xm41_u9.nsg13_hv_pmos[w]
print @n.xbgr.xm41_u9.nsg13_hv_pmos[l]
print @n.xbgr.xm41_u9.nsg13_hv_pmos[delvto]
print @n.xbgr.xm41_u9.nsg13_hv_pmos[factuo]
print @n.xbgr.xm41_u10.nsg13_hv_pmos[w]
print @n.xbgr.xm41_u10.nsg13_hv_pmos[l]
print @n.xbgr.xm41_u10.nsg13_hv_pmos[delvto]
print @n.xbgr.xm41_u10.nsg13_hv_pmos[factuo]
print @n.xbgr.xm41_u11.nsg13_hv_pmos[w]
print @n.xbgr.xm41_u11.nsg13_hv_pmos[l]
print @n.xbgr.xm41_u11.nsg13_hv_pmos[delvto]
print @n.xbgr.xm41_u11.nsg13_hv_pmos[factuo]
print @n.xbgr.xm41_u12.nsg13_hv_pmos[w]
print @n.xbgr.xm41_u12.nsg13_hv_pmos[l]
print @n.xbgr.xm41_u12.nsg13_hv_pmos[delvto]
print @n.xbgr.xm41_u12.nsg13_hv_pmos[factuo]
print @n.xbgr.xm41_u13.nsg13_hv_pmos[w]
print @n.xbgr.xm41_u13.nsg13_hv_pmos[l]
print @n.xbgr.xm41_u13.nsg13_hv_pmos[delvto]
print @n.xbgr.xm41_u13.nsg13_hv_pmos[factuo]
print @n.xbgr.xm41_u14.nsg13_hv_pmos[w]
print @n.xbgr.xm41_u14.nsg13_hv_pmos[l]
print @n.xbgr.xm41_u14.nsg13_hv_pmos[delvto]
print @n.xbgr.xm41_u14.nsg13_hv_pmos[factuo]
print @n.xbgr.xm41_u15.nsg13_hv_pmos[w]
print @n.xbgr.xm41_u15.nsg13_hv_pmos[l]
print @n.xbgr.xm41_u15.nsg13_hv_pmos[delvto]
print @n.xbgr.xm41_u15.nsg13_hv_pmos[factuo]
print @n.xbgr.xm41_u16.nsg13_hv_pmos[w]
print @n.xbgr.xm41_u16.nsg13_hv_pmos[l]
print @n.xbgr.xm41_u16.nsg13_hv_pmos[delvto]
print @n.xbgr.xm41_u16.nsg13_hv_pmos[factuo]
print @n.xbgr.xm41_u17.nsg13_hv_pmos[w]
print @n.xbgr.xm41_u17.nsg13_hv_pmos[l]
print @n.xbgr.xm41_u17.nsg13_hv_pmos[delvto]
print @n.xbgr.xm41_u17.nsg13_hv_pmos[factuo]
print @n.xbgr.xm41_u18.nsg13_hv_pmos[w]
print @n.xbgr.xm41_u18.nsg13_hv_pmos[l]
print @n.xbgr.xm41_u18.nsg13_hv_pmos[delvto]
print @n.xbgr.xm41_u18.nsg13_hv_pmos[factuo]
print @n.xbgr.xm41_u19.nsg13_hv_pmos[w]
print @n.xbgr.xm41_u19.nsg13_hv_pmos[l]
print @n.xbgr.xm41_u19.nsg13_hv_pmos[delvto]
print @n.xbgr.xm41_u19.nsg13_hv_pmos[factuo]
print @n.xbgr.xm41_u20.nsg13_hv_pmos[w]
print @n.xbgr.xm41_u20.nsg13_hv_pmos[l]
print @n.xbgr.xm41_u20.nsg13_hv_pmos[delvto]
print @n.xbgr.xm41_u20.nsg13_hv_pmos[factuo]
print @n.xbgr.xm41_u21.nsg13_hv_pmos[w]
print @n.xbgr.xm41_u21.nsg13_hv_pmos[l]
print @n.xbgr.xm41_u21.nsg13_hv_pmos[delvto]
print @n.xbgr.xm41_u21.nsg13_hv_pmos[factuo]
print @n.xbgr.xm41_u22.nsg13_hv_pmos[w]
print @n.xbgr.xm41_u22.nsg13_hv_pmos[l]
print @n.xbgr.xm41_u22.nsg13_hv_pmos[delvto]
print @n.xbgr.xm41_u22.nsg13_hv_pmos[factuo]
print @n.xbgr.xm41_u23.nsg13_hv_pmos[w]
print @n.xbgr.xm41_u23.nsg13_hv_pmos[l]
print @n.xbgr.xm41_u23.nsg13_hv_pmos[delvto]
print @n.xbgr.xm41_u23.nsg13_hv_pmos[factuo]
print @n.xbgr.xm41_u24.nsg13_hv_pmos[w]
print @n.xbgr.xm41_u24.nsg13_hv_pmos[l]
print @n.xbgr.xm41_u24.nsg13_hv_pmos[delvto]
print @n.xbgr.xm41_u24.nsg13_hv_pmos[factuo]
print @n.xbgr.xm43_u2.nsg13_hv_pmos[w]
print @n.xbgr.xm43_u2.nsg13_hv_pmos[l]
print @n.xbgr.xm43_u2.nsg13_hv_pmos[delvto]
print @n.xbgr.xm43_u2.nsg13_hv_pmos[factuo]
print @n.xbgr.xm43_u3.nsg13_hv_pmos[w]
print @n.xbgr.xm43_u3.nsg13_hv_pmos[l]
print @n.xbgr.xm43_u3.nsg13_hv_pmos[delvto]
print @n.xbgr.xm43_u3.nsg13_hv_pmos[factuo]
print @n.xbgr.xm43_u4.nsg13_hv_pmos[w]
print @n.xbgr.xm43_u4.nsg13_hv_pmos[l]
print @n.xbgr.xm43_u4.nsg13_hv_pmos[delvto]
print @n.xbgr.xm43_u4.nsg13_hv_pmos[factuo]
print @n.xbgr.xm44_u2.nsg13_hv_pmos[w]
print @n.xbgr.xm44_u2.nsg13_hv_pmos[l]
print @n.xbgr.xm44_u2.nsg13_hv_pmos[delvto]
print @n.xbgr.xm44_u2.nsg13_hv_pmos[factuo]
print @n.xbgr.xm44_u3.nsg13_hv_pmos[w]
print @n.xbgr.xm44_u3.nsg13_hv_pmos[l]
print @n.xbgr.xm44_u3.nsg13_hv_pmos[delvto]
print @n.xbgr.xm44_u3.nsg13_hv_pmos[factuo]
print @n.xbgr.xm44_u4.nsg13_hv_pmos[w]
print @n.xbgr.xm44_u4.nsg13_hv_pmos[l]
print @n.xbgr.xm44_u4.nsg13_hv_pmos[delvto]
print @n.xbgr.xm44_u4.nsg13_hv_pmos[factuo]
print @n.xbgr.xm45_u2.nsg13_hv_pmos[w]
print @n.xbgr.xm45_u2.nsg13_hv_pmos[l]
print @n.xbgr.xm45_u2.nsg13_hv_pmos[delvto]
print @n.xbgr.xm45_u2.nsg13_hv_pmos[factuo]
print @n.xbgr.xm45_u3.nsg13_hv_pmos[w]
print @n.xbgr.xm45_u3.nsg13_hv_pmos[l]
print @n.xbgr.xm45_u3.nsg13_hv_pmos[delvto]
print @n.xbgr.xm45_u3.nsg13_hv_pmos[factuo]
print @n.xbgr.xm45_u4.nsg13_hv_pmos[w]
print @n.xbgr.xm45_u4.nsg13_hv_pmos[l]
print @n.xbgr.xm45_u4.nsg13_hv_pmos[delvto]
print @n.xbgr.xm45_u4.nsg13_hv_pmos[factuo]
print @n.xbgr.xm45_u5.nsg13_hv_pmos[w]
print @n.xbgr.xm45_u5.nsg13_hv_pmos[l]
print @n.xbgr.xm45_u5.nsg13_hv_pmos[delvto]
print @n.xbgr.xm45_u5.nsg13_hv_pmos[factuo]
print @n.xbgr.xm45_u6.nsg13_hv_pmos[w]
print @n.xbgr.xm45_u6.nsg13_hv_pmos[l]
print @n.xbgr.xm45_u6.nsg13_hv_pmos[delvto]
print @n.xbgr.xm45_u6.nsg13_hv_pmos[factuo]
print @n.xbgr.xm45_u7.nsg13_hv_pmos[w]
print @n.xbgr.xm45_u7.nsg13_hv_pmos[l]
print @n.xbgr.xm45_u7.nsg13_hv_pmos[delvto]
print @n.xbgr.xm45_u7.nsg13_hv_pmos[factuo]
print @n.xbgr.xm45_u8.nsg13_hv_pmos[w]
print @n.xbgr.xm45_u8.nsg13_hv_pmos[l]
print @n.xbgr.xm45_u8.nsg13_hv_pmos[delvto]
print @n.xbgr.xm45_u8.nsg13_hv_pmos[factuo]
print @n.xbgr.xm45_u9.nsg13_hv_pmos[w]
print @n.xbgr.xm45_u9.nsg13_hv_pmos[l]
print @n.xbgr.xm45_u9.nsg13_hv_pmos[delvto]
print @n.xbgr.xm45_u9.nsg13_hv_pmos[factuo]
print @n.xbgr.xm45_u10.nsg13_hv_pmos[w]
print @n.xbgr.xm45_u10.nsg13_hv_pmos[l]
print @n.xbgr.xm45_u10.nsg13_hv_pmos[delvto]
print @n.xbgr.xm45_u10.nsg13_hv_pmos[factuo]
print @n.xbgr.xm45_u11.nsg13_hv_pmos[w]
print @n.xbgr.xm45_u11.nsg13_hv_pmos[l]
print @n.xbgr.xm45_u11.nsg13_hv_pmos[delvto]
print @n.xbgr.xm45_u11.nsg13_hv_pmos[factuo]
print @n.xbgr.xm45_u12.nsg13_hv_pmos[w]
print @n.xbgr.xm45_u12.nsg13_hv_pmos[l]
print @n.xbgr.xm45_u12.nsg13_hv_pmos[delvto]
print @n.xbgr.xm45_u12.nsg13_hv_pmos[factuo]
print @n.xbgr.xm45_u13.nsg13_hv_pmos[w]
print @n.xbgr.xm45_u13.nsg13_hv_pmos[l]
print @n.xbgr.xm45_u13.nsg13_hv_pmos[delvto]
print @n.xbgr.xm45_u13.nsg13_hv_pmos[factuo]
print @n.xbgr.xm45_u14.nsg13_hv_pmos[w]
print @n.xbgr.xm45_u14.nsg13_hv_pmos[l]
print @n.xbgr.xm45_u14.nsg13_hv_pmos[delvto]
print @n.xbgr.xm45_u14.nsg13_hv_pmos[factuo]
print @n.xbgr.xm45_u15.nsg13_hv_pmos[w]
print @n.xbgr.xm45_u15.nsg13_hv_pmos[l]
print @n.xbgr.xm45_u15.nsg13_hv_pmos[delvto]
print @n.xbgr.xm45_u15.nsg13_hv_pmos[factuo]
print @n.xbgr.xm45_u16.nsg13_hv_pmos[w]
print @n.xbgr.xm45_u16.nsg13_hv_pmos[l]
print @n.xbgr.xm45_u16.nsg13_hv_pmos[delvto]
print @n.xbgr.xm45_u16.nsg13_hv_pmos[factuo]
print @n.xbgr.xm45_u17.nsg13_hv_pmos[w]
print @n.xbgr.xm45_u17.nsg13_hv_pmos[l]
print @n.xbgr.xm45_u17.nsg13_hv_pmos[delvto]
print @n.xbgr.xm45_u17.nsg13_hv_pmos[factuo]
print @n.xbgr.xm45_u18.nsg13_hv_pmos[w]
print @n.xbgr.xm45_u18.nsg13_hv_pmos[l]
print @n.xbgr.xm45_u18.nsg13_hv_pmos[delvto]
print @n.xbgr.xm45_u18.nsg13_hv_pmos[factuo]
print @n.xbgr.xm45_u19.nsg13_hv_pmos[w]
print @n.xbgr.xm45_u19.nsg13_hv_pmos[l]
print @n.xbgr.xm45_u19.nsg13_hv_pmos[delvto]
print @n.xbgr.xm45_u19.nsg13_hv_pmos[factuo]
print @n.xbgr.xm45_u20.nsg13_hv_pmos[w]
print @n.xbgr.xm45_u20.nsg13_hv_pmos[l]
print @n.xbgr.xm45_u20.nsg13_hv_pmos[delvto]
print @n.xbgr.xm45_u20.nsg13_hv_pmos[factuo]
print @n.xbgr.xm45_u21.nsg13_hv_pmos[w]
print @n.xbgr.xm45_u21.nsg13_hv_pmos[l]
print @n.xbgr.xm45_u21.nsg13_hv_pmos[delvto]
print @n.xbgr.xm45_u21.nsg13_hv_pmos[factuo]
print @n.xbgr.xm45_u22.nsg13_hv_pmos[w]
print @n.xbgr.xm45_u22.nsg13_hv_pmos[l]
print @n.xbgr.xm45_u22.nsg13_hv_pmos[delvto]
print @n.xbgr.xm45_u22.nsg13_hv_pmos[factuo]
print @n.xbgr.xm45_u23.nsg13_hv_pmos[w]
print @n.xbgr.xm45_u23.nsg13_hv_pmos[l]
print @n.xbgr.xm45_u23.nsg13_hv_pmos[delvto]
print @n.xbgr.xm45_u23.nsg13_hv_pmos[factuo]
print @n.xbgr.xm45_u24.nsg13_hv_pmos[w]
print @n.xbgr.xm45_u24.nsg13_hv_pmos[l]
print @n.xbgr.xm45_u24.nsg13_hv_pmos[delvto]
print @n.xbgr.xm45_u24.nsg13_hv_pmos[factuo]
print @n.xbgr.xm47_u2.nsg13_hv_pmos[w]
print @n.xbgr.xm47_u2.nsg13_hv_pmos[l]
print @n.xbgr.xm47_u2.nsg13_hv_pmos[delvto]
print @n.xbgr.xm47_u2.nsg13_hv_pmos[factuo]
print @n.xbgr.xm47_u3.nsg13_hv_pmos[w]
print @n.xbgr.xm47_u3.nsg13_hv_pmos[l]
print @n.xbgr.xm47_u3.nsg13_hv_pmos[delvto]
print @n.xbgr.xm47_u3.nsg13_hv_pmos[factuo]
print @n.xbgr.xm47_u4.nsg13_hv_pmos[w]
print @n.xbgr.xm47_u4.nsg13_hv_pmos[l]
print @n.xbgr.xm47_u4.nsg13_hv_pmos[delvto]
print @n.xbgr.xm47_u4.nsg13_hv_pmos[factuo]
print @n.xbgr.xm47_u5.nsg13_hv_pmos[w]
print @n.xbgr.xm47_u5.nsg13_hv_pmos[l]
print @n.xbgr.xm47_u5.nsg13_hv_pmos[delvto]
print @n.xbgr.xm47_u5.nsg13_hv_pmos[factuo]
print @n.xbgr.xm47_u6.nsg13_hv_pmos[w]
print @n.xbgr.xm47_u6.nsg13_hv_pmos[l]
print @n.xbgr.xm47_u6.nsg13_hv_pmos[delvto]
print @n.xbgr.xm47_u6.nsg13_hv_pmos[factuo]
print @n.xbgr.xm47_u7.nsg13_hv_pmos[w]
print @n.xbgr.xm47_u7.nsg13_hv_pmos[l]
print @n.xbgr.xm47_u7.nsg13_hv_pmos[delvto]
print @n.xbgr.xm47_u7.nsg13_hv_pmos[factuo]
print @n.xbgr.xm47_u8.nsg13_hv_pmos[w]
print @n.xbgr.xm47_u8.nsg13_hv_pmos[l]
print @n.xbgr.xm47_u8.nsg13_hv_pmos[delvto]
print @n.xbgr.xm47_u8.nsg13_hv_pmos[factuo]
print @n.xbgr.xm47_u9.nsg13_hv_pmos[w]
print @n.xbgr.xm47_u9.nsg13_hv_pmos[l]
print @n.xbgr.xm47_u9.nsg13_hv_pmos[delvto]
print @n.xbgr.xm47_u9.nsg13_hv_pmos[factuo]
print @n.xbgr.xm47_u10.nsg13_hv_pmos[w]
print @n.xbgr.xm47_u10.nsg13_hv_pmos[l]
print @n.xbgr.xm47_u10.nsg13_hv_pmos[delvto]
print @n.xbgr.xm47_u10.nsg13_hv_pmos[factuo]
print @n.xbgr.xm47_u11.nsg13_hv_pmos[w]
print @n.xbgr.xm47_u11.nsg13_hv_pmos[l]
print @n.xbgr.xm47_u11.nsg13_hv_pmos[delvto]
print @n.xbgr.xm47_u11.nsg13_hv_pmos[factuo]
print @n.xbgr.xm47_u12.nsg13_hv_pmos[w]
print @n.xbgr.xm47_u12.nsg13_hv_pmos[l]
print @n.xbgr.xm47_u12.nsg13_hv_pmos[delvto]
print @n.xbgr.xm47_u12.nsg13_hv_pmos[factuo]
print @n.xbgr.xm47_u13.nsg13_hv_pmos[w]
print @n.xbgr.xm47_u13.nsg13_hv_pmos[l]
print @n.xbgr.xm47_u13.nsg13_hv_pmos[delvto]
print @n.xbgr.xm47_u13.nsg13_hv_pmos[factuo]
print @n.xbgr.xm47_u14.nsg13_hv_pmos[w]
print @n.xbgr.xm47_u14.nsg13_hv_pmos[l]
print @n.xbgr.xm47_u14.nsg13_hv_pmos[delvto]
print @n.xbgr.xm47_u14.nsg13_hv_pmos[factuo]
print @n.xbgr.xm47_u15.nsg13_hv_pmos[w]
print @n.xbgr.xm47_u15.nsg13_hv_pmos[l]
print @n.xbgr.xm47_u15.nsg13_hv_pmos[delvto]
print @n.xbgr.xm47_u15.nsg13_hv_pmos[factuo]
print @n.xbgr.xm47_u16.nsg13_hv_pmos[w]
print @n.xbgr.xm47_u16.nsg13_hv_pmos[l]
print @n.xbgr.xm47_u16.nsg13_hv_pmos[delvto]
print @n.xbgr.xm47_u16.nsg13_hv_pmos[factuo]
print @n.xbgr.xm47_u17.nsg13_hv_pmos[w]
print @n.xbgr.xm47_u17.nsg13_hv_pmos[l]
print @n.xbgr.xm47_u17.nsg13_hv_pmos[delvto]
print @n.xbgr.xm47_u17.nsg13_hv_pmos[factuo]
print @n.xbgr.xm47_u18.nsg13_hv_pmos[w]
print @n.xbgr.xm47_u18.nsg13_hv_pmos[l]
print @n.xbgr.xm47_u18.nsg13_hv_pmos[delvto]
print @n.xbgr.xm47_u18.nsg13_hv_pmos[factuo]
print @n.xbgr.xm47_u19.nsg13_hv_pmos[w]
print @n.xbgr.xm47_u19.nsg13_hv_pmos[l]
print @n.xbgr.xm47_u19.nsg13_hv_pmos[delvto]
print @n.xbgr.xm47_u19.nsg13_hv_pmos[factuo]
print @n.xbgr.xm47_u20.nsg13_hv_pmos[w]
print @n.xbgr.xm47_u20.nsg13_hv_pmos[l]
print @n.xbgr.xm47_u20.nsg13_hv_pmos[delvto]
print @n.xbgr.xm47_u20.nsg13_hv_pmos[factuo]
print @n.xbgr.xm47_u21.nsg13_hv_pmos[w]
print @n.xbgr.xm47_u21.nsg13_hv_pmos[l]
print @n.xbgr.xm47_u21.nsg13_hv_pmos[delvto]
print @n.xbgr.xm47_u21.nsg13_hv_pmos[factuo]
print @n.xbgr.xm47_u22.nsg13_hv_pmos[w]
print @n.xbgr.xm47_u22.nsg13_hv_pmos[l]
print @n.xbgr.xm47_u22.nsg13_hv_pmos[delvto]
print @n.xbgr.xm47_u22.nsg13_hv_pmos[factuo]
print @n.xbgr.xm47_u23.nsg13_hv_pmos[w]
print @n.xbgr.xm47_u23.nsg13_hv_pmos[l]
print @n.xbgr.xm47_u23.nsg13_hv_pmos[delvto]
print @n.xbgr.xm47_u23.nsg13_hv_pmos[factuo]
print @n.xbgr.xm47_u24.nsg13_hv_pmos[w]
print @n.xbgr.xm47_u24.nsg13_hv_pmos[l]
print @n.xbgr.xm47_u24.nsg13_hv_pmos[delvto]
print @n.xbgr.xm47_u24.nsg13_hv_pmos[factuo]
print @n.xbgr.xm48_u2.nsg13_hv_pmos[w]
print @n.xbgr.xm48_u2.nsg13_hv_pmos[l]
print @n.xbgr.xm48_u2.nsg13_hv_pmos[delvto]
print @n.xbgr.xm48_u2.nsg13_hv_pmos[factuo]
print @n.xbgr.xm48_u3.nsg13_hv_pmos[w]
print @n.xbgr.xm48_u3.nsg13_hv_pmos[l]
print @n.xbgr.xm48_u3.nsg13_hv_pmos[delvto]
print @n.xbgr.xm48_u3.nsg13_hv_pmos[factuo]
print @n.xbgr.xm48_u4.nsg13_hv_pmos[w]
print @n.xbgr.xm48_u4.nsg13_hv_pmos[l]
print @n.xbgr.xm48_u4.nsg13_hv_pmos[delvto]
print @n.xbgr.xm48_u4.nsg13_hv_pmos[factuo]
print @n.xbgr.xm48_u5.nsg13_hv_pmos[w]
print @n.xbgr.xm48_u5.nsg13_hv_pmos[l]
print @n.xbgr.xm48_u5.nsg13_hv_pmos[delvto]
print @n.xbgr.xm48_u5.nsg13_hv_pmos[factuo]
print @n.xbgr.xm48_u6.nsg13_hv_pmos[w]
print @n.xbgr.xm48_u6.nsg13_hv_pmos[l]
print @n.xbgr.xm48_u6.nsg13_hv_pmos[delvto]
print @n.xbgr.xm48_u6.nsg13_hv_pmos[factuo]
print @n.xbgr.xm48_u7.nsg13_hv_pmos[w]
print @n.xbgr.xm48_u7.nsg13_hv_pmos[l]
print @n.xbgr.xm48_u7.nsg13_hv_pmos[delvto]
print @n.xbgr.xm48_u7.nsg13_hv_pmos[factuo]
print @n.xbgr.xm48_u8.nsg13_hv_pmos[w]
print @n.xbgr.xm48_u8.nsg13_hv_pmos[l]
print @n.xbgr.xm48_u8.nsg13_hv_pmos[delvto]
print @n.xbgr.xm48_u8.nsg13_hv_pmos[factuo]
print @n.xbgr.xm48_u9.nsg13_hv_pmos[w]
print @n.xbgr.xm48_u9.nsg13_hv_pmos[l]
print @n.xbgr.xm48_u9.nsg13_hv_pmos[delvto]
print @n.xbgr.xm48_u9.nsg13_hv_pmos[factuo]
print @n.xbgr.xm48_u10.nsg13_hv_pmos[w]
print @n.xbgr.xm48_u10.nsg13_hv_pmos[l]
print @n.xbgr.xm48_u10.nsg13_hv_pmos[delvto]
print @n.xbgr.xm48_u10.nsg13_hv_pmos[factuo]
print @n.xbgr.xm48_u11.nsg13_hv_pmos[w]
print @n.xbgr.xm48_u11.nsg13_hv_pmos[l]
print @n.xbgr.xm48_u11.nsg13_hv_pmos[delvto]
print @n.xbgr.xm48_u11.nsg13_hv_pmos[factuo]
print @n.xbgr.xm48_u12.nsg13_hv_pmos[w]
print @n.xbgr.xm48_u12.nsg13_hv_pmos[l]
print @n.xbgr.xm48_u12.nsg13_hv_pmos[delvto]
print @n.xbgr.xm48_u12.nsg13_hv_pmos[factuo]
print @n.xbgr.xm48_u13.nsg13_hv_pmos[w]
print @n.xbgr.xm48_u13.nsg13_hv_pmos[l]
print @n.xbgr.xm48_u13.nsg13_hv_pmos[delvto]
print @n.xbgr.xm48_u13.nsg13_hv_pmos[factuo]
print @n.xbgr.xm48_u14.nsg13_hv_pmos[w]
print @n.xbgr.xm48_u14.nsg13_hv_pmos[l]
print @n.xbgr.xm48_u14.nsg13_hv_pmos[delvto]
print @n.xbgr.xm48_u14.nsg13_hv_pmos[factuo]
print @n.xbgr.xm48_u15.nsg13_hv_pmos[w]
print @n.xbgr.xm48_u15.nsg13_hv_pmos[l]
print @n.xbgr.xm48_u15.nsg13_hv_pmos[delvto]
print @n.xbgr.xm48_u15.nsg13_hv_pmos[factuo]
print @n.xbgr.xm48_u16.nsg13_hv_pmos[w]
print @n.xbgr.xm48_u16.nsg13_hv_pmos[l]
print @n.xbgr.xm48_u16.nsg13_hv_pmos[delvto]
print @n.xbgr.xm48_u16.nsg13_hv_pmos[factuo]
print @n.xbgr.xm48_u17.nsg13_hv_pmos[w]
print @n.xbgr.xm48_u17.nsg13_hv_pmos[l]
print @n.xbgr.xm48_u17.nsg13_hv_pmos[delvto]
print @n.xbgr.xm48_u17.nsg13_hv_pmos[factuo]
print @n.xbgr.xm48_u18.nsg13_hv_pmos[w]
print @n.xbgr.xm48_u18.nsg13_hv_pmos[l]
print @n.xbgr.xm48_u18.nsg13_hv_pmos[delvto]
print @n.xbgr.xm48_u18.nsg13_hv_pmos[factuo]
print @n.xbgr.xm48_u19.nsg13_hv_pmos[w]
print @n.xbgr.xm48_u19.nsg13_hv_pmos[l]
print @n.xbgr.xm48_u19.nsg13_hv_pmos[delvto]
print @n.xbgr.xm48_u19.nsg13_hv_pmos[factuo]
print @n.xbgr.xm48_u20.nsg13_hv_pmos[w]
print @n.xbgr.xm48_u20.nsg13_hv_pmos[l]
print @n.xbgr.xm48_u20.nsg13_hv_pmos[delvto]
print @n.xbgr.xm48_u20.nsg13_hv_pmos[factuo]
print @n.xbgr.xm48_u21.nsg13_hv_pmos[w]
print @n.xbgr.xm48_u21.nsg13_hv_pmos[l]
print @n.xbgr.xm48_u21.nsg13_hv_pmos[delvto]
print @n.xbgr.xm48_u21.nsg13_hv_pmos[factuo]
print @n.xbgr.xm48_u22.nsg13_hv_pmos[w]
print @n.xbgr.xm48_u22.nsg13_hv_pmos[l]
print @n.xbgr.xm48_u22.nsg13_hv_pmos[delvto]
print @n.xbgr.xm48_u22.nsg13_hv_pmos[factuo]
print @n.xbgr.xm48_u23.nsg13_hv_pmos[w]
print @n.xbgr.xm48_u23.nsg13_hv_pmos[l]
print @n.xbgr.xm48_u23.nsg13_hv_pmos[delvto]
print @n.xbgr.xm48_u23.nsg13_hv_pmos[factuo]
print @n.xbgr.xm48_u24.nsg13_hv_pmos[w]
print @n.xbgr.xm48_u24.nsg13_hv_pmos[l]
print @n.xbgr.xm48_u24.nsg13_hv_pmos[delvto]
print @n.xbgr.xm48_u24.nsg13_hv_pmos[factuo]
print @n.xbgr.xm50_u2.nsg13_hv_pmos[w]
print @n.xbgr.xm50_u2.nsg13_hv_pmos[l]
print @n.xbgr.xm50_u2.nsg13_hv_pmos[delvto]
print @n.xbgr.xm50_u2.nsg13_hv_pmos[factuo]
print @n.xbgr.xm50_u3.nsg13_hv_pmos[w]
print @n.xbgr.xm50_u3.nsg13_hv_pmos[l]
print @n.xbgr.xm50_u3.nsg13_hv_pmos[delvto]
print @n.xbgr.xm50_u3.nsg13_hv_pmos[factuo]
print @n.xbgr.xm50_u4.nsg13_hv_pmos[w]
print @n.xbgr.xm50_u4.nsg13_hv_pmos[l]
print @n.xbgr.xm50_u4.nsg13_hv_pmos[delvto]
print @n.xbgr.xm50_u4.nsg13_hv_pmos[factuo]
print @n.xbgr.xm50_u5.nsg13_hv_pmos[w]
print @n.xbgr.xm50_u5.nsg13_hv_pmos[l]
print @n.xbgr.xm50_u5.nsg13_hv_pmos[delvto]
print @n.xbgr.xm50_u5.nsg13_hv_pmos[factuo]
print @n.xbgr.xm50_u6.nsg13_hv_pmos[w]
print @n.xbgr.xm50_u6.nsg13_hv_pmos[l]
print @n.xbgr.xm50_u6.nsg13_hv_pmos[delvto]
print @n.xbgr.xm50_u6.nsg13_hv_pmos[factuo]
print @n.xbgr.xm50_u7.nsg13_hv_pmos[w]
print @n.xbgr.xm50_u7.nsg13_hv_pmos[l]
print @n.xbgr.xm50_u7.nsg13_hv_pmos[delvto]
print @n.xbgr.xm50_u7.nsg13_hv_pmos[factuo]
print @n.xbgr.xm50_u8.nsg13_hv_pmos[w]
print @n.xbgr.xm50_u8.nsg13_hv_pmos[l]
print @n.xbgr.xm50_u8.nsg13_hv_pmos[delvto]
print @n.xbgr.xm50_u8.nsg13_hv_pmos[factuo]
print @n.xbgr.xm50_u9.nsg13_hv_pmos[w]
print @n.xbgr.xm50_u9.nsg13_hv_pmos[l]
print @n.xbgr.xm50_u9.nsg13_hv_pmos[delvto]
print @n.xbgr.xm50_u9.nsg13_hv_pmos[factuo]
print @n.xbgr.xm50_u10.nsg13_hv_pmos[w]
print @n.xbgr.xm50_u10.nsg13_hv_pmos[l]
print @n.xbgr.xm50_u10.nsg13_hv_pmos[delvto]
print @n.xbgr.xm50_u10.nsg13_hv_pmos[factuo]
print @n.xbgr.xm50_u11.nsg13_hv_pmos[w]
print @n.xbgr.xm50_u11.nsg13_hv_pmos[l]
print @n.xbgr.xm50_u11.nsg13_hv_pmos[delvto]
print @n.xbgr.xm50_u11.nsg13_hv_pmos[factuo]
print @n.xbgr.xm50_u12.nsg13_hv_pmos[w]
print @n.xbgr.xm50_u12.nsg13_hv_pmos[l]
print @n.xbgr.xm50_u12.nsg13_hv_pmos[delvto]
print @n.xbgr.xm50_u12.nsg13_hv_pmos[factuo]
print @n.xbgr.xm50_u13.nsg13_hv_pmos[w]
print @n.xbgr.xm50_u13.nsg13_hv_pmos[l]
print @n.xbgr.xm50_u13.nsg13_hv_pmos[delvto]
print @n.xbgr.xm50_u13.nsg13_hv_pmos[factuo]
print @n.xbgr.xm50_u14.nsg13_hv_pmos[w]
print @n.xbgr.xm50_u14.nsg13_hv_pmos[l]
print @n.xbgr.xm50_u14.nsg13_hv_pmos[delvto]
print @n.xbgr.xm50_u14.nsg13_hv_pmos[factuo]
print @n.xbgr.xm50_u15.nsg13_hv_pmos[w]
print @n.xbgr.xm50_u15.nsg13_hv_pmos[l]
print @n.xbgr.xm50_u15.nsg13_hv_pmos[delvto]
print @n.xbgr.xm50_u15.nsg13_hv_pmos[factuo]
print @n.xbgr.xm50_u16.nsg13_hv_pmos[w]
print @n.xbgr.xm50_u16.nsg13_hv_pmos[l]
print @n.xbgr.xm50_u16.nsg13_hv_pmos[delvto]
print @n.xbgr.xm50_u16.nsg13_hv_pmos[factuo]
print @n.xbgr.xm50_u17.nsg13_hv_pmos[w]
print @n.xbgr.xm50_u17.nsg13_hv_pmos[l]
print @n.xbgr.xm50_u17.nsg13_hv_pmos[delvto]
print @n.xbgr.xm50_u17.nsg13_hv_pmos[factuo]
print @n.xbgr.xm50_u18.nsg13_hv_pmos[w]
print @n.xbgr.xm50_u18.nsg13_hv_pmos[l]
print @n.xbgr.xm50_u18.nsg13_hv_pmos[delvto]
print @n.xbgr.xm50_u18.nsg13_hv_pmos[factuo]
print @n.xbgr.xm50_u19.nsg13_hv_pmos[w]
print @n.xbgr.xm50_u19.nsg13_hv_pmos[l]
print @n.xbgr.xm50_u19.nsg13_hv_pmos[delvto]
print @n.xbgr.xm50_u19.nsg13_hv_pmos[factuo]
print @n.xbgr.xm50_u20.nsg13_hv_pmos[w]
print @n.xbgr.xm50_u20.nsg13_hv_pmos[l]
print @n.xbgr.xm50_u20.nsg13_hv_pmos[delvto]
print @n.xbgr.xm50_u20.nsg13_hv_pmos[factuo]
print @n.xbgr.xm50_u21.nsg13_hv_pmos[w]
print @n.xbgr.xm50_u21.nsg13_hv_pmos[l]
print @n.xbgr.xm50_u21.nsg13_hv_pmos[delvto]
print @n.xbgr.xm50_u21.nsg13_hv_pmos[factuo]
print @n.xbgr.xm50_u22.nsg13_hv_pmos[w]
print @n.xbgr.xm50_u22.nsg13_hv_pmos[l]
print @n.xbgr.xm50_u22.nsg13_hv_pmos[delvto]
print @n.xbgr.xm50_u22.nsg13_hv_pmos[factuo]
print @n.xbgr.xm50_u23.nsg13_hv_pmos[w]
print @n.xbgr.xm50_u23.nsg13_hv_pmos[l]
print @n.xbgr.xm50_u23.nsg13_hv_pmos[delvto]
print @n.xbgr.xm50_u23.nsg13_hv_pmos[factuo]
print @n.xbgr.xm50_u24.nsg13_hv_pmos[w]
print @n.xbgr.xm50_u24.nsg13_hv_pmos[l]
print @n.xbgr.xm50_u24.nsg13_hv_pmos[delvto]
print @n.xbgr.xm50_u24.nsg13_hv_pmos[factuo]
print @n.xbgr.xm51_u2.nsg13_hv_pmos[w]
print @n.xbgr.xm51_u2.nsg13_hv_pmos[l]
print @n.xbgr.xm51_u2.nsg13_hv_pmos[delvto]
print @n.xbgr.xm51_u2.nsg13_hv_pmos[factuo]
print @n.xbgr.xm51_u3.nsg13_hv_pmos[w]
print @n.xbgr.xm51_u3.nsg13_hv_pmos[l]
print @n.xbgr.xm51_u3.nsg13_hv_pmos[delvto]
print @n.xbgr.xm51_u3.nsg13_hv_pmos[factuo]
print @n.xbgr.xm51_u4.nsg13_hv_pmos[w]
print @n.xbgr.xm51_u4.nsg13_hv_pmos[l]
print @n.xbgr.xm51_u4.nsg13_hv_pmos[delvto]
print @n.xbgr.xm51_u4.nsg13_hv_pmos[factuo]
print @n.xbgr.xm52_u2.nsg13_hv_pmos[w]
print @n.xbgr.xm52_u2.nsg13_hv_pmos[l]
print @n.xbgr.xm52_u2.nsg13_hv_pmos[delvto]
print @n.xbgr.xm52_u2.nsg13_hv_pmos[factuo]
print @n.xbgr.xm52_u3.nsg13_hv_pmos[w]
print @n.xbgr.xm52_u3.nsg13_hv_pmos[l]
print @n.xbgr.xm52_u3.nsg13_hv_pmos[delvto]
print @n.xbgr.xm52_u3.nsg13_hv_pmos[factuo]
print @n.xbgr.xm52_u4.nsg13_hv_pmos[w]
print @n.xbgr.xm52_u4.nsg13_hv_pmos[l]
print @n.xbgr.xm52_u4.nsg13_hv_pmos[delvto]
print @n.xbgr.xm52_u4.nsg13_hv_pmos[factuo]
print @n.xbgr.xm52_u5.nsg13_hv_pmos[w]
print @n.xbgr.xm52_u5.nsg13_hv_pmos[l]
print @n.xbgr.xm52_u5.nsg13_hv_pmos[delvto]
print @n.xbgr.xm52_u5.nsg13_hv_pmos[factuo]
print @n.xbgr.xm52_u6.nsg13_hv_pmos[w]
print @n.xbgr.xm52_u6.nsg13_hv_pmos[l]
print @n.xbgr.xm52_u6.nsg13_hv_pmos[delvto]
print @n.xbgr.xm52_u6.nsg13_hv_pmos[factuo]
print @n.xbgr.xm52_u7.nsg13_hv_pmos[w]
print @n.xbgr.xm52_u7.nsg13_hv_pmos[l]
print @n.xbgr.xm52_u7.nsg13_hv_pmos[delvto]
print @n.xbgr.xm52_u7.nsg13_hv_pmos[factuo]
print @n.xbgr.xm52_u8.nsg13_hv_pmos[w]
print @n.xbgr.xm52_u8.nsg13_hv_pmos[l]
print @n.xbgr.xm52_u8.nsg13_hv_pmos[delvto]
print @n.xbgr.xm52_u8.nsg13_hv_pmos[factuo]
print @n.xbgr.xm52_u9.nsg13_hv_pmos[w]
print @n.xbgr.xm52_u9.nsg13_hv_pmos[l]
print @n.xbgr.xm52_u9.nsg13_hv_pmos[delvto]
print @n.xbgr.xm52_u9.nsg13_hv_pmos[factuo]
print @n.xbgr.xm52_u10.nsg13_hv_pmos[w]
print @n.xbgr.xm52_u10.nsg13_hv_pmos[l]
print @n.xbgr.xm52_u10.nsg13_hv_pmos[delvto]
print @n.xbgr.xm52_u10.nsg13_hv_pmos[factuo]
print @n.xbgr.xm52_u11.nsg13_hv_pmos[w]
print @n.xbgr.xm52_u11.nsg13_hv_pmos[l]
print @n.xbgr.xm52_u11.nsg13_hv_pmos[delvto]
print @n.xbgr.xm52_u11.nsg13_hv_pmos[factuo]
print @n.xbgr.xm52_u12.nsg13_hv_pmos[w]
print @n.xbgr.xm52_u12.nsg13_hv_pmos[l]
print @n.xbgr.xm52_u12.nsg13_hv_pmos[delvto]
print @n.xbgr.xm52_u12.nsg13_hv_pmos[factuo]
print @n.xbgr.xm52_u13.nsg13_hv_pmos[w]
print @n.xbgr.xm52_u13.nsg13_hv_pmos[l]
print @n.xbgr.xm52_u13.nsg13_hv_pmos[delvto]
print @n.xbgr.xm52_u13.nsg13_hv_pmos[factuo]
print @n.xbgr.xm52_u14.nsg13_hv_pmos[w]
print @n.xbgr.xm52_u14.nsg13_hv_pmos[l]
print @n.xbgr.xm52_u14.nsg13_hv_pmos[delvto]
print @n.xbgr.xm52_u14.nsg13_hv_pmos[factuo]
print @n.xbgr.xm52_u15.nsg13_hv_pmos[w]
print @n.xbgr.xm52_u15.nsg13_hv_pmos[l]
print @n.xbgr.xm52_u15.nsg13_hv_pmos[delvto]
print @n.xbgr.xm52_u15.nsg13_hv_pmos[factuo]
print @n.xbgr.xm52_u16.nsg13_hv_pmos[w]
print @n.xbgr.xm52_u16.nsg13_hv_pmos[l]
print @n.xbgr.xm52_u16.nsg13_hv_pmos[delvto]
print @n.xbgr.xm52_u16.nsg13_hv_pmos[factuo]
print @n.xbgr.xm52_u17.nsg13_hv_pmos[w]
print @n.xbgr.xm52_u17.nsg13_hv_pmos[l]
print @n.xbgr.xm52_u17.nsg13_hv_pmos[delvto]
print @n.xbgr.xm52_u17.nsg13_hv_pmos[factuo]
print @n.xbgr.xm52_u18.nsg13_hv_pmos[w]
print @n.xbgr.xm52_u18.nsg13_hv_pmos[l]
print @n.xbgr.xm52_u18.nsg13_hv_pmos[delvto]
print @n.xbgr.xm52_u18.nsg13_hv_pmos[factuo]
print @n.xbgr.xm52_u19.nsg13_hv_pmos[w]
print @n.xbgr.xm52_u19.nsg13_hv_pmos[l]
print @n.xbgr.xm52_u19.nsg13_hv_pmos[delvto]
print @n.xbgr.xm52_u19.nsg13_hv_pmos[factuo]
print @n.xbgr.xm52_u20.nsg13_hv_pmos[w]
print @n.xbgr.xm52_u20.nsg13_hv_pmos[l]
print @n.xbgr.xm52_u20.nsg13_hv_pmos[delvto]
print @n.xbgr.xm52_u20.nsg13_hv_pmos[factuo]
print @n.xbgr.xm52_u21.nsg13_hv_pmos[w]
print @n.xbgr.xm52_u21.nsg13_hv_pmos[l]
print @n.xbgr.xm52_u21.nsg13_hv_pmos[delvto]
print @n.xbgr.xm52_u21.nsg13_hv_pmos[factuo]
print @n.xbgr.xm52_u22.nsg13_hv_pmos[w]
print @n.xbgr.xm52_u22.nsg13_hv_pmos[l]
print @n.xbgr.xm52_u22.nsg13_hv_pmos[delvto]
print @n.xbgr.xm52_u22.nsg13_hv_pmos[factuo]
print @n.xbgr.xm52_u23.nsg13_hv_pmos[w]
print @n.xbgr.xm52_u23.nsg13_hv_pmos[l]
print @n.xbgr.xm52_u23.nsg13_hv_pmos[delvto]
print @n.xbgr.xm52_u23.nsg13_hv_pmos[factuo]
print @n.xbgr.xm52_u24.nsg13_hv_pmos[w]
print @n.xbgr.xm52_u24.nsg13_hv_pmos[l]
print @n.xbgr.xm52_u24.nsg13_hv_pmos[delvto]
print @n.xbgr.xm52_u24.nsg13_hv_pmos[factuo]
print @n.xbgr.xm54_u2.nsg13_hv_pmos[w]
print @n.xbgr.xm54_u2.nsg13_hv_pmos[l]
print @n.xbgr.xm54_u2.nsg13_hv_pmos[delvto]
print @n.xbgr.xm54_u2.nsg13_hv_pmos[factuo]
print @n.xbgr.xm54_u3.nsg13_hv_pmos[w]
print @n.xbgr.xm54_u3.nsg13_hv_pmos[l]
print @n.xbgr.xm54_u3.nsg13_hv_pmos[delvto]
print @n.xbgr.xm54_u3.nsg13_hv_pmos[factuo]
print @n.xbgr.xm54_u4.nsg13_hv_pmos[w]
print @n.xbgr.xm54_u4.nsg13_hv_pmos[l]
print @n.xbgr.xm54_u4.nsg13_hv_pmos[delvto]
print @n.xbgr.xm54_u4.nsg13_hv_pmos[factuo]
print @n.xbgr.xm54_u5.nsg13_hv_pmos[w]
print @n.xbgr.xm54_u5.nsg13_hv_pmos[l]
print @n.xbgr.xm54_u5.nsg13_hv_pmos[delvto]
print @n.xbgr.xm54_u5.nsg13_hv_pmos[factuo]
print @n.xbgr.xm54_u6.nsg13_hv_pmos[w]
print @n.xbgr.xm54_u6.nsg13_hv_pmos[l]
print @n.xbgr.xm54_u6.nsg13_hv_pmos[delvto]
print @n.xbgr.xm54_u6.nsg13_hv_pmos[factuo]
print @n.xbgr.xm54_u7.nsg13_hv_pmos[w]
print @n.xbgr.xm54_u7.nsg13_hv_pmos[l]
print @n.xbgr.xm54_u7.nsg13_hv_pmos[delvto]
print @n.xbgr.xm54_u7.nsg13_hv_pmos[factuo]
print @n.xbgr.xm54_u8.nsg13_hv_pmos[w]
print @n.xbgr.xm54_u8.nsg13_hv_pmos[l]
print @n.xbgr.xm54_u8.nsg13_hv_pmos[delvto]
print @n.xbgr.xm54_u8.nsg13_hv_pmos[factuo]
print @n.xbgr.xm54_u9.nsg13_hv_pmos[w]
print @n.xbgr.xm54_u9.nsg13_hv_pmos[l]
print @n.xbgr.xm54_u9.nsg13_hv_pmos[delvto]
print @n.xbgr.xm54_u9.nsg13_hv_pmos[factuo]
print @n.xbgr.xm54_u10.nsg13_hv_pmos[w]
print @n.xbgr.xm54_u10.nsg13_hv_pmos[l]
print @n.xbgr.xm54_u10.nsg13_hv_pmos[delvto]
print @n.xbgr.xm54_u10.nsg13_hv_pmos[factuo]
print @n.xbgr.xm54_u11.nsg13_hv_pmos[w]
print @n.xbgr.xm54_u11.nsg13_hv_pmos[l]
print @n.xbgr.xm54_u11.nsg13_hv_pmos[delvto]
print @n.xbgr.xm54_u11.nsg13_hv_pmos[factuo]
print @n.xbgr.xm54_u12.nsg13_hv_pmos[w]
print @n.xbgr.xm54_u12.nsg13_hv_pmos[l]
print @n.xbgr.xm54_u12.nsg13_hv_pmos[delvto]
print @n.xbgr.xm54_u12.nsg13_hv_pmos[factuo]
print @n.xbgr.xm54_u13.nsg13_hv_pmos[w]
print @n.xbgr.xm54_u13.nsg13_hv_pmos[l]
print @n.xbgr.xm54_u13.nsg13_hv_pmos[delvto]
print @n.xbgr.xm54_u13.nsg13_hv_pmos[factuo]
print @n.xbgr.xm54_u14.nsg13_hv_pmos[w]
print @n.xbgr.xm54_u14.nsg13_hv_pmos[l]
print @n.xbgr.xm54_u14.nsg13_hv_pmos[delvto]
print @n.xbgr.xm54_u14.nsg13_hv_pmos[factuo]
print @n.xbgr.xm54_u15.nsg13_hv_pmos[w]
print @n.xbgr.xm54_u15.nsg13_hv_pmos[l]
print @n.xbgr.xm54_u15.nsg13_hv_pmos[delvto]
print @n.xbgr.xm54_u15.nsg13_hv_pmos[factuo]
print @n.xbgr.xm54_u16.nsg13_hv_pmos[w]
print @n.xbgr.xm54_u16.nsg13_hv_pmos[l]
print @n.xbgr.xm54_u16.nsg13_hv_pmos[delvto]
print @n.xbgr.xm54_u16.nsg13_hv_pmos[factuo]
print @n.xbgr.xm54_u17.nsg13_hv_pmos[w]
print @n.xbgr.xm54_u17.nsg13_hv_pmos[l]
print @n.xbgr.xm54_u17.nsg13_hv_pmos[delvto]
print @n.xbgr.xm54_u17.nsg13_hv_pmos[factuo]
print @n.xbgr.xm54_u18.nsg13_hv_pmos[w]
print @n.xbgr.xm54_u18.nsg13_hv_pmos[l]
print @n.xbgr.xm54_u18.nsg13_hv_pmos[delvto]
print @n.xbgr.xm54_u18.nsg13_hv_pmos[factuo]
print @n.xbgr.xm54_u19.nsg13_hv_pmos[w]
print @n.xbgr.xm54_u19.nsg13_hv_pmos[l]
print @n.xbgr.xm54_u19.nsg13_hv_pmos[delvto]
print @n.xbgr.xm54_u19.nsg13_hv_pmos[factuo]
print @n.xbgr.xm54_u20.nsg13_hv_pmos[w]
print @n.xbgr.xm54_u20.nsg13_hv_pmos[l]
print @n.xbgr.xm54_u20.nsg13_hv_pmos[delvto]
print @n.xbgr.xm54_u20.nsg13_hv_pmos[factuo]
print @n.xbgr.xm54_u21.nsg13_hv_pmos[w]
print @n.xbgr.xm54_u21.nsg13_hv_pmos[l]
print @n.xbgr.xm54_u21.nsg13_hv_pmos[delvto]
print @n.xbgr.xm54_u21.nsg13_hv_pmos[factuo]
print @n.xbgr.xm54_u22.nsg13_hv_pmos[w]
print @n.xbgr.xm54_u22.nsg13_hv_pmos[l]
print @n.xbgr.xm54_u22.nsg13_hv_pmos[delvto]
print @n.xbgr.xm54_u22.nsg13_hv_pmos[factuo]
print @n.xbgr.xm54_u23.nsg13_hv_pmos[w]
print @n.xbgr.xm54_u23.nsg13_hv_pmos[l]
print @n.xbgr.xm54_u23.nsg13_hv_pmos[delvto]
print @n.xbgr.xm54_u23.nsg13_hv_pmos[factuo]
print @n.xbgr.xm54_u24.nsg13_hv_pmos[w]
print @n.xbgr.xm54_u24.nsg13_hv_pmos[l]
print @n.xbgr.xm54_u24.nsg13_hv_pmos[delvto]
print @n.xbgr.xm54_u24.nsg13_hv_pmos[factuo]
print @q.xbgr.xq56_u2.qnpn13g2[area]
print @q.xbgr.xq56_u3.qnpn13g2[area]
print @q.xbgr.xq56_u4.qnpn13g2[area]
print @q.xbgr.xq56_u5.qnpn13g2[area]
print @q.xbgr.xq56_u6.qnpn13g2[area]
print @q.xbgr.xq56_u7.qnpn13g2[area]
print @q.xbgr.xq56_u8.qnpn13g2[area]
print @q.xbgr.xq56_u9.qnpn13g2[area]
print @q.xbgr.xq56_u10.qnpn13g2[area]
print @q.xbgr.xq56_u11.qnpn13g2[area]
print @q.xbgr.xq56_u12.qnpn13g2[area]
print @q.xbgr.xq56_u13.qnpn13g2[area]
print @q.xbgr.xq56_u14.qnpn13g2[area]
print @q.xbgr.xq56_u15.qnpn13g2[area]
print @q.xbgr.xq56_u16.qnpn13g2[area]
print @q.xbgr.xq56_u17.qnpn13g2[area]
print @q.xbgr.xq56_u18.qnpn13g2[area]
print @q.xbgr.xq56_u19.qnpn13g2[area]
print @q.xbgr.xq56_u20.qnpn13g2[area]
print @q.xbgr.xq56_u21.qnpn13g2[area]
print @q.xbgr.xq56_u22.qnpn13g2[area]
print @q.xbgr.xq56_u23.qnpn13g2[area]
print @q.xbgr.xq56_u24.qnpn13g2[area]
print @q.xbgr.xq60_u2.qnpn13g2[area]
print @q.xbgr.xq60_u3.qnpn13g2[area]
print @q.xbgr.xq60_u4.qnpn13g2[area]
print @q.xbgr.xq62_u2.qnpn13g2[area]
print @q.xbgr.xq62_u3.qnpn13g2[area]
print @q.xbgr.xq62_u4.qnpn13g2[area]
print @q.xbgr.xq62_u5.qnpn13g2[area]
print @q.xbgr.xq62_u6.qnpn13g2[area]
print @q.xbgr.xq62_u7.qnpn13g2[area]
print @q.xbgr.xq62_u8.qnpn13g2[area]
print @q.xbgr.xq62_u9.qnpn13g2[area]
print @q.xbgr.xq62_u10.qnpn13g2[area]
print @q.xbgr.xq62_u11.qnpn13g2[area]
print @q.xbgr.xq62_u12.qnpn13g2[area]
print @q.xbgr.xq62_u13.qnpn13g2[area]
print @q.xbgr.xq62_u14.qnpn13g2[area]
print @q.xbgr.xq62_u15.qnpn13g2[area]
print @q.xbgr.xq62_u16.qnpn13g2[area]
print @q.xbgr.xq62_u17.qnpn13g2[area]
print @q.xbgr.xq62_u18.qnpn13g2[area]
print @q.xbgr.xq62_u19.qnpn13g2[area]
print @q.xbgr.xq62_u20.qnpn13g2[area]
print @q.xbgr.xq62_u21.qnpn13g2[area]
print @q.xbgr.xq62_u22.qnpn13g2[area]
print @q.xbgr.xq62_u23.qnpn13g2[area]
print @q.xbgr.xq62_u24.qnpn13g2[area]
print @q.xbgr.xq67_u2.qnpn13g2[area]
print @q.xbgr.xq67_u3.qnpn13g2[area]
print @q.xbgr.xq67_u4.qnpn13g2[area]
print @q.xbgr.xq67_u5.qnpn13g2[area]
print @q.xbgr.xq67_u6.qnpn13g2[area]
print @q.xbgr.xq67_u7.qnpn13g2[area]
print @q.xbgr.xq67_u8.qnpn13g2[area]
print @q.xbgr.xq67_u9.qnpn13g2[area]
print @q.xbgr.xq67_u10.qnpn13g2[area]
print @q.xbgr.xq67_u11.qnpn13g2[area]
print @q.xbgr.xq67_u12.qnpn13g2[area]
print @q.xbgr.xq67_u13.qnpn13g2[area]
print @q.xbgr.xq67_u14.qnpn13g2[area]
print @q.xbgr.xq67_u15.qnpn13g2[area]
print @q.xbgr.xq67_u16.qnpn13g2[area]
print @q.xbgr.xq67_u17.qnpn13g2[area]
print @q.xbgr.xq67_u18.qnpn13g2[area]
print @q.xbgr.xq67_u19.qnpn13g2[area]
print @q.xbgr.xq67_u20.qnpn13g2[area]
print @q.xbgr.xq67_u21.qnpn13g2[area]
print @q.xbgr.xq67_u22.qnpn13g2[area]
print @q.xbgr.xq67_u23.qnpn13g2[area]
print @q.xbgr.xq67_u24.qnpn13g2[area]
print @q.xbgr.xq68_u2.qnpn13g2[area]
print @q.xbgr.xq68_u3.qnpn13g2[area]
print @q.xbgr.xq68_u4.qnpn13g2[area]
print @q.xbgr.xq68_u5.qnpn13g2[area]
print @q.xbgr.xq68_u6.qnpn13g2[area]
print @q.xbgr.xq68_u7.qnpn13g2[area]
print @q.xbgr.xq68_u8.qnpn13g2[area]
print @q.xbgr.xq68_u9.qnpn13g2[area]
print @q.xbgr.xq68_u10.qnpn13g2[area]
print @q.xbgr.xq68_u11.qnpn13g2[area]
print @q.xbgr.xq68_u12.qnpn13g2[area]
print @q.xbgr.xq68_u13.qnpn13g2[area]
print @q.xbgr.xq68_u14.qnpn13g2[area]
print @q.xbgr.xq68_u15.qnpn13g2[area]
print @q.xbgr.xq68_u16.qnpn13g2[area]
print @q.xbgr.xq68_u17.qnpn13g2[area]
print @q.xbgr.xq68_u18.qnpn13g2[area]
print @q.xbgr.xq68_u19.qnpn13g2[area]
print @q.xbgr.xq68_u20.qnpn13g2[area]
print @q.xbgr.xq68_u21.qnpn13g2[area]
print @q.xbgr.xq68_u22.qnpn13g2[area]
print @q.xbgr.xq68_u23.qnpn13g2[area]
print @q.xbgr.xq68_u24.qnpn13g2[area]
print @q.xbgr.xq69_u2.qnpn13g2[area]
print @q.xbgr.xq69_u3.qnpn13g2[area]
print @q.xbgr.xq69_u4.qnpn13g2[area]
print @q.xbgr.xq69_u5.qnpn13g2[area]
print @q.xbgr.xq69_u6.qnpn13g2[area]
print @q.xbgr.xq69_u7.qnpn13g2[area]
print @q.xbgr.xq69_u8.qnpn13g2[area]
print @q.xbgr.xq69_u9.qnpn13g2[area]
print @q.xbgr.xq69_u10.qnpn13g2[area]
print @q.xbgr.xq69_u11.qnpn13g2[area]
print @q.xbgr.xq69_u12.qnpn13g2[area]
print @q.xbgr.xq69_u13.qnpn13g2[area]
print @q.xbgr.xq69_u14.qnpn13g2[area]
print @q.xbgr.xq69_u15.qnpn13g2[area]
print @q.xbgr.xq69_u16.qnpn13g2[area]
print @q.xbgr.xq69_u17.qnpn13g2[area]
print @q.xbgr.xq69_u18.qnpn13g2[area]
print @q.xbgr.xq69_u19.qnpn13g2[area]
print @q.xbgr.xq69_u20.qnpn13g2[area]
print @q.xbgr.xq69_u21.qnpn13g2[area]
print @q.xbgr.xq69_u22.qnpn13g2[area]
print @q.xbgr.xq69_u23.qnpn13g2[area]
print @q.xbgr.xq69_u24.qnpn13g2[area]
print @q.xbgr.xq70_u2.qnpn13g2[area]
print @q.xbgr.xq70_u3.qnpn13g2[area]
print @q.xbgr.xq70_u4.qnpn13g2[area]
print @q.xbgr.xq70_u5.qnpn13g2[area]
print @q.xbgr.xq70_u6.qnpn13g2[area]
print @q.xbgr.xq70_u7.qnpn13g2[area]
print @q.xbgr.xq70_u8.qnpn13g2[area]
print @q.xbgr.xq70_u9.qnpn13g2[area]
print @q.xbgr.xq70_u10.qnpn13g2[area]
print @q.xbgr.xq70_u11.qnpn13g2[area]
print @q.xbgr.xq70_u12.qnpn13g2[area]
print @q.xbgr.xq70_u13.qnpn13g2[area]
print @q.xbgr.xq70_u14.qnpn13g2[area]
print @q.xbgr.xq70_u15.qnpn13g2[area]
print @q.xbgr.xq70_u16.qnpn13g2[area]
print @q.xbgr.xq70_u17.qnpn13g2[area]
print @q.xbgr.xq70_u18.qnpn13g2[area]
print @q.xbgr.xq70_u19.qnpn13g2[area]
print @q.xbgr.xq70_u20.qnpn13g2[area]
print @q.xbgr.xq70_u21.qnpn13g2[area]
print @q.xbgr.xq70_u22.qnpn13g2[area]
print @q.xbgr.xq70_u23.qnpn13g2[area]
print @q.xbgr.xq70_u24.qnpn13g2[area]
print @q.xbgr.xq71_u2.qnpn13g2[area]
print @q.xbgr.xq71_u3.qnpn13g2[area]
print @q.xbgr.xq71_u4.qnpn13g2[area]
print @q.xbgr.xq71_u5.qnpn13g2[area]
print @q.xbgr.xq71_u6.qnpn13g2[area]
print @q.xbgr.xq71_u7.qnpn13g2[area]
print @q.xbgr.xq71_u8.qnpn13g2[area]
print @q.xbgr.xq71_u9.qnpn13g2[area]
print @q.xbgr.xq71_u10.qnpn13g2[area]
print @q.xbgr.xq71_u11.qnpn13g2[area]
print @q.xbgr.xq71_u12.qnpn13g2[area]
print @q.xbgr.xq71_u13.qnpn13g2[area]
print @q.xbgr.xq71_u14.qnpn13g2[area]
print @q.xbgr.xq71_u15.qnpn13g2[area]
print @q.xbgr.xq71_u16.qnpn13g2[area]
print @q.xbgr.xq71_u17.qnpn13g2[area]
print @q.xbgr.xq71_u18.qnpn13g2[area]
print @q.xbgr.xq71_u19.qnpn13g2[area]
print @q.xbgr.xq71_u20.qnpn13g2[area]
print @q.xbgr.xq71_u21.qnpn13g2[area]
print @q.xbgr.xq71_u22.qnpn13g2[area]
print @q.xbgr.xq71_u23.qnpn13g2[area]
print @q.xbgr.xq71_u24.qnpn13g2[area]
print @q.xbgr.xq72_u2.qnpn13g2[area]
print @q.xbgr.xq72_u3.qnpn13g2[area]
print @q.xbgr.xq72_u4.qnpn13g2[area]
print @q.xbgr.xq72_u5.qnpn13g2[area]
print @q.xbgr.xq72_u6.qnpn13g2[area]
print @q.xbgr.xq72_u7.qnpn13g2[area]
print @q.xbgr.xq72_u8.qnpn13g2[area]
print @q.xbgr.xq72_u9.qnpn13g2[area]
print @q.xbgr.xq72_u10.qnpn13g2[area]
print @q.xbgr.xq72_u11.qnpn13g2[area]
print @q.xbgr.xq72_u12.qnpn13g2[area]
print @q.xbgr.xq72_u13.qnpn13g2[area]
print @q.xbgr.xq72_u14.qnpn13g2[area]
print @q.xbgr.xq72_u15.qnpn13g2[area]
print @q.xbgr.xq72_u16.qnpn13g2[area]
print @q.xbgr.xq72_u17.qnpn13g2[area]
print @q.xbgr.xq72_u18.qnpn13g2[area]
print @q.xbgr.xq72_u19.qnpn13g2[area]
print @q.xbgr.xq72_u20.qnpn13g2[area]
print @q.xbgr.xq72_u21.qnpn13g2[area]
print @q.xbgr.xq72_u22.qnpn13g2[area]
print @q.xbgr.xq72_u23.qnpn13g2[area]
print @q.xbgr.xq72_u24.qnpn13g2[area]
print @q.xbgr.xq73_u2.qnpn13g2[area]
print @q.xbgr.xq73_u3.qnpn13g2[area]
print @q.xbgr.xq73_u4.qnpn13g2[area]
print @q.xbgr.xq73_u5.qnpn13g2[area]
print @q.xbgr.xq73_u6.qnpn13g2[area]
print @q.xbgr.xq73_u7.qnpn13g2[area]
print @q.xbgr.xq73_u8.qnpn13g2[area]
print @q.xbgr.xq73_u9.qnpn13g2[area]
print @q.xbgr.xq73_u10.qnpn13g2[area]
print @q.xbgr.xq73_u11.qnpn13g2[area]
print @q.xbgr.xq73_u12.qnpn13g2[area]
print @q.xbgr.xq73_u13.qnpn13g2[area]
print @q.xbgr.xq73_u14.qnpn13g2[area]
print @q.xbgr.xq73_u15.qnpn13g2[area]
print @q.xbgr.xq73_u16.qnpn13g2[area]
print @q.xbgr.xq73_u17.qnpn13g2[area]
print @q.xbgr.xq73_u18.qnpn13g2[area]
print @q.xbgr.xq73_u19.qnpn13g2[area]
print @q.xbgr.xq73_u20.qnpn13g2[area]
print @q.xbgr.xq73_u21.qnpn13g2[area]
print @q.xbgr.xq73_u22.qnpn13g2[area]
print @q.xbgr.xq73_u23.qnpn13g2[area]
print @q.xbgr.xq73_u24.qnpn13g2[area]
print @q.xbgr.xq74_u2.qnpn13g2[area]
print @q.xbgr.xq74_u3.qnpn13g2[area]
print @q.xbgr.xq74_u4.qnpn13g2[area]
print @q.xbgr.xq74_u5.qnpn13g2[area]
print @q.xbgr.xq74_u6.qnpn13g2[area]
print @q.xbgr.xq74_u7.qnpn13g2[area]
print @q.xbgr.xq74_u8.qnpn13g2[area]
print @q.xbgr.xq74_u9.qnpn13g2[area]
print @q.xbgr.xq74_u10.qnpn13g2[area]
print @q.xbgr.xq74_u11.qnpn13g2[area]
print @q.xbgr.xq74_u12.qnpn13g2[area]
print @q.xbgr.xq74_u13.qnpn13g2[area]
print @q.xbgr.xq74_u14.qnpn13g2[area]
print @q.xbgr.xq74_u15.qnpn13g2[area]
print @q.xbgr.xq74_u16.qnpn13g2[area]
print @q.xbgr.xq74_u17.qnpn13g2[area]
print @q.xbgr.xq74_u18.qnpn13g2[area]
print @q.xbgr.xq74_u19.qnpn13g2[area]
print @q.xbgr.xq74_u20.qnpn13g2[area]
print @q.xbgr.xq74_u21.qnpn13g2[area]
print @q.xbgr.xq74_u22.qnpn13g2[area]
print @q.xbgr.xq74_u23.qnpn13g2[area]
print @q.xbgr.xq74_u24.qnpn13g2[area]
print @q.xbgr.xq75_u2.qnpn13g2[area]
print @q.xbgr.xq75_u3.qnpn13g2[area]
print @q.xbgr.xq75_u4.qnpn13g2[area]
print @q.xbgr.xq75_u5.qnpn13g2[area]
print @q.xbgr.xq75_u6.qnpn13g2[area]
print @q.xbgr.xq75_u7.qnpn13g2[area]
print @q.xbgr.xq75_u8.qnpn13g2[area]
print @q.xbgr.xq75_u9.qnpn13g2[area]
print @q.xbgr.xq75_u10.qnpn13g2[area]
print @q.xbgr.xq75_u11.qnpn13g2[area]
print @q.xbgr.xq75_u12.qnpn13g2[area]
print @q.xbgr.xq75_u13.qnpn13g2[area]
print @q.xbgr.xq75_u14.qnpn13g2[area]
print @q.xbgr.xq75_u15.qnpn13g2[area]
print @q.xbgr.xq75_u16.qnpn13g2[area]
print @q.xbgr.xq75_u17.qnpn13g2[area]
print @q.xbgr.xq75_u18.qnpn13g2[area]
print @q.xbgr.xq75_u19.qnpn13g2[area]
print @q.xbgr.xq75_u20.qnpn13g2[area]
print @q.xbgr.xq75_u21.qnpn13g2[area]
print @q.xbgr.xq75_u22.qnpn13g2[area]
print @q.xbgr.xq75_u23.qnpn13g2[area]
print @q.xbgr.xq75_u24.qnpn13g2[area]
print @q.xbgr.xq76_u2.qnpn13g2[area]
print @q.xbgr.xq76_u3.qnpn13g2[area]
print @q.xbgr.xq76_u4.qnpn13g2[area]
print @q.xbgr.xq76_u5.qnpn13g2[area]
print @q.xbgr.xq76_u6.qnpn13g2[area]
print @q.xbgr.xq76_u7.qnpn13g2[area]
print @q.xbgr.xq76_u8.qnpn13g2[area]
print @q.xbgr.xq76_u9.qnpn13g2[area]
print @q.xbgr.xq76_u10.qnpn13g2[area]
print @q.xbgr.xq76_u11.qnpn13g2[area]
print @q.xbgr.xq76_u12.qnpn13g2[area]
print @q.xbgr.xq76_u13.qnpn13g2[area]
print @q.xbgr.xq76_u14.qnpn13g2[area]
print @q.xbgr.xq76_u15.qnpn13g2[area]
print @q.xbgr.xq76_u16.qnpn13g2[area]
print @q.xbgr.xq76_u17.qnpn13g2[area]
print @q.xbgr.xq76_u18.qnpn13g2[area]
print @q.xbgr.xq76_u19.qnpn13g2[area]
print @q.xbgr.xq76_u20.qnpn13g2[area]
print @q.xbgr.xq76_u21.qnpn13g2[area]
print @q.xbgr.xq76_u22.qnpn13g2[area]
print @q.xbgr.xq76_u23.qnpn13g2[area]
print @q.xbgr.xq76_u24.qnpn13g2[area]
print @n.xbgr.xr77_u2.nr1[nsmm_rsh]
print @n.xbgr.xr77_u2.nr1[nsmm_w]
print @n.xbgr.xr77_u2.nr1[nsmm_l]
print @n.xbgr.xr77_u3.nr1[nsmm_rsh]
print @n.xbgr.xr77_u3.nr1[nsmm_w]
print @n.xbgr.xr77_u3.nr1[nsmm_l]
print @n.xbgr.xr77_u4.nr1[nsmm_rsh]
print @n.xbgr.xr77_u4.nr1[nsmm_w]
print @n.xbgr.xr77_u4.nr1[nsmm_l]
print @n.xbgr.xr77_u5.nr1[nsmm_rsh]
print @n.xbgr.xr77_u5.nr1[nsmm_w]
print @n.xbgr.xr77_u5.nr1[nsmm_l]
print @n.xbgr.xr77_u6.nr1[nsmm_rsh]
print @n.xbgr.xr77_u6.nr1[nsmm_w]
print @n.xbgr.xr77_u6.nr1[nsmm_l]
print @n.xbgr.xr77_u7.nr1[nsmm_rsh]
print @n.xbgr.xr77_u7.nr1[nsmm_w]
print @n.xbgr.xr77_u7.nr1[nsmm_l]
print @n.xbgr.xr77_u8.nr1[nsmm_rsh]
print @n.xbgr.xr77_u8.nr1[nsmm_w]
print @n.xbgr.xr77_u8.nr1[nsmm_l]
print @n.xbgr.xr77_u9.nr1[nsmm_rsh]
print @n.xbgr.xr77_u9.nr1[nsmm_w]
print @n.xbgr.xr77_u9.nr1[nsmm_l]
print @n.xbgr.xr77_u10.nr1[nsmm_rsh]
print @n.xbgr.xr77_u10.nr1[nsmm_w]
print @n.xbgr.xr77_u10.nr1[nsmm_l]
print @n.xbgr.xr77_u11.nr1[nsmm_rsh]
print @n.xbgr.xr77_u11.nr1[nsmm_w]
print @n.xbgr.xr77_u11.nr1[nsmm_l]
print @n.xbgr.xr77_u12.nr1[nsmm_rsh]
print @n.xbgr.xr77_u12.nr1[nsmm_w]
print @n.xbgr.xr77_u12.nr1[nsmm_l]
print @n.xbgr.xr77_u13.nr1[nsmm_rsh]
print @n.xbgr.xr77_u13.nr1[nsmm_w]
print @n.xbgr.xr77_u13.nr1[nsmm_l]
print @n.xbgr.xr77_u14.nr1[nsmm_rsh]
print @n.xbgr.xr77_u14.nr1[nsmm_w]
print @n.xbgr.xr77_u14.nr1[nsmm_l]
print @n.xbgr.xr77_u15.nr1[nsmm_rsh]
print @n.xbgr.xr77_u15.nr1[nsmm_w]
print @n.xbgr.xr77_u15.nr1[nsmm_l]
print @n.xbgr.xr77_u16.nr1[nsmm_rsh]
print @n.xbgr.xr77_u16.nr1[nsmm_w]
print @n.xbgr.xr77_u16.nr1[nsmm_l]
print @n.xbgr.xr77_u17.nr1[nsmm_rsh]
print @n.xbgr.xr77_u17.nr1[nsmm_w]
print @n.xbgr.xr77_u17.nr1[nsmm_l]
print @n.xbgr.xr77_u18.nr1[nsmm_rsh]
print @n.xbgr.xr77_u18.nr1[nsmm_w]
print @n.xbgr.xr77_u18.nr1[nsmm_l]
print @n.xbgr.xr77_u19.nr1[nsmm_rsh]
print @n.xbgr.xr77_u19.nr1[nsmm_w]
print @n.xbgr.xr77_u19.nr1[nsmm_l]
print @n.xbgr.xr77_u20.nr1[nsmm_rsh]
print @n.xbgr.xr77_u20.nr1[nsmm_w]
print @n.xbgr.xr77_u20.nr1[nsmm_l]
print @n.xbgr.xr77_u21.nr1[nsmm_rsh]
print @n.xbgr.xr77_u21.nr1[nsmm_w]
print @n.xbgr.xr77_u21.nr1[nsmm_l]
print @n.xbgr.xr77_u22.nr1[nsmm_rsh]
print @n.xbgr.xr77_u22.nr1[nsmm_w]
print @n.xbgr.xr77_u22.nr1[nsmm_l]
print @n.xbgr.xr77_u23.nr1[nsmm_rsh]
print @n.xbgr.xr77_u23.nr1[nsmm_w]
print @n.xbgr.xr77_u23.nr1[nsmm_l]
print @n.xbgr.xr77_u24.nr1[nsmm_rsh]
print @n.xbgr.xr77_u24.nr1[nsmm_w]
print @n.xbgr.xr77_u24.nr1[nsmm_l]
print @n.xbgr.xr78_u2.nr1[nsmm_rsh]
print @n.xbgr.xr78_u2.nr1[nsmm_w]
print @n.xbgr.xr78_u2.nr1[nsmm_l]
print @n.xbgr.xr78_u3.nr1[nsmm_rsh]
print @n.xbgr.xr78_u3.nr1[nsmm_w]
print @n.xbgr.xr78_u3.nr1[nsmm_l]
print @n.xbgr.xr78_u4.nr1[nsmm_rsh]
print @n.xbgr.xr78_u4.nr1[nsmm_w]
print @n.xbgr.xr78_u4.nr1[nsmm_l]
print @n.xbgr.xr78_u5.nr1[nsmm_rsh]
print @n.xbgr.xr78_u5.nr1[nsmm_w]
print @n.xbgr.xr78_u5.nr1[nsmm_l]
print @n.xbgr.xr78_u6.nr1[nsmm_rsh]
print @n.xbgr.xr78_u6.nr1[nsmm_w]
print @n.xbgr.xr78_u6.nr1[nsmm_l]
print @n.xbgr.xr78_u7.nr1[nsmm_rsh]
print @n.xbgr.xr78_u7.nr1[nsmm_w]
print @n.xbgr.xr78_u7.nr1[nsmm_l]
print @n.xbgr.xr78_u8.nr1[nsmm_rsh]
print @n.xbgr.xr78_u8.nr1[nsmm_w]
print @n.xbgr.xr78_u8.nr1[nsmm_l]
print @n.xbgr.xr78_u9.nr1[nsmm_rsh]
print @n.xbgr.xr78_u9.nr1[nsmm_w]
print @n.xbgr.xr78_u9.nr1[nsmm_l]
print @n.xbgr.xr78_u10.nr1[nsmm_rsh]
print @n.xbgr.xr78_u10.nr1[nsmm_w]
print @n.xbgr.xr78_u10.nr1[nsmm_l]
print @n.xbgr.xr78_u11.nr1[nsmm_rsh]
print @n.xbgr.xr78_u11.nr1[nsmm_w]
print @n.xbgr.xr78_u11.nr1[nsmm_l]
print @n.xbgr.xr78_u12.nr1[nsmm_rsh]
print @n.xbgr.xr78_u12.nr1[nsmm_w]
print @n.xbgr.xr78_u12.nr1[nsmm_l]
print @n.xbgr.xr78_u13.nr1[nsmm_rsh]
print @n.xbgr.xr78_u13.nr1[nsmm_w]
print @n.xbgr.xr78_u13.nr1[nsmm_l]
print @n.xbgr.xr78_u14.nr1[nsmm_rsh]
print @n.xbgr.xr78_u14.nr1[nsmm_w]
print @n.xbgr.xr78_u14.nr1[nsmm_l]
print @n.xbgr.xr78_u15.nr1[nsmm_rsh]
print @n.xbgr.xr78_u15.nr1[nsmm_w]
print @n.xbgr.xr78_u15.nr1[nsmm_l]
print @n.xbgr.xr78_u16.nr1[nsmm_rsh]
print @n.xbgr.xr78_u16.nr1[nsmm_w]
print @n.xbgr.xr78_u16.nr1[nsmm_l]
print @n.xbgr.xr78_u17.nr1[nsmm_rsh]
print @n.xbgr.xr78_u17.nr1[nsmm_w]
print @n.xbgr.xr78_u17.nr1[nsmm_l]
print @n.xbgr.xr78_u18.nr1[nsmm_rsh]
print @n.xbgr.xr78_u18.nr1[nsmm_w]
print @n.xbgr.xr78_u18.nr1[nsmm_l]
print @n.xbgr.xr78_u19.nr1[nsmm_rsh]
print @n.xbgr.xr78_u19.nr1[nsmm_w]
print @n.xbgr.xr78_u19.nr1[nsmm_l]
print @n.xbgr.xr78_u20.nr1[nsmm_rsh]
print @n.xbgr.xr78_u20.nr1[nsmm_w]
print @n.xbgr.xr78_u20.nr1[nsmm_l]
print @n.xbgr.xr78_u21.nr1[nsmm_rsh]
print @n.xbgr.xr78_u21.nr1[nsmm_w]
print @n.xbgr.xr78_u21.nr1[nsmm_l]
print @n.xbgr.xr78_u22.nr1[nsmm_rsh]
print @n.xbgr.xr78_u22.nr1[nsmm_w]
print @n.xbgr.xr78_u22.nr1[nsmm_l]
print @n.xbgr.xr78_u23.nr1[nsmm_rsh]
print @n.xbgr.xr78_u23.nr1[nsmm_w]
print @n.xbgr.xr78_u23.nr1[nsmm_l]
print @n.xbgr.xr78_u24.nr1[nsmm_rsh]
print @n.xbgr.xr78_u24.nr1[nsmm_w]
print @n.xbgr.xr78_u24.nr1[nsmm_l]
print @n.xbgr.xr79_u2.nr1[nsmm_rsh]
print @n.xbgr.xr79_u2.nr1[nsmm_w]
print @n.xbgr.xr79_u2.nr1[nsmm_l]
print @n.xbgr.xr79_u3.nr1[nsmm_rsh]
print @n.xbgr.xr79_u3.nr1[nsmm_w]
print @n.xbgr.xr79_u3.nr1[nsmm_l]
print @n.xbgr.xr79_u4.nr1[nsmm_rsh]
print @n.xbgr.xr79_u4.nr1[nsmm_w]
print @n.xbgr.xr79_u4.nr1[nsmm_l]
print @n.xbgr.xr79_u5.nr1[nsmm_rsh]
print @n.xbgr.xr79_u5.nr1[nsmm_w]
print @n.xbgr.xr79_u5.nr1[nsmm_l]
print @n.xbgr.xr79_u6.nr1[nsmm_rsh]
print @n.xbgr.xr79_u6.nr1[nsmm_w]
print @n.xbgr.xr79_u6.nr1[nsmm_l]
print @n.xbgr.xr79_u7.nr1[nsmm_rsh]
print @n.xbgr.xr79_u7.nr1[nsmm_w]
print @n.xbgr.xr79_u7.nr1[nsmm_l]
print @n.xbgr.xr79_u8.nr1[nsmm_rsh]
print @n.xbgr.xr79_u8.nr1[nsmm_w]
print @n.xbgr.xr79_u8.nr1[nsmm_l]
print @n.xbgr.xr79_u9.nr1[nsmm_rsh]
print @n.xbgr.xr79_u9.nr1[nsmm_w]
print @n.xbgr.xr79_u9.nr1[nsmm_l]
print @n.xbgr.xr79_u10.nr1[nsmm_rsh]
print @n.xbgr.xr79_u10.nr1[nsmm_w]
print @n.xbgr.xr79_u10.nr1[nsmm_l]
print @n.xbgr.xr79_u11.nr1[nsmm_rsh]
print @n.xbgr.xr79_u11.nr1[nsmm_w]
print @n.xbgr.xr79_u11.nr1[nsmm_l]
print @n.xbgr.xr79_u12.nr1[nsmm_rsh]
print @n.xbgr.xr79_u12.nr1[nsmm_w]
print @n.xbgr.xr79_u12.nr1[nsmm_l]
print @n.xbgr.xr79_u13.nr1[nsmm_rsh]
print @n.xbgr.xr79_u13.nr1[nsmm_w]
print @n.xbgr.xr79_u13.nr1[nsmm_l]
print @n.xbgr.xr79_u14.nr1[nsmm_rsh]
print @n.xbgr.xr79_u14.nr1[nsmm_w]
print @n.xbgr.xr79_u14.nr1[nsmm_l]
print @n.xbgr.xr79_u15.nr1[nsmm_rsh]
print @n.xbgr.xr79_u15.nr1[nsmm_w]
print @n.xbgr.xr79_u15.nr1[nsmm_l]
print @n.xbgr.xr79_u16.nr1[nsmm_rsh]
print @n.xbgr.xr79_u16.nr1[nsmm_w]
print @n.xbgr.xr79_u16.nr1[nsmm_l]
print @n.xbgr.xr79_u17.nr1[nsmm_rsh]
print @n.xbgr.xr79_u17.nr1[nsmm_w]
print @n.xbgr.xr79_u17.nr1[nsmm_l]
print @n.xbgr.xr79_u18.nr1[nsmm_rsh]
print @n.xbgr.xr79_u18.nr1[nsmm_w]
print @n.xbgr.xr79_u18.nr1[nsmm_l]
print @n.xbgr.xr79_u19.nr1[nsmm_rsh]
print @n.xbgr.xr79_u19.nr1[nsmm_w]
print @n.xbgr.xr79_u19.nr1[nsmm_l]
print @n.xbgr.xr79_u20.nr1[nsmm_rsh]
print @n.xbgr.xr79_u20.nr1[nsmm_w]
print @n.xbgr.xr79_u20.nr1[nsmm_l]
print @n.xbgr.xr79_u21.nr1[nsmm_rsh]
print @n.xbgr.xr79_u21.nr1[nsmm_w]
print @n.xbgr.xr79_u21.nr1[nsmm_l]
print @n.xbgr.xr79_u22.nr1[nsmm_rsh]
print @n.xbgr.xr79_u22.nr1[nsmm_w]
print @n.xbgr.xr79_u22.nr1[nsmm_l]
print @n.xbgr.xr79_u23.nr1[nsmm_rsh]
print @n.xbgr.xr79_u23.nr1[nsmm_w]
print @n.xbgr.xr79_u23.nr1[nsmm_l]
print @n.xbgr.xr79_u24.nr1[nsmm_rsh]
print @n.xbgr.xr79_u24.nr1[nsmm_w]
print @n.xbgr.xr79_u24.nr1[nsmm_l]
print @n.xbgr.xr80_u2.nr1[nsmm_rsh]
print @n.xbgr.xr80_u2.nr1[nsmm_w]
print @n.xbgr.xr80_u2.nr1[nsmm_l]
print @n.xbgr.xr80_u3.nr1[nsmm_rsh]
print @n.xbgr.xr80_u3.nr1[nsmm_w]
print @n.xbgr.xr80_u3.nr1[nsmm_l]
print @n.xbgr.xr80_u4.nr1[nsmm_rsh]
print @n.xbgr.xr80_u4.nr1[nsmm_w]
print @n.xbgr.xr80_u4.nr1[nsmm_l]
print @n.xbgr.xr80_u5.nr1[nsmm_rsh]
print @n.xbgr.xr80_u5.nr1[nsmm_w]
print @n.xbgr.xr80_u5.nr1[nsmm_l]
print @n.xbgr.xr80_u6.nr1[nsmm_rsh]
print @n.xbgr.xr80_u6.nr1[nsmm_w]
print @n.xbgr.xr80_u6.nr1[nsmm_l]
print @n.xbgr.xr80_u7.nr1[nsmm_rsh]
print @n.xbgr.xr80_u7.nr1[nsmm_w]
print @n.xbgr.xr80_u7.nr1[nsmm_l]
print @n.xbgr.xr80_u8.nr1[nsmm_rsh]
print @n.xbgr.xr80_u8.nr1[nsmm_w]
print @n.xbgr.xr80_u8.nr1[nsmm_l]
print @n.xbgr.xr80_u9.nr1[nsmm_rsh]
print @n.xbgr.xr80_u9.nr1[nsmm_w]
print @n.xbgr.xr80_u9.nr1[nsmm_l]
print @n.xbgr.xr80_u10.nr1[nsmm_rsh]
print @n.xbgr.xr80_u10.nr1[nsmm_w]
print @n.xbgr.xr80_u10.nr1[nsmm_l]
print @n.xbgr.xr80_u11.nr1[nsmm_rsh]
print @n.xbgr.xr80_u11.nr1[nsmm_w]
print @n.xbgr.xr80_u11.nr1[nsmm_l]
print @n.xbgr.xr80_u12.nr1[nsmm_rsh]
print @n.xbgr.xr80_u12.nr1[nsmm_w]
print @n.xbgr.xr80_u12.nr1[nsmm_l]
print @n.xbgr.xr80_u13.nr1[nsmm_rsh]
print @n.xbgr.xr80_u13.nr1[nsmm_w]
print @n.xbgr.xr80_u13.nr1[nsmm_l]
print @n.xbgr.xr80_u14.nr1[nsmm_rsh]
print @n.xbgr.xr80_u14.nr1[nsmm_w]
print @n.xbgr.xr80_u14.nr1[nsmm_l]
print @n.xbgr.xr80_u15.nr1[nsmm_rsh]
print @n.xbgr.xr80_u15.nr1[nsmm_w]
print @n.xbgr.xr80_u15.nr1[nsmm_l]
print @n.xbgr.xr80_u16.nr1[nsmm_rsh]
print @n.xbgr.xr80_u16.nr1[nsmm_w]
print @n.xbgr.xr80_u16.nr1[nsmm_l]
print @n.xbgr.xr80_u17.nr1[nsmm_rsh]
print @n.xbgr.xr80_u17.nr1[nsmm_w]
print @n.xbgr.xr80_u17.nr1[nsmm_l]
print @n.xbgr.xr80_u18.nr1[nsmm_rsh]
print @n.xbgr.xr80_u18.nr1[nsmm_w]
print @n.xbgr.xr80_u18.nr1[nsmm_l]
print @n.xbgr.xr80_u19.nr1[nsmm_rsh]
print @n.xbgr.xr80_u19.nr1[nsmm_w]
print @n.xbgr.xr80_u19.nr1[nsmm_l]
print @n.xbgr.xr80_u20.nr1[nsmm_rsh]
print @n.xbgr.xr80_u20.nr1[nsmm_w]
print @n.xbgr.xr80_u20.nr1[nsmm_l]
print @n.xbgr.xr80_u21.nr1[nsmm_rsh]
print @n.xbgr.xr80_u21.nr1[nsmm_w]
print @n.xbgr.xr80_u21.nr1[nsmm_l]
print @n.xbgr.xr80_u22.nr1[nsmm_rsh]
print @n.xbgr.xr80_u22.nr1[nsmm_w]
print @n.xbgr.xr80_u22.nr1[nsmm_l]
print @n.xbgr.xr80_u23.nr1[nsmm_rsh]
print @n.xbgr.xr80_u23.nr1[nsmm_w]
print @n.xbgr.xr80_u23.nr1[nsmm_l]
print @n.xbgr.xr80_u24.nr1[nsmm_rsh]
print @n.xbgr.xr80_u24.nr1[nsmm_w]
print @n.xbgr.xr80_u24.nr1[nsmm_l]
print @n.xbgr.xr81_u2.nr1[nsmm_rsh]
print @n.xbgr.xr81_u2.nr1[nsmm_w]
print @n.xbgr.xr81_u2.nr1[nsmm_l]
print @n.xbgr.xr81_u3.nr1[nsmm_rsh]
print @n.xbgr.xr81_u3.nr1[nsmm_w]
print @n.xbgr.xr81_u3.nr1[nsmm_l]
print @n.xbgr.xr81_u4.nr1[nsmm_rsh]
print @n.xbgr.xr81_u4.nr1[nsmm_w]
print @n.xbgr.xr81_u4.nr1[nsmm_l]
print @n.xbgr.xr81_u5.nr1[nsmm_rsh]
print @n.xbgr.xr81_u5.nr1[nsmm_w]
print @n.xbgr.xr81_u5.nr1[nsmm_l]
print @n.xbgr.xr81_u6.nr1[nsmm_rsh]
print @n.xbgr.xr81_u6.nr1[nsmm_w]
print @n.xbgr.xr81_u6.nr1[nsmm_l]
print @n.xbgr.xr81_u7.nr1[nsmm_rsh]
print @n.xbgr.xr81_u7.nr1[nsmm_w]
print @n.xbgr.xr81_u7.nr1[nsmm_l]
print @n.xbgr.xr81_u8.nr1[nsmm_rsh]
print @n.xbgr.xr81_u8.nr1[nsmm_w]
print @n.xbgr.xr81_u8.nr1[nsmm_l]
print @n.xbgr.xr81_u9.nr1[nsmm_rsh]
print @n.xbgr.xr81_u9.nr1[nsmm_w]
print @n.xbgr.xr81_u9.nr1[nsmm_l]
print @n.xbgr.xr81_u10.nr1[nsmm_rsh]
print @n.xbgr.xr81_u10.nr1[nsmm_w]
print @n.xbgr.xr81_u10.nr1[nsmm_l]
print @n.xbgr.xr81_u11.nr1[nsmm_rsh]
print @n.xbgr.xr81_u11.nr1[nsmm_w]
print @n.xbgr.xr81_u11.nr1[nsmm_l]
print @n.xbgr.xr81_u12.nr1[nsmm_rsh]
print @n.xbgr.xr81_u12.nr1[nsmm_w]
print @n.xbgr.xr81_u12.nr1[nsmm_l]
print @n.xbgr.xr81_u13.nr1[nsmm_rsh]
print @n.xbgr.xr81_u13.nr1[nsmm_w]
print @n.xbgr.xr81_u13.nr1[nsmm_l]
print @n.xbgr.xr81_u14.nr1[nsmm_rsh]
print @n.xbgr.xr81_u14.nr1[nsmm_w]
print @n.xbgr.xr81_u14.nr1[nsmm_l]
print @n.xbgr.xr81_u15.nr1[nsmm_rsh]
print @n.xbgr.xr81_u15.nr1[nsmm_w]
print @n.xbgr.xr81_u15.nr1[nsmm_l]
print @n.xbgr.xr81_u16.nr1[nsmm_rsh]
print @n.xbgr.xr81_u16.nr1[nsmm_w]
print @n.xbgr.xr81_u16.nr1[nsmm_l]
print @n.xbgr.xr81_u17.nr1[nsmm_rsh]
print @n.xbgr.xr81_u17.nr1[nsmm_w]
print @n.xbgr.xr81_u17.nr1[nsmm_l]
print @n.xbgr.xr81_u18.nr1[nsmm_rsh]
print @n.xbgr.xr81_u18.nr1[nsmm_w]
print @n.xbgr.xr81_u18.nr1[nsmm_l]
print @n.xbgr.xr81_u19.nr1[nsmm_rsh]
print @n.xbgr.xr81_u19.nr1[nsmm_w]
print @n.xbgr.xr81_u19.nr1[nsmm_l]
print @n.xbgr.xr81_u20.nr1[nsmm_rsh]
print @n.xbgr.xr81_u20.nr1[nsmm_w]
print @n.xbgr.xr81_u20.nr1[nsmm_l]
print @n.xbgr.xr81_u21.nr1[nsmm_rsh]
print @n.xbgr.xr81_u21.nr1[nsmm_w]
print @n.xbgr.xr81_u21.nr1[nsmm_l]
print @n.xbgr.xr81_u22.nr1[nsmm_rsh]
print @n.xbgr.xr81_u22.nr1[nsmm_w]
print @n.xbgr.xr81_u22.nr1[nsmm_l]
print @n.xbgr.xr81_u23.nr1[nsmm_rsh]
print @n.xbgr.xr81_u23.nr1[nsmm_w]
print @n.xbgr.xr81_u23.nr1[nsmm_l]
print @n.xbgr.xr81_u24.nr1[nsmm_rsh]
print @n.xbgr.xr81_u24.nr1[nsmm_w]
print @n.xbgr.xr81_u24.nr1[nsmm_l]
print @n.xbgr.xr82_u2.nr1[nsmm_rsh]
print @n.xbgr.xr82_u2.nr1[nsmm_w]
print @n.xbgr.xr82_u2.nr1[nsmm_l]
print @n.xbgr.xr82_u3.nr1[nsmm_rsh]
print @n.xbgr.xr82_u3.nr1[nsmm_w]
print @n.xbgr.xr82_u3.nr1[nsmm_l]
print @n.xbgr.xr82_u4.nr1[nsmm_rsh]
print @n.xbgr.xr82_u4.nr1[nsmm_w]
print @n.xbgr.xr82_u4.nr1[nsmm_l]
print @n.xbgr.xr82_u5.nr1[nsmm_rsh]
print @n.xbgr.xr82_u5.nr1[nsmm_w]
print @n.xbgr.xr82_u5.nr1[nsmm_l]
print @n.xbgr.xr82_u6.nr1[nsmm_rsh]
print @n.xbgr.xr82_u6.nr1[nsmm_w]
print @n.xbgr.xr82_u6.nr1[nsmm_l]
print @n.xbgr.xr82_u7.nr1[nsmm_rsh]
print @n.xbgr.xr82_u7.nr1[nsmm_w]
print @n.xbgr.xr82_u7.nr1[nsmm_l]
print @n.xbgr.xr82_u8.nr1[nsmm_rsh]
print @n.xbgr.xr82_u8.nr1[nsmm_w]
print @n.xbgr.xr82_u8.nr1[nsmm_l]
print @n.xbgr.xr82_u9.nr1[nsmm_rsh]
print @n.xbgr.xr82_u9.nr1[nsmm_w]
print @n.xbgr.xr82_u9.nr1[nsmm_l]
print @n.xbgr.xr82_u10.nr1[nsmm_rsh]
print @n.xbgr.xr82_u10.nr1[nsmm_w]
print @n.xbgr.xr82_u10.nr1[nsmm_l]
print @n.xbgr.xr82_u11.nr1[nsmm_rsh]
print @n.xbgr.xr82_u11.nr1[nsmm_w]
print @n.xbgr.xr82_u11.nr1[nsmm_l]
print @n.xbgr.xr82_u12.nr1[nsmm_rsh]
print @n.xbgr.xr82_u12.nr1[nsmm_w]
print @n.xbgr.xr82_u12.nr1[nsmm_l]
print @n.xbgr.xr82_u13.nr1[nsmm_rsh]
print @n.xbgr.xr82_u13.nr1[nsmm_w]
print @n.xbgr.xr82_u13.nr1[nsmm_l]
print @n.xbgr.xr82_u14.nr1[nsmm_rsh]
print @n.xbgr.xr82_u14.nr1[nsmm_w]
print @n.xbgr.xr82_u14.nr1[nsmm_l]
print @n.xbgr.xr82_u15.nr1[nsmm_rsh]
print @n.xbgr.xr82_u15.nr1[nsmm_w]
print @n.xbgr.xr82_u15.nr1[nsmm_l]
print @n.xbgr.xr82_u16.nr1[nsmm_rsh]
print @n.xbgr.xr82_u16.nr1[nsmm_w]
print @n.xbgr.xr82_u16.nr1[nsmm_l]
print @n.xbgr.xr82_u17.nr1[nsmm_rsh]
print @n.xbgr.xr82_u17.nr1[nsmm_w]
print @n.xbgr.xr82_u17.nr1[nsmm_l]
print @n.xbgr.xr82_u18.nr1[nsmm_rsh]
print @n.xbgr.xr82_u18.nr1[nsmm_w]
print @n.xbgr.xr82_u18.nr1[nsmm_l]
print @n.xbgr.xr82_u19.nr1[nsmm_rsh]
print @n.xbgr.xr82_u19.nr1[nsmm_w]
print @n.xbgr.xr82_u19.nr1[nsmm_l]
print @n.xbgr.xr82_u20.nr1[nsmm_rsh]
print @n.xbgr.xr82_u20.nr1[nsmm_w]
print @n.xbgr.xr82_u20.nr1[nsmm_l]
print @n.xbgr.xr82_u21.nr1[nsmm_rsh]
print @n.xbgr.xr82_u21.nr1[nsmm_w]
print @n.xbgr.xr82_u21.nr1[nsmm_l]
print @n.xbgr.xr82_u22.nr1[nsmm_rsh]
print @n.xbgr.xr82_u22.nr1[nsmm_w]
print @n.xbgr.xr82_u22.nr1[nsmm_l]
print @n.xbgr.xr82_u23.nr1[nsmm_rsh]
print @n.xbgr.xr82_u23.nr1[nsmm_w]
print @n.xbgr.xr82_u23.nr1[nsmm_l]
print @n.xbgr.xr82_u24.nr1[nsmm_rsh]
print @n.xbgr.xr82_u24.nr1[nsmm_w]
print @n.xbgr.xr82_u24.nr1[nsmm_l]
print @n.xbgr.xr83_u2.nr1[nsmm_rsh]
print @n.xbgr.xr83_u2.nr1[nsmm_w]
print @n.xbgr.xr83_u2.nr1[nsmm_l]
print @n.xbgr.xr83_u3.nr1[nsmm_rsh]
print @n.xbgr.xr83_u3.nr1[nsmm_w]
print @n.xbgr.xr83_u3.nr1[nsmm_l]
print @n.xbgr.xr83_u4.nr1[nsmm_rsh]
print @n.xbgr.xr83_u4.nr1[nsmm_w]
print @n.xbgr.xr83_u4.nr1[nsmm_l]
print @n.xbgr.xr83_u5.nr1[nsmm_rsh]
print @n.xbgr.xr83_u5.nr1[nsmm_w]
print @n.xbgr.xr83_u5.nr1[nsmm_l]
print @n.xbgr.xr83_u6.nr1[nsmm_rsh]
print @n.xbgr.xr83_u6.nr1[nsmm_w]
print @n.xbgr.xr83_u6.nr1[nsmm_l]
print @n.xbgr.xr83_u7.nr1[nsmm_rsh]
print @n.xbgr.xr83_u7.nr1[nsmm_w]
print @n.xbgr.xr83_u7.nr1[nsmm_l]
print @n.xbgr.xr83_u8.nr1[nsmm_rsh]
print @n.xbgr.xr83_u8.nr1[nsmm_w]
print @n.xbgr.xr83_u8.nr1[nsmm_l]
print @n.xbgr.xr83_u9.nr1[nsmm_rsh]
print @n.xbgr.xr83_u9.nr1[nsmm_w]
print @n.xbgr.xr83_u9.nr1[nsmm_l]
print @n.xbgr.xr83_u10.nr1[nsmm_rsh]
print @n.xbgr.xr83_u10.nr1[nsmm_w]
print @n.xbgr.xr83_u10.nr1[nsmm_l]
print @n.xbgr.xr83_u11.nr1[nsmm_rsh]
print @n.xbgr.xr83_u11.nr1[nsmm_w]
print @n.xbgr.xr83_u11.nr1[nsmm_l]
print @n.xbgr.xr83_u12.nr1[nsmm_rsh]
print @n.xbgr.xr83_u12.nr1[nsmm_w]
print @n.xbgr.xr83_u12.nr1[nsmm_l]
print @n.xbgr.xr83_u13.nr1[nsmm_rsh]
print @n.xbgr.xr83_u13.nr1[nsmm_w]
print @n.xbgr.xr83_u13.nr1[nsmm_l]
print @n.xbgr.xr83_u14.nr1[nsmm_rsh]
print @n.xbgr.xr83_u14.nr1[nsmm_w]
print @n.xbgr.xr83_u14.nr1[nsmm_l]
print @n.xbgr.xr83_u15.nr1[nsmm_rsh]
print @n.xbgr.xr83_u15.nr1[nsmm_w]
print @n.xbgr.xr83_u15.nr1[nsmm_l]
print @n.xbgr.xr83_u16.nr1[nsmm_rsh]
print @n.xbgr.xr83_u16.nr1[nsmm_w]
print @n.xbgr.xr83_u16.nr1[nsmm_l]
print @n.xbgr.xr83_u17.nr1[nsmm_rsh]
print @n.xbgr.xr83_u17.nr1[nsmm_w]
print @n.xbgr.xr83_u17.nr1[nsmm_l]
print @n.xbgr.xr83_u18.nr1[nsmm_rsh]
print @n.xbgr.xr83_u18.nr1[nsmm_w]
print @n.xbgr.xr83_u18.nr1[nsmm_l]
print @n.xbgr.xr83_u19.nr1[nsmm_rsh]
print @n.xbgr.xr83_u19.nr1[nsmm_w]
print @n.xbgr.xr83_u19.nr1[nsmm_l]
print @n.xbgr.xr83_u20.nr1[nsmm_rsh]
print @n.xbgr.xr83_u20.nr1[nsmm_w]
print @n.xbgr.xr83_u20.nr1[nsmm_l]
print @n.xbgr.xr83_u21.nr1[nsmm_rsh]
print @n.xbgr.xr83_u21.nr1[nsmm_w]
print @n.xbgr.xr83_u21.nr1[nsmm_l]
print @n.xbgr.xr83_u22.nr1[nsmm_rsh]
print @n.xbgr.xr83_u22.nr1[nsmm_w]
print @n.xbgr.xr83_u22.nr1[nsmm_l]
print @n.xbgr.xr83_u23.nr1[nsmm_rsh]
print @n.xbgr.xr83_u23.nr1[nsmm_w]
print @n.xbgr.xr83_u23.nr1[nsmm_l]
print @n.xbgr.xr83_u24.nr1[nsmm_rsh]
print @n.xbgr.xr83_u24.nr1[nsmm_w]
print @n.xbgr.xr83_u24.nr1[nsmm_l]
print @n.xbgr.xr84_u2.nr1[nsmm_rsh]
print @n.xbgr.xr84_u2.nr1[nsmm_w]
print @n.xbgr.xr84_u2.nr1[nsmm_l]
print @n.xbgr.xr84_u3.nr1[nsmm_rsh]
print @n.xbgr.xr84_u3.nr1[nsmm_w]
print @n.xbgr.xr84_u3.nr1[nsmm_l]
print @n.xbgr.xr84_u4.nr1[nsmm_rsh]
print @n.xbgr.xr84_u4.nr1[nsmm_w]
print @n.xbgr.xr84_u4.nr1[nsmm_l]
print @n.xbgr.xr84_u5.nr1[nsmm_rsh]
print @n.xbgr.xr84_u5.nr1[nsmm_w]
print @n.xbgr.xr84_u5.nr1[nsmm_l]
print @n.xbgr.xr84_u6.nr1[nsmm_rsh]
print @n.xbgr.xr84_u6.nr1[nsmm_w]
print @n.xbgr.xr84_u6.nr1[nsmm_l]
print @n.xbgr.xr84_u7.nr1[nsmm_rsh]
print @n.xbgr.xr84_u7.nr1[nsmm_w]
print @n.xbgr.xr84_u7.nr1[nsmm_l]
print @n.xbgr.xr84_u8.nr1[nsmm_rsh]
print @n.xbgr.xr84_u8.nr1[nsmm_w]
print @n.xbgr.xr84_u8.nr1[nsmm_l]
print @n.xbgr.xr84_u9.nr1[nsmm_rsh]
print @n.xbgr.xr84_u9.nr1[nsmm_w]
print @n.xbgr.xr84_u9.nr1[nsmm_l]
print @n.xbgr.xr84_u10.nr1[nsmm_rsh]
print @n.xbgr.xr84_u10.nr1[nsmm_w]
print @n.xbgr.xr84_u10.nr1[nsmm_l]
print @n.xbgr.xr84_u11.nr1[nsmm_rsh]
print @n.xbgr.xr84_u11.nr1[nsmm_w]
print @n.xbgr.xr84_u11.nr1[nsmm_l]
print @n.xbgr.xr84_u12.nr1[nsmm_rsh]
print @n.xbgr.xr84_u12.nr1[nsmm_w]
print @n.xbgr.xr84_u12.nr1[nsmm_l]
print @n.xbgr.xr84_u13.nr1[nsmm_rsh]
print @n.xbgr.xr84_u13.nr1[nsmm_w]
print @n.xbgr.xr84_u13.nr1[nsmm_l]
print @n.xbgr.xr84_u14.nr1[nsmm_rsh]
print @n.xbgr.xr84_u14.nr1[nsmm_w]
print @n.xbgr.xr84_u14.nr1[nsmm_l]
print @n.xbgr.xr84_u15.nr1[nsmm_rsh]
print @n.xbgr.xr84_u15.nr1[nsmm_w]
print @n.xbgr.xr84_u15.nr1[nsmm_l]
print @n.xbgr.xr84_u16.nr1[nsmm_rsh]
print @n.xbgr.xr84_u16.nr1[nsmm_w]
print @n.xbgr.xr84_u16.nr1[nsmm_l]
print @n.xbgr.xr84_u17.nr1[nsmm_rsh]
print @n.xbgr.xr84_u17.nr1[nsmm_w]
print @n.xbgr.xr84_u17.nr1[nsmm_l]
print @n.xbgr.xr84_u18.nr1[nsmm_rsh]
print @n.xbgr.xr84_u18.nr1[nsmm_w]
print @n.xbgr.xr84_u18.nr1[nsmm_l]
print @n.xbgr.xr84_u19.nr1[nsmm_rsh]
print @n.xbgr.xr84_u19.nr1[nsmm_w]
print @n.xbgr.xr84_u19.nr1[nsmm_l]
print @n.xbgr.xr84_u20.nr1[nsmm_rsh]
print @n.xbgr.xr84_u20.nr1[nsmm_w]
print @n.xbgr.xr84_u20.nr1[nsmm_l]
print @n.xbgr.xr84_u21.nr1[nsmm_rsh]
print @n.xbgr.xr84_u21.nr1[nsmm_w]
print @n.xbgr.xr84_u21.nr1[nsmm_l]
print @n.xbgr.xr84_u22.nr1[nsmm_rsh]
print @n.xbgr.xr84_u22.nr1[nsmm_w]
print @n.xbgr.xr84_u22.nr1[nsmm_l]
print @n.xbgr.xr84_u23.nr1[nsmm_rsh]
print @n.xbgr.xr84_u23.nr1[nsmm_w]
print @n.xbgr.xr84_u23.nr1[nsmm_l]
print @n.xbgr.xr84_u24.nr1[nsmm_rsh]
print @n.xbgr.xr84_u24.nr1[nsmm_w]
print @n.xbgr.xr84_u24.nr1[nsmm_l]
print @n.xbgr.xr85_u2.nr1[nsmm_rsh]
print @n.xbgr.xr85_u2.nr1[nsmm_w]
print @n.xbgr.xr85_u2.nr1[nsmm_l]
print @n.xbgr.xr85_u3.nr1[nsmm_rsh]
print @n.xbgr.xr85_u3.nr1[nsmm_w]
print @n.xbgr.xr85_u3.nr1[nsmm_l]
print @n.xbgr.xr85_u4.nr1[nsmm_rsh]
print @n.xbgr.xr85_u4.nr1[nsmm_w]
print @n.xbgr.xr85_u4.nr1[nsmm_l]
print @n.xbgr.xr85_u5.nr1[nsmm_rsh]
print @n.xbgr.xr85_u5.nr1[nsmm_w]
print @n.xbgr.xr85_u5.nr1[nsmm_l]
print @n.xbgr.xr85_u6.nr1[nsmm_rsh]
print @n.xbgr.xr85_u6.nr1[nsmm_w]
print @n.xbgr.xr85_u6.nr1[nsmm_l]
print @n.xbgr.xr85_u7.nr1[nsmm_rsh]
print @n.xbgr.xr85_u7.nr1[nsmm_w]
print @n.xbgr.xr85_u7.nr1[nsmm_l]
print @n.xbgr.xr85_u8.nr1[nsmm_rsh]
print @n.xbgr.xr85_u8.nr1[nsmm_w]
print @n.xbgr.xr85_u8.nr1[nsmm_l]
print @n.xbgr.xr85_u9.nr1[nsmm_rsh]
print @n.xbgr.xr85_u9.nr1[nsmm_w]
print @n.xbgr.xr85_u9.nr1[nsmm_l]
print @n.xbgr.xr85_u10.nr1[nsmm_rsh]
print @n.xbgr.xr85_u10.nr1[nsmm_w]
print @n.xbgr.xr85_u10.nr1[nsmm_l]
print @n.xbgr.xr85_u11.nr1[nsmm_rsh]
print @n.xbgr.xr85_u11.nr1[nsmm_w]
print @n.xbgr.xr85_u11.nr1[nsmm_l]
print @n.xbgr.xr85_u12.nr1[nsmm_rsh]
print @n.xbgr.xr85_u12.nr1[nsmm_w]
print @n.xbgr.xr85_u12.nr1[nsmm_l]
print @n.xbgr.xr85_u13.nr1[nsmm_rsh]
print @n.xbgr.xr85_u13.nr1[nsmm_w]
print @n.xbgr.xr85_u13.nr1[nsmm_l]
print @n.xbgr.xr85_u14.nr1[nsmm_rsh]
print @n.xbgr.xr85_u14.nr1[nsmm_w]
print @n.xbgr.xr85_u14.nr1[nsmm_l]
print @n.xbgr.xr85_u15.nr1[nsmm_rsh]
print @n.xbgr.xr85_u15.nr1[nsmm_w]
print @n.xbgr.xr85_u15.nr1[nsmm_l]
print @n.xbgr.xr85_u16.nr1[nsmm_rsh]
print @n.xbgr.xr85_u16.nr1[nsmm_w]
print @n.xbgr.xr85_u16.nr1[nsmm_l]
print @n.xbgr.xr85_u17.nr1[nsmm_rsh]
print @n.xbgr.xr85_u17.nr1[nsmm_w]
print @n.xbgr.xr85_u17.nr1[nsmm_l]
print @n.xbgr.xr85_u18.nr1[nsmm_rsh]
print @n.xbgr.xr85_u18.nr1[nsmm_w]
print @n.xbgr.xr85_u18.nr1[nsmm_l]
print @n.xbgr.xr85_u19.nr1[nsmm_rsh]
print @n.xbgr.xr85_u19.nr1[nsmm_w]
print @n.xbgr.xr85_u19.nr1[nsmm_l]
print @n.xbgr.xr85_u20.nr1[nsmm_rsh]
print @n.xbgr.xr85_u20.nr1[nsmm_w]
print @n.xbgr.xr85_u20.nr1[nsmm_l]
print @n.xbgr.xr85_u21.nr1[nsmm_rsh]
print @n.xbgr.xr85_u21.nr1[nsmm_w]
print @n.xbgr.xr85_u21.nr1[nsmm_l]
print @n.xbgr.xr85_u22.nr1[nsmm_rsh]
print @n.xbgr.xr85_u22.nr1[nsmm_w]
print @n.xbgr.xr85_u22.nr1[nsmm_l]
print @n.xbgr.xr85_u23.nr1[nsmm_rsh]
print @n.xbgr.xr85_u23.nr1[nsmm_w]
print @n.xbgr.xr85_u23.nr1[nsmm_l]
print @n.xbgr.xr85_u24.nr1[nsmm_rsh]
print @n.xbgr.xr85_u24.nr1[nsmm_w]
print @n.xbgr.xr85_u24.nr1[nsmm_l]
print @n.xbgr.xr86_u2.nr1[nsmm_rsh]
print @n.xbgr.xr86_u2.nr1[nsmm_w]
print @n.xbgr.xr86_u2.nr1[nsmm_l]
print @n.xbgr.xr86_u3.nr1[nsmm_rsh]
print @n.xbgr.xr86_u3.nr1[nsmm_w]
print @n.xbgr.xr86_u3.nr1[nsmm_l]
print @n.xbgr.xr86_u4.nr1[nsmm_rsh]
print @n.xbgr.xr86_u4.nr1[nsmm_w]
print @n.xbgr.xr86_u4.nr1[nsmm_l]
print @n.xbgr.xr86_u5.nr1[nsmm_rsh]
print @n.xbgr.xr86_u5.nr1[nsmm_w]
print @n.xbgr.xr86_u5.nr1[nsmm_l]
print @n.xbgr.xr86_u6.nr1[nsmm_rsh]
print @n.xbgr.xr86_u6.nr1[nsmm_w]
print @n.xbgr.xr86_u6.nr1[nsmm_l]
print @n.xbgr.xr86_u7.nr1[nsmm_rsh]
print @n.xbgr.xr86_u7.nr1[nsmm_w]
print @n.xbgr.xr86_u7.nr1[nsmm_l]
print @n.xbgr.xr86_u8.nr1[nsmm_rsh]
print @n.xbgr.xr86_u8.nr1[nsmm_w]
print @n.xbgr.xr86_u8.nr1[nsmm_l]
print @n.xbgr.xr86_u9.nr1[nsmm_rsh]
print @n.xbgr.xr86_u9.nr1[nsmm_w]
print @n.xbgr.xr86_u9.nr1[nsmm_l]
print @n.xbgr.xr86_u10.nr1[nsmm_rsh]
print @n.xbgr.xr86_u10.nr1[nsmm_w]
print @n.xbgr.xr86_u10.nr1[nsmm_l]
print @n.xbgr.xr86_u11.nr1[nsmm_rsh]
print @n.xbgr.xr86_u11.nr1[nsmm_w]
print @n.xbgr.xr86_u11.nr1[nsmm_l]
print @n.xbgr.xr86_u12.nr1[nsmm_rsh]
print @n.xbgr.xr86_u12.nr1[nsmm_w]
print @n.xbgr.xr86_u12.nr1[nsmm_l]
print @n.xbgr.xr86_u13.nr1[nsmm_rsh]
print @n.xbgr.xr86_u13.nr1[nsmm_w]
print @n.xbgr.xr86_u13.nr1[nsmm_l]
print @n.xbgr.xr86_u14.nr1[nsmm_rsh]
print @n.xbgr.xr86_u14.nr1[nsmm_w]
print @n.xbgr.xr86_u14.nr1[nsmm_l]
print @n.xbgr.xr86_u15.nr1[nsmm_rsh]
print @n.xbgr.xr86_u15.nr1[nsmm_w]
print @n.xbgr.xr86_u15.nr1[nsmm_l]
print @n.xbgr.xr86_u16.nr1[nsmm_rsh]
print @n.xbgr.xr86_u16.nr1[nsmm_w]
print @n.xbgr.xr86_u16.nr1[nsmm_l]
print @n.xbgr.xr86_u17.nr1[nsmm_rsh]
print @n.xbgr.xr86_u17.nr1[nsmm_w]
print @n.xbgr.xr86_u17.nr1[nsmm_l]
print @n.xbgr.xr86_u18.nr1[nsmm_rsh]
print @n.xbgr.xr86_u18.nr1[nsmm_w]
print @n.xbgr.xr86_u18.nr1[nsmm_l]
print @n.xbgr.xr86_u19.nr1[nsmm_rsh]
print @n.xbgr.xr86_u19.nr1[nsmm_w]
print @n.xbgr.xr86_u19.nr1[nsmm_l]
print @n.xbgr.xr86_u20.nr1[nsmm_rsh]
print @n.xbgr.xr86_u20.nr1[nsmm_w]
print @n.xbgr.xr86_u20.nr1[nsmm_l]
print @n.xbgr.xr86_u21.nr1[nsmm_rsh]
print @n.xbgr.xr86_u21.nr1[nsmm_w]
print @n.xbgr.xr86_u21.nr1[nsmm_l]
print @n.xbgr.xr86_u22.nr1[nsmm_rsh]
print @n.xbgr.xr86_u22.nr1[nsmm_w]
print @n.xbgr.xr86_u22.nr1[nsmm_l]
print @n.xbgr.xr86_u23.nr1[nsmm_rsh]
print @n.xbgr.xr86_u23.nr1[nsmm_w]
print @n.xbgr.xr86_u23.nr1[nsmm_l]
print @n.xbgr.xr86_u24.nr1[nsmm_rsh]
print @n.xbgr.xr86_u24.nr1[nsmm_w]
print @n.xbgr.xr86_u24.nr1[nsmm_l]
set numdgt=17
echo METALLIC_POINT_VOLTAGES_BEGIN
print v(xbgr.mr_n73518944)
print v(xbgr.vd2)
print v(xbgr.mr_n72755552)
print v(xbgr.c2)
print v(xbgr.mr_n73807456)
print v(xbgr.mr_n73904560)
print v(xbgr.mr_n74025024)
print v(xbgr.mr_n74082656)
print v(xbgr.mr_n74261520)
print v(xbgr.mr_n74395776)
print v(xbgr.mr_n74571152)
print v(xbgr.mr_n74692000)
print v(xbgr.mr_n74864720)
print v(xbgr.mr_n74982928)
print v(xbgr.mr_n75008736)
print v(xbgr.mr_n75299536)
print v(xbgr.mr_n75388832)
print v(xbgr.mr_n75454832)
print v(xbgr.mr_n72122240)
print v(xbgr.mr_n76071088)
print v(xbgr.mr_n76241120)
print v(xbgr.mr_n76438864)
print v(xbgr.mr_n76604512)
print v(xbgr.mr_n76742608)
print v(xbgr.mr_n76952848)
print v(xbgr.mr_n77151840)
print v(xbgr.mr_n77362944)
print v(xbgr.mr_n74405872)
print v(xbgr.mr_n77448816)
print v(xbgr.mr_n77731600)
print v(xbgr.mr_n77924704)
print v(xbgr.mr_n78141152)
print v(xbgr.mr_n78322000)
print v(xbgr.mr_n78532480)
print v(xbgr.mr_n78832848)
print v(xbgr.mr_n79066576)
print v(xbgr.mr_n79399872)
print v(xbgr.mr_n73519392)
print v(xbgr.mr_n73582832)
print v(xbgr.b1b)
print v(xbgr.mr_n73661616)
print v(xbgr.mr_n73764512)
print v(xbgr.mr_n73861040)
print v(xbgr.mr_n73969792)
print v(xbgr.mr_n74084640)
print v(xbgr.mr_n74200320)
print v(xbgr.mr_n74536816)
print v(xbgr.mr_n74654400)
print v(xbgr.mr_n74785344)
print v(xbgr.mr_n74887472)
print v(xbgr.mr_n75061232)
print v(xbgr.mr_n75177440)
print v(xbgr.mr_n75330432)
print v(xbgr.mr_n75580016)
print v(xbgr.mr_n73554208)
print v(xbgr.mr_n73615712)
print v(xbgr.mr_n72984080)
print v(xbgr.mr_n73753216)
print v(xbgr.mr_n73852848)
print v(xbgr.mr_n73968624)
print v(xbgr.mr_n74027680)
print v(xbgr.mr_n74178160)
print v(xbgr.mr_n74280800)
print v(xbgr.mr_n74395104)
print v(xbgr.mr_n74456336)
print v(xbgr.mr_n74702096)
print v(xbgr.mr_n74857200)
print v(xbgr.mr_n74983040)
print v(xbgr.mr_n75185808)
print v(xbgr.mr_n75302352)
print v(xbgr.mr_n75408880)
print v(xbgr.mr_n75581648)
print v(xbgr.mr_n72788256)
print v(xbgr.mr_n73053008)
print v(xbgr.n_13)
print v(xbgr.n_24)
print v(xbgr.mr_n72786384)
print v(xbgr.mr_n73054912)
print v(xbgr.n_14)
print v(xbgr.mr_n73396640)
print v(xbgr.mr_n73512704)
print v(xbgr.mr_n73583024)
print v(xbgr.mr_n72727392)
print v(xbgr.mr_n73731056)
print v(xbgr.mr_n73810128)
print v(xbgr.mr_n73890048)
print v(xbgr.mr_n73966256)
print v(xbgr.vd1)
print v(xbgr.mr_n74262464)
print v(xbgr.mr_n74358256)
print v(xbgr.mr_n74505248)
print v(xbgr.mr_n74631792)
print v(xbgr.mr_n74863904)
print v(xbgr.mr_n74986560)
print v(xbgr.mr_n75096544)
print v(xbgr.mr_n75233280)
print v(xbgr.mr_n75389424)
print v(xbgr.mr_n75580352)
print v(xbgr.mr_n75921376)
print v(xbgr.mr_n76068560)
print v(xbgr.mr_n76245264)
print v(xbgr.mr_n76439056)
print v(xbgr.mr_n76550992)
print v(xbgr.mr_n76789104)
print v(xbgr.mr_n76991072)
print v(xbgr.mr_n77153008)
print v(xbgr.mr_n77367392)
print v(xbgr.mr_n74396112)
print v(xbgr.mr_n77454352)
print v(xbgr.mr_n77710048)
print v(xbgr.mr_n77940624)
print v(xbgr.mr_n78142272)
print v(xbgr.mr_n78329552)
print v(xbgr.mr_n78532832)
print v(xbgr.mr_n78818704)
print v(xbgr.mr_n79070400)
print v(xbgr.mr_n79402704)
print v(xbgr.mr_n73519968)
print v(xbgr.mr_n73583968)
print v(xbgr.mr_n72830544)
print v(xbgr.mr_n73692384)
print v(xbgr.mr_n73765904)
print v(xbgr.mr_n73861312)
print v(xbgr.mr_n73806544)
print v(xbgr.mr_n74141248)
print v(xbgr.mr_n74202320)
print v(xbgr.mr_n74538208)
print v(xbgr.mr_n74655792)
print v(xbgr.mr_n74786736)
print v(xbgr.mr_n74935088)
print v(xbgr.mr_n75062688)
print v(xbgr.mr_n75004736)
print v(xbgr.mr_n75324896)
print v(xbgr.mr_n75579680)
print v(xbgr.mr_n72789184)
print v(xbgr.mr_n73055344)
print v(xbgr.mr_n73282304)
print v(xbgr.n_26)
print v(xbgr.mr_n72788720)
print v(xbgr.mr_n73055776)
print v(xbgr.n_15)
print v(xbgr.mr_n73398080)
print v(xbgr.mr_n73555664)
print v(xbgr.mr_n73616352)
print v(xbgr.mr_n72800448)
print v(xbgr.mr_n73754736)
print v(xbgr.mr_n73853648)
print v(xbgr.mr_n73969392)
print v(xbgr.mr_n73904368)
print v(xbgr.mr_n74173152)
print v(xbgr.mr_n74282384)
print v(xbgr.mr_n74395440)
print v(xbgr.mr_n74584112)
print v(xbgr.mr_n74703952)
print v(xbgr.mr_n74878848)
print v(xbgr.mr_n75000112)
print v(xbgr.mr_n75187024)
print v(xbgr.mr_n75300128)
print v(xbgr.mr_n75388240)
print v(xbgr.mr_n75454288)
print v(xbgr.mr_n72790112)
print v(xbgr.mr_n73056288)
print v(xbgr.mr_n73283232)
print v(xbgr.n_27)
print v(xbgr.mr_n72789648)
print v(xbgr.mr_n73056880)
print v(xbgr.n_16)
print v(xbgr.mr_n73399520)
print v(xbgr.mr_n72791040)
print v(xbgr.mr_n73057472)
print v(xbgr.mr_n73283696)
print v(xbgr.n_21)
print v(xbgr.mr_n73525728)
print v(xbgr.mr_n73582640)
print v(xbgr.mr_n72768928)
print v(xbgr.mr_n73754000)
print v(xbgr.mr_n73683824)
print v(xbgr.mr_n73905264)
print v(xbgr.mr_n74024688)
print v(xbgr.mr_n74138768)
print v(xbgr.mr_n74265088)
print v(xbgr.mr_n74508208)
print v(xbgr.mr_n74692448)
print v(xbgr.mr_n74878672)
print v(xbgr.mr_n74999936)
print v(xbgr.mr_n75094128)
print v(xbgr.mr_n75239232)
print v(xbgr.mr_n75408224)
print v(xbgr.mr_n75452656)
print v(xbgr.mr_n72790576)
print v(xbgr.mr_n73058064)
print v(xbgr.mr_n75935216)
print v(xbgr.mr_n76106256)
print v(xbgr.mr_n76318624)
print v(xbgr.mr_n76431232)
print v(xbgr.mr_n76605760)
print v(xbgr.mr_n76777280)
print v(xbgr.mr_n76949072)
print v(xbgr.mr_n77138240)
print v(xbgr.mr_n77372048)
print v(xbgr.mr_n77729024)
print v(xbgr.mr_n77940112)
print v(xbgr.mr_n78147872)
print v(xbgr.mr_n78342656)
print v(xbgr.mr_n78641888)
print v(xbgr.mr_n78833040)
print v(xbgr.mr_n79046016)
print v(xbgr.mr_n79413920)
print v(xbgr.mr_n73519584)
print v(xbgr.mr_n73602288)
print v(xbgr.mr_n72683632)
print v(xbgr.mr_n73693776)
print v(xbgr.mr_n73767296)
print v(xbgr.mr_n73861920)
print v(xbgr.mr_n74006416)
print v(xbgr.mr_n74139280)
print v(xbgr.mr_n74216112)
print v(xbgr.mr_n74537744)
print v(xbgr.mr_n74657184)
print v(xbgr.mr_n74788128)
print v(xbgr.mr_n74936864)
print v(xbgr.mr_n75064464)
print v(xbgr.mr_n75179232)
print v(xbgr.mr_n75358816)
print v(xbgr.mr_n75582240)
print v(xbgr.mr_n72791968)
print v(xbgr.mr_n73058656)
print v(xbgr.n_8)
print v(xbgr.vbe3)
print v(xbgr.mr_n73557120)
print v(xbgr.mr_n73616752)
print v(xbgr.mr_n73308912)
print v(xbgr.mr_n73755696)
print v(xbgr.mr_n73854448)
print v(xbgr.mr_n73965584)
print v(xbgr.mr_n74026688)
print v(xbgr.mr_n74180224)
print v(xbgr.mr_n74283264)
print v(xbgr.mr_n74460336)
print v(xbgr.mr_n74705760)
print v(xbgr.mr_n74879648)
print v(xbgr.mr_n75000912)
print v(xbgr.mr_n75188624)
print v(xbgr.mr_n75255776)
print v(xbgr.mr_n75391200)
print v(xbgr.mr_n75580688)
print v(xbgr.mr_n72791504)
print v(xbgr.mr_n73059840)
print v(xbgr.mr_n73132288)
print v(xbgr.mr_n72947392)
print v(xbgr.mr_n72792896)
print v(xbgr.mr_n73061616)
print v(xbgr.mr_n73132528)
print v(xbgr.n_37)
print v(xbgr.mr_n72792432)
print v(xbgr.mr_n73063392)
print v(xbgr.mr_n73132768)
print v(xbgr.mr_n73399408)
print v(xbgr.n_6)
print v(xbgr.vb2)
print v(xbgr.n_2)
print v(xbgr.mr_n73446416)
print v(xbgr.mr_n73524672)
print v(xbgr.mr_n73602992)
print v(xbgr.mr_n72712704)
print v(xbgr.mr_n73704672)
print v(xbgr.mr_n73813488)
print v(xbgr.mr_n73932240)
print v(xbgr.mr_n74030880)
print v(xbgr.mr_n74021696)
print v(xbgr.mr_n74261712)
print v(xbgr.mr_n74580000)
print v(xbgr.mr_n74663040)
print v(xbgr.mr_n74863488)
print v(xbgr.mr_n74986144)
print v(xbgr.mr_n75163696)
print v(xbgr.mr_n75305120)
print v(xbgr.mr_n75390016)
print v(xbgr.mr_n75582352)
print v(xbgr.mr_n75689072)
print v(xbgr.mr_n76089696)
print v(xbgr.mr_n76321072)
print v(xbgr.mr_n76420528)
print v(xbgr.mr_n76548464)
print v(xbgr.mr_n76800240)
print v(xbgr.mr_n76950016)
print v(xbgr.mr_n77151952)
print v(xbgr.mr_n77385152)
print v(xbgr.mr_n77728256)
print v(xbgr.mr_n77930896)
print v(xbgr.mr_n78152736)
print v(xbgr.mr_n78339664)
print v(xbgr.mr_n78643632)
print v(xbgr.mr_n78851328)
print v(xbgr.mr_n79066000)
print v(xbgr.mr_n79401760)
print v(xbgr.mr_n72895344)
print v(xbgr.mr_n72930224)
print v(xbgr.mr_n73133248)
print v(xbgr.mr_n73447008)
print v(xbgr.mr_n73526640)
print v(xbgr.mr_n73603344)
print v(xbgr.mr_n73006272)
print v(xbgr.mr_n73695168)
print v(xbgr.mr_n73768688)
print v(xbgr.mr_n73877152)
print v(xbgr.mr_n74007568)
print v(xbgr.mr_n74085856)
print v(xbgr.mr_n74217504)
print v(xbgr.mr_n74537280)
print v(xbgr.mr_n74658896)
print v(xbgr.mr_n74789840)
print v(xbgr.mr_n74938640)
print v(xbgr.mr_n75066240)
print v(xbgr.mr_n75183696)
print v(xbgr.mr_n75360208)
print v(xbgr.mr_n75584304)
print v(xbgr.mr_n72896080)
print v(xbgr.mr_n72903536)
print v(xbgr.n_7)
print v(xbgr.n_36)
print v(xbgr.mr_n73558176)
print v(xbgr.mr_n73614720)
print v(xbgr.mr_n72924656)
print v(xbgr.mr_n73756576)
print v(xbgr.mr_n73855248)
print v(xbgr.mr_n73966592)
print v(xbgr.mr_n74032752)
print v(xbgr.mr_n74180784)
print v(xbgr.mr_n74284064)
print v(xbgr.mr_n74587728)
print v(xbgr.mr_n74629984)
print v(xbgr.mr_n74880448)
print v(xbgr.mr_n75001712)
print v(xbgr.mr_n75189968)
print v(xbgr.mr_n75305008)
print v(xbgr.mr_n75411200)
print v(xbgr.mr_n75582464)
print v(xbgr.mr_n72896816)
print v(xbgr.mr_n72931408)
print v(xbgr.mr_n73133888)
print v(xbgr.mr_n73448192)
print v(xbgr.mr_n72897552)
print v(xbgr.mr_n72932080)
print v(xbgr.mr_n73134288)
print v(xbgr.mr_n73448784)
print v(xbgr.mr_n72898288)
print v(xbgr.mr_n72928688)
print v(xbgr.mr_n73134688)
print v(xbgr.mr_n73449376)
print v(xbgr.mr_n72899024)
print v(xbgr.mr_n72933184)
print v(xbgr.mr_n73135088)
print v(xbgr.mr_n73449968)
print v(xbgr.mr_n73519776)
print v(xbgr.mr_n73604048)
print v(xbgr.mr_n73039088)
print v(xbgr.mr_n73755264)
print v(xbgr.mr_n73814816)
print v(xbgr.mr_n73933040)
print v(xbgr.mr_n74030768)
print v(xbgr.mr_n74011552)
print v(xbgr.mr_n74283088)
print v(xbgr.mr_n74580336)
print v(xbgr.mr_n74706352)
print v(xbgr.mr_n74880272)
print v(xbgr.mr_n74987376)
print v(xbgr.mr_n75164880)
print v(xbgr.mr_n75306816)
print v(xbgr.mr_n75409504)
print v(xbgr.mr_n75586592)
print v(xbgr.mr_n75935024)
print v(xbgr.mr_n76106720)
print v(xbgr.mr_n72093360)
print v(xbgr.mr_n76444848)
print v(xbgr.mr_n76607728)
print v(xbgr.mr_n76788640)
print v(xbgr.mr_n77005504)
print v(xbgr.mr_n77158816)
print v(xbgr.mr_n77382160)
print v(xbgr.mr_n77736864)
print v(xbgr.mr_n77951824)
print v(xbgr.mr_n78157168)
print v(xbgr.mr_n78344480)
print v(xbgr.mr_n78649312)
print v(xbgr.mr_n78834096)
print v(xbgr.mr_n79069872)
print v(xbgr.mr_n79414688)
print v(xbgr.mr_n73530720)
print v(xbgr.mr_n73604400)
print v(xbgr.mr_n73034000)
print v(xbgr.mr_n73696560)
print v(xbgr.mr_n73770080)
print v(xbgr.mr_n73879872)
print v(xbgr.mr_n74008960)
print v(xbgr.mr_n74166912)
print v(xbgr.mr_n74218896)
print v(xbgr.mr_n74507328)
print v(xbgr.mr_n74660672)
print v(xbgr.mr_n74791616)
print v(xbgr.mr_n74940416)
print v(xbgr.mr_n75068016)
print v(xbgr.mr_n75189136)
print v(xbgr.mr_n75361728)
print v(xbgr.mr_n75584416)
print v(xbgr.mr_n72899536)
print v(xbgr.mr_n72930896)
print v(xbgr.mr_n73135488)
print v(xbgr.mr_n73451152)
print v(xbgr.mr_n72900080)
print v(xbgr.mr_n72934368)
print v(xbgr.n_11)
print v(xbgr.mr_n73277184)
print v(xbgr.mr_n73559952)
print v(xbgr.mr_n73617552)
print v(xbgr.mr_n73042112)
print v(xbgr.mr_n73731728)
print v(xbgr.mr_n73856048)
print v(xbgr.mr_n73970592)
print v(xbgr.mr_n74036704)
print v(xbgr.mr_n74181600)
print v(xbgr.mr_n74284864)
print v(xbgr.mr_n74589792)
print v(xbgr.mr_n74702736)
print v(xbgr.mr_n74881248)
print v(xbgr.mr_n75002512)
print v(xbgr.mr_n75192112)
print v(xbgr.mr_n75303136)
print v(xbgr.mr_n75413008)
print v(xbgr.mr_n75453744)
print v(xbgr.mr_n72900576)
print v(xbgr.mr_n72935040)
print v(xbgr.mr_n73216032)
print v(xbgr.mr_n73451744)
print v(xbgr.mr_n72901632)
print v(xbgr.mr_n72932672)
print v(xbgr.mr_n73216624)
print v(xbgr.mr_n73452336)
print v(xbgr.mr_n72901904)
print v(xbgr.mr_n72936144)
print v(xbgr.mr_n73217216)
print v(xbgr.mr_n73444704)
print v(xbgr.mr_n73524976)
print v(xbgr.mr_n73605104)
print v(xbgr.mr_n72961888)
print v(xbgr.mr_n73758640)
print v(xbgr.mr_n73819632)
print v(xbgr.mr_n73933840)
print v(xbgr.mr_n74033776)
print v(xbgr.mr_n74166576)
print v(xbgr.mr_n74265840)
print v(xbgr.mr_n74584704)
print v(xbgr.mr_n74459344)
print v(xbgr.mr_n74842976)
print v(xbgr.mr_n75002336)
print v(xbgr.mr_n75166064)
print v(xbgr.mr_n75303248)
print v(xbgr.mr_n75411312)
print v(xbgr.mr_n75588432)
print v(xbgr.n_9)
print v(xbgr.mr_n72936816)
print v(xbgr.mr_n73217808)
print v(xbgr.mr_n73453520)
print v(xbgr.mr_n75939376)
print v(xbgr.mr_n76069824)
print v(xbgr.mr_n76323152)
print v(xbgr.mr_n76441936)
print v(xbgr.mr_n76604704)
print v(xbgr.mr_n76811376)
print v(xbgr.mr_n77010512)
print v(xbgr.mr_n77153120)
print v(xbgr.mr_n77386976)
print v(xbgr.mr_n77779200)
print v(xbgr.mr_n77951312)
print v(xbgr.mr_n78162144)
print v(xbgr.mr_n78349456)
print v(xbgr.mr_n78661792)
print v(xbgr.mr_n78849104)
print v(xbgr.mr_n79093904)
print v(xbgr.mr_n79310368)
print v(xbgr.mr_n73531632)
print v(xbgr.mr_n73605456)
print v(xbgr.mr_n72758368)
print v(xbgr.mr_n73697952)
print v(xbgr.mr_n73771472)
print v(xbgr.mr_n73882416)
print v(xbgr.mr_n74010352)
print v(xbgr.mr_n74169216)
print v(xbgr.mr_n74220288)
print v(xbgr.mr_n74571344)
print v(xbgr.mr_n74662448)
print v(xbgr.mr_n74793392)
print v(xbgr.mr_n74942192)
print v(xbgr.mr_n75069792)
print v(xbgr.mr_n75190592)
print v(xbgr.mr_n75363504)
print v(xbgr.mr_n75590496)
print v(xbgr.mr_n72902992)
print v(xbgr.mr_n72937408)
print v(xbgr.mr_n73218400)
print v(xbgr.mr_n73442256)
print v(xbgr.mr_n73561088)
print v(xbgr.mr_n73617952)
print v(xbgr.mr_n73008096)
print v(xbgr.mr_n73758816)
print v(xbgr.mr_n73856768)
print v(xbgr.mr_n73970992)
print v(xbgr.mr_n74028624)
print v(xbgr.mr_n74182480)
print v(xbgr.mr_n74285664)
print v(xbgr.mr_n74591936)
print v(xbgr.mr_n74708624)
print v(xbgr.mr_n74882048)
print v(xbgr.mr_n75003312)
print v(xbgr.mr_n75193712)
print v(xbgr.mr_n75308624)
print v(xbgr.mr_n75409392)
print v(xbgr.mr_n75584528)
print v(xbgr.mr_n72900464)
print v(xbgr.mr_n72913056)
print v(xbgr.mr_n73218992)
print v(xbgr.mr_n73454704)
print v(xbgr.mr_n72904080)
print v(xbgr.mr_n72935632)
print v(xbgr.mr_n73219584)
print v(xbgr.mr_n73455296)
print v(xbgr.mr_n72904624)
print v(xbgr.mr_n72939104)
print v(xbgr.mr_n73207440)
print v(xbgr.mr_n73455888)
print v(xbgr.mr_n72905168)
print v(xbgr.mr_n72933856)
print v(xbgr.mr_n73210768)
print v(xbgr.mr_n73456480)
print v(xbgr.mr_n73529664)
print v(xbgr.mr_n73606160)
print v(xbgr.mr_n73370224)
print v(xbgr.mr_n73760000)
print v(xbgr.mr_n73820960)
print v(xbgr.mr_n73934704)
print v(xbgr.mr_n74039808)
print v(xbgr.mr_n74167248)
print v(xbgr.mr_n74283888)
print v(xbgr.mr_n74590384)
print v(xbgr.mr_n74573104)
print v(xbgr.mr_n74881872)
print v(xbgr.mr_n74982576)
print v(xbgr.mr_n75167248)
print v(xbgr.mr_n75308736)
print v(xbgr.mr_n75416736)
print v(xbgr.mr_n75588544)
print v(xbgr.mr_n75943312)
print v(xbgr.mr_n76113360)
print v(xbgr.mr_n76345072)
print v(xbgr.mr_n76473952)
print v(xbgr.mr_n76605648)
print v(xbgr.mr_n76799776)
print v(xbgr.mr_n77005696)
print v(xbgr.mr_n77167984)
print v(xbgr.mr_n77400080)
print v(xbgr.mr_n77761920)
print v(xbgr.mr_n77961552)
print v(xbgr.mr_n78167040)
print v(xbgr.mr_n78354544)
print v(xbgr.mr_n78661680)
print v(xbgr.mr_n78845376)
print v(xbgr.mr_n78955728)
print v(xbgr.mr_n79313184)
print v(xbgr.mr_n72905712)
print v(xbgr.mr_n72940288)
print v(xbgr.mr_n72787200)
print v(xbgr.mr_n73457072)
print v(xbgr.mr_n73535712)
print v(xbgr.mr_n73606512)
print v(xbgr.mr_n72759776)
print v(xbgr.mr_n73699344)
print v(xbgr.mr_n73771008)
print v(xbgr.mr_n73884784)
print v(xbgr.mr_n74009888)
print v(xbgr.mr_n74170528)
print v(xbgr.mr_n74221680)
print v(xbgr.mr_n74582368)
print v(xbgr.mr_n74661856)
print v(xbgr.mr_n74792800)
print v(xbgr.mr_n74943968)
print v(xbgr.mr_n75069200)
print v(xbgr.mr_n75194224)
print v(xbgr.mr_n75365280)
print v(xbgr.mr_n75588656)
print v(xbgr.mr_n72906528)
print v(xbgr.mr_n72940960)
print v(xbgr.mr_n73220416)
print v(xbgr.mr_n73457664)
print v(xbgr.mr_n73562944)
print v(xbgr.mr_n73618352)
print v(xbgr.mr_n73626816)
print v(xbgr.mr_n73760176)
print v(xbgr.mr_n73857568)
print v(xbgr.mr_n73971392)
print v(xbgr.mr_n74041904)
print v(xbgr.mr_n74183456)
print v(xbgr.mr_n74286464)
print v(xbgr.mr_n74593920)
print v(xbgr.mr_n74711760)
print v(xbgr.mr_n74882848)
print v(xbgr.mr_n75004112)
print v(xbgr.mr_n75195376)
print v(xbgr.mr_n75238416)
print v(xbgr.mr_n75416624)
print v(xbgr.mr_n75586368)
print v(xbgr.mr_n72902720)
print v(xbgr.mr_n72941552)
print v(xbgr.n_3)
print v(xbgr.n_33)
print v(xbgr.mr_n72907344)
print v(xbgr.mr_n72942144)
print v(xbgr.mr_n73222128)
print v(xbgr.mr_n73458848)
print v(xbgr.mr_n72907952)
print v(xbgr.mr_n72939776)
print v(xbgr.mr_n73222720)
print v(xbgr.mr_n73459440)
print v(xbgr.mr_n72909344)
print v(xbgr.mr_n72943248)
print v(xbgr.mr_n73223312)
print v(xbgr.mr_n73460032)
print v(xbgr.mr_n73527392)
print v(xbgr.mr_n73610512)
print v(xbgr.mr_n72724864)
print v(xbgr.mr_n73756400)
print v(xbgr.mr_n73825776)
print v(xbgr.mr_n73935888)
print v(xbgr.mr_n74037600)
print v(xbgr.mr_n74169696)
print v(xbgr.mr_n74286288)
print v(xbgr.mr_n74453088)
print v(xbgr.mr_n74592448)
print v(xbgr.mr_n74694864)
print v(xbgr.mr_n74881072)
print v(xbgr.mr_n75000736)
print v(xbgr.mr_n75168432)
print v(xbgr.mr_n75306928)
print v(xbgr.mr_n75407888)
print v(xbgr.mr_n75594624)
print v(xbgr.mr_n75941056)
print v(xbgr.mr_n76135792)
print v(xbgr.mr_n76339328)
print v(xbgr.mr_n76470832)
print v(xbgr.mr_n76617072)
print v(xbgr.mr_n76822512)
print v(xbgr.mr_n77023088)
print v(xbgr.mr_n77187328)
print v(xbgr.mr_n77397088)
print v(xbgr.mr_n77567792)
print v(xbgr.mr_n77760592)
print v(xbgr.mr_n77973264)
print v(xbgr.mr_n78169488)
print v(xbgr.mr_n78356592)
print v(xbgr.mr_n78657568)
print v(xbgr.mr_n78840720)
print v(xbgr.mr_n79069360)
print v(xbgr.mr_n79300320)
print v(xbgr.mr_n73536624)
print v(xbgr.mr_n73582016)
print v(xbgr.mr_n73013872)
print v(xbgr.mr_n73699808)
print v(xbgr.mr_n73770544)
print v(xbgr.mr_n73893920)
print v(xbgr.mr_n74009424)
print v(xbgr.mr_n74171840)
print v(xbgr.mr_n74223072)
print v(xbgr.mr_n74453280)
print v(xbgr.mr_n74593344)
print v(xbgr.mr_n74661264)
print v(xbgr.mr_n74792208)
print v(xbgr.mr_n74945744)
print v(xbgr.mr_n75068608)
print v(xbgr.mr_n75193296)
print v(xbgr.mr_n75367056)
print v(xbgr.mr_n75592672)
print v(xbgr.mr_n72909808)
print v(xbgr.n_19)
print v(xbgr.mr_n73223904)
print v(xbgr.mr_n73460624)
print v(xbgr.mr_n73564400)
print v(xbgr.mr_n73618752)
print v(xbgr.mr_n73629424)
print v(xbgr.mr_n73758464)
print v(xbgr.mr_n73858368)
print v(xbgr.mr_n73971792)
print v(xbgr.mr_n74044768)
print v(xbgr.mr_n74184912)
print v(xbgr.mr_n74287264)
print v(xbgr.mr_n74463616)
print v(xbgr.mr_n74595984)
print v(xbgr.mr_n74713568)
print v(xbgr.mr_n74883648)
print v(xbgr.mr_n75004912)
print v(xbgr.mr_n75196576)
print v(xbgr.mr_n75312352)
print v(xbgr.mr_n75413120)
print v(xbgr.mr_n75592560)
print v(xbgr.mr_n72910736)
print v(xbgr.mr_n72938512)
print v(xbgr.mr_n73224496)
print v(xbgr.mr_n73442144)
print v(xbgr.mr_n72911664)
print v(xbgr.mr_n72945024)
print v(xbgr.mr_n73225088)
print v(xbgr.mr_n73461808)
print v(xbgr.mr_n72906800)
print v(xbgr.mr_n72945696)
print v(xbgr.mr_n73225680)
print v(xbgr.mr_n73400128)
print v(xbgr.mr_n72884256)
print v(xbgr.mr_n72946288)
print v(xbgr.mr_n73226272)
print v(xbgr.mr_n73462992)
print v(xbgr.mr_n73532384)
print v(xbgr.mr_n73615056)
print v(xbgr.mr_n73012112)
print v(xbgr.mr_n72734432)
print v(xbgr.mr_n73827104)
print v(xbgr.mr_n73937072)
print v(xbgr.mr_n74044208)
print v(xbgr.mr_n74170352)
print v(xbgr.mr_n74226976)
print v(xbgr.mr_n74453984)
print v(xbgr.mr_n74585920)
print v(xbgr.mr_n74629104)
print v(xbgr.mr_n74879472)
print v(xbgr.mr_n74976256)
print v(xbgr.mr_n75169024)
print v(xbgr.mr_n75310432)
print v(xbgr.mr_n75418432)
print v(xbgr.mr_n75596688)
print v(xbgr.mr_n72912128)
print v(xbgr.mr_n72938000)
print v(xbgr.mr_n73226864)
print v(xbgr.mr_n73463584)
print v(xbgr.mr_n75937760)
print v(xbgr.mr_n76140576)
print v(xbgr.mr_n76334400)
print v(xbgr.mr_n76479072)
print v(xbgr.mr_n76626384)
print v(xbgr.mr_n76817072)
print v(xbgr.mr_n76979936)
print v(xbgr.mr_n77177312)
print v(xbgr.mr_n77301904)
print v(xbgr.mr_n77570992)
print v(xbgr.mr_n77756528)
print v(xbgr.mr_n77972752)
print v(xbgr.mr_n78164592)
print v(xbgr.mr_n78361360)
print v(xbgr.mr_n78681584)
print v(xbgr.mr_n78841184)
print v(xbgr.mr_n79070208)
print v(xbgr.mr_n79262832)
print v(xbgr.mr_n73540704)
print v(xbgr.mr_n73581744)
print v(xbgr.mr_n73036896)
print v(xbgr.mr_n73698880)
print v(xbgr.mr_n73769616)
print v(xbgr.mr_n73887328)
print v(xbgr.mr_n74008496)
print v(xbgr.mr_n74172496)
print v(xbgr.mr_n74259536)
print v(xbgr.mr_n74422928)
print v(xbgr.mr_n74538672)
print v(xbgr.mr_n74660080)
print v(xbgr.mr_n74791024)
print v(xbgr.mr_n74947520)
print v(xbgr.mr_n75067424)
print v(xbgr.mr_n75197280)
print v(xbgr.mr_n75368832)
print v(xbgr.mr_n75592784)
print v(xbgr.mr_n72911200)
print v(xbgr.mr_n72944512)
print v(xbgr.mr_n73227456)
print v(xbgr.mr_n73464176)
print v(xbgr.mr_n73565456)
print v(xbgr.mr_n73614384)
print v(xbgr.mr_n73632112)
print v(xbgr.mr_n73003840)
print v(xbgr.mr_n73858768)
print v(xbgr.mr_n73972192)
print v(xbgr.mr_n74047248)
print v(xbgr.mr_n74185792)
print v(xbgr.mr_n74288064)
print v(xbgr.mr_n74466912)
print v(xbgr.mr_n74598048)
print v(xbgr.mr_n74715216)
print v(xbgr.mr_n74882672)
print v(xbgr.mr_n75005712)
print v(xbgr.mr_n75189632)
print v(xbgr.mr_n75310544)
print v(xbgr.mr_n75414816)
print v(xbgr.mr_n75586480)
print v(xbgr.mr_n72910272)
print v(xbgr.mr_n72947984)
print v(xbgr.mr_n73228048)
print v(xbgr.mr_n73464768)
print v(xbgr.mr_n72908880)
print v(xbgr.mr_n72948656)
print v(xbgr.n_4)
print v(xbgr.n_30)
print v(xbgr.mr_n72908416)
print v(xbgr.mr_n72949248)
print v(xbgr.mr_n73206672)
print v(xbgr.mr_n73465952)
print v(xbgr.mr_n72907616)
print v(xbgr.mr_n72898800)
print v(xbgr.mr_n73229824)
print v(xbgr.mr_n73466544)
print v(xbgr.mr_n73534960)
print v(xbgr.mr_n73619216)
print v(xbgr.mr_n73370928)
print v(xbgr.mr_n73757776)
print v(xbgr.mr_n73831920)
print v(xbgr.mr_n73938256)
print v(xbgr.mr_n74048000)
print v(xbgr.mr_n74169040)
print v(xbgr.mr_n74197040)
print v(xbgr.mr_n74426608)
print v(xbgr.mr_n74586512)
print v(xbgr.mr_n74692704)
print v(xbgr.mr_n74860496)
print v(xbgr.mr_n74986672)
print v(xbgr.mr_n75167840)
print v(xbgr.mr_n75312240)
print v(xbgr.mr_n75390608)
print v(xbgr.mr_n75596912)
print v(xbgr.mr_n75920432)
print v(xbgr.mr_n76146352)
print v(xbgr.mr_n76350464)
print v(xbgr.mr_n76479344)
print v(xbgr.mr_n76640816)
print v(xbgr.mr_n76833648)
print v(xbgr.mr_n77034224)
print v(xbgr.mr_n77142992)
print v(xbgr.mr_n77305328)
print v(xbgr.mr_n77602560)
print v(xbgr.mr_n77741040)
print v(xbgr.mr_n77984400)
print v(xbgr.mr_n78159696)
print v(xbgr.mr_n78375184)
print v(xbgr.mr_n78681696)
print v(xbgr.mr_n78845840)
print v(xbgr.mr_n79066192)
print v(xbgr.mr_n79160224)
print v(xbgr.mr_n72907072)
print v(xbgr.mr_n72682720)
print v(xbgr.mr_n72992784)
print v(xbgr.mr_n73450560)
print v(xbgr.mr_n73541616)
print v(xbgr.mr_n73581472)
print v(xbgr.mr_n72818864)
print v(xbgr.mr_n73698416)
print v(xbgr.mr_n73769152)
print v(xbgr.mr_n73810912)
print v(xbgr.mr_n74008032)
print v(xbgr.mr_n74171184)
print v(xbgr.mr_n74203376)
print v(xbgr.mr_n73962288)
print v(xbgr.mr_n74589216)
print v(xbgr.mr_n74659488)
print v(xbgr.mr_n74790432)
print v(xbgr.mr_n74949296)
print v(xbgr.mr_n75066832)
print v(xbgr.mr_n75199168)
print v(xbgr.mr_n75370608)
print v(xbgr.mr_n75590720)
print v(xbgr.mr_n72906256)
print v(xbgr.mr_n72752528)
print v(xbgr.mr_n73231008)
print v(xbgr.mr_n73467728)
print v(xbgr.mr_n73567232)
print v(xbgr.mr_n73620192)
print v(xbgr.mr_n73633920)
print v(xbgr.mr_n72813456)
print v(xbgr.mr_n73857968)
print v(xbgr.mr_n73972592)
print v(xbgr.mr_n74045552)
print v(xbgr.mr_n74186768)
print v(xbgr.mr_n74288624)
print v(xbgr.mr_n74468720)
print v(xbgr.mr_n74600192)
print v(xbgr.mr_n74714080)
print v(xbgr.mr_n74885248)
print v(xbgr.mr_n75006512)
print v(xbgr.mr_n75200624)
print v(xbgr.mr_n75315856)
print v(xbgr.mr_n75422160)
print v(xbgr.mr_n75590608)
print v(xbgr.mr_n72905984)
print v(xbgr.mr_n72760272)
print v(xbgr.mr_n73231600)
print v(xbgr.mr_n73468320)
print v(xbgr.mr_n72905440)
print v(xbgr.mr_n72771536)
print v(xbgr.mr_n73232192)
print v(xbgr.mr_n73468912)
print v(xbgr.mr_n72904896)
print v(xbgr.mr_n72827248)
print v(xbgr.mr_n73232784)
print v(xbgr.mr_n73461216)
print v(xbgr.mr_n73537376)
print v(xbgr.mr_n73614048)
print v(xbgr.mr_n73625584)
print v(xbgr.mr_n73685104)
print v(xbgr.mr_n73833248)
print v(xbgr.mr_n73939440)
print v(xbgr.mr_n74049920)
print v(xbgr.mr_n74166800)
print v(xbgr.mr_n74261408)
print v(xbgr.mr_n74464400)
print v(xbgr.mr_n74596576)
print v(xbgr.mr_n74712272)
print v(xbgr.mr_n74864016)
print v(xbgr.mr_n74978976)
print v(xbgr.mr_n75166656)
print v(xbgr.mr_n75300464)
print v(xbgr.mr_n75423968)
print v(xbgr.mr_n75596800)
print v(xbgr.mr_n72876832)
print v(xbgr.mr_n72685536)
print v(xbgr.mr_n73233376)
print v(xbgr.mr_n73470096)
print v(xbgr.mr_n75930704)
print v(xbgr.mr_n76139136)
print v(xbgr.mr_n76346944)
print v(xbgr.mr_n76479536)
print v(xbgr.mr_n76612416)
print v(xbgr.mr_n76828208)
print v(xbgr.mr_n77028784)
print v(xbgr.mr_n77201040)
print v(xbgr.mr_n74281440)
print v(xbgr.mr_n77305440)
print v(xbgr.mr_n77599664)
print v(xbgr.mr_n77745552)
print v(xbgr.mr_n77986144)
print v(xbgr.mr_n78174960)
print v(xbgr.mr_n78380160)
print v(xbgr.mr_n78689120)
print v(xbgr.mr_n78848720)
print v(xbgr.mr_n79047280)
print v(xbgr.mr_n79318208)
print v(xbgr.mr_n73545696)
print v(xbgr.mr_n73581200)
print v(xbgr.mr_n72690832)
print v(xbgr.mr_n73697488)
print v(xbgr.mr_n73768224)
print v(xbgr.mr_n73848688)
print v(xbgr.mr_n74007104)
print v(xbgr.mr_n74169872)
print v(xbgr.mr_n74229520)
print v(xbgr.mr_n74599536)
print v(xbgr.mr_n74658304)
print v(xbgr.mr_n74789248)
print v(xbgr.mr_n74944912)
print v(xbgr.mr_n75065648)
print v(xbgr.mr_n75196400)
print v(xbgr.mr_n75422048)
print v(xbgr.mr_n75598752)
print v(xbgr.mr_n72903808)
print v(xbgr.mr_n72755344)
print v(xbgr.mr_n73233968)
print v(xbgr.mr_n73445824)
print v(xbgr.mr_n73568768)
print v(xbgr.mr_n73620992)
print v(xbgr.mr_n73635808)
print v(xbgr.mr_n73684592)
print v(xbgr.mr_n73857168)
print v(xbgr.mr_n73972992)
print v(xbgr.mr_n74049696)
print v(xbgr.mr_n74187648)
print v(xbgr.mr_n74284688)
print v(xbgr.mr_n74470528)
print v(xbgr.mr_n74597472)
print v(xbgr.mr_n74718912)
print v(xbgr.mr_n74886048)
print v(xbgr.mr_n75007312)
print v(xbgr.mr_n75203008)
print v(xbgr.mr_n75317776)
print v(xbgr.mr_n75414928)
print v(xbgr.mr_n75594848)
print v(xbgr.mr_n72903264)
print v(xbgr.mr_n72765200)
print v(xbgr.mr_n73234560)
print v(xbgr.mr_n73471280)
print v(xbgr.mr_n72900352)
print v(xbgr.mr_n72890752)
print v(xbgr.mr_n73235152)
print v(xbgr.mr_n73471872)
print v(xbgr.mr_n72902176)
print v(xbgr.mr_n72285952)
print v(xbgr.n_5)
print v(xbgr.mr_n73472464)
print v(xbgr.mr_n72901360)
print v(xbgr.mr_n72775760)
print v(xbgr.mr_n73236336)
print v(xbgr.mr_n73473056)
print v(xbgr.mr_n73544640)
print v(xbgr.mr_n73607216)
print v(xbgr.mr_n73632704)
print v(xbgr.mr_n72799536)
print v(xbgr.mr_n73807904)
print v(xbgr.mr_n73940624)
print v(xbgr.mr_n74052656)
print v(xbgr.mr_n74166464)
print v(xbgr.mr_n74285488)
print v(xbgr.mr_n74421568)
print v(xbgr.mr_n74588320)
print v(xbgr.mr_n74704544)
print v(xbgr.mr_n74885072)
print v(xbgr.mr_n75001536)
print v(xbgr.mr_n75165472)
print v(xbgr.mr_n75299792)
print v(xbgr.mr_n75425776)
print v(xbgr.mr_n75594736)
print v(xbgr.mr_n75813232)
print v(xbgr.mr_n76117984)
print v(xbgr.mr_n76361600)
print v(xbgr.mr_n76490672)
print v(xbgr.mr_n76640352)
print v(xbgr.mr_n76777008)
print v(xbgr.mr_n77017648)
print v(xbgr.mr_n77195536)
print v(xbgr.mr_n74310240)
print v(xbgr.mr_n77294080)
print v(xbgr.mr_n77604640)
print v(xbgr.mr_n77766320)
print v(xbgr.mr_n77967712)
print v(xbgr.mr_n78151056)
print v(xbgr.mr_n78377456)
print v(xbgr.mr_n78701488)
print v(xbgr.mr_n78868656)
print v(xbgr.mr_n79070096)
print v(xbgr.mr_n79236288)
print v(xbgr.mr_n72901088)
print v(xbgr.mr_n72729296)
print v(xbgr.mr_n73236928)
print v(xbgr.mr_n73473648)
print v(xbgr.mr_n73544752)
print v(xbgr.mr_n73580928)
print v(xbgr.mr_n72691136)
print v(xbgr.mr_n73697024)
print v(xbgr.mr_n73767760)
print v(xbgr.mr_n73847920)
print v(xbgr.mr_n74006720)
print v(xbgr.mr_n74167584)
print v(xbgr.mr_n74315968)
print v(xbgr.mr_n74594512)
print v(xbgr.mr_n74657712)
print v(xbgr.mr_n74788656)
print v(xbgr.mr_n74952384)
print v(xbgr.mr_n75065056)
print v(xbgr.mr_n75197392)
print v(xbgr.mr_n75420352)
print v(xbgr.mr_n75600816)
print v(xbgr.mr_n72899808)
print v(xbgr.mr_n72780688)
print v(xbgr.mr_n73237520)
print v(xbgr.mr_n73474224)
print v(xbgr.mr_n73570064)
print v(xbgr.mr_n73621792)
print v(xbgr.mr_n73637536)
print v(xbgr.mr_n73675760)
print v(xbgr.mr_n73856448)
print v(xbgr.mr_n73973392)
print v(xbgr.mr_n74055024)
print v(xbgr.mr_n74188624)
print v(xbgr.mr_n74287088)
print v(xbgr.mr_n74472256)
print v(xbgr.mr_n74604240)
print v(xbgr.mr_n74720800)
print v(xbgr.mr_n74884448)
print v(xbgr.mr_n75008112)
print v(xbgr.mr_n75203968)
print v(xbgr.mr_n75315968)
print v(xbgr.mr_n75418544)
print v(xbgr.mr_n75598976)
print v(xbgr.mr_n72861056)
print v(xbgr.mr_n73068128)
print v(xbgr.mr_n73238112)
print v(xbgr.mr_n73474816)
print v(xbgr.mr_n72861520)
print v(xbgr.mr_n73068720)
print v(xbgr.mr_n73238704)
print v(xbgr.mr_n73475408)
print v(xbgr.mr_n72861984)
print v(xbgr.mr_n72898176)
print v(xbgr.mr_n73239296)
print v(xbgr.mr_n73476000)
print v(xbgr.mr_n72862448)
print v(xbgr.mr_n73069904)
print v(xbgr.mr_n73239888)
print v(xbgr.mr_n73476592)
print v(xbgr.mr_n73539648)
print v(xbgr.mr_n73621616)
print v(xbgr.mr_n72756960)
print v(xbgr.mr_n72740064)
print v(xbgr.mr_n73808160)
print v(xbgr.mr_n73941808)
print v(xbgr.mr_n74052352)
print v(xbgr.mr_n74166352)
print v(xbgr.mr_n74309808)
print v(xbgr.mr_n74462656)
print v(xbgr.mr_n74600704)
print v(xbgr.mr_n74692192)
print v(xbgr.mr_n74885872)
print v(xbgr.mr_n75003936)
print v(xbgr.mr_n75164288)
print v(xbgr.mr_n75321280)
print v(xbgr.mr_n75425664)
print v(xbgr.mr_n75602992)
print v(xbgr.mr_n75922320)
print v(xbgr.mr_n76120928)
print v(xbgr.mr_n76352784)
print v(xbgr.mr_n76484048)
print v(xbgr.mr_n76635696)
print v(xbgr.mr_n76813696)
print v(xbgr.mr_n76990608)
print v(xbgr.mr_n77198080)
print v(xbgr.mr_n74317664)
print v(xbgr.mr_n77299760)
print v(xbgr.mr_n77609616)
print v(xbgr.mr_n77764000)
print v(xbgr.mr_n77938112)
print v(xbgr.mr_n78143536)
print v(xbgr.mr_n78390368)
print v(xbgr.mr_n78685648)
print v(xbgr.mr_n78873312)
print v(xbgr.mr_n79070784)
print v(xbgr.mr_n79305424)
print v(xbgr.mr_n73539760)
print v(xbgr.mr_n73580656)
print v(xbgr.mr_n72710272)
print v(xbgr.mr_n73696096)
print v(xbgr.mr_n73766832)
print v(xbgr.mr_n59583200)
print v(xbgr.mr_n74006112)
print v(xbgr.mr_n74166688)
print v(xbgr.mr_n74306976)
print v(xbgr.mr_n74603664)
print v(xbgr.mr_n74656720)
print v(xbgr.mr_n74787664)
print v(xbgr.mr_n74952992)
print v(xbgr.mr_n75063872)
print v(xbgr.mr_n75202000)
print v(xbgr.mr_n75423856)
print v(xbgr.mr_n75601040)
print v(xbgr.mr_n72840720)
print v(xbgr.mr_n73070496)
print v(xbgr.mr_n73240480)
print v(xbgr.mr_n73477184)
print v(xbgr.mr_n72863376)
print v(xbgr.mr_n73071088)
print v(xbgr.mr_n73241072)
print v(xbgr.mr_n73452928)
print v(xbgr.mr_n73571280)
print v(xbgr.mr_n73622592)
print v(xbgr.mr_n73639424)
print v(xbgr.mr_n73671344)
print v(xbgr.mr_n73855648)
print v(xbgr.mr_n73973792)
print v(xbgr.mr_n74057280)
print v(xbgr.mr_n74189264)
print v(xbgr.mr_n74320672)
print v(xbgr.mr_n74469232)
print v(xbgr.mr_n74606384)
print v(xbgr.mr_n74722608)
print v(xbgr.mr_n74887648)
print v(xbgr.mr_n75005536)
print v(xbgr.mr_n75205632)
print v(xbgr.mr_n75314048)
print v(xbgr.mr_n75420240)
print v(xbgr.mr_n75598864)
print v(xbgr.mr_n72863840)
print v(xbgr.mr_n73071680)
print v(xbgr.mr_n73241664)
print v(xbgr.mr_n73478368)
print v(xbgr.mr_n72864304)
print v(xbgr.mr_n73072272)
print v(xbgr.mr_n73242256)
print v(xbgr.mr_n73454112)
print v(xbgr.mr_n72864768)
print v(xbgr.mr_n73072864)
print v(xbgr.mr_n73242848)
print v(xbgr.n_31)
print v(xbgr.mr_n73534656)
print v(xbgr.mr_n73619392)
print v(xbgr.mr_n73629936)
print v(xbgr.mr_n73733952)
print v(xbgr.mr_n73733168)
print v(xbgr.mr_n73942992)
print v(xbgr.mr_n74058112)
print v(xbgr.mr_n73960848)
print v(xbgr.mr_n74281872)
print v(xbgr.mr_n74466256)
print v(xbgr.mr_n74595408)
print v(xbgr.mr_n74709216)
print v(xbgr.mr_n74860144)
print v(xbgr.mr_n75003136)
print v(xbgr.mr_n75163104)
print v(xbgr.mr_n75319584)
print v(xbgr.mr_n75431600)
print v(xbgr.mr_n75605168)
print v(xbgr.mr_n72865232)
print v(xbgr.mr_n73073456)
print v(xbgr.mr_n73243440)
print v(xbgr.mr_n73480144)
print v(xbgr.mr_n75808432)
print v(xbgr.mr_n76112976)
print v(xbgr.mr_n76341728)
print v(xbgr.mr_n76471440)
print v(xbgr.mr_n76598096)
print v(xbgr.mr_n76741344)
print v(xbgr.mr_n76996768)
print v(xbgr.mr_n77184304)
print v(xbgr.mr_n74332176)
print v(xbgr.mr_n77302016)
print v(xbgr.mr_n77614704)
print v(xbgr.mr_n77743696)
print v(xbgr.mr_n77924240)
print v(xbgr.mr_n78050112)
print v(xbgr.mr_n78387568)
print v(xbgr.mr_n78663536)
print v(xbgr.mr_n78854688)
print v(xbgr.mr_n79068896)
print v(xbgr.mr_n79276416)
print v(xbgr.mr_n73534768)
print v(xbgr.mr_n73580464)
print v(xbgr.mr_n73018496)
print v(xbgr.mr_n73695632)
print v(xbgr.mr_n73766368)
print v(xbgr.mr_n73878528)
print v(xbgr.mr_n74005808)
print v(xbgr.mr_n74091376)
print v(xbgr.mr_n74390816)
print v(xbgr.mr_n74602016)
print v(xbgr.mr_n74656256)
print v(xbgr.mr_n74787200)
print v(xbgr.mr_n74952656)
print v(xbgr.mr_n75063280)
print v(xbgr.mr_n75201056)
print v(xbgr.mr_n75429648)
print v(xbgr.mr_n75603104)
print v(xbgr.mr_n72865696)
print v(xbgr.mr_n73074048)
print v(xbgr.mr_n73244032)
print v(xbgr.mr_n73480736)
print v(xbgr.mr_n73572656)
print v(xbgr.mr_n73623392)
print v(xbgr.mr_n73641232)
print v(xbgr.mr_n73757600)
print v(xbgr.mr_n73854848)
print v(xbgr.mr_n73974192)
print v(xbgr.mr_n74052464)
print v(xbgr.mr_n74190400)
print v(xbgr.mr_n74319536)
print v(xbgr.mr_n74475952)
print v(xbgr.mr_n74608368)
print v(xbgr.mr_n74724336)
print v(xbgr.mr_n74888448)
print v(xbgr.mr_n75009712)
print v(xbgr.mr_n75207376)
print v(xbgr.mr_n75323088)
print v(xbgr.mr_n75427696)
print v(xbgr.mr_n75604944)
print v(xbgr.mr_n72866160)
print v(xbgr.mr_n73074640)
print v(xbgr.mr_n73244624)
print v(xbgr.mr_n73481328)
print v(xbgr.mr_n72866624)
print v(xbgr.n_34)
print v(xbgr.mr_n73245216)
print v(xbgr.mr_n73481920)
print v(xbgr.mr_n72867088)
print v(xbgr.mr_n73075824)
print v(xbgr.mr_n73245808)
print v(xbgr.mr_n73482480)
print v(xbgr.mr_n72867552)
print v(xbgr.mr_n73076416)
print v(xbgr.mr_n73246400)
print v(xbgr.mr_n73483040)
print v(xbgr.mr_n73529776)
print v(xbgr.mr_n73622416)
print v(xbgr.mr_n73625696)
print v(xbgr.mr_n73755440)
print v(xbgr.mr_n73771936)
print v(xbgr.mr_n73944176)
print v(xbgr.mr_n74060032)
print v(xbgr.mr_n74139024)
print v(xbgr.mr_n74323376)
print v(xbgr.mr_n74472848)
print v(xbgr.mr_n74606896)
print v(xbgr.mr_n74716944)
print v(xbgr.mr_n74886672)
print v(xbgr.mr_n75007136)
print v(xbgr.mr_n75094384)
print v(xbgr.mr_n75325008)
print v(xbgr.mr_n75433888)
print v(xbgr.mr_n75605056)
print v(xbgr.mr_n75812784)
print v(xbgr.mr_n76104512)
print v(xbgr.mr_n76329824)
print v(xbgr.mr_n76446864)
print v(xbgr.mr_n76631040)
print v(xbgr.mr_n76576160)
print v(xbgr.mr_n76985632)
print v(xbgr.mr_n77212016)
print v(xbgr.mr_n74332480)
print v(xbgr.mr_n77299568)
print v(xbgr.mr_n77619568)
print v(xbgr.mr_n77743808)
print v(xbgr.mr_n77935072)
print v(xbgr.mr_n78134688)
print v(xbgr.mr_n78392192)
print v(xbgr.mr_n78645840)
print v(xbgr.mr_n78891936)
print v(xbgr.mr_n79074352)
print v(xbgr.mr_n79309408)
print v(xbgr.mr_n72868016)
print v(xbgr.mr_n73077008)
print v(xbgr.mr_n73246992)
print v(xbgr.mr_n73467136)
print v(xbgr.mr_n73529968)
print v(xbgr.mr_n73578800)
print v(xbgr.mr_n73012352)
print v(xbgr.mr_n73694704)
print v(xbgr.mr_n73765440)
print v(xbgr.mr_n73811024)
print v(xbgr.mr_n73970192)
print v(xbgr.mr_n74091072)
print v(xbgr.mr_n74382944)
print v(xbgr.mr_n74607792)
print v(xbgr.mr_n74655328)
print v(xbgr.mr_n74786272)
print v(xbgr.mr_n74952112)
print v(xbgr.mr_n75062160)
print v(xbgr.mr_n75206144)
print v(xbgr.mr_n75429760)
print v(xbgr.mr_n75600928)
print v(xbgr.mr_n72848608)
print v(xbgr.mr_n72999152)
print v(xbgr.mr_n73247584)
print v(xbgr.mr_n73484224)
print v(xbgr.mr_n73574192)
print v(xbgr.mr_n73624192)
print v(xbgr.mr_n73642960)
print v(xbgr.mr_n73759536)
print v(xbgr.mr_n73854048)
print v(xbgr.mr_n73974592)
print v(xbgr.mr_n74059808)
print v(xbgr.mr_n74191360)
print v(xbgr.mr_n74325616)
print v(xbgr.mr_n74477680)
print v(xbgr.mr_n74610432)
print v(xbgr.mr_n74726224)
print v(xbgr.mr_n74886848)
print v(xbgr.mr_n75010512)
print v(xbgr.mr_n75208976)
print v(xbgr.mr_n75321392)
print v(xbgr.mr_n75427584)
print v(xbgr.mr_n75607008)
print v(xbgr.mr_n72868944)
print v(xbgr.mr_n73078192)
print v(xbgr.mr_n73248176)
print v(xbgr.mr_n73484816)
print v(xbgr.mr_n72869408)
print v(xbgr.mr_n73078784)
print v(xbgr.mr_n73248768)
print v(xbgr.mr_n73485408)
print v(xbgr.mr_n72869872)
print v(xbgr.mr_n73079376)
print v(xbgr.mr_n73249360)
print v(xbgr.mr_n73477776)
print v(xbgr.mr_n72856416)
print v(xbgr.mr_n73079968)
print v(xbgr.n_10)
print v(xbgr.mr_n73486592)
print v(xbgr.mr_n73513504)
print v(xbgr.mr_n73607568)
print v(xbgr.mr_n73634512)
print v(xbgr.mr_n73708256)
print v(xbgr.mr_n73807648)
print v(xbgr.mr_n73945360)
print v(xbgr.mr_n74024352)
print v(xbgr.mr_n74084224)
print v(xbgr.mr_n74322480)
print v(xbgr.mr_n74467424)
print v(xbgr.mr_n74602768)
print v(xbgr.mr_n74715888)
print v(xbgr.mr_n74883472)
print v(xbgr.mr_n75007936)
print v(xbgr.mr_n75008912)
print v(xbgr.mr_n75326816)
print v(xbgr.mr_n75433776)
print v(xbgr.mr_n75607120)
print v(xbgr.mr_n75921888)
print v(xbgr.mr_n76102400)
print v(xbgr.mr_n76325984)
print v(xbgr.mr_n76451248)
print v(xbgr.mr_n76645008)
print v(xbgr.mr_n76774112)
print v(xbgr.mr_n76977040)
print v(xbgr.mr_n77216992)
print v(xbgr.mr_n74331632)
print v(xbgr.mr_n77298992)
print v(xbgr.mr_n77624544)
print v(xbgr.mr_n77746016)
print v(xbgr.mr_n77921424)
print v(xbgr.mr_n78137360)
print v(xbgr.mr_n78405040)
print v(xbgr.mr_n78628960)
print v(xbgr.mr_n78633824)
print v(xbgr.mr_n78946192)
print v(xbgr.mr_n79233472)
print v(xbgr.mr_n73524784)
print v(xbgr.mr_n73580000)
print v(xbgr.mr_n73617152)
print v(xbgr.mr_n73694240)
print v(xbgr.mr_n73764976)
print v(xbgr.mr_n73893376)
print v(xbgr.mr_n73949536)
print v(xbgr.mr_n74062768)
print v(xbgr.mr_n74393184)
print v(xbgr.mr_n74604832)
print v(xbgr.mr_n74654864)
print v(xbgr.mr_n74785808)
print v(xbgr.mr_n74936032)
print v(xbgr.mr_n75061696)
print v(xbgr.mr_n75204400)
print v(xbgr.mr_n75431824)
print v(xbgr.mr_n75609776)
print v(xbgr.mr_n72870800)
print v(xbgr.mr_n73080560)
print v(xbgr.mr_n73250544)
print v(xbgr.mr_n73462400)
print v(xbgr.mr_n72871264)
print v(xbgr.mr_n73052832)
print v(xbgr.mr_n73251136)
print v(xbgr.mr_n73487776)
print v(xbgr.mr_n73575968)
print v(xbgr.mr_n73624992)
print v(xbgr.mr_n73644848)
print v(xbgr.mr_n73757136)
print v(xbgr.mr_n73853248)
print v(xbgr.mr_n73974992)
print v(xbgr.mr_n74050192)
print v(xbgr.mr_n74192336)
print v(xbgr.mr_n74323488)
print v(xbgr.mr_n74479568)
print v(xbgr.mr_n74612576)
print v(xbgr.mr_n74727952)
print v(xbgr.mr_n74890048)
print v(xbgr.mr_n75011312)
print v(xbgr.mr_n75210320)
print v(xbgr.mr_n75326704)
print v(xbgr.mr_n75433664)
print v(xbgr.mr_n75602880)
print v(xbgr.mr_n72871728)
print v(xbgr.mr_n73081744)
print v(xbgr.mr_n73251728)
print v(xbgr.mr_n73488368)
print v(xbgr.mr_n72872192)
print v(xbgr.mr_n73082336)
print v(xbgr.mr_n73252320)
print v(xbgr.mr_n73488960)
print v(xbgr.mr_n72872656)
print v(xbgr.mr_n73082928)
print v(xbgr.mr_n73252912)
print v(xbgr.mr_n73489552)
print v(xbgr.mr_n73520912)
print v(xbgr.mr_n73620016)
print v(xbgr.mr_n73641744)
print v(xbgr.mr_n73705008)
print v(xbgr.mr_n73689072)
print v(xbgr.mr_n73946544)
print v(xbgr.mr_n74065024)
print v(xbgr.mr_n74138576)
print v(xbgr.mr_n74327552)
print v(xbgr.mr_n74453728)
print v(xbgr.mr_n74601600)
print v(xbgr.mr_n74724928)
print v(xbgr.mr_n74889072)
print v(xbgr.mr_n75011136)
print v(xbgr.mr_n75093680)
print v(xbgr.mr_n75314160)
print v(xbgr.mr_n75435952)
print v(xbgr.mr_n75614240)
print v(xbgr.mr_n72873120)
print v(xbgr.mr_n73083520)
print v(xbgr.mr_n73253504)
print v(xbgr.mr_n73490144)
print v(xbgr.mr_n75807632)
print v(xbgr.mr_n76092800)
print v(xbgr.mr_n76314208)
print v(xbgr.mr_n76446592)
print v(xbgr.mr_n76673408)
print v(xbgr.mr_n76739504)
print v(xbgr.mr_n76948128)
print v(xbgr.mr_n77222080)
print v(xbgr.mr_n74318416)
print v(xbgr.mr_n77299184)
print v(xbgr.mr_n77585248)
print v(xbgr.mr_n77732112)
print v(xbgr.mr_n77888608)
print v(xbgr.mr_n78151568)
print v(xbgr.mr_n78300960)
print v(xbgr.mr_n78533536)
print v(xbgr.mr_n78716352)
print v(xbgr.mr_n79043680)
print v(xbgr.mr_n79311904)
print v(xbgr.mr_n73507104)
print v(xbgr.mr_n73576928)
print v(xbgr.mr_n73436144)
print v(xbgr.mr_n73693312)
print v(xbgr.mr_n73670704)
print v(xbgr.mr_n73894960)
print v(xbgr.mr_n73947728)
print v(xbgr.mr_n74083072)
print v(xbgr.mr_n74429232)
print v(xbgr.mr_n74503936)
print v(xbgr.mr_n74629568)
print v(xbgr.mr_n74754624)
print v(xbgr.mr_n74950240)
print v(xbgr.mr_n75010336)
print v(xbgr.mr_n75208560)
print v(xbgr.mr_n75437792)
print v(xbgr.mr_n75610256)
print v(xbgr.mr_n72873584)
print v(xbgr.mr_n73084112)
print v(xbgr.mr_n73254096)
print v(xbgr.mr_n73469504)
print v(xbgr.mr_n73577104)
print v(xbgr.mr_n73014848)
print v(xbgr.mr_n73646576)
print v(xbgr.mr_n73754176)
print v(xbgr.mr_n73835296)
print v(xbgr.mr_n73975392)
print v(xbgr.mr_n74064800)
print v(xbgr.mr_n74188448)
print v(xbgr.mr_n74315792)
print v(xbgr.mr_n74481296)
print v(xbgr.mr_n74614304)
print v(xbgr.mr_n74729840)
print v(xbgr.mr_n74888272)
print v(xbgr.mr_n75012112)
print v(xbgr.mr_n75213184)
print v(xbgr.mr_n75328512)
print v(xbgr.mr_n75431712)
print v(xbgr.mr_n75609888)
print v(xbgr.mr_n72849072)
print v(xbgr.mr_n73084704)
print v(xbgr.mr_n73254688)
print v(xbgr.mr_n73470688)
print v(xbgr.mr_n72874512)
print v(xbgr.mr_n72681312)
print v(xbgr.mr_n73255280)
print v(xbgr.mr_n73392448)
print v(xbgr.mr_n72874976)
print v(xbgr.mr_n73038704)
print v(xbgr.mr_n73255872)
print v(xbgr.mr_n73438864)
print v(xbgr.mr_n72875440)
print v(xbgr.mr_n73042736)
print v(xbgr.mr_n73256464)
print v(xbgr.mr_n73443408)
print v(xbgr.mr_n72875904)
print v(xbgr.mr_n73036688)
print v(xbgr.mr_n73257056)
print v(xbgr.mr_n73207696)
print v(xbgr.mr_n72874048)
print v(xbgr.mr_n73063984)
print v(xbgr.mr_n73257648)
print v(xbgr.mr_n72787344)
print v(xbgr.mr_n72856880)
print v(xbgr.mr_n72991824)
print v(xbgr.mr_n73258240)
print v(xbgr.mr_n73443552)
print v(xbgr.mr_n72877296)
print v(xbgr.mr_n72793456)
print v(xbgr.mr_n73258832)
print v(xbgr.mr_n73439120)
print v(xbgr.mr_n73732976)
print v(xbgr.mr_n75212176)
print v(xbgr.mr_n75438016)
print v(xbgr.mr_n75617856)
print v(xbgr.mr_n72877760)
print v(xbgr.mr_n72758864)
print v(xbgr.mr_n73259424)
print v(xbgr.mr_n73438608)
print v(xbgr.d5)
print v(xbgr.d1)
print v(xbgr.mr_n73730016)
print v(xbgr.mr_n74060304)
print v(xbgr.mr_n73577728)
print v(xbgr.mr_n73636320)
print v(xbgr.mr_n74067824)
print v(xbgr.mr_n75211056)
print v(xbgr.n1)
print v(xbgr.mr_n75618224)
print v(xbgr.mr_n72878224)
print v(xbgr.mr_n72753232)
print v(xbgr.mr_n73260016)
print v(xbgr.mr_n72686976)
print v(xbgr.mr_n75009536)
print v(xbgr.mr_n75238160)
print v(xbgr.mr_n75453200)
print v(xbgr.mr_n73518128)
print v(xbgr.mr_n73610240)
print v(xbgr.kick)
print v(xbgr.mr_n73904752)
print v(xbgr.mr_n75210832)
print v(xbgr.mr_n75379840)
print v(xbgr.mr_n75617744)
print v(xbgr.mr_n72878688)
print v(xbgr.mr_n73050224)
print v(xbgr.mr_n73260608)
print v(xbgr.mr_n73440160)
print v(xbgr.mr_n72879152)
print v(xbgr.mr_n73047392)
print v(xbgr.mr_n73261200)
print v(xbgr.mr_n73478960)
print v(xbgr.mr_n73573680)
print v(xbgr.mr_n73647168)
print v(xbgr.mr_n73704128)
print v(xbgr.mr_n74064912)
print v(xbgr.mr_n75212352)
print v(xbgr.mr_n75439856)
print v(xbgr.mr_n75607232)
print v(xbgr.mr_n74192160)
print v(xbgr.mr_n74289088)
print v(xbgr.mr_n74378512)
print v(xbgr.mr_n74473904)
print v(xbgr.mr_n74726736)
print v(xbgr.mr_n74846976)
print v(xbgr.mr_n74973824)
print v(xbgr.mr_n74191984)
print v(xbgr.mr_n74304592)
print v(xbgr.mr_n74407632)
print v(xbgr.mr_n74453472)
print v(xbgr.mr_n74728544)
print v(xbgr.mr_n74857904)
print v(xbgr.mr_n74978032)
print v(xbgr.mr_n72879616)
print v(xbgr.mr_n72793840)
print v(xbgr.mr_n73261792)
print v(xbgr.mr_n73490400)
print v(xbgr.mr_n75213776)
print v(xbgr.mr_n75287840)
print v(xbgr.mr_n75613760)
print v(xbgr.mr_n74091760)
print v(xbgr.mr_n74224464)
print v(xbgr.mr_n74354320)
print v(xbgr.mr_n74426048)
print v(xbgr.mr_n74628416)
print v(xbgr.mr_n74753472)
print v(xbgr.mr_n74860608)
print v(xbgr.mr_n75024656)
print v(xbgr.mr_n75255312)
print v(xbgr.mr_n75457200)
print v(xbgr.mr_n72880080)
print v(xbgr.mr_n72688976)
print v(xbgr.mr_n73262384)
print v(xbgr.mr_n73301968)
print v(xbgr.mr_n75213888)
print v(xbgr.mr_n75381616)
print v(xbgr.mr_n75622208)
print v(xbgr.mr_n73731616)
print v(xbgr.mr_n74183104)
print v(xbgr.d2)
print v(xbgr.mr_n74409552)
print v(xbgr.mr_n74474656)
print v(xbgr.mr_n74723120)
print v(xbgr.mr_n74822992)
print v(xbgr.mr_n74948464)
print v(xbgr.mr_n73577952)
print v(xbgr.mr_n73647280)
print v(xbgr.mr_n74067520)
print v(xbgr.mr_n72880544)
print v(xbgr.mr_n73085024)
print v(xbgr.mr_n73262976)
print v(xbgr.mr_n73491696)
print v(xbgr.mr_n73578064)
print v(xbgr.mr_n73647392)
print v(xbgr.mr_n74055776)
print v(xbgr.mr_n75215168)
print v(xbgr.mr_n75435840)
print v(xbgr.mr_n75613872)
print v(xbgr.mr_n73730800)
print v(xbgr.mr_n72881008)
print v(xbgr.mr_n73085568)
print v(xbgr.mr_n73263568)
print v(xbgr.mr_n73493936)
print v(xbgr.mr_n73518672)
print v(xbgr.mr_n73609968)
print v(xbgr.mr_n73948800)
print v(xbgr.det)
print v(xbgr.mr_n75215968)
print v(xbgr.mr_n75382960)
print v(xbgr.mr_n75621840)
print v(xbgr.mr_n73669456)
print v(xbgr.mr_n72881472)
print v(xbgr.mr_n73086272)
print v(xbgr.mr_n73264160)
print v(xbgr.mr_n73492672)
print v(xbgr.mr_n75026432)
print v(xbgr.mr_n75254848)
print v(xbgr.mr_n75459056)
print v(xbgr.mr_n73577840)
print v(xbgr.mr_n73643552)
print v(xbgr.mr_n74067632)
print v(xbgr.mr_n75210944)
print v(xbgr.mr_n75287696)
print v(xbgr.mr_n75626416)
print v(xbgr.mr_n74193584)
print v(xbgr.mr_n74288976)
print v(xbgr.mr_n74404512)
print v(xbgr.mr_n74476464)
print v(xbgr.mr_n74717696)
print v(xbgr.mr_n74853792)
print v(xbgr.mr_n74839776)
print v(xbgr.mr_n74193696)
print v(xbgr.mr_n74331120)
print v(xbgr.mr_n74378400)
print v(xbgr.mr_n74482000)
print v(xbgr.mr_n74730576)
print v(xbgr.mr_n74861312)
print v(xbgr.mr_n74983744)
print v(xbgr.mr_n72881936)
print v(xbgr.mr_n73087312)
print v(xbgr.mr_n73264752)
print v(xbgr.mr_n73497904)
print v(xbgr.mr_n74115040)
print v(xbgr.mr_n74226384)
print v(xbgr.mr_n74359072)
print v(xbgr.mr_n74430048)
print v(xbgr.mr_n74632448)
print v(xbgr.mr_n74757504)
print v(xbgr.mr_n74891392)
print v(xbgr.mr_n75217328)
print v(xbgr.mr_n75442400)
print v(xbgr.mr_n75621728)
print v(xbgr.mr_n72860128)
print v(xbgr.mr_n73088256)
print v(xbgr.mr_n73265344)
print v(xbgr.mr_n73363456)
print v(xbgr.mr_n75215632)
print v(xbgr.mr_n75289936)
print v(xbgr.mr_n75624912)
print v(xbgr.mr_n72882864)
print v(xbgr.mr_n73088848)
print v(xbgr.mr_n73265936)
print v(xbgr.mr_n73487184)
print v(xbgr.mr_n73729824)
print v(xbgr.mr_n74193248)
print v(xbgr.mr_n74333328)
print v(xbgr.mr_n74357632)
print v(xbgr.mr_n74482112)
print v(xbgr.mr_n74731072)
print v(xbgr.mr_n74818848)
print v(xbgr.mr_n74943792)
print v(xbgr.mr_n73578688)
print v(xbgr.mr_n73648240)
print v(xbgr.mr_n74069024)
print v(xbgr.mr_n75028288)
print v(xbgr.mr_n75254384)
print v(xbgr.mr_n75460912)
print v(xbgr.mr_n73574816)
print v(xbgr.mr_n73647776)
print v(xbgr.mr_n74069648)
print v(xbgr.mr_n75217440)
print v(xbgr.mr_n75384640)
print v(xbgr.mr_n75627312)
print v(xbgr.mr_n72883328)
print v(xbgr.mr_n73089440)
print v(xbgr.mr_n73266528)
print v(xbgr.mr_n73499856)
print v(xbgr.mr_n73707664)
print v(xbgr.mr_n73518400)
print v(xbgr.mr_n73609696)
print v(xbgr.mr_n73668272)
print v(xbgr.mr_n73949072)
print v(xbgr.r4n)
print v(xbgr.mr_n72883792)
print v(xbgr.mr_n73090032)
print v(xbgr.mr_n73267120)
print v(xbgr.mr_n73499968)
print v(xbgr.mr_n75218000)
print v(xbgr.mr_n75440992)
print v(xbgr.mr_n75624800)
print v(xbgr.mr_n73569888)
print v(xbgr.mr_n73648896)
print v(xbgr.mr_n74068608)
print v(xbgr.mr_n74193472)
print v(xbgr.mr_n74340048)
print v(xbgr.mr_n74401776)
print v(xbgr.mr_n74455952)
print v(xbgr.mr_n74721312)
print v(xbgr.mr_n74856672)
print v(xbgr.mr_n74962192)
print v(xbgr.mr_n74194544)
print v(xbgr.mr_n74336528)
print v(xbgr.mr_n74398928)
print v(xbgr.mr_n74480080)
print v(xbgr.mr_n74731536)
print v(xbgr.mr_n74857088)
print v(xbgr.mr_n74981760)
print v(xbgr.mr_n72870336)
print v(xbgr.mr_n73090624)
print v(xbgr.mr_n73267712)
print v(xbgr.mr_n73486000)
print v(xbgr.mr_n75218256)
print v(xbgr.mr_n75384176)
print v(xbgr.mr_n75628880)
print v(xbgr.mr_n75030144)
print v(xbgr.mr_n75253920)
print v(xbgr.mr_n75462768)
print v(xbgr.mr_n74114576)
print v(xbgr.mr_n74225856)
print v(xbgr.mr_n74359888)
print v(xbgr.mr_n74430864)
print v(xbgr.mr_n74633264)
print v(xbgr.mr_n74758320)
print v(xbgr.mr_n74891808)
print v(xbgr.mr_n72884720)
print v(xbgr.mr_n73091216)
print v(xbgr.mr_n73268304)
print v(xbgr.mr_n73490592)
print v(xbgr.mr_n75220608)
print v(xbgr.mr_n74456816)
print v(xbgr.mr_n75627136)
print v(xbgr.mr_n72885184)
print v(xbgr.mr_n73091792)
print v(xbgr.mr_n73268896)
print v(xbgr.mr_n73500304)
print v(xbgr.mr_n73728768)
print v(xbgr.mr_n74195632)
print v(xbgr.mr_n74279440)
print v(xbgr.mr_n74407824)
print v(xbgr.mr_n74482528)
print v(xbgr.mr_n74730688)
print v(xbgr.mr_n74821808)
print v(xbgr.mr_n74946688)
print v(xbgr.mr_n75221472)
print v(xbgr.mr_n75443488)
print v(xbgr.mr_n75629872)
print v(xbgr.mr_n73579424)
print v(xbgr.mr_n73649008)
print v(xbgr.mr_n74058000)
print v(xbgr.mr_n73579664)
print v(xbgr.mr_n73649504)
print v(xbgr.mr_n74071216)
print v(xbgr.mr_n72885648)
print v(xbgr.mr_n73092384)
print v(xbgr.mr_n73269488)
print v(xbgr.mr_n73500768)
print v(xbgr.mr_n75214080)
print v(xbgr.mr_n75386464)
print v(xbgr.mr_n75631440)
print v(xbgr.mr_n73722400)
print v(xbgr.mr_n73517856)
print v(xbgr.mr_n73609424)
print v(xbgr.mr_n73948608)
print v(xbgr.mr_n73669920)
print v(xbgr.mr_n75032000)
print v(xbgr.mr_n75253456)
print v(xbgr.mr_n75464624)
print v(xbgr.mr_n72886112)
print v(xbgr.mr_n73092976)
print v(xbgr.mr_n73270080)
print v(xbgr.mr_n73483632)
print v(xbgr.mr_n73700272)
print v(xbgr.mr_n75223632)
print v(xbgr.mr_n75387056)
print v(xbgr.mr_n75634000)
print v(xbgr.mr_n73579072)
print v(xbgr.mr_n73639936)
print v(xbgr.mr_n74070176)
print v(xbgr.mr_n72886576)
print v(xbgr.mr_n73093568)
print v(xbgr.mr_n73270672)
print v(xbgr.mr_n73499520)
print v(xbgr.mr_n74193360)
print v(xbgr.mr_n74305408)
print v(xbgr.mr_n74410432)
print v(xbgr.mr_n74482336)
print v(xbgr.mr_n74719504)
print v(xbgr.mr_n74850384)
print v(xbgr.mr_n74962656)
print v(xbgr.mr_n74196352)
print v(xbgr.mr_n74342896)
print v(xbgr.mr_n74350144)
print v(xbgr.mr_n74483072)
print v(xbgr.mr_n74732640)
print v(xbgr.mr_n74853680)
print v(xbgr.mr_n74978144)
print v(xbgr.mr_n75224048)
print v(xbgr.mr_n75447296)
print v(xbgr.mr_n75629696)
print v(xbgr.mr_n72887040)
print v(xbgr.mr_n73094160)
print v(xbgr.mr_n73271264)
print v(xbgr.mr_n73500080)
print v(xbgr.mr_n74114112)
print v(xbgr.mr_n74225392)
print v(xbgr.mr_n74360704)
print v(xbgr.mr_n74431600)
print v(xbgr.mr_n74634080)
print v(xbgr.mr_n74759136)
print v(xbgr.mr_n74892624)
print v(xbgr.mr_n75219072)
print v(xbgr.mr_n75387648)
print v(xbgr.mr_n75632432)
print v(xbgr.mr_n72887504)
print v(xbgr.mr_n73094752)
print v(xbgr.mr_n73271856)
print v(xbgr.mr_n73501856)
print v(xbgr.mr_n75033856)
print v(xbgr.mr_n75252992)
print v(xbgr.mr_n75466512)
print v(xbgr.mr_n74194320)
print v(xbgr.mr_n74343952)
print v(xbgr.mr_n74396624)
print v(xbgr.mr_n74483344)
print v(xbgr.mr_n74732272)
print v(xbgr.mr_n74821216)
print v(xbgr.mr_n74947344)
print v(xbgr.mr_n75225920)
print v(xbgr.mr_n75385584)
print v(xbgr.mr_n75632256)
print v(xbgr.mr_n73575376)
print v(xbgr.mr_n73651520)
print v(xbgr.d3)
print v(xbgr.mr_n74068336)
print v(xbgr.mr_n73576752)
print v(xbgr.mr_n73650672)
print v(xbgr.mr_n73895136)
print v(xbgr.mr_n74072784)
print v(xbgr.mr_n72862912)
print v(xbgr.mr_n73095344)
print v(xbgr.mr_n73272448)
print v(xbgr.mr_n73502128)
print v(xbgr.mr_n73517584)
print v(xbgr.mr_n73609152)
print v(xbgr.mr_n73186032)
print v(xbgr.mr_n73947424)
print v(xbgr.mr_n75226448)
print v(xbgr.mr_n75448928)
print v(xbgr.mr_n75634992)
print v(xbgr.mr_n72888432)
print v(xbgr.mr_n73039712)
print v(xbgr.mr_n73273040)
print v(xbgr.mr_n73501040)
print v(xbgr.mr_n75221360)
print v(xbgr.mr_n75383072)
print v(xbgr.mr_n75636560)
print v(xbgr.mr_n72888896)
print v(xbgr.mr_n73096448)
print v(xbgr.mr_n73273632)
print v(xbgr.mr_n73503104)
print v(xbgr.mr_n73574704)
print v(xbgr.mr_n73651104)
print v(xbgr.mr_n73859680)
print v(xbgr.mr_n74071744)
print v(xbgr.mr_n74171664)
print v(xbgr.mr_n74339184)
print v(xbgr.mr_n74404320)
print v(xbgr.mr_n74471040)
print v(xbgr.mr_n74609856)
print v(xbgr.mr_n74731424)
print v(xbgr.mr_n74853264)
print v(xbgr.mr_n74975760)
print v(xbgr.mr_n74197648)
print v(xbgr.mr_n74304784)
print v(xbgr.mr_n74396848)
print v(xbgr.mr_n74482224)
print v(xbgr.mr_n74615504)
print v(xbgr.mr_n74735344)
print v(xbgr.mr_n74843200)
print v(xbgr.mr_n74443600)
print v(xbgr.mr_n75035712)
print v(xbgr.mr_n75252528)
print v(xbgr.mr_n75468880)
print v(xbgr.mr_n75227328)
print v(xbgr.mr_n75382736)
print v(xbgr.mr_n75637552)
print v(xbgr.mr_n72889360)
print v(xbgr.mr_n73097120)
print v(xbgr.mr_n73274224)
print v(xbgr.mr_n73503504)
print v(xbgr.mr_n74113648)
print v(xbgr.mr_n74224928)
print v(xbgr.mr_n74361520)
print v(xbgr.mr_n74431136)
print v(xbgr.mr_n74506640)
print v(xbgr.mr_n74634896)
print v(xbgr.mr_n74759952)
print v(xbgr.mr_n74893440)
print v(xbgr.mr_n72889824)
print v(xbgr.mr_n73097712)
print v(xbgr.mr_n73274816)
print v(xbgr.mr_n73500192)
print v(xbgr.mr_n75226560)
print v(xbgr.mr_n75445664)
print v(xbgr.mr_n75634816)
print v(xbgr.mr_n74198800)
print v(xbgr.mr_n74339376)
print v(xbgr.mr_n74411088)
print v(xbgr.mr_n74483936)
print v(xbgr.mr_n74611920)
print v(xbgr.mr_n74733328)
print v(xbgr.mr_n74820624)
print v(xbgr.mr_n74932560)
print v(xbgr.mr_n73573248)
print v(xbgr.mr_n73653088)
print v(xbgr.mr_n73890832)
print v(xbgr.mr_n74065296)
print v(xbgr.mr_n73571792)
print v(xbgr.mr_n73652208)
print v(xbgr.mr_n73894352)
print v(xbgr.mr_n74070528)
print v(xbgr.mr_n72887968)
print v(xbgr.mr_n73098304)
print v(xbgr.mr_n73275408)
print v(xbgr.mr_n73504304)
print v(xbgr.mr_n75220784)
print v(xbgr.mr_n75382848)
print v(xbgr.mr_n75639120)
print v(xbgr.mr_n75036640)
print v(xbgr.mr_n75252064)
print v(xbgr.mr_n75470064)
print v(xbgr.mr_n72868480)
print v(xbgr.mr_n73098896)
print v(xbgr.mr_n73276000)
print v(xbgr.mr_n73501312)
print v(xbgr.mr_n73517312)
print v(xbgr.mr_n73608880)
print v(xbgr.mr_n73676720)
print v(xbgr.mr_n73946240)
print v(xbgr.mr_n75230032)
print v(xbgr.mr_n74458624)
print v(xbgr.mr_n75641680)
print v(xbgr.mr_n72891216)
print v(xbgr.mr_n73099488)
print v(xbgr.mr_n73276592)
print v(xbgr.mr_n73505504)
print v(xbgr.mr_n73567824)
print v(xbgr.mr_n73652672)
print v(xbgr.mr_n73859152)
print v(xbgr.mr_n74074816)
print v(xbgr.mr_n75230880)
print v(xbgr.mr_n75450016)
print v(xbgr.mr_n75637376)
print v(xbgr.mr_n74195984)
print v(xbgr.mr_n74343760)
print v(xbgr.mr_n74397152)
print v(xbgr.mr_n74484688)
print v(xbgr.mr_n74615968)
print v(xbgr.mr_n74736224)
print v(xbgr.mr_n74850272)
print v(xbgr.mr_n74460480)
print v(xbgr.mr_n74199520)
print v(xbgr.mr_n74026416)
print v(xbgr.mr_n74410896)
print v(xbgr.mr_n74481888)
print v(xbgr.mr_n74611024)
print v(xbgr.mr_n74730464)
print v(xbgr.mr_n74854496)
print v(xbgr.mr_n74461344)
print v(xbgr.mr_n72891680)
print v(xbgr.mr_n73100080)
print v(xbgr.mr_n73220304)
print v(xbgr.mr_n73501584)
print v(xbgr.mr_n75231696)
print v(xbgr.mr_n75382208)
print v(xbgr.mr_n75640112)
print v(xbgr.mr_n74113184)
print v(xbgr.mr_n74224000)
print v(xbgr.mr_n74362592)
print v(xbgr.mr_n74430592)
print v(xbgr.mr_n74509104)
print v(xbgr.mr_n74635712)
print v(xbgr.mr_n74760768)
print v(xbgr.mr_n74894256)
print v(xbgr.mr_n75036176)
print v(xbgr.mr_n75251600)
print v(xbgr.mr_n75469472)
print v(xbgr.mr_n72892144)
print v(xbgr.mr_n73100672)
print v(xbgr.mr_n73277776)
print v(xbgr.mr_n73502400)
print v(xbgr.mr_n75232640)
print v(xbgr.mr_n75294864)
print v(xbgr.mr_n75644240)
print v(xbgr.mr_n74198144)
print v(xbgr.mr_n72825232)
print v(xbgr.mr_n74396736)
print v(xbgr.mr_n74483696)
print v(xbgr.mr_n74617280)
print v(xbgr.mr_n74734656)
print v(xbgr.mr_n74820032)
print v(xbgr.mr_n74945568)
print v(xbgr.mr_n72892608)
print v(xbgr.mr_n73101264)
print v(xbgr.mr_n73278368)
print v(xbgr.mr_n73506624)
print v(xbgr.mr_n73573856)
print v(xbgr.mr_n73654656)
print v(xbgr.mr_n73892592)
print v(xbgr.mr_n74074352)
print v(xbgr.mr_n73572400)
print v(xbgr.mr_n73655344)
print v(xbgr.mr_n73892416)
print v(xbgr.mr_n74075920)
print v(xbgr.mr_n75233168)
print v(xbgr.mr_n75445120)
print v(xbgr.mr_n75639936)
print v(xbgr.mr_n72893072)
print v(xbgr.mr_n73101856)
print v(xbgr.mr_n73278960)
print v(xbgr.mr_n73507504)
print v(xbgr.mr_n73517040)
print v(xbgr.mr_n73608608)
print v(xbgr.mr_n73675504)
print v(xbgr.mr_n73945056)
print v(xbgr.mr_n75228672)
print v(xbgr.mr_n75382000)
print v(xbgr.mr_n75642672)
print v(xbgr.mr_n72893536)
print v(xbgr.mr_n73102448)
print v(xbgr.mr_n73279552)
print v(xbgr.mr_n73507904)
print v(xbgr.mr_n75035248)
print v(xbgr.mr_n75251136)
print v(xbgr.mr_n75468288)
print v(xbgr.mr_n73568432)
print v(xbgr.mr_n73647888)
print v(xbgr.mr_n73859952)
print v(xbgr.mr_n74076448)
print v(xbgr.mr_n74200208)
print v(xbgr.mr_n74343568)
print v(xbgr.mr_n74397264)
print v(xbgr.mr_n74485120)
print v(xbgr.mr_n74617104)
print v(xbgr.mr_n74738512)
print v(xbgr.mr_n74849920)
print v(xbgr.mr_n74972880)
print v(xbgr.mr_n75228848)
print v(xbgr.mr_n75379248)
print v(xbgr.mr_n75645232)
print v(xbgr.mr_n74196688)
print v(xbgr.mr_n74332592)
print v(xbgr.mr_n74398160)
print v(xbgr.mr_n74486976)
print v(xbgr.mr_n74618000)
print v(xbgr.mr_n74740048)
print v(xbgr.mr_n74847680)
print v(xbgr.mr_n74976992)
print v(xbgr.mr_n72894000)
print v(xbgr.mr_n73103040)
print v(xbgr.mr_n73280144)
print v(xbgr.mr_n73503904)
print v(xbgr.mr_n74112720)
print v(xbgr.mr_n74223536)
print v(xbgr.mr_n74363056)
print v(xbgr.mr_n74430320)
print v(xbgr.mr_n74509920)
print v(xbgr.mr_n74636528)
print v(xbgr.mr_n74761584)
print v(xbgr.mr_n74895072)
print v(xbgr.mr_n72860592)
print v(xbgr.mr_n73084912)
print v(xbgr.mr_n73280736)
print v(xbgr.mr_n73508704)
print v(xbgr.mr_n75235200)
print v(xbgr.mr_n75451568)
print v(xbgr.mr_n75642496)
print v(xbgr.mr_n75236128)
print v(xbgr.mr_n75380432)
print v(xbgr.mr_n75646800)
print v(xbgr.mr_n72698288)
print v(xbgr.mr_n73104144)
print v(xbgr.mr_n73214848)
print v(xbgr.mr_n73505904)
print v(xbgr.mr_n74201968)
print v(xbgr.mr_n74302352)
print v(xbgr.mr_n74397808)
print v(xbgr.mr_n74488512)
print v(xbgr.mr_n74616624)
print v(xbgr.mr_n74737968)
print v(xbgr.mr_n74817664)
print v(xbgr.mr_n74943136)
print v(xbgr.mr_n73572224)
print v(xbgr.mr_n73656224)
print v(xbgr.mr_n73888352)
print v(xbgr.mr_n74073664)
print v(xbgr.mr_n73566640)
print v(xbgr.mr_n73656912)
print v(xbgr.mr_n73891872)
print v(xbgr.mr_n74077488)
print v(xbgr.mr_n75034784)
print v(xbgr.mr_n75250672)
print v(xbgr.mr_n75467696)
print v(xbgr.mr_n75237072)
print v(xbgr.mr_n75381024)
print v(xbgr.mr_n75649360)
print v(xbgr.mr_n72859664)
print v(xbgr.mr_n73104816)
print v(xbgr.mr_n73214256)
print v(xbgr.mr_n73509904)
print v(xbgr.mr_n73516768)
print v(xbgr.mr_n73608336)
print v(xbgr.mr_n73709328)
print v(xbgr.mr_n73943872)
print v(xbgr.mr_n72859200)
print v(xbgr.mr_n73105408)
print v(xbgr.mr_n73213664)
print v(xbgr.mr_n73510304)
print v(xbgr.mr_n75237488)
print v(xbgr.mr_n75451104)
print v(xbgr.mr_n75647792)
print v(xbgr.mr_n73571104)
print v(xbgr.mr_n73655872)
print v(xbgr.mr_n73860496)
print v(xbgr.mr_n74078016)
print v(xbgr.mr_n74202688)
print v(xbgr.mr_n74301888)
print v(xbgr.mr_n74398272)
print v(xbgr.mr_n74487408)
print v(xbgr.mr_n74618688)
print v(xbgr.mr_n74742048)
print v(xbgr.mr_n74843392)
print v(xbgr.mr_n74969472)
print v(xbgr.mr_n72858736)
print v(xbgr.mr_n73106000)
print v(xbgr.mr_n73213072)
print v(xbgr.mr_n73510704)
print v(xbgr.mr_n74201792)
print v(xbgr.mr_n74347136)
print v(xbgr.mr_n74414816)
print v(xbgr.mr_n74490512)
print v(xbgr.mr_n74616080)
print v(xbgr.mr_n74736656)
print v(xbgr.mr_n74851088)
print v(xbgr.mr_n74972768)
print v(xbgr.mr_n75237600)
print v(xbgr.mr_n75378656)
print v(xbgr.mr_n75645056)
print v(xbgr.mr_n75034320)
print v(xbgr.mr_n75250208)
print v(xbgr.mr_n75467104)
print v(xbgr.mr_n72858272)
print v(xbgr.mr_n73106592)
print v(xbgr.mr_n73212480)
print v(xbgr.mr_n73511104)
print v(xbgr.mr_n74112256)
print v(xbgr.mr_n74222608)
print v(xbgr.mr_n74362128)
print v(xbgr.mr_n74429776)
print v(xbgr.mr_n74510736)
print v(xbgr.mr_n74636256)
print v(xbgr.mr_n74761312)
print v(xbgr.mr_n74894800)
print v(xbgr.mr_n75239664)
print v(xbgr.mr_n75378064)
print v(xbgr.mr_n75651920)
print v(xbgr.mr_n72857808)
print v(xbgr.mr_n73107184)
print v(xbgr.mr_n73211888)
print v(xbgr.mr_n73506304)
print v(xbgr.mr_n74203024)
print v(xbgr.mr_n74348480)
print v(xbgr.mr_n74416160)
print v(xbgr.mr_n74492176)
print v(xbgr.mr_n74620448)
print v(xbgr.mr_n74743712)
print v(xbgr.mr_n74812336)
print v(xbgr.mr_n74936688)
print v(xbgr.mr_n73570928)
print v(xbgr.mr_n73657792)
print v(xbgr.mr_n73889872)
print v(xbgr.mr_n74075232)
print v(xbgr.mr_n75234048)
print v(xbgr.mr_n75450560)
print v(xbgr.mr_n75557232)
print v(xbgr.mr_n73569280)
print v(xbgr.mr_n73653776)
print v(xbgr.mr_n73891376)
print v(xbgr.mr_n74079056)
print v(xbgr.mr_n72857344)
print v(xbgr.mr_n73107776)
print v(xbgr.mr_n73209888)
print v(xbgr.mr_n73512304)
print v(xbgr.mr_n75233056)
print v(xbgr.mr_n75375696)
print v(xbgr.mr_n75650352)
print v(xbgr.mr_n73516496)
print v(xbgr.mr_n73608144)
print v(xbgr.mr_n73713168)
print v(xbgr.mr_n73942688)
print v(xbgr.mr_n72854640)
print v(xbgr.mr_n73108368)
print v(xbgr.mr_n73285680)
print v(xbgr.mr_n73350992)
print v(xbgr.mr_n75033392)
print v(xbgr.mr_n75249744)
print v(xbgr.mr_n75466016)
print v(xbgr.mr_n75234384)
print v(xbgr.mr_n75376880)
print v(xbgr.mr_n75652736)
print v(xbgr.mr_n73556176)
print v(xbgr.mr_n73657440)
print v(xbgr.mr_n73860224)
print v(xbgr.mr_n74079584)
print v(xbgr.mr_n72698816)
print v(xbgr.mr_n73108960)
print v(xbgr.mr_n73287120)
print v(xbgr.mr_n73350320)
print v(xbgr.mr_n74200816)
print v(xbgr.mr_n74346832)
print v(xbgr.mr_n74414512)
print v(xbgr.mr_n74478272)
print v(xbgr.mr_n74617632)
print v(xbgr.mr_n74738944)
print v(xbgr.mr_n74846512)
print v(xbgr.mr_n74972416)
print v(xbgr.mr_n74199856)
print v(xbgr.mr_n74348112)
print v(xbgr.mr_n74415792)
print v(xbgr.mr_n74487824)
print v(xbgr.mr_n74621168)
print v(xbgr.mr_n74739360)
print v(xbgr.mr_n74846864)
print v(xbgr.mr_n74968944)
print v(xbgr.mr_n75235312)
print v(xbgr.mr_n75449472)
print v(xbgr.mr_n75652912)
print v(xbgr.mr_n72855952)
print v(xbgr.mr_n73109552)
print v(xbgr.mr_n73287520)
print v(xbgr.mr_n73346848)
print v(xbgr.mr_n74111792)
print v(xbgr.mr_n74222144)
print v(xbgr.mr_n74361792)
print v(xbgr.mr_n74429504)
print v(xbgr.mr_n74511552)
print v(xbgr.mr_n74635984)
print v(xbgr.mr_n74761040)
print v(xbgr.mr_n74894528)
print v(xbgr.mr_n75227664)
print v(xbgr.mr_n75376288)
print v(xbgr.mr_n75547568)
print v(xbgr.mr_n72855568)
print v(xbgr.mr_n73110144)
print v(xbgr.mr_n73288720)
print v(xbgr.mr_n73325536)
print v(xbgr.mr_n75032928)
print v(xbgr.mr_n75249280)
print v(xbgr.mr_n75465552)
print v(xbgr.mr_n74197152)
print v(xbgr.mr_n74349328)
print v(xbgr.mr_n74417008)
print v(xbgr.mr_n74491200)
print v(xbgr.mr_n74619792)
print v(xbgr.mr_n74742736)
print v(xbgr.mr_n74818256)
print v(xbgr.mr_n74941360)
print v(xbgr.mr_n73562448)
print v(xbgr.mr_n73659360)
print v(xbgr.mr_n73880656)
print v(xbgr.mr_n74073312)
print v(xbgr.mr_n75229856)
print v(xbgr.mr_n75377472)
print v(xbgr.mr_n75650176)
print v(xbgr.mr_n73569712)
print v(xbgr.mr_n73658480)
print v(xbgr.mr_n73889328)
print v(xbgr.mr_n74076800)
print v(xbgr.mr_n72855104)
print v(xbgr.mr_n73110736)
print v(xbgr.mr_n73289520)
print v(xbgr.mr_n73348624)
print v(xbgr.mr_n73516224)
print v(xbgr.mr_n73607392)
print v(xbgr.mr_n73679408)
print v(xbgr.mr_n73941504)
print v(xbgr.mr_n72699088)
print v(xbgr.mr_n73111328)
print v(xbgr.mr_n73289920)
print v(xbgr.mr_n73348032)
print v(xbgr.mr_n75230768)
print v(xbgr.mr_n75647616)
print v(xbgr.mr_n72854176)
print v(xbgr.mr_n73111920)
print v(xbgr.mr_n73291120)
print v(xbgr.mr_n73347360)
print v(xbgr.mr_n75231440)
print v(xbgr.mr_n75560096)
print v(xbgr.mr_n73568256)
print v(xbgr.mr_n73648464)
print v(xbgr.mr_n73859376)
print v(xbgr.mr_n74081088)
print v(xbgr.mr_n74194976)
print v(xbgr.mr_n74302240)
print v(xbgr.mr_n74413344)
print v(xbgr.mr_n74489824)
print v(xbgr.mr_n74619296)
print v(xbgr.mr_n74741360)
print v(xbgr.mr_n74835184)
print v(xbgr.mr_n74973584)
print v(xbgr.mr_n74198624)
print v(xbgr.mr_n74350880)
print v(xbgr.mr_n74418560)
print v(xbgr.mr_n74495216)
print v(xbgr.mr_n74622464)
print v(xbgr.mr_n74746752)
print v(xbgr.mr_n74839408)
print v(xbgr.mr_n74966064)
print v(xbgr.mr_n75032464)
print v(xbgr.mr_n75465088)
print v(xbgr.mr_n72853712)
print v(xbgr.mr_n73112512)
print v(xbgr.mr_n73291520)
print v(xbgr.mr_n73343888)
print v(xbgr.mr_n75229424)
print v(xbgr.mr_n75652576)
print v(xbgr.mr_n74111328)
print v(xbgr.mr_n74221216)
print v(xbgr.mr_n74361248)
print v(xbgr.mr_n74428960)
print v(xbgr.mr_n74512096)
print v(xbgr.mr_n74635440)
print v(xbgr.mr_n74760496)
print v(xbgr.mr_n74893984)
print v(xbgr.mr_n72853248)
print v(xbgr.mr_n73113104)
print v(xbgr.mr_n73292720)
print v(xbgr.mr_n73346256)
print v(xbgr.mr_n75222688)
print v(xbgr.mr_n75567248)
print v(xbgr.mr_n74194432)
print v(xbgr.mr_n74352288)
print v(xbgr.mr_n74419968)
print v(xbgr.mr_n74496880)
print v(xbgr.mr_n74620800)
print v(xbgr.mr_n74748352)
print v(xbgr.mr_n74793984)
print v(xbgr.mr_n74942016)
print v(xbgr.mr_n73564064)
print v(xbgr.mr_n73660928)
print v(xbgr.mr_n73885808)
print v(xbgr.mr_n74072096)
print v(xbgr.mr_n72852784)
print v(xbgr.mr_n73113696)
print v(xbgr.mr_n73293520)
print v(xbgr.mr_n73345664)
print v(xbgr.mr_n73566080)
print v(xbgr.mr_n73660048)
print v(xbgr.mr_n73888832)
print v(xbgr.mr_n74080624)
print v(xbgr.mr_n75226336)
print v(xbgr.mr_n75524432)
print v(xbgr.mr_n75031536)
print v(xbgr.mr_n75464160)
print v(xbgr.mr_n72852320)
print v(xbgr.mr_n73114288)
print v(xbgr.mr_n73293920)
print v(xbgr.mr_n73345072)
print v(xbgr.mr_n73515952)
print v(xbgr.mr_n73605280)
print v(xbgr.mr_n73759840)
print v(xbgr.mr_n73940320)
print v(xbgr.mr_n75224976)
print v(xbgr.mr_n75526688)
print v(xbgr.mr_n72851856)
print v(xbgr.mr_n73114880)
print v(xbgr.mr_n73294720)
print v(xbgr.mr_n73344400)
print v(xbgr.mr_n73565280)
print v(xbgr.mr_n73654160)
print v(xbgr.mr_n73816864)
print v(xbgr.mr_n74079936)
print v(xbgr.mr_n74188272)
print v(xbgr.mr_n74348896)
print v(xbgr.mr_n74416576)
print v(xbgr.mr_n74492528)
print v(xbgr.mr_n74623440)
print v(xbgr.mr_n74749456)
print v(xbgr.mr_n74843088)
print v(xbgr.mr_n74951072)
print v(xbgr.mr_n75224160)
print v(xbgr.mr_n75574368)
print v(xbgr.mr_n74195456)
print v(xbgr.mr_n74353072)
print v(xbgr.mr_n74420752)
print v(xbgr.mr_n74497920)
print v(xbgr.mr_n74624400)
print v(xbgr.mr_n74747920)
print v(xbgr.mr_n74845616)
print v(xbgr.mr_n74969360)
print v(xbgr.mr_n72851392)
print v(xbgr.mr_n73115472)
print v(xbgr.mr_n73295520)
print v(xbgr.mr_n73340928)
print v(xbgr.mr_n75224720)
print v(xbgr.mr_n75523616)
print v(xbgr.mr_n74110864)
print v(xbgr.mr_n74220752)
print v(xbgr.mr_n74360976)
print v(xbgr.mr_n74428688)
print v(xbgr.mr_n74511824)
print v(xbgr.mr_n74635168)
print v(xbgr.mr_n74760224)
print v(xbgr.mr_n74893712)
print v(xbgr.mr_n72850928)
print v(xbgr.mr_n73116064)
print v(xbgr.mr_n73296720)
print v(xbgr.mr_n73343296)
print v(xbgr.mr_n75031072)
print v(xbgr.mr_n75463696)
print v(xbgr.mr_n75222352)
print v(xbgr.mr_n75536352)
print v(xbgr.mr_n72850464)
print v(xbgr.mr_n73116656)
print v(xbgr.mr_n73297120)
print v(xbgr.mr_n73342704)
print v(xbgr.mr_n74193968)
print v(xbgr.mr_n74351504)
print v(xbgr.mr_n74419184)
print v(xbgr.mr_n74495904)
print v(xbgr.mr_n74621856)
print v(xbgr.mr_n74745632)
print v(xbgr.mr_n74817072)
print v(xbgr.mr_n74939584)
print v(xbgr.mr_n73565968)
print v(xbgr.mr_n73662496)
print v(xbgr.mr_n73886784)
print v(xbgr.mr_n74078368)
print v(xbgr.mr_n73566816)
print v(xbgr.mr_n73663184)
print v(xbgr.mr_n73887504)
print v(xbgr.mr_n74082192)
print v(xbgr.mr_n75221584)
print v(xbgr.mr_n75448384)
print v(xbgr.mr_n75548880)
print v(xbgr.mr_n72850000)
print v(xbgr.mr_n73117248)
print v(xbgr.mr_n73297920)
print v(xbgr.mr_n73342112)
print v(xbgr.mr_n73515680)
print v(xbgr.mr_n73604224)
print v(xbgr.mr_n72735136)
print v(xbgr.mr_n73939136)
print v(xbgr.mr_n75219680)
print v(xbgr.mr_n75375104)
print v(xbgr.mr_n75653104)
print v(xbgr.mr_n72849536)
print v(xbgr.mr_n73117840)
print v(xbgr.mr_n73081152)
print v(xbgr.mr_n73341440)
print v(xbgr.mr_n75030608)
print v(xbgr.mr_n75248832)
print v(xbgr.mr_n75463232)
print v(xbgr.mr_n73562272)
print v(xbgr.mr_n73658864)
print v(xbgr.mr_n73859488)
print v(xbgr.mr_n74081504)
print v(xbgr.mr_n74192976)
print v(xbgr.mr_n74353888)
print v(xbgr.mr_n74414080)
print v(xbgr.mr_n74498800)
print v(xbgr.mr_n74621968)
print v(xbgr.mr_n74750336)
print v(xbgr.mr_n74839296)
print v(xbgr.mr_n74965952)
print v(xbgr.mr_n75219504)
print v(xbgr.mr_n75374512)
print v(xbgr.mr_n75523040)
print v(xbgr.mr_n74189536)
print v(xbgr.mr_n74349728)
print v(xbgr.mr_n74422304)
print v(xbgr.mr_n74493680)
print v(xbgr.mr_n74626400)
print v(xbgr.mr_n74746064)
print v(xbgr.mr_n74838592)
print v(xbgr.mr_n74970176)
print v(xbgr.mr_n72698176)
print v(xbgr.mr_n73118432)
print v(xbgr.mr_n73299520)
print v(xbgr.mr_n73337968)
print v(xbgr.mr_n74110400)
print v(xbgr.mr_n74219824)
print v(xbgr.mr_n74360432)
print v(xbgr.mr_n74428416)
print v(xbgr.mr_n74511280)
print v(xbgr.mr_n74634624)
print v(xbgr.mr_n74759680)
print v(xbgr.mr_n74893168)
print v(xbgr.mr_n72846288)
print v(xbgr.mr_n73119024)
print v(xbgr.mr_n73300784)
print v(xbgr.mr_n73340336)
print v(xbgr.mr_n75215056)
print v(xbgr.mr_n75447840)
print v(xbgr.mr_n75561408)
print v(xbgr.mr_n72848144)
print v(xbgr.mr_n73119616)
print v(xbgr.mr_n73301376)
print v(xbgr.mr_n73339744)
print v(xbgr.mr_n75216912)
print v(xbgr.mr_n75373920)
print v(xbgr.mr_n75655760)
print v(xbgr.mr_n74190144)
print v(xbgr.mr_n74355968)
print v(xbgr.mr_n74423712)
print v(xbgr.mr_n74497232)
print v(xbgr.mr_n74628064)
print v(xbgr.mr_n74753120)
print v(xbgr.mr_n74811824)
print v(xbgr.mr_n74940240)
print v(xbgr.mr_n73563456)
print v(xbgr.mr_n73664064)
print v(xbgr.mr_n73883200)
print v(xbgr.mr_n74083760)
print v(xbgr.mr_n73565104)
print v(xbgr.mr_n73660512)
print v(xbgr.mr_n73886288)
print v(xbgr.mr_n74085328)
print v(xbgr.mr_n75029680)
print v(xbgr.mr_n75248368)
print v(xbgr.mr_n75462304)
print v(xbgr.mr_n72847680)
print v(xbgr.mr_n73120208)
print v(xbgr.mr_n73303152)
print v(xbgr.mr_n73339152)
print v(xbgr.mr_n75208384)
print v(xbgr.mr_n75373328)
print v(xbgr.mr_n75653216)
print v(xbgr.mr_n73515408)
print v(xbgr.mr_n73603168)
print v(xbgr.mr_n72798928)
print v(xbgr.mr_n73937952)
print v(xbgr.mr_n72847216)
print v(xbgr.mr_n73120800)
print v(xbgr.mr_n73304336)
print v(xbgr.mr_n73338480)
print v(xbgr.mr_n75215280)
print v(xbgr.mr_n75446752)
print v(xbgr.mr_n75570768)
print v(xbgr.mr_n73560912)
print v(xbgr.mr_n73662080)
print v(xbgr.mr_n73823008)
print v(xbgr.mr_n74062464)
print v(xbgr.mr_n72846752)
print v(xbgr.mr_n73121392)
print v(xbgr.mr_n73304928)
print v(xbgr.mr_n73335008)
print v(xbgr.mr_n74189968)
print v(xbgr.mr_n74355600)
print v(xbgr.mr_n74418256)
print v(xbgr.mr_n74501088)
print v(xbgr.mr_n74623616)
print v(xbgr.mr_n74751456)
print v(xbgr.mr_n74824768)
print v(xbgr.mr_n74966768)
print v(xbgr.mr_n74191184)
print v(xbgr.mr_n74356816)
print v(xbgr.mr_n74420320)
print v(xbgr.mr_n74502624)
print v(xbgr.mr_n74623968)
print v(xbgr.mr_n74748768)
print v(xbgr.mr_n74841888)
print v(xbgr.mr_n74965600)
print v(xbgr.mr_n75214544)
print v(xbgr.mr_n75372384)
print v(xbgr.mr_n75655264)
print v(xbgr.mr_n75029216)
print v(xbgr.mr_n75247664)
print v(xbgr.mr_n75461840)
print v(xbgr.mr_n72698512)
print v(xbgr.mr_n73121984)
print v(xbgr.mr_n73306112)
print v(xbgr.mr_n73337376)
print v(xbgr.mr_n74109936)
print v(xbgr.mr_n74219360)
print v(xbgr.mr_n74360160)
print v(xbgr.mr_n74428144)
print v(xbgr.mr_n74511008)
print v(xbgr.mr_n74634352)
print v(xbgr.mr_n74759408)
print v(xbgr.mr_n74892896)
print v(xbgr.mr_n75214432)
print v(xbgr.mr_n75368000)
print v(xbgr.mr_n75653328)
print v(xbgr.mr_n72845824)
print v(xbgr.mr_n73122576)
print v(xbgr.mr_n73306704)
print v(xbgr.mr_n73336704)
print v(xbgr.mr_n74186592)
print v(xbgr.mr_n74357280)
print v(xbgr.mr_n74424496)
print v(xbgr.mr_n74500544)
print v(xbgr.mr_n74627088)
print v(xbgr.mr_n74754160)
print v(xbgr.mr_n74815888)
print v(xbgr.mr_n74937808)
print v(xbgr.mr_n73561712)
print v(xbgr.mr_n73665632)
print v(xbgr.mr_n73884240)
print v(xbgr.mr_n74054128)
print v(xbgr.mr_n73563888)
print v(xbgr.mr_n73666320)
print v(xbgr.mr_n73884960)
print v(xbgr.mr_n74062576)
print v(xbgr.mr_n75212608)
print v(xbgr.mr_n75446208)
print v(xbgr.mr_n75655872)
print v(xbgr.mr_n72845360)
print v(xbgr.mr_n73123168)
print v(xbgr.mr_n73291920)
print v(xbgr.mr_n73324352)
print v(xbgr.mr_n75207888)
print v(xbgr.mr_n75372208)
print v(xbgr.mr_n75657456)
print v(xbgr.mr_n73515136)
print v(xbgr.mr_n73602112)
print v(xbgr.mr_n73670848)
print v(xbgr.mr_n73936768)
print v(xbgr.mr_n72844896)
print v(xbgr.mr_n73123760)
print v(xbgr.mr_n73303744)
print v(xbgr.mr_n73335520)
print v(xbgr.mr_n75028752)
print v(xbgr.mr_n75247552)
print v(xbgr.mr_n75461376)
print v(xbgr.mr_n75200448)
print v(xbgr.mr_n75366224)
print v(xbgr.mr_n75658064)
print v(xbgr.mr_n72844432)
print v(xbgr.mr_n73124352)
print v(xbgr.mr_n73302560)
print v(xbgr.mr_n73332048)
print v(xbgr.mr_n73559536)
print v(xbgr.mr_n73665216)
print v(xbgr.mr_n73859264)
print v(xbgr.mr_n74059920)
print v(xbgr.mr_n74181424)
print v(xbgr.mr_n74354624)
print v(xbgr.mr_n74425312)
print v(xbgr.mr_n74503504)
print v(xbgr.mr_n74625712)
print v(xbgr.mr_n74750768)
print v(xbgr.mr_n74824176)
print v(xbgr.mr_n74953808)
print v(xbgr.mr_n74183280)
print v(xbgr.mr_n74350576)
print v(xbgr.mr_n74422000)
print v(xbgr.mr_n74499232)
print v(xbgr.mr_n74631104)
print v(xbgr.mr_n74756160)
print v(xbgr.mr_n74841536)
print v(xbgr.mr_n74959248)
print v(xbgr.mr_n72843968)
print v(xbgr.mr_n73124944)
print v(xbgr.mr_n73283584)
print v(xbgr.mr_n73334416)
print v(xbgr.mr_n75209984)
print v(xbgr.mr_n75444032)
print v(xbgr.mr_n75654768)
print v(xbgr.mr_n74109472)
print v(xbgr.mr_n74218432)
print v(xbgr.mr_n74359616)
print v(xbgr.mr_n74427872)
print v(xbgr.mr_n74510464)
print v(xbgr.mr_n74633808)
print v(xbgr.mr_n74758864)
print v(xbgr.mr_n74892352)
print v(xbgr.mr_n75204960)
print v(xbgr.mr_n75371552)
print v(xbgr.mr_n75660560)
print v(xbgr.mr_n72843504)
print v(xbgr.mr_n73125536)
print v(xbgr.mr_n73300320)
print v(xbgr.mr_n73333824)
print v(xbgr.mr_n75027824)
print v(xbgr.mr_n75173312)
print v(xbgr.mr_n75460448)
print v(xbgr.mr_n74186416)
print v(xbgr.mr_n74353536)
print v(xbgr.mr_n74424896)
print v(xbgr.mr_n74506288)
print v(xbgr.mr_n74625280)
print v(xbgr.mr_n74747440)
print v(xbgr.mr_n74815296)
print v(xbgr.mr_n74938464)
print v(xbgr.mr_n73560736)
print v(xbgr.mr_n73667200)
print v(xbgr.mr_n73882240)
print v(xbgr.mr_n74039696)
print v(xbgr.mr_n73561600)
print v(xbgr.mr_n73663712)
print v(xbgr.mr_n73883744)
print v(xbgr.mr_n74055664)
print v(xbgr.mr_n75209488)
print v(xbgr.mr_n75368656)
print v(xbgr.mr_n75661904)
print v(xbgr.mr_n72843040)
print v(xbgr.mr_n73126128)
print v(xbgr.mr_n73299920)
print v(xbgr.mr_n73333232)
print v(xbgr.mr_n73514864)
print v(xbgr.mr_n73577616)
print v(xbgr.mr_n73709568)
print v(xbgr.mr_n73935584)
print v(xbgr.mr_n72842576)
print v(xbgr.mr_n73126720)
print v(xbgr.mr_n73298720)
print v(xbgr.mr_n73332560)
print v(xbgr.mr_n75206960)
print v(xbgr.mr_n75444576)
print v(xbgr.mr_n75657952)
print v(xbgr.mr_n72842112)
print v(xbgr.mr_n73103632)
print v(xbgr.mr_n73298320)
print v(xbgr.mr_n73329088)
print v(xbgr.mr_n75205136)
print v(xbgr.mr_n75369776)
print v(xbgr.mr_n75663472)
print v(xbgr.mr_n73549632)
print v(xbgr.mr_n73666848)
print v(xbgr.mr_n73844208)
print v(xbgr.mr_n74040080)
print v(xbgr.mr_n74187472)
print v(xbgr.mr_n74347760)
print v(xbgr.mr_n74423280)
print v(xbgr.mr_n74504624)
print v(xbgr.mr_n74627568)
print v(xbgr.mr_n74744064)
print v(xbgr.mr_n74838064)
print v(xbgr.mr_n74959952)
print v(xbgr.mr_n74185616)
print v(xbgr.mr_n74351856)
print v(xbgr.mr_n74417824)
print v(xbgr.mr_n74501936)
print v(xbgr.mr_n74622960)
print v(xbgr.mr_n74752624)
print v(xbgr.mr_n74838480)
print v(xbgr.mr_n74962544)
print v(xbgr.mr_n75027360)
print v(xbgr.mr_n75172848)
print v(xbgr.mr_n75459984)
print v(xbgr.mr_n72841648)
print v(xbgr.mr_n73127824)
print v(xbgr.mr_n73297520)
print v(xbgr.mr_n73331456)
print v(xbgr.mr_n75206256)
print v(xbgr.mr_n75370432)
print v(xbgr.mr_n75661728)
print v(xbgr.mr_n74109008)
print v(xbgr.mr_n74217968)
print v(xbgr.mr_n74359344)
print v(xbgr.mr_n74427600)
print v(xbgr.mr_n74510192)
print v(xbgr.mr_n74633536)
print v(xbgr.mr_n74758592)
print v(xbgr.mr_n74892080)
print v(xbgr.mr_n72841184)
print v(xbgr.mr_n73128496)
print v(xbgr.mr_n73296320)
print v(xbgr.mr_n73330864)
print v(xbgr.mr_n75202432)
print v(xbgr.mr_n75441344)
print v(xbgr.mr_n75664464)
print v(xbgr.mr_n74183968)
print v(xbgr.mr_n74303040)
print v(xbgr.mr_n74421216)
print v(xbgr.mr_n74494096)
print v(xbgr.mr_n74624928)
print v(xbgr.mr_n74749984)
print v(xbgr.mr_n74814704)
print v(xbgr.mr_n74932736)
print v(xbgr.mr_n72698400)
print v(xbgr.mr_n73129088)
print v(xbgr.mr_n73295920)
print v(xbgr.mr_n73330272)
print v(xbgr.mr_n73558800)
print v(xbgr.mr_n73668768)
print v(xbgr.mr_n73878176)
print v(xbgr.mr_n74049808)
print v(xbgr.mr_n73558688)
print v(xbgr.mr_n73667888)
print v(xbgr.mr_n73881696)
print v(xbgr.mr_n74042832)
print v(xbgr.mr_n75202176)
print v(xbgr.mr_n75364448)
print v(xbgr.mr_n75666032)
print v(xbgr.mr_n72840256)
print v(xbgr.mr_n73129680)
print v(xbgr.mr_n73295120)
print v(xbgr.mr_n73329600)
print v(xbgr.mr_n75026896)
print v(xbgr.mr_n75172384)
print v(xbgr.mr_n75459520)
print v(xbgr.mr_n73514592)
print v(xbgr.mr_n73583216)
print v(xbgr.mr_n73709456)
print v(xbgr.mr_n73934400)
print v(xbgr.mr_n75197504)
print v(xbgr.mr_n75365104)
print v(xbgr.mr_n75668592)
print v(xbgr.mr_n72839792)
print v(xbgr.mr_n73130272)
print v(xbgr.mr_n73294320)
print v(xbgr.mr_n73326048)
print v(xbgr.mr_n73559360)
print v(xbgr.mr_n73664752)
print v(xbgr.mr_n73859040)
print v(xbgr.mr_n74047888)
print v(xbgr.mr_n74184576)
print v(xbgr.mr_n74302624)
print v(xbgr.mr_n74415440)
print v(xbgr.mr_n74505792)
print v(xbgr.mr_n74618800)
print v(xbgr.mr_n74740928)
print v(xbgr.mr_n74833744)
print v(xbgr.mr_n74954384)
print v(xbgr.mr_n74181248)
print v(xbgr.mr_n74301424)
print v(xbgr.mr_n74419536)
print v(xbgr.mr_n74501520)
print v(xbgr.mr_n74615232)
print v(xbgr.mr_n74744752)
print v(xbgr.mr_n74835072)
print v(xbgr.mr_n74963360)
print v(xbgr.mr_n75203792)
print v(xbgr.mr_n75442944)
print v(xbgr.mr_n75667024)
print v(xbgr.mr_n72839328)
print v(xbgr.mr_n73130864)
print v(xbgr.mr_n73293120)
print v(xbgr.mr_n73328496)
print v(xbgr.mr_n75201168)
print v(xbgr.mr_n75330320)
print v(xbgr.mr_n75664288)
print v(xbgr.mr_n74108544)
print v(xbgr.mr_n74217040)
print v(xbgr.mr_n74358800)
print v(xbgr.mr_n74427328)
print v(xbgr.mr_n74509648)
print v(xbgr.mr_n74632992)
print v(xbgr.mr_n74758048)
print v(xbgr.mr_n74891616)
print v(xbgr.mr_n72837216)
print v(xbgr.mr_n73131456)
print v(xbgr.mr_n73292320)
print v(xbgr.mr_n73327904)
print v(xbgr.mr_n75025968)
print v(xbgr.mr_n75171920)
print v(xbgr.mr_n75458592)
print v(xbgr.mr_n75190480)
print v(xbgr.mr_n75366880)
print v(xbgr.mr_n75669584)
print v(xbgr.mr_n72706112)
print v(xbgr.mr_n73067536)
print v(xbgr.mr_n73287920)
print v(xbgr.mr_n73327312)
print v(xbgr.mr_n74184400)
print v(xbgr.mr_n74337472)
print v(xbgr.mr_n74417408)
print v(xbgr.mr_n74503152)
print v(xbgr.mr_n74621504)
print v(xbgr.mr_n74745216)
print v(xbgr.mr_n74814112)
print v(xbgr.mr_n74889872)
print v(xbgr.mr_n73558000)
print v(xbgr.mr_n73647504)
print v(xbgr.mr_n73879696)
print v(xbgr.mr_n74045664)
print v(xbgr.mr_n73556784)
print v(xbgr.mr_n73648352)
print v(xbgr.mr_n73881200)
print v(xbgr.mr_n74042944)
print v(xbgr.mr_n72705648)
print v(xbgr.mr_n73066944)
print v(xbgr.mr_n73290720)
print v(xbgr.mr_n73326640)
print v(xbgr.mr_n75184032)
print v(xbgr.mr_n75441856)
print v(xbgr.mr_n75666848)
print v(xbgr.mr_n73514320)
print v(xbgr.mr_n73580352)
print v(xbgr.mr_n73682576)
print v(xbgr.mr_n73933536)
print v(xbgr.mr_n72705184)
print v(xbgr.mr_n73066352)
print v(xbgr.mr_n73290320)
print v(xbgr.mr_n73322080)
print v(xbgr.mr_n75199504)
print v(xbgr.mr_n75323200)
print v(xbgr.mr_n75674528)
print v(xbgr.mr_n75025504)
print v(xbgr.mr_n75171456)
print v(xbgr.mr_n75458128)
print v(xbgr.mr_n73554720)
print v(xbgr.mr_n72711488)
print v(xbgr.mr_n73829152)
print v(xbgr.mr_n74039584)
print v(xbgr.mr_n74179344)
print v(xbgr.mr_n74327216)
print v(xbgr.mr_n74411280)
print v(xbgr.mr_n74499920)
print v(xbgr.mr_n74613088)
print v(xbgr.mr_n74732160)
print v(xbgr.mr_n74835888)
print v(xbgr.mr_n74958720)
print v(xbgr.mr_n72704720)
print v(xbgr.mr_n73065760)
print v(xbgr.mr_n73289120)
print v(xbgr.mr_n73286720)
print v(xbgr.mr_n74177168)
print v(xbgr.mr_n74301776)
print v(xbgr.mr_n74413456)
print v(xbgr.mr_n74498448)
print v(xbgr.mr_n74620272)
print v(xbgr.mr_n74743216)
print v(xbgr.mr_n74834656)
print v(xbgr.mr_n74959136)
print v(xbgr.mr_n75198992)
print v(xbgr.mr_n75361552)
print v(xbgr.mr_n75672144)
print v(xbgr.mr_n72704256)
print v(xbgr.mr_n73065168)
print v(xbgr.mr_n73288320)
print v(xbgr.mr_n73324864)
print v(xbgr.mr_n74108080)
print v(xbgr.mr_n74216576)
print v(xbgr.mr_n74358528)
print v(xbgr.mr_n74427136)
print v(xbgr.mr_n74509376)
print v(xbgr.mr_n74632720)
print v(xbgr.mr_n74757776)
print v(xbgr.mr_n74891504)
print v(xbgr.mr_n75197168)
print v(xbgr.mr_n75427472)
print v(xbgr.mr_n75669408)
print v(xbgr.mr_n72703792)
print v(xbgr.mr_n73052656)
print v(xbgr.mr_n73285344)
print v(xbgr.mr_n73305520)
print v(xbgr.mr_n75194960)
print v(xbgr.mr_n75362672)
print v(xbgr.mr_n75673712)
print v(xbgr.mr_n74173632)
print v(xbgr.mr_n74319648)
print v(xbgr.mr_n74413728)
print v(xbgr.d4)
print v(xbgr.mr_n74618336)
print v(xbgr.mr_n74740576)
print v(xbgr.mr_n74752080)
print v(xbgr.mr_n74933072)
print v(xbgr.mr_n73555328)
print v(xbgr.mr_n73627600)
print v(xbgr.mr_n73862320)
print v(xbgr.mr_n74037488)
print v(xbgr.mr_n73557824)
print v(xbgr.mr_n73035280)
print v(xbgr.mr_n73879152)
print v(xbgr.mr_n74031472)
print v(xbgr.mr_n75025040)
print v(xbgr.mr_n74977664)
print v(xbgr.mr_n75457664)
print v(xbgr.mr_n72703328)
print v(xbgr.mr_n73061024)
print v(xbgr.mr_n73285088)
print v(xbgr.mr_n73323680)
print v(xbgr.mr_n75194784)
print v(xbgr.mr_n75363328)
print v(xbgr.mr_n75674704)
print v(xbgr.mr_n73508304)
print v(xbgr.mr_n73578336)
print v(xbgr.mr_n73700384)
print v(xbgr.mr_n73932736)
print v(xbgr.mr_n72702864)
print v(xbgr.mr_n73062800)
print v(xbgr.mr_n73286320)
print v(xbgr.mr_n73299120)
print v(xbgr.mr_n75196224)
print v(xbgr.mr_n75435728)
print v(xbgr.mr_n75671968)
print v(xbgr.mr_n73556608)
print v(xbgr.mr_n73645360)
print v(xbgr.mr_n73841440)
print v(xbgr.mr_n74025360)
print v(xbgr.mr_n72702400)
print v(xbgr.mr_n73062208)
print v(xbgr.mr_n73172816)
print v(xbgr.mr_n73509504)
print v(xbgr.mr_n74182304)
print v(xbgr.mr_n74345680)
print v(xbgr.mr_n74397376)
print v(xbgr.mr_n74493216)
print v(xbgr.mr_n74616192)
print v(xbgr.mr_n74737344)
print v(xbgr.mr_n74816480)
print v(xbgr.mr_n74954000)
print v(xbgr.mr_n74180048)
print v(xbgr.mr_n74341648)
print v(xbgr.mr_n74396960)
print v(xbgr.mr_n74496384)
print v(xbgr.mr_n74615616)
print v(xbgr.mr_n74734304)
print v(xbgr.mr_n74834224)
print v(xbgr.mr_n74954192)
print v(xbgr.mr_n75193120)
print v(xbgr.mr_n75361024)
print v(xbgr.mr_n75676272)
print v(xbgr.mr_n72701936)
print v(xbgr.mr_n72737040)
print v(xbgr.mr_n73173408)
print v(xbgr.mr_n73438336)
print v(xbgr.mr_n75024352)
print v(xbgr.mr_n75237968)
print v(xbgr.mr_n75456736)
print v(xbgr.mr_n74107616)
print v(xbgr.mr_n74215648)
print v(xbgr.mr_n74358064)
print v(xbgr.mr_n74427024)
print v(xbgr.mr_n74508832)
print v(xbgr.mr_n74632256)
print v(xbgr.mr_n74757312)
print v(xbgr.mr_n74891280)
print v(xbgr.mr_n75192624)
print v(xbgr.mr_n75358704)
print v(xbgr.mr_n75677264)
print v(xbgr.mr_n72701472)
print v(xbgr.mr_n73060432)
print v(xbgr.mr_n73171632)
print v(xbgr.mr_n73513104)
print v(xbgr.mr_n74178992)
print v(xbgr.mr_n74344848)
print v(xbgr.mr_n74409808)
print v(xbgr.mr_n74489392)
print v(xbgr.mr_n74615008)
print v(xbgr.mr_n74735872)
print v(xbgr.mr_n74755040)
print v(xbgr.mr_n74934912)
print v(xbgr.mr_n73544944)
print v(xbgr.mr_n73878656)
print v(xbgr.mr_n74033392)
print v(xbgr.mr_n73547360)
print v(xbgr.mr_n73860768)
print v(xbgr.mr_n74033504)
print v(xbgr.mr_n75191696)
print v(xbgr.mr_n75439968)
print v(xbgr.mr_n75671152)
print v(xbgr.mr_n72699360)
print v(xbgr.mr_n73059248)
print v(xbgr.mr_n73172224)
print v(xbgr.mr_n73500496)
print v(xbgr.mr_n73623216)
print v(xbgr.mr_n73014480)
print v(xbgr.mr_n75187536)
print v(xbgr.mr_n75359632)
print v(xbgr.mr_n75678832)
print v(xbgr.mr_n73509104)
print v(xbgr.mr_n73624016)
print v(xbgr.mr_n73702432)
print v(xbgr.mr_n73905008)
print v(xbgr.mr_n72897440)
print v(xbgr.n_23)
print v(xbgr.mr_n73170448)
print v(xbgr.mr_n73511904)
print v(xbgr.mr_n73620816)
print v(xbgr.mr_n75024048)
print v(xbgr.mr_n75174592)
print v(xbgr.mr_n75456352)
print v(xbgr.mr_n75190704)
print v(xbgr.mr_n75360096)
print v(xbgr.mr_n75681392)
print v(xbgr.n_12)
print v(xbgr.n_25)
print v(xbgr.mr_n73171040)
print v(xbgr.mr_n73505104)
print v(xbgr.mr_n73549744)
print v(xbgr.mr_n73838064)
print v(xbgr.mr_n72687776)
print v(xbgr.mr_n74179168)
print v(xbgr.mr_n74341840)
print v(xbgr.mr_n74402800)
print v(xbgr.mr_n74486432)
print v(xbgr.mr_n74591280)
print v(xbgr.mr_n74730352)
print v(xbgr.mr_n74822400)
print v(xbgr.mr_n74955136)
print v(xbgr.mr_n74173808)
print v(xbgr.mr_n74289200)
print v(xbgr.mr_n74412384)
print v(xbgr.mr_n74491680)
print v(xbgr.mr_n74615120)
print v(xbgr.mr_n74733808)
print v(xbgr.mr_n74819440)
print v(xbgr.mr_n74949120)
print v(xbgr.mr_n72876368)
print v(xbgr.mr_n72998544)
print v(xbgr.mr_n73169264)
print v(xbgr.mr_n73502624)
print v(xbgr.mr_n75188208)
print v(xbgr.mr_n75429536)
print v(xbgr.mr_n75679824)
print v(xbgr.mr_n74107152)
print v(xbgr.mr_n74215264)
print v(xbgr.mr_n74356384)
print v(xbgr.mr_n74424064)
print v(xbgr.mr_n74508640)
print v(xbgr.mr_n74632144)
print v(xbgr.mr_n74757200)
print v(xbgr.mr_n74890848)
print v(xbgr.n_17)
print v(xbgr.n_22)
print v(xbgr.mr_n73169856)
print v(xbgr.mr_n73504704)
print v(xbgr.mr_n75188032)
print v(xbgr.mr_n75358240)
print v(xbgr.mr_n75677088)
print v(xbgr.mr_n75023744)
print v(xbgr.mr_n75181744)
print v(xbgr.mr_n75456048)
print v(xbgr.mr_n74177504)
print v(xbgr.mr_n74313600)
print v(xbgr.mr_n74394464)
print v(xbgr.mr_n74488976)
print v(xbgr.mr_n74614896)
print v(xbgr.mr_n74731808)
print v(xbgr.mr_n74812000)
print v(xbgr.mr_n74884272)
print v(xbgr.mr_n73542368)
print v(xbgr.mr_n73876608)
print v(xbgr.mr_n73964016)
print v(xbgr.n_18)
print v(xbgr.mr_n72997104)
print v(xbgr.mr_n73168080)
print v(xbgr.mr_n73208336)
print v(xbgr.mr_n73555152)
print v(xbgr.mr_n73877328)
print v(xbgr.mr_n74010816)
print v(xbgr.mr_n75184368)
print v(xbgr.mr_n75319472)
print v(xbgr.mr_n75683952)
print v(xbgr.mr_n73624816)
print v(xbgr.mr_n73606336)
print v(xbgr.mr_n72894576)
print v(xbgr.mr_n72996384)
print v(xbgr.mr_n73168672)
print v(xbgr.mr_n73499632)
print v(xbgr.mr_n73513904)
print v(xbgr.mr_n73007248)
print v(xbgr.mr_n73044192)
print v(xbgr.mr_n73907232)
print v(xbgr.mr_n75186848)
print v(xbgr.mr_n75437904)
print v(xbgr.mr_n75682384)
print v(xbgr.mr_n73009680)
print v(xbgr.mr_n72882400)
print v(xbgr.mr_n72995664)
print v(xbgr.mr_n73167488)
print v(xbgr.mr_n73499744)
print v(xbgr.mr_n73550688)
print v(xbgr.mr_n73839392)
print v(xbgr.mr_n74030656)
print v(xbgr.mr_n75093872)
print v(xbgr.mr_n75332240)
print v(xbgr.mr_n75679648)
print v(xbgr.mr_n74172976)
print v(xbgr.mr_n74259024)
print v(xbgr.mr_n74399120)
print v(xbgr.mr_n74485808)
print v(xbgr.mr_n74608960)
print v(xbgr.mr_n74707680)
print v(xbgr.mr_n74823584)
print v(xbgr.mr_n74950896)
print v(xbgr.mr_n74172320)
print v(xbgr.mr_n74259200)
print v(xbgr.mr_n74400096)
print v(xbgr.mr_n74482960)
print v(xbgr.mr_n74598640)
print v(xbgr.mr_n74730960)
print v(xbgr.mr_n74832016)
print v(xbgr.mr_n74953456)
print v(xbgr.mr_n75006336)
print v(xbgr.mr_n75239840)
print v(xbgr.mr_n75452112)
print v(xbgr.mr_n72837024)
print v(xbgr.mr_n72994944)
print v(xbgr.mr_n73165584)
print v(xbgr.mr_n73440768)
print v(xbgr.mr_n75169616)
print v(xbgr.mr_n75332128)
print v(xbgr.mr_n75682208)
print v(xbgr.mr_n74106688)
print v(xbgr.mr_n74199152)
print v(xbgr.mr_n74352640)
print v(xbgr.mr_n74425744)
print v(xbgr.mr_n74507792)
print v(xbgr.mr_n74630416)
print v(xbgr.mr_n74755472)
print v(xbgr.mr_n74890672)
print v(xbgr.mr_n75177088)
print v(xbgr.mr_n75440080)
print v(xbgr.mr_n75684944)
print v(xbgr.mr_n72831552)
print v(xbgr.mr_n74171008)
print v(xbgr.mr_n74201312)
print v(xbgr.mr_n74399728)
print v(xbgr.mr_n74484272)
print v(xbgr.mr_n74605728)
print v(xbgr.mr_n74707792)
print v(xbgr.mr_n74756848)
print v(xbgr.mr_n74889248)
print v(xbgr.mr_n73539952)
print v(xbgr.mr_n73861584)
print v(xbgr.mr_n74028320)
print v(xbgr.mr_n73549936)
print v(xbgr.mr_n73874880)
print v(xbgr.mr_n74028432)
print v(xbgr.mr_n75177264)
print v(xbgr.mr_n75328624)
print v(xbgr.mr_n75686512)
print v(xbgr.mr_n73005424)
print v(xbgr.mr_n75011936)
print v(xbgr.mr_n75235872)
print v(xbgr.mr_n75455376)
print v(xbgr.mr_n73511504)
print v(xbgr.mr_n73006032)
print v(xbgr.mr_n73650192)
print v(xbgr.mr_n73788720)
print v(xbgr.mr_n72724320)
print v(xbgr.mr_n75070384)
print v(xbgr.mr_n75317664)
print v(xbgr.mr_n75684768)
print v(xbgr.mr_n73546608)
print v(xbgr.mr_n73845536)
print v(xbgr.mr_n73965920)
print v(dvbe)
print v(iptat)
print v(pbias)
print v(pcasc)
print v(r4)
print v(vbe)
print v(vdd)
print v(vref)
print v(vdd)-v(vdd)
echo METALLIC_POINT_VOLTAGES_END
echo METALLIC_ALL_NODE_VOLTAGES_BEGIN
print v(xbgr.b1b)
print v(xbgr.c2)
print v(xbgr.d1)
print v(xbgr.d2)
print v(xbgr.d3)
print v(xbgr.d4)
print v(xbgr.d5)
print v(xbgr.det)
print v(dvbe)
print v(iptat)
print v(xbgr.kick)
print v(xbgr.mr_n59578144)
print v(xbgr.mr_n59583200)
print v(xbgr.mr_n59623760)
print v(xbgr.mr_n61508704)
print v(xbgr.mr_n62985824)
print v(xbgr.mr_n62988576)
print v(xbgr.mr_n62988688)
print v(xbgr.mr_n62989104)
print v(xbgr.mr_n62989216)
print v(xbgr.mr_n62989536)
print v(xbgr.mr_n62989648)
print v(xbgr.mr_n62990080)
print v(xbgr.mr_n62990320)
print v(xbgr.mr_n62990432)
print v(xbgr.mr_n62990784)
print v(xbgr.mr_n62991104)
print v(xbgr.mr_n62991216)
print v(xbgr.mr_n62991648)
print v(xbgr.mr_n62991968)
print v(xbgr.mr_n62992080)
print v(xbgr.mr_n62992512)
print v(xbgr.mr_n62992832)
print v(xbgr.mr_n62992944)
print v(xbgr.mr_n62993376)
print v(xbgr.mr_n62993696)
print v(xbgr.mr_n62993808)
print v(xbgr.mr_n62994240)
print v(xbgr.mr_n62994560)
print v(xbgr.mr_n62994672)
print v(xbgr.mr_n62995104)
print v(xbgr.mr_n62995424)
print v(xbgr.mr_n62995536)
print v(xbgr.mr_n62995968)
print v(xbgr.mr_n62996288)
print v(xbgr.mr_n62996400)
print v(xbgr.mr_n62996832)
print v(xbgr.mr_n62997152)
print v(xbgr.mr_n62997264)
print v(xbgr.mr_n62997696)
print v(xbgr.mr_n62998016)
print v(xbgr.mr_n62998128)
print v(xbgr.mr_n62998560)
print v(xbgr.mr_n62998880)
print v(xbgr.mr_n62998992)
print v(xbgr.mr_n62999424)
print v(xbgr.mr_n62999744)
print v(xbgr.mr_n62999856)
print v(xbgr.mr_n63000288)
print v(xbgr.mr_n63000608)
print v(xbgr.mr_n63000720)
print v(xbgr.mr_n63001152)
print v(xbgr.mr_n63001472)
print v(xbgr.mr_n63001584)
print v(xbgr.mr_n63002016)
print v(xbgr.mr_n63002336)
print v(xbgr.mr_n63002448)
print v(xbgr.mr_n63002880)
print v(xbgr.mr_n63003200)
print v(xbgr.mr_n63003312)
print v(xbgr.mr_n63003744)
print v(xbgr.mr_n63004064)
print v(xbgr.mr_n63004176)
print v(xbgr.mr_n63004496)
print v(xbgr.mr_n63004608)
print v(xbgr.mr_n63004928)
print v(xbgr.mr_n63005040)
print v(xbgr.mr_n63005360)
print v(xbgr.mr_n63005472)
print v(xbgr.mr_n63005792)
print v(xbgr.mr_n63005904)
print v(xbgr.mr_n63006224)
print v(xbgr.mr_n63006336)
print v(xbgr.mr_n63006656)
print v(xbgr.mr_n63006768)
print v(xbgr.mr_n63007088)
print v(xbgr.mr_n63007200)
print v(xbgr.mr_n63007520)
print v(xbgr.mr_n63007632)
print v(xbgr.mr_n63007952)
print v(xbgr.mr_n63008064)
print v(xbgr.mr_n63008384)
print v(xbgr.mr_n63008496)
print v(xbgr.mr_n63008816)
print v(xbgr.mr_n63008928)
print v(xbgr.mr_n63009248)
print v(xbgr.mr_n63009360)
print v(xbgr.mr_n63009680)
print v(xbgr.mr_n63009792)
print v(xbgr.mr_n63010112)
print v(xbgr.mr_n63010224)
print v(xbgr.mr_n63010544)
print v(xbgr.mr_n63010656)
print v(xbgr.mr_n63010976)
print v(xbgr.mr_n63011088)
print v(xbgr.mr_n63011408)
print v(xbgr.mr_n63011520)
print v(xbgr.mr_n63011840)
print v(xbgr.mr_n63011952)
print v(xbgr.mr_n63012272)
print v(xbgr.mr_n63012384)
print v(xbgr.mr_n63012704)
print v(xbgr.mr_n63012816)
print v(xbgr.mr_n63013136)
print v(xbgr.mr_n63013248)
print v(xbgr.mr_n63013568)
print v(xbgr.mr_n63013680)
print v(xbgr.mr_n63014000)
print v(xbgr.mr_n63014112)
print v(xbgr.mr_n63014432)
print v(xbgr.mr_n63014544)
print v(xbgr.mr_n63014864)
print v(xbgr.mr_n63014976)
print v(xbgr.mr_n63015296)
print v(xbgr.mr_n63015408)
print v(xbgr.mr_n63015728)
print v(xbgr.mr_n63015840)
print v(xbgr.mr_n63016160)
print v(xbgr.mr_n63016272)
print v(xbgr.mr_n63016592)
print v(xbgr.mr_n63016704)
print v(xbgr.mr_n63017024)
print v(xbgr.mr_n63017136)
print v(xbgr.mr_n63017456)
print v(xbgr.mr_n63017568)
print v(xbgr.mr_n63017888)
print v(xbgr.mr_n63018000)
print v(xbgr.mr_n63018320)
print v(xbgr.mr_n63018432)
print v(xbgr.mr_n63018752)
print v(xbgr.mr_n63018864)
print v(xbgr.mr_n63019184)
print v(xbgr.mr_n63019296)
print v(xbgr.mr_n63019616)
print v(xbgr.mr_n63019728)
print v(xbgr.mr_n63019856)
print v(xbgr.mr_n63019968)
print v(xbgr.mr_n63020288)
print v(xbgr.mr_n63020400)
print v(xbgr.mr_n63020720)
print v(xbgr.mr_n63020832)
print v(xbgr.mr_n63021152)
print v(xbgr.mr_n63021264)
print v(xbgr.mr_n63021584)
print v(xbgr.mr_n63021696)
print v(xbgr.mr_n63022016)
print v(xbgr.mr_n63022128)
print v(xbgr.mr_n63022448)
print v(xbgr.mr_n63022560)
print v(xbgr.mr_n63022880)
print v(xbgr.mr_n63022992)
print v(xbgr.mr_n63023312)
print v(xbgr.mr_n63023424)
print v(xbgr.mr_n63023744)
print v(xbgr.mr_n63023856)
print v(xbgr.mr_n63024176)
print v(xbgr.mr_n63024288)
print v(xbgr.mr_n63024608)
print v(xbgr.mr_n63024720)
print v(xbgr.mr_n63025040)
print v(xbgr.mr_n63025152)
print v(xbgr.mr_n63025472)
print v(xbgr.mr_n63025584)
print v(xbgr.mr_n63025904)
print v(xbgr.mr_n63026016)
print v(xbgr.mr_n63026336)
print v(xbgr.mr_n63026448)
print v(xbgr.mr_n63026768)
print v(xbgr.mr_n63026880)
print v(xbgr.mr_n63027200)
print v(xbgr.mr_n63027312)
print v(xbgr.mr_n63027632)
print v(xbgr.mr_n63027744)
print v(xbgr.mr_n63028064)
print v(xbgr.mr_n63028176)
print v(xbgr.mr_n63028496)
print v(xbgr.mr_n63028608)
print v(xbgr.mr_n63028928)
print v(xbgr.mr_n63029040)
print v(xbgr.mr_n63029360)
print v(xbgr.mr_n63029472)
print v(xbgr.mr_n63029792)
print v(xbgr.mr_n63029904)
print v(xbgr.mr_n63030224)
print v(xbgr.mr_n63030336)
print v(xbgr.mr_n63030656)
print v(xbgr.mr_n63030768)
print v(xbgr.mr_n63031088)
print v(xbgr.mr_n63031200)
print v(xbgr.mr_n63031520)
print v(xbgr.mr_n63031632)
print v(xbgr.mr_n63031952)
print v(xbgr.mr_n63032064)
print v(xbgr.mr_n63032384)
print v(xbgr.mr_n63032496)
print v(xbgr.mr_n63032816)
print v(xbgr.mr_n63032928)
print v(xbgr.mr_n63033248)
print v(xbgr.mr_n63033360)
print v(xbgr.mr_n63033680)
print v(xbgr.mr_n63033792)
print v(xbgr.mr_n63034112)
print v(xbgr.mr_n63034224)
print v(xbgr.mr_n63034544)
print v(xbgr.mr_n63034656)
print v(xbgr.mr_n63034976)
print v(xbgr.mr_n63035088)
print v(xbgr.mr_n63035408)
print v(xbgr.mr_n63035520)
print v(xbgr.mr_n63035840)
print v(xbgr.mr_n63035952)
print v(xbgr.mr_n63036272)
print v(xbgr.mr_n63036384)
print v(xbgr.mr_n63036704)
print v(xbgr.mr_n63036816)
print v(xbgr.mr_n63037136)
print v(xbgr.mr_n63037248)
print v(xbgr.mr_n63037568)
print v(xbgr.mr_n63037680)
print v(xbgr.mr_n63038000)
print v(xbgr.mr_n63038112)
print v(xbgr.mr_n63038432)
print v(xbgr.mr_n63038544)
print v(xbgr.mr_n63038864)
print v(xbgr.mr_n63038976)
print v(xbgr.mr_n63039296)
print v(xbgr.mr_n63039408)
print v(xbgr.mr_n63039728)
print v(xbgr.mr_n63039840)
print v(xbgr.mr_n63040160)
print v(xbgr.mr_n63040272)
print v(xbgr.mr_n63040592)
print v(xbgr.mr_n63040704)
print v(xbgr.mr_n63041024)
print v(xbgr.mr_n63041136)
print v(xbgr.mr_n63041456)
print v(xbgr.mr_n63041568)
print v(xbgr.mr_n63041888)
print v(xbgr.mr_n63042000)
print v(xbgr.mr_n63042320)
print v(xbgr.mr_n63042432)
print v(xbgr.mr_n63042752)
print v(xbgr.mr_n63042864)
print v(xbgr.mr_n63043184)
print v(xbgr.mr_n63043296)
print v(xbgr.mr_n63043616)
print v(xbgr.mr_n63043728)
print v(xbgr.mr_n63044048)
print v(xbgr.mr_n63044160)
print v(xbgr.mr_n63044480)
print v(xbgr.mr_n63044592)
print v(xbgr.mr_n63044912)
print v(xbgr.mr_n63045024)
print v(xbgr.mr_n63045344)
print v(xbgr.mr_n63045456)
print v(xbgr.mr_n63045776)
print v(xbgr.mr_n63045888)
print v(xbgr.mr_n63046208)
print v(xbgr.mr_n63046320)
print v(xbgr.mr_n63046640)
print v(xbgr.mr_n63046752)
print v(xbgr.mr_n63047072)
print v(xbgr.mr_n63047184)
print v(xbgr.mr_n63047504)
print v(xbgr.mr_n63047616)
print v(xbgr.mr_n63047936)
print v(xbgr.mr_n63048048)
print v(xbgr.mr_n63048368)
print v(xbgr.mr_n63048480)
print v(xbgr.mr_n63048800)
print v(xbgr.mr_n63048912)
print v(xbgr.mr_n63049232)
print v(xbgr.mr_n63049344)
print v(xbgr.mr_n63049664)
print v(xbgr.mr_n63049776)
print v(xbgr.mr_n63050096)
print v(xbgr.mr_n63050208)
print v(xbgr.mr_n63050528)
print v(xbgr.mr_n63050640)
print v(xbgr.mr_n63050960)
print v(xbgr.mr_n63051072)
print v(xbgr.mr_n63051392)
print v(xbgr.mr_n63051504)
print v(xbgr.mr_n63051824)
print v(xbgr.mr_n63051936)
print v(xbgr.mr_n63052256)
print v(xbgr.mr_n63052368)
print v(xbgr.mr_n63052688)
print v(xbgr.mr_n63052800)
print v(xbgr.mr_n63053120)
print v(xbgr.mr_n63053232)
print v(xbgr.mr_n63053552)
print v(xbgr.mr_n63053664)
print v(xbgr.mr_n63053984)
print v(xbgr.mr_n63054096)
print v(xbgr.mr_n63054416)
print v(xbgr.mr_n63054528)
print v(xbgr.mr_n63054848)
print v(xbgr.mr_n63054960)
print v(xbgr.mr_n63055280)
print v(xbgr.mr_n63055392)
print v(xbgr.mr_n63055936)
print v(xbgr.mr_n63056048)
print v(xbgr.mr_n63056368)
print v(xbgr.mr_n63056480)
print v(xbgr.mr_n63056800)
print v(xbgr.mr_n63056912)
print v(xbgr.mr_n63057232)
print v(xbgr.mr_n63057344)
print v(xbgr.mr_n63057664)
print v(xbgr.mr_n63057776)
print v(xbgr.mr_n63058096)
print v(xbgr.mr_n63058208)
print v(xbgr.mr_n63058528)
print v(xbgr.mr_n63058640)
print v(xbgr.mr_n63058960)
print v(xbgr.mr_n63059072)
print v(xbgr.mr_n63059392)
print v(xbgr.mr_n63059504)
print v(xbgr.mr_n63059824)
print v(xbgr.mr_n63059936)
print v(xbgr.mr_n63060256)
print v(xbgr.mr_n63060368)
print v(xbgr.mr_n63060688)
print v(xbgr.mr_n63060800)
print v(xbgr.mr_n63061120)
print v(xbgr.mr_n63061232)
print v(xbgr.mr_n63061552)
print v(xbgr.mr_n63061664)
print v(xbgr.mr_n63061984)
print v(xbgr.mr_n63062096)
print v(xbgr.mr_n63062416)
print v(xbgr.mr_n63062528)
print v(xbgr.mr_n63062848)
print v(xbgr.mr_n63062960)
print v(xbgr.mr_n63063280)
print v(xbgr.mr_n63063392)
print v(xbgr.mr_n63063712)
print v(xbgr.mr_n63063824)
print v(xbgr.mr_n63064144)
print v(xbgr.mr_n63064256)
print v(xbgr.mr_n63064576)
print v(xbgr.mr_n63064688)
print v(xbgr.mr_n63065008)
print v(xbgr.mr_n63065120)
print v(xbgr.mr_n63065440)
print v(xbgr.mr_n63065552)
print v(xbgr.mr_n63065872)
print v(xbgr.mr_n63065984)
print v(xbgr.mr_n63066304)
print v(xbgr.mr_n63066416)
print v(xbgr.mr_n63066736)
print v(xbgr.mr_n63066848)
print v(xbgr.mr_n63067168)
print v(xbgr.mr_n63067280)
print v(xbgr.mr_n63067600)
print v(xbgr.mr_n63067712)
print v(xbgr.mr_n63068032)
print v(xbgr.mr_n63068144)
print v(xbgr.mr_n63068464)
print v(xbgr.mr_n63068576)
print v(xbgr.mr_n63068896)
print v(xbgr.mr_n63069008)
print v(xbgr.mr_n63069328)
print v(xbgr.mr_n63069440)
print v(xbgr.mr_n63069760)
print v(xbgr.mr_n63069872)
print v(xbgr.mr_n63070192)
print v(xbgr.mr_n63070304)
print v(xbgr.mr_n63070624)
print v(xbgr.mr_n63070736)
print v(xbgr.mr_n63071056)
print v(xbgr.mr_n63071168)
print v(xbgr.mr_n63071488)
print v(xbgr.mr_n63071600)
print v(xbgr.mr_n63071920)
print v(xbgr.mr_n63072032)
print v(xbgr.mr_n63072352)
print v(xbgr.mr_n63072464)
print v(xbgr.mr_n63072784)
print v(xbgr.mr_n63072896)
print v(xbgr.mr_n63073216)
print v(xbgr.mr_n63073328)
print v(xbgr.mr_n63073648)
print v(xbgr.mr_n63073760)
print v(xbgr.mr_n63074080)
print v(xbgr.mr_n63074192)
print v(xbgr.mr_n63074512)
print v(xbgr.mr_n63074624)
print v(xbgr.mr_n63074944)
print v(xbgr.mr_n63075056)
print v(xbgr.mr_n63075376)
print v(xbgr.mr_n63075488)
print v(xbgr.mr_n63075808)
print v(xbgr.mr_n63075920)
print v(xbgr.mr_n63076240)
print v(xbgr.mr_n63076352)
print v(xbgr.mr_n63076672)
print v(xbgr.mr_n63076784)
print v(xbgr.mr_n63077104)
print v(xbgr.mr_n63077216)
print v(xbgr.mr_n63077536)
print v(xbgr.mr_n63077648)
print v(xbgr.mr_n63077968)
print v(xbgr.mr_n63078080)
print v(xbgr.mr_n63078400)
print v(xbgr.mr_n63078512)
print v(xbgr.mr_n63078832)
print v(xbgr.mr_n63078944)
print v(xbgr.mr_n63079264)
print v(xbgr.mr_n63079376)
print v(xbgr.mr_n63079696)
print v(xbgr.mr_n63079808)
print v(xbgr.mr_n63080128)
print v(xbgr.mr_n63080240)
print v(xbgr.mr_n63080560)
print v(xbgr.mr_n63080672)
print v(xbgr.mr_n63080992)
print v(xbgr.mr_n63081104)
print v(xbgr.mr_n63081424)
print v(xbgr.mr_n63081536)
print v(xbgr.mr_n63081856)
print v(xbgr.mr_n63081968)
print v(xbgr.mr_n63082288)
print v(xbgr.mr_n63082400)
print v(xbgr.mr_n63082720)
print v(xbgr.mr_n63082832)
print v(xbgr.mr_n63083152)
print v(xbgr.mr_n63083264)
print v(xbgr.mr_n63083584)
print v(xbgr.mr_n63083696)
print v(xbgr.mr_n63084016)
print v(xbgr.mr_n63084128)
print v(xbgr.mr_n63084448)
print v(xbgr.mr_n63084560)
print v(xbgr.mr_n63084880)
print v(xbgr.mr_n63084992)
print v(xbgr.mr_n63085312)
print v(xbgr.mr_n63085424)
print v(xbgr.mr_n63085744)
print v(xbgr.mr_n63085856)
print v(xbgr.mr_n63086176)
print v(xbgr.mr_n63086288)
print v(xbgr.mr_n63086608)
print v(xbgr.mr_n63086720)
print v(xbgr.mr_n63087040)
print v(xbgr.mr_n63087152)
print v(xbgr.mr_n63087472)
print v(xbgr.mr_n63087584)
print v(xbgr.mr_n63087904)
print v(xbgr.mr_n63088016)
print v(xbgr.mr_n63088336)
print v(xbgr.mr_n63088448)
print v(xbgr.mr_n63088768)
print v(xbgr.mr_n63088880)
print v(xbgr.mr_n63089200)
print v(xbgr.mr_n63089312)
print v(xbgr.mr_n63089632)
print v(xbgr.mr_n63089744)
print v(xbgr.mr_n63090064)
print v(xbgr.mr_n63090176)
print v(xbgr.mr_n63090496)
print v(xbgr.mr_n63090608)
print v(xbgr.mr_n63090928)
print v(xbgr.mr_n63091040)
print v(xbgr.mr_n63091360)
print v(xbgr.mr_n63091472)
print v(xbgr.mr_n63091792)
print v(xbgr.mr_n63091904)
print v(xbgr.mr_n63092224)
print v(xbgr.mr_n63092336)
print v(xbgr.mr_n63092656)
print v(xbgr.mr_n63092768)
print v(xbgr.mr_n63093088)
print v(xbgr.mr_n63093200)
print v(xbgr.mr_n63093520)
print v(xbgr.mr_n63093632)
print v(xbgr.mr_n63093952)
print v(xbgr.mr_n63094064)
print v(xbgr.mr_n63094384)
print v(xbgr.mr_n63094496)
print v(xbgr.mr_n63094816)
print v(xbgr.mr_n63094928)
print v(xbgr.mr_n63095248)
print v(xbgr.mr_n63095360)
print v(xbgr.mr_n63095680)
print v(xbgr.mr_n63095792)
print v(xbgr.mr_n63096112)
print v(xbgr.mr_n63096224)
print v(xbgr.mr_n63096544)
print v(xbgr.mr_n63096656)
print v(xbgr.mr_n63096976)
print v(xbgr.mr_n63097088)
print v(xbgr.mr_n63097408)
print v(xbgr.mr_n63097520)
print v(xbgr.mr_n63097840)
print v(xbgr.mr_n63097952)
print v(xbgr.mr_n63098272)
print v(xbgr.mr_n63098384)
print v(xbgr.mr_n63098704)
print v(xbgr.mr_n63098816)
print v(xbgr.mr_n63099136)
print v(xbgr.mr_n63099248)
print v(xbgr.mr_n63099568)
print v(xbgr.mr_n63099680)
print v(xbgr.mr_n63100000)
print v(xbgr.mr_n63100112)
print v(xbgr.mr_n63100432)
print v(xbgr.mr_n63100544)
print v(xbgr.mr_n63100864)
print v(xbgr.mr_n63100976)
print v(xbgr.mr_n63101296)
print v(xbgr.mr_n63101408)
print v(xbgr.mr_n63101728)
print v(xbgr.mr_n63101840)
print v(xbgr.mr_n63102160)
print v(xbgr.mr_n63102272)
print v(xbgr.mr_n63102592)
print v(xbgr.mr_n63102704)
print v(xbgr.mr_n63103024)
print v(xbgr.mr_n63103136)
print v(xbgr.mr_n63103456)
print v(xbgr.mr_n63103568)
print v(xbgr.mr_n63103888)
print v(xbgr.mr_n63104000)
print v(xbgr.mr_n63104320)
print v(xbgr.mr_n63104432)
print v(xbgr.mr_n63104752)
print v(xbgr.mr_n63104864)
print v(xbgr.mr_n63105184)
print v(xbgr.mr_n63105296)
print v(xbgr.mr_n63105616)
print v(xbgr.mr_n63105728)
print v(xbgr.mr_n63106048)
print v(xbgr.mr_n63106160)
print v(xbgr.mr_n63106480)
print v(xbgr.mr_n63106592)
print v(xbgr.mr_n63106912)
print v(xbgr.mr_n63107024)
print v(xbgr.mr_n63107344)
print v(xbgr.mr_n63107456)
print v(xbgr.mr_n63107776)
print v(xbgr.mr_n63107888)
print v(xbgr.mr_n63108208)
print v(xbgr.mr_n63108320)
print v(xbgr.mr_n63108640)
print v(xbgr.mr_n63108752)
print v(xbgr.mr_n63109072)
print v(xbgr.mr_n63109184)
print v(xbgr.mr_n63109504)
print v(xbgr.mr_n63109616)
print v(xbgr.mr_n63109936)
print v(xbgr.mr_n63110048)
print v(xbgr.mr_n63110368)
print v(xbgr.mr_n63110480)
print v(xbgr.mr_n63110800)
print v(xbgr.mr_n63110912)
print v(xbgr.mr_n63111232)
print v(xbgr.mr_n63111344)
print v(xbgr.mr_n63111664)
print v(xbgr.mr_n63111776)
print v(xbgr.mr_n63112096)
print v(xbgr.mr_n63112208)
print v(xbgr.mr_n63112528)
print v(xbgr.mr_n63112640)
print v(xbgr.mr_n63112960)
print v(xbgr.mr_n63113072)
print v(xbgr.mr_n63113392)
print v(xbgr.mr_n63113504)
print v(xbgr.mr_n63113824)
print v(xbgr.mr_n63113936)
print v(xbgr.mr_n63114256)
print v(xbgr.mr_n63114368)
print v(xbgr.mr_n63114688)
print v(xbgr.mr_n63114800)
print v(xbgr.mr_n63115120)
print v(xbgr.mr_n63115232)
print v(xbgr.mr_n63115552)
print v(xbgr.mr_n63115664)
print v(xbgr.mr_n63115984)
print v(xbgr.mr_n63116096)
print v(xbgr.mr_n63116416)
print v(xbgr.mr_n63116528)
print v(xbgr.mr_n63116848)
print v(xbgr.mr_n63116960)
print v(xbgr.mr_n63117280)
print v(xbgr.mr_n63117392)
print v(xbgr.mr_n63117712)
print v(xbgr.mr_n63117824)
print v(xbgr.mr_n63118144)
print v(xbgr.mr_n63118256)
print v(xbgr.mr_n63118576)
print v(xbgr.mr_n63118688)
print v(xbgr.mr_n63119008)
print v(xbgr.mr_n63119120)
print v(xbgr.mr_n63119440)
print v(xbgr.mr_n63119552)
print v(xbgr.mr_n63119872)
print v(xbgr.mr_n63119984)
print v(xbgr.mr_n63120304)
print v(xbgr.mr_n63120416)
print v(xbgr.mr_n63120736)
print v(xbgr.mr_n63120848)
print v(xbgr.mr_n63121168)
print v(xbgr.mr_n63121280)
print v(xbgr.mr_n63121600)
print v(xbgr.mr_n63121712)
print v(xbgr.mr_n63122032)
print v(xbgr.mr_n63122144)
print v(xbgr.mr_n63122464)
print v(xbgr.mr_n63122576)
print v(xbgr.mr_n63122896)
print v(xbgr.mr_n63123008)
print v(xbgr.mr_n63123328)
print v(xbgr.mr_n63123440)
print v(xbgr.mr_n63123760)
print v(xbgr.mr_n63123872)
print v(xbgr.mr_n63124192)
print v(xbgr.mr_n63124304)
print v(xbgr.mr_n63124624)
print v(xbgr.mr_n63124736)
print v(xbgr.mr_n63125056)
print v(xbgr.mr_n63125168)
print v(xbgr.mr_n63125488)
print v(xbgr.mr_n63125600)
print v(xbgr.mr_n63125920)
print v(xbgr.mr_n63126032)
print v(xbgr.mr_n63126352)
print v(xbgr.mr_n63126464)
print v(xbgr.mr_n63126784)
print v(xbgr.mr_n63126896)
print v(xbgr.mr_n63127216)
print v(xbgr.mr_n63127328)
print v(xbgr.mr_n63127648)
print v(xbgr.mr_n63127760)
print v(xbgr.mr_n63128080)
print v(xbgr.mr_n63128192)
print v(xbgr.mr_n63128512)
print v(xbgr.mr_n63128624)
print v(xbgr.mr_n63128944)
print v(xbgr.mr_n63129056)
print v(xbgr.mr_n63129376)
print v(xbgr.mr_n63129488)
print v(xbgr.mr_n63129808)
print v(xbgr.mr_n63129920)
print v(xbgr.mr_n63130240)
print v(xbgr.mr_n63130352)
print v(xbgr.mr_n63130672)
print v(xbgr.mr_n63130784)
print v(xbgr.mr_n63131104)
print v(xbgr.mr_n63131216)
print v(xbgr.mr_n63131536)
print v(xbgr.mr_n63131648)
print v(xbgr.mr_n63131968)
print v(xbgr.mr_n63132080)
print v(xbgr.mr_n63132400)
print v(xbgr.mr_n63132512)
print v(xbgr.mr_n63132832)
print v(xbgr.mr_n63132944)
print v(xbgr.mr_n63133264)
print v(xbgr.mr_n63133376)
print v(xbgr.mr_n63133696)
print v(xbgr.mr_n63133808)
print v(xbgr.mr_n63134128)
print v(xbgr.mr_n63134240)
print v(xbgr.mr_n63134560)
print v(xbgr.mr_n63134672)
print v(xbgr.mr_n63134992)
print v(xbgr.mr_n63135104)
print v(xbgr.mr_n63135424)
print v(xbgr.mr_n63135536)
print v(xbgr.mr_n63135856)
print v(xbgr.mr_n63135968)
print v(xbgr.mr_n63136288)
print v(xbgr.mr_n63136400)
print v(xbgr.mr_n63136720)
print v(xbgr.mr_n63136832)
print v(xbgr.mr_n63137152)
print v(xbgr.mr_n63137264)
print v(xbgr.mr_n63137584)
print v(xbgr.mr_n63137696)
print v(xbgr.mr_n63138016)
print v(xbgr.mr_n63138128)
print v(xbgr.mr_n63138448)
print v(xbgr.mr_n63138560)
print v(xbgr.mr_n63138880)
print v(xbgr.mr_n63138992)
print v(xbgr.mr_n63139312)
print v(xbgr.mr_n63139424)
print v(xbgr.mr_n63139744)
print v(xbgr.mr_n63139856)
print v(xbgr.mr_n63140176)
print v(xbgr.mr_n63140288)
print v(xbgr.mr_n63140608)
print v(xbgr.mr_n63140720)
print v(xbgr.mr_n63141040)
print v(xbgr.mr_n63141152)
print v(xbgr.mr_n63141472)
print v(xbgr.mr_n63141584)
print v(xbgr.mr_n63141904)
print v(xbgr.mr_n63142016)
print v(xbgr.mr_n63142336)
print v(xbgr.mr_n63142448)
print v(xbgr.mr_n63142768)
print v(xbgr.mr_n63142880)
print v(xbgr.mr_n63143200)
print v(xbgr.mr_n63143312)
print v(xbgr.mr_n63143632)
print v(xbgr.mr_n63143744)
print v(xbgr.mr_n63144064)
print v(xbgr.mr_n63144176)
print v(xbgr.mr_n63144496)
print v(xbgr.mr_n63144608)
print v(xbgr.mr_n63144928)
print v(xbgr.mr_n63145040)
print v(xbgr.mr_n63145360)
print v(xbgr.mr_n63145472)
print v(xbgr.mr_n63145792)
print v(xbgr.mr_n63145904)
print v(xbgr.mr_n63146224)
print v(xbgr.mr_n63146336)
print v(xbgr.mr_n63146656)
print v(xbgr.mr_n63146768)
print v(xbgr.mr_n63147088)
print v(xbgr.mr_n63147200)
print v(xbgr.mr_n63147520)
print v(xbgr.mr_n63147632)
print v(xbgr.mr_n63147952)
print v(xbgr.mr_n63148064)
print v(xbgr.mr_n63148384)
print v(xbgr.mr_n63148496)
print v(xbgr.mr_n63148816)
print v(xbgr.mr_n63148928)
print v(xbgr.mr_n63149248)
print v(xbgr.mr_n63149360)
print v(xbgr.mr_n63149680)
print v(xbgr.mr_n63149792)
print v(xbgr.mr_n63150112)
print v(xbgr.mr_n63150224)
print v(xbgr.mr_n63150544)
print v(xbgr.mr_n63150656)
print v(xbgr.mr_n63150976)
print v(xbgr.mr_n63151088)
print v(xbgr.mr_n63151408)
print v(xbgr.mr_n63151520)
print v(xbgr.mr_n63151840)
print v(xbgr.mr_n63151952)
print v(xbgr.mr_n63152272)
print v(xbgr.mr_n63152384)
print v(xbgr.mr_n63152704)
print v(xbgr.mr_n63152816)
print v(xbgr.mr_n63153136)
print v(xbgr.mr_n63153248)
print v(xbgr.mr_n63153568)
print v(xbgr.mr_n63153680)
print v(xbgr.mr_n63154000)
print v(xbgr.mr_n63154112)
print v(xbgr.mr_n64158384)
print v(xbgr.mr_n64158496)
print v(xbgr.mr_n64158752)
print v(xbgr.mr_n64158864)
print v(xbgr.mr_n64159120)
print v(xbgr.mr_n64159232)
print v(xbgr.mr_n64159488)
print v(xbgr.mr_n64159600)
print v(xbgr.mr_n64159856)
print v(xbgr.mr_n64159968)
print v(xbgr.mr_n64160224)
print v(xbgr.mr_n64160336)
print v(xbgr.mr_n64160592)
print v(xbgr.mr_n64160704)
print v(xbgr.mr_n64160960)
print v(xbgr.mr_n64161072)
print v(xbgr.mr_n64161328)
print v(xbgr.mr_n64161440)
print v(xbgr.mr_n64161696)
print v(xbgr.mr_n64161808)
print v(xbgr.mr_n64162128)
print v(xbgr.mr_n64162240)
print v(xbgr.mr_n64162560)
print v(xbgr.mr_n64162672)
print v(xbgr.mr_n64162992)
print v(xbgr.mr_n64163104)
print v(xbgr.mr_n64163424)
print v(xbgr.mr_n64163536)
print v(xbgr.mr_n64163856)
print v(xbgr.mr_n64163968)
print v(xbgr.mr_n64164288)
print v(xbgr.mr_n64164400)
print v(xbgr.mr_n64164720)
print v(xbgr.mr_n64164832)
print v(xbgr.mr_n64165152)
print v(xbgr.mr_n64165264)
print v(xbgr.mr_n64165584)
print v(xbgr.mr_n64165696)
print v(xbgr.mr_n64166016)
print v(xbgr.mr_n64166128)
print v(xbgr.mr_n64166448)
print v(xbgr.mr_n64166560)
print v(xbgr.mr_n64166880)
print v(xbgr.mr_n64166992)
print v(xbgr.mr_n64167312)
print v(xbgr.mr_n64167424)
print v(xbgr.mr_n64167744)
print v(xbgr.mr_n64167856)
print v(xbgr.mr_n64168176)
print v(xbgr.mr_n64168288)
print v(xbgr.mr_n64168608)
print v(xbgr.mr_n64168720)
print v(xbgr.mr_n64169040)
print v(xbgr.mr_n64169152)
print v(xbgr.mr_n64169472)
print v(xbgr.mr_n64169584)
print v(xbgr.mr_n64169904)
print v(xbgr.mr_n64170016)
print v(xbgr.mr_n64170336)
print v(xbgr.mr_n64170448)
print v(xbgr.mr_n64170768)
print v(xbgr.mr_n64170880)
print v(xbgr.mr_n64171200)
print v(xbgr.mr_n64171312)
print v(xbgr.mr_n64171632)
print v(xbgr.mr_n64171744)
print v(xbgr.mr_n64172064)
print v(xbgr.mr_n64172176)
print v(xbgr.mr_n64172496)
print v(xbgr.mr_n64172608)
print v(xbgr.mr_n64172928)
print v(xbgr.mr_n64173040)
print v(xbgr.mr_n64173360)
print v(xbgr.mr_n64173472)
print v(xbgr.mr_n64173792)
print v(xbgr.mr_n64173904)
print v(xbgr.mr_n64174224)
print v(xbgr.mr_n64174336)
print v(xbgr.mr_n64174656)
print v(xbgr.mr_n64174768)
print v(xbgr.mr_n64175088)
print v(xbgr.mr_n64175200)
print v(xbgr.mr_n64175520)
print v(xbgr.mr_n64175632)
print v(xbgr.mr_n64175952)
print v(xbgr.mr_n64176064)
print v(xbgr.mr_n64176384)
print v(xbgr.mr_n64176496)
print v(xbgr.mr_n64176816)
print v(xbgr.mr_n64176928)
print v(xbgr.mr_n64177248)
print v(xbgr.mr_n64177360)
print v(xbgr.mr_n64177680)
print v(xbgr.mr_n64177792)
print v(xbgr.mr_n64178112)
print v(xbgr.mr_n64178224)
print v(xbgr.mr_n64178544)
print v(xbgr.mr_n64178656)
print v(xbgr.mr_n64178976)
print v(xbgr.mr_n64179088)
print v(xbgr.mr_n64179408)
print v(xbgr.mr_n64179520)
print v(xbgr.mr_n64179840)
print v(xbgr.mr_n64179952)
print v(xbgr.mr_n64180272)
print v(xbgr.mr_n64180384)
print v(xbgr.mr_n64180704)
print v(xbgr.mr_n64180816)
print v(xbgr.mr_n64181136)
print v(xbgr.mr_n64181248)
print v(xbgr.mr_n64181568)
print v(xbgr.mr_n64181680)
print v(xbgr.mr_n64182000)
print v(xbgr.mr_n64182112)
print v(xbgr.mr_n64182432)
print v(xbgr.mr_n64182544)
print v(xbgr.mr_n64182864)
print v(xbgr.mr_n64182976)
print v(xbgr.mr_n64183296)
print v(xbgr.mr_n64183408)
print v(xbgr.mr_n64183728)
print v(xbgr.mr_n64183840)
print v(xbgr.mr_n64184160)
print v(xbgr.mr_n64184272)
print v(xbgr.mr_n64184592)
print v(xbgr.mr_n64184704)
print v(xbgr.mr_n64185024)
print v(xbgr.mr_n64185136)
print v(xbgr.mr_n64185456)
print v(xbgr.mr_n64185568)
print v(xbgr.mr_n64185888)
print v(xbgr.mr_n64186000)
print v(xbgr.mr_n64186320)
print v(xbgr.mr_n64186432)
print v(xbgr.mr_n64186752)
print v(xbgr.mr_n64186864)
print v(xbgr.mr_n64187184)
print v(xbgr.mr_n64187296)
print v(xbgr.mr_n64187616)
print v(xbgr.mr_n64187728)
print v(xbgr.mr_n64188048)
print v(xbgr.mr_n64188160)
print v(xbgr.mr_n64188480)
print v(xbgr.mr_n64188592)
print v(xbgr.mr_n64188912)
print v(xbgr.mr_n64189024)
print v(xbgr.mr_n64189344)
print v(xbgr.mr_n64189456)
print v(xbgr.mr_n64189776)
print v(xbgr.mr_n64189888)
print v(xbgr.mr_n64190208)
print v(xbgr.mr_n64190320)
print v(xbgr.mr_n64190640)
print v(xbgr.mr_n64190752)
print v(xbgr.mr_n64191072)
print v(xbgr.mr_n64191184)
print v(xbgr.mr_n64191504)
print v(xbgr.mr_n64191616)
print v(xbgr.mr_n64191936)
print v(xbgr.mr_n64192048)
print v(xbgr.mr_n64192368)
print v(xbgr.mr_n64192480)
print v(xbgr.mr_n64192800)
print v(xbgr.mr_n64192912)
print v(xbgr.mr_n64193232)
print v(xbgr.mr_n64193344)
print v(xbgr.mr_n64193664)
print v(xbgr.mr_n64193776)
print v(xbgr.mr_n64194096)
print v(xbgr.mr_n64194208)
print v(xbgr.mr_n64194528)
print v(xbgr.mr_n64194640)
print v(xbgr.mr_n64194960)
print v(xbgr.mr_n64195072)
print v(xbgr.mr_n64195392)
print v(xbgr.mr_n64195504)
print v(xbgr.mr_n64195824)
print v(xbgr.mr_n64195936)
print v(xbgr.mr_n64196256)
print v(xbgr.mr_n64196368)
print v(xbgr.mr_n64196688)
print v(xbgr.mr_n64196800)
print v(xbgr.mr_n64197120)
print v(xbgr.mr_n64197232)
print v(xbgr.mr_n64197552)
print v(xbgr.mr_n64197664)
print v(xbgr.mr_n64197984)
print v(xbgr.mr_n64198096)
print v(xbgr.mr_n64198416)
print v(xbgr.mr_n64198528)
print v(xbgr.mr_n64198848)
print v(xbgr.mr_n64198960)
print v(xbgr.mr_n64199280)
print v(xbgr.mr_n64199392)
print v(xbgr.mr_n64199712)
print v(xbgr.mr_n64199824)
print v(xbgr.mr_n64200144)
print v(xbgr.mr_n64200256)
print v(xbgr.mr_n64200576)
print v(xbgr.mr_n64200688)
print v(xbgr.mr_n64201008)
print v(xbgr.mr_n64201120)
print v(xbgr.mr_n64201440)
print v(xbgr.mr_n64201552)
print v(xbgr.mr_n64201872)
print v(xbgr.mr_n64201984)
print v(xbgr.mr_n64202304)
print v(xbgr.mr_n64202416)
print v(xbgr.mr_n64202736)
print v(xbgr.mr_n64202848)
print v(xbgr.mr_n64203168)
print v(xbgr.mr_n64203280)
print v(xbgr.mr_n64203600)
print v(xbgr.mr_n64203712)
print v(xbgr.mr_n64204032)
print v(xbgr.mr_n64204144)
print v(xbgr.mr_n64204464)
print v(xbgr.mr_n64204576)
print v(xbgr.mr_n64204896)
print v(xbgr.mr_n64205008)
print v(xbgr.mr_n64205328)
print v(xbgr.mr_n64205440)
print v(xbgr.mr_n64205760)
print v(xbgr.mr_n64205872)
print v(xbgr.mr_n64206192)
print v(xbgr.mr_n64206304)
print v(xbgr.mr_n64206624)
print v(xbgr.mr_n64206736)
print v(xbgr.mr_n64207056)
print v(xbgr.mr_n64207168)
print v(xbgr.mr_n64207488)
print v(xbgr.mr_n64207600)
print v(xbgr.mr_n64207920)
print v(xbgr.mr_n64208032)
print v(xbgr.mr_n64208352)
print v(xbgr.mr_n64208464)
print v(xbgr.mr_n64208784)
print v(xbgr.mr_n64208896)
print v(xbgr.mr_n64209216)
print v(xbgr.mr_n64209328)
print v(xbgr.mr_n64209648)
print v(xbgr.mr_n64209760)
print v(xbgr.mr_n64210080)
print v(xbgr.mr_n64210192)
print v(xbgr.mr_n64210512)
print v(xbgr.mr_n64210624)
print v(xbgr.mr_n64210944)
print v(xbgr.mr_n64211056)
print v(xbgr.mr_n64211376)
print v(xbgr.mr_n64211488)
print v(xbgr.mr_n64211808)
print v(xbgr.mr_n64211920)
print v(xbgr.mr_n64212240)
print v(xbgr.mr_n64212352)
print v(xbgr.mr_n64212672)
print v(xbgr.mr_n64212784)
print v(xbgr.mr_n64213104)
print v(xbgr.mr_n64213216)
print v(xbgr.mr_n64213536)
print v(xbgr.mr_n64213648)
print v(xbgr.mr_n64213968)
print v(xbgr.mr_n64214080)
print v(xbgr.mr_n64214400)
print v(xbgr.mr_n64214512)
print v(xbgr.mr_n64214832)
print v(xbgr.mr_n64214944)
print v(xbgr.mr_n64215264)
print v(xbgr.mr_n64215376)
print v(xbgr.mr_n64215696)
print v(xbgr.mr_n64215808)
print v(xbgr.mr_n64216128)
print v(xbgr.mr_n64216240)
print v(xbgr.mr_n64216560)
print v(xbgr.mr_n64216672)
print v(xbgr.mr_n64216992)
print v(xbgr.mr_n64217104)
print v(xbgr.mr_n64217424)
print v(xbgr.mr_n64217536)
print v(xbgr.mr_n64217856)
print v(xbgr.mr_n64217968)
print v(xbgr.mr_n64218288)
print v(xbgr.mr_n64218400)
print v(xbgr.mr_n64218720)
print v(xbgr.mr_n64218832)
print v(xbgr.mr_n64219152)
print v(xbgr.mr_n64219264)
print v(xbgr.mr_n64219584)
print v(xbgr.mr_n64219696)
print v(xbgr.mr_n64220016)
print v(xbgr.mr_n64220128)
print v(xbgr.mr_n64220448)
print v(xbgr.mr_n64220560)
print v(xbgr.mr_n64220880)
print v(xbgr.mr_n64220992)
print v(xbgr.mr_n64221312)
print v(xbgr.mr_n64221424)
print v(xbgr.mr_n64221744)
print v(xbgr.mr_n64221856)
print v(xbgr.mr_n64222176)
print v(xbgr.mr_n64222288)
print v(xbgr.mr_n64222608)
print v(xbgr.mr_n64222720)
print v(xbgr.mr_n64223040)
print v(xbgr.mr_n64223152)
print v(xbgr.mr_n64223472)
print v(xbgr.mr_n64223584)
print v(xbgr.mr_n64223904)
print v(xbgr.mr_n64224016)
print v(xbgr.mr_n64224336)
print v(xbgr.mr_n64224448)
print v(xbgr.mr_n64224768)
print v(xbgr.mr_n64224880)
print v(xbgr.mr_n64225200)
print v(xbgr.mr_n64225312)
print v(xbgr.mr_n64225632)
print v(xbgr.mr_n64225744)
print v(xbgr.mr_n64226064)
print v(xbgr.mr_n64226176)
print v(xbgr.mr_n64226496)
print v(xbgr.mr_n64226608)
print v(xbgr.mr_n64226928)
print v(xbgr.mr_n64227040)
print v(xbgr.mr_n64227360)
print v(xbgr.mr_n64227472)
print v(xbgr.mr_n64227792)
print v(xbgr.mr_n64227904)
print v(xbgr.mr_n64228224)
print v(xbgr.mr_n64228336)
print v(xbgr.mr_n64228656)
print v(xbgr.mr_n64228768)
print v(xbgr.mr_n64229088)
print v(xbgr.mr_n64229200)
print v(xbgr.mr_n64229520)
print v(xbgr.mr_n64229632)
print v(xbgr.mr_n64229952)
print v(xbgr.mr_n64230064)
print v(xbgr.mr_n64230384)
print v(xbgr.mr_n64230496)
print v(xbgr.mr_n64230816)
print v(xbgr.mr_n64230928)
print v(xbgr.mr_n64231248)
print v(xbgr.mr_n64231360)
print v(xbgr.mr_n64231680)
print v(xbgr.mr_n64231792)
print v(xbgr.mr_n64232112)
print v(xbgr.mr_n64232224)
print v(xbgr.mr_n64232544)
print v(xbgr.mr_n64232656)
print v(xbgr.mr_n64232976)
print v(xbgr.mr_n64233088)
print v(xbgr.mr_n64233408)
print v(xbgr.mr_n64233520)
print v(xbgr.mr_n64233840)
print v(xbgr.mr_n64233952)
print v(xbgr.mr_n64234272)
print v(xbgr.mr_n64234384)
print v(xbgr.mr_n64234704)
print v(xbgr.mr_n64234816)
print v(xbgr.mr_n64235136)
print v(xbgr.mr_n64235248)
print v(xbgr.mr_n64235568)
print v(xbgr.mr_n64235680)
print v(xbgr.mr_n64236000)
print v(xbgr.mr_n64236112)
print v(xbgr.mr_n64236432)
print v(xbgr.mr_n64236544)
print v(xbgr.mr_n64236864)
print v(xbgr.mr_n64236976)
print v(xbgr.mr_n64237296)
print v(xbgr.mr_n64237408)
print v(xbgr.mr_n64237728)
print v(xbgr.mr_n64237840)
print v(xbgr.mr_n64238160)
print v(xbgr.mr_n64238272)
print v(xbgr.mr_n64238592)
print v(xbgr.mr_n64238704)
print v(xbgr.mr_n64239024)
print v(xbgr.mr_n64239136)
print v(xbgr.mr_n64239456)
print v(xbgr.mr_n64239568)
print v(xbgr.mr_n64239888)
print v(xbgr.mr_n64240000)
print v(xbgr.mr_n64240320)
print v(xbgr.mr_n64240432)
print v(xbgr.mr_n64240752)
print v(xbgr.mr_n64240864)
print v(xbgr.mr_n64241184)
print v(xbgr.mr_n64241296)
print v(xbgr.mr_n64241616)
print v(xbgr.mr_n64241728)
print v(xbgr.mr_n64242048)
print v(xbgr.mr_n64242160)
print v(xbgr.mr_n64242480)
print v(xbgr.mr_n64242592)
print v(xbgr.mr_n64242912)
print v(xbgr.mr_n64243024)
print v(xbgr.mr_n64243344)
print v(xbgr.mr_n64243456)
print v(xbgr.mr_n64243776)
print v(xbgr.mr_n64243888)
print v(xbgr.mr_n64244208)
print v(xbgr.mr_n64244320)
print v(xbgr.mr_n64244640)
print v(xbgr.mr_n64244752)
print v(xbgr.mr_n64245072)
print v(xbgr.mr_n64245184)
print v(xbgr.mr_n64245504)
print v(xbgr.mr_n64245616)
print v(xbgr.mr_n64245936)
print v(xbgr.mr_n64246048)
print v(xbgr.mr_n64246368)
print v(xbgr.mr_n64246480)
print v(xbgr.mr_n64246800)
print v(xbgr.mr_n64246912)
print v(xbgr.mr_n64247232)
print v(xbgr.mr_n64247344)
print v(xbgr.mr_n64247664)
print v(xbgr.mr_n64247776)
print v(xbgr.mr_n64248096)
print v(xbgr.mr_n64248208)
print v(xbgr.mr_n64248528)
print v(xbgr.mr_n64248640)
print v(xbgr.mr_n64248960)
print v(xbgr.mr_n64249072)
print v(xbgr.mr_n64249392)
print v(xbgr.mr_n64249504)
print v(xbgr.mr_n64249824)
print v(xbgr.mr_n64249936)
print v(xbgr.mr_n64250256)
print v(xbgr.mr_n64250368)
print v(xbgr.mr_n64250688)
print v(xbgr.mr_n64250800)
print v(xbgr.mr_n64251120)
print v(xbgr.mr_n64251232)
print v(xbgr.mr_n64251552)
print v(xbgr.mr_n64251664)
print v(xbgr.mr_n64251984)
print v(xbgr.mr_n64252096)
print v(xbgr.mr_n64252416)
print v(xbgr.mr_n64252528)
print v(xbgr.mr_n64252848)
print v(xbgr.mr_n64252960)
print v(xbgr.mr_n64253280)
print v(xbgr.mr_n64253392)
print v(xbgr.mr_n64253712)
print v(xbgr.mr_n64253824)
print v(xbgr.mr_n64254144)
print v(xbgr.mr_n64254256)
print v(xbgr.mr_n64254576)
print v(xbgr.mr_n64254688)
print v(xbgr.mr_n64255008)
print v(xbgr.mr_n64255120)
print v(xbgr.mr_n64255440)
print v(xbgr.mr_n64255552)
print v(xbgr.mr_n64255872)
print v(xbgr.mr_n64255984)
print v(xbgr.mr_n64256304)
print v(xbgr.mr_n64256416)
print v(xbgr.mr_n64256736)
print v(xbgr.mr_n64256848)
print v(xbgr.mr_n64257168)
print v(xbgr.mr_n64257280)
print v(xbgr.mr_n64257600)
print v(xbgr.mr_n64257712)
print v(xbgr.mr_n64258032)
print v(xbgr.mr_n64258144)
print v(xbgr.mr_n64258464)
print v(xbgr.mr_n64258576)
print v(xbgr.mr_n64258896)
print v(xbgr.mr_n64259008)
print v(xbgr.mr_n64259328)
print v(xbgr.mr_n64259440)
print v(xbgr.mr_n64259760)
print v(xbgr.mr_n64259872)
print v(xbgr.mr_n64260192)
print v(xbgr.mr_n64260304)
print v(xbgr.mr_n64260624)
print v(xbgr.mr_n64260736)
print v(xbgr.mr_n64261056)
print v(xbgr.mr_n64261168)
print v(xbgr.mr_n64261488)
print v(xbgr.mr_n64261600)
print v(xbgr.mr_n64261888)
print v(xbgr.mr_n64262000)
print v(xbgr.mr_n64262320)
print v(xbgr.mr_n64262432)
print v(xbgr.mr_n64262752)
print v(xbgr.mr_n64262864)
print v(xbgr.mr_n64263184)
print v(xbgr.mr_n64263296)
print v(xbgr.mr_n64263616)
print v(xbgr.mr_n64263728)
print v(xbgr.mr_n64264048)
print v(xbgr.mr_n64264160)
print v(xbgr.mr_n64264480)
print v(xbgr.mr_n64264592)
print v(xbgr.mr_n64264912)
print v(xbgr.mr_n64265024)
print v(xbgr.mr_n64265344)
print v(xbgr.mr_n64265456)
print v(xbgr.mr_n64265776)
print v(xbgr.mr_n64265888)
print v(xbgr.mr_n64266208)
print v(xbgr.mr_n64266320)
print v(xbgr.mr_n64266640)
print v(xbgr.mr_n64266752)
print v(xbgr.mr_n64267072)
print v(xbgr.mr_n64267184)
print v(xbgr.mr_n64267504)
print v(xbgr.mr_n64267616)
print v(xbgr.mr_n64267936)
print v(xbgr.mr_n64268048)
print v(xbgr.mr_n64268368)
print v(xbgr.mr_n64268480)
print v(xbgr.mr_n64268800)
print v(xbgr.mr_n64268912)
print v(xbgr.mr_n64269232)
print v(xbgr.mr_n64269344)
print v(xbgr.mr_n64269664)
print v(xbgr.mr_n64269776)
print v(xbgr.mr_n64270096)
print v(xbgr.mr_n64270208)
print v(xbgr.mr_n64270528)
print v(xbgr.mr_n64270640)
print v(xbgr.mr_n64270960)
print v(xbgr.mr_n64271072)
print v(xbgr.mr_n64271392)
print v(xbgr.mr_n64271504)
print v(xbgr.mr_n64271824)
print v(xbgr.mr_n64271936)
print v(xbgr.mr_n64272256)
print v(xbgr.mr_n64272368)
print v(xbgr.mr_n64272688)
print v(xbgr.mr_n64272800)
print v(xbgr.mr_n64273120)
print v(xbgr.mr_n64273232)
print v(xbgr.mr_n64273552)
print v(xbgr.mr_n64273664)
print v(xbgr.mr_n64273984)
print v(xbgr.mr_n64274096)
print v(xbgr.mr_n64274416)
print v(xbgr.mr_n64274528)
print v(xbgr.mr_n64274848)
print v(xbgr.mr_n64274960)
print v(xbgr.mr_n64275280)
print v(xbgr.mr_n64275392)
print v(xbgr.mr_n64275712)
print v(xbgr.mr_n64275824)
print v(xbgr.mr_n64276144)
print v(xbgr.mr_n64276256)
print v(xbgr.mr_n64276576)
print v(xbgr.mr_n64276688)
print v(xbgr.mr_n64277008)
print v(xbgr.mr_n64277120)
print v(xbgr.mr_n64277440)
print v(xbgr.mr_n64277552)
print v(xbgr.mr_n64277872)
print v(xbgr.mr_n64277984)
print v(xbgr.mr_n64278304)
print v(xbgr.mr_n64278416)
print v(xbgr.mr_n64278736)
print v(xbgr.mr_n64278848)
print v(xbgr.mr_n64279168)
print v(xbgr.mr_n64279280)
print v(xbgr.mr_n64279600)
print v(xbgr.mr_n64279712)
print v(xbgr.mr_n64280032)
print v(xbgr.mr_n64280144)
print v(xbgr.mr_n64280464)
print v(xbgr.mr_n64280576)
print v(xbgr.mr_n64280896)
print v(xbgr.mr_n64281008)
print v(xbgr.mr_n64281328)
print v(xbgr.mr_n64281440)
print v(xbgr.mr_n64281760)
print v(xbgr.mr_n64281872)
print v(xbgr.mr_n64282192)
print v(xbgr.mr_n64282304)
print v(xbgr.mr_n64282624)
print v(xbgr.mr_n64282736)
print v(xbgr.mr_n64283056)
print v(xbgr.mr_n64283168)
print v(xbgr.mr_n64283488)
print v(xbgr.mr_n64283600)
print v(xbgr.mr_n64283920)
print v(xbgr.mr_n64284032)
print v(xbgr.mr_n64284352)
print v(xbgr.mr_n64284464)
print v(xbgr.mr_n64284784)
print v(xbgr.mr_n64284896)
print v(xbgr.mr_n64285216)
print v(xbgr.mr_n64285328)
print v(xbgr.mr_n64285648)
print v(xbgr.mr_n64285760)
print v(xbgr.mr_n64286080)
print v(xbgr.mr_n64286192)
print v(xbgr.mr_n64286512)
print v(xbgr.mr_n64286624)
print v(xbgr.mr_n64286944)
print v(xbgr.mr_n64287056)
print v(xbgr.mr_n64287376)
print v(xbgr.mr_n64287488)
print v(xbgr.mr_n64287808)
print v(xbgr.mr_n64287920)
print v(xbgr.mr_n64288240)
print v(xbgr.mr_n64288352)
print v(xbgr.mr_n64288672)
print v(xbgr.mr_n64288784)
print v(xbgr.mr_n64289104)
print v(xbgr.mr_n64289216)
print v(xbgr.mr_n64289536)
print v(xbgr.mr_n64289648)
print v(xbgr.mr_n64289968)
print v(xbgr.mr_n64290080)
print v(xbgr.mr_n64290400)
print v(xbgr.mr_n64290512)
print v(xbgr.mr_n64290832)
print v(xbgr.mr_n64290944)
print v(xbgr.mr_n64291264)
print v(xbgr.mr_n64291376)
print v(xbgr.mr_n64291696)
print v(xbgr.mr_n64291808)
print v(xbgr.mr_n64292128)
print v(xbgr.mr_n64292240)
print v(xbgr.mr_n64292560)
print v(xbgr.mr_n64292672)
print v(xbgr.mr_n64292992)
print v(xbgr.mr_n64293104)
print v(xbgr.mr_n64293424)
print v(xbgr.mr_n64293536)
print v(xbgr.mr_n64293856)
print v(xbgr.mr_n64293968)
print v(xbgr.mr_n64294288)
print v(xbgr.mr_n64294400)
print v(xbgr.mr_n64294720)
print v(xbgr.mr_n64294832)
print v(xbgr.mr_n64295152)
print v(xbgr.mr_n64295264)
print v(xbgr.mr_n64295584)
print v(xbgr.mr_n64295696)
print v(xbgr.mr_n64296016)
print v(xbgr.mr_n64296128)
print v(xbgr.mr_n64296448)
print v(xbgr.mr_n64296560)
print v(xbgr.mr_n64296880)
print v(xbgr.mr_n64296992)
print v(xbgr.mr_n64297312)
print v(xbgr.mr_n64297424)
print v(xbgr.mr_n64297744)
print v(xbgr.mr_n64297856)
print v(xbgr.mr_n64298176)
print v(xbgr.mr_n64298288)
print v(xbgr.mr_n64298608)
print v(xbgr.mr_n64298720)
print v(xbgr.mr_n64299040)
print v(xbgr.mr_n64299152)
print v(xbgr.mr_n64299472)
print v(xbgr.mr_n64299584)
print v(xbgr.mr_n64299904)
print v(xbgr.mr_n64300016)
print v(xbgr.mr_n64300336)
print v(xbgr.mr_n64300448)
print v(xbgr.mr_n64300768)
print v(xbgr.mr_n64300880)
print v(xbgr.mr_n64301200)
print v(xbgr.mr_n64301312)
print v(xbgr.mr_n64301632)
print v(xbgr.mr_n64301744)
print v(xbgr.mr_n64302064)
print v(xbgr.mr_n64302176)
print v(xbgr.mr_n64302496)
print v(xbgr.mr_n64302608)
print v(xbgr.mr_n64302928)
print v(xbgr.mr_n64303040)
print v(xbgr.mr_n64303360)
print v(xbgr.mr_n64303472)
print v(xbgr.mr_n64303792)
print v(xbgr.mr_n64303904)
print v(xbgr.mr_n64304224)
print v(xbgr.mr_n64304336)
print v(xbgr.mr_n64304656)
print v(xbgr.mr_n64304768)
print v(xbgr.mr_n64305088)
print v(xbgr.mr_n64305200)
print v(xbgr.mr_n64305520)
print v(xbgr.mr_n64305632)
print v(xbgr.mr_n64305952)
print v(xbgr.mr_n64306064)
print v(xbgr.mr_n64306384)
print v(xbgr.mr_n64306496)
print v(xbgr.mr_n64306816)
print v(xbgr.mr_n64306928)
print v(xbgr.mr_n64307248)
print v(xbgr.mr_n64307360)
print v(xbgr.mr_n64307680)
print v(xbgr.mr_n64307792)
print v(xbgr.mr_n64308112)
print v(xbgr.mr_n64308224)
print v(xbgr.mr_n64308544)
print v(xbgr.mr_n64308656)
print v(xbgr.mr_n64308976)
print v(xbgr.mr_n64309088)
print v(xbgr.mr_n64309408)
print v(xbgr.mr_n64309520)
print v(xbgr.mr_n64309840)
print v(xbgr.mr_n64309952)
print v(xbgr.mr_n64310272)
print v(xbgr.mr_n64310384)
print v(xbgr.mr_n64310704)
print v(xbgr.mr_n64310816)
print v(xbgr.mr_n64311136)
print v(xbgr.mr_n64311248)
print v(xbgr.mr_n64311568)
print v(xbgr.mr_n64311680)
print v(xbgr.mr_n64312000)
print v(xbgr.mr_n64312112)
print v(xbgr.mr_n64312432)
print v(xbgr.mr_n64312544)
print v(xbgr.mr_n64312864)
print v(xbgr.mr_n64312976)
print v(xbgr.mr_n64313296)
print v(xbgr.mr_n64313408)
print v(xbgr.mr_n64313728)
print v(xbgr.mr_n64313840)
print v(xbgr.mr_n64314160)
print v(xbgr.mr_n64314272)
print v(xbgr.mr_n64314592)
print v(xbgr.mr_n64314704)
print v(xbgr.mr_n64315024)
print v(xbgr.mr_n64315136)
print v(xbgr.mr_n64315456)
print v(xbgr.mr_n64315568)
print v(xbgr.mr_n64315888)
print v(xbgr.mr_n64316000)
print v(xbgr.mr_n64316320)
print v(xbgr.mr_n64316432)
print v(xbgr.mr_n64316752)
print v(xbgr.mr_n64316864)
print v(xbgr.mr_n64317184)
print v(xbgr.mr_n64317296)
print v(xbgr.mr_n64317616)
print v(xbgr.mr_n64317728)
print v(xbgr.mr_n64318048)
print v(xbgr.mr_n64318160)
print v(xbgr.mr_n64318480)
print v(xbgr.mr_n64318592)
print v(xbgr.mr_n64318912)
print v(xbgr.mr_n64319024)
print v(xbgr.mr_n64319344)
print v(xbgr.mr_n64319456)
print v(xbgr.mr_n64319776)
print v(xbgr.mr_n64319888)
print v(xbgr.mr_n64320208)
print v(xbgr.mr_n64320320)
print v(xbgr.mr_n64320640)
print v(xbgr.mr_n64320752)
print v(xbgr.mr_n64321072)
print v(xbgr.mr_n64321184)
print v(xbgr.mr_n64321504)
print v(xbgr.mr_n64321616)
print v(xbgr.mr_n64321936)
print v(xbgr.mr_n64322048)
print v(xbgr.mr_n64322368)
print v(xbgr.mr_n64322480)
print v(xbgr.mr_n64322800)
print v(xbgr.mr_n64322912)
print v(xbgr.mr_n64323232)
print v(xbgr.mr_n64323344)
print v(xbgr.mr_n64323664)
print v(xbgr.mr_n64323776)
print v(xbgr.mr_n64324096)
print v(xbgr.mr_n64324208)
print v(xbgr.mr_n64324528)
print v(xbgr.mr_n64324640)
print v(xbgr.mr_n64324960)
print v(xbgr.mr_n64325072)
print v(xbgr.mr_n64325392)
print v(xbgr.mr_n64325504)
print v(xbgr.mr_n64325824)
print v(xbgr.mr_n64325936)
print v(xbgr.mr_n64326256)
print v(xbgr.mr_n64326368)
print v(xbgr.mr_n64326688)
print v(xbgr.mr_n64326800)
print v(xbgr.mr_n64327120)
print v(xbgr.mr_n64327232)
print v(xbgr.mr_n64327552)
print v(xbgr.mr_n64327664)
print v(xbgr.mr_n64327984)
print v(xbgr.mr_n64328096)
print v(xbgr.mr_n64328416)
print v(xbgr.mr_n64328528)
print v(xbgr.mr_n64328848)
print v(xbgr.mr_n64328960)
print v(xbgr.mr_n64329280)
print v(xbgr.mr_n64329392)
print v(xbgr.mr_n64329712)
print v(xbgr.mr_n64329824)
print v(xbgr.mr_n64330144)
print v(xbgr.mr_n64330256)
print v(xbgr.mr_n64330576)
print v(xbgr.mr_n64330688)
print v(xbgr.mr_n64331008)
print v(xbgr.mr_n64331120)
print v(xbgr.mr_n64331440)
print v(xbgr.mr_n64331552)
print v(xbgr.mr_n64331872)
print v(xbgr.mr_n64331984)
print v(xbgr.mr_n64332304)
print v(xbgr.mr_n64332416)
print v(xbgr.mr_n64332736)
print v(xbgr.mr_n64332848)
print v(xbgr.mr_n64333168)
print v(xbgr.mr_n64333280)
print v(xbgr.mr_n64333600)
print v(xbgr.mr_n64333712)
print v(xbgr.mr_n64334032)
print v(xbgr.mr_n64334144)
print v(xbgr.mr_n64334464)
print v(xbgr.mr_n64334576)
print v(xbgr.mr_n64334896)
print v(xbgr.mr_n64335008)
print v(xbgr.mr_n64335328)
print v(xbgr.mr_n64335440)
print v(xbgr.mr_n64335760)
print v(xbgr.mr_n64335872)
print v(xbgr.mr_n64336192)
print v(xbgr.mr_n64336304)
print v(xbgr.mr_n64336624)
print v(xbgr.mr_n64336736)
print v(xbgr.mr_n64337056)
print v(xbgr.mr_n64337168)
print v(xbgr.mr_n64337488)
print v(xbgr.mr_n64337600)
print v(xbgr.mr_n64337920)
print v(xbgr.mr_n64338032)
print v(xbgr.mr_n64338352)
print v(xbgr.mr_n64338464)
print v(xbgr.mr_n64338784)
print v(xbgr.mr_n64338896)
print v(xbgr.mr_n64339216)
print v(xbgr.mr_n64339328)
print v(xbgr.mr_n64339648)
print v(xbgr.mr_n64339760)
print v(xbgr.mr_n64340080)
print v(xbgr.mr_n64340192)
print v(xbgr.mr_n64340512)
print v(xbgr.mr_n64340624)
print v(xbgr.mr_n64340944)
print v(xbgr.mr_n64341056)
print v(xbgr.mr_n64341376)
print v(xbgr.mr_n64341488)
print v(xbgr.mr_n64341808)
print v(xbgr.mr_n64341920)
print v(xbgr.mr_n64342240)
print v(xbgr.mr_n64342352)
print v(xbgr.mr_n64342672)
print v(xbgr.mr_n64342784)
print v(xbgr.mr_n64343104)
print v(xbgr.mr_n64343216)
print v(xbgr.mr_n64343536)
print v(xbgr.mr_n64343648)
print v(xbgr.mr_n64343968)
print v(xbgr.mr_n64344080)
print v(xbgr.mr_n64344400)
print v(xbgr.mr_n64344512)
print v(xbgr.mr_n64344832)
print v(xbgr.mr_n64344944)
print v(xbgr.mr_n64345264)
print v(xbgr.mr_n64345376)
print v(xbgr.mr_n64345696)
print v(xbgr.mr_n64345808)
print v(xbgr.mr_n64346128)
print v(xbgr.mr_n64346240)
print v(xbgr.mr_n64346560)
print v(xbgr.mr_n64346672)
print v(xbgr.mr_n64346992)
print v(xbgr.mr_n64347104)
print v(xbgr.mr_n64347424)
print v(xbgr.mr_n64347536)
print v(xbgr.mr_n64347856)
print v(xbgr.mr_n64347968)
print v(xbgr.mr_n64348288)
print v(xbgr.mr_n64348400)
print v(xbgr.mr_n64348720)
print v(xbgr.mr_n64348832)
print v(xbgr.mr_n64349152)
print v(xbgr.mr_n64349264)
print v(xbgr.mr_n64349584)
print v(xbgr.mr_n64349696)
print v(xbgr.mr_n64350016)
print v(xbgr.mr_n64350128)
print v(xbgr.mr_n64350448)
print v(xbgr.mr_n64350560)
print v(xbgr.mr_n64350880)
print v(xbgr.mr_n64350992)
print v(xbgr.mr_n64351312)
print v(xbgr.mr_n64351424)
print v(xbgr.mr_n64351744)
print v(xbgr.mr_n64351856)
print v(xbgr.mr_n64352176)
print v(xbgr.mr_n64352288)
print v(xbgr.mr_n64352608)
print v(xbgr.mr_n64352720)
print v(xbgr.mr_n64353040)
print v(xbgr.mr_n64353152)
print v(xbgr.mr_n64353472)
print v(xbgr.mr_n64353584)
print v(xbgr.mr_n64353904)
print v(xbgr.mr_n64354016)
print v(xbgr.mr_n64354336)
print v(xbgr.mr_n64354448)
print v(xbgr.mr_n64354768)
print v(xbgr.mr_n64354880)
print v(xbgr.mr_n64355200)
print v(xbgr.mr_n64355312)
print v(xbgr.mr_n64355632)
print v(xbgr.mr_n64355744)
print v(xbgr.mr_n64356064)
print v(xbgr.mr_n64356176)
print v(xbgr.mr_n64356496)
print v(xbgr.mr_n64356608)
print v(xbgr.mr_n64356928)
print v(xbgr.mr_n64357040)
print v(xbgr.mr_n64357360)
print v(xbgr.mr_n64357472)
print v(xbgr.mr_n64357792)
print v(xbgr.mr_n64357904)
print v(xbgr.mr_n64358224)
print v(xbgr.mr_n64358336)
print v(xbgr.mr_n64358656)
print v(xbgr.mr_n64358768)
print v(xbgr.mr_n64359088)
print v(xbgr.mr_n64359200)
print v(xbgr.mr_n64359520)
print v(xbgr.mr_n64359632)
print v(xbgr.mr_n64359952)
print v(xbgr.mr_n64360064)
print v(xbgr.mr_n64360384)
print v(xbgr.mr_n64360496)
print v(xbgr.mr_n64360816)
print v(xbgr.mr_n64360928)
print v(xbgr.mr_n64361248)
print v(xbgr.mr_n64361360)
print v(xbgr.mr_n64361680)
print v(xbgr.mr_n64361792)
print v(xbgr.mr_n64362112)
print v(xbgr.mr_n64362224)
print v(xbgr.mr_n64362544)
print v(xbgr.mr_n64362656)
print v(xbgr.mr_n64362976)
print v(xbgr.mr_n64363088)
print v(xbgr.mr_n64363408)
print v(xbgr.mr_n64363520)
print v(xbgr.mr_n64363840)
print v(xbgr.mr_n64363952)
print v(xbgr.mr_n64364272)
print v(xbgr.mr_n64364384)
print v(xbgr.mr_n64364704)
print v(xbgr.mr_n64364816)
print v(xbgr.mr_n64365136)
print v(xbgr.mr_n64365248)
print v(xbgr.mr_n64365568)
print v(xbgr.mr_n64365680)
print v(xbgr.mr_n64366000)
print v(xbgr.mr_n64366112)
print v(xbgr.mr_n64366432)
print v(xbgr.mr_n64366544)
print v(xbgr.mr_n64366864)
print v(xbgr.mr_n64366976)
print v(xbgr.mr_n64367296)
print v(xbgr.mr_n64367408)
print v(xbgr.mr_n64367728)
print v(xbgr.mr_n64367840)
print v(xbgr.mr_n64368160)
print v(xbgr.mr_n64368272)
print v(xbgr.mr_n64368592)
print v(xbgr.mr_n64368704)
print v(xbgr.mr_n64369024)
print v(xbgr.mr_n64369136)
print v(xbgr.mr_n64369456)
print v(xbgr.mr_n64369568)
print v(xbgr.mr_n64369888)
print v(xbgr.mr_n64370000)
print v(xbgr.mr_n64370320)
print v(xbgr.mr_n64370432)
print v(xbgr.mr_n64370752)
print v(xbgr.mr_n64370864)
print v(xbgr.mr_n64371184)
print v(xbgr.mr_n64371296)
print v(xbgr.mr_n64371616)
print v(xbgr.mr_n64371728)
print v(xbgr.mr_n64372048)
print v(xbgr.mr_n64372160)
print v(xbgr.mr_n64372480)
print v(xbgr.mr_n64372592)
print v(xbgr.mr_n64372912)
print v(xbgr.mr_n64373024)
print v(xbgr.mr_n64373344)
print v(xbgr.mr_n64373456)
print v(xbgr.mr_n64373776)
print v(xbgr.mr_n64373888)
print v(xbgr.mr_n64374208)
print v(xbgr.mr_n64374320)
print v(xbgr.mr_n64374640)
print v(xbgr.mr_n64374752)
print v(xbgr.mr_n64375072)
print v(xbgr.mr_n64375184)
print v(xbgr.mr_n64375504)
print v(xbgr.mr_n64375616)
print v(xbgr.mr_n64375936)
print v(xbgr.mr_n64376048)
print v(xbgr.mr_n64376368)
print v(xbgr.mr_n64376480)
print v(xbgr.mr_n64376800)
print v(xbgr.mr_n64376912)
print v(xbgr.mr_n64377232)
print v(xbgr.mr_n64377344)
print v(xbgr.mr_n64377664)
print v(xbgr.mr_n64377776)
print v(xbgr.mr_n64378096)
print v(xbgr.mr_n64378208)
print v(xbgr.mr_n64378528)
print v(xbgr.mr_n64378640)
print v(xbgr.mr_n64378960)
print v(xbgr.mr_n64379072)
print v(xbgr.mr_n64379392)
print v(xbgr.mr_n64379504)
print v(xbgr.mr_n64379824)
print v(xbgr.mr_n64379936)
print v(xbgr.mr_n64380256)
print v(xbgr.mr_n64380368)
print v(xbgr.mr_n64380688)
print v(xbgr.mr_n64380800)
print v(xbgr.mr_n64381120)
print v(xbgr.mr_n64381232)
print v(xbgr.mr_n64381552)
print v(xbgr.mr_n64381664)
print v(xbgr.mr_n64381984)
print v(xbgr.mr_n64382096)
print v(xbgr.mr_n64382416)
print v(xbgr.mr_n64382528)
print v(xbgr.mr_n64382848)
print v(xbgr.mr_n64382960)
print v(xbgr.mr_n64383280)
print v(xbgr.mr_n64383392)
print v(xbgr.mr_n64383712)
print v(xbgr.mr_n64383824)
print v(xbgr.mr_n64384144)
print v(xbgr.mr_n64384256)
print v(xbgr.mr_n64384576)
print v(xbgr.mr_n64384688)
print v(xbgr.mr_n64385008)
print v(xbgr.mr_n64385120)
print v(xbgr.mr_n64385440)
print v(xbgr.mr_n64385552)
print v(xbgr.mr_n64385872)
print v(xbgr.mr_n64385984)
print v(xbgr.mr_n64386304)
print v(xbgr.mr_n64386416)
print v(xbgr.mr_n64386736)
print v(xbgr.mr_n64386848)
print v(xbgr.mr_n64387168)
print v(xbgr.mr_n64387280)
print v(xbgr.mr_n64387600)
print v(xbgr.mr_n64387712)
print v(xbgr.mr_n64388032)
print v(xbgr.mr_n64388144)
print v(xbgr.mr_n64388464)
print v(xbgr.mr_n64388576)
print v(xbgr.mr_n64388896)
print v(xbgr.mr_n64389008)
print v(xbgr.mr_n64389328)
print v(xbgr.mr_n64389440)
print v(xbgr.mr_n64389760)
print v(xbgr.mr_n64389872)
print v(xbgr.mr_n64390192)
print v(xbgr.mr_n64390304)
print v(xbgr.mr_n64390624)
print v(xbgr.mr_n64390736)
print v(xbgr.mr_n64391056)
print v(xbgr.mr_n64391168)
print v(xbgr.mr_n64391488)
print v(xbgr.mr_n64391600)
print v(xbgr.mr_n64391920)
print v(xbgr.mr_n64392032)
print v(xbgr.mr_n64392352)
print v(xbgr.mr_n64392464)
print v(xbgr.mr_n64392784)
print v(xbgr.mr_n64392896)
print v(xbgr.mr_n64393216)
print v(xbgr.mr_n64393328)
print v(xbgr.mr_n64393648)
print v(xbgr.mr_n64393760)
print v(xbgr.mr_n64394080)
print v(xbgr.mr_n64394192)
print v(xbgr.mr_n64394512)
print v(xbgr.mr_n64394624)
print v(xbgr.mr_n64394944)
print v(xbgr.mr_n64395056)
print v(xbgr.mr_n64395376)
print v(xbgr.mr_n64395488)
print v(xbgr.mr_n64395808)
print v(xbgr.mr_n64395920)
print v(xbgr.mr_n64396240)
print v(xbgr.mr_n64396352)
print v(xbgr.mr_n64396672)
print v(xbgr.mr_n64396784)
print v(xbgr.mr_n64397104)
print v(xbgr.mr_n64397216)
print v(xbgr.mr_n64397536)
print v(xbgr.mr_n64397648)
print v(xbgr.mr_n64397968)
print v(xbgr.mr_n64398080)
print v(xbgr.mr_n64398400)
print v(xbgr.mr_n64398512)
print v(xbgr.mr_n64398832)
print v(xbgr.mr_n64398944)
print v(xbgr.mr_n64399264)
print v(xbgr.mr_n64399376)
print v(xbgr.mr_n64399696)
print v(xbgr.mr_n64399808)
print v(xbgr.mr_n64400128)
print v(xbgr.mr_n64400240)
print v(xbgr.mr_n64400560)
print v(xbgr.mr_n64400672)
print v(xbgr.mr_n64400992)
print v(xbgr.mr_n64401104)
print v(xbgr.mr_n64401424)
print v(xbgr.mr_n64401536)
print v(xbgr.mr_n64401856)
print v(xbgr.mr_n64401968)
print v(xbgr.mr_n64402288)
print v(xbgr.mr_n64402400)
print v(xbgr.mr_n64402720)
print v(xbgr.mr_n64402832)
print v(xbgr.mr_n64403152)
print v(xbgr.mr_n64403264)
print v(xbgr.mr_n64403584)
print v(xbgr.mr_n64403696)
print v(xbgr.mr_n64404016)
print v(xbgr.mr_n64404128)
print v(xbgr.mr_n64404448)
print v(xbgr.mr_n64404560)
print v(xbgr.mr_n64404880)
print v(xbgr.mr_n64404992)
print v(xbgr.mr_n64405312)
print v(xbgr.mr_n64405424)
print v(xbgr.mr_n64405744)
print v(xbgr.mr_n64405856)
print v(xbgr.mr_n64406176)
print v(xbgr.mr_n64406288)
print v(xbgr.mr_n64406608)
print v(xbgr.mr_n64406720)
print v(xbgr.mr_n64407040)
print v(xbgr.mr_n64407152)
print v(xbgr.mr_n64407472)
print v(xbgr.mr_n64407584)
print v(xbgr.mr_n64407904)
print v(xbgr.mr_n64408016)
print v(xbgr.mr_n64408336)
print v(xbgr.mr_n64408448)
print v(xbgr.mr_n64408768)
print v(xbgr.mr_n64408880)
print v(xbgr.mr_n64409200)
print v(xbgr.mr_n64409312)
print v(xbgr.mr_n64409632)
print v(xbgr.mr_n64409744)
print v(xbgr.mr_n64410064)
print v(xbgr.mr_n64410176)
print v(xbgr.mr_n64410496)
print v(xbgr.mr_n64410608)
print v(xbgr.mr_n64410928)
print v(xbgr.mr_n64411040)
print v(xbgr.mr_n64411360)
print v(xbgr.mr_n64411472)
print v(xbgr.mr_n64411792)
print v(xbgr.mr_n64411904)
print v(xbgr.mr_n64412224)
print v(xbgr.mr_n64412336)
print v(xbgr.mr_n64412656)
print v(xbgr.mr_n64412768)
print v(xbgr.mr_n64413088)
print v(xbgr.mr_n64413200)
print v(xbgr.mr_n64413520)
print v(xbgr.mr_n64413632)
print v(xbgr.mr_n64413952)
print v(xbgr.mr_n64414064)
print v(xbgr.mr_n64414384)
print v(xbgr.mr_n64414496)
print v(xbgr.mr_n64414816)
print v(xbgr.mr_n64414928)
print v(xbgr.mr_n64415248)
print v(xbgr.mr_n64415360)
print v(xbgr.mr_n64415680)
print v(xbgr.mr_n64415792)
print v(xbgr.mr_n64416112)
print v(xbgr.mr_n64416224)
print v(xbgr.mr_n64416544)
print v(xbgr.mr_n64416656)
print v(xbgr.mr_n64416976)
print v(xbgr.mr_n64417088)
print v(xbgr.mr_n64417408)
print v(xbgr.mr_n64417520)
print v(xbgr.mr_n64417840)
print v(xbgr.mr_n64417952)
print v(xbgr.mr_n64418272)
print v(xbgr.mr_n64418384)
print v(xbgr.mr_n64418704)
print v(xbgr.mr_n64418816)
print v(xbgr.mr_n64419136)
print v(xbgr.mr_n64419248)
print v(xbgr.mr_n64419568)
print v(xbgr.mr_n64419680)
print v(xbgr.mr_n64420000)
print v(xbgr.mr_n64420112)
print v(xbgr.mr_n64420432)
print v(xbgr.mr_n64420544)
print v(xbgr.mr_n64420864)
print v(xbgr.mr_n64420976)
print v(xbgr.mr_n64421296)
print v(xbgr.mr_n64421408)
print v(xbgr.mr_n64421728)
print v(xbgr.mr_n64421840)
print v(xbgr.mr_n64422160)
print v(xbgr.mr_n64422272)
print v(xbgr.mr_n64422592)
print v(xbgr.mr_n64422704)
print v(xbgr.mr_n64423024)
print v(xbgr.mr_n64423136)
print v(xbgr.mr_n64423456)
print v(xbgr.mr_n64423568)
print v(xbgr.mr_n64423888)
print v(xbgr.mr_n64424000)
print v(xbgr.mr_n64424320)
print v(xbgr.mr_n64424432)
print v(xbgr.mr_n64424752)
print v(xbgr.mr_n64424864)
print v(xbgr.mr_n64425184)
print v(xbgr.mr_n64425296)
print v(xbgr.mr_n64425616)
print v(xbgr.mr_n64425728)
print v(xbgr.mr_n64426048)
print v(xbgr.mr_n64426160)
print v(xbgr.mr_n64426480)
print v(xbgr.mr_n64426592)
print v(xbgr.mr_n64426912)
print v(xbgr.mr_n64427024)
print v(xbgr.mr_n64427344)
print v(xbgr.mr_n64427456)
print v(xbgr.mr_n64427776)
print v(xbgr.mr_n64427888)
print v(xbgr.mr_n64428208)
print v(xbgr.mr_n64428320)
print v(xbgr.mr_n64428640)
print v(xbgr.mr_n64428752)
print v(xbgr.mr_n64429072)
print v(xbgr.mr_n64429184)
print v(xbgr.mr_n64429504)
print v(xbgr.mr_n64429616)
print v(xbgr.mr_n64429936)
print v(xbgr.mr_n64430048)
print v(xbgr.mr_n64430368)
print v(xbgr.mr_n64430480)
print v(xbgr.mr_n64430800)
print v(xbgr.mr_n64430912)
print v(xbgr.mr_n64431232)
print v(xbgr.mr_n64431344)
print v(xbgr.mr_n64431664)
print v(xbgr.mr_n64431776)
print v(xbgr.mr_n64432096)
print v(xbgr.mr_n64432208)
print v(xbgr.mr_n64432528)
print v(xbgr.mr_n64432640)
print v(xbgr.mr_n64432960)
print v(xbgr.mr_n64433072)
print v(xbgr.mr_n64433392)
print v(xbgr.mr_n64433504)
print v(xbgr.mr_n64433824)
print v(xbgr.mr_n64433936)
print v(xbgr.mr_n64434256)
print v(xbgr.mr_n64434368)
print v(xbgr.mr_n64434688)
print v(xbgr.mr_n64434800)
print v(xbgr.mr_n64435120)
print v(xbgr.mr_n64435232)
print v(xbgr.mr_n64435552)
print v(xbgr.mr_n64435664)
print v(xbgr.mr_n64435984)
print v(xbgr.mr_n64436096)
print v(xbgr.mr_n64436416)
print v(xbgr.mr_n64436528)
print v(xbgr.mr_n64436848)
print v(xbgr.mr_n64436960)
print v(xbgr.mr_n64437280)
print v(xbgr.mr_n64437392)
print v(xbgr.mr_n64437712)
print v(xbgr.mr_n64437824)
print v(xbgr.mr_n64438144)
print v(xbgr.mr_n64438256)
print v(xbgr.mr_n64438576)
print v(xbgr.mr_n64438688)
print v(xbgr.mr_n64439008)
print v(xbgr.mr_n64439120)
print v(xbgr.mr_n64439440)
print v(xbgr.mr_n64439552)
print v(xbgr.mr_n64439872)
print v(xbgr.mr_n64439984)
print v(xbgr.mr_n64440304)
print v(xbgr.mr_n64440416)
print v(xbgr.mr_n64440736)
print v(xbgr.mr_n64440848)
print v(xbgr.mr_n64441168)
print v(xbgr.mr_n64441280)
print v(xbgr.mr_n64441600)
print v(xbgr.mr_n64441712)
print v(xbgr.mr_n64442032)
print v(xbgr.mr_n64442144)
print v(xbgr.mr_n64442464)
print v(xbgr.mr_n64442576)
print v(xbgr.mr_n64442896)
print v(xbgr.mr_n64443008)
print v(xbgr.mr_n64443328)
print v(xbgr.mr_n64443440)
print v(xbgr.mr_n64443760)
print v(xbgr.mr_n64443872)
print v(xbgr.mr_n64444192)
print v(xbgr.mr_n64444304)
print v(xbgr.mr_n64444624)
print v(xbgr.mr_n64444736)
print v(xbgr.mr_n64445056)
print v(xbgr.mr_n64445168)
print v(xbgr.mr_n64445488)
print v(xbgr.mr_n64445600)
print v(xbgr.mr_n64445920)
print v(xbgr.mr_n64446032)
print v(xbgr.mr_n64446352)
print v(xbgr.mr_n64446464)
print v(xbgr.mr_n64446784)
print v(xbgr.mr_n64446896)
print v(xbgr.mr_n64447216)
print v(xbgr.mr_n64447328)
print v(xbgr.mr_n64447648)
print v(xbgr.mr_n64447760)
print v(xbgr.mr_n64448080)
print v(xbgr.mr_n64448192)
print v(xbgr.mr_n64448512)
print v(xbgr.mr_n64448624)
print v(xbgr.mr_n64448944)
print v(xbgr.mr_n64449056)
print v(xbgr.mr_n64449376)
print v(xbgr.mr_n64449488)
print v(xbgr.mr_n64449808)
print v(xbgr.mr_n64449920)
print v(xbgr.mr_n64450240)
print v(xbgr.mr_n64450352)
print v(xbgr.mr_n64450672)
print v(xbgr.mr_n64450784)
print v(xbgr.mr_n64451104)
print v(xbgr.mr_n64451216)
print v(xbgr.mr_n64451536)
print v(xbgr.mr_n64451648)
print v(xbgr.mr_n64451968)
print v(xbgr.mr_n64452080)
print v(xbgr.mr_n64452400)
print v(xbgr.mr_n64452512)
print v(xbgr.mr_n64452832)
print v(xbgr.mr_n64452944)
print v(xbgr.mr_n64453264)
print v(xbgr.mr_n64453376)
print v(xbgr.mr_n64453696)
print v(xbgr.mr_n64453808)
print v(xbgr.mr_n64454128)
print v(xbgr.mr_n64454240)
print v(xbgr.mr_n64454560)
print v(xbgr.mr_n64454672)
print v(xbgr.mr_n64454992)
print v(xbgr.mr_n64455104)
print v(xbgr.mr_n64455424)
print v(xbgr.mr_n64455536)
print v(xbgr.mr_n64455856)
print v(xbgr.mr_n64455968)
print v(xbgr.mr_n64456288)
print v(xbgr.mr_n64456400)
print v(xbgr.mr_n64456720)
print v(xbgr.mr_n64456832)
print v(xbgr.mr_n64457152)
print v(xbgr.mr_n64457264)
print v(xbgr.mr_n64457584)
print v(xbgr.mr_n64457696)
print v(xbgr.mr_n64458016)
print v(xbgr.mr_n64458128)
print v(xbgr.mr_n64458448)
print v(xbgr.mr_n64458560)
print v(xbgr.mr_n64458880)
print v(xbgr.mr_n64458992)
print v(xbgr.mr_n64459312)
print v(xbgr.mr_n64459424)
print v(xbgr.mr_n64459744)
print v(xbgr.mr_n64459856)
print v(xbgr.mr_n64460176)
print v(xbgr.mr_n64460288)
print v(xbgr.mr_n64460608)
print v(xbgr.mr_n64460720)
print v(xbgr.mr_n64461040)
print v(xbgr.mr_n64461152)
print v(xbgr.mr_n64461472)
print v(xbgr.mr_n64461584)
print v(xbgr.mr_n64461904)
print v(xbgr.mr_n64462016)
print v(xbgr.mr_n64462336)
print v(xbgr.mr_n64462448)
print v(xbgr.mr_n64462768)
print v(xbgr.mr_n64462880)
print v(xbgr.mr_n64463200)
print v(xbgr.mr_n64463312)
print v(xbgr.mr_n64463632)
print v(xbgr.mr_n64463744)
print v(xbgr.mr_n64464064)
print v(xbgr.mr_n64464176)
print v(xbgr.mr_n64464496)
print v(xbgr.mr_n64464608)
print v(xbgr.mr_n64464928)
print v(xbgr.mr_n64465040)
print v(xbgr.mr_n64465360)
print v(xbgr.mr_n64465472)
print v(xbgr.mr_n64465792)
print v(xbgr.mr_n64465904)
print v(xbgr.mr_n64466224)
print v(xbgr.mr_n64466336)
print v(xbgr.mr_n64466656)
print v(xbgr.mr_n64466768)
print v(xbgr.mr_n64467200)
print v(xbgr.mr_n64467520)
print v(xbgr.mr_n64467632)
print v(xbgr.mr_n64468064)
print v(xbgr.mr_n64468384)
print v(xbgr.mr_n64468496)
print v(xbgr.mr_n64468928)
print v(xbgr.mr_n64469248)
print v(xbgr.mr_n64470112)
print v(xbgr.mr_n64470976)
print v(xbgr.mr_n64471840)
print v(xbgr.mr_n64472704)
print v(xbgr.mr_n64473568)
print v(xbgr.mr_n64474432)
print v(xbgr.mr_n64474544)
print v(xbgr.mr_n64474864)
print v(xbgr.mr_n64474976)
print v(xbgr.mr_n64475296)
print v(xbgr.mr_n64475408)
print v(xbgr.mr_n64475728)
print v(xbgr.mr_n64475840)
print v(xbgr.mr_n64476160)
print v(xbgr.mr_n64477024)
print v(xbgr.mr_n64477888)
print v(xbgr.mr_n64478752)
print v(xbgr.mr_n64478864)
print v(xbgr.mr_n64479184)
print v(xbgr.mr_n64479296)
print v(xbgr.mr_n64479616)
print v(xbgr.mr_n64479728)
print v(xbgr.mr_n64480160)
print v(xbgr.mr_n64480592)
print v(xbgr.mr_n64481024)
print v(xbgr.mr_n64481344)
print v(xbgr.mr_n64481456)
print v(xbgr.mr_n64481776)
print v(xbgr.mr_n64481888)
print v(xbgr.mr_n64482208)
print v(xbgr.mr_n64482320)
print v(xbgr.mr_n64482640)
print v(xbgr.mr_n64482752)
print v(xbgr.mr_n64483072)
print v(xbgr.mr_n64483184)
print v(xbgr.mr_n64483504)
print v(xbgr.mr_n64483616)
print v(xbgr.mr_n64483936)
print v(xbgr.mr_n64484048)
print v(xbgr.mr_n64484368)
print v(xbgr.mr_n64484480)
print v(xbgr.mr_n64484800)
print v(xbgr.mr_n64484912)
print v(xbgr.mr_n64485232)
print v(xbgr.mr_n64485344)
print v(xbgr.mr_n64485664)
print v(xbgr.mr_n64485776)
print v(xbgr.mr_n64486096)
print v(xbgr.mr_n64486208)
print v(xbgr.mr_n64486528)
print v(xbgr.mr_n64486640)
print v(xbgr.mr_n64486960)
print v(xbgr.mr_n64487072)
print v(xbgr.mr_n64487392)
print v(xbgr.mr_n64487504)
print v(xbgr.mr_n64487824)
print v(xbgr.mr_n64487936)
print v(xbgr.mr_n64488256)
print v(xbgr.mr_n64488368)
print v(xbgr.mr_n64488688)
print v(xbgr.mr_n64488800)
print v(xbgr.mr_n64489120)
print v(xbgr.mr_n64489232)
print v(xbgr.mr_n64489552)
print v(xbgr.mr_n64489664)
print v(xbgr.mr_n64489984)
print v(xbgr.mr_n64490096)
print v(xbgr.mr_n64490416)
print v(xbgr.mr_n64490528)
print v(xbgr.mr_n64490848)
print v(xbgr.mr_n64490960)
print v(xbgr.mr_n64491280)
print v(xbgr.mr_n64491392)
print v(xbgr.mr_n64491712)
print v(xbgr.mr_n64491824)
print v(xbgr.mr_n64492144)
print v(xbgr.mr_n64492256)
print v(xbgr.mr_n64492576)
print v(xbgr.mr_n64492688)
print v(xbgr.mr_n64493008)
print v(xbgr.mr_n64493120)
print v(xbgr.mr_n64493440)
print v(xbgr.mr_n64493552)
print v(xbgr.mr_n64493872)
print v(xbgr.mr_n64493984)
print v(xbgr.mr_n64494304)
print v(xbgr.mr_n64494416)
print v(xbgr.mr_n64494848)
print v(xbgr.mr_n64495168)
print v(xbgr.mr_n64495280)
print v(xbgr.mr_n64495712)
print v(xbgr.mr_n64496032)
print v(xbgr.mr_n64496896)
print v(xbgr.mr_n64497760)
print v(xbgr.mr_n64498624)
print v(xbgr.mr_n64499488)
print v(xbgr.mr_n64499600)
print v(xbgr.mr_n64499920)
print v(xbgr.mr_n64500032)
print v(xbgr.mr_n64500352)
print v(xbgr.mr_n64500464)
print v(xbgr.mr_n64500784)
print v(xbgr.mr_n64500896)
print v(xbgr.mr_n64501216)
print v(xbgr.mr_n64502080)
print v(xbgr.mr_n64502944)
print v(xbgr.mr_n64503056)
print v(xbgr.mr_n64503376)
print v(xbgr.mr_n64503488)
print v(xbgr.mr_n64503808)
print v(xbgr.mr_n64503920)
print v(xbgr.mr_n64504240)
print v(xbgr.mr_n64504352)
print v(xbgr.mr_n64504672)
print v(xbgr.mr_n64504784)
print v(xbgr.mr_n64505216)
print v(xbgr.mr_n64505536)
print v(xbgr.mr_n64505648)
print v(xbgr.mr_n64506080)
print v(xbgr.mr_n64506400)
print v(xbgr.mr_n64507264)
print v(xbgr.mr_n64508128)
print v(xbgr.mr_n64508992)
print v(xbgr.mr_n64509856)
print v(xbgr.mr_n64509968)
print v(xbgr.mr_n64510288)
print v(xbgr.mr_n64510400)
print v(xbgr.mr_n64510720)
print v(xbgr.mr_n64510832)
print v(xbgr.mr_n64511152)
print v(xbgr.mr_n64511264)
print v(xbgr.mr_n64511584)
print v(xbgr.mr_n64512448)
print v(xbgr.mr_n64513312)
print v(xbgr.mr_n64513424)
print v(xbgr.mr_n64513856)
print v(xbgr.mr_n64514176)
print v(xbgr.mr_n64514288)
print v(xbgr.mr_n64514608)
print v(xbgr.mr_n64514720)
print v(xbgr.mr_n64515040)
print v(xbgr.mr_n64515152)
print v(xbgr.mr_n64515472)
print v(xbgr.mr_n64515584)
print v(xbgr.mr_n64515904)
print v(xbgr.mr_n64516016)
print v(xbgr.mr_n64516448)
print v(xbgr.mr_n64516768)
print v(xbgr.mr_n64517632)
print v(xbgr.mr_n64517744)
print v(xbgr.mr_n64518176)
print v(xbgr.mr_n64518496)
print v(xbgr.mr_n64518608)
print v(xbgr.mr_n64519040)
print v(xbgr.mr_n64519360)
print v(xbgr.mr_n64519472)
print v(xbgr.mr_n64519792)
print v(xbgr.mr_n64519904)
print v(xbgr.mr_n64520224)
print v(xbgr.mr_n64520336)
print v(xbgr.mr_n64520656)
print v(xbgr.mr_n64520768)
print v(xbgr.mr_n64521088)
print v(xbgr.mr_n64521952)
print v(xbgr.mr_n64522816)
print v(xbgr.mr_n64522928)
print v(xbgr.mr_n64523248)
print v(xbgr.mr_n64523360)
print v(xbgr.mr_n64523680)
print v(xbgr.mr_n64523792)
print v(xbgr.mr_n64524112)
print v(xbgr.mr_n64524224)
print v(xbgr.mr_n64524544)
print v(xbgr.mr_n64525408)
print v(xbgr.mr_n64526272)
print v(xbgr.mr_n64526384)
print v(xbgr.mr_n64526704)
print v(xbgr.mr_n64526816)
print v(xbgr.mr_n64527136)
print v(xbgr.mr_n64528000)
print v(xbgr.mr_n64528112)
print v(xbgr.mr_n64528432)
print v(xbgr.mr_n64528544)
print v(xbgr.mr_n64528864)
print v(xbgr.mr_n64528976)
print v(xbgr.mr_n64529296)
print v(xbgr.mr_n64529408)
print v(xbgr.mr_n64529728)
print v(xbgr.mr_n64529840)
print v(xbgr.mr_n64530160)
print v(xbgr.mr_n64530272)
print v(xbgr.mr_n64530592)
print v(xbgr.mr_n64531456)
print v(xbgr.mr_n64532256)
print v(xbgr.mr_n64532368)
print v(xbgr.mr_n64532688)
print v(xbgr.mr_n64532800)
print v(xbgr.mr_n64533120)
print v(xbgr.mr_n64533232)
print v(xbgr.mr_n64533552)
print v(xbgr.mr_n64533664)
print v(xbgr.mr_n64533984)
print v(xbgr.mr_n64534096)
print v(xbgr.mr_n64534416)
print v(xbgr.mr_n64534528)
print v(xbgr.mr_n64534848)
print v(xbgr.mr_n64534960)
print v(xbgr.mr_n64535280)
print v(xbgr.mr_n64535392)
print v(xbgr.mr_n64535712)
print v(xbgr.mr_n64535824)
print v(xbgr.mr_n64536144)
print v(xbgr.mr_n64536256)
print v(xbgr.mr_n64536576)
print v(xbgr.mr_n64536688)
print v(xbgr.mr_n64537008)
print v(xbgr.mr_n64537120)
print v(xbgr.mr_n64537440)
print v(xbgr.mr_n64537552)
print v(xbgr.mr_n64537872)
print v(xbgr.mr_n64537984)
print v(xbgr.mr_n64538304)
print v(xbgr.mr_n64538416)
print v(xbgr.mr_n64538736)
print v(xbgr.mr_n64538848)
print v(xbgr.mr_n64539168)
print v(xbgr.mr_n64539280)
print v(xbgr.mr_n64539600)
print v(xbgr.mr_n64539712)
print v(xbgr.mr_n64540032)
print v(xbgr.mr_n64540144)
print v(xbgr.mr_n64540464)
print v(xbgr.mr_n64540576)
print v(xbgr.mr_n64540896)
print v(xbgr.mr_n64541008)
print v(xbgr.mr_n64541328)
print v(xbgr.mr_n64541440)
print v(xbgr.mr_n64541760)
print v(xbgr.mr_n64541872)
print v(xbgr.mr_n64542192)
print v(xbgr.mr_n64542304)
print v(xbgr.mr_n64542624)
print v(xbgr.mr_n64542736)
print v(xbgr.mr_n64543056)
print v(xbgr.mr_n64543168)
print v(xbgr.mr_n64543488)
print v(xbgr.mr_n64543600)
print v(xbgr.mr_n64543920)
print v(xbgr.mr_n64544032)
print v(xbgr.mr_n64544352)
print v(xbgr.mr_n64544464)
print v(xbgr.mr_n64544784)
print v(xbgr.mr_n64544896)
print v(xbgr.mr_n64545216)
print v(xbgr.mr_n64545328)
print v(xbgr.mr_n64545648)
print v(xbgr.mr_n64545760)
print v(xbgr.mr_n64546080)
print v(xbgr.mr_n64546192)
print v(xbgr.mr_n64546512)
print v(xbgr.mr_n64546624)
print v(xbgr.mr_n64546944)
print v(xbgr.mr_n64547056)
print v(xbgr.mr_n64547376)
print v(xbgr.mr_n64547488)
print v(xbgr.mr_n64547808)
print v(xbgr.mr_n64547920)
print v(xbgr.mr_n64548240)
print v(xbgr.mr_n64548352)
print v(xbgr.mr_n64548672)
print v(xbgr.mr_n64548784)
print v(xbgr.mr_n64549104)
print v(xbgr.mr_n64549216)
print v(xbgr.mr_n64549536)
print v(xbgr.mr_n64549648)
print v(xbgr.mr_n64549968)
print v(xbgr.mr_n64550080)
print v(xbgr.mr_n64550400)
print v(xbgr.mr_n64550512)
print v(xbgr.mr_n64550832)
print v(xbgr.mr_n64550944)
print v(xbgr.mr_n64551264)
print v(xbgr.mr_n64551376)
print v(xbgr.mr_n64551696)
print v(xbgr.mr_n64551808)
print v(xbgr.mr_n64552128)
print v(xbgr.mr_n64552240)
print v(xbgr.mr_n64552560)
print v(xbgr.mr_n64552672)
print v(xbgr.mr_n64552992)
print v(xbgr.mr_n64553104)
print v(xbgr.mr_n64553424)
print v(xbgr.mr_n64553536)
print v(xbgr.mr_n64553856)
print v(xbgr.mr_n64553968)
print v(xbgr.mr_n64554288)
print v(xbgr.mr_n64554400)
print v(xbgr.mr_n64554720)
print v(xbgr.mr_n64554832)
print v(xbgr.mr_n64555152)
print v(xbgr.mr_n64555264)
print v(xbgr.mr_n64555584)
print v(xbgr.mr_n64555696)
print v(xbgr.mr_n64556016)
print v(xbgr.mr_n64556128)
print v(xbgr.mr_n64556448)
print v(xbgr.mr_n64556560)
print v(xbgr.mr_n64556880)
print v(xbgr.mr_n64556992)
print v(xbgr.mr_n64557312)
print v(xbgr.mr_n64557424)
print v(xbgr.mr_n64557744)
print v(xbgr.mr_n64557856)
print v(xbgr.mr_n64558176)
print v(xbgr.mr_n64558288)
print v(xbgr.mr_n64558608)
print v(xbgr.mr_n64558720)
print v(xbgr.mr_n64559040)
print v(xbgr.mr_n64559152)
print v(xbgr.mr_n64559472)
print v(xbgr.mr_n64559584)
print v(xbgr.mr_n64559904)
print v(xbgr.mr_n64560016)
print v(xbgr.mr_n64560336)
print v(xbgr.mr_n64560448)
print v(xbgr.mr_n64560768)
print v(xbgr.mr_n64560880)
print v(xbgr.mr_n64561200)
print v(xbgr.mr_n64561312)
print v(xbgr.mr_n64561632)
print v(xbgr.mr_n64561744)
print v(xbgr.mr_n64562064)
print v(xbgr.mr_n64562176)
print v(xbgr.mr_n64562496)
print v(xbgr.mr_n64562608)
print v(xbgr.mr_n64562928)
print v(xbgr.mr_n64563040)
print v(xbgr.mr_n64563360)
print v(xbgr.mr_n64563472)
print v(xbgr.mr_n64563792)
print v(xbgr.mr_n64563904)
print v(xbgr.mr_n64564224)
print v(xbgr.mr_n64564336)
print v(xbgr.mr_n64564656)
print v(xbgr.mr_n64564768)
print v(xbgr.mr_n64565088)
print v(xbgr.mr_n64565200)
print v(xbgr.mr_n64565520)
print v(xbgr.mr_n64565632)
print v(xbgr.mr_n64565952)
print v(xbgr.mr_n64566064)
print v(xbgr.mr_n64566384)
print v(xbgr.mr_n64566496)
print v(xbgr.mr_n64566816)
print v(xbgr.mr_n64566928)
print v(xbgr.mr_n64567248)
print v(xbgr.mr_n64567360)
print v(xbgr.mr_n64567680)
print v(xbgr.mr_n64567792)
print v(xbgr.mr_n64568112)
print v(xbgr.mr_n64568224)
print v(xbgr.mr_n64568544)
print v(xbgr.mr_n64568656)
print v(xbgr.mr_n64568976)
print v(xbgr.mr_n64569088)
print v(xbgr.mr_n64569408)
print v(xbgr.mr_n64569520)
print v(xbgr.mr_n64569840)
print v(xbgr.mr_n64569952)
print v(xbgr.mr_n64570272)
print v(xbgr.mr_n64570384)
print v(xbgr.mr_n64570704)
print v(xbgr.mr_n64570816)
print v(xbgr.mr_n64571136)
print v(xbgr.mr_n64571248)
print v(xbgr.mr_n64571568)
print v(xbgr.mr_n64571680)
print v(xbgr.mr_n64572000)
print v(xbgr.mr_n64572112)
print v(xbgr.mr_n64572432)
print v(xbgr.mr_n64572544)
print v(xbgr.mr_n64572864)
print v(xbgr.mr_n64572976)
print v(xbgr.mr_n64573296)
print v(xbgr.mr_n64573408)
print v(xbgr.mr_n64573728)
print v(xbgr.mr_n64573840)
print v(xbgr.mr_n64574160)
print v(xbgr.mr_n64574272)
print v(xbgr.mr_n64574592)
print v(xbgr.mr_n64574704)
print v(xbgr.mr_n64575024)
print v(xbgr.mr_n64575136)
print v(xbgr.mr_n64575456)
print v(xbgr.mr_n64575568)
print v(xbgr.mr_n64575888)
print v(xbgr.mr_n64576000)
print v(xbgr.mr_n64576320)
print v(xbgr.mr_n64576432)
print v(xbgr.mr_n64576752)
print v(xbgr.mr_n64576864)
print v(xbgr.mr_n64577184)
print v(xbgr.mr_n64577296)
print v(xbgr.mr_n64577616)
print v(xbgr.mr_n64577728)
print v(xbgr.mr_n64578048)
print v(xbgr.mr_n64578160)
print v(xbgr.mr_n64578480)
print v(xbgr.mr_n64578592)
print v(xbgr.mr_n64578912)
print v(xbgr.mr_n64579024)
print v(xbgr.mr_n64579344)
print v(xbgr.mr_n64579456)
print v(xbgr.mr_n64579776)
print v(xbgr.mr_n64579888)
print v(xbgr.mr_n64580208)
print v(xbgr.mr_n64580320)
print v(xbgr.mr_n64580640)
print v(xbgr.mr_n64580752)
print v(xbgr.mr_n64581072)
print v(xbgr.mr_n64581184)
print v(xbgr.mr_n64581504)
print v(xbgr.mr_n64581616)
print v(xbgr.mr_n64581936)
print v(xbgr.mr_n64582048)
print v(xbgr.mr_n64582368)
print v(xbgr.mr_n64582480)
print v(xbgr.mr_n64582800)
print v(xbgr.mr_n64582912)
print v(xbgr.mr_n64583232)
print v(xbgr.mr_n64583344)
print v(xbgr.mr_n64583664)
print v(xbgr.mr_n64583776)
print v(xbgr.mr_n64584096)
print v(xbgr.mr_n64584208)
print v(xbgr.mr_n64584528)
print v(xbgr.mr_n64584640)
print v(xbgr.mr_n64584960)
print v(xbgr.mr_n64585072)
print v(xbgr.mr_n64585392)
print v(xbgr.mr_n64585504)
print v(xbgr.mr_n64585824)
print v(xbgr.mr_n64585936)
print v(xbgr.mr_n64586256)
print v(xbgr.mr_n64586368)
print v(xbgr.mr_n64586688)
print v(xbgr.mr_n64586800)
print v(xbgr.mr_n64587120)
print v(xbgr.mr_n64587232)
print v(xbgr.mr_n64587552)
print v(xbgr.mr_n64587664)
print v(xbgr.mr_n64587984)
print v(xbgr.mr_n64588096)
print v(xbgr.mr_n64588416)
print v(xbgr.mr_n64588528)
print v(xbgr.mr_n64588848)
print v(xbgr.mr_n64588960)
print v(xbgr.mr_n64589280)
print v(xbgr.mr_n64589392)
print v(xbgr.mr_n64589712)
print v(xbgr.mr_n64589824)
print v(xbgr.mr_n64590144)
print v(xbgr.mr_n64590256)
print v(xbgr.mr_n64590576)
print v(xbgr.mr_n64590688)
print v(xbgr.mr_n64591008)
print v(xbgr.mr_n64591120)
print v(xbgr.mr_n64591440)
print v(xbgr.mr_n64591552)
print v(xbgr.mr_n64591872)
print v(xbgr.mr_n64591984)
print v(xbgr.mr_n64592304)
print v(xbgr.mr_n64592416)
print v(xbgr.mr_n64592736)
print v(xbgr.mr_n64592848)
print v(xbgr.mr_n64593168)
print v(xbgr.mr_n64593280)
print v(xbgr.mr_n64593600)
print v(xbgr.mr_n64593712)
print v(xbgr.mr_n64594032)
print v(xbgr.mr_n64594144)
print v(xbgr.mr_n64594464)
print v(xbgr.mr_n64594576)
print v(xbgr.mr_n64594896)
print v(xbgr.mr_n64595008)
print v(xbgr.mr_n64595328)
print v(xbgr.mr_n64595440)
print v(xbgr.mr_n64595760)
print v(xbgr.mr_n64595872)
print v(xbgr.mr_n64596192)
print v(xbgr.mr_n64596304)
print v(xbgr.mr_n64596624)
print v(xbgr.mr_n64596736)
print v(xbgr.mr_n64597056)
print v(xbgr.mr_n64597168)
print v(xbgr.mr_n64597488)
print v(xbgr.mr_n64597600)
print v(xbgr.mr_n64597920)
print v(xbgr.mr_n64598032)
print v(xbgr.mr_n64598352)
print v(xbgr.mr_n64598464)
print v(xbgr.mr_n64598784)
print v(xbgr.mr_n64598896)
print v(xbgr.mr_n64599216)
print v(xbgr.mr_n64599328)
print v(xbgr.mr_n64599648)
print v(xbgr.mr_n64599760)
print v(xbgr.mr_n64600080)
print v(xbgr.mr_n64600192)
print v(xbgr.mr_n64600512)
print v(xbgr.mr_n64600624)
print v(xbgr.mr_n64600944)
print v(xbgr.mr_n64601056)
print v(xbgr.mr_n64601376)
print v(xbgr.mr_n64601488)
print v(xbgr.mr_n64601808)
print v(xbgr.mr_n64601920)
print v(xbgr.mr_n64602240)
print v(xbgr.mr_n64602352)
print v(xbgr.mr_n64602672)
print v(xbgr.mr_n64602784)
print v(xbgr.mr_n64603104)
print v(xbgr.mr_n64603216)
print v(xbgr.mr_n64603536)
print v(xbgr.mr_n64603648)
print v(xbgr.mr_n64603968)
print v(xbgr.mr_n64604080)
print v(xbgr.mr_n64604400)
print v(xbgr.mr_n64604512)
print v(xbgr.mr_n64604832)
print v(xbgr.mr_n64604944)
print v(xbgr.mr_n64605264)
print v(xbgr.mr_n64605376)
print v(xbgr.mr_n64605696)
print v(xbgr.mr_n64605808)
print v(xbgr.mr_n64606128)
print v(xbgr.mr_n64606240)
print v(xbgr.mr_n64606560)
print v(xbgr.mr_n64606672)
print v(xbgr.mr_n64606992)
print v(xbgr.mr_n64607104)
print v(xbgr.mr_n64607424)
print v(xbgr.mr_n64607536)
print v(xbgr.mr_n64607856)
print v(xbgr.mr_n64607968)
print v(xbgr.mr_n64608288)
print v(xbgr.mr_n64608400)
print v(xbgr.mr_n64608720)
print v(xbgr.mr_n64608832)
print v(xbgr.mr_n64609152)
print v(xbgr.mr_n64609264)
print v(xbgr.mr_n64609584)
print v(xbgr.mr_n64609696)
print v(xbgr.mr_n64610016)
print v(xbgr.mr_n64610128)
print v(xbgr.mr_n64610448)
print v(xbgr.mr_n64610560)
print v(xbgr.mr_n64610880)
print v(xbgr.mr_n64610992)
print v(xbgr.mr_n64611312)
print v(xbgr.mr_n64611424)
print v(xbgr.mr_n64611744)
print v(xbgr.mr_n64611856)
print v(xbgr.mr_n64612176)
print v(xbgr.mr_n64612288)
print v(xbgr.mr_n64612608)
print v(xbgr.mr_n64612720)
print v(xbgr.mr_n64613040)
print v(xbgr.mr_n64613152)
print v(xbgr.mr_n64613472)
print v(xbgr.mr_n64613584)
print v(xbgr.mr_n64613904)
print v(xbgr.mr_n64614016)
print v(xbgr.mr_n64614336)
print v(xbgr.mr_n64614448)
print v(xbgr.mr_n64614768)
print v(xbgr.mr_n64614880)
print v(xbgr.mr_n64615200)
print v(xbgr.mr_n64615312)
print v(xbgr.mr_n64615632)
print v(xbgr.mr_n64615744)
print v(xbgr.mr_n64616064)
print v(xbgr.mr_n64616176)
print v(xbgr.mr_n64616496)
print v(xbgr.mr_n64616608)
print v(xbgr.mr_n64616928)
print v(xbgr.mr_n64617040)
print v(xbgr.mr_n64617360)
print v(xbgr.mr_n64617472)
print v(xbgr.mr_n64617792)
print v(xbgr.mr_n64617904)
print v(xbgr.mr_n64618224)
print v(xbgr.mr_n64618336)
print v(xbgr.mr_n64618656)
print v(xbgr.mr_n64618768)
print v(xbgr.mr_n64619088)
print v(xbgr.mr_n64619200)
print v(xbgr.mr_n64619520)
print v(xbgr.mr_n64619632)
print v(xbgr.mr_n64619952)
print v(xbgr.mr_n64620064)
print v(xbgr.mr_n64620384)
print v(xbgr.mr_n64620496)
print v(xbgr.mr_n64620816)
print v(xbgr.mr_n64620928)
print v(xbgr.mr_n64621248)
print v(xbgr.mr_n64621360)
print v(xbgr.mr_n64621680)
print v(xbgr.mr_n64621792)
print v(xbgr.mr_n64622112)
print v(xbgr.mr_n64622224)
print v(xbgr.mr_n64622544)
print v(xbgr.mr_n64622656)
print v(xbgr.mr_n64622976)
print v(xbgr.mr_n64623088)
print v(xbgr.mr_n64623408)
print v(xbgr.mr_n64623520)
print v(xbgr.mr_n64623840)
print v(xbgr.mr_n64623952)
print v(xbgr.mr_n64624272)
print v(xbgr.mr_n64624384)
print v(xbgr.mr_n64624704)
print v(xbgr.mr_n64624816)
print v(xbgr.mr_n64625136)
print v(xbgr.mr_n64625248)
print v(xbgr.mr_n64625568)
print v(xbgr.mr_n64625680)
print v(xbgr.mr_n64626000)
print v(xbgr.mr_n64626112)
print v(xbgr.mr_n64626432)
print v(xbgr.mr_n64626544)
print v(xbgr.mr_n64626864)
print v(xbgr.mr_n64626976)
print v(xbgr.mr_n64627296)
print v(xbgr.mr_n64627408)
print v(xbgr.mr_n64627728)
print v(xbgr.mr_n64627840)
print v(xbgr.mr_n64628160)
print v(xbgr.mr_n64628272)
print v(xbgr.mr_n64628592)
print v(xbgr.mr_n64628704)
print v(xbgr.mr_n64629024)
print v(xbgr.mr_n64629136)
print v(xbgr.mr_n64629456)
print v(xbgr.mr_n64629568)
print v(xbgr.mr_n64629888)
print v(xbgr.mr_n64630000)
print v(xbgr.mr_n64630320)
print v(xbgr.mr_n64630432)
print v(xbgr.mr_n64630752)
print v(xbgr.mr_n64630864)
print v(xbgr.mr_n64631184)
print v(xbgr.mr_n64631296)
print v(xbgr.mr_n64631616)
print v(xbgr.mr_n64631728)
print v(xbgr.mr_n64632048)
print v(xbgr.mr_n64632160)
print v(xbgr.mr_n64632480)
print v(xbgr.mr_n64632592)
print v(xbgr.mr_n64632912)
print v(xbgr.mr_n64633024)
print v(xbgr.mr_n64633344)
print v(xbgr.mr_n64633456)
print v(xbgr.mr_n64633776)
print v(xbgr.mr_n64633888)
print v(xbgr.mr_n64634208)
print v(xbgr.mr_n64634320)
print v(xbgr.mr_n64634640)
print v(xbgr.mr_n64634752)
print v(xbgr.mr_n64635072)
print v(xbgr.mr_n64635184)
print v(xbgr.mr_n64635504)
print v(xbgr.mr_n64635616)
print v(xbgr.mr_n64635936)
print v(xbgr.mr_n64636048)
print v(xbgr.mr_n64636368)
print v(xbgr.mr_n64636480)
print v(xbgr.mr_n64636800)
print v(xbgr.mr_n64636912)
print v(xbgr.mr_n64637232)
print v(xbgr.mr_n64637344)
print v(xbgr.mr_n64637664)
print v(xbgr.mr_n64637776)
print v(xbgr.mr_n64638096)
print v(xbgr.mr_n64638208)
print v(xbgr.mr_n64638528)
print v(xbgr.mr_n64638640)
print v(xbgr.mr_n64638960)
print v(xbgr.mr_n64639072)
print v(xbgr.mr_n64639392)
print v(xbgr.mr_n64639504)
print v(xbgr.mr_n64639824)
print v(xbgr.mr_n64639936)
print v(xbgr.mr_n64640256)
print v(xbgr.mr_n64640368)
print v(xbgr.mr_n64640688)
print v(xbgr.mr_n64640800)
print v(xbgr.mr_n64641120)
print v(xbgr.mr_n64641232)
print v(xbgr.mr_n64641552)
print v(xbgr.mr_n64641664)
print v(xbgr.mr_n64641984)
print v(xbgr.mr_n64642096)
print v(xbgr.mr_n64642416)
print v(xbgr.mr_n64642528)
print v(xbgr.mr_n64642848)
print v(xbgr.mr_n64642960)
print v(xbgr.mr_n64643280)
print v(xbgr.mr_n64643392)
print v(xbgr.mr_n64643712)
print v(xbgr.mr_n64643824)
print v(xbgr.mr_n64644144)
print v(xbgr.mr_n64644256)
print v(xbgr.mr_n64644576)
print v(xbgr.mr_n64644688)
print v(xbgr.mr_n64645008)
print v(xbgr.mr_n64645120)
print v(xbgr.mr_n64645440)
print v(xbgr.mr_n64645552)
print v(xbgr.mr_n64645872)
print v(xbgr.mr_n64645984)
print v(xbgr.mr_n64646304)
print v(xbgr.mr_n64646416)
print v(xbgr.mr_n64646736)
print v(xbgr.mr_n64646848)
print v(xbgr.mr_n64647168)
print v(xbgr.mr_n64647280)
print v(xbgr.mr_n64647600)
print v(xbgr.mr_n64647712)
print v(xbgr.mr_n64648032)
print v(xbgr.mr_n64648144)
print v(xbgr.mr_n64648464)
print v(xbgr.mr_n64648576)
print v(xbgr.mr_n64648896)
print v(xbgr.mr_n64649008)
print v(xbgr.mr_n64649328)
print v(xbgr.mr_n64649440)
print v(xbgr.mr_n64649760)
print v(xbgr.mr_n64649872)
print v(xbgr.mr_n64650192)
print v(xbgr.mr_n64650304)
print v(xbgr.mr_n64650624)
print v(xbgr.mr_n64650736)
print v(xbgr.mr_n64651056)
print v(xbgr.mr_n64651168)
print v(xbgr.mr_n64651488)
print v(xbgr.mr_n64651600)
print v(xbgr.mr_n64651920)
print v(xbgr.mr_n64652032)
print v(xbgr.mr_n64652352)
print v(xbgr.mr_n64652464)
print v(xbgr.mr_n64652784)
print v(xbgr.mr_n64652896)
print v(xbgr.mr_n64653216)
print v(xbgr.mr_n64653328)
print v(xbgr.mr_n64653648)
print v(xbgr.mr_n64653760)
print v(xbgr.mr_n64654080)
print v(xbgr.mr_n64654192)
print v(xbgr.mr_n64654512)
print v(xbgr.mr_n64654624)
print v(xbgr.mr_n64654944)
print v(xbgr.mr_n64655056)
print v(xbgr.mr_n64655376)
print v(xbgr.mr_n64655488)
print v(xbgr.mr_n64655808)
print v(xbgr.mr_n64655920)
print v(xbgr.mr_n64656240)
print v(xbgr.mr_n64656352)
print v(xbgr.mr_n64656672)
print v(xbgr.mr_n64656784)
print v(xbgr.mr_n64657104)
print v(xbgr.mr_n64657216)
print v(xbgr.mr_n64657536)
print v(xbgr.mr_n64657648)
print v(xbgr.mr_n64657968)
print v(xbgr.mr_n64658080)
print v(xbgr.mr_n64658400)
print v(xbgr.mr_n64658512)
print v(xbgr.mr_n64658832)
print v(xbgr.mr_n64658944)
print v(xbgr.mr_n64659264)
print v(xbgr.mr_n64659376)
print v(xbgr.mr_n64659696)
print v(xbgr.mr_n64659808)
print v(xbgr.mr_n64660128)
print v(xbgr.mr_n64660240)
print v(xbgr.mr_n64660560)
print v(xbgr.mr_n64660672)
print v(xbgr.mr_n64660992)
print v(xbgr.mr_n64661104)
print v(xbgr.mr_n64661424)
print v(xbgr.mr_n64661536)
print v(xbgr.mr_n64661856)
print v(xbgr.mr_n64661968)
print v(xbgr.mr_n64662288)
print v(xbgr.mr_n64662400)
print v(xbgr.mr_n64662720)
print v(xbgr.mr_n64662832)
print v(xbgr.mr_n64663152)
print v(xbgr.mr_n64663264)
print v(xbgr.mr_n64663584)
print v(xbgr.mr_n64663696)
print v(xbgr.mr_n64664016)
print v(xbgr.mr_n64664128)
print v(xbgr.mr_n64664448)
print v(xbgr.mr_n64664560)
print v(xbgr.mr_n64664880)
print v(xbgr.mr_n64664992)
print v(xbgr.mr_n64665312)
print v(xbgr.mr_n64665424)
print v(xbgr.mr_n64665744)
print v(xbgr.mr_n64665856)
print v(xbgr.mr_n64666176)
print v(xbgr.mr_n64666288)
print v(xbgr.mr_n64666608)
print v(xbgr.mr_n64666720)
print v(xbgr.mr_n64667040)
print v(xbgr.mr_n64667152)
print v(xbgr.mr_n64667472)
print v(xbgr.mr_n64667584)
print v(xbgr.mr_n64667904)
print v(xbgr.mr_n64668016)
print v(xbgr.mr_n64668336)
print v(xbgr.mr_n64668448)
print v(xbgr.mr_n64668768)
print v(xbgr.mr_n64668880)
print v(xbgr.mr_n64669200)
print v(xbgr.mr_n64669312)
print v(xbgr.mr_n64669632)
print v(xbgr.mr_n64669744)
print v(xbgr.mr_n64670064)
print v(xbgr.mr_n64670176)
print v(xbgr.mr_n64670496)
print v(xbgr.mr_n64670608)
print v(xbgr.mr_n64670928)
print v(xbgr.mr_n64671040)
print v(xbgr.mr_n64671360)
print v(xbgr.mr_n64671472)
print v(xbgr.mr_n64671792)
print v(xbgr.mr_n64671904)
print v(xbgr.mr_n64672224)
print v(xbgr.mr_n64672336)
print v(xbgr.mr_n64672656)
print v(xbgr.mr_n64672768)
print v(xbgr.mr_n64673088)
print v(xbgr.mr_n64673200)
print v(xbgr.mr_n64673520)
print v(xbgr.mr_n64673632)
print v(xbgr.mr_n64673952)
print v(xbgr.mr_n64674064)
print v(xbgr.mr_n64674384)
print v(xbgr.mr_n64674496)
print v(xbgr.mr_n64674816)
print v(xbgr.mr_n64674928)
print v(xbgr.mr_n64675248)
print v(xbgr.mr_n64675360)
print v(xbgr.mr_n64675680)
print v(xbgr.mr_n64675792)
print v(xbgr.mr_n64676112)
print v(xbgr.mr_n64676224)
print v(xbgr.mr_n64676544)
print v(xbgr.mr_n64676656)
print v(xbgr.mr_n64676976)
print v(xbgr.mr_n64677088)
print v(xbgr.mr_n64677408)
print v(xbgr.mr_n64677520)
print v(xbgr.mr_n64677840)
print v(xbgr.mr_n64677952)
print v(xbgr.mr_n64678272)
print v(xbgr.mr_n64678384)
print v(xbgr.mr_n64678704)
print v(xbgr.mr_n64678816)
print v(xbgr.mr_n64679136)
print v(xbgr.mr_n64679248)
print v(xbgr.mr_n64679568)
print v(xbgr.mr_n64679680)
print v(xbgr.mr_n64680000)
print v(xbgr.mr_n64680112)
print v(xbgr.mr_n64680432)
print v(xbgr.mr_n64680544)
print v(xbgr.mr_n64680864)
print v(xbgr.mr_n64680976)
print v(xbgr.mr_n64681296)
print v(xbgr.mr_n64681408)
print v(xbgr.mr_n64681728)
print v(xbgr.mr_n64681840)
print v(xbgr.mr_n64682160)
print v(xbgr.mr_n64682272)
print v(xbgr.mr_n64682592)
print v(xbgr.mr_n64682704)
print v(xbgr.mr_n64683024)
print v(xbgr.mr_n64683136)
print v(xbgr.mr_n64683456)
print v(xbgr.mr_n64683568)
print v(xbgr.mr_n64683888)
print v(xbgr.mr_n64684000)
print v(xbgr.mr_n64684320)
print v(xbgr.mr_n64684432)
print v(xbgr.mr_n64684752)
print v(xbgr.mr_n64684864)
print v(xbgr.mr_n64685184)
print v(xbgr.mr_n64685296)
print v(xbgr.mr_n64685616)
print v(xbgr.mr_n64685728)
print v(xbgr.mr_n64686048)
print v(xbgr.mr_n64686160)
print v(xbgr.mr_n64686480)
print v(xbgr.mr_n64686592)
print v(xbgr.mr_n64686912)
print v(xbgr.mr_n64687024)
print v(xbgr.mr_n64687344)
print v(xbgr.mr_n64687456)
print v(xbgr.mr_n64687776)
print v(xbgr.mr_n64687888)
print v(xbgr.mr_n64688208)
print v(xbgr.mr_n64688320)
print v(xbgr.mr_n64688640)
print v(xbgr.mr_n64688752)
print v(xbgr.mr_n64689072)
print v(xbgr.mr_n64689184)
print v(xbgr.mr_n64689504)
print v(xbgr.mr_n64689616)
print v(xbgr.mr_n64689936)
print v(xbgr.mr_n64690048)
print v(xbgr.mr_n64690368)
print v(xbgr.mr_n64690480)
print v(xbgr.mr_n64690800)
print v(xbgr.mr_n64690912)
print v(xbgr.mr_n64691232)
print v(xbgr.mr_n64691344)
print v(xbgr.mr_n64691664)
print v(xbgr.mr_n64691776)
print v(xbgr.mr_n64692096)
print v(xbgr.mr_n64692208)
print v(xbgr.mr_n64692528)
print v(xbgr.mr_n64692640)
print v(xbgr.mr_n64692960)
print v(xbgr.mr_n64693072)
print v(xbgr.mr_n64693392)
print v(xbgr.mr_n64693824)
print v(xbgr.mr_n64693936)
print v(xbgr.mr_n64694256)
print v(xbgr.mr_n64694688)
print v(xbgr.mr_n64694800)
print v(xbgr.mr_n64695120)
print v(xbgr.mr_n64695232)
print v(xbgr.mr_n64695552)
print v(xbgr.mr_n64695664)
print v(xbgr.mr_n64695984)
print v(xbgr.mr_n64696096)
print v(xbgr.mr_n64696416)
print v(xbgr.mr_n64696528)
print v(xbgr.mr_n64696848)
print v(xbgr.mr_n64696960)
print v(xbgr.mr_n64697280)
print v(xbgr.mr_n64697392)
print v(xbgr.mr_n64697712)
print v(xbgr.mr_n64697824)
print v(xbgr.mr_n64698144)
print v(xbgr.mr_n64698256)
print v(xbgr.mr_n64698576)
print v(xbgr.mr_n64698688)
print v(xbgr.mr_n64699008)
print v(xbgr.mr_n64699120)
print v(xbgr.mr_n64699440)
print v(xbgr.mr_n64699552)
print v(xbgr.mr_n64699872)
print v(xbgr.mr_n64699984)
print v(xbgr.mr_n64700304)
print v(xbgr.mr_n64700416)
print v(xbgr.mr_n64700736)
print v(xbgr.mr_n64700848)
print v(xbgr.mr_n64701168)
print v(xbgr.mr_n64701280)
print v(xbgr.mr_n64701600)
print v(xbgr.mr_n64701712)
print v(xbgr.mr_n64702032)
print v(xbgr.mr_n64702144)
print v(xbgr.mr_n64702464)
print v(xbgr.mr_n64702576)
print v(xbgr.mr_n64702896)
print v(xbgr.mr_n64703008)
print v(xbgr.mr_n64703328)
print v(xbgr.mr_n64703440)
print v(xbgr.mr_n64703760)
print v(xbgr.mr_n64703872)
print v(xbgr.mr_n64704192)
print v(xbgr.mr_n64704624)
print v(xbgr.mr_n64704736)
print v(xbgr.mr_n64705056)
print v(xbgr.mr_n64705488)
print v(xbgr.mr_n64705600)
print v(xbgr.mr_n64705920)
print v(xbgr.mr_n64706352)
print v(xbgr.mr_n64706464)
print v(xbgr.mr_n64706784)
print v(xbgr.mr_n64707216)
print v(xbgr.mr_n64707328)
print v(xbgr.mr_n64707648)
print v(xbgr.mr_n64708080)
print v(xbgr.mr_n64708192)
print v(xbgr.mr_n64708512)
print v(xbgr.mr_n64708624)
print v(xbgr.mr_n64708944)
print v(xbgr.mr_n64709056)
print v(xbgr.mr_n64709376)
print v(xbgr.mr_n64709488)
print v(xbgr.mr_n64709808)
print v(xbgr.mr_n64709920)
print v(xbgr.mr_n64710240)
print v(xbgr.mr_n64710352)
print v(xbgr.mr_n64710672)
print v(xbgr.mr_n64710784)
print v(xbgr.mr_n64711104)
print v(xbgr.mr_n64711216)
print v(xbgr.mr_n64711536)
print v(xbgr.mr_n64711648)
print v(xbgr.mr_n64711968)
print v(xbgr.mr_n64712080)
print v(xbgr.mr_n64712400)
print v(xbgr.mr_n64712512)
print v(xbgr.mr_n64712832)
print v(xbgr.mr_n64712944)
print v(xbgr.mr_n64713264)
print v(xbgr.mr_n64713376)
print v(xbgr.mr_n64713696)
print v(xbgr.mr_n64713808)
print v(xbgr.mr_n64714128)
print v(xbgr.mr_n64714240)
print v(xbgr.mr_n64714560)
print v(xbgr.mr_n64714672)
print v(xbgr.mr_n64714992)
print v(xbgr.mr_n64715104)
print v(xbgr.mr_n64715424)
print v(xbgr.mr_n64715536)
print v(xbgr.mr_n64715856)
print v(xbgr.mr_n64715968)
print v(xbgr.mr_n64716288)
print v(xbgr.mr_n64716400)
print v(xbgr.mr_n64716720)
print v(xbgr.mr_n64716832)
print v(xbgr.mr_n64717152)
print v(xbgr.mr_n64717264)
print v(xbgr.mr_n64717584)
print v(xbgr.mr_n64717696)
print v(xbgr.mr_n64718016)
print v(xbgr.mr_n64718128)
print v(xbgr.mr_n64718448)
print v(xbgr.mr_n64718560)
print v(xbgr.mr_n64718880)
print v(xbgr.mr_n64718992)
print v(xbgr.mr_n64719312)
print v(xbgr.mr_n64719424)
print v(xbgr.mr_n64719744)
print v(xbgr.mr_n64719856)
print v(xbgr.mr_n64720176)
print v(xbgr.mr_n64720288)
print v(xbgr.mr_n64720608)
print v(xbgr.mr_n64720720)
print v(xbgr.mr_n64721040)
print v(xbgr.mr_n64721152)
print v(xbgr.mr_n64721472)
print v(xbgr.mr_n64721584)
print v(xbgr.mr_n64721904)
print v(xbgr.mr_n64722016)
print v(xbgr.mr_n64722336)
print v(xbgr.mr_n64722448)
print v(xbgr.mr_n64722768)
print v(xbgr.mr_n64722880)
print v(xbgr.mr_n64723200)
print v(xbgr.mr_n64723312)
print v(xbgr.mr_n64723632)
print v(xbgr.mr_n64723744)
print v(xbgr.mr_n64724064)
print v(xbgr.mr_n64724176)
print v(xbgr.mr_n64724496)
print v(xbgr.mr_n64724608)
print v(xbgr.mr_n64724928)
print v(xbgr.mr_n64725040)
print v(xbgr.mr_n64725360)
print v(xbgr.mr_n64725472)
print v(xbgr.mr_n64725792)
print v(xbgr.mr_n64725904)
print v(xbgr.mr_n64726224)
print v(xbgr.mr_n64726336)
print v(xbgr.mr_n64726656)
print v(xbgr.mr_n64726768)
print v(xbgr.mr_n64727088)
print v(xbgr.mr_n64727200)
print v(xbgr.mr_n64727520)
print v(xbgr.mr_n64727632)
print v(xbgr.mr_n64727952)
print v(xbgr.mr_n64728384)
print v(xbgr.mr_n64728496)
print v(xbgr.mr_n64728816)
print v(xbgr.mr_n64729248)
print v(xbgr.mr_n64729360)
print v(xbgr.mr_n64729680)
print v(xbgr.mr_n64730112)
print v(xbgr.mr_n64730224)
print v(xbgr.mr_n64730544)
print v(xbgr.mr_n64730656)
print v(xbgr.mr_n64730976)
print v(xbgr.mr_n64731088)
print v(xbgr.mr_n64731408)
print v(xbgr.mr_n64731520)
print v(xbgr.mr_n64731840)
print v(xbgr.mr_n64731952)
print v(xbgr.mr_n64732272)
print v(xbgr.mr_n64732384)
print v(xbgr.mr_n64732704)
print v(xbgr.mr_n64732816)
print v(xbgr.mr_n64733136)
print v(xbgr.mr_n64733248)
print v(xbgr.mr_n64733568)
print v(xbgr.mr_n64733680)
print v(xbgr.mr_n64734000)
print v(xbgr.mr_n64734112)
print v(xbgr.mr_n64734432)
print v(xbgr.mr_n64734544)
print v(xbgr.mr_n64734864)
print v(xbgr.mr_n64734976)
print v(xbgr.mr_n64735296)
print v(xbgr.mr_n64735408)
print v(xbgr.mr_n64735728)
print v(xbgr.mr_n64735840)
print v(xbgr.mr_n64736160)
print v(xbgr.mr_n64736272)
print v(xbgr.mr_n64736592)
print v(xbgr.mr_n64736704)
print v(xbgr.mr_n64737024)
print v(xbgr.mr_n64737136)
print v(xbgr.mr_n64737456)
print v(xbgr.mr_n64737568)
print v(xbgr.mr_n64737888)
print v(xbgr.mr_n64738000)
print v(xbgr.mr_n64738320)
print v(xbgr.mr_n64738432)
print v(xbgr.mr_n64738752)
print v(xbgr.mr_n64738864)
print v(xbgr.mr_n64739184)
print v(xbgr.mr_n64739296)
print v(xbgr.mr_n64739616)
print v(xbgr.mr_n64739728)
print v(xbgr.mr_n64740048)
print v(xbgr.mr_n64740160)
print v(xbgr.mr_n64740480)
print v(xbgr.mr_n64740592)
print v(xbgr.mr_n64740912)
print v(xbgr.mr_n64741024)
print v(xbgr.mr_n64741344)
print v(xbgr.mr_n64741456)
print v(xbgr.mr_n64741776)
print v(xbgr.mr_n64741888)
print v(xbgr.mr_n64742208)
print v(xbgr.mr_n64742320)
print v(xbgr.mr_n64742640)
print v(xbgr.mr_n64742752)
print v(xbgr.mr_n64743072)
print v(xbgr.mr_n64743184)
print v(xbgr.mr_n64743504)
print v(xbgr.mr_n64743616)
print v(xbgr.mr_n64743936)
print v(xbgr.mr_n64744048)
print v(xbgr.mr_n64744368)
print v(xbgr.mr_n64744480)
print v(xbgr.mr_n64744800)
print v(xbgr.mr_n64744912)
print v(xbgr.mr_n64745232)
print v(xbgr.mr_n64745344)
print v(xbgr.mr_n64745664)
print v(xbgr.mr_n64745776)
print v(xbgr.mr_n64746096)
print v(xbgr.mr_n64746208)
print v(xbgr.mr_n64746528)
print v(xbgr.mr_n64746640)
print v(xbgr.mr_n64746960)
print v(xbgr.mr_n64747072)
print v(xbgr.mr_n64747392)
print v(xbgr.mr_n64747504)
print v(xbgr.mr_n64747824)
print v(xbgr.mr_n64747936)
print v(xbgr.mr_n64748256)
print v(xbgr.mr_n64748368)
print v(xbgr.mr_n64748688)
print v(xbgr.mr_n64748800)
print v(xbgr.mr_n64749120)
print v(xbgr.mr_n64749232)
print v(xbgr.mr_n64749552)
print v(xbgr.mr_n64749664)
print v(xbgr.mr_n64749984)
print v(xbgr.mr_n64750096)
print v(xbgr.mr_n64750416)
print v(xbgr.mr_n64750528)
print v(xbgr.mr_n64750848)
print v(xbgr.mr_n64750960)
print v(xbgr.mr_n64751280)
print v(xbgr.mr_n64751392)
print v(xbgr.mr_n64751712)
print v(xbgr.mr_n64751824)
print v(xbgr.mr_n64752144)
print v(xbgr.mr_n64752256)
print v(xbgr.mr_n64752576)
print v(xbgr.mr_n64752688)
print v(xbgr.mr_n64753008)
print v(xbgr.mr_n64753120)
print v(xbgr.mr_n64753440)
print v(xbgr.mr_n64753552)
print v(xbgr.mr_n64753872)
print v(xbgr.mr_n64753984)
print v(xbgr.mr_n64754304)
print v(xbgr.mr_n64754416)
print v(xbgr.mr_n64754736)
print v(xbgr.mr_n64754848)
print v(xbgr.mr_n64755168)
print v(xbgr.mr_n64755280)
print v(xbgr.mr_n64755600)
print v(xbgr.mr_n64755712)
print v(xbgr.mr_n64756032)
print v(xbgr.mr_n64756144)
print v(xbgr.mr_n64756464)
print v(xbgr.mr_n64756576)
print v(xbgr.mr_n64756896)
print v(xbgr.mr_n64757008)
print v(xbgr.mr_n64757328)
print v(xbgr.mr_n64757440)
print v(xbgr.mr_n64757760)
print v(xbgr.mr_n64757872)
print v(xbgr.mr_n64758192)
print v(xbgr.mr_n64758304)
print v(xbgr.mr_n64758624)
print v(xbgr.mr_n64758736)
print v(xbgr.mr_n64759056)
print v(xbgr.mr_n64759168)
print v(xbgr.mr_n64759488)
print v(xbgr.mr_n64759600)
print v(xbgr.mr_n64759920)
print v(xbgr.mr_n64760032)
print v(xbgr.mr_n64760352)
print v(xbgr.mr_n64760464)
print v(xbgr.mr_n64760784)
print v(xbgr.mr_n64760896)
print v(xbgr.mr_n64761216)
print v(xbgr.mr_n64761328)
print v(xbgr.mr_n64761648)
print v(xbgr.mr_n64761760)
print v(xbgr.mr_n64762080)
print v(xbgr.mr_n64762192)
print v(xbgr.mr_n64762512)
print v(xbgr.mr_n64762624)
print v(xbgr.mr_n64762944)
print v(xbgr.mr_n64763056)
print v(xbgr.mr_n64763376)
print v(xbgr.mr_n64763488)
print v(xbgr.mr_n64763808)
print v(xbgr.mr_n64763920)
print v(xbgr.mr_n64764240)
print v(xbgr.mr_n64764352)
print v(xbgr.mr_n64764672)
print v(xbgr.mr_n64764784)
print v(xbgr.mr_n64765104)
print v(xbgr.mr_n64765216)
print v(xbgr.mr_n64765536)
print v(xbgr.mr_n64765648)
print v(xbgr.mr_n64765968)
print v(xbgr.mr_n64766080)
print v(xbgr.mr_n64766400)
print v(xbgr.mr_n64766512)
print v(xbgr.mr_n64766832)
print v(xbgr.mr_n64766944)
print v(xbgr.mr_n64767264)
print v(xbgr.mr_n64767376)
print v(xbgr.mr_n64767696)
print v(xbgr.mr_n64767808)
print v(xbgr.mr_n64768128)
print v(xbgr.mr_n64768240)
print v(xbgr.mr_n64768560)
print v(xbgr.mr_n64768672)
print v(xbgr.mr_n64768992)
print v(xbgr.mr_n64769104)
print v(xbgr.mr_n64769424)
print v(xbgr.mr_n64769536)
print v(xbgr.mr_n64769856)
print v(xbgr.mr_n64769968)
print v(xbgr.mr_n64770288)
print v(xbgr.mr_n64770400)
print v(xbgr.mr_n64770720)
print v(xbgr.mr_n64770832)
print v(xbgr.mr_n64771152)
print v(xbgr.mr_n64771264)
print v(xbgr.mr_n64771584)
print v(xbgr.mr_n64771696)
print v(xbgr.mr_n64772016)
print v(xbgr.mr_n64772128)
print v(xbgr.mr_n64772448)
print v(xbgr.mr_n64772560)
print v(xbgr.mr_n64772880)
print v(xbgr.mr_n64772992)
print v(xbgr.mr_n64773312)
print v(xbgr.mr_n64773424)
print v(xbgr.mr_n64773744)
print v(xbgr.mr_n64773856)
print v(xbgr.mr_n64774176)
print v(xbgr.mr_n64774288)
print v(xbgr.mr_n64774608)
print v(xbgr.mr_n64774720)
print v(xbgr.mr_n64775040)
print v(xbgr.mr_n64775152)
print v(xbgr.mr_n64775472)
print v(xbgr.mr_n64775584)
print v(xbgr.mr_n64775904)
print v(xbgr.mr_n64776016)
print v(xbgr.mr_n64776336)
print v(xbgr.mr_n64776448)
print v(xbgr.mr_n64776768)
print v(xbgr.mr_n64776880)
print v(xbgr.mr_n64777200)
print v(xbgr.mr_n64777312)
print v(xbgr.mr_n64777632)
print v(xbgr.mr_n64777744)
print v(xbgr.mr_n64778064)
print v(xbgr.mr_n64778176)
print v(xbgr.mr_n64778496)
print v(xbgr.mr_n64778608)
print v(xbgr.mr_n64778928)
print v(xbgr.mr_n64779040)
print v(xbgr.mr_n64779360)
print v(xbgr.mr_n64779472)
print v(xbgr.mr_n64779792)
print v(xbgr.mr_n64779904)
print v(xbgr.mr_n64780224)
print v(xbgr.mr_n64780336)
print v(xbgr.mr_n64780656)
print v(xbgr.mr_n64780768)
print v(xbgr.mr_n64781088)
print v(xbgr.mr_n64781200)
print v(xbgr.mr_n64781520)
print v(xbgr.mr_n64781632)
print v(xbgr.mr_n64781952)
print v(xbgr.mr_n64782064)
print v(xbgr.mr_n64782384)
print v(xbgr.mr_n64782496)
print v(xbgr.mr_n64782816)
print v(xbgr.mr_n64782928)
print v(xbgr.mr_n64783248)
print v(xbgr.mr_n64783360)
print v(xbgr.mr_n64783680)
print v(xbgr.mr_n64783792)
print v(xbgr.mr_n64784112)
print v(xbgr.mr_n64784224)
print v(xbgr.mr_n64784544)
print v(xbgr.mr_n64784656)
print v(xbgr.mr_n64784976)
print v(xbgr.mr_n64785088)
print v(xbgr.mr_n64785408)
print v(xbgr.mr_n64785520)
print v(xbgr.mr_n64785840)
print v(xbgr.mr_n64785952)
print v(xbgr.mr_n64786272)
print v(xbgr.mr_n64786384)
print v(xbgr.mr_n64786704)
print v(xbgr.mr_n64786816)
print v(xbgr.mr_n64787136)
print v(xbgr.mr_n64787248)
print v(xbgr.mr_n64787568)
print v(xbgr.mr_n64787680)
print v(xbgr.mr_n64788000)
print v(xbgr.mr_n64788112)
print v(xbgr.mr_n64788432)
print v(xbgr.mr_n64788544)
print v(xbgr.mr_n64788864)
print v(xbgr.mr_n64788976)
print v(xbgr.mr_n64789296)
print v(xbgr.mr_n64789408)
print v(xbgr.mr_n64789728)
print v(xbgr.mr_n64789840)
print v(xbgr.mr_n64790160)
print v(xbgr.mr_n64790272)
print v(xbgr.mr_n64790592)
print v(xbgr.mr_n64790704)
print v(xbgr.mr_n64791024)
print v(xbgr.mr_n64791136)
print v(xbgr.mr_n64791456)
print v(xbgr.mr_n64791568)
print v(xbgr.mr_n64791888)
print v(xbgr.mr_n64792000)
print v(xbgr.mr_n64792320)
print v(xbgr.mr_n64792432)
print v(xbgr.mr_n64792752)
print v(xbgr.mr_n64792864)
print v(xbgr.mr_n64793184)
print v(xbgr.mr_n64793296)
print v(xbgr.mr_n64793616)
print v(xbgr.mr_n64793728)
print v(xbgr.mr_n64794048)
print v(xbgr.mr_n64794160)
print v(xbgr.mr_n64794480)
print v(xbgr.mr_n64794592)
print v(xbgr.mr_n64794912)
print v(xbgr.mr_n64795024)
print v(xbgr.mr_n64795344)
print v(xbgr.mr_n64795456)
print v(xbgr.mr_n64795776)
print v(xbgr.mr_n64795888)
print v(xbgr.mr_n64796208)
print v(xbgr.mr_n64796320)
print v(xbgr.mr_n64796640)
print v(xbgr.mr_n64796752)
print v(xbgr.mr_n64797072)
print v(xbgr.mr_n64797184)
print v(xbgr.mr_n64797504)
print v(xbgr.mr_n64797616)
print v(xbgr.mr_n64797936)
print v(xbgr.mr_n64798048)
print v(xbgr.mr_n64798368)
print v(xbgr.mr_n64798480)
print v(xbgr.mr_n64798800)
print v(xbgr.mr_n64798912)
print v(xbgr.mr_n64799232)
print v(xbgr.mr_n64799344)
print v(xbgr.mr_n64799664)
print v(xbgr.mr_n64799776)
print v(xbgr.mr_n64800096)
print v(xbgr.mr_n64800208)
print v(xbgr.mr_n64800528)
print v(xbgr.mr_n64800640)
print v(xbgr.mr_n64800960)
print v(xbgr.mr_n64801072)
print v(xbgr.mr_n64801392)
print v(xbgr.mr_n64801504)
print v(xbgr.mr_n64801824)
print v(xbgr.mr_n64801936)
print v(xbgr.mr_n64802256)
print v(xbgr.mr_n64802368)
print v(xbgr.mr_n64802688)
print v(xbgr.mr_n64802800)
print v(xbgr.mr_n64803120)
print v(xbgr.mr_n64803232)
print v(xbgr.mr_n64803552)
print v(xbgr.mr_n64803664)
print v(xbgr.mr_n64803984)
print v(xbgr.mr_n64804096)
print v(xbgr.mr_n64804416)
print v(xbgr.mr_n64804528)
print v(xbgr.mr_n64804848)
print v(xbgr.mr_n64804960)
print v(xbgr.mr_n64805280)
print v(xbgr.mr_n64805392)
print v(xbgr.mr_n64805712)
print v(xbgr.mr_n64805824)
print v(xbgr.mr_n64806144)
print v(xbgr.mr_n64806256)
print v(xbgr.mr_n64806576)
print v(xbgr.mr_n64806688)
print v(xbgr.mr_n64807008)
print v(xbgr.mr_n64807120)
print v(xbgr.mr_n64807440)
print v(xbgr.mr_n64807552)
print v(xbgr.mr_n64807872)
print v(xbgr.mr_n64807984)
print v(xbgr.mr_n64808304)
print v(xbgr.mr_n64808416)
print v(xbgr.mr_n64808736)
print v(xbgr.mr_n64808848)
print v(xbgr.mr_n64809168)
print v(xbgr.mr_n64809280)
print v(xbgr.mr_n64809600)
print v(xbgr.mr_n64809712)
print v(xbgr.mr_n64810032)
print v(xbgr.mr_n64810144)
print v(xbgr.mr_n64810464)
print v(xbgr.mr_n64810576)
print v(xbgr.mr_n64810896)
print v(xbgr.mr_n64811008)
print v(xbgr.mr_n64811328)
print v(xbgr.mr_n64811440)
print v(xbgr.mr_n64811760)
print v(xbgr.mr_n64811872)
print v(xbgr.mr_n64812192)
print v(xbgr.mr_n64812304)
print v(xbgr.mr_n64812624)
print v(xbgr.mr_n64812736)
print v(xbgr.mr_n64813056)
print v(xbgr.mr_n64813168)
print v(xbgr.mr_n64813488)
print v(xbgr.mr_n64813600)
print v(xbgr.mr_n64813920)
print v(xbgr.mr_n64814032)
print v(xbgr.mr_n64814352)
print v(xbgr.mr_n64814464)
print v(xbgr.mr_n64814784)
print v(xbgr.mr_n64814896)
print v(xbgr.mr_n64815216)
print v(xbgr.mr_n64815328)
print v(xbgr.mr_n64815648)
print v(xbgr.mr_n64815760)
print v(xbgr.mr_n64816080)
print v(xbgr.mr_n64816192)
print v(xbgr.mr_n64816512)
print v(xbgr.mr_n64816624)
print v(xbgr.mr_n64816944)
print v(xbgr.mr_n64817056)
print v(xbgr.mr_n64817376)
print v(xbgr.mr_n64817488)
print v(xbgr.mr_n64817808)
print v(xbgr.mr_n64817920)
print v(xbgr.mr_n64818240)
print v(xbgr.mr_n64818352)
print v(xbgr.mr_n64818672)
print v(xbgr.mr_n64818784)
print v(xbgr.mr_n64819104)
print v(xbgr.mr_n64819216)
print v(xbgr.mr_n64819536)
print v(xbgr.mr_n64819648)
print v(xbgr.mr_n64819968)
print v(xbgr.mr_n64820080)
print v(xbgr.mr_n64820400)
print v(xbgr.mr_n64820512)
print v(xbgr.mr_n64820832)
print v(xbgr.mr_n64820944)
print v(xbgr.mr_n64821264)
print v(xbgr.mr_n64821376)
print v(xbgr.mr_n64821696)
print v(xbgr.mr_n64821808)
print v(xbgr.mr_n64822128)
print v(xbgr.mr_n64822240)
print v(xbgr.mr_n64822560)
print v(xbgr.mr_n64822672)
print v(xbgr.mr_n64822992)
print v(xbgr.mr_n64823104)
print v(xbgr.mr_n64823424)
print v(xbgr.mr_n64823536)
print v(xbgr.mr_n64823856)
print v(xbgr.mr_n64823968)
print v(xbgr.mr_n64824288)
print v(xbgr.mr_n64824400)
print v(xbgr.mr_n64824720)
print v(xbgr.mr_n64824832)
print v(xbgr.mr_n64825152)
print v(xbgr.mr_n64825264)
print v(xbgr.mr_n64825584)
print v(xbgr.mr_n64825696)
print v(xbgr.mr_n64826016)
print v(xbgr.mr_n64826128)
print v(xbgr.mr_n64826448)
print v(xbgr.mr_n64826560)
print v(xbgr.mr_n64826880)
print v(xbgr.mr_n64826992)
print v(xbgr.mr_n64827312)
print v(xbgr.mr_n64827424)
print v(xbgr.mr_n64827744)
print v(xbgr.mr_n64827856)
print v(xbgr.mr_n64828176)
print v(xbgr.mr_n64828288)
print v(xbgr.mr_n64828608)
print v(xbgr.mr_n64828720)
print v(xbgr.mr_n64829040)
print v(xbgr.mr_n64829152)
print v(xbgr.mr_n64829472)
print v(xbgr.mr_n64829584)
print v(xbgr.mr_n64829904)
print v(xbgr.mr_n64830016)
print v(xbgr.mr_n64830336)
print v(xbgr.mr_n64830448)
print v(xbgr.mr_n64830768)
print v(xbgr.mr_n64830880)
print v(xbgr.mr_n64831200)
print v(xbgr.mr_n64831312)
print v(xbgr.mr_n64831632)
print v(xbgr.mr_n64831744)
print v(xbgr.mr_n64832064)
print v(xbgr.mr_n64832176)
print v(xbgr.mr_n64832496)
print v(xbgr.mr_n64832608)
print v(xbgr.mr_n64832928)
print v(xbgr.mr_n64833040)
print v(xbgr.mr_n64833360)
print v(xbgr.mr_n64833472)
print v(xbgr.mr_n64833792)
print v(xbgr.mr_n64833904)
print v(xbgr.mr_n64834224)
print v(xbgr.mr_n64834336)
print v(xbgr.mr_n64834656)
print v(xbgr.mr_n64834768)
print v(xbgr.mr_n64835088)
print v(xbgr.mr_n64835200)
print v(xbgr.mr_n64835520)
print v(xbgr.mr_n64835632)
print v(xbgr.mr_n64835952)
print v(xbgr.mr_n64836064)
print v(xbgr.mr_n64836384)
print v(xbgr.mr_n64836496)
print v(xbgr.mr_n64836816)
print v(xbgr.mr_n64836928)
print v(xbgr.mr_n64837248)
print v(xbgr.mr_n64837360)
print v(xbgr.mr_n64837680)
print v(xbgr.mr_n64837792)
print v(xbgr.mr_n64838112)
print v(xbgr.mr_n64838224)
print v(xbgr.mr_n64838544)
print v(xbgr.mr_n64838656)
print v(xbgr.mr_n64838976)
print v(xbgr.mr_n64839088)
print v(xbgr.mr_n64839408)
print v(xbgr.mr_n64839520)
print v(xbgr.mr_n64839840)
print v(xbgr.mr_n64839952)
print v(xbgr.mr_n64840272)
print v(xbgr.mr_n64840384)
print v(xbgr.mr_n64840704)
print v(xbgr.mr_n64840816)
print v(xbgr.mr_n64841136)
print v(xbgr.mr_n64841248)
print v(xbgr.mr_n64841568)
print v(xbgr.mr_n64841680)
print v(xbgr.mr_n64842000)
print v(xbgr.mr_n64842112)
print v(xbgr.mr_n64842432)
print v(xbgr.mr_n64842544)
print v(xbgr.mr_n64842864)
print v(xbgr.mr_n64842976)
print v(xbgr.mr_n64843296)
print v(xbgr.mr_n64843408)
print v(xbgr.mr_n64843728)
print v(xbgr.mr_n64843840)
print v(xbgr.mr_n64844160)
print v(xbgr.mr_n64844272)
print v(xbgr.mr_n64844592)
print v(xbgr.mr_n64844704)
print v(xbgr.mr_n64845024)
print v(xbgr.mr_n64845136)
print v(xbgr.mr_n64845456)
print v(xbgr.mr_n64845568)
print v(xbgr.mr_n64845888)
print v(xbgr.mr_n64846000)
print v(xbgr.mr_n64846320)
print v(xbgr.mr_n64846432)
print v(xbgr.mr_n64846752)
print v(xbgr.mr_n64846864)
print v(xbgr.mr_n64847184)
print v(xbgr.mr_n64847296)
print v(xbgr.mr_n64847616)
print v(xbgr.mr_n64847728)
print v(xbgr.mr_n64848048)
print v(xbgr.mr_n64848160)
print v(xbgr.mr_n64848480)
print v(xbgr.mr_n64848592)
print v(xbgr.mr_n64848912)
print v(xbgr.mr_n64849024)
print v(xbgr.mr_n64849344)
print v(xbgr.mr_n64849456)
print v(xbgr.mr_n64849776)
print v(xbgr.mr_n64849888)
print v(xbgr.mr_n64850208)
print v(xbgr.mr_n64850320)
print v(xbgr.mr_n64850640)
print v(xbgr.mr_n64850752)
print v(xbgr.mr_n64851072)
print v(xbgr.mr_n64851184)
print v(xbgr.mr_n64851504)
print v(xbgr.mr_n64851616)
print v(xbgr.mr_n64851936)
print v(xbgr.mr_n64852048)
print v(xbgr.mr_n64852368)
print v(xbgr.mr_n64852480)
print v(xbgr.mr_n64852800)
print v(xbgr.mr_n64852912)
print v(xbgr.mr_n64853232)
print v(xbgr.mr_n64853344)
print v(xbgr.mr_n64853664)
print v(xbgr.mr_n64853776)
print v(xbgr.mr_n64854096)
print v(xbgr.mr_n64854208)
print v(xbgr.mr_n64854528)
print v(xbgr.mr_n64854640)
print v(xbgr.mr_n64854960)
print v(xbgr.mr_n64855072)
print v(xbgr.mr_n64855392)
print v(xbgr.mr_n64855504)
print v(xbgr.mr_n64855824)
print v(xbgr.mr_n64855936)
print v(xbgr.mr_n64856256)
print v(xbgr.mr_n64856368)
print v(xbgr.mr_n64856688)
print v(xbgr.mr_n64856800)
print v(xbgr.mr_n64857120)
print v(xbgr.mr_n64857232)
print v(xbgr.mr_n64857552)
print v(xbgr.mr_n64857664)
print v(xbgr.mr_n64857984)
print v(xbgr.mr_n64858096)
print v(xbgr.mr_n64858416)
print v(xbgr.mr_n64858528)
print v(xbgr.mr_n64858848)
print v(xbgr.mr_n64858960)
print v(xbgr.mr_n64859280)
print v(xbgr.mr_n64859392)
print v(xbgr.mr_n64859712)
print v(xbgr.mr_n64859824)
print v(xbgr.mr_n64860144)
print v(xbgr.mr_n64860256)
print v(xbgr.mr_n64860576)
print v(xbgr.mr_n64860688)
print v(xbgr.mr_n64861008)
print v(xbgr.mr_n64861120)
print v(xbgr.mr_n64861440)
print v(xbgr.mr_n64861552)
print v(xbgr.mr_n64861872)
print v(xbgr.mr_n64861984)
print v(xbgr.mr_n64862304)
print v(xbgr.mr_n64862416)
print v(xbgr.mr_n64862736)
print v(xbgr.mr_n64862848)
print v(xbgr.mr_n64863168)
print v(xbgr.mr_n64863280)
print v(xbgr.mr_n64863600)
print v(xbgr.mr_n64863712)
print v(xbgr.mr_n64864032)
print v(xbgr.mr_n64864144)
print v(xbgr.mr_n64864464)
print v(xbgr.mr_n64864576)
print v(xbgr.mr_n64864896)
print v(xbgr.mr_n64865008)
print v(xbgr.mr_n64865328)
print v(xbgr.mr_n64865440)
print v(xbgr.mr_n64865760)
print v(xbgr.mr_n64865872)
print v(xbgr.mr_n64866192)
print v(xbgr.mr_n64866304)
print v(xbgr.mr_n64866624)
print v(xbgr.mr_n64866736)
print v(xbgr.mr_n64867056)
print v(xbgr.mr_n64867168)
print v(xbgr.mr_n64867488)
print v(xbgr.mr_n64867600)
print v(xbgr.mr_n64867920)
print v(xbgr.mr_n64868032)
print v(xbgr.mr_n64868352)
print v(xbgr.mr_n64868464)
print v(xbgr.mr_n64868784)
print v(xbgr.mr_n64868896)
print v(xbgr.mr_n64869216)
print v(xbgr.mr_n64869328)
print v(xbgr.mr_n64869648)
print v(xbgr.mr_n64869760)
print v(xbgr.mr_n64870080)
print v(xbgr.mr_n64870192)
print v(xbgr.mr_n64870512)
print v(xbgr.mr_n64870624)
print v(xbgr.mr_n64870944)
print v(xbgr.mr_n64871056)
print v(xbgr.mr_n64871376)
print v(xbgr.mr_n64871488)
print v(xbgr.mr_n64871808)
print v(xbgr.mr_n64871920)
print v(xbgr.mr_n64872240)
print v(xbgr.mr_n64872352)
print v(xbgr.mr_n64872672)
print v(xbgr.mr_n64872784)
print v(xbgr.mr_n64873104)
print v(xbgr.mr_n64873216)
print v(xbgr.mr_n64873536)
print v(xbgr.mr_n64873648)
print v(xbgr.mr_n64873968)
print v(xbgr.mr_n64874080)
print v(xbgr.mr_n64874400)
print v(xbgr.mr_n64874512)
print v(xbgr.mr_n64874832)
print v(xbgr.mr_n64874944)
print v(xbgr.mr_n64875264)
print v(xbgr.mr_n64875376)
print v(xbgr.mr_n64875696)
print v(xbgr.mr_n64875808)
print v(xbgr.mr_n64876128)
print v(xbgr.mr_n64876240)
print v(xbgr.mr_n64876560)
print v(xbgr.mr_n64876672)
print v(xbgr.mr_n64876992)
print v(xbgr.mr_n64877104)
print v(xbgr.mr_n64877424)
print v(xbgr.mr_n64877536)
print v(xbgr.mr_n64877856)
print v(xbgr.mr_n64877968)
print v(xbgr.mr_n64878288)
print v(xbgr.mr_n64878400)
print v(xbgr.mr_n64878720)
print v(xbgr.mr_n64878832)
print v(xbgr.mr_n64879152)
print v(xbgr.mr_n64879264)
print v(xbgr.mr_n64879584)
print v(xbgr.mr_n64879696)
print v(xbgr.mr_n64880016)
print v(xbgr.mr_n64880128)
print v(xbgr.mr_n64880448)
print v(xbgr.mr_n64880560)
print v(xbgr.mr_n64880880)
print v(xbgr.mr_n64880992)
print v(xbgr.mr_n64881312)
print v(xbgr.mr_n64881424)
print v(xbgr.mr_n64881744)
print v(xbgr.mr_n64881856)
print v(xbgr.mr_n64882176)
print v(xbgr.mr_n64882288)
print v(xbgr.mr_n64882608)
print v(xbgr.mr_n64882720)
print v(xbgr.mr_n64883040)
print v(xbgr.mr_n64883152)
print v(xbgr.mr_n64883472)
print v(xbgr.mr_n64883584)
print v(xbgr.mr_n64883904)
print v(xbgr.mr_n64884016)
print v(xbgr.mr_n64884336)
print v(xbgr.mr_n64884448)
print v(xbgr.mr_n64884768)
print v(xbgr.mr_n64884880)
print v(xbgr.mr_n64885200)
print v(xbgr.mr_n64885312)
print v(xbgr.mr_n64885632)
print v(xbgr.mr_n64885744)
print v(xbgr.mr_n64886064)
print v(xbgr.mr_n64886176)
print v(xbgr.mr_n64886496)
print v(xbgr.mr_n64886608)
print v(xbgr.mr_n64886928)
print v(xbgr.mr_n64887040)
print v(xbgr.mr_n64887360)
print v(xbgr.mr_n64887472)
print v(xbgr.mr_n64887792)
print v(xbgr.mr_n64887904)
print v(xbgr.mr_n64888224)
print v(xbgr.mr_n64888336)
print v(xbgr.mr_n64888656)
print v(xbgr.mr_n64888768)
print v(xbgr.mr_n64889088)
print v(xbgr.mr_n64889200)
print v(xbgr.mr_n64889520)
print v(xbgr.mr_n64889632)
print v(xbgr.mr_n64889952)
print v(xbgr.mr_n64890064)
print v(xbgr.mr_n64890384)
print v(xbgr.mr_n64890496)
print v(xbgr.mr_n64890816)
print v(xbgr.mr_n64890928)
print v(xbgr.mr_n64891248)
print v(xbgr.mr_n64891360)
print v(xbgr.mr_n64891680)
print v(xbgr.mr_n64891792)
print v(xbgr.mr_n64892112)
print v(xbgr.mr_n64892224)
print v(xbgr.mr_n64892544)
print v(xbgr.mr_n64892656)
print v(xbgr.mr_n64892976)
print v(xbgr.mr_n64893088)
print v(xbgr.mr_n64893408)
print v(xbgr.mr_n64893520)
print v(xbgr.mr_n64893840)
print v(xbgr.mr_n64893952)
print v(xbgr.mr_n64894272)
print v(xbgr.mr_n64894384)
print v(xbgr.mr_n64894704)
print v(xbgr.mr_n64894816)
print v(xbgr.mr_n64895136)
print v(xbgr.mr_n64895248)
print v(xbgr.mr_n64895680)
print v(xbgr.mr_n64896000)
print v(xbgr.mr_n64896112)
print v(xbgr.mr_n64896544)
print v(xbgr.mr_n64896864)
print v(xbgr.mr_n64896976)
print v(xbgr.mr_n64897408)
print v(xbgr.mr_n64897728)
print v(xbgr.mr_n64898592)
print v(xbgr.mr_n64899456)
print v(xbgr.mr_n64899568)
print v(xbgr.mr_n64899888)
print v(xbgr.mr_n64900000)
print v(xbgr.mr_n64900320)
print v(xbgr.mr_n64900432)
print v(xbgr.mr_n64900752)
print v(xbgr.mr_n64900864)
print v(xbgr.mr_n64901184)
print v(xbgr.mr_n64901296)
print v(xbgr.mr_n64901616)
print v(xbgr.mr_n64901728)
print v(xbgr.mr_n64902048)
print v(xbgr.mr_n64902912)
print v(xbgr.mr_n64903776)
print v(xbgr.mr_n64904640)
print v(xbgr.mr_n64904752)
print v(xbgr.mr_n64905072)
print v(xbgr.mr_n64905184)
print v(xbgr.mr_n64905504)
print v(xbgr.mr_n64905616)
print v(xbgr.mr_n64905936)
print v(xbgr.mr_n64906048)
print v(xbgr.mr_n64906368)
print v(xbgr.mr_n64907232)
print v(xbgr.mr_n64908096)
print v(xbgr.mr_n64908208)
print v(xbgr.mr_n64908528)
print v(xbgr.mr_n64908640)
print v(xbgr.mr_n64908960)
print v(xbgr.mr_n64909072)
print v(xbgr.mr_n64909392)
print v(xbgr.mr_n64909504)
print v(xbgr.mr_n64909824)
print v(xbgr.mr_n64909936)
print v(xbgr.mr_n64910256)
print v(xbgr.mr_n64910368)
print v(xbgr.mr_n64910688)
print v(xbgr.mr_n64911552)
print v(xbgr.mr_n64911664)
print v(xbgr.mr_n64912096)
print v(xbgr.mr_n64912416)
print v(xbgr.mr_n64912528)
print v(xbgr.mr_n64912960)
print v(xbgr.mr_n64913280)
print v(xbgr.mr_n64913392)
print v(xbgr.mr_n64913824)
print v(xbgr.mr_n64914144)
print v(xbgr.mr_n64915008)
print v(xbgr.mr_n64915872)
print v(xbgr.mr_n64916736)
print v(xbgr.mr_n64917600)
print v(xbgr.mr_n64918464)
print v(xbgr.mr_n64919328)
print v(xbgr.mr_n64919440)
print v(xbgr.mr_n64919760)
print v(xbgr.mr_n64919872)
print v(xbgr.mr_n64920192)
print v(xbgr.mr_n64920304)
print v(xbgr.mr_n64920624)
print v(xbgr.mr_n64920736)
print v(xbgr.mr_n64921056)
print v(xbgr.mr_n64921920)
print v(xbgr.mr_n64922784)
print v(xbgr.mr_n64923648)
print v(xbgr.mr_n64924512)
print v(xbgr.mr_n64924624)
print v(xbgr.mr_n64925056)
print v(xbgr.mr_n64925376)
print v(xbgr.mr_n64925488)
print v(xbgr.mr_n64925920)
print v(xbgr.mr_n64926240)
print v(xbgr.mr_n64926352)
print v(xbgr.mr_n64926784)
print v(xbgr.mr_n64927104)
print v(xbgr.mr_n64927968)
print v(xbgr.mr_n64928832)
print v(xbgr.mr_n64929696)
print v(xbgr.mr_n64930560)
print v(xbgr.mr_n64931424)
print v(xbgr.mr_n64932288)
print v(xbgr.mr_n64932400)
print v(xbgr.mr_n64932720)
print v(xbgr.mr_n64932832)
print v(xbgr.mr_n64933152)
print v(xbgr.mr_n64933264)
print v(xbgr.mr_n64933584)
print v(xbgr.mr_n64933696)
print v(xbgr.mr_n64934016)
print v(xbgr.mr_n64934880)
print v(xbgr.mr_n64935744)
print v(xbgr.mr_n64936608)
print v(xbgr.mr_n64936720)
print v(xbgr.mr_n64937040)
print v(xbgr.mr_n64937152)
print v(xbgr.mr_n64937472)
print v(xbgr.mr_n64937584)
print v(xbgr.mr_n64938016)
print v(xbgr.mr_n64938448)
print v(xbgr.mr_n64938880)
print v(xbgr.mr_n64939200)
print v(xbgr.mr_n64939312)
print v(xbgr.mr_n64939632)
print v(xbgr.mr_n64939744)
print v(xbgr.mr_n64940064)
print v(xbgr.mr_n64940176)
print v(xbgr.mr_n64940496)
print v(xbgr.mr_n64940608)
print v(xbgr.mr_n64940928)
print v(xbgr.mr_n64941040)
print v(xbgr.mr_n64941360)
print v(xbgr.mr_n64941472)
print v(xbgr.mr_n64941792)
print v(xbgr.mr_n64941904)
print v(xbgr.mr_n64942336)
print v(xbgr.mr_n64942656)
print v(xbgr.mr_n64943088)
print v(xbgr.mr_n64943200)
print v(xbgr.mr_n64943520)
print v(xbgr.mr_n64943632)
print v(xbgr.mr_n64943952)
print v(xbgr.mr_n64944064)
print v(xbgr.mr_n64944384)
print v(xbgr.mr_n64944496)
print v(xbgr.mr_n64944816)
print v(xbgr.mr_n64944928)
print v(xbgr.mr_n64945248)
print v(xbgr.mr_n64945360)
print v(xbgr.mr_n64945680)
print v(xbgr.mr_n64945792)
print v(xbgr.mr_n64946224)
print v(xbgr.mr_n64946544)
print v(xbgr.mr_n64946656)
print v(xbgr.mr_n64947088)
print v(xbgr.mr_n64947408)
print v(xbgr.mr_n64947520)
print v(xbgr.mr_n64947840)
print v(xbgr.mr_n64947952)
print v(xbgr.mr_n64948272)
print v(xbgr.mr_n64948384)
print v(xbgr.mr_n64948816)
print v(xbgr.mr_n64949248)
print v(xbgr.mr_n64949568)
print v(xbgr.mr_n64949680)
print v(xbgr.mr_n64950000)
print v(xbgr.mr_n64950112)
print v(xbgr.mr_n64950432)
print v(xbgr.mr_n64950544)
print v(xbgr.mr_n64950864)
print v(xbgr.mr_n64950976)
print v(xbgr.mr_n64951296)
print v(xbgr.mr_n64951408)
print v(xbgr.mr_n64951728)
print v(xbgr.mr_n64951840)
print v(xbgr.mr_n64952160)
print v(xbgr.mr_n64952272)
print v(xbgr.mr_n64952592)
print v(xbgr.mr_n64952704)
print v(xbgr.mr_n64953024)
print v(xbgr.mr_n64953136)
print v(xbgr.mr_n64953456)
print v(xbgr.mr_n64953568)
print v(xbgr.mr_n64953888)
print v(xbgr.mr_n64954000)
print v(xbgr.mr_n64954320)
print v(xbgr.mr_n64955184)
print v(xbgr.mr_n64956048)
print v(xbgr.mr_n64956160)
print v(xbgr.mr_n64956592)
print v(xbgr.mr_n64956912)
print v(xbgr.mr_n64957024)
print v(xbgr.mr_n64957776)
print v(xbgr.mr_n64958208)
print v(xbgr.mr_n64958320)
print v(xbgr.mr_n64958640)
print v(xbgr.mr_n64958752)
print v(xbgr.mr_n64959072)
print v(xbgr.mr_n64959184)
print v(xbgr.mr_n64959504)
print v(xbgr.mr_n64959616)
print v(xbgr.mr_n64959936)
print v(xbgr.mr_n64960800)
print v(xbgr.mr_n64961232)
print v(xbgr.mr_n64961344)
print v(xbgr.mr_n64961664)
print v(xbgr.mr_n64961776)
print v(xbgr.mr_n64962096)
print v(xbgr.mr_n64962960)
print v(xbgr.mr_n64964256)
print v(xbgr.mr_n64965120)
print v(xbgr.mr_n64965984)
print v(xbgr.mr_n64966096)
print v(xbgr.mr_n64966848)
print v(xbgr.mr_n64966960)
print v(xbgr.mr_n64967392)
print v(xbgr.mr_n64967824)
print v(xbgr.mr_n64968576)
print v(xbgr.mr_n64969440)
print v(xbgr.mr_n64970304)
print v(xbgr.mr_n64970416)
print v(xbgr.mr_n64970736)
print v(xbgr.mr_n64970848)
print v(xbgr.mr_n64971280)
print v(xbgr.mr_n64971600)
print v(xbgr.mr_n64971712)
print v(xbgr.mr_n64972144)
print v(xbgr.mr_n64972464)
print v(xbgr.mr_n64972576)
print v(xbgr.mr_n64972896)
print v(xbgr.mr_n64973008)
print v(xbgr.mr_n64973328)
print v(xbgr.mr_n64974192)
print v(xbgr.mr_n64974304)
print v(xbgr.mr_n64974736)
print v(xbgr.mr_n64975056)
print v(xbgr.mr_n64976032)
print v(xbgr.mr_n64976352)
print v(xbgr.mr_n64976464)
print v(xbgr.mr_n64976896)
print v(xbgr.mr_n64977216)
print v(xbgr.mr_n64977648)
print v(xbgr.mr_n64977760)
print v(xbgr.mr_n64978080)
print v(xbgr.mr_n64978192)
print v(xbgr.mr_n64978512)
print v(xbgr.mr_n64978944)
print v(xbgr.mr_n64979056)
print v(xbgr.mr_n64979376)
print v(xbgr.mr_n64979488)
print v(xbgr.mr_n64979808)
print v(xbgr.mr_n64979920)
print v(xbgr.mr_n64980240)
print v(xbgr.mr_n64980352)
print v(xbgr.mr_n64980672)
print v(xbgr.mr_n64980784)
print v(xbgr.mr_n64981216)
print v(xbgr.mr_n64981536)
print v(xbgr.mr_n64981648)
print v(xbgr.mr_n64981968)
print v(xbgr.mr_n64982080)
print v(xbgr.mr_n64982400)
print v(xbgr.mr_n64982944)
print v(xbgr.mr_n64983696)
print v(xbgr.mr_n64984992)
print v(xbgr.mr_n64985104)
print v(xbgr.mr_n64985424)
print v(xbgr.mr_n64985536)
print v(xbgr.mr_n64985856)
print v(xbgr.mr_n64986720)
print v(xbgr.mr_n64987584)
print v(xbgr.mr_n64988448)
print v(xbgr.mr_n64988560)
print v(xbgr.mr_n64988880)
print v(xbgr.mr_n64988992)
print v(xbgr.mr_n64989312)
print v(xbgr.mr_n64989424)
print v(xbgr.mr_n64989744)
print v(xbgr.mr_n64989856)
print v(xbgr.mr_n64990176)
print v(xbgr.mr_n64990288)
print v(xbgr.mr_n64990608)
print v(xbgr.mr_n64991472)
print v(xbgr.mr_n64992336)
print v(xbgr.mr_n64993200)
print v(xbgr.mr_n64993312)
print v(xbgr.mr_n64993632)
print v(xbgr.mr_n64993744)
print v(xbgr.mr_n64994064)
print v(xbgr.mr_n64994176)
print v(xbgr.mr_n64994496)
print v(xbgr.mr_n64994608)
print v(xbgr.mr_n64995040)
print v(xbgr.mr_n64995360)
print v(xbgr.mr_n64995472)
print v(xbgr.mr_n64995792)
print v(xbgr.mr_n64995904)
print v(xbgr.mr_n64996224)
print v(xbgr.mr_n64996336)
print v(xbgr.mr_n64996656)
print v(xbgr.mr_n64996768)
print v(xbgr.mr_n64997520)
print v(xbgr.mr_n64998064)
print v(xbgr.mr_n64998496)
print v(xbgr.mr_n64998928)
print v(xbgr.mr_n64999360)
print v(xbgr.mr_n64999680)
print v(xbgr.mr_n64999792)
print v(xbgr.mr_n65000544)
print v(xbgr.mr_n65001408)
print v(xbgr.mr_n65002272)
print v(xbgr.mr_n65003136)
print v(xbgr.mr_n65004000)
print v(xbgr.mr_n65004864)
print v(xbgr.mr_n65005728)
print v(xbgr.mr_n65005840)
print v(xbgr.mr_n65006160)
print v(xbgr.mr_n65006272)
print v(xbgr.mr_n65006704)
print v(xbgr.mr_n65007024)
print v(xbgr.mr_n65007136)
print v(xbgr.mr_n65007568)
print v(xbgr.mr_n65007888)
print v(xbgr.mr_n65008000)
print v(xbgr.mr_n65008320)
print v(xbgr.mr_n65008432)
print v(xbgr.mr_n65008752)
print v(xbgr.mr_n65008864)
print v(xbgr.mr_n65009184)
print v(xbgr.mr_n65009296)
print v(xbgr.mr_n65009616)
print v(xbgr.mr_n65009728)
print v(xbgr.mr_n65010048)
print v(xbgr.mr_n65010160)
print v(xbgr.mr_n65010480)
print v(xbgr.mr_n65011344)
print v(xbgr.mr_n65011776)
print v(xbgr.mr_n65012752)
print v(xbgr.mr_n65013184)
print v(xbgr.mr_n65013616)
print v(xbgr.mr_n65014048)
print v(xbgr.mr_n65014368)
print v(xbgr.mr_n65015232)
print v(xbgr.mr_n65016096)
print v(xbgr.mr_n65016960)
print v(xbgr.mr_n65017824)
print v(xbgr.mr_n65018688)
print v(xbgr.mr_n65019552)
print v(xbgr.mr_n65020848)
print v(xbgr.mr_n65021280)
print v(xbgr.mr_n65022576)
print v(xbgr.mr_n65022688)
print v(xbgr.mr_n65023008)
print v(xbgr.mr_n65023120)
print v(xbgr.mr_n65023440)
print v(xbgr.mr_n65023552)
print v(xbgr.mr_n65023984)
print v(xbgr.mr_n65024416)
print v(xbgr.mr_n65024736)
print v(xbgr.mr_n65024848)
print v(xbgr.mr_n65025168)
print v(xbgr.mr_n65025280)
print v(xbgr.mr_n65025600)
print v(xbgr.mr_n65025712)
print v(xbgr.mr_n65026032)
print v(xbgr.mr_n65026144)
print v(xbgr.mr_n65026576)
print v(xbgr.mr_n65026896)
print v(xbgr.mr_n65027760)
print v(xbgr.mr_n65027872)
print v(xbgr.mr_n65028192)
print v(xbgr.mr_n65028304)
print v(xbgr.mr_n65028624)
print v(xbgr.mr_n65028736)
print v(xbgr.mr_n65029056)
print v(xbgr.mr_n65029168)
print v(xbgr.mr_n65029488)
print v(xbgr.mr_n65030352)
print v(xbgr.mr_n65030784)
print v(xbgr.mr_n65032080)
print v(xbgr.mr_n65032192)
print v(xbgr.mr_n65032512)
print v(xbgr.mr_n65032624)
print v(xbgr.mr_n65032944)
print v(xbgr.mr_n65033056)
print v(xbgr.mr_n65033376)
print v(xbgr.mr_n65034240)
print v(xbgr.mr_n65034352)
print v(xbgr.mr_n65034784)
print v(xbgr.mr_n65035104)
print v(xbgr.mr_n65035216)
print v(xbgr.mr_n65035536)
print v(xbgr.mr_n65035648)
print v(xbgr.mr_n65035968)
print v(xbgr.mr_n65036080)
print v(xbgr.mr_n65036400)
print v(xbgr.mr_n65036512)
print v(xbgr.mr_n65036944)
print v(xbgr.mr_n65037264)
print v(xbgr.mr_n65038128)
print v(xbgr.mr_n65038240)
print v(xbgr.mr_n65038560)
print v(xbgr.mr_n65039424)
print v(xbgr.mr_n65039536)
print v(xbgr.mr_n65039856)
print v(xbgr.mr_n65039968)
print v(xbgr.mr_n65040288)
print v(xbgr.mr_n65040832)
print v(xbgr.mr_n65041264)
print v(xbgr.mr_n65041584)
print v(xbgr.mr_n65042016)
print v(xbgr.mr_n65042128)
print v(xbgr.mr_n65042448)
print v(xbgr.mr_n65042560)
print v(xbgr.mr_n65042880)
print v(xbgr.mr_n65042992)
print v(xbgr.mr_n65043312)
print v(xbgr.mr_n65043424)
print v(xbgr.mr_n65043744)
print v(xbgr.mr_n65043856)
print v(xbgr.mr_n65044608)
print v(xbgr.mr_n65044720)
print v(xbgr.mr_n65045040)
print v(xbgr.mr_n65045152)
print v(xbgr.mr_n65045472)
print v(xbgr.mr_n65046768)
print v(xbgr.mr_n65046880)
print v(xbgr.mr_n65047200)
print v(xbgr.mr_n65047312)
print v(xbgr.mr_n65047632)
print v(xbgr.mr_n65048608)
print v(xbgr.mr_n65048928)
print v(xbgr.mr_n65049792)
print v(xbgr.mr_n65050224)
print v(xbgr.mr_n65050336)
print v(xbgr.mr_n65050656)
print v(xbgr.mr_n65050768)
print v(xbgr.mr_n65051088)
print v(xbgr.mr_n65051200)
print v(xbgr.mr_n65051520)
print v(xbgr.mr_n65052384)
print v(xbgr.mr_n65053680)
print v(xbgr.mr_n65054544)
print v(xbgr.mr_n65055520)
print v(xbgr.mr_n65055840)
print v(xbgr.mr_n65055952)
print v(xbgr.mr_n65056384)
print v(xbgr.mr_n65056704)
print v(xbgr.mr_n65056816)
print v(xbgr.mr_n65057136)
print v(xbgr.mr_n65057248)
print v(xbgr.mr_n65057568)
print v(xbgr.mr_n65057680)
print v(xbgr.mr_n65058000)
print v(xbgr.mr_n65058112)
print v(xbgr.mr_n65058432)
print v(xbgr.mr_n65058544)
print v(xbgr.mr_n65058864)
print v(xbgr.mr_n65058976)
print v(xbgr.mr_n65059296)
print v(xbgr.mr_n65059408)
print v(xbgr.mr_n65059728)
print v(xbgr.mr_n65059840)
print v(xbgr.mr_n65060272)
print v(xbgr.mr_n65060592)
print v(xbgr.mr_n65060704)
print v(xbgr.mr_n65061136)
print v(xbgr.mr_n65061456)
print v(xbgr.mr_n65062320)
print v(xbgr.mr_n65063184)
print v(xbgr.mr_n65064048)
print v(xbgr.mr_n65064160)
print v(xbgr.mr_n65064480)
print v(xbgr.mr_n65064592)
print v(xbgr.mr_n65064912)
print v(xbgr.mr_n65065024)
print v(xbgr.mr_n65065344)
print v(xbgr.mr_n65065456)
print v(xbgr.mr_n65065888)
print v(xbgr.mr_n65066320)
print v(xbgr.mr_n65066752)
print v(xbgr.mr_n65067184)
print v(xbgr.mr_n65067504)
print v(xbgr.mr_n65067616)
print v(xbgr.mr_n65067936)
print v(xbgr.mr_n65068048)
print v(xbgr.mr_n65068368)
print v(xbgr.mr_n65068480)
print v(xbgr.mr_n65068800)
print v(xbgr.mr_n65068912)
print v(xbgr.mr_n65069232)
print v(xbgr.mr_n65069344)
print v(xbgr.mr_n65069664)
print v(xbgr.mr_n65069776)
print v(xbgr.mr_n65070096)
print v(xbgr.mr_n65070208)
print v(xbgr.mr_n65070640)
print v(xbgr.mr_n65070960)
print v(xbgr.mr_n65071072)
print v(xbgr.mr_n65071392)
print v(xbgr.mr_n65072256)
print v(xbgr.mr_n65072992)
print v(xbgr.mr_n65073856)
print v(xbgr.mr_n65074720)
print v(xbgr.mr_n65075584)
print v(xbgr.mr_n65076448)
print v(xbgr.mr_n65076560)
print v(xbgr.mr_n65076992)
print v(xbgr.mr_n65077312)
print v(xbgr.mr_n65077424)
print v(xbgr.mr_n65077856)
print v(xbgr.mr_n65078176)
print v(xbgr.mr_n65078288)
print v(xbgr.mr_n65078608)
print v(xbgr.mr_n65078720)
print v(xbgr.mr_n65079040)
print v(xbgr.mr_n65079152)
print v(xbgr.mr_n65079584)
print v(xbgr.mr_n65079904)
print v(xbgr.mr_n65080768)
print v(xbgr.mr_n65080880)
print v(xbgr.mr_n65081200)
print v(xbgr.mr_n65081312)
print v(xbgr.mr_n65081632)
print v(xbgr.mr_n65081744)
print v(xbgr.mr_n65082064)
print v(xbgr.mr_n65082176)
print v(xbgr.mr_n65082496)
print v(xbgr.mr_n65082608)
print v(xbgr.mr_n65082928)
print v(xbgr.mr_n65083040)
print v(xbgr.mr_n65083360)
print v(xbgr.mr_n65083472)
print v(xbgr.mr_n65083792)
print v(xbgr.mr_n65084224)
print v(xbgr.mr_n65084336)
print v(xbgr.mr_n65084656)
print v(xbgr.mr_n65084768)
print v(xbgr.mr_n65085088)
print v(xbgr.mr_n65085200)
print v(xbgr.mr_n65085520)
print v(xbgr.mr_n65085632)
print v(xbgr.mr_n65085952)
print v(xbgr.mr_n65087248)
print v(xbgr.mr_n65088112)
print v(xbgr.mr_n65088656)
print v(xbgr.mr_n65089088)
print v(xbgr.mr_n65089408)
print v(xbgr.mr_n65089520)
print v(xbgr.mr_n65089840)
print v(xbgr.mr_n65089952)
print v(xbgr.mr_n65090272)
print v(xbgr.mr_n65090384)
print v(xbgr.mr_n65090704)
print v(xbgr.mr_n65090816)
print v(xbgr.mr_n65091136)
print v(xbgr.mr_n65091248)
print v(xbgr.mr_n65091568)
print v(xbgr.mr_n65091680)
print v(xbgr.mr_n65092000)
print v(xbgr.mr_n65092112)
print v(xbgr.mr_n65092432)
print v(xbgr.mr_n65092544)
print v(xbgr.mr_n65092864)
print v(xbgr.mr_n65092976)
print v(xbgr.mr_n65093296)
print v(xbgr.mr_n65094160)
print v(xbgr.mr_n65095024)
print v(xbgr.mr_n65095136)
print v(xbgr.mr_n65095568)
print v(xbgr.mr_n65096320)
print v(xbgr.mr_n65097184)
print v(xbgr.mr_n65098048)
print v(xbgr.mr_n65099024)
print v(xbgr.mr_n65099456)
print v(xbgr.mr_n65099776)
print v(xbgr.mr_n65099888)
print v(xbgr.mr_n65100208)
print v(xbgr.mr_n65100320)
print v(xbgr.mr_n65100640)
print v(xbgr.mr_n65101504)
print v(xbgr.mr_n65102368)
print v(xbgr.mr_n65102480)
print v(xbgr.mr_n65102800)
print v(xbgr.mr_n65102912)
print v(xbgr.mr_n65103232)
print v(xbgr.mr_n65103344)
print v(xbgr.mr_n65103664)
print v(xbgr.mr_n65103776)
print v(xbgr.mr_n65104096)
print v(xbgr.mr_n65104208)
print v(xbgr.mr_n65104528)
print v(xbgr.mr_n65104640)
print v(xbgr.mr_n65104960)
print v(xbgr.mr_n65105072)
print v(xbgr.mr_n65105392)
print v(xbgr.mr_n65105504)
print v(xbgr.mr_n65105824)
print v(xbgr.mr_n65105936)
print v(xbgr.mr_n65106368)
print v(xbgr.mr_n65106688)
print v(xbgr.mr_n65107120)
print v(xbgr.mr_n65107232)
print v(xbgr.mr_n65107984)
print v(xbgr.mr_n65108096)
print v(xbgr.mr_n65108528)
print v(xbgr.mr_n65109280)
print v(xbgr.mr_n65109392)
print v(xbgr.mr_n65109712)
print v(xbgr.mr_n65109824)
print v(xbgr.mr_n65110256)
print v(xbgr.mr_n65110688)
print v(xbgr.mr_n65111120)
print v(xbgr.mr_n65111440)
print v(xbgr.mr_n65111552)
print v(xbgr.mr_n65111872)
print v(xbgr.mr_n65111984)
print v(xbgr.mr_n65112416)
print v(xbgr.mr_n65112736)
print v(xbgr.mr_n65113600)
print v(xbgr.mr_n65113712)
print v(xbgr.mr_n65114032)
print v(xbgr.mr_n65114144)
print v(xbgr.mr_n65114464)
print v(xbgr.mr_n65114576)
print v(xbgr.mr_n65114896)
print v(xbgr.mr_n65115008)
print v(xbgr.mr_n65115328)
print v(xbgr.mr_n65115440)
print v(xbgr.mr_n65115760)
print v(xbgr.mr_n65115872)
print v(xbgr.mr_n65116192)
print v(xbgr.mr_n65117056)
print v(xbgr.mr_n65117920)
print v(xbgr.mr_n65118032)
print v(xbgr.mr_n65118352)
print v(xbgr.mr_n65118464)
print v(xbgr.mr_n65118784)
print v(xbgr.mr_n65118896)
print v(xbgr.mr_n65119216)
print v(xbgr.mr_n65119328)
print v(xbgr.mr_n65119648)
print v(xbgr.mr_n65120512)
print v(xbgr.mr_n65121376)
print v(xbgr.mr_n65122240)
print v(xbgr.mr_n65123104)
print v(xbgr.mr_n65124512)
print v(xbgr.mr_n65124832)
print v(xbgr.mr_n65125696)
print v(xbgr.mr_n65126560)
print v(xbgr.mr_n65126672)
print v(xbgr.mr_n65127104)
print v(xbgr.mr_n65127424)
print v(xbgr.mr_n65127536)
print v(xbgr.mr_n65127968)
print v(xbgr.mr_n65128288)
print v(xbgr.mr_n65129152)
print v(xbgr.mr_n65130016)
print v(xbgr.mr_n65130880)
print v(xbgr.mr_n65131744)
print v(xbgr.mr_n65131856)
print v(xbgr.mr_n65132176)
print v(xbgr.mr_n65132288)
print v(xbgr.mr_n65132608)
print v(xbgr.mr_n65132720)
print v(xbgr.mr_n65133040)
print v(xbgr.mr_n65133152)
print v(xbgr.mr_n65133472)
print v(xbgr.mr_n65134336)
print v(xbgr.mr_n65135200)
print v(xbgr.mr_n65135312)
print v(xbgr.mr_n65135632)
print v(xbgr.mr_n65135744)
print v(xbgr.mr_n65136176)
print v(xbgr.mr_n65136608)
print v(xbgr.mr_n65136928)
print v(xbgr.mr_n65137040)
print v(xbgr.mr_n65137360)
print v(xbgr.mr_n65137472)
print v(xbgr.mr_n65137792)
print v(xbgr.mr_n65137904)
print v(xbgr.mr_n65138224)
print v(xbgr.mr_n65138336)
print v(xbgr.mr_n65138656)
print v(xbgr.mr_n65138768)
print v(xbgr.mr_n65139200)
print v(xbgr.mr_n65139520)
print v(xbgr.mr_n65139632)
print v(xbgr.mr_n65140064)
print v(xbgr.mr_n65140384)
print v(xbgr.mr_n65141248)
print v(xbgr.mr_n65142112)
print v(xbgr.mr_n65142976)
print v(xbgr.mr_n65143840)
print v(xbgr.mr_n65143952)
print v(xbgr.mr_n65144272)
print v(xbgr.mr_n65144384)
print v(xbgr.mr_n65144704)
print v(xbgr.mr_n65144816)
print v(xbgr.mr_n65145136)
print v(xbgr.mr_n65145248)
print v(xbgr.mr_n65145568)
print v(xbgr.mr_n65146432)
print v(xbgr.mr_n65147296)
print v(xbgr.mr_n65147408)
print v(xbgr.mr_n65147728)
print v(xbgr.mr_n65147840)
print v(xbgr.mr_n65148272)
print v(xbgr.mr_n65148704)
print v(xbgr.mr_n65149024)
print v(xbgr.mr_n65149136)
print v(xbgr.mr_n65149456)
print v(xbgr.mr_n65149568)
print v(xbgr.mr_n65149888)
print v(xbgr.mr_n65150000)
print v(xbgr.mr_n65150320)
print v(xbgr.mr_n65150432)
print v(xbgr.mr_n65150752)
print v(xbgr.mr_n65150864)
print v(xbgr.mr_n65151296)
print v(xbgr.mr_n65151616)
print v(xbgr.mr_n65151728)
print v(xbgr.mr_n65152160)
print v(xbgr.mr_n65152480)
print v(xbgr.mr_n65152592)
print v(xbgr.mr_n65153024)
print v(xbgr.mr_n65153344)
print v(xbgr.mr_n65153456)
print v(xbgr.mr_n65153888)
print v(xbgr.mr_n65154208)
print v(xbgr.mr_n65155072)
print v(xbgr.mr_n65155936)
print v(xbgr.mr_n65156800)
print v(xbgr.mr_n65157664)
print v(xbgr.mr_n65158528)
print v(xbgr.mr_n65159392)
print v(xbgr.mr_n65159504)
print v(xbgr.mr_n65159824)
print v(xbgr.mr_n65159936)
print v(xbgr.mr_n65160256)
print v(xbgr.mr_n65160368)
print v(xbgr.mr_n65160688)
print v(xbgr.mr_n65160800)
print v(xbgr.mr_n65161120)
print v(xbgr.mr_n65161232)
print v(xbgr.mr_n65161552)
print v(xbgr.mr_n65161664)
print v(xbgr.mr_n65161984)
print v(xbgr.mr_n65162096)
print v(xbgr.mr_n65162416)
print v(xbgr.mr_n65162528)
print v(xbgr.mr_n65162848)
print v(xbgr.mr_n65162960)
print v(xbgr.mr_n65163280)
print v(xbgr.mr_n65163392)
print v(xbgr.mr_n65163824)
print v(xbgr.mr_n65164256)
print v(xbgr.mr_n65164576)
print v(xbgr.mr_n65165440)
print v(xbgr.mr_n65166304)
print v(xbgr.mr_n65166416)
print v(xbgr.mr_n65166736)
print v(xbgr.mr_n65166848)
print v(xbgr.mr_n65167168)
print v(xbgr.mr_n65167280)
print v(xbgr.mr_n65167600)
print v(xbgr.mr_n65167712)
print v(xbgr.mr_n65168032)
print v(xbgr.mr_n65168144)
print v(xbgr.mr_n65168464)
print v(xbgr.mr_n65168576)
print v(xbgr.mr_n65168896)
print v(xbgr.mr_n65169008)
print v(xbgr.mr_n65169328)
print v(xbgr.mr_n65169440)
print v(xbgr.mr_n65169872)
print v(xbgr.mr_n65170304)
print v(xbgr.mr_n65170624)
print v(xbgr.mr_n65170736)
print v(xbgr.mr_n65171056)
print v(xbgr.mr_n65171168)
print v(xbgr.mr_n65171488)
print v(xbgr.mr_n65171600)
print v(xbgr.mr_n65171920)
print v(xbgr.mr_n65172032)
print v(xbgr.mr_n65172352)
print v(xbgr.mr_n65172464)
print v(xbgr.mr_n65172784)
print v(xbgr.mr_n65172896)
print v(xbgr.mr_n65173216)
print v(xbgr.mr_n65174080)
print v(xbgr.mr_n65174944)
print v(xbgr.mr_n65175808)
print v(xbgr.mr_n65176672)
print v(xbgr.mr_n65176784)
print v(xbgr.mr_n65177216)
print v(xbgr.mr_n65177536)
print v(xbgr.mr_n65177648)
print v(xbgr.mr_n65177968)
print v(xbgr.mr_n65178080)
print v(xbgr.mr_n65178400)
print v(xbgr.mr_n65178512)
print v(xbgr.mr_n65178832)
print v(xbgr.mr_n65178944)
print v(xbgr.mr_n65179264)
print v(xbgr.mr_n65179376)
print v(xbgr.mr_n65179696)
print v(xbgr.mr_n65179808)
print v(xbgr.mr_n65180128)
print v(xbgr.mr_n65180240)
print v(xbgr.mr_n65180672)
print v(xbgr.mr_n65180992)
print v(xbgr.mr_n65181856)
print v(xbgr.mr_n65181968)
print v(xbgr.mr_n65182288)
print v(xbgr.mr_n65182400)
print v(xbgr.mr_n65182720)
print v(xbgr.mr_n65182832)
print v(xbgr.mr_n65183152)
print v(xbgr.mr_n65183264)
print v(xbgr.mr_n65183584)
print v(xbgr.mr_n65183696)
print v(xbgr.mr_n65184128)
print v(xbgr.mr_n65184448)
print v(xbgr.mr_n65184560)
print v(xbgr.mr_n65184992)
print v(xbgr.mr_n65185312)
print v(xbgr.mr_n65186176)
print v(xbgr.mr_n65187040)
print v(xbgr.mr_n65187904)
print v(xbgr.mr_n65188768)
print v(xbgr.mr_n65188880)
print v(xbgr.mr_n65189200)
print v(xbgr.mr_n65189312)
print v(xbgr.mr_n65189632)
print v(xbgr.mr_n65189744)
print v(xbgr.mr_n65190064)
print v(xbgr.mr_n65190176)
print v(xbgr.mr_n65190496)
print v(xbgr.mr_n65190608)
print v(xbgr.mr_n65190928)
print v(xbgr.mr_n65191040)
print v(xbgr.mr_n65191360)
print v(xbgr.mr_n65192224)
print v(xbgr.mr_n65193088)
print v(xbgr.mr_n65193200)
print v(xbgr.mr_n65193520)
print v(xbgr.mr_n65193632)
print v(xbgr.mr_n65194064)
print v(xbgr.mr_n65194496)
print v(xbgr.mr_n65194816)
print v(xbgr.mr_n65194928)
print v(xbgr.mr_n65195248)
print v(xbgr.mr_n65195360)
print v(xbgr.mr_n65195680)
print v(xbgr.mr_n65195792)
print v(xbgr.mr_n65196112)
print v(xbgr.mr_n65196224)
print v(xbgr.mr_n65196544)
print v(xbgr.mr_n65197408)
print v(xbgr.mr_n65198272)
print v(xbgr.mr_n65199136)
print v(xbgr.mr_n65200000)
print v(xbgr.mr_n65200864)
print v(xbgr.mr_n65200976)
print v(xbgr.mr_n65201296)
print v(xbgr.mr_n65201408)
print v(xbgr.mr_n65201728)
print v(xbgr.mr_n65201840)
print v(xbgr.mr_n65202160)
print v(xbgr.mr_n65202272)
print v(xbgr.mr_n65202592)
print v(xbgr.mr_n65202704)
print v(xbgr.mr_n65203136)
print v(xbgr.mr_n65203456)
print v(xbgr.mr_n65203568)
print v(xbgr.mr_n65204000)
print v(xbgr.mr_n65204320)
print v(xbgr.mr_n65204432)
print v(xbgr.mr_n65204864)
print v(xbgr.mr_n65205184)
print v(xbgr.mr_n65205296)
print v(xbgr.mr_n65205728)
print v(xbgr.mr_n65206048)
print v(xbgr.mr_n65206912)
print v(xbgr.mr_n65207024)
print v(xbgr.mr_n65207344)
print v(xbgr.mr_n65207456)
print v(xbgr.mr_n65207776)
print v(xbgr.mr_n65207888)
print v(xbgr.mr_n65208208)
print v(xbgr.mr_n65208320)
print v(xbgr.mr_n65208640)
print v(xbgr.mr_n65209504)
print v(xbgr.mr_n65210368)
print v(xbgr.mr_n65211232)
print v(xbgr.mr_n65212096)
print v(xbgr.mr_n65212960)
print v(xbgr.mr_n65213072)
print v(xbgr.mr_n65213392)
print v(xbgr.mr_n65213504)
print v(xbgr.mr_n65213824)
print v(xbgr.mr_n65213936)
print v(xbgr.mr_n65214256)
print v(xbgr.mr_n65214368)
print v(xbgr.mr_n65214800)
print v(xbgr.mr_n65215232)
print v(xbgr.mr_n65215552)
print v(xbgr.mr_n65215664)
print v(xbgr.mr_n65215984)
print v(xbgr.mr_n65216096)
print v(xbgr.mr_n65216416)
print v(xbgr.mr_n65217280)
print v(xbgr.mr_n65217392)
print v(xbgr.mr_n65217712)
print v(xbgr.mr_n65217824)
print v(xbgr.mr_n65218144)
print v(xbgr.mr_n65219008)
print v(xbgr.mr_n65219872)
print v(xbgr.mr_n65219984)
print v(xbgr.mr_n65220304)
print v(xbgr.mr_n65220416)
print v(xbgr.mr_n65220736)
print v(xbgr.mr_n65221600)
print v(xbgr.mr_n65222464)
print v(xbgr.mr_n65223328)
print v(xbgr.mr_n65223440)
print v(xbgr.mr_n65223760)
print v(xbgr.mr_n65223872)
print v(xbgr.mr_n65224192)
print v(xbgr.mr_n65224304)
print v(xbgr.mr_n65224624)
print v(xbgr.mr_n65224736)
print v(xbgr.mr_n65225056)
print v(xbgr.mr_n65225168)
print v(xbgr.mr_n65225488)
print v(xbgr.mr_n65225600)
print v(xbgr.mr_n65225920)
print v(xbgr.mr_n65226032)
print v(xbgr.mr_n65226352)
print v(xbgr.mr_n65226464)
print v(xbgr.mr_n65226784)
print v(xbgr.mr_n65226896)
print v(xbgr.mr_n65227216)
print v(xbgr.mr_n65227328)
print v(xbgr.mr_n65227648)
print v(xbgr.mr_n65227760)
print v(xbgr.mr_n65228080)
print v(xbgr.mr_n65228192)
print v(xbgr.mr_n65228624)
print v(xbgr.mr_n65228944)
print v(xbgr.mr_n65229056)
print v(xbgr.mr_n65229488)
print v(xbgr.mr_n65229808)
print v(xbgr.mr_n65229920)
print v(xbgr.mr_n65230352)
print v(xbgr.mr_n65230672)
print v(xbgr.mr_n65231536)
print v(xbgr.mr_n65232400)
print v(xbgr.mr_n65233264)
print v(xbgr.mr_n65233376)
print v(xbgr.mr_n65233696)
print v(xbgr.mr_n65233808)
print v(xbgr.mr_n65234128)
print v(xbgr.mr_n65234992)
print v(xbgr.mr_n65235856)
print v(xbgr.mr_n65236720)
print v(xbgr.mr_n65236832)
print v(xbgr.mr_n65237152)
print v(xbgr.mr_n65237264)
print v(xbgr.mr_n65237584)
print v(xbgr.mr_n65237696)
print v(xbgr.mr_n65238016)
print v(xbgr.mr_n65238128)
print v(xbgr.mr_n65238448)
print v(xbgr.mr_n65238560)
print v(xbgr.mr_n65238880)
print v(xbgr.mr_n65238992)
print v(xbgr.mr_n65239312)
print v(xbgr.mr_n65239424)
print v(xbgr.mr_n65239744)
print v(xbgr.mr_n65239856)
print v(xbgr.mr_n65240176)
print v(xbgr.mr_n65240288)
print v(xbgr.mr_n65240608)
print v(xbgr.mr_n65240720)
print v(xbgr.mr_n65241040)
print v(xbgr.mr_n65241152)
print v(xbgr.mr_n65241472)
print v(xbgr.mr_n65241584)
print v(xbgr.mr_n65241904)
print v(xbgr.mr_n65242016)
print v(xbgr.mr_n65242448)
print v(xbgr.mr_n65242768)
print v(xbgr.mr_n65243632)
print v(xbgr.mr_n65244496)
print v(xbgr.mr_n65245360)
print v(xbgr.mr_n65245472)
print v(xbgr.mr_n65245904)
print v(xbgr.mr_n65246224)
print v(xbgr.mr_n65246336)
print v(xbgr.mr_n65246768)
print v(xbgr.mr_n65247088)
print v(xbgr.mr_n65247200)
print v(xbgr.mr_n65247520)
print v(xbgr.mr_n65247632)
print v(xbgr.mr_n65247952)
print v(xbgr.mr_n65248064)
print v(xbgr.mr_n65248496)
print v(xbgr.mr_n65248928)
print v(xbgr.mr_n65249360)
print v(xbgr.mr_n65249680)
print v(xbgr.mr_n65250544)
print v(xbgr.mr_n65251408)
print v(xbgr.mr_n65252272)
print v(xbgr.mr_n65253136)
print v(xbgr.mr_n65254000)
print v(xbgr.mr_n65254864)
print v(xbgr.mr_n65254976)
print v(xbgr.mr_n65255296)
print v(xbgr.mr_n65255408)
print v(xbgr.mr_n65255728)
print v(xbgr.mr_n65255840)
print v(xbgr.mr_n65256160)
print v(xbgr.mr_n65256272)
print v(xbgr.mr_n65256592)
print v(xbgr.mr_n65256704)
print v(xbgr.mr_n65257024)
print v(xbgr.mr_n65257136)
print v(xbgr.mr_n65257456)
print v(xbgr.mr_n65258320)
print v(xbgr.mr_n65259184)
print v(xbgr.mr_n65260160)
print v(xbgr.mr_n65260592)
print v(xbgr.mr_n65261024)
print v(xbgr.mr_n65261344)
print v(xbgr.mr_n65261456)
print v(xbgr.mr_n65261776)
print v(xbgr.mr_n65261888)
print v(xbgr.mr_n65262208)
print v(xbgr.mr_n65262320)
print v(xbgr.mr_n65262752)
print v(xbgr.mr_n65263072)
print v(xbgr.mr_n65263184)
print v(xbgr.mr_n65263504)
print v(xbgr.mr_n65263616)
print v(xbgr.mr_n65264048)
print v(xbgr.mr_n65264368)
print v(xbgr.mr_n65264480)
print v(xbgr.mr_n65264912)
print v(xbgr.mr_n65265232)
print v(xbgr.mr_n65265344)
print v(xbgr.mr_n65265776)
print v(xbgr.mr_n65266096)
print v(xbgr.mr_n65266960)
print v(xbgr.mr_n65267824)
print v(xbgr.mr_n65267936)
print v(xbgr.mr_n65268256)
print v(xbgr.mr_n65268368)
print v(xbgr.mr_n65268688)
print v(xbgr.mr_n65268800)
print v(xbgr.mr_n65269120)
print v(xbgr.mr_n65269232)
print v(xbgr.mr_n65269664)
print v(xbgr.mr_n65269984)
print v(xbgr.mr_n65270848)
print v(xbgr.mr_n65270960)
print v(xbgr.mr_n65271280)
print v(xbgr.mr_n65271392)
print v(xbgr.mr_n65271712)
print v(xbgr.mr_n65271824)
print v(xbgr.mr_n65272144)
print v(xbgr.mr_n65273008)
print v(xbgr.mr_n65273440)
print v(xbgr.mr_n65274304)
print v(xbgr.mr_n65274416)
print v(xbgr.mr_n65274736)
print v(xbgr.mr_n65274848)
print v(xbgr.mr_n65275168)
print v(xbgr.mr_n65275280)
print v(xbgr.mr_n65275600)
print v(xbgr.mr_n65275712)
print v(xbgr.mr_n65276032)
print v(xbgr.mr_n65276144)
print v(xbgr.mr_n65276576)
print v(xbgr.mr_n65277328)
print v(xbgr.mr_n65278192)
print v(xbgr.mr_n65278624)
print v(xbgr.mr_n65278736)
print v(xbgr.mr_n65279056)
print v(xbgr.mr_n65279488)
print v(xbgr.mr_n65280352)
print v(xbgr.mr_n65281216)
print v(xbgr.mr_n65282080)
print v(xbgr.mr_n65282944)
print v(xbgr.mr_n65284240)
print v(xbgr.mr_n65285104)
print v(xbgr.mr_n65286080)
print v(xbgr.mr_n65286400)
print v(xbgr.mr_n65286512)
print v(xbgr.mr_n65286944)
print v(xbgr.mr_n65287264)
print v(xbgr.mr_n65288128)
print v(xbgr.mr_n65288240)
print v(xbgr.mr_n65288560)
print v(xbgr.mr_n65288672)
print v(xbgr.mr_n65289104)
print v(xbgr.mr_n65289424)
print v(xbgr.mr_n65289536)
print v(xbgr.mr_n65289856)
print v(xbgr.mr_n65289968)
print v(xbgr.mr_n65290288)
print v(xbgr.mr_n65290400)
print v(xbgr.mr_n65290720)
print v(xbgr.mr_n65290832)
print v(xbgr.mr_n65291264)
print v(xbgr.mr_n65291584)
print v(xbgr.mr_n65291696)
print v(xbgr.mr_n65292016)
print v(xbgr.mr_n65292128)
print v(xbgr.mr_n65292448)
print v(xbgr.mr_n65293312)
print v(xbgr.mr_n65293424)
print v(xbgr.mr_n65294176)
print v(xbgr.mr_n65294288)
print v(xbgr.mr_n65294608)
print v(xbgr.mr_n65294720)
print v(xbgr.mr_n65295040)
print v(xbgr.mr_n65295152)
print v(xbgr.mr_n65295472)
print v(xbgr.mr_n65295584)
print v(xbgr.mr_n65295904)
print v(xbgr.mr_n65296016)
print v(xbgr.mr_n65296336)
print v(xbgr.mr_n65296448)
print v(xbgr.mr_n65296768)
print v(xbgr.mr_n65296880)
print v(xbgr.mr_n65297200)
print v(xbgr.mr_n65297312)
print v(xbgr.mr_n65297632)
print v(xbgr.mr_n65297744)
print v(xbgr.mr_n65298064)
print v(xbgr.mr_n65298176)
print v(xbgr.mr_n65298496)
print v(xbgr.mr_n65298608)
print v(xbgr.mr_n65298928)
print v(xbgr.mr_n65299040)
print v(xbgr.mr_n65299360)
print v(xbgr.mr_n65299472)
print v(xbgr.mr_n65299904)
print v(xbgr.mr_n65300224)
print v(xbgr.mr_n65300336)
print v(xbgr.mr_n65300768)
print v(xbgr.mr_n65301088)
print v(xbgr.mr_n65301200)
print v(xbgr.mr_n65301632)
print v(xbgr.mr_n65301952)
print v(xbgr.mr_n65302816)
print v(xbgr.mr_n65303680)
print v(xbgr.mr_n65304544)
print v(xbgr.mr_n65305408)
print v(xbgr.mr_n65306272)
print v(xbgr.mr_n65307136)
print v(xbgr.mr_n65307248)
print v(xbgr.mr_n65307568)
print v(xbgr.mr_n65307680)
print v(xbgr.mr_n65308000)
print v(xbgr.mr_n65308112)
print v(xbgr.mr_n65308432)
print v(xbgr.mr_n65308544)
print v(xbgr.mr_n65308864)
print v(xbgr.mr_n65309728)
print v(xbgr.mr_n65310592)
print v(xbgr.mr_n65311456)
print v(xbgr.mr_n65311568)
print v(xbgr.mr_n65311888)
print v(xbgr.mr_n65312000)
print v(xbgr.mr_n65312320)
print v(xbgr.mr_n65312432)
print v(xbgr.mr_n65312864)
print v(xbgr.mr_n65313296)
print v(xbgr.mr_n65313728)
print v(xbgr.mr_n65314048)
print v(xbgr.mr_n65314160)
print v(xbgr.mr_n65314480)
print v(xbgr.mr_n65314592)
print v(xbgr.mr_n65314912)
print v(xbgr.mr_n65315024)
print v(xbgr.mr_n65315344)
print v(xbgr.mr_n65315456)
print v(xbgr.mr_n65315776)
print v(xbgr.mr_n65315888)
print v(xbgr.mr_n65316208)
print v(xbgr.mr_n65316320)
print v(xbgr.mr_n65316640)
print v(xbgr.mr_n65316752)
print v(xbgr.mr_n65317184)
print v(xbgr.mr_n65317504)
print v(xbgr.mr_n65317616)
print v(xbgr.mr_n65318048)
print v(xbgr.mr_n65318368)
print v(xbgr.mr_n65318480)
print v(xbgr.mr_n65318912)
print v(xbgr.mr_n65319232)
print v(xbgr.mr_n65320096)
print v(xbgr.mr_n65320960)
print v(xbgr.mr_n65321824)
print v(xbgr.mr_n65322688)
print v(xbgr.mr_n65323552)
print v(xbgr.mr_n65324416)
print v(xbgr.mr_n65324528)
print v(xbgr.mr_n65324848)
print v(xbgr.mr_n65324960)
print v(xbgr.mr_n65325280)
print v(xbgr.mr_n65325392)
print v(xbgr.mr_n65325712)
print v(xbgr.mr_n65325824)
print v(xbgr.mr_n65326144)
print v(xbgr.mr_n65327008)
print v(xbgr.mr_n65327872)
print v(xbgr.mr_n65328736)
print v(xbgr.mr_n65328848)
print v(xbgr.mr_n65329168)
print v(xbgr.mr_n65329280)
print v(xbgr.mr_n65329600)
print v(xbgr.mr_n65329712)
print v(xbgr.mr_n65330144)
print v(xbgr.mr_n65330464)
print v(xbgr.mr_n65330576)
print v(xbgr.mr_n65331008)
print v(xbgr.mr_n65331328)
print v(xbgr.mr_n65331440)
print v(xbgr.mr_n65331872)
print v(xbgr.mr_n65332192)
print v(xbgr.mr_n65332304)
print v(xbgr.mr_n65332624)
print v(xbgr.mr_n65332736)
print v(xbgr.mr_n65333056)
print v(xbgr.mr_n65333168)
print v(xbgr.mr_n65333600)
print v(xbgr.mr_n65333920)
print v(xbgr.mr_n65334784)
print v(xbgr.mr_n65335648)
print v(xbgr.mr_n65336512)
print v(xbgr.mr_n65336624)
print v(xbgr.mr_n65336944)
print v(xbgr.mr_n65337056)
print v(xbgr.mr_n65337376)
print v(xbgr.mr_n65338240)
print v(xbgr.mr_n65339104)
print v(xbgr.mr_n65339968)
print v(xbgr.mr_n65340832)
print v(xbgr.mr_n65340944)
print v(xbgr.mr_n65341264)
print v(xbgr.mr_n65341376)
print v(xbgr.mr_n65341696)
print v(xbgr.mr_n65342560)
print v(xbgr.mr_n65343104)
print v(xbgr.mr_n65343424)
print v(xbgr.mr_n65343536)
print v(xbgr.mr_n65343856)
print v(xbgr.mr_n65343968)
print v(xbgr.mr_n65344288)
print v(xbgr.mr_n65344400)
print v(xbgr.mr_n65344720)
print v(xbgr.mr_n65344832)
print v(xbgr.mr_n65345264)
print v(xbgr.mr_n65346016)
print v(xbgr.mr_n65346880)
print v(xbgr.mr_n65347744)
print v(xbgr.mr_n65348608)
print v(xbgr.mr_n65348720)
print v(xbgr.mr_n65349040)
print v(xbgr.mr_n65349152)
print v(xbgr.mr_n65349472)
print v(xbgr.mr_n65349584)
print v(xbgr.mr_n65349904)
print v(xbgr.mr_n65350016)
print v(xbgr.mr_n65350336)
print v(xbgr.mr_n65350448)
print v(xbgr.mr_n65350768)
print v(xbgr.mr_n65350880)
print v(xbgr.mr_n65351200)
print v(xbgr.mr_n65351312)
print v(xbgr.mr_n65351744)
print v(xbgr.mr_n65352064)
print v(xbgr.mr_n65352176)
print v(xbgr.mr_n65352496)
print v(xbgr.mr_n65352608)
print v(xbgr.mr_n65352928)
print v(xbgr.mr_n65353040)
print v(xbgr.mr_n65353360)
print v(xbgr.mr_n65353472)
print v(xbgr.mr_n65353792)
print v(xbgr.mr_n65353904)
print v(xbgr.mr_n65354336)
print v(xbgr.mr_n65354656)
print v(xbgr.mr_n65355520)
print v(xbgr.mr_n65355632)
print v(xbgr.mr_n65355952)
print v(xbgr.mr_n65356064)
print v(xbgr.mr_n65356496)
print v(xbgr.mr_n65356928)
print v(xbgr.mr_n65357248)
print v(xbgr.mr_n65357360)
print v(xbgr.mr_n65357680)
print v(xbgr.mr_n65357792)
print v(xbgr.mr_n65358112)
print v(xbgr.mr_n65358224)
print v(xbgr.mr_n65358544)
print v(xbgr.mr_n65358656)
print v(xbgr.mr_n65358976)
print v(xbgr.mr_n65359088)
print v(xbgr.mr_n65359520)
print v(xbgr.mr_n65359840)
print v(xbgr.mr_n65359952)
print v(xbgr.mr_n65360384)
print v(xbgr.mr_n65360704)
print v(xbgr.mr_n65361568)
print v(xbgr.mr_n65362432)
print v(xbgr.mr_n65363296)
print v(xbgr.mr_n65364160)
print v(xbgr.mr_n65364272)
print v(xbgr.mr_n65364592)
print v(xbgr.mr_n65364704)
print v(xbgr.mr_n65365024)
print v(xbgr.mr_n65365136)
print v(xbgr.mr_n65365456)
print v(xbgr.mr_n65365568)
print v(xbgr.mr_n65365888)
print v(xbgr.mr_n65366752)
print v(xbgr.mr_n65367616)
print v(xbgr.mr_n65367728)
print v(xbgr.mr_n65368048)
print v(xbgr.mr_n65368160)
print v(xbgr.mr_n65368592)
print v(xbgr.mr_n65369024)
print v(xbgr.mr_n65369344)
print v(xbgr.mr_n65369456)
print v(xbgr.mr_n65369776)
print v(xbgr.mr_n65369888)
print v(xbgr.mr_n65370208)
print v(xbgr.mr_n65370320)
print v(xbgr.mr_n65370640)
print v(xbgr.mr_n65370752)
print v(xbgr.mr_n65371072)
print v(xbgr.mr_n65371936)
print v(xbgr.mr_n65372800)
print v(xbgr.mr_n65373664)
print v(xbgr.mr_n65374528)
print v(xbgr.mr_n65375392)
print v(xbgr.mr_n65375504)
print v(xbgr.mr_n65375936)
print v(xbgr.mr_n65376256)
print v(xbgr.mr_n65376368)
print v(xbgr.mr_n65376800)
print v(xbgr.mr_n65377120)
print v(xbgr.mr_n65377232)
print v(xbgr.mr_n65377664)
print v(xbgr.mr_n65377984)
print v(xbgr.mr_n65378096)
print v(xbgr.mr_n65378416)
print v(xbgr.mr_n65378528)
print v(xbgr.mr_n65378848)
print v(xbgr.mr_n65378960)
print v(xbgr.mr_n65379280)
print v(xbgr.mr_n65379392)
print v(xbgr.mr_n65379712)
print v(xbgr.mr_n65379824)
print v(xbgr.mr_n65380144)
print v(xbgr.mr_n65380256)
print v(xbgr.mr_n65380576)
print v(xbgr.mr_n65380688)
print v(xbgr.mr_n65381008)
print v(xbgr.mr_n65381120)
print v(xbgr.mr_n65381440)
print v(xbgr.mr_n65381552)
print v(xbgr.mr_n65381872)
print v(xbgr.mr_n65381984)
print v(xbgr.mr_n65382304)
print v(xbgr.mr_n65382416)
print v(xbgr.mr_n65382736)
print v(xbgr.mr_n65382848)
print v(xbgr.mr_n65383168)
print v(xbgr.mr_n65384032)
print v(xbgr.mr_n65384896)
print v(xbgr.mr_n65385760)
print v(xbgr.mr_n65385872)
print v(xbgr.mr_n65386304)
print v(xbgr.mr_n65386624)
print v(xbgr.mr_n65386736)
print v(xbgr.mr_n65387056)
print v(xbgr.mr_n65387168)
print v(xbgr.mr_n65387488)
print v(xbgr.mr_n65387600)
print v(xbgr.mr_n65387920)
print v(xbgr.mr_n65388032)
print v(xbgr.mr_n65388464)
print v(xbgr.mr_n65388896)
print v(xbgr.mr_n65389328)
print v(xbgr.mr_n65389760)
print v(xbgr.mr_n65390080)
print v(xbgr.mr_n65390192)
print v(xbgr.mr_n65390624)
print v(xbgr.mr_n65390944)
print v(xbgr.mr_n65391808)
print v(xbgr.mr_n65391920)
print v(xbgr.mr_n65392240)
print v(xbgr.mr_n65392352)
print v(xbgr.mr_n65392672)
print v(xbgr.mr_n65392784)
print v(xbgr.mr_n65393104)
print v(xbgr.mr_n65394080)
print v(xbgr.mr_n65394512)
print v(xbgr.mr_n65394944)
print v(xbgr.mr_n65395264)
print v(xbgr.mr_n65396128)
print v(xbgr.mr_n65396240)
print v(xbgr.mr_n65396560)
print v(xbgr.mr_n65396672)
print v(xbgr.mr_n65396992)
print v(xbgr.mr_n65397104)
print v(xbgr.mr_n65397424)
print v(xbgr.mr_n65397536)
print v(xbgr.mr_n65397856)
print v(xbgr.mr_n65397968)
print v(xbgr.mr_n65398288)
print v(xbgr.mr_n65398400)
print v(xbgr.mr_n65398720)
print v(xbgr.mr_n65398832)
print v(xbgr.mr_n65399152)
print v(xbgr.mr_n65399264)
print v(xbgr.mr_n65399584)
print v(xbgr.mr_n65400448)
print v(xbgr.mr_n65401312)
print v(xbgr.mr_n65402176)
print v(xbgr.mr_n65403040)
print v(xbgr.mr_n65403904)
print v(xbgr.mr_n65404768)
print v(xbgr.mr_n65405632)
print v(xbgr.mr_n65406496)
print v(xbgr.mr_n65407360)
print v(xbgr.mr_n65408224)
print v(xbgr.mr_n65409088)
print v(xbgr.mr_n65409952)
print v(xbgr.mr_n65410064)
print v(xbgr.mr_n65410384)
print v(xbgr.mr_n65410496)
print v(xbgr.mr_n65410816)
print v(xbgr.mr_n65410928)
print v(xbgr.mr_n65411248)
print v(xbgr.mr_n65411360)
print v(xbgr.mr_n65411680)
print v(xbgr.mr_n65411792)
print v(xbgr.mr_n65412224)
print v(xbgr.mr_n65412544)
print v(xbgr.mr_n65412656)
print v(xbgr.mr_n65413088)
print v(xbgr.mr_n65413408)
print v(xbgr.mr_n65414272)
print v(xbgr.mr_n65415136)
print v(xbgr.mr_n65416000)
print v(xbgr.mr_n65416864)
print v(xbgr.mr_n65416976)
print v(xbgr.mr_n65417296)
print v(xbgr.mr_n65417408)
print v(xbgr.mr_n65417728)
print v(xbgr.mr_n65417840)
print v(xbgr.mr_n65418160)
print v(xbgr.mr_n65418272)
print v(xbgr.mr_n65418592)
print v(xbgr.mr_n65418704)
print v(xbgr.mr_n65419024)
print v(xbgr.mr_n65419136)
print v(xbgr.mr_n65419456)
print v(xbgr.mr_n65419568)
print v(xbgr.mr_n65419888)
print v(xbgr.mr_n65420752)
print v(xbgr.mr_n65421616)
print v(xbgr.mr_n65421728)
print v(xbgr.mr_n65422048)
print v(xbgr.mr_n65422160)
print v(xbgr.mr_n65422592)
print v(xbgr.mr_n65423024)
print v(xbgr.mr_n65423344)
print v(xbgr.mr_n65423456)
print v(xbgr.mr_n65423776)
print v(xbgr.mr_n65423888)
print v(xbgr.mr_n65424208)
print v(xbgr.mr_n65424320)
print v(xbgr.mr_n65424640)
print v(xbgr.mr_n65424752)
print v(xbgr.mr_n65425072)
print v(xbgr.mr_n65425184)
print v(xbgr.mr_n65425616)
print v(xbgr.mr_n65425936)
print v(xbgr.mr_n65426048)
print v(xbgr.mr_n65426480)
print v(xbgr.mr_n65426800)
print v(xbgr.mr_n65426912)
print v(xbgr.mr_n65427232)
print v(xbgr.mr_n65428096)
print v(xbgr.mr_n65428960)
print v(xbgr.mr_n65429824)
print v(xbgr.mr_n65430688)
print v(xbgr.mr_n65430800)
print v(xbgr.mr_n65431120)
print v(xbgr.mr_n65431232)
print v(xbgr.mr_n65431552)
print v(xbgr.mr_n65431664)
print v(xbgr.mr_n65431984)
print v(xbgr.mr_n65432096)
print v(xbgr.mr_n65432416)
print v(xbgr.mr_n65432528)
print v(xbgr.mr_n65432848)
print v(xbgr.mr_n65432960)
print v(xbgr.mr_n65433280)
print v(xbgr.mr_n65434144)
print v(xbgr.mr_n65435008)
print v(xbgr.mr_n65435120)
print v(xbgr.mr_n65435552)
print v(xbgr.mr_n65435872)
print v(xbgr.mr_n65435984)
print v(xbgr.mr_n65436304)
print v(xbgr.mr_n65436416)
print v(xbgr.mr_n65436736)
print v(xbgr.mr_n65436848)
print v(xbgr.mr_n65437168)
print v(xbgr.mr_n65437280)
print v(xbgr.mr_n65437600)
print v(xbgr.mr_n65437712)
print v(xbgr.mr_n65438032)
print v(xbgr.mr_n65438144)
print v(xbgr.mr_n65438576)
print v(xbgr.mr_n65439008)
print v(xbgr.mr_n65439440)
print v(xbgr.mr_n65439872)
print v(xbgr.mr_n65440192)
print v(xbgr.mr_n65440624)
print v(xbgr.mr_n65440736)
print v(xbgr.mr_n65441056)
print v(xbgr.mr_n65441168)
print v(xbgr.mr_n65441488)
print v(xbgr.mr_n65441600)
print v(xbgr.mr_n65441920)
print v(xbgr.mr_n65442032)
print v(xbgr.mr_n65442352)
print v(xbgr.mr_n65442464)
print v(xbgr.mr_n65442784)
print v(xbgr.mr_n65442896)
print v(xbgr.mr_n65443648)
print v(xbgr.mr_n65443760)
print v(xbgr.mr_n65444192)
print v(xbgr.mr_n65444512)
print v(xbgr.mr_n65444944)
print v(xbgr.mr_n65445056)
print v(xbgr.mr_n65445488)
print v(xbgr.mr_n65445808)
print v(xbgr.mr_n65445920)
print v(xbgr.mr_n65446352)
print v(xbgr.mr_n65446672)
print v(xbgr.mr_n65446784)
print v(xbgr.mr_n65447216)
print v(xbgr.mr_n65447968)
print v(xbgr.mr_n65448832)
print v(xbgr.mr_n65449696)
print v(xbgr.mr_n65450560)
print v(xbgr.mr_n65451424)
print v(xbgr.mr_n65452288)
print v(xbgr.mr_n65452400)
print v(xbgr.mr_n65452720)
print v(xbgr.mr_n65452832)
print v(xbgr.mr_n65453152)
print v(xbgr.mr_n65453264)
print v(xbgr.mr_n65453584)
print v(xbgr.mr_n65453696)
print v(xbgr.mr_n65454016)
print v(xbgr.mr_n65454880)
print v(xbgr.mr_n65455744)
print v(xbgr.mr_n65456608)
print v(xbgr.mr_n65456720)
print v(xbgr.mr_n65457040)
print v(xbgr.mr_n65457152)
print v(xbgr.mr_n65457472)
print v(xbgr.mr_n65457584)
print v(xbgr.mr_n65457904)
print v(xbgr.mr_n65458016)
print v(xbgr.mr_n65458336)
print v(xbgr.mr_n65458448)
print v(xbgr.mr_n65458768)
print v(xbgr.mr_n65458880)
print v(xbgr.mr_n65459200)
print v(xbgr.mr_n65459312)
print v(xbgr.mr_n65459632)
print v(xbgr.mr_n65459744)
print v(xbgr.mr_n65460064)
print v(xbgr.mr_n65460928)
print v(xbgr.mr_n65461360)
print v(xbgr.mr_n65462224)
print v(xbgr.mr_n65462656)
print v(xbgr.mr_n65463520)
print v(xbgr.mr_n65464384)
print v(xbgr.mr_n65465680)
print v(xbgr.mr_n65466976)
print v(xbgr.mr_n65467088)
print v(xbgr.mr_n65467408)
print v(xbgr.mr_n65467520)
print v(xbgr.mr_n65467952)
print v(xbgr.mr_n65468272)
print v(xbgr.mr_n65468384)
print v(xbgr.mr_n65468816)
print v(xbgr.mr_n65469136)
print v(xbgr.mr_n65469248)
print v(xbgr.mr_n65469568)
print v(xbgr.mr_n65469680)
print v(xbgr.mr_n65470000)
print v(xbgr.mr_n65470112)
print v(xbgr.mr_n65470544)
print v(xbgr.mr_n65470864)
print v(xbgr.mr_n65470976)
print v(xbgr.mr_n65471408)
print v(xbgr.mr_n65471728)
print v(xbgr.mr_n65471840)
print v(xbgr.mr_n65472272)
print v(xbgr.mr_n65472592)
print v(xbgr.mr_n65472704)
print v(xbgr.mr_n65473024)
print v(xbgr.mr_n65473456)
print v(xbgr.mr_n65473568)
print v(xbgr.mr_n65473888)
print v(xbgr.mr_n65474000)
print v(xbgr.mr_n65474320)
print v(xbgr.mr_n65474432)
print v(xbgr.mr_n65474752)
print v(xbgr.mr_n65474864)
print v(xbgr.mr_n65475616)
print v(xbgr.mr_n65476480)
print v(xbgr.mr_n65477344)
print v(xbgr.mr_n65477456)
print v(xbgr.mr_n65477776)
print v(xbgr.mr_n65477888)
print v(xbgr.mr_n65478208)
print v(xbgr.mr_n65478320)
print v(xbgr.mr_n65478640)
print v(xbgr.mr_n65478752)
print v(xbgr.mr_n65479504)
print v(xbgr.mr_n65479936)
print v(xbgr.mr_n65480800)
print v(xbgr.mr_n65482096)
print v(xbgr.mr_n65482528)
print v(xbgr.mr_n65483392)
print v(xbgr.mr_n65483504)
print v(xbgr.mr_n65483824)
print v(xbgr.mr_n65483936)
print v(xbgr.mr_n65484256)
print v(xbgr.mr_n65485120)
print v(xbgr.mr_n65485552)
print v(xbgr.mr_n65485664)
print v(xbgr.mr_n65485984)
print v(xbgr.mr_n65486848)
print v(xbgr.mr_n65487712)
print v(xbgr.mr_n65488576)
print v(xbgr.mr_n65489440)
print v(xbgr.mr_n65489552)
print v(xbgr.mr_n65489872)
print v(xbgr.mr_n65489984)
print v(xbgr.mr_n65490304)
print v(xbgr.mr_n65490416)
print v(xbgr.mr_n65490736)
print v(xbgr.mr_n65490848)
print v(xbgr.mr_n65491600)
print v(xbgr.mr_n65492464)
print v(xbgr.mr_n65493328)
print v(xbgr.mr_n65493440)
print v(xbgr.mr_n65493872)
print v(xbgr.mr_n65494304)
print v(xbgr.mr_n65494736)
print v(xbgr.mr_n65495056)
print v(xbgr.mr_n65495168)
print v(xbgr.mr_n65495488)
print v(xbgr.mr_n65495600)
print v(xbgr.mr_n65495920)
print v(xbgr.mr_n65496032)
print v(xbgr.mr_n65496352)
print v(xbgr.mr_n65496464)
print v(xbgr.mr_n65496784)
print v(xbgr.mr_n65496896)
print v(xbgr.mr_n65497216)
print v(xbgr.mr_n65497328)
print v(xbgr.mr_n65497648)
print v(xbgr.mr_n65497760)
print v(xbgr.mr_n65498080)
print v(xbgr.mr_n65498192)
print v(xbgr.mr_n65499376)
print v(xbgr.mr_n65499920)
print v(xbgr.mr_n65500352)
print v(xbgr.mr_n65500784)
print v(xbgr.mr_n65501536)
print v(xbgr.mr_n65501648)
print v(xbgr.mr_n65501968)
print v(xbgr.mr_n65502080)
print v(xbgr.mr_n65502400)
print v(xbgr.mr_n65502512)
print v(xbgr.mr_n65502832)
print v(xbgr.mr_n65502944)
print v(xbgr.mr_n65503264)
print v(xbgr.mr_n65503376)
print v(xbgr.mr_n65503696)
print v(xbgr.mr_n65503808)
print v(xbgr.mr_n65504240)
print v(xbgr.mr_n65504560)
print v(xbgr.mr_n65504672)
print v(xbgr.mr_n65504992)
print v(xbgr.mr_n65505104)
print v(xbgr.mr_n65505536)
print v(xbgr.mr_n65505856)
print v(xbgr.mr_n65505968)
print v(xbgr.mr_n65506288)
print v(xbgr.mr_n65506400)
print v(xbgr.mr_n65506720)
print v(xbgr.mr_n65506832)
print v(xbgr.mr_n65507152)
print v(xbgr.mr_n65507264)
print v(xbgr.mr_n65507584)
print v(xbgr.mr_n65507696)
print v(xbgr.mr_n65508016)
print v(xbgr.mr_n65508128)
print v(xbgr.mr_n65508448)
print v(xbgr.mr_n65509312)
print v(xbgr.mr_n65509856)
print v(xbgr.mr_n65510176)
print v(xbgr.mr_n65510288)
print v(xbgr.mr_n65510720)
print v(xbgr.mr_n65511040)
print v(xbgr.mr_n65511152)
print v(xbgr.mr_n65511904)
print v(xbgr.mr_n65512768)
print v(xbgr.mr_n65512880)
print v(xbgr.mr_n65513200)
print v(xbgr.mr_n65513312)
print v(xbgr.mr_n65513632)
print v(xbgr.mr_n65513744)
print v(xbgr.mr_n65514064)
print v(xbgr.mr_n65514496)
print v(xbgr.mr_n65515360)
print v(xbgr.mr_n65516656)
print v(xbgr.mr_n65517632)
print v(xbgr.mr_n65517952)
print v(xbgr.mr_n65518064)
print v(xbgr.mr_n65518384)
print v(xbgr.mr_n65518496)
print v(xbgr.mr_n65518816)
print v(xbgr.mr_n65519680)
print v(xbgr.mr_n65519792)
print v(xbgr.mr_n65520112)
print v(xbgr.mr_n65520224)
print v(xbgr.mr_n65520544)
print v(xbgr.mr_n65520656)
print v(xbgr.mr_n65520976)
print v(xbgr.mr_n65521088)
print v(xbgr.mr_n65521408)
print v(xbgr.mr_n65521520)
print v(xbgr.mr_n65521840)
print v(xbgr.mr_n65522384)
print v(xbgr.mr_n65522704)
print v(xbgr.mr_n65524000)
print v(xbgr.mr_n65524864)
print v(xbgr.mr_n65525408)
print v(xbgr.mr_n65525840)
print v(xbgr.mr_n65526592)
print v(xbgr.mr_n65526704)
print v(xbgr.mr_n65527024)
print v(xbgr.mr_n65527136)
print v(xbgr.mr_n65527456)
print v(xbgr.mr_n65527568)
print v(xbgr.mr_n65527888)
print v(xbgr.mr_n65528000)
print v(xbgr.mr_n65528320)
print v(xbgr.mr_n65528432)
print v(xbgr.mr_n65528752)
print v(xbgr.mr_n65528864)
print v(xbgr.mr_n65529296)
print v(xbgr.mr_n65529616)
print v(xbgr.mr_n65529728)
print v(xbgr.mr_n65530048)
print v(xbgr.mr_n65530160)
print v(xbgr.mr_n65530480)
print v(xbgr.mr_n65530592)
print v(xbgr.mr_n65530912)
print v(xbgr.mr_n65531024)
print v(xbgr.mr_n65531344)
print v(xbgr.mr_n65531456)
print v(xbgr.mr_n65531776)
print v(xbgr.mr_n65531888)
print v(xbgr.mr_n65532208)
print v(xbgr.mr_n65532320)
print v(xbgr.mr_n65532640)
print v(xbgr.mr_n65532752)
print v(xbgr.mr_n65533184)
print v(xbgr.mr_n65533616)
print v(xbgr.mr_n65534048)
print v(xbgr.mr_n65534368)
print v(xbgr.mr_n65534480)
print v(xbgr.mr_n65534800)
print v(xbgr.mr_n65534912)
print v(xbgr.mr_n65535232)
print v(xbgr.mr_n65535344)
print v(xbgr.mr_n65535664)
print v(xbgr.mr_n65535776)
print v(xbgr.mr_n65536096)
print v(xbgr.mr_n65536208)
print v(xbgr.mr_n65536640)
print v(xbgr.mr_n65536960)
print v(xbgr.mr_n65537824)
print v(xbgr.mr_n65538688)
print v(xbgr.mr_n65538800)
print v(xbgr.mr_n65539120)
print v(xbgr.mr_n65539232)
print v(xbgr.mr_n65539552)
print v(xbgr.mr_n65539664)
print v(xbgr.mr_n65539984)
print v(xbgr.mr_n65540096)
print v(xbgr.mr_n65540416)
print v(xbgr.mr_n65541392)
print v(xbgr.mr_n65541712)
print v(xbgr.mr_n65541824)
print v(xbgr.mr_n65542144)
print v(xbgr.mr_n65542256)
print v(xbgr.mr_n65542576)
print v(xbgr.mr_n65542688)
print v(xbgr.mr_n65543008)
print v(xbgr.mr_n65543120)
print v(xbgr.mr_n65543440)
print v(xbgr.mr_n65543552)
print v(xbgr.mr_n65543872)
print v(xbgr.mr_n65544736)
print v(xbgr.mr_n65545600)
print v(xbgr.mr_n65546464)
print v(xbgr.mr_n65547328)
print v(xbgr.mr_n65547440)
print v(xbgr.mr_n65547760)
print v(xbgr.mr_n65547872)
print v(xbgr.mr_n65548192)
print v(xbgr.mr_n65549168)
print v(xbgr.mr_n65549600)
print v(xbgr.mr_n65549920)
print v(xbgr.mr_n65550784)
print v(xbgr.mr_n65551648)
print v(xbgr.mr_n65552512)
print v(xbgr.mr_n65553376)
print v(xbgr.mr_n65553488)
print v(xbgr.mr_n65553920)
print v(xbgr.mr_n65554240)
print v(xbgr.mr_n65554352)
print v(xbgr.mr_n65554672)
print v(xbgr.mr_n65554784)
print v(xbgr.mr_n65555104)
print v(xbgr.mr_n65555216)
print v(xbgr.mr_n65555648)
print v(xbgr.mr_n65555968)
print v(xbgr.mr_n65556080)
print v(xbgr.mr_n65556512)
print v(xbgr.mr_n65556832)
print v(xbgr.mr_n65556944)
print v(xbgr.mr_n65557264)
print v(xbgr.mr_n65557376)
print v(xbgr.mr_n65557696)
print v(xbgr.mr_n65557808)
print v(xbgr.mr_n65558128)
print v(xbgr.mr_n65558240)
print v(xbgr.mr_n65558560)
print v(xbgr.mr_n65558672)
print v(xbgr.mr_n65558992)
print v(xbgr.mr_n65559104)
print v(xbgr.mr_n65559536)
print v(xbgr.mr_n65559856)
print v(xbgr.mr_n65560720)
print v(xbgr.mr_n65561264)
print v(xbgr.mr_n65561584)
print v(xbgr.mr_n65561696)
print v(xbgr.mr_n65562016)
print v(xbgr.mr_n65562128)
print v(xbgr.mr_n65562448)
print v(xbgr.mr_n65562560)
print v(xbgr.mr_n65562880)
print v(xbgr.mr_n65562992)
print v(xbgr.mr_n65563312)
print v(xbgr.mr_n65563424)
print v(xbgr.mr_n65563744)
print v(xbgr.mr_n65563856)
print v(xbgr.mr_n65564288)
print v(xbgr.mr_n65564608)
print v(xbgr.mr_n65565472)
print v(xbgr.mr_n65565904)
print v(xbgr.mr_n65566768)
print v(xbgr.mr_n65567632)
print v(xbgr.mr_n65569040)
print v(xbgr.mr_n65569904)
print v(xbgr.mr_n65570336)
print v(xbgr.mr_n65570656)
print v(xbgr.mr_n65571520)
print v(xbgr.mr_n65571632)
print v(xbgr.mr_n65571952)
print v(xbgr.mr_n65572064)
print v(xbgr.mr_n65572384)
print v(xbgr.mr_n65572496)
print v(xbgr.mr_n65572816)
print v(xbgr.mr_n65572928)
print v(xbgr.mr_n65573248)
print v(xbgr.mr_n65573360)
print v(xbgr.mr_n65573680)
print v(xbgr.mr_n65573792)
print v(xbgr.mr_n65574112)
print v(xbgr.mr_n65574224)
print v(xbgr.mr_n65574544)
print v(xbgr.mr_n65575408)
print v(xbgr.mr_n65576384)
print v(xbgr.mr_n65576816)
print v(xbgr.mr_n65577248)
print v(xbgr.mr_n65577568)
print v(xbgr.mr_n65577680)
print v(xbgr.mr_n65578000)
print v(xbgr.mr_n65578112)
print v(xbgr.mr_n65578432)
print v(xbgr.mr_n65579296)
print v(xbgr.mr_n65580160)
print v(xbgr.mr_n65581024)
print v(xbgr.mr_n65581136)
print v(xbgr.mr_n65581456)
print v(xbgr.mr_n65581568)
print v(xbgr.mr_n65581888)
print v(xbgr.mr_n65582752)
print v(xbgr.mr_n65583616)
print v(xbgr.mr_n65584480)
print v(xbgr.mr_n65584592)
print v(xbgr.mr_n65584912)
print v(xbgr.mr_n65585024)
print v(xbgr.mr_n65585344)
print v(xbgr.mr_n65585456)
print v(xbgr.mr_n65585776)
print v(xbgr.mr_n65585888)
print v(xbgr.mr_n65586208)
print v(xbgr.mr_n65587072)
print v(xbgr.mr_n65587936)
print v(xbgr.mr_n65588048)
print v(xbgr.mr_n65588368)
print v(xbgr.mr_n65588480)
print v(xbgr.mr_n65588800)
print v(xbgr.mr_n65588912)
print v(xbgr.mr_n65589232)
print v(xbgr.mr_n65589344)
print v(xbgr.mr_n65589664)
print v(xbgr.mr_n65589776)
print v(xbgr.mr_n65590208)
print v(xbgr.mr_n65590528)
print v(xbgr.mr_n65590640)
print v(xbgr.mr_n65590960)
print v(xbgr.mr_n65591072)
print v(xbgr.mr_n65591392)
print v(xbgr.mr_n65591504)
print v(xbgr.mr_n65591824)
print v(xbgr.mr_n65591936)
print v(xbgr.mr_n65592256)
print v(xbgr.mr_n65593120)
print v(xbgr.mr_n65593232)
print v(xbgr.mr_n65593664)
print v(xbgr.mr_n65593984)
print v(xbgr.mr_n65594096)
print v(xbgr.mr_n65594416)
print v(xbgr.mr_n65594528)
print v(xbgr.mr_n65594848)
print v(xbgr.mr_n65594960)
print v(xbgr.mr_n65595280)
print v(xbgr.mr_n65595392)
print v(xbgr.mr_n65595712)
print v(xbgr.mr_n65595824)
print v(xbgr.mr_n65596144)
print v(xbgr.mr_n65596256)
print v(xbgr.mr_n65596576)
print v(xbgr.mr_n65597008)
print v(xbgr.mr_n65597120)
print v(xbgr.mr_n65597440)
print v(xbgr.mr_n65597984)
print v(xbgr.mr_n65598304)
print v(xbgr.mr_n65598416)
print v(xbgr.mr_n65598848)
print v(xbgr.mr_n65599280)
print v(xbgr.mr_n65599712)
print v(xbgr.mr_n65600144)
print v(xbgr.mr_n65600576)
print v(xbgr.mr_n65600896)
print v(xbgr.mr_n65601008)
print v(xbgr.mr_n65601440)
print v(xbgr.mr_n65601760)
print v(xbgr.mr_n65601872)
print v(xbgr.mr_n65602304)
print v(xbgr.mr_n65602624)
print v(xbgr.mr_n65603488)
print v(xbgr.mr_n65604784)
print v(xbgr.mr_n65605328)
print v(xbgr.mr_n65605648)
print v(xbgr.mr_n65606192)
print v(xbgr.mr_n65606512)
print v(xbgr.mr_n65606624)
print v(xbgr.mr_n65607376)
print v(xbgr.mr_n65607808)
print v(xbgr.mr_n65608672)
print v(xbgr.mr_n65609536)
print v(xbgr.mr_n65610832)
print v(xbgr.mr_n65611696)
print v(xbgr.mr_n65612128)
print v(xbgr.mr_n65612240)
print v(xbgr.mr_n65612992)
print v(xbgr.mr_n65613104)
print v(xbgr.mr_n65613424)
print v(xbgr.mr_n65613536)
print v(xbgr.mr_n65613856)
print v(xbgr.mr_n65613968)
print v(xbgr.mr_n65614720)
print v(xbgr.mr_n65616016)
print v(xbgr.mr_n65616880)
print v(xbgr.mr_n65617744)
print v(xbgr.mr_n65618176)
print v(xbgr.mr_n65618288)
print v(xbgr.mr_n65618608)
print v(xbgr.mr_n65618720)
print v(xbgr.mr_n65619040)
print v(xbgr.mr_n65619152)
print v(xbgr.mr_n65619472)
print v(xbgr.mr_n65619584)
print v(xbgr.mr_n65620336)
print v(xbgr.mr_n65620448)
print v(xbgr.mr_n65620768)
print v(xbgr.mr_n65620880)
print v(xbgr.mr_n65621200)
print v(xbgr.mr_n65621312)
print v(xbgr.mr_n65621632)
print v(xbgr.mr_n65622496)
print v(xbgr.mr_n65622608)
print v(xbgr.mr_n65622928)
print v(xbgr.mr_n65623040)
print v(xbgr.mr_n65623472)
print v(xbgr.mr_n65623792)
print v(xbgr.mr_n65623904)
print v(xbgr.mr_n65624224)
print v(xbgr.mr_n65624336)
print v(xbgr.mr_n65624656)
print v(xbgr.mr_n65624768)
print v(xbgr.mr_n65625200)
print v(xbgr.mr_n65625632)
print v(xbgr.mr_n65625952)
print v(xbgr.mr_n65626064)
print v(xbgr.mr_n65626384)
print v(xbgr.mr_n65626496)
print v(xbgr.mr_n65626816)
print v(xbgr.mr_n65626928)
print v(xbgr.mr_n65627360)
print v(xbgr.mr_n65627680)
print v(xbgr.mr_n65627792)
print v(xbgr.mr_n65628224)
print v(xbgr.mr_n65628544)
print v(xbgr.mr_n65628656)
print v(xbgr.mr_n65628976)
print v(xbgr.mr_n65629088)
print v(xbgr.mr_n65629408)
print v(xbgr.mr_n65629520)
print v(xbgr.mr_n65629840)
print v(xbgr.mr_n65629952)
print v(xbgr.mr_n65630272)
print v(xbgr.mr_n65631136)
print v(xbgr.mr_n65632000)
print v(xbgr.mr_n65632112)
print v(xbgr.mr_n65632432)
print v(xbgr.mr_n65632976)
print v(xbgr.mr_n65633296)
print v(xbgr.mr_n65633728)
print v(xbgr.mr_n65635024)
print v(xbgr.mr_n65636320)
print v(xbgr.mr_n65636432)
print v(xbgr.mr_n65636752)
print v(xbgr.mr_n65636864)
print v(xbgr.mr_n65637184)
print v(xbgr.mr_n65637296)
print v(xbgr.mr_n65637616)
print v(xbgr.mr_n65637728)
print v(xbgr.mr_n65638048)
print v(xbgr.mr_n65638160)
print v(xbgr.mr_n65638480)
print v(xbgr.mr_n65638592)
print v(xbgr.mr_n65638912)
print v(xbgr.mr_n65639024)
print v(xbgr.mr_n65639456)
print v(xbgr.mr_n65639776)
print v(xbgr.mr_n65640640)
print v(xbgr.mr_n65640752)
print v(xbgr.mr_n65641072)
print v(xbgr.mr_n65641184)
print v(xbgr.mr_n65641504)
print v(xbgr.mr_n65641616)
print v(xbgr.mr_n65641936)
print v(xbgr.mr_n65642048)
print v(xbgr.mr_n65642368)
print v(xbgr.mr_n65643232)
print v(xbgr.mr_n65644096)
print v(xbgr.mr_n65644960)
print v(xbgr.mr_n65645824)
print v(xbgr.mr_n65646688)
print v(xbgr.mr_n65646800)
print v(xbgr.mr_n65647120)
print v(xbgr.mr_n65647232)
print v(xbgr.mr_n65647552)
print v(xbgr.mr_n65647664)
print v(xbgr.mr_n65647984)
print v(xbgr.mr_n65648096)
print v(xbgr.mr_n65648416)
print v(xbgr.mr_n65648528)
print v(xbgr.mr_n65648848)
print v(xbgr.mr_n65648960)
print v(xbgr.mr_n65649280)
print v(xbgr.mr_n65649392)
print v(xbgr.mr_n65649712)
print v(xbgr.mr_n65649824)
print v(xbgr.mr_n65650144)
print v(xbgr.mr_n65650256)
print v(xbgr.mr_n65650576)
print v(xbgr.mr_n65650688)
print v(xbgr.mr_n65651120)
print v(xbgr.mr_n65651440)
print v(xbgr.mr_n65651552)
print v(xbgr.mr_n65651872)
print v(xbgr.mr_n65651984)
print v(xbgr.mr_n65652416)
print v(xbgr.mr_n65652736)
print v(xbgr.mr_n65652848)
print v(xbgr.mr_n65653280)
print v(xbgr.mr_n65653600)
print v(xbgr.mr_n65653712)
print v(xbgr.mr_n65654144)
print v(xbgr.mr_n65654576)
print v(xbgr.mr_n65654896)
print v(xbgr.mr_n65655008)
print v(xbgr.mr_n65655440)
print v(xbgr.mr_n65655760)
print v(xbgr.mr_n65655872)
print v(xbgr.mr_n65656192)
print v(xbgr.mr_n65656304)
print v(xbgr.mr_n65656624)
print v(xbgr.mr_n65656736)
print v(xbgr.mr_n65657056)
print v(xbgr.mr_n65657168)
print v(xbgr.mr_n65657488)
print v(xbgr.mr_n65657600)
print v(xbgr.mr_n65657920)
print v(xbgr.mr_n65658032)
print v(xbgr.mr_n65658352)
print v(xbgr.mr_n65658464)
print v(xbgr.mr_n65658784)
print v(xbgr.mr_n65658896)
print v(xbgr.mr_n65659216)
print v(xbgr.mr_n65660080)
print v(xbgr.mr_n65660192)
print v(xbgr.mr_n65660512)
print v(xbgr.mr_n65660624)
print v(xbgr.mr_n65660944)
print v(xbgr.mr_n65661808)
print v(xbgr.mr_n65662672)
print v(xbgr.mr_n65663536)
print v(xbgr.mr_n65664400)
print v(xbgr.mr_n65665264)
print v(xbgr.mr_n65665376)
print v(xbgr.mr_n65665696)
print v(xbgr.mr_n65665808)
print v(xbgr.mr_n65666128)
print v(xbgr.mr_n65666240)
print v(xbgr.mr_n65666560)
print v(xbgr.mr_n65667424)
print v(xbgr.mr_n65668288)
print v(xbgr.mr_n65669152)
print v(xbgr.mr_n65670016)
print v(xbgr.mr_n65670880)
print v(xbgr.mr_n65671744)
print v(xbgr.mr_n65672608)
print v(xbgr.mr_n65672720)
print v(xbgr.mr_n65673040)
print v(xbgr.mr_n65673152)
print v(xbgr.mr_n65673584)
print v(xbgr.mr_n65673904)
print v(xbgr.mr_n65674768)
print v(xbgr.mr_n65675312)
print v(xbgr.mr_n65675744)
print v(xbgr.mr_n65676176)
print v(xbgr.mr_n65676928)
print v(xbgr.mr_n65677792)
print v(xbgr.mr_n65678656)
print v(xbgr.mr_n65678768)
print v(xbgr.mr_n65679088)
print v(xbgr.mr_n65679200)
print v(xbgr.mr_n65679632)
print v(xbgr.mr_n65680064)
print v(xbgr.mr_n65680384)
print v(xbgr.mr_n65681248)
print v(xbgr.mr_n65681360)
print v(xbgr.mr_n65681792)
print v(xbgr.mr_n65682112)
print v(xbgr.mr_n65682224)
print v(xbgr.mr_n65682656)
print v(xbgr.mr_n65682976)
print v(xbgr.mr_n65683840)
print v(xbgr.mr_n65683952)
print v(xbgr.mr_n65684272)
print v(xbgr.mr_n65685136)
print v(xbgr.mr_n65686000)
print v(xbgr.mr_n65686112)
print v(xbgr.mr_n65686432)
print v(xbgr.mr_n65686544)
print v(xbgr.mr_n65686864)
print v(xbgr.mr_n65687728)
print v(xbgr.mr_n65688160)
print v(xbgr.mr_n65688272)
print v(xbgr.mr_n65688704)
print v(xbgr.mr_n65689024)
print v(xbgr.mr_n65689136)
print v(xbgr.mr_n65689568)
print v(xbgr.mr_n65690320)
print v(xbgr.mr_n65690432)
print v(xbgr.mr_n65690752)
print v(xbgr.mr_n65690864)
print v(xbgr.mr_n65691184)
print v(xbgr.mr_n65691296)
print v(xbgr.mr_n65691616)
print v(xbgr.mr_n65692048)
print v(xbgr.mr_n65692160)
print v(xbgr.mr_n65692912)
print v(xbgr.mr_n65693344)
print v(xbgr.mr_n65693456)
print v(xbgr.mr_n65694320)
print v(xbgr.mr_n65694640)
print v(xbgr.mr_n65694752)
print v(xbgr.mr_n65695072)
print v(xbgr.mr_n65695936)
print v(xbgr.mr_n65696800)
print v(xbgr.mr_n65697664)
print v(xbgr.mr_n65698528)
print v(xbgr.mr_n65698640)
print v(xbgr.mr_n65698960)
print v(xbgr.mr_n65699072)
print v(xbgr.mr_n65699392)
print v(xbgr.mr_n65699504)
print v(xbgr.mr_n65699824)
print v(xbgr.mr_n65699936)
print v(xbgr.mr_n65700256)
print v(xbgr.mr_n65700368)
print v(xbgr.mr_n65700688)
print v(xbgr.mr_n65700800)
print v(xbgr.mr_n65701120)
print v(xbgr.mr_n65701232)
print v(xbgr.mr_n65701552)
print v(xbgr.mr_n65701664)
print v(xbgr.mr_n65701984)
print v(xbgr.mr_n65702096)
print v(xbgr.mr_n65702416)
print v(xbgr.mr_n65702528)
print v(xbgr.mr_n65702960)
print v(xbgr.mr_n65703392)
print v(xbgr.mr_n65703824)
print v(xbgr.mr_n65704144)
print v(xbgr.mr_n65704256)
print v(xbgr.mr_n65704576)
print v(xbgr.mr_n65705440)
print v(xbgr.mr_n65705552)
print v(xbgr.mr_n65705872)
print v(xbgr.mr_n65705984)
print v(xbgr.mr_n65706304)
print v(xbgr.mr_n65706416)
print v(xbgr.mr_n65706848)
print v(xbgr.mr_n65707168)
print v(xbgr.mr_n65707280)
print v(xbgr.mr_n65707600)
print v(xbgr.mr_n65707712)
print v(xbgr.mr_n65708144)
print v(xbgr.mr_n65708464)
print v(xbgr.mr_n65708896)
print v(xbgr.mr_n65709008)
print v(xbgr.mr_n65709328)
print v(xbgr.mr_n65709440)
print v(xbgr.mr_n65709760)
print v(xbgr.mr_n65709872)
print v(xbgr.mr_n65710192)
print v(xbgr.mr_n65710304)
print v(xbgr.mr_n65710736)
print v(xbgr.mr_n65711056)
print v(xbgr.mr_n65711168)
print v(xbgr.mr_n65711488)
print v(xbgr.mr_n65711600)
print v(xbgr.mr_n65711920)
print v(xbgr.mr_n65712032)
print v(xbgr.mr_n65712352)
print v(xbgr.mr_n65712464)
print v(xbgr.mr_n65712784)
print v(xbgr.mr_n65712896)
print v(xbgr.mr_n65713216)
print v(xbgr.mr_n65713328)
print v(xbgr.mr_n65713648)
print v(xbgr.mr_n65713760)
print v(xbgr.mr_n65714512)
print v(xbgr.mr_n65714944)
print v(xbgr.mr_n65715808)
print v(xbgr.mr_n65715920)
print v(xbgr.mr_n65716240)
print v(xbgr.mr_n65716784)
print v(xbgr.mr_n65717216)
print v(xbgr.mr_n65717648)
print v(xbgr.mr_n65717968)
print v(xbgr.mr_n65718400)
print v(xbgr.mr_n65719264)
print v(xbgr.mr_n65721424)
print v(xbgr.mr_n65722288)
print v(xbgr.mr_n65722400)
print v(xbgr.mr_n65722720)
print v(xbgr.mr_n65723584)
print v(xbgr.mr_n65724448)
print v(xbgr.mr_n65724560)
print v(xbgr.mr_n65724880)
print v(xbgr.mr_n65724992)
print v(xbgr.mr_n65725312)
print v(xbgr.mr_n65725424)
print v(xbgr.mr_n65725744)
print v(xbgr.mr_n65725856)
print v(xbgr.mr_n65726176)
print v(xbgr.mr_n65727040)
print v(xbgr.mr_n65727904)
print v(xbgr.mr_n65728016)
print v(xbgr.mr_n65728336)
print v(xbgr.mr_n65728448)
print v(xbgr.mr_n65728768)
print v(xbgr.mr_n65728880)
print v(xbgr.mr_n65729200)
print v(xbgr.mr_n65729312)
print v(xbgr.mr_n65729632)
print v(xbgr.mr_n65729744)
print v(xbgr.mr_n65730064)
print v(xbgr.mr_n65730176)
print v(xbgr.mr_n65730496)
print v(xbgr.mr_n65730608)
print v(xbgr.mr_n65731040)
print v(xbgr.mr_n65731360)
print v(xbgr.mr_n65731472)
print v(xbgr.mr_n65731904)
print v(xbgr.mr_n65732224)
print v(xbgr.mr_n65732768)
print v(xbgr.mr_n65733632)
print v(xbgr.mr_n65733952)
print v(xbgr.mr_n65734064)
print v(xbgr.mr_n65735248)
print v(xbgr.mr_n65735360)
print v(xbgr.mr_n65735680)
print v(xbgr.mr_n65735792)
print v(xbgr.mr_n65736112)
print v(xbgr.mr_n65736224)
print v(xbgr.mr_n65736544)
print v(xbgr.mr_n65736656)
print v(xbgr.mr_n65736976)
print v(xbgr.mr_n65737840)
print v(xbgr.mr_n65738704)
print v(xbgr.mr_n65738816)
print v(xbgr.mr_n65739248)
print v(xbgr.mr_n65739680)
print v(xbgr.mr_n65740112)
print v(xbgr.mr_n65740432)
print v(xbgr.mr_n65740544)
print v(xbgr.mr_n65740864)
print v(xbgr.mr_n65740976)
print v(xbgr.mr_n65741296)
print v(xbgr.mr_n65741408)
print v(xbgr.mr_n65741728)
print v(xbgr.mr_n65741840)
print v(xbgr.mr_n65742160)
print v(xbgr.mr_n65742272)
print v(xbgr.mr_n65742592)
print v(xbgr.mr_n65742704)
print v(xbgr.mr_n65743024)
print v(xbgr.mr_n65743888)
print v(xbgr.mr_n65744000)
print v(xbgr.mr_n65744320)
print v(xbgr.mr_n65744432)
print v(xbgr.mr_n65744752)
print v(xbgr.mr_n65744864)
print v(xbgr.mr_n65745184)
print v(xbgr.mr_n65745296)
print v(xbgr.mr_n65745616)
print v(xbgr.mr_n65746160)
print v(xbgr.mr_n65746912)
print v(xbgr.mr_n65747776)
print v(xbgr.mr_n65748640)
print v(xbgr.mr_n65749504)
print v(xbgr.mr_n65750368)
print v(xbgr.mr_n65751232)
print v(xbgr.mr_n65751344)
print v(xbgr.mr_n65751664)
print v(xbgr.mr_n65751776)
print v(xbgr.mr_n65752096)
print v(xbgr.mr_n65752208)
print v(xbgr.mr_n65752528)
print v(xbgr.mr_n65752640)
print v(xbgr.mr_n65752960)
print v(xbgr.mr_n65753072)
print v(xbgr.mr_n65753392)
print v(xbgr.mr_n65753504)
print v(xbgr.mr_n65753824)
print v(xbgr.mr_n65754688)
print v(xbgr.mr_n65755552)
print v(xbgr.mr_n65756416)
print v(xbgr.mr_n65757280)
print v(xbgr.mr_n65758144)
print v(xbgr.mr_n65759008)
print v(xbgr.mr_n65759872)
print v(xbgr.mr_n65759984)
print v(xbgr.mr_n65760304)
print v(xbgr.mr_n65760416)
print v(xbgr.mr_n65760736)
print v(xbgr.mr_n65760848)
print v(xbgr.mr_n65761168)
print v(xbgr.mr_n65761280)
print v(xbgr.mr_n65761600)
print v(xbgr.mr_n65761712)
print v(xbgr.mr_n65762032)
print v(xbgr.mr_n65762144)
print v(xbgr.mr_n65762464)
print v(xbgr.mr_n65762576)
print v(xbgr.mr_n65763008)
print v(xbgr.mr_n65763328)
print v(xbgr.mr_n65763440)
print v(xbgr.mr_n65763872)
print v(xbgr.mr_n65764192)
print v(xbgr.mr_n65764304)
print v(xbgr.mr_n65764736)
print v(xbgr.mr_n65765056)
print v(xbgr.mr_n65765920)
print v(xbgr.mr_n65766784)
print v(xbgr.mr_n65767648)
print v(xbgr.mr_n65768512)
print v(xbgr.mr_n65769376)
print v(xbgr.mr_n65770240)
print v(xbgr.mr_n65770352)
print v(xbgr.mr_n65770672)
print v(xbgr.mr_n65770784)
print v(xbgr.mr_n65771104)
print v(xbgr.mr_n65771216)
print v(xbgr.mr_n65771536)
print v(xbgr.mr_n65771648)
print v(xbgr.mr_n65771968)
print v(xbgr.mr_n65772832)
print v(xbgr.mr_n65773696)
print v(xbgr.mr_n65774560)
print v(xbgr.mr_n65774672)
print v(xbgr.mr_n65775104)
print v(xbgr.mr_n65775424)
print v(xbgr.mr_n65775536)
print v(xbgr.mr_n65775856)
print v(xbgr.mr_n65775968)
print v(xbgr.mr_n65776288)
print v(xbgr.mr_n65776400)
print v(xbgr.mr_n65776720)
print v(xbgr.mr_n65776832)
print v(xbgr.mr_n65777152)
print v(xbgr.mr_n65777264)
print v(xbgr.mr_n65777696)
print v(xbgr.mr_n65778016)
print v(xbgr.mr_n65778128)
print v(xbgr.mr_n65778560)
print v(xbgr.mr_n65778880)
print v(xbgr.mr_n65778992)
print v(xbgr.mr_n65779312)
print v(xbgr.mr_n65779424)
print v(xbgr.mr_n65779856)
print v(xbgr.mr_n65780288)
print v(xbgr.mr_n65780608)
print v(xbgr.mr_n65780720)
print v(xbgr.mr_n65781152)
print v(xbgr.mr_n65781472)
print v(xbgr.mr_n65781584)
print v(xbgr.mr_n65782016)
print v(xbgr.mr_n65782336)
print v(xbgr.mr_n65783200)
print v(xbgr.mr_n65784064)
print v(xbgr.mr_n65784928)
print v(xbgr.mr_n65785792)
print v(xbgr.mr_n65785904)
print v(xbgr.mr_n65786224)
print v(xbgr.mr_n65786336)
print v(xbgr.mr_n65786656)
print v(xbgr.mr_n65786768)
print v(xbgr.mr_n65787088)
print v(xbgr.mr_n65787200)
print v(xbgr.mr_n65787520)
print v(xbgr.mr_n65788384)
print v(xbgr.mr_n65789248)
print v(xbgr.mr_n65790112)
print v(xbgr.mr_n65790976)
print v(xbgr.mr_n65791840)
print v(xbgr.mr_n65792704)
print v(xbgr.mr_n65793568)
print v(xbgr.mr_n65794432)
print v(xbgr.mr_n65794544)
print v(xbgr.mr_n65794864)
print v(xbgr.mr_n65794976)
print v(xbgr.mr_n65795296)
print v(xbgr.mr_n65795408)
print v(xbgr.mr_n65795728)
print v(xbgr.mr_n65795840)
print v(xbgr.mr_n65796160)
print v(xbgr.mr_n65796272)
print v(xbgr.mr_n65796592)
print v(xbgr.mr_n65796704)
print v(xbgr.mr_n65797024)
print v(xbgr.mr_n65797136)
print v(xbgr.mr_n65797456)
print v(xbgr.mr_n65797568)
print v(xbgr.mr_n65797888)
print v(xbgr.mr_n65798000)
print v(xbgr.mr_n65798320)
print v(xbgr.mr_n65798432)
print v(xbgr.mr_n65798864)
print v(xbgr.mr_n65799184)
print v(xbgr.mr_n65799296)
print v(xbgr.mr_n65799616)
print v(xbgr.mr_n65799728)
print v(xbgr.mr_n65800048)
print v(xbgr.mr_n65800160)
print v(xbgr.mr_n65800480)
print v(xbgr.mr_n65800592)
print v(xbgr.mr_n65800912)
print v(xbgr.mr_n65801024)
print v(xbgr.mr_n65801456)
print v(xbgr.mr_n65801776)
print v(xbgr.mr_n65801888)
print v(xbgr.mr_n65802320)
print v(xbgr.mr_n65802640)
print v(xbgr.mr_n65802752)
print v(xbgr.mr_n65803072)
print v(xbgr.mr_n65803936)
print v(xbgr.mr_n65804800)
print v(xbgr.mr_n65805344)
print v(xbgr.mr_n65806096)
print v(xbgr.mr_n65806528)
print v(xbgr.mr_n65806640)
print v(xbgr.mr_n65807392)
print v(xbgr.mr_n65807504)
print v(xbgr.mr_n65807936)
print v(xbgr.mr_n65808368)
print v(xbgr.mr_n65808688)
print v(xbgr.mr_n65809552)
print v(xbgr.mr_n65809984)
print v(xbgr.mr_n65810848)
print v(xbgr.mr_n65810960)
print v(xbgr.mr_n65811712)
print v(xbgr.mr_n65813008)
print v(xbgr.mr_n65813872)
print v(xbgr.mr_n65813984)
print v(xbgr.mr_n65814304)
print v(xbgr.mr_n65814416)
print v(xbgr.mr_n65814736)
print v(xbgr.mr_n65814848)
print v(xbgr.mr_n65815168)
print v(xbgr.mr_n65815280)
print v(xbgr.mr_n65815600)
print v(xbgr.mr_n65816464)
print v(xbgr.mr_n65817328)
print v(xbgr.mr_n65818192)
print v(xbgr.mr_n65818304)
print v(xbgr.mr_n65818624)
print v(xbgr.mr_n65818736)
print v(xbgr.mr_n65819056)
print v(xbgr.mr_n65819920)
print v(xbgr.mr_n65820032)
print v(xbgr.mr_n65820352)
print v(xbgr.mr_n65820464)
print v(xbgr.mr_n65820784)
print v(xbgr.mr_n65820896)
print v(xbgr.mr_n65821216)
print v(xbgr.mr_n65821328)
print v(xbgr.mr_n65821648)
print v(xbgr.mr_n65822512)
print v(xbgr.mr_n65823376)
print v(xbgr.mr_n65823488)
print v(xbgr.mr_n65823808)
print v(xbgr.mr_n65823920)
print v(xbgr.mr_n65824240)
print v(xbgr.mr_n65824352)
print v(xbgr.mr_n65824672)
print v(xbgr.mr_n65824784)
print v(xbgr.mr_n65825104)
print v(xbgr.mr_n65825216)
print v(xbgr.mr_n65825536)
print v(xbgr.mr_n65825648)
print v(xbgr.mr_n65826400)
print v(xbgr.mr_n65827264)
print v(xbgr.mr_n65828128)
print v(xbgr.mr_n65828240)
print v(xbgr.mr_n65828560)
print v(xbgr.mr_n65828672)
print v(xbgr.mr_n65828992)
print v(xbgr.mr_n65829104)
print v(xbgr.mr_n65829424)
print v(xbgr.mr_n65829536)
print v(xbgr.mr_n65829968)
print v(xbgr.mr_n65830288)
print v(xbgr.mr_n65830400)
print v(xbgr.mr_n65831152)
print v(xbgr.mr_n65832016)
print v(xbgr.mr_n65832880)
print v(xbgr.mr_n65833744)
print v(xbgr.mr_n65833856)
print v(xbgr.mr_n65834176)
print v(xbgr.mr_n65834288)
print v(xbgr.mr_n65834608)
print v(xbgr.mr_n65834720)
print v(xbgr.mr_n65835040)
print v(xbgr.mr_n65835152)
print v(xbgr.mr_n65835472)
print v(xbgr.mr_n65836336)
print v(xbgr.mr_n65837632)
print v(xbgr.mr_n65837744)
print v(xbgr.mr_n65838064)
print v(xbgr.mr_n65838176)
print v(xbgr.mr_n65838608)
print v(xbgr.mr_n65838928)
print v(xbgr.mr_n65839040)
print v(xbgr.mr_n65839472)
print v(xbgr.mr_n65839792)
print v(xbgr.mr_n65840224)
print v(xbgr.mr_n65841088)
print v(xbgr.mr_n65841952)
print v(xbgr.mr_n65842064)
print v(xbgr.mr_n65842384)
print v(xbgr.mr_n65842496)
print v(xbgr.mr_n65842928)
print v(xbgr.mr_n65843248)
print v(xbgr.mr_n65843360)
print v(xbgr.mr_n65843680)
print v(xbgr.mr_n65843792)
print v(xbgr.mr_n65844112)
print v(xbgr.mr_n65844224)
print v(xbgr.mr_n65844544)
print v(xbgr.mr_n65844656)
print v(xbgr.mr_n65845088)
print v(xbgr.mr_n65845520)
print v(xbgr.mr_n65845952)
print v(xbgr.mr_n65846384)
print v(xbgr.mr_n65846704)
print v(xbgr.mr_n65846816)
print v(xbgr.mr_n65847248)
print v(xbgr.mr_n65847568)
print v(xbgr.mr_n65848432)
print v(xbgr.mr_n65849296)
print v(xbgr.mr_n65849728)
print v(xbgr.mr_n65850592)
print v(xbgr.mr_n65851024)
print v(xbgr.mr_n65851136)
print v(xbgr.mr_n65851888)
print v(xbgr.mr_n65852752)
print v(xbgr.mr_n65853616)
print v(xbgr.mr_n65853728)
print v(xbgr.mr_n65854160)
print v(xbgr.mr_n65854480)
print v(xbgr.mr_n65855344)
print v(xbgr.mr_n65855456)
print v(xbgr.mr_n65855776)
print v(xbgr.mr_n65855888)
print v(xbgr.mr_n65856208)
print v(xbgr.mr_n65856320)
print v(xbgr.mr_n65856640)
print v(xbgr.mr_n65856752)
print v(xbgr.mr_n65857072)
print v(xbgr.mr_n65857184)
print v(xbgr.mr_n65857504)
print v(xbgr.mr_n65857616)
print v(xbgr.mr_n65857936)
print v(xbgr.mr_n65858048)
print v(xbgr.mr_n65858368)
print v(xbgr.mr_n65858480)
print v(xbgr.mr_n65858800)
print v(xbgr.mr_n65858912)
print v(xbgr.mr_n65859232)
print v(xbgr.mr_n65859344)
print v(xbgr.mr_n65860096)
print v(xbgr.mr_n65861392)
print v(xbgr.mr_n65862256)
print v(xbgr.mr_n65863552)
print v(xbgr.mr_n65863664)
print v(xbgr.mr_n65863984)
print v(xbgr.mr_n65864096)
print v(xbgr.mr_n65864416)
print v(xbgr.mr_n65864528)
print v(xbgr.mr_n65864848)
print v(xbgr.mr_n65864960)
print v(xbgr.mr_n65865712)
print v(xbgr.mr_n65866576)
print v(xbgr.mr_n65867440)
print v(xbgr.mr_n65868304)
print v(xbgr.mr_n65868416)
print v(xbgr.mr_n65868736)
print v(xbgr.mr_n65868848)
print v(xbgr.mr_n65869168)
print v(xbgr.mr_n65869280)
print v(xbgr.mr_n65869600)
print v(xbgr.mr_n65869712)
print v(xbgr.mr_n65870032)
print v(xbgr.mr_n65870144)
print v(xbgr.mr_n65870464)
print v(xbgr.mr_n65871008)
print v(xbgr.mr_n65871760)
print v(xbgr.mr_n65872624)
print v(xbgr.mr_n65872736)
print v(xbgr.mr_n65873056)
print v(xbgr.mr_n65873168)
print v(xbgr.mr_n65873600)
print v(xbgr.mr_n65873920)
print v(xbgr.mr_n65874032)
print v(xbgr.mr_n65874352)
print v(xbgr.mr_n65874464)
print v(xbgr.mr_n65874784)
print v(xbgr.mr_n65874896)
print v(xbgr.mr_n65875216)
print v(xbgr.mr_n65875328)
print v(xbgr.mr_n65875648)
print v(xbgr.mr_n65876080)
print v(xbgr.mr_n65876192)
print v(xbgr.mr_n65876512)
print v(xbgr.mr_n65876624)
print v(xbgr.mr_n65877376)
print v(xbgr.mr_n65877488)
print v(xbgr.mr_n65877808)
print v(xbgr.mr_n65877920)
print v(xbgr.mr_n65878672)
print v(xbgr.mr_n65879536)
print v(xbgr.mr_n65879648)
print v(xbgr.mr_n65879968)
print v(xbgr.mr_n65880832)
print v(xbgr.mr_n65881376)
print v(xbgr.mr_n65881696)
print v(xbgr.mr_n65882240)
print v(xbgr.mr_n65882672)
print v(xbgr.mr_n65882992)
print v(xbgr.mr_n65883104)
print v(xbgr.mr_n65883856)
print v(xbgr.mr_n65883968)
print v(xbgr.mr_n65884288)
print v(xbgr.mr_n65884400)
print v(xbgr.mr_n65884720)
print v(xbgr.mr_n65885584)
print v(xbgr.mr_n65886016)
print v(xbgr.mr_n65886128)
print v(xbgr.mr_n65886448)
print v(xbgr.mr_n65886560)
print v(xbgr.mr_n65886880)
print v(xbgr.mr_n65886992)
print v(xbgr.mr_n65887312)
print v(xbgr.mr_n65887424)
print v(xbgr.mr_n65887744)
print v(xbgr.mr_n65887856)
print v(xbgr.mr_n65889040)
print v(xbgr.mr_n65889152)
print v(xbgr.mr_n65889472)
print v(xbgr.mr_n65889584)
print v(xbgr.mr_n65889904)
print v(xbgr.mr_n65890016)
print v(xbgr.mr_n65890336)
print v(xbgr.mr_n65890768)
print v(xbgr.mr_n66023152)
print v(xbgr.mr_n66023264)
print v(xbgr.mr_n66023584)
print v(xbgr.mr_n66023696)
print v(xbgr.mr_n66024016)
print v(xbgr.mr_n66024128)
print v(xbgr.mr_n66024448)
print v(xbgr.mr_n66024560)
print v(xbgr.mr_n66024880)
print v(xbgr.mr_n66024992)
print v(xbgr.mr_n66025312)
print v(xbgr.mr_n66025424)
print v(xbgr.mr_n66025744)
print v(xbgr.mr_n66025856)
print v(xbgr.mr_n66026176)
print v(xbgr.mr_n66026288)
print v(xbgr.mr_n66026608)
print v(xbgr.mr_n66026720)
print v(xbgr.mr_n66027040)
print v(xbgr.mr_n66027152)
print v(xbgr.mr_n66027472)
print v(xbgr.mr_n66027584)
print v(xbgr.mr_n66027904)
print v(xbgr.mr_n66028016)
print v(xbgr.mr_n66028336)
print v(xbgr.mr_n66028448)
print v(xbgr.mr_n66028768)
print v(xbgr.mr_n66028880)
print v(xbgr.mr_n66029200)
print v(xbgr.mr_n66029312)
print v(xbgr.mr_n66029632)
print v(xbgr.mr_n66029744)
print v(xbgr.mr_n66030064)
print v(xbgr.mr_n66030176)
print v(xbgr.mr_n66030496)
print v(xbgr.mr_n66030608)
print v(xbgr.mr_n66030928)
print v(xbgr.mr_n66031040)
print v(xbgr.mr_n66031360)
print v(xbgr.mr_n66031472)
print v(xbgr.mr_n66031792)
print v(xbgr.mr_n66031904)
print v(xbgr.mr_n66032224)
print v(xbgr.mr_n66032336)
print v(xbgr.mr_n66032656)
print v(xbgr.mr_n66032768)
print v(xbgr.mr_n66033088)
print v(xbgr.mr_n66033200)
print v(xbgr.mr_n66033520)
print v(xbgr.mr_n66033632)
print v(xbgr.mr_n66033952)
print v(xbgr.mr_n66034064)
print v(xbgr.mr_n66034384)
print v(xbgr.mr_n66034496)
print v(xbgr.mr_n66034816)
print v(xbgr.mr_n66034928)
print v(xbgr.mr_n66035248)
print v(xbgr.mr_n66035360)
print v(xbgr.mr_n66035680)
print v(xbgr.mr_n66035792)
print v(xbgr.mr_n66036112)
print v(xbgr.mr_n66036224)
print v(xbgr.mr_n66036544)
print v(xbgr.mr_n66036656)
print v(xbgr.mr_n66036976)
print v(xbgr.mr_n66037088)
print v(xbgr.mr_n66037408)
print v(xbgr.mr_n66037520)
print v(xbgr.mr_n66037840)
print v(xbgr.mr_n66037952)
print v(xbgr.mr_n66038272)
print v(xbgr.mr_n66038384)
print v(xbgr.mr_n66038704)
print v(xbgr.mr_n66038816)
print v(xbgr.mr_n66039136)
print v(xbgr.mr_n66039248)
print v(xbgr.mr_n66039568)
print v(xbgr.mr_n66039680)
print v(xbgr.mr_n66040000)
print v(xbgr.mr_n66040112)
print v(xbgr.mr_n66040432)
print v(xbgr.mr_n66040544)
print v(xbgr.mr_n66040864)
print v(xbgr.mr_n66040976)
print v(xbgr.mr_n66041296)
print v(xbgr.mr_n66041408)
print v(xbgr.mr_n66041728)
print v(xbgr.mr_n66041840)
print v(xbgr.mr_n66042160)
print v(xbgr.mr_n66042272)
print v(xbgr.mr_n66042592)
print v(xbgr.mr_n66042704)
print v(xbgr.mr_n66043024)
print v(xbgr.mr_n66043136)
print v(xbgr.mr_n66043456)
print v(xbgr.mr_n66043568)
print v(xbgr.mr_n66043888)
print v(xbgr.mr_n66044000)
print v(xbgr.mr_n66044320)
print v(xbgr.mr_n66044432)
print v(xbgr.mr_n66044752)
print v(xbgr.mr_n66044864)
print v(xbgr.mr_n66045184)
print v(xbgr.mr_n66045296)
print v(xbgr.mr_n66045616)
print v(xbgr.mr_n66045728)
print v(xbgr.mr_n66046048)
print v(xbgr.mr_n66046160)
print v(xbgr.mr_n66046480)
print v(xbgr.mr_n66046592)
print v(xbgr.mr_n66046912)
print v(xbgr.mr_n66047024)
print v(xbgr.mr_n66047344)
print v(xbgr.mr_n66047456)
print v(xbgr.mr_n66047776)
print v(xbgr.mr_n66047888)
print v(xbgr.mr_n66048208)
print v(xbgr.mr_n66048320)
print v(xbgr.mr_n66048640)
print v(xbgr.mr_n66048752)
print v(xbgr.mr_n66049072)
print v(xbgr.mr_n66049184)
print v(xbgr.mr_n66049504)
print v(xbgr.mr_n66049616)
print v(xbgr.mr_n66049936)
print v(xbgr.mr_n66050048)
print v(xbgr.mr_n66050368)
print v(xbgr.mr_n66050480)
print v(xbgr.mr_n66050800)
print v(xbgr.mr_n66050912)
print v(xbgr.mr_n66051232)
print v(xbgr.mr_n66051344)
print v(xbgr.mr_n66051664)
print v(xbgr.mr_n66051776)
print v(xbgr.mr_n66052096)
print v(xbgr.mr_n66052208)
print v(xbgr.mr_n66052528)
print v(xbgr.mr_n66052640)
print v(xbgr.mr_n66052960)
print v(xbgr.mr_n66053072)
print v(xbgr.mr_n66053392)
print v(xbgr.mr_n66053504)
print v(xbgr.mr_n66053824)
print v(xbgr.mr_n66053936)
print v(xbgr.mr_n66054256)
print v(xbgr.mr_n66054368)
print v(xbgr.mr_n66054688)
print v(xbgr.mr_n66054800)
print v(xbgr.mr_n66055120)
print v(xbgr.mr_n66055232)
print v(xbgr.mr_n66055552)
print v(xbgr.mr_n66055664)
print v(xbgr.mr_n66055984)
print v(xbgr.mr_n66056096)
print v(xbgr.mr_n66056416)
print v(xbgr.mr_n66056528)
print v(xbgr.mr_n66056848)
print v(xbgr.mr_n66056960)
print v(xbgr.mr_n66057280)
print v(xbgr.mr_n66057392)
print v(xbgr.mr_n66057712)
print v(xbgr.mr_n66057824)
print v(xbgr.mr_n66058144)
print v(xbgr.mr_n66058256)
print v(xbgr.mr_n66058576)
print v(xbgr.mr_n66058688)
print v(xbgr.mr_n66059008)
print v(xbgr.mr_n66059120)
print v(xbgr.mr_n66059440)
print v(xbgr.mr_n66059552)
print v(xbgr.mr_n66059872)
print v(xbgr.mr_n66059984)
print v(xbgr.mr_n66060304)
print v(xbgr.mr_n66060416)
print v(xbgr.mr_n66060736)
print v(xbgr.mr_n66060848)
print v(xbgr.mr_n66061168)
print v(xbgr.mr_n66061280)
print v(xbgr.mr_n66061600)
print v(xbgr.mr_n66061712)
print v(xbgr.mr_n66062032)
print v(xbgr.mr_n66062144)
print v(xbgr.mr_n66062464)
print v(xbgr.mr_n66062576)
print v(xbgr.mr_n66062896)
print v(xbgr.mr_n66063008)
print v(xbgr.mr_n66063328)
print v(xbgr.mr_n66063440)
print v(xbgr.mr_n66063760)
print v(xbgr.mr_n66063872)
print v(xbgr.mr_n66064192)
print v(xbgr.mr_n66064304)
print v(xbgr.mr_n66064624)
print v(xbgr.mr_n66064736)
print v(xbgr.mr_n66065056)
print v(xbgr.mr_n66065168)
print v(xbgr.mr_n66065488)
print v(xbgr.mr_n66065600)
print v(xbgr.mr_n66065920)
print v(xbgr.mr_n66066032)
print v(xbgr.mr_n66066352)
print v(xbgr.mr_n66066464)
print v(xbgr.mr_n66066784)
print v(xbgr.mr_n66066896)
print v(xbgr.mr_n66067216)
print v(xbgr.mr_n66067328)
print v(xbgr.mr_n66067648)
print v(xbgr.mr_n66067760)
print v(xbgr.mr_n66068080)
print v(xbgr.mr_n66068192)
print v(xbgr.mr_n66068512)
print v(xbgr.mr_n66068624)
print v(xbgr.mr_n66068944)
print v(xbgr.mr_n66069056)
print v(xbgr.mr_n66069376)
print v(xbgr.mr_n66069488)
print v(xbgr.mr_n66069808)
print v(xbgr.mr_n66069920)
print v(xbgr.mr_n66070240)
print v(xbgr.mr_n66070352)
print v(xbgr.mr_n66070672)
print v(xbgr.mr_n66070784)
print v(xbgr.mr_n66071104)
print v(xbgr.mr_n66071216)
print v(xbgr.mr_n66071536)
print v(xbgr.mr_n66071648)
print v(xbgr.mr_n66071968)
print v(xbgr.mr_n66072080)
print v(xbgr.mr_n66072400)
print v(xbgr.mr_n66072512)
print v(xbgr.mr_n66072832)
print v(xbgr.mr_n66072944)
print v(xbgr.mr_n66073264)
print v(xbgr.mr_n66073376)
print v(xbgr.mr_n66073696)
print v(xbgr.mr_n66073808)
print v(xbgr.mr_n66074128)
print v(xbgr.mr_n66074240)
print v(xbgr.mr_n66074560)
print v(xbgr.mr_n66074672)
print v(xbgr.mr_n66074992)
print v(xbgr.mr_n66075104)
print v(xbgr.mr_n66075424)
print v(xbgr.mr_n66075536)
print v(xbgr.mr_n66075856)
print v(xbgr.mr_n66075968)
print v(xbgr.mr_n66076288)
print v(xbgr.mr_n66076400)
print v(xbgr.mr_n66076720)
print v(xbgr.mr_n66076832)
print v(xbgr.mr_n66077152)
print v(xbgr.mr_n66077264)
print v(xbgr.mr_n66077584)
print v(xbgr.mr_n66077696)
print v(xbgr.mr_n66078016)
print v(xbgr.mr_n66078128)
print v(xbgr.mr_n66078448)
print v(xbgr.mr_n66078560)
print v(xbgr.mr_n66078880)
print v(xbgr.mr_n66078992)
print v(xbgr.mr_n66079312)
print v(xbgr.mr_n66079424)
print v(xbgr.mr_n66079744)
print v(xbgr.mr_n66079856)
print v(xbgr.mr_n66080176)
print v(xbgr.mr_n66080288)
print v(xbgr.mr_n66080608)
print v(xbgr.mr_n66080720)
print v(xbgr.mr_n66081040)
print v(xbgr.mr_n66081152)
print v(xbgr.mr_n66081472)
print v(xbgr.mr_n66081584)
print v(xbgr.mr_n66081904)
print v(xbgr.mr_n66082016)
print v(xbgr.mr_n66082336)
print v(xbgr.mr_n66082448)
print v(xbgr.mr_n66082768)
print v(xbgr.mr_n66082880)
print v(xbgr.mr_n66083200)
print v(xbgr.mr_n66083312)
print v(xbgr.mr_n66083632)
print v(xbgr.mr_n66083744)
print v(xbgr.mr_n66084064)
print v(xbgr.mr_n66084176)
print v(xbgr.mr_n66084496)
print v(xbgr.mr_n66084608)
print v(xbgr.mr_n66084928)
print v(xbgr.mr_n66085040)
print v(xbgr.mr_n66085360)
print v(xbgr.mr_n66085472)
print v(xbgr.mr_n66085792)
print v(xbgr.mr_n66085904)
print v(xbgr.mr_n66086224)
print v(xbgr.mr_n66086336)
print v(xbgr.mr_n66086656)
print v(xbgr.mr_n66086768)
print v(xbgr.mr_n66087088)
print v(xbgr.mr_n66087200)
print v(xbgr.mr_n66087520)
print v(xbgr.mr_n66087632)
print v(xbgr.mr_n66087952)
print v(xbgr.mr_n66088064)
print v(xbgr.mr_n66088384)
print v(xbgr.mr_n66088496)
print v(xbgr.mr_n66088816)
print v(xbgr.mr_n66088928)
print v(xbgr.mr_n66089248)
print v(xbgr.mr_n66089360)
print v(xbgr.mr_n66089680)
print v(xbgr.mr_n66089792)
print v(xbgr.mr_n66090112)
print v(xbgr.mr_n66090224)
print v(xbgr.mr_n66090544)
print v(xbgr.mr_n66090656)
print v(xbgr.mr_n66090976)
print v(xbgr.mr_n66091088)
print v(xbgr.mr_n66091408)
print v(xbgr.mr_n66091520)
print v(xbgr.mr_n66091840)
print v(xbgr.mr_n66091952)
print v(xbgr.mr_n66092272)
print v(xbgr.mr_n66092384)
print v(xbgr.mr_n66092704)
print v(xbgr.mr_n66092816)
print v(xbgr.mr_n66093136)
print v(xbgr.mr_n66093248)
print v(xbgr.mr_n66093568)
print v(xbgr.mr_n66093680)
print v(xbgr.mr_n66094000)
print v(xbgr.mr_n66094112)
print v(xbgr.mr_n66094432)
print v(xbgr.mr_n66094544)
print v(xbgr.mr_n66094864)
print v(xbgr.mr_n66094976)
print v(xbgr.mr_n66095296)
print v(xbgr.mr_n66095408)
print v(xbgr.mr_n66095728)
print v(xbgr.mr_n66095840)
print v(xbgr.mr_n66096160)
print v(xbgr.mr_n66096272)
print v(xbgr.mr_n66096592)
print v(xbgr.mr_n66096704)
print v(xbgr.mr_n66097024)
print v(xbgr.mr_n66097136)
print v(xbgr.mr_n66097456)
print v(xbgr.mr_n66097568)
print v(xbgr.mr_n66097888)
print v(xbgr.mr_n66098000)
print v(xbgr.mr_n66098320)
print v(xbgr.mr_n66098432)
print v(xbgr.mr_n66098752)
print v(xbgr.mr_n66098864)
print v(xbgr.mr_n66099184)
print v(xbgr.mr_n66099296)
print v(xbgr.mr_n66099616)
print v(xbgr.mr_n66099728)
print v(xbgr.mr_n66100048)
print v(xbgr.mr_n66100160)
print v(xbgr.mr_n66100480)
print v(xbgr.mr_n66100592)
print v(xbgr.mr_n66100912)
print v(xbgr.mr_n66101024)
print v(xbgr.mr_n66101344)
print v(xbgr.mr_n66101456)
print v(xbgr.mr_n66101776)
print v(xbgr.mr_n66101888)
print v(xbgr.mr_n66102208)
print v(xbgr.mr_n66102320)
print v(xbgr.mr_n66102640)
print v(xbgr.mr_n66102752)
print v(xbgr.mr_n66103072)
print v(xbgr.mr_n66103184)
print v(xbgr.mr_n66103504)
print v(xbgr.mr_n66103616)
print v(xbgr.mr_n66103936)
print v(xbgr.mr_n66104048)
print v(xbgr.mr_n66104368)
print v(xbgr.mr_n66104480)
print v(xbgr.mr_n66104800)
print v(xbgr.mr_n66104912)
print v(xbgr.mr_n66105232)
print v(xbgr.mr_n66105344)
print v(xbgr.mr_n66105664)
print v(xbgr.mr_n66105776)
print v(xbgr.mr_n66106080)
print v(xbgr.mr_n66106192)
print v(xbgr.mr_n66106512)
print v(xbgr.mr_n66106624)
print v(xbgr.mr_n66106944)
print v(xbgr.mr_n66107056)
print v(xbgr.mr_n66107376)
print v(xbgr.mr_n66107488)
print v(xbgr.mr_n66107808)
print v(xbgr.mr_n66107920)
print v(xbgr.mr_n66108240)
print v(xbgr.mr_n66108352)
print v(xbgr.mr_n66108672)
print v(xbgr.mr_n66108784)
print v(xbgr.mr_n66109104)
print v(xbgr.mr_n66109216)
print v(xbgr.mr_n66109536)
print v(xbgr.mr_n66109648)
print v(xbgr.mr_n66109968)
print v(xbgr.mr_n66110080)
print v(xbgr.mr_n66110400)
print v(xbgr.mr_n66110512)
print v(xbgr.mr_n66110832)
print v(xbgr.mr_n66110944)
print v(xbgr.mr_n66111264)
print v(xbgr.mr_n66111376)
print v(xbgr.mr_n66111696)
print v(xbgr.mr_n66111808)
print v(xbgr.mr_n66112128)
print v(xbgr.mr_n66112240)
print v(xbgr.mr_n66112560)
print v(xbgr.mr_n66112672)
print v(xbgr.mr_n66112992)
print v(xbgr.mr_n66113104)
print v(xbgr.mr_n66113424)
print v(xbgr.mr_n66113536)
print v(xbgr.mr_n66113856)
print v(xbgr.mr_n66113968)
print v(xbgr.mr_n66114288)
print v(xbgr.mr_n66114400)
print v(xbgr.mr_n66114720)
print v(xbgr.mr_n66114832)
print v(xbgr.mr_n66115152)
print v(xbgr.mr_n66115264)
print v(xbgr.mr_n66115584)
print v(xbgr.mr_n66115696)
print v(xbgr.mr_n66116016)
print v(xbgr.mr_n66116128)
print v(xbgr.mr_n66116448)
print v(xbgr.mr_n66116560)
print v(xbgr.mr_n66116880)
print v(xbgr.mr_n66116992)
print v(xbgr.mr_n66117312)
print v(xbgr.mr_n66117424)
print v(xbgr.mr_n66117744)
print v(xbgr.mr_n66117856)
print v(xbgr.mr_n66118176)
print v(xbgr.mr_n66118288)
print v(xbgr.mr_n66118608)
print v(xbgr.mr_n66118720)
print v(xbgr.mr_n66119040)
print v(xbgr.mr_n66119152)
print v(xbgr.mr_n66119472)
print v(xbgr.mr_n66119584)
print v(xbgr.mr_n66119904)
print v(xbgr.mr_n66120016)
print v(xbgr.mr_n66120336)
print v(xbgr.mr_n66120448)
print v(xbgr.mr_n66120768)
print v(xbgr.mr_n66120880)
print v(xbgr.mr_n66121200)
print v(xbgr.mr_n66121312)
print v(xbgr.mr_n66121632)
print v(xbgr.mr_n66121744)
print v(xbgr.mr_n66122064)
print v(xbgr.mr_n66122176)
print v(xbgr.mr_n66122496)
print v(xbgr.mr_n66122608)
print v(xbgr.mr_n66122928)
print v(xbgr.mr_n66123040)
print v(xbgr.mr_n66123360)
print v(xbgr.mr_n66123472)
print v(xbgr.mr_n66123792)
print v(xbgr.mr_n66123904)
print v(xbgr.mr_n66124224)
print v(xbgr.mr_n66124336)
print v(xbgr.mr_n66124656)
print v(xbgr.mr_n66124768)
print v(xbgr.mr_n66125088)
print v(xbgr.mr_n66125200)
print v(xbgr.mr_n66125520)
print v(xbgr.mr_n66125632)
print v(xbgr.mr_n66125952)
print v(xbgr.mr_n66126064)
print v(xbgr.mr_n66126384)
print v(xbgr.mr_n66126496)
print v(xbgr.mr_n66126816)
print v(xbgr.mr_n66126928)
print v(xbgr.mr_n66127248)
print v(xbgr.mr_n66127360)
print v(xbgr.mr_n66127680)
print v(xbgr.mr_n66127792)
print v(xbgr.mr_n66128112)
print v(xbgr.mr_n66128224)
print v(xbgr.mr_n66128544)
print v(xbgr.mr_n66128656)
print v(xbgr.mr_n66128976)
print v(xbgr.mr_n66129088)
print v(xbgr.mr_n66129408)
print v(xbgr.mr_n66129520)
print v(xbgr.mr_n66129840)
print v(xbgr.mr_n66129952)
print v(xbgr.mr_n66130272)
print v(xbgr.mr_n66130384)
print v(xbgr.mr_n66130704)
print v(xbgr.mr_n66130816)
print v(xbgr.mr_n66131136)
print v(xbgr.mr_n66131248)
print v(xbgr.mr_n66131568)
print v(xbgr.mr_n66131680)
print v(xbgr.mr_n66132000)
print v(xbgr.mr_n66132112)
print v(xbgr.mr_n66132432)
print v(xbgr.mr_n66132544)
print v(xbgr.mr_n66132864)
print v(xbgr.mr_n66132976)
print v(xbgr.mr_n66133296)
print v(xbgr.mr_n66133408)
print v(xbgr.mr_n66133728)
print v(xbgr.mr_n66133840)
print v(xbgr.mr_n66134160)
print v(xbgr.mr_n66134272)
print v(xbgr.mr_n66134592)
print v(xbgr.mr_n66134704)
print v(xbgr.mr_n66135024)
print v(xbgr.mr_n66135136)
print v(xbgr.mr_n66135456)
print v(xbgr.mr_n66135568)
print v(xbgr.mr_n66135888)
print v(xbgr.mr_n66136000)
print v(xbgr.mr_n66136320)
print v(xbgr.mr_n66136432)
print v(xbgr.mr_n66136752)
print v(xbgr.mr_n66136864)
print v(xbgr.mr_n66137184)
print v(xbgr.mr_n66137296)
print v(xbgr.mr_n66137616)
print v(xbgr.mr_n66137728)
print v(xbgr.mr_n66138048)
print v(xbgr.mr_n66138160)
print v(xbgr.mr_n66138480)
print v(xbgr.mr_n66138592)
print v(xbgr.mr_n66138912)
print v(xbgr.mr_n66139024)
print v(xbgr.mr_n66139344)
print v(xbgr.mr_n66139456)
print v(xbgr.mr_n66139776)
print v(xbgr.mr_n66139888)
print v(xbgr.mr_n66140208)
print v(xbgr.mr_n66140320)
print v(xbgr.mr_n66140640)
print v(xbgr.mr_n66140752)
print v(xbgr.mr_n66141072)
print v(xbgr.mr_n66141184)
print v(xbgr.mr_n66141504)
print v(xbgr.mr_n66141616)
print v(xbgr.mr_n66141936)
print v(xbgr.mr_n66142048)
print v(xbgr.mr_n66142368)
print v(xbgr.mr_n66142480)
print v(xbgr.mr_n66142800)
print v(xbgr.mr_n66142912)
print v(xbgr.mr_n66143232)
print v(xbgr.mr_n66143344)
print v(xbgr.mr_n66143664)
print v(xbgr.mr_n66143776)
print v(xbgr.mr_n66144096)
print v(xbgr.mr_n66144208)
print v(xbgr.mr_n66144528)
print v(xbgr.mr_n66144640)
print v(xbgr.mr_n66144960)
print v(xbgr.mr_n66145072)
print v(xbgr.mr_n66145392)
print v(xbgr.mr_n66145504)
print v(xbgr.mr_n66145824)
print v(xbgr.mr_n66145936)
print v(xbgr.mr_n66146256)
print v(xbgr.mr_n66146368)
print v(xbgr.mr_n66146688)
print v(xbgr.mr_n66146800)
print v(xbgr.mr_n66147120)
print v(xbgr.mr_n66147232)
print v(xbgr.mr_n66147552)
print v(xbgr.mr_n66147664)
print v(xbgr.mr_n66147984)
print v(xbgr.mr_n66148096)
print v(xbgr.mr_n66148416)
print v(xbgr.mr_n66148528)
print v(xbgr.mr_n66148848)
print v(xbgr.mr_n66148960)
print v(xbgr.mr_n66149280)
print v(xbgr.mr_n66149392)
print v(xbgr.mr_n66149712)
print v(xbgr.mr_n66149824)
print v(xbgr.mr_n66150144)
print v(xbgr.mr_n66150256)
print v(xbgr.mr_n66150576)
print v(xbgr.mr_n66150688)
print v(xbgr.mr_n66151008)
print v(xbgr.mr_n66151120)
print v(xbgr.mr_n66151440)
print v(xbgr.mr_n66151552)
print v(xbgr.mr_n66151872)
print v(xbgr.mr_n66151984)
print v(xbgr.mr_n66152304)
print v(xbgr.mr_n66152416)
print v(xbgr.mr_n66152736)
print v(xbgr.mr_n66152848)
print v(xbgr.mr_n66153168)
print v(xbgr.mr_n66153280)
print v(xbgr.mr_n66153600)
print v(xbgr.mr_n66153712)
print v(xbgr.mr_n66154032)
print v(xbgr.mr_n66154240)
print v(xbgr.mr_n66154480)
print v(xbgr.mr_n66155344)
print v(xbgr.mr_n66155456)
print v(xbgr.mr_n66155776)
print v(xbgr.mr_n66155888)
print v(xbgr.mr_n66156208)
print v(xbgr.mr_n66156320)
print v(xbgr.mr_n66156640)
print v(xbgr.mr_n66156752)
print v(xbgr.mr_n66157072)
print v(xbgr.mr_n66157184)
print v(xbgr.mr_n66157504)
print v(xbgr.mr_n66157616)
print v(xbgr.mr_n66157936)
print v(xbgr.mr_n66158800)
print v(xbgr.mr_n66159664)
print v(xbgr.mr_n66160528)
print v(xbgr.mr_n66160640)
print v(xbgr.mr_n66161392)
print v(xbgr.mr_n66161504)
print v(xbgr.mr_n66161824)
print v(xbgr.mr_n66162688)
print v(xbgr.mr_n66163552)
print v(xbgr.mr_n66164416)
print v(xbgr.mr_n66165280)
print v(xbgr.mr_n66165824)
print v(xbgr.mr_n66166576)
print v(xbgr.mr_n66167120)
print v(xbgr.mr_n66167552)
print v(xbgr.mr_n66168304)
print v(xbgr.mr_n66168416)
print v(xbgr.mr_n66168736)
print v(xbgr.mr_n66168848)
print v(xbgr.mr_n66169168)
print v(xbgr.mr_n66170032)
print v(xbgr.mr_n66170896)
print v(xbgr.mr_n66171760)
print v(xbgr.mr_n66171872)
print v(xbgr.mr_n66172192)
print v(xbgr.mr_n66172304)
print v(xbgr.mr_n66172736)
print v(xbgr.mr_n66173056)
print v(xbgr.mr_n66173168)
print v(xbgr.mr_n66173488)
print v(xbgr.mr_n66174352)
print v(xbgr.mr_n66174464)
print v(xbgr.mr_n66174896)
print v(xbgr.mr_n66175216)
print v(xbgr.mr_n66175328)
print v(xbgr.mr_n66175648)
print v(xbgr.mr_n66175760)
print v(xbgr.mr_n66176080)
print v(xbgr.mr_n66176192)
print v(xbgr.mr_n66176512)
print v(xbgr.mr_n66176624)
print v(xbgr.mr_n66176944)
print v(xbgr.mr_n66177920)
print v(xbgr.mr_n66178240)
print v(xbgr.mr_n66178352)
print v(xbgr.mr_n66178672)
print v(xbgr.mr_n66178784)
print v(xbgr.mr_n66179104)
print v(xbgr.mr_n66179216)
print v(xbgr.mr_n66179536)
print v(xbgr.mr_n66179648)
print v(xbgr.mr_n66179968)
print v(xbgr.mr_n66180400)
print v(xbgr.mr_n66181376)
print v(xbgr.mr_n66181696)
print v(xbgr.mr_n66182560)
print v(xbgr.mr_n66183424)
print v(xbgr.mr_n66183536)
print v(xbgr.mr_n66184288)
print v(xbgr.mr_n66185152)
print v(xbgr.mr_n66185264)
print v(xbgr.mr_n66185584)
print v(xbgr.mr_n66186448)
print v(xbgr.mr_n66186560)
print v(xbgr.mr_n66186880)
print v(xbgr.mr_n66186992)
print v(xbgr.mr_n66187312)
print v(xbgr.mr_n66188176)
print v(xbgr.mr_n66188288)
print v(xbgr.mr_n66188608)
print v(xbgr.mr_n66188720)
print v(xbgr.mr_n66189040)
print v(xbgr.mr_n66189152)
print v(xbgr.mr_n66189472)
print v(xbgr.mr_n66189584)
print v(xbgr.mr_n66189904)
print v(xbgr.mr_n66190880)
print v(xbgr.mr_n66191312)
print v(xbgr.mr_n66191632)
print v(xbgr.mr_n66192496)
print v(xbgr.mr_n66193360)
print v(xbgr.mr_n66193472)
print v(xbgr.mr_n66193792)
print v(xbgr.mr_n66193904)
print v(xbgr.mr_n66194224)
print v(xbgr.mr_n66194336)
print v(xbgr.mr_n66194656)
print v(xbgr.mr_n66194768)
print v(xbgr.mr_n66195200)
print v(xbgr.mr_n66195632)
print v(xbgr.mr_n66195952)
print v(xbgr.mr_n66196064)
print v(xbgr.mr_n66196384)
print v(xbgr.mr_n66196496)
print v(xbgr.mr_n66196816)
print v(xbgr.mr_n66196928)
print v(xbgr.mr_n66197248)
print v(xbgr.mr_n66197360)
print v(xbgr.mr_n66197680)
print v(xbgr.mr_n66198544)
print v(xbgr.mr_n66199408)
print v(xbgr.mr_n66199520)
print v(xbgr.mr_n66199840)
print v(xbgr.mr_n66200704)
print v(xbgr.mr_n66201568)
print v(xbgr.mr_n66201680)
print v(xbgr.mr_n66202000)
print v(xbgr.mr_n66202112)
print v(xbgr.mr_n66202544)
print v(xbgr.mr_n66202864)
print v(xbgr.mr_n66202976)
print v(xbgr.mr_n66203408)
print v(xbgr.mr_n66203728)
print v(xbgr.mr_n66204160)
print v(xbgr.mr_n66204272)
print v(xbgr.mr_n66204592)
print v(xbgr.mr_n66204704)
print v(xbgr.mr_n66205024)
print v(xbgr.mr_n66205456)
print v(xbgr.mr_n66205568)
print v(xbgr.mr_n66206320)
print v(xbgr.mr_n66206432)
print v(xbgr.mr_n66206752)
print v(xbgr.mr_n66206864)
print v(xbgr.mr_n66207184)
print v(xbgr.mr_n66207616)
print v(xbgr.mr_n66207728)
print v(xbgr.mr_n66208048)
print v(xbgr.mr_n66208480)
print v(xbgr.mr_n66209344)
print v(xbgr.mr_n66211072)
print v(xbgr.mr_n66211184)
print v(xbgr.mr_n66211504)
print v(xbgr.mr_n66211616)
print v(xbgr.mr_n66211936)
print v(xbgr.mr_n66212048)
print v(xbgr.mr_n66212480)
print v(xbgr.mr_n66212912)
print v(xbgr.mr_n66213232)
print v(xbgr.mr_n66213344)
print v(xbgr.mr_n66213664)
print v(xbgr.mr_n66215072)
print v(xbgr.mr_n66215392)
print v(xbgr.mr_n66216368)
print v(xbgr.mr_n66216688)
print v(xbgr.mr_n66216800)
print v(xbgr.mr_n66217120)
print v(xbgr.mr_n66217232)
print v(xbgr.mr_n66217664)
print v(xbgr.mr_n66217984)
print v(xbgr.mr_n66218096)
print v(xbgr.mr_n66218528)
print v(xbgr.mr_n66218848)
print v(xbgr.mr_n66218960)
print v(xbgr.mr_n66219280)
print v(xbgr.mr_n66219392)
print v(xbgr.mr_n66219712)
print v(xbgr.mr_n66220576)
print v(xbgr.mr_n66221008)
print v(xbgr.mr_n66221872)
print v(xbgr.mr_n66221984)
print v(xbgr.mr_n66222304)
print v(xbgr.mr_n66222416)
print v(xbgr.mr_n66222736)
print v(xbgr.mr_n66222848)
print v(xbgr.mr_n66223600)
print v(xbgr.mr_n66224032)
print v(xbgr.mr_n66224144)
print v(xbgr.mr_n66224464)
print v(xbgr.mr_n66224896)
print v(xbgr.mr_n66225008)
print v(xbgr.mr_n66225328)
print v(xbgr.mr_n66225440)
print v(xbgr.mr_n66225760)
print v(xbgr.mr_n66225872)
print v(xbgr.mr_n66226192)
print v(xbgr.mr_n66226304)
print v(xbgr.mr_n66226624)
print v(xbgr.mr_n66226736)
print v(xbgr.mr_n66227056)
print v(xbgr.mr_n66228464)
print v(xbgr.mr_n66228784)
print v(xbgr.mr_n66228896)
print v(xbgr.mr_n66229328)
print v(xbgr.mr_n66229648)
print v(xbgr.mr_n66229760)
print v(xbgr.mr_n66230080)
print v(xbgr.mr_n66230512)
print v(xbgr.mr_n66231376)
print v(xbgr.mr_n66232240)
print v(xbgr.mr_n66233104)
print v(xbgr.mr_n66233968)
print v(xbgr.mr_n66234832)
print v(xbgr.mr_n66236128)
print v(xbgr.mr_n66236560)
print v(xbgr.mr_n66236672)
print v(xbgr.mr_n66236992)
print v(xbgr.mr_n66237424)
print v(xbgr.mr_n66237536)
print v(xbgr.mr_n66237856)
print v(xbgr.mr_n66238720)
print v(xbgr.mr_n66238832)
print v(xbgr.mr_n66239152)
print v(xbgr.mr_n66239264)
print v(xbgr.mr_n66239584)
print v(xbgr.mr_n66240448)
print v(xbgr.mr_n66240560)
print v(xbgr.mr_n66241424)
print v(xbgr.mr_n66241856)
print v(xbgr.mr_n66242288)
print v(xbgr.mr_n66243040)
print v(xbgr.mr_n66243152)
print v(xbgr.mr_n66243584)
print v(xbgr.mr_n66244336)
print v(xbgr.mr_n66244768)
print v(xbgr.mr_n66244880)
print v(xbgr.mr_n66245312)
print v(xbgr.mr_n66246064)
print v(xbgr.mr_n66246176)
print v(xbgr.mr_n66246496)
print v(xbgr.mr_n66246608)
print v(xbgr.mr_n66246928)
print v(xbgr.mr_n66247040)
print v(xbgr.mr_n66247360)
print v(xbgr.mr_n66247472)
print v(xbgr.mr_n66247792)
print v(xbgr.mr_n66247904)
print v(xbgr.mr_n66248224)
print v(xbgr.mr_n66248336)
print v(xbgr.mr_n66248656)
print v(xbgr.mr_n66248768)
print v(xbgr.mr_n66249088)
print v(xbgr.mr_n66249200)
print v(xbgr.mr_n66249520)
print v(xbgr.mr_n66249632)
print v(xbgr.mr_n66249952)
print v(xbgr.mr_n66250064)
print v(xbgr.mr_n66250384)
print v(xbgr.mr_n66250496)
print v(xbgr.mr_n66250816)
print v(xbgr.mr_n66250928)
print v(xbgr.mr_n66251248)
print v(xbgr.mr_n66251360)
print v(xbgr.mr_n66251680)
print v(xbgr.mr_n66251792)
print v(xbgr.mr_n66252224)
print v(xbgr.mr_n66252544)
print v(xbgr.mr_n66252656)
print v(xbgr.mr_n66253088)
print v(xbgr.mr_n66253408)
print v(xbgr.mr_n66253520)
print v(xbgr.mr_n66254272)
print v(xbgr.mr_n66254704)
print v(xbgr.mr_n66255568)
print v(xbgr.mr_n66256432)
print v(xbgr.mr_n66257296)
print v(xbgr.mr_n66257408)
print v(xbgr.mr_n66257728)
print v(xbgr.mr_n66257840)
print v(xbgr.mr_n66258160)
print v(xbgr.mr_n66258272)
print v(xbgr.mr_n66258592)
print v(xbgr.mr_n66258704)
print v(xbgr.mr_n66259456)
print v(xbgr.mr_n66260320)
print v(xbgr.mr_n66261184)
print v(xbgr.mr_n66262048)
print v(xbgr.mr_n66263344)
print v(xbgr.mr_n66263456)
print v(xbgr.mr_n66263776)
print v(xbgr.mr_n66263888)
print v(xbgr.mr_n66264208)
print v(xbgr.mr_n66264320)
print v(xbgr.mr_n66264752)
print v(xbgr.mr_n66265184)
print v(xbgr.mr_n66265616)
print v(xbgr.mr_n66265936)
print v(xbgr.mr_n66266048)
print v(xbgr.mr_n66266480)
print v(xbgr.mr_n66266800)
print v(xbgr.mr_n66266912)
print v(xbgr.mr_n66267232)
print v(xbgr.mr_n66267344)
print v(xbgr.mr_n66267664)
print v(xbgr.mr_n66267776)
print v(xbgr.mr_n66268096)
print v(xbgr.mr_n66268208)
print v(xbgr.mr_n66268528)
print v(xbgr.mr_n66268640)
print v(xbgr.mr_n66269072)
print v(xbgr.mr_n66269392)
print v(xbgr.mr_n66269504)
print v(xbgr.mr_n66269936)
print v(xbgr.mr_n66270256)
print v(xbgr.mr_n66270688)
print v(xbgr.mr_n66270800)
print v(xbgr.mr_n66271232)
print v(xbgr.mr_n66271552)
print v(xbgr.mr_n66271664)
print v(xbgr.mr_n66272096)
print v(xbgr.mr_n66272416)
print v(xbgr.mr_n66272528)
print v(xbgr.mr_n66272960)
print v(xbgr.mr_n66273280)
print v(xbgr.mr_n66273392)
print v(xbgr.mr_n66273712)
print v(xbgr.mr_n66273824)
print v(xbgr.mr_n66274144)
print v(xbgr.mr_n66275008)
print v(xbgr.mr_n66275872)
print v(xbgr.mr_n66276736)
print v(xbgr.mr_n66277600)
print v(xbgr.mr_n66278464)
print v(xbgr.mr_n66279328)
print v(xbgr.mr_n66279440)
print v(xbgr.mr_n66280192)
print v(xbgr.mr_n66281056)
print v(xbgr.mr_n66281920)
print v(xbgr.mr_n66282784)
print v(xbgr.mr_n66283648)
print v(xbgr.mr_n66284512)
print v(xbgr.mr_n66284624)
print v(xbgr.mr_n66284944)
print v(xbgr.mr_n66285056)
print v(xbgr.mr_n66285376)
print v(xbgr.mr_n66285488)
print v(xbgr.mr_n66285808)
print v(xbgr.mr_n66285920)
print v(xbgr.mr_n66286240)
print v(xbgr.mr_n66287104)
print v(xbgr.mr_n66287968)
print v(xbgr.mr_n66288832)
print v(xbgr.mr_n66288944)
print v(xbgr.mr_n66289264)
print v(xbgr.mr_n66289376)
print v(xbgr.mr_n66289696)
print v(xbgr.mr_n66289808)
print v(xbgr.mr_n66290128)
print v(xbgr.mr_n66290992)
print v(xbgr.mr_n66291856)
print v(xbgr.mr_n66292720)
print v(xbgr.mr_n66292832)
print v(xbgr.mr_n66293152)
print v(xbgr.mr_n66293264)
print v(xbgr.mr_n66293584)
print v(xbgr.mr_n66293696)
print v(xbgr.mr_n66294128)
print v(xbgr.mr_n66294560)
print v(xbgr.mr_n66294992)
print v(xbgr.mr_n66295312)
print v(xbgr.mr_n66295424)
print v(xbgr.mr_n66295744)
print v(xbgr.mr_n66295856)
print v(xbgr.mr_n66296176)
print v(xbgr.mr_n66296288)
print v(xbgr.mr_n66296608)
print v(xbgr.mr_n66296720)
print v(xbgr.mr_n66297040)
print v(xbgr.mr_n66297152)
print v(xbgr.mr_n66297472)
print v(xbgr.mr_n66297584)
print v(xbgr.mr_n66297904)
print v(xbgr.mr_n66298016)
print v(xbgr.mr_n66298336)
print v(xbgr.mr_n66298448)
print v(xbgr.mr_n66298768)
print v(xbgr.mr_n66298880)
print v(xbgr.mr_n66299312)
print v(xbgr.mr_n66299632)
print v(xbgr.mr_n66299744)
print v(xbgr.mr_n66300064)
print v(xbgr.mr_n66300496)
print v(xbgr.mr_n66300608)
print v(xbgr.mr_n66300928)
print v(xbgr.mr_n66301040)
print v(xbgr.mr_n66301360)
print v(xbgr.mr_n66301472)
print v(xbgr.mr_n66301792)
print v(xbgr.mr_n66301904)
print v(xbgr.mr_n66302656)
print v(xbgr.mr_n66302768)
print v(xbgr.mr_n66303520)
print v(xbgr.mr_n66304384)
print v(xbgr.mr_n66304496)
print v(xbgr.mr_n66304816)
print v(xbgr.mr_n66304928)
print v(xbgr.mr_n66305248)
print v(xbgr.mr_n66305360)
print v(xbgr.mr_n66305680)
print v(xbgr.mr_n66305792)
print v(xbgr.mr_n66306224)
print v(xbgr.mr_n66306656)
print v(xbgr.mr_n66306976)
print v(xbgr.mr_n66307088)
print v(xbgr.mr_n66307408)
print v(xbgr.mr_n66307520)
print v(xbgr.mr_n66307840)
print v(xbgr.mr_n66308704)
print v(xbgr.mr_n66310000)
print v(xbgr.mr_n66310864)
print v(xbgr.mr_n66310976)
print v(xbgr.mr_n66311296)
print v(xbgr.mr_n66311408)
print v(xbgr.mr_n66311728)
print v(xbgr.mr_n66311840)
print v(xbgr.mr_n66312160)
print v(xbgr.mr_n66312272)
print v(xbgr.mr_n66312704)
print v(xbgr.mr_n66313024)
print v(xbgr.mr_n66313136)
print v(xbgr.mr_n66313456)
print v(xbgr.mr_n66313568)
print v(xbgr.mr_n66313888)
print v(xbgr.mr_n66314000)
print v(xbgr.mr_n66314432)
print v(xbgr.mr_n66314752)
print v(xbgr.mr_n66314864)
print v(xbgr.mr_n66315184)
print v(xbgr.mr_n66315296)
print v(xbgr.mr_n66315616)
print v(xbgr.mr_n66316480)
print v(xbgr.mr_n66317344)
print v(xbgr.mr_n66318208)
print v(xbgr.mr_n66319072)
print v(xbgr.mr_n66319184)
print v(xbgr.mr_n66319504)
print v(xbgr.mr_n66319616)
print v(xbgr.mr_n66320048)
print v(xbgr.mr_n66320480)
print v(xbgr.mr_n66320800)
print v(xbgr.mr_n66320912)
print v(xbgr.mr_n66321232)
print v(xbgr.mr_n66322096)
print v(xbgr.mr_n66322960)
print v(xbgr.mr_n66323072)
print v(xbgr.mr_n66323392)
print v(xbgr.mr_n66323504)
print v(xbgr.mr_n66323824)
print v(xbgr.mr_n66323936)
print v(xbgr.mr_n66324256)
print v(xbgr.mr_n66324368)
print v(xbgr.mr_n66324688)
print v(xbgr.mr_n66324800)
print v(xbgr.mr_n66325232)
print v(xbgr.mr_n66325552)
print v(xbgr.mr_n66325664)
print v(xbgr.mr_n66326416)
print v(xbgr.mr_n66327280)
print v(xbgr.mr_n66327392)
print v(xbgr.mr_n66327712)
print v(xbgr.mr_n66327824)
print v(xbgr.mr_n66328256)
print v(xbgr.mr_n66328576)
print v(xbgr.mr_n66328688)
print v(xbgr.mr_n66329008)
print v(xbgr.mr_n66329120)
print v(xbgr.mr_n66329440)
print v(xbgr.mr_n66329552)
print v(xbgr.mr_n66329872)
print v(xbgr.mr_n66329984)
print v(xbgr.mr_n66330304)
print v(xbgr.mr_n66330416)
print v(xbgr.mr_n66330736)
print v(xbgr.mr_n66331600)
print v(xbgr.mr_n66332576)
print v(xbgr.mr_n66332896)
print v(xbgr.mr_n66333760)
print v(xbgr.mr_n66334624)
print v(xbgr.mr_n66335488)
print v(xbgr.mr_n66335920)
print v(xbgr.mr_n66336352)
print v(xbgr.mr_n66336464)
print v(xbgr.mr_n66336784)
print v(xbgr.mr_n66336896)
print v(xbgr.mr_n66337216)
print v(xbgr.mr_n66337328)
print v(xbgr.mr_n66337648)
print v(xbgr.mr_n66337760)
print v(xbgr.mr_n66338080)
print v(xbgr.mr_n66338192)
print v(xbgr.mr_n66338512)
print v(xbgr.mr_n66338624)
print v(xbgr.mr_n66338944)
print v(xbgr.mr_n66339808)
print v(xbgr.mr_n66340672)
print v(xbgr.mr_n66340784)
print v(xbgr.mr_n66341104)
print v(xbgr.mr_n66341216)
print v(xbgr.mr_n66341536)
print v(xbgr.mr_n66341648)
print v(xbgr.mr_n66341968)
print v(xbgr.mr_n66342080)
print v(xbgr.mr_n66343696)
print v(xbgr.mr_n66344560)
print v(xbgr.mr_n66344672)
print v(xbgr.mr_n66344992)
print v(xbgr.mr_n66345104)
print v(xbgr.mr_n66345424)
print v(xbgr.mr_n66345856)
print v(xbgr.mr_n66345968)
print v(xbgr.mr_n66346288)
print v(xbgr.mr_n66346400)
print v(xbgr.mr_n66346720)
print v(xbgr.mr_n66346832)
print v(xbgr.mr_n66347264)
print v(xbgr.mr_n66347584)
print v(xbgr.mr_n66347696)
print v(xbgr.mr_n66348128)
print v(xbgr.mr_n66348880)
print v(xbgr.mr_n66349744)
print v(xbgr.mr_n66351040)
print v(xbgr.mr_n66351152)
print v(xbgr.mr_n66351584)
print v(xbgr.mr_n66351904)
print v(xbgr.mr_n66352768)
print v(xbgr.mr_n66353632)
print v(xbgr.mr_n66354064)
print v(xbgr.mr_n66355360)
print v(xbgr.mr_n66356224)
print v(xbgr.mr_n66356656)
print v(xbgr.mr_n66357520)
print v(xbgr.mr_n66358816)
print v(xbgr.mr_n66358928)
print v(xbgr.mr_n66359248)
print v(xbgr.mr_n66359360)
print v(xbgr.mr_n66359680)
print v(xbgr.mr_n66359792)
print v(xbgr.mr_n66360112)
print v(xbgr.mr_n66360224)
print v(xbgr.mr_n66360544)
print v(xbgr.mr_n66360656)
print v(xbgr.mr_n66360976)
print v(xbgr.mr_n66361088)
print v(xbgr.mr_n66361408)
print v(xbgr.mr_n66361520)
print v(xbgr.mr_n66362272)
print v(xbgr.mr_n66362384)
print v(xbgr.mr_n66362816)
print v(xbgr.mr_n66363136)
print v(xbgr.mr_n66363248)
print v(xbgr.mr_n66363568)
print v(xbgr.mr_n66363680)
print v(xbgr.mr_n66364000)
print v(xbgr.mr_n66364112)
print v(xbgr.mr_n66364432)
print v(xbgr.mr_n66364544)
print v(xbgr.mr_n66364864)
print v(xbgr.mr_n66364976)
print v(xbgr.mr_n66365408)
print v(xbgr.mr_n66365728)
print v(xbgr.mr_n66366272)
print v(xbgr.mr_n66366592)
print v(xbgr.mr_n66366704)
print v(xbgr.mr_n66367136)
print v(xbgr.mr_n66367456)
print v(xbgr.mr_n66367568)
print v(xbgr.mr_n66368000)
print v(xbgr.mr_n66368320)
print v(xbgr.mr_n66368432)
print v(xbgr.mr_n66368752)
print v(xbgr.mr_n66368864)
print v(xbgr.mr_n66369184)
print v(xbgr.mr_n66369296)
print v(xbgr.mr_n66369616)
print v(xbgr.mr_n66369728)
print v(xbgr.mr_n66370048)
print v(xbgr.mr_n66370160)
print v(xbgr.mr_n66370480)
print v(xbgr.mr_n66370592)
print v(xbgr.mr_n66370912)
print v(xbgr.mr_n66371024)
print v(xbgr.mr_n66371344)
print v(xbgr.mr_n66371456)
print v(xbgr.mr_n66371776)
print v(xbgr.mr_n66372640)
print v(xbgr.mr_n66372752)
print v(xbgr.mr_n66373072)
print v(xbgr.mr_n66373184)
print v(xbgr.mr_n66373504)
print v(xbgr.mr_n66373616)
print v(xbgr.mr_n66373936)
print v(xbgr.mr_n66374048)
print v(xbgr.mr_n66374368)
print v(xbgr.mr_n66375232)
print v(xbgr.mr_n66376096)
print v(xbgr.mr_n66376960)
print v(xbgr.mr_n66377504)
print v(xbgr.mr_n66377936)
print v(xbgr.mr_n66378256)
print v(xbgr.mr_n66378368)
print v(xbgr.mr_n66378688)
print v(xbgr.mr_n66378800)
print v(xbgr.mr_n66379120)
print v(xbgr.mr_n66379232)
print v(xbgr.mr_n66379552)
print v(xbgr.mr_n66379664)
print v(xbgr.mr_n66379984)
print v(xbgr.mr_n66381280)
print v(xbgr.mr_n66382144)
print v(xbgr.mr_n66383120)
print v(xbgr.mr_n66383552)
print v(xbgr.mr_n66383872)
print v(xbgr.mr_n66384304)
print v(xbgr.mr_n66385168)
print v(xbgr.mr_n66386032)
print v(xbgr.mr_n66386144)
print v(xbgr.mr_n66386464)
print v(xbgr.mr_n66386576)
print v(xbgr.mr_n66386896)
print v(xbgr.mr_n66387008)
print v(xbgr.mr_n66387328)
print v(xbgr.mr_n66387440)
print v(xbgr.mr_n66388624)
print v(xbgr.mr_n66388736)
print v(xbgr.mr_n66389056)
print v(xbgr.mr_n66389168)
print v(xbgr.mr_n66389488)
print v(xbgr.mr_n66389600)
print v(xbgr.mr_n66390032)
print v(xbgr.mr_n66390352)
print v(xbgr.mr_n66390784)
print v(xbgr.mr_n66390896)
print v(xbgr.mr_n66391328)
print v(xbgr.mr_n66391648)
print v(xbgr.mr_n66392512)
print v(xbgr.mr_n66392624)
print v(xbgr.mr_n66393056)
print v(xbgr.mr_n66393376)
print v(xbgr.mr_n66393488)
print v(xbgr.mr_n66394240)
print v(xbgr.mr_n66394784)
print v(xbgr.mr_n66395104)
print v(xbgr.mr_n66395216)
print v(xbgr.mr_n66395536)
print v(xbgr.mr_n66395648)
print v(xbgr.mr_n66395968)
print v(xbgr.mr_n66396080)
print v(xbgr.mr_n66396400)
print v(xbgr.mr_n66396832)
print v(xbgr.mr_n66396944)
print v(xbgr.mr_n66397264)
print v(xbgr.mr_n66397376)
print v(xbgr.mr_n66397696)
print v(xbgr.mr_n66397808)
print v(xbgr.mr_n66398560)
print v(xbgr.mr_n66398672)
print v(xbgr.mr_n66399104)
print v(xbgr.mr_n66399424)
print v(xbgr.mr_n66399536)
print v(xbgr.mr_n66399856)
print v(xbgr.mr_n66399968)
print v(xbgr.mr_n66400288)
print v(xbgr.mr_n66400400)
print v(xbgr.mr_n66400720)
print v(xbgr.mr_n66401584)
print v(xbgr.mr_n66402016)
print v(xbgr.mr_n66402448)
print v(xbgr.mr_n66402560)
print v(xbgr.mr_n66402880)
print v(xbgr.mr_n66402992)
print v(xbgr.mr_n66403744)
print v(xbgr.mr_n66403856)
print v(xbgr.mr_n66404176)
print v(xbgr.mr_n66404288)
print v(xbgr.mr_n66405040)
print v(xbgr.mr_n66405904)
print v(xbgr.mr_n66406016)
print v(xbgr.mr_n66406336)
print v(xbgr.mr_n66407200)
print v(xbgr.mr_n66407312)
print v(xbgr.mr_n66407632)
print v(xbgr.mr_n66407744)
print v(xbgr.mr_n66408064)
print v(xbgr.mr_n66408176)
print v(xbgr.mr_n66408496)
print v(xbgr.mr_n66408608)
print v(xbgr.mr_n66408928)
print v(xbgr.mr_n66409040)
print v(xbgr.mr_n66409360)
print v(xbgr.mr_n66409472)
print v(xbgr.mr_n66409792)
print v(xbgr.mr_n66409904)
print v(xbgr.mr_n66410336)
print v(xbgr.mr_n66410768)
print v(xbgr.mr_n66411088)
print v(xbgr.mr_n66411520)
print v(xbgr.mr_n66411632)
print v(xbgr.mr_n66412816)
print v(xbgr.mr_n66414544)
print v(xbgr.mr_n66414656)
print v(xbgr.mr_n66415088)
print v(xbgr.mr_n66415408)
print v(xbgr.mr_n66415520)
print v(xbgr.mr_n66415840)
print v(xbgr.mr_n66415952)
print v(xbgr.mr_n66416384)
print v(xbgr.mr_n66416704)
print v(xbgr.mr_n66416816)
print v(xbgr.mr_n66417136)
print v(xbgr.mr_n66417568)
print v(xbgr.mr_n66417680)
print v(xbgr.mr_n66418432)
print v(xbgr.mr_n66418544)
print v(xbgr.mr_n66418864)
print v(xbgr.mr_n66418976)
print v(xbgr.mr_n66419296)
print v(xbgr.mr_n66419408)
print v(xbgr.mr_n66419728)
print v(xbgr.mr_n66419840)
print v(xbgr.mr_n66420160)
print v(xbgr.mr_n66420272)
print v(xbgr.mr_n66420592)
print v(xbgr.mr_n66421456)
print v(xbgr.mr_n66422320)
print v(xbgr.mr_n66423184)
print v(xbgr.mr_n66423296)
print v(xbgr.mr_n66423616)
print v(xbgr.mr_n66424048)
print v(xbgr.mr_n66424160)
print v(xbgr.mr_n66424480)
print v(xbgr.mr_n66424592)
print v(xbgr.mr_n66424912)
print v(xbgr.mr_n66425024)
print v(xbgr.mr_n66425344)
print v(xbgr.mr_n66426208)
print v(xbgr.mr_n66427184)
print v(xbgr.mr_n66427504)
print v(xbgr.mr_n66427616)
print v(xbgr.mr_n66427936)
print v(xbgr.mr_n66428048)
print v(xbgr.mr_n66428368)
print v(xbgr.mr_n66428480)
print v(xbgr.mr_n66428800)
print v(xbgr.mr_n66428912)
print v(xbgr.mr_n66429232)
print v(xbgr.mr_n66429776)
print v(xbgr.mr_n66430208)
print v(xbgr.mr_n66430640)
print v(xbgr.mr_n66431824)
print v(xbgr.mr_n66431936)
print v(xbgr.mr_n66432256)
print v(xbgr.mr_n66432368)
print v(xbgr.mr_n66432688)
print v(xbgr.mr_n66433552)
print v(xbgr.mr_n66433664)
print v(xbgr.mr_n66433984)
print v(xbgr.mr_n66434096)
print v(xbgr.mr_n66434416)
print v(xbgr.mr_n66434848)
print v(xbgr.mr_n66435712)
print v(xbgr.mr_n66437008)
print v(xbgr.mr_n66437120)
print v(xbgr.mr_n66437440)
print v(xbgr.mr_n66437552)
print v(xbgr.mr_n66437872)
print v(xbgr.mr_n66438304)
print v(xbgr.mr_n66439168)
print v(xbgr.mr_n66439600)
print v(xbgr.mr_n66439712)
print v(xbgr.mr_n66440032)
print v(xbgr.mr_n66440144)
print v(xbgr.mr_n66440464)
print v(xbgr.mr_n66440576)
print v(xbgr.mr_n66440896)
print v(xbgr.mr_n66441008)
print v(xbgr.mr_n66441760)
print v(xbgr.mr_n66441872)
print v(xbgr.mr_n66442624)
print v(xbgr.mr_n66443600)
print v(xbgr.mr_n66443920)
print v(xbgr.mr_n66444032)
print v(xbgr.mr_n66444352)
print v(xbgr.mr_n66444464)
print v(xbgr.mr_n66444784)
print v(xbgr.mr_n66445216)
print v(xbgr.mr_n66446080)
print v(xbgr.mr_n66446192)
print v(xbgr.mr_n66446512)
print v(xbgr.mr_n66446624)
print v(xbgr.mr_n66446944)
print v(xbgr.mr_n66447056)
print v(xbgr.mr_n66447376)
print v(xbgr.mr_n66447488)
print v(xbgr.mr_n66447808)
print v(xbgr.mr_n66447920)
print v(xbgr.mr_n66448352)
print v(xbgr.mr_n66449104)
print v(xbgr.mr_n66450080)
print v(xbgr.mr_n66450512)
print v(xbgr.mr_n66450832)
print v(xbgr.mr_n66451264)
print v(xbgr.mr_n66452240)
print v(xbgr.mr_n66452672)
print v(xbgr.mr_n66452992)
print v(xbgr.mr_n66453424)
print v(xbgr.mr_n66453536)
print v(xbgr.mr_n66453856)
print v(xbgr.mr_n66453968)
print v(xbgr.mr_n66454288)
print v(xbgr.mr_n66454400)
print v(xbgr.mr_n66454720)
print v(xbgr.mr_n66454832)
print v(xbgr.mr_n66455584)
print v(xbgr.mr_n66456448)
print v(xbgr.mr_n66457744)
print v(xbgr.mr_n66457856)
print v(xbgr.mr_n66458176)
print v(xbgr.mr_n66458288)
print v(xbgr.mr_n66458608)
print v(xbgr.mr_n66458720)
print v(xbgr.mr_n66459040)
print v(xbgr.mr_n66459152)
print v(xbgr.mr_n66459472)
print v(xbgr.mr_n66459584)
print v(xbgr.mr_n66459904)
print v(xbgr.mr_n66460336)
print v(xbgr.mr_n66460448)
print v(xbgr.mr_n66460768)
print v(xbgr.mr_n66460880)
print v(xbgr.mr_n66461200)
print v(xbgr.mr_n66461312)
print v(xbgr.mr_n66461632)
print v(xbgr.mr_n66461744)
print v(xbgr.mr_n66462064)
print v(xbgr.mr_n66462176)
print v(xbgr.mr_n66462496)
print v(xbgr.mr_n66462608)
print v(xbgr.mr_n66462928)
print v(xbgr.mr_n66463040)
print v(xbgr.mr_n66463360)
print v(xbgr.mr_n66463472)
print v(xbgr.mr_n66463792)
print v(xbgr.mr_n66463904)
print v(xbgr.mr_n66464336)
print v(xbgr.mr_n66464656)
print v(xbgr.mr_n66464768)
print v(xbgr.mr_n66465200)
print v(xbgr.mr_n66465632)
print v(xbgr.mr_n66465952)
print v(xbgr.mr_n66466064)
print v(xbgr.mr_n66466384)
print v(xbgr.mr_n66466496)
print v(xbgr.mr_n66466816)
print v(xbgr.mr_n66466928)
print v(xbgr.mr_n66467248)
print v(xbgr.mr_n66467360)
print v(xbgr.mr_n66468112)
print v(xbgr.mr_n66468224)
print v(xbgr.mr_n66468656)
print v(xbgr.mr_n66468976)
print v(xbgr.mr_n66469520)
print v(xbgr.mr_n66469840)
print v(xbgr.mr_n66470704)
print v(xbgr.mr_n66470816)
print v(xbgr.mr_n66471136)
print v(xbgr.mr_n66471568)
print v(xbgr.mr_n66472000)
print v(xbgr.mr_n66472432)
print v(xbgr.mr_n66472544)
print v(xbgr.mr_n66473296)
print v(xbgr.mr_n66473408)
print v(xbgr.mr_n66473728)
print v(xbgr.mr_n66473840)
print v(xbgr.mr_n66474160)
print v(xbgr.mr_n66474592)
print v(xbgr.mr_n66474704)
print v(xbgr.mr_n66475024)
print v(xbgr.mr_n66475136)
print v(xbgr.mr_n66475456)
print v(xbgr.mr_n66475568)
print v(xbgr.mr_n66475888)
print v(xbgr.mr_n66476320)
print v(xbgr.mr_n66477184)
print v(xbgr.mr_n66478048)
print v(xbgr.mr_n66479344)
print v(xbgr.mr_n66480208)
print v(xbgr.mr_n66481072)
print v(xbgr.mr_n66481936)
print v(xbgr.mr_n66482048)
print v(xbgr.mr_n66482368)
print v(xbgr.mr_n66483232)
print v(xbgr.mr_n66484096)
print v(xbgr.mr_n66484960)
print v(xbgr.mr_n66485072)
print v(xbgr.mr_n66485392)
print v(xbgr.mr_n66485504)
print v(xbgr.mr_n66485824)
print v(xbgr.mr_n66485936)
print v(xbgr.mr_n66486256)
print v(xbgr.mr_n66486368)
print v(xbgr.mr_n66486688)
print v(xbgr.mr_n66486800)
print v(xbgr.mr_n66487120)
print v(xbgr.mr_n66487232)
print v(xbgr.mr_n66488848)
print v(xbgr.mr_n66489824)
print v(xbgr.mr_n66490256)
print v(xbgr.mr_n66490688)
print v(xbgr.mr_n66491008)
print v(xbgr.mr_n66491120)
print v(xbgr.mr_n66491440)
print v(xbgr.mr_n66491552)
print v(xbgr.mr_n66491872)
print v(xbgr.mr_n66491984)
print v(xbgr.mr_n66492304)
print v(xbgr.mr_n66492416)
print v(xbgr.mr_n66492736)
print v(xbgr.mr_n66492848)
print v(xbgr.mr_n66493168)
print v(xbgr.mr_n66493280)
print v(xbgr.mr_n66493600)
print v(xbgr.mr_n66493712)
print v(xbgr.mr_n66494144)
print v(xbgr.mr_n66494464)
print v(xbgr.mr_n66494576)
print v(xbgr.mr_n66495008)
print v(xbgr.mr_n66495440)
print v(xbgr.mr_n66496624)
print v(xbgr.mr_n66496736)
print v(xbgr.mr_n66497056)
print v(xbgr.mr_n66497168)
print v(xbgr.mr_n66497488)
print v(xbgr.mr_n66497600)
print v(xbgr.mr_n66497920)
print v(xbgr.mr_n66498032)
print v(xbgr.mr_n66498352)
print v(xbgr.mr_n66498464)
print v(xbgr.mr_n66498784)
print v(xbgr.mr_n66499216)
print v(xbgr.mr_n66499328)
print v(xbgr.mr_n66499648)
print v(xbgr.mr_n66499760)
print v(xbgr.mr_n66500080)
print v(xbgr.mr_n66500192)
print v(xbgr.mr_n66500512)
print v(xbgr.mr_n66500624)
print v(xbgr.mr_n66501056)
print v(xbgr.mr_n66501376)
print v(xbgr.mr_n66501808)
print v(xbgr.mr_n66502672)
print v(xbgr.mr_n66502784)
print v(xbgr.mr_n66503104)
print v(xbgr.mr_n66503536)
print v(xbgr.mr_n66503968)
print v(xbgr.mr_n66504512)
print v(xbgr.mr_n66504832)
print v(xbgr.mr_n66505696)
print v(xbgr.mr_n66505808)
print v(xbgr.mr_n66506128)
print v(xbgr.mr_n66506240)
print v(xbgr.mr_n66506672)
print v(xbgr.mr_n66507424)
print v(xbgr.mr_n66507856)
print v(xbgr.mr_n66508288)
print v(xbgr.mr_n66508720)
print v(xbgr.mr_n66508832)
print v(xbgr.mr_n66510016)
print v(xbgr.mr_n66510880)
print v(xbgr.mr_n66511856)
print v(xbgr.mr_n66512176)
print v(xbgr.mr_n66512288)
print v(xbgr.mr_n66512720)
print v(xbgr.mr_n66513040)
print v(xbgr.mr_n66513152)
print v(xbgr.mr_n66513472)
print v(xbgr.mr_n66513584)
print v(xbgr.mr_n66513904)
print v(xbgr.mr_n66514016)
print v(xbgr.mr_n66514336)
print v(xbgr.mr_n66514448)
print v(xbgr.mr_n66514768)
print v(xbgr.mr_n66514880)
print v(xbgr.mr_n66515200)
print v(xbgr.mr_n66515312)
print v(xbgr.mr_n66515744)
print v(xbgr.mr_n66516176)
print v(xbgr.mr_n66516608)
print v(xbgr.mr_n66517360)
print v(xbgr.mr_n66517792)
print v(xbgr.mr_n66518656)
print v(xbgr.mr_n66519520)
print v(xbgr.mr_n66521248)
print v(xbgr.mr_n66522112)
print v(xbgr.mr_n66522224)
print v(xbgr.mr_n66522976)
print v(xbgr.mr_n66523088)
print v(xbgr.mr_n66523408)
print v(xbgr.mr_n66523520)
print v(xbgr.mr_n66523840)
print v(xbgr.mr_n66523952)
print v(xbgr.mr_n66526000)
print v(xbgr.mr_n66526112)
print v(xbgr.mr_n66526432)
print v(xbgr.mr_n66526544)
print v(xbgr.mr_n66526864)
print v(xbgr.mr_n66526976)
print v(xbgr.mr_n66527296)
print v(xbgr.mr_n66527408)
print v(xbgr.mr_n66527728)
print v(xbgr.mr_n66527840)
print v(xbgr.mr_n66528160)
print v(xbgr.mr_n66528272)
print v(xbgr.mr_n66528592)
print v(xbgr.mr_n66528704)
print v(xbgr.mr_n66529136)
print v(xbgr.mr_n66529456)
print v(xbgr.mr_n66529568)
print v(xbgr.mr_n66530000)
print v(xbgr.mr_n66530320)
print v(xbgr.mr_n66530432)
print v(xbgr.mr_n66530864)
print v(xbgr.mr_n66531184)
print v(xbgr.mr_n66531296)
print v(xbgr.mr_n66531616)
print v(xbgr.mr_n66531728)
print v(xbgr.mr_n66532048)
print v(xbgr.mr_n66532160)
print v(xbgr.mr_n66532480)
print v(xbgr.mr_n66532592)
print v(xbgr.mr_n66532912)
print v(xbgr.mr_n66533024)
print v(xbgr.mr_n66533344)
print v(xbgr.mr_n66533456)
print v(xbgr.mr_n66533776)
print v(xbgr.mr_n66533888)
print v(xbgr.mr_n66534208)
print v(xbgr.mr_n66534320)
print v(xbgr.mr_n66534640)
print v(xbgr.mr_n66534752)
print v(xbgr.mr_n66535072)
print v(xbgr.mr_n66535184)
print v(xbgr.mr_n66535504)
print v(xbgr.mr_n66535616)
print v(xbgr.mr_n66535936)
print v(xbgr.mr_n66536048)
print v(xbgr.mr_n66536368)
print v(xbgr.mr_n66536480)
print v(xbgr.mr_n66536800)
print v(xbgr.mr_n66536912)
print v(xbgr.mr_n66537232)
print v(xbgr.mr_n66537344)
print v(xbgr.mr_n66537664)
print v(xbgr.mr_n66537776)
print v(xbgr.mr_n66538096)
print v(xbgr.mr_n66538208)
print v(xbgr.mr_n66538528)
print v(xbgr.mr_n66538640)
print v(xbgr.mr_n66539072)
print v(xbgr.mr_n66539392)
print v(xbgr.mr_n66539504)
print v(xbgr.mr_n66539936)
print v(xbgr.mr_n66540256)
print v(xbgr.mr_n66540368)
print v(xbgr.mr_n66540800)
print v(xbgr.mr_n66541120)
print v(xbgr.mr_n66541984)
print v(xbgr.mr_n66542848)
print v(xbgr.mr_n66543712)
print v(xbgr.mr_n66544576)
print v(xbgr.mr_n66545440)
print v(xbgr.mr_n66546304)
print v(xbgr.mr_n66546416)
print v(xbgr.mr_n66546736)
print v(xbgr.mr_n66546848)
print v(xbgr.mr_n66547168)
print v(xbgr.mr_n66547280)
print v(xbgr.mr_n66547600)
print v(xbgr.mr_n66547712)
print v(xbgr.mr_n66548032)
print v(xbgr.mr_n66548144)
print v(xbgr.mr_n66548464)
print v(xbgr.mr_n66548576)
print v(xbgr.mr_n66548896)
print v(xbgr.mr_n66549760)
print v(xbgr.mr_n66550624)
print v(xbgr.mr_n66551488)
print v(xbgr.mr_n66551600)
print v(xbgr.mr_n66551920)
print v(xbgr.mr_n66552032)
print v(xbgr.mr_n66552352)
print v(xbgr.mr_n66552464)
print v(xbgr.mr_n66552896)
print v(xbgr.mr_n66553328)
print v(xbgr.mr_n66553760)
print v(xbgr.mr_n66554080)
print v(xbgr.mr_n66554192)
print v(xbgr.mr_n66554624)
print v(xbgr.mr_n66554944)
print v(xbgr.mr_n66555056)
print v(xbgr.mr_n66555376)
print v(xbgr.mr_n66555488)
print v(xbgr.mr_n66555808)
print v(xbgr.mr_n66555920)
print v(xbgr.mr_n66556240)
print v(xbgr.mr_n66556352)
print v(xbgr.mr_n66556672)
print v(xbgr.mr_n66556784)
print v(xbgr.mr_n66557104)
print v(xbgr.mr_n66557216)
print v(xbgr.mr_n66557648)
print v(xbgr.mr_n66558080)
print v(xbgr.mr_n66558400)
print v(xbgr.mr_n66558512)
print v(xbgr.mr_n66558944)
print v(xbgr.mr_n66559264)
print v(xbgr.mr_n66559376)
print v(xbgr.mr_n66559808)
print v(xbgr.mr_n66560128)
print v(xbgr.mr_n66560240)
print v(xbgr.mr_n66560672)
print v(xbgr.mr_n66560992)
print v(xbgr.mr_n66561856)
print v(xbgr.mr_n66562720)
print v(xbgr.mr_n66563584)
print v(xbgr.mr_n66564448)
print v(xbgr.mr_n66565312)
print v(xbgr.mr_n66565424)
print v(xbgr.mr_n66565744)
print v(xbgr.mr_n66565856)
print v(xbgr.mr_n66566176)
print v(xbgr.mr_n66566288)
print v(xbgr.mr_n66566608)
print v(xbgr.mr_n66566720)
print v(xbgr.mr_n66567040)
print v(xbgr.mr_n66567904)
print v(xbgr.mr_n66568768)
print v(xbgr.mr_n66569632)
print v(xbgr.mr_n66569744)
print v(xbgr.mr_n66570064)
print v(xbgr.mr_n66570176)
print v(xbgr.mr_n66570496)
print v(xbgr.mr_n66570608)
print v(xbgr.mr_n66570928)
print v(xbgr.mr_n66571040)
print v(xbgr.mr_n66571360)
print v(xbgr.mr_n66571472)
print v(xbgr.mr_n66571792)
print v(xbgr.mr_n66571904)
print v(xbgr.mr_n66572224)
print v(xbgr.mr_n66573088)
print v(xbgr.mr_n66573952)
print v(xbgr.mr_n66574816)
print v(xbgr.mr_n66575680)
print v(xbgr.mr_n66576544)
print v(xbgr.mr_n66577408)
print v(xbgr.mr_n66578272)
print v(xbgr.mr_n66579136)
print v(xbgr.mr_n66580000)
print v(xbgr.mr_n66580112)
print v(xbgr.mr_n66580432)
print v(xbgr.mr_n66580544)
print v(xbgr.mr_n66580864)
print v(xbgr.mr_n66580976)
print v(xbgr.mr_n66581296)
print v(xbgr.mr_n66581408)
print v(xbgr.mr_n66581728)
print v(xbgr.mr_n66581840)
print v(xbgr.mr_n66582160)
print v(xbgr.mr_n66582272)
print v(xbgr.mr_n66582592)
print v(xbgr.mr_n66582704)
print v(xbgr.mr_n66583024)
print v(xbgr.mr_n66583136)
print v(xbgr.mr_n66583456)
print v(xbgr.mr_n66583568)
print v(xbgr.mr_n66583888)
print v(xbgr.mr_n66584000)
print v(xbgr.mr_n66584320)
print v(xbgr.mr_n66585184)
print v(xbgr.mr_n66585296)
print v(xbgr.mr_n66585616)
print v(xbgr.mr_n66585728)
print v(xbgr.mr_n66586048)
print v(xbgr.mr_n66586160)
print v(xbgr.mr_n66586480)
print v(xbgr.mr_n66586592)
print v(xbgr.mr_n66586912)
print v(xbgr.mr_n66587024)
print v(xbgr.mr_n66587344)
print v(xbgr.mr_n66587456)
print v(xbgr.mr_n66587776)
print v(xbgr.mr_n66587888)
print v(xbgr.mr_n66588208)
print v(xbgr.mr_n66588320)
print v(xbgr.mr_n66588640)
print v(xbgr.mr_n66588752)
print v(xbgr.mr_n66589072)
print v(xbgr.mr_n66589184)
print v(xbgr.mr_n66589504)
print v(xbgr.mr_n66589616)
print v(xbgr.mr_n66590048)
print v(xbgr.mr_n66590368)
print v(xbgr.mr_n66590480)
print v(xbgr.mr_n66590912)
print v(xbgr.mr_n66591232)
print v(xbgr.mr_n66591344)
print v(xbgr.mr_n66591776)
print v(xbgr.mr_n66592096)
print v(xbgr.mr_n66592208)
print v(xbgr.mr_n66592640)
print v(xbgr.mr_n66592960)
print v(xbgr.mr_n66593072)
print v(xbgr.mr_n66593392)
print v(xbgr.mr_n66593504)
print v(xbgr.mr_n66593936)
print v(xbgr.mr_n66594368)
print v(xbgr.mr_n66594688)
print v(xbgr.mr_n66594800)
print v(xbgr.mr_n66595120)
print v(xbgr.mr_n66595232)
print v(xbgr.mr_n66595552)
print v(xbgr.mr_n66595664)
print v(xbgr.mr_n66595984)
print v(xbgr.mr_n66596096)
print v(xbgr.mr_n66596416)
print v(xbgr.mr_n66596528)
print v(xbgr.mr_n66596960)
print v(xbgr.mr_n66597280)
print v(xbgr.mr_n66597392)
print v(xbgr.mr_n66597824)
print v(xbgr.mr_n66598144)
print v(xbgr.mr_n66599008)
print v(xbgr.mr_n66599872)
print v(xbgr.mr_n66600736)
print v(xbgr.mr_n66601600)
print v(xbgr.mr_n66601712)
print v(xbgr.mr_n66602032)
print v(xbgr.mr_n66602144)
print v(xbgr.mr_n66602464)
print v(xbgr.mr_n66602576)
print v(xbgr.mr_n66602896)
print v(xbgr.mr_n66603008)
print v(xbgr.mr_n66603328)
print v(xbgr.mr_n66604192)
print v(xbgr.mr_n66605056)
print v(xbgr.mr_n66605168)
print v(xbgr.mr_n66605488)
print v(xbgr.mr_n66605600)
print v(xbgr.mr_n66606032)
print v(xbgr.mr_n66606464)
print v(xbgr.mr_n66606784)
print v(xbgr.mr_n66606896)
print v(xbgr.mr_n66607216)
print v(xbgr.mr_n66607328)
print v(xbgr.mr_n66607648)
print v(xbgr.mr_n66607760)
print v(xbgr.mr_n66608080)
print v(xbgr.mr_n66608192)
print v(xbgr.mr_n66608512)
print v(xbgr.mr_n66608624)
print v(xbgr.mr_n66609056)
print v(xbgr.mr_n66609376)
print v(xbgr.mr_n66609488)
print v(xbgr.mr_n66609920)
print v(xbgr.mr_n66610240)
print v(xbgr.mr_n66610352)
print v(xbgr.mr_n66610672)
print v(xbgr.mr_n66610784)
print v(xbgr.mr_n66611104)
print v(xbgr.mr_n66611216)
print v(xbgr.mr_n66611536)
print v(xbgr.mr_n66611648)
print v(xbgr.mr_n66611968)
print v(xbgr.mr_n66612080)
print v(xbgr.mr_n66612400)
print v(xbgr.mr_n66612512)
print v(xbgr.mr_n66612832)
print v(xbgr.mr_n66612944)
print v(xbgr.mr_n66613264)
print v(xbgr.mr_n66613376)
print v(xbgr.mr_n66613696)
print v(xbgr.mr_n66613808)
print v(xbgr.mr_n66614128)
print v(xbgr.mr_n66614240)
print v(xbgr.mr_n66614560)
print v(xbgr.mr_n66615424)
print v(xbgr.mr_n66616288)
print v(xbgr.mr_n66617152)
print v(xbgr.mr_n66618016)
print v(xbgr.mr_n66618128)
print v(xbgr.mr_n66618448)
print v(xbgr.mr_n66618560)
print v(xbgr.mr_n66618880)
print v(xbgr.mr_n66618992)
print v(xbgr.mr_n66619312)
print v(xbgr.mr_n66619424)
print v(xbgr.mr_n66619856)
print v(xbgr.mr_n66620288)
print v(xbgr.mr_n66620720)
print v(xbgr.mr_n66621152)
print v(xbgr.mr_n66621472)
print v(xbgr.mr_n66621584)
print v(xbgr.mr_n66621904)
print v(xbgr.mr_n66622016)
print v(xbgr.mr_n66622336)
print v(xbgr.mr_n66622448)
print v(xbgr.mr_n66622768)
print v(xbgr.mr_n66622880)
print v(xbgr.mr_n66623200)
print v(xbgr.mr_n66624064)
print v(xbgr.mr_n66624928)
print v(xbgr.mr_n66625040)
print v(xbgr.mr_n66625472)
print v(xbgr.mr_n66625792)
print v(xbgr.mr_n66626656)
print v(xbgr.mr_n66626768)
print v(xbgr.mr_n66627088)
print v(xbgr.mr_n66627200)
print v(xbgr.mr_n66627520)
print v(xbgr.mr_n66627632)
print v(xbgr.mr_n66627952)
print v(xbgr.mr_n66628064)
print v(xbgr.mr_n66628384)
print v(xbgr.mr_n66629248)
print v(xbgr.mr_n66629360)
print v(xbgr.mr_n66629792)
print v(xbgr.mr_n66630112)
print v(xbgr.mr_n66630224)
print v(xbgr.mr_n66630544)
print v(xbgr.mr_n66630656)
print v(xbgr.mr_n66630976)
print v(xbgr.mr_n66631088)
print v(xbgr.mr_n66631408)
print v(xbgr.mr_n66631520)
print v(xbgr.mr_n66631840)
print v(xbgr.mr_n66632704)
print v(xbgr.mr_n66633136)
print v(xbgr.mr_n66633248)
print v(xbgr.mr_n66633568)
print v(xbgr.mr_n66633680)
print v(xbgr.mr_n66634000)
print v(xbgr.mr_n66634432)
print v(xbgr.mr_n66635296)
print v(xbgr.mr_n66636160)
print v(xbgr.mr_n66636272)
print v(xbgr.mr_n66637024)
print v(xbgr.mr_n66637136)
print v(xbgr.mr_n66637456)
print v(xbgr.mr_n66637568)
print v(xbgr.mr_n66637888)
print v(xbgr.mr_n66638752)
print v(xbgr.mr_n66639616)
print v(xbgr.mr_n66639728)
print v(xbgr.mr_n66640048)
print v(xbgr.mr_n66640160)
print v(xbgr.mr_n66640480)
print v(xbgr.mr_n66641344)
print v(xbgr.mr_n66641456)
print v(xbgr.mr_n66641776)
print v(xbgr.mr_n66641888)
print v(xbgr.mr_n66642208)
print v(xbgr.mr_n66642320)
print v(xbgr.mr_n66642640)
print v(xbgr.mr_n66642752)
print v(xbgr.mr_n66643072)
print v(xbgr.mr_n66643184)
print v(xbgr.mr_n66643936)
print v(xbgr.mr_n66644800)
print v(xbgr.mr_n66645664)
print v(xbgr.mr_n66645776)
print v(xbgr.mr_n66646096)
print v(xbgr.mr_n66646208)
print v(xbgr.mr_n66646528)
print v(xbgr.mr_n66646640)
print v(xbgr.mr_n66646960)
print v(xbgr.mr_n66647072)
print v(xbgr.mr_n66647392)
print v(xbgr.mr_n66647504)
print v(xbgr.mr_n66647824)
print v(xbgr.mr_n66647936)
print v(xbgr.mr_n66648256)
print v(xbgr.mr_n66648368)
print v(xbgr.mr_n66648800)
print v(xbgr.mr_n66649120)
print v(xbgr.mr_n66649232)
print v(xbgr.mr_n66649552)
print v(xbgr.mr_n66649664)
print v(xbgr.mr_n66649984)
print v(xbgr.mr_n66650848)
print v(xbgr.mr_n66651712)
print v(xbgr.mr_n66652576)
print v(xbgr.mr_n66653440)
print v(xbgr.mr_n66653872)
print v(xbgr.mr_n66653984)
print v(xbgr.mr_n66654304)
print v(xbgr.mr_n66654416)
print v(xbgr.mr_n66654736)
print v(xbgr.mr_n66654848)
print v(xbgr.mr_n66655280)
print v(xbgr.mr_n66656032)
print v(xbgr.mr_n66656144)
print v(xbgr.mr_n66656464)
print v(xbgr.mr_n66656576)
print v(xbgr.mr_n66656896)
print v(xbgr.mr_n66657760)
print v(xbgr.mr_n66658624)
print v(xbgr.mr_n66658736)
print v(xbgr.mr_n66659056)
print v(xbgr.mr_n66659168)
print v(xbgr.mr_n66659488)
print v(xbgr.mr_n66660352)
print v(xbgr.mr_n66661216)
print v(xbgr.mr_n66662080)
print v(xbgr.mr_n66662192)
print v(xbgr.mr_n66662512)
print v(xbgr.mr_n66662624)
print v(xbgr.mr_n66662944)
print v(xbgr.mr_n66663808)
print v(xbgr.mr_n66664672)
print v(xbgr.mr_n66664784)
print v(xbgr.mr_n66665104)
print v(xbgr.mr_n66665216)
print v(xbgr.mr_n66665536)
print v(xbgr.mr_n66665648)
print v(xbgr.mr_n66665968)
print v(xbgr.mr_n66666080)
print v(xbgr.mr_n66666400)
print v(xbgr.mr_n66666512)
print v(xbgr.mr_n66666832)
print v(xbgr.mr_n66666944)
print v(xbgr.mr_n66667264)
print v(xbgr.mr_n66667376)
print v(xbgr.mr_n66667696)
print v(xbgr.mr_n66667808)
print v(xbgr.mr_n66668128)
print v(xbgr.mr_n66668240)
print v(xbgr.mr_n66668560)
print v(xbgr.mr_n66668672)
print v(xbgr.mr_n66668992)
print v(xbgr.mr_n66669104)
print v(xbgr.mr_n66669424)
print v(xbgr.mr_n66669536)
print v(xbgr.mr_n66669856)
print v(xbgr.mr_n66669968)
print v(xbgr.mr_n66670288)
print v(xbgr.mr_n66670400)
print v(xbgr.mr_n66670720)
print v(xbgr.mr_n66670832)
print v(xbgr.mr_n66671152)
print v(xbgr.mr_n66671264)
print v(xbgr.mr_n66671584)
print v(xbgr.mr_n66671696)
print v(xbgr.mr_n66672016)
print v(xbgr.mr_n66672128)
print v(xbgr.mr_n66672448)
print v(xbgr.mr_n66672560)
print v(xbgr.mr_n66672880)
print v(xbgr.mr_n66672992)
print v(xbgr.mr_n66673312)
print v(xbgr.mr_n66673424)
print v(xbgr.mr_n66673744)
print v(xbgr.mr_n66673856)
print v(xbgr.mr_n66674176)
print v(xbgr.mr_n66674288)
print v(xbgr.mr_n66674608)
print v(xbgr.mr_n66674720)
print v(xbgr.mr_n66675040)
print v(xbgr.mr_n66675152)
print v(xbgr.mr_n66675472)
print v(xbgr.mr_n66675584)
print v(xbgr.mr_n66676016)
print v(xbgr.mr_n66676448)
print v(xbgr.mr_n66676880)
print v(xbgr.mr_n66677312)
print v(xbgr.mr_n66677744)
print v(xbgr.mr_n66678176)
print v(xbgr.mr_n66678608)
print v(xbgr.mr_n66679040)
print v(xbgr.mr_n66679472)
print v(xbgr.mr_n66679904)
print v(xbgr.mr_n66680336)
print v(xbgr.mr_n66680768)
print v(xbgr.mr_n66681200)
print v(xbgr.mr_n66681632)
print v(xbgr.mr_n66682064)
print v(xbgr.mr_n66682496)
print v(xbgr.mr_n66682928)
print v(xbgr.mr_n66683360)
print v(xbgr.mr_n66683792)
print v(xbgr.mr_n66684224)
print v(xbgr.mr_n66684656)
print v(xbgr.mr_n66685088)
print v(xbgr.mr_n66685520)
print v(xbgr.mr_n66685952)
print v(xbgr.mr_n66686384)
print v(xbgr.mr_n66686816)
print v(xbgr.mr_n66687136)
print v(xbgr.mr_n66687248)
print v(xbgr.mr_n66687568)
print v(xbgr.mr_n66687680)
print v(xbgr.mr_n66688000)
print v(xbgr.mr_n66688112)
print v(xbgr.mr_n66688432)
print v(xbgr.mr_n66688544)
print v(xbgr.mr_n66688864)
print v(xbgr.mr_n66688976)
print v(xbgr.mr_n66689296)
print v(xbgr.mr_n66689408)
print v(xbgr.mr_n66689728)
print v(xbgr.mr_n66689840)
print v(xbgr.mr_n66690160)
print v(xbgr.mr_n66690272)
print v(xbgr.mr_n66690592)
print v(xbgr.mr_n66690704)
print v(xbgr.mr_n66691024)
print v(xbgr.mr_n66691136)
print v(xbgr.mr_n66691456)
print v(xbgr.mr_n66691568)
print v(xbgr.mr_n66691888)
print v(xbgr.mr_n66692000)
print v(xbgr.mr_n66692320)
print v(xbgr.mr_n66692432)
print v(xbgr.mr_n66692752)
print v(xbgr.mr_n66692864)
print v(xbgr.mr_n66693184)
print v(xbgr.mr_n66693296)
print v(xbgr.mr_n66693616)
print v(xbgr.mr_n66693728)
print v(xbgr.mr_n66694048)
print v(xbgr.mr_n66694160)
print v(xbgr.mr_n66694480)
print v(xbgr.mr_n66694592)
print v(xbgr.mr_n66694912)
print v(xbgr.mr_n66695024)
print v(xbgr.mr_n66695344)
print v(xbgr.mr_n66695456)
print v(xbgr.mr_n66695776)
print v(xbgr.mr_n66695888)
print v(xbgr.mr_n66696208)
print v(xbgr.mr_n66696320)
print v(xbgr.mr_n66696640)
print v(xbgr.mr_n66696752)
print v(xbgr.mr_n66697072)
print v(xbgr.mr_n66697184)
print v(xbgr.mr_n66697616)
print v(xbgr.mr_n66698048)
print v(xbgr.mr_n66698480)
print v(xbgr.mr_n66698912)
print v(xbgr.mr_n66699232)
print v(xbgr.mr_n66699344)
print v(xbgr.mr_n66699664)
print v(xbgr.mr_n66699776)
print v(xbgr.mr_n66700208)
print v(xbgr.mr_n66700640)
print v(xbgr.mr_n66701072)
print v(xbgr.mr_n66701504)
print v(xbgr.mr_n66701936)
print v(xbgr.mr_n66702368)
print v(xbgr.mr_n66702800)
print v(xbgr.mr_n66703232)
print v(xbgr.mr_n66703664)
print v(xbgr.mr_n66704096)
print v(xbgr.mr_n66704528)
print v(xbgr.mr_n66704960)
print v(xbgr.mr_n66705392)
print v(xbgr.mr_n66705824)
print v(xbgr.mr_n66706256)
print v(xbgr.mr_n66706688)
print v(xbgr.mr_n66707120)
print v(xbgr.mr_n66707552)
print v(xbgr.mr_n66707984)
print v(xbgr.mr_n66708416)
print v(xbgr.mr_n66708848)
print v(xbgr.mr_n66709280)
print v(xbgr.mr_n66709600)
print v(xbgr.mr_n66709712)
print v(xbgr.mr_n66710144)
print v(xbgr.mr_n66710464)
print v(xbgr.mr_n66710576)
print v(xbgr.mr_n66711008)
print v(xbgr.mr_n66711328)
print v(xbgr.mr_n66711440)
print v(xbgr.mr_n66711872)
print v(xbgr.mr_n66712192)
print v(xbgr.mr_n66712304)
print v(xbgr.mr_n66712736)
print v(xbgr.mr_n66713056)
print v(xbgr.mr_n66713168)
print v(xbgr.mr_n66713600)
print v(xbgr.mr_n66713920)
print v(xbgr.mr_n66714032)
print v(xbgr.mr_n66714352)
print v(xbgr.mr_n66714464)
print v(xbgr.mr_n66714784)
print v(xbgr.mr_n66714896)
print v(xbgr.mr_n66715328)
print v(xbgr.mr_n66715760)
print v(xbgr.mr_n66716192)
print v(xbgr.mr_n66716512)
print v(xbgr.mr_n66716624)
print v(xbgr.mr_n66716944)
print v(xbgr.mr_n66717056)
print v(xbgr.mr_n66717376)
print v(xbgr.mr_n66717488)
print v(xbgr.mr_n66717808)
print v(xbgr.mr_n66717920)
print v(xbgr.mr_n66718240)
print v(xbgr.mr_n66718352)
print v(xbgr.mr_n66718672)
print v(xbgr.mr_n66718784)
print v(xbgr.mr_n66719104)
print v(xbgr.mr_n66719216)
print v(xbgr.mr_n66719648)
print v(xbgr.mr_n66719968)
print v(xbgr.mr_n66720080)
print v(xbgr.mr_n66720512)
print v(xbgr.mr_n66720832)
print v(xbgr.mr_n66720944)
print v(xbgr.mr_n66721376)
print v(xbgr.mr_n66721696)
print v(xbgr.mr_n66722560)
print v(xbgr.mr_n66723424)
print v(xbgr.mr_n66724288)
print v(xbgr.mr_n66725152)
print v(xbgr.mr_n66726016)
print v(xbgr.mr_n66726880)
print v(xbgr.mr_n66726992)
print v(xbgr.mr_n66727312)
print v(xbgr.mr_n66727424)
print v(xbgr.mr_n66727744)
print v(xbgr.mr_n66727856)
print v(xbgr.mr_n66728176)
print v(xbgr.mr_n66728288)
print v(xbgr.mr_n66728608)
print v(xbgr.mr_n66729472)
print v(xbgr.mr_n66730336)
print v(xbgr.mr_n66731200)
print v(xbgr.mr_n66731312)
print v(xbgr.mr_n66731632)
print v(xbgr.mr_n66731744)
print v(xbgr.mr_n66732064)
print v(xbgr.mr_n66732176)
print v(xbgr.mr_n66732608)
print v(xbgr.mr_n66733040)
print v(xbgr.mr_n66733472)
print v(xbgr.mr_n66733792)
print v(xbgr.mr_n66733904)
print v(xbgr.mr_n66734224)
print v(xbgr.mr_n66734336)
print v(xbgr.mr_n66734656)
print v(xbgr.mr_n66734768)
print v(xbgr.mr_n66735088)
print v(xbgr.mr_n66735200)
print v(xbgr.mr_n66735520)
print v(xbgr.mr_n66735632)
print v(xbgr.mr_n66735952)
print v(xbgr.mr_n66736064)
print v(xbgr.mr_n66736384)
print v(xbgr.mr_n66736496)
print v(xbgr.mr_n66736816)
print v(xbgr.mr_n66736928)
print v(xbgr.mr_n66737248)
print v(xbgr.mr_n66737360)
print v(xbgr.mr_n66737792)
print v(xbgr.mr_n66738112)
print v(xbgr.mr_n66738224)
print v(xbgr.mr_n66738656)
print v(xbgr.mr_n66738976)
print v(xbgr.mr_n66739088)
print v(xbgr.mr_n66739408)
print v(xbgr.mr_n66739520)
print v(xbgr.mr_n66739840)
print v(xbgr.mr_n66740704)
print v(xbgr.mr_n66741568)
print v(xbgr.mr_n66741680)
print v(xbgr.mr_n66742000)
print v(xbgr.mr_n66742112)
print v(xbgr.mr_n66742432)
print v(xbgr.mr_n66743296)
print v(xbgr.mr_n66743840)
print v(xbgr.mr_n66744272)
print v(xbgr.mr_n66745024)
print v(xbgr.mr_n66745888)
print v(xbgr.mr_n66746000)
print v(xbgr.mr_n66746320)
print v(xbgr.mr_n66746432)
print v(xbgr.mr_n66746752)
print v(xbgr.mr_n66746864)
print v(xbgr.mr_n66747184)
print v(xbgr.mr_n66747296)
print v(xbgr.mr_n66747616)
print v(xbgr.mr_n66747728)
print v(xbgr.mr_n66748048)
print v(xbgr.mr_n66748160)
print v(xbgr.mr_n66748480)
print v(xbgr.mr_n66748592)
print v(xbgr.mr_n66748912)
print v(xbgr.mr_n66749024)
print v(xbgr.mr_n66749344)
print v(xbgr.mr_n66750208)
print v(xbgr.mr_n66750320)
print v(xbgr.mr_n66750640)
print v(xbgr.mr_n66750752)
print v(xbgr.mr_n66751072)
print v(xbgr.mr_n66751936)
print v(xbgr.mr_n66752800)
print v(xbgr.mr_n66752912)
print v(xbgr.mr_n66753232)
print v(xbgr.mr_n66753344)
print v(xbgr.mr_n66753664)
print v(xbgr.mr_n66753776)
print v(xbgr.mr_n66754208)
print v(xbgr.mr_n66754528)
print v(xbgr.mr_n66754960)
print v(xbgr.mr_n66756256)
print v(xbgr.mr_n66756368)
print v(xbgr.mr_n66756688)
print v(xbgr.mr_n66756800)
print v(xbgr.mr_n66757120)
print v(xbgr.mr_n66757232)
print v(xbgr.mr_n66757552)
print v(xbgr.mr_n66757664)
print v(xbgr.mr_n66757984)
print v(xbgr.mr_n66758096)
print v(xbgr.mr_n66758528)
print v(xbgr.mr_n66758848)
print v(xbgr.mr_n66758960)
print v(xbgr.mr_n66759280)
print v(xbgr.mr_n66759392)
print v(xbgr.mr_n66759712)
print v(xbgr.mr_n66759824)
print v(xbgr.mr_n66760144)
print v(xbgr.mr_n66760256)
print v(xbgr.mr_n66760576)
print v(xbgr.mr_n66761440)
print v(xbgr.mr_n66762304)
print v(xbgr.mr_n66763168)
print v(xbgr.mr_n66764032)
print v(xbgr.mr_n66764144)
print v(xbgr.mr_n66764464)
print v(xbgr.mr_n66764576)
print v(xbgr.mr_n66764896)
print v(xbgr.mr_n66765008)
print v(xbgr.mr_n66765328)
print v(xbgr.mr_n66765440)
print v(xbgr.mr_n66765760)
print v(xbgr.mr_n66766624)
print v(xbgr.mr_n66767488)
print v(xbgr.mr_n66768352)
print v(xbgr.mr_n66769216)
print v(xbgr.mr_n66769648)
print v(xbgr.mr_n66769760)
print v(xbgr.mr_n66770080)
print v(xbgr.mr_n66770192)
print v(xbgr.mr_n66770512)
print v(xbgr.mr_n66770624)
print v(xbgr.mr_n66770944)
print v(xbgr.mr_n66771056)
print v(xbgr.mr_n66771376)
print v(xbgr.mr_n66771488)
print v(xbgr.mr_n66771808)
print v(xbgr.mr_n66771920)
print v(xbgr.mr_n66772240)
print v(xbgr.mr_n66772352)
print v(xbgr.mr_n66772672)
print v(xbgr.mr_n66772784)
print v(xbgr.mr_n66773216)
print v(xbgr.mr_n66773536)
print v(xbgr.mr_n66773648)
print v(xbgr.mr_n66774080)
print v(xbgr.mr_n66774400)
print v(xbgr.mr_n66774512)
print v(xbgr.mr_n66774944)
print v(xbgr.mr_n66775264)
print v(xbgr.mr_n66775376)
print v(xbgr.mr_n66775696)
print v(xbgr.mr_n66775808)
print v(xbgr.mr_n66776128)
print v(xbgr.mr_n66776992)
print v(xbgr.mr_n66777856)
print v(xbgr.mr_n66778720)
print v(xbgr.mr_n66779584)
print v(xbgr.mr_n66780448)
print v(xbgr.mr_n66781312)
print v(xbgr.mr_n66782176)
print v(xbgr.mr_n66783040)
print v(xbgr.mr_n66783904)
print v(xbgr.mr_n66784016)
print v(xbgr.mr_n66784336)
print v(xbgr.mr_n66784448)
print v(xbgr.mr_n66784768)
print v(xbgr.mr_n66785632)
print v(xbgr.mr_n66785744)
print v(xbgr.mr_n66786064)
print v(xbgr.mr_n66786176)
print v(xbgr.mr_n66786496)
print v(xbgr.mr_n66786608)
print v(xbgr.mr_n66786928)
print v(xbgr.mr_n66787040)
print v(xbgr.mr_n66787360)
print v(xbgr.mr_n66787472)
print v(xbgr.mr_n66787792)
print v(xbgr.mr_n66787904)
print v(xbgr.mr_n66788224)
print v(xbgr.mr_n66788336)
print v(xbgr.mr_n66788656)
print v(xbgr.mr_n66788768)
print v(xbgr.mr_n66789088)
print v(xbgr.mr_n66789952)
print v(xbgr.mr_n66790816)
print v(xbgr.mr_n66791680)
print v(xbgr.mr_n66791792)
print v(xbgr.mr_n66792112)
print v(xbgr.mr_n66793408)
print v(xbgr.mr_n66794272)
print v(xbgr.mr_n66795136)
print v(xbgr.mr_n66796000)
print v(xbgr.mr_n66796112)
print v(xbgr.mr_n66796432)
print v(xbgr.mr_n66796544)
print v(xbgr.mr_n66796976)
print v(xbgr.mr_n66797296)
print v(xbgr.mr_n66797408)
print v(xbgr.mr_n66797840)
print v(xbgr.mr_n66798160)
print v(xbgr.mr_n66798272)
print v(xbgr.mr_n66798704)
print v(xbgr.mr_n66799024)
print v(xbgr.mr_n66799136)
print v(xbgr.mr_n66799568)
print v(xbgr.mr_n66799888)
print v(xbgr.mr_n66800000)
print v(xbgr.mr_n66800432)
print v(xbgr.mr_n66800752)
print v(xbgr.mr_n66800864)
print v(xbgr.mr_n66801184)
print v(xbgr.mr_n66801296)
print v(xbgr.mr_n66801616)
print v(xbgr.mr_n66801728)
print v(xbgr.mr_n66802160)
print v(xbgr.mr_n66802480)
print v(xbgr.mr_n66802592)
print v(xbgr.mr_n66802912)
print v(xbgr.mr_n66803024)
print v(xbgr.mr_n66803344)
print v(xbgr.mr_n66803456)
print v(xbgr.mr_n66803776)
print v(xbgr.mr_n66803888)
print v(xbgr.mr_n66804208)
print v(xbgr.mr_n66804320)
print v(xbgr.mr_n66804640)
print v(xbgr.mr_n66804752)
print v(xbgr.mr_n66805072)
print v(xbgr.mr_n66805184)
print v(xbgr.mr_n66805504)
print v(xbgr.mr_n66805616)
print v(xbgr.mr_n66806048)
print v(xbgr.mr_n66806368)
print v(xbgr.mr_n66807344)
print v(xbgr.mr_n66807776)
print v(xbgr.mr_n66808096)
print v(xbgr.mr_n66808960)
print v(xbgr.mr_n66809072)
print v(xbgr.mr_n66809392)
print v(xbgr.mr_n66809504)
print v(xbgr.mr_n66809824)
print v(xbgr.mr_n66809936)
print v(xbgr.mr_n66810256)
print v(xbgr.mr_n66810368)
print v(xbgr.mr_n66810688)
print v(xbgr.mr_n66811552)
print v(xbgr.mr_n66811984)
print v(xbgr.mr_n66812848)
print v(xbgr.mr_n66813712)
print v(xbgr.mr_n66813824)
print v(xbgr.mr_n66814144)
print v(xbgr.mr_n66814256)
print v(xbgr.mr_n66814576)
print v(xbgr.mr_n66814688)
print v(xbgr.mr_n66815008)
print v(xbgr.mr_n66815120)
print v(xbgr.mr_n66815872)
print v(xbgr.mr_n66815984)
print v(xbgr.mr_n66816304)
print v(xbgr.mr_n66816416)
print v(xbgr.mr_n66816736)
print v(xbgr.mr_n66816848)
print v(xbgr.mr_n66817168)
print v(xbgr.mr_n66817280)
print v(xbgr.mr_n66817600)
print v(xbgr.mr_n66818144)
print v(xbgr.mr_n66818464)
print v(xbgr.mr_n66818576)
print v(xbgr.mr_n66819008)
print v(xbgr.mr_n66819328)
print v(xbgr.mr_n66819440)
print v(xbgr.mr_n66820624)
print v(xbgr.mr_n66821056)
print v(xbgr.mr_n66821168)
print v(xbgr.mr_n66821488)
print v(xbgr.mr_n66821600)
print v(xbgr.mr_n66821920)
print v(xbgr.mr_n66822032)
print v(xbgr.mr_n66822352)
print v(xbgr.mr_n66822464)
print v(xbgr.mr_n66822784)
print v(xbgr.mr_n66822896)
print v(xbgr.mr_n66823216)
print v(xbgr.mr_n66823328)
print v(xbgr.mr_n66824080)
print v(xbgr.mr_n66824944)
print v(xbgr.mr_n66825056)
print v(xbgr.mr_n66825376)
print v(xbgr.mr_n66825488)
print v(xbgr.mr_n66825808)
print v(xbgr.mr_n66825920)
print v(xbgr.mr_n66826240)
print v(xbgr.mr_n66826352)
print v(xbgr.mr_n66826672)
print v(xbgr.mr_n66826784)
print v(xbgr.mr_n66827104)
print v(xbgr.mr_n66827216)
print v(xbgr.mr_n66827536)
print v(xbgr.mr_n66827648)
print v(xbgr.mr_n66827968)
print v(xbgr.mr_n66828080)
print v(xbgr.mr_n66828400)
print v(xbgr.mr_n66829264)
print v(xbgr.mr_n66830128)
print v(xbgr.mr_n66830992)
print v(xbgr.mr_n66831104)
print v(xbgr.mr_n66831536)
print v(xbgr.mr_n66831968)
print v(xbgr.mr_n66832288)
print v(xbgr.mr_n66832720)
print v(xbgr.mr_n66832832)
print v(xbgr.mr_n66833152)
print v(xbgr.mr_n66833264)
print v(xbgr.mr_n66834016)
print v(xbgr.mr_n66835424)
print v(xbgr.mr_n66835744)
print v(xbgr.mr_n66835856)
print v(xbgr.mr_n66836176)
print v(xbgr.mr_n66836288)
print v(xbgr.mr_n66836608)
print v(xbgr.mr_n66836720)
print v(xbgr.mr_n66837152)
print v(xbgr.mr_n66837472)
print v(xbgr.mr_n66837584)
print v(xbgr.mr_n66838016)
print v(xbgr.mr_n66838336)
print v(xbgr.mr_n66838768)
print v(xbgr.mr_n66839200)
print v(xbgr.mr_n66839312)
print v(xbgr.mr_n66839632)
print v(xbgr.mr_n66839744)
print v(xbgr.mr_n66840064)
print v(xbgr.mr_n66840176)
print v(xbgr.mr_n66840928)
print v(xbgr.mr_n66841792)
print v(xbgr.mr_n66841904)
print v(xbgr.mr_n66842336)
print v(xbgr.mr_n66842656)
print v(xbgr.mr_n66843520)
print v(xbgr.mr_n66844384)
print v(xbgr.mr_n66845680)
print v(xbgr.mr_n66846112)
print v(xbgr.mr_n66846224)
print v(xbgr.mr_n66846544)
print v(xbgr.mr_n66846656)
print v(xbgr.mr_n66846976)
print v(xbgr.mr_n66847088)
print v(xbgr.mr_n66847408)
print v(xbgr.mr_n66847520)
print v(xbgr.mr_n66847840)
print v(xbgr.mr_n66847952)
print v(xbgr.mr_n66848272)
print v(xbgr.mr_n66848384)
print v(xbgr.mr_n66848704)
print v(xbgr.mr_n66848816)
print v(xbgr.mr_n66849136)
print v(xbgr.mr_n66849248)
print v(xbgr.mr_n66850000)
print v(xbgr.mr_n66850864)
print v(xbgr.mr_n66851728)
print v(xbgr.mr_n66851840)
print v(xbgr.mr_n66852160)
print v(xbgr.mr_n66852272)
print v(xbgr.mr_n66852592)
print v(xbgr.mr_n66852704)
print v(xbgr.mr_n66853024)
print v(xbgr.mr_n66853888)
print v(xbgr.mr_n66854752)
print v(xbgr.mr_n66855616)
print v(xbgr.mr_n66856480)
print v(xbgr.mr_n66857344)
print v(xbgr.mr_n66858208)
print v(xbgr.mr_n66858320)
print v(xbgr.mr_n66858640)
print v(xbgr.mr_n66859504)
print v(xbgr.mr_n66859616)
print v(xbgr.mr_n66859936)
print v(xbgr.mr_n66860048)
print v(xbgr.mr_n66860368)
print v(xbgr.mr_n66861232)
print v(xbgr.mr_n66861664)
print v(xbgr.mr_n66861776)
print v(xbgr.mr_n66862528)
print v(xbgr.mr_n66862640)
print v(xbgr.mr_n66862960)
print v(xbgr.mr_n66863072)
print v(xbgr.mr_n66863392)
print v(xbgr.mr_n66863504)
print v(xbgr.mr_n66863824)
print v(xbgr.mr_n66863936)
print v(xbgr.mr_n66864256)
print v(xbgr.mr_n66864368)
print v(xbgr.mr_n66864688)
print v(xbgr.mr_n66864800)
print v(xbgr.mr_n66865120)
print v(xbgr.mr_n66865232)
print v(xbgr.mr_n66865552)
print v(xbgr.mr_n66865664)
print v(xbgr.mr_n66865984)
print v(xbgr.mr_n66866096)
print v(xbgr.mr_n66866416)
print v(xbgr.mr_n66866960)
print v(xbgr.mr_n66867712)
print v(xbgr.mr_n66868576)
print v(xbgr.mr_n66869440)
print v(xbgr.mr_n66869552)
print v(xbgr.mr_n66869984)
print v(xbgr.mr_n66870304)
print v(xbgr.mr_n66871168)
print v(xbgr.mr_n66872032)
print v(xbgr.mr_n66872896)
print v(xbgr.mr_n66873760)
print v(xbgr.mr_n66874624)
print v(xbgr.mr_n66875488)
print v(xbgr.mr_n66875600)
print v(xbgr.mr_n66875920)
print v(xbgr.mr_n66876032)
print v(xbgr.mr_n66876352)
print v(xbgr.mr_n66877216)
print v(xbgr.mr_n66878080)
print v(xbgr.mr_n66878192)
print v(xbgr.mr_n66878512)
print v(xbgr.mr_n66878624)
print v(xbgr.mr_n66878944)
print v(xbgr.mr_n66879056)
print v(xbgr.mr_n66879376)
print v(xbgr.mr_n66879488)
print v(xbgr.mr_n66879808)
print v(xbgr.mr_n66879920)
print v(xbgr.mr_n66880240)
print v(xbgr.mr_n66880352)
print v(xbgr.mr_n66880672)
print v(xbgr.mr_n66880784)
print v(xbgr.mr_n66881104)
print v(xbgr.mr_n66881968)
print v(xbgr.mr_n66882080)
print v(xbgr.mr_n66882400)
print v(xbgr.mr_n66882512)
print v(xbgr.mr_n66882832)
print v(xbgr.mr_n66882944)
print v(xbgr.mr_n66883264)
print v(xbgr.mr_n66883376)
print v(xbgr.mr_n66883696)
print v(xbgr.mr_n66883808)
print v(xbgr.mr_n66884128)
print v(xbgr.mr_n66884240)
print v(xbgr.mr_n66884560)
print v(xbgr.mr_n66884672)
print v(xbgr.mr_n66884992)
print v(xbgr.mr_n66885104)
print v(xbgr.mr_n66885536)
print v(xbgr.mr_n66885968)
print v(xbgr.mr_n66886400)
print v(xbgr.mr_n66886720)
print v(xbgr.mr_n66886832)
print v(xbgr.mr_n66887152)
print v(xbgr.mr_n66887264)
print v(xbgr.mr_n66887584)
print v(xbgr.mr_n66887696)
print v(xbgr.mr_n66888016)
print v(xbgr.mr_n66888128)
print v(xbgr.mr_n66888448)
print v(xbgr.mr_n66888560)
print v(xbgr.mr_n66888880)
print v(xbgr.mr_n66888992)
print v(xbgr.mr_n66889312)
print v(xbgr.mr_n66889424)
print v(xbgr.mr_n66889744)
print v(xbgr.mr_n66889856)
print v(xbgr.mr_n66890176)
print v(xbgr.mr_n66890288)
print v(xbgr.mr_n66890608)
print v(xbgr.mr_n66890720)
print v(xbgr.mr_n66891040)
print v(xbgr.mr_n66891152)
print v(xbgr.mr_n66891472)
print v(xbgr.mr_n66891584)
print v(xbgr.mr_n66891904)
print v(xbgr.mr_n66892016)
print v(xbgr.mr_n66892336)
print v(xbgr.mr_n66892448)
print v(xbgr.mr_n66892768)
print v(xbgr.mr_n66892880)
print v(xbgr.mr_n66893200)
print v(xbgr.mr_n66893312)
print v(xbgr.mr_n66893744)
print v(xbgr.mr_n66894064)
print v(xbgr.mr_n66894176)
print v(xbgr.mr_n66894608)
print v(xbgr.mr_n66895040)
print v(xbgr.mr_n66895360)
print v(xbgr.mr_n66895472)
print v(xbgr.mr_n66895792)
print v(xbgr.mr_n66895904)
print v(xbgr.mr_n66896224)
print v(xbgr.mr_n66896336)
print v(xbgr.mr_n66896656)
print v(xbgr.mr_n66896768)
print v(xbgr.mr_n66897200)
print v(xbgr.mr_n66897632)
print v(xbgr.mr_n66898064)
print v(xbgr.mr_n66898496)
print v(xbgr.mr_n66898928)
print v(xbgr.mr_n66899360)
print v(xbgr.mr_n66899792)
print v(xbgr.mr_n66900224)
print v(xbgr.mr_n66900544)
print v(xbgr.mr_n66900656)
print v(xbgr.mr_n66900976)
print v(xbgr.mr_n66901088)
print v(xbgr.mr_n66901408)
print v(xbgr.mr_n66901520)
print v(xbgr.mr_n66901840)
print v(xbgr.mr_n66901952)
print v(xbgr.mr_n66902272)
print v(xbgr.mr_n66902384)
print v(xbgr.mr_n66902704)
print v(xbgr.mr_n66902816)
print v(xbgr.mr_n66903136)
print v(xbgr.mr_n66903248)
print v(xbgr.mr_n66903568)
print v(xbgr.mr_n66903680)
print v(xbgr.mr_n66904000)
print v(xbgr.mr_n66904112)
print v(xbgr.mr_n66904432)
print v(xbgr.mr_n66904544)
print v(xbgr.mr_n66904864)
print v(xbgr.mr_n66904976)
print v(xbgr.mr_n66905296)
print v(xbgr.mr_n66905408)
print v(xbgr.mr_n66905728)
print v(xbgr.mr_n66905840)
print v(xbgr.mr_n66906160)
print v(xbgr.mr_n66906272)
print v(xbgr.mr_n66906592)
print v(xbgr.mr_n66906704)
print v(xbgr.mr_n66907024)
print v(xbgr.mr_n66907136)
print v(xbgr.mr_n66907456)
print v(xbgr.mr_n66907568)
print v(xbgr.mr_n66907888)
print v(xbgr.mr_n66908000)
print v(xbgr.mr_n66908320)
print v(xbgr.mr_n66908432)
print v(xbgr.mr_n66908752)
print v(xbgr.mr_n66908864)
print v(xbgr.mr_n66909184)
print v(xbgr.mr_n66909296)
print v(xbgr.mr_n66909616)
print v(xbgr.mr_n66909728)
print v(xbgr.mr_n66910048)
print v(xbgr.mr_n66910160)
print v(xbgr.mr_n66910480)
print v(xbgr.mr_n66910592)
print v(xbgr.mr_n66911024)
print v(xbgr.mr_n66911456)
print v(xbgr.mr_n66911776)
print v(xbgr.mr_n66911888)
print v(xbgr.mr_n66912208)
print v(xbgr.mr_n66912320)
print v(xbgr.mr_n66912752)
print v(xbgr.mr_n66913184)
print v(xbgr.mr_n66913616)
print v(xbgr.mr_n66914048)
print v(xbgr.mr_n66914480)
print v(xbgr.mr_n66914912)
print v(xbgr.mr_n66915344)
print v(xbgr.mr_n66915776)
print v(xbgr.mr_n66916208)
print v(xbgr.mr_n66916640)
print v(xbgr.mr_n66917072)
print v(xbgr.mr_n66917504)
print v(xbgr.mr_n66917936)
print v(xbgr.mr_n66918368)
print v(xbgr.mr_n66918800)
print v(xbgr.mr_n66919232)
print v(xbgr.mr_n66919664)
print v(xbgr.mr_n66920096)
print v(xbgr.mr_n66920528)
print v(xbgr.mr_n66920960)
print v(xbgr.mr_n66921392)
print v(xbgr.mr_n66921824)
print v(xbgr.mr_n66922256)
print v(xbgr.mr_n66922688)
print v(xbgr.mr_n66923008)
print v(xbgr.mr_n66923120)
print v(xbgr.mr_n66923440)
print v(xbgr.mr_n66923552)
print v(xbgr.mr_n66923872)
print v(xbgr.mr_n66923984)
print v(xbgr.mr_n66924304)
print v(xbgr.mr_n66924416)
print v(xbgr.mr_n66924736)
print v(xbgr.mr_n66924848)
print v(xbgr.mr_n66925168)
print v(xbgr.mr_n66925280)
print v(xbgr.mr_n66925600)
print v(xbgr.mr_n66925712)
print v(xbgr.mr_n66926032)
print v(xbgr.mr_n66926144)
print v(xbgr.mr_n66926464)
print v(xbgr.mr_n66926576)
print v(xbgr.mr_n66926896)
print v(xbgr.mr_n66927008)
print v(xbgr.mr_n66927328)
print v(xbgr.mr_n66927440)
print v(xbgr.mr_n66927760)
print v(xbgr.mr_n66927872)
print v(xbgr.mr_n66928192)
print v(xbgr.mr_n66928304)
print v(xbgr.mr_n66928736)
print v(xbgr.mr_n66929168)
print v(xbgr.mr_n66929600)
print v(xbgr.mr_n66930032)
print v(xbgr.mr_n66930464)
print v(xbgr.mr_n66930896)
print v(xbgr.mr_n66931328)
print v(xbgr.mr_n66931760)
print v(xbgr.mr_n66932192)
print v(xbgr.mr_n66932624)
print v(xbgr.mr_n66933056)
print v(xbgr.mr_n66933488)
print v(xbgr.mr_n66933920)
print v(xbgr.mr_n66934240)
print v(xbgr.mr_n66934352)
print v(xbgr.mr_n66934672)
print v(xbgr.mr_n66934784)
print v(xbgr.mr_n66935104)
print v(xbgr.mr_n66935216)
print v(xbgr.mr_n66935536)
print v(xbgr.mr_n66935648)
print v(xbgr.mr_n66935968)
print v(xbgr.mr_n66936080)
print v(xbgr.mr_n66936400)
print v(xbgr.mr_n66936512)
print v(xbgr.mr_n66936832)
print v(xbgr.mr_n66936944)
print v(xbgr.mr_n66937264)
print v(xbgr.mr_n66937376)
print v(xbgr.mr_n66937696)
print v(xbgr.mr_n66937808)
print v(xbgr.mr_n66938128)
print v(xbgr.mr_n66938240)
print v(xbgr.mr_n66938560)
print v(xbgr.mr_n66938672)
print v(xbgr.mr_n66938992)
print v(xbgr.mr_n66939104)
print v(xbgr.mr_n66939424)
print v(xbgr.mr_n66939536)
print v(xbgr.mr_n66939968)
print v(xbgr.mr_n66940400)
print v(xbgr.mr_n66940832)
print v(xbgr.mr_n66941264)
print v(xbgr.mr_n66941696)
print v(xbgr.mr_n66942128)
print v(xbgr.mr_n66942560)
print v(xbgr.mr_n66942992)
print v(xbgr.mr_n66943424)
print v(xbgr.mr_n66943856)
print v(xbgr.mr_n66944288)
print v(xbgr.mr_n66944720)
print v(xbgr.mr_n66945152)
print v(xbgr.mr_n66945472)
print v(xbgr.mr_n66945584)
print v(xbgr.mr_n66945904)
print v(xbgr.mr_n66946016)
print v(xbgr.mr_n66946336)
print v(xbgr.mr_n66946448)
print v(xbgr.mr_n66946768)
print v(xbgr.mr_n66946880)
print v(xbgr.mr_n66947200)
print v(xbgr.mr_n66947312)
print v(xbgr.mr_n66947632)
print v(xbgr.mr_n66947744)
print v(xbgr.mr_n66948064)
print v(xbgr.mr_n66948176)
print v(xbgr.mr_n66948496)
print v(xbgr.mr_n66948608)
print v(xbgr.mr_n66948928)
print v(xbgr.mr_n66949040)
print v(xbgr.mr_n66949360)
print v(xbgr.mr_n66949472)
print v(xbgr.mr_n66949792)
print v(xbgr.mr_n66949904)
print v(xbgr.mr_n66950224)
print v(xbgr.mr_n66950336)
print v(xbgr.mr_n66950656)
print v(xbgr.mr_n66950768)
print v(xbgr.mr_n66951200)
print v(xbgr.mr_n66951632)
print v(xbgr.mr_n66952064)
print v(xbgr.mr_n66952496)
print v(xbgr.mr_n66952928)
print v(xbgr.mr_n66953360)
print v(xbgr.mr_n66953792)
print v(xbgr.mr_n66954224)
print v(xbgr.mr_n66954656)
print v(xbgr.mr_n66955088)
print v(xbgr.mr_n66955520)
print v(xbgr.mr_n66955952)
print v(xbgr.mr_n66956384)
print v(xbgr.mr_n66956704)
print v(xbgr.mr_n66956816)
print v(xbgr.mr_n66957136)
print v(xbgr.mr_n66957248)
print v(xbgr.mr_n66957568)
print v(xbgr.mr_n66957680)
print v(xbgr.mr_n66958000)
print v(xbgr.mr_n66958112)
print v(xbgr.mr_n66958432)
print v(xbgr.mr_n66958544)
print v(xbgr.mr_n66958864)
print v(xbgr.mr_n66958976)
print v(xbgr.mr_n66959296)
print v(xbgr.mr_n66959408)
print v(xbgr.mr_n66959840)
print v(xbgr.mr_n66960272)
print v(xbgr.mr_n66960704)
print v(xbgr.mr_n66961136)
print v(xbgr.mr_n66961456)
print v(xbgr.mr_n66961568)
print v(xbgr.mr_n66961888)
print v(xbgr.mr_n66962000)
print v(xbgr.mr_n66962320)
print v(xbgr.mr_n66962432)
print v(xbgr.mr_n66962752)
print v(xbgr.mr_n66962864)
print v(xbgr.mr_n66963184)
print v(xbgr.mr_n66963296)
print v(xbgr.mr_n66963616)
print v(xbgr.mr_n66963728)
print v(xbgr.mr_n66964160)
print v(xbgr.mr_n66964592)
print v(xbgr.mr_n66965024)
print v(xbgr.mr_n66965456)
print v(xbgr.mr_n66965888)
print v(xbgr.mr_n66966320)
print v(xbgr.mr_n66966752)
print v(xbgr.mr_n66967184)
print v(xbgr.mr_n66967616)
print v(xbgr.mr_n66967936)
print v(xbgr.mr_n66968048)
print v(xbgr.mr_n66968368)
print v(xbgr.mr_n66968480)
print v(xbgr.mr_n66968800)
print v(xbgr.mr_n66968912)
print v(xbgr.mr_n66969232)
print v(xbgr.mr_n66969344)
print v(xbgr.mr_n66969664)
print v(xbgr.mr_n66969776)
print v(xbgr.mr_n66970096)
print v(xbgr.mr_n66970208)
print v(xbgr.mr_n66970528)
print v(xbgr.mr_n66970640)
print v(xbgr.mr_n66970960)
print v(xbgr.mr_n66971072)
print v(xbgr.mr_n66971392)
print v(xbgr.mr_n66971504)
print v(xbgr.mr_n66971824)
print v(xbgr.mr_n66971936)
print v(xbgr.mr_n66972256)
print v(xbgr.mr_n66972368)
print v(xbgr.mr_n66972688)
print v(xbgr.mr_n66972800)
print v(xbgr.mr_n66973120)
print v(xbgr.mr_n66973232)
print v(xbgr.mr_n66973552)
print v(xbgr.mr_n66973664)
print v(xbgr.mr_n66974096)
print v(xbgr.mr_n66974528)
print v(xbgr.mr_n66974960)
print v(xbgr.mr_n66975392)
print v(xbgr.mr_n66975712)
print v(xbgr.mr_n66975824)
print v(xbgr.mr_n66976144)
print v(xbgr.mr_n66976256)
print v(xbgr.mr_n66976688)
print v(xbgr.mr_n66977120)
print v(xbgr.mr_n66977552)
print v(xbgr.mr_n66977984)
print v(xbgr.mr_n66978416)
print v(xbgr.mr_n66978848)
print v(xbgr.mr_n66979280)
print v(xbgr.mr_n66979712)
print v(xbgr.mr_n66980032)
print v(xbgr.mr_n66980144)
print v(xbgr.mr_n66980464)
print v(xbgr.mr_n66980576)
print v(xbgr.mr_n66980896)
print v(xbgr.mr_n66981008)
print v(xbgr.mr_n66981328)
print v(xbgr.mr_n66981440)
print v(xbgr.mr_n66981760)
print v(xbgr.mr_n66981872)
print v(xbgr.mr_n66982192)
print v(xbgr.mr_n66982304)
print v(xbgr.mr_n66982624)
print v(xbgr.mr_n66982736)
print v(xbgr.mr_n66983056)
print v(xbgr.mr_n66983168)
print v(xbgr.mr_n66983488)
print v(xbgr.mr_n66983600)
print v(xbgr.mr_n66983920)
print v(xbgr.mr_n66984032)
print v(xbgr.mr_n66984352)
print v(xbgr.mr_n66984464)
print v(xbgr.mr_n66984784)
print v(xbgr.mr_n66984896)
print v(xbgr.mr_n66985328)
print v(xbgr.mr_n66985760)
print v(xbgr.mr_n66986192)
print v(xbgr.mr_n66986624)
print v(xbgr.mr_n66987056)
print v(xbgr.mr_n66987488)
print v(xbgr.mr_n66987808)
print v(xbgr.mr_n66987920)
print v(xbgr.mr_n66988240)
print v(xbgr.mr_n66988352)
print v(xbgr.mr_n66988672)
print v(xbgr.mr_n66988784)
print v(xbgr.mr_n66989104)
print v(xbgr.mr_n66989216)
print v(xbgr.mr_n66989536)
print v(xbgr.mr_n66989648)
print v(xbgr.mr_n66989968)
print v(xbgr.mr_n66990080)
print v(xbgr.mr_n66990400)
print v(xbgr.mr_n66990512)
print v(xbgr.mr_n66990832)
print v(xbgr.mr_n66990944)
print v(xbgr.mr_n66991264)
print v(xbgr.mr_n66991376)
print v(xbgr.mr_n66991696)
print v(xbgr.mr_n66991808)
print v(xbgr.mr_n66992128)
print v(xbgr.mr_n66992240)
print v(xbgr.mr_n66992560)
print v(xbgr.mr_n66992672)
print v(xbgr.mr_n66992992)
print v(xbgr.mr_n66993104)
print v(xbgr.mr_n66993424)
print v(xbgr.mr_n66993536)
print v(xbgr.mr_n66993856)
print v(xbgr.mr_n66993968)
print v(xbgr.mr_n66994288)
print v(xbgr.mr_n66994400)
print v(xbgr.mr_n66994720)
print v(xbgr.mr_n66994832)
print v(xbgr.mr_n66995152)
print v(xbgr.mr_n66995264)
print v(xbgr.mr_n66995696)
print v(xbgr.mr_n66996128)
print v(xbgr.mr_n66996448)
print v(xbgr.mr_n66996560)
print v(xbgr.mr_n66996880)
print v(xbgr.mr_n66996992)
print v(xbgr.mr_n66997312)
print v(xbgr.mr_n66997424)
print v(xbgr.mr_n66997744)
print v(xbgr.mr_n66997856)
print v(xbgr.mr_n66998288)
print v(xbgr.mr_n66998720)
print v(xbgr.mr_n66999152)
print v(xbgr.mr_n66999584)
print v(xbgr.mr_n67000016)
print v(xbgr.mr_n67000448)
print v(xbgr.mr_n67000880)
print v(xbgr.mr_n67001312)
print v(xbgr.mr_n67001744)
print v(xbgr.mr_n67002176)
print v(xbgr.mr_n67002608)
print v(xbgr.mr_n67003040)
print v(xbgr.mr_n67003472)
print v(xbgr.mr_n67003904)
print v(xbgr.mr_n67004336)
print v(xbgr.mr_n67004768)
print v(xbgr.mr_n67005088)
print v(xbgr.mr_n67005200)
print v(xbgr.mr_n67005520)
print v(xbgr.mr_n67005632)
print v(xbgr.mr_n67005952)
print v(xbgr.mr_n67006064)
print v(xbgr.mr_n67006384)
print v(xbgr.mr_n67006496)
print v(xbgr.mr_n67006816)
print v(xbgr.mr_n67006928)
print v(xbgr.mr_n67007248)
print v(xbgr.mr_n67007360)
print v(xbgr.mr_n67007680)
print v(xbgr.mr_n67007792)
print v(xbgr.mr_n67008112)
print v(xbgr.mr_n67008224)
print v(xbgr.mr_n67008544)
print v(xbgr.mr_n67008656)
print v(xbgr.mr_n67008976)
print v(xbgr.mr_n67009088)
print v(xbgr.mr_n67009520)
print v(xbgr.mr_n67009952)
print v(xbgr.mr_n67010384)
print v(xbgr.mr_n67010816)
print v(xbgr.mr_n67011248)
print v(xbgr.mr_n67011680)
print v(xbgr.mr_n67012112)
print v(xbgr.mr_n67012544)
print v(xbgr.mr_n67012864)
print v(xbgr.mr_n67012976)
print v(xbgr.mr_n67013296)
print v(xbgr.mr_n67013408)
print v(xbgr.mr_n67013728)
print v(xbgr.mr_n67013840)
print v(xbgr.mr_n67014160)
print v(xbgr.mr_n67014272)
print v(xbgr.mr_n67014592)
print v(xbgr.mr_n67014704)
print v(xbgr.mr_n67015024)
print v(xbgr.mr_n67015136)
print v(xbgr.mr_n67015456)
print v(xbgr.mr_n67015568)
print v(xbgr.mr_n67015888)
print v(xbgr.mr_n67016000)
print v(xbgr.mr_n67016320)
print v(xbgr.mr_n67016432)
print v(xbgr.mr_n67016752)
print v(xbgr.mr_n67016864)
print v(xbgr.mr_n67017184)
print v(xbgr.mr_n67017296)
print v(xbgr.mr_n67017616)
print v(xbgr.mr_n67017728)
print v(xbgr.mr_n67018048)
print v(xbgr.mr_n67018160)
print v(xbgr.mr_n67018480)
print v(xbgr.mr_n67018592)
print v(xbgr.mr_n67019024)
print v(xbgr.mr_n67019456)
print v(xbgr.mr_n67019888)
print v(xbgr.mr_n67020320)
print v(xbgr.mr_n67020752)
print v(xbgr.mr_n67021184)
print v(xbgr.mr_n67021616)
print v(xbgr.mr_n67022048)
print v(xbgr.mr_n67022480)
print v(xbgr.mr_n67022912)
print v(xbgr.mr_n67023344)
print v(xbgr.mr_n67023776)
print v(xbgr.mr_n67024208)
print v(xbgr.mr_n67024640)
print v(xbgr.mr_n67024960)
print v(xbgr.mr_n67025072)
print v(xbgr.mr_n67025392)
print v(xbgr.mr_n67025504)
print v(xbgr.mr_n67025824)
print v(xbgr.mr_n67025936)
print v(xbgr.mr_n67026256)
print v(xbgr.mr_n67026368)
print v(xbgr.mr_n67026688)
print v(xbgr.mr_n67026800)
print v(xbgr.mr_n67027120)
print v(xbgr.mr_n67027232)
print v(xbgr.mr_n67027552)
print v(xbgr.mr_n67027664)
print v(xbgr.mr_n67027984)
print v(xbgr.mr_n67028096)
print v(xbgr.mr_n67028416)
print v(xbgr.mr_n67028528)
print v(xbgr.mr_n67028848)
print v(xbgr.mr_n67028960)
print v(xbgr.mr_n67029280)
print v(xbgr.mr_n67029392)
print v(xbgr.mr_n67029712)
print v(xbgr.mr_n67029824)
print v(xbgr.mr_n67030144)
print v(xbgr.mr_n67030256)
print v(xbgr.mr_n67030576)
print v(xbgr.mr_n67030688)
print v(xbgr.mr_n67031008)
print v(xbgr.mr_n67031120)
print v(xbgr.mr_n67031440)
print v(xbgr.mr_n67031552)
print v(xbgr.mr_n67031872)
print v(xbgr.mr_n67031984)
print v(xbgr.mr_n67032304)
print v(xbgr.mr_n67032416)
print v(xbgr.mr_n67032736)
print v(xbgr.mr_n67032848)
print v(xbgr.mr_n67033168)
print v(xbgr.mr_n67033280)
print v(xbgr.mr_n67033600)
print v(xbgr.mr_n67033712)
print v(xbgr.mr_n67034032)
print v(xbgr.mr_n67034144)
print v(xbgr.mr_n67034464)
print v(xbgr.mr_n67034576)
print v(xbgr.mr_n67034896)
print v(xbgr.mr_n67035008)
print v(xbgr.mr_n67035440)
print v(xbgr.mr_n67035872)
print v(xbgr.mr_n67036304)
print v(xbgr.mr_n67036736)
print v(xbgr.mr_n67037168)
print v(xbgr.mr_n67037600)
print v(xbgr.mr_n67038032)
print v(xbgr.mr_n67038464)
print v(xbgr.mr_n67038896)
print v(xbgr.mr_n67039328)
print v(xbgr.mr_n67039760)
print v(xbgr.mr_n67040192)
print v(xbgr.mr_n67040624)
print v(xbgr.mr_n67041056)
print v(xbgr.mr_n67041488)
print v(xbgr.mr_n67041920)
print v(xbgr.mr_n67042240)
print v(xbgr.mr_n67042352)
print v(xbgr.mr_n67042672)
print v(xbgr.mr_n67042784)
print v(xbgr.mr_n67043216)
print v(xbgr.mr_n67043648)
print v(xbgr.mr_n67044080)
print v(xbgr.mr_n67044512)
print v(xbgr.mr_n67044944)
print v(xbgr.mr_n67045376)
print v(xbgr.mr_n67045808)
print v(xbgr.mr_n67046240)
print v(xbgr.mr_n67046672)
print v(xbgr.mr_n67047104)
print v(xbgr.mr_n67047424)
print v(xbgr.mr_n67047536)
print v(xbgr.mr_n67047856)
print v(xbgr.mr_n67047968)
print v(xbgr.mr_n67048288)
print v(xbgr.mr_n67048400)
print v(xbgr.mr_n67048720)
print v(xbgr.mr_n67048832)
print v(xbgr.mr_n67049152)
print v(xbgr.mr_n67049264)
print v(xbgr.mr_n67049584)
print v(xbgr.mr_n67049696)
print v(xbgr.mr_n67050016)
print v(xbgr.mr_n67050128)
print v(xbgr.mr_n67050448)
print v(xbgr.mr_n67050560)
print v(xbgr.mr_n67050880)
print v(xbgr.mr_n67050992)
print v(xbgr.mr_n67051312)
print v(xbgr.mr_n67051424)
print v(xbgr.mr_n67051744)
print v(xbgr.mr_n67051856)
print v(xbgr.mr_n67052176)
print v(xbgr.mr_n67052288)
print v(xbgr.mr_n67052608)
print v(xbgr.mr_n67052720)
print v(xbgr.mr_n67053152)
print v(xbgr.mr_n67053584)
print v(xbgr.mr_n67054016)
print v(xbgr.mr_n67054448)
print v(xbgr.mr_n67054880)
print v(xbgr.mr_n67055312)
print v(xbgr.mr_n67055744)
print v(xbgr.mr_n67056176)
print v(xbgr.mr_n67056608)
print v(xbgr.mr_n67057040)
print v(xbgr.mr_n67057472)
print v(xbgr.mr_n67057904)
print v(xbgr.mr_n67058336)
print v(xbgr.mr_n67058656)
print v(xbgr.mr_n67058768)
print v(xbgr.mr_n67059088)
print v(xbgr.mr_n67059200)
print v(xbgr.mr_n67059520)
print v(xbgr.mr_n67059632)
print v(xbgr.mr_n67059952)
print v(xbgr.mr_n67060064)
print v(xbgr.mr_n67060384)
print v(xbgr.mr_n67060496)
print v(xbgr.mr_n67060816)
print v(xbgr.mr_n67060928)
print v(xbgr.mr_n67061248)
print v(xbgr.mr_n67061360)
print v(xbgr.mr_n67061680)
print v(xbgr.mr_n67061792)
print v(xbgr.mr_n67062112)
print v(xbgr.mr_n67062224)
print v(xbgr.mr_n67062544)
print v(xbgr.mr_n67062656)
print v(xbgr.mr_n67062976)
print v(xbgr.mr_n67063088)
print v(xbgr.mr_n67063408)
print v(xbgr.mr_n67063520)
print v(xbgr.mr_n67063840)
print v(xbgr.mr_n67063952)
print v(xbgr.mr_n67064384)
print v(xbgr.mr_n67064816)
print v(xbgr.mr_n67065248)
print v(xbgr.mr_n67065680)
print v(xbgr.mr_n67066112)
print v(xbgr.mr_n67066544)
print v(xbgr.mr_n67066976)
print v(xbgr.mr_n67067408)
print v(xbgr.mr_n67067840)
print v(xbgr.mr_n67068272)
print v(xbgr.mr_n67068704)
print v(xbgr.mr_n67069136)
print v(xbgr.mr_n67069568)
print v(xbgr.mr_n67069888)
print v(xbgr.mr_n67070000)
print v(xbgr.mr_n67070320)
print v(xbgr.mr_n67070432)
print v(xbgr.mr_n67070752)
print v(xbgr.mr_n67070864)
print v(xbgr.mr_n67071184)
print v(xbgr.mr_n67071296)
print v(xbgr.mr_n67071616)
print v(xbgr.mr_n67071728)
print v(xbgr.mr_n67072048)
print v(xbgr.mr_n67072160)
print v(xbgr.mr_n67072480)
print v(xbgr.mr_n67072592)
print v(xbgr.mr_n67072912)
print v(xbgr.mr_n67073024)
print v(xbgr.mr_n67073344)
print v(xbgr.mr_n67073456)
print v(xbgr.mr_n67073776)
print v(xbgr.mr_n67073888)
print v(xbgr.mr_n67074208)
print v(xbgr.mr_n67074320)
print v(xbgr.mr_n67074640)
print v(xbgr.mr_n67074752)
print v(xbgr.mr_n67075072)
print v(xbgr.mr_n67075184)
print v(xbgr.mr_n67075616)
print v(xbgr.mr_n67076048)
print v(xbgr.mr_n67076480)
print v(xbgr.mr_n67076912)
print v(xbgr.mr_n67077344)
print v(xbgr.mr_n67077776)
print v(xbgr.mr_n67078208)
print v(xbgr.mr_n67078640)
print v(xbgr.mr_n67079072)
print v(xbgr.mr_n67079504)
print v(xbgr.mr_n67079936)
print v(xbgr.mr_n67080368)
print v(xbgr.mr_n67080800)
print v(xbgr.mr_n67081120)
print v(xbgr.mr_n67081232)
print v(xbgr.mr_n67081552)
print v(xbgr.mr_n67081664)
print v(xbgr.mr_n67081984)
print v(xbgr.mr_n67082096)
print v(xbgr.mr_n67082416)
print v(xbgr.mr_n67082528)
print v(xbgr.mr_n67082848)
print v(xbgr.mr_n67082960)
print v(xbgr.mr_n67083280)
print v(xbgr.mr_n67083392)
print v(xbgr.mr_n67083712)
print v(xbgr.mr_n67083824)
print v(xbgr.mr_n67084144)
print v(xbgr.mr_n67084256)
print v(xbgr.mr_n67084576)
print v(xbgr.mr_n67084688)
print v(xbgr.mr_n67085008)
print v(xbgr.mr_n67085120)
print v(xbgr.mr_n67085440)
print v(xbgr.mr_n67085552)
print v(xbgr.mr_n67085872)
print v(xbgr.mr_n67085984)
print v(xbgr.mr_n67086304)
print v(xbgr.mr_n67086416)
print v(xbgr.mr_n67086848)
print v(xbgr.mr_n67087280)
print v(xbgr.mr_n67087712)
print v(xbgr.mr_n67088144)
print v(xbgr.mr_n67088576)
print v(xbgr.mr_n67089008)
print v(xbgr.mr_n67089440)
print v(xbgr.mr_n67089872)
print v(xbgr.mr_n67090304)
print v(xbgr.mr_n67090736)
print v(xbgr.mr_n67091168)
print v(xbgr.mr_n67091600)
print v(xbgr.mr_n67092032)
print v(xbgr.mr_n67092352)
print v(xbgr.mr_n67092464)
print v(xbgr.mr_n67092784)
print v(xbgr.mr_n67092896)
print v(xbgr.mr_n67093216)
print v(xbgr.mr_n67093328)
print v(xbgr.mr_n67093648)
print v(xbgr.mr_n67093760)
print v(xbgr.mr_n67094080)
print v(xbgr.mr_n67094192)
print v(xbgr.mr_n67094624)
print v(xbgr.mr_n67095056)
print v(xbgr.mr_n67095488)
print v(xbgr.mr_n67095920)
print v(xbgr.mr_n67096352)
print v(xbgr.mr_n67096672)
print v(xbgr.mr_n67096784)
print v(xbgr.mr_n67097104)
print v(xbgr.mr_n67097216)
print v(xbgr.mr_n67097536)
print v(xbgr.mr_n67097648)
print v(xbgr.mr_n67097968)
print v(xbgr.mr_n67098080)
print v(xbgr.mr_n67098400)
print v(xbgr.mr_n67098512)
print v(xbgr.mr_n67098832)
print v(xbgr.mr_n67098944)
print v(xbgr.mr_n67099264)
print v(xbgr.mr_n67099376)
print v(xbgr.mr_n67099696)
print v(xbgr.mr_n67099808)
print v(xbgr.mr_n67100240)
print v(xbgr.mr_n67100672)
print v(xbgr.mr_n67101104)
print v(xbgr.mr_n67101536)
print v(xbgr.mr_n67101968)
print v(xbgr.mr_n67102400)
print v(xbgr.mr_n67102832)
print v(xbgr.mr_n67103264)
print v(xbgr.mr_n67103584)
print v(xbgr.mr_n67103696)
print v(xbgr.mr_n67104016)
print v(xbgr.mr_n67104128)
print v(xbgr.mr_n67104448)
print v(xbgr.mr_n67104560)
print v(xbgr.mr_n67104880)
print v(xbgr.mr_n67104992)
print v(xbgr.mr_n67105312)
print v(xbgr.mr_n67105424)
print v(xbgr.mr_n67105744)
print v(xbgr.mr_n67105856)
print v(xbgr.mr_n67106176)
print v(xbgr.mr_n67106288)
print v(xbgr.mr_n67106608)
print v(xbgr.mr_n67106720)
print v(xbgr.mr_n67107152)
print v(xbgr.mr_n67107584)
print v(xbgr.mr_n67108016)
print v(xbgr.mr_n67108448)
print v(xbgr.mr_n67108880)
print v(xbgr.mr_n67109200)
print v(xbgr.mr_n67109312)
print v(xbgr.mr_n67109632)
print v(xbgr.mr_n67109744)
print v(xbgr.mr_n67110064)
print v(xbgr.mr_n67110176)
print v(xbgr.mr_n67110496)
print v(xbgr.mr_n67110608)
print v(xbgr.mr_n67110928)
print v(xbgr.mr_n67111040)
print v(xbgr.mr_n67111472)
print v(xbgr.mr_n67111904)
print v(xbgr.mr_n67112336)
print v(xbgr.mr_n67112768)
print v(xbgr.mr_n67113200)
print v(xbgr.mr_n67113632)
print v(xbgr.mr_n67114064)
print v(xbgr.mr_n67114496)
print v(xbgr.mr_n67114816)
print v(xbgr.mr_n67114928)
print v(xbgr.mr_n67115248)
print v(xbgr.mr_n67115360)
print v(xbgr.mr_n67115680)
print v(xbgr.mr_n67115792)
print v(xbgr.mr_n67116112)
print v(xbgr.mr_n67116224)
print v(xbgr.mr_n67116544)
print v(xbgr.mr_n67116656)
print v(xbgr.mr_n67116976)
print v(xbgr.mr_n67117088)
print v(xbgr.mr_n67117408)
print v(xbgr.mr_n67117520)
print v(xbgr.mr_n67117952)
print v(xbgr.mr_n67118384)
print v(xbgr.mr_n67118816)
print v(xbgr.mr_n67119248)
print v(xbgr.mr_n67119568)
print v(xbgr.mr_n67119680)
print v(xbgr.mr_n67120112)
print v(xbgr.mr_n67120544)
print v(xbgr.mr_n67120864)
print v(xbgr.mr_n67120976)
print v(xbgr.mr_n67121296)
print v(xbgr.mr_n67121408)
print v(xbgr.mr_n67121728)
print v(xbgr.mr_n67121840)
print v(xbgr.mr_n67122160)
print v(xbgr.mr_n67122272)
print v(xbgr.mr_n67122592)
print v(xbgr.mr_n67122704)
print v(xbgr.mr_n67123136)
print v(xbgr.mr_n67123568)
print v(xbgr.mr_n67124000)
print v(xbgr.mr_n67124432)
print v(xbgr.mr_n67124864)
print v(xbgr.mr_n67125296)
print v(xbgr.mr_n67125728)
print v(xbgr.mr_n67126048)
print v(xbgr.mr_n67126160)
print v(xbgr.mr_n67126480)
print v(xbgr.mr_n67126592)
print v(xbgr.mr_n67126912)
print v(xbgr.mr_n67127024)
print v(xbgr.mr_n67127344)
print v(xbgr.mr_n67127456)
print v(xbgr.mr_n67127776)
print v(xbgr.mr_n67127888)
print v(xbgr.mr_n67128208)
print v(xbgr.mr_n67128320)
print v(xbgr.mr_n67128640)
print v(xbgr.mr_n67128752)
print v(xbgr.mr_n67129072)
print v(xbgr.mr_n67129184)
print v(xbgr.mr_n67129504)
print v(xbgr.mr_n67129616)
print v(xbgr.mr_n67129936)
print v(xbgr.mr_n67130048)
print v(xbgr.mr_n67130368)
print v(xbgr.mr_n67130480)
print v(xbgr.mr_n67130800)
print v(xbgr.mr_n67130912)
print v(xbgr.mr_n67131232)
print v(xbgr.mr_n67131344)
print v(xbgr.mr_n67131776)
print v(xbgr.mr_n67132208)
print v(xbgr.mr_n67132640)
print v(xbgr.mr_n67133072)
print v(xbgr.mr_n67133504)
print v(xbgr.mr_n67133936)
print v(xbgr.mr_n67134368)
print v(xbgr.mr_n67134800)
print v(xbgr.mr_n67135232)
print v(xbgr.mr_n67135664)
print v(xbgr.mr_n67136096)
print v(xbgr.mr_n67136528)
print v(xbgr.mr_n67136960)
print v(xbgr.mr_n67137280)
print v(xbgr.mr_n67137392)
print v(xbgr.mr_n67137712)
print v(xbgr.mr_n67137824)
print v(xbgr.mr_n67138144)
print v(xbgr.mr_n67138256)
print v(xbgr.mr_n67138576)
print v(xbgr.mr_n67138688)
print v(xbgr.mr_n67139008)
print v(xbgr.mr_n67139120)
print v(xbgr.mr_n67139440)
print v(xbgr.mr_n67139552)
print v(xbgr.mr_n67139872)
print v(xbgr.mr_n67139984)
print v(xbgr.mr_n67140304)
print v(xbgr.mr_n67140416)
print v(xbgr.mr_n67140736)
print v(xbgr.mr_n67140848)
print v(xbgr.mr_n67141168)
print v(xbgr.mr_n67141280)
print v(xbgr.mr_n67141600)
print v(xbgr.mr_n67141712)
print v(xbgr.mr_n67142032)
print v(xbgr.mr_n67142144)
print v(xbgr.mr_n67142464)
print v(xbgr.mr_n67142576)
print v(xbgr.mr_n67142896)
print v(xbgr.mr_n67143008)
print v(xbgr.mr_n67143328)
print v(xbgr.mr_n67143440)
print v(xbgr.mr_n67143760)
print v(xbgr.mr_n67143872)
print v(xbgr.mr_n67144304)
print v(xbgr.mr_n67144736)
print v(xbgr.mr_n67145168)
print v(xbgr.mr_n67145600)
print v(xbgr.mr_n67146032)
print v(xbgr.mr_n67146464)
print v(xbgr.mr_n67146784)
print v(xbgr.mr_n67146896)
print v(xbgr.mr_n67147216)
print v(xbgr.mr_n67147328)
print v(xbgr.mr_n67147648)
print v(xbgr.mr_n67147760)
print v(xbgr.mr_n67148080)
print v(xbgr.mr_n67148192)
print v(xbgr.mr_n67148512)
print v(xbgr.mr_n67148624)
print v(xbgr.mr_n67148944)
print v(xbgr.mr_n67149056)
print v(xbgr.mr_n67149376)
print v(xbgr.mr_n67149488)
print v(xbgr.mr_n67149808)
print v(xbgr.mr_n67149920)
print v(xbgr.mr_n67150240)
print v(xbgr.mr_n67150352)
print v(xbgr.mr_n67150672)
print v(xbgr.mr_n67150784)
print v(xbgr.mr_n67151216)
print v(xbgr.mr_n67151648)
print v(xbgr.mr_n67152080)
print v(xbgr.mr_n67152512)
print v(xbgr.mr_n67152944)
print v(xbgr.mr_n67153376)
print v(xbgr.mr_n67153808)
print v(xbgr.mr_n67154240)
print v(xbgr.mr_n67154672)
print v(xbgr.mr_n67155104)
print v(xbgr.mr_n67155536)
print v(xbgr.mr_n67155968)
print v(xbgr.mr_n67156400)
print v(xbgr.mr_n67156832)
print v(xbgr.mr_n67157264)
print v(xbgr.mr_n67157696)
print v(xbgr.mr_n67158128)
print v(xbgr.mr_n67158560)
print v(xbgr.mr_n67158992)
print v(xbgr.mr_n67159424)
print v(xbgr.mr_n67159744)
print v(xbgr.mr_n67159856)
print v(xbgr.mr_n67160176)
print v(xbgr.mr_n67160288)
print v(xbgr.mr_n67160608)
print v(xbgr.mr_n67160720)
print v(xbgr.mr_n67161040)
print v(xbgr.mr_n67161152)
print v(xbgr.mr_n67161472)
print v(xbgr.mr_n67161584)
print v(xbgr.mr_n67161904)
print v(xbgr.mr_n67162016)
print v(xbgr.mr_n67162336)
print v(xbgr.mr_n67162448)
print v(xbgr.mr_n67162768)
print v(xbgr.mr_n67162880)
print v(xbgr.mr_n67163200)
print v(xbgr.mr_n67163312)
print v(xbgr.mr_n67163632)
print v(xbgr.mr_n67163744)
print v(xbgr.mr_n67164064)
print v(xbgr.mr_n67164176)
print v(xbgr.mr_n67164496)
print v(xbgr.mr_n67164608)
print v(xbgr.mr_n67164928)
print v(xbgr.mr_n67165040)
print v(xbgr.mr_n67165360)
print v(xbgr.mr_n67165472)
print v(xbgr.mr_n67165904)
print v(xbgr.mr_n67166336)
print v(xbgr.mr_n67166768)
print v(xbgr.mr_n67167200)
print v(xbgr.mr_n67167520)
print v(xbgr.mr_n67167632)
print v(xbgr.mr_n67167952)
print v(xbgr.mr_n67168064)
print v(xbgr.mr_n67168384)
print v(xbgr.mr_n67168496)
print v(xbgr.mr_n67168816)
print v(xbgr.mr_n67168928)
print v(xbgr.mr_n67169248)
print v(xbgr.mr_n67169360)
print v(xbgr.mr_n67169680)
print v(xbgr.mr_n67169792)
print v(xbgr.mr_n67170224)
print v(xbgr.mr_n67170656)
print v(xbgr.mr_n67171088)
print v(xbgr.mr_n67171520)
print v(xbgr.mr_n67171952)
print v(xbgr.mr_n67172384)
print v(xbgr.mr_n67172816)
print v(xbgr.mr_n67173248)
print v(xbgr.mr_n67173680)
print v(xbgr.mr_n67174112)
print v(xbgr.mr_n67174432)
print v(xbgr.mr_n67174544)
print v(xbgr.mr_n67174864)
print v(xbgr.mr_n67174976)
print v(xbgr.mr_n67175408)
print v(xbgr.mr_n67175840)
print v(xbgr.mr_n67176160)
print v(xbgr.mr_n67176272)
print v(xbgr.mr_n67176592)
print v(xbgr.mr_n67176704)
print v(xbgr.mr_n67177024)
print v(xbgr.mr_n67177136)
print v(xbgr.mr_n67177456)
print v(xbgr.mr_n67177568)
print v(xbgr.mr_n67178000)
print v(xbgr.mr_n67178432)
print v(xbgr.mr_n67178864)
print v(xbgr.mr_n67179296)
print v(xbgr.mr_n67179728)
print v(xbgr.mr_n67180160)
print v(xbgr.mr_n67180592)
print v(xbgr.mr_n67181024)
print v(xbgr.mr_n67181456)
print v(xbgr.mr_n67181888)
print v(xbgr.mr_n67182208)
print v(xbgr.mr_n67182320)
print v(xbgr.mr_n67182640)
print v(xbgr.mr_n67182752)
print v(xbgr.mr_n67183072)
print v(xbgr.mr_n67183184)
print v(xbgr.mr_n67183504)
print v(xbgr.mr_n67183616)
print v(xbgr.mr_n67183936)
print v(xbgr.mr_n67184048)
print v(xbgr.mr_n67184368)
print v(xbgr.mr_n67184480)
print v(xbgr.mr_n67184800)
print v(xbgr.mr_n67184912)
print v(xbgr.mr_n67185232)
print v(xbgr.mr_n67185344)
print v(xbgr.mr_n67185664)
print v(xbgr.mr_n67185776)
print v(xbgr.mr_n67186096)
print v(xbgr.mr_n67186208)
print v(xbgr.mr_n67186528)
print v(xbgr.mr_n67186640)
print v(xbgr.mr_n67186960)
print v(xbgr.mr_n67187072)
print v(xbgr.mr_n67187392)
print v(xbgr.mr_n67187504)
print v(xbgr.mr_n67187824)
print v(xbgr.mr_n67187936)
print v(xbgr.mr_n67188256)
print v(xbgr.mr_n67188368)
print v(xbgr.mr_n67188688)
print v(xbgr.mr_n67188800)
print v(xbgr.mr_n67189120)
print v(xbgr.mr_n67189232)
print v(xbgr.mr_n67189552)
print v(xbgr.mr_n67189664)
print v(xbgr.mr_n67189984)
print v(xbgr.mr_n67190096)
print v(xbgr.mr_n67190416)
print v(xbgr.mr_n67190528)
print v(xbgr.mr_n67190848)
print v(xbgr.mr_n67190960)
print v(xbgr.mr_n67191280)
print v(xbgr.mr_n67191712)
print v(xbgr.mr_n67191824)
print v(xbgr.mr_n67192144)
print v(xbgr.mr_n67192576)
print v(xbgr.mr_n67192688)
print v(xbgr.mr_n67193008)
print v(xbgr.mr_n67193440)
print v(xbgr.mr_n67193552)
print v(xbgr.mr_n67193872)
print v(xbgr.mr_n67194304)
print v(xbgr.mr_n67194416)
print v(xbgr.mr_n67194736)
print v(xbgr.mr_n67195168)
print v(xbgr.mr_n67195280)
print v(xbgr.mr_n67195600)
print v(xbgr.mr_n67195712)
print v(xbgr.mr_n67196032)
print v(xbgr.mr_n67196144)
print v(xbgr.mr_n67196464)
print v(xbgr.mr_n67196576)
print v(xbgr.mr_n67196896)
print v(xbgr.mr_n67197008)
print v(xbgr.mr_n67197328)
print v(xbgr.mr_n67197440)
print v(xbgr.mr_n67197760)
print v(xbgr.mr_n67197872)
print v(xbgr.mr_n67198192)
print v(xbgr.mr_n67198304)
print v(xbgr.mr_n67198624)
print v(xbgr.mr_n67198736)
print v(xbgr.mr_n67199056)
print v(xbgr.mr_n67199168)
print v(xbgr.mr_n67199488)
print v(xbgr.mr_n67199600)
print v(xbgr.mr_n67199920)
print v(xbgr.mr_n67200032)
print v(xbgr.mr_n67200352)
print v(xbgr.mr_n67200464)
print v(xbgr.mr_n67200784)
print v(xbgr.mr_n67200896)
print v(xbgr.mr_n67201216)
print v(xbgr.mr_n67201328)
print v(xbgr.mr_n67201648)
print v(xbgr.mr_n67201760)
print v(xbgr.mr_n67202080)
print v(xbgr.mr_n67202192)
print v(xbgr.mr_n67202512)
print v(xbgr.mr_n67202624)
print v(xbgr.mr_n67202944)
print v(xbgr.mr_n67203056)
print v(xbgr.mr_n67203376)
print v(xbgr.mr_n67203488)
print v(xbgr.mr_n67203808)
print v(xbgr.mr_n67203920)
print v(xbgr.mr_n67204240)
print v(xbgr.mr_n67204352)
print v(xbgr.mr_n67204672)
print v(xbgr.mr_n67204784)
print v(xbgr.mr_n67205104)
print v(xbgr.mr_n67205216)
print v(xbgr.mr_n67205536)
print v(xbgr.mr_n67205648)
print v(xbgr.mr_n67205968)
print v(xbgr.mr_n67206080)
print v(xbgr.mr_n67206400)
print v(xbgr.mr_n67206512)
print v(xbgr.mr_n67206832)
print v(xbgr.mr_n67206944)
print v(xbgr.mr_n67207264)
print v(xbgr.mr_n67207376)
print v(xbgr.mr_n67207696)
print v(xbgr.mr_n67207808)
print v(xbgr.mr_n67208128)
print v(xbgr.mr_n67208240)
print v(xbgr.mr_n67208560)
print v(xbgr.mr_n67208672)
print v(xbgr.mr_n67208992)
print v(xbgr.mr_n67209104)
print v(xbgr.mr_n67209424)
print v(xbgr.mr_n67209536)
print v(xbgr.mr_n67209856)
print v(xbgr.mr_n67209968)
print v(xbgr.mr_n67210288)
print v(xbgr.mr_n67210400)
print v(xbgr.mr_n67210720)
print v(xbgr.mr_n67210832)
print v(xbgr.mr_n67211152)
print v(xbgr.mr_n67211264)
print v(xbgr.mr_n67211584)
print v(xbgr.mr_n67211696)
print v(xbgr.mr_n67212016)
print v(xbgr.mr_n67212128)
print v(xbgr.mr_n67212448)
print v(xbgr.mr_n67212560)
print v(xbgr.mr_n67212880)
print v(xbgr.mr_n67212992)
print v(xbgr.mr_n67213312)
print v(xbgr.mr_n67213424)
print v(xbgr.mr_n67213744)
print v(xbgr.mr_n67213856)
print v(xbgr.mr_n67214176)
print v(xbgr.mr_n67214288)
print v(xbgr.mr_n67214608)
print v(xbgr.mr_n67214720)
print v(xbgr.mr_n67215040)
print v(xbgr.mr_n67215152)
print v(xbgr.mr_n67215472)
print v(xbgr.mr_n67215584)
print v(xbgr.mr_n67215904)
print v(xbgr.mr_n67216016)
print v(xbgr.mr_n67216336)
print v(xbgr.mr_n67216448)
print v(xbgr.mr_n67216768)
print v(xbgr.mr_n67216880)
print v(xbgr.mr_n67217200)
print v(xbgr.mr_n67217312)
print v(xbgr.mr_n67217632)
print v(xbgr.mr_n67217744)
print v(xbgr.mr_n67218064)
print v(xbgr.mr_n67218176)
print v(xbgr.mr_n67218496)
print v(xbgr.mr_n67218608)
print v(xbgr.mr_n67218928)
print v(xbgr.mr_n67219040)
print v(xbgr.mr_n67219360)
print v(xbgr.mr_n67219472)
print v(xbgr.mr_n67219792)
print v(xbgr.mr_n67219904)
print v(xbgr.mr_n67220224)
print v(xbgr.mr_n67220336)
print v(xbgr.mr_n67220656)
print v(xbgr.mr_n67220768)
print v(xbgr.mr_n67221088)
print v(xbgr.mr_n67221200)
print v(xbgr.mr_n67221520)
print v(xbgr.mr_n67221632)
print v(xbgr.mr_n67221952)
print v(xbgr.mr_n67222064)
print v(xbgr.mr_n67222384)
print v(xbgr.mr_n67222496)
print v(xbgr.mr_n67222816)
print v(xbgr.mr_n67222928)
print v(xbgr.mr_n67223248)
print v(xbgr.mr_n67223360)
print v(xbgr.mr_n67223680)
print v(xbgr.mr_n67223792)
print v(xbgr.mr_n67224112)
print v(xbgr.mr_n67224224)
print v(xbgr.mr_n67224544)
print v(xbgr.mr_n67224656)
print v(xbgr.mr_n67224976)
print v(xbgr.mr_n67225088)
print v(xbgr.mr_n67225408)
print v(xbgr.mr_n67225520)
print v(xbgr.mr_n67225840)
print v(xbgr.mr_n67225952)
print v(xbgr.mr_n67226272)
print v(xbgr.mr_n67226704)
print v(xbgr.mr_n67226816)
print v(xbgr.mr_n67227136)
print v(xbgr.mr_n67227568)
print v(xbgr.mr_n67227680)
print v(xbgr.mr_n67228000)
print v(xbgr.mr_n67228432)
print v(xbgr.mr_n67228544)
print v(xbgr.mr_n67228864)
print v(xbgr.mr_n67229296)
print v(xbgr.mr_n67229408)
print v(xbgr.mr_n67229728)
print v(xbgr.mr_n67229840)
print v(xbgr.mr_n67230160)
print v(xbgr.mr_n67230272)
print v(xbgr.mr_n67230592)
print v(xbgr.mr_n67230704)
print v(xbgr.mr_n67231024)
print v(xbgr.mr_n67231456)
print v(xbgr.mr_n67231568)
print v(xbgr.mr_n67231888)
print v(xbgr.mr_n67232320)
print v(xbgr.mr_n67232432)
print v(xbgr.mr_n67232752)
print v(xbgr.mr_n67233184)
print v(xbgr.mr_n67233296)
print v(xbgr.mr_n67233616)
print v(xbgr.mr_n67234048)
print v(xbgr.mr_n67234160)
print v(xbgr.mr_n67234480)
print v(xbgr.mr_n67234592)
print v(xbgr.mr_n67234912)
print v(xbgr.mr_n67235024)
print v(xbgr.mr_n67235344)
print v(xbgr.mr_n67235456)
print v(xbgr.mr_n67235776)
print v(xbgr.mr_n67235888)
print v(xbgr.mr_n67236208)
print v(xbgr.mr_n67236320)
print v(xbgr.mr_n67236640)
print v(xbgr.mr_n67236752)
print v(xbgr.mr_n67237072)
print v(xbgr.mr_n67237184)
print v(xbgr.mr_n67237504)
print v(xbgr.mr_n67237616)
print v(xbgr.mr_n67237936)
print v(xbgr.mr_n67238048)
print v(xbgr.mr_n67238368)
print v(xbgr.mr_n67238480)
print v(xbgr.mr_n67238800)
print v(xbgr.mr_n67238912)
print v(xbgr.mr_n67239232)
print v(xbgr.mr_n67239344)
print v(xbgr.mr_n67239664)
print v(xbgr.mr_n67239776)
print v(xbgr.mr_n67240096)
print v(xbgr.mr_n67240208)
print v(xbgr.mr_n67240528)
print v(xbgr.mr_n67240640)
print v(xbgr.mr_n67240960)
print v(xbgr.mr_n67241072)
print v(xbgr.mr_n67241392)
print v(xbgr.mr_n67241504)
print v(xbgr.mr_n67241824)
print v(xbgr.mr_n67241936)
print v(xbgr.mr_n67242256)
print v(xbgr.mr_n67242368)
print v(xbgr.mr_n67242688)
print v(xbgr.mr_n67242800)
print v(xbgr.mr_n67243120)
print v(xbgr.mr_n67243232)
print v(xbgr.mr_n67243552)
print v(xbgr.mr_n67243664)
print v(xbgr.mr_n67243984)
print v(xbgr.mr_n67244096)
print v(xbgr.mr_n67244416)
print v(xbgr.mr_n67244528)
print v(xbgr.mr_n67244848)
print v(xbgr.mr_n67244960)
print v(xbgr.mr_n67245280)
print v(xbgr.mr_n67245392)
print v(xbgr.mr_n67245712)
print v(xbgr.mr_n67245824)
print v(xbgr.mr_n67246256)
print v(xbgr.mr_n67246688)
print v(xbgr.mr_n67247120)
print v(xbgr.mr_n67247552)
print v(xbgr.mr_n67247984)
print v(xbgr.mr_n67248416)
print v(xbgr.mr_n67248848)
print v(xbgr.mr_n67249280)
print v(xbgr.mr_n67249712)
print v(xbgr.mr_n67250144)
print v(xbgr.mr_n67250576)
print v(xbgr.mr_n67251008)
print v(xbgr.mr_n67251440)
print v(xbgr.mr_n67251872)
print v(xbgr.mr_n67252304)
print v(xbgr.mr_n67252736)
print v(xbgr.mr_n67253168)
print v(xbgr.mr_n67253600)
print v(xbgr.mr_n67254032)
print v(xbgr.mr_n67254464)
print v(xbgr.mr_n67254896)
print v(xbgr.mr_n67255328)
print v(xbgr.mr_n67255760)
print v(xbgr.mr_n67256192)
print v(xbgr.mr_n67256624)
print v(xbgr.mr_n67257056)
print v(xbgr.mr_n67257376)
print v(xbgr.mr_n67257488)
print v(xbgr.mr_n67257808)
print v(xbgr.mr_n67257920)
print v(xbgr.mr_n67258240)
print v(xbgr.mr_n67258352)
print v(xbgr.mr_n67258672)
print v(xbgr.mr_n67258784)
print v(xbgr.mr_n67259104)
print v(xbgr.mr_n67259216)
print v(xbgr.mr_n67259536)
print v(xbgr.mr_n67259648)
print v(xbgr.mr_n67259968)
print v(xbgr.mr_n67260080)
print v(xbgr.mr_n67260400)
print v(xbgr.mr_n67260512)
print v(xbgr.mr_n67260832)
print v(xbgr.mr_n67260944)
print v(xbgr.mr_n67261264)
print v(xbgr.mr_n67261376)
print v(xbgr.mr_n67261696)
print v(xbgr.mr_n67261808)
print v(xbgr.mr_n67262128)
print v(xbgr.mr_n67262240)
print v(xbgr.mr_n67262560)
print v(xbgr.mr_n67262672)
print v(xbgr.mr_n67262992)
print v(xbgr.mr_n67263104)
print v(xbgr.mr_n67263424)
print v(xbgr.mr_n67263536)
print v(xbgr.mr_n67263856)
print v(xbgr.mr_n67263968)
print v(xbgr.mr_n67264288)
print v(xbgr.mr_n67264400)
print v(xbgr.mr_n67264720)
print v(xbgr.mr_n67264832)
print v(xbgr.mr_n67265152)
print v(xbgr.mr_n67265264)
print v(xbgr.mr_n67265584)
print v(xbgr.mr_n67265696)
print v(xbgr.mr_n67266128)
print v(xbgr.mr_n67266560)
print v(xbgr.mr_n67266992)
print v(xbgr.mr_n67267424)
print v(xbgr.mr_n67267856)
print v(xbgr.mr_n67268288)
print v(xbgr.mr_n67268720)
print v(xbgr.mr_n67269152)
print v(xbgr.mr_n67269584)
print v(xbgr.mr_n67270016)
print v(xbgr.mr_n67270448)
print v(xbgr.mr_n67270880)
print v(xbgr.mr_n67271200)
print v(xbgr.mr_n67271312)
print v(xbgr.mr_n67271632)
print v(xbgr.mr_n67271744)
print v(xbgr.mr_n67272176)
print v(xbgr.mr_n67272608)
print v(xbgr.mr_n67273040)
print v(xbgr.mr_n67273472)
print v(xbgr.mr_n67273904)
print v(xbgr.mr_n67274336)
print v(xbgr.mr_n67274768)
print v(xbgr.mr_n67275200)
print v(xbgr.mr_n67275632)
print v(xbgr.mr_n67276064)
print v(xbgr.mr_n67276384)
print v(xbgr.mr_n67276496)
print v(xbgr.mr_n67276816)
print v(xbgr.mr_n67276928)
print v(xbgr.mr_n67277248)
print v(xbgr.mr_n67277360)
print v(xbgr.mr_n67277680)
print v(xbgr.mr_n67277792)
print v(xbgr.mr_n67278112)
print v(xbgr.mr_n67278224)
print v(xbgr.mr_n67278544)
print v(xbgr.mr_n67278656)
print v(xbgr.mr_n67278976)
print v(xbgr.mr_n67279088)
print v(xbgr.mr_n67279408)
print v(xbgr.mr_n67279520)
print v(xbgr.mr_n67279840)
print v(xbgr.mr_n67279952)
print v(xbgr.mr_n67280272)
print v(xbgr.mr_n67280384)
print v(xbgr.mr_n67280704)
print v(xbgr.mr_n67280816)
print v(xbgr.mr_n67281136)
print v(xbgr.mr_n67281248)
print v(xbgr.mr_n67281568)
print v(xbgr.mr_n67281680)
print v(xbgr.mr_n67282000)
print v(xbgr.mr_n67282112)
print v(xbgr.mr_n67282432)
print v(xbgr.mr_n67282544)
print v(xbgr.mr_n67282864)
print v(xbgr.mr_n67282976)
print v(xbgr.mr_n67283296)
print v(xbgr.mr_n67283408)
print v(xbgr.mr_n67283728)
print v(xbgr.mr_n67283840)
print v(xbgr.mr_n67284160)
print v(xbgr.mr_n67284272)
print v(xbgr.mr_n67284592)
print v(xbgr.mr_n67284704)
print v(xbgr.mr_n67285024)
print v(xbgr.mr_n67285136)
print v(xbgr.mr_n67285456)
print v(xbgr.mr_n67285568)
print v(xbgr.mr_n67285888)
print v(xbgr.mr_n67286000)
print v(xbgr.mr_n67286320)
print v(xbgr.mr_n67286432)
print v(xbgr.mr_n67286752)
print v(xbgr.mr_n67286864)
print v(xbgr.mr_n67287184)
print v(xbgr.mr_n67287296)
print v(xbgr.mr_n67287616)
print v(xbgr.mr_n67288048)
print v(xbgr.mr_n67288160)
print v(xbgr.mr_n67288480)
print v(xbgr.mr_n67288912)
print v(xbgr.mr_n67289024)
print v(xbgr.mr_n67289344)
print v(xbgr.mr_n67289776)
print v(xbgr.mr_n67289888)
print v(xbgr.mr_n67290208)
print v(xbgr.mr_n67290640)
print v(xbgr.mr_n67290752)
print v(xbgr.mr_n67291072)
print v(xbgr.mr_n67291504)
print v(xbgr.mr_n67291616)
print v(xbgr.mr_n67291936)
print v(xbgr.mr_n67292048)
print v(xbgr.mr_n67292368)
print v(xbgr.mr_n67292480)
print v(xbgr.mr_n67292800)
print v(xbgr.mr_n67292912)
print v(xbgr.mr_n67293232)
print v(xbgr.mr_n67293344)
print v(xbgr.mr_n67293664)
print v(xbgr.mr_n67293776)
print v(xbgr.mr_n67294096)
print v(xbgr.mr_n67294208)
print v(xbgr.mr_n67294528)
print v(xbgr.mr_n67294640)
print v(xbgr.mr_n67294960)
print v(xbgr.mr_n67295072)
print v(xbgr.mr_n67295392)
print v(xbgr.mr_n67295504)
print v(xbgr.mr_n67295824)
print v(xbgr.mr_n67295936)
print v(xbgr.mr_n67296256)
print v(xbgr.mr_n67296368)
print v(xbgr.mr_n67296688)
print v(xbgr.mr_n67296800)
print v(xbgr.mr_n67297120)
print v(xbgr.mr_n67297232)
print v(xbgr.mr_n67297552)
print v(xbgr.mr_n67297664)
print v(xbgr.mr_n67297984)
print v(xbgr.mr_n67298096)
print v(xbgr.mr_n67298416)
print v(xbgr.mr_n67298528)
print v(xbgr.mr_n67298848)
print v(xbgr.mr_n67298960)
print v(xbgr.mr_n67299280)
print v(xbgr.mr_n67299392)
print v(xbgr.mr_n67299712)
print v(xbgr.mr_n67299824)
print v(xbgr.mr_n67300144)
print v(xbgr.mr_n67300256)
print v(xbgr.mr_n67300576)
print v(xbgr.mr_n67300688)
print v(xbgr.mr_n67301008)
print v(xbgr.mr_n67301120)
print v(xbgr.mr_n67301440)
print v(xbgr.mr_n67301552)
print v(xbgr.mr_n67301872)
print v(xbgr.mr_n67301984)
print v(xbgr.mr_n67302304)
print v(xbgr.mr_n67302416)
print v(xbgr.mr_n67302736)
print v(xbgr.mr_n67302848)
print v(xbgr.mr_n67303168)
print v(xbgr.mr_n67303280)
print v(xbgr.mr_n67303600)
print v(xbgr.mr_n67303712)
print v(xbgr.mr_n67304032)
print v(xbgr.mr_n67304144)
print v(xbgr.mr_n67304464)
print v(xbgr.mr_n67304576)
print v(xbgr.mr_n67304896)
print v(xbgr.mr_n67305008)
print v(xbgr.mr_n67305328)
print v(xbgr.mr_n67305440)
print v(xbgr.mr_n67305760)
print v(xbgr.mr_n67305872)
print v(xbgr.mr_n67306192)
print v(xbgr.mr_n67306304)
print v(xbgr.mr_n67306624)
print v(xbgr.mr_n67306736)
print v(xbgr.mr_n67307056)
print v(xbgr.mr_n67307168)
print v(xbgr.mr_n67307488)
print v(xbgr.mr_n67307600)
print v(xbgr.mr_n67307920)
print v(xbgr.mr_n67308032)
print v(xbgr.mr_n67308352)
print v(xbgr.mr_n67308464)
print v(xbgr.mr_n67308784)
print v(xbgr.mr_n67308896)
print v(xbgr.mr_n67309216)
print v(xbgr.mr_n67309328)
print v(xbgr.mr_n67309648)
print v(xbgr.mr_n67309760)
print v(xbgr.mr_n67310080)
print v(xbgr.mr_n67310512)
print v(xbgr.mr_n67310624)
print v(xbgr.mr_n67310944)
print v(xbgr.mr_n67311056)
print v(xbgr.mr_n67311376)
print v(xbgr.mr_n67311488)
print v(xbgr.mr_n67311808)
print v(xbgr.mr_n67312240)
print v(xbgr.mr_n67312352)
print v(xbgr.mr_n67312672)
print v(xbgr.mr_n67313104)
print v(xbgr.mr_n67313216)
print v(xbgr.mr_n67313536)
print v(xbgr.mr_n67313648)
print v(xbgr.mr_n67313968)
print v(xbgr.mr_n67314080)
print v(xbgr.mr_n67314400)
print v(xbgr.mr_n67314512)
print v(xbgr.mr_n67314832)
print v(xbgr.mr_n67314944)
print v(xbgr.mr_n67315264)
print v(xbgr.mr_n67315376)
print v(xbgr.mr_n67315696)
print v(xbgr.mr_n67315808)
print v(xbgr.mr_n67316128)
print v(xbgr.mr_n67316240)
print v(xbgr.mr_n67316560)
print v(xbgr.mr_n67316672)
print v(xbgr.mr_n67316992)
print v(xbgr.mr_n67317104)
print v(xbgr.mr_n67317424)
print v(xbgr.mr_n67317536)
print v(xbgr.mr_n67317856)
print v(xbgr.mr_n67317968)
print v(xbgr.mr_n67318288)
print v(xbgr.mr_n67318400)
print v(xbgr.mr_n67318720)
print v(xbgr.mr_n67319152)
print v(xbgr.mr_n67319264)
print v(xbgr.mr_n67319584)
print v(xbgr.mr_n67319696)
print v(xbgr.mr_n67320016)
print v(xbgr.mr_n67320128)
print v(xbgr.mr_n67320448)
print v(xbgr.mr_n67320560)
print v(xbgr.mr_n67320880)
print v(xbgr.mr_n67320992)
print v(xbgr.mr_n67321312)
print v(xbgr.mr_n67321424)
print v(xbgr.mr_n67321744)
print v(xbgr.mr_n67321856)
print v(xbgr.mr_n67322176)
print v(xbgr.mr_n67322288)
print v(xbgr.mr_n67322608)
print v(xbgr.mr_n67322720)
print v(xbgr.mr_n67323040)
print v(xbgr.mr_n67323152)
print v(xbgr.mr_n67323472)
print v(xbgr.mr_n67323584)
print v(xbgr.mr_n67323904)
print v(xbgr.mr_n67324016)
print v(xbgr.mr_n67324336)
print v(xbgr.mr_n67324448)
print v(xbgr.mr_n67324768)
print v(xbgr.mr_n67324880)
print v(xbgr.mr_n67325200)
print v(xbgr.mr_n67325312)
print v(xbgr.mr_n67325632)
print v(xbgr.mr_n67325744)
print v(xbgr.mr_n67326064)
print v(xbgr.mr_n67326176)
print v(xbgr.mr_n67326496)
print v(xbgr.mr_n67326608)
print v(xbgr.mr_n67326928)
print v(xbgr.mr_n67327040)
print v(xbgr.mr_n67327360)
print v(xbgr.mr_n67327472)
print v(xbgr.mr_n67327792)
print v(xbgr.mr_n67327904)
print v(xbgr.mr_n67328224)
print v(xbgr.mr_n67328336)
print v(xbgr.mr_n67328656)
print v(xbgr.mr_n67328768)
print v(xbgr.mr_n67329088)
print v(xbgr.mr_n67329200)
print v(xbgr.mr_n67329520)
print v(xbgr.mr_n67329632)
print v(xbgr.mr_n67329952)
print v(xbgr.mr_n67330064)
print v(xbgr.mr_n67330384)
print v(xbgr.mr_n67330496)
print v(xbgr.mr_n67330816)
print v(xbgr.mr_n67330928)
print v(xbgr.mr_n67331248)
print v(xbgr.mr_n67331360)
print v(xbgr.mr_n67331680)
print v(xbgr.mr_n67331792)
print v(xbgr.mr_n67332112)
print v(xbgr.mr_n67332224)
print v(xbgr.mr_n67332544)
print v(xbgr.mr_n67332656)
print v(xbgr.mr_n67332976)
print v(xbgr.mr_n67333088)
print v(xbgr.mr_n67333408)
print v(xbgr.mr_n67333520)
print v(xbgr.mr_n67333840)
print v(xbgr.mr_n67333952)
print v(xbgr.mr_n67334272)
print v(xbgr.mr_n67334384)
print v(xbgr.mr_n67334704)
print v(xbgr.mr_n67334816)
print v(xbgr.mr_n67335136)
print v(xbgr.mr_n67335248)
print v(xbgr.mr_n67335568)
print v(xbgr.mr_n67335680)
print v(xbgr.mr_n67336000)
print v(xbgr.mr_n67336112)
print v(xbgr.mr_n67336432)
print v(xbgr.mr_n67336544)
print v(xbgr.mr_n67336864)
print v(xbgr.mr_n67336976)
print v(xbgr.mr_n67337296)
print v(xbgr.mr_n67337408)
print v(xbgr.mr_n67337728)
print v(xbgr.mr_n67337840)
print v(xbgr.mr_n67338160)
print v(xbgr.mr_n67338272)
print v(xbgr.mr_n67338592)
print v(xbgr.mr_n67338704)
print v(xbgr.mr_n67339024)
print v(xbgr.mr_n67339136)
print v(xbgr.mr_n67339456)
print v(xbgr.mr_n67339568)
print v(xbgr.mr_n67339888)
print v(xbgr.mr_n67340000)
print v(xbgr.mr_n67340320)
print v(xbgr.mr_n67340432)
print v(xbgr.mr_n67340864)
print v(xbgr.mr_n67341296)
print v(xbgr.mr_n67341728)
print v(xbgr.mr_n67342160)
print v(xbgr.mr_n67342592)
print v(xbgr.mr_n67343024)
print v(xbgr.mr_n67343456)
print v(xbgr.mr_n67343888)
print v(xbgr.mr_n67344208)
print v(xbgr.mr_n67344320)
print v(xbgr.mr_n67344640)
print v(xbgr.mr_n67344752)
print v(xbgr.mr_n67345072)
print v(xbgr.mr_n67345184)
print v(xbgr.mr_n67345504)
print v(xbgr.mr_n67345616)
print v(xbgr.mr_n67345936)
print v(xbgr.mr_n67346048)
print v(xbgr.mr_n67346368)
print v(xbgr.mr_n67346480)
print v(xbgr.mr_n67346800)
print v(xbgr.mr_n67346912)
print v(xbgr.mr_n67347232)
print v(xbgr.mr_n67347344)
print v(xbgr.mr_n67347776)
print v(xbgr.mr_n67348208)
print v(xbgr.mr_n67348640)
print v(xbgr.mr_n67349072)
print v(xbgr.mr_n67349504)
print v(xbgr.mr_n67349936)
print v(xbgr.mr_n67350256)
print v(xbgr.mr_n67350368)
print v(xbgr.mr_n67350800)
print v(xbgr.mr_n67351232)
print v(xbgr.mr_n67351664)
print v(xbgr.mr_n67352096)
print v(xbgr.mr_n67352528)
print v(xbgr.mr_n67352960)
print v(xbgr.mr_n67353392)
print v(xbgr.mr_n67353824)
print v(xbgr.mr_n67354256)
print v(xbgr.mr_n67354688)
print v(xbgr.mr_n67355120)
print v(xbgr.mr_n67355552)
print v(xbgr.mr_n67355872)
print v(xbgr.mr_n67355984)
print v(xbgr.mr_n67356304)
print v(xbgr.mr_n67356416)
print v(xbgr.mr_n67356736)
print v(xbgr.mr_n67356848)
print v(xbgr.mr_n67357168)
print v(xbgr.mr_n67357280)
print v(xbgr.mr_n67357600)
print v(xbgr.mr_n67357712)
print v(xbgr.mr_n67358032)
print v(xbgr.mr_n67358144)
print v(xbgr.mr_n67358464)
print v(xbgr.mr_n67358576)
print v(xbgr.mr_n67358896)
print v(xbgr.mr_n67359008)
print v(xbgr.mr_n67359328)
print v(xbgr.mr_n67359440)
print v(xbgr.mr_n67359760)
print v(xbgr.mr_n67359872)
print v(xbgr.mr_n67360192)
print v(xbgr.mr_n67360304)
print v(xbgr.mr_n67360624)
print v(xbgr.mr_n67360736)
print v(xbgr.mr_n67361056)
print v(xbgr.mr_n67361168)
print v(xbgr.mr_n67361488)
print v(xbgr.mr_n67361600)
print v(xbgr.mr_n67361920)
print v(xbgr.mr_n67362032)
print v(xbgr.mr_n67362352)
print v(xbgr.mr_n67362464)
print v(xbgr.mr_n67362784)
print v(xbgr.mr_n67362896)
print v(xbgr.mr_n67363216)
print v(xbgr.mr_n67363328)
print v(xbgr.mr_n67363648)
print v(xbgr.mr_n67363760)
print v(xbgr.mr_n67364080)
print v(xbgr.mr_n67364192)
print v(xbgr.mr_n67364512)
print v(xbgr.mr_n67364624)
print v(xbgr.mr_n67365056)
print v(xbgr.mr_n67365488)
print v(xbgr.mr_n67365920)
print v(xbgr.mr_n67366352)
print v(xbgr.mr_n67366784)
print v(xbgr.mr_n67367216)
print v(xbgr.mr_n67367648)
print v(xbgr.mr_n67368080)
print v(xbgr.mr_n67368512)
print v(xbgr.mr_n67368944)
print v(xbgr.mr_n67369376)
print v(xbgr.mr_n67369808)
print v(xbgr.mr_n67370240)
print v(xbgr.mr_n67370672)
print v(xbgr.mr_n67371104)
print v(xbgr.mr_n67371536)
print v(xbgr.mr_n67371968)
print v(xbgr.mr_n67372400)
print v(xbgr.mr_n67372832)
print v(xbgr.mr_n67373152)
print v(xbgr.mr_n67373264)
print v(xbgr.mr_n67373584)
print v(xbgr.mr_n67373696)
print v(xbgr.mr_n67374016)
print v(xbgr.mr_n67374128)
print v(xbgr.mr_n67374448)
print v(xbgr.mr_n67374560)
print v(xbgr.mr_n67374880)
print v(xbgr.mr_n67374992)
print v(xbgr.mr_n67375424)
print v(xbgr.mr_n67375856)
print v(xbgr.mr_n67376288)
print v(xbgr.mr_n67376720)
print v(xbgr.mr_n67377152)
print v(xbgr.mr_n67377584)
print v(xbgr.mr_n67378016)
print v(xbgr.mr_n67378336)
print v(xbgr.mr_n67378448)
print v(xbgr.mr_n67378768)
print v(xbgr.mr_n67378880)
print v(xbgr.mr_n67379200)
print v(xbgr.mr_n67379312)
print v(xbgr.mr_n67379632)
print v(xbgr.mr_n67379744)
print v(xbgr.mr_n67380064)
print v(xbgr.mr_n67380176)
print v(xbgr.mr_n67380496)
print v(xbgr.mr_n67380608)
print v(xbgr.mr_n67380928)
print v(xbgr.mr_n67381040)
print v(xbgr.mr_n67381360)
print v(xbgr.mr_n67381472)
print v(xbgr.mr_n67381792)
print v(xbgr.mr_n67381904)
print v(xbgr.mr_n67382224)
print v(xbgr.mr_n67382336)
print v(xbgr.mr_n67382656)
print v(xbgr.mr_n67382768)
print v(xbgr.mr_n67383088)
print v(xbgr.mr_n67383200)
print v(xbgr.mr_n67383520)
print v(xbgr.mr_n67383632)
print v(xbgr.mr_n67384064)
print v(xbgr.mr_n67384496)
print v(xbgr.mr_n67384928)
print v(xbgr.mr_n67385360)
print v(xbgr.mr_n67385792)
print v(xbgr.mr_n67386224)
print v(xbgr.mr_n67386656)
print v(xbgr.mr_n67387088)
print v(xbgr.mr_n67387520)
print v(xbgr.mr_n67387952)
print v(xbgr.mr_n67388384)
print v(xbgr.mr_n67388816)
print v(xbgr.mr_n67389248)
print v(xbgr.mr_n67389568)
print v(xbgr.mr_n67389680)
print v(xbgr.mr_n67390000)
print v(xbgr.mr_n67390112)
print v(xbgr.mr_n67390432)
print v(xbgr.mr_n67390544)
print v(xbgr.mr_n67390864)
print v(xbgr.mr_n67390976)
print v(xbgr.mr_n67391296)
print v(xbgr.mr_n67391408)
print v(xbgr.mr_n67391728)
print v(xbgr.mr_n67391840)
print v(xbgr.mr_n67392160)
print v(xbgr.mr_n67392272)
print v(xbgr.mr_n67392592)
print v(xbgr.mr_n67392704)
print v(xbgr.mr_n67393024)
print v(xbgr.mr_n67393136)
print v(xbgr.mr_n67393456)
print v(xbgr.mr_n67393568)
print v(xbgr.mr_n67393888)
print v(xbgr.mr_n67394000)
print v(xbgr.mr_n67394320)
print v(xbgr.mr_n67394432)
print v(xbgr.mr_n67394864)
print v(xbgr.mr_n67395296)
print v(xbgr.mr_n67395728)
print v(xbgr.mr_n67396160)
print v(xbgr.mr_n67396592)
print v(xbgr.mr_n67397024)
print v(xbgr.mr_n67397456)
print v(xbgr.mr_n67397888)
print v(xbgr.mr_n67398320)
print v(xbgr.mr_n67398752)
print v(xbgr.mr_n67399184)
print v(xbgr.mr_n67399616)
print v(xbgr.mr_n67399936)
print v(xbgr.mr_n67400048)
print v(xbgr.mr_n67400480)
print v(xbgr.mr_n67400800)
print v(xbgr.mr_n67400912)
print v(xbgr.mr_n67401232)
print v(xbgr.mr_n67401344)
print v(xbgr.mr_n67401664)
print v(xbgr.mr_n67401776)
print v(xbgr.mr_n67402096)
print v(xbgr.mr_n67402208)
print v(xbgr.mr_n67402528)
print v(xbgr.mr_n67402640)
print v(xbgr.mr_n67403072)
print v(xbgr.mr_n67403504)
print v(xbgr.mr_n67403824)
print v(xbgr.mr_n67403936)
print v(xbgr.mr_n67404256)
print v(xbgr.mr_n67404368)
print v(xbgr.mr_n67404688)
print v(xbgr.mr_n67404800)
print v(xbgr.mr_n67405120)
print v(xbgr.mr_n67405232)
print v(xbgr.mr_n67405552)
print v(xbgr.mr_n67405664)
print v(xbgr.mr_n67405984)
print v(xbgr.mr_n67406096)
print v(xbgr.mr_n67406416)
print v(xbgr.mr_n67406528)
print v(xbgr.mr_n67406848)
print v(xbgr.mr_n67406960)
print v(xbgr.mr_n67407392)
print v(xbgr.mr_n67407824)
print v(xbgr.mr_n67408256)
print v(xbgr.mr_n67408688)
print v(xbgr.mr_n67409120)
print v(xbgr.mr_n67409552)
print v(xbgr.mr_n67409984)
print v(xbgr.mr_n67410416)
print v(xbgr.mr_n67410848)
print v(xbgr.mr_n67411280)
print v(xbgr.mr_n67411712)
print v(xbgr.mr_n67412032)
print v(xbgr.mr_n67412144)
print v(xbgr.mr_n67412464)
print v(xbgr.mr_n67412576)
print v(xbgr.mr_n67412896)
print v(xbgr.mr_n67413008)
print v(xbgr.mr_n67413440)
print v(xbgr.mr_n67413872)
print v(xbgr.mr_n67414192)
print v(xbgr.mr_n67414304)
print v(xbgr.mr_n67414624)
print v(xbgr.mr_n67414736)
print v(xbgr.mr_n67415056)
print v(xbgr.mr_n67415168)
print v(xbgr.mr_n67415488)
print v(xbgr.mr_n67415600)
print v(xbgr.mr_n67416032)
print v(xbgr.mr_n67416352)
print v(xbgr.mr_n67416464)
print v(xbgr.mr_n67416784)
print v(xbgr.mr_n67416896)
print v(xbgr.mr_n67417216)
print v(xbgr.mr_n67417328)
print v(xbgr.mr_n67417648)
print v(xbgr.mr_n67417760)
print v(xbgr.mr_n67418080)
print v(xbgr.mr_n67418192)
print v(xbgr.mr_n67418512)
print v(xbgr.mr_n67418624)
print v(xbgr.mr_n67419056)
print v(xbgr.mr_n67419488)
print v(xbgr.mr_n67419920)
print v(xbgr.mr_n67420352)
print v(xbgr.mr_n67420784)
print v(xbgr.mr_n67421216)
print v(xbgr.mr_n67421648)
print v(xbgr.mr_n67422080)
print v(xbgr.mr_n67422512)
print v(xbgr.mr_n67422944)
print v(xbgr.mr_n67423264)
print v(xbgr.mr_n67423376)
print v(xbgr.mr_n67423696)
print v(xbgr.mr_n67423808)
print v(xbgr.mr_n67424128)
print v(xbgr.mr_n67424240)
print v(xbgr.mr_n67424560)
print v(xbgr.mr_n67424672)
print v(xbgr.mr_n67424992)
print v(xbgr.mr_n67425104)
print v(xbgr.mr_n67425424)
print v(xbgr.mr_n67425536)
print v(xbgr.mr_n67425856)
print v(xbgr.mr_n67425968)
print v(xbgr.mr_n67426288)
print v(xbgr.mr_n67426400)
print v(xbgr.mr_n67426720)
print v(xbgr.mr_n67426832)
print v(xbgr.mr_n67427152)
print v(xbgr.mr_n67427264)
print v(xbgr.mr_n67427584)
print v(xbgr.mr_n67427696)
print v(xbgr.mr_n67428016)
print v(xbgr.mr_n67428128)
print v(xbgr.mr_n67428448)
print v(xbgr.mr_n67428560)
print v(xbgr.mr_n67428992)
print v(xbgr.mr_n67429424)
print v(xbgr.mr_n67429856)
print v(xbgr.mr_n67430288)
print v(xbgr.mr_n67430720)
print v(xbgr.mr_n67431152)
print v(xbgr.mr_n67431584)
print v(xbgr.mr_n67432016)
print v(xbgr.mr_n67432448)
print v(xbgr.mr_n67432880)
print v(xbgr.mr_n67433312)
print v(xbgr.mr_n67433744)
print v(xbgr.mr_n67434176)
print v(xbgr.mr_n67434496)
print v(xbgr.mr_n67434608)
print v(xbgr.mr_n67434928)
print v(xbgr.mr_n67435040)
print v(xbgr.mr_n67435360)
print v(xbgr.mr_n67435472)
print v(xbgr.mr_n67435792)
print v(xbgr.mr_n67435904)
print v(xbgr.mr_n67436224)
print v(xbgr.mr_n67436336)
print v(xbgr.mr_n67436656)
print v(xbgr.mr_n67436768)
print v(xbgr.mr_n67437088)
print v(xbgr.mr_n67437200)
print v(xbgr.mr_n67437520)
print v(xbgr.mr_n67437632)
print v(xbgr.mr_n67437952)
print v(xbgr.mr_n67438064)
print v(xbgr.mr_n67438384)
print v(xbgr.mr_n67438496)
print v(xbgr.mr_n67438816)
print v(xbgr.mr_n67438928)
print v(xbgr.mr_n67439248)
print v(xbgr.mr_n67439360)
print v(xbgr.mr_n67439680)
print v(xbgr.mr_n67439792)
print v(xbgr.mr_n67440224)
print v(xbgr.mr_n67440656)
print v(xbgr.mr_n67441088)
print v(xbgr.mr_n67441520)
print v(xbgr.mr_n67441952)
print v(xbgr.mr_n67442384)
print v(xbgr.mr_n67442816)
print v(xbgr.mr_n67443248)
print v(xbgr.mr_n67443680)
print v(xbgr.mr_n67444112)
print v(xbgr.mr_n67444544)
print v(xbgr.mr_n67444976)
print v(xbgr.mr_n67445408)
print v(xbgr.mr_n67445728)
print v(xbgr.mr_n67445840)
print v(xbgr.mr_n67446160)
print v(xbgr.mr_n67446272)
print v(xbgr.mr_n67446592)
print v(xbgr.mr_n67446704)
print v(xbgr.mr_n67447024)
print v(xbgr.mr_n67447136)
print v(xbgr.mr_n67447456)
print v(xbgr.mr_n67447568)
print v(xbgr.mr_n67447888)
print v(xbgr.mr_n67448000)
print v(xbgr.mr_n67448320)
print v(xbgr.mr_n67448432)
print v(xbgr.mr_n67448752)
print v(xbgr.mr_n67448864)
print v(xbgr.mr_n67449184)
print v(xbgr.mr_n67449296)
print v(xbgr.mr_n67449616)
print v(xbgr.mr_n67449728)
print v(xbgr.mr_n67450048)
print v(xbgr.mr_n67450160)
print v(xbgr.mr_n67450480)
print v(xbgr.mr_n67450592)
print v(xbgr.mr_n67450912)
print v(xbgr.mr_n67451024)
print v(xbgr.mr_n67451456)
print v(xbgr.mr_n67451888)
print v(xbgr.mr_n67452320)
print v(xbgr.mr_n67452752)
print v(xbgr.mr_n67453184)
print v(xbgr.mr_n67453616)
print v(xbgr.mr_n67454048)
print v(xbgr.mr_n67454480)
print v(xbgr.mr_n67454912)
print v(xbgr.mr_n67455344)
print v(xbgr.mr_n67455776)
print v(xbgr.mr_n67456208)
print v(xbgr.mr_n67456640)
print v(xbgr.mr_n67456960)
print v(xbgr.mr_n67457072)
print v(xbgr.mr_n67457392)
print v(xbgr.mr_n67457504)
print v(xbgr.mr_n67457936)
print v(xbgr.mr_n67458256)
print v(xbgr.mr_n67458368)
print v(xbgr.mr_n67458688)
print v(xbgr.mr_n67458800)
print v(xbgr.mr_n67459120)
print v(xbgr.mr_n67459232)
print v(xbgr.mr_n67459552)
print v(xbgr.mr_n67459664)
print v(xbgr.mr_n67460096)
print v(xbgr.mr_n67460528)
print v(xbgr.mr_n67460960)
print v(xbgr.mr_n67461392)
print v(xbgr.mr_n67461712)
print v(xbgr.mr_n67461824)
print v(xbgr.mr_n67462144)
print v(xbgr.mr_n67462256)
print v(xbgr.mr_n67462688)
print v(xbgr.mr_n67463120)
print v(xbgr.mr_n67463440)
print v(xbgr.mr_n67463552)
print v(xbgr.mr_n67463872)
print v(xbgr.mr_n67463984)
print v(xbgr.mr_n67464304)
print v(xbgr.mr_n67464416)
print v(xbgr.mr_n67464736)
print v(xbgr.mr_n67464848)
print v(xbgr.mr_n67465168)
print v(xbgr.mr_n67465280)
print v(xbgr.mr_n67465712)
print v(xbgr.mr_n67466144)
print v(xbgr.mr_n67466576)
print v(xbgr.mr_n67467008)
print v(xbgr.mr_n67467440)
print v(xbgr.mr_n67467872)
print v(xbgr.mr_n67468192)
print v(xbgr.mr_n67468304)
print v(xbgr.mr_n67468624)
print v(xbgr.mr_n67468736)
print v(xbgr.mr_n67469056)
print v(xbgr.mr_n67469168)
print v(xbgr.mr_n67469488)
print v(xbgr.mr_n67469600)
print v(xbgr.mr_n67469920)
print v(xbgr.mr_n67470032)
print v(xbgr.mr_n67470352)
print v(xbgr.mr_n67470464)
print v(xbgr.mr_n67470784)
print v(xbgr.mr_n67470896)
print v(xbgr.mr_n67471216)
print v(xbgr.mr_n67471328)
print v(xbgr.mr_n67471648)
print v(xbgr.mr_n67471760)
print v(xbgr.mr_n67472080)
print v(xbgr.mr_n67472192)
print v(xbgr.mr_n67472512)
print v(xbgr.mr_n67472624)
print v(xbgr.mr_n67472944)
print v(xbgr.mr_n67473056)
print v(xbgr.mr_n67473488)
print v(xbgr.mr_n67473920)
print v(xbgr.mr_n67474352)
print v(xbgr.mr_n67474784)
print v(xbgr.mr_n67475216)
print v(xbgr.mr_n67475648)
print v(xbgr.mr_n67476080)
print v(xbgr.mr_n67476512)
print v(xbgr.mr_n67476832)
print v(xbgr.mr_n67476944)
print v(xbgr.mr_n67477264)
print v(xbgr.mr_n67477376)
print v(xbgr.mr_n67477696)
print v(xbgr.mr_n67477808)
print v(xbgr.mr_n67478128)
print v(xbgr.mr_n67478240)
print v(xbgr.mr_n67478560)
print v(xbgr.mr_n67478672)
print v(xbgr.mr_n67478992)
print v(xbgr.mr_n67479104)
print v(xbgr.mr_n67479424)
print v(xbgr.mr_n67479536)
print v(xbgr.mr_n67479856)
print v(xbgr.mr_n67479968)
print v(xbgr.mr_n67480400)
print v(xbgr.mr_n67480832)
print v(xbgr.mr_n67481152)
print v(xbgr.mr_n67481264)
print v(xbgr.mr_n67481584)
print v(xbgr.mr_n67481696)
print v(xbgr.mr_n67482016)
print v(xbgr.mr_n67482128)
print v(xbgr.mr_n67482448)
print v(xbgr.mr_n67482560)
print v(xbgr.mr_n67482880)
print v(xbgr.mr_n67482992)
print v(xbgr.mr_n67483312)
print v(xbgr.mr_n67483424)
print v(xbgr.mr_n67483856)
print v(xbgr.mr_n67484288)
print v(xbgr.mr_n67484720)
print v(xbgr.mr_n67485152)
print v(xbgr.mr_n67485584)
print v(xbgr.mr_n67486016)
print v(xbgr.mr_n67486448)
print v(xbgr.mr_n67486880)
print v(xbgr.mr_n67487312)
print v(xbgr.mr_n67487744)
print v(xbgr.mr_n67488176)
print v(xbgr.mr_n67488608)
print v(xbgr.mr_n67489040)
print v(xbgr.mr_n67489472)
print v(xbgr.mr_n67489904)
print v(xbgr.mr_n67490336)
print v(xbgr.mr_n67490656)
print v(xbgr.mr_n67490768)
print v(xbgr.mr_n67491088)
print v(xbgr.mr_n67491200)
print v(xbgr.mr_n67491520)
print v(xbgr.mr_n67491632)
print v(xbgr.mr_n67491952)
print v(xbgr.mr_n67492064)
print v(xbgr.mr_n67492384)
print v(xbgr.mr_n67492496)
print v(xbgr.mr_n67492816)
print v(xbgr.mr_n67492928)
print v(xbgr.mr_n67493248)
print v(xbgr.mr_n67493360)
print v(xbgr.mr_n67493680)
print v(xbgr.mr_n67493792)
print v(xbgr.mr_n67494112)
print v(xbgr.mr_n67494224)
print v(xbgr.mr_n67494544)
print v(xbgr.mr_n67494656)
print v(xbgr.mr_n67494976)
print v(xbgr.mr_n67495088)
print v(xbgr.mr_n67495408)
print v(xbgr.mr_n67495520)
print v(xbgr.mr_n67495840)
print v(xbgr.mr_n67495952)
print v(xbgr.mr_n67496272)
print v(xbgr.mr_n67496384)
print v(xbgr.mr_n67496704)
print v(xbgr.mr_n67496816)
print v(xbgr.mr_n67497136)
print v(xbgr.mr_n67497248)
print v(xbgr.mr_n67497568)
print v(xbgr.mr_n67497680)
print v(xbgr.mr_n67498000)
print v(xbgr.mr_n67498112)
print v(xbgr.mr_n67498432)
print v(xbgr.mr_n67498544)
print v(xbgr.mr_n67498864)
print v(xbgr.mr_n67498976)
print v(xbgr.mr_n67499408)
print v(xbgr.mr_n67499840)
print v(xbgr.mr_n67500272)
print v(xbgr.mr_n67500704)
print v(xbgr.mr_n67501136)
print v(xbgr.mr_n67501568)
print v(xbgr.mr_n67501888)
print v(xbgr.mr_n67502000)
print v(xbgr.mr_n67502320)
print v(xbgr.mr_n67502432)
print v(xbgr.mr_n67502752)
print v(xbgr.mr_n67502864)
print v(xbgr.mr_n67503184)
print v(xbgr.mr_n67503296)
print v(xbgr.mr_n67503616)
print v(xbgr.mr_n67503728)
print v(xbgr.mr_n67504048)
print v(xbgr.mr_n67504160)
print v(xbgr.mr_n67504592)
print v(xbgr.mr_n67505024)
print v(xbgr.mr_n67505456)
print v(xbgr.mr_n67505888)
print v(xbgr.mr_n67506320)
print v(xbgr.mr_n67506752)
print v(xbgr.mr_n67507184)
print v(xbgr.mr_n67507616)
print v(xbgr.mr_n67508048)
print v(xbgr.mr_n67508480)
print v(xbgr.mr_n67508912)
print v(xbgr.mr_n67509344)
print v(xbgr.mr_n67509776)
print v(xbgr.mr_n67510208)
print v(xbgr.mr_n67510640)
print v(xbgr.mr_n67511072)
print v(xbgr.mr_n67511504)
print v(xbgr.mr_n67511936)
print v(xbgr.mr_n67512368)
print v(xbgr.mr_n67512800)
print v(xbgr.mr_n67513120)
print v(xbgr.mr_n67513232)
print v(xbgr.mr_n67513552)
print v(xbgr.mr_n67513664)
print v(xbgr.mr_n67513984)
print v(xbgr.mr_n67514096)
print v(xbgr.mr_n67514416)
print v(xbgr.mr_n67514528)
print v(xbgr.mr_n67514848)
print v(xbgr.mr_n67514960)
print v(xbgr.mr_n67515280)
print v(xbgr.mr_n67515392)
print v(xbgr.mr_n67515712)
print v(xbgr.mr_n67515824)
print v(xbgr.mr_n67516144)
print v(xbgr.mr_n67516256)
print v(xbgr.mr_n67516576)
print v(xbgr.mr_n67516688)
print v(xbgr.mr_n67517008)
print v(xbgr.mr_n67517120)
print v(xbgr.mr_n67517440)
print v(xbgr.mr_n67517552)
print v(xbgr.mr_n67517872)
print v(xbgr.mr_n67517984)
print v(xbgr.mr_n67518304)
print v(xbgr.mr_n67518416)
print v(xbgr.mr_n67518736)
print v(xbgr.mr_n67518848)
print v(xbgr.mr_n67519168)
print v(xbgr.mr_n67519280)
print v(xbgr.mr_n67519600)
print v(xbgr.mr_n67519712)
print v(xbgr.mr_n67520032)
print v(xbgr.mr_n67520144)
print v(xbgr.mr_n67520464)
print v(xbgr.mr_n67520576)
print v(xbgr.mr_n67520896)
print v(xbgr.mr_n67521008)
print v(xbgr.mr_n67521328)
print v(xbgr.mr_n67521440)
print v(xbgr.mr_n67521760)
print v(xbgr.mr_n67521872)
print v(xbgr.mr_n67522192)
print v(xbgr.mr_n67522304)
print v(xbgr.mr_n67522624)
print v(xbgr.mr_n67522736)
print v(xbgr.mr_n67523056)
print v(xbgr.mr_n67523168)
print v(xbgr.mr_n67523488)
print v(xbgr.mr_n67523600)
print v(xbgr.mr_n67523920)
print v(xbgr.mr_n67524032)
print v(xbgr.mr_n67524352)
print v(xbgr.mr_n67524464)
print v(xbgr.mr_n67524784)
print v(xbgr.mr_n67524896)
print v(xbgr.mr_n67525216)
print v(xbgr.mr_n67525328)
print v(xbgr.mr_n67525648)
print v(xbgr.mr_n67525760)
print v(xbgr.mr_n67526080)
print v(xbgr.mr_n67526192)
print v(xbgr.mr_n67526512)
print v(xbgr.mr_n67526624)
print v(xbgr.mr_n67527056)
print v(xbgr.mr_n67527488)
print v(xbgr.mr_n67527808)
print v(xbgr.mr_n67527920)
print v(xbgr.mr_n67528240)
print v(xbgr.mr_n67528352)
print v(xbgr.mr_n67528672)
print v(xbgr.mr_n67528784)
print v(xbgr.mr_n67529104)
print v(xbgr.mr_n67529216)
print v(xbgr.mr_n67529536)
print v(xbgr.mr_n67529648)
print v(xbgr.mr_n67529968)
print v(xbgr.mr_n67530080)
print v(xbgr.mr_n67530400)
print v(xbgr.mr_n67530512)
print v(xbgr.mr_n67530832)
print v(xbgr.mr_n67530944)
print v(xbgr.mr_n67531264)
print v(xbgr.mr_n67531376)
print v(xbgr.mr_n67531696)
print v(xbgr.mr_n67531808)
print v(xbgr.mr_n67532240)
print v(xbgr.mr_n67532672)
print v(xbgr.mr_n67533104)
print v(xbgr.mr_n67533424)
print v(xbgr.mr_n67533536)
print v(xbgr.mr_n67533856)
print v(xbgr.mr_n67533968)
print v(xbgr.mr_n67534400)
print v(xbgr.mr_n67534832)
print v(xbgr.mr_n67535264)
print v(xbgr.mr_n67535696)
print v(xbgr.mr_n67536128)
print v(xbgr.mr_n67536560)
print v(xbgr.mr_n67536992)
print v(xbgr.mr_n67537424)
print v(xbgr.mr_n67537856)
print v(xbgr.mr_n67538288)
print v(xbgr.mr_n67538720)
print v(xbgr.mr_n67539040)
print v(xbgr.mr_n67539152)
print v(xbgr.mr_n67539472)
print v(xbgr.mr_n67539584)
print v(xbgr.mr_n67539904)
print v(xbgr.mr_n67540016)
print v(xbgr.mr_n67540336)
print v(xbgr.mr_n67540448)
print v(xbgr.mr_n67540768)
print v(xbgr.mr_n67540880)
print v(xbgr.mr_n67541200)
print v(xbgr.mr_n67541312)
print v(xbgr.mr_n67541632)
print v(xbgr.mr_n67541744)
print v(xbgr.mr_n67542064)
print v(xbgr.mr_n67542176)
print v(xbgr.mr_n67542608)
print v(xbgr.mr_n67543040)
print v(xbgr.mr_n67543472)
print v(xbgr.mr_n67543904)
print v(xbgr.mr_n67544336)
print v(xbgr.mr_n67544768)
print v(xbgr.mr_n67545200)
print v(xbgr.mr_n67545632)
print v(xbgr.mr_n67546064)
print v(xbgr.mr_n67546496)
print v(xbgr.mr_n67546928)
print v(xbgr.mr_n67547360)
print v(xbgr.mr_n67547792)
print v(xbgr.mr_n67548224)
print v(xbgr.mr_n67548656)
print v(xbgr.mr_n67549088)
print v(xbgr.mr_n67549520)
print v(xbgr.mr_n67549952)
print v(xbgr.mr_n67550384)
print v(xbgr.mr_n67550816)
print v(xbgr.mr_n67551136)
print v(xbgr.mr_n67551248)
print v(xbgr.mr_n67551568)
print v(xbgr.mr_n67551680)
print v(xbgr.mr_n67552000)
print v(xbgr.mr_n67552112)
print v(xbgr.mr_n67552432)
print v(xbgr.mr_n67552544)
print v(xbgr.mr_n67552864)
print v(xbgr.mr_n67552976)
print v(xbgr.mr_n67553296)
print v(xbgr.mr_n67553408)
print v(xbgr.mr_n67553728)
print v(xbgr.mr_n67553840)
print v(xbgr.mr_n67554160)
print v(xbgr.mr_n67554272)
print v(xbgr.mr_n67554592)
print v(xbgr.mr_n67554704)
print v(xbgr.mr_n67555024)
print v(xbgr.mr_n67555136)
print v(xbgr.mr_n67555456)
print v(xbgr.mr_n67555568)
print v(xbgr.mr_n67555888)
print v(xbgr.mr_n67556000)
print v(xbgr.mr_n67556320)
print v(xbgr.mr_n67556432)
print v(xbgr.mr_n67556864)
print v(xbgr.mr_n67557296)
print v(xbgr.mr_n67557728)
print v(xbgr.mr_n67558160)
print v(xbgr.mr_n67558592)
print v(xbgr.mr_n67559024)
print v(xbgr.mr_n67559456)
print v(xbgr.mr_n67559888)
print v(xbgr.mr_n67560320)
print v(xbgr.mr_n67560752)
print v(xbgr.mr_n67561184)
print v(xbgr.mr_n67561616)
print v(xbgr.mr_n67562048)
print v(xbgr.mr_n67562368)
print v(xbgr.mr_n67562480)
print v(xbgr.mr_n67562800)
print v(xbgr.mr_n67562912)
print v(xbgr.mr_n67563232)
print v(xbgr.mr_n67563344)
print v(xbgr.mr_n67563664)
print v(xbgr.mr_n67563776)
print v(xbgr.mr_n67564096)
print v(xbgr.mr_n67564208)
print v(xbgr.mr_n67564528)
print v(xbgr.mr_n67564640)
print v(xbgr.mr_n67564960)
print v(xbgr.mr_n67565072)
print v(xbgr.mr_n67565392)
print v(xbgr.mr_n67565504)
print v(xbgr.mr_n67565824)
print v(xbgr.mr_n67565936)
print v(xbgr.mr_n67566256)
print v(xbgr.mr_n67566368)
print v(xbgr.mr_n67566688)
print v(xbgr.mr_n67566800)
print v(xbgr.mr_n67567120)
print v(xbgr.mr_n67567232)
print v(xbgr.mr_n67567664)
print v(xbgr.mr_n67567984)
print v(xbgr.mr_n67568096)
print v(xbgr.mr_n67568528)
print v(xbgr.mr_n67568960)
print v(xbgr.mr_n67569392)
print v(xbgr.mr_n67569824)
print v(xbgr.mr_n67570256)
print v(xbgr.mr_n67570688)
print v(xbgr.mr_n67571120)
print v(xbgr.mr_n67571552)
print v(xbgr.mr_n67571984)
print v(xbgr.mr_n67572416)
print v(xbgr.mr_n67572848)
print v(xbgr.mr_n67573280)
print v(xbgr.mr_n67573600)
print v(xbgr.mr_n67573712)
print v(xbgr.mr_n67574032)
print v(xbgr.mr_n67574144)
print v(xbgr.mr_n67574464)
print v(xbgr.mr_n67574576)
print v(xbgr.mr_n67574896)
print v(xbgr.mr_n67575008)
print v(xbgr.mr_n67575328)
print v(xbgr.mr_n67575440)
print v(xbgr.mr_n67575760)
print v(xbgr.mr_n67575872)
print v(xbgr.mr_n67576192)
print v(xbgr.mr_n67576304)
print v(xbgr.mr_n67576624)
print v(xbgr.mr_n67576736)
print v(xbgr.mr_n67577056)
print v(xbgr.mr_n67577168)
print v(xbgr.mr_n67577488)
print v(xbgr.mr_n67577600)
print v(xbgr.mr_n67577920)
print v(xbgr.mr_n67578032)
print v(xbgr.mr_n67578464)
print v(xbgr.mr_n67578896)
print v(xbgr.mr_n67579328)
print v(xbgr.mr_n67579648)
print v(xbgr.mr_n67579760)
print v(xbgr.mr_n67580080)
print v(xbgr.mr_n67580192)
print v(xbgr.mr_n67580624)
print v(xbgr.mr_n67581056)
print v(xbgr.mr_n67581488)
print v(xbgr.mr_n67581920)
print v(xbgr.mr_n67582352)
print v(xbgr.mr_n67582784)
print v(xbgr.mr_n67583216)
print v(xbgr.mr_n67583648)
print v(xbgr.mr_n67584080)
print v(xbgr.mr_n67584512)
print v(xbgr.mr_n67584832)
print v(xbgr.mr_n67584944)
print v(xbgr.mr_n67585264)
print v(xbgr.mr_n67585376)
print v(xbgr.mr_n67585696)
print v(xbgr.mr_n67585808)
print v(xbgr.mr_n67586128)
print v(xbgr.mr_n67586240)
print v(xbgr.mr_n67586560)
print v(xbgr.mr_n67586672)
print v(xbgr.mr_n67586992)
print v(xbgr.mr_n67587104)
print v(xbgr.mr_n67587424)
print v(xbgr.mr_n67587536)
print v(xbgr.mr_n67587856)
print v(xbgr.mr_n67587968)
print v(xbgr.mr_n67588288)
print v(xbgr.mr_n67588400)
print v(xbgr.mr_n67588720)
print v(xbgr.mr_n67588832)
print v(xbgr.mr_n67589152)
print v(xbgr.mr_n67589264)
print v(xbgr.mr_n67589584)
print v(xbgr.mr_n67589696)
print v(xbgr.mr_n67590128)
print v(xbgr.mr_n67590560)
print v(xbgr.mr_n67590992)
print v(xbgr.mr_n67591424)
print v(xbgr.mr_n67591856)
print v(xbgr.mr_n67592288)
print v(xbgr.mr_n67592720)
print v(xbgr.mr_n67593040)
print v(xbgr.mr_n67593152)
print v(xbgr.mr_n67593584)
print v(xbgr.mr_n67594016)
print v(xbgr.mr_n67594448)
print v(xbgr.mr_n67594880)
print v(xbgr.mr_n67595312)
print v(xbgr.mr_n67595744)
print v(xbgr.mr_n67596064)
print v(xbgr.mr_n67596176)
print v(xbgr.mr_n67596496)
print v(xbgr.mr_n67596608)
print v(xbgr.mr_n67596928)
print v(xbgr.mr_n67597040)
print v(xbgr.mr_n67597360)
print v(xbgr.mr_n67597472)
print v(xbgr.mr_n67597792)
print v(xbgr.mr_n67597904)
print v(xbgr.mr_n67598224)
print v(xbgr.mr_n67598336)
print v(xbgr.mr_n67598656)
print v(xbgr.mr_n67598768)
print v(xbgr.mr_n67599088)
print v(xbgr.mr_n67599200)
print v(xbgr.mr_n67599520)
print v(xbgr.mr_n67599632)
print v(xbgr.mr_n67599952)
print v(xbgr.mr_n67600064)
print v(xbgr.mr_n67600384)
print v(xbgr.mr_n67600496)
print v(xbgr.mr_n67600816)
print v(xbgr.mr_n67600928)
print v(xbgr.mr_n67601248)
print v(xbgr.mr_n67601360)
print v(xbgr.mr_n67601680)
print v(xbgr.mr_n67601792)
print v(xbgr.mr_n67602112)
print v(xbgr.mr_n67602224)
print v(xbgr.mr_n67602544)
print v(xbgr.mr_n67602656)
print v(xbgr.mr_n67602976)
print v(xbgr.mr_n67603088)
print v(xbgr.mr_n67603408)
print v(xbgr.mr_n67603520)
print v(xbgr.mr_n67603840)
print v(xbgr.mr_n67603952)
print v(xbgr.mr_n67604272)
print v(xbgr.mr_n67604384)
print v(xbgr.mr_n67604704)
print v(xbgr.mr_n67604816)
print v(xbgr.mr_n67605136)
print v(xbgr.mr_n67605248)
print v(xbgr.mr_n67605568)
print v(xbgr.mr_n67605680)
print v(xbgr.mr_n67606000)
print v(xbgr.mr_n67606112)
print v(xbgr.mr_n67606544)
print v(xbgr.mr_n67606976)
print v(xbgr.mr_n67607408)
print v(xbgr.mr_n67607728)
print v(xbgr.mr_n67607840)
print v(xbgr.mr_n67608160)
print v(xbgr.mr_n67608272)
print v(xbgr.mr_n67608704)
print v(xbgr.mr_n67609136)
print v(xbgr.mr_n67609568)
print v(xbgr.mr_n67610000)
print v(xbgr.mr_n67610432)
print v(xbgr.mr_n67610864)
print v(xbgr.mr_n67611296)
print v(xbgr.mr_n67611728)
print v(xbgr.mr_n67612160)
print v(xbgr.mr_n67612592)
print v(xbgr.mr_n67613024)
print v(xbgr.mr_n67613456)
print v(xbgr.mr_n67613888)
print v(xbgr.mr_n67614320)
print v(xbgr.mr_n67614752)
print v(xbgr.mr_n67615184)
print v(xbgr.mr_n67615616)
print v(xbgr.mr_n67616048)
print v(xbgr.mr_n67616480)
print v(xbgr.mr_n67616912)
print v(xbgr.mr_n67617344)
print v(xbgr.mr_n67617776)
print v(xbgr.mr_n67618208)
print v(xbgr.mr_n67618528)
print v(xbgr.mr_n67618640)
print v(xbgr.mr_n67618960)
print v(xbgr.mr_n67619072)
print v(xbgr.mr_n67619392)
print v(xbgr.mr_n67619504)
print v(xbgr.mr_n67619824)
print v(xbgr.mr_n67619936)
print v(xbgr.mr_n67620256)
print v(xbgr.mr_n67620368)
print v(xbgr.mr_n67620688)
print v(xbgr.mr_n67620800)
print v(xbgr.mr_n67621120)
print v(xbgr.mr_n67621232)
print v(xbgr.mr_n67621552)
print v(xbgr.mr_n67621664)
print v(xbgr.mr_n67621984)
print v(xbgr.mr_n67622096)
print v(xbgr.mr_n67622416)
print v(xbgr.mr_n67622528)
print v(xbgr.mr_n67622848)
print v(xbgr.mr_n67622960)
print v(xbgr.mr_n67623280)
print v(xbgr.mr_n67623392)
print v(xbgr.mr_n67623712)
print v(xbgr.mr_n67623824)
print v(xbgr.mr_n67624144)
print v(xbgr.mr_n67624256)
print v(xbgr.mr_n67624688)
print v(xbgr.mr_n67625120)
print v(xbgr.mr_n67625440)
print v(xbgr.mr_n67625552)
print v(xbgr.mr_n67625872)
print v(xbgr.mr_n67625984)
print v(xbgr.mr_n67626304)
print v(xbgr.mr_n67626416)
print v(xbgr.mr_n67626736)
print v(xbgr.mr_n67626848)
print v(xbgr.mr_n67627280)
print v(xbgr.mr_n67627712)
print v(xbgr.mr_n67628032)
print v(xbgr.mr_n67628144)
print v(xbgr.mr_n67628464)
print v(xbgr.mr_n67628576)
print v(xbgr.mr_n67628896)
print v(xbgr.mr_n67629008)
print v(xbgr.mr_n67629328)
print v(xbgr.mr_n67629440)
print v(xbgr.mr_n67629760)
print v(xbgr.mr_n67629872)
print v(xbgr.mr_n67630192)
print v(xbgr.mr_n67630304)
print v(xbgr.mr_n67630624)
print v(xbgr.mr_n67630736)
print v(xbgr.mr_n67631056)
print v(xbgr.mr_n67631168)
print v(xbgr.mr_n67631600)
print v(xbgr.mr_n67632032)
print v(xbgr.mr_n67632464)
print v(xbgr.mr_n67632896)
print v(xbgr.mr_n67633328)
print v(xbgr.mr_n67633760)
print v(xbgr.mr_n67634192)
print v(xbgr.mr_n67634624)
print v(xbgr.mr_n67635056)
print v(xbgr.mr_n67635488)
print v(xbgr.mr_n67635808)
print v(xbgr.mr_n67635920)
print v(xbgr.mr_n67636240)
print v(xbgr.mr_n67636352)
print v(xbgr.mr_n67636672)
print v(xbgr.mr_n67636784)
print v(xbgr.mr_n67637104)
print v(xbgr.mr_n67637216)
print v(xbgr.mr_n67642368)
print v(xbgr.mr_n67642480)
print v(xbgr.mr_n67642816)
print v(xbgr.mr_n67642928)
print v(xbgr.mr_n67643248)
print v(xbgr.mr_n67643360)
print v(xbgr.mr_n67643728)
print v(xbgr.mr_n67643840)
print v(xbgr.mr_n67644160)
print v(xbgr.mr_n67644272)
print v(xbgr.mr_n67644592)
print v(xbgr.mr_n67644704)
print v(xbgr.mr_n67644944)
print v(xbgr.mr_n67645056)
print v(xbgr.mr_n67645376)
print v(xbgr.mr_n67645488)
print v(xbgr.mr_n67645808)
print v(xbgr.mr_n67645920)
print v(xbgr.mr_n67646240)
print v(xbgr.mr_n67646352)
print v(xbgr.mr_n67646672)
print v(xbgr.mr_n67646784)
print v(xbgr.mr_n67647104)
print v(xbgr.mr_n67647216)
print v(xbgr.mr_n67647536)
print v(xbgr.mr_n67647648)
print v(xbgr.mr_n67647968)
print v(xbgr.mr_n67648080)
print v(xbgr.mr_n67648400)
print v(xbgr.mr_n67648512)
print v(xbgr.mr_n67648832)
print v(xbgr.mr_n67648944)
print v(xbgr.mr_n67649264)
print v(xbgr.mr_n67649376)
print v(xbgr.mr_n67649696)
print v(xbgr.mr_n67649808)
print v(xbgr.mr_n67650128)
print v(xbgr.mr_n67650240)
print v(xbgr.mr_n67650560)
print v(xbgr.mr_n67650672)
print v(xbgr.mr_n67650992)
print v(xbgr.mr_n67651104)
print v(xbgr.mr_n67651424)
print v(xbgr.mr_n67651536)
print v(xbgr.mr_n67651856)
print v(xbgr.mr_n67651968)
print v(xbgr.mr_n67652288)
print v(xbgr.mr_n67652400)
print v(xbgr.mr_n67652720)
print v(xbgr.mr_n67652832)
print v(xbgr.mr_n67653152)
print v(xbgr.mr_n67653264)
print v(xbgr.mr_n67653584)
print v(xbgr.mr_n67653696)
print v(xbgr.mr_n67654016)
print v(xbgr.mr_n67654128)
print v(xbgr.mr_n67654448)
print v(xbgr.mr_n67654560)
print v(xbgr.mr_n67654880)
print v(xbgr.mr_n67654992)
print v(xbgr.mr_n67655312)
print v(xbgr.mr_n67655424)
print v(xbgr.mr_n67655744)
print v(xbgr.mr_n67655856)
print v(xbgr.mr_n67656176)
print v(xbgr.mr_n67656288)
print v(xbgr.mr_n67656608)
print v(xbgr.mr_n67656720)
print v(xbgr.mr_n67657040)
print v(xbgr.mr_n67657152)
print v(xbgr.mr_n67657472)
print v(xbgr.mr_n67657584)
print v(xbgr.mr_n67657904)
print v(xbgr.mr_n67658016)
print v(xbgr.mr_n67658336)
print v(xbgr.mr_n67658448)
print v(xbgr.mr_n67658768)
print v(xbgr.mr_n67658880)
print v(xbgr.mr_n67659200)
print v(xbgr.mr_n67659312)
print v(xbgr.mr_n67659632)
print v(xbgr.mr_n67659744)
print v(xbgr.mr_n67660064)
print v(xbgr.mr_n67660176)
print v(xbgr.mr_n67660496)
print v(xbgr.mr_n67660608)
print v(xbgr.mr_n67660928)
print v(xbgr.mr_n67661040)
print v(xbgr.mr_n67661360)
print v(xbgr.mr_n67661472)
print v(xbgr.mr_n67661792)
print v(xbgr.mr_n67661904)
print v(xbgr.mr_n67662224)
print v(xbgr.mr_n67662336)
print v(xbgr.mr_n67662656)
print v(xbgr.mr_n67662768)
print v(xbgr.mr_n67663088)
print v(xbgr.mr_n67663200)
print v(xbgr.mr_n67663520)
print v(xbgr.mr_n67663632)
print v(xbgr.mr_n67663952)
print v(xbgr.mr_n67664064)
print v(xbgr.mr_n67664384)
print v(xbgr.mr_n67664496)
print v(xbgr.mr_n67664816)
print v(xbgr.mr_n67664928)
print v(xbgr.mr_n67665248)
print v(xbgr.mr_n67665360)
print v(xbgr.mr_n67665680)
print v(xbgr.mr_n67665792)
print v(xbgr.mr_n67666112)
print v(xbgr.mr_n67666224)
print v(xbgr.mr_n67666544)
print v(xbgr.mr_n67666656)
print v(xbgr.mr_n67666976)
print v(xbgr.mr_n67667088)
print v(xbgr.mr_n67667408)
print v(xbgr.mr_n67667520)
print v(xbgr.mr_n67667840)
print v(xbgr.mr_n67667952)
print v(xbgr.mr_n67668272)
print v(xbgr.mr_n67668384)
print v(xbgr.mr_n67668704)
print v(xbgr.mr_n67668816)
print v(xbgr.mr_n67669136)
print v(xbgr.mr_n67669248)
print v(xbgr.mr_n67669568)
print v(xbgr.mr_n67669680)
print v(xbgr.mr_n67670000)
print v(xbgr.mr_n67670112)
print v(xbgr.mr_n67670432)
print v(xbgr.mr_n67670544)
print v(xbgr.mr_n67670864)
print v(xbgr.mr_n67670976)
print v(xbgr.mr_n67671296)
print v(xbgr.mr_n67671408)
print v(xbgr.mr_n67671728)
print v(xbgr.mr_n67671840)
print v(xbgr.mr_n67672160)
print v(xbgr.mr_n67672272)
print v(xbgr.mr_n67672496)
print v(xbgr.mr_n67672608)
print v(xbgr.mr_n67672864)
print v(xbgr.mr_n67672976)
print v(xbgr.mr_n67673232)
print v(xbgr.mr_n67673344)
print v(xbgr.mr_n67673600)
print v(xbgr.mr_n67673712)
print v(xbgr.mr_n67673968)
print v(xbgr.mr_n67674080)
print v(xbgr.mr_n67674336)
print v(xbgr.mr_n67674448)
print v(xbgr.mr_n67674704)
print v(xbgr.mr_n67674816)
print v(xbgr.mr_n67675072)
print v(xbgr.mr_n67675184)
print v(xbgr.mr_n67675440)
print v(xbgr.mr_n67675552)
print v(xbgr.mr_n67675808)
print v(xbgr.mr_n67675920)
print v(xbgr.mr_n67676176)
print v(xbgr.mr_n67676288)
print v(xbgr.mr_n67676576)
print v(xbgr.mr_n67676688)
print v(xbgr.mr_n67677008)
print v(xbgr.mr_n67677120)
print v(xbgr.mr_n67677440)
print v(xbgr.mr_n67677552)
print v(xbgr.mr_n67677872)
print v(xbgr.mr_n67677984)
print v(xbgr.mr_n67678304)
print v(xbgr.mr_n67678416)
print v(xbgr.mr_n67678736)
print v(xbgr.mr_n67678848)
print v(xbgr.mr_n67679168)
print v(xbgr.mr_n67679280)
print v(xbgr.mr_n67679600)
print v(xbgr.mr_n67679712)
print v(xbgr.mr_n67680032)
print v(xbgr.mr_n67680144)
print v(xbgr.mr_n67680464)
print v(xbgr.mr_n67680576)
print v(xbgr.mr_n67680896)
print v(xbgr.mr_n67681008)
print v(xbgr.mr_n67681328)
print v(xbgr.mr_n67681440)
print v(xbgr.mr_n67681760)
print v(xbgr.mr_n67681872)
print v(xbgr.mr_n67682192)
print v(xbgr.mr_n67682304)
print v(xbgr.mr_n67682624)
print v(xbgr.mr_n67682736)
print v(xbgr.mr_n67683056)
print v(xbgr.mr_n67683168)
print v(xbgr.mr_n67683488)
print v(xbgr.mr_n67683600)
print v(xbgr.mr_n67683920)
print v(xbgr.mr_n67684032)
print v(xbgr.mr_n67684352)
print v(xbgr.mr_n67684464)
print v(xbgr.mr_n67684784)
print v(xbgr.mr_n67684896)
print v(xbgr.mr_n67685216)
print v(xbgr.mr_n67685328)
print v(xbgr.mr_n67685648)
print v(xbgr.mr_n67685760)
print v(xbgr.mr_n67686080)
print v(xbgr.mr_n67686192)
print v(xbgr.mr_n67686512)
print v(xbgr.mr_n67686624)
print v(xbgr.mr_n67686944)
print v(xbgr.mr_n67687056)
print v(xbgr.mr_n67687376)
print v(xbgr.mr_n67687488)
print v(xbgr.mr_n67687808)
print v(xbgr.mr_n67687920)
print v(xbgr.mr_n67688240)
print v(xbgr.mr_n67688352)
print v(xbgr.mr_n67688672)
print v(xbgr.mr_n67688784)
print v(xbgr.mr_n67689104)
print v(xbgr.mr_n67689216)
print v(xbgr.mr_n67689536)
print v(xbgr.mr_n67689648)
print v(xbgr.mr_n67689968)
print v(xbgr.mr_n67690080)
print v(xbgr.mr_n67690400)
print v(xbgr.mr_n67690512)
print v(xbgr.mr_n67690832)
print v(xbgr.mr_n67690944)
print v(xbgr.mr_n67691264)
print v(xbgr.mr_n67691376)
print v(xbgr.mr_n67691696)
print v(xbgr.mr_n67691808)
print v(xbgr.mr_n67692128)
print v(xbgr.mr_n67692240)
print v(xbgr.mr_n67692560)
print v(xbgr.mr_n67692672)
print v(xbgr.mr_n67692992)
print v(xbgr.mr_n67693104)
print v(xbgr.mr_n67693424)
print v(xbgr.mr_n67693536)
print v(xbgr.mr_n67693856)
print v(xbgr.mr_n67693968)
print v(xbgr.mr_n67694288)
print v(xbgr.mr_n67694400)
print v(xbgr.mr_n67694720)
print v(xbgr.mr_n67694832)
print v(xbgr.mr_n67695152)
print v(xbgr.mr_n67695264)
print v(xbgr.mr_n67695584)
print v(xbgr.mr_n67695696)
print v(xbgr.mr_n67696016)
print v(xbgr.mr_n67696128)
print v(xbgr.mr_n67696448)
print v(xbgr.mr_n67696560)
print v(xbgr.mr_n67696880)
print v(xbgr.mr_n67696992)
print v(xbgr.mr_n67697312)
print v(xbgr.mr_n67697424)
print v(xbgr.mr_n67697744)
print v(xbgr.mr_n67697856)
print v(xbgr.mr_n67698176)
print v(xbgr.mr_n67698288)
print v(xbgr.mr_n67698608)
print v(xbgr.mr_n67698720)
print v(xbgr.mr_n67699040)
print v(xbgr.mr_n67699152)
print v(xbgr.mr_n67699472)
print v(xbgr.mr_n67699584)
print v(xbgr.mr_n67699904)
print v(xbgr.mr_n67700016)
print v(xbgr.mr_n67700336)
print v(xbgr.mr_n67700448)
print v(xbgr.mr_n67700768)
print v(xbgr.mr_n67700880)
print v(xbgr.mr_n67701200)
print v(xbgr.mr_n67701312)
print v(xbgr.mr_n67701632)
print v(xbgr.mr_n67701744)
print v(xbgr.mr_n67702064)
print v(xbgr.mr_n67702176)
print v(xbgr.mr_n67702496)
print v(xbgr.mr_n67702608)
print v(xbgr.mr_n67702928)
print v(xbgr.mr_n67703040)
print v(xbgr.mr_n67703360)
print v(xbgr.mr_n67703472)
print v(xbgr.mr_n67703680)
print v(xbgr.mr_n67703792)
print v(xbgr.mr_n67704112)
print v(xbgr.mr_n67704224)
print v(xbgr.mr_n67704544)
print v(xbgr.mr_n67704656)
print v(xbgr.mr_n67704976)
print v(xbgr.mr_n67705088)
print v(xbgr.mr_n67705408)
print v(xbgr.mr_n67705520)
print v(xbgr.mr_n67705840)
print v(xbgr.mr_n67705952)
print v(xbgr.mr_n67706272)
print v(xbgr.mr_n67706384)
print v(xbgr.mr_n67706704)
print v(xbgr.mr_n67706816)
print v(xbgr.mr_n67707136)
print v(xbgr.mr_n67707248)
print v(xbgr.mr_n67707568)
print v(xbgr.mr_n67707680)
print v(xbgr.mr_n67708000)
print v(xbgr.mr_n67708112)
print v(xbgr.mr_n67708432)
print v(xbgr.mr_n67708544)
print v(xbgr.mr_n67708864)
print v(xbgr.mr_n67708976)
print v(xbgr.mr_n67709296)
print v(xbgr.mr_n67709408)
print v(xbgr.mr_n67709728)
print v(xbgr.mr_n67709840)
print v(xbgr.mr_n67710160)
print v(xbgr.mr_n67710272)
print v(xbgr.mr_n67710592)
print v(xbgr.mr_n67710704)
print v(xbgr.mr_n67711024)
print v(xbgr.mr_n67711136)
print v(xbgr.mr_n67711456)
print v(xbgr.mr_n67711568)
print v(xbgr.mr_n67711888)
print v(xbgr.mr_n67712000)
print v(xbgr.mr_n67712320)
print v(xbgr.mr_n67712432)
print v(xbgr.mr_n67712752)
print v(xbgr.mr_n67712864)
print v(xbgr.mr_n67713184)
print v(xbgr.mr_n67713296)
print v(xbgr.mr_n67713616)
print v(xbgr.mr_n67713728)
print v(xbgr.mr_n67714048)
print v(xbgr.mr_n67714160)
print v(xbgr.mr_n67714480)
print v(xbgr.mr_n67714592)
print v(xbgr.mr_n67714912)
print v(xbgr.mr_n67715024)
print v(xbgr.mr_n67715344)
print v(xbgr.mr_n67715456)
print v(xbgr.mr_n67715776)
print v(xbgr.mr_n67715888)
print v(xbgr.mr_n67716208)
print v(xbgr.mr_n67716320)
print v(xbgr.mr_n67716640)
print v(xbgr.mr_n67716752)
print v(xbgr.mr_n67717072)
print v(xbgr.mr_n67717184)
print v(xbgr.mr_n67717504)
print v(xbgr.mr_n67717616)
print v(xbgr.mr_n67717936)
print v(xbgr.mr_n67718048)
print v(xbgr.mr_n67718368)
print v(xbgr.mr_n67718480)
print v(xbgr.mr_n67718800)
print v(xbgr.mr_n67718912)
print v(xbgr.mr_n67719232)
print v(xbgr.mr_n67719344)
print v(xbgr.mr_n67719664)
print v(xbgr.mr_n67719776)
print v(xbgr.mr_n67720096)
print v(xbgr.mr_n67720208)
print v(xbgr.mr_n67720528)
print v(xbgr.mr_n67720640)
print v(xbgr.mr_n67720960)
print v(xbgr.mr_n67721072)
print v(xbgr.mr_n67721392)
print v(xbgr.mr_n67721504)
print v(xbgr.mr_n67721824)
print v(xbgr.mr_n67721936)
print v(xbgr.mr_n67722256)
print v(xbgr.mr_n67722368)
print v(xbgr.mr_n67722688)
print v(xbgr.mr_n67722800)
print v(xbgr.mr_n67723120)
print v(xbgr.mr_n67723232)
print v(xbgr.mr_n67723552)
print v(xbgr.mr_n67723664)
print v(xbgr.mr_n67723984)
print v(xbgr.mr_n67724096)
print v(xbgr.mr_n67724416)
print v(xbgr.mr_n67724528)
print v(xbgr.mr_n67724848)
print v(xbgr.mr_n67724960)
print v(xbgr.mr_n67725280)
print v(xbgr.mr_n67725392)
print v(xbgr.mr_n67725712)
print v(xbgr.mr_n67725824)
print v(xbgr.mr_n67726144)
print v(xbgr.mr_n67726256)
print v(xbgr.mr_n67726576)
print v(xbgr.mr_n67726688)
print v(xbgr.mr_n67727008)
print v(xbgr.mr_n67727120)
print v(xbgr.mr_n67727440)
print v(xbgr.mr_n67727552)
print v(xbgr.mr_n67727872)
print v(xbgr.mr_n67727984)
print v(xbgr.mr_n67728304)
print v(xbgr.mr_n67728416)
print v(xbgr.mr_n67728736)
print v(xbgr.mr_n67728848)
print v(xbgr.mr_n67729168)
print v(xbgr.mr_n67729280)
print v(xbgr.mr_n67729600)
print v(xbgr.mr_n67729712)
print v(xbgr.mr_n67730032)
print v(xbgr.mr_n67730144)
print v(xbgr.mr_n67730464)
print v(xbgr.mr_n67730576)
print v(xbgr.mr_n67730896)
print v(xbgr.mr_n67731008)
print v(xbgr.mr_n67731328)
print v(xbgr.mr_n67731440)
print v(xbgr.mr_n67731760)
print v(xbgr.mr_n67731872)
print v(xbgr.mr_n67732192)
print v(xbgr.mr_n67732304)
print v(xbgr.mr_n67732624)
print v(xbgr.mr_n67732736)
print v(xbgr.mr_n67733056)
print v(xbgr.mr_n67733168)
print v(xbgr.mr_n67733488)
print v(xbgr.mr_n67733600)
print v(xbgr.mr_n67733920)
print v(xbgr.mr_n67734032)
print v(xbgr.mr_n67734352)
print v(xbgr.mr_n67734464)
print v(xbgr.mr_n67734784)
print v(xbgr.mr_n67734896)
print v(xbgr.mr_n67735216)
print v(xbgr.mr_n67735328)
print v(xbgr.mr_n67735648)
print v(xbgr.mr_n67735760)
print v(xbgr.mr_n67736080)
print v(xbgr.mr_n67736192)
print v(xbgr.mr_n67736512)
print v(xbgr.mr_n67736624)
print v(xbgr.mr_n67736944)
print v(xbgr.mr_n67737056)
print v(xbgr.mr_n67737376)
print v(xbgr.mr_n67737488)
print v(xbgr.mr_n67737808)
print v(xbgr.mr_n67737920)
print v(xbgr.mr_n67738240)
print v(xbgr.mr_n67738352)
print v(xbgr.mr_n67738672)
print v(xbgr.mr_n67738784)
print v(xbgr.mr_n67739104)
print v(xbgr.mr_n67739216)
print v(xbgr.mr_n67739536)
print v(xbgr.mr_n67739648)
print v(xbgr.mr_n67739968)
print v(xbgr.mr_n67740080)
print v(xbgr.mr_n67740400)
print v(xbgr.mr_n67740512)
print v(xbgr.mr_n67740832)
print v(xbgr.mr_n67740944)
print v(xbgr.mr_n67741264)
print v(xbgr.mr_n67741376)
print v(xbgr.mr_n67741696)
print v(xbgr.mr_n67741808)
print v(xbgr.mr_n67742128)
print v(xbgr.mr_n67742240)
print v(xbgr.mr_n67742560)
print v(xbgr.mr_n67742672)
print v(xbgr.mr_n67742992)
print v(xbgr.mr_n67743104)
print v(xbgr.mr_n67743424)
print v(xbgr.mr_n67743536)
print v(xbgr.mr_n67743856)
print v(xbgr.mr_n67743968)
print v(xbgr.mr_n67744288)
print v(xbgr.mr_n67744400)
print v(xbgr.mr_n67744720)
print v(xbgr.mr_n67744832)
print v(xbgr.mr_n67745152)
print v(xbgr.mr_n67745264)
print v(xbgr.mr_n67745584)
print v(xbgr.mr_n67745696)
print v(xbgr.mr_n67746016)
print v(xbgr.mr_n67746128)
print v(xbgr.mr_n67746448)
print v(xbgr.mr_n67746560)
print v(xbgr.mr_n67746880)
print v(xbgr.mr_n67746992)
print v(xbgr.mr_n67747312)
print v(xbgr.mr_n67747424)
print v(xbgr.mr_n67747744)
print v(xbgr.mr_n67747856)
print v(xbgr.mr_n67748176)
print v(xbgr.mr_n67748288)
print v(xbgr.mr_n67748608)
print v(xbgr.mr_n67748720)
print v(xbgr.mr_n67749040)
print v(xbgr.mr_n67749152)
print v(xbgr.mr_n67749472)
print v(xbgr.mr_n67749584)
print v(xbgr.mr_n67749904)
print v(xbgr.mr_n67750016)
print v(xbgr.mr_n67750336)
print v(xbgr.mr_n67750448)
print v(xbgr.mr_n67750768)
print v(xbgr.mr_n67750880)
print v(xbgr.mr_n67751200)
print v(xbgr.mr_n67751312)
print v(xbgr.mr_n67751632)
print v(xbgr.mr_n67751744)
print v(xbgr.mr_n67752064)
print v(xbgr.mr_n67752176)
print v(xbgr.mr_n67752496)
print v(xbgr.mr_n67752608)
print v(xbgr.mr_n67752928)
print v(xbgr.mr_n67753040)
print v(xbgr.mr_n67753360)
print v(xbgr.mr_n67753472)
print v(xbgr.mr_n67753792)
print v(xbgr.mr_n67753904)
print v(xbgr.mr_n67754224)
print v(xbgr.mr_n67754336)
print v(xbgr.mr_n67754656)
print v(xbgr.mr_n67754768)
print v(xbgr.mr_n67755088)
print v(xbgr.mr_n67755200)
print v(xbgr.mr_n67755520)
print v(xbgr.mr_n67755632)
print v(xbgr.mr_n67755952)
print v(xbgr.mr_n67756064)
print v(xbgr.mr_n67756384)
print v(xbgr.mr_n67756496)
print v(xbgr.mr_n67756816)
print v(xbgr.mr_n67756928)
print v(xbgr.mr_n67757248)
print v(xbgr.mr_n67757360)
print v(xbgr.mr_n67757680)
print v(xbgr.mr_n67757792)
print v(xbgr.mr_n67758112)
print v(xbgr.mr_n67758224)
print v(xbgr.mr_n67758544)
print v(xbgr.mr_n67758656)
print v(xbgr.mr_n67758976)
print v(xbgr.mr_n67759088)
print v(xbgr.mr_n67759408)
print v(xbgr.mr_n67759520)
print v(xbgr.mr_n67759840)
print v(xbgr.mr_n67759952)
print v(xbgr.mr_n67760272)
print v(xbgr.mr_n67760384)
print v(xbgr.mr_n67760704)
print v(xbgr.mr_n67760816)
print v(xbgr.mr_n67761136)
print v(xbgr.mr_n67761248)
print v(xbgr.mr_n67761568)
print v(xbgr.mr_n67761680)
print v(xbgr.mr_n67762000)
print v(xbgr.mr_n67762112)
print v(xbgr.mr_n67762432)
print v(xbgr.mr_n67762544)
print v(xbgr.mr_n67762864)
print v(xbgr.mr_n67762976)
print v(xbgr.mr_n67763296)
print v(xbgr.mr_n67763408)
print v(xbgr.mr_n67763728)
print v(xbgr.mr_n67763840)
print v(xbgr.mr_n67764160)
print v(xbgr.mr_n67764272)
print v(xbgr.mr_n67764592)
print v(xbgr.mr_n67764704)
print v(xbgr.mr_n67765232)
print v(xbgr.mr_n67765344)
print v(xbgr.mr_n67765664)
print v(xbgr.mr_n67765776)
print v(xbgr.mr_n67766096)
print v(xbgr.mr_n67766208)
print v(xbgr.mr_n67766528)
print v(xbgr.mr_n67766640)
print v(xbgr.mr_n67766960)
print v(xbgr.mr_n67767072)
print v(xbgr.mr_n67767392)
print v(xbgr.mr_n67767504)
print v(xbgr.mr_n67767824)
print v(xbgr.mr_n67767936)
print v(xbgr.mr_n67768256)
print v(xbgr.mr_n67768368)
print v(xbgr.mr_n67768688)
print v(xbgr.mr_n67768800)
print v(xbgr.mr_n67769120)
print v(xbgr.mr_n67769232)
print v(xbgr.mr_n67769552)
print v(xbgr.mr_n67769664)
print v(xbgr.mr_n67769984)
print v(xbgr.mr_n67770096)
print v(xbgr.mr_n67770416)
print v(xbgr.mr_n67770528)
print v(xbgr.mr_n67770848)
print v(xbgr.mr_n67770960)
print v(xbgr.mr_n67771280)
print v(xbgr.mr_n67771392)
print v(xbgr.mr_n67771712)
print v(xbgr.mr_n67771824)
print v(xbgr.mr_n67772144)
print v(xbgr.mr_n67772256)
print v(xbgr.mr_n67772576)
print v(xbgr.mr_n67772688)
print v(xbgr.mr_n67773008)
print v(xbgr.mr_n67773120)
print v(xbgr.mr_n67773440)
print v(xbgr.mr_n67773552)
print v(xbgr.mr_n67773872)
print v(xbgr.mr_n67773984)
print v(xbgr.mr_n67774304)
print v(xbgr.mr_n67774416)
print v(xbgr.mr_n67774736)
print v(xbgr.mr_n67774848)
print v(xbgr.mr_n67775168)
print v(xbgr.mr_n67775280)
print v(xbgr.mr_n67775600)
print v(xbgr.mr_n67775712)
print v(xbgr.mr_n67776032)
print v(xbgr.mr_n67776144)
print v(xbgr.mr_n67776464)
print v(xbgr.mr_n67776576)
print v(xbgr.mr_n67776896)
print v(xbgr.mr_n67777008)
print v(xbgr.mr_n67777328)
print v(xbgr.mr_n67777440)
print v(xbgr.mr_n67777760)
print v(xbgr.mr_n67777872)
print v(xbgr.mr_n67778192)
print v(xbgr.mr_n67778304)
print v(xbgr.mr_n67778624)
print v(xbgr.mr_n67778736)
print v(xbgr.mr_n67779056)
print v(xbgr.mr_n67779168)
print v(xbgr.mr_n67779488)
print v(xbgr.mr_n67779600)
print v(xbgr.mr_n67779920)
print v(xbgr.mr_n67780032)
print v(xbgr.mr_n67780352)
print v(xbgr.mr_n67780464)
print v(xbgr.mr_n67780784)
print v(xbgr.mr_n67780896)
print v(xbgr.mr_n67781216)
print v(xbgr.mr_n67781328)
print v(xbgr.mr_n67781648)
print v(xbgr.mr_n67781760)
print v(xbgr.mr_n67782080)
print v(xbgr.mr_n67782192)
print v(xbgr.mr_n67782512)
print v(xbgr.mr_n67782624)
print v(xbgr.mr_n67782944)
print v(xbgr.mr_n67783056)
print v(xbgr.mr_n67783376)
print v(xbgr.mr_n67783488)
print v(xbgr.mr_n67783808)
print v(xbgr.mr_n67783920)
print v(xbgr.mr_n67784240)
print v(xbgr.mr_n67784352)
print v(xbgr.mr_n67784672)
print v(xbgr.mr_n67784784)
print v(xbgr.mr_n67785104)
print v(xbgr.mr_n67785216)
print v(xbgr.mr_n67785536)
print v(xbgr.mr_n67785648)
print v(xbgr.mr_n67785968)
print v(xbgr.mr_n67786080)
print v(xbgr.mr_n67786400)
print v(xbgr.mr_n67786512)
print v(xbgr.mr_n67786832)
print v(xbgr.mr_n67786944)
print v(xbgr.mr_n67787264)
print v(xbgr.mr_n67787376)
print v(xbgr.mr_n67787696)
print v(xbgr.mr_n67787808)
print v(xbgr.mr_n67788128)
print v(xbgr.mr_n67788240)
print v(xbgr.mr_n67788560)
print v(xbgr.mr_n67788672)
print v(xbgr.mr_n67788992)
print v(xbgr.mr_n67789104)
print v(xbgr.mr_n67789424)
print v(xbgr.mr_n67789536)
print v(xbgr.mr_n67789856)
print v(xbgr.mr_n67789968)
print v(xbgr.mr_n67790288)
print v(xbgr.mr_n67790400)
print v(xbgr.mr_n67790720)
print v(xbgr.mr_n67790832)
print v(xbgr.mr_n67791152)
print v(xbgr.mr_n67791264)
print v(xbgr.mr_n67791584)
print v(xbgr.mr_n67791696)
print v(xbgr.mr_n67792016)
print v(xbgr.mr_n67792128)
print v(xbgr.mr_n67792448)
print v(xbgr.mr_n67792560)
print v(xbgr.mr_n67792880)
print v(xbgr.mr_n67792992)
print v(xbgr.mr_n67793312)
print v(xbgr.mr_n67793424)
print v(xbgr.mr_n67793744)
print v(xbgr.mr_n67793856)
print v(xbgr.mr_n67794176)
print v(xbgr.mr_n67794288)
print v(xbgr.mr_n67794608)
print v(xbgr.mr_n67794720)
print v(xbgr.mr_n67795040)
print v(xbgr.mr_n67795152)
print v(xbgr.mr_n67795472)
print v(xbgr.mr_n67795584)
print v(xbgr.mr_n67795904)
print v(xbgr.mr_n67796016)
print v(xbgr.mr_n67796336)
print v(xbgr.mr_n67796448)
print v(xbgr.mr_n67796768)
print v(xbgr.mr_n67796880)
print v(xbgr.mr_n67797200)
print v(xbgr.mr_n67797312)
print v(xbgr.mr_n67797632)
print v(xbgr.mr_n67797744)
print v(xbgr.mr_n67798064)
print v(xbgr.mr_n67798176)
print v(xbgr.mr_n67798496)
print v(xbgr.mr_n67798608)
print v(xbgr.mr_n67798928)
print v(xbgr.mr_n67799040)
print v(xbgr.mr_n67799360)
print v(xbgr.mr_n67799472)
print v(xbgr.mr_n67799792)
print v(xbgr.mr_n67799904)
print v(xbgr.mr_n67800224)
print v(xbgr.mr_n67800336)
print v(xbgr.mr_n67800656)
print v(xbgr.mr_n67800768)
print v(xbgr.mr_n67801088)
print v(xbgr.mr_n67801200)
print v(xbgr.mr_n67801520)
print v(xbgr.mr_n67801632)
print v(xbgr.mr_n67801952)
print v(xbgr.mr_n67802064)
print v(xbgr.mr_n67802384)
print v(xbgr.mr_n67802496)
print v(xbgr.mr_n67802816)
print v(xbgr.mr_n67802928)
print v(xbgr.mr_n67803248)
print v(xbgr.mr_n67803360)
print v(xbgr.mr_n67803680)
print v(xbgr.mr_n67803792)
print v(xbgr.mr_n67804112)
print v(xbgr.mr_n67804224)
print v(xbgr.mr_n67804544)
print v(xbgr.mr_n67804656)
print v(xbgr.mr_n68067136)
print v(xbgr.mr_n68067376)
print v(xbgr.mr_n68067488)
print v(xbgr.mr_n68067808)
print v(xbgr.mr_n68067920)
print v(xbgr.mr_n68068240)
print v(xbgr.mr_n68068352)
print v(xbgr.mr_n68068672)
print v(xbgr.mr_n68068784)
print v(xbgr.mr_n68069104)
print v(xbgr.mr_n68069216)
print v(xbgr.mr_n68069536)
print v(xbgr.mr_n68069648)
print v(xbgr.mr_n68069968)
print v(xbgr.mr_n68070080)
print v(xbgr.mr_n68070400)
print v(xbgr.mr_n68070512)
print v(xbgr.mr_n68070832)
print v(xbgr.mr_n68070944)
print v(xbgr.mr_n68071264)
print v(xbgr.mr_n68071376)
print v(xbgr.mr_n68071696)
print v(xbgr.mr_n68071808)
print v(xbgr.mr_n68072128)
print v(xbgr.mr_n68072240)
print v(xbgr.mr_n68072560)
print v(xbgr.mr_n68072672)
print v(xbgr.mr_n68072992)
print v(xbgr.mr_n68073104)
print v(xbgr.mr_n68073424)
print v(xbgr.mr_n68073536)
print v(xbgr.mr_n68073856)
print v(xbgr.mr_n68073968)
print v(xbgr.mr_n68074288)
print v(xbgr.mr_n68074400)
print v(xbgr.mr_n68074720)
print v(xbgr.mr_n68074832)
print v(xbgr.mr_n68075152)
print v(xbgr.mr_n68075264)
print v(xbgr.mr_n68075584)
print v(xbgr.mr_n68075696)
print v(xbgr.mr_n68076016)
print v(xbgr.mr_n68076128)
print v(xbgr.mr_n68076448)
print v(xbgr.mr_n68076560)
print v(xbgr.mr_n68076880)
print v(xbgr.mr_n68076992)
print v(xbgr.mr_n68077312)
print v(xbgr.mr_n68077424)
print v(xbgr.mr_n68077744)
print v(xbgr.mr_n68077856)
print v(xbgr.mr_n68078176)
print v(xbgr.mr_n68078288)
print v(xbgr.mr_n68078608)
print v(xbgr.mr_n68078720)
print v(xbgr.mr_n68079040)
print v(xbgr.mr_n68079152)
print v(xbgr.mr_n68079472)
print v(xbgr.mr_n68079584)
print v(xbgr.mr_n68079904)
print v(xbgr.mr_n68080016)
print v(xbgr.mr_n68080336)
print v(xbgr.mr_n68080448)
print v(xbgr.mr_n68080768)
print v(xbgr.mr_n68080880)
print v(xbgr.mr_n68081200)
print v(xbgr.mr_n68081312)
print v(xbgr.mr_n68081632)
print v(xbgr.mr_n68081744)
print v(xbgr.mr_n68082064)
print v(xbgr.mr_n68082176)
print v(xbgr.mr_n68082496)
print v(xbgr.mr_n68082608)
print v(xbgr.mr_n68082928)
print v(xbgr.mr_n68083040)
print v(xbgr.mr_n68083360)
print v(xbgr.mr_n68083472)
print v(xbgr.mr_n68083792)
print v(xbgr.mr_n68083904)
print v(xbgr.mr_n68084224)
print v(xbgr.mr_n68084336)
print v(xbgr.mr_n68084656)
print v(xbgr.mr_n68084768)
print v(xbgr.mr_n68085088)
print v(xbgr.mr_n68085200)
print v(xbgr.mr_n68085520)
print v(xbgr.mr_n68085632)
print v(xbgr.mr_n68085952)
print v(xbgr.mr_n68086064)
print v(xbgr.mr_n68086384)
print v(xbgr.mr_n68086496)
print v(xbgr.mr_n68086816)
print v(xbgr.mr_n68086928)
print v(xbgr.mr_n68087248)
print v(xbgr.mr_n68087360)
print v(xbgr.mr_n68087680)
print v(xbgr.mr_n68087792)
print v(xbgr.mr_n68088112)
print v(xbgr.mr_n68088224)
print v(xbgr.mr_n68088544)
print v(xbgr.mr_n68088656)
print v(xbgr.mr_n68088976)
print v(xbgr.mr_n68089088)
print v(xbgr.mr_n68089408)
print v(xbgr.mr_n68089520)
print v(xbgr.mr_n68089840)
print v(xbgr.mr_n68089952)
print v(xbgr.mr_n68090272)
print v(xbgr.mr_n68090384)
print v(xbgr.mr_n68090704)
print v(xbgr.mr_n68090816)
print v(xbgr.mr_n68091136)
print v(xbgr.mr_n68091248)
print v(xbgr.mr_n68091568)
print v(xbgr.mr_n68091680)
print v(xbgr.mr_n68092000)
print v(xbgr.mr_n68092112)
print v(xbgr.mr_n68092432)
print v(xbgr.mr_n68092544)
print v(xbgr.mr_n68092864)
print v(xbgr.mr_n68092976)
print v(xbgr.mr_n68093296)
print v(xbgr.mr_n68093408)
print v(xbgr.mr_n68093728)
print v(xbgr.mr_n68093840)
print v(xbgr.mr_n68094160)
print v(xbgr.mr_n68094272)
print v(xbgr.mr_n68094592)
print v(xbgr.mr_n68094704)
print v(xbgr.mr_n68095024)
print v(xbgr.mr_n68095136)
print v(xbgr.mr_n68095456)
print v(xbgr.mr_n68095568)
print v(xbgr.mr_n68095888)
print v(xbgr.mr_n68096000)
print v(xbgr.mr_n68096320)
print v(xbgr.mr_n68096432)
print v(xbgr.mr_n68096752)
print v(xbgr.mr_n68096864)
print v(xbgr.mr_n68097184)
print v(xbgr.mr_n68097296)
print v(xbgr.mr_n68097616)
print v(xbgr.mr_n68097728)
print v(xbgr.mr_n68098048)
print v(xbgr.mr_n68098160)
print v(xbgr.mr_n68098480)
print v(xbgr.mr_n68098592)
print v(xbgr.mr_n68098912)
print v(xbgr.mr_n68099024)
print v(xbgr.mr_n68099344)
print v(xbgr.mr_n68099456)
print v(xbgr.mr_n68099776)
print v(xbgr.mr_n68099888)
print v(xbgr.mr_n68100208)
print v(xbgr.mr_n68100320)
print v(xbgr.mr_n68100640)
print v(xbgr.mr_n68100752)
print v(xbgr.mr_n68101072)
print v(xbgr.mr_n68101184)
print v(xbgr.mr_n68101504)
print v(xbgr.mr_n68101616)
print v(xbgr.mr_n68101936)
print v(xbgr.mr_n68102048)
print v(xbgr.mr_n68102368)
print v(xbgr.mr_n68102480)
print v(xbgr.mr_n68102800)
print v(xbgr.mr_n68102912)
print v(xbgr.mr_n68103232)
print v(xbgr.mr_n68103344)
print v(xbgr.mr_n68103664)
print v(xbgr.mr_n68103776)
print v(xbgr.mr_n68104096)
print v(xbgr.mr_n68104208)
print v(xbgr.mr_n68104528)
print v(xbgr.mr_n68104640)
print v(xbgr.mr_n68104960)
print v(xbgr.mr_n68105072)
print v(xbgr.mr_n68105392)
print v(xbgr.mr_n68105504)
print v(xbgr.mr_n68105824)
print v(xbgr.mr_n68105936)
print v(xbgr.mr_n68106256)
print v(xbgr.mr_n68106368)
print v(xbgr.mr_n68106688)
print v(xbgr.mr_n68106800)
print v(xbgr.mr_n68107120)
print v(xbgr.mr_n68107232)
print v(xbgr.mr_n68107552)
print v(xbgr.mr_n68107664)
print v(xbgr.mr_n68107984)
print v(xbgr.mr_n68108096)
print v(xbgr.mr_n68108416)
print v(xbgr.mr_n68108528)
print v(xbgr.mr_n68108848)
print v(xbgr.mr_n68108960)
print v(xbgr.mr_n68109280)
print v(xbgr.mr_n68109392)
print v(xbgr.mr_n68109712)
print v(xbgr.mr_n68109824)
print v(xbgr.mr_n68110144)
print v(xbgr.mr_n68110256)
print v(xbgr.mr_n68110576)
print v(xbgr.mr_n68110688)
print v(xbgr.mr_n68111008)
print v(xbgr.mr_n68111120)
print v(xbgr.mr_n68111440)
print v(xbgr.mr_n68111552)
print v(xbgr.mr_n68111872)
print v(xbgr.mr_n68111984)
print v(xbgr.mr_n68112304)
print v(xbgr.mr_n68112416)
print v(xbgr.mr_n68112736)
print v(xbgr.mr_n68112848)
print v(xbgr.mr_n68113168)
print v(xbgr.mr_n68113280)
print v(xbgr.mr_n68113600)
print v(xbgr.mr_n68113712)
print v(xbgr.mr_n68114032)
print v(xbgr.mr_n68114144)
print v(xbgr.mr_n68114464)
print v(xbgr.mr_n68114576)
print v(xbgr.mr_n68114896)
print v(xbgr.mr_n68115008)
print v(xbgr.mr_n68115328)
print v(xbgr.mr_n68115440)
print v(xbgr.mr_n68115760)
print v(xbgr.mr_n68115872)
print v(xbgr.mr_n68116192)
print v(xbgr.mr_n68116304)
print v(xbgr.mr_n68116624)
print v(xbgr.mr_n68116736)
print v(xbgr.mr_n68117056)
print v(xbgr.mr_n68117168)
print v(xbgr.mr_n68117488)
print v(xbgr.mr_n68117600)
print v(xbgr.mr_n68117920)
print v(xbgr.mr_n68118032)
print v(xbgr.mr_n68118352)
print v(xbgr.mr_n68118464)
print v(xbgr.mr_n68118784)
print v(xbgr.mr_n68118896)
print v(xbgr.mr_n68119216)
print v(xbgr.mr_n68119328)
print v(xbgr.mr_n68119648)
print v(xbgr.mr_n68119760)
print v(xbgr.mr_n68120080)
print v(xbgr.mr_n68120192)
print v(xbgr.mr_n68120512)
print v(xbgr.mr_n68120624)
print v(xbgr.mr_n68120944)
print v(xbgr.mr_n68121056)
print v(xbgr.mr_n68121376)
print v(xbgr.mr_n68121488)
print v(xbgr.mr_n68121808)
print v(xbgr.mr_n68121920)
print v(xbgr.mr_n68122240)
print v(xbgr.mr_n68122352)
print v(xbgr.mr_n68122672)
print v(xbgr.mr_n68122784)
print v(xbgr.mr_n68123104)
print v(xbgr.mr_n68123216)
print v(xbgr.mr_n68123536)
print v(xbgr.mr_n68123648)
print v(xbgr.mr_n68123968)
print v(xbgr.mr_n68124080)
print v(xbgr.mr_n68124400)
print v(xbgr.mr_n68124512)
print v(xbgr.mr_n68124832)
print v(xbgr.mr_n68124944)
print v(xbgr.mr_n68125264)
print v(xbgr.mr_n68125376)
print v(xbgr.mr_n68125696)
print v(xbgr.mr_n68125808)
print v(xbgr.mr_n68126128)
print v(xbgr.mr_n68126240)
print v(xbgr.mr_n68126560)
print v(xbgr.mr_n68126672)
print v(xbgr.mr_n68126992)
print v(xbgr.mr_n68127104)
print v(xbgr.mr_n68127424)
print v(xbgr.mr_n68127536)
print v(xbgr.mr_n68127856)
print v(xbgr.mr_n68127968)
print v(xbgr.mr_n68128288)
print v(xbgr.mr_n68128400)
print v(xbgr.mr_n68128720)
print v(xbgr.mr_n68128832)
print v(xbgr.mr_n68129152)
print v(xbgr.mr_n68129264)
print v(xbgr.mr_n68129584)
print v(xbgr.mr_n68129696)
print v(xbgr.mr_n68130016)
print v(xbgr.mr_n68130128)
print v(xbgr.mr_n68130448)
print v(xbgr.mr_n68130560)
print v(xbgr.mr_n68130880)
print v(xbgr.mr_n68130992)
print v(xbgr.mr_n68131312)
print v(xbgr.mr_n68131424)
print v(xbgr.mr_n68131744)
print v(xbgr.mr_n68131856)
print v(xbgr.mr_n68132176)
print v(xbgr.mr_n68132288)
print v(xbgr.mr_n68132608)
print v(xbgr.mr_n68132720)
print v(xbgr.mr_n68133040)
print v(xbgr.mr_n68133152)
print v(xbgr.mr_n68133472)
print v(xbgr.mr_n68133584)
print v(xbgr.mr_n68133904)
print v(xbgr.mr_n68134016)
print v(xbgr.mr_n68134336)
print v(xbgr.mr_n68134448)
print v(xbgr.mr_n68134768)
print v(xbgr.mr_n68134880)
print v(xbgr.mr_n68135200)
print v(xbgr.mr_n68135312)
print v(xbgr.mr_n68135632)
print v(xbgr.mr_n68135744)
print v(xbgr.mr_n68136064)
print v(xbgr.mr_n68136176)
print v(xbgr.mr_n68136496)
print v(xbgr.mr_n68136608)
print v(xbgr.mr_n68136928)
print v(xbgr.mr_n68137040)
print v(xbgr.mr_n68137360)
print v(xbgr.mr_n68137472)
print v(xbgr.mr_n68137792)
print v(xbgr.mr_n68137904)
print v(xbgr.mr_n68138224)
print v(xbgr.mr_n68138336)
print v(xbgr.mr_n68138656)
print v(xbgr.mr_n68138768)
print v(xbgr.mr_n68139088)
print v(xbgr.mr_n68139200)
print v(xbgr.mr_n68139520)
print v(xbgr.mr_n68139632)
print v(xbgr.mr_n68139952)
print v(xbgr.mr_n68140064)
print v(xbgr.mr_n68140384)
print v(xbgr.mr_n68140496)
print v(xbgr.mr_n68140816)
print v(xbgr.mr_n68140928)
print v(xbgr.mr_n68141248)
print v(xbgr.mr_n68141360)
print v(xbgr.mr_n68141680)
print v(xbgr.mr_n68141792)
print v(xbgr.mr_n68142112)
print v(xbgr.mr_n68142224)
print v(xbgr.mr_n68142544)
print v(xbgr.mr_n68142656)
print v(xbgr.mr_n68142976)
print v(xbgr.mr_n68143088)
print v(xbgr.mr_n68143408)
print v(xbgr.mr_n68143520)
print v(xbgr.mr_n68143840)
print v(xbgr.mr_n68143952)
print v(xbgr.mr_n68144272)
print v(xbgr.mr_n68144384)
print v(xbgr.mr_n68144704)
print v(xbgr.mr_n68144816)
print v(xbgr.mr_n68145136)
print v(xbgr.mr_n68145248)
print v(xbgr.mr_n68145568)
print v(xbgr.mr_n68145680)
print v(xbgr.mr_n68146000)
print v(xbgr.mr_n68146112)
print v(xbgr.mr_n68146432)
print v(xbgr.mr_n68146544)
print v(xbgr.mr_n68146864)
print v(xbgr.mr_n68146976)
print v(xbgr.mr_n68147296)
print v(xbgr.mr_n68147408)
print v(xbgr.mr_n68147728)
print v(xbgr.mr_n68147840)
print v(xbgr.mr_n68148160)
print v(xbgr.mr_n68148272)
print v(xbgr.mr_n68148592)
print v(xbgr.mr_n68148704)
print v(xbgr.mr_n68149024)
print v(xbgr.mr_n68149136)
print v(xbgr.mr_n68149456)
print v(xbgr.mr_n68149568)
print v(xbgr.mr_n68149888)
print v(xbgr.mr_n68150000)
print v(xbgr.mr_n68150320)
print v(xbgr.mr_n68150432)
print v(xbgr.mr_n68150752)
print v(xbgr.mr_n68150864)
print v(xbgr.mr_n68151184)
print v(xbgr.mr_n68151296)
print v(xbgr.mr_n68151616)
print v(xbgr.mr_n68151728)
print v(xbgr.mr_n68152048)
print v(xbgr.mr_n68152160)
print v(xbgr.mr_n68152480)
print v(xbgr.mr_n68152592)
print v(xbgr.mr_n68152912)
print v(xbgr.mr_n68153024)
print v(xbgr.mr_n68153344)
print v(xbgr.mr_n68153456)
print v(xbgr.mr_n68153776)
print v(xbgr.mr_n68153888)
print v(xbgr.mr_n68154208)
print v(xbgr.mr_n68154320)
print v(xbgr.mr_n68154640)
print v(xbgr.mr_n68154752)
print v(xbgr.mr_n68155072)
print v(xbgr.mr_n68155184)
print v(xbgr.mr_n68155504)
print v(xbgr.mr_n68155616)
print v(xbgr.mr_n68155936)
print v(xbgr.mr_n68156048)
print v(xbgr.mr_n68156368)
print v(xbgr.mr_n68156480)
print v(xbgr.mr_n68156800)
print v(xbgr.mr_n68156912)
print v(xbgr.mr_n68157232)
print v(xbgr.mr_n68157344)
print v(xbgr.mr_n68157664)
print v(xbgr.mr_n68157776)
print v(xbgr.mr_n68158096)
print v(xbgr.mr_n68158208)
print v(xbgr.mr_n68158528)
print v(xbgr.mr_n68158640)
print v(xbgr.mr_n68158960)
print v(xbgr.mr_n68159072)
print v(xbgr.mr_n68159392)
print v(xbgr.mr_n68159504)
print v(xbgr.mr_n68159824)
print v(xbgr.mr_n68159936)
print v(xbgr.mr_n68160256)
print v(xbgr.mr_n68160368)
print v(xbgr.mr_n68160688)
print v(xbgr.mr_n68160800)
print v(xbgr.mr_n68161120)
print v(xbgr.mr_n68161232)
print v(xbgr.mr_n68161552)
print v(xbgr.mr_n68161664)
print v(xbgr.mr_n68161984)
print v(xbgr.mr_n68162096)
print v(xbgr.mr_n68162416)
print v(xbgr.mr_n68162528)
print v(xbgr.mr_n68162848)
print v(xbgr.mr_n68162960)
print v(xbgr.mr_n68163280)
print v(xbgr.mr_n68163392)
print v(xbgr.mr_n68163712)
print v(xbgr.mr_n68163824)
print v(xbgr.mr_n68164144)
print v(xbgr.mr_n68164256)
print v(xbgr.mr_n68164576)
print v(xbgr.mr_n68164688)
print v(xbgr.mr_n68165008)
print v(xbgr.mr_n68165120)
print v(xbgr.mr_n68165440)
print v(xbgr.mr_n68165552)
print v(xbgr.mr_n68165872)
print v(xbgr.mr_n68165984)
print v(xbgr.mr_n68166304)
print v(xbgr.mr_n68166416)
print v(xbgr.mr_n68166736)
print v(xbgr.mr_n68166848)
print v(xbgr.mr_n68167168)
print v(xbgr.mr_n68167280)
print v(xbgr.mr_n68167600)
print v(xbgr.mr_n68167712)
print v(xbgr.mr_n68168032)
print v(xbgr.mr_n68168144)
print v(xbgr.mr_n68168464)
print v(xbgr.mr_n68168576)
print v(xbgr.mr_n68168896)
print v(xbgr.mr_n68169008)
print v(xbgr.mr_n68169328)
print v(xbgr.mr_n68169440)
print v(xbgr.mr_n68169760)
print v(xbgr.mr_n68169872)
print v(xbgr.mr_n68170192)
print v(xbgr.mr_n68170304)
print v(xbgr.mr_n68170624)
print v(xbgr.mr_n68170736)
print v(xbgr.mr_n68171056)
print v(xbgr.mr_n68171168)
print v(xbgr.mr_n68171488)
print v(xbgr.mr_n68171600)
print v(xbgr.mr_n68171920)
print v(xbgr.mr_n68172032)
print v(xbgr.mr_n68172352)
print v(xbgr.mr_n68172464)
print v(xbgr.mr_n68172784)
print v(xbgr.mr_n68172896)
print v(xbgr.mr_n68173216)
print v(xbgr.mr_n68173328)
print v(xbgr.mr_n68173648)
print v(xbgr.mr_n68173760)
print v(xbgr.mr_n68174080)
print v(xbgr.mr_n68174192)
print v(xbgr.mr_n68174512)
print v(xbgr.mr_n68174624)
print v(xbgr.mr_n68174944)
print v(xbgr.mr_n68175056)
print v(xbgr.mr_n68175376)
print v(xbgr.mr_n68175488)
print v(xbgr.mr_n68175808)
print v(xbgr.mr_n68175920)
print v(xbgr.mr_n68176240)
print v(xbgr.mr_n68176352)
print v(xbgr.mr_n68176672)
print v(xbgr.mr_n68176784)
print v(xbgr.mr_n68177104)
print v(xbgr.mr_n68177216)
print v(xbgr.mr_n68177536)
print v(xbgr.mr_n68177648)
print v(xbgr.mr_n68177968)
print v(xbgr.mr_n68178080)
print v(xbgr.mr_n68178400)
print v(xbgr.mr_n68178512)
print v(xbgr.mr_n68178832)
print v(xbgr.mr_n68178944)
print v(xbgr.mr_n68179264)
print v(xbgr.mr_n68179376)
print v(xbgr.mr_n68179696)
print v(xbgr.mr_n68179808)
print v(xbgr.mr_n68180128)
print v(xbgr.mr_n68180240)
print v(xbgr.mr_n68180560)
print v(xbgr.mr_n68180672)
print v(xbgr.mr_n68180992)
print v(xbgr.mr_n68181104)
print v(xbgr.mr_n68181424)
print v(xbgr.mr_n68181536)
print v(xbgr.mr_n68181856)
print v(xbgr.mr_n68181968)
print v(xbgr.mr_n68182288)
print v(xbgr.mr_n68182400)
print v(xbgr.mr_n68182720)
print v(xbgr.mr_n68182832)
print v(xbgr.mr_n68183152)
print v(xbgr.mr_n68183264)
print v(xbgr.mr_n68183584)
print v(xbgr.mr_n68183696)
print v(xbgr.mr_n68184016)
print v(xbgr.mr_n68184128)
print v(xbgr.mr_n68184448)
print v(xbgr.mr_n68184560)
print v(xbgr.mr_n68184880)
print v(xbgr.mr_n68184992)
print v(xbgr.mr_n68185312)
print v(xbgr.mr_n68185424)
print v(xbgr.mr_n68185744)
print v(xbgr.mr_n68185856)
print v(xbgr.mr_n68186176)
print v(xbgr.mr_n68186288)
print v(xbgr.mr_n68186608)
print v(xbgr.mr_n68186720)
print v(xbgr.mr_n68187040)
print v(xbgr.mr_n68187152)
print v(xbgr.mr_n68187472)
print v(xbgr.mr_n68187584)
print v(xbgr.mr_n68187904)
print v(xbgr.mr_n68188016)
print v(xbgr.mr_n68188336)
print v(xbgr.mr_n68188448)
print v(xbgr.mr_n68188768)
print v(xbgr.mr_n68188880)
print v(xbgr.mr_n68189200)
print v(xbgr.mr_n68189312)
print v(xbgr.mr_n68189632)
print v(xbgr.mr_n68189744)
print v(xbgr.mr_n68190064)
print v(xbgr.mr_n68190176)
print v(xbgr.mr_n68190496)
print v(xbgr.mr_n68190608)
print v(xbgr.mr_n68190928)
print v(xbgr.mr_n68191040)
print v(xbgr.mr_n68191360)
print v(xbgr.mr_n68191472)
print v(xbgr.mr_n68191792)
print v(xbgr.mr_n68191904)
print v(xbgr.mr_n68192224)
print v(xbgr.mr_n68192336)
print v(xbgr.mr_n68192656)
print v(xbgr.mr_n68192768)
print v(xbgr.mr_n68193088)
print v(xbgr.mr_n68193200)
print v(xbgr.mr_n68193520)
print v(xbgr.mr_n68193632)
print v(xbgr.mr_n68193952)
print v(xbgr.mr_n68194064)
print v(xbgr.mr_n68194384)
print v(xbgr.mr_n68194496)
print v(xbgr.mr_n68194816)
print v(xbgr.mr_n68194928)
print v(xbgr.mr_n68195248)
print v(xbgr.mr_n68195360)
print v(xbgr.mr_n68195680)
print v(xbgr.mr_n68195792)
print v(xbgr.mr_n68196112)
print v(xbgr.mr_n68196224)
print v(xbgr.mr_n68196544)
print v(xbgr.mr_n68196656)
print v(xbgr.mr_n68196976)
print v(xbgr.mr_n68197088)
print v(xbgr.mr_n68197408)
print v(xbgr.mr_n68197520)
print v(xbgr.mr_n68197840)
print v(xbgr.mr_n68197952)
print v(xbgr.mr_n68198272)
print v(xbgr.mr_n68198384)
print v(xbgr.mr_n68198704)
print v(xbgr.mr_n68198816)
print v(xbgr.mr_n68199136)
print v(xbgr.mr_n68199248)
print v(xbgr.mr_n68199568)
print v(xbgr.mr_n68199680)
print v(xbgr.mr_n68200000)
print v(xbgr.mr_n68200112)
print v(xbgr.mr_n68200432)
print v(xbgr.mr_n68200544)
print v(xbgr.mr_n68200864)
print v(xbgr.mr_n68200976)
print v(xbgr.mr_n68201296)
print v(xbgr.mr_n68201408)
print v(xbgr.mr_n68201728)
print v(xbgr.mr_n68201840)
print v(xbgr.mr_n68202160)
print v(xbgr.mr_n68202272)
print v(xbgr.mr_n68202592)
print v(xbgr.mr_n68202704)
print v(xbgr.mr_n68203024)
print v(xbgr.mr_n68203136)
print v(xbgr.mr_n68203456)
print v(xbgr.mr_n68203568)
print v(xbgr.mr_n68203888)
print v(xbgr.mr_n68204000)
print v(xbgr.mr_n68204320)
print v(xbgr.mr_n68204432)
print v(xbgr.mr_n68204752)
print v(xbgr.mr_n68204864)
print v(xbgr.mr_n68205184)
print v(xbgr.mr_n68205296)
print v(xbgr.mr_n68205616)
print v(xbgr.mr_n68205728)
print v(xbgr.mr_n68206048)
print v(xbgr.mr_n68206160)
print v(xbgr.mr_n68206480)
print v(xbgr.mr_n68206592)
print v(xbgr.mr_n68206912)
print v(xbgr.mr_n68207024)
print v(xbgr.mr_n68207344)
print v(xbgr.mr_n68207456)
print v(xbgr.mr_n68207776)
print v(xbgr.mr_n68207888)
print v(xbgr.mr_n68208208)
print v(xbgr.mr_n68208320)
print v(xbgr.mr_n68208640)
print v(xbgr.mr_n68208752)
print v(xbgr.mr_n68209072)
print v(xbgr.mr_n68209184)
print v(xbgr.mr_n68209504)
print v(xbgr.mr_n68209616)
print v(xbgr.mr_n68209936)
print v(xbgr.mr_n68210048)
print v(xbgr.mr_n68210368)
print v(xbgr.mr_n68210480)
print v(xbgr.mr_n68210800)
print v(xbgr.mr_n68210912)
print v(xbgr.mr_n68211232)
print v(xbgr.mr_n68211344)
print v(xbgr.mr_n68211664)
print v(xbgr.mr_n68211776)
print v(xbgr.mr_n68212096)
print v(xbgr.mr_n68212208)
print v(xbgr.mr_n68212528)
print v(xbgr.mr_n68212640)
print v(xbgr.mr_n68212960)
print v(xbgr.mr_n68213072)
print v(xbgr.mr_n68213392)
print v(xbgr.mr_n68213504)
print v(xbgr.mr_n68213824)
print v(xbgr.mr_n68213936)
print v(xbgr.mr_n68214256)
print v(xbgr.mr_n68214368)
print v(xbgr.mr_n68214688)
print v(xbgr.mr_n68214800)
print v(xbgr.mr_n68215120)
print v(xbgr.mr_n68215232)
print v(xbgr.mr_n68215552)
print v(xbgr.mr_n68215664)
print v(xbgr.mr_n68215984)
print v(xbgr.mr_n68216096)
print v(xbgr.mr_n68216416)
print v(xbgr.mr_n68216528)
print v(xbgr.mr_n68216848)
print v(xbgr.mr_n68216960)
print v(xbgr.mr_n68217280)
print v(xbgr.mr_n68217392)
print v(xbgr.mr_n68217712)
print v(xbgr.mr_n68217824)
print v(xbgr.mr_n68218144)
print v(xbgr.mr_n68218256)
print v(xbgr.mr_n68218576)
print v(xbgr.mr_n68218688)
print v(xbgr.mr_n68219008)
print v(xbgr.mr_n68219120)
print v(xbgr.mr_n68219440)
print v(xbgr.mr_n68219552)
print v(xbgr.mr_n68219872)
print v(xbgr.mr_n68219984)
print v(xbgr.mr_n68220304)
print v(xbgr.mr_n68220416)
print v(xbgr.mr_n68220736)
print v(xbgr.mr_n68220848)
print v(xbgr.mr_n68221168)
print v(xbgr.mr_n68221280)
print v(xbgr.mr_n68221600)
print v(xbgr.mr_n68221712)
print v(xbgr.mr_n68222032)
print v(xbgr.mr_n68222144)
print v(xbgr.mr_n68222464)
print v(xbgr.mr_n68222576)
print v(xbgr.mr_n68222896)
print v(xbgr.mr_n68223008)
print v(xbgr.mr_n68223328)
print v(xbgr.mr_n68223440)
print v(xbgr.mr_n68223760)
print v(xbgr.mr_n68223872)
print v(xbgr.mr_n68224192)
print v(xbgr.mr_n68224304)
print v(xbgr.mr_n68224624)
print v(xbgr.mr_n68224736)
print v(xbgr.mr_n68225056)
print v(xbgr.mr_n68225168)
print v(xbgr.mr_n68225488)
print v(xbgr.mr_n68225600)
print v(xbgr.mr_n68225920)
print v(xbgr.mr_n68226032)
print v(xbgr.mr_n68226352)
print v(xbgr.mr_n68226464)
print v(xbgr.mr_n68226784)
print v(xbgr.mr_n68226896)
print v(xbgr.mr_n68227216)
print v(xbgr.mr_n68227328)
print v(xbgr.mr_n68227648)
print v(xbgr.mr_n68227760)
print v(xbgr.mr_n68228080)
print v(xbgr.mr_n68228192)
print v(xbgr.mr_n68228512)
print v(xbgr.mr_n68228624)
print v(xbgr.mr_n68228944)
print v(xbgr.mr_n68229056)
print v(xbgr.mr_n68229376)
print v(xbgr.mr_n68229488)
print v(xbgr.mr_n68229808)
print v(xbgr.mr_n68229920)
print v(xbgr.mr_n68230240)
print v(xbgr.mr_n68230352)
print v(xbgr.mr_n68230672)
print v(xbgr.mr_n68230784)
print v(xbgr.mr_n68231104)
print v(xbgr.mr_n68231216)
print v(xbgr.mr_n68231536)
print v(xbgr.mr_n68231648)
print v(xbgr.mr_n68231968)
print v(xbgr.mr_n68232080)
print v(xbgr.mr_n68232400)
print v(xbgr.mr_n68232512)
print v(xbgr.mr_n68232832)
print v(xbgr.mr_n68232944)
print v(xbgr.mr_n68233264)
print v(xbgr.mr_n68233376)
print v(xbgr.mr_n68233696)
print v(xbgr.mr_n68233808)
print v(xbgr.mr_n68234128)
print v(xbgr.mr_n68234240)
print v(xbgr.mr_n68234560)
print v(xbgr.mr_n68234672)
print v(xbgr.mr_n68234992)
print v(xbgr.mr_n68235104)
print v(xbgr.mr_n68235424)
print v(xbgr.mr_n68235536)
print v(xbgr.mr_n68235856)
print v(xbgr.mr_n68235968)
print v(xbgr.mr_n68236288)
print v(xbgr.mr_n68236400)
print v(xbgr.mr_n68236720)
print v(xbgr.mr_n68236832)
print v(xbgr.mr_n68237152)
print v(xbgr.mr_n68237264)
print v(xbgr.mr_n68237584)
print v(xbgr.mr_n68237696)
print v(xbgr.mr_n68238016)
print v(xbgr.mr_n68238128)
print v(xbgr.mr_n68238448)
print v(xbgr.mr_n68238560)
print v(xbgr.mr_n68238880)
print v(xbgr.mr_n68238992)
print v(xbgr.mr_n68239312)
print v(xbgr.mr_n68239424)
print v(xbgr.mr_n68239744)
print v(xbgr.mr_n68239856)
print v(xbgr.mr_n68240176)
print v(xbgr.mr_n68240288)
print v(xbgr.mr_n68240608)
print v(xbgr.mr_n68240720)
print v(xbgr.mr_n68241040)
print v(xbgr.mr_n68241152)
print v(xbgr.mr_n68241472)
print v(xbgr.mr_n68241584)
print v(xbgr.mr_n68241904)
print v(xbgr.mr_n68242016)
print v(xbgr.mr_n68242336)
print v(xbgr.mr_n68242448)
print v(xbgr.mr_n68242768)
print v(xbgr.mr_n68242880)
print v(xbgr.mr_n68243200)
print v(xbgr.mr_n68243312)
print v(xbgr.mr_n68243632)
print v(xbgr.mr_n68243744)
print v(xbgr.mr_n68244064)
print v(xbgr.mr_n68244176)
print v(xbgr.mr_n68244496)
print v(xbgr.mr_n68244608)
print v(xbgr.mr_n68244928)
print v(xbgr.mr_n68245040)
print v(xbgr.mr_n68245360)
print v(xbgr.mr_n68245472)
print v(xbgr.mr_n68245792)
print v(xbgr.mr_n68245904)
print v(xbgr.mr_n68246224)
print v(xbgr.mr_n68246336)
print v(xbgr.mr_n68246656)
print v(xbgr.mr_n68246768)
print v(xbgr.mr_n68247088)
print v(xbgr.mr_n68247200)
print v(xbgr.mr_n68247520)
print v(xbgr.mr_n68247632)
print v(xbgr.mr_n68247952)
print v(xbgr.mr_n68248064)
print v(xbgr.mr_n68248384)
print v(xbgr.mr_n68248496)
print v(xbgr.mr_n68248816)
print v(xbgr.mr_n68248928)
print v(xbgr.mr_n68249248)
print v(xbgr.mr_n68249360)
print v(xbgr.mr_n68249680)
print v(xbgr.mr_n68249792)
print v(xbgr.mr_n68250112)
print v(xbgr.mr_n68250224)
print v(xbgr.mr_n68250544)
print v(xbgr.mr_n68250656)
print v(xbgr.mr_n68250976)
print v(xbgr.mr_n68251088)
print v(xbgr.mr_n68251408)
print v(xbgr.mr_n68251520)
print v(xbgr.mr_n68251840)
print v(xbgr.mr_n68251952)
print v(xbgr.mr_n68252272)
print v(xbgr.mr_n68252384)
print v(xbgr.mr_n68252704)
print v(xbgr.mr_n68252816)
print v(xbgr.mr_n68253136)
print v(xbgr.mr_n68253248)
print v(xbgr.mr_n68253568)
print v(xbgr.mr_n68253680)
print v(xbgr.mr_n68254000)
print v(xbgr.mr_n68254112)
print v(xbgr.mr_n68254432)
print v(xbgr.mr_n68254544)
print v(xbgr.mr_n68254864)
print v(xbgr.mr_n68254976)
print v(xbgr.mr_n68255296)
print v(xbgr.mr_n68255408)
print v(xbgr.mr_n68255728)
print v(xbgr.mr_n68255840)
print v(xbgr.mr_n68256160)
print v(xbgr.mr_n68256272)
print v(xbgr.mr_n68256592)
print v(xbgr.mr_n68256704)
print v(xbgr.mr_n68257024)
print v(xbgr.mr_n68257136)
print v(xbgr.mr_n68257456)
print v(xbgr.mr_n68257568)
print v(xbgr.mr_n68257888)
print v(xbgr.mr_n68258000)
print v(xbgr.mr_n68258320)
print v(xbgr.mr_n68258432)
print v(xbgr.mr_n68258752)
print v(xbgr.mr_n68258864)
print v(xbgr.mr_n68259184)
print v(xbgr.mr_n68259296)
print v(xbgr.mr_n68259616)
print v(xbgr.mr_n68259728)
print v(xbgr.mr_n68260048)
print v(xbgr.mr_n68260160)
print v(xbgr.mr_n68260480)
print v(xbgr.mr_n68260592)
print v(xbgr.mr_n68260912)
print v(xbgr.mr_n68261024)
print v(xbgr.mr_n68261344)
print v(xbgr.mr_n68261456)
print v(xbgr.mr_n68261776)
print v(xbgr.mr_n68261888)
print v(xbgr.mr_n68262208)
print v(xbgr.mr_n68262320)
print v(xbgr.mr_n68262640)
print v(xbgr.mr_n68262752)
print v(xbgr.mr_n68263072)
print v(xbgr.mr_n68263184)
print v(xbgr.mr_n68263504)
print v(xbgr.mr_n68263616)
print v(xbgr.mr_n68263936)
print v(xbgr.mr_n68264048)
print v(xbgr.mr_n68264368)
print v(xbgr.mr_n68264480)
print v(xbgr.mr_n68264784)
print v(xbgr.mr_n68264896)
print v(xbgr.mr_n68265216)
print v(xbgr.mr_n68265328)
print v(xbgr.mr_n68265648)
print v(xbgr.mr_n68265760)
print v(xbgr.mr_n68266080)
print v(xbgr.mr_n68266192)
print v(xbgr.mr_n68266512)
print v(xbgr.mr_n68266624)
print v(xbgr.mr_n68266944)
print v(xbgr.mr_n68267056)
print v(xbgr.mr_n68267376)
print v(xbgr.mr_n68267488)
print v(xbgr.mr_n68267808)
print v(xbgr.mr_n68267920)
print v(xbgr.mr_n68268240)
print v(xbgr.mr_n68268352)
print v(xbgr.mr_n68268672)
print v(xbgr.mr_n68268784)
print v(xbgr.mr_n68269104)
print v(xbgr.mr_n68269216)
print v(xbgr.mr_n68269536)
print v(xbgr.mr_n68269648)
print v(xbgr.mr_n68269968)
print v(xbgr.mr_n68270080)
print v(xbgr.mr_n68270400)
print v(xbgr.mr_n68270512)
print v(xbgr.mr_n68270832)
print v(xbgr.mr_n68270944)
print v(xbgr.mr_n68271264)
print v(xbgr.mr_n68271376)
print v(xbgr.mr_n68271696)
print v(xbgr.mr_n68271808)
print v(xbgr.mr_n68272128)
print v(xbgr.mr_n68272240)
print v(xbgr.mr_n68272560)
print v(xbgr.mr_n68272672)
print v(xbgr.mr_n68272992)
print v(xbgr.mr_n68273104)
print v(xbgr.mr_n68273424)
print v(xbgr.mr_n68273536)
print v(xbgr.mr_n68273856)
print v(xbgr.mr_n68273968)
print v(xbgr.mr_n68274288)
print v(xbgr.mr_n68274400)
print v(xbgr.mr_n68274720)
print v(xbgr.mr_n68274832)
print v(xbgr.mr_n68275152)
print v(xbgr.mr_n68275264)
print v(xbgr.mr_n68275584)
print v(xbgr.mr_n68275696)
print v(xbgr.mr_n68276016)
print v(xbgr.mr_n68276128)
print v(xbgr.mr_n68276448)
print v(xbgr.mr_n68276560)
print v(xbgr.mr_n68276880)
print v(xbgr.mr_n68276992)
print v(xbgr.mr_n68277312)
print v(xbgr.mr_n68277424)
print v(xbgr.mr_n68277744)
print v(xbgr.mr_n68277856)
print v(xbgr.mr_n68278176)
print v(xbgr.mr_n68278288)
print v(xbgr.mr_n68278608)
print v(xbgr.mr_n68278720)
print v(xbgr.mr_n68279040)
print v(xbgr.mr_n68279152)
print v(xbgr.mr_n68279472)
print v(xbgr.mr_n68279584)
print v(xbgr.mr_n68279904)
print v(xbgr.mr_n68280016)
print v(xbgr.mr_n68280336)
print v(xbgr.mr_n68280448)
print v(xbgr.mr_n68280768)
print v(xbgr.mr_n68280880)
print v(xbgr.mr_n68281200)
print v(xbgr.mr_n68281312)
print v(xbgr.mr_n68281632)
print v(xbgr.mr_n68281744)
print v(xbgr.mr_n68282064)
print v(xbgr.mr_n68282176)
print v(xbgr.mr_n68282496)
print v(xbgr.mr_n68282608)
print v(xbgr.mr_n68282928)
print v(xbgr.mr_n68283040)
print v(xbgr.mr_n68283360)
print v(xbgr.mr_n68283472)
print v(xbgr.mr_n68283792)
print v(xbgr.mr_n68283904)
print v(xbgr.mr_n68284224)
print v(xbgr.mr_n68284336)
print v(xbgr.mr_n68284656)
print v(xbgr.mr_n68284768)
print v(xbgr.mr_n68285088)
print v(xbgr.mr_n68285200)
print v(xbgr.mr_n68285520)
print v(xbgr.mr_n68285632)
print v(xbgr.mr_n68285952)
print v(xbgr.mr_n68286064)
print v(xbgr.mr_n68286384)
print v(xbgr.mr_n68286496)
print v(xbgr.mr_n68286816)
print v(xbgr.mr_n68286928)
print v(xbgr.mr_n68287248)
print v(xbgr.mr_n68287360)
print v(xbgr.mr_n68287680)
print v(xbgr.mr_n68287792)
print v(xbgr.mr_n68288112)
print v(xbgr.mr_n68288224)
print v(xbgr.mr_n68288544)
print v(xbgr.mr_n68288656)
print v(xbgr.mr_n68288976)
print v(xbgr.mr_n68289088)
print v(xbgr.mr_n68289408)
print v(xbgr.mr_n68289520)
print v(xbgr.mr_n68289840)
print v(xbgr.mr_n68289952)
print v(xbgr.mr_n68290272)
print v(xbgr.mr_n68290384)
print v(xbgr.mr_n68290704)
print v(xbgr.mr_n68290816)
print v(xbgr.mr_n68291136)
print v(xbgr.mr_n68291248)
print v(xbgr.mr_n68291568)
print v(xbgr.mr_n68291680)
print v(xbgr.mr_n68292000)
print v(xbgr.mr_n68292112)
print v(xbgr.mr_n68292432)
print v(xbgr.mr_n68292544)
print v(xbgr.mr_n68292864)
print v(xbgr.mr_n68292976)
print v(xbgr.mr_n68293296)
print v(xbgr.mr_n68293408)
print v(xbgr.mr_n68293728)
print v(xbgr.mr_n68293840)
print v(xbgr.mr_n68294160)
print v(xbgr.mr_n68294272)
print v(xbgr.mr_n68294592)
print v(xbgr.mr_n68294704)
print v(xbgr.mr_n68295024)
print v(xbgr.mr_n68295136)
print v(xbgr.mr_n68295456)
print v(xbgr.mr_n68295568)
print v(xbgr.mr_n68295888)
print v(xbgr.mr_n68296000)
print v(xbgr.mr_n68296320)
print v(xbgr.mr_n68296432)
print v(xbgr.mr_n68296752)
print v(xbgr.mr_n68296864)
print v(xbgr.mr_n68297184)
print v(xbgr.mr_n68297296)
print v(xbgr.mr_n68297616)
print v(xbgr.mr_n68297728)
print v(xbgr.mr_n68298048)
print v(xbgr.mr_n68298160)
print v(xbgr.mr_n68298480)
print v(xbgr.mr_n68298592)
print v(xbgr.mr_n68298912)
print v(xbgr.mr_n68299024)
print v(xbgr.mr_n68299344)
print v(xbgr.mr_n68299456)
print v(xbgr.mr_n68299776)
print v(xbgr.mr_n68299888)
print v(xbgr.mr_n68300208)
print v(xbgr.mr_n68300320)
print v(xbgr.mr_n68300640)
print v(xbgr.mr_n68300752)
print v(xbgr.mr_n68301072)
print v(xbgr.mr_n68301184)
print v(xbgr.mr_n68301504)
print v(xbgr.mr_n68301616)
print v(xbgr.mr_n68301936)
print v(xbgr.mr_n68302048)
print v(xbgr.mr_n68302368)
print v(xbgr.mr_n68302480)
print v(xbgr.mr_n68302800)
print v(xbgr.mr_n68302912)
print v(xbgr.mr_n68303232)
print v(xbgr.mr_n68303344)
print v(xbgr.mr_n68303664)
print v(xbgr.mr_n68303776)
print v(xbgr.mr_n68304096)
print v(xbgr.mr_n68304208)
print v(xbgr.mr_n68304528)
print v(xbgr.mr_n68304640)
print v(xbgr.mr_n68304960)
print v(xbgr.mr_n68305072)
print v(xbgr.mr_n68305392)
print v(xbgr.mr_n68305504)
print v(xbgr.mr_n68305824)
print v(xbgr.mr_n68305936)
print v(xbgr.mr_n68306256)
print v(xbgr.mr_n68306368)
print v(xbgr.mr_n68306688)
print v(xbgr.mr_n68306800)
print v(xbgr.mr_n68307120)
print v(xbgr.mr_n68307232)
print v(xbgr.mr_n68307552)
print v(xbgr.mr_n68307664)
print v(xbgr.mr_n68307984)
print v(xbgr.mr_n68308096)
print v(xbgr.mr_n68308416)
print v(xbgr.mr_n68308528)
print v(xbgr.mr_n68308848)
print v(xbgr.mr_n68308960)
print v(xbgr.mr_n68309280)
print v(xbgr.mr_n68309392)
print v(xbgr.mr_n68309712)
print v(xbgr.mr_n68309824)
print v(xbgr.mr_n68310144)
print v(xbgr.mr_n68310256)
print v(xbgr.mr_n68310576)
print v(xbgr.mr_n68310688)
print v(xbgr.mr_n68311008)
print v(xbgr.mr_n68311120)
print v(xbgr.mr_n68311440)
print v(xbgr.mr_n68311552)
print v(xbgr.mr_n68311872)
print v(xbgr.mr_n68311984)
print v(xbgr.mr_n68312304)
print v(xbgr.mr_n68312416)
print v(xbgr.mr_n68312736)
print v(xbgr.mr_n68312848)
print v(xbgr.mr_n68313168)
print v(xbgr.mr_n68313280)
print v(xbgr.mr_n68313600)
print v(xbgr.mr_n68313712)
print v(xbgr.mr_n68314032)
print v(xbgr.mr_n68314144)
print v(xbgr.mr_n68314464)
print v(xbgr.mr_n68314576)
print v(xbgr.mr_n68314896)
print v(xbgr.mr_n68315008)
print v(xbgr.mr_n68315328)
print v(xbgr.mr_n68315440)
print v(xbgr.mr_n68315760)
print v(xbgr.mr_n68315872)
print v(xbgr.mr_n68316192)
print v(xbgr.mr_n68316304)
print v(xbgr.mr_n68316624)
print v(xbgr.mr_n68316736)
print v(xbgr.mr_n68317056)
print v(xbgr.mr_n68317168)
print v(xbgr.mr_n68317488)
print v(xbgr.mr_n68317600)
print v(xbgr.mr_n68317920)
print v(xbgr.mr_n68318032)
print v(xbgr.mr_n68318352)
print v(xbgr.mr_n68318464)
print v(xbgr.mr_n68318784)
print v(xbgr.mr_n68318896)
print v(xbgr.mr_n68319216)
print v(xbgr.mr_n68319328)
print v(xbgr.mr_n68319648)
print v(xbgr.mr_n68319760)
print v(xbgr.mr_n68320080)
print v(xbgr.mr_n68320192)
print v(xbgr.mr_n68320512)
print v(xbgr.mr_n68320624)
print v(xbgr.mr_n68320944)
print v(xbgr.mr_n68321056)
print v(xbgr.mr_n68321376)
print v(xbgr.mr_n68321488)
print v(xbgr.mr_n68321808)
print v(xbgr.mr_n68321920)
print v(xbgr.mr_n68322240)
print v(xbgr.mr_n68322352)
print v(xbgr.mr_n68322672)
print v(xbgr.mr_n68322784)
print v(xbgr.mr_n68323104)
print v(xbgr.mr_n68323216)
print v(xbgr.mr_n68323536)
print v(xbgr.mr_n68323648)
print v(xbgr.mr_n68323968)
print v(xbgr.mr_n68324080)
print v(xbgr.mr_n68324400)
print v(xbgr.mr_n68324512)
print v(xbgr.mr_n68324832)
print v(xbgr.mr_n68324944)
print v(xbgr.mr_n68325264)
print v(xbgr.mr_n68325376)
print v(xbgr.mr_n68325696)
print v(xbgr.mr_n68325808)
print v(xbgr.mr_n68326128)
print v(xbgr.mr_n68326240)
print v(xbgr.mr_n68326560)
print v(xbgr.mr_n68326672)
print v(xbgr.mr_n68326992)
print v(xbgr.mr_n68327104)
print v(xbgr.mr_n68327424)
print v(xbgr.mr_n68327536)
print v(xbgr.mr_n68327856)
print v(xbgr.mr_n68327968)
print v(xbgr.mr_n68328288)
print v(xbgr.mr_n68328400)
print v(xbgr.mr_n68328720)
print v(xbgr.mr_n68328832)
print v(xbgr.mr_n68329152)
print v(xbgr.mr_n68329264)
print v(xbgr.mr_n68329584)
print v(xbgr.mr_n68329696)
print v(xbgr.mr_n68330016)
print v(xbgr.mr_n68330128)
print v(xbgr.mr_n68330448)
print v(xbgr.mr_n68330560)
print v(xbgr.mr_n68330880)
print v(xbgr.mr_n68330992)
print v(xbgr.mr_n68331312)
print v(xbgr.mr_n68331424)
print v(xbgr.mr_n68331744)
print v(xbgr.mr_n68331856)
print v(xbgr.mr_n68332176)
print v(xbgr.mr_n68332288)
print v(xbgr.mr_n68332608)
print v(xbgr.mr_n68332720)
print v(xbgr.mr_n68333040)
print v(xbgr.mr_n68333152)
print v(xbgr.mr_n68333472)
print v(xbgr.mr_n68333584)
print v(xbgr.mr_n68333904)
print v(xbgr.mr_n68334016)
print v(xbgr.mr_n68334336)
print v(xbgr.mr_n68334448)
print v(xbgr.mr_n68334768)
print v(xbgr.mr_n68334880)
print v(xbgr.mr_n68335200)
print v(xbgr.mr_n68335312)
print v(xbgr.mr_n68335632)
print v(xbgr.mr_n68335744)
print v(xbgr.mr_n68336064)
print v(xbgr.mr_n68336176)
print v(xbgr.mr_n68336496)
print v(xbgr.mr_n68336608)
print v(xbgr.mr_n68336928)
print v(xbgr.mr_n68337040)
print v(xbgr.mr_n68337360)
print v(xbgr.mr_n68337472)
print v(xbgr.mr_n68337792)
print v(xbgr.mr_n68337904)
print v(xbgr.mr_n68338224)
print v(xbgr.mr_n68338336)
print v(xbgr.mr_n68338656)
print v(xbgr.mr_n68338768)
print v(xbgr.mr_n68339088)
print v(xbgr.mr_n68339200)
print v(xbgr.mr_n68339520)
print v(xbgr.mr_n68339632)
print v(xbgr.mr_n68339952)
print v(xbgr.mr_n68340064)
print v(xbgr.mr_n68340384)
print v(xbgr.mr_n68340496)
print v(xbgr.mr_n68340816)
print v(xbgr.mr_n68340928)
print v(xbgr.mr_n68341248)
print v(xbgr.mr_n68341360)
print v(xbgr.mr_n68341680)
print v(xbgr.mr_n68341792)
print v(xbgr.mr_n68342112)
print v(xbgr.mr_n68342224)
print v(xbgr.mr_n68342544)
print v(xbgr.mr_n68342656)
print v(xbgr.mr_n68342976)
print v(xbgr.mr_n68343088)
print v(xbgr.mr_n68343408)
print v(xbgr.mr_n68343520)
print v(xbgr.mr_n68343840)
print v(xbgr.mr_n68343952)
print v(xbgr.mr_n68344272)
print v(xbgr.mr_n68344384)
print v(xbgr.mr_n68344704)
print v(xbgr.mr_n68344816)
print v(xbgr.mr_n68345136)
print v(xbgr.mr_n68345248)
print v(xbgr.mr_n68345568)
print v(xbgr.mr_n68345680)
print v(xbgr.mr_n68346000)
print v(xbgr.mr_n68346112)
print v(xbgr.mr_n68346432)
print v(xbgr.mr_n68346544)
print v(xbgr.mr_n68346864)
print v(xbgr.mr_n68346976)
print v(xbgr.mr_n68347296)
print v(xbgr.mr_n68347408)
print v(xbgr.mr_n68347728)
print v(xbgr.mr_n68347840)
print v(xbgr.mr_n68348160)
print v(xbgr.mr_n68348272)
print v(xbgr.mr_n68348592)
print v(xbgr.mr_n68348704)
print v(xbgr.mr_n68349024)
print v(xbgr.mr_n68349136)
print v(xbgr.mr_n68349456)
print v(xbgr.mr_n68349568)
print v(xbgr.mr_n68349888)
print v(xbgr.mr_n68350000)
print v(xbgr.mr_n68350320)
print v(xbgr.mr_n68350432)
print v(xbgr.mr_n68350752)
print v(xbgr.mr_n68350864)
print v(xbgr.mr_n68351184)
print v(xbgr.mr_n68351296)
print v(xbgr.mr_n68351616)
print v(xbgr.mr_n68351728)
print v(xbgr.mr_n68352048)
print v(xbgr.mr_n68352160)
print v(xbgr.mr_n68352480)
print v(xbgr.mr_n68352592)
print v(xbgr.mr_n68352912)
print v(xbgr.mr_n68353024)
print v(xbgr.mr_n68353344)
print v(xbgr.mr_n68353456)
print v(xbgr.mr_n68353776)
print v(xbgr.mr_n68353888)
print v(xbgr.mr_n68354208)
print v(xbgr.mr_n68354320)
print v(xbgr.mr_n68354640)
print v(xbgr.mr_n68354752)
print v(xbgr.mr_n68355072)
print v(xbgr.mr_n68355184)
print v(xbgr.mr_n68355504)
print v(xbgr.mr_n68355616)
print v(xbgr.mr_n68355936)
print v(xbgr.mr_n68356048)
print v(xbgr.mr_n68356368)
print v(xbgr.mr_n68356480)
print v(xbgr.mr_n68356800)
print v(xbgr.mr_n68356912)
print v(xbgr.mr_n68357232)
print v(xbgr.mr_n68357344)
print v(xbgr.mr_n68357664)
print v(xbgr.mr_n68357776)
print v(xbgr.mr_n68358096)
print v(xbgr.mr_n68358208)
print v(xbgr.mr_n68358528)
print v(xbgr.mr_n68358640)
print v(xbgr.mr_n68358960)
print v(xbgr.mr_n68359072)
print v(xbgr.mr_n68359392)
print v(xbgr.mr_n68359504)
print v(xbgr.mr_n68359824)
print v(xbgr.mr_n68359936)
print v(xbgr.mr_n68360256)
print v(xbgr.mr_n68360368)
print v(xbgr.mr_n68360688)
print v(xbgr.mr_n68360800)
print v(xbgr.mr_n68361120)
print v(xbgr.mr_n68361232)
print v(xbgr.mr_n68361552)
print v(xbgr.mr_n68361664)
print v(xbgr.mr_n68361984)
print v(xbgr.mr_n68362096)
print v(xbgr.mr_n68362416)
print v(xbgr.mr_n68362528)
print v(xbgr.mr_n68362848)
print v(xbgr.mr_n68362960)
print v(xbgr.mr_n68363280)
print v(xbgr.mr_n68363392)
print v(xbgr.mr_n68363712)
print v(xbgr.mr_n68363824)
print v(xbgr.mr_n68364144)
print v(xbgr.mr_n68364256)
print v(xbgr.mr_n68364576)
print v(xbgr.mr_n68364688)
print v(xbgr.mr_n68365008)
print v(xbgr.mr_n68365120)
print v(xbgr.mr_n68365440)
print v(xbgr.mr_n68365552)
print v(xbgr.mr_n68365872)
print v(xbgr.mr_n68365984)
print v(xbgr.mr_n68366304)
print v(xbgr.mr_n68366416)
print v(xbgr.mr_n68366736)
print v(xbgr.mr_n68366848)
print v(xbgr.mr_n68367168)
print v(xbgr.mr_n68367280)
print v(xbgr.mr_n68367600)
print v(xbgr.mr_n68367712)
print v(xbgr.mr_n68368032)
print v(xbgr.mr_n68368144)
print v(xbgr.mr_n68368464)
print v(xbgr.mr_n68368576)
print v(xbgr.mr_n68368896)
print v(xbgr.mr_n68369008)
print v(xbgr.mr_n68369328)
print v(xbgr.mr_n68369440)
print v(xbgr.mr_n68369760)
print v(xbgr.mr_n68369872)
print v(xbgr.mr_n68370192)
print v(xbgr.mr_n68370304)
print v(xbgr.mr_n68370624)
print v(xbgr.mr_n68370736)
print v(xbgr.mr_n68371056)
print v(xbgr.mr_n68371168)
print v(xbgr.mr_n68371488)
print v(xbgr.mr_n68371600)
print v(xbgr.mr_n68371920)
print v(xbgr.mr_n68372032)
print v(xbgr.mr_n68372352)
print v(xbgr.mr_n68372464)
print v(xbgr.mr_n68372784)
print v(xbgr.mr_n68372896)
print v(xbgr.mr_n68373216)
print v(xbgr.mr_n68373328)
print v(xbgr.mr_n68373648)
print v(xbgr.mr_n68373760)
print v(xbgr.mr_n68374080)
print v(xbgr.mr_n68374192)
print v(xbgr.mr_n68374512)
print v(xbgr.mr_n68374624)
print v(xbgr.mr_n68374944)
print v(xbgr.mr_n68375056)
print v(xbgr.mr_n68375376)
print v(xbgr.mr_n68375488)
print v(xbgr.mr_n68375808)
print v(xbgr.mr_n68375920)
print v(xbgr.mr_n68376240)
print v(xbgr.mr_n68376352)
print v(xbgr.mr_n68376672)
print v(xbgr.mr_n68376784)
print v(xbgr.mr_n68377104)
print v(xbgr.mr_n68377216)
print v(xbgr.mr_n68377536)
print v(xbgr.mr_n68377648)
print v(xbgr.mr_n68377968)
print v(xbgr.mr_n68378080)
print v(xbgr.mr_n68378400)
print v(xbgr.mr_n68378512)
print v(xbgr.mr_n68378832)
print v(xbgr.mr_n68378944)
print v(xbgr.mr_n68379264)
print v(xbgr.mr_n68379376)
print v(xbgr.mr_n68379696)
print v(xbgr.mr_n68379808)
print v(xbgr.mr_n68380128)
print v(xbgr.mr_n68380240)
print v(xbgr.mr_n68380560)
print v(xbgr.mr_n68380672)
print v(xbgr.mr_n68380992)
print v(xbgr.mr_n68381104)
print v(xbgr.mr_n68381424)
print v(xbgr.mr_n68381536)
print v(xbgr.mr_n68381856)
print v(xbgr.mr_n68381968)
print v(xbgr.mr_n68382288)
print v(xbgr.mr_n68382400)
print v(xbgr.mr_n68382720)
print v(xbgr.mr_n68382832)
print v(xbgr.mr_n68383152)
print v(xbgr.mr_n68383264)
print v(xbgr.mr_n68383584)
print v(xbgr.mr_n68383696)
print v(xbgr.mr_n68384016)
print v(xbgr.mr_n68384128)
print v(xbgr.mr_n68384448)
print v(xbgr.mr_n68384560)
print v(xbgr.mr_n68384880)
print v(xbgr.mr_n68384992)
print v(xbgr.mr_n68385312)
print v(xbgr.mr_n68385424)
print v(xbgr.mr_n68385744)
print v(xbgr.mr_n68385856)
print v(xbgr.mr_n68386176)
print v(xbgr.mr_n68386288)
print v(xbgr.mr_n68386608)
print v(xbgr.mr_n68386720)
print v(xbgr.mr_n68387040)
print v(xbgr.mr_n68387152)
print v(xbgr.mr_n68387472)
print v(xbgr.mr_n68387584)
print v(xbgr.mr_n68387904)
print v(xbgr.mr_n68388016)
print v(xbgr.mr_n68388336)
print v(xbgr.mr_n68388448)
print v(xbgr.mr_n68388768)
print v(xbgr.mr_n68388880)
print v(xbgr.mr_n68389200)
print v(xbgr.mr_n68389312)
print v(xbgr.mr_n68389632)
print v(xbgr.mr_n68389744)
print v(xbgr.mr_n68390064)
print v(xbgr.mr_n68390176)
print v(xbgr.mr_n68390496)
print v(xbgr.mr_n68390608)
print v(xbgr.mr_n68390928)
print v(xbgr.mr_n68391040)
print v(xbgr.mr_n68391360)
print v(xbgr.mr_n68391472)
print v(xbgr.mr_n68391792)
print v(xbgr.mr_n68391904)
print v(xbgr.mr_n68392224)
print v(xbgr.mr_n68392336)
print v(xbgr.mr_n68392656)
print v(xbgr.mr_n68392768)
print v(xbgr.mr_n68393088)
print v(xbgr.mr_n68393200)
print v(xbgr.mr_n68393520)
print v(xbgr.mr_n68393632)
print v(xbgr.mr_n68393952)
print v(xbgr.mr_n68394064)
print v(xbgr.mr_n68394384)
print v(xbgr.mr_n68394496)
print v(xbgr.mr_n68394816)
print v(xbgr.mr_n68394928)
print v(xbgr.mr_n68395248)
print v(xbgr.mr_n68395360)
print v(xbgr.mr_n68395680)
print v(xbgr.mr_n68395792)
print v(xbgr.mr_n68396112)
print v(xbgr.mr_n68396224)
print v(xbgr.mr_n68396544)
print v(xbgr.mr_n68396656)
print v(xbgr.mr_n68396976)
print v(xbgr.mr_n68397088)
print v(xbgr.mr_n68397408)
print v(xbgr.mr_n68397520)
print v(xbgr.mr_n68397840)
print v(xbgr.mr_n68397952)
print v(xbgr.mr_n68398272)
print v(xbgr.mr_n68398384)
print v(xbgr.mr_n68398704)
print v(xbgr.mr_n68398816)
print v(xbgr.mr_n68399136)
print v(xbgr.mr_n68399248)
print v(xbgr.mr_n68399568)
print v(xbgr.mr_n68399680)
print v(xbgr.mr_n68400000)
print v(xbgr.mr_n68400112)
print v(xbgr.mr_n68400432)
print v(xbgr.mr_n68400544)
print v(xbgr.mr_n68400864)
print v(xbgr.mr_n68400976)
print v(xbgr.mr_n68401296)
print v(xbgr.mr_n68401408)
print v(xbgr.mr_n68401728)
print v(xbgr.mr_n68401840)
print v(xbgr.mr_n68402160)
print v(xbgr.mr_n68402272)
print v(xbgr.mr_n68402592)
print v(xbgr.mr_n68402704)
print v(xbgr.mr_n68403024)
print v(xbgr.mr_n68403136)
print v(xbgr.mr_n68403456)
print v(xbgr.mr_n68403568)
print v(xbgr.mr_n68403888)
print v(xbgr.mr_n68404000)
print v(xbgr.mr_n68404320)
print v(xbgr.mr_n68404432)
print v(xbgr.mr_n68404752)
print v(xbgr.mr_n68404864)
print v(xbgr.mr_n68405184)
print v(xbgr.mr_n68405296)
print v(xbgr.mr_n68405616)
print v(xbgr.mr_n68405728)
print v(xbgr.mr_n68406048)
print v(xbgr.mr_n68406160)
print v(xbgr.mr_n68406480)
print v(xbgr.mr_n68406592)
print v(xbgr.mr_n68406912)
print v(xbgr.mr_n68407024)
print v(xbgr.mr_n68407344)
print v(xbgr.mr_n68407456)
print v(xbgr.mr_n68407776)
print v(xbgr.mr_n68407888)
print v(xbgr.mr_n68408208)
print v(xbgr.mr_n68408320)
print v(xbgr.mr_n68408640)
print v(xbgr.mr_n68408752)
print v(xbgr.mr_n68409072)
print v(xbgr.mr_n68409184)
print v(xbgr.mr_n68409504)
print v(xbgr.mr_n68409616)
print v(xbgr.mr_n68409936)
print v(xbgr.mr_n68410048)
print v(xbgr.mr_n68410368)
print v(xbgr.mr_n68410480)
print v(xbgr.mr_n68410800)
print v(xbgr.mr_n68410912)
print v(xbgr.mr_n68411232)
print v(xbgr.mr_n68411344)
print v(xbgr.mr_n68411664)
print v(xbgr.mr_n68411776)
print v(xbgr.mr_n68412096)
print v(xbgr.mr_n68412208)
print v(xbgr.mr_n68412528)
print v(xbgr.mr_n68412640)
print v(xbgr.mr_n68412960)
print v(xbgr.mr_n68413072)
print v(xbgr.mr_n68413392)
print v(xbgr.mr_n68413504)
print v(xbgr.mr_n68413824)
print v(xbgr.mr_n68413936)
print v(xbgr.mr_n68414256)
print v(xbgr.mr_n68414368)
print v(xbgr.mr_n68414688)
print v(xbgr.mr_n68414800)
print v(xbgr.mr_n68415120)
print v(xbgr.mr_n68415232)
print v(xbgr.mr_n68415552)
print v(xbgr.mr_n68415664)
print v(xbgr.mr_n68415984)
print v(xbgr.mr_n68416096)
print v(xbgr.mr_n68416416)
print v(xbgr.mr_n68416528)
print v(xbgr.mr_n68416848)
print v(xbgr.mr_n68416960)
print v(xbgr.mr_n68417280)
print v(xbgr.mr_n68417392)
print v(xbgr.mr_n68417712)
print v(xbgr.mr_n68417824)
print v(xbgr.mr_n68418144)
print v(xbgr.mr_n68418256)
print v(xbgr.mr_n68418576)
print v(xbgr.mr_n68418688)
print v(xbgr.mr_n68419008)
print v(xbgr.mr_n68419120)
print v(xbgr.mr_n68419440)
print v(xbgr.mr_n68419552)
print v(xbgr.mr_n68419872)
print v(xbgr.mr_n68419984)
print v(xbgr.mr_n68420304)
print v(xbgr.mr_n68420416)
print v(xbgr.mr_n68420736)
print v(xbgr.mr_n68420848)
print v(xbgr.mr_n68421168)
print v(xbgr.mr_n68421280)
print v(xbgr.mr_n68421600)
print v(xbgr.mr_n68421712)
print v(xbgr.mr_n68422032)
print v(xbgr.mr_n68422144)
print v(xbgr.mr_n68422464)
print v(xbgr.mr_n68422576)
print v(xbgr.mr_n68422896)
print v(xbgr.mr_n68423008)
print v(xbgr.mr_n68423328)
print v(xbgr.mr_n68423440)
print v(xbgr.mr_n68423760)
print v(xbgr.mr_n68423872)
print v(xbgr.mr_n68424192)
print v(xbgr.mr_n68424304)
print v(xbgr.mr_n68424624)
print v(xbgr.mr_n68424736)
print v(xbgr.mr_n68425056)
print v(xbgr.mr_n68425168)
print v(xbgr.mr_n68425488)
print v(xbgr.mr_n68425600)
print v(xbgr.mr_n68425920)
print v(xbgr.mr_n68426032)
print v(xbgr.mr_n68426352)
print v(xbgr.mr_n68426464)
print v(xbgr.mr_n68426784)
print v(xbgr.mr_n68426896)
print v(xbgr.mr_n68427216)
print v(xbgr.mr_n68427328)
print v(xbgr.mr_n68427648)
print v(xbgr.mr_n68427760)
print v(xbgr.mr_n68428080)
print v(xbgr.mr_n68428192)
print v(xbgr.mr_n68428512)
print v(xbgr.mr_n68428624)
print v(xbgr.mr_n68428944)
print v(xbgr.mr_n68429056)
print v(xbgr.mr_n68429376)
print v(xbgr.mr_n68429488)
print v(xbgr.mr_n68429808)
print v(xbgr.mr_n68429920)
print v(xbgr.mr_n68430240)
print v(xbgr.mr_n68430352)
print v(xbgr.mr_n68430672)
print v(xbgr.mr_n68430784)
print v(xbgr.mr_n68431104)
print v(xbgr.mr_n68431216)
print v(xbgr.mr_n68431536)
print v(xbgr.mr_n68431648)
print v(xbgr.mr_n68431968)
print v(xbgr.mr_n68432080)
print v(xbgr.mr_n68432400)
print v(xbgr.mr_n68432512)
print v(xbgr.mr_n68432832)
print v(xbgr.mr_n68432944)
print v(xbgr.mr_n68433264)
print v(xbgr.mr_n68433376)
print v(xbgr.mr_n68433696)
print v(xbgr.mr_n68433808)
print v(xbgr.mr_n68434128)
print v(xbgr.mr_n68434240)
print v(xbgr.mr_n68434560)
print v(xbgr.mr_n68434672)
print v(xbgr.mr_n68434992)
print v(xbgr.mr_n68435104)
print v(xbgr.mr_n68435424)
print v(xbgr.mr_n68435536)
print v(xbgr.mr_n68435856)
print v(xbgr.mr_n68435968)
print v(xbgr.mr_n68436288)
print v(xbgr.mr_n68436400)
print v(xbgr.mr_n68436720)
print v(xbgr.mr_n68436832)
print v(xbgr.mr_n68437152)
print v(xbgr.mr_n68437264)
print v(xbgr.mr_n68437584)
print v(xbgr.mr_n68437696)
print v(xbgr.mr_n68438016)
print v(xbgr.mr_n68438128)
print v(xbgr.mr_n68438448)
print v(xbgr.mr_n68438560)
print v(xbgr.mr_n68438880)
print v(xbgr.mr_n68438992)
print v(xbgr.mr_n68439312)
print v(xbgr.mr_n68439424)
print v(xbgr.mr_n68439744)
print v(xbgr.mr_n68439856)
print v(xbgr.mr_n68440176)
print v(xbgr.mr_n68440288)
print v(xbgr.mr_n68440608)
print v(xbgr.mr_n68440720)
print v(xbgr.mr_n68441040)
print v(xbgr.mr_n68441152)
print v(xbgr.mr_n68441472)
print v(xbgr.mr_n68441584)
print v(xbgr.mr_n68441904)
print v(xbgr.mr_n68442016)
print v(xbgr.mr_n68442336)
print v(xbgr.mr_n68442448)
print v(xbgr.mr_n68442768)
print v(xbgr.mr_n68442880)
print v(xbgr.mr_n68443200)
print v(xbgr.mr_n68443312)
print v(xbgr.mr_n68443632)
print v(xbgr.mr_n68443744)
print v(xbgr.mr_n68444064)
print v(xbgr.mr_n68444176)
print v(xbgr.mr_n68444496)
print v(xbgr.mr_n68444608)
print v(xbgr.mr_n68444928)
print v(xbgr.mr_n68445040)
print v(xbgr.mr_n68445360)
print v(xbgr.mr_n68445472)
print v(xbgr.mr_n68445792)
print v(xbgr.mr_n68445904)
print v(xbgr.mr_n68446224)
print v(xbgr.mr_n68446336)
print v(xbgr.mr_n68446656)
print v(xbgr.mr_n68446768)
print v(xbgr.mr_n68447088)
print v(xbgr.mr_n68447200)
print v(xbgr.mr_n68447520)
print v(xbgr.mr_n68447632)
print v(xbgr.mr_n68447952)
print v(xbgr.mr_n68448064)
print v(xbgr.mr_n68448384)
print v(xbgr.mr_n68448496)
print v(xbgr.mr_n68448816)
print v(xbgr.mr_n68448928)
print v(xbgr.mr_n68449248)
print v(xbgr.mr_n68449360)
print v(xbgr.mr_n68449680)
print v(xbgr.mr_n68449792)
print v(xbgr.mr_n68450112)
print v(xbgr.mr_n68450224)
print v(xbgr.mr_n68450544)
print v(xbgr.mr_n68450656)
print v(xbgr.mr_n68450976)
print v(xbgr.mr_n68451088)
print v(xbgr.mr_n68451408)
print v(xbgr.mr_n68451520)
print v(xbgr.mr_n68451840)
print v(xbgr.mr_n68451952)
print v(xbgr.mr_n68452272)
print v(xbgr.mr_n68452384)
print v(xbgr.mr_n68452704)
print v(xbgr.mr_n68452816)
print v(xbgr.mr_n68453136)
print v(xbgr.mr_n68453248)
print v(xbgr.mr_n68453568)
print v(xbgr.mr_n68453680)
print v(xbgr.mr_n68454000)
print v(xbgr.mr_n68454112)
print v(xbgr.mr_n68454432)
print v(xbgr.mr_n68454544)
print v(xbgr.mr_n68454864)
print v(xbgr.mr_n68454976)
print v(xbgr.mr_n68455296)
print v(xbgr.mr_n68455408)
print v(xbgr.mr_n68455728)
print v(xbgr.mr_n68455840)
print v(xbgr.mr_n68456160)
print v(xbgr.mr_n68456272)
print v(xbgr.mr_n68456592)
print v(xbgr.mr_n68456704)
print v(xbgr.mr_n68457024)
print v(xbgr.mr_n68457136)
print v(xbgr.mr_n68457456)
print v(xbgr.mr_n68457568)
print v(xbgr.mr_n68457888)
print v(xbgr.mr_n68458000)
print v(xbgr.mr_n68458320)
print v(xbgr.mr_n68458432)
print v(xbgr.mr_n68458752)
print v(xbgr.mr_n68458864)
print v(xbgr.mr_n68459184)
print v(xbgr.mr_n68459296)
print v(xbgr.mr_n68459616)
print v(xbgr.mr_n68459728)
print v(xbgr.mr_n68460048)
print v(xbgr.mr_n68460160)
print v(xbgr.mr_n68460480)
print v(xbgr.mr_n68460592)
print v(xbgr.mr_n68460912)
print v(xbgr.mr_n68461024)
print v(xbgr.mr_n68461344)
print v(xbgr.mr_n68461456)
print v(xbgr.mr_n68461776)
print v(xbgr.mr_n68461888)
print v(xbgr.mr_n68462208)
print v(xbgr.mr_n68462320)
print v(xbgr.mr_n68462640)
print v(xbgr.mr_n68462752)
print v(xbgr.mr_n68463072)
print v(xbgr.mr_n68463184)
print v(xbgr.mr_n68463504)
print v(xbgr.mr_n68463616)
print v(xbgr.mr_n68463936)
print v(xbgr.mr_n68464048)
print v(xbgr.mr_n68464368)
print v(xbgr.mr_n68464480)
print v(xbgr.mr_n68464800)
print v(xbgr.mr_n68464912)
print v(xbgr.mr_n68465232)
print v(xbgr.mr_n68465344)
print v(xbgr.mr_n68465664)
print v(xbgr.mr_n68465776)
print v(xbgr.mr_n68466096)
print v(xbgr.mr_n68466208)
print v(xbgr.mr_n68466528)
print v(xbgr.mr_n68466640)
print v(xbgr.mr_n68466960)
print v(xbgr.mr_n68467072)
print v(xbgr.mr_n68467392)
print v(xbgr.mr_n68467504)
print v(xbgr.mr_n68467824)
print v(xbgr.mr_n68467936)
print v(xbgr.mr_n68468256)
print v(xbgr.mr_n68468368)
print v(xbgr.mr_n68468688)
print v(xbgr.mr_n68468800)
print v(xbgr.mr_n68469120)
print v(xbgr.mr_n68469232)
print v(xbgr.mr_n68469552)
print v(xbgr.mr_n68469664)
print v(xbgr.mr_n68469984)
print v(xbgr.mr_n68470096)
print v(xbgr.mr_n68470416)
print v(xbgr.mr_n68470528)
print v(xbgr.mr_n68470848)
print v(xbgr.mr_n68470960)
print v(xbgr.mr_n68471280)
print v(xbgr.mr_n68471392)
print v(xbgr.mr_n68471712)
print v(xbgr.mr_n68471824)
print v(xbgr.mr_n68472144)
print v(xbgr.mr_n68472256)
print v(xbgr.mr_n68472576)
print v(xbgr.mr_n68472688)
print v(xbgr.mr_n68473008)
print v(xbgr.mr_n68473120)
print v(xbgr.mr_n68473440)
print v(xbgr.mr_n68473552)
print v(xbgr.mr_n68473872)
print v(xbgr.mr_n68473984)
print v(xbgr.mr_n68474304)
print v(xbgr.mr_n68474416)
print v(xbgr.mr_n68474736)
print v(xbgr.mr_n68474848)
print v(xbgr.mr_n68475168)
print v(xbgr.mr_n68475280)
print v(xbgr.mr_n68475600)
print v(xbgr.mr_n68475712)
print v(xbgr.mr_n68476032)
print v(xbgr.mr_n68476144)
print v(xbgr.mr_n68476464)
print v(xbgr.mr_n68476576)
print v(xbgr.mr_n68476896)
print v(xbgr.mr_n68477008)
print v(xbgr.mr_n68477328)
print v(xbgr.mr_n68477440)
print v(xbgr.mr_n68477760)
print v(xbgr.mr_n68477872)
print v(xbgr.mr_n68478192)
print v(xbgr.mr_n68478304)
print v(xbgr.mr_n68478624)
print v(xbgr.mr_n68478736)
print v(xbgr.mr_n68479056)
print v(xbgr.mr_n68479168)
print v(xbgr.mr_n68479488)
print v(xbgr.mr_n68479600)
print v(xbgr.mr_n68479920)
print v(xbgr.mr_n68480032)
print v(xbgr.mr_n68480352)
print v(xbgr.mr_n68480464)
print v(xbgr.mr_n68480784)
print v(xbgr.mr_n68480896)
print v(xbgr.mr_n68481216)
print v(xbgr.mr_n68481328)
print v(xbgr.mr_n68481648)
print v(xbgr.mr_n68481760)
print v(xbgr.mr_n68482080)
print v(xbgr.mr_n68482192)
print v(xbgr.mr_n68482512)
print v(xbgr.mr_n68482624)
print v(xbgr.mr_n68482944)
print v(xbgr.mr_n68483056)
print v(xbgr.mr_n68483376)
print v(xbgr.mr_n68483488)
print v(xbgr.mr_n68483808)
print v(xbgr.mr_n68483920)
print v(xbgr.mr_n68484240)
print v(xbgr.mr_n68484352)
print v(xbgr.mr_n68484672)
print v(xbgr.mr_n68484784)
print v(xbgr.mr_n68485104)
print v(xbgr.mr_n68485216)
print v(xbgr.mr_n68485536)
print v(xbgr.mr_n68485648)
print v(xbgr.mr_n68485968)
print v(xbgr.mr_n68486080)
print v(xbgr.mr_n68486400)
print v(xbgr.mr_n68486512)
print v(xbgr.mr_n68486832)
print v(xbgr.mr_n68486944)
print v(xbgr.mr_n68487264)
print v(xbgr.mr_n68487376)
print v(xbgr.mr_n68487696)
print v(xbgr.mr_n68487808)
print v(xbgr.mr_n68488128)
print v(xbgr.mr_n68488240)
print v(xbgr.mr_n68488560)
print v(xbgr.mr_n68488672)
print v(xbgr.mr_n68488992)
print v(xbgr.mr_n68489104)
print v(xbgr.mr_n68489424)
print v(xbgr.mr_n68489536)
print v(xbgr.mr_n68489856)
print v(xbgr.mr_n68489968)
print v(xbgr.mr_n68490288)
print v(xbgr.mr_n68490400)
print v(xbgr.mr_n68490720)
print v(xbgr.mr_n68490832)
print v(xbgr.mr_n68491152)
print v(xbgr.mr_n68491264)
print v(xbgr.mr_n68491584)
print v(xbgr.mr_n68491696)
print v(xbgr.mr_n68492016)
print v(xbgr.mr_n68492128)
print v(xbgr.mr_n68492448)
print v(xbgr.mr_n68492560)
print v(xbgr.mr_n68492880)
print v(xbgr.mr_n68492992)
print v(xbgr.mr_n68493312)
print v(xbgr.mr_n68493424)
print v(xbgr.mr_n68493744)
print v(xbgr.mr_n68493856)
print v(xbgr.mr_n68494176)
print v(xbgr.mr_n68494288)
print v(xbgr.mr_n68494608)
print v(xbgr.mr_n68494720)
print v(xbgr.mr_n68495040)
print v(xbgr.mr_n68495152)
print v(xbgr.mr_n68495472)
print v(xbgr.mr_n68495584)
print v(xbgr.mr_n68495904)
print v(xbgr.mr_n68496016)
print v(xbgr.mr_n68496336)
print v(xbgr.mr_n68496448)
print v(xbgr.mr_n68496768)
print v(xbgr.mr_n68496880)
print v(xbgr.mr_n68497200)
print v(xbgr.mr_n68497312)
print v(xbgr.mr_n68497632)
print v(xbgr.mr_n68497744)
print v(xbgr.mr_n68498064)
print v(xbgr.mr_n68498176)
print v(xbgr.mr_n68498496)
print v(xbgr.mr_n68498608)
print v(xbgr.mr_n68498928)
print v(xbgr.mr_n68499040)
print v(xbgr.mr_n68499360)
print v(xbgr.mr_n68499472)
print v(xbgr.mr_n68499792)
print v(xbgr.mr_n68499904)
print v(xbgr.mr_n68500224)
print v(xbgr.mr_n68500336)
print v(xbgr.mr_n68500656)
print v(xbgr.mr_n68500768)
print v(xbgr.mr_n68501088)
print v(xbgr.mr_n68501200)
print v(xbgr.mr_n68501520)
print v(xbgr.mr_n68501632)
print v(xbgr.mr_n68501952)
print v(xbgr.mr_n68502064)
print v(xbgr.mr_n68502384)
print v(xbgr.mr_n68502496)
print v(xbgr.mr_n68502816)
print v(xbgr.mr_n68502928)
print v(xbgr.mr_n68503248)
print v(xbgr.mr_n68503360)
print v(xbgr.mr_n68503680)
print v(xbgr.mr_n68503792)
print v(xbgr.mr_n68504112)
print v(xbgr.mr_n68504224)
print v(xbgr.mr_n68504544)
print v(xbgr.mr_n68504656)
print v(xbgr.mr_n68504976)
print v(xbgr.mr_n68505088)
print v(xbgr.mr_n68505408)
print v(xbgr.mr_n68505520)
print v(xbgr.mr_n68505840)
print v(xbgr.mr_n68505952)
print v(xbgr.mr_n68506272)
print v(xbgr.mr_n68506384)
print v(xbgr.mr_n68506704)
print v(xbgr.mr_n68506816)
print v(xbgr.mr_n68507136)
print v(xbgr.mr_n68507248)
print v(xbgr.mr_n68507568)
print v(xbgr.mr_n68507680)
print v(xbgr.mr_n68508000)
print v(xbgr.mr_n68508112)
print v(xbgr.mr_n68508432)
print v(xbgr.mr_n68508544)
print v(xbgr.mr_n68508864)
print v(xbgr.mr_n68508976)
print v(xbgr.mr_n68509296)
print v(xbgr.mr_n68509408)
print v(xbgr.mr_n68509728)
print v(xbgr.mr_n68509840)
print v(xbgr.mr_n68510160)
print v(xbgr.mr_n68510272)
print v(xbgr.mr_n68510592)
print v(xbgr.mr_n68510704)
print v(xbgr.mr_n68511024)
print v(xbgr.mr_n68511136)
print v(xbgr.mr_n68511456)
print v(xbgr.mr_n68511568)
print v(xbgr.mr_n68511888)
print v(xbgr.mr_n68512000)
print v(xbgr.mr_n68512320)
print v(xbgr.mr_n68512432)
print v(xbgr.mr_n68512752)
print v(xbgr.mr_n68512864)
print v(xbgr.mr_n68513184)
print v(xbgr.mr_n68513296)
print v(xbgr.mr_n68513616)
print v(xbgr.mr_n68513728)
print v(xbgr.mr_n68514048)
print v(xbgr.mr_n68514160)
print v(xbgr.mr_n68514480)
print v(xbgr.mr_n68514592)
print v(xbgr.mr_n68514912)
print v(xbgr.mr_n68515024)
print v(xbgr.mr_n68515344)
print v(xbgr.mr_n68515456)
print v(xbgr.mr_n68515776)
print v(xbgr.mr_n68515888)
print v(xbgr.mr_n68516208)
print v(xbgr.mr_n68516320)
print v(xbgr.mr_n68516640)
print v(xbgr.mr_n68516752)
print v(xbgr.mr_n68517072)
print v(xbgr.mr_n68517184)
print v(xbgr.mr_n68517504)
print v(xbgr.mr_n68517616)
print v(xbgr.mr_n68517936)
print v(xbgr.mr_n68518048)
print v(xbgr.mr_n68518368)
print v(xbgr.mr_n68518480)
print v(xbgr.mr_n68518800)
print v(xbgr.mr_n68518912)
print v(xbgr.mr_n68519232)
print v(xbgr.mr_n68519344)
print v(xbgr.mr_n68519664)
print v(xbgr.mr_n68519776)
print v(xbgr.mr_n68520096)
print v(xbgr.mr_n68520208)
print v(xbgr.mr_n68520528)
print v(xbgr.mr_n68520640)
print v(xbgr.mr_n68520960)
print v(xbgr.mr_n68521072)
print v(xbgr.mr_n68521392)
print v(xbgr.mr_n68521504)
print v(xbgr.mr_n68521824)
print v(xbgr.mr_n68521936)
print v(xbgr.mr_n68522256)
print v(xbgr.mr_n68522368)
print v(xbgr.mr_n68522688)
print v(xbgr.mr_n68522800)
print v(xbgr.mr_n68523120)
print v(xbgr.mr_n68523232)
print v(xbgr.mr_n68523552)
print v(xbgr.mr_n68523664)
print v(xbgr.mr_n68523984)
print v(xbgr.mr_n68524096)
print v(xbgr.mr_n68524416)
print v(xbgr.mr_n68524528)
print v(xbgr.mr_n68524848)
print v(xbgr.mr_n68524960)
print v(xbgr.mr_n68525280)
print v(xbgr.mr_n68525392)
print v(xbgr.mr_n68525712)
print v(xbgr.mr_n68525824)
print v(xbgr.mr_n68526144)
print v(xbgr.mr_n68526256)
print v(xbgr.mr_n68526576)
print v(xbgr.mr_n68526688)
print v(xbgr.mr_n68527008)
print v(xbgr.mr_n68527120)
print v(xbgr.mr_n68527440)
print v(xbgr.mr_n68527552)
print v(xbgr.mr_n68527872)
print v(xbgr.mr_n68527984)
print v(xbgr.mr_n68528304)
print v(xbgr.mr_n68528416)
print v(xbgr.mr_n68528736)
print v(xbgr.mr_n68528848)
print v(xbgr.mr_n68529168)
print v(xbgr.mr_n68529280)
print v(xbgr.mr_n68529600)
print v(xbgr.mr_n68529712)
print v(xbgr.mr_n68530032)
print v(xbgr.mr_n68530144)
print v(xbgr.mr_n68530464)
print v(xbgr.mr_n68530576)
print v(xbgr.mr_n68530896)
print v(xbgr.mr_n68531008)
print v(xbgr.mr_n68531328)
print v(xbgr.mr_n68531440)
print v(xbgr.mr_n68531760)
print v(xbgr.mr_n68531872)
print v(xbgr.mr_n68532192)
print v(xbgr.mr_n68532304)
print v(xbgr.mr_n68532624)
print v(xbgr.mr_n68532736)
print v(xbgr.mr_n68533056)
print v(xbgr.mr_n68533168)
print v(xbgr.mr_n68533488)
print v(xbgr.mr_n68533600)
print v(xbgr.mr_n68533920)
print v(xbgr.mr_n68534032)
print v(xbgr.mr_n68534352)
print v(xbgr.mr_n68534464)
print v(xbgr.mr_n68534784)
print v(xbgr.mr_n68534896)
print v(xbgr.mr_n68535216)
print v(xbgr.mr_n68535328)
print v(xbgr.mr_n68535648)
print v(xbgr.mr_n68535760)
print v(xbgr.mr_n68536080)
print v(xbgr.mr_n68536192)
print v(xbgr.mr_n68536512)
print v(xbgr.mr_n68536624)
print v(xbgr.mr_n68536944)
print v(xbgr.mr_n68537056)
print v(xbgr.mr_n68537376)
print v(xbgr.mr_n68537488)
print v(xbgr.mr_n68537808)
print v(xbgr.mr_n68537920)
print v(xbgr.mr_n68538240)
print v(xbgr.mr_n68538352)
print v(xbgr.mr_n68538672)
print v(xbgr.mr_n68538784)
print v(xbgr.mr_n68539104)
print v(xbgr.mr_n68539216)
print v(xbgr.mr_n68539536)
print v(xbgr.mr_n68539648)
print v(xbgr.mr_n68539968)
print v(xbgr.mr_n68540080)
print v(xbgr.mr_n68540400)
print v(xbgr.mr_n68540512)
print v(xbgr.mr_n68540832)
print v(xbgr.mr_n68540944)
print v(xbgr.mr_n68541264)
print v(xbgr.mr_n68541376)
print v(xbgr.mr_n68541696)
print v(xbgr.mr_n68541808)
print v(xbgr.mr_n68542128)
print v(xbgr.mr_n68542240)
print v(xbgr.mr_n68542560)
print v(xbgr.mr_n68542672)
print v(xbgr.mr_n68542992)
print v(xbgr.mr_n68543104)
print v(xbgr.mr_n68543424)
print v(xbgr.mr_n68543536)
print v(xbgr.mr_n68543856)
print v(xbgr.mr_n68543968)
print v(xbgr.mr_n68544288)
print v(xbgr.mr_n68544400)
print v(xbgr.mr_n68544720)
print v(xbgr.mr_n68544832)
print v(xbgr.mr_n68545152)
print v(xbgr.mr_n68545264)
print v(xbgr.mr_n68545584)
print v(xbgr.mr_n68545696)
print v(xbgr.mr_n68546016)
print v(xbgr.mr_n68546128)
print v(xbgr.mr_n68546448)
print v(xbgr.mr_n68546560)
print v(xbgr.mr_n68546880)
print v(xbgr.mr_n68546992)
print v(xbgr.mr_n68547312)
print v(xbgr.mr_n68547424)
print v(xbgr.mr_n68547744)
print v(xbgr.mr_n68547856)
print v(xbgr.mr_n68548176)
print v(xbgr.mr_n68548288)
print v(xbgr.mr_n68548608)
print v(xbgr.mr_n68548720)
print v(xbgr.mr_n68549040)
print v(xbgr.mr_n68549152)
print v(xbgr.mr_n68549472)
print v(xbgr.mr_n68549584)
print v(xbgr.mr_n68549904)
print v(xbgr.mr_n68550016)
print v(xbgr.mr_n68550336)
print v(xbgr.mr_n68550448)
print v(xbgr.mr_n68550768)
print v(xbgr.mr_n68550880)
print v(xbgr.mr_n68551200)
print v(xbgr.mr_n68551312)
print v(xbgr.mr_n68551632)
print v(xbgr.mr_n68551744)
print v(xbgr.mr_n68552064)
print v(xbgr.mr_n68552176)
print v(xbgr.mr_n68552496)
print v(xbgr.mr_n68552608)
print v(xbgr.mr_n68552928)
print v(xbgr.mr_n68553040)
print v(xbgr.mr_n68553360)
print v(xbgr.mr_n68553472)
print v(xbgr.mr_n68553792)
print v(xbgr.mr_n68553904)
print v(xbgr.mr_n68554224)
print v(xbgr.mr_n68554336)
print v(xbgr.mr_n68554656)
print v(xbgr.mr_n68554768)
print v(xbgr.mr_n68555088)
print v(xbgr.mr_n68555200)
print v(xbgr.mr_n68555520)
print v(xbgr.mr_n68555632)
print v(xbgr.mr_n68555952)
print v(xbgr.mr_n68556064)
print v(xbgr.mr_n68556384)
print v(xbgr.mr_n68556496)
print v(xbgr.mr_n68556816)
print v(xbgr.mr_n68556928)
print v(xbgr.mr_n68557248)
print v(xbgr.mr_n68557360)
print v(xbgr.mr_n68557680)
print v(xbgr.mr_n68557792)
print v(xbgr.mr_n68558112)
print v(xbgr.mr_n68558224)
print v(xbgr.mr_n68558544)
print v(xbgr.mr_n68558656)
print v(xbgr.mr_n68558976)
print v(xbgr.mr_n68559088)
print v(xbgr.mr_n68559408)
print v(xbgr.mr_n68559520)
print v(xbgr.mr_n68559840)
print v(xbgr.mr_n68559952)
print v(xbgr.mr_n68560272)
print v(xbgr.mr_n68560384)
print v(xbgr.mr_n68560704)
print v(xbgr.mr_n68560816)
print v(xbgr.mr_n68561136)
print v(xbgr.mr_n68561248)
print v(xbgr.mr_n68561568)
print v(xbgr.mr_n68561680)
print v(xbgr.mr_n68562000)
print v(xbgr.mr_n68562112)
print v(xbgr.mr_n68562432)
print v(xbgr.mr_n68562544)
print v(xbgr.mr_n68562864)
print v(xbgr.mr_n68562976)
print v(xbgr.mr_n68563296)
print v(xbgr.mr_n68563408)
print v(xbgr.mr_n68563728)
print v(xbgr.mr_n68563840)
print v(xbgr.mr_n68564160)
print v(xbgr.mr_n68564272)
print v(xbgr.mr_n68564592)
print v(xbgr.mr_n68564704)
print v(xbgr.mr_n68565024)
print v(xbgr.mr_n68565136)
print v(xbgr.mr_n68565456)
print v(xbgr.mr_n68565568)
print v(xbgr.mr_n68565888)
print v(xbgr.mr_n68566000)
print v(xbgr.mr_n68566320)
print v(xbgr.mr_n68566432)
print v(xbgr.mr_n68566752)
print v(xbgr.mr_n68566864)
print v(xbgr.mr_n68567184)
print v(xbgr.mr_n68567296)
print v(xbgr.mr_n68567616)
print v(xbgr.mr_n68567728)
print v(xbgr.mr_n68568048)
print v(xbgr.mr_n68568160)
print v(xbgr.mr_n68568480)
print v(xbgr.mr_n68568592)
print v(xbgr.mr_n68568912)
print v(xbgr.mr_n68569024)
print v(xbgr.mr_n68569344)
print v(xbgr.mr_n68569456)
print v(xbgr.mr_n68569776)
print v(xbgr.mr_n68569888)
print v(xbgr.mr_n68570208)
print v(xbgr.mr_n68570320)
print v(xbgr.mr_n68570640)
print v(xbgr.mr_n68570752)
print v(xbgr.mr_n68571072)
print v(xbgr.mr_n68571184)
print v(xbgr.mr_n68571504)
print v(xbgr.mr_n68571616)
print v(xbgr.mr_n68571936)
print v(xbgr.mr_n68572048)
print v(xbgr.mr_n68572368)
print v(xbgr.mr_n68572480)
print v(xbgr.mr_n68572800)
print v(xbgr.mr_n68572912)
print v(xbgr.mr_n68573232)
print v(xbgr.mr_n68573344)
print v(xbgr.mr_n68573664)
print v(xbgr.mr_n68573776)
print v(xbgr.mr_n68574096)
print v(xbgr.mr_n68574208)
print v(xbgr.mr_n68574528)
print v(xbgr.mr_n68574640)
print v(xbgr.mr_n68574960)
print v(xbgr.mr_n68575072)
print v(xbgr.mr_n68575392)
print v(xbgr.mr_n68575504)
print v(xbgr.mr_n68575824)
print v(xbgr.mr_n68575936)
print v(xbgr.mr_n68576256)
print v(xbgr.mr_n68576368)
print v(xbgr.mr_n68576688)
print v(xbgr.mr_n68576800)
print v(xbgr.mr_n68577120)
print v(xbgr.mr_n68577232)
print v(xbgr.mr_n68577552)
print v(xbgr.mr_n68577664)
print v(xbgr.mr_n68577984)
print v(xbgr.mr_n68578096)
print v(xbgr.mr_n68578416)
print v(xbgr.mr_n68578528)
print v(xbgr.mr_n68578848)
print v(xbgr.mr_n68578960)
print v(xbgr.mr_n68579280)
print v(xbgr.mr_n68579392)
print v(xbgr.mr_n68579712)
print v(xbgr.mr_n68579824)
print v(xbgr.mr_n68580144)
print v(xbgr.mr_n68580256)
print v(xbgr.mr_n68580576)
print v(xbgr.mr_n68580688)
print v(xbgr.mr_n68581008)
print v(xbgr.mr_n68581120)
print v(xbgr.mr_n68581440)
print v(xbgr.mr_n68581552)
print v(xbgr.mr_n68581872)
print v(xbgr.mr_n68581984)
print v(xbgr.mr_n68582304)
print v(xbgr.mr_n68582416)
print v(xbgr.mr_n68582736)
print v(xbgr.mr_n68582848)
print v(xbgr.mr_n68583168)
print v(xbgr.mr_n68583280)
print v(xbgr.mr_n68583600)
print v(xbgr.mr_n68583712)
print v(xbgr.mr_n68584032)
print v(xbgr.mr_n68584144)
print v(xbgr.mr_n68584464)
print v(xbgr.mr_n68584576)
print v(xbgr.mr_n68584896)
print v(xbgr.mr_n68585008)
print v(xbgr.mr_n68585328)
print v(xbgr.mr_n68585440)
print v(xbgr.mr_n68585760)
print v(xbgr.mr_n68585872)
print v(xbgr.mr_n68586192)
print v(xbgr.mr_n68586304)
print v(xbgr.mr_n68586624)
print v(xbgr.mr_n68586736)
print v(xbgr.mr_n68587056)
print v(xbgr.mr_n68587168)
print v(xbgr.mr_n68587488)
print v(xbgr.mr_n68587600)
print v(xbgr.mr_n68587920)
print v(xbgr.mr_n68588032)
print v(xbgr.mr_n68588352)
print v(xbgr.mr_n68588464)
print v(xbgr.mr_n68588784)
print v(xbgr.mr_n68588896)
print v(xbgr.mr_n68589216)
print v(xbgr.mr_n68589328)
print v(xbgr.mr_n68589648)
print v(xbgr.mr_n68589760)
print v(xbgr.mr_n68590080)
print v(xbgr.mr_n68590192)
print v(xbgr.mr_n68590512)
print v(xbgr.mr_n68590624)
print v(xbgr.mr_n68590944)
print v(xbgr.mr_n68591056)
print v(xbgr.mr_n68591376)
print v(xbgr.mr_n68591488)
print v(xbgr.mr_n68591808)
print v(xbgr.mr_n68591920)
print v(xbgr.mr_n68592240)
print v(xbgr.mr_n68592352)
print v(xbgr.mr_n68592672)
print v(xbgr.mr_n68592784)
print v(xbgr.mr_n68593104)
print v(xbgr.mr_n68593216)
print v(xbgr.mr_n68593536)
print v(xbgr.mr_n68593648)
print v(xbgr.mr_n68593968)
print v(xbgr.mr_n68594080)
print v(xbgr.mr_n68594400)
print v(xbgr.mr_n68594512)
print v(xbgr.mr_n68594832)
print v(xbgr.mr_n68594944)
print v(xbgr.mr_n68595264)
print v(xbgr.mr_n68595376)
print v(xbgr.mr_n68595696)
print v(xbgr.mr_n68595808)
print v(xbgr.mr_n68596128)
print v(xbgr.mr_n68596240)
print v(xbgr.mr_n68596560)
print v(xbgr.mr_n68596672)
print v(xbgr.mr_n68596992)
print v(xbgr.mr_n68597104)
print v(xbgr.mr_n68597424)
print v(xbgr.mr_n68597536)
print v(xbgr.mr_n68597856)
print v(xbgr.mr_n68597968)
print v(xbgr.mr_n68598288)
print v(xbgr.mr_n68598400)
print v(xbgr.mr_n68598720)
print v(xbgr.mr_n68598832)
print v(xbgr.mr_n68599152)
print v(xbgr.mr_n68599264)
print v(xbgr.mr_n68599584)
print v(xbgr.mr_n68599696)
print v(xbgr.mr_n68600016)
print v(xbgr.mr_n68600128)
print v(xbgr.mr_n68600448)
print v(xbgr.mr_n68600560)
print v(xbgr.mr_n68600880)
print v(xbgr.mr_n68600992)
print v(xbgr.mr_n68601312)
print v(xbgr.mr_n68601424)
print v(xbgr.mr_n68601744)
print v(xbgr.mr_n68601856)
print v(xbgr.mr_n68602176)
print v(xbgr.mr_n68602288)
print v(xbgr.mr_n68602608)
print v(xbgr.mr_n68602720)
print v(xbgr.mr_n68603040)
print v(xbgr.mr_n68603152)
print v(xbgr.mr_n68603472)
print v(xbgr.mr_n68603584)
print v(xbgr.mr_n68603904)
print v(xbgr.mr_n68604016)
print v(xbgr.mr_n68604336)
print v(xbgr.mr_n68604448)
print v(xbgr.mr_n68604768)
print v(xbgr.mr_n68604880)
print v(xbgr.mr_n68605200)
print v(xbgr.mr_n68605312)
print v(xbgr.mr_n68605632)
print v(xbgr.mr_n68605744)
print v(xbgr.mr_n68606064)
print v(xbgr.mr_n68606176)
print v(xbgr.mr_n68606496)
print v(xbgr.mr_n68606608)
print v(xbgr.mr_n68606928)
print v(xbgr.mr_n68607040)
print v(xbgr.mr_n68607360)
print v(xbgr.mr_n68607472)
print v(xbgr.mr_n68607792)
print v(xbgr.mr_n68607904)
print v(xbgr.mr_n68608224)
print v(xbgr.mr_n68608336)
print v(xbgr.mr_n68608656)
print v(xbgr.mr_n68608768)
print v(xbgr.mr_n68609088)
print v(xbgr.mr_n68609200)
print v(xbgr.mr_n68609520)
print v(xbgr.mr_n68609632)
print v(xbgr.mr_n68609952)
print v(xbgr.mr_n68610064)
print v(xbgr.mr_n68610384)
print v(xbgr.mr_n68610496)
print v(xbgr.mr_n68610816)
print v(xbgr.mr_n68610928)
print v(xbgr.mr_n68611248)
print v(xbgr.mr_n68611360)
print v(xbgr.mr_n68611680)
print v(xbgr.mr_n68611792)
print v(xbgr.mr_n68612112)
print v(xbgr.mr_n68612224)
print v(xbgr.mr_n68612544)
print v(xbgr.mr_n68612656)
print v(xbgr.mr_n68612976)
print v(xbgr.mr_n68613088)
print v(xbgr.mr_n68613408)
print v(xbgr.mr_n68613520)
print v(xbgr.mr_n68613840)
print v(xbgr.mr_n68613952)
print v(xbgr.mr_n68614272)
print v(xbgr.mr_n68614384)
print v(xbgr.mr_n68614704)
print v(xbgr.mr_n68614816)
print v(xbgr.mr_n68615136)
print v(xbgr.mr_n68615248)
print v(xbgr.mr_n68615568)
print v(xbgr.mr_n68615680)
print v(xbgr.mr_n68616000)
print v(xbgr.mr_n68616112)
print v(xbgr.mr_n68616432)
print v(xbgr.mr_n68616544)
print v(xbgr.mr_n68616864)
print v(xbgr.mr_n68616976)
print v(xbgr.mr_n68617296)
print v(xbgr.mr_n68617408)
print v(xbgr.mr_n68617728)
print v(xbgr.mr_n68617840)
print v(xbgr.mr_n68618160)
print v(xbgr.mr_n68618272)
print v(xbgr.mr_n68618592)
print v(xbgr.mr_n68618704)
print v(xbgr.mr_n68619024)
print v(xbgr.mr_n68619136)
print v(xbgr.mr_n68619456)
print v(xbgr.mr_n68619568)
print v(xbgr.mr_n68619888)
print v(xbgr.mr_n68620000)
print v(xbgr.mr_n68620320)
print v(xbgr.mr_n68620432)
print v(xbgr.mr_n68620752)
print v(xbgr.mr_n68620864)
print v(xbgr.mr_n68621184)
print v(xbgr.mr_n68621296)
print v(xbgr.mr_n68621616)
print v(xbgr.mr_n68621728)
print v(xbgr.mr_n68622048)
print v(xbgr.mr_n68622160)
print v(xbgr.mr_n68622480)
print v(xbgr.mr_n68622592)
print v(xbgr.mr_n68622912)
print v(xbgr.mr_n68623024)
print v(xbgr.mr_n68623344)
print v(xbgr.mr_n68623456)
print v(xbgr.mr_n68623776)
print v(xbgr.mr_n68623888)
print v(xbgr.mr_n68624208)
print v(xbgr.mr_n68624320)
print v(xbgr.mr_n68624640)
print v(xbgr.mr_n68624752)
print v(xbgr.mr_n68625072)
print v(xbgr.mr_n68625184)
print v(xbgr.mr_n68625504)
print v(xbgr.mr_n68625616)
print v(xbgr.mr_n68625936)
print v(xbgr.mr_n68626048)
print v(xbgr.mr_n68626368)
print v(xbgr.mr_n68626480)
print v(xbgr.mr_n68626800)
print v(xbgr.mr_n68626912)
print v(xbgr.mr_n68627232)
print v(xbgr.mr_n68627344)
print v(xbgr.mr_n68627664)
print v(xbgr.mr_n68627776)
print v(xbgr.mr_n68628096)
print v(xbgr.mr_n68628208)
print v(xbgr.mr_n68628528)
print v(xbgr.mr_n68628640)
print v(xbgr.mr_n68628960)
print v(xbgr.mr_n68629072)
print v(xbgr.mr_n68629392)
print v(xbgr.mr_n68629504)
print v(xbgr.mr_n68629824)
print v(xbgr.mr_n68629936)
print v(xbgr.mr_n68630256)
print v(xbgr.mr_n68630368)
print v(xbgr.mr_n68630688)
print v(xbgr.mr_n68630800)
print v(xbgr.mr_n68631120)
print v(xbgr.mr_n68631232)
print v(xbgr.mr_n68631552)
print v(xbgr.mr_n68631664)
print v(xbgr.mr_n68631984)
print v(xbgr.mr_n68632096)
print v(xbgr.mr_n68632416)
print v(xbgr.mr_n68632528)
print v(xbgr.mr_n68632848)
print v(xbgr.mr_n68632960)
print v(xbgr.mr_n68633280)
print v(xbgr.mr_n68633392)
print v(xbgr.mr_n68633712)
print v(xbgr.mr_n68633824)
print v(xbgr.mr_n68634144)
print v(xbgr.mr_n68634256)
print v(xbgr.mr_n68634576)
print v(xbgr.mr_n68634688)
print v(xbgr.mr_n68635008)
print v(xbgr.mr_n68635120)
print v(xbgr.mr_n68635440)
print v(xbgr.mr_n68635552)
print v(xbgr.mr_n68635872)
print v(xbgr.mr_n68635984)
print v(xbgr.mr_n68636304)
print v(xbgr.mr_n68636416)
print v(xbgr.mr_n68636736)
print v(xbgr.mr_n68636848)
print v(xbgr.mr_n68637168)
print v(xbgr.mr_n68637280)
print v(xbgr.mr_n68637600)
print v(xbgr.mr_n68637712)
print v(xbgr.mr_n68638032)
print v(xbgr.mr_n68638144)
print v(xbgr.mr_n68638464)
print v(xbgr.mr_n68638576)
print v(xbgr.mr_n68638896)
print v(xbgr.mr_n68639008)
print v(xbgr.mr_n68639328)
print v(xbgr.mr_n68639440)
print v(xbgr.mr_n68639760)
print v(xbgr.mr_n68639872)
print v(xbgr.mr_n68640192)
print v(xbgr.mr_n68640304)
print v(xbgr.mr_n68640624)
print v(xbgr.mr_n68640736)
print v(xbgr.mr_n68641056)
print v(xbgr.mr_n68641168)
print v(xbgr.mr_n68641488)
print v(xbgr.mr_n68641600)
print v(xbgr.mr_n68641920)
print v(xbgr.mr_n68642032)
print v(xbgr.mr_n68642464)
print v(xbgr.mr_n68642784)
print v(xbgr.mr_n68642896)
print v(xbgr.mr_n68643216)
print v(xbgr.mr_n68643328)
print v(xbgr.mr_n68643648)
print v(xbgr.mr_n68643760)
print v(xbgr.mr_n68644080)
print v(xbgr.mr_n68644192)
print v(xbgr.mr_n68644512)
print v(xbgr.mr_n68644624)
print v(xbgr.mr_n68644944)
print v(xbgr.mr_n68645056)
print v(xbgr.mr_n68645376)
print v(xbgr.mr_n68645488)
print v(xbgr.mr_n68645808)
print v(xbgr.mr_n68645920)
print v(xbgr.mr_n68646240)
print v(xbgr.mr_n68646352)
print v(xbgr.mr_n68646672)
print v(xbgr.mr_n68646784)
print v(xbgr.mr_n68647104)
print v(xbgr.mr_n68647216)
print v(xbgr.mr_n68647536)
print v(xbgr.mr_n68647648)
print v(xbgr.mr_n68647968)
print v(xbgr.mr_n68648080)
print v(xbgr.mr_n68648512)
print v(xbgr.mr_n68648832)
print v(xbgr.mr_n68648944)
print v(xbgr.mr_n68649264)
print v(xbgr.mr_n68649376)
print v(xbgr.mr_n68649696)
print v(xbgr.mr_n68649808)
print v(xbgr.mr_n68650128)
print v(xbgr.mr_n68650240)
print v(xbgr.mr_n68650560)
print v(xbgr.mr_n68650672)
print v(xbgr.mr_n68650992)
print v(xbgr.mr_n68651104)
print v(xbgr.mr_n68651424)
print v(xbgr.mr_n68651536)
print v(xbgr.mr_n68651856)
print v(xbgr.mr_n68651968)
print v(xbgr.mr_n68652288)
print v(xbgr.mr_n68652400)
print v(xbgr.mr_n68652720)
print v(xbgr.mr_n68652832)
print v(xbgr.mr_n68653152)
print v(xbgr.mr_n68653264)
print v(xbgr.mr_n68653584)
print v(xbgr.mr_n68653696)
print v(xbgr.mr_n68654016)
print v(xbgr.mr_n68654128)
print v(xbgr.mr_n68654448)
print v(xbgr.mr_n68654560)
print v(xbgr.mr_n68654880)
print v(xbgr.mr_n68654992)
print v(xbgr.mr_n68655312)
print v(xbgr.mr_n68655424)
print v(xbgr.mr_n68655744)
print v(xbgr.mr_n68655856)
print v(xbgr.mr_n68656176)
print v(xbgr.mr_n68656288)
print v(xbgr.mr_n68656608)
print v(xbgr.mr_n68656720)
print v(xbgr.mr_n68657040)
print v(xbgr.mr_n68657152)
print v(xbgr.mr_n68657472)
print v(xbgr.mr_n68657584)
print v(xbgr.mr_n68657904)
print v(xbgr.mr_n68658016)
print v(xbgr.mr_n68658336)
print v(xbgr.mr_n68658448)
print v(xbgr.mr_n68658768)
print v(xbgr.mr_n68658880)
print v(xbgr.mr_n68659200)
print v(xbgr.mr_n68659312)
print v(xbgr.mr_n68659632)
print v(xbgr.mr_n68659744)
print v(xbgr.mr_n68660064)
print v(xbgr.mr_n68660176)
print v(xbgr.mr_n68660496)
print v(xbgr.mr_n68660608)
print v(xbgr.mr_n68660928)
print v(xbgr.mr_n68661040)
print v(xbgr.mr_n68661360)
print v(xbgr.mr_n68661472)
print v(xbgr.mr_n68661792)
print v(xbgr.mr_n68661904)
print v(xbgr.mr_n68662224)
print v(xbgr.mr_n68662336)
print v(xbgr.mr_n68662656)
print v(xbgr.mr_n68662768)
print v(xbgr.mr_n68663088)
print v(xbgr.mr_n68663200)
print v(xbgr.mr_n68663520)
print v(xbgr.mr_n68663632)
print v(xbgr.mr_n68663952)
print v(xbgr.mr_n68664064)
print v(xbgr.mr_n68664384)
print v(xbgr.mr_n68664496)
print v(xbgr.mr_n68664816)
print v(xbgr.mr_n68664928)
print v(xbgr.mr_n68665248)
print v(xbgr.mr_n68665360)
print v(xbgr.mr_n68665680)
print v(xbgr.mr_n68665792)
print v(xbgr.mr_n68666112)
print v(xbgr.mr_n68666224)
print v(xbgr.mr_n68666544)
print v(xbgr.mr_n68666656)
print v(xbgr.mr_n68666976)
print v(xbgr.mr_n68667088)
print v(xbgr.mr_n68667408)
print v(xbgr.mr_n68667520)
print v(xbgr.mr_n68667840)
print v(xbgr.mr_n68667952)
print v(xbgr.mr_n68668272)
print v(xbgr.mr_n68668384)
print v(xbgr.mr_n68668704)
print v(xbgr.mr_n68668816)
print v(xbgr.mr_n68669136)
print v(xbgr.mr_n68669248)
print v(xbgr.mr_n68669568)
print v(xbgr.mr_n68669680)
print v(xbgr.mr_n68670000)
print v(xbgr.mr_n68670112)
print v(xbgr.mr_n68670432)
print v(xbgr.mr_n68670544)
print v(xbgr.mr_n68670864)
print v(xbgr.mr_n68670976)
print v(xbgr.mr_n68671296)
print v(xbgr.mr_n68671408)
print v(xbgr.mr_n68671728)
print v(xbgr.mr_n68671840)
print v(xbgr.mr_n68672160)
print v(xbgr.mr_n68672272)
print v(xbgr.mr_n68672592)
print v(xbgr.mr_n68672704)
print v(xbgr.mr_n68673024)
print v(xbgr.mr_n68673136)
print v(xbgr.mr_n68673456)
print v(xbgr.mr_n68673568)
print v(xbgr.mr_n68673888)
print v(xbgr.mr_n68674000)
print v(xbgr.mr_n68674320)
print v(xbgr.mr_n68674432)
print v(xbgr.mr_n68674752)
print v(xbgr.mr_n68674864)
print v(xbgr.mr_n68675184)
print v(xbgr.mr_n68675296)
print v(xbgr.mr_n68675616)
print v(xbgr.mr_n68675728)
print v(xbgr.mr_n68676048)
print v(xbgr.mr_n68676160)
print v(xbgr.mr_n68676480)
print v(xbgr.mr_n68676592)
print v(xbgr.mr_n68676912)
print v(xbgr.mr_n68677024)
print v(xbgr.mr_n68677344)
print v(xbgr.mr_n68677456)
print v(xbgr.mr_n68677776)
print v(xbgr.mr_n68677888)
print v(xbgr.mr_n68678208)
print v(xbgr.mr_n68678320)
print v(xbgr.mr_n68678640)
print v(xbgr.mr_n68678752)
print v(xbgr.mr_n68679072)
print v(xbgr.mr_n68679184)
print v(xbgr.mr_n68679504)
print v(xbgr.mr_n68679616)
print v(xbgr.mr_n68679936)
print v(xbgr.mr_n68680048)
print v(xbgr.mr_n68680368)
print v(xbgr.mr_n68680480)
print v(xbgr.mr_n68680800)
print v(xbgr.mr_n68680912)
print v(xbgr.mr_n68681344)
print v(xbgr.mr_n68681664)
print v(xbgr.mr_n68681776)
print v(xbgr.mr_n68682096)
print v(xbgr.mr_n68682208)
print v(xbgr.mr_n68682528)
print v(xbgr.mr_n68682640)
print v(xbgr.mr_n68683072)
print v(xbgr.mr_n68683392)
print v(xbgr.mr_n68683504)
print v(xbgr.mr_n68683824)
print v(xbgr.mr_n68683936)
print v(xbgr.mr_n68684256)
print v(xbgr.mr_n68684368)
print v(xbgr.mr_n68684800)
print v(xbgr.mr_n68685120)
print v(xbgr.mr_n68685232)
print v(xbgr.mr_n68685552)
print v(xbgr.mr_n68685664)
print v(xbgr.mr_n68685984)
print v(xbgr.mr_n68686096)
print v(xbgr.mr_n68686416)
print v(xbgr.mr_n68686528)
print v(xbgr.mr_n68686848)
print v(xbgr.mr_n68686960)
print v(xbgr.mr_n68687280)
print v(xbgr.mr_n68687392)
print v(xbgr.mr_n68687712)
print v(xbgr.mr_n68687824)
print v(xbgr.mr_n68688144)
print v(xbgr.mr_n68688256)
print v(xbgr.mr_n68688576)
print v(xbgr.mr_n68688688)
print v(xbgr.mr_n68689008)
print v(xbgr.mr_n68689120)
print v(xbgr.mr_n68689440)
print v(xbgr.mr_n68689552)
print v(xbgr.mr_n68689872)
print v(xbgr.mr_n68689984)
print v(xbgr.mr_n68690304)
print v(xbgr.mr_n68690416)
print v(xbgr.mr_n68690736)
print v(xbgr.mr_n68690848)
print v(xbgr.mr_n68691168)
print v(xbgr.mr_n68691280)
print v(xbgr.mr_n68691600)
print v(xbgr.mr_n68691712)
print v(xbgr.mr_n68692032)
print v(xbgr.mr_n68692144)
print v(xbgr.mr_n68692464)
print v(xbgr.mr_n68692576)
print v(xbgr.mr_n68692896)
print v(xbgr.mr_n68693008)
print v(xbgr.mr_n68693328)
print v(xbgr.mr_n68693440)
print v(xbgr.mr_n68693760)
print v(xbgr.mr_n68693872)
print v(xbgr.mr_n68694192)
print v(xbgr.mr_n68694304)
print v(xbgr.mr_n68694624)
print v(xbgr.mr_n68694736)
print v(xbgr.mr_n68695056)
print v(xbgr.mr_n68695168)
print v(xbgr.mr_n68695488)
print v(xbgr.mr_n68695600)
print v(xbgr.mr_n68695920)
print v(xbgr.mr_n68696032)
print v(xbgr.mr_n68696352)
print v(xbgr.mr_n68696464)
print v(xbgr.mr_n68696784)
print v(xbgr.mr_n68696896)
print v(xbgr.mr_n68697216)
print v(xbgr.mr_n68697328)
print v(xbgr.mr_n68697648)
print v(xbgr.mr_n68697760)
print v(xbgr.mr_n68698080)
print v(xbgr.mr_n68698192)
print v(xbgr.mr_n68698512)
print v(xbgr.mr_n68698624)
print v(xbgr.mr_n68698944)
print v(xbgr.mr_n68699056)
print v(xbgr.mr_n68699376)
print v(xbgr.mr_n68699488)
print v(xbgr.mr_n68699808)
print v(xbgr.mr_n68699920)
print v(xbgr.mr_n68700240)
print v(xbgr.mr_n68700352)
print v(xbgr.mr_n68700672)
print v(xbgr.mr_n68700784)
print v(xbgr.mr_n68701104)
print v(xbgr.mr_n68701216)
print v(xbgr.mr_n68701536)
print v(xbgr.mr_n68701648)
print v(xbgr.mr_n68701968)
print v(xbgr.mr_n68702080)
print v(xbgr.mr_n68702400)
print v(xbgr.mr_n68702512)
print v(xbgr.mr_n68702832)
print v(xbgr.mr_n68702944)
print v(xbgr.mr_n68703264)
print v(xbgr.mr_n68703376)
print v(xbgr.mr_n68703696)
print v(xbgr.mr_n68703808)
print v(xbgr.mr_n68704128)
print v(xbgr.mr_n68704240)
print v(xbgr.mr_n68704560)
print v(xbgr.mr_n68704672)
print v(xbgr.mr_n68705104)
print v(xbgr.mr_n68705536)
print v(xbgr.mr_n68705968)
print v(xbgr.mr_n68706400)
print v(xbgr.mr_n68706832)
print v(xbgr.mr_n68707264)
print v(xbgr.mr_n68707696)
print v(xbgr.mr_n68708128)
print v(xbgr.mr_n68708560)
print v(xbgr.mr_n68708992)
print v(xbgr.mr_n68709424)
print v(xbgr.mr_n68709856)
print v(xbgr.mr_n68710288)
print v(xbgr.mr_n68710720)
print v(xbgr.mr_n68711152)
print v(xbgr.mr_n68711584)
print v(xbgr.mr_n68712016)
print v(xbgr.mr_n68712448)
print v(xbgr.mr_n68712880)
print v(xbgr.mr_n68713312)
print v(xbgr.mr_n68713744)
print v(xbgr.mr_n68714176)
print v(xbgr.mr_n68714608)
print v(xbgr.mr_n68715040)
print v(xbgr.mr_n68715472)
print v(xbgr.mr_n68715904)
print v(xbgr.mr_n68716336)
print v(xbgr.mr_n68716768)
print v(xbgr.mr_n68717200)
print v(xbgr.mr_n68717632)
print v(xbgr.mr_n68718064)
print v(xbgr.mr_n68718496)
print v(xbgr.mr_n68718928)
print v(xbgr.mr_n68719360)
print v(xbgr.mr_n68719792)
print v(xbgr.mr_n68720224)
print v(xbgr.mr_n68720656)
print v(xbgr.mr_n68721088)
print v(xbgr.mr_n68721520)
print v(xbgr.mr_n68721952)
print v(xbgr.mr_n68722384)
print v(xbgr.mr_n68722816)
print v(xbgr.mr_n68723248)
print v(xbgr.mr_n68723680)
print v(xbgr.mr_n68724112)
print v(xbgr.mr_n68724544)
print v(xbgr.mr_n68724976)
print v(xbgr.mr_n68725408)
print v(xbgr.mr_n68725840)
print v(xbgr.mr_n68726272)
print v(xbgr.mr_n68726704)
print v(xbgr.mr_n68727136)
print v(xbgr.mr_n68727568)
print v(xbgr.mr_n68728000)
print v(xbgr.mr_n68728432)
print v(xbgr.mr_n68728864)
print v(xbgr.mr_n68729296)
print v(xbgr.mr_n68729728)
print v(xbgr.mr_n68730160)
print v(xbgr.mr_n68730592)
print v(xbgr.mr_n68731024)
print v(xbgr.mr_n68731456)
print v(xbgr.mr_n68731888)
print v(xbgr.mr_n68732320)
print v(xbgr.mr_n68732752)
print v(xbgr.mr_n68733184)
print v(xbgr.mr_n68733616)
print v(xbgr.mr_n68734048)
print v(xbgr.mr_n68734480)
print v(xbgr.mr_n68734912)
print v(xbgr.mr_n68735344)
print v(xbgr.mr_n68735776)
print v(xbgr.mr_n68736208)
print v(xbgr.mr_n68736640)
print v(xbgr.mr_n68737072)
print v(xbgr.mr_n68737504)
print v(xbgr.mr_n68737936)
print v(xbgr.mr_n68738368)
print v(xbgr.mr_n68738800)
print v(xbgr.mr_n68739232)
print v(xbgr.mr_n68739552)
print v(xbgr.mr_n68739664)
print v(xbgr.mr_n68740096)
print v(xbgr.mr_n68740416)
print v(xbgr.mr_n68740528)
print v(xbgr.mr_n68740848)
print v(xbgr.mr_n68740960)
print v(xbgr.mr_n68741280)
print v(xbgr.mr_n68741392)
print v(xbgr.mr_n68741712)
print v(xbgr.mr_n68741824)
print v(xbgr.mr_n68742144)
print v(xbgr.mr_n68742256)
print v(xbgr.mr_n68742576)
print v(xbgr.mr_n68742688)
print v(xbgr.mr_n68743008)
print v(xbgr.mr_n68743120)
print v(xbgr.mr_n68743440)
print v(xbgr.mr_n68743552)
print v(xbgr.mr_n68743872)
print v(xbgr.mr_n68743984)
print v(xbgr.mr_n68744304)
print v(xbgr.mr_n68744416)
print v(xbgr.mr_n68744848)
print v(xbgr.mr_n68745280)
print v(xbgr.mr_n68745712)
print v(xbgr.mr_n68746144)
print v(xbgr.mr_n68746576)
print v(xbgr.mr_n68747008)
print v(xbgr.mr_n68747440)
print v(xbgr.mr_n68747872)
print v(xbgr.mr_n68748304)
print v(xbgr.mr_n68748736)
print v(xbgr.mr_n68749168)
print v(xbgr.mr_n68749600)
print v(xbgr.mr_n68750032)
print v(xbgr.mr_n68750464)
print v(xbgr.mr_n68750896)
print v(xbgr.mr_n68751328)
print v(xbgr.mr_n68751760)
print v(xbgr.mr_n68752192)
print v(xbgr.mr_n68752624)
print v(xbgr.mr_n68753056)
print v(xbgr.mr_n68753488)
print v(xbgr.mr_n68753920)
print v(xbgr.mr_n68754352)
print v(xbgr.mr_n68754784)
print v(xbgr.mr_n68755216)
print v(xbgr.mr_n68755648)
print v(xbgr.mr_n68756080)
print v(xbgr.mr_n68756352)
print v(xbgr.mr_n68756464)
print v(xbgr.mr_n68756784)
print v(xbgr.mr_n68756896)
print v(xbgr.mr_n68757216)
print v(xbgr.mr_n68757328)
print v(xbgr.mr_n68757648)
print v(xbgr.mr_n68757760)
print v(xbgr.mr_n68758080)
print v(xbgr.mr_n68758192)
print v(xbgr.mr_n68758512)
print v(xbgr.mr_n68758624)
print v(xbgr.mr_n68758944)
print v(xbgr.mr_n68759056)
print v(xbgr.mr_n68759376)
print v(xbgr.mr_n68759488)
print v(xbgr.mr_n68759808)
print v(xbgr.mr_n68759920)
print v(xbgr.mr_n68760240)
print v(xbgr.mr_n68760352)
print v(xbgr.mr_n68760672)
print v(xbgr.mr_n68760784)
print v(xbgr.mr_n68761104)
print v(xbgr.mr_n68761216)
print v(xbgr.mr_n68761536)
print v(xbgr.mr_n68761648)
print v(xbgr.mr_n68761968)
print v(xbgr.mr_n68762080)
print v(xbgr.mr_n68762400)
print v(xbgr.mr_n68762512)
print v(xbgr.mr_n68762832)
print v(xbgr.mr_n68762944)
print v(xbgr.mr_n68763264)
print v(xbgr.mr_n68763376)
print v(xbgr.mr_n68763696)
print v(xbgr.mr_n68763808)
print v(xbgr.mr_n68764128)
print v(xbgr.mr_n68764240)
print v(xbgr.mr_n68764560)
print v(xbgr.mr_n68764672)
print v(xbgr.mr_n68764992)
print v(xbgr.mr_n68765104)
print v(xbgr.mr_n68765424)
print v(xbgr.mr_n68765536)
print v(xbgr.mr_n68765856)
print v(xbgr.mr_n68765968)
print v(xbgr.mr_n68766288)
print v(xbgr.mr_n68766400)
print v(xbgr.mr_n68766720)
print v(xbgr.mr_n68766832)
print v(xbgr.mr_n68767152)
print v(xbgr.mr_n68767264)
print v(xbgr.mr_n68767584)
print v(xbgr.mr_n68767696)
print v(xbgr.mr_n68768016)
print v(xbgr.mr_n68768128)
print v(xbgr.mr_n68768448)
print v(xbgr.mr_n68768560)
print v(xbgr.mr_n68768880)
print v(xbgr.mr_n68768992)
print v(xbgr.mr_n68769312)
print v(xbgr.mr_n68769424)
print v(xbgr.mr_n68769744)
print v(xbgr.mr_n68769856)
print v(xbgr.mr_n68770176)
print v(xbgr.mr_n68770288)
print v(xbgr.mr_n68770608)
print v(xbgr.mr_n68770720)
print v(xbgr.mr_n68771040)
print v(xbgr.mr_n68771152)
print v(xbgr.mr_n68771472)
print v(xbgr.mr_n68771584)
print v(xbgr.mr_n68771904)
print v(xbgr.mr_n68772016)
print v(xbgr.mr_n68772336)
print v(xbgr.mr_n68772448)
print v(xbgr.mr_n68772768)
print v(xbgr.mr_n68772880)
print v(xbgr.mr_n68773200)
print v(xbgr.mr_n68773312)
print v(xbgr.mr_n68773632)
print v(xbgr.mr_n68773744)
print v(xbgr.mr_n68774064)
print v(xbgr.mr_n68774176)
print v(xbgr.mr_n68774496)
print v(xbgr.mr_n68774608)
print v(xbgr.mr_n68774928)
print v(xbgr.mr_n68775040)
print v(xbgr.mr_n68775360)
print v(xbgr.mr_n68775472)
print v(xbgr.mr_n68775792)
print v(xbgr.mr_n68775904)
print v(xbgr.mr_n68776224)
print v(xbgr.mr_n68776336)
print v(xbgr.mr_n68776656)
print v(xbgr.mr_n68776768)
print v(xbgr.mr_n68777088)
print v(xbgr.mr_n68777200)
print v(xbgr.mr_n68777520)
print v(xbgr.mr_n68777632)
print v(xbgr.mr_n68777952)
print v(xbgr.mr_n68778064)
print v(xbgr.mr_n68778384)
print v(xbgr.mr_n68778496)
print v(xbgr.mr_n68778816)
print v(xbgr.mr_n68778928)
print v(xbgr.mr_n68779248)
print v(xbgr.mr_n68779360)
print v(xbgr.mr_n68779680)
print v(xbgr.mr_n68779792)
print v(xbgr.mr_n68780112)
print v(xbgr.mr_n68780224)
print v(xbgr.mr_n68780544)
print v(xbgr.mr_n68780656)
print v(xbgr.mr_n68780976)
print v(xbgr.mr_n68781088)
print v(xbgr.mr_n68781408)
print v(xbgr.mr_n68781520)
print v(xbgr.mr_n68781840)
print v(xbgr.mr_n68781952)
print v(xbgr.mr_n68782272)
print v(xbgr.mr_n68782384)
print v(xbgr.mr_n68782704)
print v(xbgr.mr_n68782816)
print v(xbgr.mr_n68783136)
print v(xbgr.mr_n68783248)
print v(xbgr.mr_n68783568)
print v(xbgr.mr_n68783680)
print v(xbgr.mr_n68784000)
print v(xbgr.mr_n68784112)
print v(xbgr.mr_n68784432)
print v(xbgr.mr_n68784544)
print v(xbgr.mr_n68784864)
print v(xbgr.mr_n68784976)
print v(xbgr.mr_n68785296)
print v(xbgr.mr_n68785408)
print v(xbgr.mr_n68785728)
print v(xbgr.mr_n68785840)
print v(xbgr.mr_n68786160)
print v(xbgr.mr_n68786272)
print v(xbgr.mr_n68786592)
print v(xbgr.mr_n68786704)
print v(xbgr.mr_n68787024)
print v(xbgr.mr_n68787136)
print v(xbgr.mr_n68787456)
print v(xbgr.mr_n68787568)
print v(xbgr.mr_n68787888)
print v(xbgr.mr_n68788000)
print v(xbgr.mr_n68788320)
print v(xbgr.mr_n68788432)
print v(xbgr.mr_n68788752)
print v(xbgr.mr_n68788864)
print v(xbgr.mr_n68789184)
print v(xbgr.mr_n68789296)
print v(xbgr.mr_n68789616)
print v(xbgr.mr_n68789728)
print v(xbgr.mr_n68790048)
print v(xbgr.mr_n68790160)
print v(xbgr.mr_n68790480)
print v(xbgr.mr_n68790592)
print v(xbgr.mr_n68790912)
print v(xbgr.mr_n68791024)
print v(xbgr.mr_n68791344)
print v(xbgr.mr_n68791456)
print v(xbgr.mr_n68791776)
print v(xbgr.mr_n68791888)
print v(xbgr.mr_n68792208)
print v(xbgr.mr_n68792320)
print v(xbgr.mr_n68792640)
print v(xbgr.mr_n68792752)
print v(xbgr.mr_n68793072)
print v(xbgr.mr_n68793184)
print v(xbgr.mr_n68793504)
print v(xbgr.mr_n68793616)
print v(xbgr.mr_n68793936)
print v(xbgr.mr_n68794048)
print v(xbgr.mr_n68794368)
print v(xbgr.mr_n68794480)
print v(xbgr.mr_n68794800)
print v(xbgr.mr_n68794912)
print v(xbgr.mr_n68795232)
print v(xbgr.mr_n68795344)
print v(xbgr.mr_n68795664)
print v(xbgr.mr_n68795776)
print v(xbgr.mr_n68796096)
print v(xbgr.mr_n68796208)
print v(xbgr.mr_n68796528)
print v(xbgr.mr_n68796640)
print v(xbgr.mr_n68796960)
print v(xbgr.mr_n68797072)
print v(xbgr.mr_n68797392)
print v(xbgr.mr_n68797504)
print v(xbgr.mr_n68797824)
print v(xbgr.mr_n68797936)
print v(xbgr.mr_n68798256)
print v(xbgr.mr_n68798368)
print v(xbgr.mr_n68798688)
print v(xbgr.mr_n68798800)
print v(xbgr.mr_n68799120)
print v(xbgr.mr_n68799232)
print v(xbgr.mr_n68799552)
print v(xbgr.mr_n68799664)
print v(xbgr.mr_n68799984)
print v(xbgr.mr_n68800096)
print v(xbgr.mr_n68800416)
print v(xbgr.mr_n68800528)
print v(xbgr.mr_n68800848)
print v(xbgr.mr_n68800960)
print v(xbgr.mr_n68801280)
print v(xbgr.mr_n68801392)
print v(xbgr.mr_n68801712)
print v(xbgr.mr_n68801824)
print v(xbgr.mr_n68802144)
print v(xbgr.mr_n68802256)
print v(xbgr.mr_n68802576)
print v(xbgr.mr_n68802688)
print v(xbgr.mr_n68803008)
print v(xbgr.mr_n68803120)
print v(xbgr.mr_n68803440)
print v(xbgr.mr_n68803552)
print v(xbgr.mr_n68803872)
print v(xbgr.mr_n68803984)
print v(xbgr.mr_n68804304)
print v(xbgr.mr_n68804416)
print v(xbgr.mr_n68804736)
print v(xbgr.mr_n68804848)
print v(xbgr.mr_n68805168)
print v(xbgr.mr_n68805280)
print v(xbgr.mr_n68805600)
print v(xbgr.mr_n68805712)
print v(xbgr.mr_n68806032)
print v(xbgr.mr_n68806144)
print v(xbgr.mr_n68806464)
print v(xbgr.mr_n68806576)
print v(xbgr.mr_n68806896)
print v(xbgr.mr_n68807008)
print v(xbgr.mr_n68807328)
print v(xbgr.mr_n68807440)
print v(xbgr.mr_n68807760)
print v(xbgr.mr_n68807872)
print v(xbgr.mr_n68808192)
print v(xbgr.mr_n68808304)
print v(xbgr.mr_n68808624)
print v(xbgr.mr_n68808736)
print v(xbgr.mr_n68809056)
print v(xbgr.mr_n68809168)
print v(xbgr.mr_n68809488)
print v(xbgr.mr_n68809600)
print v(xbgr.mr_n68809920)
print v(xbgr.mr_n68810032)
print v(xbgr.mr_n68810352)
print v(xbgr.mr_n68810464)
print v(xbgr.mr_n68810784)
print v(xbgr.mr_n68810896)
print v(xbgr.mr_n68811216)
print v(xbgr.mr_n68811328)
print v(xbgr.mr_n68811648)
print v(xbgr.mr_n68811760)
print v(xbgr.mr_n68812080)
print v(xbgr.mr_n68812192)
print v(xbgr.mr_n68812512)
print v(xbgr.mr_n68812624)
print v(xbgr.mr_n68812944)
print v(xbgr.mr_n68813056)
print v(xbgr.mr_n68813376)
print v(xbgr.mr_n68813488)
print v(xbgr.mr_n68813808)
print v(xbgr.mr_n68813920)
print v(xbgr.mr_n68814240)
print v(xbgr.mr_n68814352)
print v(xbgr.mr_n68814672)
print v(xbgr.mr_n68814784)
print v(xbgr.mr_n68815104)
print v(xbgr.mr_n68815216)
print v(xbgr.mr_n68815536)
print v(xbgr.mr_n68815648)
print v(xbgr.mr_n68815968)
print v(xbgr.mr_n68816080)
print v(xbgr.mr_n68816400)
print v(xbgr.mr_n68816512)
print v(xbgr.mr_n68816832)
print v(xbgr.mr_n68816944)
print v(xbgr.mr_n68817264)
print v(xbgr.mr_n68817376)
print v(xbgr.mr_n68817696)
print v(xbgr.mr_n68817808)
print v(xbgr.mr_n68818128)
print v(xbgr.mr_n68818240)
print v(xbgr.mr_n68818560)
print v(xbgr.mr_n68818672)
print v(xbgr.mr_n68818992)
print v(xbgr.mr_n68819104)
print v(xbgr.mr_n68819424)
print v(xbgr.mr_n68819536)
print v(xbgr.mr_n68819856)
print v(xbgr.mr_n68819968)
print v(xbgr.mr_n68820288)
print v(xbgr.mr_n68820400)
print v(xbgr.mr_n68820720)
print v(xbgr.mr_n68820832)
print v(xbgr.mr_n68821152)
print v(xbgr.mr_n68821264)
print v(xbgr.mr_n68821584)
print v(xbgr.mr_n68821696)
print v(xbgr.mr_n68822016)
print v(xbgr.mr_n68822128)
print v(xbgr.mr_n68822448)
print v(xbgr.mr_n68822560)
print v(xbgr.mr_n68822880)
print v(xbgr.mr_n68822992)
print v(xbgr.mr_n68823312)
print v(xbgr.mr_n68823424)
print v(xbgr.mr_n68823744)
print v(xbgr.mr_n68823856)
print v(xbgr.mr_n68824176)
print v(xbgr.mr_n68824288)
print v(xbgr.mr_n68824608)
print v(xbgr.mr_n68824720)
print v(xbgr.mr_n68825040)
print v(xbgr.mr_n68825152)
print v(xbgr.mr_n68825472)
print v(xbgr.mr_n68825584)
print v(xbgr.mr_n68825904)
print v(xbgr.mr_n68826016)
print v(xbgr.mr_n68826336)
print v(xbgr.mr_n68826448)
print v(xbgr.mr_n68826768)
print v(xbgr.mr_n68826880)
print v(xbgr.mr_n68827200)
print v(xbgr.mr_n68827312)
print v(xbgr.mr_n68827632)
print v(xbgr.mr_n68827744)
print v(xbgr.mr_n68828064)
print v(xbgr.mr_n68828176)
print v(xbgr.mr_n68828496)
print v(xbgr.mr_n68828608)
print v(xbgr.mr_n68828928)
print v(xbgr.mr_n68829040)
print v(xbgr.mr_n68829360)
print v(xbgr.mr_n68829472)
print v(xbgr.mr_n68829792)
print v(xbgr.mr_n68829904)
print v(xbgr.mr_n68830224)
print v(xbgr.mr_n68830336)
print v(xbgr.mr_n68830656)
print v(xbgr.mr_n68830768)
print v(xbgr.mr_n68831088)
print v(xbgr.mr_n68831200)
print v(xbgr.mr_n68831520)
print v(xbgr.mr_n68831632)
print v(xbgr.mr_n68831952)
print v(xbgr.mr_n68832064)
print v(xbgr.mr_n68832384)
print v(xbgr.mr_n68832496)
print v(xbgr.mr_n68832816)
print v(xbgr.mr_n68832928)
print v(xbgr.mr_n68833248)
print v(xbgr.mr_n68833360)
print v(xbgr.mr_n68833680)
print v(xbgr.mr_n68833792)
print v(xbgr.mr_n68834112)
print v(xbgr.mr_n68834224)
print v(xbgr.mr_n68834544)
print v(xbgr.mr_n68834656)
print v(xbgr.mr_n68834976)
print v(xbgr.mr_n68835088)
print v(xbgr.mr_n68835408)
print v(xbgr.mr_n68835520)
print v(xbgr.mr_n68835840)
print v(xbgr.mr_n68835952)
print v(xbgr.mr_n68836272)
print v(xbgr.mr_n68836384)
print v(xbgr.mr_n68836704)
print v(xbgr.mr_n68836816)
print v(xbgr.mr_n68837136)
print v(xbgr.mr_n68837248)
print v(xbgr.mr_n68837568)
print v(xbgr.mr_n68837680)
print v(xbgr.mr_n68838000)
print v(xbgr.mr_n68838112)
print v(xbgr.mr_n68838432)
print v(xbgr.mr_n68838544)
print v(xbgr.mr_n68838864)
print v(xbgr.mr_n68838976)
print v(xbgr.mr_n68839296)
print v(xbgr.mr_n68839408)
print v(xbgr.mr_n68839728)
print v(xbgr.mr_n68839840)
print v(xbgr.mr_n68840160)
print v(xbgr.mr_n68840272)
print v(xbgr.mr_n68840592)
print v(xbgr.mr_n68840704)
print v(xbgr.mr_n68841136)
print v(xbgr.mr_n68841456)
print v(xbgr.mr_n68841568)
print v(xbgr.mr_n68841888)
print v(xbgr.mr_n68842000)
print v(xbgr.mr_n68842320)
print v(xbgr.mr_n68842432)
print v(xbgr.mr_n68842864)
print v(xbgr.mr_n68843184)
print v(xbgr.mr_n68843296)
print v(xbgr.mr_n68843616)
print v(xbgr.mr_n68843728)
print v(xbgr.mr_n68844048)
print v(xbgr.mr_n68844160)
print v(xbgr.mr_n68844592)
print v(xbgr.mr_n68844912)
print v(xbgr.mr_n68845024)
print v(xbgr.mr_n68845344)
print v(xbgr.mr_n68845456)
print v(xbgr.mr_n68845776)
print v(xbgr.mr_n68845888)
print v(xbgr.mr_n68846320)
print v(xbgr.mr_n68846640)
print v(xbgr.mr_n68846752)
print v(xbgr.mr_n68847072)
print v(xbgr.mr_n68847184)
print v(xbgr.mr_n68847504)
print v(xbgr.mr_n68847616)
print v(xbgr.mr_n68848048)
print v(xbgr.mr_n68848368)
print v(xbgr.mr_n68848480)
print v(xbgr.mr_n68848800)
print v(xbgr.mr_n68848912)
print v(xbgr.mr_n68849232)
print v(xbgr.mr_n68849344)
print v(xbgr.mr_n68849776)
print v(xbgr.mr_n68850096)
print v(xbgr.mr_n68850208)
print v(xbgr.mr_n68850528)
print v(xbgr.mr_n68850640)
print v(xbgr.mr_n68850960)
print v(xbgr.mr_n68851072)
print v(xbgr.mr_n68851504)
print v(xbgr.mr_n68851824)
print v(xbgr.mr_n68851936)
print v(xbgr.mr_n68852256)
print v(xbgr.mr_n68852368)
print v(xbgr.mr_n68852688)
print v(xbgr.mr_n68852800)
print v(xbgr.mr_n68853232)
print v(xbgr.mr_n68853552)
print v(xbgr.mr_n68853664)
print v(xbgr.mr_n68853984)
print v(xbgr.mr_n68854096)
print v(xbgr.mr_n68854416)
print v(xbgr.mr_n68854528)
print v(xbgr.mr_n68854848)
print v(xbgr.mr_n68854960)
print v(xbgr.mr_n68855280)
print v(xbgr.mr_n68855392)
print v(xbgr.mr_n68855712)
print v(xbgr.mr_n68855824)
print v(xbgr.mr_n68856144)
print v(xbgr.mr_n68856256)
print v(xbgr.mr_n68856576)
print v(xbgr.mr_n68856688)
print v(xbgr.mr_n68857008)
print v(xbgr.mr_n68857120)
print v(xbgr.mr_n68857440)
print v(xbgr.mr_n68857552)
print v(xbgr.mr_n68857872)
print v(xbgr.mr_n68857984)
print v(xbgr.mr_n68858304)
print v(xbgr.mr_n68858416)
print v(xbgr.mr_n68858736)
print v(xbgr.mr_n68858848)
print v(xbgr.mr_n68859168)
print v(xbgr.mr_n68859280)
print v(xbgr.mr_n68859600)
print v(xbgr.mr_n68859712)
print v(xbgr.mr_n68860032)
print v(xbgr.mr_n68860144)
print v(xbgr.mr_n68860464)
print v(xbgr.mr_n68860576)
print v(xbgr.mr_n68860896)
print v(xbgr.mr_n68861008)
print v(xbgr.mr_n68861328)
print v(xbgr.mr_n68861440)
print v(xbgr.mr_n68861760)
print v(xbgr.mr_n68861872)
print v(xbgr.mr_n68862192)
print v(xbgr.mr_n68862304)
print v(xbgr.mr_n68862624)
print v(xbgr.mr_n68862736)
print v(xbgr.mr_n68863056)
print v(xbgr.mr_n68863168)
print v(xbgr.mr_n68863488)
print v(xbgr.mr_n68863600)
print v(xbgr.mr_n68863920)
print v(xbgr.mr_n68864032)
print v(xbgr.mr_n68864352)
print v(xbgr.mr_n68864464)
print v(xbgr.mr_n68864784)
print v(xbgr.mr_n68864896)
print v(xbgr.mr_n68865216)
print v(xbgr.mr_n68865328)
print v(xbgr.mr_n68865648)
print v(xbgr.mr_n68865760)
print v(xbgr.mr_n68866080)
print v(xbgr.mr_n68866192)
print v(xbgr.mr_n68866512)
print v(xbgr.mr_n68866624)
print v(xbgr.mr_n68866944)
print v(xbgr.mr_n68867056)
print v(xbgr.mr_n68867376)
print v(xbgr.mr_n68867488)
print v(xbgr.mr_n68867808)
print v(xbgr.mr_n68867920)
print v(xbgr.mr_n68868240)
print v(xbgr.mr_n68868352)
print v(xbgr.mr_n68868672)
print v(xbgr.mr_n68868784)
print v(xbgr.mr_n68869104)
print v(xbgr.mr_n68869216)
print v(xbgr.mr_n68869536)
print v(xbgr.mr_n68869648)
print v(xbgr.mr_n68869968)
print v(xbgr.mr_n68870080)
print v(xbgr.mr_n68870400)
print v(xbgr.mr_n68870512)
print v(xbgr.mr_n68870832)
print v(xbgr.mr_n68870944)
print v(xbgr.mr_n68871264)
print v(xbgr.mr_n68871376)
print v(xbgr.mr_n68871696)
print v(xbgr.mr_n68871808)
print v(xbgr.mr_n68872128)
print v(xbgr.mr_n68872240)
print v(xbgr.mr_n68872560)
print v(xbgr.mr_n68872672)
print v(xbgr.mr_n68872992)
print v(xbgr.mr_n68873104)
print v(xbgr.mr_n68873424)
print v(xbgr.mr_n68873536)
print v(xbgr.mr_n68873856)
print v(xbgr.mr_n68873968)
print v(xbgr.mr_n68874288)
print v(xbgr.mr_n68874400)
print v(xbgr.mr_n68874720)
print v(xbgr.mr_n68874832)
print v(xbgr.mr_n68875152)
print v(xbgr.mr_n68875264)
print v(xbgr.mr_n68875584)
print v(xbgr.mr_n68875696)
print v(xbgr.mr_n68876016)
print v(xbgr.mr_n68876128)
print v(xbgr.mr_n68876448)
print v(xbgr.mr_n68876560)
print v(xbgr.mr_n68876880)
print v(xbgr.mr_n68876992)
print v(xbgr.mr_n68877312)
print v(xbgr.mr_n68877424)
print v(xbgr.mr_n68877744)
print v(xbgr.mr_n68877856)
print v(xbgr.mr_n68878176)
print v(xbgr.mr_n68878288)
print v(xbgr.mr_n68878608)
print v(xbgr.mr_n68878720)
print v(xbgr.mr_n68879040)
print v(xbgr.mr_n68879152)
print v(xbgr.mr_n68879472)
print v(xbgr.mr_n68879584)
print v(xbgr.mr_n68879904)
print v(xbgr.mr_n68880016)
print v(xbgr.mr_n68880336)
print v(xbgr.mr_n68880448)
print v(xbgr.mr_n68880768)
print v(xbgr.mr_n68880880)
print v(xbgr.mr_n68881200)
print v(xbgr.mr_n68881312)
print v(xbgr.mr_n68881632)
print v(xbgr.mr_n68881744)
print v(xbgr.mr_n68882064)
print v(xbgr.mr_n68882176)
print v(xbgr.mr_n68882496)
print v(xbgr.mr_n68882608)
print v(xbgr.mr_n68882928)
print v(xbgr.mr_n68883040)
print v(xbgr.mr_n68883472)
print v(xbgr.mr_n68883792)
print v(xbgr.mr_n68883904)
print v(xbgr.mr_n68884224)
print v(xbgr.mr_n68884336)
print v(xbgr.mr_n68884656)
print v(xbgr.mr_n68884768)
print v(xbgr.mr_n68885200)
print v(xbgr.mr_n68885520)
print v(xbgr.mr_n68885632)
print v(xbgr.mr_n68885952)
print v(xbgr.mr_n68886064)
print v(xbgr.mr_n68886384)
print v(xbgr.mr_n68886496)
print v(xbgr.mr_n68886928)
print v(xbgr.mr_n68887248)
print v(xbgr.mr_n68887360)
print v(xbgr.mr_n68887680)
print v(xbgr.mr_n68887792)
print v(xbgr.mr_n68888112)
print v(xbgr.mr_n68888224)
print v(xbgr.mr_n68888544)
print v(xbgr.mr_n68888656)
print v(xbgr.mr_n68888976)
print v(xbgr.mr_n68889088)
print v(xbgr.mr_n68889408)
print v(xbgr.mr_n68889520)
print v(xbgr.mr_n68889840)
print v(xbgr.mr_n68889952)
print v(xbgr.mr_n68890272)
print v(xbgr.mr_n68890384)
print v(xbgr.mr_n68890704)
print v(xbgr.mr_n68890816)
print v(xbgr.mr_n68891248)
print v(xbgr.mr_n68891568)
print v(xbgr.mr_n68891680)
print v(xbgr.mr_n68892112)
print v(xbgr.mr_n68892432)
print v(xbgr.mr_n68892544)
print v(xbgr.mr_n68892976)
print v(xbgr.mr_n68893296)
print v(xbgr.mr_n68893408)
print v(xbgr.mr_n68893728)
print v(xbgr.mr_n68893840)
print v(xbgr.mr_n68894160)
print v(xbgr.mr_n68894272)
print v(xbgr.mr_n68894704)
print v(xbgr.mr_n68895024)
print v(xbgr.mr_n68895136)
print v(xbgr.mr_n68895456)
print v(xbgr.mr_n68895568)
print v(xbgr.mr_n68895888)
print v(xbgr.mr_n68896000)
print v(xbgr.mr_n68896320)
print v(xbgr.mr_n68896432)
print v(xbgr.mr_n68896752)
print v(xbgr.mr_n68896864)
print v(xbgr.mr_n68897296)
print v(xbgr.mr_n68897616)
print v(xbgr.mr_n68897728)
print v(xbgr.mr_n68898048)
print v(xbgr.mr_n68898160)
print v(xbgr.mr_n68898480)
print v(xbgr.mr_n68898592)
print v(xbgr.mr_n68898912)
print v(xbgr.mr_n68899024)
print v(xbgr.mr_n68899344)
print v(xbgr.mr_n68899456)
print v(xbgr.mr_n68899776)
print v(xbgr.mr_n68899888)
print v(xbgr.mr_n68900208)
print v(xbgr.mr_n68900320)
print v(xbgr.mr_n68900640)
print v(xbgr.mr_n68900752)
print v(xbgr.mr_n68901072)
print v(xbgr.mr_n68901184)
print v(xbgr.mr_n68901504)
print v(xbgr.mr_n68901616)
print v(xbgr.mr_n68901936)
print v(xbgr.mr_n68902048)
print v(xbgr.mr_n68902368)
print v(xbgr.mr_n68902480)
print v(xbgr.mr_n68902800)
print v(xbgr.mr_n68902912)
print v(xbgr.mr_n68903232)
print v(xbgr.mr_n68903344)
print v(xbgr.mr_n68903664)
print v(xbgr.mr_n68903776)
print v(xbgr.mr_n68904096)
print v(xbgr.mr_n68904208)
print v(xbgr.mr_n68904528)
print v(xbgr.mr_n68904640)
print v(xbgr.mr_n68904960)
print v(xbgr.mr_n68905072)
print v(xbgr.mr_n68905392)
print v(xbgr.mr_n68905504)
print v(xbgr.mr_n68905824)
print v(xbgr.mr_n68905936)
print v(xbgr.mr_n68906256)
print v(xbgr.mr_n68906368)
print v(xbgr.mr_n68906688)
print v(xbgr.mr_n68906800)
print v(xbgr.mr_n68907120)
print v(xbgr.mr_n68907232)
print v(xbgr.mr_n68907552)
print v(xbgr.mr_n68907664)
print v(xbgr.mr_n68907984)
print v(xbgr.mr_n68908096)
print v(xbgr.mr_n68908416)
print v(xbgr.mr_n68908528)
print v(xbgr.mr_n68908848)
print v(xbgr.mr_n68908960)
print v(xbgr.mr_n68909280)
print v(xbgr.mr_n68909392)
print v(xbgr.mr_n68909712)
print v(xbgr.mr_n68909824)
print v(xbgr.mr_n68910144)
print v(xbgr.mr_n68910256)
print v(xbgr.mr_n68910576)
print v(xbgr.mr_n68910688)
print v(xbgr.mr_n68911008)
print v(xbgr.mr_n68911120)
print v(xbgr.mr_n68911440)
print v(xbgr.mr_n68911552)
print v(xbgr.mr_n68911872)
print v(xbgr.mr_n68911984)
print v(xbgr.mr_n68912304)
print v(xbgr.mr_n68912416)
print v(xbgr.mr_n68912736)
print v(xbgr.mr_n68912848)
print v(xbgr.mr_n68913168)
print v(xbgr.mr_n68913280)
print v(xbgr.mr_n68913600)
print v(xbgr.mr_n68913712)
print v(xbgr.mr_n68914032)
print v(xbgr.mr_n68914144)
print v(xbgr.mr_n68914464)
print v(xbgr.mr_n68914576)
print v(xbgr.mr_n68914896)
print v(xbgr.mr_n68915008)
print v(xbgr.mr_n68915328)
print v(xbgr.mr_n68915440)
print v(xbgr.mr_n68915760)
print v(xbgr.mr_n68915872)
print v(xbgr.mr_n68916192)
print v(xbgr.mr_n68916304)
print v(xbgr.mr_n68916624)
print v(xbgr.mr_n68916736)
print v(xbgr.mr_n68917056)
print v(xbgr.mr_n68917168)
print v(xbgr.mr_n68917488)
print v(xbgr.mr_n68917600)
print v(xbgr.mr_n68917920)
print v(xbgr.mr_n68918032)
print v(xbgr.mr_n68918352)
print v(xbgr.mr_n68918464)
print v(xbgr.mr_n68918784)
print v(xbgr.mr_n68918896)
print v(xbgr.mr_n68919216)
print v(xbgr.mr_n68919328)
print v(xbgr.mr_n68919648)
print v(xbgr.mr_n68919760)
print v(xbgr.mr_n68920080)
print v(xbgr.mr_n68920192)
print v(xbgr.mr_n68920512)
print v(xbgr.mr_n68920624)
print v(xbgr.mr_n68920944)
print v(xbgr.mr_n68921056)
print v(xbgr.mr_n68921376)
print v(xbgr.mr_n68921488)
print v(xbgr.mr_n68921808)
print v(xbgr.mr_n68921920)
print v(xbgr.mr_n68922240)
print v(xbgr.mr_n68922352)
print v(xbgr.mr_n68922672)
print v(xbgr.mr_n68922784)
print v(xbgr.mr_n68923104)
print v(xbgr.mr_n68923216)
print v(xbgr.mr_n68923536)
print v(xbgr.mr_n68923648)
print v(xbgr.mr_n68923968)
print v(xbgr.mr_n68924080)
print v(xbgr.mr_n68924400)
print v(xbgr.mr_n68924512)
print v(xbgr.mr_n68924832)
print v(xbgr.mr_n68924944)
print v(xbgr.mr_n68925264)
print v(xbgr.mr_n68925376)
print v(xbgr.mr_n68925696)
print v(xbgr.mr_n68925808)
print v(xbgr.mr_n68926128)
print v(xbgr.mr_n68926240)
print v(xbgr.mr_n68926560)
print v(xbgr.mr_n68926672)
print v(xbgr.mr_n68926992)
print v(xbgr.mr_n68927104)
print v(xbgr.mr_n68927424)
print v(xbgr.mr_n68927536)
print v(xbgr.mr_n68927856)
print v(xbgr.mr_n68927968)
print v(xbgr.mr_n68928288)
print v(xbgr.mr_n68928400)
print v(xbgr.mr_n68928720)
print v(xbgr.mr_n68928832)
print v(xbgr.mr_n68929152)
print v(xbgr.mr_n68929264)
print v(xbgr.mr_n68929584)
print v(xbgr.mr_n68929696)
print v(xbgr.mr_n68930016)
print v(xbgr.mr_n68930128)
print v(xbgr.mr_n68930448)
print v(xbgr.mr_n68930560)
print v(xbgr.mr_n68930880)
print v(xbgr.mr_n68930992)
print v(xbgr.mr_n68931312)
print v(xbgr.mr_n68931424)
print v(xbgr.mr_n68931744)
print v(xbgr.mr_n68931856)
print v(xbgr.mr_n68932176)
print v(xbgr.mr_n68932288)
print v(xbgr.mr_n68932608)
print v(xbgr.mr_n68932720)
print v(xbgr.mr_n68933040)
print v(xbgr.mr_n68933152)
print v(xbgr.mr_n68933472)
print v(xbgr.mr_n68933584)
print v(xbgr.mr_n68933904)
print v(xbgr.mr_n68934016)
print v(xbgr.mr_n68934336)
print v(xbgr.mr_n68934448)
print v(xbgr.mr_n68934768)
print v(xbgr.mr_n68934880)
print v(xbgr.mr_n68935200)
print v(xbgr.mr_n68935312)
print v(xbgr.mr_n68935632)
print v(xbgr.mr_n68935744)
print v(xbgr.mr_n68936064)
print v(xbgr.mr_n68936176)
print v(xbgr.mr_n68936496)
print v(xbgr.mr_n68936608)
print v(xbgr.mr_n68936928)
print v(xbgr.mr_n68937040)
print v(xbgr.mr_n68937360)
print v(xbgr.mr_n68937472)
print v(xbgr.mr_n68937792)
print v(xbgr.mr_n68937904)
print v(xbgr.mr_n68938224)
print v(xbgr.mr_n68938336)
print v(xbgr.mr_n68938656)
print v(xbgr.mr_n68938768)
print v(xbgr.mr_n68939088)
print v(xbgr.mr_n68939200)
print v(xbgr.mr_n68939520)
print v(xbgr.mr_n68939632)
print v(xbgr.mr_n68939952)
print v(xbgr.mr_n68940064)
print v(xbgr.mr_n68940384)
print v(xbgr.mr_n68940496)
print v(xbgr.mr_n68940816)
print v(xbgr.mr_n68940928)
print v(xbgr.mr_n68941248)
print v(xbgr.mr_n68941360)
print v(xbgr.mr_n68941680)
print v(xbgr.mr_n68941792)
print v(xbgr.mr_n68942112)
print v(xbgr.mr_n68942224)
print v(xbgr.mr_n68942544)
print v(xbgr.mr_n68942656)
print v(xbgr.mr_n68942976)
print v(xbgr.mr_n68943088)
print v(xbgr.mr_n68943408)
print v(xbgr.mr_n68943520)
print v(xbgr.mr_n68943840)
print v(xbgr.mr_n68943952)
print v(xbgr.mr_n68944272)
print v(xbgr.mr_n68944384)
print v(xbgr.mr_n68944704)
print v(xbgr.mr_n68944816)
print v(xbgr.mr_n68945136)
print v(xbgr.mr_n68945248)
print v(xbgr.mr_n68945568)
print v(xbgr.mr_n68945680)
print v(xbgr.mr_n68946000)
print v(xbgr.mr_n68946112)
print v(xbgr.mr_n68946432)
print v(xbgr.mr_n68946544)
print v(xbgr.mr_n68946864)
print v(xbgr.mr_n68946976)
print v(xbgr.mr_n68947296)
print v(xbgr.mr_n68947408)
print v(xbgr.mr_n68947728)
print v(xbgr.mr_n68947840)
print v(xbgr.mr_n68948160)
print v(xbgr.mr_n68948272)
print v(xbgr.mr_n68948592)
print v(xbgr.mr_n68948704)
print v(xbgr.mr_n68949024)
print v(xbgr.mr_n68949136)
print v(xbgr.mr_n68949456)
print v(xbgr.mr_n68949568)
print v(xbgr.mr_n68949888)
print v(xbgr.mr_n68950000)
print v(xbgr.mr_n68950320)
print v(xbgr.mr_n68950432)
print v(xbgr.mr_n68950752)
print v(xbgr.mr_n68950864)
print v(xbgr.mr_n68951184)
print v(xbgr.mr_n68951296)
print v(xbgr.mr_n68951616)
print v(xbgr.mr_n68951728)
print v(xbgr.mr_n68952048)
print v(xbgr.mr_n68952160)
print v(xbgr.mr_n68952480)
print v(xbgr.mr_n68952592)
print v(xbgr.mr_n68952912)
print v(xbgr.mr_n68953024)
print v(xbgr.mr_n68953344)
print v(xbgr.mr_n68953456)
print v(xbgr.mr_n68953776)
print v(xbgr.mr_n68953888)
print v(xbgr.mr_n68954208)
print v(xbgr.mr_n68954320)
print v(xbgr.mr_n68954640)
print v(xbgr.mr_n68954752)
print v(xbgr.mr_n68955072)
print v(xbgr.mr_n68955184)
print v(xbgr.mr_n68955504)
print v(xbgr.mr_n68955616)
print v(xbgr.mr_n68955936)
print v(xbgr.mr_n68956048)
print v(xbgr.mr_n68956368)
print v(xbgr.mr_n68956480)
print v(xbgr.mr_n68956800)
print v(xbgr.mr_n68956912)
print v(xbgr.mr_n68957232)
print v(xbgr.mr_n68957344)
print v(xbgr.mr_n68957664)
print v(xbgr.mr_n68957776)
print v(xbgr.mr_n68958096)
print v(xbgr.mr_n68958208)
print v(xbgr.mr_n68958528)
print v(xbgr.mr_n68958640)
print v(xbgr.mr_n68958960)
print v(xbgr.mr_n68959072)
print v(xbgr.mr_n68959392)
print v(xbgr.mr_n68959504)
print v(xbgr.mr_n68959824)
print v(xbgr.mr_n68959936)
print v(xbgr.mr_n68960256)
print v(xbgr.mr_n68960368)
print v(xbgr.mr_n68960688)
print v(xbgr.mr_n68960800)
print v(xbgr.mr_n68961120)
print v(xbgr.mr_n68961232)
print v(xbgr.mr_n68961552)
print v(xbgr.mr_n68961664)
print v(xbgr.mr_n68961984)
print v(xbgr.mr_n68962096)
print v(xbgr.mr_n68962416)
print v(xbgr.mr_n68962528)
print v(xbgr.mr_n68962848)
print v(xbgr.mr_n68962960)
print v(xbgr.mr_n68963280)
print v(xbgr.mr_n68963392)
print v(xbgr.mr_n68963712)
print v(xbgr.mr_n68963824)
print v(xbgr.mr_n68964144)
print v(xbgr.mr_n68964256)
print v(xbgr.mr_n68964576)
print v(xbgr.mr_n68964688)
print v(xbgr.mr_n68965008)
print v(xbgr.mr_n68965120)
print v(xbgr.mr_n68965440)
print v(xbgr.mr_n68965552)
print v(xbgr.mr_n68965872)
print v(xbgr.mr_n68965984)
print v(xbgr.mr_n68966304)
print v(xbgr.mr_n68966416)
print v(xbgr.mr_n68966736)
print v(xbgr.mr_n68966848)
print v(xbgr.mr_n68967168)
print v(xbgr.mr_n68967280)
print v(xbgr.mr_n68967600)
print v(xbgr.mr_n68967712)
print v(xbgr.mr_n68968032)
print v(xbgr.mr_n68968144)
print v(xbgr.mr_n68968464)
print v(xbgr.mr_n68968576)
print v(xbgr.mr_n68968896)
print v(xbgr.mr_n68969008)
print v(xbgr.mr_n68969328)
print v(xbgr.mr_n68969440)
print v(xbgr.mr_n68969760)
print v(xbgr.mr_n68969872)
print v(xbgr.mr_n68970192)
print v(xbgr.mr_n68970304)
print v(xbgr.mr_n68970624)
print v(xbgr.mr_n68970736)
print v(xbgr.mr_n68971056)
print v(xbgr.mr_n68971168)
print v(xbgr.mr_n68971488)
print v(xbgr.mr_n68971600)
print v(xbgr.mr_n68971920)
print v(xbgr.mr_n68972032)
print v(xbgr.mr_n68972464)
print v(xbgr.mr_n68972784)
print v(xbgr.mr_n68972896)
print v(xbgr.mr_n68973328)
print v(xbgr.mr_n68973648)
print v(xbgr.mr_n68973760)
print v(xbgr.mr_n68974192)
print v(xbgr.mr_n68974512)
print v(xbgr.mr_n68975376)
print v(xbgr.mr_n68975488)
print v(xbgr.mr_n68975920)
print v(xbgr.mr_n68976240)
print v(xbgr.mr_n68976352)
print v(xbgr.mr_n68976672)
print v(xbgr.mr_n68976784)
print v(xbgr.mr_n68977104)
print v(xbgr.mr_n68977216)
print v(xbgr.mr_n68977536)
print v(xbgr.mr_n68977648)
print v(xbgr.mr_n68977968)
print v(xbgr.mr_n68978080)
print v(xbgr.mr_n68978400)
print v(xbgr.mr_n68978512)
print v(xbgr.mr_n68978832)
print v(xbgr.mr_n68978944)
print v(xbgr.mr_n68979264)
print v(xbgr.mr_n68979376)
print v(xbgr.mr_n68979696)
print v(xbgr.mr_n68980560)
print v(xbgr.mr_n68981424)
print v(xbgr.mr_n68981536)
print v(xbgr.mr_n68981856)
print v(xbgr.mr_n68981968)
print v(xbgr.mr_n68982288)
print v(xbgr.mr_n68983152)
print v(xbgr.mr_n68983264)
print v(xbgr.mr_n68983584)
print v(xbgr.mr_n68983696)
print v(xbgr.mr_n68984016)
print v(xbgr.mr_n68984128)
print v(xbgr.mr_n68984448)
print v(xbgr.mr_n68984560)
print v(xbgr.mr_n68984880)
print v(xbgr.mr_n68984992)
print v(xbgr.mr_n68985312)
print v(xbgr.mr_n68985424)
print v(xbgr.mr_n68985744)
print v(xbgr.mr_n68985856)
print v(xbgr.mr_n68986176)
print v(xbgr.mr_n68986288)
print v(xbgr.mr_n68986608)
print v(xbgr.mr_n68986720)
print v(xbgr.mr_n68987040)
print v(xbgr.mr_n68987152)
print v(xbgr.mr_n68987472)
print v(xbgr.mr_n68987584)
print v(xbgr.mr_n68987904)
print v(xbgr.mr_n68988016)
print v(xbgr.mr_n68988336)
print v(xbgr.mr_n68988448)
print v(xbgr.mr_n68988768)
print v(xbgr.mr_n68988880)
print v(xbgr.mr_n68989200)
print v(xbgr.mr_n68989312)
print v(xbgr.mr_n68989632)
print v(xbgr.mr_n68989744)
print v(xbgr.mr_n68990064)
print v(xbgr.mr_n68990176)
print v(xbgr.mr_n68990496)
print v(xbgr.mr_n68990608)
print v(xbgr.mr_n68990928)
print v(xbgr.mr_n68991040)
print v(xbgr.mr_n68991360)
print v(xbgr.mr_n68991472)
print v(xbgr.mr_n68991792)
print v(xbgr.mr_n68991904)
print v(xbgr.mr_n68992224)
print v(xbgr.mr_n68992336)
print v(xbgr.mr_n68992656)
print v(xbgr.mr_n68992768)
print v(xbgr.mr_n68993088)
print v(xbgr.mr_n68993200)
print v(xbgr.mr_n68993520)
print v(xbgr.mr_n68993632)
print v(xbgr.mr_n68994064)
print v(xbgr.mr_n68994384)
print v(xbgr.mr_n68994496)
print v(xbgr.mr_n68994816)
print v(xbgr.mr_n68994928)
print v(xbgr.mr_n68995248)
print v(xbgr.mr_n68995360)
print v(xbgr.mr_n68995680)
print v(xbgr.mr_n68995792)
print v(xbgr.mr_n68996112)
print v(xbgr.mr_n68996224)
print v(xbgr.mr_n68996544)
print v(xbgr.mr_n68996656)
print v(xbgr.mr_n68996976)
print v(xbgr.mr_n68997088)
print v(xbgr.mr_n68997408)
print v(xbgr.mr_n68997520)
print v(xbgr.mr_n68997840)
print v(xbgr.mr_n68997952)
print v(xbgr.mr_n68998272)
print v(xbgr.mr_n68998384)
print v(xbgr.mr_n68998704)
print v(xbgr.mr_n68998816)
print v(xbgr.mr_n68999136)
print v(xbgr.mr_n68999248)
print v(xbgr.mr_n68999568)
print v(xbgr.mr_n68999680)
print v(xbgr.mr_n69000000)
print v(xbgr.mr_n69000112)
print v(xbgr.mr_n69000432)
print v(xbgr.mr_n69001296)
print v(xbgr.mr_n69001408)
print v(xbgr.mr_n69001728)
print v(xbgr.mr_n69001840)
print v(xbgr.mr_n69002160)
print v(xbgr.mr_n69002272)
print v(xbgr.mr_n69002592)
print v(xbgr.mr_n69002704)
print v(xbgr.mr_n69003024)
print v(xbgr.mr_n69003136)
print v(xbgr.mr_n69003456)
print v(xbgr.mr_n69003568)
print v(xbgr.mr_n69003888)
print v(xbgr.mr_n69004000)
print v(xbgr.mr_n69004320)
print v(xbgr.mr_n69004432)
print v(xbgr.mr_n69004752)
print v(xbgr.mr_n69004864)
print v(xbgr.mr_n69005184)
print v(xbgr.mr_n69005296)
print v(xbgr.mr_n69005616)
print v(xbgr.mr_n69005728)
print v(xbgr.mr_n69006048)
print v(xbgr.mr_n69006160)
print v(xbgr.mr_n69006480)
print v(xbgr.mr_n69006592)
print v(xbgr.mr_n69006912)
print v(xbgr.mr_n69007024)
print v(xbgr.mr_n69007344)
print v(xbgr.mr_n69007456)
print v(xbgr.mr_n69007776)
print v(xbgr.mr_n69007888)
print v(xbgr.mr_n69008208)
print v(xbgr.mr_n69008320)
print v(xbgr.mr_n69008640)
print v(xbgr.mr_n69008752)
print v(xbgr.mr_n69009072)
print v(xbgr.mr_n69009184)
print v(xbgr.mr_n69009504)
print v(xbgr.mr_n69009616)
print v(xbgr.mr_n69009936)
print v(xbgr.mr_n69010048)
print v(xbgr.mr_n69010368)
print v(xbgr.mr_n69010480)
print v(xbgr.mr_n69010800)
print v(xbgr.mr_n69010912)
print v(xbgr.mr_n69011232)
print v(xbgr.mr_n69011344)
print v(xbgr.mr_n69011664)
print v(xbgr.mr_n69011776)
print v(xbgr.mr_n69012096)
print v(xbgr.mr_n69012208)
print v(xbgr.mr_n69012528)
print v(xbgr.mr_n69012640)
print v(xbgr.mr_n69012960)
print v(xbgr.mr_n69013072)
print v(xbgr.mr_n69013392)
print v(xbgr.mr_n69013504)
print v(xbgr.mr_n69013824)
print v(xbgr.mr_n69013936)
print v(xbgr.mr_n69014256)
print v(xbgr.mr_n69014368)
print v(xbgr.mr_n69014688)
print v(xbgr.mr_n69014800)
print v(xbgr.mr_n69015120)
print v(xbgr.mr_n69015232)
print v(xbgr.mr_n69015552)
print v(xbgr.mr_n69015664)
print v(xbgr.mr_n69015984)
print v(xbgr.mr_n69016096)
print v(xbgr.mr_n69016416)
print v(xbgr.mr_n69016528)
print v(xbgr.mr_n69016848)
print v(xbgr.mr_n69016960)
print v(xbgr.mr_n69017280)
print v(xbgr.mr_n69017392)
print v(xbgr.mr_n69017712)
print v(xbgr.mr_n69017824)
print v(xbgr.mr_n69018144)
print v(xbgr.mr_n69018256)
print v(xbgr.mr_n69018576)
print v(xbgr.mr_n69018688)
print v(xbgr.mr_n69019008)
print v(xbgr.mr_n69019120)
print v(xbgr.mr_n69019440)
print v(xbgr.mr_n69019552)
print v(xbgr.mr_n69019872)
print v(xbgr.mr_n69019984)
print v(xbgr.mr_n69020304)
print v(xbgr.mr_n69020416)
print v(xbgr.mr_n69020736)
print v(xbgr.mr_n69020848)
print v(xbgr.mr_n69021168)
print v(xbgr.mr_n69021280)
print v(xbgr.mr_n69021600)
print v(xbgr.mr_n69021712)
print v(xbgr.mr_n69022032)
print v(xbgr.mr_n69022144)
print v(xbgr.mr_n69022464)
print v(xbgr.mr_n69022576)
print v(xbgr.mr_n69022896)
print v(xbgr.mr_n69023008)
print v(xbgr.mr_n69023328)
print v(xbgr.mr_n69023440)
print v(xbgr.mr_n69023760)
print v(xbgr.mr_n69023872)
print v(xbgr.mr_n69024192)
print v(xbgr.mr_n69024304)
print v(xbgr.mr_n69024624)
print v(xbgr.mr_n69024736)
print v(xbgr.mr_n69025056)
print v(xbgr.mr_n69025168)
print v(xbgr.mr_n69025488)
print v(xbgr.mr_n69025600)
print v(xbgr.mr_n69025920)
print v(xbgr.mr_n69026032)
print v(xbgr.mr_n69026352)
print v(xbgr.mr_n69026464)
print v(xbgr.mr_n69026784)
print v(xbgr.mr_n69026896)
print v(xbgr.mr_n69027216)
print v(xbgr.mr_n69027328)
print v(xbgr.mr_n69027648)
print v(xbgr.mr_n69027760)
print v(xbgr.mr_n69028080)
print v(xbgr.mr_n69028192)
print v(xbgr.mr_n69028512)
print v(xbgr.mr_n69028624)
print v(xbgr.mr_n69028944)
print v(xbgr.mr_n69029056)
print v(xbgr.mr_n69029376)
print v(xbgr.mr_n69029488)
print v(xbgr.mr_n69029808)
print v(xbgr.mr_n69029920)
print v(xbgr.mr_n69030240)
print v(xbgr.mr_n69030352)
print v(xbgr.mr_n69030672)
print v(xbgr.mr_n69030784)
print v(xbgr.mr_n69031104)
print v(xbgr.mr_n69031216)
print v(xbgr.mr_n69031536)
print v(xbgr.mr_n69031648)
print v(xbgr.mr_n69031968)
print v(xbgr.mr_n69032080)
print v(xbgr.mr_n69032400)
print v(xbgr.mr_n69032512)
print v(xbgr.mr_n69032832)
print v(xbgr.mr_n69032944)
print v(xbgr.mr_n69033264)
print v(xbgr.mr_n69033376)
print v(xbgr.mr_n69033696)
print v(xbgr.mr_n69033808)
print v(xbgr.mr_n69034128)
print v(xbgr.mr_n69034240)
print v(xbgr.mr_n69034560)
print v(xbgr.mr_n69034672)
print v(xbgr.mr_n69034992)
print v(xbgr.mr_n69035104)
print v(xbgr.mr_n69035424)
print v(xbgr.mr_n69035536)
print v(xbgr.mr_n69035856)
print v(xbgr.mr_n69035968)
print v(xbgr.mr_n69036288)
print v(xbgr.mr_n69036400)
print v(xbgr.mr_n69036720)
print v(xbgr.mr_n69036832)
print v(xbgr.mr_n69037152)
print v(xbgr.mr_n69037264)
print v(xbgr.mr_n69037584)
print v(xbgr.mr_n69037696)
print v(xbgr.mr_n69038016)
print v(xbgr.mr_n69038128)
print v(xbgr.mr_n69038448)
print v(xbgr.mr_n69038560)
print v(xbgr.mr_n69038880)
print v(xbgr.mr_n69038992)
print v(xbgr.mr_n69039312)
print v(xbgr.mr_n69039424)
print v(xbgr.mr_n69039744)
print v(xbgr.mr_n69039856)
print v(xbgr.mr_n69040176)
print v(xbgr.mr_n69040288)
print v(xbgr.mr_n69040608)
print v(xbgr.mr_n69040720)
print v(xbgr.mr_n69041040)
print v(xbgr.mr_n69041152)
print v(xbgr.mr_n69041472)
print v(xbgr.mr_n69041584)
print v(xbgr.mr_n69041904)
print v(xbgr.mr_n69042016)
print v(xbgr.mr_n69042336)
print v(xbgr.mr_n69042448)
print v(xbgr.mr_n69042768)
print v(xbgr.mr_n69042880)
print v(xbgr.mr_n69043200)
print v(xbgr.mr_n69043312)
print v(xbgr.mr_n69043632)
print v(xbgr.mr_n69043744)
print v(xbgr.mr_n69044064)
print v(xbgr.mr_n69044176)
print v(xbgr.mr_n69044496)
print v(xbgr.mr_n69044608)
print v(xbgr.mr_n69044928)
print v(xbgr.mr_n69045040)
print v(xbgr.mr_n69045360)
print v(xbgr.mr_n69045472)
print v(xbgr.mr_n69045792)
print v(xbgr.mr_n69045904)
print v(xbgr.mr_n69046224)
print v(xbgr.mr_n69046336)
print v(xbgr.mr_n69046656)
print v(xbgr.mr_n69046768)
print v(xbgr.mr_n69047088)
print v(xbgr.mr_n69047200)
print v(xbgr.mr_n69047520)
print v(xbgr.mr_n69047632)
print v(xbgr.mr_n69047952)
print v(xbgr.mr_n69048064)
print v(xbgr.mr_n69048384)
print v(xbgr.mr_n69048496)
print v(xbgr.mr_n69048816)
print v(xbgr.mr_n69048928)
print v(xbgr.mr_n69049248)
print v(xbgr.mr_n69049360)
print v(xbgr.mr_n69049680)
print v(xbgr.mr_n69049792)
print v(xbgr.mr_n69050112)
print v(xbgr.mr_n69050224)
print v(xbgr.mr_n69050544)
print v(xbgr.mr_n69050656)
print v(xbgr.mr_n69050976)
print v(xbgr.mr_n69051088)
print v(xbgr.mr_n69051408)
print v(xbgr.mr_n69051520)
print v(xbgr.mr_n69051840)
print v(xbgr.mr_n69051952)
print v(xbgr.mr_n69052272)
print v(xbgr.mr_n69052384)
print v(xbgr.mr_n69052704)
print v(xbgr.mr_n69052816)
print v(xbgr.mr_n69053136)
print v(xbgr.mr_n69053248)
print v(xbgr.mr_n69053568)
print v(xbgr.mr_n69053680)
print v(xbgr.mr_n69054000)
print v(xbgr.mr_n69054112)
print v(xbgr.mr_n69054432)
print v(xbgr.mr_n69054544)
print v(xbgr.mr_n69054864)
print v(xbgr.mr_n69054976)
print v(xbgr.mr_n69055296)
print v(xbgr.mr_n69055408)
print v(xbgr.mr_n69055728)
print v(xbgr.mr_n69055840)
print v(xbgr.mr_n69056160)
print v(xbgr.mr_n69056272)
print v(xbgr.mr_n69056592)
print v(xbgr.mr_n69056704)
print v(xbgr.mr_n69057024)
print v(xbgr.mr_n69057136)
print v(xbgr.mr_n69057456)
print v(xbgr.mr_n69057568)
print v(xbgr.mr_n69057888)
print v(xbgr.mr_n69058000)
print v(xbgr.mr_n69058320)
print v(xbgr.mr_n69058432)
print v(xbgr.mr_n69058752)
print v(xbgr.mr_n69058864)
print v(xbgr.mr_n69059184)
print v(xbgr.mr_n69059296)
print v(xbgr.mr_n69059616)
print v(xbgr.mr_n69059728)
print v(xbgr.mr_n69060048)
print v(xbgr.mr_n69060160)
print v(xbgr.mr_n69060480)
print v(xbgr.mr_n69060592)
print v(xbgr.mr_n69060912)
print v(xbgr.mr_n69061024)
print v(xbgr.mr_n69061344)
print v(xbgr.mr_n69061456)
print v(xbgr.mr_n69061776)
print v(xbgr.mr_n69061888)
print v(xbgr.mr_n69062208)
print v(xbgr.mr_n69062320)
print v(xbgr.mr_n69062640)
print v(xbgr.mr_n69062752)
print v(xbgr.mr_n69063072)
print v(xbgr.mr_n69063184)
print v(xbgr.mr_n69063504)
print v(xbgr.mr_n69063616)
print v(xbgr.mr_n69063936)
print v(xbgr.mr_n69064048)
print v(xbgr.mr_n69064368)
print v(xbgr.mr_n69064480)
print v(xbgr.mr_n69064800)
print v(xbgr.mr_n69064912)
print v(xbgr.mr_n69065232)
print v(xbgr.mr_n69065344)
print v(xbgr.mr_n69065664)
print v(xbgr.mr_n69065776)
print v(xbgr.mr_n69066096)
print v(xbgr.mr_n69066208)
print v(xbgr.mr_n69066528)
print v(xbgr.mr_n69066640)
print v(xbgr.mr_n69066960)
print v(xbgr.mr_n69067072)
print v(xbgr.mr_n69067392)
print v(xbgr.mr_n69067504)
print v(xbgr.mr_n69067824)
print v(xbgr.mr_n69067936)
print v(xbgr.mr_n69068256)
print v(xbgr.mr_n69068368)
print v(xbgr.mr_n69068688)
print v(xbgr.mr_n69068800)
print v(xbgr.mr_n69069120)
print v(xbgr.mr_n69069232)
print v(xbgr.mr_n69069552)
print v(xbgr.mr_n69069664)
print v(xbgr.mr_n69069984)
print v(xbgr.mr_n69070096)
print v(xbgr.mr_n69070416)
print v(xbgr.mr_n69070528)
print v(xbgr.mr_n69070848)
print v(xbgr.mr_n69070960)
print v(xbgr.mr_n69071280)
print v(xbgr.mr_n69071392)
print v(xbgr.mr_n69071712)
print v(xbgr.mr_n69071824)
print v(xbgr.mr_n69072144)
print v(xbgr.mr_n69072256)
print v(xbgr.mr_n69072576)
print v(xbgr.mr_n69072688)
print v(xbgr.mr_n69073008)
print v(xbgr.mr_n69073120)
print v(xbgr.mr_n69073440)
print v(xbgr.mr_n69073552)
print v(xbgr.mr_n69073872)
print v(xbgr.mr_n69073984)
print v(xbgr.mr_n69074304)
print v(xbgr.mr_n69074416)
print v(xbgr.mr_n69074736)
print v(xbgr.mr_n69074848)
print v(xbgr.mr_n69075168)
print v(xbgr.mr_n69075280)
print v(xbgr.mr_n69075600)
print v(xbgr.mr_n69075712)
print v(xbgr.mr_n69076032)
print v(xbgr.mr_n69076144)
print v(xbgr.mr_n69076464)
print v(xbgr.mr_n69076576)
print v(xbgr.mr_n69076896)
print v(xbgr.mr_n69077008)
print v(xbgr.mr_n69077328)
print v(xbgr.mr_n69077440)
print v(xbgr.mr_n69077760)
print v(xbgr.mr_n69077872)
print v(xbgr.mr_n69078192)
print v(xbgr.mr_n69078304)
print v(xbgr.mr_n69078624)
print v(xbgr.mr_n69078736)
print v(xbgr.mr_n69079056)
print v(xbgr.mr_n69079168)
print v(xbgr.mr_n69079488)
print v(xbgr.mr_n69079600)
print v(xbgr.mr_n69079920)
print v(xbgr.mr_n69080032)
print v(xbgr.mr_n69080352)
print v(xbgr.mr_n69080464)
print v(xbgr.mr_n69080784)
print v(xbgr.mr_n69080896)
print v(xbgr.mr_n69081216)
print v(xbgr.mr_n69081328)
print v(xbgr.mr_n69081648)
print v(xbgr.mr_n69081760)
print v(xbgr.mr_n69082080)
print v(xbgr.mr_n69082192)
print v(xbgr.mr_n69082512)
print v(xbgr.mr_n69082624)
print v(xbgr.mr_n69082944)
print v(xbgr.mr_n69083056)
print v(xbgr.mr_n69083376)
print v(xbgr.mr_n69083488)
print v(xbgr.mr_n69083808)
print v(xbgr.mr_n69083920)
print v(xbgr.mr_n69084240)
print v(xbgr.mr_n69084352)
print v(xbgr.mr_n69084672)
print v(xbgr.mr_n69084784)
print v(xbgr.mr_n69085104)
print v(xbgr.mr_n69085216)
print v(xbgr.mr_n69085536)
print v(xbgr.mr_n69085648)
print v(xbgr.mr_n69085968)
print v(xbgr.mr_n69086080)
print v(xbgr.mr_n69086400)
print v(xbgr.mr_n69086512)
print v(xbgr.mr_n69086832)
print v(xbgr.mr_n69086944)
print v(xbgr.mr_n69087264)
print v(xbgr.mr_n69087376)
print v(xbgr.mr_n69087696)
print v(xbgr.mr_n69087808)
print v(xbgr.mr_n69088128)
print v(xbgr.mr_n69088240)
print v(xbgr.mr_n69088560)
print v(xbgr.mr_n69088672)
print v(xbgr.mr_n69088992)
print v(xbgr.mr_n69089104)
print v(xbgr.mr_n69089424)
print v(xbgr.mr_n69089536)
print v(xbgr.mr_n69089856)
print v(xbgr.mr_n69089968)
print v(xbgr.mr_n69090288)
print v(xbgr.mr_n69090400)
print v(xbgr.mr_n69090720)
print v(xbgr.mr_n69090832)
print v(xbgr.mr_n69091152)
print v(xbgr.mr_n69091264)
print v(xbgr.mr_n69091584)
print v(xbgr.mr_n69091696)
print v(xbgr.mr_n69092016)
print v(xbgr.mr_n69092128)
print v(xbgr.mr_n69092448)
print v(xbgr.mr_n69092560)
print v(xbgr.mr_n69092880)
print v(xbgr.mr_n69092992)
print v(xbgr.mr_n69093312)
print v(xbgr.mr_n69093424)
print v(xbgr.mr_n69093744)
print v(xbgr.mr_n69093856)
print v(xbgr.mr_n69094176)
print v(xbgr.mr_n69094288)
print v(xbgr.mr_n69094608)
print v(xbgr.mr_n69094720)
print v(xbgr.mr_n69095040)
print v(xbgr.mr_n69095152)
print v(xbgr.mr_n69095472)
print v(xbgr.mr_n69095584)
print v(xbgr.mr_n69095904)
print v(xbgr.mr_n69096016)
print v(xbgr.mr_n69096336)
print v(xbgr.mr_n69096448)
print v(xbgr.mr_n69096768)
print v(xbgr.mr_n69096880)
print v(xbgr.mr_n69097200)
print v(xbgr.mr_n69097312)
print v(xbgr.mr_n69097632)
print v(xbgr.mr_n69097744)
print v(xbgr.mr_n69098064)
print v(xbgr.mr_n69098176)
print v(xbgr.mr_n69098496)
print v(xbgr.mr_n69098608)
print v(xbgr.mr_n69098928)
print v(xbgr.mr_n69099040)
print v(xbgr.mr_n69099360)
print v(xbgr.mr_n69099472)
print v(xbgr.mr_n69099792)
print v(xbgr.mr_n69099904)
print v(xbgr.mr_n69100224)
print v(xbgr.mr_n69100336)
print v(xbgr.mr_n69100656)
print v(xbgr.mr_n69100768)
print v(xbgr.mr_n69101088)
print v(xbgr.mr_n69101200)
print v(xbgr.mr_n69101520)
print v(xbgr.mr_n69101632)
print v(xbgr.mr_n69101952)
print v(xbgr.mr_n69102064)
print v(xbgr.mr_n69102384)
print v(xbgr.mr_n69102496)
print v(xbgr.mr_n69102816)
print v(xbgr.mr_n69102928)
print v(xbgr.mr_n69103248)
print v(xbgr.mr_n69103360)
print v(xbgr.mr_n69103680)
print v(xbgr.mr_n69103792)
print v(xbgr.mr_n69104112)
print v(xbgr.mr_n69104224)
print v(xbgr.mr_n69104544)
print v(xbgr.mr_n69104656)
print v(xbgr.mr_n69104976)
print v(xbgr.mr_n69105088)
print v(xbgr.mr_n69105408)
print v(xbgr.mr_n69105520)
print v(xbgr.mr_n69105840)
print v(xbgr.mr_n69105952)
print v(xbgr.mr_n69106272)
print v(xbgr.mr_n69106384)
print v(xbgr.mr_n69106704)
print v(xbgr.mr_n69106816)
print v(xbgr.mr_n69107136)
print v(xbgr.mr_n69107248)
print v(xbgr.mr_n69107568)
print v(xbgr.mr_n69107680)
print v(xbgr.mr_n69108000)
print v(xbgr.mr_n69108112)
print v(xbgr.mr_n69108432)
print v(xbgr.mr_n69108544)
print v(xbgr.mr_n69108864)
print v(xbgr.mr_n69108976)
print v(xbgr.mr_n69109296)
print v(xbgr.mr_n69109408)
print v(xbgr.mr_n69109728)
print v(xbgr.mr_n69109840)
print v(xbgr.mr_n69110160)
print v(xbgr.mr_n69110272)
print v(xbgr.mr_n69110592)
print v(xbgr.mr_n69110704)
print v(xbgr.mr_n69111024)
print v(xbgr.mr_n69111136)
print v(xbgr.mr_n69111456)
print v(xbgr.mr_n69111568)
print v(xbgr.mr_n69111888)
print v(xbgr.mr_n69112000)
print v(xbgr.mr_n69112320)
print v(xbgr.mr_n69112432)
print v(xbgr.mr_n69112752)
print v(xbgr.mr_n69112864)
print v(xbgr.mr_n69113184)
print v(xbgr.mr_n69113296)
print v(xbgr.mr_n69113616)
print v(xbgr.mr_n69113728)
print v(xbgr.mr_n69114048)
print v(xbgr.mr_n69114160)
print v(xbgr.mr_n69114480)
print v(xbgr.mr_n69114592)
print v(xbgr.mr_n69114912)
print v(xbgr.mr_n69115024)
print v(xbgr.mr_n69115344)
print v(xbgr.mr_n69115456)
print v(xbgr.mr_n69115776)
print v(xbgr.mr_n69115888)
print v(xbgr.mr_n69116208)
print v(xbgr.mr_n69116320)
print v(xbgr.mr_n69116640)
print v(xbgr.mr_n69116752)
print v(xbgr.mr_n69117072)
print v(xbgr.mr_n69117184)
print v(xbgr.mr_n69117504)
print v(xbgr.mr_n69117616)
print v(xbgr.mr_n69117936)
print v(xbgr.mr_n69118048)
print v(xbgr.mr_n69118368)
print v(xbgr.mr_n69118480)
print v(xbgr.mr_n69118800)
print v(xbgr.mr_n69118912)
print v(xbgr.mr_n69119232)
print v(xbgr.mr_n69119344)
print v(xbgr.mr_n69119664)
print v(xbgr.mr_n69119776)
print v(xbgr.mr_n69120096)
print v(xbgr.mr_n69120208)
print v(xbgr.mr_n69120528)
print v(xbgr.mr_n69120640)
print v(xbgr.mr_n69120960)
print v(xbgr.mr_n69121072)
print v(xbgr.mr_n69121392)
print v(xbgr.mr_n69121504)
print v(xbgr.mr_n69121824)
print v(xbgr.mr_n69121936)
print v(xbgr.mr_n69122256)
print v(xbgr.mr_n69122368)
print v(xbgr.mr_n69122688)
print v(xbgr.mr_n69122800)
print v(xbgr.mr_n69123120)
print v(xbgr.mr_n69123232)
print v(xbgr.mr_n69123552)
print v(xbgr.mr_n69123664)
print v(xbgr.mr_n69123984)
print v(xbgr.mr_n69124096)
print v(xbgr.mr_n69124416)
print v(xbgr.mr_n69124528)
print v(xbgr.mr_n69124848)
print v(xbgr.mr_n69124960)
print v(xbgr.mr_n69125280)
print v(xbgr.mr_n69125392)
print v(xbgr.mr_n69125712)
print v(xbgr.mr_n69125824)
print v(xbgr.mr_n69126144)
print v(xbgr.mr_n69126256)
print v(xbgr.mr_n69126576)
print v(xbgr.mr_n69126688)
print v(xbgr.mr_n69127008)
print v(xbgr.mr_n69127120)
print v(xbgr.mr_n69127440)
print v(xbgr.mr_n69127552)
print v(xbgr.mr_n69127872)
print v(xbgr.mr_n69127984)
print v(xbgr.mr_n69128304)
print v(xbgr.mr_n69128416)
print v(xbgr.mr_n69128736)
print v(xbgr.mr_n69128848)
print v(xbgr.mr_n69129168)
print v(xbgr.mr_n69129280)
print v(xbgr.mr_n69129600)
print v(xbgr.mr_n69129712)
print v(xbgr.mr_n69130032)
print v(xbgr.mr_n69130144)
print v(xbgr.mr_n69130464)
print v(xbgr.mr_n69130576)
print v(xbgr.mr_n69130896)
print v(xbgr.mr_n69131008)
print v(xbgr.mr_n69131328)
print v(xbgr.mr_n69131440)
print v(xbgr.mr_n69131760)
print v(xbgr.mr_n69131872)
print v(xbgr.mr_n69132192)
print v(xbgr.mr_n69132304)
print v(xbgr.mr_n69132624)
print v(xbgr.mr_n69132736)
print v(xbgr.mr_n69133056)
print v(xbgr.mr_n69133168)
print v(xbgr.mr_n69133488)
print v(xbgr.mr_n69133600)
print v(xbgr.mr_n69133920)
print v(xbgr.mr_n69134032)
print v(xbgr.mr_n69134352)
print v(xbgr.mr_n69134464)
print v(xbgr.mr_n69134784)
print v(xbgr.mr_n69134896)
print v(xbgr.mr_n69135216)
print v(xbgr.mr_n69135328)
print v(xbgr.mr_n69135648)
print v(xbgr.mr_n69135760)
print v(xbgr.mr_n69136080)
print v(xbgr.mr_n69136192)
print v(xbgr.mr_n69136512)
print v(xbgr.mr_n69136624)
print v(xbgr.mr_n69136944)
print v(xbgr.mr_n69137056)
print v(xbgr.mr_n69137376)
print v(xbgr.mr_n69137488)
print v(xbgr.mr_n69137808)
print v(xbgr.mr_n69137920)
print v(xbgr.mr_n69138240)
print v(xbgr.mr_n69138352)
print v(xbgr.mr_n69138672)
print v(xbgr.mr_n69138784)
print v(xbgr.mr_n69139104)
print v(xbgr.mr_n69139216)
print v(xbgr.mr_n69139536)
print v(xbgr.mr_n69139648)
print v(xbgr.mr_n69139968)
print v(xbgr.mr_n69140080)
print v(xbgr.mr_n69140400)
print v(xbgr.mr_n69140512)
print v(xbgr.mr_n69140832)
print v(xbgr.mr_n69140944)
print v(xbgr.mr_n69141264)
print v(xbgr.mr_n69141376)
print v(xbgr.mr_n69141696)
print v(xbgr.mr_n69141808)
print v(xbgr.mr_n69142128)
print v(xbgr.mr_n69142240)
print v(xbgr.mr_n69142560)
print v(xbgr.mr_n69142672)
print v(xbgr.mr_n69142992)
print v(xbgr.mr_n69143104)
print v(xbgr.mr_n69143424)
print v(xbgr.mr_n69143536)
print v(xbgr.mr_n69143856)
print v(xbgr.mr_n69143968)
print v(xbgr.mr_n69144288)
print v(xbgr.mr_n69144400)
print v(xbgr.mr_n69144720)
print v(xbgr.mr_n69144832)
print v(xbgr.mr_n69145152)
print v(xbgr.mr_n69145264)
print v(xbgr.mr_n69145584)
print v(xbgr.mr_n69145696)
print v(xbgr.mr_n69146016)
print v(xbgr.mr_n69146128)
print v(xbgr.mr_n69146448)
print v(xbgr.mr_n69146560)
print v(xbgr.mr_n69146880)
print v(xbgr.mr_n69146992)
print v(xbgr.mr_n69147312)
print v(xbgr.mr_n69147424)
print v(xbgr.mr_n69147744)
print v(xbgr.mr_n69147856)
print v(xbgr.mr_n69148176)
print v(xbgr.mr_n69148288)
print v(xbgr.mr_n69148608)
print v(xbgr.mr_n69148720)
print v(xbgr.mr_n69149040)
print v(xbgr.mr_n69149152)
print v(xbgr.mr_n69149472)
print v(xbgr.mr_n69149584)
print v(xbgr.mr_n69149904)
print v(xbgr.mr_n69150016)
print v(xbgr.mr_n69150336)
print v(xbgr.mr_n69150448)
print v(xbgr.mr_n69150768)
print v(xbgr.mr_n69150880)
print v(xbgr.mr_n69151200)
print v(xbgr.mr_n69151312)
print v(xbgr.mr_n69151632)
print v(xbgr.mr_n69151744)
print v(xbgr.mr_n69152064)
print v(xbgr.mr_n69152176)
print v(xbgr.mr_n69152496)
print v(xbgr.mr_n69152608)
print v(xbgr.mr_n69152928)
print v(xbgr.mr_n69153040)
print v(xbgr.mr_n69153360)
print v(xbgr.mr_n69153472)
print v(xbgr.mr_n69153792)
print v(xbgr.mr_n69153904)
print v(xbgr.mr_n69154224)
print v(xbgr.mr_n69154336)
print v(xbgr.mr_n69154656)
print v(xbgr.mr_n69154768)
print v(xbgr.mr_n69155088)
print v(xbgr.mr_n69155200)
print v(xbgr.mr_n69155520)
print v(xbgr.mr_n69155632)
print v(xbgr.mr_n69155952)
print v(xbgr.mr_n69156064)
print v(xbgr.mr_n69156384)
print v(xbgr.mr_n69156496)
print v(xbgr.mr_n69156816)
print v(xbgr.mr_n69156928)
print v(xbgr.mr_n69157248)
print v(xbgr.mr_n69157360)
print v(xbgr.mr_n69157680)
print v(xbgr.mr_n69157792)
print v(xbgr.mr_n69158112)
print v(xbgr.mr_n69158224)
print v(xbgr.mr_n69158544)
print v(xbgr.mr_n69158656)
print v(xbgr.mr_n69158976)
print v(xbgr.mr_n69159088)
print v(xbgr.mr_n69159408)
print v(xbgr.mr_n69159520)
print v(xbgr.mr_n69159840)
print v(xbgr.mr_n69159952)
print v(xbgr.mr_n69160272)
print v(xbgr.mr_n69160384)
print v(xbgr.mr_n69160704)
print v(xbgr.mr_n69160816)
print v(xbgr.mr_n69161136)
print v(xbgr.mr_n69161248)
print v(xbgr.mr_n69161568)
print v(xbgr.mr_n69161680)
print v(xbgr.mr_n69162000)
print v(xbgr.mr_n69162112)
print v(xbgr.mr_n69162432)
print v(xbgr.mr_n69162544)
print v(xbgr.mr_n69162864)
print v(xbgr.mr_n69162976)
print v(xbgr.mr_n69163296)
print v(xbgr.mr_n69163408)
print v(xbgr.mr_n69163728)
print v(xbgr.mr_n69163840)
print v(xbgr.mr_n69164160)
print v(xbgr.mr_n69164272)
print v(xbgr.mr_n69164592)
print v(xbgr.mr_n69164704)
print v(xbgr.mr_n69165024)
print v(xbgr.mr_n69165136)
print v(xbgr.mr_n69165456)
print v(xbgr.mr_n69165568)
print v(xbgr.mr_n69165888)
print v(xbgr.mr_n69166000)
print v(xbgr.mr_n69166320)
print v(xbgr.mr_n69166432)
print v(xbgr.mr_n69166752)
print v(xbgr.mr_n69166864)
print v(xbgr.mr_n69167184)
print v(xbgr.mr_n69167296)
print v(xbgr.mr_n69167616)
print v(xbgr.mr_n69167728)
print v(xbgr.mr_n69168048)
print v(xbgr.mr_n69168160)
print v(xbgr.mr_n69168480)
print v(xbgr.mr_n69168592)
print v(xbgr.mr_n69168912)
print v(xbgr.mr_n69169024)
print v(xbgr.mr_n69169344)
print v(xbgr.mr_n69169456)
print v(xbgr.mr_n69169776)
print v(xbgr.mr_n69169888)
print v(xbgr.mr_n69170208)
print v(xbgr.mr_n69170320)
print v(xbgr.mr_n69170640)
print v(xbgr.mr_n69170752)
print v(xbgr.mr_n69171072)
print v(xbgr.mr_n69171184)
print v(xbgr.mr_n69171504)
print v(xbgr.mr_n69171616)
print v(xbgr.mr_n69171936)
print v(xbgr.mr_n69172048)
print v(xbgr.mr_n69172368)
print v(xbgr.mr_n69172480)
print v(xbgr.mr_n69172912)
print v(xbgr.mr_n69173232)
print v(xbgr.mr_n69173344)
print v(xbgr.mr_n69173664)
print v(xbgr.mr_n69173776)
print v(xbgr.mr_n69174096)
print v(xbgr.mr_n69174208)
print v(xbgr.mr_n69174528)
print v(xbgr.mr_n69174640)
print v(xbgr.mr_n69174960)
print v(xbgr.mr_n69175824)
print v(xbgr.mr_n69175936)
print v(xbgr.mr_n69176256)
print v(xbgr.mr_n69176368)
print v(xbgr.mr_n69176688)
print v(xbgr.mr_n69176800)
print v(xbgr.mr_n69177120)
print v(xbgr.mr_n69177232)
print v(xbgr.mr_n69177552)
print v(xbgr.mr_n69177664)
print v(xbgr.mr_n69177984)
print v(xbgr.mr_n69178096)
print v(xbgr.mr_n69178416)
print v(xbgr.mr_n69178528)
print v(xbgr.mr_n69178848)
print v(xbgr.mr_n69178960)
print v(xbgr.mr_n69179280)
print v(xbgr.mr_n69179392)
print v(xbgr.mr_n69179712)
print v(xbgr.mr_n69179824)
print v(xbgr.mr_n69180144)
print v(xbgr.mr_n69180256)
print v(xbgr.mr_n69180688)
print v(xbgr.mr_n69181008)
print v(xbgr.mr_n69181120)
print v(xbgr.mr_n69181440)
print v(xbgr.mr_n69181552)
print v(xbgr.mr_n69181872)
print v(xbgr.mr_n69181984)
print v(xbgr.mr_n69182304)
print v(xbgr.mr_n69182416)
print v(xbgr.mr_n69182736)
print v(xbgr.mr_n69182848)
print v(xbgr.mr_n69183168)
print v(xbgr.mr_n69183280)
print v(xbgr.mr_n69183600)
print v(xbgr.mr_n69183712)
print v(xbgr.mr_n69184032)
print v(xbgr.mr_n69184144)
print v(xbgr.mr_n69184464)
print v(xbgr.mr_n69184576)
print v(xbgr.mr_n69184896)
print v(xbgr.mr_n69185008)
print v(xbgr.mr_n69185328)
print v(xbgr.mr_n69185440)
print v(xbgr.mr_n69185760)
print v(xbgr.mr_n69185872)
print v(xbgr.mr_n69186192)
print v(xbgr.mr_n69186304)
print v(xbgr.mr_n69186624)
print v(xbgr.mr_n69186736)
print v(xbgr.mr_n69187056)
print v(xbgr.mr_n69187168)
print v(xbgr.mr_n69187488)
print v(xbgr.mr_n69187600)
print v(xbgr.mr_n69187920)
print v(xbgr.mr_n69188032)
print v(xbgr.mr_n69188352)
print v(xbgr.mr_n69188464)
print v(xbgr.mr_n69188784)
print v(xbgr.mr_n69188896)
print v(xbgr.mr_n69189216)
print v(xbgr.mr_n69189328)
print v(xbgr.mr_n69189648)
print v(xbgr.mr_n69189760)
print v(xbgr.mr_n69190080)
print v(xbgr.mr_n69190192)
print v(xbgr.mr_n69190512)
print v(xbgr.mr_n69190624)
print v(xbgr.mr_n69190944)
print v(xbgr.mr_n69191056)
print v(xbgr.mr_n69191376)
print v(xbgr.mr_n69191488)
print v(xbgr.mr_n69191808)
print v(xbgr.mr_n69191920)
print v(xbgr.mr_n69192240)
print v(xbgr.mr_n69192352)
print v(xbgr.mr_n69192672)
print v(xbgr.mr_n69192784)
print v(xbgr.mr_n69193104)
print v(xbgr.mr_n69193216)
print v(xbgr.mr_n69193536)
print v(xbgr.mr_n69193648)
print v(xbgr.mr_n69193968)
print v(xbgr.mr_n69194080)
print v(xbgr.mr_n69194400)
print v(xbgr.mr_n69194512)
print v(xbgr.mr_n69194832)
print v(xbgr.mr_n69194944)
print v(xbgr.mr_n69195264)
print v(xbgr.mr_n69195376)
print v(xbgr.mr_n69195696)
print v(xbgr.mr_n69195808)
print v(xbgr.mr_n69196128)
print v(xbgr.mr_n69196240)
print v(xbgr.mr_n69196560)
print v(xbgr.mr_n69196672)
print v(xbgr.mr_n69196992)
print v(xbgr.mr_n69197104)
print v(xbgr.mr_n69197424)
print v(xbgr.mr_n69198288)
print v(xbgr.mr_n69198400)
print v(xbgr.mr_n69198720)
print v(xbgr.mr_n69198832)
print v(xbgr.mr_n69199152)
print v(xbgr.mr_n69199264)
print v(xbgr.mr_n69199584)
print v(xbgr.mr_n69199696)
print v(xbgr.mr_n69200016)
print v(xbgr.mr_n69200128)
print v(xbgr.mr_n69200448)
print v(xbgr.mr_n69200560)
print v(xbgr.mr_n69200880)
print v(xbgr.mr_n69200992)
print v(xbgr.mr_n69201312)
print v(xbgr.mr_n69201424)
print v(xbgr.mr_n69201744)
print v(xbgr.mr_n69201856)
print v(xbgr.mr_n69202176)
print v(xbgr.mr_n69202288)
print v(xbgr.mr_n69202608)
print v(xbgr.mr_n69202720)
print v(xbgr.mr_n69203040)
print v(xbgr.mr_n69203152)
print v(xbgr.mr_n69203472)
print v(xbgr.mr_n69203584)
print v(xbgr.mr_n69203904)
print v(xbgr.mr_n69204016)
print v(xbgr.mr_n69204336)
print v(xbgr.mr_n69204448)
print v(xbgr.mr_n69204768)
print v(xbgr.mr_n69204880)
print v(xbgr.mr_n69205200)
print v(xbgr.mr_n69205312)
print v(xbgr.mr_n69205632)
print v(xbgr.mr_n69205744)
print v(xbgr.mr_n69206064)
print v(xbgr.mr_n69206176)
print v(xbgr.mr_n69206496)
print v(xbgr.mr_n69206608)
print v(xbgr.mr_n69206928)
print v(xbgr.mr_n69207040)
print v(xbgr.mr_n69207360)
print v(xbgr.mr_n69207472)
print v(xbgr.mr_n69207792)
print v(xbgr.mr_n69207904)
print v(xbgr.mr_n69208224)
print v(xbgr.mr_n69208336)
print v(xbgr.mr_n69208656)
print v(xbgr.mr_n69208768)
print v(xbgr.mr_n69209088)
print v(xbgr.mr_n69209200)
print v(xbgr.mr_n69209520)
print v(xbgr.mr_n69209632)
print v(xbgr.mr_n69209952)
print v(xbgr.mr_n69210064)
print v(xbgr.mr_n69210384)
print v(xbgr.mr_n69210496)
print v(xbgr.mr_n69210816)
print v(xbgr.mr_n69210928)
print v(xbgr.mr_n69211248)
print v(xbgr.mr_n69211360)
print v(xbgr.mr_n69211680)
print v(xbgr.mr_n69211792)
print v(xbgr.mr_n69212112)
print v(xbgr.mr_n69212224)
print v(xbgr.mr_n69212544)
print v(xbgr.mr_n69212656)
print v(xbgr.mr_n69212976)
print v(xbgr.mr_n69213088)
print v(xbgr.mr_n69213408)
print v(xbgr.mr_n69213520)
print v(xbgr.mr_n69213840)
print v(xbgr.mr_n69213952)
print v(xbgr.mr_n69214272)
print v(xbgr.mr_n69214384)
print v(xbgr.mr_n69214704)
print v(xbgr.mr_n69214816)
print v(xbgr.mr_n69215136)
print v(xbgr.mr_n69215248)
print v(xbgr.mr_n69215568)
print v(xbgr.mr_n69215680)
print v(xbgr.mr_n69216000)
print v(xbgr.mr_n69216112)
print v(xbgr.mr_n69216432)
print v(xbgr.mr_n69216544)
print v(xbgr.mr_n69216864)
print v(xbgr.mr_n69216976)
print v(xbgr.mr_n69217296)
print v(xbgr.mr_n69217408)
print v(xbgr.mr_n69217728)
print v(xbgr.mr_n69217840)
print v(xbgr.mr_n69218160)
print v(xbgr.mr_n69218272)
print v(xbgr.mr_n69218592)
print v(xbgr.mr_n69218704)
print v(xbgr.mr_n69219024)
print v(xbgr.mr_n69219136)
print v(xbgr.mr_n69219456)
print v(xbgr.mr_n69219568)
print v(xbgr.mr_n69219888)
print v(xbgr.mr_n69220000)
print v(xbgr.mr_n69220320)
print v(xbgr.mr_n69220432)
print v(xbgr.mr_n69220752)
print v(xbgr.mr_n69220864)
print v(xbgr.mr_n69221184)
print v(xbgr.mr_n69221296)
print v(xbgr.mr_n69221616)
print v(xbgr.mr_n69221728)
print v(xbgr.mr_n69222048)
print v(xbgr.mr_n69222160)
print v(xbgr.mr_n69222480)
print v(xbgr.mr_n69222592)
print v(xbgr.mr_n69222912)
print v(xbgr.mr_n69223024)
print v(xbgr.mr_n69223344)
print v(xbgr.mr_n69223456)
print v(xbgr.mr_n69223776)
print v(xbgr.mr_n69223888)
print v(xbgr.mr_n69224208)
print v(xbgr.mr_n69224320)
print v(xbgr.mr_n69224640)
print v(xbgr.mr_n69224752)
print v(xbgr.mr_n69225072)
print v(xbgr.mr_n69225184)
print v(xbgr.mr_n69225504)
print v(xbgr.mr_n69225616)
print v(xbgr.mr_n69225936)
print v(xbgr.mr_n69226048)
print v(xbgr.mr_n69226368)
print v(xbgr.mr_n69226480)
print v(xbgr.mr_n69226800)
print v(xbgr.mr_n69226912)
print v(xbgr.mr_n69227232)
print v(xbgr.mr_n69227344)
print v(xbgr.mr_n69227664)
print v(xbgr.mr_n69227776)
print v(xbgr.mr_n69228096)
print v(xbgr.mr_n69228208)
print v(xbgr.mr_n69228528)
print v(xbgr.mr_n69228640)
print v(xbgr.mr_n69228960)
print v(xbgr.mr_n69229072)
print v(xbgr.mr_n69229392)
print v(xbgr.mr_n69229504)
print v(xbgr.mr_n69229824)
print v(xbgr.mr_n69229936)
print v(xbgr.mr_n69230256)
print v(xbgr.mr_n69230368)
print v(xbgr.mr_n69230688)
print v(xbgr.mr_n69230800)
print v(xbgr.mr_n69231120)
print v(xbgr.mr_n69231232)
print v(xbgr.mr_n69231552)
print v(xbgr.mr_n69231664)
print v(xbgr.mr_n69231984)
print v(xbgr.mr_n69232096)
print v(xbgr.mr_n69232416)
print v(xbgr.mr_n69232528)
print v(xbgr.mr_n69232848)
print v(xbgr.mr_n69232960)
print v(xbgr.mr_n69233280)
print v(xbgr.mr_n69233392)
print v(xbgr.mr_n69233712)
print v(xbgr.mr_n69233824)
print v(xbgr.mr_n69234144)
print v(xbgr.mr_n69234256)
print v(xbgr.mr_n69234576)
print v(xbgr.mr_n69234688)
print v(xbgr.mr_n69235008)
print v(xbgr.mr_n69235120)
print v(xbgr.mr_n69235440)
print v(xbgr.mr_n69235552)
print v(xbgr.mr_n69235872)
print v(xbgr.mr_n69235984)
print v(xbgr.mr_n69236304)
print v(xbgr.mr_n69236416)
print v(xbgr.mr_n69236736)
print v(xbgr.mr_n69236848)
print v(xbgr.mr_n69237168)
print v(xbgr.mr_n69237280)
print v(xbgr.mr_n69237600)
print v(xbgr.mr_n69237712)
print v(xbgr.mr_n69238032)
print v(xbgr.mr_n69238144)
print v(xbgr.mr_n69238464)
print v(xbgr.mr_n69238576)
print v(xbgr.mr_n69238896)
print v(xbgr.mr_n69239008)
print v(xbgr.mr_n69239328)
print v(xbgr.mr_n69239440)
print v(xbgr.mr_n69239760)
print v(xbgr.mr_n69239872)
print v(xbgr.mr_n69240192)
print v(xbgr.mr_n69240304)
print v(xbgr.mr_n69240624)
print v(xbgr.mr_n69240736)
print v(xbgr.mr_n69241056)
print v(xbgr.mr_n69241168)
print v(xbgr.mr_n69241488)
print v(xbgr.mr_n69241600)
print v(xbgr.mr_n69241920)
print v(xbgr.mr_n69242032)
print v(xbgr.mr_n69242352)
print v(xbgr.mr_n69242464)
print v(xbgr.mr_n69242784)
print v(xbgr.mr_n69242896)
print v(xbgr.mr_n69243216)
print v(xbgr.mr_n69243328)
print v(xbgr.mr_n69243648)
print v(xbgr.mr_n69243760)
print v(xbgr.mr_n69244080)
print v(xbgr.mr_n69244192)
print v(xbgr.mr_n69244512)
print v(xbgr.mr_n69244624)
print v(xbgr.mr_n69244944)
print v(xbgr.mr_n69245056)
print v(xbgr.mr_n69245376)
print v(xbgr.mr_n69245488)
print v(xbgr.mr_n69245808)
print v(xbgr.mr_n69245920)
print v(xbgr.mr_n69246240)
print v(xbgr.mr_n69246352)
print v(xbgr.mr_n69246672)
print v(xbgr.mr_n69246784)
print v(xbgr.mr_n69247104)
print v(xbgr.mr_n69247216)
print v(xbgr.mr_n69247536)
print v(xbgr.mr_n69247648)
print v(xbgr.mr_n69247968)
print v(xbgr.mr_n69248080)
print v(xbgr.mr_n69248400)
print v(xbgr.mr_n69248512)
print v(xbgr.mr_n69248832)
print v(xbgr.mr_n69248944)
print v(xbgr.mr_n69249264)
print v(xbgr.mr_n69249376)
print v(xbgr.mr_n69249696)
print v(xbgr.mr_n69249808)
print v(xbgr.mr_n69250128)
print v(xbgr.mr_n69250240)
print v(xbgr.mr_n69250560)
print v(xbgr.mr_n69250672)
print v(xbgr.mr_n69250992)
print v(xbgr.mr_n69251104)
print v(xbgr.mr_n69251424)
print v(xbgr.mr_n69251536)
print v(xbgr.mr_n69251856)
print v(xbgr.mr_n69251968)
print v(xbgr.mr_n69252288)
print v(xbgr.mr_n69252400)
print v(xbgr.mr_n69252720)
print v(xbgr.mr_n69252832)
print v(xbgr.mr_n69253152)
print v(xbgr.mr_n69253264)
print v(xbgr.mr_n69253584)
print v(xbgr.mr_n69253696)
print v(xbgr.mr_n69254016)
print v(xbgr.mr_n69254128)
print v(xbgr.mr_n69254448)
print v(xbgr.mr_n69254560)
print v(xbgr.mr_n69254880)
print v(xbgr.mr_n69254992)
print v(xbgr.mr_n69255312)
print v(xbgr.mr_n69255424)
print v(xbgr.mr_n69255744)
print v(xbgr.mr_n69255856)
print v(xbgr.mr_n69256176)
print v(xbgr.mr_n69256288)
print v(xbgr.mr_n69256608)
print v(xbgr.mr_n69256720)
print v(xbgr.mr_n69257040)
print v(xbgr.mr_n69257152)
print v(xbgr.mr_n69257472)
print v(xbgr.mr_n69257584)
print v(xbgr.mr_n69257904)
print v(xbgr.mr_n69258016)
print v(xbgr.mr_n69258336)
print v(xbgr.mr_n69258448)
print v(xbgr.mr_n69258768)
print v(xbgr.mr_n69258880)
print v(xbgr.mr_n69259200)
print v(xbgr.mr_n69259312)
print v(xbgr.mr_n69259632)
print v(xbgr.mr_n69259744)
print v(xbgr.mr_n69260064)
print v(xbgr.mr_n69260176)
print v(xbgr.mr_n69260496)
print v(xbgr.mr_n69260608)
print v(xbgr.mr_n69260928)
print v(xbgr.mr_n69261040)
print v(xbgr.mr_n69261360)
print v(xbgr.mr_n69261472)
print v(xbgr.mr_n69261792)
print v(xbgr.mr_n69261904)
print v(xbgr.mr_n69262224)
print v(xbgr.mr_n69262336)
print v(xbgr.mr_n69262656)
print v(xbgr.mr_n69262768)
print v(xbgr.mr_n69263088)
print v(xbgr.mr_n69263200)
print v(xbgr.mr_n69263520)
print v(xbgr.mr_n69263632)
print v(xbgr.mr_n69263952)
print v(xbgr.mr_n69264064)
print v(xbgr.mr_n69264384)
print v(xbgr.mr_n69264496)
print v(xbgr.mr_n69264816)
print v(xbgr.mr_n69264928)
print v(xbgr.mr_n69265248)
print v(xbgr.mr_n69265360)
print v(xbgr.mr_n69265680)
print v(xbgr.mr_n69265792)
print v(xbgr.mr_n69266112)
print v(xbgr.mr_n69266224)
print v(xbgr.mr_n69266544)
print v(xbgr.mr_n69266656)
print v(xbgr.mr_n69266976)
print v(xbgr.mr_n69267088)
print v(xbgr.mr_n69267408)
print v(xbgr.mr_n69267520)
print v(xbgr.mr_n69267840)
print v(xbgr.mr_n69267952)
print v(xbgr.mr_n69268272)
print v(xbgr.mr_n69268384)
print v(xbgr.mr_n69268704)
print v(xbgr.mr_n69268816)
print v(xbgr.mr_n69269136)
print v(xbgr.mr_n69269248)
print v(xbgr.mr_n69269568)
print v(xbgr.mr_n69269680)
print v(xbgr.mr_n69270000)
print v(xbgr.mr_n69270112)
print v(xbgr.mr_n69270432)
print v(xbgr.mr_n69270544)
print v(xbgr.mr_n69270864)
print v(xbgr.mr_n69270976)
print v(xbgr.mr_n69271296)
print v(xbgr.mr_n69271408)
print v(xbgr.mr_n69271728)
print v(xbgr.mr_n69271840)
print v(xbgr.mr_n69272160)
print v(xbgr.mr_n69272272)
print v(xbgr.mr_n69272592)
print v(xbgr.mr_n69272704)
print v(xbgr.mr_n69273024)
print v(xbgr.mr_n69273136)
print v(xbgr.mr_n69273456)
print v(xbgr.mr_n69273568)
print v(xbgr.mr_n69273888)
print v(xbgr.mr_n69274000)
print v(xbgr.mr_n69274320)
print v(xbgr.mr_n69274432)
print v(xbgr.mr_n69274752)
print v(xbgr.mr_n69274864)
print v(xbgr.mr_n69275184)
print v(xbgr.mr_n69275296)
print v(xbgr.mr_n69275616)
print v(xbgr.mr_n69275728)
print v(xbgr.mr_n69276048)
print v(xbgr.mr_n69276160)
print v(xbgr.mr_n69276480)
print v(xbgr.mr_n69276592)
print v(xbgr.mr_n69276912)
print v(xbgr.mr_n69277024)
print v(xbgr.mr_n69277344)
print v(xbgr.mr_n69277456)
print v(xbgr.mr_n69277776)
print v(xbgr.mr_n69277888)
print v(xbgr.mr_n69278208)
print v(xbgr.mr_n69278320)
print v(xbgr.mr_n69278640)
print v(xbgr.mr_n69278752)
print v(xbgr.mr_n69279072)
print v(xbgr.mr_n69279184)
print v(xbgr.mr_n69279504)
print v(xbgr.mr_n69279616)
print v(xbgr.mr_n69279936)
print v(xbgr.mr_n69280048)
print v(xbgr.mr_n69280368)
print v(xbgr.mr_n69280480)
print v(xbgr.mr_n69280800)
print v(xbgr.mr_n69280912)
print v(xbgr.mr_n69281232)
print v(xbgr.mr_n69281344)
print v(xbgr.mr_n69281664)
print v(xbgr.mr_n69281776)
print v(xbgr.mr_n69282096)
print v(xbgr.mr_n69282208)
print v(xbgr.mr_n69282528)
print v(xbgr.mr_n69282640)
print v(xbgr.mr_n69282960)
print v(xbgr.mr_n69283072)
print v(xbgr.mr_n69283392)
print v(xbgr.mr_n69283504)
print v(xbgr.mr_n69283824)
print v(xbgr.mr_n69283936)
print v(xbgr.mr_n69284256)
print v(xbgr.mr_n69284368)
print v(xbgr.mr_n69284688)
print v(xbgr.mr_n69284800)
print v(xbgr.mr_n69285120)
print v(xbgr.mr_n69285232)
print v(xbgr.mr_n69285552)
print v(xbgr.mr_n69285664)
print v(xbgr.mr_n69285984)
print v(xbgr.mr_n69286096)
print v(xbgr.mr_n69286416)
print v(xbgr.mr_n69286528)
print v(xbgr.mr_n69286848)
print v(xbgr.mr_n69286960)
print v(xbgr.mr_n69287280)
print v(xbgr.mr_n69287392)
print v(xbgr.mr_n69287712)
print v(xbgr.mr_n69287824)
print v(xbgr.mr_n69288144)
print v(xbgr.mr_n69288256)
print v(xbgr.mr_n69288576)
print v(xbgr.mr_n69288688)
print v(xbgr.mr_n69289008)
print v(xbgr.mr_n69289120)
print v(xbgr.mr_n69289440)
print v(xbgr.mr_n69289552)
print v(xbgr.mr_n69289872)
print v(xbgr.mr_n69289984)
print v(xbgr.mr_n69290304)
print v(xbgr.mr_n69290416)
print v(xbgr.mr_n69290736)
print v(xbgr.mr_n69290848)
print v(xbgr.mr_n69291168)
print v(xbgr.mr_n69291280)
print v(xbgr.mr_n69291600)
print v(xbgr.mr_n69291712)
print v(xbgr.mr_n69292032)
print v(xbgr.mr_n69292144)
print v(xbgr.mr_n69292464)
print v(xbgr.mr_n69292576)
print v(xbgr.mr_n69292896)
print v(xbgr.mr_n69293008)
print v(xbgr.mr_n69293328)
print v(xbgr.mr_n69293440)
print v(xbgr.mr_n69293760)
print v(xbgr.mr_n69293872)
print v(xbgr.mr_n69294192)
print v(xbgr.mr_n69294304)
print v(xbgr.mr_n69294624)
print v(xbgr.mr_n69294736)
print v(xbgr.mr_n69295056)
print v(xbgr.mr_n69295168)
print v(xbgr.mr_n69295488)
print v(xbgr.mr_n69295600)
print v(xbgr.mr_n69295920)
print v(xbgr.mr_n69296032)
print v(xbgr.mr_n69296352)
print v(xbgr.mr_n69296464)
print v(xbgr.mr_n69296784)
print v(xbgr.mr_n69296896)
print v(xbgr.mr_n69297216)
print v(xbgr.mr_n69297328)
print v(xbgr.mr_n69297648)
print v(xbgr.mr_n69297760)
print v(xbgr.mr_n69298080)
print v(xbgr.mr_n69298192)
print v(xbgr.mr_n69298512)
print v(xbgr.mr_n69298624)
print v(xbgr.mr_n69298944)
print v(xbgr.mr_n69299056)
print v(xbgr.mr_n69299376)
print v(xbgr.mr_n69299488)
print v(xbgr.mr_n69299808)
print v(xbgr.mr_n69299920)
print v(xbgr.mr_n69300240)
print v(xbgr.mr_n69300352)
print v(xbgr.mr_n69300672)
print v(xbgr.mr_n69300784)
print v(xbgr.mr_n69301104)
print v(xbgr.mr_n69301216)
print v(xbgr.mr_n69301536)
print v(xbgr.mr_n69301648)
print v(xbgr.mr_n69301968)
print v(xbgr.mr_n69302080)
print v(xbgr.mr_n69302400)
print v(xbgr.mr_n69302512)
print v(xbgr.mr_n69302832)
print v(xbgr.mr_n69302944)
print v(xbgr.mr_n69303264)
print v(xbgr.mr_n69303376)
print v(xbgr.mr_n69303696)
print v(xbgr.mr_n69303808)
print v(xbgr.mr_n69304128)
print v(xbgr.mr_n69304240)
print v(xbgr.mr_n69304560)
print v(xbgr.mr_n69304672)
print v(xbgr.mr_n69304992)
print v(xbgr.mr_n69305104)
print v(xbgr.mr_n69305424)
print v(xbgr.mr_n69305536)
print v(xbgr.mr_n69305856)
print v(xbgr.mr_n69305968)
print v(xbgr.mr_n69306288)
print v(xbgr.mr_n69306400)
print v(xbgr.mr_n69306720)
print v(xbgr.mr_n69306832)
print v(xbgr.mr_n69307152)
print v(xbgr.mr_n69307264)
print v(xbgr.mr_n69307584)
print v(xbgr.mr_n69307696)
print v(xbgr.mr_n69308016)
print v(xbgr.mr_n69308128)
print v(xbgr.mr_n69308448)
print v(xbgr.mr_n69308560)
print v(xbgr.mr_n69308880)
print v(xbgr.mr_n69308992)
print v(xbgr.mr_n69309312)
print v(xbgr.mr_n69309424)
print v(xbgr.mr_n69309744)
print v(xbgr.mr_n69309856)
print v(xbgr.mr_n69310176)
print v(xbgr.mr_n69310288)
print v(xbgr.mr_n69310608)
print v(xbgr.mr_n69310720)
print v(xbgr.mr_n69311040)
print v(xbgr.mr_n69311152)
print v(xbgr.mr_n69311472)
print v(xbgr.mr_n69311584)
print v(xbgr.mr_n69311904)
print v(xbgr.mr_n69312016)
print v(xbgr.mr_n69312336)
print v(xbgr.mr_n69312448)
print v(xbgr.mr_n69312768)
print v(xbgr.mr_n69312880)
print v(xbgr.mr_n69313200)
print v(xbgr.mr_n69313312)
print v(xbgr.mr_n69313632)
print v(xbgr.mr_n69313744)
print v(xbgr.mr_n69314064)
print v(xbgr.mr_n69314176)
print v(xbgr.mr_n69314496)
print v(xbgr.mr_n69314608)
print v(xbgr.mr_n69314928)
print v(xbgr.mr_n69315040)
print v(xbgr.mr_n69315360)
print v(xbgr.mr_n69315472)
print v(xbgr.mr_n69315792)
print v(xbgr.mr_n69315904)
print v(xbgr.mr_n69316224)
print v(xbgr.mr_n69316336)
print v(xbgr.mr_n69316656)
print v(xbgr.mr_n69316768)
print v(xbgr.mr_n69317088)
print v(xbgr.mr_n69317200)
print v(xbgr.mr_n69317520)
print v(xbgr.mr_n69317632)
print v(xbgr.mr_n69317952)
print v(xbgr.mr_n69318064)
print v(xbgr.mr_n69318384)
print v(xbgr.mr_n69318496)
print v(xbgr.mr_n69318816)
print v(xbgr.mr_n69318928)
print v(xbgr.mr_n69319248)
print v(xbgr.mr_n69319360)
print v(xbgr.mr_n69319680)
print v(xbgr.mr_n69319792)
print v(xbgr.mr_n69320112)
print v(xbgr.mr_n69320224)
print v(xbgr.mr_n69320544)
print v(xbgr.mr_n69320656)
print v(xbgr.mr_n69320976)
print v(xbgr.mr_n69321088)
print v(xbgr.mr_n69321408)
print v(xbgr.mr_n69321520)
print v(xbgr.mr_n69321840)
print v(xbgr.mr_n69321952)
print v(xbgr.mr_n69322272)
print v(xbgr.mr_n69322384)
print v(xbgr.mr_n69322704)
print v(xbgr.mr_n69322816)
print v(xbgr.mr_n69323136)
print v(xbgr.mr_n69323248)
print v(xbgr.mr_n69323568)
print v(xbgr.mr_n69323680)
print v(xbgr.mr_n69324000)
print v(xbgr.mr_n69324112)
print v(xbgr.mr_n69324432)
print v(xbgr.mr_n69324544)
print v(xbgr.mr_n69324976)
print v(xbgr.mr_n69325296)
print v(xbgr.mr_n69325408)
print v(xbgr.mr_n69325728)
print v(xbgr.mr_n69325840)
print v(xbgr.mr_n69326160)
print v(xbgr.mr_n69326272)
print v(xbgr.mr_n69326704)
print v(xbgr.mr_n69327024)
print v(xbgr.mr_n69327136)
print v(xbgr.mr_n69327456)
print v(xbgr.mr_n69327568)
print v(xbgr.mr_n69327888)
print v(xbgr.mr_n69328000)
print v(xbgr.mr_n69328320)
print v(xbgr.mr_n69328432)
print v(xbgr.mr_n69328752)
print v(xbgr.mr_n69328864)
print v(xbgr.mr_n69329184)
print v(xbgr.mr_n69329296)
print v(xbgr.mr_n69329616)
print v(xbgr.mr_n69329728)
print v(xbgr.mr_n69330048)
print v(xbgr.mr_n69330160)
print v(xbgr.mr_n69330480)
print v(xbgr.mr_n69330592)
print v(xbgr.mr_n69330912)
print v(xbgr.mr_n69331024)
print v(xbgr.mr_n69331344)
print v(xbgr.mr_n69331456)
print v(xbgr.mr_n69331776)
print v(xbgr.mr_n69331888)
print v(xbgr.mr_n69332208)
print v(xbgr.mr_n69332320)
print v(xbgr.mr_n69332640)
print v(xbgr.mr_n69332752)
print v(xbgr.mr_n69333072)
print v(xbgr.mr_n69333184)
print v(xbgr.mr_n69333616)
print v(xbgr.mr_n69333936)
print v(xbgr.mr_n69334048)
print v(xbgr.mr_n69334368)
print v(xbgr.mr_n69334480)
print v(xbgr.mr_n69334800)
print v(xbgr.mr_n69334912)
print v(xbgr.mr_n69335232)
print v(xbgr.mr_n69335344)
print v(xbgr.mr_n69335664)
print v(xbgr.mr_n69335776)
print v(xbgr.mr_n69336096)
print v(xbgr.mr_n69336208)
print v(xbgr.mr_n69336528)
print v(xbgr.mr_n69336640)
print v(xbgr.mr_n69337072)
print v(xbgr.mr_n69337392)
print v(xbgr.mr_n69337504)
print v(xbgr.mr_n69337824)
print v(xbgr.mr_n69337936)
print v(xbgr.mr_n69338256)
print v(xbgr.mr_n69338368)
print v(xbgr.mr_n69338688)
print v(xbgr.mr_n69338800)
print v(xbgr.mr_n69339120)
print v(xbgr.mr_n69339232)
print v(xbgr.mr_n69339552)
print v(xbgr.mr_n69339664)
print v(xbgr.mr_n69339984)
print v(xbgr.mr_n69340096)
print v(xbgr.mr_n69340416)
print v(xbgr.mr_n69340528)
print v(xbgr.mr_n69340848)
print v(xbgr.mr_n69340960)
print v(xbgr.mr_n69341280)
print v(xbgr.mr_n69341392)
print v(xbgr.mr_n69341712)
print v(xbgr.mr_n69341824)
print v(xbgr.mr_n69342144)
print v(xbgr.mr_n69342256)
print v(xbgr.mr_n69342576)
print v(xbgr.mr_n69342688)
print v(xbgr.mr_n69343120)
print v(xbgr.mr_n69343440)
print v(xbgr.mr_n69343552)
print v(xbgr.mr_n69343872)
print v(xbgr.mr_n69343984)
print v(xbgr.mr_n69344304)
print v(xbgr.mr_n69344416)
print v(xbgr.mr_n69344848)
print v(xbgr.mr_n69345168)
print v(xbgr.mr_n69345280)
print v(xbgr.mr_n69345600)
print v(xbgr.mr_n69345712)
print v(xbgr.mr_n69346032)
print v(xbgr.mr_n69346144)
print v(xbgr.mr_n69346464)
print v(xbgr.mr_n69346576)
print v(xbgr.mr_n69346896)
print v(xbgr.mr_n69347008)
print v(xbgr.mr_n69347440)
print v(xbgr.mr_n69347760)
print v(xbgr.mr_n69347872)
print v(xbgr.mr_n69348192)
print v(xbgr.mr_n69348304)
print v(xbgr.mr_n69348624)
print v(xbgr.mr_n69348736)
print v(xbgr.mr_n69349056)
print v(xbgr.mr_n69349168)
print v(xbgr.mr_n69349488)
print v(xbgr.mr_n69349600)
print v(xbgr.mr_n69349920)
print v(xbgr.mr_n69350032)
print v(xbgr.mr_n69350352)
print v(xbgr.mr_n69350464)
print v(xbgr.mr_n69350784)
print v(xbgr.mr_n69350896)
print v(xbgr.mr_n69351216)
print v(xbgr.mr_n69351328)
print v(xbgr.mr_n69351648)
print v(xbgr.mr_n69351760)
print v(xbgr.mr_n69352080)
print v(xbgr.mr_n69352192)
print v(xbgr.mr_n69352512)
print v(xbgr.mr_n69352624)
print v(xbgr.mr_n69352944)
print v(xbgr.mr_n69353056)
print v(xbgr.mr_n69353488)
print v(xbgr.mr_n69353808)
print v(xbgr.mr_n69353920)
print v(xbgr.mr_n69354240)
print v(xbgr.mr_n69354352)
print v(xbgr.mr_n69354672)
print v(xbgr.mr_n69354784)
print v(xbgr.mr_n69355216)
print v(xbgr.mr_n69355536)
print v(xbgr.mr_n69355648)
print v(xbgr.mr_n69356080)
print v(xbgr.mr_n69356400)
print v(xbgr.mr_n69356512)
print v(xbgr.mr_n69356832)
print v(xbgr.mr_n69356944)
print v(xbgr.mr_n69357264)
print v(xbgr.mr_n69357376)
print v(xbgr.mr_n69357808)
print v(xbgr.mr_n69358128)
print v(xbgr.mr_n69358240)
print v(xbgr.mr_n69358560)
print v(xbgr.mr_n69358672)
print v(xbgr.mr_n69358992)
print v(xbgr.mr_n69359104)
print v(xbgr.mr_n69359424)
print v(xbgr.mr_n69359536)
print v(xbgr.mr_n69359856)
print v(xbgr.mr_n69359968)
print v(xbgr.mr_n69360288)
print v(xbgr.mr_n69360400)
print v(xbgr.mr_n69360720)
print v(xbgr.mr_n69360832)
print v(xbgr.mr_n69361152)
print v(xbgr.mr_n69361264)
print v(xbgr.mr_n69361584)
print v(xbgr.mr_n69361696)
print v(xbgr.mr_n69362128)
print v(xbgr.mr_n69362448)
print v(xbgr.mr_n69362560)
print v(xbgr.mr_n69362880)
print v(xbgr.mr_n69362992)
print v(xbgr.mr_n69363312)
print v(xbgr.mr_n69363424)
print v(xbgr.mr_n69363744)
print v(xbgr.mr_n69363856)
print v(xbgr.mr_n69364176)
print v(xbgr.mr_n69364288)
print v(xbgr.mr_n69364608)
print v(xbgr.mr_n69364720)
print v(xbgr.mr_n69365040)
print v(xbgr.mr_n69365152)
print v(xbgr.mr_n69365472)
print v(xbgr.mr_n69365584)
print v(xbgr.mr_n69365904)
print v(xbgr.mr_n69366016)
print v(xbgr.mr_n69366336)
print v(xbgr.mr_n69366448)
print v(xbgr.mr_n69366768)
print v(xbgr.mr_n69366880)
print v(xbgr.mr_n69367200)
print v(xbgr.mr_n69367312)
print v(xbgr.mr_n69367632)
print v(xbgr.mr_n69367744)
print v(xbgr.mr_n69368064)
print v(xbgr.mr_n69368176)
print v(xbgr.mr_n69368496)
print v(xbgr.mr_n69368608)
print v(xbgr.mr_n69368928)
print v(xbgr.mr_n69369040)
print v(xbgr.mr_n69369360)
print v(xbgr.mr_n69369472)
print v(xbgr.mr_n69369792)
print v(xbgr.mr_n69369904)
print v(xbgr.mr_n69370224)
print v(xbgr.mr_n69370336)
print v(xbgr.mr_n69370656)
print v(xbgr.mr_n69370768)
print v(xbgr.mr_n69371088)
print v(xbgr.mr_n69371200)
print v(xbgr.mr_n69371520)
print v(xbgr.mr_n69371632)
print v(xbgr.mr_n69371952)
print v(xbgr.mr_n69372064)
print v(xbgr.mr_n69372384)
print v(xbgr.mr_n69372496)
print v(xbgr.mr_n69372816)
print v(xbgr.mr_n69372928)
print v(xbgr.mr_n69373248)
print v(xbgr.mr_n69373360)
print v(xbgr.mr_n69373680)
print v(xbgr.mr_n69373792)
print v(xbgr.mr_n69374112)
print v(xbgr.mr_n69374224)
print v(xbgr.mr_n69374544)
print v(xbgr.mr_n69374656)
print v(xbgr.mr_n69374976)
print v(xbgr.mr_n69375088)
print v(xbgr.mr_n69375408)
print v(xbgr.mr_n69375520)
print v(xbgr.mr_n69375840)
print v(xbgr.mr_n69375952)
print v(xbgr.mr_n69376272)
print v(xbgr.mr_n69376384)
print v(xbgr.mr_n69376704)
print v(xbgr.mr_n69376816)
print v(xbgr.mr_n69377136)
print v(xbgr.mr_n69377248)
print v(xbgr.mr_n69377568)
print v(xbgr.mr_n69377680)
print v(xbgr.mr_n69378000)
print v(xbgr.mr_n69378112)
print v(xbgr.mr_n69378432)
print v(xbgr.mr_n69378544)
print v(xbgr.mr_n69378864)
print v(xbgr.mr_n69378976)
print v(xbgr.mr_n69379296)
print v(xbgr.mr_n69379408)
print v(xbgr.mr_n69379728)
print v(xbgr.mr_n69379840)
print v(xbgr.mr_n69380160)
print v(xbgr.mr_n69380272)
print v(xbgr.mr_n69380592)
print v(xbgr.mr_n69380704)
print v(xbgr.mr_n69381024)
print v(xbgr.mr_n69381136)
print v(xbgr.mr_n69381456)
print v(xbgr.mr_n69381568)
print v(xbgr.mr_n69381888)
print v(xbgr.mr_n69382000)
print v(xbgr.mr_n69382320)
print v(xbgr.mr_n69382432)
print v(xbgr.mr_n69382752)
print v(xbgr.mr_n69382864)
print v(xbgr.mr_n69383184)
print v(xbgr.mr_n69383296)
print v(xbgr.mr_n69383616)
print v(xbgr.mr_n69383728)
print v(xbgr.mr_n69384048)
print v(xbgr.mr_n69384160)
print v(xbgr.mr_n69384480)
print v(xbgr.mr_n69384592)
print v(xbgr.mr_n69384912)
print v(xbgr.mr_n69385024)
print v(xbgr.mr_n69385344)
print v(xbgr.mr_n69385456)
print v(xbgr.mr_n69385776)
print v(xbgr.mr_n69385888)
print v(xbgr.mr_n69386208)
print v(xbgr.mr_n69386320)
print v(xbgr.mr_n69386640)
print v(xbgr.mr_n69386752)
print v(xbgr.mr_n69387072)
print v(xbgr.mr_n69387184)
print v(xbgr.mr_n69387504)
print v(xbgr.mr_n69387616)
print v(xbgr.mr_n69387936)
print v(xbgr.mr_n69388048)
print v(xbgr.mr_n69388368)
print v(xbgr.mr_n69388480)
print v(xbgr.mr_n69388800)
print v(xbgr.mr_n69388912)
print v(xbgr.mr_n69389232)
print v(xbgr.mr_n69389344)
print v(xbgr.mr_n69389664)
print v(xbgr.mr_n69389776)
print v(xbgr.mr_n69390096)
print v(xbgr.mr_n69390208)
print v(xbgr.mr_n69390528)
print v(xbgr.mr_n69390640)
print v(xbgr.mr_n69390960)
print v(xbgr.mr_n69391072)
print v(xbgr.mr_n69391392)
print v(xbgr.mr_n69391504)
print v(xbgr.mr_n69391824)
print v(xbgr.mr_n69391936)
print v(xbgr.mr_n69392256)
print v(xbgr.mr_n69392368)
print v(xbgr.mr_n69392688)
print v(xbgr.mr_n69392800)
print v(xbgr.mr_n69393120)
print v(xbgr.mr_n69393232)
print v(xbgr.mr_n69393552)
print v(xbgr.mr_n69393664)
print v(xbgr.mr_n69393984)
print v(xbgr.mr_n69394096)
print v(xbgr.mr_n69394416)
print v(xbgr.mr_n69394528)
print v(xbgr.mr_n69394848)
print v(xbgr.mr_n69394960)
print v(xbgr.mr_n69395280)
print v(xbgr.mr_n69395392)
print v(xbgr.mr_n69395712)
print v(xbgr.mr_n69395824)
print v(xbgr.mr_n69396144)
print v(xbgr.mr_n69396256)
print v(xbgr.mr_n69396576)
print v(xbgr.mr_n69396688)
print v(xbgr.mr_n69397008)
print v(xbgr.mr_n69397120)
print v(xbgr.mr_n69397440)
print v(xbgr.mr_n69397552)
print v(xbgr.mr_n69397872)
print v(xbgr.mr_n69397984)
print v(xbgr.mr_n69398304)
print v(xbgr.mr_n69398416)
print v(xbgr.mr_n69398736)
print v(xbgr.mr_n69398848)
print v(xbgr.mr_n69399168)
print v(xbgr.mr_n69399280)
print v(xbgr.mr_n69399600)
print v(xbgr.mr_n69399712)
print v(xbgr.mr_n69400032)
print v(xbgr.mr_n69400144)
print v(xbgr.mr_n69400464)
print v(xbgr.mr_n69400576)
print v(xbgr.mr_n69400896)
print v(xbgr.mr_n69401008)
print v(xbgr.mr_n69401328)
print v(xbgr.mr_n69401440)
print v(xbgr.mr_n69401760)
print v(xbgr.mr_n69401872)
print v(xbgr.mr_n69402192)
print v(xbgr.mr_n69402304)
print v(xbgr.mr_n69402624)
print v(xbgr.mr_n69402736)
print v(xbgr.mr_n69403056)
print v(xbgr.mr_n69403168)
print v(xbgr.mr_n69403488)
print v(xbgr.mr_n69403600)
print v(xbgr.mr_n69403920)
print v(xbgr.mr_n69404032)
print v(xbgr.mr_n69404352)
print v(xbgr.mr_n69404464)
print v(xbgr.mr_n69404784)
print v(xbgr.mr_n69404896)
print v(xbgr.mr_n69405216)
print v(xbgr.mr_n69405328)
print v(xbgr.mr_n69405648)
print v(xbgr.mr_n69405760)
print v(xbgr.mr_n69406080)
print v(xbgr.mr_n69406192)
print v(xbgr.mr_n69406512)
print v(xbgr.mr_n69406624)
print v(xbgr.mr_n69406944)
print v(xbgr.mr_n69407056)
print v(xbgr.mr_n69407376)
print v(xbgr.mr_n69407488)
print v(xbgr.mr_n69407808)
print v(xbgr.mr_n69407920)
print v(xbgr.mr_n69408240)
print v(xbgr.mr_n69408352)
print v(xbgr.mr_n69408672)
print v(xbgr.mr_n69408784)
print v(xbgr.mr_n69409104)
print v(xbgr.mr_n69409216)
print v(xbgr.mr_n69409536)
print v(xbgr.mr_n69409648)
print v(xbgr.mr_n69409968)
print v(xbgr.mr_n69410080)
print v(xbgr.mr_n69410400)
print v(xbgr.mr_n69410512)
print v(xbgr.mr_n69410832)
print v(xbgr.mr_n69410944)
print v(xbgr.mr_n69411264)
print v(xbgr.mr_n69411376)
print v(xbgr.mr_n69411696)
print v(xbgr.mr_n69411808)
print v(xbgr.mr_n69412128)
print v(xbgr.mr_n69412240)
print v(xbgr.mr_n69412560)
print v(xbgr.mr_n69412672)
print v(xbgr.mr_n69412992)
print v(xbgr.mr_n69413104)
print v(xbgr.mr_n69413424)
print v(xbgr.mr_n69413536)
print v(xbgr.mr_n69413856)
print v(xbgr.mr_n69413968)
print v(xbgr.mr_n69414288)
print v(xbgr.mr_n69414400)
print v(xbgr.mr_n69414720)
print v(xbgr.mr_n69414832)
print v(xbgr.mr_n69415152)
print v(xbgr.mr_n69415264)
print v(xbgr.mr_n69415584)
print v(xbgr.mr_n69415696)
print v(xbgr.mr_n69416016)
print v(xbgr.mr_n69416128)
print v(xbgr.mr_n69416448)
print v(xbgr.mr_n69416560)
print v(xbgr.mr_n69416880)
print v(xbgr.mr_n69416992)
print v(xbgr.mr_n69417312)
print v(xbgr.mr_n69417424)
print v(xbgr.mr_n69417744)
print v(xbgr.mr_n69417856)
print v(xbgr.mr_n69418176)
print v(xbgr.mr_n69418288)
print v(xbgr.mr_n69418608)
print v(xbgr.mr_n69418720)
print v(xbgr.mr_n69419040)
print v(xbgr.mr_n69419152)
print v(xbgr.mr_n69419472)
print v(xbgr.mr_n69419584)
print v(xbgr.mr_n69419904)
print v(xbgr.mr_n69420016)
print v(xbgr.mr_n69420336)
print v(xbgr.mr_n69420448)
print v(xbgr.mr_n69420768)
print v(xbgr.mr_n69420880)
print v(xbgr.mr_n69421200)
print v(xbgr.mr_n69421312)
print v(xbgr.mr_n69421632)
print v(xbgr.mr_n69421744)
print v(xbgr.mr_n69422064)
print v(xbgr.mr_n69422176)
print v(xbgr.mr_n69422496)
print v(xbgr.mr_n69422608)
print v(xbgr.mr_n69422928)
print v(xbgr.mr_n69423040)
print v(xbgr.mr_n69423360)
print v(xbgr.mr_n69423472)
print v(xbgr.mr_n69423792)
print v(xbgr.mr_n69423904)
print v(xbgr.mr_n69424224)
print v(xbgr.mr_n69424336)
print v(xbgr.mr_n69424656)
print v(xbgr.mr_n69424768)
print v(xbgr.mr_n69425088)
print v(xbgr.mr_n69425200)
print v(xbgr.mr_n69425520)
print v(xbgr.mr_n69425632)
print v(xbgr.mr_n69425952)
print v(xbgr.mr_n69426064)
print v(xbgr.mr_n69426384)
print v(xbgr.mr_n69426496)
print v(xbgr.mr_n69426816)
print v(xbgr.mr_n69426928)
print v(xbgr.mr_n69427248)
print v(xbgr.mr_n69427360)
print v(xbgr.mr_n69427680)
print v(xbgr.mr_n69427792)
print v(xbgr.mr_n69428112)
print v(xbgr.mr_n69428224)
print v(xbgr.mr_n69428544)
print v(xbgr.mr_n69428656)
print v(xbgr.mr_n69428976)
print v(xbgr.mr_n69429088)
print v(xbgr.mr_n69429408)
print v(xbgr.mr_n69429520)
print v(xbgr.mr_n69429840)
print v(xbgr.mr_n69429952)
print v(xbgr.mr_n69430272)
print v(xbgr.mr_n69430384)
print v(xbgr.mr_n69430704)
print v(xbgr.mr_n69430816)
print v(xbgr.mr_n69431136)
print v(xbgr.mr_n69431248)
print v(xbgr.mr_n69431568)
print v(xbgr.mr_n69431680)
print v(xbgr.mr_n69432000)
print v(xbgr.mr_n69432112)
print v(xbgr.mr_n69432432)
print v(xbgr.mr_n69432544)
print v(xbgr.mr_n69432864)
print v(xbgr.mr_n69432976)
print v(xbgr.mr_n69433296)
print v(xbgr.mr_n69433408)
print v(xbgr.mr_n69433728)
print v(xbgr.mr_n69433840)
print v(xbgr.mr_n69434160)
print v(xbgr.mr_n69434272)
print v(xbgr.mr_n69434592)
print v(xbgr.mr_n69434704)
print v(xbgr.mr_n69435024)
print v(xbgr.mr_n69435136)
print v(xbgr.mr_n69435456)
print v(xbgr.mr_n69435568)
print v(xbgr.mr_n69435888)
print v(xbgr.mr_n69436000)
print v(xbgr.mr_n69436320)
print v(xbgr.mr_n69436432)
print v(xbgr.mr_n69436752)
print v(xbgr.mr_n69436864)
print v(xbgr.mr_n69437184)
print v(xbgr.mr_n69437296)
print v(xbgr.mr_n69437616)
print v(xbgr.mr_n69437728)
print v(xbgr.mr_n69438048)
print v(xbgr.mr_n69438160)
print v(xbgr.mr_n69438480)
print v(xbgr.mr_n69438592)
print v(xbgr.mr_n69438912)
print v(xbgr.mr_n69439024)
print v(xbgr.mr_n69439344)
print v(xbgr.mr_n69439456)
print v(xbgr.mr_n69439776)
print v(xbgr.mr_n69439888)
print v(xbgr.mr_n69440208)
print v(xbgr.mr_n69440320)
print v(xbgr.mr_n69440640)
print v(xbgr.mr_n69440752)
print v(xbgr.mr_n69441072)
print v(xbgr.mr_n69441184)
print v(xbgr.mr_n69441504)
print v(xbgr.mr_n69441616)
print v(xbgr.mr_n69441936)
print v(xbgr.mr_n69442048)
print v(xbgr.mr_n69442368)
print v(xbgr.mr_n69442480)
print v(xbgr.mr_n69442800)
print v(xbgr.mr_n69442912)
print v(xbgr.mr_n69443232)
print v(xbgr.mr_n69443344)
print v(xbgr.mr_n69443664)
print v(xbgr.mr_n69443776)
print v(xbgr.mr_n69444096)
print v(xbgr.mr_n69444208)
print v(xbgr.mr_n69444528)
print v(xbgr.mr_n69444640)
print v(xbgr.mr_n69444960)
print v(xbgr.mr_n69445072)
print v(xbgr.mr_n69445392)
print v(xbgr.mr_n69445504)
print v(xbgr.mr_n69445824)
print v(xbgr.mr_n69445936)
print v(xbgr.mr_n69446256)
print v(xbgr.mr_n69446368)
print v(xbgr.mr_n69446688)
print v(xbgr.mr_n69446800)
print v(xbgr.mr_n69447120)
print v(xbgr.mr_n69447232)
print v(xbgr.mr_n69447552)
print v(xbgr.mr_n69447664)
print v(xbgr.mr_n69447984)
print v(xbgr.mr_n69448096)
print v(xbgr.mr_n69448416)
print v(xbgr.mr_n69448528)
print v(xbgr.mr_n69448848)
print v(xbgr.mr_n69448960)
print v(xbgr.mr_n69449280)
print v(xbgr.mr_n69449392)
print v(xbgr.mr_n69449712)
print v(xbgr.mr_n69449824)
print v(xbgr.mr_n69450144)
print v(xbgr.mr_n69450256)
print v(xbgr.mr_n69450576)
print v(xbgr.mr_n69450688)
print v(xbgr.mr_n69451008)
print v(xbgr.mr_n69451120)
print v(xbgr.mr_n69451440)
print v(xbgr.mr_n69451552)
print v(xbgr.mr_n69451872)
print v(xbgr.mr_n69451984)
print v(xbgr.mr_n69452304)
print v(xbgr.mr_n69452416)
print v(xbgr.mr_n69452736)
print v(xbgr.mr_n69452848)
print v(xbgr.mr_n69453168)
print v(xbgr.mr_n69453280)
print v(xbgr.mr_n69453600)
print v(xbgr.mr_n69453712)
print v(xbgr.mr_n69454032)
print v(xbgr.mr_n69454144)
print v(xbgr.mr_n69454464)
print v(xbgr.mr_n69454576)
print v(xbgr.mr_n69454896)
print v(xbgr.mr_n69455008)
print v(xbgr.mr_n69455328)
print v(xbgr.mr_n69455440)
print v(xbgr.mr_n69455760)
print v(xbgr.mr_n69455872)
print v(xbgr.mr_n69456192)
print v(xbgr.mr_n69456304)
print v(xbgr.mr_n69456624)
print v(xbgr.mr_n69456736)
print v(xbgr.mr_n69457056)
print v(xbgr.mr_n69457168)
print v(xbgr.mr_n69457488)
print v(xbgr.mr_n69457600)
print v(xbgr.mr_n69457920)
print v(xbgr.mr_n69458032)
print v(xbgr.mr_n69458352)
print v(xbgr.mr_n69458464)
print v(xbgr.mr_n69458784)
print v(xbgr.mr_n69458896)
print v(xbgr.mr_n69459216)
print v(xbgr.mr_n69459328)
print v(xbgr.mr_n69459648)
print v(xbgr.mr_n69459760)
print v(xbgr.mr_n69460080)
print v(xbgr.mr_n69460192)
print v(xbgr.mr_n69460512)
print v(xbgr.mr_n69460624)
print v(xbgr.mr_n69460944)
print v(xbgr.mr_n69461056)
print v(xbgr.mr_n69461376)
print v(xbgr.mr_n69461488)
print v(xbgr.mr_n69461808)
print v(xbgr.mr_n69461920)
print v(xbgr.mr_n69462240)
print v(xbgr.mr_n69462352)
print v(xbgr.mr_n69462672)
print v(xbgr.mr_n69462784)
print v(xbgr.mr_n69463104)
print v(xbgr.mr_n69463216)
print v(xbgr.mr_n69463536)
print v(xbgr.mr_n69463648)
print v(xbgr.mr_n69463968)
print v(xbgr.mr_n69464080)
print v(xbgr.mr_n69464400)
print v(xbgr.mr_n69464512)
print v(xbgr.mr_n69464832)
print v(xbgr.mr_n69464944)
print v(xbgr.mr_n69465264)
print v(xbgr.mr_n69465376)
print v(xbgr.mr_n69465696)
print v(xbgr.mr_n69465808)
print v(xbgr.mr_n69466128)
print v(xbgr.mr_n69466240)
print v(xbgr.mr_n69466672)
print v(xbgr.mr_n69466992)
print v(xbgr.mr_n69467104)
print v(xbgr.mr_n69467424)
print v(xbgr.mr_n69467536)
print v(xbgr.mr_n69467856)
print v(xbgr.mr_n69467968)
print v(xbgr.mr_n69468288)
print v(xbgr.mr_n69468400)
print v(xbgr.mr_n69468720)
print v(xbgr.mr_n69468832)
print v(xbgr.mr_n69469264)
print v(xbgr.mr_n69469584)
print v(xbgr.mr_n69469696)
print v(xbgr.mr_n69470016)
print v(xbgr.mr_n69470128)
print v(xbgr.mr_n69470448)
print v(xbgr.mr_n69470560)
print v(xbgr.mr_n69470880)
print v(xbgr.mr_n69470992)
print v(xbgr.mr_n69471312)
print v(xbgr.mr_n69471424)
print v(xbgr.mr_n69471856)
print v(xbgr.mr_n69472176)
print v(xbgr.mr_n69472288)
print v(xbgr.mr_n69472608)
print v(xbgr.mr_n69472720)
print v(xbgr.mr_n69473040)
print v(xbgr.mr_n69473152)
print v(xbgr.mr_n69473472)
print v(xbgr.mr_n69473584)
print v(xbgr.mr_n69473904)
print v(xbgr.mr_n69474016)
print v(xbgr.mr_n69474336)
print v(xbgr.mr_n69474448)
print v(xbgr.mr_n69474768)
print v(xbgr.mr_n69474880)
print v(xbgr.mr_n69475312)
print v(xbgr.mr_n69475632)
print v(xbgr.mr_n69475744)
print v(xbgr.mr_n69476176)
print v(xbgr.mr_n69476496)
print v(xbgr.mr_n69476608)
print v(xbgr.mr_n69476928)
print v(xbgr.mr_n69477040)
print v(xbgr.mr_n69477360)
print v(xbgr.mr_n69477472)
print v(xbgr.mr_n69477792)
print v(xbgr.mr_n69477904)
print v(xbgr.mr_n69478224)
print v(xbgr.mr_n69478336)
print v(xbgr.mr_n69478768)
print v(xbgr.mr_n69479088)
print v(xbgr.mr_n69479200)
print v(xbgr.mr_n69479632)
print v(xbgr.mr_n69479952)
print v(xbgr.mr_n69480064)
print v(xbgr.mr_n69480384)
print v(xbgr.mr_n69480496)
print v(xbgr.mr_n69480816)
print v(xbgr.mr_n69480928)
print v(xbgr.mr_n69481248)
print v(xbgr.mr_n69481360)
print v(xbgr.mr_n69481680)
print v(xbgr.mr_n69481792)
print v(xbgr.mr_n69482112)
print v(xbgr.mr_n69482224)
print v(xbgr.mr_n69482544)
print v(xbgr.mr_n69482656)
print v(xbgr.mr_n69482976)
print v(xbgr.mr_n69483088)
print v(xbgr.mr_n69483408)
print v(xbgr.mr_n69483520)
print v(xbgr.mr_n69483840)
print v(xbgr.mr_n69483952)
print v(xbgr.mr_n69484272)
print v(xbgr.mr_n69484384)
print v(xbgr.mr_n69484704)
print v(xbgr.mr_n69484816)
print v(xbgr.mr_n69485136)
print v(xbgr.mr_n69485248)
print v(xbgr.mr_n69485568)
print v(xbgr.mr_n69485680)
print v(xbgr.mr_n69486000)
print v(xbgr.mr_n69486112)
print v(xbgr.mr_n69486432)
print v(xbgr.mr_n69486544)
print v(xbgr.mr_n69486864)
print v(xbgr.mr_n69486976)
print v(xbgr.mr_n69487296)
print v(xbgr.mr_n69487408)
print v(xbgr.mr_n69487728)
print v(xbgr.mr_n69487840)
print v(xbgr.mr_n69488160)
print v(xbgr.mr_n69488272)
print v(xbgr.mr_n69488592)
print v(xbgr.mr_n69488704)
print v(xbgr.mr_n69489024)
print v(xbgr.mr_n69489136)
print v(xbgr.mr_n69489456)
print v(xbgr.mr_n69489568)
print v(xbgr.mr_n69489888)
print v(xbgr.mr_n69490000)
print v(xbgr.mr_n69490320)
print v(xbgr.mr_n69490432)
print v(xbgr.mr_n69490752)
print v(xbgr.mr_n69490864)
print v(xbgr.mr_n69491184)
print v(xbgr.mr_n69491296)
print v(xbgr.mr_n69491616)
print v(xbgr.mr_n69491728)
print v(xbgr.mr_n69492048)
print v(xbgr.mr_n69492160)
print v(xbgr.mr_n69492480)
print v(xbgr.mr_n69492592)
print v(xbgr.mr_n69492912)
print v(xbgr.mr_n69493024)
print v(xbgr.mr_n69493344)
print v(xbgr.mr_n69493456)
print v(xbgr.mr_n69493776)
print v(xbgr.mr_n69493888)
print v(xbgr.mr_n69494208)
print v(xbgr.mr_n69494320)
print v(xbgr.mr_n69494640)
print v(xbgr.mr_n69494752)
print v(xbgr.mr_n69495072)
print v(xbgr.mr_n69495184)
print v(xbgr.mr_n69495504)
print v(xbgr.mr_n69495616)
print v(xbgr.mr_n69495936)
print v(xbgr.mr_n69496048)
print v(xbgr.mr_n69496368)
print v(xbgr.mr_n69496480)
print v(xbgr.mr_n69496800)
print v(xbgr.mr_n69496912)
print v(xbgr.mr_n69497232)
print v(xbgr.mr_n69497344)
print v(xbgr.mr_n69497664)
print v(xbgr.mr_n69497776)
print v(xbgr.mr_n69498096)
print v(xbgr.mr_n69498208)
print v(xbgr.mr_n69498528)
print v(xbgr.mr_n69498640)
print v(xbgr.mr_n69498960)
print v(xbgr.mr_n69499072)
print v(xbgr.mr_n69499392)
print v(xbgr.mr_n69499504)
print v(xbgr.mr_n69499824)
print v(xbgr.mr_n69499936)
print v(xbgr.mr_n69500256)
print v(xbgr.mr_n69500368)
print v(xbgr.mr_n69500688)
print v(xbgr.mr_n69500800)
print v(xbgr.mr_n69501120)
print v(xbgr.mr_n69501232)
print v(xbgr.mr_n69501552)
print v(xbgr.mr_n69501664)
print v(xbgr.mr_n69501984)
print v(xbgr.mr_n69502096)
print v(xbgr.mr_n69502416)
print v(xbgr.mr_n69502528)
print v(xbgr.mr_n69502848)
print v(xbgr.mr_n69502960)
print v(xbgr.mr_n69503280)
print v(xbgr.mr_n69503392)
print v(xbgr.mr_n69503712)
print v(xbgr.mr_n69503824)
print v(xbgr.mr_n69504144)
print v(xbgr.mr_n69504256)
print v(xbgr.mr_n69504576)
print v(xbgr.mr_n69504688)
print v(xbgr.mr_n69505008)
print v(xbgr.mr_n69505120)
print v(xbgr.mr_n69505440)
print v(xbgr.mr_n69505552)
print v(xbgr.mr_n69505872)
print v(xbgr.mr_n69505984)
print v(xbgr.mr_n69506304)
print v(xbgr.mr_n69506416)
print v(xbgr.mr_n69506736)
print v(xbgr.mr_n69506848)
print v(xbgr.mr_n69507168)
print v(xbgr.mr_n69507280)
print v(xbgr.mr_n69507600)
print v(xbgr.mr_n69507712)
print v(xbgr.mr_n69508032)
print v(xbgr.mr_n69508144)
print v(xbgr.mr_n69508464)
print v(xbgr.mr_n69508576)
print v(xbgr.mr_n69508896)
print v(xbgr.mr_n69509008)
print v(xbgr.mr_n69509328)
print v(xbgr.mr_n69509440)
print v(xbgr.mr_n69509760)
print v(xbgr.mr_n69509872)
print v(xbgr.mr_n69510192)
print v(xbgr.mr_n69510304)
print v(xbgr.mr_n69510624)
print v(xbgr.mr_n69510736)
print v(xbgr.mr_n69511056)
print v(xbgr.mr_n69511168)
print v(xbgr.mr_n69511488)
print v(xbgr.mr_n69511600)
print v(xbgr.mr_n69511920)
print v(xbgr.mr_n69512032)
print v(xbgr.mr_n69512352)
print v(xbgr.mr_n69512464)
print v(xbgr.mr_n69512784)
print v(xbgr.mr_n69512896)
print v(xbgr.mr_n69513328)
print v(xbgr.mr_n69513648)
print v(xbgr.mr_n69513760)
print v(xbgr.mr_n69514080)
print v(xbgr.mr_n69514192)
print v(xbgr.mr_n69514512)
print v(xbgr.mr_n69514624)
print v(xbgr.mr_n69515056)
print v(xbgr.mr_n69515376)
print v(xbgr.mr_n69515488)
print v(xbgr.mr_n69515920)
print v(xbgr.mr_n69516240)
print v(xbgr.mr_n69516352)
print v(xbgr.mr_n69516672)
print v(xbgr.mr_n69516784)
print v(xbgr.mr_n69517104)
print v(xbgr.mr_n69517216)
print v(xbgr.mr_n69517536)
print v(xbgr.mr_n69517648)
print v(xbgr.mr_n69517968)
print v(xbgr.mr_n69518080)
print v(xbgr.mr_n69518400)
print v(xbgr.mr_n69518512)
print v(xbgr.mr_n69518832)
print v(xbgr.mr_n69518944)
print v(xbgr.mr_n69519264)
print v(xbgr.mr_n69519376)
print v(xbgr.mr_n69519696)
print v(xbgr.mr_n69519808)
print v(xbgr.mr_n69520128)
print v(xbgr.mr_n69520240)
print v(xbgr.mr_n69520560)
print v(xbgr.mr_n69520672)
print v(xbgr.mr_n69520992)
print v(xbgr.mr_n69521104)
print v(xbgr.mr_n69521424)
print v(xbgr.mr_n69521536)
print v(xbgr.mr_n69521856)
print v(xbgr.mr_n69521968)
print v(xbgr.mr_n69522288)
print v(xbgr.mr_n69522400)
print v(xbgr.mr_n69522720)
print v(xbgr.mr_n69522832)
print v(xbgr.mr_n69523152)
print v(xbgr.mr_n69523264)
print v(xbgr.mr_n69523584)
print v(xbgr.mr_n69523696)
print v(xbgr.mr_n69524016)
print v(xbgr.mr_n69524128)
print v(xbgr.mr_n69524448)
print v(xbgr.mr_n69524560)
print v(xbgr.mr_n69524880)
print v(xbgr.mr_n69524992)
print v(xbgr.mr_n69525312)
print v(xbgr.mr_n69525424)
print v(xbgr.mr_n69525744)
print v(xbgr.mr_n69525856)
print v(xbgr.mr_n69526176)
print v(xbgr.mr_n69526288)
print v(xbgr.mr_n69526608)
print v(xbgr.mr_n69526720)
print v(xbgr.mr_n69527040)
print v(xbgr.mr_n69527152)
print v(xbgr.mr_n69527472)
print v(xbgr.mr_n69527584)
print v(xbgr.mr_n69528016)
print v(xbgr.mr_n69528336)
print v(xbgr.mr_n69528448)
print v(xbgr.mr_n69528768)
print v(xbgr.mr_n69528880)
print v(xbgr.mr_n69529200)
print v(xbgr.mr_n69529312)
print v(xbgr.mr_n69529632)
print v(xbgr.mr_n69529744)
print v(xbgr.mr_n69530064)
print v(xbgr.mr_n69530176)
print v(xbgr.mr_n69530496)
print v(xbgr.mr_n69530608)
print v(xbgr.mr_n69530928)
print v(xbgr.mr_n69531040)
print v(xbgr.mr_n69531360)
print v(xbgr.mr_n69531472)
print v(xbgr.mr_n69531792)
print v(xbgr.mr_n69531904)
print v(xbgr.mr_n69532336)
print v(xbgr.mr_n69532656)
print v(xbgr.mr_n69532768)
print v(xbgr.mr_n69533088)
print v(xbgr.mr_n69533200)
print v(xbgr.mr_n69533520)
print v(xbgr.mr_n69533632)
print v(xbgr.mr_n69534064)
print v(xbgr.mr_n69534384)
print v(xbgr.mr_n69534496)
print v(xbgr.mr_n69534816)
print v(xbgr.mr_n69534928)
print v(xbgr.mr_n69535248)
print v(xbgr.mr_n69535360)
print v(xbgr.mr_n69535680)
print v(xbgr.mr_n69535792)
print v(xbgr.mr_n69536112)
print v(xbgr.mr_n69536224)
print v(xbgr.mr_n69536656)
print v(xbgr.mr_n69536976)
print v(xbgr.mr_n69537088)
print v(xbgr.mr_n69537408)
print v(xbgr.mr_n69537520)
print v(xbgr.mr_n69537840)
print v(xbgr.mr_n69537952)
print v(xbgr.mr_n69538272)
print v(xbgr.mr_n69538384)
print v(xbgr.mr_n69538704)
print v(xbgr.mr_n69538816)
print v(xbgr.mr_n69539136)
print v(xbgr.mr_n69539248)
print v(xbgr.mr_n69539568)
print v(xbgr.mr_n69539680)
print v(xbgr.mr_n69540000)
print v(xbgr.mr_n69540112)
print v(xbgr.mr_n69540432)
print v(xbgr.mr_n69540544)
print v(xbgr.mr_n69540864)
print v(xbgr.mr_n69540976)
print v(xbgr.mr_n69541296)
print v(xbgr.mr_n69541408)
print v(xbgr.mr_n69541728)
print v(xbgr.mr_n69541840)
print v(xbgr.mr_n69542160)
print v(xbgr.mr_n69542272)
print v(xbgr.mr_n69542592)
print v(xbgr.mr_n69542704)
print v(xbgr.mr_n69543024)
print v(xbgr.mr_n69543136)
print v(xbgr.mr_n69543456)
print v(xbgr.mr_n69543568)
print v(xbgr.mr_n69543888)
print v(xbgr.mr_n69544000)
print v(xbgr.mr_n69544320)
print v(xbgr.mr_n69544432)
print v(xbgr.mr_n69544752)
print v(xbgr.mr_n69544864)
print v(xbgr.mr_n69545184)
print v(xbgr.mr_n69545296)
print v(xbgr.mr_n69545616)
print v(xbgr.mr_n69545728)
print v(xbgr.mr_n69546048)
print v(xbgr.mr_n69546160)
print v(xbgr.mr_n69546480)
print v(xbgr.mr_n69546592)
print v(xbgr.mr_n69546912)
print v(xbgr.mr_n69547024)
print v(xbgr.mr_n69547344)
print v(xbgr.mr_n69547456)
print v(xbgr.mr_n69547776)
print v(xbgr.mr_n69547888)
print v(xbgr.mr_n69548208)
print v(xbgr.mr_n69548320)
print v(xbgr.mr_n69548640)
print v(xbgr.mr_n69548752)
print v(xbgr.mr_n69549072)
print v(xbgr.mr_n69549184)
print v(xbgr.mr_n69549504)
print v(xbgr.mr_n69549616)
print v(xbgr.mr_n69549936)
print v(xbgr.mr_n69550048)
print v(xbgr.mr_n69550368)
print v(xbgr.mr_n69550480)
print v(xbgr.mr_n69550800)
print v(xbgr.mr_n69550912)
print v(xbgr.mr_n69551232)
print v(xbgr.mr_n69551344)
print v(xbgr.mr_n69551664)
print v(xbgr.mr_n69551776)
print v(xbgr.mr_n69552096)
print v(xbgr.mr_n69552208)
print v(xbgr.mr_n69552528)
print v(xbgr.mr_n69552640)
print v(xbgr.mr_n69552960)
print v(xbgr.mr_n69553072)
print v(xbgr.mr_n69553392)
print v(xbgr.mr_n69553504)
print v(xbgr.mr_n69553824)
print v(xbgr.mr_n69553936)
print v(xbgr.mr_n69554256)
print v(xbgr.mr_n69554368)
print v(xbgr.mr_n69554688)
print v(xbgr.mr_n69554800)
print v(xbgr.mr_n69555120)
print v(xbgr.mr_n69555232)
print v(xbgr.mr_n69555552)
print v(xbgr.mr_n69555664)
print v(xbgr.mr_n69555984)
print v(xbgr.mr_n69556096)
print v(xbgr.mr_n69556416)
print v(xbgr.mr_n69556528)
print v(xbgr.mr_n69556848)
print v(xbgr.mr_n69556960)
print v(xbgr.mr_n69557280)
print v(xbgr.mr_n69557392)
print v(xbgr.mr_n69557712)
print v(xbgr.mr_n69557824)
print v(xbgr.mr_n69558144)
print v(xbgr.mr_n69558256)
print v(xbgr.mr_n69558576)
print v(xbgr.mr_n69558688)
print v(xbgr.mr_n69559008)
print v(xbgr.mr_n69559120)
print v(xbgr.mr_n69559440)
print v(xbgr.mr_n69559552)
print v(xbgr.mr_n69559872)
print v(xbgr.mr_n69559984)
print v(xbgr.mr_n69560304)
print v(xbgr.mr_n69560416)
print v(xbgr.mr_n69560736)
print v(xbgr.mr_n69560848)
print v(xbgr.mr_n69561168)
print v(xbgr.mr_n69561280)
print v(xbgr.mr_n69561600)
print v(xbgr.mr_n69561712)
print v(xbgr.mr_n69562032)
print v(xbgr.mr_n69562144)
print v(xbgr.mr_n69562464)
print v(xbgr.mr_n69562576)
print v(xbgr.mr_n69562896)
print v(xbgr.mr_n69563008)
print v(xbgr.mr_n69563328)
print v(xbgr.mr_n69563440)
print v(xbgr.mr_n69563760)
print v(xbgr.mr_n69563872)
print v(xbgr.mr_n69564192)
print v(xbgr.mr_n69564304)
print v(xbgr.mr_n69564624)
print v(xbgr.mr_n69564736)
print v(xbgr.mr_n69565056)
print v(xbgr.mr_n69565168)
print v(xbgr.mr_n69565488)
print v(xbgr.mr_n69565600)
print v(xbgr.mr_n69565920)
print v(xbgr.mr_n69566032)
print v(xbgr.mr_n69566352)
print v(xbgr.mr_n69566464)
print v(xbgr.mr_n69566896)
print v(xbgr.mr_n69567216)
print v(xbgr.mr_n69567328)
print v(xbgr.mr_n69567648)
print v(xbgr.mr_n69567760)
print v(xbgr.mr_n69568080)
print v(xbgr.mr_n69568192)
print v(xbgr.mr_n69568624)
print v(xbgr.mr_n69568944)
print v(xbgr.mr_n69569056)
print v(xbgr.mr_n69569488)
print v(xbgr.mr_n69569808)
print v(xbgr.mr_n69569920)
print v(xbgr.mr_n69570240)
print v(xbgr.mr_n69570352)
print v(xbgr.mr_n69570672)
print v(xbgr.mr_n69570784)
print v(xbgr.mr_n69571104)
print v(xbgr.mr_n69571216)
print v(xbgr.mr_n69571536)
print v(xbgr.mr_n69571648)
print v(xbgr.mr_n69571968)
print v(xbgr.mr_n69572080)
print v(xbgr.mr_n69572400)
print v(xbgr.mr_n69572512)
print v(xbgr.mr_n69572832)
print v(xbgr.mr_n69572944)
print v(xbgr.mr_n69573264)
print v(xbgr.mr_n69573376)
print v(xbgr.mr_n69573696)
print v(xbgr.mr_n69573808)
print v(xbgr.mr_n69574128)
print v(xbgr.mr_n69574240)
print v(xbgr.mr_n69574560)
print v(xbgr.mr_n69574672)
print v(xbgr.mr_n69574992)
print v(xbgr.mr_n69575104)
print v(xbgr.mr_n69575424)
print v(xbgr.mr_n69575536)
print v(xbgr.mr_n69575856)
print v(xbgr.mr_n69575968)
print v(xbgr.mr_n69576288)
print v(xbgr.mr_n69576400)
print v(xbgr.mr_n69576720)
print v(xbgr.mr_n69576832)
print v(xbgr.mr_n69577152)
print v(xbgr.mr_n69577264)
print v(xbgr.mr_n69577584)
print v(xbgr.mr_n69577696)
print v(xbgr.mr_n69578016)
print v(xbgr.mr_n69578128)
print v(xbgr.mr_n69578448)
print v(xbgr.mr_n69578560)
print v(xbgr.mr_n69578880)
print v(xbgr.mr_n69578992)
print v(xbgr.mr_n69579312)
print v(xbgr.mr_n69579424)
print v(xbgr.mr_n69579744)
print v(xbgr.mr_n69579856)
print v(xbgr.mr_n69580176)
print v(xbgr.mr_n69580288)
print v(xbgr.mr_n69580608)
print v(xbgr.mr_n69580720)
print v(xbgr.mr_n69581040)
print v(xbgr.mr_n69581152)
print v(xbgr.mr_n69581472)
print v(xbgr.mr_n69581584)
print v(xbgr.mr_n69581904)
print v(xbgr.mr_n69582016)
print v(xbgr.mr_n69582336)
print v(xbgr.mr_n69582448)
print v(xbgr.mr_n69582768)
print v(xbgr.mr_n69582880)
print v(xbgr.mr_n69583200)
print v(xbgr.mr_n69583312)
print v(xbgr.mr_n69583632)
print v(xbgr.mr_n69583744)
print v(xbgr.mr_n69584064)
print v(xbgr.mr_n69584176)
print v(xbgr.mr_n69584496)
print v(xbgr.mr_n69584608)
print v(xbgr.mr_n69584928)
print v(xbgr.mr_n69585040)
print v(xbgr.mr_n69585360)
print v(xbgr.mr_n69585472)
print v(xbgr.mr_n69585792)
print v(xbgr.mr_n69585904)
print v(xbgr.mr_n69586224)
print v(xbgr.mr_n69586336)
print v(xbgr.mr_n69586656)
print v(xbgr.mr_n69586768)
print v(xbgr.mr_n69587088)
print v(xbgr.mr_n69587200)
print v(xbgr.mr_n69587520)
print v(xbgr.mr_n69587632)
print v(xbgr.mr_n69587952)
print v(xbgr.mr_n69588064)
print v(xbgr.mr_n69588384)
print v(xbgr.mr_n69588496)
print v(xbgr.mr_n69588816)
print v(xbgr.mr_n69588928)
print v(xbgr.mr_n69589248)
print v(xbgr.mr_n69589360)
print v(xbgr.mr_n69589680)
print v(xbgr.mr_n69589792)
print v(xbgr.mr_n69590112)
print v(xbgr.mr_n69590224)
print v(xbgr.mr_n69590544)
print v(xbgr.mr_n69590656)
print v(xbgr.mr_n69590976)
print v(xbgr.mr_n69591088)
print v(xbgr.mr_n69591408)
print v(xbgr.mr_n69591520)
print v(xbgr.mr_n69591840)
print v(xbgr.mr_n69591952)
print v(xbgr.mr_n69592272)
print v(xbgr.mr_n69592384)
print v(xbgr.mr_n69592704)
print v(xbgr.mr_n69592816)
print v(xbgr.mr_n69593136)
print v(xbgr.mr_n69593248)
print v(xbgr.mr_n69593568)
print v(xbgr.mr_n69593680)
print v(xbgr.mr_n69594000)
print v(xbgr.mr_n69594112)
print v(xbgr.mr_n69594432)
print v(xbgr.mr_n69594544)
print v(xbgr.mr_n69594864)
print v(xbgr.mr_n69594976)
print v(xbgr.mr_n69595296)
print v(xbgr.mr_n69595408)
print v(xbgr.mr_n69595728)
print v(xbgr.mr_n69595840)
print v(xbgr.mr_n69596160)
print v(xbgr.mr_n69596272)
print v(xbgr.mr_n69596592)
print v(xbgr.mr_n69596704)
print v(xbgr.mr_n69597024)
print v(xbgr.mr_n69597136)
print v(xbgr.mr_n69597456)
print v(xbgr.mr_n69597568)
print v(xbgr.mr_n69597888)
print v(xbgr.mr_n69598000)
print v(xbgr.mr_n69598320)
print v(xbgr.mr_n69598432)
print v(xbgr.mr_n69598752)
print v(xbgr.mr_n69598864)
print v(xbgr.mr_n69599184)
print v(xbgr.mr_n69599296)
print v(xbgr.mr_n69599616)
print v(xbgr.mr_n69599728)
print v(xbgr.mr_n69600048)
print v(xbgr.mr_n69600160)
print v(xbgr.mr_n69600480)
print v(xbgr.mr_n69600592)
print v(xbgr.mr_n69600912)
print v(xbgr.mr_n69601024)
print v(xbgr.mr_n69601344)
print v(xbgr.mr_n69601456)
print v(xbgr.mr_n69601776)
print v(xbgr.mr_n69601888)
print v(xbgr.mr_n69602208)
print v(xbgr.mr_n69602320)
print v(xbgr.mr_n69602640)
print v(xbgr.mr_n69602752)
print v(xbgr.mr_n69603072)
print v(xbgr.mr_n69603184)
print v(xbgr.mr_n69603504)
print v(xbgr.mr_n69603616)
print v(xbgr.mr_n69603936)
print v(xbgr.mr_n69604048)
print v(xbgr.mr_n69604368)
print v(xbgr.mr_n69604480)
print v(xbgr.mr_n69604800)
print v(xbgr.mr_n69604912)
print v(xbgr.mr_n69605232)
print v(xbgr.mr_n69605344)
print v(xbgr.mr_n69605664)
print v(xbgr.mr_n69605776)
print v(xbgr.mr_n69606096)
print v(xbgr.mr_n69606208)
print v(xbgr.mr_n69606528)
print v(xbgr.mr_n69606640)
print v(xbgr.mr_n69606960)
print v(xbgr.mr_n69607072)
print v(xbgr.mr_n69607392)
print v(xbgr.mr_n69607504)
print v(xbgr.mr_n69607824)
print v(xbgr.mr_n69607936)
print v(xbgr.mr_n69608256)
print v(xbgr.mr_n69608368)
print v(xbgr.mr_n69608688)
print v(xbgr.mr_n69608800)
print v(xbgr.mr_n69609120)
print v(xbgr.mr_n69609232)
print v(xbgr.mr_n69609552)
print v(xbgr.mr_n69609664)
print v(xbgr.mr_n69609984)
print v(xbgr.mr_n69610096)
print v(xbgr.mr_n69610416)
print v(xbgr.mr_n69610528)
print v(xbgr.mr_n69610848)
print v(xbgr.mr_n69610960)
print v(xbgr.mr_n69611280)
print v(xbgr.mr_n69611392)
print v(xbgr.mr_n69611712)
print v(xbgr.mr_n69611824)
print v(xbgr.mr_n69612144)
print v(xbgr.mr_n69612256)
print v(xbgr.mr_n69612576)
print v(xbgr.mr_n69612688)
print v(xbgr.mr_n69613008)
print v(xbgr.mr_n69613120)
print v(xbgr.mr_n69613440)
print v(xbgr.mr_n69613552)
print v(xbgr.mr_n69613872)
print v(xbgr.mr_n69613984)
print v(xbgr.mr_n69614304)
print v(xbgr.mr_n69614416)
print v(xbgr.mr_n69614736)
print v(xbgr.mr_n69614848)
print v(xbgr.mr_n69615168)
print v(xbgr.mr_n69615280)
print v(xbgr.mr_n69615600)
print v(xbgr.mr_n69615712)
print v(xbgr.mr_n69616032)
print v(xbgr.mr_n69616144)
print v(xbgr.mr_n69616464)
print v(xbgr.mr_n69616576)
print v(xbgr.mr_n69616896)
print v(xbgr.mr_n69617008)
print v(xbgr.mr_n69617328)
print v(xbgr.mr_n69617440)
print v(xbgr.mr_n69617760)
print v(xbgr.mr_n69617872)
print v(xbgr.mr_n69618192)
print v(xbgr.mr_n69618304)
print v(xbgr.mr_n69618624)
print v(xbgr.mr_n69618736)
print v(xbgr.mr_n69619056)
print v(xbgr.mr_n69619168)
print v(xbgr.mr_n69619488)
print v(xbgr.mr_n69619600)
print v(xbgr.mr_n69619920)
print v(xbgr.mr_n69620032)
print v(xbgr.mr_n69620352)
print v(xbgr.mr_n69620464)
print v(xbgr.mr_n69620784)
print v(xbgr.mr_n69620896)
print v(xbgr.mr_n69621216)
print v(xbgr.mr_n69621328)
print v(xbgr.mr_n69621648)
print v(xbgr.mr_n69621760)
print v(xbgr.mr_n69622080)
print v(xbgr.mr_n69622192)
print v(xbgr.mr_n69622512)
print v(xbgr.mr_n69622624)
print v(xbgr.mr_n69622944)
print v(xbgr.mr_n69623056)
print v(xbgr.mr_n69623376)
print v(xbgr.mr_n69623488)
print v(xbgr.mr_n69623808)
print v(xbgr.mr_n69623920)
print v(xbgr.mr_n69624240)
print v(xbgr.mr_n69624352)
print v(xbgr.mr_n69624672)
print v(xbgr.mr_n69624784)
print v(xbgr.mr_n69625104)
print v(xbgr.mr_n69625216)
print v(xbgr.mr_n69625536)
print v(xbgr.mr_n69625648)
print v(xbgr.mr_n69625968)
print v(xbgr.mr_n69626080)
print v(xbgr.mr_n69626400)
print v(xbgr.mr_n69626512)
print v(xbgr.mr_n69626832)
print v(xbgr.mr_n69626944)
print v(xbgr.mr_n69627264)
print v(xbgr.mr_n69627376)
print v(xbgr.mr_n69627696)
print v(xbgr.mr_n69627808)
print v(xbgr.mr_n69628128)
print v(xbgr.mr_n69628240)
print v(xbgr.mr_n69628560)
print v(xbgr.mr_n69628672)
print v(xbgr.mr_n69628992)
print v(xbgr.mr_n69629104)
print v(xbgr.mr_n69629424)
print v(xbgr.mr_n69629536)
print v(xbgr.mr_n69629856)
print v(xbgr.mr_n69629968)
print v(xbgr.mr_n69630288)
print v(xbgr.mr_n69630400)
print v(xbgr.mr_n69630720)
print v(xbgr.mr_n69630832)
print v(xbgr.mr_n69631152)
print v(xbgr.mr_n69631264)
print v(xbgr.mr_n69631584)
print v(xbgr.mr_n69631696)
print v(xbgr.mr_n69632016)
print v(xbgr.mr_n69632128)
print v(xbgr.mr_n69632448)
print v(xbgr.mr_n69632560)
print v(xbgr.mr_n69632880)
print v(xbgr.mr_n69632992)
print v(xbgr.mr_n69633312)
print v(xbgr.mr_n69633424)
print v(xbgr.mr_n69633744)
print v(xbgr.mr_n69633856)
print v(xbgr.mr_n69634176)
print v(xbgr.mr_n69634288)
print v(xbgr.mr_n69634608)
print v(xbgr.mr_n69634720)
print v(xbgr.mr_n69635040)
print v(xbgr.mr_n69635152)
print v(xbgr.mr_n69635472)
print v(xbgr.mr_n69635584)
print v(xbgr.mr_n69635904)
print v(xbgr.mr_n69636016)
print v(xbgr.mr_n69636336)
print v(xbgr.mr_n69636448)
print v(xbgr.mr_n69636768)
print v(xbgr.mr_n69636880)
print v(xbgr.mr_n69637200)
print v(xbgr.mr_n69637312)
print v(xbgr.mr_n69637632)
print v(xbgr.mr_n69637744)
print v(xbgr.mr_n69638064)
print v(xbgr.mr_n69638176)
print v(xbgr.mr_n69638496)
print v(xbgr.mr_n69638608)
print v(xbgr.mr_n69638928)
print v(xbgr.mr_n69639040)
print v(xbgr.mr_n69639360)
print v(xbgr.mr_n69639472)
print v(xbgr.mr_n69639792)
print v(xbgr.mr_n69639904)
print v(xbgr.mr_n69640224)
print v(xbgr.mr_n69640336)
print v(xbgr.mr_n69640656)
print v(xbgr.mr_n69640768)
print v(xbgr.mr_n69641088)
print v(xbgr.mr_n69641200)
print v(xbgr.mr_n69641520)
print v(xbgr.mr_n69641632)
print v(xbgr.mr_n69641952)
print v(xbgr.mr_n69642064)
print v(xbgr.mr_n69642384)
print v(xbgr.mr_n69642496)
print v(xbgr.mr_n69642816)
print v(xbgr.mr_n69642928)
print v(xbgr.mr_n69643248)
print v(xbgr.mr_n69643360)
print v(xbgr.mr_n69643680)
print v(xbgr.mr_n69643792)
print v(xbgr.mr_n69644112)
print v(xbgr.mr_n69644224)
print v(xbgr.mr_n69644544)
print v(xbgr.mr_n69644656)
print v(xbgr.mr_n69644976)
print v(xbgr.mr_n69645088)
print v(xbgr.mr_n69645408)
print v(xbgr.mr_n69645520)
print v(xbgr.mr_n69645840)
print v(xbgr.mr_n69645952)
print v(xbgr.mr_n69646272)
print v(xbgr.mr_n69646384)
print v(xbgr.mr_n69646704)
print v(xbgr.mr_n69646816)
print v(xbgr.mr_n69647136)
print v(xbgr.mr_n69647248)
print v(xbgr.mr_n69647568)
print v(xbgr.mr_n69647680)
print v(xbgr.mr_n69648000)
print v(xbgr.mr_n69648112)
print v(xbgr.mr_n69648432)
print v(xbgr.mr_n69648544)
print v(xbgr.mr_n69648864)
print v(xbgr.mr_n69648976)
print v(xbgr.mr_n69649296)
print v(xbgr.mr_n69649408)
print v(xbgr.mr_n69649728)
print v(xbgr.mr_n69649840)
print v(xbgr.mr_n69650160)
print v(xbgr.mr_n69650272)
print v(xbgr.mr_n69650592)
print v(xbgr.mr_n69650704)
print v(xbgr.mr_n69651024)
print v(xbgr.mr_n69651136)
print v(xbgr.mr_n69651456)
print v(xbgr.mr_n69651568)
print v(xbgr.mr_n69651888)
print v(xbgr.mr_n69652000)
print v(xbgr.mr_n69652320)
print v(xbgr.mr_n69652432)
print v(xbgr.mr_n69652752)
print v(xbgr.mr_n69652864)
print v(xbgr.mr_n69653184)
print v(xbgr.mr_n69653296)
print v(xbgr.mr_n69653616)
print v(xbgr.mr_n69653728)
print v(xbgr.mr_n69654048)
print v(xbgr.mr_n69654160)
print v(xbgr.mr_n69654480)
print v(xbgr.mr_n69654592)
print v(xbgr.mr_n69654912)
print v(xbgr.mr_n69655024)
print v(xbgr.mr_n69655344)
print v(xbgr.mr_n69655456)
print v(xbgr.mr_n69655776)
print v(xbgr.mr_n69655888)
print v(xbgr.mr_n69656208)
print v(xbgr.mr_n69656320)
print v(xbgr.mr_n69656640)
print v(xbgr.mr_n69656752)
print v(xbgr.mr_n69657072)
print v(xbgr.mr_n69657184)
print v(xbgr.mr_n69657504)
print v(xbgr.mr_n69657616)
print v(xbgr.mr_n69657936)
print v(xbgr.mr_n69658048)
print v(xbgr.mr_n69658368)
print v(xbgr.mr_n69658480)
print v(xbgr.mr_n69658800)
print v(xbgr.mr_n69658912)
print v(xbgr.mr_n69659232)
print v(xbgr.mr_n69659344)
print v(xbgr.mr_n69659664)
print v(xbgr.mr_n69659776)
print v(xbgr.mr_n69725648)
print v(xbgr.mr_n69725760)
print v(xbgr.mr_n69726080)
print v(xbgr.mr_n69726192)
print v(xbgr.mr_n69726512)
print v(xbgr.mr_n69726624)
print v(xbgr.mr_n69727056)
print v(xbgr.mr_n69727376)
print v(xbgr.mr_n69727488)
print v(xbgr.mr_n69727808)
print v(xbgr.mr_n69727920)
print v(xbgr.mr_n69728352)
print v(xbgr.mr_n69728784)
print v(xbgr.mr_n69729104)
print v(xbgr.mr_n69729216)
print v(xbgr.mr_n69729536)
print v(xbgr.mr_n69729648)
print v(xbgr.mr_n69729968)
print v(xbgr.mr_n69730080)
print v(xbgr.mr_n69730400)
print v(xbgr.mr_n69730512)
print v(xbgr.mr_n69730832)
print v(xbgr.mr_n69730944)
print v(xbgr.mr_n69731264)
print v(xbgr.mr_n69731376)
print v(xbgr.mr_n69731696)
print v(xbgr.mr_n69731808)
print v(xbgr.mr_n69732128)
print v(xbgr.mr_n69732240)
print v(xbgr.mr_n69732560)
print v(xbgr.mr_n69732672)
print v(xbgr.mr_n69732992)
print v(xbgr.mr_n69733104)
print v(xbgr.mr_n69733424)
print v(xbgr.mr_n69733536)
print v(xbgr.mr_n69733856)
print v(xbgr.mr_n69733968)
print v(xbgr.mr_n69734400)
print v(xbgr.mr_n69734720)
print v(xbgr.mr_n69734832)
print v(xbgr.mr_n69735152)
print v(xbgr.mr_n69735264)
print v(xbgr.mr_n69735584)
print v(xbgr.mr_n69735696)
print v(xbgr.mr_n69736016)
print v(xbgr.mr_n69736128)
print v(xbgr.mr_n69736448)
print v(xbgr.mr_n69736560)
print v(xbgr.mr_n69736880)
print v(xbgr.mr_n69736992)
print v(xbgr.mr_n69737312)
print v(xbgr.mr_n69737424)
print v(xbgr.mr_n69737744)
print v(xbgr.mr_n69737856)
print v(xbgr.mr_n69738176)
print v(xbgr.mr_n69738288)
print v(xbgr.mr_n69738608)
print v(xbgr.mr_n69738720)
print v(xbgr.mr_n69739152)
print v(xbgr.mr_n69739584)
print v(xbgr.mr_n69739904)
print v(xbgr.mr_n69740016)
print v(xbgr.mr_n69740336)
print v(xbgr.mr_n69740448)
print v(xbgr.mr_n69740768)
print v(xbgr.mr_n69740880)
print v(xbgr.mr_n69741200)
print v(xbgr.mr_n69741312)
print v(xbgr.mr_n69741632)
print v(xbgr.mr_n69741744)
print v(xbgr.mr_n69742064)
print v(xbgr.mr_n69742176)
print v(xbgr.mr_n69742496)
print v(xbgr.mr_n69742608)
print v(xbgr.mr_n69742928)
print v(xbgr.mr_n69743040)
print v(xbgr.mr_n69743360)
print v(xbgr.mr_n69743472)
print v(xbgr.mr_n69743792)
print v(xbgr.mr_n69743904)
print v(xbgr.mr_n69744224)
print v(xbgr.mr_n69744336)
print v(xbgr.mr_n69744656)
print v(xbgr.mr_n69744768)
print v(xbgr.mr_n69745088)
print v(xbgr.mr_n69745200)
print v(xbgr.mr_n69745520)
print v(xbgr.mr_n69745632)
print v(xbgr.mr_n69745952)
print v(xbgr.mr_n69746064)
print v(xbgr.mr_n69746384)
print v(xbgr.mr_n69746496)
print v(xbgr.mr_n69746816)
print v(xbgr.mr_n69746928)
print v(xbgr.mr_n69747248)
print v(xbgr.mr_n69747360)
print v(xbgr.mr_n69747680)
print v(xbgr.mr_n69747792)
print v(xbgr.mr_n69748112)
print v(xbgr.mr_n69748224)
print v(xbgr.mr_n69748544)
print v(xbgr.mr_n69748656)
print v(xbgr.mr_n69748976)
print v(xbgr.mr_n69749088)
print v(xbgr.mr_n69749408)
print v(xbgr.mr_n69749520)
print v(xbgr.mr_n69749840)
print v(xbgr.mr_n69749952)
print v(xbgr.mr_n69750272)
print v(xbgr.mr_n69750384)
print v(xbgr.mr_n69750704)
print v(xbgr.mr_n69750816)
print v(xbgr.mr_n69751136)
print v(xbgr.mr_n69751248)
print v(xbgr.mr_n69751568)
print v(xbgr.mr_n69751680)
print v(xbgr.mr_n69752000)
print v(xbgr.mr_n69752112)
print v(xbgr.mr_n69752432)
print v(xbgr.mr_n69752544)
print v(xbgr.mr_n69752864)
print v(xbgr.mr_n69752976)
print v(xbgr.mr_n69753296)
print v(xbgr.mr_n69753408)
print v(xbgr.mr_n69753728)
print v(xbgr.mr_n69753840)
print v(xbgr.mr_n69754160)
print v(xbgr.mr_n69754272)
print v(xbgr.mr_n69754592)
print v(xbgr.mr_n69754704)
print v(xbgr.mr_n69755024)
print v(xbgr.mr_n69755136)
print v(xbgr.mr_n69755456)
print v(xbgr.mr_n69755568)
print v(xbgr.mr_n69755888)
print v(xbgr.mr_n69756000)
print v(xbgr.mr_n69756320)
print v(xbgr.mr_n69756432)
print v(xbgr.mr_n69756752)
print v(xbgr.mr_n69756864)
print v(xbgr.mr_n69757184)
print v(xbgr.mr_n69757296)
print v(xbgr.mr_n69757616)
print v(xbgr.mr_n69757728)
print v(xbgr.mr_n69758048)
print v(xbgr.mr_n69758160)
print v(xbgr.mr_n69758480)
print v(xbgr.mr_n69758592)
print v(xbgr.mr_n69758912)
print v(xbgr.mr_n69759024)
print v(xbgr.mr_n69759344)
print v(xbgr.mr_n69759456)
print v(xbgr.mr_n69759776)
print v(xbgr.mr_n69759888)
print v(xbgr.mr_n69760208)
print v(xbgr.mr_n69760320)
print v(xbgr.mr_n69760640)
print v(xbgr.mr_n69760752)
print v(xbgr.mr_n69761072)
print v(xbgr.mr_n69761184)
print v(xbgr.mr_n69761504)
print v(xbgr.mr_n69761616)
print v(xbgr.mr_n69761936)
print v(xbgr.mr_n69762048)
print v(xbgr.mr_n69762368)
print v(xbgr.mr_n69762480)
print v(xbgr.mr_n69762800)
print v(xbgr.mr_n69762912)
print v(xbgr.mr_n69763232)
print v(xbgr.mr_n69763344)
print v(xbgr.mr_n69763664)
print v(xbgr.mr_n69763776)
print v(xbgr.mr_n69764096)
print v(xbgr.mr_n69764208)
print v(xbgr.mr_n69764528)
print v(xbgr.mr_n69764640)
print v(xbgr.mr_n69764960)
print v(xbgr.mr_n69765072)
print v(xbgr.mr_n69765392)
print v(xbgr.mr_n69765504)
print v(xbgr.mr_n69765824)
print v(xbgr.mr_n69765936)
print v(xbgr.mr_n69766256)
print v(xbgr.mr_n69766368)
print v(xbgr.mr_n69766688)
print v(xbgr.mr_n69766800)
print v(xbgr.mr_n69767120)
print v(xbgr.mr_n69767232)
print v(xbgr.mr_n69767552)
print v(xbgr.mr_n69767664)
print v(xbgr.mr_n69767984)
print v(xbgr.mr_n69768096)
print v(xbgr.mr_n69768416)
print v(xbgr.mr_n69768528)
print v(xbgr.mr_n69768848)
print v(xbgr.mr_n69768960)
print v(xbgr.mr_n69769280)
print v(xbgr.mr_n69769392)
print v(xbgr.mr_n69769712)
print v(xbgr.mr_n69769824)
print v(xbgr.mr_n69770144)
print v(xbgr.mr_n69770256)
print v(xbgr.mr_n69770576)
print v(xbgr.mr_n69770688)
print v(xbgr.mr_n69771008)
print v(xbgr.mr_n69771120)
print v(xbgr.mr_n69771440)
print v(xbgr.mr_n69771552)
print v(xbgr.mr_n69771872)
print v(xbgr.mr_n69771984)
print v(xbgr.mr_n69772304)
print v(xbgr.mr_n69772416)
print v(xbgr.mr_n69772736)
print v(xbgr.mr_n69772848)
print v(xbgr.mr_n69773168)
print v(xbgr.mr_n69773280)
print v(xbgr.mr_n69773600)
print v(xbgr.mr_n69773712)
print v(xbgr.mr_n69774032)
print v(xbgr.mr_n69774144)
print v(xbgr.mr_n69774464)
print v(xbgr.mr_n69774576)
print v(xbgr.mr_n69774896)
print v(xbgr.mr_n69775008)
print v(xbgr.mr_n69775328)
print v(xbgr.mr_n69775440)
print v(xbgr.mr_n69775760)
print v(xbgr.mr_n69775872)
print v(xbgr.mr_n69776192)
print v(xbgr.mr_n69776304)
print v(xbgr.mr_n69776624)
print v(xbgr.mr_n69776736)
print v(xbgr.mr_n69777056)
print v(xbgr.mr_n69777168)
print v(xbgr.mr_n69777488)
print v(xbgr.mr_n69777600)
print v(xbgr.mr_n69777920)
print v(xbgr.mr_n69778032)
print v(xbgr.mr_n69778352)
print v(xbgr.mr_n69778464)
print v(xbgr.mr_n69778784)
print v(xbgr.mr_n69778896)
print v(xbgr.mr_n69779216)
print v(xbgr.mr_n69779328)
print v(xbgr.mr_n69779648)
print v(xbgr.mr_n69779760)
print v(xbgr.mr_n69780080)
print v(xbgr.mr_n69780192)
print v(xbgr.mr_n69780512)
print v(xbgr.mr_n69780624)
print v(xbgr.mr_n69780944)
print v(xbgr.mr_n69781056)
print v(xbgr.mr_n69781376)
print v(xbgr.mr_n69781488)
print v(xbgr.mr_n69781808)
print v(xbgr.mr_n69781920)
print v(xbgr.mr_n69782240)
print v(xbgr.mr_n69782352)
print v(xbgr.mr_n69782672)
print v(xbgr.mr_n69782784)
print v(xbgr.mr_n69783104)
print v(xbgr.mr_n69783216)
print v(xbgr.mr_n69783536)
print v(xbgr.mr_n69783648)
print v(xbgr.mr_n69783968)
print v(xbgr.mr_n69784080)
print v(xbgr.mr_n69784400)
print v(xbgr.mr_n69784512)
print v(xbgr.mr_n69784832)
print v(xbgr.mr_n69784944)
print v(xbgr.mr_n69785264)
print v(xbgr.mr_n69785376)
print v(xbgr.mr_n69785696)
print v(xbgr.mr_n69785808)
print v(xbgr.mr_n69786128)
print v(xbgr.mr_n69786240)
print v(xbgr.mr_n69786560)
print v(xbgr.mr_n69786672)
print v(xbgr.mr_n69786992)
print v(xbgr.mr_n69787104)
print v(xbgr.mr_n69787424)
print v(xbgr.mr_n69787536)
print v(xbgr.mr_n69787856)
print v(xbgr.mr_n69787968)
print v(xbgr.mr_n69788288)
print v(xbgr.mr_n69788400)
print v(xbgr.mr_n69788720)
print v(xbgr.mr_n69788832)
print v(xbgr.mr_n69789152)
print v(xbgr.mr_n69789264)
print v(xbgr.mr_n69789584)
print v(xbgr.mr_n69789696)
print v(xbgr.mr_n69790016)
print v(xbgr.mr_n69790128)
print v(xbgr.mr_n69790448)
print v(xbgr.mr_n69790560)
print v(xbgr.mr_n69790880)
print v(xbgr.mr_n69790992)
print v(xbgr.mr_n69791312)
print v(xbgr.mr_n69791424)
print v(xbgr.mr_n69791744)
print v(xbgr.mr_n69791856)
print v(xbgr.mr_n69792176)
print v(xbgr.mr_n69792288)
print v(xbgr.mr_n69792608)
print v(xbgr.mr_n69792720)
print v(xbgr.mr_n69793040)
print v(xbgr.mr_n69793152)
print v(xbgr.mr_n69793472)
print v(xbgr.mr_n69793584)
print v(xbgr.mr_n69793904)
print v(xbgr.mr_n69794016)
print v(xbgr.mr_n69794336)
print v(xbgr.mr_n69794448)
print v(xbgr.mr_n69794768)
print v(xbgr.mr_n69794880)
print v(xbgr.mr_n69795200)
print v(xbgr.mr_n69795312)
print v(xbgr.mr_n69795632)
print v(xbgr.mr_n69795744)
print v(xbgr.mr_n69796064)
print v(xbgr.mr_n69796176)
print v(xbgr.mr_n69796496)
print v(xbgr.mr_n69796608)
print v(xbgr.mr_n69796928)
print v(xbgr.mr_n69797040)
print v(xbgr.mr_n69797360)
print v(xbgr.mr_n69797472)
print v(xbgr.mr_n69797792)
print v(xbgr.mr_n69797904)
print v(xbgr.mr_n69798224)
print v(xbgr.mr_n69798336)
print v(xbgr.mr_n69798656)
print v(xbgr.mr_n69798768)
print v(xbgr.mr_n69799088)
print v(xbgr.mr_n69799200)
print v(xbgr.mr_n69799520)
print v(xbgr.mr_n69799632)
print v(xbgr.mr_n69799952)
print v(xbgr.mr_n69800064)
print v(xbgr.mr_n69800384)
print v(xbgr.mr_n69800496)
print v(xbgr.mr_n69800816)
print v(xbgr.mr_n69800928)
print v(xbgr.mr_n69801248)
print v(xbgr.mr_n69801360)
print v(xbgr.mr_n69801680)
print v(xbgr.mr_n69801792)
print v(xbgr.mr_n69802112)
print v(xbgr.mr_n69802224)
print v(xbgr.mr_n69802544)
print v(xbgr.mr_n69802656)
print v(xbgr.mr_n69802976)
print v(xbgr.mr_n69803088)
print v(xbgr.mr_n69803408)
print v(xbgr.mr_n69803520)
print v(xbgr.mr_n69803840)
print v(xbgr.mr_n69803952)
print v(xbgr.mr_n69804272)
print v(xbgr.mr_n69804384)
print v(xbgr.mr_n69804704)
print v(xbgr.mr_n69804816)
print v(xbgr.mr_n69805136)
print v(xbgr.mr_n69805248)
print v(xbgr.mr_n69805568)
print v(xbgr.mr_n69805680)
print v(xbgr.mr_n69806000)
print v(xbgr.mr_n69806112)
print v(xbgr.mr_n69806432)
print v(xbgr.mr_n69806544)
print v(xbgr.mr_n69806864)
print v(xbgr.mr_n69806976)
print v(xbgr.mr_n69807296)
print v(xbgr.mr_n69807408)
print v(xbgr.mr_n69807840)
print v(xbgr.mr_n69808160)
print v(xbgr.mr_n69808272)
print v(xbgr.mr_n69808592)
print v(xbgr.mr_n69808704)
print v(xbgr.mr_n69809024)
print v(xbgr.mr_n69809136)
print v(xbgr.mr_n69809456)
print v(xbgr.mr_n69809568)
print v(xbgr.mr_n69809888)
print v(xbgr.mr_n69810752)
print v(xbgr.mr_n69810864)
print v(xbgr.mr_n69811184)
print v(xbgr.mr_n69811296)
print v(xbgr.mr_n69811616)
print v(xbgr.mr_n69811728)
print v(xbgr.mr_n69812048)
print v(xbgr.mr_n69812160)
print v(xbgr.mr_n69812480)
print v(xbgr.mr_n69812592)
print v(xbgr.mr_n69813024)
print v(xbgr.mr_n69813344)
print v(xbgr.mr_n69813456)
print v(xbgr.mr_n69813776)
print v(xbgr.mr_n69813888)
print v(xbgr.mr_n69814208)
print v(xbgr.mr_n69814320)
print v(xbgr.mr_n69814640)
print v(xbgr.mr_n69814752)
print v(xbgr.mr_n69815072)
print v(xbgr.mr_n69815184)
print v(xbgr.mr_n69815616)
print v(xbgr.mr_n69815936)
print v(xbgr.mr_n69816800)
print v(xbgr.mr_n69816912)
print v(xbgr.mr_n69817344)
print v(xbgr.mr_n69817664)
print v(xbgr.mr_n69818528)
print v(xbgr.mr_n69818640)
print v(xbgr.mr_n69819072)
print v(xbgr.mr_n69819392)
print v(xbgr.mr_n69819504)
print v(xbgr.mr_n69819824)
print v(xbgr.mr_n69819936)
print v(xbgr.mr_n69820256)
print v(xbgr.mr_n69820368)
print v(xbgr.mr_n69820688)
print v(xbgr.mr_n69820800)
print v(xbgr.mr_n69821120)
print v(xbgr.mr_n69821232)
print v(xbgr.mr_n69821552)
print v(xbgr.mr_n69821664)
print v(xbgr.mr_n69821984)
print v(xbgr.mr_n69822848)
print v(xbgr.mr_n69822960)
print v(xbgr.mr_n69823280)
print v(xbgr.mr_n69823392)
print v(xbgr.mr_n69823712)
print v(xbgr.mr_n69824576)
print v(xbgr.mr_n69824688)
print v(xbgr.mr_n69825008)
print v(xbgr.mr_n69825120)
print v(xbgr.mr_n69825440)
print v(xbgr.mr_n69825552)
print v(xbgr.mr_n69825872)
print v(xbgr.mr_n69825984)
print v(xbgr.mr_n69826304)
print v(xbgr.mr_n69826416)
print v(xbgr.mr_n69826736)
print v(xbgr.mr_n69826848)
print v(xbgr.mr_n69827168)
print v(xbgr.mr_n69827280)
print v(xbgr.mr_n69827600)
print v(xbgr.mr_n69827712)
print v(xbgr.mr_n69828032)
print v(xbgr.mr_n69828144)
print v(xbgr.mr_n69828464)
print v(xbgr.mr_n69828576)
print v(xbgr.mr_n69828896)
print v(xbgr.mr_n69829008)
print v(xbgr.mr_n69829328)
print v(xbgr.mr_n69829440)
print v(xbgr.mr_n69829760)
print v(xbgr.mr_n69829872)
print v(xbgr.mr_n69830192)
print v(xbgr.mr_n69830304)
print v(xbgr.mr_n69830624)
print v(xbgr.mr_n69830736)
print v(xbgr.mr_n69831056)
print v(xbgr.mr_n69831168)
print v(xbgr.mr_n69831488)
print v(xbgr.mr_n69831600)
print v(xbgr.mr_n69831920)
print v(xbgr.mr_n69832032)
print v(xbgr.mr_n69832352)
print v(xbgr.mr_n69832464)
print v(xbgr.mr_n69832784)
print v(xbgr.mr_n69832896)
print v(xbgr.mr_n69833216)
print v(xbgr.mr_n69833328)
print v(xbgr.mr_n69833648)
print v(xbgr.mr_n69833760)
print v(xbgr.mr_n69834080)
print v(xbgr.mr_n69834192)
print v(xbgr.mr_n69834512)
print v(xbgr.mr_n69834624)
print v(xbgr.mr_n69834944)
print v(xbgr.mr_n69835056)
print v(xbgr.mr_n69835376)
print v(xbgr.mr_n69835488)
print v(xbgr.mr_n69835920)
print v(xbgr.mr_n69836352)
print v(xbgr.mr_n69836784)
print v(xbgr.mr_n69837216)
print v(xbgr.mr_n69837648)
print v(xbgr.mr_n69838080)
print v(xbgr.mr_n69838512)
print v(xbgr.mr_n69838944)
print v(xbgr.mr_n69839376)
print v(xbgr.mr_n69839808)
print v(xbgr.mr_n69840240)
print v(xbgr.mr_n69840672)
print v(xbgr.mr_n69841104)
print v(xbgr.mr_n69841536)
print v(xbgr.mr_n69841968)
print v(xbgr.mr_n69842400)
print v(xbgr.mr_n69842832)
print v(xbgr.mr_n69843264)
print v(xbgr.mr_n69843696)
print v(xbgr.mr_n69844128)
print v(xbgr.mr_n69844560)
print v(xbgr.mr_n69844992)
print v(xbgr.mr_n69845312)
print v(xbgr.mr_n69845424)
print v(xbgr.mr_n69845856)
print v(xbgr.mr_n69846288)
print v(xbgr.mr_n69846720)
print v(xbgr.mr_n69847152)
print v(xbgr.mr_n69847584)
print v(xbgr.mr_n69848016)
print v(xbgr.mr_n69848448)
print v(xbgr.mr_n69848880)
print v(xbgr.mr_n69849312)
print v(xbgr.mr_n69849744)
print v(xbgr.mr_n69850176)
print v(xbgr.mr_n69850608)
print v(xbgr.mr_n69851040)
print v(xbgr.mr_n69851472)
print v(xbgr.mr_n69851904)
print v(xbgr.mr_n69852336)
print v(xbgr.mr_n69852768)
print v(xbgr.mr_n69853200)
print v(xbgr.mr_n69853632)
print v(xbgr.mr_n69854064)
print v(xbgr.mr_n69854496)
print v(xbgr.mr_n69854928)
print v(xbgr.mr_n69855360)
print v(xbgr.mr_n69855792)
print v(xbgr.mr_n69856224)
print v(xbgr.mr_n69856656)
print v(xbgr.mr_n69857088)
print v(xbgr.mr_n69857520)
print v(xbgr.mr_n69857952)
print v(xbgr.mr_n69858384)
print v(xbgr.mr_n69858816)
print v(xbgr.mr_n69859248)
print v(xbgr.mr_n69859680)
print v(xbgr.mr_n69860112)
print v(xbgr.mr_n69860544)
print v(xbgr.mr_n69860976)
print v(xbgr.mr_n69861408)
print v(xbgr.mr_n69861840)
print v(xbgr.mr_n69862272)
print v(xbgr.mr_n69862704)
print v(xbgr.mr_n69863136)
print v(xbgr.mr_n69863568)
print v(xbgr.mr_n69864000)
print v(xbgr.mr_n69864432)
print v(xbgr.mr_n69864864)
print v(xbgr.mr_n69865296)
print v(xbgr.mr_n69865728)
print v(xbgr.mr_n69866160)
print v(xbgr.mr_n69866592)
print v(xbgr.mr_n69867024)
print v(xbgr.mr_n69867456)
print v(xbgr.mr_n69867888)
print v(xbgr.mr_n69868320)
print v(xbgr.mr_n69868752)
print v(xbgr.mr_n69869184)
print v(xbgr.mr_n69869616)
print v(xbgr.mr_n69870048)
print v(xbgr.mr_n69870480)
print v(xbgr.mr_n69870912)
print v(xbgr.mr_n69871344)
print v(xbgr.mr_n69871776)
print v(xbgr.mr_n69872208)
print v(xbgr.mr_n69872640)
print v(xbgr.mr_n69872960)
print v(xbgr.mr_n69873072)
print v(xbgr.mr_n69873392)
print v(xbgr.mr_n69873504)
print v(xbgr.mr_n69873824)
print v(xbgr.mr_n69873936)
print v(xbgr.mr_n69874256)
print v(xbgr.mr_n69874368)
print v(xbgr.mr_n69874688)
print v(xbgr.mr_n69874800)
print v(xbgr.mr_n69875120)
print v(xbgr.mr_n69875232)
print v(xbgr.mr_n69875552)
print v(xbgr.mr_n69875664)
print v(xbgr.mr_n69875984)
print v(xbgr.mr_n69876096)
print v(xbgr.mr_n69876416)
print v(xbgr.mr_n69876528)
print v(xbgr.mr_n69876848)
print v(xbgr.mr_n69876960)
print v(xbgr.mr_n69877280)
print v(xbgr.mr_n69877392)
print v(xbgr.mr_n69877712)
print v(xbgr.mr_n69877824)
print v(xbgr.mr_n69878144)
print v(xbgr.mr_n69878576)
print v(xbgr.mr_n69878688)
print v(xbgr.mr_n69879008)
print v(xbgr.mr_n69879120)
print v(xbgr.mr_n69879440)
print v(xbgr.mr_n69879552)
print v(xbgr.mr_n69879872)
print v(xbgr.mr_n69879984)
print v(xbgr.mr_n69880304)
print v(xbgr.mr_n69880416)
print v(xbgr.mr_n69880736)
print v(xbgr.mr_n69880848)
print v(xbgr.mr_n69881168)
print v(xbgr.mr_n69881280)
print v(xbgr.mr_n69881600)
print v(xbgr.mr_n69881712)
print v(xbgr.mr_n69882032)
print v(xbgr.mr_n69882144)
print v(xbgr.mr_n69882464)
print v(xbgr.mr_n69882576)
print v(xbgr.mr_n69882896)
print v(xbgr.mr_n69883008)
print v(xbgr.mr_n69883440)
print v(xbgr.mr_n69883872)
print v(xbgr.mr_n69884304)
print v(xbgr.mr_n69884736)
print v(xbgr.mr_n69885168)
print v(xbgr.mr_n69885600)
print v(xbgr.mr_n69886032)
print v(xbgr.mr_n69886464)
print v(xbgr.mr_n69886896)
print v(xbgr.mr_n69887328)
print v(xbgr.mr_n69887760)
print v(xbgr.mr_n69888192)
print v(xbgr.mr_n69888624)
print v(xbgr.mr_n69889056)
print v(xbgr.mr_n69889488)
print v(xbgr.mr_n69889920)
print v(xbgr.mr_n69890352)
print v(xbgr.mr_n69890784)
print v(xbgr.mr_n69891216)
print v(xbgr.mr_n69891648)
print v(xbgr.mr_n69892080)
print v(xbgr.mr_n69892512)
print v(xbgr.mr_n69892944)
print v(xbgr.mr_n69893376)
print v(xbgr.mr_n69893808)
print v(xbgr.mr_n69894240)
print v(xbgr.mr_n69894672)
print v(xbgr.mr_n69895104)
print v(xbgr.mr_n69895536)
print v(xbgr.mr_n69895968)
print v(xbgr.mr_n69896400)
print v(xbgr.mr_n69896832)
print v(xbgr.mr_n69897264)
print v(xbgr.mr_n69897696)
print v(xbgr.mr_n69898128)
print v(xbgr.mr_n69898560)
print v(xbgr.mr_n69898992)
print v(xbgr.mr_n69899424)
print v(xbgr.mr_n69899856)
print v(xbgr.mr_n69900288)
print v(xbgr.mr_n69900720)
print v(xbgr.mr_n69901152)
print v(xbgr.mr_n69901584)
print v(xbgr.mr_n69902016)
print v(xbgr.mr_n69902448)
print v(xbgr.mr_n69902880)
print v(xbgr.mr_n69903312)
print v(xbgr.mr_n69903744)
print v(xbgr.mr_n69904176)
print v(xbgr.mr_n69904608)
print v(xbgr.mr_n69905040)
print v(xbgr.mr_n69905472)
print v(xbgr.mr_n69905904)
print v(xbgr.mr_n69906336)
print v(xbgr.mr_n69906768)
print v(xbgr.mr_n69907200)
print v(xbgr.mr_n69907632)
print v(xbgr.mr_n69908064)
print v(xbgr.mr_n69908496)
print v(xbgr.mr_n69908928)
print v(xbgr.mr_n69909360)
print v(xbgr.mr_n69909792)
print v(xbgr.mr_n69910224)
print v(xbgr.mr_n69910656)
print v(xbgr.mr_n69911088)
print v(xbgr.mr_n69911520)
print v(xbgr.mr_n69911952)
print v(xbgr.mr_n69912384)
print v(xbgr.mr_n69912816)
print v(xbgr.mr_n69913248)
print v(xbgr.mr_n69913680)
print v(xbgr.mr_n69914112)
print v(xbgr.mr_n69914544)
print v(xbgr.mr_n69914976)
print v(xbgr.mr_n69915408)
print v(xbgr.mr_n69915840)
print v(xbgr.mr_n69916272)
print v(xbgr.mr_n69916704)
print v(xbgr.mr_n69917136)
print v(xbgr.mr_n69917568)
print v(xbgr.mr_n69918000)
print v(xbgr.mr_n69918432)
print v(xbgr.mr_n69918864)
print v(xbgr.mr_n69919296)
print v(xbgr.mr_n69919728)
print v(xbgr.mr_n69920160)
print v(xbgr.mr_n69920480)
print v(xbgr.mr_n69920592)
print v(xbgr.mr_n69920912)
print v(xbgr.mr_n69921024)
print v(xbgr.mr_n69921344)
print v(xbgr.mr_n69921456)
print v(xbgr.mr_n69921776)
print v(xbgr.mr_n69921888)
print v(xbgr.mr_n69922208)
print v(xbgr.mr_n69922320)
print v(xbgr.mr_n69922640)
print v(xbgr.mr_n69922752)
print v(xbgr.mr_n69923072)
print v(xbgr.mr_n69923184)
print v(xbgr.mr_n69923504)
print v(xbgr.mr_n69923616)
print v(xbgr.mr_n69923936)
print v(xbgr.mr_n69924048)
print v(xbgr.mr_n69924368)
print v(xbgr.mr_n69924480)
print v(xbgr.mr_n69924800)
print v(xbgr.mr_n69924912)
print v(xbgr.mr_n69925232)
print v(xbgr.mr_n69925344)
print v(xbgr.mr_n69925664)
print v(xbgr.mr_n69925776)
print v(xbgr.mr_n69926096)
print v(xbgr.mr_n69926208)
print v(xbgr.mr_n69926528)
print v(xbgr.mr_n69926640)
print v(xbgr.mr_n69926960)
print v(xbgr.mr_n69927072)
print v(xbgr.mr_n69927392)
print v(xbgr.mr_n69927504)
print v(xbgr.mr_n69927824)
print v(xbgr.mr_n69927936)
print v(xbgr.mr_n69928256)
print v(xbgr.mr_n69928800)
print v(xbgr.mr_n69929120)
print v(xbgr.mr_n69929552)
print v(xbgr.mr_n69929664)
print v(xbgr.mr_n69929984)
print v(xbgr.mr_n69930096)
print v(xbgr.mr_n69930528)
print v(xbgr.mr_n69930848)
print v(xbgr.mr_n69931712)
print v(xbgr.mr_n69931824)
print v(xbgr.mr_n69932256)
print v(xbgr.mr_n69932576)
print v(xbgr.mr_n69933440)
print v(xbgr.mr_n69933552)
print v(xbgr.mr_n69933984)
print v(xbgr.mr_n69934304)
print v(xbgr.mr_n69934416)
print v(xbgr.mr_n69934848)
print v(xbgr.mr_n69935280)
print v(xbgr.mr_n69935600)
print v(xbgr.mr_n69936464)
print v(xbgr.mr_n69937440)
print v(xbgr.mr_n69937760)
print v(xbgr.mr_n69937872)
print v(xbgr.mr_n69938304)
print v(xbgr.mr_n69938624)
print v(xbgr.mr_n69938736)
print v(xbgr.mr_n69939168)
print v(xbgr.mr_n69939488)
print v(xbgr.mr_n69939600)
print v(xbgr.mr_n69939920)
print v(xbgr.mr_n69940032)
print v(xbgr.mr_n69940352)
print v(xbgr.mr_n69940464)
print v(xbgr.mr_n69940784)
print v(xbgr.mr_n69940896)
print v(xbgr.mr_n69941216)
print v(xbgr.mr_n69941328)
print v(xbgr.mr_n69941648)
print v(xbgr.mr_n69941760)
print v(xbgr.mr_n69942080)
print v(xbgr.mr_n69942192)
print v(xbgr.mr_n69942512)
print v(xbgr.mr_n69942624)
print v(xbgr.mr_n69942944)
print v(xbgr.mr_n69943056)
print v(xbgr.mr_n69943376)
print v(xbgr.mr_n69943488)
print v(xbgr.mr_n69943808)
print v(xbgr.mr_n69943920)
print v(xbgr.mr_n69944240)
print v(xbgr.mr_n69944352)
print v(xbgr.mr_n69944672)
print v(xbgr.mr_n69945536)
print v(xbgr.mr_n69946400)
print v(xbgr.mr_n69946832)
print v(xbgr.mr_n69947264)
print v(xbgr.mr_n69947696)
print v(xbgr.mr_n69948128)
print v(xbgr.mr_n69948560)
print v(xbgr.mr_n69948992)
print v(xbgr.mr_n69949424)
print v(xbgr.mr_n69949856)
print v(xbgr.mr_n69950288)
print v(xbgr.mr_n69950720)
print v(xbgr.mr_n69951152)
print v(xbgr.mr_n69951584)
print v(xbgr.mr_n69951696)
print v(xbgr.mr_n69952016)
print v(xbgr.mr_n69952128)
print v(xbgr.mr_n69952448)
print v(xbgr.mr_n69952560)
print v(xbgr.mr_n69952880)
print v(xbgr.mr_n69952992)
print v(xbgr.mr_n69953312)
print v(xbgr.mr_n69953424)
print v(xbgr.mr_n69953744)
print v(xbgr.mr_n69953856)
print v(xbgr.mr_n69954176)
print v(xbgr.mr_n69954288)
print v(xbgr.mr_n69954608)
print v(xbgr.mr_n69954720)
print v(xbgr.mr_n69955040)
print v(xbgr.mr_n69955152)
print v(xbgr.mr_n69955472)
print v(xbgr.mr_n69955584)
print v(xbgr.mr_n69955904)
print v(xbgr.mr_n69956016)
print v(xbgr.mr_n69956336)
print v(xbgr.mr_n69956448)
print v(xbgr.mr_n69956768)
print v(xbgr.mr_n69957200)
print v(xbgr.mr_n69957312)
print v(xbgr.mr_n69957632)
print v(xbgr.mr_n69957744)
print v(xbgr.mr_n69958064)
print v(xbgr.mr_n69958176)
print v(xbgr.mr_n69958496)
print v(xbgr.mr_n69958608)
print v(xbgr.mr_n69958928)
print v(xbgr.mr_n69959040)
print v(xbgr.mr_n69959360)
print v(xbgr.mr_n69959472)
print v(xbgr.mr_n69959792)
print v(xbgr.mr_n69959904)
print v(xbgr.mr_n69960224)
print v(xbgr.mr_n69960336)
print v(xbgr.mr_n69960656)
print v(xbgr.mr_n69960768)
print v(xbgr.mr_n69961088)
print v(xbgr.mr_n69961200)
print v(xbgr.mr_n69961520)
print v(xbgr.mr_n69961952)
print v(xbgr.mr_n69962064)
print v(xbgr.mr_n69962384)
print v(xbgr.mr_n69962496)
print v(xbgr.mr_n69962816)
print v(xbgr.mr_n69962928)
print v(xbgr.mr_n69963248)
print v(xbgr.mr_n69963360)
print v(xbgr.mr_n69963680)
print v(xbgr.mr_n69963792)
print v(xbgr.mr_n69964112)
print v(xbgr.mr_n69964224)
print v(xbgr.mr_n69964544)
print v(xbgr.mr_n69964656)
print v(xbgr.mr_n69964976)
print v(xbgr.mr_n69965088)
print v(xbgr.mr_n69965408)
print v(xbgr.mr_n69965520)
print v(xbgr.mr_n69965840)
print v(xbgr.mr_n69965952)
print v(xbgr.mr_n69966272)
print v(xbgr.mr_n69966384)
print v(xbgr.mr_n69966704)
print v(xbgr.mr_n69966816)
print v(xbgr.mr_n69967136)
print v(xbgr.mr_n69967248)
print v(xbgr.mr_n69967568)
print v(xbgr.mr_n69967680)
print v(xbgr.mr_n69968000)
print v(xbgr.mr_n69968112)
print v(xbgr.mr_n69968432)
print v(xbgr.mr_n69968544)
print v(xbgr.mr_n69968864)
print v(xbgr.mr_n69968976)
print v(xbgr.mr_n69969296)
print v(xbgr.mr_n69969408)
print v(xbgr.mr_n69969728)
print v(xbgr.mr_n69969840)
print v(xbgr.mr_n69970160)
print v(xbgr.mr_n69970272)
print v(xbgr.mr_n69970592)
print v(xbgr.mr_n69970704)
print v(xbgr.mr_n69971024)
print v(xbgr.mr_n69971136)
print v(xbgr.mr_n69971456)
print v(xbgr.mr_n69971568)
print v(xbgr.mr_n69971888)
print v(xbgr.mr_n69972000)
print v(xbgr.mr_n69972320)
print v(xbgr.mr_n69972432)
print v(xbgr.mr_n69972752)
print v(xbgr.mr_n69972864)
print v(xbgr.mr_n69973184)
print v(xbgr.mr_n69973296)
print v(xbgr.mr_n69973616)
print v(xbgr.mr_n69973728)
print v(xbgr.mr_n69974048)
print v(xbgr.mr_n69974160)
print v(xbgr.mr_n69974480)
print v(xbgr.mr_n69974592)
print v(xbgr.mr_n69974912)
print v(xbgr.mr_n69975024)
print v(xbgr.mr_n69975344)
print v(xbgr.mr_n69975456)
print v(xbgr.mr_n69975776)
print v(xbgr.mr_n69975888)
print v(xbgr.mr_n69976208)
print v(xbgr.mr_n69976320)
print v(xbgr.mr_n69976640)
print v(xbgr.mr_n69976752)
print v(xbgr.mr_n69977072)
print v(xbgr.mr_n69977184)
print v(xbgr.mr_n69977504)
print v(xbgr.mr_n69977616)
print v(xbgr.mr_n69977936)
print v(xbgr.mr_n69978048)
print v(xbgr.mr_n69978368)
print v(xbgr.mr_n69978480)
print v(xbgr.mr_n69978800)
print v(xbgr.mr_n69978912)
print v(xbgr.mr_n69979232)
print v(xbgr.mr_n69979344)
print v(xbgr.mr_n69979664)
print v(xbgr.mr_n69979776)
print v(xbgr.mr_n69980096)
print v(xbgr.mr_n69980208)
print v(xbgr.mr_n69980528)
print v(xbgr.mr_n69980640)
print v(xbgr.mr_n69980960)
print v(xbgr.mr_n69981072)
print v(xbgr.mr_n69981392)
print v(xbgr.mr_n69981504)
print v(xbgr.mr_n69981824)
print v(xbgr.mr_n69981936)
print v(xbgr.mr_n69982256)
print v(xbgr.mr_n69982368)
print v(xbgr.mr_n69982688)
print v(xbgr.mr_n69982800)
print v(xbgr.mr_n69983120)
print v(xbgr.mr_n69983232)
print v(xbgr.mr_n69983552)
print v(xbgr.mr_n69983664)
print v(xbgr.mr_n69983984)
print v(xbgr.mr_n69984096)
print v(xbgr.mr_n69984416)
print v(xbgr.mr_n69984528)
print v(xbgr.mr_n69984848)
print v(xbgr.mr_n69984960)
print v(xbgr.mr_n69985280)
print v(xbgr.mr_n69985392)
print v(xbgr.mr_n69985712)
print v(xbgr.mr_n69985824)
print v(xbgr.mr_n69986144)
print v(xbgr.mr_n69986256)
print v(xbgr.mr_n69986576)
print v(xbgr.mr_n69986688)
print v(xbgr.mr_n69987008)
print v(xbgr.mr_n69987120)
print v(xbgr.mr_n69987440)
print v(xbgr.mr_n69987552)
print v(xbgr.mr_n69987872)
print v(xbgr.mr_n69987984)
print v(xbgr.mr_n69988304)
print v(xbgr.mr_n69988416)
print v(xbgr.mr_n69988736)
print v(xbgr.mr_n69989168)
print v(xbgr.mr_n69989280)
print v(xbgr.mr_n69989600)
print v(xbgr.mr_n69989712)
print v(xbgr.mr_n69990032)
print v(xbgr.mr_n69990144)
print v(xbgr.mr_n69990464)
print v(xbgr.mr_n69990576)
print v(xbgr.mr_n69990896)
print v(xbgr.mr_n69991008)
print v(xbgr.mr_n69991328)
print v(xbgr.mr_n69991440)
print v(xbgr.mr_n69991760)
print v(xbgr.mr_n69991872)
print v(xbgr.mr_n69992192)
print v(xbgr.mr_n69992304)
print v(xbgr.mr_n69992624)
print v(xbgr.mr_n69992736)
print v(xbgr.mr_n69993056)
print v(xbgr.mr_n69993168)
print v(xbgr.mr_n69993488)
print v(xbgr.mr_n69993600)
print v(xbgr.mr_n69993920)
print v(xbgr.mr_n69994032)
print v(xbgr.mr_n69994352)
print v(xbgr.mr_n69994464)
print v(xbgr.mr_n69994784)
print v(xbgr.mr_n69994896)
print v(xbgr.mr_n69995216)
print v(xbgr.mr_n69995328)
print v(xbgr.mr_n69995648)
print v(xbgr.mr_n69995760)
print v(xbgr.mr_n69996080)
print v(xbgr.mr_n69996192)
print v(xbgr.mr_n69996512)
print v(xbgr.mr_n69996624)
print v(xbgr.mr_n69996944)
print v(xbgr.mr_n69997488)
print v(xbgr.mr_n69997808)
print v(xbgr.mr_n69997920)
print v(xbgr.mr_n69998240)
print v(xbgr.mr_n69998352)
print v(xbgr.mr_n69998784)
print v(xbgr.mr_n69999216)
print v(xbgr.mr_n69999648)
print v(xbgr.mr_n70000080)
print v(xbgr.mr_n70000512)
print v(xbgr.mr_n70000944)
print v(xbgr.mr_n70001376)
print v(xbgr.mr_n70001808)
print v(xbgr.mr_n70002240)
print v(xbgr.mr_n70002672)
print v(xbgr.mr_n70003104)
print v(xbgr.mr_n70003536)
print v(xbgr.mr_n70003968)
print v(xbgr.mr_n70004400)
print v(xbgr.mr_n70004832)
print v(xbgr.mr_n70005264)
print v(xbgr.mr_n70005696)
print v(xbgr.mr_n70006128)
print v(xbgr.mr_n70006560)
print v(xbgr.mr_n70006992)
print v(xbgr.mr_n70007424)
print v(xbgr.mr_n70007856)
print v(xbgr.mr_n70008288)
print v(xbgr.mr_n70008720)
print v(xbgr.mr_n70009152)
print v(xbgr.mr_n70009584)
print v(xbgr.mr_n70010016)
print v(xbgr.mr_n70010448)
print v(xbgr.mr_n70010880)
print v(xbgr.mr_n70011312)
print v(xbgr.mr_n70011744)
print v(xbgr.mr_n70012176)
print v(xbgr.mr_n70012608)
print v(xbgr.mr_n70013040)
print v(xbgr.mr_n70013472)
print v(xbgr.mr_n70013904)
print v(xbgr.mr_n70014336)
print v(xbgr.mr_n70014768)
print v(xbgr.mr_n70015200)
print v(xbgr.mr_n70015632)
print v(xbgr.mr_n70016064)
print v(xbgr.mr_n70016496)
print v(xbgr.mr_n70016928)
print v(xbgr.mr_n70017360)
print v(xbgr.mr_n70017792)
print v(xbgr.mr_n70018224)
print v(xbgr.mr_n70018656)
print v(xbgr.mr_n70019088)
print v(xbgr.mr_n70019520)
print v(xbgr.mr_n70019952)
print v(xbgr.mr_n70020384)
print v(xbgr.mr_n70020816)
print v(xbgr.mr_n70021248)
print v(xbgr.mr_n70021680)
print v(xbgr.mr_n70022112)
print v(xbgr.mr_n70022544)
print v(xbgr.mr_n70022976)
print v(xbgr.mr_n70023408)
print v(xbgr.mr_n70023840)
print v(xbgr.mr_n70024272)
print v(xbgr.mr_n70024704)
print v(xbgr.mr_n70025136)
print v(xbgr.mr_n70025568)
print v(xbgr.mr_n70026000)
print v(xbgr.mr_n70026432)
print v(xbgr.mr_n70026864)
print v(xbgr.mr_n70027296)
print v(xbgr.mr_n70027728)
print v(xbgr.mr_n70028160)
print v(xbgr.mr_n70028592)
print v(xbgr.mr_n70029024)
print v(xbgr.mr_n70029456)
print v(xbgr.mr_n70029888)
print v(xbgr.mr_n70030320)
print v(xbgr.mr_n70030752)
print v(xbgr.mr_n70031184)
print v(xbgr.mr_n70031616)
print v(xbgr.mr_n70032048)
print v(xbgr.mr_n70032480)
print v(xbgr.mr_n70032912)
print v(xbgr.mr_n70033344)
print v(xbgr.mr_n70033776)
print v(xbgr.mr_n70034208)
print v(xbgr.mr_n70034640)
print v(xbgr.mr_n70035072)
print v(xbgr.mr_n70035504)
print v(xbgr.mr_n70035936)
print v(xbgr.mr_n70036368)
print v(xbgr.mr_n70036800)
print v(xbgr.mr_n70037232)
print v(xbgr.mr_n70037664)
print v(xbgr.mr_n70038096)
print v(xbgr.mr_n70038528)
print v(xbgr.mr_n70038960)
print v(xbgr.mr_n70039392)
print v(xbgr.mr_n70039824)
print v(xbgr.mr_n70040256)
print v(xbgr.mr_n70040688)
print v(xbgr.mr_n70041120)
print v(xbgr.mr_n70041552)
print v(xbgr.mr_n70041984)
print v(xbgr.mr_n70042416)
print v(xbgr.mr_n70042848)
print v(xbgr.mr_n70043280)
print v(xbgr.mr_n70043712)
print v(xbgr.mr_n70044032)
print v(xbgr.mr_n70044144)
print v(xbgr.mr_n70044464)
print v(xbgr.mr_n70044576)
print v(xbgr.mr_n70044896)
print v(xbgr.mr_n70045008)
print v(xbgr.mr_n70045328)
print v(xbgr.mr_n70045440)
print v(xbgr.mr_n70045760)
print v(xbgr.mr_n70045872)
print v(xbgr.mr_n70046192)
print v(xbgr.mr_n70046304)
print v(xbgr.mr_n70046624)
print v(xbgr.mr_n70046736)
print v(xbgr.mr_n70047056)
print v(xbgr.mr_n70047168)
print v(xbgr.mr_n70047488)
print v(xbgr.mr_n70047600)
print v(xbgr.mr_n70047920)
print v(xbgr.mr_n70048032)
print v(xbgr.mr_n70048352)
print v(xbgr.mr_n70048464)
print v(xbgr.mr_n70048784)
print v(xbgr.mr_n70048896)
print v(xbgr.mr_n70049216)
print v(xbgr.mr_n70049328)
print v(xbgr.mr_n70049648)
print v(xbgr.mr_n70049760)
print v(xbgr.mr_n70050080)
print v(xbgr.mr_n70050192)
print v(xbgr.mr_n70050512)
print v(xbgr.mr_n70050624)
print v(xbgr.mr_n70050944)
print v(xbgr.mr_n70051056)
print v(xbgr.mr_n70051376)
print v(xbgr.mr_n70051488)
print v(xbgr.mr_n70051808)
print v(xbgr.mr_n70051920)
print v(xbgr.mr_n70052240)
print v(xbgr.mr_n70052352)
print v(xbgr.mr_n70052672)
print v(xbgr.mr_n70052784)
print v(xbgr.mr_n70053104)
print v(xbgr.mr_n70053216)
print v(xbgr.mr_n70053536)
print v(xbgr.mr_n70053648)
print v(xbgr.mr_n70053968)
print v(xbgr.mr_n70054080)
print v(xbgr.mr_n70054400)
print v(xbgr.mr_n70054512)
print v(xbgr.mr_n70054832)
print v(xbgr.mr_n70054944)
print v(xbgr.mr_n70055264)
print v(xbgr.mr_n70055376)
print v(xbgr.mr_n70055696)
print v(xbgr.mr_n70055808)
print v(xbgr.mr_n70056128)
print v(xbgr.mr_n70056240)
print v(xbgr.mr_n70056560)
print v(xbgr.mr_n70056672)
print v(xbgr.mr_n70056992)
print v(xbgr.mr_n70057104)
print v(xbgr.mr_n70057424)
print v(xbgr.mr_n70057536)
print v(xbgr.mr_n70057856)
print v(xbgr.mr_n70057968)
print v(xbgr.mr_n70058288)
print v(xbgr.mr_n70058400)
print v(xbgr.mr_n70058720)
print v(xbgr.mr_n70058832)
print v(xbgr.mr_n70059152)
print v(xbgr.mr_n70059264)
print v(xbgr.mr_n70059584)
print v(xbgr.mr_n70059696)
print v(xbgr.mr_n70060016)
print v(xbgr.mr_n70060128)
print v(xbgr.mr_n70060448)
print v(xbgr.mr_n70060560)
print v(xbgr.mr_n70060880)
print v(xbgr.mr_n70060992)
print v(xbgr.mr_n70061312)
print v(xbgr.mr_n70061424)
print v(xbgr.mr_n70061744)
print v(xbgr.mr_n70061856)
print v(xbgr.mr_n70062176)
print v(xbgr.mr_n70062608)
print v(xbgr.mr_n70062720)
print v(xbgr.mr_n70063040)
print v(xbgr.mr_n70063152)
print v(xbgr.mr_n70063472)
print v(xbgr.mr_n70063584)
print v(xbgr.mr_n70063904)
print v(xbgr.mr_n70064016)
print v(xbgr.mr_n70064336)
print v(xbgr.mr_n70064448)
print v(xbgr.mr_n70064768)
print v(xbgr.mr_n70064880)
print v(xbgr.mr_n70065200)
print v(xbgr.mr_n70065312)
print v(xbgr.mr_n70065632)
print v(xbgr.mr_n70065744)
print v(xbgr.mr_n70066064)
print v(xbgr.mr_n70066176)
print v(xbgr.mr_n70066496)
print v(xbgr.mr_n70066608)
print v(xbgr.mr_n70066928)
print v(xbgr.mr_n70067040)
print v(xbgr.mr_n70067360)
print v(xbgr.mr_n70067472)
print v(xbgr.mr_n70067792)
print v(xbgr.mr_n70067904)
print v(xbgr.mr_n70068224)
print v(xbgr.mr_n70068336)
print v(xbgr.mr_n70068656)
print v(xbgr.mr_n70068768)
print v(xbgr.mr_n70069088)
print v(xbgr.mr_n70069200)
print v(xbgr.mr_n70069520)
print v(xbgr.mr_n70069632)
print v(xbgr.mr_n70069952)
print v(xbgr.mr_n70070064)
print v(xbgr.mr_n70070384)
print v(xbgr.mr_n70070496)
print v(xbgr.mr_n70070816)
print v(xbgr.mr_n70070928)
print v(xbgr.mr_n70071248)
print v(xbgr.mr_n70071360)
print v(xbgr.mr_n70071680)
print v(xbgr.mr_n70071792)
print v(xbgr.mr_n70072112)
print v(xbgr.mr_n70072224)
print v(xbgr.mr_n70072544)
print v(xbgr.mr_n70072656)
print v(xbgr.mr_n70072976)
print v(xbgr.mr_n70073088)
print v(xbgr.mr_n70073408)
print v(xbgr.mr_n70073520)
print v(xbgr.mr_n70073840)
print v(xbgr.mr_n70073952)
print v(xbgr.mr_n70074272)
print v(xbgr.mr_n70074384)
print v(xbgr.mr_n70074704)
print v(xbgr.mr_n70074816)
print v(xbgr.mr_n70075136)
print v(xbgr.mr_n70075248)
print v(xbgr.mr_n70075568)
print v(xbgr.mr_n70075680)
print v(xbgr.mr_n70076000)
print v(xbgr.mr_n70076112)
print v(xbgr.mr_n70076432)
print v(xbgr.mr_n70076544)
print v(xbgr.mr_n70076864)
print v(xbgr.mr_n70076976)
print v(xbgr.mr_n70077296)
print v(xbgr.mr_n70077408)
print v(xbgr.mr_n70077728)
print v(xbgr.mr_n70077840)
print v(xbgr.mr_n70078160)
print v(xbgr.mr_n70078272)
print v(xbgr.mr_n70078592)
print v(xbgr.mr_n70078704)
print v(xbgr.mr_n70079024)
print v(xbgr.mr_n70079136)
print v(xbgr.mr_n70079456)
print v(xbgr.mr_n70079568)
print v(xbgr.mr_n70079888)
print v(xbgr.mr_n70080000)
print v(xbgr.mr_n70080320)
print v(xbgr.mr_n70080432)
print v(xbgr.mr_n70080752)
print v(xbgr.mr_n70080864)
print v(xbgr.mr_n70081184)
print v(xbgr.mr_n70081296)
print v(xbgr.mr_n70081616)
print v(xbgr.mr_n70081728)
print v(xbgr.mr_n70082048)
print v(xbgr.mr_n70082160)
print v(xbgr.mr_n70082480)
print v(xbgr.mr_n70082592)
print v(xbgr.mr_n70082912)
print v(xbgr.mr_n70083024)
print v(xbgr.mr_n70083344)
print v(xbgr.mr_n70083456)
print v(xbgr.mr_n70083776)
print v(xbgr.mr_n70083888)
print v(xbgr.mr_n70084208)
print v(xbgr.mr_n70084320)
print v(xbgr.mr_n70084640)
print v(xbgr.mr_n70084752)
print v(xbgr.mr_n70085072)
print v(xbgr.mr_n70085184)
print v(xbgr.mr_n70085504)
print v(xbgr.mr_n70085616)
print v(xbgr.mr_n70085936)
print v(xbgr.mr_n70086048)
print v(xbgr.mr_n70086368)
print v(xbgr.mr_n70086480)
print v(xbgr.mr_n70086800)
print v(xbgr.mr_n70086912)
print v(xbgr.mr_n70087232)
print v(xbgr.mr_n70087344)
print v(xbgr.mr_n70087664)
print v(xbgr.mr_n70087776)
print v(xbgr.mr_n70088096)
print v(xbgr.mr_n70088208)
print v(xbgr.mr_n70088528)
print v(xbgr.mr_n70088640)
print v(xbgr.mr_n70088960)
print v(xbgr.mr_n70089072)
print v(xbgr.mr_n70089392)
print v(xbgr.mr_n70089504)
print v(xbgr.mr_n70089824)
print v(xbgr.mr_n70089936)
print v(xbgr.mr_n70090256)
print v(xbgr.mr_n70090368)
print v(xbgr.mr_n70090688)
print v(xbgr.mr_n70090800)
print v(xbgr.mr_n70091120)
print v(xbgr.mr_n70091232)
print v(xbgr.mr_n70091552)
print v(xbgr.mr_n70091664)
print v(xbgr.mr_n70091984)
print v(xbgr.mr_n70092096)
print v(xbgr.mr_n70092416)
print v(xbgr.mr_n70092528)
print v(xbgr.mr_n70092848)
print v(xbgr.mr_n70092960)
print v(xbgr.mr_n70093280)
print v(xbgr.mr_n70093392)
print v(xbgr.mr_n70093712)
print v(xbgr.mr_n70093824)
print v(xbgr.mr_n70094144)
print v(xbgr.mr_n70094256)
print v(xbgr.mr_n70094576)
print v(xbgr.mr_n70094688)
print v(xbgr.mr_n70095008)
print v(xbgr.mr_n70095120)
print v(xbgr.mr_n70095440)
print v(xbgr.mr_n70095552)
print v(xbgr.mr_n70095872)
print v(xbgr.mr_n70095984)
print v(xbgr.mr_n70096304)
print v(xbgr.mr_n70096416)
print v(xbgr.mr_n70096736)
print v(xbgr.mr_n70096848)
print v(xbgr.mr_n70097168)
print v(xbgr.mr_n70097280)
print v(xbgr.mr_n70097600)
print v(xbgr.mr_n70097712)
print v(xbgr.mr_n70098032)
print v(xbgr.mr_n70098144)
print v(xbgr.mr_n70098464)
print v(xbgr.mr_n70098576)
print v(xbgr.mr_n70098896)
print v(xbgr.mr_n70099008)
print v(xbgr.mr_n70099328)
print v(xbgr.mr_n70099440)
print v(xbgr.mr_n70099760)
print v(xbgr.mr_n70099872)
print v(xbgr.mr_n70100192)
print v(xbgr.mr_n70100304)
print v(xbgr.mr_n70100624)
print v(xbgr.mr_n70100736)
print v(xbgr.mr_n70101056)
print v(xbgr.mr_n70101168)
print v(xbgr.mr_n70101488)
print v(xbgr.mr_n70101600)
print v(xbgr.mr_n70101920)
print v(xbgr.mr_n70102032)
print v(xbgr.mr_n70102352)
print v(xbgr.mr_n70102464)
print v(xbgr.mr_n70102784)
print v(xbgr.mr_n70102896)
print v(xbgr.mr_n70103216)
print v(xbgr.mr_n70103328)
print v(xbgr.mr_n70103648)
print v(xbgr.mr_n70103760)
print v(xbgr.mr_n70104080)
print v(xbgr.mr_n70104192)
print v(xbgr.mr_n70104512)
print v(xbgr.mr_n70104624)
print v(xbgr.mr_n70104944)
print v(xbgr.mr_n70105056)
print v(xbgr.mr_n70105376)
print v(xbgr.mr_n70105488)
print v(xbgr.mr_n70105808)
print v(xbgr.mr_n70105920)
print v(xbgr.mr_n70106240)
print v(xbgr.mr_n70106352)
print v(xbgr.mr_n70106672)
print v(xbgr.mr_n70106784)
print v(xbgr.mr_n70107104)
print v(xbgr.mr_n70107216)
print v(xbgr.mr_n70107536)
print v(xbgr.mr_n70107648)
print v(xbgr.mr_n70107968)
print v(xbgr.mr_n70108080)
print v(xbgr.mr_n70108400)
print v(xbgr.mr_n70108512)
print v(xbgr.mr_n70108832)
print v(xbgr.mr_n70108944)
print v(xbgr.mr_n70109264)
print v(xbgr.mr_n70109376)
print v(xbgr.mr_n70109696)
print v(xbgr.mr_n70109808)
print v(xbgr.mr_n70110128)
print v(xbgr.mr_n70110240)
print v(xbgr.mr_n70110560)
print v(xbgr.mr_n70110672)
print v(xbgr.mr_n70110992)
print v(xbgr.mr_n70111104)
print v(xbgr.mr_n70111424)
print v(xbgr.mr_n70111536)
print v(xbgr.mr_n70111856)
print v(xbgr.mr_n70111968)
print v(xbgr.mr_n70112288)
print v(xbgr.mr_n70112720)
print v(xbgr.mr_n70112832)
print v(xbgr.mr_n70113152)
print v(xbgr.mr_n70113264)
print v(xbgr.mr_n70113584)
print v(xbgr.mr_n70113696)
print v(xbgr.mr_n70114016)
print v(xbgr.mr_n70114128)
print v(xbgr.mr_n70114448)
print v(xbgr.mr_n70114560)
print v(xbgr.mr_n70114880)
print v(xbgr.mr_n70114992)
print v(xbgr.mr_n70115312)
print v(xbgr.mr_n70115424)
print v(xbgr.mr_n70115744)
print v(xbgr.mr_n70115856)
print v(xbgr.mr_n70116176)
print v(xbgr.mr_n70116288)
print v(xbgr.mr_n70116608)
print v(xbgr.mr_n70116720)
print v(xbgr.mr_n70117040)
print v(xbgr.mr_n70117152)
print v(xbgr.mr_n70117472)
print v(xbgr.mr_n70117584)
print v(xbgr.mr_n70117904)
print v(xbgr.mr_n70118016)
print v(xbgr.mr_n70118336)
print v(xbgr.mr_n70118448)
print v(xbgr.mr_n70118768)
print v(xbgr.mr_n70118880)
print v(xbgr.mr_n70119200)
print v(xbgr.mr_n70119312)
print v(xbgr.mr_n70119632)
print v(xbgr.mr_n70119744)
print v(xbgr.mr_n70120064)
print v(xbgr.mr_n70120176)
print v(xbgr.mr_n70120496)
print v(xbgr.mr_n70120608)
print v(xbgr.mr_n70120928)
print v(xbgr.mr_n70121040)
print v(xbgr.mr_n70121360)
print v(xbgr.mr_n70121472)
print v(xbgr.mr_n70121792)
print v(xbgr.mr_n70121904)
print v(xbgr.mr_n70122224)
print v(xbgr.mr_n70122336)
print v(xbgr.mr_n70122656)
print v(xbgr.mr_n70122768)
print v(xbgr.mr_n70123088)
print v(xbgr.mr_n70123200)
print v(xbgr.mr_n70123520)
print v(xbgr.mr_n70123632)
print v(xbgr.mr_n70123952)
print v(xbgr.mr_n70124064)
print v(xbgr.mr_n70124384)
print v(xbgr.mr_n70124496)
print v(xbgr.mr_n70124816)
print v(xbgr.mr_n70124928)
print v(xbgr.mr_n70125248)
print v(xbgr.mr_n70125360)
print v(xbgr.mr_n70125680)
print v(xbgr.mr_n70125792)
print v(xbgr.mr_n70126112)
print v(xbgr.mr_n70126224)
print v(xbgr.mr_n70126544)
print v(xbgr.mr_n70126656)
print v(xbgr.mr_n70126976)
print v(xbgr.mr_n70127088)
print v(xbgr.mr_n70127408)
print v(xbgr.mr_n70127520)
print v(xbgr.mr_n70127840)
print v(xbgr.mr_n70127952)
print v(xbgr.mr_n70128272)
print v(xbgr.mr_n70128384)
print v(xbgr.mr_n70128704)
print v(xbgr.mr_n70128816)
print v(xbgr.mr_n70129136)
print v(xbgr.mr_n70129248)
print v(xbgr.mr_n70129568)
print v(xbgr.mr_n70129680)
print v(xbgr.mr_n70130000)
print v(xbgr.mr_n70130112)
print v(xbgr.mr_n70130432)
print v(xbgr.mr_n70130544)
print v(xbgr.mr_n70130864)
print v(xbgr.mr_n70130976)
print v(xbgr.mr_n70131296)
print v(xbgr.mr_n70131408)
print v(xbgr.mr_n70131728)
print v(xbgr.mr_n70131840)
print v(xbgr.mr_n70132160)
print v(xbgr.mr_n70132272)
print v(xbgr.mr_n70132592)
print v(xbgr.mr_n70132704)
print v(xbgr.mr_n70133024)
print v(xbgr.mr_n70133456)
print v(xbgr.mr_n70133568)
print v(xbgr.mr_n70133888)
print v(xbgr.mr_n70134000)
print v(xbgr.mr_n70134320)
print v(xbgr.mr_n70134432)
print v(xbgr.mr_n70134752)
print v(xbgr.mr_n70134864)
print v(xbgr.mr_n70135184)
print v(xbgr.mr_n70135296)
print v(xbgr.mr_n70135616)
print v(xbgr.mr_n70135728)
print v(xbgr.mr_n70136160)
print v(xbgr.mr_n70136592)
print v(xbgr.mr_n70136912)
print v(xbgr.mr_n70137024)
print v(xbgr.mr_n70137344)
print v(xbgr.mr_n70137456)
print v(xbgr.mr_n70137776)
print v(xbgr.mr_n70137888)
print v(xbgr.mr_n70138208)
print v(xbgr.mr_n70138320)
print v(xbgr.mr_n70138640)
print v(xbgr.mr_n70138752)
print v(xbgr.mr_n70139072)
print v(xbgr.mr_n70139184)
print v(xbgr.mr_n70139504)
print v(xbgr.mr_n70139616)
print v(xbgr.mr_n70139936)
print v(xbgr.mr_n70140048)
print v(xbgr.mr_n70140368)
print v(xbgr.mr_n70140480)
print v(xbgr.mr_n70140800)
print v(xbgr.mr_n70140912)
print v(xbgr.mr_n70141232)
print v(xbgr.mr_n70141344)
print v(xbgr.mr_n70141664)
print v(xbgr.mr_n70141776)
print v(xbgr.mr_n70142096)
print v(xbgr.mr_n70142208)
print v(xbgr.mr_n70142528)
print v(xbgr.mr_n70142640)
print v(xbgr.mr_n70142960)
print v(xbgr.mr_n70143072)
print v(xbgr.mr_n70143392)
print v(xbgr.mr_n70143504)
print v(xbgr.mr_n70143824)
print v(xbgr.mr_n70143936)
print v(xbgr.mr_n70144256)
print v(xbgr.mr_n70144368)
print v(xbgr.mr_n70144688)
print v(xbgr.mr_n70144800)
print v(xbgr.mr_n70145120)
print v(xbgr.mr_n70145232)
print v(xbgr.mr_n70145552)
print v(xbgr.mr_n70145664)
print v(xbgr.mr_n70145984)
print v(xbgr.mr_n70146096)
print v(xbgr.mr_n70146416)
print v(xbgr.mr_n70146528)
print v(xbgr.mr_n70146848)
print v(xbgr.mr_n70146960)
print v(xbgr.mr_n70147280)
print v(xbgr.mr_n70147392)
print v(xbgr.mr_n70147712)
print v(xbgr.mr_n70147824)
print v(xbgr.mr_n70148144)
print v(xbgr.mr_n70148256)
print v(xbgr.mr_n70148576)
print v(xbgr.mr_n70148688)
print v(xbgr.mr_n70149008)
print v(xbgr.mr_n70149120)
print v(xbgr.mr_n70149440)
print v(xbgr.mr_n70149552)
print v(xbgr.mr_n70149872)
print v(xbgr.mr_n70149984)
print v(xbgr.mr_n70150304)
print v(xbgr.mr_n70150416)
print v(xbgr.mr_n70150736)
print v(xbgr.mr_n70150848)
print v(xbgr.mr_n70151168)
print v(xbgr.mr_n70151280)
print v(xbgr.mr_n70151600)
print v(xbgr.mr_n70151712)
print v(xbgr.mr_n70152032)
print v(xbgr.mr_n70152144)
print v(xbgr.mr_n70152464)
print v(xbgr.mr_n70152576)
print v(xbgr.mr_n70152896)
print v(xbgr.mr_n70153008)
print v(xbgr.mr_n70153328)
print v(xbgr.mr_n70153440)
print v(xbgr.mr_n70153760)
print v(xbgr.mr_n70153872)
print v(xbgr.mr_n70154192)
print v(xbgr.mr_n70154304)
print v(xbgr.mr_n70154624)
print v(xbgr.mr_n70154736)
print v(xbgr.mr_n70155056)
print v(xbgr.mr_n70155168)
print v(xbgr.mr_n70155488)
print v(xbgr.mr_n70155600)
print v(xbgr.mr_n70155920)
print v(xbgr.mr_n70156032)
print v(xbgr.mr_n70156352)
print v(xbgr.mr_n70156464)
print v(xbgr.mr_n70156784)
print v(xbgr.mr_n70156896)
print v(xbgr.mr_n70157216)
print v(xbgr.mr_n70157328)
print v(xbgr.mr_n70157648)
print v(xbgr.mr_n70157760)
print v(xbgr.mr_n70158080)
print v(xbgr.mr_n70158192)
print v(xbgr.mr_n70158512)
print v(xbgr.mr_n70158624)
print v(xbgr.mr_n70158944)
print v(xbgr.mr_n70159056)
print v(xbgr.mr_n70159376)
print v(xbgr.mr_n70159488)
print v(xbgr.mr_n70159808)
print v(xbgr.mr_n70159920)
print v(xbgr.mr_n70160240)
print v(xbgr.mr_n70160352)
print v(xbgr.mr_n70160672)
print v(xbgr.mr_n70160784)
print v(xbgr.mr_n70161104)
print v(xbgr.mr_n70161216)
print v(xbgr.mr_n70161536)
print v(xbgr.mr_n70161648)
print v(xbgr.mr_n70161968)
print v(xbgr.mr_n70162080)
print v(xbgr.mr_n70162400)
print v(xbgr.mr_n70162512)
print v(xbgr.mr_n70162832)
print v(xbgr.mr_n70162944)
print v(xbgr.mr_n70163264)
print v(xbgr.mr_n70163376)
print v(xbgr.mr_n70163696)
print v(xbgr.mr_n70163808)
print v(xbgr.mr_n70164128)
print v(xbgr.mr_n70164240)
print v(xbgr.mr_n70164560)
print v(xbgr.mr_n70164672)
print v(xbgr.mr_n70164992)
print v(xbgr.mr_n70165104)
print v(xbgr.mr_n70165424)
print v(xbgr.mr_n70165536)
print v(xbgr.mr_n70165856)
print v(xbgr.mr_n70165968)
print v(xbgr.mr_n70166288)
print v(xbgr.mr_n70166400)
print v(xbgr.mr_n70166720)
print v(xbgr.mr_n70166832)
print v(xbgr.mr_n70167152)
print v(xbgr.mr_n70167264)
print v(xbgr.mr_n70167584)
print v(xbgr.mr_n70167696)
print v(xbgr.mr_n70168016)
print v(xbgr.mr_n70168128)
print v(xbgr.mr_n70168448)
print v(xbgr.mr_n70168560)
print v(xbgr.mr_n70168880)
print v(xbgr.mr_n70168992)
print v(xbgr.mr_n70169312)
print v(xbgr.mr_n70169424)
print v(xbgr.mr_n70169744)
print v(xbgr.mr_n70169856)
print v(xbgr.mr_n70170176)
print v(xbgr.mr_n70170288)
print v(xbgr.mr_n70170608)
print v(xbgr.mr_n70170720)
print v(xbgr.mr_n70171040)
print v(xbgr.mr_n70171152)
print v(xbgr.mr_n70171472)
print v(xbgr.mr_n70171584)
print v(xbgr.mr_n70171904)
print v(xbgr.mr_n70172016)
print v(xbgr.mr_n70172336)
print v(xbgr.mr_n70172448)
print v(xbgr.mr_n70172768)
print v(xbgr.mr_n70172880)
print v(xbgr.mr_n70173200)
print v(xbgr.mr_n70173312)
print v(xbgr.mr_n70173632)
print v(xbgr.mr_n70173744)
print v(xbgr.mr_n70174064)
print v(xbgr.mr_n70174176)
print v(xbgr.mr_n70174496)
print v(xbgr.mr_n70174608)
print v(xbgr.mr_n70174928)
print v(xbgr.mr_n70175040)
print v(xbgr.mr_n70175360)
print v(xbgr.mr_n70175472)
print v(xbgr.mr_n70175792)
print v(xbgr.mr_n70175904)
print v(xbgr.mr_n70176224)
print v(xbgr.mr_n70176336)
print v(xbgr.mr_n70176656)
print v(xbgr.mr_n70176768)
print v(xbgr.mr_n70177088)
print v(xbgr.mr_n70177200)
print v(xbgr.mr_n70177520)
print v(xbgr.mr_n70177632)
print v(xbgr.mr_n70177952)
print v(xbgr.mr_n70178064)
print v(xbgr.mr_n70178384)
print v(xbgr.mr_n70178496)
print v(xbgr.mr_n70178816)
print v(xbgr.mr_n70178928)
print v(xbgr.mr_n70179248)
print v(xbgr.mr_n70179360)
print v(xbgr.mr_n70179680)
print v(xbgr.mr_n70179792)
print v(xbgr.mr_n70180112)
print v(xbgr.mr_n70180224)
print v(xbgr.mr_n70180544)
print v(xbgr.mr_n70180656)
print v(xbgr.mr_n70180976)
print v(xbgr.mr_n70181088)
print v(xbgr.mr_n70181408)
print v(xbgr.mr_n70181520)
print v(xbgr.mr_n70181840)
print v(xbgr.mr_n70181952)
print v(xbgr.mr_n70182272)
print v(xbgr.mr_n70182384)
print v(xbgr.mr_n70182704)
print v(xbgr.mr_n70182816)
print v(xbgr.mr_n70183136)
print v(xbgr.mr_n70183248)
print v(xbgr.mr_n70183568)
print v(xbgr.mr_n70183680)
print v(xbgr.mr_n70184000)
print v(xbgr.mr_n70184112)
print v(xbgr.mr_n70184432)
print v(xbgr.mr_n70184544)
print v(xbgr.mr_n70184864)
print v(xbgr.mr_n70184976)
print v(xbgr.mr_n70185296)
print v(xbgr.mr_n70185408)
print v(xbgr.mr_n70185728)
print v(xbgr.mr_n70185840)
print v(xbgr.mr_n70186160)
print v(xbgr.mr_n70186272)
print v(xbgr.mr_n70186592)
print v(xbgr.mr_n70186704)
print v(xbgr.mr_n70187024)
print v(xbgr.mr_n70187136)
print v(xbgr.mr_n70187456)
print v(xbgr.mr_n70187568)
print v(xbgr.mr_n70187888)
print v(xbgr.mr_n70188000)
print v(xbgr.mr_n70188320)
print v(xbgr.mr_n70188432)
print v(xbgr.mr_n70188752)
print v(xbgr.mr_n70188864)
print v(xbgr.mr_n70189184)
print v(xbgr.mr_n70189296)
print v(xbgr.mr_n70189616)
print v(xbgr.mr_n70189728)
print v(xbgr.mr_n70190048)
print v(xbgr.mr_n70190160)
print v(xbgr.mr_n70190480)
print v(xbgr.mr_n70190592)
print v(xbgr.mr_n70190912)
print v(xbgr.mr_n70191024)
print v(xbgr.mr_n70191344)
print v(xbgr.mr_n70191456)
print v(xbgr.mr_n70191776)
print v(xbgr.mr_n70191888)
print v(xbgr.mr_n70192208)
print v(xbgr.mr_n70192320)
print v(xbgr.mr_n70192752)
print v(xbgr.mr_n70193184)
print v(xbgr.mr_n70193616)
print v(xbgr.mr_n70194048)
print v(xbgr.mr_n70194480)
print v(xbgr.mr_n70194912)
print v(xbgr.mr_n70195344)
print v(xbgr.mr_n70195776)
print v(xbgr.mr_n70196208)
print v(xbgr.mr_n70196640)
print v(xbgr.mr_n70197072)
print v(xbgr.mr_n70197504)
print v(xbgr.mr_n70197936)
print v(xbgr.mr_n70198368)
print v(xbgr.mr_n70198800)
print v(xbgr.mr_n70199232)
print v(xbgr.mr_n70199664)
print v(xbgr.mr_n70200096)
print v(xbgr.mr_n70200528)
print v(xbgr.mr_n70200960)
print v(xbgr.mr_n70201392)
print v(xbgr.mr_n70201824)
print v(xbgr.mr_n70202256)
print v(xbgr.mr_n70202688)
print v(xbgr.mr_n70203120)
print v(xbgr.mr_n70203552)
print v(xbgr.mr_n70203984)
print v(xbgr.mr_n70204416)
print v(xbgr.mr_n70204848)
print v(xbgr.mr_n70205280)
print v(xbgr.mr_n70205712)
print v(xbgr.mr_n70206144)
print v(xbgr.mr_n70206576)
print v(xbgr.mr_n70207008)
print v(xbgr.mr_n70207440)
print v(xbgr.mr_n70207872)
print v(xbgr.mr_n70208304)
print v(xbgr.mr_n70208736)
print v(xbgr.mr_n70209168)
print v(xbgr.mr_n70209600)
print v(xbgr.mr_n70210032)
print v(xbgr.mr_n70210464)
print v(xbgr.mr_n70210896)
print v(xbgr.mr_n70211328)
print v(xbgr.mr_n70211760)
print v(xbgr.mr_n70212192)
print v(xbgr.mr_n70212624)
print v(xbgr.mr_n70213056)
print v(xbgr.mr_n70213488)
print v(xbgr.mr_n70213920)
print v(xbgr.mr_n70214352)
print v(xbgr.mr_n70214784)
print v(xbgr.mr_n70215216)
print v(xbgr.mr_n70215648)
print v(xbgr.mr_n70216080)
print v(xbgr.mr_n70216512)
print v(xbgr.mr_n70216944)
print v(xbgr.mr_n70217376)
print v(xbgr.mr_n70217808)
print v(xbgr.mr_n70218240)
print v(xbgr.mr_n70218672)
print v(xbgr.mr_n70219104)
print v(xbgr.mr_n70219536)
print v(xbgr.mr_n70219968)
print v(xbgr.mr_n70220400)
print v(xbgr.mr_n70220832)
print v(xbgr.mr_n70221264)
print v(xbgr.mr_n70221696)
print v(xbgr.mr_n70222128)
print v(xbgr.mr_n70222560)
print v(xbgr.mr_n70222992)
print v(xbgr.mr_n70223424)
print v(xbgr.mr_n70223856)
print v(xbgr.mr_n70224288)
print v(xbgr.mr_n70224720)
print v(xbgr.mr_n70225152)
print v(xbgr.mr_n70225584)
print v(xbgr.mr_n70226016)
print v(xbgr.mr_n70226448)
print v(xbgr.mr_n70226880)
print v(xbgr.mr_n70227312)
print v(xbgr.mr_n70227744)
print v(xbgr.mr_n70228176)
print v(xbgr.mr_n70228608)
print v(xbgr.mr_n70229040)
print v(xbgr.mr_n70229472)
print v(xbgr.mr_n70229904)
print v(xbgr.mr_n70230336)
print v(xbgr.mr_n70230768)
print v(xbgr.mr_n70231200)
print v(xbgr.mr_n70231632)
print v(xbgr.mr_n70232064)
print v(xbgr.mr_n70232496)
print v(xbgr.mr_n70232928)
print v(xbgr.mr_n70233360)
print v(xbgr.mr_n70233792)
print v(xbgr.mr_n70234224)
print v(xbgr.mr_n70234656)
print v(xbgr.mr_n70234976)
print v(xbgr.mr_n70235088)
print v(xbgr.mr_n70235408)
print v(xbgr.mr_n70235520)
print v(xbgr.mr_n70235840)
print v(xbgr.mr_n70235952)
print v(xbgr.mr_n70236272)
print v(xbgr.mr_n70236384)
print v(xbgr.mr_n70236704)
print v(xbgr.mr_n70236816)
print v(xbgr.mr_n70237136)
print v(xbgr.mr_n70237248)
print v(xbgr.mr_n70237568)
print v(xbgr.mr_n70237680)
print v(xbgr.mr_n70238000)
print v(xbgr.mr_n70238112)
print v(xbgr.mr_n70238432)
print v(xbgr.mr_n70238544)
print v(xbgr.mr_n70238864)
print v(xbgr.mr_n70238976)
print v(xbgr.mr_n70239296)
print v(xbgr.mr_n70239408)
print v(xbgr.mr_n70239728)
print v(xbgr.mr_n70239840)
print v(xbgr.mr_n70240160)
print v(xbgr.mr_n70240272)
print v(xbgr.mr_n70240592)
print v(xbgr.mr_n70240704)
print v(xbgr.mr_n70241024)
print v(xbgr.mr_n70241136)
print v(xbgr.mr_n70241456)
print v(xbgr.mr_n70241568)
print v(xbgr.mr_n70241888)
print v(xbgr.mr_n70242000)
print v(xbgr.mr_n70242320)
print v(xbgr.mr_n70242432)
print v(xbgr.mr_n70242752)
print v(xbgr.mr_n70242864)
print v(xbgr.mr_n70243184)
print v(xbgr.mr_n70243296)
print v(xbgr.mr_n70243616)
print v(xbgr.mr_n70243728)
print v(xbgr.mr_n70244048)
print v(xbgr.mr_n70244160)
print v(xbgr.mr_n70244480)
print v(xbgr.mr_n70244592)
print v(xbgr.mr_n70244912)
print v(xbgr.mr_n70245024)
print v(xbgr.mr_n70245344)
print v(xbgr.mr_n70245456)
print v(xbgr.mr_n70245776)
print v(xbgr.mr_n70245888)
print v(xbgr.mr_n70246208)
print v(xbgr.mr_n70246320)
print v(xbgr.mr_n70246640)
print v(xbgr.mr_n70246752)
print v(xbgr.mr_n70247072)
print v(xbgr.mr_n70247184)
print v(xbgr.mr_n70247504)
print v(xbgr.mr_n70247616)
print v(xbgr.mr_n70247936)
print v(xbgr.mr_n70248048)
print v(xbgr.mr_n70248368)
print v(xbgr.mr_n70248480)
print v(xbgr.mr_n70248800)
print v(xbgr.mr_n70248912)
print v(xbgr.mr_n70249232)
print v(xbgr.mr_n70249344)
print v(xbgr.mr_n70249664)
print v(xbgr.mr_n70249776)
print v(xbgr.mr_n70250096)
print v(xbgr.mr_n70250208)
print v(xbgr.mr_n70250528)
print v(xbgr.mr_n70250640)
print v(xbgr.mr_n70250960)
print v(xbgr.mr_n70251072)
print v(xbgr.mr_n70251392)
print v(xbgr.mr_n70251504)
print v(xbgr.mr_n70251824)
print v(xbgr.mr_n70251936)
print v(xbgr.mr_n70252256)
print v(xbgr.mr_n70252368)
print v(xbgr.mr_n70252688)
print v(xbgr.mr_n70252800)
print v(xbgr.mr_n70253120)
print v(xbgr.mr_n70253232)
print v(xbgr.mr_n70253552)
print v(xbgr.mr_n70253664)
print v(xbgr.mr_n70253984)
print v(xbgr.mr_n70254096)
print v(xbgr.mr_n70254416)
print v(xbgr.mr_n70254528)
print v(xbgr.mr_n70254848)
print v(xbgr.mr_n70254960)
print v(xbgr.mr_n70255280)
print v(xbgr.mr_n70255392)
print v(xbgr.mr_n70255712)
print v(xbgr.mr_n70255824)
print v(xbgr.mr_n70256144)
print v(xbgr.mr_n70256256)
print v(xbgr.mr_n70256576)
print v(xbgr.mr_n70256688)
print v(xbgr.mr_n70257008)
print v(xbgr.mr_n70257120)
print v(xbgr.mr_n70257440)
print v(xbgr.mr_n70257552)
print v(xbgr.mr_n70257872)
print v(xbgr.mr_n70257984)
print v(xbgr.mr_n70258304)
print v(xbgr.mr_n70258416)
print v(xbgr.mr_n70258736)
print v(xbgr.mr_n70258848)
print v(xbgr.mr_n70259168)
print v(xbgr.mr_n70259280)
print v(xbgr.mr_n70259600)
print v(xbgr.mr_n70259712)
print v(xbgr.mr_n70260032)
print v(xbgr.mr_n70260144)
print v(xbgr.mr_n70260464)
print v(xbgr.mr_n70260576)
print v(xbgr.mr_n70260896)
print v(xbgr.mr_n70261008)
print v(xbgr.mr_n70261328)
print v(xbgr.mr_n70261440)
print v(xbgr.mr_n70261760)
print v(xbgr.mr_n70261872)
print v(xbgr.mr_n70262192)
print v(xbgr.mr_n70262304)
print v(xbgr.mr_n70262624)
print v(xbgr.mr_n70262736)
print v(xbgr.mr_n70263056)
print v(xbgr.mr_n70263168)
print v(xbgr.mr_n70263488)
print v(xbgr.mr_n70263600)
print v(xbgr.mr_n70263920)
print v(xbgr.mr_n70264032)
print v(xbgr.mr_n70264352)
print v(xbgr.mr_n70264464)
print v(xbgr.mr_n70264784)
print v(xbgr.mr_n70264896)
print v(xbgr.mr_n70265216)
print v(xbgr.mr_n70265328)
print v(xbgr.mr_n70265648)
print v(xbgr.mr_n70265760)
print v(xbgr.mr_n70266080)
print v(xbgr.mr_n70266192)
print v(xbgr.mr_n70266512)
print v(xbgr.mr_n70266624)
print v(xbgr.mr_n70266944)
print v(xbgr.mr_n70267056)
print v(xbgr.mr_n70267376)
print v(xbgr.mr_n70267488)
print v(xbgr.mr_n70267808)
print v(xbgr.mr_n70267920)
print v(xbgr.mr_n70268240)
print v(xbgr.mr_n70268352)
print v(xbgr.mr_n70268672)
print v(xbgr.mr_n70268784)
print v(xbgr.mr_n70269104)
print v(xbgr.mr_n70269216)
print v(xbgr.mr_n70269536)
print v(xbgr.mr_n70269648)
print v(xbgr.mr_n70269968)
print v(xbgr.mr_n70270080)
print v(xbgr.mr_n70270400)
print v(xbgr.mr_n70270512)
print v(xbgr.mr_n70270832)
print v(xbgr.mr_n70270944)
print v(xbgr.mr_n70271264)
print v(xbgr.mr_n70271376)
print v(xbgr.mr_n70271696)
print v(xbgr.mr_n70271808)
print v(xbgr.mr_n70272128)
print v(xbgr.mr_n70272240)
print v(xbgr.mr_n70272560)
print v(xbgr.mr_n70272672)
print v(xbgr.mr_n70272992)
print v(xbgr.mr_n70273104)
print v(xbgr.mr_n70273424)
print v(xbgr.mr_n70273536)
print v(xbgr.mr_n70273856)
print v(xbgr.mr_n70273968)
print v(xbgr.mr_n70274288)
print v(xbgr.mr_n70274400)
print v(xbgr.mr_n70274720)
print v(xbgr.mr_n70274832)
print v(xbgr.mr_n70275152)
print v(xbgr.mr_n70275264)
print v(xbgr.mr_n70275584)
print v(xbgr.mr_n70275696)
print v(xbgr.mr_n70276016)
print v(xbgr.mr_n70276128)
print v(xbgr.mr_n70276448)
print v(xbgr.mr_n70276560)
print v(xbgr.mr_n70276880)
print v(xbgr.mr_n70276992)
print v(xbgr.mr_n70277312)
print v(xbgr.mr_n70277424)
print v(xbgr.mr_n70277744)
print v(xbgr.mr_n70277856)
print v(xbgr.mr_n70278176)
print v(xbgr.mr_n70278288)
print v(xbgr.mr_n70278608)
print v(xbgr.mr_n70278720)
print v(xbgr.mr_n70279040)
print v(xbgr.mr_n70279152)
print v(xbgr.mr_n70279472)
print v(xbgr.mr_n70279584)
print v(xbgr.mr_n70279904)
print v(xbgr.mr_n70280016)
print v(xbgr.mr_n70280336)
print v(xbgr.mr_n70280448)
print v(xbgr.mr_n70280768)
print v(xbgr.mr_n70280880)
print v(xbgr.mr_n70281200)
print v(xbgr.mr_n70281312)
print v(xbgr.mr_n70281632)
print v(xbgr.mr_n70281744)
print v(xbgr.mr_n70282064)
print v(xbgr.mr_n70282176)
print v(xbgr.mr_n70282496)
print v(xbgr.mr_n70282608)
print v(xbgr.mr_n70282928)
print v(xbgr.mr_n70283040)
print v(xbgr.mr_n70283360)
print v(xbgr.mr_n70283472)
print v(xbgr.mr_n70283792)
print v(xbgr.mr_n70283904)
print v(xbgr.mr_n70284224)
print v(xbgr.mr_n70284336)
print v(xbgr.mr_n70284656)
print v(xbgr.mr_n70284768)
print v(xbgr.mr_n70285088)
print v(xbgr.mr_n70285200)
print v(xbgr.mr_n70285520)
print v(xbgr.mr_n70285632)
print v(xbgr.mr_n70285952)
print v(xbgr.mr_n70286064)
print v(xbgr.mr_n70286384)
print v(xbgr.mr_n70286496)
print v(xbgr.mr_n70286816)
print v(xbgr.mr_n70286928)
print v(xbgr.mr_n70287248)
print v(xbgr.mr_n70287360)
print v(xbgr.mr_n70287680)
print v(xbgr.mr_n70287792)
print v(xbgr.mr_n70288112)
print v(xbgr.mr_n70288224)
print v(xbgr.mr_n70288544)
print v(xbgr.mr_n70288656)
print v(xbgr.mr_n70288976)
print v(xbgr.mr_n70289088)
print v(xbgr.mr_n70289408)
print v(xbgr.mr_n70289520)
print v(xbgr.mr_n70289840)
print v(xbgr.mr_n70289952)
print v(xbgr.mr_n70290272)
print v(xbgr.mr_n70290384)
print v(xbgr.mr_n70290704)
print v(xbgr.mr_n70290816)
print v(xbgr.mr_n70291136)
print v(xbgr.mr_n70291248)
print v(xbgr.mr_n70291568)
print v(xbgr.mr_n70291680)
print v(xbgr.mr_n70292000)
print v(xbgr.mr_n70292112)
print v(xbgr.mr_n70292432)
print v(xbgr.mr_n70292544)
print v(xbgr.mr_n70292864)
print v(xbgr.mr_n70292976)
print v(xbgr.mr_n70293296)
print v(xbgr.mr_n70293408)
print v(xbgr.mr_n70293728)
print v(xbgr.mr_n70293840)
print v(xbgr.mr_n70294160)
print v(xbgr.mr_n70294272)
print v(xbgr.mr_n70294592)
print v(xbgr.mr_n70294704)
print v(xbgr.mr_n70295024)
print v(xbgr.mr_n70295136)
print v(xbgr.mr_n70295456)
print v(xbgr.mr_n70295568)
print v(xbgr.mr_n70295888)
print v(xbgr.mr_n70296000)
print v(xbgr.mr_n70296320)
print v(xbgr.mr_n70296432)
print v(xbgr.mr_n70296752)
print v(xbgr.mr_n70296864)
print v(xbgr.mr_n70297184)
print v(xbgr.mr_n70297296)
print v(xbgr.mr_n70297616)
print v(xbgr.mr_n70297728)
print v(xbgr.mr_n70298160)
print v(xbgr.mr_n70298592)
print v(xbgr.mr_n70299024)
print v(xbgr.mr_n70299456)
print v(xbgr.mr_n70299888)
print v(xbgr.mr_n70300320)
print v(xbgr.mr_n70300752)
print v(xbgr.mr_n70301184)
print v(xbgr.mr_n70301616)
print v(xbgr.mr_n70302048)
print v(xbgr.mr_n70302480)
print v(xbgr.mr_n70302912)
print v(xbgr.mr_n70303344)
print v(xbgr.mr_n70303776)
print v(xbgr.mr_n70304208)
print v(xbgr.mr_n70304640)
print v(xbgr.mr_n70305072)
print v(xbgr.mr_n70305504)
print v(xbgr.mr_n70305936)
print v(xbgr.mr_n70306368)
print v(xbgr.mr_n70306800)
print v(xbgr.mr_n70307232)
print v(xbgr.mr_n70307664)
print v(xbgr.mr_n70308096)
print v(xbgr.mr_n70308528)
print v(xbgr.mr_n70308960)
print v(xbgr.mr_n70309392)
print v(xbgr.mr_n70309824)
print v(xbgr.mr_n70310256)
print v(xbgr.mr_n70310688)
print v(xbgr.mr_n70311120)
print v(xbgr.mr_n70311552)
print v(xbgr.mr_n70311984)
print v(xbgr.mr_n70312416)
print v(xbgr.mr_n70312848)
print v(xbgr.mr_n70313280)
print v(xbgr.mr_n70313712)
print v(xbgr.mr_n70314144)
print v(xbgr.mr_n70314576)
print v(xbgr.mr_n70315008)
print v(xbgr.mr_n70315440)
print v(xbgr.mr_n70315872)
print v(xbgr.mr_n70316304)
print v(xbgr.mr_n70316736)
print v(xbgr.mr_n70317168)
print v(xbgr.mr_n70317600)
print v(xbgr.mr_n70318032)
print v(xbgr.mr_n70318464)
print v(xbgr.mr_n70318896)
print v(xbgr.mr_n70319328)
print v(xbgr.mr_n70319760)
print v(xbgr.mr_n70320192)
print v(xbgr.mr_n70320624)
print v(xbgr.mr_n70321056)
print v(xbgr.mr_n70321488)
print v(xbgr.mr_n70321920)
print v(xbgr.mr_n70322352)
print v(xbgr.mr_n70322784)
print v(xbgr.mr_n70323216)
print v(xbgr.mr_n70323648)
print v(xbgr.mr_n70324080)
print v(xbgr.mr_n70324512)
print v(xbgr.mr_n70324944)
print v(xbgr.mr_n70325376)
print v(xbgr.mr_n70325808)
print v(xbgr.mr_n70326240)
print v(xbgr.mr_n70326672)
print v(xbgr.mr_n70327104)
print v(xbgr.mr_n70327536)
print v(xbgr.mr_n70327968)
print v(xbgr.mr_n70328400)
print v(xbgr.mr_n70328832)
print v(xbgr.mr_n70329264)
print v(xbgr.mr_n70329696)
print v(xbgr.mr_n70330128)
print v(xbgr.mr_n70330560)
print v(xbgr.mr_n70330992)
print v(xbgr.mr_n70331424)
print v(xbgr.mr_n70331856)
print v(xbgr.mr_n70332288)
print v(xbgr.mr_n70332720)
print v(xbgr.mr_n70333152)
print v(xbgr.mr_n70333584)
print v(xbgr.mr_n70334016)
print v(xbgr.mr_n70334448)
print v(xbgr.mr_n70334880)
print v(xbgr.mr_n70335312)
print v(xbgr.mr_n70335744)
print v(xbgr.mr_n70336176)
print v(xbgr.mr_n70336608)
print v(xbgr.mr_n70337040)
print v(xbgr.mr_n70337472)
print v(xbgr.mr_n70337904)
print v(xbgr.mr_n70338336)
print v(xbgr.mr_n70338768)
print v(xbgr.mr_n70339200)
print v(xbgr.mr_n70339632)
print v(xbgr.mr_n70340064)
print v(xbgr.mr_n70340496)
print v(xbgr.mr_n70340928)
print v(xbgr.mr_n70341360)
print v(xbgr.mr_n70341792)
print v(xbgr.mr_n70342224)
print v(xbgr.mr_n70342656)
print v(xbgr.mr_n70343088)
print v(xbgr.mr_n70343520)
print v(xbgr.mr_n70343952)
print v(xbgr.mr_n70344384)
print v(xbgr.mr_n70344816)
print v(xbgr.mr_n70345248)
print v(xbgr.mr_n70345680)
print v(xbgr.mr_n70346112)
print v(xbgr.mr_n70346544)
print v(xbgr.mr_n70346976)
print v(xbgr.mr_n70347408)
print v(xbgr.mr_n70347840)
print v(xbgr.mr_n70348272)
print v(xbgr.mr_n70348704)
print v(xbgr.mr_n70349136)
print v(xbgr.mr_n70349568)
print v(xbgr.mr_n70350000)
print v(xbgr.mr_n70350432)
print v(xbgr.mr_n70350864)
print v(xbgr.mr_n70351296)
print v(xbgr.mr_n70351728)
print v(xbgr.mr_n70352160)
print v(xbgr.mr_n70352592)
print v(xbgr.mr_n70353024)
print v(xbgr.mr_n70353456)
print v(xbgr.mr_n70353888)
print v(xbgr.mr_n70354320)
print v(xbgr.mr_n70354752)
print v(xbgr.mr_n70355184)
print v(xbgr.mr_n70355616)
print v(xbgr.mr_n70356048)
print v(xbgr.mr_n70356480)
print v(xbgr.mr_n70356912)
print v(xbgr.mr_n70357344)
print v(xbgr.mr_n70357776)
print v(xbgr.mr_n70358208)
print v(xbgr.mr_n70358640)
print v(xbgr.mr_n70359072)
print v(xbgr.mr_n70359504)
print v(xbgr.mr_n70359936)
print v(xbgr.mr_n70360368)
print v(xbgr.mr_n70360800)
print v(xbgr.mr_n70361232)
print v(xbgr.mr_n70361664)
print v(xbgr.mr_n70362096)
print v(xbgr.mr_n70362528)
print v(xbgr.mr_n70362960)
print v(xbgr.mr_n70363392)
print v(xbgr.mr_n70363824)
print v(xbgr.mr_n70364256)
print v(xbgr.mr_n70364688)
print v(xbgr.mr_n70365120)
print v(xbgr.mr_n70365552)
print v(xbgr.mr_n70365984)
print v(xbgr.mr_n70366416)
print v(xbgr.mr_n70366848)
print v(xbgr.mr_n70367280)
print v(xbgr.mr_n70367712)
print v(xbgr.mr_n70368144)
print v(xbgr.mr_n70368576)
print v(xbgr.mr_n70369008)
print v(xbgr.mr_n70369440)
print v(xbgr.mr_n70369872)
print v(xbgr.mr_n70370304)
print v(xbgr.mr_n70370736)
print v(xbgr.mr_n70371168)
print v(xbgr.mr_n70371600)
print v(xbgr.mr_n70372032)
print v(xbgr.mr_n70372464)
print v(xbgr.mr_n70372896)
print v(xbgr.mr_n70373328)
print v(xbgr.mr_n70373760)
print v(xbgr.mr_n70374192)
print v(xbgr.mr_n70374624)
print v(xbgr.mr_n70375056)
print v(xbgr.mr_n70375488)
print v(xbgr.mr_n70375920)
print v(xbgr.mr_n70376352)
print v(xbgr.mr_n70376784)
print v(xbgr.mr_n70377216)
print v(xbgr.mr_n70377648)
print v(xbgr.mr_n70378080)
print v(xbgr.mr_n70378512)
print v(xbgr.mr_n70378944)
print v(xbgr.mr_n70379376)
print v(xbgr.mr_n70379808)
print v(xbgr.mr_n70380240)
print v(xbgr.mr_n70380672)
print v(xbgr.mr_n70381104)
print v(xbgr.mr_n70381536)
print v(xbgr.mr_n70381968)
print v(xbgr.mr_n70382400)
print v(xbgr.mr_n70382832)
print v(xbgr.mr_n70383264)
print v(xbgr.mr_n70383696)
print v(xbgr.mr_n70384128)
print v(xbgr.mr_n70384560)
print v(xbgr.mr_n70384992)
print v(xbgr.mr_n70385424)
print v(xbgr.mr_n70385856)
print v(xbgr.mr_n70386288)
print v(xbgr.mr_n70386720)
print v(xbgr.mr_n70387152)
print v(xbgr.mr_n70387584)
print v(xbgr.mr_n70388016)
print v(xbgr.mr_n70388448)
print v(xbgr.mr_n70388880)
print v(xbgr.mr_n70389312)
print v(xbgr.mr_n70389744)
print v(xbgr.mr_n70390176)
print v(xbgr.mr_n70390496)
print v(xbgr.mr_n70390608)
print v(xbgr.mr_n70390928)
print v(xbgr.mr_n70391040)
print v(xbgr.mr_n70391360)
print v(xbgr.mr_n70391472)
print v(xbgr.mr_n70391792)
print v(xbgr.mr_n70391904)
print v(xbgr.mr_n70392224)
print v(xbgr.mr_n70392336)
print v(xbgr.mr_n70392656)
print v(xbgr.mr_n70392768)
print v(xbgr.mr_n70393088)
print v(xbgr.mr_n70393200)
print v(xbgr.mr_n70393520)
print v(xbgr.mr_n70393632)
print v(xbgr.mr_n70393952)
print v(xbgr.mr_n70394064)
print v(xbgr.mr_n70394384)
print v(xbgr.mr_n70394496)
print v(xbgr.mr_n70394816)
print v(xbgr.mr_n70394928)
print v(xbgr.mr_n70395248)
print v(xbgr.mr_n70395360)
print v(xbgr.mr_n70395680)
print v(xbgr.mr_n70395792)
print v(xbgr.mr_n70396112)
print v(xbgr.mr_n70396224)
print v(xbgr.mr_n70396544)
print v(xbgr.mr_n70396656)
print v(xbgr.mr_n70396976)
print v(xbgr.mr_n70397088)
print v(xbgr.mr_n70397408)
print v(xbgr.mr_n70397520)
print v(xbgr.mr_n70397840)
print v(xbgr.mr_n70397952)
print v(xbgr.mr_n70398272)
print v(xbgr.mr_n70398384)
print v(xbgr.mr_n70398704)
print v(xbgr.mr_n70398816)
print v(xbgr.mr_n70399136)
print v(xbgr.mr_n70399248)
print v(xbgr.mr_n70399568)
print v(xbgr.mr_n70399680)
print v(xbgr.mr_n70400000)
print v(xbgr.mr_n70400112)
print v(xbgr.mr_n70400432)
print v(xbgr.mr_n70400544)
print v(xbgr.mr_n70400864)
print v(xbgr.mr_n70400976)
print v(xbgr.mr_n70401296)
print v(xbgr.mr_n70401408)
print v(xbgr.mr_n70401728)
print v(xbgr.mr_n70401840)
print v(xbgr.mr_n70402160)
print v(xbgr.mr_n70402272)
print v(xbgr.mr_n70402592)
print v(xbgr.mr_n70402704)
print v(xbgr.mr_n70403024)
print v(xbgr.mr_n70403136)
print v(xbgr.mr_n70403456)
print v(xbgr.mr_n70403568)
print v(xbgr.mr_n70403888)
print v(xbgr.mr_n70404000)
print v(xbgr.mr_n70404320)
print v(xbgr.mr_n70404432)
print v(xbgr.mr_n70404752)
print v(xbgr.mr_n70404864)
print v(xbgr.mr_n70405184)
print v(xbgr.mr_n70405296)
print v(xbgr.mr_n70405616)
print v(xbgr.mr_n70405728)
print v(xbgr.mr_n70406048)
print v(xbgr.mr_n70406160)
print v(xbgr.mr_n70406480)
print v(xbgr.mr_n70406592)
print v(xbgr.mr_n70406912)
print v(xbgr.mr_n70407024)
print v(xbgr.mr_n70407344)
print v(xbgr.mr_n70407456)
print v(xbgr.mr_n70407776)
print v(xbgr.mr_n70407888)
print v(xbgr.mr_n70408208)
print v(xbgr.mr_n70408320)
print v(xbgr.mr_n70408640)
print v(xbgr.mr_n70408752)
print v(xbgr.mr_n70409072)
print v(xbgr.mr_n70409184)
print v(xbgr.mr_n70409504)
print v(xbgr.mr_n70409616)
print v(xbgr.mr_n70409936)
print v(xbgr.mr_n70410048)
print v(xbgr.mr_n70410368)
print v(xbgr.mr_n70410480)
print v(xbgr.mr_n70410800)
print v(xbgr.mr_n70410912)
print v(xbgr.mr_n70411232)
print v(xbgr.mr_n70411344)
print v(xbgr.mr_n70411664)
print v(xbgr.mr_n70411776)
print v(xbgr.mr_n70412096)
print v(xbgr.mr_n70412208)
print v(xbgr.mr_n70412528)
print v(xbgr.mr_n70412640)
print v(xbgr.mr_n70412960)
print v(xbgr.mr_n70413072)
print v(xbgr.mr_n70413392)
print v(xbgr.mr_n70413504)
print v(xbgr.mr_n70413824)
print v(xbgr.mr_n70413936)
print v(xbgr.mr_n70414256)
print v(xbgr.mr_n70414368)
print v(xbgr.mr_n70414688)
print v(xbgr.mr_n70414800)
print v(xbgr.mr_n70415120)
print v(xbgr.mr_n70415232)
print v(xbgr.mr_n70415552)
print v(xbgr.mr_n70415664)
print v(xbgr.mr_n70415984)
print v(xbgr.mr_n70416096)
print v(xbgr.mr_n70416416)
print v(xbgr.mr_n70416528)
print v(xbgr.mr_n70416848)
print v(xbgr.mr_n70416960)
print v(xbgr.mr_n70417280)
print v(xbgr.mr_n70417392)
print v(xbgr.mr_n70417712)
print v(xbgr.mr_n70417824)
print v(xbgr.mr_n70418144)
print v(xbgr.mr_n70418256)
print v(xbgr.mr_n70418576)
print v(xbgr.mr_n70418688)
print v(xbgr.mr_n70419008)
print v(xbgr.mr_n70419120)
print v(xbgr.mr_n70419440)
print v(xbgr.mr_n70419552)
print v(xbgr.mr_n70419872)
print v(xbgr.mr_n70419984)
print v(xbgr.mr_n70420304)
print v(xbgr.mr_n70420416)
print v(xbgr.mr_n70420736)
print v(xbgr.mr_n70420848)
print v(xbgr.mr_n70421168)
print v(xbgr.mr_n70421280)
print v(xbgr.mr_n70421600)
print v(xbgr.mr_n70421712)
print v(xbgr.mr_n70422032)
print v(xbgr.mr_n70422144)
print v(xbgr.mr_n70422464)
print v(xbgr.mr_n70422576)
print v(xbgr.mr_n70422896)
print v(xbgr.mr_n70423008)
print v(xbgr.mr_n70423328)
print v(xbgr.mr_n70423440)
print v(xbgr.mr_n70423760)
print v(xbgr.mr_n70423872)
print v(xbgr.mr_n70424192)
print v(xbgr.mr_n70424304)
print v(xbgr.mr_n70424624)
print v(xbgr.mr_n70424736)
print v(xbgr.mr_n70425056)
print v(xbgr.mr_n70425168)
print v(xbgr.mr_n70425488)
print v(xbgr.mr_n70425600)
print v(xbgr.mr_n70425920)
print v(xbgr.mr_n70426032)
print v(xbgr.mr_n70426352)
print v(xbgr.mr_n70426464)
print v(xbgr.mr_n70426784)
print v(xbgr.mr_n70426896)
print v(xbgr.mr_n70427216)
print v(xbgr.mr_n70427328)
print v(xbgr.mr_n70427648)
print v(xbgr.mr_n70427760)
print v(xbgr.mr_n70428080)
print v(xbgr.mr_n70428192)
print v(xbgr.mr_n70428512)
print v(xbgr.mr_n70428624)
print v(xbgr.mr_n70428944)
print v(xbgr.mr_n70429056)
print v(xbgr.mr_n70429376)
print v(xbgr.mr_n70429488)
print v(xbgr.mr_n70429808)
print v(xbgr.mr_n70429920)
print v(xbgr.mr_n70430240)
print v(xbgr.mr_n70430352)
print v(xbgr.mr_n70430672)
print v(xbgr.mr_n70430784)
print v(xbgr.mr_n70431104)
print v(xbgr.mr_n70431216)
print v(xbgr.mr_n70431536)
print v(xbgr.mr_n70431648)
print v(xbgr.mr_n70431968)
print v(xbgr.mr_n70432080)
print v(xbgr.mr_n70432400)
print v(xbgr.mr_n70432512)
print v(xbgr.mr_n70432832)
print v(xbgr.mr_n70432944)
print v(xbgr.mr_n70433264)
print v(xbgr.mr_n70433376)
print v(xbgr.mr_n70433696)
print v(xbgr.mr_n70433808)
print v(xbgr.mr_n70434128)
print v(xbgr.mr_n70434240)
print v(xbgr.mr_n70434560)
print v(xbgr.mr_n70434672)
print v(xbgr.mr_n70434992)
print v(xbgr.mr_n70435104)
print v(xbgr.mr_n70435424)
print v(xbgr.mr_n70435536)
print v(xbgr.mr_n70435856)
print v(xbgr.mr_n70435968)
print v(xbgr.mr_n70436288)
print v(xbgr.mr_n70436400)
print v(xbgr.mr_n70436720)
print v(xbgr.mr_n70436832)
print v(xbgr.mr_n70437152)
print v(xbgr.mr_n70437264)
print v(xbgr.mr_n70437584)
print v(xbgr.mr_n70437696)
print v(xbgr.mr_n70438016)
print v(xbgr.mr_n70438128)
print v(xbgr.mr_n70438448)
print v(xbgr.mr_n70438560)
print v(xbgr.mr_n70438880)
print v(xbgr.mr_n70438992)
print v(xbgr.mr_n70439312)
print v(xbgr.mr_n70439424)
print v(xbgr.mr_n70439744)
print v(xbgr.mr_n70439856)
print v(xbgr.mr_n70440176)
print v(xbgr.mr_n70440288)
print v(xbgr.mr_n70440608)
print v(xbgr.mr_n70440720)
print v(xbgr.mr_n70441040)
print v(xbgr.mr_n70441152)
print v(xbgr.mr_n70441472)
print v(xbgr.mr_n70441584)
print v(xbgr.mr_n70441904)
print v(xbgr.mr_n70442016)
print v(xbgr.mr_n70442336)
print v(xbgr.mr_n70442448)
print v(xbgr.mr_n70442768)
print v(xbgr.mr_n70442880)
print v(xbgr.mr_n70443200)
print v(xbgr.mr_n70443312)
print v(xbgr.mr_n70443632)
print v(xbgr.mr_n70443744)
print v(xbgr.mr_n70444064)
print v(xbgr.mr_n70444176)
print v(xbgr.mr_n70444496)
print v(xbgr.mr_n70444608)
print v(xbgr.mr_n70444928)
print v(xbgr.mr_n70445040)
print v(xbgr.mr_n70445360)
print v(xbgr.mr_n70445472)
print v(xbgr.mr_n70445792)
print v(xbgr.mr_n70445904)
print v(xbgr.mr_n70446224)
print v(xbgr.mr_n70446336)
print v(xbgr.mr_n70446656)
print v(xbgr.mr_n70446768)
print v(xbgr.mr_n70447088)
print v(xbgr.mr_n70447200)
print v(xbgr.mr_n70447520)
print v(xbgr.mr_n70447632)
print v(xbgr.mr_n70447952)
print v(xbgr.mr_n70448064)
print v(xbgr.mr_n70448384)
print v(xbgr.mr_n70448496)
print v(xbgr.mr_n70448816)
print v(xbgr.mr_n70448928)
print v(xbgr.mr_n70449248)
print v(xbgr.mr_n70449360)
print v(xbgr.mr_n70449680)
print v(xbgr.mr_n70449792)
print v(xbgr.mr_n70450112)
print v(xbgr.mr_n70450224)
print v(xbgr.mr_n70450544)
print v(xbgr.mr_n70450656)
print v(xbgr.mr_n70450976)
print v(xbgr.mr_n70451088)
print v(xbgr.mr_n70451408)
print v(xbgr.mr_n70451520)
print v(xbgr.mr_n70451840)
print v(xbgr.mr_n70451952)
print v(xbgr.mr_n70452272)
print v(xbgr.mr_n70452384)
print v(xbgr.mr_n70452704)
print v(xbgr.mr_n70452816)
print v(xbgr.mr_n70453136)
print v(xbgr.mr_n70453248)
print v(xbgr.mr_n70453568)
print v(xbgr.mr_n70453680)
print v(xbgr.mr_n70454000)
print v(xbgr.mr_n70454112)
print v(xbgr.mr_n70454432)
print v(xbgr.mr_n70454544)
print v(xbgr.mr_n70454864)
print v(xbgr.mr_n70454976)
print v(xbgr.mr_n70455296)
print v(xbgr.mr_n70455408)
print v(xbgr.mr_n70455728)
print v(xbgr.mr_n70455840)
print v(xbgr.mr_n70456160)
print v(xbgr.mr_n70456272)
print v(xbgr.mr_n70456592)
print v(xbgr.mr_n70456704)
print v(xbgr.mr_n70457024)
print v(xbgr.mr_n70457136)
print v(xbgr.mr_n70457456)
print v(xbgr.mr_n70457568)
print v(xbgr.mr_n70457888)
print v(xbgr.mr_n70458000)
print v(xbgr.mr_n70458320)
print v(xbgr.mr_n70458432)
print v(xbgr.mr_n70458752)
print v(xbgr.mr_n70458864)
print v(xbgr.mr_n70459184)
print v(xbgr.mr_n70459296)
print v(xbgr.mr_n70459616)
print v(xbgr.mr_n70459728)
print v(xbgr.mr_n70460048)
print v(xbgr.mr_n70460160)
print v(xbgr.mr_n70460480)
print v(xbgr.mr_n70460592)
print v(xbgr.mr_n70460912)
print v(xbgr.mr_n70461024)
print v(xbgr.mr_n70461344)
print v(xbgr.mr_n70461456)
print v(xbgr.mr_n70461776)
print v(xbgr.mr_n70461888)
print v(xbgr.mr_n70462208)
print v(xbgr.mr_n70462320)
print v(xbgr.mr_n70462640)
print v(xbgr.mr_n70462752)
print v(xbgr.mr_n70463072)
print v(xbgr.mr_n70463184)
print v(xbgr.mr_n70463504)
print v(xbgr.mr_n70463616)
print v(xbgr.mr_n70463936)
print v(xbgr.mr_n70464048)
print v(xbgr.mr_n70464368)
print v(xbgr.mr_n70464480)
print v(xbgr.mr_n70464800)
print v(xbgr.mr_n70464912)
print v(xbgr.mr_n70465232)
print v(xbgr.mr_n70465344)
print v(xbgr.mr_n70465664)
print v(xbgr.mr_n70465776)
print v(xbgr.mr_n70466096)
print v(xbgr.mr_n70466208)
print v(xbgr.mr_n70466528)
print v(xbgr.mr_n70466640)
print v(xbgr.mr_n70466960)
print v(xbgr.mr_n70467072)
print v(xbgr.mr_n70467392)
print v(xbgr.mr_n70467504)
print v(xbgr.mr_n70467824)
print v(xbgr.mr_n70467936)
print v(xbgr.mr_n70468256)
print v(xbgr.mr_n70468368)
print v(xbgr.mr_n70468688)
print v(xbgr.mr_n70468800)
print v(xbgr.mr_n70469120)
print v(xbgr.mr_n70469232)
print v(xbgr.mr_n70469552)
print v(xbgr.mr_n70469664)
print v(xbgr.mr_n70469984)
print v(xbgr.mr_n70470096)
print v(xbgr.mr_n70470416)
print v(xbgr.mr_n70470528)
print v(xbgr.mr_n70470848)
print v(xbgr.mr_n70470960)
print v(xbgr.mr_n70471280)
print v(xbgr.mr_n70471392)
print v(xbgr.mr_n70471712)
print v(xbgr.mr_n70471824)
print v(xbgr.mr_n70472144)
print v(xbgr.mr_n70472256)
print v(xbgr.mr_n70472576)
print v(xbgr.mr_n70472688)
print v(xbgr.mr_n70473008)
print v(xbgr.mr_n70473120)
print v(xbgr.mr_n70473440)
print v(xbgr.mr_n70473552)
print v(xbgr.mr_n70473872)
print v(xbgr.mr_n70473984)
print v(xbgr.mr_n70474304)
print v(xbgr.mr_n70474416)
print v(xbgr.mr_n70474736)
print v(xbgr.mr_n70474848)
print v(xbgr.mr_n70475168)
print v(xbgr.mr_n70475280)
print v(xbgr.mr_n70475600)
print v(xbgr.mr_n70475712)
print v(xbgr.mr_n70476032)
print v(xbgr.mr_n70476144)
print v(xbgr.mr_n70476464)
print v(xbgr.mr_n70476576)
print v(xbgr.mr_n70476896)
print v(xbgr.mr_n70477008)
print v(xbgr.mr_n70477328)
print v(xbgr.mr_n70477440)
print v(xbgr.mr_n70477760)
print v(xbgr.mr_n70477872)
print v(xbgr.mr_n70478192)
print v(xbgr.mr_n70478304)
print v(xbgr.mr_n70478624)
print v(xbgr.mr_n70478736)
print v(xbgr.mr_n70479056)
print v(xbgr.mr_n70479168)
print v(xbgr.mr_n70479488)
print v(xbgr.mr_n70479600)
print v(xbgr.mr_n70479920)
print v(xbgr.mr_n70480032)
print v(xbgr.mr_n70480352)
print v(xbgr.mr_n70480464)
print v(xbgr.mr_n70480784)
print v(xbgr.mr_n70480896)
print v(xbgr.mr_n70481216)
print v(xbgr.mr_n70481328)
print v(xbgr.mr_n70481648)
print v(xbgr.mr_n70481760)
print v(xbgr.mr_n70482080)
print v(xbgr.mr_n70482192)
print v(xbgr.mr_n70482512)
print v(xbgr.mr_n70482624)
print v(xbgr.mr_n70482944)
print v(xbgr.mr_n70483056)
print v(xbgr.mr_n70483376)
print v(xbgr.mr_n70483488)
print v(xbgr.mr_n70483808)
print v(xbgr.mr_n70483920)
print v(xbgr.mr_n70484240)
print v(xbgr.mr_n70484352)
print v(xbgr.mr_n70485216)
print v(xbgr.mr_n70485648)
print v(xbgr.mr_n70486080)
print v(xbgr.mr_n70486512)
print v(xbgr.mr_n70486944)
print v(xbgr.mr_n70487376)
print v(xbgr.mr_n70487808)
print v(xbgr.mr_n70488240)
print v(xbgr.mr_n70488672)
print v(xbgr.mr_n70489104)
print v(xbgr.mr_n70489536)
print v(xbgr.mr_n70489968)
print v(xbgr.mr_n70490400)
print v(xbgr.mr_n70490832)
print v(xbgr.mr_n70491264)
print v(xbgr.mr_n70491696)
print v(xbgr.mr_n70492128)
print v(xbgr.mr_n70492560)
print v(xbgr.mr_n70492992)
print v(xbgr.mr_n70493424)
print v(xbgr.mr_n70493856)
print v(xbgr.mr_n70494288)
print v(xbgr.mr_n70494720)
print v(xbgr.mr_n70495152)
print v(xbgr.mr_n70497312)
print v(xbgr.mr_n70497744)
print v(xbgr.mr_n70498176)
print v(xbgr.mr_n70498608)
print v(xbgr.mr_n70499040)
print v(xbgr.mr_n70499472)
print v(xbgr.mr_n70499904)
print v(xbgr.mr_n70500336)
print v(xbgr.mr_n70500768)
print v(xbgr.mr_n70501200)
print v(xbgr.mr_n70501632)
print v(xbgr.mr_n70502064)
print v(xbgr.mr_n70502496)
print v(xbgr.mr_n70502928)
print v(xbgr.mr_n70503360)
print v(xbgr.mr_n70503792)
print v(xbgr.mr_n70504224)
print v(xbgr.mr_n70504656)
print v(xbgr.mr_n70505088)
print v(xbgr.mr_n70505520)
print v(xbgr.mr_n70505952)
print v(xbgr.mr_n70506384)
print v(xbgr.mr_n70506816)
print v(xbgr.mr_n70507248)
print v(xbgr.mr_n70511136)
print v(xbgr.mr_n70511568)
print v(xbgr.mr_n70512000)
print v(xbgr.mr_n70512432)
print v(xbgr.mr_n70512864)
print v(xbgr.mr_n70513296)
print v(xbgr.mr_n70513728)
print v(xbgr.mr_n70514160)
print v(xbgr.mr_n70514592)
print v(xbgr.mr_n70515024)
print v(xbgr.mr_n70515456)
print v(xbgr.mr_n70515888)
print v(xbgr.mr_n70516320)
print v(xbgr.mr_n70516752)
print v(xbgr.mr_n70517184)
print v(xbgr.mr_n70518480)
print v(xbgr.mr_n70518912)
print v(xbgr.mr_n70519344)
print v(xbgr.mr_n70519776)
print v(xbgr.mr_n70520208)
print v(xbgr.mr_n70520640)
print v(xbgr.mr_n70521072)
print v(xbgr.mr_n70521504)
print v(xbgr.mr_n70521936)
print v(xbgr.mr_n70522368)
print v(xbgr.mr_n70523664)
print v(xbgr.mr_n70524096)
print v(xbgr.mr_n70524528)
print v(xbgr.mr_n70524960)
print v(xbgr.mr_n70525392)
print v(xbgr.mr_n70525824)
print v(xbgr.mr_n70526256)
print v(xbgr.mr_n70526688)
print v(xbgr.mr_n70527008)
print v(xbgr.mr_n70527120)
print v(xbgr.mr_n70527440)
print v(xbgr.mr_n70527552)
print v(xbgr.mr_n70527872)
print v(xbgr.mr_n70527984)
print v(xbgr.mr_n70528304)
print v(xbgr.mr_n70528416)
print v(xbgr.mr_n70528736)
print v(xbgr.mr_n70528848)
print v(xbgr.mr_n70529168)
print v(xbgr.mr_n70529280)
print v(xbgr.mr_n70529600)
print v(xbgr.mr_n70529712)
print v(xbgr.mr_n70530032)
print v(xbgr.mr_n70530144)
print v(xbgr.mr_n70530464)
print v(xbgr.mr_n70530576)
print v(xbgr.mr_n70530896)
print v(xbgr.mr_n70531008)
print v(xbgr.mr_n70531328)
print v(xbgr.mr_n70531440)
print v(xbgr.mr_n70531760)
print v(xbgr.mr_n70531872)
print v(xbgr.mr_n70532192)
print v(xbgr.mr_n70532304)
print v(xbgr.mr_n70532624)
print v(xbgr.mr_n70532736)
print v(xbgr.mr_n70533056)
print v(xbgr.mr_n70533168)
print v(xbgr.mr_n70533488)
print v(xbgr.mr_n70533600)
print v(xbgr.mr_n70533920)
print v(xbgr.mr_n70534032)
print v(xbgr.mr_n70534352)
print v(xbgr.mr_n70534464)
print v(xbgr.mr_n70534784)
print v(xbgr.mr_n70534896)
print v(xbgr.mr_n70535216)
print v(xbgr.mr_n70535328)
print v(xbgr.mr_n70535648)
print v(xbgr.mr_n70535760)
print v(xbgr.mr_n70536080)
print v(xbgr.mr_n70536192)
print v(xbgr.mr_n70536512)
print v(xbgr.mr_n70536624)
print v(xbgr.mr_n70536944)
print v(xbgr.mr_n70537056)
print v(xbgr.mr_n70537376)
print v(xbgr.mr_n70537488)
print v(xbgr.mr_n70537808)
print v(xbgr.mr_n70537920)
print v(xbgr.mr_n70538240)
print v(xbgr.mr_n70538352)
print v(xbgr.mr_n70538672)
print v(xbgr.mr_n70538784)
print v(xbgr.mr_n70539104)
print v(xbgr.mr_n70539216)
print v(xbgr.mr_n70539536)
print v(xbgr.mr_n70539648)
print v(xbgr.mr_n70539968)
print v(xbgr.mr_n70540080)
print v(xbgr.mr_n70540400)
print v(xbgr.mr_n70540512)
print v(xbgr.mr_n70540832)
print v(xbgr.mr_n70540944)
print v(xbgr.mr_n70541264)
print v(xbgr.mr_n70541376)
print v(xbgr.mr_n70541696)
print v(xbgr.mr_n70541808)
print v(xbgr.mr_n70542128)
print v(xbgr.mr_n70542240)
print v(xbgr.mr_n70542560)
print v(xbgr.mr_n70542672)
print v(xbgr.mr_n70542992)
print v(xbgr.mr_n70543104)
print v(xbgr.mr_n70543424)
print v(xbgr.mr_n70543536)
print v(xbgr.mr_n70543856)
print v(xbgr.mr_n70543968)
print v(xbgr.mr_n70544288)
print v(xbgr.mr_n70544400)
print v(xbgr.mr_n70544720)
print v(xbgr.mr_n70544832)
print v(xbgr.mr_n70545152)
print v(xbgr.mr_n70545264)
print v(xbgr.mr_n70545584)
print v(xbgr.mr_n70545696)
print v(xbgr.mr_n70546016)
print v(xbgr.mr_n70546128)
print v(xbgr.mr_n70546448)
print v(xbgr.mr_n70546560)
print v(xbgr.mr_n70546880)
print v(xbgr.mr_n70546992)
print v(xbgr.mr_n70547312)
print v(xbgr.mr_n70547424)
print v(xbgr.mr_n70547744)
print v(xbgr.mr_n70547856)
print v(xbgr.mr_n70548176)
print v(xbgr.mr_n70548288)
print v(xbgr.mr_n70548608)
print v(xbgr.mr_n70548720)
print v(xbgr.mr_n70549040)
print v(xbgr.mr_n70549152)
print v(xbgr.mr_n70549472)
print v(xbgr.mr_n70549584)
print v(xbgr.mr_n70549904)
print v(xbgr.mr_n70550016)
print v(xbgr.mr_n70550336)
print v(xbgr.mr_n70550448)
print v(xbgr.mr_n70550768)
print v(xbgr.mr_n70550880)
print v(xbgr.mr_n70551200)
print v(xbgr.mr_n70551312)
print v(xbgr.mr_n70551632)
print v(xbgr.mr_n70551744)
print v(xbgr.mr_n70552064)
print v(xbgr.mr_n70552176)
print v(xbgr.mr_n70552496)
print v(xbgr.mr_n70552608)
print v(xbgr.mr_n70552928)
print v(xbgr.mr_n70553040)
print v(xbgr.mr_n70553360)
print v(xbgr.mr_n70553472)
print v(xbgr.mr_n70553792)
print v(xbgr.mr_n70553904)
print v(xbgr.mr_n70554224)
print v(xbgr.mr_n70554336)
print v(xbgr.mr_n70554656)
print v(xbgr.mr_n70554768)
print v(xbgr.mr_n70555088)
print v(xbgr.mr_n70555200)
print v(xbgr.mr_n70555520)
print v(xbgr.mr_n70555632)
print v(xbgr.mr_n70555952)
print v(xbgr.mr_n70556064)
print v(xbgr.mr_n70556384)
print v(xbgr.mr_n70556496)
print v(xbgr.mr_n70556816)
print v(xbgr.mr_n70556928)
print v(xbgr.mr_n70557248)
print v(xbgr.mr_n70557360)
print v(xbgr.mr_n70557680)
print v(xbgr.mr_n70557792)
print v(xbgr.mr_n70558112)
print v(xbgr.mr_n70558224)
print v(xbgr.mr_n70558544)
print v(xbgr.mr_n70558656)
print v(xbgr.mr_n70558976)
print v(xbgr.mr_n70559088)
print v(xbgr.mr_n70559408)
print v(xbgr.mr_n70559520)
print v(xbgr.mr_n70559840)
print v(xbgr.mr_n70559952)
print v(xbgr.mr_n70560272)
print v(xbgr.mr_n70560384)
print v(xbgr.mr_n70560704)
print v(xbgr.mr_n70560816)
print v(xbgr.mr_n70561136)
print v(xbgr.mr_n70561248)
print v(xbgr.mr_n70561568)
print v(xbgr.mr_n70561680)
print v(xbgr.mr_n70562000)
print v(xbgr.mr_n70562112)
print v(xbgr.mr_n70562432)
print v(xbgr.mr_n70562544)
print v(xbgr.mr_n70562864)
print v(xbgr.mr_n70562976)
print v(xbgr.mr_n70563296)
print v(xbgr.mr_n70563408)
print v(xbgr.mr_n70563728)
print v(xbgr.mr_n70563840)
print v(xbgr.mr_n70564160)
print v(xbgr.mr_n70564272)
print v(xbgr.mr_n70564592)
print v(xbgr.mr_n70564704)
print v(xbgr.mr_n70565024)
print v(xbgr.mr_n70565136)
print v(xbgr.mr_n70565456)
print v(xbgr.mr_n70565568)
print v(xbgr.mr_n70565888)
print v(xbgr.mr_n70566000)
print v(xbgr.mr_n70566320)
print v(xbgr.mr_n70566432)
print v(xbgr.mr_n70566752)
print v(xbgr.mr_n70566864)
print v(xbgr.mr_n70567184)
print v(xbgr.mr_n70567296)
print v(xbgr.mr_n70567616)
print v(xbgr.mr_n70567728)
print v(xbgr.mr_n70568048)
print v(xbgr.mr_n70568160)
print v(xbgr.mr_n70568480)
print v(xbgr.mr_n70568592)
print v(xbgr.mr_n70568912)
print v(xbgr.mr_n70569024)
print v(xbgr.mr_n70569344)
print v(xbgr.mr_n70569456)
print v(xbgr.mr_n70569776)
print v(xbgr.mr_n70569888)
print v(xbgr.mr_n70570208)
print v(xbgr.mr_n70570320)
print v(xbgr.mr_n70570640)
print v(xbgr.mr_n70570752)
print v(xbgr.mr_n70571072)
print v(xbgr.mr_n70571184)
print v(xbgr.mr_n70571504)
print v(xbgr.mr_n70571616)
print v(xbgr.mr_n70571936)
print v(xbgr.mr_n70572048)
print v(xbgr.mr_n70572368)
print v(xbgr.mr_n70572480)
print v(xbgr.mr_n70572800)
print v(xbgr.mr_n70572912)
print v(xbgr.mr_n70573232)
print v(xbgr.mr_n70573344)
print v(xbgr.mr_n70573664)
print v(xbgr.mr_n70574096)
print v(xbgr.mr_n70574208)
print v(xbgr.mr_n70574528)
print v(xbgr.mr_n70574640)
print v(xbgr.mr_n70574960)
print v(xbgr.mr_n70575072)
print v(xbgr.mr_n70575392)
print v(xbgr.mr_n70575504)
print v(xbgr.mr_n70575824)
print v(xbgr.mr_n70575936)
print v(xbgr.mr_n70576256)
print v(xbgr.mr_n70576368)
print v(xbgr.mr_n70576688)
print v(xbgr.mr_n70576800)
print v(xbgr.mr_n70577120)
print v(xbgr.mr_n70577232)
print v(xbgr.mr_n70577552)
print v(xbgr.mr_n70577664)
print v(xbgr.mr_n70577984)
print v(xbgr.mr_n70578096)
print v(xbgr.mr_n70578416)
print v(xbgr.mr_n70578528)
print v(xbgr.mr_n70578848)
print v(xbgr.mr_n70578960)
print v(xbgr.mr_n70579280)
print v(xbgr.mr_n70579392)
print v(xbgr.mr_n70579712)
print v(xbgr.mr_n70579824)
print v(xbgr.mr_n70580144)
print v(xbgr.mr_n70580256)
print v(xbgr.mr_n70580576)
print v(xbgr.mr_n70580688)
print v(xbgr.mr_n70581008)
print v(xbgr.mr_n70581120)
print v(xbgr.mr_n70581440)
print v(xbgr.mr_n70581552)
print v(xbgr.mr_n70581872)
print v(xbgr.mr_n70581984)
print v(xbgr.mr_n70582304)
print v(xbgr.mr_n70582416)
print v(xbgr.mr_n70582736)
print v(xbgr.mr_n70582848)
print v(xbgr.mr_n70583168)
print v(xbgr.mr_n70583280)
print v(xbgr.mr_n70583600)
print v(xbgr.mr_n70583712)
print v(xbgr.mr_n70584032)
print v(xbgr.mr_n70584144)
print v(xbgr.mr_n70584464)
print v(xbgr.mr_n70584576)
print v(xbgr.mr_n70584896)
print v(xbgr.mr_n70585008)
print v(xbgr.mr_n70585328)
print v(xbgr.mr_n70585440)
print v(xbgr.mr_n70585760)
print v(xbgr.mr_n70585872)
print v(xbgr.mr_n70586192)
print v(xbgr.mr_n70586304)
print v(xbgr.mr_n70586624)
print v(xbgr.mr_n70586736)
print v(xbgr.mr_n70587056)
print v(xbgr.mr_n70587168)
print v(xbgr.mr_n70587488)
print v(xbgr.mr_n70587600)
print v(xbgr.mr_n70587920)
print v(xbgr.mr_n70588032)
print v(xbgr.mr_n70588352)
print v(xbgr.mr_n70588464)
print v(xbgr.mr_n70588784)
print v(xbgr.mr_n70588896)
print v(xbgr.mr_n70589216)
print v(xbgr.mr_n70589648)
print v(xbgr.mr_n70589760)
print v(xbgr.mr_n70590080)
print v(xbgr.mr_n70590192)
print v(xbgr.mr_n70590512)
print v(xbgr.mr_n70590624)
print v(xbgr.mr_n70590944)
print v(xbgr.mr_n70591376)
print v(xbgr.mr_n70591488)
print v(xbgr.mr_n70591808)
print v(xbgr.mr_n70591920)
print v(xbgr.mr_n70592240)
print v(xbgr.mr_n70592352)
print v(xbgr.mr_n70592672)
print v(xbgr.mr_n70593104)
print v(xbgr.mr_n70593216)
print v(xbgr.mr_n70593536)
print v(xbgr.mr_n70593648)
print v(xbgr.mr_n70593968)
print v(xbgr.mr_n70594080)
print v(xbgr.mr_n70594400)
print v(xbgr.mr_n70594512)
print v(xbgr.mr_n70594832)
print v(xbgr.mr_n70594944)
print v(xbgr.mr_n70595264)
print v(xbgr.mr_n70595376)
print v(xbgr.mr_n70595696)
print v(xbgr.mr_n70595808)
print v(xbgr.mr_n70596128)
print v(xbgr.mr_n70596240)
print v(xbgr.mr_n70596560)
print v(xbgr.mr_n70596672)
print v(xbgr.mr_n70596992)
print v(xbgr.mr_n70597104)
print v(xbgr.mr_n70597424)
print v(xbgr.mr_n70597536)
print v(xbgr.mr_n70597856)
print v(xbgr.mr_n70597968)
print v(xbgr.mr_n70598288)
print v(xbgr.mr_n70598400)
print v(xbgr.mr_n70598720)
print v(xbgr.mr_n70598832)
print v(xbgr.mr_n70599152)
print v(xbgr.mr_n70599264)
print v(xbgr.mr_n70599584)
print v(xbgr.mr_n70599696)
print v(xbgr.mr_n70600016)
print v(xbgr.mr_n70600448)
print v(xbgr.mr_n70600560)
print v(xbgr.mr_n70600880)
print v(xbgr.mr_n70600992)
print v(xbgr.mr_n70601312)
print v(xbgr.mr_n70601424)
print v(xbgr.mr_n70601744)
print v(xbgr.mr_n70601856)
print v(xbgr.mr_n70602176)
print v(xbgr.mr_n70602288)
print v(xbgr.mr_n70602608)
print v(xbgr.mr_n70602720)
print v(xbgr.mr_n70603040)
print v(xbgr.mr_n70603152)
print v(xbgr.mr_n70603472)
print v(xbgr.mr_n70603584)
print v(xbgr.mr_n70603904)
print v(xbgr.mr_n70604016)
print v(xbgr.mr_n70604336)
print v(xbgr.mr_n70604448)
print v(xbgr.mr_n70604768)
print v(xbgr.mr_n70605200)
print v(xbgr.mr_n70605312)
print v(xbgr.mr_n70605632)
print v(xbgr.mr_n70606064)
print v(xbgr.mr_n70606176)
print v(xbgr.mr_n70606496)
print v(xbgr.mr_n70606608)
print v(xbgr.mr_n70606928)
print v(xbgr.mr_n70607040)
print v(xbgr.mr_n70607360)
print v(xbgr.mr_n70607472)
print v(xbgr.mr_n70607792)
print v(xbgr.mr_n70607904)
print v(xbgr.mr_n70608224)
print v(xbgr.mr_n70608656)
print v(xbgr.mr_n70608768)
print v(xbgr.mr_n70609088)
print v(xbgr.mr_n70609200)
print v(xbgr.mr_n70609520)
print v(xbgr.mr_n70609632)
print v(xbgr.mr_n70613568)
print v(xbgr.mr_n70613680)
print v(xbgr.mr_n70614016)
print v(xbgr.mr_n70614128)
print v(xbgr.mr_n70614448)
print v(xbgr.mr_n70614560)
print v(xbgr.mr_n70614928)
print v(xbgr.mr_n70615040)
print v(xbgr.mr_n70615360)
print v(xbgr.mr_n70615472)
print v(xbgr.mr_n70615792)
print v(xbgr.mr_n70616144)
print v(xbgr.mr_n70616256)
print v(xbgr.mr_n70616576)
print v(xbgr.mr_n70617008)
print v(xbgr.mr_n70617120)
print v(xbgr.mr_n70617440)
print v(xbgr.mr_n70617552)
print v(xbgr.mr_n70617872)
print v(xbgr.mr_n70617984)
print v(xbgr.mr_n70618304)
print v(xbgr.mr_n70618416)
print v(xbgr.mr_n70618736)
print v(xbgr.mr_n70618848)
print v(xbgr.mr_n70619168)
print v(xbgr.mr_n70619600)
print v(xbgr.mr_n70619712)
print v(xbgr.mr_n70620032)
print v(xbgr.mr_n70620464)
print v(xbgr.mr_n70620576)
print v(xbgr.mr_n70620896)
print v(xbgr.mr_n70621008)
print v(xbgr.mr_n70621328)
print v(xbgr.mr_n70621440)
print v(xbgr.mr_n70621760)
print v(xbgr.mr_n70621872)
print v(xbgr.mr_n70622192)
print v(xbgr.mr_n70622304)
print v(xbgr.mr_n70622624)
print v(xbgr.mr_n70622736)
print v(xbgr.mr_n70623056)
print v(xbgr.mr_n70623168)
print v(xbgr.mr_n70623488)
print v(xbgr.mr_n70623920)
print v(xbgr.mr_n70624032)
print v(xbgr.mr_n70624352)
print v(xbgr.mr_n70624464)
print v(xbgr.mr_n70624784)
print v(xbgr.mr_n70624896)
print v(xbgr.mr_n70625216)
print v(xbgr.mr_n70625328)
print v(xbgr.mr_n70625648)
print v(xbgr.mr_n70625760)
print v(xbgr.mr_n70626080)
print v(xbgr.mr_n70626192)
print v(xbgr.mr_n70626512)
print v(xbgr.mr_n70626624)
print v(xbgr.mr_n70626944)
print v(xbgr.mr_n70627376)
print v(xbgr.mr_n70627488)
print v(xbgr.mr_n70627808)
print v(xbgr.mr_n70628240)
print v(xbgr.mr_n70628352)
print v(xbgr.mr_n70628672)
print v(xbgr.mr_n70628784)
print v(xbgr.mr_n70629104)
print v(xbgr.mr_n70629216)
print v(xbgr.mr_n70629536)
print v(xbgr.mr_n70629648)
print v(xbgr.mr_n70629968)
print v(xbgr.mr_n70630080)
print v(xbgr.mr_n70630400)
print v(xbgr.mr_n70630512)
print v(xbgr.mr_n70630832)
print v(xbgr.mr_n70630944)
print v(xbgr.mr_n70631264)
print v(xbgr.mr_n70631696)
print v(xbgr.mr_n70631808)
print v(xbgr.mr_n70632128)
print v(xbgr.mr_n70632240)
print v(xbgr.mr_n70632560)
print v(xbgr.mr_n70632672)
print v(xbgr.mr_n70632992)
print v(xbgr.mr_n70633424)
print v(xbgr.mr_n70633536)
print v(xbgr.mr_n70633856)
print v(xbgr.mr_n70633968)
print v(xbgr.mr_n70634288)
print v(xbgr.mr_n70634400)
print v(xbgr.mr_n70634720)
print v(xbgr.mr_n70634832)
print v(xbgr.mr_n70635152)
print v(xbgr.mr_n70635264)
print v(xbgr.mr_n70635584)
print v(xbgr.mr_n70635696)
print v(xbgr.mr_n70636016)
print v(xbgr.mr_n70636128)
print v(xbgr.mr_n70636448)
print v(xbgr.mr_n70636880)
print v(xbgr.mr_n70636992)
print v(xbgr.mr_n70637312)
print v(xbgr.mr_n70637424)
print v(xbgr.mr_n70637744)
print v(xbgr.mr_n70637856)
print v(xbgr.mr_n70638176)
print v(xbgr.mr_n70638608)
print v(xbgr.mr_n70638720)
print v(xbgr.mr_n70639040)
print v(xbgr.mr_n70639152)
print v(xbgr.mr_n70639472)
print v(xbgr.mr_n70639584)
print v(xbgr.mr_n70639904)
print v(xbgr.mr_n70640016)
print v(xbgr.mr_n70640336)
print v(xbgr.mr_n70640448)
print v(xbgr.mr_n70640768)
print v(xbgr.mr_n70640880)
print v(xbgr.mr_n70641200)
print v(xbgr.mr_n70641312)
print v(xbgr.mr_n70641632)
print v(xbgr.mr_n70641744)
print v(xbgr.mr_n70642064)
print v(xbgr.mr_n70642176)
print v(xbgr.mr_n70642496)
print v(xbgr.mr_n70642928)
print v(xbgr.mr_n70643040)
print v(xbgr.mr_n70643360)
print v(xbgr.mr_n70643472)
print v(xbgr.mr_n70643696)
print v(xbgr.mr_n70644064)
print v(xbgr.mr_n70644176)
print v(xbgr.mr_n70644432)
print v(xbgr.mr_n70644544)
print v(xbgr.mr_n70644800)
print v(xbgr.mr_n70644912)
print v(xbgr.mr_n70645168)
print v(xbgr.mr_n70645280)
print v(xbgr.mr_n70645536)
print v(xbgr.mr_n70645648)
print v(xbgr.mr_n70645904)
print v(xbgr.mr_n70646272)
print v(xbgr.mr_n70646384)
print v(xbgr.mr_n70646640)
print v(xbgr.mr_n70647008)
print v(xbgr.mr_n70647120)
print v(xbgr.mr_n70647376)
print v(xbgr.mr_n70647744)
print v(xbgr.mr_n70647856)
print v(xbgr.mr_n70648112)
print v(xbgr.mr_n70648224)
print v(xbgr.mr_n70648480)
print v(xbgr.mr_n70648592)
print v(xbgr.mr_n70648848)
print v(xbgr.mr_n70649216)
print v(xbgr.mr_n70649328)
print v(xbgr.mr_n70649584)
print v(xbgr.mr_n70649952)
print v(xbgr.mr_n70650064)
print v(xbgr.mr_n70650320)
print v(xbgr.mr_n70650688)
print v(xbgr.mr_n70650800)
print v(xbgr.mr_n70651056)
print v(xbgr.mr_n70651168)
print v(xbgr.mr_n70651424)
print v(xbgr.mr_n70651536)
print v(xbgr.mr_n70651792)
print v(xbgr.mr_n70651904)
print v(xbgr.mr_n70652160)
print v(xbgr.mr_n70652272)
print v(xbgr.mr_n70652528)
print v(xbgr.mr_n70652896)
print v(xbgr.mr_n70653008)
print v(xbgr.mr_n70653264)
print v(xbgr.mr_n70653376)
print v(xbgr.mr_n70653632)
print v(xbgr.mr_n70653744)
print v(xbgr.mr_n70654000)
print v(xbgr.mr_n70654112)
print v(xbgr.mr_n70654368)
print v(xbgr.mr_n70654480)
print v(xbgr.mr_n70654736)
print v(xbgr.mr_n70655104)
print v(xbgr.mr_n70655216)
print v(xbgr.mr_n70655472)
print v(xbgr.mr_n70655872)
print v(xbgr.mr_n70655984)
print v(xbgr.mr_n70656304)
print v(xbgr.mr_n70656416)
print v(xbgr.mr_n70656736)
print v(xbgr.mr_n70656848)
print v(xbgr.mr_n70657168)
print v(xbgr.mr_n70657600)
print v(xbgr.mr_n70657712)
print v(xbgr.mr_n70658032)
print v(xbgr.mr_n70658464)
print v(xbgr.mr_n70658576)
print v(xbgr.mr_n70658896)
print v(xbgr.mr_n70659008)
print v(xbgr.mr_n70659328)
print v(xbgr.mr_n70659440)
print v(xbgr.mr_n70659760)
print v(xbgr.mr_n70659872)
print v(xbgr.mr_n70660192)
print v(xbgr.mr_n70660304)
print v(xbgr.mr_n70660624)
print v(xbgr.mr_n70660736)
print v(xbgr.mr_n70661056)
print v(xbgr.mr_n70661168)
print v(xbgr.mr_n70661488)
print v(xbgr.mr_n70661920)
print v(xbgr.mr_n70662032)
print v(xbgr.mr_n70662352)
print v(xbgr.mr_n70662464)
print v(xbgr.mr_n70662784)
print v(xbgr.mr_n70662896)
print v(xbgr.mr_n70663216)
print v(xbgr.mr_n70663328)
print v(xbgr.mr_n70663648)
print v(xbgr.mr_n70663760)
print v(xbgr.mr_n70664080)
print v(xbgr.mr_n70664512)
print v(xbgr.mr_n70664624)
print v(xbgr.mr_n70664944)
print v(xbgr.mr_n70665376)
print v(xbgr.mr_n70665488)
print v(xbgr.mr_n70665808)
print v(xbgr.mr_n70665920)
print v(xbgr.mr_n70666240)
print v(xbgr.mr_n70666352)
print v(xbgr.mr_n70666672)
print v(xbgr.mr_n70666784)
print v(xbgr.mr_n70667104)
print v(xbgr.mr_n70667216)
print v(xbgr.mr_n70667536)
print v(xbgr.mr_n70667648)
print v(xbgr.mr_n70667968)
print v(xbgr.mr_n70668080)
print v(xbgr.mr_n70668400)
print v(xbgr.mr_n70668512)
print v(xbgr.mr_n70668832)
print v(xbgr.mr_n70669376)
print v(xbgr.mr_n70669808)
print v(xbgr.mr_n70670240)
print v(xbgr.mr_n70670672)
print v(xbgr.mr_n70671104)
print v(xbgr.mr_n70671536)
print v(xbgr.mr_n70671968)
print v(xbgr.mr_n70672400)
print v(xbgr.mr_n70672832)
print v(xbgr.mr_n70673264)
print v(xbgr.mr_n70673584)
print v(xbgr.mr_n70674016)
print v(xbgr.mr_n70674448)
print v(xbgr.mr_n70674880)
print v(xbgr.mr_n70675312)
print v(xbgr.mr_n70675744)
print v(xbgr.mr_n70676176)
print v(xbgr.mr_n70676608)
print v(xbgr.mr_n70677040)
print v(xbgr.mr_n70677472)
print v(xbgr.mr_n70677904)
print v(xbgr.mr_n70678336)
print v(xbgr.mr_n70678768)
print v(xbgr.mr_n70679200)
print v(xbgr.mr_n70679632)
print v(xbgr.mr_n70680064)
print v(xbgr.mr_n70680496)
print v(xbgr.mr_n70680928)
print v(xbgr.mr_n70681360)
print v(xbgr.mr_n70681792)
print v(xbgr.mr_n70682224)
print v(xbgr.mr_n70682656)
print v(xbgr.mr_n70683088)
print v(xbgr.mr_n70683520)
print v(xbgr.mr_n70683952)
print v(xbgr.mr_n70684384)
print v(xbgr.mr_n70684816)
print v(xbgr.mr_n70685248)
print v(xbgr.mr_n70685680)
print v(xbgr.mr_n70686112)
print v(xbgr.mr_n70686544)
print v(xbgr.mr_n70686976)
print v(xbgr.mr_n70687408)
print v(xbgr.mr_n70687840)
print v(xbgr.mr_n70688272)
print v(xbgr.mr_n70688704)
print v(xbgr.mr_n70689136)
print v(xbgr.mr_n70689568)
print v(xbgr.mr_n70690000)
print v(xbgr.mr_n70690432)
print v(xbgr.mr_n70690864)
print v(xbgr.mr_n70691296)
print v(xbgr.mr_n70691728)
print v(xbgr.mr_n70692160)
print v(xbgr.mr_n70692592)
print v(xbgr.mr_n70693024)
print v(xbgr.mr_n70693456)
print v(xbgr.mr_n70693888)
print v(xbgr.mr_n70695184)
print v(xbgr.mr_n70695616)
print v(xbgr.mr_n70696048)
print v(xbgr.mr_n70696480)
print v(xbgr.mr_n70696912)
print v(xbgr.mr_n70697344)
print v(xbgr.mr_n70697776)
print v(xbgr.mr_n70698208)
print v(xbgr.mr_n70698640)
print v(xbgr.mr_n70699072)
print v(xbgr.mr_n70699504)
print v(xbgr.mr_n70699936)
print v(xbgr.mr_n70702096)
print v(xbgr.mr_n70702528)
print v(xbgr.mr_n70702960)
print v(xbgr.mr_n70703392)
print v(xbgr.mr_n70703824)
print v(xbgr.mr_n70704256)
print v(xbgr.mr_n70704688)
print v(xbgr.mr_n70705120)
print v(xbgr.mr_n70705552)
print v(xbgr.mr_n70705984)
print v(xbgr.mr_n70707280)
print v(xbgr.mr_n70707712)
print v(xbgr.mr_n70708144)
print v(xbgr.mr_n70708576)
print v(xbgr.mr_n70709008)
print v(xbgr.mr_n70709440)
print v(xbgr.mr_n70709872)
print v(xbgr.mr_n70710304)
print v(xbgr.mr_n70710736)
print v(xbgr.mr_n70711168)
print v(xbgr.mr_n70711600)
print v(xbgr.mr_n70712032)
print v(xbgr.mr_n70713328)
print v(xbgr.mr_n70713760)
print v(xbgr.mr_n70715056)
print v(xbgr.mr_n70715488)
print v(xbgr.mr_n70715920)
print v(xbgr.mr_n70716352)
print v(xbgr.mr_n70716784)
print v(xbgr.mr_n70717216)
print v(xbgr.mr_n70717648)
print v(xbgr.mr_n70718080)
print v(xbgr.mr_n70719376)
print v(xbgr.mr_n70719808)
print v(xbgr.mr_n70720128)
print v(xbgr.mr_n70720240)
print v(xbgr.mr_n70720560)
print v(xbgr.mr_n70720672)
print v(xbgr.mr_n70720992)
print v(xbgr.mr_n70721104)
print v(xbgr.mr_n70721424)
print v(xbgr.mr_n70721536)
print v(xbgr.mr_n70721856)
print v(xbgr.mr_n70721968)
print v(xbgr.mr_n70722288)
print v(xbgr.mr_n70722400)
print v(xbgr.mr_n70722720)
print v(xbgr.mr_n70722832)
print v(xbgr.mr_n70723152)
print v(xbgr.mr_n70723264)
print v(xbgr.mr_n70723696)
print v(xbgr.mr_n70724128)
print v(xbgr.mr_n70724560)
print v(xbgr.mr_n70724992)
print v(xbgr.mr_n70725424)
print v(xbgr.mr_n70725856)
print v(xbgr.mr_n70726288)
print v(xbgr.mr_n70726720)
print v(xbgr.mr_n70727152)
print v(xbgr.mr_n70727584)
print v(xbgr.mr_n70728016)
print v(xbgr.mr_n70728448)
print v(xbgr.mr_n70728880)
print v(xbgr.mr_n70729312)
print v(xbgr.mr_n70729744)
print v(xbgr.mr_n70730176)
print v(xbgr.mr_n70730608)
print v(xbgr.mr_n70731040)
print v(xbgr.mr_n70731472)
print v(xbgr.mr_n70731904)
print v(xbgr.mr_n70732336)
print v(xbgr.mr_n70732768)
print v(xbgr.mr_n70733200)
print v(xbgr.mr_n70733632)
print v(xbgr.mr_n70734064)
print v(xbgr.mr_n70734496)
print v(xbgr.mr_n70735136)
print v(xbgr.mr_n70735568)
print v(xbgr.mr_n70736000)
print v(xbgr.mr_n70736432)
print v(xbgr.mr_n70736864)
print v(xbgr.mr_n70737296)
print v(xbgr.mr_n70737728)
print v(xbgr.mr_n70738160)
print v(xbgr.mr_n70738592)
print v(xbgr.mr_n70739024)
print v(xbgr.mr_n70739456)
print v(xbgr.mr_n70739888)
print v(xbgr.mr_n70740320)
print v(xbgr.mr_n70740752)
print v(xbgr.mr_n70741184)
print v(xbgr.mr_n70741616)
print v(xbgr.mr_n70742048)
print v(xbgr.mr_n70742480)
print v(xbgr.mr_n70742912)
print v(xbgr.mr_n70743344)
print v(xbgr.mr_n70743776)
print v(xbgr.mr_n70744208)
print v(xbgr.mr_n70744640)
print v(xbgr.mr_n70745072)
print v(xbgr.mr_n70745504)
print v(xbgr.mr_n70745936)
print v(xbgr.mr_n70746368)
print v(xbgr.mr_n70746800)
print v(xbgr.mr_n70747232)
print v(xbgr.mr_n70747664)
print v(xbgr.mr_n70748096)
print v(xbgr.mr_n70748528)
print v(xbgr.mr_n70748960)
print v(xbgr.mr_n70749392)
print v(xbgr.mr_n70749824)
print v(xbgr.mr_n70750256)
print v(xbgr.mr_n70750688)
print v(xbgr.mr_n70751120)
print v(xbgr.mr_n70751552)
print v(xbgr.mr_n70751984)
print v(xbgr.mr_n70752416)
print v(xbgr.mr_n70752848)
print v(xbgr.mr_n70753280)
print v(xbgr.mr_n70753712)
print v(xbgr.mr_n70754144)
print v(xbgr.mr_n70754576)
print v(xbgr.mr_n70755008)
print v(xbgr.mr_n70755440)
print v(xbgr.mr_n70755872)
print v(xbgr.mr_n70756304)
print v(xbgr.mr_n70756736)
print v(xbgr.mr_n70757168)
print v(xbgr.mr_n70757600)
print v(xbgr.mr_n70758032)
print v(xbgr.mr_n70758464)
print v(xbgr.mr_n70758896)
print v(xbgr.mr_n70759328)
print v(xbgr.mr_n70759760)
print v(xbgr.mr_n70760192)
print v(xbgr.mr_n70760624)
print v(xbgr.mr_n70761056)
print v(xbgr.mr_n70761488)
print v(xbgr.mr_n70761920)
print v(xbgr.mr_n70762352)
print v(xbgr.mr_n70762784)
print v(xbgr.mr_n70763216)
print v(xbgr.mr_n70763648)
print v(xbgr.mr_n70764080)
print v(xbgr.mr_n70764512)
print v(xbgr.mr_n70764944)
print v(xbgr.mr_n70765376)
print v(xbgr.mr_n70765808)
print v(xbgr.mr_n70766240)
print v(xbgr.mr_n70766672)
print v(xbgr.mr_n70767104)
print v(xbgr.mr_n70767536)
print v(xbgr.mr_n70767968)
print v(xbgr.mr_n70768400)
print v(xbgr.mr_n70768832)
print v(xbgr.mr_n70769264)
print v(xbgr.mr_n70769696)
print v(xbgr.mr_n70770128)
print v(xbgr.mr_n70770560)
print v(xbgr.mr_n70770992)
print v(xbgr.mr_n70771424)
print v(xbgr.mr_n70771744)
print v(xbgr.mr_n70771856)
print v(xbgr.mr_n70772176)
print v(xbgr.mr_n70772288)
print v(xbgr.mr_n70772608)
print v(xbgr.mr_n70772720)
print v(xbgr.mr_n70773040)
print v(xbgr.mr_n70773152)
print v(xbgr.mr_n70773584)
print v(xbgr.mr_n70774016)
print v(xbgr.mr_n70774448)
print v(xbgr.mr_n70774880)
print v(xbgr.mr_n70775312)
print v(xbgr.mr_n70775744)
print v(xbgr.mr_n70776176)
print v(xbgr.mr_n70776608)
print v(xbgr.mr_n70777040)
print v(xbgr.mr_n70777472)
print v(xbgr.mr_n70777904)
print v(xbgr.mr_n70778336)
print v(xbgr.mr_n70778768)
print v(xbgr.mr_n70779200)
print v(xbgr.mr_n70779632)
print v(xbgr.mr_n70780064)
print v(xbgr.mr_n70780496)
print v(xbgr.mr_n70780928)
print v(xbgr.mr_n70781360)
print v(xbgr.mr_n70781792)
print v(xbgr.mr_n70782224)
print v(xbgr.mr_n70782656)
print v(xbgr.mr_n70783088)
print v(xbgr.mr_n70783520)
print v(xbgr.mr_n70783952)
print v(xbgr.mr_n70784384)
print v(xbgr.mr_n70784816)
print v(xbgr.mr_n70785248)
print v(xbgr.mr_n70785680)
print v(xbgr.mr_n70786112)
print v(xbgr.mr_n70786544)
print v(xbgr.mr_n70786976)
print v(xbgr.mr_n70787408)
print v(xbgr.mr_n70787840)
print v(xbgr.mr_n70788272)
print v(xbgr.mr_n70788704)
print v(xbgr.mr_n70789136)
print v(xbgr.mr_n70789568)
print v(xbgr.mr_n70790000)
print v(xbgr.mr_n70790432)
print v(xbgr.mr_n70790864)
print v(xbgr.mr_n70791296)
print v(xbgr.mr_n70791728)
print v(xbgr.mr_n70792160)
print v(xbgr.mr_n70792592)
print v(xbgr.mr_n70793024)
print v(xbgr.mr_n70793456)
print v(xbgr.mr_n70793888)
print v(xbgr.mr_n70794320)
print v(xbgr.mr_n70794752)
print v(xbgr.mr_n70795184)
print v(xbgr.mr_n70795616)
print v(xbgr.mr_n70796048)
print v(xbgr.mr_n70796480)
print v(xbgr.mr_n70796912)
print v(xbgr.mr_n70797344)
print v(xbgr.mr_n70797776)
print v(xbgr.mr_n70798208)
print v(xbgr.mr_n70798640)
print v(xbgr.mr_n70799072)
print v(xbgr.mr_n70799504)
print v(xbgr.mr_n70799936)
print v(xbgr.mr_n70800368)
print v(xbgr.mr_n70800800)
print v(xbgr.mr_n70802096)
print v(xbgr.mr_n70802528)
print v(xbgr.mr_n70803824)
print v(xbgr.mr_n70804256)
print v(xbgr.mr_n70805552)
print v(xbgr.mr_n70805984)
print v(xbgr.mr_n70806416)
print v(xbgr.mr_n70806848)
print v(xbgr.mr_n70807280)
print v(xbgr.mr_n70807712)
print v(xbgr.mr_n70808144)
print v(xbgr.mr_n70808576)
print v(xbgr.mr_n70809008)
print v(xbgr.mr_n70809440)
print v(xbgr.mr_n70809872)
print v(xbgr.mr_n70810304)
print v(xbgr.mr_n70810736)
print v(xbgr.mr_n70811168)
print v(xbgr.mr_n70811600)
print v(xbgr.mr_n70812032)
print v(xbgr.mr_n70813328)
print v(xbgr.mr_n70813760)
print v(xbgr.mr_n70814192)
print v(xbgr.mr_n70814624)
print v(xbgr.mr_n70815056)
print v(xbgr.mr_n70815488)
print v(xbgr.mr_n70816784)
print v(xbgr.mr_n70817216)
print v(xbgr.mr_n70817648)
print v(xbgr.mr_n70818080)
print v(xbgr.mr_n70818512)
print v(xbgr.mr_n70818944)
print v(xbgr.mr_n70819376)
print v(xbgr.mr_n70819808)
print v(xbgr.mr_n70820240)
print v(xbgr.mr_n70820672)
print v(xbgr.mr_n70821104)
print v(xbgr.mr_n70821536)
print v(xbgr.mr_n70821968)
print v(xbgr.mr_n70822400)
print v(xbgr.mr_n70822832)
print v(xbgr.mr_n70823264)
print v(xbgr.mr_n70823696)
print v(xbgr.mr_n70824128)
print v(xbgr.mr_n70824560)
print v(xbgr.mr_n70824992)
print v(xbgr.mr_n70825424)
print v(xbgr.mr_n70825856)
print v(xbgr.mr_n70826288)
print v(xbgr.mr_n70826720)
print v(xbgr.mr_n70827152)
print v(xbgr.mr_n70827584)
print v(xbgr.mr_n70828016)
print v(xbgr.mr_n70828448)
print v(xbgr.mr_n70828880)
print v(xbgr.mr_n70829312)
print v(xbgr.mr_n70829744)
print v(xbgr.mr_n70830176)
print v(xbgr.mr_n70830608)
print v(xbgr.mr_n70831040)
print v(xbgr.mr_n70831472)
print v(xbgr.mr_n70831904)
print v(xbgr.mr_n70832336)
print v(xbgr.mr_n70832768)
print v(xbgr.mr_n70833200)
print v(xbgr.mr_n70833632)
print v(xbgr.mr_n70834064)
print v(xbgr.mr_n70834496)
print v(xbgr.mr_n70834928)
print v(xbgr.mr_n70835360)
print v(xbgr.mr_n70835792)
print v(xbgr.mr_n70836224)
print v(xbgr.mr_n70836656)
print v(xbgr.mr_n70837088)
print v(xbgr.mr_n70837520)
print v(xbgr.mr_n70837952)
print v(xbgr.mr_n70838384)
print v(xbgr.mr_n70838816)
print v(xbgr.mr_n70839248)
print v(xbgr.mr_n70839680)
print v(xbgr.mr_n70840112)
print v(xbgr.mr_n70840544)
print v(xbgr.mr_n70840976)
print v(xbgr.mr_n70841296)
print v(xbgr.mr_n70841408)
print v(xbgr.mr_n70841728)
print v(xbgr.mr_n70841840)
print v(xbgr.mr_n70842160)
print v(xbgr.mr_n70842272)
print v(xbgr.mr_n70842592)
print v(xbgr.mr_n70842704)
print v(xbgr.mr_n70843024)
print v(xbgr.mr_n70843136)
print v(xbgr.mr_n70843456)
print v(xbgr.mr_n70843568)
print v(xbgr.mr_n70843888)
print v(xbgr.mr_n70844000)
print v(xbgr.mr_n70844320)
print v(xbgr.mr_n70844432)
print v(xbgr.mr_n70844752)
print v(xbgr.mr_n70844864)
print v(xbgr.mr_n70845184)
print v(xbgr.mr_n70845296)
print v(xbgr.mr_n70845616)
print v(xbgr.mr_n70845728)
print v(xbgr.mr_n70846048)
print v(xbgr.mr_n70846160)
print v(xbgr.mr_n70846480)
print v(xbgr.mr_n70846592)
print v(xbgr.mr_n70846912)
print v(xbgr.mr_n70847024)
print v(xbgr.mr_n70847344)
print v(xbgr.mr_n70847456)
print v(xbgr.mr_n70847776)
print v(xbgr.mr_n70847888)
print v(xbgr.mr_n70848208)
print v(xbgr.mr_n70848320)
print v(xbgr.mr_n70848640)
print v(xbgr.mr_n70848752)
print v(xbgr.mr_n70849072)
print v(xbgr.mr_n70849184)
print v(xbgr.mr_n70849504)
print v(xbgr.mr_n70849616)
print v(xbgr.mr_n70849936)
print v(xbgr.mr_n70850048)
print v(xbgr.mr_n70850368)
print v(xbgr.mr_n70850480)
print v(xbgr.mr_n70850800)
print v(xbgr.mr_n70850912)
print v(xbgr.mr_n70851232)
print v(xbgr.mr_n70851344)
print v(xbgr.mr_n70851664)
print v(xbgr.mr_n70851776)
print v(xbgr.mr_n70852096)
print v(xbgr.mr_n70852208)
print v(xbgr.mr_n70852528)
print v(xbgr.mr_n70852640)
print v(xbgr.mr_n70852960)
print v(xbgr.mr_n70853072)
print v(xbgr.mr_n70853392)
print v(xbgr.mr_n70853504)
print v(xbgr.mr_n70853824)
print v(xbgr.mr_n70853936)
print v(xbgr.mr_n70854256)
print v(xbgr.mr_n70854368)
print v(xbgr.mr_n70854688)
print v(xbgr.mr_n70854800)
print v(xbgr.mr_n70855120)
print v(xbgr.mr_n70855232)
print v(xbgr.mr_n70855552)
print v(xbgr.mr_n70855664)
print v(xbgr.mr_n70855984)
print v(xbgr.mr_n70856096)
print v(xbgr.mr_n70856416)
print v(xbgr.mr_n70856528)
print v(xbgr.mr_n70856848)
print v(xbgr.mr_n70856960)
print v(xbgr.mr_n70857280)
print v(xbgr.mr_n70857392)
print v(xbgr.mr_n70857808)
print v(xbgr.mr_n70858240)
print v(xbgr.mr_n70858672)
print v(xbgr.mr_n70859104)
print v(xbgr.mr_n70859536)
print v(xbgr.mr_n70859968)
print v(xbgr.mr_n70860400)
print v(xbgr.mr_n70860832)
print v(xbgr.mr_n70861264)
print v(xbgr.mr_n70861696)
print v(xbgr.mr_n70862128)
print v(xbgr.mr_n70862560)
print v(xbgr.mr_n70862880)
print v(xbgr.mr_n70862992)
print v(xbgr.mr_n70863312)
print v(xbgr.mr_n70863424)
print v(xbgr.mr_n70863856)
print v(xbgr.mr_n70864288)
print v(xbgr.mr_n70864720)
print v(xbgr.mr_n70865152)
print v(xbgr.mr_n70865584)
print v(xbgr.mr_n70866016)
print v(xbgr.mr_n70866448)
print v(xbgr.mr_n70866880)
print v(xbgr.mr_n70867312)
print v(xbgr.mr_n70867744)
print v(xbgr.mr_n70868176)
print v(xbgr.mr_n70868608)
print v(xbgr.mr_n70869040)
print v(xbgr.mr_n70869472)
print v(xbgr.mr_n70869904)
print v(xbgr.mr_n70870336)
print v(xbgr.mr_n70870768)
print v(xbgr.mr_n70871200)
print v(xbgr.mr_n70871632)
print v(xbgr.mr_n70872064)
print v(xbgr.mr_n70872496)
print v(xbgr.mr_n70872928)
print v(xbgr.mr_n70873360)
print v(xbgr.mr_n70873792)
print v(xbgr.mr_n70874224)
print v(xbgr.mr_n70874656)
print v(xbgr.mr_n70875088)
print v(xbgr.mr_n70875520)
print v(xbgr.mr_n70875952)
print v(xbgr.mr_n70876384)
print v(xbgr.mr_n70876816)
print v(xbgr.mr_n70877248)
print v(xbgr.mr_n70877680)
print v(xbgr.mr_n70878112)
print v(xbgr.mr_n70878544)
print v(xbgr.mr_n70878976)
print v(xbgr.mr_n70879408)
print v(xbgr.mr_n70879840)
print v(xbgr.mr_n70880272)
print v(xbgr.mr_n70880704)
print v(xbgr.mr_n70881024)
print v(xbgr.mr_n70881136)
print v(xbgr.mr_n70881456)
print v(xbgr.mr_n70881568)
print v(xbgr.mr_n70882000)
print v(xbgr.mr_n70882320)
print v(xbgr.mr_n70882432)
print v(xbgr.mr_n70882864)
print v(xbgr.mr_n70883296)
print v(xbgr.mr_n70883728)
print v(xbgr.mr_n70884160)
print v(xbgr.mr_n70884592)
print v(xbgr.mr_n70885024)
print v(xbgr.mr_n70885456)
print v(xbgr.mr_n70885888)
print v(xbgr.mr_n70886320)
print v(xbgr.mr_n70886752)
print v(xbgr.mr_n70887184)
print v(xbgr.mr_n70887616)
print v(xbgr.mr_n70888048)
print v(xbgr.mr_n70888480)
print v(xbgr.mr_n70888912)
print v(xbgr.mr_n70889344)
print v(xbgr.mr_n70889776)
print v(xbgr.mr_n70890208)
print v(xbgr.mr_n70890640)
print v(xbgr.mr_n70891072)
print v(xbgr.mr_n70891504)
print v(xbgr.mr_n70891936)
print v(xbgr.mr_n70892368)
print v(xbgr.mr_n70892800)
print v(xbgr.mr_n70893232)
print v(xbgr.mr_n70893664)
print v(xbgr.mr_n70894096)
print v(xbgr.mr_n70894528)
print v(xbgr.mr_n70894960)
print v(xbgr.mr_n70895392)
print v(xbgr.mr_n70895824)
print v(xbgr.mr_n70896256)
print v(xbgr.mr_n70896688)
print v(xbgr.mr_n70897120)
print v(xbgr.mr_n70897552)
print v(xbgr.mr_n70897984)
print v(xbgr.mr_n70898416)
print v(xbgr.mr_n70898848)
print v(xbgr.mr_n70899280)
print v(xbgr.mr_n70899712)
print v(xbgr.mr_n70900144)
print v(xbgr.mr_n70900576)
print v(xbgr.mr_n70901008)
print v(xbgr.mr_n70901440)
print v(xbgr.mr_n70901872)
print v(xbgr.mr_n70902304)
print v(xbgr.mr_n70902736)
print v(xbgr.mr_n70903056)
print v(xbgr.mr_n70903168)
print v(xbgr.mr_n70903600)
print v(xbgr.mr_n70904032)
print v(xbgr.mr_n70904352)
print v(xbgr.mr_n70904464)
print v(xbgr.mr_n70904784)
print v(xbgr.mr_n70904896)
print v(xbgr.mr_n70905216)
print v(xbgr.mr_n70905328)
print v(xbgr.mr_n70905648)
print v(xbgr.mr_n70905760)
print v(xbgr.mr_n70906080)
print v(xbgr.mr_n70906192)
print v(xbgr.mr_n70906512)
print v(xbgr.mr_n70906624)
print v(xbgr.mr_n70907056)
print v(xbgr.mr_n70907376)
print v(xbgr.mr_n70907488)
print v(xbgr.mr_n70907808)
print v(xbgr.mr_n70907920)
print v(xbgr.mr_n70908240)
print v(xbgr.mr_n70908352)
print v(xbgr.mr_n70908672)
print v(xbgr.mr_n70908784)
print v(xbgr.mr_n70909104)
print v(xbgr.mr_n70909216)
print v(xbgr.mr_n70909536)
print v(xbgr.mr_n70909648)
print v(xbgr.mr_n70910080)
print v(xbgr.mr_n70910400)
print v(xbgr.mr_n70910512)
print v(xbgr.mr_n70910832)
print v(xbgr.mr_n70910944)
print v(xbgr.mr_n70911264)
print v(xbgr.mr_n70911376)
print v(xbgr.mr_n70911696)
print v(xbgr.mr_n70911808)
print v(xbgr.mr_n70912128)
print v(xbgr.mr_n70912240)
print v(xbgr.mr_n70912560)
print v(xbgr.mr_n70912672)
print v(xbgr.mr_n70913104)
print v(xbgr.mr_n70913424)
print v(xbgr.mr_n70913536)
print v(xbgr.mr_n70913856)
print v(xbgr.mr_n70913968)
print v(xbgr.mr_n70914288)
print v(xbgr.mr_n70914400)
print v(xbgr.mr_n70914832)
print v(xbgr.mr_n70915152)
print v(xbgr.mr_n70915264)
print v(xbgr.mr_n70915696)
print v(xbgr.mr_n70916128)
print v(xbgr.mr_n70916560)
print v(xbgr.mr_n70916992)
print v(xbgr.mr_n70918288)
print v(xbgr.mr_n70918720)
print v(xbgr.mr_n70920016)
print v(xbgr.mr_n70920448)
print v(xbgr.mr_n70920768)
print v(xbgr.mr_n70920880)
print v(xbgr.mr_n70921200)
print v(xbgr.mr_n70921312)
print v(xbgr.mr_n70921632)
print v(xbgr.mr_n70921744)
print v(xbgr.mr_n70922064)
print v(xbgr.mr_n70922608)
print v(xbgr.mr_n70923360)
print v(xbgr.mr_n70923472)
print v(xbgr.mr_n70923792)
print v(xbgr.mr_n70926064)
print v(xbgr.mr_n70926928)
print v(xbgr.mr_n70927792)
print v(xbgr.mr_n70928224)
print v(xbgr.mr_n70928656)
print v(xbgr.mr_n70929088)
print v(xbgr.mr_n70931136)
print v(xbgr.mr_n70931248)
print v(xbgr.mr_n70931680)
print v(xbgr.mr_n70932000)
print v(xbgr.mr_n70932112)
print v(xbgr.mr_n70932432)
print v(xbgr.mr_n70932544)
print v(xbgr.mr_n70932976)
print v(xbgr.mr_n70933296)
print v(xbgr.mr_n70933408)
print v(xbgr.mr_n70933728)
print v(xbgr.mr_n70933840)
print v(xbgr.mr_n70934160)
print v(xbgr.mr_n70934272)
print v(xbgr.mr_n70934704)
print v(xbgr.mr_n70935024)
print v(xbgr.mr_n70935136)
print v(xbgr.mr_n70935456)
print v(xbgr.mr_n70935568)
print v(xbgr.mr_n70935888)
print v(xbgr.mr_n70936000)
print v(xbgr.mr_n70936432)
print v(xbgr.mr_n70936752)
print v(xbgr.mr_n70936864)
print v(xbgr.mr_n70937184)
print v(xbgr.mr_n70937296)
print v(xbgr.mr_n70937616)
print v(xbgr.mr_n70937728)
print v(xbgr.mr_n70938048)
print v(xbgr.mr_n70938160)
print v(xbgr.mr_n70938480)
print v(xbgr.mr_n70938592)
print v(xbgr.mr_n70939024)
print v(xbgr.mr_n70939344)
print v(xbgr.mr_n70939456)
print v(xbgr.mr_n70939776)
print v(xbgr.mr_n70939888)
print v(xbgr.mr_n70940208)
print v(xbgr.mr_n70940320)
print v(xbgr.mr_n70940640)
print v(xbgr.mr_n70940752)
print v(xbgr.mr_n70941184)
print v(xbgr.mr_n70941504)
print v(xbgr.mr_n70941616)
print v(xbgr.mr_n70941936)
print v(xbgr.mr_n70942048)
print v(xbgr.mr_n70942480)
print v(xbgr.mr_n70942800)
print v(xbgr.mr_n70942912)
print v(xbgr.mr_n70943232)
print v(xbgr.mr_n70943344)
print v(xbgr.mr_n70943664)
print v(xbgr.mr_n70943776)
print v(xbgr.mr_n70944208)
print v(xbgr.mr_n70944528)
print v(xbgr.mr_n70944640)
print v(xbgr.mr_n70944960)
print v(xbgr.mr_n70945072)
print v(xbgr.mr_n70945392)
print v(xbgr.mr_n70945504)
print v(xbgr.mr_n70945936)
print v(xbgr.mr_n70946256)
print v(xbgr.mr_n70946368)
print v(xbgr.mr_n70946688)
print v(xbgr.mr_n70946800)
print v(xbgr.mr_n70947120)
print v(xbgr.mr_n70947232)
print v(xbgr.mr_n70947552)
print v(xbgr.mr_n70947664)
print v(xbgr.mr_n70947984)
print v(xbgr.mr_n70948096)
print v(xbgr.mr_n70948416)
print v(xbgr.mr_n70948528)
print v(xbgr.mr_n70948848)
print v(xbgr.mr_n70948960)
print v(xbgr.mr_n70949280)
print v(xbgr.mr_n70949392)
print v(xbgr.mr_n70949712)
print v(xbgr.mr_n70949824)
print v(xbgr.mr_n70950144)
print v(xbgr.mr_n70950256)
print v(xbgr.mr_n70950576)
print v(xbgr.mr_n70950688)
print v(xbgr.mr_n70951008)
print v(xbgr.mr_n70951120)
print v(xbgr.mr_n70951440)
print v(xbgr.mr_n70951552)
print v(xbgr.mr_n70951984)
print v(xbgr.mr_n70952304)
print v(xbgr.mr_n70952416)
print v(xbgr.mr_n70952736)
print v(xbgr.mr_n70952848)
print v(xbgr.mr_n70953168)
print v(xbgr.mr_n70953280)
print v(xbgr.mr_n70953600)
print v(xbgr.mr_n70953712)
print v(xbgr.mr_n70954032)
print v(xbgr.mr_n70954144)
print v(xbgr.mr_n70954464)
print v(xbgr.mr_n70954576)
print v(xbgr.mr_n70954896)
print v(xbgr.mr_n70955008)
print v(xbgr.mr_n70955328)
print v(xbgr.mr_n70955440)
print v(xbgr.mr_n70955760)
print v(xbgr.mr_n70955872)
print v(xbgr.mr_n70956192)
print v(xbgr.mr_n70956304)
print v(xbgr.mr_n70956736)
print v(xbgr.mr_n70957056)
print v(xbgr.mr_n70957168)
print v(xbgr.mr_n70957488)
print v(xbgr.mr_n70957600)
print v(xbgr.mr_n70957920)
print v(xbgr.mr_n70958032)
print v(xbgr.mr_n70958352)
print v(xbgr.mr_n70958464)
print v(xbgr.mr_n70958784)
print v(xbgr.mr_n70958896)
print v(xbgr.mr_n70959216)
print v(xbgr.mr_n70959328)
print v(xbgr.mr_n70959648)
print v(xbgr.mr_n70959760)
print v(xbgr.mr_n70960080)
print v(xbgr.mr_n70960192)
print v(xbgr.mr_n70960512)
print v(xbgr.mr_n70960624)
print v(xbgr.mr_n70960944)
print v(xbgr.mr_n70961056)
print v(xbgr.mr_n70961376)
print v(xbgr.mr_n70961488)
print v(xbgr.mr_n70961808)
print v(xbgr.mr_n70961920)
print v(xbgr.mr_n70962240)
print v(xbgr.mr_n70962352)
print v(xbgr.mr_n70962672)
print v(xbgr.mr_n70962784)
print v(xbgr.mr_n70963104)
print v(xbgr.mr_n70963216)
print v(xbgr.mr_n70963536)
print v(xbgr.mr_n70963648)
print v(xbgr.mr_n70964080)
print v(xbgr.mr_n70964400)
print v(xbgr.mr_n70964512)
print v(xbgr.mr_n70964832)
print v(xbgr.mr_n70964944)
print v(xbgr.mr_n70965264)
print v(xbgr.mr_n70965376)
print v(xbgr.mr_n70965696)
print v(xbgr.mr_n70965808)
print v(xbgr.mr_n70966128)
print v(xbgr.mr_n70966240)
print v(xbgr.mr_n70966560)
print v(xbgr.mr_n70966672)
print v(xbgr.mr_n70966992)
print v(xbgr.mr_n70967104)
print v(xbgr.mr_n70967424)
print v(xbgr.mr_n70967536)
print v(xbgr.mr_n70967856)
print v(xbgr.mr_n70967968)
print v(xbgr.mr_n70968288)
print v(xbgr.mr_n70968400)
print v(xbgr.mr_n70968720)
print v(xbgr.mr_n70968832)
print v(xbgr.mr_n70969152)
print v(xbgr.mr_n70969264)
print v(xbgr.mr_n70969696)
print v(xbgr.mr_n70970016)
print v(xbgr.mr_n70970128)
print v(xbgr.mr_n70970448)
print v(xbgr.mr_n70970560)
print v(xbgr.mr_n70970880)
print v(xbgr.mr_n70970992)
print v(xbgr.mr_n70971312)
print v(xbgr.mr_n70971424)
print v(xbgr.mr_n70971744)
print v(xbgr.mr_n70971856)
print v(xbgr.mr_n70972176)
print v(xbgr.mr_n70972288)
print v(xbgr.mr_n70972608)
print v(xbgr.mr_n70972720)
print v(xbgr.mr_n70973040)
print v(xbgr.mr_n70973152)
print v(xbgr.mr_n70973472)
print v(xbgr.mr_n70973584)
print v(xbgr.mr_n70973904)
print v(xbgr.mr_n70974016)
print v(xbgr.mr_n70974336)
print v(xbgr.mr_n70974448)
print v(xbgr.mr_n70974768)
print v(xbgr.mr_n70974880)
print v(xbgr.mr_n70975200)
print v(xbgr.mr_n70975312)
print v(xbgr.mr_n70975632)
print v(xbgr.mr_n70975744)
print v(xbgr.mr_n70976064)
print v(xbgr.mr_n70976176)
print v(xbgr.mr_n70976496)
print v(xbgr.mr_n70976608)
print v(xbgr.mr_n70976928)
print v(xbgr.mr_n70977040)
print v(xbgr.mr_n70977360)
print v(xbgr.mr_n70977472)
print v(xbgr.mr_n70977792)
print v(xbgr.mr_n70977904)
print v(xbgr.mr_n70978224)
print v(xbgr.mr_n70978336)
print v(xbgr.mr_n70978768)
print v(xbgr.mr_n70979088)
print v(xbgr.mr_n70979200)
print v(xbgr.mr_n70979520)
print v(xbgr.mr_n70979632)
print v(xbgr.mr_n70979952)
print v(xbgr.mr_n70980064)
print v(xbgr.mr_n70980384)
print v(xbgr.mr_n70980496)
print v(xbgr.mr_n70980816)
print v(xbgr.mr_n70980928)
print v(xbgr.mr_n70981248)
print v(xbgr.mr_n70981360)
print v(xbgr.mr_n70981680)
print v(xbgr.mr_n70981792)
print v(xbgr.mr_n70982112)
print v(xbgr.mr_n70982224)
print v(xbgr.mr_n70982544)
print v(xbgr.mr_n70982656)
print v(xbgr.mr_n70982976)
print v(xbgr.mr_n70983088)
print v(xbgr.mr_n70983408)
print v(xbgr.mr_n70983520)
print v(xbgr.mr_n70983840)
print v(xbgr.mr_n70983952)
print v(xbgr.mr_n70984272)
print v(xbgr.mr_n70984384)
print v(xbgr.mr_n70984704)
print v(xbgr.mr_n70984816)
print v(xbgr.mr_n70985136)
print v(xbgr.mr_n70985248)
print v(xbgr.mr_n70985568)
print v(xbgr.mr_n70985680)
print v(xbgr.mr_n70986000)
print v(xbgr.mr_n70986112)
print v(xbgr.mr_n70986432)
print v(xbgr.mr_n70986544)
print v(xbgr.mr_n70986864)
print v(xbgr.mr_n70986976)
print v(xbgr.mr_n70987296)
print v(xbgr.mr_n70987408)
print v(xbgr.mr_n70987728)
print v(xbgr.mr_n70987840)
print v(xbgr.mr_n70988160)
print v(xbgr.mr_n70988272)
print v(xbgr.mr_n70988704)
print v(xbgr.mr_n70989024)
print v(xbgr.mr_n70989136)
print v(xbgr.mr_n70989456)
print v(xbgr.mr_n70989568)
print v(xbgr.mr_n70989888)
print v(xbgr.mr_n70990000)
print v(xbgr.mr_n70990320)
print v(xbgr.mr_n70990432)
print v(xbgr.mr_n70990752)
print v(xbgr.mr_n70990864)
print v(xbgr.mr_n70991184)
print v(xbgr.mr_n70991296)
print v(xbgr.mr_n70991616)
print v(xbgr.mr_n70991728)
print v(xbgr.mr_n70992048)
print v(xbgr.mr_n70992160)
print v(xbgr.mr_n70992480)
print v(xbgr.mr_n70992592)
print v(xbgr.mr_n70992912)
print v(xbgr.mr_n70993024)
print v(xbgr.mr_n70993344)
print v(xbgr.mr_n70993456)
print v(xbgr.mr_n70993776)
print v(xbgr.mr_n70993888)
print v(xbgr.mr_n70994320)
print v(xbgr.mr_n70994752)
print v(xbgr.mr_n70995184)
print v(xbgr.mr_n70995616)
print v(xbgr.mr_n70996048)
print v(xbgr.mr_n70996480)
print v(xbgr.mr_n70996912)
print v(xbgr.mr_n70997344)
print v(xbgr.mr_n70997776)
print v(xbgr.mr_n70998208)
print v(xbgr.mr_n70998640)
print v(xbgr.mr_n70999072)
print v(xbgr.mr_n70999504)
print v(xbgr.mr_n70999936)
print v(xbgr.mr_n71000368)
print v(xbgr.mr_n71000800)
print v(xbgr.mr_n71001232)
print v(xbgr.mr_n71001664)
print v(xbgr.mr_n71002096)
print v(xbgr.mr_n71002528)
print v(xbgr.mr_n71002960)
print v(xbgr.mr_n71003392)
print v(xbgr.mr_n71003824)
print v(xbgr.mr_n71004256)
print v(xbgr.mr_n71004688)
print v(xbgr.mr_n71005120)
print v(xbgr.mr_n71005552)
print v(xbgr.mr_n71005984)
print v(xbgr.mr_n71006416)
print v(xbgr.mr_n71006848)
print v(xbgr.mr_n71007280)
print v(xbgr.mr_n71007712)
print v(xbgr.mr_n71008144)
print v(xbgr.mr_n71008576)
print v(xbgr.mr_n71009008)
print v(xbgr.mr_n71009440)
print v(xbgr.mr_n71009872)
print v(xbgr.mr_n71010304)
print v(xbgr.mr_n71010736)
print v(xbgr.mr_n71011168)
print v(xbgr.mr_n71011600)
print v(xbgr.mr_n71012032)
print v(xbgr.mr_n71012464)
print v(xbgr.mr_n71012896)
print v(xbgr.mr_n71013328)
print v(xbgr.mr_n71013760)
print v(xbgr.mr_n71014192)
print v(xbgr.mr_n71014624)
print v(xbgr.mr_n71015056)
print v(xbgr.mr_n71015488)
print v(xbgr.mr_n71015920)
print v(xbgr.mr_n71016352)
print v(xbgr.mr_n71016784)
print v(xbgr.mr_n71017216)
print v(xbgr.mr_n71017648)
print v(xbgr.mr_n71018080)
print v(xbgr.mr_n71018512)
print v(xbgr.mr_n71018944)
print v(xbgr.mr_n71019376)
print v(xbgr.mr_n71019808)
print v(xbgr.mr_n71020240)
print v(xbgr.mr_n71020672)
print v(xbgr.mr_n71021104)
print v(xbgr.mr_n71021536)
print v(xbgr.mr_n71021968)
print v(xbgr.mr_n71022400)
print v(xbgr.mr_n71022832)
print v(xbgr.mr_n71023264)
print v(xbgr.mr_n71023696)
print v(xbgr.mr_n71024128)
print v(xbgr.mr_n71024560)
print v(xbgr.mr_n71024992)
print v(xbgr.mr_n71025424)
print v(xbgr.mr_n71025856)
print v(xbgr.mr_n71026288)
print v(xbgr.mr_n71026720)
print v(xbgr.mr_n71027152)
print v(xbgr.mr_n71027584)
print v(xbgr.mr_n71028016)
print v(xbgr.mr_n71028448)
print v(xbgr.mr_n71028880)
print v(xbgr.mr_n71029312)
print v(xbgr.mr_n71029744)
print v(xbgr.mr_n71030176)
print v(xbgr.mr_n71030608)
print v(xbgr.mr_n71031040)
print v(xbgr.mr_n71031472)
print v(xbgr.mr_n71031904)
print v(xbgr.mr_n71032336)
print v(xbgr.mr_n71032768)
print v(xbgr.mr_n71033200)
print v(xbgr.mr_n71033632)
print v(xbgr.mr_n71034064)
print v(xbgr.mr_n71034496)
print v(xbgr.mr_n71034928)
print v(xbgr.mr_n71035360)
print v(xbgr.mr_n71035792)
print v(xbgr.mr_n71036224)
print v(xbgr.mr_n71036656)
print v(xbgr.mr_n71037088)
print v(xbgr.mr_n71037520)
print v(xbgr.mr_n71037952)
print v(xbgr.mr_n71038384)
print v(xbgr.mr_n71038816)
print v(xbgr.mr_n71039248)
print v(xbgr.mr_n71039680)
print v(xbgr.mr_n71040112)
print v(xbgr.mr_n71040544)
print v(xbgr.mr_n71040976)
print v(xbgr.mr_n71041408)
print v(xbgr.mr_n71041728)
print v(xbgr.mr_n71041840)
print v(xbgr.mr_n71042160)
print v(xbgr.mr_n71042272)
print v(xbgr.mr_n71042592)
print v(xbgr.mr_n71042704)
print v(xbgr.mr_n71043024)
print v(xbgr.mr_n71043136)
print v(xbgr.mr_n71043456)
print v(xbgr.mr_n71043568)
print v(xbgr.mr_n71043888)
print v(xbgr.mr_n71044000)
print v(xbgr.mr_n71044320)
print v(xbgr.mr_n71044432)
print v(xbgr.mr_n71044752)
print v(xbgr.mr_n71044864)
print v(xbgr.mr_n71045184)
print v(xbgr.mr_n71045296)
print v(xbgr.mr_n71045616)
print v(xbgr.mr_n71045728)
print v(xbgr.mr_n71046048)
print v(xbgr.mr_n71046160)
print v(xbgr.mr_n71046480)
print v(xbgr.mr_n71046592)
print v(xbgr.mr_n71046912)
print v(xbgr.mr_n71047024)
print v(xbgr.mr_n71047344)
print v(xbgr.mr_n71047456)
print v(xbgr.mr_n71047776)
print v(xbgr.mr_n71047888)
print v(xbgr.mr_n71048208)
print v(xbgr.mr_n71048320)
print v(xbgr.mr_n71048640)
print v(xbgr.mr_n71048752)
print v(xbgr.mr_n71049072)
print v(xbgr.mr_n71049184)
print v(xbgr.mr_n71049504)
print v(xbgr.mr_n71049616)
print v(xbgr.mr_n71049936)
print v(xbgr.mr_n71050048)
print v(xbgr.mr_n71050368)
print v(xbgr.mr_n71050480)
print v(xbgr.mr_n71050800)
print v(xbgr.mr_n71050912)
print v(xbgr.mr_n71051232)
print v(xbgr.mr_n71051344)
print v(xbgr.mr_n71051664)
print v(xbgr.mr_n71051776)
print v(xbgr.mr_n71052096)
print v(xbgr.mr_n71052208)
print v(xbgr.mr_n71052528)
print v(xbgr.mr_n71052640)
print v(xbgr.mr_n71052960)
print v(xbgr.mr_n71053072)
print v(xbgr.mr_n71053392)
print v(xbgr.mr_n71053504)
print v(xbgr.mr_n71053824)
print v(xbgr.mr_n71053936)
print v(xbgr.mr_n71054256)
print v(xbgr.mr_n71054368)
print v(xbgr.mr_n71054688)
print v(xbgr.mr_n71054800)
print v(xbgr.mr_n71055120)
print v(xbgr.mr_n71055232)
print v(xbgr.mr_n71055552)
print v(xbgr.mr_n71055664)
print v(xbgr.mr_n71055984)
print v(xbgr.mr_n71056096)
print v(xbgr.mr_n71056416)
print v(xbgr.mr_n71056528)
print v(xbgr.mr_n71056848)
print v(xbgr.mr_n71056960)
print v(xbgr.mr_n71057280)
print v(xbgr.mr_n71057392)
print v(xbgr.mr_n71057712)
print v(xbgr.mr_n71057824)
print v(xbgr.mr_n71058144)
print v(xbgr.mr_n71058256)
print v(xbgr.mr_n71058576)
print v(xbgr.mr_n71058688)
print v(xbgr.mr_n71059008)
print v(xbgr.mr_n71059120)
print v(xbgr.mr_n71059440)
print v(xbgr.mr_n71059552)
print v(xbgr.mr_n71059872)
print v(xbgr.mr_n71059984)
print v(xbgr.mr_n71060304)
print v(xbgr.mr_n71060416)
print v(xbgr.mr_n71060736)
print v(xbgr.mr_n71060848)
print v(xbgr.mr_n71061168)
print v(xbgr.mr_n71061280)
print v(xbgr.mr_n71061600)
print v(xbgr.mr_n71061712)
print v(xbgr.mr_n71062032)
print v(xbgr.mr_n71062144)
print v(xbgr.mr_n71062464)
print v(xbgr.mr_n71062576)
print v(xbgr.mr_n71062896)
print v(xbgr.mr_n71063008)
print v(xbgr.mr_n71063440)
print v(xbgr.mr_n71063760)
print v(xbgr.mr_n71063872)
print v(xbgr.mr_n71064192)
print v(xbgr.mr_n71064304)
print v(xbgr.mr_n71064624)
print v(xbgr.mr_n71064736)
print v(xbgr.mr_n71065056)
print v(xbgr.mr_n71065168)
print v(xbgr.mr_n71065488)
print v(xbgr.mr_n71065600)
print v(xbgr.mr_n71065920)
print v(xbgr.mr_n71066032)
print v(xbgr.mr_n71066352)
print v(xbgr.mr_n71066464)
print v(xbgr.mr_n71066784)
print v(xbgr.mr_n71066896)
print v(xbgr.mr_n71067216)
print v(xbgr.mr_n71067328)
print v(xbgr.mr_n71067648)
print v(xbgr.mr_n71067760)
print v(xbgr.mr_n71068080)
print v(xbgr.mr_n71068192)
print v(xbgr.mr_n71068512)
print v(xbgr.mr_n71068624)
print v(xbgr.mr_n71068944)
print v(xbgr.mr_n71069056)
print v(xbgr.mr_n71069376)
print v(xbgr.mr_n71069488)
print v(xbgr.mr_n71069808)
print v(xbgr.mr_n71069920)
print v(xbgr.mr_n71070240)
print v(xbgr.mr_n71070352)
print v(xbgr.mr_n71070800)
print v(xbgr.mr_n71070912)
print v(xbgr.mr_n71071232)
print v(xbgr.mr_n71071344)
print v(xbgr.mr_n71071664)
print v(xbgr.mr_n71071776)
print v(xbgr.mr_n71072096)
print v(xbgr.mr_n71072208)
print v(xbgr.mr_n71072528)
print v(xbgr.mr_n71072640)
print v(xbgr.mr_n71072960)
print v(xbgr.mr_n71073072)
print v(xbgr.mr_n71073392)
print v(xbgr.mr_n71073504)
print v(xbgr.mr_n71073824)
print v(xbgr.mr_n71073936)
print v(xbgr.mr_n71074256)
print v(xbgr.mr_n71074368)
print v(xbgr.mr_n71074688)
print v(xbgr.mr_n71074800)
print v(xbgr.mr_n71075120)
print v(xbgr.mr_n71075232)
print v(xbgr.mr_n71075664)
print v(xbgr.mr_n71075984)
print v(xbgr.mr_n71076096)
print v(xbgr.mr_n71076416)
print v(xbgr.mr_n71076528)
print v(xbgr.mr_n71076848)
print v(xbgr.mr_n71076960)
print v(xbgr.mr_n71077280)
print v(xbgr.mr_n71077392)
print v(xbgr.mr_n71077824)
print v(xbgr.mr_n71078256)
print v(xbgr.mr_n71078576)
print v(xbgr.mr_n71078688)
print v(xbgr.mr_n71079008)
print v(xbgr.mr_n71079120)
print v(xbgr.mr_n71079440)
print v(xbgr.mr_n71079552)
print v(xbgr.mr_n71079872)
print v(xbgr.mr_n71079984)
print v(xbgr.mr_n71080304)
print v(xbgr.mr_n71080416)
print v(xbgr.mr_n71080736)
print v(xbgr.mr_n71080848)
print v(xbgr.mr_n71081280)
print v(xbgr.mr_n71081600)
print v(xbgr.mr_n71081712)
print v(xbgr.mr_n71082032)
print v(xbgr.mr_n71082144)
print v(xbgr.mr_n71082464)
print v(xbgr.mr_n71082576)
print v(xbgr.mr_n71082896)
print v(xbgr.mr_n71083008)
print v(xbgr.mr_n71083328)
print v(xbgr.mr_n71083440)
print v(xbgr.mr_n71083760)
print v(xbgr.mr_n71083872)
print v(xbgr.mr_n71084192)
print v(xbgr.mr_n71084304)
print v(xbgr.mr_n71084624)
print v(xbgr.mr_n71084736)
print v(xbgr.mr_n71085056)
print v(xbgr.mr_n71085168)
print v(xbgr.mr_n71085488)
print v(xbgr.mr_n71085600)
print v(xbgr.mr_n71085920)
print v(xbgr.mr_n71086032)
print v(xbgr.mr_n71086352)
print v(xbgr.mr_n71086464)
print v(xbgr.mr_n71086896)
print v(xbgr.mr_n71087328)
print v(xbgr.mr_n71087760)
print v(xbgr.mr_n71088192)
print v(xbgr.mr_n71088688)
print v(xbgr.mr_n71088800)
print v(xbgr.mr_n71089136)
print v(xbgr.mr_n71089248)
print v(xbgr.mr_n71089568)
print v(xbgr.mr_n71089680)
print v(xbgr.mr_n71090048)
print v(xbgr.mr_n71090160)
print v(xbgr.mr_n71090480)
print v(xbgr.mr_n71090592)
print v(xbgr.mr_n71090912)
print v(xbgr.mr_n71091024)
print v(xbgr.mr_n71091264)
print v(xbgr.mr_n71091376)
print v(xbgr.mr_n71091696)
print v(xbgr.mr_n71091808)
print v(xbgr.mr_n71092128)
print v(xbgr.mr_n71092240)
print v(xbgr.mr_n71092560)
print v(xbgr.mr_n71092672)
print v(xbgr.mr_n71092992)
print v(xbgr.mr_n71093104)
print v(xbgr.mr_n71093424)
print v(xbgr.mr_n71093536)
print v(xbgr.mr_n71093856)
print v(xbgr.mr_n71093968)
print v(xbgr.mr_n71094288)
print v(xbgr.mr_n71094400)
print v(xbgr.mr_n71094720)
print v(xbgr.mr_n71094832)
print v(xbgr.mr_n71095152)
print v(xbgr.mr_n71095264)
print v(xbgr.mr_n71095584)
print v(xbgr.mr_n71095696)
print v(xbgr.mr_n71096016)
print v(xbgr.mr_n71096128)
print v(xbgr.mr_n71096448)
print v(xbgr.mr_n71096560)
print v(xbgr.mr_n71096880)
print v(xbgr.mr_n71096992)
print v(xbgr.mr_n71097312)
print v(xbgr.mr_n71097424)
print v(xbgr.mr_n71097744)
print v(xbgr.mr_n71097856)
print v(xbgr.mr_n71098176)
print v(xbgr.mr_n71098288)
print v(xbgr.mr_n71098608)
print v(xbgr.mr_n71098720)
print v(xbgr.mr_n71099040)
print v(xbgr.mr_n71099152)
print v(xbgr.mr_n71099472)
print v(xbgr.mr_n71099584)
print v(xbgr.mr_n71099904)
print v(xbgr.mr_n71100016)
print v(xbgr.mr_n71100336)
print v(xbgr.mr_n71100448)
print v(xbgr.mr_n71100768)
print v(xbgr.mr_n71100880)
print v(xbgr.mr_n71101200)
print v(xbgr.mr_n71101312)
print v(xbgr.mr_n71101632)
print v(xbgr.mr_n71101744)
print v(xbgr.mr_n71102176)
print v(xbgr.mr_n71102496)
print v(xbgr.mr_n71103488)
print v(xbgr.mr_n71103600)
print v(xbgr.mr_n71103920)
print v(xbgr.mr_n71104032)
print v(xbgr.mr_n71104352)
print v(xbgr.mr_n71104464)
print v(xbgr.mr_n71104896)
print v(xbgr.mr_n71105216)
print v(xbgr.mr_n71105328)
print v(xbgr.mr_n71105648)
print v(xbgr.mr_n71105760)
print v(xbgr.mr_n71106080)
print v(xbgr.mr_n71106192)
print v(xbgr.mr_n71106512)
print v(xbgr.mr_n71106624)
print v(xbgr.mr_n71106944)
print v(xbgr.mr_n71107056)
print v(xbgr.mr_n71107488)
print v(xbgr.mr_n71107920)
print v(xbgr.mr_n71108352)
print v(xbgr.mr_n71108784)
print v(xbgr.mr_n71109104)
print v(xbgr.mr_n71109216)
print v(xbgr.mr_n71109536)
print v(xbgr.mr_n71109648)
print v(xbgr.mr_n71109968)
print v(xbgr.mr_n71110080)
print v(xbgr.mr_n71110512)
print v(xbgr.mr_n71110944)
print v(xbgr.mr_n71111264)
print v(xbgr.mr_n71111376)
print v(xbgr.mr_n71111696)
print v(xbgr.mr_n71111808)
print v(xbgr.mr_n71112128)
print v(xbgr.mr_n71112240)
print v(xbgr.mr_n71112560)
print v(xbgr.mr_n71112672)
print v(xbgr.mr_n71113104)
print v(xbgr.mr_n71113536)
print v(xbgr.mr_n71113968)
print v(xbgr.mr_n71114400)
print v(xbgr.mr_n71114832)
print v(xbgr.mr_n71115152)
print v(xbgr.mr_n71115264)
print v(xbgr.mr_n71115584)
print v(xbgr.mr_n71115696)
print v(xbgr.mr_n71116016)
print v(xbgr.mr_n71116128)
print v(xbgr.mr_n71116448)
print v(xbgr.mr_n71116560)
print v(xbgr.mr_n71116880)
print v(xbgr.mr_n71116992)
print v(xbgr.mr_n71117312)
print v(xbgr.mr_n71117424)
print v(xbgr.mr_n71117744)
print v(xbgr.mr_n71117856)
print v(xbgr.mr_n71118176)
print v(xbgr.mr_n71118288)
print v(xbgr.mr_n71118608)
print v(xbgr.mr_n71118720)
print v(xbgr.mr_n71119040)
print v(xbgr.mr_n71119152)
print v(xbgr.mr_n71119472)
print v(xbgr.mr_n71119584)
print v(xbgr.mr_n71119904)
print v(xbgr.mr_n71120016)
print v(xbgr.mr_n71120448)
print v(xbgr.mr_n71120768)
print v(xbgr.mr_n71120880)
print v(xbgr.mr_n71121200)
print v(xbgr.mr_n71121312)
print v(xbgr.mr_n71121632)
print v(xbgr.mr_n71121744)
print v(xbgr.mr_n71122064)
print v(xbgr.mr_n71122176)
print v(xbgr.mr_n71122496)
print v(xbgr.mr_n71122608)
print v(xbgr.mr_n71123040)
print v(xbgr.mr_n71123472)
print v(xbgr.mr_n71123904)
print v(xbgr.mr_n71124336)
print v(xbgr.mr_n71124656)
print v(xbgr.mr_n71124768)
print v(xbgr.mr_n71125088)
print v(xbgr.mr_n71125200)
print v(xbgr.mr_n71125520)
print v(xbgr.mr_n71125632)
print v(xbgr.mr_n71125952)
print v(xbgr.mr_n71126064)
print v(xbgr.mr_n71126384)
print v(xbgr.mr_n71126496)
print v(xbgr.mr_n71126816)
print v(xbgr.mr_n71126928)
print v(xbgr.mr_n71127248)
print v(xbgr.mr_n71127360)
print v(xbgr.mr_n71127680)
print v(xbgr.mr_n71127792)
print v(xbgr.mr_n71128112)
print v(xbgr.mr_n71128224)
print v(xbgr.mr_n71128544)
print v(xbgr.mr_n71128656)
print v(xbgr.mr_n71128976)
print v(xbgr.mr_n71129088)
print v(xbgr.mr_n71129408)
print v(xbgr.mr_n71129520)
print v(xbgr.mr_n71129840)
print v(xbgr.mr_n71129952)
print v(xbgr.mr_n71130272)
print v(xbgr.mr_n71130384)
print v(xbgr.mr_n71130704)
print v(xbgr.mr_n71130816)
print v(xbgr.mr_n71131136)
print v(xbgr.mr_n71131248)
print v(xbgr.mr_n71131568)
print v(xbgr.mr_n71131680)
print v(xbgr.mr_n71132000)
print v(xbgr.mr_n71132112)
print v(xbgr.mr_n71132432)
print v(xbgr.mr_n71132544)
print v(xbgr.mr_n71132864)
print v(xbgr.mr_n71132976)
print v(xbgr.mr_n71133296)
print v(xbgr.mr_n71133408)
print v(xbgr.mr_n71133728)
print v(xbgr.mr_n71133840)
print v(xbgr.mr_n71134160)
print v(xbgr.mr_n71134272)
print v(xbgr.mr_n71134592)
print v(xbgr.mr_n71134704)
print v(xbgr.mr_n71135024)
print v(xbgr.mr_n71135136)
print v(xbgr.mr_n71135456)
print v(xbgr.mr_n71135568)
print v(xbgr.mr_n71135888)
print v(xbgr.mr_n71136000)
print v(xbgr.mr_n71136320)
print v(xbgr.mr_n71136432)
print v(xbgr.mr_n71136752)
print v(xbgr.mr_n71136864)
print v(xbgr.mr_n71137184)
print v(xbgr.mr_n71137296)
print v(xbgr.mr_n71137616)
print v(xbgr.mr_n71137728)
print v(xbgr.mr_n71138048)
print v(xbgr.mr_n71138160)
print v(xbgr.mr_n71138480)
print v(xbgr.mr_n71138592)
print v(xbgr.mr_n71138912)
print v(xbgr.mr_n71139024)
print v(xbgr.mr_n71139344)
print v(xbgr.mr_n71139456)
print v(xbgr.mr_n71139776)
print v(xbgr.mr_n71139888)
print v(xbgr.mr_n71140208)
print v(xbgr.mr_n71140320)
print v(xbgr.mr_n71140640)
print v(xbgr.mr_n71140752)
print v(xbgr.mr_n71141072)
print v(xbgr.mr_n71141184)
print v(xbgr.mr_n71141504)
print v(xbgr.mr_n71141616)
print v(xbgr.mr_n71141936)
print v(xbgr.mr_n71142048)
print v(xbgr.mr_n71142368)
print v(xbgr.mr_n71142480)
print v(xbgr.mr_n71142800)
print v(xbgr.mr_n71142912)
print v(xbgr.mr_n71143232)
print v(xbgr.mr_n71143344)
print v(xbgr.mr_n71143776)
print v(xbgr.mr_n71144208)
print v(xbgr.mr_n71144528)
print v(xbgr.mr_n71144640)
print v(xbgr.mr_n71144960)
print v(xbgr.mr_n71145072)
print v(xbgr.mr_n71145392)
print v(xbgr.mr_n71145504)
print v(xbgr.mr_n71145824)
print v(xbgr.mr_n71145936)
print v(xbgr.mr_n71146368)
print v(xbgr.mr_n71146800)
print v(xbgr.mr_n71147120)
print v(xbgr.mr_n71147232)
print v(xbgr.mr_n71147552)
print v(xbgr.mr_n71147664)
print v(xbgr.mr_n71147984)
print v(xbgr.mr_n71148096)
print v(xbgr.mr_n71148528)
print v(xbgr.mr_n71148960)
print v(xbgr.mr_n71149392)
print v(xbgr.mr_n71149824)
print v(xbgr.mr_n71150256)
print v(xbgr.mr_n71150688)
print v(xbgr.mr_n71151120)
print v(xbgr.mr_n71151552)
print v(xbgr.mr_n71151984)
print v(xbgr.mr_n71152416)
print v(xbgr.mr_n71152848)
print v(xbgr.mr_n71153280)
print v(xbgr.mr_n71153712)
print v(xbgr.mr_n71154032)
print v(xbgr.mr_n71154464)
print v(xbgr.mr_n71154896)
print v(xbgr.mr_n71155328)
print v(xbgr.mr_n71155760)
print v(xbgr.mr_n71156192)
print v(xbgr.mr_n71156624)
print v(xbgr.mr_n71157056)
print v(xbgr.mr_n71157488)
print v(xbgr.mr_n71157600)
print v(xbgr.mr_n71157920)
print v(xbgr.mr_n71158032)
print v(xbgr.mr_n71158352)
print v(xbgr.mr_n71158464)
print v(xbgr.mr_n71158784)
print v(xbgr.mr_n71158896)
print v(xbgr.mr_n71159216)
print v(xbgr.mr_n71159328)
print v(xbgr.mr_n71159648)
print v(xbgr.mr_n71159760)
print v(xbgr.mr_n71160080)
print v(xbgr.mr_n71160192)
print v(xbgr.mr_n71160512)
print v(xbgr.mr_n71160624)
print v(xbgr.mr_n71160944)
print v(xbgr.mr_n71161376)
print v(xbgr.mr_n71161808)
print v(xbgr.mr_n71162240)
print v(xbgr.mr_n71162672)
print v(xbgr.mr_n71163104)
print v(xbgr.mr_n71163536)
print v(xbgr.mr_n71163968)
print v(xbgr.mr_n71164400)
print v(xbgr.mr_n71164832)
print v(xbgr.mr_n71165376)
print v(xbgr.mr_n71165808)
print v(xbgr.mr_n71166240)
print v(xbgr.mr_n71166672)
print v(xbgr.mr_n71167104)
print v(xbgr.mr_n71167536)
print v(xbgr.mr_n71167968)
print v(xbgr.mr_n71168400)
print v(xbgr.mr_n71168832)
print v(xbgr.mr_n71169264)
print v(xbgr.mr_n71169696)
print v(xbgr.mr_n71170128)
print v(xbgr.mr_n71170560)
print v(xbgr.mr_n71170992)
print v(xbgr.mr_n71171424)
print v(xbgr.mr_n71171856)
print v(xbgr.mr_n71172288)
print v(xbgr.mr_n71172720)
print v(xbgr.mr_n71173152)
print v(xbgr.mr_n71173584)
print v(xbgr.mr_n71174016)
print v(xbgr.mr_n71174448)
print v(xbgr.mr_n71174880)
print v(xbgr.mr_n71175312)
print v(xbgr.mr_n71175744)
print v(xbgr.mr_n71176176)
print v(xbgr.mr_n71176608)
print v(xbgr.mr_n71177040)
print v(xbgr.mr_n71177472)
print v(xbgr.mr_n71177904)
print v(xbgr.mr_n71178336)
print v(xbgr.mr_n71178768)
print v(xbgr.mr_n71179200)
print v(xbgr.mr_n71179632)
print v(xbgr.mr_n71180064)
print v(xbgr.mr_n71180496)
print v(xbgr.mr_n71180928)
print v(xbgr.mr_n71181360)
print v(xbgr.mr_n71181792)
print v(xbgr.mr_n71182224)
print v(xbgr.mr_n71182656)
print v(xbgr.mr_n71183088)
print v(xbgr.mr_n71183520)
print v(xbgr.mr_n71183952)
print v(xbgr.mr_n71184384)
print v(xbgr.mr_n71184816)
print v(xbgr.mr_n71185248)
print v(xbgr.mr_n71185680)
print v(xbgr.mr_n71186112)
print v(xbgr.mr_n71186544)
print v(xbgr.mr_n71186976)
print v(xbgr.mr_n71187408)
print v(xbgr.mr_n71187840)
print v(xbgr.mr_n71188272)
print v(xbgr.mr_n71188704)
print v(xbgr.mr_n71189136)
print v(xbgr.mr_n71189568)
print v(xbgr.mr_n71190000)
print v(xbgr.mr_n71190432)
print v(xbgr.mr_n71190864)
print v(xbgr.mr_n71191296)
print v(xbgr.mr_n71191728)
print v(xbgr.mr_n71192160)
print v(xbgr.mr_n71192592)
print v(xbgr.mr_n71192912)
print v(xbgr.mr_n71193344)
print v(xbgr.mr_n71193776)
print v(xbgr.mr_n71194208)
print v(xbgr.mr_n71194640)
print v(xbgr.mr_n71195072)
print v(xbgr.mr_n71195616)
print v(xbgr.mr_n71196048)
print v(xbgr.mr_n71196480)
print v(xbgr.mr_n71196912)
print v(xbgr.mr_n71197344)
print v(xbgr.mr_n71197776)
print v(xbgr.mr_n71198208)
print v(xbgr.mr_n71198640)
print v(xbgr.mr_n71199072)
print v(xbgr.mr_n71199504)
print v(xbgr.mr_n71199936)
print v(xbgr.mr_n71200368)
print v(xbgr.mr_n71200800)
print v(xbgr.mr_n71201232)
print v(xbgr.mr_n71201664)
print v(xbgr.mr_n71202096)
print v(xbgr.mr_n71202528)
print v(xbgr.mr_n71202960)
print v(xbgr.mr_n71203392)
print v(xbgr.mr_n71203824)
print v(xbgr.mr_n71204256)
print v(xbgr.mr_n71204688)
print v(xbgr.mr_n71205120)
print v(xbgr.mr_n71205552)
print v(xbgr.mr_n71205984)
print v(xbgr.mr_n71206416)
print v(xbgr.mr_n71206736)
print v(xbgr.mr_n71206848)
print v(xbgr.mr_n71207168)
print v(xbgr.mr_n71207280)
print v(xbgr.mr_n71207600)
print v(xbgr.mr_n71207712)
print v(xbgr.mr_n71208032)
print v(xbgr.mr_n71208144)
print v(xbgr.mr_n71208464)
print v(xbgr.mr_n71208576)
print v(xbgr.mr_n71208896)
print v(xbgr.mr_n71209008)
print v(xbgr.mr_n71209328)
print v(xbgr.mr_n71209440)
print v(xbgr.mr_n71209760)
print v(xbgr.mr_n71209872)
print v(xbgr.mr_n71210192)
print v(xbgr.mr_n71210304)
print v(xbgr.mr_n71210624)
print v(xbgr.mr_n71210736)
print v(xbgr.mr_n71211056)
print v(xbgr.mr_n71211168)
print v(xbgr.mr_n71211488)
print v(xbgr.mr_n71211600)
print v(xbgr.mr_n71211920)
print v(xbgr.mr_n71212032)
print v(xbgr.mr_n71212352)
print v(xbgr.mr_n71212464)
print v(xbgr.mr_n71212784)
print v(xbgr.mr_n71212896)
print v(xbgr.mr_n71213216)
print v(xbgr.mr_n71213648)
print v(xbgr.mr_n71213760)
print v(xbgr.mr_n71214080)
print v(xbgr.mr_n71214512)
print v(xbgr.mr_n71214624)
print v(xbgr.mr_n71214944)
print v(xbgr.mr_n71215056)
print v(xbgr.mr_n71215376)
print v(xbgr.mr_n71215488)
print v(xbgr.mr_n71215808)
print v(xbgr.mr_n71215920)
print v(xbgr.mr_n71216240)
print v(xbgr.mr_n71216352)
print v(xbgr.mr_n71216672)
print v(xbgr.mr_n71216784)
print v(xbgr.mr_n71217104)
print v(xbgr.mr_n71217216)
print v(xbgr.mr_n71217536)
print v(xbgr.mr_n71217968)
print v(xbgr.mr_n71218080)
print v(xbgr.mr_n71218400)
print v(xbgr.mr_n71218512)
print v(xbgr.mr_n71218832)
print v(xbgr.mr_n71218944)
print v(xbgr.mr_n71219264)
print v(xbgr.mr_n71219376)
print v(xbgr.mr_n71219696)
print v(xbgr.mr_n71219808)
print v(xbgr.mr_n71220128)
print v(xbgr.mr_n71220240)
print v(xbgr.mr_n71220560)
print v(xbgr.mr_n71220672)
print v(xbgr.mr_n71220992)
print v(xbgr.mr_n71221104)
print v(xbgr.mr_n71221424)
print v(xbgr.mr_n71221536)
print v(xbgr.mr_n71221856)
print v(xbgr.mr_n71221968)
print v(xbgr.mr_n71222288)
print v(xbgr.mr_n71222400)
print v(xbgr.mr_n71222720)
print v(xbgr.mr_n71223152)
print v(xbgr.mr_n71223264)
print v(xbgr.mr_n71223584)
print v(xbgr.mr_n71223696)
print v(xbgr.mr_n71224016)
print v(xbgr.mr_n71224128)
print v(xbgr.mr_n71224448)
print v(xbgr.mr_n71224560)
print v(xbgr.mr_n71224880)
print v(xbgr.mr_n71224992)
print v(xbgr.mr_n71225312)
print v(xbgr.mr_n71225424)
print v(xbgr.mr_n71225744)
print v(xbgr.mr_n71225856)
print v(xbgr.mr_n71226176)
print v(xbgr.mr_n71226288)
print v(xbgr.mr_n71226608)
print v(xbgr.mr_n71226720)
print v(xbgr.mr_n71227040)
print v(xbgr.mr_n71227152)
print v(xbgr.mr_n71227472)
print v(xbgr.mr_n71227584)
print v(xbgr.mr_n71227904)
print v(xbgr.mr_n71228016)
print v(xbgr.mr_n71228336)
print v(xbgr.mr_n71228448)
print v(xbgr.mr_n71228768)
print v(xbgr.mr_n71229200)
print v(xbgr.mr_n71229312)
print v(xbgr.mr_n71229632)
print v(xbgr.mr_n71229744)
print v(xbgr.mr_n71230064)
print v(xbgr.mr_n71230176)
print v(xbgr.mr_n71230496)
print v(xbgr.mr_n71230608)
print v(xbgr.mr_n71230928)
print v(xbgr.mr_n71231040)
print v(xbgr.mr_n71231360)
print v(xbgr.mr_n71231472)
print v(xbgr.mr_n71231792)
print v(xbgr.mr_n71231904)
print v(xbgr.mr_n71232224)
print v(xbgr.mr_n71232656)
print v(xbgr.mr_n71232768)
print v(xbgr.mr_n71233088)
print v(xbgr.mr_n71233520)
print v(xbgr.mr_n71233632)
print v(xbgr.mr_n71233952)
print v(xbgr.mr_n71234064)
print v(xbgr.mr_n71234384)
print v(xbgr.mr_n71234496)
print v(xbgr.mr_n71234816)
print v(xbgr.mr_n71234928)
print v(xbgr.mr_n71235248)
print v(xbgr.mr_n71235360)
print v(xbgr.mr_n71235680)
print v(xbgr.mr_n71235792)
print v(xbgr.mr_n71236112)
print v(xbgr.mr_n71236224)
print v(xbgr.mr_n71236544)
print v(xbgr.mr_n71236656)
print v(xbgr.mr_n71236976)
print v(xbgr.mr_n71237088)
print v(xbgr.mr_n71237408)
print v(xbgr.mr_n71237520)
print v(xbgr.mr_n71237840)
print v(xbgr.mr_n71237952)
print v(xbgr.mr_n71238272)
print v(xbgr.mr_n71238384)
print v(xbgr.mr_n71238816)
print v(xbgr.mr_n71239248)
print v(xbgr.mr_n71239680)
print v(xbgr.mr_n71240112)
print v(xbgr.mr_n71240544)
print v(xbgr.mr_n71240976)
print v(xbgr.mr_n71241408)
print v(xbgr.mr_n71241840)
print v(xbgr.mr_n71242272)
print v(xbgr.mr_n71242704)
print v(xbgr.mr_n71243136)
print v(xbgr.mr_n71243568)
print v(xbgr.mr_n71244000)
print v(xbgr.mr_n71244432)
print v(xbgr.mr_n71244864)
print v(xbgr.mr_n71245296)
print v(xbgr.mr_n71245728)
print v(xbgr.mr_n71246160)
print v(xbgr.mr_n71246592)
print v(xbgr.mr_n71247024)
print v(xbgr.mr_n71247456)
print v(xbgr.mr_n71247888)
print v(xbgr.mr_n71248320)
print v(xbgr.mr_n71248752)
print v(xbgr.mr_n71249184)
print v(xbgr.mr_n71249616)
print v(xbgr.mr_n71250048)
print v(xbgr.mr_n71250480)
print v(xbgr.mr_n71250912)
print v(xbgr.mr_n71251344)
print v(xbgr.mr_n71251776)
print v(xbgr.mr_n71252208)
print v(xbgr.mr_n71252640)
print v(xbgr.mr_n71253072)
print v(xbgr.mr_n71253504)
print v(xbgr.mr_n71253936)
print v(xbgr.mr_n71254368)
print v(xbgr.mr_n71254800)
print v(xbgr.mr_n71255232)
print v(xbgr.mr_n71255664)
print v(xbgr.mr_n71256096)
print v(xbgr.mr_n71256528)
print v(xbgr.mr_n71256960)
print v(xbgr.mr_n71257392)
print v(xbgr.mr_n71257824)
print v(xbgr.mr_n71258256)
print v(xbgr.mr_n71258688)
print v(xbgr.mr_n71259120)
print v(xbgr.mr_n71259552)
print v(xbgr.mr_n71259984)
print v(xbgr.mr_n71260416)
print v(xbgr.mr_n71260848)
print v(xbgr.mr_n71261280)
print v(xbgr.mr_n71261712)
print v(xbgr.mr_n71262144)
print v(xbgr.mr_n71262576)
print v(xbgr.mr_n71263008)
print v(xbgr.mr_n71263440)
print v(xbgr.mr_n71263872)
print v(xbgr.mr_n71264304)
print v(xbgr.mr_n71264736)
print v(xbgr.mr_n71265168)
print v(xbgr.mr_n71265600)
print v(xbgr.mr_n71266032)
print v(xbgr.mr_n71266464)
print v(xbgr.mr_n71266896)
print v(xbgr.mr_n71267328)
print v(xbgr.mr_n71267760)
print v(xbgr.mr_n71268192)
print v(xbgr.mr_n71268624)
print v(xbgr.mr_n71269056)
print v(xbgr.mr_n71269488)
print v(xbgr.mr_n71269920)
print v(xbgr.mr_n71270352)
print v(xbgr.mr_n71270784)
print v(xbgr.mr_n71271216)
print v(xbgr.mr_n71271648)
print v(xbgr.mr_n71272080)
print v(xbgr.mr_n71272400)
print v(xbgr.mr_n71272512)
print v(xbgr.mr_n71272832)
print v(xbgr.mr_n71272944)
print v(xbgr.mr_n71273376)
print v(xbgr.mr_n71273808)
print v(xbgr.mr_n71274128)
print v(xbgr.mr_n71274240)
print v(xbgr.mr_n71274560)
print v(xbgr.mr_n71275104)
print v(xbgr.mr_n71275536)
print v(xbgr.mr_n71275856)
print v(xbgr.mr_n71275968)
print v(xbgr.mr_n71276288)
print v(xbgr.mr_n71276400)
print v(xbgr.mr_n71276720)
print v(xbgr.mr_n71276832)
print v(xbgr.mr_n71277152)
print v(xbgr.mr_n71277264)
print v(xbgr.mr_n71277584)
print v(xbgr.mr_n71277696)
print v(xbgr.mr_n71278016)
print v(xbgr.mr_n71278128)
print v(xbgr.mr_n71278448)
print v(xbgr.mr_n71278560)
print v(xbgr.mr_n71278880)
print v(xbgr.mr_n71278992)
print v(xbgr.mr_n71279312)
print v(xbgr.mr_n71279424)
print v(xbgr.mr_n71279744)
print v(xbgr.mr_n71279856)
print v(xbgr.mr_n71280176)
print v(xbgr.mr_n71280288)
print v(xbgr.mr_n71280608)
print v(xbgr.mr_n71280720)
print v(xbgr.mr_n71281152)
print v(xbgr.mr_n71281584)
print v(xbgr.mr_n71281904)
print v(xbgr.mr_n71282016)
print v(xbgr.mr_n71282336)
print v(xbgr.mr_n71282448)
print v(xbgr.mr_n71282880)
print v(xbgr.mr_n71283312)
print v(xbgr.mr_n71283744)
print v(xbgr.mr_n71284176)
print v(xbgr.mr_n71284608)
print v(xbgr.mr_n71285040)
print v(xbgr.mr_n71285472)
print v(xbgr.mr_n71285904)
print v(xbgr.mr_n71286336)
print v(xbgr.mr_n71286768)
print v(xbgr.mr_n71287200)
print v(xbgr.mr_n71287632)
print v(xbgr.mr_n71288064)
print v(xbgr.mr_n71288496)
print v(xbgr.mr_n71288928)
print v(xbgr.mr_n71289360)
print v(xbgr.mr_n71289792)
print v(xbgr.mr_n71290224)
print v(xbgr.mr_n71290656)
print v(xbgr.mr_n71291088)
print v(xbgr.mr_n71291520)
print v(xbgr.mr_n71291952)
print v(xbgr.mr_n71292384)
print v(xbgr.mr_n71292816)
print v(xbgr.mr_n71293248)
print v(xbgr.mr_n71293680)
print v(xbgr.mr_n71294112)
print v(xbgr.mr_n71294544)
print v(xbgr.mr_n71294976)
print v(xbgr.mr_n71295408)
print v(xbgr.mr_n71295840)
print v(xbgr.mr_n71296272)
print v(xbgr.mr_n71296704)
print v(xbgr.mr_n71297136)
print v(xbgr.mr_n71297568)
print v(xbgr.mr_n71298000)
print v(xbgr.mr_n71298432)
print v(xbgr.mr_n71298864)
print v(xbgr.mr_n71299296)
print v(xbgr.mr_n71299728)
print v(xbgr.mr_n71300160)
print v(xbgr.mr_n71300592)
print v(xbgr.mr_n71301024)
print v(xbgr.mr_n71301456)
print v(xbgr.mr_n71301888)
print v(xbgr.mr_n71302320)
print v(xbgr.mr_n71302752)
print v(xbgr.mr_n71303184)
print v(xbgr.mr_n71303616)
print v(xbgr.mr_n71304048)
print v(xbgr.mr_n71304480)
print v(xbgr.mr_n71304912)
print v(xbgr.mr_n71305344)
print v(xbgr.mr_n71305776)
print v(xbgr.mr_n71306208)
print v(xbgr.mr_n71306640)
print v(xbgr.mr_n71307072)
print v(xbgr.mr_n71307504)
print v(xbgr.mr_n71307936)
print v(xbgr.mr_n71308368)
print v(xbgr.mr_n71308800)
print v(xbgr.mr_n71309232)
print v(xbgr.mr_n71309664)
print v(xbgr.mr_n71310096)
print v(xbgr.mr_n71310528)
print v(xbgr.mr_n71310960)
print v(xbgr.mr_n71311392)
print v(xbgr.mr_n71311824)
print v(xbgr.mr_n71312256)
print v(xbgr.mr_n71312688)
print v(xbgr.mr_n71313120)
print v(xbgr.mr_n71313552)
print v(xbgr.mr_n71313984)
print v(xbgr.mr_n71314416)
print v(xbgr.mr_n71314848)
print v(xbgr.mr_n71315280)
print v(xbgr.mr_n71315712)
print v(xbgr.mr_n71316144)
print v(xbgr.mr_n71316576)
print v(xbgr.mr_n71317008)
print v(xbgr.mr_n71317440)
print v(xbgr.mr_n71317872)
print v(xbgr.mr_n71318304)
print v(xbgr.mr_n71318736)
print v(xbgr.mr_n71319168)
print v(xbgr.mr_n71319600)
print v(xbgr.mr_n71320032)
print v(xbgr.mr_n71320464)
print v(xbgr.mr_n71320896)
print v(xbgr.mr_n71321328)
print v(xbgr.mr_n71321760)
print v(xbgr.mr_n71322192)
print v(xbgr.mr_n71322624)
print v(xbgr.mr_n71323056)
print v(xbgr.mr_n71323488)
print v(xbgr.mr_n71323920)
print v(xbgr.mr_n71324352)
print v(xbgr.mr_n71324784)
print v(xbgr.mr_n71325216)
print v(xbgr.mr_n71325648)
print v(xbgr.mr_n71326080)
print v(xbgr.mr_n71326512)
print v(xbgr.mr_n71326944)
print v(xbgr.mr_n71327376)
print v(xbgr.mr_n71327808)
print v(xbgr.mr_n71328240)
print v(xbgr.mr_n71328672)
print v(xbgr.mr_n71329104)
print v(xbgr.mr_n71329536)
print v(xbgr.mr_n71329968)
print v(xbgr.mr_n71330400)
print v(xbgr.mr_n71330832)
print v(xbgr.mr_n71331264)
print v(xbgr.mr_n71331696)
print v(xbgr.mr_n71332128)
print v(xbgr.mr_n71332560)
print v(xbgr.mr_n71332992)
print v(xbgr.mr_n71333424)
print v(xbgr.mr_n71333856)
print v(xbgr.mr_n71334288)
print v(xbgr.mr_n71334720)
print v(xbgr.mr_n71335152)
print v(xbgr.mr_n71335584)
print v(xbgr.mr_n71336016)
print v(xbgr.mr_n71336448)
print v(xbgr.mr_n71336880)
print v(xbgr.mr_n71337312)
print v(xbgr.mr_n71337744)
print v(xbgr.mr_n71338176)
print v(xbgr.mr_n71338608)
print v(xbgr.mr_n71339040)
print v(xbgr.mr_n71339472)
print v(xbgr.mr_n71339904)
print v(xbgr.mr_n71340336)
print v(xbgr.mr_n71340768)
print v(xbgr.mr_n71341200)
print v(xbgr.mr_n71341520)
print v(xbgr.mr_n71341632)
print v(xbgr.mr_n71341952)
print v(xbgr.mr_n71342064)
print v(xbgr.mr_n71342384)
print v(xbgr.mr_n71342496)
print v(xbgr.mr_n71342816)
print v(xbgr.mr_n71342928)
print v(xbgr.mr_n71343248)
print v(xbgr.mr_n71343360)
print v(xbgr.mr_n71343680)
print v(xbgr.mr_n71343792)
print v(xbgr.mr_n71344112)
print v(xbgr.mr_n71344224)
print v(xbgr.mr_n71344544)
print v(xbgr.mr_n71344656)
print v(xbgr.mr_n71344976)
print v(xbgr.mr_n71345088)
print v(xbgr.mr_n71345408)
print v(xbgr.mr_n71345520)
print v(xbgr.mr_n71345840)
print v(xbgr.mr_n71345952)
print v(xbgr.mr_n71346272)
print v(xbgr.mr_n71346384)
print v(xbgr.mr_n71346704)
print v(xbgr.mr_n71346816)
print v(xbgr.mr_n71347136)
print v(xbgr.mr_n71347248)
print v(xbgr.mr_n71347568)
print v(xbgr.mr_n71347680)
print v(xbgr.mr_n71348000)
print v(xbgr.mr_n71348112)
print v(xbgr.mr_n71348432)
print v(xbgr.mr_n71348544)
print v(xbgr.mr_n71348864)
print v(xbgr.mr_n71348976)
print v(xbgr.mr_n71349296)
print v(xbgr.mr_n71349408)
print v(xbgr.mr_n71349728)
print v(xbgr.mr_n71349840)
print v(xbgr.mr_n71350160)
print v(xbgr.mr_n71350272)
print v(xbgr.mr_n71350592)
print v(xbgr.mr_n71350704)
print v(xbgr.mr_n71351024)
print v(xbgr.mr_n71351136)
print v(xbgr.mr_n71351456)
print v(xbgr.mr_n71351568)
print v(xbgr.mr_n71351888)
print v(xbgr.mr_n71352000)
print v(xbgr.mr_n71352320)
print v(xbgr.mr_n71352432)
print v(xbgr.mr_n71352752)
print v(xbgr.mr_n71352864)
print v(xbgr.mr_n71353184)
print v(xbgr.mr_n71353296)
print v(xbgr.mr_n71353616)
print v(xbgr.mr_n71353728)
print v(xbgr.mr_n71354048)
print v(xbgr.mr_n71354160)
print v(xbgr.mr_n71354592)
print v(xbgr.mr_n71355024)
print v(xbgr.mr_n71355456)
print v(xbgr.mr_n71355888)
print v(xbgr.mr_n71356208)
print v(xbgr.mr_n71356320)
print v(xbgr.mr_n71356640)
print v(xbgr.mr_n71356752)
print v(xbgr.mr_n71357072)
print v(xbgr.mr_n71357184)
print v(xbgr.mr_n71357504)
print v(xbgr.mr_n71357616)
print v(xbgr.mr_n71357936)
print v(xbgr.mr_n71358048)
print v(xbgr.mr_n71358368)
print v(xbgr.mr_n71358480)
print v(xbgr.mr_n71358912)
print v(xbgr.mr_n71359344)
print v(xbgr.mr_n71359776)
print v(xbgr.mr_n71360096)
print v(xbgr.mr_n71360208)
print v(xbgr.mr_n71360528)
print v(xbgr.mr_n71360640)
print v(xbgr.mr_n71360960)
print v(xbgr.mr_n71361072)
print v(xbgr.mr_n71361392)
print v(xbgr.mr_n71361504)
print v(xbgr.mr_n71361824)
print v(xbgr.mr_n71361936)
print v(xbgr.mr_n71362256)
print v(xbgr.mr_n71362368)
print v(xbgr.mr_n71362688)
print v(xbgr.mr_n71362800)
print v(xbgr.mr_n71363120)
print v(xbgr.mr_n71363232)
print v(xbgr.mr_n71363552)
print v(xbgr.mr_n71363664)
print v(xbgr.mr_n71363984)
print v(xbgr.mr_n71364096)
print v(xbgr.mr_n71364528)
print v(xbgr.mr_n71364960)
print v(xbgr.mr_n71365392)
print v(xbgr.mr_n71365824)
print v(xbgr.mr_n71366256)
print v(xbgr.mr_n71366688)
print v(xbgr.mr_n71367120)
print v(xbgr.mr_n71367552)
print v(xbgr.mr_n71367984)
print v(xbgr.mr_n71368416)
print v(xbgr.mr_n71368848)
print v(xbgr.mr_n71369280)
print v(xbgr.mr_n71369712)
print v(xbgr.mr_n71370032)
print v(xbgr.mr_n71370144)
print v(xbgr.mr_n71370464)
print v(xbgr.mr_n71370576)
print v(xbgr.mr_n71370896)
print v(xbgr.mr_n71371008)
print v(xbgr.mr_n71371328)
print v(xbgr.mr_n71371440)
print v(xbgr.mr_n71371760)
print v(xbgr.mr_n71371872)
print v(xbgr.mr_n71372304)
print v(xbgr.mr_n71372736)
print v(xbgr.mr_n71373168)
print v(xbgr.mr_n71373600)
print v(xbgr.mr_n71374032)
print v(xbgr.mr_n71374464)
print v(xbgr.mr_n71374784)
print v(xbgr.mr_n71374896)
print v(xbgr.mr_n71375216)
print v(xbgr.mr_n71375328)
print v(xbgr.mr_n71375760)
print v(xbgr.mr_n71376192)
print v(xbgr.mr_n71376512)
print v(xbgr.mr_n71376624)
print v(xbgr.mr_n71376944)
print v(xbgr.mr_n71377056)
print v(xbgr.mr_n71377376)
print v(xbgr.mr_n71377488)
print v(xbgr.mr_n71377808)
print v(xbgr.mr_n71377920)
print v(xbgr.mr_n71378240)
print v(xbgr.mr_n71378352)
print v(xbgr.mr_n71378672)
print v(xbgr.mr_n71378784)
print v(xbgr.mr_n71379104)
print v(xbgr.mr_n71379216)
print v(xbgr.mr_n71379536)
print v(xbgr.mr_n71379648)
print v(xbgr.mr_n71379968)
print v(xbgr.mr_n71380080)
print v(xbgr.mr_n71380400)
print v(xbgr.mr_n71380512)
print v(xbgr.mr_n71380832)
print v(xbgr.mr_n71380944)
print v(xbgr.mr_n71381264)
print v(xbgr.mr_n71381376)
print v(xbgr.mr_n71381696)
print v(xbgr.mr_n71381808)
print v(xbgr.mr_n71382128)
print v(xbgr.mr_n71382240)
print v(xbgr.mr_n71382672)
print v(xbgr.mr_n71383104)
print v(xbgr.mr_n71383424)
print v(xbgr.mr_n71383536)
print v(xbgr.mr_n71383856)
print v(xbgr.mr_n71383968)
print v(xbgr.mr_n71384288)
print v(xbgr.mr_n71384400)
print v(xbgr.mr_n71384720)
print v(xbgr.mr_n71384832)
print v(xbgr.mr_n71385152)
print v(xbgr.mr_n71385264)
print v(xbgr.mr_n71385584)
print v(xbgr.mr_n71385696)
print v(xbgr.mr_n71386128)
print v(xbgr.mr_n71386560)
print v(xbgr.mr_n71386880)
print v(xbgr.mr_n71386992)
print v(xbgr.mr_n71387312)
print v(xbgr.mr_n71387424)
print v(xbgr.mr_n71387744)
print v(xbgr.mr_n71387856)
print v(xbgr.mr_n71388176)
print v(xbgr.mr_n71388288)
print v(xbgr.mr_n71388608)
print v(xbgr.mr_n71388720)
print v(xbgr.mr_n71389040)
print v(xbgr.mr_n71389152)
print v(xbgr.mr_n71389472)
print v(xbgr.mr_n71389584)
print v(xbgr.mr_n71389904)
print v(xbgr.mr_n71390016)
print v(xbgr.mr_n71390336)
print v(xbgr.mr_n71390448)
print v(xbgr.mr_n71390768)
print v(xbgr.mr_n71390880)
print v(xbgr.mr_n71391200)
print v(xbgr.mr_n71391312)
print v(xbgr.mr_n71391632)
print v(xbgr.mr_n71391744)
print v(xbgr.mr_n71392064)
print v(xbgr.mr_n71392176)
print v(xbgr.mr_n71392496)
print v(xbgr.mr_n71392608)
print v(xbgr.mr_n71392928)
print v(xbgr.mr_n71393040)
print v(xbgr.mr_n71393360)
print v(xbgr.mr_n71393472)
print v(xbgr.mr_n71393792)
print v(xbgr.mr_n71393904)
print v(xbgr.mr_n71394224)
print v(xbgr.mr_n71394336)
print v(xbgr.mr_n71394656)
print v(xbgr.mr_n71394768)
print v(xbgr.mr_n71395088)
print v(xbgr.mr_n71395200)
print v(xbgr.mr_n71395520)
print v(xbgr.mr_n71395632)
print v(xbgr.mr_n71395952)
print v(xbgr.mr_n71396064)
print v(xbgr.mr_n71396384)
print v(xbgr.mr_n71396496)
print v(xbgr.mr_n71396816)
print v(xbgr.mr_n71396928)
print v(xbgr.mr_n71397248)
print v(xbgr.mr_n71397360)
print v(xbgr.mr_n71397680)
print v(xbgr.mr_n71397792)
print v(xbgr.mr_n71398112)
print v(xbgr.mr_n71398224)
print v(xbgr.mr_n71398544)
print v(xbgr.mr_n71398656)
print v(xbgr.mr_n71398976)
print v(xbgr.mr_n71399088)
print v(xbgr.mr_n71399408)
print v(xbgr.mr_n71399520)
print v(xbgr.mr_n71399840)
print v(xbgr.mr_n71399952)
print v(xbgr.mr_n71400272)
print v(xbgr.mr_n71400384)
print v(xbgr.mr_n71400704)
print v(xbgr.mr_n71400816)
print v(xbgr.mr_n71401136)
print v(xbgr.mr_n71401248)
print v(xbgr.mr_n71401568)
print v(xbgr.mr_n71401680)
print v(xbgr.mr_n71402000)
print v(xbgr.mr_n71402112)
print v(xbgr.mr_n71402432)
print v(xbgr.mr_n71402544)
print v(xbgr.mr_n71402864)
print v(xbgr.mr_n71402976)
print v(xbgr.mr_n71403296)
print v(xbgr.mr_n71403408)
print v(xbgr.mr_n71403728)
print v(xbgr.mr_n71403840)
print v(xbgr.mr_n71404160)
print v(xbgr.mr_n71404272)
print v(xbgr.mr_n71404592)
print v(xbgr.mr_n71404704)
print v(xbgr.mr_n71405024)
print v(xbgr.mr_n71405136)
print v(xbgr.mr_n71405456)
print v(xbgr.mr_n71405568)
print v(xbgr.mr_n71405888)
print v(xbgr.mr_n71406000)
print v(xbgr.mr_n71406320)
print v(xbgr.mr_n71406432)
print v(xbgr.mr_n71406752)
print v(xbgr.mr_n71406864)
print v(xbgr.mr_n71407184)
print v(xbgr.mr_n71407296)
print v(xbgr.mr_n71407616)
print v(xbgr.mr_n71407728)
print v(xbgr.mr_n71408048)
print v(xbgr.mr_n71408160)
print v(xbgr.mr_n71408480)
print v(xbgr.mr_n71408592)
print v(xbgr.mr_n71408912)
print v(xbgr.mr_n71409024)
print v(xbgr.mr_n71409344)
print v(xbgr.mr_n71409456)
print v(xbgr.mr_n71409776)
print v(xbgr.mr_n71409888)
print v(xbgr.mr_n71410208)
print v(xbgr.mr_n71410320)
print v(xbgr.mr_n71410640)
print v(xbgr.mr_n71410752)
print v(xbgr.mr_n71411072)
print v(xbgr.mr_n71411184)
print v(xbgr.mr_n71411504)
print v(xbgr.mr_n71411616)
print v(xbgr.mr_n71411936)
print v(xbgr.mr_n71412048)
print v(xbgr.mr_n71412368)
print v(xbgr.mr_n71412480)
print v(xbgr.mr_n71412800)
print v(xbgr.mr_n71412912)
print v(xbgr.mr_n71413232)
print v(xbgr.mr_n71413344)
print v(xbgr.mr_n71413664)
print v(xbgr.mr_n71413776)
print v(xbgr.mr_n71414096)
print v(xbgr.mr_n71414208)
print v(xbgr.mr_n71414528)
print v(xbgr.mr_n71414640)
print v(xbgr.mr_n71414960)
print v(xbgr.mr_n71415072)
print v(xbgr.mr_n71415392)
print v(xbgr.mr_n71415504)
print v(xbgr.mr_n71415824)
print v(xbgr.mr_n71415936)
print v(xbgr.mr_n71416256)
print v(xbgr.mr_n71416368)
print v(xbgr.mr_n71416688)
print v(xbgr.mr_n71416800)
print v(xbgr.mr_n71417120)
print v(xbgr.mr_n71417232)
print v(xbgr.mr_n71417552)
print v(xbgr.mr_n71417664)
print v(xbgr.mr_n71417984)
print v(xbgr.mr_n71418096)
print v(xbgr.mr_n71418416)
print v(xbgr.mr_n71418528)
print v(xbgr.mr_n71418848)
print v(xbgr.mr_n71418960)
print v(xbgr.mr_n71419280)
print v(xbgr.mr_n71419392)
print v(xbgr.mr_n71419712)
print v(xbgr.mr_n71419824)
print v(xbgr.mr_n71420144)
print v(xbgr.mr_n71420256)
print v(xbgr.mr_n71420576)
print v(xbgr.mr_n71420688)
print v(xbgr.mr_n71421008)
print v(xbgr.mr_n71421120)
print v(xbgr.mr_n71421440)
print v(xbgr.mr_n71421552)
print v(xbgr.mr_n71421872)
print v(xbgr.mr_n71421984)
print v(xbgr.mr_n71422304)
print v(xbgr.mr_n71422416)
print v(xbgr.mr_n71422736)
print v(xbgr.mr_n71422848)
print v(xbgr.mr_n71423168)
print v(xbgr.mr_n71423280)
print v(xbgr.mr_n71423600)
print v(xbgr.mr_n71423712)
print v(xbgr.mr_n71424032)
print v(xbgr.mr_n71424144)
print v(xbgr.mr_n71424464)
print v(xbgr.mr_n71424576)
print v(xbgr.mr_n71424896)
print v(xbgr.mr_n71425008)
print v(xbgr.mr_n71425328)
print v(xbgr.mr_n71425440)
print v(xbgr.mr_n71425760)
print v(xbgr.mr_n71425872)
print v(xbgr.mr_n71426192)
print v(xbgr.mr_n71426304)
print v(xbgr.mr_n71426624)
print v(xbgr.mr_n71426736)
print v(xbgr.mr_n71427056)
print v(xbgr.mr_n71427168)
print v(xbgr.mr_n71427488)
print v(xbgr.mr_n71427600)
print v(xbgr.mr_n71427920)
print v(xbgr.mr_n71428032)
print v(xbgr.mr_n71428352)
print v(xbgr.mr_n71428464)
print v(xbgr.mr_n71428784)
print v(xbgr.mr_n71428896)
print v(xbgr.mr_n71429216)
print v(xbgr.mr_n71429328)
print v(xbgr.mr_n71429648)
print v(xbgr.mr_n71429760)
print v(xbgr.mr_n71430080)
print v(xbgr.mr_n71430192)
print v(xbgr.mr_n71430512)
print v(xbgr.mr_n71430624)
print v(xbgr.mr_n71430944)
print v(xbgr.mr_n71431056)
print v(xbgr.mr_n71431376)
print v(xbgr.mr_n71431488)
print v(xbgr.mr_n71431808)
print v(xbgr.mr_n71431920)
print v(xbgr.mr_n71432240)
print v(xbgr.mr_n71432352)
print v(xbgr.mr_n71432672)
print v(xbgr.mr_n71432784)
print v(xbgr.mr_n71433104)
print v(xbgr.mr_n71433216)
print v(xbgr.mr_n71433536)
print v(xbgr.mr_n71433648)
print v(xbgr.mr_n71433968)
print v(xbgr.mr_n71434080)
print v(xbgr.mr_n71434400)
print v(xbgr.mr_n71434512)
print v(xbgr.mr_n71434832)
print v(xbgr.mr_n71434944)
print v(xbgr.mr_n71435264)
print v(xbgr.mr_n71435376)
print v(xbgr.mr_n71435696)
print v(xbgr.mr_n71435808)
print v(xbgr.mr_n71436128)
print v(xbgr.mr_n71436240)
print v(xbgr.mr_n71436560)
print v(xbgr.mr_n71436672)
print v(xbgr.mr_n71436992)
print v(xbgr.mr_n71437104)
print v(xbgr.mr_n71437536)
print v(xbgr.mr_n71437968)
print v(xbgr.mr_n71438400)
print v(xbgr.mr_n71438832)
print v(xbgr.mr_n71439264)
print v(xbgr.mr_n71439696)
print v(xbgr.mr_n71440128)
print v(xbgr.mr_n71440560)
print v(xbgr.mr_n71440992)
print v(xbgr.mr_n71441424)
print v(xbgr.mr_n71441856)
print v(xbgr.mr_n71442288)
print v(xbgr.mr_n71442720)
print v(xbgr.mr_n71443152)
print v(xbgr.mr_n71443584)
print v(xbgr.mr_n71444016)
print v(xbgr.mr_n71444448)
print v(xbgr.mr_n71444880)
print v(xbgr.mr_n71445312)
print v(xbgr.mr_n71445744)
print v(xbgr.mr_n71446176)
print v(xbgr.mr_n71446608)
print v(xbgr.mr_n71447040)
print v(xbgr.mr_n71447472)
print v(xbgr.mr_n71447904)
print v(xbgr.mr_n71448336)
print v(xbgr.mr_n71448768)
print v(xbgr.mr_n71449200)
print v(xbgr.mr_n71449632)
print v(xbgr.mr_n71450064)
print v(xbgr.mr_n71450496)
print v(xbgr.mr_n71450928)
print v(xbgr.mr_n71451360)
print v(xbgr.mr_n71451792)
print v(xbgr.mr_n71452112)
print v(xbgr.mr_n71452224)
print v(xbgr.mr_n71452544)
print v(xbgr.mr_n71452656)
print v(xbgr.mr_n71453088)
print v(xbgr.mr_n71453408)
print v(xbgr.mr_n71453520)
print v(xbgr.mr_n71453840)
print v(xbgr.mr_n71453952)
print v(xbgr.mr_n71454272)
print v(xbgr.mr_n71454384)
print v(xbgr.mr_n71454704)
print v(xbgr.mr_n71454816)
print v(xbgr.mr_n71455136)
print v(xbgr.mr_n71455248)
print v(xbgr.mr_n71455568)
print v(xbgr.mr_n71455680)
print v(xbgr.mr_n71456000)
print v(xbgr.mr_n71456112)
print v(xbgr.mr_n71456432)
print v(xbgr.mr_n71456544)
print v(xbgr.mr_n71456976)
print v(xbgr.mr_n71457408)
print v(xbgr.mr_n71457840)
print v(xbgr.mr_n71458272)
print v(xbgr.mr_n71458704)
print v(xbgr.mr_n71459136)
print v(xbgr.mr_n71459568)
print v(xbgr.mr_n71460000)
print v(xbgr.mr_n71460432)
print v(xbgr.mr_n71460752)
print v(xbgr.mr_n71460864)
print v(xbgr.mr_n71461184)
print v(xbgr.mr_n71461296)
print v(xbgr.mr_n71461616)
print v(xbgr.mr_n71461728)
print v(xbgr.mr_n71462048)
print v(xbgr.mr_n71462160)
print v(xbgr.mr_n71462592)
print v(xbgr.mr_n71463024)
print v(xbgr.mr_n71463456)
print v(xbgr.mr_n71463888)
print v(xbgr.mr_n71464320)
print v(xbgr.mr_n71464752)
print v(xbgr.mr_n71465184)
print v(xbgr.mr_n71465616)
print v(xbgr.mr_n71466048)
print v(xbgr.mr_n71466480)
print v(xbgr.mr_n71466912)
print v(xbgr.mr_n71467344)
print v(xbgr.mr_n71467776)
print v(xbgr.mr_n71468208)
print v(xbgr.mr_n71468640)
print v(xbgr.mr_n71469072)
print v(xbgr.mr_n71469504)
print v(xbgr.mr_n71469936)
print v(xbgr.mr_n71470368)
print v(xbgr.mr_n71470800)
print v(xbgr.mr_n71471232)
print v(xbgr.mr_n71471664)
print v(xbgr.mr_n71472096)
print v(xbgr.mr_n71472528)
print v(xbgr.mr_n71472960)
print v(xbgr.mr_n71473392)
print v(xbgr.mr_n71473824)
print v(xbgr.mr_n71474256)
print v(xbgr.mr_n71474688)
print v(xbgr.mr_n71475008)
print v(xbgr.mr_n71475120)
print v(xbgr.mr_n71475440)
print v(xbgr.mr_n71475552)
print v(xbgr.mr_n71475872)
print v(xbgr.mr_n71475984)
print v(xbgr.mr_n71476304)
print v(xbgr.mr_n71476416)
print v(xbgr.mr_n71476736)
print v(xbgr.mr_n71476848)
print v(xbgr.mr_n71477168)
print v(xbgr.mr_n71477280)
print v(xbgr.mr_n71739760)
print v(xbgr.mr_n71740544)
print v(xbgr.mr_n71741408)
print v(xbgr.mr_n71741520)
print v(xbgr.mr_n71741840)
print v(xbgr.mr_n71742272)
print v(xbgr.mr_n71742704)
print v(xbgr.mr_n71743136)
print v(xbgr.mr_n71743248)
print v(xbgr.mr_n71743568)
print v(xbgr.mr_n71744000)
print v(xbgr.mr_n71744432)
print v(xbgr.mr_n71744864)
print v(xbgr.mr_n71744976)
print v(xbgr.mr_n71745296)
print v(xbgr.mr_n71745408)
print v(xbgr.mr_n71745728)
print v(xbgr.mr_n71745840)
print v(xbgr.mr_n71746272)
print v(xbgr.mr_n71746704)
print v(xbgr.mr_n71747136)
print v(xbgr.mr_n71747456)
print v(xbgr.mr_n71748320)
print v(xbgr.mr_n71748432)
print v(xbgr.mr_n71748752)
print v(xbgr.mr_n71748864)
print v(xbgr.mr_n71749184)
print v(xbgr.mr_n71750160)
print v(xbgr.mr_n71750592)
print v(xbgr.mr_n71750912)
print v(xbgr.mr_n71751776)
print v(xbgr.mr_n71751888)
print v(xbgr.mr_n71752208)
print v(xbgr.mr_n71752320)
print v(xbgr.mr_n71752640)
print v(xbgr.mr_n71752752)
print v(xbgr.mr_n71755248)
print v(xbgr.mr_n71755680)
print v(xbgr.mr_n71756000)
print v(xbgr.mr_n71756976)
print v(xbgr.mr_n71757296)
print v(xbgr.mr_n71758272)
print v(xbgr.mr_n71758592)
print v(xbgr.mr_n71759568)
print v(xbgr.mr_n71759888)
print v(xbgr.mr_n71760000)
print v(xbgr.mr_n71760432)
print v(xbgr.mr_n71760864)
print v(xbgr.mr_n71761184)
print v(xbgr.mr_n71762160)
print v(xbgr.mr_n71762480)
print v(xbgr.mr_n71763456)
print v(xbgr.mr_n71763776)
print v(xbgr.mr_n71764752)
print v(xbgr.mr_n71765184)
print v(xbgr.mr_n71765616)
print v(xbgr.mr_n71766048)
print v(xbgr.mr_n71766480)
print v(xbgr.mr_n71766912)
print v(xbgr.mr_n71767344)
print v(xbgr.mr_n71767776)
print v(xbgr.mr_n71768208)
print v(xbgr.mr_n71768640)
print v(xbgr.mr_n71769072)
print v(xbgr.mr_n71769504)
print v(xbgr.mr_n71769936)
print v(xbgr.mr_n71770368)
print v(xbgr.mr_n71770800)
print v(xbgr.mr_n71771232)
print v(xbgr.mr_n71771664)
print v(xbgr.mr_n71772096)
print v(xbgr.mr_n71772528)
print v(xbgr.mr_n71772960)
print v(xbgr.mr_n71773392)
print v(xbgr.mr_n71773824)
print v(xbgr.mr_n71774256)
print v(xbgr.mr_n71774688)
print v(xbgr.mr_n71775120)
print v(xbgr.mr_n71835072)
print v(xbgr.mr_n71839040)
print v(xbgr.mr_n71839552)
print v(xbgr.mr_n71840128)
print v(xbgr.mr_n71840864)
print v(xbgr.mr_n71842544)
print v(xbgr.mr_n71844896)
print v(xbgr.mr_n71845728)
print v(xbgr.mr_n71846128)
print v(xbgr.mr_n71846480)
print v(xbgr.mr_n71848928)
print v(xbgr.mr_n71849264)
print v(xbgr.mr_n71850960)
print v(xbgr.mr_n71852128)
print v(xbgr.mr_n71853216)
print v(xbgr.mr_n71854720)
print v(xbgr.mr_n71856640)
print v(xbgr.mr_n71857152)
print v(xbgr.mr_n71857680)
print v(xbgr.mr_n71858000)
print v(xbgr.mr_n71858576)
print v(xbgr.mr_n71859104)
print v(xbgr.mr_n71860464)
print v(xbgr.mr_n71861168)
print v(xbgr.mr_n71862688)
print v(xbgr.mr_n71864416)
print v(xbgr.mr_n71864800)
print v(xbgr.mr_n71866000)
print v(xbgr.mr_n71866448)
print v(xbgr.mr_n71868000)
print v(xbgr.mr_n71868240)
print v(xbgr.mr_n71868448)
print v(xbgr.mr_n71870240)
print v(xbgr.mr_n71871024)
print v(xbgr.mr_n71874064)
print v(xbgr.mr_n71876512)
print v(xbgr.mr_n71971408)
print v(xbgr.mr_n71975440)
print v(xbgr.mr_n71975616)
print v(xbgr.mr_n71984320)
print v(xbgr.mr_n71990160)
print v(xbgr.mr_n72001792)
print v(xbgr.mr_n72009360)
print v(xbgr.mr_n72091328)
print v(xbgr.mr_n72091712)
print v(xbgr.mr_n72092672)
print v(xbgr.mr_n72093120)
print v(xbgr.mr_n72093360)
print v(xbgr.mr_n72093504)
print v(xbgr.mr_n72093808)
print v(xbgr.mr_n72094080)
print v(xbgr.mr_n72094976)
print v(xbgr.mr_n72095360)
print v(xbgr.mr_n72095808)
print v(xbgr.mr_n72096256)
print v(xbgr.mr_n72096704)
print v(xbgr.mr_n72098384)
print v(xbgr.mr_n72098560)
print v(xbgr.mr_n72099280)
print v(xbgr.mr_n72100224)
print v(xbgr.mr_n72100736)
print v(xbgr.mr_n72101376)
print v(xbgr.mr_n72102528)
print v(xbgr.mr_n72103664)
print v(xbgr.mr_n72105216)
print v(xbgr.mr_n72105456)
print v(xbgr.mr_n72106176)
print v(xbgr.mr_n72107248)
print v(xbgr.mr_n72108416)
print v(xbgr.mr_n72109760)
print v(xbgr.mr_n72109936)
print v(xbgr.mr_n72110208)
print v(xbgr.mr_n72111936)
print v(xbgr.mr_n72112272)
print v(xbgr.mr_n72113664)
print v(xbgr.mr_n72114512)
print v(xbgr.mr_n72115904)
print v(xbgr.mr_n72116800)
print v(xbgr.mr_n72117248)
print v(xbgr.mr_n72117824)
print v(xbgr.mr_n72119168)
print v(xbgr.mr_n72122240)
print v(xbgr.mr_n72136112)
print v(xbgr.mr_n72136304)
print v(xbgr.mr_n72137328)
print v(xbgr.mr_n72138096)
print v(xbgr.mr_n72138480)
print v(xbgr.mr_n72138672)
print v(xbgr.mr_n72143264)
print v(xbgr.mr_n72151360)
print v(xbgr.mr_n72182768)
print v(xbgr.mr_n72182960)
print v(xbgr.mr_n72183152)
print v(xbgr.mr_n72183584)
print v(xbgr.mr_n72183856)
print v(xbgr.mr_n72184128)
print v(xbgr.mr_n72188752)
print v(xbgr.mr_n72189776)
print v(xbgr.mr_n72191392)
print v(xbgr.mr_n72191888)
print v(xbgr.mr_n72192464)
print v(xbgr.mr_n72193392)
print v(xbgr.mr_n72193872)
print v(xbgr.mr_n72194048)
print v(xbgr.mr_n72195632)
print v(xbgr.mr_n72196096)
print v(xbgr.mr_n72197248)
print v(xbgr.mr_n72199344)
print v(xbgr.mr_n72199792)
print v(xbgr.mr_n72201072)
print v(xbgr.mr_n72202752)
print v(xbgr.mr_n72203056)
print v(xbgr.mr_n72208432)
print v(xbgr.mr_n72209824)
print v(xbgr.mr_n72210016)
print v(xbgr.mr_n72214416)
print v(xbgr.mr_n72214656)
print v(xbgr.mr_n72215600)
print v(xbgr.mr_n72216144)
print v(xbgr.mr_n72217920)
print v(xbgr.mr_n72218192)
print v(xbgr.mr_n72218896)
print v(xbgr.mr_n72220656)
print v(xbgr.mr_n72222704)
print v(xbgr.mr_n72223728)
print v(xbgr.mr_n72224000)
print v(xbgr.mr_n72225008)
print v(xbgr.mr_n72275184)
print v(xbgr.mr_n72275552)
print v(xbgr.mr_n72275936)
print v(xbgr.mr_n72285952)
print v(xbgr.mr_n72286224)
print v(xbgr.mr_n72301824)
print v(xbgr.mr_n72302016)
print v(xbgr.mr_n72312704)
print v(xbgr.mr_n72335632)
print v(xbgr.mr_n72335824)
print v(xbgr.mr_n72341632)
print v(xbgr.mr_n72341824)
print v(xbgr.mr_n72453840)
print v(xbgr.mr_n72454192)
print v(xbgr.mr_n72454384)
print v(xbgr.mr_n72515552)
print v(xbgr.mr_n72515744)
print v(xbgr.mr_n72516448)
print v(xbgr.mr_n72516800)
print v(xbgr.mr_n72549408)
print v(xbgr.mr_n72549760)
print v(xbgr.mr_n72550048)
print v(xbgr.mr_n72550288)
print v(xbgr.mr_n72587264)
print v(xbgr.mr_n72614704)
print v(xbgr.mr_n72647520)
print v(xbgr.mr_n72655968)
print v(xbgr.mr_n72660704)
print v(xbgr.mr_n72665376)
print v(xbgr.mr_n72666080)
print v(xbgr.mr_n72667952)
print v(xbgr.mr_n72681312)
print v(xbgr.mr_n72682192)
print v(xbgr.mr_n72682720)
print v(xbgr.mr_n72683632)
print v(xbgr.mr_n72685104)
print v(xbgr.mr_n72685536)
print v(xbgr.mr_n72686976)
print v(xbgr.mr_n72687776)
print v(xbgr.mr_n72688272)
print v(xbgr.mr_n72688704)
print v(xbgr.mr_n72688976)
print v(xbgr.mr_n72690832)
print v(xbgr.mr_n72691136)
print v(xbgr.mr_n72696128)
print v(xbgr.mr_n72698176)
print v(xbgr.mr_n72698288)
print v(xbgr.mr_n72698400)
print v(xbgr.mr_n72698512)
print v(xbgr.mr_n72698816)
print v(xbgr.mr_n72699088)
print v(xbgr.mr_n72699360)
print v(xbgr.mr_n72700384)
print v(xbgr.mr_n72701472)
print v(xbgr.mr_n72701936)
print v(xbgr.mr_n72702400)
print v(xbgr.mr_n72702864)
print v(xbgr.mr_n72703328)
print v(xbgr.mr_n72703792)
print v(xbgr.mr_n72704256)
print v(xbgr.mr_n72704720)
print v(xbgr.mr_n72705184)
print v(xbgr.mr_n72705648)
print v(xbgr.mr_n72706112)
print v(xbgr.mr_n72706896)
print v(xbgr.mr_n72710272)
print v(xbgr.mr_n72711488)
print v(xbgr.mr_n72712704)
print v(xbgr.mr_n72713200)
print v(xbgr.mr_n72713808)
print v(xbgr.mr_n72716000)
print v(xbgr.mr_n72717680)
print v(xbgr.mr_n72718672)
print v(xbgr.mr_n72719216)
print v(xbgr.mr_n72720496)
print v(xbgr.mr_n72722256)
print v(xbgr.mr_n72724320)
print v(xbgr.mr_n72724864)
print v(xbgr.mr_n72726400)
print v(xbgr.mr_n72727392)
print v(xbgr.mr_n72728464)
print v(xbgr.mr_n72729296)
print v(xbgr.mr_n72734432)
print v(xbgr.mr_n72735136)
print v(xbgr.mr_n72736336)
print v(xbgr.mr_n72737040)
print v(xbgr.mr_n72740064)
print v(xbgr.mr_n72741360)
print v(xbgr.mr_n72745056)
print v(xbgr.mr_n72746336)
print v(xbgr.mr_n72749104)
print v(xbgr.mr_n72752528)
print v(xbgr.mr_n72753232)
print v(xbgr.mr_n72755168)
print v(xbgr.mr_n72755344)
print v(xbgr.mr_n72755552)
print v(xbgr.mr_n72756960)
print v(xbgr.mr_n72758368)
print v(xbgr.mr_n72758864)
print v(xbgr.mr_n72759776)
print v(xbgr.mr_n72760272)
print v(xbgr.mr_n72764064)
print v(xbgr.mr_n72765200)
print v(xbgr.mr_n72765376)
print v(xbgr.mr_n72765664)
print v(xbgr.mr_n72768112)
print v(xbgr.mr_n72768928)
print v(xbgr.mr_n72771104)
print v(xbgr.mr_n72771536)
print v(xbgr.mr_n72771744)
print v(xbgr.mr_n72774624)
print v(xbgr.mr_n72775760)
print v(xbgr.mr_n72776736)
print v(xbgr.mr_n72779088)
print v(xbgr.mr_n72780688)
print v(xbgr.mr_n72784576)
print v(xbgr.mr_n72786384)
print v(xbgr.mr_n72787200)
print v(xbgr.mr_n72787344)
print v(xbgr.mr_n72788256)
print v(xbgr.mr_n72788720)
print v(xbgr.mr_n72789184)
print v(xbgr.mr_n72789648)
print v(xbgr.mr_n72790000)
print v(xbgr.mr_n72790112)
print v(xbgr.mr_n72790576)
print v(xbgr.mr_n72791040)
print v(xbgr.mr_n72791504)
print v(xbgr.mr_n72791968)
print v(xbgr.mr_n72792432)
print v(xbgr.mr_n72792896)
print v(xbgr.mr_n72793456)
print v(xbgr.mr_n72793840)
print v(xbgr.mr_n72796832)
print v(xbgr.mr_n72798928)
print v(xbgr.mr_n72799536)
print v(xbgr.mr_n72800448)
print v(xbgr.mr_n72801296)
print v(xbgr.mr_n72802208)
print v(xbgr.mr_n72803120)
print v(xbgr.mr_n72804704)
print v(xbgr.mr_n72805008)
print v(xbgr.mr_n72807376)
print v(xbgr.mr_n72812064)
print v(xbgr.mr_n72813456)
print v(xbgr.mr_n72815280)
print v(xbgr.mr_n72815888)
print v(xbgr.mr_n72818256)
print v(xbgr.mr_n72818864)
print v(xbgr.mr_n72819840)
print v(xbgr.mr_n72821360)
print v(xbgr.mr_n72822512)
print v(xbgr.mr_n72825232)
print v(xbgr.mr_n72827248)
print v(xbgr.mr_n72829360)
print v(xbgr.mr_n72830368)
print v(xbgr.mr_n72830544)
print v(xbgr.mr_n72831552)
print v(xbgr.mr_n72837024)
print v(xbgr.mr_n72837216)
print v(xbgr.mr_n72839328)
print v(xbgr.mr_n72839792)
print v(xbgr.mr_n72840256)
print v(xbgr.mr_n72840720)
print v(xbgr.mr_n72841184)
print v(xbgr.mr_n72841648)
print v(xbgr.mr_n72842112)
print v(xbgr.mr_n72842576)
print v(xbgr.mr_n72843040)
print v(xbgr.mr_n72843504)
print v(xbgr.mr_n72843968)
print v(xbgr.mr_n72844432)
print v(xbgr.mr_n72844896)
print v(xbgr.mr_n72845360)
print v(xbgr.mr_n72845824)
print v(xbgr.mr_n72846288)
print v(xbgr.mr_n72846752)
print v(xbgr.mr_n72847216)
print v(xbgr.mr_n72847680)
print v(xbgr.mr_n72848144)
print v(xbgr.mr_n72848608)
print v(xbgr.mr_n72849072)
print v(xbgr.mr_n72849536)
print v(xbgr.mr_n72849808)
print v(xbgr.mr_n72850000)
print v(xbgr.mr_n72850464)
print v(xbgr.mr_n72850928)
print v(xbgr.mr_n72851392)
print v(xbgr.mr_n72851856)
print v(xbgr.mr_n72852320)
print v(xbgr.mr_n72852784)
print v(xbgr.mr_n72853248)
print v(xbgr.mr_n72853712)
print v(xbgr.mr_n72854176)
print v(xbgr.mr_n72854640)
print v(xbgr.mr_n72855104)
print v(xbgr.mr_n72855568)
print v(xbgr.mr_n72855952)
print v(xbgr.mr_n72856416)
print v(xbgr.mr_n72856688)
print v(xbgr.mr_n72856880)
print v(xbgr.mr_n72857344)
print v(xbgr.mr_n72857808)
print v(xbgr.mr_n72858272)
print v(xbgr.mr_n72858736)
print v(xbgr.mr_n72859200)
print v(xbgr.mr_n72859664)
print v(xbgr.mr_n72860128)
print v(xbgr.mr_n72860592)
print v(xbgr.mr_n72861056)
print v(xbgr.mr_n72861520)
print v(xbgr.mr_n72861984)
print v(xbgr.mr_n72862448)
print v(xbgr.mr_n72862912)
print v(xbgr.mr_n72863376)
print v(xbgr.mr_n72863728)
print v(xbgr.mr_n72863840)
print v(xbgr.mr_n72864304)
print v(xbgr.mr_n72864768)
print v(xbgr.mr_n72865232)
print v(xbgr.mr_n72865696)
print v(xbgr.mr_n72866160)
print v(xbgr.mr_n72866624)
print v(xbgr.mr_n72867088)
print v(xbgr.mr_n72867552)
print v(xbgr.mr_n72868016)
print v(xbgr.mr_n72868480)
print v(xbgr.mr_n72868944)
print v(xbgr.mr_n72869408)
print v(xbgr.mr_n72869872)
print v(xbgr.mr_n72870336)
print v(xbgr.mr_n72870800)
print v(xbgr.mr_n72871264)
print v(xbgr.mr_n72871728)
print v(xbgr.mr_n72872192)
print v(xbgr.mr_n72872656)
print v(xbgr.mr_n72873120)
print v(xbgr.mr_n72873584)
print v(xbgr.mr_n72874048)
print v(xbgr.mr_n72874512)
print v(xbgr.mr_n72874976)
print v(xbgr.mr_n72875440)
print v(xbgr.mr_n72875904)
print v(xbgr.mr_n72876368)
print v(xbgr.mr_n72876832)
print v(xbgr.mr_n72877296)
print v(xbgr.mr_n72877760)
print v(xbgr.mr_n72878224)
print v(xbgr.mr_n72878688)
print v(xbgr.mr_n72879152)
print v(xbgr.mr_n72879616)
print v(xbgr.mr_n72880080)
print v(xbgr.mr_n72880544)
print v(xbgr.mr_n72881008)
print v(xbgr.mr_n72881472)
print v(xbgr.mr_n72881936)
print v(xbgr.mr_n72882400)
print v(xbgr.mr_n72882864)
print v(xbgr.mr_n72883328)
print v(xbgr.mr_n72883792)
print v(xbgr.mr_n72884256)
print v(xbgr.mr_n72884720)
print v(xbgr.mr_n72885184)
print v(xbgr.mr_n72885648)
print v(xbgr.mr_n72886112)
print v(xbgr.mr_n72886576)
print v(xbgr.mr_n72887040)
print v(xbgr.mr_n72887504)
print v(xbgr.mr_n72887968)
print v(xbgr.mr_n72888432)
print v(xbgr.mr_n72888896)
print v(xbgr.mr_n72889360)
print v(xbgr.mr_n72889824)
print v(xbgr.mr_n72890288)
print v(xbgr.mr_n72890752)
print v(xbgr.mr_n72891216)
print v(xbgr.mr_n72891680)
print v(xbgr.mr_n72892144)
print v(xbgr.mr_n72892608)
print v(xbgr.mr_n72893072)
print v(xbgr.mr_n72893536)
print v(xbgr.mr_n72894000)
print v(xbgr.mr_n72894464)
print v(xbgr.mr_n72894576)
print v(xbgr.mr_n72895120)
print v(xbgr.mr_n72895344)
print v(xbgr.mr_n72895856)
print v(xbgr.mr_n72896080)
print v(xbgr.mr_n72896592)
print v(xbgr.mr_n72896816)
print v(xbgr.mr_n72897328)
print v(xbgr.mr_n72897440)
print v(xbgr.mr_n72897552)
print v(xbgr.mr_n72898064)
print v(xbgr.mr_n72898176)
print v(xbgr.mr_n72898288)
print v(xbgr.mr_n72898800)
print v(xbgr.mr_n72898912)
print v(xbgr.mr_n72899024)
print v(xbgr.mr_n72899536)
print v(xbgr.mr_n72899808)
print v(xbgr.mr_n72900080)
print v(xbgr.mr_n72900352)
print v(xbgr.mr_n72900464)
print v(xbgr.mr_n72900576)
print v(xbgr.mr_n72901088)
print v(xbgr.mr_n72901360)
print v(xbgr.mr_n72901632)
print v(xbgr.mr_n72901904)
print v(xbgr.mr_n72902176)
print v(xbgr.mr_n72902720)
print v(xbgr.mr_n72902992)
print v(xbgr.mr_n72903264)
print v(xbgr.mr_n72903536)
print v(xbgr.mr_n72903808)
print v(xbgr.mr_n72904080)
print v(xbgr.mr_n72904624)
print v(xbgr.mr_n72904896)
print v(xbgr.mr_n72905168)
print v(xbgr.mr_n72905440)
print v(xbgr.mr_n72905712)
print v(xbgr.mr_n72905984)
print v(xbgr.mr_n72906256)
print v(xbgr.mr_n72906528)
print v(xbgr.mr_n72906800)
print v(xbgr.mr_n72907072)
print v(xbgr.mr_n72907344)
print v(xbgr.mr_n72907616)
print v(xbgr.mr_n72907952)
print v(xbgr.mr_n72908416)
print v(xbgr.mr_n72908880)
print v(xbgr.mr_n72909344)
print v(xbgr.mr_n72909808)
print v(xbgr.mr_n72910272)
print v(xbgr.mr_n72910736)
print v(xbgr.mr_n72911200)
print v(xbgr.mr_n72911664)
print v(xbgr.mr_n72912128)
print v(xbgr.mr_n72912592)
print v(xbgr.mr_n72913056)
print v(xbgr.mr_n72915248)
print v(xbgr.mr_n72918144)
print v(xbgr.mr_n72918960)
print v(xbgr.mr_n72924656)
print v(xbgr.mr_n72924912)
print v(xbgr.mr_n72926400)
print v(xbgr.mr_n72928176)
print v(xbgr.mr_n72928688)
print v(xbgr.mr_n72930224)
print v(xbgr.mr_n72930896)
print v(xbgr.mr_n72931408)
print v(xbgr.mr_n72932080)
print v(xbgr.mr_n72932672)
print v(xbgr.mr_n72933184)
print v(xbgr.mr_n72933856)
print v(xbgr.mr_n72934368)
print v(xbgr.mr_n72935040)
print v(xbgr.mr_n72935632)
print v(xbgr.mr_n72936144)
print v(xbgr.mr_n72936560)
print v(xbgr.mr_n72936816)
print v(xbgr.mr_n72937408)
print v(xbgr.mr_n72938000)
print v(xbgr.mr_n72938512)
print v(xbgr.mr_n72939104)
print v(xbgr.mr_n72939776)
print v(xbgr.mr_n72940288)
print v(xbgr.mr_n72940960)
print v(xbgr.mr_n72941376)
print v(xbgr.mr_n72941552)
print v(xbgr.mr_n72942144)
print v(xbgr.mr_n72942736)
print v(xbgr.mr_n72943248)
print v(xbgr.mr_n72944512)
print v(xbgr.mr_n72945024)
print v(xbgr.mr_n72945696)
print v(xbgr.mr_n72946288)
print v(xbgr.mr_n72946944)
print v(xbgr.mr_n72947392)
print v(xbgr.mr_n72947984)
print v(xbgr.mr_n72948656)
print v(xbgr.mr_n72949248)
print v(xbgr.mr_n72961888)
print v(xbgr.mr_n72977008)
print v(xbgr.mr_n72979232)
print v(xbgr.mr_n72984080)
print v(xbgr.mr_n72987280)
print v(xbgr.mr_n72987744)
print v(xbgr.mr_n72991824)
print v(xbgr.mr_n72992784)
print v(xbgr.mr_n72992928)
print v(xbgr.mr_n72994944)
print v(xbgr.mr_n72995552)
print v(xbgr.mr_n72995664)
print v(xbgr.mr_n72996272)
print v(xbgr.mr_n72996384)
print v(xbgr.mr_n72996992)
print v(xbgr.mr_n72997104)
print v(xbgr.mr_n72997712)
print v(xbgr.mr_n72998432)
print v(xbgr.mr_n72998544)
print v(xbgr.mr_n72999152)
print v(xbgr.mr_n72999872)
print v(xbgr.mr_n73003840)
print v(xbgr.mr_n73005424)
print v(xbgr.mr_n73006032)
print v(xbgr.mr_n73006272)
print v(xbgr.mr_n73007248)
print v(xbgr.mr_n73008096)
print v(xbgr.mr_n73009376)
print v(xbgr.mr_n73009680)
print v(xbgr.mr_n73011440)
print v(xbgr.mr_n73012112)
print v(xbgr.mr_n73012352)
print v(xbgr.mr_n73013264)
print v(xbgr.mr_n73013872)
print v(xbgr.mr_n73014480)
print v(xbgr.mr_n73014848)
print v(xbgr.mr_n73015024)
print v(xbgr.mr_n73016064)
print v(xbgr.mr_n73016976)
print v(xbgr.mr_n73018496)
print v(xbgr.mr_n73019296)
print v(xbgr.mr_n73021120)
print v(xbgr.mr_n73021536)
print v(xbgr.mr_n73025184)
print v(xbgr.mr_n73025392)
print v(xbgr.mr_n73027504)
print v(xbgr.mr_n73029440)
print v(xbgr.mr_n73034000)
print v(xbgr.mr_n73034432)
print v(xbgr.mr_n73034928)
print v(xbgr.mr_n73035280)
print v(xbgr.mr_n73036688)
print v(xbgr.mr_n73036896)
print v(xbgr.mr_n73038704)
print v(xbgr.mr_n73039088)
print v(xbgr.mr_n73039712)
print v(xbgr.mr_n73040992)
print v(xbgr.mr_n73042112)
print v(xbgr.mr_n73042736)
print v(xbgr.mr_n73043040)
print v(xbgr.mr_n73044192)
print v(xbgr.mr_n73047392)
print v(xbgr.mr_n73050224)
print v(xbgr.mr_n73052656)
print v(xbgr.mr_n73052832)
print v(xbgr.mr_n73053008)
print v(xbgr.mr_n73053520)
print v(xbgr.mr_n73054912)
print v(xbgr.mr_n73055344)
print v(xbgr.mr_n73055776)
print v(xbgr.mr_n73056288)
print v(xbgr.mr_n73056880)
print v(xbgr.mr_n73057472)
print v(xbgr.mr_n73058064)
print v(xbgr.mr_n73058656)
print v(xbgr.mr_n73059248)
print v(xbgr.mr_n73059840)
print v(xbgr.mr_n73060432)
print v(xbgr.mr_n73061024)
print v(xbgr.mr_n73061360)
print v(xbgr.mr_n73061616)
print v(xbgr.mr_n73062208)
print v(xbgr.mr_n73062800)
print v(xbgr.mr_n73063392)
print v(xbgr.mr_n73063984)
print v(xbgr.mr_n73065168)
print v(xbgr.mr_n73065760)
print v(xbgr.mr_n73066352)
print v(xbgr.mr_n73066944)
print v(xbgr.mr_n73067536)
print v(xbgr.mr_n73068128)
print v(xbgr.mr_n73068720)
print v(xbgr.mr_n73069904)
print v(xbgr.mr_n73070496)
print v(xbgr.mr_n73071088)
print v(xbgr.mr_n73071680)
print v(xbgr.mr_n73072272)
print v(xbgr.mr_n73072864)
print v(xbgr.mr_n73073456)
print v(xbgr.mr_n73074048)
print v(xbgr.mr_n73074640)
print v(xbgr.mr_n73075824)
print v(xbgr.mr_n73076416)
print v(xbgr.mr_n73077008)
print v(xbgr.mr_n73078192)
print v(xbgr.mr_n73078784)
print v(xbgr.mr_n73079376)
print v(xbgr.mr_n73079968)
print v(xbgr.mr_n73080560)
print v(xbgr.mr_n73081152)
print v(xbgr.mr_n73081744)
print v(xbgr.mr_n73082336)
print v(xbgr.mr_n73082928)
print v(xbgr.mr_n73083520)
print v(xbgr.mr_n73084112)
print v(xbgr.mr_n73084704)
print v(xbgr.mr_n73084912)
print v(xbgr.mr_n73085024)
print v(xbgr.mr_n73085568)
print v(xbgr.mr_n73086272)
print v(xbgr.mr_n73087312)
print v(xbgr.mr_n73088256)
print v(xbgr.mr_n73088848)
print v(xbgr.mr_n73089440)
print v(xbgr.mr_n73090032)
print v(xbgr.mr_n73090624)
print v(xbgr.mr_n73091216)
print v(xbgr.mr_n73091792)
print v(xbgr.mr_n73092384)
print v(xbgr.mr_n73092976)
print v(xbgr.mr_n73093568)
print v(xbgr.mr_n73094160)
print v(xbgr.mr_n73094752)
print v(xbgr.mr_n73095344)
print v(xbgr.mr_n73096448)
print v(xbgr.mr_n73097120)
print v(xbgr.mr_n73097712)
print v(xbgr.mr_n73098304)
print v(xbgr.mr_n73098896)
print v(xbgr.mr_n73099488)
print v(xbgr.mr_n73100080)
print v(xbgr.mr_n73100672)
print v(xbgr.mr_n73101264)
print v(xbgr.mr_n73101856)
print v(xbgr.mr_n73102448)
print v(xbgr.mr_n73103040)
print v(xbgr.mr_n73103632)
print v(xbgr.mr_n73104144)
print v(xbgr.mr_n73104816)
print v(xbgr.mr_n73105408)
print v(xbgr.mr_n73106000)
print v(xbgr.mr_n73106592)
print v(xbgr.mr_n73107184)
print v(xbgr.mr_n73107776)
print v(xbgr.mr_n73108368)
print v(xbgr.mr_n73108960)
print v(xbgr.mr_n73109376)
print v(xbgr.mr_n73109552)
print v(xbgr.mr_n73110144)
print v(xbgr.mr_n73110736)
print v(xbgr.mr_n73111328)
print v(xbgr.mr_n73111920)
print v(xbgr.mr_n73112512)
print v(xbgr.mr_n73113104)
print v(xbgr.mr_n73113696)
print v(xbgr.mr_n73114288)
print v(xbgr.mr_n73114880)
print v(xbgr.mr_n73115472)
print v(xbgr.mr_n73116064)
print v(xbgr.mr_n73116656)
print v(xbgr.mr_n73117248)
print v(xbgr.mr_n73117840)
print v(xbgr.mr_n73118432)
print v(xbgr.mr_n73118768)
print v(xbgr.mr_n73119024)
print v(xbgr.mr_n73119616)
print v(xbgr.mr_n73120208)
print v(xbgr.mr_n73120800)
print v(xbgr.mr_n73121392)
print v(xbgr.mr_n73121984)
print v(xbgr.mr_n73122576)
print v(xbgr.mr_n73123168)
print v(xbgr.mr_n73123760)
print v(xbgr.mr_n73124352)
print v(xbgr.mr_n73124944)
print v(xbgr.mr_n73125536)
print v(xbgr.mr_n73126128)
print v(xbgr.mr_n73126720)
print v(xbgr.mr_n73127376)
print v(xbgr.mr_n73127824)
print v(xbgr.mr_n73128496)
print v(xbgr.mr_n73129088)
print v(xbgr.mr_n73129680)
print v(xbgr.mr_n73130272)
print v(xbgr.mr_n73130688)
print v(xbgr.mr_n73130864)
print v(xbgr.mr_n73131280)
print v(xbgr.mr_n73131456)
print v(xbgr.mr_n73132288)
print v(xbgr.mr_n73132528)
print v(xbgr.mr_n73132768)
print v(xbgr.mr_n73133248)
print v(xbgr.mr_n73133888)
print v(xbgr.mr_n73134288)
print v(xbgr.mr_n73134688)
print v(xbgr.mr_n73135088)
print v(xbgr.mr_n73135488)
print v(xbgr.mr_n73136208)
print v(xbgr.mr_n73140368)
print v(xbgr.mr_n73144272)
print v(xbgr.mr_n73146192)
print v(xbgr.mr_n73156256)
print v(xbgr.mr_n73160976)
print v(xbgr.mr_n73163056)
print v(xbgr.mr_n73164512)
print v(xbgr.mr_n73165584)
print v(xbgr.mr_n73166544)
print v(xbgr.mr_n73167488)
print v(xbgr.mr_n73168080)
print v(xbgr.mr_n73168672)
print v(xbgr.mr_n73169264)
print v(xbgr.mr_n73169856)
print v(xbgr.mr_n73170448)
print v(xbgr.mr_n73171040)
print v(xbgr.mr_n73171632)
print v(xbgr.mr_n73172224)
print v(xbgr.mr_n73172816)
print v(xbgr.mr_n73173408)
print v(xbgr.mr_n73186032)
print v(xbgr.mr_n73187824)
print v(xbgr.mr_n73196352)
print v(xbgr.mr_n73199600)
print v(xbgr.mr_n73206672)
print v(xbgr.mr_n73207440)
print v(xbgr.mr_n73207696)
print v(xbgr.mr_n73208336)
print v(xbgr.mr_n73209888)
print v(xbgr.mr_n73210768)
print v(xbgr.mr_n73211888)
print v(xbgr.mr_n73212480)
print v(xbgr.mr_n73213072)
print v(xbgr.mr_n73213664)
print v(xbgr.mr_n73214256)
print v(xbgr.mr_n73214848)
print v(xbgr.mr_n73216032)
print v(xbgr.mr_n73216368)
print v(xbgr.mr_n73216624)
print v(xbgr.mr_n73217216)
print v(xbgr.mr_n73217808)
print v(xbgr.mr_n73218400)
print v(xbgr.mr_n73218992)
print v(xbgr.mr_n73219584)
print v(xbgr.mr_n73220064)
print v(xbgr.mr_n73220304)
print v(xbgr.mr_n73220416)
print v(xbgr.mr_n73222128)
print v(xbgr.mr_n73222720)
print v(xbgr.mr_n73223312)
print v(xbgr.mr_n73223904)
print v(xbgr.mr_n73224496)
print v(xbgr.mr_n73225088)
print v(xbgr.mr_n73225680)
print v(xbgr.mr_n73226272)
print v(xbgr.mr_n73226864)
print v(xbgr.mr_n73227456)
print v(xbgr.mr_n73228048)
print v(xbgr.mr_n73229232)
print v(xbgr.mr_n73229824)
print v(xbgr.mr_n73230416)
print v(xbgr.mr_n73231008)
print v(xbgr.mr_n73231600)
print v(xbgr.mr_n73232192)
print v(xbgr.mr_n73232784)
print v(xbgr.mr_n73233376)
print v(xbgr.mr_n73233968)
print v(xbgr.mr_n73234560)
print v(xbgr.mr_n73235152)
print v(xbgr.mr_n73236336)
print v(xbgr.mr_n73236928)
print v(xbgr.mr_n73237520)
print v(xbgr.mr_n73238112)
print v(xbgr.mr_n73238704)
print v(xbgr.mr_n73239296)
print v(xbgr.mr_n73239888)
print v(xbgr.mr_n73240480)
print v(xbgr.mr_n73241072)
print v(xbgr.mr_n73241664)
print v(xbgr.mr_n73242256)
print v(xbgr.mr_n73242848)
print v(xbgr.mr_n73243440)
print v(xbgr.mr_n73244032)
print v(xbgr.mr_n73244624)
print v(xbgr.mr_n73245216)
print v(xbgr.mr_n73245808)
print v(xbgr.mr_n73246400)
print v(xbgr.mr_n73246992)
print v(xbgr.mr_n73247584)
print v(xbgr.mr_n73248176)
print v(xbgr.mr_n73248768)
print v(xbgr.mr_n73249360)
print v(xbgr.mr_n73250544)
print v(xbgr.mr_n73251136)
print v(xbgr.mr_n73251728)
print v(xbgr.mr_n73252320)
print v(xbgr.mr_n73252912)
print v(xbgr.mr_n73253504)
print v(xbgr.mr_n73254096)
print v(xbgr.mr_n73254688)
print v(xbgr.mr_n73255280)
print v(xbgr.mr_n73255872)
print v(xbgr.mr_n73256464)
print v(xbgr.mr_n73257056)
print v(xbgr.mr_n73257648)
print v(xbgr.mr_n73258240)
print v(xbgr.mr_n73258832)
print v(xbgr.mr_n73259424)
print v(xbgr.mr_n73260016)
print v(xbgr.mr_n73260608)
print v(xbgr.mr_n73261200)
print v(xbgr.mr_n73261792)
print v(xbgr.mr_n73262384)
print v(xbgr.mr_n73262976)
print v(xbgr.mr_n73263568)
print v(xbgr.mr_n73264160)
print v(xbgr.mr_n73264752)
print v(xbgr.mr_n73265344)
print v(xbgr.mr_n73265936)
print v(xbgr.mr_n73266528)
print v(xbgr.mr_n73267120)
print v(xbgr.mr_n73267712)
print v(xbgr.mr_n73268304)
print v(xbgr.mr_n73268896)
print v(xbgr.mr_n73269488)
print v(xbgr.mr_n73270080)
print v(xbgr.mr_n73270672)
print v(xbgr.mr_n73271264)
print v(xbgr.mr_n73271856)
print v(xbgr.mr_n73272448)
print v(xbgr.mr_n73273040)
print v(xbgr.mr_n73273632)
print v(xbgr.mr_n73274224)
print v(xbgr.mr_n73274816)
print v(xbgr.mr_n73275408)
print v(xbgr.mr_n73276000)
print v(xbgr.mr_n73276592)
print v(xbgr.mr_n73277184)
print v(xbgr.mr_n73277776)
print v(xbgr.mr_n73278368)
print v(xbgr.mr_n73278960)
print v(xbgr.mr_n73279552)
print v(xbgr.mr_n73280144)
print v(xbgr.mr_n73280736)
print v(xbgr.mr_n73281264)
print v(xbgr.mr_n73281728)
print v(xbgr.mr_n73282192)
print v(xbgr.mr_n73282304)
print v(xbgr.mr_n73282656)
print v(xbgr.mr_n73283232)
print v(xbgr.mr_n73283584)
print v(xbgr.mr_n73283696)
print v(xbgr.mr_n73285088)
print v(xbgr.mr_n73285344)
print v(xbgr.mr_n73285680)
print v(xbgr.mr_n73286320)
print v(xbgr.mr_n73286720)
print v(xbgr.mr_n73287120)
print v(xbgr.mr_n73287520)
print v(xbgr.mr_n73287920)
print v(xbgr.mr_n73288320)
print v(xbgr.mr_n73288720)
print v(xbgr.mr_n73289120)
print v(xbgr.mr_n73289520)
print v(xbgr.mr_n73289920)
print v(xbgr.mr_n73290320)
print v(xbgr.mr_n73290720)
print v(xbgr.mr_n73291120)
print v(xbgr.mr_n73291520)
print v(xbgr.mr_n73291920)
print v(xbgr.mr_n73292320)
print v(xbgr.mr_n73292720)
print v(xbgr.mr_n73293120)
print v(xbgr.mr_n73293520)
print v(xbgr.mr_n73293920)
print v(xbgr.mr_n73294320)
print v(xbgr.mr_n73294720)
print v(xbgr.mr_n73295120)
print v(xbgr.mr_n73295520)
print v(xbgr.mr_n73295920)
print v(xbgr.mr_n73296320)
print v(xbgr.mr_n73296720)
print v(xbgr.mr_n73297120)
print v(xbgr.mr_n73297520)
print v(xbgr.mr_n73297920)
print v(xbgr.mr_n73298320)
print v(xbgr.mr_n73298720)
print v(xbgr.mr_n73299120)
print v(xbgr.mr_n73299520)
print v(xbgr.mr_n73299920)
print v(xbgr.mr_n73300320)
print v(xbgr.mr_n73300784)
print v(xbgr.mr_n73301376)
print v(xbgr.mr_n73301968)
print v(xbgr.mr_n73302560)
print v(xbgr.mr_n73303152)
print v(xbgr.mr_n73303744)
print v(xbgr.mr_n73304336)
print v(xbgr.mr_n73304928)
print v(xbgr.mr_n73305520)
print v(xbgr.mr_n73306112)
print v(xbgr.mr_n73306704)
print v(xbgr.mr_n73308912)
print v(xbgr.mr_n73315312)
print v(xbgr.mr_n73319328)
print v(xbgr.mr_n73322080)
print v(xbgr.mr_n73323056)
print v(xbgr.mr_n73323680)
print v(xbgr.mr_n73324352)
print v(xbgr.mr_n73324864)
print v(xbgr.mr_n73325536)
print v(xbgr.mr_n73326048)
print v(xbgr.mr_n73326640)
print v(xbgr.mr_n73327312)
print v(xbgr.mr_n73327904)
print v(xbgr.mr_n73328496)
print v(xbgr.mr_n73329088)
print v(xbgr.mr_n73329600)
print v(xbgr.mr_n73330272)
print v(xbgr.mr_n73330864)
print v(xbgr.mr_n73331456)
print v(xbgr.mr_n73332048)
print v(xbgr.mr_n73332560)
print v(xbgr.mr_n73332976)
print v(xbgr.mr_n73333232)
print v(xbgr.mr_n73333824)
print v(xbgr.mr_n73334416)
print v(xbgr.mr_n73335008)
print v(xbgr.mr_n73335520)
print v(xbgr.mr_n73336192)
print v(xbgr.mr_n73336704)
print v(xbgr.mr_n73337376)
print v(xbgr.mr_n73337968)
print v(xbgr.mr_n73338480)
print v(xbgr.mr_n73339152)
print v(xbgr.mr_n73339744)
print v(xbgr.mr_n73340336)
print v(xbgr.mr_n73340928)
print v(xbgr.mr_n73341440)
print v(xbgr.mr_n73342112)
print v(xbgr.mr_n73342704)
print v(xbgr.mr_n73343296)
print v(xbgr.mr_n73343888)
print v(xbgr.mr_n73344400)
print v(xbgr.mr_n73344816)
print v(xbgr.mr_n73345072)
print v(xbgr.mr_n73345664)
print v(xbgr.mr_n73346256)
print v(xbgr.mr_n73346848)
print v(xbgr.mr_n73347360)
print v(xbgr.mr_n73348032)
print v(xbgr.mr_n73348624)
print v(xbgr.mr_n73349216)
print v(xbgr.mr_n73349728)
print v(xbgr.mr_n73350320)
print v(xbgr.mr_n73350992)
print v(xbgr.mr_n73358832)
print v(xbgr.mr_n73359360)
print v(xbgr.mr_n73363456)
print v(xbgr.mr_n73363568)
print v(xbgr.mr_n73364560)
print v(xbgr.mr_n73370224)
print v(xbgr.mr_n73370928)
print v(xbgr.mr_n73374496)
print v(xbgr.mr_n73380176)
print v(xbgr.mr_n73387056)
print v(xbgr.mr_n73388256)
print v(xbgr.mr_n73389408)
print v(xbgr.mr_n73392448)
print v(xbgr.mr_n73393504)
print v(xbgr.mr_n73394096)
print v(xbgr.mr_n73396528)
print v(xbgr.mr_n73396640)
print v(xbgr.mr_n73397248)
print v(xbgr.mr_n73397968)
print v(xbgr.mr_n73398080)
print v(xbgr.mr_n73398688)
print v(xbgr.mr_n73399408)
print v(xbgr.mr_n73399520)
print v(xbgr.mr_n73400128)
print v(xbgr.mr_n73407072)
print v(xbgr.mr_n73412064)
print v(xbgr.mr_n73413232)
print v(xbgr.mr_n73413792)
print v(xbgr.mr_n73414768)
print v(xbgr.mr_n73415024)
print v(xbgr.mr_n73420640)
print v(xbgr.mr_n73421232)
print v(xbgr.mr_n73421664)
print v(xbgr.mr_n73427280)
print v(xbgr.mr_n73430944)
print v(xbgr.mr_n73431472)
print v(xbgr.mr_n73436144)
print v(xbgr.mr_n73437088)
print v(xbgr.mr_n73438336)
print v(xbgr.mr_n73438608)
print v(xbgr.mr_n73438864)
print v(xbgr.mr_n73439120)
print v(xbgr.mr_n73440160)
print v(xbgr.mr_n73440768)
print v(xbgr.mr_n73442144)
print v(xbgr.mr_n73442256)
print v(xbgr.mr_n73443408)
print v(xbgr.mr_n73443552)
print v(xbgr.mr_n73444704)
print v(xbgr.mr_n73445056)
print v(xbgr.mr_n73445824)
print v(xbgr.mr_n73446416)
print v(xbgr.mr_n73447008)
print v(xbgr.mr_n73448192)
print v(xbgr.mr_n73448784)
print v(xbgr.mr_n73449376)
print v(xbgr.mr_n73449968)
print v(xbgr.mr_n73450560)
print v(xbgr.mr_n73451152)
print v(xbgr.mr_n73451744)
print v(xbgr.mr_n73452336)
print v(xbgr.mr_n73452928)
print v(xbgr.mr_n73453520)
print v(xbgr.mr_n73454112)
print v(xbgr.mr_n73454704)
print v(xbgr.mr_n73455296)
print v(xbgr.mr_n73455888)
print v(xbgr.mr_n73456480)
print v(xbgr.mr_n73457072)
print v(xbgr.mr_n73457664)
print v(xbgr.mr_n73458848)
print v(xbgr.mr_n73459440)
print v(xbgr.mr_n73460032)
print v(xbgr.mr_n73460624)
print v(xbgr.mr_n73461216)
print v(xbgr.mr_n73461808)
print v(xbgr.mr_n73462400)
print v(xbgr.mr_n73462992)
print v(xbgr.mr_n73463584)
print v(xbgr.mr_n73464176)
print v(xbgr.mr_n73464768)
print v(xbgr.mr_n73465952)
print v(xbgr.mr_n73466544)
print v(xbgr.mr_n73467136)
print v(xbgr.mr_n73467728)
print v(xbgr.mr_n73468320)
print v(xbgr.mr_n73468912)
print v(xbgr.mr_n73469504)
print v(xbgr.mr_n73470096)
print v(xbgr.mr_n73470688)
print v(xbgr.mr_n73471280)
print v(xbgr.mr_n73471872)
print v(xbgr.mr_n73472464)
print v(xbgr.mr_n73473056)
print v(xbgr.mr_n73473648)
print v(xbgr.mr_n73474224)
print v(xbgr.mr_n73474816)
print v(xbgr.mr_n73475408)
print v(xbgr.mr_n73476000)
print v(xbgr.mr_n73476592)
print v(xbgr.mr_n73477184)
print v(xbgr.mr_n73477776)
print v(xbgr.mr_n73478368)
print v(xbgr.mr_n73478960)
print v(xbgr.mr_n73480144)
print v(xbgr.mr_n73480736)
print v(xbgr.mr_n73481328)
print v(xbgr.mr_n73481920)
print v(xbgr.mr_n73482480)
print v(xbgr.mr_n73483040)
print v(xbgr.mr_n73483632)
print v(xbgr.mr_n73484224)
print v(xbgr.mr_n73484816)
print v(xbgr.mr_n73485408)
print v(xbgr.mr_n73486000)
print v(xbgr.mr_n73486592)
print v(xbgr.mr_n73487184)
print v(xbgr.mr_n73487776)
print v(xbgr.mr_n73488368)
print v(xbgr.mr_n73488960)
print v(xbgr.mr_n73489552)
print v(xbgr.mr_n73490144)
print v(xbgr.mr_n73490400)
print v(xbgr.mr_n73490592)
print v(xbgr.mr_n73491696)
print v(xbgr.mr_n73492672)
print v(xbgr.mr_n73493072)
print v(xbgr.mr_n73493936)
print v(xbgr.mr_n73497904)
print v(xbgr.mr_n73499520)
print v(xbgr.mr_n73499632)
print v(xbgr.mr_n73499744)
print v(xbgr.mr_n73499856)
print v(xbgr.mr_n73499968)
print v(xbgr.mr_n73500080)
print v(xbgr.mr_n73500192)
print v(xbgr.mr_n73500304)
print v(xbgr.mr_n73500496)
print v(xbgr.mr_n73500768)
print v(xbgr.mr_n73501040)
print v(xbgr.mr_n73501312)
print v(xbgr.mr_n73501584)
print v(xbgr.mr_n73501856)
print v(xbgr.mr_n73502128)
print v(xbgr.mr_n73502400)
print v(xbgr.mr_n73502624)
print v(xbgr.mr_n73503104)
print v(xbgr.mr_n73503504)
print v(xbgr.mr_n73503904)
print v(xbgr.mr_n73504304)
print v(xbgr.mr_n73504704)
print v(xbgr.mr_n73505104)
print v(xbgr.mr_n73505504)
print v(xbgr.mr_n73505904)
print v(xbgr.mr_n73506304)
print v(xbgr.mr_n73506624)
print v(xbgr.mr_n73507104)
print v(xbgr.mr_n73507504)
print v(xbgr.mr_n73507904)
print v(xbgr.mr_n73508304)
print v(xbgr.mr_n73508704)
print v(xbgr.mr_n73509104)
print v(xbgr.mr_n73509504)
print v(xbgr.mr_n73509904)
print v(xbgr.mr_n73510304)
print v(xbgr.mr_n73510704)
print v(xbgr.mr_n73511104)
print v(xbgr.mr_n73511504)
print v(xbgr.mr_n73511904)
print v(xbgr.mr_n73512304)
print v(xbgr.mr_n73512704)
print v(xbgr.mr_n73513104)
print v(xbgr.mr_n73513504)
print v(xbgr.mr_n73513904)
print v(xbgr.mr_n73514320)
print v(xbgr.mr_n73514592)
print v(xbgr.mr_n73514864)
print v(xbgr.mr_n73515136)
print v(xbgr.mr_n73515408)
print v(xbgr.mr_n73515680)
print v(xbgr.mr_n73515952)
print v(xbgr.mr_n73516224)
print v(xbgr.mr_n73516496)
print v(xbgr.mr_n73516768)
print v(xbgr.mr_n73517040)
print v(xbgr.mr_n73517312)
print v(xbgr.mr_n73517584)
print v(xbgr.mr_n73517856)
print v(xbgr.mr_n73518128)
print v(xbgr.mr_n73518400)
print v(xbgr.mr_n73518672)
print v(xbgr.mr_n73518944)
print v(xbgr.mr_n73519392)
print v(xbgr.mr_n73519584)
print v(xbgr.mr_n73519776)
print v(xbgr.mr_n73519968)
print v(xbgr.mr_n73520912)
print v(xbgr.mr_n73524672)
print v(xbgr.mr_n73524784)
print v(xbgr.mr_n73524976)
print v(xbgr.mr_n73525728)
print v(xbgr.mr_n73526640)
print v(xbgr.mr_n73527392)
print v(xbgr.mr_n73529664)
print v(xbgr.mr_n73529776)
print v(xbgr.mr_n73529968)
print v(xbgr.mr_n73530720)
print v(xbgr.mr_n73531632)
print v(xbgr.mr_n73532384)
print v(xbgr.mr_n73534656)
print v(xbgr.mr_n73534768)
print v(xbgr.mr_n73534960)
print v(xbgr.mr_n73535712)
print v(xbgr.mr_n73536624)
print v(xbgr.mr_n73537376)
print v(xbgr.mr_n73539648)
print v(xbgr.mr_n73539760)
print v(xbgr.mr_n73539952)
print v(xbgr.mr_n73540704)
print v(xbgr.mr_n73541616)
print v(xbgr.mr_n73542368)
print v(xbgr.mr_n73544640)
print v(xbgr.mr_n73544752)
print v(xbgr.mr_n73544944)
print v(xbgr.mr_n73545696)
print v(xbgr.mr_n73546608)
print v(xbgr.mr_n73547360)
print v(xbgr.mr_n73549632)
print v(xbgr.mr_n73549744)
print v(xbgr.mr_n73549936)
print v(xbgr.mr_n73550688)
print v(xbgr.mr_n73554208)
print v(xbgr.mr_n73554720)
print v(xbgr.mr_n73555152)
print v(xbgr.mr_n73555328)
print v(xbgr.mr_n73555664)
print v(xbgr.mr_n73556176)
print v(xbgr.mr_n73556608)
print v(xbgr.mr_n73556784)
print v(xbgr.mr_n73557120)
print v(xbgr.mr_n73557824)
print v(xbgr.mr_n73558000)
print v(xbgr.mr_n73558176)
print v(xbgr.mr_n73558688)
print v(xbgr.mr_n73558800)
print v(xbgr.mr_n73559360)
print v(xbgr.mr_n73559536)
print v(xbgr.mr_n73559952)
print v(xbgr.mr_n73560736)
print v(xbgr.mr_n73560912)
print v(xbgr.mr_n73561088)
print v(xbgr.mr_n73561600)
print v(xbgr.mr_n73561712)
print v(xbgr.mr_n73562272)
print v(xbgr.mr_n73562448)
print v(xbgr.mr_n73562944)
print v(xbgr.mr_n73563456)
print v(xbgr.mr_n73563888)
print v(xbgr.mr_n73564064)
print v(xbgr.mr_n73564400)
print v(xbgr.mr_n73565104)
print v(xbgr.mr_n73565280)
print v(xbgr.mr_n73565456)
print v(xbgr.mr_n73565968)
print v(xbgr.mr_n73566080)
print v(xbgr.mr_n73566640)
print v(xbgr.mr_n73566816)
print v(xbgr.mr_n73567232)
print v(xbgr.mr_n73567824)
print v(xbgr.mr_n73568256)
print v(xbgr.mr_n73568432)
print v(xbgr.mr_n73568768)
print v(xbgr.mr_n73569280)
print v(xbgr.mr_n73569712)
print v(xbgr.mr_n73569888)
print v(xbgr.mr_n73570064)
print v(xbgr.mr_n73570928)
print v(xbgr.mr_n73571104)
print v(xbgr.mr_n73571280)
print v(xbgr.mr_n73571792)
print v(xbgr.mr_n73572224)
print v(xbgr.mr_n73572400)
print v(xbgr.mr_n73572656)
print v(xbgr.mr_n73573248)
print v(xbgr.mr_n73573680)
print v(xbgr.mr_n73573856)
print v(xbgr.mr_n73574192)
print v(xbgr.mr_n73574704)
print v(xbgr.mr_n73574816)
print v(xbgr.mr_n73575376)
print v(xbgr.mr_n73575968)
print v(xbgr.mr_n73576752)
print v(xbgr.mr_n73576928)
print v(xbgr.mr_n73577104)
print v(xbgr.mr_n73577616)
print v(xbgr.mr_n73577728)
print v(xbgr.mr_n73577840)
print v(xbgr.mr_n73577952)
print v(xbgr.mr_n73578064)
print v(xbgr.mr_n73578336)
print v(xbgr.mr_n73578688)
print v(xbgr.mr_n73578800)
print v(xbgr.mr_n73579072)
print v(xbgr.mr_n73579424)
print v(xbgr.mr_n73579664)
print v(xbgr.mr_n73580000)
print v(xbgr.mr_n73580352)
print v(xbgr.mr_n73580464)
print v(xbgr.mr_n73580656)
print v(xbgr.mr_n73580928)
print v(xbgr.mr_n73581200)
print v(xbgr.mr_n73581472)
print v(xbgr.mr_n73581744)
print v(xbgr.mr_n73582016)
print v(xbgr.mr_n73582640)
print v(xbgr.mr_n73582832)
print v(xbgr.mr_n73583024)
print v(xbgr.mr_n73583216)
print v(xbgr.mr_n73583968)
print v(xbgr.mr_n73602112)
print v(xbgr.mr_n73602288)
print v(xbgr.mr_n73602992)
print v(xbgr.mr_n73603168)
print v(xbgr.mr_n73603344)
print v(xbgr.mr_n73604048)
print v(xbgr.mr_n73604224)
print v(xbgr.mr_n73604400)
print v(xbgr.mr_n73605104)
print v(xbgr.mr_n73605280)
print v(xbgr.mr_n73605456)
print v(xbgr.mr_n73606160)
print v(xbgr.mr_n73606336)
print v(xbgr.mr_n73606512)
print v(xbgr.mr_n73607216)
print v(xbgr.mr_n73607392)
print v(xbgr.mr_n73607568)
print v(xbgr.mr_n73608144)
print v(xbgr.mr_n73608336)
print v(xbgr.mr_n73608608)
print v(xbgr.mr_n73608880)
print v(xbgr.mr_n73609152)
print v(xbgr.mr_n73609424)
print v(xbgr.mr_n73609696)
print v(xbgr.mr_n73609968)
print v(xbgr.mr_n73610240)
print v(xbgr.mr_n73610512)
print v(xbgr.mr_n73614048)
print v(xbgr.mr_n73614384)
print v(xbgr.mr_n73614720)
print v(xbgr.mr_n73615056)
print v(xbgr.mr_n73615712)
print v(xbgr.mr_n73616352)
print v(xbgr.mr_n73616752)
print v(xbgr.mr_n73617152)
print v(xbgr.mr_n73617552)
print v(xbgr.mr_n73617952)
print v(xbgr.mr_n73618352)
print v(xbgr.mr_n73618752)
print v(xbgr.mr_n73619216)
print v(xbgr.mr_n73619392)
print v(xbgr.mr_n73620016)
print v(xbgr.mr_n73620192)
print v(xbgr.mr_n73620816)
print v(xbgr.mr_n73620992)
print v(xbgr.mr_n73621616)
print v(xbgr.mr_n73621792)
print v(xbgr.mr_n73622416)
print v(xbgr.mr_n73622592)
print v(xbgr.mr_n73623216)
print v(xbgr.mr_n73623392)
print v(xbgr.mr_n73624016)
print v(xbgr.mr_n73624192)
print v(xbgr.mr_n73624816)
print v(xbgr.mr_n73624992)
print v(xbgr.mr_n73625584)
print v(xbgr.mr_n73625696)
print v(xbgr.mr_n73626816)
print v(xbgr.mr_n73627600)
print v(xbgr.mr_n73629424)
print v(xbgr.mr_n73629936)
print v(xbgr.mr_n73632112)
print v(xbgr.mr_n73632704)
print v(xbgr.mr_n73633920)
print v(xbgr.mr_n73634512)
print v(xbgr.mr_n73635808)
print v(xbgr.mr_n73636320)
print v(xbgr.mr_n73637536)
print v(xbgr.mr_n73639424)
print v(xbgr.mr_n73639936)
print v(xbgr.mr_n73641232)
print v(xbgr.mr_n73641744)
print v(xbgr.mr_n73642960)
print v(xbgr.mr_n73643552)
print v(xbgr.mr_n73644848)
print v(xbgr.mr_n73645360)
print v(xbgr.mr_n73646576)
print v(xbgr.mr_n73647168)
print v(xbgr.mr_n73647280)
print v(xbgr.mr_n73647392)
print v(xbgr.mr_n73647504)
print v(xbgr.mr_n73647776)
print v(xbgr.mr_n73647888)
print v(xbgr.mr_n73648240)
print v(xbgr.mr_n73648352)
print v(xbgr.mr_n73648464)
print v(xbgr.mr_n73648896)
print v(xbgr.mr_n73649008)
print v(xbgr.mr_n73649504)
print v(xbgr.mr_n73650192)
print v(xbgr.mr_n73650672)
print v(xbgr.mr_n73651104)
print v(xbgr.mr_n73651520)
print v(xbgr.mr_n73652208)
print v(xbgr.mr_n73652672)
print v(xbgr.mr_n73653088)
print v(xbgr.mr_n73653776)
print v(xbgr.mr_n73654160)
print v(xbgr.mr_n73654656)
print v(xbgr.mr_n73655344)
print v(xbgr.mr_n73655872)
print v(xbgr.mr_n73656224)
print v(xbgr.mr_n73656912)
print v(xbgr.mr_n73657440)
print v(xbgr.mr_n73657792)
print v(xbgr.mr_n73658032)
print v(xbgr.mr_n73658480)
print v(xbgr.mr_n73658864)
print v(xbgr.mr_n73659360)
print v(xbgr.mr_n73660048)
print v(xbgr.mr_n73660512)
print v(xbgr.mr_n73660928)
print v(xbgr.mr_n73661616)
print v(xbgr.mr_n73662080)
print v(xbgr.mr_n73662496)
print v(xbgr.mr_n73663184)
print v(xbgr.mr_n73663712)
print v(xbgr.mr_n73664064)
print v(xbgr.mr_n73664752)
print v(xbgr.mr_n73665216)
print v(xbgr.mr_n73665632)
print v(xbgr.mr_n73666320)
print v(xbgr.mr_n73666848)
print v(xbgr.mr_n73667200)
print v(xbgr.mr_n73667888)
print v(xbgr.mr_n73668272)
print v(xbgr.mr_n73668768)
print v(xbgr.mr_n73669456)
print v(xbgr.mr_n73669920)
print v(xbgr.mr_n73670336)
print v(xbgr.mr_n73670704)
print v(xbgr.mr_n73670848)
print v(xbgr.mr_n73671344)
print v(xbgr.mr_n73673712)
print v(xbgr.mr_n73675504)
print v(xbgr.mr_n73675760)
print v(xbgr.mr_n73676720)
print v(xbgr.mr_n73677312)
print v(xbgr.mr_n73679408)
print v(xbgr.mr_n73681648)
print v(xbgr.mr_n73682112)
print v(xbgr.mr_n73682576)
print v(xbgr.mr_n73683392)
print v(xbgr.mr_n73683824)
print v(xbgr.mr_n73684592)
print v(xbgr.mr_n73685104)
print v(xbgr.mr_n73686464)
print v(xbgr.mr_n73689072)
print v(xbgr.mr_n73692384)
print v(xbgr.mr_n73693312)
print v(xbgr.mr_n73693776)
print v(xbgr.mr_n73694240)
print v(xbgr.mr_n73694704)
print v(xbgr.mr_n73695168)
print v(xbgr.mr_n73695632)
print v(xbgr.mr_n73696096)
print v(xbgr.mr_n73696560)
print v(xbgr.mr_n73697024)
print v(xbgr.mr_n73697488)
print v(xbgr.mr_n73697952)
print v(xbgr.mr_n73698416)
print v(xbgr.mr_n73698880)
print v(xbgr.mr_n73699344)
print v(xbgr.mr_n73699808)
print v(xbgr.mr_n73700272)
print v(xbgr.mr_n73700384)
print v(xbgr.mr_n73701168)
print v(xbgr.mr_n73702432)
print v(xbgr.mr_n73704128)
print v(xbgr.mr_n73704336)
print v(xbgr.mr_n73704672)
print v(xbgr.mr_n73705008)
print v(xbgr.mr_n73707664)
print v(xbgr.mr_n73708256)
print v(xbgr.mr_n73709328)
print v(xbgr.mr_n73709456)
print v(xbgr.mr_n73709568)
print v(xbgr.mr_n73710864)
print v(xbgr.mr_n73713168)
print v(xbgr.mr_n73714272)
print v(xbgr.mr_n73716064)
print v(xbgr.mr_n73718624)
print v(xbgr.mr_n73719008)
print v(xbgr.mr_n73721904)
print v(xbgr.mr_n73722256)
print v(xbgr.mr_n73722400)
print v(xbgr.mr_n73728768)
print v(xbgr.mr_n73729824)
print v(xbgr.mr_n73730016)
print v(xbgr.mr_n73730800)
print v(xbgr.mr_n73731056)
print v(xbgr.mr_n73731616)
print v(xbgr.mr_n73731728)
print v(xbgr.mr_n73732976)
print v(xbgr.mr_n73733168)
print v(xbgr.mr_n73733952)
print v(xbgr.mr_n73753216)
print v(xbgr.mr_n73754000)
print v(xbgr.mr_n73754176)
print v(xbgr.mr_n73754736)
print v(xbgr.mr_n73755264)
print v(xbgr.mr_n73755440)
print v(xbgr.mr_n73755696)
print v(xbgr.mr_n73756400)
print v(xbgr.mr_n73756576)
print v(xbgr.mr_n73757136)
print v(xbgr.mr_n73757600)
print v(xbgr.mr_n73757776)
print v(xbgr.mr_n73758464)
print v(xbgr.mr_n73758640)
print v(xbgr.mr_n73758816)
print v(xbgr.mr_n73759536)
print v(xbgr.mr_n73759840)
print v(xbgr.mr_n73760000)
print v(xbgr.mr_n73760176)
print v(xbgr.mr_n73761552)
print v(xbgr.mr_n73762256)
print v(xbgr.mr_n73764512)
print v(xbgr.mr_n73764976)
print v(xbgr.mr_n73765440)
print v(xbgr.mr_n73765904)
print v(xbgr.mr_n73766368)
print v(xbgr.mr_n73766832)
print v(xbgr.mr_n73767296)
print v(xbgr.mr_n73767760)
print v(xbgr.mr_n73768224)
print v(xbgr.mr_n73768688)
print v(xbgr.mr_n73769152)
print v(xbgr.mr_n73769616)
print v(xbgr.mr_n73770080)
print v(xbgr.mr_n73770544)
print v(xbgr.mr_n73771008)
print v(xbgr.mr_n73771472)
print v(xbgr.mr_n73771936)
print v(xbgr.mr_n73773920)
print v(xbgr.mr_n73775968)
print v(xbgr.mr_n73778784)
print v(xbgr.mr_n73788256)
print v(xbgr.mr_n73788720)
print v(xbgr.mr_n73789088)
print v(xbgr.mr_n73789440)
print v(xbgr.mr_n73790944)
print v(xbgr.mr_n73791200)
print v(xbgr.mr_n73798832)
print v(xbgr.mr_n73802272)
print v(xbgr.mr_n73805680)
print v(xbgr.mr_n73806544)
print v(xbgr.mr_n73807456)
print v(xbgr.mr_n73807648)
print v(xbgr.mr_n73807904)
print v(xbgr.mr_n73808160)
print v(xbgr.mr_n73810128)
print v(xbgr.mr_n73810912)
print v(xbgr.mr_n73811024)
print v(xbgr.mr_n73813488)
print v(xbgr.mr_n73814816)
print v(xbgr.mr_n73816864)
print v(xbgr.mr_n73819632)
print v(xbgr.mr_n73820960)
print v(xbgr.mr_n73823008)
print v(xbgr.mr_n73825776)
print v(xbgr.mr_n73827104)
print v(xbgr.mr_n73829152)
print v(xbgr.mr_n73831920)
print v(xbgr.mr_n73833248)
print v(xbgr.mr_n73835296)
print v(xbgr.mr_n73838064)
print v(xbgr.mr_n73839392)
print v(xbgr.mr_n73841440)
print v(xbgr.mr_n73844208)
print v(xbgr.mr_n73845536)
print v(xbgr.mr_n73847920)
print v(xbgr.mr_n73848688)
print v(xbgr.mr_n73852848)
print v(xbgr.mr_n73853248)
print v(xbgr.mr_n73853648)
print v(xbgr.mr_n73854048)
print v(xbgr.mr_n73854448)
print v(xbgr.mr_n73854848)
print v(xbgr.mr_n73855248)
print v(xbgr.mr_n73855648)
print v(xbgr.mr_n73856048)
print v(xbgr.mr_n73856448)
print v(xbgr.mr_n73856768)
print v(xbgr.mr_n73857168)
print v(xbgr.mr_n73857568)
print v(xbgr.mr_n73857968)
print v(xbgr.mr_n73858368)
print v(xbgr.mr_n73858768)
print v(xbgr.mr_n73859040)
print v(xbgr.mr_n73859152)
print v(xbgr.mr_n73859264)
print v(xbgr.mr_n73859376)
print v(xbgr.mr_n73859488)
print v(xbgr.mr_n73859680)
print v(xbgr.mr_n73859952)
print v(xbgr.mr_n73860224)
print v(xbgr.mr_n73860496)
print v(xbgr.mr_n73860768)
print v(xbgr.mr_n73861040)
print v(xbgr.mr_n73861312)
print v(xbgr.mr_n73861584)
print v(xbgr.mr_n73861920)
print v(xbgr.mr_n73862320)
print v(xbgr.mr_n73862784)
print v(xbgr.mr_n73872512)
print v(xbgr.mr_n73874880)
print v(xbgr.mr_n73875136)
print v(xbgr.mr_n73875520)
print v(xbgr.mr_n73876608)
print v(xbgr.mr_n73877152)
print v(xbgr.mr_n73877328)
print v(xbgr.mr_n73878176)
print v(xbgr.mr_n73878528)
print v(xbgr.mr_n73878656)
print v(xbgr.mr_n73879152)
print v(xbgr.mr_n73879696)
print v(xbgr.mr_n73879872)
print v(xbgr.mr_n73880656)
print v(xbgr.mr_n73881200)
print v(xbgr.mr_n73881696)
print v(xbgr.mr_n73882240)
print v(xbgr.mr_n73882416)
print v(xbgr.mr_n73883200)
print v(xbgr.mr_n73883744)
print v(xbgr.mr_n73884240)
print v(xbgr.mr_n73884784)
print v(xbgr.mr_n73884960)
print v(xbgr.mr_n73885808)
print v(xbgr.mr_n73886288)
print v(xbgr.mr_n73886784)
print v(xbgr.mr_n73887328)
print v(xbgr.mr_n73887504)
print v(xbgr.mr_n73888352)
print v(xbgr.mr_n73888832)
print v(xbgr.mr_n73889328)
print v(xbgr.mr_n73889872)
print v(xbgr.mr_n73890048)
print v(xbgr.mr_n73890832)
print v(xbgr.mr_n73891376)
print v(xbgr.mr_n73891872)
print v(xbgr.mr_n73892416)
print v(xbgr.mr_n73892592)
print v(xbgr.mr_n73893376)
print v(xbgr.mr_n73893920)
print v(xbgr.mr_n73894352)
print v(xbgr.mr_n73894960)
print v(xbgr.mr_n73895136)
print v(xbgr.mr_n73904368)
print v(xbgr.mr_n73904560)
print v(xbgr.mr_n73904752)
print v(xbgr.mr_n73905008)
print v(xbgr.mr_n73905264)
print v(xbgr.mr_n73907232)
print v(xbgr.mr_n73932240)
print v(xbgr.mr_n73932736)
print v(xbgr.mr_n73933040)
print v(xbgr.mr_n73933536)
print v(xbgr.mr_n73933840)
print v(xbgr.mr_n73934400)
print v(xbgr.mr_n73934704)
print v(xbgr.mr_n73935584)
print v(xbgr.mr_n73935888)
print v(xbgr.mr_n73936768)
print v(xbgr.mr_n73937072)
print v(xbgr.mr_n73937952)
print v(xbgr.mr_n73938256)
print v(xbgr.mr_n73939136)
print v(xbgr.mr_n73939440)
print v(xbgr.mr_n73940320)
print v(xbgr.mr_n73940624)
print v(xbgr.mr_n73941504)
print v(xbgr.mr_n73941808)
print v(xbgr.mr_n73942064)
print v(xbgr.mr_n73942688)
print v(xbgr.mr_n73942992)
print v(xbgr.mr_n73943872)
print v(xbgr.mr_n73944176)
print v(xbgr.mr_n73944352)
print v(xbgr.mr_n73945056)
print v(xbgr.mr_n73945360)
print v(xbgr.mr_n73946240)
print v(xbgr.mr_n73946544)
print v(xbgr.mr_n73947424)
print v(xbgr.mr_n73947728)
print v(xbgr.mr_n73948608)
print v(xbgr.mr_n73948800)
print v(xbgr.mr_n73949072)
print v(xbgr.mr_n73949536)
print v(xbgr.mr_n73960848)
print v(xbgr.mr_n73962288)
print v(xbgr.mr_n73964016)
print v(xbgr.mr_n73965584)
print v(xbgr.mr_n73965920)
print v(xbgr.mr_n73966256)
print v(xbgr.mr_n73966592)
print v(xbgr.mr_n73967376)
print v(xbgr.mr_n73968144)
print v(xbgr.mr_n73968624)
print v(xbgr.mr_n73969392)
print v(xbgr.mr_n73969792)
print v(xbgr.mr_n73970192)
print v(xbgr.mr_n73970592)
print v(xbgr.mr_n73970992)
print v(xbgr.mr_n73971392)
print v(xbgr.mr_n73971792)
print v(xbgr.mr_n73972192)
print v(xbgr.mr_n73972592)
print v(xbgr.mr_n73972992)
print v(xbgr.mr_n73973392)
print v(xbgr.mr_n73973792)
print v(xbgr.mr_n73974192)
print v(xbgr.mr_n73974592)
print v(xbgr.mr_n73974992)
print v(xbgr.mr_n73975392)
print v(xbgr.mr_n73979968)
print v(xbgr.mr_n73980336)
print v(xbgr.mr_n73983920)
print v(xbgr.mr_n73988352)
print v(xbgr.mr_n73995888)
print v(xbgr.mr_n73999488)
print v(xbgr.mr_n74005360)
print v(xbgr.mr_n74005808)
print v(xbgr.mr_n74006112)
print v(xbgr.mr_n74006416)
print v(xbgr.mr_n74006720)
print v(xbgr.mr_n74007104)
print v(xbgr.mr_n74007568)
print v(xbgr.mr_n74008032)
print v(xbgr.mr_n74008496)
print v(xbgr.mr_n74008960)
print v(xbgr.mr_n74009424)
print v(xbgr.mr_n74009888)
print v(xbgr.mr_n74010352)
print v(xbgr.mr_n74010816)
print v(xbgr.mr_n74011440)
print v(xbgr.mr_n74011552)
print v(xbgr.mr_n74012576)
print v(xbgr.mr_n74013792)
print v(xbgr.mr_n74017792)
print v(xbgr.mr_n74021696)
print v(xbgr.mr_n74022704)
print v(xbgr.mr_n74024352)
print v(xbgr.mr_n74024688)
print v(xbgr.mr_n74025024)
print v(xbgr.mr_n74025360)
print v(xbgr.mr_n74026416)
print v(xbgr.mr_n74026688)
print v(xbgr.mr_n74027680)
print v(xbgr.mr_n74028320)
print v(xbgr.mr_n74028432)
print v(xbgr.mr_n74028624)
print v(xbgr.mr_n74030656)
print v(xbgr.mr_n74030768)
print v(xbgr.mr_n74030880)
print v(xbgr.mr_n74031472)
print v(xbgr.mr_n74032752)
print v(xbgr.mr_n74033392)
print v(xbgr.mr_n74033504)
print v(xbgr.mr_n74033776)
print v(xbgr.mr_n74036704)
print v(xbgr.mr_n74037488)
print v(xbgr.mr_n74037600)
print v(xbgr.mr_n74039584)
print v(xbgr.mr_n74039696)
print v(xbgr.mr_n74039808)
print v(xbgr.mr_n74040080)
print v(xbgr.mr_n74041904)
print v(xbgr.mr_n74042832)
print v(xbgr.mr_n74042944)
print v(xbgr.mr_n74044208)
print v(xbgr.mr_n74044768)
print v(xbgr.mr_n74045552)
print v(xbgr.mr_n74045664)
print v(xbgr.mr_n74047248)
print v(xbgr.mr_n74047888)
print v(xbgr.mr_n74048000)
print v(xbgr.mr_n74049696)
print v(xbgr.mr_n74049808)
print v(xbgr.mr_n74049920)
print v(xbgr.mr_n74050192)
print v(xbgr.mr_n74052352)
print v(xbgr.mr_n74052464)
print v(xbgr.mr_n74052656)
print v(xbgr.mr_n74054128)
print v(xbgr.mr_n74055024)
print v(xbgr.mr_n74055664)
print v(xbgr.mr_n74055776)
print v(xbgr.mr_n74057280)
print v(xbgr.mr_n74058000)
print v(xbgr.mr_n74058112)
print v(xbgr.mr_n74059808)
print v(xbgr.mr_n74059920)
print v(xbgr.mr_n74060032)
print v(xbgr.mr_n74060304)
print v(xbgr.mr_n74062464)
print v(xbgr.mr_n74062576)
print v(xbgr.mr_n74062768)
print v(xbgr.mr_n74064800)
print v(xbgr.mr_n74064912)
print v(xbgr.mr_n74065024)
print v(xbgr.mr_n74065296)
print v(xbgr.mr_n74067520)
print v(xbgr.mr_n74067632)
print v(xbgr.mr_n74067824)
print v(xbgr.mr_n74068336)
print v(xbgr.mr_n74068608)
print v(xbgr.mr_n74069024)
print v(xbgr.mr_n74069648)
print v(xbgr.mr_n74070176)
print v(xbgr.mr_n74070528)
print v(xbgr.mr_n74071216)
print v(xbgr.mr_n74071744)
print v(xbgr.mr_n74072096)
print v(xbgr.mr_n74072272)
print v(xbgr.mr_n74072784)
print v(xbgr.mr_n74073312)
print v(xbgr.mr_n74073664)
print v(xbgr.mr_n74074352)
print v(xbgr.mr_n74074816)
print v(xbgr.mr_n74075232)
print v(xbgr.mr_n74075920)
print v(xbgr.mr_n74076448)
print v(xbgr.mr_n74076800)
print v(xbgr.mr_n74077488)
print v(xbgr.mr_n74078016)
print v(xbgr.mr_n74078368)
print v(xbgr.mr_n74079056)
print v(xbgr.mr_n74079584)
print v(xbgr.mr_n74079936)
print v(xbgr.mr_n74080624)
print v(xbgr.mr_n74081088)
print v(xbgr.mr_n74081504)
print v(xbgr.mr_n74082192)
print v(xbgr.mr_n74082656)
print v(xbgr.mr_n74083072)
print v(xbgr.mr_n74083760)
print v(xbgr.mr_n74084224)
print v(xbgr.mr_n74084640)
print v(xbgr.mr_n74085328)
print v(xbgr.mr_n74085856)
print v(xbgr.mr_n74091072)
print v(xbgr.mr_n74091376)
print v(xbgr.mr_n74091760)
print v(xbgr.mr_n74096672)
print v(xbgr.mr_n74100448)
print v(xbgr.mr_n74101040)
print v(xbgr.mr_n74105056)
print v(xbgr.mr_n74106688)
print v(xbgr.mr_n74107152)
print v(xbgr.mr_n74107616)
print v(xbgr.mr_n74108080)
print v(xbgr.mr_n74108544)
print v(xbgr.mr_n74109008)
print v(xbgr.mr_n74109472)
print v(xbgr.mr_n74109936)
print v(xbgr.mr_n74110400)
print v(xbgr.mr_n74110864)
print v(xbgr.mr_n74111328)
print v(xbgr.mr_n74111792)
print v(xbgr.mr_n74112256)
print v(xbgr.mr_n74112720)
print v(xbgr.mr_n74113184)
print v(xbgr.mr_n74113648)
print v(xbgr.mr_n74114112)
print v(xbgr.mr_n74114576)
print v(xbgr.mr_n74115040)
print v(xbgr.mr_n74116528)
print v(xbgr.mr_n74119648)
print v(xbgr.mr_n74121200)
print v(xbgr.mr_n74122272)
print v(xbgr.mr_n74124080)
print v(xbgr.mr_n74126368)
print v(xbgr.mr_n74127968)
print v(xbgr.mr_n74129328)
print v(xbgr.mr_n74129696)
print v(xbgr.mr_n74130160)
print v(xbgr.mr_n74130736)
print v(xbgr.mr_n74134624)
print v(xbgr.mr_n74136992)
print v(xbgr.mr_n74138576)
print v(xbgr.mr_n74138768)
print v(xbgr.mr_n74139024)
print v(xbgr.mr_n74139280)
print v(xbgr.mr_n74141248)
print v(xbgr.mr_n74166352)
print v(xbgr.mr_n74166464)
print v(xbgr.mr_n74166576)
print v(xbgr.mr_n74166688)
print v(xbgr.mr_n74166800)
print v(xbgr.mr_n74166912)
print v(xbgr.mr_n74167248)
print v(xbgr.mr_n74167584)
print v(xbgr.mr_n74169040)
print v(xbgr.mr_n74169216)
print v(xbgr.mr_n74169696)
print v(xbgr.mr_n74169872)
print v(xbgr.mr_n74170352)
print v(xbgr.mr_n74170528)
print v(xbgr.mr_n74171008)
print v(xbgr.mr_n74171184)
print v(xbgr.mr_n74171664)
print v(xbgr.mr_n74171840)
print v(xbgr.mr_n74172320)
print v(xbgr.mr_n74172496)
print v(xbgr.mr_n74172976)
print v(xbgr.mr_n74173152)
print v(xbgr.mr_n74173632)
print v(xbgr.mr_n74173808)
print v(xbgr.mr_n74177168)
print v(xbgr.mr_n74177504)
print v(xbgr.mr_n74178160)
print v(xbgr.mr_n74178992)
print v(xbgr.mr_n74179168)
print v(xbgr.mr_n74179344)
print v(xbgr.mr_n74180048)
print v(xbgr.mr_n74180224)
print v(xbgr.mr_n74180784)
print v(xbgr.mr_n74181248)
print v(xbgr.mr_n74181424)
print v(xbgr.mr_n74181600)
print v(xbgr.mr_n74182304)
print v(xbgr.mr_n74182480)
print v(xbgr.mr_n74183104)
print v(xbgr.mr_n74183280)
print v(xbgr.mr_n74183456)
print v(xbgr.mr_n74183968)
print v(xbgr.mr_n74184400)
print v(xbgr.mr_n74184576)
print v(xbgr.mr_n74184912)
print v(xbgr.mr_n74185616)
print v(xbgr.mr_n74185792)
print v(xbgr.mr_n74186416)
print v(xbgr.mr_n74186592)
print v(xbgr.mr_n74186768)
print v(xbgr.mr_n74187472)
print v(xbgr.mr_n74187648)
print v(xbgr.mr_n74188272)
print v(xbgr.mr_n74188448)
print v(xbgr.mr_n74188624)
print v(xbgr.mr_n74189264)
print v(xbgr.mr_n74189536)
print v(xbgr.mr_n74189968)
print v(xbgr.mr_n74190144)
print v(xbgr.mr_n74190400)
print v(xbgr.mr_n74191184)
print v(xbgr.mr_n74191360)
print v(xbgr.mr_n74191984)
print v(xbgr.mr_n74192160)
print v(xbgr.mr_n74192336)
print v(xbgr.mr_n74192976)
print v(xbgr.mr_n74193248)
print v(xbgr.mr_n74193360)
print v(xbgr.mr_n74193472)
print v(xbgr.mr_n74193584)
print v(xbgr.mr_n74193696)
print v(xbgr.mr_n74193968)
print v(xbgr.mr_n74194320)
print v(xbgr.mr_n74194432)
print v(xbgr.mr_n74194544)
print v(xbgr.mr_n74194976)
print v(xbgr.mr_n74195456)
print v(xbgr.mr_n74195632)
print v(xbgr.mr_n74195984)
print v(xbgr.mr_n74196352)
print v(xbgr.mr_n74196688)
print v(xbgr.mr_n74197040)
print v(xbgr.mr_n74197152)
print v(xbgr.mr_n74197648)
print v(xbgr.mr_n74198144)
print v(xbgr.mr_n74198624)
print v(xbgr.mr_n74198800)
print v(xbgr.mr_n74199152)
print v(xbgr.mr_n74199520)
print v(xbgr.mr_n74199856)
print v(xbgr.mr_n74200208)
print v(xbgr.mr_n74200320)
print v(xbgr.mr_n74200816)
print v(xbgr.mr_n74201312)
print v(xbgr.mr_n74201792)
print v(xbgr.mr_n74201968)
print v(xbgr.mr_n74202320)
print v(xbgr.mr_n74202688)
print v(xbgr.mr_n74203024)
print v(xbgr.mr_n74203376)
print v(xbgr.mr_n74215264)
print v(xbgr.mr_n74215648)
print v(xbgr.mr_n74216112)
print v(xbgr.mr_n74216576)
print v(xbgr.mr_n74217040)
print v(xbgr.mr_n74217504)
print v(xbgr.mr_n74217968)
print v(xbgr.mr_n74218432)
print v(xbgr.mr_n74218896)
print v(xbgr.mr_n74219360)
print v(xbgr.mr_n74219824)
print v(xbgr.mr_n74220288)
print v(xbgr.mr_n74220752)
print v(xbgr.mr_n74221216)
print v(xbgr.mr_n74221680)
print v(xbgr.mr_n74222144)
print v(xbgr.mr_n74222608)
print v(xbgr.mr_n74223072)
print v(xbgr.mr_n74223536)
print v(xbgr.mr_n74224000)
print v(xbgr.mr_n74224464)
print v(xbgr.mr_n74224928)
print v(xbgr.mr_n74225392)
print v(xbgr.mr_n74225856)
print v(xbgr.mr_n74226384)
print v(xbgr.mr_n74226976)
print v(xbgr.mr_n74229520)
print v(xbgr.mr_n74232928)
print v(xbgr.mr_n74236688)
print v(xbgr.mr_n74241888)
print v(xbgr.mr_n74247376)
print v(xbgr.mr_n74248928)
print v(xbgr.mr_n74252624)
print v(xbgr.mr_n74253408)
print v(xbgr.mr_n74253664)
print v(xbgr.mr_n74259024)
print v(xbgr.mr_n74259200)
print v(xbgr.mr_n74259536)
print v(xbgr.mr_n74260496)
print v(xbgr.mr_n74261408)
print v(xbgr.mr_n74261520)
print v(xbgr.mr_n74261712)
print v(xbgr.mr_n74262464)
print v(xbgr.mr_n74264752)
print v(xbgr.mr_n74265088)
print v(xbgr.mr_n74265840)
print v(xbgr.mr_n74279440)
print v(xbgr.mr_n74280800)
print v(xbgr.mr_n74281440)
print v(xbgr.mr_n74281872)
print v(xbgr.mr_n74282048)
print v(xbgr.mr_n74282384)
print v(xbgr.mr_n74283088)
print v(xbgr.mr_n74283264)
print v(xbgr.mr_n74283888)
print v(xbgr.mr_n74284064)
print v(xbgr.mr_n74284688)
print v(xbgr.mr_n74284864)
print v(xbgr.mr_n74285488)
print v(xbgr.mr_n74285664)
print v(xbgr.mr_n74286288)
print v(xbgr.mr_n74286464)
print v(xbgr.mr_n74287088)
print v(xbgr.mr_n74287264)
print v(xbgr.mr_n74287888)
print v(xbgr.mr_n74288064)
print v(xbgr.mr_n74288336)
print v(xbgr.mr_n74288624)
print v(xbgr.mr_n74288736)
print v(xbgr.mr_n74288976)
print v(xbgr.mr_n74289088)
print v(xbgr.mr_n74289200)
print v(xbgr.mr_n74301424)
print v(xbgr.mr_n74301776)
print v(xbgr.mr_n74301888)
print v(xbgr.mr_n74302240)
print v(xbgr.mr_n74302352)
print v(xbgr.mr_n74302624)
print v(xbgr.mr_n74303040)
print v(xbgr.mr_n74304592)
print v(xbgr.mr_n74304784)
print v(xbgr.mr_n74304976)
print v(xbgr.mr_n74305408)
print v(xbgr.mr_n74305728)
print v(xbgr.mr_n74306976)
print v(xbgr.mr_n74309808)
print v(xbgr.mr_n74309984)
print v(xbgr.mr_n74310240)
print v(xbgr.mr_n74310752)
print v(xbgr.mr_n74310912)
print v(xbgr.mr_n74311248)
print v(xbgr.mr_n74312464)
print v(xbgr.mr_n74313296)
print v(xbgr.mr_n74313600)
print v(xbgr.mr_n74315680)
print v(xbgr.mr_n74315792)
print v(xbgr.mr_n74315968)
print v(xbgr.mr_n74316384)
print v(xbgr.mr_n74317360)
print v(xbgr.mr_n74317664)
print v(xbgr.mr_n74318416)
print v(xbgr.mr_n74319536)
print v(xbgr.mr_n74319648)
print v(xbgr.mr_n74320672)
print v(xbgr.mr_n74320944)
print v(xbgr.mr_n74321616)
print v(xbgr.mr_n74322480)
print v(xbgr.mr_n74323376)
print v(xbgr.mr_n74323488)
print v(xbgr.mr_n74323936)
print v(xbgr.mr_n74325616)
print v(xbgr.mr_n74326400)
print v(xbgr.mr_n74327216)
print v(xbgr.mr_n74327552)
print v(xbgr.mr_n74330928)
print v(xbgr.mr_n74331120)
print v(xbgr.mr_n74331632)
print v(xbgr.mr_n74331872)
print v(xbgr.mr_n74332176)
print v(xbgr.mr_n74332288)
print v(xbgr.mr_n74332480)
print v(xbgr.mr_n74332592)
print v(xbgr.mr_n74333328)
print v(xbgr.mr_n74336528)
print v(xbgr.mr_n74337472)
print v(xbgr.mr_n74339184)
print v(xbgr.mr_n74339376)
print v(xbgr.mr_n74340048)
print v(xbgr.mr_n74341648)
print v(xbgr.mr_n74341840)
print v(xbgr.mr_n74342480)
print v(xbgr.mr_n74342896)
print v(xbgr.mr_n74343376)
print v(xbgr.mr_n74343568)
print v(xbgr.mr_n74343760)
print v(xbgr.mr_n74343952)
print v(xbgr.mr_n74344848)
print v(xbgr.mr_n74345680)
print v(xbgr.mr_n74345952)
print v(xbgr.mr_n74346832)
print v(xbgr.mr_n74347136)
print v(xbgr.mr_n74347760)
print v(xbgr.mr_n74348112)
print v(xbgr.mr_n74348480)
print v(xbgr.mr_n74348896)
print v(xbgr.mr_n74349328)
print v(xbgr.mr_n74349728)
print v(xbgr.mr_n74350144)
print v(xbgr.mr_n74350576)
print v(xbgr.mr_n74350880)
print v(xbgr.mr_n74351504)
print v(xbgr.mr_n74351856)
print v(xbgr.mr_n74352288)
print v(xbgr.mr_n74352640)
print v(xbgr.mr_n74353072)
print v(xbgr.mr_n74353536)
print v(xbgr.mr_n74353888)
print v(xbgr.mr_n74354064)
print v(xbgr.mr_n74354320)
print v(xbgr.mr_n74354624)
print v(xbgr.mr_n74355184)
print v(xbgr.mr_n74355600)
print v(xbgr.mr_n74355968)
print v(xbgr.mr_n74356384)
print v(xbgr.mr_n74356816)
print v(xbgr.mr_n74357280)
print v(xbgr.mr_n74357632)
print v(xbgr.mr_n74358064)
print v(xbgr.mr_n74358256)
print v(xbgr.mr_n74358528)
print v(xbgr.mr_n74358800)
print v(xbgr.mr_n74359072)
print v(xbgr.mr_n74359344)
print v(xbgr.mr_n74359616)
print v(xbgr.mr_n74359888)
print v(xbgr.mr_n74360160)
print v(xbgr.mr_n74360432)
print v(xbgr.mr_n74360704)
print v(xbgr.mr_n74360976)
print v(xbgr.mr_n74361248)
print v(xbgr.mr_n74361520)
print v(xbgr.mr_n74361792)
print v(xbgr.mr_n74362128)
print v(xbgr.mr_n74362592)
print v(xbgr.mr_n74363056)
print v(xbgr.mr_n74364064)
print v(xbgr.mr_n74371184)
print v(xbgr.mr_n74373296)
print v(xbgr.mr_n74374368)
print v(xbgr.mr_n74378400)
print v(xbgr.mr_n74378512)
print v(xbgr.mr_n74382944)
print v(xbgr.mr_n74390816)
print v(xbgr.mr_n74393184)
print v(xbgr.mr_n74394464)
print v(xbgr.mr_n74395104)
print v(xbgr.mr_n74395440)
print v(xbgr.mr_n74395776)
print v(xbgr.mr_n74396112)
print v(xbgr.mr_n74396448)
print v(xbgr.mr_n74396624)
print v(xbgr.mr_n74396736)
print v(xbgr.mr_n74396848)
print v(xbgr.mr_n74396960)
print v(xbgr.mr_n74397152)
print v(xbgr.mr_n74397264)
print v(xbgr.mr_n74397376)
print v(xbgr.mr_n74397808)
print v(xbgr.mr_n74398160)
print v(xbgr.mr_n74398272)
print v(xbgr.mr_n74398928)
print v(xbgr.mr_n74399120)
print v(xbgr.mr_n74399728)
print v(xbgr.mr_n74400096)
print v(xbgr.mr_n74400464)
print v(xbgr.mr_n74401776)
print v(xbgr.mr_n74402800)
print v(xbgr.mr_n74404320)
print v(xbgr.mr_n74404512)
print v(xbgr.mr_n74404704)
print v(xbgr.mr_n74405872)
print v(xbgr.mr_n74406336)
print v(xbgr.mr_n74407632)
print v(xbgr.mr_n74407824)
print v(xbgr.mr_n74408016)
print v(xbgr.mr_n74409552)
print v(xbgr.mr_n74409808)
print v(xbgr.mr_n74410432)
print v(xbgr.mr_n74410704)
print v(xbgr.mr_n74410896)
print v(xbgr.mr_n74411088)
print v(xbgr.mr_n74411280)
print v(xbgr.mr_n74412384)
print v(xbgr.mr_n74413344)
print v(xbgr.mr_n74413456)
print v(xbgr.mr_n74413728)
print v(xbgr.mr_n74414080)
print v(xbgr.mr_n74414512)
print v(xbgr.mr_n74414816)
print v(xbgr.mr_n74415440)
print v(xbgr.mr_n74415792)
print v(xbgr.mr_n74416160)
print v(xbgr.mr_n74416576)
print v(xbgr.mr_n74416816)
print v(xbgr.mr_n74417008)
print v(xbgr.mr_n74417408)
print v(xbgr.mr_n74417824)
print v(xbgr.mr_n74418256)
print v(xbgr.mr_n74418560)
print v(xbgr.mr_n74419184)
print v(xbgr.mr_n74419536)
print v(xbgr.mr_n74419968)
print v(xbgr.mr_n74420320)
print v(xbgr.mr_n74420752)
print v(xbgr.mr_n74421216)
print v(xbgr.mr_n74421568)
print v(xbgr.mr_n74422000)
print v(xbgr.mr_n74422192)
print v(xbgr.mr_n74422304)
print v(xbgr.mr_n74422928)
print v(xbgr.mr_n74423280)
print v(xbgr.mr_n74423712)
print v(xbgr.mr_n74424064)
print v(xbgr.mr_n74424496)
print v(xbgr.mr_n74424896)
print v(xbgr.mr_n74425312)
print v(xbgr.mr_n74425744)
print v(xbgr.mr_n74426048)
print v(xbgr.mr_n74426608)
print v(xbgr.mr_n74427024)
print v(xbgr.mr_n74427136)
print v(xbgr.mr_n74427328)
print v(xbgr.mr_n74427600)
print v(xbgr.mr_n74427872)
print v(xbgr.mr_n74428144)
print v(xbgr.mr_n74428416)
print v(xbgr.mr_n74428688)
print v(xbgr.mr_n74428960)
print v(xbgr.mr_n74429232)
print v(xbgr.mr_n74429504)
print v(xbgr.mr_n74429776)
print v(xbgr.mr_n74430048)
print v(xbgr.mr_n74430320)
print v(xbgr.mr_n74430592)
print v(xbgr.mr_n74430864)
print v(xbgr.mr_n74431136)
print v(xbgr.mr_n74431600)
print v(xbgr.mr_n74435184)
print v(xbgr.mr_n74437792)
print v(xbgr.mr_n74437904)
print v(xbgr.mr_n74442272)
print v(xbgr.mr_n74443184)
print v(xbgr.mr_n74443600)
print v(xbgr.mr_n74446080)
print v(xbgr.mr_n74448512)
print v(xbgr.mr_n74449040)
print v(xbgr.mr_n74453088)
print v(xbgr.mr_n74453280)
print v(xbgr.mr_n74453472)
print v(xbgr.mr_n74453728)
print v(xbgr.mr_n74453984)
print v(xbgr.mr_n74455952)
print v(xbgr.mr_n74456064)
print v(xbgr.mr_n74456336)
print v(xbgr.mr_n74456816)
print v(xbgr.mr_n74458624)
print v(xbgr.mr_n74458768)
print v(xbgr.mr_n74459344)
print v(xbgr.mr_n74460080)
print v(xbgr.mr_n74460336)
print v(xbgr.mr_n74460480)
print v(xbgr.mr_n74461344)
print v(xbgr.mr_n74462656)
print v(xbgr.mr_n74463616)
print v(xbgr.mr_n74464400)
print v(xbgr.mr_n74466256)
print v(xbgr.mr_n74466912)
print v(xbgr.mr_n74467424)
print v(xbgr.mr_n74468720)
print v(xbgr.mr_n74469232)
print v(xbgr.mr_n74470528)
print v(xbgr.mr_n74471040)
print v(xbgr.mr_n74472256)
print v(xbgr.mr_n74472848)
print v(xbgr.mr_n74473904)
print v(xbgr.mr_n74474656)
print v(xbgr.mr_n74475952)
print v(xbgr.mr_n74476464)
print v(xbgr.mr_n74477680)
print v(xbgr.mr_n74478272)
print v(xbgr.mr_n74479568)
print v(xbgr.mr_n74480080)
print v(xbgr.mr_n74481296)
print v(xbgr.mr_n74481888)
print v(xbgr.mr_n74482000)
print v(xbgr.mr_n74482112)
print v(xbgr.mr_n74482224)
print v(xbgr.mr_n74482336)
print v(xbgr.mr_n74482528)
print v(xbgr.mr_n74482960)
print v(xbgr.mr_n74483072)
print v(xbgr.mr_n74483344)
print v(xbgr.mr_n74483696)
print v(xbgr.mr_n74483936)
print v(xbgr.mr_n74484272)
print v(xbgr.mr_n74484688)
print v(xbgr.mr_n74485120)
print v(xbgr.mr_n74485808)
print v(xbgr.mr_n74486432)
print v(xbgr.mr_n74486976)
print v(xbgr.mr_n74487408)
print v(xbgr.mr_n74487824)
print v(xbgr.mr_n74488512)
print v(xbgr.mr_n74488976)
print v(xbgr.mr_n74489392)
print v(xbgr.mr_n74489824)
print v(xbgr.mr_n74489936)
print v(xbgr.mr_n74490512)
print v(xbgr.mr_n74491200)
print v(xbgr.mr_n74491680)
print v(xbgr.mr_n74492176)
print v(xbgr.mr_n74492528)
print v(xbgr.mr_n74493216)
print v(xbgr.mr_n74493680)
print v(xbgr.mr_n74494096)
print v(xbgr.mr_n74495216)
print v(xbgr.mr_n74495904)
print v(xbgr.mr_n74496384)
print v(xbgr.mr_n74496880)
print v(xbgr.mr_n74497232)
print v(xbgr.mr_n74497920)
print v(xbgr.mr_n74498448)
print v(xbgr.mr_n74498800)
print v(xbgr.mr_n74499232)
print v(xbgr.mr_n74499920)
print v(xbgr.mr_n74500544)
print v(xbgr.mr_n74501088)
print v(xbgr.mr_n74501520)
print v(xbgr.mr_n74501936)
print v(xbgr.mr_n74502624)
print v(xbgr.mr_n74503152)
print v(xbgr.mr_n74503504)
print v(xbgr.mr_n74503936)
print v(xbgr.mr_n74504624)
print v(xbgr.mr_n74505248)
print v(xbgr.mr_n74505792)
print v(xbgr.mr_n74506288)
print v(xbgr.mr_n74506640)
print v(xbgr.mr_n74507328)
print v(xbgr.mr_n74507792)
print v(xbgr.mr_n74508208)
print v(xbgr.mr_n74508640)
print v(xbgr.mr_n74508832)
print v(xbgr.mr_n74509104)
print v(xbgr.mr_n74509376)
print v(xbgr.mr_n74509648)
print v(xbgr.mr_n74509920)
print v(xbgr.mr_n74510192)
print v(xbgr.mr_n74510464)
print v(xbgr.mr_n74510736)
print v(xbgr.mr_n74511008)
print v(xbgr.mr_n74511280)
print v(xbgr.mr_n74511552)
print v(xbgr.mr_n74511824)
print v(xbgr.mr_n74512096)
print v(xbgr.mr_n74524304)
print v(xbgr.mr_n74524560)
print v(xbgr.mr_n74536816)
print v(xbgr.mr_n74537280)
print v(xbgr.mr_n74537744)
print v(xbgr.mr_n74538208)
print v(xbgr.mr_n74538672)
print v(xbgr.mr_n74545776)
print v(xbgr.mr_n74550560)
print v(xbgr.mr_n74557872)
print v(xbgr.mr_n74563552)
print v(xbgr.mr_n74569264)
print v(xbgr.mr_n74571152)
print v(xbgr.mr_n74571344)
print v(xbgr.mr_n74573104)
print v(xbgr.mr_n74577984)
print v(xbgr.mr_n74580000)
print v(xbgr.mr_n74580336)
print v(xbgr.mr_n74582368)
print v(xbgr.mr_n74584112)
print v(xbgr.mr_n74584704)
print v(xbgr.mr_n74585920)
print v(xbgr.mr_n74586512)
print v(xbgr.mr_n74587728)
print v(xbgr.mr_n74588320)
print v(xbgr.mr_n74589216)
print v(xbgr.mr_n74589792)
print v(xbgr.mr_n74590384)
print v(xbgr.mr_n74591280)
print v(xbgr.mr_n74591936)
print v(xbgr.mr_n74592448)
print v(xbgr.mr_n74593344)
print v(xbgr.mr_n74593920)
print v(xbgr.mr_n74594512)
print v(xbgr.mr_n74595408)
print v(xbgr.mr_n74595984)
print v(xbgr.mr_n74596576)
print v(xbgr.mr_n74597472)
print v(xbgr.mr_n74598048)
print v(xbgr.mr_n74598640)
print v(xbgr.mr_n74599536)
print v(xbgr.mr_n74600192)
print v(xbgr.mr_n74600704)
print v(xbgr.mr_n74601600)
print v(xbgr.mr_n74602016)
print v(xbgr.mr_n74602768)
print v(xbgr.mr_n74603664)
print v(xbgr.mr_n74604240)
print v(xbgr.mr_n74604832)
print v(xbgr.mr_n74605728)
print v(xbgr.mr_n74606384)
print v(xbgr.mr_n74606896)
print v(xbgr.mr_n74607792)
print v(xbgr.mr_n74608368)
print v(xbgr.mr_n74608960)
print v(xbgr.mr_n74609856)
print v(xbgr.mr_n74610432)
print v(xbgr.mr_n74611024)
print v(xbgr.mr_n74611920)
print v(xbgr.mr_n74612576)
print v(xbgr.mr_n74613088)
print v(xbgr.mr_n74614304)
print v(xbgr.mr_n74614896)
print v(xbgr.mr_n74615008)
print v(xbgr.mr_n74615120)
print v(xbgr.mr_n74615232)
print v(xbgr.mr_n74615504)
print v(xbgr.mr_n74615616)
print v(xbgr.mr_n74615968)
print v(xbgr.mr_n74616080)
print v(xbgr.mr_n74616192)
print v(xbgr.mr_n74616624)
print v(xbgr.mr_n74617104)
print v(xbgr.mr_n74617280)
print v(xbgr.mr_n74617632)
print v(xbgr.mr_n74618000)
print v(xbgr.mr_n74618336)
print v(xbgr.mr_n74618688)
print v(xbgr.mr_n74618800)
print v(xbgr.mr_n74619296)
print v(xbgr.mr_n74619792)
print v(xbgr.mr_n74620272)
print v(xbgr.mr_n74620448)
print v(xbgr.mr_n74620800)
print v(xbgr.mr_n74621168)
print v(xbgr.mr_n74621504)
print v(xbgr.mr_n74621856)
print v(xbgr.mr_n74621968)
print v(xbgr.mr_n74622464)
print v(xbgr.mr_n74622960)
print v(xbgr.mr_n74623440)
print v(xbgr.mr_n74623616)
print v(xbgr.mr_n74623968)
print v(xbgr.mr_n74624400)
print v(xbgr.mr_n74624928)
print v(xbgr.mr_n74625280)
print v(xbgr.mr_n74625712)
print v(xbgr.mr_n74626400)
print v(xbgr.mr_n74627088)
print v(xbgr.mr_n74627568)
print v(xbgr.mr_n74628064)
print v(xbgr.mr_n74628416)
print v(xbgr.mr_n74628656)
print v(xbgr.mr_n74629104)
print v(xbgr.mr_n74629568)
print v(xbgr.mr_n74629984)
print v(xbgr.mr_n74630416)
print v(xbgr.mr_n74631104)
print v(xbgr.mr_n74631792)
print v(xbgr.mr_n74632144)
print v(xbgr.mr_n74632256)
print v(xbgr.mr_n74632448)
print v(xbgr.mr_n74632720)
print v(xbgr.mr_n74632992)
print v(xbgr.mr_n74633264)
print v(xbgr.mr_n74633536)
print v(xbgr.mr_n74633808)
print v(xbgr.mr_n74634080)
print v(xbgr.mr_n74634352)
print v(xbgr.mr_n74634624)
print v(xbgr.mr_n74634896)
print v(xbgr.mr_n74635168)
print v(xbgr.mr_n74635440)
print v(xbgr.mr_n74635712)
print v(xbgr.mr_n74635984)
print v(xbgr.mr_n74636256)
print v(xbgr.mr_n74636528)
print v(xbgr.mr_n74636720)
print v(xbgr.mr_n74648688)
print v(xbgr.mr_n74649312)
print v(xbgr.mr_n74651232)
print v(xbgr.mr_n74651744)
print v(xbgr.mr_n74653872)
print v(xbgr.mr_n74654400)
print v(xbgr.mr_n74654864)
print v(xbgr.mr_n74655328)
print v(xbgr.mr_n74655792)
print v(xbgr.mr_n74656256)
print v(xbgr.mr_n74656720)
print v(xbgr.mr_n74657184)
print v(xbgr.mr_n74657712)
print v(xbgr.mr_n74658304)
print v(xbgr.mr_n74658896)
print v(xbgr.mr_n74659488)
print v(xbgr.mr_n74660080)
print v(xbgr.mr_n74660672)
print v(xbgr.mr_n74661264)
print v(xbgr.mr_n74661856)
print v(xbgr.mr_n74662448)
print v(xbgr.mr_n74663040)
print v(xbgr.mr_n74677744)
print v(xbgr.mr_n74680368)
print v(xbgr.mr_n74680832)
print v(xbgr.mr_n74691584)
print v(xbgr.mr_n74692000)
print v(xbgr.mr_n74692192)
print v(xbgr.mr_n74692448)
print v(xbgr.mr_n74692704)
print v(xbgr.mr_n74694864)
print v(xbgr.mr_n74702096)
print v(xbgr.mr_n74702736)
print v(xbgr.mr_n74703952)
print v(xbgr.mr_n74704544)
print v(xbgr.mr_n74705760)
print v(xbgr.mr_n74706352)
print v(xbgr.mr_n74707376)
print v(xbgr.mr_n74707680)
print v(xbgr.mr_n74707792)
print v(xbgr.mr_n74708624)
print v(xbgr.mr_n74709216)
print v(xbgr.mr_n74711760)
print v(xbgr.mr_n74712272)
print v(xbgr.mr_n74713568)
print v(xbgr.mr_n74714080)
print v(xbgr.mr_n74715216)
print v(xbgr.mr_n74715888)
print v(xbgr.mr_n74716944)
print v(xbgr.mr_n74717696)
print v(xbgr.mr_n74718912)
print v(xbgr.mr_n74719504)
print v(xbgr.mr_n74720800)
print v(xbgr.mr_n74721312)
print v(xbgr.mr_n74722608)
print v(xbgr.mr_n74723120)
print v(xbgr.mr_n74724336)
print v(xbgr.mr_n74724928)
print v(xbgr.mr_n74726224)
print v(xbgr.mr_n74726736)
print v(xbgr.mr_n74727952)
print v(xbgr.mr_n74728544)
print v(xbgr.mr_n74729840)
print v(xbgr.mr_n74730352)
print v(xbgr.mr_n74730464)
print v(xbgr.mr_n74730576)
print v(xbgr.mr_n74730688)
print v(xbgr.mr_n74730960)
print v(xbgr.mr_n74731072)
print v(xbgr.mr_n74731424)
print v(xbgr.mr_n74731536)
print v(xbgr.mr_n74731808)
print v(xbgr.mr_n74732160)
print v(xbgr.mr_n74732272)
print v(xbgr.mr_n74732640)
print v(xbgr.mr_n74733328)
print v(xbgr.mr_n74733808)
print v(xbgr.mr_n74734304)
print v(xbgr.mr_n74734656)
print v(xbgr.mr_n74735344)
print v(xbgr.mr_n74735872)
print v(xbgr.mr_n74736224)
print v(xbgr.mr_n74736656)
print v(xbgr.mr_n74737344)
print v(xbgr.mr_n74737968)
print v(xbgr.mr_n74738512)
print v(xbgr.mr_n74738752)
print v(xbgr.mr_n74738944)
print v(xbgr.mr_n74739360)
print v(xbgr.mr_n74740048)
print v(xbgr.mr_n74740576)
print v(xbgr.mr_n74740928)
print v(xbgr.mr_n74741360)
print v(xbgr.mr_n74742048)
print v(xbgr.mr_n74742736)
print v(xbgr.mr_n74743216)
print v(xbgr.mr_n74743712)
print v(xbgr.mr_n74744064)
print v(xbgr.mr_n74744752)
print v(xbgr.mr_n74745216)
print v(xbgr.mr_n74745632)
print v(xbgr.mr_n74746064)
print v(xbgr.mr_n74746176)
print v(xbgr.mr_n74746752)
print v(xbgr.mr_n74747440)
print v(xbgr.mr_n74747920)
print v(xbgr.mr_n74748352)
print v(xbgr.mr_n74748768)
print v(xbgr.mr_n74749456)
print v(xbgr.mr_n74749984)
print v(xbgr.mr_n74750336)
print v(xbgr.mr_n74750768)
print v(xbgr.mr_n74751456)
print v(xbgr.mr_n74752080)
print v(xbgr.mr_n74752624)
print v(xbgr.mr_n74752928)
print v(xbgr.mr_n74753120)
print v(xbgr.mr_n74753472)
print v(xbgr.mr_n74754160)
print v(xbgr.mr_n74754624)
print v(xbgr.mr_n74755040)
print v(xbgr.mr_n74755472)
print v(xbgr.mr_n74756160)
print v(xbgr.mr_n74756848)
print v(xbgr.mr_n74757200)
print v(xbgr.mr_n74757312)
print v(xbgr.mr_n74757504)
print v(xbgr.mr_n74757776)
print v(xbgr.mr_n74758048)
print v(xbgr.mr_n74758320)
print v(xbgr.mr_n74758592)
print v(xbgr.mr_n74758864)
print v(xbgr.mr_n74759136)
print v(xbgr.mr_n74759408)
print v(xbgr.mr_n74759680)
print v(xbgr.mr_n74759952)
print v(xbgr.mr_n74760224)
print v(xbgr.mr_n74760496)
print v(xbgr.mr_n74760768)
print v(xbgr.mr_n74761040)
print v(xbgr.mr_n74761312)
print v(xbgr.mr_n74761584)
print v(xbgr.mr_n74763616)
print v(xbgr.mr_n74764192)
print v(xbgr.mr_n74779440)
print v(xbgr.mr_n74781680)
print v(xbgr.mr_n74781856)
print v(xbgr.mr_n74784736)
print v(xbgr.mr_n74785344)
print v(xbgr.mr_n74785808)
print v(xbgr.mr_n74786272)
print v(xbgr.mr_n74786736)
print v(xbgr.mr_n74787200)
print v(xbgr.mr_n74787664)
print v(xbgr.mr_n74788128)
print v(xbgr.mr_n74788656)
print v(xbgr.mr_n74789248)
print v(xbgr.mr_n74789840)
print v(xbgr.mr_n74790432)
print v(xbgr.mr_n74791024)
print v(xbgr.mr_n74791616)
print v(xbgr.mr_n74792208)
print v(xbgr.mr_n74792800)
print v(xbgr.mr_n74793392)
print v(xbgr.mr_n74793984)
print v(xbgr.mr_n74794544)
print v(xbgr.mr_n74805616)
print v(xbgr.mr_n74807728)
print v(xbgr.mr_n74811824)
print v(xbgr.mr_n74812000)
print v(xbgr.mr_n74812336)
print v(xbgr.mr_n74814112)
print v(xbgr.mr_n74814704)
print v(xbgr.mr_n74815296)
print v(xbgr.mr_n74815888)
print v(xbgr.mr_n74816480)
print v(xbgr.mr_n74817072)
print v(xbgr.mr_n74817664)
print v(xbgr.mr_n74818256)
print v(xbgr.mr_n74818848)
print v(xbgr.mr_n74819440)
print v(xbgr.mr_n74820032)
print v(xbgr.mr_n74820624)
print v(xbgr.mr_n74821216)
print v(xbgr.mr_n74821808)
print v(xbgr.mr_n74822400)
print v(xbgr.mr_n74822992)
print v(xbgr.mr_n74823584)
print v(xbgr.mr_n74824176)
print v(xbgr.mr_n74824768)
print v(xbgr.mr_n74827104)
print v(xbgr.mr_n74828096)
print v(xbgr.mr_n74832016)
print v(xbgr.mr_n74833744)
print v(xbgr.mr_n74834224)
print v(xbgr.mr_n74834656)
print v(xbgr.mr_n74835072)
print v(xbgr.mr_n74835184)
print v(xbgr.mr_n74835888)
print v(xbgr.mr_n74838064)
print v(xbgr.mr_n74838480)
print v(xbgr.mr_n74838592)
print v(xbgr.mr_n74839296)
print v(xbgr.mr_n74839408)
print v(xbgr.mr_n74839776)
print v(xbgr.mr_n74841536)
print v(xbgr.mr_n74841888)
print v(xbgr.mr_n74842976)
print v(xbgr.mr_n74843088)
print v(xbgr.mr_n74843200)
print v(xbgr.mr_n74843392)
print v(xbgr.mr_n74845616)
print v(xbgr.mr_n74846512)
print v(xbgr.mr_n74846864)
print v(xbgr.mr_n74846976)
print v(xbgr.mr_n74847680)
print v(xbgr.mr_n74849920)
print v(xbgr.mr_n74850272)
print v(xbgr.mr_n74850384)
print v(xbgr.mr_n74851088)
print v(xbgr.mr_n74853264)
print v(xbgr.mr_n74853680)
print v(xbgr.mr_n74853792)
print v(xbgr.mr_n74854496)
print v(xbgr.mr_n74856672)
print v(xbgr.mr_n74857088)
print v(xbgr.mr_n74857200)
print v(xbgr.mr_n74857904)
print v(xbgr.mr_n74860144)
print v(xbgr.mr_n74860496)
print v(xbgr.mr_n74860608)
print v(xbgr.mr_n74861312)
print v(xbgr.mr_n74863488)
print v(xbgr.mr_n74863904)
print v(xbgr.mr_n74864016)
print v(xbgr.mr_n74864720)
print v(xbgr.mr_n74878672)
print v(xbgr.mr_n74878848)
print v(xbgr.mr_n74879472)
print v(xbgr.mr_n74879648)
print v(xbgr.mr_n74880272)
print v(xbgr.mr_n74880448)
print v(xbgr.mr_n74881072)
print v(xbgr.mr_n74881248)
print v(xbgr.mr_n74881872)
print v(xbgr.mr_n74882048)
print v(xbgr.mr_n74882672)
print v(xbgr.mr_n74882848)
print v(xbgr.mr_n74883472)
print v(xbgr.mr_n74883648)
print v(xbgr.mr_n74884272)
print v(xbgr.mr_n74884448)
print v(xbgr.mr_n74885072)
print v(xbgr.mr_n74885248)
print v(xbgr.mr_n74885872)
print v(xbgr.mr_n74886048)
print v(xbgr.mr_n74886672)
print v(xbgr.mr_n74886848)
print v(xbgr.mr_n74887472)
print v(xbgr.mr_n74887648)
print v(xbgr.mr_n74888272)
print v(xbgr.mr_n74888448)
print v(xbgr.mr_n74889072)
print v(xbgr.mr_n74889248)
print v(xbgr.mr_n74889872)
print v(xbgr.mr_n74890048)
print v(xbgr.mr_n74890672)
print v(xbgr.mr_n74890848)
print v(xbgr.mr_n74891280)
print v(xbgr.mr_n74891392)
print v(xbgr.mr_n74891504)
print v(xbgr.mr_n74891616)
print v(xbgr.mr_n74891808)
print v(xbgr.mr_n74892080)
print v(xbgr.mr_n74892352)
print v(xbgr.mr_n74892624)
print v(xbgr.mr_n74892896)
print v(xbgr.mr_n74893168)
print v(xbgr.mr_n74893440)
print v(xbgr.mr_n74893712)
print v(xbgr.mr_n74893984)
print v(xbgr.mr_n74894256)
print v(xbgr.mr_n74894528)
print v(xbgr.mr_n74894800)
print v(xbgr.mr_n74895072)
print v(xbgr.mr_n74895568)
print v(xbgr.mr_n74898640)
print v(xbgr.mr_n74900448)
print v(xbgr.mr_n74904400)
print v(xbgr.mr_n74906208)
print v(xbgr.mr_n74911456)
print v(xbgr.mr_n74911824)
print v(xbgr.mr_n74917456)
print v(xbgr.mr_n74920400)
print v(xbgr.mr_n74922256)
print v(xbgr.mr_n74927120)
print v(xbgr.mr_n74928400)
print v(xbgr.mr_n74931664)
print v(xbgr.mr_n74932560)
print v(xbgr.mr_n74932736)
print v(xbgr.mr_n74933072)
print v(xbgr.mr_n74934912)
print v(xbgr.mr_n74935088)
print v(xbgr.mr_n74936032)
print v(xbgr.mr_n74936688)
print v(xbgr.mr_n74936864)
print v(xbgr.mr_n74937808)
print v(xbgr.mr_n74938464)
print v(xbgr.mr_n74938640)
print v(xbgr.mr_n74939584)
print v(xbgr.mr_n74940240)
print v(xbgr.mr_n74940416)
print v(xbgr.mr_n74941360)
print v(xbgr.mr_n74942016)
print v(xbgr.mr_n74942192)
print v(xbgr.mr_n74943136)
print v(xbgr.mr_n74943792)
print v(xbgr.mr_n74943968)
print v(xbgr.mr_n74944912)
print v(xbgr.mr_n74945568)
print v(xbgr.mr_n74945744)
print v(xbgr.mr_n74946688)
print v(xbgr.mr_n74947344)
print v(xbgr.mr_n74947520)
print v(xbgr.mr_n74948464)
print v(xbgr.mr_n74949120)
print v(xbgr.mr_n74949296)
print v(xbgr.mr_n74950240)
print v(xbgr.mr_n74950896)
print v(xbgr.mr_n74951072)
print v(xbgr.mr_n74952112)
print v(xbgr.mr_n74952384)
print v(xbgr.mr_n74952656)
print v(xbgr.mr_n74952992)
print v(xbgr.mr_n74953456)
print v(xbgr.mr_n74953808)
print v(xbgr.mr_n74954000)
print v(xbgr.mr_n74954192)
print v(xbgr.mr_n74954384)
print v(xbgr.mr_n74955136)
print v(xbgr.mr_n74957616)
print v(xbgr.mr_n74958720)
print v(xbgr.mr_n74959136)
print v(xbgr.mr_n74959248)
print v(xbgr.mr_n74959952)
print v(xbgr.mr_n74962192)
print v(xbgr.mr_n74962544)
print v(xbgr.mr_n74962656)
print v(xbgr.mr_n74963360)
print v(xbgr.mr_n74964112)
print v(xbgr.mr_n74965600)
print v(xbgr.mr_n74965952)
print v(xbgr.mr_n74966064)
print v(xbgr.mr_n74966768)
print v(xbgr.mr_n74968944)
print v(xbgr.mr_n74969360)
print v(xbgr.mr_n74969472)
print v(xbgr.mr_n74970176)
print v(xbgr.mr_n74970960)
print v(xbgr.mr_n74972416)
print v(xbgr.mr_n74972768)
print v(xbgr.mr_n74972880)
print v(xbgr.mr_n74973584)
print v(xbgr.mr_n74973824)
print v(xbgr.mr_n74975760)
print v(xbgr.mr_n74976256)
print v(xbgr.mr_n74976992)
print v(xbgr.mr_n74977664)
print v(xbgr.mr_n74978032)
print v(xbgr.mr_n74978144)
print v(xbgr.mr_n74978976)
print v(xbgr.mr_n74981760)
print v(xbgr.mr_n74982576)
print v(xbgr.mr_n74982928)
print v(xbgr.mr_n74983040)
print v(xbgr.mr_n74983744)
print v(xbgr.mr_n74986144)
print v(xbgr.mr_n74986560)
print v(xbgr.mr_n74986672)
print v(xbgr.mr_n74987376)
print v(xbgr.mr_n74999936)
print v(xbgr.mr_n75000112)
print v(xbgr.mr_n75000736)
print v(xbgr.mr_n75000912)
print v(xbgr.mr_n75001536)
print v(xbgr.mr_n75001712)
print v(xbgr.mr_n75002336)
print v(xbgr.mr_n75002512)
print v(xbgr.mr_n75003136)
print v(xbgr.mr_n75003312)
print v(xbgr.mr_n75003936)
print v(xbgr.mr_n75004112)
print v(xbgr.mr_n75004736)
print v(xbgr.mr_n75004912)
print v(xbgr.mr_n75005536)
print v(xbgr.mr_n75005712)
print v(xbgr.mr_n75006336)
print v(xbgr.mr_n75006512)
print v(xbgr.mr_n75007136)
print v(xbgr.mr_n75007312)
print v(xbgr.mr_n75007936)
print v(xbgr.mr_n75008112)
print v(xbgr.mr_n75008736)
print v(xbgr.mr_n75008912)
print v(xbgr.mr_n75009536)
print v(xbgr.mr_n75009712)
print v(xbgr.mr_n75010336)
print v(xbgr.mr_n75010512)
print v(xbgr.mr_n75011136)
print v(xbgr.mr_n75011312)
print v(xbgr.mr_n75011936)
print v(xbgr.mr_n75012112)
print v(xbgr.mr_n75019280)
print v(xbgr.mr_n75020496)
print v(xbgr.mr_n75023744)
print v(xbgr.mr_n75024048)
print v(xbgr.mr_n75024352)
print v(xbgr.mr_n75024656)
print v(xbgr.mr_n75025040)
print v(xbgr.mr_n75025504)
print v(xbgr.mr_n75025968)
print v(xbgr.mr_n75026432)
print v(xbgr.mr_n75026896)
print v(xbgr.mr_n75027360)
print v(xbgr.mr_n75027824)
print v(xbgr.mr_n75028288)
print v(xbgr.mr_n75028752)
print v(xbgr.mr_n75029216)
print v(xbgr.mr_n75029680)
print v(xbgr.mr_n75030144)
print v(xbgr.mr_n75030608)
print v(xbgr.mr_n75031072)
print v(xbgr.mr_n75031536)
print v(xbgr.mr_n75032000)
print v(xbgr.mr_n75032464)
print v(xbgr.mr_n75032928)
print v(xbgr.mr_n75033392)
print v(xbgr.mr_n75033856)
print v(xbgr.mr_n75034320)
print v(xbgr.mr_n75034784)
print v(xbgr.mr_n75035248)
print v(xbgr.mr_n75035712)
print v(xbgr.mr_n75036176)
print v(xbgr.mr_n75036640)
print v(xbgr.mr_n75043856)
print v(xbgr.mr_n75046608)
print v(xbgr.mr_n75048976)
print v(xbgr.mr_n75053776)
print v(xbgr.mr_n75061232)
print v(xbgr.mr_n75061696)
print v(xbgr.mr_n75062160)
print v(xbgr.mr_n75062688)
print v(xbgr.mr_n75063280)
print v(xbgr.mr_n75063872)
print v(xbgr.mr_n75064464)
print v(xbgr.mr_n75065056)
print v(xbgr.mr_n75065648)
print v(xbgr.mr_n75066240)
print v(xbgr.mr_n75066832)
print v(xbgr.mr_n75067424)
print v(xbgr.mr_n75068016)
print v(xbgr.mr_n75068608)
print v(xbgr.mr_n75069200)
print v(xbgr.mr_n75069792)
print v(xbgr.mr_n75070384)
print v(xbgr.mr_n75072544)
print v(xbgr.mr_n75075936)
print v(xbgr.mr_n75077088)
print v(xbgr.mr_n75078176)
print v(xbgr.mr_n75082592)
print v(xbgr.mr_n75083360)
print v(xbgr.mr_n75093680)
print v(xbgr.mr_n75093872)
print v(xbgr.mr_n75094128)
print v(xbgr.mr_n75094384)
print v(xbgr.mr_n75096544)
print v(xbgr.mr_n75120160)
print v(xbgr.mr_n75120704)
print v(xbgr.mr_n75124544)
print v(xbgr.mr_n75125216)
print v(xbgr.mr_n75130400)
print v(xbgr.mr_n75135456)
print v(xbgr.mr_n75136064)
print v(xbgr.mr_n75138240)
print v(xbgr.mr_n75142448)
print v(xbgr.mr_n75155376)
print v(xbgr.mr_n75157520)
print v(xbgr.mr_n75158880)
print v(xbgr.mr_n75161168)
print v(xbgr.mr_n75163104)
print v(xbgr.mr_n75163696)
print v(xbgr.mr_n75164288)
print v(xbgr.mr_n75164880)
print v(xbgr.mr_n75165472)
print v(xbgr.mr_n75166064)
print v(xbgr.mr_n75166656)
print v(xbgr.mr_n75167248)
print v(xbgr.mr_n75167840)
print v(xbgr.mr_n75168432)
print v(xbgr.mr_n75169024)
print v(xbgr.mr_n75169616)
print v(xbgr.mr_n75170144)
print v(xbgr.mr_n75171456)
print v(xbgr.mr_n75171920)
print v(xbgr.mr_n75172384)
print v(xbgr.mr_n75172848)
print v(xbgr.mr_n75173312)
print v(xbgr.mr_n75174592)
print v(xbgr.mr_n75177088)
print v(xbgr.mr_n75177264)
print v(xbgr.mr_n75177440)
print v(xbgr.mr_n75179232)
print v(xbgr.mr_n75181744)
print v(xbgr.mr_n75183696)
print v(xbgr.mr_n75184032)
print v(xbgr.mr_n75184368)
print v(xbgr.mr_n75185808)
print v(xbgr.mr_n75186848)
print v(xbgr.mr_n75187024)
print v(xbgr.mr_n75187536)
print v(xbgr.mr_n75188032)
print v(xbgr.mr_n75188208)
print v(xbgr.mr_n75188624)
print v(xbgr.mr_n75189136)
print v(xbgr.mr_n75189632)
print v(xbgr.mr_n75189968)
print v(xbgr.mr_n75190480)
print v(xbgr.mr_n75190592)
print v(xbgr.mr_n75190704)
print v(xbgr.mr_n75191696)
print v(xbgr.mr_n75192112)
print v(xbgr.mr_n75192624)
print v(xbgr.mr_n75193120)
print v(xbgr.mr_n75193296)
print v(xbgr.mr_n75193712)
print v(xbgr.mr_n75194224)
print v(xbgr.mr_n75194784)
print v(xbgr.mr_n75194960)
print v(xbgr.mr_n75195376)
print v(xbgr.mr_n75196224)
print v(xbgr.mr_n75196400)
print v(xbgr.mr_n75196576)
print v(xbgr.mr_n75197168)
print v(xbgr.mr_n75197280)
print v(xbgr.mr_n75197392)
print v(xbgr.mr_n75197504)
print v(xbgr.mr_n75198992)
print v(xbgr.mr_n75199168)
print v(xbgr.mr_n75199504)
print v(xbgr.mr_n75200448)
print v(xbgr.mr_n75200624)
print v(xbgr.mr_n75201056)
print v(xbgr.mr_n75201168)
print v(xbgr.mr_n75202000)
print v(xbgr.mr_n75202176)
print v(xbgr.mr_n75202432)
print v(xbgr.mr_n75203008)
print v(xbgr.mr_n75203792)
print v(xbgr.mr_n75203968)
print v(xbgr.mr_n75204400)
print v(xbgr.mr_n75204960)
print v(xbgr.mr_n75205136)
print v(xbgr.mr_n75205632)
print v(xbgr.mr_n75206144)
print v(xbgr.mr_n75206256)
print v(xbgr.mr_n75206960)
print v(xbgr.mr_n75207376)
print v(xbgr.mr_n75207888)
print v(xbgr.mr_n75208384)
print v(xbgr.mr_n75208560)
print v(xbgr.mr_n75208976)
print v(xbgr.mr_n75209488)
print v(xbgr.mr_n75209984)
print v(xbgr.mr_n75210320)
print v(xbgr.mr_n75210832)
print v(xbgr.mr_n75210944)
print v(xbgr.mr_n75211056)
print v(xbgr.mr_n75212176)
print v(xbgr.mr_n75212352)
print v(xbgr.mr_n75212608)
print v(xbgr.mr_n75213184)
print v(xbgr.mr_n75213776)
print v(xbgr.mr_n75213888)
print v(xbgr.mr_n75214080)
print v(xbgr.mr_n75214432)
print v(xbgr.mr_n75214544)
print v(xbgr.mr_n75215056)
print v(xbgr.mr_n75215168)
print v(xbgr.mr_n75215280)
print v(xbgr.mr_n75215632)
print v(xbgr.mr_n75215968)
print v(xbgr.mr_n75216912)
print v(xbgr.mr_n75217328)
print v(xbgr.mr_n75217440)
print v(xbgr.mr_n75218000)
print v(xbgr.mr_n75218256)
print v(xbgr.mr_n75219072)
print v(xbgr.mr_n75219504)
print v(xbgr.mr_n75219680)
print v(xbgr.mr_n75220608)
print v(xbgr.mr_n75220784)
print v(xbgr.mr_n75221360)
print v(xbgr.mr_n75221472)
print v(xbgr.mr_n75221584)
print v(xbgr.mr_n75222352)
print v(xbgr.mr_n75222688)
print v(xbgr.mr_n75223632)
print v(xbgr.mr_n75224048)
print v(xbgr.mr_n75224160)
print v(xbgr.mr_n75224720)
print v(xbgr.mr_n75224976)
print v(xbgr.mr_n75225920)
print v(xbgr.mr_n75226336)
print v(xbgr.mr_n75226448)
print v(xbgr.mr_n75226560)
print v(xbgr.mr_n75227328)
print v(xbgr.mr_n75227664)
print v(xbgr.mr_n75228672)
print v(xbgr.mr_n75228848)
print v(xbgr.mr_n75229424)
print v(xbgr.mr_n75229856)
print v(xbgr.mr_n75230032)
print v(xbgr.mr_n75230768)
print v(xbgr.mr_n75230880)
print v(xbgr.mr_n75231440)
print v(xbgr.mr_n75231696)
print v(xbgr.mr_n75232640)
print v(xbgr.mr_n75233056)
print v(xbgr.mr_n75233168)
print v(xbgr.mr_n75233280)
print v(xbgr.mr_n75234048)
print v(xbgr.mr_n75234384)
print v(xbgr.mr_n75235200)
print v(xbgr.mr_n75235312)
print v(xbgr.mr_n75235872)
print v(xbgr.mr_n75236128)
print v(xbgr.mr_n75237072)
print v(xbgr.mr_n75237488)
print v(xbgr.mr_n75237600)
print v(xbgr.mr_n75237968)
print v(xbgr.mr_n75238160)
print v(xbgr.mr_n75238416)
print v(xbgr.mr_n75239232)
print v(xbgr.mr_n75239664)
print v(xbgr.mr_n75239840)
print v(xbgr.mr_n75243600)
print v(xbgr.mr_n75247552)
print v(xbgr.mr_n75247664)
print v(xbgr.mr_n75248368)
print v(xbgr.mr_n75248832)
print v(xbgr.mr_n75249280)
print v(xbgr.mr_n75249744)
print v(xbgr.mr_n75250208)
print v(xbgr.mr_n75250672)
print v(xbgr.mr_n75251136)
print v(xbgr.mr_n75251600)
print v(xbgr.mr_n75252064)
print v(xbgr.mr_n75252528)
print v(xbgr.mr_n75252992)
print v(xbgr.mr_n75253456)
print v(xbgr.mr_n75253920)
print v(xbgr.mr_n75254384)
print v(xbgr.mr_n75254848)
print v(xbgr.mr_n75255312)
print v(xbgr.mr_n75255776)
print v(xbgr.mr_n75259984)
print v(xbgr.mr_n75268336)
print v(xbgr.mr_n75275072)
print v(xbgr.mr_n75275408)
print v(xbgr.mr_n75278512)
print v(xbgr.mr_n75279600)
print v(xbgr.mr_n75280336)
print v(xbgr.mr_n75284464)
print v(xbgr.mr_n75286032)
print v(xbgr.mr_n75286704)
print v(xbgr.mr_n75287696)
print v(xbgr.mr_n75287840)
print v(xbgr.mr_n75288048)
print v(xbgr.mr_n75289040)
print v(xbgr.mr_n75289936)
print v(xbgr.mr_n75294864)
print v(xbgr.mr_n75296336)
print v(xbgr.mr_n75299536)
print v(xbgr.mr_n75299792)
print v(xbgr.mr_n75300128)
print v(xbgr.mr_n75300464)
print v(xbgr.mr_n75302352)
print v(xbgr.mr_n75303136)
print v(xbgr.mr_n75303248)
print v(xbgr.mr_n75305008)
print v(xbgr.mr_n75305120)
print v(xbgr.mr_n75306816)
print v(xbgr.mr_n75306928)
print v(xbgr.mr_n75308624)
print v(xbgr.mr_n75308736)
print v(xbgr.mr_n75310432)
print v(xbgr.mr_n75310544)
print v(xbgr.mr_n75312240)
print v(xbgr.mr_n75312352)
print v(xbgr.mr_n75314048)
print v(xbgr.mr_n75314160)
print v(xbgr.mr_n75315856)
print v(xbgr.mr_n75315968)
print v(xbgr.mr_n75317664)
print v(xbgr.mr_n75317776)
print v(xbgr.mr_n75319472)
print v(xbgr.mr_n75319584)
print v(xbgr.mr_n75321280)
print v(xbgr.mr_n75321392)
print v(xbgr.mr_n75323088)
print v(xbgr.mr_n75323200)
print v(xbgr.mr_n75324896)
print v(xbgr.mr_n75325008)
print v(xbgr.mr_n75326704)
print v(xbgr.mr_n75326816)
print v(xbgr.mr_n75328512)
print v(xbgr.mr_n75328624)
print v(xbgr.mr_n75330320)
print v(xbgr.mr_n75330432)
print v(xbgr.mr_n75332128)
print v(xbgr.mr_n75332240)
print v(xbgr.mr_n75335040)
print v(xbgr.mr_n75337856)
print v(xbgr.mr_n75343824)
print v(xbgr.mr_n75353280)
print v(xbgr.mr_n75358240)
print v(xbgr.mr_n75358704)
print v(xbgr.mr_n75358816)
print v(xbgr.mr_n75359632)
print v(xbgr.mr_n75360096)
print v(xbgr.mr_n75360208)
print v(xbgr.mr_n75361024)
print v(xbgr.mr_n75361552)
print v(xbgr.mr_n75361728)
print v(xbgr.mr_n75362672)
print v(xbgr.mr_n75363328)
print v(xbgr.mr_n75363504)
print v(xbgr.mr_n75364448)
print v(xbgr.mr_n75365104)
print v(xbgr.mr_n75365280)
print v(xbgr.mr_n75366224)
print v(xbgr.mr_n75366880)
print v(xbgr.mr_n75367056)
print v(xbgr.mr_n75368000)
print v(xbgr.mr_n75368656)
print v(xbgr.mr_n75368832)
print v(xbgr.mr_n75369776)
print v(xbgr.mr_n75370432)
print v(xbgr.mr_n75370608)
print v(xbgr.mr_n75371552)
print v(xbgr.mr_n75372208)
print v(xbgr.mr_n75372384)
print v(xbgr.mr_n75373328)
print v(xbgr.mr_n75373920)
print v(xbgr.mr_n75374512)
print v(xbgr.mr_n75375104)
print v(xbgr.mr_n75375696)
print v(xbgr.mr_n75376288)
print v(xbgr.mr_n75376880)
print v(xbgr.mr_n75377472)
print v(xbgr.mr_n75378064)
print v(xbgr.mr_n75378656)
print v(xbgr.mr_n75379248)
print v(xbgr.mr_n75379840)
print v(xbgr.mr_n75380432)
print v(xbgr.mr_n75381024)
print v(xbgr.mr_n75381616)
print v(xbgr.mr_n75382000)
print v(xbgr.mr_n75382208)
print v(xbgr.mr_n75382736)
print v(xbgr.mr_n75382848)
print v(xbgr.mr_n75382960)
print v(xbgr.mr_n75383072)
print v(xbgr.mr_n75384176)
print v(xbgr.mr_n75384640)
print v(xbgr.mr_n75385584)
print v(xbgr.mr_n75386464)
print v(xbgr.mr_n75387056)
print v(xbgr.mr_n75387648)
print v(xbgr.mr_n75388240)
print v(xbgr.mr_n75388832)
print v(xbgr.mr_n75389424)
print v(xbgr.mr_n75390016)
print v(xbgr.mr_n75390608)
print v(xbgr.mr_n75391200)
print v(xbgr.mr_n75394864)
print v(xbgr.mr_n75399040)
print v(xbgr.mr_n75400112)
print v(xbgr.mr_n75405440)
print v(xbgr.mr_n75407888)
print v(xbgr.mr_n75408224)
print v(xbgr.mr_n75408880)
print v(xbgr.mr_n75409392)
print v(xbgr.mr_n75409504)
print v(xbgr.mr_n75411200)
print v(xbgr.mr_n75411312)
print v(xbgr.mr_n75413008)
print v(xbgr.mr_n75413120)
print v(xbgr.mr_n75414816)
print v(xbgr.mr_n75414928)
print v(xbgr.mr_n75416624)
print v(xbgr.mr_n75416736)
print v(xbgr.mr_n75418432)
print v(xbgr.mr_n75418544)
print v(xbgr.mr_n75420240)
print v(xbgr.mr_n75420352)
print v(xbgr.mr_n75422048)
print v(xbgr.mr_n75422160)
print v(xbgr.mr_n75423856)
print v(xbgr.mr_n75423968)
print v(xbgr.mr_n75425664)
print v(xbgr.mr_n75425776)
print v(xbgr.mr_n75427472)
print v(xbgr.mr_n75427584)
print v(xbgr.mr_n75427696)
print v(xbgr.mr_n75429536)
print v(xbgr.mr_n75429648)
print v(xbgr.mr_n75429760)
print v(xbgr.mr_n75431600)
print v(xbgr.mr_n75431712)
print v(xbgr.mr_n75431824)
print v(xbgr.mr_n75433664)
print v(xbgr.mr_n75433776)
print v(xbgr.mr_n75433888)
print v(xbgr.mr_n75435728)
print v(xbgr.mr_n75435840)
print v(xbgr.mr_n75435952)
print v(xbgr.mr_n75437792)
print v(xbgr.mr_n75437904)
print v(xbgr.mr_n75438016)
print v(xbgr.mr_n75439856)
print v(xbgr.mr_n75439968)
print v(xbgr.mr_n75440080)
print v(xbgr.mr_n75440992)
print v(xbgr.mr_n75441344)
print v(xbgr.mr_n75441856)
print v(xbgr.mr_n75442400)
print v(xbgr.mr_n75442944)
print v(xbgr.mr_n75443488)
print v(xbgr.mr_n75444032)
print v(xbgr.mr_n75444576)
print v(xbgr.mr_n75445120)
print v(xbgr.mr_n75445664)
print v(xbgr.mr_n75446208)
print v(xbgr.mr_n75446752)
print v(xbgr.mr_n75447296)
print v(xbgr.mr_n75447840)
print v(xbgr.mr_n75448384)
print v(xbgr.mr_n75448928)
print v(xbgr.mr_n75449472)
print v(xbgr.mr_n75450016)
print v(xbgr.mr_n75450560)
print v(xbgr.mr_n75451104)
print v(xbgr.mr_n75451568)
print v(xbgr.mr_n75452112)
print v(xbgr.mr_n75452656)
print v(xbgr.mr_n75453200)
print v(xbgr.mr_n75453744)
print v(xbgr.mr_n75454288)
print v(xbgr.mr_n75454832)
print v(xbgr.mr_n75455376)
print v(xbgr.mr_n75456048)
print v(xbgr.mr_n75456352)
print v(xbgr.mr_n75456736)
print v(xbgr.mr_n75457200)
print v(xbgr.mr_n75457664)
print v(xbgr.mr_n75458128)
print v(xbgr.mr_n75458592)
print v(xbgr.mr_n75459056)
print v(xbgr.mr_n75459520)
print v(xbgr.mr_n75459984)
print v(xbgr.mr_n75460448)
print v(xbgr.mr_n75460912)
print v(xbgr.mr_n75461376)
print v(xbgr.mr_n75461840)
print v(xbgr.mr_n75462304)
print v(xbgr.mr_n75462768)
print v(xbgr.mr_n75463232)
print v(xbgr.mr_n75463696)
print v(xbgr.mr_n75464160)
print v(xbgr.mr_n75464624)
print v(xbgr.mr_n75465088)
print v(xbgr.mr_n75465552)
print v(xbgr.mr_n75466016)
print v(xbgr.mr_n75466512)
print v(xbgr.mr_n75467104)
print v(xbgr.mr_n75467696)
print v(xbgr.mr_n75468288)
print v(xbgr.mr_n75468880)
print v(xbgr.mr_n75469472)
print v(xbgr.mr_n75470064)
print v(xbgr.mr_n75470848)
print v(xbgr.mr_n75470992)
print v(xbgr.mr_n75471168)
print v(xbgr.mr_n75487520)
print v(xbgr.mr_n75487712)
print v(xbgr.mr_n75491856)
print v(xbgr.mr_n75500128)
print v(xbgr.mr_n75500832)
print v(xbgr.mr_n75506400)
print v(xbgr.mr_n75506848)
print v(xbgr.mr_n75507248)
print v(xbgr.mr_n75514464)
print v(xbgr.mr_n75517600)
print v(xbgr.mr_n75517872)
print v(xbgr.mr_n75519328)
print v(xbgr.mr_n75523040)
print v(xbgr.mr_n75523616)
print v(xbgr.mr_n75524112)
print v(xbgr.mr_n75524432)
print v(xbgr.mr_n75526432)
print v(xbgr.mr_n75526544)
print v(xbgr.mr_n75526688)
print v(xbgr.mr_n75527136)
print v(xbgr.mr_n75529488)
print v(xbgr.mr_n75532448)
print v(xbgr.mr_n75532624)
print v(xbgr.mr_n75534656)
print v(xbgr.mr_n75535664)
print v(xbgr.mr_n75536352)
print v(xbgr.mr_n75541664)
print v(xbgr.mr_n75547568)
print v(xbgr.mr_n75548880)
print v(xbgr.mr_n75550192)
print v(xbgr.mr_n75551360)
print v(xbgr.mr_n75553504)
print v(xbgr.mr_n75557232)
print v(xbgr.mr_n75557424)
print v(xbgr.mr_n75560096)
print v(xbgr.mr_n75561408)
print v(xbgr.mr_n75566208)
print v(xbgr.mr_n75567248)
print v(xbgr.mr_n75570768)
print v(xbgr.mr_n75571216)
print v(xbgr.mr_n75572848)
print v(xbgr.mr_n75574368)
print v(xbgr.mr_n75579680)
print v(xbgr.mr_n75580016)
print v(xbgr.mr_n75580352)
print v(xbgr.mr_n75580688)
print v(xbgr.mr_n75581648)
print v(xbgr.mr_n75582240)
print v(xbgr.mr_n75582352)
print v(xbgr.mr_n75582464)
print v(xbgr.mr_n75584304)
print v(xbgr.mr_n75584416)
print v(xbgr.mr_n75584528)
print v(xbgr.mr_n75586368)
print v(xbgr.mr_n75586480)
print v(xbgr.mr_n75586592)
print v(xbgr.mr_n75588432)
print v(xbgr.mr_n75588544)
print v(xbgr.mr_n75588656)
print v(xbgr.mr_n75590496)
print v(xbgr.mr_n75590608)
print v(xbgr.mr_n75590720)
print v(xbgr.mr_n75592560)
print v(xbgr.mr_n75592672)
print v(xbgr.mr_n75592784)
print v(xbgr.mr_n75594624)
print v(xbgr.mr_n75594736)
print v(xbgr.mr_n75594848)
print v(xbgr.mr_n75596688)
print v(xbgr.mr_n75596800)
print v(xbgr.mr_n75596912)
print v(xbgr.mr_n75598752)
print v(xbgr.mr_n75598864)
print v(xbgr.mr_n75598976)
print v(xbgr.mr_n75600816)
print v(xbgr.mr_n75600928)
print v(xbgr.mr_n75601040)
print v(xbgr.mr_n75602880)
print v(xbgr.mr_n75602992)
print v(xbgr.mr_n75603104)
print v(xbgr.mr_n75604944)
print v(xbgr.mr_n75605056)
print v(xbgr.mr_n75605168)
print v(xbgr.mr_n75607008)
print v(xbgr.mr_n75607120)
print v(xbgr.mr_n75607232)
print v(xbgr.mr_n75609776)
print v(xbgr.mr_n75609888)
print v(xbgr.mr_n75610256)
print v(xbgr.mr_n75613760)
print v(xbgr.mr_n75613872)
print v(xbgr.mr_n75614240)
print v(xbgr.mr_n75617744)
print v(xbgr.mr_n75617856)
print v(xbgr.mr_n75618224)
print v(xbgr.mr_n75621728)
print v(xbgr.mr_n75621840)
print v(xbgr.mr_n75622208)
print v(xbgr.mr_n75624800)
print v(xbgr.mr_n75624912)
print v(xbgr.mr_n75626416)
print v(xbgr.mr_n75627136)
print v(xbgr.mr_n75627312)
print v(xbgr.mr_n75628880)
print v(xbgr.mr_n75629696)
print v(xbgr.mr_n75629872)
print v(xbgr.mr_n75631440)
print v(xbgr.mr_n75632256)
print v(xbgr.mr_n75632432)
print v(xbgr.mr_n75634000)
print v(xbgr.mr_n75634816)
print v(xbgr.mr_n75634992)
print v(xbgr.mr_n75636560)
print v(xbgr.mr_n75637376)
print v(xbgr.mr_n75637552)
print v(xbgr.mr_n75639120)
print v(xbgr.mr_n75639936)
print v(xbgr.mr_n75640112)
print v(xbgr.mr_n75641680)
print v(xbgr.mr_n75642496)
print v(xbgr.mr_n75642672)
print v(xbgr.mr_n75644240)
print v(xbgr.mr_n75645056)
print v(xbgr.mr_n75645232)
print v(xbgr.mr_n75646800)
print v(xbgr.mr_n75647616)
print v(xbgr.mr_n75647792)
print v(xbgr.mr_n75648432)
print v(xbgr.mr_n75649360)
print v(xbgr.mr_n75650176)
print v(xbgr.mr_n75650352)
print v(xbgr.mr_n75651056)
print v(xbgr.mr_n75651920)
print v(xbgr.mr_n75652576)
print v(xbgr.mr_n75652736)
print v(xbgr.mr_n75652912)
print v(xbgr.mr_n75653104)
print v(xbgr.mr_n75653216)
print v(xbgr.mr_n75653328)
print v(xbgr.mr_n75654768)
print v(xbgr.mr_n75655264)
print v(xbgr.mr_n75655760)
print v(xbgr.mr_n75655872)
print v(xbgr.mr_n75657456)
print v(xbgr.mr_n75657952)
print v(xbgr.mr_n75658064)
print v(xbgr.mr_n75660560)
print v(xbgr.mr_n75661728)
print v(xbgr.mr_n75661904)
print v(xbgr.mr_n75663472)
print v(xbgr.mr_n75664288)
print v(xbgr.mr_n75664464)
print v(xbgr.mr_n75666032)
print v(xbgr.mr_n75666848)
print v(xbgr.mr_n75667024)
print v(xbgr.mr_n75668592)
print v(xbgr.mr_n75669408)
print v(xbgr.mr_n75669584)
print v(xbgr.mr_n75671152)
print v(xbgr.mr_n75671968)
print v(xbgr.mr_n75672144)
print v(xbgr.mr_n75672720)
print v(xbgr.mr_n75673712)
print v(xbgr.mr_n75674528)
print v(xbgr.mr_n75674704)
print v(xbgr.mr_n75676272)
print v(xbgr.mr_n75677088)
print v(xbgr.mr_n75677264)
print v(xbgr.mr_n75678832)
print v(xbgr.mr_n75679648)
print v(xbgr.mr_n75679824)
print v(xbgr.mr_n75681392)
print v(xbgr.mr_n75682208)
print v(xbgr.mr_n75682384)
print v(xbgr.mr_n75683952)
print v(xbgr.mr_n75684768)
print v(xbgr.mr_n75684944)
print v(xbgr.mr_n75685248)
print v(xbgr.mr_n75686512)
print v(xbgr.mr_n75687328)
print v(xbgr.mr_n75687504)
print v(xbgr.mr_n75689072)
print v(xbgr.mr_n75689888)
print v(xbgr.mr_n75690064)
print v(xbgr.mr_n75690368)
print v(xbgr.mr_n75690752)
print v(xbgr.mr_n75691632)
print v(xbgr.mr_n75767904)
print v(xbgr.mr_n75768160)
print v(xbgr.mr_n75769136)
print v(xbgr.mr_n75773488)
print v(xbgr.mr_n75777120)
print v(xbgr.mr_n75777504)
print v(xbgr.mr_n75777888)
print v(xbgr.mr_n75778288)
print v(xbgr.mr_n75781168)
print v(xbgr.mr_n75789088)
print v(xbgr.mr_n75796960)
print v(xbgr.mr_n75800368)
print v(xbgr.mr_n75803104)
print v(xbgr.mr_n75803344)
print v(xbgr.mr_n75805824)
print v(xbgr.mr_n75807632)
print v(xbgr.mr_n75808432)
print v(xbgr.mr_n75809296)
print v(xbgr.mr_n75809472)
print v(xbgr.mr_n75810272)
print v(xbgr.mr_n75810448)
print v(xbgr.mr_n75810720)
print v(xbgr.mr_n75810832)
print v(xbgr.mr_n75811696)
print v(xbgr.mr_n75812320)
print v(xbgr.mr_n75812496)
print v(xbgr.mr_n75812672)
print v(xbgr.mr_n75812784)
print v(xbgr.mr_n75813232)
print v(xbgr.mr_n75814176)
print v(xbgr.mr_n75911008)
print v(xbgr.mr_n75912720)
print v(xbgr.mr_n75912832)
print v(xbgr.mr_n75913264)
print v(xbgr.mr_n75913376)
print v(xbgr.mr_n75913808)
print v(xbgr.mr_n75913920)
print v(xbgr.mr_n75914352)
print v(xbgr.mr_n75914464)
print v(xbgr.mr_n75914896)
print v(xbgr.mr_n75915008)
print v(xbgr.mr_n75915440)
print v(xbgr.mr_n75915552)
print v(xbgr.mr_n75915984)
print v(xbgr.mr_n75916096)
print v(xbgr.mr_n75916528)
print v(xbgr.mr_n75916640)
print v(xbgr.mr_n75917072)
print v(xbgr.mr_n75917184)
print v(xbgr.mr_n75917616)
print v(xbgr.mr_n75917728)
print v(xbgr.mr_n75918160)
print v(xbgr.mr_n75918272)
print v(xbgr.mr_n75918704)
print v(xbgr.mr_n75918816)
print v(xbgr.mr_n75919488)
print v(xbgr.mr_n75919600)
print v(xbgr.mr_n75920432)
print v(xbgr.mr_n75920544)
print v(xbgr.mr_n75921376)
print v(xbgr.mr_n75921488)
print v(xbgr.mr_n75921888)
print v(xbgr.mr_n75922320)
print v(xbgr.mr_n75922432)
print v(xbgr.mr_n75923264)
print v(xbgr.mr_n75923520)
print v(xbgr.mr_n75924176)
print v(xbgr.mr_n75924352)
print v(xbgr.mr_n75930704)
print v(xbgr.mr_n75933616)
print v(xbgr.mr_n75935024)
print v(xbgr.mr_n75935216)
print v(xbgr.mr_n75937760)
print v(xbgr.mr_n75939376)
print v(xbgr.mr_n75941056)
print v(xbgr.mr_n75943312)
print v(xbgr.mr_n75945568)
print v(xbgr.mr_n75947824)
print v(xbgr.mr_n75950080)
print v(xbgr.mr_n75952336)
print v(xbgr.mr_n75954592)
print v(xbgr.mr_n75956848)
print v(xbgr.mr_n75961264)
print v(xbgr.mr_n75965744)
print v(xbgr.mr_n75978496)
print v(xbgr.mr_n75981888)
print v(xbgr.mr_n75982880)
print v(xbgr.mr_n75982992)
print v(xbgr.mr_n75983616)
print v(xbgr.mr_n75985152)
print v(xbgr.mr_n75986016)
print v(xbgr.mr_n75986976)
print v(xbgr.mr_n75987088)
print v(xbgr.mr_n75988032)
print v(xbgr.mr_n75989184)
print v(xbgr.mr_n75989296)
print v(xbgr.mr_n75989920)
print v(xbgr.mr_n75991456)
print v(xbgr.mr_n75992320)
print v(xbgr.mr_n75993280)
print v(xbgr.mr_n75993392)
print v(xbgr.mr_n75994336)
print v(xbgr.mr_n75995488)
print v(xbgr.mr_n75995600)
print v(xbgr.mr_n75996224)
print v(xbgr.mr_n75997760)
print v(xbgr.mr_n75998624)
print v(xbgr.mr_n75999584)
print v(xbgr.mr_n75999696)
print v(xbgr.mr_n76000640)
print v(xbgr.mr_n76001792)
print v(xbgr.mr_n76001904)
print v(xbgr.mr_n76002528)
print v(xbgr.mr_n76004064)
print v(xbgr.mr_n76004928)
print v(xbgr.mr_n76005888)
print v(xbgr.mr_n76006000)
print v(xbgr.mr_n76006944)
print v(xbgr.mr_n76008096)
print v(xbgr.mr_n76008208)
print v(xbgr.mr_n76008832)
print v(xbgr.mr_n76010368)
print v(xbgr.mr_n76011232)
print v(xbgr.mr_n76012192)
print v(xbgr.mr_n76012304)
print v(xbgr.mr_n76013248)
print v(xbgr.mr_n76014400)
print v(xbgr.mr_n76014512)
print v(xbgr.mr_n76015136)
print v(xbgr.mr_n76017312)
print v(xbgr.mr_n76017648)
print v(xbgr.mr_n76019568)
print v(xbgr.mr_n76020128)
print v(xbgr.mr_n76020816)
print v(xbgr.mr_n76021568)
print v(xbgr.mr_n76022512)
print v(xbgr.mr_n76023456)
print v(xbgr.mr_n76024400)
print v(xbgr.mr_n76025344)
print v(xbgr.mr_n76026288)
print v(xbgr.mr_n76027232)
print v(xbgr.mr_n76028176)
print v(xbgr.mr_n76029120)
print v(xbgr.mr_n76030064)
print v(xbgr.mr_n76031008)
print v(xbgr.mr_n76031952)
print v(xbgr.mr_n76032896)
print v(xbgr.mr_n76033840)
print v(xbgr.mr_n76034784)
print v(xbgr.mr_n76035728)
print v(xbgr.mr_n76036672)
print v(xbgr.mr_n76037616)
print v(xbgr.mr_n76038560)
print v(xbgr.mr_n76039504)
print v(xbgr.mr_n76040448)
print v(xbgr.mr_n76041392)
print v(xbgr.mr_n76042336)
print v(xbgr.mr_n76043280)
print v(xbgr.mr_n76044224)
print v(xbgr.mr_n76045168)
print v(xbgr.mr_n76046112)
print v(xbgr.mr_n76047056)
print v(xbgr.mr_n76048000)
print v(xbgr.mr_n76048944)
print v(xbgr.mr_n76049888)
print v(xbgr.mr_n76050832)
print v(xbgr.mr_n76051776)
print v(xbgr.mr_n76055792)
print v(xbgr.mr_n76057040)
print v(xbgr.mr_n76058736)
print v(xbgr.mr_n76058992)
print v(xbgr.mr_n76060704)
print v(xbgr.mr_n76060816)
print v(xbgr.mr_n76062672)
print v(xbgr.mr_n76062784)
print v(xbgr.mr_n76064768)
print v(xbgr.mr_n76064880)
print v(xbgr.mr_n76066032)
print v(xbgr.mr_n76066144)
print v(xbgr.mr_n76067296)
print v(xbgr.mr_n76067408)
print v(xbgr.mr_n76068560)
print v(xbgr.mr_n76068672)
print v(xbgr.mr_n76069824)
print v(xbgr.mr_n76069936)
print v(xbgr.mr_n76071088)
print v(xbgr.mr_n76071200)
print v(xbgr.mr_n76072352)
print v(xbgr.mr_n76072464)
print v(xbgr.mr_n76089440)
print v(xbgr.mr_n76089696)
print v(xbgr.mr_n76089952)
print v(xbgr.mr_n76090208)
print v(xbgr.mr_n76092800)
print v(xbgr.mr_n76092912)
print v(xbgr.mr_n76093696)
print v(xbgr.mr_n76094176)
print v(xbgr.mr_n76094448)
print v(xbgr.mr_n76100128)
print v(xbgr.mr_n76101152)
print v(xbgr.mr_n76102400)
print v(xbgr.mr_n76102512)
print v(xbgr.mr_n76104512)
print v(xbgr.mr_n76106256)
print v(xbgr.mr_n76106528)
print v(xbgr.mr_n76106720)
print v(xbgr.mr_n76109952)
print v(xbgr.mr_n76110144)
print v(xbgr.mr_n76112976)
print v(xbgr.mr_n76113168)
print v(xbgr.mr_n76113360)
print v(xbgr.mr_n76116704)
print v(xbgr.mr_n76117984)
print v(xbgr.mr_n76118176)
print v(xbgr.mr_n76120928)
print v(xbgr.mr_n76122656)
print v(xbgr.mr_n76122848)
print v(xbgr.mr_n76126016)
print v(xbgr.mr_n76126208)
print v(xbgr.mr_n76129024)
print v(xbgr.mr_n76130352)
print v(xbgr.mr_n76130624)
print v(xbgr.mr_n76130816)
print v(xbgr.mr_n76134544)
print v(xbgr.mr_n76135792)
print v(xbgr.mr_n76135904)
print v(xbgr.mr_n76138944)
print v(xbgr.mr_n76139136)
print v(xbgr.mr_n76139328)
print v(xbgr.mr_n76140576)
print v(xbgr.mr_n76140688)
print v(xbgr.mr_n76142304)
print v(xbgr.mr_n76145104)
print v(xbgr.mr_n76146352)
print v(xbgr.mr_n76146464)
print v(xbgr.mr_n76158400)
print v(xbgr.mr_n76159232)
print v(xbgr.mr_n76159344)
print v(xbgr.mr_n76160176)
print v(xbgr.mr_n76160288)
print v(xbgr.mr_n76161120)
print v(xbgr.mr_n76161232)
print v(xbgr.mr_n76162320)
print v(xbgr.mr_n76162432)
print v(xbgr.mr_n76163584)
print v(xbgr.mr_n76163696)
print v(xbgr.mr_n76164848)
print v(xbgr.mr_n76164960)
print v(xbgr.mr_n76166112)
print v(xbgr.mr_n76166224)
print v(xbgr.mr_n76167376)
print v(xbgr.mr_n76167488)
print v(xbgr.mr_n76168640)
print v(xbgr.mr_n76168752)
print v(xbgr.mr_n76169904)
print v(xbgr.mr_n76170016)
print v(xbgr.mr_n76171168)
print v(xbgr.mr_n76171280)
print v(xbgr.mr_n76172432)
print v(xbgr.mr_n76172544)
print v(xbgr.mr_n76173696)
print v(xbgr.mr_n76173808)
print v(xbgr.mr_n76174960)
print v(xbgr.mr_n76175072)
print v(xbgr.mr_n76176224)
print v(xbgr.mr_n76176336)
print v(xbgr.mr_n76182016)
print v(xbgr.mr_n76183744)
print v(xbgr.mr_n76184432)
print v(xbgr.mr_n76185120)
print v(xbgr.mr_n76185840)
print v(xbgr.mr_n76187456)
print v(xbgr.mr_n76188736)
print v(xbgr.mr_n76188848)
print v(xbgr.mr_n76189792)
print v(xbgr.mr_n76190944)
print v(xbgr.mr_n76191056)
print v(xbgr.mr_n76191680)
print v(xbgr.mr_n76193216)
print v(xbgr.mr_n76194336)
print v(xbgr.mr_n76194720)
print v(xbgr.mr_n76194832)
print v(xbgr.mr_n76195104)
print v(xbgr.mr_n76197056)
print v(xbgr.mr_n76198240)
print v(xbgr.mr_n76199584)
print v(xbgr.mr_n76200128)
print v(xbgr.mr_n76201472)
print v(xbgr.mr_n76202016)
print v(xbgr.mr_n76203360)
print v(xbgr.mr_n76203904)
print v(xbgr.mr_n76205248)
print v(xbgr.mr_n76205792)
print v(xbgr.mr_n76207136)
print v(xbgr.mr_n76207680)
print v(xbgr.mr_n76208960)
print v(xbgr.mr_n76209504)
print v(xbgr.mr_n76210912)
print v(xbgr.mr_n76211456)
print v(xbgr.mr_n76212800)
print v(xbgr.mr_n76213664)
print v(xbgr.mr_n76214624)
print v(xbgr.mr_n76214736)
print v(xbgr.mr_n76215680)
print v(xbgr.mr_n76216832)
print v(xbgr.mr_n76216944)
print v(xbgr.mr_n76217888)
print v(xbgr.mr_n76219040)
print v(xbgr.mr_n76219152)
print v(xbgr.mr_n76220560)
print v(xbgr.mr_n76228352)
print v(xbgr.mr_n76233776)
print v(xbgr.mr_n76234976)
print v(xbgr.mr_n76235664)
print v(xbgr.mr_n76236352)
print v(xbgr.mr_n76237072)
print v(xbgr.mr_n76238016)
print v(xbgr.mr_n76238208)
print v(xbgr.mr_n76238400)
print v(xbgr.mr_n76238592)
print v(xbgr.mr_n76238784)
print v(xbgr.mr_n76238976)
print v(xbgr.mr_n76241120)
print v(xbgr.mr_n76241232)
print v(xbgr.mr_n76243248)
print v(xbgr.mr_n76245264)
print v(xbgr.mr_n76245376)
print v(xbgr.mr_n76251024)
print v(xbgr.mr_n76251968)
print v(xbgr.mr_n76258368)
print v(xbgr.mr_n76266992)
print v(xbgr.mr_n76267936)
print v(xbgr.mr_n76268880)
print v(xbgr.mr_n76269824)
print v(xbgr.mr_n76270768)
print v(xbgr.mr_n76271712)
print v(xbgr.mr_n76272656)
print v(xbgr.mr_n76273600)
print v(xbgr.mr_n76274992)
print v(xbgr.mr_n76277520)
print v(xbgr.mr_n76279152)
print v(xbgr.mr_n76279344)
print v(xbgr.mr_n76280176)
print v(xbgr.mr_n76280688)
print v(xbgr.mr_n76282304)
print v(xbgr.mr_n76282496)
print v(xbgr.mr_n76283328)
print v(xbgr.mr_n76283840)
print v(xbgr.mr_n76285392)
print v(xbgr.mr_n76285920)
print v(xbgr.mr_n76286480)
print v(xbgr.mr_n76286992)
print v(xbgr.mr_n76288608)
print v(xbgr.mr_n76288800)
print v(xbgr.mr_n76289632)
print v(xbgr.mr_n76290144)
print v(xbgr.mr_n76291392)
print v(xbgr.mr_n76291696)
print v(xbgr.mr_n76292224)
print v(xbgr.mr_n76292784)
print v(xbgr.mr_n76293296)
print v(xbgr.mr_n76294912)
print v(xbgr.mr_n76295104)
print v(xbgr.mr_n76295936)
print v(xbgr.mr_n76296448)
print v(xbgr.mr_n76298208)
print v(xbgr.mr_n76298400)
print v(xbgr.mr_n76299088)
print v(xbgr.mr_n76299600)
print v(xbgr.mr_n76301152)
print v(xbgr.mr_n76301680)
print v(xbgr.mr_n76302240)
print v(xbgr.mr_n76302816)
print v(xbgr.mr_n76303504)
print v(xbgr.mr_n76304208)
print v(xbgr.mr_n76304768)
print v(xbgr.mr_n76305472)
print v(xbgr.mr_n76306032)
print v(xbgr.mr_n76306608)
print v(xbgr.mr_n76307296)
print v(xbgr.mr_n76307728)
print v(xbgr.mr_n76308560)
print v(xbgr.mr_n76308992)
print v(xbgr.mr_n76309824)
print v(xbgr.mr_n76310256)
print v(xbgr.mr_n76311088)
print v(xbgr.mr_n76313520)
print v(xbgr.mr_n76314208)
print v(xbgr.mr_n76314896)
print v(xbgr.mr_n76317216)
print v(xbgr.mr_n76317552)
print v(xbgr.mr_n76317744)
print v(xbgr.mr_n76318432)
print v(xbgr.mr_n76318624)
print v(xbgr.mr_n76319200)
print v(xbgr.mr_n76319312)
print v(xbgr.mr_n76321072)
print v(xbgr.mr_n76321904)
print v(xbgr.mr_n76322176)
print v(xbgr.mr_n76322288)
print v(xbgr.mr_n76322928)
print v(xbgr.mr_n76323040)
print v(xbgr.mr_n76323152)
print v(xbgr.mr_n76323344)
print v(xbgr.mr_n76323536)
print v(xbgr.mr_n76323728)
print v(xbgr.mr_n76324240)
print v(xbgr.mr_n76325984)
print v(xbgr.mr_n76326256)
print v(xbgr.mr_n76326448)
print v(xbgr.mr_n76326960)
print v(xbgr.mr_n76328448)
print v(xbgr.mr_n76329824)
print v(xbgr.mr_n76330016)
print v(xbgr.mr_n76330208)
print v(xbgr.mr_n76330800)
print v(xbgr.mr_n76333904)
print v(xbgr.mr_n76334208)
print v(xbgr.mr_n76334400)
print v(xbgr.mr_n76335232)
print v(xbgr.mr_n76339056)
print v(xbgr.mr_n76339328)
print v(xbgr.mr_n76339520)
print v(xbgr.mr_n76340032)
print v(xbgr.mr_n76341728)
print v(xbgr.mr_n76341920)
print v(xbgr.mr_n76342112)
print v(xbgr.mr_n76342640)
print v(xbgr.mr_n76344368)
print v(xbgr.mr_n76344560)
print v(xbgr.mr_n76345072)
print v(xbgr.mr_n76346944)
print v(xbgr.mr_n76347456)
print v(xbgr.mr_n76350192)
print v(xbgr.mr_n76350464)
print v(xbgr.mr_n76350656)
print v(xbgr.mr_n76351168)
print v(xbgr.mr_n76352784)
print v(xbgr.mr_n76352976)
print v(xbgr.mr_n76355168)
print v(xbgr.mr_n76355440)
print v(xbgr.mr_n76355632)
print v(xbgr.mr_n76356144)
print v(xbgr.mr_n76358080)
print v(xbgr.mr_n76358592)
print v(xbgr.mr_n76361328)
print v(xbgr.mr_n76361600)
print v(xbgr.mr_n76361792)
print v(xbgr.mr_n76362304)
print v(xbgr.mr_n76363920)
print v(xbgr.mr_n76364112)
print v(xbgr.mr_n76366304)
print v(xbgr.mr_n76366576)
print v(xbgr.mr_n76366768)
print v(xbgr.mr_n76367280)
print v(xbgr.mr_n76369216)
print v(xbgr.mr_n76369728)
print v(xbgr.mr_n76372464)
print v(xbgr.mr_n76372736)
print v(xbgr.mr_n76372928)
print v(xbgr.mr_n76373440)
print v(xbgr.mr_n76377152)
print v(xbgr.mr_n76378304)
print v(xbgr.mr_n76378416)
print v(xbgr.mr_n76379568)
print v(xbgr.mr_n76379680)
print v(xbgr.mr_n76380832)
print v(xbgr.mr_n76380944)
print v(xbgr.mr_n76382096)
print v(xbgr.mr_n76382208)
print v(xbgr.mr_n76383360)
print v(xbgr.mr_n76383472)
print v(xbgr.mr_n76384624)
print v(xbgr.mr_n76384736)
print v(xbgr.mr_n76385888)
print v(xbgr.mr_n76386000)
print v(xbgr.mr_n76387152)
print v(xbgr.mr_n76387264)
print v(xbgr.mr_n76388416)
print v(xbgr.mr_n76388528)
print v(xbgr.mr_n76389680)
print v(xbgr.mr_n76389792)
print v(xbgr.mr_n76390944)
print v(xbgr.mr_n76391056)
print v(xbgr.mr_n76392208)
print v(xbgr.mr_n76392320)
print v(xbgr.mr_n76393472)
print v(xbgr.mr_n76393584)
print v(xbgr.mr_n76394736)
print v(xbgr.mr_n76394848)
print v(xbgr.mr_n76396000)
print v(xbgr.mr_n76396112)
print v(xbgr.mr_n76403872)
print v(xbgr.mr_n76404208)
print v(xbgr.mr_n76413904)
print v(xbgr.mr_n76420528)
print v(xbgr.mr_n76426400)
print v(xbgr.mr_n76428016)
print v(xbgr.mr_n76429792)
print v(xbgr.mr_n76430480)
print v(xbgr.mr_n76431232)
print v(xbgr.mr_n76432176)
print v(xbgr.mr_n76435872)
print v(xbgr.mr_n76436896)
print v(xbgr.mr_n76438864)
print v(xbgr.mr_n76439056)
print v(xbgr.mr_n76439744)
print v(xbgr.mr_n76439856)
print v(xbgr.mr_n76439968)
print v(xbgr.mr_n76440080)
print v(xbgr.mr_n76440192)
print v(xbgr.mr_n76441936)
print v(xbgr.mr_n76442208)
print v(xbgr.mr_n76442400)
print v(xbgr.mr_n76442912)
print v(xbgr.mr_n76444848)
print v(xbgr.mr_n76445120)
print v(xbgr.mr_n76446592)
print v(xbgr.mr_n76446864)
print v(xbgr.mr_n76447056)
print v(xbgr.mr_n76447568)
print v(xbgr.mr_n76449504)
print v(xbgr.mr_n76451248)
print v(xbgr.mr_n76451520)
print v(xbgr.mr_n76451712)
print v(xbgr.mr_n76452224)
print v(xbgr.mr_n76453456)
print v(xbgr.mr_n76453968)
print v(xbgr.mr_n76457408)
print v(xbgr.mr_n76457680)
print v(xbgr.mr_n76457872)
print v(xbgr.mr_n76458384)
print v(xbgr.mr_n76462384)
print v(xbgr.mr_n76462656)
print v(xbgr.mr_n76462848)
print v(xbgr.mr_n76463360)
print v(xbgr.mr_n76464256)
print v(xbgr.mr_n76466096)
print v(xbgr.mr_n76467792)
print v(xbgr.mr_n76469888)
print v(xbgr.mr_n76470720)
print v(xbgr.mr_n76470832)
print v(xbgr.mr_n76470944)
print v(xbgr.mr_n76471056)
print v(xbgr.mr_n76471248)
print v(xbgr.mr_n76471440)
print v(xbgr.mr_n76473248)
print v(xbgr.mr_n76473440)
print v(xbgr.mr_n76473952)
print v(xbgr.mr_n76475120)
print v(xbgr.mr_n76475632)
print v(xbgr.mr_n76479072)
print v(xbgr.mr_n76479344)
print v(xbgr.mr_n76479536)
print v(xbgr.mr_n76480048)
print v(xbgr.mr_n76482192)
print v(xbgr.mr_n76482304)
print v(xbgr.mr_n76484048)
print v(xbgr.mr_n76484320)
print v(xbgr.mr_n76484512)
print v(xbgr.mr_n76485024)
print v(xbgr.mr_n76486256)
print v(xbgr.mr_n76486768)
print v(xbgr.mr_n76490208)
print v(xbgr.mr_n76490480)
print v(xbgr.mr_n76490672)
print v(xbgr.mr_n76491184)
print v(xbgr.mr_n76493328)
print v(xbgr.mr_n76493440)
print v(xbgr.mr_n76495184)
print v(xbgr.mr_n76495456)
print v(xbgr.mr_n76495648)
print v(xbgr.mr_n76496160)
print v(xbgr.mr_n76497392)
print v(xbgr.mr_n76497904)
print v(xbgr.mr_n76499872)
print v(xbgr.mr_n76501344)
print v(xbgr.mr_n76501616)
print v(xbgr.mr_n76501808)
print v(xbgr.mr_n76502320)
print v(xbgr.mr_n76504384)
print v(xbgr.mr_n76504496)
print v(xbgr.mr_n76505008)
print v(xbgr.mr_n76505120)
print v(xbgr.mr_n76505632)
print v(xbgr.mr_n76505744)
print v(xbgr.mr_n76506512)
print v(xbgr.mr_n76506624)
print v(xbgr.mr_n76507456)
print v(xbgr.mr_n76507568)
print v(xbgr.mr_n76508400)
print v(xbgr.mr_n76508512)
print v(xbgr.mr_n76509344)
print v(xbgr.mr_n76509456)
print v(xbgr.mr_n76510288)
print v(xbgr.mr_n76510400)
print v(xbgr.mr_n76511296)
print v(xbgr.mr_n76511408)
print v(xbgr.mr_n76512560)
print v(xbgr.mr_n76512672)
print v(xbgr.mr_n76513824)
print v(xbgr.mr_n76513936)
print v(xbgr.mr_n76515088)
print v(xbgr.mr_n76515200)
print v(xbgr.mr_n76516352)
print v(xbgr.mr_n76516464)
print v(xbgr.mr_n76517616)
print v(xbgr.mr_n76517728)
print v(xbgr.mr_n76518880)
print v(xbgr.mr_n76518992)
print v(xbgr.mr_n76519440)
print v(xbgr.mr_n76520320)
print v(xbgr.mr_n76521536)
print v(xbgr.mr_n76522112)
print v(xbgr.mr_n76530768)
print v(xbgr.mr_n76530880)
print v(xbgr.mr_n76532032)
print v(xbgr.mr_n76532144)
print v(xbgr.mr_n76533296)
print v(xbgr.mr_n76533408)
print v(xbgr.mr_n76534560)
print v(xbgr.mr_n76534672)
print v(xbgr.mr_n76535824)
print v(xbgr.mr_n76535936)
print v(xbgr.mr_n76537088)
print v(xbgr.mr_n76537200)
print v(xbgr.mr_n76538352)
print v(xbgr.mr_n76538464)
print v(xbgr.mr_n76539616)
print v(xbgr.mr_n76539728)
print v(xbgr.mr_n76540880)
print v(xbgr.mr_n76540992)
print v(xbgr.mr_n76542144)
print v(xbgr.mr_n76542256)
print v(xbgr.mr_n76543408)
print v(xbgr.mr_n76543520)
print v(xbgr.mr_n76544672)
print v(xbgr.mr_n76544784)
print v(xbgr.mr_n76545936)
print v(xbgr.mr_n76546048)
print v(xbgr.mr_n76547200)
print v(xbgr.mr_n76547312)
print v(xbgr.mr_n76548464)
print v(xbgr.mr_n76548576)
print v(xbgr.mr_n76549728)
print v(xbgr.mr_n76549840)
print v(xbgr.mr_n76550992)
print v(xbgr.mr_n76551104)
print v(xbgr.mr_n76552176)
print v(xbgr.mr_n76553136)
print v(xbgr.mr_n76561408)
print v(xbgr.mr_n76562544)
print v(xbgr.mr_n76564528)
print v(xbgr.mr_n76572432)
print v(xbgr.mr_n76574992)
print v(xbgr.mr_n76575216)
print v(xbgr.mr_n76575456)
print v(xbgr.mr_n76575632)
print v(xbgr.mr_n76576160)
print v(xbgr.mr_n76576512)
print v(xbgr.mr_n76577920)
print v(xbgr.mr_n76578976)
print v(xbgr.mr_n76579328)
print v(xbgr.mr_n76580800)
print v(xbgr.mr_n76581152)
print v(xbgr.mr_n76583376)
print v(xbgr.mr_n76584144)
print v(xbgr.mr_n76584432)
print v(xbgr.mr_n76586432)
print v(xbgr.mr_n76586784)
print v(xbgr.mr_n76587488)
print v(xbgr.mr_n76589008)
print v(xbgr.mr_n76589536)
print v(xbgr.mr_n76589712)
print v(xbgr.mr_n76589888)
print v(xbgr.mr_n76590592)
print v(xbgr.mr_n76591008)
print v(xbgr.mr_n76591888)
print v(xbgr.mr_n76592592)
print v(xbgr.mr_n76592928)
print v(xbgr.mr_n76593040)
print v(xbgr.mr_n76594736)
print v(xbgr.mr_n76597408)
print v(xbgr.mr_n76598096)
print v(xbgr.mr_n76598784)
print v(xbgr.mr_n76599280)
print v(xbgr.mr_n76599696)
print v(xbgr.mr_n76602112)
print v(xbgr.mr_n76603888)
print v(xbgr.mr_n76604512)
print v(xbgr.mr_n76604704)
print v(xbgr.mr_n76605536)
print v(xbgr.mr_n76605648)
print v(xbgr.mr_n76605760)
print v(xbgr.mr_n76605872)
print v(xbgr.mr_n76605984)
print v(xbgr.mr_n76607728)
print v(xbgr.mr_n76608000)
print v(xbgr.mr_n76608192)
print v(xbgr.mr_n76608704)
print v(xbgr.mr_n76610672)
print v(xbgr.mr_n76612416)
print v(xbgr.mr_n76612688)
print v(xbgr.mr_n76612880)
print v(xbgr.mr_n76613392)
print v(xbgr.mr_n76615328)
print v(xbgr.mr_n76617072)
print v(xbgr.mr_n76617344)
print v(xbgr.mr_n76617536)
print v(xbgr.mr_n76618048)
print v(xbgr.mr_n76619984)
print v(xbgr.mr_n76621728)
print v(xbgr.mr_n76622000)
print v(xbgr.mr_n76622192)
print v(xbgr.mr_n76622704)
print v(xbgr.mr_n76624640)
print v(xbgr.mr_n76626384)
print v(xbgr.mr_n76626656)
print v(xbgr.mr_n76626848)
print v(xbgr.mr_n76627360)
print v(xbgr.mr_n76629296)
print v(xbgr.mr_n76631040)
print v(xbgr.mr_n76631312)
print v(xbgr.mr_n76631504)
print v(xbgr.mr_n76632016)
print v(xbgr.mr_n76633952)
print v(xbgr.mr_n76635696)
print v(xbgr.mr_n76635968)
print v(xbgr.mr_n76636160)
print v(xbgr.mr_n76636672)
print v(xbgr.mr_n76638608)
print v(xbgr.mr_n76640352)
print v(xbgr.mr_n76640624)
print v(xbgr.mr_n76640816)
print v(xbgr.mr_n76641328)
print v(xbgr.mr_n76643264)
print v(xbgr.mr_n76645008)
print v(xbgr.mr_n76645280)
print v(xbgr.mr_n76645472)
print v(xbgr.mr_n76645984)
print v(xbgr.mr_n76647920)
print v(xbgr.mr_n76649664)
print v(xbgr.mr_n76649936)
print v(xbgr.mr_n76650128)
print v(xbgr.mr_n76650640)
print v(xbgr.mr_n76652576)
print v(xbgr.mr_n76654320)
print v(xbgr.mr_n76654592)
print v(xbgr.mr_n76654784)
print v(xbgr.mr_n76655296)
print v(xbgr.mr_n76657232)
print v(xbgr.mr_n76658976)
print v(xbgr.mr_n76659248)
print v(xbgr.mr_n76659440)
print v(xbgr.mr_n76659952)
print v(xbgr.mr_n76661888)
print v(xbgr.mr_n76663632)
print v(xbgr.mr_n76663904)
print v(xbgr.mr_n76664096)
print v(xbgr.mr_n76664608)
print v(xbgr.mr_n76666544)
print v(xbgr.mr_n76668288)
print v(xbgr.mr_n76668560)
print v(xbgr.mr_n76668752)
print v(xbgr.mr_n76669264)
print v(xbgr.mr_n76671200)
print v(xbgr.mr_n76672944)
print v(xbgr.mr_n76673216)
print v(xbgr.mr_n76673408)
print v(xbgr.mr_n76673920)
print v(xbgr.mr_n76675856)
print v(xbgr.mr_n76677600)
print v(xbgr.mr_n76677872)
print v(xbgr.mr_n76678064)
print v(xbgr.mr_n76678576)
print v(xbgr.mr_n76680512)
print v(xbgr.mr_n76682256)
print v(xbgr.mr_n76682528)
print v(xbgr.mr_n76682720)
print v(xbgr.mr_n76683232)
print v(xbgr.mr_n76686064)
print v(xbgr.mr_n76686848)
print v(xbgr.mr_n76688496)
print v(xbgr.mr_n76688832)
print v(xbgr.mr_n76691040)
print v(xbgr.mr_n76693568)
print v(xbgr.mr_n76694992)
print v(xbgr.mr_n76695568)
print v(xbgr.mr_n76695680)
print v(xbgr.mr_n76696624)
print v(xbgr.mr_n76697456)
print v(xbgr.mr_n76697568)
print v(xbgr.mr_n76698512)
print v(xbgr.mr_n76699664)
print v(xbgr.mr_n76699776)
print v(xbgr.mr_n76700720)
print v(xbgr.mr_n76701872)
print v(xbgr.mr_n76701984)
print v(xbgr.mr_n76702928)
print v(xbgr.mr_n76704080)
print v(xbgr.mr_n76704192)
print v(xbgr.mr_n76705136)
print v(xbgr.mr_n76706288)
print v(xbgr.mr_n76706400)
print v(xbgr.mr_n76707344)
print v(xbgr.mr_n76708496)
print v(xbgr.mr_n76708608)
print v(xbgr.mr_n76709552)
print v(xbgr.mr_n76710640)
print v(xbgr.mr_n76710752)
print v(xbgr.mr_n76711696)
print v(xbgr.mr_n76712848)
print v(xbgr.mr_n76712960)
print v(xbgr.mr_n76713904)
print v(xbgr.mr_n76715120)
print v(xbgr.mr_n76715232)
print v(xbgr.mr_n76716176)
print v(xbgr.mr_n76717328)
print v(xbgr.mr_n76717440)
print v(xbgr.mr_n76718384)
print v(xbgr.mr_n76719536)
print v(xbgr.mr_n76719648)
print v(xbgr.mr_n76720592)
print v(xbgr.mr_n76721744)
print v(xbgr.mr_n76721856)
print v(xbgr.mr_n76722800)
print v(xbgr.mr_n76723952)
print v(xbgr.mr_n76724064)
print v(xbgr.mr_n76725008)
print v(xbgr.mr_n76726096)
print v(xbgr.mr_n76726208)
print v(xbgr.mr_n76727424)
print v(xbgr.mr_n76727536)
print v(xbgr.mr_n76728688)
print v(xbgr.mr_n76728800)
print v(xbgr.mr_n76733792)
print v(xbgr.mr_n76733904)
print v(xbgr.mr_n76734144)
print v(xbgr.mr_n76734672)
print v(xbgr.mr_n76735424)
print v(xbgr.mr_n76736384)
print v(xbgr.mr_n76736496)
print v(xbgr.mr_n76739504)
print v(xbgr.mr_n76739616)
print v(xbgr.mr_n76741344)
print v(xbgr.mr_n76741456)
print v(xbgr.mr_n76742608)
print v(xbgr.mr_n76742720)
print v(xbgr.mr_n76743808)
print v(xbgr.mr_n76743920)
print v(xbgr.mr_n76746912)
print v(xbgr.mr_n76753824)
print v(xbgr.mr_n76756592)
print v(xbgr.mr_n76759536)
print v(xbgr.mr_n76774112)
print v(xbgr.mr_n76774304)
print v(xbgr.mr_n76774496)
print v(xbgr.mr_n76774688)
print v(xbgr.mr_n76777008)
print v(xbgr.mr_n76777280)
print v(xbgr.mr_n76777472)
print v(xbgr.mr_n76777984)
print v(xbgr.mr_n76783664)
print v(xbgr.mr_n76783856)
print v(xbgr.mr_n76784048)
print v(xbgr.mr_n76784640)
print v(xbgr.mr_n76786784)
print v(xbgr.mr_n76786896)
print v(xbgr.mr_n76788640)
print v(xbgr.mr_n76788912)
print v(xbgr.mr_n76789104)
print v(xbgr.mr_n76789616)
print v(xbgr.mr_n76790768)
print v(xbgr.mr_n76791360)
print v(xbgr.mr_n76794800)
print v(xbgr.mr_n76795072)
print v(xbgr.mr_n76795264)
print v(xbgr.mr_n76795776)
print v(xbgr.mr_n76797920)
print v(xbgr.mr_n76798032)
print v(xbgr.mr_n76799776)
print v(xbgr.mr_n76800048)
print v(xbgr.mr_n76800240)
print v(xbgr.mr_n76800752)
print v(xbgr.mr_n76801984)
print v(xbgr.mr_n76802496)
print v(xbgr.mr_n76805936)
print v(xbgr.mr_n76806208)
print v(xbgr.mr_n76806400)
print v(xbgr.mr_n76806912)
print v(xbgr.mr_n76809056)
print v(xbgr.mr_n76809168)
print v(xbgr.mr_n76809424)
print v(xbgr.mr_n76810912)
print v(xbgr.mr_n76811184)
print v(xbgr.mr_n76811376)
print v(xbgr.mr_n76811888)
print v(xbgr.mr_n76813184)
print v(xbgr.mr_n76813696)
print v(xbgr.mr_n76817072)
print v(xbgr.mr_n76817344)
print v(xbgr.mr_n76817536)
print v(xbgr.mr_n76818048)
print v(xbgr.mr_n76820192)
print v(xbgr.mr_n76820304)
print v(xbgr.mr_n76822048)
print v(xbgr.mr_n76822320)
print v(xbgr.mr_n76822512)
print v(xbgr.mr_n76823024)
print v(xbgr.mr_n76824256)
print v(xbgr.mr_n76824768)
print v(xbgr.mr_n76828208)
print v(xbgr.mr_n76828480)
print v(xbgr.mr_n76828672)
print v(xbgr.mr_n76829184)
print v(xbgr.mr_n76831328)
print v(xbgr.mr_n76831440)
print v(xbgr.mr_n76833184)
print v(xbgr.mr_n76833456)
print v(xbgr.mr_n76833648)
print v(xbgr.mr_n76834160)
print v(xbgr.mr_n76835392)
print v(xbgr.mr_n76835904)
print v(xbgr.mr_n76837968)
print v(xbgr.mr_n76839344)
print v(xbgr.mr_n76839616)
print v(xbgr.mr_n76839808)
print v(xbgr.mr_n76840320)
print v(xbgr.mr_n76845520)
print v(xbgr.mr_n76845632)
print v(xbgr.mr_n76846464)
print v(xbgr.mr_n76846576)
print v(xbgr.mr_n76847408)
print v(xbgr.mr_n76847520)
print v(xbgr.mr_n76848608)
print v(xbgr.mr_n76848720)
print v(xbgr.mr_n76849872)
print v(xbgr.mr_n76849984)
print v(xbgr.mr_n76851136)
print v(xbgr.mr_n76851248)
print v(xbgr.mr_n76852400)
print v(xbgr.mr_n76852512)
print v(xbgr.mr_n76853664)
print v(xbgr.mr_n76853776)
print v(xbgr.mr_n76854928)
print v(xbgr.mr_n76855040)
print v(xbgr.mr_n76856192)
print v(xbgr.mr_n76856304)
print v(xbgr.mr_n76857456)
print v(xbgr.mr_n76857568)
print v(xbgr.mr_n76858720)
print v(xbgr.mr_n76858832)
print v(xbgr.mr_n76859984)
print v(xbgr.mr_n76860096)
print v(xbgr.mr_n76861248)
print v(xbgr.mr_n76861360)
print v(xbgr.mr_n76862512)
print v(xbgr.mr_n76862624)
print v(xbgr.mr_n76865616)
print v(xbgr.mr_n76866256)
print v(xbgr.mr_n76872784)
print v(xbgr.mr_n76873472)
print v(xbgr.mr_n76874160)
print v(xbgr.mr_n76874848)
print v(xbgr.mr_n76876592)
print v(xbgr.mr_n76877664)
print v(xbgr.mr_n76878608)
print v(xbgr.mr_n76879552)
print v(xbgr.mr_n76880496)
print v(xbgr.mr_n76881440)
print v(xbgr.mr_n76882384)
print v(xbgr.mr_n76883744)
print v(xbgr.mr_n76884800)
print v(xbgr.mr_n76885136)
print v(xbgr.mr_n76887344)
print v(xbgr.mr_n76888272)
print v(xbgr.mr_n76888912)
print v(xbgr.mr_n76890480)
print v(xbgr.mr_n76892048)
print v(xbgr.mr_n76893616)
print v(xbgr.mr_n76895184)
print v(xbgr.mr_n76896752)
print v(xbgr.mr_n76898320)
print v(xbgr.mr_n76902800)
print v(xbgr.mr_n76903488)
print v(xbgr.mr_n76904176)
print v(xbgr.mr_n76904928)
print v(xbgr.mr_n76906544)
print v(xbgr.mr_n76907824)
print v(xbgr.mr_n76907936)
print v(xbgr.mr_n76908880)
print v(xbgr.mr_n76909136)
print v(xbgr.mr_n76910032)
print v(xbgr.mr_n76910144)
print v(xbgr.mr_n76911088)
print v(xbgr.mr_n76912240)
print v(xbgr.mr_n76912352)
print v(xbgr.mr_n76913296)
print v(xbgr.mr_n76913472)
print v(xbgr.mr_n76914448)
print v(xbgr.mr_n76914560)
print v(xbgr.mr_n76915504)
print v(xbgr.mr_n76916656)
print v(xbgr.mr_n76916768)
print v(xbgr.mr_n76917712)
print v(xbgr.mr_n76918864)
print v(xbgr.mr_n76918976)
print v(xbgr.mr_n76919920)
print v(xbgr.mr_n76921072)
print v(xbgr.mr_n76921184)
print v(xbgr.mr_n76922128)
print v(xbgr.mr_n76923280)
print v(xbgr.mr_n76923392)
print v(xbgr.mr_n76924336)
print v(xbgr.mr_n76925488)
print v(xbgr.mr_n76925600)
print v(xbgr.mr_n76926544)
print v(xbgr.mr_n76927696)
print v(xbgr.mr_n76927808)
print v(xbgr.mr_n76928752)
print v(xbgr.mr_n76929904)
print v(xbgr.mr_n76930016)
print v(xbgr.mr_n76930960)
print v(xbgr.mr_n76932112)
print v(xbgr.mr_n76932224)
print v(xbgr.mr_n76933168)
print v(xbgr.mr_n76933344)
print v(xbgr.mr_n76934320)
print v(xbgr.mr_n76934432)
print v(xbgr.mr_n76935376)
print v(xbgr.mr_n76936528)
print v(xbgr.mr_n76936640)
print v(xbgr.mr_n76937584)
print v(xbgr.mr_n76938736)
print v(xbgr.mr_n76938848)
print v(xbgr.mr_n76939792)
print v(xbgr.mr_n76940944)
print v(xbgr.mr_n76941056)
print v(xbgr.mr_n76942000)
print v(xbgr.mr_n76943152)
print v(xbgr.mr_n76943264)
print v(xbgr.mr_n76944144)
print v(xbgr.mr_n76944832)
print v(xbgr.mr_n76945520)
print v(xbgr.mr_n76946240)
print v(xbgr.mr_n76947184)
print v(xbgr.mr_n76948128)
print v(xbgr.mr_n76949072)
print v(xbgr.mr_n76950016)
print v(xbgr.mr_n76950960)
print v(xbgr.mr_n76951904)
print v(xbgr.mr_n76952848)
print v(xbgr.mr_n76956240)
print v(xbgr.mr_n76961856)
print v(xbgr.mr_n76965440)
print v(xbgr.mr_n76970320)
print v(xbgr.mr_n76975296)
print v(xbgr.mr_n76975968)
print v(xbgr.mr_n76977040)
print v(xbgr.mr_n76977232)
print v(xbgr.mr_n76977424)
print v(xbgr.mr_n76977616)
print v(xbgr.mr_n76978400)
print v(xbgr.mr_n76979936)
print v(xbgr.mr_n76980208)
print v(xbgr.mr_n76980400)
print v(xbgr.mr_n76980912)
print v(xbgr.mr_n76985632)
print v(xbgr.mr_n76985904)
print v(xbgr.mr_n76986608)
print v(xbgr.mr_n76988752)
print v(xbgr.mr_n76988864)
print v(xbgr.mr_n76990608)
print v(xbgr.mr_n76990880)
print v(xbgr.mr_n76991072)
print v(xbgr.mr_n76991584)
print v(xbgr.mr_n76992816)
print v(xbgr.mr_n76993328)
print v(xbgr.mr_n76996768)
print v(xbgr.mr_n76997040)
print v(xbgr.mr_n76997232)
print v(xbgr.mr_n76997744)
print v(xbgr.mr_n77001744)
print v(xbgr.mr_n77002016)
print v(xbgr.mr_n77002208)
print v(xbgr.mr_n77002720)
print v(xbgr.mr_n77003248)
print v(xbgr.mr_n77003872)
print v(xbgr.mr_n77004464)
print v(xbgr.mr_n77004816)
print v(xbgr.mr_n77005504)
print v(xbgr.mr_n77005696)
print v(xbgr.mr_n77006384)
print v(xbgr.mr_n77007728)
print v(xbgr.mr_n77007920)
print v(xbgr.mr_n77008112)
print v(xbgr.mr_n77008304)
print v(xbgr.mr_n77010048)
print v(xbgr.mr_n77010320)
print v(xbgr.mr_n77010512)
print v(xbgr.mr_n77011024)
print v(xbgr.mr_n77013312)
print v(xbgr.mr_n77013824)
print v(xbgr.mr_n77017648)
print v(xbgr.mr_n77017920)
print v(xbgr.mr_n77018112)
print v(xbgr.mr_n77018624)
print v(xbgr.mr_n77020768)
print v(xbgr.mr_n77020880)
print v(xbgr.mr_n77022624)
print v(xbgr.mr_n77022896)
print v(xbgr.mr_n77023088)
print v(xbgr.mr_n77023600)
print v(xbgr.mr_n77024832)
print v(xbgr.mr_n77025344)
print v(xbgr.mr_n77028784)
print v(xbgr.mr_n77029056)
print v(xbgr.mr_n77029248)
print v(xbgr.mr_n77029760)
print v(xbgr.mr_n77031904)
print v(xbgr.mr_n77032016)
print v(xbgr.mr_n77033760)
print v(xbgr.mr_n77034032)
print v(xbgr.mr_n77034224)
print v(xbgr.mr_n77034736)
print v(xbgr.mr_n77035056)
print v(xbgr.mr_n77035968)
print v(xbgr.mr_n77036480)
print v(xbgr.mr_n77039920)
print v(xbgr.mr_n77040192)
print v(xbgr.mr_n77040384)
print v(xbgr.mr_n77040896)
print v(xbgr.mr_n77045840)
print v(xbgr.mr_n77045952)
print v(xbgr.mr_n77046784)
print v(xbgr.mr_n77046896)
print v(xbgr.mr_n77047728)
print v(xbgr.mr_n77047840)
print v(xbgr.mr_n77048928)
print v(xbgr.mr_n77049040)
print v(xbgr.mr_n77050192)
print v(xbgr.mr_n77050304)
print v(xbgr.mr_n77051456)
print v(xbgr.mr_n77051568)
print v(xbgr.mr_n77052720)
print v(xbgr.mr_n77052832)
print v(xbgr.mr_n77053984)
print v(xbgr.mr_n77054096)
print v(xbgr.mr_n77055248)
print v(xbgr.mr_n77055360)
print v(xbgr.mr_n77056512)
print v(xbgr.mr_n77056624)
print v(xbgr.mr_n77057776)
print v(xbgr.mr_n77057888)
print v(xbgr.mr_n77059040)
print v(xbgr.mr_n77059152)
print v(xbgr.mr_n77060304)
print v(xbgr.mr_n77060416)
print v(xbgr.mr_n77061568)
print v(xbgr.mr_n77061680)
print v(xbgr.mr_n77062832)
print v(xbgr.mr_n77062944)
print v(xbgr.mr_n77064480)
print v(xbgr.mr_n77064592)
print v(xbgr.mr_n77065744)
print v(xbgr.mr_n77065856)
print v(xbgr.mr_n77067008)
print v(xbgr.mr_n77067120)
print v(xbgr.mr_n77068272)
print v(xbgr.mr_n77068384)
print v(xbgr.mr_n77069536)
print v(xbgr.mr_n77069648)
print v(xbgr.mr_n77070800)
print v(xbgr.mr_n77070912)
print v(xbgr.mr_n77072064)
print v(xbgr.mr_n77072176)
print v(xbgr.mr_n77073328)
print v(xbgr.mr_n77073440)
print v(xbgr.mr_n77074592)
print v(xbgr.mr_n77074704)
print v(xbgr.mr_n77075856)
print v(xbgr.mr_n77075968)
print v(xbgr.mr_n77077120)
print v(xbgr.mr_n77077232)
print v(xbgr.mr_n77078384)
print v(xbgr.mr_n77078496)
print v(xbgr.mr_n77079648)
print v(xbgr.mr_n77079760)
print v(xbgr.mr_n77080912)
print v(xbgr.mr_n77081024)
print v(xbgr.mr_n77082176)
print v(xbgr.mr_n77082288)
print v(xbgr.mr_n77083440)
print v(xbgr.mr_n77083552)
print v(xbgr.mr_n77084704)
print v(xbgr.mr_n77084816)
print v(xbgr.mr_n77092496)
print v(xbgr.mr_n77095312)
print v(xbgr.mr_n77097952)
print v(xbgr.mr_n77121984)
print v(xbgr.mr_n77122672)
print v(xbgr.mr_n77123360)
print v(xbgr.mr_n77124080)
print v(xbgr.mr_n77125024)
print v(xbgr.mr_n77125968)
print v(xbgr.mr_n77126912)
print v(xbgr.mr_n77127856)
print v(xbgr.mr_n77128800)
print v(xbgr.mr_n77129744)
print v(xbgr.mr_n77130688)
print v(xbgr.mr_n77131632)
print v(xbgr.mr_n77132576)
print v(xbgr.mr_n77133520)
print v(xbgr.mr_n77134464)
print v(xbgr.mr_n77135408)
print v(xbgr.mr_n77136352)
print v(xbgr.mr_n77137296)
print v(xbgr.mr_n77138240)
print v(xbgr.mr_n77140144)
print v(xbgr.mr_n77140912)
print v(xbgr.mr_n77142992)
print v(xbgr.mr_n77147776)
print v(xbgr.mr_n77151840)
print v(xbgr.mr_n77151952)
print v(xbgr.mr_n77152784)
print v(xbgr.mr_n77152896)
print v(xbgr.mr_n77153008)
print v(xbgr.mr_n77153120)
print v(xbgr.mr_n77153232)
print v(xbgr.mr_n77154976)
print v(xbgr.mr_n77155248)
print v(xbgr.mr_n77155440)
print v(xbgr.mr_n77155952)
print v(xbgr.mr_n77156416)
print v(xbgr.mr_n77156944)
print v(xbgr.mr_n77158544)
print v(xbgr.mr_n77158816)
print v(xbgr.mr_n77159008)
print v(xbgr.mr_n77159520)
print v(xbgr.mr_n77163008)
print v(xbgr.mr_n77163280)
print v(xbgr.mr_n77163472)
print v(xbgr.mr_n77163984)
print v(xbgr.mr_n77165536)
print v(xbgr.mr_n77167792)
print v(xbgr.mr_n77167984)
print v(xbgr.mr_n77168176)
print v(xbgr.mr_n77168768)
print v(xbgr.mr_n77172256)
print v(xbgr.mr_n77172528)
print v(xbgr.mr_n77172720)
print v(xbgr.mr_n77173232)
print v(xbgr.mr_n77174784)
print v(xbgr.mr_n77177040)
print v(xbgr.mr_n77177312)
print v(xbgr.mr_n77177504)
print v(xbgr.mr_n77178016)
print v(xbgr.mr_n77181504)
print v(xbgr.mr_n77181776)
print v(xbgr.mr_n77181968)
print v(xbgr.mr_n77182480)
print v(xbgr.mr_n77184112)
print v(xbgr.mr_n77184304)
print v(xbgr.mr_n77186624)
print v(xbgr.mr_n77186816)
print v(xbgr.mr_n77187328)
print v(xbgr.mr_n77190752)
print v(xbgr.mr_n77191024)
print v(xbgr.mr_n77191216)
print v(xbgr.mr_n77191728)
print v(xbgr.mr_n77193280)
print v(xbgr.mr_n77195536)
print v(xbgr.mr_n77195808)
print v(xbgr.mr_n77196000)
print v(xbgr.mr_n77196512)
print v(xbgr.mr_n77198080)
print v(xbgr.mr_n77200336)
print v(xbgr.mr_n77200528)
print v(xbgr.mr_n77201040)
print v(xbgr.mr_n77203840)
print v(xbgr.mr_n77204112)
print v(xbgr.mr_n77204304)
print v(xbgr.mr_n77204816)
print v(xbgr.mr_n77207680)
print v(xbgr.mr_n77207952)
print v(xbgr.mr_n77208144)
print v(xbgr.mr_n77208656)
print v(xbgr.mr_n77212016)
print v(xbgr.mr_n77212128)
print v(xbgr.mr_n77213872)
print v(xbgr.mr_n77214144)
print v(xbgr.mr_n77214336)
print v(xbgr.mr_n77214848)
print v(xbgr.mr_n77216992)
print v(xbgr.mr_n77217104)
print v(xbgr.mr_n77217296)
print v(xbgr.mr_n77218848)
print v(xbgr.mr_n77219120)
print v(xbgr.mr_n77219312)
print v(xbgr.mr_n77219824)
print v(xbgr.mr_n77221968)
print v(xbgr.mr_n77222080)
print v(xbgr.mr_n77223824)
print v(xbgr.mr_n77224096)
print v(xbgr.mr_n77224288)
print v(xbgr.mr_n77224800)
print v(xbgr.mr_n77226944)
print v(xbgr.mr_n77227056)
print v(xbgr.mr_n77228800)
print v(xbgr.mr_n77229072)
print v(xbgr.mr_n77229264)
print v(xbgr.mr_n77229776)
print v(xbgr.mr_n77234944)
print v(xbgr.mr_n77237136)
print v(xbgr.mr_n77238704)
print v(xbgr.mr_n77239648)
print v(xbgr.mr_n77241840)
print v(xbgr.mr_n77243408)
print v(xbgr.mr_n77244352)
print v(xbgr.mr_n77246544)
print v(xbgr.mr_n77248160)
print v(xbgr.mr_n77248736)
print v(xbgr.mr_n77248848)
print v(xbgr.mr_n77249680)
print v(xbgr.mr_n77249792)
print v(xbgr.mr_n77250624)
print v(xbgr.mr_n77250736)
print v(xbgr.mr_n77251568)
print v(xbgr.mr_n77251680)
print v(xbgr.mr_n77252512)
print v(xbgr.mr_n77252624)
print v(xbgr.mr_n77253456)
print v(xbgr.mr_n77253568)
print v(xbgr.mr_n77254400)
print v(xbgr.mr_n77254512)
print v(xbgr.mr_n77255344)
print v(xbgr.mr_n77255456)
print v(xbgr.mr_n77256288)
print v(xbgr.mr_n77256400)
print v(xbgr.mr_n77257360)
print v(xbgr.mr_n77257472)
print v(xbgr.mr_n77267584)
print v(xbgr.mr_n77270976)
print v(xbgr.mr_n77271984)
print v(xbgr.mr_n77278288)
print v(xbgr.mr_n77278432)
print v(xbgr.mr_n77281808)
print v(xbgr.mr_n77282496)
print v(xbgr.mr_n77283184)
print v(xbgr.mr_n77284128)
print v(xbgr.mr_n77285584)
print v(xbgr.mr_n77286528)
print v(xbgr.mr_n77287472)
print v(xbgr.mr_n77288416)
print v(xbgr.mr_n77289360)
print v(xbgr.mr_n77290304)
print v(xbgr.mr_n77291248)
print v(xbgr.mr_n77292192)
print v(xbgr.mr_n77293136)
print v(xbgr.mr_n77294080)
print v(xbgr.mr_n77295024)
print v(xbgr.mr_n77295968)
print v(xbgr.mr_n77296912)
print v(xbgr.mr_n77297856)
print v(xbgr.mr_n77298800)
print v(xbgr.mr_n77298992)
print v(xbgr.mr_n77299184)
print v(xbgr.mr_n77299376)
print v(xbgr.mr_n77299568)
print v(xbgr.mr_n77299760)
print v(xbgr.mr_n77301904)
print v(xbgr.mr_n77302016)
print v(xbgr.mr_n77305328)
print v(xbgr.mr_n77305440)
print v(xbgr.mr_n77310320)
print v(xbgr.mr_n77312160)
print v(xbgr.mr_n77314000)
print v(xbgr.mr_n77315840)
print v(xbgr.mr_n77319792)
print v(xbgr.mr_n77333008)
print v(xbgr.mr_n77334576)
print v(xbgr.mr_n77336144)
print v(xbgr.mr_n77337712)
print v(xbgr.mr_n77339280)
print v(xbgr.mr_n77340848)
print v(xbgr.mr_n77342416)
print v(xbgr.mr_n77343984)
print v(xbgr.mr_n77345552)
print v(xbgr.mr_n77347120)
print v(xbgr.mr_n77348688)
print v(xbgr.mr_n77350256)
print v(xbgr.mr_n77351824)
print v(xbgr.mr_n77353392)
print v(xbgr.mr_n77354960)
print v(xbgr.mr_n77356528)
print v(xbgr.mr_n77359776)
print v(xbgr.mr_n77360112)
print v(xbgr.mr_n77360224)
print v(xbgr.mr_n77361056)
print v(xbgr.mr_n77361168)
print v(xbgr.mr_n77362000)
print v(xbgr.mr_n77362112)
print v(xbgr.mr_n77362944)
print v(xbgr.mr_n77363056)
print v(xbgr.mr_n77363200)
print v(xbgr.mr_n77366544)
print v(xbgr.mr_n77367056)
print v(xbgr.mr_n77367168)
print v(xbgr.mr_n77367280)
print v(xbgr.mr_n77367392)
print v(xbgr.mr_n77367504)
print v(xbgr.mr_n77368928)
print v(xbgr.mr_n77369200)
print v(xbgr.mr_n77369392)
print v(xbgr.mr_n77369904)
print v(xbgr.mr_n77372048)
print v(xbgr.mr_n77372160)
print v(xbgr.mr_n77373904)
print v(xbgr.mr_n77374176)
print v(xbgr.mr_n77374368)
print v(xbgr.mr_n77374880)
print v(xbgr.mr_n77377024)
print v(xbgr.mr_n77377136)
print v(xbgr.mr_n77378880)
print v(xbgr.mr_n77379152)
print v(xbgr.mr_n77379344)
print v(xbgr.mr_n77379856)
print v(xbgr.mr_n77382160)
print v(xbgr.mr_n77382352)
print v(xbgr.mr_n77382544)
print v(xbgr.mr_n77382736)
print v(xbgr.mr_n77382928)
print v(xbgr.mr_n77385152)
print v(xbgr.mr_n77386976)
print v(xbgr.mr_n77387088)
print v(xbgr.mr_n77387280)
print v(xbgr.mr_n77388832)
print v(xbgr.mr_n77389104)
print v(xbgr.mr_n77389296)
print v(xbgr.mr_n77389808)
print v(xbgr.mr_n77391952)
print v(xbgr.mr_n77392064)
print v(xbgr.mr_n77393808)
print v(xbgr.mr_n77394080)
print v(xbgr.mr_n77394272)
print v(xbgr.mr_n77394784)
print v(xbgr.mr_n77397088)
print v(xbgr.mr_n77397280)
print v(xbgr.mr_n77397472)
print v(xbgr.mr_n77397664)
print v(xbgr.mr_n77397856)
print v(xbgr.mr_n77400080)
print v(xbgr.mr_n77401904)
print v(xbgr.mr_n77402016)
print v(xbgr.mr_n77403760)
print v(xbgr.mr_n77404032)
print v(xbgr.mr_n77404224)
print v(xbgr.mr_n77404736)
print v(xbgr.mr_n77406544)
print v(xbgr.mr_n77406656)
print v(xbgr.mr_n77407808)
print v(xbgr.mr_n77407920)
print v(xbgr.mr_n77409072)
print v(xbgr.mr_n77409184)
print v(xbgr.mr_n77410608)
print v(xbgr.mr_n77410864)
print v(xbgr.mr_n77411680)
print v(xbgr.mr_n77412368)
print v(xbgr.mr_n77413056)
print v(xbgr.mr_n77413744)
print v(xbgr.mr_n77414432)
print v(xbgr.mr_n77415120)
print v(xbgr.mr_n77416000)
print v(xbgr.mr_n77418000)
print v(xbgr.mr_n77418944)
print v(xbgr.mr_n77419888)
print v(xbgr.mr_n77420832)
print v(xbgr.mr_n77421776)
print v(xbgr.mr_n77422720)
print v(xbgr.mr_n77423664)
print v(xbgr.mr_n77424608)
print v(xbgr.mr_n77425552)
print v(xbgr.mr_n77426496)
print v(xbgr.mr_n77427440)
print v(xbgr.mr_n77429360)
print v(xbgr.mr_n77434208)
print v(xbgr.mr_n77440688)
print v(xbgr.mr_n77440960)
print v(xbgr.mr_n77444384)
print v(xbgr.mr_n77445952)
print v(xbgr.mr_n77446992)
print v(xbgr.mr_n77447104)
print v(xbgr.mr_n77447216)
print v(xbgr.mr_n77448816)
print v(xbgr.mr_n77448928)
print v(xbgr.mr_n77453136)
print v(xbgr.mr_n77454352)
print v(xbgr.mr_n77454464)
print v(xbgr.mr_n77458208)
print v(xbgr.mr_n77459680)
print v(xbgr.mr_n77461248)
print v(xbgr.mr_n77462816)
print v(xbgr.mr_n77464384)
print v(xbgr.mr_n77470464)
print v(xbgr.mr_n77470736)
print v(xbgr.mr_n77471808)
print v(xbgr.mr_n77473040)
print v(xbgr.mr_n77473232)
print v(xbgr.mr_n77473776)
print v(xbgr.mr_n77474608)
print v(xbgr.mr_n77474720)
print v(xbgr.mr_n77476880)
print v(xbgr.mr_n77477696)
print v(xbgr.mr_n77478432)
print v(xbgr.mr_n77479552)
print v(xbgr.mr_n77480240)
print v(xbgr.mr_n77483136)
print v(xbgr.mr_n77484704)
print v(xbgr.mr_n77485648)
print v(xbgr.mr_n77492800)
print v(xbgr.mr_n77494416)
print v(xbgr.mr_n77494528)
print v(xbgr.mr_n77495680)
print v(xbgr.mr_n77495792)
print v(xbgr.mr_n77496944)
print v(xbgr.mr_n77497056)
print v(xbgr.mr_n77498208)
print v(xbgr.mr_n77498320)
print v(xbgr.mr_n77499472)
print v(xbgr.mr_n77499584)
print v(xbgr.mr_n77500736)
print v(xbgr.mr_n77500848)
print v(xbgr.mr_n77502000)
print v(xbgr.mr_n77502112)
print v(xbgr.mr_n77503200)
print v(xbgr.mr_n77503312)
print v(xbgr.mr_n77504528)
print v(xbgr.mr_n77504640)
print v(xbgr.mr_n77505792)
print v(xbgr.mr_n77505904)
print v(xbgr.mr_n77507696)
print v(xbgr.mr_n77508896)
print v(xbgr.mr_n77509664)
print v(xbgr.mr_n77512288)
print v(xbgr.mr_n77514272)
print v(xbgr.mr_n77514416)
print v(xbgr.mr_n77516896)
print v(xbgr.mr_n77524624)
print v(xbgr.mr_n77525408)
print v(xbgr.mr_n77525520)
print v(xbgr.mr_n77525712)
print v(xbgr.mr_n77525904)
print v(xbgr.mr_n77526096)
print v(xbgr.mr_n77528512)
print v(xbgr.mr_n77534352)
print v(xbgr.mr_n77535296)
print v(xbgr.mr_n77536240)
print v(xbgr.mr_n77537184)
print v(xbgr.mr_n77538128)
print v(xbgr.mr_n77539072)
print v(xbgr.mr_n77540016)
print v(xbgr.mr_n77540960)
print v(xbgr.mr_n77541904)
print v(xbgr.mr_n77542848)
print v(xbgr.mr_n77543792)
print v(xbgr.mr_n77544736)
print v(xbgr.mr_n77545808)
print v(xbgr.mr_n77546240)
print v(xbgr.mr_n77546512)
print v(xbgr.mr_n77547120)
print v(xbgr.mr_n77548224)
print v(xbgr.mr_n77550544)
print v(xbgr.mr_n77551488)
print v(xbgr.mr_n77552432)
print v(xbgr.mr_n77553376)
print v(xbgr.mr_n77554320)
print v(xbgr.mr_n77555264)
print v(xbgr.mr_n77556208)
print v(xbgr.mr_n77557152)
print v(xbgr.mr_n77558096)
print v(xbgr.mr_n77559040)
print v(xbgr.mr_n77561792)
print v(xbgr.mr_n77562800)
print v(xbgr.mr_n77563744)
print v(xbgr.mr_n77564688)
print v(xbgr.mr_n77564880)
print v(xbgr.mr_n77565072)
print v(xbgr.mr_n77565264)
print v(xbgr.mr_n77565456)
print v(xbgr.mr_n77565648)
print v(xbgr.mr_n77567792)
print v(xbgr.mr_n77567904)
print v(xbgr.mr_n77570992)
print v(xbgr.mr_n77571104)
print v(xbgr.mr_n77576752)
print v(xbgr.mr_n77577696)
print v(xbgr.mr_n77578640)
print v(xbgr.mr_n77579584)
print v(xbgr.mr_n77580528)
print v(xbgr.mr_n77581472)
print v(xbgr.mr_n77582416)
print v(xbgr.mr_n77583360)
print v(xbgr.mr_n77584304)
print v(xbgr.mr_n77585248)
print v(xbgr.mr_n77586128)
print v(xbgr.mr_n77587632)
print v(xbgr.mr_n77588208)
print v(xbgr.mr_n77588320)
print v(xbgr.mr_n77588592)
print v(xbgr.mr_n77589264)
print v(xbgr.mr_n77589456)
print v(xbgr.mr_n77589648)
print v(xbgr.mr_n77589840)
print v(xbgr.mr_n77592032)
print v(xbgr.mr_n77592304)
print v(xbgr.mr_n77593008)
print v(xbgr.mr_n77594816)
print v(xbgr.mr_n77598496)
print v(xbgr.mr_n77599328)
print v(xbgr.mr_n77599440)
print v(xbgr.mr_n77599552)
print v(xbgr.mr_n77599664)
print v(xbgr.mr_n77599856)
print v(xbgr.mr_n77600048)
print v(xbgr.mr_n77601856)
print v(xbgr.mr_n77602048)
print v(xbgr.mr_n77602560)
print v(xbgr.mr_n77604640)
print v(xbgr.mr_n77604752)
print v(xbgr.mr_n77606496)
print v(xbgr.mr_n77606768)
print v(xbgr.mr_n77606960)
print v(xbgr.mr_n77607472)
print v(xbgr.mr_n77609616)
print v(xbgr.mr_n77609728)
print v(xbgr.mr_n77611472)
print v(xbgr.mr_n77611744)
print v(xbgr.mr_n77611936)
print v(xbgr.mr_n77612448)
print v(xbgr.mr_n77614592)
print v(xbgr.mr_n77614704)
print v(xbgr.mr_n77616448)
print v(xbgr.mr_n77616720)
print v(xbgr.mr_n77616912)
print v(xbgr.mr_n77617424)
print v(xbgr.mr_n77619568)
print v(xbgr.mr_n77619680)
print v(xbgr.mr_n77621424)
print v(xbgr.mr_n77621696)
print v(xbgr.mr_n77621888)
print v(xbgr.mr_n77622400)
print v(xbgr.mr_n77624544)
print v(xbgr.mr_n77626400)
print v(xbgr.mr_n77626672)
print v(xbgr.mr_n77627376)
print v(xbgr.mr_n77629520)
print v(xbgr.mr_n77629632)
print v(xbgr.mr_n77631376)
print v(xbgr.mr_n77631648)
print v(xbgr.mr_n77631840)
print v(xbgr.mr_n77632352)
print v(xbgr.mr_n77633360)
print v(xbgr.mr_n77634064)
print v(xbgr.mr_n77642016)
print v(xbgr.mr_n77642688)
print v(xbgr.mr_n77642960)
print v(xbgr.mr_n77643920)
print v(xbgr.mr_n77644032)
print v(xbgr.mr_n77646720)
print v(xbgr.mr_n77650432)
print v(xbgr.mr_n77651120)
print v(xbgr.mr_n77651808)
print v(xbgr.mr_n77652496)
print v(xbgr.mr_n77653184)
print v(xbgr.mr_n77653872)
print v(xbgr.mr_n77654560)
print v(xbgr.mr_n77655248)
print v(xbgr.mr_n77655936)
print v(xbgr.mr_n77656624)
print v(xbgr.mr_n77657312)
print v(xbgr.mr_n77658000)
print v(xbgr.mr_n77669216)
print v(xbgr.mr_n77669584)
print v(xbgr.mr_n77671072)
print v(xbgr.mr_n77671184)
print v(xbgr.mr_n77673232)
print v(xbgr.mr_n77673344)
print v(xbgr.mr_n77674496)
print v(xbgr.mr_n77674608)
print v(xbgr.mr_n77675760)
print v(xbgr.mr_n77675872)
print v(xbgr.mr_n77677024)
print v(xbgr.mr_n77677136)
print v(xbgr.mr_n77678288)
print v(xbgr.mr_n77678400)
print v(xbgr.mr_n77679552)
print v(xbgr.mr_n77679664)
print v(xbgr.mr_n77680608)
print v(xbgr.mr_n77680720)
print v(xbgr.mr_n77680832)
print v(xbgr.mr_n77680944)
print v(xbgr.mr_n77681472)
print v(xbgr.mr_n77681584)
print v(xbgr.mr_n77682896)
print v(xbgr.mr_n77683008)
print v(xbgr.mr_n77684544)
print v(xbgr.mr_n77684656)
print v(xbgr.mr_n77686960)
print v(xbgr.mr_n77687072)
print v(xbgr.mr_n77688224)
print v(xbgr.mr_n77688336)
print v(xbgr.mr_n77689488)
print v(xbgr.mr_n77689600)
print v(xbgr.mr_n77693344)
print v(xbgr.mr_n77694464)
print v(xbgr.mr_n77695936)
print v(xbgr.mr_n77697504)
print v(xbgr.mr_n77699072)
print v(xbgr.mr_n77700640)
print v(xbgr.mr_n77702208)
print v(xbgr.mr_n77703776)
print v(xbgr.mr_n77705344)
print v(xbgr.mr_n77706912)
print v(xbgr.mr_n77708480)
print v(xbgr.mr_n77710048)
print v(xbgr.mr_n77712240)
print v(xbgr.mr_n77713808)
print v(xbgr.mr_n77715376)
print v(xbgr.mr_n77720672)
print v(xbgr.mr_n77727104)
print v(xbgr.mr_n77727344)
print v(xbgr.mr_n77728256)
print v(xbgr.mr_n77728448)
print v(xbgr.mr_n77728640)
print v(xbgr.mr_n77728832)
print v(xbgr.mr_n77729024)
print v(xbgr.mr_n77731408)
print v(xbgr.mr_n77731600)
print v(xbgr.mr_n77732112)
print v(xbgr.mr_n77736864)
print v(xbgr.mr_n77737056)
print v(xbgr.mr_n77737248)
print v(xbgr.mr_n77737840)
print v(xbgr.mr_n77740576)
print v(xbgr.mr_n77740848)
print v(xbgr.mr_n77741040)
print v(xbgr.mr_n77741552)
print v(xbgr.mr_n77743696)
print v(xbgr.mr_n77743808)
print v(xbgr.mr_n77745552)
print v(xbgr.mr_n77745824)
print v(xbgr.mr_n77746016)
print v(xbgr.mr_n77746528)
print v(xbgr.mr_n77747760)
print v(xbgr.mr_n77748272)
print v(xbgr.mr_n77753072)
print v(xbgr.mr_n77756064)
print v(xbgr.mr_n77756336)
print v(xbgr.mr_n77756528)
print v(xbgr.mr_n77757040)
print v(xbgr.mr_n77757616)
print v(xbgr.mr_n77758320)
print v(xbgr.mr_n77758912)
print v(xbgr.mr_n77760592)
print v(xbgr.mr_n77761104)
print v(xbgr.mr_n77761920)
print v(xbgr.mr_n77762224)
print v(xbgr.mr_n77764000)
print v(xbgr.mr_n77765808)
print v(xbgr.mr_n77766320)
print v(xbgr.mr_n77768320)
print v(xbgr.mr_n77768832)
print v(xbgr.mr_n77770896)
print v(xbgr.mr_n77771408)
print v(xbgr.mr_n77773472)
print v(xbgr.mr_n77773984)
print v(xbgr.mr_n77776048)
print v(xbgr.mr_n77776560)
print v(xbgr.mr_n77778688)
print v(xbgr.mr_n77779200)
print v(xbgr.mr_n77781200)
print v(xbgr.mr_n77781712)
print v(xbgr.mr_n77783696)
print v(xbgr.mr_n77784288)
print v(xbgr.mr_n77792624)
print v(xbgr.mr_n77792736)
print v(xbgr.mr_n77793888)
print v(xbgr.mr_n77794000)
print v(xbgr.mr_n77795088)
print v(xbgr.mr_n77795200)
print v(xbgr.mr_n77796416)
print v(xbgr.mr_n77796528)
print v(xbgr.mr_n77797680)
print v(xbgr.mr_n77797792)
print v(xbgr.mr_n77798944)
print v(xbgr.mr_n77799056)
print v(xbgr.mr_n77800208)
print v(xbgr.mr_n77800320)
print v(xbgr.mr_n77801472)
print v(xbgr.mr_n77801584)
print v(xbgr.mr_n77802736)
print v(xbgr.mr_n77802848)
print v(xbgr.mr_n77804000)
print v(xbgr.mr_n77804112)
print v(xbgr.mr_n77805264)
print v(xbgr.mr_n77805376)
print v(xbgr.mr_n77806528)
print v(xbgr.mr_n77806640)
print v(xbgr.mr_n77807792)
print v(xbgr.mr_n77807904)
print v(xbgr.mr_n77809056)
print v(xbgr.mr_n77809168)
print v(xbgr.mr_n77814848)
print v(xbgr.mr_n77820480)
print v(xbgr.mr_n77822624)
print v(xbgr.mr_n77824544)
print v(xbgr.mr_n77825232)
print v(xbgr.mr_n77826112)
print v(xbgr.mr_n77827792)
print v(xbgr.mr_n77828736)
print v(xbgr.mr_n77829680)
print v(xbgr.mr_n77830624)
print v(xbgr.mr_n77831568)
print v(xbgr.mr_n77832512)
print v(xbgr.mr_n77833456)
print v(xbgr.mr_n77834400)
print v(xbgr.mr_n77835344)
print v(xbgr.mr_n77836288)
print v(xbgr.mr_n77837232)
print v(xbgr.mr_n77838176)
print v(xbgr.mr_n77839120)
print v(xbgr.mr_n77840064)
print v(xbgr.mr_n77841008)
print v(xbgr.mr_n77841952)
print v(xbgr.mr_n77846944)
print v(xbgr.mr_n77848272)
print v(xbgr.mr_n77849840)
print v(xbgr.mr_n77851392)
print v(xbgr.mr_n77852384)
print v(xbgr.mr_n77853184)
print v(xbgr.mr_n77854416)
print v(xbgr.mr_n77854528)
print v(xbgr.mr_n77855472)
print v(xbgr.mr_n77856624)
print v(xbgr.mr_n77856736)
print v(xbgr.mr_n77858512)
print v(xbgr.mr_n77858624)
print v(xbgr.mr_n77859568)
print v(xbgr.mr_n77860720)
print v(xbgr.mr_n77860832)
print v(xbgr.mr_n77862608)
print v(xbgr.mr_n77862720)
print v(xbgr.mr_n77863664)
print v(xbgr.mr_n77864752)
print v(xbgr.mr_n77864864)
print v(xbgr.mr_n77866176)
print v(xbgr.mr_n77866704)
print v(xbgr.mr_n77866816)
print v(xbgr.mr_n77867760)
print v(xbgr.mr_n77868912)
print v(xbgr.mr_n77869024)
print v(xbgr.mr_n77870800)
print v(xbgr.mr_n77870912)
print v(xbgr.mr_n77871856)
print v(xbgr.mr_n77873008)
print v(xbgr.mr_n77873120)
print v(xbgr.mr_n77874896)
print v(xbgr.mr_n77875008)
print v(xbgr.mr_n77875952)
print v(xbgr.mr_n77877104)
print v(xbgr.mr_n77877216)
print v(xbgr.mr_n77878464)
print v(xbgr.mr_n77878992)
print v(xbgr.mr_n77879104)
print v(xbgr.mr_n77880048)
print v(xbgr.mr_n77881200)
print v(xbgr.mr_n77881312)
print v(xbgr.mr_n77882560)
print v(xbgr.mr_n77883088)
print v(xbgr.mr_n77883200)
print v(xbgr.mr_n77884144)
print v(xbgr.mr_n77885296)
print v(xbgr.mr_n77885408)
print v(xbgr.mr_n77887184)
print v(xbgr.mr_n77887296)
print v(xbgr.mr_n77888608)
print v(xbgr.mr_n77889728)
print v(xbgr.mr_n77891824)
print v(xbgr.mr_n77893392)
print v(xbgr.mr_n77894960)
print v(xbgr.mr_n77896528)
print v(xbgr.mr_n77898096)
print v(xbgr.mr_n77899664)
print v(xbgr.mr_n77901232)
print v(xbgr.mr_n77903792)
print v(xbgr.mr_n77904624)
print v(xbgr.mr_n77907312)
print v(xbgr.mr_n77914528)
print v(xbgr.mr_n77920160)
print v(xbgr.mr_n77921424)
print v(xbgr.mr_n77921536)
print v(xbgr.mr_n77921728)
print v(xbgr.mr_n77921920)
print v(xbgr.mr_n77924240)
print v(xbgr.mr_n77924512)
print v(xbgr.mr_n77924704)
print v(xbgr.mr_n77925216)
print v(xbgr.mr_n77926128)
print v(xbgr.mr_n77930896)
print v(xbgr.mr_n77931168)
print v(xbgr.mr_n77931360)
print v(xbgr.mr_n77931872)
print v(xbgr.mr_n77934608)
print v(xbgr.mr_n77934880)
print v(xbgr.mr_n77935072)
print v(xbgr.mr_n77935584)
print v(xbgr.mr_n77937728)
print v(xbgr.mr_n77937920)
print v(xbgr.mr_n77938112)
print v(xbgr.mr_n77939920)
print v(xbgr.mr_n77940112)
print v(xbgr.mr_n77940624)
print v(xbgr.mr_n77941792)
print v(xbgr.mr_n77942304)
print v(xbgr.mr_n77945744)
print v(xbgr.mr_n77946208)
print v(xbgr.mr_n77946720)
print v(xbgr.mr_n77950720)
print v(xbgr.mr_n77951120)
print v(xbgr.mr_n77951312)
print v(xbgr.mr_n77951824)
print v(xbgr.mr_n77952096)
print v(xbgr.mr_n77953248)
print v(xbgr.mr_n77955872)
print v(xbgr.mr_n77958064)
print v(xbgr.mr_n77958896)
print v(xbgr.mr_n77959008)
print v(xbgr.mr_n77959120)
print v(xbgr.mr_n77959232)
print v(xbgr.mr_n77959344)
print v(xbgr.mr_n77961088)
print v(xbgr.mr_n77961360)
print v(xbgr.mr_n77961552)
print v(xbgr.mr_n77962064)
print v(xbgr.mr_n77963296)
print v(xbgr.mr_n77963808)
print v(xbgr.mr_n77967248)
print v(xbgr.mr_n77967520)
print v(xbgr.mr_n77967712)
print v(xbgr.mr_n77968224)
print v(xbgr.mr_n77970368)
print v(xbgr.mr_n77970560)
print v(xbgr.mr_n77970752)
print v(xbgr.mr_n77972560)
print v(xbgr.mr_n77972752)
print v(xbgr.mr_n77973264)
print v(xbgr.mr_n77974432)
print v(xbgr.mr_n77974944)
print v(xbgr.mr_n77978384)
print v(xbgr.mr_n77978656)
print v(xbgr.mr_n77978848)
print v(xbgr.mr_n77979360)
print v(xbgr.mr_n77981504)
print v(xbgr.mr_n77981696)
print v(xbgr.mr_n77981888)
print v(xbgr.mr_n77983696)
print v(xbgr.mr_n77983888)
print v(xbgr.mr_n77984400)
print v(xbgr.mr_n77985632)
print v(xbgr.mr_n77986144)
print v(xbgr.mr_n77993136)
print v(xbgr.mr_n77993248)
print v(xbgr.mr_n77994080)
print v(xbgr.mr_n77994192)
print v(xbgr.mr_n77995024)
print v(xbgr.mr_n77995136)
print v(xbgr.mr_n77996224)
print v(xbgr.mr_n77996336)
print v(xbgr.mr_n77997488)
print v(xbgr.mr_n77997600)
print v(xbgr.mr_n77998752)
print v(xbgr.mr_n77998864)
print v(xbgr.mr_n78000016)
print v(xbgr.mr_n78000128)
print v(xbgr.mr_n78001280)
print v(xbgr.mr_n78001392)
print v(xbgr.mr_n78002544)
print v(xbgr.mr_n78002656)
print v(xbgr.mr_n78003808)
print v(xbgr.mr_n78003920)
print v(xbgr.mr_n78005072)
print v(xbgr.mr_n78005184)
print v(xbgr.mr_n78006272)
print v(xbgr.mr_n78006384)
print v(xbgr.mr_n78007600)
print v(xbgr.mr_n78007712)
print v(xbgr.mr_n78008864)
print v(xbgr.mr_n78008976)
print v(xbgr.mr_n78010128)
print v(xbgr.mr_n78010240)
print v(xbgr.mr_n78010608)
print v(xbgr.mr_n78016752)
print v(xbgr.mr_n78017440)
print v(xbgr.mr_n78018128)
print v(xbgr.mr_n78018848)
print v(xbgr.mr_n78019792)
print v(xbgr.mr_n78020736)
print v(xbgr.mr_n78021680)
print v(xbgr.mr_n78022624)
print v(xbgr.mr_n78023568)
print v(xbgr.mr_n78024512)
print v(xbgr.mr_n78025456)
print v(xbgr.mr_n78026400)
print v(xbgr.mr_n78027344)
print v(xbgr.mr_n78028288)
print v(xbgr.mr_n78029232)
print v(xbgr.mr_n78030176)
print v(xbgr.mr_n78031120)
print v(xbgr.mr_n78032064)
print v(xbgr.mr_n78033008)
print v(xbgr.mr_n78033584)
print v(xbgr.mr_n78046640)
print v(xbgr.mr_n78048544)
print v(xbgr.mr_n78050112)
print v(xbgr.mr_n78052592)
print v(xbgr.mr_n78053168)
print v(xbgr.mr_n78053824)
print v(xbgr.mr_n78053936)
print v(xbgr.mr_n78054880)
print v(xbgr.mr_n78056032)
print v(xbgr.mr_n78056144)
print v(xbgr.mr_n78057920)
print v(xbgr.mr_n78058032)
print v(xbgr.mr_n78058976)
print v(xbgr.mr_n78060128)
print v(xbgr.mr_n78060240)
print v(xbgr.mr_n78061488)
print v(xbgr.mr_n78062016)
print v(xbgr.mr_n78062128)
print v(xbgr.mr_n78063072)
print v(xbgr.mr_n78064224)
print v(xbgr.mr_n78064336)
print v(xbgr.mr_n78066112)
print v(xbgr.mr_n78066224)
print v(xbgr.mr_n78067168)
print v(xbgr.mr_n78068320)
print v(xbgr.mr_n78068432)
print v(xbgr.mr_n78070208)
print v(xbgr.mr_n78070320)
print v(xbgr.mr_n78071264)
print v(xbgr.mr_n78072416)
print v(xbgr.mr_n78072528)
print v(xbgr.mr_n78074304)
print v(xbgr.mr_n78074416)
print v(xbgr.mr_n78075360)
print v(xbgr.mr_n78076512)
print v(xbgr.mr_n78076624)
print v(xbgr.mr_n78078400)
print v(xbgr.mr_n78078512)
print v(xbgr.mr_n78079456)
print v(xbgr.mr_n78080608)
print v(xbgr.mr_n78080720)
print v(xbgr.mr_n78082496)
print v(xbgr.mr_n78082608)
print v(xbgr.mr_n78083552)
print v(xbgr.mr_n78084704)
print v(xbgr.mr_n78084816)
print v(xbgr.mr_n78086112)
print v(xbgr.mr_n78086288)
print v(xbgr.mr_n78087616)
print v(xbgr.mr_n78088736)
print v(xbgr.mr_n78090624)
print v(xbgr.mr_n78092896)
print v(xbgr.mr_n78094464)
print v(xbgr.mr_n78096032)
print v(xbgr.mr_n78102160)
print v(xbgr.mr_n78102624)
print v(xbgr.mr_n78105168)
print v(xbgr.mr_n78107664)
print v(xbgr.mr_n78112624)
print v(xbgr.mr_n78112880)
print v(xbgr.mr_n78114384)
print v(xbgr.mr_n78115840)
print v(xbgr.mr_n78116048)
print v(xbgr.mr_n78123264)
print v(xbgr.mr_n78123456)
print v(xbgr.mr_n78124144)
print v(xbgr.mr_n78124576)
print v(xbgr.mr_n78125408)
print v(xbgr.mr_n78125984)
print v(xbgr.mr_n78126672)
print v(xbgr.mr_n78127248)
print v(xbgr.mr_n78127936)
print v(xbgr.mr_n78128512)
print v(xbgr.mr_n78129200)
print v(xbgr.mr_n78129776)
print v(xbgr.mr_n78130464)
print v(xbgr.mr_n78131040)
print v(xbgr.mr_n78131728)
print v(xbgr.mr_n78132160)
print v(xbgr.mr_n78132992)
print v(xbgr.mr_n78133568)
print v(xbgr.mr_n78134256)
print v(xbgr.mr_n78134688)
print v(xbgr.mr_n78135520)
print v(xbgr.mr_n78135952)
print v(xbgr.mr_n78136784)
print v(xbgr.mr_n78137360)
print v(xbgr.mr_n78138048)
print v(xbgr.mr_n78138624)
print v(xbgr.mr_n78139312)
print v(xbgr.mr_n78139744)
print v(xbgr.mr_n78140576)
print v(xbgr.mr_n78141152)
print v(xbgr.mr_n78141840)
print v(xbgr.mr_n78142272)
print v(xbgr.mr_n78143104)
print v(xbgr.mr_n78143536)
print v(xbgr.mr_n78144368)
print v(xbgr.mr_n78147872)
print v(xbgr.mr_n78147984)
print v(xbgr.mr_n78148096)
print v(xbgr.mr_n78148288)
print v(xbgr.mr_n78148480)
print v(xbgr.mr_n78150864)
print v(xbgr.mr_n78151056)
print v(xbgr.mr_n78151568)
print v(xbgr.mr_n78152736)
print v(xbgr.mr_n78153248)
print v(xbgr.mr_n78154800)
print v(xbgr.mr_n78155312)
print v(xbgr.mr_n78157168)
print v(xbgr.mr_n78157760)
print v(xbgr.mr_n78159696)
print v(xbgr.mr_n78160208)
print v(xbgr.mr_n78161360)
print v(xbgr.mr_n78162144)
print v(xbgr.mr_n78162656)
print v(xbgr.mr_n78164592)
print v(xbgr.mr_n78165104)
print v(xbgr.mr_n78167040)
print v(xbgr.mr_n78167552)
print v(xbgr.mr_n78169488)
print v(xbgr.mr_n78170000)
print v(xbgr.mr_n78171936)
print v(xbgr.mr_n78172448)
print v(xbgr.mr_n78174448)
print v(xbgr.mr_n78174960)
print v(xbgr.mr_n78176832)
print v(xbgr.mr_n78177344)
print v(xbgr.mr_n78179280)
print v(xbgr.mr_n78179792)
print v(xbgr.mr_n78181728)
print v(xbgr.mr_n78182240)
print v(xbgr.mr_n78184176)
print v(xbgr.mr_n78184688)
print v(xbgr.mr_n78186624)
print v(xbgr.mr_n78187136)
print v(xbgr.mr_n78189072)
print v(xbgr.mr_n78189584)
print v(xbgr.mr_n78197504)
print v(xbgr.mr_n78198656)
print v(xbgr.mr_n78198768)
print v(xbgr.mr_n78199920)
print v(xbgr.mr_n78200032)
print v(xbgr.mr_n78201120)
print v(xbgr.mr_n78201232)
print v(xbgr.mr_n78202448)
print v(xbgr.mr_n78202560)
print v(xbgr.mr_n78203712)
print v(xbgr.mr_n78203824)
print v(xbgr.mr_n78204976)
print v(xbgr.mr_n78205088)
print v(xbgr.mr_n78206240)
print v(xbgr.mr_n78206352)
print v(xbgr.mr_n78207504)
print v(xbgr.mr_n78207616)
print v(xbgr.mr_n78208768)
print v(xbgr.mr_n78208880)
print v(xbgr.mr_n78210032)
print v(xbgr.mr_n78210144)
print v(xbgr.mr_n78211296)
print v(xbgr.mr_n78211408)
print v(xbgr.mr_n78212560)
print v(xbgr.mr_n78212672)
print v(xbgr.mr_n78213824)
print v(xbgr.mr_n78213936)
print v(xbgr.mr_n78215088)
print v(xbgr.mr_n78215200)
print v(xbgr.mr_n78216288)
print v(xbgr.mr_n78216400)
print v(xbgr.mr_n78217344)
print v(xbgr.mr_n78218032)
print v(xbgr.mr_n78218720)
print v(xbgr.mr_n78219440)
print v(xbgr.mr_n78220384)
print v(xbgr.mr_n78221264)
print v(xbgr.mr_n78221376)
print v(xbgr.mr_n78221488)
print v(xbgr.mr_n78222736)
print v(xbgr.mr_n78233440)
print v(xbgr.mr_n78240112)
print v(xbgr.mr_n78241776)
print v(xbgr.mr_n78244016)
print v(xbgr.mr_n78244976)
print v(xbgr.mr_n78245376)
print v(xbgr.mr_n78246784)
print v(xbgr.mr_n78249920)
print v(xbgr.mr_n78252304)
print v(xbgr.mr_n78252912)
print v(xbgr.mr_n78254144)
print v(xbgr.mr_n78254256)
print v(xbgr.mr_n78255200)
print v(xbgr.mr_n78256288)
print v(xbgr.mr_n78256400)
print v(xbgr.mr_n78258240)
print v(xbgr.mr_n78258352)
print v(xbgr.mr_n78259296)
print v(xbgr.mr_n78260448)
print v(xbgr.mr_n78260560)
print v(xbgr.mr_n78262336)
print v(xbgr.mr_n78262448)
print v(xbgr.mr_n78263392)
print v(xbgr.mr_n78264544)
print v(xbgr.mr_n78264656)
print v(xbgr.mr_n78266432)
print v(xbgr.mr_n78266544)
print v(xbgr.mr_n78267488)
print v(xbgr.mr_n78268640)
print v(xbgr.mr_n78268752)
print v(xbgr.mr_n78270528)
print v(xbgr.mr_n78270640)
print v(xbgr.mr_n78271584)
print v(xbgr.mr_n78272736)
print v(xbgr.mr_n78272848)
print v(xbgr.mr_n78274560)
print v(xbgr.mr_n78274672)
print v(xbgr.mr_n78275616)
print v(xbgr.mr_n78276832)
print v(xbgr.mr_n78276944)
print v(xbgr.mr_n78278720)
print v(xbgr.mr_n78278832)
print v(xbgr.mr_n78279776)
print v(xbgr.mr_n78280928)
print v(xbgr.mr_n78281040)
print v(xbgr.mr_n78282752)
print v(xbgr.mr_n78282864)
print v(xbgr.mr_n78283808)
print v(xbgr.mr_n78285024)
print v(xbgr.mr_n78285136)
print v(xbgr.mr_n78286912)
print v(xbgr.mr_n78287024)
print v(xbgr.mr_n78288336)
print v(xbgr.mr_n78289456)
print v(xbgr.mr_n78291552)
print v(xbgr.mr_n78293120)
print v(xbgr.mr_n78294688)
print v(xbgr.mr_n78296256)
print v(xbgr.mr_n78297824)
print v(xbgr.mr_n78299392)
print v(xbgr.mr_n78300960)
print v(xbgr.mr_n78316112)
print v(xbgr.mr_n78318704)
print v(xbgr.mr_n78320560)
print v(xbgr.mr_n78320672)
print v(xbgr.mr_n78321616)
print v(xbgr.mr_n78321808)
print v(xbgr.mr_n78322000)
print v(xbgr.mr_n78322192)
print v(xbgr.mr_n78324448)
print v(xbgr.mr_n78324720)
print v(xbgr.mr_n78324912)
print v(xbgr.mr_n78325424)
print v(xbgr.mr_n78329552)
print v(xbgr.mr_n78329664)
print v(xbgr.mr_n78331408)
print v(xbgr.mr_n78331680)
print v(xbgr.mr_n78331872)
print v(xbgr.mr_n78332384)
print v(xbgr.mr_n78334528)
print v(xbgr.mr_n78334640)
print v(xbgr.mr_n78336384)
print v(xbgr.mr_n78336656)
print v(xbgr.mr_n78336848)
print v(xbgr.mr_n78337360)
print v(xbgr.mr_n78339664)
print v(xbgr.mr_n78339856)
print v(xbgr.mr_n78340048)
print v(xbgr.mr_n78340240)
print v(xbgr.mr_n78340432)
print v(xbgr.mr_n78342656)
print v(xbgr.mr_n78344480)
print v(xbgr.mr_n78344592)
print v(xbgr.mr_n78346336)
print v(xbgr.mr_n78346608)
print v(xbgr.mr_n78346800)
print v(xbgr.mr_n78347312)
print v(xbgr.mr_n78349456)
print v(xbgr.mr_n78349568)
print v(xbgr.mr_n78351312)
print v(xbgr.mr_n78351584)
print v(xbgr.mr_n78351776)
print v(xbgr.mr_n78352288)
print v(xbgr.mr_n78354432)
print v(xbgr.mr_n78354544)
print v(xbgr.mr_n78356288)
print v(xbgr.mr_n78356592)
print v(xbgr.mr_n78356704)
print v(xbgr.mr_n78356816)
print v(xbgr.mr_n78357072)
print v(xbgr.mr_n78357216)
print v(xbgr.mr_n78359936)
print v(xbgr.mr_n78360624)
print v(xbgr.mr_n78361024)
print v(xbgr.mr_n78361136)
print v(xbgr.mr_n78361248)
print v(xbgr.mr_n78361360)
print v(xbgr.mr_n78363104)
print v(xbgr.mr_n78363376)
print v(xbgr.mr_n78363568)
print v(xbgr.mr_n78364080)
print v(xbgr.mr_n78367312)
print v(xbgr.mr_n78367424)
print v(xbgr.mr_n78369168)
print v(xbgr.mr_n78369440)
print v(xbgr.mr_n78369632)
print v(xbgr.mr_n78370144)
print v(xbgr.mr_n78372288)
print v(xbgr.mr_n78372480)
print v(xbgr.mr_n78372672)
print v(xbgr.mr_n78374480)
print v(xbgr.mr_n78374672)
print v(xbgr.mr_n78375184)
print v(xbgr.mr_n78377264)
print v(xbgr.mr_n78377456)
print v(xbgr.mr_n78377648)
print v(xbgr.mr_n78379456)
print v(xbgr.mr_n78379648)
print v(xbgr.mr_n78380160)
print v(xbgr.mr_n78382240)
print v(xbgr.mr_n78382352)
print v(xbgr.mr_n78384096)
print v(xbgr.mr_n78384368)
print v(xbgr.mr_n78384560)
print v(xbgr.mr_n78385072)
print v(xbgr.mr_n78387376)
print v(xbgr.mr_n78387568)
print v(xbgr.mr_n78387760)
print v(xbgr.mr_n78387952)
print v(xbgr.mr_n78388144)
print v(xbgr.mr_n78390368)
print v(xbgr.mr_n78392192)
print v(xbgr.mr_n78392304)
print v(xbgr.mr_n78392496)
print v(xbgr.mr_n78394048)
print v(xbgr.mr_n78394320)
print v(xbgr.mr_n78394512)
print v(xbgr.mr_n78395024)
print v(xbgr.mr_n78397168)
print v(xbgr.mr_n78397280)
print v(xbgr.mr_n78399024)
print v(xbgr.mr_n78399216)
print v(xbgr.mr_n78399408)
print v(xbgr.mr_n78400000)
print v(xbgr.mr_n78402144)
print v(xbgr.mr_n78402336)
print v(xbgr.mr_n78402528)
print v(xbgr.mr_n78404336)
print v(xbgr.mr_n78404528)
print v(xbgr.mr_n78405040)
print v(xbgr.mr_n78428320)
print v(xbgr.mr_n78433072)
print v(xbgr.mr_n78436832)
print v(xbgr.mr_n78437168)
print v(xbgr.mr_n78438368)
print v(xbgr.mr_n78439360)
print v(xbgr.mr_n78442848)
print v(xbgr.mr_n78442960)
print v(xbgr.mr_n78444112)
print v(xbgr.mr_n78444224)
print v(xbgr.mr_n78445376)
print v(xbgr.mr_n78445488)
print v(xbgr.mr_n78446640)
print v(xbgr.mr_n78446752)
print v(xbgr.mr_n78447904)
print v(xbgr.mr_n78448016)
print v(xbgr.mr_n78449168)
print v(xbgr.mr_n78449280)
print v(xbgr.mr_n78450432)
print v(xbgr.mr_n78450544)
print v(xbgr.mr_n78451696)
print v(xbgr.mr_n78451808)
print v(xbgr.mr_n78452960)
print v(xbgr.mr_n78453072)
print v(xbgr.mr_n78454160)
print v(xbgr.mr_n78454272)
print v(xbgr.mr_n78455488)
print v(xbgr.mr_n78455600)
print v(xbgr.mr_n78456688)
print v(xbgr.mr_n78456800)
print v(xbgr.mr_n78458016)
print v(xbgr.mr_n78458128)
print v(xbgr.mr_n78459280)
print v(xbgr.mr_n78459392)
print v(xbgr.mr_n78460544)
print v(xbgr.mr_n78460656)
print v(xbgr.mr_n78464480)
print v(xbgr.mr_n78468592)
print v(xbgr.mr_n78470816)
print v(xbgr.mr_n78471504)
print v(xbgr.mr_n78472192)
print v(xbgr.mr_n78472912)
print v(xbgr.mr_n78473856)
print v(xbgr.mr_n78474800)
print v(xbgr.mr_n78475744)
print v(xbgr.mr_n78476688)
print v(xbgr.mr_n78477632)
print v(xbgr.mr_n78478576)
print v(xbgr.mr_n78479520)
print v(xbgr.mr_n78480464)
print v(xbgr.mr_n78481408)
print v(xbgr.mr_n78482352)
print v(xbgr.mr_n78483296)
print v(xbgr.mr_n78484240)
print v(xbgr.mr_n78485184)
print v(xbgr.mr_n78486128)
print v(xbgr.mr_n78487072)
print v(xbgr.mr_n78488016)
print v(xbgr.mr_n78488960)
print v(xbgr.mr_n78489904)
print v(xbgr.mr_n78490848)
print v(xbgr.mr_n78491936)
print v(xbgr.mr_n78502096)
print v(xbgr.mr_n78502336)
print v(xbgr.mr_n78503552)
print v(xbgr.mr_n78503840)
print v(xbgr.mr_n78504128)
print v(xbgr.mr_n78504848)
print v(xbgr.mr_n78505264)
print v(xbgr.mr_n78505712)
print v(xbgr.mr_n78507376)
print v(xbgr.mr_n78507520)
print v(xbgr.mr_n78507760)
print v(xbgr.mr_n78508432)
print v(xbgr.mr_n78508880)
print v(xbgr.mr_n78509056)
print v(xbgr.mr_n78509488)
print v(xbgr.mr_n78510480)
print v(xbgr.mr_n78511008)
print v(xbgr.mr_n78511184)
print v(xbgr.mr_n78512240)
print v(xbgr.mr_n78512416)
print v(xbgr.mr_n78516464)
print v(xbgr.mr_n78516816)
print v(xbgr.mr_n78517584)
print v(xbgr.mr_n78518112)
print v(xbgr.mr_n78518400)
print v(xbgr.mr_n78518752)
print v(xbgr.mr_n78518992)
print v(xbgr.mr_n78519984)
print v(xbgr.mr_n78521808)
print v(xbgr.mr_n78521984)
print v(xbgr.mr_n78523152)
print v(xbgr.mr_n78523328)
print v(xbgr.mr_n78523568)
print v(xbgr.mr_n78523920)
print v(xbgr.mr_n78524912)
print v(xbgr.mr_n78525440)
print v(xbgr.mr_n78526560)
print v(xbgr.mr_n78526848)
print v(xbgr.mr_n78527088)
print v(xbgr.mr_n78531072)
print v(xbgr.mr_n78531952)
print v(xbgr.mr_n78532304)
print v(xbgr.mr_n78532480)
print v(xbgr.mr_n78532656)
print v(xbgr.mr_n78532832)
print v(xbgr.mr_n78533008)
print v(xbgr.mr_n78533184)
print v(xbgr.mr_n78533536)
print v(xbgr.mr_n78533712)
print v(xbgr.mr_n78533952)
print v(xbgr.mr_n78534672)
print v(xbgr.mr_n78535296)
print v(xbgr.mr_n78538160)
print v(xbgr.mr_n78538656)
print v(xbgr.mr_n78539744)
print v(xbgr.mr_n78540016)
print v(xbgr.mr_n78540624)
print v(xbgr.mr_n78541568)
print v(xbgr.mr_n78542512)
print v(xbgr.mr_n78543456)
print v(xbgr.mr_n78544400)
print v(xbgr.mr_n78545344)
print v(xbgr.mr_n78546288)
print v(xbgr.mr_n78547232)
print v(xbgr.mr_n78548176)
print v(xbgr.mr_n78549120)
print v(xbgr.mr_n78550064)
print v(xbgr.mr_n78551008)
print v(xbgr.mr_n78551952)
print v(xbgr.mr_n78552896)
print v(xbgr.mr_n78553840)
print v(xbgr.mr_n78554784)
print v(xbgr.mr_n78555728)
print v(xbgr.mr_n78556672)
print v(xbgr.mr_n78557616)
print v(xbgr.mr_n78558560)
print v(xbgr.mr_n78559504)
print v(xbgr.mr_n78560448)
print v(xbgr.mr_n78561392)
print v(xbgr.mr_n78562336)
print v(xbgr.mr_n78563280)
print v(xbgr.mr_n78564224)
print v(xbgr.mr_n78565168)
print v(xbgr.mr_n78566112)
print v(xbgr.mr_n78567056)
print v(xbgr.mr_n78568000)
print v(xbgr.mr_n78568944)
print v(xbgr.mr_n78569888)
print v(xbgr.mr_n78570832)
print v(xbgr.mr_n78571776)
print v(xbgr.mr_n78572720)
print v(xbgr.mr_n78573664)
print v(xbgr.mr_n78574608)
print v(xbgr.mr_n78575552)
print v(xbgr.mr_n78576496)
print v(xbgr.mr_n78577440)
print v(xbgr.mr_n78578384)
print v(xbgr.mr_n78579328)
print v(xbgr.mr_n78580272)
print v(xbgr.mr_n78581216)
print v(xbgr.mr_n78582160)
print v(xbgr.mr_n78583104)
print v(xbgr.mr_n78584048)
print v(xbgr.mr_n78584992)
print v(xbgr.mr_n78585936)
print v(xbgr.mr_n78586880)
print v(xbgr.mr_n78587824)
print v(xbgr.mr_n78588768)
print v(xbgr.mr_n78589712)
print v(xbgr.mr_n78590656)
print v(xbgr.mr_n78591600)
print v(xbgr.mr_n78592544)
print v(xbgr.mr_n78593488)
print v(xbgr.mr_n78594432)
print v(xbgr.mr_n78595376)
print v(xbgr.mr_n78596320)
print v(xbgr.mr_n78597264)
print v(xbgr.mr_n78598208)
print v(xbgr.mr_n78599152)
print v(xbgr.mr_n78600096)
print v(xbgr.mr_n78601040)
print v(xbgr.mr_n78601984)
print v(xbgr.mr_n78602928)
print v(xbgr.mr_n78603872)
print v(xbgr.mr_n78604816)
print v(xbgr.mr_n78605760)
print v(xbgr.mr_n78606704)
print v(xbgr.mr_n78607648)
print v(xbgr.mr_n78608592)
print v(xbgr.mr_n78609536)
print v(xbgr.mr_n78610480)
print v(xbgr.mr_n78611424)
print v(xbgr.mr_n78612368)
print v(xbgr.mr_n78613312)
print v(xbgr.mr_n78614256)
print v(xbgr.mr_n78615200)
print v(xbgr.mr_n78616144)
print v(xbgr.mr_n78617088)
print v(xbgr.mr_n78618032)
print v(xbgr.mr_n78618976)
print v(xbgr.mr_n78619920)
print v(xbgr.mr_n78620864)
print v(xbgr.mr_n78621808)
print v(xbgr.mr_n78622752)
print v(xbgr.mr_n78623696)
print v(xbgr.mr_n78624640)
print v(xbgr.mr_n78625584)
print v(xbgr.mr_n78626528)
print v(xbgr.mr_n78628960)
print v(xbgr.mr_n78629232)
print v(xbgr.mr_n78629424)
print v(xbgr.mr_n78630064)
print v(xbgr.mr_n78633824)
print v(xbgr.mr_n78635536)
print v(xbgr.mr_n78635648)
print v(xbgr.mr_n78637392)
print v(xbgr.mr_n78637584)
print v(xbgr.mr_n78637776)
print v(xbgr.mr_n78638368)
print v(xbgr.mr_n78641552)
print v(xbgr.mr_n78641664)
print v(xbgr.mr_n78641776)
print v(xbgr.mr_n78641888)
print v(xbgr.mr_n78643632)
print v(xbgr.mr_n78643904)
print v(xbgr.mr_n78644096)
print v(xbgr.mr_n78644608)
print v(xbgr.mr_n78645840)
print v(xbgr.mr_n78646352)
print v(xbgr.mr_n78649200)
print v(xbgr.mr_n78649312)
print v(xbgr.mr_n78649504)
print v(xbgr.mr_n78651056)
print v(xbgr.mr_n78651328)
print v(xbgr.mr_n78651520)
print v(xbgr.mr_n78652032)
print v(xbgr.mr_n78655216)
print v(xbgr.mr_n78655328)
print v(xbgr.mr_n78655440)
print v(xbgr.mr_n78655552)
print v(xbgr.mr_n78657296)
print v(xbgr.mr_n78657568)
print v(xbgr.mr_n78657760)
print v(xbgr.mr_n78658272)
print v(xbgr.mr_n78661456)
print v(xbgr.mr_n78661568)
print v(xbgr.mr_n78661680)
print v(xbgr.mr_n78661792)
print v(xbgr.mr_n78663536)
print v(xbgr.mr_n78663808)
print v(xbgr.mr_n78664000)
print v(xbgr.mr_n78664512)
print v(xbgr.mr_n78665744)
print v(xbgr.mr_n78666256)
print v(xbgr.mr_n78669104)
print v(xbgr.mr_n78669216)
print v(xbgr.mr_n78670960)
print v(xbgr.mr_n78671232)
print v(xbgr.mr_n78671424)
print v(xbgr.mr_n78671936)
print v(xbgr.mr_n78675120)
print v(xbgr.mr_n78675232)
print v(xbgr.mr_n78675344)
print v(xbgr.mr_n78675456)
print v(xbgr.mr_n78677200)
print v(xbgr.mr_n78677472)
print v(xbgr.mr_n78677664)
print v(xbgr.mr_n78678176)
print v(xbgr.mr_n78681360)
print v(xbgr.mr_n78681472)
print v(xbgr.mr_n78681584)
print v(xbgr.mr_n78681696)
print v(xbgr.mr_n78683440)
print v(xbgr.mr_n78683712)
print v(xbgr.mr_n78683904)
print v(xbgr.mr_n78684416)
print v(xbgr.mr_n78685648)
print v(xbgr.mr_n78686160)
print v(xbgr.mr_n78689008)
print v(xbgr.mr_n78689120)
print v(xbgr.mr_n78690864)
print v(xbgr.mr_n78691136)
print v(xbgr.mr_n78691328)
print v(xbgr.mr_n78691840)
print v(xbgr.mr_n78695024)
print v(xbgr.mr_n78695136)
print v(xbgr.mr_n78695248)
print v(xbgr.mr_n78695360)
print v(xbgr.mr_n78697104)
print v(xbgr.mr_n78697376)
print v(xbgr.mr_n78697568)
print v(xbgr.mr_n78698080)
print v(xbgr.mr_n78701264)
print v(xbgr.mr_n78701376)
print v(xbgr.mr_n78701488)
print v(xbgr.mr_n78701600)
print v(xbgr.mr_n78703344)
print v(xbgr.mr_n78703616)
print v(xbgr.mr_n78703808)
print v(xbgr.mr_n78704320)
print v(xbgr.mr_n78705552)
print v(xbgr.mr_n78706064)
print v(xbgr.mr_n78708912)
print v(xbgr.mr_n78709024)
print v(xbgr.mr_n78710768)
print v(xbgr.mr_n78711040)
print v(xbgr.mr_n78711232)
print v(xbgr.mr_n78711744)
print v(xbgr.mr_n78713808)
print v(xbgr.mr_n78713920)
print v(xbgr.mr_n78714432)
print v(xbgr.mr_n78714544)
print v(xbgr.mr_n78715056)
print v(xbgr.mr_n78715168)
print v(xbgr.mr_n78715936)
print v(xbgr.mr_n78716048)
print v(xbgr.mr_n78716352)
print v(xbgr.mr_n78716880)
print v(xbgr.mr_n78716992)
print v(xbgr.mr_n78718080)
print v(xbgr.mr_n78718192)
print v(xbgr.mr_n78719344)
print v(xbgr.mr_n78719456)
print v(xbgr.mr_n78720608)
print v(xbgr.mr_n78720720)
print v(xbgr.mr_n78721872)
print v(xbgr.mr_n78721984)
print v(xbgr.mr_n78723136)
print v(xbgr.mr_n78723248)
print v(xbgr.mr_n78724400)
print v(xbgr.mr_n78724512)
print v(xbgr.mr_n78725664)
print v(xbgr.mr_n78725776)
print v(xbgr.mr_n78726928)
print v(xbgr.mr_n78727040)
print v(xbgr.mr_n78728192)
print v(xbgr.mr_n78728304)
print v(xbgr.mr_n78729456)
print v(xbgr.mr_n78729568)
print v(xbgr.mr_n78730720)
print v(xbgr.mr_n78730832)
print v(xbgr.mr_n78732624)
print v(xbgr.mr_n78739200)
print v(xbgr.mr_n78753216)
print v(xbgr.mr_n78759232)
print v(xbgr.mr_n78759488)
print v(xbgr.mr_n78759744)
print v(xbgr.mr_n78760000)
print v(xbgr.mr_n78763520)
print v(xbgr.mr_n78766464)
print v(xbgr.mr_n78775216)
print v(xbgr.mr_n78775328)
print v(xbgr.mr_n78775936)
print v(xbgr.mr_n78781696)
print v(xbgr.mr_n78785648)
print v(xbgr.mr_n78786624)
print v(xbgr.mr_n78786736)
print v(xbgr.mr_n78788672)
print v(xbgr.mr_n78789216)
print v(xbgr.mr_n78796048)
print v(xbgr.mr_n78796992)
print v(xbgr.mr_n78797936)
print v(xbgr.mr_n78798880)
print v(xbgr.mr_n78799824)
print v(xbgr.mr_n78800768)
print v(xbgr.mr_n78801712)
print v(xbgr.mr_n78802656)
print v(xbgr.mr_n78803600)
print v(xbgr.mr_n78804544)
print v(xbgr.mr_n78805488)
print v(xbgr.mr_n78806432)
print v(xbgr.mr_n78807376)
print v(xbgr.mr_n78808320)
print v(xbgr.mr_n78809264)
print v(xbgr.mr_n78810208)
print v(xbgr.mr_n78811152)
print v(xbgr.mr_n78812096)
print v(xbgr.mr_n78813040)
print v(xbgr.mr_n78813984)
print v(xbgr.mr_n78814928)
print v(xbgr.mr_n78815872)
print v(xbgr.mr_n78816816)
print v(xbgr.mr_n78817760)
print v(xbgr.mr_n78818704)
print v(xbgr.mr_n78824640)
print v(xbgr.mr_n78825584)
print v(xbgr.mr_n78826528)
print v(xbgr.mr_n78827664)
print v(xbgr.mr_n78828688)
print v(xbgr.mr_n78832848)
print v(xbgr.mr_n78833040)
print v(xbgr.mr_n78833872)
print v(xbgr.mr_n78833984)
print v(xbgr.mr_n78834096)
print v(xbgr.mr_n78834208)
print v(xbgr.mr_n78834320)
print v(xbgr.mr_n78836064)
print v(xbgr.mr_n78836336)
print v(xbgr.mr_n78836528)
print v(xbgr.mr_n78837040)
print v(xbgr.mr_n78838976)
print v(xbgr.mr_n78840720)
print v(xbgr.mr_n78840992)
print v(xbgr.mr_n78841184)
print v(xbgr.mr_n78841696)
print v(xbgr.mr_n78843632)
print v(xbgr.mr_n78845376)
print v(xbgr.mr_n78845648)
print v(xbgr.mr_n78845840)
print v(xbgr.mr_n78846352)
print v(xbgr.mr_n78848528)
print v(xbgr.mr_n78848720)
print v(xbgr.mr_n78848912)
print v(xbgr.mr_n78849104)
print v(xbgr.mr_n78851328)
print v(xbgr.mr_n78852944)
print v(xbgr.mr_n78854688)
print v(xbgr.mr_n78854960)
print v(xbgr.mr_n78855152)
print v(xbgr.mr_n78855664)
print v(xbgr.mr_n78857600)
print v(xbgr.mr_n78859344)
print v(xbgr.mr_n78859616)
print v(xbgr.mr_n78859808)
print v(xbgr.mr_n78860320)
print v(xbgr.mr_n78862256)
print v(xbgr.mr_n78864000)
print v(xbgr.mr_n78864272)
print v(xbgr.mr_n78864464)
print v(xbgr.mr_n78864976)
print v(xbgr.mr_n78866912)
print v(xbgr.mr_n78868656)
print v(xbgr.mr_n78868928)
print v(xbgr.mr_n78869120)
print v(xbgr.mr_n78869632)
print v(xbgr.mr_n78871568)
print v(xbgr.mr_n78873312)
print v(xbgr.mr_n78873584)
print v(xbgr.mr_n78873776)
print v(xbgr.mr_n78874288)
print v(xbgr.mr_n78876224)
print v(xbgr.mr_n78877968)
print v(xbgr.mr_n78878240)
print v(xbgr.mr_n78878432)
print v(xbgr.mr_n78878944)
print v(xbgr.mr_n78880880)
print v(xbgr.mr_n78882624)
print v(xbgr.mr_n78882896)
print v(xbgr.mr_n78883088)
print v(xbgr.mr_n78883600)
print v(xbgr.mr_n78885536)
print v(xbgr.mr_n78887280)
print v(xbgr.mr_n78887472)
print v(xbgr.mr_n78887664)
print v(xbgr.mr_n78888256)
print v(xbgr.mr_n78890192)
print v(xbgr.mr_n78891936)
print v(xbgr.mr_n78892208)
print v(xbgr.mr_n78892400)
print v(xbgr.mr_n78892912)
print v(xbgr.mr_n78894848)
print v(xbgr.mr_n78896592)
print v(xbgr.mr_n78896864)
print v(xbgr.mr_n78897328)
print v(xbgr.mr_n78898192)
print v(xbgr.mr_n78898416)
print v(xbgr.mr_n78899520)
print v(xbgr.mr_n78900656)
print v(xbgr.mr_n78901056)
print v(xbgr.mr_n78906400)
print v(xbgr.mr_n78908512)
print v(xbgr.mr_n78914416)
print v(xbgr.mr_n78914624)
print v(xbgr.mr_n78915392)
print v(xbgr.mr_n78920960)
print v(xbgr.mr_n78921536)
print v(xbgr.mr_n78923136)
print v(xbgr.mr_n78923744)
print v(xbgr.mr_n78924640)
print v(xbgr.mr_n78925088)
print v(xbgr.mr_n78928960)
print v(xbgr.mr_n78929728)
print v(xbgr.mr_n78930144)
print v(xbgr.mr_n78931936)
print v(xbgr.mr_n78932368)
print v(xbgr.mr_n78933104)
print v(xbgr.mr_n78933536)
print v(xbgr.mr_n78935040)
print v(xbgr.mr_n78938896)
print v(xbgr.mr_n78939600)
print v(xbgr.mr_n78940768)
print v(xbgr.mr_n78942672)
print v(xbgr.mr_n78945680)
print v(xbgr.mr_n78945792)
print v(xbgr.mr_n78946192)
print v(xbgr.mr_n78947920)
print v(xbgr.mr_n78949200)
print v(xbgr.mr_n78949792)
print v(xbgr.mr_n78950304)
print v(xbgr.mr_n78950960)
print v(xbgr.mr_n78951984)
print v(xbgr.mr_n78955728)
print v(xbgr.mr_n78955872)
print v(xbgr.mr_n78959984)
print v(xbgr.mr_n78961744)
print v(xbgr.mr_n78962512)
print v(xbgr.mr_n78966416)
print v(xbgr.mr_n78966992)
print v(xbgr.mr_n78967504)
print v(xbgr.mr_n78967760)
print v(xbgr.mr_n78967984)
print v(xbgr.mr_n78969104)
print v(xbgr.mr_n78969536)
print v(xbgr.mr_n78970048)
print v(xbgr.mr_n78970160)
print v(xbgr.mr_n78970592)
print v(xbgr.mr_n78971104)
print v(xbgr.mr_n78971216)
print v(xbgr.mr_n78971648)
print v(xbgr.mr_n78972416)
print v(xbgr.mr_n78972672)
print v(xbgr.mr_n78975200)
print v(xbgr.mr_n78975808)
print v(xbgr.mr_n78976864)
print v(xbgr.mr_n78977472)
print v(xbgr.mr_n78977664)
print v(xbgr.mr_n78978064)
print v(xbgr.mr_n78978256)
print v(xbgr.mr_n78978832)
print v(xbgr.mr_n78981504)
print v(xbgr.mr_n78981936)
print v(xbgr.mr_n78986736)
print v(xbgr.mr_n78986928)
print v(xbgr.mr_n78987456)
print v(xbgr.mr_n78993104)
print v(xbgr.mr_n78993216)
print v(xbgr.mr_n78993328)
print v(xbgr.mr_n78993920)
print v(xbgr.mr_n78994256)
print v(xbgr.mr_n78995552)
print v(xbgr.mr_n78996512)
print v(xbgr.mr_n78997776)
print v(xbgr.mr_n78997968)
print v(xbgr.mr_n78998368)
print v(xbgr.mr_n78998832)
print v(xbgr.mr_n78999024)
print v(xbgr.mr_n78999488)
print v(xbgr.mr_n78999952)
print v(xbgr.mr_n79000416)
print v(xbgr.mr_n79000608)
print v(xbgr.mr_n79001280)
print v(xbgr.mr_n79001456)
print v(xbgr.mr_n79001936)
print v(xbgr.mr_n79002736)
print v(xbgr.mr_n79002928)
print v(xbgr.mr_n79003120)
print v(xbgr.mr_n79004064)
print v(xbgr.mr_n79004400)
print v(xbgr.mr_n79004864)
print v(xbgr.mr_n79005808)
print v(xbgr.mr_n79006144)
print v(xbgr.mr_n79006608)
print v(xbgr.mr_n79009120)
print v(xbgr.mr_n79009312)
print v(xbgr.mr_n79009584)
print v(xbgr.mr_n79010688)
print v(xbgr.mr_n79014304)
print v(xbgr.mr_n79017488)
print v(xbgr.mr_n79018368)
print v(xbgr.mr_n79019056)
print v(xbgr.mr_n79019744)
print v(xbgr.mr_n79020432)
print v(xbgr.mr_n79021120)
print v(xbgr.mr_n79021808)
print v(xbgr.mr_n79022496)
print v(xbgr.mr_n79023184)
print v(xbgr.mr_n79023872)
print v(xbgr.mr_n79024560)
print v(xbgr.mr_n79025248)
print v(xbgr.mr_n79025936)
print v(xbgr.mr_n79026624)
print v(xbgr.mr_n79027312)
print v(xbgr.mr_n79028000)
print v(xbgr.mr_n79028688)
print v(xbgr.mr_n79029376)
print v(xbgr.mr_n79030064)
print v(xbgr.mr_n79030752)
print v(xbgr.mr_n79031440)
print v(xbgr.mr_n79032128)
print v(xbgr.mr_n79033264)
print v(xbgr.mr_n79033776)
print v(xbgr.mr_n79033888)
print v(xbgr.mr_n79034400)
print v(xbgr.mr_n79034512)
print v(xbgr.mr_n79035024)
print v(xbgr.mr_n79035136)
print v(xbgr.mr_n79035648)
print v(xbgr.mr_n79035760)
print v(xbgr.mr_n79036272)
print v(xbgr.mr_n79036384)
print v(xbgr.mr_n79037024)
print v(xbgr.mr_n79037136)
print v(xbgr.mr_n79038960)
print v(xbgr.mr_n79039072)
print v(xbgr.mr_n79039904)
print v(xbgr.mr_n79040016)
print v(xbgr.mr_n79040848)
print v(xbgr.mr_n79040960)
print v(xbgr.mr_n79041792)
print v(xbgr.mr_n79041904)
print v(xbgr.mr_n79042736)
print v(xbgr.mr_n79042848)
print v(xbgr.mr_n79043680)
print v(xbgr.mr_n79043792)
print v(xbgr.mr_n79044752)
print v(xbgr.mr_n79044864)
print v(xbgr.mr_n79046016)
print v(xbgr.mr_n79046128)
print v(xbgr.mr_n79047280)
print v(xbgr.mr_n79047392)
print v(xbgr.mr_n79047952)
print v(xbgr.mr_n79048096)
print v(xbgr.mr_n79056720)
print v(xbgr.mr_n79066000)
print v(xbgr.mr_n79066192)
print v(xbgr.mr_n79066384)
print v(xbgr.mr_n79066576)
print v(xbgr.mr_n79068896)
print v(xbgr.mr_n79069168)
print v(xbgr.mr_n79069360)
print v(xbgr.mr_n79069872)
print v(xbgr.mr_n79069984)
print v(xbgr.mr_n79070096)
print v(xbgr.mr_n79070208)
print v(xbgr.mr_n79070400)
print v(xbgr.mr_n79070592)
print v(xbgr.mr_n79070784)
print v(xbgr.mr_n79074352)
print v(xbgr.mr_n79087808)
print v(xbgr.mr_n79093904)
print v(xbgr.mr_n79095520)
print v(xbgr.mr_n79097200)
print v(xbgr.mr_n79099456)
print v(xbgr.mr_n79101712)
print v(xbgr.mr_n79103968)
print v(xbgr.mr_n79106224)
print v(xbgr.mr_n79112304)
print v(xbgr.mr_n79127520)
print v(xbgr.mr_n79127952)
print v(xbgr.mr_n79128784)
print v(xbgr.mr_n79129360)
print v(xbgr.mr_n79130048)
print v(xbgr.mr_n79130624)
print v(xbgr.mr_n79131312)
print v(xbgr.mr_n79131744)
print v(xbgr.mr_n79132576)
print v(xbgr.mr_n79133008)
print v(xbgr.mr_n79133840)
print v(xbgr.mr_n79134272)
print v(xbgr.mr_n79135104)
print v(xbgr.mr_n79135808)
print v(xbgr.mr_n79136368)
print v(xbgr.mr_n79158448)
print v(xbgr.mr_n79160224)
print v(xbgr.mr_n79162848)
print v(xbgr.mr_n79168992)
print v(xbgr.mr_n79169568)
print v(xbgr.mr_n79169984)
print v(xbgr.mr_n79170864)
print v(xbgr.mr_n79170976)
print v(xbgr.mr_n79171088)
print v(xbgr.mr_n79171200)
print v(xbgr.mr_n79171312)
print v(xbgr.mr_n79171424)
print v(xbgr.mr_n79171536)
print v(xbgr.mr_n79171648)
print v(xbgr.mr_n79171760)
print v(xbgr.mr_n79172112)
print v(xbgr.mr_n79172224)
print v(xbgr.mr_n79172496)
print v(xbgr.mr_n79172768)
print v(xbgr.mr_n79173712)
print v(xbgr.mr_n79175200)
print v(xbgr.mr_n79175472)
print v(xbgr.mr_n79175872)
print v(xbgr.mr_n79176272)
print v(xbgr.mr_n79176464)
print v(xbgr.mr_n79176864)
print v(xbgr.mr_n79177200)
print v(xbgr.mr_n79177392)
print v(xbgr.mr_n79178208)
print v(xbgr.mr_n79178688)
print v(xbgr.mr_n79181392)
print v(xbgr.mr_n79181504)
print v(xbgr.mr_n79182016)
print v(xbgr.mr_n79182128)
print v(xbgr.mr_n79182640)
print v(xbgr.mr_n79182752)
print v(xbgr.mr_n79183264)
print v(xbgr.mr_n79183376)
print v(xbgr.mr_n79183888)
print v(xbgr.mr_n79184000)
print v(xbgr.mr_n79184512)
print v(xbgr.mr_n79184624)
print v(xbgr.mr_n79185136)
print v(xbgr.mr_n79185248)
print v(xbgr.mr_n79185760)
print v(xbgr.mr_n79185872)
print v(xbgr.mr_n79199424)
print v(xbgr.mr_n79200112)
print v(xbgr.mr_n79200800)
print v(xbgr.mr_n79201488)
print v(xbgr.mr_n79202176)
print v(xbgr.mr_n79202864)
print v(xbgr.mr_n79203552)
print v(xbgr.mr_n79204240)
print v(xbgr.mr_n79204928)
print v(xbgr.mr_n79206000)
print v(xbgr.mr_n79207744)
print v(xbgr.mr_n79208688)
print v(xbgr.mr_n79209632)
print v(xbgr.mr_n79210576)
print v(xbgr.mr_n79211520)
print v(xbgr.mr_n79212464)
print v(xbgr.mr_n79213408)
print v(xbgr.mr_n79213744)
print v(xbgr.mr_n79214352)
print v(xbgr.mr_n79222128)
print v(xbgr.mr_n79223584)
print v(xbgr.mr_n79223968)
print v(xbgr.mr_n79224352)
print v(xbgr.mr_n79226272)
print v(xbgr.mr_n79226656)
print v(xbgr.mr_n79227040)
print v(xbgr.mr_n79228192)
print v(xbgr.mr_n79228960)
print v(xbgr.mr_n79229344)
print v(xbgr.mr_n79230496)
print v(xbgr.mr_n79230880)
print v(xbgr.mr_n79231648)
print v(xbgr.mr_n79233472)
print v(xbgr.mr_n79234512)
print v(xbgr.mr_n79236288)
print v(xbgr.mr_n79239040)
print v(xbgr.mr_n79240480)
print v(xbgr.mr_n79243392)
print v(xbgr.mr_n79243616)
print v(xbgr.mr_n79245552)
print v(xbgr.mr_n79245664)
print v(xbgr.mr_n79245856)
print v(xbgr.mr_n79246976)
print v(xbgr.mr_n79247424)
print v(xbgr.mr_n79254944)
print v(xbgr.mr_n79258400)
print v(xbgr.mr_n79260048)
print v(xbgr.mr_n79260784)
print v(xbgr.mr_n79261328)
print v(xbgr.mr_n79262832)
print v(xbgr.mr_n79263424)
print v(xbgr.mr_n79267536)
print v(xbgr.mr_n79269008)
print v(xbgr.mr_n79270960)
print v(xbgr.mr_n79271072)
print v(xbgr.mr_n79271504)
print v(xbgr.mr_n79272016)
print v(xbgr.mr_n79272128)
print v(xbgr.mr_n79272560)
print v(xbgr.mr_n79273072)
print v(xbgr.mr_n79273184)
print v(xbgr.mr_n79273616)
print v(xbgr.mr_n79276048)
print v(xbgr.mr_n79276416)
print v(xbgr.mr_n79276912)
print v(xbgr.mr_n79278592)
print v(xbgr.mr_n79280144)
print v(xbgr.mr_n79281824)
print v(xbgr.mr_n79282128)
print v(xbgr.mr_n79283824)
print v(xbgr.mr_n79284512)
print v(xbgr.mr_n79284800)
print v(xbgr.mr_n79288576)
print v(xbgr.mr_n79288832)
print v(xbgr.mr_n79293472)
print v(xbgr.mr_n79295600)
print v(xbgr.mr_n79298656)
print v(xbgr.mr_n79300320)
print v(xbgr.mr_n79300976)
print v(xbgr.mr_n79301488)
print v(xbgr.mr_n79303840)
print v(xbgr.mr_n79305424)
print v(xbgr.mr_n79308624)
print v(xbgr.mr_n79309408)
print v(xbgr.mr_n79310368)
print v(xbgr.mr_n79311904)
print v(xbgr.mr_n79312208)
print v(xbgr.mr_n79312416)
print v(xbgr.mr_n79313184)
print v(xbgr.mr_n79313856)
print v(xbgr.mr_n79314288)
print v(xbgr.mr_n79318208)
print v(xbgr.mr_n79319008)
print v(xbgr.mr_n79319456)
print v(xbgr.mr_n79319648)
print v(xbgr.mr_n79320864)
print v(xbgr.mr_n79321616)
print v(xbgr.mr_n79321808)
print v(xbgr.mr_n79322144)
print v(xbgr.mr_n79322336)
print v(xbgr.mr_n79323136)
print v(xbgr.mr_n79323328)
print v(xbgr.mr_n79323520)
print v(xbgr.mr_n79324400)
print v(xbgr.mr_n79324736)
print v(xbgr.mr_n79325200)
print v(xbgr.mr_n79325664)
print v(xbgr.mr_n79325856)
print v(xbgr.mr_n79326928)
print v(xbgr.mr_n79327376)
print v(xbgr.mr_n79327488)
print v(xbgr.mr_n79327680)
print v(xbgr.mr_n79328080)
print v(xbgr.mr_n79328544)
print v(xbgr.mr_n79329008)
print v(xbgr.mr_n79329472)
print v(xbgr.mr_n79329936)
print v(xbgr.mr_n79330608)
print v(xbgr.mr_n79331552)
print v(xbgr.mr_n79331888)
print v(xbgr.mr_n79332080)
print v(xbgr.mr_n79332544)
print v(xbgr.mr_n79333008)
print v(xbgr.mr_n79333952)
print v(xbgr.mr_n79334288)
print v(xbgr.mr_n79334752)
print v(xbgr.mr_n79335936)
print v(xbgr.mr_n79344288)
print v(xbgr.mr_n79344672)
print v(xbgr.mr_n79345440)
print v(xbgr.mr_n79345936)
print v(xbgr.mr_n79346128)
print v(xbgr.mr_n79346528)
print v(xbgr.mr_n79347728)
print v(xbgr.mr_n79349920)
print v(xbgr.mr_n79350960)
print v(xbgr.mr_n79355776)
print v(xbgr.mr_n79355888)
print v(xbgr.mr_n79356320)
print v(xbgr.mr_n79356832)
print v(xbgr.mr_n79356944)
print v(xbgr.mr_n79357376)
print v(xbgr.mr_n79357888)
print v(xbgr.mr_n79358000)
print v(xbgr.mr_n79358432)
print v(xbgr.mr_n79358944)
print v(xbgr.mr_n79359056)
print v(xbgr.mr_n79359488)
print v(xbgr.mr_n79360000)
print v(xbgr.mr_n79360112)
print v(xbgr.mr_n79360544)
print v(xbgr.mr_n79361056)
print v(xbgr.mr_n79361168)
print v(xbgr.mr_n79361600)
print v(xbgr.mr_n79362112)
print v(xbgr.mr_n79362224)
print v(xbgr.mr_n79362656)
print v(xbgr.mr_n79363168)
print v(xbgr.mr_n79363280)
print v(xbgr.mr_n79363712)
print v(xbgr.mr_n79364224)
print v(xbgr.mr_n79364336)
print v(xbgr.mr_n79364768)
print v(xbgr.mr_n79365728)
print v(xbgr.mr_n79365840)
print v(xbgr.mr_n79366720)
print v(xbgr.mr_n79367408)
print v(xbgr.mr_n79368096)
print v(xbgr.mr_n79368784)
print v(xbgr.mr_n79369472)
print v(xbgr.mr_n79370160)
print v(xbgr.mr_n79370848)
print v(xbgr.mr_n79371536)
print v(xbgr.mr_n79372224)
print v(xbgr.mr_n79372912)
print v(xbgr.mr_n79373600)
print v(xbgr.mr_n79374288)
print v(xbgr.mr_n79374976)
print v(xbgr.mr_n79375664)
print v(xbgr.mr_n79376352)
print v(xbgr.mr_n79377040)
print v(xbgr.mr_n79377728)
print v(xbgr.mr_n79378416)
print v(xbgr.mr_n79379104)
print v(xbgr.mr_n79379792)
print v(xbgr.mr_n79380480)
print v(xbgr.mr_n79381776)
print v(xbgr.mr_n79382880)
print v(xbgr.mr_n79383824)
print v(xbgr.mr_n79384768)
print v(xbgr.mr_n79385712)
print v(xbgr.mr_n79386656)
print v(xbgr.mr_n79387600)
print v(xbgr.mr_n79388544)
print v(xbgr.mr_n79389488)
print v(xbgr.mr_n79390432)
print v(xbgr.mr_n79391376)
print v(xbgr.mr_n79392320)
print v(xbgr.mr_n79393264)
print v(xbgr.mr_n79394208)
print v(xbgr.mr_n79395152)
print v(xbgr.mr_n79396096)
print v(xbgr.mr_n79397040)
print v(xbgr.mr_n79397984)
print v(xbgr.mr_n79398928)
print v(xbgr.mr_n79399872)
print v(xbgr.mr_n79400816)
print v(xbgr.mr_n79401760)
print v(xbgr.mr_n79402704)
print v(xbgr.mr_n79403648)
print v(xbgr.mr_n79404592)
print v(xbgr.mr_n79409392)
print v(xbgr.mr_n79409648)
print v(xbgr.mr_n79409904)
print v(xbgr.mr_n79410160)
print v(xbgr.mr_n79410416)
print v(xbgr.mr_n79410672)
print v(xbgr.mr_n79413472)
print v(xbgr.mr_n79413920)
print v(xbgr.mr_n79414112)
print v(xbgr.mr_n79414304)
print v(xbgr.mr_n79414496)
print v(xbgr.mr_n79414688)
print v(xbgr.mr_n79414880)
print v(xbgr.mr_n79415136)
print v(xbgr.mr_n79420144)
print v(xbgr.mr_n79437168)
print v(xbgr.mr_n79437360)
print v(xbgr.mr_n79438480)
print v(xbgr.mr_n79441456)
print v(xbgr.mr_n79441776)
print v(xbgr.mr_n79442224)
print v(xbgr.mr_n79442736)
print v(xbgr.mr_n79442992)
print v(xbgr.mr_n79443248)
print v(xbgr.mr_n79450336)
print v(xbgr.mr_n79450528)
print v(xbgr.mr_n79459056)
print v(xbgr.mr_n79461040)
print v(xbgr.mr_n79739760)
print v(xbgr.mr_n79740240)
print v(xbgr.mr_n79754560)
print v(xbgr.mr_n79842672)
print v(xbgr.mr_n79843856)
print v(xbgr.mr_n79859744)
print v(xbgr.mr_n79859936)
print v(xbgr.mr_n79883520)
print v(xbgr.mr_n79887936)
print v(xbgr.mr_n79888480)
print v(xbgr.mr_n79974496)
print v(xbgr.mr_n79994784)
print v(xbgr.mr_n79995360)
print v(xbgr.mr_n79995760)
print v(xbgr.mr_n80007168)
print v(xbgr.mr_n80007280)
print v(xbgr.mr_n80007600)
print v(xbgr.mr_n80022416)
print v(xbgr.mr_n80022704)
print v(xbgr.mr_n80055712)
print v(xbgr.mr_n80075728)
print v(xbgr.mr_n80076368)
print v(xbgr.mr_n80076672)
print v(xbgr.mr_n80138144)
print v(xbgr.mr_n80138368)
print v(xbgr.mr_n80177296)
print v(xbgr.mr_n80204352)
print v(xbgr.mr_n80227344)
print v(xbgr.mr_n80235744)
print v(xbgr.mr_n80236016)
print v(xbgr.mr_n80236720)
print v(xbgr.mr_n80249776)
print v(xbgr.mr_n80250416)
print v(xbgr.mr_n80271104)
print v(xbgr.mr_n80271296)
print v(xbgr.mr_n80272800)
print v(xbgr.mr_n80279456)
print v(xbgr.mr_n80297904)
print v(xbgr.mr_n80299520)
print v(xbgr.mr_n80341808)
print v(xbgr.mr_n80342256)
print v(xbgr.mr_n80342896)
print v(xbgr.mr_n80343120)
print v(xbgr.mr_n80350256)
print v(xbgr.mr_n80378016)
print v(xbgr.mr_n80385936)
print v(xbgr.mr_n80387392)
print v(xbgr.mr_n80417520)
print v(xbgr.mr_n80451104)
print v(xbgr.mr_n80466944)
print v(xbgr.mr_n80474608)
print v(xbgr.mr_n80478112)
print v(xbgr.mr_n80513200)
print v(xbgr.mr_n80513712)
print v(xbgr.mr_n80513968)
print v(xbgr.mr_n80520144)
print v(xbgr.mr_n80526416)
print v(xbgr.mr_n80526608)
print v(xbgr.mr_n80526800)
print v(xbgr.mr_n80526992)
print v(xbgr.mr_n80527184)
print v(xbgr.mr_n80557840)
print v(xbgr.mr_n80558736)
print v(xbgr.mr_n80558976)
print v(xbgr.n1)
print v(xbgr.n_10)
print v(xbgr.n_11)
print v(xbgr.n_12)
print v(xbgr.n_13)
print v(xbgr.n_14)
print v(xbgr.n_15)
print v(xbgr.n_16)
print v(xbgr.n_17)
print v(xbgr.n_18)
print v(xbgr.n_19)
print v(xbgr.n_2)
print v(xbgr.n_21)
print v(xbgr.n_22)
print v(xbgr.n_23)
print v(xbgr.n_24)
print v(xbgr.n_25)
print v(xbgr.n_26)
print v(xbgr.n_27)
print v(xbgr.n_3)
print v(xbgr.n_30)
print v(xbgr.n_31)
print v(xbgr.n_33)
print v(xbgr.n_34)
print v(xbgr.n_36)
print v(xbgr.n_37)
print v(xbgr.n_4)
print v(xbgr.n_5)
print v(xbgr.n_6)
print v(xbgr.n_7)
print v(xbgr.n_8)
print v(xbgr.n_9)
print v(pbias)
print v(pcasc)
print v(r4)
print v(xbgr.r4n)
print v(xbgr.vb2)
print v(vbe)
print v(xbgr.vbe3)
print v(xbgr.vd1)
print v(xbgr.vd2)
print v(vdd)
print v(vref)
print v(vdd)-v(vdd)
echo METALLIC_ALL_NODE_VOLTAGES_END
quit
.endc
.end
