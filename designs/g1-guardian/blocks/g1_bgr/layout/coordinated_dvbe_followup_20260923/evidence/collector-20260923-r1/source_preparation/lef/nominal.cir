* G1_BGR standalone capacitance-PEX qualification
.lib /foss/pdks/ihp-sg13g2/libs.tech/ngspice/models/cornerHBT.lib hbt_typ
.lib /foss/pdks/ihp-sg13g2/libs.tech/ngspice/models/cornerMOShv.lib mos_tt
.lib /foss/pdks/ihp-sg13g2/libs.tech/ngspice/models/cornerRES.lib res_typ
.include conditional_metal.spice
.option seed=44001 gmin=1e-15 abstol=1e-14 reltol=1e-5 vntol=1e-7
.global sub!
Vsub sub! 0 0
Vdd vdd 0 3.3
Vr4 r4 0 0
Xbgr vdd 0 r4 vref iptat pbias pcasc vbe dvbe g1_bgr
Vload iptat 0 1
Cload vref 0 1e-12
.control
set num_threads=1
set numdgt=15
set wr_singlescale
set wr_vecnames
op
echo RAW_CURRENT_LEDGER_BEGIN
print @n.xbgr.xr1.nr1[ibody]
print @n.xbgr.xr2.nr1[ibody]
print @n.xbgr.xr3.nr1[ibody]
print @n.xbgr.xr4.nr1[ibody]
print @n.xbgr.xr5.nr1[ibody]
print @n.xbgr.xr6.nr1[ibody]
print @n.xbgr.xr7.nr1[ibody]
print @n.xbgr.xr8.nr1[ibody]
print @n.xbgr.xr9.nr1[ibody]
print @n.xbgr.xr10.nr1[ibody]
print @n.xbgr.xr11.nr1[ibody]
print @n.xbgr.xr12.nr1[ibody]
print @n.xbgr.xr13.nr1[ibody]
print @n.xbgr.xr14.nr1[ibody]
print @n.xbgr.xr15.nr1[ibody]
print @n.xbgr.xr16.nr1[ibody]
print @n.xbgr.xr17.nr1[ibody]
print @n.xbgr.xr18.nr1[ibody]
print @n.xbgr.xr19.nr1[ibody]
print @n.xbgr.xr20.nr1[ibody]
print @n.xbgr.xr21.nr1[ibody]
print @n.xbgr.xr22.nr1[ibody]
print @n.xbgr.xr23.nr1[ibody]
print @n.xbgr.xr24.nr1[ibody]
print @n.xbgr.xr25.nr1[ibody]
print @n.xbgr.xr26.nr1[ibody]
print @n.xbgr.xm27.nsg13_hv_pmos[ide]
print @n.xbgr.xm27.nsg13_hv_pmos[ige]
print @n.xbgr.xm27.nsg13_hv_pmos[ise]
print @n.xbgr.xm27.nsg13_hv_pmos[ibe]
print @n.xbgr.xm27.nsg13_hv_pmos[ctype]
print @n.xbgr.xm28.nsg13_hv_pmos[ide]
print @n.xbgr.xm28.nsg13_hv_pmos[ige]
print @n.xbgr.xm28.nsg13_hv_pmos[ise]
print @n.xbgr.xm28.nsg13_hv_pmos[ibe]
print @n.xbgr.xm28.nsg13_hv_pmos[ctype]
print @n.xbgr.xm29.nsg13_hv_nmos[ide]
print @n.xbgr.xm29.nsg13_hv_nmos[ige]
print @n.xbgr.xm29.nsg13_hv_nmos[ise]
print @n.xbgr.xm29.nsg13_hv_nmos[ibe]
print @n.xbgr.xm29.nsg13_hv_nmos[ctype]
print @n.xbgr.xm30.nsg13_hv_nmos[ide]
print @n.xbgr.xm30.nsg13_hv_nmos[ige]
print @n.xbgr.xm30.nsg13_hv_nmos[ise]
print @n.xbgr.xm30.nsg13_hv_nmos[ibe]
print @n.xbgr.xm30.nsg13_hv_nmos[ctype]
print @n.xbgr.xm31.nsg13_hv_nmos[ide]
print @n.xbgr.xm31.nsg13_hv_nmos[ige]
print @n.xbgr.xm31.nsg13_hv_nmos[ise]
print @n.xbgr.xm31.nsg13_hv_nmos[ibe]
print @n.xbgr.xm31.nsg13_hv_nmos[ctype]
print @n.xbgr.xm32.nsg13_hv_nmos[ide]
print @n.xbgr.xm32.nsg13_hv_nmos[ige]
print @n.xbgr.xm32.nsg13_hv_nmos[ise]
print @n.xbgr.xm32.nsg13_hv_nmos[ibe]
print @n.xbgr.xm32.nsg13_hv_nmos[ctype]
print @n.xbgr.xm33.nsg13_hv_nmos[ide]
print @n.xbgr.xm33.nsg13_hv_nmos[ige]
print @n.xbgr.xm33.nsg13_hv_nmos[ise]
print @n.xbgr.xm33.nsg13_hv_nmos[ibe]
print @n.xbgr.xm33.nsg13_hv_nmos[ctype]
print @n.xbgr.xm34.nsg13_hv_nmos[ide]
print @n.xbgr.xm34.nsg13_hv_nmos[ige]
print @n.xbgr.xm34.nsg13_hv_nmos[ise]
print @n.xbgr.xm34.nsg13_hv_nmos[ibe]
print @n.xbgr.xm34.nsg13_hv_nmos[ctype]
print @n.xbgr.xm35.nsg13_hv_nmos[ide]
print @n.xbgr.xm35.nsg13_hv_nmos[ige]
print @n.xbgr.xm35.nsg13_hv_nmos[ise]
print @n.xbgr.xm35.nsg13_hv_nmos[ibe]
print @n.xbgr.xm35.nsg13_hv_nmos[ctype]
print @n.xbgr.xm36.nsg13_hv_nmos[ide]
print @n.xbgr.xm36.nsg13_hv_nmos[ige]
print @n.xbgr.xm36.nsg13_hv_nmos[ise]
print @n.xbgr.xm36.nsg13_hv_nmos[ibe]
print @n.xbgr.xm36.nsg13_hv_nmos[ctype]
print @n.xbgr.xm37.nsg13_hv_nmos[ide]
print @n.xbgr.xm37.nsg13_hv_nmos[ige]
print @n.xbgr.xm37.nsg13_hv_nmos[ise]
print @n.xbgr.xm37.nsg13_hv_nmos[ibe]
print @n.xbgr.xm37.nsg13_hv_nmos[ctype]
print @n.xbgr.xm38.nsg13_hv_pmos[ide]
print @n.xbgr.xm38.nsg13_hv_pmos[ige]
print @n.xbgr.xm38.nsg13_hv_pmos[ise]
print @n.xbgr.xm38.nsg13_hv_pmos[ibe]
print @n.xbgr.xm38.nsg13_hv_pmos[ctype]
print @n.xbgr.xm39.nsg13_hv_pmos[ide]
print @n.xbgr.xm39.nsg13_hv_pmos[ige]
print @n.xbgr.xm39.nsg13_hv_pmos[ise]
print @n.xbgr.xm39.nsg13_hv_pmos[ibe]
print @n.xbgr.xm39.nsg13_hv_pmos[ctype]
print @n.xbgr.xm40.nsg13_hv_pmos[ide]
print @n.xbgr.xm40.nsg13_hv_pmos[ige]
print @n.xbgr.xm40.nsg13_hv_pmos[ise]
print @n.xbgr.xm40.nsg13_hv_pmos[ibe]
print @n.xbgr.xm40.nsg13_hv_pmos[ctype]
print @n.xbgr.xm41.nsg13_hv_pmos[ide]
print @n.xbgr.xm41.nsg13_hv_pmos[ige]
print @n.xbgr.xm41.nsg13_hv_pmos[ise]
print @n.xbgr.xm41.nsg13_hv_pmos[ibe]
print @n.xbgr.xm41.nsg13_hv_pmos[ctype]
print @n.xbgr.xm42.nsg13_hv_pmos[ide]
print @n.xbgr.xm42.nsg13_hv_pmos[ige]
print @n.xbgr.xm42.nsg13_hv_pmos[ise]
print @n.xbgr.xm42.nsg13_hv_pmos[ibe]
print @n.xbgr.xm42.nsg13_hv_pmos[ctype]
print @n.xbgr.xm43.nsg13_hv_pmos[ide]
print @n.xbgr.xm43.nsg13_hv_pmos[ige]
print @n.xbgr.xm43.nsg13_hv_pmos[ise]
print @n.xbgr.xm43.nsg13_hv_pmos[ibe]
print @n.xbgr.xm43.nsg13_hv_pmos[ctype]
print @n.xbgr.xm44.nsg13_hv_pmos[ide]
print @n.xbgr.xm44.nsg13_hv_pmos[ige]
print @n.xbgr.xm44.nsg13_hv_pmos[ise]
print @n.xbgr.xm44.nsg13_hv_pmos[ibe]
print @n.xbgr.xm44.nsg13_hv_pmos[ctype]
print @n.xbgr.xm45.nsg13_hv_pmos[ide]
print @n.xbgr.xm45.nsg13_hv_pmos[ige]
print @n.xbgr.xm45.nsg13_hv_pmos[ise]
print @n.xbgr.xm45.nsg13_hv_pmos[ibe]
print @n.xbgr.xm45.nsg13_hv_pmos[ctype]
print @n.xbgr.xm46.nsg13_hv_pmos[ide]
print @n.xbgr.xm46.nsg13_hv_pmos[ige]
print @n.xbgr.xm46.nsg13_hv_pmos[ise]
print @n.xbgr.xm46.nsg13_hv_pmos[ibe]
print @n.xbgr.xm46.nsg13_hv_pmos[ctype]
print @n.xbgr.xm47.nsg13_hv_pmos[ide]
print @n.xbgr.xm47.nsg13_hv_pmos[ige]
print @n.xbgr.xm47.nsg13_hv_pmos[ise]
print @n.xbgr.xm47.nsg13_hv_pmos[ibe]
print @n.xbgr.xm47.nsg13_hv_pmos[ctype]
print @n.xbgr.xm48.nsg13_hv_pmos[ide]
print @n.xbgr.xm48.nsg13_hv_pmos[ige]
print @n.xbgr.xm48.nsg13_hv_pmos[ise]
print @n.xbgr.xm48.nsg13_hv_pmos[ibe]
print @n.xbgr.xm48.nsg13_hv_pmos[ctype]
print @n.xbgr.xm49.nsg13_hv_pmos[ide]
print @n.xbgr.xm49.nsg13_hv_pmos[ige]
print @n.xbgr.xm49.nsg13_hv_pmos[ise]
print @n.xbgr.xm49.nsg13_hv_pmos[ibe]
print @n.xbgr.xm49.nsg13_hv_pmos[ctype]
print @n.xbgr.xm50.nsg13_hv_pmos[ide]
print @n.xbgr.xm50.nsg13_hv_pmos[ige]
print @n.xbgr.xm50.nsg13_hv_pmos[ise]
print @n.xbgr.xm50.nsg13_hv_pmos[ibe]
print @n.xbgr.xm50.nsg13_hv_pmos[ctype]
print @n.xbgr.xm51.nsg13_hv_pmos[ide]
print @n.xbgr.xm51.nsg13_hv_pmos[ige]
print @n.xbgr.xm51.nsg13_hv_pmos[ise]
print @n.xbgr.xm51.nsg13_hv_pmos[ibe]
print @n.xbgr.xm51.nsg13_hv_pmos[ctype]
print @n.xbgr.xm52.nsg13_hv_pmos[ide]
print @n.xbgr.xm52.nsg13_hv_pmos[ige]
print @n.xbgr.xm52.nsg13_hv_pmos[ise]
print @n.xbgr.xm52.nsg13_hv_pmos[ibe]
print @n.xbgr.xm52.nsg13_hv_pmos[ctype]
print @n.xbgr.xm53.nsg13_hv_pmos[ide]
print @n.xbgr.xm53.nsg13_hv_pmos[ige]
print @n.xbgr.xm53.nsg13_hv_pmos[ise]
print @n.xbgr.xm53.nsg13_hv_pmos[ibe]
print @n.xbgr.xm53.nsg13_hv_pmos[ctype]
print @n.xbgr.xm54.nsg13_hv_pmos[ide]
print @n.xbgr.xm54.nsg13_hv_pmos[ige]
print @n.xbgr.xm54.nsg13_hv_pmos[ise]
print @n.xbgr.xm54.nsg13_hv_pmos[ibe]
print @n.xbgr.xm54.nsg13_hv_pmos[ctype]
print @q.xbgr.xq55.qnpn13g2[ic]
print @q.xbgr.xq55.qnpn13g2[ib]
print @q.xbgr.xq55.qnpn13g2[ie]
print @q.xbgr.xq55.qnpn13g2[is]
print @r.xbgr.xq55.rsub[i]
print @c.xbgr.xq55.csub[i]
print @q.xbgr.xq56.qnpn13g2[ic]
print @q.xbgr.xq56.qnpn13g2[ib]
print @q.xbgr.xq56.qnpn13g2[ie]
print @q.xbgr.xq56.qnpn13g2[is]
print @r.xbgr.xq56.rsub[i]
print @c.xbgr.xq56.csub[i]
print @q.xbgr.xq57.qnpn13g2[ic]
print @q.xbgr.xq57.qnpn13g2[ib]
print @q.xbgr.xq57.qnpn13g2[ie]
print @q.xbgr.xq57.qnpn13g2[is]
print @r.xbgr.xq57.rsub[i]
print @c.xbgr.xq57.csub[i]
print @q.xbgr.xq58.qnpn13g2[ic]
print @q.xbgr.xq58.qnpn13g2[ib]
print @q.xbgr.xq58.qnpn13g2[ie]
print @q.xbgr.xq58.qnpn13g2[is]
print @r.xbgr.xq58.rsub[i]
print @c.xbgr.xq58.csub[i]
print @q.xbgr.xq59.qnpn13g2[ic]
print @q.xbgr.xq59.qnpn13g2[ib]
print @q.xbgr.xq59.qnpn13g2[ie]
print @q.xbgr.xq59.qnpn13g2[is]
print @r.xbgr.xq59.rsub[i]
print @c.xbgr.xq59.csub[i]
print @q.xbgr.xq60.qnpn13g2[ic]
print @q.xbgr.xq60.qnpn13g2[ib]
print @q.xbgr.xq60.qnpn13g2[ie]
print @q.xbgr.xq60.qnpn13g2[is]
print @r.xbgr.xq60.rsub[i]
print @c.xbgr.xq60.csub[i]
print @q.xbgr.xq61.qnpn13g2[ic]
print @q.xbgr.xq61.qnpn13g2[ib]
print @q.xbgr.xq61.qnpn13g2[ie]
print @q.xbgr.xq61.qnpn13g2[is]
print @r.xbgr.xq61.rsub[i]
print @c.xbgr.xq61.csub[i]
print @q.xbgr.xq62.qnpn13g2[ic]
print @q.xbgr.xq62.qnpn13g2[ib]
print @q.xbgr.xq62.qnpn13g2[ie]
print @q.xbgr.xq62.qnpn13g2[is]
print @r.xbgr.xq62.rsub[i]
print @c.xbgr.xq62.csub[i]
print @q.xbgr.xq63.qnpn13g2[ic]
print @q.xbgr.xq63.qnpn13g2[ib]
print @q.xbgr.xq63.qnpn13g2[ie]
print @q.xbgr.xq63.qnpn13g2[is]
print @r.xbgr.xq63.rsub[i]
print @c.xbgr.xq63.csub[i]
print @q.xbgr.xq64.qnpn13g2[ic]
print @q.xbgr.xq64.qnpn13g2[ib]
print @q.xbgr.xq64.qnpn13g2[ie]
print @q.xbgr.xq64.qnpn13g2[is]
print @r.xbgr.xq64.rsub[i]
print @c.xbgr.xq64.csub[i]
print @q.xbgr.xq65.qnpn13g2[ic]
print @q.xbgr.xq65.qnpn13g2[ib]
print @q.xbgr.xq65.qnpn13g2[ie]
print @q.xbgr.xq65.qnpn13g2[is]
print @r.xbgr.xq65.rsub[i]
print @c.xbgr.xq65.csub[i]
print @q.xbgr.xq66.qnpn13g2[ic]
print @q.xbgr.xq66.qnpn13g2[ib]
print @q.xbgr.xq66.qnpn13g2[ie]
print @q.xbgr.xq66.qnpn13g2[is]
print @r.xbgr.xq66.rsub[i]
print @c.xbgr.xq66.csub[i]
print @q.xbgr.xq67.qnpn13g2[ic]
print @q.xbgr.xq67.qnpn13g2[ib]
print @q.xbgr.xq67.qnpn13g2[ie]
print @q.xbgr.xq67.qnpn13g2[is]
print @r.xbgr.xq67.rsub[i]
print @c.xbgr.xq67.csub[i]
print @q.xbgr.xq68.qnpn13g2[ic]
print @q.xbgr.xq68.qnpn13g2[ib]
print @q.xbgr.xq68.qnpn13g2[ie]
print @q.xbgr.xq68.qnpn13g2[is]
print @r.xbgr.xq68.rsub[i]
print @c.xbgr.xq68.csub[i]
print @q.xbgr.xq69.qnpn13g2[ic]
print @q.xbgr.xq69.qnpn13g2[ib]
print @q.xbgr.xq69.qnpn13g2[ie]
print @q.xbgr.xq69.qnpn13g2[is]
print @r.xbgr.xq69.rsub[i]
print @c.xbgr.xq69.csub[i]
print @q.xbgr.xq70.qnpn13g2[ic]
print @q.xbgr.xq70.qnpn13g2[ib]
print @q.xbgr.xq70.qnpn13g2[ie]
print @q.xbgr.xq70.qnpn13g2[is]
print @r.xbgr.xq70.rsub[i]
print @c.xbgr.xq70.csub[i]
print @q.xbgr.xq71.qnpn13g2[ic]
print @q.xbgr.xq71.qnpn13g2[ib]
print @q.xbgr.xq71.qnpn13g2[ie]
print @q.xbgr.xq71.qnpn13g2[is]
print @r.xbgr.xq71.rsub[i]
print @c.xbgr.xq71.csub[i]
print @q.xbgr.xq72.qnpn13g2[ic]
print @q.xbgr.xq72.qnpn13g2[ib]
print @q.xbgr.xq72.qnpn13g2[ie]
print @q.xbgr.xq72.qnpn13g2[is]
print @r.xbgr.xq72.rsub[i]
print @c.xbgr.xq72.csub[i]
print @q.xbgr.xq73.qnpn13g2[ic]
print @q.xbgr.xq73.qnpn13g2[ib]
print @q.xbgr.xq73.qnpn13g2[ie]
print @q.xbgr.xq73.qnpn13g2[is]
print @r.xbgr.xq73.rsub[i]
print @c.xbgr.xq73.csub[i]
print @q.xbgr.xq74.qnpn13g2[ic]
print @q.xbgr.xq74.qnpn13g2[ib]
print @q.xbgr.xq74.qnpn13g2[ie]
print @q.xbgr.xq74.qnpn13g2[is]
print @r.xbgr.xq74.rsub[i]
print @c.xbgr.xq74.csub[i]
print @q.xbgr.xq75.qnpn13g2[ic]
print @q.xbgr.xq75.qnpn13g2[ib]
print @q.xbgr.xq75.qnpn13g2[ie]
print @q.xbgr.xq75.qnpn13g2[is]
print @r.xbgr.xq75.rsub[i]
print @c.xbgr.xq75.csub[i]
print @q.xbgr.xq76.qnpn13g2[ic]
print @q.xbgr.xq76.qnpn13g2[ib]
print @q.xbgr.xq76.qnpn13g2[ie]
print @q.xbgr.xq76.qnpn13g2[is]
print @r.xbgr.xq76.rsub[i]
print @c.xbgr.xq76.csub[i]
print @n.xbgr.xr77.nr1[ibody]
print @n.xbgr.xr78.nr1[ibody]
print @n.xbgr.xr79.nr1[ibody]
print @n.xbgr.xr80.nr1[ibody]
print @n.xbgr.xr81.nr1[ibody]
print @n.xbgr.xr82.nr1[ibody]
print @n.xbgr.xr83.nr1[ibody]
print @n.xbgr.xr84.nr1[ibody]
print @n.xbgr.xr85.nr1[ibody]
print @n.xbgr.xr86.nr1[ibody]
print @n.xbgr.xr16_u2.nr1[ibody]
print @n.xbgr.xr16_u3.nr1[ibody]
print @n.xbgr.xr16_u4.nr1[ibody]
print @n.xbgr.xr16_u5.nr1[ibody]
print @n.xbgr.xr16_u6.nr1[ibody]
print @n.xbgr.xr16_u7.nr1[ibody]
print @n.xbgr.xr16_u8.nr1[ibody]
print @n.xbgr.xr16_u9.nr1[ibody]
print @n.xbgr.xr16_u10.nr1[ibody]
print @n.xbgr.xr16_u11.nr1[ibody]
print @n.xbgr.xr16_u12.nr1[ibody]
print @n.xbgr.xr16_u13.nr1[ibody]
print @n.xbgr.xr16_u14.nr1[ibody]
print @n.xbgr.xr16_u15.nr1[ibody]
print @n.xbgr.xr16_u16.nr1[ibody]
print @n.xbgr.xr16_u17.nr1[ibody]
print @n.xbgr.xr16_u18.nr1[ibody]
print @n.xbgr.xr16_u19.nr1[ibody]
print @n.xbgr.xr16_u20.nr1[ibody]
print @n.xbgr.xr16_u21.nr1[ibody]
print @n.xbgr.xr16_u22.nr1[ibody]
print @n.xbgr.xr16_u23.nr1[ibody]
print @n.xbgr.xr16_u24.nr1[ibody]
print @n.xbgr.xr17_u2.nr1[ibody]
print @n.xbgr.xr17_u3.nr1[ibody]
print @n.xbgr.xr17_u4.nr1[ibody]
print @n.xbgr.xr18_u2.nr1[ibody]
print @n.xbgr.xr18_u3.nr1[ibody]
print @n.xbgr.xr18_u4.nr1[ibody]
print @n.xbgr.xr19_u2.nr1[ibody]
print @n.xbgr.xr19_u3.nr1[ibody]
print @n.xbgr.xr19_u4.nr1[ibody]
print @n.xbgr.xr20_u2.nr1[ibody]
print @n.xbgr.xr20_u3.nr1[ibody]
print @n.xbgr.xr20_u4.nr1[ibody]
print @n.xbgr.xr21_u2.nr1[ibody]
print @n.xbgr.xr21_u3.nr1[ibody]
print @n.xbgr.xr21_u4.nr1[ibody]
print @n.xbgr.xr22_u2.nr1[ibody]
print @n.xbgr.xr22_u3.nr1[ibody]
print @n.xbgr.xr22_u4.nr1[ibody]
print @n.xbgr.xr23_u2.nr1[ibody]
print @n.xbgr.xr23_u3.nr1[ibody]
print @n.xbgr.xr23_u4.nr1[ibody]
print @n.xbgr.xr23_u5.nr1[ibody]
print @n.xbgr.xr23_u6.nr1[ibody]
print @n.xbgr.xr23_u7.nr1[ibody]
print @n.xbgr.xr23_u8.nr1[ibody]
print @n.xbgr.xr23_u9.nr1[ibody]
print @n.xbgr.xr23_u10.nr1[ibody]
print @n.xbgr.xr23_u11.nr1[ibody]
print @n.xbgr.xr23_u12.nr1[ibody]
print @n.xbgr.xr23_u13.nr1[ibody]
print @n.xbgr.xr23_u14.nr1[ibody]
print @n.xbgr.xr23_u15.nr1[ibody]
print @n.xbgr.xr23_u16.nr1[ibody]
print @n.xbgr.xr23_u17.nr1[ibody]
print @n.xbgr.xr23_u18.nr1[ibody]
print @n.xbgr.xr23_u19.nr1[ibody]
print @n.xbgr.xr23_u20.nr1[ibody]
print @n.xbgr.xr23_u21.nr1[ibody]
print @n.xbgr.xr23_u22.nr1[ibody]
print @n.xbgr.xr23_u23.nr1[ibody]
print @n.xbgr.xr23_u24.nr1[ibody]
print @n.xbgr.xr24_u2.nr1[ibody]
print @n.xbgr.xr24_u3.nr1[ibody]
print @n.xbgr.xr24_u4.nr1[ibody]
print @n.xbgr.xr24_u5.nr1[ibody]
print @n.xbgr.xr24_u6.nr1[ibody]
print @n.xbgr.xr24_u7.nr1[ibody]
print @n.xbgr.xr24_u8.nr1[ibody]
print @n.xbgr.xr24_u9.nr1[ibody]
print @n.xbgr.xr24_u10.nr1[ibody]
print @n.xbgr.xr24_u11.nr1[ibody]
print @n.xbgr.xr24_u12.nr1[ibody]
print @n.xbgr.xr24_u13.nr1[ibody]
print @n.xbgr.xr24_u14.nr1[ibody]
print @n.xbgr.xr24_u15.nr1[ibody]
print @n.xbgr.xr24_u16.nr1[ibody]
print @n.xbgr.xr24_u17.nr1[ibody]
print @n.xbgr.xr24_u18.nr1[ibody]
print @n.xbgr.xr24_u19.nr1[ibody]
print @n.xbgr.xr24_u20.nr1[ibody]
print @n.xbgr.xr24_u21.nr1[ibody]
print @n.xbgr.xr24_u22.nr1[ibody]
print @n.xbgr.xr24_u23.nr1[ibody]
print @n.xbgr.xr24_u24.nr1[ibody]
print @n.xbgr.xr25_u2.nr1[ibody]
print @n.xbgr.xr25_u3.nr1[ibody]
print @n.xbgr.xr25_u4.nr1[ibody]
print @n.xbgr.xr25_u5.nr1[ibody]
print @n.xbgr.xr25_u6.nr1[ibody]
print @n.xbgr.xr25_u7.nr1[ibody]
print @n.xbgr.xr25_u8.nr1[ibody]
print @n.xbgr.xr25_u9.nr1[ibody]
print @n.xbgr.xr25_u10.nr1[ibody]
print @n.xbgr.xr25_u11.nr1[ibody]
print @n.xbgr.xr25_u12.nr1[ibody]
print @n.xbgr.xr25_u13.nr1[ibody]
print @n.xbgr.xr25_u14.nr1[ibody]
print @n.xbgr.xr25_u15.nr1[ibody]
print @n.xbgr.xr25_u16.nr1[ibody]
print @n.xbgr.xr25_u17.nr1[ibody]
print @n.xbgr.xr25_u18.nr1[ibody]
print @n.xbgr.xr25_u19.nr1[ibody]
print @n.xbgr.xr25_u20.nr1[ibody]
print @n.xbgr.xr25_u21.nr1[ibody]
print @n.xbgr.xr25_u22.nr1[ibody]
print @n.xbgr.xr25_u23.nr1[ibody]
print @n.xbgr.xr25_u24.nr1[ibody]
print @n.xbgr.xr26_u2.nr1[ibody]
print @n.xbgr.xr26_u3.nr1[ibody]
print @n.xbgr.xr26_u4.nr1[ibody]
print @n.xbgr.xr26_u5.nr1[ibody]
print @n.xbgr.xr26_u6.nr1[ibody]
print @n.xbgr.xr26_u7.nr1[ibody]
print @n.xbgr.xr26_u8.nr1[ibody]
print @n.xbgr.xr26_u9.nr1[ibody]
print @n.xbgr.xr26_u10.nr1[ibody]
print @n.xbgr.xr26_u11.nr1[ibody]
print @n.xbgr.xr26_u12.nr1[ibody]
print @n.xbgr.xr26_u13.nr1[ibody]
print @n.xbgr.xr26_u14.nr1[ibody]
print @n.xbgr.xr26_u15.nr1[ibody]
print @n.xbgr.xr26_u16.nr1[ibody]
print @n.xbgr.xr26_u17.nr1[ibody]
print @n.xbgr.xr26_u18.nr1[ibody]
print @n.xbgr.xr26_u19.nr1[ibody]
print @n.xbgr.xr26_u20.nr1[ibody]
print @n.xbgr.xr26_u21.nr1[ibody]
print @n.xbgr.xr26_u22.nr1[ibody]
print @n.xbgr.xr26_u23.nr1[ibody]
print @n.xbgr.xr26_u24.nr1[ibody]
print @n.xbgr.xm34_u2.nsg13_hv_nmos[ide]
print @n.xbgr.xm34_u2.nsg13_hv_nmos[ige]
print @n.xbgr.xm34_u2.nsg13_hv_nmos[ise]
print @n.xbgr.xm34_u2.nsg13_hv_nmos[ibe]
print @n.xbgr.xm34_u2.nsg13_hv_nmos[ctype]
print @n.xbgr.xm34_u3.nsg13_hv_nmos[ide]
print @n.xbgr.xm34_u3.nsg13_hv_nmos[ige]
print @n.xbgr.xm34_u3.nsg13_hv_nmos[ise]
print @n.xbgr.xm34_u3.nsg13_hv_nmos[ibe]
print @n.xbgr.xm34_u3.nsg13_hv_nmos[ctype]
print @n.xbgr.xm34_u4.nsg13_hv_nmos[ide]
print @n.xbgr.xm34_u4.nsg13_hv_nmos[ige]
print @n.xbgr.xm34_u4.nsg13_hv_nmos[ise]
print @n.xbgr.xm34_u4.nsg13_hv_nmos[ibe]
print @n.xbgr.xm34_u4.nsg13_hv_nmos[ctype]
print @n.xbgr.xm34_u5.nsg13_hv_nmos[ide]
print @n.xbgr.xm34_u5.nsg13_hv_nmos[ige]
print @n.xbgr.xm34_u5.nsg13_hv_nmos[ise]
print @n.xbgr.xm34_u5.nsg13_hv_nmos[ibe]
print @n.xbgr.xm34_u5.nsg13_hv_nmos[ctype]
print @n.xbgr.xm34_u6.nsg13_hv_nmos[ide]
print @n.xbgr.xm34_u6.nsg13_hv_nmos[ige]
print @n.xbgr.xm34_u6.nsg13_hv_nmos[ise]
print @n.xbgr.xm34_u6.nsg13_hv_nmos[ibe]
print @n.xbgr.xm34_u6.nsg13_hv_nmos[ctype]
print @n.xbgr.xm34_u7.nsg13_hv_nmos[ide]
print @n.xbgr.xm34_u7.nsg13_hv_nmos[ige]
print @n.xbgr.xm34_u7.nsg13_hv_nmos[ise]
print @n.xbgr.xm34_u7.nsg13_hv_nmos[ibe]
print @n.xbgr.xm34_u7.nsg13_hv_nmos[ctype]
print @n.xbgr.xm34_u8.nsg13_hv_nmos[ide]
print @n.xbgr.xm34_u8.nsg13_hv_nmos[ige]
print @n.xbgr.xm34_u8.nsg13_hv_nmos[ise]
print @n.xbgr.xm34_u8.nsg13_hv_nmos[ibe]
print @n.xbgr.xm34_u8.nsg13_hv_nmos[ctype]
print @n.xbgr.xm34_u9.nsg13_hv_nmos[ide]
print @n.xbgr.xm34_u9.nsg13_hv_nmos[ige]
print @n.xbgr.xm34_u9.nsg13_hv_nmos[ise]
print @n.xbgr.xm34_u9.nsg13_hv_nmos[ibe]
print @n.xbgr.xm34_u9.nsg13_hv_nmos[ctype]
print @n.xbgr.xm34_u10.nsg13_hv_nmos[ide]
print @n.xbgr.xm34_u10.nsg13_hv_nmos[ige]
print @n.xbgr.xm34_u10.nsg13_hv_nmos[ise]
print @n.xbgr.xm34_u10.nsg13_hv_nmos[ibe]
print @n.xbgr.xm34_u10.nsg13_hv_nmos[ctype]
print @n.xbgr.xm34_u11.nsg13_hv_nmos[ide]
print @n.xbgr.xm34_u11.nsg13_hv_nmos[ige]
print @n.xbgr.xm34_u11.nsg13_hv_nmos[ise]
print @n.xbgr.xm34_u11.nsg13_hv_nmos[ibe]
print @n.xbgr.xm34_u11.nsg13_hv_nmos[ctype]
print @n.xbgr.xm34_u12.nsg13_hv_nmos[ide]
print @n.xbgr.xm34_u12.nsg13_hv_nmos[ige]
print @n.xbgr.xm34_u12.nsg13_hv_nmos[ise]
print @n.xbgr.xm34_u12.nsg13_hv_nmos[ibe]
print @n.xbgr.xm34_u12.nsg13_hv_nmos[ctype]
print @n.xbgr.xm34_u13.nsg13_hv_nmos[ide]
print @n.xbgr.xm34_u13.nsg13_hv_nmos[ige]
print @n.xbgr.xm34_u13.nsg13_hv_nmos[ise]
print @n.xbgr.xm34_u13.nsg13_hv_nmos[ibe]
print @n.xbgr.xm34_u13.nsg13_hv_nmos[ctype]
print @n.xbgr.xm34_u14.nsg13_hv_nmos[ide]
print @n.xbgr.xm34_u14.nsg13_hv_nmos[ige]
print @n.xbgr.xm34_u14.nsg13_hv_nmos[ise]
print @n.xbgr.xm34_u14.nsg13_hv_nmos[ibe]
print @n.xbgr.xm34_u14.nsg13_hv_nmos[ctype]
print @n.xbgr.xm34_u15.nsg13_hv_nmos[ide]
print @n.xbgr.xm34_u15.nsg13_hv_nmos[ige]
print @n.xbgr.xm34_u15.nsg13_hv_nmos[ise]
print @n.xbgr.xm34_u15.nsg13_hv_nmos[ibe]
print @n.xbgr.xm34_u15.nsg13_hv_nmos[ctype]
print @n.xbgr.xm34_u16.nsg13_hv_nmos[ide]
print @n.xbgr.xm34_u16.nsg13_hv_nmos[ige]
print @n.xbgr.xm34_u16.nsg13_hv_nmos[ise]
print @n.xbgr.xm34_u16.nsg13_hv_nmos[ibe]
print @n.xbgr.xm34_u16.nsg13_hv_nmos[ctype]
print @n.xbgr.xm34_u17.nsg13_hv_nmos[ide]
print @n.xbgr.xm34_u17.nsg13_hv_nmos[ige]
print @n.xbgr.xm34_u17.nsg13_hv_nmos[ise]
print @n.xbgr.xm34_u17.nsg13_hv_nmos[ibe]
print @n.xbgr.xm34_u17.nsg13_hv_nmos[ctype]
print @n.xbgr.xm34_u18.nsg13_hv_nmos[ide]
print @n.xbgr.xm34_u18.nsg13_hv_nmos[ige]
print @n.xbgr.xm34_u18.nsg13_hv_nmos[ise]
print @n.xbgr.xm34_u18.nsg13_hv_nmos[ibe]
print @n.xbgr.xm34_u18.nsg13_hv_nmos[ctype]
print @n.xbgr.xm34_u19.nsg13_hv_nmos[ide]
print @n.xbgr.xm34_u19.nsg13_hv_nmos[ige]
print @n.xbgr.xm34_u19.nsg13_hv_nmos[ise]
print @n.xbgr.xm34_u19.nsg13_hv_nmos[ibe]
print @n.xbgr.xm34_u19.nsg13_hv_nmos[ctype]
print @n.xbgr.xm34_u20.nsg13_hv_nmos[ide]
print @n.xbgr.xm34_u20.nsg13_hv_nmos[ige]
print @n.xbgr.xm34_u20.nsg13_hv_nmos[ise]
print @n.xbgr.xm34_u20.nsg13_hv_nmos[ibe]
print @n.xbgr.xm34_u20.nsg13_hv_nmos[ctype]
print @n.xbgr.xm34_u21.nsg13_hv_nmos[ide]
print @n.xbgr.xm34_u21.nsg13_hv_nmos[ige]
print @n.xbgr.xm34_u21.nsg13_hv_nmos[ise]
print @n.xbgr.xm34_u21.nsg13_hv_nmos[ibe]
print @n.xbgr.xm34_u21.nsg13_hv_nmos[ctype]
print @n.xbgr.xm34_u22.nsg13_hv_nmos[ide]
print @n.xbgr.xm34_u22.nsg13_hv_nmos[ige]
print @n.xbgr.xm34_u22.nsg13_hv_nmos[ise]
print @n.xbgr.xm34_u22.nsg13_hv_nmos[ibe]
print @n.xbgr.xm34_u22.nsg13_hv_nmos[ctype]
print @n.xbgr.xm34_u23.nsg13_hv_nmos[ide]
print @n.xbgr.xm34_u23.nsg13_hv_nmos[ige]
print @n.xbgr.xm34_u23.nsg13_hv_nmos[ise]
print @n.xbgr.xm34_u23.nsg13_hv_nmos[ibe]
print @n.xbgr.xm34_u23.nsg13_hv_nmos[ctype]
print @n.xbgr.xm34_u24.nsg13_hv_nmos[ide]
print @n.xbgr.xm34_u24.nsg13_hv_nmos[ige]
print @n.xbgr.xm34_u24.nsg13_hv_nmos[ise]
print @n.xbgr.xm34_u24.nsg13_hv_nmos[ibe]
print @n.xbgr.xm34_u24.nsg13_hv_nmos[ctype]
print @n.xbgr.xm35_u2.nsg13_hv_nmos[ide]
print @n.xbgr.xm35_u2.nsg13_hv_nmos[ige]
print @n.xbgr.xm35_u2.nsg13_hv_nmos[ise]
print @n.xbgr.xm35_u2.nsg13_hv_nmos[ibe]
print @n.xbgr.xm35_u2.nsg13_hv_nmos[ctype]
print @n.xbgr.xm35_u3.nsg13_hv_nmos[ide]
print @n.xbgr.xm35_u3.nsg13_hv_nmos[ige]
print @n.xbgr.xm35_u3.nsg13_hv_nmos[ise]
print @n.xbgr.xm35_u3.nsg13_hv_nmos[ibe]
print @n.xbgr.xm35_u3.nsg13_hv_nmos[ctype]
print @n.xbgr.xm35_u4.nsg13_hv_nmos[ide]
print @n.xbgr.xm35_u4.nsg13_hv_nmos[ige]
print @n.xbgr.xm35_u4.nsg13_hv_nmos[ise]
print @n.xbgr.xm35_u4.nsg13_hv_nmos[ibe]
print @n.xbgr.xm35_u4.nsg13_hv_nmos[ctype]
print @n.xbgr.xm35_u5.nsg13_hv_nmos[ide]
print @n.xbgr.xm35_u5.nsg13_hv_nmos[ige]
print @n.xbgr.xm35_u5.nsg13_hv_nmos[ise]
print @n.xbgr.xm35_u5.nsg13_hv_nmos[ibe]
print @n.xbgr.xm35_u5.nsg13_hv_nmos[ctype]
print @n.xbgr.xm35_u6.nsg13_hv_nmos[ide]
print @n.xbgr.xm35_u6.nsg13_hv_nmos[ige]
print @n.xbgr.xm35_u6.nsg13_hv_nmos[ise]
print @n.xbgr.xm35_u6.nsg13_hv_nmos[ibe]
print @n.xbgr.xm35_u6.nsg13_hv_nmos[ctype]
print @n.xbgr.xm35_u7.nsg13_hv_nmos[ide]
print @n.xbgr.xm35_u7.nsg13_hv_nmos[ige]
print @n.xbgr.xm35_u7.nsg13_hv_nmos[ise]
print @n.xbgr.xm35_u7.nsg13_hv_nmos[ibe]
print @n.xbgr.xm35_u7.nsg13_hv_nmos[ctype]
print @n.xbgr.xm35_u8.nsg13_hv_nmos[ide]
print @n.xbgr.xm35_u8.nsg13_hv_nmos[ige]
print @n.xbgr.xm35_u8.nsg13_hv_nmos[ise]
print @n.xbgr.xm35_u8.nsg13_hv_nmos[ibe]
print @n.xbgr.xm35_u8.nsg13_hv_nmos[ctype]
print @n.xbgr.xm35_u9.nsg13_hv_nmos[ide]
print @n.xbgr.xm35_u9.nsg13_hv_nmos[ige]
print @n.xbgr.xm35_u9.nsg13_hv_nmos[ise]
print @n.xbgr.xm35_u9.nsg13_hv_nmos[ibe]
print @n.xbgr.xm35_u9.nsg13_hv_nmos[ctype]
print @n.xbgr.xm35_u10.nsg13_hv_nmos[ide]
print @n.xbgr.xm35_u10.nsg13_hv_nmos[ige]
print @n.xbgr.xm35_u10.nsg13_hv_nmos[ise]
print @n.xbgr.xm35_u10.nsg13_hv_nmos[ibe]
print @n.xbgr.xm35_u10.nsg13_hv_nmos[ctype]
print @n.xbgr.xm35_u11.nsg13_hv_nmos[ide]
print @n.xbgr.xm35_u11.nsg13_hv_nmos[ige]
print @n.xbgr.xm35_u11.nsg13_hv_nmos[ise]
print @n.xbgr.xm35_u11.nsg13_hv_nmos[ibe]
print @n.xbgr.xm35_u11.nsg13_hv_nmos[ctype]
print @n.xbgr.xm35_u12.nsg13_hv_nmos[ide]
print @n.xbgr.xm35_u12.nsg13_hv_nmos[ige]
print @n.xbgr.xm35_u12.nsg13_hv_nmos[ise]
print @n.xbgr.xm35_u12.nsg13_hv_nmos[ibe]
print @n.xbgr.xm35_u12.nsg13_hv_nmos[ctype]
print @n.xbgr.xm35_u13.nsg13_hv_nmos[ide]
print @n.xbgr.xm35_u13.nsg13_hv_nmos[ige]
print @n.xbgr.xm35_u13.nsg13_hv_nmos[ise]
print @n.xbgr.xm35_u13.nsg13_hv_nmos[ibe]
print @n.xbgr.xm35_u13.nsg13_hv_nmos[ctype]
print @n.xbgr.xm35_u14.nsg13_hv_nmos[ide]
print @n.xbgr.xm35_u14.nsg13_hv_nmos[ige]
print @n.xbgr.xm35_u14.nsg13_hv_nmos[ise]
print @n.xbgr.xm35_u14.nsg13_hv_nmos[ibe]
print @n.xbgr.xm35_u14.nsg13_hv_nmos[ctype]
print @n.xbgr.xm35_u15.nsg13_hv_nmos[ide]
print @n.xbgr.xm35_u15.nsg13_hv_nmos[ige]
print @n.xbgr.xm35_u15.nsg13_hv_nmos[ise]
print @n.xbgr.xm35_u15.nsg13_hv_nmos[ibe]
print @n.xbgr.xm35_u15.nsg13_hv_nmos[ctype]
print @n.xbgr.xm35_u16.nsg13_hv_nmos[ide]
print @n.xbgr.xm35_u16.nsg13_hv_nmos[ige]
print @n.xbgr.xm35_u16.nsg13_hv_nmos[ise]
print @n.xbgr.xm35_u16.nsg13_hv_nmos[ibe]
print @n.xbgr.xm35_u16.nsg13_hv_nmos[ctype]
print @n.xbgr.xm35_u17.nsg13_hv_nmos[ide]
print @n.xbgr.xm35_u17.nsg13_hv_nmos[ige]
print @n.xbgr.xm35_u17.nsg13_hv_nmos[ise]
print @n.xbgr.xm35_u17.nsg13_hv_nmos[ibe]
print @n.xbgr.xm35_u17.nsg13_hv_nmos[ctype]
print @n.xbgr.xm35_u18.nsg13_hv_nmos[ide]
print @n.xbgr.xm35_u18.nsg13_hv_nmos[ige]
print @n.xbgr.xm35_u18.nsg13_hv_nmos[ise]
print @n.xbgr.xm35_u18.nsg13_hv_nmos[ibe]
print @n.xbgr.xm35_u18.nsg13_hv_nmos[ctype]
print @n.xbgr.xm35_u19.nsg13_hv_nmos[ide]
print @n.xbgr.xm35_u19.nsg13_hv_nmos[ige]
print @n.xbgr.xm35_u19.nsg13_hv_nmos[ise]
print @n.xbgr.xm35_u19.nsg13_hv_nmos[ibe]
print @n.xbgr.xm35_u19.nsg13_hv_nmos[ctype]
print @n.xbgr.xm35_u20.nsg13_hv_nmos[ide]
print @n.xbgr.xm35_u20.nsg13_hv_nmos[ige]
print @n.xbgr.xm35_u20.nsg13_hv_nmos[ise]
print @n.xbgr.xm35_u20.nsg13_hv_nmos[ibe]
print @n.xbgr.xm35_u20.nsg13_hv_nmos[ctype]
print @n.xbgr.xm35_u21.nsg13_hv_nmos[ide]
print @n.xbgr.xm35_u21.nsg13_hv_nmos[ige]
print @n.xbgr.xm35_u21.nsg13_hv_nmos[ise]
print @n.xbgr.xm35_u21.nsg13_hv_nmos[ibe]
print @n.xbgr.xm35_u21.nsg13_hv_nmos[ctype]
print @n.xbgr.xm35_u22.nsg13_hv_nmos[ide]
print @n.xbgr.xm35_u22.nsg13_hv_nmos[ige]
print @n.xbgr.xm35_u22.nsg13_hv_nmos[ise]
print @n.xbgr.xm35_u22.nsg13_hv_nmos[ibe]
print @n.xbgr.xm35_u22.nsg13_hv_nmos[ctype]
print @n.xbgr.xm35_u23.nsg13_hv_nmos[ide]
print @n.xbgr.xm35_u23.nsg13_hv_nmos[ige]
print @n.xbgr.xm35_u23.nsg13_hv_nmos[ise]
print @n.xbgr.xm35_u23.nsg13_hv_nmos[ibe]
print @n.xbgr.xm35_u23.nsg13_hv_nmos[ctype]
print @n.xbgr.xm35_u24.nsg13_hv_nmos[ide]
print @n.xbgr.xm35_u24.nsg13_hv_nmos[ige]
print @n.xbgr.xm35_u24.nsg13_hv_nmos[ise]
print @n.xbgr.xm35_u24.nsg13_hv_nmos[ibe]
print @n.xbgr.xm35_u24.nsg13_hv_nmos[ctype]
print @n.xbgr.xm36_u2.nsg13_hv_nmos[ide]
print @n.xbgr.xm36_u2.nsg13_hv_nmos[ige]
print @n.xbgr.xm36_u2.nsg13_hv_nmos[ise]
print @n.xbgr.xm36_u2.nsg13_hv_nmos[ibe]
print @n.xbgr.xm36_u2.nsg13_hv_nmos[ctype]
print @n.xbgr.xm36_u3.nsg13_hv_nmos[ide]
print @n.xbgr.xm36_u3.nsg13_hv_nmos[ige]
print @n.xbgr.xm36_u3.nsg13_hv_nmos[ise]
print @n.xbgr.xm36_u3.nsg13_hv_nmos[ibe]
print @n.xbgr.xm36_u3.nsg13_hv_nmos[ctype]
print @n.xbgr.xm36_u4.nsg13_hv_nmos[ide]
print @n.xbgr.xm36_u4.nsg13_hv_nmos[ige]
print @n.xbgr.xm36_u4.nsg13_hv_nmos[ise]
print @n.xbgr.xm36_u4.nsg13_hv_nmos[ibe]
print @n.xbgr.xm36_u4.nsg13_hv_nmos[ctype]
print @n.xbgr.xm36_u5.nsg13_hv_nmos[ide]
print @n.xbgr.xm36_u5.nsg13_hv_nmos[ige]
print @n.xbgr.xm36_u5.nsg13_hv_nmos[ise]
print @n.xbgr.xm36_u5.nsg13_hv_nmos[ibe]
print @n.xbgr.xm36_u5.nsg13_hv_nmos[ctype]
print @n.xbgr.xm36_u6.nsg13_hv_nmos[ide]
print @n.xbgr.xm36_u6.nsg13_hv_nmos[ige]
print @n.xbgr.xm36_u6.nsg13_hv_nmos[ise]
print @n.xbgr.xm36_u6.nsg13_hv_nmos[ibe]
print @n.xbgr.xm36_u6.nsg13_hv_nmos[ctype]
print @n.xbgr.xm36_u7.nsg13_hv_nmos[ide]
print @n.xbgr.xm36_u7.nsg13_hv_nmos[ige]
print @n.xbgr.xm36_u7.nsg13_hv_nmos[ise]
print @n.xbgr.xm36_u7.nsg13_hv_nmos[ibe]
print @n.xbgr.xm36_u7.nsg13_hv_nmos[ctype]
print @n.xbgr.xm36_u8.nsg13_hv_nmos[ide]
print @n.xbgr.xm36_u8.nsg13_hv_nmos[ige]
print @n.xbgr.xm36_u8.nsg13_hv_nmos[ise]
print @n.xbgr.xm36_u8.nsg13_hv_nmos[ibe]
print @n.xbgr.xm36_u8.nsg13_hv_nmos[ctype]
print @n.xbgr.xm36_u9.nsg13_hv_nmos[ide]
print @n.xbgr.xm36_u9.nsg13_hv_nmos[ige]
print @n.xbgr.xm36_u9.nsg13_hv_nmos[ise]
print @n.xbgr.xm36_u9.nsg13_hv_nmos[ibe]
print @n.xbgr.xm36_u9.nsg13_hv_nmos[ctype]
print @n.xbgr.xm36_u10.nsg13_hv_nmos[ide]
print @n.xbgr.xm36_u10.nsg13_hv_nmos[ige]
print @n.xbgr.xm36_u10.nsg13_hv_nmos[ise]
print @n.xbgr.xm36_u10.nsg13_hv_nmos[ibe]
print @n.xbgr.xm36_u10.nsg13_hv_nmos[ctype]
print @n.xbgr.xm36_u11.nsg13_hv_nmos[ide]
print @n.xbgr.xm36_u11.nsg13_hv_nmos[ige]
print @n.xbgr.xm36_u11.nsg13_hv_nmos[ise]
print @n.xbgr.xm36_u11.nsg13_hv_nmos[ibe]
print @n.xbgr.xm36_u11.nsg13_hv_nmos[ctype]
print @n.xbgr.xm36_u12.nsg13_hv_nmos[ide]
print @n.xbgr.xm36_u12.nsg13_hv_nmos[ige]
print @n.xbgr.xm36_u12.nsg13_hv_nmos[ise]
print @n.xbgr.xm36_u12.nsg13_hv_nmos[ibe]
print @n.xbgr.xm36_u12.nsg13_hv_nmos[ctype]
print @n.xbgr.xm36_u13.nsg13_hv_nmos[ide]
print @n.xbgr.xm36_u13.nsg13_hv_nmos[ige]
print @n.xbgr.xm36_u13.nsg13_hv_nmos[ise]
print @n.xbgr.xm36_u13.nsg13_hv_nmos[ibe]
print @n.xbgr.xm36_u13.nsg13_hv_nmos[ctype]
print @n.xbgr.xm36_u14.nsg13_hv_nmos[ide]
print @n.xbgr.xm36_u14.nsg13_hv_nmos[ige]
print @n.xbgr.xm36_u14.nsg13_hv_nmos[ise]
print @n.xbgr.xm36_u14.nsg13_hv_nmos[ibe]
print @n.xbgr.xm36_u14.nsg13_hv_nmos[ctype]
print @n.xbgr.xm36_u15.nsg13_hv_nmos[ide]
print @n.xbgr.xm36_u15.nsg13_hv_nmos[ige]
print @n.xbgr.xm36_u15.nsg13_hv_nmos[ise]
print @n.xbgr.xm36_u15.nsg13_hv_nmos[ibe]
print @n.xbgr.xm36_u15.nsg13_hv_nmos[ctype]
print @n.xbgr.xm36_u16.nsg13_hv_nmos[ide]
print @n.xbgr.xm36_u16.nsg13_hv_nmos[ige]
print @n.xbgr.xm36_u16.nsg13_hv_nmos[ise]
print @n.xbgr.xm36_u16.nsg13_hv_nmos[ibe]
print @n.xbgr.xm36_u16.nsg13_hv_nmos[ctype]
print @n.xbgr.xm36_u17.nsg13_hv_nmos[ide]
print @n.xbgr.xm36_u17.nsg13_hv_nmos[ige]
print @n.xbgr.xm36_u17.nsg13_hv_nmos[ise]
print @n.xbgr.xm36_u17.nsg13_hv_nmos[ibe]
print @n.xbgr.xm36_u17.nsg13_hv_nmos[ctype]
print @n.xbgr.xm36_u18.nsg13_hv_nmos[ide]
print @n.xbgr.xm36_u18.nsg13_hv_nmos[ige]
print @n.xbgr.xm36_u18.nsg13_hv_nmos[ise]
print @n.xbgr.xm36_u18.nsg13_hv_nmos[ibe]
print @n.xbgr.xm36_u18.nsg13_hv_nmos[ctype]
print @n.xbgr.xm36_u19.nsg13_hv_nmos[ide]
print @n.xbgr.xm36_u19.nsg13_hv_nmos[ige]
print @n.xbgr.xm36_u19.nsg13_hv_nmos[ise]
print @n.xbgr.xm36_u19.nsg13_hv_nmos[ibe]
print @n.xbgr.xm36_u19.nsg13_hv_nmos[ctype]
print @n.xbgr.xm36_u20.nsg13_hv_nmos[ide]
print @n.xbgr.xm36_u20.nsg13_hv_nmos[ige]
print @n.xbgr.xm36_u20.nsg13_hv_nmos[ise]
print @n.xbgr.xm36_u20.nsg13_hv_nmos[ibe]
print @n.xbgr.xm36_u20.nsg13_hv_nmos[ctype]
print @n.xbgr.xm36_u21.nsg13_hv_nmos[ide]
print @n.xbgr.xm36_u21.nsg13_hv_nmos[ige]
print @n.xbgr.xm36_u21.nsg13_hv_nmos[ise]
print @n.xbgr.xm36_u21.nsg13_hv_nmos[ibe]
print @n.xbgr.xm36_u21.nsg13_hv_nmos[ctype]
print @n.xbgr.xm36_u22.nsg13_hv_nmos[ide]
print @n.xbgr.xm36_u22.nsg13_hv_nmos[ige]
print @n.xbgr.xm36_u22.nsg13_hv_nmos[ise]
print @n.xbgr.xm36_u22.nsg13_hv_nmos[ibe]
print @n.xbgr.xm36_u22.nsg13_hv_nmos[ctype]
print @n.xbgr.xm36_u23.nsg13_hv_nmos[ide]
print @n.xbgr.xm36_u23.nsg13_hv_nmos[ige]
print @n.xbgr.xm36_u23.nsg13_hv_nmos[ise]
print @n.xbgr.xm36_u23.nsg13_hv_nmos[ibe]
print @n.xbgr.xm36_u23.nsg13_hv_nmos[ctype]
print @n.xbgr.xm36_u24.nsg13_hv_nmos[ide]
print @n.xbgr.xm36_u24.nsg13_hv_nmos[ige]
print @n.xbgr.xm36_u24.nsg13_hv_nmos[ise]
print @n.xbgr.xm36_u24.nsg13_hv_nmos[ibe]
print @n.xbgr.xm36_u24.nsg13_hv_nmos[ctype]
print @n.xbgr.xm37_u2.nsg13_hv_nmos[ide]
print @n.xbgr.xm37_u2.nsg13_hv_nmos[ige]
print @n.xbgr.xm37_u2.nsg13_hv_nmos[ise]
print @n.xbgr.xm37_u2.nsg13_hv_nmos[ibe]
print @n.xbgr.xm37_u2.nsg13_hv_nmos[ctype]
print @n.xbgr.xm37_u3.nsg13_hv_nmos[ide]
print @n.xbgr.xm37_u3.nsg13_hv_nmos[ige]
print @n.xbgr.xm37_u3.nsg13_hv_nmos[ise]
print @n.xbgr.xm37_u3.nsg13_hv_nmos[ibe]
print @n.xbgr.xm37_u3.nsg13_hv_nmos[ctype]
print @n.xbgr.xm37_u4.nsg13_hv_nmos[ide]
print @n.xbgr.xm37_u4.nsg13_hv_nmos[ige]
print @n.xbgr.xm37_u4.nsg13_hv_nmos[ise]
print @n.xbgr.xm37_u4.nsg13_hv_nmos[ibe]
print @n.xbgr.xm37_u4.nsg13_hv_nmos[ctype]
print @n.xbgr.xm37_u5.nsg13_hv_nmos[ide]
print @n.xbgr.xm37_u5.nsg13_hv_nmos[ige]
print @n.xbgr.xm37_u5.nsg13_hv_nmos[ise]
print @n.xbgr.xm37_u5.nsg13_hv_nmos[ibe]
print @n.xbgr.xm37_u5.nsg13_hv_nmos[ctype]
print @n.xbgr.xm37_u6.nsg13_hv_nmos[ide]
print @n.xbgr.xm37_u6.nsg13_hv_nmos[ige]
print @n.xbgr.xm37_u6.nsg13_hv_nmos[ise]
print @n.xbgr.xm37_u6.nsg13_hv_nmos[ibe]
print @n.xbgr.xm37_u6.nsg13_hv_nmos[ctype]
print @n.xbgr.xm37_u7.nsg13_hv_nmos[ide]
print @n.xbgr.xm37_u7.nsg13_hv_nmos[ige]
print @n.xbgr.xm37_u7.nsg13_hv_nmos[ise]
print @n.xbgr.xm37_u7.nsg13_hv_nmos[ibe]
print @n.xbgr.xm37_u7.nsg13_hv_nmos[ctype]
print @n.xbgr.xm37_u8.nsg13_hv_nmos[ide]
print @n.xbgr.xm37_u8.nsg13_hv_nmos[ige]
print @n.xbgr.xm37_u8.nsg13_hv_nmos[ise]
print @n.xbgr.xm37_u8.nsg13_hv_nmos[ibe]
print @n.xbgr.xm37_u8.nsg13_hv_nmos[ctype]
print @n.xbgr.xm37_u9.nsg13_hv_nmos[ide]
print @n.xbgr.xm37_u9.nsg13_hv_nmos[ige]
print @n.xbgr.xm37_u9.nsg13_hv_nmos[ise]
print @n.xbgr.xm37_u9.nsg13_hv_nmos[ibe]
print @n.xbgr.xm37_u9.nsg13_hv_nmos[ctype]
print @n.xbgr.xm37_u10.nsg13_hv_nmos[ide]
print @n.xbgr.xm37_u10.nsg13_hv_nmos[ige]
print @n.xbgr.xm37_u10.nsg13_hv_nmos[ise]
print @n.xbgr.xm37_u10.nsg13_hv_nmos[ibe]
print @n.xbgr.xm37_u10.nsg13_hv_nmos[ctype]
print @n.xbgr.xm37_u11.nsg13_hv_nmos[ide]
print @n.xbgr.xm37_u11.nsg13_hv_nmos[ige]
print @n.xbgr.xm37_u11.nsg13_hv_nmos[ise]
print @n.xbgr.xm37_u11.nsg13_hv_nmos[ibe]
print @n.xbgr.xm37_u11.nsg13_hv_nmos[ctype]
print @n.xbgr.xm37_u12.nsg13_hv_nmos[ide]
print @n.xbgr.xm37_u12.nsg13_hv_nmos[ige]
print @n.xbgr.xm37_u12.nsg13_hv_nmos[ise]
print @n.xbgr.xm37_u12.nsg13_hv_nmos[ibe]
print @n.xbgr.xm37_u12.nsg13_hv_nmos[ctype]
print @n.xbgr.xm37_u13.nsg13_hv_nmos[ide]
print @n.xbgr.xm37_u13.nsg13_hv_nmos[ige]
print @n.xbgr.xm37_u13.nsg13_hv_nmos[ise]
print @n.xbgr.xm37_u13.nsg13_hv_nmos[ibe]
print @n.xbgr.xm37_u13.nsg13_hv_nmos[ctype]
print @n.xbgr.xm37_u14.nsg13_hv_nmos[ide]
print @n.xbgr.xm37_u14.nsg13_hv_nmos[ige]
print @n.xbgr.xm37_u14.nsg13_hv_nmos[ise]
print @n.xbgr.xm37_u14.nsg13_hv_nmos[ibe]
print @n.xbgr.xm37_u14.nsg13_hv_nmos[ctype]
print @n.xbgr.xm37_u15.nsg13_hv_nmos[ide]
print @n.xbgr.xm37_u15.nsg13_hv_nmos[ige]
print @n.xbgr.xm37_u15.nsg13_hv_nmos[ise]
print @n.xbgr.xm37_u15.nsg13_hv_nmos[ibe]
print @n.xbgr.xm37_u15.nsg13_hv_nmos[ctype]
print @n.xbgr.xm37_u16.nsg13_hv_nmos[ide]
print @n.xbgr.xm37_u16.nsg13_hv_nmos[ige]
print @n.xbgr.xm37_u16.nsg13_hv_nmos[ise]
print @n.xbgr.xm37_u16.nsg13_hv_nmos[ibe]
print @n.xbgr.xm37_u16.nsg13_hv_nmos[ctype]
print @n.xbgr.xm37_u17.nsg13_hv_nmos[ide]
print @n.xbgr.xm37_u17.nsg13_hv_nmos[ige]
print @n.xbgr.xm37_u17.nsg13_hv_nmos[ise]
print @n.xbgr.xm37_u17.nsg13_hv_nmos[ibe]
print @n.xbgr.xm37_u17.nsg13_hv_nmos[ctype]
print @n.xbgr.xm37_u18.nsg13_hv_nmos[ide]
print @n.xbgr.xm37_u18.nsg13_hv_nmos[ige]
print @n.xbgr.xm37_u18.nsg13_hv_nmos[ise]
print @n.xbgr.xm37_u18.nsg13_hv_nmos[ibe]
print @n.xbgr.xm37_u18.nsg13_hv_nmos[ctype]
print @n.xbgr.xm37_u19.nsg13_hv_nmos[ide]
print @n.xbgr.xm37_u19.nsg13_hv_nmos[ige]
print @n.xbgr.xm37_u19.nsg13_hv_nmos[ise]
print @n.xbgr.xm37_u19.nsg13_hv_nmos[ibe]
print @n.xbgr.xm37_u19.nsg13_hv_nmos[ctype]
print @n.xbgr.xm37_u20.nsg13_hv_nmos[ide]
print @n.xbgr.xm37_u20.nsg13_hv_nmos[ige]
print @n.xbgr.xm37_u20.nsg13_hv_nmos[ise]
print @n.xbgr.xm37_u20.nsg13_hv_nmos[ibe]
print @n.xbgr.xm37_u20.nsg13_hv_nmos[ctype]
print @n.xbgr.xm37_u21.nsg13_hv_nmos[ide]
print @n.xbgr.xm37_u21.nsg13_hv_nmos[ige]
print @n.xbgr.xm37_u21.nsg13_hv_nmos[ise]
print @n.xbgr.xm37_u21.nsg13_hv_nmos[ibe]
print @n.xbgr.xm37_u21.nsg13_hv_nmos[ctype]
print @n.xbgr.xm37_u22.nsg13_hv_nmos[ide]
print @n.xbgr.xm37_u22.nsg13_hv_nmos[ige]
print @n.xbgr.xm37_u22.nsg13_hv_nmos[ise]
print @n.xbgr.xm37_u22.nsg13_hv_nmos[ibe]
print @n.xbgr.xm37_u22.nsg13_hv_nmos[ctype]
print @n.xbgr.xm37_u23.nsg13_hv_nmos[ide]
print @n.xbgr.xm37_u23.nsg13_hv_nmos[ige]
print @n.xbgr.xm37_u23.nsg13_hv_nmos[ise]
print @n.xbgr.xm37_u23.nsg13_hv_nmos[ibe]
print @n.xbgr.xm37_u23.nsg13_hv_nmos[ctype]
print @n.xbgr.xm37_u24.nsg13_hv_nmos[ide]
print @n.xbgr.xm37_u24.nsg13_hv_nmos[ige]
print @n.xbgr.xm37_u24.nsg13_hv_nmos[ise]
print @n.xbgr.xm37_u24.nsg13_hv_nmos[ibe]
print @n.xbgr.xm37_u24.nsg13_hv_nmos[ctype]
print @n.xbgr.xm38_u2.nsg13_hv_pmos[ide]
print @n.xbgr.xm38_u2.nsg13_hv_pmos[ige]
print @n.xbgr.xm38_u2.nsg13_hv_pmos[ise]
print @n.xbgr.xm38_u2.nsg13_hv_pmos[ibe]
print @n.xbgr.xm38_u2.nsg13_hv_pmos[ctype]
print @n.xbgr.xm38_u3.nsg13_hv_pmos[ide]
print @n.xbgr.xm38_u3.nsg13_hv_pmos[ige]
print @n.xbgr.xm38_u3.nsg13_hv_pmos[ise]
print @n.xbgr.xm38_u3.nsg13_hv_pmos[ibe]
print @n.xbgr.xm38_u3.nsg13_hv_pmos[ctype]
print @n.xbgr.xm38_u4.nsg13_hv_pmos[ide]
print @n.xbgr.xm38_u4.nsg13_hv_pmos[ige]
print @n.xbgr.xm38_u4.nsg13_hv_pmos[ise]
print @n.xbgr.xm38_u4.nsg13_hv_pmos[ibe]
print @n.xbgr.xm38_u4.nsg13_hv_pmos[ctype]
print @n.xbgr.xm38_u5.nsg13_hv_pmos[ide]
print @n.xbgr.xm38_u5.nsg13_hv_pmos[ige]
print @n.xbgr.xm38_u5.nsg13_hv_pmos[ise]
print @n.xbgr.xm38_u5.nsg13_hv_pmos[ibe]
print @n.xbgr.xm38_u5.nsg13_hv_pmos[ctype]
print @n.xbgr.xm38_u6.nsg13_hv_pmos[ide]
print @n.xbgr.xm38_u6.nsg13_hv_pmos[ige]
print @n.xbgr.xm38_u6.nsg13_hv_pmos[ise]
print @n.xbgr.xm38_u6.nsg13_hv_pmos[ibe]
print @n.xbgr.xm38_u6.nsg13_hv_pmos[ctype]
print @n.xbgr.xm38_u7.nsg13_hv_pmos[ide]
print @n.xbgr.xm38_u7.nsg13_hv_pmos[ige]
print @n.xbgr.xm38_u7.nsg13_hv_pmos[ise]
print @n.xbgr.xm38_u7.nsg13_hv_pmos[ibe]
print @n.xbgr.xm38_u7.nsg13_hv_pmos[ctype]
print @n.xbgr.xm38_u8.nsg13_hv_pmos[ide]
print @n.xbgr.xm38_u8.nsg13_hv_pmos[ige]
print @n.xbgr.xm38_u8.nsg13_hv_pmos[ise]
print @n.xbgr.xm38_u8.nsg13_hv_pmos[ibe]
print @n.xbgr.xm38_u8.nsg13_hv_pmos[ctype]
print @n.xbgr.xm38_u9.nsg13_hv_pmos[ide]
print @n.xbgr.xm38_u9.nsg13_hv_pmos[ige]
print @n.xbgr.xm38_u9.nsg13_hv_pmos[ise]
print @n.xbgr.xm38_u9.nsg13_hv_pmos[ibe]
print @n.xbgr.xm38_u9.nsg13_hv_pmos[ctype]
print @n.xbgr.xm38_u10.nsg13_hv_pmos[ide]
print @n.xbgr.xm38_u10.nsg13_hv_pmos[ige]
print @n.xbgr.xm38_u10.nsg13_hv_pmos[ise]
print @n.xbgr.xm38_u10.nsg13_hv_pmos[ibe]
print @n.xbgr.xm38_u10.nsg13_hv_pmos[ctype]
print @n.xbgr.xm38_u11.nsg13_hv_pmos[ide]
print @n.xbgr.xm38_u11.nsg13_hv_pmos[ige]
print @n.xbgr.xm38_u11.nsg13_hv_pmos[ise]
print @n.xbgr.xm38_u11.nsg13_hv_pmos[ibe]
print @n.xbgr.xm38_u11.nsg13_hv_pmos[ctype]
print @n.xbgr.xm38_u12.nsg13_hv_pmos[ide]
print @n.xbgr.xm38_u12.nsg13_hv_pmos[ige]
print @n.xbgr.xm38_u12.nsg13_hv_pmos[ise]
print @n.xbgr.xm38_u12.nsg13_hv_pmos[ibe]
print @n.xbgr.xm38_u12.nsg13_hv_pmos[ctype]
print @n.xbgr.xm38_u13.nsg13_hv_pmos[ide]
print @n.xbgr.xm38_u13.nsg13_hv_pmos[ige]
print @n.xbgr.xm38_u13.nsg13_hv_pmos[ise]
print @n.xbgr.xm38_u13.nsg13_hv_pmos[ibe]
print @n.xbgr.xm38_u13.nsg13_hv_pmos[ctype]
print @n.xbgr.xm38_u14.nsg13_hv_pmos[ide]
print @n.xbgr.xm38_u14.nsg13_hv_pmos[ige]
print @n.xbgr.xm38_u14.nsg13_hv_pmos[ise]
print @n.xbgr.xm38_u14.nsg13_hv_pmos[ibe]
print @n.xbgr.xm38_u14.nsg13_hv_pmos[ctype]
print @n.xbgr.xm38_u15.nsg13_hv_pmos[ide]
print @n.xbgr.xm38_u15.nsg13_hv_pmos[ige]
print @n.xbgr.xm38_u15.nsg13_hv_pmos[ise]
print @n.xbgr.xm38_u15.nsg13_hv_pmos[ibe]
print @n.xbgr.xm38_u15.nsg13_hv_pmos[ctype]
print @n.xbgr.xm38_u16.nsg13_hv_pmos[ide]
print @n.xbgr.xm38_u16.nsg13_hv_pmos[ige]
print @n.xbgr.xm38_u16.nsg13_hv_pmos[ise]
print @n.xbgr.xm38_u16.nsg13_hv_pmos[ibe]
print @n.xbgr.xm38_u16.nsg13_hv_pmos[ctype]
print @n.xbgr.xm38_u17.nsg13_hv_pmos[ide]
print @n.xbgr.xm38_u17.nsg13_hv_pmos[ige]
print @n.xbgr.xm38_u17.nsg13_hv_pmos[ise]
print @n.xbgr.xm38_u17.nsg13_hv_pmos[ibe]
print @n.xbgr.xm38_u17.nsg13_hv_pmos[ctype]
print @n.xbgr.xm38_u18.nsg13_hv_pmos[ide]
print @n.xbgr.xm38_u18.nsg13_hv_pmos[ige]
print @n.xbgr.xm38_u18.nsg13_hv_pmos[ise]
print @n.xbgr.xm38_u18.nsg13_hv_pmos[ibe]
print @n.xbgr.xm38_u18.nsg13_hv_pmos[ctype]
print @n.xbgr.xm38_u19.nsg13_hv_pmos[ide]
print @n.xbgr.xm38_u19.nsg13_hv_pmos[ige]
print @n.xbgr.xm38_u19.nsg13_hv_pmos[ise]
print @n.xbgr.xm38_u19.nsg13_hv_pmos[ibe]
print @n.xbgr.xm38_u19.nsg13_hv_pmos[ctype]
print @n.xbgr.xm38_u20.nsg13_hv_pmos[ide]
print @n.xbgr.xm38_u20.nsg13_hv_pmos[ige]
print @n.xbgr.xm38_u20.nsg13_hv_pmos[ise]
print @n.xbgr.xm38_u20.nsg13_hv_pmos[ibe]
print @n.xbgr.xm38_u20.nsg13_hv_pmos[ctype]
print @n.xbgr.xm38_u21.nsg13_hv_pmos[ide]
print @n.xbgr.xm38_u21.nsg13_hv_pmos[ige]
print @n.xbgr.xm38_u21.nsg13_hv_pmos[ise]
print @n.xbgr.xm38_u21.nsg13_hv_pmos[ibe]
print @n.xbgr.xm38_u21.nsg13_hv_pmos[ctype]
print @n.xbgr.xm38_u22.nsg13_hv_pmos[ide]
print @n.xbgr.xm38_u22.nsg13_hv_pmos[ige]
print @n.xbgr.xm38_u22.nsg13_hv_pmos[ise]
print @n.xbgr.xm38_u22.nsg13_hv_pmos[ibe]
print @n.xbgr.xm38_u22.nsg13_hv_pmos[ctype]
print @n.xbgr.xm38_u23.nsg13_hv_pmos[ide]
print @n.xbgr.xm38_u23.nsg13_hv_pmos[ige]
print @n.xbgr.xm38_u23.nsg13_hv_pmos[ise]
print @n.xbgr.xm38_u23.nsg13_hv_pmos[ibe]
print @n.xbgr.xm38_u23.nsg13_hv_pmos[ctype]
print @n.xbgr.xm38_u24.nsg13_hv_pmos[ide]
print @n.xbgr.xm38_u24.nsg13_hv_pmos[ige]
print @n.xbgr.xm38_u24.nsg13_hv_pmos[ise]
print @n.xbgr.xm38_u24.nsg13_hv_pmos[ibe]
print @n.xbgr.xm38_u24.nsg13_hv_pmos[ctype]
print @n.xbgr.xm39_u2.nsg13_hv_pmos[ide]
print @n.xbgr.xm39_u2.nsg13_hv_pmos[ige]
print @n.xbgr.xm39_u2.nsg13_hv_pmos[ise]
print @n.xbgr.xm39_u2.nsg13_hv_pmos[ibe]
print @n.xbgr.xm39_u2.nsg13_hv_pmos[ctype]
print @n.xbgr.xm39_u3.nsg13_hv_pmos[ide]
print @n.xbgr.xm39_u3.nsg13_hv_pmos[ige]
print @n.xbgr.xm39_u3.nsg13_hv_pmos[ise]
print @n.xbgr.xm39_u3.nsg13_hv_pmos[ibe]
print @n.xbgr.xm39_u3.nsg13_hv_pmos[ctype]
print @n.xbgr.xm39_u4.nsg13_hv_pmos[ide]
print @n.xbgr.xm39_u4.nsg13_hv_pmos[ige]
print @n.xbgr.xm39_u4.nsg13_hv_pmos[ise]
print @n.xbgr.xm39_u4.nsg13_hv_pmos[ibe]
print @n.xbgr.xm39_u4.nsg13_hv_pmos[ctype]
print @n.xbgr.xm39_u5.nsg13_hv_pmos[ide]
print @n.xbgr.xm39_u5.nsg13_hv_pmos[ige]
print @n.xbgr.xm39_u5.nsg13_hv_pmos[ise]
print @n.xbgr.xm39_u5.nsg13_hv_pmos[ibe]
print @n.xbgr.xm39_u5.nsg13_hv_pmos[ctype]
print @n.xbgr.xm39_u6.nsg13_hv_pmos[ide]
print @n.xbgr.xm39_u6.nsg13_hv_pmos[ige]
print @n.xbgr.xm39_u6.nsg13_hv_pmos[ise]
print @n.xbgr.xm39_u6.nsg13_hv_pmos[ibe]
print @n.xbgr.xm39_u6.nsg13_hv_pmos[ctype]
print @n.xbgr.xm39_u7.nsg13_hv_pmos[ide]
print @n.xbgr.xm39_u7.nsg13_hv_pmos[ige]
print @n.xbgr.xm39_u7.nsg13_hv_pmos[ise]
print @n.xbgr.xm39_u7.nsg13_hv_pmos[ibe]
print @n.xbgr.xm39_u7.nsg13_hv_pmos[ctype]
print @n.xbgr.xm39_u8.nsg13_hv_pmos[ide]
print @n.xbgr.xm39_u8.nsg13_hv_pmos[ige]
print @n.xbgr.xm39_u8.nsg13_hv_pmos[ise]
print @n.xbgr.xm39_u8.nsg13_hv_pmos[ibe]
print @n.xbgr.xm39_u8.nsg13_hv_pmos[ctype]
print @n.xbgr.xm39_u9.nsg13_hv_pmos[ide]
print @n.xbgr.xm39_u9.nsg13_hv_pmos[ige]
print @n.xbgr.xm39_u9.nsg13_hv_pmos[ise]
print @n.xbgr.xm39_u9.nsg13_hv_pmos[ibe]
print @n.xbgr.xm39_u9.nsg13_hv_pmos[ctype]
print @n.xbgr.xm39_u10.nsg13_hv_pmos[ide]
print @n.xbgr.xm39_u10.nsg13_hv_pmos[ige]
print @n.xbgr.xm39_u10.nsg13_hv_pmos[ise]
print @n.xbgr.xm39_u10.nsg13_hv_pmos[ibe]
print @n.xbgr.xm39_u10.nsg13_hv_pmos[ctype]
print @n.xbgr.xm39_u11.nsg13_hv_pmos[ide]
print @n.xbgr.xm39_u11.nsg13_hv_pmos[ige]
print @n.xbgr.xm39_u11.nsg13_hv_pmos[ise]
print @n.xbgr.xm39_u11.nsg13_hv_pmos[ibe]
print @n.xbgr.xm39_u11.nsg13_hv_pmos[ctype]
print @n.xbgr.xm39_u12.nsg13_hv_pmos[ide]
print @n.xbgr.xm39_u12.nsg13_hv_pmos[ige]
print @n.xbgr.xm39_u12.nsg13_hv_pmos[ise]
print @n.xbgr.xm39_u12.nsg13_hv_pmos[ibe]
print @n.xbgr.xm39_u12.nsg13_hv_pmos[ctype]
print @n.xbgr.xm39_u13.nsg13_hv_pmos[ide]
print @n.xbgr.xm39_u13.nsg13_hv_pmos[ige]
print @n.xbgr.xm39_u13.nsg13_hv_pmos[ise]
print @n.xbgr.xm39_u13.nsg13_hv_pmos[ibe]
print @n.xbgr.xm39_u13.nsg13_hv_pmos[ctype]
print @n.xbgr.xm39_u14.nsg13_hv_pmos[ide]
print @n.xbgr.xm39_u14.nsg13_hv_pmos[ige]
print @n.xbgr.xm39_u14.nsg13_hv_pmos[ise]
print @n.xbgr.xm39_u14.nsg13_hv_pmos[ibe]
print @n.xbgr.xm39_u14.nsg13_hv_pmos[ctype]
print @n.xbgr.xm39_u15.nsg13_hv_pmos[ide]
print @n.xbgr.xm39_u15.nsg13_hv_pmos[ige]
print @n.xbgr.xm39_u15.nsg13_hv_pmos[ise]
print @n.xbgr.xm39_u15.nsg13_hv_pmos[ibe]
print @n.xbgr.xm39_u15.nsg13_hv_pmos[ctype]
print @n.xbgr.xm39_u16.nsg13_hv_pmos[ide]
print @n.xbgr.xm39_u16.nsg13_hv_pmos[ige]
print @n.xbgr.xm39_u16.nsg13_hv_pmos[ise]
print @n.xbgr.xm39_u16.nsg13_hv_pmos[ibe]
print @n.xbgr.xm39_u16.nsg13_hv_pmos[ctype]
print @n.xbgr.xm39_u17.nsg13_hv_pmos[ide]
print @n.xbgr.xm39_u17.nsg13_hv_pmos[ige]
print @n.xbgr.xm39_u17.nsg13_hv_pmos[ise]
print @n.xbgr.xm39_u17.nsg13_hv_pmos[ibe]
print @n.xbgr.xm39_u17.nsg13_hv_pmos[ctype]
print @n.xbgr.xm39_u18.nsg13_hv_pmos[ide]
print @n.xbgr.xm39_u18.nsg13_hv_pmos[ige]
print @n.xbgr.xm39_u18.nsg13_hv_pmos[ise]
print @n.xbgr.xm39_u18.nsg13_hv_pmos[ibe]
print @n.xbgr.xm39_u18.nsg13_hv_pmos[ctype]
print @n.xbgr.xm39_u19.nsg13_hv_pmos[ide]
print @n.xbgr.xm39_u19.nsg13_hv_pmos[ige]
print @n.xbgr.xm39_u19.nsg13_hv_pmos[ise]
print @n.xbgr.xm39_u19.nsg13_hv_pmos[ibe]
print @n.xbgr.xm39_u19.nsg13_hv_pmos[ctype]
print @n.xbgr.xm39_u20.nsg13_hv_pmos[ide]
print @n.xbgr.xm39_u20.nsg13_hv_pmos[ige]
print @n.xbgr.xm39_u20.nsg13_hv_pmos[ise]
print @n.xbgr.xm39_u20.nsg13_hv_pmos[ibe]
print @n.xbgr.xm39_u20.nsg13_hv_pmos[ctype]
print @n.xbgr.xm39_u21.nsg13_hv_pmos[ide]
print @n.xbgr.xm39_u21.nsg13_hv_pmos[ige]
print @n.xbgr.xm39_u21.nsg13_hv_pmos[ise]
print @n.xbgr.xm39_u21.nsg13_hv_pmos[ibe]
print @n.xbgr.xm39_u21.nsg13_hv_pmos[ctype]
print @n.xbgr.xm39_u22.nsg13_hv_pmos[ide]
print @n.xbgr.xm39_u22.nsg13_hv_pmos[ige]
print @n.xbgr.xm39_u22.nsg13_hv_pmos[ise]
print @n.xbgr.xm39_u22.nsg13_hv_pmos[ibe]
print @n.xbgr.xm39_u22.nsg13_hv_pmos[ctype]
print @n.xbgr.xm39_u23.nsg13_hv_pmos[ide]
print @n.xbgr.xm39_u23.nsg13_hv_pmos[ige]
print @n.xbgr.xm39_u23.nsg13_hv_pmos[ise]
print @n.xbgr.xm39_u23.nsg13_hv_pmos[ibe]
print @n.xbgr.xm39_u23.nsg13_hv_pmos[ctype]
print @n.xbgr.xm39_u24.nsg13_hv_pmos[ide]
print @n.xbgr.xm39_u24.nsg13_hv_pmos[ige]
print @n.xbgr.xm39_u24.nsg13_hv_pmos[ise]
print @n.xbgr.xm39_u24.nsg13_hv_pmos[ibe]
print @n.xbgr.xm39_u24.nsg13_hv_pmos[ctype]
print @n.xbgr.xm41_u2.nsg13_hv_pmos[ide]
print @n.xbgr.xm41_u2.nsg13_hv_pmos[ige]
print @n.xbgr.xm41_u2.nsg13_hv_pmos[ise]
print @n.xbgr.xm41_u2.nsg13_hv_pmos[ibe]
print @n.xbgr.xm41_u2.nsg13_hv_pmos[ctype]
print @n.xbgr.xm41_u3.nsg13_hv_pmos[ide]
print @n.xbgr.xm41_u3.nsg13_hv_pmos[ige]
print @n.xbgr.xm41_u3.nsg13_hv_pmos[ise]
print @n.xbgr.xm41_u3.nsg13_hv_pmos[ibe]
print @n.xbgr.xm41_u3.nsg13_hv_pmos[ctype]
print @n.xbgr.xm41_u4.nsg13_hv_pmos[ide]
print @n.xbgr.xm41_u4.nsg13_hv_pmos[ige]
print @n.xbgr.xm41_u4.nsg13_hv_pmos[ise]
print @n.xbgr.xm41_u4.nsg13_hv_pmos[ibe]
print @n.xbgr.xm41_u4.nsg13_hv_pmos[ctype]
print @n.xbgr.xm41_u5.nsg13_hv_pmos[ide]
print @n.xbgr.xm41_u5.nsg13_hv_pmos[ige]
print @n.xbgr.xm41_u5.nsg13_hv_pmos[ise]
print @n.xbgr.xm41_u5.nsg13_hv_pmos[ibe]
print @n.xbgr.xm41_u5.nsg13_hv_pmos[ctype]
print @n.xbgr.xm41_u6.nsg13_hv_pmos[ide]
print @n.xbgr.xm41_u6.nsg13_hv_pmos[ige]
print @n.xbgr.xm41_u6.nsg13_hv_pmos[ise]
print @n.xbgr.xm41_u6.nsg13_hv_pmos[ibe]
print @n.xbgr.xm41_u6.nsg13_hv_pmos[ctype]
print @n.xbgr.xm41_u7.nsg13_hv_pmos[ide]
print @n.xbgr.xm41_u7.nsg13_hv_pmos[ige]
print @n.xbgr.xm41_u7.nsg13_hv_pmos[ise]
print @n.xbgr.xm41_u7.nsg13_hv_pmos[ibe]
print @n.xbgr.xm41_u7.nsg13_hv_pmos[ctype]
print @n.xbgr.xm41_u8.nsg13_hv_pmos[ide]
print @n.xbgr.xm41_u8.nsg13_hv_pmos[ige]
print @n.xbgr.xm41_u8.nsg13_hv_pmos[ise]
print @n.xbgr.xm41_u8.nsg13_hv_pmos[ibe]
print @n.xbgr.xm41_u8.nsg13_hv_pmos[ctype]
print @n.xbgr.xm41_u9.nsg13_hv_pmos[ide]
print @n.xbgr.xm41_u9.nsg13_hv_pmos[ige]
print @n.xbgr.xm41_u9.nsg13_hv_pmos[ise]
print @n.xbgr.xm41_u9.nsg13_hv_pmos[ibe]
print @n.xbgr.xm41_u9.nsg13_hv_pmos[ctype]
print @n.xbgr.xm41_u10.nsg13_hv_pmos[ide]
print @n.xbgr.xm41_u10.nsg13_hv_pmos[ige]
print @n.xbgr.xm41_u10.nsg13_hv_pmos[ise]
print @n.xbgr.xm41_u10.nsg13_hv_pmos[ibe]
print @n.xbgr.xm41_u10.nsg13_hv_pmos[ctype]
print @n.xbgr.xm41_u11.nsg13_hv_pmos[ide]
print @n.xbgr.xm41_u11.nsg13_hv_pmos[ige]
print @n.xbgr.xm41_u11.nsg13_hv_pmos[ise]
print @n.xbgr.xm41_u11.nsg13_hv_pmos[ibe]
print @n.xbgr.xm41_u11.nsg13_hv_pmos[ctype]
print @n.xbgr.xm41_u12.nsg13_hv_pmos[ide]
print @n.xbgr.xm41_u12.nsg13_hv_pmos[ige]
print @n.xbgr.xm41_u12.nsg13_hv_pmos[ise]
print @n.xbgr.xm41_u12.nsg13_hv_pmos[ibe]
print @n.xbgr.xm41_u12.nsg13_hv_pmos[ctype]
print @n.xbgr.xm41_u13.nsg13_hv_pmos[ide]
print @n.xbgr.xm41_u13.nsg13_hv_pmos[ige]
print @n.xbgr.xm41_u13.nsg13_hv_pmos[ise]
print @n.xbgr.xm41_u13.nsg13_hv_pmos[ibe]
print @n.xbgr.xm41_u13.nsg13_hv_pmos[ctype]
print @n.xbgr.xm41_u14.nsg13_hv_pmos[ide]
print @n.xbgr.xm41_u14.nsg13_hv_pmos[ige]
print @n.xbgr.xm41_u14.nsg13_hv_pmos[ise]
print @n.xbgr.xm41_u14.nsg13_hv_pmos[ibe]
print @n.xbgr.xm41_u14.nsg13_hv_pmos[ctype]
print @n.xbgr.xm41_u15.nsg13_hv_pmos[ide]
print @n.xbgr.xm41_u15.nsg13_hv_pmos[ige]
print @n.xbgr.xm41_u15.nsg13_hv_pmos[ise]
print @n.xbgr.xm41_u15.nsg13_hv_pmos[ibe]
print @n.xbgr.xm41_u15.nsg13_hv_pmos[ctype]
print @n.xbgr.xm41_u16.nsg13_hv_pmos[ide]
print @n.xbgr.xm41_u16.nsg13_hv_pmos[ige]
print @n.xbgr.xm41_u16.nsg13_hv_pmos[ise]
print @n.xbgr.xm41_u16.nsg13_hv_pmos[ibe]
print @n.xbgr.xm41_u16.nsg13_hv_pmos[ctype]
print @n.xbgr.xm41_u17.nsg13_hv_pmos[ide]
print @n.xbgr.xm41_u17.nsg13_hv_pmos[ige]
print @n.xbgr.xm41_u17.nsg13_hv_pmos[ise]
print @n.xbgr.xm41_u17.nsg13_hv_pmos[ibe]
print @n.xbgr.xm41_u17.nsg13_hv_pmos[ctype]
print @n.xbgr.xm41_u18.nsg13_hv_pmos[ide]
print @n.xbgr.xm41_u18.nsg13_hv_pmos[ige]
print @n.xbgr.xm41_u18.nsg13_hv_pmos[ise]
print @n.xbgr.xm41_u18.nsg13_hv_pmos[ibe]
print @n.xbgr.xm41_u18.nsg13_hv_pmos[ctype]
print @n.xbgr.xm41_u19.nsg13_hv_pmos[ide]
print @n.xbgr.xm41_u19.nsg13_hv_pmos[ige]
print @n.xbgr.xm41_u19.nsg13_hv_pmos[ise]
print @n.xbgr.xm41_u19.nsg13_hv_pmos[ibe]
print @n.xbgr.xm41_u19.nsg13_hv_pmos[ctype]
print @n.xbgr.xm41_u20.nsg13_hv_pmos[ide]
print @n.xbgr.xm41_u20.nsg13_hv_pmos[ige]
print @n.xbgr.xm41_u20.nsg13_hv_pmos[ise]
print @n.xbgr.xm41_u20.nsg13_hv_pmos[ibe]
print @n.xbgr.xm41_u20.nsg13_hv_pmos[ctype]
print @n.xbgr.xm41_u21.nsg13_hv_pmos[ide]
print @n.xbgr.xm41_u21.nsg13_hv_pmos[ige]
print @n.xbgr.xm41_u21.nsg13_hv_pmos[ise]
print @n.xbgr.xm41_u21.nsg13_hv_pmos[ibe]
print @n.xbgr.xm41_u21.nsg13_hv_pmos[ctype]
print @n.xbgr.xm41_u22.nsg13_hv_pmos[ide]
print @n.xbgr.xm41_u22.nsg13_hv_pmos[ige]
print @n.xbgr.xm41_u22.nsg13_hv_pmos[ise]
print @n.xbgr.xm41_u22.nsg13_hv_pmos[ibe]
print @n.xbgr.xm41_u22.nsg13_hv_pmos[ctype]
print @n.xbgr.xm41_u23.nsg13_hv_pmos[ide]
print @n.xbgr.xm41_u23.nsg13_hv_pmos[ige]
print @n.xbgr.xm41_u23.nsg13_hv_pmos[ise]
print @n.xbgr.xm41_u23.nsg13_hv_pmos[ibe]
print @n.xbgr.xm41_u23.nsg13_hv_pmos[ctype]
print @n.xbgr.xm41_u24.nsg13_hv_pmos[ide]
print @n.xbgr.xm41_u24.nsg13_hv_pmos[ige]
print @n.xbgr.xm41_u24.nsg13_hv_pmos[ise]
print @n.xbgr.xm41_u24.nsg13_hv_pmos[ibe]
print @n.xbgr.xm41_u24.nsg13_hv_pmos[ctype]
print @n.xbgr.xm43_u2.nsg13_hv_pmos[ide]
print @n.xbgr.xm43_u2.nsg13_hv_pmos[ige]
print @n.xbgr.xm43_u2.nsg13_hv_pmos[ise]
print @n.xbgr.xm43_u2.nsg13_hv_pmos[ibe]
print @n.xbgr.xm43_u2.nsg13_hv_pmos[ctype]
print @n.xbgr.xm43_u3.nsg13_hv_pmos[ide]
print @n.xbgr.xm43_u3.nsg13_hv_pmos[ige]
print @n.xbgr.xm43_u3.nsg13_hv_pmos[ise]
print @n.xbgr.xm43_u3.nsg13_hv_pmos[ibe]
print @n.xbgr.xm43_u3.nsg13_hv_pmos[ctype]
print @n.xbgr.xm43_u4.nsg13_hv_pmos[ide]
print @n.xbgr.xm43_u4.nsg13_hv_pmos[ige]
print @n.xbgr.xm43_u4.nsg13_hv_pmos[ise]
print @n.xbgr.xm43_u4.nsg13_hv_pmos[ibe]
print @n.xbgr.xm43_u4.nsg13_hv_pmos[ctype]
print @n.xbgr.xm44_u2.nsg13_hv_pmos[ide]
print @n.xbgr.xm44_u2.nsg13_hv_pmos[ige]
print @n.xbgr.xm44_u2.nsg13_hv_pmos[ise]
print @n.xbgr.xm44_u2.nsg13_hv_pmos[ibe]
print @n.xbgr.xm44_u2.nsg13_hv_pmos[ctype]
print @n.xbgr.xm44_u3.nsg13_hv_pmos[ide]
print @n.xbgr.xm44_u3.nsg13_hv_pmos[ige]
print @n.xbgr.xm44_u3.nsg13_hv_pmos[ise]
print @n.xbgr.xm44_u3.nsg13_hv_pmos[ibe]
print @n.xbgr.xm44_u3.nsg13_hv_pmos[ctype]
print @n.xbgr.xm44_u4.nsg13_hv_pmos[ide]
print @n.xbgr.xm44_u4.nsg13_hv_pmos[ige]
print @n.xbgr.xm44_u4.nsg13_hv_pmos[ise]
print @n.xbgr.xm44_u4.nsg13_hv_pmos[ibe]
print @n.xbgr.xm44_u4.nsg13_hv_pmos[ctype]
print @n.xbgr.xm45_u2.nsg13_hv_pmos[ide]
print @n.xbgr.xm45_u2.nsg13_hv_pmos[ige]
print @n.xbgr.xm45_u2.nsg13_hv_pmos[ise]
print @n.xbgr.xm45_u2.nsg13_hv_pmos[ibe]
print @n.xbgr.xm45_u2.nsg13_hv_pmos[ctype]
print @n.xbgr.xm45_u3.nsg13_hv_pmos[ide]
print @n.xbgr.xm45_u3.nsg13_hv_pmos[ige]
print @n.xbgr.xm45_u3.nsg13_hv_pmos[ise]
print @n.xbgr.xm45_u3.nsg13_hv_pmos[ibe]
print @n.xbgr.xm45_u3.nsg13_hv_pmos[ctype]
print @n.xbgr.xm45_u4.nsg13_hv_pmos[ide]
print @n.xbgr.xm45_u4.nsg13_hv_pmos[ige]
print @n.xbgr.xm45_u4.nsg13_hv_pmos[ise]
print @n.xbgr.xm45_u4.nsg13_hv_pmos[ibe]
print @n.xbgr.xm45_u4.nsg13_hv_pmos[ctype]
print @n.xbgr.xm45_u5.nsg13_hv_pmos[ide]
print @n.xbgr.xm45_u5.nsg13_hv_pmos[ige]
print @n.xbgr.xm45_u5.nsg13_hv_pmos[ise]
print @n.xbgr.xm45_u5.nsg13_hv_pmos[ibe]
print @n.xbgr.xm45_u5.nsg13_hv_pmos[ctype]
print @n.xbgr.xm45_u6.nsg13_hv_pmos[ide]
print @n.xbgr.xm45_u6.nsg13_hv_pmos[ige]
print @n.xbgr.xm45_u6.nsg13_hv_pmos[ise]
print @n.xbgr.xm45_u6.nsg13_hv_pmos[ibe]
print @n.xbgr.xm45_u6.nsg13_hv_pmos[ctype]
print @n.xbgr.xm45_u7.nsg13_hv_pmos[ide]
print @n.xbgr.xm45_u7.nsg13_hv_pmos[ige]
print @n.xbgr.xm45_u7.nsg13_hv_pmos[ise]
print @n.xbgr.xm45_u7.nsg13_hv_pmos[ibe]
print @n.xbgr.xm45_u7.nsg13_hv_pmos[ctype]
print @n.xbgr.xm45_u8.nsg13_hv_pmos[ide]
print @n.xbgr.xm45_u8.nsg13_hv_pmos[ige]
print @n.xbgr.xm45_u8.nsg13_hv_pmos[ise]
print @n.xbgr.xm45_u8.nsg13_hv_pmos[ibe]
print @n.xbgr.xm45_u8.nsg13_hv_pmos[ctype]
print @n.xbgr.xm45_u9.nsg13_hv_pmos[ide]
print @n.xbgr.xm45_u9.nsg13_hv_pmos[ige]
print @n.xbgr.xm45_u9.nsg13_hv_pmos[ise]
print @n.xbgr.xm45_u9.nsg13_hv_pmos[ibe]
print @n.xbgr.xm45_u9.nsg13_hv_pmos[ctype]
print @n.xbgr.xm45_u10.nsg13_hv_pmos[ide]
print @n.xbgr.xm45_u10.nsg13_hv_pmos[ige]
print @n.xbgr.xm45_u10.nsg13_hv_pmos[ise]
print @n.xbgr.xm45_u10.nsg13_hv_pmos[ibe]
print @n.xbgr.xm45_u10.nsg13_hv_pmos[ctype]
print @n.xbgr.xm45_u11.nsg13_hv_pmos[ide]
print @n.xbgr.xm45_u11.nsg13_hv_pmos[ige]
print @n.xbgr.xm45_u11.nsg13_hv_pmos[ise]
print @n.xbgr.xm45_u11.nsg13_hv_pmos[ibe]
print @n.xbgr.xm45_u11.nsg13_hv_pmos[ctype]
print @n.xbgr.xm45_u12.nsg13_hv_pmos[ide]
print @n.xbgr.xm45_u12.nsg13_hv_pmos[ige]
print @n.xbgr.xm45_u12.nsg13_hv_pmos[ise]
print @n.xbgr.xm45_u12.nsg13_hv_pmos[ibe]
print @n.xbgr.xm45_u12.nsg13_hv_pmos[ctype]
print @n.xbgr.xm45_u13.nsg13_hv_pmos[ide]
print @n.xbgr.xm45_u13.nsg13_hv_pmos[ige]
print @n.xbgr.xm45_u13.nsg13_hv_pmos[ise]
print @n.xbgr.xm45_u13.nsg13_hv_pmos[ibe]
print @n.xbgr.xm45_u13.nsg13_hv_pmos[ctype]
print @n.xbgr.xm45_u14.nsg13_hv_pmos[ide]
print @n.xbgr.xm45_u14.nsg13_hv_pmos[ige]
print @n.xbgr.xm45_u14.nsg13_hv_pmos[ise]
print @n.xbgr.xm45_u14.nsg13_hv_pmos[ibe]
print @n.xbgr.xm45_u14.nsg13_hv_pmos[ctype]
print @n.xbgr.xm45_u15.nsg13_hv_pmos[ide]
print @n.xbgr.xm45_u15.nsg13_hv_pmos[ige]
print @n.xbgr.xm45_u15.nsg13_hv_pmos[ise]
print @n.xbgr.xm45_u15.nsg13_hv_pmos[ibe]
print @n.xbgr.xm45_u15.nsg13_hv_pmos[ctype]
print @n.xbgr.xm45_u16.nsg13_hv_pmos[ide]
print @n.xbgr.xm45_u16.nsg13_hv_pmos[ige]
print @n.xbgr.xm45_u16.nsg13_hv_pmos[ise]
print @n.xbgr.xm45_u16.nsg13_hv_pmos[ibe]
print @n.xbgr.xm45_u16.nsg13_hv_pmos[ctype]
print @n.xbgr.xm45_u17.nsg13_hv_pmos[ide]
print @n.xbgr.xm45_u17.nsg13_hv_pmos[ige]
print @n.xbgr.xm45_u17.nsg13_hv_pmos[ise]
print @n.xbgr.xm45_u17.nsg13_hv_pmos[ibe]
print @n.xbgr.xm45_u17.nsg13_hv_pmos[ctype]
print @n.xbgr.xm45_u18.nsg13_hv_pmos[ide]
print @n.xbgr.xm45_u18.nsg13_hv_pmos[ige]
print @n.xbgr.xm45_u18.nsg13_hv_pmos[ise]
print @n.xbgr.xm45_u18.nsg13_hv_pmos[ibe]
print @n.xbgr.xm45_u18.nsg13_hv_pmos[ctype]
print @n.xbgr.xm45_u19.nsg13_hv_pmos[ide]
print @n.xbgr.xm45_u19.nsg13_hv_pmos[ige]
print @n.xbgr.xm45_u19.nsg13_hv_pmos[ise]
print @n.xbgr.xm45_u19.nsg13_hv_pmos[ibe]
print @n.xbgr.xm45_u19.nsg13_hv_pmos[ctype]
print @n.xbgr.xm45_u20.nsg13_hv_pmos[ide]
print @n.xbgr.xm45_u20.nsg13_hv_pmos[ige]
print @n.xbgr.xm45_u20.nsg13_hv_pmos[ise]
print @n.xbgr.xm45_u20.nsg13_hv_pmos[ibe]
print @n.xbgr.xm45_u20.nsg13_hv_pmos[ctype]
print @n.xbgr.xm45_u21.nsg13_hv_pmos[ide]
print @n.xbgr.xm45_u21.nsg13_hv_pmos[ige]
print @n.xbgr.xm45_u21.nsg13_hv_pmos[ise]
print @n.xbgr.xm45_u21.nsg13_hv_pmos[ibe]
print @n.xbgr.xm45_u21.nsg13_hv_pmos[ctype]
print @n.xbgr.xm45_u22.nsg13_hv_pmos[ide]
print @n.xbgr.xm45_u22.nsg13_hv_pmos[ige]
print @n.xbgr.xm45_u22.nsg13_hv_pmos[ise]
print @n.xbgr.xm45_u22.nsg13_hv_pmos[ibe]
print @n.xbgr.xm45_u22.nsg13_hv_pmos[ctype]
print @n.xbgr.xm45_u23.nsg13_hv_pmos[ide]
print @n.xbgr.xm45_u23.nsg13_hv_pmos[ige]
print @n.xbgr.xm45_u23.nsg13_hv_pmos[ise]
print @n.xbgr.xm45_u23.nsg13_hv_pmos[ibe]
print @n.xbgr.xm45_u23.nsg13_hv_pmos[ctype]
print @n.xbgr.xm45_u24.nsg13_hv_pmos[ide]
print @n.xbgr.xm45_u24.nsg13_hv_pmos[ige]
print @n.xbgr.xm45_u24.nsg13_hv_pmos[ise]
print @n.xbgr.xm45_u24.nsg13_hv_pmos[ibe]
print @n.xbgr.xm45_u24.nsg13_hv_pmos[ctype]
print @n.xbgr.xm47_u2.nsg13_hv_pmos[ide]
print @n.xbgr.xm47_u2.nsg13_hv_pmos[ige]
print @n.xbgr.xm47_u2.nsg13_hv_pmos[ise]
print @n.xbgr.xm47_u2.nsg13_hv_pmos[ibe]
print @n.xbgr.xm47_u2.nsg13_hv_pmos[ctype]
print @n.xbgr.xm47_u3.nsg13_hv_pmos[ide]
print @n.xbgr.xm47_u3.nsg13_hv_pmos[ige]
print @n.xbgr.xm47_u3.nsg13_hv_pmos[ise]
print @n.xbgr.xm47_u3.nsg13_hv_pmos[ibe]
print @n.xbgr.xm47_u3.nsg13_hv_pmos[ctype]
print @n.xbgr.xm47_u4.nsg13_hv_pmos[ide]
print @n.xbgr.xm47_u4.nsg13_hv_pmos[ige]
print @n.xbgr.xm47_u4.nsg13_hv_pmos[ise]
print @n.xbgr.xm47_u4.nsg13_hv_pmos[ibe]
print @n.xbgr.xm47_u4.nsg13_hv_pmos[ctype]
print @n.xbgr.xm47_u5.nsg13_hv_pmos[ide]
print @n.xbgr.xm47_u5.nsg13_hv_pmos[ige]
print @n.xbgr.xm47_u5.nsg13_hv_pmos[ise]
print @n.xbgr.xm47_u5.nsg13_hv_pmos[ibe]
print @n.xbgr.xm47_u5.nsg13_hv_pmos[ctype]
print @n.xbgr.xm47_u6.nsg13_hv_pmos[ide]
print @n.xbgr.xm47_u6.nsg13_hv_pmos[ige]
print @n.xbgr.xm47_u6.nsg13_hv_pmos[ise]
print @n.xbgr.xm47_u6.nsg13_hv_pmos[ibe]
print @n.xbgr.xm47_u6.nsg13_hv_pmos[ctype]
print @n.xbgr.xm47_u7.nsg13_hv_pmos[ide]
print @n.xbgr.xm47_u7.nsg13_hv_pmos[ige]
print @n.xbgr.xm47_u7.nsg13_hv_pmos[ise]
print @n.xbgr.xm47_u7.nsg13_hv_pmos[ibe]
print @n.xbgr.xm47_u7.nsg13_hv_pmos[ctype]
print @n.xbgr.xm47_u8.nsg13_hv_pmos[ide]
print @n.xbgr.xm47_u8.nsg13_hv_pmos[ige]
print @n.xbgr.xm47_u8.nsg13_hv_pmos[ise]
print @n.xbgr.xm47_u8.nsg13_hv_pmos[ibe]
print @n.xbgr.xm47_u8.nsg13_hv_pmos[ctype]
print @n.xbgr.xm47_u9.nsg13_hv_pmos[ide]
print @n.xbgr.xm47_u9.nsg13_hv_pmos[ige]
print @n.xbgr.xm47_u9.nsg13_hv_pmos[ise]
print @n.xbgr.xm47_u9.nsg13_hv_pmos[ibe]
print @n.xbgr.xm47_u9.nsg13_hv_pmos[ctype]
print @n.xbgr.xm47_u10.nsg13_hv_pmos[ide]
print @n.xbgr.xm47_u10.nsg13_hv_pmos[ige]
print @n.xbgr.xm47_u10.nsg13_hv_pmos[ise]
print @n.xbgr.xm47_u10.nsg13_hv_pmos[ibe]
print @n.xbgr.xm47_u10.nsg13_hv_pmos[ctype]
print @n.xbgr.xm47_u11.nsg13_hv_pmos[ide]
print @n.xbgr.xm47_u11.nsg13_hv_pmos[ige]
print @n.xbgr.xm47_u11.nsg13_hv_pmos[ise]
print @n.xbgr.xm47_u11.nsg13_hv_pmos[ibe]
print @n.xbgr.xm47_u11.nsg13_hv_pmos[ctype]
print @n.xbgr.xm47_u12.nsg13_hv_pmos[ide]
print @n.xbgr.xm47_u12.nsg13_hv_pmos[ige]
print @n.xbgr.xm47_u12.nsg13_hv_pmos[ise]
print @n.xbgr.xm47_u12.nsg13_hv_pmos[ibe]
print @n.xbgr.xm47_u12.nsg13_hv_pmos[ctype]
print @n.xbgr.xm47_u13.nsg13_hv_pmos[ide]
print @n.xbgr.xm47_u13.nsg13_hv_pmos[ige]
print @n.xbgr.xm47_u13.nsg13_hv_pmos[ise]
print @n.xbgr.xm47_u13.nsg13_hv_pmos[ibe]
print @n.xbgr.xm47_u13.nsg13_hv_pmos[ctype]
print @n.xbgr.xm47_u14.nsg13_hv_pmos[ide]
print @n.xbgr.xm47_u14.nsg13_hv_pmos[ige]
print @n.xbgr.xm47_u14.nsg13_hv_pmos[ise]
print @n.xbgr.xm47_u14.nsg13_hv_pmos[ibe]
print @n.xbgr.xm47_u14.nsg13_hv_pmos[ctype]
print @n.xbgr.xm47_u15.nsg13_hv_pmos[ide]
print @n.xbgr.xm47_u15.nsg13_hv_pmos[ige]
print @n.xbgr.xm47_u15.nsg13_hv_pmos[ise]
print @n.xbgr.xm47_u15.nsg13_hv_pmos[ibe]
print @n.xbgr.xm47_u15.nsg13_hv_pmos[ctype]
print @n.xbgr.xm47_u16.nsg13_hv_pmos[ide]
print @n.xbgr.xm47_u16.nsg13_hv_pmos[ige]
print @n.xbgr.xm47_u16.nsg13_hv_pmos[ise]
print @n.xbgr.xm47_u16.nsg13_hv_pmos[ibe]
print @n.xbgr.xm47_u16.nsg13_hv_pmos[ctype]
print @n.xbgr.xm47_u17.nsg13_hv_pmos[ide]
print @n.xbgr.xm47_u17.nsg13_hv_pmos[ige]
print @n.xbgr.xm47_u17.nsg13_hv_pmos[ise]
print @n.xbgr.xm47_u17.nsg13_hv_pmos[ibe]
print @n.xbgr.xm47_u17.nsg13_hv_pmos[ctype]
print @n.xbgr.xm47_u18.nsg13_hv_pmos[ide]
print @n.xbgr.xm47_u18.nsg13_hv_pmos[ige]
print @n.xbgr.xm47_u18.nsg13_hv_pmos[ise]
print @n.xbgr.xm47_u18.nsg13_hv_pmos[ibe]
print @n.xbgr.xm47_u18.nsg13_hv_pmos[ctype]
print @n.xbgr.xm47_u19.nsg13_hv_pmos[ide]
print @n.xbgr.xm47_u19.nsg13_hv_pmos[ige]
print @n.xbgr.xm47_u19.nsg13_hv_pmos[ise]
print @n.xbgr.xm47_u19.nsg13_hv_pmos[ibe]
print @n.xbgr.xm47_u19.nsg13_hv_pmos[ctype]
print @n.xbgr.xm47_u20.nsg13_hv_pmos[ide]
print @n.xbgr.xm47_u20.nsg13_hv_pmos[ige]
print @n.xbgr.xm47_u20.nsg13_hv_pmos[ise]
print @n.xbgr.xm47_u20.nsg13_hv_pmos[ibe]
print @n.xbgr.xm47_u20.nsg13_hv_pmos[ctype]
print @n.xbgr.xm47_u21.nsg13_hv_pmos[ide]
print @n.xbgr.xm47_u21.nsg13_hv_pmos[ige]
print @n.xbgr.xm47_u21.nsg13_hv_pmos[ise]
print @n.xbgr.xm47_u21.nsg13_hv_pmos[ibe]
print @n.xbgr.xm47_u21.nsg13_hv_pmos[ctype]
print @n.xbgr.xm47_u22.nsg13_hv_pmos[ide]
print @n.xbgr.xm47_u22.nsg13_hv_pmos[ige]
print @n.xbgr.xm47_u22.nsg13_hv_pmos[ise]
print @n.xbgr.xm47_u22.nsg13_hv_pmos[ibe]
print @n.xbgr.xm47_u22.nsg13_hv_pmos[ctype]
print @n.xbgr.xm47_u23.nsg13_hv_pmos[ide]
print @n.xbgr.xm47_u23.nsg13_hv_pmos[ige]
print @n.xbgr.xm47_u23.nsg13_hv_pmos[ise]
print @n.xbgr.xm47_u23.nsg13_hv_pmos[ibe]
print @n.xbgr.xm47_u23.nsg13_hv_pmos[ctype]
print @n.xbgr.xm47_u24.nsg13_hv_pmos[ide]
print @n.xbgr.xm47_u24.nsg13_hv_pmos[ige]
print @n.xbgr.xm47_u24.nsg13_hv_pmos[ise]
print @n.xbgr.xm47_u24.nsg13_hv_pmos[ibe]
print @n.xbgr.xm47_u24.nsg13_hv_pmos[ctype]
print @n.xbgr.xm48_u2.nsg13_hv_pmos[ide]
print @n.xbgr.xm48_u2.nsg13_hv_pmos[ige]
print @n.xbgr.xm48_u2.nsg13_hv_pmos[ise]
print @n.xbgr.xm48_u2.nsg13_hv_pmos[ibe]
print @n.xbgr.xm48_u2.nsg13_hv_pmos[ctype]
print @n.xbgr.xm48_u3.nsg13_hv_pmos[ide]
print @n.xbgr.xm48_u3.nsg13_hv_pmos[ige]
print @n.xbgr.xm48_u3.nsg13_hv_pmos[ise]
print @n.xbgr.xm48_u3.nsg13_hv_pmos[ibe]
print @n.xbgr.xm48_u3.nsg13_hv_pmos[ctype]
print @n.xbgr.xm48_u4.nsg13_hv_pmos[ide]
print @n.xbgr.xm48_u4.nsg13_hv_pmos[ige]
print @n.xbgr.xm48_u4.nsg13_hv_pmos[ise]
print @n.xbgr.xm48_u4.nsg13_hv_pmos[ibe]
print @n.xbgr.xm48_u4.nsg13_hv_pmos[ctype]
print @n.xbgr.xm48_u5.nsg13_hv_pmos[ide]
print @n.xbgr.xm48_u5.nsg13_hv_pmos[ige]
print @n.xbgr.xm48_u5.nsg13_hv_pmos[ise]
print @n.xbgr.xm48_u5.nsg13_hv_pmos[ibe]
print @n.xbgr.xm48_u5.nsg13_hv_pmos[ctype]
print @n.xbgr.xm48_u6.nsg13_hv_pmos[ide]
print @n.xbgr.xm48_u6.nsg13_hv_pmos[ige]
print @n.xbgr.xm48_u6.nsg13_hv_pmos[ise]
print @n.xbgr.xm48_u6.nsg13_hv_pmos[ibe]
print @n.xbgr.xm48_u6.nsg13_hv_pmos[ctype]
print @n.xbgr.xm48_u7.nsg13_hv_pmos[ide]
print @n.xbgr.xm48_u7.nsg13_hv_pmos[ige]
print @n.xbgr.xm48_u7.nsg13_hv_pmos[ise]
print @n.xbgr.xm48_u7.nsg13_hv_pmos[ibe]
print @n.xbgr.xm48_u7.nsg13_hv_pmos[ctype]
print @n.xbgr.xm48_u8.nsg13_hv_pmos[ide]
print @n.xbgr.xm48_u8.nsg13_hv_pmos[ige]
print @n.xbgr.xm48_u8.nsg13_hv_pmos[ise]
print @n.xbgr.xm48_u8.nsg13_hv_pmos[ibe]
print @n.xbgr.xm48_u8.nsg13_hv_pmos[ctype]
print @n.xbgr.xm48_u9.nsg13_hv_pmos[ide]
print @n.xbgr.xm48_u9.nsg13_hv_pmos[ige]
print @n.xbgr.xm48_u9.nsg13_hv_pmos[ise]
print @n.xbgr.xm48_u9.nsg13_hv_pmos[ibe]
print @n.xbgr.xm48_u9.nsg13_hv_pmos[ctype]
print @n.xbgr.xm48_u10.nsg13_hv_pmos[ide]
print @n.xbgr.xm48_u10.nsg13_hv_pmos[ige]
print @n.xbgr.xm48_u10.nsg13_hv_pmos[ise]
print @n.xbgr.xm48_u10.nsg13_hv_pmos[ibe]
print @n.xbgr.xm48_u10.nsg13_hv_pmos[ctype]
print @n.xbgr.xm48_u11.nsg13_hv_pmos[ide]
print @n.xbgr.xm48_u11.nsg13_hv_pmos[ige]
print @n.xbgr.xm48_u11.nsg13_hv_pmos[ise]
print @n.xbgr.xm48_u11.nsg13_hv_pmos[ibe]
print @n.xbgr.xm48_u11.nsg13_hv_pmos[ctype]
print @n.xbgr.xm48_u12.nsg13_hv_pmos[ide]
print @n.xbgr.xm48_u12.nsg13_hv_pmos[ige]
print @n.xbgr.xm48_u12.nsg13_hv_pmos[ise]
print @n.xbgr.xm48_u12.nsg13_hv_pmos[ibe]
print @n.xbgr.xm48_u12.nsg13_hv_pmos[ctype]
print @n.xbgr.xm48_u13.nsg13_hv_pmos[ide]
print @n.xbgr.xm48_u13.nsg13_hv_pmos[ige]
print @n.xbgr.xm48_u13.nsg13_hv_pmos[ise]
print @n.xbgr.xm48_u13.nsg13_hv_pmos[ibe]
print @n.xbgr.xm48_u13.nsg13_hv_pmos[ctype]
print @n.xbgr.xm48_u14.nsg13_hv_pmos[ide]
print @n.xbgr.xm48_u14.nsg13_hv_pmos[ige]
print @n.xbgr.xm48_u14.nsg13_hv_pmos[ise]
print @n.xbgr.xm48_u14.nsg13_hv_pmos[ibe]
print @n.xbgr.xm48_u14.nsg13_hv_pmos[ctype]
print @n.xbgr.xm48_u15.nsg13_hv_pmos[ide]
print @n.xbgr.xm48_u15.nsg13_hv_pmos[ige]
print @n.xbgr.xm48_u15.nsg13_hv_pmos[ise]
print @n.xbgr.xm48_u15.nsg13_hv_pmos[ibe]
print @n.xbgr.xm48_u15.nsg13_hv_pmos[ctype]
print @n.xbgr.xm48_u16.nsg13_hv_pmos[ide]
print @n.xbgr.xm48_u16.nsg13_hv_pmos[ige]
print @n.xbgr.xm48_u16.nsg13_hv_pmos[ise]
print @n.xbgr.xm48_u16.nsg13_hv_pmos[ibe]
print @n.xbgr.xm48_u16.nsg13_hv_pmos[ctype]
print @n.xbgr.xm48_u17.nsg13_hv_pmos[ide]
print @n.xbgr.xm48_u17.nsg13_hv_pmos[ige]
print @n.xbgr.xm48_u17.nsg13_hv_pmos[ise]
print @n.xbgr.xm48_u17.nsg13_hv_pmos[ibe]
print @n.xbgr.xm48_u17.nsg13_hv_pmos[ctype]
print @n.xbgr.xm48_u18.nsg13_hv_pmos[ide]
print @n.xbgr.xm48_u18.nsg13_hv_pmos[ige]
print @n.xbgr.xm48_u18.nsg13_hv_pmos[ise]
print @n.xbgr.xm48_u18.nsg13_hv_pmos[ibe]
print @n.xbgr.xm48_u18.nsg13_hv_pmos[ctype]
print @n.xbgr.xm48_u19.nsg13_hv_pmos[ide]
print @n.xbgr.xm48_u19.nsg13_hv_pmos[ige]
print @n.xbgr.xm48_u19.nsg13_hv_pmos[ise]
print @n.xbgr.xm48_u19.nsg13_hv_pmos[ibe]
print @n.xbgr.xm48_u19.nsg13_hv_pmos[ctype]
print @n.xbgr.xm48_u20.nsg13_hv_pmos[ide]
print @n.xbgr.xm48_u20.nsg13_hv_pmos[ige]
print @n.xbgr.xm48_u20.nsg13_hv_pmos[ise]
print @n.xbgr.xm48_u20.nsg13_hv_pmos[ibe]
print @n.xbgr.xm48_u20.nsg13_hv_pmos[ctype]
print @n.xbgr.xm48_u21.nsg13_hv_pmos[ide]
print @n.xbgr.xm48_u21.nsg13_hv_pmos[ige]
print @n.xbgr.xm48_u21.nsg13_hv_pmos[ise]
print @n.xbgr.xm48_u21.nsg13_hv_pmos[ibe]
print @n.xbgr.xm48_u21.nsg13_hv_pmos[ctype]
print @n.xbgr.xm48_u22.nsg13_hv_pmos[ide]
print @n.xbgr.xm48_u22.nsg13_hv_pmos[ige]
print @n.xbgr.xm48_u22.nsg13_hv_pmos[ise]
print @n.xbgr.xm48_u22.nsg13_hv_pmos[ibe]
print @n.xbgr.xm48_u22.nsg13_hv_pmos[ctype]
print @n.xbgr.xm48_u23.nsg13_hv_pmos[ide]
print @n.xbgr.xm48_u23.nsg13_hv_pmos[ige]
print @n.xbgr.xm48_u23.nsg13_hv_pmos[ise]
print @n.xbgr.xm48_u23.nsg13_hv_pmos[ibe]
print @n.xbgr.xm48_u23.nsg13_hv_pmos[ctype]
print @n.xbgr.xm48_u24.nsg13_hv_pmos[ide]
print @n.xbgr.xm48_u24.nsg13_hv_pmos[ige]
print @n.xbgr.xm48_u24.nsg13_hv_pmos[ise]
print @n.xbgr.xm48_u24.nsg13_hv_pmos[ibe]
print @n.xbgr.xm48_u24.nsg13_hv_pmos[ctype]
print @n.xbgr.xm50_u2.nsg13_hv_pmos[ide]
print @n.xbgr.xm50_u2.nsg13_hv_pmos[ige]
print @n.xbgr.xm50_u2.nsg13_hv_pmos[ise]
print @n.xbgr.xm50_u2.nsg13_hv_pmos[ibe]
print @n.xbgr.xm50_u2.nsg13_hv_pmos[ctype]
print @n.xbgr.xm50_u3.nsg13_hv_pmos[ide]
print @n.xbgr.xm50_u3.nsg13_hv_pmos[ige]
print @n.xbgr.xm50_u3.nsg13_hv_pmos[ise]
print @n.xbgr.xm50_u3.nsg13_hv_pmos[ibe]
print @n.xbgr.xm50_u3.nsg13_hv_pmos[ctype]
print @n.xbgr.xm50_u4.nsg13_hv_pmos[ide]
print @n.xbgr.xm50_u4.nsg13_hv_pmos[ige]
print @n.xbgr.xm50_u4.nsg13_hv_pmos[ise]
print @n.xbgr.xm50_u4.nsg13_hv_pmos[ibe]
print @n.xbgr.xm50_u4.nsg13_hv_pmos[ctype]
print @n.xbgr.xm50_u5.nsg13_hv_pmos[ide]
print @n.xbgr.xm50_u5.nsg13_hv_pmos[ige]
print @n.xbgr.xm50_u5.nsg13_hv_pmos[ise]
print @n.xbgr.xm50_u5.nsg13_hv_pmos[ibe]
print @n.xbgr.xm50_u5.nsg13_hv_pmos[ctype]
print @n.xbgr.xm50_u6.nsg13_hv_pmos[ide]
print @n.xbgr.xm50_u6.nsg13_hv_pmos[ige]
print @n.xbgr.xm50_u6.nsg13_hv_pmos[ise]
print @n.xbgr.xm50_u6.nsg13_hv_pmos[ibe]
print @n.xbgr.xm50_u6.nsg13_hv_pmos[ctype]
print @n.xbgr.xm50_u7.nsg13_hv_pmos[ide]
print @n.xbgr.xm50_u7.nsg13_hv_pmos[ige]
print @n.xbgr.xm50_u7.nsg13_hv_pmos[ise]
print @n.xbgr.xm50_u7.nsg13_hv_pmos[ibe]
print @n.xbgr.xm50_u7.nsg13_hv_pmos[ctype]
print @n.xbgr.xm50_u8.nsg13_hv_pmos[ide]
print @n.xbgr.xm50_u8.nsg13_hv_pmos[ige]
print @n.xbgr.xm50_u8.nsg13_hv_pmos[ise]
print @n.xbgr.xm50_u8.nsg13_hv_pmos[ibe]
print @n.xbgr.xm50_u8.nsg13_hv_pmos[ctype]
print @n.xbgr.xm50_u9.nsg13_hv_pmos[ide]
print @n.xbgr.xm50_u9.nsg13_hv_pmos[ige]
print @n.xbgr.xm50_u9.nsg13_hv_pmos[ise]
print @n.xbgr.xm50_u9.nsg13_hv_pmos[ibe]
print @n.xbgr.xm50_u9.nsg13_hv_pmos[ctype]
print @n.xbgr.xm50_u10.nsg13_hv_pmos[ide]
print @n.xbgr.xm50_u10.nsg13_hv_pmos[ige]
print @n.xbgr.xm50_u10.nsg13_hv_pmos[ise]
print @n.xbgr.xm50_u10.nsg13_hv_pmos[ibe]
print @n.xbgr.xm50_u10.nsg13_hv_pmos[ctype]
print @n.xbgr.xm50_u11.nsg13_hv_pmos[ide]
print @n.xbgr.xm50_u11.nsg13_hv_pmos[ige]
print @n.xbgr.xm50_u11.nsg13_hv_pmos[ise]
print @n.xbgr.xm50_u11.nsg13_hv_pmos[ibe]
print @n.xbgr.xm50_u11.nsg13_hv_pmos[ctype]
print @n.xbgr.xm50_u12.nsg13_hv_pmos[ide]
print @n.xbgr.xm50_u12.nsg13_hv_pmos[ige]
print @n.xbgr.xm50_u12.nsg13_hv_pmos[ise]
print @n.xbgr.xm50_u12.nsg13_hv_pmos[ibe]
print @n.xbgr.xm50_u12.nsg13_hv_pmos[ctype]
print @n.xbgr.xm50_u13.nsg13_hv_pmos[ide]
print @n.xbgr.xm50_u13.nsg13_hv_pmos[ige]
print @n.xbgr.xm50_u13.nsg13_hv_pmos[ise]
print @n.xbgr.xm50_u13.nsg13_hv_pmos[ibe]
print @n.xbgr.xm50_u13.nsg13_hv_pmos[ctype]
print @n.xbgr.xm50_u14.nsg13_hv_pmos[ide]
print @n.xbgr.xm50_u14.nsg13_hv_pmos[ige]
print @n.xbgr.xm50_u14.nsg13_hv_pmos[ise]
print @n.xbgr.xm50_u14.nsg13_hv_pmos[ibe]
print @n.xbgr.xm50_u14.nsg13_hv_pmos[ctype]
print @n.xbgr.xm50_u15.nsg13_hv_pmos[ide]
print @n.xbgr.xm50_u15.nsg13_hv_pmos[ige]
print @n.xbgr.xm50_u15.nsg13_hv_pmos[ise]
print @n.xbgr.xm50_u15.nsg13_hv_pmos[ibe]
print @n.xbgr.xm50_u15.nsg13_hv_pmos[ctype]
print @n.xbgr.xm50_u16.nsg13_hv_pmos[ide]
print @n.xbgr.xm50_u16.nsg13_hv_pmos[ige]
print @n.xbgr.xm50_u16.nsg13_hv_pmos[ise]
print @n.xbgr.xm50_u16.nsg13_hv_pmos[ibe]
print @n.xbgr.xm50_u16.nsg13_hv_pmos[ctype]
print @n.xbgr.xm50_u17.nsg13_hv_pmos[ide]
print @n.xbgr.xm50_u17.nsg13_hv_pmos[ige]
print @n.xbgr.xm50_u17.nsg13_hv_pmos[ise]
print @n.xbgr.xm50_u17.nsg13_hv_pmos[ibe]
print @n.xbgr.xm50_u17.nsg13_hv_pmos[ctype]
print @n.xbgr.xm50_u18.nsg13_hv_pmos[ide]
print @n.xbgr.xm50_u18.nsg13_hv_pmos[ige]
print @n.xbgr.xm50_u18.nsg13_hv_pmos[ise]
print @n.xbgr.xm50_u18.nsg13_hv_pmos[ibe]
print @n.xbgr.xm50_u18.nsg13_hv_pmos[ctype]
print @n.xbgr.xm50_u19.nsg13_hv_pmos[ide]
print @n.xbgr.xm50_u19.nsg13_hv_pmos[ige]
print @n.xbgr.xm50_u19.nsg13_hv_pmos[ise]
print @n.xbgr.xm50_u19.nsg13_hv_pmos[ibe]
print @n.xbgr.xm50_u19.nsg13_hv_pmos[ctype]
print @n.xbgr.xm50_u20.nsg13_hv_pmos[ide]
print @n.xbgr.xm50_u20.nsg13_hv_pmos[ige]
print @n.xbgr.xm50_u20.nsg13_hv_pmos[ise]
print @n.xbgr.xm50_u20.nsg13_hv_pmos[ibe]
print @n.xbgr.xm50_u20.nsg13_hv_pmos[ctype]
print @n.xbgr.xm50_u21.nsg13_hv_pmos[ide]
print @n.xbgr.xm50_u21.nsg13_hv_pmos[ige]
print @n.xbgr.xm50_u21.nsg13_hv_pmos[ise]
print @n.xbgr.xm50_u21.nsg13_hv_pmos[ibe]
print @n.xbgr.xm50_u21.nsg13_hv_pmos[ctype]
print @n.xbgr.xm50_u22.nsg13_hv_pmos[ide]
print @n.xbgr.xm50_u22.nsg13_hv_pmos[ige]
print @n.xbgr.xm50_u22.nsg13_hv_pmos[ise]
print @n.xbgr.xm50_u22.nsg13_hv_pmos[ibe]
print @n.xbgr.xm50_u22.nsg13_hv_pmos[ctype]
print @n.xbgr.xm50_u23.nsg13_hv_pmos[ide]
print @n.xbgr.xm50_u23.nsg13_hv_pmos[ige]
print @n.xbgr.xm50_u23.nsg13_hv_pmos[ise]
print @n.xbgr.xm50_u23.nsg13_hv_pmos[ibe]
print @n.xbgr.xm50_u23.nsg13_hv_pmos[ctype]
print @n.xbgr.xm50_u24.nsg13_hv_pmos[ide]
print @n.xbgr.xm50_u24.nsg13_hv_pmos[ige]
print @n.xbgr.xm50_u24.nsg13_hv_pmos[ise]
print @n.xbgr.xm50_u24.nsg13_hv_pmos[ibe]
print @n.xbgr.xm50_u24.nsg13_hv_pmos[ctype]
print @n.xbgr.xm51_u2.nsg13_hv_pmos[ide]
print @n.xbgr.xm51_u2.nsg13_hv_pmos[ige]
print @n.xbgr.xm51_u2.nsg13_hv_pmos[ise]
print @n.xbgr.xm51_u2.nsg13_hv_pmos[ibe]
print @n.xbgr.xm51_u2.nsg13_hv_pmos[ctype]
print @n.xbgr.xm51_u3.nsg13_hv_pmos[ide]
print @n.xbgr.xm51_u3.nsg13_hv_pmos[ige]
print @n.xbgr.xm51_u3.nsg13_hv_pmos[ise]
print @n.xbgr.xm51_u3.nsg13_hv_pmos[ibe]
print @n.xbgr.xm51_u3.nsg13_hv_pmos[ctype]
print @n.xbgr.xm51_u4.nsg13_hv_pmos[ide]
print @n.xbgr.xm51_u4.nsg13_hv_pmos[ige]
print @n.xbgr.xm51_u4.nsg13_hv_pmos[ise]
print @n.xbgr.xm51_u4.nsg13_hv_pmos[ibe]
print @n.xbgr.xm51_u4.nsg13_hv_pmos[ctype]
print @n.xbgr.xm52_u2.nsg13_hv_pmos[ide]
print @n.xbgr.xm52_u2.nsg13_hv_pmos[ige]
print @n.xbgr.xm52_u2.nsg13_hv_pmos[ise]
print @n.xbgr.xm52_u2.nsg13_hv_pmos[ibe]
print @n.xbgr.xm52_u2.nsg13_hv_pmos[ctype]
print @n.xbgr.xm52_u3.nsg13_hv_pmos[ide]
print @n.xbgr.xm52_u3.nsg13_hv_pmos[ige]
print @n.xbgr.xm52_u3.nsg13_hv_pmos[ise]
print @n.xbgr.xm52_u3.nsg13_hv_pmos[ibe]
print @n.xbgr.xm52_u3.nsg13_hv_pmos[ctype]
print @n.xbgr.xm52_u4.nsg13_hv_pmos[ide]
print @n.xbgr.xm52_u4.nsg13_hv_pmos[ige]
print @n.xbgr.xm52_u4.nsg13_hv_pmos[ise]
print @n.xbgr.xm52_u4.nsg13_hv_pmos[ibe]
print @n.xbgr.xm52_u4.nsg13_hv_pmos[ctype]
print @n.xbgr.xm52_u5.nsg13_hv_pmos[ide]
print @n.xbgr.xm52_u5.nsg13_hv_pmos[ige]
print @n.xbgr.xm52_u5.nsg13_hv_pmos[ise]
print @n.xbgr.xm52_u5.nsg13_hv_pmos[ibe]
print @n.xbgr.xm52_u5.nsg13_hv_pmos[ctype]
print @n.xbgr.xm52_u6.nsg13_hv_pmos[ide]
print @n.xbgr.xm52_u6.nsg13_hv_pmos[ige]
print @n.xbgr.xm52_u6.nsg13_hv_pmos[ise]
print @n.xbgr.xm52_u6.nsg13_hv_pmos[ibe]
print @n.xbgr.xm52_u6.nsg13_hv_pmos[ctype]
print @n.xbgr.xm52_u7.nsg13_hv_pmos[ide]
print @n.xbgr.xm52_u7.nsg13_hv_pmos[ige]
print @n.xbgr.xm52_u7.nsg13_hv_pmos[ise]
print @n.xbgr.xm52_u7.nsg13_hv_pmos[ibe]
print @n.xbgr.xm52_u7.nsg13_hv_pmos[ctype]
print @n.xbgr.xm52_u8.nsg13_hv_pmos[ide]
print @n.xbgr.xm52_u8.nsg13_hv_pmos[ige]
print @n.xbgr.xm52_u8.nsg13_hv_pmos[ise]
print @n.xbgr.xm52_u8.nsg13_hv_pmos[ibe]
print @n.xbgr.xm52_u8.nsg13_hv_pmos[ctype]
print @n.xbgr.xm52_u9.nsg13_hv_pmos[ide]
print @n.xbgr.xm52_u9.nsg13_hv_pmos[ige]
print @n.xbgr.xm52_u9.nsg13_hv_pmos[ise]
print @n.xbgr.xm52_u9.nsg13_hv_pmos[ibe]
print @n.xbgr.xm52_u9.nsg13_hv_pmos[ctype]
print @n.xbgr.xm52_u10.nsg13_hv_pmos[ide]
print @n.xbgr.xm52_u10.nsg13_hv_pmos[ige]
print @n.xbgr.xm52_u10.nsg13_hv_pmos[ise]
print @n.xbgr.xm52_u10.nsg13_hv_pmos[ibe]
print @n.xbgr.xm52_u10.nsg13_hv_pmos[ctype]
print @n.xbgr.xm52_u11.nsg13_hv_pmos[ide]
print @n.xbgr.xm52_u11.nsg13_hv_pmos[ige]
print @n.xbgr.xm52_u11.nsg13_hv_pmos[ise]
print @n.xbgr.xm52_u11.nsg13_hv_pmos[ibe]
print @n.xbgr.xm52_u11.nsg13_hv_pmos[ctype]
print @n.xbgr.xm52_u12.nsg13_hv_pmos[ide]
print @n.xbgr.xm52_u12.nsg13_hv_pmos[ige]
print @n.xbgr.xm52_u12.nsg13_hv_pmos[ise]
print @n.xbgr.xm52_u12.nsg13_hv_pmos[ibe]
print @n.xbgr.xm52_u12.nsg13_hv_pmos[ctype]
print @n.xbgr.xm52_u13.nsg13_hv_pmos[ide]
print @n.xbgr.xm52_u13.nsg13_hv_pmos[ige]
print @n.xbgr.xm52_u13.nsg13_hv_pmos[ise]
print @n.xbgr.xm52_u13.nsg13_hv_pmos[ibe]
print @n.xbgr.xm52_u13.nsg13_hv_pmos[ctype]
print @n.xbgr.xm52_u14.nsg13_hv_pmos[ide]
print @n.xbgr.xm52_u14.nsg13_hv_pmos[ige]
print @n.xbgr.xm52_u14.nsg13_hv_pmos[ise]
print @n.xbgr.xm52_u14.nsg13_hv_pmos[ibe]
print @n.xbgr.xm52_u14.nsg13_hv_pmos[ctype]
print @n.xbgr.xm52_u15.nsg13_hv_pmos[ide]
print @n.xbgr.xm52_u15.nsg13_hv_pmos[ige]
print @n.xbgr.xm52_u15.nsg13_hv_pmos[ise]
print @n.xbgr.xm52_u15.nsg13_hv_pmos[ibe]
print @n.xbgr.xm52_u15.nsg13_hv_pmos[ctype]
print @n.xbgr.xm52_u16.nsg13_hv_pmos[ide]
print @n.xbgr.xm52_u16.nsg13_hv_pmos[ige]
print @n.xbgr.xm52_u16.nsg13_hv_pmos[ise]
print @n.xbgr.xm52_u16.nsg13_hv_pmos[ibe]
print @n.xbgr.xm52_u16.nsg13_hv_pmos[ctype]
print @n.xbgr.xm52_u17.nsg13_hv_pmos[ide]
print @n.xbgr.xm52_u17.nsg13_hv_pmos[ige]
print @n.xbgr.xm52_u17.nsg13_hv_pmos[ise]
print @n.xbgr.xm52_u17.nsg13_hv_pmos[ibe]
print @n.xbgr.xm52_u17.nsg13_hv_pmos[ctype]
print @n.xbgr.xm52_u18.nsg13_hv_pmos[ide]
print @n.xbgr.xm52_u18.nsg13_hv_pmos[ige]
print @n.xbgr.xm52_u18.nsg13_hv_pmos[ise]
print @n.xbgr.xm52_u18.nsg13_hv_pmos[ibe]
print @n.xbgr.xm52_u18.nsg13_hv_pmos[ctype]
print @n.xbgr.xm52_u19.nsg13_hv_pmos[ide]
print @n.xbgr.xm52_u19.nsg13_hv_pmos[ige]
print @n.xbgr.xm52_u19.nsg13_hv_pmos[ise]
print @n.xbgr.xm52_u19.nsg13_hv_pmos[ibe]
print @n.xbgr.xm52_u19.nsg13_hv_pmos[ctype]
print @n.xbgr.xm52_u20.nsg13_hv_pmos[ide]
print @n.xbgr.xm52_u20.nsg13_hv_pmos[ige]
print @n.xbgr.xm52_u20.nsg13_hv_pmos[ise]
print @n.xbgr.xm52_u20.nsg13_hv_pmos[ibe]
print @n.xbgr.xm52_u20.nsg13_hv_pmos[ctype]
print @n.xbgr.xm52_u21.nsg13_hv_pmos[ide]
print @n.xbgr.xm52_u21.nsg13_hv_pmos[ige]
print @n.xbgr.xm52_u21.nsg13_hv_pmos[ise]
print @n.xbgr.xm52_u21.nsg13_hv_pmos[ibe]
print @n.xbgr.xm52_u21.nsg13_hv_pmos[ctype]
print @n.xbgr.xm52_u22.nsg13_hv_pmos[ide]
print @n.xbgr.xm52_u22.nsg13_hv_pmos[ige]
print @n.xbgr.xm52_u22.nsg13_hv_pmos[ise]
print @n.xbgr.xm52_u22.nsg13_hv_pmos[ibe]
print @n.xbgr.xm52_u22.nsg13_hv_pmos[ctype]
print @n.xbgr.xm52_u23.nsg13_hv_pmos[ide]
print @n.xbgr.xm52_u23.nsg13_hv_pmos[ige]
print @n.xbgr.xm52_u23.nsg13_hv_pmos[ise]
print @n.xbgr.xm52_u23.nsg13_hv_pmos[ibe]
print @n.xbgr.xm52_u23.nsg13_hv_pmos[ctype]
print @n.xbgr.xm52_u24.nsg13_hv_pmos[ide]
print @n.xbgr.xm52_u24.nsg13_hv_pmos[ige]
print @n.xbgr.xm52_u24.nsg13_hv_pmos[ise]
print @n.xbgr.xm52_u24.nsg13_hv_pmos[ibe]
print @n.xbgr.xm52_u24.nsg13_hv_pmos[ctype]
print @n.xbgr.xm54_u2.nsg13_hv_pmos[ide]
print @n.xbgr.xm54_u2.nsg13_hv_pmos[ige]
print @n.xbgr.xm54_u2.nsg13_hv_pmos[ise]
print @n.xbgr.xm54_u2.nsg13_hv_pmos[ibe]
print @n.xbgr.xm54_u2.nsg13_hv_pmos[ctype]
print @n.xbgr.xm54_u3.nsg13_hv_pmos[ide]
print @n.xbgr.xm54_u3.nsg13_hv_pmos[ige]
print @n.xbgr.xm54_u3.nsg13_hv_pmos[ise]
print @n.xbgr.xm54_u3.nsg13_hv_pmos[ibe]
print @n.xbgr.xm54_u3.nsg13_hv_pmos[ctype]
print @n.xbgr.xm54_u4.nsg13_hv_pmos[ide]
print @n.xbgr.xm54_u4.nsg13_hv_pmos[ige]
print @n.xbgr.xm54_u4.nsg13_hv_pmos[ise]
print @n.xbgr.xm54_u4.nsg13_hv_pmos[ibe]
print @n.xbgr.xm54_u4.nsg13_hv_pmos[ctype]
print @n.xbgr.xm54_u5.nsg13_hv_pmos[ide]
print @n.xbgr.xm54_u5.nsg13_hv_pmos[ige]
print @n.xbgr.xm54_u5.nsg13_hv_pmos[ise]
print @n.xbgr.xm54_u5.nsg13_hv_pmos[ibe]
print @n.xbgr.xm54_u5.nsg13_hv_pmos[ctype]
print @n.xbgr.xm54_u6.nsg13_hv_pmos[ide]
print @n.xbgr.xm54_u6.nsg13_hv_pmos[ige]
print @n.xbgr.xm54_u6.nsg13_hv_pmos[ise]
print @n.xbgr.xm54_u6.nsg13_hv_pmos[ibe]
print @n.xbgr.xm54_u6.nsg13_hv_pmos[ctype]
print @n.xbgr.xm54_u7.nsg13_hv_pmos[ide]
print @n.xbgr.xm54_u7.nsg13_hv_pmos[ige]
print @n.xbgr.xm54_u7.nsg13_hv_pmos[ise]
print @n.xbgr.xm54_u7.nsg13_hv_pmos[ibe]
print @n.xbgr.xm54_u7.nsg13_hv_pmos[ctype]
print @n.xbgr.xm54_u8.nsg13_hv_pmos[ide]
print @n.xbgr.xm54_u8.nsg13_hv_pmos[ige]
print @n.xbgr.xm54_u8.nsg13_hv_pmos[ise]
print @n.xbgr.xm54_u8.nsg13_hv_pmos[ibe]
print @n.xbgr.xm54_u8.nsg13_hv_pmos[ctype]
print @n.xbgr.xm54_u9.nsg13_hv_pmos[ide]
print @n.xbgr.xm54_u9.nsg13_hv_pmos[ige]
print @n.xbgr.xm54_u9.nsg13_hv_pmos[ise]
print @n.xbgr.xm54_u9.nsg13_hv_pmos[ibe]
print @n.xbgr.xm54_u9.nsg13_hv_pmos[ctype]
print @n.xbgr.xm54_u10.nsg13_hv_pmos[ide]
print @n.xbgr.xm54_u10.nsg13_hv_pmos[ige]
print @n.xbgr.xm54_u10.nsg13_hv_pmos[ise]
print @n.xbgr.xm54_u10.nsg13_hv_pmos[ibe]
print @n.xbgr.xm54_u10.nsg13_hv_pmos[ctype]
print @n.xbgr.xm54_u11.nsg13_hv_pmos[ide]
print @n.xbgr.xm54_u11.nsg13_hv_pmos[ige]
print @n.xbgr.xm54_u11.nsg13_hv_pmos[ise]
print @n.xbgr.xm54_u11.nsg13_hv_pmos[ibe]
print @n.xbgr.xm54_u11.nsg13_hv_pmos[ctype]
print @n.xbgr.xm54_u12.nsg13_hv_pmos[ide]
print @n.xbgr.xm54_u12.nsg13_hv_pmos[ige]
print @n.xbgr.xm54_u12.nsg13_hv_pmos[ise]
print @n.xbgr.xm54_u12.nsg13_hv_pmos[ibe]
print @n.xbgr.xm54_u12.nsg13_hv_pmos[ctype]
print @n.xbgr.xm54_u13.nsg13_hv_pmos[ide]
print @n.xbgr.xm54_u13.nsg13_hv_pmos[ige]
print @n.xbgr.xm54_u13.nsg13_hv_pmos[ise]
print @n.xbgr.xm54_u13.nsg13_hv_pmos[ibe]
print @n.xbgr.xm54_u13.nsg13_hv_pmos[ctype]
print @n.xbgr.xm54_u14.nsg13_hv_pmos[ide]
print @n.xbgr.xm54_u14.nsg13_hv_pmos[ige]
print @n.xbgr.xm54_u14.nsg13_hv_pmos[ise]
print @n.xbgr.xm54_u14.nsg13_hv_pmos[ibe]
print @n.xbgr.xm54_u14.nsg13_hv_pmos[ctype]
print @n.xbgr.xm54_u15.nsg13_hv_pmos[ide]
print @n.xbgr.xm54_u15.nsg13_hv_pmos[ige]
print @n.xbgr.xm54_u15.nsg13_hv_pmos[ise]
print @n.xbgr.xm54_u15.nsg13_hv_pmos[ibe]
print @n.xbgr.xm54_u15.nsg13_hv_pmos[ctype]
print @n.xbgr.xm54_u16.nsg13_hv_pmos[ide]
print @n.xbgr.xm54_u16.nsg13_hv_pmos[ige]
print @n.xbgr.xm54_u16.nsg13_hv_pmos[ise]
print @n.xbgr.xm54_u16.nsg13_hv_pmos[ibe]
print @n.xbgr.xm54_u16.nsg13_hv_pmos[ctype]
print @n.xbgr.xm54_u17.nsg13_hv_pmos[ide]
print @n.xbgr.xm54_u17.nsg13_hv_pmos[ige]
print @n.xbgr.xm54_u17.nsg13_hv_pmos[ise]
print @n.xbgr.xm54_u17.nsg13_hv_pmos[ibe]
print @n.xbgr.xm54_u17.nsg13_hv_pmos[ctype]
print @n.xbgr.xm54_u18.nsg13_hv_pmos[ide]
print @n.xbgr.xm54_u18.nsg13_hv_pmos[ige]
print @n.xbgr.xm54_u18.nsg13_hv_pmos[ise]
print @n.xbgr.xm54_u18.nsg13_hv_pmos[ibe]
print @n.xbgr.xm54_u18.nsg13_hv_pmos[ctype]
print @n.xbgr.xm54_u19.nsg13_hv_pmos[ide]
print @n.xbgr.xm54_u19.nsg13_hv_pmos[ige]
print @n.xbgr.xm54_u19.nsg13_hv_pmos[ise]
print @n.xbgr.xm54_u19.nsg13_hv_pmos[ibe]
print @n.xbgr.xm54_u19.nsg13_hv_pmos[ctype]
print @n.xbgr.xm54_u20.nsg13_hv_pmos[ide]
print @n.xbgr.xm54_u20.nsg13_hv_pmos[ige]
print @n.xbgr.xm54_u20.nsg13_hv_pmos[ise]
print @n.xbgr.xm54_u20.nsg13_hv_pmos[ibe]
print @n.xbgr.xm54_u20.nsg13_hv_pmos[ctype]
print @n.xbgr.xm54_u21.nsg13_hv_pmos[ide]
print @n.xbgr.xm54_u21.nsg13_hv_pmos[ige]
print @n.xbgr.xm54_u21.nsg13_hv_pmos[ise]
print @n.xbgr.xm54_u21.nsg13_hv_pmos[ibe]
print @n.xbgr.xm54_u21.nsg13_hv_pmos[ctype]
print @n.xbgr.xm54_u22.nsg13_hv_pmos[ide]
print @n.xbgr.xm54_u22.nsg13_hv_pmos[ige]
print @n.xbgr.xm54_u22.nsg13_hv_pmos[ise]
print @n.xbgr.xm54_u22.nsg13_hv_pmos[ibe]
print @n.xbgr.xm54_u22.nsg13_hv_pmos[ctype]
print @n.xbgr.xm54_u23.nsg13_hv_pmos[ide]
print @n.xbgr.xm54_u23.nsg13_hv_pmos[ige]
print @n.xbgr.xm54_u23.nsg13_hv_pmos[ise]
print @n.xbgr.xm54_u23.nsg13_hv_pmos[ibe]
print @n.xbgr.xm54_u23.nsg13_hv_pmos[ctype]
print @n.xbgr.xm54_u24.nsg13_hv_pmos[ide]
print @n.xbgr.xm54_u24.nsg13_hv_pmos[ige]
print @n.xbgr.xm54_u24.nsg13_hv_pmos[ise]
print @n.xbgr.xm54_u24.nsg13_hv_pmos[ibe]
print @n.xbgr.xm54_u24.nsg13_hv_pmos[ctype]
print @q.xbgr.xq56_u2.qnpn13g2[ic]
print @q.xbgr.xq56_u2.qnpn13g2[ib]
print @q.xbgr.xq56_u2.qnpn13g2[ie]
print @q.xbgr.xq56_u2.qnpn13g2[is]
print @r.xbgr.xq56_u2.rsub[i]
print @c.xbgr.xq56_u2.csub[i]
print @q.xbgr.xq56_u3.qnpn13g2[ic]
print @q.xbgr.xq56_u3.qnpn13g2[ib]
print @q.xbgr.xq56_u3.qnpn13g2[ie]
print @q.xbgr.xq56_u3.qnpn13g2[is]
print @r.xbgr.xq56_u3.rsub[i]
print @c.xbgr.xq56_u3.csub[i]
print @q.xbgr.xq56_u4.qnpn13g2[ic]
print @q.xbgr.xq56_u4.qnpn13g2[ib]
print @q.xbgr.xq56_u4.qnpn13g2[ie]
print @q.xbgr.xq56_u4.qnpn13g2[is]
print @r.xbgr.xq56_u4.rsub[i]
print @c.xbgr.xq56_u4.csub[i]
print @q.xbgr.xq56_u5.qnpn13g2[ic]
print @q.xbgr.xq56_u5.qnpn13g2[ib]
print @q.xbgr.xq56_u5.qnpn13g2[ie]
print @q.xbgr.xq56_u5.qnpn13g2[is]
print @r.xbgr.xq56_u5.rsub[i]
print @c.xbgr.xq56_u5.csub[i]
print @q.xbgr.xq56_u6.qnpn13g2[ic]
print @q.xbgr.xq56_u6.qnpn13g2[ib]
print @q.xbgr.xq56_u6.qnpn13g2[ie]
print @q.xbgr.xq56_u6.qnpn13g2[is]
print @r.xbgr.xq56_u6.rsub[i]
print @c.xbgr.xq56_u6.csub[i]
print @q.xbgr.xq56_u7.qnpn13g2[ic]
print @q.xbgr.xq56_u7.qnpn13g2[ib]
print @q.xbgr.xq56_u7.qnpn13g2[ie]
print @q.xbgr.xq56_u7.qnpn13g2[is]
print @r.xbgr.xq56_u7.rsub[i]
print @c.xbgr.xq56_u7.csub[i]
print @q.xbgr.xq56_u8.qnpn13g2[ic]
print @q.xbgr.xq56_u8.qnpn13g2[ib]
print @q.xbgr.xq56_u8.qnpn13g2[ie]
print @q.xbgr.xq56_u8.qnpn13g2[is]
print @r.xbgr.xq56_u8.rsub[i]
print @c.xbgr.xq56_u8.csub[i]
print @q.xbgr.xq56_u9.qnpn13g2[ic]
print @q.xbgr.xq56_u9.qnpn13g2[ib]
print @q.xbgr.xq56_u9.qnpn13g2[ie]
print @q.xbgr.xq56_u9.qnpn13g2[is]
print @r.xbgr.xq56_u9.rsub[i]
print @c.xbgr.xq56_u9.csub[i]
print @q.xbgr.xq56_u10.qnpn13g2[ic]
print @q.xbgr.xq56_u10.qnpn13g2[ib]
print @q.xbgr.xq56_u10.qnpn13g2[ie]
print @q.xbgr.xq56_u10.qnpn13g2[is]
print @r.xbgr.xq56_u10.rsub[i]
print @c.xbgr.xq56_u10.csub[i]
print @q.xbgr.xq56_u11.qnpn13g2[ic]
print @q.xbgr.xq56_u11.qnpn13g2[ib]
print @q.xbgr.xq56_u11.qnpn13g2[ie]
print @q.xbgr.xq56_u11.qnpn13g2[is]
print @r.xbgr.xq56_u11.rsub[i]
print @c.xbgr.xq56_u11.csub[i]
print @q.xbgr.xq56_u12.qnpn13g2[ic]
print @q.xbgr.xq56_u12.qnpn13g2[ib]
print @q.xbgr.xq56_u12.qnpn13g2[ie]
print @q.xbgr.xq56_u12.qnpn13g2[is]
print @r.xbgr.xq56_u12.rsub[i]
print @c.xbgr.xq56_u12.csub[i]
print @q.xbgr.xq56_u13.qnpn13g2[ic]
print @q.xbgr.xq56_u13.qnpn13g2[ib]
print @q.xbgr.xq56_u13.qnpn13g2[ie]
print @q.xbgr.xq56_u13.qnpn13g2[is]
print @r.xbgr.xq56_u13.rsub[i]
print @c.xbgr.xq56_u13.csub[i]
print @q.xbgr.xq56_u14.qnpn13g2[ic]
print @q.xbgr.xq56_u14.qnpn13g2[ib]
print @q.xbgr.xq56_u14.qnpn13g2[ie]
print @q.xbgr.xq56_u14.qnpn13g2[is]
print @r.xbgr.xq56_u14.rsub[i]
print @c.xbgr.xq56_u14.csub[i]
print @q.xbgr.xq56_u15.qnpn13g2[ic]
print @q.xbgr.xq56_u15.qnpn13g2[ib]
print @q.xbgr.xq56_u15.qnpn13g2[ie]
print @q.xbgr.xq56_u15.qnpn13g2[is]
print @r.xbgr.xq56_u15.rsub[i]
print @c.xbgr.xq56_u15.csub[i]
print @q.xbgr.xq56_u16.qnpn13g2[ic]
print @q.xbgr.xq56_u16.qnpn13g2[ib]
print @q.xbgr.xq56_u16.qnpn13g2[ie]
print @q.xbgr.xq56_u16.qnpn13g2[is]
print @r.xbgr.xq56_u16.rsub[i]
print @c.xbgr.xq56_u16.csub[i]
print @q.xbgr.xq56_u17.qnpn13g2[ic]
print @q.xbgr.xq56_u17.qnpn13g2[ib]
print @q.xbgr.xq56_u17.qnpn13g2[ie]
print @q.xbgr.xq56_u17.qnpn13g2[is]
print @r.xbgr.xq56_u17.rsub[i]
print @c.xbgr.xq56_u17.csub[i]
print @q.xbgr.xq56_u18.qnpn13g2[ic]
print @q.xbgr.xq56_u18.qnpn13g2[ib]
print @q.xbgr.xq56_u18.qnpn13g2[ie]
print @q.xbgr.xq56_u18.qnpn13g2[is]
print @r.xbgr.xq56_u18.rsub[i]
print @c.xbgr.xq56_u18.csub[i]
print @q.xbgr.xq56_u19.qnpn13g2[ic]
print @q.xbgr.xq56_u19.qnpn13g2[ib]
print @q.xbgr.xq56_u19.qnpn13g2[ie]
print @q.xbgr.xq56_u19.qnpn13g2[is]
print @r.xbgr.xq56_u19.rsub[i]
print @c.xbgr.xq56_u19.csub[i]
print @q.xbgr.xq56_u20.qnpn13g2[ic]
print @q.xbgr.xq56_u20.qnpn13g2[ib]
print @q.xbgr.xq56_u20.qnpn13g2[ie]
print @q.xbgr.xq56_u20.qnpn13g2[is]
print @r.xbgr.xq56_u20.rsub[i]
print @c.xbgr.xq56_u20.csub[i]
print @q.xbgr.xq56_u21.qnpn13g2[ic]
print @q.xbgr.xq56_u21.qnpn13g2[ib]
print @q.xbgr.xq56_u21.qnpn13g2[ie]
print @q.xbgr.xq56_u21.qnpn13g2[is]
print @r.xbgr.xq56_u21.rsub[i]
print @c.xbgr.xq56_u21.csub[i]
print @q.xbgr.xq56_u22.qnpn13g2[ic]
print @q.xbgr.xq56_u22.qnpn13g2[ib]
print @q.xbgr.xq56_u22.qnpn13g2[ie]
print @q.xbgr.xq56_u22.qnpn13g2[is]
print @r.xbgr.xq56_u22.rsub[i]
print @c.xbgr.xq56_u22.csub[i]
print @q.xbgr.xq56_u23.qnpn13g2[ic]
print @q.xbgr.xq56_u23.qnpn13g2[ib]
print @q.xbgr.xq56_u23.qnpn13g2[ie]
print @q.xbgr.xq56_u23.qnpn13g2[is]
print @r.xbgr.xq56_u23.rsub[i]
print @c.xbgr.xq56_u23.csub[i]
print @q.xbgr.xq56_u24.qnpn13g2[ic]
print @q.xbgr.xq56_u24.qnpn13g2[ib]
print @q.xbgr.xq56_u24.qnpn13g2[ie]
print @q.xbgr.xq56_u24.qnpn13g2[is]
print @r.xbgr.xq56_u24.rsub[i]
print @c.xbgr.xq56_u24.csub[i]
print @q.xbgr.xq60_u2.qnpn13g2[ic]
print @q.xbgr.xq60_u2.qnpn13g2[ib]
print @q.xbgr.xq60_u2.qnpn13g2[ie]
print @q.xbgr.xq60_u2.qnpn13g2[is]
print @r.xbgr.xq60_u2.rsub[i]
print @c.xbgr.xq60_u2.csub[i]
print @q.xbgr.xq60_u3.qnpn13g2[ic]
print @q.xbgr.xq60_u3.qnpn13g2[ib]
print @q.xbgr.xq60_u3.qnpn13g2[ie]
print @q.xbgr.xq60_u3.qnpn13g2[is]
print @r.xbgr.xq60_u3.rsub[i]
print @c.xbgr.xq60_u3.csub[i]
print @q.xbgr.xq60_u4.qnpn13g2[ic]
print @q.xbgr.xq60_u4.qnpn13g2[ib]
print @q.xbgr.xq60_u4.qnpn13g2[ie]
print @q.xbgr.xq60_u4.qnpn13g2[is]
print @r.xbgr.xq60_u4.rsub[i]
print @c.xbgr.xq60_u4.csub[i]
print @q.xbgr.xq62_u2.qnpn13g2[ic]
print @q.xbgr.xq62_u2.qnpn13g2[ib]
print @q.xbgr.xq62_u2.qnpn13g2[ie]
print @q.xbgr.xq62_u2.qnpn13g2[is]
print @r.xbgr.xq62_u2.rsub[i]
print @c.xbgr.xq62_u2.csub[i]
print @q.xbgr.xq62_u3.qnpn13g2[ic]
print @q.xbgr.xq62_u3.qnpn13g2[ib]
print @q.xbgr.xq62_u3.qnpn13g2[ie]
print @q.xbgr.xq62_u3.qnpn13g2[is]
print @r.xbgr.xq62_u3.rsub[i]
print @c.xbgr.xq62_u3.csub[i]
print @q.xbgr.xq62_u4.qnpn13g2[ic]
print @q.xbgr.xq62_u4.qnpn13g2[ib]
print @q.xbgr.xq62_u4.qnpn13g2[ie]
print @q.xbgr.xq62_u4.qnpn13g2[is]
print @r.xbgr.xq62_u4.rsub[i]
print @c.xbgr.xq62_u4.csub[i]
print @q.xbgr.xq62_u5.qnpn13g2[ic]
print @q.xbgr.xq62_u5.qnpn13g2[ib]
print @q.xbgr.xq62_u5.qnpn13g2[ie]
print @q.xbgr.xq62_u5.qnpn13g2[is]
print @r.xbgr.xq62_u5.rsub[i]
print @c.xbgr.xq62_u5.csub[i]
print @q.xbgr.xq62_u6.qnpn13g2[ic]
print @q.xbgr.xq62_u6.qnpn13g2[ib]
print @q.xbgr.xq62_u6.qnpn13g2[ie]
print @q.xbgr.xq62_u6.qnpn13g2[is]
print @r.xbgr.xq62_u6.rsub[i]
print @c.xbgr.xq62_u6.csub[i]
print @q.xbgr.xq62_u7.qnpn13g2[ic]
print @q.xbgr.xq62_u7.qnpn13g2[ib]
print @q.xbgr.xq62_u7.qnpn13g2[ie]
print @q.xbgr.xq62_u7.qnpn13g2[is]
print @r.xbgr.xq62_u7.rsub[i]
print @c.xbgr.xq62_u7.csub[i]
print @q.xbgr.xq62_u8.qnpn13g2[ic]
print @q.xbgr.xq62_u8.qnpn13g2[ib]
print @q.xbgr.xq62_u8.qnpn13g2[ie]
print @q.xbgr.xq62_u8.qnpn13g2[is]
print @r.xbgr.xq62_u8.rsub[i]
print @c.xbgr.xq62_u8.csub[i]
print @q.xbgr.xq62_u9.qnpn13g2[ic]
print @q.xbgr.xq62_u9.qnpn13g2[ib]
print @q.xbgr.xq62_u9.qnpn13g2[ie]
print @q.xbgr.xq62_u9.qnpn13g2[is]
print @r.xbgr.xq62_u9.rsub[i]
print @c.xbgr.xq62_u9.csub[i]
print @q.xbgr.xq62_u10.qnpn13g2[ic]
print @q.xbgr.xq62_u10.qnpn13g2[ib]
print @q.xbgr.xq62_u10.qnpn13g2[ie]
print @q.xbgr.xq62_u10.qnpn13g2[is]
print @r.xbgr.xq62_u10.rsub[i]
print @c.xbgr.xq62_u10.csub[i]
print @q.xbgr.xq62_u11.qnpn13g2[ic]
print @q.xbgr.xq62_u11.qnpn13g2[ib]
print @q.xbgr.xq62_u11.qnpn13g2[ie]
print @q.xbgr.xq62_u11.qnpn13g2[is]
print @r.xbgr.xq62_u11.rsub[i]
print @c.xbgr.xq62_u11.csub[i]
print @q.xbgr.xq62_u12.qnpn13g2[ic]
print @q.xbgr.xq62_u12.qnpn13g2[ib]
print @q.xbgr.xq62_u12.qnpn13g2[ie]
print @q.xbgr.xq62_u12.qnpn13g2[is]
print @r.xbgr.xq62_u12.rsub[i]
print @c.xbgr.xq62_u12.csub[i]
print @q.xbgr.xq62_u13.qnpn13g2[ic]
print @q.xbgr.xq62_u13.qnpn13g2[ib]
print @q.xbgr.xq62_u13.qnpn13g2[ie]
print @q.xbgr.xq62_u13.qnpn13g2[is]
print @r.xbgr.xq62_u13.rsub[i]
print @c.xbgr.xq62_u13.csub[i]
print @q.xbgr.xq62_u14.qnpn13g2[ic]
print @q.xbgr.xq62_u14.qnpn13g2[ib]
print @q.xbgr.xq62_u14.qnpn13g2[ie]
print @q.xbgr.xq62_u14.qnpn13g2[is]
print @r.xbgr.xq62_u14.rsub[i]
print @c.xbgr.xq62_u14.csub[i]
print @q.xbgr.xq62_u15.qnpn13g2[ic]
print @q.xbgr.xq62_u15.qnpn13g2[ib]
print @q.xbgr.xq62_u15.qnpn13g2[ie]
print @q.xbgr.xq62_u15.qnpn13g2[is]
print @r.xbgr.xq62_u15.rsub[i]
print @c.xbgr.xq62_u15.csub[i]
print @q.xbgr.xq62_u16.qnpn13g2[ic]
print @q.xbgr.xq62_u16.qnpn13g2[ib]
print @q.xbgr.xq62_u16.qnpn13g2[ie]
print @q.xbgr.xq62_u16.qnpn13g2[is]
print @r.xbgr.xq62_u16.rsub[i]
print @c.xbgr.xq62_u16.csub[i]
print @q.xbgr.xq62_u17.qnpn13g2[ic]
print @q.xbgr.xq62_u17.qnpn13g2[ib]
print @q.xbgr.xq62_u17.qnpn13g2[ie]
print @q.xbgr.xq62_u17.qnpn13g2[is]
print @r.xbgr.xq62_u17.rsub[i]
print @c.xbgr.xq62_u17.csub[i]
print @q.xbgr.xq62_u18.qnpn13g2[ic]
print @q.xbgr.xq62_u18.qnpn13g2[ib]
print @q.xbgr.xq62_u18.qnpn13g2[ie]
print @q.xbgr.xq62_u18.qnpn13g2[is]
print @r.xbgr.xq62_u18.rsub[i]
print @c.xbgr.xq62_u18.csub[i]
print @q.xbgr.xq62_u19.qnpn13g2[ic]
print @q.xbgr.xq62_u19.qnpn13g2[ib]
print @q.xbgr.xq62_u19.qnpn13g2[ie]
print @q.xbgr.xq62_u19.qnpn13g2[is]
print @r.xbgr.xq62_u19.rsub[i]
print @c.xbgr.xq62_u19.csub[i]
print @q.xbgr.xq62_u20.qnpn13g2[ic]
print @q.xbgr.xq62_u20.qnpn13g2[ib]
print @q.xbgr.xq62_u20.qnpn13g2[ie]
print @q.xbgr.xq62_u20.qnpn13g2[is]
print @r.xbgr.xq62_u20.rsub[i]
print @c.xbgr.xq62_u20.csub[i]
print @q.xbgr.xq62_u21.qnpn13g2[ic]
print @q.xbgr.xq62_u21.qnpn13g2[ib]
print @q.xbgr.xq62_u21.qnpn13g2[ie]
print @q.xbgr.xq62_u21.qnpn13g2[is]
print @r.xbgr.xq62_u21.rsub[i]
print @c.xbgr.xq62_u21.csub[i]
print @q.xbgr.xq62_u22.qnpn13g2[ic]
print @q.xbgr.xq62_u22.qnpn13g2[ib]
print @q.xbgr.xq62_u22.qnpn13g2[ie]
print @q.xbgr.xq62_u22.qnpn13g2[is]
print @r.xbgr.xq62_u22.rsub[i]
print @c.xbgr.xq62_u22.csub[i]
print @q.xbgr.xq62_u23.qnpn13g2[ic]
print @q.xbgr.xq62_u23.qnpn13g2[ib]
print @q.xbgr.xq62_u23.qnpn13g2[ie]
print @q.xbgr.xq62_u23.qnpn13g2[is]
print @r.xbgr.xq62_u23.rsub[i]
print @c.xbgr.xq62_u23.csub[i]
print @q.xbgr.xq62_u24.qnpn13g2[ic]
print @q.xbgr.xq62_u24.qnpn13g2[ib]
print @q.xbgr.xq62_u24.qnpn13g2[ie]
print @q.xbgr.xq62_u24.qnpn13g2[is]
print @r.xbgr.xq62_u24.rsub[i]
print @c.xbgr.xq62_u24.csub[i]
print @q.xbgr.xq67_u2.qnpn13g2[ic]
print @q.xbgr.xq67_u2.qnpn13g2[ib]
print @q.xbgr.xq67_u2.qnpn13g2[ie]
print @q.xbgr.xq67_u2.qnpn13g2[is]
print @r.xbgr.xq67_u2.rsub[i]
print @c.xbgr.xq67_u2.csub[i]
print @q.xbgr.xq67_u3.qnpn13g2[ic]
print @q.xbgr.xq67_u3.qnpn13g2[ib]
print @q.xbgr.xq67_u3.qnpn13g2[ie]
print @q.xbgr.xq67_u3.qnpn13g2[is]
print @r.xbgr.xq67_u3.rsub[i]
print @c.xbgr.xq67_u3.csub[i]
print @q.xbgr.xq67_u4.qnpn13g2[ic]
print @q.xbgr.xq67_u4.qnpn13g2[ib]
print @q.xbgr.xq67_u4.qnpn13g2[ie]
print @q.xbgr.xq67_u4.qnpn13g2[is]
print @r.xbgr.xq67_u4.rsub[i]
print @c.xbgr.xq67_u4.csub[i]
print @q.xbgr.xq67_u5.qnpn13g2[ic]
print @q.xbgr.xq67_u5.qnpn13g2[ib]
print @q.xbgr.xq67_u5.qnpn13g2[ie]
print @q.xbgr.xq67_u5.qnpn13g2[is]
print @r.xbgr.xq67_u5.rsub[i]
print @c.xbgr.xq67_u5.csub[i]
print @q.xbgr.xq67_u6.qnpn13g2[ic]
print @q.xbgr.xq67_u6.qnpn13g2[ib]
print @q.xbgr.xq67_u6.qnpn13g2[ie]
print @q.xbgr.xq67_u6.qnpn13g2[is]
print @r.xbgr.xq67_u6.rsub[i]
print @c.xbgr.xq67_u6.csub[i]
print @q.xbgr.xq67_u7.qnpn13g2[ic]
print @q.xbgr.xq67_u7.qnpn13g2[ib]
print @q.xbgr.xq67_u7.qnpn13g2[ie]
print @q.xbgr.xq67_u7.qnpn13g2[is]
print @r.xbgr.xq67_u7.rsub[i]
print @c.xbgr.xq67_u7.csub[i]
print @q.xbgr.xq67_u8.qnpn13g2[ic]
print @q.xbgr.xq67_u8.qnpn13g2[ib]
print @q.xbgr.xq67_u8.qnpn13g2[ie]
print @q.xbgr.xq67_u8.qnpn13g2[is]
print @r.xbgr.xq67_u8.rsub[i]
print @c.xbgr.xq67_u8.csub[i]
print @q.xbgr.xq67_u9.qnpn13g2[ic]
print @q.xbgr.xq67_u9.qnpn13g2[ib]
print @q.xbgr.xq67_u9.qnpn13g2[ie]
print @q.xbgr.xq67_u9.qnpn13g2[is]
print @r.xbgr.xq67_u9.rsub[i]
print @c.xbgr.xq67_u9.csub[i]
print @q.xbgr.xq67_u10.qnpn13g2[ic]
print @q.xbgr.xq67_u10.qnpn13g2[ib]
print @q.xbgr.xq67_u10.qnpn13g2[ie]
print @q.xbgr.xq67_u10.qnpn13g2[is]
print @r.xbgr.xq67_u10.rsub[i]
print @c.xbgr.xq67_u10.csub[i]
print @q.xbgr.xq67_u11.qnpn13g2[ic]
print @q.xbgr.xq67_u11.qnpn13g2[ib]
print @q.xbgr.xq67_u11.qnpn13g2[ie]
print @q.xbgr.xq67_u11.qnpn13g2[is]
print @r.xbgr.xq67_u11.rsub[i]
print @c.xbgr.xq67_u11.csub[i]
print @q.xbgr.xq67_u12.qnpn13g2[ic]
print @q.xbgr.xq67_u12.qnpn13g2[ib]
print @q.xbgr.xq67_u12.qnpn13g2[ie]
print @q.xbgr.xq67_u12.qnpn13g2[is]
print @r.xbgr.xq67_u12.rsub[i]
print @c.xbgr.xq67_u12.csub[i]
print @q.xbgr.xq67_u13.qnpn13g2[ic]
print @q.xbgr.xq67_u13.qnpn13g2[ib]
print @q.xbgr.xq67_u13.qnpn13g2[ie]
print @q.xbgr.xq67_u13.qnpn13g2[is]
print @r.xbgr.xq67_u13.rsub[i]
print @c.xbgr.xq67_u13.csub[i]
print @q.xbgr.xq67_u14.qnpn13g2[ic]
print @q.xbgr.xq67_u14.qnpn13g2[ib]
print @q.xbgr.xq67_u14.qnpn13g2[ie]
print @q.xbgr.xq67_u14.qnpn13g2[is]
print @r.xbgr.xq67_u14.rsub[i]
print @c.xbgr.xq67_u14.csub[i]
print @q.xbgr.xq67_u15.qnpn13g2[ic]
print @q.xbgr.xq67_u15.qnpn13g2[ib]
print @q.xbgr.xq67_u15.qnpn13g2[ie]
print @q.xbgr.xq67_u15.qnpn13g2[is]
print @r.xbgr.xq67_u15.rsub[i]
print @c.xbgr.xq67_u15.csub[i]
print @q.xbgr.xq67_u16.qnpn13g2[ic]
print @q.xbgr.xq67_u16.qnpn13g2[ib]
print @q.xbgr.xq67_u16.qnpn13g2[ie]
print @q.xbgr.xq67_u16.qnpn13g2[is]
print @r.xbgr.xq67_u16.rsub[i]
print @c.xbgr.xq67_u16.csub[i]
print @q.xbgr.xq67_u17.qnpn13g2[ic]
print @q.xbgr.xq67_u17.qnpn13g2[ib]
print @q.xbgr.xq67_u17.qnpn13g2[ie]
print @q.xbgr.xq67_u17.qnpn13g2[is]
print @r.xbgr.xq67_u17.rsub[i]
print @c.xbgr.xq67_u17.csub[i]
print @q.xbgr.xq67_u18.qnpn13g2[ic]
print @q.xbgr.xq67_u18.qnpn13g2[ib]
print @q.xbgr.xq67_u18.qnpn13g2[ie]
print @q.xbgr.xq67_u18.qnpn13g2[is]
print @r.xbgr.xq67_u18.rsub[i]
print @c.xbgr.xq67_u18.csub[i]
print @q.xbgr.xq67_u19.qnpn13g2[ic]
print @q.xbgr.xq67_u19.qnpn13g2[ib]
print @q.xbgr.xq67_u19.qnpn13g2[ie]
print @q.xbgr.xq67_u19.qnpn13g2[is]
print @r.xbgr.xq67_u19.rsub[i]
print @c.xbgr.xq67_u19.csub[i]
print @q.xbgr.xq67_u20.qnpn13g2[ic]
print @q.xbgr.xq67_u20.qnpn13g2[ib]
print @q.xbgr.xq67_u20.qnpn13g2[ie]
print @q.xbgr.xq67_u20.qnpn13g2[is]
print @r.xbgr.xq67_u20.rsub[i]
print @c.xbgr.xq67_u20.csub[i]
print @q.xbgr.xq67_u21.qnpn13g2[ic]
print @q.xbgr.xq67_u21.qnpn13g2[ib]
print @q.xbgr.xq67_u21.qnpn13g2[ie]
print @q.xbgr.xq67_u21.qnpn13g2[is]
print @r.xbgr.xq67_u21.rsub[i]
print @c.xbgr.xq67_u21.csub[i]
print @q.xbgr.xq67_u22.qnpn13g2[ic]
print @q.xbgr.xq67_u22.qnpn13g2[ib]
print @q.xbgr.xq67_u22.qnpn13g2[ie]
print @q.xbgr.xq67_u22.qnpn13g2[is]
print @r.xbgr.xq67_u22.rsub[i]
print @c.xbgr.xq67_u22.csub[i]
print @q.xbgr.xq67_u23.qnpn13g2[ic]
print @q.xbgr.xq67_u23.qnpn13g2[ib]
print @q.xbgr.xq67_u23.qnpn13g2[ie]
print @q.xbgr.xq67_u23.qnpn13g2[is]
print @r.xbgr.xq67_u23.rsub[i]
print @c.xbgr.xq67_u23.csub[i]
print @q.xbgr.xq67_u24.qnpn13g2[ic]
print @q.xbgr.xq67_u24.qnpn13g2[ib]
print @q.xbgr.xq67_u24.qnpn13g2[ie]
print @q.xbgr.xq67_u24.qnpn13g2[is]
print @r.xbgr.xq67_u24.rsub[i]
print @c.xbgr.xq67_u24.csub[i]
print @q.xbgr.xq68_u2.qnpn13g2[ic]
print @q.xbgr.xq68_u2.qnpn13g2[ib]
print @q.xbgr.xq68_u2.qnpn13g2[ie]
print @q.xbgr.xq68_u2.qnpn13g2[is]
print @r.xbgr.xq68_u2.rsub[i]
print @c.xbgr.xq68_u2.csub[i]
print @q.xbgr.xq68_u3.qnpn13g2[ic]
print @q.xbgr.xq68_u3.qnpn13g2[ib]
print @q.xbgr.xq68_u3.qnpn13g2[ie]
print @q.xbgr.xq68_u3.qnpn13g2[is]
print @r.xbgr.xq68_u3.rsub[i]
print @c.xbgr.xq68_u3.csub[i]
print @q.xbgr.xq68_u4.qnpn13g2[ic]
print @q.xbgr.xq68_u4.qnpn13g2[ib]
print @q.xbgr.xq68_u4.qnpn13g2[ie]
print @q.xbgr.xq68_u4.qnpn13g2[is]
print @r.xbgr.xq68_u4.rsub[i]
print @c.xbgr.xq68_u4.csub[i]
print @q.xbgr.xq68_u5.qnpn13g2[ic]
print @q.xbgr.xq68_u5.qnpn13g2[ib]
print @q.xbgr.xq68_u5.qnpn13g2[ie]
print @q.xbgr.xq68_u5.qnpn13g2[is]
print @r.xbgr.xq68_u5.rsub[i]
print @c.xbgr.xq68_u5.csub[i]
print @q.xbgr.xq68_u6.qnpn13g2[ic]
print @q.xbgr.xq68_u6.qnpn13g2[ib]
print @q.xbgr.xq68_u6.qnpn13g2[ie]
print @q.xbgr.xq68_u6.qnpn13g2[is]
print @r.xbgr.xq68_u6.rsub[i]
print @c.xbgr.xq68_u6.csub[i]
print @q.xbgr.xq68_u7.qnpn13g2[ic]
print @q.xbgr.xq68_u7.qnpn13g2[ib]
print @q.xbgr.xq68_u7.qnpn13g2[ie]
print @q.xbgr.xq68_u7.qnpn13g2[is]
print @r.xbgr.xq68_u7.rsub[i]
print @c.xbgr.xq68_u7.csub[i]
print @q.xbgr.xq68_u8.qnpn13g2[ic]
print @q.xbgr.xq68_u8.qnpn13g2[ib]
print @q.xbgr.xq68_u8.qnpn13g2[ie]
print @q.xbgr.xq68_u8.qnpn13g2[is]
print @r.xbgr.xq68_u8.rsub[i]
print @c.xbgr.xq68_u8.csub[i]
print @q.xbgr.xq68_u9.qnpn13g2[ic]
print @q.xbgr.xq68_u9.qnpn13g2[ib]
print @q.xbgr.xq68_u9.qnpn13g2[ie]
print @q.xbgr.xq68_u9.qnpn13g2[is]
print @r.xbgr.xq68_u9.rsub[i]
print @c.xbgr.xq68_u9.csub[i]
print @q.xbgr.xq68_u10.qnpn13g2[ic]
print @q.xbgr.xq68_u10.qnpn13g2[ib]
print @q.xbgr.xq68_u10.qnpn13g2[ie]
print @q.xbgr.xq68_u10.qnpn13g2[is]
print @r.xbgr.xq68_u10.rsub[i]
print @c.xbgr.xq68_u10.csub[i]
print @q.xbgr.xq68_u11.qnpn13g2[ic]
print @q.xbgr.xq68_u11.qnpn13g2[ib]
print @q.xbgr.xq68_u11.qnpn13g2[ie]
print @q.xbgr.xq68_u11.qnpn13g2[is]
print @r.xbgr.xq68_u11.rsub[i]
print @c.xbgr.xq68_u11.csub[i]
print @q.xbgr.xq68_u12.qnpn13g2[ic]
print @q.xbgr.xq68_u12.qnpn13g2[ib]
print @q.xbgr.xq68_u12.qnpn13g2[ie]
print @q.xbgr.xq68_u12.qnpn13g2[is]
print @r.xbgr.xq68_u12.rsub[i]
print @c.xbgr.xq68_u12.csub[i]
print @q.xbgr.xq68_u13.qnpn13g2[ic]
print @q.xbgr.xq68_u13.qnpn13g2[ib]
print @q.xbgr.xq68_u13.qnpn13g2[ie]
print @q.xbgr.xq68_u13.qnpn13g2[is]
print @r.xbgr.xq68_u13.rsub[i]
print @c.xbgr.xq68_u13.csub[i]
print @q.xbgr.xq68_u14.qnpn13g2[ic]
print @q.xbgr.xq68_u14.qnpn13g2[ib]
print @q.xbgr.xq68_u14.qnpn13g2[ie]
print @q.xbgr.xq68_u14.qnpn13g2[is]
print @r.xbgr.xq68_u14.rsub[i]
print @c.xbgr.xq68_u14.csub[i]
print @q.xbgr.xq68_u15.qnpn13g2[ic]
print @q.xbgr.xq68_u15.qnpn13g2[ib]
print @q.xbgr.xq68_u15.qnpn13g2[ie]
print @q.xbgr.xq68_u15.qnpn13g2[is]
print @r.xbgr.xq68_u15.rsub[i]
print @c.xbgr.xq68_u15.csub[i]
print @q.xbgr.xq68_u16.qnpn13g2[ic]
print @q.xbgr.xq68_u16.qnpn13g2[ib]
print @q.xbgr.xq68_u16.qnpn13g2[ie]
print @q.xbgr.xq68_u16.qnpn13g2[is]
print @r.xbgr.xq68_u16.rsub[i]
print @c.xbgr.xq68_u16.csub[i]
print @q.xbgr.xq68_u17.qnpn13g2[ic]
print @q.xbgr.xq68_u17.qnpn13g2[ib]
print @q.xbgr.xq68_u17.qnpn13g2[ie]
print @q.xbgr.xq68_u17.qnpn13g2[is]
print @r.xbgr.xq68_u17.rsub[i]
print @c.xbgr.xq68_u17.csub[i]
print @q.xbgr.xq68_u18.qnpn13g2[ic]
print @q.xbgr.xq68_u18.qnpn13g2[ib]
print @q.xbgr.xq68_u18.qnpn13g2[ie]
print @q.xbgr.xq68_u18.qnpn13g2[is]
print @r.xbgr.xq68_u18.rsub[i]
print @c.xbgr.xq68_u18.csub[i]
print @q.xbgr.xq68_u19.qnpn13g2[ic]
print @q.xbgr.xq68_u19.qnpn13g2[ib]
print @q.xbgr.xq68_u19.qnpn13g2[ie]
print @q.xbgr.xq68_u19.qnpn13g2[is]
print @r.xbgr.xq68_u19.rsub[i]
print @c.xbgr.xq68_u19.csub[i]
print @q.xbgr.xq68_u20.qnpn13g2[ic]
print @q.xbgr.xq68_u20.qnpn13g2[ib]
print @q.xbgr.xq68_u20.qnpn13g2[ie]
print @q.xbgr.xq68_u20.qnpn13g2[is]
print @r.xbgr.xq68_u20.rsub[i]
print @c.xbgr.xq68_u20.csub[i]
print @q.xbgr.xq68_u21.qnpn13g2[ic]
print @q.xbgr.xq68_u21.qnpn13g2[ib]
print @q.xbgr.xq68_u21.qnpn13g2[ie]
print @q.xbgr.xq68_u21.qnpn13g2[is]
print @r.xbgr.xq68_u21.rsub[i]
print @c.xbgr.xq68_u21.csub[i]
print @q.xbgr.xq68_u22.qnpn13g2[ic]
print @q.xbgr.xq68_u22.qnpn13g2[ib]
print @q.xbgr.xq68_u22.qnpn13g2[ie]
print @q.xbgr.xq68_u22.qnpn13g2[is]
print @r.xbgr.xq68_u22.rsub[i]
print @c.xbgr.xq68_u22.csub[i]
print @q.xbgr.xq68_u23.qnpn13g2[ic]
print @q.xbgr.xq68_u23.qnpn13g2[ib]
print @q.xbgr.xq68_u23.qnpn13g2[ie]
print @q.xbgr.xq68_u23.qnpn13g2[is]
print @r.xbgr.xq68_u23.rsub[i]
print @c.xbgr.xq68_u23.csub[i]
print @q.xbgr.xq68_u24.qnpn13g2[ic]
print @q.xbgr.xq68_u24.qnpn13g2[ib]
print @q.xbgr.xq68_u24.qnpn13g2[ie]
print @q.xbgr.xq68_u24.qnpn13g2[is]
print @r.xbgr.xq68_u24.rsub[i]
print @c.xbgr.xq68_u24.csub[i]
print @q.xbgr.xq69_u2.qnpn13g2[ic]
print @q.xbgr.xq69_u2.qnpn13g2[ib]
print @q.xbgr.xq69_u2.qnpn13g2[ie]
print @q.xbgr.xq69_u2.qnpn13g2[is]
print @r.xbgr.xq69_u2.rsub[i]
print @c.xbgr.xq69_u2.csub[i]
print @q.xbgr.xq69_u3.qnpn13g2[ic]
print @q.xbgr.xq69_u3.qnpn13g2[ib]
print @q.xbgr.xq69_u3.qnpn13g2[ie]
print @q.xbgr.xq69_u3.qnpn13g2[is]
print @r.xbgr.xq69_u3.rsub[i]
print @c.xbgr.xq69_u3.csub[i]
print @q.xbgr.xq69_u4.qnpn13g2[ic]
print @q.xbgr.xq69_u4.qnpn13g2[ib]
print @q.xbgr.xq69_u4.qnpn13g2[ie]
print @q.xbgr.xq69_u4.qnpn13g2[is]
print @r.xbgr.xq69_u4.rsub[i]
print @c.xbgr.xq69_u4.csub[i]
print @q.xbgr.xq69_u5.qnpn13g2[ic]
print @q.xbgr.xq69_u5.qnpn13g2[ib]
print @q.xbgr.xq69_u5.qnpn13g2[ie]
print @q.xbgr.xq69_u5.qnpn13g2[is]
print @r.xbgr.xq69_u5.rsub[i]
print @c.xbgr.xq69_u5.csub[i]
print @q.xbgr.xq69_u6.qnpn13g2[ic]
print @q.xbgr.xq69_u6.qnpn13g2[ib]
print @q.xbgr.xq69_u6.qnpn13g2[ie]
print @q.xbgr.xq69_u6.qnpn13g2[is]
print @r.xbgr.xq69_u6.rsub[i]
print @c.xbgr.xq69_u6.csub[i]
print @q.xbgr.xq69_u7.qnpn13g2[ic]
print @q.xbgr.xq69_u7.qnpn13g2[ib]
print @q.xbgr.xq69_u7.qnpn13g2[ie]
print @q.xbgr.xq69_u7.qnpn13g2[is]
print @r.xbgr.xq69_u7.rsub[i]
print @c.xbgr.xq69_u7.csub[i]
print @q.xbgr.xq69_u8.qnpn13g2[ic]
print @q.xbgr.xq69_u8.qnpn13g2[ib]
print @q.xbgr.xq69_u8.qnpn13g2[ie]
print @q.xbgr.xq69_u8.qnpn13g2[is]
print @r.xbgr.xq69_u8.rsub[i]
print @c.xbgr.xq69_u8.csub[i]
print @q.xbgr.xq69_u9.qnpn13g2[ic]
print @q.xbgr.xq69_u9.qnpn13g2[ib]
print @q.xbgr.xq69_u9.qnpn13g2[ie]
print @q.xbgr.xq69_u9.qnpn13g2[is]
print @r.xbgr.xq69_u9.rsub[i]
print @c.xbgr.xq69_u9.csub[i]
print @q.xbgr.xq69_u10.qnpn13g2[ic]
print @q.xbgr.xq69_u10.qnpn13g2[ib]
print @q.xbgr.xq69_u10.qnpn13g2[ie]
print @q.xbgr.xq69_u10.qnpn13g2[is]
print @r.xbgr.xq69_u10.rsub[i]
print @c.xbgr.xq69_u10.csub[i]
print @q.xbgr.xq69_u11.qnpn13g2[ic]
print @q.xbgr.xq69_u11.qnpn13g2[ib]
print @q.xbgr.xq69_u11.qnpn13g2[ie]
print @q.xbgr.xq69_u11.qnpn13g2[is]
print @r.xbgr.xq69_u11.rsub[i]
print @c.xbgr.xq69_u11.csub[i]
print @q.xbgr.xq69_u12.qnpn13g2[ic]
print @q.xbgr.xq69_u12.qnpn13g2[ib]
print @q.xbgr.xq69_u12.qnpn13g2[ie]
print @q.xbgr.xq69_u12.qnpn13g2[is]
print @r.xbgr.xq69_u12.rsub[i]
print @c.xbgr.xq69_u12.csub[i]
print @q.xbgr.xq69_u13.qnpn13g2[ic]
print @q.xbgr.xq69_u13.qnpn13g2[ib]
print @q.xbgr.xq69_u13.qnpn13g2[ie]
print @q.xbgr.xq69_u13.qnpn13g2[is]
print @r.xbgr.xq69_u13.rsub[i]
print @c.xbgr.xq69_u13.csub[i]
print @q.xbgr.xq69_u14.qnpn13g2[ic]
print @q.xbgr.xq69_u14.qnpn13g2[ib]
print @q.xbgr.xq69_u14.qnpn13g2[ie]
print @q.xbgr.xq69_u14.qnpn13g2[is]
print @r.xbgr.xq69_u14.rsub[i]
print @c.xbgr.xq69_u14.csub[i]
print @q.xbgr.xq69_u15.qnpn13g2[ic]
print @q.xbgr.xq69_u15.qnpn13g2[ib]
print @q.xbgr.xq69_u15.qnpn13g2[ie]
print @q.xbgr.xq69_u15.qnpn13g2[is]
print @r.xbgr.xq69_u15.rsub[i]
print @c.xbgr.xq69_u15.csub[i]
print @q.xbgr.xq69_u16.qnpn13g2[ic]
print @q.xbgr.xq69_u16.qnpn13g2[ib]
print @q.xbgr.xq69_u16.qnpn13g2[ie]
print @q.xbgr.xq69_u16.qnpn13g2[is]
print @r.xbgr.xq69_u16.rsub[i]
print @c.xbgr.xq69_u16.csub[i]
print @q.xbgr.xq69_u17.qnpn13g2[ic]
print @q.xbgr.xq69_u17.qnpn13g2[ib]
print @q.xbgr.xq69_u17.qnpn13g2[ie]
print @q.xbgr.xq69_u17.qnpn13g2[is]
print @r.xbgr.xq69_u17.rsub[i]
print @c.xbgr.xq69_u17.csub[i]
print @q.xbgr.xq69_u18.qnpn13g2[ic]
print @q.xbgr.xq69_u18.qnpn13g2[ib]
print @q.xbgr.xq69_u18.qnpn13g2[ie]
print @q.xbgr.xq69_u18.qnpn13g2[is]
print @r.xbgr.xq69_u18.rsub[i]
print @c.xbgr.xq69_u18.csub[i]
print @q.xbgr.xq69_u19.qnpn13g2[ic]
print @q.xbgr.xq69_u19.qnpn13g2[ib]
print @q.xbgr.xq69_u19.qnpn13g2[ie]
print @q.xbgr.xq69_u19.qnpn13g2[is]
print @r.xbgr.xq69_u19.rsub[i]
print @c.xbgr.xq69_u19.csub[i]
print @q.xbgr.xq69_u20.qnpn13g2[ic]
print @q.xbgr.xq69_u20.qnpn13g2[ib]
print @q.xbgr.xq69_u20.qnpn13g2[ie]
print @q.xbgr.xq69_u20.qnpn13g2[is]
print @r.xbgr.xq69_u20.rsub[i]
print @c.xbgr.xq69_u20.csub[i]
print @q.xbgr.xq69_u21.qnpn13g2[ic]
print @q.xbgr.xq69_u21.qnpn13g2[ib]
print @q.xbgr.xq69_u21.qnpn13g2[ie]
print @q.xbgr.xq69_u21.qnpn13g2[is]
print @r.xbgr.xq69_u21.rsub[i]
print @c.xbgr.xq69_u21.csub[i]
print @q.xbgr.xq69_u22.qnpn13g2[ic]
print @q.xbgr.xq69_u22.qnpn13g2[ib]
print @q.xbgr.xq69_u22.qnpn13g2[ie]
print @q.xbgr.xq69_u22.qnpn13g2[is]
print @r.xbgr.xq69_u22.rsub[i]
print @c.xbgr.xq69_u22.csub[i]
print @q.xbgr.xq69_u23.qnpn13g2[ic]
print @q.xbgr.xq69_u23.qnpn13g2[ib]
print @q.xbgr.xq69_u23.qnpn13g2[ie]
print @q.xbgr.xq69_u23.qnpn13g2[is]
print @r.xbgr.xq69_u23.rsub[i]
print @c.xbgr.xq69_u23.csub[i]
print @q.xbgr.xq69_u24.qnpn13g2[ic]
print @q.xbgr.xq69_u24.qnpn13g2[ib]
print @q.xbgr.xq69_u24.qnpn13g2[ie]
print @q.xbgr.xq69_u24.qnpn13g2[is]
print @r.xbgr.xq69_u24.rsub[i]
print @c.xbgr.xq69_u24.csub[i]
print @q.xbgr.xq70_u2.qnpn13g2[ic]
print @q.xbgr.xq70_u2.qnpn13g2[ib]
print @q.xbgr.xq70_u2.qnpn13g2[ie]
print @q.xbgr.xq70_u2.qnpn13g2[is]
print @r.xbgr.xq70_u2.rsub[i]
print @c.xbgr.xq70_u2.csub[i]
print @q.xbgr.xq70_u3.qnpn13g2[ic]
print @q.xbgr.xq70_u3.qnpn13g2[ib]
print @q.xbgr.xq70_u3.qnpn13g2[ie]
print @q.xbgr.xq70_u3.qnpn13g2[is]
print @r.xbgr.xq70_u3.rsub[i]
print @c.xbgr.xq70_u3.csub[i]
print @q.xbgr.xq70_u4.qnpn13g2[ic]
print @q.xbgr.xq70_u4.qnpn13g2[ib]
print @q.xbgr.xq70_u4.qnpn13g2[ie]
print @q.xbgr.xq70_u4.qnpn13g2[is]
print @r.xbgr.xq70_u4.rsub[i]
print @c.xbgr.xq70_u4.csub[i]
print @q.xbgr.xq70_u5.qnpn13g2[ic]
print @q.xbgr.xq70_u5.qnpn13g2[ib]
print @q.xbgr.xq70_u5.qnpn13g2[ie]
print @q.xbgr.xq70_u5.qnpn13g2[is]
print @r.xbgr.xq70_u5.rsub[i]
print @c.xbgr.xq70_u5.csub[i]
print @q.xbgr.xq70_u6.qnpn13g2[ic]
print @q.xbgr.xq70_u6.qnpn13g2[ib]
print @q.xbgr.xq70_u6.qnpn13g2[ie]
print @q.xbgr.xq70_u6.qnpn13g2[is]
print @r.xbgr.xq70_u6.rsub[i]
print @c.xbgr.xq70_u6.csub[i]
print @q.xbgr.xq70_u7.qnpn13g2[ic]
print @q.xbgr.xq70_u7.qnpn13g2[ib]
print @q.xbgr.xq70_u7.qnpn13g2[ie]
print @q.xbgr.xq70_u7.qnpn13g2[is]
print @r.xbgr.xq70_u7.rsub[i]
print @c.xbgr.xq70_u7.csub[i]
print @q.xbgr.xq70_u8.qnpn13g2[ic]
print @q.xbgr.xq70_u8.qnpn13g2[ib]
print @q.xbgr.xq70_u8.qnpn13g2[ie]
print @q.xbgr.xq70_u8.qnpn13g2[is]
print @r.xbgr.xq70_u8.rsub[i]
print @c.xbgr.xq70_u8.csub[i]
print @q.xbgr.xq70_u9.qnpn13g2[ic]
print @q.xbgr.xq70_u9.qnpn13g2[ib]
print @q.xbgr.xq70_u9.qnpn13g2[ie]
print @q.xbgr.xq70_u9.qnpn13g2[is]
print @r.xbgr.xq70_u9.rsub[i]
print @c.xbgr.xq70_u9.csub[i]
print @q.xbgr.xq70_u10.qnpn13g2[ic]
print @q.xbgr.xq70_u10.qnpn13g2[ib]
print @q.xbgr.xq70_u10.qnpn13g2[ie]
print @q.xbgr.xq70_u10.qnpn13g2[is]
print @r.xbgr.xq70_u10.rsub[i]
print @c.xbgr.xq70_u10.csub[i]
print @q.xbgr.xq70_u11.qnpn13g2[ic]
print @q.xbgr.xq70_u11.qnpn13g2[ib]
print @q.xbgr.xq70_u11.qnpn13g2[ie]
print @q.xbgr.xq70_u11.qnpn13g2[is]
print @r.xbgr.xq70_u11.rsub[i]
print @c.xbgr.xq70_u11.csub[i]
print @q.xbgr.xq70_u12.qnpn13g2[ic]
print @q.xbgr.xq70_u12.qnpn13g2[ib]
print @q.xbgr.xq70_u12.qnpn13g2[ie]
print @q.xbgr.xq70_u12.qnpn13g2[is]
print @r.xbgr.xq70_u12.rsub[i]
print @c.xbgr.xq70_u12.csub[i]
print @q.xbgr.xq70_u13.qnpn13g2[ic]
print @q.xbgr.xq70_u13.qnpn13g2[ib]
print @q.xbgr.xq70_u13.qnpn13g2[ie]
print @q.xbgr.xq70_u13.qnpn13g2[is]
print @r.xbgr.xq70_u13.rsub[i]
print @c.xbgr.xq70_u13.csub[i]
print @q.xbgr.xq70_u14.qnpn13g2[ic]
print @q.xbgr.xq70_u14.qnpn13g2[ib]
print @q.xbgr.xq70_u14.qnpn13g2[ie]
print @q.xbgr.xq70_u14.qnpn13g2[is]
print @r.xbgr.xq70_u14.rsub[i]
print @c.xbgr.xq70_u14.csub[i]
print @q.xbgr.xq70_u15.qnpn13g2[ic]
print @q.xbgr.xq70_u15.qnpn13g2[ib]
print @q.xbgr.xq70_u15.qnpn13g2[ie]
print @q.xbgr.xq70_u15.qnpn13g2[is]
print @r.xbgr.xq70_u15.rsub[i]
print @c.xbgr.xq70_u15.csub[i]
print @q.xbgr.xq70_u16.qnpn13g2[ic]
print @q.xbgr.xq70_u16.qnpn13g2[ib]
print @q.xbgr.xq70_u16.qnpn13g2[ie]
print @q.xbgr.xq70_u16.qnpn13g2[is]
print @r.xbgr.xq70_u16.rsub[i]
print @c.xbgr.xq70_u16.csub[i]
print @q.xbgr.xq70_u17.qnpn13g2[ic]
print @q.xbgr.xq70_u17.qnpn13g2[ib]
print @q.xbgr.xq70_u17.qnpn13g2[ie]
print @q.xbgr.xq70_u17.qnpn13g2[is]
print @r.xbgr.xq70_u17.rsub[i]
print @c.xbgr.xq70_u17.csub[i]
print @q.xbgr.xq70_u18.qnpn13g2[ic]
print @q.xbgr.xq70_u18.qnpn13g2[ib]
print @q.xbgr.xq70_u18.qnpn13g2[ie]
print @q.xbgr.xq70_u18.qnpn13g2[is]
print @r.xbgr.xq70_u18.rsub[i]
print @c.xbgr.xq70_u18.csub[i]
print @q.xbgr.xq70_u19.qnpn13g2[ic]
print @q.xbgr.xq70_u19.qnpn13g2[ib]
print @q.xbgr.xq70_u19.qnpn13g2[ie]
print @q.xbgr.xq70_u19.qnpn13g2[is]
print @r.xbgr.xq70_u19.rsub[i]
print @c.xbgr.xq70_u19.csub[i]
print @q.xbgr.xq70_u20.qnpn13g2[ic]
print @q.xbgr.xq70_u20.qnpn13g2[ib]
print @q.xbgr.xq70_u20.qnpn13g2[ie]
print @q.xbgr.xq70_u20.qnpn13g2[is]
print @r.xbgr.xq70_u20.rsub[i]
print @c.xbgr.xq70_u20.csub[i]
print @q.xbgr.xq70_u21.qnpn13g2[ic]
print @q.xbgr.xq70_u21.qnpn13g2[ib]
print @q.xbgr.xq70_u21.qnpn13g2[ie]
print @q.xbgr.xq70_u21.qnpn13g2[is]
print @r.xbgr.xq70_u21.rsub[i]
print @c.xbgr.xq70_u21.csub[i]
print @q.xbgr.xq70_u22.qnpn13g2[ic]
print @q.xbgr.xq70_u22.qnpn13g2[ib]
print @q.xbgr.xq70_u22.qnpn13g2[ie]
print @q.xbgr.xq70_u22.qnpn13g2[is]
print @r.xbgr.xq70_u22.rsub[i]
print @c.xbgr.xq70_u22.csub[i]
print @q.xbgr.xq70_u23.qnpn13g2[ic]
print @q.xbgr.xq70_u23.qnpn13g2[ib]
print @q.xbgr.xq70_u23.qnpn13g2[ie]
print @q.xbgr.xq70_u23.qnpn13g2[is]
print @r.xbgr.xq70_u23.rsub[i]
print @c.xbgr.xq70_u23.csub[i]
print @q.xbgr.xq70_u24.qnpn13g2[ic]
print @q.xbgr.xq70_u24.qnpn13g2[ib]
print @q.xbgr.xq70_u24.qnpn13g2[ie]
print @q.xbgr.xq70_u24.qnpn13g2[is]
print @r.xbgr.xq70_u24.rsub[i]
print @c.xbgr.xq70_u24.csub[i]
print @q.xbgr.xq71_u2.qnpn13g2[ic]
print @q.xbgr.xq71_u2.qnpn13g2[ib]
print @q.xbgr.xq71_u2.qnpn13g2[ie]
print @q.xbgr.xq71_u2.qnpn13g2[is]
print @r.xbgr.xq71_u2.rsub[i]
print @c.xbgr.xq71_u2.csub[i]
print @q.xbgr.xq71_u3.qnpn13g2[ic]
print @q.xbgr.xq71_u3.qnpn13g2[ib]
print @q.xbgr.xq71_u3.qnpn13g2[ie]
print @q.xbgr.xq71_u3.qnpn13g2[is]
print @r.xbgr.xq71_u3.rsub[i]
print @c.xbgr.xq71_u3.csub[i]
print @q.xbgr.xq71_u4.qnpn13g2[ic]
print @q.xbgr.xq71_u4.qnpn13g2[ib]
print @q.xbgr.xq71_u4.qnpn13g2[ie]
print @q.xbgr.xq71_u4.qnpn13g2[is]
print @r.xbgr.xq71_u4.rsub[i]
print @c.xbgr.xq71_u4.csub[i]
print @q.xbgr.xq71_u5.qnpn13g2[ic]
print @q.xbgr.xq71_u5.qnpn13g2[ib]
print @q.xbgr.xq71_u5.qnpn13g2[ie]
print @q.xbgr.xq71_u5.qnpn13g2[is]
print @r.xbgr.xq71_u5.rsub[i]
print @c.xbgr.xq71_u5.csub[i]
print @q.xbgr.xq71_u6.qnpn13g2[ic]
print @q.xbgr.xq71_u6.qnpn13g2[ib]
print @q.xbgr.xq71_u6.qnpn13g2[ie]
print @q.xbgr.xq71_u6.qnpn13g2[is]
print @r.xbgr.xq71_u6.rsub[i]
print @c.xbgr.xq71_u6.csub[i]
print @q.xbgr.xq71_u7.qnpn13g2[ic]
print @q.xbgr.xq71_u7.qnpn13g2[ib]
print @q.xbgr.xq71_u7.qnpn13g2[ie]
print @q.xbgr.xq71_u7.qnpn13g2[is]
print @r.xbgr.xq71_u7.rsub[i]
print @c.xbgr.xq71_u7.csub[i]
print @q.xbgr.xq71_u8.qnpn13g2[ic]
print @q.xbgr.xq71_u8.qnpn13g2[ib]
print @q.xbgr.xq71_u8.qnpn13g2[ie]
print @q.xbgr.xq71_u8.qnpn13g2[is]
print @r.xbgr.xq71_u8.rsub[i]
print @c.xbgr.xq71_u8.csub[i]
print @q.xbgr.xq71_u9.qnpn13g2[ic]
print @q.xbgr.xq71_u9.qnpn13g2[ib]
print @q.xbgr.xq71_u9.qnpn13g2[ie]
print @q.xbgr.xq71_u9.qnpn13g2[is]
print @r.xbgr.xq71_u9.rsub[i]
print @c.xbgr.xq71_u9.csub[i]
print @q.xbgr.xq71_u10.qnpn13g2[ic]
print @q.xbgr.xq71_u10.qnpn13g2[ib]
print @q.xbgr.xq71_u10.qnpn13g2[ie]
print @q.xbgr.xq71_u10.qnpn13g2[is]
print @r.xbgr.xq71_u10.rsub[i]
print @c.xbgr.xq71_u10.csub[i]
print @q.xbgr.xq71_u11.qnpn13g2[ic]
print @q.xbgr.xq71_u11.qnpn13g2[ib]
print @q.xbgr.xq71_u11.qnpn13g2[ie]
print @q.xbgr.xq71_u11.qnpn13g2[is]
print @r.xbgr.xq71_u11.rsub[i]
print @c.xbgr.xq71_u11.csub[i]
print @q.xbgr.xq71_u12.qnpn13g2[ic]
print @q.xbgr.xq71_u12.qnpn13g2[ib]
print @q.xbgr.xq71_u12.qnpn13g2[ie]
print @q.xbgr.xq71_u12.qnpn13g2[is]
print @r.xbgr.xq71_u12.rsub[i]
print @c.xbgr.xq71_u12.csub[i]
print @q.xbgr.xq71_u13.qnpn13g2[ic]
print @q.xbgr.xq71_u13.qnpn13g2[ib]
print @q.xbgr.xq71_u13.qnpn13g2[ie]
print @q.xbgr.xq71_u13.qnpn13g2[is]
print @r.xbgr.xq71_u13.rsub[i]
print @c.xbgr.xq71_u13.csub[i]
print @q.xbgr.xq71_u14.qnpn13g2[ic]
print @q.xbgr.xq71_u14.qnpn13g2[ib]
print @q.xbgr.xq71_u14.qnpn13g2[ie]
print @q.xbgr.xq71_u14.qnpn13g2[is]
print @r.xbgr.xq71_u14.rsub[i]
print @c.xbgr.xq71_u14.csub[i]
print @q.xbgr.xq71_u15.qnpn13g2[ic]
print @q.xbgr.xq71_u15.qnpn13g2[ib]
print @q.xbgr.xq71_u15.qnpn13g2[ie]
print @q.xbgr.xq71_u15.qnpn13g2[is]
print @r.xbgr.xq71_u15.rsub[i]
print @c.xbgr.xq71_u15.csub[i]
print @q.xbgr.xq71_u16.qnpn13g2[ic]
print @q.xbgr.xq71_u16.qnpn13g2[ib]
print @q.xbgr.xq71_u16.qnpn13g2[ie]
print @q.xbgr.xq71_u16.qnpn13g2[is]
print @r.xbgr.xq71_u16.rsub[i]
print @c.xbgr.xq71_u16.csub[i]
print @q.xbgr.xq71_u17.qnpn13g2[ic]
print @q.xbgr.xq71_u17.qnpn13g2[ib]
print @q.xbgr.xq71_u17.qnpn13g2[ie]
print @q.xbgr.xq71_u17.qnpn13g2[is]
print @r.xbgr.xq71_u17.rsub[i]
print @c.xbgr.xq71_u17.csub[i]
print @q.xbgr.xq71_u18.qnpn13g2[ic]
print @q.xbgr.xq71_u18.qnpn13g2[ib]
print @q.xbgr.xq71_u18.qnpn13g2[ie]
print @q.xbgr.xq71_u18.qnpn13g2[is]
print @r.xbgr.xq71_u18.rsub[i]
print @c.xbgr.xq71_u18.csub[i]
print @q.xbgr.xq71_u19.qnpn13g2[ic]
print @q.xbgr.xq71_u19.qnpn13g2[ib]
print @q.xbgr.xq71_u19.qnpn13g2[ie]
print @q.xbgr.xq71_u19.qnpn13g2[is]
print @r.xbgr.xq71_u19.rsub[i]
print @c.xbgr.xq71_u19.csub[i]
print @q.xbgr.xq71_u20.qnpn13g2[ic]
print @q.xbgr.xq71_u20.qnpn13g2[ib]
print @q.xbgr.xq71_u20.qnpn13g2[ie]
print @q.xbgr.xq71_u20.qnpn13g2[is]
print @r.xbgr.xq71_u20.rsub[i]
print @c.xbgr.xq71_u20.csub[i]
print @q.xbgr.xq71_u21.qnpn13g2[ic]
print @q.xbgr.xq71_u21.qnpn13g2[ib]
print @q.xbgr.xq71_u21.qnpn13g2[ie]
print @q.xbgr.xq71_u21.qnpn13g2[is]
print @r.xbgr.xq71_u21.rsub[i]
print @c.xbgr.xq71_u21.csub[i]
print @q.xbgr.xq71_u22.qnpn13g2[ic]
print @q.xbgr.xq71_u22.qnpn13g2[ib]
print @q.xbgr.xq71_u22.qnpn13g2[ie]
print @q.xbgr.xq71_u22.qnpn13g2[is]
print @r.xbgr.xq71_u22.rsub[i]
print @c.xbgr.xq71_u22.csub[i]
print @q.xbgr.xq71_u23.qnpn13g2[ic]
print @q.xbgr.xq71_u23.qnpn13g2[ib]
print @q.xbgr.xq71_u23.qnpn13g2[ie]
print @q.xbgr.xq71_u23.qnpn13g2[is]
print @r.xbgr.xq71_u23.rsub[i]
print @c.xbgr.xq71_u23.csub[i]
print @q.xbgr.xq71_u24.qnpn13g2[ic]
print @q.xbgr.xq71_u24.qnpn13g2[ib]
print @q.xbgr.xq71_u24.qnpn13g2[ie]
print @q.xbgr.xq71_u24.qnpn13g2[is]
print @r.xbgr.xq71_u24.rsub[i]
print @c.xbgr.xq71_u24.csub[i]
print @q.xbgr.xq72_u2.qnpn13g2[ic]
print @q.xbgr.xq72_u2.qnpn13g2[ib]
print @q.xbgr.xq72_u2.qnpn13g2[ie]
print @q.xbgr.xq72_u2.qnpn13g2[is]
print @r.xbgr.xq72_u2.rsub[i]
print @c.xbgr.xq72_u2.csub[i]
print @q.xbgr.xq72_u3.qnpn13g2[ic]
print @q.xbgr.xq72_u3.qnpn13g2[ib]
print @q.xbgr.xq72_u3.qnpn13g2[ie]
print @q.xbgr.xq72_u3.qnpn13g2[is]
print @r.xbgr.xq72_u3.rsub[i]
print @c.xbgr.xq72_u3.csub[i]
print @q.xbgr.xq72_u4.qnpn13g2[ic]
print @q.xbgr.xq72_u4.qnpn13g2[ib]
print @q.xbgr.xq72_u4.qnpn13g2[ie]
print @q.xbgr.xq72_u4.qnpn13g2[is]
print @r.xbgr.xq72_u4.rsub[i]
print @c.xbgr.xq72_u4.csub[i]
print @q.xbgr.xq72_u5.qnpn13g2[ic]
print @q.xbgr.xq72_u5.qnpn13g2[ib]
print @q.xbgr.xq72_u5.qnpn13g2[ie]
print @q.xbgr.xq72_u5.qnpn13g2[is]
print @r.xbgr.xq72_u5.rsub[i]
print @c.xbgr.xq72_u5.csub[i]
print @q.xbgr.xq72_u6.qnpn13g2[ic]
print @q.xbgr.xq72_u6.qnpn13g2[ib]
print @q.xbgr.xq72_u6.qnpn13g2[ie]
print @q.xbgr.xq72_u6.qnpn13g2[is]
print @r.xbgr.xq72_u6.rsub[i]
print @c.xbgr.xq72_u6.csub[i]
print @q.xbgr.xq72_u7.qnpn13g2[ic]
print @q.xbgr.xq72_u7.qnpn13g2[ib]
print @q.xbgr.xq72_u7.qnpn13g2[ie]
print @q.xbgr.xq72_u7.qnpn13g2[is]
print @r.xbgr.xq72_u7.rsub[i]
print @c.xbgr.xq72_u7.csub[i]
print @q.xbgr.xq72_u8.qnpn13g2[ic]
print @q.xbgr.xq72_u8.qnpn13g2[ib]
print @q.xbgr.xq72_u8.qnpn13g2[ie]
print @q.xbgr.xq72_u8.qnpn13g2[is]
print @r.xbgr.xq72_u8.rsub[i]
print @c.xbgr.xq72_u8.csub[i]
print @q.xbgr.xq72_u9.qnpn13g2[ic]
print @q.xbgr.xq72_u9.qnpn13g2[ib]
print @q.xbgr.xq72_u9.qnpn13g2[ie]
print @q.xbgr.xq72_u9.qnpn13g2[is]
print @r.xbgr.xq72_u9.rsub[i]
print @c.xbgr.xq72_u9.csub[i]
print @q.xbgr.xq72_u10.qnpn13g2[ic]
print @q.xbgr.xq72_u10.qnpn13g2[ib]
print @q.xbgr.xq72_u10.qnpn13g2[ie]
print @q.xbgr.xq72_u10.qnpn13g2[is]
print @r.xbgr.xq72_u10.rsub[i]
print @c.xbgr.xq72_u10.csub[i]
print @q.xbgr.xq72_u11.qnpn13g2[ic]
print @q.xbgr.xq72_u11.qnpn13g2[ib]
print @q.xbgr.xq72_u11.qnpn13g2[ie]
print @q.xbgr.xq72_u11.qnpn13g2[is]
print @r.xbgr.xq72_u11.rsub[i]
print @c.xbgr.xq72_u11.csub[i]
print @q.xbgr.xq72_u12.qnpn13g2[ic]
print @q.xbgr.xq72_u12.qnpn13g2[ib]
print @q.xbgr.xq72_u12.qnpn13g2[ie]
print @q.xbgr.xq72_u12.qnpn13g2[is]
print @r.xbgr.xq72_u12.rsub[i]
print @c.xbgr.xq72_u12.csub[i]
print @q.xbgr.xq72_u13.qnpn13g2[ic]
print @q.xbgr.xq72_u13.qnpn13g2[ib]
print @q.xbgr.xq72_u13.qnpn13g2[ie]
print @q.xbgr.xq72_u13.qnpn13g2[is]
print @r.xbgr.xq72_u13.rsub[i]
print @c.xbgr.xq72_u13.csub[i]
print @q.xbgr.xq72_u14.qnpn13g2[ic]
print @q.xbgr.xq72_u14.qnpn13g2[ib]
print @q.xbgr.xq72_u14.qnpn13g2[ie]
print @q.xbgr.xq72_u14.qnpn13g2[is]
print @r.xbgr.xq72_u14.rsub[i]
print @c.xbgr.xq72_u14.csub[i]
print @q.xbgr.xq72_u15.qnpn13g2[ic]
print @q.xbgr.xq72_u15.qnpn13g2[ib]
print @q.xbgr.xq72_u15.qnpn13g2[ie]
print @q.xbgr.xq72_u15.qnpn13g2[is]
print @r.xbgr.xq72_u15.rsub[i]
print @c.xbgr.xq72_u15.csub[i]
print @q.xbgr.xq72_u16.qnpn13g2[ic]
print @q.xbgr.xq72_u16.qnpn13g2[ib]
print @q.xbgr.xq72_u16.qnpn13g2[ie]
print @q.xbgr.xq72_u16.qnpn13g2[is]
print @r.xbgr.xq72_u16.rsub[i]
print @c.xbgr.xq72_u16.csub[i]
print @q.xbgr.xq72_u17.qnpn13g2[ic]
print @q.xbgr.xq72_u17.qnpn13g2[ib]
print @q.xbgr.xq72_u17.qnpn13g2[ie]
print @q.xbgr.xq72_u17.qnpn13g2[is]
print @r.xbgr.xq72_u17.rsub[i]
print @c.xbgr.xq72_u17.csub[i]
print @q.xbgr.xq72_u18.qnpn13g2[ic]
print @q.xbgr.xq72_u18.qnpn13g2[ib]
print @q.xbgr.xq72_u18.qnpn13g2[ie]
print @q.xbgr.xq72_u18.qnpn13g2[is]
print @r.xbgr.xq72_u18.rsub[i]
print @c.xbgr.xq72_u18.csub[i]
print @q.xbgr.xq72_u19.qnpn13g2[ic]
print @q.xbgr.xq72_u19.qnpn13g2[ib]
print @q.xbgr.xq72_u19.qnpn13g2[ie]
print @q.xbgr.xq72_u19.qnpn13g2[is]
print @r.xbgr.xq72_u19.rsub[i]
print @c.xbgr.xq72_u19.csub[i]
print @q.xbgr.xq72_u20.qnpn13g2[ic]
print @q.xbgr.xq72_u20.qnpn13g2[ib]
print @q.xbgr.xq72_u20.qnpn13g2[ie]
print @q.xbgr.xq72_u20.qnpn13g2[is]
print @r.xbgr.xq72_u20.rsub[i]
print @c.xbgr.xq72_u20.csub[i]
print @q.xbgr.xq72_u21.qnpn13g2[ic]
print @q.xbgr.xq72_u21.qnpn13g2[ib]
print @q.xbgr.xq72_u21.qnpn13g2[ie]
print @q.xbgr.xq72_u21.qnpn13g2[is]
print @r.xbgr.xq72_u21.rsub[i]
print @c.xbgr.xq72_u21.csub[i]
print @q.xbgr.xq72_u22.qnpn13g2[ic]
print @q.xbgr.xq72_u22.qnpn13g2[ib]
print @q.xbgr.xq72_u22.qnpn13g2[ie]
print @q.xbgr.xq72_u22.qnpn13g2[is]
print @r.xbgr.xq72_u22.rsub[i]
print @c.xbgr.xq72_u22.csub[i]
print @q.xbgr.xq72_u23.qnpn13g2[ic]
print @q.xbgr.xq72_u23.qnpn13g2[ib]
print @q.xbgr.xq72_u23.qnpn13g2[ie]
print @q.xbgr.xq72_u23.qnpn13g2[is]
print @r.xbgr.xq72_u23.rsub[i]
print @c.xbgr.xq72_u23.csub[i]
print @q.xbgr.xq72_u24.qnpn13g2[ic]
print @q.xbgr.xq72_u24.qnpn13g2[ib]
print @q.xbgr.xq72_u24.qnpn13g2[ie]
print @q.xbgr.xq72_u24.qnpn13g2[is]
print @r.xbgr.xq72_u24.rsub[i]
print @c.xbgr.xq72_u24.csub[i]
print @q.xbgr.xq73_u2.qnpn13g2[ic]
print @q.xbgr.xq73_u2.qnpn13g2[ib]
print @q.xbgr.xq73_u2.qnpn13g2[ie]
print @q.xbgr.xq73_u2.qnpn13g2[is]
print @r.xbgr.xq73_u2.rsub[i]
print @c.xbgr.xq73_u2.csub[i]
print @q.xbgr.xq73_u3.qnpn13g2[ic]
print @q.xbgr.xq73_u3.qnpn13g2[ib]
print @q.xbgr.xq73_u3.qnpn13g2[ie]
print @q.xbgr.xq73_u3.qnpn13g2[is]
print @r.xbgr.xq73_u3.rsub[i]
print @c.xbgr.xq73_u3.csub[i]
print @q.xbgr.xq73_u4.qnpn13g2[ic]
print @q.xbgr.xq73_u4.qnpn13g2[ib]
print @q.xbgr.xq73_u4.qnpn13g2[ie]
print @q.xbgr.xq73_u4.qnpn13g2[is]
print @r.xbgr.xq73_u4.rsub[i]
print @c.xbgr.xq73_u4.csub[i]
print @q.xbgr.xq73_u5.qnpn13g2[ic]
print @q.xbgr.xq73_u5.qnpn13g2[ib]
print @q.xbgr.xq73_u5.qnpn13g2[ie]
print @q.xbgr.xq73_u5.qnpn13g2[is]
print @r.xbgr.xq73_u5.rsub[i]
print @c.xbgr.xq73_u5.csub[i]
print @q.xbgr.xq73_u6.qnpn13g2[ic]
print @q.xbgr.xq73_u6.qnpn13g2[ib]
print @q.xbgr.xq73_u6.qnpn13g2[ie]
print @q.xbgr.xq73_u6.qnpn13g2[is]
print @r.xbgr.xq73_u6.rsub[i]
print @c.xbgr.xq73_u6.csub[i]
print @q.xbgr.xq73_u7.qnpn13g2[ic]
print @q.xbgr.xq73_u7.qnpn13g2[ib]
print @q.xbgr.xq73_u7.qnpn13g2[ie]
print @q.xbgr.xq73_u7.qnpn13g2[is]
print @r.xbgr.xq73_u7.rsub[i]
print @c.xbgr.xq73_u7.csub[i]
print @q.xbgr.xq73_u8.qnpn13g2[ic]
print @q.xbgr.xq73_u8.qnpn13g2[ib]
print @q.xbgr.xq73_u8.qnpn13g2[ie]
print @q.xbgr.xq73_u8.qnpn13g2[is]
print @r.xbgr.xq73_u8.rsub[i]
print @c.xbgr.xq73_u8.csub[i]
print @q.xbgr.xq73_u9.qnpn13g2[ic]
print @q.xbgr.xq73_u9.qnpn13g2[ib]
print @q.xbgr.xq73_u9.qnpn13g2[ie]
print @q.xbgr.xq73_u9.qnpn13g2[is]
print @r.xbgr.xq73_u9.rsub[i]
print @c.xbgr.xq73_u9.csub[i]
print @q.xbgr.xq73_u10.qnpn13g2[ic]
print @q.xbgr.xq73_u10.qnpn13g2[ib]
print @q.xbgr.xq73_u10.qnpn13g2[ie]
print @q.xbgr.xq73_u10.qnpn13g2[is]
print @r.xbgr.xq73_u10.rsub[i]
print @c.xbgr.xq73_u10.csub[i]
print @q.xbgr.xq73_u11.qnpn13g2[ic]
print @q.xbgr.xq73_u11.qnpn13g2[ib]
print @q.xbgr.xq73_u11.qnpn13g2[ie]
print @q.xbgr.xq73_u11.qnpn13g2[is]
print @r.xbgr.xq73_u11.rsub[i]
print @c.xbgr.xq73_u11.csub[i]
print @q.xbgr.xq73_u12.qnpn13g2[ic]
print @q.xbgr.xq73_u12.qnpn13g2[ib]
print @q.xbgr.xq73_u12.qnpn13g2[ie]
print @q.xbgr.xq73_u12.qnpn13g2[is]
print @r.xbgr.xq73_u12.rsub[i]
print @c.xbgr.xq73_u12.csub[i]
print @q.xbgr.xq73_u13.qnpn13g2[ic]
print @q.xbgr.xq73_u13.qnpn13g2[ib]
print @q.xbgr.xq73_u13.qnpn13g2[ie]
print @q.xbgr.xq73_u13.qnpn13g2[is]
print @r.xbgr.xq73_u13.rsub[i]
print @c.xbgr.xq73_u13.csub[i]
print @q.xbgr.xq73_u14.qnpn13g2[ic]
print @q.xbgr.xq73_u14.qnpn13g2[ib]
print @q.xbgr.xq73_u14.qnpn13g2[ie]
print @q.xbgr.xq73_u14.qnpn13g2[is]
print @r.xbgr.xq73_u14.rsub[i]
print @c.xbgr.xq73_u14.csub[i]
print @q.xbgr.xq73_u15.qnpn13g2[ic]
print @q.xbgr.xq73_u15.qnpn13g2[ib]
print @q.xbgr.xq73_u15.qnpn13g2[ie]
print @q.xbgr.xq73_u15.qnpn13g2[is]
print @r.xbgr.xq73_u15.rsub[i]
print @c.xbgr.xq73_u15.csub[i]
print @q.xbgr.xq73_u16.qnpn13g2[ic]
print @q.xbgr.xq73_u16.qnpn13g2[ib]
print @q.xbgr.xq73_u16.qnpn13g2[ie]
print @q.xbgr.xq73_u16.qnpn13g2[is]
print @r.xbgr.xq73_u16.rsub[i]
print @c.xbgr.xq73_u16.csub[i]
print @q.xbgr.xq73_u17.qnpn13g2[ic]
print @q.xbgr.xq73_u17.qnpn13g2[ib]
print @q.xbgr.xq73_u17.qnpn13g2[ie]
print @q.xbgr.xq73_u17.qnpn13g2[is]
print @r.xbgr.xq73_u17.rsub[i]
print @c.xbgr.xq73_u17.csub[i]
print @q.xbgr.xq73_u18.qnpn13g2[ic]
print @q.xbgr.xq73_u18.qnpn13g2[ib]
print @q.xbgr.xq73_u18.qnpn13g2[ie]
print @q.xbgr.xq73_u18.qnpn13g2[is]
print @r.xbgr.xq73_u18.rsub[i]
print @c.xbgr.xq73_u18.csub[i]
print @q.xbgr.xq73_u19.qnpn13g2[ic]
print @q.xbgr.xq73_u19.qnpn13g2[ib]
print @q.xbgr.xq73_u19.qnpn13g2[ie]
print @q.xbgr.xq73_u19.qnpn13g2[is]
print @r.xbgr.xq73_u19.rsub[i]
print @c.xbgr.xq73_u19.csub[i]
print @q.xbgr.xq73_u20.qnpn13g2[ic]
print @q.xbgr.xq73_u20.qnpn13g2[ib]
print @q.xbgr.xq73_u20.qnpn13g2[ie]
print @q.xbgr.xq73_u20.qnpn13g2[is]
print @r.xbgr.xq73_u20.rsub[i]
print @c.xbgr.xq73_u20.csub[i]
print @q.xbgr.xq73_u21.qnpn13g2[ic]
print @q.xbgr.xq73_u21.qnpn13g2[ib]
print @q.xbgr.xq73_u21.qnpn13g2[ie]
print @q.xbgr.xq73_u21.qnpn13g2[is]
print @r.xbgr.xq73_u21.rsub[i]
print @c.xbgr.xq73_u21.csub[i]
print @q.xbgr.xq73_u22.qnpn13g2[ic]
print @q.xbgr.xq73_u22.qnpn13g2[ib]
print @q.xbgr.xq73_u22.qnpn13g2[ie]
print @q.xbgr.xq73_u22.qnpn13g2[is]
print @r.xbgr.xq73_u22.rsub[i]
print @c.xbgr.xq73_u22.csub[i]
print @q.xbgr.xq73_u23.qnpn13g2[ic]
print @q.xbgr.xq73_u23.qnpn13g2[ib]
print @q.xbgr.xq73_u23.qnpn13g2[ie]
print @q.xbgr.xq73_u23.qnpn13g2[is]
print @r.xbgr.xq73_u23.rsub[i]
print @c.xbgr.xq73_u23.csub[i]
print @q.xbgr.xq73_u24.qnpn13g2[ic]
print @q.xbgr.xq73_u24.qnpn13g2[ib]
print @q.xbgr.xq73_u24.qnpn13g2[ie]
print @q.xbgr.xq73_u24.qnpn13g2[is]
print @r.xbgr.xq73_u24.rsub[i]
print @c.xbgr.xq73_u24.csub[i]
print @q.xbgr.xq74_u2.qnpn13g2[ic]
print @q.xbgr.xq74_u2.qnpn13g2[ib]
print @q.xbgr.xq74_u2.qnpn13g2[ie]
print @q.xbgr.xq74_u2.qnpn13g2[is]
print @r.xbgr.xq74_u2.rsub[i]
print @c.xbgr.xq74_u2.csub[i]
print @q.xbgr.xq74_u3.qnpn13g2[ic]
print @q.xbgr.xq74_u3.qnpn13g2[ib]
print @q.xbgr.xq74_u3.qnpn13g2[ie]
print @q.xbgr.xq74_u3.qnpn13g2[is]
print @r.xbgr.xq74_u3.rsub[i]
print @c.xbgr.xq74_u3.csub[i]
print @q.xbgr.xq74_u4.qnpn13g2[ic]
print @q.xbgr.xq74_u4.qnpn13g2[ib]
print @q.xbgr.xq74_u4.qnpn13g2[ie]
print @q.xbgr.xq74_u4.qnpn13g2[is]
print @r.xbgr.xq74_u4.rsub[i]
print @c.xbgr.xq74_u4.csub[i]
print @q.xbgr.xq74_u5.qnpn13g2[ic]
print @q.xbgr.xq74_u5.qnpn13g2[ib]
print @q.xbgr.xq74_u5.qnpn13g2[ie]
print @q.xbgr.xq74_u5.qnpn13g2[is]
print @r.xbgr.xq74_u5.rsub[i]
print @c.xbgr.xq74_u5.csub[i]
print @q.xbgr.xq74_u6.qnpn13g2[ic]
print @q.xbgr.xq74_u6.qnpn13g2[ib]
print @q.xbgr.xq74_u6.qnpn13g2[ie]
print @q.xbgr.xq74_u6.qnpn13g2[is]
print @r.xbgr.xq74_u6.rsub[i]
print @c.xbgr.xq74_u6.csub[i]
print @q.xbgr.xq74_u7.qnpn13g2[ic]
print @q.xbgr.xq74_u7.qnpn13g2[ib]
print @q.xbgr.xq74_u7.qnpn13g2[ie]
print @q.xbgr.xq74_u7.qnpn13g2[is]
print @r.xbgr.xq74_u7.rsub[i]
print @c.xbgr.xq74_u7.csub[i]
print @q.xbgr.xq74_u8.qnpn13g2[ic]
print @q.xbgr.xq74_u8.qnpn13g2[ib]
print @q.xbgr.xq74_u8.qnpn13g2[ie]
print @q.xbgr.xq74_u8.qnpn13g2[is]
print @r.xbgr.xq74_u8.rsub[i]
print @c.xbgr.xq74_u8.csub[i]
print @q.xbgr.xq74_u9.qnpn13g2[ic]
print @q.xbgr.xq74_u9.qnpn13g2[ib]
print @q.xbgr.xq74_u9.qnpn13g2[ie]
print @q.xbgr.xq74_u9.qnpn13g2[is]
print @r.xbgr.xq74_u9.rsub[i]
print @c.xbgr.xq74_u9.csub[i]
print @q.xbgr.xq74_u10.qnpn13g2[ic]
print @q.xbgr.xq74_u10.qnpn13g2[ib]
print @q.xbgr.xq74_u10.qnpn13g2[ie]
print @q.xbgr.xq74_u10.qnpn13g2[is]
print @r.xbgr.xq74_u10.rsub[i]
print @c.xbgr.xq74_u10.csub[i]
print @q.xbgr.xq74_u11.qnpn13g2[ic]
print @q.xbgr.xq74_u11.qnpn13g2[ib]
print @q.xbgr.xq74_u11.qnpn13g2[ie]
print @q.xbgr.xq74_u11.qnpn13g2[is]
print @r.xbgr.xq74_u11.rsub[i]
print @c.xbgr.xq74_u11.csub[i]
print @q.xbgr.xq74_u12.qnpn13g2[ic]
print @q.xbgr.xq74_u12.qnpn13g2[ib]
print @q.xbgr.xq74_u12.qnpn13g2[ie]
print @q.xbgr.xq74_u12.qnpn13g2[is]
print @r.xbgr.xq74_u12.rsub[i]
print @c.xbgr.xq74_u12.csub[i]
print @q.xbgr.xq74_u13.qnpn13g2[ic]
print @q.xbgr.xq74_u13.qnpn13g2[ib]
print @q.xbgr.xq74_u13.qnpn13g2[ie]
print @q.xbgr.xq74_u13.qnpn13g2[is]
print @r.xbgr.xq74_u13.rsub[i]
print @c.xbgr.xq74_u13.csub[i]
print @q.xbgr.xq74_u14.qnpn13g2[ic]
print @q.xbgr.xq74_u14.qnpn13g2[ib]
print @q.xbgr.xq74_u14.qnpn13g2[ie]
print @q.xbgr.xq74_u14.qnpn13g2[is]
print @r.xbgr.xq74_u14.rsub[i]
print @c.xbgr.xq74_u14.csub[i]
print @q.xbgr.xq74_u15.qnpn13g2[ic]
print @q.xbgr.xq74_u15.qnpn13g2[ib]
print @q.xbgr.xq74_u15.qnpn13g2[ie]
print @q.xbgr.xq74_u15.qnpn13g2[is]
print @r.xbgr.xq74_u15.rsub[i]
print @c.xbgr.xq74_u15.csub[i]
print @q.xbgr.xq74_u16.qnpn13g2[ic]
print @q.xbgr.xq74_u16.qnpn13g2[ib]
print @q.xbgr.xq74_u16.qnpn13g2[ie]
print @q.xbgr.xq74_u16.qnpn13g2[is]
print @r.xbgr.xq74_u16.rsub[i]
print @c.xbgr.xq74_u16.csub[i]
print @q.xbgr.xq74_u17.qnpn13g2[ic]
print @q.xbgr.xq74_u17.qnpn13g2[ib]
print @q.xbgr.xq74_u17.qnpn13g2[ie]
print @q.xbgr.xq74_u17.qnpn13g2[is]
print @r.xbgr.xq74_u17.rsub[i]
print @c.xbgr.xq74_u17.csub[i]
print @q.xbgr.xq74_u18.qnpn13g2[ic]
print @q.xbgr.xq74_u18.qnpn13g2[ib]
print @q.xbgr.xq74_u18.qnpn13g2[ie]
print @q.xbgr.xq74_u18.qnpn13g2[is]
print @r.xbgr.xq74_u18.rsub[i]
print @c.xbgr.xq74_u18.csub[i]
print @q.xbgr.xq74_u19.qnpn13g2[ic]
print @q.xbgr.xq74_u19.qnpn13g2[ib]
print @q.xbgr.xq74_u19.qnpn13g2[ie]
print @q.xbgr.xq74_u19.qnpn13g2[is]
print @r.xbgr.xq74_u19.rsub[i]
print @c.xbgr.xq74_u19.csub[i]
print @q.xbgr.xq74_u20.qnpn13g2[ic]
print @q.xbgr.xq74_u20.qnpn13g2[ib]
print @q.xbgr.xq74_u20.qnpn13g2[ie]
print @q.xbgr.xq74_u20.qnpn13g2[is]
print @r.xbgr.xq74_u20.rsub[i]
print @c.xbgr.xq74_u20.csub[i]
print @q.xbgr.xq74_u21.qnpn13g2[ic]
print @q.xbgr.xq74_u21.qnpn13g2[ib]
print @q.xbgr.xq74_u21.qnpn13g2[ie]
print @q.xbgr.xq74_u21.qnpn13g2[is]
print @r.xbgr.xq74_u21.rsub[i]
print @c.xbgr.xq74_u21.csub[i]
print @q.xbgr.xq74_u22.qnpn13g2[ic]
print @q.xbgr.xq74_u22.qnpn13g2[ib]
print @q.xbgr.xq74_u22.qnpn13g2[ie]
print @q.xbgr.xq74_u22.qnpn13g2[is]
print @r.xbgr.xq74_u22.rsub[i]
print @c.xbgr.xq74_u22.csub[i]
print @q.xbgr.xq74_u23.qnpn13g2[ic]
print @q.xbgr.xq74_u23.qnpn13g2[ib]
print @q.xbgr.xq74_u23.qnpn13g2[ie]
print @q.xbgr.xq74_u23.qnpn13g2[is]
print @r.xbgr.xq74_u23.rsub[i]
print @c.xbgr.xq74_u23.csub[i]
print @q.xbgr.xq74_u24.qnpn13g2[ic]
print @q.xbgr.xq74_u24.qnpn13g2[ib]
print @q.xbgr.xq74_u24.qnpn13g2[ie]
print @q.xbgr.xq74_u24.qnpn13g2[is]
print @r.xbgr.xq74_u24.rsub[i]
print @c.xbgr.xq74_u24.csub[i]
print @q.xbgr.xq75_u2.qnpn13g2[ic]
print @q.xbgr.xq75_u2.qnpn13g2[ib]
print @q.xbgr.xq75_u2.qnpn13g2[ie]
print @q.xbgr.xq75_u2.qnpn13g2[is]
print @r.xbgr.xq75_u2.rsub[i]
print @c.xbgr.xq75_u2.csub[i]
print @q.xbgr.xq75_u3.qnpn13g2[ic]
print @q.xbgr.xq75_u3.qnpn13g2[ib]
print @q.xbgr.xq75_u3.qnpn13g2[ie]
print @q.xbgr.xq75_u3.qnpn13g2[is]
print @r.xbgr.xq75_u3.rsub[i]
print @c.xbgr.xq75_u3.csub[i]
print @q.xbgr.xq75_u4.qnpn13g2[ic]
print @q.xbgr.xq75_u4.qnpn13g2[ib]
print @q.xbgr.xq75_u4.qnpn13g2[ie]
print @q.xbgr.xq75_u4.qnpn13g2[is]
print @r.xbgr.xq75_u4.rsub[i]
print @c.xbgr.xq75_u4.csub[i]
print @q.xbgr.xq75_u5.qnpn13g2[ic]
print @q.xbgr.xq75_u5.qnpn13g2[ib]
print @q.xbgr.xq75_u5.qnpn13g2[ie]
print @q.xbgr.xq75_u5.qnpn13g2[is]
print @r.xbgr.xq75_u5.rsub[i]
print @c.xbgr.xq75_u5.csub[i]
print @q.xbgr.xq75_u6.qnpn13g2[ic]
print @q.xbgr.xq75_u6.qnpn13g2[ib]
print @q.xbgr.xq75_u6.qnpn13g2[ie]
print @q.xbgr.xq75_u6.qnpn13g2[is]
print @r.xbgr.xq75_u6.rsub[i]
print @c.xbgr.xq75_u6.csub[i]
print @q.xbgr.xq75_u7.qnpn13g2[ic]
print @q.xbgr.xq75_u7.qnpn13g2[ib]
print @q.xbgr.xq75_u7.qnpn13g2[ie]
print @q.xbgr.xq75_u7.qnpn13g2[is]
print @r.xbgr.xq75_u7.rsub[i]
print @c.xbgr.xq75_u7.csub[i]
print @q.xbgr.xq75_u8.qnpn13g2[ic]
print @q.xbgr.xq75_u8.qnpn13g2[ib]
print @q.xbgr.xq75_u8.qnpn13g2[ie]
print @q.xbgr.xq75_u8.qnpn13g2[is]
print @r.xbgr.xq75_u8.rsub[i]
print @c.xbgr.xq75_u8.csub[i]
print @q.xbgr.xq75_u9.qnpn13g2[ic]
print @q.xbgr.xq75_u9.qnpn13g2[ib]
print @q.xbgr.xq75_u9.qnpn13g2[ie]
print @q.xbgr.xq75_u9.qnpn13g2[is]
print @r.xbgr.xq75_u9.rsub[i]
print @c.xbgr.xq75_u9.csub[i]
print @q.xbgr.xq75_u10.qnpn13g2[ic]
print @q.xbgr.xq75_u10.qnpn13g2[ib]
print @q.xbgr.xq75_u10.qnpn13g2[ie]
print @q.xbgr.xq75_u10.qnpn13g2[is]
print @r.xbgr.xq75_u10.rsub[i]
print @c.xbgr.xq75_u10.csub[i]
print @q.xbgr.xq75_u11.qnpn13g2[ic]
print @q.xbgr.xq75_u11.qnpn13g2[ib]
print @q.xbgr.xq75_u11.qnpn13g2[ie]
print @q.xbgr.xq75_u11.qnpn13g2[is]
print @r.xbgr.xq75_u11.rsub[i]
print @c.xbgr.xq75_u11.csub[i]
print @q.xbgr.xq75_u12.qnpn13g2[ic]
print @q.xbgr.xq75_u12.qnpn13g2[ib]
print @q.xbgr.xq75_u12.qnpn13g2[ie]
print @q.xbgr.xq75_u12.qnpn13g2[is]
print @r.xbgr.xq75_u12.rsub[i]
print @c.xbgr.xq75_u12.csub[i]
print @q.xbgr.xq75_u13.qnpn13g2[ic]
print @q.xbgr.xq75_u13.qnpn13g2[ib]
print @q.xbgr.xq75_u13.qnpn13g2[ie]
print @q.xbgr.xq75_u13.qnpn13g2[is]
print @r.xbgr.xq75_u13.rsub[i]
print @c.xbgr.xq75_u13.csub[i]
print @q.xbgr.xq75_u14.qnpn13g2[ic]
print @q.xbgr.xq75_u14.qnpn13g2[ib]
print @q.xbgr.xq75_u14.qnpn13g2[ie]
print @q.xbgr.xq75_u14.qnpn13g2[is]
print @r.xbgr.xq75_u14.rsub[i]
print @c.xbgr.xq75_u14.csub[i]
print @q.xbgr.xq75_u15.qnpn13g2[ic]
print @q.xbgr.xq75_u15.qnpn13g2[ib]
print @q.xbgr.xq75_u15.qnpn13g2[ie]
print @q.xbgr.xq75_u15.qnpn13g2[is]
print @r.xbgr.xq75_u15.rsub[i]
print @c.xbgr.xq75_u15.csub[i]
print @q.xbgr.xq75_u16.qnpn13g2[ic]
print @q.xbgr.xq75_u16.qnpn13g2[ib]
print @q.xbgr.xq75_u16.qnpn13g2[ie]
print @q.xbgr.xq75_u16.qnpn13g2[is]
print @r.xbgr.xq75_u16.rsub[i]
print @c.xbgr.xq75_u16.csub[i]
print @q.xbgr.xq75_u17.qnpn13g2[ic]
print @q.xbgr.xq75_u17.qnpn13g2[ib]
print @q.xbgr.xq75_u17.qnpn13g2[ie]
print @q.xbgr.xq75_u17.qnpn13g2[is]
print @r.xbgr.xq75_u17.rsub[i]
print @c.xbgr.xq75_u17.csub[i]
print @q.xbgr.xq75_u18.qnpn13g2[ic]
print @q.xbgr.xq75_u18.qnpn13g2[ib]
print @q.xbgr.xq75_u18.qnpn13g2[ie]
print @q.xbgr.xq75_u18.qnpn13g2[is]
print @r.xbgr.xq75_u18.rsub[i]
print @c.xbgr.xq75_u18.csub[i]
print @q.xbgr.xq75_u19.qnpn13g2[ic]
print @q.xbgr.xq75_u19.qnpn13g2[ib]
print @q.xbgr.xq75_u19.qnpn13g2[ie]
print @q.xbgr.xq75_u19.qnpn13g2[is]
print @r.xbgr.xq75_u19.rsub[i]
print @c.xbgr.xq75_u19.csub[i]
print @q.xbgr.xq75_u20.qnpn13g2[ic]
print @q.xbgr.xq75_u20.qnpn13g2[ib]
print @q.xbgr.xq75_u20.qnpn13g2[ie]
print @q.xbgr.xq75_u20.qnpn13g2[is]
print @r.xbgr.xq75_u20.rsub[i]
print @c.xbgr.xq75_u20.csub[i]
print @q.xbgr.xq75_u21.qnpn13g2[ic]
print @q.xbgr.xq75_u21.qnpn13g2[ib]
print @q.xbgr.xq75_u21.qnpn13g2[ie]
print @q.xbgr.xq75_u21.qnpn13g2[is]
print @r.xbgr.xq75_u21.rsub[i]
print @c.xbgr.xq75_u21.csub[i]
print @q.xbgr.xq75_u22.qnpn13g2[ic]
print @q.xbgr.xq75_u22.qnpn13g2[ib]
print @q.xbgr.xq75_u22.qnpn13g2[ie]
print @q.xbgr.xq75_u22.qnpn13g2[is]
print @r.xbgr.xq75_u22.rsub[i]
print @c.xbgr.xq75_u22.csub[i]
print @q.xbgr.xq75_u23.qnpn13g2[ic]
print @q.xbgr.xq75_u23.qnpn13g2[ib]
print @q.xbgr.xq75_u23.qnpn13g2[ie]
print @q.xbgr.xq75_u23.qnpn13g2[is]
print @r.xbgr.xq75_u23.rsub[i]
print @c.xbgr.xq75_u23.csub[i]
print @q.xbgr.xq75_u24.qnpn13g2[ic]
print @q.xbgr.xq75_u24.qnpn13g2[ib]
print @q.xbgr.xq75_u24.qnpn13g2[ie]
print @q.xbgr.xq75_u24.qnpn13g2[is]
print @r.xbgr.xq75_u24.rsub[i]
print @c.xbgr.xq75_u24.csub[i]
print @q.xbgr.xq76_u2.qnpn13g2[ic]
print @q.xbgr.xq76_u2.qnpn13g2[ib]
print @q.xbgr.xq76_u2.qnpn13g2[ie]
print @q.xbgr.xq76_u2.qnpn13g2[is]
print @r.xbgr.xq76_u2.rsub[i]
print @c.xbgr.xq76_u2.csub[i]
print @q.xbgr.xq76_u3.qnpn13g2[ic]
print @q.xbgr.xq76_u3.qnpn13g2[ib]
print @q.xbgr.xq76_u3.qnpn13g2[ie]
print @q.xbgr.xq76_u3.qnpn13g2[is]
print @r.xbgr.xq76_u3.rsub[i]
print @c.xbgr.xq76_u3.csub[i]
print @q.xbgr.xq76_u4.qnpn13g2[ic]
print @q.xbgr.xq76_u4.qnpn13g2[ib]
print @q.xbgr.xq76_u4.qnpn13g2[ie]
print @q.xbgr.xq76_u4.qnpn13g2[is]
print @r.xbgr.xq76_u4.rsub[i]
print @c.xbgr.xq76_u4.csub[i]
print @q.xbgr.xq76_u5.qnpn13g2[ic]
print @q.xbgr.xq76_u5.qnpn13g2[ib]
print @q.xbgr.xq76_u5.qnpn13g2[ie]
print @q.xbgr.xq76_u5.qnpn13g2[is]
print @r.xbgr.xq76_u5.rsub[i]
print @c.xbgr.xq76_u5.csub[i]
print @q.xbgr.xq76_u6.qnpn13g2[ic]
print @q.xbgr.xq76_u6.qnpn13g2[ib]
print @q.xbgr.xq76_u6.qnpn13g2[ie]
print @q.xbgr.xq76_u6.qnpn13g2[is]
print @r.xbgr.xq76_u6.rsub[i]
print @c.xbgr.xq76_u6.csub[i]
print @q.xbgr.xq76_u7.qnpn13g2[ic]
print @q.xbgr.xq76_u7.qnpn13g2[ib]
print @q.xbgr.xq76_u7.qnpn13g2[ie]
print @q.xbgr.xq76_u7.qnpn13g2[is]
print @r.xbgr.xq76_u7.rsub[i]
print @c.xbgr.xq76_u7.csub[i]
print @q.xbgr.xq76_u8.qnpn13g2[ic]
print @q.xbgr.xq76_u8.qnpn13g2[ib]
print @q.xbgr.xq76_u8.qnpn13g2[ie]
print @q.xbgr.xq76_u8.qnpn13g2[is]
print @r.xbgr.xq76_u8.rsub[i]
print @c.xbgr.xq76_u8.csub[i]
print @q.xbgr.xq76_u9.qnpn13g2[ic]
print @q.xbgr.xq76_u9.qnpn13g2[ib]
print @q.xbgr.xq76_u9.qnpn13g2[ie]
print @q.xbgr.xq76_u9.qnpn13g2[is]
print @r.xbgr.xq76_u9.rsub[i]
print @c.xbgr.xq76_u9.csub[i]
print @q.xbgr.xq76_u10.qnpn13g2[ic]
print @q.xbgr.xq76_u10.qnpn13g2[ib]
print @q.xbgr.xq76_u10.qnpn13g2[ie]
print @q.xbgr.xq76_u10.qnpn13g2[is]
print @r.xbgr.xq76_u10.rsub[i]
print @c.xbgr.xq76_u10.csub[i]
print @q.xbgr.xq76_u11.qnpn13g2[ic]
print @q.xbgr.xq76_u11.qnpn13g2[ib]
print @q.xbgr.xq76_u11.qnpn13g2[ie]
print @q.xbgr.xq76_u11.qnpn13g2[is]
print @r.xbgr.xq76_u11.rsub[i]
print @c.xbgr.xq76_u11.csub[i]
print @q.xbgr.xq76_u12.qnpn13g2[ic]
print @q.xbgr.xq76_u12.qnpn13g2[ib]
print @q.xbgr.xq76_u12.qnpn13g2[ie]
print @q.xbgr.xq76_u12.qnpn13g2[is]
print @r.xbgr.xq76_u12.rsub[i]
print @c.xbgr.xq76_u12.csub[i]
print @q.xbgr.xq76_u13.qnpn13g2[ic]
print @q.xbgr.xq76_u13.qnpn13g2[ib]
print @q.xbgr.xq76_u13.qnpn13g2[ie]
print @q.xbgr.xq76_u13.qnpn13g2[is]
print @r.xbgr.xq76_u13.rsub[i]
print @c.xbgr.xq76_u13.csub[i]
print @q.xbgr.xq76_u14.qnpn13g2[ic]
print @q.xbgr.xq76_u14.qnpn13g2[ib]
print @q.xbgr.xq76_u14.qnpn13g2[ie]
print @q.xbgr.xq76_u14.qnpn13g2[is]
print @r.xbgr.xq76_u14.rsub[i]
print @c.xbgr.xq76_u14.csub[i]
print @q.xbgr.xq76_u15.qnpn13g2[ic]
print @q.xbgr.xq76_u15.qnpn13g2[ib]
print @q.xbgr.xq76_u15.qnpn13g2[ie]
print @q.xbgr.xq76_u15.qnpn13g2[is]
print @r.xbgr.xq76_u15.rsub[i]
print @c.xbgr.xq76_u15.csub[i]
print @q.xbgr.xq76_u16.qnpn13g2[ic]
print @q.xbgr.xq76_u16.qnpn13g2[ib]
print @q.xbgr.xq76_u16.qnpn13g2[ie]
print @q.xbgr.xq76_u16.qnpn13g2[is]
print @r.xbgr.xq76_u16.rsub[i]
print @c.xbgr.xq76_u16.csub[i]
print @q.xbgr.xq76_u17.qnpn13g2[ic]
print @q.xbgr.xq76_u17.qnpn13g2[ib]
print @q.xbgr.xq76_u17.qnpn13g2[ie]
print @q.xbgr.xq76_u17.qnpn13g2[is]
print @r.xbgr.xq76_u17.rsub[i]
print @c.xbgr.xq76_u17.csub[i]
print @q.xbgr.xq76_u18.qnpn13g2[ic]
print @q.xbgr.xq76_u18.qnpn13g2[ib]
print @q.xbgr.xq76_u18.qnpn13g2[ie]
print @q.xbgr.xq76_u18.qnpn13g2[is]
print @r.xbgr.xq76_u18.rsub[i]
print @c.xbgr.xq76_u18.csub[i]
print @q.xbgr.xq76_u19.qnpn13g2[ic]
print @q.xbgr.xq76_u19.qnpn13g2[ib]
print @q.xbgr.xq76_u19.qnpn13g2[ie]
print @q.xbgr.xq76_u19.qnpn13g2[is]
print @r.xbgr.xq76_u19.rsub[i]
print @c.xbgr.xq76_u19.csub[i]
print @q.xbgr.xq76_u20.qnpn13g2[ic]
print @q.xbgr.xq76_u20.qnpn13g2[ib]
print @q.xbgr.xq76_u20.qnpn13g2[ie]
print @q.xbgr.xq76_u20.qnpn13g2[is]
print @r.xbgr.xq76_u20.rsub[i]
print @c.xbgr.xq76_u20.csub[i]
print @q.xbgr.xq76_u21.qnpn13g2[ic]
print @q.xbgr.xq76_u21.qnpn13g2[ib]
print @q.xbgr.xq76_u21.qnpn13g2[ie]
print @q.xbgr.xq76_u21.qnpn13g2[is]
print @r.xbgr.xq76_u21.rsub[i]
print @c.xbgr.xq76_u21.csub[i]
print @q.xbgr.xq76_u22.qnpn13g2[ic]
print @q.xbgr.xq76_u22.qnpn13g2[ib]
print @q.xbgr.xq76_u22.qnpn13g2[ie]
print @q.xbgr.xq76_u22.qnpn13g2[is]
print @r.xbgr.xq76_u22.rsub[i]
print @c.xbgr.xq76_u22.csub[i]
print @q.xbgr.xq76_u23.qnpn13g2[ic]
print @q.xbgr.xq76_u23.qnpn13g2[ib]
print @q.xbgr.xq76_u23.qnpn13g2[ie]
print @q.xbgr.xq76_u23.qnpn13g2[is]
print @r.xbgr.xq76_u23.rsub[i]
print @c.xbgr.xq76_u23.csub[i]
print @q.xbgr.xq76_u24.qnpn13g2[ic]
print @q.xbgr.xq76_u24.qnpn13g2[ib]
print @q.xbgr.xq76_u24.qnpn13g2[ie]
print @q.xbgr.xq76_u24.qnpn13g2[is]
print @r.xbgr.xq76_u24.rsub[i]
print @c.xbgr.xq76_u24.csub[i]
print @n.xbgr.xr77_u2.nr1[ibody]
print @n.xbgr.xr77_u3.nr1[ibody]
print @n.xbgr.xr77_u4.nr1[ibody]
print @n.xbgr.xr77_u5.nr1[ibody]
print @n.xbgr.xr77_u6.nr1[ibody]
print @n.xbgr.xr77_u7.nr1[ibody]
print @n.xbgr.xr77_u8.nr1[ibody]
print @n.xbgr.xr77_u9.nr1[ibody]
print @n.xbgr.xr77_u10.nr1[ibody]
print @n.xbgr.xr77_u11.nr1[ibody]
print @n.xbgr.xr77_u12.nr1[ibody]
print @n.xbgr.xr77_u13.nr1[ibody]
print @n.xbgr.xr77_u14.nr1[ibody]
print @n.xbgr.xr77_u15.nr1[ibody]
print @n.xbgr.xr77_u16.nr1[ibody]
print @n.xbgr.xr77_u17.nr1[ibody]
print @n.xbgr.xr77_u18.nr1[ibody]
print @n.xbgr.xr77_u19.nr1[ibody]
print @n.xbgr.xr77_u20.nr1[ibody]
print @n.xbgr.xr77_u21.nr1[ibody]
print @n.xbgr.xr77_u22.nr1[ibody]
print @n.xbgr.xr77_u23.nr1[ibody]
print @n.xbgr.xr77_u24.nr1[ibody]
print @n.xbgr.xr78_u2.nr1[ibody]
print @n.xbgr.xr78_u3.nr1[ibody]
print @n.xbgr.xr78_u4.nr1[ibody]
print @n.xbgr.xr78_u5.nr1[ibody]
print @n.xbgr.xr78_u6.nr1[ibody]
print @n.xbgr.xr78_u7.nr1[ibody]
print @n.xbgr.xr78_u8.nr1[ibody]
print @n.xbgr.xr78_u9.nr1[ibody]
print @n.xbgr.xr78_u10.nr1[ibody]
print @n.xbgr.xr78_u11.nr1[ibody]
print @n.xbgr.xr78_u12.nr1[ibody]
print @n.xbgr.xr78_u13.nr1[ibody]
print @n.xbgr.xr78_u14.nr1[ibody]
print @n.xbgr.xr78_u15.nr1[ibody]
print @n.xbgr.xr78_u16.nr1[ibody]
print @n.xbgr.xr78_u17.nr1[ibody]
print @n.xbgr.xr78_u18.nr1[ibody]
print @n.xbgr.xr78_u19.nr1[ibody]
print @n.xbgr.xr78_u20.nr1[ibody]
print @n.xbgr.xr78_u21.nr1[ibody]
print @n.xbgr.xr78_u22.nr1[ibody]
print @n.xbgr.xr78_u23.nr1[ibody]
print @n.xbgr.xr78_u24.nr1[ibody]
print @n.xbgr.xr79_u2.nr1[ibody]
print @n.xbgr.xr79_u3.nr1[ibody]
print @n.xbgr.xr79_u4.nr1[ibody]
print @n.xbgr.xr79_u5.nr1[ibody]
print @n.xbgr.xr79_u6.nr1[ibody]
print @n.xbgr.xr79_u7.nr1[ibody]
print @n.xbgr.xr79_u8.nr1[ibody]
print @n.xbgr.xr79_u9.nr1[ibody]
print @n.xbgr.xr79_u10.nr1[ibody]
print @n.xbgr.xr79_u11.nr1[ibody]
print @n.xbgr.xr79_u12.nr1[ibody]
print @n.xbgr.xr79_u13.nr1[ibody]
print @n.xbgr.xr79_u14.nr1[ibody]
print @n.xbgr.xr79_u15.nr1[ibody]
print @n.xbgr.xr79_u16.nr1[ibody]
print @n.xbgr.xr79_u17.nr1[ibody]
print @n.xbgr.xr79_u18.nr1[ibody]
print @n.xbgr.xr79_u19.nr1[ibody]
print @n.xbgr.xr79_u20.nr1[ibody]
print @n.xbgr.xr79_u21.nr1[ibody]
print @n.xbgr.xr79_u22.nr1[ibody]
print @n.xbgr.xr79_u23.nr1[ibody]
print @n.xbgr.xr79_u24.nr1[ibody]
print @n.xbgr.xr80_u2.nr1[ibody]
print @n.xbgr.xr80_u3.nr1[ibody]
print @n.xbgr.xr80_u4.nr1[ibody]
print @n.xbgr.xr80_u5.nr1[ibody]
print @n.xbgr.xr80_u6.nr1[ibody]
print @n.xbgr.xr80_u7.nr1[ibody]
print @n.xbgr.xr80_u8.nr1[ibody]
print @n.xbgr.xr80_u9.nr1[ibody]
print @n.xbgr.xr80_u10.nr1[ibody]
print @n.xbgr.xr80_u11.nr1[ibody]
print @n.xbgr.xr80_u12.nr1[ibody]
print @n.xbgr.xr80_u13.nr1[ibody]
print @n.xbgr.xr80_u14.nr1[ibody]
print @n.xbgr.xr80_u15.nr1[ibody]
print @n.xbgr.xr80_u16.nr1[ibody]
print @n.xbgr.xr80_u17.nr1[ibody]
print @n.xbgr.xr80_u18.nr1[ibody]
print @n.xbgr.xr80_u19.nr1[ibody]
print @n.xbgr.xr80_u20.nr1[ibody]
print @n.xbgr.xr80_u21.nr1[ibody]
print @n.xbgr.xr80_u22.nr1[ibody]
print @n.xbgr.xr80_u23.nr1[ibody]
print @n.xbgr.xr80_u24.nr1[ibody]
print @n.xbgr.xr81_u2.nr1[ibody]
print @n.xbgr.xr81_u3.nr1[ibody]
print @n.xbgr.xr81_u4.nr1[ibody]
print @n.xbgr.xr81_u5.nr1[ibody]
print @n.xbgr.xr81_u6.nr1[ibody]
print @n.xbgr.xr81_u7.nr1[ibody]
print @n.xbgr.xr81_u8.nr1[ibody]
print @n.xbgr.xr81_u9.nr1[ibody]
print @n.xbgr.xr81_u10.nr1[ibody]
print @n.xbgr.xr81_u11.nr1[ibody]
print @n.xbgr.xr81_u12.nr1[ibody]
print @n.xbgr.xr81_u13.nr1[ibody]
print @n.xbgr.xr81_u14.nr1[ibody]
print @n.xbgr.xr81_u15.nr1[ibody]
print @n.xbgr.xr81_u16.nr1[ibody]
print @n.xbgr.xr81_u17.nr1[ibody]
print @n.xbgr.xr81_u18.nr1[ibody]
print @n.xbgr.xr81_u19.nr1[ibody]
print @n.xbgr.xr81_u20.nr1[ibody]
print @n.xbgr.xr81_u21.nr1[ibody]
print @n.xbgr.xr81_u22.nr1[ibody]
print @n.xbgr.xr81_u23.nr1[ibody]
print @n.xbgr.xr81_u24.nr1[ibody]
print @n.xbgr.xr82_u2.nr1[ibody]
print @n.xbgr.xr82_u3.nr1[ibody]
print @n.xbgr.xr82_u4.nr1[ibody]
print @n.xbgr.xr82_u5.nr1[ibody]
print @n.xbgr.xr82_u6.nr1[ibody]
print @n.xbgr.xr82_u7.nr1[ibody]
print @n.xbgr.xr82_u8.nr1[ibody]
print @n.xbgr.xr82_u9.nr1[ibody]
print @n.xbgr.xr82_u10.nr1[ibody]
print @n.xbgr.xr82_u11.nr1[ibody]
print @n.xbgr.xr82_u12.nr1[ibody]
print @n.xbgr.xr82_u13.nr1[ibody]
print @n.xbgr.xr82_u14.nr1[ibody]
print @n.xbgr.xr82_u15.nr1[ibody]
print @n.xbgr.xr82_u16.nr1[ibody]
print @n.xbgr.xr82_u17.nr1[ibody]
print @n.xbgr.xr82_u18.nr1[ibody]
print @n.xbgr.xr82_u19.nr1[ibody]
print @n.xbgr.xr82_u20.nr1[ibody]
print @n.xbgr.xr82_u21.nr1[ibody]
print @n.xbgr.xr82_u22.nr1[ibody]
print @n.xbgr.xr82_u23.nr1[ibody]
print @n.xbgr.xr82_u24.nr1[ibody]
print @n.xbgr.xr83_u2.nr1[ibody]
print @n.xbgr.xr83_u3.nr1[ibody]
print @n.xbgr.xr83_u4.nr1[ibody]
print @n.xbgr.xr83_u5.nr1[ibody]
print @n.xbgr.xr83_u6.nr1[ibody]
print @n.xbgr.xr83_u7.nr1[ibody]
print @n.xbgr.xr83_u8.nr1[ibody]
print @n.xbgr.xr83_u9.nr1[ibody]
print @n.xbgr.xr83_u10.nr1[ibody]
print @n.xbgr.xr83_u11.nr1[ibody]
print @n.xbgr.xr83_u12.nr1[ibody]
print @n.xbgr.xr83_u13.nr1[ibody]
print @n.xbgr.xr83_u14.nr1[ibody]
print @n.xbgr.xr83_u15.nr1[ibody]
print @n.xbgr.xr83_u16.nr1[ibody]
print @n.xbgr.xr83_u17.nr1[ibody]
print @n.xbgr.xr83_u18.nr1[ibody]
print @n.xbgr.xr83_u19.nr1[ibody]
print @n.xbgr.xr83_u20.nr1[ibody]
print @n.xbgr.xr83_u21.nr1[ibody]
print @n.xbgr.xr83_u22.nr1[ibody]
print @n.xbgr.xr83_u23.nr1[ibody]
print @n.xbgr.xr83_u24.nr1[ibody]
print @n.xbgr.xr84_u2.nr1[ibody]
print @n.xbgr.xr84_u3.nr1[ibody]
print @n.xbgr.xr84_u4.nr1[ibody]
print @n.xbgr.xr84_u5.nr1[ibody]
print @n.xbgr.xr84_u6.nr1[ibody]
print @n.xbgr.xr84_u7.nr1[ibody]
print @n.xbgr.xr84_u8.nr1[ibody]
print @n.xbgr.xr84_u9.nr1[ibody]
print @n.xbgr.xr84_u10.nr1[ibody]
print @n.xbgr.xr84_u11.nr1[ibody]
print @n.xbgr.xr84_u12.nr1[ibody]
print @n.xbgr.xr84_u13.nr1[ibody]
print @n.xbgr.xr84_u14.nr1[ibody]
print @n.xbgr.xr84_u15.nr1[ibody]
print @n.xbgr.xr84_u16.nr1[ibody]
print @n.xbgr.xr84_u17.nr1[ibody]
print @n.xbgr.xr84_u18.nr1[ibody]
print @n.xbgr.xr84_u19.nr1[ibody]
print @n.xbgr.xr84_u20.nr1[ibody]
print @n.xbgr.xr84_u21.nr1[ibody]
print @n.xbgr.xr84_u22.nr1[ibody]
print @n.xbgr.xr84_u23.nr1[ibody]
print @n.xbgr.xr84_u24.nr1[ibody]
print @n.xbgr.xr85_u2.nr1[ibody]
print @n.xbgr.xr85_u3.nr1[ibody]
print @n.xbgr.xr85_u4.nr1[ibody]
print @n.xbgr.xr85_u5.nr1[ibody]
print @n.xbgr.xr85_u6.nr1[ibody]
print @n.xbgr.xr85_u7.nr1[ibody]
print @n.xbgr.xr85_u8.nr1[ibody]
print @n.xbgr.xr85_u9.nr1[ibody]
print @n.xbgr.xr85_u10.nr1[ibody]
print @n.xbgr.xr85_u11.nr1[ibody]
print @n.xbgr.xr85_u12.nr1[ibody]
print @n.xbgr.xr85_u13.nr1[ibody]
print @n.xbgr.xr85_u14.nr1[ibody]
print @n.xbgr.xr85_u15.nr1[ibody]
print @n.xbgr.xr85_u16.nr1[ibody]
print @n.xbgr.xr85_u17.nr1[ibody]
print @n.xbgr.xr85_u18.nr1[ibody]
print @n.xbgr.xr85_u19.nr1[ibody]
print @n.xbgr.xr85_u20.nr1[ibody]
print @n.xbgr.xr85_u21.nr1[ibody]
print @n.xbgr.xr85_u22.nr1[ibody]
print @n.xbgr.xr85_u23.nr1[ibody]
print @n.xbgr.xr85_u24.nr1[ibody]
print @n.xbgr.xr86_u2.nr1[ibody]
print @n.xbgr.xr86_u3.nr1[ibody]
print @n.xbgr.xr86_u4.nr1[ibody]
print @n.xbgr.xr86_u5.nr1[ibody]
print @n.xbgr.xr86_u6.nr1[ibody]
print @n.xbgr.xr86_u7.nr1[ibody]
print @n.xbgr.xr86_u8.nr1[ibody]
print @n.xbgr.xr86_u9.nr1[ibody]
print @n.xbgr.xr86_u10.nr1[ibody]
print @n.xbgr.xr86_u11.nr1[ibody]
print @n.xbgr.xr86_u12.nr1[ibody]
print @n.xbgr.xr86_u13.nr1[ibody]
print @n.xbgr.xr86_u14.nr1[ibody]
print @n.xbgr.xr86_u15.nr1[ibody]
print @n.xbgr.xr86_u16.nr1[ibody]
print @n.xbgr.xr86_u17.nr1[ibody]
print @n.xbgr.xr86_u18.nr1[ibody]
print @n.xbgr.xr86_u19.nr1[ibody]
print @n.xbgr.xr86_u20.nr1[ibody]
print @n.xbgr.xr86_u21.nr1[ibody]
print @n.xbgr.xr86_u22.nr1[ibody]
print @n.xbgr.xr86_u23.nr1[ibody]
print @n.xbgr.xr86_u24.nr1[ibody]
echo RAW_CURRENT_LEDGER_END
wrdata op_nodes.dat v(xbgr.b1b) v(xbgr.c2) v(xbgr.d1) v(xbgr.d2) v(xbgr.d3) v(xbgr.d4) v(xbgr.d5) v(xbgr.det) v(dvbe) v(iptat) v(xbgr.kick) v(xbgr.n1) v(xbgr.n_10) v(xbgr.n_11) v(xbgr.n_12) v(xbgr.n_13) v(xbgr.n_14) v(xbgr.n_15) v(xbgr.n_16) v(xbgr.n_17) v(xbgr.n_18) v(xbgr.n_19) v(xbgr.n_2) v(xbgr.n_21) v(xbgr.n_22) v(xbgr.n_23) v(xbgr.n_24) v(xbgr.n_25) v(xbgr.n_26) v(xbgr.n_27) v(xbgr.n_3) v(xbgr.n_30) v(xbgr.n_31) v(xbgr.n_33) v(xbgr.n_34) v(xbgr.n_36) v(xbgr.n_37) v(xbgr.n_4) v(xbgr.n_5) v(xbgr.n_6) v(xbgr.n_7) v(xbgr.n_8) v(xbgr.n_9) v(pbias) v(pcasc) v(r4) v(xbgr.r4n) v(xbgr.vb2) v(vbe) v(xbgr.vbe3) v(xbgr.vd1) v(xbgr.vd2) v(vdd) v(vref) v(vdd)-v(vdd) i(vdd) i(vload) i(vr4) i(vsub)
print @n.xbgr.xr1.nr1[nsmm_rsh]
print @n.xbgr.xr1.nr1[nsmm_w]
print @n.xbgr.xr1.nr1[nsmm_l]
print @n.xbgr.xr2.nr1[nsmm_rsh]
print @n.xbgr.xr2.nr1[nsmm_w]
print @n.xbgr.xr2.nr1[nsmm_l]
print @n.xbgr.xr3.nr1[nsmm_rsh]
print @n.xbgr.xr3.nr1[nsmm_w]
print @n.xbgr.xr3.nr1[nsmm_l]
print @n.xbgr.xr4.nr1[nsmm_rsh]
print @n.xbgr.xr4.nr1[nsmm_w]
print @n.xbgr.xr4.nr1[nsmm_l]
print @n.xbgr.xr5.nr1[nsmm_rsh]
print @n.xbgr.xr5.nr1[nsmm_w]
print @n.xbgr.xr5.nr1[nsmm_l]
print @n.xbgr.xr6.nr1[nsmm_rsh]
print @n.xbgr.xr6.nr1[nsmm_w]
print @n.xbgr.xr6.nr1[nsmm_l]
print @n.xbgr.xr7.nr1[nsmm_rsh]
print @n.xbgr.xr7.nr1[nsmm_w]
print @n.xbgr.xr7.nr1[nsmm_l]
print @n.xbgr.xr8.nr1[nsmm_rsh]
print @n.xbgr.xr8.nr1[nsmm_w]
print @n.xbgr.xr8.nr1[nsmm_l]
print @n.xbgr.xr9.nr1[nsmm_rsh]
print @n.xbgr.xr9.nr1[nsmm_w]
print @n.xbgr.xr9.nr1[nsmm_l]
print @n.xbgr.xr10.nr1[nsmm_rsh]
print @n.xbgr.xr10.nr1[nsmm_w]
print @n.xbgr.xr10.nr1[nsmm_l]
print @n.xbgr.xr11.nr1[nsmm_rsh]
print @n.xbgr.xr11.nr1[nsmm_w]
print @n.xbgr.xr11.nr1[nsmm_l]
print @n.xbgr.xr12.nr1[nsmm_rsh]
print @n.xbgr.xr12.nr1[nsmm_w]
print @n.xbgr.xr12.nr1[nsmm_l]
print @n.xbgr.xr13.nr1[nsmm_rsh]
print @n.xbgr.xr13.nr1[nsmm_w]
print @n.xbgr.xr13.nr1[nsmm_l]
print @n.xbgr.xr14.nr1[nsmm_rsh]
print @n.xbgr.xr14.nr1[nsmm_w]
print @n.xbgr.xr14.nr1[nsmm_l]
print @n.xbgr.xr15.nr1[nsmm_rsh]
print @n.xbgr.xr15.nr1[nsmm_w]
print @n.xbgr.xr15.nr1[nsmm_l]
print @n.xbgr.xr16.nr1[nsmm_rsh]
print @n.xbgr.xr16.nr1[nsmm_w]
print @n.xbgr.xr16.nr1[nsmm_l]
print @n.xbgr.xr17.nr1[nsmm_rsh]
print @n.xbgr.xr17.nr1[nsmm_w]
print @n.xbgr.xr17.nr1[nsmm_l]
print @n.xbgr.xr18.nr1[nsmm_rsh]
print @n.xbgr.xr18.nr1[nsmm_w]
print @n.xbgr.xr18.nr1[nsmm_l]
print @n.xbgr.xr19.nr1[nsmm_rsh]
print @n.xbgr.xr19.nr1[nsmm_w]
print @n.xbgr.xr19.nr1[nsmm_l]
print @n.xbgr.xr20.nr1[nsmm_rsh]
print @n.xbgr.xr20.nr1[nsmm_w]
print @n.xbgr.xr20.nr1[nsmm_l]
print @n.xbgr.xr21.nr1[nsmm_rsh]
print @n.xbgr.xr21.nr1[nsmm_w]
print @n.xbgr.xr21.nr1[nsmm_l]
print @n.xbgr.xr22.nr1[nsmm_rsh]
print @n.xbgr.xr22.nr1[nsmm_w]
print @n.xbgr.xr22.nr1[nsmm_l]
print @n.xbgr.xr23.nr1[nsmm_rsh]
print @n.xbgr.xr23.nr1[nsmm_w]
print @n.xbgr.xr23.nr1[nsmm_l]
print @n.xbgr.xr24.nr1[nsmm_rsh]
print @n.xbgr.xr24.nr1[nsmm_w]
print @n.xbgr.xr24.nr1[nsmm_l]
print @n.xbgr.xr25.nr1[nsmm_rsh]
print @n.xbgr.xr25.nr1[nsmm_w]
print @n.xbgr.xr25.nr1[nsmm_l]
print @n.xbgr.xr26.nr1[nsmm_rsh]
print @n.xbgr.xr26.nr1[nsmm_w]
print @n.xbgr.xr26.nr1[nsmm_l]
print @n.xbgr.xm27.nsg13_hv_pmos[w]
print @n.xbgr.xm27.nsg13_hv_pmos[l]
print @n.xbgr.xm27.nsg13_hv_pmos[delvto]
print @n.xbgr.xm27.nsg13_hv_pmos[factuo]
print @n.xbgr.xm28.nsg13_hv_pmos[w]
print @n.xbgr.xm28.nsg13_hv_pmos[l]
print @n.xbgr.xm28.nsg13_hv_pmos[delvto]
print @n.xbgr.xm28.nsg13_hv_pmos[factuo]
print @n.xbgr.xm29.nsg13_hv_nmos[w]
print @n.xbgr.xm29.nsg13_hv_nmos[l]
print @n.xbgr.xm29.nsg13_hv_nmos[delvto]
print @n.xbgr.xm29.nsg13_hv_nmos[factuo]
print @n.xbgr.xm30.nsg13_hv_nmos[w]
print @n.xbgr.xm30.nsg13_hv_nmos[l]
print @n.xbgr.xm30.nsg13_hv_nmos[delvto]
print @n.xbgr.xm30.nsg13_hv_nmos[factuo]
print @n.xbgr.xm31.nsg13_hv_nmos[w]
print @n.xbgr.xm31.nsg13_hv_nmos[l]
print @n.xbgr.xm31.nsg13_hv_nmos[delvto]
print @n.xbgr.xm31.nsg13_hv_nmos[factuo]
print @n.xbgr.xm32.nsg13_hv_nmos[w]
print @n.xbgr.xm32.nsg13_hv_nmos[l]
print @n.xbgr.xm32.nsg13_hv_nmos[delvto]
print @n.xbgr.xm32.nsg13_hv_nmos[factuo]
print @n.xbgr.xm33.nsg13_hv_nmos[w]
print @n.xbgr.xm33.nsg13_hv_nmos[l]
print @n.xbgr.xm33.nsg13_hv_nmos[delvto]
print @n.xbgr.xm33.nsg13_hv_nmos[factuo]
print @n.xbgr.xm34.nsg13_hv_nmos[w]
print @n.xbgr.xm34.nsg13_hv_nmos[l]
print @n.xbgr.xm34.nsg13_hv_nmos[delvto]
print @n.xbgr.xm34.nsg13_hv_nmos[factuo]
print @n.xbgr.xm35.nsg13_hv_nmos[w]
print @n.xbgr.xm35.nsg13_hv_nmos[l]
print @n.xbgr.xm35.nsg13_hv_nmos[delvto]
print @n.xbgr.xm35.nsg13_hv_nmos[factuo]
print @n.xbgr.xm36.nsg13_hv_nmos[w]
print @n.xbgr.xm36.nsg13_hv_nmos[l]
print @n.xbgr.xm36.nsg13_hv_nmos[delvto]
print @n.xbgr.xm36.nsg13_hv_nmos[factuo]
print @n.xbgr.xm37.nsg13_hv_nmos[w]
print @n.xbgr.xm37.nsg13_hv_nmos[l]
print @n.xbgr.xm37.nsg13_hv_nmos[delvto]
print @n.xbgr.xm37.nsg13_hv_nmos[factuo]
print @n.xbgr.xm38.nsg13_hv_pmos[w]
print @n.xbgr.xm38.nsg13_hv_pmos[l]
print @n.xbgr.xm38.nsg13_hv_pmos[delvto]
print @n.xbgr.xm38.nsg13_hv_pmos[factuo]
print @n.xbgr.xm39.nsg13_hv_pmos[w]
print @n.xbgr.xm39.nsg13_hv_pmos[l]
print @n.xbgr.xm39.nsg13_hv_pmos[delvto]
print @n.xbgr.xm39.nsg13_hv_pmos[factuo]
print @n.xbgr.xm40.nsg13_hv_pmos[w]
print @n.xbgr.xm40.nsg13_hv_pmos[l]
print @n.xbgr.xm40.nsg13_hv_pmos[delvto]
print @n.xbgr.xm40.nsg13_hv_pmos[factuo]
print @n.xbgr.xm41.nsg13_hv_pmos[w]
print @n.xbgr.xm41.nsg13_hv_pmos[l]
print @n.xbgr.xm41.nsg13_hv_pmos[delvto]
print @n.xbgr.xm41.nsg13_hv_pmos[factuo]
print @n.xbgr.xm42.nsg13_hv_pmos[w]
print @n.xbgr.xm42.nsg13_hv_pmos[l]
print @n.xbgr.xm42.nsg13_hv_pmos[delvto]
print @n.xbgr.xm42.nsg13_hv_pmos[factuo]
print @n.xbgr.xm43.nsg13_hv_pmos[w]
print @n.xbgr.xm43.nsg13_hv_pmos[l]
print @n.xbgr.xm43.nsg13_hv_pmos[delvto]
print @n.xbgr.xm43.nsg13_hv_pmos[factuo]
print @n.xbgr.xm44.nsg13_hv_pmos[w]
print @n.xbgr.xm44.nsg13_hv_pmos[l]
print @n.xbgr.xm44.nsg13_hv_pmos[delvto]
print @n.xbgr.xm44.nsg13_hv_pmos[factuo]
print @n.xbgr.xm45.nsg13_hv_pmos[w]
print @n.xbgr.xm45.nsg13_hv_pmos[l]
print @n.xbgr.xm45.nsg13_hv_pmos[delvto]
print @n.xbgr.xm45.nsg13_hv_pmos[factuo]
print @n.xbgr.xm46.nsg13_hv_pmos[w]
print @n.xbgr.xm46.nsg13_hv_pmos[l]
print @n.xbgr.xm46.nsg13_hv_pmos[delvto]
print @n.xbgr.xm46.nsg13_hv_pmos[factuo]
print @n.xbgr.xm47.nsg13_hv_pmos[w]
print @n.xbgr.xm47.nsg13_hv_pmos[l]
print @n.xbgr.xm47.nsg13_hv_pmos[delvto]
print @n.xbgr.xm47.nsg13_hv_pmos[factuo]
print @n.xbgr.xm48.nsg13_hv_pmos[w]
print @n.xbgr.xm48.nsg13_hv_pmos[l]
print @n.xbgr.xm48.nsg13_hv_pmos[delvto]
print @n.xbgr.xm48.nsg13_hv_pmos[factuo]
print @n.xbgr.xm49.nsg13_hv_pmos[w]
print @n.xbgr.xm49.nsg13_hv_pmos[l]
print @n.xbgr.xm49.nsg13_hv_pmos[delvto]
print @n.xbgr.xm49.nsg13_hv_pmos[factuo]
print @n.xbgr.xm50.nsg13_hv_pmos[w]
print @n.xbgr.xm50.nsg13_hv_pmos[l]
print @n.xbgr.xm50.nsg13_hv_pmos[delvto]
print @n.xbgr.xm50.nsg13_hv_pmos[factuo]
print @n.xbgr.xm51.nsg13_hv_pmos[w]
print @n.xbgr.xm51.nsg13_hv_pmos[l]
print @n.xbgr.xm51.nsg13_hv_pmos[delvto]
print @n.xbgr.xm51.nsg13_hv_pmos[factuo]
print @n.xbgr.xm52.nsg13_hv_pmos[w]
print @n.xbgr.xm52.nsg13_hv_pmos[l]
print @n.xbgr.xm52.nsg13_hv_pmos[delvto]
print @n.xbgr.xm52.nsg13_hv_pmos[factuo]
print @n.xbgr.xm53.nsg13_hv_pmos[w]
print @n.xbgr.xm53.nsg13_hv_pmos[l]
print @n.xbgr.xm53.nsg13_hv_pmos[delvto]
print @n.xbgr.xm53.nsg13_hv_pmos[factuo]
print @n.xbgr.xm54.nsg13_hv_pmos[w]
print @n.xbgr.xm54.nsg13_hv_pmos[l]
print @n.xbgr.xm54.nsg13_hv_pmos[delvto]
print @n.xbgr.xm54.nsg13_hv_pmos[factuo]
print @q.xbgr.xq55.qnpn13g2[area]
print @q.xbgr.xq56.qnpn13g2[area]
print @q.xbgr.xq57.qnpn13g2[area]
print @q.xbgr.xq58.qnpn13g2[area]
print @q.xbgr.xq59.qnpn13g2[area]
print @q.xbgr.xq60.qnpn13g2[area]
print @q.xbgr.xq61.qnpn13g2[area]
print @q.xbgr.xq62.qnpn13g2[area]
print @q.xbgr.xq63.qnpn13g2[area]
print @q.xbgr.xq64.qnpn13g2[area]
print @q.xbgr.xq65.qnpn13g2[area]
print @q.xbgr.xq66.qnpn13g2[area]
print @q.xbgr.xq67.qnpn13g2[area]
print @q.xbgr.xq68.qnpn13g2[area]
print @q.xbgr.xq69.qnpn13g2[area]
print @q.xbgr.xq70.qnpn13g2[area]
print @q.xbgr.xq71.qnpn13g2[area]
print @q.xbgr.xq72.qnpn13g2[area]
print @q.xbgr.xq73.qnpn13g2[area]
print @q.xbgr.xq74.qnpn13g2[area]
print @q.xbgr.xq75.qnpn13g2[area]
print @q.xbgr.xq76.qnpn13g2[area]
print @n.xbgr.xr77.nr1[nsmm_rsh]
print @n.xbgr.xr77.nr1[nsmm_w]
print @n.xbgr.xr77.nr1[nsmm_l]
print @n.xbgr.xr78.nr1[nsmm_rsh]
print @n.xbgr.xr78.nr1[nsmm_w]
print @n.xbgr.xr78.nr1[nsmm_l]
print @n.xbgr.xr79.nr1[nsmm_rsh]
print @n.xbgr.xr79.nr1[nsmm_w]
print @n.xbgr.xr79.nr1[nsmm_l]
print @n.xbgr.xr80.nr1[nsmm_rsh]
print @n.xbgr.xr80.nr1[nsmm_w]
print @n.xbgr.xr80.nr1[nsmm_l]
print @n.xbgr.xr81.nr1[nsmm_rsh]
print @n.xbgr.xr81.nr1[nsmm_w]
print @n.xbgr.xr81.nr1[nsmm_l]
print @n.xbgr.xr82.nr1[nsmm_rsh]
print @n.xbgr.xr82.nr1[nsmm_w]
print @n.xbgr.xr82.nr1[nsmm_l]
print @n.xbgr.xr83.nr1[nsmm_rsh]
print @n.xbgr.xr83.nr1[nsmm_w]
print @n.xbgr.xr83.nr1[nsmm_l]
print @n.xbgr.xr84.nr1[nsmm_rsh]
print @n.xbgr.xr84.nr1[nsmm_w]
print @n.xbgr.xr84.nr1[nsmm_l]
print @n.xbgr.xr85.nr1[nsmm_rsh]
print @n.xbgr.xr85.nr1[nsmm_w]
print @n.xbgr.xr85.nr1[nsmm_l]
print @n.xbgr.xr86.nr1[nsmm_rsh]
print @n.xbgr.xr86.nr1[nsmm_w]
print @n.xbgr.xr86.nr1[nsmm_l]
print @n.xbgr.xr16_u2.nr1[nsmm_rsh]
print @n.xbgr.xr16_u2.nr1[nsmm_w]
print @n.xbgr.xr16_u2.nr1[nsmm_l]
print @n.xbgr.xr16_u3.nr1[nsmm_rsh]
print @n.xbgr.xr16_u3.nr1[nsmm_w]
print @n.xbgr.xr16_u3.nr1[nsmm_l]
print @n.xbgr.xr16_u4.nr1[nsmm_rsh]
print @n.xbgr.xr16_u4.nr1[nsmm_w]
print @n.xbgr.xr16_u4.nr1[nsmm_l]
print @n.xbgr.xr16_u5.nr1[nsmm_rsh]
print @n.xbgr.xr16_u5.nr1[nsmm_w]
print @n.xbgr.xr16_u5.nr1[nsmm_l]
print @n.xbgr.xr16_u6.nr1[nsmm_rsh]
print @n.xbgr.xr16_u6.nr1[nsmm_w]
print @n.xbgr.xr16_u6.nr1[nsmm_l]
print @n.xbgr.xr16_u7.nr1[nsmm_rsh]
print @n.xbgr.xr16_u7.nr1[nsmm_w]
print @n.xbgr.xr16_u7.nr1[nsmm_l]
print @n.xbgr.xr16_u8.nr1[nsmm_rsh]
print @n.xbgr.xr16_u8.nr1[nsmm_w]
print @n.xbgr.xr16_u8.nr1[nsmm_l]
print @n.xbgr.xr16_u9.nr1[nsmm_rsh]
print @n.xbgr.xr16_u9.nr1[nsmm_w]
print @n.xbgr.xr16_u9.nr1[nsmm_l]
print @n.xbgr.xr16_u10.nr1[nsmm_rsh]
print @n.xbgr.xr16_u10.nr1[nsmm_w]
print @n.xbgr.xr16_u10.nr1[nsmm_l]
print @n.xbgr.xr16_u11.nr1[nsmm_rsh]
print @n.xbgr.xr16_u11.nr1[nsmm_w]
print @n.xbgr.xr16_u11.nr1[nsmm_l]
print @n.xbgr.xr16_u12.nr1[nsmm_rsh]
print @n.xbgr.xr16_u12.nr1[nsmm_w]
print @n.xbgr.xr16_u12.nr1[nsmm_l]
print @n.xbgr.xr16_u13.nr1[nsmm_rsh]
print @n.xbgr.xr16_u13.nr1[nsmm_w]
print @n.xbgr.xr16_u13.nr1[nsmm_l]
print @n.xbgr.xr16_u14.nr1[nsmm_rsh]
print @n.xbgr.xr16_u14.nr1[nsmm_w]
print @n.xbgr.xr16_u14.nr1[nsmm_l]
print @n.xbgr.xr16_u15.nr1[nsmm_rsh]
print @n.xbgr.xr16_u15.nr1[nsmm_w]
print @n.xbgr.xr16_u15.nr1[nsmm_l]
print @n.xbgr.xr16_u16.nr1[nsmm_rsh]
print @n.xbgr.xr16_u16.nr1[nsmm_w]
print @n.xbgr.xr16_u16.nr1[nsmm_l]
print @n.xbgr.xr16_u17.nr1[nsmm_rsh]
print @n.xbgr.xr16_u17.nr1[nsmm_w]
print @n.xbgr.xr16_u17.nr1[nsmm_l]
print @n.xbgr.xr16_u18.nr1[nsmm_rsh]
print @n.xbgr.xr16_u18.nr1[nsmm_w]
print @n.xbgr.xr16_u18.nr1[nsmm_l]
print @n.xbgr.xr16_u19.nr1[nsmm_rsh]
print @n.xbgr.xr16_u19.nr1[nsmm_w]
print @n.xbgr.xr16_u19.nr1[nsmm_l]
print @n.xbgr.xr16_u20.nr1[nsmm_rsh]
print @n.xbgr.xr16_u20.nr1[nsmm_w]
print @n.xbgr.xr16_u20.nr1[nsmm_l]
print @n.xbgr.xr16_u21.nr1[nsmm_rsh]
print @n.xbgr.xr16_u21.nr1[nsmm_w]
print @n.xbgr.xr16_u21.nr1[nsmm_l]
print @n.xbgr.xr16_u22.nr1[nsmm_rsh]
print @n.xbgr.xr16_u22.nr1[nsmm_w]
print @n.xbgr.xr16_u22.nr1[nsmm_l]
print @n.xbgr.xr16_u23.nr1[nsmm_rsh]
print @n.xbgr.xr16_u23.nr1[nsmm_w]
print @n.xbgr.xr16_u23.nr1[nsmm_l]
print @n.xbgr.xr16_u24.nr1[nsmm_rsh]
print @n.xbgr.xr16_u24.nr1[nsmm_w]
print @n.xbgr.xr16_u24.nr1[nsmm_l]
print @n.xbgr.xr17_u2.nr1[nsmm_rsh]
print @n.xbgr.xr17_u2.nr1[nsmm_w]
print @n.xbgr.xr17_u2.nr1[nsmm_l]
print @n.xbgr.xr17_u3.nr1[nsmm_rsh]
print @n.xbgr.xr17_u3.nr1[nsmm_w]
print @n.xbgr.xr17_u3.nr1[nsmm_l]
print @n.xbgr.xr17_u4.nr1[nsmm_rsh]
print @n.xbgr.xr17_u4.nr1[nsmm_w]
print @n.xbgr.xr17_u4.nr1[nsmm_l]
print @n.xbgr.xr18_u2.nr1[nsmm_rsh]
print @n.xbgr.xr18_u2.nr1[nsmm_w]
print @n.xbgr.xr18_u2.nr1[nsmm_l]
print @n.xbgr.xr18_u3.nr1[nsmm_rsh]
print @n.xbgr.xr18_u3.nr1[nsmm_w]
print @n.xbgr.xr18_u3.nr1[nsmm_l]
print @n.xbgr.xr18_u4.nr1[nsmm_rsh]
print @n.xbgr.xr18_u4.nr1[nsmm_w]
print @n.xbgr.xr18_u4.nr1[nsmm_l]
print @n.xbgr.xr19_u2.nr1[nsmm_rsh]
print @n.xbgr.xr19_u2.nr1[nsmm_w]
print @n.xbgr.xr19_u2.nr1[nsmm_l]
print @n.xbgr.xr19_u3.nr1[nsmm_rsh]
print @n.xbgr.xr19_u3.nr1[nsmm_w]
print @n.xbgr.xr19_u3.nr1[nsmm_l]
print @n.xbgr.xr19_u4.nr1[nsmm_rsh]
print @n.xbgr.xr19_u4.nr1[nsmm_w]
print @n.xbgr.xr19_u4.nr1[nsmm_l]
print @n.xbgr.xr20_u2.nr1[nsmm_rsh]
print @n.xbgr.xr20_u2.nr1[nsmm_w]
print @n.xbgr.xr20_u2.nr1[nsmm_l]
print @n.xbgr.xr20_u3.nr1[nsmm_rsh]
print @n.xbgr.xr20_u3.nr1[nsmm_w]
print @n.xbgr.xr20_u3.nr1[nsmm_l]
print @n.xbgr.xr20_u4.nr1[nsmm_rsh]
print @n.xbgr.xr20_u4.nr1[nsmm_w]
print @n.xbgr.xr20_u4.nr1[nsmm_l]
print @n.xbgr.xr21_u2.nr1[nsmm_rsh]
print @n.xbgr.xr21_u2.nr1[nsmm_w]
print @n.xbgr.xr21_u2.nr1[nsmm_l]
print @n.xbgr.xr21_u3.nr1[nsmm_rsh]
print @n.xbgr.xr21_u3.nr1[nsmm_w]
print @n.xbgr.xr21_u3.nr1[nsmm_l]
print @n.xbgr.xr21_u4.nr1[nsmm_rsh]
print @n.xbgr.xr21_u4.nr1[nsmm_w]
print @n.xbgr.xr21_u4.nr1[nsmm_l]
print @n.xbgr.xr22_u2.nr1[nsmm_rsh]
print @n.xbgr.xr22_u2.nr1[nsmm_w]
print @n.xbgr.xr22_u2.nr1[nsmm_l]
print @n.xbgr.xr22_u3.nr1[nsmm_rsh]
print @n.xbgr.xr22_u3.nr1[nsmm_w]
print @n.xbgr.xr22_u3.nr1[nsmm_l]
print @n.xbgr.xr22_u4.nr1[nsmm_rsh]
print @n.xbgr.xr22_u4.nr1[nsmm_w]
print @n.xbgr.xr22_u4.nr1[nsmm_l]
print @n.xbgr.xr23_u2.nr1[nsmm_rsh]
print @n.xbgr.xr23_u2.nr1[nsmm_w]
print @n.xbgr.xr23_u2.nr1[nsmm_l]
print @n.xbgr.xr23_u3.nr1[nsmm_rsh]
print @n.xbgr.xr23_u3.nr1[nsmm_w]
print @n.xbgr.xr23_u3.nr1[nsmm_l]
print @n.xbgr.xr23_u4.nr1[nsmm_rsh]
print @n.xbgr.xr23_u4.nr1[nsmm_w]
print @n.xbgr.xr23_u4.nr1[nsmm_l]
print @n.xbgr.xr23_u5.nr1[nsmm_rsh]
print @n.xbgr.xr23_u5.nr1[nsmm_w]
print @n.xbgr.xr23_u5.nr1[nsmm_l]
print @n.xbgr.xr23_u6.nr1[nsmm_rsh]
print @n.xbgr.xr23_u6.nr1[nsmm_w]
print @n.xbgr.xr23_u6.nr1[nsmm_l]
print @n.xbgr.xr23_u7.nr1[nsmm_rsh]
print @n.xbgr.xr23_u7.nr1[nsmm_w]
print @n.xbgr.xr23_u7.nr1[nsmm_l]
print @n.xbgr.xr23_u8.nr1[nsmm_rsh]
print @n.xbgr.xr23_u8.nr1[nsmm_w]
print @n.xbgr.xr23_u8.nr1[nsmm_l]
print @n.xbgr.xr23_u9.nr1[nsmm_rsh]
print @n.xbgr.xr23_u9.nr1[nsmm_w]
print @n.xbgr.xr23_u9.nr1[nsmm_l]
print @n.xbgr.xr23_u10.nr1[nsmm_rsh]
print @n.xbgr.xr23_u10.nr1[nsmm_w]
print @n.xbgr.xr23_u10.nr1[nsmm_l]
print @n.xbgr.xr23_u11.nr1[nsmm_rsh]
print @n.xbgr.xr23_u11.nr1[nsmm_w]
print @n.xbgr.xr23_u11.nr1[nsmm_l]
print @n.xbgr.xr23_u12.nr1[nsmm_rsh]
print @n.xbgr.xr23_u12.nr1[nsmm_w]
print @n.xbgr.xr23_u12.nr1[nsmm_l]
print @n.xbgr.xr23_u13.nr1[nsmm_rsh]
print @n.xbgr.xr23_u13.nr1[nsmm_w]
print @n.xbgr.xr23_u13.nr1[nsmm_l]
print @n.xbgr.xr23_u14.nr1[nsmm_rsh]
print @n.xbgr.xr23_u14.nr1[nsmm_w]
print @n.xbgr.xr23_u14.nr1[nsmm_l]
print @n.xbgr.xr23_u15.nr1[nsmm_rsh]
print @n.xbgr.xr23_u15.nr1[nsmm_w]
print @n.xbgr.xr23_u15.nr1[nsmm_l]
print @n.xbgr.xr23_u16.nr1[nsmm_rsh]
print @n.xbgr.xr23_u16.nr1[nsmm_w]
print @n.xbgr.xr23_u16.nr1[nsmm_l]
print @n.xbgr.xr23_u17.nr1[nsmm_rsh]
print @n.xbgr.xr23_u17.nr1[nsmm_w]
print @n.xbgr.xr23_u17.nr1[nsmm_l]
print @n.xbgr.xr23_u18.nr1[nsmm_rsh]
print @n.xbgr.xr23_u18.nr1[nsmm_w]
print @n.xbgr.xr23_u18.nr1[nsmm_l]
print @n.xbgr.xr23_u19.nr1[nsmm_rsh]
print @n.xbgr.xr23_u19.nr1[nsmm_w]
print @n.xbgr.xr23_u19.nr1[nsmm_l]
print @n.xbgr.xr23_u20.nr1[nsmm_rsh]
print @n.xbgr.xr23_u20.nr1[nsmm_w]
print @n.xbgr.xr23_u20.nr1[nsmm_l]
print @n.xbgr.xr23_u21.nr1[nsmm_rsh]
print @n.xbgr.xr23_u21.nr1[nsmm_w]
print @n.xbgr.xr23_u21.nr1[nsmm_l]
print @n.xbgr.xr23_u22.nr1[nsmm_rsh]
print @n.xbgr.xr23_u22.nr1[nsmm_w]
print @n.xbgr.xr23_u22.nr1[nsmm_l]
print @n.xbgr.xr23_u23.nr1[nsmm_rsh]
print @n.xbgr.xr23_u23.nr1[nsmm_w]
print @n.xbgr.xr23_u23.nr1[nsmm_l]
print @n.xbgr.xr23_u24.nr1[nsmm_rsh]
print @n.xbgr.xr23_u24.nr1[nsmm_w]
print @n.xbgr.xr23_u24.nr1[nsmm_l]
print @n.xbgr.xr24_u2.nr1[nsmm_rsh]
print @n.xbgr.xr24_u2.nr1[nsmm_w]
print @n.xbgr.xr24_u2.nr1[nsmm_l]
print @n.xbgr.xr24_u3.nr1[nsmm_rsh]
print @n.xbgr.xr24_u3.nr1[nsmm_w]
print @n.xbgr.xr24_u3.nr1[nsmm_l]
print @n.xbgr.xr24_u4.nr1[nsmm_rsh]
print @n.xbgr.xr24_u4.nr1[nsmm_w]
print @n.xbgr.xr24_u4.nr1[nsmm_l]
print @n.xbgr.xr24_u5.nr1[nsmm_rsh]
print @n.xbgr.xr24_u5.nr1[nsmm_w]
print @n.xbgr.xr24_u5.nr1[nsmm_l]
print @n.xbgr.xr24_u6.nr1[nsmm_rsh]
print @n.xbgr.xr24_u6.nr1[nsmm_w]
print @n.xbgr.xr24_u6.nr1[nsmm_l]
print @n.xbgr.xr24_u7.nr1[nsmm_rsh]
print @n.xbgr.xr24_u7.nr1[nsmm_w]
print @n.xbgr.xr24_u7.nr1[nsmm_l]
print @n.xbgr.xr24_u8.nr1[nsmm_rsh]
print @n.xbgr.xr24_u8.nr1[nsmm_w]
print @n.xbgr.xr24_u8.nr1[nsmm_l]
print @n.xbgr.xr24_u9.nr1[nsmm_rsh]
print @n.xbgr.xr24_u9.nr1[nsmm_w]
print @n.xbgr.xr24_u9.nr1[nsmm_l]
print @n.xbgr.xr24_u10.nr1[nsmm_rsh]
print @n.xbgr.xr24_u10.nr1[nsmm_w]
print @n.xbgr.xr24_u10.nr1[nsmm_l]
print @n.xbgr.xr24_u11.nr1[nsmm_rsh]
print @n.xbgr.xr24_u11.nr1[nsmm_w]
print @n.xbgr.xr24_u11.nr1[nsmm_l]
print @n.xbgr.xr24_u12.nr1[nsmm_rsh]
print @n.xbgr.xr24_u12.nr1[nsmm_w]
print @n.xbgr.xr24_u12.nr1[nsmm_l]
print @n.xbgr.xr24_u13.nr1[nsmm_rsh]
print @n.xbgr.xr24_u13.nr1[nsmm_w]
print @n.xbgr.xr24_u13.nr1[nsmm_l]
print @n.xbgr.xr24_u14.nr1[nsmm_rsh]
print @n.xbgr.xr24_u14.nr1[nsmm_w]
print @n.xbgr.xr24_u14.nr1[nsmm_l]
print @n.xbgr.xr24_u15.nr1[nsmm_rsh]
print @n.xbgr.xr24_u15.nr1[nsmm_w]
print @n.xbgr.xr24_u15.nr1[nsmm_l]
print @n.xbgr.xr24_u16.nr1[nsmm_rsh]
print @n.xbgr.xr24_u16.nr1[nsmm_w]
print @n.xbgr.xr24_u16.nr1[nsmm_l]
print @n.xbgr.xr24_u17.nr1[nsmm_rsh]
print @n.xbgr.xr24_u17.nr1[nsmm_w]
print @n.xbgr.xr24_u17.nr1[nsmm_l]
print @n.xbgr.xr24_u18.nr1[nsmm_rsh]
print @n.xbgr.xr24_u18.nr1[nsmm_w]
print @n.xbgr.xr24_u18.nr1[nsmm_l]
print @n.xbgr.xr24_u19.nr1[nsmm_rsh]
print @n.xbgr.xr24_u19.nr1[nsmm_w]
print @n.xbgr.xr24_u19.nr1[nsmm_l]
print @n.xbgr.xr24_u20.nr1[nsmm_rsh]
print @n.xbgr.xr24_u20.nr1[nsmm_w]
print @n.xbgr.xr24_u20.nr1[nsmm_l]
print @n.xbgr.xr24_u21.nr1[nsmm_rsh]
print @n.xbgr.xr24_u21.nr1[nsmm_w]
print @n.xbgr.xr24_u21.nr1[nsmm_l]
print @n.xbgr.xr24_u22.nr1[nsmm_rsh]
print @n.xbgr.xr24_u22.nr1[nsmm_w]
print @n.xbgr.xr24_u22.nr1[nsmm_l]
print @n.xbgr.xr24_u23.nr1[nsmm_rsh]
print @n.xbgr.xr24_u23.nr1[nsmm_w]
print @n.xbgr.xr24_u23.nr1[nsmm_l]
print @n.xbgr.xr24_u24.nr1[nsmm_rsh]
print @n.xbgr.xr24_u24.nr1[nsmm_w]
print @n.xbgr.xr24_u24.nr1[nsmm_l]
print @n.xbgr.xr25_u2.nr1[nsmm_rsh]
print @n.xbgr.xr25_u2.nr1[nsmm_w]
print @n.xbgr.xr25_u2.nr1[nsmm_l]
print @n.xbgr.xr25_u3.nr1[nsmm_rsh]
print @n.xbgr.xr25_u3.nr1[nsmm_w]
print @n.xbgr.xr25_u3.nr1[nsmm_l]
print @n.xbgr.xr25_u4.nr1[nsmm_rsh]
print @n.xbgr.xr25_u4.nr1[nsmm_w]
print @n.xbgr.xr25_u4.nr1[nsmm_l]
print @n.xbgr.xr25_u5.nr1[nsmm_rsh]
print @n.xbgr.xr25_u5.nr1[nsmm_w]
print @n.xbgr.xr25_u5.nr1[nsmm_l]
print @n.xbgr.xr25_u6.nr1[nsmm_rsh]
print @n.xbgr.xr25_u6.nr1[nsmm_w]
print @n.xbgr.xr25_u6.nr1[nsmm_l]
print @n.xbgr.xr25_u7.nr1[nsmm_rsh]
print @n.xbgr.xr25_u7.nr1[nsmm_w]
print @n.xbgr.xr25_u7.nr1[nsmm_l]
print @n.xbgr.xr25_u8.nr1[nsmm_rsh]
print @n.xbgr.xr25_u8.nr1[nsmm_w]
print @n.xbgr.xr25_u8.nr1[nsmm_l]
print @n.xbgr.xr25_u9.nr1[nsmm_rsh]
print @n.xbgr.xr25_u9.nr1[nsmm_w]
print @n.xbgr.xr25_u9.nr1[nsmm_l]
print @n.xbgr.xr25_u10.nr1[nsmm_rsh]
print @n.xbgr.xr25_u10.nr1[nsmm_w]
print @n.xbgr.xr25_u10.nr1[nsmm_l]
print @n.xbgr.xr25_u11.nr1[nsmm_rsh]
print @n.xbgr.xr25_u11.nr1[nsmm_w]
print @n.xbgr.xr25_u11.nr1[nsmm_l]
print @n.xbgr.xr25_u12.nr1[nsmm_rsh]
print @n.xbgr.xr25_u12.nr1[nsmm_w]
print @n.xbgr.xr25_u12.nr1[nsmm_l]
print @n.xbgr.xr25_u13.nr1[nsmm_rsh]
print @n.xbgr.xr25_u13.nr1[nsmm_w]
print @n.xbgr.xr25_u13.nr1[nsmm_l]
print @n.xbgr.xr25_u14.nr1[nsmm_rsh]
print @n.xbgr.xr25_u14.nr1[nsmm_w]
print @n.xbgr.xr25_u14.nr1[nsmm_l]
print @n.xbgr.xr25_u15.nr1[nsmm_rsh]
print @n.xbgr.xr25_u15.nr1[nsmm_w]
print @n.xbgr.xr25_u15.nr1[nsmm_l]
print @n.xbgr.xr25_u16.nr1[nsmm_rsh]
print @n.xbgr.xr25_u16.nr1[nsmm_w]
print @n.xbgr.xr25_u16.nr1[nsmm_l]
print @n.xbgr.xr25_u17.nr1[nsmm_rsh]
print @n.xbgr.xr25_u17.nr1[nsmm_w]
print @n.xbgr.xr25_u17.nr1[nsmm_l]
print @n.xbgr.xr25_u18.nr1[nsmm_rsh]
print @n.xbgr.xr25_u18.nr1[nsmm_w]
print @n.xbgr.xr25_u18.nr1[nsmm_l]
print @n.xbgr.xr25_u19.nr1[nsmm_rsh]
print @n.xbgr.xr25_u19.nr1[nsmm_w]
print @n.xbgr.xr25_u19.nr1[nsmm_l]
print @n.xbgr.xr25_u20.nr1[nsmm_rsh]
print @n.xbgr.xr25_u20.nr1[nsmm_w]
print @n.xbgr.xr25_u20.nr1[nsmm_l]
print @n.xbgr.xr25_u21.nr1[nsmm_rsh]
print @n.xbgr.xr25_u21.nr1[nsmm_w]
print @n.xbgr.xr25_u21.nr1[nsmm_l]
print @n.xbgr.xr25_u22.nr1[nsmm_rsh]
print @n.xbgr.xr25_u22.nr1[nsmm_w]
print @n.xbgr.xr25_u22.nr1[nsmm_l]
print @n.xbgr.xr25_u23.nr1[nsmm_rsh]
print @n.xbgr.xr25_u23.nr1[nsmm_w]
print @n.xbgr.xr25_u23.nr1[nsmm_l]
print @n.xbgr.xr25_u24.nr1[nsmm_rsh]
print @n.xbgr.xr25_u24.nr1[nsmm_w]
print @n.xbgr.xr25_u24.nr1[nsmm_l]
print @n.xbgr.xr26_u2.nr1[nsmm_rsh]
print @n.xbgr.xr26_u2.nr1[nsmm_w]
print @n.xbgr.xr26_u2.nr1[nsmm_l]
print @n.xbgr.xr26_u3.nr1[nsmm_rsh]
print @n.xbgr.xr26_u3.nr1[nsmm_w]
print @n.xbgr.xr26_u3.nr1[nsmm_l]
print @n.xbgr.xr26_u4.nr1[nsmm_rsh]
print @n.xbgr.xr26_u4.nr1[nsmm_w]
print @n.xbgr.xr26_u4.nr1[nsmm_l]
print @n.xbgr.xr26_u5.nr1[nsmm_rsh]
print @n.xbgr.xr26_u5.nr1[nsmm_w]
print @n.xbgr.xr26_u5.nr1[nsmm_l]
print @n.xbgr.xr26_u6.nr1[nsmm_rsh]
print @n.xbgr.xr26_u6.nr1[nsmm_w]
print @n.xbgr.xr26_u6.nr1[nsmm_l]
print @n.xbgr.xr26_u7.nr1[nsmm_rsh]
print @n.xbgr.xr26_u7.nr1[nsmm_w]
print @n.xbgr.xr26_u7.nr1[nsmm_l]
print @n.xbgr.xr26_u8.nr1[nsmm_rsh]
print @n.xbgr.xr26_u8.nr1[nsmm_w]
print @n.xbgr.xr26_u8.nr1[nsmm_l]
print @n.xbgr.xr26_u9.nr1[nsmm_rsh]
print @n.xbgr.xr26_u9.nr1[nsmm_w]
print @n.xbgr.xr26_u9.nr1[nsmm_l]
print @n.xbgr.xr26_u10.nr1[nsmm_rsh]
print @n.xbgr.xr26_u10.nr1[nsmm_w]
print @n.xbgr.xr26_u10.nr1[nsmm_l]
print @n.xbgr.xr26_u11.nr1[nsmm_rsh]
print @n.xbgr.xr26_u11.nr1[nsmm_w]
print @n.xbgr.xr26_u11.nr1[nsmm_l]
print @n.xbgr.xr26_u12.nr1[nsmm_rsh]
print @n.xbgr.xr26_u12.nr1[nsmm_w]
print @n.xbgr.xr26_u12.nr1[nsmm_l]
print @n.xbgr.xr26_u13.nr1[nsmm_rsh]
print @n.xbgr.xr26_u13.nr1[nsmm_w]
print @n.xbgr.xr26_u13.nr1[nsmm_l]
print @n.xbgr.xr26_u14.nr1[nsmm_rsh]
print @n.xbgr.xr26_u14.nr1[nsmm_w]
print @n.xbgr.xr26_u14.nr1[nsmm_l]
print @n.xbgr.xr26_u15.nr1[nsmm_rsh]
print @n.xbgr.xr26_u15.nr1[nsmm_w]
print @n.xbgr.xr26_u15.nr1[nsmm_l]
print @n.xbgr.xr26_u16.nr1[nsmm_rsh]
print @n.xbgr.xr26_u16.nr1[nsmm_w]
print @n.xbgr.xr26_u16.nr1[nsmm_l]
print @n.xbgr.xr26_u17.nr1[nsmm_rsh]
print @n.xbgr.xr26_u17.nr1[nsmm_w]
print @n.xbgr.xr26_u17.nr1[nsmm_l]
print @n.xbgr.xr26_u18.nr1[nsmm_rsh]
print @n.xbgr.xr26_u18.nr1[nsmm_w]
print @n.xbgr.xr26_u18.nr1[nsmm_l]
print @n.xbgr.xr26_u19.nr1[nsmm_rsh]
print @n.xbgr.xr26_u19.nr1[nsmm_w]
print @n.xbgr.xr26_u19.nr1[nsmm_l]
print @n.xbgr.xr26_u20.nr1[nsmm_rsh]
print @n.xbgr.xr26_u20.nr1[nsmm_w]
print @n.xbgr.xr26_u20.nr1[nsmm_l]
print @n.xbgr.xr26_u21.nr1[nsmm_rsh]
print @n.xbgr.xr26_u21.nr1[nsmm_w]
print @n.xbgr.xr26_u21.nr1[nsmm_l]
print @n.xbgr.xr26_u22.nr1[nsmm_rsh]
print @n.xbgr.xr26_u22.nr1[nsmm_w]
print @n.xbgr.xr26_u22.nr1[nsmm_l]
print @n.xbgr.xr26_u23.nr1[nsmm_rsh]
print @n.xbgr.xr26_u23.nr1[nsmm_w]
print @n.xbgr.xr26_u23.nr1[nsmm_l]
print @n.xbgr.xr26_u24.nr1[nsmm_rsh]
print @n.xbgr.xr26_u24.nr1[nsmm_w]
print @n.xbgr.xr26_u24.nr1[nsmm_l]
print @n.xbgr.xm34_u2.nsg13_hv_nmos[w]
print @n.xbgr.xm34_u2.nsg13_hv_nmos[l]
print @n.xbgr.xm34_u2.nsg13_hv_nmos[delvto]
print @n.xbgr.xm34_u2.nsg13_hv_nmos[factuo]
print @n.xbgr.xm34_u3.nsg13_hv_nmos[w]
print @n.xbgr.xm34_u3.nsg13_hv_nmos[l]
print @n.xbgr.xm34_u3.nsg13_hv_nmos[delvto]
print @n.xbgr.xm34_u3.nsg13_hv_nmos[factuo]
print @n.xbgr.xm34_u4.nsg13_hv_nmos[w]
print @n.xbgr.xm34_u4.nsg13_hv_nmos[l]
print @n.xbgr.xm34_u4.nsg13_hv_nmos[delvto]
print @n.xbgr.xm34_u4.nsg13_hv_nmos[factuo]
print @n.xbgr.xm34_u5.nsg13_hv_nmos[w]
print @n.xbgr.xm34_u5.nsg13_hv_nmos[l]
print @n.xbgr.xm34_u5.nsg13_hv_nmos[delvto]
print @n.xbgr.xm34_u5.nsg13_hv_nmos[factuo]
print @n.xbgr.xm34_u6.nsg13_hv_nmos[w]
print @n.xbgr.xm34_u6.nsg13_hv_nmos[l]
print @n.xbgr.xm34_u6.nsg13_hv_nmos[delvto]
print @n.xbgr.xm34_u6.nsg13_hv_nmos[factuo]
print @n.xbgr.xm34_u7.nsg13_hv_nmos[w]
print @n.xbgr.xm34_u7.nsg13_hv_nmos[l]
print @n.xbgr.xm34_u7.nsg13_hv_nmos[delvto]
print @n.xbgr.xm34_u7.nsg13_hv_nmos[factuo]
print @n.xbgr.xm34_u8.nsg13_hv_nmos[w]
print @n.xbgr.xm34_u8.nsg13_hv_nmos[l]
print @n.xbgr.xm34_u8.nsg13_hv_nmos[delvto]
print @n.xbgr.xm34_u8.nsg13_hv_nmos[factuo]
print @n.xbgr.xm34_u9.nsg13_hv_nmos[w]
print @n.xbgr.xm34_u9.nsg13_hv_nmos[l]
print @n.xbgr.xm34_u9.nsg13_hv_nmos[delvto]
print @n.xbgr.xm34_u9.nsg13_hv_nmos[factuo]
print @n.xbgr.xm34_u10.nsg13_hv_nmos[w]
print @n.xbgr.xm34_u10.nsg13_hv_nmos[l]
print @n.xbgr.xm34_u10.nsg13_hv_nmos[delvto]
print @n.xbgr.xm34_u10.nsg13_hv_nmos[factuo]
print @n.xbgr.xm34_u11.nsg13_hv_nmos[w]
print @n.xbgr.xm34_u11.nsg13_hv_nmos[l]
print @n.xbgr.xm34_u11.nsg13_hv_nmos[delvto]
print @n.xbgr.xm34_u11.nsg13_hv_nmos[factuo]
print @n.xbgr.xm34_u12.nsg13_hv_nmos[w]
print @n.xbgr.xm34_u12.nsg13_hv_nmos[l]
print @n.xbgr.xm34_u12.nsg13_hv_nmos[delvto]
print @n.xbgr.xm34_u12.nsg13_hv_nmos[factuo]
print @n.xbgr.xm34_u13.nsg13_hv_nmos[w]
print @n.xbgr.xm34_u13.nsg13_hv_nmos[l]
print @n.xbgr.xm34_u13.nsg13_hv_nmos[delvto]
print @n.xbgr.xm34_u13.nsg13_hv_nmos[factuo]
print @n.xbgr.xm34_u14.nsg13_hv_nmos[w]
print @n.xbgr.xm34_u14.nsg13_hv_nmos[l]
print @n.xbgr.xm34_u14.nsg13_hv_nmos[delvto]
print @n.xbgr.xm34_u14.nsg13_hv_nmos[factuo]
print @n.xbgr.xm34_u15.nsg13_hv_nmos[w]
print @n.xbgr.xm34_u15.nsg13_hv_nmos[l]
print @n.xbgr.xm34_u15.nsg13_hv_nmos[delvto]
print @n.xbgr.xm34_u15.nsg13_hv_nmos[factuo]
print @n.xbgr.xm34_u16.nsg13_hv_nmos[w]
print @n.xbgr.xm34_u16.nsg13_hv_nmos[l]
print @n.xbgr.xm34_u16.nsg13_hv_nmos[delvto]
print @n.xbgr.xm34_u16.nsg13_hv_nmos[factuo]
print @n.xbgr.xm34_u17.nsg13_hv_nmos[w]
print @n.xbgr.xm34_u17.nsg13_hv_nmos[l]
print @n.xbgr.xm34_u17.nsg13_hv_nmos[delvto]
print @n.xbgr.xm34_u17.nsg13_hv_nmos[factuo]
print @n.xbgr.xm34_u18.nsg13_hv_nmos[w]
print @n.xbgr.xm34_u18.nsg13_hv_nmos[l]
print @n.xbgr.xm34_u18.nsg13_hv_nmos[delvto]
print @n.xbgr.xm34_u18.nsg13_hv_nmos[factuo]
print @n.xbgr.xm34_u19.nsg13_hv_nmos[w]
print @n.xbgr.xm34_u19.nsg13_hv_nmos[l]
print @n.xbgr.xm34_u19.nsg13_hv_nmos[delvto]
print @n.xbgr.xm34_u19.nsg13_hv_nmos[factuo]
print @n.xbgr.xm34_u20.nsg13_hv_nmos[w]
print @n.xbgr.xm34_u20.nsg13_hv_nmos[l]
print @n.xbgr.xm34_u20.nsg13_hv_nmos[delvto]
print @n.xbgr.xm34_u20.nsg13_hv_nmos[factuo]
print @n.xbgr.xm34_u21.nsg13_hv_nmos[w]
print @n.xbgr.xm34_u21.nsg13_hv_nmos[l]
print @n.xbgr.xm34_u21.nsg13_hv_nmos[delvto]
print @n.xbgr.xm34_u21.nsg13_hv_nmos[factuo]
print @n.xbgr.xm34_u22.nsg13_hv_nmos[w]
print @n.xbgr.xm34_u22.nsg13_hv_nmos[l]
print @n.xbgr.xm34_u22.nsg13_hv_nmos[delvto]
print @n.xbgr.xm34_u22.nsg13_hv_nmos[factuo]
print @n.xbgr.xm34_u23.nsg13_hv_nmos[w]
print @n.xbgr.xm34_u23.nsg13_hv_nmos[l]
print @n.xbgr.xm34_u23.nsg13_hv_nmos[delvto]
print @n.xbgr.xm34_u23.nsg13_hv_nmos[factuo]
print @n.xbgr.xm34_u24.nsg13_hv_nmos[w]
print @n.xbgr.xm34_u24.nsg13_hv_nmos[l]
print @n.xbgr.xm34_u24.nsg13_hv_nmos[delvto]
print @n.xbgr.xm34_u24.nsg13_hv_nmos[factuo]
print @n.xbgr.xm35_u2.nsg13_hv_nmos[w]
print @n.xbgr.xm35_u2.nsg13_hv_nmos[l]
print @n.xbgr.xm35_u2.nsg13_hv_nmos[delvto]
print @n.xbgr.xm35_u2.nsg13_hv_nmos[factuo]
print @n.xbgr.xm35_u3.nsg13_hv_nmos[w]
print @n.xbgr.xm35_u3.nsg13_hv_nmos[l]
print @n.xbgr.xm35_u3.nsg13_hv_nmos[delvto]
print @n.xbgr.xm35_u3.nsg13_hv_nmos[factuo]
print @n.xbgr.xm35_u4.nsg13_hv_nmos[w]
print @n.xbgr.xm35_u4.nsg13_hv_nmos[l]
print @n.xbgr.xm35_u4.nsg13_hv_nmos[delvto]
print @n.xbgr.xm35_u4.nsg13_hv_nmos[factuo]
print @n.xbgr.xm35_u5.nsg13_hv_nmos[w]
print @n.xbgr.xm35_u5.nsg13_hv_nmos[l]
print @n.xbgr.xm35_u5.nsg13_hv_nmos[delvto]
print @n.xbgr.xm35_u5.nsg13_hv_nmos[factuo]
print @n.xbgr.xm35_u6.nsg13_hv_nmos[w]
print @n.xbgr.xm35_u6.nsg13_hv_nmos[l]
print @n.xbgr.xm35_u6.nsg13_hv_nmos[delvto]
print @n.xbgr.xm35_u6.nsg13_hv_nmos[factuo]
print @n.xbgr.xm35_u7.nsg13_hv_nmos[w]
print @n.xbgr.xm35_u7.nsg13_hv_nmos[l]
print @n.xbgr.xm35_u7.nsg13_hv_nmos[delvto]
print @n.xbgr.xm35_u7.nsg13_hv_nmos[factuo]
print @n.xbgr.xm35_u8.nsg13_hv_nmos[w]
print @n.xbgr.xm35_u8.nsg13_hv_nmos[l]
print @n.xbgr.xm35_u8.nsg13_hv_nmos[delvto]
print @n.xbgr.xm35_u8.nsg13_hv_nmos[factuo]
print @n.xbgr.xm35_u9.nsg13_hv_nmos[w]
print @n.xbgr.xm35_u9.nsg13_hv_nmos[l]
print @n.xbgr.xm35_u9.nsg13_hv_nmos[delvto]
print @n.xbgr.xm35_u9.nsg13_hv_nmos[factuo]
print @n.xbgr.xm35_u10.nsg13_hv_nmos[w]
print @n.xbgr.xm35_u10.nsg13_hv_nmos[l]
print @n.xbgr.xm35_u10.nsg13_hv_nmos[delvto]
print @n.xbgr.xm35_u10.nsg13_hv_nmos[factuo]
print @n.xbgr.xm35_u11.nsg13_hv_nmos[w]
print @n.xbgr.xm35_u11.nsg13_hv_nmos[l]
print @n.xbgr.xm35_u11.nsg13_hv_nmos[delvto]
print @n.xbgr.xm35_u11.nsg13_hv_nmos[factuo]
print @n.xbgr.xm35_u12.nsg13_hv_nmos[w]
print @n.xbgr.xm35_u12.nsg13_hv_nmos[l]
print @n.xbgr.xm35_u12.nsg13_hv_nmos[delvto]
print @n.xbgr.xm35_u12.nsg13_hv_nmos[factuo]
print @n.xbgr.xm35_u13.nsg13_hv_nmos[w]
print @n.xbgr.xm35_u13.nsg13_hv_nmos[l]
print @n.xbgr.xm35_u13.nsg13_hv_nmos[delvto]
print @n.xbgr.xm35_u13.nsg13_hv_nmos[factuo]
print @n.xbgr.xm35_u14.nsg13_hv_nmos[w]
print @n.xbgr.xm35_u14.nsg13_hv_nmos[l]
print @n.xbgr.xm35_u14.nsg13_hv_nmos[delvto]
print @n.xbgr.xm35_u14.nsg13_hv_nmos[factuo]
print @n.xbgr.xm35_u15.nsg13_hv_nmos[w]
print @n.xbgr.xm35_u15.nsg13_hv_nmos[l]
print @n.xbgr.xm35_u15.nsg13_hv_nmos[delvto]
print @n.xbgr.xm35_u15.nsg13_hv_nmos[factuo]
print @n.xbgr.xm35_u16.nsg13_hv_nmos[w]
print @n.xbgr.xm35_u16.nsg13_hv_nmos[l]
print @n.xbgr.xm35_u16.nsg13_hv_nmos[delvto]
print @n.xbgr.xm35_u16.nsg13_hv_nmos[factuo]
print @n.xbgr.xm35_u17.nsg13_hv_nmos[w]
print @n.xbgr.xm35_u17.nsg13_hv_nmos[l]
print @n.xbgr.xm35_u17.nsg13_hv_nmos[delvto]
print @n.xbgr.xm35_u17.nsg13_hv_nmos[factuo]
print @n.xbgr.xm35_u18.nsg13_hv_nmos[w]
print @n.xbgr.xm35_u18.nsg13_hv_nmos[l]
print @n.xbgr.xm35_u18.nsg13_hv_nmos[delvto]
print @n.xbgr.xm35_u18.nsg13_hv_nmos[factuo]
print @n.xbgr.xm35_u19.nsg13_hv_nmos[w]
print @n.xbgr.xm35_u19.nsg13_hv_nmos[l]
print @n.xbgr.xm35_u19.nsg13_hv_nmos[delvto]
print @n.xbgr.xm35_u19.nsg13_hv_nmos[factuo]
print @n.xbgr.xm35_u20.nsg13_hv_nmos[w]
print @n.xbgr.xm35_u20.nsg13_hv_nmos[l]
print @n.xbgr.xm35_u20.nsg13_hv_nmos[delvto]
print @n.xbgr.xm35_u20.nsg13_hv_nmos[factuo]
print @n.xbgr.xm35_u21.nsg13_hv_nmos[w]
print @n.xbgr.xm35_u21.nsg13_hv_nmos[l]
print @n.xbgr.xm35_u21.nsg13_hv_nmos[delvto]
print @n.xbgr.xm35_u21.nsg13_hv_nmos[factuo]
print @n.xbgr.xm35_u22.nsg13_hv_nmos[w]
print @n.xbgr.xm35_u22.nsg13_hv_nmos[l]
print @n.xbgr.xm35_u22.nsg13_hv_nmos[delvto]
print @n.xbgr.xm35_u22.nsg13_hv_nmos[factuo]
print @n.xbgr.xm35_u23.nsg13_hv_nmos[w]
print @n.xbgr.xm35_u23.nsg13_hv_nmos[l]
print @n.xbgr.xm35_u23.nsg13_hv_nmos[delvto]
print @n.xbgr.xm35_u23.nsg13_hv_nmos[factuo]
print @n.xbgr.xm35_u24.nsg13_hv_nmos[w]
print @n.xbgr.xm35_u24.nsg13_hv_nmos[l]
print @n.xbgr.xm35_u24.nsg13_hv_nmos[delvto]
print @n.xbgr.xm35_u24.nsg13_hv_nmos[factuo]
print @n.xbgr.xm36_u2.nsg13_hv_nmos[w]
print @n.xbgr.xm36_u2.nsg13_hv_nmos[l]
print @n.xbgr.xm36_u2.nsg13_hv_nmos[delvto]
print @n.xbgr.xm36_u2.nsg13_hv_nmos[factuo]
print @n.xbgr.xm36_u3.nsg13_hv_nmos[w]
print @n.xbgr.xm36_u3.nsg13_hv_nmos[l]
print @n.xbgr.xm36_u3.nsg13_hv_nmos[delvto]
print @n.xbgr.xm36_u3.nsg13_hv_nmos[factuo]
print @n.xbgr.xm36_u4.nsg13_hv_nmos[w]
print @n.xbgr.xm36_u4.nsg13_hv_nmos[l]
print @n.xbgr.xm36_u4.nsg13_hv_nmos[delvto]
print @n.xbgr.xm36_u4.nsg13_hv_nmos[factuo]
print @n.xbgr.xm36_u5.nsg13_hv_nmos[w]
print @n.xbgr.xm36_u5.nsg13_hv_nmos[l]
print @n.xbgr.xm36_u5.nsg13_hv_nmos[delvto]
print @n.xbgr.xm36_u5.nsg13_hv_nmos[factuo]
print @n.xbgr.xm36_u6.nsg13_hv_nmos[w]
print @n.xbgr.xm36_u6.nsg13_hv_nmos[l]
print @n.xbgr.xm36_u6.nsg13_hv_nmos[delvto]
print @n.xbgr.xm36_u6.nsg13_hv_nmos[factuo]
print @n.xbgr.xm36_u7.nsg13_hv_nmos[w]
print @n.xbgr.xm36_u7.nsg13_hv_nmos[l]
print @n.xbgr.xm36_u7.nsg13_hv_nmos[delvto]
print @n.xbgr.xm36_u7.nsg13_hv_nmos[factuo]
print @n.xbgr.xm36_u8.nsg13_hv_nmos[w]
print @n.xbgr.xm36_u8.nsg13_hv_nmos[l]
print @n.xbgr.xm36_u8.nsg13_hv_nmos[delvto]
print @n.xbgr.xm36_u8.nsg13_hv_nmos[factuo]
print @n.xbgr.xm36_u9.nsg13_hv_nmos[w]
print @n.xbgr.xm36_u9.nsg13_hv_nmos[l]
print @n.xbgr.xm36_u9.nsg13_hv_nmos[delvto]
print @n.xbgr.xm36_u9.nsg13_hv_nmos[factuo]
print @n.xbgr.xm36_u10.nsg13_hv_nmos[w]
print @n.xbgr.xm36_u10.nsg13_hv_nmos[l]
print @n.xbgr.xm36_u10.nsg13_hv_nmos[delvto]
print @n.xbgr.xm36_u10.nsg13_hv_nmos[factuo]
print @n.xbgr.xm36_u11.nsg13_hv_nmos[w]
print @n.xbgr.xm36_u11.nsg13_hv_nmos[l]
print @n.xbgr.xm36_u11.nsg13_hv_nmos[delvto]
print @n.xbgr.xm36_u11.nsg13_hv_nmos[factuo]
print @n.xbgr.xm36_u12.nsg13_hv_nmos[w]
print @n.xbgr.xm36_u12.nsg13_hv_nmos[l]
print @n.xbgr.xm36_u12.nsg13_hv_nmos[delvto]
print @n.xbgr.xm36_u12.nsg13_hv_nmos[factuo]
print @n.xbgr.xm36_u13.nsg13_hv_nmos[w]
print @n.xbgr.xm36_u13.nsg13_hv_nmos[l]
print @n.xbgr.xm36_u13.nsg13_hv_nmos[delvto]
print @n.xbgr.xm36_u13.nsg13_hv_nmos[factuo]
print @n.xbgr.xm36_u14.nsg13_hv_nmos[w]
print @n.xbgr.xm36_u14.nsg13_hv_nmos[l]
print @n.xbgr.xm36_u14.nsg13_hv_nmos[delvto]
print @n.xbgr.xm36_u14.nsg13_hv_nmos[factuo]
print @n.xbgr.xm36_u15.nsg13_hv_nmos[w]
print @n.xbgr.xm36_u15.nsg13_hv_nmos[l]
print @n.xbgr.xm36_u15.nsg13_hv_nmos[delvto]
print @n.xbgr.xm36_u15.nsg13_hv_nmos[factuo]
print @n.xbgr.xm36_u16.nsg13_hv_nmos[w]
print @n.xbgr.xm36_u16.nsg13_hv_nmos[l]
print @n.xbgr.xm36_u16.nsg13_hv_nmos[delvto]
print @n.xbgr.xm36_u16.nsg13_hv_nmos[factuo]
print @n.xbgr.xm36_u17.nsg13_hv_nmos[w]
print @n.xbgr.xm36_u17.nsg13_hv_nmos[l]
print @n.xbgr.xm36_u17.nsg13_hv_nmos[delvto]
print @n.xbgr.xm36_u17.nsg13_hv_nmos[factuo]
print @n.xbgr.xm36_u18.nsg13_hv_nmos[w]
print @n.xbgr.xm36_u18.nsg13_hv_nmos[l]
print @n.xbgr.xm36_u18.nsg13_hv_nmos[delvto]
print @n.xbgr.xm36_u18.nsg13_hv_nmos[factuo]
print @n.xbgr.xm36_u19.nsg13_hv_nmos[w]
print @n.xbgr.xm36_u19.nsg13_hv_nmos[l]
print @n.xbgr.xm36_u19.nsg13_hv_nmos[delvto]
print @n.xbgr.xm36_u19.nsg13_hv_nmos[factuo]
print @n.xbgr.xm36_u20.nsg13_hv_nmos[w]
print @n.xbgr.xm36_u20.nsg13_hv_nmos[l]
print @n.xbgr.xm36_u20.nsg13_hv_nmos[delvto]
print @n.xbgr.xm36_u20.nsg13_hv_nmos[factuo]
print @n.xbgr.xm36_u21.nsg13_hv_nmos[w]
print @n.xbgr.xm36_u21.nsg13_hv_nmos[l]
print @n.xbgr.xm36_u21.nsg13_hv_nmos[delvto]
print @n.xbgr.xm36_u21.nsg13_hv_nmos[factuo]
print @n.xbgr.xm36_u22.nsg13_hv_nmos[w]
print @n.xbgr.xm36_u22.nsg13_hv_nmos[l]
print @n.xbgr.xm36_u22.nsg13_hv_nmos[delvto]
print @n.xbgr.xm36_u22.nsg13_hv_nmos[factuo]
print @n.xbgr.xm36_u23.nsg13_hv_nmos[w]
print @n.xbgr.xm36_u23.nsg13_hv_nmos[l]
print @n.xbgr.xm36_u23.nsg13_hv_nmos[delvto]
print @n.xbgr.xm36_u23.nsg13_hv_nmos[factuo]
print @n.xbgr.xm36_u24.nsg13_hv_nmos[w]
print @n.xbgr.xm36_u24.nsg13_hv_nmos[l]
print @n.xbgr.xm36_u24.nsg13_hv_nmos[delvto]
print @n.xbgr.xm36_u24.nsg13_hv_nmos[factuo]
print @n.xbgr.xm37_u2.nsg13_hv_nmos[w]
print @n.xbgr.xm37_u2.nsg13_hv_nmos[l]
print @n.xbgr.xm37_u2.nsg13_hv_nmos[delvto]
print @n.xbgr.xm37_u2.nsg13_hv_nmos[factuo]
print @n.xbgr.xm37_u3.nsg13_hv_nmos[w]
print @n.xbgr.xm37_u3.nsg13_hv_nmos[l]
print @n.xbgr.xm37_u3.nsg13_hv_nmos[delvto]
print @n.xbgr.xm37_u3.nsg13_hv_nmos[factuo]
print @n.xbgr.xm37_u4.nsg13_hv_nmos[w]
print @n.xbgr.xm37_u4.nsg13_hv_nmos[l]
print @n.xbgr.xm37_u4.nsg13_hv_nmos[delvto]
print @n.xbgr.xm37_u4.nsg13_hv_nmos[factuo]
print @n.xbgr.xm37_u5.nsg13_hv_nmos[w]
print @n.xbgr.xm37_u5.nsg13_hv_nmos[l]
print @n.xbgr.xm37_u5.nsg13_hv_nmos[delvto]
print @n.xbgr.xm37_u5.nsg13_hv_nmos[factuo]
print @n.xbgr.xm37_u6.nsg13_hv_nmos[w]
print @n.xbgr.xm37_u6.nsg13_hv_nmos[l]
print @n.xbgr.xm37_u6.nsg13_hv_nmos[delvto]
print @n.xbgr.xm37_u6.nsg13_hv_nmos[factuo]
print @n.xbgr.xm37_u7.nsg13_hv_nmos[w]
print @n.xbgr.xm37_u7.nsg13_hv_nmos[l]
print @n.xbgr.xm37_u7.nsg13_hv_nmos[delvto]
print @n.xbgr.xm37_u7.nsg13_hv_nmos[factuo]
print @n.xbgr.xm37_u8.nsg13_hv_nmos[w]
print @n.xbgr.xm37_u8.nsg13_hv_nmos[l]
print @n.xbgr.xm37_u8.nsg13_hv_nmos[delvto]
print @n.xbgr.xm37_u8.nsg13_hv_nmos[factuo]
print @n.xbgr.xm37_u9.nsg13_hv_nmos[w]
print @n.xbgr.xm37_u9.nsg13_hv_nmos[l]
print @n.xbgr.xm37_u9.nsg13_hv_nmos[delvto]
print @n.xbgr.xm37_u9.nsg13_hv_nmos[factuo]
print @n.xbgr.xm37_u10.nsg13_hv_nmos[w]
print @n.xbgr.xm37_u10.nsg13_hv_nmos[l]
print @n.xbgr.xm37_u10.nsg13_hv_nmos[delvto]
print @n.xbgr.xm37_u10.nsg13_hv_nmos[factuo]
print @n.xbgr.xm37_u11.nsg13_hv_nmos[w]
print @n.xbgr.xm37_u11.nsg13_hv_nmos[l]
print @n.xbgr.xm37_u11.nsg13_hv_nmos[delvto]
print @n.xbgr.xm37_u11.nsg13_hv_nmos[factuo]
print @n.xbgr.xm37_u12.nsg13_hv_nmos[w]
print @n.xbgr.xm37_u12.nsg13_hv_nmos[l]
print @n.xbgr.xm37_u12.nsg13_hv_nmos[delvto]
print @n.xbgr.xm37_u12.nsg13_hv_nmos[factuo]
print @n.xbgr.xm37_u13.nsg13_hv_nmos[w]
print @n.xbgr.xm37_u13.nsg13_hv_nmos[l]
print @n.xbgr.xm37_u13.nsg13_hv_nmos[delvto]
print @n.xbgr.xm37_u13.nsg13_hv_nmos[factuo]
print @n.xbgr.xm37_u14.nsg13_hv_nmos[w]
print @n.xbgr.xm37_u14.nsg13_hv_nmos[l]
print @n.xbgr.xm37_u14.nsg13_hv_nmos[delvto]
print @n.xbgr.xm37_u14.nsg13_hv_nmos[factuo]
print @n.xbgr.xm37_u15.nsg13_hv_nmos[w]
print @n.xbgr.xm37_u15.nsg13_hv_nmos[l]
print @n.xbgr.xm37_u15.nsg13_hv_nmos[delvto]
print @n.xbgr.xm37_u15.nsg13_hv_nmos[factuo]
print @n.xbgr.xm37_u16.nsg13_hv_nmos[w]
print @n.xbgr.xm37_u16.nsg13_hv_nmos[l]
print @n.xbgr.xm37_u16.nsg13_hv_nmos[delvto]
print @n.xbgr.xm37_u16.nsg13_hv_nmos[factuo]
print @n.xbgr.xm37_u17.nsg13_hv_nmos[w]
print @n.xbgr.xm37_u17.nsg13_hv_nmos[l]
print @n.xbgr.xm37_u17.nsg13_hv_nmos[delvto]
print @n.xbgr.xm37_u17.nsg13_hv_nmos[factuo]
print @n.xbgr.xm37_u18.nsg13_hv_nmos[w]
print @n.xbgr.xm37_u18.nsg13_hv_nmos[l]
print @n.xbgr.xm37_u18.nsg13_hv_nmos[delvto]
print @n.xbgr.xm37_u18.nsg13_hv_nmos[factuo]
print @n.xbgr.xm37_u19.nsg13_hv_nmos[w]
print @n.xbgr.xm37_u19.nsg13_hv_nmos[l]
print @n.xbgr.xm37_u19.nsg13_hv_nmos[delvto]
print @n.xbgr.xm37_u19.nsg13_hv_nmos[factuo]
print @n.xbgr.xm37_u20.nsg13_hv_nmos[w]
print @n.xbgr.xm37_u20.nsg13_hv_nmos[l]
print @n.xbgr.xm37_u20.nsg13_hv_nmos[delvto]
print @n.xbgr.xm37_u20.nsg13_hv_nmos[factuo]
print @n.xbgr.xm37_u21.nsg13_hv_nmos[w]
print @n.xbgr.xm37_u21.nsg13_hv_nmos[l]
print @n.xbgr.xm37_u21.nsg13_hv_nmos[delvto]
print @n.xbgr.xm37_u21.nsg13_hv_nmos[factuo]
print @n.xbgr.xm37_u22.nsg13_hv_nmos[w]
print @n.xbgr.xm37_u22.nsg13_hv_nmos[l]
print @n.xbgr.xm37_u22.nsg13_hv_nmos[delvto]
print @n.xbgr.xm37_u22.nsg13_hv_nmos[factuo]
print @n.xbgr.xm37_u23.nsg13_hv_nmos[w]
print @n.xbgr.xm37_u23.nsg13_hv_nmos[l]
print @n.xbgr.xm37_u23.nsg13_hv_nmos[delvto]
print @n.xbgr.xm37_u23.nsg13_hv_nmos[factuo]
print @n.xbgr.xm37_u24.nsg13_hv_nmos[w]
print @n.xbgr.xm37_u24.nsg13_hv_nmos[l]
print @n.xbgr.xm37_u24.nsg13_hv_nmos[delvto]
print @n.xbgr.xm37_u24.nsg13_hv_nmos[factuo]
print @n.xbgr.xm38_u2.nsg13_hv_pmos[w]
print @n.xbgr.xm38_u2.nsg13_hv_pmos[l]
print @n.xbgr.xm38_u2.nsg13_hv_pmos[delvto]
print @n.xbgr.xm38_u2.nsg13_hv_pmos[factuo]
print @n.xbgr.xm38_u3.nsg13_hv_pmos[w]
print @n.xbgr.xm38_u3.nsg13_hv_pmos[l]
print @n.xbgr.xm38_u3.nsg13_hv_pmos[delvto]
print @n.xbgr.xm38_u3.nsg13_hv_pmos[factuo]
print @n.xbgr.xm38_u4.nsg13_hv_pmos[w]
print @n.xbgr.xm38_u4.nsg13_hv_pmos[l]
print @n.xbgr.xm38_u4.nsg13_hv_pmos[delvto]
print @n.xbgr.xm38_u4.nsg13_hv_pmos[factuo]
print @n.xbgr.xm38_u5.nsg13_hv_pmos[w]
print @n.xbgr.xm38_u5.nsg13_hv_pmos[l]
print @n.xbgr.xm38_u5.nsg13_hv_pmos[delvto]
print @n.xbgr.xm38_u5.nsg13_hv_pmos[factuo]
print @n.xbgr.xm38_u6.nsg13_hv_pmos[w]
print @n.xbgr.xm38_u6.nsg13_hv_pmos[l]
print @n.xbgr.xm38_u6.nsg13_hv_pmos[delvto]
print @n.xbgr.xm38_u6.nsg13_hv_pmos[factuo]
print @n.xbgr.xm38_u7.nsg13_hv_pmos[w]
print @n.xbgr.xm38_u7.nsg13_hv_pmos[l]
print @n.xbgr.xm38_u7.nsg13_hv_pmos[delvto]
print @n.xbgr.xm38_u7.nsg13_hv_pmos[factuo]
print @n.xbgr.xm38_u8.nsg13_hv_pmos[w]
print @n.xbgr.xm38_u8.nsg13_hv_pmos[l]
print @n.xbgr.xm38_u8.nsg13_hv_pmos[delvto]
print @n.xbgr.xm38_u8.nsg13_hv_pmos[factuo]
print @n.xbgr.xm38_u9.nsg13_hv_pmos[w]
print @n.xbgr.xm38_u9.nsg13_hv_pmos[l]
print @n.xbgr.xm38_u9.nsg13_hv_pmos[delvto]
print @n.xbgr.xm38_u9.nsg13_hv_pmos[factuo]
print @n.xbgr.xm38_u10.nsg13_hv_pmos[w]
print @n.xbgr.xm38_u10.nsg13_hv_pmos[l]
print @n.xbgr.xm38_u10.nsg13_hv_pmos[delvto]
print @n.xbgr.xm38_u10.nsg13_hv_pmos[factuo]
print @n.xbgr.xm38_u11.nsg13_hv_pmos[w]
print @n.xbgr.xm38_u11.nsg13_hv_pmos[l]
print @n.xbgr.xm38_u11.nsg13_hv_pmos[delvto]
print @n.xbgr.xm38_u11.nsg13_hv_pmos[factuo]
print @n.xbgr.xm38_u12.nsg13_hv_pmos[w]
print @n.xbgr.xm38_u12.nsg13_hv_pmos[l]
print @n.xbgr.xm38_u12.nsg13_hv_pmos[delvto]
print @n.xbgr.xm38_u12.nsg13_hv_pmos[factuo]
print @n.xbgr.xm38_u13.nsg13_hv_pmos[w]
print @n.xbgr.xm38_u13.nsg13_hv_pmos[l]
print @n.xbgr.xm38_u13.nsg13_hv_pmos[delvto]
print @n.xbgr.xm38_u13.nsg13_hv_pmos[factuo]
print @n.xbgr.xm38_u14.nsg13_hv_pmos[w]
print @n.xbgr.xm38_u14.nsg13_hv_pmos[l]
print @n.xbgr.xm38_u14.nsg13_hv_pmos[delvto]
print @n.xbgr.xm38_u14.nsg13_hv_pmos[factuo]
print @n.xbgr.xm38_u15.nsg13_hv_pmos[w]
print @n.xbgr.xm38_u15.nsg13_hv_pmos[l]
print @n.xbgr.xm38_u15.nsg13_hv_pmos[delvto]
print @n.xbgr.xm38_u15.nsg13_hv_pmos[factuo]
print @n.xbgr.xm38_u16.nsg13_hv_pmos[w]
print @n.xbgr.xm38_u16.nsg13_hv_pmos[l]
print @n.xbgr.xm38_u16.nsg13_hv_pmos[delvto]
print @n.xbgr.xm38_u16.nsg13_hv_pmos[factuo]
print @n.xbgr.xm38_u17.nsg13_hv_pmos[w]
print @n.xbgr.xm38_u17.nsg13_hv_pmos[l]
print @n.xbgr.xm38_u17.nsg13_hv_pmos[delvto]
print @n.xbgr.xm38_u17.nsg13_hv_pmos[factuo]
print @n.xbgr.xm38_u18.nsg13_hv_pmos[w]
print @n.xbgr.xm38_u18.nsg13_hv_pmos[l]
print @n.xbgr.xm38_u18.nsg13_hv_pmos[delvto]
print @n.xbgr.xm38_u18.nsg13_hv_pmos[factuo]
print @n.xbgr.xm38_u19.nsg13_hv_pmos[w]
print @n.xbgr.xm38_u19.nsg13_hv_pmos[l]
print @n.xbgr.xm38_u19.nsg13_hv_pmos[delvto]
print @n.xbgr.xm38_u19.nsg13_hv_pmos[factuo]
print @n.xbgr.xm38_u20.nsg13_hv_pmos[w]
print @n.xbgr.xm38_u20.nsg13_hv_pmos[l]
print @n.xbgr.xm38_u20.nsg13_hv_pmos[delvto]
print @n.xbgr.xm38_u20.nsg13_hv_pmos[factuo]
print @n.xbgr.xm38_u21.nsg13_hv_pmos[w]
print @n.xbgr.xm38_u21.nsg13_hv_pmos[l]
print @n.xbgr.xm38_u21.nsg13_hv_pmos[delvto]
print @n.xbgr.xm38_u21.nsg13_hv_pmos[factuo]
print @n.xbgr.xm38_u22.nsg13_hv_pmos[w]
print @n.xbgr.xm38_u22.nsg13_hv_pmos[l]
print @n.xbgr.xm38_u22.nsg13_hv_pmos[delvto]
print @n.xbgr.xm38_u22.nsg13_hv_pmos[factuo]
print @n.xbgr.xm38_u23.nsg13_hv_pmos[w]
print @n.xbgr.xm38_u23.nsg13_hv_pmos[l]
print @n.xbgr.xm38_u23.nsg13_hv_pmos[delvto]
print @n.xbgr.xm38_u23.nsg13_hv_pmos[factuo]
print @n.xbgr.xm38_u24.nsg13_hv_pmos[w]
print @n.xbgr.xm38_u24.nsg13_hv_pmos[l]
print @n.xbgr.xm38_u24.nsg13_hv_pmos[delvto]
print @n.xbgr.xm38_u24.nsg13_hv_pmos[factuo]
print @n.xbgr.xm39_u2.nsg13_hv_pmos[w]
print @n.xbgr.xm39_u2.nsg13_hv_pmos[l]
print @n.xbgr.xm39_u2.nsg13_hv_pmos[delvto]
print @n.xbgr.xm39_u2.nsg13_hv_pmos[factuo]
print @n.xbgr.xm39_u3.nsg13_hv_pmos[w]
print @n.xbgr.xm39_u3.nsg13_hv_pmos[l]
print @n.xbgr.xm39_u3.nsg13_hv_pmos[delvto]
print @n.xbgr.xm39_u3.nsg13_hv_pmos[factuo]
print @n.xbgr.xm39_u4.nsg13_hv_pmos[w]
print @n.xbgr.xm39_u4.nsg13_hv_pmos[l]
print @n.xbgr.xm39_u4.nsg13_hv_pmos[delvto]
print @n.xbgr.xm39_u4.nsg13_hv_pmos[factuo]
print @n.xbgr.xm39_u5.nsg13_hv_pmos[w]
print @n.xbgr.xm39_u5.nsg13_hv_pmos[l]
print @n.xbgr.xm39_u5.nsg13_hv_pmos[delvto]
print @n.xbgr.xm39_u5.nsg13_hv_pmos[factuo]
print @n.xbgr.xm39_u6.nsg13_hv_pmos[w]
print @n.xbgr.xm39_u6.nsg13_hv_pmos[l]
print @n.xbgr.xm39_u6.nsg13_hv_pmos[delvto]
print @n.xbgr.xm39_u6.nsg13_hv_pmos[factuo]
print @n.xbgr.xm39_u7.nsg13_hv_pmos[w]
print @n.xbgr.xm39_u7.nsg13_hv_pmos[l]
print @n.xbgr.xm39_u7.nsg13_hv_pmos[delvto]
print @n.xbgr.xm39_u7.nsg13_hv_pmos[factuo]
print @n.xbgr.xm39_u8.nsg13_hv_pmos[w]
print @n.xbgr.xm39_u8.nsg13_hv_pmos[l]
print @n.xbgr.xm39_u8.nsg13_hv_pmos[delvto]
print @n.xbgr.xm39_u8.nsg13_hv_pmos[factuo]
print @n.xbgr.xm39_u9.nsg13_hv_pmos[w]
print @n.xbgr.xm39_u9.nsg13_hv_pmos[l]
print @n.xbgr.xm39_u9.nsg13_hv_pmos[delvto]
print @n.xbgr.xm39_u9.nsg13_hv_pmos[factuo]
print @n.xbgr.xm39_u10.nsg13_hv_pmos[w]
print @n.xbgr.xm39_u10.nsg13_hv_pmos[l]
print @n.xbgr.xm39_u10.nsg13_hv_pmos[delvto]
print @n.xbgr.xm39_u10.nsg13_hv_pmos[factuo]
print @n.xbgr.xm39_u11.nsg13_hv_pmos[w]
print @n.xbgr.xm39_u11.nsg13_hv_pmos[l]
print @n.xbgr.xm39_u11.nsg13_hv_pmos[delvto]
print @n.xbgr.xm39_u11.nsg13_hv_pmos[factuo]
print @n.xbgr.xm39_u12.nsg13_hv_pmos[w]
print @n.xbgr.xm39_u12.nsg13_hv_pmos[l]
print @n.xbgr.xm39_u12.nsg13_hv_pmos[delvto]
print @n.xbgr.xm39_u12.nsg13_hv_pmos[factuo]
print @n.xbgr.xm39_u13.nsg13_hv_pmos[w]
print @n.xbgr.xm39_u13.nsg13_hv_pmos[l]
print @n.xbgr.xm39_u13.nsg13_hv_pmos[delvto]
print @n.xbgr.xm39_u13.nsg13_hv_pmos[factuo]
print @n.xbgr.xm39_u14.nsg13_hv_pmos[w]
print @n.xbgr.xm39_u14.nsg13_hv_pmos[l]
print @n.xbgr.xm39_u14.nsg13_hv_pmos[delvto]
print @n.xbgr.xm39_u14.nsg13_hv_pmos[factuo]
print @n.xbgr.xm39_u15.nsg13_hv_pmos[w]
print @n.xbgr.xm39_u15.nsg13_hv_pmos[l]
print @n.xbgr.xm39_u15.nsg13_hv_pmos[delvto]
print @n.xbgr.xm39_u15.nsg13_hv_pmos[factuo]
print @n.xbgr.xm39_u16.nsg13_hv_pmos[w]
print @n.xbgr.xm39_u16.nsg13_hv_pmos[l]
print @n.xbgr.xm39_u16.nsg13_hv_pmos[delvto]
print @n.xbgr.xm39_u16.nsg13_hv_pmos[factuo]
print @n.xbgr.xm39_u17.nsg13_hv_pmos[w]
print @n.xbgr.xm39_u17.nsg13_hv_pmos[l]
print @n.xbgr.xm39_u17.nsg13_hv_pmos[delvto]
print @n.xbgr.xm39_u17.nsg13_hv_pmos[factuo]
print @n.xbgr.xm39_u18.nsg13_hv_pmos[w]
print @n.xbgr.xm39_u18.nsg13_hv_pmos[l]
print @n.xbgr.xm39_u18.nsg13_hv_pmos[delvto]
print @n.xbgr.xm39_u18.nsg13_hv_pmos[factuo]
print @n.xbgr.xm39_u19.nsg13_hv_pmos[w]
print @n.xbgr.xm39_u19.nsg13_hv_pmos[l]
print @n.xbgr.xm39_u19.nsg13_hv_pmos[delvto]
print @n.xbgr.xm39_u19.nsg13_hv_pmos[factuo]
print @n.xbgr.xm39_u20.nsg13_hv_pmos[w]
print @n.xbgr.xm39_u20.nsg13_hv_pmos[l]
print @n.xbgr.xm39_u20.nsg13_hv_pmos[delvto]
print @n.xbgr.xm39_u20.nsg13_hv_pmos[factuo]
print @n.xbgr.xm39_u21.nsg13_hv_pmos[w]
print @n.xbgr.xm39_u21.nsg13_hv_pmos[l]
print @n.xbgr.xm39_u21.nsg13_hv_pmos[delvto]
print @n.xbgr.xm39_u21.nsg13_hv_pmos[factuo]
print @n.xbgr.xm39_u22.nsg13_hv_pmos[w]
print @n.xbgr.xm39_u22.nsg13_hv_pmos[l]
print @n.xbgr.xm39_u22.nsg13_hv_pmos[delvto]
print @n.xbgr.xm39_u22.nsg13_hv_pmos[factuo]
print @n.xbgr.xm39_u23.nsg13_hv_pmos[w]
print @n.xbgr.xm39_u23.nsg13_hv_pmos[l]
print @n.xbgr.xm39_u23.nsg13_hv_pmos[delvto]
print @n.xbgr.xm39_u23.nsg13_hv_pmos[factuo]
print @n.xbgr.xm39_u24.nsg13_hv_pmos[w]
print @n.xbgr.xm39_u24.nsg13_hv_pmos[l]
print @n.xbgr.xm39_u24.nsg13_hv_pmos[delvto]
print @n.xbgr.xm39_u24.nsg13_hv_pmos[factuo]
print @n.xbgr.xm41_u2.nsg13_hv_pmos[w]
print @n.xbgr.xm41_u2.nsg13_hv_pmos[l]
print @n.xbgr.xm41_u2.nsg13_hv_pmos[delvto]
print @n.xbgr.xm41_u2.nsg13_hv_pmos[factuo]
print @n.xbgr.xm41_u3.nsg13_hv_pmos[w]
print @n.xbgr.xm41_u3.nsg13_hv_pmos[l]
print @n.xbgr.xm41_u3.nsg13_hv_pmos[delvto]
print @n.xbgr.xm41_u3.nsg13_hv_pmos[factuo]
print @n.xbgr.xm41_u4.nsg13_hv_pmos[w]
print @n.xbgr.xm41_u4.nsg13_hv_pmos[l]
print @n.xbgr.xm41_u4.nsg13_hv_pmos[delvto]
print @n.xbgr.xm41_u4.nsg13_hv_pmos[factuo]
print @n.xbgr.xm41_u5.nsg13_hv_pmos[w]
print @n.xbgr.xm41_u5.nsg13_hv_pmos[l]
print @n.xbgr.xm41_u5.nsg13_hv_pmos[delvto]
print @n.xbgr.xm41_u5.nsg13_hv_pmos[factuo]
print @n.xbgr.xm41_u6.nsg13_hv_pmos[w]
print @n.xbgr.xm41_u6.nsg13_hv_pmos[l]
print @n.xbgr.xm41_u6.nsg13_hv_pmos[delvto]
print @n.xbgr.xm41_u6.nsg13_hv_pmos[factuo]
print @n.xbgr.xm41_u7.nsg13_hv_pmos[w]
print @n.xbgr.xm41_u7.nsg13_hv_pmos[l]
print @n.xbgr.xm41_u7.nsg13_hv_pmos[delvto]
print @n.xbgr.xm41_u7.nsg13_hv_pmos[factuo]
print @n.xbgr.xm41_u8.nsg13_hv_pmos[w]
print @n.xbgr.xm41_u8.nsg13_hv_pmos[l]
print @n.xbgr.xm41_u8.nsg13_hv_pmos[delvto]
print @n.xbgr.xm41_u8.nsg13_hv_pmos[factuo]
print @n.xbgr.xm41_u9.nsg13_hv_pmos[w]
print @n.xbgr.xm41_u9.nsg13_hv_pmos[l]
print @n.xbgr.xm41_u9.nsg13_hv_pmos[delvto]
print @n.xbgr.xm41_u9.nsg13_hv_pmos[factuo]
print @n.xbgr.xm41_u10.nsg13_hv_pmos[w]
print @n.xbgr.xm41_u10.nsg13_hv_pmos[l]
print @n.xbgr.xm41_u10.nsg13_hv_pmos[delvto]
print @n.xbgr.xm41_u10.nsg13_hv_pmos[factuo]
print @n.xbgr.xm41_u11.nsg13_hv_pmos[w]
print @n.xbgr.xm41_u11.nsg13_hv_pmos[l]
print @n.xbgr.xm41_u11.nsg13_hv_pmos[delvto]
print @n.xbgr.xm41_u11.nsg13_hv_pmos[factuo]
print @n.xbgr.xm41_u12.nsg13_hv_pmos[w]
print @n.xbgr.xm41_u12.nsg13_hv_pmos[l]
print @n.xbgr.xm41_u12.nsg13_hv_pmos[delvto]
print @n.xbgr.xm41_u12.nsg13_hv_pmos[factuo]
print @n.xbgr.xm41_u13.nsg13_hv_pmos[w]
print @n.xbgr.xm41_u13.nsg13_hv_pmos[l]
print @n.xbgr.xm41_u13.nsg13_hv_pmos[delvto]
print @n.xbgr.xm41_u13.nsg13_hv_pmos[factuo]
print @n.xbgr.xm41_u14.nsg13_hv_pmos[w]
print @n.xbgr.xm41_u14.nsg13_hv_pmos[l]
print @n.xbgr.xm41_u14.nsg13_hv_pmos[delvto]
print @n.xbgr.xm41_u14.nsg13_hv_pmos[factuo]
print @n.xbgr.xm41_u15.nsg13_hv_pmos[w]
print @n.xbgr.xm41_u15.nsg13_hv_pmos[l]
print @n.xbgr.xm41_u15.nsg13_hv_pmos[delvto]
print @n.xbgr.xm41_u15.nsg13_hv_pmos[factuo]
print @n.xbgr.xm41_u16.nsg13_hv_pmos[w]
print @n.xbgr.xm41_u16.nsg13_hv_pmos[l]
print @n.xbgr.xm41_u16.nsg13_hv_pmos[delvto]
print @n.xbgr.xm41_u16.nsg13_hv_pmos[factuo]
print @n.xbgr.xm41_u17.nsg13_hv_pmos[w]
print @n.xbgr.xm41_u17.nsg13_hv_pmos[l]
print @n.xbgr.xm41_u17.nsg13_hv_pmos[delvto]
print @n.xbgr.xm41_u17.nsg13_hv_pmos[factuo]
print @n.xbgr.xm41_u18.nsg13_hv_pmos[w]
print @n.xbgr.xm41_u18.nsg13_hv_pmos[l]
print @n.xbgr.xm41_u18.nsg13_hv_pmos[delvto]
print @n.xbgr.xm41_u18.nsg13_hv_pmos[factuo]
print @n.xbgr.xm41_u19.nsg13_hv_pmos[w]
print @n.xbgr.xm41_u19.nsg13_hv_pmos[l]
print @n.xbgr.xm41_u19.nsg13_hv_pmos[delvto]
print @n.xbgr.xm41_u19.nsg13_hv_pmos[factuo]
print @n.xbgr.xm41_u20.nsg13_hv_pmos[w]
print @n.xbgr.xm41_u20.nsg13_hv_pmos[l]
print @n.xbgr.xm41_u20.nsg13_hv_pmos[delvto]
print @n.xbgr.xm41_u20.nsg13_hv_pmos[factuo]
print @n.xbgr.xm41_u21.nsg13_hv_pmos[w]
print @n.xbgr.xm41_u21.nsg13_hv_pmos[l]
print @n.xbgr.xm41_u21.nsg13_hv_pmos[delvto]
print @n.xbgr.xm41_u21.nsg13_hv_pmos[factuo]
print @n.xbgr.xm41_u22.nsg13_hv_pmos[w]
print @n.xbgr.xm41_u22.nsg13_hv_pmos[l]
print @n.xbgr.xm41_u22.nsg13_hv_pmos[delvto]
print @n.xbgr.xm41_u22.nsg13_hv_pmos[factuo]
print @n.xbgr.xm41_u23.nsg13_hv_pmos[w]
print @n.xbgr.xm41_u23.nsg13_hv_pmos[l]
print @n.xbgr.xm41_u23.nsg13_hv_pmos[delvto]
print @n.xbgr.xm41_u23.nsg13_hv_pmos[factuo]
print @n.xbgr.xm41_u24.nsg13_hv_pmos[w]
print @n.xbgr.xm41_u24.nsg13_hv_pmos[l]
print @n.xbgr.xm41_u24.nsg13_hv_pmos[delvto]
print @n.xbgr.xm41_u24.nsg13_hv_pmos[factuo]
print @n.xbgr.xm43_u2.nsg13_hv_pmos[w]
print @n.xbgr.xm43_u2.nsg13_hv_pmos[l]
print @n.xbgr.xm43_u2.nsg13_hv_pmos[delvto]
print @n.xbgr.xm43_u2.nsg13_hv_pmos[factuo]
print @n.xbgr.xm43_u3.nsg13_hv_pmos[w]
print @n.xbgr.xm43_u3.nsg13_hv_pmos[l]
print @n.xbgr.xm43_u3.nsg13_hv_pmos[delvto]
print @n.xbgr.xm43_u3.nsg13_hv_pmos[factuo]
print @n.xbgr.xm43_u4.nsg13_hv_pmos[w]
print @n.xbgr.xm43_u4.nsg13_hv_pmos[l]
print @n.xbgr.xm43_u4.nsg13_hv_pmos[delvto]
print @n.xbgr.xm43_u4.nsg13_hv_pmos[factuo]
print @n.xbgr.xm44_u2.nsg13_hv_pmos[w]
print @n.xbgr.xm44_u2.nsg13_hv_pmos[l]
print @n.xbgr.xm44_u2.nsg13_hv_pmos[delvto]
print @n.xbgr.xm44_u2.nsg13_hv_pmos[factuo]
print @n.xbgr.xm44_u3.nsg13_hv_pmos[w]
print @n.xbgr.xm44_u3.nsg13_hv_pmos[l]
print @n.xbgr.xm44_u3.nsg13_hv_pmos[delvto]
print @n.xbgr.xm44_u3.nsg13_hv_pmos[factuo]
print @n.xbgr.xm44_u4.nsg13_hv_pmos[w]
print @n.xbgr.xm44_u4.nsg13_hv_pmos[l]
print @n.xbgr.xm44_u4.nsg13_hv_pmos[delvto]
print @n.xbgr.xm44_u4.nsg13_hv_pmos[factuo]
print @n.xbgr.xm45_u2.nsg13_hv_pmos[w]
print @n.xbgr.xm45_u2.nsg13_hv_pmos[l]
print @n.xbgr.xm45_u2.nsg13_hv_pmos[delvto]
print @n.xbgr.xm45_u2.nsg13_hv_pmos[factuo]
print @n.xbgr.xm45_u3.nsg13_hv_pmos[w]
print @n.xbgr.xm45_u3.nsg13_hv_pmos[l]
print @n.xbgr.xm45_u3.nsg13_hv_pmos[delvto]
print @n.xbgr.xm45_u3.nsg13_hv_pmos[factuo]
print @n.xbgr.xm45_u4.nsg13_hv_pmos[w]
print @n.xbgr.xm45_u4.nsg13_hv_pmos[l]
print @n.xbgr.xm45_u4.nsg13_hv_pmos[delvto]
print @n.xbgr.xm45_u4.nsg13_hv_pmos[factuo]
print @n.xbgr.xm45_u5.nsg13_hv_pmos[w]
print @n.xbgr.xm45_u5.nsg13_hv_pmos[l]
print @n.xbgr.xm45_u5.nsg13_hv_pmos[delvto]
print @n.xbgr.xm45_u5.nsg13_hv_pmos[factuo]
print @n.xbgr.xm45_u6.nsg13_hv_pmos[w]
print @n.xbgr.xm45_u6.nsg13_hv_pmos[l]
print @n.xbgr.xm45_u6.nsg13_hv_pmos[delvto]
print @n.xbgr.xm45_u6.nsg13_hv_pmos[factuo]
print @n.xbgr.xm45_u7.nsg13_hv_pmos[w]
print @n.xbgr.xm45_u7.nsg13_hv_pmos[l]
print @n.xbgr.xm45_u7.nsg13_hv_pmos[delvto]
print @n.xbgr.xm45_u7.nsg13_hv_pmos[factuo]
print @n.xbgr.xm45_u8.nsg13_hv_pmos[w]
print @n.xbgr.xm45_u8.nsg13_hv_pmos[l]
print @n.xbgr.xm45_u8.nsg13_hv_pmos[delvto]
print @n.xbgr.xm45_u8.nsg13_hv_pmos[factuo]
print @n.xbgr.xm45_u9.nsg13_hv_pmos[w]
print @n.xbgr.xm45_u9.nsg13_hv_pmos[l]
print @n.xbgr.xm45_u9.nsg13_hv_pmos[delvto]
print @n.xbgr.xm45_u9.nsg13_hv_pmos[factuo]
print @n.xbgr.xm45_u10.nsg13_hv_pmos[w]
print @n.xbgr.xm45_u10.nsg13_hv_pmos[l]
print @n.xbgr.xm45_u10.nsg13_hv_pmos[delvto]
print @n.xbgr.xm45_u10.nsg13_hv_pmos[factuo]
print @n.xbgr.xm45_u11.nsg13_hv_pmos[w]
print @n.xbgr.xm45_u11.nsg13_hv_pmos[l]
print @n.xbgr.xm45_u11.nsg13_hv_pmos[delvto]
print @n.xbgr.xm45_u11.nsg13_hv_pmos[factuo]
print @n.xbgr.xm45_u12.nsg13_hv_pmos[w]
print @n.xbgr.xm45_u12.nsg13_hv_pmos[l]
print @n.xbgr.xm45_u12.nsg13_hv_pmos[delvto]
print @n.xbgr.xm45_u12.nsg13_hv_pmos[factuo]
print @n.xbgr.xm45_u13.nsg13_hv_pmos[w]
print @n.xbgr.xm45_u13.nsg13_hv_pmos[l]
print @n.xbgr.xm45_u13.nsg13_hv_pmos[delvto]
print @n.xbgr.xm45_u13.nsg13_hv_pmos[factuo]
print @n.xbgr.xm45_u14.nsg13_hv_pmos[w]
print @n.xbgr.xm45_u14.nsg13_hv_pmos[l]
print @n.xbgr.xm45_u14.nsg13_hv_pmos[delvto]
print @n.xbgr.xm45_u14.nsg13_hv_pmos[factuo]
print @n.xbgr.xm45_u15.nsg13_hv_pmos[w]
print @n.xbgr.xm45_u15.nsg13_hv_pmos[l]
print @n.xbgr.xm45_u15.nsg13_hv_pmos[delvto]
print @n.xbgr.xm45_u15.nsg13_hv_pmos[factuo]
print @n.xbgr.xm45_u16.nsg13_hv_pmos[w]
print @n.xbgr.xm45_u16.nsg13_hv_pmos[l]
print @n.xbgr.xm45_u16.nsg13_hv_pmos[delvto]
print @n.xbgr.xm45_u16.nsg13_hv_pmos[factuo]
print @n.xbgr.xm45_u17.nsg13_hv_pmos[w]
print @n.xbgr.xm45_u17.nsg13_hv_pmos[l]
print @n.xbgr.xm45_u17.nsg13_hv_pmos[delvto]
print @n.xbgr.xm45_u17.nsg13_hv_pmos[factuo]
print @n.xbgr.xm45_u18.nsg13_hv_pmos[w]
print @n.xbgr.xm45_u18.nsg13_hv_pmos[l]
print @n.xbgr.xm45_u18.nsg13_hv_pmos[delvto]
print @n.xbgr.xm45_u18.nsg13_hv_pmos[factuo]
print @n.xbgr.xm45_u19.nsg13_hv_pmos[w]
print @n.xbgr.xm45_u19.nsg13_hv_pmos[l]
print @n.xbgr.xm45_u19.nsg13_hv_pmos[delvto]
print @n.xbgr.xm45_u19.nsg13_hv_pmos[factuo]
print @n.xbgr.xm45_u20.nsg13_hv_pmos[w]
print @n.xbgr.xm45_u20.nsg13_hv_pmos[l]
print @n.xbgr.xm45_u20.nsg13_hv_pmos[delvto]
print @n.xbgr.xm45_u20.nsg13_hv_pmos[factuo]
print @n.xbgr.xm45_u21.nsg13_hv_pmos[w]
print @n.xbgr.xm45_u21.nsg13_hv_pmos[l]
print @n.xbgr.xm45_u21.nsg13_hv_pmos[delvto]
print @n.xbgr.xm45_u21.nsg13_hv_pmos[factuo]
print @n.xbgr.xm45_u22.nsg13_hv_pmos[w]
print @n.xbgr.xm45_u22.nsg13_hv_pmos[l]
print @n.xbgr.xm45_u22.nsg13_hv_pmos[delvto]
print @n.xbgr.xm45_u22.nsg13_hv_pmos[factuo]
print @n.xbgr.xm45_u23.nsg13_hv_pmos[w]
print @n.xbgr.xm45_u23.nsg13_hv_pmos[l]
print @n.xbgr.xm45_u23.nsg13_hv_pmos[delvto]
print @n.xbgr.xm45_u23.nsg13_hv_pmos[factuo]
print @n.xbgr.xm45_u24.nsg13_hv_pmos[w]
print @n.xbgr.xm45_u24.nsg13_hv_pmos[l]
print @n.xbgr.xm45_u24.nsg13_hv_pmos[delvto]
print @n.xbgr.xm45_u24.nsg13_hv_pmos[factuo]
print @n.xbgr.xm47_u2.nsg13_hv_pmos[w]
print @n.xbgr.xm47_u2.nsg13_hv_pmos[l]
print @n.xbgr.xm47_u2.nsg13_hv_pmos[delvto]
print @n.xbgr.xm47_u2.nsg13_hv_pmos[factuo]
print @n.xbgr.xm47_u3.nsg13_hv_pmos[w]
print @n.xbgr.xm47_u3.nsg13_hv_pmos[l]
print @n.xbgr.xm47_u3.nsg13_hv_pmos[delvto]
print @n.xbgr.xm47_u3.nsg13_hv_pmos[factuo]
print @n.xbgr.xm47_u4.nsg13_hv_pmos[w]
print @n.xbgr.xm47_u4.nsg13_hv_pmos[l]
print @n.xbgr.xm47_u4.nsg13_hv_pmos[delvto]
print @n.xbgr.xm47_u4.nsg13_hv_pmos[factuo]
print @n.xbgr.xm47_u5.nsg13_hv_pmos[w]
print @n.xbgr.xm47_u5.nsg13_hv_pmos[l]
print @n.xbgr.xm47_u5.nsg13_hv_pmos[delvto]
print @n.xbgr.xm47_u5.nsg13_hv_pmos[factuo]
print @n.xbgr.xm47_u6.nsg13_hv_pmos[w]
print @n.xbgr.xm47_u6.nsg13_hv_pmos[l]
print @n.xbgr.xm47_u6.nsg13_hv_pmos[delvto]
print @n.xbgr.xm47_u6.nsg13_hv_pmos[factuo]
print @n.xbgr.xm47_u7.nsg13_hv_pmos[w]
print @n.xbgr.xm47_u7.nsg13_hv_pmos[l]
print @n.xbgr.xm47_u7.nsg13_hv_pmos[delvto]
print @n.xbgr.xm47_u7.nsg13_hv_pmos[factuo]
print @n.xbgr.xm47_u8.nsg13_hv_pmos[w]
print @n.xbgr.xm47_u8.nsg13_hv_pmos[l]
print @n.xbgr.xm47_u8.nsg13_hv_pmos[delvto]
print @n.xbgr.xm47_u8.nsg13_hv_pmos[factuo]
print @n.xbgr.xm47_u9.nsg13_hv_pmos[w]
print @n.xbgr.xm47_u9.nsg13_hv_pmos[l]
print @n.xbgr.xm47_u9.nsg13_hv_pmos[delvto]
print @n.xbgr.xm47_u9.nsg13_hv_pmos[factuo]
print @n.xbgr.xm47_u10.nsg13_hv_pmos[w]
print @n.xbgr.xm47_u10.nsg13_hv_pmos[l]
print @n.xbgr.xm47_u10.nsg13_hv_pmos[delvto]
print @n.xbgr.xm47_u10.nsg13_hv_pmos[factuo]
print @n.xbgr.xm47_u11.nsg13_hv_pmos[w]
print @n.xbgr.xm47_u11.nsg13_hv_pmos[l]
print @n.xbgr.xm47_u11.nsg13_hv_pmos[delvto]
print @n.xbgr.xm47_u11.nsg13_hv_pmos[factuo]
print @n.xbgr.xm47_u12.nsg13_hv_pmos[w]
print @n.xbgr.xm47_u12.nsg13_hv_pmos[l]
print @n.xbgr.xm47_u12.nsg13_hv_pmos[delvto]
print @n.xbgr.xm47_u12.nsg13_hv_pmos[factuo]
print @n.xbgr.xm47_u13.nsg13_hv_pmos[w]
print @n.xbgr.xm47_u13.nsg13_hv_pmos[l]
print @n.xbgr.xm47_u13.nsg13_hv_pmos[delvto]
print @n.xbgr.xm47_u13.nsg13_hv_pmos[factuo]
print @n.xbgr.xm47_u14.nsg13_hv_pmos[w]
print @n.xbgr.xm47_u14.nsg13_hv_pmos[l]
print @n.xbgr.xm47_u14.nsg13_hv_pmos[delvto]
print @n.xbgr.xm47_u14.nsg13_hv_pmos[factuo]
print @n.xbgr.xm47_u15.nsg13_hv_pmos[w]
print @n.xbgr.xm47_u15.nsg13_hv_pmos[l]
print @n.xbgr.xm47_u15.nsg13_hv_pmos[delvto]
print @n.xbgr.xm47_u15.nsg13_hv_pmos[factuo]
print @n.xbgr.xm47_u16.nsg13_hv_pmos[w]
print @n.xbgr.xm47_u16.nsg13_hv_pmos[l]
print @n.xbgr.xm47_u16.nsg13_hv_pmos[delvto]
print @n.xbgr.xm47_u16.nsg13_hv_pmos[factuo]
print @n.xbgr.xm47_u17.nsg13_hv_pmos[w]
print @n.xbgr.xm47_u17.nsg13_hv_pmos[l]
print @n.xbgr.xm47_u17.nsg13_hv_pmos[delvto]
print @n.xbgr.xm47_u17.nsg13_hv_pmos[factuo]
print @n.xbgr.xm47_u18.nsg13_hv_pmos[w]
print @n.xbgr.xm47_u18.nsg13_hv_pmos[l]
print @n.xbgr.xm47_u18.nsg13_hv_pmos[delvto]
print @n.xbgr.xm47_u18.nsg13_hv_pmos[factuo]
print @n.xbgr.xm47_u19.nsg13_hv_pmos[w]
print @n.xbgr.xm47_u19.nsg13_hv_pmos[l]
print @n.xbgr.xm47_u19.nsg13_hv_pmos[delvto]
print @n.xbgr.xm47_u19.nsg13_hv_pmos[factuo]
print @n.xbgr.xm47_u20.nsg13_hv_pmos[w]
print @n.xbgr.xm47_u20.nsg13_hv_pmos[l]
print @n.xbgr.xm47_u20.nsg13_hv_pmos[delvto]
print @n.xbgr.xm47_u20.nsg13_hv_pmos[factuo]
print @n.xbgr.xm47_u21.nsg13_hv_pmos[w]
print @n.xbgr.xm47_u21.nsg13_hv_pmos[l]
print @n.xbgr.xm47_u21.nsg13_hv_pmos[delvto]
print @n.xbgr.xm47_u21.nsg13_hv_pmos[factuo]
print @n.xbgr.xm47_u22.nsg13_hv_pmos[w]
print @n.xbgr.xm47_u22.nsg13_hv_pmos[l]
print @n.xbgr.xm47_u22.nsg13_hv_pmos[delvto]
print @n.xbgr.xm47_u22.nsg13_hv_pmos[factuo]
print @n.xbgr.xm47_u23.nsg13_hv_pmos[w]
print @n.xbgr.xm47_u23.nsg13_hv_pmos[l]
print @n.xbgr.xm47_u23.nsg13_hv_pmos[delvto]
print @n.xbgr.xm47_u23.nsg13_hv_pmos[factuo]
print @n.xbgr.xm47_u24.nsg13_hv_pmos[w]
print @n.xbgr.xm47_u24.nsg13_hv_pmos[l]
print @n.xbgr.xm47_u24.nsg13_hv_pmos[delvto]
print @n.xbgr.xm47_u24.nsg13_hv_pmos[factuo]
print @n.xbgr.xm48_u2.nsg13_hv_pmos[w]
print @n.xbgr.xm48_u2.nsg13_hv_pmos[l]
print @n.xbgr.xm48_u2.nsg13_hv_pmos[delvto]
print @n.xbgr.xm48_u2.nsg13_hv_pmos[factuo]
print @n.xbgr.xm48_u3.nsg13_hv_pmos[w]
print @n.xbgr.xm48_u3.nsg13_hv_pmos[l]
print @n.xbgr.xm48_u3.nsg13_hv_pmos[delvto]
print @n.xbgr.xm48_u3.nsg13_hv_pmos[factuo]
print @n.xbgr.xm48_u4.nsg13_hv_pmos[w]
print @n.xbgr.xm48_u4.nsg13_hv_pmos[l]
print @n.xbgr.xm48_u4.nsg13_hv_pmos[delvto]
print @n.xbgr.xm48_u4.nsg13_hv_pmos[factuo]
print @n.xbgr.xm48_u5.nsg13_hv_pmos[w]
print @n.xbgr.xm48_u5.nsg13_hv_pmos[l]
print @n.xbgr.xm48_u5.nsg13_hv_pmos[delvto]
print @n.xbgr.xm48_u5.nsg13_hv_pmos[factuo]
print @n.xbgr.xm48_u6.nsg13_hv_pmos[w]
print @n.xbgr.xm48_u6.nsg13_hv_pmos[l]
print @n.xbgr.xm48_u6.nsg13_hv_pmos[delvto]
print @n.xbgr.xm48_u6.nsg13_hv_pmos[factuo]
print @n.xbgr.xm48_u7.nsg13_hv_pmos[w]
print @n.xbgr.xm48_u7.nsg13_hv_pmos[l]
print @n.xbgr.xm48_u7.nsg13_hv_pmos[delvto]
print @n.xbgr.xm48_u7.nsg13_hv_pmos[factuo]
print @n.xbgr.xm48_u8.nsg13_hv_pmos[w]
print @n.xbgr.xm48_u8.nsg13_hv_pmos[l]
print @n.xbgr.xm48_u8.nsg13_hv_pmos[delvto]
print @n.xbgr.xm48_u8.nsg13_hv_pmos[factuo]
print @n.xbgr.xm48_u9.nsg13_hv_pmos[w]
print @n.xbgr.xm48_u9.nsg13_hv_pmos[l]
print @n.xbgr.xm48_u9.nsg13_hv_pmos[delvto]
print @n.xbgr.xm48_u9.nsg13_hv_pmos[factuo]
print @n.xbgr.xm48_u10.nsg13_hv_pmos[w]
print @n.xbgr.xm48_u10.nsg13_hv_pmos[l]
print @n.xbgr.xm48_u10.nsg13_hv_pmos[delvto]
print @n.xbgr.xm48_u10.nsg13_hv_pmos[factuo]
print @n.xbgr.xm48_u11.nsg13_hv_pmos[w]
print @n.xbgr.xm48_u11.nsg13_hv_pmos[l]
print @n.xbgr.xm48_u11.nsg13_hv_pmos[delvto]
print @n.xbgr.xm48_u11.nsg13_hv_pmos[factuo]
print @n.xbgr.xm48_u12.nsg13_hv_pmos[w]
print @n.xbgr.xm48_u12.nsg13_hv_pmos[l]
print @n.xbgr.xm48_u12.nsg13_hv_pmos[delvto]
print @n.xbgr.xm48_u12.nsg13_hv_pmos[factuo]
print @n.xbgr.xm48_u13.nsg13_hv_pmos[w]
print @n.xbgr.xm48_u13.nsg13_hv_pmos[l]
print @n.xbgr.xm48_u13.nsg13_hv_pmos[delvto]
print @n.xbgr.xm48_u13.nsg13_hv_pmos[factuo]
print @n.xbgr.xm48_u14.nsg13_hv_pmos[w]
print @n.xbgr.xm48_u14.nsg13_hv_pmos[l]
print @n.xbgr.xm48_u14.nsg13_hv_pmos[delvto]
print @n.xbgr.xm48_u14.nsg13_hv_pmos[factuo]
print @n.xbgr.xm48_u15.nsg13_hv_pmos[w]
print @n.xbgr.xm48_u15.nsg13_hv_pmos[l]
print @n.xbgr.xm48_u15.nsg13_hv_pmos[delvto]
print @n.xbgr.xm48_u15.nsg13_hv_pmos[factuo]
print @n.xbgr.xm48_u16.nsg13_hv_pmos[w]
print @n.xbgr.xm48_u16.nsg13_hv_pmos[l]
print @n.xbgr.xm48_u16.nsg13_hv_pmos[delvto]
print @n.xbgr.xm48_u16.nsg13_hv_pmos[factuo]
print @n.xbgr.xm48_u17.nsg13_hv_pmos[w]
print @n.xbgr.xm48_u17.nsg13_hv_pmos[l]
print @n.xbgr.xm48_u17.nsg13_hv_pmos[delvto]
print @n.xbgr.xm48_u17.nsg13_hv_pmos[factuo]
print @n.xbgr.xm48_u18.nsg13_hv_pmos[w]
print @n.xbgr.xm48_u18.nsg13_hv_pmos[l]
print @n.xbgr.xm48_u18.nsg13_hv_pmos[delvto]
print @n.xbgr.xm48_u18.nsg13_hv_pmos[factuo]
print @n.xbgr.xm48_u19.nsg13_hv_pmos[w]
print @n.xbgr.xm48_u19.nsg13_hv_pmos[l]
print @n.xbgr.xm48_u19.nsg13_hv_pmos[delvto]
print @n.xbgr.xm48_u19.nsg13_hv_pmos[factuo]
print @n.xbgr.xm48_u20.nsg13_hv_pmos[w]
print @n.xbgr.xm48_u20.nsg13_hv_pmos[l]
print @n.xbgr.xm48_u20.nsg13_hv_pmos[delvto]
print @n.xbgr.xm48_u20.nsg13_hv_pmos[factuo]
print @n.xbgr.xm48_u21.nsg13_hv_pmos[w]
print @n.xbgr.xm48_u21.nsg13_hv_pmos[l]
print @n.xbgr.xm48_u21.nsg13_hv_pmos[delvto]
print @n.xbgr.xm48_u21.nsg13_hv_pmos[factuo]
print @n.xbgr.xm48_u22.nsg13_hv_pmos[w]
print @n.xbgr.xm48_u22.nsg13_hv_pmos[l]
print @n.xbgr.xm48_u22.nsg13_hv_pmos[delvto]
print @n.xbgr.xm48_u22.nsg13_hv_pmos[factuo]
print @n.xbgr.xm48_u23.nsg13_hv_pmos[w]
print @n.xbgr.xm48_u23.nsg13_hv_pmos[l]
print @n.xbgr.xm48_u23.nsg13_hv_pmos[delvto]
print @n.xbgr.xm48_u23.nsg13_hv_pmos[factuo]
print @n.xbgr.xm48_u24.nsg13_hv_pmos[w]
print @n.xbgr.xm48_u24.nsg13_hv_pmos[l]
print @n.xbgr.xm48_u24.nsg13_hv_pmos[delvto]
print @n.xbgr.xm48_u24.nsg13_hv_pmos[factuo]
print @n.xbgr.xm50_u2.nsg13_hv_pmos[w]
print @n.xbgr.xm50_u2.nsg13_hv_pmos[l]
print @n.xbgr.xm50_u2.nsg13_hv_pmos[delvto]
print @n.xbgr.xm50_u2.nsg13_hv_pmos[factuo]
print @n.xbgr.xm50_u3.nsg13_hv_pmos[w]
print @n.xbgr.xm50_u3.nsg13_hv_pmos[l]
print @n.xbgr.xm50_u3.nsg13_hv_pmos[delvto]
print @n.xbgr.xm50_u3.nsg13_hv_pmos[factuo]
print @n.xbgr.xm50_u4.nsg13_hv_pmos[w]
print @n.xbgr.xm50_u4.nsg13_hv_pmos[l]
print @n.xbgr.xm50_u4.nsg13_hv_pmos[delvto]
print @n.xbgr.xm50_u4.nsg13_hv_pmos[factuo]
print @n.xbgr.xm50_u5.nsg13_hv_pmos[w]
print @n.xbgr.xm50_u5.nsg13_hv_pmos[l]
print @n.xbgr.xm50_u5.nsg13_hv_pmos[delvto]
print @n.xbgr.xm50_u5.nsg13_hv_pmos[factuo]
print @n.xbgr.xm50_u6.nsg13_hv_pmos[w]
print @n.xbgr.xm50_u6.nsg13_hv_pmos[l]
print @n.xbgr.xm50_u6.nsg13_hv_pmos[delvto]
print @n.xbgr.xm50_u6.nsg13_hv_pmos[factuo]
print @n.xbgr.xm50_u7.nsg13_hv_pmos[w]
print @n.xbgr.xm50_u7.nsg13_hv_pmos[l]
print @n.xbgr.xm50_u7.nsg13_hv_pmos[delvto]
print @n.xbgr.xm50_u7.nsg13_hv_pmos[factuo]
print @n.xbgr.xm50_u8.nsg13_hv_pmos[w]
print @n.xbgr.xm50_u8.nsg13_hv_pmos[l]
print @n.xbgr.xm50_u8.nsg13_hv_pmos[delvto]
print @n.xbgr.xm50_u8.nsg13_hv_pmos[factuo]
print @n.xbgr.xm50_u9.nsg13_hv_pmos[w]
print @n.xbgr.xm50_u9.nsg13_hv_pmos[l]
print @n.xbgr.xm50_u9.nsg13_hv_pmos[delvto]
print @n.xbgr.xm50_u9.nsg13_hv_pmos[factuo]
print @n.xbgr.xm50_u10.nsg13_hv_pmos[w]
print @n.xbgr.xm50_u10.nsg13_hv_pmos[l]
print @n.xbgr.xm50_u10.nsg13_hv_pmos[delvto]
print @n.xbgr.xm50_u10.nsg13_hv_pmos[factuo]
print @n.xbgr.xm50_u11.nsg13_hv_pmos[w]
print @n.xbgr.xm50_u11.nsg13_hv_pmos[l]
print @n.xbgr.xm50_u11.nsg13_hv_pmos[delvto]
print @n.xbgr.xm50_u11.nsg13_hv_pmos[factuo]
print @n.xbgr.xm50_u12.nsg13_hv_pmos[w]
print @n.xbgr.xm50_u12.nsg13_hv_pmos[l]
print @n.xbgr.xm50_u12.nsg13_hv_pmos[delvto]
print @n.xbgr.xm50_u12.nsg13_hv_pmos[factuo]
print @n.xbgr.xm50_u13.nsg13_hv_pmos[w]
print @n.xbgr.xm50_u13.nsg13_hv_pmos[l]
print @n.xbgr.xm50_u13.nsg13_hv_pmos[delvto]
print @n.xbgr.xm50_u13.nsg13_hv_pmos[factuo]
print @n.xbgr.xm50_u14.nsg13_hv_pmos[w]
print @n.xbgr.xm50_u14.nsg13_hv_pmos[l]
print @n.xbgr.xm50_u14.nsg13_hv_pmos[delvto]
print @n.xbgr.xm50_u14.nsg13_hv_pmos[factuo]
print @n.xbgr.xm50_u15.nsg13_hv_pmos[w]
print @n.xbgr.xm50_u15.nsg13_hv_pmos[l]
print @n.xbgr.xm50_u15.nsg13_hv_pmos[delvto]
print @n.xbgr.xm50_u15.nsg13_hv_pmos[factuo]
print @n.xbgr.xm50_u16.nsg13_hv_pmos[w]
print @n.xbgr.xm50_u16.nsg13_hv_pmos[l]
print @n.xbgr.xm50_u16.nsg13_hv_pmos[delvto]
print @n.xbgr.xm50_u16.nsg13_hv_pmos[factuo]
print @n.xbgr.xm50_u17.nsg13_hv_pmos[w]
print @n.xbgr.xm50_u17.nsg13_hv_pmos[l]
print @n.xbgr.xm50_u17.nsg13_hv_pmos[delvto]
print @n.xbgr.xm50_u17.nsg13_hv_pmos[factuo]
print @n.xbgr.xm50_u18.nsg13_hv_pmos[w]
print @n.xbgr.xm50_u18.nsg13_hv_pmos[l]
print @n.xbgr.xm50_u18.nsg13_hv_pmos[delvto]
print @n.xbgr.xm50_u18.nsg13_hv_pmos[factuo]
print @n.xbgr.xm50_u19.nsg13_hv_pmos[w]
print @n.xbgr.xm50_u19.nsg13_hv_pmos[l]
print @n.xbgr.xm50_u19.nsg13_hv_pmos[delvto]
print @n.xbgr.xm50_u19.nsg13_hv_pmos[factuo]
print @n.xbgr.xm50_u20.nsg13_hv_pmos[w]
print @n.xbgr.xm50_u20.nsg13_hv_pmos[l]
print @n.xbgr.xm50_u20.nsg13_hv_pmos[delvto]
print @n.xbgr.xm50_u20.nsg13_hv_pmos[factuo]
print @n.xbgr.xm50_u21.nsg13_hv_pmos[w]
print @n.xbgr.xm50_u21.nsg13_hv_pmos[l]
print @n.xbgr.xm50_u21.nsg13_hv_pmos[delvto]
print @n.xbgr.xm50_u21.nsg13_hv_pmos[factuo]
print @n.xbgr.xm50_u22.nsg13_hv_pmos[w]
print @n.xbgr.xm50_u22.nsg13_hv_pmos[l]
print @n.xbgr.xm50_u22.nsg13_hv_pmos[delvto]
print @n.xbgr.xm50_u22.nsg13_hv_pmos[factuo]
print @n.xbgr.xm50_u23.nsg13_hv_pmos[w]
print @n.xbgr.xm50_u23.nsg13_hv_pmos[l]
print @n.xbgr.xm50_u23.nsg13_hv_pmos[delvto]
print @n.xbgr.xm50_u23.nsg13_hv_pmos[factuo]
print @n.xbgr.xm50_u24.nsg13_hv_pmos[w]
print @n.xbgr.xm50_u24.nsg13_hv_pmos[l]
print @n.xbgr.xm50_u24.nsg13_hv_pmos[delvto]
print @n.xbgr.xm50_u24.nsg13_hv_pmos[factuo]
print @n.xbgr.xm51_u2.nsg13_hv_pmos[w]
print @n.xbgr.xm51_u2.nsg13_hv_pmos[l]
print @n.xbgr.xm51_u2.nsg13_hv_pmos[delvto]
print @n.xbgr.xm51_u2.nsg13_hv_pmos[factuo]
print @n.xbgr.xm51_u3.nsg13_hv_pmos[w]
print @n.xbgr.xm51_u3.nsg13_hv_pmos[l]
print @n.xbgr.xm51_u3.nsg13_hv_pmos[delvto]
print @n.xbgr.xm51_u3.nsg13_hv_pmos[factuo]
print @n.xbgr.xm51_u4.nsg13_hv_pmos[w]
print @n.xbgr.xm51_u4.nsg13_hv_pmos[l]
print @n.xbgr.xm51_u4.nsg13_hv_pmos[delvto]
print @n.xbgr.xm51_u4.nsg13_hv_pmos[factuo]
print @n.xbgr.xm52_u2.nsg13_hv_pmos[w]
print @n.xbgr.xm52_u2.nsg13_hv_pmos[l]
print @n.xbgr.xm52_u2.nsg13_hv_pmos[delvto]
print @n.xbgr.xm52_u2.nsg13_hv_pmos[factuo]
print @n.xbgr.xm52_u3.nsg13_hv_pmos[w]
print @n.xbgr.xm52_u3.nsg13_hv_pmos[l]
print @n.xbgr.xm52_u3.nsg13_hv_pmos[delvto]
print @n.xbgr.xm52_u3.nsg13_hv_pmos[factuo]
print @n.xbgr.xm52_u4.nsg13_hv_pmos[w]
print @n.xbgr.xm52_u4.nsg13_hv_pmos[l]
print @n.xbgr.xm52_u4.nsg13_hv_pmos[delvto]
print @n.xbgr.xm52_u4.nsg13_hv_pmos[factuo]
print @n.xbgr.xm52_u5.nsg13_hv_pmos[w]
print @n.xbgr.xm52_u5.nsg13_hv_pmos[l]
print @n.xbgr.xm52_u5.nsg13_hv_pmos[delvto]
print @n.xbgr.xm52_u5.nsg13_hv_pmos[factuo]
print @n.xbgr.xm52_u6.nsg13_hv_pmos[w]
print @n.xbgr.xm52_u6.nsg13_hv_pmos[l]
print @n.xbgr.xm52_u6.nsg13_hv_pmos[delvto]
print @n.xbgr.xm52_u6.nsg13_hv_pmos[factuo]
print @n.xbgr.xm52_u7.nsg13_hv_pmos[w]
print @n.xbgr.xm52_u7.nsg13_hv_pmos[l]
print @n.xbgr.xm52_u7.nsg13_hv_pmos[delvto]
print @n.xbgr.xm52_u7.nsg13_hv_pmos[factuo]
print @n.xbgr.xm52_u8.nsg13_hv_pmos[w]
print @n.xbgr.xm52_u8.nsg13_hv_pmos[l]
print @n.xbgr.xm52_u8.nsg13_hv_pmos[delvto]
print @n.xbgr.xm52_u8.nsg13_hv_pmos[factuo]
print @n.xbgr.xm52_u9.nsg13_hv_pmos[w]
print @n.xbgr.xm52_u9.nsg13_hv_pmos[l]
print @n.xbgr.xm52_u9.nsg13_hv_pmos[delvto]
print @n.xbgr.xm52_u9.nsg13_hv_pmos[factuo]
print @n.xbgr.xm52_u10.nsg13_hv_pmos[w]
print @n.xbgr.xm52_u10.nsg13_hv_pmos[l]
print @n.xbgr.xm52_u10.nsg13_hv_pmos[delvto]
print @n.xbgr.xm52_u10.nsg13_hv_pmos[factuo]
print @n.xbgr.xm52_u11.nsg13_hv_pmos[w]
print @n.xbgr.xm52_u11.nsg13_hv_pmos[l]
print @n.xbgr.xm52_u11.nsg13_hv_pmos[delvto]
print @n.xbgr.xm52_u11.nsg13_hv_pmos[factuo]
print @n.xbgr.xm52_u12.nsg13_hv_pmos[w]
print @n.xbgr.xm52_u12.nsg13_hv_pmos[l]
print @n.xbgr.xm52_u12.nsg13_hv_pmos[delvto]
print @n.xbgr.xm52_u12.nsg13_hv_pmos[factuo]
print @n.xbgr.xm52_u13.nsg13_hv_pmos[w]
print @n.xbgr.xm52_u13.nsg13_hv_pmos[l]
print @n.xbgr.xm52_u13.nsg13_hv_pmos[delvto]
print @n.xbgr.xm52_u13.nsg13_hv_pmos[factuo]
print @n.xbgr.xm52_u14.nsg13_hv_pmos[w]
print @n.xbgr.xm52_u14.nsg13_hv_pmos[l]
print @n.xbgr.xm52_u14.nsg13_hv_pmos[delvto]
print @n.xbgr.xm52_u14.nsg13_hv_pmos[factuo]
print @n.xbgr.xm52_u15.nsg13_hv_pmos[w]
print @n.xbgr.xm52_u15.nsg13_hv_pmos[l]
print @n.xbgr.xm52_u15.nsg13_hv_pmos[delvto]
print @n.xbgr.xm52_u15.nsg13_hv_pmos[factuo]
print @n.xbgr.xm52_u16.nsg13_hv_pmos[w]
print @n.xbgr.xm52_u16.nsg13_hv_pmos[l]
print @n.xbgr.xm52_u16.nsg13_hv_pmos[delvto]
print @n.xbgr.xm52_u16.nsg13_hv_pmos[factuo]
print @n.xbgr.xm52_u17.nsg13_hv_pmos[w]
print @n.xbgr.xm52_u17.nsg13_hv_pmos[l]
print @n.xbgr.xm52_u17.nsg13_hv_pmos[delvto]
print @n.xbgr.xm52_u17.nsg13_hv_pmos[factuo]
print @n.xbgr.xm52_u18.nsg13_hv_pmos[w]
print @n.xbgr.xm52_u18.nsg13_hv_pmos[l]
print @n.xbgr.xm52_u18.nsg13_hv_pmos[delvto]
print @n.xbgr.xm52_u18.nsg13_hv_pmos[factuo]
print @n.xbgr.xm52_u19.nsg13_hv_pmos[w]
print @n.xbgr.xm52_u19.nsg13_hv_pmos[l]
print @n.xbgr.xm52_u19.nsg13_hv_pmos[delvto]
print @n.xbgr.xm52_u19.nsg13_hv_pmos[factuo]
print @n.xbgr.xm52_u20.nsg13_hv_pmos[w]
print @n.xbgr.xm52_u20.nsg13_hv_pmos[l]
print @n.xbgr.xm52_u20.nsg13_hv_pmos[delvto]
print @n.xbgr.xm52_u20.nsg13_hv_pmos[factuo]
print @n.xbgr.xm52_u21.nsg13_hv_pmos[w]
print @n.xbgr.xm52_u21.nsg13_hv_pmos[l]
print @n.xbgr.xm52_u21.nsg13_hv_pmos[delvto]
print @n.xbgr.xm52_u21.nsg13_hv_pmos[factuo]
print @n.xbgr.xm52_u22.nsg13_hv_pmos[w]
print @n.xbgr.xm52_u22.nsg13_hv_pmos[l]
print @n.xbgr.xm52_u22.nsg13_hv_pmos[delvto]
print @n.xbgr.xm52_u22.nsg13_hv_pmos[factuo]
print @n.xbgr.xm52_u23.nsg13_hv_pmos[w]
print @n.xbgr.xm52_u23.nsg13_hv_pmos[l]
print @n.xbgr.xm52_u23.nsg13_hv_pmos[delvto]
print @n.xbgr.xm52_u23.nsg13_hv_pmos[factuo]
print @n.xbgr.xm52_u24.nsg13_hv_pmos[w]
print @n.xbgr.xm52_u24.nsg13_hv_pmos[l]
print @n.xbgr.xm52_u24.nsg13_hv_pmos[delvto]
print @n.xbgr.xm52_u24.nsg13_hv_pmos[factuo]
print @n.xbgr.xm54_u2.nsg13_hv_pmos[w]
print @n.xbgr.xm54_u2.nsg13_hv_pmos[l]
print @n.xbgr.xm54_u2.nsg13_hv_pmos[delvto]
print @n.xbgr.xm54_u2.nsg13_hv_pmos[factuo]
print @n.xbgr.xm54_u3.nsg13_hv_pmos[w]
print @n.xbgr.xm54_u3.nsg13_hv_pmos[l]
print @n.xbgr.xm54_u3.nsg13_hv_pmos[delvto]
print @n.xbgr.xm54_u3.nsg13_hv_pmos[factuo]
print @n.xbgr.xm54_u4.nsg13_hv_pmos[w]
print @n.xbgr.xm54_u4.nsg13_hv_pmos[l]
print @n.xbgr.xm54_u4.nsg13_hv_pmos[delvto]
print @n.xbgr.xm54_u4.nsg13_hv_pmos[factuo]
print @n.xbgr.xm54_u5.nsg13_hv_pmos[w]
print @n.xbgr.xm54_u5.nsg13_hv_pmos[l]
print @n.xbgr.xm54_u5.nsg13_hv_pmos[delvto]
print @n.xbgr.xm54_u5.nsg13_hv_pmos[factuo]
print @n.xbgr.xm54_u6.nsg13_hv_pmos[w]
print @n.xbgr.xm54_u6.nsg13_hv_pmos[l]
print @n.xbgr.xm54_u6.nsg13_hv_pmos[delvto]
print @n.xbgr.xm54_u6.nsg13_hv_pmos[factuo]
print @n.xbgr.xm54_u7.nsg13_hv_pmos[w]
print @n.xbgr.xm54_u7.nsg13_hv_pmos[l]
print @n.xbgr.xm54_u7.nsg13_hv_pmos[delvto]
print @n.xbgr.xm54_u7.nsg13_hv_pmos[factuo]
print @n.xbgr.xm54_u8.nsg13_hv_pmos[w]
print @n.xbgr.xm54_u8.nsg13_hv_pmos[l]
print @n.xbgr.xm54_u8.nsg13_hv_pmos[delvto]
print @n.xbgr.xm54_u8.nsg13_hv_pmos[factuo]
print @n.xbgr.xm54_u9.nsg13_hv_pmos[w]
print @n.xbgr.xm54_u9.nsg13_hv_pmos[l]
print @n.xbgr.xm54_u9.nsg13_hv_pmos[delvto]
print @n.xbgr.xm54_u9.nsg13_hv_pmos[factuo]
print @n.xbgr.xm54_u10.nsg13_hv_pmos[w]
print @n.xbgr.xm54_u10.nsg13_hv_pmos[l]
print @n.xbgr.xm54_u10.nsg13_hv_pmos[delvto]
print @n.xbgr.xm54_u10.nsg13_hv_pmos[factuo]
print @n.xbgr.xm54_u11.nsg13_hv_pmos[w]
print @n.xbgr.xm54_u11.nsg13_hv_pmos[l]
print @n.xbgr.xm54_u11.nsg13_hv_pmos[delvto]
print @n.xbgr.xm54_u11.nsg13_hv_pmos[factuo]
print @n.xbgr.xm54_u12.nsg13_hv_pmos[w]
print @n.xbgr.xm54_u12.nsg13_hv_pmos[l]
print @n.xbgr.xm54_u12.nsg13_hv_pmos[delvto]
print @n.xbgr.xm54_u12.nsg13_hv_pmos[factuo]
print @n.xbgr.xm54_u13.nsg13_hv_pmos[w]
print @n.xbgr.xm54_u13.nsg13_hv_pmos[l]
print @n.xbgr.xm54_u13.nsg13_hv_pmos[delvto]
print @n.xbgr.xm54_u13.nsg13_hv_pmos[factuo]
print @n.xbgr.xm54_u14.nsg13_hv_pmos[w]
print @n.xbgr.xm54_u14.nsg13_hv_pmos[l]
print @n.xbgr.xm54_u14.nsg13_hv_pmos[delvto]
print @n.xbgr.xm54_u14.nsg13_hv_pmos[factuo]
print @n.xbgr.xm54_u15.nsg13_hv_pmos[w]
print @n.xbgr.xm54_u15.nsg13_hv_pmos[l]
print @n.xbgr.xm54_u15.nsg13_hv_pmos[delvto]
print @n.xbgr.xm54_u15.nsg13_hv_pmos[factuo]
print @n.xbgr.xm54_u16.nsg13_hv_pmos[w]
print @n.xbgr.xm54_u16.nsg13_hv_pmos[l]
print @n.xbgr.xm54_u16.nsg13_hv_pmos[delvto]
print @n.xbgr.xm54_u16.nsg13_hv_pmos[factuo]
print @n.xbgr.xm54_u17.nsg13_hv_pmos[w]
print @n.xbgr.xm54_u17.nsg13_hv_pmos[l]
print @n.xbgr.xm54_u17.nsg13_hv_pmos[delvto]
print @n.xbgr.xm54_u17.nsg13_hv_pmos[factuo]
print @n.xbgr.xm54_u18.nsg13_hv_pmos[w]
print @n.xbgr.xm54_u18.nsg13_hv_pmos[l]
print @n.xbgr.xm54_u18.nsg13_hv_pmos[delvto]
print @n.xbgr.xm54_u18.nsg13_hv_pmos[factuo]
print @n.xbgr.xm54_u19.nsg13_hv_pmos[w]
print @n.xbgr.xm54_u19.nsg13_hv_pmos[l]
print @n.xbgr.xm54_u19.nsg13_hv_pmos[delvto]
print @n.xbgr.xm54_u19.nsg13_hv_pmos[factuo]
print @n.xbgr.xm54_u20.nsg13_hv_pmos[w]
print @n.xbgr.xm54_u20.nsg13_hv_pmos[l]
print @n.xbgr.xm54_u20.nsg13_hv_pmos[delvto]
print @n.xbgr.xm54_u20.nsg13_hv_pmos[factuo]
print @n.xbgr.xm54_u21.nsg13_hv_pmos[w]
print @n.xbgr.xm54_u21.nsg13_hv_pmos[l]
print @n.xbgr.xm54_u21.nsg13_hv_pmos[delvto]
print @n.xbgr.xm54_u21.nsg13_hv_pmos[factuo]
print @n.xbgr.xm54_u22.nsg13_hv_pmos[w]
print @n.xbgr.xm54_u22.nsg13_hv_pmos[l]
print @n.xbgr.xm54_u22.nsg13_hv_pmos[delvto]
print @n.xbgr.xm54_u22.nsg13_hv_pmos[factuo]
print @n.xbgr.xm54_u23.nsg13_hv_pmos[w]
print @n.xbgr.xm54_u23.nsg13_hv_pmos[l]
print @n.xbgr.xm54_u23.nsg13_hv_pmos[delvto]
print @n.xbgr.xm54_u23.nsg13_hv_pmos[factuo]
print @n.xbgr.xm54_u24.nsg13_hv_pmos[w]
print @n.xbgr.xm54_u24.nsg13_hv_pmos[l]
print @n.xbgr.xm54_u24.nsg13_hv_pmos[delvto]
print @n.xbgr.xm54_u24.nsg13_hv_pmos[factuo]
print @q.xbgr.xq56_u2.qnpn13g2[area]
print @q.xbgr.xq56_u3.qnpn13g2[area]
print @q.xbgr.xq56_u4.qnpn13g2[area]
print @q.xbgr.xq56_u5.qnpn13g2[area]
print @q.xbgr.xq56_u6.qnpn13g2[area]
print @q.xbgr.xq56_u7.qnpn13g2[area]
print @q.xbgr.xq56_u8.qnpn13g2[area]
print @q.xbgr.xq56_u9.qnpn13g2[area]
print @q.xbgr.xq56_u10.qnpn13g2[area]
print @q.xbgr.xq56_u11.qnpn13g2[area]
print @q.xbgr.xq56_u12.qnpn13g2[area]
print @q.xbgr.xq56_u13.qnpn13g2[area]
print @q.xbgr.xq56_u14.qnpn13g2[area]
print @q.xbgr.xq56_u15.qnpn13g2[area]
print @q.xbgr.xq56_u16.qnpn13g2[area]
print @q.xbgr.xq56_u17.qnpn13g2[area]
print @q.xbgr.xq56_u18.qnpn13g2[area]
print @q.xbgr.xq56_u19.qnpn13g2[area]
print @q.xbgr.xq56_u20.qnpn13g2[area]
print @q.xbgr.xq56_u21.qnpn13g2[area]
print @q.xbgr.xq56_u22.qnpn13g2[area]
print @q.xbgr.xq56_u23.qnpn13g2[area]
print @q.xbgr.xq56_u24.qnpn13g2[area]
print @q.xbgr.xq60_u2.qnpn13g2[area]
print @q.xbgr.xq60_u3.qnpn13g2[area]
print @q.xbgr.xq60_u4.qnpn13g2[area]
print @q.xbgr.xq62_u2.qnpn13g2[area]
print @q.xbgr.xq62_u3.qnpn13g2[area]
print @q.xbgr.xq62_u4.qnpn13g2[area]
print @q.xbgr.xq62_u5.qnpn13g2[area]
print @q.xbgr.xq62_u6.qnpn13g2[area]
print @q.xbgr.xq62_u7.qnpn13g2[area]
print @q.xbgr.xq62_u8.qnpn13g2[area]
print @q.xbgr.xq62_u9.qnpn13g2[area]
print @q.xbgr.xq62_u10.qnpn13g2[area]
print @q.xbgr.xq62_u11.qnpn13g2[area]
print @q.xbgr.xq62_u12.qnpn13g2[area]
print @q.xbgr.xq62_u13.qnpn13g2[area]
print @q.xbgr.xq62_u14.qnpn13g2[area]
print @q.xbgr.xq62_u15.qnpn13g2[area]
print @q.xbgr.xq62_u16.qnpn13g2[area]
print @q.xbgr.xq62_u17.qnpn13g2[area]
print @q.xbgr.xq62_u18.qnpn13g2[area]
print @q.xbgr.xq62_u19.qnpn13g2[area]
print @q.xbgr.xq62_u20.qnpn13g2[area]
print @q.xbgr.xq62_u21.qnpn13g2[area]
print @q.xbgr.xq62_u22.qnpn13g2[area]
print @q.xbgr.xq62_u23.qnpn13g2[area]
print @q.xbgr.xq62_u24.qnpn13g2[area]
print @q.xbgr.xq67_u2.qnpn13g2[area]
print @q.xbgr.xq67_u3.qnpn13g2[area]
print @q.xbgr.xq67_u4.qnpn13g2[area]
print @q.xbgr.xq67_u5.qnpn13g2[area]
print @q.xbgr.xq67_u6.qnpn13g2[area]
print @q.xbgr.xq67_u7.qnpn13g2[area]
print @q.xbgr.xq67_u8.qnpn13g2[area]
print @q.xbgr.xq67_u9.qnpn13g2[area]
print @q.xbgr.xq67_u10.qnpn13g2[area]
print @q.xbgr.xq67_u11.qnpn13g2[area]
print @q.xbgr.xq67_u12.qnpn13g2[area]
print @q.xbgr.xq67_u13.qnpn13g2[area]
print @q.xbgr.xq67_u14.qnpn13g2[area]
print @q.xbgr.xq67_u15.qnpn13g2[area]
print @q.xbgr.xq67_u16.qnpn13g2[area]
print @q.xbgr.xq67_u17.qnpn13g2[area]
print @q.xbgr.xq67_u18.qnpn13g2[area]
print @q.xbgr.xq67_u19.qnpn13g2[area]
print @q.xbgr.xq67_u20.qnpn13g2[area]
print @q.xbgr.xq67_u21.qnpn13g2[area]
print @q.xbgr.xq67_u22.qnpn13g2[area]
print @q.xbgr.xq67_u23.qnpn13g2[area]
print @q.xbgr.xq67_u24.qnpn13g2[area]
print @q.xbgr.xq68_u2.qnpn13g2[area]
print @q.xbgr.xq68_u3.qnpn13g2[area]
print @q.xbgr.xq68_u4.qnpn13g2[area]
print @q.xbgr.xq68_u5.qnpn13g2[area]
print @q.xbgr.xq68_u6.qnpn13g2[area]
print @q.xbgr.xq68_u7.qnpn13g2[area]
print @q.xbgr.xq68_u8.qnpn13g2[area]
print @q.xbgr.xq68_u9.qnpn13g2[area]
print @q.xbgr.xq68_u10.qnpn13g2[area]
print @q.xbgr.xq68_u11.qnpn13g2[area]
print @q.xbgr.xq68_u12.qnpn13g2[area]
print @q.xbgr.xq68_u13.qnpn13g2[area]
print @q.xbgr.xq68_u14.qnpn13g2[area]
print @q.xbgr.xq68_u15.qnpn13g2[area]
print @q.xbgr.xq68_u16.qnpn13g2[area]
print @q.xbgr.xq68_u17.qnpn13g2[area]
print @q.xbgr.xq68_u18.qnpn13g2[area]
print @q.xbgr.xq68_u19.qnpn13g2[area]
print @q.xbgr.xq68_u20.qnpn13g2[area]
print @q.xbgr.xq68_u21.qnpn13g2[area]
print @q.xbgr.xq68_u22.qnpn13g2[area]
print @q.xbgr.xq68_u23.qnpn13g2[area]
print @q.xbgr.xq68_u24.qnpn13g2[area]
print @q.xbgr.xq69_u2.qnpn13g2[area]
print @q.xbgr.xq69_u3.qnpn13g2[area]
print @q.xbgr.xq69_u4.qnpn13g2[area]
print @q.xbgr.xq69_u5.qnpn13g2[area]
print @q.xbgr.xq69_u6.qnpn13g2[area]
print @q.xbgr.xq69_u7.qnpn13g2[area]
print @q.xbgr.xq69_u8.qnpn13g2[area]
print @q.xbgr.xq69_u9.qnpn13g2[area]
print @q.xbgr.xq69_u10.qnpn13g2[area]
print @q.xbgr.xq69_u11.qnpn13g2[area]
print @q.xbgr.xq69_u12.qnpn13g2[area]
print @q.xbgr.xq69_u13.qnpn13g2[area]
print @q.xbgr.xq69_u14.qnpn13g2[area]
print @q.xbgr.xq69_u15.qnpn13g2[area]
print @q.xbgr.xq69_u16.qnpn13g2[area]
print @q.xbgr.xq69_u17.qnpn13g2[area]
print @q.xbgr.xq69_u18.qnpn13g2[area]
print @q.xbgr.xq69_u19.qnpn13g2[area]
print @q.xbgr.xq69_u20.qnpn13g2[area]
print @q.xbgr.xq69_u21.qnpn13g2[area]
print @q.xbgr.xq69_u22.qnpn13g2[area]
print @q.xbgr.xq69_u23.qnpn13g2[area]
print @q.xbgr.xq69_u24.qnpn13g2[area]
print @q.xbgr.xq70_u2.qnpn13g2[area]
print @q.xbgr.xq70_u3.qnpn13g2[area]
print @q.xbgr.xq70_u4.qnpn13g2[area]
print @q.xbgr.xq70_u5.qnpn13g2[area]
print @q.xbgr.xq70_u6.qnpn13g2[area]
print @q.xbgr.xq70_u7.qnpn13g2[area]
print @q.xbgr.xq70_u8.qnpn13g2[area]
print @q.xbgr.xq70_u9.qnpn13g2[area]
print @q.xbgr.xq70_u10.qnpn13g2[area]
print @q.xbgr.xq70_u11.qnpn13g2[area]
print @q.xbgr.xq70_u12.qnpn13g2[area]
print @q.xbgr.xq70_u13.qnpn13g2[area]
print @q.xbgr.xq70_u14.qnpn13g2[area]
print @q.xbgr.xq70_u15.qnpn13g2[area]
print @q.xbgr.xq70_u16.qnpn13g2[area]
print @q.xbgr.xq70_u17.qnpn13g2[area]
print @q.xbgr.xq70_u18.qnpn13g2[area]
print @q.xbgr.xq70_u19.qnpn13g2[area]
print @q.xbgr.xq70_u20.qnpn13g2[area]
print @q.xbgr.xq70_u21.qnpn13g2[area]
print @q.xbgr.xq70_u22.qnpn13g2[area]
print @q.xbgr.xq70_u23.qnpn13g2[area]
print @q.xbgr.xq70_u24.qnpn13g2[area]
print @q.xbgr.xq71_u2.qnpn13g2[area]
print @q.xbgr.xq71_u3.qnpn13g2[area]
print @q.xbgr.xq71_u4.qnpn13g2[area]
print @q.xbgr.xq71_u5.qnpn13g2[area]
print @q.xbgr.xq71_u6.qnpn13g2[area]
print @q.xbgr.xq71_u7.qnpn13g2[area]
print @q.xbgr.xq71_u8.qnpn13g2[area]
print @q.xbgr.xq71_u9.qnpn13g2[area]
print @q.xbgr.xq71_u10.qnpn13g2[area]
print @q.xbgr.xq71_u11.qnpn13g2[area]
print @q.xbgr.xq71_u12.qnpn13g2[area]
print @q.xbgr.xq71_u13.qnpn13g2[area]
print @q.xbgr.xq71_u14.qnpn13g2[area]
print @q.xbgr.xq71_u15.qnpn13g2[area]
print @q.xbgr.xq71_u16.qnpn13g2[area]
print @q.xbgr.xq71_u17.qnpn13g2[area]
print @q.xbgr.xq71_u18.qnpn13g2[area]
print @q.xbgr.xq71_u19.qnpn13g2[area]
print @q.xbgr.xq71_u20.qnpn13g2[area]
print @q.xbgr.xq71_u21.qnpn13g2[area]
print @q.xbgr.xq71_u22.qnpn13g2[area]
print @q.xbgr.xq71_u23.qnpn13g2[area]
print @q.xbgr.xq71_u24.qnpn13g2[area]
print @q.xbgr.xq72_u2.qnpn13g2[area]
print @q.xbgr.xq72_u3.qnpn13g2[area]
print @q.xbgr.xq72_u4.qnpn13g2[area]
print @q.xbgr.xq72_u5.qnpn13g2[area]
print @q.xbgr.xq72_u6.qnpn13g2[area]
print @q.xbgr.xq72_u7.qnpn13g2[area]
print @q.xbgr.xq72_u8.qnpn13g2[area]
print @q.xbgr.xq72_u9.qnpn13g2[area]
print @q.xbgr.xq72_u10.qnpn13g2[area]
print @q.xbgr.xq72_u11.qnpn13g2[area]
print @q.xbgr.xq72_u12.qnpn13g2[area]
print @q.xbgr.xq72_u13.qnpn13g2[area]
print @q.xbgr.xq72_u14.qnpn13g2[area]
print @q.xbgr.xq72_u15.qnpn13g2[area]
print @q.xbgr.xq72_u16.qnpn13g2[area]
print @q.xbgr.xq72_u17.qnpn13g2[area]
print @q.xbgr.xq72_u18.qnpn13g2[area]
print @q.xbgr.xq72_u19.qnpn13g2[area]
print @q.xbgr.xq72_u20.qnpn13g2[area]
print @q.xbgr.xq72_u21.qnpn13g2[area]
print @q.xbgr.xq72_u22.qnpn13g2[area]
print @q.xbgr.xq72_u23.qnpn13g2[area]
print @q.xbgr.xq72_u24.qnpn13g2[area]
print @q.xbgr.xq73_u2.qnpn13g2[area]
print @q.xbgr.xq73_u3.qnpn13g2[area]
print @q.xbgr.xq73_u4.qnpn13g2[area]
print @q.xbgr.xq73_u5.qnpn13g2[area]
print @q.xbgr.xq73_u6.qnpn13g2[area]
print @q.xbgr.xq73_u7.qnpn13g2[area]
print @q.xbgr.xq73_u8.qnpn13g2[area]
print @q.xbgr.xq73_u9.qnpn13g2[area]
print @q.xbgr.xq73_u10.qnpn13g2[area]
print @q.xbgr.xq73_u11.qnpn13g2[area]
print @q.xbgr.xq73_u12.qnpn13g2[area]
print @q.xbgr.xq73_u13.qnpn13g2[area]
print @q.xbgr.xq73_u14.qnpn13g2[area]
print @q.xbgr.xq73_u15.qnpn13g2[area]
print @q.xbgr.xq73_u16.qnpn13g2[area]
print @q.xbgr.xq73_u17.qnpn13g2[area]
print @q.xbgr.xq73_u18.qnpn13g2[area]
print @q.xbgr.xq73_u19.qnpn13g2[area]
print @q.xbgr.xq73_u20.qnpn13g2[area]
print @q.xbgr.xq73_u21.qnpn13g2[area]
print @q.xbgr.xq73_u22.qnpn13g2[area]
print @q.xbgr.xq73_u23.qnpn13g2[area]
print @q.xbgr.xq73_u24.qnpn13g2[area]
print @q.xbgr.xq74_u2.qnpn13g2[area]
print @q.xbgr.xq74_u3.qnpn13g2[area]
print @q.xbgr.xq74_u4.qnpn13g2[area]
print @q.xbgr.xq74_u5.qnpn13g2[area]
print @q.xbgr.xq74_u6.qnpn13g2[area]
print @q.xbgr.xq74_u7.qnpn13g2[area]
print @q.xbgr.xq74_u8.qnpn13g2[area]
print @q.xbgr.xq74_u9.qnpn13g2[area]
print @q.xbgr.xq74_u10.qnpn13g2[area]
print @q.xbgr.xq74_u11.qnpn13g2[area]
print @q.xbgr.xq74_u12.qnpn13g2[area]
print @q.xbgr.xq74_u13.qnpn13g2[area]
print @q.xbgr.xq74_u14.qnpn13g2[area]
print @q.xbgr.xq74_u15.qnpn13g2[area]
print @q.xbgr.xq74_u16.qnpn13g2[area]
print @q.xbgr.xq74_u17.qnpn13g2[area]
print @q.xbgr.xq74_u18.qnpn13g2[area]
print @q.xbgr.xq74_u19.qnpn13g2[area]
print @q.xbgr.xq74_u20.qnpn13g2[area]
print @q.xbgr.xq74_u21.qnpn13g2[area]
print @q.xbgr.xq74_u22.qnpn13g2[area]
print @q.xbgr.xq74_u23.qnpn13g2[area]
print @q.xbgr.xq74_u24.qnpn13g2[area]
print @q.xbgr.xq75_u2.qnpn13g2[area]
print @q.xbgr.xq75_u3.qnpn13g2[area]
print @q.xbgr.xq75_u4.qnpn13g2[area]
print @q.xbgr.xq75_u5.qnpn13g2[area]
print @q.xbgr.xq75_u6.qnpn13g2[area]
print @q.xbgr.xq75_u7.qnpn13g2[area]
print @q.xbgr.xq75_u8.qnpn13g2[area]
print @q.xbgr.xq75_u9.qnpn13g2[area]
print @q.xbgr.xq75_u10.qnpn13g2[area]
print @q.xbgr.xq75_u11.qnpn13g2[area]
print @q.xbgr.xq75_u12.qnpn13g2[area]
print @q.xbgr.xq75_u13.qnpn13g2[area]
print @q.xbgr.xq75_u14.qnpn13g2[area]
print @q.xbgr.xq75_u15.qnpn13g2[area]
print @q.xbgr.xq75_u16.qnpn13g2[area]
print @q.xbgr.xq75_u17.qnpn13g2[area]
print @q.xbgr.xq75_u18.qnpn13g2[area]
print @q.xbgr.xq75_u19.qnpn13g2[area]
print @q.xbgr.xq75_u20.qnpn13g2[area]
print @q.xbgr.xq75_u21.qnpn13g2[area]
print @q.xbgr.xq75_u22.qnpn13g2[area]
print @q.xbgr.xq75_u23.qnpn13g2[area]
print @q.xbgr.xq75_u24.qnpn13g2[area]
print @q.xbgr.xq76_u2.qnpn13g2[area]
print @q.xbgr.xq76_u3.qnpn13g2[area]
print @q.xbgr.xq76_u4.qnpn13g2[area]
print @q.xbgr.xq76_u5.qnpn13g2[area]
print @q.xbgr.xq76_u6.qnpn13g2[area]
print @q.xbgr.xq76_u7.qnpn13g2[area]
print @q.xbgr.xq76_u8.qnpn13g2[area]
print @q.xbgr.xq76_u9.qnpn13g2[area]
print @q.xbgr.xq76_u10.qnpn13g2[area]
print @q.xbgr.xq76_u11.qnpn13g2[area]
print @q.xbgr.xq76_u12.qnpn13g2[area]
print @q.xbgr.xq76_u13.qnpn13g2[area]
print @q.xbgr.xq76_u14.qnpn13g2[area]
print @q.xbgr.xq76_u15.qnpn13g2[area]
print @q.xbgr.xq76_u16.qnpn13g2[area]
print @q.xbgr.xq76_u17.qnpn13g2[area]
print @q.xbgr.xq76_u18.qnpn13g2[area]
print @q.xbgr.xq76_u19.qnpn13g2[area]
print @q.xbgr.xq76_u20.qnpn13g2[area]
print @q.xbgr.xq76_u21.qnpn13g2[area]
print @q.xbgr.xq76_u22.qnpn13g2[area]
print @q.xbgr.xq76_u23.qnpn13g2[area]
print @q.xbgr.xq76_u24.qnpn13g2[area]
print @n.xbgr.xr77_u2.nr1[nsmm_rsh]
print @n.xbgr.xr77_u2.nr1[nsmm_w]
print @n.xbgr.xr77_u2.nr1[nsmm_l]
print @n.xbgr.xr77_u3.nr1[nsmm_rsh]
print @n.xbgr.xr77_u3.nr1[nsmm_w]
print @n.xbgr.xr77_u3.nr1[nsmm_l]
print @n.xbgr.xr77_u4.nr1[nsmm_rsh]
print @n.xbgr.xr77_u4.nr1[nsmm_w]
print @n.xbgr.xr77_u4.nr1[nsmm_l]
print @n.xbgr.xr77_u5.nr1[nsmm_rsh]
print @n.xbgr.xr77_u5.nr1[nsmm_w]
print @n.xbgr.xr77_u5.nr1[nsmm_l]
print @n.xbgr.xr77_u6.nr1[nsmm_rsh]
print @n.xbgr.xr77_u6.nr1[nsmm_w]
print @n.xbgr.xr77_u6.nr1[nsmm_l]
print @n.xbgr.xr77_u7.nr1[nsmm_rsh]
print @n.xbgr.xr77_u7.nr1[nsmm_w]
print @n.xbgr.xr77_u7.nr1[nsmm_l]
print @n.xbgr.xr77_u8.nr1[nsmm_rsh]
print @n.xbgr.xr77_u8.nr1[nsmm_w]
print @n.xbgr.xr77_u8.nr1[nsmm_l]
print @n.xbgr.xr77_u9.nr1[nsmm_rsh]
print @n.xbgr.xr77_u9.nr1[nsmm_w]
print @n.xbgr.xr77_u9.nr1[nsmm_l]
print @n.xbgr.xr77_u10.nr1[nsmm_rsh]
print @n.xbgr.xr77_u10.nr1[nsmm_w]
print @n.xbgr.xr77_u10.nr1[nsmm_l]
print @n.xbgr.xr77_u11.nr1[nsmm_rsh]
print @n.xbgr.xr77_u11.nr1[nsmm_w]
print @n.xbgr.xr77_u11.nr1[nsmm_l]
print @n.xbgr.xr77_u12.nr1[nsmm_rsh]
print @n.xbgr.xr77_u12.nr1[nsmm_w]
print @n.xbgr.xr77_u12.nr1[nsmm_l]
print @n.xbgr.xr77_u13.nr1[nsmm_rsh]
print @n.xbgr.xr77_u13.nr1[nsmm_w]
print @n.xbgr.xr77_u13.nr1[nsmm_l]
print @n.xbgr.xr77_u14.nr1[nsmm_rsh]
print @n.xbgr.xr77_u14.nr1[nsmm_w]
print @n.xbgr.xr77_u14.nr1[nsmm_l]
print @n.xbgr.xr77_u15.nr1[nsmm_rsh]
print @n.xbgr.xr77_u15.nr1[nsmm_w]
print @n.xbgr.xr77_u15.nr1[nsmm_l]
print @n.xbgr.xr77_u16.nr1[nsmm_rsh]
print @n.xbgr.xr77_u16.nr1[nsmm_w]
print @n.xbgr.xr77_u16.nr1[nsmm_l]
print @n.xbgr.xr77_u17.nr1[nsmm_rsh]
print @n.xbgr.xr77_u17.nr1[nsmm_w]
print @n.xbgr.xr77_u17.nr1[nsmm_l]
print @n.xbgr.xr77_u18.nr1[nsmm_rsh]
print @n.xbgr.xr77_u18.nr1[nsmm_w]
print @n.xbgr.xr77_u18.nr1[nsmm_l]
print @n.xbgr.xr77_u19.nr1[nsmm_rsh]
print @n.xbgr.xr77_u19.nr1[nsmm_w]
print @n.xbgr.xr77_u19.nr1[nsmm_l]
print @n.xbgr.xr77_u20.nr1[nsmm_rsh]
print @n.xbgr.xr77_u20.nr1[nsmm_w]
print @n.xbgr.xr77_u20.nr1[nsmm_l]
print @n.xbgr.xr77_u21.nr1[nsmm_rsh]
print @n.xbgr.xr77_u21.nr1[nsmm_w]
print @n.xbgr.xr77_u21.nr1[nsmm_l]
print @n.xbgr.xr77_u22.nr1[nsmm_rsh]
print @n.xbgr.xr77_u22.nr1[nsmm_w]
print @n.xbgr.xr77_u22.nr1[nsmm_l]
print @n.xbgr.xr77_u23.nr1[nsmm_rsh]
print @n.xbgr.xr77_u23.nr1[nsmm_w]
print @n.xbgr.xr77_u23.nr1[nsmm_l]
print @n.xbgr.xr77_u24.nr1[nsmm_rsh]
print @n.xbgr.xr77_u24.nr1[nsmm_w]
print @n.xbgr.xr77_u24.nr1[nsmm_l]
print @n.xbgr.xr78_u2.nr1[nsmm_rsh]
print @n.xbgr.xr78_u2.nr1[nsmm_w]
print @n.xbgr.xr78_u2.nr1[nsmm_l]
print @n.xbgr.xr78_u3.nr1[nsmm_rsh]
print @n.xbgr.xr78_u3.nr1[nsmm_w]
print @n.xbgr.xr78_u3.nr1[nsmm_l]
print @n.xbgr.xr78_u4.nr1[nsmm_rsh]
print @n.xbgr.xr78_u4.nr1[nsmm_w]
print @n.xbgr.xr78_u4.nr1[nsmm_l]
print @n.xbgr.xr78_u5.nr1[nsmm_rsh]
print @n.xbgr.xr78_u5.nr1[nsmm_w]
print @n.xbgr.xr78_u5.nr1[nsmm_l]
print @n.xbgr.xr78_u6.nr1[nsmm_rsh]
print @n.xbgr.xr78_u6.nr1[nsmm_w]
print @n.xbgr.xr78_u6.nr1[nsmm_l]
print @n.xbgr.xr78_u7.nr1[nsmm_rsh]
print @n.xbgr.xr78_u7.nr1[nsmm_w]
print @n.xbgr.xr78_u7.nr1[nsmm_l]
print @n.xbgr.xr78_u8.nr1[nsmm_rsh]
print @n.xbgr.xr78_u8.nr1[nsmm_w]
print @n.xbgr.xr78_u8.nr1[nsmm_l]
print @n.xbgr.xr78_u9.nr1[nsmm_rsh]
print @n.xbgr.xr78_u9.nr1[nsmm_w]
print @n.xbgr.xr78_u9.nr1[nsmm_l]
print @n.xbgr.xr78_u10.nr1[nsmm_rsh]
print @n.xbgr.xr78_u10.nr1[nsmm_w]
print @n.xbgr.xr78_u10.nr1[nsmm_l]
print @n.xbgr.xr78_u11.nr1[nsmm_rsh]
print @n.xbgr.xr78_u11.nr1[nsmm_w]
print @n.xbgr.xr78_u11.nr1[nsmm_l]
print @n.xbgr.xr78_u12.nr1[nsmm_rsh]
print @n.xbgr.xr78_u12.nr1[nsmm_w]
print @n.xbgr.xr78_u12.nr1[nsmm_l]
print @n.xbgr.xr78_u13.nr1[nsmm_rsh]
print @n.xbgr.xr78_u13.nr1[nsmm_w]
print @n.xbgr.xr78_u13.nr1[nsmm_l]
print @n.xbgr.xr78_u14.nr1[nsmm_rsh]
print @n.xbgr.xr78_u14.nr1[nsmm_w]
print @n.xbgr.xr78_u14.nr1[nsmm_l]
print @n.xbgr.xr78_u15.nr1[nsmm_rsh]
print @n.xbgr.xr78_u15.nr1[nsmm_w]
print @n.xbgr.xr78_u15.nr1[nsmm_l]
print @n.xbgr.xr78_u16.nr1[nsmm_rsh]
print @n.xbgr.xr78_u16.nr1[nsmm_w]
print @n.xbgr.xr78_u16.nr1[nsmm_l]
print @n.xbgr.xr78_u17.nr1[nsmm_rsh]
print @n.xbgr.xr78_u17.nr1[nsmm_w]
print @n.xbgr.xr78_u17.nr1[nsmm_l]
print @n.xbgr.xr78_u18.nr1[nsmm_rsh]
print @n.xbgr.xr78_u18.nr1[nsmm_w]
print @n.xbgr.xr78_u18.nr1[nsmm_l]
print @n.xbgr.xr78_u19.nr1[nsmm_rsh]
print @n.xbgr.xr78_u19.nr1[nsmm_w]
print @n.xbgr.xr78_u19.nr1[nsmm_l]
print @n.xbgr.xr78_u20.nr1[nsmm_rsh]
print @n.xbgr.xr78_u20.nr1[nsmm_w]
print @n.xbgr.xr78_u20.nr1[nsmm_l]
print @n.xbgr.xr78_u21.nr1[nsmm_rsh]
print @n.xbgr.xr78_u21.nr1[nsmm_w]
print @n.xbgr.xr78_u21.nr1[nsmm_l]
print @n.xbgr.xr78_u22.nr1[nsmm_rsh]
print @n.xbgr.xr78_u22.nr1[nsmm_w]
print @n.xbgr.xr78_u22.nr1[nsmm_l]
print @n.xbgr.xr78_u23.nr1[nsmm_rsh]
print @n.xbgr.xr78_u23.nr1[nsmm_w]
print @n.xbgr.xr78_u23.nr1[nsmm_l]
print @n.xbgr.xr78_u24.nr1[nsmm_rsh]
print @n.xbgr.xr78_u24.nr1[nsmm_w]
print @n.xbgr.xr78_u24.nr1[nsmm_l]
print @n.xbgr.xr79_u2.nr1[nsmm_rsh]
print @n.xbgr.xr79_u2.nr1[nsmm_w]
print @n.xbgr.xr79_u2.nr1[nsmm_l]
print @n.xbgr.xr79_u3.nr1[nsmm_rsh]
print @n.xbgr.xr79_u3.nr1[nsmm_w]
print @n.xbgr.xr79_u3.nr1[nsmm_l]
print @n.xbgr.xr79_u4.nr1[nsmm_rsh]
print @n.xbgr.xr79_u4.nr1[nsmm_w]
print @n.xbgr.xr79_u4.nr1[nsmm_l]
print @n.xbgr.xr79_u5.nr1[nsmm_rsh]
print @n.xbgr.xr79_u5.nr1[nsmm_w]
print @n.xbgr.xr79_u5.nr1[nsmm_l]
print @n.xbgr.xr79_u6.nr1[nsmm_rsh]
print @n.xbgr.xr79_u6.nr1[nsmm_w]
print @n.xbgr.xr79_u6.nr1[nsmm_l]
print @n.xbgr.xr79_u7.nr1[nsmm_rsh]
print @n.xbgr.xr79_u7.nr1[nsmm_w]
print @n.xbgr.xr79_u7.nr1[nsmm_l]
print @n.xbgr.xr79_u8.nr1[nsmm_rsh]
print @n.xbgr.xr79_u8.nr1[nsmm_w]
print @n.xbgr.xr79_u8.nr1[nsmm_l]
print @n.xbgr.xr79_u9.nr1[nsmm_rsh]
print @n.xbgr.xr79_u9.nr1[nsmm_w]
print @n.xbgr.xr79_u9.nr1[nsmm_l]
print @n.xbgr.xr79_u10.nr1[nsmm_rsh]
print @n.xbgr.xr79_u10.nr1[nsmm_w]
print @n.xbgr.xr79_u10.nr1[nsmm_l]
print @n.xbgr.xr79_u11.nr1[nsmm_rsh]
print @n.xbgr.xr79_u11.nr1[nsmm_w]
print @n.xbgr.xr79_u11.nr1[nsmm_l]
print @n.xbgr.xr79_u12.nr1[nsmm_rsh]
print @n.xbgr.xr79_u12.nr1[nsmm_w]
print @n.xbgr.xr79_u12.nr1[nsmm_l]
print @n.xbgr.xr79_u13.nr1[nsmm_rsh]
print @n.xbgr.xr79_u13.nr1[nsmm_w]
print @n.xbgr.xr79_u13.nr1[nsmm_l]
print @n.xbgr.xr79_u14.nr1[nsmm_rsh]
print @n.xbgr.xr79_u14.nr1[nsmm_w]
print @n.xbgr.xr79_u14.nr1[nsmm_l]
print @n.xbgr.xr79_u15.nr1[nsmm_rsh]
print @n.xbgr.xr79_u15.nr1[nsmm_w]
print @n.xbgr.xr79_u15.nr1[nsmm_l]
print @n.xbgr.xr79_u16.nr1[nsmm_rsh]
print @n.xbgr.xr79_u16.nr1[nsmm_w]
print @n.xbgr.xr79_u16.nr1[nsmm_l]
print @n.xbgr.xr79_u17.nr1[nsmm_rsh]
print @n.xbgr.xr79_u17.nr1[nsmm_w]
print @n.xbgr.xr79_u17.nr1[nsmm_l]
print @n.xbgr.xr79_u18.nr1[nsmm_rsh]
print @n.xbgr.xr79_u18.nr1[nsmm_w]
print @n.xbgr.xr79_u18.nr1[nsmm_l]
print @n.xbgr.xr79_u19.nr1[nsmm_rsh]
print @n.xbgr.xr79_u19.nr1[nsmm_w]
print @n.xbgr.xr79_u19.nr1[nsmm_l]
print @n.xbgr.xr79_u20.nr1[nsmm_rsh]
print @n.xbgr.xr79_u20.nr1[nsmm_w]
print @n.xbgr.xr79_u20.nr1[nsmm_l]
print @n.xbgr.xr79_u21.nr1[nsmm_rsh]
print @n.xbgr.xr79_u21.nr1[nsmm_w]
print @n.xbgr.xr79_u21.nr1[nsmm_l]
print @n.xbgr.xr79_u22.nr1[nsmm_rsh]
print @n.xbgr.xr79_u22.nr1[nsmm_w]
print @n.xbgr.xr79_u22.nr1[nsmm_l]
print @n.xbgr.xr79_u23.nr1[nsmm_rsh]
print @n.xbgr.xr79_u23.nr1[nsmm_w]
print @n.xbgr.xr79_u23.nr1[nsmm_l]
print @n.xbgr.xr79_u24.nr1[nsmm_rsh]
print @n.xbgr.xr79_u24.nr1[nsmm_w]
print @n.xbgr.xr79_u24.nr1[nsmm_l]
print @n.xbgr.xr80_u2.nr1[nsmm_rsh]
print @n.xbgr.xr80_u2.nr1[nsmm_w]
print @n.xbgr.xr80_u2.nr1[nsmm_l]
print @n.xbgr.xr80_u3.nr1[nsmm_rsh]
print @n.xbgr.xr80_u3.nr1[nsmm_w]
print @n.xbgr.xr80_u3.nr1[nsmm_l]
print @n.xbgr.xr80_u4.nr1[nsmm_rsh]
print @n.xbgr.xr80_u4.nr1[nsmm_w]
print @n.xbgr.xr80_u4.nr1[nsmm_l]
print @n.xbgr.xr80_u5.nr1[nsmm_rsh]
print @n.xbgr.xr80_u5.nr1[nsmm_w]
print @n.xbgr.xr80_u5.nr1[nsmm_l]
print @n.xbgr.xr80_u6.nr1[nsmm_rsh]
print @n.xbgr.xr80_u6.nr1[nsmm_w]
print @n.xbgr.xr80_u6.nr1[nsmm_l]
print @n.xbgr.xr80_u7.nr1[nsmm_rsh]
print @n.xbgr.xr80_u7.nr1[nsmm_w]
print @n.xbgr.xr80_u7.nr1[nsmm_l]
print @n.xbgr.xr80_u8.nr1[nsmm_rsh]
print @n.xbgr.xr80_u8.nr1[nsmm_w]
print @n.xbgr.xr80_u8.nr1[nsmm_l]
print @n.xbgr.xr80_u9.nr1[nsmm_rsh]
print @n.xbgr.xr80_u9.nr1[nsmm_w]
print @n.xbgr.xr80_u9.nr1[nsmm_l]
print @n.xbgr.xr80_u10.nr1[nsmm_rsh]
print @n.xbgr.xr80_u10.nr1[nsmm_w]
print @n.xbgr.xr80_u10.nr1[nsmm_l]
print @n.xbgr.xr80_u11.nr1[nsmm_rsh]
print @n.xbgr.xr80_u11.nr1[nsmm_w]
print @n.xbgr.xr80_u11.nr1[nsmm_l]
print @n.xbgr.xr80_u12.nr1[nsmm_rsh]
print @n.xbgr.xr80_u12.nr1[nsmm_w]
print @n.xbgr.xr80_u12.nr1[nsmm_l]
print @n.xbgr.xr80_u13.nr1[nsmm_rsh]
print @n.xbgr.xr80_u13.nr1[nsmm_w]
print @n.xbgr.xr80_u13.nr1[nsmm_l]
print @n.xbgr.xr80_u14.nr1[nsmm_rsh]
print @n.xbgr.xr80_u14.nr1[nsmm_w]
print @n.xbgr.xr80_u14.nr1[nsmm_l]
print @n.xbgr.xr80_u15.nr1[nsmm_rsh]
print @n.xbgr.xr80_u15.nr1[nsmm_w]
print @n.xbgr.xr80_u15.nr1[nsmm_l]
print @n.xbgr.xr80_u16.nr1[nsmm_rsh]
print @n.xbgr.xr80_u16.nr1[nsmm_w]
print @n.xbgr.xr80_u16.nr1[nsmm_l]
print @n.xbgr.xr80_u17.nr1[nsmm_rsh]
print @n.xbgr.xr80_u17.nr1[nsmm_w]
print @n.xbgr.xr80_u17.nr1[nsmm_l]
print @n.xbgr.xr80_u18.nr1[nsmm_rsh]
print @n.xbgr.xr80_u18.nr1[nsmm_w]
print @n.xbgr.xr80_u18.nr1[nsmm_l]
print @n.xbgr.xr80_u19.nr1[nsmm_rsh]
print @n.xbgr.xr80_u19.nr1[nsmm_w]
print @n.xbgr.xr80_u19.nr1[nsmm_l]
print @n.xbgr.xr80_u20.nr1[nsmm_rsh]
print @n.xbgr.xr80_u20.nr1[nsmm_w]
print @n.xbgr.xr80_u20.nr1[nsmm_l]
print @n.xbgr.xr80_u21.nr1[nsmm_rsh]
print @n.xbgr.xr80_u21.nr1[nsmm_w]
print @n.xbgr.xr80_u21.nr1[nsmm_l]
print @n.xbgr.xr80_u22.nr1[nsmm_rsh]
print @n.xbgr.xr80_u22.nr1[nsmm_w]
print @n.xbgr.xr80_u22.nr1[nsmm_l]
print @n.xbgr.xr80_u23.nr1[nsmm_rsh]
print @n.xbgr.xr80_u23.nr1[nsmm_w]
print @n.xbgr.xr80_u23.nr1[nsmm_l]
print @n.xbgr.xr80_u24.nr1[nsmm_rsh]
print @n.xbgr.xr80_u24.nr1[nsmm_w]
print @n.xbgr.xr80_u24.nr1[nsmm_l]
print @n.xbgr.xr81_u2.nr1[nsmm_rsh]
print @n.xbgr.xr81_u2.nr1[nsmm_w]
print @n.xbgr.xr81_u2.nr1[nsmm_l]
print @n.xbgr.xr81_u3.nr1[nsmm_rsh]
print @n.xbgr.xr81_u3.nr1[nsmm_w]
print @n.xbgr.xr81_u3.nr1[nsmm_l]
print @n.xbgr.xr81_u4.nr1[nsmm_rsh]
print @n.xbgr.xr81_u4.nr1[nsmm_w]
print @n.xbgr.xr81_u4.nr1[nsmm_l]
print @n.xbgr.xr81_u5.nr1[nsmm_rsh]
print @n.xbgr.xr81_u5.nr1[nsmm_w]
print @n.xbgr.xr81_u5.nr1[nsmm_l]
print @n.xbgr.xr81_u6.nr1[nsmm_rsh]
print @n.xbgr.xr81_u6.nr1[nsmm_w]
print @n.xbgr.xr81_u6.nr1[nsmm_l]
print @n.xbgr.xr81_u7.nr1[nsmm_rsh]
print @n.xbgr.xr81_u7.nr1[nsmm_w]
print @n.xbgr.xr81_u7.nr1[nsmm_l]
print @n.xbgr.xr81_u8.nr1[nsmm_rsh]
print @n.xbgr.xr81_u8.nr1[nsmm_w]
print @n.xbgr.xr81_u8.nr1[nsmm_l]
print @n.xbgr.xr81_u9.nr1[nsmm_rsh]
print @n.xbgr.xr81_u9.nr1[nsmm_w]
print @n.xbgr.xr81_u9.nr1[nsmm_l]
print @n.xbgr.xr81_u10.nr1[nsmm_rsh]
print @n.xbgr.xr81_u10.nr1[nsmm_w]
print @n.xbgr.xr81_u10.nr1[nsmm_l]
print @n.xbgr.xr81_u11.nr1[nsmm_rsh]
print @n.xbgr.xr81_u11.nr1[nsmm_w]
print @n.xbgr.xr81_u11.nr1[nsmm_l]
print @n.xbgr.xr81_u12.nr1[nsmm_rsh]
print @n.xbgr.xr81_u12.nr1[nsmm_w]
print @n.xbgr.xr81_u12.nr1[nsmm_l]
print @n.xbgr.xr81_u13.nr1[nsmm_rsh]
print @n.xbgr.xr81_u13.nr1[nsmm_w]
print @n.xbgr.xr81_u13.nr1[nsmm_l]
print @n.xbgr.xr81_u14.nr1[nsmm_rsh]
print @n.xbgr.xr81_u14.nr1[nsmm_w]
print @n.xbgr.xr81_u14.nr1[nsmm_l]
print @n.xbgr.xr81_u15.nr1[nsmm_rsh]
print @n.xbgr.xr81_u15.nr1[nsmm_w]
print @n.xbgr.xr81_u15.nr1[nsmm_l]
print @n.xbgr.xr81_u16.nr1[nsmm_rsh]
print @n.xbgr.xr81_u16.nr1[nsmm_w]
print @n.xbgr.xr81_u16.nr1[nsmm_l]
print @n.xbgr.xr81_u17.nr1[nsmm_rsh]
print @n.xbgr.xr81_u17.nr1[nsmm_w]
print @n.xbgr.xr81_u17.nr1[nsmm_l]
print @n.xbgr.xr81_u18.nr1[nsmm_rsh]
print @n.xbgr.xr81_u18.nr1[nsmm_w]
print @n.xbgr.xr81_u18.nr1[nsmm_l]
print @n.xbgr.xr81_u19.nr1[nsmm_rsh]
print @n.xbgr.xr81_u19.nr1[nsmm_w]
print @n.xbgr.xr81_u19.nr1[nsmm_l]
print @n.xbgr.xr81_u20.nr1[nsmm_rsh]
print @n.xbgr.xr81_u20.nr1[nsmm_w]
print @n.xbgr.xr81_u20.nr1[nsmm_l]
print @n.xbgr.xr81_u21.nr1[nsmm_rsh]
print @n.xbgr.xr81_u21.nr1[nsmm_w]
print @n.xbgr.xr81_u21.nr1[nsmm_l]
print @n.xbgr.xr81_u22.nr1[nsmm_rsh]
print @n.xbgr.xr81_u22.nr1[nsmm_w]
print @n.xbgr.xr81_u22.nr1[nsmm_l]
print @n.xbgr.xr81_u23.nr1[nsmm_rsh]
print @n.xbgr.xr81_u23.nr1[nsmm_w]
print @n.xbgr.xr81_u23.nr1[nsmm_l]
print @n.xbgr.xr81_u24.nr1[nsmm_rsh]
print @n.xbgr.xr81_u24.nr1[nsmm_w]
print @n.xbgr.xr81_u24.nr1[nsmm_l]
print @n.xbgr.xr82_u2.nr1[nsmm_rsh]
print @n.xbgr.xr82_u2.nr1[nsmm_w]
print @n.xbgr.xr82_u2.nr1[nsmm_l]
print @n.xbgr.xr82_u3.nr1[nsmm_rsh]
print @n.xbgr.xr82_u3.nr1[nsmm_w]
print @n.xbgr.xr82_u3.nr1[nsmm_l]
print @n.xbgr.xr82_u4.nr1[nsmm_rsh]
print @n.xbgr.xr82_u4.nr1[nsmm_w]
print @n.xbgr.xr82_u4.nr1[nsmm_l]
print @n.xbgr.xr82_u5.nr1[nsmm_rsh]
print @n.xbgr.xr82_u5.nr1[nsmm_w]
print @n.xbgr.xr82_u5.nr1[nsmm_l]
print @n.xbgr.xr82_u6.nr1[nsmm_rsh]
print @n.xbgr.xr82_u6.nr1[nsmm_w]
print @n.xbgr.xr82_u6.nr1[nsmm_l]
print @n.xbgr.xr82_u7.nr1[nsmm_rsh]
print @n.xbgr.xr82_u7.nr1[nsmm_w]
print @n.xbgr.xr82_u7.nr1[nsmm_l]
print @n.xbgr.xr82_u8.nr1[nsmm_rsh]
print @n.xbgr.xr82_u8.nr1[nsmm_w]
print @n.xbgr.xr82_u8.nr1[nsmm_l]
print @n.xbgr.xr82_u9.nr1[nsmm_rsh]
print @n.xbgr.xr82_u9.nr1[nsmm_w]
print @n.xbgr.xr82_u9.nr1[nsmm_l]
print @n.xbgr.xr82_u10.nr1[nsmm_rsh]
print @n.xbgr.xr82_u10.nr1[nsmm_w]
print @n.xbgr.xr82_u10.nr1[nsmm_l]
print @n.xbgr.xr82_u11.nr1[nsmm_rsh]
print @n.xbgr.xr82_u11.nr1[nsmm_w]
print @n.xbgr.xr82_u11.nr1[nsmm_l]
print @n.xbgr.xr82_u12.nr1[nsmm_rsh]
print @n.xbgr.xr82_u12.nr1[nsmm_w]
print @n.xbgr.xr82_u12.nr1[nsmm_l]
print @n.xbgr.xr82_u13.nr1[nsmm_rsh]
print @n.xbgr.xr82_u13.nr1[nsmm_w]
print @n.xbgr.xr82_u13.nr1[nsmm_l]
print @n.xbgr.xr82_u14.nr1[nsmm_rsh]
print @n.xbgr.xr82_u14.nr1[nsmm_w]
print @n.xbgr.xr82_u14.nr1[nsmm_l]
print @n.xbgr.xr82_u15.nr1[nsmm_rsh]
print @n.xbgr.xr82_u15.nr1[nsmm_w]
print @n.xbgr.xr82_u15.nr1[nsmm_l]
print @n.xbgr.xr82_u16.nr1[nsmm_rsh]
print @n.xbgr.xr82_u16.nr1[nsmm_w]
print @n.xbgr.xr82_u16.nr1[nsmm_l]
print @n.xbgr.xr82_u17.nr1[nsmm_rsh]
print @n.xbgr.xr82_u17.nr1[nsmm_w]
print @n.xbgr.xr82_u17.nr1[nsmm_l]
print @n.xbgr.xr82_u18.nr1[nsmm_rsh]
print @n.xbgr.xr82_u18.nr1[nsmm_w]
print @n.xbgr.xr82_u18.nr1[nsmm_l]
print @n.xbgr.xr82_u19.nr1[nsmm_rsh]
print @n.xbgr.xr82_u19.nr1[nsmm_w]
print @n.xbgr.xr82_u19.nr1[nsmm_l]
print @n.xbgr.xr82_u20.nr1[nsmm_rsh]
print @n.xbgr.xr82_u20.nr1[nsmm_w]
print @n.xbgr.xr82_u20.nr1[nsmm_l]
print @n.xbgr.xr82_u21.nr1[nsmm_rsh]
print @n.xbgr.xr82_u21.nr1[nsmm_w]
print @n.xbgr.xr82_u21.nr1[nsmm_l]
print @n.xbgr.xr82_u22.nr1[nsmm_rsh]
print @n.xbgr.xr82_u22.nr1[nsmm_w]
print @n.xbgr.xr82_u22.nr1[nsmm_l]
print @n.xbgr.xr82_u23.nr1[nsmm_rsh]
print @n.xbgr.xr82_u23.nr1[nsmm_w]
print @n.xbgr.xr82_u23.nr1[nsmm_l]
print @n.xbgr.xr82_u24.nr1[nsmm_rsh]
print @n.xbgr.xr82_u24.nr1[nsmm_w]
print @n.xbgr.xr82_u24.nr1[nsmm_l]
print @n.xbgr.xr83_u2.nr1[nsmm_rsh]
print @n.xbgr.xr83_u2.nr1[nsmm_w]
print @n.xbgr.xr83_u2.nr1[nsmm_l]
print @n.xbgr.xr83_u3.nr1[nsmm_rsh]
print @n.xbgr.xr83_u3.nr1[nsmm_w]
print @n.xbgr.xr83_u3.nr1[nsmm_l]
print @n.xbgr.xr83_u4.nr1[nsmm_rsh]
print @n.xbgr.xr83_u4.nr1[nsmm_w]
print @n.xbgr.xr83_u4.nr1[nsmm_l]
print @n.xbgr.xr83_u5.nr1[nsmm_rsh]
print @n.xbgr.xr83_u5.nr1[nsmm_w]
print @n.xbgr.xr83_u5.nr1[nsmm_l]
print @n.xbgr.xr83_u6.nr1[nsmm_rsh]
print @n.xbgr.xr83_u6.nr1[nsmm_w]
print @n.xbgr.xr83_u6.nr1[nsmm_l]
print @n.xbgr.xr83_u7.nr1[nsmm_rsh]
print @n.xbgr.xr83_u7.nr1[nsmm_w]
print @n.xbgr.xr83_u7.nr1[nsmm_l]
print @n.xbgr.xr83_u8.nr1[nsmm_rsh]
print @n.xbgr.xr83_u8.nr1[nsmm_w]
print @n.xbgr.xr83_u8.nr1[nsmm_l]
print @n.xbgr.xr83_u9.nr1[nsmm_rsh]
print @n.xbgr.xr83_u9.nr1[nsmm_w]
print @n.xbgr.xr83_u9.nr1[nsmm_l]
print @n.xbgr.xr83_u10.nr1[nsmm_rsh]
print @n.xbgr.xr83_u10.nr1[nsmm_w]
print @n.xbgr.xr83_u10.nr1[nsmm_l]
print @n.xbgr.xr83_u11.nr1[nsmm_rsh]
print @n.xbgr.xr83_u11.nr1[nsmm_w]
print @n.xbgr.xr83_u11.nr1[nsmm_l]
print @n.xbgr.xr83_u12.nr1[nsmm_rsh]
print @n.xbgr.xr83_u12.nr1[nsmm_w]
print @n.xbgr.xr83_u12.nr1[nsmm_l]
print @n.xbgr.xr83_u13.nr1[nsmm_rsh]
print @n.xbgr.xr83_u13.nr1[nsmm_w]
print @n.xbgr.xr83_u13.nr1[nsmm_l]
print @n.xbgr.xr83_u14.nr1[nsmm_rsh]
print @n.xbgr.xr83_u14.nr1[nsmm_w]
print @n.xbgr.xr83_u14.nr1[nsmm_l]
print @n.xbgr.xr83_u15.nr1[nsmm_rsh]
print @n.xbgr.xr83_u15.nr1[nsmm_w]
print @n.xbgr.xr83_u15.nr1[nsmm_l]
print @n.xbgr.xr83_u16.nr1[nsmm_rsh]
print @n.xbgr.xr83_u16.nr1[nsmm_w]
print @n.xbgr.xr83_u16.nr1[nsmm_l]
print @n.xbgr.xr83_u17.nr1[nsmm_rsh]
print @n.xbgr.xr83_u17.nr1[nsmm_w]
print @n.xbgr.xr83_u17.nr1[nsmm_l]
print @n.xbgr.xr83_u18.nr1[nsmm_rsh]
print @n.xbgr.xr83_u18.nr1[nsmm_w]
print @n.xbgr.xr83_u18.nr1[nsmm_l]
print @n.xbgr.xr83_u19.nr1[nsmm_rsh]
print @n.xbgr.xr83_u19.nr1[nsmm_w]
print @n.xbgr.xr83_u19.nr1[nsmm_l]
print @n.xbgr.xr83_u20.nr1[nsmm_rsh]
print @n.xbgr.xr83_u20.nr1[nsmm_w]
print @n.xbgr.xr83_u20.nr1[nsmm_l]
print @n.xbgr.xr83_u21.nr1[nsmm_rsh]
print @n.xbgr.xr83_u21.nr1[nsmm_w]
print @n.xbgr.xr83_u21.nr1[nsmm_l]
print @n.xbgr.xr83_u22.nr1[nsmm_rsh]
print @n.xbgr.xr83_u22.nr1[nsmm_w]
print @n.xbgr.xr83_u22.nr1[nsmm_l]
print @n.xbgr.xr83_u23.nr1[nsmm_rsh]
print @n.xbgr.xr83_u23.nr1[nsmm_w]
print @n.xbgr.xr83_u23.nr1[nsmm_l]
print @n.xbgr.xr83_u24.nr1[nsmm_rsh]
print @n.xbgr.xr83_u24.nr1[nsmm_w]
print @n.xbgr.xr83_u24.nr1[nsmm_l]
print @n.xbgr.xr84_u2.nr1[nsmm_rsh]
print @n.xbgr.xr84_u2.nr1[nsmm_w]
print @n.xbgr.xr84_u2.nr1[nsmm_l]
print @n.xbgr.xr84_u3.nr1[nsmm_rsh]
print @n.xbgr.xr84_u3.nr1[nsmm_w]
print @n.xbgr.xr84_u3.nr1[nsmm_l]
print @n.xbgr.xr84_u4.nr1[nsmm_rsh]
print @n.xbgr.xr84_u4.nr1[nsmm_w]
print @n.xbgr.xr84_u4.nr1[nsmm_l]
print @n.xbgr.xr84_u5.nr1[nsmm_rsh]
print @n.xbgr.xr84_u5.nr1[nsmm_w]
print @n.xbgr.xr84_u5.nr1[nsmm_l]
print @n.xbgr.xr84_u6.nr1[nsmm_rsh]
print @n.xbgr.xr84_u6.nr1[nsmm_w]
print @n.xbgr.xr84_u6.nr1[nsmm_l]
print @n.xbgr.xr84_u7.nr1[nsmm_rsh]
print @n.xbgr.xr84_u7.nr1[nsmm_w]
print @n.xbgr.xr84_u7.nr1[nsmm_l]
print @n.xbgr.xr84_u8.nr1[nsmm_rsh]
print @n.xbgr.xr84_u8.nr1[nsmm_w]
print @n.xbgr.xr84_u8.nr1[nsmm_l]
print @n.xbgr.xr84_u9.nr1[nsmm_rsh]
print @n.xbgr.xr84_u9.nr1[nsmm_w]
print @n.xbgr.xr84_u9.nr1[nsmm_l]
print @n.xbgr.xr84_u10.nr1[nsmm_rsh]
print @n.xbgr.xr84_u10.nr1[nsmm_w]
print @n.xbgr.xr84_u10.nr1[nsmm_l]
print @n.xbgr.xr84_u11.nr1[nsmm_rsh]
print @n.xbgr.xr84_u11.nr1[nsmm_w]
print @n.xbgr.xr84_u11.nr1[nsmm_l]
print @n.xbgr.xr84_u12.nr1[nsmm_rsh]
print @n.xbgr.xr84_u12.nr1[nsmm_w]
print @n.xbgr.xr84_u12.nr1[nsmm_l]
print @n.xbgr.xr84_u13.nr1[nsmm_rsh]
print @n.xbgr.xr84_u13.nr1[nsmm_w]
print @n.xbgr.xr84_u13.nr1[nsmm_l]
print @n.xbgr.xr84_u14.nr1[nsmm_rsh]
print @n.xbgr.xr84_u14.nr1[nsmm_w]
print @n.xbgr.xr84_u14.nr1[nsmm_l]
print @n.xbgr.xr84_u15.nr1[nsmm_rsh]
print @n.xbgr.xr84_u15.nr1[nsmm_w]
print @n.xbgr.xr84_u15.nr1[nsmm_l]
print @n.xbgr.xr84_u16.nr1[nsmm_rsh]
print @n.xbgr.xr84_u16.nr1[nsmm_w]
print @n.xbgr.xr84_u16.nr1[nsmm_l]
print @n.xbgr.xr84_u17.nr1[nsmm_rsh]
print @n.xbgr.xr84_u17.nr1[nsmm_w]
print @n.xbgr.xr84_u17.nr1[nsmm_l]
print @n.xbgr.xr84_u18.nr1[nsmm_rsh]
print @n.xbgr.xr84_u18.nr1[nsmm_w]
print @n.xbgr.xr84_u18.nr1[nsmm_l]
print @n.xbgr.xr84_u19.nr1[nsmm_rsh]
print @n.xbgr.xr84_u19.nr1[nsmm_w]
print @n.xbgr.xr84_u19.nr1[nsmm_l]
print @n.xbgr.xr84_u20.nr1[nsmm_rsh]
print @n.xbgr.xr84_u20.nr1[nsmm_w]
print @n.xbgr.xr84_u20.nr1[nsmm_l]
print @n.xbgr.xr84_u21.nr1[nsmm_rsh]
print @n.xbgr.xr84_u21.nr1[nsmm_w]
print @n.xbgr.xr84_u21.nr1[nsmm_l]
print @n.xbgr.xr84_u22.nr1[nsmm_rsh]
print @n.xbgr.xr84_u22.nr1[nsmm_w]
print @n.xbgr.xr84_u22.nr1[nsmm_l]
print @n.xbgr.xr84_u23.nr1[nsmm_rsh]
print @n.xbgr.xr84_u23.nr1[nsmm_w]
print @n.xbgr.xr84_u23.nr1[nsmm_l]
print @n.xbgr.xr84_u24.nr1[nsmm_rsh]
print @n.xbgr.xr84_u24.nr1[nsmm_w]
print @n.xbgr.xr84_u24.nr1[nsmm_l]
print @n.xbgr.xr85_u2.nr1[nsmm_rsh]
print @n.xbgr.xr85_u2.nr1[nsmm_w]
print @n.xbgr.xr85_u2.nr1[nsmm_l]
print @n.xbgr.xr85_u3.nr1[nsmm_rsh]
print @n.xbgr.xr85_u3.nr1[nsmm_w]
print @n.xbgr.xr85_u3.nr1[nsmm_l]
print @n.xbgr.xr85_u4.nr1[nsmm_rsh]
print @n.xbgr.xr85_u4.nr1[nsmm_w]
print @n.xbgr.xr85_u4.nr1[nsmm_l]
print @n.xbgr.xr85_u5.nr1[nsmm_rsh]
print @n.xbgr.xr85_u5.nr1[nsmm_w]
print @n.xbgr.xr85_u5.nr1[nsmm_l]
print @n.xbgr.xr85_u6.nr1[nsmm_rsh]
print @n.xbgr.xr85_u6.nr1[nsmm_w]
print @n.xbgr.xr85_u6.nr1[nsmm_l]
print @n.xbgr.xr85_u7.nr1[nsmm_rsh]
print @n.xbgr.xr85_u7.nr1[nsmm_w]
print @n.xbgr.xr85_u7.nr1[nsmm_l]
print @n.xbgr.xr85_u8.nr1[nsmm_rsh]
print @n.xbgr.xr85_u8.nr1[nsmm_w]
print @n.xbgr.xr85_u8.nr1[nsmm_l]
print @n.xbgr.xr85_u9.nr1[nsmm_rsh]
print @n.xbgr.xr85_u9.nr1[nsmm_w]
print @n.xbgr.xr85_u9.nr1[nsmm_l]
print @n.xbgr.xr85_u10.nr1[nsmm_rsh]
print @n.xbgr.xr85_u10.nr1[nsmm_w]
print @n.xbgr.xr85_u10.nr1[nsmm_l]
print @n.xbgr.xr85_u11.nr1[nsmm_rsh]
print @n.xbgr.xr85_u11.nr1[nsmm_w]
print @n.xbgr.xr85_u11.nr1[nsmm_l]
print @n.xbgr.xr85_u12.nr1[nsmm_rsh]
print @n.xbgr.xr85_u12.nr1[nsmm_w]
print @n.xbgr.xr85_u12.nr1[nsmm_l]
print @n.xbgr.xr85_u13.nr1[nsmm_rsh]
print @n.xbgr.xr85_u13.nr1[nsmm_w]
print @n.xbgr.xr85_u13.nr1[nsmm_l]
print @n.xbgr.xr85_u14.nr1[nsmm_rsh]
print @n.xbgr.xr85_u14.nr1[nsmm_w]
print @n.xbgr.xr85_u14.nr1[nsmm_l]
print @n.xbgr.xr85_u15.nr1[nsmm_rsh]
print @n.xbgr.xr85_u15.nr1[nsmm_w]
print @n.xbgr.xr85_u15.nr1[nsmm_l]
print @n.xbgr.xr85_u16.nr1[nsmm_rsh]
print @n.xbgr.xr85_u16.nr1[nsmm_w]
print @n.xbgr.xr85_u16.nr1[nsmm_l]
print @n.xbgr.xr85_u17.nr1[nsmm_rsh]
print @n.xbgr.xr85_u17.nr1[nsmm_w]
print @n.xbgr.xr85_u17.nr1[nsmm_l]
print @n.xbgr.xr85_u18.nr1[nsmm_rsh]
print @n.xbgr.xr85_u18.nr1[nsmm_w]
print @n.xbgr.xr85_u18.nr1[nsmm_l]
print @n.xbgr.xr85_u19.nr1[nsmm_rsh]
print @n.xbgr.xr85_u19.nr1[nsmm_w]
print @n.xbgr.xr85_u19.nr1[nsmm_l]
print @n.xbgr.xr85_u20.nr1[nsmm_rsh]
print @n.xbgr.xr85_u20.nr1[nsmm_w]
print @n.xbgr.xr85_u20.nr1[nsmm_l]
print @n.xbgr.xr85_u21.nr1[nsmm_rsh]
print @n.xbgr.xr85_u21.nr1[nsmm_w]
print @n.xbgr.xr85_u21.nr1[nsmm_l]
print @n.xbgr.xr85_u22.nr1[nsmm_rsh]
print @n.xbgr.xr85_u22.nr1[nsmm_w]
print @n.xbgr.xr85_u22.nr1[nsmm_l]
print @n.xbgr.xr85_u23.nr1[nsmm_rsh]
print @n.xbgr.xr85_u23.nr1[nsmm_w]
print @n.xbgr.xr85_u23.nr1[nsmm_l]
print @n.xbgr.xr85_u24.nr1[nsmm_rsh]
print @n.xbgr.xr85_u24.nr1[nsmm_w]
print @n.xbgr.xr85_u24.nr1[nsmm_l]
print @n.xbgr.xr86_u2.nr1[nsmm_rsh]
print @n.xbgr.xr86_u2.nr1[nsmm_w]
print @n.xbgr.xr86_u2.nr1[nsmm_l]
print @n.xbgr.xr86_u3.nr1[nsmm_rsh]
print @n.xbgr.xr86_u3.nr1[nsmm_w]
print @n.xbgr.xr86_u3.nr1[nsmm_l]
print @n.xbgr.xr86_u4.nr1[nsmm_rsh]
print @n.xbgr.xr86_u4.nr1[nsmm_w]
print @n.xbgr.xr86_u4.nr1[nsmm_l]
print @n.xbgr.xr86_u5.nr1[nsmm_rsh]
print @n.xbgr.xr86_u5.nr1[nsmm_w]
print @n.xbgr.xr86_u5.nr1[nsmm_l]
print @n.xbgr.xr86_u6.nr1[nsmm_rsh]
print @n.xbgr.xr86_u6.nr1[nsmm_w]
print @n.xbgr.xr86_u6.nr1[nsmm_l]
print @n.xbgr.xr86_u7.nr1[nsmm_rsh]
print @n.xbgr.xr86_u7.nr1[nsmm_w]
print @n.xbgr.xr86_u7.nr1[nsmm_l]
print @n.xbgr.xr86_u8.nr1[nsmm_rsh]
print @n.xbgr.xr86_u8.nr1[nsmm_w]
print @n.xbgr.xr86_u8.nr1[nsmm_l]
print @n.xbgr.xr86_u9.nr1[nsmm_rsh]
print @n.xbgr.xr86_u9.nr1[nsmm_w]
print @n.xbgr.xr86_u9.nr1[nsmm_l]
print @n.xbgr.xr86_u10.nr1[nsmm_rsh]
print @n.xbgr.xr86_u10.nr1[nsmm_w]
print @n.xbgr.xr86_u10.nr1[nsmm_l]
print @n.xbgr.xr86_u11.nr1[nsmm_rsh]
print @n.xbgr.xr86_u11.nr1[nsmm_w]
print @n.xbgr.xr86_u11.nr1[nsmm_l]
print @n.xbgr.xr86_u12.nr1[nsmm_rsh]
print @n.xbgr.xr86_u12.nr1[nsmm_w]
print @n.xbgr.xr86_u12.nr1[nsmm_l]
print @n.xbgr.xr86_u13.nr1[nsmm_rsh]
print @n.xbgr.xr86_u13.nr1[nsmm_w]
print @n.xbgr.xr86_u13.nr1[nsmm_l]
print @n.xbgr.xr86_u14.nr1[nsmm_rsh]
print @n.xbgr.xr86_u14.nr1[nsmm_w]
print @n.xbgr.xr86_u14.nr1[nsmm_l]
print @n.xbgr.xr86_u15.nr1[nsmm_rsh]
print @n.xbgr.xr86_u15.nr1[nsmm_w]
print @n.xbgr.xr86_u15.nr1[nsmm_l]
print @n.xbgr.xr86_u16.nr1[nsmm_rsh]
print @n.xbgr.xr86_u16.nr1[nsmm_w]
print @n.xbgr.xr86_u16.nr1[nsmm_l]
print @n.xbgr.xr86_u17.nr1[nsmm_rsh]
print @n.xbgr.xr86_u17.nr1[nsmm_w]
print @n.xbgr.xr86_u17.nr1[nsmm_l]
print @n.xbgr.xr86_u18.nr1[nsmm_rsh]
print @n.xbgr.xr86_u18.nr1[nsmm_w]
print @n.xbgr.xr86_u18.nr1[nsmm_l]
print @n.xbgr.xr86_u19.nr1[nsmm_rsh]
print @n.xbgr.xr86_u19.nr1[nsmm_w]
print @n.xbgr.xr86_u19.nr1[nsmm_l]
print @n.xbgr.xr86_u20.nr1[nsmm_rsh]
print @n.xbgr.xr86_u20.nr1[nsmm_w]
print @n.xbgr.xr86_u20.nr1[nsmm_l]
print @n.xbgr.xr86_u21.nr1[nsmm_rsh]
print @n.xbgr.xr86_u21.nr1[nsmm_w]
print @n.xbgr.xr86_u21.nr1[nsmm_l]
print @n.xbgr.xr86_u22.nr1[nsmm_rsh]
print @n.xbgr.xr86_u22.nr1[nsmm_w]
print @n.xbgr.xr86_u22.nr1[nsmm_l]
print @n.xbgr.xr86_u23.nr1[nsmm_rsh]
print @n.xbgr.xr86_u23.nr1[nsmm_w]
print @n.xbgr.xr86_u23.nr1[nsmm_l]
print @n.xbgr.xr86_u24.nr1[nsmm_rsh]
print @n.xbgr.xr86_u24.nr1[nsmm_w]
print @n.xbgr.xr86_u24.nr1[nsmm_l]
set numdgt=17
echo METALLIC_POINT_VOLTAGES_BEGIN
print v(xbgr.mr_n86935104)
print v(xbgr.vd2)
print v(xbgr.mr_n86152496)
print v(xbgr.c2)
print v(xbgr.mr_n87222224)
print v(xbgr.mr_n87323152)
print v(xbgr.mr_n87311024)
print v(xbgr.mr_n87495616)
print v(xbgr.mr_n87672544)
print v(xbgr.mr_n87810256)
print v(xbgr.mr_n87982224)
print v(xbgr.mr_n88106976)
print v(xbgr.mr_n88272144)
print v(xbgr.mr_n88398432)
print v(xbgr.mr_n88425616)
print v(xbgr.mr_n88713488)
print v(xbgr.mr_n88803072)
print v(xbgr.mr_n88866224)
print v(xbgr.mr_n85963088)
print v(xbgr.mr_n89479456)
print v(xbgr.mr_n89652000)
print v(xbgr.mr_n89849712)
print v(xbgr.mr_n90015392)
print v(xbgr.mr_n90201248)
print v(xbgr.mr_n90361328)
print v(xbgr.mr_n90567808)
print v(xbgr.mr_n90781760)
print v(xbgr.mr_n87809584)
print v(xbgr.mr_n90860128)
print v(xbgr.mr_n91142528)
print v(xbgr.mr_n91335776)
print v(xbgr.mr_n91552112)
print v(xbgr.mr_n91733632)
print v(xbgr.mr_n92038816)
print v(xbgr.mr_n92243264)
print v(xbgr.mr_n92476528)
print v(xbgr.mr_n92810896)
print v(xbgr.mr_n86935552)
print v(xbgr.mr_n86998992)
print v(xbgr.b1b)
print v(xbgr.mr_n87081872)
print v(xbgr.mr_n87179312)
print v(xbgr.mr_n87289936)
print v(xbgr.mr_n87385232)
print v(xbgr.mr_n87497536)
print v(xbgr.mr_n87610784)
print v(xbgr.mr_n87951936)
print v(xbgr.mr_n88069376)
print v(xbgr.mr_n88201568)
print v(xbgr.mr_n88301792)
print v(xbgr.mr_n88476512)
print v(xbgr.mr_n88590784)
print v(xbgr.mr_n88743792)
print v(xbgr.mr_n88992928)
print v(xbgr.mr_n86970368)
print v(xbgr.mr_n87031872)
print v(xbgr.mr_n86853712)
print v(xbgr.mr_n87167184)
print v(xbgr.mr_n87267904)
print v(xbgr.mr_n87383520)
print v(xbgr.mr_n87440512)
print v(xbgr.mr_n87588544)
print v(xbgr.mr_n87693168)
print v(xbgr.mr_n87743120)
print v(xbgr.mr_n87997232)
print v(xbgr.mr_n88116928)
print v(xbgr.mr_n88278432)
print v(xbgr.mr_n88398544)
print v(xbgr.mr_n88599152)
print v(xbgr.mr_n88715792)
print v(xbgr.mr_n88822528)
print v(xbgr.mr_n88994976)
print v(xbgr.mr_n86201328)
print v(xbgr.mr_n86464688)
print v(xbgr.n_13)
print v(xbgr.n_24)
print v(xbgr.mr_n86199456)
print v(xbgr.mr_n86297328)
print v(xbgr.n_14)
print v(xbgr.mr_n86809840)
print v(xbgr.mr_n86918944)
print v(xbgr.mr_n86999184)
print v(xbgr.mr_n86776272)
print v(xbgr.mr_n87146208)
print v(xbgr.mr_n87224896)
print v(xbgr.mr_n87305888)
print v(xbgr.mr_n87431776)
print v(xbgr.vd1)
print v(xbgr.mr_n87672656)
print v(xbgr.mr_n87814192)
print v(xbgr.mr_n87920368)
print v(xbgr.mr_n88046704)
print v(xbgr.mr_n88278848)
print v(xbgr.mr_n88401424)
print v(xbgr.mr_n88511440)
print v(xbgr.mr_n88713152)
print v(xbgr.mr_n88821536)
print v(xbgr.mr_n88993600)
print v(xbgr.mr_n89336448)
print v(xbgr.mr_n89480720)
print v(xbgr.mr_n89656144)
print v(xbgr.mr_n89849904)
print v(xbgr.mr_n90016528)
print v(xbgr.mr_n90199024)
print v(xbgr.mr_n90402384)
print v(xbgr.mr_n90564624)
print v(xbgr.mr_n90779088)
print v(xbgr.mr_n87813376)
print v(xbgr.mr_n90865664)
print v(xbgr.mr_n91157872)
print v(xbgr.mr_n91335584)
print v(xbgr.mr_n91553376)
print v(xbgr.mr_n91741104)
print v(xbgr.mr_n91948800)
print v(xbgr.mr_n92244256)
print v(xbgr.mr_n92475952)
print v(xbgr.mr_n92813728)
print v(xbgr.mr_n86936128)
print v(xbgr.mr_n87000128)
print v(xbgr.mr_n86219536)
print v(xbgr.mr_n87108016)
print v(xbgr.mr_n87180704)
print v(xbgr.mr_n87293712)
print v(xbgr.mr_n87381296)
print v(xbgr.mr_n87552176)
print v(xbgr.mr_n87612784)
print v(xbgr.mr_n87953328)
print v(xbgr.mr_n88070768)
print v(xbgr.mr_n88202960)
print v(xbgr.mr_n88350032)
print v(xbgr.mr_n88477968)
print v(xbgr.mr_n88597040)
print v(xbgr.mr_n88731136)
print v(xbgr.mr_n88855968)
print v(xbgr.mr_n86202256)
print v(xbgr.mr_n86135936)
print v(xbgr.mr_n86695024)
print v(xbgr.n_26)
print v(xbgr.mr_n86201792)
print v(xbgr.mr_n86225552)
print v(xbgr.n_15)
print v(xbgr.mr_n86811280)
print v(xbgr.mr_n86971744)
print v(xbgr.mr_n87022496)
print v(xbgr.mr_n86853056)
print v(xbgr.mr_n87168624)
print v(xbgr.mr_n87268704)
print v(xbgr.mr_n87384432)
print v(xbgr.mr_n87365040)
print v(xbgr.mr_n87589808)
print v(xbgr.mr_n87694960)
print v(xbgr.mr_n87825600)
print v(xbgr.mr_n87999168)
print v(xbgr.mr_n88107424)
print v(xbgr.mr_n88293792)
print v(xbgr.mr_n88415392)
print v(xbgr.mr_n88600368)
print v(xbgr.mr_n88646624)
print v(xbgr.mr_n88801888)
print v(xbgr.mr_n88868400)
print v(xbgr.mr_n86203184)
print v(xbgr.mr_n86412304)
print v(xbgr.mr_n86695952)
print v(xbgr.n_27)
print v(xbgr.mr_n86202720)
print v(xbgr.mr_n86469040)
print v(xbgr.n_16)
print v(xbgr.mr_n86812720)
print v(xbgr.mr_n86204112)
print v(xbgr.mr_n86469712)
print v(xbgr.mr_n86696416)
print v(xbgr.n_21)
print v(xbgr.mr_n86935744)
print v(xbgr.mr_n86998800)
print v(xbgr.mr_n86153632)
print v(xbgr.mr_n87167888)
print v(xbgr.mr_n87134544)
print v(xbgr.mr_n87323856)
print v(xbgr.mr_n87444368)
print v(xbgr.mr_n87551664)
print v(xbgr.mr_n87676976)
print v(xbgr.mr_n87922448)
print v(xbgr.mr_n88042000)
print v(xbgr.mr_n88293616)
print v(xbgr.mr_n88399248)
print v(xbgr.mr_n88509024)
print v(xbgr.mr_n88712976)
print v(xbgr.mr_n88823152)
print v(xbgr.mr_n88993264)
print v(xbgr.mr_n86203648)
print v(xbgr.mr_n86468448)
print v(xbgr.mr_n89346464)
print v(xbgr.mr_n89513696)
print v(xbgr.mr_n89729504)
print v(xbgr.mr_n89842032)
print v(xbgr.mr_n90016640)
print v(xbgr.mr_n90000384)
print v(xbgr.mr_n90360384)
print v(xbgr.mr_n90549776)
print v(xbgr.mr_n90783584)
print v(xbgr.mr_n91126304)
print v(xbgr.mr_n91351120)
print v(xbgr.mr_n91558976)
print v(xbgr.mr_n91746080)
print v(xbgr.mr_n92052960)
print v(xbgr.mr_n92244368)
print v(xbgr.mr_n92455968)
print v(xbgr.mr_n92824944)
print v(xbgr.mr_n86941888)
print v(xbgr.mr_n87018448)
print v(xbgr.mr_n86229200)
print v(xbgr.mr_n87109408)
print v(xbgr.mr_n87182064)
print v(xbgr.mr_n87274544)
print v(xbgr.mr_n87421456)
print v(xbgr.mr_n87554144)
print v(xbgr.mr_n87626576)
print v(xbgr.mr_n87952864)
print v(xbgr.mr_n88072160)
print v(xbgr.mr_n88204352)
print v(xbgr.mr_n88351808)
print v(xbgr.mr_n88479744)
print v(xbgr.mr_n88601376)
print v(xbgr.mr_n88772176)
print v(xbgr.mr_n88995488)
print v(xbgr.mr_n86205040)
print v(xbgr.mr_n86470960)
print v(xbgr.n_8)
print v(xbgr.vbe3)
print v(xbgr.mr_n86973280)
print v(xbgr.mr_n87031216)
print v(xbgr.mr_n86337792)
print v(xbgr.mr_n87169504)
print v(xbgr.mr_n87269504)
print v(xbgr.mr_n87384832)
print v(xbgr.mr_n87432160)
print v(xbgr.mr_n87590688)
print v(xbgr.mr_n87695840)
print v(xbgr.mr_n88000976)
print v(xbgr.mr_n88118912)
print v(xbgr.mr_n88294592)
print v(xbgr.mr_n88416192)
print v(xbgr.mr_n88601888)
print v(xbgr.mr_n88651760)
print v(xbgr.mr_n88804848)
print v(xbgr.mr_n88993936)
print v(xbgr.mr_n86204576)
print v(xbgr.mr_n86472016)
print v(xbgr.mr_n86545456)
print v(xbgr.mr_n86857952)
print v(xbgr.mr_n86205968)
print v(xbgr.mr_n86467280)
print v(xbgr.mr_n86545696)
print v(xbgr.n_37)
print v(xbgr.mr_n86205504)
print v(xbgr.mr_n86467936)
print v(xbgr.mr_n86545936)
print v(xbgr.mr_n86858880)
print v(xbgr.n_6)
print v(xbgr.vb2)
print v(xbgr.n_2)
print v(xbgr.mr_n86859344)
print v(xbgr.mr_n86921344)
print v(xbgr.mr_n87019152)
print v(xbgr.mr_n86846656)
print v(xbgr.mr_n87147184)
print v(xbgr.mr_n87228544)
print v(xbgr.mr_n87349552)
print v(xbgr.mr_n87437104)
print v(xbgr.mr_n87551920)
print v(xbgr.mr_n87672848)
print v(xbgr.mr_n87923328)
print v(xbgr.mr_n88117984)
print v(xbgr.mr_n88275440)
print v(xbgr.mr_n88381712)
print v(xbgr.mr_n88577328)
print v(xbgr.mr_n88716608)
print v(xbgr.mr_n88803664)
print v(xbgr.mr_n88995600)
print v(xbgr.mr_n85247856)
print v(xbgr.mr_n89517440)
print v(xbgr.mr_n89737328)
print v(xbgr.mr_n89841280)
print v(xbgr.mr_n90008256)
print v(xbgr.mr_n90211552)
print v(xbgr.mr_n90408544)
print v(xbgr.mr_n90563488)
print v(xbgr.mr_n90788560)
print v(xbgr.mr_n91139184)
print v(xbgr.mr_n91309152)
print v(xbgr.mr_n91563840)
print v(xbgr.mr_n91751056)
print v(xbgr.mr_n92053072)
print v(xbgr.mr_n92235856)
print v(xbgr.mr_n92476336)
print v(xbgr.mr_n92812784)
print v(xbgr.mr_n86308416)
print v(xbgr.mr_n86343232)
print v(xbgr.mr_n86546656)
print v(xbgr.mr_n86859808)
print v(xbgr.mr_n86942800)
print v(xbgr.mr_n87019328)
print v(xbgr.mr_n86380384)
print v(xbgr.mr_n87110800)
print v(xbgr.mr_n87183456)
print v(xbgr.mr_n87298800)
print v(xbgr.mr_n87422608)
print v(xbgr.mr_n87577600)
print v(xbgr.mr_n87627968)
print v(xbgr.mr_n87952400)
print v(xbgr.mr_n88073872)
print v(xbgr.mr_n88206064)
print v(xbgr.mr_n88353584)
print v(xbgr.mr_n88481520)
print v(xbgr.mr_n88597712)
print v(xbgr.mr_n88773568)
print v(xbgr.mr_n88997552)
print v(xbgr.mr_n86309152)
print v(xbgr.mr_n86319328)
print v(xbgr.n_7)
print v(xbgr.n_36)
print v(xbgr.mr_n86974336)
print v(xbgr.mr_n87033312)
print v(xbgr.mr_n87036976)
print v(xbgr.mr_n87170464)
print v(xbgr.mr_n87270224)
print v(xbgr.mr_n87380624)
print v(xbgr.mr_n87442592)
print v(xbgr.mr_n87591248)
print v(xbgr.mr_n87696640)
print v(xbgr.mr_n88002784)
print v(xbgr.mr_n88122688)
print v(xbgr.mr_n88295392)
print v(xbgr.mr_n88416992)
print v(xbgr.mr_n88603312)
print v(xbgr.mr_n88713824)
print v(xbgr.mr_n88824848)
print v(xbgr.mr_n88995712)
print v(xbgr.mr_n86309888)
print v(xbgr.mr_n86344416)
print v(xbgr.mr_n86547456)
print v(xbgr.mr_n86860768)
print v(xbgr.mr_n86310624)
print v(xbgr.mr_n86345088)
print v(xbgr.mr_n86547856)
print v(xbgr.mr_n86861360)
print v(xbgr.mr_n86311360)
print v(xbgr.mr_n86341760)
print v(xbgr.mr_n86548256)
print v(xbgr.mr_n86520944)
print v(xbgr.mr_n86312096)
print v(xbgr.mr_n86317696)
print v(xbgr.mr_n86548656)
print v(xbgr.mr_n86862544)
print v(xbgr.mr_n86935936)
print v(xbgr.mr_n87020208)
print v(xbgr.mr_n87036576)
print v(xbgr.mr_n87169328)
print v(xbgr.mr_n87229872)
print v(xbgr.mr_n87350352)
print v(xbgr.mr_n87308448)
print v(xbgr.mr_n87498752)
print v(xbgr.mr_n87694624)
print v(xbgr.mr_n87982928)
print v(xbgr.mr_n88109840)
print v(xbgr.mr_n88278960)
print v(xbgr.mr_n88401952)
print v(xbgr.mr_n88578512)
print v(xbgr.mr_n88718368)
print v(xbgr.mr_n88824960)
print v(xbgr.mr_n89001904)
print v(xbgr.mr_n89346272)
print v(xbgr.mr_n89461168)
print v(xbgr.mr_n85289440)
print v(xbgr.mr_n89855840)
print v(xbgr.mr_n89961264)
print v(xbgr.mr_n85514240)
print v(xbgr.mr_n90397408)
print v(xbgr.mr_n90570352)
print v(xbgr.mr_n90793536)
print v(xbgr.mr_n91158784)
print v(xbgr.mr_n91350656)
print v(xbgr.mr_n91568352)
print v(xbgr.mr_n91756032)
print v(xbgr.mr_n92060496)
print v(xbgr.mr_n92246336)
print v(xbgr.mr_n92385120)
print v(xbgr.mr_n92824496)
print v(xbgr.mr_n86946880)
print v(xbgr.mr_n87020560)
print v(xbgr.mr_n86327616)
print v(xbgr.mr_n87112192)
print v(xbgr.mr_n87184848)
print v(xbgr.mr_n87274736)
print v(xbgr.mr_n87424000)
print v(xbgr.mr_n87579072)
print v(xbgr.mr_n87629360)
print v(xbgr.mr_n87982416)
print v(xbgr.mr_n88075648)
print v(xbgr.mr_n88207840)
print v(xbgr.mr_n88355360)
print v(xbgr.mr_n88483296)
print v(xbgr.mr_n88600880)
print v(xbgr.mr_n88775088)
print v(xbgr.mr_n88867312)
print v(xbgr.mr_n86312608)
print v(xbgr.mr_n86343904)
print v(xbgr.mr_n86549056)
print v(xbgr.mr_n86863728)
print v(xbgr.mr_n86313152)
print v(xbgr.mr_n86347376)
print v(xbgr.n_11)
print v(xbgr.mr_n86863136)
print v(xbgr.mr_n86965904)
print v(xbgr.mr_n87033712)
print v(xbgr.mr_n87040624)
print v(xbgr.mr_n87145456)
print v(xbgr.mr_n87271024)
print v(xbgr.mr_n87385632)
print v(xbgr.mr_n87450032)
print v(xbgr.mr_n87582784)
print v(xbgr.mr_n87697440)
print v(xbgr.mr_n88004848)
print v(xbgr.mr_n88124496)
print v(xbgr.mr_n88296192)
print v(xbgr.mr_n88417792)
print v(xbgr.mr_n88605376)
print v(xbgr.mr_n88718480)
print v(xbgr.mr_n88804256)
print v(xbgr.mr_n88997776)
print v(xbgr.mr_n86313648)
print v(xbgr.mr_n86348048)
print v(xbgr.mr_n86628608)
print v(xbgr.mr_n86864320)
print v(xbgr.mr_n86314704)
print v(xbgr.mr_n86345680)
print v(xbgr.mr_n86629200)
print v(xbgr.mr_n86864912)
print v(xbgr.mr_n86311872)
print v(xbgr.mr_n86349152)
print v(xbgr.mr_n86629792)
print v(xbgr.mr_n86865504)
print v(xbgr.mr_n86941136)
print v(xbgr.mr_n87021264)
print v(xbgr.mr_n86910720)
print v(xbgr.mr_n87169152)
print v(xbgr.mr_n87234688)
print v(xbgr.mr_n87351152)
print v(xbgr.mr_n87450672)
print v(xbgr.mr_n87578336)
print v(xbgr.mr_n87695664)
print v(xbgr.mr_n87982672)
print v(xbgr.mr_n88077664)
print v(xbgr.mr_n88296016)
print v(xbgr.mr_n88415216)
print v(xbgr.mr_n88579696)
print v(xbgr.mr_n88720288)
print v(xbgr.mr_n88826656)
print v(xbgr.mr_n88999840)
print v(xbgr.n_9)
print v(xbgr.mr_n86349824)
print v(xbgr.mr_n86629536)
print v(xbgr.mr_n86866096)
print v(xbgr.mr_n89350624)
print v(xbgr.mr_n89521392)
print v(xbgr.mr_n89734608)
print v(xbgr.mr_n89862704)
print v(xbgr.mr_n90015584)
print v(xbgr.mr_n90222688)
print v(xbgr.mr_n90422624)
print v(xbgr.mr_n90564816)
print v(xbgr.mr_n90798512)
print v(xbgr.mr_n91169488)
print v(xbgr.mr_n91365168)
print v(xbgr.mr_n91573248)
print v(xbgr.mr_n91761008)
print v(xbgr.mr_n92072864)
print v(xbgr.mr_n92250992)
print v(xbgr.mr_n92503856)
print v(xbgr.mr_n92729520)
print v(xbgr.mr_n86947792)
print v(xbgr.mr_n87021616)
print v(xbgr.mr_n86207680)
print v(xbgr.mr_n87113584)
print v(xbgr.mr_n87186240)
print v(xbgr.mr_n87294752)
print v(xbgr.mr_n87425392)
print v(xbgr.mr_n87580000)
print v(xbgr.mr_n87630752)
print v(xbgr.mr_n87999680)
print v(xbgr.mr_n88077424)
print v(xbgr.mr_n88209616)
print v(xbgr.mr_n88357136)
print v(xbgr.mr_n88485072)
print v(xbgr.mr_n88603936)
print v(xbgr.mr_n88776864)
print v(xbgr.mr_n89003744)
print v(xbgr.mr_n86316064)
print v(xbgr.mr_n86350416)
print v(xbgr.mr_n86623344)
print v(xbgr.mr_n86866688)
print v(xbgr.mr_n86977248)
print v(xbgr.mr_n87034112)
print v(xbgr.mr_n87042432)
print v(xbgr.mr_n87100080)
print v(xbgr.mr_n87271824)
print v(xbgr.mr_n87386032)
print v(xbgr.mr_n87447648)
print v(xbgr.mr_n87592944)
print v(xbgr.mr_n87698240)
print v(xbgr.mr_n88006832)
print v(xbgr.mr_n88126304)
print v(xbgr.mr_n88296992)
print v(xbgr.mr_n88418592)
print v(xbgr.mr_n88607056)
print v(xbgr.mr_n88722096)
print v(xbgr.mr_n88821872)
print v(xbgr.mr_n88999616)
print v(xbgr.mr_n86313424)
print v(xbgr.mr_n86326128)
print v(xbgr.mr_n86630496)
print v(xbgr.mr_n86867280)
print v(xbgr.mr_n86317152)
print v(xbgr.mr_n86348640)
print v(xbgr.mr_n86630880)
print v(xbgr.mr_n86867872)
print v(xbgr.mr_n86316608)
print v(xbgr.mr_n86352112)
print v(xbgr.mr_n86631728)
print v(xbgr.mr_n86868464)
print v(xbgr.mr_n86318240)
print v(xbgr.mr_n86352784)
print v(xbgr.mr_n86632480)
print v(xbgr.mr_n86869056)
print v(xbgr.mr_n86943552)
print v(xbgr.mr_n87022320)
print v(xbgr.mr_n86909792)
print v(xbgr.mr_n86210720)
print v(xbgr.mr_n87236016)
print v(xbgr.mr_n87352016)
print v(xbgr.mr_n87452480)
print v(xbgr.mr_n87579424)
print v(xbgr.mr_n87698064)
print v(xbgr.mr_n88005360)
print v(xbgr.mr_n88117872)
print v(xbgr.mr_n88265328)
print v(xbgr.mr_n88417616)
print v(xbgr.mr_n88580880)
print v(xbgr.mr_n88716496)
print v(xbgr.mr_n88802480)
print v(xbgr.mr_n89003968)
print v(xbgr.mr_n89354560)
print v(xbgr.mr_n89525936)
print v(xbgr.mr_n89755872)
print v(xbgr.mr_n89876864)
print v(xbgr.mr_n90047776)
print v(xbgr.mr_n90211360)
print v(xbgr.mr_n90416320)
print v(xbgr.mr_n90579600)
print v(xbgr.mr_n90811552)
print v(xbgr.mr_n91174192)
print v(xbgr.mr_n91380176)
print v(xbgr.mr_n91578144)
print v(xbgr.mr_n91765984)
print v(xbgr.mr_n92089680)
print v(xbgr.mr_n92275312)
print v(xbgr.mr_n92480544)
print v(xbgr.mr_n92578496)
print v(xbgr.mr_n86318784)
print v(xbgr.mr_n86353376)
print v(xbgr.mr_n86633072)
print v(xbgr.mr_n86869648)
print v(xbgr.mr_n86951872)
print v(xbgr.mr_n87022672)
print v(xbgr.mr_n86365728)
print v(xbgr.mr_n87114976)
print v(xbgr.mr_n87185776)
print v(xbgr.mr_n87302384)
print v(xbgr.mr_n87424928)
print v(xbgr.mr_n87580992)
print v(xbgr.mr_n87632144)
print v(xbgr.mr_n88006256)
print v(xbgr.mr_n88076832)
print v(xbgr.mr_n88209024)
print v(xbgr.mr_n88358912)
print v(xbgr.mr_n88484480)
print v(xbgr.mr_n88607568)
print v(xbgr.mr_n88778640)
print v(xbgr.mr_n89001792)
print v(xbgr.mr_n86319600)
print v(xbgr.mr_n86353968)
print v(xbgr.mr_n86633664)
print v(xbgr.mr_n86813328)
print v(xbgr.mr_n86979104)
print v(xbgr.mr_n87034512)
print v(xbgr.mr_n87044240)
print v(xbgr.mr_n86576752)
print v(xbgr.mr_n87272624)
print v(xbgr.mr_n87386432)
print v(xbgr.mr_n87454944)
print v(xbgr.mr_n87593920)
print v(xbgr.mr_n87699040)
print v(xbgr.mr_n88008976)
print v(xbgr.mr_n87753152)
print v(xbgr.mr_n88295216)
print v(xbgr.mr_n88419392)
print v(xbgr.mr_n88608800)
print v(xbgr.mr_n88720176)
print v(xbgr.mr_n88830272)
print v(xbgr.mr_n89001680)
print v(xbgr.mr_n86314976)
print v(xbgr.mr_n86354560)
print v(xbgr.n_3)
print v(xbgr.n_33)
print v(xbgr.mr_n86320416)
print v(xbgr.mr_n86355152)
print v(xbgr.mr_n86634848)
print v(xbgr.mr_n86871424)
print v(xbgr.mr_n86321024)
print v(xbgr.mr_n86346864)
print v(xbgr.mr_n86635440)
print v(xbgr.mr_n86872016)
print v(xbgr.mr_n86322416)
print v(xbgr.mr_n86356256)
print v(xbgr.mr_n86636032)
print v(xbgr.mr_n86657344)
print v(xbgr.mr_n86946128)
print v(xbgr.mr_n87030208)
print v(xbgr.mr_n87041136)
print v(xbgr.mr_n87135200)
print v(xbgr.mr_n87240832)
print v(xbgr.mr_n87353200)
print v(xbgr.mr_n87455840)
print v(xbgr.mr_n87579888)
print v(xbgr.mr_n87696464)
print v(xbgr.mr_n87867152)
print v(xbgr.mr_n87875216)
print v(xbgr.mr_n88042976)
print v(xbgr.mr_n88276256)
print v(xbgr.mr_n88419216)
print v(xbgr.mr_n88582064)
print v(xbgr.mr_n88669696)
print v(xbgr.mr_n88830384)
print v(xbgr.mr_n89003856)
print v(xbgr.mr_n89352304)
print v(xbgr.mr_n89546976)
print v(xbgr.mr_n89737136)
print v(xbgr.mr_n89877328)
print v(xbgr.mr_n90018608)
print v(xbgr.mr_n90228656)
print v(xbgr.mr_n90434240)
print v(xbgr.mr_n90598864)
print v(xbgr.mr_n90808544)
print v(xbgr.mr_n90979392)
print v(xbgr.mr_n91171616)
print v(xbgr.mr_n91357280)
print v(xbgr.mr_n91580592)
print v(xbgr.mr_n91758352)
print v(xbgr.mr_n92095664)
print v(xbgr.mr_n92255648)
print v(xbgr.mr_n92479312)
print v(xbgr.mr_n92693808)
print v(xbgr.mr_n86952784)
print v(xbgr.mr_n86998176)
print v(xbgr.mr_n86553936)
print v(xbgr.mr_n87115440)
print v(xbgr.mr_n87185312)
print v(xbgr.mr_n87303408)
print v(xbgr.mr_n87424464)
print v(xbgr.mr_n87582304)
print v(xbgr.mr_n87633536)
print v(xbgr.mr_n87867344)
print v(xbgr.mr_n88003296)
print v(xbgr.mr_n88076240)
print v(xbgr.mr_n88208432)
print v(xbgr.mr_n88360688)
print v(xbgr.mr_n88483888)
print v(xbgr.mr_n88603824)
print v(xbgr.mr_n88780416)
print v(xbgr.mr_n89005920)
print v(xbgr.mr_n86322880)
print v(xbgr.n_19)
print v(xbgr.mr_n86636624)
print v(xbgr.mr_n86873136)
print v(xbgr.mr_n86980560)
print v(xbgr.mr_n87032512)
print v(xbgr.mr_n87045968)
print v(xbgr.mr_n87147696)
print v(xbgr.mr_n87273424)
print v(xbgr.mr_n87386832)
print v(xbgr.mr_n87457808)
print v(xbgr.mr_n87595296)
print v(xbgr.mr_n87699840)
print v(xbgr.mr_n87878448)
print v(xbgr.mr_n88011040)
print v(xbgr.mr_n88129920)
print v(xbgr.mr_n88298592)
print v(xbgr.mr_n88420192)
print v(xbgr.mr_n88606464)
print v(xbgr.mr_n88723792)
print v(xbgr.mr_n88832192)
print v(xbgr.mr_n89005808)
print v(xbgr.mr_n86319872)
print v(xbgr.mr_n86351520)
print v(xbgr.mr_n86637216)
print v(xbgr.mr_n86873792)
print v(xbgr.mr_n86315792)
print v(xbgr.mr_n86358032)
print v(xbgr.mr_n86637808)
print v(xbgr.mr_n86874384)
print v(xbgr.mr_n86323808)
print v(xbgr.mr_n86358704)
print v(xbgr.mr_n86638400)
print v(xbgr.mr_n86874976)
print v(xbgr.mr_n86325664)
print v(xbgr.mr_n86359296)
print v(xbgr.mr_n86638992)
print v(xbgr.mr_n86875568)
print v(xbgr.mr_n86948544)
print v(xbgr.mr_n87030880)
print v(xbgr.mr_n86141872)
print v(xbgr.mr_n87134816)
print v(xbgr.mr_n87242160)
print v(xbgr.mr_n87354384)
print v(xbgr.mr_n87455728)
print v(xbgr.mr_n87580816)
print v(xbgr.mr_n87637440)
print v(xbgr.mr_n87867792)
print v(xbgr.mr_n87997872)
print v(xbgr.mr_n88107680)
print v(xbgr.mr_n88296816)
print v(xbgr.mr_n88395136)
print v(xbgr.mr_n88582656)
print v(xbgr.mr_n88723904)
print v(xbgr.mr_n88828576)
print v(xbgr.mr_n89009936)
print v(xbgr.mr_n86325200)
print v(xbgr.mr_n86351008)
print v(xbgr.mr_n86639584)
print v(xbgr.mr_n86876160)
print v(xbgr.mr_n89349008)
print v(xbgr.mr_n89551760)
print v(xbgr.mr_n89744944)
print v(xbgr.mr_n89889248)
print v(xbgr.mr_n90037424)
print v(xbgr.mr_n90245536)
print v(xbgr.mr_n90422160)
print v(xbgr.mr_n90588848)
print v(xbgr.mr_n90713440)
print v(xbgr.mr_n90982592)
print v(xbgr.mr_n91167552)
print v(xbgr.mr_n91391312)
print v(xbgr.mr_n91575696)
print v(xbgr.mr_n91772032)
print v(xbgr.mr_n92103088)
print v(xbgr.mr_n92228032)
print v(xbgr.mr_n92457232)
print v(xbgr.mr_n92668512)
print v(xbgr.mr_n86956864)
print v(xbgr.mr_n86997904)
print v(xbgr.mr_n86339904)
print v(xbgr.mr_n87114512)
print v(xbgr.mr_n87184384)
print v(xbgr.mr_n87307680)
print v(xbgr.mr_n87423536)
print v(xbgr.mr_n87582960)
print v(xbgr.mr_n87670480)
print v(xbgr.mr_n87877520)
print v(xbgr.mr_n87953792)
print v(xbgr.mr_n88075056)
print v(xbgr.mr_n88207248)
print v(xbgr.mr_n88362464)
print v(xbgr.mr_n88482704)
print v(xbgr.mr_n88610624)
print v(xbgr.mr_n88782192)
print v(xbgr.mr_n89007984)
print v(xbgr.mr_n86324272)
print v(xbgr.mr_n86359888)
print v(xbgr.mr_n86640176)
print v(xbgr.mr_n86876752)
print v(xbgr.mr_n86981616)
print v(xbgr.mr_n87035552)
print v(xbgr.mr_n87047856)
print v(xbgr.mr_n87088368)
print v(xbgr.mr_n87273824)
print v(xbgr.mr_n87387232)
print v(xbgr.mr_n87460144)
print v(xbgr.mr_n87596256)
print v(xbgr.mr_n87669968)
print v(xbgr.mr_n87882032)
print v(xbgr.mr_n88013104)
print v(xbgr.mr_n88131728)
print v(xbgr.mr_n88299392)
print v(xbgr.mr_n88420992)
print v(xbgr.mr_n88613008)
print v(xbgr.mr_n88652576)
print v(xbgr.mr_n88832080)
print v(xbgr.mr_n88997664)
print v(xbgr.mr_n86323344)
print v(xbgr.mr_n86346192)
print v(xbgr.mr_n86640768)
print v(xbgr.mr_n86877344)
print v(xbgr.mr_n86321952)
print v(xbgr.mr_n86357520)
print v(xbgr.n_4)
print v(xbgr.n_30)
print v(xbgr.mr_n86321488)
print v(xbgr.mr_n86100848)
print v(xbgr.mr_n86641952)
print v(xbgr.mr_n86855392)
print v(xbgr.mr_n86320688)
print v(xbgr.mr_n86149408)
print v(xbgr.mr_n86642544)
print v(xbgr.mr_n86879120)
print v(xbgr.mr_n86953536)
print v(xbgr.mr_n87030544)
print v(xbgr.mr_n87036464)
print v(xbgr.mr_n87087936)
print v(xbgr.mr_n87246976)
print v(xbgr.mr_n87355568)
print v(xbgr.mr_n87460784)
print v(xbgr.mr_n87581648)
print v(xbgr.mr_n87608608)
print v(xbgr.mr_n87841152)
print v(xbgr.mr_n88001488)
print v(xbgr.mr_n88127872)
print v(xbgr.mr_n88294416)
print v(xbgr.mr_n88420816)
print v(xbgr.mr_n88581472)
print v(xbgr.mr_n88727520)
print v(xbgr.mr_n88835808)
print v(xbgr.mr_n89010160)
print v(xbgr.mr_n85262752)
print v(xbgr.mr_n89557536)
print v(xbgr.mr_n89773168)
print v(xbgr.mr_n89889712)
print v(xbgr.mr_n90028112)
print v(xbgr.mr_n90245024)
print v(xbgr.mr_n90445376)
print v(xbgr.mr_n90554528)
print v(xbgr.mr_n90716864)
print v(xbgr.mr_n91000800)
print v(xbgr.mr_n91117840)
print v(xbgr.mr_n91377664)
print v(xbgr.mr_n91570864)
print v(xbgr.mr_n91778480)
print v(xbgr.mr_n92093152)
print v(xbgr.mr_n92269616)
print v(xbgr.mr_n92454704)
print v(xbgr.mr_n92573664)
print v(xbgr.mr_n86320144)
print v(xbgr.mr_n86147296)
print v(xbgr.mr_n86643136)
print v(xbgr.mr_n86879712)
print v(xbgr.mr_n86951120)
print v(xbgr.mr_n86997632)
print v(xbgr.mr_n86391872)
print v(xbgr.mr_n87114048)
print v(xbgr.mr_n87183920)
print v(xbgr.mr_n87308864)
print v(xbgr.mr_n87423072)
print v(xbgr.mr_n87581472)
print v(xbgr.mr_n87613840)
print v(xbgr.mr_n87586256)
print v(xbgr.mr_n88008320)
print v(xbgr.mr_n88074464)
print v(xbgr.mr_n88206656)
print v(xbgr.mr_n88364240)
print v(xbgr.mr_n88482112)
print v(xbgr.mr_n88610736)
print v(xbgr.mr_n88783968)
print v(xbgr.mr_n89008096)
print v(xbgr.mr_n86313536)
print v(xbgr.mr_n86143072)
print v(xbgr.mr_n86643728)
print v(xbgr.mr_n86880304)
print v(xbgr.mr_n86983472)
print v(xbgr.mr_n86125232)
print v(xbgr.mr_n86137936)
print v(xbgr.mr_n87088816)
print v(xbgr.mr_n87273024)
print v(xbgr.mr_n87387632)
print v(xbgr.mr_n87458448)
print v(xbgr.mr_n87597232)
print v(xbgr.mr_n87701200)
print v(xbgr.mr_n87883840)
print v(xbgr.mr_n88015168)
print v(xbgr.mr_n88130432)
print v(xbgr.mr_n88300192)
print v(xbgr.mr_n88421792)
print v(xbgr.mr_n88613968)
print v(xbgr.mr_n88725712)
print v(xbgr.mr_n88823040)
print v(xbgr.mr_n89007872)
print v(xbgr.mr_n86319056)
print v(xbgr.mr_n86095792)
print v(xbgr.mr_n86644320)
print v(xbgr.mr_n86872608)
print v(xbgr.mr_n86318512)
print v(xbgr.mr_n85699024)
print v(xbgr.mr_n86644912)
print v(xbgr.mr_n86881424)
print v(xbgr.mr_n86317968)
print v(xbgr.mr_n86324736)
print v(xbgr.mr_n86645504)
print v(xbgr.mr_n86882080)
print v(xbgr.mr_n86958528)
print v(xbgr.mr_n87035376)
print v(xbgr.mr_n86805792)
print v(xbgr.mr_n87126176)
print v(xbgr.mr_n87248304)
print v(xbgr.mr_n87356752)
print v(xbgr.mr_n87463088)
print v(xbgr.mr_n87578960)
print v(xbgr.mr_n87694448)
print v(xbgr.mr_n87837408)
print v(xbgr.mr_n88011552)
print v(xbgr.mr_n88123200)
print v(xbgr.mr_n88300016)
print v(xbgr.mr_n88420016)
print v(xbgr.mr_n88580288)
print v(xbgr.mr_n88727408)
print v(xbgr.mr_n88839424)
print v(xbgr.mr_n89010048)
print v(xbgr.mr_n86111584)
print v(xbgr.mr_n86165600)
print v(xbgr.mr_n86646096)
print v(xbgr.mr_n86882672)
print v(xbgr.mr_n89342016)
print v(xbgr.mr_n89550320)
print v(xbgr.mr_n89757808)
print v(xbgr.mr_n89857856)
print v(xbgr.mr_n90045264)
print v(xbgr.mr_n90239520)
print v(xbgr.mr_n90401920)
print v(xbgr.mr_n90612576)
print v(xbgr.mr_n87676224)
print v(xbgr.mr_n90716976)
print v(xbgr.mr_n91010624)
print v(xbgr.mr_n91155264)
print v(xbgr.mr_n91388800)
print v(xbgr.mr_n91586064)
print v(xbgr.mr_n91783456)
print v(xbgr.mr_n92100384)
print v(xbgr.mr_n92260304)
print v(xbgr.mr_n92479120)
print v(xbgr.mr_n92657376)
print v(xbgr.mr_n86961856)
print v(xbgr.mr_n86997360)
print v(xbgr.mr_n86394976)
print v(xbgr.mr_n87113120)
print v(xbgr.mr_n87182992)
print v(xbgr.mr_n87309632)
print v(xbgr.mr_n87422144)
print v(xbgr.mr_n87580464)
print v(xbgr.mr_n87739456)
print v(xbgr.mr_n88010384)
print v(xbgr.mr_n88073280)
print v(xbgr.mr_n88205472)
print v(xbgr.mr_n88348016)
print v(xbgr.mr_n88480928)
print v(xbgr.mr_n88613792)
print v(xbgr.mr_n88834000)
print v(xbgr.mr_n89014064)
print v(xbgr.mr_n86316880)
print v(xbgr.mr_n86168416)
print v(xbgr.mr_n86646688)
print v(xbgr.mr_n86883264)
print v(xbgr.mr_n86984928)
print v(xbgr.mr_n86216192)
print v(xbgr.mr_n87051472)
print v(xbgr.mr_n87092976)
print v(xbgr.mr_n87272224)
print v(xbgr.mr_n87388032)
print v(xbgr.mr_n87462592)
print v(xbgr.mr_n87598112)
print v(xbgr.mr_n87700640)
print v(xbgr.mr_n87885568)
print v(xbgr.mr_n88017152)
print v(xbgr.mr_n88135344)
print v(xbgr.mr_n88300992)
print v(xbgr.mr_n88422592)
print v(xbgr.mr_n88616432)
print v(xbgr.mr_n88731024)
print v(xbgr.mr_n88837504)
print v(xbgr.mr_n89006032)
print v(xbgr.mr_n86316336)
print v(xbgr.mr_n86175456)
print v(xbgr.mr_n86647280)
print v(xbgr.mr_n86883840)
print v(xbgr.mr_n86314432)
print v(xbgr.mr_n86179680)
print v(xbgr.mr_n86647872)
print v(xbgr.mr_n86884432)
print v(xbgr.mr_n86315248)
print v(xbgr.mr_n86182528)
print v(xbgr.n_5)
print v(xbgr.mr_n86885024)
print v(xbgr.mr_n86111360)
print v(xbgr.mr_n86186016)
print v(xbgr.mr_n86649056)
print v(xbgr.mr_n86885616)
print v(xbgr.mr_n86960800)
print v(xbgr.mr_n86448640)
print v(xbgr.mr_n87048368)
print v(xbgr.mr_n86213760)
print v(xbgr.mr_n87222672)
print v(xbgr.mr_n87357936)
print v(xbgr.mr_n87462816)
print v(xbgr.mr_n87578224)
print v(xbgr.mr_n87697264)
print v(xbgr.mr_n87870016)
print v(xbgr.mr_n88015680)
print v(xbgr.mr_n88107168)
print v(xbgr.mr_n88300816)
print v(xbgr.mr_n88401840)
print v(xbgr.mr_n88579104)
print v(xbgr.mr_n88729328)
print v(xbgr.mr_n88839312)
print v(xbgr.mr_n89012224)
print v(xbgr.mr_n89101184)
print v(xbgr.mr_n89529168)
print v(xbgr.mr_n89772464)
print v(xbgr.mr_n89900848)
print v(xbgr.mr_n90032768)
print v(xbgr.mr_n90228848)
print v(xbgr.mr_n90419280)
print v(xbgr.mr_n90607072)
print v(xbgr.mr_n87735856)
print v(xbgr.mr_n90705616)
print v(xbgr.mr_n91015600)
print v(xbgr.mr_n91152064)
print v(xbgr.mr_n91379664)
print v(xbgr.mr_n91565904)
print v(xbgr.mr_n91788432)
print v(xbgr.mr_n92112672)
print v(xbgr.mr_n92264960)
print v(xbgr.mr_n92372320)
print v(xbgr.mr_n92658592)
print v(xbgr.mr_n86314160)
print v(xbgr.mr_n86189536)
print v(xbgr.mr_n86649648)
print v(xbgr.mr_n86886208)
print v(xbgr.mr_n86960912)
print v(xbgr.mr_n86997088)
print v(xbgr.mr_n86693856)
print v(xbgr.mr_n87112656)
print v(xbgr.mr_n87182528)
print v(xbgr.mr_n87310560)
print v(xbgr.mr_n87421760)
print v(xbgr.mr_n87579536)
print v(xbgr.mr_n87787184)
print v(xbgr.mr_n88016576)
print v(xbgr.mr_n88072688)
print v(xbgr.mr_n88204880)
print v(xbgr.mr_n88367328)
print v(xbgr.mr_n88480336)
print v(xbgr.mr_n88612512)
print v(xbgr.mr_n88828464)
print v(xbgr.mr_n89014288)
print v(xbgr.mr_n86312880)
print v(xbgr.mr_n86167920)
print v(xbgr.mr_n86650240)
print v(xbgr.mr_n86812608)
print v(xbgr.mr_n86986304)
print v(xbgr.mr_n87023728)
print v(xbgr.mr_n87053200)
print v(xbgr.mr_n87124512)
print v(xbgr.mr_n87271424)
print v(xbgr.mr_n87388432)
print v(xbgr.mr_n87467776)
print v(xbgr.mr_n87599088)
print v(xbgr.mr_n87699664)
print v(xbgr.mr_n87887456)
print v(xbgr.mr_n88019296)
print v(xbgr.mr_n88137152)
print v(xbgr.mr_n88298416)
print v(xbgr.mr_n88421616)
print v(xbgr.mr_n88617312)
print v(xbgr.mr_n88732832)
print v(xbgr.mr_n88826768)
print v(xbgr.mr_n89012000)
print v(xbgr.mr_n86274128)
print v(xbgr.mr_n86480288)
print v(xbgr.mr_n86650832)
print v(xbgr.mr_n86887392)
print v(xbgr.mr_n86274592)
print v(xbgr.mr_n86480960)
print v(xbgr.mr_n86651424)
print v(xbgr.mr_n86887984)
print v(xbgr.mr_n86275056)
print v(xbgr.mr_n86478528)
print v(xbgr.mr_n86652016)
print v(xbgr.mr_n86888576)
print v(xbgr.mr_n86275520)
print v(xbgr.mr_n86479248)
print v(xbgr.mr_n86546256)
print v(xbgr.mr_n86889168)
print v(xbgr.mr_n86955808)
print v(xbgr.mr_n86138608)
print v(xbgr.mr_n87044752)
print v(xbgr.mr_n87170288)
print v(xbgr.mr_n87222928)
print v(xbgr.mr_n87359120)
print v(xbgr.mr_n87465552)
print v(xbgr.mr_n87528400)
print v(xbgr.mr_n87721776)
print v(xbgr.mr_n87881376)
print v(xbgr.mr_n88012448)
print v(xbgr.mr_n88133376)
print v(xbgr.mr_n88275552)
print v(xbgr.mr_n88423216)
print v(xbgr.mr_n88577920)
print v(xbgr.mr_n88725600)
print v(xbgr.mr_n88841344)
print v(xbgr.mr_n89018192)
print v(xbgr.mr_n85266368)
print v(xbgr.mr_n89532112)
print v(xbgr.mr_n89763584)
print v(xbgr.mr_n89894224)
print v(xbgr.mr_n90042080)
print v(xbgr.mr_n90213296)
print v(xbgr.mr_n90413328)
print v(xbgr.mr_n90609616)
print v(xbgr.mr_n87740816)
print v(xbgr.mr_n90711296)
print v(xbgr.mr_n91020576)
print v(xbgr.mr_n91155456)
print v(xbgr.mr_n91335312)
print v(xbgr.mr_n91554784)
print v(xbgr.mr_n91793520)
print v(xbgr.mr_n92117568)
print v(xbgr.mr_n92303248)
print v(xbgr.mr_n92479824)
print v(xbgr.mr_n92711856)
print v(xbgr.mr_n86955920)
print v(xbgr.mr_n86996816)
print v(xbgr.mr_n86140464)
print v(xbgr.mr_n87111728)
print v(xbgr.mr_n87181600)
print v(xbgr.mr_n87310096)
print v(xbgr.mr_n87421152)
print v(xbgr.mr_n87578448)
print v(xbgr.mr_n87824016)
print v(xbgr.mr_n88013616)
print v(xbgr.mr_n88071696)
print v(xbgr.mr_n88203888)
print v(xbgr.mr_n88367936)
print v(xbgr.mr_n88479152)
print v(xbgr.mr_n88617744)
print v(xbgr.mr_n88833888)
print v(xbgr.mr_n89016352)
print v(xbgr.mr_n86275984)
print v(xbgr.mr_n86479712)
print v(xbgr.mr_n86653200)
print v(xbgr.mr_n86889760)
print v(xbgr.mr_n86276448)
print v(xbgr.mr_n86470304)
print v(xbgr.mr_n86653792)
print v(xbgr.mr_n86880896)
print v(xbgr.mr_n86987440)
print v(xbgr.mr_n86446288)
print v(xbgr.mr_n87055008)
print v(xbgr.mr_n87099376)
print v(xbgr.mr_n87270624)
print v(xbgr.mr_n87388832)
print v(xbgr.mr_n87470176)
print v(xbgr.mr_n87599728)
print v(xbgr.mr_n87700464)
print v(xbgr.mr_n87879232)
print v(xbgr.mr_n88021360)
print v(xbgr.mr_n88138960)
print v(xbgr.mr_n88302592)
print v(xbgr.mr_n88424192)
print v(xbgr.mr_n88618976)
print v(xbgr.mr_n88732944)
print v(xbgr.mr_n88837616)
print v(xbgr.mr_n89012112)
print v(xbgr.mr_n86276912)
print v(xbgr.mr_n86483856)
print v(xbgr.mr_n86654384)
print v(xbgr.mr_n86890880)
print v(xbgr.mr_n86277376)
print v(xbgr.mr_n86464512)
print v(xbgr.mr_n86654976)
print v(xbgr.mr_n86891536)
print v(xbgr.mr_n86277840)
print v(xbgr.mr_n86485040)
print v(xbgr.mr_n86655568)
print v(xbgr.n_31)
print v(xbgr.mr_n86950816)
print v(xbgr.mr_n87032912)
print v(xbgr.mr_n87049504)
print v(xbgr.mr_n86576256)
print v(xbgr.mr_n87124976)
print v(xbgr.mr_n87360304)
print v(xbgr.mr_n87458560)
print v(xbgr.mr_n87577712)
print v(xbgr.mr_n87722448)
print v(xbgr.mr_n87884352)
print v(xbgr.mr_n88009488)
print v(xbgr.mr_n88135856)
print v(xbgr.mr_n88302416)
print v(xbgr.mr_n88416016)
print v(xbgr.mr_n88576736)
print v(xbgr.mr_n88736448)
print v(xbgr.mr_n88835696)
print v(xbgr.mr_n89018416)
print v(xbgr.mr_n86278304)
print v(xbgr.mr_n86482656)
print v(xbgr.mr_n86530416)
print v(xbgr.mr_n86892672)
print v(xbgr.mr_n88885328)
print v(xbgr.mr_n89501392)
print v(xbgr.mr_n89752528)
print v(xbgr.mr_n89883088)
print v(xbgr.mr_n90060704)
print v(xbgr.mr_n90206112)
print v(xbgr.mr_n90408080)
print v(xbgr.mr_n90612064)
print v(xbgr.mr_n87694016)
print v(xbgr.mr_n90713552)
print v(xbgr.mr_n91025552)
print v(xbgr.mr_n91154880)
print v(xbgr.mr_n91356816)
print v(xbgr.mr_n91571376)
print v(xbgr.mr_n91798384)
print v(xbgr.mr_n92072640)
print v(xbgr.mr_n92298016)
print v(xbgr.mr_n92478848)
print v(xbgr.mr_n92727184)
print v(xbgr.mr_n86950928)
print v(xbgr.mr_n86996624)
print v(xbgr.mr_n86135504)
print v(xbgr.mr_n87111264)
print v(xbgr.mr_n87181136)
print v(xbgr.mr_n87309168)
print v(xbgr.mr_n87420848)
print v(xbgr.mr_n87504272)
print v(xbgr.mr_n87803152)
print v(xbgr.mr_n88020704)
print v(xbgr.mr_n88071232)
print v(xbgr.mr_n88203424)
print v(xbgr.mr_n88367600)
print v(xbgr.mr_n88478560)
print v(xbgr.mr_n88618480)
print v(xbgr.mr_n88843296)
print v(xbgr.mr_n88999728)
print v(xbgr.mr_n86278768)
print v(xbgr.mr_n86483248)
print v(xbgr.mr_n86656752)
print v(xbgr.mr_n86893264)
print v(xbgr.mr_n86988896)
print v(xbgr.mr_n86231936)
print v(xbgr.mr_n87056896)
print v(xbgr.mr_n86807296)
print v(xbgr.mr_n87269824)
print v(xbgr.mr_n87389232)
print v(xbgr.mr_n87465360)
print v(xbgr.mr_n87600864)
print v(xbgr.mr_n87733008)
print v(xbgr.mr_n87891072)
print v(xbgr.mr_n88023424)
print v(xbgr.mr_n88140768)
print v(xbgr.mr_n88303392)
print v(xbgr.mr_n88424992)
print v(xbgr.mr_n88620720)
print v(xbgr.mr_n88734640)
print v(xbgr.mr_n88843184)
print v(xbgr.mr_n89016128)
print v(xbgr.mr_n86279232)
print v(xbgr.mr_n86486800)
print v(xbgr.mr_n86630384)
print v(xbgr.mr_n86893856)
print v(xbgr.mr_n86279696)
print v(xbgr.n_34)
print v(xbgr.mr_n86657936)
print v(xbgr.mr_n86894448)
print v(xbgr.mr_n86280160)
print v(xbgr.mr_n86488064)
print v(xbgr.mr_n86658528)
print v(xbgr.mr_n86878528)
print v(xbgr.mr_n86280624)
print v(xbgr.mr_n86485696)
print v(xbgr.mr_n86659120)
print v(xbgr.mr_n86895632)
print v(xbgr.mr_n86945824)
print v(xbgr.mr_n86217408)
print v(xbgr.mr_n87038096)
print v(xbgr.mr_n87085888)
print v(xbgr.mr_n87186704)
print v(xbgr.mr_n87361488)
print v(xbgr.mr_n87470896)
print v(xbgr.mr_n87576896)
print v(xbgr.mr_n87735264)
print v(xbgr.mr_n87832368)
print v(xbgr.mr_n88019808)
print v(xbgr.mr_n88132240)
print v(xbgr.mr_n88299216)
print v(xbgr.mr_n88402656)
print v(xbgr.mr_n88509280)
print v(xbgr.mr_n88736560)
print v(xbgr.mr_n88847312)
print v(xbgr.mr_n89020368)
print v(xbgr.mr_n89331488)
print v(xbgr.mr_n89515696)
print v(xbgr.mr_n89758320)
print v(xbgr.mr_n89868672)
print v(xbgr.mr_n90075136)
print v(xbgr.mr_n90202736)
print v(xbgr.mr_n90364160)
print v(xbgr.mr_n90623552)
print v(xbgr.mr_n87737408)
print v(xbgr.mr_n90711104)
print v(xbgr.mr_n91030528)
print v(xbgr.mr_n91170000)
print v(xbgr.mr_n91345680)
print v(xbgr.mr_n91544672)
print v(xbgr.mr_n91803360)
print v(xbgr.mr_n92057024)
print v(xbgr.mr_n92045200)
print v(xbgr.mr_n92484304)
print v(xbgr.mr_n92696592)
print v(xbgr.mr_n86281088)
print v(xbgr.mr_n86486208)
print v(xbgr.mr_n86659712)
print v(xbgr.mr_n86896224)
print v(xbgr.mr_n86945936)
print v(xbgr.mr_n86995824)
print v(xbgr.mr_n86455696)
print v(xbgr.mr_n87110336)
print v(xbgr.mr_n87180240)
print v(xbgr.mr_n87308976)
print v(xbgr.mr_n87366848)
print v(xbgr.mr_n87503968)
print v(xbgr.mr_n87780624)
print v(xbgr.mr_n88017744)
print v(xbgr.mr_n88070304)
print v(xbgr.mr_n88202496)
print v(xbgr.mr_n88367056)
print v(xbgr.mr_n88477440)
print v(xbgr.mr_n88619488)
print v(xbgr.mr_n88845360)
print v(xbgr.mr_n89014176)
print v(xbgr.mr_n86281552)
print v(xbgr.mr_n86489760)
print v(xbgr.mr_n86660304)
print v(xbgr.mr_n86896816)
print v(xbgr.mr_n86990272)
print v(xbgr.mr_n86227072)
print v(xbgr.mr_n87058624)
print v(xbgr.mr_n87091392)
print v(xbgr.mr_n87260592)
print v(xbgr.mr_n87389632)
print v(xbgr.mr_n87472704)
print v(xbgr.mr_n87601824)
print v(xbgr.mr_n87742480)
print v(xbgr.mr_n87892880)
print v(xbgr.mr_n88025488)
print v(xbgr.mr_n88137664)
print v(xbgr.mr_n88304192)
print v(xbgr.mr_n88418416)
print v(xbgr.mr_n88622320)
print v(xbgr.mr_n88738256)
print v(xbgr.mr_n88841120)
print v(xbgr.mr_n89020256)
print v(xbgr.mr_n86282016)
print v(xbgr.mr_n86477328)
print v(xbgr.mr_n86660896)
print v(xbgr.mr_n86855504)
print v(xbgr.mr_n86282480)
print v(xbgr.mr_n86489168)
print v(xbgr.mr_n86661488)
print v(xbgr.mr_n86897936)
print v(xbgr.mr_n86282944)
print v(xbgr.mr_n86491680)
print v(xbgr.mr_n86662080)
print v(xbgr.mr_n86898592)
print v(xbgr.mr_n86269568)
print v(xbgr.mr_n86492208)
print v(xbgr.n_10)
print v(xbgr.mr_n86899184)
print v(xbgr.mr_n86940832)
print v(xbgr.mr_n87026672)
print v(xbgr.mr_n87053792)
print v(xbgr.mr_n87146320)
print v(xbgr.mr_n87222416)
print v(xbgr.mr_n87362672)
print v(xbgr.mr_n87475360)
print v(xbgr.mr_n87494400)
print v(xbgr.mr_n87744560)
print v(xbgr.mr_n87882544)
print v(xbgr.mr_n88004192)
print v(xbgr.mr_n88126816)
print v(xbgr.mr_n88301616)
print v(xbgr.mr_n88423392)
print v(xbgr.mr_n88422416)
print v(xbgr.mr_n88738368)
print v(xbgr.mr_n88841232)
print v(xbgr.mr_n89027488)
print v(xbgr.mr_n85610576)
print v(xbgr.mr_n89513584)
print v(xbgr.mr_n89733056)
print v(xbgr.mr_n89862240)
print v(xbgr.mr_n90070016)
print v(xbgr.mr_n90185424)
print v(xbgr.mr_n90388352)
print v(xbgr.mr_n90628640)
print v(xbgr.mr_n87712928)
print v(xbgr.mr_n90710528)
print v(xbgr.mr_n91035616)
print v(xbgr.mr_n91155648)
print v(xbgr.mr_n91332416)
print v(xbgr.mr_n91550992)
print v(xbgr.mr_n91808336)
print v(xbgr.mr_n91946592)
print v(xbgr.mr_n91655040)
print v(xbgr.mr_n92349552)
print v(xbgr.mr_n92706544)
print v(xbgr.mr_n86940944)
print v(xbgr.mr_n86994496)
print v(xbgr.mr_n86147504)
print v(xbgr.mr_n87109872)
print v(xbgr.mr_n87179776)
print v(xbgr.mr_n87307168)
print v(xbgr.mr_n87381632)
print v(xbgr.mr_n87477808)
print v(xbgr.mr_n87810992)
print v(xbgr.mr_n88024832)
print v(xbgr.mr_n88069840)
print v(xbgr.mr_n88202032)
print v(xbgr.mr_n88358080)
print v(xbgr.mr_n88476976)
print v(xbgr.mr_n88618304)
print v(xbgr.mr_n88843408)
print v(xbgr.mr_n89020480)
print v(xbgr.mr_n86283872)
print v(xbgr.mr_n86492736)
print v(xbgr.mr_n86663264)
print v(xbgr.mr_n86899776)
print v(xbgr.mr_n86284336)
print v(xbgr.mr_n86493392)
print v(xbgr.mr_n86663856)
print v(xbgr.mr_n86900368)
print v(xbgr.mr_n86992128)
print v(xbgr.mr_n86447872)
print v(xbgr.mr_n87060512)
print v(xbgr.mr_n87137888)
print v(xbgr.mr_n87268304)
print v(xbgr.mr_n87390032)
print v(xbgr.mr_n87465248)
print v(xbgr.mr_n87602800)
print v(xbgr.mr_n87701312)
print v(xbgr.mr_n87894688)
print v(xbgr.mr_n88021872)
print v(xbgr.mr_n88144384)
print v(xbgr.mr_n88304992)
print v(xbgr.mr_n88426592)
print v(xbgr.mr_n88623664)
print v(xbgr.mr_n88740064)
print v(xbgr.mr_n88845248)
print v(xbgr.mr_n89018304)
print v(xbgr.mr_n86284800)
print v(xbgr.mr_n86490944)
print v(xbgr.mr_n86664448)
print v(xbgr.mr_n86805648)
print v(xbgr.mr_n86285264)
print v(xbgr.mr_n86494496)
print v(xbgr.mr_n86665040)
print v(xbgr.mr_n86870240)
print v(xbgr.mr_n86285728)
print v(xbgr.mr_n86490432)
print v(xbgr.mr_n86665632)
print v(xbgr.mr_n86856656)
print v(xbgr.mr_n86916736)
print v(xbgr.mr_n86448880)
print v(xbgr.mr_n87046560)
print v(xbgr.mr_n87120304)
print v(xbgr.mr_n86126992)
print v(xbgr.mr_n87363856)
print v(xbgr.mr_n87430496)
print v(xbgr.mr_n87551472)
print v(xbgr.mr_n87724096)
print v(xbgr.mr_n87868048)
print v(xbgr.mr_n88022768)
print v(xbgr.mr_n88141280)
print v(xbgr.mr_n88304016)
print v(xbgr.mr_n88416816)
print v(xbgr.mr_n88508576)
print v(xbgr.mr_n88729216)
print v(xbgr.mr_n88851440)
print v(xbgr.mr_n89016240)
print v(xbgr.mr_n86286192)
print v(xbgr.mr_n86482064)
print v(xbgr.mr_n86666224)
print v(xbgr.mr_n86855104)
print v(xbgr.mr_n85261888)
print v(xbgr.mr_n89503984)
print v(xbgr.mr_n89725088)
print v(xbgr.mr_n89857584)
print v(xbgr.mr_n90051392)
print v(xbgr.mr_n90151968)
print v(xbgr.mr_n90359440)
print v(xbgr.mr_n90633504)
print v(xbgr.mr_n87756096)
print v(xbgr.mr_n90710720)
print v(xbgr.mr_n90996848)
print v(xbgr.mr_n91143040)
print v(xbgr.mr_n91299664)
print v(xbgr.mr_n91545792)
print v(xbgr.mr_n91737040)
print v(xbgr.mr_n91930976)
print v(xbgr.mr_n91946816)
print v(xbgr.mr_n92453440)
print v(xbgr.mr_n92657776)
print v(xbgr.mr_n86937072)
print v(xbgr.mr_n86996160)
print v(xbgr.mr_n86143280)
print v(xbgr.mr_n87108944)
print v(xbgr.mr_n86847408)
print v(xbgr.mr_n87306224)
print v(xbgr.mr_n87380960)
print v(xbgr.mr_n87495968)
print v(xbgr.mr_n87843776)
print v(xbgr.mr_n87917056)
print v(xbgr.mr_n88046080)
print v(xbgr.mr_n88170912)
print v(xbgr.mr_n88365184)
print v(xbgr.mr_n88425792)
print v(xbgr.mr_n88621904)
print v(xbgr.mr_n88847424)
print v(xbgr.mr_n89023136)
print v(xbgr.mr_n86286656)
print v(xbgr.mr_n86238304)
print v(xbgr.mr_n86666816)
print v(xbgr.mr_n86854688)
print v(xbgr.mr_n86993264)
print v(xbgr.mr_n86186928)
print v(xbgr.mr_n87062320)
print v(xbgr.mr_n87168064)
print v(xbgr.mr_n87250352)
print v(xbgr.mr_n87390432)
print v(xbgr.mr_n87477696)
print v(xbgr.mr_n87603440)
print v(xbgr.mr_n87740160)
print v(xbgr.mr_n87896416)
print v(xbgr.mr_n88029360)
print v(xbgr.mr_n88146192)
print v(xbgr.mr_n88305792)
print v(xbgr.mr_n88427392)
print v(xbgr.mr_n88626528)
print v(xbgr.mr_n88741984)
print v(xbgr.mr_n88847536)
print v(xbgr.mr_n89027008)
print v(xbgr.mr_n86287120)
print v(xbgr.mr_n86477920)
print v(xbgr.mr_n86667408)
print v(xbgr.mr_n86851200)
print v(xbgr.mr_n86287584)
print v(xbgr.mr_n86481552)
print v(xbgr.mr_n86668000)
print v(xbgr.mr_n86856800)
print v(xbgr.mr_n86288048)
print v(xbgr.mr_n86456496)
print v(xbgr.mr_n86668592)
print v(xbgr.mr_n86900704)
print v(xbgr.mr_n86288512)
print v(xbgr.mr_n86484512)
print v(xbgr.mr_n86669184)
print v(xbgr.mr_n86900816)
print v(xbgr.mr_n86288976)
print v(xbgr.mr_n86453472)
print v(xbgr.mr_n86669776)
print v(xbgr.mr_n86902160)
print v(xbgr.mr_n86261680)
print v(xbgr.mr_n86405888)
print v(xbgr.mr_n86670368)
print v(xbgr.mr_n86902624)
print v(xbgr.mr_n86289904)
print v(xbgr.mr_n86493984)
print v(xbgr.mr_n86670960)
print v(xbgr.mr_n86903088)
print v(xbgr.mr_n86290368)
print v(xbgr.mr_n86465776)
print v(xbgr.mr_n86671552)
print v(xbgr.mr_n86903552)
print v(xbgr.mr_n87146912)
print v(xbgr.mr_n88625520)
print v(xbgr.mr_n88851552)
print v(xbgr.mr_n89031472)
print v(xbgr.mr_n86290832)
print v(xbgr.mr_n86243344)
print v(xbgr.mr_n86672144)
print v(xbgr.mr_n86886800)
print v(xbgr.d5)
print v(xbgr.d1)
print v(xbgr.mr_n87144496)
print v(xbgr.mr_n87477920)
print v(xbgr.mr_n86993888)
print v(xbgr.mr_n87051984)
print v(xbgr.mr_n87480720)
print v(xbgr.mr_n88624400)
print v(xbgr.n1)
print v(xbgr.mr_n89031104)
print v(xbgr.mr_n86291296)
print v(xbgr.mr_n86460032)
print v(xbgr.mr_n86672736)
print v(xbgr.mr_n86904688)
print v(xbgr.mr_n88424816)
print v(xbgr.mr_n88651504)
print v(xbgr.mr_n88866768)
print v(xbgr.mr_n86934288)
print v(xbgr.mr_n87026400)
print v(xbgr.kick)
print v(xbgr.mr_n87323344)
print v(xbgr.mr_n88624176)
print v(xbgr.mr_n88794080)
print v(xbgr.mr_n89023024)
print v(xbgr.mr_n86291760)
print v(xbgr.mr_n86495952)
print v(xbgr.mr_n86673328)
print v(xbgr.mr_n86906496)
print v(xbgr.mr_n86292224)
print v(xbgr.mr_n86495424)
print v(xbgr.mr_n86673920)
print v(xbgr.mr_n86907088)
print v(xbgr.mr_n86990016)
print v(xbgr.mr_n87062832)
print v(xbgr.mr_n87123888)
print v(xbgr.mr_n87468560)
print v(xbgr.mr_n88625696)
print v(xbgr.mr_n88849488)
print v(xbgr.mr_n89030992)
print v(xbgr.mr_n87600608)
print v(xbgr.mr_n87687504)
print v(xbgr.mr_n87814832)
print v(xbgr.mr_n87891584)
print v(xbgr.mr_n88078016)
print v(xbgr.mr_n88271616)
print v(xbgr.mr_n88388448)
print v(xbgr.mr_n87602448)
print v(xbgr.mr_n87716912)
print v(xbgr.mr_n87818992)
print v(xbgr.mr_n87895200)
print v(xbgr.mr_n88125008)
print v(xbgr.mr_n88275088)
print v(xbgr.mr_n88398016)
print v(xbgr.mr_n86292688)
print v(xbgr.mr_n86497440)
print v(xbgr.mr_n86674512)
print v(xbgr.mr_n86907680)
print v(xbgr.mr_n88627120)
print v(xbgr.mr_n88793296)
print v(xbgr.mr_n89023504)
print v(xbgr.mr_n87504656)
print v(xbgr.mr_n87634928)
print v(xbgr.mr_n87752224)
print v(xbgr.mr_n87840592)
print v(xbgr.mr_n88043392)
print v(xbgr.mr_n88169696)
print v(xbgr.mr_n88304816)
print v(xbgr.mr_n88439936)
print v(xbgr.mr_n88669232)
print v(xbgr.mr_n88870832)
print v(xbgr.mr_n86293152)
print v(xbgr.mr_n86498480)
print v(xbgr.mr_n86675104)
print v(xbgr.mr_n86908272)
print v(xbgr.mr_n88621728)
print v(xbgr.mr_n88793072)
print v(xbgr.mr_n89035088)
print v(xbgr.mr_n87142896)
print v(xbgr.mr_n87601648)
print v(xbgr.d2)
print v(xbgr.mr_n87814432)
print v(xbgr.mr_n87889024)
print v(xbgr.mr_n88144896)
print v(xbgr.mr_n88239216)
print v(xbgr.mr_n88363408)
print v(xbgr.mr_n86994112)
print v(xbgr.mr_n87062944)
print v(xbgr.mr_n87480416)
print v(xbgr.mr_n86250096)
print v(xbgr.mr_n86499072)
print v(xbgr.mr_n86675696)
print v(xbgr.mr_n86908864)
print v(xbgr.mr_n86994224)
print v(xbgr.mr_n86206512)
print v(xbgr.mr_n87475664)
print v(xbgr.mr_n88628512)
print v(xbgr.mr_n88849600)
print v(xbgr.mr_n89027120)
print v(xbgr.mr_n87145072)
print v(xbgr.mr_n86294080)
print v(xbgr.mr_n86499664)
print v(xbgr.mr_n86676288)
print v(xbgr.mr_n86910048)
print v(xbgr.mr_n86934832)
print v(xbgr.mr_n87026128)
print v(xbgr.mr_n87366112)
print v(xbgr.det)
print v(xbgr.mr_n88629312)
print v(xbgr.mr_n88793808)
print v(xbgr.mr_n89035456)
print v(xbgr.mr_n87085008)
print v(xbgr.mr_n86294544)
print v(xbgr.mr_n86500256)
print v(xbgr.mr_n86676880)
print v(xbgr.mr_n86909456)
print v(xbgr.mr_n88441712)
print v(xbgr.mr_n88668768)
print v(xbgr.mr_n88872688)
print v(xbgr.mr_n86991712)
print v(xbgr.mr_n87063056)
print v(xbgr.mr_n87480528)
print v(xbgr.mr_n88630256)
print v(xbgr.mr_n88794704)
print v(xbgr.mr_n89039664)
print v(xbgr.mr_n87604048)
print v(xbgr.mr_n87753632)
print v(xbgr.mr_n87814544)
print v(xbgr.mr_n87889776)
print v(xbgr.mr_n88128624)
print v(xbgr.mr_n88259216)
print v(xbgr.mr_n88390416)
print v(xbgr.mr_n87604160)
print v(xbgr.mr_n87704352)
print v(xbgr.mr_n87810880)
print v(xbgr.mr_n87897120)
print v(xbgr.mr_n88146928)
print v(xbgr.mr_n88268736)
print v(xbgr.mr_n88395024)
print v(xbgr.mr_n86295008)
print v(xbgr.mr_n86500848)
print v(xbgr.mr_n86677472)
print v(xbgr.mr_n86890352)
print v(xbgr.mr_n87527936)
print v(xbgr.mr_n87636848)
print v(xbgr.mr_n87711568)
print v(xbgr.mr_n87844592)
print v(xbgr.mr_n88047424)
print v(xbgr.mr_n88173728)
print v(xbgr.mr_n88306336)
print v(xbgr.mr_n88630672)
print v(xbgr.mr_n88853504)
print v(xbgr.mr_n89034976)
print v(xbgr.mr_n86295472)
print v(xbgr.mr_n86501408)
print v(xbgr.mr_n86678064)
print v(xbgr.mr_n86915760)
print v(xbgr.mr_n88628400)
print v(xbgr.mr_n88798336)
print v(xbgr.mr_n89038160)
print v(xbgr.mr_n86295936)
print v(xbgr.mr_n86502000)
print v(xbgr.mr_n86678656)
print v(xbgr.mr_n86915872)
print v(xbgr.mr_n87144224)
print v(xbgr.mr_n87593744)
print v(xbgr.mr_n87750800)
print v(xbgr.mr_n87820400)
print v(xbgr.mr_n87893392)
print v(xbgr.mr_n88146816)
print v(xbgr.mr_n88235072)
print v(xbgr.mr_n88362288)
print v(xbgr.mr_n86994848)
print v(xbgr.mr_n87063904)
print v(xbgr.mr_n87481920)
print v(xbgr.mr_n88443568)
print v(xbgr.mr_n88668304)
print v(xbgr.mr_n88874544)
print v(xbgr.mr_n86994960)
print v(xbgr.mr_n87055600)
print v(xbgr.mr_n87481232)
print v(xbgr.mr_n88632848)
print v(xbgr.mr_n88798928)
print v(xbgr.mr_n89042128)
print v(xbgr.mr_n86296400)
print v(xbgr.mr_n86502592)
print v(xbgr.mr_n86679248)
print v(xbgr.mr_n86916096)
print v(xbgr.mr_n87123296)
print v(xbgr.mr_n86934560)
print v(xbgr.mr_n87025856)
print v(xbgr.mr_n87083968)
print v(xbgr.mr_n87366384)
print v(xbgr.r4n)
print v(xbgr.mr_n86296864)
print v(xbgr.mr_n86503184)
print v(xbgr.mr_n86679840)
print v(xbgr.mr_n86916208)
print v(xbgr.mr_n88631344)
print v(xbgr.mr_n88857600)
print v(xbgr.mr_n89038048)
print v(xbgr.mr_n86994000)
print v(xbgr.mr_n87064640)
print v(xbgr.mr_n87483008)
print v(xbgr.mr_n87603936)
print v(xbgr.mr_n87744192)
print v(xbgr.mr_n87813648)
print v(xbgr.mr_n87867536)
print v(xbgr.mr_n88143088)
print v(xbgr.mr_n88258512)
print v(xbgr.mr_n88395840)
print v(xbgr.mr_n87605008)
print v(xbgr.mr_n87701856)
print v(xbgr.mr_n87809920)
print v(xbgr.mr_n87886160)
print v(xbgr.mr_n88142336)
print v(xbgr.mr_n88272032)
print v(xbgr.mr_n88394608)
print v(xbgr.mr_n86283408)
print v(xbgr.mr_n86503776)
print v(xbgr.mr_n86680432)
print v(xbgr.mr_n86916320)
print v(xbgr.mr_n88631600)
print v(xbgr.mr_n88800112)
print v(xbgr.mr_n89045504)
print v(xbgr.mr_n88445424)
print v(xbgr.mr_n88667840)
print v(xbgr.mr_n88876400)
print v(xbgr.mr_n87527472)
print v(xbgr.mr_n87636320)
print v(xbgr.mr_n87759776)
print v(xbgr.mr_n87845408)
print v(xbgr.mr_n88048240)
print v(xbgr.mr_n88174544)
print v(xbgr.mr_n88306752)
print v(xbgr.mr_n86297792)
print v(xbgr.mr_n86504368)
print v(xbgr.mr_n86681024)
print v(xbgr.mr_n86916432)
print v(xbgr.mr_n88633952)
print v(xbgr.mr_n88797152)
print v(xbgr.mr_n89043120)
print v(xbgr.mr_n86298256)
print v(xbgr.mr_n86504960)
print v(xbgr.mr_n86681616)
print v(xbgr.mr_n86916544)
print v(xbgr.mr_n87143456)
print v(xbgr.mr_n87606096)
print v(xbgr.mr_n87756672)
print v(xbgr.mr_n87825216)
print v(xbgr.mr_n87897648)
print v(xbgr.mr_n88147040)
print v(xbgr.mr_n88234480)
print v(xbgr.mr_n88361632)
print v(xbgr.mr_n88634816)
print v(xbgr.mr_n88859232)
print v(xbgr.mr_n89040384)
print v(xbgr.mr_n86995584)
print v(xbgr.mr_n87064752)
print v(xbgr.mr_n87482544)
print v(xbgr.mr_n86989408)
print v(xbgr.mr_n87064288)
print v(xbgr.mr_n87484112)
print v(xbgr.mr_n86298720)
print v(xbgr.mr_n86505552)
print v(xbgr.mr_n86682208)
print v(xbgr.mr_n86916928)
print v(xbgr.mr_n88636032)
print v(xbgr.mr_n88796560)
print v(xbgr.mr_n89044688)
print v(xbgr.mr_n87138032)
print v(xbgr.mr_n86934016)
print v(xbgr.mr_n87025584)
print v(xbgr.mr_n87365920)
print v(xbgr.mr_n87085472)
print v(xbgr.mr_n88447280)
print v(xbgr.mr_n88667376)
print v(xbgr.mr_n88878256)
print v(xbgr.mr_n86299184)
print v(xbgr.mr_n86506144)
print v(xbgr.mr_n86682800)
print v(xbgr.mr_n86917280)
print v(xbgr.mr_n87115904)
print v(xbgr.mr_n88636976)
print v(xbgr.mr_n88800704)
print v(xbgr.mr_n89047248)
print v(xbgr.mr_n86995232)
print v(xbgr.mr_n87065120)
print v(xbgr.mr_n87473200)
print v(xbgr.mr_n86299648)
print v(xbgr.mr_n86451456)
print v(xbgr.mr_n86683392)
print v(xbgr.mr_n86917552)
print v(xbgr.mr_n87598736)
print v(xbgr.mr_n87758048)
print v(xbgr.mr_n87819184)
print v(xbgr.mr_n87897456)
print v(xbgr.mr_n88147424)
print v(xbgr.mr_n88268624)
print v(xbgr.mr_n88388560)
print v(xbgr.mr_n87606816)
print v(xbgr.mr_n87749184)
print v(xbgr.mr_n87824800)
print v(xbgr.mr_n87898192)
print v(xbgr.mr_n88148992)
print v(xbgr.mr_n88272848)
print v(xbgr.mr_n88390304)
print v(xbgr.mr_n88637392)
print v(xbgr.mr_n88860864)
print v(xbgr.mr_n89042944)
print v(xbgr.mr_n86300112)
print v(xbgr.mr_n86507248)
print v(xbgr.mr_n86683984)
print v(xbgr.mr_n86917824)
print v(xbgr.mr_n87527008)
print v(xbgr.mr_n87635856)
print v(xbgr.mr_n87760592)
print v(xbgr.mr_n87846144)
print v(xbgr.mr_n88049056)
print v(xbgr.mr_n88175360)
print v(xbgr.mr_n88307568)
print v(xbgr.mr_n88638320)
print v(xbgr.mr_n88801296)
print v(xbgr.mr_n89045680)
print v(xbgr.mr_n86300576)
print v(xbgr.mr_n86507920)
print v(xbgr.mr_n86684576)
print v(xbgr.mr_n86918096)
print v(xbgr.mr_n88449136)
print v(xbgr.mr_n88666912)
print v(xbgr.mr_n88880144)
print v(xbgr.mr_n87605440)
print v(xbgr.mr_n87756480)
print v(xbgr.mr_n87825408)
print v(xbgr.mr_n87898464)
print v(xbgr.mr_n88150464)
print v(xbgr.mr_n88233888)
print v(xbgr.mr_n88358736)
print v(xbgr.mr_n88639264)
print v(xbgr.mr_n88799520)
print v(xbgr.mr_n89040560)
print v(xbgr.mr_n86990864)
print v(xbgr.mr_n87067072)
print v(xbgr.d3)
print v(xbgr.mr_n87450784)
print v(xbgr.mr_n86992912)
print v(xbgr.mr_n87067760)
print v(xbgr.mr_n87306336)
print v(xbgr.mr_n87481504)
print v(xbgr.mr_n86301040)
print v(xbgr.mr_n86508512)
print v(xbgr.mr_n86685168)
print v(xbgr.mr_n86918368)
print v(xbgr.mr_n86933744)
print v(xbgr.mr_n87025312)
print v(xbgr.mr_n86845648)
print v(xbgr.mr_n87364736)
print v(xbgr.mr_n88639792)
print v(xbgr.mr_n88862496)
print v(xbgr.mr_n89048240)
print v(xbgr.mr_n86301504)
print v(xbgr.mr_n86509104)
print v(xbgr.mr_n86685760)
print v(xbgr.mr_n86918640)
print v(xbgr.mr_n88640672)
print v(xbgr.mr_n88795680)
print v(xbgr.mr_n89053184)
print v(xbgr.mr_n86301968)
print v(xbgr.mr_n86509696)
print v(xbgr.mr_n86686352)
print v(xbgr.mr_n86919264)
print v(xbgr.mr_n86991536)
print v(xbgr.mr_n87066720)
print v(xbgr.mr_n87276368)
print v(xbgr.mr_n87486144)
print v(xbgr.mr_n87604432)
print v(xbgr.mr_n87733232)
print v(xbgr.mr_n87748192)
print v(xbgr.mr_n87897344)
print v(xbgr.mr_n88023936)
print v(xbgr.mr_n88148624)
print v(xbgr.mr_n88268272)
print v(xbgr.mr_n88391120)
print v(xbgr.mr_n87608112)
print v(xbgr.mr_n87744672)
print v(xbgr.mr_n87811440)
print v(xbgr.mr_n87899056)
print v(xbgr.mr_n88029872)
print v(xbgr.mr_n88150032)
print v(xbgr.mr_n88264800)
print v(xbgr.mr_n88389952)
print v(xbgr.mr_n88450992)
print v(xbgr.mr_n88666464)
print v(xbgr.mr_n88882512)
print v(xbgr.mr_n88642016)
print v(xbgr.mr_n88797744)
print v(xbgr.mr_n89050800)
print v(xbgr.mr_n86302432)
print v(xbgr.mr_n86510288)
print v(xbgr.mr_n86686944)
print v(xbgr.mr_n86919744)
print v(xbgr.mr_n87526544)
print v(xbgr.mr_n87635392)
print v(xbgr.mr_n87761408)
print v(xbgr.mr_n87845680)
print v(xbgr.mr_n87921760)
print v(xbgr.mr_n88049872)
print v(xbgr.mr_n88176176)
print v(xbgr.mr_n88308384)
print v(xbgr.mr_n86302896)
print v(xbgr.mr_n86510880)
print v(xbgr.mr_n86687536)
print v(xbgr.mr_n86920144)
print v(xbgr.mr_n88639904)
print v(xbgr.mr_n88863584)
print v(xbgr.mr_n89048064)
print v(xbgr.mr_n87609264)
print v(xbgr.mr_n87757632)
print v(xbgr.mr_n87819376)
print v(xbgr.mr_n87898080)
print v(xbgr.mr_n88030208)
print v(xbgr.mr_n88151568)
print v(xbgr.mr_n88236848)
print v(xbgr.mr_n88359856)
print v(xbgr.mr_n86983984)
print v(xbgr.mr_n87068640)
print v(xbgr.mr_n87264416)
print v(xbgr.mr_n87484640)
print v(xbgr.mr_n86990976)
print v(xbgr.mr_n87066224)
print v(xbgr.mr_n87306560)
print v(xbgr.mr_n87485680)
print v(xbgr.mr_n86289440)
print v(xbgr.mr_n86511472)
print v(xbgr.mr_n86688128)
print v(xbgr.mr_n86897408)
print v(xbgr.mr_n88643200)
print v(xbgr.mr_n88790240)
print v(xbgr.mr_n89052368)
print v(xbgr.mr_n88451920)
print v(xbgr.mr_n88666000)
print v(xbgr.mr_n88883696)
print v(xbgr.mr_n86303824)
print v(xbgr.mr_n86512064)
print v(xbgr.mr_n86688720)
print v(xbgr.mr_n86748912)
print v(xbgr.mr_n86933472)
print v(xbgr.mr_n87025040)
print v(xbgr.mr_n86382144)
print v(xbgr.mr_n87363552)
print v(xbgr.mr_n88643376)
print v(xbgr.mr_n88793184)
print v(xbgr.mr_n89053360)
print v(xbgr.mr_n86304288)
print v(xbgr.mr_n86488592)
print v(xbgr.mr_n86404512)
print v(xbgr.mr_n86921744)
print v(xbgr.mr_n86985440)
print v(xbgr.mr_n87063168)
print v(xbgr.mr_n87276096)
print v(xbgr.mr_n87484992)
print v(xbgr.mr_n88644224)
print v(xbgr.mr_n88865760)
print v(xbgr.mr_n89050624)
print v(xbgr.mr_n87604896)
print v(xbgr.mr_n87722592)
print v(xbgr.mr_n87826640)
print v(xbgr.mr_n87899808)
print v(xbgr.mr_n88029984)
print v(xbgr.mr_n88152448)
print v(xbgr.mr_n88261920)
print v(xbgr.mr_n88378304)
print v(xbgr.mr_n87606448)
print v(xbgr.mr_n87712224)
print v(xbgr.mr_n87811888)
print v(xbgr.mr_n87897232)
print v(xbgr.mr_n88031168)
print v(xbgr.mr_n88147776)
print v(xbgr.mr_n88269440)
print v(xbgr.mr_n87857840)
print v(xbgr.mr_n86304752)
print v(xbgr.mr_n86513184)
print v(xbgr.mr_n86689904)
print v(xbgr.mr_n86852112)
print v(xbgr.mr_n88645040)
print v(xbgr.mr_n88710064)
print v(xbgr.mr_n89054928)
print v(xbgr.mr_n87526080)
print v(xbgr.mr_n87634464)
print v(xbgr.mr_n87762416)
print v(xbgr.mr_n87845136)
print v(xbgr.mr_n87924224)
print v(xbgr.mr_n88050688)
print v(xbgr.mr_n88176992)
print v(xbgr.mr_n88309200)
print v(xbgr.mr_n88451456)
print v(xbgr.mr_n88665536)
print v(xbgr.mr_n88883104)
print v(xbgr.mr_n86305216)
print v(xbgr.mr_n86506736)
print v(xbgr.mr_n86690496)
print v(xbgr.mr_n86922464)
print v(xbgr.mr_n88641008)
print v(xbgr.mr_n88593104)
print v(xbgr.mr_n89057488)
print v(xbgr.mr_n87609984)
print v(xbgr.mr_n87708384)
print v(xbgr.mr_n87812704)
print v(xbgr.mr_n87902528)
print v(xbgr.mr_n88026000)
print v(xbgr.mr_n88152880)
print v(xbgr.mr_n88236256)
print v(xbgr.mr_n88360512)
print v(xbgr.mr_n86305680)
print v(xbgr.mr_n86514368)
print v(xbgr.mr_n86691088)
print v(xbgr.mr_n86922944)
print v(xbgr.mr_n86989840)
print v(xbgr.mr_n87070208)
print v(xbgr.mr_n87221312)
print v(xbgr.mr_n87487248)
print v(xbgr.mr_n86986048)
print v(xbgr.mr_n87070896)
print v(xbgr.mr_n87221056)
print v(xbgr.mr_n87488816)
print v(xbgr.mr_n88646512)
print v(xbgr.mr_n88865216)
print v(xbgr.mr_n89055920)
print v(xbgr.mr_n86306144)
print v(xbgr.mr_n86515024)
print v(xbgr.mr_n86691680)
print v(xbgr.mr_n86923744)
print v(xbgr.mr_n86933200)
print v(xbgr.mr_n87024768)
print v(xbgr.mr_n87100592)
print v(xbgr.mr_n87362368)
print v(xbgr.mr_n88645984)
print v(xbgr.mr_n88701392)
print v(xbgr.mr_n89049808)
print v(xbgr.mr_n86306608)
print v(xbgr.mr_n86512656)
print v(xbgr.mr_n86692272)
print v(xbgr.mr_n86924144)
print v(xbgr.mr_n88450528)
print v(xbgr.mr_n88665072)
print v(xbgr.mr_n88881920)
print v(xbgr.mr_n86988384)
print v(xbgr.mr_n87069792)
print v(xbgr.mr_n87275008)
print v(xbgr.mr_n87489344)
print v(xbgr.mr_n87610672)
print v(xbgr.mr_n87731680)
print v(xbgr.mr_n87827872)
print v(xbgr.mr_n87900240)
print v(xbgr.mr_n88031056)
print v(xbgr.mr_n88150880)
print v(xbgr.mr_n88251408)
print v(xbgr.mr_n88388976)
print v(xbgr.mr_n88644784)
print v(xbgr.mr_n88584592)
print v(xbgr.mr_n89060048)
print v(xbgr.mr_n87607616)
print v(xbgr.mr_n87691936)
print v(xbgr.mr_n87812592)
print v(xbgr.mr_n87902096)
print v(xbgr.mr_n88032080)
print v(xbgr.mr_n88156272)
print v(xbgr.mr_n88265216)
print v(xbgr.mr_n88388336)
print v(xbgr.mr_n86307072)
print v(xbgr.mr_n86516128)
print v(xbgr.mr_n86692864)
print v(xbgr.mr_n86924544)
print v(xbgr.mr_n87525616)
print v(xbgr.mr_n87634000)
print v(xbgr.mr_n87762880)
print v(xbgr.mr_n87844864)
print v(xbgr.mr_n87925040)
print v(xbgr.mr_n88051504)
print v(xbgr.mr_n88177808)
print v(xbgr.mr_n88310016)
print v(xbgr.mr_n86273664)
print v(xbgr.mr_n86516800)
print v(xbgr.mr_n86693456)
print v(xbgr.mr_n86924944)
print v(xbgr.mr_n88648544)
print v(xbgr.mr_n88864128)
print v(xbgr.mr_n89062608)
print v(xbgr.mr_n88646400)
print v(xbgr.mr_n88789648)
print v(xbgr.mr_n89060864)
print v(xbgr.mr_n86273200)
print v(xbgr.mr_n86517392)
print v(xbgr.mr_n86627424)
print v(xbgr.mr_n86925344)
print v(xbgr.mr_n87612432)
print v(xbgr.mr_n87743712)
print v(xbgr.mr_n87811664)
print v(xbgr.mr_n87901552)
print v(xbgr.mr_n88032976)
print v(xbgr.mr_n88149552)
print v(xbgr.mr_n88235664)
print v(xbgr.mr_n88354528)
print v(xbgr.mr_n86988560)
print v(xbgr.mr_n87071776)
print v(xbgr.mr_n87203488)
print v(xbgr.mr_n87483424)
print v(xbgr.mr_n86984592)
print v(xbgr.mr_n87068288)
print v(xbgr.mr_n87225680)
print v(xbgr.mr_n87486560)
print v(xbgr.mr_n88450064)
print v(xbgr.mr_n88664608)
print v(xbgr.mr_n88881328)
print v(xbgr.mr_n88650416)
print v(xbgr.mr_n88708400)
print v(xbgr.mr_n88994592)
print v(xbgr.mr_n86272816)
print v(xbgr.mr_n86517984)
print v(xbgr.mr_n86626832)
print v(xbgr.mr_n86922144)
print v(xbgr.mr_n86932928)
print v(xbgr.mr_n87024496)
print v(xbgr.mr_n86806960)
print v(xbgr.mr_n87361184)
print v(xbgr.mr_n86272352)
print v(xbgr.mr_n86518576)
print v(xbgr.mr_n86626240)
print v(xbgr.mr_n86926464)
print v(xbgr.mr_n88650832)
print v(xbgr.mr_n88864672)
print v(xbgr.mr_n89061040)
print v(xbgr.mr_n86987264)
print v(xbgr.mr_n87063552)
print v(xbgr.mr_n87275552)
print v(xbgr.mr_n87488128)
print v(xbgr.mr_n87612256)
print v(xbgr.mr_n87693648)
print v(xbgr.mr_n87828624)
print v(xbgr.mr_n87898816)
print v(xbgr.mr_n88033664)
print v(xbgr.mr_n88153568)
print v(xbgr.mr_n88261808)
print v(xbgr.mr_n88384416)
print v(xbgr.mr_n86271888)
print v(xbgr.mr_n86519168)
print v(xbgr.mr_n86625648)
print v(xbgr.mr_n86926944)
print v(xbgr.mr_n87613152)
print v(xbgr.mr_n87687312)
print v(xbgr.mr_n87811776)
print v(xbgr.mr_n87905632)
print v(xbgr.mr_n88032256)
print v(xbgr.mr_n88158272)
print v(xbgr.mr_n88266032)
print v(xbgr.mr_n88253040)
print v(xbgr.mr_n88649472)
print v(xbgr.mr_n88792016)
print v(xbgr.mr_n89058304)
print v(xbgr.mr_n88449600)
print v(xbgr.mr_n88664144)
print v(xbgr.mr_n88880736)
print v(xbgr.mr_n86271424)
print v(xbgr.mr_n86519760)
print v(xbgr.mr_n86625056)
print v(xbgr.mr_n86927344)
print v(xbgr.mr_n87525152)
print v(xbgr.mr_n87633072)
print v(xbgr.mr_n87761952)
print v(xbgr.mr_n87844320)
print v(xbgr.mr_n87925856)
print v(xbgr.mr_n88051232)
print v(xbgr.mr_n88177536)
print v(xbgr.mr_n88309744)
print v(xbgr.mr_n88650944)
print v(xbgr.mr_n88711184)
print v(xbgr.mr_n88994352)
print v(xbgr.mr_n86270960)
print v(xbgr.mr_n86520352)
print v(xbgr.mr_n86624464)
print v(xbgr.mr_n86927744)
print v(xbgr.mr_n87609616)
print v(xbgr.mr_n87692320)
print v(xbgr.mr_n87829056)
print v(xbgr.mr_n87907232)
print v(xbgr.mr_n88035424)
print v(xbgr.mr_n88157584)
print v(xbgr.mr_n88228560)
print v(xbgr.mr_n88356960)
print v(xbgr.mr_n86987088)
print v(xbgr.mr_n87073344)
print v(xbgr.mr_n87304928)
print v(xbgr.mr_n87490384)
print v(xbgr.mr_n88647728)
print v(xbgr.mr_n88859776)
print v(xbgr.mr_n89058480)
print v(xbgr.mr_n86985872)
print v(xbgr.mr_n87069328)
print v(xbgr.mr_n87299840)
print v(xbgr.mr_n87491952)
print v(xbgr.mr_n86270496)
print v(xbgr.mr_n86495536)
print v(xbgr.mr_n86622464)
print v(xbgr.mr_n86928544)
print v(xbgr.mr_n88647392)
print v(xbgr.mr_n88792608)
print v(xbgr.mr_n88977424)
print v(xbgr.mr_n86932656)
print v(xbgr.mr_n87024304)
print v(xbgr.mr_n87092016)
print v(xbgr.mr_n87360000)
print v(xbgr.mr_n86111248)
print v(xbgr.mr_n86521472)
print v(xbgr.mr_n86698400)
print v(xbgr.mr_n86763712)
print v(xbgr.mr_n88448672)
print v(xbgr.mr_n88663680)
print v(xbgr.mr_n88879648)
print v(xbgr.mr_n88649216)
print v(xbgr.mr_n88790832)
print v(xbgr.mr_n88985792)
print v(xbgr.mr_n86982976)
print v(xbgr.mr_n87072992)
print v(xbgr.mr_n87275280)
print v(xbgr.mr_n87490848)
print v(xbgr.mr_n86111888)
print v(xbgr.mr_n86522128)
print v(xbgr.mr_n86699840)
print v(xbgr.mr_n86763120)
print v(xbgr.mr_n87611280)
print v(xbgr.mr_n87712464)
print v(xbgr.mr_n87813056)
print v(xbgr.mr_n87906800)
print v(xbgr.mr_n88032608)
print v(xbgr.mr_n88155232)
print v(xbgr.mr_n88262624)
print v(xbgr.mr_n87875408)
print v(xbgr.mr_n87610320)
print v(xbgr.mr_n87718480)
print v(xbgr.mr_n87831552)
print v(xbgr.mr_n87908336)
print v(xbgr.mr_n88036144)
print v(xbgr.mr_n88155584)
print v(xbgr.mr_n88261456)
print v(xbgr.mr_n88387296)
print v(xbgr.mr_n88648656)
print v(xbgr.mr_n88863040)
print v(xbgr.mr_n88978736)
print v(xbgr.mr_n86269104)
print v(xbgr.mr_n86522720)
print v(xbgr.mr_n86700240)
print v(xbgr.mr_n86762592)
print v(xbgr.mr_n87524688)
print v(xbgr.mr_n87632608)
print v(xbgr.mr_n87761680)
print v(xbgr.mr_n87844048)
print v(xbgr.mr_n87926672)
print v(xbgr.mr_n88050960)
print v(xbgr.mr_n88177264)
print v(xbgr.mr_n88309472)
print v(xbgr.mr_n88642192)
print v(xbgr.mr_n88791424)
print v(xbgr.mr_n89055744)
print v(xbgr.mr_n86268640)
print v(xbgr.mr_n86523312)
print v(xbgr.mr_n86701440)
print v(xbgr.mr_n86754240)
print v(xbgr.mr_n88448208)
print v(xbgr.mr_n88663216)
print v(xbgr.mr_n88879184)
print v(xbgr.mr_n87607504)
print v(xbgr.mr_n87727888)
print v(xbgr.mr_n87812240)
print v(xbgr.mr_n87904512)
print v(xbgr.mr_n88034768)
print v(xbgr.mr_n88158960)
print v(xbgr.mr_n88232704)
print v(xbgr.mr_n88356304)
print v(xbgr.mr_n86980224)
print v(xbgr.mr_n87074912)
print v(xbgr.mr_n87277376)
print v(xbgr.mr_n87487712)
print v(xbgr.mr_n88632416)
print v(xbgr.mr_n88789056)
print v(xbgr.mr_n88983584)
print v(xbgr.mr_n86981440)
print v(xbgr.mr_n87075600)
print v(xbgr.mr_n87304384)
print v(xbgr.mr_n87489696)
print v(xbgr.mr_n86268176)
print v(xbgr.mr_n86523904)
print v(xbgr.mr_n86702240)
print v(xbgr.mr_n86761344)
print v(xbgr.mr_n86932384)
print v(xbgr.mr_n87023552)
print v(xbgr.mr_n86775184)
print v(xbgr.mr_n87358816)
print v(xbgr.mr_n86267712)
print v(xbgr.mr_n86524496)
print v(xbgr.mr_n86702640)
print v(xbgr.mr_n86760752)
print v(xbgr.mr_n88644112)
print v(xbgr.mr_n88937872)
print v(xbgr.mr_n86267248)
print v(xbgr.mr_n86525088)
print v(xbgr.mr_n86703840)
print v(xbgr.mr_n86760160)
print v(xbgr.mr_n88638064)
print v(xbgr.mr_n88937200)
print v(xbgr.mr_n86978432)
print v(xbgr.mr_n87074496)
print v(xbgr.mr_n87238064)
print v(xbgr.mr_n87491264)
print v(xbgr.mr_n87604784)
print v(xbgr.mr_n87704928)
print v(xbgr.mr_n87829360)
print v(xbgr.mr_n87904944)
print v(xbgr.mr_n88036832)
print v(xbgr.mr_n88162976)
print v(xbgr.mr_n88253248)
print v(xbgr.mr_n88381008)
print v(xbgr.mr_n87609088)
print v(xbgr.mr_n87721920)
print v(xbgr.mr_n87833104)
print v(xbgr.mr_n87910336)
print v(xbgr.mr_n88034272)
print v(xbgr.mr_n88159936)
print v(xbgr.mr_n88255152)
print v(xbgr.mr_n88384304)
print v(xbgr.mr_n88447744)
print v(xbgr.mr_n88878720)
print v(xbgr.mr_n86266784)
print v(xbgr.mr_n86525680)
print v(xbgr.mr_n86704240)
print v(xbgr.mr_n86759568)
print v(xbgr.mr_n88642768)
print v(xbgr.mr_n88981552)
print v(xbgr.mr_n87524224)
print v(xbgr.mr_n87631680)
print v(xbgr.mr_n87761136)
print v(xbgr.mr_n87843504)
print v(xbgr.mr_n87927216)
print v(xbgr.mr_n88050416)
print v(xbgr.mr_n88176720)
print v(xbgr.mr_n88308928)
print v(xbgr.mr_n86266320)
print v(xbgr.mr_n86526272)
print v(xbgr.mr_n86705440)
print v(xbgr.mr_n86758976)
print v(xbgr.mr_n88634704)
print v(xbgr.mr_n88987472)
print v(xbgr.mr_n87607152)
print v(xbgr.mr_n87686880)
print v(xbgr.mr_n87832800)
print v(xbgr.mr_n87909648)
print v(xbgr.mr_n88038592)
print v(xbgr.mr_n88162288)
print v(xbgr.mr_n88210208)
print v(xbgr.mr_n88351632)
print v(xbgr.mr_n86974160)
print v(xbgr.mr_n87076480)
print v(xbgr.mr_n87300864)
print v(xbgr.mr_n87493520)
print v(xbgr.mr_n86265856)
print v(xbgr.mr_n86526864)
print v(xbgr.mr_n86706240)
print v(xbgr.mr_n86758448)
print v(xbgr.mr_n86984416)
print v(xbgr.mr_n87077168)
print v(xbgr.mr_n87303888)
print v(xbgr.mr_n87495088)
print v(xbgr.mr_n88639680)
print v(xbgr.mr_n88981728)
print v(xbgr.mr_n88446816)
print v(xbgr.mr_n88877792)
print v(xbgr.mr_n86265392)
print v(xbgr.mr_n86515616)
print v(xbgr.mr_n86706640)
print v(xbgr.mr_n86753056)
print v(xbgr.mr_n86932112)
print v(xbgr.mr_n87021440)
print v(xbgr.mr_n87089840)
print v(xbgr.mr_n87357632)
print v(xbgr.mr_n88635696)
print v(xbgr.mr_n89063392)
print v(xbgr.mr_n86264928)
print v(xbgr.mr_n86527968)
print v(xbgr.mr_n86707440)
print v(xbgr.mr_n86757200)
print v(xbgr.mr_n86982128)
print v(xbgr.mr_n87072464)
print v(xbgr.mr_n87244208)
print v(xbgr.mr_n87493984)
print v(xbgr.mr_n87603712)
print v(xbgr.mr_n87686768)
print v(xbgr.mr_n87831120)
print v(xbgr.mr_n87907648)
print v(xbgr.mr_n88038416)
print v(xbgr.mr_n88160288)
print v(xbgr.mr_n88257984)
print v(xbgr.mr_n88385120)
print v(xbgr.mr_n88637504)
print v(xbgr.mr_n89063504)
print v(xbgr.mr_n87605920)
print v(xbgr.mr_n87717088)
print v(xbgr.mr_n87835296)
print v(xbgr.mr_n87913040)
print v(xbgr.mr_n88039376)
print v(xbgr.mr_n88165680)
print v(xbgr.mr_n88258400)
print v(xbgr.mr_n88383952)
print v(xbgr.mr_n86264464)
print v(xbgr.mr_n86528640)
print v(xbgr.mr_n86708240)
print v(xbgr.mr_n86756608)
print v(xbgr.mr_n88624288)
print v(xbgr.mr_n88974560)
print v(xbgr.mr_n87523760)
print v(xbgr.mr_n87631216)
print v(xbgr.mr_n87760864)
print v(xbgr.mr_n87843232)
print v(xbgr.mr_n87926944)
print v(xbgr.mr_n88050144)
print v(xbgr.mr_n88176448)
print v(xbgr.mr_n88308656)
print v(xbgr.mr_n86264000)
print v(xbgr.mr_n86529232)
print v(xbgr.mr_n86709440)
print v(xbgr.mr_n86756016)
print v(xbgr.mr_n88446352)
print v(xbgr.mr_n88877328)
print v(xbgr.mr_n88633024)
print v(xbgr.mr_n88982560)
print v(xbgr.mr_n86263536)
print v(xbgr.mr_n86529824)
print v(xbgr.mr_n86709840)
print v(xbgr.mr_n86755424)
print v(xbgr.mr_n87595040)
print v(xbgr.mr_n87702304)
print v(xbgr.mr_n87833728)
print v(xbgr.mr_n87909216)
print v(xbgr.mr_n88037936)
print v(xbgr.mr_n88161856)
print v(xbgr.mr_n88233296)
print v(xbgr.mr_n88350976)
print v(xbgr.mr_n86982800)
print v(xbgr.mr_n87078048)
print v(xbgr.mr_n87301840)
print v(xbgr.mr_n87492480)
print v(xbgr.mr_n86982240)
print v(xbgr.mr_n87074032)
print v(xbgr.mr_n87302560)
print v(xbgr.mr_n87492832)
print v(xbgr.mr_n88634928)
print v(xbgr.mr_n88861952)
print v(xbgr.mr_n88962032)
print v(xbgr.mr_n86263072)
print v(xbgr.mr_n86496720)
print v(xbgr.mr_n86710640)
print v(xbgr.mr_n86754752)
print v(xbgr.mr_n86931840)
print v(xbgr.mr_n87020384)
print v(xbgr.mr_n86364896)
print v(xbgr.mr_n87356448)
print v(xbgr.mr_n88634128)
print v(xbgr.mr_n88788464)
print v(xbgr.mr_n89063616)
print v(xbgr.mr_n86262608)
print v(xbgr.mr_n86530944)
print v(xbgr.mr_n86711840)
print v(xbgr.mr_n86751280)
print v(xbgr.mr_n88445888)
print v(xbgr.mr_n88662752)
print v(xbgr.mr_n88876864)
print v(xbgr.mr_n86979616)
print v(xbgr.mr_n87077696)
print v(xbgr.mr_n87274208)
print v(xbgr.mr_n87497120)
print v(xbgr.mr_n87600432)
print v(xbgr.mr_n87715280)
print v(xbgr.mr_n87836112)
print v(xbgr.mr_n87913920)
print v(xbgr.mr_n88040256)
print v(xbgr.mr_n88167680)
print v(xbgr.mr_n87990688)
print v(xbgr.mr_n88366016)
print v(xbgr.mr_n88630784)
print v(xbgr.mr_n88787872)
print v(xbgr.mr_n89064992)
print v(xbgr.mr_n87603824)
print v(xbgr.mr_n87705952)
print v(xbgr.mr_n87830768)
print v(xbgr.mr_n87902944)
print v(xbgr.mr_n88036944)
print v(xbgr.mr_n88157152)
print v(xbgr.mr_n88257552)
print v(xbgr.mr_n88377600)
print v(xbgr.mr_n86262144)
print v(xbgr.mr_n86531600)
print v(xbgr.mr_n86712240)
print v(xbgr.mr_n86753568)
print v(xbgr.mr_n87523296)
print v(xbgr.mr_n87630288)
print v(xbgr.mr_n87760320)
print v(xbgr.mr_n87842960)
print v(xbgr.mr_n87926400)
print v(xbgr.mr_n88049600)
print v(xbgr.mr_n88175904)
print v(xbgr.mr_n88308112)
print v(xbgr.mr_n86112160)
print v(xbgr.mr_n86532192)
print v(xbgr.mr_n86713504)
print v(xbgr.mr_n86741216)
print v(xbgr.mr_n88628976)
print v(xbgr.mr_n88861408)
print v(xbgr.mr_n88941152)
print v(xbgr.mr_n86261216)
print v(xbgr.mr_n86532784)
print v(xbgr.mr_n86714096)
print v(xbgr.mr_n86752464)
print v(xbgr.mr_n88627232)
print v(xbgr.mr_n88784912)
print v(xbgr.mr_n89069120)
print v(xbgr.mr_n87602624)
print v(xbgr.mr_n87707872)
print v(xbgr.mr_n87838256)
print v(xbgr.mr_n87912352)
print v(xbgr.mr_n88038944)
print v(xbgr.mr_n88169344)
print v(xbgr.mr_n88171264)
print v(xbgr.mr_n88355184)
print v(xbgr.mr_n86981264)
print v(xbgr.mr_n87079616)
print v(xbgr.mr_n87298320)
print v(xbgr.mr_n87496656)
print v(xbgr.mr_n86975952)
print v(xbgr.mr_n87080304)
print v(xbgr.mr_n87301344)
print v(xbgr.mr_n87498224)
print v(xbgr.mr_n88444960)
print v(xbgr.mr_n88662288)
print v(xbgr.mr_n88875936)
print v(xbgr.mr_n86260752)
print v(xbgr.mr_n86533376)
print v(xbgr.mr_n86715872)
print v(xbgr.mr_n86751792)
print v(xbgr.mr_n88627424)
print v(xbgr.mr_n88786688)
print v(xbgr.mr_n89067120)
print v(xbgr.mr_n86931568)
print v(xbgr.mr_n86993776)
print v(xbgr.mr_n86774576)
print v(xbgr.mr_n87355264)
print v(xbgr.mr_n86260288)
print v(xbgr.mr_n86533968)
print v(xbgr.mr_n86717056)
print v(xbgr.mr_n86745280)
print v(xbgr.mr_n88628624)
print v(xbgr.mr_n88860320)
print v(xbgr.mr_n89064720)
print v(xbgr.mr_n86978608)
print v(xbgr.mr_n87079200)
print v(xbgr.mr_n87274432)
print v(xbgr.mr_n87478192)
print v(xbgr.mr_n86259824)
print v(xbgr.mr_n86534560)
print v(xbgr.mr_n86717648)
print v(xbgr.mr_n86750688)
print v(xbgr.mr_n87600000)
print v(xbgr.mr_n87718112)
print v(xbgr.mr_n87836848)
print v(xbgr.mr_n87916208)
print v(xbgr.mr_n88042544)
print v(xbgr.mr_n88164992)
print v(xbgr.mr_n88253472)
print v(xbgr.mr_n88380544)
print v(xbgr.mr_n87587968)
print v(xbgr.mr_n87716368)
print v(xbgr.mr_n87834864)
print v(xbgr.mr_n87917744)
print v(xbgr.mr_n88044080)
print v(xbgr.mr_n88170384)
print v(xbgr.mr_n88253360)
print v(xbgr.mr_n88380896)
print v(xbgr.mr_n88627888)
print v(xbgr.mr_n88785744)
print v(xbgr.mr_n89068624)
print v(xbgr.mr_n88444496)
print v(xbgr.mr_n88661824)
print v(xbgr.mr_n88875472)
print v(xbgr.mr_n86259360)
print v(xbgr.mr_n86535152)
print v(xbgr.mr_n86718832)
print v(xbgr.mr_n86750096)
print v(xbgr.mr_n87522832)
print v(xbgr.mr_n87629824)
print v(xbgr.mr_n87760048)
print v(xbgr.mr_n87842688)
print v(xbgr.mr_n87926128)
print v(xbgr.mr_n88049328)
print v(xbgr.mr_n88175632)
print v(xbgr.mr_n88307840)
print v(xbgr.mr_n88627776)
print v(xbgr.mr_n88787280)
print v(xbgr.mr_n89071856)
print v(xbgr.mr_n86258896)
print v(xbgr.mr_n86535744)
print v(xbgr.mr_n86719424)
print v(xbgr.mr_n86749424)
print v(xbgr.mr_n87597936)
print v(xbgr.mr_n87718224)
print v(xbgr.mr_n87839040)
print v(xbgr.mr_n87915664)
print v(xbgr.mr_n88031600)
print v(xbgr.mr_n88166560)
print v(xbgr.mr_n88232112)
print v(xbgr.mr_n88352752)
print v(xbgr.mr_n86977872)
print v(xbgr.mr_n87081184)
print v(xbgr.mr_n87299232)
print v(xbgr.mr_n87472928)
print v(xbgr.mr_n86980048)
print v(xbgr.mr_n87076128)
print v(xbgr.mr_n87300016)
print v(xbgr.mr_n87475472)
print v(xbgr.mr_n88625952)
print v(xbgr.mr_n88858688)
print v(xbgr.mr_n89069232)
print v(xbgr.mr_n86258432)
print v(xbgr.mr_n86536336)
print v(xbgr.mr_n86718240)
print v(xbgr.mr_n86746016)
print v(xbgr.mr_n88622832)
print v(xbgr.mr_n88773456)
print v(xbgr.mr_n89067008)
print v(xbgr.mr_n86931296)
print v(xbgr.mr_n87019504)
print v(xbgr.mr_n86772144)
print v(xbgr.mr_n87354080)
print v(xbgr.mr_n86257968)
print v(xbgr.mr_n86536928)
print v(xbgr.mr_n86716464)
print v(xbgr.mr_n86748320)
print v(xbgr.mr_n88444032)
print v(xbgr.mr_n88661360)
print v(xbgr.mr_n88875008)
print v(xbgr.mr_n88623328)
print v(xbgr.mr_n88772992)
print v(xbgr.mr_n89066512)
print v(xbgr.mr_n86257504)
print v(xbgr.mr_n86527456)
print v(xbgr.mr_n86715280)
print v(xbgr.mr_n86747728)
print v(xbgr.mr_n86974960)
print v(xbgr.mr_n87071424)
print v(xbgr.mr_n87274320)
print v(xbgr.mr_n87472816)
print v(xbgr.mr_n87598912)
print v(xbgr.mr_n87690880)
print v(xbgr.mr_n87839856)
print v(xbgr.mr_n87918624)
print v(xbgr.mr_n88044960)
print v(xbgr.mr_n88166208)
print v(xbgr.mr_n88251296)
print v(xbgr.mr_n88368752)
print v(xbgr.mr_n87589456)
print v(xbgr.mr_n87755488)
print v(xbgr.mr_n87836544)
print v(xbgr.mr_n87914352)
print v(xbgr.mr_n88040688)
print v(xbgr.mr_n88172384)
print v(xbgr.mr_n88240992)
print v(xbgr.mr_n88374192)
print v(xbgr.mr_n86257040)
print v(xbgr.mr_n86538048)
print v(xbgr.mr_n86714688)
print v(xbgr.mr_n86747136)
print v(xbgr.mr_n88615344)
print v(xbgr.mr_n88856512)
print v(xbgr.mr_n89073200)
print v(xbgr.mr_n87522368)
print v(xbgr.mr_n87628896)
print v(xbgr.mr_n87759504)
print v(xbgr.mr_n87842416)
print v(xbgr.mr_n87925584)
print v(xbgr.mr_n88048784)
print v(xbgr.mr_n88175088)
print v(xbgr.mr_n88307296)
print v(xbgr.mr_n88614400)
print v(xbgr.mr_n88781360)
print v(xbgr.mr_n89078144)
print v(xbgr.mr_n86256576)
print v(xbgr.mr_n86513840)
print v(xbgr.mr_n86713040)
print v(xbgr.mr_n86746464)
print v(xbgr.mr_n88443104)
print v(xbgr.mr_n88660896)
print v(xbgr.mr_n88874080)
print v(xbgr.mr_n87596880)
print v(xbgr.mr_n87726416)
print v(xbgr.mr_n87839440)
print v(xbgr.mr_n87921344)
print v(xbgr.mr_n88044608)
print v(xbgr.mr_n88166992)
print v(xbgr.mr_n88231520)
print v(xbgr.mr_n88353408)
print v(xbgr.mr_n86974848)
print v(xbgr.mr_n87082752)
print v(xbgr.mr_n87297296)
print v(xbgr.mr_n87468672)
print v(xbgr.mr_n86977760)
print v(xbgr.mr_n87083440)
print v(xbgr.mr_n87295776)
print v(xbgr.mr_n87471008)
print v(xbgr.mr_n88621232)
print v(xbgr.mr_n88785568)
print v(xbgr.mr_n89077328)
print v(xbgr.mr_n86256112)
print v(xbgr.mr_n86539232)
print v(xbgr.mr_n86712640)
print v(xbgr.mr_n86737072)
print v(xbgr.mr_n86931024)
print v(xbgr.mr_n87018272)
print v(xbgr.mr_n87092208)
print v(xbgr.mr_n87352896)
print v(xbgr.mr_n86255648)
print v(xbgr.mr_n86539888)
print v(xbgr.mr_n86699440)
print v(xbgr.mr_n86709040)
print v(xbgr.mr_n88620304)
print v(xbgr.mr_n88858144)
print v(xbgr.mr_n89073024)
print v(xbgr.mr_n86255184)
print v(xbgr.mr_n86540480)
print v(xbgr.mr_n86711040)
print v(xbgr.mr_n86465632)
print v(xbgr.mr_n88615776)
print v(xbgr.mr_n88783136)
print v(xbgr.mr_n89075760)
print v(xbgr.mr_n86977072)
print v(xbgr.mr_n87078736)
print v(xbgr.mr_n87254448)
print v(xbgr.mr_n87467024)
print v(xbgr.mr_n87594864)
print v(xbgr.mr_n87729056)
print v(xbgr.mr_n87835760)
print v(xbgr.mr_n87919056)
print v(xbgr.mr_n88041376)
print v(xbgr.mr_n88163664)
print v(xbgr.mr_n87985568)
print v(xbgr.mr_n88377072)
print v(xbgr.mr_n87597056)
print v(xbgr.mr_n87738752)
print v(xbgr.mr_n87837824)
print v(xbgr.mr_n87920912)
print v(xbgr.mr_n88035776)
print v(xbgr.mr_n88168848)
print v(xbgr.mr_n88117440)
print v(xbgr.mr_n88377488)
print v(xbgr.mr_n88442640)
print v(xbgr.mr_n88660432)
print v(xbgr.mr_n88873616)
print v(xbgr.mr_n86254720)
print v(xbgr.mr_n86541072)
print v(xbgr.mr_n86696304)
print v(xbgr.mr_n86744176)
print v(xbgr.mr_n88619600)
print v(xbgr.mr_n88783792)
print v(xbgr.mr_n89078320)
print v(xbgr.mr_n87521904)
print v(xbgr.mr_n87628432)
print v(xbgr.mr_n87759152)
print v(xbgr.mr_n87842144)
print v(xbgr.mr_n87925312)
print v(xbgr.mr_n88048512)
print v(xbgr.mr_n88174816)
print v(xbgr.mr_n88307024)
print v(xbgr.mr_n86254256)
print v(xbgr.mr_n86541664)
print v(xbgr.mr_n86695840)
print v(xbgr.mr_n86743584)
print v(xbgr.mr_n88614512)
print v(xbgr.mr_n88857056)
print v(xbgr.mr_n89075584)
print v(xbgr.mr_n87596080)
print v(xbgr.mr_n87740672)
print v(xbgr.mr_n87834512)
print v(xbgr.mr_n87922912)
print v(xbgr.mr_n88039904)
print v(xbgr.mr_n88164640)
print v(xbgr.mr_n88230928)
print v(xbgr.mr_n88347680)
print v(xbgr.mr_n86253792)
print v(xbgr.mr_n86542256)
print v(xbgr.mr_n86708640)
print v(xbgr.mr_n86742992)
print v(xbgr.mr_n86976896)
print v(xbgr.mr_n87084320)
print v(xbgr.mr_n87296752)
print v(xbgr.mr_n87462704)
print v(xbgr.mr_n86975696)
print v(xbgr.mr_n87080832)
print v(xbgr.mr_n87297472)
print v(xbgr.mr_n87452592)
print v(xbgr.mr_n88583248)
print v(xbgr.mr_n88734752)
print v(xbgr.mr_n89079888)
print v(xbgr.mr_n86253328)
print v(xbgr.mr_n86542848)
print v(xbgr.mr_n86707840)
print v(xbgr.mr_n86742400)
print v(xbgr.mr_n88442176)
print v(xbgr.mr_n88659968)
print v(xbgr.mr_n88873152)
print v(xbgr.mr_n86930752)
print v(xbgr.mr_n86999376)
print v(xbgr.mr_n87116464)
print v(xbgr.mr_n87351712)
print v(xbgr.mr_n88615520)
print v(xbgr.mr_n88782016)
print v(xbgr.mr_n89080880)
print v(xbgr.mr_n86252864)
print v(xbgr.mr_n86543440)
print v(xbgr.mr_n86707040)
print v(xbgr.mr_n86741872)
print v(xbgr.mr_n86975520)
print v(xbgr.mr_n87082336)
print v(xbgr.mr_n87274096)
print v(xbgr.mr_n87460896)
print v(xbgr.mr_n87582128)
print v(xbgr.mr_n87739744)
print v(xbgr.mr_n87829920)
print v(xbgr.mr_n87919744)
print v(xbgr.mr_n88037440)
print v(xbgr.mr_n88160976)
print v(xbgr.mr_n88237440)
print v(xbgr.mr_n88369328)
print v(xbgr.mr_n87594432)
print v(xbgr.mr_n87720112)
print v(xbgr.mr_n87834080)
print v(xbgr.mr_n87916640)
print v(xbgr.mr_n88036480)
print v(xbgr.mr_n88164144)
print v(xbgr.mr_n88248240)
print v(xbgr.mr_n88374080)
print v(xbgr.mr_n88617136)
print v(xbgr.mr_n88854640)
print v(xbgr.mr_n89074768)
print v(xbgr.mr_n86252400)
print v(xbgr.mr_n86544032)
print v(xbgr.mr_n86705840)
print v(xbgr.mr_n86710240)
print v(xbgr.mr_n88609920)
print v(xbgr.mr_n88779584)
print v(xbgr.mr_n89082448)
print v(xbgr.mr_n87521440)
print v(xbgr.mr_n87627504)
print v(xbgr.mr_n87711296)
print v(xbgr.mr_n87841872)
print v(xbgr.mr_n87924768)
print v(xbgr.mr_n88047968)
print v(xbgr.mr_n88174272)
print v(xbgr.mr_n88306560)
print v(xbgr.mr_n86250288)
print v(xbgr.mr_n86544624)
print v(xbgr.mr_n86705040)
print v(xbgr.mr_n86740624)
print v(xbgr.mr_n88441248)
print v(xbgr.mr_n88659504)
print v(xbgr.mr_n88872224)
print v(xbgr.mr_n88608304)
print v(xbgr.mr_n88780240)
print v(xbgr.mr_n89083440)
print v(xbgr.mr_n86119184)
print v(xbgr.mr_n86475568)
print v(xbgr.mr_n86704640)
print v(xbgr.mr_n86740032)
print v(xbgr.mr_n87592064)
print v(xbgr.mr_n87702656)
print v(xbgr.mr_n87832016)
print v(xbgr.mr_n87918272)
print v(xbgr.mr_n88033776)
print v(xbgr.mr_n88161440)
print v(xbgr.mr_n88230336)
print v(xbgr.mr_n88303216)
print v(xbgr.mr_n86957776)
print v(xbgr.mr_n87064016)
print v(xbgr.mr_n87293232)
print v(xbgr.mr_n87457104)
print v(xbgr.mr_n86973984)
print v(xbgr.mr_n87057408)
print v(xbgr.mr_n87296256)
print v(xbgr.mr_n87438000)
print v(xbgr.mr_n86118720)
print v(xbgr.mr_n86475104)
print v(xbgr.mr_n86703440)
print v(xbgr.mr_n86739440)
print v(xbgr.mr_n88610848)
print v(xbgr.mr_n88855424)
print v(xbgr.mr_n89080704)
print v(xbgr.mr_n86930480)
print v(xbgr.mr_n86996512)
print v(xbgr.mr_n87092736)
print v(xbgr.mr_n87350848)
print v(xbgr.mr_n86118256)
print v(xbgr.mr_n86476816)
print v(xbgr.mr_n86703040)
print v(xbgr.mr_n86738848)
print v(xbgr.mr_n88612336)
print v(xbgr.mr_n88777808)
print v(xbgr.mr_n89088384)
print v(xbgr.mr_n88440784)
print v(xbgr.mr_n88659040)
print v(xbgr.mr_n88871760)
print v(xbgr.mr_n86966096)
print v(xbgr.mr_n87042944)
print v(xbgr.mr_n87269104)
print v(xbgr.mr_n87452976)
print v(xbgr.mr_n87591712)
print v(xbgr.mr_n87724576)
print v(xbgr.mr_n87811328)
print v(xbgr.mr_n87915040)
print v(xbgr.mr_n88030944)
print v(xbgr.mr_n88154192)
print v(xbgr.mr_n88250944)
print v(xbgr.mr_n88374896)
print v(xbgr.mr_n86117792)
print v(xbgr.mr_n86411584)
print v(xbgr.mr_n86701840)
print v(xbgr.mr_n86738256)
print v(xbgr.mr_n87592768)
print v(xbgr.mr_n87754400)
print v(xbgr.mr_n87830336)
print v(xbgr.mr_n87913568)
print v(xbgr.mr_n88035248)
print v(xbgr.mr_n88159440)
print v(xbgr.mr_n88249904)
print v(xbgr.mr_n88373664)
print v(xbgr.mr_n88609568)
print v(xbgr.mr_n88778464)
print v(xbgr.mr_n89087568)
print v(xbgr.mr_n86117328)
print v(xbgr.mr_n86474384)
print v(xbgr.mr_n86701040)
print v(xbgr.mr_n86737728)
print v(xbgr.mr_n87520976)
print v(xbgr.mr_n87627040)
print v(xbgr.mr_n87711024)
print v(xbgr.mr_n87841680)
print v(xbgr.mr_n87924496)
print v(xbgr.mr_n88047696)
print v(xbgr.mr_n88174000)
print v(xbgr.mr_n88306448)
print v(xbgr.mr_n88610512)
print v(xbgr.mr_n88854912)
print v(xbgr.mr_n89083264)
print v(xbgr.mr_n86116864)
print v(xbgr.mr_n86473856)
print v(xbgr.mr_n86700640)
print v(xbgr.mr_n86711440)
print v(xbgr.mr_n88602976)
print v(xbgr.mr_n88776032)
print v(xbgr.mr_n89086000)
print v(xbgr.mr_n87593568)
print v(xbgr.mr_n87691760)
print v(xbgr.mr_n87828272)
print v(xbgr.d4)
print v(xbgr.mr_n88033312)
print v(xbgr.mr_n88156800)
print v(xbgr.mr_n88168368)
print v(xbgr.mr_n88347504)
print v(xbgr.mr_n86972336)
print v(xbgr.mr_n87059216)
print v(xbgr.mr_n87294144)
print v(xbgr.mr_n87452704)
print v(xbgr.mr_n86972944)
print v(xbgr.mr_n87063440)
print v(xbgr.mr_n87294928)
print v(xbgr.mr_n87445152)
print v(xbgr.mr_n88440320)
print v(xbgr.mr_n88658576)
print v(xbgr.mr_n88871296)
print v(xbgr.mr_n86116400)
print v(xbgr.mr_n86476224)
print v(xbgr.mr_n86697808)
print v(xbgr.mr_n86736480)
print v(xbgr.mr_n88609744)
print v(xbgr.mr_n88776688)
print v(xbgr.mr_n89088560)
print v(xbgr.mr_n86920544)
print v(xbgr.mr_n86993088)
print v(xbgr.mr_n87086320)
print v(xbgr.mr_n87350048)
print v(xbgr.mr_n86115936)
print v(xbgr.mr_n86464336)
print v(xbgr.mr_n86699040)
print v(xbgr.mr_n86734800)
print v(xbgr.mr_n88608128)
print v(xbgr.mr_n88849376)
print v(xbgr.mr_n89085824)
print v(xbgr.mr_n86970880)
print v(xbgr.mr_n87061024)
print v(xbgr.mr_n87253120)
print v(xbgr.mr_n87447920)
print v(xbgr.mr_n86115472)
print v(xbgr.mr_n86466752)
print v(xbgr.mr_n86585392)
print v(xbgr.mr_n86930144)
print v(xbgr.mr_n87589632)
print v(xbgr.mr_n87751600)
print v(xbgr.mr_n87811216)
print v(xbgr.mr_n87906320)
print v(xbgr.mr_n88030592)
print v(xbgr.mr_n88152032)
print v(xbgr.mr_n88238032)
print v(xbgr.mr_n88368944)
print v(xbgr.mr_n87591888)
print v(xbgr.mr_n87751408)
print v(xbgr.mr_n87808944)
print v(xbgr.mr_n87911504)
print v(xbgr.mr_n88030480)
print v(xbgr.mr_n88154736)
print v(xbgr.mr_n88252112)
print v(xbgr.mr_n88369136)
print v(xbgr.mr_n88605968)
print v(xbgr.mr_n88774384)
print v(xbgr.mr_n89090128)
print v(xbgr.mr_n86115008)
print v(xbgr.mr_n86473264)
print v(xbgr.mr_n86585984)
print v(xbgr.mr_n86929744)
print v(xbgr.mr_n88439632)
print v(xbgr.mr_n88657952)
print v(xbgr.mr_n88870368)
print v(xbgr.mr_n87520512)
print v(xbgr.mr_n87626112)
print v(xbgr.mr_n87747472)
print v(xbgr.mr_n87841568)
print v(xbgr.mr_n87923952)
print v(xbgr.mr_n88047232)
print v(xbgr.mr_n88173536)
print v(xbgr.mr_n88306224)
print v(xbgr.mr_n88606640)
print v(xbgr.mr_n88774912)
print v(xbgr.mr_n89091120)
print v(xbgr.mr_n86114544)
print v(xbgr.mr_n86472672)
print v(xbgr.mr_n86584208)
print v(xbgr.mr_n86895040)
print v(xbgr.mr_n87590512)
print v(xbgr.mr_n87713168)
print v(xbgr.mr_n87811552)
print v(xbgr.mr_n87908864)
print v(xbgr.mr_n88028064)
print v(xbgr.mr_n88148512)
print v(xbgr.mr_n88228048)
print v(xbgr.mr_n88349856)
print v(xbgr.mr_n86971488)
print v(xbgr.mr_n87292208)
print v(xbgr.mr_n87437808)
print v(xbgr.mr_n86972768)
print v(xbgr.mr_n87275824)
print v(xbgr.mr_n87447536)
print v(xbgr.mr_n88605040)
print v(xbgr.mr_n88853616)
print v(xbgr.mr_n89085008)
print v(xbgr.mr_n86112432)
print v(xbgr.mr_n86471488)
print v(xbgr.mr_n86584800)
print v(xbgr.mr_n86928944)
print v(xbgr.mr_n87023376)
print v(xbgr.mr_n86146096)
print v(xbgr.mr_n88604048)
print v(xbgr.mr_n88743680)
print v(xbgr.mr_n89092688)
print v(xbgr.mr_n86929344)
print v(xbgr.mr_n86425376)
print v(xbgr.mr_n86911632)
print v(xbgr.mr_n87323600)
print v(xbgr.mr_n86310512)
print v(xbgr.n_23)
print v(xbgr.mr_n86583024)
print v(xbgr.mr_n86928144)
print v(xbgr.mr_n86134288)
print v(xbgr.mr_n88439328)
print v(xbgr.mr_n88586768)
print v(xbgr.mr_n88869984)
print v(xbgr.mr_n88601552)
print v(xbgr.mr_n88740176)
print v(xbgr.mr_n89090944)
print v(xbgr.n_12)
print v(xbgr.n_25)
print v(xbgr.mr_n86583616)
print v(xbgr.mr_n86925744)
print v(xbgr.mr_n86971312)
print v(xbgr.mr_n87231920)
print v(xbgr.mr_n87447424)
print v(xbgr.mr_n87587632)
print v(xbgr.mr_n87718336)
print v(xbgr.mr_n87810768)
print v(xbgr.mr_n87887968)
print v(xbgr.mr_n88018640)
print v(xbgr.mr_n88146704)
print v(xbgr.mr_n88238624)
print v(xbgr.mr_n88370080)
print v(xbgr.mr_n87583616)
print v(xbgr.mr_n87756288)
print v(xbgr.mr_n87811104)
print v(xbgr.mr_n87903632)
print v(xbgr.mr_n88030096)
print v(xbgr.mr_n88147888)
print v(xbgr.mr_n88250448)
print v(xbgr.mr_n88364064)
print v(xbgr.mr_n86111472)
print v(xbgr.mr_n86410976)
print v(xbgr.mr_n86581840)
print v(xbgr.mr_n86923344)
print v(xbgr.mr_n88602480)
print v(xbgr.mr_n88845472)
print v(xbgr.mr_n89093680)
print v(xbgr.mr_n87520048)
print v(xbgr.mr_n87625728)
print v(xbgr.mr_n87706176)
print v(xbgr.mr_n87838608)
print v(xbgr.mr_n87923760)
print v(xbgr.mr_n88047120)
print v(xbgr.mr_n88173424)
print v(xbgr.mr_n88279664)
print v(xbgr.n_17)
print v(xbgr.n_22)
print v(xbgr.mr_n86582432)
print v(xbgr.mr_n86920864)
print v(xbgr.mr_n88485664)
print v(xbgr.mr_n88771600)
print v(xbgr.mr_n89098624)
print v(xbgr.mr_n88439024)
print v(xbgr.mr_n88586304)
print v(xbgr.mr_n88869680)
print v(xbgr.mr_n87583440)
print v(xbgr.mr_n87723600)
print v(xbgr.mr_n87826912)
print v(xbgr.mr_n87904096)
print v(xbgr.mr_n88027312)
print v(xbgr.mr_n88148160)
print v(xbgr.mr_n88228224)
print v(xbgr.mr_n88297616)
print v(xbgr.mr_n86966848)
print v(xbgr.mr_n87291600)
print v(xbgr.mr_n87438336)
print v(xbgr.n_18)
print v(xbgr.mr_n86409536)
print v(xbgr.mr_n86580656)
print v(xbgr.mr_n86904016)
print v(xbgr.mr_n86963520)
print v(xbgr.mr_n87292384)
print v(xbgr.mr_n87442928)
print v(xbgr.mr_n88508768)
print v(xbgr.mr_n88772064)
print v(xbgr.mr_n89096240)
print v(xbgr.mr_n86153136)
print v(xbgr.mr_n86109584)
print v(xbgr.mr_n86307648)
print v(xbgr.mr_n86408816)
print v(xbgr.mr_n86581248)
print v(xbgr.mr_n86861952)
print v(xbgr.mr_n86926144)
print v(xbgr.mr_n86104208)
print v(xbgr.mr_n86387616)
print v(xbgr.mr_n87325824)
print v(xbgr.mr_n88590432)
print v(xbgr.mr_n88851664)
print v(xbgr.mr_n89093504)
print v(xbgr.mr_n86423792)
print v(xbgr.mr_n86270032)
print v(xbgr.mr_n86408096)
print v(xbgr.mr_n86580064)
print v(xbgr.mr_n86915984)
print v(xbgr.mr_n86961104)
print v(xbgr.mr_n87259264)
print v(xbgr.mr_n87431952)
print v(xbgr.mr_n88600192)
print v(xbgr.mr_n88745600)
print v(xbgr.mr_n89097808)
print v(xbgr.mr_n87584272)
print v(xbgr.mr_n87611776)
print v(xbgr.mr_n87820512)
print v(xbgr.mr_n87900928)
print v(xbgr.mr_n88007424)
print v(xbgr.mr_n88134048)
print v(xbgr.mr_n88240400)
print v(xbgr.mr_n88365840)
print v(xbgr.mr_n87584096)
print v(xbgr.mr_n87673600)
print v(xbgr.mr_n87813920)
print v(xbgr.mr_n87897008)
print v(xbgr.mr_n88014512)
print v(xbgr.mr_n88147312)
print v(xbgr.mr_n88239808)
print v(xbgr.mr_n88368400)
print v(xbgr.mr_n88424016)
print v(xbgr.mr_n88653184)
print v(xbgr.mr_n88867856)
print v(xbgr.mr_n86293616)
print v(xbgr.mr_n86407376)
print v(xbgr.mr_n86578160)
print v(xbgr.mr_n86905904)
print v(xbgr.mr_n88592576)
print v(xbgr.mr_n88745488)
print v(xbgr.mr_n89098800)
print v(xbgr.mr_n87519584)
print v(xbgr.mr_n87613488)
print v(xbgr.mr_n87742768)
print v(xbgr.mr_n87840288)
print v(xbgr.mr_n87911024)
print v(xbgr.mr_n88045392)
print v(xbgr.mr_n88171696)
print v(xbgr.mr_n88305616)
print v(xbgr.mr_n88597376)
print v(xbgr.mr_n88853728)
print v(xbgr.mr_n89096064)
print v(xbgr.mr_n86160768)
print v(xbgr.mr_n87580352)
print v(xbgr.mr_n87670144)
print v(xbgr.mr_n87814944)
print v(xbgr.mr_n87899456)
print v(xbgr.mr_n88026896)
print v(xbgr.mr_n88139472)
print v(xbgr.mr_n88173072)
print v(xbgr.mr_n88297792)
print v(xbgr.mr_n86965792)
print v(xbgr.mr_n87276976)
print v(xbgr.mr_n87437328)
print v(xbgr.mr_n86956112)
print v(xbgr.mr_n87276640)
print v(xbgr.mr_n87437664)
print v(xbgr.mr_n88590608)
print v(xbgr.mr_n88741872)
print v(xbgr.mr_n89103744)
print v(xbgr.mr_n86168624)
print v(xbgr.mr_n88427216)
print v(xbgr.mr_n88653008)
print v(xbgr.mr_n88868944)
print v(xbgr.mr_n86914144)
print v(xbgr.mr_n87034912)
print v(xbgr.mr_n87134432)
print v(xbgr.mr_n87305104)
print v(xbgr.mr_n86154544)
print v(xbgr.mr_n88426416)
print v(xbgr.mr_n88721984)
print v(xbgr.mr_n89102928)
print v(xbgr.mr_n86962768)
print v(xbgr.mr_n87256496)
print v(xbgr.mr_n87425856)
print v(dvbe)
print v(iptat)
print v(pbias)
print v(pcasc)
print v(r4)
print v(vbe)
print v(vdd)
print v(vref)
print v(vdd)-v(vdd)
echo METALLIC_POINT_VOLTAGES_END
echo METALLIC_ALL_NODE_VOLTAGES_BEGIN
print v(xbgr.b1b)
print v(xbgr.c2)
print v(xbgr.d1)
print v(xbgr.d2)
print v(xbgr.d3)
print v(xbgr.d4)
print v(xbgr.d5)
print v(xbgr.det)
print v(dvbe)
print v(iptat)
print v(xbgr.kick)
print v(xbgr.mr_n72989824)
print v(xbgr.mr_n73035440)
print v(xbgr.mr_n75472112)
print v(xbgr.mr_n75502880)
print v(xbgr.mr_n75504592)
print v(xbgr.mr_n76400032)
print v(xbgr.mr_n76400144)
print v(xbgr.mr_n76400464)
print v(xbgr.mr_n76400576)
print v(xbgr.mr_n76400992)
print v(xbgr.mr_n76401104)
print v(xbgr.mr_n76401424)
print v(xbgr.mr_n76401536)
print v(xbgr.mr_n76401968)
print v(xbgr.mr_n76402208)
print v(xbgr.mr_n76402320)
print v(xbgr.mr_n76402672)
print v(xbgr.mr_n76402992)
print v(xbgr.mr_n76403104)
print v(xbgr.mr_n76403536)
print v(xbgr.mr_n76403856)
print v(xbgr.mr_n76403968)
print v(xbgr.mr_n76404400)
print v(xbgr.mr_n76404720)
print v(xbgr.mr_n76404832)
print v(xbgr.mr_n76405264)
print v(xbgr.mr_n76405584)
print v(xbgr.mr_n76405696)
print v(xbgr.mr_n76406128)
print v(xbgr.mr_n76406448)
print v(xbgr.mr_n76406560)
print v(xbgr.mr_n76406992)
print v(xbgr.mr_n76407312)
print v(xbgr.mr_n76407424)
print v(xbgr.mr_n76407856)
print v(xbgr.mr_n76408176)
print v(xbgr.mr_n76408288)
print v(xbgr.mr_n76408720)
print v(xbgr.mr_n76409040)
print v(xbgr.mr_n76409152)
print v(xbgr.mr_n76409584)
print v(xbgr.mr_n76409904)
print v(xbgr.mr_n76410016)
print v(xbgr.mr_n76410448)
print v(xbgr.mr_n76410768)
print v(xbgr.mr_n76410880)
print v(xbgr.mr_n76411312)
print v(xbgr.mr_n76411632)
print v(xbgr.mr_n76411744)
print v(xbgr.mr_n76412176)
print v(xbgr.mr_n76412496)
print v(xbgr.mr_n76412608)
print v(xbgr.mr_n76413040)
print v(xbgr.mr_n76413360)
print v(xbgr.mr_n76413472)
print v(xbgr.mr_n76413904)
print v(xbgr.mr_n76414224)
print v(xbgr.mr_n76414336)
print v(xbgr.mr_n76414768)
print v(xbgr.mr_n76415088)
print v(xbgr.mr_n76415200)
print v(xbgr.mr_n76415632)
print v(xbgr.mr_n76415952)
print v(xbgr.mr_n76416064)
print v(xbgr.mr_n76416384)
print v(xbgr.mr_n76416496)
print v(xbgr.mr_n76416816)
print v(xbgr.mr_n76416928)
print v(xbgr.mr_n76417248)
print v(xbgr.mr_n76417360)
print v(xbgr.mr_n76417680)
print v(xbgr.mr_n76417792)
print v(xbgr.mr_n76418112)
print v(xbgr.mr_n76418224)
print v(xbgr.mr_n76418544)
print v(xbgr.mr_n76418656)
print v(xbgr.mr_n76418976)
print v(xbgr.mr_n76419088)
print v(xbgr.mr_n76419408)
print v(xbgr.mr_n76419520)
print v(xbgr.mr_n76419840)
print v(xbgr.mr_n76419952)
print v(xbgr.mr_n76420272)
print v(xbgr.mr_n76420384)
print v(xbgr.mr_n76420704)
print v(xbgr.mr_n76420816)
print v(xbgr.mr_n76421136)
print v(xbgr.mr_n76421248)
print v(xbgr.mr_n76421568)
print v(xbgr.mr_n76421680)
print v(xbgr.mr_n76422000)
print v(xbgr.mr_n76422112)
print v(xbgr.mr_n76422432)
print v(xbgr.mr_n76422544)
print v(xbgr.mr_n76422864)
print v(xbgr.mr_n76422976)
print v(xbgr.mr_n76423296)
print v(xbgr.mr_n76423408)
print v(xbgr.mr_n76423728)
print v(xbgr.mr_n76423840)
print v(xbgr.mr_n76424160)
print v(xbgr.mr_n76424272)
print v(xbgr.mr_n76424592)
print v(xbgr.mr_n76424704)
print v(xbgr.mr_n76425024)
print v(xbgr.mr_n76425136)
print v(xbgr.mr_n76425456)
print v(xbgr.mr_n76425568)
print v(xbgr.mr_n76425888)
print v(xbgr.mr_n76426000)
print v(xbgr.mr_n76426320)
print v(xbgr.mr_n76426432)
print v(xbgr.mr_n76426752)
print v(xbgr.mr_n76426864)
print v(xbgr.mr_n76427184)
print v(xbgr.mr_n76427296)
print v(xbgr.mr_n76427616)
print v(xbgr.mr_n76427728)
print v(xbgr.mr_n76428048)
print v(xbgr.mr_n76428160)
print v(xbgr.mr_n76428480)
print v(xbgr.mr_n76428592)
print v(xbgr.mr_n76428912)
print v(xbgr.mr_n76429024)
print v(xbgr.mr_n76429344)
print v(xbgr.mr_n76429456)
print v(xbgr.mr_n76429776)
print v(xbgr.mr_n76429888)
print v(xbgr.mr_n76430208)
print v(xbgr.mr_n76430320)
print v(xbgr.mr_n76430640)
print v(xbgr.mr_n76430752)
print v(xbgr.mr_n76431072)
print v(xbgr.mr_n76431184)
print v(xbgr.mr_n76431504)
print v(xbgr.mr_n76431616)
print v(xbgr.mr_n76431744)
print v(xbgr.mr_n76431856)
print v(xbgr.mr_n76432176)
print v(xbgr.mr_n76432288)
print v(xbgr.mr_n76432608)
print v(xbgr.mr_n76432720)
print v(xbgr.mr_n76433040)
print v(xbgr.mr_n76433152)
print v(xbgr.mr_n76433472)
print v(xbgr.mr_n76433584)
print v(xbgr.mr_n76433904)
print v(xbgr.mr_n76434016)
print v(xbgr.mr_n76434336)
print v(xbgr.mr_n76434448)
print v(xbgr.mr_n76434768)
print v(xbgr.mr_n76434880)
print v(xbgr.mr_n76435200)
print v(xbgr.mr_n76435312)
print v(xbgr.mr_n76435632)
print v(xbgr.mr_n76435744)
print v(xbgr.mr_n76436064)
print v(xbgr.mr_n76436176)
print v(xbgr.mr_n76436496)
print v(xbgr.mr_n76436608)
print v(xbgr.mr_n76436928)
print v(xbgr.mr_n76437040)
print v(xbgr.mr_n76437360)
print v(xbgr.mr_n76437472)
print v(xbgr.mr_n76437792)
print v(xbgr.mr_n76437904)
print v(xbgr.mr_n76438224)
print v(xbgr.mr_n76438336)
print v(xbgr.mr_n76438656)
print v(xbgr.mr_n76438768)
print v(xbgr.mr_n76439088)
print v(xbgr.mr_n76439200)
print v(xbgr.mr_n76439520)
print v(xbgr.mr_n76439632)
print v(xbgr.mr_n76439952)
print v(xbgr.mr_n76440064)
print v(xbgr.mr_n76440384)
print v(xbgr.mr_n76440496)
print v(xbgr.mr_n76440816)
print v(xbgr.mr_n76440928)
print v(xbgr.mr_n76441248)
print v(xbgr.mr_n76441360)
print v(xbgr.mr_n76441680)
print v(xbgr.mr_n76441792)
print v(xbgr.mr_n76442112)
print v(xbgr.mr_n76442224)
print v(xbgr.mr_n76442544)
print v(xbgr.mr_n76442656)
print v(xbgr.mr_n76442976)
print v(xbgr.mr_n76443088)
print v(xbgr.mr_n76443408)
print v(xbgr.mr_n76443520)
print v(xbgr.mr_n76443840)
print v(xbgr.mr_n76443952)
print v(xbgr.mr_n76444272)
print v(xbgr.mr_n76444384)
print v(xbgr.mr_n76444704)
print v(xbgr.mr_n76444816)
print v(xbgr.mr_n76445136)
print v(xbgr.mr_n76445248)
print v(xbgr.mr_n76445568)
print v(xbgr.mr_n76445680)
print v(xbgr.mr_n76446000)
print v(xbgr.mr_n76446112)
print v(xbgr.mr_n76446432)
print v(xbgr.mr_n76446544)
print v(xbgr.mr_n76446864)
print v(xbgr.mr_n76446976)
print v(xbgr.mr_n76447296)
print v(xbgr.mr_n76447408)
print v(xbgr.mr_n76447728)
print v(xbgr.mr_n76447840)
print v(xbgr.mr_n76448160)
print v(xbgr.mr_n76448272)
print v(xbgr.mr_n76448592)
print v(xbgr.mr_n76448704)
print v(xbgr.mr_n76449024)
print v(xbgr.mr_n76449136)
print v(xbgr.mr_n76449456)
print v(xbgr.mr_n76449568)
print v(xbgr.mr_n76449888)
print v(xbgr.mr_n76450000)
print v(xbgr.mr_n76450320)
print v(xbgr.mr_n76450432)
print v(xbgr.mr_n76450752)
print v(xbgr.mr_n76450864)
print v(xbgr.mr_n76451184)
print v(xbgr.mr_n76451296)
print v(xbgr.mr_n76451616)
print v(xbgr.mr_n76451728)
print v(xbgr.mr_n76452048)
print v(xbgr.mr_n76452160)
print v(xbgr.mr_n76452480)
print v(xbgr.mr_n76452592)
print v(xbgr.mr_n76452912)
print v(xbgr.mr_n76453024)
print v(xbgr.mr_n76453344)
print v(xbgr.mr_n76453456)
print v(xbgr.mr_n76453776)
print v(xbgr.mr_n76453888)
print v(xbgr.mr_n76454208)
print v(xbgr.mr_n76454320)
print v(xbgr.mr_n76454640)
print v(xbgr.mr_n76454752)
print v(xbgr.mr_n76455072)
print v(xbgr.mr_n76455184)
print v(xbgr.mr_n76455504)
print v(xbgr.mr_n76455616)
print v(xbgr.mr_n76455936)
print v(xbgr.mr_n76456048)
print v(xbgr.mr_n76456368)
print v(xbgr.mr_n76456480)
print v(xbgr.mr_n76456800)
print v(xbgr.mr_n76456912)
print v(xbgr.mr_n76457232)
print v(xbgr.mr_n76457344)
print v(xbgr.mr_n76457664)
print v(xbgr.mr_n76457776)
print v(xbgr.mr_n76458096)
print v(xbgr.mr_n76458208)
print v(xbgr.mr_n76458528)
print v(xbgr.mr_n76458640)
print v(xbgr.mr_n76458960)
print v(xbgr.mr_n76459072)
print v(xbgr.mr_n76459392)
print v(xbgr.mr_n76459504)
print v(xbgr.mr_n76459824)
print v(xbgr.mr_n76459936)
print v(xbgr.mr_n76460256)
print v(xbgr.mr_n76460368)
print v(xbgr.mr_n76460688)
print v(xbgr.mr_n76460800)
print v(xbgr.mr_n76461120)
print v(xbgr.mr_n76461232)
print v(xbgr.mr_n76461552)
print v(xbgr.mr_n76461664)
print v(xbgr.mr_n76461984)
print v(xbgr.mr_n76462096)
print v(xbgr.mr_n76462416)
print v(xbgr.mr_n76462528)
print v(xbgr.mr_n76462848)
print v(xbgr.mr_n76462960)
print v(xbgr.mr_n76463280)
print v(xbgr.mr_n76463392)
print v(xbgr.mr_n76463712)
print v(xbgr.mr_n76463824)
print v(xbgr.mr_n76464144)
print v(xbgr.mr_n76464256)
print v(xbgr.mr_n76464576)
print v(xbgr.mr_n76464688)
print v(xbgr.mr_n76465008)
print v(xbgr.mr_n76465120)
print v(xbgr.mr_n76465440)
print v(xbgr.mr_n76465552)
print v(xbgr.mr_n76465872)
print v(xbgr.mr_n76465984)
print v(xbgr.mr_n76466304)
print v(xbgr.mr_n76466416)
print v(xbgr.mr_n76466736)
print v(xbgr.mr_n76466848)
print v(xbgr.mr_n76467168)
print v(xbgr.mr_n76467280)
print v(xbgr.mr_n76467744)
print v(xbgr.mr_n76467856)
print v(xbgr.mr_n76468176)
print v(xbgr.mr_n76468288)
print v(xbgr.mr_n76468608)
print v(xbgr.mr_n76468720)
print v(xbgr.mr_n76469040)
print v(xbgr.mr_n76469152)
print v(xbgr.mr_n76469472)
print v(xbgr.mr_n76469584)
print v(xbgr.mr_n76469904)
print v(xbgr.mr_n76470016)
print v(xbgr.mr_n76470336)
print v(xbgr.mr_n76470448)
print v(xbgr.mr_n76470768)
print v(xbgr.mr_n76470880)
print v(xbgr.mr_n76471200)
print v(xbgr.mr_n76471312)
print v(xbgr.mr_n76471632)
print v(xbgr.mr_n76471744)
print v(xbgr.mr_n76472064)
print v(xbgr.mr_n76472176)
print v(xbgr.mr_n76472496)
print v(xbgr.mr_n76472608)
print v(xbgr.mr_n76472928)
print v(xbgr.mr_n76473040)
print v(xbgr.mr_n76473360)
print v(xbgr.mr_n76473472)
print v(xbgr.mr_n76473792)
print v(xbgr.mr_n76473904)
print v(xbgr.mr_n76474224)
print v(xbgr.mr_n76474336)
print v(xbgr.mr_n76474656)
print v(xbgr.mr_n76474768)
print v(xbgr.mr_n76475088)
print v(xbgr.mr_n76475200)
print v(xbgr.mr_n76475520)
print v(xbgr.mr_n76475632)
print v(xbgr.mr_n76475952)
print v(xbgr.mr_n76476064)
print v(xbgr.mr_n76476384)
print v(xbgr.mr_n76476496)
print v(xbgr.mr_n76476816)
print v(xbgr.mr_n76476928)
print v(xbgr.mr_n76477248)
print v(xbgr.mr_n76477360)
print v(xbgr.mr_n76477680)
print v(xbgr.mr_n76477792)
print v(xbgr.mr_n76478112)
print v(xbgr.mr_n76478224)
print v(xbgr.mr_n76478544)
print v(xbgr.mr_n76478656)
print v(xbgr.mr_n76478976)
print v(xbgr.mr_n76479088)
print v(xbgr.mr_n76479408)
print v(xbgr.mr_n76479520)
print v(xbgr.mr_n76479840)
print v(xbgr.mr_n76479952)
print v(xbgr.mr_n76480272)
print v(xbgr.mr_n76480384)
print v(xbgr.mr_n76480704)
print v(xbgr.mr_n76480816)
print v(xbgr.mr_n76481136)
print v(xbgr.mr_n76481248)
print v(xbgr.mr_n76481568)
print v(xbgr.mr_n76481680)
print v(xbgr.mr_n76482000)
print v(xbgr.mr_n76482112)
print v(xbgr.mr_n76482432)
print v(xbgr.mr_n76482544)
print v(xbgr.mr_n76482864)
print v(xbgr.mr_n76482976)
print v(xbgr.mr_n76483296)
print v(xbgr.mr_n76483408)
print v(xbgr.mr_n76483728)
print v(xbgr.mr_n76483840)
print v(xbgr.mr_n76484160)
print v(xbgr.mr_n76484272)
print v(xbgr.mr_n76484592)
print v(xbgr.mr_n76484704)
print v(xbgr.mr_n76485024)
print v(xbgr.mr_n76485136)
print v(xbgr.mr_n76485456)
print v(xbgr.mr_n76485568)
print v(xbgr.mr_n76485888)
print v(xbgr.mr_n76486000)
print v(xbgr.mr_n76486320)
print v(xbgr.mr_n76486432)
print v(xbgr.mr_n76486752)
print v(xbgr.mr_n76486864)
print v(xbgr.mr_n76487184)
print v(xbgr.mr_n76487296)
print v(xbgr.mr_n76487616)
print v(xbgr.mr_n76487728)
print v(xbgr.mr_n76488048)
print v(xbgr.mr_n76488160)
print v(xbgr.mr_n76488480)
print v(xbgr.mr_n76488592)
print v(xbgr.mr_n76488912)
print v(xbgr.mr_n76489024)
print v(xbgr.mr_n76489344)
print v(xbgr.mr_n76489456)
print v(xbgr.mr_n76489776)
print v(xbgr.mr_n76489888)
print v(xbgr.mr_n76490208)
print v(xbgr.mr_n76490320)
print v(xbgr.mr_n76490640)
print v(xbgr.mr_n76490752)
print v(xbgr.mr_n76491072)
print v(xbgr.mr_n76491184)
print v(xbgr.mr_n76491504)
print v(xbgr.mr_n76491616)
print v(xbgr.mr_n76491936)
print v(xbgr.mr_n76492048)
print v(xbgr.mr_n76492368)
print v(xbgr.mr_n76492480)
print v(xbgr.mr_n76492800)
print v(xbgr.mr_n76492912)
print v(xbgr.mr_n76493232)
print v(xbgr.mr_n76493344)
print v(xbgr.mr_n76493664)
print v(xbgr.mr_n76493776)
print v(xbgr.mr_n76494096)
print v(xbgr.mr_n76494208)
print v(xbgr.mr_n76494528)
print v(xbgr.mr_n76494640)
print v(xbgr.mr_n76494960)
print v(xbgr.mr_n76495072)
print v(xbgr.mr_n76495392)
print v(xbgr.mr_n76495504)
print v(xbgr.mr_n76495824)
print v(xbgr.mr_n76495936)
print v(xbgr.mr_n76496256)
print v(xbgr.mr_n76496368)
print v(xbgr.mr_n76496688)
print v(xbgr.mr_n76496800)
print v(xbgr.mr_n76497120)
print v(xbgr.mr_n76497232)
print v(xbgr.mr_n76497552)
print v(xbgr.mr_n76497664)
print v(xbgr.mr_n76497984)
print v(xbgr.mr_n76498096)
print v(xbgr.mr_n76498416)
print v(xbgr.mr_n76498528)
print v(xbgr.mr_n76498848)
print v(xbgr.mr_n76498960)
print v(xbgr.mr_n76499280)
print v(xbgr.mr_n76499392)
print v(xbgr.mr_n76499712)
print v(xbgr.mr_n76499824)
print v(xbgr.mr_n76500144)
print v(xbgr.mr_n76500256)
print v(xbgr.mr_n76500576)
print v(xbgr.mr_n76500688)
print v(xbgr.mr_n76501008)
print v(xbgr.mr_n76501120)
print v(xbgr.mr_n76501440)
print v(xbgr.mr_n76501552)
print v(xbgr.mr_n76501872)
print v(xbgr.mr_n76501984)
print v(xbgr.mr_n76502304)
print v(xbgr.mr_n76502416)
print v(xbgr.mr_n76502736)
print v(xbgr.mr_n76502848)
print v(xbgr.mr_n76503168)
print v(xbgr.mr_n76503280)
print v(xbgr.mr_n76503600)
print v(xbgr.mr_n76503712)
print v(xbgr.mr_n76504032)
print v(xbgr.mr_n76504144)
print v(xbgr.mr_n76504464)
print v(xbgr.mr_n76504576)
print v(xbgr.mr_n76504896)
print v(xbgr.mr_n76505008)
print v(xbgr.mr_n76505328)
print v(xbgr.mr_n76505440)
print v(xbgr.mr_n76505760)
print v(xbgr.mr_n76505872)
print v(xbgr.mr_n76506192)
print v(xbgr.mr_n76506304)
print v(xbgr.mr_n76506624)
print v(xbgr.mr_n76506736)
print v(xbgr.mr_n76507056)
print v(xbgr.mr_n76507168)
print v(xbgr.mr_n76507488)
print v(xbgr.mr_n76507600)
print v(xbgr.mr_n76507920)
print v(xbgr.mr_n76508032)
print v(xbgr.mr_n76508352)
print v(xbgr.mr_n76508464)
print v(xbgr.mr_n76508784)
print v(xbgr.mr_n76508896)
print v(xbgr.mr_n76509216)
print v(xbgr.mr_n76509328)
print v(xbgr.mr_n76509648)
print v(xbgr.mr_n76509760)
print v(xbgr.mr_n76510080)
print v(xbgr.mr_n76510192)
print v(xbgr.mr_n76510512)
print v(xbgr.mr_n76510624)
print v(xbgr.mr_n76510944)
print v(xbgr.mr_n76511056)
print v(xbgr.mr_n76511376)
print v(xbgr.mr_n76511488)
print v(xbgr.mr_n76511808)
print v(xbgr.mr_n76511920)
print v(xbgr.mr_n76512240)
print v(xbgr.mr_n76512352)
print v(xbgr.mr_n76512672)
print v(xbgr.mr_n76512784)
print v(xbgr.mr_n76513104)
print v(xbgr.mr_n76513216)
print v(xbgr.mr_n76513536)
print v(xbgr.mr_n76513648)
print v(xbgr.mr_n76513968)
print v(xbgr.mr_n76514080)
print v(xbgr.mr_n76514400)
print v(xbgr.mr_n76514512)
print v(xbgr.mr_n76514832)
print v(xbgr.mr_n76514944)
print v(xbgr.mr_n76515264)
print v(xbgr.mr_n76515376)
print v(xbgr.mr_n76515696)
print v(xbgr.mr_n76515808)
print v(xbgr.mr_n76516128)
print v(xbgr.mr_n76516240)
print v(xbgr.mr_n76516560)
print v(xbgr.mr_n76516672)
print v(xbgr.mr_n76516992)
print v(xbgr.mr_n76517104)
print v(xbgr.mr_n76517424)
print v(xbgr.mr_n76517536)
print v(xbgr.mr_n76517856)
print v(xbgr.mr_n76517968)
print v(xbgr.mr_n76518288)
print v(xbgr.mr_n76518400)
print v(xbgr.mr_n76518720)
print v(xbgr.mr_n76518832)
print v(xbgr.mr_n76519152)
print v(xbgr.mr_n76519264)
print v(xbgr.mr_n76519584)
print v(xbgr.mr_n76519696)
print v(xbgr.mr_n76520016)
print v(xbgr.mr_n76520128)
print v(xbgr.mr_n76520448)
print v(xbgr.mr_n76520560)
print v(xbgr.mr_n76520880)
print v(xbgr.mr_n76520992)
print v(xbgr.mr_n76521312)
print v(xbgr.mr_n76521424)
print v(xbgr.mr_n76521744)
print v(xbgr.mr_n76521856)
print v(xbgr.mr_n76522176)
print v(xbgr.mr_n76522288)
print v(xbgr.mr_n76522608)
print v(xbgr.mr_n76522720)
print v(xbgr.mr_n76523040)
print v(xbgr.mr_n76523152)
print v(xbgr.mr_n76523472)
print v(xbgr.mr_n76523584)
print v(xbgr.mr_n76523904)
print v(xbgr.mr_n76524016)
print v(xbgr.mr_n76524336)
print v(xbgr.mr_n76524448)
print v(xbgr.mr_n76524768)
print v(xbgr.mr_n76524880)
print v(xbgr.mr_n76525200)
print v(xbgr.mr_n76525312)
print v(xbgr.mr_n76525632)
print v(xbgr.mr_n76525744)
print v(xbgr.mr_n76526064)
print v(xbgr.mr_n76526176)
print v(xbgr.mr_n76526496)
print v(xbgr.mr_n76526608)
print v(xbgr.mr_n76526928)
print v(xbgr.mr_n76527040)
print v(xbgr.mr_n76527360)
print v(xbgr.mr_n76527472)
print v(xbgr.mr_n76527792)
print v(xbgr.mr_n76527904)
print v(xbgr.mr_n76528224)
print v(xbgr.mr_n76528336)
print v(xbgr.mr_n76528656)
print v(xbgr.mr_n76528768)
print v(xbgr.mr_n76529088)
print v(xbgr.mr_n76529200)
print v(xbgr.mr_n76529520)
print v(xbgr.mr_n76529632)
print v(xbgr.mr_n76529952)
print v(xbgr.mr_n76530064)
print v(xbgr.mr_n76530384)
print v(xbgr.mr_n76530496)
print v(xbgr.mr_n76530816)
print v(xbgr.mr_n76530928)
print v(xbgr.mr_n76531248)
print v(xbgr.mr_n76531360)
print v(xbgr.mr_n76531680)
print v(xbgr.mr_n76531792)
print v(xbgr.mr_n76532112)
print v(xbgr.mr_n76532224)
print v(xbgr.mr_n76532544)
print v(xbgr.mr_n76532656)
print v(xbgr.mr_n76532976)
print v(xbgr.mr_n76533088)
print v(xbgr.mr_n76533408)
print v(xbgr.mr_n76533520)
print v(xbgr.mr_n76533840)
print v(xbgr.mr_n76533952)
print v(xbgr.mr_n76534272)
print v(xbgr.mr_n76534384)
print v(xbgr.mr_n76534704)
print v(xbgr.mr_n76534816)
print v(xbgr.mr_n76535136)
print v(xbgr.mr_n76535248)
print v(xbgr.mr_n76535568)
print v(xbgr.mr_n76535680)
print v(xbgr.mr_n76536000)
print v(xbgr.mr_n76536112)
print v(xbgr.mr_n76536432)
print v(xbgr.mr_n76536544)
print v(xbgr.mr_n76536864)
print v(xbgr.mr_n76536976)
print v(xbgr.mr_n76537296)
print v(xbgr.mr_n76537408)
print v(xbgr.mr_n76537728)
print v(xbgr.mr_n76537840)
print v(xbgr.mr_n76538160)
print v(xbgr.mr_n76538272)
print v(xbgr.mr_n76538592)
print v(xbgr.mr_n76538704)
print v(xbgr.mr_n76539024)
print v(xbgr.mr_n76539136)
print v(xbgr.mr_n76539456)
print v(xbgr.mr_n76539568)
print v(xbgr.mr_n76539888)
print v(xbgr.mr_n76540000)
print v(xbgr.mr_n76540320)
print v(xbgr.mr_n76540432)
print v(xbgr.mr_n76540752)
print v(xbgr.mr_n76540864)
print v(xbgr.mr_n76541184)
print v(xbgr.mr_n76541296)
print v(xbgr.mr_n76541616)
print v(xbgr.mr_n76541728)
print v(xbgr.mr_n76542048)
print v(xbgr.mr_n76542160)
print v(xbgr.mr_n76542480)
print v(xbgr.mr_n76542592)
print v(xbgr.mr_n76542912)
print v(xbgr.mr_n76543024)
print v(xbgr.mr_n76543344)
print v(xbgr.mr_n76543456)
print v(xbgr.mr_n76543776)
print v(xbgr.mr_n76543888)
print v(xbgr.mr_n76544208)
print v(xbgr.mr_n76544320)
print v(xbgr.mr_n76544640)
print v(xbgr.mr_n76544752)
print v(xbgr.mr_n76545072)
print v(xbgr.mr_n76545184)
print v(xbgr.mr_n76545504)
print v(xbgr.mr_n76545616)
print v(xbgr.mr_n76545936)
print v(xbgr.mr_n76546048)
print v(xbgr.mr_n76546368)
print v(xbgr.mr_n76546480)
print v(xbgr.mr_n76546800)
print v(xbgr.mr_n76546912)
print v(xbgr.mr_n76547232)
print v(xbgr.mr_n76547344)
print v(xbgr.mr_n76547664)
print v(xbgr.mr_n76547776)
print v(xbgr.mr_n76548096)
print v(xbgr.mr_n76548208)
print v(xbgr.mr_n76548528)
print v(xbgr.mr_n76548640)
print v(xbgr.mr_n76548960)
print v(xbgr.mr_n76549072)
print v(xbgr.mr_n76549392)
print v(xbgr.mr_n76549504)
print v(xbgr.mr_n76549824)
print v(xbgr.mr_n76549936)
print v(xbgr.mr_n76550256)
print v(xbgr.mr_n76550368)
print v(xbgr.mr_n76550688)
print v(xbgr.mr_n76550800)
print v(xbgr.mr_n76551120)
print v(xbgr.mr_n76551232)
print v(xbgr.mr_n76551552)
print v(xbgr.mr_n76551664)
print v(xbgr.mr_n76551984)
print v(xbgr.mr_n76552096)
print v(xbgr.mr_n76552416)
print v(xbgr.mr_n76552528)
print v(xbgr.mr_n76552848)
print v(xbgr.mr_n76552960)
print v(xbgr.mr_n76553280)
print v(xbgr.mr_n76553392)
print v(xbgr.mr_n76553712)
print v(xbgr.mr_n76553824)
print v(xbgr.mr_n76554144)
print v(xbgr.mr_n76554256)
print v(xbgr.mr_n76554576)
print v(xbgr.mr_n76554688)
print v(xbgr.mr_n76555008)
print v(xbgr.mr_n76555120)
print v(xbgr.mr_n76555440)
print v(xbgr.mr_n76555552)
print v(xbgr.mr_n76555872)
print v(xbgr.mr_n76555984)
print v(xbgr.mr_n76556304)
print v(xbgr.mr_n76556416)
print v(xbgr.mr_n76556736)
print v(xbgr.mr_n76556848)
print v(xbgr.mr_n76557168)
print v(xbgr.mr_n76557280)
print v(xbgr.mr_n76557600)
print v(xbgr.mr_n76557712)
print v(xbgr.mr_n76558032)
print v(xbgr.mr_n76558144)
print v(xbgr.mr_n76558464)
print v(xbgr.mr_n76558576)
print v(xbgr.mr_n76558896)
print v(xbgr.mr_n76559008)
print v(xbgr.mr_n76559328)
print v(xbgr.mr_n76559440)
print v(xbgr.mr_n76559760)
print v(xbgr.mr_n76559872)
print v(xbgr.mr_n76560192)
print v(xbgr.mr_n76560304)
print v(xbgr.mr_n76560624)
print v(xbgr.mr_n76560736)
print v(xbgr.mr_n76561056)
print v(xbgr.mr_n76561168)
print v(xbgr.mr_n76561488)
print v(xbgr.mr_n76561600)
print v(xbgr.mr_n76561920)
print v(xbgr.mr_n76562032)
print v(xbgr.mr_n76562352)
print v(xbgr.mr_n76562464)
print v(xbgr.mr_n76562784)
print v(xbgr.mr_n76562896)
print v(xbgr.mr_n76563216)
print v(xbgr.mr_n76563328)
print v(xbgr.mr_n76563648)
print v(xbgr.mr_n76563760)
print v(xbgr.mr_n76564080)
print v(xbgr.mr_n76564192)
print v(xbgr.mr_n77570032)
print v(xbgr.mr_n77570144)
print v(xbgr.mr_n77570400)
print v(xbgr.mr_n77570512)
print v(xbgr.mr_n77570768)
print v(xbgr.mr_n77570880)
print v(xbgr.mr_n77571136)
print v(xbgr.mr_n77571248)
print v(xbgr.mr_n77571504)
print v(xbgr.mr_n77571616)
print v(xbgr.mr_n77571872)
print v(xbgr.mr_n77571984)
print v(xbgr.mr_n77572240)
print v(xbgr.mr_n77572352)
print v(xbgr.mr_n77572608)
print v(xbgr.mr_n77572720)
print v(xbgr.mr_n77572976)
print v(xbgr.mr_n77573088)
print v(xbgr.mr_n77573344)
print v(xbgr.mr_n77573456)
print v(xbgr.mr_n77573712)
print v(xbgr.mr_n77573824)
print v(xbgr.mr_n77574080)
print v(xbgr.mr_n77574192)
print v(xbgr.mr_n77574448)
print v(xbgr.mr_n77574560)
print v(xbgr.mr_n77574816)
print v(xbgr.mr_n77574928)
print v(xbgr.mr_n77575216)
print v(xbgr.mr_n77575328)
print v(xbgr.mr_n77575648)
print v(xbgr.mr_n77575760)
print v(xbgr.mr_n77576080)
print v(xbgr.mr_n77576192)
print v(xbgr.mr_n77576512)
print v(xbgr.mr_n77576624)
print v(xbgr.mr_n77576944)
print v(xbgr.mr_n77577056)
print v(xbgr.mr_n77577376)
print v(xbgr.mr_n77577488)
print v(xbgr.mr_n77577808)
print v(xbgr.mr_n77577920)
print v(xbgr.mr_n77578240)
print v(xbgr.mr_n77578352)
print v(xbgr.mr_n77578672)
print v(xbgr.mr_n77578784)
print v(xbgr.mr_n77579104)
print v(xbgr.mr_n77579216)
print v(xbgr.mr_n77579536)
print v(xbgr.mr_n77579648)
print v(xbgr.mr_n77579968)
print v(xbgr.mr_n77580080)
print v(xbgr.mr_n77580400)
print v(xbgr.mr_n77580512)
print v(xbgr.mr_n77580832)
print v(xbgr.mr_n77580944)
print v(xbgr.mr_n77581264)
print v(xbgr.mr_n77581376)
print v(xbgr.mr_n77581696)
print v(xbgr.mr_n77581808)
print v(xbgr.mr_n77582128)
print v(xbgr.mr_n77582240)
print v(xbgr.mr_n77582560)
print v(xbgr.mr_n77582672)
print v(xbgr.mr_n77582992)
print v(xbgr.mr_n77583104)
print v(xbgr.mr_n77583424)
print v(xbgr.mr_n77583536)
print v(xbgr.mr_n77583856)
print v(xbgr.mr_n77583968)
print v(xbgr.mr_n77584288)
print v(xbgr.mr_n77584400)
print v(xbgr.mr_n77584720)
print v(xbgr.mr_n77584832)
print v(xbgr.mr_n77585152)
print v(xbgr.mr_n77585264)
print v(xbgr.mr_n77585584)
print v(xbgr.mr_n77585696)
print v(xbgr.mr_n77586016)
print v(xbgr.mr_n77586128)
print v(xbgr.mr_n77586448)
print v(xbgr.mr_n77586560)
print v(xbgr.mr_n77586880)
print v(xbgr.mr_n77586992)
print v(xbgr.mr_n77587312)
print v(xbgr.mr_n77587424)
print v(xbgr.mr_n77587744)
print v(xbgr.mr_n77587856)
print v(xbgr.mr_n77588176)
print v(xbgr.mr_n77588288)
print v(xbgr.mr_n77588608)
print v(xbgr.mr_n77588720)
print v(xbgr.mr_n77589040)
print v(xbgr.mr_n77589152)
print v(xbgr.mr_n77589472)
print v(xbgr.mr_n77589584)
print v(xbgr.mr_n77589904)
print v(xbgr.mr_n77590016)
print v(xbgr.mr_n77590336)
print v(xbgr.mr_n77590448)
print v(xbgr.mr_n77590768)
print v(xbgr.mr_n77590880)
print v(xbgr.mr_n77591200)
print v(xbgr.mr_n77591312)
print v(xbgr.mr_n77591632)
print v(xbgr.mr_n77591744)
print v(xbgr.mr_n77592064)
print v(xbgr.mr_n77592176)
print v(xbgr.mr_n77592496)
print v(xbgr.mr_n77592608)
print v(xbgr.mr_n77592928)
print v(xbgr.mr_n77593040)
print v(xbgr.mr_n77593360)
print v(xbgr.mr_n77593472)
print v(xbgr.mr_n77593792)
print v(xbgr.mr_n77593904)
print v(xbgr.mr_n77594224)
print v(xbgr.mr_n77594336)
print v(xbgr.mr_n77594656)
print v(xbgr.mr_n77594768)
print v(xbgr.mr_n77595088)
print v(xbgr.mr_n77595200)
print v(xbgr.mr_n77595520)
print v(xbgr.mr_n77595632)
print v(xbgr.mr_n77595952)
print v(xbgr.mr_n77596064)
print v(xbgr.mr_n77596384)
print v(xbgr.mr_n77596496)
print v(xbgr.mr_n77596816)
print v(xbgr.mr_n77596928)
print v(xbgr.mr_n77597248)
print v(xbgr.mr_n77597360)
print v(xbgr.mr_n77597680)
print v(xbgr.mr_n77597792)
print v(xbgr.mr_n77598112)
print v(xbgr.mr_n77598224)
print v(xbgr.mr_n77598544)
print v(xbgr.mr_n77598656)
print v(xbgr.mr_n77598976)
print v(xbgr.mr_n77599088)
print v(xbgr.mr_n77599408)
print v(xbgr.mr_n77599520)
print v(xbgr.mr_n77599840)
print v(xbgr.mr_n77599952)
print v(xbgr.mr_n77600272)
print v(xbgr.mr_n77600384)
print v(xbgr.mr_n77600704)
print v(xbgr.mr_n77600816)
print v(xbgr.mr_n77601136)
print v(xbgr.mr_n77601248)
print v(xbgr.mr_n77601568)
print v(xbgr.mr_n77601680)
print v(xbgr.mr_n77602000)
print v(xbgr.mr_n77602112)
print v(xbgr.mr_n77602432)
print v(xbgr.mr_n77602544)
print v(xbgr.mr_n77602864)
print v(xbgr.mr_n77602976)
print v(xbgr.mr_n77603296)
print v(xbgr.mr_n77603408)
print v(xbgr.mr_n77603728)
print v(xbgr.mr_n77603840)
print v(xbgr.mr_n77604160)
print v(xbgr.mr_n77604272)
print v(xbgr.mr_n77604592)
print v(xbgr.mr_n77604704)
print v(xbgr.mr_n77605024)
print v(xbgr.mr_n77605136)
print v(xbgr.mr_n77605456)
print v(xbgr.mr_n77605568)
print v(xbgr.mr_n77605888)
print v(xbgr.mr_n77606000)
print v(xbgr.mr_n77606320)
print v(xbgr.mr_n77606432)
print v(xbgr.mr_n77606752)
print v(xbgr.mr_n77606864)
print v(xbgr.mr_n77607184)
print v(xbgr.mr_n77607296)
print v(xbgr.mr_n77607616)
print v(xbgr.mr_n77607728)
print v(xbgr.mr_n77608048)
print v(xbgr.mr_n77608160)
print v(xbgr.mr_n77608480)
print v(xbgr.mr_n77608592)
print v(xbgr.mr_n77608912)
print v(xbgr.mr_n77609024)
print v(xbgr.mr_n77609344)
print v(xbgr.mr_n77609456)
print v(xbgr.mr_n77609776)
print v(xbgr.mr_n77609888)
print v(xbgr.mr_n77610208)
print v(xbgr.mr_n77610320)
print v(xbgr.mr_n77610640)
print v(xbgr.mr_n77610752)
print v(xbgr.mr_n77611072)
print v(xbgr.mr_n77611184)
print v(xbgr.mr_n77611504)
print v(xbgr.mr_n77611616)
print v(xbgr.mr_n77611936)
print v(xbgr.mr_n77612048)
print v(xbgr.mr_n77612368)
print v(xbgr.mr_n77612480)
print v(xbgr.mr_n77612800)
print v(xbgr.mr_n77612912)
print v(xbgr.mr_n77613232)
print v(xbgr.mr_n77613344)
print v(xbgr.mr_n77613664)
print v(xbgr.mr_n77613776)
print v(xbgr.mr_n77614096)
print v(xbgr.mr_n77614208)
print v(xbgr.mr_n77614528)
print v(xbgr.mr_n77614640)
print v(xbgr.mr_n77614960)
print v(xbgr.mr_n77615072)
print v(xbgr.mr_n77615392)
print v(xbgr.mr_n77615504)
print v(xbgr.mr_n77615824)
print v(xbgr.mr_n77615936)
print v(xbgr.mr_n77616256)
print v(xbgr.mr_n77616368)
print v(xbgr.mr_n77616688)
print v(xbgr.mr_n77616800)
print v(xbgr.mr_n77617120)
print v(xbgr.mr_n77617232)
print v(xbgr.mr_n77617552)
print v(xbgr.mr_n77617664)
print v(xbgr.mr_n77617984)
print v(xbgr.mr_n77618096)
print v(xbgr.mr_n77618416)
print v(xbgr.mr_n77618528)
print v(xbgr.mr_n77618848)
print v(xbgr.mr_n77618960)
print v(xbgr.mr_n77619280)
print v(xbgr.mr_n77619392)
print v(xbgr.mr_n77619712)
print v(xbgr.mr_n77619824)
print v(xbgr.mr_n77620144)
print v(xbgr.mr_n77620256)
print v(xbgr.mr_n77620576)
print v(xbgr.mr_n77620688)
print v(xbgr.mr_n77621008)
print v(xbgr.mr_n77621120)
print v(xbgr.mr_n77621440)
print v(xbgr.mr_n77621552)
print v(xbgr.mr_n77621872)
print v(xbgr.mr_n77621984)
print v(xbgr.mr_n77622304)
print v(xbgr.mr_n77622416)
print v(xbgr.mr_n77622736)
print v(xbgr.mr_n77622848)
print v(xbgr.mr_n77623168)
print v(xbgr.mr_n77623280)
print v(xbgr.mr_n77623600)
print v(xbgr.mr_n77623712)
print v(xbgr.mr_n77624032)
print v(xbgr.mr_n77624144)
print v(xbgr.mr_n77624464)
print v(xbgr.mr_n77624576)
print v(xbgr.mr_n77624896)
print v(xbgr.mr_n77625008)
print v(xbgr.mr_n77625328)
print v(xbgr.mr_n77625440)
print v(xbgr.mr_n77625760)
print v(xbgr.mr_n77625872)
print v(xbgr.mr_n77626192)
print v(xbgr.mr_n77626304)
print v(xbgr.mr_n77626624)
print v(xbgr.mr_n77626736)
print v(xbgr.mr_n77627056)
print v(xbgr.mr_n77627168)
print v(xbgr.mr_n77627488)
print v(xbgr.mr_n77627600)
print v(xbgr.mr_n77627920)
print v(xbgr.mr_n77628032)
print v(xbgr.mr_n77628352)
print v(xbgr.mr_n77628464)
print v(xbgr.mr_n77628784)
print v(xbgr.mr_n77628896)
print v(xbgr.mr_n77629216)
print v(xbgr.mr_n77629328)
print v(xbgr.mr_n77629648)
print v(xbgr.mr_n77629760)
print v(xbgr.mr_n77630080)
print v(xbgr.mr_n77630192)
print v(xbgr.mr_n77630512)
print v(xbgr.mr_n77630624)
print v(xbgr.mr_n77630944)
print v(xbgr.mr_n77631056)
print v(xbgr.mr_n77631376)
print v(xbgr.mr_n77631488)
print v(xbgr.mr_n77631808)
print v(xbgr.mr_n77631920)
print v(xbgr.mr_n77632240)
print v(xbgr.mr_n77632352)
print v(xbgr.mr_n77632672)
print v(xbgr.mr_n77632784)
print v(xbgr.mr_n77633104)
print v(xbgr.mr_n77633216)
print v(xbgr.mr_n77633536)
print v(xbgr.mr_n77633648)
print v(xbgr.mr_n77633968)
print v(xbgr.mr_n77634080)
print v(xbgr.mr_n77634400)
print v(xbgr.mr_n77634512)
print v(xbgr.mr_n77634832)
print v(xbgr.mr_n77634944)
print v(xbgr.mr_n77635264)
print v(xbgr.mr_n77635376)
print v(xbgr.mr_n77635696)
print v(xbgr.mr_n77635808)
print v(xbgr.mr_n77636128)
print v(xbgr.mr_n77636240)
print v(xbgr.mr_n77636560)
print v(xbgr.mr_n77636672)
print v(xbgr.mr_n77636992)
print v(xbgr.mr_n77637104)
print v(xbgr.mr_n77637424)
print v(xbgr.mr_n77637536)
print v(xbgr.mr_n77637856)
print v(xbgr.mr_n77637968)
print v(xbgr.mr_n77638288)
print v(xbgr.mr_n77638400)
print v(xbgr.mr_n77638720)
print v(xbgr.mr_n77638832)
print v(xbgr.mr_n77639152)
print v(xbgr.mr_n77639264)
print v(xbgr.mr_n77639584)
print v(xbgr.mr_n77639696)
print v(xbgr.mr_n77640016)
print v(xbgr.mr_n77640128)
print v(xbgr.mr_n77640448)
print v(xbgr.mr_n77640560)
print v(xbgr.mr_n77640880)
print v(xbgr.mr_n77640992)
print v(xbgr.mr_n77641312)
print v(xbgr.mr_n77641424)
print v(xbgr.mr_n77641744)
print v(xbgr.mr_n77641856)
print v(xbgr.mr_n77642176)
print v(xbgr.mr_n77642288)
print v(xbgr.mr_n77642608)
print v(xbgr.mr_n77642720)
print v(xbgr.mr_n77643040)
print v(xbgr.mr_n77643152)
print v(xbgr.mr_n77643472)
print v(xbgr.mr_n77643584)
print v(xbgr.mr_n77643904)
print v(xbgr.mr_n77644016)
print v(xbgr.mr_n77644336)
print v(xbgr.mr_n77644448)
print v(xbgr.mr_n77644768)
print v(xbgr.mr_n77644880)
print v(xbgr.mr_n77645200)
print v(xbgr.mr_n77645312)
print v(xbgr.mr_n77645632)
print v(xbgr.mr_n77645744)
print v(xbgr.mr_n77646064)
print v(xbgr.mr_n77646176)
print v(xbgr.mr_n77646496)
print v(xbgr.mr_n77646608)
print v(xbgr.mr_n77646928)
print v(xbgr.mr_n77647040)
print v(xbgr.mr_n77647360)
print v(xbgr.mr_n77647472)
print v(xbgr.mr_n77647792)
print v(xbgr.mr_n77647904)
print v(xbgr.mr_n77648224)
print v(xbgr.mr_n77648336)
print v(xbgr.mr_n77648656)
print v(xbgr.mr_n77648768)
print v(xbgr.mr_n77649088)
print v(xbgr.mr_n77649200)
print v(xbgr.mr_n77649520)
print v(xbgr.mr_n77649632)
print v(xbgr.mr_n77649952)
print v(xbgr.mr_n77650064)
print v(xbgr.mr_n77650384)
print v(xbgr.mr_n77650496)
print v(xbgr.mr_n77650816)
print v(xbgr.mr_n77650928)
print v(xbgr.mr_n77651248)
print v(xbgr.mr_n77651360)
print v(xbgr.mr_n77651680)
print v(xbgr.mr_n77651792)
print v(xbgr.mr_n77652112)
print v(xbgr.mr_n77652224)
print v(xbgr.mr_n77652544)
print v(xbgr.mr_n77652656)
print v(xbgr.mr_n77652976)
print v(xbgr.mr_n77653088)
print v(xbgr.mr_n77653408)
print v(xbgr.mr_n77653520)
print v(xbgr.mr_n77653840)
print v(xbgr.mr_n77653952)
print v(xbgr.mr_n77654272)
print v(xbgr.mr_n77654384)
print v(xbgr.mr_n77654704)
print v(xbgr.mr_n77654816)
print v(xbgr.mr_n77655136)
print v(xbgr.mr_n77655248)
print v(xbgr.mr_n77655568)
print v(xbgr.mr_n77655680)
print v(xbgr.mr_n77656000)
print v(xbgr.mr_n77656112)
print v(xbgr.mr_n77656432)
print v(xbgr.mr_n77656544)
print v(xbgr.mr_n77656864)
print v(xbgr.mr_n77656976)
print v(xbgr.mr_n77657296)
print v(xbgr.mr_n77657408)
print v(xbgr.mr_n77657728)
print v(xbgr.mr_n77657840)
print v(xbgr.mr_n77658160)
print v(xbgr.mr_n77658272)
print v(xbgr.mr_n77658592)
print v(xbgr.mr_n77658704)
print v(xbgr.mr_n77659024)
print v(xbgr.mr_n77659136)
print v(xbgr.mr_n77659456)
print v(xbgr.mr_n77659568)
print v(xbgr.mr_n77659888)
print v(xbgr.mr_n77660000)
print v(xbgr.mr_n77660320)
print v(xbgr.mr_n77660432)
print v(xbgr.mr_n77660752)
print v(xbgr.mr_n77660864)
print v(xbgr.mr_n77661184)
print v(xbgr.mr_n77661296)
print v(xbgr.mr_n77661616)
print v(xbgr.mr_n77661728)
print v(xbgr.mr_n77662048)
print v(xbgr.mr_n77662160)
print v(xbgr.mr_n77662480)
print v(xbgr.mr_n77662592)
print v(xbgr.mr_n77662912)
print v(xbgr.mr_n77663024)
print v(xbgr.mr_n77663344)
print v(xbgr.mr_n77663456)
print v(xbgr.mr_n77663776)
print v(xbgr.mr_n77663888)
print v(xbgr.mr_n77664208)
print v(xbgr.mr_n77664320)
print v(xbgr.mr_n77664640)
print v(xbgr.mr_n77664752)
print v(xbgr.mr_n77665072)
print v(xbgr.mr_n77665184)
print v(xbgr.mr_n77665504)
print v(xbgr.mr_n77665616)
print v(xbgr.mr_n77665936)
print v(xbgr.mr_n77666048)
print v(xbgr.mr_n77666368)
print v(xbgr.mr_n77666480)
print v(xbgr.mr_n77666800)
print v(xbgr.mr_n77666912)
print v(xbgr.mr_n77667232)
print v(xbgr.mr_n77667344)
print v(xbgr.mr_n77667664)
print v(xbgr.mr_n77667776)
print v(xbgr.mr_n77668096)
print v(xbgr.mr_n77668208)
print v(xbgr.mr_n77668528)
print v(xbgr.mr_n77668640)
print v(xbgr.mr_n77668960)
print v(xbgr.mr_n77669072)
print v(xbgr.mr_n77669392)
print v(xbgr.mr_n77669504)
print v(xbgr.mr_n77669824)
print v(xbgr.mr_n77669936)
print v(xbgr.mr_n77670256)
print v(xbgr.mr_n77670368)
print v(xbgr.mr_n77670688)
print v(xbgr.mr_n77670800)
print v(xbgr.mr_n77671120)
print v(xbgr.mr_n77671232)
print v(xbgr.mr_n77671552)
print v(xbgr.mr_n77671664)
print v(xbgr.mr_n77671984)
print v(xbgr.mr_n77672096)
print v(xbgr.mr_n77672416)
print v(xbgr.mr_n77672528)
print v(xbgr.mr_n77672848)
print v(xbgr.mr_n77672960)
print v(xbgr.mr_n77673280)
print v(xbgr.mr_n77673392)
print v(xbgr.mr_n77673712)
print v(xbgr.mr_n77673824)
print v(xbgr.mr_n77674144)
print v(xbgr.mr_n77674256)
print v(xbgr.mr_n77674576)
print v(xbgr.mr_n77674688)
print v(xbgr.mr_n77674976)
print v(xbgr.mr_n77675088)
print v(xbgr.mr_n77675408)
print v(xbgr.mr_n77675520)
print v(xbgr.mr_n77675840)
print v(xbgr.mr_n77675952)
print v(xbgr.mr_n77676272)
print v(xbgr.mr_n77676384)
print v(xbgr.mr_n77676704)
print v(xbgr.mr_n77676816)
print v(xbgr.mr_n77677136)
print v(xbgr.mr_n77677248)
print v(xbgr.mr_n77677568)
print v(xbgr.mr_n77677680)
print v(xbgr.mr_n77678000)
print v(xbgr.mr_n77678112)
print v(xbgr.mr_n77678432)
print v(xbgr.mr_n77678544)
print v(xbgr.mr_n77678864)
print v(xbgr.mr_n77678976)
print v(xbgr.mr_n77679296)
print v(xbgr.mr_n77679408)
print v(xbgr.mr_n77679728)
print v(xbgr.mr_n77679840)
print v(xbgr.mr_n77680160)
print v(xbgr.mr_n77680272)
print v(xbgr.mr_n77680592)
print v(xbgr.mr_n77680704)
print v(xbgr.mr_n77681024)
print v(xbgr.mr_n77681136)
print v(xbgr.mr_n77681456)
print v(xbgr.mr_n77681568)
print v(xbgr.mr_n77681888)
print v(xbgr.mr_n77682000)
print v(xbgr.mr_n77682320)
print v(xbgr.mr_n77682432)
print v(xbgr.mr_n77682752)
print v(xbgr.mr_n77682864)
print v(xbgr.mr_n77683184)
print v(xbgr.mr_n77683296)
print v(xbgr.mr_n77683616)
print v(xbgr.mr_n77683728)
print v(xbgr.mr_n77684048)
print v(xbgr.mr_n77684160)
print v(xbgr.mr_n77684480)
print v(xbgr.mr_n77684592)
print v(xbgr.mr_n77684912)
print v(xbgr.mr_n77685024)
print v(xbgr.mr_n77685344)
print v(xbgr.mr_n77685456)
print v(xbgr.mr_n77685776)
print v(xbgr.mr_n77685888)
print v(xbgr.mr_n77686208)
print v(xbgr.mr_n77686320)
print v(xbgr.mr_n77686640)
print v(xbgr.mr_n77686752)
print v(xbgr.mr_n77687072)
print v(xbgr.mr_n77687184)
print v(xbgr.mr_n77687504)
print v(xbgr.mr_n77687616)
print v(xbgr.mr_n77687936)
print v(xbgr.mr_n77688048)
print v(xbgr.mr_n77688368)
print v(xbgr.mr_n77688480)
print v(xbgr.mr_n77688800)
print v(xbgr.mr_n77688912)
print v(xbgr.mr_n77689232)
print v(xbgr.mr_n77689344)
print v(xbgr.mr_n77689664)
print v(xbgr.mr_n77689776)
print v(xbgr.mr_n77690096)
print v(xbgr.mr_n77690208)
print v(xbgr.mr_n77690528)
print v(xbgr.mr_n77690640)
print v(xbgr.mr_n77690960)
print v(xbgr.mr_n77691072)
print v(xbgr.mr_n77691392)
print v(xbgr.mr_n77691504)
print v(xbgr.mr_n77691824)
print v(xbgr.mr_n77691936)
print v(xbgr.mr_n77692256)
print v(xbgr.mr_n77692368)
print v(xbgr.mr_n77692688)
print v(xbgr.mr_n77692800)
print v(xbgr.mr_n77693120)
print v(xbgr.mr_n77693232)
print v(xbgr.mr_n77693552)
print v(xbgr.mr_n77693664)
print v(xbgr.mr_n77693984)
print v(xbgr.mr_n77694096)
print v(xbgr.mr_n77694416)
print v(xbgr.mr_n77694528)
print v(xbgr.mr_n77694848)
print v(xbgr.mr_n77694960)
print v(xbgr.mr_n77695280)
print v(xbgr.mr_n77695392)
print v(xbgr.mr_n77695712)
print v(xbgr.mr_n77695824)
print v(xbgr.mr_n77696144)
print v(xbgr.mr_n77696256)
print v(xbgr.mr_n77696576)
print v(xbgr.mr_n77696688)
print v(xbgr.mr_n77697008)
print v(xbgr.mr_n77697120)
print v(xbgr.mr_n77697440)
print v(xbgr.mr_n77697552)
print v(xbgr.mr_n77697872)
print v(xbgr.mr_n77697984)
print v(xbgr.mr_n77698304)
print v(xbgr.mr_n77698416)
print v(xbgr.mr_n77698736)
print v(xbgr.mr_n77698848)
print v(xbgr.mr_n77699168)
print v(xbgr.mr_n77699280)
print v(xbgr.mr_n77699600)
print v(xbgr.mr_n77699712)
print v(xbgr.mr_n77700032)
print v(xbgr.mr_n77700144)
print v(xbgr.mr_n77700464)
print v(xbgr.mr_n77700576)
print v(xbgr.mr_n77700896)
print v(xbgr.mr_n77701008)
print v(xbgr.mr_n77701328)
print v(xbgr.mr_n77701440)
print v(xbgr.mr_n77701760)
print v(xbgr.mr_n77701872)
print v(xbgr.mr_n77702192)
print v(xbgr.mr_n77702304)
print v(xbgr.mr_n77702624)
print v(xbgr.mr_n77702736)
print v(xbgr.mr_n77703056)
print v(xbgr.mr_n77703168)
print v(xbgr.mr_n77703488)
print v(xbgr.mr_n77703600)
print v(xbgr.mr_n77703920)
print v(xbgr.mr_n77704032)
print v(xbgr.mr_n77704352)
print v(xbgr.mr_n77704464)
print v(xbgr.mr_n77704784)
print v(xbgr.mr_n77704896)
print v(xbgr.mr_n77705216)
print v(xbgr.mr_n77705328)
print v(xbgr.mr_n77705648)
print v(xbgr.mr_n77705760)
print v(xbgr.mr_n77706080)
print v(xbgr.mr_n77706192)
print v(xbgr.mr_n77706512)
print v(xbgr.mr_n77706624)
print v(xbgr.mr_n77706944)
print v(xbgr.mr_n77707056)
print v(xbgr.mr_n77707376)
print v(xbgr.mr_n77707488)
print v(xbgr.mr_n77707808)
print v(xbgr.mr_n77707920)
print v(xbgr.mr_n77708240)
print v(xbgr.mr_n77708352)
print v(xbgr.mr_n77708672)
print v(xbgr.mr_n77708784)
print v(xbgr.mr_n77709104)
print v(xbgr.mr_n77709216)
print v(xbgr.mr_n77709536)
print v(xbgr.mr_n77709648)
print v(xbgr.mr_n77709968)
print v(xbgr.mr_n77710080)
print v(xbgr.mr_n77710400)
print v(xbgr.mr_n77710512)
print v(xbgr.mr_n77710832)
print v(xbgr.mr_n77710944)
print v(xbgr.mr_n77711264)
print v(xbgr.mr_n77711376)
print v(xbgr.mr_n77711696)
print v(xbgr.mr_n77711808)
print v(xbgr.mr_n77712128)
print v(xbgr.mr_n77712240)
print v(xbgr.mr_n77712560)
print v(xbgr.mr_n77712672)
print v(xbgr.mr_n77712992)
print v(xbgr.mr_n77713104)
print v(xbgr.mr_n77713424)
print v(xbgr.mr_n77713536)
print v(xbgr.mr_n77713856)
print v(xbgr.mr_n77713968)
print v(xbgr.mr_n77714288)
print v(xbgr.mr_n77714400)
print v(xbgr.mr_n77714720)
print v(xbgr.mr_n77714832)
print v(xbgr.mr_n77715152)
print v(xbgr.mr_n77715264)
print v(xbgr.mr_n77715584)
print v(xbgr.mr_n77715696)
print v(xbgr.mr_n77716016)
print v(xbgr.mr_n77716128)
print v(xbgr.mr_n77716448)
print v(xbgr.mr_n77716560)
print v(xbgr.mr_n77716880)
print v(xbgr.mr_n77716992)
print v(xbgr.mr_n77717312)
print v(xbgr.mr_n77717424)
print v(xbgr.mr_n77717744)
print v(xbgr.mr_n77717856)
print v(xbgr.mr_n77718176)
print v(xbgr.mr_n77718288)
print v(xbgr.mr_n77718608)
print v(xbgr.mr_n77718720)
print v(xbgr.mr_n77719040)
print v(xbgr.mr_n77719152)
print v(xbgr.mr_n77719472)
print v(xbgr.mr_n77719584)
print v(xbgr.mr_n77719904)
print v(xbgr.mr_n77720016)
print v(xbgr.mr_n77720336)
print v(xbgr.mr_n77720448)
print v(xbgr.mr_n77720768)
print v(xbgr.mr_n77720880)
print v(xbgr.mr_n77721200)
print v(xbgr.mr_n77721312)
print v(xbgr.mr_n77721632)
print v(xbgr.mr_n77721744)
print v(xbgr.mr_n77722064)
print v(xbgr.mr_n77722176)
print v(xbgr.mr_n77722496)
print v(xbgr.mr_n77722608)
print v(xbgr.mr_n77722928)
print v(xbgr.mr_n77723040)
print v(xbgr.mr_n77723360)
print v(xbgr.mr_n77723472)
print v(xbgr.mr_n77723792)
print v(xbgr.mr_n77723904)
print v(xbgr.mr_n77724224)
print v(xbgr.mr_n77724336)
print v(xbgr.mr_n77724656)
print v(xbgr.mr_n77724768)
print v(xbgr.mr_n77725088)
print v(xbgr.mr_n77725200)
print v(xbgr.mr_n77725520)
print v(xbgr.mr_n77725632)
print v(xbgr.mr_n77725952)
print v(xbgr.mr_n77726064)
print v(xbgr.mr_n77726384)
print v(xbgr.mr_n77726496)
print v(xbgr.mr_n77726816)
print v(xbgr.mr_n77726928)
print v(xbgr.mr_n77727248)
print v(xbgr.mr_n77727360)
print v(xbgr.mr_n77727680)
print v(xbgr.mr_n77727792)
print v(xbgr.mr_n77728112)
print v(xbgr.mr_n77728224)
print v(xbgr.mr_n77728544)
print v(xbgr.mr_n77728656)
print v(xbgr.mr_n77728976)
print v(xbgr.mr_n77729088)
print v(xbgr.mr_n77729408)
print v(xbgr.mr_n77729520)
print v(xbgr.mr_n77729840)
print v(xbgr.mr_n77729952)
print v(xbgr.mr_n77730272)
print v(xbgr.mr_n77730384)
print v(xbgr.mr_n77730704)
print v(xbgr.mr_n77730816)
print v(xbgr.mr_n77731136)
print v(xbgr.mr_n77731248)
print v(xbgr.mr_n77731568)
print v(xbgr.mr_n77731680)
print v(xbgr.mr_n77732000)
print v(xbgr.mr_n77732112)
print v(xbgr.mr_n77732432)
print v(xbgr.mr_n77732544)
print v(xbgr.mr_n77732864)
print v(xbgr.mr_n77732976)
print v(xbgr.mr_n77733296)
print v(xbgr.mr_n77733408)
print v(xbgr.mr_n77733728)
print v(xbgr.mr_n77733840)
print v(xbgr.mr_n77734160)
print v(xbgr.mr_n77734272)
print v(xbgr.mr_n77734592)
print v(xbgr.mr_n77734704)
print v(xbgr.mr_n77735024)
print v(xbgr.mr_n77735136)
print v(xbgr.mr_n77735456)
print v(xbgr.mr_n77735568)
print v(xbgr.mr_n77735888)
print v(xbgr.mr_n77736000)
print v(xbgr.mr_n77736320)
print v(xbgr.mr_n77736432)
print v(xbgr.mr_n77736752)
print v(xbgr.mr_n77736864)
print v(xbgr.mr_n77737184)
print v(xbgr.mr_n77737296)
print v(xbgr.mr_n77737616)
print v(xbgr.mr_n77737728)
print v(xbgr.mr_n77738048)
print v(xbgr.mr_n77738160)
print v(xbgr.mr_n77738480)
print v(xbgr.mr_n77738592)
print v(xbgr.mr_n77738912)
print v(xbgr.mr_n77739024)
print v(xbgr.mr_n77739344)
print v(xbgr.mr_n77739456)
print v(xbgr.mr_n77739776)
print v(xbgr.mr_n77739888)
print v(xbgr.mr_n77740208)
print v(xbgr.mr_n77740320)
print v(xbgr.mr_n77740640)
print v(xbgr.mr_n77740752)
print v(xbgr.mr_n77741072)
print v(xbgr.mr_n77741184)
print v(xbgr.mr_n77741504)
print v(xbgr.mr_n77741616)
print v(xbgr.mr_n77741936)
print v(xbgr.mr_n77742048)
print v(xbgr.mr_n77742368)
print v(xbgr.mr_n77742480)
print v(xbgr.mr_n77742800)
print v(xbgr.mr_n77742912)
print v(xbgr.mr_n77743232)
print v(xbgr.mr_n77743344)
print v(xbgr.mr_n77743664)
print v(xbgr.mr_n77743776)
print v(xbgr.mr_n77744096)
print v(xbgr.mr_n77744208)
print v(xbgr.mr_n77744528)
print v(xbgr.mr_n77744640)
print v(xbgr.mr_n77744960)
print v(xbgr.mr_n77745072)
print v(xbgr.mr_n77745392)
print v(xbgr.mr_n77745504)
print v(xbgr.mr_n77745824)
print v(xbgr.mr_n77745936)
print v(xbgr.mr_n77746256)
print v(xbgr.mr_n77746368)
print v(xbgr.mr_n77746688)
print v(xbgr.mr_n77746800)
print v(xbgr.mr_n77747120)
print v(xbgr.mr_n77747232)
print v(xbgr.mr_n77747552)
print v(xbgr.mr_n77747664)
print v(xbgr.mr_n77747984)
print v(xbgr.mr_n77748096)
print v(xbgr.mr_n77748416)
print v(xbgr.mr_n77748528)
print v(xbgr.mr_n77748848)
print v(xbgr.mr_n77748960)
print v(xbgr.mr_n77749280)
print v(xbgr.mr_n77749392)
print v(xbgr.mr_n77749712)
print v(xbgr.mr_n77749824)
print v(xbgr.mr_n77750144)
print v(xbgr.mr_n77750256)
print v(xbgr.mr_n77750576)
print v(xbgr.mr_n77750688)
print v(xbgr.mr_n77751008)
print v(xbgr.mr_n77751120)
print v(xbgr.mr_n77751440)
print v(xbgr.mr_n77751552)
print v(xbgr.mr_n77751872)
print v(xbgr.mr_n77751984)
print v(xbgr.mr_n77752304)
print v(xbgr.mr_n77752416)
print v(xbgr.mr_n77752736)
print v(xbgr.mr_n77752848)
print v(xbgr.mr_n77753168)
print v(xbgr.mr_n77753280)
print v(xbgr.mr_n77753600)
print v(xbgr.mr_n77753712)
print v(xbgr.mr_n77754032)
print v(xbgr.mr_n77754144)
print v(xbgr.mr_n77754464)
print v(xbgr.mr_n77754576)
print v(xbgr.mr_n77754896)
print v(xbgr.mr_n77755008)
print v(xbgr.mr_n77755328)
print v(xbgr.mr_n77755440)
print v(xbgr.mr_n77755760)
print v(xbgr.mr_n77755872)
print v(xbgr.mr_n77756192)
print v(xbgr.mr_n77756304)
print v(xbgr.mr_n77756624)
print v(xbgr.mr_n77756736)
print v(xbgr.mr_n77757056)
print v(xbgr.mr_n77757168)
print v(xbgr.mr_n77757488)
print v(xbgr.mr_n77757600)
print v(xbgr.mr_n77757920)
print v(xbgr.mr_n77758032)
print v(xbgr.mr_n77758352)
print v(xbgr.mr_n77758464)
print v(xbgr.mr_n77758784)
print v(xbgr.mr_n77758896)
print v(xbgr.mr_n77759216)
print v(xbgr.mr_n77759328)
print v(xbgr.mr_n77759648)
print v(xbgr.mr_n77759760)
print v(xbgr.mr_n77760080)
print v(xbgr.mr_n77760192)
print v(xbgr.mr_n77760512)
print v(xbgr.mr_n77760624)
print v(xbgr.mr_n77760944)
print v(xbgr.mr_n77761056)
print v(xbgr.mr_n77761376)
print v(xbgr.mr_n77761488)
print v(xbgr.mr_n77761808)
print v(xbgr.mr_n77761920)
print v(xbgr.mr_n77762240)
print v(xbgr.mr_n77762352)
print v(xbgr.mr_n77762672)
print v(xbgr.mr_n77762784)
print v(xbgr.mr_n77763104)
print v(xbgr.mr_n77763216)
print v(xbgr.mr_n77763536)
print v(xbgr.mr_n77763648)
print v(xbgr.mr_n77763968)
print v(xbgr.mr_n77764080)
print v(xbgr.mr_n77764400)
print v(xbgr.mr_n77764512)
print v(xbgr.mr_n77764832)
print v(xbgr.mr_n77764944)
print v(xbgr.mr_n77765264)
print v(xbgr.mr_n77765376)
print v(xbgr.mr_n77765696)
print v(xbgr.mr_n77765808)
print v(xbgr.mr_n77766128)
print v(xbgr.mr_n77766240)
print v(xbgr.mr_n77766560)
print v(xbgr.mr_n77766672)
print v(xbgr.mr_n77766992)
print v(xbgr.mr_n77767104)
print v(xbgr.mr_n77767424)
print v(xbgr.mr_n77767536)
print v(xbgr.mr_n77767856)
print v(xbgr.mr_n77767968)
print v(xbgr.mr_n77768288)
print v(xbgr.mr_n77768400)
print v(xbgr.mr_n77768720)
print v(xbgr.mr_n77768832)
print v(xbgr.mr_n77769152)
print v(xbgr.mr_n77769264)
print v(xbgr.mr_n77769584)
print v(xbgr.mr_n77769696)
print v(xbgr.mr_n77770016)
print v(xbgr.mr_n77770128)
print v(xbgr.mr_n77770448)
print v(xbgr.mr_n77770560)
print v(xbgr.mr_n77770880)
print v(xbgr.mr_n77770992)
print v(xbgr.mr_n77771312)
print v(xbgr.mr_n77771424)
print v(xbgr.mr_n77771744)
print v(xbgr.mr_n77771856)
print v(xbgr.mr_n77772176)
print v(xbgr.mr_n77772288)
print v(xbgr.mr_n77772608)
print v(xbgr.mr_n77772720)
print v(xbgr.mr_n77773040)
print v(xbgr.mr_n77773152)
print v(xbgr.mr_n77773472)
print v(xbgr.mr_n77773584)
print v(xbgr.mr_n77773904)
print v(xbgr.mr_n77774016)
print v(xbgr.mr_n77774336)
print v(xbgr.mr_n77774448)
print v(xbgr.mr_n77774768)
print v(xbgr.mr_n77774880)
print v(xbgr.mr_n77775200)
print v(xbgr.mr_n77775312)
print v(xbgr.mr_n77775632)
print v(xbgr.mr_n77775744)
print v(xbgr.mr_n77776064)
print v(xbgr.mr_n77776176)
print v(xbgr.mr_n77776496)
print v(xbgr.mr_n77776608)
print v(xbgr.mr_n77776928)
print v(xbgr.mr_n77777040)
print v(xbgr.mr_n77777360)
print v(xbgr.mr_n77777472)
print v(xbgr.mr_n77777792)
print v(xbgr.mr_n77777904)
print v(xbgr.mr_n77778224)
print v(xbgr.mr_n77778336)
print v(xbgr.mr_n77778656)
print v(xbgr.mr_n77778768)
print v(xbgr.mr_n77779088)
print v(xbgr.mr_n77779200)
print v(xbgr.mr_n77779520)
print v(xbgr.mr_n77779632)
print v(xbgr.mr_n77779952)
print v(xbgr.mr_n77780064)
print v(xbgr.mr_n77780384)
print v(xbgr.mr_n77780496)
print v(xbgr.mr_n77780816)
print v(xbgr.mr_n77780928)
print v(xbgr.mr_n77781248)
print v(xbgr.mr_n77781360)
print v(xbgr.mr_n77781680)
print v(xbgr.mr_n77781792)
print v(xbgr.mr_n77782112)
print v(xbgr.mr_n77782224)
print v(xbgr.mr_n77782544)
print v(xbgr.mr_n77782656)
print v(xbgr.mr_n77782976)
print v(xbgr.mr_n77783088)
print v(xbgr.mr_n77783408)
print v(xbgr.mr_n77783520)
print v(xbgr.mr_n77783840)
print v(xbgr.mr_n77783952)
print v(xbgr.mr_n77784272)
print v(xbgr.mr_n77784384)
print v(xbgr.mr_n77784704)
print v(xbgr.mr_n77784816)
print v(xbgr.mr_n77785136)
print v(xbgr.mr_n77785248)
print v(xbgr.mr_n77785568)
print v(xbgr.mr_n77785680)
print v(xbgr.mr_n77786000)
print v(xbgr.mr_n77786112)
print v(xbgr.mr_n77786432)
print v(xbgr.mr_n77786544)
print v(xbgr.mr_n77786864)
print v(xbgr.mr_n77786976)
print v(xbgr.mr_n77787296)
print v(xbgr.mr_n77787408)
print v(xbgr.mr_n77787728)
print v(xbgr.mr_n77787840)
print v(xbgr.mr_n77788160)
print v(xbgr.mr_n77788272)
print v(xbgr.mr_n77788592)
print v(xbgr.mr_n77788704)
print v(xbgr.mr_n77789024)
print v(xbgr.mr_n77789136)
print v(xbgr.mr_n77789456)
print v(xbgr.mr_n77789568)
print v(xbgr.mr_n77789888)
print v(xbgr.mr_n77790000)
print v(xbgr.mr_n77790320)
print v(xbgr.mr_n77790432)
print v(xbgr.mr_n77790752)
print v(xbgr.mr_n77790864)
print v(xbgr.mr_n77791184)
print v(xbgr.mr_n77791296)
print v(xbgr.mr_n77791616)
print v(xbgr.mr_n77791728)
print v(xbgr.mr_n77792048)
print v(xbgr.mr_n77792160)
print v(xbgr.mr_n77792480)
print v(xbgr.mr_n77792592)
print v(xbgr.mr_n77792912)
print v(xbgr.mr_n77793024)
print v(xbgr.mr_n77793344)
print v(xbgr.mr_n77793456)
print v(xbgr.mr_n77793776)
print v(xbgr.mr_n77793888)
print v(xbgr.mr_n77794208)
print v(xbgr.mr_n77794320)
print v(xbgr.mr_n77794640)
print v(xbgr.mr_n77794752)
print v(xbgr.mr_n77795072)
print v(xbgr.mr_n77795184)
print v(xbgr.mr_n77795504)
print v(xbgr.mr_n77795616)
print v(xbgr.mr_n77795936)
print v(xbgr.mr_n77796048)
print v(xbgr.mr_n77796368)
print v(xbgr.mr_n77796480)
print v(xbgr.mr_n77796800)
print v(xbgr.mr_n77796912)
print v(xbgr.mr_n77797232)
print v(xbgr.mr_n77797344)
print v(xbgr.mr_n77797664)
print v(xbgr.mr_n77797776)
print v(xbgr.mr_n77798096)
print v(xbgr.mr_n77798208)
print v(xbgr.mr_n77798528)
print v(xbgr.mr_n77798640)
print v(xbgr.mr_n77798960)
print v(xbgr.mr_n77799072)
print v(xbgr.mr_n77799392)
print v(xbgr.mr_n77799504)
print v(xbgr.mr_n77799824)
print v(xbgr.mr_n77799936)
print v(xbgr.mr_n77800256)
print v(xbgr.mr_n77800368)
print v(xbgr.mr_n77800688)
print v(xbgr.mr_n77800800)
print v(xbgr.mr_n77801120)
print v(xbgr.mr_n77801232)
print v(xbgr.mr_n77801552)
print v(xbgr.mr_n77801664)
print v(xbgr.mr_n77801984)
print v(xbgr.mr_n77802096)
print v(xbgr.mr_n77802416)
print v(xbgr.mr_n77802528)
print v(xbgr.mr_n77802848)
print v(xbgr.mr_n77802960)
print v(xbgr.mr_n77803280)
print v(xbgr.mr_n77803392)
print v(xbgr.mr_n77803712)
print v(xbgr.mr_n77803824)
print v(xbgr.mr_n77804144)
print v(xbgr.mr_n77804256)
print v(xbgr.mr_n77804576)
print v(xbgr.mr_n77804688)
print v(xbgr.mr_n77805008)
print v(xbgr.mr_n77805120)
print v(xbgr.mr_n77805440)
print v(xbgr.mr_n77805552)
print v(xbgr.mr_n77805872)
print v(xbgr.mr_n77805984)
print v(xbgr.mr_n77806304)
print v(xbgr.mr_n77806416)
print v(xbgr.mr_n77806736)
print v(xbgr.mr_n77806848)
print v(xbgr.mr_n77807168)
print v(xbgr.mr_n77807280)
print v(xbgr.mr_n77807600)
print v(xbgr.mr_n77807712)
print v(xbgr.mr_n77808032)
print v(xbgr.mr_n77808144)
print v(xbgr.mr_n77808464)
print v(xbgr.mr_n77808576)
print v(xbgr.mr_n77808896)
print v(xbgr.mr_n77809008)
print v(xbgr.mr_n77809328)
print v(xbgr.mr_n77809440)
print v(xbgr.mr_n77809760)
print v(xbgr.mr_n77809872)
print v(xbgr.mr_n77810192)
print v(xbgr.mr_n77810304)
print v(xbgr.mr_n77810624)
print v(xbgr.mr_n77810736)
print v(xbgr.mr_n77811056)
print v(xbgr.mr_n77811168)
print v(xbgr.mr_n77811488)
print v(xbgr.mr_n77811600)
print v(xbgr.mr_n77811920)
print v(xbgr.mr_n77812032)
print v(xbgr.mr_n77812352)
print v(xbgr.mr_n77812464)
print v(xbgr.mr_n77812784)
print v(xbgr.mr_n77812896)
print v(xbgr.mr_n77813216)
print v(xbgr.mr_n77813328)
print v(xbgr.mr_n77813648)
print v(xbgr.mr_n77813760)
print v(xbgr.mr_n77814080)
print v(xbgr.mr_n77814192)
print v(xbgr.mr_n77814512)
print v(xbgr.mr_n77814624)
print v(xbgr.mr_n77814944)
print v(xbgr.mr_n77815056)
print v(xbgr.mr_n77815376)
print v(xbgr.mr_n77815488)
print v(xbgr.mr_n77815808)
print v(xbgr.mr_n77815920)
print v(xbgr.mr_n77816240)
print v(xbgr.mr_n77816352)
print v(xbgr.mr_n77816672)
print v(xbgr.mr_n77816784)
print v(xbgr.mr_n77817104)
print v(xbgr.mr_n77817216)
print v(xbgr.mr_n77817536)
print v(xbgr.mr_n77817648)
print v(xbgr.mr_n77817968)
print v(xbgr.mr_n77818080)
print v(xbgr.mr_n77818400)
print v(xbgr.mr_n77818512)
print v(xbgr.mr_n77818832)
print v(xbgr.mr_n77818944)
print v(xbgr.mr_n77819264)
print v(xbgr.mr_n77819376)
print v(xbgr.mr_n77819696)
print v(xbgr.mr_n77819808)
print v(xbgr.mr_n77820128)
print v(xbgr.mr_n77820240)
print v(xbgr.mr_n77820560)
print v(xbgr.mr_n77820672)
print v(xbgr.mr_n77820992)
print v(xbgr.mr_n77821104)
print v(xbgr.mr_n77821424)
print v(xbgr.mr_n77821536)
print v(xbgr.mr_n77821856)
print v(xbgr.mr_n77821968)
print v(xbgr.mr_n77822288)
print v(xbgr.mr_n77822400)
print v(xbgr.mr_n77822720)
print v(xbgr.mr_n77822832)
print v(xbgr.mr_n77823152)
print v(xbgr.mr_n77823264)
print v(xbgr.mr_n77823584)
print v(xbgr.mr_n77823696)
print v(xbgr.mr_n77824016)
print v(xbgr.mr_n77824128)
print v(xbgr.mr_n77824448)
print v(xbgr.mr_n77824560)
print v(xbgr.mr_n77824880)
print v(xbgr.mr_n77824992)
print v(xbgr.mr_n77825312)
print v(xbgr.mr_n77825424)
print v(xbgr.mr_n77825744)
print v(xbgr.mr_n77825856)
print v(xbgr.mr_n77826176)
print v(xbgr.mr_n77826288)
print v(xbgr.mr_n77826608)
print v(xbgr.mr_n77826720)
print v(xbgr.mr_n77827040)
print v(xbgr.mr_n77827152)
print v(xbgr.mr_n77827472)
print v(xbgr.mr_n77827584)
print v(xbgr.mr_n77827904)
print v(xbgr.mr_n77828016)
print v(xbgr.mr_n77828336)
print v(xbgr.mr_n77828448)
print v(xbgr.mr_n77828768)
print v(xbgr.mr_n77828880)
print v(xbgr.mr_n77829200)
print v(xbgr.mr_n77829312)
print v(xbgr.mr_n77829632)
print v(xbgr.mr_n77829744)
print v(xbgr.mr_n77830064)
print v(xbgr.mr_n77830176)
print v(xbgr.mr_n77830496)
print v(xbgr.mr_n77830608)
print v(xbgr.mr_n77830928)
print v(xbgr.mr_n77831040)
print v(xbgr.mr_n77831360)
print v(xbgr.mr_n77831472)
print v(xbgr.mr_n77831792)
print v(xbgr.mr_n77831904)
print v(xbgr.mr_n77832224)
print v(xbgr.mr_n77832336)
print v(xbgr.mr_n77832656)
print v(xbgr.mr_n77832768)
print v(xbgr.mr_n77833088)
print v(xbgr.mr_n77833200)
print v(xbgr.mr_n77833520)
print v(xbgr.mr_n77833632)
print v(xbgr.mr_n77833952)
print v(xbgr.mr_n77834064)
print v(xbgr.mr_n77834384)
print v(xbgr.mr_n77834496)
print v(xbgr.mr_n77834816)
print v(xbgr.mr_n77834928)
print v(xbgr.mr_n77835248)
print v(xbgr.mr_n77835360)
print v(xbgr.mr_n77835680)
print v(xbgr.mr_n77835792)
print v(xbgr.mr_n77836112)
print v(xbgr.mr_n77836224)
print v(xbgr.mr_n77836544)
print v(xbgr.mr_n77836656)
print v(xbgr.mr_n77836976)
print v(xbgr.mr_n77837088)
print v(xbgr.mr_n77837408)
print v(xbgr.mr_n77837520)
print v(xbgr.mr_n77837840)
print v(xbgr.mr_n77837952)
print v(xbgr.mr_n77838272)
print v(xbgr.mr_n77838384)
print v(xbgr.mr_n77838704)
print v(xbgr.mr_n77838816)
print v(xbgr.mr_n77839136)
print v(xbgr.mr_n77839248)
print v(xbgr.mr_n77839568)
print v(xbgr.mr_n77839680)
print v(xbgr.mr_n77840000)
print v(xbgr.mr_n77840112)
print v(xbgr.mr_n77840432)
print v(xbgr.mr_n77840544)
print v(xbgr.mr_n77840864)
print v(xbgr.mr_n77840976)
print v(xbgr.mr_n77841296)
print v(xbgr.mr_n77841408)
print v(xbgr.mr_n77841728)
print v(xbgr.mr_n77841840)
print v(xbgr.mr_n77842160)
print v(xbgr.mr_n77842272)
print v(xbgr.mr_n77842592)
print v(xbgr.mr_n77842704)
print v(xbgr.mr_n77843024)
print v(xbgr.mr_n77843136)
print v(xbgr.mr_n77843456)
print v(xbgr.mr_n77843568)
print v(xbgr.mr_n77843888)
print v(xbgr.mr_n77844000)
print v(xbgr.mr_n77844320)
print v(xbgr.mr_n77844432)
print v(xbgr.mr_n77844752)
print v(xbgr.mr_n77844864)
print v(xbgr.mr_n77845184)
print v(xbgr.mr_n77845296)
print v(xbgr.mr_n77845616)
print v(xbgr.mr_n77845728)
print v(xbgr.mr_n77846048)
print v(xbgr.mr_n77846160)
print v(xbgr.mr_n77846480)
print v(xbgr.mr_n77846592)
print v(xbgr.mr_n77846912)
print v(xbgr.mr_n77847024)
print v(xbgr.mr_n77847344)
print v(xbgr.mr_n77847456)
print v(xbgr.mr_n77847776)
print v(xbgr.mr_n77847888)
print v(xbgr.mr_n77848208)
print v(xbgr.mr_n77848320)
print v(xbgr.mr_n77848640)
print v(xbgr.mr_n77848752)
print v(xbgr.mr_n77849072)
print v(xbgr.mr_n77849184)
print v(xbgr.mr_n77849504)
print v(xbgr.mr_n77849616)
print v(xbgr.mr_n77849936)
print v(xbgr.mr_n77850048)
print v(xbgr.mr_n77850368)
print v(xbgr.mr_n77850480)
print v(xbgr.mr_n77850800)
print v(xbgr.mr_n77850912)
print v(xbgr.mr_n77851232)
print v(xbgr.mr_n77851344)
print v(xbgr.mr_n77851664)
print v(xbgr.mr_n77851776)
print v(xbgr.mr_n77852096)
print v(xbgr.mr_n77852208)
print v(xbgr.mr_n77852528)
print v(xbgr.mr_n77852640)
print v(xbgr.mr_n77852960)
print v(xbgr.mr_n77853072)
print v(xbgr.mr_n77853392)
print v(xbgr.mr_n77853504)
print v(xbgr.mr_n77853824)
print v(xbgr.mr_n77853936)
print v(xbgr.mr_n77854256)
print v(xbgr.mr_n77854368)
print v(xbgr.mr_n77854688)
print v(xbgr.mr_n77854800)
print v(xbgr.mr_n77855120)
print v(xbgr.mr_n77855232)
print v(xbgr.mr_n77855552)
print v(xbgr.mr_n77855664)
print v(xbgr.mr_n77855984)
print v(xbgr.mr_n77856096)
print v(xbgr.mr_n77856416)
print v(xbgr.mr_n77856528)
print v(xbgr.mr_n77856848)
print v(xbgr.mr_n77856960)
print v(xbgr.mr_n77857280)
print v(xbgr.mr_n77857392)
print v(xbgr.mr_n77857712)
print v(xbgr.mr_n77857824)
print v(xbgr.mr_n77858144)
print v(xbgr.mr_n77858256)
print v(xbgr.mr_n77858576)
print v(xbgr.mr_n77858688)
print v(xbgr.mr_n77859008)
print v(xbgr.mr_n77859120)
print v(xbgr.mr_n77859440)
print v(xbgr.mr_n77859552)
print v(xbgr.mr_n77859872)
print v(xbgr.mr_n77859984)
print v(xbgr.mr_n77860304)
print v(xbgr.mr_n77860416)
print v(xbgr.mr_n77860736)
print v(xbgr.mr_n77860848)
print v(xbgr.mr_n77861168)
print v(xbgr.mr_n77861280)
print v(xbgr.mr_n77861600)
print v(xbgr.mr_n77861712)
print v(xbgr.mr_n77862032)
print v(xbgr.mr_n77862144)
print v(xbgr.mr_n77862464)
print v(xbgr.mr_n77862576)
print v(xbgr.mr_n77862896)
print v(xbgr.mr_n77863008)
print v(xbgr.mr_n77863328)
print v(xbgr.mr_n77863440)
print v(xbgr.mr_n77863760)
print v(xbgr.mr_n77863872)
print v(xbgr.mr_n77864192)
print v(xbgr.mr_n77864304)
print v(xbgr.mr_n77864624)
print v(xbgr.mr_n77864736)
print v(xbgr.mr_n77865056)
print v(xbgr.mr_n77865168)
print v(xbgr.mr_n77865488)
print v(xbgr.mr_n77865600)
print v(xbgr.mr_n77865920)
print v(xbgr.mr_n77866032)
print v(xbgr.mr_n77866352)
print v(xbgr.mr_n77866464)
print v(xbgr.mr_n77866784)
print v(xbgr.mr_n77866896)
print v(xbgr.mr_n77867216)
print v(xbgr.mr_n77867328)
print v(xbgr.mr_n77867648)
print v(xbgr.mr_n77867760)
print v(xbgr.mr_n77868080)
print v(xbgr.mr_n77868192)
print v(xbgr.mr_n77868512)
print v(xbgr.mr_n77868624)
print v(xbgr.mr_n77868944)
print v(xbgr.mr_n77869056)
print v(xbgr.mr_n77869376)
print v(xbgr.mr_n77869488)
print v(xbgr.mr_n77869808)
print v(xbgr.mr_n77869920)
print v(xbgr.mr_n77870240)
print v(xbgr.mr_n77870352)
print v(xbgr.mr_n77870672)
print v(xbgr.mr_n77870784)
print v(xbgr.mr_n77871104)
print v(xbgr.mr_n77871216)
print v(xbgr.mr_n77871536)
print v(xbgr.mr_n77871648)
print v(xbgr.mr_n77871968)
print v(xbgr.mr_n77872080)
print v(xbgr.mr_n77872400)
print v(xbgr.mr_n77872512)
print v(xbgr.mr_n77872832)
print v(xbgr.mr_n77872944)
print v(xbgr.mr_n77873264)
print v(xbgr.mr_n77873376)
print v(xbgr.mr_n77873696)
print v(xbgr.mr_n77873808)
print v(xbgr.mr_n77874128)
print v(xbgr.mr_n77874240)
print v(xbgr.mr_n77874560)
print v(xbgr.mr_n77874672)
print v(xbgr.mr_n77874992)
print v(xbgr.mr_n77875104)
print v(xbgr.mr_n77875424)
print v(xbgr.mr_n77875536)
print v(xbgr.mr_n77875856)
print v(xbgr.mr_n77875968)
print v(xbgr.mr_n77876288)
print v(xbgr.mr_n77876400)
print v(xbgr.mr_n77876720)
print v(xbgr.mr_n77876832)
print v(xbgr.mr_n77877152)
print v(xbgr.mr_n77877264)
print v(xbgr.mr_n77877584)
print v(xbgr.mr_n77877696)
print v(xbgr.mr_n77878016)
print v(xbgr.mr_n77878128)
print v(xbgr.mr_n77878448)
print v(xbgr.mr_n77878560)
print v(xbgr.mr_n77878880)
print v(xbgr.mr_n77878992)
print v(xbgr.mr_n77879312)
print v(xbgr.mr_n77879424)
print v(xbgr.mr_n77879744)
print v(xbgr.mr_n77879856)
print v(xbgr.mr_n77880288)
print v(xbgr.mr_n77880608)
print v(xbgr.mr_n77880720)
print v(xbgr.mr_n77881152)
print v(xbgr.mr_n77881472)
print v(xbgr.mr_n77881584)
print v(xbgr.mr_n77882016)
print v(xbgr.mr_n77882336)
print v(xbgr.mr_n77883200)
print v(xbgr.mr_n77884064)
print v(xbgr.mr_n77884928)
print v(xbgr.mr_n77885792)
print v(xbgr.mr_n77886656)
print v(xbgr.mr_n77887520)
print v(xbgr.mr_n77887632)
print v(xbgr.mr_n77887952)
print v(xbgr.mr_n77888064)
print v(xbgr.mr_n77888384)
print v(xbgr.mr_n77888496)
print v(xbgr.mr_n77888816)
print v(xbgr.mr_n77888928)
print v(xbgr.mr_n77889248)
print v(xbgr.mr_n77890112)
print v(xbgr.mr_n77890976)
print v(xbgr.mr_n77891840)
print v(xbgr.mr_n77891952)
print v(xbgr.mr_n77892272)
print v(xbgr.mr_n77892384)
print v(xbgr.mr_n77892704)
print v(xbgr.mr_n77892816)
print v(xbgr.mr_n77893248)
print v(xbgr.mr_n77893680)
print v(xbgr.mr_n77894112)
print v(xbgr.mr_n77894432)
print v(xbgr.mr_n77894544)
print v(xbgr.mr_n77894864)
print v(xbgr.mr_n77894976)
print v(xbgr.mr_n77895296)
print v(xbgr.mr_n77895408)
print v(xbgr.mr_n77895728)
print v(xbgr.mr_n77895840)
print v(xbgr.mr_n77896160)
print v(xbgr.mr_n77896272)
print v(xbgr.mr_n77896592)
print v(xbgr.mr_n77896704)
print v(xbgr.mr_n77897024)
print v(xbgr.mr_n77897136)
print v(xbgr.mr_n77897456)
print v(xbgr.mr_n77897568)
print v(xbgr.mr_n77897888)
print v(xbgr.mr_n77898000)
print v(xbgr.mr_n77898320)
print v(xbgr.mr_n77898432)
print v(xbgr.mr_n77898752)
print v(xbgr.mr_n77898864)
print v(xbgr.mr_n77899184)
print v(xbgr.mr_n77899296)
print v(xbgr.mr_n77899616)
print v(xbgr.mr_n77899728)
print v(xbgr.mr_n77900048)
print v(xbgr.mr_n77900160)
print v(xbgr.mr_n77900480)
print v(xbgr.mr_n77900592)
print v(xbgr.mr_n77900912)
print v(xbgr.mr_n77901024)
print v(xbgr.mr_n77901344)
print v(xbgr.mr_n77901456)
print v(xbgr.mr_n77901776)
print v(xbgr.mr_n77901888)
print v(xbgr.mr_n77902208)
print v(xbgr.mr_n77902320)
print v(xbgr.mr_n77902640)
print v(xbgr.mr_n77902752)
print v(xbgr.mr_n77903072)
print v(xbgr.mr_n77903184)
print v(xbgr.mr_n77903504)
print v(xbgr.mr_n77903616)
print v(xbgr.mr_n77903936)
print v(xbgr.mr_n77904048)
print v(xbgr.mr_n77904368)
print v(xbgr.mr_n77904480)
print v(xbgr.mr_n77904800)
print v(xbgr.mr_n77904912)
print v(xbgr.mr_n77905232)
print v(xbgr.mr_n77905344)
print v(xbgr.mr_n77905664)
print v(xbgr.mr_n77905776)
print v(xbgr.mr_n77906096)
print v(xbgr.mr_n77906208)
print v(xbgr.mr_n77906528)
print v(xbgr.mr_n77906640)
print v(xbgr.mr_n77906960)
print v(xbgr.mr_n77907072)
print v(xbgr.mr_n77907392)
print v(xbgr.mr_n77907504)
print v(xbgr.mr_n77907936)
print v(xbgr.mr_n77908256)
print v(xbgr.mr_n77908368)
print v(xbgr.mr_n77908800)
print v(xbgr.mr_n77909120)
print v(xbgr.mr_n77909984)
print v(xbgr.mr_n77910848)
print v(xbgr.mr_n77911712)
print v(xbgr.mr_n77912576)
print v(xbgr.mr_n77912688)
print v(xbgr.mr_n77913008)
print v(xbgr.mr_n77913120)
print v(xbgr.mr_n77913440)
print v(xbgr.mr_n77913552)
print v(xbgr.mr_n77913872)
print v(xbgr.mr_n77913984)
print v(xbgr.mr_n77914304)
print v(xbgr.mr_n77915168)
print v(xbgr.mr_n77916032)
print v(xbgr.mr_n77916144)
print v(xbgr.mr_n77916464)
print v(xbgr.mr_n77916576)
print v(xbgr.mr_n77916896)
print v(xbgr.mr_n77917008)
print v(xbgr.mr_n77917328)
print v(xbgr.mr_n77917440)
print v(xbgr.mr_n77917760)
print v(xbgr.mr_n77917872)
print v(xbgr.mr_n77918304)
print v(xbgr.mr_n77918624)
print v(xbgr.mr_n77918736)
print v(xbgr.mr_n77919168)
print v(xbgr.mr_n77919488)
print v(xbgr.mr_n77920352)
print v(xbgr.mr_n77921216)
print v(xbgr.mr_n77922080)
print v(xbgr.mr_n77922944)
print v(xbgr.mr_n77923056)
print v(xbgr.mr_n77923376)
print v(xbgr.mr_n77923488)
print v(xbgr.mr_n77923808)
print v(xbgr.mr_n77923920)
print v(xbgr.mr_n77924240)
print v(xbgr.mr_n77924352)
print v(xbgr.mr_n77924672)
print v(xbgr.mr_n77925536)
print v(xbgr.mr_n77926400)
print v(xbgr.mr_n77926512)
print v(xbgr.mr_n77926944)
print v(xbgr.mr_n77927264)
print v(xbgr.mr_n77927376)
print v(xbgr.mr_n77927696)
print v(xbgr.mr_n77927808)
print v(xbgr.mr_n77928128)
print v(xbgr.mr_n77928240)
print v(xbgr.mr_n77928560)
print v(xbgr.mr_n77928672)
print v(xbgr.mr_n77928992)
print v(xbgr.mr_n77929104)
print v(xbgr.mr_n77929536)
print v(xbgr.mr_n77929856)
print v(xbgr.mr_n77930720)
print v(xbgr.mr_n77930832)
print v(xbgr.mr_n77931264)
print v(xbgr.mr_n77931584)
print v(xbgr.mr_n77931696)
print v(xbgr.mr_n77932128)
print v(xbgr.mr_n77932448)
print v(xbgr.mr_n77932560)
print v(xbgr.mr_n77932880)
print v(xbgr.mr_n77932992)
print v(xbgr.mr_n77933312)
print v(xbgr.mr_n77933424)
print v(xbgr.mr_n77933744)
print v(xbgr.mr_n77933856)
print v(xbgr.mr_n77934176)
print v(xbgr.mr_n77935040)
print v(xbgr.mr_n77935904)
print v(xbgr.mr_n77936016)
print v(xbgr.mr_n77936336)
print v(xbgr.mr_n77936448)
print v(xbgr.mr_n77936768)
print v(xbgr.mr_n77936880)
print v(xbgr.mr_n77937200)
print v(xbgr.mr_n77937312)
print v(xbgr.mr_n77937632)
print v(xbgr.mr_n77938496)
print v(xbgr.mr_n77939360)
print v(xbgr.mr_n77939472)
print v(xbgr.mr_n77939792)
print v(xbgr.mr_n77939904)
print v(xbgr.mr_n77940224)
print v(xbgr.mr_n77941088)
print v(xbgr.mr_n77941200)
print v(xbgr.mr_n77941520)
print v(xbgr.mr_n77941632)
print v(xbgr.mr_n77941952)
print v(xbgr.mr_n77942064)
print v(xbgr.mr_n77942384)
print v(xbgr.mr_n77942496)
print v(xbgr.mr_n77942816)
print v(xbgr.mr_n77942928)
print v(xbgr.mr_n77943248)
print v(xbgr.mr_n77943360)
print v(xbgr.mr_n77943680)
print v(xbgr.mr_n77944544)
print v(xbgr.mr_n77945344)
print v(xbgr.mr_n77945456)
print v(xbgr.mr_n77945776)
print v(xbgr.mr_n77945888)
print v(xbgr.mr_n77946208)
print v(xbgr.mr_n77946320)
print v(xbgr.mr_n77946640)
print v(xbgr.mr_n77946752)
print v(xbgr.mr_n77947072)
print v(xbgr.mr_n77947184)
print v(xbgr.mr_n77947504)
print v(xbgr.mr_n77947616)
print v(xbgr.mr_n77947936)
print v(xbgr.mr_n77948048)
print v(xbgr.mr_n77948368)
print v(xbgr.mr_n77948480)
print v(xbgr.mr_n77948800)
print v(xbgr.mr_n77948912)
print v(xbgr.mr_n77949232)
print v(xbgr.mr_n77949344)
print v(xbgr.mr_n77949664)
print v(xbgr.mr_n77949776)
print v(xbgr.mr_n77950096)
print v(xbgr.mr_n77950208)
print v(xbgr.mr_n77950528)
print v(xbgr.mr_n77950640)
print v(xbgr.mr_n77950960)
print v(xbgr.mr_n77951072)
print v(xbgr.mr_n77951392)
print v(xbgr.mr_n77951504)
print v(xbgr.mr_n77951824)
print v(xbgr.mr_n77951936)
print v(xbgr.mr_n77952256)
print v(xbgr.mr_n77952368)
print v(xbgr.mr_n77952688)
print v(xbgr.mr_n77952800)
print v(xbgr.mr_n77953120)
print v(xbgr.mr_n77953232)
print v(xbgr.mr_n77953552)
print v(xbgr.mr_n77953664)
print v(xbgr.mr_n77953984)
print v(xbgr.mr_n77954096)
print v(xbgr.mr_n77954416)
print v(xbgr.mr_n77954528)
print v(xbgr.mr_n77954848)
print v(xbgr.mr_n77954960)
print v(xbgr.mr_n77955280)
print v(xbgr.mr_n77955392)
print v(xbgr.mr_n77955712)
print v(xbgr.mr_n77955824)
print v(xbgr.mr_n77956144)
print v(xbgr.mr_n77956256)
print v(xbgr.mr_n77956576)
print v(xbgr.mr_n77956688)
print v(xbgr.mr_n77957008)
print v(xbgr.mr_n77957120)
print v(xbgr.mr_n77957440)
print v(xbgr.mr_n77957552)
print v(xbgr.mr_n77957872)
print v(xbgr.mr_n77957984)
print v(xbgr.mr_n77958304)
print v(xbgr.mr_n77958416)
print v(xbgr.mr_n77958736)
print v(xbgr.mr_n77958848)
print v(xbgr.mr_n77959168)
print v(xbgr.mr_n77959280)
print v(xbgr.mr_n77959600)
print v(xbgr.mr_n77959712)
print v(xbgr.mr_n77960032)
print v(xbgr.mr_n77960144)
print v(xbgr.mr_n77960464)
print v(xbgr.mr_n77960576)
print v(xbgr.mr_n77960896)
print v(xbgr.mr_n77961008)
print v(xbgr.mr_n77961328)
print v(xbgr.mr_n77961440)
print v(xbgr.mr_n77961760)
print v(xbgr.mr_n77961872)
print v(xbgr.mr_n77962192)
print v(xbgr.mr_n77962304)
print v(xbgr.mr_n77962624)
print v(xbgr.mr_n77962736)
print v(xbgr.mr_n77963056)
print v(xbgr.mr_n77963168)
print v(xbgr.mr_n77963488)
print v(xbgr.mr_n77963600)
print v(xbgr.mr_n77963920)
print v(xbgr.mr_n77964032)
print v(xbgr.mr_n77964352)
print v(xbgr.mr_n77964464)
print v(xbgr.mr_n77964784)
print v(xbgr.mr_n77964896)
print v(xbgr.mr_n77965216)
print v(xbgr.mr_n77965328)
print v(xbgr.mr_n77965648)
print v(xbgr.mr_n77965760)
print v(xbgr.mr_n77966080)
print v(xbgr.mr_n77966192)
print v(xbgr.mr_n77966512)
print v(xbgr.mr_n77966624)
print v(xbgr.mr_n77966944)
print v(xbgr.mr_n77967056)
print v(xbgr.mr_n77967376)
print v(xbgr.mr_n77967488)
print v(xbgr.mr_n77967808)
print v(xbgr.mr_n77967920)
print v(xbgr.mr_n77968240)
print v(xbgr.mr_n77968352)
print v(xbgr.mr_n77968672)
print v(xbgr.mr_n77968784)
print v(xbgr.mr_n77969104)
print v(xbgr.mr_n77969216)
print v(xbgr.mr_n77969536)
print v(xbgr.mr_n77969648)
print v(xbgr.mr_n77969968)
print v(xbgr.mr_n77970080)
print v(xbgr.mr_n77970400)
print v(xbgr.mr_n77970512)
print v(xbgr.mr_n77970832)
print v(xbgr.mr_n77970944)
print v(xbgr.mr_n77971264)
print v(xbgr.mr_n77971376)
print v(xbgr.mr_n77971696)
print v(xbgr.mr_n77971808)
print v(xbgr.mr_n77972128)
print v(xbgr.mr_n77972240)
print v(xbgr.mr_n77972560)
print v(xbgr.mr_n77972672)
print v(xbgr.mr_n77972992)
print v(xbgr.mr_n77973104)
print v(xbgr.mr_n77973424)
print v(xbgr.mr_n77973536)
print v(xbgr.mr_n77973856)
print v(xbgr.mr_n77973968)
print v(xbgr.mr_n77974288)
print v(xbgr.mr_n77974400)
print v(xbgr.mr_n77974720)
print v(xbgr.mr_n77974832)
print v(xbgr.mr_n77975152)
print v(xbgr.mr_n77975264)
print v(xbgr.mr_n77975584)
print v(xbgr.mr_n77975696)
print v(xbgr.mr_n77976016)
print v(xbgr.mr_n77976128)
print v(xbgr.mr_n77976448)
print v(xbgr.mr_n77976560)
print v(xbgr.mr_n77976880)
print v(xbgr.mr_n77976992)
print v(xbgr.mr_n77977312)
print v(xbgr.mr_n77977424)
print v(xbgr.mr_n77977744)
print v(xbgr.mr_n77977856)
print v(xbgr.mr_n77978176)
print v(xbgr.mr_n77978288)
print v(xbgr.mr_n77978608)
print v(xbgr.mr_n77978720)
print v(xbgr.mr_n77979040)
print v(xbgr.mr_n77979152)
print v(xbgr.mr_n77979472)
print v(xbgr.mr_n77979584)
print v(xbgr.mr_n77979904)
print v(xbgr.mr_n77980016)
print v(xbgr.mr_n77980336)
print v(xbgr.mr_n77980448)
print v(xbgr.mr_n77980768)
print v(xbgr.mr_n77980880)
print v(xbgr.mr_n77981200)
print v(xbgr.mr_n77981312)
print v(xbgr.mr_n77981632)
print v(xbgr.mr_n77981744)
print v(xbgr.mr_n77982064)
print v(xbgr.mr_n77982176)
print v(xbgr.mr_n77982496)
print v(xbgr.mr_n77982608)
print v(xbgr.mr_n77982928)
print v(xbgr.mr_n77983040)
print v(xbgr.mr_n77983360)
print v(xbgr.mr_n77983472)
print v(xbgr.mr_n77983792)
print v(xbgr.mr_n77983904)
print v(xbgr.mr_n77984224)
print v(xbgr.mr_n77984336)
print v(xbgr.mr_n77984656)
print v(xbgr.mr_n77984768)
print v(xbgr.mr_n77985088)
print v(xbgr.mr_n77985200)
print v(xbgr.mr_n77985520)
print v(xbgr.mr_n77985632)
print v(xbgr.mr_n77985952)
print v(xbgr.mr_n77986064)
print v(xbgr.mr_n77986384)
print v(xbgr.mr_n77986496)
print v(xbgr.mr_n77986816)
print v(xbgr.mr_n77986928)
print v(xbgr.mr_n77987248)
print v(xbgr.mr_n77987360)
print v(xbgr.mr_n77987680)
print v(xbgr.mr_n77987792)
print v(xbgr.mr_n77988112)
print v(xbgr.mr_n77988224)
print v(xbgr.mr_n77988544)
print v(xbgr.mr_n77988656)
print v(xbgr.mr_n77988976)
print v(xbgr.mr_n77989088)
print v(xbgr.mr_n77989408)
print v(xbgr.mr_n77989520)
print v(xbgr.mr_n77989840)
print v(xbgr.mr_n77989952)
print v(xbgr.mr_n77990272)
print v(xbgr.mr_n77990384)
print v(xbgr.mr_n77990704)
print v(xbgr.mr_n77990816)
print v(xbgr.mr_n77991136)
print v(xbgr.mr_n77991248)
print v(xbgr.mr_n77991568)
print v(xbgr.mr_n77991680)
print v(xbgr.mr_n77992000)
print v(xbgr.mr_n77992112)
print v(xbgr.mr_n77992432)
print v(xbgr.mr_n77992544)
print v(xbgr.mr_n77992864)
print v(xbgr.mr_n77992976)
print v(xbgr.mr_n77993296)
print v(xbgr.mr_n77993408)
print v(xbgr.mr_n77993728)
print v(xbgr.mr_n77993840)
print v(xbgr.mr_n77994160)
print v(xbgr.mr_n77994272)
print v(xbgr.mr_n77994592)
print v(xbgr.mr_n77994704)
print v(xbgr.mr_n77995024)
print v(xbgr.mr_n77995136)
print v(xbgr.mr_n77995456)
print v(xbgr.mr_n77995568)
print v(xbgr.mr_n77995888)
print v(xbgr.mr_n77996000)
print v(xbgr.mr_n77996320)
print v(xbgr.mr_n77996432)
print v(xbgr.mr_n77996752)
print v(xbgr.mr_n77996864)
print v(xbgr.mr_n77997184)
print v(xbgr.mr_n77997296)
print v(xbgr.mr_n77997616)
print v(xbgr.mr_n77997728)
print v(xbgr.mr_n77998048)
print v(xbgr.mr_n77998160)
print v(xbgr.mr_n77998480)
print v(xbgr.mr_n77998592)
print v(xbgr.mr_n77998912)
print v(xbgr.mr_n77999024)
print v(xbgr.mr_n77999344)
print v(xbgr.mr_n77999456)
print v(xbgr.mr_n77999776)
print v(xbgr.mr_n77999888)
print v(xbgr.mr_n78000208)
print v(xbgr.mr_n78000320)
print v(xbgr.mr_n78000640)
print v(xbgr.mr_n78000752)
print v(xbgr.mr_n78001072)
print v(xbgr.mr_n78001184)
print v(xbgr.mr_n78001504)
print v(xbgr.mr_n78001616)
print v(xbgr.mr_n78001936)
print v(xbgr.mr_n78002048)
print v(xbgr.mr_n78002368)
print v(xbgr.mr_n78002480)
print v(xbgr.mr_n78002800)
print v(xbgr.mr_n78002912)
print v(xbgr.mr_n78003232)
print v(xbgr.mr_n78003344)
print v(xbgr.mr_n78003664)
print v(xbgr.mr_n78003776)
print v(xbgr.mr_n78004096)
print v(xbgr.mr_n78004208)
print v(xbgr.mr_n78004528)
print v(xbgr.mr_n78004640)
print v(xbgr.mr_n78004960)
print v(xbgr.mr_n78005072)
print v(xbgr.mr_n78005392)
print v(xbgr.mr_n78005504)
print v(xbgr.mr_n78005824)
print v(xbgr.mr_n78005936)
print v(xbgr.mr_n78006256)
print v(xbgr.mr_n78006368)
print v(xbgr.mr_n78006688)
print v(xbgr.mr_n78006800)
print v(xbgr.mr_n78007120)
print v(xbgr.mr_n78007232)
print v(xbgr.mr_n78007552)
print v(xbgr.mr_n78007664)
print v(xbgr.mr_n78007984)
print v(xbgr.mr_n78008096)
print v(xbgr.mr_n78008416)
print v(xbgr.mr_n78008528)
print v(xbgr.mr_n78008848)
print v(xbgr.mr_n78008960)
print v(xbgr.mr_n78009280)
print v(xbgr.mr_n78009392)
print v(xbgr.mr_n78009712)
print v(xbgr.mr_n78009824)
print v(xbgr.mr_n78010144)
print v(xbgr.mr_n78010256)
print v(xbgr.mr_n78010576)
print v(xbgr.mr_n78010688)
print v(xbgr.mr_n78011008)
print v(xbgr.mr_n78011120)
print v(xbgr.mr_n78011440)
print v(xbgr.mr_n78011552)
print v(xbgr.mr_n78011872)
print v(xbgr.mr_n78011984)
print v(xbgr.mr_n78012304)
print v(xbgr.mr_n78012416)
print v(xbgr.mr_n78012736)
print v(xbgr.mr_n78012848)
print v(xbgr.mr_n78013168)
print v(xbgr.mr_n78013280)
print v(xbgr.mr_n78013600)
print v(xbgr.mr_n78013712)
print v(xbgr.mr_n78014032)
print v(xbgr.mr_n78014144)
print v(xbgr.mr_n78014464)
print v(xbgr.mr_n78014576)
print v(xbgr.mr_n78014896)
print v(xbgr.mr_n78015008)
print v(xbgr.mr_n78015328)
print v(xbgr.mr_n78015440)
print v(xbgr.mr_n78015760)
print v(xbgr.mr_n78015872)
print v(xbgr.mr_n78016192)
print v(xbgr.mr_n78016304)
print v(xbgr.mr_n78016624)
print v(xbgr.mr_n78016736)
print v(xbgr.mr_n78017056)
print v(xbgr.mr_n78017168)
print v(xbgr.mr_n78017488)
print v(xbgr.mr_n78017600)
print v(xbgr.mr_n78017920)
print v(xbgr.mr_n78018032)
print v(xbgr.mr_n78018352)
print v(xbgr.mr_n78018464)
print v(xbgr.mr_n78018784)
print v(xbgr.mr_n78018896)
print v(xbgr.mr_n78019216)
print v(xbgr.mr_n78019328)
print v(xbgr.mr_n78019648)
print v(xbgr.mr_n78019760)
print v(xbgr.mr_n78020080)
print v(xbgr.mr_n78020192)
print v(xbgr.mr_n78020512)
print v(xbgr.mr_n78020624)
print v(xbgr.mr_n78020944)
print v(xbgr.mr_n78021056)
print v(xbgr.mr_n78021376)
print v(xbgr.mr_n78021488)
print v(xbgr.mr_n78021808)
print v(xbgr.mr_n78021920)
print v(xbgr.mr_n78022240)
print v(xbgr.mr_n78022352)
print v(xbgr.mr_n78022672)
print v(xbgr.mr_n78022784)
print v(xbgr.mr_n78023104)
print v(xbgr.mr_n78023216)
print v(xbgr.mr_n78023536)
print v(xbgr.mr_n78023648)
print v(xbgr.mr_n78023968)
print v(xbgr.mr_n78024080)
print v(xbgr.mr_n78024400)
print v(xbgr.mr_n78024512)
print v(xbgr.mr_n78024832)
print v(xbgr.mr_n78024944)
print v(xbgr.mr_n78025264)
print v(xbgr.mr_n78025376)
print v(xbgr.mr_n78025696)
print v(xbgr.mr_n78025808)
print v(xbgr.mr_n78026128)
print v(xbgr.mr_n78026240)
print v(xbgr.mr_n78026560)
print v(xbgr.mr_n78026672)
print v(xbgr.mr_n78026992)
print v(xbgr.mr_n78027104)
print v(xbgr.mr_n78027424)
print v(xbgr.mr_n78027536)
print v(xbgr.mr_n78027856)
print v(xbgr.mr_n78027968)
print v(xbgr.mr_n78028288)
print v(xbgr.mr_n78028400)
print v(xbgr.mr_n78028720)
print v(xbgr.mr_n78028832)
print v(xbgr.mr_n78029152)
print v(xbgr.mr_n78029264)
print v(xbgr.mr_n78029584)
print v(xbgr.mr_n78029696)
print v(xbgr.mr_n78030016)
print v(xbgr.mr_n78030128)
print v(xbgr.mr_n78030448)
print v(xbgr.mr_n78030560)
print v(xbgr.mr_n78030880)
print v(xbgr.mr_n78030992)
print v(xbgr.mr_n78031312)
print v(xbgr.mr_n78031424)
print v(xbgr.mr_n78031744)
print v(xbgr.mr_n78031856)
print v(xbgr.mr_n78032176)
print v(xbgr.mr_n78032288)
print v(xbgr.mr_n78032608)
print v(xbgr.mr_n78032720)
print v(xbgr.mr_n78033040)
print v(xbgr.mr_n78033152)
print v(xbgr.mr_n78033472)
print v(xbgr.mr_n78033584)
print v(xbgr.mr_n78033904)
print v(xbgr.mr_n78034016)
print v(xbgr.mr_n78034336)
print v(xbgr.mr_n78034448)
print v(xbgr.mr_n78034768)
print v(xbgr.mr_n78034880)
print v(xbgr.mr_n78035200)
print v(xbgr.mr_n78035312)
print v(xbgr.mr_n78035632)
print v(xbgr.mr_n78035744)
print v(xbgr.mr_n78036064)
print v(xbgr.mr_n78036176)
print v(xbgr.mr_n78036496)
print v(xbgr.mr_n78036608)
print v(xbgr.mr_n78036928)
print v(xbgr.mr_n78037040)
print v(xbgr.mr_n78037360)
print v(xbgr.mr_n78037472)
print v(xbgr.mr_n78037792)
print v(xbgr.mr_n78037904)
print v(xbgr.mr_n78038224)
print v(xbgr.mr_n78038336)
print v(xbgr.mr_n78038656)
print v(xbgr.mr_n78038768)
print v(xbgr.mr_n78039088)
print v(xbgr.mr_n78039200)
print v(xbgr.mr_n78039520)
print v(xbgr.mr_n78039632)
print v(xbgr.mr_n78039952)
print v(xbgr.mr_n78040064)
print v(xbgr.mr_n78040384)
print v(xbgr.mr_n78040496)
print v(xbgr.mr_n78040816)
print v(xbgr.mr_n78040928)
print v(xbgr.mr_n78041248)
print v(xbgr.mr_n78041360)
print v(xbgr.mr_n78041680)
print v(xbgr.mr_n78041792)
print v(xbgr.mr_n78042112)
print v(xbgr.mr_n78042224)
print v(xbgr.mr_n78042544)
print v(xbgr.mr_n78042656)
print v(xbgr.mr_n78042976)
print v(xbgr.mr_n78043088)
print v(xbgr.mr_n78043408)
print v(xbgr.mr_n78043520)
print v(xbgr.mr_n78043840)
print v(xbgr.mr_n78043952)
print v(xbgr.mr_n78044272)
print v(xbgr.mr_n78044384)
print v(xbgr.mr_n78044704)
print v(xbgr.mr_n78044816)
print v(xbgr.mr_n78045136)
print v(xbgr.mr_n78045248)
print v(xbgr.mr_n78045568)
print v(xbgr.mr_n78045680)
print v(xbgr.mr_n78046000)
print v(xbgr.mr_n78046112)
print v(xbgr.mr_n78046432)
print v(xbgr.mr_n78046544)
print v(xbgr.mr_n78046864)
print v(xbgr.mr_n78046976)
print v(xbgr.mr_n78047296)
print v(xbgr.mr_n78047408)
print v(xbgr.mr_n78047728)
print v(xbgr.mr_n78047840)
print v(xbgr.mr_n78048160)
print v(xbgr.mr_n78048272)
print v(xbgr.mr_n78048592)
print v(xbgr.mr_n78048704)
print v(xbgr.mr_n78049024)
print v(xbgr.mr_n78049136)
print v(xbgr.mr_n78049456)
print v(xbgr.mr_n78049568)
print v(xbgr.mr_n78049888)
print v(xbgr.mr_n78050000)
print v(xbgr.mr_n78050320)
print v(xbgr.mr_n78050432)
print v(xbgr.mr_n78050752)
print v(xbgr.mr_n78050864)
print v(xbgr.mr_n78051184)
print v(xbgr.mr_n78051296)
print v(xbgr.mr_n78051616)
print v(xbgr.mr_n78051728)
print v(xbgr.mr_n78052048)
print v(xbgr.mr_n78052160)
print v(xbgr.mr_n78052480)
print v(xbgr.mr_n78052592)
print v(xbgr.mr_n78052912)
print v(xbgr.mr_n78053024)
print v(xbgr.mr_n78053344)
print v(xbgr.mr_n78053456)
print v(xbgr.mr_n78053776)
print v(xbgr.mr_n78053888)
print v(xbgr.mr_n78054208)
print v(xbgr.mr_n78054320)
print v(xbgr.mr_n78054640)
print v(xbgr.mr_n78054752)
print v(xbgr.mr_n78055072)
print v(xbgr.mr_n78055184)
print v(xbgr.mr_n78055504)
print v(xbgr.mr_n78055616)
print v(xbgr.mr_n78055936)
print v(xbgr.mr_n78056048)
print v(xbgr.mr_n78056368)
print v(xbgr.mr_n78056480)
print v(xbgr.mr_n78056800)
print v(xbgr.mr_n78056912)
print v(xbgr.mr_n78057232)
print v(xbgr.mr_n78057344)
print v(xbgr.mr_n78057664)
print v(xbgr.mr_n78057776)
print v(xbgr.mr_n78058096)
print v(xbgr.mr_n78058208)
print v(xbgr.mr_n78058528)
print v(xbgr.mr_n78058640)
print v(xbgr.mr_n78058960)
print v(xbgr.mr_n78059072)
print v(xbgr.mr_n78059392)
print v(xbgr.mr_n78059504)
print v(xbgr.mr_n78059824)
print v(xbgr.mr_n78059936)
print v(xbgr.mr_n78060256)
print v(xbgr.mr_n78060368)
print v(xbgr.mr_n78060688)
print v(xbgr.mr_n78060800)
print v(xbgr.mr_n78061120)
print v(xbgr.mr_n78061232)
print v(xbgr.mr_n78061552)
print v(xbgr.mr_n78061664)
print v(xbgr.mr_n78061984)
print v(xbgr.mr_n78062096)
print v(xbgr.mr_n78062416)
print v(xbgr.mr_n78062528)
print v(xbgr.mr_n78062848)
print v(xbgr.mr_n78062960)
print v(xbgr.mr_n78063280)
print v(xbgr.mr_n78063392)
print v(xbgr.mr_n78063712)
print v(xbgr.mr_n78063824)
print v(xbgr.mr_n78064144)
print v(xbgr.mr_n78064256)
print v(xbgr.mr_n78064576)
print v(xbgr.mr_n78064688)
print v(xbgr.mr_n78065008)
print v(xbgr.mr_n78065120)
print v(xbgr.mr_n78065440)
print v(xbgr.mr_n78065552)
print v(xbgr.mr_n78065872)
print v(xbgr.mr_n78065984)
print v(xbgr.mr_n78066304)
print v(xbgr.mr_n78066416)
print v(xbgr.mr_n78066736)
print v(xbgr.mr_n78066848)
print v(xbgr.mr_n78067168)
print v(xbgr.mr_n78067280)
print v(xbgr.mr_n78067600)
print v(xbgr.mr_n78067712)
print v(xbgr.mr_n78068032)
print v(xbgr.mr_n78068144)
print v(xbgr.mr_n78068464)
print v(xbgr.mr_n78068576)
print v(xbgr.mr_n78068896)
print v(xbgr.mr_n78069008)
print v(xbgr.mr_n78069328)
print v(xbgr.mr_n78069440)
print v(xbgr.mr_n78069760)
print v(xbgr.mr_n78069872)
print v(xbgr.mr_n78070192)
print v(xbgr.mr_n78070304)
print v(xbgr.mr_n78070624)
print v(xbgr.mr_n78070736)
print v(xbgr.mr_n78071056)
print v(xbgr.mr_n78071168)
print v(xbgr.mr_n78071488)
print v(xbgr.mr_n78071600)
print v(xbgr.mr_n78071920)
print v(xbgr.mr_n78072032)
print v(xbgr.mr_n78072352)
print v(xbgr.mr_n78072464)
print v(xbgr.mr_n78072784)
print v(xbgr.mr_n78072896)
print v(xbgr.mr_n78073216)
print v(xbgr.mr_n78073328)
print v(xbgr.mr_n78073648)
print v(xbgr.mr_n78073760)
print v(xbgr.mr_n78074080)
print v(xbgr.mr_n78074192)
print v(xbgr.mr_n78074512)
print v(xbgr.mr_n78074624)
print v(xbgr.mr_n78074944)
print v(xbgr.mr_n78075056)
print v(xbgr.mr_n78075376)
print v(xbgr.mr_n78075488)
print v(xbgr.mr_n78075808)
print v(xbgr.mr_n78075920)
print v(xbgr.mr_n78076240)
print v(xbgr.mr_n78076352)
print v(xbgr.mr_n78076672)
print v(xbgr.mr_n78076784)
print v(xbgr.mr_n78077104)
print v(xbgr.mr_n78077216)
print v(xbgr.mr_n78077536)
print v(xbgr.mr_n78077648)
print v(xbgr.mr_n78077968)
print v(xbgr.mr_n78078080)
print v(xbgr.mr_n78078400)
print v(xbgr.mr_n78078512)
print v(xbgr.mr_n78078832)
print v(xbgr.mr_n78078944)
print v(xbgr.mr_n78079264)
print v(xbgr.mr_n78079376)
print v(xbgr.mr_n78079696)
print v(xbgr.mr_n78079808)
print v(xbgr.mr_n78080128)
print v(xbgr.mr_n78080240)
print v(xbgr.mr_n78080560)
print v(xbgr.mr_n78080672)
print v(xbgr.mr_n78080992)
print v(xbgr.mr_n78081104)
print v(xbgr.mr_n78081424)
print v(xbgr.mr_n78081536)
print v(xbgr.mr_n78081856)
print v(xbgr.mr_n78081968)
print v(xbgr.mr_n78082288)
print v(xbgr.mr_n78082400)
print v(xbgr.mr_n78082720)
print v(xbgr.mr_n78082832)
print v(xbgr.mr_n78083152)
print v(xbgr.mr_n78083264)
print v(xbgr.mr_n78083584)
print v(xbgr.mr_n78083696)
print v(xbgr.mr_n78084016)
print v(xbgr.mr_n78084128)
print v(xbgr.mr_n78084448)
print v(xbgr.mr_n78084560)
print v(xbgr.mr_n78084880)
print v(xbgr.mr_n78084992)
print v(xbgr.mr_n78085312)
print v(xbgr.mr_n78085424)
print v(xbgr.mr_n78085744)
print v(xbgr.mr_n78085856)
print v(xbgr.mr_n78086176)
print v(xbgr.mr_n78086288)
print v(xbgr.mr_n78086608)
print v(xbgr.mr_n78086720)
print v(xbgr.mr_n78087040)
print v(xbgr.mr_n78087152)
print v(xbgr.mr_n78087472)
print v(xbgr.mr_n78087584)
print v(xbgr.mr_n78087904)
print v(xbgr.mr_n78088016)
print v(xbgr.mr_n78088336)
print v(xbgr.mr_n78088448)
print v(xbgr.mr_n78088768)
print v(xbgr.mr_n78088880)
print v(xbgr.mr_n78089200)
print v(xbgr.mr_n78089312)
print v(xbgr.mr_n78089632)
print v(xbgr.mr_n78089744)
print v(xbgr.mr_n78090064)
print v(xbgr.mr_n78090176)
print v(xbgr.mr_n78090496)
print v(xbgr.mr_n78090608)
print v(xbgr.mr_n78090928)
print v(xbgr.mr_n78091040)
print v(xbgr.mr_n78091360)
print v(xbgr.mr_n78091472)
print v(xbgr.mr_n78091792)
print v(xbgr.mr_n78091904)
print v(xbgr.mr_n78092224)
print v(xbgr.mr_n78092336)
print v(xbgr.mr_n78092656)
print v(xbgr.mr_n78092768)
print v(xbgr.mr_n78093088)
print v(xbgr.mr_n78093200)
print v(xbgr.mr_n78093520)
print v(xbgr.mr_n78093632)
print v(xbgr.mr_n78093952)
print v(xbgr.mr_n78094064)
print v(xbgr.mr_n78094384)
print v(xbgr.mr_n78094496)
print v(xbgr.mr_n78094816)
print v(xbgr.mr_n78094928)
print v(xbgr.mr_n78095248)
print v(xbgr.mr_n78095360)
print v(xbgr.mr_n78095680)
print v(xbgr.mr_n78095792)
print v(xbgr.mr_n78096112)
print v(xbgr.mr_n78096224)
print v(xbgr.mr_n78096544)
print v(xbgr.mr_n78096656)
print v(xbgr.mr_n78096976)
print v(xbgr.mr_n78097088)
print v(xbgr.mr_n78097408)
print v(xbgr.mr_n78097520)
print v(xbgr.mr_n78097840)
print v(xbgr.mr_n78097952)
print v(xbgr.mr_n78098272)
print v(xbgr.mr_n78098384)
print v(xbgr.mr_n78098704)
print v(xbgr.mr_n78098816)
print v(xbgr.mr_n78099136)
print v(xbgr.mr_n78099248)
print v(xbgr.mr_n78099568)
print v(xbgr.mr_n78099680)
print v(xbgr.mr_n78100000)
print v(xbgr.mr_n78100112)
print v(xbgr.mr_n78100432)
print v(xbgr.mr_n78100544)
print v(xbgr.mr_n78100864)
print v(xbgr.mr_n78100976)
print v(xbgr.mr_n78101296)
print v(xbgr.mr_n78101408)
print v(xbgr.mr_n78101728)
print v(xbgr.mr_n78101840)
print v(xbgr.mr_n78102160)
print v(xbgr.mr_n78102272)
print v(xbgr.mr_n78102592)
print v(xbgr.mr_n78102704)
print v(xbgr.mr_n78103024)
print v(xbgr.mr_n78103136)
print v(xbgr.mr_n78103456)
print v(xbgr.mr_n78103568)
print v(xbgr.mr_n78103888)
print v(xbgr.mr_n78104000)
print v(xbgr.mr_n78104320)
print v(xbgr.mr_n78104432)
print v(xbgr.mr_n78104752)
print v(xbgr.mr_n78104864)
print v(xbgr.mr_n78105184)
print v(xbgr.mr_n78105296)
print v(xbgr.mr_n78105616)
print v(xbgr.mr_n78105728)
print v(xbgr.mr_n78106048)
print v(xbgr.mr_n78106160)
print v(xbgr.mr_n78106480)
print v(xbgr.mr_n78106912)
print v(xbgr.mr_n78107024)
print v(xbgr.mr_n78107344)
print v(xbgr.mr_n78107776)
print v(xbgr.mr_n78107888)
print v(xbgr.mr_n78108208)
print v(xbgr.mr_n78108320)
print v(xbgr.mr_n78108640)
print v(xbgr.mr_n78108752)
print v(xbgr.mr_n78109072)
print v(xbgr.mr_n78109184)
print v(xbgr.mr_n78109504)
print v(xbgr.mr_n78109616)
print v(xbgr.mr_n78109936)
print v(xbgr.mr_n78110048)
print v(xbgr.mr_n78110368)
print v(xbgr.mr_n78110480)
print v(xbgr.mr_n78110800)
print v(xbgr.mr_n78110912)
print v(xbgr.mr_n78111232)
print v(xbgr.mr_n78111344)
print v(xbgr.mr_n78111664)
print v(xbgr.mr_n78111776)
print v(xbgr.mr_n78112096)
print v(xbgr.mr_n78112208)
print v(xbgr.mr_n78112528)
print v(xbgr.mr_n78112640)
print v(xbgr.mr_n78112960)
print v(xbgr.mr_n78113072)
print v(xbgr.mr_n78113392)
print v(xbgr.mr_n78113504)
print v(xbgr.mr_n78113824)
print v(xbgr.mr_n78113936)
print v(xbgr.mr_n78114256)
print v(xbgr.mr_n78114368)
print v(xbgr.mr_n78114688)
print v(xbgr.mr_n78114800)
print v(xbgr.mr_n78115120)
print v(xbgr.mr_n78115232)
print v(xbgr.mr_n78115552)
print v(xbgr.mr_n78115664)
print v(xbgr.mr_n78115984)
print v(xbgr.mr_n78116096)
print v(xbgr.mr_n78116416)
print v(xbgr.mr_n78116528)
print v(xbgr.mr_n78116848)
print v(xbgr.mr_n78116960)
print v(xbgr.mr_n78117280)
print v(xbgr.mr_n78117712)
print v(xbgr.mr_n78117824)
print v(xbgr.mr_n78118144)
print v(xbgr.mr_n78118576)
print v(xbgr.mr_n78118688)
print v(xbgr.mr_n78119008)
print v(xbgr.mr_n78119440)
print v(xbgr.mr_n78119552)
print v(xbgr.mr_n78119872)
print v(xbgr.mr_n78120304)
print v(xbgr.mr_n78120416)
print v(xbgr.mr_n78120736)
print v(xbgr.mr_n78121168)
print v(xbgr.mr_n78121280)
print v(xbgr.mr_n78121600)
print v(xbgr.mr_n78121712)
print v(xbgr.mr_n78122032)
print v(xbgr.mr_n78122144)
print v(xbgr.mr_n78122464)
print v(xbgr.mr_n78122576)
print v(xbgr.mr_n78122896)
print v(xbgr.mr_n78123008)
print v(xbgr.mr_n78123328)
print v(xbgr.mr_n78123440)
print v(xbgr.mr_n78123760)
print v(xbgr.mr_n78123872)
print v(xbgr.mr_n78124192)
print v(xbgr.mr_n78124304)
print v(xbgr.mr_n78124624)
print v(xbgr.mr_n78124736)
print v(xbgr.mr_n78125056)
print v(xbgr.mr_n78125168)
print v(xbgr.mr_n78125488)
print v(xbgr.mr_n78125600)
print v(xbgr.mr_n78125920)
print v(xbgr.mr_n78126032)
print v(xbgr.mr_n78126352)
print v(xbgr.mr_n78126464)
print v(xbgr.mr_n78126784)
print v(xbgr.mr_n78126896)
print v(xbgr.mr_n78127216)
print v(xbgr.mr_n78127328)
print v(xbgr.mr_n78127648)
print v(xbgr.mr_n78127760)
print v(xbgr.mr_n78128080)
print v(xbgr.mr_n78128192)
print v(xbgr.mr_n78128512)
print v(xbgr.mr_n78128624)
print v(xbgr.mr_n78128944)
print v(xbgr.mr_n78129056)
print v(xbgr.mr_n78129376)
print v(xbgr.mr_n78129488)
print v(xbgr.mr_n78129808)
print v(xbgr.mr_n78129920)
print v(xbgr.mr_n78130240)
print v(xbgr.mr_n78130352)
print v(xbgr.mr_n78130672)
print v(xbgr.mr_n78130784)
print v(xbgr.mr_n78131104)
print v(xbgr.mr_n78131216)
print v(xbgr.mr_n78131536)
print v(xbgr.mr_n78131648)
print v(xbgr.mr_n78131968)
print v(xbgr.mr_n78132080)
print v(xbgr.mr_n78132400)
print v(xbgr.mr_n78132512)
print v(xbgr.mr_n78132832)
print v(xbgr.mr_n78132944)
print v(xbgr.mr_n78133264)
print v(xbgr.mr_n78133376)
print v(xbgr.mr_n78133696)
print v(xbgr.mr_n78133808)
print v(xbgr.mr_n78134128)
print v(xbgr.mr_n78134240)
print v(xbgr.mr_n78134560)
print v(xbgr.mr_n78134672)
print v(xbgr.mr_n78134992)
print v(xbgr.mr_n78135104)
print v(xbgr.mr_n78135424)
print v(xbgr.mr_n78135536)
print v(xbgr.mr_n78135856)
print v(xbgr.mr_n78135968)
print v(xbgr.mr_n78136288)
print v(xbgr.mr_n78136400)
print v(xbgr.mr_n78136720)
print v(xbgr.mr_n78136832)
print v(xbgr.mr_n78137152)
print v(xbgr.mr_n78137264)
print v(xbgr.mr_n78137584)
print v(xbgr.mr_n78137696)
print v(xbgr.mr_n78138016)
print v(xbgr.mr_n78138128)
print v(xbgr.mr_n78138448)
print v(xbgr.mr_n78138560)
print v(xbgr.mr_n78138880)
print v(xbgr.mr_n78138992)
print v(xbgr.mr_n78139312)
print v(xbgr.mr_n78139424)
print v(xbgr.mr_n78139744)
print v(xbgr.mr_n78139856)
print v(xbgr.mr_n78140176)
print v(xbgr.mr_n78140288)
print v(xbgr.mr_n78140608)
print v(xbgr.mr_n78140720)
print v(xbgr.mr_n78141040)
print v(xbgr.mr_n78141472)
print v(xbgr.mr_n78141584)
print v(xbgr.mr_n78141904)
print v(xbgr.mr_n78142336)
print v(xbgr.mr_n78142448)
print v(xbgr.mr_n78142768)
print v(xbgr.mr_n78143200)
print v(xbgr.mr_n78143312)
print v(xbgr.mr_n78143632)
print v(xbgr.mr_n78143744)
print v(xbgr.mr_n78144064)
print v(xbgr.mr_n78144176)
print v(xbgr.mr_n78144496)
print v(xbgr.mr_n78144608)
print v(xbgr.mr_n78144928)
print v(xbgr.mr_n78145040)
print v(xbgr.mr_n78145360)
print v(xbgr.mr_n78145472)
print v(xbgr.mr_n78145792)
print v(xbgr.mr_n78145904)
print v(xbgr.mr_n78146224)
print v(xbgr.mr_n78146336)
print v(xbgr.mr_n78146656)
print v(xbgr.mr_n78146768)
print v(xbgr.mr_n78147088)
print v(xbgr.mr_n78147200)
print v(xbgr.mr_n78147520)
print v(xbgr.mr_n78147632)
print v(xbgr.mr_n78147952)
print v(xbgr.mr_n78148064)
print v(xbgr.mr_n78148384)
print v(xbgr.mr_n78148496)
print v(xbgr.mr_n78148816)
print v(xbgr.mr_n78148928)
print v(xbgr.mr_n78149248)
print v(xbgr.mr_n78149360)
print v(xbgr.mr_n78149680)
print v(xbgr.mr_n78149792)
print v(xbgr.mr_n78150112)
print v(xbgr.mr_n78150224)
print v(xbgr.mr_n78150544)
print v(xbgr.mr_n78150656)
print v(xbgr.mr_n78150976)
print v(xbgr.mr_n78151088)
print v(xbgr.mr_n78151408)
print v(xbgr.mr_n78151520)
print v(xbgr.mr_n78151840)
print v(xbgr.mr_n78151952)
print v(xbgr.mr_n78152272)
print v(xbgr.mr_n78152384)
print v(xbgr.mr_n78152704)
print v(xbgr.mr_n78152816)
print v(xbgr.mr_n78153136)
print v(xbgr.mr_n78153248)
print v(xbgr.mr_n78153568)
print v(xbgr.mr_n78153680)
print v(xbgr.mr_n78154000)
print v(xbgr.mr_n78154112)
print v(xbgr.mr_n78154432)
print v(xbgr.mr_n78154544)
print v(xbgr.mr_n78154864)
print v(xbgr.mr_n78154976)
print v(xbgr.mr_n78155296)
print v(xbgr.mr_n78155408)
print v(xbgr.mr_n78155728)
print v(xbgr.mr_n78155840)
print v(xbgr.mr_n78156160)
print v(xbgr.mr_n78156272)
print v(xbgr.mr_n78156592)
print v(xbgr.mr_n78156704)
print v(xbgr.mr_n78157024)
print v(xbgr.mr_n78157136)
print v(xbgr.mr_n78157456)
print v(xbgr.mr_n78157568)
print v(xbgr.mr_n78157888)
print v(xbgr.mr_n78158000)
print v(xbgr.mr_n78158320)
print v(xbgr.mr_n78158432)
print v(xbgr.mr_n78158752)
print v(xbgr.mr_n78158864)
print v(xbgr.mr_n78159184)
print v(xbgr.mr_n78159296)
print v(xbgr.mr_n78159616)
print v(xbgr.mr_n78159728)
print v(xbgr.mr_n78160048)
print v(xbgr.mr_n78160160)
print v(xbgr.mr_n78160480)
print v(xbgr.mr_n78160592)
print v(xbgr.mr_n78160912)
print v(xbgr.mr_n78161024)
print v(xbgr.mr_n78161344)
print v(xbgr.mr_n78161456)
print v(xbgr.mr_n78161776)
print v(xbgr.mr_n78161888)
print v(xbgr.mr_n78162208)
print v(xbgr.mr_n78162320)
print v(xbgr.mr_n78162640)
print v(xbgr.mr_n78162752)
print v(xbgr.mr_n78163072)
print v(xbgr.mr_n78163184)
print v(xbgr.mr_n78163504)
print v(xbgr.mr_n78163616)
print v(xbgr.mr_n78163936)
print v(xbgr.mr_n78164048)
print v(xbgr.mr_n78164368)
print v(xbgr.mr_n78164480)
print v(xbgr.mr_n78164800)
print v(xbgr.mr_n78164912)
print v(xbgr.mr_n78165232)
print v(xbgr.mr_n78165344)
print v(xbgr.mr_n78165664)
print v(xbgr.mr_n78165776)
print v(xbgr.mr_n78166096)
print v(xbgr.mr_n78166208)
print v(xbgr.mr_n78166528)
print v(xbgr.mr_n78166640)
print v(xbgr.mr_n78166960)
print v(xbgr.mr_n78167072)
print v(xbgr.mr_n78167392)
print v(xbgr.mr_n78167504)
print v(xbgr.mr_n78167824)
print v(xbgr.mr_n78167936)
print v(xbgr.mr_n78168256)
print v(xbgr.mr_n78168368)
print v(xbgr.mr_n78168688)
print v(xbgr.mr_n78168800)
print v(xbgr.mr_n78169120)
print v(xbgr.mr_n78169232)
print v(xbgr.mr_n78169552)
print v(xbgr.mr_n78169664)
print v(xbgr.mr_n78169984)
print v(xbgr.mr_n78170096)
print v(xbgr.mr_n78170416)
print v(xbgr.mr_n78170528)
print v(xbgr.mr_n78170848)
print v(xbgr.mr_n78170960)
print v(xbgr.mr_n78171280)
print v(xbgr.mr_n78171392)
print v(xbgr.mr_n78171712)
print v(xbgr.mr_n78171824)
print v(xbgr.mr_n78172144)
print v(xbgr.mr_n78172256)
print v(xbgr.mr_n78172576)
print v(xbgr.mr_n78172688)
print v(xbgr.mr_n78173008)
print v(xbgr.mr_n78173120)
print v(xbgr.mr_n78173440)
print v(xbgr.mr_n78173552)
print v(xbgr.mr_n78173872)
print v(xbgr.mr_n78173984)
print v(xbgr.mr_n78174304)
print v(xbgr.mr_n78174416)
print v(xbgr.mr_n78174736)
print v(xbgr.mr_n78174848)
print v(xbgr.mr_n78175168)
print v(xbgr.mr_n78175280)
print v(xbgr.mr_n78175600)
print v(xbgr.mr_n78175712)
print v(xbgr.mr_n78176032)
print v(xbgr.mr_n78176144)
print v(xbgr.mr_n78176464)
print v(xbgr.mr_n78176576)
print v(xbgr.mr_n78176896)
print v(xbgr.mr_n78177008)
print v(xbgr.mr_n78177328)
print v(xbgr.mr_n78177440)
print v(xbgr.mr_n78177760)
print v(xbgr.mr_n78177872)
print v(xbgr.mr_n78178192)
print v(xbgr.mr_n78178304)
print v(xbgr.mr_n78178624)
print v(xbgr.mr_n78178736)
print v(xbgr.mr_n78179056)
print v(xbgr.mr_n78179168)
print v(xbgr.mr_n78179488)
print v(xbgr.mr_n78179600)
print v(xbgr.mr_n78179920)
print v(xbgr.mr_n78180032)
print v(xbgr.mr_n78180352)
print v(xbgr.mr_n78180464)
print v(xbgr.mr_n78180784)
print v(xbgr.mr_n78180896)
print v(xbgr.mr_n78181216)
print v(xbgr.mr_n78181328)
print v(xbgr.mr_n78181648)
print v(xbgr.mr_n78181760)
print v(xbgr.mr_n78182080)
print v(xbgr.mr_n78182192)
print v(xbgr.mr_n78182512)
print v(xbgr.mr_n78182624)
print v(xbgr.mr_n78182944)
print v(xbgr.mr_n78183056)
print v(xbgr.mr_n78183376)
print v(xbgr.mr_n78183488)
print v(xbgr.mr_n78183808)
print v(xbgr.mr_n78183920)
print v(xbgr.mr_n78184240)
print v(xbgr.mr_n78184352)
print v(xbgr.mr_n78184672)
print v(xbgr.mr_n78184784)
print v(xbgr.mr_n78185104)
print v(xbgr.mr_n78185216)
print v(xbgr.mr_n78185536)
print v(xbgr.mr_n78185648)
print v(xbgr.mr_n78185968)
print v(xbgr.mr_n78186080)
print v(xbgr.mr_n78186400)
print v(xbgr.mr_n78186512)
print v(xbgr.mr_n78186832)
print v(xbgr.mr_n78186944)
print v(xbgr.mr_n78187264)
print v(xbgr.mr_n78187376)
print v(xbgr.mr_n78187696)
print v(xbgr.mr_n78187808)
print v(xbgr.mr_n78188128)
print v(xbgr.mr_n78188240)
print v(xbgr.mr_n78188560)
print v(xbgr.mr_n78188672)
print v(xbgr.mr_n78188992)
print v(xbgr.mr_n78189104)
print v(xbgr.mr_n78189424)
print v(xbgr.mr_n78189536)
print v(xbgr.mr_n78189856)
print v(xbgr.mr_n78189968)
print v(xbgr.mr_n78190288)
print v(xbgr.mr_n78190400)
print v(xbgr.mr_n78190720)
print v(xbgr.mr_n78190832)
print v(xbgr.mr_n78191152)
print v(xbgr.mr_n78191264)
print v(xbgr.mr_n78191584)
print v(xbgr.mr_n78191696)
print v(xbgr.mr_n78192016)
print v(xbgr.mr_n78192128)
print v(xbgr.mr_n78192448)
print v(xbgr.mr_n78192560)
print v(xbgr.mr_n78192880)
print v(xbgr.mr_n78192992)
print v(xbgr.mr_n78193312)
print v(xbgr.mr_n78193424)
print v(xbgr.mr_n78193744)
print v(xbgr.mr_n78193856)
print v(xbgr.mr_n78194176)
print v(xbgr.mr_n78194288)
print v(xbgr.mr_n78194608)
print v(xbgr.mr_n78194720)
print v(xbgr.mr_n78195040)
print v(xbgr.mr_n78195152)
print v(xbgr.mr_n78195472)
print v(xbgr.mr_n78195584)
print v(xbgr.mr_n78195904)
print v(xbgr.mr_n78196016)
print v(xbgr.mr_n78196336)
print v(xbgr.mr_n78196448)
print v(xbgr.mr_n78196768)
print v(xbgr.mr_n78196880)
print v(xbgr.mr_n78197200)
print v(xbgr.mr_n78197312)
print v(xbgr.mr_n78197632)
print v(xbgr.mr_n78197744)
print v(xbgr.mr_n78198064)
print v(xbgr.mr_n78198176)
print v(xbgr.mr_n78198496)
print v(xbgr.mr_n78198608)
print v(xbgr.mr_n78198928)
print v(xbgr.mr_n78199040)
print v(xbgr.mr_n78199360)
print v(xbgr.mr_n78199472)
print v(xbgr.mr_n78199792)
print v(xbgr.mr_n78199904)
print v(xbgr.mr_n78200224)
print v(xbgr.mr_n78200336)
print v(xbgr.mr_n78200656)
print v(xbgr.mr_n78200768)
print v(xbgr.mr_n78201088)
print v(xbgr.mr_n78201200)
print v(xbgr.mr_n78201520)
print v(xbgr.mr_n78201632)
print v(xbgr.mr_n78201952)
print v(xbgr.mr_n78202064)
print v(xbgr.mr_n78202384)
print v(xbgr.mr_n78202496)
print v(xbgr.mr_n78202816)
print v(xbgr.mr_n78202928)
print v(xbgr.mr_n78203248)
print v(xbgr.mr_n78203360)
print v(xbgr.mr_n78203680)
print v(xbgr.mr_n78203792)
print v(xbgr.mr_n78204112)
print v(xbgr.mr_n78204224)
print v(xbgr.mr_n78204544)
print v(xbgr.mr_n78204656)
print v(xbgr.mr_n78204976)
print v(xbgr.mr_n78205088)
print v(xbgr.mr_n78205408)
print v(xbgr.mr_n78205520)
print v(xbgr.mr_n78205840)
print v(xbgr.mr_n78205952)
print v(xbgr.mr_n78206272)
print v(xbgr.mr_n78206384)
print v(xbgr.mr_n78206704)
print v(xbgr.mr_n78206816)
print v(xbgr.mr_n78207136)
print v(xbgr.mr_n78207248)
print v(xbgr.mr_n78207568)
print v(xbgr.mr_n78207680)
print v(xbgr.mr_n78208000)
print v(xbgr.mr_n78208112)
print v(xbgr.mr_n78208432)
print v(xbgr.mr_n78208544)
print v(xbgr.mr_n78208864)
print v(xbgr.mr_n78208976)
print v(xbgr.mr_n78209296)
print v(xbgr.mr_n78209408)
print v(xbgr.mr_n78209728)
print v(xbgr.mr_n78209840)
print v(xbgr.mr_n78210160)
print v(xbgr.mr_n78210272)
print v(xbgr.mr_n78210592)
print v(xbgr.mr_n78210704)
print v(xbgr.mr_n78211024)
print v(xbgr.mr_n78211136)
print v(xbgr.mr_n78211456)
print v(xbgr.mr_n78211568)
print v(xbgr.mr_n78211888)
print v(xbgr.mr_n78212000)
print v(xbgr.mr_n78212320)
print v(xbgr.mr_n78212432)
print v(xbgr.mr_n78212752)
print v(xbgr.mr_n78212864)
print v(xbgr.mr_n78213184)
print v(xbgr.mr_n78213296)
print v(xbgr.mr_n78213616)
print v(xbgr.mr_n78213728)
print v(xbgr.mr_n78214048)
print v(xbgr.mr_n78214160)
print v(xbgr.mr_n78214480)
print v(xbgr.mr_n78214592)
print v(xbgr.mr_n78214912)
print v(xbgr.mr_n78215024)
print v(xbgr.mr_n78215344)
print v(xbgr.mr_n78215456)
print v(xbgr.mr_n78215776)
print v(xbgr.mr_n78215888)
print v(xbgr.mr_n78216208)
print v(xbgr.mr_n78216320)
print v(xbgr.mr_n78216640)
print v(xbgr.mr_n78216752)
print v(xbgr.mr_n78217072)
print v(xbgr.mr_n78217184)
print v(xbgr.mr_n78217504)
print v(xbgr.mr_n78217616)
print v(xbgr.mr_n78217936)
print v(xbgr.mr_n78218048)
print v(xbgr.mr_n78218368)
print v(xbgr.mr_n78218480)
print v(xbgr.mr_n78218800)
print v(xbgr.mr_n78218912)
print v(xbgr.mr_n78219232)
print v(xbgr.mr_n78219344)
print v(xbgr.mr_n78219664)
print v(xbgr.mr_n78219776)
print v(xbgr.mr_n78220096)
print v(xbgr.mr_n78220208)
print v(xbgr.mr_n78220528)
print v(xbgr.mr_n78220640)
print v(xbgr.mr_n78220960)
print v(xbgr.mr_n78221072)
print v(xbgr.mr_n78221392)
print v(xbgr.mr_n78221504)
print v(xbgr.mr_n78221824)
print v(xbgr.mr_n78221936)
print v(xbgr.mr_n78222256)
print v(xbgr.mr_n78222368)
print v(xbgr.mr_n78222688)
print v(xbgr.mr_n78222800)
print v(xbgr.mr_n78223120)
print v(xbgr.mr_n78223232)
print v(xbgr.mr_n78223552)
print v(xbgr.mr_n78223664)
print v(xbgr.mr_n78223984)
print v(xbgr.mr_n78224096)
print v(xbgr.mr_n78224416)
print v(xbgr.mr_n78224528)
print v(xbgr.mr_n78224848)
print v(xbgr.mr_n78224960)
print v(xbgr.mr_n78225280)
print v(xbgr.mr_n78225392)
print v(xbgr.mr_n78225712)
print v(xbgr.mr_n78225824)
print v(xbgr.mr_n78226144)
print v(xbgr.mr_n78226256)
print v(xbgr.mr_n78226576)
print v(xbgr.mr_n78226688)
print v(xbgr.mr_n78227008)
print v(xbgr.mr_n78227120)
print v(xbgr.mr_n78227440)
print v(xbgr.mr_n78227552)
print v(xbgr.mr_n78227872)
print v(xbgr.mr_n78227984)
print v(xbgr.mr_n78228304)
print v(xbgr.mr_n78228416)
print v(xbgr.mr_n78228736)
print v(xbgr.mr_n78228848)
print v(xbgr.mr_n78229168)
print v(xbgr.mr_n78229280)
print v(xbgr.mr_n78229600)
print v(xbgr.mr_n78229712)
print v(xbgr.mr_n78230032)
print v(xbgr.mr_n78230144)
print v(xbgr.mr_n78230464)
print v(xbgr.mr_n78230576)
print v(xbgr.mr_n78230896)
print v(xbgr.mr_n78231008)
print v(xbgr.mr_n78231328)
print v(xbgr.mr_n78231440)
print v(xbgr.mr_n78231760)
print v(xbgr.mr_n78231872)
print v(xbgr.mr_n78232192)
print v(xbgr.mr_n78232304)
print v(xbgr.mr_n78232624)
print v(xbgr.mr_n78232736)
print v(xbgr.mr_n78233056)
print v(xbgr.mr_n78233168)
print v(xbgr.mr_n78233488)
print v(xbgr.mr_n78233600)
print v(xbgr.mr_n78233920)
print v(xbgr.mr_n78234032)
print v(xbgr.mr_n78234352)
print v(xbgr.mr_n78234464)
print v(xbgr.mr_n78234784)
print v(xbgr.mr_n78234896)
print v(xbgr.mr_n78235216)
print v(xbgr.mr_n78235328)
print v(xbgr.mr_n78235648)
print v(xbgr.mr_n78235760)
print v(xbgr.mr_n78236080)
print v(xbgr.mr_n78236192)
print v(xbgr.mr_n78236512)
print v(xbgr.mr_n78236624)
print v(xbgr.mr_n78236944)
print v(xbgr.mr_n78237056)
print v(xbgr.mr_n78237376)
print v(xbgr.mr_n78237488)
print v(xbgr.mr_n78237808)
print v(xbgr.mr_n78237920)
print v(xbgr.mr_n78238240)
print v(xbgr.mr_n78238352)
print v(xbgr.mr_n78238672)
print v(xbgr.mr_n78238784)
print v(xbgr.mr_n78239104)
print v(xbgr.mr_n78239216)
print v(xbgr.mr_n78239536)
print v(xbgr.mr_n78239648)
print v(xbgr.mr_n78239968)
print v(xbgr.mr_n78240080)
print v(xbgr.mr_n78240400)
print v(xbgr.mr_n78240512)
print v(xbgr.mr_n78240832)
print v(xbgr.mr_n78240944)
print v(xbgr.mr_n78241264)
print v(xbgr.mr_n78241376)
print v(xbgr.mr_n78241696)
print v(xbgr.mr_n78241808)
print v(xbgr.mr_n78242128)
print v(xbgr.mr_n78242240)
print v(xbgr.mr_n78242560)
print v(xbgr.mr_n78242672)
print v(xbgr.mr_n78242992)
print v(xbgr.mr_n78243104)
print v(xbgr.mr_n78243424)
print v(xbgr.mr_n78243536)
print v(xbgr.mr_n78243856)
print v(xbgr.mr_n78243968)
print v(xbgr.mr_n78244288)
print v(xbgr.mr_n78244400)
print v(xbgr.mr_n78244720)
print v(xbgr.mr_n78244832)
print v(xbgr.mr_n78245152)
print v(xbgr.mr_n78245264)
print v(xbgr.mr_n78245584)
print v(xbgr.mr_n78245696)
print v(xbgr.mr_n78246016)
print v(xbgr.mr_n78246128)
print v(xbgr.mr_n78246448)
print v(xbgr.mr_n78246560)
print v(xbgr.mr_n78246880)
print v(xbgr.mr_n78246992)
print v(xbgr.mr_n78247312)
print v(xbgr.mr_n78247424)
print v(xbgr.mr_n78247744)
print v(xbgr.mr_n78247856)
print v(xbgr.mr_n78248176)
print v(xbgr.mr_n78248288)
print v(xbgr.mr_n78248608)
print v(xbgr.mr_n78248720)
print v(xbgr.mr_n78249040)
print v(xbgr.mr_n78249152)
print v(xbgr.mr_n78249472)
print v(xbgr.mr_n78249584)
print v(xbgr.mr_n78249904)
print v(xbgr.mr_n78250016)
print v(xbgr.mr_n78250336)
print v(xbgr.mr_n78250448)
print v(xbgr.mr_n78250768)
print v(xbgr.mr_n78250880)
print v(xbgr.mr_n78251200)
print v(xbgr.mr_n78251312)
print v(xbgr.mr_n78251632)
print v(xbgr.mr_n78251744)
print v(xbgr.mr_n78252064)
print v(xbgr.mr_n78252176)
print v(xbgr.mr_n78252496)
print v(xbgr.mr_n78252608)
print v(xbgr.mr_n78252928)
print v(xbgr.mr_n78253040)
print v(xbgr.mr_n78253360)
print v(xbgr.mr_n78253472)
print v(xbgr.mr_n78253792)
print v(xbgr.mr_n78253904)
print v(xbgr.mr_n78254224)
print v(xbgr.mr_n78254336)
print v(xbgr.mr_n78254656)
print v(xbgr.mr_n78254768)
print v(xbgr.mr_n78255088)
print v(xbgr.mr_n78255200)
print v(xbgr.mr_n78255520)
print v(xbgr.mr_n78255632)
print v(xbgr.mr_n78255952)
print v(xbgr.mr_n78256064)
print v(xbgr.mr_n78256384)
print v(xbgr.mr_n78256496)
print v(xbgr.mr_n78256816)
print v(xbgr.mr_n78256928)
print v(xbgr.mr_n78257248)
print v(xbgr.mr_n78257360)
print v(xbgr.mr_n78257680)
print v(xbgr.mr_n78257792)
print v(xbgr.mr_n78258112)
print v(xbgr.mr_n78258224)
print v(xbgr.mr_n78258544)
print v(xbgr.mr_n78258656)
print v(xbgr.mr_n78258976)
print v(xbgr.mr_n78259088)
print v(xbgr.mr_n78259408)
print v(xbgr.mr_n78259520)
print v(xbgr.mr_n78259840)
print v(xbgr.mr_n78259952)
print v(xbgr.mr_n78260272)
print v(xbgr.mr_n78260384)
print v(xbgr.mr_n78260704)
print v(xbgr.mr_n78260816)
print v(xbgr.mr_n78261136)
print v(xbgr.mr_n78261248)
print v(xbgr.mr_n78261568)
print v(xbgr.mr_n78261680)
print v(xbgr.mr_n78262000)
print v(xbgr.mr_n78262112)
print v(xbgr.mr_n78262432)
print v(xbgr.mr_n78262544)
print v(xbgr.mr_n78262864)
print v(xbgr.mr_n78262976)
print v(xbgr.mr_n78263296)
print v(xbgr.mr_n78263408)
print v(xbgr.mr_n78263728)
print v(xbgr.mr_n78263840)
print v(xbgr.mr_n78264160)
print v(xbgr.mr_n78264272)
print v(xbgr.mr_n78264592)
print v(xbgr.mr_n78264704)
print v(xbgr.mr_n78265024)
print v(xbgr.mr_n78265136)
print v(xbgr.mr_n78265456)
print v(xbgr.mr_n78265568)
print v(xbgr.mr_n78265888)
print v(xbgr.mr_n78266000)
print v(xbgr.mr_n78266320)
print v(xbgr.mr_n78266432)
print v(xbgr.mr_n78266752)
print v(xbgr.mr_n78266864)
print v(xbgr.mr_n78267184)
print v(xbgr.mr_n78267296)
print v(xbgr.mr_n78267616)
print v(xbgr.mr_n78267728)
print v(xbgr.mr_n78268048)
print v(xbgr.mr_n78268160)
print v(xbgr.mr_n78268480)
print v(xbgr.mr_n78268592)
print v(xbgr.mr_n78268912)
print v(xbgr.mr_n78269024)
print v(xbgr.mr_n78269344)
print v(xbgr.mr_n78269456)
print v(xbgr.mr_n78269776)
print v(xbgr.mr_n78269888)
print v(xbgr.mr_n78270208)
print v(xbgr.mr_n78270320)
print v(xbgr.mr_n78270640)
print v(xbgr.mr_n78270752)
print v(xbgr.mr_n78271072)
print v(xbgr.mr_n78271184)
print v(xbgr.mr_n78271504)
print v(xbgr.mr_n78271616)
print v(xbgr.mr_n78271936)
print v(xbgr.mr_n78272048)
print v(xbgr.mr_n78272368)
print v(xbgr.mr_n78272480)
print v(xbgr.mr_n78272800)
print v(xbgr.mr_n78272912)
print v(xbgr.mr_n78273232)
print v(xbgr.mr_n78273344)
print v(xbgr.mr_n78273664)
print v(xbgr.mr_n78273776)
print v(xbgr.mr_n78274096)
print v(xbgr.mr_n78274208)
print v(xbgr.mr_n78274528)
print v(xbgr.mr_n78274640)
print v(xbgr.mr_n78274960)
print v(xbgr.mr_n78275072)
print v(xbgr.mr_n78275392)
print v(xbgr.mr_n78275504)
print v(xbgr.mr_n78275824)
print v(xbgr.mr_n78275936)
print v(xbgr.mr_n78276256)
print v(xbgr.mr_n78276368)
print v(xbgr.mr_n78276688)
print v(xbgr.mr_n78276800)
print v(xbgr.mr_n78277120)
print v(xbgr.mr_n78277232)
print v(xbgr.mr_n78277552)
print v(xbgr.mr_n78277664)
print v(xbgr.mr_n78277984)
print v(xbgr.mr_n78278096)
print v(xbgr.mr_n78278416)
print v(xbgr.mr_n78278528)
print v(xbgr.mr_n78278848)
print v(xbgr.mr_n78278960)
print v(xbgr.mr_n78279280)
print v(xbgr.mr_n78279392)
print v(xbgr.mr_n78279712)
print v(xbgr.mr_n78279824)
print v(xbgr.mr_n78280144)
print v(xbgr.mr_n78280256)
print v(xbgr.mr_n78280576)
print v(xbgr.mr_n78280688)
print v(xbgr.mr_n78281008)
print v(xbgr.mr_n78281120)
print v(xbgr.mr_n78281440)
print v(xbgr.mr_n78281552)
print v(xbgr.mr_n78281872)
print v(xbgr.mr_n78281984)
print v(xbgr.mr_n78282304)
print v(xbgr.mr_n78282416)
print v(xbgr.mr_n78282736)
print v(xbgr.mr_n78282848)
print v(xbgr.mr_n78283168)
print v(xbgr.mr_n78283280)
print v(xbgr.mr_n78283600)
print v(xbgr.mr_n78283712)
print v(xbgr.mr_n78284032)
print v(xbgr.mr_n78284144)
print v(xbgr.mr_n78284464)
print v(xbgr.mr_n78284576)
print v(xbgr.mr_n78284896)
print v(xbgr.mr_n78285008)
print v(xbgr.mr_n78285328)
print v(xbgr.mr_n78285440)
print v(xbgr.mr_n78285760)
print v(xbgr.mr_n78285872)
print v(xbgr.mr_n78286192)
print v(xbgr.mr_n78286304)
print v(xbgr.mr_n78286624)
print v(xbgr.mr_n78286736)
print v(xbgr.mr_n78287056)
print v(xbgr.mr_n78287168)
print v(xbgr.mr_n78287488)
print v(xbgr.mr_n78287600)
print v(xbgr.mr_n78287920)
print v(xbgr.mr_n78288032)
print v(xbgr.mr_n78288352)
print v(xbgr.mr_n78288464)
print v(xbgr.mr_n78288784)
print v(xbgr.mr_n78288896)
print v(xbgr.mr_n78289216)
print v(xbgr.mr_n78289328)
print v(xbgr.mr_n78289648)
print v(xbgr.mr_n78289760)
print v(xbgr.mr_n78290080)
print v(xbgr.mr_n78290192)
print v(xbgr.mr_n78290512)
print v(xbgr.mr_n78290624)
print v(xbgr.mr_n78290944)
print v(xbgr.mr_n78291056)
print v(xbgr.mr_n78291376)
print v(xbgr.mr_n78291488)
print v(xbgr.mr_n78291808)
print v(xbgr.mr_n78291920)
print v(xbgr.mr_n78292240)
print v(xbgr.mr_n78292352)
print v(xbgr.mr_n78292672)
print v(xbgr.mr_n78292784)
print v(xbgr.mr_n78293104)
print v(xbgr.mr_n78293216)
print v(xbgr.mr_n78293536)
print v(xbgr.mr_n78293648)
print v(xbgr.mr_n78293968)
print v(xbgr.mr_n78294080)
print v(xbgr.mr_n78294400)
print v(xbgr.mr_n78294512)
print v(xbgr.mr_n78294832)
print v(xbgr.mr_n78294944)
print v(xbgr.mr_n78295264)
print v(xbgr.mr_n78295376)
print v(xbgr.mr_n78295696)
print v(xbgr.mr_n78295808)
print v(xbgr.mr_n78296128)
print v(xbgr.mr_n78296240)
print v(xbgr.mr_n78296560)
print v(xbgr.mr_n78296672)
print v(xbgr.mr_n78296992)
print v(xbgr.mr_n78297104)
print v(xbgr.mr_n78297424)
print v(xbgr.mr_n78297536)
print v(xbgr.mr_n78297856)
print v(xbgr.mr_n78297968)
print v(xbgr.mr_n78298288)
print v(xbgr.mr_n78298400)
print v(xbgr.mr_n78298720)
print v(xbgr.mr_n78298832)
print v(xbgr.mr_n78299152)
print v(xbgr.mr_n78299264)
print v(xbgr.mr_n78299584)
print v(xbgr.mr_n78299696)
print v(xbgr.mr_n78300016)
print v(xbgr.mr_n78300128)
print v(xbgr.mr_n78300448)
print v(xbgr.mr_n78300560)
print v(xbgr.mr_n78300880)
print v(xbgr.mr_n78300992)
print v(xbgr.mr_n78301312)
print v(xbgr.mr_n78301424)
print v(xbgr.mr_n78301744)
print v(xbgr.mr_n78301856)
print v(xbgr.mr_n78302176)
print v(xbgr.mr_n78302288)
print v(xbgr.mr_n78302608)
print v(xbgr.mr_n78302720)
print v(xbgr.mr_n78303040)
print v(xbgr.mr_n78303152)
print v(xbgr.mr_n78303472)
print v(xbgr.mr_n78303584)
print v(xbgr.mr_n78303904)
print v(xbgr.mr_n78304016)
print v(xbgr.mr_n78304336)
print v(xbgr.mr_n78304448)
print v(xbgr.mr_n78304768)
print v(xbgr.mr_n78304880)
print v(xbgr.mr_n78305200)
print v(xbgr.mr_n78305312)
print v(xbgr.mr_n78305632)
print v(xbgr.mr_n78305744)
print v(xbgr.mr_n78306064)
print v(xbgr.mr_n78306176)
print v(xbgr.mr_n78306496)
print v(xbgr.mr_n78306608)
print v(xbgr.mr_n78306928)
print v(xbgr.mr_n78307040)
print v(xbgr.mr_n78307360)
print v(xbgr.mr_n78307472)
print v(xbgr.mr_n78307792)
print v(xbgr.mr_n78307904)
print v(xbgr.mr_n78308224)
print v(xbgr.mr_n78308336)
print v(xbgr.mr_n78308768)
print v(xbgr.mr_n78309088)
print v(xbgr.mr_n78309200)
print v(xbgr.mr_n78309632)
print v(xbgr.mr_n78309952)
print v(xbgr.mr_n78310064)
print v(xbgr.mr_n78310496)
print v(xbgr.mr_n78310816)
print v(xbgr.mr_n78311680)
print v(xbgr.mr_n78312544)
print v(xbgr.mr_n78312656)
print v(xbgr.mr_n78312976)
print v(xbgr.mr_n78313088)
print v(xbgr.mr_n78313408)
print v(xbgr.mr_n78313520)
print v(xbgr.mr_n78313840)
print v(xbgr.mr_n78313952)
print v(xbgr.mr_n78314272)
print v(xbgr.mr_n78314384)
print v(xbgr.mr_n78314704)
print v(xbgr.mr_n78314816)
print v(xbgr.mr_n78315136)
print v(xbgr.mr_n78316000)
print v(xbgr.mr_n78316864)
print v(xbgr.mr_n78317728)
print v(xbgr.mr_n78317840)
print v(xbgr.mr_n78318160)
print v(xbgr.mr_n78318272)
print v(xbgr.mr_n78318592)
print v(xbgr.mr_n78318704)
print v(xbgr.mr_n78319024)
print v(xbgr.mr_n78319136)
print v(xbgr.mr_n78319456)
print v(xbgr.mr_n78320320)
print v(xbgr.mr_n78321184)
print v(xbgr.mr_n78321296)
print v(xbgr.mr_n78321616)
print v(xbgr.mr_n78321728)
print v(xbgr.mr_n78322048)
print v(xbgr.mr_n78322160)
print v(xbgr.mr_n78322480)
print v(xbgr.mr_n78322592)
print v(xbgr.mr_n78322912)
print v(xbgr.mr_n78323024)
print v(xbgr.mr_n78323344)
print v(xbgr.mr_n78323456)
print v(xbgr.mr_n78323776)
print v(xbgr.mr_n78324640)
print v(xbgr.mr_n78324752)
print v(xbgr.mr_n78325184)
print v(xbgr.mr_n78325504)
print v(xbgr.mr_n78325616)
print v(xbgr.mr_n78326048)
print v(xbgr.mr_n78326368)
print v(xbgr.mr_n78326480)
print v(xbgr.mr_n78326912)
print v(xbgr.mr_n78327232)
print v(xbgr.mr_n78328096)
print v(xbgr.mr_n78328960)
print v(xbgr.mr_n78329824)
print v(xbgr.mr_n78330688)
print v(xbgr.mr_n78331552)
print v(xbgr.mr_n78332416)
print v(xbgr.mr_n78332528)
print v(xbgr.mr_n78332848)
print v(xbgr.mr_n78332960)
print v(xbgr.mr_n78333280)
print v(xbgr.mr_n78333392)
print v(xbgr.mr_n78333712)
print v(xbgr.mr_n78333824)
print v(xbgr.mr_n78334144)
print v(xbgr.mr_n78335008)
print v(xbgr.mr_n78335872)
print v(xbgr.mr_n78336736)
print v(xbgr.mr_n78337600)
print v(xbgr.mr_n78337712)
print v(xbgr.mr_n78338144)
print v(xbgr.mr_n78338464)
print v(xbgr.mr_n78338576)
print v(xbgr.mr_n78339008)
print v(xbgr.mr_n78339328)
print v(xbgr.mr_n78339440)
print v(xbgr.mr_n78339872)
print v(xbgr.mr_n78340192)
print v(xbgr.mr_n78341056)
print v(xbgr.mr_n78341920)
print v(xbgr.mr_n78342784)
print v(xbgr.mr_n78343648)
print v(xbgr.mr_n78344512)
print v(xbgr.mr_n78345376)
print v(xbgr.mr_n78345488)
print v(xbgr.mr_n78345808)
print v(xbgr.mr_n78345920)
print v(xbgr.mr_n78346240)
print v(xbgr.mr_n78346352)
print v(xbgr.mr_n78346672)
print v(xbgr.mr_n78346784)
print v(xbgr.mr_n78347104)
print v(xbgr.mr_n78347968)
print v(xbgr.mr_n78348832)
print v(xbgr.mr_n78349696)
print v(xbgr.mr_n78349808)
print v(xbgr.mr_n78350128)
print v(xbgr.mr_n78350240)
print v(xbgr.mr_n78350560)
print v(xbgr.mr_n78350672)
print v(xbgr.mr_n78351104)
print v(xbgr.mr_n78351536)
print v(xbgr.mr_n78351968)
print v(xbgr.mr_n78352288)
print v(xbgr.mr_n78352400)
print v(xbgr.mr_n78352720)
print v(xbgr.mr_n78352832)
print v(xbgr.mr_n78353152)
print v(xbgr.mr_n78353264)
print v(xbgr.mr_n78353584)
print v(xbgr.mr_n78353696)
print v(xbgr.mr_n78354016)
print v(xbgr.mr_n78354128)
print v(xbgr.mr_n78354448)
print v(xbgr.mr_n78354560)
print v(xbgr.mr_n78354880)
print v(xbgr.mr_n78354992)
print v(xbgr.mr_n78355424)
print v(xbgr.mr_n78355744)
print v(xbgr.mr_n78356176)
print v(xbgr.mr_n78356288)
print v(xbgr.mr_n78356608)
print v(xbgr.mr_n78356720)
print v(xbgr.mr_n78357040)
print v(xbgr.mr_n78357152)
print v(xbgr.mr_n78357472)
print v(xbgr.mr_n78357584)
print v(xbgr.mr_n78357904)
print v(xbgr.mr_n78358016)
print v(xbgr.mr_n78358336)
print v(xbgr.mr_n78358448)
print v(xbgr.mr_n78358768)
print v(xbgr.mr_n78358880)
print v(xbgr.mr_n78359312)
print v(xbgr.mr_n78359632)
print v(xbgr.mr_n78359744)
print v(xbgr.mr_n78360176)
print v(xbgr.mr_n78360496)
print v(xbgr.mr_n78360608)
print v(xbgr.mr_n78360928)
print v(xbgr.mr_n78361040)
print v(xbgr.mr_n78361360)
print v(xbgr.mr_n78361472)
print v(xbgr.mr_n78361904)
print v(xbgr.mr_n78362336)
print v(xbgr.mr_n78362656)
print v(xbgr.mr_n78362768)
print v(xbgr.mr_n78363088)
print v(xbgr.mr_n78363200)
print v(xbgr.mr_n78363520)
print v(xbgr.mr_n78363632)
print v(xbgr.mr_n78363952)
print v(xbgr.mr_n78364064)
print v(xbgr.mr_n78364384)
print v(xbgr.mr_n78364496)
print v(xbgr.mr_n78364816)
print v(xbgr.mr_n78364928)
print v(xbgr.mr_n78365248)
print v(xbgr.mr_n78365360)
print v(xbgr.mr_n78365680)
print v(xbgr.mr_n78365792)
print v(xbgr.mr_n78366112)
print v(xbgr.mr_n78366224)
print v(xbgr.mr_n78366544)
print v(xbgr.mr_n78366656)
print v(xbgr.mr_n78366976)
print v(xbgr.mr_n78367088)
print v(xbgr.mr_n78367408)
print v(xbgr.mr_n78368272)
print v(xbgr.mr_n78369136)
print v(xbgr.mr_n78369248)
print v(xbgr.mr_n78369680)
print v(xbgr.mr_n78370000)
print v(xbgr.mr_n78370112)
print v(xbgr.mr_n78370864)
print v(xbgr.mr_n78371296)
print v(xbgr.mr_n78371408)
print v(xbgr.mr_n78371728)
print v(xbgr.mr_n78371840)
print v(xbgr.mr_n78372160)
print v(xbgr.mr_n78372272)
print v(xbgr.mr_n78372592)
print v(xbgr.mr_n78372704)
print v(xbgr.mr_n78373024)
print v(xbgr.mr_n78373888)
print v(xbgr.mr_n78374320)
print v(xbgr.mr_n78374432)
print v(xbgr.mr_n78374752)
print v(xbgr.mr_n78374864)
print v(xbgr.mr_n78375184)
print v(xbgr.mr_n78376048)
print v(xbgr.mr_n78377344)
print v(xbgr.mr_n78378208)
print v(xbgr.mr_n78379072)
print v(xbgr.mr_n78379184)
print v(xbgr.mr_n78379936)
print v(xbgr.mr_n78380048)
print v(xbgr.mr_n78380480)
print v(xbgr.mr_n78380912)
print v(xbgr.mr_n78381664)
print v(xbgr.mr_n78382528)
print v(xbgr.mr_n78383392)
print v(xbgr.mr_n78383504)
print v(xbgr.mr_n78383824)
print v(xbgr.mr_n78383936)
print v(xbgr.mr_n78384368)
print v(xbgr.mr_n78384688)
print v(xbgr.mr_n78384800)
print v(xbgr.mr_n78385232)
print v(xbgr.mr_n78385552)
print v(xbgr.mr_n78385664)
print v(xbgr.mr_n78385984)
print v(xbgr.mr_n78386096)
print v(xbgr.mr_n78386416)
print v(xbgr.mr_n78387280)
print v(xbgr.mr_n78387392)
print v(xbgr.mr_n78387824)
print v(xbgr.mr_n78388144)
print v(xbgr.mr_n78389120)
print v(xbgr.mr_n78389440)
print v(xbgr.mr_n78389552)
print v(xbgr.mr_n78389984)
print v(xbgr.mr_n78390304)
print v(xbgr.mr_n78390736)
print v(xbgr.mr_n78390848)
print v(xbgr.mr_n78391168)
print v(xbgr.mr_n78391280)
print v(xbgr.mr_n78391600)
print v(xbgr.mr_n78392032)
print v(xbgr.mr_n78392144)
print v(xbgr.mr_n78392464)
print v(xbgr.mr_n78392576)
print v(xbgr.mr_n78392896)
print v(xbgr.mr_n78393008)
print v(xbgr.mr_n78393328)
print v(xbgr.mr_n78393440)
print v(xbgr.mr_n78393760)
print v(xbgr.mr_n78393872)
print v(xbgr.mr_n78394304)
print v(xbgr.mr_n78394624)
print v(xbgr.mr_n78394736)
print v(xbgr.mr_n78395056)
print v(xbgr.mr_n78395168)
print v(xbgr.mr_n78395488)
print v(xbgr.mr_n78396032)
print v(xbgr.mr_n78396784)
print v(xbgr.mr_n78398080)
print v(xbgr.mr_n78398192)
print v(xbgr.mr_n78398512)
print v(xbgr.mr_n78398624)
print v(xbgr.mr_n78398944)
print v(xbgr.mr_n78399808)
print v(xbgr.mr_n78400672)
print v(xbgr.mr_n78401536)
print v(xbgr.mr_n78401648)
print v(xbgr.mr_n78401968)
print v(xbgr.mr_n78402080)
print v(xbgr.mr_n78402400)
print v(xbgr.mr_n78402512)
print v(xbgr.mr_n78402832)
print v(xbgr.mr_n78402944)
print v(xbgr.mr_n78403264)
print v(xbgr.mr_n78403376)
print v(xbgr.mr_n78403696)
print v(xbgr.mr_n78404560)
print v(xbgr.mr_n78405424)
print v(xbgr.mr_n78406288)
print v(xbgr.mr_n78406400)
print v(xbgr.mr_n78406720)
print v(xbgr.mr_n78406832)
print v(xbgr.mr_n78407152)
print v(xbgr.mr_n78407264)
print v(xbgr.mr_n78407584)
print v(xbgr.mr_n78407696)
print v(xbgr.mr_n78408128)
print v(xbgr.mr_n78408448)
print v(xbgr.mr_n78408560)
print v(xbgr.mr_n78408880)
print v(xbgr.mr_n78408992)
print v(xbgr.mr_n78409312)
print v(xbgr.mr_n78409424)
print v(xbgr.mr_n78409744)
print v(xbgr.mr_n78409856)
print v(xbgr.mr_n78410608)
print v(xbgr.mr_n78411152)
print v(xbgr.mr_n78411584)
print v(xbgr.mr_n78412016)
print v(xbgr.mr_n78412448)
print v(xbgr.mr_n78412768)
print v(xbgr.mr_n78412880)
print v(xbgr.mr_n78413632)
print v(xbgr.mr_n78414496)
print v(xbgr.mr_n78415360)
print v(xbgr.mr_n78416224)
print v(xbgr.mr_n78417088)
print v(xbgr.mr_n78417952)
print v(xbgr.mr_n78418816)
print v(xbgr.mr_n78418928)
print v(xbgr.mr_n78419248)
print v(xbgr.mr_n78419360)
print v(xbgr.mr_n78419792)
print v(xbgr.mr_n78420112)
print v(xbgr.mr_n78420224)
print v(xbgr.mr_n78420656)
print v(xbgr.mr_n78420976)
print v(xbgr.mr_n78421088)
print v(xbgr.mr_n78421408)
print v(xbgr.mr_n78421520)
print v(xbgr.mr_n78421840)
print v(xbgr.mr_n78421952)
print v(xbgr.mr_n78422272)
print v(xbgr.mr_n78422384)
print v(xbgr.mr_n78422704)
print v(xbgr.mr_n78422816)
print v(xbgr.mr_n78423136)
print v(xbgr.mr_n78423248)
print v(xbgr.mr_n78423568)
print v(xbgr.mr_n78424432)
print v(xbgr.mr_n78424864)
print v(xbgr.mr_n78425840)
print v(xbgr.mr_n78426272)
print v(xbgr.mr_n78426704)
print v(xbgr.mr_n78427136)
print v(xbgr.mr_n78427456)
print v(xbgr.mr_n78428320)
print v(xbgr.mr_n78429184)
print v(xbgr.mr_n78430048)
print v(xbgr.mr_n78430912)
print v(xbgr.mr_n78431776)
print v(xbgr.mr_n78432640)
print v(xbgr.mr_n78433936)
print v(xbgr.mr_n78434368)
print v(xbgr.mr_n78435664)
print v(xbgr.mr_n78435776)
print v(xbgr.mr_n78436096)
print v(xbgr.mr_n78436208)
print v(xbgr.mr_n78436528)
print v(xbgr.mr_n78436640)
print v(xbgr.mr_n78437072)
print v(xbgr.mr_n78437504)
print v(xbgr.mr_n78437824)
print v(xbgr.mr_n78437936)
print v(xbgr.mr_n78438256)
print v(xbgr.mr_n78438368)
print v(xbgr.mr_n78438688)
print v(xbgr.mr_n78438800)
print v(xbgr.mr_n78439120)
print v(xbgr.mr_n78439232)
print v(xbgr.mr_n78439664)
print v(xbgr.mr_n78439984)
print v(xbgr.mr_n78440848)
print v(xbgr.mr_n78440960)
print v(xbgr.mr_n78441280)
print v(xbgr.mr_n78441392)
print v(xbgr.mr_n78441712)
print v(xbgr.mr_n78441824)
print v(xbgr.mr_n78442144)
print v(xbgr.mr_n78442256)
print v(xbgr.mr_n78442576)
print v(xbgr.mr_n78443440)
print v(xbgr.mr_n78443872)
print v(xbgr.mr_n78445168)
print v(xbgr.mr_n78445280)
print v(xbgr.mr_n78445600)
print v(xbgr.mr_n78445712)
print v(xbgr.mr_n78446032)
print v(xbgr.mr_n78446144)
print v(xbgr.mr_n78446464)
print v(xbgr.mr_n78447328)
print v(xbgr.mr_n78447440)
print v(xbgr.mr_n78447872)
print v(xbgr.mr_n78448192)
print v(xbgr.mr_n78448304)
print v(xbgr.mr_n78448624)
print v(xbgr.mr_n78448736)
print v(xbgr.mr_n78449056)
print v(xbgr.mr_n78449168)
print v(xbgr.mr_n78449488)
print v(xbgr.mr_n78449600)
print v(xbgr.mr_n78450032)
print v(xbgr.mr_n78450352)
print v(xbgr.mr_n78451216)
print v(xbgr.mr_n78451328)
print v(xbgr.mr_n78451648)
print v(xbgr.mr_n78452512)
print v(xbgr.mr_n78452624)
print v(xbgr.mr_n78452944)
print v(xbgr.mr_n78453056)
print v(xbgr.mr_n78453376)
print v(xbgr.mr_n78453920)
print v(xbgr.mr_n78454352)
print v(xbgr.mr_n78454672)
print v(xbgr.mr_n78455104)
print v(xbgr.mr_n78455216)
print v(xbgr.mr_n78455536)
print v(xbgr.mr_n78455648)
print v(xbgr.mr_n78455968)
print v(xbgr.mr_n78456080)
print v(xbgr.mr_n78456400)
print v(xbgr.mr_n78456512)
print v(xbgr.mr_n78456832)
print v(xbgr.mr_n78456944)
print v(xbgr.mr_n78457696)
print v(xbgr.mr_n78457808)
print v(xbgr.mr_n78458128)
print v(xbgr.mr_n78458240)
print v(xbgr.mr_n78458560)
print v(xbgr.mr_n78459856)
print v(xbgr.mr_n78459968)
print v(xbgr.mr_n78460288)
print v(xbgr.mr_n78460400)
print v(xbgr.mr_n78460720)
print v(xbgr.mr_n78461696)
print v(xbgr.mr_n78462016)
print v(xbgr.mr_n78462880)
print v(xbgr.mr_n78463312)
print v(xbgr.mr_n78463424)
print v(xbgr.mr_n78463744)
print v(xbgr.mr_n78463856)
print v(xbgr.mr_n78464176)
print v(xbgr.mr_n78464288)
print v(xbgr.mr_n78464608)
print v(xbgr.mr_n78465472)
print v(xbgr.mr_n78466768)
print v(xbgr.mr_n78467632)
print v(xbgr.mr_n78468608)
print v(xbgr.mr_n78468928)
print v(xbgr.mr_n78469040)
print v(xbgr.mr_n78469472)
print v(xbgr.mr_n78469792)
print v(xbgr.mr_n78469904)
print v(xbgr.mr_n78470224)
print v(xbgr.mr_n78470336)
print v(xbgr.mr_n78470656)
print v(xbgr.mr_n78470768)
print v(xbgr.mr_n78471088)
print v(xbgr.mr_n78471200)
print v(xbgr.mr_n78471520)
print v(xbgr.mr_n78471632)
print v(xbgr.mr_n78471952)
print v(xbgr.mr_n78472064)
print v(xbgr.mr_n78472384)
print v(xbgr.mr_n78472496)
print v(xbgr.mr_n78472816)
print v(xbgr.mr_n78472928)
print v(xbgr.mr_n78473360)
print v(xbgr.mr_n78473680)
print v(xbgr.mr_n78473792)
print v(xbgr.mr_n78474224)
print v(xbgr.mr_n78474544)
print v(xbgr.mr_n78475408)
print v(xbgr.mr_n78476272)
print v(xbgr.mr_n78477136)
print v(xbgr.mr_n78477248)
print v(xbgr.mr_n78477568)
print v(xbgr.mr_n78477680)
print v(xbgr.mr_n78478000)
print v(xbgr.mr_n78478112)
print v(xbgr.mr_n78478432)
print v(xbgr.mr_n78478544)
print v(xbgr.mr_n78478976)
print v(xbgr.mr_n78479408)
print v(xbgr.mr_n78479840)
print v(xbgr.mr_n78480272)
print v(xbgr.mr_n78480592)
print v(xbgr.mr_n78480704)
print v(xbgr.mr_n78481024)
print v(xbgr.mr_n78481136)
print v(xbgr.mr_n78481456)
print v(xbgr.mr_n78481568)
print v(xbgr.mr_n78481888)
print v(xbgr.mr_n78482000)
print v(xbgr.mr_n78482320)
print v(xbgr.mr_n78482432)
print v(xbgr.mr_n78482752)
print v(xbgr.mr_n78482864)
print v(xbgr.mr_n78483184)
print v(xbgr.mr_n78483296)
print v(xbgr.mr_n78483728)
print v(xbgr.mr_n78484048)
print v(xbgr.mr_n78484160)
print v(xbgr.mr_n78484480)
print v(xbgr.mr_n78485344)
print v(xbgr.mr_n78486080)
print v(xbgr.mr_n78486944)
print v(xbgr.mr_n78487808)
print v(xbgr.mr_n78488672)
print v(xbgr.mr_n78489536)
print v(xbgr.mr_n78489648)
print v(xbgr.mr_n78490080)
print v(xbgr.mr_n78490400)
print v(xbgr.mr_n78490512)
print v(xbgr.mr_n78490944)
print v(xbgr.mr_n78491264)
print v(xbgr.mr_n78491376)
print v(xbgr.mr_n78491696)
print v(xbgr.mr_n78491808)
print v(xbgr.mr_n78492128)
print v(xbgr.mr_n78492240)
print v(xbgr.mr_n78492672)
print v(xbgr.mr_n78492992)
print v(xbgr.mr_n78493856)
print v(xbgr.mr_n78493968)
print v(xbgr.mr_n78494288)
print v(xbgr.mr_n78494400)
print v(xbgr.mr_n78494720)
print v(xbgr.mr_n78494832)
print v(xbgr.mr_n78495152)
print v(xbgr.mr_n78495264)
print v(xbgr.mr_n78495584)
print v(xbgr.mr_n78495696)
print v(xbgr.mr_n78496016)
print v(xbgr.mr_n78496128)
print v(xbgr.mr_n78496448)
print v(xbgr.mr_n78496560)
print v(xbgr.mr_n78496880)
print v(xbgr.mr_n78497312)
print v(xbgr.mr_n78497424)
print v(xbgr.mr_n78497744)
print v(xbgr.mr_n78497856)
print v(xbgr.mr_n78498176)
print v(xbgr.mr_n78498288)
print v(xbgr.mr_n78498608)
print v(xbgr.mr_n78498720)
print v(xbgr.mr_n78499040)
print v(xbgr.mr_n78500336)
print v(xbgr.mr_n78501200)
print v(xbgr.mr_n78501744)
print v(xbgr.mr_n78502176)
print v(xbgr.mr_n78502496)
print v(xbgr.mr_n78502608)
print v(xbgr.mr_n78502928)
print v(xbgr.mr_n78503040)
print v(xbgr.mr_n78503360)
print v(xbgr.mr_n78503472)
print v(xbgr.mr_n78503792)
print v(xbgr.mr_n78503904)
print v(xbgr.mr_n78504224)
print v(xbgr.mr_n78504336)
print v(xbgr.mr_n78504656)
print v(xbgr.mr_n78504768)
print v(xbgr.mr_n78505088)
print v(xbgr.mr_n78505200)
print v(xbgr.mr_n78505520)
print v(xbgr.mr_n78505632)
print v(xbgr.mr_n78505952)
print v(xbgr.mr_n78506064)
print v(xbgr.mr_n78506384)
print v(xbgr.mr_n78507248)
print v(xbgr.mr_n78508112)
print v(xbgr.mr_n78508224)
print v(xbgr.mr_n78508656)
print v(xbgr.mr_n78509408)
print v(xbgr.mr_n78510272)
print v(xbgr.mr_n78511136)
print v(xbgr.mr_n78512112)
print v(xbgr.mr_n78512544)
print v(xbgr.mr_n78512864)
print v(xbgr.mr_n78512976)
print v(xbgr.mr_n78513296)
print v(xbgr.mr_n78513408)
print v(xbgr.mr_n78513728)
print v(xbgr.mr_n78514592)
print v(xbgr.mr_n78515456)
print v(xbgr.mr_n78515568)
print v(xbgr.mr_n78515888)
print v(xbgr.mr_n78516000)
print v(xbgr.mr_n78516320)
print v(xbgr.mr_n78516432)
print v(xbgr.mr_n78516752)
print v(xbgr.mr_n78516864)
print v(xbgr.mr_n78517184)
print v(xbgr.mr_n78517296)
print v(xbgr.mr_n78517616)
print v(xbgr.mr_n78517728)
print v(xbgr.mr_n78518048)
print v(xbgr.mr_n78518160)
print v(xbgr.mr_n78518480)
print v(xbgr.mr_n78518592)
print v(xbgr.mr_n78518912)
print v(xbgr.mr_n78519024)
print v(xbgr.mr_n78519456)
print v(xbgr.mr_n78519776)
print v(xbgr.mr_n78520208)
print v(xbgr.mr_n78520320)
print v(xbgr.mr_n78521072)
print v(xbgr.mr_n78521184)
print v(xbgr.mr_n78521616)
print v(xbgr.mr_n78522368)
print v(xbgr.mr_n78522480)
print v(xbgr.mr_n78522800)
print v(xbgr.mr_n78522912)
print v(xbgr.mr_n78523344)
print v(xbgr.mr_n78523776)
print v(xbgr.mr_n78524208)
print v(xbgr.mr_n78524528)
print v(xbgr.mr_n78524640)
print v(xbgr.mr_n78524960)
print v(xbgr.mr_n78525072)
print v(xbgr.mr_n78525504)
print v(xbgr.mr_n78525824)
print v(xbgr.mr_n78526688)
print v(xbgr.mr_n78526800)
print v(xbgr.mr_n78527120)
print v(xbgr.mr_n78527232)
print v(xbgr.mr_n78527552)
print v(xbgr.mr_n78527664)
print v(xbgr.mr_n78527984)
print v(xbgr.mr_n78528096)
print v(xbgr.mr_n78528416)
print v(xbgr.mr_n78528528)
print v(xbgr.mr_n78528848)
print v(xbgr.mr_n78528960)
print v(xbgr.mr_n78529280)
print v(xbgr.mr_n78530144)
print v(xbgr.mr_n78531008)
print v(xbgr.mr_n78531120)
print v(xbgr.mr_n78531440)
print v(xbgr.mr_n78531552)
print v(xbgr.mr_n78531872)
print v(xbgr.mr_n78531984)
print v(xbgr.mr_n78532304)
print v(xbgr.mr_n78532416)
print v(xbgr.mr_n78532736)
print v(xbgr.mr_n78533600)
print v(xbgr.mr_n78534464)
print v(xbgr.mr_n78535328)
print v(xbgr.mr_n78536192)
print v(xbgr.mr_n78537600)
print v(xbgr.mr_n78537920)
print v(xbgr.mr_n78538784)
print v(xbgr.mr_n78539648)
print v(xbgr.mr_n78539760)
print v(xbgr.mr_n78540192)
print v(xbgr.mr_n78540512)
print v(xbgr.mr_n78540624)
print v(xbgr.mr_n78541056)
print v(xbgr.mr_n78541376)
print v(xbgr.mr_n78542240)
print v(xbgr.mr_n78543104)
print v(xbgr.mr_n78543968)
print v(xbgr.mr_n78544832)
print v(xbgr.mr_n78544944)
print v(xbgr.mr_n78545264)
print v(xbgr.mr_n78545376)
print v(xbgr.mr_n78545696)
print v(xbgr.mr_n78545808)
print v(xbgr.mr_n78546128)
print v(xbgr.mr_n78546240)
print v(xbgr.mr_n78546560)
print v(xbgr.mr_n78547424)
print v(xbgr.mr_n78548288)
print v(xbgr.mr_n78548400)
print v(xbgr.mr_n78548720)
print v(xbgr.mr_n78548832)
print v(xbgr.mr_n78549264)
print v(xbgr.mr_n78549696)
print v(xbgr.mr_n78550016)
print v(xbgr.mr_n78550128)
print v(xbgr.mr_n78550448)
print v(xbgr.mr_n78550560)
print v(xbgr.mr_n78550880)
print v(xbgr.mr_n78550992)
print v(xbgr.mr_n78551312)
print v(xbgr.mr_n78551424)
print v(xbgr.mr_n78551744)
print v(xbgr.mr_n78551856)
print v(xbgr.mr_n78552288)
print v(xbgr.mr_n78552608)
print v(xbgr.mr_n78552720)
print v(xbgr.mr_n78553152)
print v(xbgr.mr_n78553472)
print v(xbgr.mr_n78554336)
print v(xbgr.mr_n78555200)
print v(xbgr.mr_n78556064)
print v(xbgr.mr_n78556928)
print v(xbgr.mr_n78557040)
print v(xbgr.mr_n78557360)
print v(xbgr.mr_n78557472)
print v(xbgr.mr_n78557792)
print v(xbgr.mr_n78557904)
print v(xbgr.mr_n78558224)
print v(xbgr.mr_n78558336)
print v(xbgr.mr_n78558656)
print v(xbgr.mr_n78559520)
print v(xbgr.mr_n78560384)
print v(xbgr.mr_n78560496)
print v(xbgr.mr_n78560816)
print v(xbgr.mr_n78560928)
print v(xbgr.mr_n78561360)
print v(xbgr.mr_n78561792)
print v(xbgr.mr_n78562112)
print v(xbgr.mr_n78562224)
print v(xbgr.mr_n78562544)
print v(xbgr.mr_n78562656)
print v(xbgr.mr_n78562976)
print v(xbgr.mr_n78563088)
print v(xbgr.mr_n78563408)
print v(xbgr.mr_n78563520)
print v(xbgr.mr_n78563840)
print v(xbgr.mr_n78563952)
print v(xbgr.mr_n78564384)
print v(xbgr.mr_n78564704)
print v(xbgr.mr_n78564816)
print v(xbgr.mr_n78565248)
print v(xbgr.mr_n78565568)
print v(xbgr.mr_n78565680)
print v(xbgr.mr_n78566112)
print v(xbgr.mr_n78566432)
print v(xbgr.mr_n78566544)
print v(xbgr.mr_n78566976)
print v(xbgr.mr_n78567296)
print v(xbgr.mr_n78568160)
print v(xbgr.mr_n78569024)
print v(xbgr.mr_n78569888)
print v(xbgr.mr_n78570752)
print v(xbgr.mr_n78571616)
print v(xbgr.mr_n78572480)
print v(xbgr.mr_n78572592)
print v(xbgr.mr_n78572912)
print v(xbgr.mr_n78573024)
print v(xbgr.mr_n78573344)
print v(xbgr.mr_n78573456)
print v(xbgr.mr_n78573776)
print v(xbgr.mr_n78573888)
print v(xbgr.mr_n78574208)
print v(xbgr.mr_n78574320)
print v(xbgr.mr_n78574640)
print v(xbgr.mr_n78574752)
print v(xbgr.mr_n78575072)
print v(xbgr.mr_n78575184)
print v(xbgr.mr_n78575504)
print v(xbgr.mr_n78575616)
print v(xbgr.mr_n78575936)
print v(xbgr.mr_n78576048)
print v(xbgr.mr_n78576368)
print v(xbgr.mr_n78576480)
print v(xbgr.mr_n78576912)
print v(xbgr.mr_n78577344)
print v(xbgr.mr_n78577664)
print v(xbgr.mr_n78578528)
print v(xbgr.mr_n78579392)
print v(xbgr.mr_n78579504)
print v(xbgr.mr_n78579824)
print v(xbgr.mr_n78579936)
print v(xbgr.mr_n78580256)
print v(xbgr.mr_n78580368)
print v(xbgr.mr_n78580688)
print v(xbgr.mr_n78580800)
print v(xbgr.mr_n78581120)
print v(xbgr.mr_n78581232)
print v(xbgr.mr_n78581552)
print v(xbgr.mr_n78581664)
print v(xbgr.mr_n78581984)
print v(xbgr.mr_n78582096)
print v(xbgr.mr_n78582416)
print v(xbgr.mr_n78582528)
print v(xbgr.mr_n78582960)
print v(xbgr.mr_n78583392)
print v(xbgr.mr_n78583712)
print v(xbgr.mr_n78583824)
print v(xbgr.mr_n78584144)
print v(xbgr.mr_n78584256)
print v(xbgr.mr_n78584576)
print v(xbgr.mr_n78584688)
print v(xbgr.mr_n78585008)
print v(xbgr.mr_n78585120)
print v(xbgr.mr_n78585440)
print v(xbgr.mr_n78585552)
print v(xbgr.mr_n78585872)
print v(xbgr.mr_n78585984)
print v(xbgr.mr_n78586304)
print v(xbgr.mr_n78587168)
print v(xbgr.mr_n78588032)
print v(xbgr.mr_n78588896)
print v(xbgr.mr_n78589760)
print v(xbgr.mr_n78589872)
print v(xbgr.mr_n78590304)
print v(xbgr.mr_n78590624)
print v(xbgr.mr_n78590736)
print v(xbgr.mr_n78591056)
print v(xbgr.mr_n78591168)
print v(xbgr.mr_n78591488)
print v(xbgr.mr_n78591600)
print v(xbgr.mr_n78591920)
print v(xbgr.mr_n78592032)
print v(xbgr.mr_n78592352)
print v(xbgr.mr_n78592464)
print v(xbgr.mr_n78592784)
print v(xbgr.mr_n78592896)
print v(xbgr.mr_n78593216)
print v(xbgr.mr_n78593328)
print v(xbgr.mr_n78593760)
print v(xbgr.mr_n78594080)
print v(xbgr.mr_n78594944)
print v(xbgr.mr_n78595056)
print v(xbgr.mr_n78595376)
print v(xbgr.mr_n78595488)
print v(xbgr.mr_n78595808)
print v(xbgr.mr_n78595920)
print v(xbgr.mr_n78596240)
print v(xbgr.mr_n78596352)
print v(xbgr.mr_n78596672)
print v(xbgr.mr_n78596784)
print v(xbgr.mr_n78597216)
print v(xbgr.mr_n78597536)
print v(xbgr.mr_n78597648)
print v(xbgr.mr_n78598080)
print v(xbgr.mr_n78598400)
print v(xbgr.mr_n78599264)
print v(xbgr.mr_n78600128)
print v(xbgr.mr_n78600992)
print v(xbgr.mr_n78601856)
print v(xbgr.mr_n78601968)
print v(xbgr.mr_n78602288)
print v(xbgr.mr_n78602400)
print v(xbgr.mr_n78602720)
print v(xbgr.mr_n78602832)
print v(xbgr.mr_n78603152)
print v(xbgr.mr_n78603264)
print v(xbgr.mr_n78603584)
print v(xbgr.mr_n78603696)
print v(xbgr.mr_n78604016)
print v(xbgr.mr_n78604128)
print v(xbgr.mr_n78604448)
print v(xbgr.mr_n78605312)
print v(xbgr.mr_n78606176)
print v(xbgr.mr_n78606288)
print v(xbgr.mr_n78606608)
print v(xbgr.mr_n78606720)
print v(xbgr.mr_n78607152)
print v(xbgr.mr_n78607584)
print v(xbgr.mr_n78607904)
print v(xbgr.mr_n78608016)
print v(xbgr.mr_n78608336)
print v(xbgr.mr_n78608448)
print v(xbgr.mr_n78608768)
print v(xbgr.mr_n78608880)
print v(xbgr.mr_n78609200)
print v(xbgr.mr_n78609312)
print v(xbgr.mr_n78609632)
print v(xbgr.mr_n78610496)
print v(xbgr.mr_n78611360)
print v(xbgr.mr_n78612224)
print v(xbgr.mr_n78613088)
print v(xbgr.mr_n78613952)
print v(xbgr.mr_n78614064)
print v(xbgr.mr_n78614384)
print v(xbgr.mr_n78614496)
print v(xbgr.mr_n78614816)
print v(xbgr.mr_n78614928)
print v(xbgr.mr_n78615248)
print v(xbgr.mr_n78615360)
print v(xbgr.mr_n78615680)
print v(xbgr.mr_n78615792)
print v(xbgr.mr_n78616224)
print v(xbgr.mr_n78616544)
print v(xbgr.mr_n78616656)
print v(xbgr.mr_n78617088)
print v(xbgr.mr_n78617408)
print v(xbgr.mr_n78617520)
print v(xbgr.mr_n78617952)
print v(xbgr.mr_n78618272)
print v(xbgr.mr_n78618384)
print v(xbgr.mr_n78618816)
print v(xbgr.mr_n78619136)
print v(xbgr.mr_n78620000)
print v(xbgr.mr_n78620112)
print v(xbgr.mr_n78620432)
print v(xbgr.mr_n78620544)
print v(xbgr.mr_n78620864)
print v(xbgr.mr_n78620976)
print v(xbgr.mr_n78621296)
print v(xbgr.mr_n78621408)
print v(xbgr.mr_n78621728)
print v(xbgr.mr_n78622592)
print v(xbgr.mr_n78623456)
print v(xbgr.mr_n78624320)
print v(xbgr.mr_n78625184)
print v(xbgr.mr_n78626048)
print v(xbgr.mr_n78626160)
print v(xbgr.mr_n78626480)
print v(xbgr.mr_n78626592)
print v(xbgr.mr_n78626912)
print v(xbgr.mr_n78627024)
print v(xbgr.mr_n78627344)
print v(xbgr.mr_n78627456)
print v(xbgr.mr_n78627888)
print v(xbgr.mr_n78628320)
print v(xbgr.mr_n78628640)
print v(xbgr.mr_n78628752)
print v(xbgr.mr_n78629072)
print v(xbgr.mr_n78629184)
print v(xbgr.mr_n78629504)
print v(xbgr.mr_n78630368)
print v(xbgr.mr_n78630480)
print v(xbgr.mr_n78630800)
print v(xbgr.mr_n78630912)
print v(xbgr.mr_n78631232)
print v(xbgr.mr_n78632096)
print v(xbgr.mr_n78632960)
print v(xbgr.mr_n78633072)
print v(xbgr.mr_n78633392)
print v(xbgr.mr_n78633504)
print v(xbgr.mr_n78633824)
print v(xbgr.mr_n78634688)
print v(xbgr.mr_n78635552)
print v(xbgr.mr_n78636416)
print v(xbgr.mr_n78636528)
print v(xbgr.mr_n78636848)
print v(xbgr.mr_n78636960)
print v(xbgr.mr_n78637280)
print v(xbgr.mr_n78637392)
print v(xbgr.mr_n78637712)
print v(xbgr.mr_n78637824)
print v(xbgr.mr_n78638144)
print v(xbgr.mr_n78638256)
print v(xbgr.mr_n78638576)
print v(xbgr.mr_n78638688)
print v(xbgr.mr_n78639008)
print v(xbgr.mr_n78639120)
print v(xbgr.mr_n78639440)
print v(xbgr.mr_n78639552)
print v(xbgr.mr_n78639872)
print v(xbgr.mr_n78639984)
print v(xbgr.mr_n78640304)
print v(xbgr.mr_n78640416)
print v(xbgr.mr_n78640736)
print v(xbgr.mr_n78640848)
print v(xbgr.mr_n78641168)
print v(xbgr.mr_n78641280)
print v(xbgr.mr_n78641712)
print v(xbgr.mr_n78642032)
print v(xbgr.mr_n78642144)
print v(xbgr.mr_n78642576)
print v(xbgr.mr_n78642896)
print v(xbgr.mr_n78643008)
print v(xbgr.mr_n78643440)
print v(xbgr.mr_n78643760)
print v(xbgr.mr_n78644624)
print v(xbgr.mr_n78645488)
print v(xbgr.mr_n78646352)
print v(xbgr.mr_n78646464)
print v(xbgr.mr_n78646784)
print v(xbgr.mr_n78646896)
print v(xbgr.mr_n78647216)
print v(xbgr.mr_n78648080)
print v(xbgr.mr_n78648944)
print v(xbgr.mr_n78649808)
print v(xbgr.mr_n78649920)
print v(xbgr.mr_n78650240)
print v(xbgr.mr_n78650352)
print v(xbgr.mr_n78650672)
print v(xbgr.mr_n78650784)
print v(xbgr.mr_n78651104)
print v(xbgr.mr_n78651216)
print v(xbgr.mr_n78651536)
print v(xbgr.mr_n78651648)
print v(xbgr.mr_n78651968)
print v(xbgr.mr_n78652080)
print v(xbgr.mr_n78652400)
print v(xbgr.mr_n78652512)
print v(xbgr.mr_n78652832)
print v(xbgr.mr_n78652944)
print v(xbgr.mr_n78653264)
print v(xbgr.mr_n78653376)
print v(xbgr.mr_n78653696)
print v(xbgr.mr_n78653808)
print v(xbgr.mr_n78654128)
print v(xbgr.mr_n78654240)
print v(xbgr.mr_n78654560)
print v(xbgr.mr_n78654672)
print v(xbgr.mr_n78654992)
print v(xbgr.mr_n78655104)
print v(xbgr.mr_n78655536)
print v(xbgr.mr_n78655856)
print v(xbgr.mr_n78656720)
print v(xbgr.mr_n78657584)
print v(xbgr.mr_n78658448)
print v(xbgr.mr_n78658560)
print v(xbgr.mr_n78658992)
print v(xbgr.mr_n78659312)
print v(xbgr.mr_n78659424)
print v(xbgr.mr_n78659856)
print v(xbgr.mr_n78660176)
print v(xbgr.mr_n78660288)
print v(xbgr.mr_n78660608)
print v(xbgr.mr_n78660720)
print v(xbgr.mr_n78661040)
print v(xbgr.mr_n78661152)
print v(xbgr.mr_n78661584)
print v(xbgr.mr_n78662016)
print v(xbgr.mr_n78662448)
print v(xbgr.mr_n78662768)
print v(xbgr.mr_n78663632)
print v(xbgr.mr_n78664496)
print v(xbgr.mr_n78665360)
print v(xbgr.mr_n78666224)
print v(xbgr.mr_n78667088)
print v(xbgr.mr_n78667952)
print v(xbgr.mr_n78668064)
print v(xbgr.mr_n78668384)
print v(xbgr.mr_n78668496)
print v(xbgr.mr_n78668816)
print v(xbgr.mr_n78668928)
print v(xbgr.mr_n78669248)
print v(xbgr.mr_n78669360)
print v(xbgr.mr_n78669680)
print v(xbgr.mr_n78669792)
print v(xbgr.mr_n78670112)
print v(xbgr.mr_n78670224)
print v(xbgr.mr_n78670544)
print v(xbgr.mr_n78671408)
print v(xbgr.mr_n78672272)
print v(xbgr.mr_n78673248)
print v(xbgr.mr_n78673680)
print v(xbgr.mr_n78674112)
print v(xbgr.mr_n78674432)
print v(xbgr.mr_n78674544)
print v(xbgr.mr_n78674864)
print v(xbgr.mr_n78674976)
print v(xbgr.mr_n78675296)
print v(xbgr.mr_n78675408)
print v(xbgr.mr_n78675840)
print v(xbgr.mr_n78676160)
print v(xbgr.mr_n78676272)
print v(xbgr.mr_n78676592)
print v(xbgr.mr_n78676704)
print v(xbgr.mr_n78677136)
print v(xbgr.mr_n78677456)
print v(xbgr.mr_n78677568)
print v(xbgr.mr_n78678000)
print v(xbgr.mr_n78678320)
print v(xbgr.mr_n78678432)
print v(xbgr.mr_n78678864)
print v(xbgr.mr_n78679184)
print v(xbgr.mr_n78680048)
print v(xbgr.mr_n78680912)
print v(xbgr.mr_n78681024)
print v(xbgr.mr_n78681344)
print v(xbgr.mr_n78681456)
print v(xbgr.mr_n78681776)
print v(xbgr.mr_n78681888)
print v(xbgr.mr_n78682208)
print v(xbgr.mr_n78682320)
print v(xbgr.mr_n78682752)
print v(xbgr.mr_n78683072)
print v(xbgr.mr_n78683936)
print v(xbgr.mr_n78684048)
print v(xbgr.mr_n78684368)
print v(xbgr.mr_n78684480)
print v(xbgr.mr_n78684800)
print v(xbgr.mr_n78684912)
print v(xbgr.mr_n78685232)
print v(xbgr.mr_n78686096)
print v(xbgr.mr_n78686528)
print v(xbgr.mr_n78687392)
print v(xbgr.mr_n78687504)
print v(xbgr.mr_n78687824)
print v(xbgr.mr_n78687936)
print v(xbgr.mr_n78688256)
print v(xbgr.mr_n78688368)
print v(xbgr.mr_n78688688)
print v(xbgr.mr_n78688800)
print v(xbgr.mr_n78689120)
print v(xbgr.mr_n78689232)
print v(xbgr.mr_n78689664)
print v(xbgr.mr_n78690416)
print v(xbgr.mr_n78691280)
print v(xbgr.mr_n78691712)
print v(xbgr.mr_n78691824)
print v(xbgr.mr_n78692144)
print v(xbgr.mr_n78692576)
print v(xbgr.mr_n78693440)
print v(xbgr.mr_n78694304)
print v(xbgr.mr_n78695168)
print v(xbgr.mr_n78696032)
print v(xbgr.mr_n78697328)
print v(xbgr.mr_n78698192)
print v(xbgr.mr_n78699168)
print v(xbgr.mr_n78699488)
print v(xbgr.mr_n78699600)
print v(xbgr.mr_n78700032)
print v(xbgr.mr_n78700352)
print v(xbgr.mr_n78701216)
print v(xbgr.mr_n78701328)
print v(xbgr.mr_n78701648)
print v(xbgr.mr_n78701760)
print v(xbgr.mr_n78702192)
print v(xbgr.mr_n78702512)
print v(xbgr.mr_n78702624)
print v(xbgr.mr_n78702944)
print v(xbgr.mr_n78703056)
print v(xbgr.mr_n78703376)
print v(xbgr.mr_n78703488)
print v(xbgr.mr_n78703808)
print v(xbgr.mr_n78703920)
print v(xbgr.mr_n78704352)
print v(xbgr.mr_n78704672)
print v(xbgr.mr_n78704784)
print v(xbgr.mr_n78705104)
print v(xbgr.mr_n78705216)
print v(xbgr.mr_n78705536)
print v(xbgr.mr_n78706400)
print v(xbgr.mr_n78706512)
print v(xbgr.mr_n78707264)
print v(xbgr.mr_n78707376)
print v(xbgr.mr_n78707696)
print v(xbgr.mr_n78707808)
print v(xbgr.mr_n78708128)
print v(xbgr.mr_n78708240)
print v(xbgr.mr_n78708560)
print v(xbgr.mr_n78708672)
print v(xbgr.mr_n78708992)
print v(xbgr.mr_n78709104)
print v(xbgr.mr_n78709424)
print v(xbgr.mr_n78709536)
print v(xbgr.mr_n78709856)
print v(xbgr.mr_n78709968)
print v(xbgr.mr_n78710288)
print v(xbgr.mr_n78710400)
print v(xbgr.mr_n78710720)
print v(xbgr.mr_n78710832)
print v(xbgr.mr_n78711152)
print v(xbgr.mr_n78711264)
print v(xbgr.mr_n78711584)
print v(xbgr.mr_n78711696)
print v(xbgr.mr_n78712016)
print v(xbgr.mr_n78712128)
print v(xbgr.mr_n78712448)
print v(xbgr.mr_n78712560)
print v(xbgr.mr_n78712992)
print v(xbgr.mr_n78713312)
print v(xbgr.mr_n78713424)
print v(xbgr.mr_n78713856)
print v(xbgr.mr_n78714176)
print v(xbgr.mr_n78714288)
print v(xbgr.mr_n78714720)
print v(xbgr.mr_n78715040)
print v(xbgr.mr_n78715904)
print v(xbgr.mr_n78716768)
print v(xbgr.mr_n78717632)
print v(xbgr.mr_n78718496)
print v(xbgr.mr_n78719360)
print v(xbgr.mr_n78720224)
print v(xbgr.mr_n78720336)
print v(xbgr.mr_n78720656)
print v(xbgr.mr_n78720768)
print v(xbgr.mr_n78721088)
print v(xbgr.mr_n78721200)
print v(xbgr.mr_n78721520)
print v(xbgr.mr_n78721632)
print v(xbgr.mr_n78721952)
print v(xbgr.mr_n78722816)
print v(xbgr.mr_n78723680)
print v(xbgr.mr_n78724544)
print v(xbgr.mr_n78724656)
print v(xbgr.mr_n78724976)
print v(xbgr.mr_n78725088)
print v(xbgr.mr_n78725408)
print v(xbgr.mr_n78725520)
print v(xbgr.mr_n78725952)
print v(xbgr.mr_n78726384)
print v(xbgr.mr_n78726816)
print v(xbgr.mr_n78727136)
print v(xbgr.mr_n78727248)
print v(xbgr.mr_n78727568)
print v(xbgr.mr_n78727680)
print v(xbgr.mr_n78728000)
print v(xbgr.mr_n78728112)
print v(xbgr.mr_n78728432)
print v(xbgr.mr_n78728544)
print v(xbgr.mr_n78728864)
print v(xbgr.mr_n78728976)
print v(xbgr.mr_n78729296)
print v(xbgr.mr_n78729408)
print v(xbgr.mr_n78729728)
print v(xbgr.mr_n78729840)
print v(xbgr.mr_n78730272)
print v(xbgr.mr_n78730592)
print v(xbgr.mr_n78730704)
print v(xbgr.mr_n78731136)
print v(xbgr.mr_n78731456)
print v(xbgr.mr_n78731568)
print v(xbgr.mr_n78732000)
print v(xbgr.mr_n78732320)
print v(xbgr.mr_n78733184)
print v(xbgr.mr_n78734048)
print v(xbgr.mr_n78734912)
print v(xbgr.mr_n78735776)
print v(xbgr.mr_n78736640)
print v(xbgr.mr_n78737504)
print v(xbgr.mr_n78737616)
print v(xbgr.mr_n78737936)
print v(xbgr.mr_n78738048)
print v(xbgr.mr_n78738368)
print v(xbgr.mr_n78738480)
print v(xbgr.mr_n78738800)
print v(xbgr.mr_n78738912)
print v(xbgr.mr_n78739232)
print v(xbgr.mr_n78740096)
print v(xbgr.mr_n78740960)
print v(xbgr.mr_n78741824)
print v(xbgr.mr_n78741936)
print v(xbgr.mr_n78742256)
print v(xbgr.mr_n78742368)
print v(xbgr.mr_n78742688)
print v(xbgr.mr_n78742800)
print v(xbgr.mr_n78743232)
print v(xbgr.mr_n78743552)
print v(xbgr.mr_n78743664)
print v(xbgr.mr_n78744096)
print v(xbgr.mr_n78744416)
print v(xbgr.mr_n78744528)
print v(xbgr.mr_n78744960)
print v(xbgr.mr_n78745280)
print v(xbgr.mr_n78745392)
print v(xbgr.mr_n78745712)
print v(xbgr.mr_n78745824)
print v(xbgr.mr_n78746144)
print v(xbgr.mr_n78746256)
print v(xbgr.mr_n78746688)
print v(xbgr.mr_n78747008)
print v(xbgr.mr_n78747872)
print v(xbgr.mr_n78748736)
print v(xbgr.mr_n78749600)
print v(xbgr.mr_n78749712)
print v(xbgr.mr_n78750032)
print v(xbgr.mr_n78750144)
print v(xbgr.mr_n78750464)
print v(xbgr.mr_n78751328)
print v(xbgr.mr_n78752192)
print v(xbgr.mr_n78753056)
print v(xbgr.mr_n78753920)
print v(xbgr.mr_n78754032)
print v(xbgr.mr_n78754352)
print v(xbgr.mr_n78754464)
print v(xbgr.mr_n78754784)
print v(xbgr.mr_n78755648)
print v(xbgr.mr_n78756192)
print v(xbgr.mr_n78756512)
print v(xbgr.mr_n78756624)
print v(xbgr.mr_n78756944)
print v(xbgr.mr_n78757056)
print v(xbgr.mr_n78757376)
print v(xbgr.mr_n78757488)
print v(xbgr.mr_n78757808)
print v(xbgr.mr_n78757920)
print v(xbgr.mr_n78758352)
print v(xbgr.mr_n78759104)
print v(xbgr.mr_n78759968)
print v(xbgr.mr_n78760832)
print v(xbgr.mr_n78761696)
print v(xbgr.mr_n78761808)
print v(xbgr.mr_n78762128)
print v(xbgr.mr_n78762240)
print v(xbgr.mr_n78762560)
print v(xbgr.mr_n78762672)
print v(xbgr.mr_n78762992)
print v(xbgr.mr_n78763104)
print v(xbgr.mr_n78763424)
print v(xbgr.mr_n78763536)
print v(xbgr.mr_n78763856)
print v(xbgr.mr_n78763968)
print v(xbgr.mr_n78764288)
print v(xbgr.mr_n78764400)
print v(xbgr.mr_n78764832)
print v(xbgr.mr_n78765152)
print v(xbgr.mr_n78765264)
print v(xbgr.mr_n78765584)
print v(xbgr.mr_n78765696)
print v(xbgr.mr_n78766016)
print v(xbgr.mr_n78766128)
print v(xbgr.mr_n78766448)
print v(xbgr.mr_n78766560)
print v(xbgr.mr_n78766880)
print v(xbgr.mr_n78766992)
print v(xbgr.mr_n78767424)
print v(xbgr.mr_n78767744)
print v(xbgr.mr_n78768608)
print v(xbgr.mr_n78768720)
print v(xbgr.mr_n78769040)
print v(xbgr.mr_n78769152)
print v(xbgr.mr_n78769584)
print v(xbgr.mr_n78770016)
print v(xbgr.mr_n78770336)
print v(xbgr.mr_n78770448)
print v(xbgr.mr_n78770768)
print v(xbgr.mr_n78770880)
print v(xbgr.mr_n78771200)
print v(xbgr.mr_n78771312)
print v(xbgr.mr_n78771632)
print v(xbgr.mr_n78771744)
print v(xbgr.mr_n78772064)
print v(xbgr.mr_n78772176)
print v(xbgr.mr_n78772608)
print v(xbgr.mr_n78772928)
print v(xbgr.mr_n78773040)
print v(xbgr.mr_n78773472)
print v(xbgr.mr_n78773792)
print v(xbgr.mr_n78774656)
print v(xbgr.mr_n78775520)
print v(xbgr.mr_n78776384)
print v(xbgr.mr_n78777248)
print v(xbgr.mr_n78777360)
print v(xbgr.mr_n78777680)
print v(xbgr.mr_n78777792)
print v(xbgr.mr_n78778112)
print v(xbgr.mr_n78778224)
print v(xbgr.mr_n78778544)
print v(xbgr.mr_n78778656)
print v(xbgr.mr_n78778976)
print v(xbgr.mr_n78779840)
print v(xbgr.mr_n78780704)
print v(xbgr.mr_n78780816)
print v(xbgr.mr_n78781136)
print v(xbgr.mr_n78781248)
print v(xbgr.mr_n78781680)
print v(xbgr.mr_n78782112)
print v(xbgr.mr_n78782432)
print v(xbgr.mr_n78782544)
print v(xbgr.mr_n78782864)
print v(xbgr.mr_n78782976)
print v(xbgr.mr_n78783296)
print v(xbgr.mr_n78783408)
print v(xbgr.mr_n78783728)
print v(xbgr.mr_n78783840)
print v(xbgr.mr_n78784160)
print v(xbgr.mr_n78785024)
print v(xbgr.mr_n78785888)
print v(xbgr.mr_n78786752)
print v(xbgr.mr_n78787616)
print v(xbgr.mr_n78788480)
print v(xbgr.mr_n78788592)
print v(xbgr.mr_n78789024)
print v(xbgr.mr_n78789344)
print v(xbgr.mr_n78789456)
print v(xbgr.mr_n78789888)
print v(xbgr.mr_n78790208)
print v(xbgr.mr_n78790320)
print v(xbgr.mr_n78790752)
print v(xbgr.mr_n78791072)
print v(xbgr.mr_n78791184)
print v(xbgr.mr_n78791504)
print v(xbgr.mr_n78791616)
print v(xbgr.mr_n78791936)
print v(xbgr.mr_n78792048)
print v(xbgr.mr_n78792368)
print v(xbgr.mr_n78792480)
print v(xbgr.mr_n78792800)
print v(xbgr.mr_n78792912)
print v(xbgr.mr_n78793232)
print v(xbgr.mr_n78793344)
print v(xbgr.mr_n78793664)
print v(xbgr.mr_n78793776)
print v(xbgr.mr_n78794096)
print v(xbgr.mr_n78794208)
print v(xbgr.mr_n78794528)
print v(xbgr.mr_n78794640)
print v(xbgr.mr_n78794960)
print v(xbgr.mr_n78795072)
print v(xbgr.mr_n78795392)
print v(xbgr.mr_n78795504)
print v(xbgr.mr_n78795824)
print v(xbgr.mr_n78795936)
print v(xbgr.mr_n78796256)
print v(xbgr.mr_n78797120)
print v(xbgr.mr_n78797984)
print v(xbgr.mr_n78798848)
print v(xbgr.mr_n78798960)
print v(xbgr.mr_n78799392)
print v(xbgr.mr_n78799712)
print v(xbgr.mr_n78799824)
print v(xbgr.mr_n78800144)
print v(xbgr.mr_n78800256)
print v(xbgr.mr_n78800576)
print v(xbgr.mr_n78800688)
print v(xbgr.mr_n78801008)
print v(xbgr.mr_n78801120)
print v(xbgr.mr_n78801552)
print v(xbgr.mr_n78801984)
print v(xbgr.mr_n78802416)
print v(xbgr.mr_n78802848)
print v(xbgr.mr_n78803168)
print v(xbgr.mr_n78803280)
print v(xbgr.mr_n78803712)
print v(xbgr.mr_n78804032)
print v(xbgr.mr_n78804896)
print v(xbgr.mr_n78805008)
print v(xbgr.mr_n78805328)
print v(xbgr.mr_n78805440)
print v(xbgr.mr_n78805760)
print v(xbgr.mr_n78805872)
print v(xbgr.mr_n78806192)
print v(xbgr.mr_n78807168)
print v(xbgr.mr_n78807600)
print v(xbgr.mr_n78808032)
print v(xbgr.mr_n78808352)
print v(xbgr.mr_n78809216)
print v(xbgr.mr_n78809328)
print v(xbgr.mr_n78809648)
print v(xbgr.mr_n78809760)
print v(xbgr.mr_n78810080)
print v(xbgr.mr_n78810192)
print v(xbgr.mr_n78810512)
print v(xbgr.mr_n78810624)
print v(xbgr.mr_n78810944)
print v(xbgr.mr_n78811056)
print v(xbgr.mr_n78811376)
print v(xbgr.mr_n78811488)
print v(xbgr.mr_n78811808)
print v(xbgr.mr_n78811920)
print v(xbgr.mr_n78812240)
print v(xbgr.mr_n78812352)
print v(xbgr.mr_n78812672)
print v(xbgr.mr_n78813536)
print v(xbgr.mr_n78814400)
print v(xbgr.mr_n78815264)
print v(xbgr.mr_n78816128)
print v(xbgr.mr_n78816992)
print v(xbgr.mr_n78817856)
print v(xbgr.mr_n78818720)
print v(xbgr.mr_n78819584)
print v(xbgr.mr_n78820448)
print v(xbgr.mr_n78821312)
print v(xbgr.mr_n78822176)
print v(xbgr.mr_n78823040)
print v(xbgr.mr_n78823152)
print v(xbgr.mr_n78823472)
print v(xbgr.mr_n78823584)
print v(xbgr.mr_n78823904)
print v(xbgr.mr_n78824016)
print v(xbgr.mr_n78824336)
print v(xbgr.mr_n78824448)
print v(xbgr.mr_n78824768)
print v(xbgr.mr_n78824880)
print v(xbgr.mr_n78825312)
print v(xbgr.mr_n78825632)
print v(xbgr.mr_n78825744)
print v(xbgr.mr_n78826176)
print v(xbgr.mr_n78826496)
print v(xbgr.mr_n78827360)
print v(xbgr.mr_n78828224)
print v(xbgr.mr_n78829088)
print v(xbgr.mr_n78829952)
print v(xbgr.mr_n78830064)
print v(xbgr.mr_n78830384)
print v(xbgr.mr_n78830496)
print v(xbgr.mr_n78830816)
print v(xbgr.mr_n78830928)
print v(xbgr.mr_n78831248)
print v(xbgr.mr_n78831360)
print v(xbgr.mr_n78831680)
print v(xbgr.mr_n78831792)
print v(xbgr.mr_n78832112)
print v(xbgr.mr_n78832224)
print v(xbgr.mr_n78832544)
print v(xbgr.mr_n78832656)
print v(xbgr.mr_n78832976)
print v(xbgr.mr_n78833840)
print v(xbgr.mr_n78834704)
print v(xbgr.mr_n78834816)
print v(xbgr.mr_n78835136)
print v(xbgr.mr_n78835248)
print v(xbgr.mr_n78835680)
print v(xbgr.mr_n78836112)
print v(xbgr.mr_n78836432)
print v(xbgr.mr_n78836544)
print v(xbgr.mr_n78836864)
print v(xbgr.mr_n78836976)
print v(xbgr.mr_n78837296)
print v(xbgr.mr_n78837408)
print v(xbgr.mr_n78837728)
print v(xbgr.mr_n78837840)
print v(xbgr.mr_n78838160)
print v(xbgr.mr_n78838272)
print v(xbgr.mr_n78838704)
print v(xbgr.mr_n78839024)
print v(xbgr.mr_n78839136)
print v(xbgr.mr_n78839568)
print v(xbgr.mr_n78839888)
print v(xbgr.mr_n78840000)
print v(xbgr.mr_n78840320)
print v(xbgr.mr_n78841184)
print v(xbgr.mr_n78842048)
print v(xbgr.mr_n78842912)
print v(xbgr.mr_n78843776)
print v(xbgr.mr_n78843888)
print v(xbgr.mr_n78844208)
print v(xbgr.mr_n78844320)
print v(xbgr.mr_n78844640)
print v(xbgr.mr_n78844752)
print v(xbgr.mr_n78845072)
print v(xbgr.mr_n78845184)
print v(xbgr.mr_n78845504)
print v(xbgr.mr_n78845616)
print v(xbgr.mr_n78845936)
print v(xbgr.mr_n78846048)
print v(xbgr.mr_n78846368)
print v(xbgr.mr_n78847232)
print v(xbgr.mr_n78848096)
print v(xbgr.mr_n78848208)
print v(xbgr.mr_n78848640)
print v(xbgr.mr_n78848960)
print v(xbgr.mr_n78849072)
print v(xbgr.mr_n78849392)
print v(xbgr.mr_n78849504)
print v(xbgr.mr_n78849824)
print v(xbgr.mr_n78849936)
print v(xbgr.mr_n78850256)
print v(xbgr.mr_n78850368)
print v(xbgr.mr_n78850688)
print v(xbgr.mr_n78850800)
print v(xbgr.mr_n78851120)
print v(xbgr.mr_n78851232)
print v(xbgr.mr_n78851664)
print v(xbgr.mr_n78852096)
print v(xbgr.mr_n78852528)
print v(xbgr.mr_n78852960)
print v(xbgr.mr_n78853280)
print v(xbgr.mr_n78853712)
print v(xbgr.mr_n78853824)
print v(xbgr.mr_n78854144)
print v(xbgr.mr_n78854256)
print v(xbgr.mr_n78854576)
print v(xbgr.mr_n78854688)
print v(xbgr.mr_n78855008)
print v(xbgr.mr_n78855120)
print v(xbgr.mr_n78855440)
print v(xbgr.mr_n78855552)
print v(xbgr.mr_n78855872)
print v(xbgr.mr_n78855984)
print v(xbgr.mr_n78856736)
print v(xbgr.mr_n78856848)
print v(xbgr.mr_n78857280)
print v(xbgr.mr_n78857600)
print v(xbgr.mr_n78858032)
print v(xbgr.mr_n78858144)
print v(xbgr.mr_n78858576)
print v(xbgr.mr_n78858896)
print v(xbgr.mr_n78859008)
print v(xbgr.mr_n78859440)
print v(xbgr.mr_n78859760)
print v(xbgr.mr_n78859872)
print v(xbgr.mr_n78860304)
print v(xbgr.mr_n78861056)
print v(xbgr.mr_n78861920)
print v(xbgr.mr_n78862784)
print v(xbgr.mr_n78863648)
print v(xbgr.mr_n78864512)
print v(xbgr.mr_n78865376)
print v(xbgr.mr_n78865488)
print v(xbgr.mr_n78865808)
print v(xbgr.mr_n78865920)
print v(xbgr.mr_n78866240)
print v(xbgr.mr_n78866352)
print v(xbgr.mr_n78866672)
print v(xbgr.mr_n78866784)
print v(xbgr.mr_n78867104)
print v(xbgr.mr_n78867968)
print v(xbgr.mr_n78868832)
print v(xbgr.mr_n78869696)
print v(xbgr.mr_n78869808)
print v(xbgr.mr_n78870128)
print v(xbgr.mr_n78870240)
print v(xbgr.mr_n78870560)
print v(xbgr.mr_n78870672)
print v(xbgr.mr_n78870992)
print v(xbgr.mr_n78871104)
print v(xbgr.mr_n78871424)
print v(xbgr.mr_n78871536)
print v(xbgr.mr_n78871856)
print v(xbgr.mr_n78871968)
print v(xbgr.mr_n78872288)
print v(xbgr.mr_n78872400)
print v(xbgr.mr_n78872720)
print v(xbgr.mr_n78872832)
print v(xbgr.mr_n78873152)
print v(xbgr.mr_n78874016)
print v(xbgr.mr_n78874448)
print v(xbgr.mr_n78875312)
print v(xbgr.mr_n78875744)
print v(xbgr.mr_n78876608)
print v(xbgr.mr_n78877472)
print v(xbgr.mr_n78878768)
print v(xbgr.mr_n78880064)
print v(xbgr.mr_n78880176)
print v(xbgr.mr_n78880496)
print v(xbgr.mr_n78880608)
print v(xbgr.mr_n78881040)
print v(xbgr.mr_n78881360)
print v(xbgr.mr_n78881472)
print v(xbgr.mr_n78881904)
print v(xbgr.mr_n78882224)
print v(xbgr.mr_n78882336)
print v(xbgr.mr_n78882656)
print v(xbgr.mr_n78882768)
print v(xbgr.mr_n78883088)
print v(xbgr.mr_n78883200)
print v(xbgr.mr_n78883632)
print v(xbgr.mr_n78883952)
print v(xbgr.mr_n78884064)
print v(xbgr.mr_n78884496)
print v(xbgr.mr_n78884816)
print v(xbgr.mr_n78884928)
print v(xbgr.mr_n78885360)
print v(xbgr.mr_n78885680)
print v(xbgr.mr_n78885792)
print v(xbgr.mr_n78886112)
print v(xbgr.mr_n78886544)
print v(xbgr.mr_n78886656)
print v(xbgr.mr_n78886976)
print v(xbgr.mr_n78887088)
print v(xbgr.mr_n78887408)
print v(xbgr.mr_n78887520)
print v(xbgr.mr_n78887840)
print v(xbgr.mr_n78887952)
print v(xbgr.mr_n78888704)
print v(xbgr.mr_n78889568)
print v(xbgr.mr_n78890432)
print v(xbgr.mr_n78890544)
print v(xbgr.mr_n78890864)
print v(xbgr.mr_n78890976)
print v(xbgr.mr_n78891296)
print v(xbgr.mr_n78891408)
print v(xbgr.mr_n78891728)
print v(xbgr.mr_n78891840)
print v(xbgr.mr_n78892592)
print v(xbgr.mr_n78893024)
print v(xbgr.mr_n78893888)
print v(xbgr.mr_n78895184)
print v(xbgr.mr_n78895616)
print v(xbgr.mr_n78896480)
print v(xbgr.mr_n78896592)
print v(xbgr.mr_n78896912)
print v(xbgr.mr_n78897024)
print v(xbgr.mr_n78897344)
print v(xbgr.mr_n78898208)
print v(xbgr.mr_n78898640)
print v(xbgr.mr_n78898752)
print v(xbgr.mr_n78899072)
print v(xbgr.mr_n78899936)
print v(xbgr.mr_n78900800)
print v(xbgr.mr_n78901664)
print v(xbgr.mr_n78902528)
print v(xbgr.mr_n78902640)
print v(xbgr.mr_n78902960)
print v(xbgr.mr_n78903072)
print v(xbgr.mr_n78903392)
print v(xbgr.mr_n78903504)
print v(xbgr.mr_n78903824)
print v(xbgr.mr_n78903936)
print v(xbgr.mr_n78904688)
print v(xbgr.mr_n78905552)
print v(xbgr.mr_n78906416)
print v(xbgr.mr_n78906528)
print v(xbgr.mr_n78906960)
print v(xbgr.mr_n78907392)
print v(xbgr.mr_n78907824)
print v(xbgr.mr_n78908144)
print v(xbgr.mr_n78908256)
print v(xbgr.mr_n78908576)
print v(xbgr.mr_n78908688)
print v(xbgr.mr_n78909008)
print v(xbgr.mr_n78909120)
print v(xbgr.mr_n78909440)
print v(xbgr.mr_n78909552)
print v(xbgr.mr_n78909872)
print v(xbgr.mr_n78909984)
print v(xbgr.mr_n78910304)
print v(xbgr.mr_n78910416)
print v(xbgr.mr_n78910736)
print v(xbgr.mr_n78910848)
print v(xbgr.mr_n78911168)
print v(xbgr.mr_n78911280)
print v(xbgr.mr_n78912464)
print v(xbgr.mr_n78913008)
print v(xbgr.mr_n78913440)
print v(xbgr.mr_n78913872)
print v(xbgr.mr_n78914624)
print v(xbgr.mr_n78914736)
print v(xbgr.mr_n78915056)
print v(xbgr.mr_n78915168)
print v(xbgr.mr_n78915488)
print v(xbgr.mr_n78915600)
print v(xbgr.mr_n78915920)
print v(xbgr.mr_n78916032)
print v(xbgr.mr_n78916352)
print v(xbgr.mr_n78916464)
print v(xbgr.mr_n78916784)
print v(xbgr.mr_n78916896)
print v(xbgr.mr_n78917328)
print v(xbgr.mr_n78917648)
print v(xbgr.mr_n78917760)
print v(xbgr.mr_n78918080)
print v(xbgr.mr_n78918192)
print v(xbgr.mr_n78918624)
print v(xbgr.mr_n78918944)
print v(xbgr.mr_n78919056)
print v(xbgr.mr_n78919376)
print v(xbgr.mr_n78919488)
print v(xbgr.mr_n78919808)
print v(xbgr.mr_n78919920)
print v(xbgr.mr_n78920240)
print v(xbgr.mr_n78920352)
print v(xbgr.mr_n78920672)
print v(xbgr.mr_n78920784)
print v(xbgr.mr_n78921104)
print v(xbgr.mr_n78921216)
print v(xbgr.mr_n78921536)
print v(xbgr.mr_n78922400)
print v(xbgr.mr_n78922944)
print v(xbgr.mr_n78923264)
print v(xbgr.mr_n78923376)
print v(xbgr.mr_n78923808)
print v(xbgr.mr_n78924128)
print v(xbgr.mr_n78924240)
print v(xbgr.mr_n78924992)
print v(xbgr.mr_n78925856)
print v(xbgr.mr_n78925968)
print v(xbgr.mr_n78926288)
print v(xbgr.mr_n78926400)
print v(xbgr.mr_n78926720)
print v(xbgr.mr_n78926832)
print v(xbgr.mr_n78927152)
print v(xbgr.mr_n78927584)
print v(xbgr.mr_n78928448)
print v(xbgr.mr_n78929744)
print v(xbgr.mr_n78930720)
print v(xbgr.mr_n78931040)
print v(xbgr.mr_n78931152)
print v(xbgr.mr_n78931472)
print v(xbgr.mr_n78931584)
print v(xbgr.mr_n78931904)
print v(xbgr.mr_n78932768)
print v(xbgr.mr_n78932880)
print v(xbgr.mr_n78933200)
print v(xbgr.mr_n78933312)
print v(xbgr.mr_n78933632)
print v(xbgr.mr_n78933744)
print v(xbgr.mr_n78934064)
print v(xbgr.mr_n78934176)
print v(xbgr.mr_n78934496)
print v(xbgr.mr_n78934608)
print v(xbgr.mr_n78934928)
print v(xbgr.mr_n78935472)
print v(xbgr.mr_n78935792)
print v(xbgr.mr_n78937088)
print v(xbgr.mr_n78937952)
print v(xbgr.mr_n78938496)
print v(xbgr.mr_n78938928)
print v(xbgr.mr_n78939680)
print v(xbgr.mr_n78939792)
print v(xbgr.mr_n78940112)
print v(xbgr.mr_n78940224)
print v(xbgr.mr_n78940544)
print v(xbgr.mr_n78940656)
print v(xbgr.mr_n78940976)
print v(xbgr.mr_n78941088)
print v(xbgr.mr_n78941408)
print v(xbgr.mr_n78941520)
print v(xbgr.mr_n78941840)
print v(xbgr.mr_n78941952)
print v(xbgr.mr_n78942384)
print v(xbgr.mr_n78942704)
print v(xbgr.mr_n78942816)
print v(xbgr.mr_n78943136)
print v(xbgr.mr_n78943248)
print v(xbgr.mr_n78943568)
print v(xbgr.mr_n78943680)
print v(xbgr.mr_n78944000)
print v(xbgr.mr_n78944112)
print v(xbgr.mr_n78944432)
print v(xbgr.mr_n78944544)
print v(xbgr.mr_n78944864)
print v(xbgr.mr_n78944976)
print v(xbgr.mr_n78945296)
print v(xbgr.mr_n78945408)
print v(xbgr.mr_n78945728)
print v(xbgr.mr_n78945840)
print v(xbgr.mr_n78946272)
print v(xbgr.mr_n78946704)
print v(xbgr.mr_n78947136)
print v(xbgr.mr_n78947456)
print v(xbgr.mr_n78947568)
print v(xbgr.mr_n78947888)
print v(xbgr.mr_n78948000)
print v(xbgr.mr_n78948320)
print v(xbgr.mr_n78948432)
print v(xbgr.mr_n78948752)
print v(xbgr.mr_n78948864)
print v(xbgr.mr_n78949184)
print v(xbgr.mr_n78949296)
print v(xbgr.mr_n78949728)
print v(xbgr.mr_n78950048)
print v(xbgr.mr_n78950912)
print v(xbgr.mr_n78951776)
print v(xbgr.mr_n78951888)
print v(xbgr.mr_n78952208)
print v(xbgr.mr_n78952320)
print v(xbgr.mr_n78952640)
print v(xbgr.mr_n78952752)
print v(xbgr.mr_n78953072)
print v(xbgr.mr_n78953184)
print v(xbgr.mr_n78953504)
print v(xbgr.mr_n78954480)
print v(xbgr.mr_n78954800)
print v(xbgr.mr_n78954912)
print v(xbgr.mr_n78955232)
print v(xbgr.mr_n78955344)
print v(xbgr.mr_n78955664)
print v(xbgr.mr_n78955776)
print v(xbgr.mr_n78956096)
print v(xbgr.mr_n78956208)
print v(xbgr.mr_n78956528)
print v(xbgr.mr_n78956640)
print v(xbgr.mr_n78956960)
print v(xbgr.mr_n78957824)
print v(xbgr.mr_n78958688)
print v(xbgr.mr_n78959552)
print v(xbgr.mr_n78960416)
print v(xbgr.mr_n78960528)
print v(xbgr.mr_n78960848)
print v(xbgr.mr_n78960960)
print v(xbgr.mr_n78961280)
print v(xbgr.mr_n78962256)
print v(xbgr.mr_n78962688)
print v(xbgr.mr_n78963008)
print v(xbgr.mr_n78963872)
print v(xbgr.mr_n78964736)
print v(xbgr.mr_n78965600)
print v(xbgr.mr_n78966464)
print v(xbgr.mr_n78966576)
print v(xbgr.mr_n78967008)
print v(xbgr.mr_n78967328)
print v(xbgr.mr_n78967440)
print v(xbgr.mr_n78967760)
print v(xbgr.mr_n78967872)
print v(xbgr.mr_n78968192)
print v(xbgr.mr_n78968304)
print v(xbgr.mr_n78968736)
print v(xbgr.mr_n78969056)
print v(xbgr.mr_n78969168)
print v(xbgr.mr_n78969600)
print v(xbgr.mr_n78969920)
print v(xbgr.mr_n78970032)
print v(xbgr.mr_n78970352)
print v(xbgr.mr_n78970464)
print v(xbgr.mr_n78970784)
print v(xbgr.mr_n78970896)
print v(xbgr.mr_n78971216)
print v(xbgr.mr_n78971328)
print v(xbgr.mr_n78971648)
print v(xbgr.mr_n78971760)
print v(xbgr.mr_n78972080)
print v(xbgr.mr_n78972192)
print v(xbgr.mr_n78972624)
print v(xbgr.mr_n78972944)
print v(xbgr.mr_n78973808)
print v(xbgr.mr_n78974352)
print v(xbgr.mr_n78974672)
print v(xbgr.mr_n78974784)
print v(xbgr.mr_n78975104)
print v(xbgr.mr_n78975216)
print v(xbgr.mr_n78975536)
print v(xbgr.mr_n78975648)
print v(xbgr.mr_n78975968)
print v(xbgr.mr_n78976080)
print v(xbgr.mr_n78976400)
print v(xbgr.mr_n78976512)
print v(xbgr.mr_n78976832)
print v(xbgr.mr_n78976944)
print v(xbgr.mr_n78977376)
print v(xbgr.mr_n78977696)
print v(xbgr.mr_n78978560)
print v(xbgr.mr_n78978992)
print v(xbgr.mr_n78979856)
print v(xbgr.mr_n78980720)
print v(xbgr.mr_n78982128)
print v(xbgr.mr_n78982992)
print v(xbgr.mr_n78983424)
print v(xbgr.mr_n78983744)
print v(xbgr.mr_n78984608)
print v(xbgr.mr_n78984720)
print v(xbgr.mr_n78985040)
print v(xbgr.mr_n78985152)
print v(xbgr.mr_n78985472)
print v(xbgr.mr_n78985584)
print v(xbgr.mr_n78985904)
print v(xbgr.mr_n78986016)
print v(xbgr.mr_n78986336)
print v(xbgr.mr_n78986448)
print v(xbgr.mr_n78986768)
print v(xbgr.mr_n78986880)
print v(xbgr.mr_n78987200)
print v(xbgr.mr_n78987312)
print v(xbgr.mr_n78987632)
print v(xbgr.mr_n78988496)
print v(xbgr.mr_n78989472)
print v(xbgr.mr_n78989904)
print v(xbgr.mr_n78990336)
print v(xbgr.mr_n78990656)
print v(xbgr.mr_n78990768)
print v(xbgr.mr_n78991088)
print v(xbgr.mr_n78991200)
print v(xbgr.mr_n78991520)
print v(xbgr.mr_n78992384)
print v(xbgr.mr_n78993248)
print v(xbgr.mr_n78994112)
print v(xbgr.mr_n78994224)
print v(xbgr.mr_n78994544)
print v(xbgr.mr_n78994656)
print v(xbgr.mr_n78994976)
print v(xbgr.mr_n78995840)
print v(xbgr.mr_n78996704)
print v(xbgr.mr_n78997568)
print v(xbgr.mr_n78997680)
print v(xbgr.mr_n78998000)
print v(xbgr.mr_n78998112)
print v(xbgr.mr_n78998432)
print v(xbgr.mr_n78998544)
print v(xbgr.mr_n78998864)
print v(xbgr.mr_n78998976)
print v(xbgr.mr_n78999296)
print v(xbgr.mr_n79000160)
print v(xbgr.mr_n79001024)
print v(xbgr.mr_n79001136)
print v(xbgr.mr_n79001456)
print v(xbgr.mr_n79001568)
print v(xbgr.mr_n79001888)
print v(xbgr.mr_n79002000)
print v(xbgr.mr_n79002320)
print v(xbgr.mr_n79002432)
print v(xbgr.mr_n79002752)
print v(xbgr.mr_n79002864)
print v(xbgr.mr_n79003296)
print v(xbgr.mr_n79003616)
print v(xbgr.mr_n79003728)
print v(xbgr.mr_n79004048)
print v(xbgr.mr_n79004160)
print v(xbgr.mr_n79004480)
print v(xbgr.mr_n79004592)
print v(xbgr.mr_n79004912)
print v(xbgr.mr_n79005024)
print v(xbgr.mr_n79005344)
print v(xbgr.mr_n79006208)
print v(xbgr.mr_n79006320)
print v(xbgr.mr_n79006752)
print v(xbgr.mr_n79007072)
print v(xbgr.mr_n79007184)
print v(xbgr.mr_n79007504)
print v(xbgr.mr_n79007616)
print v(xbgr.mr_n79007936)
print v(xbgr.mr_n79008048)
print v(xbgr.mr_n79008368)
print v(xbgr.mr_n79008480)
print v(xbgr.mr_n79008800)
print v(xbgr.mr_n79008912)
print v(xbgr.mr_n79009232)
print v(xbgr.mr_n79009344)
print v(xbgr.mr_n79009664)
print v(xbgr.mr_n79010096)
print v(xbgr.mr_n79010208)
print v(xbgr.mr_n79010528)
print v(xbgr.mr_n79011072)
print v(xbgr.mr_n79011392)
print v(xbgr.mr_n79011504)
print v(xbgr.mr_n79011936)
print v(xbgr.mr_n79012368)
print v(xbgr.mr_n79012800)
print v(xbgr.mr_n79013232)
print v(xbgr.mr_n79013664)
print v(xbgr.mr_n79013984)
print v(xbgr.mr_n79014096)
print v(xbgr.mr_n79014528)
print v(xbgr.mr_n79014848)
print v(xbgr.mr_n79014960)
print v(xbgr.mr_n79015392)
print v(xbgr.mr_n79015712)
print v(xbgr.mr_n79016576)
print v(xbgr.mr_n79017872)
print v(xbgr.mr_n79018416)
print v(xbgr.mr_n79018736)
print v(xbgr.mr_n79019280)
print v(xbgr.mr_n79019600)
print v(xbgr.mr_n79019712)
print v(xbgr.mr_n79020464)
print v(xbgr.mr_n79020896)
print v(xbgr.mr_n79021760)
print v(xbgr.mr_n79022624)
print v(xbgr.mr_n79023920)
print v(xbgr.mr_n79024784)
print v(xbgr.mr_n79025216)
print v(xbgr.mr_n79025328)
print v(xbgr.mr_n79026080)
print v(xbgr.mr_n79026192)
print v(xbgr.mr_n79026512)
print v(xbgr.mr_n79026624)
print v(xbgr.mr_n79026944)
print v(xbgr.mr_n79027056)
print v(xbgr.mr_n79027808)
print v(xbgr.mr_n79029104)
print v(xbgr.mr_n79029968)
print v(xbgr.mr_n79030832)
print v(xbgr.mr_n79031264)
print v(xbgr.mr_n79031376)
print v(xbgr.mr_n79031696)
print v(xbgr.mr_n79031808)
print v(xbgr.mr_n79032128)
print v(xbgr.mr_n79032240)
print v(xbgr.mr_n79032560)
print v(xbgr.mr_n79032672)
print v(xbgr.mr_n79033424)
print v(xbgr.mr_n79033536)
print v(xbgr.mr_n79033856)
print v(xbgr.mr_n79033968)
print v(xbgr.mr_n79034288)
print v(xbgr.mr_n79034400)
print v(xbgr.mr_n79034720)
print v(xbgr.mr_n79035584)
print v(xbgr.mr_n79035696)
print v(xbgr.mr_n79036016)
print v(xbgr.mr_n79036128)
print v(xbgr.mr_n79036560)
print v(xbgr.mr_n79036880)
print v(xbgr.mr_n79036992)
print v(xbgr.mr_n79037312)
print v(xbgr.mr_n79037424)
print v(xbgr.mr_n79037744)
print v(xbgr.mr_n79037856)
print v(xbgr.mr_n79038288)
print v(xbgr.mr_n79038720)
print v(xbgr.mr_n79039040)
print v(xbgr.mr_n79039152)
print v(xbgr.mr_n79039472)
print v(xbgr.mr_n79039584)
print v(xbgr.mr_n79039904)
print v(xbgr.mr_n79040016)
print v(xbgr.mr_n79040448)
print v(xbgr.mr_n79040768)
print v(xbgr.mr_n79040880)
print v(xbgr.mr_n79041312)
print v(xbgr.mr_n79041632)
print v(xbgr.mr_n79041744)
print v(xbgr.mr_n79042064)
print v(xbgr.mr_n79042176)
print v(xbgr.mr_n79042496)
print v(xbgr.mr_n79042608)
print v(xbgr.mr_n79042928)
print v(xbgr.mr_n79043040)
print v(xbgr.mr_n79043360)
print v(xbgr.mr_n79044224)
print v(xbgr.mr_n79045088)
print v(xbgr.mr_n79045200)
print v(xbgr.mr_n79045520)
print v(xbgr.mr_n79046064)
print v(xbgr.mr_n79046384)
print v(xbgr.mr_n79046816)
print v(xbgr.mr_n79048112)
print v(xbgr.mr_n79049408)
print v(xbgr.mr_n79049520)
print v(xbgr.mr_n79049840)
print v(xbgr.mr_n79049952)
print v(xbgr.mr_n79050272)
print v(xbgr.mr_n79050384)
print v(xbgr.mr_n79050704)
print v(xbgr.mr_n79050816)
print v(xbgr.mr_n79051136)
print v(xbgr.mr_n79051248)
print v(xbgr.mr_n79051568)
print v(xbgr.mr_n79051680)
print v(xbgr.mr_n79052000)
print v(xbgr.mr_n79052112)
print v(xbgr.mr_n79052544)
print v(xbgr.mr_n79052864)
print v(xbgr.mr_n79053728)
print v(xbgr.mr_n79053840)
print v(xbgr.mr_n79054160)
print v(xbgr.mr_n79054272)
print v(xbgr.mr_n79054592)
print v(xbgr.mr_n79054704)
print v(xbgr.mr_n79055024)
print v(xbgr.mr_n79055136)
print v(xbgr.mr_n79055456)
print v(xbgr.mr_n79056320)
print v(xbgr.mr_n79057184)
print v(xbgr.mr_n79058048)
print v(xbgr.mr_n79058912)
print v(xbgr.mr_n79059776)
print v(xbgr.mr_n79059888)
print v(xbgr.mr_n79060208)
print v(xbgr.mr_n79060320)
print v(xbgr.mr_n79060640)
print v(xbgr.mr_n79060752)
print v(xbgr.mr_n79061072)
print v(xbgr.mr_n79061184)
print v(xbgr.mr_n79061504)
print v(xbgr.mr_n79061616)
print v(xbgr.mr_n79061936)
print v(xbgr.mr_n79062048)
print v(xbgr.mr_n79062368)
print v(xbgr.mr_n79062480)
print v(xbgr.mr_n79062800)
print v(xbgr.mr_n79062912)
print v(xbgr.mr_n79063232)
print v(xbgr.mr_n79063344)
print v(xbgr.mr_n79063664)
print v(xbgr.mr_n79063776)
print v(xbgr.mr_n79064208)
print v(xbgr.mr_n79064528)
print v(xbgr.mr_n79064640)
print v(xbgr.mr_n79064960)
print v(xbgr.mr_n79065072)
print v(xbgr.mr_n79065504)
print v(xbgr.mr_n79065824)
print v(xbgr.mr_n79065936)
print v(xbgr.mr_n79066368)
print v(xbgr.mr_n79066688)
print v(xbgr.mr_n79066800)
print v(xbgr.mr_n79067232)
print v(xbgr.mr_n79067664)
print v(xbgr.mr_n79067984)
print v(xbgr.mr_n79068096)
print v(xbgr.mr_n79068528)
print v(xbgr.mr_n79068848)
print v(xbgr.mr_n79068960)
print v(xbgr.mr_n79069280)
print v(xbgr.mr_n79069392)
print v(xbgr.mr_n79069712)
print v(xbgr.mr_n79069824)
print v(xbgr.mr_n79070144)
print v(xbgr.mr_n79070256)
print v(xbgr.mr_n79070576)
print v(xbgr.mr_n79070688)
print v(xbgr.mr_n79071008)
print v(xbgr.mr_n79071120)
print v(xbgr.mr_n79071440)
print v(xbgr.mr_n79071552)
print v(xbgr.mr_n79071872)
print v(xbgr.mr_n79071984)
print v(xbgr.mr_n79072304)
print v(xbgr.mr_n79073168)
print v(xbgr.mr_n79073280)
print v(xbgr.mr_n79073600)
print v(xbgr.mr_n79073712)
print v(xbgr.mr_n79074032)
print v(xbgr.mr_n79074896)
print v(xbgr.mr_n79075760)
print v(xbgr.mr_n79076624)
print v(xbgr.mr_n79077488)
print v(xbgr.mr_n79078352)
print v(xbgr.mr_n79078464)
print v(xbgr.mr_n79078784)
print v(xbgr.mr_n79078896)
print v(xbgr.mr_n79079216)
print v(xbgr.mr_n79079328)
print v(xbgr.mr_n79079648)
print v(xbgr.mr_n79080512)
print v(xbgr.mr_n79081376)
print v(xbgr.mr_n79082240)
print v(xbgr.mr_n79083104)
print v(xbgr.mr_n79083968)
print v(xbgr.mr_n79084832)
print v(xbgr.mr_n79085696)
print v(xbgr.mr_n79085808)
print v(xbgr.mr_n79086128)
print v(xbgr.mr_n79086240)
print v(xbgr.mr_n79086672)
print v(xbgr.mr_n79086992)
print v(xbgr.mr_n79087856)
print v(xbgr.mr_n79088400)
print v(xbgr.mr_n79088832)
print v(xbgr.mr_n79089264)
print v(xbgr.mr_n79090016)
print v(xbgr.mr_n79090880)
print v(xbgr.mr_n79091744)
print v(xbgr.mr_n79091856)
print v(xbgr.mr_n79092176)
print v(xbgr.mr_n79092288)
print v(xbgr.mr_n79092720)
print v(xbgr.mr_n79093152)
print v(xbgr.mr_n79093472)
print v(xbgr.mr_n79094336)
print v(xbgr.mr_n79094448)
print v(xbgr.mr_n79094880)
print v(xbgr.mr_n79095200)
print v(xbgr.mr_n79095312)
print v(xbgr.mr_n79095744)
print v(xbgr.mr_n79096064)
print v(xbgr.mr_n79096928)
print v(xbgr.mr_n79097040)
print v(xbgr.mr_n79097360)
print v(xbgr.mr_n79098224)
print v(xbgr.mr_n79099088)
print v(xbgr.mr_n79099200)
print v(xbgr.mr_n79099520)
print v(xbgr.mr_n79099632)
print v(xbgr.mr_n79099952)
print v(xbgr.mr_n79100816)
print v(xbgr.mr_n79101248)
print v(xbgr.mr_n79101360)
print v(xbgr.mr_n79101792)
print v(xbgr.mr_n79102112)
print v(xbgr.mr_n79102224)
print v(xbgr.mr_n79102656)
print v(xbgr.mr_n79103408)
print v(xbgr.mr_n79103520)
print v(xbgr.mr_n79103840)
print v(xbgr.mr_n79103952)
print v(xbgr.mr_n79104272)
print v(xbgr.mr_n79104384)
print v(xbgr.mr_n79104704)
print v(xbgr.mr_n79105136)
print v(xbgr.mr_n79105248)
print v(xbgr.mr_n79106000)
print v(xbgr.mr_n79106432)
print v(xbgr.mr_n79106544)
print v(xbgr.mr_n79107408)
print v(xbgr.mr_n79107728)
print v(xbgr.mr_n79107840)
print v(xbgr.mr_n79108160)
print v(xbgr.mr_n79109024)
print v(xbgr.mr_n79109888)
print v(xbgr.mr_n79110752)
print v(xbgr.mr_n79111616)
print v(xbgr.mr_n79111728)
print v(xbgr.mr_n79112048)
print v(xbgr.mr_n79112160)
print v(xbgr.mr_n79112480)
print v(xbgr.mr_n79112592)
print v(xbgr.mr_n79112912)
print v(xbgr.mr_n79113024)
print v(xbgr.mr_n79113344)
print v(xbgr.mr_n79113456)
print v(xbgr.mr_n79113776)
print v(xbgr.mr_n79113888)
print v(xbgr.mr_n79114208)
print v(xbgr.mr_n79114320)
print v(xbgr.mr_n79114640)
print v(xbgr.mr_n79114752)
print v(xbgr.mr_n79115072)
print v(xbgr.mr_n79115184)
print v(xbgr.mr_n79115504)
print v(xbgr.mr_n79115616)
print v(xbgr.mr_n79116048)
print v(xbgr.mr_n79116480)
print v(xbgr.mr_n79116912)
print v(xbgr.mr_n79117232)
print v(xbgr.mr_n79117344)
print v(xbgr.mr_n79117664)
print v(xbgr.mr_n79118528)
print v(xbgr.mr_n79118640)
print v(xbgr.mr_n79118960)
print v(xbgr.mr_n79119072)
print v(xbgr.mr_n79119392)
print v(xbgr.mr_n79119504)
print v(xbgr.mr_n79119936)
print v(xbgr.mr_n79120256)
print v(xbgr.mr_n79120368)
print v(xbgr.mr_n79120688)
print v(xbgr.mr_n79120800)
print v(xbgr.mr_n79121232)
print v(xbgr.mr_n79121552)
print v(xbgr.mr_n79121984)
print v(xbgr.mr_n79122096)
print v(xbgr.mr_n79122416)
print v(xbgr.mr_n79122528)
print v(xbgr.mr_n79122848)
print v(xbgr.mr_n79122960)
print v(xbgr.mr_n79123280)
print v(xbgr.mr_n79123392)
print v(xbgr.mr_n79123824)
print v(xbgr.mr_n79124144)
print v(xbgr.mr_n79124256)
print v(xbgr.mr_n79124576)
print v(xbgr.mr_n79124688)
print v(xbgr.mr_n79125008)
print v(xbgr.mr_n79125120)
print v(xbgr.mr_n79125440)
print v(xbgr.mr_n79125552)
print v(xbgr.mr_n79125872)
print v(xbgr.mr_n79125984)
print v(xbgr.mr_n79126304)
print v(xbgr.mr_n79126416)
print v(xbgr.mr_n79126736)
print v(xbgr.mr_n79126848)
print v(xbgr.mr_n79127600)
print v(xbgr.mr_n79128032)
print v(xbgr.mr_n79128896)
print v(xbgr.mr_n79129008)
print v(xbgr.mr_n79129328)
print v(xbgr.mr_n79129872)
print v(xbgr.mr_n79130304)
print v(xbgr.mr_n79130736)
print v(xbgr.mr_n79131056)
print v(xbgr.mr_n79131488)
print v(xbgr.mr_n79132352)
print v(xbgr.mr_n79134512)
print v(xbgr.mr_n79135376)
print v(xbgr.mr_n79135488)
print v(xbgr.mr_n79135808)
print v(xbgr.mr_n79136672)
print v(xbgr.mr_n79137536)
print v(xbgr.mr_n79137648)
print v(xbgr.mr_n79137968)
print v(xbgr.mr_n79138080)
print v(xbgr.mr_n79138400)
print v(xbgr.mr_n79138512)
print v(xbgr.mr_n79138832)
print v(xbgr.mr_n79138944)
print v(xbgr.mr_n79139264)
print v(xbgr.mr_n79140128)
print v(xbgr.mr_n79140992)
print v(xbgr.mr_n79141104)
print v(xbgr.mr_n79141424)
print v(xbgr.mr_n79141536)
print v(xbgr.mr_n79141856)
print v(xbgr.mr_n79141968)
print v(xbgr.mr_n79142288)
print v(xbgr.mr_n79142400)
print v(xbgr.mr_n79142720)
print v(xbgr.mr_n79142832)
print v(xbgr.mr_n79143152)
print v(xbgr.mr_n79143264)
print v(xbgr.mr_n79143584)
print v(xbgr.mr_n79143696)
print v(xbgr.mr_n79144128)
print v(xbgr.mr_n79144448)
print v(xbgr.mr_n79144560)
print v(xbgr.mr_n79144992)
print v(xbgr.mr_n79145312)
print v(xbgr.mr_n79145856)
print v(xbgr.mr_n79146720)
print v(xbgr.mr_n79147040)
print v(xbgr.mr_n79147152)
print v(xbgr.mr_n79148336)
print v(xbgr.mr_n79148448)
print v(xbgr.mr_n79148768)
print v(xbgr.mr_n79148880)
print v(xbgr.mr_n79149200)
print v(xbgr.mr_n79149312)
print v(xbgr.mr_n79149632)
print v(xbgr.mr_n79149744)
print v(xbgr.mr_n79150064)
print v(xbgr.mr_n79150928)
print v(xbgr.mr_n79151792)
print v(xbgr.mr_n79151904)
print v(xbgr.mr_n79152336)
print v(xbgr.mr_n79152768)
print v(xbgr.mr_n79153200)
print v(xbgr.mr_n79153520)
print v(xbgr.mr_n79153632)
print v(xbgr.mr_n79153952)
print v(xbgr.mr_n79154064)
print v(xbgr.mr_n79154384)
print v(xbgr.mr_n79154496)
print v(xbgr.mr_n79154816)
print v(xbgr.mr_n79154928)
print v(xbgr.mr_n79155248)
print v(xbgr.mr_n79155360)
print v(xbgr.mr_n79155680)
print v(xbgr.mr_n79155792)
print v(xbgr.mr_n79156112)
print v(xbgr.mr_n79156976)
print v(xbgr.mr_n79157088)
print v(xbgr.mr_n79157408)
print v(xbgr.mr_n79157520)
print v(xbgr.mr_n79157840)
print v(xbgr.mr_n79157952)
print v(xbgr.mr_n79158272)
print v(xbgr.mr_n79158384)
print v(xbgr.mr_n79158704)
print v(xbgr.mr_n79159248)
print v(xbgr.mr_n79160000)
print v(xbgr.mr_n79160864)
print v(xbgr.mr_n79161728)
print v(xbgr.mr_n79162592)
print v(xbgr.mr_n79163456)
print v(xbgr.mr_n79164320)
print v(xbgr.mr_n79164432)
print v(xbgr.mr_n79164752)
print v(xbgr.mr_n79164864)
print v(xbgr.mr_n79165184)
print v(xbgr.mr_n79165296)
print v(xbgr.mr_n79165616)
print v(xbgr.mr_n79165728)
print v(xbgr.mr_n79166048)
print v(xbgr.mr_n79166160)
print v(xbgr.mr_n79166480)
print v(xbgr.mr_n79166592)
print v(xbgr.mr_n79166912)
print v(xbgr.mr_n79167776)
print v(xbgr.mr_n79168640)
print v(xbgr.mr_n79169504)
print v(xbgr.mr_n79170368)
print v(xbgr.mr_n79171232)
print v(xbgr.mr_n79172096)
print v(xbgr.mr_n79172960)
print v(xbgr.mr_n79173072)
print v(xbgr.mr_n79173392)
print v(xbgr.mr_n79173504)
print v(xbgr.mr_n79173824)
print v(xbgr.mr_n79173936)
print v(xbgr.mr_n79174256)
print v(xbgr.mr_n79174368)
print v(xbgr.mr_n79174688)
print v(xbgr.mr_n79174800)
print v(xbgr.mr_n79175120)
print v(xbgr.mr_n79175232)
print v(xbgr.mr_n79175552)
print v(xbgr.mr_n79175664)
print v(xbgr.mr_n79176096)
print v(xbgr.mr_n79176416)
print v(xbgr.mr_n79176528)
print v(xbgr.mr_n79176960)
print v(xbgr.mr_n79177280)
print v(xbgr.mr_n79177392)
print v(xbgr.mr_n79177824)
print v(xbgr.mr_n79178144)
print v(xbgr.mr_n79179008)
print v(xbgr.mr_n79179872)
print v(xbgr.mr_n79180736)
print v(xbgr.mr_n79181600)
print v(xbgr.mr_n79182464)
print v(xbgr.mr_n79183328)
print v(xbgr.mr_n79183440)
print v(xbgr.mr_n79183760)
print v(xbgr.mr_n79183872)
print v(xbgr.mr_n79184192)
print v(xbgr.mr_n79184304)
print v(xbgr.mr_n79184624)
print v(xbgr.mr_n79184736)
print v(xbgr.mr_n79185056)
print v(xbgr.mr_n79185920)
print v(xbgr.mr_n79186784)
print v(xbgr.mr_n79187648)
print v(xbgr.mr_n79187760)
print v(xbgr.mr_n79188192)
print v(xbgr.mr_n79188512)
print v(xbgr.mr_n79188624)
print v(xbgr.mr_n79188944)
print v(xbgr.mr_n79189056)
print v(xbgr.mr_n79189376)
print v(xbgr.mr_n79189488)
print v(xbgr.mr_n79189808)
print v(xbgr.mr_n79189920)
print v(xbgr.mr_n79190240)
print v(xbgr.mr_n79190352)
print v(xbgr.mr_n79190784)
print v(xbgr.mr_n79191104)
print v(xbgr.mr_n79191216)
print v(xbgr.mr_n79191648)
print v(xbgr.mr_n79191968)
print v(xbgr.mr_n79192080)
print v(xbgr.mr_n79192400)
print v(xbgr.mr_n79192512)
print v(xbgr.mr_n79192944)
print v(xbgr.mr_n79193376)
print v(xbgr.mr_n79193696)
print v(xbgr.mr_n79193808)
print v(xbgr.mr_n79194240)
print v(xbgr.mr_n79194560)
print v(xbgr.mr_n79194672)
print v(xbgr.mr_n79195104)
print v(xbgr.mr_n79195424)
print v(xbgr.mr_n79196288)
print v(xbgr.mr_n79197152)
print v(xbgr.mr_n79198016)
print v(xbgr.mr_n79198880)
print v(xbgr.mr_n79198992)
print v(xbgr.mr_n79199312)
print v(xbgr.mr_n79199424)
print v(xbgr.mr_n79199744)
print v(xbgr.mr_n79199856)
print v(xbgr.mr_n79200176)
print v(xbgr.mr_n79200288)
print v(xbgr.mr_n79200608)
print v(xbgr.mr_n79201472)
print v(xbgr.mr_n79202336)
print v(xbgr.mr_n79203200)
print v(xbgr.mr_n79204064)
print v(xbgr.mr_n79204928)
print v(xbgr.mr_n79205792)
print v(xbgr.mr_n79206656)
print v(xbgr.mr_n79207520)
print v(xbgr.mr_n79207632)
print v(xbgr.mr_n79207952)
print v(xbgr.mr_n79208064)
print v(xbgr.mr_n79208384)
print v(xbgr.mr_n79208496)
print v(xbgr.mr_n79208816)
print v(xbgr.mr_n79208928)
print v(xbgr.mr_n79209248)
print v(xbgr.mr_n79209360)
print v(xbgr.mr_n79209680)
print v(xbgr.mr_n79209792)
print v(xbgr.mr_n79210112)
print v(xbgr.mr_n79210224)
print v(xbgr.mr_n79210544)
print v(xbgr.mr_n79210656)
print v(xbgr.mr_n79210976)
print v(xbgr.mr_n79211088)
print v(xbgr.mr_n79211408)
print v(xbgr.mr_n79211520)
print v(xbgr.mr_n79211952)
print v(xbgr.mr_n79212272)
print v(xbgr.mr_n79212384)
print v(xbgr.mr_n79212704)
print v(xbgr.mr_n79212816)
print v(xbgr.mr_n79213136)
print v(xbgr.mr_n79213248)
print v(xbgr.mr_n79213568)
print v(xbgr.mr_n79213680)
print v(xbgr.mr_n79214000)
print v(xbgr.mr_n79214112)
print v(xbgr.mr_n79214544)
print v(xbgr.mr_n79214864)
print v(xbgr.mr_n79214976)
print v(xbgr.mr_n79215408)
print v(xbgr.mr_n79215728)
print v(xbgr.mr_n79215840)
print v(xbgr.mr_n79216160)
print v(xbgr.mr_n79217024)
print v(xbgr.mr_n79217888)
print v(xbgr.mr_n79218432)
print v(xbgr.mr_n79219184)
print v(xbgr.mr_n79219616)
print v(xbgr.mr_n79219728)
print v(xbgr.mr_n79220480)
print v(xbgr.mr_n79220592)
print v(xbgr.mr_n79221024)
print v(xbgr.mr_n79221456)
print v(xbgr.mr_n79221776)
print v(xbgr.mr_n79222640)
print v(xbgr.mr_n79223072)
print v(xbgr.mr_n79223936)
print v(xbgr.mr_n79224048)
print v(xbgr.mr_n79224800)
print v(xbgr.mr_n79226096)
print v(xbgr.mr_n79226960)
print v(xbgr.mr_n79227072)
print v(xbgr.mr_n79227392)
print v(xbgr.mr_n79227504)
print v(xbgr.mr_n79227824)
print v(xbgr.mr_n79227936)
print v(xbgr.mr_n79228256)
print v(xbgr.mr_n79228368)
print v(xbgr.mr_n79228688)
print v(xbgr.mr_n79229552)
print v(xbgr.mr_n79230416)
print v(xbgr.mr_n79231280)
print v(xbgr.mr_n79231392)
print v(xbgr.mr_n79231712)
print v(xbgr.mr_n79231824)
print v(xbgr.mr_n79232144)
print v(xbgr.mr_n79233008)
print v(xbgr.mr_n79233120)
print v(xbgr.mr_n79233440)
print v(xbgr.mr_n79233552)
print v(xbgr.mr_n79233872)
print v(xbgr.mr_n79233984)
print v(xbgr.mr_n79234304)
print v(xbgr.mr_n79234416)
print v(xbgr.mr_n79234736)
print v(xbgr.mr_n79235600)
print v(xbgr.mr_n79236464)
print v(xbgr.mr_n79236576)
print v(xbgr.mr_n79236896)
print v(xbgr.mr_n79237008)
print v(xbgr.mr_n79237328)
print v(xbgr.mr_n79237440)
print v(xbgr.mr_n79237760)
print v(xbgr.mr_n79237872)
print v(xbgr.mr_n79238192)
print v(xbgr.mr_n79238304)
print v(xbgr.mr_n79238624)
print v(xbgr.mr_n79238736)
print v(xbgr.mr_n79239488)
print v(xbgr.mr_n79240352)
print v(xbgr.mr_n79241216)
print v(xbgr.mr_n79241328)
print v(xbgr.mr_n79241648)
print v(xbgr.mr_n79241760)
print v(xbgr.mr_n79242080)
print v(xbgr.mr_n79242192)
print v(xbgr.mr_n79242512)
print v(xbgr.mr_n79242624)
print v(xbgr.mr_n79243056)
print v(xbgr.mr_n79243376)
print v(xbgr.mr_n79243488)
print v(xbgr.mr_n79244240)
print v(xbgr.mr_n79245104)
print v(xbgr.mr_n79245968)
print v(xbgr.mr_n79246832)
print v(xbgr.mr_n79246944)
print v(xbgr.mr_n79247264)
print v(xbgr.mr_n79247376)
print v(xbgr.mr_n79247696)
print v(xbgr.mr_n79247808)
print v(xbgr.mr_n79248128)
print v(xbgr.mr_n79248240)
print v(xbgr.mr_n79248560)
print v(xbgr.mr_n79249424)
print v(xbgr.mr_n79250720)
print v(xbgr.mr_n79250832)
print v(xbgr.mr_n79251152)
print v(xbgr.mr_n79251264)
print v(xbgr.mr_n79251696)
print v(xbgr.mr_n79252016)
print v(xbgr.mr_n79252128)
print v(xbgr.mr_n79252560)
print v(xbgr.mr_n79252880)
print v(xbgr.mr_n79253312)
print v(xbgr.mr_n79254176)
print v(xbgr.mr_n79255040)
print v(xbgr.mr_n79255152)
print v(xbgr.mr_n79255472)
print v(xbgr.mr_n79255584)
print v(xbgr.mr_n79256016)
print v(xbgr.mr_n79256336)
print v(xbgr.mr_n79256448)
print v(xbgr.mr_n79256768)
print v(xbgr.mr_n79256880)
print v(xbgr.mr_n79257200)
print v(xbgr.mr_n79257312)
print v(xbgr.mr_n79257632)
print v(xbgr.mr_n79257744)
print v(xbgr.mr_n79258176)
print v(xbgr.mr_n79258608)
print v(xbgr.mr_n79259040)
print v(xbgr.mr_n79259472)
print v(xbgr.mr_n79259792)
print v(xbgr.mr_n79259904)
print v(xbgr.mr_n79260336)
print v(xbgr.mr_n79260656)
print v(xbgr.mr_n79261520)
print v(xbgr.mr_n79262384)
print v(xbgr.mr_n79262816)
print v(xbgr.mr_n79263680)
print v(xbgr.mr_n79264112)
print v(xbgr.mr_n79264224)
print v(xbgr.mr_n79264976)
print v(xbgr.mr_n79265840)
print v(xbgr.mr_n79266704)
print v(xbgr.mr_n79266816)
print v(xbgr.mr_n79267248)
print v(xbgr.mr_n79267568)
print v(xbgr.mr_n79268432)
print v(xbgr.mr_n79268544)
print v(xbgr.mr_n79268864)
print v(xbgr.mr_n79268976)
print v(xbgr.mr_n79269296)
print v(xbgr.mr_n79269408)
print v(xbgr.mr_n79269728)
print v(xbgr.mr_n79269840)
print v(xbgr.mr_n79270160)
print v(xbgr.mr_n79270272)
print v(xbgr.mr_n79270592)
print v(xbgr.mr_n79270704)
print v(xbgr.mr_n79271024)
print v(xbgr.mr_n79271136)
print v(xbgr.mr_n79271456)
print v(xbgr.mr_n79271568)
print v(xbgr.mr_n79271888)
print v(xbgr.mr_n79272000)
print v(xbgr.mr_n79272320)
print v(xbgr.mr_n79272432)
print v(xbgr.mr_n79273184)
print v(xbgr.mr_n79274480)
print v(xbgr.mr_n79275344)
print v(xbgr.mr_n79276640)
print v(xbgr.mr_n79276752)
print v(xbgr.mr_n79277072)
print v(xbgr.mr_n79277184)
print v(xbgr.mr_n79277504)
print v(xbgr.mr_n79277616)
print v(xbgr.mr_n79277936)
print v(xbgr.mr_n79278048)
print v(xbgr.mr_n79278800)
print v(xbgr.mr_n79279664)
print v(xbgr.mr_n79280528)
print v(xbgr.mr_n79281392)
print v(xbgr.mr_n79281504)
print v(xbgr.mr_n79281824)
print v(xbgr.mr_n79281936)
print v(xbgr.mr_n79282256)
print v(xbgr.mr_n79282368)
print v(xbgr.mr_n79282688)
print v(xbgr.mr_n79282800)
print v(xbgr.mr_n79283120)
print v(xbgr.mr_n79283232)
print v(xbgr.mr_n79283552)
print v(xbgr.mr_n79284096)
print v(xbgr.mr_n79284848)
print v(xbgr.mr_n79285712)
print v(xbgr.mr_n79285824)
print v(xbgr.mr_n79286144)
print v(xbgr.mr_n79286256)
print v(xbgr.mr_n79286688)
print v(xbgr.mr_n79287008)
print v(xbgr.mr_n79287120)
print v(xbgr.mr_n79287440)
print v(xbgr.mr_n79287552)
print v(xbgr.mr_n79287872)
print v(xbgr.mr_n79287984)
print v(xbgr.mr_n79288304)
print v(xbgr.mr_n79288416)
print v(xbgr.mr_n79288736)
print v(xbgr.mr_n79289168)
print v(xbgr.mr_n79289280)
print v(xbgr.mr_n79289600)
print v(xbgr.mr_n79289712)
print v(xbgr.mr_n79290464)
print v(xbgr.mr_n79290576)
print v(xbgr.mr_n79290896)
print v(xbgr.mr_n79291008)
print v(xbgr.mr_n79291760)
print v(xbgr.mr_n79292624)
print v(xbgr.mr_n79292736)
print v(xbgr.mr_n79293056)
print v(xbgr.mr_n79293920)
print v(xbgr.mr_n79294464)
print v(xbgr.mr_n79294784)
print v(xbgr.mr_n79295328)
print v(xbgr.mr_n79295760)
print v(xbgr.mr_n79296080)
print v(xbgr.mr_n79296192)
print v(xbgr.mr_n79296944)
print v(xbgr.mr_n79297056)
print v(xbgr.mr_n79297376)
print v(xbgr.mr_n79297488)
print v(xbgr.mr_n79297808)
print v(xbgr.mr_n79298672)
print v(xbgr.mr_n79299104)
print v(xbgr.mr_n79299216)
print v(xbgr.mr_n79299536)
print v(xbgr.mr_n79299648)
print v(xbgr.mr_n79299968)
print v(xbgr.mr_n79300080)
print v(xbgr.mr_n79300400)
print v(xbgr.mr_n79300512)
print v(xbgr.mr_n79300832)
print v(xbgr.mr_n79300944)
print v(xbgr.mr_n79302128)
print v(xbgr.mr_n79302240)
print v(xbgr.mr_n79302560)
print v(xbgr.mr_n79302672)
print v(xbgr.mr_n79302992)
print v(xbgr.mr_n79303104)
print v(xbgr.mr_n79303424)
print v(xbgr.mr_n79303856)
print v(xbgr.mr_n79436240)
print v(xbgr.mr_n79436352)
print v(xbgr.mr_n79436672)
print v(xbgr.mr_n79436784)
print v(xbgr.mr_n79437104)
print v(xbgr.mr_n79437216)
print v(xbgr.mr_n79437536)
print v(xbgr.mr_n79437648)
print v(xbgr.mr_n79437968)
print v(xbgr.mr_n79438080)
print v(xbgr.mr_n79438400)
print v(xbgr.mr_n79438512)
print v(xbgr.mr_n79438832)
print v(xbgr.mr_n79438944)
print v(xbgr.mr_n79439264)
print v(xbgr.mr_n79439376)
print v(xbgr.mr_n79439696)
print v(xbgr.mr_n79439808)
print v(xbgr.mr_n79440128)
print v(xbgr.mr_n79440240)
print v(xbgr.mr_n79440560)
print v(xbgr.mr_n79440672)
print v(xbgr.mr_n79440992)
print v(xbgr.mr_n79441104)
print v(xbgr.mr_n79441424)
print v(xbgr.mr_n79441536)
print v(xbgr.mr_n79441856)
print v(xbgr.mr_n79441968)
print v(xbgr.mr_n79442288)
print v(xbgr.mr_n79442400)
print v(xbgr.mr_n79442720)
print v(xbgr.mr_n79442832)
print v(xbgr.mr_n79443152)
print v(xbgr.mr_n79443264)
print v(xbgr.mr_n79443584)
print v(xbgr.mr_n79443696)
print v(xbgr.mr_n79444016)
print v(xbgr.mr_n79444128)
print v(xbgr.mr_n79444448)
print v(xbgr.mr_n79444560)
print v(xbgr.mr_n79444880)
print v(xbgr.mr_n79444992)
print v(xbgr.mr_n79445312)
print v(xbgr.mr_n79445424)
print v(xbgr.mr_n79445744)
print v(xbgr.mr_n79445856)
print v(xbgr.mr_n79446176)
print v(xbgr.mr_n79446288)
print v(xbgr.mr_n79446608)
print v(xbgr.mr_n79446720)
print v(xbgr.mr_n79447040)
print v(xbgr.mr_n79447152)
print v(xbgr.mr_n79447472)
print v(xbgr.mr_n79447584)
print v(xbgr.mr_n79447904)
print v(xbgr.mr_n79448016)
print v(xbgr.mr_n79448336)
print v(xbgr.mr_n79448448)
print v(xbgr.mr_n79448768)
print v(xbgr.mr_n79448880)
print v(xbgr.mr_n79449200)
print v(xbgr.mr_n79449312)
print v(xbgr.mr_n79449632)
print v(xbgr.mr_n79449744)
print v(xbgr.mr_n79450064)
print v(xbgr.mr_n79450176)
print v(xbgr.mr_n79450496)
print v(xbgr.mr_n79450608)
print v(xbgr.mr_n79450928)
print v(xbgr.mr_n79451040)
print v(xbgr.mr_n79451360)
print v(xbgr.mr_n79451472)
print v(xbgr.mr_n79451792)
print v(xbgr.mr_n79451904)
print v(xbgr.mr_n79452224)
print v(xbgr.mr_n79452336)
print v(xbgr.mr_n79452656)
print v(xbgr.mr_n79452768)
print v(xbgr.mr_n79453088)
print v(xbgr.mr_n79453200)
print v(xbgr.mr_n79453520)
print v(xbgr.mr_n79453632)
print v(xbgr.mr_n79453952)
print v(xbgr.mr_n79454064)
print v(xbgr.mr_n79454384)
print v(xbgr.mr_n79454496)
print v(xbgr.mr_n79454816)
print v(xbgr.mr_n79454928)
print v(xbgr.mr_n79455248)
print v(xbgr.mr_n79455360)
print v(xbgr.mr_n79455680)
print v(xbgr.mr_n79455792)
print v(xbgr.mr_n79456112)
print v(xbgr.mr_n79456224)
print v(xbgr.mr_n79456544)
print v(xbgr.mr_n79456656)
print v(xbgr.mr_n79456976)
print v(xbgr.mr_n79457088)
print v(xbgr.mr_n79457408)
print v(xbgr.mr_n79457520)
print v(xbgr.mr_n79457840)
print v(xbgr.mr_n79457952)
print v(xbgr.mr_n79458272)
print v(xbgr.mr_n79458384)
print v(xbgr.mr_n79458704)
print v(xbgr.mr_n79458816)
print v(xbgr.mr_n79459136)
print v(xbgr.mr_n79459248)
print v(xbgr.mr_n79459568)
print v(xbgr.mr_n79459680)
print v(xbgr.mr_n79460000)
print v(xbgr.mr_n79460112)
print v(xbgr.mr_n79460432)
print v(xbgr.mr_n79460544)
print v(xbgr.mr_n79460864)
print v(xbgr.mr_n79460976)
print v(xbgr.mr_n79461296)
print v(xbgr.mr_n79461408)
print v(xbgr.mr_n79461728)
print v(xbgr.mr_n79461840)
print v(xbgr.mr_n79462160)
print v(xbgr.mr_n79462272)
print v(xbgr.mr_n79462592)
print v(xbgr.mr_n79462704)
print v(xbgr.mr_n79463024)
print v(xbgr.mr_n79463136)
print v(xbgr.mr_n79463456)
print v(xbgr.mr_n79463568)
print v(xbgr.mr_n79463888)
print v(xbgr.mr_n79464000)
print v(xbgr.mr_n79464320)
print v(xbgr.mr_n79464432)
print v(xbgr.mr_n79464752)
print v(xbgr.mr_n79464864)
print v(xbgr.mr_n79465184)
print v(xbgr.mr_n79465296)
print v(xbgr.mr_n79465616)
print v(xbgr.mr_n79465728)
print v(xbgr.mr_n79466048)
print v(xbgr.mr_n79466160)
print v(xbgr.mr_n79466480)
print v(xbgr.mr_n79466592)
print v(xbgr.mr_n79466912)
print v(xbgr.mr_n79467024)
print v(xbgr.mr_n79467344)
print v(xbgr.mr_n79467456)
print v(xbgr.mr_n79467776)
print v(xbgr.mr_n79467888)
print v(xbgr.mr_n79468208)
print v(xbgr.mr_n79468320)
print v(xbgr.mr_n79468640)
print v(xbgr.mr_n79468752)
print v(xbgr.mr_n79469072)
print v(xbgr.mr_n79469184)
print v(xbgr.mr_n79469504)
print v(xbgr.mr_n79469616)
print v(xbgr.mr_n79469936)
print v(xbgr.mr_n79470048)
print v(xbgr.mr_n79470368)
print v(xbgr.mr_n79470480)
print v(xbgr.mr_n79470800)
print v(xbgr.mr_n79470912)
print v(xbgr.mr_n79471232)
print v(xbgr.mr_n79471344)
print v(xbgr.mr_n79471664)
print v(xbgr.mr_n79471776)
print v(xbgr.mr_n79472096)
print v(xbgr.mr_n79472208)
print v(xbgr.mr_n79472528)
print v(xbgr.mr_n79472640)
print v(xbgr.mr_n79472960)
print v(xbgr.mr_n79473072)
print v(xbgr.mr_n79473392)
print v(xbgr.mr_n79473504)
print v(xbgr.mr_n79473824)
print v(xbgr.mr_n79473936)
print v(xbgr.mr_n79474256)
print v(xbgr.mr_n79474368)
print v(xbgr.mr_n79474688)
print v(xbgr.mr_n79474800)
print v(xbgr.mr_n79475120)
print v(xbgr.mr_n79475232)
print v(xbgr.mr_n79475552)
print v(xbgr.mr_n79475664)
print v(xbgr.mr_n79475984)
print v(xbgr.mr_n79476096)
print v(xbgr.mr_n79476416)
print v(xbgr.mr_n79476528)
print v(xbgr.mr_n79476848)
print v(xbgr.mr_n79476960)
print v(xbgr.mr_n79477280)
print v(xbgr.mr_n79477392)
print v(xbgr.mr_n79477712)
print v(xbgr.mr_n79477824)
print v(xbgr.mr_n79478144)
print v(xbgr.mr_n79478256)
print v(xbgr.mr_n79478576)
print v(xbgr.mr_n79478688)
print v(xbgr.mr_n79479008)
print v(xbgr.mr_n79479120)
print v(xbgr.mr_n79479440)
print v(xbgr.mr_n79479552)
print v(xbgr.mr_n79479872)
print v(xbgr.mr_n79479984)
print v(xbgr.mr_n79480304)
print v(xbgr.mr_n79480416)
print v(xbgr.mr_n79480736)
print v(xbgr.mr_n79480848)
print v(xbgr.mr_n79481168)
print v(xbgr.mr_n79481280)
print v(xbgr.mr_n79481600)
print v(xbgr.mr_n79481712)
print v(xbgr.mr_n79482032)
print v(xbgr.mr_n79482144)
print v(xbgr.mr_n79482464)
print v(xbgr.mr_n79482576)
print v(xbgr.mr_n79482896)
print v(xbgr.mr_n79483008)
print v(xbgr.mr_n79483328)
print v(xbgr.mr_n79483440)
print v(xbgr.mr_n79483760)
print v(xbgr.mr_n79483872)
print v(xbgr.mr_n79484192)
print v(xbgr.mr_n79484304)
print v(xbgr.mr_n79484624)
print v(xbgr.mr_n79484736)
print v(xbgr.mr_n79485056)
print v(xbgr.mr_n79485168)
print v(xbgr.mr_n79485488)
print v(xbgr.mr_n79485600)
print v(xbgr.mr_n79485920)
print v(xbgr.mr_n79486032)
print v(xbgr.mr_n79486352)
print v(xbgr.mr_n79486464)
print v(xbgr.mr_n79486784)
print v(xbgr.mr_n79486896)
print v(xbgr.mr_n79487216)
print v(xbgr.mr_n79487328)
print v(xbgr.mr_n79487648)
print v(xbgr.mr_n79487760)
print v(xbgr.mr_n79488080)
print v(xbgr.mr_n79488192)
print v(xbgr.mr_n79488512)
print v(xbgr.mr_n79488624)
print v(xbgr.mr_n79488944)
print v(xbgr.mr_n79489056)
print v(xbgr.mr_n79489376)
print v(xbgr.mr_n79489488)
print v(xbgr.mr_n79489808)
print v(xbgr.mr_n79489920)
print v(xbgr.mr_n79490240)
print v(xbgr.mr_n79490352)
print v(xbgr.mr_n79490672)
print v(xbgr.mr_n79490784)
print v(xbgr.mr_n79491104)
print v(xbgr.mr_n79491216)
print v(xbgr.mr_n79491536)
print v(xbgr.mr_n79491648)
print v(xbgr.mr_n79491968)
print v(xbgr.mr_n79492080)
print v(xbgr.mr_n79492400)
print v(xbgr.mr_n79492512)
print v(xbgr.mr_n79492832)
print v(xbgr.mr_n79492944)
print v(xbgr.mr_n79493264)
print v(xbgr.mr_n79493376)
print v(xbgr.mr_n79493696)
print v(xbgr.mr_n79493808)
print v(xbgr.mr_n79494128)
print v(xbgr.mr_n79494240)
print v(xbgr.mr_n79494560)
print v(xbgr.mr_n79494672)
print v(xbgr.mr_n79494992)
print v(xbgr.mr_n79495104)
print v(xbgr.mr_n79495424)
print v(xbgr.mr_n79495536)
print v(xbgr.mr_n79495856)
print v(xbgr.mr_n79495968)
print v(xbgr.mr_n79496288)
print v(xbgr.mr_n79496400)
print v(xbgr.mr_n79496720)
print v(xbgr.mr_n79496832)
print v(xbgr.mr_n79497152)
print v(xbgr.mr_n79497264)
print v(xbgr.mr_n79497584)
print v(xbgr.mr_n79497696)
print v(xbgr.mr_n79498016)
print v(xbgr.mr_n79498128)
print v(xbgr.mr_n79498448)
print v(xbgr.mr_n79498560)
print v(xbgr.mr_n79498880)
print v(xbgr.mr_n79498992)
print v(xbgr.mr_n79499312)
print v(xbgr.mr_n79499424)
print v(xbgr.mr_n79499744)
print v(xbgr.mr_n79499856)
print v(xbgr.mr_n79500176)
print v(xbgr.mr_n79500288)
print v(xbgr.mr_n79500608)
print v(xbgr.mr_n79500720)
print v(xbgr.mr_n79501040)
print v(xbgr.mr_n79501152)
print v(xbgr.mr_n79501472)
print v(xbgr.mr_n79501584)
print v(xbgr.mr_n79501904)
print v(xbgr.mr_n79502016)
print v(xbgr.mr_n79502336)
print v(xbgr.mr_n79502448)
print v(xbgr.mr_n79502768)
print v(xbgr.mr_n79502880)
print v(xbgr.mr_n79503200)
print v(xbgr.mr_n79503312)
print v(xbgr.mr_n79503632)
print v(xbgr.mr_n79503744)
print v(xbgr.mr_n79504064)
print v(xbgr.mr_n79504176)
print v(xbgr.mr_n79504496)
print v(xbgr.mr_n79504608)
print v(xbgr.mr_n79504928)
print v(xbgr.mr_n79505040)
print v(xbgr.mr_n79505360)
print v(xbgr.mr_n79505472)
print v(xbgr.mr_n79505792)
print v(xbgr.mr_n79505904)
print v(xbgr.mr_n79506224)
print v(xbgr.mr_n79506336)
print v(xbgr.mr_n79506656)
print v(xbgr.mr_n79506768)
print v(xbgr.mr_n79507088)
print v(xbgr.mr_n79507200)
print v(xbgr.mr_n79507520)
print v(xbgr.mr_n79507632)
print v(xbgr.mr_n79507952)
print v(xbgr.mr_n79508064)
print v(xbgr.mr_n79508384)
print v(xbgr.mr_n79508496)
print v(xbgr.mr_n79508816)
print v(xbgr.mr_n79508928)
print v(xbgr.mr_n79509248)
print v(xbgr.mr_n79509360)
print v(xbgr.mr_n79509680)
print v(xbgr.mr_n79509792)
print v(xbgr.mr_n79510112)
print v(xbgr.mr_n79510224)
print v(xbgr.mr_n79510544)
print v(xbgr.mr_n79510656)
print v(xbgr.mr_n79510976)
print v(xbgr.mr_n79511088)
print v(xbgr.mr_n79511408)
print v(xbgr.mr_n79511520)
print v(xbgr.mr_n79511840)
print v(xbgr.mr_n79511952)
print v(xbgr.mr_n79512272)
print v(xbgr.mr_n79512384)
print v(xbgr.mr_n79512704)
print v(xbgr.mr_n79512816)
print v(xbgr.mr_n79513136)
print v(xbgr.mr_n79513248)
print v(xbgr.mr_n79513568)
print v(xbgr.mr_n79513680)
print v(xbgr.mr_n79514000)
print v(xbgr.mr_n79514112)
print v(xbgr.mr_n79514432)
print v(xbgr.mr_n79514544)
print v(xbgr.mr_n79514864)
print v(xbgr.mr_n79514976)
print v(xbgr.mr_n79515296)
print v(xbgr.mr_n79515408)
print v(xbgr.mr_n79515728)
print v(xbgr.mr_n79515840)
print v(xbgr.mr_n79516160)
print v(xbgr.mr_n79516272)
print v(xbgr.mr_n79516592)
print v(xbgr.mr_n79516704)
print v(xbgr.mr_n79517024)
print v(xbgr.mr_n79517136)
print v(xbgr.mr_n79517456)
print v(xbgr.mr_n79517568)
print v(xbgr.mr_n79517888)
print v(xbgr.mr_n79518000)
print v(xbgr.mr_n79518320)
print v(xbgr.mr_n79518432)
print v(xbgr.mr_n79518752)
print v(xbgr.mr_n79518864)
print v(xbgr.mr_n79519168)
print v(xbgr.mr_n79519280)
print v(xbgr.mr_n79519600)
print v(xbgr.mr_n79519712)
print v(xbgr.mr_n79520032)
print v(xbgr.mr_n79520144)
print v(xbgr.mr_n79520464)
print v(xbgr.mr_n79520576)
print v(xbgr.mr_n79520896)
print v(xbgr.mr_n79521008)
print v(xbgr.mr_n79521328)
print v(xbgr.mr_n79521440)
print v(xbgr.mr_n79521760)
print v(xbgr.mr_n79521872)
print v(xbgr.mr_n79522192)
print v(xbgr.mr_n79522304)
print v(xbgr.mr_n79522624)
print v(xbgr.mr_n79522736)
print v(xbgr.mr_n79523056)
print v(xbgr.mr_n79523168)
print v(xbgr.mr_n79523488)
print v(xbgr.mr_n79523600)
print v(xbgr.mr_n79523920)
print v(xbgr.mr_n79524032)
print v(xbgr.mr_n79524352)
print v(xbgr.mr_n79524464)
print v(xbgr.mr_n79524784)
print v(xbgr.mr_n79524896)
print v(xbgr.mr_n79525216)
print v(xbgr.mr_n79525328)
print v(xbgr.mr_n79525648)
print v(xbgr.mr_n79525760)
print v(xbgr.mr_n79526080)
print v(xbgr.mr_n79526192)
print v(xbgr.mr_n79526512)
print v(xbgr.mr_n79526624)
print v(xbgr.mr_n79526944)
print v(xbgr.mr_n79527056)
print v(xbgr.mr_n79527376)
print v(xbgr.mr_n79527488)
print v(xbgr.mr_n79527808)
print v(xbgr.mr_n79527920)
print v(xbgr.mr_n79528240)
print v(xbgr.mr_n79528352)
print v(xbgr.mr_n79528672)
print v(xbgr.mr_n79528784)
print v(xbgr.mr_n79529104)
print v(xbgr.mr_n79529216)
print v(xbgr.mr_n79529536)
print v(xbgr.mr_n79529648)
print v(xbgr.mr_n79529968)
print v(xbgr.mr_n79530080)
print v(xbgr.mr_n79530400)
print v(xbgr.mr_n79530512)
print v(xbgr.mr_n79530832)
print v(xbgr.mr_n79530944)
print v(xbgr.mr_n79531264)
print v(xbgr.mr_n79531376)
print v(xbgr.mr_n79531696)
print v(xbgr.mr_n79531808)
print v(xbgr.mr_n79532128)
print v(xbgr.mr_n79532240)
print v(xbgr.mr_n79532560)
print v(xbgr.mr_n79532672)
print v(xbgr.mr_n79532992)
print v(xbgr.mr_n79533104)
print v(xbgr.mr_n79533424)
print v(xbgr.mr_n79533536)
print v(xbgr.mr_n79533856)
print v(xbgr.mr_n79533968)
print v(xbgr.mr_n79534288)
print v(xbgr.mr_n79534400)
print v(xbgr.mr_n79534720)
print v(xbgr.mr_n79534832)
print v(xbgr.mr_n79535152)
print v(xbgr.mr_n79535264)
print v(xbgr.mr_n79535584)
print v(xbgr.mr_n79535696)
print v(xbgr.mr_n79536016)
print v(xbgr.mr_n79536128)
print v(xbgr.mr_n79536448)
print v(xbgr.mr_n79536560)
print v(xbgr.mr_n79536880)
print v(xbgr.mr_n79536992)
print v(xbgr.mr_n79537312)
print v(xbgr.mr_n79537424)
print v(xbgr.mr_n79537744)
print v(xbgr.mr_n79537856)
print v(xbgr.mr_n79538176)
print v(xbgr.mr_n79538288)
print v(xbgr.mr_n79538608)
print v(xbgr.mr_n79538720)
print v(xbgr.mr_n79539040)
print v(xbgr.mr_n79539152)
print v(xbgr.mr_n79539472)
print v(xbgr.mr_n79539584)
print v(xbgr.mr_n79539904)
print v(xbgr.mr_n79540016)
print v(xbgr.mr_n79540336)
print v(xbgr.mr_n79540448)
print v(xbgr.mr_n79540768)
print v(xbgr.mr_n79540880)
print v(xbgr.mr_n79541200)
print v(xbgr.mr_n79541312)
print v(xbgr.mr_n79541632)
print v(xbgr.mr_n79541744)
print v(xbgr.mr_n79542064)
print v(xbgr.mr_n79542176)
print v(xbgr.mr_n79542496)
print v(xbgr.mr_n79542608)
print v(xbgr.mr_n79542928)
print v(xbgr.mr_n79543040)
print v(xbgr.mr_n79543360)
print v(xbgr.mr_n79543472)
print v(xbgr.mr_n79543792)
print v(xbgr.mr_n79543904)
print v(xbgr.mr_n79544224)
print v(xbgr.mr_n79544336)
print v(xbgr.mr_n79544656)
print v(xbgr.mr_n79544768)
print v(xbgr.mr_n79545088)
print v(xbgr.mr_n79545200)
print v(xbgr.mr_n79545520)
print v(xbgr.mr_n79545632)
print v(xbgr.mr_n79545952)
print v(xbgr.mr_n79546064)
print v(xbgr.mr_n79546384)
print v(xbgr.mr_n79546496)
print v(xbgr.mr_n79546816)
print v(xbgr.mr_n79546928)
print v(xbgr.mr_n79547248)
print v(xbgr.mr_n79547360)
print v(xbgr.mr_n79547680)
print v(xbgr.mr_n79547792)
print v(xbgr.mr_n79548112)
print v(xbgr.mr_n79548224)
print v(xbgr.mr_n79548544)
print v(xbgr.mr_n79548656)
print v(xbgr.mr_n79548976)
print v(xbgr.mr_n79549088)
print v(xbgr.mr_n79549408)
print v(xbgr.mr_n79549520)
print v(xbgr.mr_n79549840)
print v(xbgr.mr_n79549952)
print v(xbgr.mr_n79550272)
print v(xbgr.mr_n79550384)
print v(xbgr.mr_n79550704)
print v(xbgr.mr_n79550816)
print v(xbgr.mr_n79551136)
print v(xbgr.mr_n79551248)
print v(xbgr.mr_n79551568)
print v(xbgr.mr_n79551680)
print v(xbgr.mr_n79552000)
print v(xbgr.mr_n79552112)
print v(xbgr.mr_n79552432)
print v(xbgr.mr_n79552544)
print v(xbgr.mr_n79552864)
print v(xbgr.mr_n79552976)
print v(xbgr.mr_n79553296)
print v(xbgr.mr_n79553408)
print v(xbgr.mr_n79553728)
print v(xbgr.mr_n79553840)
print v(xbgr.mr_n79554160)
print v(xbgr.mr_n79554272)
print v(xbgr.mr_n79554592)
print v(xbgr.mr_n79554704)
print v(xbgr.mr_n79555024)
print v(xbgr.mr_n79555136)
print v(xbgr.mr_n79555456)
print v(xbgr.mr_n79555568)
print v(xbgr.mr_n79555888)
print v(xbgr.mr_n79556000)
print v(xbgr.mr_n79556320)
print v(xbgr.mr_n79556432)
print v(xbgr.mr_n79556752)
print v(xbgr.mr_n79556864)
print v(xbgr.mr_n79557184)
print v(xbgr.mr_n79557296)
print v(xbgr.mr_n79557616)
print v(xbgr.mr_n79557728)
print v(xbgr.mr_n79558048)
print v(xbgr.mr_n79558160)
print v(xbgr.mr_n79558480)
print v(xbgr.mr_n79558592)
print v(xbgr.mr_n79558912)
print v(xbgr.mr_n79559024)
print v(xbgr.mr_n79559344)
print v(xbgr.mr_n79559456)
print v(xbgr.mr_n79559776)
print v(xbgr.mr_n79559888)
print v(xbgr.mr_n79560208)
print v(xbgr.mr_n79560320)
print v(xbgr.mr_n79560640)
print v(xbgr.mr_n79560752)
print v(xbgr.mr_n79561072)
print v(xbgr.mr_n79561184)
print v(xbgr.mr_n79561504)
print v(xbgr.mr_n79561616)
print v(xbgr.mr_n79561936)
print v(xbgr.mr_n79562048)
print v(xbgr.mr_n79562368)
print v(xbgr.mr_n79562480)
print v(xbgr.mr_n79562800)
print v(xbgr.mr_n79562912)
print v(xbgr.mr_n79563232)
print v(xbgr.mr_n79563344)
print v(xbgr.mr_n79563664)
print v(xbgr.mr_n79563776)
print v(xbgr.mr_n79564096)
print v(xbgr.mr_n79564208)
print v(xbgr.mr_n79564528)
print v(xbgr.mr_n79564640)
print v(xbgr.mr_n79564960)
print v(xbgr.mr_n79565072)
print v(xbgr.mr_n79565392)
print v(xbgr.mr_n79565504)
print v(xbgr.mr_n79565824)
print v(xbgr.mr_n79565936)
print v(xbgr.mr_n79566256)
print v(xbgr.mr_n79566368)
print v(xbgr.mr_n79566688)
print v(xbgr.mr_n79566800)
print v(xbgr.mr_n79567120)
print v(xbgr.mr_n79567328)
print v(xbgr.mr_n79567568)
print v(xbgr.mr_n79568432)
print v(xbgr.mr_n79568544)
print v(xbgr.mr_n79568864)
print v(xbgr.mr_n79568976)
print v(xbgr.mr_n79569296)
print v(xbgr.mr_n79569408)
print v(xbgr.mr_n79569728)
print v(xbgr.mr_n79569840)
print v(xbgr.mr_n79570160)
print v(xbgr.mr_n79570272)
print v(xbgr.mr_n79570592)
print v(xbgr.mr_n79570704)
print v(xbgr.mr_n79571024)
print v(xbgr.mr_n79571888)
print v(xbgr.mr_n79572752)
print v(xbgr.mr_n79573616)
print v(xbgr.mr_n79573728)
print v(xbgr.mr_n79574480)
print v(xbgr.mr_n79574592)
print v(xbgr.mr_n79574912)
print v(xbgr.mr_n79575776)
print v(xbgr.mr_n79576640)
print v(xbgr.mr_n79577504)
print v(xbgr.mr_n79578368)
print v(xbgr.mr_n79578912)
print v(xbgr.mr_n79579664)
print v(xbgr.mr_n79580208)
print v(xbgr.mr_n79580640)
print v(xbgr.mr_n79581392)
print v(xbgr.mr_n79581504)
print v(xbgr.mr_n79581824)
print v(xbgr.mr_n79581936)
print v(xbgr.mr_n79582256)
print v(xbgr.mr_n79583120)
print v(xbgr.mr_n79583984)
print v(xbgr.mr_n79584848)
print v(xbgr.mr_n79584960)
print v(xbgr.mr_n79585280)
print v(xbgr.mr_n79585392)
print v(xbgr.mr_n79585824)
print v(xbgr.mr_n79586144)
print v(xbgr.mr_n79586256)
print v(xbgr.mr_n79586576)
print v(xbgr.mr_n79587440)
print v(xbgr.mr_n79587552)
print v(xbgr.mr_n79587984)
print v(xbgr.mr_n79588304)
print v(xbgr.mr_n79588416)
print v(xbgr.mr_n79588736)
print v(xbgr.mr_n79588848)
print v(xbgr.mr_n79589168)
print v(xbgr.mr_n79589280)
print v(xbgr.mr_n79589600)
print v(xbgr.mr_n79589712)
print v(xbgr.mr_n79590032)
print v(xbgr.mr_n79591008)
print v(xbgr.mr_n79591328)
print v(xbgr.mr_n79591440)
print v(xbgr.mr_n79591760)
print v(xbgr.mr_n79591872)
print v(xbgr.mr_n79592192)
print v(xbgr.mr_n79592304)
print v(xbgr.mr_n79592624)
print v(xbgr.mr_n79592736)
print v(xbgr.mr_n79593056)
print v(xbgr.mr_n79593488)
print v(xbgr.mr_n79594464)
print v(xbgr.mr_n79594784)
print v(xbgr.mr_n79595648)
print v(xbgr.mr_n79596512)
print v(xbgr.mr_n79596624)
print v(xbgr.mr_n79597376)
print v(xbgr.mr_n79598240)
print v(xbgr.mr_n79598352)
print v(xbgr.mr_n79598672)
print v(xbgr.mr_n79599536)
print v(xbgr.mr_n79599648)
print v(xbgr.mr_n79599968)
print v(xbgr.mr_n79600080)
print v(xbgr.mr_n79600400)
print v(xbgr.mr_n79601264)
print v(xbgr.mr_n79601376)
print v(xbgr.mr_n79601696)
print v(xbgr.mr_n79601808)
print v(xbgr.mr_n79602128)
print v(xbgr.mr_n79602240)
print v(xbgr.mr_n79602560)
print v(xbgr.mr_n79602672)
print v(xbgr.mr_n79602992)
print v(xbgr.mr_n79603968)
print v(xbgr.mr_n79604400)
print v(xbgr.mr_n79604720)
print v(xbgr.mr_n79605584)
print v(xbgr.mr_n79606448)
print v(xbgr.mr_n79606560)
print v(xbgr.mr_n79606880)
print v(xbgr.mr_n79606992)
print v(xbgr.mr_n79607312)
print v(xbgr.mr_n79607424)
print v(xbgr.mr_n79607744)
print v(xbgr.mr_n79607856)
print v(xbgr.mr_n79608288)
print v(xbgr.mr_n79608720)
print v(xbgr.mr_n79609040)
print v(xbgr.mr_n79609152)
print v(xbgr.mr_n79609472)
print v(xbgr.mr_n79609584)
print v(xbgr.mr_n79609904)
print v(xbgr.mr_n79610016)
print v(xbgr.mr_n79610336)
print v(xbgr.mr_n79610448)
print v(xbgr.mr_n79610768)
print v(xbgr.mr_n79611632)
print v(xbgr.mr_n79612496)
print v(xbgr.mr_n79612608)
print v(xbgr.mr_n79612928)
print v(xbgr.mr_n79613792)
print v(xbgr.mr_n79614656)
print v(xbgr.mr_n79614768)
print v(xbgr.mr_n79615088)
print v(xbgr.mr_n79615200)
print v(xbgr.mr_n79615632)
print v(xbgr.mr_n79615952)
print v(xbgr.mr_n79616064)
print v(xbgr.mr_n79616496)
print v(xbgr.mr_n79616816)
print v(xbgr.mr_n79617248)
print v(xbgr.mr_n79617360)
print v(xbgr.mr_n79617680)
print v(xbgr.mr_n79617792)
print v(xbgr.mr_n79618112)
print v(xbgr.mr_n79618544)
print v(xbgr.mr_n79618656)
print v(xbgr.mr_n79619408)
print v(xbgr.mr_n79619520)
print v(xbgr.mr_n79619840)
print v(xbgr.mr_n79619952)
print v(xbgr.mr_n79620272)
print v(xbgr.mr_n79620704)
print v(xbgr.mr_n79620816)
print v(xbgr.mr_n79621136)
print v(xbgr.mr_n79621568)
print v(xbgr.mr_n79622432)
print v(xbgr.mr_n79624160)
print v(xbgr.mr_n79624272)
print v(xbgr.mr_n79624592)
print v(xbgr.mr_n79624704)
print v(xbgr.mr_n79625024)
print v(xbgr.mr_n79625136)
print v(xbgr.mr_n79625568)
print v(xbgr.mr_n79626000)
print v(xbgr.mr_n79626320)
print v(xbgr.mr_n79626432)
print v(xbgr.mr_n79626752)
print v(xbgr.mr_n79628160)
print v(xbgr.mr_n79628480)
print v(xbgr.mr_n79629456)
print v(xbgr.mr_n79629776)
print v(xbgr.mr_n79629888)
print v(xbgr.mr_n79630208)
print v(xbgr.mr_n79630320)
print v(xbgr.mr_n79630752)
print v(xbgr.mr_n79631072)
print v(xbgr.mr_n79631184)
print v(xbgr.mr_n79631616)
print v(xbgr.mr_n79631936)
print v(xbgr.mr_n79632048)
print v(xbgr.mr_n79632368)
print v(xbgr.mr_n79632480)
print v(xbgr.mr_n79632800)
print v(xbgr.mr_n79633664)
print v(xbgr.mr_n79634096)
print v(xbgr.mr_n79634960)
print v(xbgr.mr_n79635072)
print v(xbgr.mr_n79635392)
print v(xbgr.mr_n79635504)
print v(xbgr.mr_n79635824)
print v(xbgr.mr_n79635936)
print v(xbgr.mr_n79636688)
print v(xbgr.mr_n79637120)
print v(xbgr.mr_n79637232)
print v(xbgr.mr_n79637552)
print v(xbgr.mr_n79637984)
print v(xbgr.mr_n79638096)
print v(xbgr.mr_n79638416)
print v(xbgr.mr_n79638528)
print v(xbgr.mr_n79638848)
print v(xbgr.mr_n79638960)
print v(xbgr.mr_n79639280)
print v(xbgr.mr_n79639392)
print v(xbgr.mr_n79639712)
print v(xbgr.mr_n79639824)
print v(xbgr.mr_n79640144)
print v(xbgr.mr_n79641552)
print v(xbgr.mr_n79641872)
print v(xbgr.mr_n79641984)
print v(xbgr.mr_n79642416)
print v(xbgr.mr_n79642736)
print v(xbgr.mr_n79642848)
print v(xbgr.mr_n79643168)
print v(xbgr.mr_n79643600)
print v(xbgr.mr_n79644464)
print v(xbgr.mr_n79645328)
print v(xbgr.mr_n79646192)
print v(xbgr.mr_n79647056)
print v(xbgr.mr_n79647920)
print v(xbgr.mr_n79649216)
print v(xbgr.mr_n79649648)
print v(xbgr.mr_n79649760)
print v(xbgr.mr_n79650080)
print v(xbgr.mr_n79650512)
print v(xbgr.mr_n79650624)
print v(xbgr.mr_n79650944)
print v(xbgr.mr_n79651808)
print v(xbgr.mr_n79651920)
print v(xbgr.mr_n79652240)
print v(xbgr.mr_n79652352)
print v(xbgr.mr_n79652672)
print v(xbgr.mr_n79653536)
print v(xbgr.mr_n79653648)
print v(xbgr.mr_n79654512)
print v(xbgr.mr_n79654944)
print v(xbgr.mr_n79655376)
print v(xbgr.mr_n79656128)
print v(xbgr.mr_n79656240)
print v(xbgr.mr_n79656672)
print v(xbgr.mr_n79657424)
print v(xbgr.mr_n79657856)
print v(xbgr.mr_n79657968)
print v(xbgr.mr_n79658400)
print v(xbgr.mr_n79659152)
print v(xbgr.mr_n79659264)
print v(xbgr.mr_n79659584)
print v(xbgr.mr_n79659696)
print v(xbgr.mr_n79660016)
print v(xbgr.mr_n79660128)
print v(xbgr.mr_n79660448)
print v(xbgr.mr_n79660560)
print v(xbgr.mr_n79660880)
print v(xbgr.mr_n79660992)
print v(xbgr.mr_n79661312)
print v(xbgr.mr_n79661424)
print v(xbgr.mr_n79661744)
print v(xbgr.mr_n79661856)
print v(xbgr.mr_n79662176)
print v(xbgr.mr_n79662288)
print v(xbgr.mr_n79662608)
print v(xbgr.mr_n79662720)
print v(xbgr.mr_n79663040)
print v(xbgr.mr_n79663152)
print v(xbgr.mr_n79663472)
print v(xbgr.mr_n79663584)
print v(xbgr.mr_n79663904)
print v(xbgr.mr_n79664016)
print v(xbgr.mr_n79664336)
print v(xbgr.mr_n79664448)
print v(xbgr.mr_n79664768)
print v(xbgr.mr_n79664880)
print v(xbgr.mr_n79665312)
print v(xbgr.mr_n79665632)
print v(xbgr.mr_n79665744)
print v(xbgr.mr_n79666176)
print v(xbgr.mr_n79666496)
print v(xbgr.mr_n79666608)
print v(xbgr.mr_n79667360)
print v(xbgr.mr_n79667792)
print v(xbgr.mr_n79668656)
print v(xbgr.mr_n79669520)
print v(xbgr.mr_n79670384)
print v(xbgr.mr_n79670496)
print v(xbgr.mr_n79670816)
print v(xbgr.mr_n79670928)
print v(xbgr.mr_n79671248)
print v(xbgr.mr_n79671360)
print v(xbgr.mr_n79671680)
print v(xbgr.mr_n79671792)
print v(xbgr.mr_n79672544)
print v(xbgr.mr_n79673408)
print v(xbgr.mr_n79674272)
print v(xbgr.mr_n79675136)
print v(xbgr.mr_n79676432)
print v(xbgr.mr_n79676544)
print v(xbgr.mr_n79676864)
print v(xbgr.mr_n79676976)
print v(xbgr.mr_n79677296)
print v(xbgr.mr_n79677408)
print v(xbgr.mr_n79677840)
print v(xbgr.mr_n79678272)
print v(xbgr.mr_n79678704)
print v(xbgr.mr_n79679024)
print v(xbgr.mr_n79679136)
print v(xbgr.mr_n79679568)
print v(xbgr.mr_n79679888)
print v(xbgr.mr_n79680000)
print v(xbgr.mr_n79680320)
print v(xbgr.mr_n79680432)
print v(xbgr.mr_n79680752)
print v(xbgr.mr_n79680864)
print v(xbgr.mr_n79681184)
print v(xbgr.mr_n79681296)
print v(xbgr.mr_n79681616)
print v(xbgr.mr_n79681728)
print v(xbgr.mr_n79682160)
print v(xbgr.mr_n79682480)
print v(xbgr.mr_n79682592)
print v(xbgr.mr_n79683024)
print v(xbgr.mr_n79683344)
print v(xbgr.mr_n79683776)
print v(xbgr.mr_n79683888)
print v(xbgr.mr_n79684320)
print v(xbgr.mr_n79684640)
print v(xbgr.mr_n79684752)
print v(xbgr.mr_n79685184)
print v(xbgr.mr_n79685504)
print v(xbgr.mr_n79685616)
print v(xbgr.mr_n79686048)
print v(xbgr.mr_n79686368)
print v(xbgr.mr_n79686480)
print v(xbgr.mr_n79686800)
print v(xbgr.mr_n79686912)
print v(xbgr.mr_n79687232)
print v(xbgr.mr_n79688096)
print v(xbgr.mr_n79688960)
print v(xbgr.mr_n79689824)
print v(xbgr.mr_n79690688)
print v(xbgr.mr_n79691552)
print v(xbgr.mr_n79692416)
print v(xbgr.mr_n79692528)
print v(xbgr.mr_n79693280)
print v(xbgr.mr_n79694144)
print v(xbgr.mr_n79695008)
print v(xbgr.mr_n79695872)
print v(xbgr.mr_n79696736)
print v(xbgr.mr_n79697600)
print v(xbgr.mr_n79697712)
print v(xbgr.mr_n79698032)
print v(xbgr.mr_n79698144)
print v(xbgr.mr_n79698464)
print v(xbgr.mr_n79698576)
print v(xbgr.mr_n79698896)
print v(xbgr.mr_n79699008)
print v(xbgr.mr_n79699328)
print v(xbgr.mr_n79700192)
print v(xbgr.mr_n79701056)
print v(xbgr.mr_n79701920)
print v(xbgr.mr_n79702032)
print v(xbgr.mr_n79702352)
print v(xbgr.mr_n79702464)
print v(xbgr.mr_n79702784)
print v(xbgr.mr_n79702896)
print v(xbgr.mr_n79703216)
print v(xbgr.mr_n79704080)
print v(xbgr.mr_n79704944)
print v(xbgr.mr_n79705808)
print v(xbgr.mr_n79705920)
print v(xbgr.mr_n79706240)
print v(xbgr.mr_n79706352)
print v(xbgr.mr_n79706672)
print v(xbgr.mr_n79706784)
print v(xbgr.mr_n79707216)
print v(xbgr.mr_n79707648)
print v(xbgr.mr_n79708080)
print v(xbgr.mr_n79708400)
print v(xbgr.mr_n79708512)
print v(xbgr.mr_n79708832)
print v(xbgr.mr_n79708944)
print v(xbgr.mr_n79709264)
print v(xbgr.mr_n79709376)
print v(xbgr.mr_n79709696)
print v(xbgr.mr_n79709808)
print v(xbgr.mr_n79710128)
print v(xbgr.mr_n79710240)
print v(xbgr.mr_n79710560)
print v(xbgr.mr_n79710672)
print v(xbgr.mr_n79710992)
print v(xbgr.mr_n79711104)
print v(xbgr.mr_n79711424)
print v(xbgr.mr_n79711536)
print v(xbgr.mr_n79711856)
print v(xbgr.mr_n79711968)
print v(xbgr.mr_n79712400)
print v(xbgr.mr_n79712720)
print v(xbgr.mr_n79712832)
print v(xbgr.mr_n79713152)
print v(xbgr.mr_n79713584)
print v(xbgr.mr_n79713696)
print v(xbgr.mr_n79714016)
print v(xbgr.mr_n79714128)
print v(xbgr.mr_n79714448)
print v(xbgr.mr_n79714560)
print v(xbgr.mr_n79714880)
print v(xbgr.mr_n79714992)
print v(xbgr.mr_n79715744)
print v(xbgr.mr_n79715856)
print v(xbgr.mr_n79716608)
print v(xbgr.mr_n79717472)
print v(xbgr.mr_n79717584)
print v(xbgr.mr_n79717904)
print v(xbgr.mr_n79718016)
print v(xbgr.mr_n79718336)
print v(xbgr.mr_n79718448)
print v(xbgr.mr_n79718768)
print v(xbgr.mr_n79718880)
print v(xbgr.mr_n79719312)
print v(xbgr.mr_n79719744)
print v(xbgr.mr_n79720064)
print v(xbgr.mr_n79720176)
print v(xbgr.mr_n79720496)
print v(xbgr.mr_n79720608)
print v(xbgr.mr_n79720928)
print v(xbgr.mr_n79721792)
print v(xbgr.mr_n79723088)
print v(xbgr.mr_n79723952)
print v(xbgr.mr_n79724064)
print v(xbgr.mr_n79724384)
print v(xbgr.mr_n79724496)
print v(xbgr.mr_n79724816)
print v(xbgr.mr_n79724928)
print v(xbgr.mr_n79725248)
print v(xbgr.mr_n79725360)
print v(xbgr.mr_n79725792)
print v(xbgr.mr_n79726112)
print v(xbgr.mr_n79726224)
print v(xbgr.mr_n79726544)
print v(xbgr.mr_n79726656)
print v(xbgr.mr_n79726976)
print v(xbgr.mr_n79727088)
print v(xbgr.mr_n79727520)
print v(xbgr.mr_n79727840)
print v(xbgr.mr_n79727952)
print v(xbgr.mr_n79728272)
print v(xbgr.mr_n79728384)
print v(xbgr.mr_n79728704)
print v(xbgr.mr_n79729568)
print v(xbgr.mr_n79730432)
print v(xbgr.mr_n79731296)
print v(xbgr.mr_n79732160)
print v(xbgr.mr_n79732272)
print v(xbgr.mr_n79732592)
print v(xbgr.mr_n79732704)
print v(xbgr.mr_n79733136)
print v(xbgr.mr_n79733568)
print v(xbgr.mr_n79733888)
print v(xbgr.mr_n79734000)
print v(xbgr.mr_n79734320)
print v(xbgr.mr_n79735184)
print v(xbgr.mr_n79736048)
print v(xbgr.mr_n79736160)
print v(xbgr.mr_n79736480)
print v(xbgr.mr_n79736592)
print v(xbgr.mr_n79736912)
print v(xbgr.mr_n79737024)
print v(xbgr.mr_n79737344)
print v(xbgr.mr_n79737456)
print v(xbgr.mr_n79737776)
print v(xbgr.mr_n79737888)
print v(xbgr.mr_n79738320)
print v(xbgr.mr_n79738640)
print v(xbgr.mr_n79738752)
print v(xbgr.mr_n79739504)
print v(xbgr.mr_n79740368)
print v(xbgr.mr_n79740480)
print v(xbgr.mr_n79740800)
print v(xbgr.mr_n79740912)
print v(xbgr.mr_n79741344)
print v(xbgr.mr_n79741664)
print v(xbgr.mr_n79741776)
print v(xbgr.mr_n79742096)
print v(xbgr.mr_n79742208)
print v(xbgr.mr_n79742528)
print v(xbgr.mr_n79742640)
print v(xbgr.mr_n79742960)
print v(xbgr.mr_n79743072)
print v(xbgr.mr_n79743392)
print v(xbgr.mr_n79743504)
print v(xbgr.mr_n79743824)
print v(xbgr.mr_n79744688)
print v(xbgr.mr_n79745664)
print v(xbgr.mr_n79745984)
print v(xbgr.mr_n79746848)
print v(xbgr.mr_n79747712)
print v(xbgr.mr_n79748576)
print v(xbgr.mr_n79749008)
print v(xbgr.mr_n79749440)
print v(xbgr.mr_n79749552)
print v(xbgr.mr_n79749872)
print v(xbgr.mr_n79749984)
print v(xbgr.mr_n79750304)
print v(xbgr.mr_n79750416)
print v(xbgr.mr_n79750736)
print v(xbgr.mr_n79750848)
print v(xbgr.mr_n79751168)
print v(xbgr.mr_n79751280)
print v(xbgr.mr_n79751600)
print v(xbgr.mr_n79751712)
print v(xbgr.mr_n79752032)
print v(xbgr.mr_n79752896)
print v(xbgr.mr_n79753760)
print v(xbgr.mr_n79753872)
print v(xbgr.mr_n79754192)
print v(xbgr.mr_n79754304)
print v(xbgr.mr_n79754624)
print v(xbgr.mr_n79754736)
print v(xbgr.mr_n79755056)
print v(xbgr.mr_n79755168)
print v(xbgr.mr_n79756784)
print v(xbgr.mr_n79757648)
print v(xbgr.mr_n79757760)
print v(xbgr.mr_n79758080)
print v(xbgr.mr_n79758192)
print v(xbgr.mr_n79758512)
print v(xbgr.mr_n79758944)
print v(xbgr.mr_n79759056)
print v(xbgr.mr_n79759376)
print v(xbgr.mr_n79759488)
print v(xbgr.mr_n79759808)
print v(xbgr.mr_n79759920)
print v(xbgr.mr_n79760352)
print v(xbgr.mr_n79760672)
print v(xbgr.mr_n79760784)
print v(xbgr.mr_n79761216)
print v(xbgr.mr_n79761968)
print v(xbgr.mr_n79762832)
print v(xbgr.mr_n79764128)
print v(xbgr.mr_n79764240)
print v(xbgr.mr_n79764672)
print v(xbgr.mr_n79764992)
print v(xbgr.mr_n79765856)
print v(xbgr.mr_n79766720)
print v(xbgr.mr_n79767152)
print v(xbgr.mr_n79768448)
print v(xbgr.mr_n79769312)
print v(xbgr.mr_n79769744)
print v(xbgr.mr_n79770608)
print v(xbgr.mr_n79771904)
print v(xbgr.mr_n79772016)
print v(xbgr.mr_n79772336)
print v(xbgr.mr_n79772448)
print v(xbgr.mr_n79772768)
print v(xbgr.mr_n79772880)
print v(xbgr.mr_n79773200)
print v(xbgr.mr_n79773312)
print v(xbgr.mr_n79773632)
print v(xbgr.mr_n79773744)
print v(xbgr.mr_n79774064)
print v(xbgr.mr_n79774176)
print v(xbgr.mr_n79774496)
print v(xbgr.mr_n79774608)
print v(xbgr.mr_n79775360)
print v(xbgr.mr_n79775472)
print v(xbgr.mr_n79775904)
print v(xbgr.mr_n79776224)
print v(xbgr.mr_n79776336)
print v(xbgr.mr_n79776656)
print v(xbgr.mr_n79776768)
print v(xbgr.mr_n79777088)
print v(xbgr.mr_n79777200)
print v(xbgr.mr_n79777520)
print v(xbgr.mr_n79777632)
print v(xbgr.mr_n79777952)
print v(xbgr.mr_n79778064)
print v(xbgr.mr_n79778496)
print v(xbgr.mr_n79778816)
print v(xbgr.mr_n79779360)
print v(xbgr.mr_n79779680)
print v(xbgr.mr_n79779792)
print v(xbgr.mr_n79780224)
print v(xbgr.mr_n79780544)
print v(xbgr.mr_n79780656)
print v(xbgr.mr_n79781088)
print v(xbgr.mr_n79781408)
print v(xbgr.mr_n79781520)
print v(xbgr.mr_n79781840)
print v(xbgr.mr_n79781952)
print v(xbgr.mr_n79782272)
print v(xbgr.mr_n79782384)
print v(xbgr.mr_n79782704)
print v(xbgr.mr_n79782816)
print v(xbgr.mr_n79783136)
print v(xbgr.mr_n79783248)
print v(xbgr.mr_n79783568)
print v(xbgr.mr_n79783680)
print v(xbgr.mr_n79784000)
print v(xbgr.mr_n79784112)
print v(xbgr.mr_n79784432)
print v(xbgr.mr_n79784544)
print v(xbgr.mr_n79784864)
print v(xbgr.mr_n79785728)
print v(xbgr.mr_n79785840)
print v(xbgr.mr_n79786160)
print v(xbgr.mr_n79786272)
print v(xbgr.mr_n79786592)
print v(xbgr.mr_n79786704)
print v(xbgr.mr_n79787024)
print v(xbgr.mr_n79787136)
print v(xbgr.mr_n79787456)
print v(xbgr.mr_n79788320)
print v(xbgr.mr_n79789184)
print v(xbgr.mr_n79790048)
print v(xbgr.mr_n79790592)
print v(xbgr.mr_n79791024)
print v(xbgr.mr_n79791344)
print v(xbgr.mr_n79791456)
print v(xbgr.mr_n79791776)
print v(xbgr.mr_n79791888)
print v(xbgr.mr_n79792208)
print v(xbgr.mr_n79792320)
print v(xbgr.mr_n79792640)
print v(xbgr.mr_n79792752)
print v(xbgr.mr_n79793072)
print v(xbgr.mr_n79794368)
print v(xbgr.mr_n79795232)
print v(xbgr.mr_n79796208)
print v(xbgr.mr_n79796640)
print v(xbgr.mr_n79796960)
print v(xbgr.mr_n79797392)
print v(xbgr.mr_n79798256)
print v(xbgr.mr_n79799120)
print v(xbgr.mr_n79799232)
print v(xbgr.mr_n79799552)
print v(xbgr.mr_n79799664)
print v(xbgr.mr_n79799984)
print v(xbgr.mr_n79800096)
print v(xbgr.mr_n79800416)
print v(xbgr.mr_n79800528)
print v(xbgr.mr_n79801712)
print v(xbgr.mr_n79801824)
print v(xbgr.mr_n79802144)
print v(xbgr.mr_n79802256)
print v(xbgr.mr_n79802576)
print v(xbgr.mr_n79802688)
print v(xbgr.mr_n79803120)
print v(xbgr.mr_n79803440)
print v(xbgr.mr_n79803872)
print v(xbgr.mr_n79803984)
print v(xbgr.mr_n79804416)
print v(xbgr.mr_n79804736)
print v(xbgr.mr_n79805600)
print v(xbgr.mr_n79805712)
print v(xbgr.mr_n79806144)
print v(xbgr.mr_n79806464)
print v(xbgr.mr_n79806576)
print v(xbgr.mr_n79807328)
print v(xbgr.mr_n79807872)
print v(xbgr.mr_n79808192)
print v(xbgr.mr_n79808304)
print v(xbgr.mr_n79808624)
print v(xbgr.mr_n79808736)
print v(xbgr.mr_n79809056)
print v(xbgr.mr_n79809168)
print v(xbgr.mr_n79809488)
print v(xbgr.mr_n79809920)
print v(xbgr.mr_n79810032)
print v(xbgr.mr_n79810352)
print v(xbgr.mr_n79810464)
print v(xbgr.mr_n79810784)
print v(xbgr.mr_n79810896)
print v(xbgr.mr_n79811648)
print v(xbgr.mr_n79811760)
print v(xbgr.mr_n79812192)
print v(xbgr.mr_n79812512)
print v(xbgr.mr_n79812624)
print v(xbgr.mr_n79812944)
print v(xbgr.mr_n79813056)
print v(xbgr.mr_n79813376)
print v(xbgr.mr_n79813488)
print v(xbgr.mr_n79813808)
print v(xbgr.mr_n79814672)
print v(xbgr.mr_n79815104)
print v(xbgr.mr_n79815536)
print v(xbgr.mr_n79815648)
print v(xbgr.mr_n79815968)
print v(xbgr.mr_n79816080)
print v(xbgr.mr_n79816832)
print v(xbgr.mr_n79816944)
print v(xbgr.mr_n79817264)
print v(xbgr.mr_n79817376)
print v(xbgr.mr_n79818128)
print v(xbgr.mr_n79818992)
print v(xbgr.mr_n79819104)
print v(xbgr.mr_n79819424)
print v(xbgr.mr_n79820288)
print v(xbgr.mr_n79820400)
print v(xbgr.mr_n79820720)
print v(xbgr.mr_n79820832)
print v(xbgr.mr_n79821152)
print v(xbgr.mr_n79821264)
print v(xbgr.mr_n79821584)
print v(xbgr.mr_n79821696)
print v(xbgr.mr_n79822016)
print v(xbgr.mr_n79822128)
print v(xbgr.mr_n79822448)
print v(xbgr.mr_n79822560)
print v(xbgr.mr_n79822880)
print v(xbgr.mr_n79822992)
print v(xbgr.mr_n79823424)
print v(xbgr.mr_n79823856)
print v(xbgr.mr_n79824176)
print v(xbgr.mr_n79824608)
print v(xbgr.mr_n79824720)
print v(xbgr.mr_n79825904)
print v(xbgr.mr_n79827632)
print v(xbgr.mr_n79827744)
print v(xbgr.mr_n79828176)
print v(xbgr.mr_n79828496)
print v(xbgr.mr_n79828608)
print v(xbgr.mr_n79828928)
print v(xbgr.mr_n79829040)
print v(xbgr.mr_n79829472)
print v(xbgr.mr_n79829792)
print v(xbgr.mr_n79829904)
print v(xbgr.mr_n79830224)
print v(xbgr.mr_n79830656)
print v(xbgr.mr_n79830768)
print v(xbgr.mr_n79831520)
print v(xbgr.mr_n79831632)
print v(xbgr.mr_n79831952)
print v(xbgr.mr_n79832064)
print v(xbgr.mr_n79832384)
print v(xbgr.mr_n79832496)
print v(xbgr.mr_n79832816)
print v(xbgr.mr_n79832928)
print v(xbgr.mr_n79833248)
print v(xbgr.mr_n79833360)
print v(xbgr.mr_n79833680)
print v(xbgr.mr_n79834544)
print v(xbgr.mr_n79835408)
print v(xbgr.mr_n79836272)
print v(xbgr.mr_n79836384)
print v(xbgr.mr_n79836704)
print v(xbgr.mr_n79837136)
print v(xbgr.mr_n79837248)
print v(xbgr.mr_n79837568)
print v(xbgr.mr_n79837680)
print v(xbgr.mr_n79838000)
print v(xbgr.mr_n79838112)
print v(xbgr.mr_n79838432)
print v(xbgr.mr_n79839296)
print v(xbgr.mr_n79840272)
print v(xbgr.mr_n79840592)
print v(xbgr.mr_n79840704)
print v(xbgr.mr_n79841024)
print v(xbgr.mr_n79841136)
print v(xbgr.mr_n79841456)
print v(xbgr.mr_n79841568)
print v(xbgr.mr_n79841888)
print v(xbgr.mr_n79842000)
print v(xbgr.mr_n79842320)
print v(xbgr.mr_n79842864)
print v(xbgr.mr_n79843296)
print v(xbgr.mr_n79843728)
print v(xbgr.mr_n79844912)
print v(xbgr.mr_n79845024)
print v(xbgr.mr_n79845344)
print v(xbgr.mr_n79845456)
print v(xbgr.mr_n79845776)
print v(xbgr.mr_n79846640)
print v(xbgr.mr_n79846752)
print v(xbgr.mr_n79847072)
print v(xbgr.mr_n79847184)
print v(xbgr.mr_n79847504)
print v(xbgr.mr_n79847936)
print v(xbgr.mr_n79848800)
print v(xbgr.mr_n79850096)
print v(xbgr.mr_n79850208)
print v(xbgr.mr_n79850528)
print v(xbgr.mr_n79850640)
print v(xbgr.mr_n79850960)
print v(xbgr.mr_n79851392)
print v(xbgr.mr_n79852256)
print v(xbgr.mr_n79852688)
print v(xbgr.mr_n79852800)
print v(xbgr.mr_n79853120)
print v(xbgr.mr_n79853232)
print v(xbgr.mr_n79853552)
print v(xbgr.mr_n79853664)
print v(xbgr.mr_n79853984)
print v(xbgr.mr_n79854096)
print v(xbgr.mr_n79854848)
print v(xbgr.mr_n79854960)
print v(xbgr.mr_n79855712)
print v(xbgr.mr_n79856688)
print v(xbgr.mr_n79857008)
print v(xbgr.mr_n79857120)
print v(xbgr.mr_n79857440)
print v(xbgr.mr_n79857552)
print v(xbgr.mr_n79857872)
print v(xbgr.mr_n79858304)
print v(xbgr.mr_n79859168)
print v(xbgr.mr_n79859280)
print v(xbgr.mr_n79859600)
print v(xbgr.mr_n79859712)
print v(xbgr.mr_n79860032)
print v(xbgr.mr_n79860144)
print v(xbgr.mr_n79860464)
print v(xbgr.mr_n79860576)
print v(xbgr.mr_n79860896)
print v(xbgr.mr_n79861008)
print v(xbgr.mr_n79861440)
print v(xbgr.mr_n79862192)
print v(xbgr.mr_n79863168)
print v(xbgr.mr_n79863600)
print v(xbgr.mr_n79863920)
print v(xbgr.mr_n79864352)
print v(xbgr.mr_n79865328)
print v(xbgr.mr_n79865760)
print v(xbgr.mr_n79866080)
print v(xbgr.mr_n79866512)
print v(xbgr.mr_n79866624)
print v(xbgr.mr_n79866944)
print v(xbgr.mr_n79867056)
print v(xbgr.mr_n79867376)
print v(xbgr.mr_n79867488)
print v(xbgr.mr_n79867808)
print v(xbgr.mr_n79867920)
print v(xbgr.mr_n79868672)
print v(xbgr.mr_n79869536)
print v(xbgr.mr_n79870832)
print v(xbgr.mr_n79870944)
print v(xbgr.mr_n79871264)
print v(xbgr.mr_n79871376)
print v(xbgr.mr_n79871696)
print v(xbgr.mr_n79871808)
print v(xbgr.mr_n79872128)
print v(xbgr.mr_n79872240)
print v(xbgr.mr_n79872560)
print v(xbgr.mr_n79872672)
print v(xbgr.mr_n79872992)
print v(xbgr.mr_n79873424)
print v(xbgr.mr_n79873536)
print v(xbgr.mr_n79873856)
print v(xbgr.mr_n79873968)
print v(xbgr.mr_n79874288)
print v(xbgr.mr_n79874400)
print v(xbgr.mr_n79874720)
print v(xbgr.mr_n79874832)
print v(xbgr.mr_n79875152)
print v(xbgr.mr_n79875264)
print v(xbgr.mr_n79875584)
print v(xbgr.mr_n79875696)
print v(xbgr.mr_n79876016)
print v(xbgr.mr_n79876128)
print v(xbgr.mr_n79876448)
print v(xbgr.mr_n79876560)
print v(xbgr.mr_n79876880)
print v(xbgr.mr_n79876992)
print v(xbgr.mr_n79877424)
print v(xbgr.mr_n79877744)
print v(xbgr.mr_n79877856)
print v(xbgr.mr_n79878288)
print v(xbgr.mr_n79878720)
print v(xbgr.mr_n79879040)
print v(xbgr.mr_n79879152)
print v(xbgr.mr_n79879472)
print v(xbgr.mr_n79879584)
print v(xbgr.mr_n79879904)
print v(xbgr.mr_n79880016)
print v(xbgr.mr_n79880336)
print v(xbgr.mr_n79880448)
print v(xbgr.mr_n79881200)
print v(xbgr.mr_n79881312)
print v(xbgr.mr_n79881744)
print v(xbgr.mr_n79882064)
print v(xbgr.mr_n79882608)
print v(xbgr.mr_n79882928)
print v(xbgr.mr_n79883792)
print v(xbgr.mr_n79883904)
print v(xbgr.mr_n79884224)
print v(xbgr.mr_n79884656)
print v(xbgr.mr_n79885088)
print v(xbgr.mr_n79885520)
print v(xbgr.mr_n79885632)
print v(xbgr.mr_n79886384)
print v(xbgr.mr_n79886496)
print v(xbgr.mr_n79886816)
print v(xbgr.mr_n79886928)
print v(xbgr.mr_n79887248)
print v(xbgr.mr_n79887680)
print v(xbgr.mr_n79887792)
print v(xbgr.mr_n79888112)
print v(xbgr.mr_n79888224)
print v(xbgr.mr_n79888544)
print v(xbgr.mr_n79888656)
print v(xbgr.mr_n79888976)
print v(xbgr.mr_n79889408)
print v(xbgr.mr_n79890272)
print v(xbgr.mr_n79891136)
print v(xbgr.mr_n79892432)
print v(xbgr.mr_n79893296)
print v(xbgr.mr_n79894160)
print v(xbgr.mr_n79895024)
print v(xbgr.mr_n79895136)
print v(xbgr.mr_n79895456)
print v(xbgr.mr_n79896320)
print v(xbgr.mr_n79897184)
print v(xbgr.mr_n79898048)
print v(xbgr.mr_n79898160)
print v(xbgr.mr_n79898480)
print v(xbgr.mr_n79898592)
print v(xbgr.mr_n79898912)
print v(xbgr.mr_n79899024)
print v(xbgr.mr_n79899344)
print v(xbgr.mr_n79899456)
print v(xbgr.mr_n79899776)
print v(xbgr.mr_n79899888)
print v(xbgr.mr_n79900208)
print v(xbgr.mr_n79900320)
print v(xbgr.mr_n79901936)
print v(xbgr.mr_n79902912)
print v(xbgr.mr_n79903344)
print v(xbgr.mr_n79903776)
print v(xbgr.mr_n79904096)
print v(xbgr.mr_n79904208)
print v(xbgr.mr_n79904528)
print v(xbgr.mr_n79904640)
print v(xbgr.mr_n79904960)
print v(xbgr.mr_n79905072)
print v(xbgr.mr_n79905392)
print v(xbgr.mr_n79905504)
print v(xbgr.mr_n79905824)
print v(xbgr.mr_n79905936)
print v(xbgr.mr_n79906256)
print v(xbgr.mr_n79906368)
print v(xbgr.mr_n79906688)
print v(xbgr.mr_n79906800)
print v(xbgr.mr_n79907232)
print v(xbgr.mr_n79907552)
print v(xbgr.mr_n79907664)
print v(xbgr.mr_n79908096)
print v(xbgr.mr_n79908528)
print v(xbgr.mr_n79909712)
print v(xbgr.mr_n79909824)
print v(xbgr.mr_n79910144)
print v(xbgr.mr_n79910256)
print v(xbgr.mr_n79910576)
print v(xbgr.mr_n79910688)
print v(xbgr.mr_n79911008)
print v(xbgr.mr_n79911120)
print v(xbgr.mr_n79911440)
print v(xbgr.mr_n79911552)
print v(xbgr.mr_n79911872)
print v(xbgr.mr_n79912304)
print v(xbgr.mr_n79912416)
print v(xbgr.mr_n79912736)
print v(xbgr.mr_n79912848)
print v(xbgr.mr_n79913168)
print v(xbgr.mr_n79913280)
print v(xbgr.mr_n79913600)
print v(xbgr.mr_n79913712)
print v(xbgr.mr_n79914144)
print v(xbgr.mr_n79914464)
print v(xbgr.mr_n79914896)
print v(xbgr.mr_n79915760)
print v(xbgr.mr_n79915872)
print v(xbgr.mr_n79916192)
print v(xbgr.mr_n79916624)
print v(xbgr.mr_n79917056)
print v(xbgr.mr_n79917600)
print v(xbgr.mr_n79917920)
print v(xbgr.mr_n79918784)
print v(xbgr.mr_n79918896)
print v(xbgr.mr_n79919216)
print v(xbgr.mr_n79919328)
print v(xbgr.mr_n79919760)
print v(xbgr.mr_n79920512)
print v(xbgr.mr_n79920944)
print v(xbgr.mr_n79921376)
print v(xbgr.mr_n79921808)
print v(xbgr.mr_n79921920)
print v(xbgr.mr_n79923104)
print v(xbgr.mr_n79923968)
print v(xbgr.mr_n79924944)
print v(xbgr.mr_n79925264)
print v(xbgr.mr_n79925376)
print v(xbgr.mr_n79925808)
print v(xbgr.mr_n79926128)
print v(xbgr.mr_n79926240)
print v(xbgr.mr_n79926560)
print v(xbgr.mr_n79926672)
print v(xbgr.mr_n79926992)
print v(xbgr.mr_n79927104)
print v(xbgr.mr_n79927424)
print v(xbgr.mr_n79927536)
print v(xbgr.mr_n79927856)
print v(xbgr.mr_n79927968)
print v(xbgr.mr_n79928288)
print v(xbgr.mr_n79928400)
print v(xbgr.mr_n79928832)
print v(xbgr.mr_n79929264)
print v(xbgr.mr_n79929696)
print v(xbgr.mr_n79930448)
print v(xbgr.mr_n79930880)
print v(xbgr.mr_n79931744)
print v(xbgr.mr_n79932608)
print v(xbgr.mr_n79934336)
print v(xbgr.mr_n79935200)
print v(xbgr.mr_n79935312)
print v(xbgr.mr_n79936064)
print v(xbgr.mr_n79936176)
print v(xbgr.mr_n79936496)
print v(xbgr.mr_n79936608)
print v(xbgr.mr_n79936928)
print v(xbgr.mr_n79937040)
print v(xbgr.mr_n79939088)
print v(xbgr.mr_n79939200)
print v(xbgr.mr_n79939520)
print v(xbgr.mr_n79939632)
print v(xbgr.mr_n79939952)
print v(xbgr.mr_n79940064)
print v(xbgr.mr_n79940384)
print v(xbgr.mr_n79940496)
print v(xbgr.mr_n79940816)
print v(xbgr.mr_n79940928)
print v(xbgr.mr_n79941248)
print v(xbgr.mr_n79941360)
print v(xbgr.mr_n79941680)
print v(xbgr.mr_n79941792)
print v(xbgr.mr_n79942224)
print v(xbgr.mr_n79942544)
print v(xbgr.mr_n79942656)
print v(xbgr.mr_n79943088)
print v(xbgr.mr_n79943408)
print v(xbgr.mr_n79943520)
print v(xbgr.mr_n79943952)
print v(xbgr.mr_n79944272)
print v(xbgr.mr_n79944384)
print v(xbgr.mr_n79944704)
print v(xbgr.mr_n79944816)
print v(xbgr.mr_n79945136)
print v(xbgr.mr_n79945248)
print v(xbgr.mr_n79945568)
print v(xbgr.mr_n79945680)
print v(xbgr.mr_n79946000)
print v(xbgr.mr_n79946112)
print v(xbgr.mr_n79946432)
print v(xbgr.mr_n79946544)
print v(xbgr.mr_n79946864)
print v(xbgr.mr_n79946976)
print v(xbgr.mr_n79947296)
print v(xbgr.mr_n79947408)
print v(xbgr.mr_n79947728)
print v(xbgr.mr_n79947840)
print v(xbgr.mr_n79948160)
print v(xbgr.mr_n79948272)
print v(xbgr.mr_n79948592)
print v(xbgr.mr_n79948704)
print v(xbgr.mr_n79949024)
print v(xbgr.mr_n79949136)
print v(xbgr.mr_n79949456)
print v(xbgr.mr_n79949568)
print v(xbgr.mr_n79949888)
print v(xbgr.mr_n79950000)
print v(xbgr.mr_n79950320)
print v(xbgr.mr_n79950432)
print v(xbgr.mr_n79950752)
print v(xbgr.mr_n79950864)
print v(xbgr.mr_n79951184)
print v(xbgr.mr_n79951296)
print v(xbgr.mr_n79951616)
print v(xbgr.mr_n79951728)
print v(xbgr.mr_n79952160)
print v(xbgr.mr_n79952480)
print v(xbgr.mr_n79952592)
print v(xbgr.mr_n79953024)
print v(xbgr.mr_n79953344)
print v(xbgr.mr_n79953456)
print v(xbgr.mr_n79953888)
print v(xbgr.mr_n79954208)
print v(xbgr.mr_n79955072)
print v(xbgr.mr_n79955936)
print v(xbgr.mr_n79956800)
print v(xbgr.mr_n79957664)
print v(xbgr.mr_n79958528)
print v(xbgr.mr_n79959392)
print v(xbgr.mr_n79959504)
print v(xbgr.mr_n79959824)
print v(xbgr.mr_n79959936)
print v(xbgr.mr_n79960256)
print v(xbgr.mr_n79960368)
print v(xbgr.mr_n79960688)
print v(xbgr.mr_n79960800)
print v(xbgr.mr_n79961120)
print v(xbgr.mr_n79961232)
print v(xbgr.mr_n79961552)
print v(xbgr.mr_n79961664)
print v(xbgr.mr_n79961984)
print v(xbgr.mr_n79962848)
print v(xbgr.mr_n79963712)
print v(xbgr.mr_n79964576)
print v(xbgr.mr_n79964688)
print v(xbgr.mr_n79965008)
print v(xbgr.mr_n79965120)
print v(xbgr.mr_n79965440)
print v(xbgr.mr_n79965552)
print v(xbgr.mr_n79965984)
print v(xbgr.mr_n79966416)
print v(xbgr.mr_n79966848)
print v(xbgr.mr_n79967168)
print v(xbgr.mr_n79967280)
print v(xbgr.mr_n79967712)
print v(xbgr.mr_n79968032)
print v(xbgr.mr_n79968144)
print v(xbgr.mr_n79968464)
print v(xbgr.mr_n79968576)
print v(xbgr.mr_n79968896)
print v(xbgr.mr_n79969008)
print v(xbgr.mr_n79969328)
print v(xbgr.mr_n79969440)
print v(xbgr.mr_n79969760)
print v(xbgr.mr_n79969872)
print v(xbgr.mr_n79970192)
print v(xbgr.mr_n79970304)
print v(xbgr.mr_n79970736)
print v(xbgr.mr_n79971168)
print v(xbgr.mr_n79971488)
print v(xbgr.mr_n79971600)
print v(xbgr.mr_n79972032)
print v(xbgr.mr_n79972352)
print v(xbgr.mr_n79972464)
print v(xbgr.mr_n79972896)
print v(xbgr.mr_n79973216)
print v(xbgr.mr_n79973328)
print v(xbgr.mr_n79973760)
print v(xbgr.mr_n79974080)
print v(xbgr.mr_n79974944)
print v(xbgr.mr_n79975808)
print v(xbgr.mr_n79976672)
print v(xbgr.mr_n79977536)
print v(xbgr.mr_n79978400)
print v(xbgr.mr_n79978512)
print v(xbgr.mr_n79978832)
print v(xbgr.mr_n79978944)
print v(xbgr.mr_n79979264)
print v(xbgr.mr_n79979376)
print v(xbgr.mr_n79979696)
print v(xbgr.mr_n79979808)
print v(xbgr.mr_n79980128)
print v(xbgr.mr_n79980992)
print v(xbgr.mr_n79981856)
print v(xbgr.mr_n79982720)
print v(xbgr.mr_n79982832)
print v(xbgr.mr_n79983152)
print v(xbgr.mr_n79983264)
print v(xbgr.mr_n79983584)
print v(xbgr.mr_n79983696)
print v(xbgr.mr_n79984016)
print v(xbgr.mr_n79984128)
print v(xbgr.mr_n79984448)
print v(xbgr.mr_n79984560)
print v(xbgr.mr_n79984880)
print v(xbgr.mr_n79984992)
print v(xbgr.mr_n79985312)
print v(xbgr.mr_n79986176)
print v(xbgr.mr_n79987040)
print v(xbgr.mr_n79987904)
print v(xbgr.mr_n79988768)
print v(xbgr.mr_n79989632)
print v(xbgr.mr_n79990496)
print v(xbgr.mr_n79991360)
print v(xbgr.mr_n79992224)
print v(xbgr.mr_n79993088)
print v(xbgr.mr_n79993200)
print v(xbgr.mr_n79993520)
print v(xbgr.mr_n79993632)
print v(xbgr.mr_n79993952)
print v(xbgr.mr_n79994064)
print v(xbgr.mr_n79994384)
print v(xbgr.mr_n79994496)
print v(xbgr.mr_n79994816)
print v(xbgr.mr_n79994928)
print v(xbgr.mr_n79995248)
print v(xbgr.mr_n79995360)
print v(xbgr.mr_n79995680)
print v(xbgr.mr_n79995792)
print v(xbgr.mr_n79996112)
print v(xbgr.mr_n79996224)
print v(xbgr.mr_n79996544)
print v(xbgr.mr_n79996656)
print v(xbgr.mr_n79996976)
print v(xbgr.mr_n79997088)
print v(xbgr.mr_n79997408)
print v(xbgr.mr_n79998272)
print v(xbgr.mr_n79998384)
print v(xbgr.mr_n79998704)
print v(xbgr.mr_n79998816)
print v(xbgr.mr_n79999136)
print v(xbgr.mr_n79999248)
print v(xbgr.mr_n79999568)
print v(xbgr.mr_n79999680)
print v(xbgr.mr_n80000000)
print v(xbgr.mr_n80000112)
print v(xbgr.mr_n80000432)
print v(xbgr.mr_n80000544)
print v(xbgr.mr_n80000864)
print v(xbgr.mr_n80000976)
print v(xbgr.mr_n80001296)
print v(xbgr.mr_n80001408)
print v(xbgr.mr_n80001728)
print v(xbgr.mr_n80001840)
print v(xbgr.mr_n80002160)
print v(xbgr.mr_n80002272)
print v(xbgr.mr_n80002592)
print v(xbgr.mr_n80002704)
print v(xbgr.mr_n80003136)
print v(xbgr.mr_n80003456)
print v(xbgr.mr_n80003568)
print v(xbgr.mr_n80004000)
print v(xbgr.mr_n80004320)
print v(xbgr.mr_n80004432)
print v(xbgr.mr_n80004864)
print v(xbgr.mr_n80005184)
print v(xbgr.mr_n80005296)
print v(xbgr.mr_n80005728)
print v(xbgr.mr_n80006048)
print v(xbgr.mr_n80006160)
print v(xbgr.mr_n80006480)
print v(xbgr.mr_n80006592)
print v(xbgr.mr_n80007024)
print v(xbgr.mr_n80007456)
print v(xbgr.mr_n80007776)
print v(xbgr.mr_n80007888)
print v(xbgr.mr_n80008208)
print v(xbgr.mr_n80008320)
print v(xbgr.mr_n80008640)
print v(xbgr.mr_n80008752)
print v(xbgr.mr_n80009072)
print v(xbgr.mr_n80009184)
print v(xbgr.mr_n80009504)
print v(xbgr.mr_n80009616)
print v(xbgr.mr_n80010048)
print v(xbgr.mr_n80010368)
print v(xbgr.mr_n80010480)
print v(xbgr.mr_n80010912)
print v(xbgr.mr_n80011232)
print v(xbgr.mr_n80012096)
print v(xbgr.mr_n80012960)
print v(xbgr.mr_n80013824)
print v(xbgr.mr_n80014688)
print v(xbgr.mr_n80014800)
print v(xbgr.mr_n80015120)
print v(xbgr.mr_n80015232)
print v(xbgr.mr_n80015552)
print v(xbgr.mr_n80015664)
print v(xbgr.mr_n80015984)
print v(xbgr.mr_n80016096)
print v(xbgr.mr_n80016416)
print v(xbgr.mr_n80017280)
print v(xbgr.mr_n80018144)
print v(xbgr.mr_n80018256)
print v(xbgr.mr_n80018576)
print v(xbgr.mr_n80018688)
print v(xbgr.mr_n80019120)
print v(xbgr.mr_n80019552)
print v(xbgr.mr_n80019872)
print v(xbgr.mr_n80019984)
print v(xbgr.mr_n80020304)
print v(xbgr.mr_n80020416)
print v(xbgr.mr_n80020736)
print v(xbgr.mr_n80020848)
print v(xbgr.mr_n80021168)
print v(xbgr.mr_n80021280)
print v(xbgr.mr_n80021600)
print v(xbgr.mr_n80021712)
print v(xbgr.mr_n80022144)
print v(xbgr.mr_n80022464)
print v(xbgr.mr_n80022576)
print v(xbgr.mr_n80023008)
print v(xbgr.mr_n80023328)
print v(xbgr.mr_n80023440)
print v(xbgr.mr_n80023760)
print v(xbgr.mr_n80023872)
print v(xbgr.mr_n80024192)
print v(xbgr.mr_n80024304)
print v(xbgr.mr_n80024624)
print v(xbgr.mr_n80024736)
print v(xbgr.mr_n80025056)
print v(xbgr.mr_n80025168)
print v(xbgr.mr_n80025488)
print v(xbgr.mr_n80025600)
print v(xbgr.mr_n80025920)
print v(xbgr.mr_n80026032)
print v(xbgr.mr_n80026352)
print v(xbgr.mr_n80026464)
print v(xbgr.mr_n80026784)
print v(xbgr.mr_n80026896)
print v(xbgr.mr_n80027216)
print v(xbgr.mr_n80027328)
print v(xbgr.mr_n80027648)
print v(xbgr.mr_n80028512)
print v(xbgr.mr_n80029376)
print v(xbgr.mr_n80030240)
print v(xbgr.mr_n80031104)
print v(xbgr.mr_n80031216)
print v(xbgr.mr_n80031536)
print v(xbgr.mr_n80031648)
print v(xbgr.mr_n80031968)
print v(xbgr.mr_n80032080)
print v(xbgr.mr_n80032400)
print v(xbgr.mr_n80032512)
print v(xbgr.mr_n80032944)
print v(xbgr.mr_n80033376)
print v(xbgr.mr_n80033808)
print v(xbgr.mr_n80034240)
print v(xbgr.mr_n80034560)
print v(xbgr.mr_n80034672)
print v(xbgr.mr_n80034992)
print v(xbgr.mr_n80035104)
print v(xbgr.mr_n80035424)
print v(xbgr.mr_n80035536)
print v(xbgr.mr_n80035856)
print v(xbgr.mr_n80035968)
print v(xbgr.mr_n80036288)
print v(xbgr.mr_n80037152)
print v(xbgr.mr_n80038016)
print v(xbgr.mr_n80038128)
print v(xbgr.mr_n80038560)
print v(xbgr.mr_n80038880)
print v(xbgr.mr_n80039744)
print v(xbgr.mr_n80039856)
print v(xbgr.mr_n80040176)
print v(xbgr.mr_n80040288)
print v(xbgr.mr_n80040608)
print v(xbgr.mr_n80040720)
print v(xbgr.mr_n80041040)
print v(xbgr.mr_n80041152)
print v(xbgr.mr_n80041472)
print v(xbgr.mr_n80042336)
print v(xbgr.mr_n80042448)
print v(xbgr.mr_n80042880)
print v(xbgr.mr_n80043200)
print v(xbgr.mr_n80043312)
print v(xbgr.mr_n80043632)
print v(xbgr.mr_n80043744)
print v(xbgr.mr_n80044064)
print v(xbgr.mr_n80044176)
print v(xbgr.mr_n80044496)
print v(xbgr.mr_n80044608)
print v(xbgr.mr_n80044928)
print v(xbgr.mr_n80045792)
print v(xbgr.mr_n80046224)
print v(xbgr.mr_n80046336)
print v(xbgr.mr_n80046656)
print v(xbgr.mr_n80046768)
print v(xbgr.mr_n80047088)
print v(xbgr.mr_n80047520)
print v(xbgr.mr_n80048384)
print v(xbgr.mr_n80049248)
print v(xbgr.mr_n80049360)
print v(xbgr.mr_n80050112)
print v(xbgr.mr_n80050224)
print v(xbgr.mr_n80050544)
print v(xbgr.mr_n80050656)
print v(xbgr.mr_n80050976)
print v(xbgr.mr_n80051840)
print v(xbgr.mr_n80052704)
print v(xbgr.mr_n80052816)
print v(xbgr.mr_n80053136)
print v(xbgr.mr_n80053248)
print v(xbgr.mr_n80053568)
print v(xbgr.mr_n80054432)
print v(xbgr.mr_n80054544)
print v(xbgr.mr_n80054864)
print v(xbgr.mr_n80054976)
print v(xbgr.mr_n80055296)
print v(xbgr.mr_n80055408)
print v(xbgr.mr_n80055728)
print v(xbgr.mr_n80055840)
print v(xbgr.mr_n80056160)
print v(xbgr.mr_n80056272)
print v(xbgr.mr_n80057024)
print v(xbgr.mr_n80057888)
print v(xbgr.mr_n80058752)
print v(xbgr.mr_n80058864)
print v(xbgr.mr_n80059184)
print v(xbgr.mr_n80059296)
print v(xbgr.mr_n80059616)
print v(xbgr.mr_n80059728)
print v(xbgr.mr_n80060048)
print v(xbgr.mr_n80060160)
print v(xbgr.mr_n80060480)
print v(xbgr.mr_n80060592)
print v(xbgr.mr_n80060912)
print v(xbgr.mr_n80061024)
print v(xbgr.mr_n80061344)
print v(xbgr.mr_n80061456)
print v(xbgr.mr_n80061888)
print v(xbgr.mr_n80062208)
print v(xbgr.mr_n80062320)
print v(xbgr.mr_n80062640)
print v(xbgr.mr_n80062752)
print v(xbgr.mr_n80063072)
print v(xbgr.mr_n80063936)
print v(xbgr.mr_n80064800)
print v(xbgr.mr_n80065664)
print v(xbgr.mr_n80066528)
print v(xbgr.mr_n80066960)
print v(xbgr.mr_n80067072)
print v(xbgr.mr_n80067392)
print v(xbgr.mr_n80067504)
print v(xbgr.mr_n80067824)
print v(xbgr.mr_n80067936)
print v(xbgr.mr_n80068368)
print v(xbgr.mr_n80069120)
print v(xbgr.mr_n80069232)
print v(xbgr.mr_n80069552)
print v(xbgr.mr_n80069664)
print v(xbgr.mr_n80069984)
print v(xbgr.mr_n80070848)
print v(xbgr.mr_n80071712)
print v(xbgr.mr_n80071824)
print v(xbgr.mr_n80072144)
print v(xbgr.mr_n80072256)
print v(xbgr.mr_n80072576)
print v(xbgr.mr_n80073440)
print v(xbgr.mr_n80074304)
print v(xbgr.mr_n80075168)
print v(xbgr.mr_n80075280)
print v(xbgr.mr_n80075600)
print v(xbgr.mr_n80075712)
print v(xbgr.mr_n80076032)
print v(xbgr.mr_n80076896)
print v(xbgr.mr_n80077760)
print v(xbgr.mr_n80077872)
print v(xbgr.mr_n80078192)
print v(xbgr.mr_n80078304)
print v(xbgr.mr_n80078624)
print v(xbgr.mr_n80078736)
print v(xbgr.mr_n80079056)
print v(xbgr.mr_n80079168)
print v(xbgr.mr_n80079488)
print v(xbgr.mr_n80079600)
print v(xbgr.mr_n80079920)
print v(xbgr.mr_n80080032)
print v(xbgr.mr_n80080352)
print v(xbgr.mr_n80080464)
print v(xbgr.mr_n80080784)
print v(xbgr.mr_n80080896)
print v(xbgr.mr_n80081216)
print v(xbgr.mr_n80081328)
print v(xbgr.mr_n80081648)
print v(xbgr.mr_n80081760)
print v(xbgr.mr_n80082080)
print v(xbgr.mr_n80082192)
print v(xbgr.mr_n80082512)
print v(xbgr.mr_n80082624)
print v(xbgr.mr_n80082944)
print v(xbgr.mr_n80083056)
print v(xbgr.mr_n80083376)
print v(xbgr.mr_n80083488)
print v(xbgr.mr_n80083808)
print v(xbgr.mr_n80083920)
print v(xbgr.mr_n80084240)
print v(xbgr.mr_n80084352)
print v(xbgr.mr_n80084672)
print v(xbgr.mr_n80084784)
print v(xbgr.mr_n80085104)
print v(xbgr.mr_n80085216)
print v(xbgr.mr_n80085536)
print v(xbgr.mr_n80085648)
print v(xbgr.mr_n80085968)
print v(xbgr.mr_n80086080)
print v(xbgr.mr_n80086400)
print v(xbgr.mr_n80086512)
print v(xbgr.mr_n80086832)
print v(xbgr.mr_n80086944)
print v(xbgr.mr_n80087264)
print v(xbgr.mr_n80087376)
print v(xbgr.mr_n80087696)
print v(xbgr.mr_n80087808)
print v(xbgr.mr_n80088128)
print v(xbgr.mr_n80088240)
print v(xbgr.mr_n80088560)
print v(xbgr.mr_n80088672)
print v(xbgr.mr_n80089104)
print v(xbgr.mr_n80089536)
print v(xbgr.mr_n80089968)
print v(xbgr.mr_n80090400)
print v(xbgr.mr_n80090832)
print v(xbgr.mr_n80091264)
print v(xbgr.mr_n80091696)
print v(xbgr.mr_n80092128)
print v(xbgr.mr_n80092560)
print v(xbgr.mr_n80092992)
print v(xbgr.mr_n80093424)
print v(xbgr.mr_n80093856)
print v(xbgr.mr_n80094288)
print v(xbgr.mr_n80094720)
print v(xbgr.mr_n80095152)
print v(xbgr.mr_n80095584)
print v(xbgr.mr_n80096016)
print v(xbgr.mr_n80096448)
print v(xbgr.mr_n80096880)
print v(xbgr.mr_n80097312)
print v(xbgr.mr_n80097744)
print v(xbgr.mr_n80098176)
print v(xbgr.mr_n80098608)
print v(xbgr.mr_n80099040)
print v(xbgr.mr_n80099472)
print v(xbgr.mr_n80099904)
print v(xbgr.mr_n80100224)
print v(xbgr.mr_n80100336)
print v(xbgr.mr_n80100656)
print v(xbgr.mr_n80100768)
print v(xbgr.mr_n80101088)
print v(xbgr.mr_n80101200)
print v(xbgr.mr_n80101520)
print v(xbgr.mr_n80101632)
print v(xbgr.mr_n80101952)
print v(xbgr.mr_n80102064)
print v(xbgr.mr_n80102384)
print v(xbgr.mr_n80102496)
print v(xbgr.mr_n80102816)
print v(xbgr.mr_n80102928)
print v(xbgr.mr_n80103248)
print v(xbgr.mr_n80103360)
print v(xbgr.mr_n80103680)
print v(xbgr.mr_n80103792)
print v(xbgr.mr_n80104112)
print v(xbgr.mr_n80104224)
print v(xbgr.mr_n80104544)
print v(xbgr.mr_n80104656)
print v(xbgr.mr_n80104976)
print v(xbgr.mr_n80105088)
print v(xbgr.mr_n80105408)
print v(xbgr.mr_n80105520)
print v(xbgr.mr_n80105840)
print v(xbgr.mr_n80105952)
print v(xbgr.mr_n80106272)
print v(xbgr.mr_n80106384)
print v(xbgr.mr_n80106704)
print v(xbgr.mr_n80106816)
print v(xbgr.mr_n80107136)
print v(xbgr.mr_n80107248)
print v(xbgr.mr_n80107568)
print v(xbgr.mr_n80107680)
print v(xbgr.mr_n80108000)
print v(xbgr.mr_n80108112)
print v(xbgr.mr_n80108432)
print v(xbgr.mr_n80108544)
print v(xbgr.mr_n80108864)
print v(xbgr.mr_n80108976)
print v(xbgr.mr_n80109296)
print v(xbgr.mr_n80109408)
print v(xbgr.mr_n80109728)
print v(xbgr.mr_n80109840)
print v(xbgr.mr_n80110160)
print v(xbgr.mr_n80110272)
print v(xbgr.mr_n80110704)
print v(xbgr.mr_n80111136)
print v(xbgr.mr_n80111568)
print v(xbgr.mr_n80112000)
print v(xbgr.mr_n80112320)
print v(xbgr.mr_n80112432)
print v(xbgr.mr_n80112752)
print v(xbgr.mr_n80112864)
print v(xbgr.mr_n80113296)
print v(xbgr.mr_n80113728)
print v(xbgr.mr_n80114160)
print v(xbgr.mr_n80114592)
print v(xbgr.mr_n80115024)
print v(xbgr.mr_n80115456)
print v(xbgr.mr_n80115888)
print v(xbgr.mr_n80116320)
print v(xbgr.mr_n80116752)
print v(xbgr.mr_n80117184)
print v(xbgr.mr_n80117616)
print v(xbgr.mr_n80118048)
print v(xbgr.mr_n80118480)
print v(xbgr.mr_n80118912)
print v(xbgr.mr_n80119344)
print v(xbgr.mr_n80119776)
print v(xbgr.mr_n80120208)
print v(xbgr.mr_n80120640)
print v(xbgr.mr_n80121072)
print v(xbgr.mr_n80121504)
print v(xbgr.mr_n80121936)
print v(xbgr.mr_n80122368)
print v(xbgr.mr_n80122688)
print v(xbgr.mr_n80122800)
print v(xbgr.mr_n80123232)
print v(xbgr.mr_n80123552)
print v(xbgr.mr_n80123664)
print v(xbgr.mr_n80124096)
print v(xbgr.mr_n80124416)
print v(xbgr.mr_n80124528)
print v(xbgr.mr_n80124960)
print v(xbgr.mr_n80125280)
print v(xbgr.mr_n80125392)
print v(xbgr.mr_n80125824)
print v(xbgr.mr_n80126144)
print v(xbgr.mr_n80126256)
print v(xbgr.mr_n80126688)
print v(xbgr.mr_n80127008)
print v(xbgr.mr_n80127120)
print v(xbgr.mr_n80127440)
print v(xbgr.mr_n80127552)
print v(xbgr.mr_n80127872)
print v(xbgr.mr_n80127984)
print v(xbgr.mr_n80128416)
print v(xbgr.mr_n80128848)
print v(xbgr.mr_n80129280)
print v(xbgr.mr_n80129600)
print v(xbgr.mr_n80129712)
print v(xbgr.mr_n80130032)
print v(xbgr.mr_n80130144)
print v(xbgr.mr_n80130464)
print v(xbgr.mr_n80130576)
print v(xbgr.mr_n80130896)
print v(xbgr.mr_n80131008)
print v(xbgr.mr_n80131328)
print v(xbgr.mr_n80131440)
print v(xbgr.mr_n80131760)
print v(xbgr.mr_n80131872)
print v(xbgr.mr_n80132192)
print v(xbgr.mr_n80132304)
print v(xbgr.mr_n80132736)
print v(xbgr.mr_n80133056)
print v(xbgr.mr_n80133168)
print v(xbgr.mr_n80133600)
print v(xbgr.mr_n80133920)
print v(xbgr.mr_n80134032)
print v(xbgr.mr_n80134464)
print v(xbgr.mr_n80134784)
print v(xbgr.mr_n80135648)
print v(xbgr.mr_n80136512)
print v(xbgr.mr_n80137376)
print v(xbgr.mr_n80138240)
print v(xbgr.mr_n80139104)
print v(xbgr.mr_n80139968)
print v(xbgr.mr_n80140080)
print v(xbgr.mr_n80140400)
print v(xbgr.mr_n80140512)
print v(xbgr.mr_n80140832)
print v(xbgr.mr_n80140944)
print v(xbgr.mr_n80141264)
print v(xbgr.mr_n80141376)
print v(xbgr.mr_n80141696)
print v(xbgr.mr_n80142560)
print v(xbgr.mr_n80143424)
print v(xbgr.mr_n80144288)
print v(xbgr.mr_n80144400)
print v(xbgr.mr_n80144720)
print v(xbgr.mr_n80144832)
print v(xbgr.mr_n80145152)
print v(xbgr.mr_n80145264)
print v(xbgr.mr_n80145696)
print v(xbgr.mr_n80146128)
print v(xbgr.mr_n80146560)
print v(xbgr.mr_n80146880)
print v(xbgr.mr_n80146992)
print v(xbgr.mr_n80147312)
print v(xbgr.mr_n80147424)
print v(xbgr.mr_n80147744)
print v(xbgr.mr_n80147856)
print v(xbgr.mr_n80148176)
print v(xbgr.mr_n80148288)
print v(xbgr.mr_n80148608)
print v(xbgr.mr_n80148720)
print v(xbgr.mr_n80149040)
print v(xbgr.mr_n80149152)
print v(xbgr.mr_n80149472)
print v(xbgr.mr_n80149584)
print v(xbgr.mr_n80149904)
print v(xbgr.mr_n80150016)
print v(xbgr.mr_n80150336)
print v(xbgr.mr_n80150448)
print v(xbgr.mr_n80150880)
print v(xbgr.mr_n80151200)
print v(xbgr.mr_n80151312)
print v(xbgr.mr_n80151744)
print v(xbgr.mr_n80152064)
print v(xbgr.mr_n80152176)
print v(xbgr.mr_n80152496)
print v(xbgr.mr_n80152608)
print v(xbgr.mr_n80152928)
print v(xbgr.mr_n80153792)
print v(xbgr.mr_n80154656)
print v(xbgr.mr_n80154768)
print v(xbgr.mr_n80155088)
print v(xbgr.mr_n80155200)
print v(xbgr.mr_n80155520)
print v(xbgr.mr_n80156384)
print v(xbgr.mr_n80156928)
print v(xbgr.mr_n80157360)
print v(xbgr.mr_n80158112)
print v(xbgr.mr_n80158976)
print v(xbgr.mr_n80159088)
print v(xbgr.mr_n80159408)
print v(xbgr.mr_n80159520)
print v(xbgr.mr_n80159840)
print v(xbgr.mr_n80159952)
print v(xbgr.mr_n80160272)
print v(xbgr.mr_n80160384)
print v(xbgr.mr_n80160704)
print v(xbgr.mr_n80160816)
print v(xbgr.mr_n80161136)
print v(xbgr.mr_n80161248)
print v(xbgr.mr_n80161568)
print v(xbgr.mr_n80161680)
print v(xbgr.mr_n80162000)
print v(xbgr.mr_n80162112)
print v(xbgr.mr_n80162432)
print v(xbgr.mr_n80163296)
print v(xbgr.mr_n80163408)
print v(xbgr.mr_n80163728)
print v(xbgr.mr_n80163840)
print v(xbgr.mr_n80164160)
print v(xbgr.mr_n80165024)
print v(xbgr.mr_n80165888)
print v(xbgr.mr_n80166000)
print v(xbgr.mr_n80166320)
print v(xbgr.mr_n80166432)
print v(xbgr.mr_n80166752)
print v(xbgr.mr_n80166864)
print v(xbgr.mr_n80167296)
print v(xbgr.mr_n80167616)
print v(xbgr.mr_n80168048)
print v(xbgr.mr_n80169344)
print v(xbgr.mr_n80169456)
print v(xbgr.mr_n80169776)
print v(xbgr.mr_n80169888)
print v(xbgr.mr_n80170208)
print v(xbgr.mr_n80170320)
print v(xbgr.mr_n80170640)
print v(xbgr.mr_n80170752)
print v(xbgr.mr_n80171072)
print v(xbgr.mr_n80171184)
print v(xbgr.mr_n80171616)
print v(xbgr.mr_n80171936)
print v(xbgr.mr_n80172048)
print v(xbgr.mr_n80172368)
print v(xbgr.mr_n80172480)
print v(xbgr.mr_n80172800)
print v(xbgr.mr_n80172912)
print v(xbgr.mr_n80173232)
print v(xbgr.mr_n80173344)
print v(xbgr.mr_n80173664)
print v(xbgr.mr_n80174528)
print v(xbgr.mr_n80175392)
print v(xbgr.mr_n80176256)
print v(xbgr.mr_n80177120)
print v(xbgr.mr_n80177232)
print v(xbgr.mr_n80177552)
print v(xbgr.mr_n80177664)
print v(xbgr.mr_n80177984)
print v(xbgr.mr_n80178096)
print v(xbgr.mr_n80178416)
print v(xbgr.mr_n80178528)
print v(xbgr.mr_n80178848)
print v(xbgr.mr_n80179712)
print v(xbgr.mr_n80180576)
print v(xbgr.mr_n80181440)
print v(xbgr.mr_n80182304)
print v(xbgr.mr_n80182736)
print v(xbgr.mr_n80182848)
print v(xbgr.mr_n80183168)
print v(xbgr.mr_n80183280)
print v(xbgr.mr_n80183600)
print v(xbgr.mr_n80183712)
print v(xbgr.mr_n80184032)
print v(xbgr.mr_n80184144)
print v(xbgr.mr_n80184464)
print v(xbgr.mr_n80184576)
print v(xbgr.mr_n80184896)
print v(xbgr.mr_n80185008)
print v(xbgr.mr_n80185328)
print v(xbgr.mr_n80185440)
print v(xbgr.mr_n80185760)
print v(xbgr.mr_n80185872)
print v(xbgr.mr_n80186304)
print v(xbgr.mr_n80186624)
print v(xbgr.mr_n80186736)
print v(xbgr.mr_n80187168)
print v(xbgr.mr_n80187488)
print v(xbgr.mr_n80187600)
print v(xbgr.mr_n80188032)
print v(xbgr.mr_n80188352)
print v(xbgr.mr_n80188464)
print v(xbgr.mr_n80188784)
print v(xbgr.mr_n80188896)
print v(xbgr.mr_n80189216)
print v(xbgr.mr_n80190080)
print v(xbgr.mr_n80190944)
print v(xbgr.mr_n80191808)
print v(xbgr.mr_n80192672)
print v(xbgr.mr_n80193536)
print v(xbgr.mr_n80194400)
print v(xbgr.mr_n80195264)
print v(xbgr.mr_n80196128)
print v(xbgr.mr_n80196992)
print v(xbgr.mr_n80197104)
print v(xbgr.mr_n80197424)
print v(xbgr.mr_n80197536)
print v(xbgr.mr_n80197856)
print v(xbgr.mr_n80198720)
print v(xbgr.mr_n80198832)
print v(xbgr.mr_n80199152)
print v(xbgr.mr_n80199264)
print v(xbgr.mr_n80199584)
print v(xbgr.mr_n80199696)
print v(xbgr.mr_n80200016)
print v(xbgr.mr_n80200128)
print v(xbgr.mr_n80200448)
print v(xbgr.mr_n80200560)
print v(xbgr.mr_n80200880)
print v(xbgr.mr_n80200992)
print v(xbgr.mr_n80201312)
print v(xbgr.mr_n80201424)
print v(xbgr.mr_n80201744)
print v(xbgr.mr_n80201856)
print v(xbgr.mr_n80202176)
print v(xbgr.mr_n80203040)
print v(xbgr.mr_n80203904)
print v(xbgr.mr_n80204768)
print v(xbgr.mr_n80204880)
print v(xbgr.mr_n80205200)
print v(xbgr.mr_n80206496)
print v(xbgr.mr_n80207360)
print v(xbgr.mr_n80208224)
print v(xbgr.mr_n80209088)
print v(xbgr.mr_n80209200)
print v(xbgr.mr_n80209520)
print v(xbgr.mr_n80209632)
print v(xbgr.mr_n80210064)
print v(xbgr.mr_n80210384)
print v(xbgr.mr_n80210496)
print v(xbgr.mr_n80210928)
print v(xbgr.mr_n80211248)
print v(xbgr.mr_n80211360)
print v(xbgr.mr_n80211792)
print v(xbgr.mr_n80212112)
print v(xbgr.mr_n80212224)
print v(xbgr.mr_n80212656)
print v(xbgr.mr_n80212976)
print v(xbgr.mr_n80213088)
print v(xbgr.mr_n80213520)
print v(xbgr.mr_n80213840)
print v(xbgr.mr_n80213952)
print v(xbgr.mr_n80214272)
print v(xbgr.mr_n80214384)
print v(xbgr.mr_n80214704)
print v(xbgr.mr_n80214816)
print v(xbgr.mr_n80215248)
print v(xbgr.mr_n80215568)
print v(xbgr.mr_n80215680)
print v(xbgr.mr_n80216000)
print v(xbgr.mr_n80216112)
print v(xbgr.mr_n80216432)
print v(xbgr.mr_n80216544)
print v(xbgr.mr_n80216864)
print v(xbgr.mr_n80216976)
print v(xbgr.mr_n80217296)
print v(xbgr.mr_n80217408)
print v(xbgr.mr_n80217728)
print v(xbgr.mr_n80217840)
print v(xbgr.mr_n80218160)
print v(xbgr.mr_n80218272)
print v(xbgr.mr_n80218592)
print v(xbgr.mr_n80218704)
print v(xbgr.mr_n80219136)
print v(xbgr.mr_n80219456)
print v(xbgr.mr_n80220432)
print v(xbgr.mr_n80220864)
print v(xbgr.mr_n80221184)
print v(xbgr.mr_n80222048)
print v(xbgr.mr_n80222160)
print v(xbgr.mr_n80222480)
print v(xbgr.mr_n80222592)
print v(xbgr.mr_n80222912)
print v(xbgr.mr_n80223024)
print v(xbgr.mr_n80223344)
print v(xbgr.mr_n80223456)
print v(xbgr.mr_n80223776)
print v(xbgr.mr_n80224640)
print v(xbgr.mr_n80225072)
print v(xbgr.mr_n80225936)
print v(xbgr.mr_n80226800)
print v(xbgr.mr_n80226912)
print v(xbgr.mr_n80227232)
print v(xbgr.mr_n80227344)
print v(xbgr.mr_n80227664)
print v(xbgr.mr_n80227776)
print v(xbgr.mr_n80228096)
print v(xbgr.mr_n80228208)
print v(xbgr.mr_n80228960)
print v(xbgr.mr_n80229072)
print v(xbgr.mr_n80229392)
print v(xbgr.mr_n80229504)
print v(xbgr.mr_n80229824)
print v(xbgr.mr_n80229936)
print v(xbgr.mr_n80230256)
print v(xbgr.mr_n80230368)
print v(xbgr.mr_n80230688)
print v(xbgr.mr_n80231232)
print v(xbgr.mr_n80231552)
print v(xbgr.mr_n80231664)
print v(xbgr.mr_n80232096)
print v(xbgr.mr_n80232416)
print v(xbgr.mr_n80232528)
print v(xbgr.mr_n80233712)
print v(xbgr.mr_n80234144)
print v(xbgr.mr_n80234256)
print v(xbgr.mr_n80234576)
print v(xbgr.mr_n80234688)
print v(xbgr.mr_n80235008)
print v(xbgr.mr_n80235120)
print v(xbgr.mr_n80235440)
print v(xbgr.mr_n80235552)
print v(xbgr.mr_n80235872)
print v(xbgr.mr_n80235984)
print v(xbgr.mr_n80236304)
print v(xbgr.mr_n80236416)
print v(xbgr.mr_n80237168)
print v(xbgr.mr_n80238032)
print v(xbgr.mr_n80238144)
print v(xbgr.mr_n80238464)
print v(xbgr.mr_n80238576)
print v(xbgr.mr_n80238896)
print v(xbgr.mr_n80239008)
print v(xbgr.mr_n80239328)
print v(xbgr.mr_n80239440)
print v(xbgr.mr_n80239760)
print v(xbgr.mr_n80239872)
print v(xbgr.mr_n80240192)
print v(xbgr.mr_n80240304)
print v(xbgr.mr_n80240624)
print v(xbgr.mr_n80240736)
print v(xbgr.mr_n80241056)
print v(xbgr.mr_n80241168)
print v(xbgr.mr_n80241488)
print v(xbgr.mr_n80242352)
print v(xbgr.mr_n80243216)
print v(xbgr.mr_n80244080)
print v(xbgr.mr_n80244192)
print v(xbgr.mr_n80244624)
print v(xbgr.mr_n80245056)
print v(xbgr.mr_n80245376)
print v(xbgr.mr_n80245808)
print v(xbgr.mr_n80245920)
print v(xbgr.mr_n80246240)
print v(xbgr.mr_n80246352)
print v(xbgr.mr_n80247104)
print v(xbgr.mr_n80248512)
print v(xbgr.mr_n80248832)
print v(xbgr.mr_n80248944)
print v(xbgr.mr_n80249264)
print v(xbgr.mr_n80249376)
print v(xbgr.mr_n80249696)
print v(xbgr.mr_n80249808)
print v(xbgr.mr_n80250240)
print v(xbgr.mr_n80250560)
print v(xbgr.mr_n80250672)
print v(xbgr.mr_n80251104)
print v(xbgr.mr_n80251424)
print v(xbgr.mr_n80251856)
print v(xbgr.mr_n80252288)
print v(xbgr.mr_n80252400)
print v(xbgr.mr_n80252720)
print v(xbgr.mr_n80252832)
print v(xbgr.mr_n80253152)
print v(xbgr.mr_n80253264)
print v(xbgr.mr_n80254016)
print v(xbgr.mr_n80254880)
print v(xbgr.mr_n80254992)
print v(xbgr.mr_n80255424)
print v(xbgr.mr_n80255744)
print v(xbgr.mr_n80256608)
print v(xbgr.mr_n80257472)
print v(xbgr.mr_n80258768)
print v(xbgr.mr_n80259200)
print v(xbgr.mr_n80259312)
print v(xbgr.mr_n80259632)
print v(xbgr.mr_n80259744)
print v(xbgr.mr_n80260064)
print v(xbgr.mr_n80260176)
print v(xbgr.mr_n80260496)
print v(xbgr.mr_n80260608)
print v(xbgr.mr_n80260928)
print v(xbgr.mr_n80261040)
print v(xbgr.mr_n80261360)
print v(xbgr.mr_n80261472)
print v(xbgr.mr_n80261792)
print v(xbgr.mr_n80261904)
print v(xbgr.mr_n80262224)
print v(xbgr.mr_n80262336)
print v(xbgr.mr_n80263088)
print v(xbgr.mr_n80263952)
print v(xbgr.mr_n80264816)
print v(xbgr.mr_n80264928)
print v(xbgr.mr_n80265248)
print v(xbgr.mr_n80265360)
print v(xbgr.mr_n80265680)
print v(xbgr.mr_n80265792)
print v(xbgr.mr_n80266112)
print v(xbgr.mr_n80266976)
print v(xbgr.mr_n80267840)
print v(xbgr.mr_n80268704)
print v(xbgr.mr_n80269568)
print v(xbgr.mr_n80270432)
print v(xbgr.mr_n80271296)
print v(xbgr.mr_n80271408)
print v(xbgr.mr_n80271728)
print v(xbgr.mr_n80272592)
print v(xbgr.mr_n80272704)
print v(xbgr.mr_n80273024)
print v(xbgr.mr_n80273136)
print v(xbgr.mr_n80273456)
print v(xbgr.mr_n80274320)
print v(xbgr.mr_n80274752)
print v(xbgr.mr_n80274864)
print v(xbgr.mr_n80275616)
print v(xbgr.mr_n80275728)
print v(xbgr.mr_n80276048)
print v(xbgr.mr_n80276160)
print v(xbgr.mr_n80276480)
print v(xbgr.mr_n80276592)
print v(xbgr.mr_n80276912)
print v(xbgr.mr_n80277024)
print v(xbgr.mr_n80277344)
print v(xbgr.mr_n80277456)
print v(xbgr.mr_n80277776)
print v(xbgr.mr_n80277888)
print v(xbgr.mr_n80278208)
print v(xbgr.mr_n80278320)
print v(xbgr.mr_n80278640)
print v(xbgr.mr_n80278752)
print v(xbgr.mr_n80279072)
print v(xbgr.mr_n80279184)
print v(xbgr.mr_n80279504)
print v(xbgr.mr_n80280048)
print v(xbgr.mr_n80280800)
print v(xbgr.mr_n80281664)
print v(xbgr.mr_n80282528)
print v(xbgr.mr_n80282640)
print v(xbgr.mr_n80283072)
print v(xbgr.mr_n80283392)
print v(xbgr.mr_n80284256)
print v(xbgr.mr_n80285120)
print v(xbgr.mr_n80285984)
print v(xbgr.mr_n80286848)
print v(xbgr.mr_n80287712)
print v(xbgr.mr_n80288576)
print v(xbgr.mr_n80288688)
print v(xbgr.mr_n80289008)
print v(xbgr.mr_n80289120)
print v(xbgr.mr_n80289440)
print v(xbgr.mr_n80290304)
print v(xbgr.mr_n80291168)
print v(xbgr.mr_n80291280)
print v(xbgr.mr_n80291600)
print v(xbgr.mr_n80291712)
print v(xbgr.mr_n80292032)
print v(xbgr.mr_n80292144)
print v(xbgr.mr_n80292464)
print v(xbgr.mr_n80292576)
print v(xbgr.mr_n80292896)
print v(xbgr.mr_n80293008)
print v(xbgr.mr_n80293328)
print v(xbgr.mr_n80293440)
print v(xbgr.mr_n80293760)
print v(xbgr.mr_n80293872)
print v(xbgr.mr_n80294192)
print v(xbgr.mr_n80295056)
print v(xbgr.mr_n80295168)
print v(xbgr.mr_n80295488)
print v(xbgr.mr_n80295600)
print v(xbgr.mr_n80295920)
print v(xbgr.mr_n80296032)
print v(xbgr.mr_n80296352)
print v(xbgr.mr_n80296464)
print v(xbgr.mr_n80296784)
print v(xbgr.mr_n80296896)
print v(xbgr.mr_n80297216)
print v(xbgr.mr_n80297328)
print v(xbgr.mr_n80297648)
print v(xbgr.mr_n80297760)
print v(xbgr.mr_n80298080)
print v(xbgr.mr_n80298192)
print v(xbgr.mr_n80298624)
print v(xbgr.mr_n80299056)
print v(xbgr.mr_n80299488)
print v(xbgr.mr_n80299808)
print v(xbgr.mr_n80299920)
print v(xbgr.mr_n80300240)
print v(xbgr.mr_n80300352)
print v(xbgr.mr_n80300672)
print v(xbgr.mr_n80300784)
print v(xbgr.mr_n80301104)
print v(xbgr.mr_n80301216)
print v(xbgr.mr_n80301536)
print v(xbgr.mr_n80301648)
print v(xbgr.mr_n80301968)
print v(xbgr.mr_n80302080)
print v(xbgr.mr_n80302400)
print v(xbgr.mr_n80302512)
print v(xbgr.mr_n80302832)
print v(xbgr.mr_n80302944)
print v(xbgr.mr_n80303264)
print v(xbgr.mr_n80303376)
print v(xbgr.mr_n80303696)
print v(xbgr.mr_n80303808)
print v(xbgr.mr_n80304128)
print v(xbgr.mr_n80304240)
print v(xbgr.mr_n80304560)
print v(xbgr.mr_n80304672)
print v(xbgr.mr_n80304992)
print v(xbgr.mr_n80305104)
print v(xbgr.mr_n80305424)
print v(xbgr.mr_n80305536)
print v(xbgr.mr_n80305856)
print v(xbgr.mr_n80305968)
print v(xbgr.mr_n80306288)
print v(xbgr.mr_n80306400)
print v(xbgr.mr_n80306832)
print v(xbgr.mr_n80307152)
print v(xbgr.mr_n80307264)
print v(xbgr.mr_n80307696)
print v(xbgr.mr_n80308128)
print v(xbgr.mr_n80308448)
print v(xbgr.mr_n80308560)
print v(xbgr.mr_n80308880)
print v(xbgr.mr_n80308992)
print v(xbgr.mr_n80309312)
print v(xbgr.mr_n80309424)
print v(xbgr.mr_n80309744)
print v(xbgr.mr_n80309856)
print v(xbgr.mr_n80310288)
print v(xbgr.mr_n80310720)
print v(xbgr.mr_n80311152)
print v(xbgr.mr_n80311584)
print v(xbgr.mr_n80312016)
print v(xbgr.mr_n80312448)
print v(xbgr.mr_n80312880)
print v(xbgr.mr_n80313312)
print v(xbgr.mr_n80313632)
print v(xbgr.mr_n80313744)
print v(xbgr.mr_n80314064)
print v(xbgr.mr_n80314176)
print v(xbgr.mr_n80314496)
print v(xbgr.mr_n80314608)
print v(xbgr.mr_n80314928)
print v(xbgr.mr_n80315040)
print v(xbgr.mr_n80315360)
print v(xbgr.mr_n80315472)
print v(xbgr.mr_n80315792)
print v(xbgr.mr_n80315904)
print v(xbgr.mr_n80316224)
print v(xbgr.mr_n80316336)
print v(xbgr.mr_n80316656)
print v(xbgr.mr_n80316768)
print v(xbgr.mr_n80317088)
print v(xbgr.mr_n80317200)
print v(xbgr.mr_n80317520)
print v(xbgr.mr_n80317632)
print v(xbgr.mr_n80317952)
print v(xbgr.mr_n80318064)
print v(xbgr.mr_n80318384)
print v(xbgr.mr_n80318496)
print v(xbgr.mr_n80318816)
print v(xbgr.mr_n80318928)
print v(xbgr.mr_n80319248)
print v(xbgr.mr_n80319360)
print v(xbgr.mr_n80319680)
print v(xbgr.mr_n80319792)
print v(xbgr.mr_n80320112)
print v(xbgr.mr_n80320224)
print v(xbgr.mr_n80320544)
print v(xbgr.mr_n80320656)
print v(xbgr.mr_n80320976)
print v(xbgr.mr_n80321088)
print v(xbgr.mr_n80321408)
print v(xbgr.mr_n80321520)
print v(xbgr.mr_n80321840)
print v(xbgr.mr_n80321952)
print v(xbgr.mr_n80322272)
print v(xbgr.mr_n80322384)
print v(xbgr.mr_n80322704)
print v(xbgr.mr_n80322816)
print v(xbgr.mr_n80323136)
print v(xbgr.mr_n80323248)
print v(xbgr.mr_n80323568)
print v(xbgr.mr_n80323680)
print v(xbgr.mr_n80324112)
print v(xbgr.mr_n80324544)
print v(xbgr.mr_n80324864)
print v(xbgr.mr_n80324976)
print v(xbgr.mr_n80325296)
print v(xbgr.mr_n80325408)
print v(xbgr.mr_n80325840)
print v(xbgr.mr_n80326272)
print v(xbgr.mr_n80326704)
print v(xbgr.mr_n80327136)
print v(xbgr.mr_n80327568)
print v(xbgr.mr_n80328000)
print v(xbgr.mr_n80328432)
print v(xbgr.mr_n80328864)
print v(xbgr.mr_n80329296)
print v(xbgr.mr_n80329728)
print v(xbgr.mr_n80330160)
print v(xbgr.mr_n80330592)
print v(xbgr.mr_n80331024)
print v(xbgr.mr_n80331456)
print v(xbgr.mr_n80331888)
print v(xbgr.mr_n80332320)
print v(xbgr.mr_n80332752)
print v(xbgr.mr_n80333184)
print v(xbgr.mr_n80333616)
print v(xbgr.mr_n80334048)
print v(xbgr.mr_n80334480)
print v(xbgr.mr_n80334912)
print v(xbgr.mr_n80335344)
print v(xbgr.mr_n80335776)
print v(xbgr.mr_n80336096)
print v(xbgr.mr_n80336208)
print v(xbgr.mr_n80336528)
print v(xbgr.mr_n80336640)
print v(xbgr.mr_n80336960)
print v(xbgr.mr_n80337072)
print v(xbgr.mr_n80337392)
print v(xbgr.mr_n80337504)
print v(xbgr.mr_n80337824)
print v(xbgr.mr_n80337936)
print v(xbgr.mr_n80338256)
print v(xbgr.mr_n80338368)
print v(xbgr.mr_n80338688)
print v(xbgr.mr_n80338800)
print v(xbgr.mr_n80339120)
print v(xbgr.mr_n80339232)
print v(xbgr.mr_n80339552)
print v(xbgr.mr_n80339664)
print v(xbgr.mr_n80339984)
print v(xbgr.mr_n80340096)
print v(xbgr.mr_n80340416)
print v(xbgr.mr_n80340528)
print v(xbgr.mr_n80340848)
print v(xbgr.mr_n80340960)
print v(xbgr.mr_n80341280)
print v(xbgr.mr_n80341392)
print v(xbgr.mr_n80341824)
print v(xbgr.mr_n80342256)
print v(xbgr.mr_n80342688)
print v(xbgr.mr_n80343120)
print v(xbgr.mr_n80343552)
print v(xbgr.mr_n80343984)
print v(xbgr.mr_n80344416)
print v(xbgr.mr_n80344848)
print v(xbgr.mr_n80345280)
print v(xbgr.mr_n80345712)
print v(xbgr.mr_n80346144)
print v(xbgr.mr_n80346576)
print v(xbgr.mr_n80347008)
print v(xbgr.mr_n80347328)
print v(xbgr.mr_n80347440)
print v(xbgr.mr_n80347760)
print v(xbgr.mr_n80347872)
print v(xbgr.mr_n80348192)
print v(xbgr.mr_n80348304)
print v(xbgr.mr_n80348624)
print v(xbgr.mr_n80348736)
print v(xbgr.mr_n80349056)
print v(xbgr.mr_n80349168)
print v(xbgr.mr_n80349488)
print v(xbgr.mr_n80349600)
print v(xbgr.mr_n80349920)
print v(xbgr.mr_n80350032)
print v(xbgr.mr_n80350352)
print v(xbgr.mr_n80350464)
print v(xbgr.mr_n80350784)
print v(xbgr.mr_n80350896)
print v(xbgr.mr_n80351216)
print v(xbgr.mr_n80351328)
print v(xbgr.mr_n80351648)
print v(xbgr.mr_n80351760)
print v(xbgr.mr_n80352080)
print v(xbgr.mr_n80352192)
print v(xbgr.mr_n80352512)
print v(xbgr.mr_n80352624)
print v(xbgr.mr_n80353056)
print v(xbgr.mr_n80353488)
print v(xbgr.mr_n80353920)
print v(xbgr.mr_n80354352)
print v(xbgr.mr_n80354784)
print v(xbgr.mr_n80355216)
print v(xbgr.mr_n80355648)
print v(xbgr.mr_n80356080)
print v(xbgr.mr_n80356512)
print v(xbgr.mr_n80356944)
print v(xbgr.mr_n80357376)
print v(xbgr.mr_n80357808)
print v(xbgr.mr_n80358240)
print v(xbgr.mr_n80358560)
print v(xbgr.mr_n80358672)
print v(xbgr.mr_n80358992)
print v(xbgr.mr_n80359104)
print v(xbgr.mr_n80359424)
print v(xbgr.mr_n80359536)
print v(xbgr.mr_n80359856)
print v(xbgr.mr_n80359968)
print v(xbgr.mr_n80360288)
print v(xbgr.mr_n80360400)
print v(xbgr.mr_n80360720)
print v(xbgr.mr_n80360832)
print v(xbgr.mr_n80361152)
print v(xbgr.mr_n80361264)
print v(xbgr.mr_n80361584)
print v(xbgr.mr_n80361696)
print v(xbgr.mr_n80362016)
print v(xbgr.mr_n80362128)
print v(xbgr.mr_n80362448)
print v(xbgr.mr_n80362560)
print v(xbgr.mr_n80362880)
print v(xbgr.mr_n80362992)
print v(xbgr.mr_n80363312)
print v(xbgr.mr_n80363424)
print v(xbgr.mr_n80363744)
print v(xbgr.mr_n80363856)
print v(xbgr.mr_n80364288)
print v(xbgr.mr_n80364720)
print v(xbgr.mr_n80365152)
print v(xbgr.mr_n80365584)
print v(xbgr.mr_n80366016)
print v(xbgr.mr_n80366448)
print v(xbgr.mr_n80366880)
print v(xbgr.mr_n80367312)
print v(xbgr.mr_n80367744)
print v(xbgr.mr_n80368176)
print v(xbgr.mr_n80368608)
print v(xbgr.mr_n80369040)
print v(xbgr.mr_n80369472)
print v(xbgr.mr_n80369792)
print v(xbgr.mr_n80369904)
print v(xbgr.mr_n80370224)
print v(xbgr.mr_n80370336)
print v(xbgr.mr_n80370656)
print v(xbgr.mr_n80370768)
print v(xbgr.mr_n80371088)
print v(xbgr.mr_n80371200)
print v(xbgr.mr_n80371520)
print v(xbgr.mr_n80371632)
print v(xbgr.mr_n80371952)
print v(xbgr.mr_n80372064)
print v(xbgr.mr_n80372384)
print v(xbgr.mr_n80372496)
print v(xbgr.mr_n80372928)
print v(xbgr.mr_n80373360)
print v(xbgr.mr_n80373792)
print v(xbgr.mr_n80374224)
print v(xbgr.mr_n80374544)
print v(xbgr.mr_n80374656)
print v(xbgr.mr_n80374976)
print v(xbgr.mr_n80375088)
print v(xbgr.mr_n80375408)
print v(xbgr.mr_n80375520)
print v(xbgr.mr_n80375840)
print v(xbgr.mr_n80375952)
print v(xbgr.mr_n80376272)
print v(xbgr.mr_n80376384)
print v(xbgr.mr_n80376704)
print v(xbgr.mr_n80376816)
print v(xbgr.mr_n80377248)
print v(xbgr.mr_n80377680)
print v(xbgr.mr_n80378112)
print v(xbgr.mr_n80378544)
print v(xbgr.mr_n80378976)
print v(xbgr.mr_n80379408)
print v(xbgr.mr_n80379840)
print v(xbgr.mr_n80380272)
print v(xbgr.mr_n80380704)
print v(xbgr.mr_n80381024)
print v(xbgr.mr_n80381136)
print v(xbgr.mr_n80381456)
print v(xbgr.mr_n80381568)
print v(xbgr.mr_n80381888)
print v(xbgr.mr_n80382000)
print v(xbgr.mr_n80382320)
print v(xbgr.mr_n80382432)
print v(xbgr.mr_n80382752)
print v(xbgr.mr_n80382864)
print v(xbgr.mr_n80383184)
print v(xbgr.mr_n80383296)
print v(xbgr.mr_n80383616)
print v(xbgr.mr_n80383728)
print v(xbgr.mr_n80384048)
print v(xbgr.mr_n80384160)
print v(xbgr.mr_n80384480)
print v(xbgr.mr_n80384592)
print v(xbgr.mr_n80384912)
print v(xbgr.mr_n80385024)
print v(xbgr.mr_n80385344)
print v(xbgr.mr_n80385456)
print v(xbgr.mr_n80385776)
print v(xbgr.mr_n80385888)
print v(xbgr.mr_n80386208)
print v(xbgr.mr_n80386320)
print v(xbgr.mr_n80386640)
print v(xbgr.mr_n80386752)
print v(xbgr.mr_n80387184)
print v(xbgr.mr_n80387616)
print v(xbgr.mr_n80388048)
print v(xbgr.mr_n80388480)
print v(xbgr.mr_n80388800)
print v(xbgr.mr_n80388912)
print v(xbgr.mr_n80389232)
print v(xbgr.mr_n80389344)
print v(xbgr.mr_n80389776)
print v(xbgr.mr_n80390208)
print v(xbgr.mr_n80390640)
print v(xbgr.mr_n80391072)
print v(xbgr.mr_n80391504)
print v(xbgr.mr_n80391936)
print v(xbgr.mr_n80392368)
print v(xbgr.mr_n80392800)
print v(xbgr.mr_n80393120)
print v(xbgr.mr_n80393232)
print v(xbgr.mr_n80393552)
print v(xbgr.mr_n80393664)
print v(xbgr.mr_n80393984)
print v(xbgr.mr_n80394096)
print v(xbgr.mr_n80394416)
print v(xbgr.mr_n80394528)
print v(xbgr.mr_n80394848)
print v(xbgr.mr_n80394960)
print v(xbgr.mr_n80395280)
print v(xbgr.mr_n80395392)
print v(xbgr.mr_n80395712)
print v(xbgr.mr_n80395824)
print v(xbgr.mr_n80396144)
print v(xbgr.mr_n80396256)
print v(xbgr.mr_n80396576)
print v(xbgr.mr_n80396688)
print v(xbgr.mr_n80397008)
print v(xbgr.mr_n80397120)
print v(xbgr.mr_n80397440)
print v(xbgr.mr_n80397552)
print v(xbgr.mr_n80397872)
print v(xbgr.mr_n80397984)
print v(xbgr.mr_n80398416)
print v(xbgr.mr_n80398848)
print v(xbgr.mr_n80399280)
print v(xbgr.mr_n80399712)
print v(xbgr.mr_n80400144)
print v(xbgr.mr_n80400576)
print v(xbgr.mr_n80400896)
print v(xbgr.mr_n80401008)
print v(xbgr.mr_n80401328)
print v(xbgr.mr_n80401440)
print v(xbgr.mr_n80401760)
print v(xbgr.mr_n80401872)
print v(xbgr.mr_n80402192)
print v(xbgr.mr_n80402304)
print v(xbgr.mr_n80402624)
print v(xbgr.mr_n80402736)
print v(xbgr.mr_n80403056)
print v(xbgr.mr_n80403168)
print v(xbgr.mr_n80403488)
print v(xbgr.mr_n80403600)
print v(xbgr.mr_n80403920)
print v(xbgr.mr_n80404032)
print v(xbgr.mr_n80404352)
print v(xbgr.mr_n80404464)
print v(xbgr.mr_n80404784)
print v(xbgr.mr_n80404896)
print v(xbgr.mr_n80405216)
print v(xbgr.mr_n80405328)
print v(xbgr.mr_n80405648)
print v(xbgr.mr_n80405760)
print v(xbgr.mr_n80406080)
print v(xbgr.mr_n80406192)
print v(xbgr.mr_n80406512)
print v(xbgr.mr_n80406624)
print v(xbgr.mr_n80406944)
print v(xbgr.mr_n80407056)
print v(xbgr.mr_n80407376)
print v(xbgr.mr_n80407488)
print v(xbgr.mr_n80407808)
print v(xbgr.mr_n80407920)
print v(xbgr.mr_n80408240)
print v(xbgr.mr_n80408352)
print v(xbgr.mr_n80408784)
print v(xbgr.mr_n80409216)
print v(xbgr.mr_n80409536)
print v(xbgr.mr_n80409648)
print v(xbgr.mr_n80409968)
print v(xbgr.mr_n80410080)
print v(xbgr.mr_n80410400)
print v(xbgr.mr_n80410512)
print v(xbgr.mr_n80410832)
print v(xbgr.mr_n80410944)
print v(xbgr.mr_n80411376)
print v(xbgr.mr_n80411808)
print v(xbgr.mr_n80412240)
print v(xbgr.mr_n80412672)
print v(xbgr.mr_n80413104)
print v(xbgr.mr_n80413536)
print v(xbgr.mr_n80413968)
print v(xbgr.mr_n80414400)
print v(xbgr.mr_n80414832)
print v(xbgr.mr_n80415264)
print v(xbgr.mr_n80415696)
print v(xbgr.mr_n80416128)
print v(xbgr.mr_n80416560)
print v(xbgr.mr_n80416992)
print v(xbgr.mr_n80417424)
print v(xbgr.mr_n80417856)
print v(xbgr.mr_n80418176)
print v(xbgr.mr_n80418288)
print v(xbgr.mr_n80418608)
print v(xbgr.mr_n80418720)
print v(xbgr.mr_n80419040)
print v(xbgr.mr_n80419152)
print v(xbgr.mr_n80419472)
print v(xbgr.mr_n80419584)
print v(xbgr.mr_n80419904)
print v(xbgr.mr_n80420016)
print v(xbgr.mr_n80420336)
print v(xbgr.mr_n80420448)
print v(xbgr.mr_n80420768)
print v(xbgr.mr_n80420880)
print v(xbgr.mr_n80421200)
print v(xbgr.mr_n80421312)
print v(xbgr.mr_n80421632)
print v(xbgr.mr_n80421744)
print v(xbgr.mr_n80422064)
print v(xbgr.mr_n80422176)
print v(xbgr.mr_n80422608)
print v(xbgr.mr_n80423040)
print v(xbgr.mr_n80423472)
print v(xbgr.mr_n80423904)
print v(xbgr.mr_n80424336)
print v(xbgr.mr_n80424768)
print v(xbgr.mr_n80425200)
print v(xbgr.mr_n80425632)
print v(xbgr.mr_n80425952)
print v(xbgr.mr_n80426064)
print v(xbgr.mr_n80426384)
print v(xbgr.mr_n80426496)
print v(xbgr.mr_n80426816)
print v(xbgr.mr_n80426928)
print v(xbgr.mr_n80427248)
print v(xbgr.mr_n80427360)
print v(xbgr.mr_n80427680)
print v(xbgr.mr_n80427792)
print v(xbgr.mr_n80428112)
print v(xbgr.mr_n80428224)
print v(xbgr.mr_n80428544)
print v(xbgr.mr_n80428656)
print v(xbgr.mr_n80428976)
print v(xbgr.mr_n80429088)
print v(xbgr.mr_n80429408)
print v(xbgr.mr_n80429520)
print v(xbgr.mr_n80429840)
print v(xbgr.mr_n80429952)
print v(xbgr.mr_n80430272)
print v(xbgr.mr_n80430384)
print v(xbgr.mr_n80430704)
print v(xbgr.mr_n80430816)
print v(xbgr.mr_n80431136)
print v(xbgr.mr_n80431248)
print v(xbgr.mr_n80431568)
print v(xbgr.mr_n80431680)
print v(xbgr.mr_n80432112)
print v(xbgr.mr_n80432544)
print v(xbgr.mr_n80432976)
print v(xbgr.mr_n80433408)
print v(xbgr.mr_n80433840)
print v(xbgr.mr_n80434272)
print v(xbgr.mr_n80434704)
print v(xbgr.mr_n80435136)
print v(xbgr.mr_n80435568)
print v(xbgr.mr_n80436000)
print v(xbgr.mr_n80436432)
print v(xbgr.mr_n80436864)
print v(xbgr.mr_n80437296)
print v(xbgr.mr_n80437728)
print v(xbgr.mr_n80438048)
print v(xbgr.mr_n80438160)
print v(xbgr.mr_n80438480)
print v(xbgr.mr_n80438592)
print v(xbgr.mr_n80438912)
print v(xbgr.mr_n80439024)
print v(xbgr.mr_n80439344)
print v(xbgr.mr_n80439456)
print v(xbgr.mr_n80439776)
print v(xbgr.mr_n80439888)
print v(xbgr.mr_n80440208)
print v(xbgr.mr_n80440320)
print v(xbgr.mr_n80440640)
print v(xbgr.mr_n80440752)
print v(xbgr.mr_n80441072)
print v(xbgr.mr_n80441184)
print v(xbgr.mr_n80441504)
print v(xbgr.mr_n80441616)
print v(xbgr.mr_n80441936)
print v(xbgr.mr_n80442048)
print v(xbgr.mr_n80442368)
print v(xbgr.mr_n80442480)
print v(xbgr.mr_n80442800)
print v(xbgr.mr_n80442912)
print v(xbgr.mr_n80443232)
print v(xbgr.mr_n80443344)
print v(xbgr.mr_n80443664)
print v(xbgr.mr_n80443776)
print v(xbgr.mr_n80444096)
print v(xbgr.mr_n80444208)
print v(xbgr.mr_n80444528)
print v(xbgr.mr_n80444640)
print v(xbgr.mr_n80444960)
print v(xbgr.mr_n80445072)
print v(xbgr.mr_n80445392)
print v(xbgr.mr_n80445504)
print v(xbgr.mr_n80445824)
print v(xbgr.mr_n80445936)
print v(xbgr.mr_n80446256)
print v(xbgr.mr_n80446368)
print v(xbgr.mr_n80446688)
print v(xbgr.mr_n80446800)
print v(xbgr.mr_n80447120)
print v(xbgr.mr_n80447232)
print v(xbgr.mr_n80447552)
print v(xbgr.mr_n80447664)
print v(xbgr.mr_n80447984)
print v(xbgr.mr_n80448096)
print v(xbgr.mr_n80448528)
print v(xbgr.mr_n80448960)
print v(xbgr.mr_n80449392)
print v(xbgr.mr_n80449824)
print v(xbgr.mr_n80450256)
print v(xbgr.mr_n80450688)
print v(xbgr.mr_n80451120)
print v(xbgr.mr_n80451552)
print v(xbgr.mr_n80451984)
print v(xbgr.mr_n80452416)
print v(xbgr.mr_n80452848)
print v(xbgr.mr_n80453280)
print v(xbgr.mr_n80453712)
print v(xbgr.mr_n80454144)
print v(xbgr.mr_n80454576)
print v(xbgr.mr_n80455008)
print v(xbgr.mr_n80455328)
print v(xbgr.mr_n80455440)
print v(xbgr.mr_n80455760)
print v(xbgr.mr_n80455872)
print v(xbgr.mr_n80456304)
print v(xbgr.mr_n80456736)
print v(xbgr.mr_n80457168)
print v(xbgr.mr_n80457600)
print v(xbgr.mr_n80458032)
print v(xbgr.mr_n80458464)
print v(xbgr.mr_n80458896)
print v(xbgr.mr_n80459328)
print v(xbgr.mr_n80459760)
print v(xbgr.mr_n80460192)
print v(xbgr.mr_n80460512)
print v(xbgr.mr_n80460624)
print v(xbgr.mr_n80460944)
print v(xbgr.mr_n80461056)
print v(xbgr.mr_n80461376)
print v(xbgr.mr_n80461488)
print v(xbgr.mr_n80461808)
print v(xbgr.mr_n80461920)
print v(xbgr.mr_n80462240)
print v(xbgr.mr_n80462352)
print v(xbgr.mr_n80462672)
print v(xbgr.mr_n80462784)
print v(xbgr.mr_n80463104)
print v(xbgr.mr_n80463216)
print v(xbgr.mr_n80463536)
print v(xbgr.mr_n80463648)
print v(xbgr.mr_n80463968)
print v(xbgr.mr_n80464080)
print v(xbgr.mr_n80464400)
print v(xbgr.mr_n80464512)
print v(xbgr.mr_n80464832)
print v(xbgr.mr_n80464944)
print v(xbgr.mr_n80465264)
print v(xbgr.mr_n80465376)
print v(xbgr.mr_n80465696)
print v(xbgr.mr_n80465808)
print v(xbgr.mr_n80466240)
print v(xbgr.mr_n80466672)
print v(xbgr.mr_n80467104)
print v(xbgr.mr_n80467536)
print v(xbgr.mr_n80467968)
print v(xbgr.mr_n80468400)
print v(xbgr.mr_n80468832)
print v(xbgr.mr_n80469264)
print v(xbgr.mr_n80469696)
print v(xbgr.mr_n80470128)
print v(xbgr.mr_n80470560)
print v(xbgr.mr_n80470992)
print v(xbgr.mr_n80471424)
print v(xbgr.mr_n80471744)
print v(xbgr.mr_n80471856)
print v(xbgr.mr_n80472176)
print v(xbgr.mr_n80472288)
print v(xbgr.mr_n80472608)
print v(xbgr.mr_n80472720)
print v(xbgr.mr_n80473040)
print v(xbgr.mr_n80473152)
print v(xbgr.mr_n80473472)
print v(xbgr.mr_n80473584)
print v(xbgr.mr_n80473904)
print v(xbgr.mr_n80474016)
print v(xbgr.mr_n80474336)
print v(xbgr.mr_n80474448)
print v(xbgr.mr_n80474768)
print v(xbgr.mr_n80474880)
print v(xbgr.mr_n80475200)
print v(xbgr.mr_n80475312)
print v(xbgr.mr_n80475632)
print v(xbgr.mr_n80475744)
print v(xbgr.mr_n80476064)
print v(xbgr.mr_n80476176)
print v(xbgr.mr_n80476496)
print v(xbgr.mr_n80476608)
print v(xbgr.mr_n80476928)
print v(xbgr.mr_n80477040)
print v(xbgr.mr_n80477472)
print v(xbgr.mr_n80477904)
print v(xbgr.mr_n80478336)
print v(xbgr.mr_n80478768)
print v(xbgr.mr_n80479200)
print v(xbgr.mr_n80479632)
print v(xbgr.mr_n80480064)
print v(xbgr.mr_n80480496)
print v(xbgr.mr_n80480928)
print v(xbgr.mr_n80481360)
print v(xbgr.mr_n80481792)
print v(xbgr.mr_n80482224)
print v(xbgr.mr_n80482656)
print v(xbgr.mr_n80482976)
print v(xbgr.mr_n80483088)
print v(xbgr.mr_n80483408)
print v(xbgr.mr_n80483520)
print v(xbgr.mr_n80483840)
print v(xbgr.mr_n80483952)
print v(xbgr.mr_n80484272)
print v(xbgr.mr_n80484384)
print v(xbgr.mr_n80484704)
print v(xbgr.mr_n80484816)
print v(xbgr.mr_n80485136)
print v(xbgr.mr_n80485248)
print v(xbgr.mr_n80485568)
print v(xbgr.mr_n80485680)
print v(xbgr.mr_n80486000)
print v(xbgr.mr_n80486112)
print v(xbgr.mr_n80486432)
print v(xbgr.mr_n80486544)
print v(xbgr.mr_n80486864)
print v(xbgr.mr_n80486976)
print v(xbgr.mr_n80487296)
print v(xbgr.mr_n80487408)
print v(xbgr.mr_n80487728)
print v(xbgr.mr_n80487840)
print v(xbgr.mr_n80488160)
print v(xbgr.mr_n80488272)
print v(xbgr.mr_n80488704)
print v(xbgr.mr_n80489136)
print v(xbgr.mr_n80489568)
print v(xbgr.mr_n80490000)
print v(xbgr.mr_n80490432)
print v(xbgr.mr_n80490864)
print v(xbgr.mr_n80491296)
print v(xbgr.mr_n80491728)
print v(xbgr.mr_n80492160)
print v(xbgr.mr_n80492592)
print v(xbgr.mr_n80493024)
print v(xbgr.mr_n80493456)
print v(xbgr.mr_n80493888)
print v(xbgr.mr_n80494208)
print v(xbgr.mr_n80494320)
print v(xbgr.mr_n80494640)
print v(xbgr.mr_n80494752)
print v(xbgr.mr_n80495072)
print v(xbgr.mr_n80495184)
print v(xbgr.mr_n80495504)
print v(xbgr.mr_n80495616)
print v(xbgr.mr_n80495936)
print v(xbgr.mr_n80496048)
print v(xbgr.mr_n80496368)
print v(xbgr.mr_n80496480)
print v(xbgr.mr_n80496800)
print v(xbgr.mr_n80496912)
print v(xbgr.mr_n80497232)
print v(xbgr.mr_n80497344)
print v(xbgr.mr_n80497664)
print v(xbgr.mr_n80497776)
print v(xbgr.mr_n80498096)
print v(xbgr.mr_n80498208)
print v(xbgr.mr_n80498528)
print v(xbgr.mr_n80498640)
print v(xbgr.mr_n80498960)
print v(xbgr.mr_n80499072)
print v(xbgr.mr_n80499392)
print v(xbgr.mr_n80499504)
print v(xbgr.mr_n80499936)
print v(xbgr.mr_n80500368)
print v(xbgr.mr_n80500800)
print v(xbgr.mr_n80501232)
print v(xbgr.mr_n80501664)
print v(xbgr.mr_n80502096)
print v(xbgr.mr_n80502528)
print v(xbgr.mr_n80502960)
print v(xbgr.mr_n80503392)
print v(xbgr.mr_n80503824)
print v(xbgr.mr_n80504256)
print v(xbgr.mr_n80504688)
print v(xbgr.mr_n80505120)
print v(xbgr.mr_n80505440)
print v(xbgr.mr_n80505552)
print v(xbgr.mr_n80505872)
print v(xbgr.mr_n80505984)
print v(xbgr.mr_n80506304)
print v(xbgr.mr_n80506416)
print v(xbgr.mr_n80506736)
print v(xbgr.mr_n80506848)
print v(xbgr.mr_n80507168)
print v(xbgr.mr_n80507280)
print v(xbgr.mr_n80507712)
print v(xbgr.mr_n80508144)
print v(xbgr.mr_n80508576)
print v(xbgr.mr_n80509008)
print v(xbgr.mr_n80509440)
print v(xbgr.mr_n80509760)
print v(xbgr.mr_n80509872)
print v(xbgr.mr_n80510192)
print v(xbgr.mr_n80510304)
print v(xbgr.mr_n80510624)
print v(xbgr.mr_n80510736)
print v(xbgr.mr_n80511056)
print v(xbgr.mr_n80511168)
print v(xbgr.mr_n80511488)
print v(xbgr.mr_n80511600)
print v(xbgr.mr_n80511920)
print v(xbgr.mr_n80512032)
print v(xbgr.mr_n80512352)
print v(xbgr.mr_n80512464)
print v(xbgr.mr_n80512784)
print v(xbgr.mr_n80512896)
print v(xbgr.mr_n80513328)
print v(xbgr.mr_n80513760)
print v(xbgr.mr_n80514192)
print v(xbgr.mr_n80514624)
print v(xbgr.mr_n80515056)
print v(xbgr.mr_n80515488)
print v(xbgr.mr_n80515920)
print v(xbgr.mr_n80516352)
print v(xbgr.mr_n80516672)
print v(xbgr.mr_n80516784)
print v(xbgr.mr_n80517104)
print v(xbgr.mr_n80517216)
print v(xbgr.mr_n80517536)
print v(xbgr.mr_n80517648)
print v(xbgr.mr_n80517968)
print v(xbgr.mr_n80518080)
print v(xbgr.mr_n80518400)
print v(xbgr.mr_n80518512)
print v(xbgr.mr_n80518832)
print v(xbgr.mr_n80518944)
print v(xbgr.mr_n80519264)
print v(xbgr.mr_n80519376)
print v(xbgr.mr_n80519696)
print v(xbgr.mr_n80519808)
print v(xbgr.mr_n80520240)
print v(xbgr.mr_n80520672)
print v(xbgr.mr_n80521104)
print v(xbgr.mr_n80521536)
print v(xbgr.mr_n80521968)
print v(xbgr.mr_n80522288)
print v(xbgr.mr_n80522400)
print v(xbgr.mr_n80522720)
print v(xbgr.mr_n80522832)
print v(xbgr.mr_n80523152)
print v(xbgr.mr_n80523264)
print v(xbgr.mr_n80523584)
print v(xbgr.mr_n80523696)
print v(xbgr.mr_n80524016)
print v(xbgr.mr_n80524128)
print v(xbgr.mr_n80524560)
print v(xbgr.mr_n80524992)
print v(xbgr.mr_n80525424)
print v(xbgr.mr_n80525856)
print v(xbgr.mr_n80526288)
print v(xbgr.mr_n80526720)
print v(xbgr.mr_n80527152)
print v(xbgr.mr_n80527584)
print v(xbgr.mr_n80527904)
print v(xbgr.mr_n80528016)
print v(xbgr.mr_n80528336)
print v(xbgr.mr_n80528448)
print v(xbgr.mr_n80528768)
print v(xbgr.mr_n80528880)
print v(xbgr.mr_n80529200)
print v(xbgr.mr_n80529312)
print v(xbgr.mr_n80529632)
print v(xbgr.mr_n80529744)
print v(xbgr.mr_n80530064)
print v(xbgr.mr_n80530176)
print v(xbgr.mr_n80530496)
print v(xbgr.mr_n80530608)
print v(xbgr.mr_n80531040)
print v(xbgr.mr_n80531472)
print v(xbgr.mr_n80531904)
print v(xbgr.mr_n80532336)
print v(xbgr.mr_n80532656)
print v(xbgr.mr_n80532768)
print v(xbgr.mr_n80533200)
print v(xbgr.mr_n80533632)
print v(xbgr.mr_n80533952)
print v(xbgr.mr_n80534064)
print v(xbgr.mr_n80534384)
print v(xbgr.mr_n80534496)
print v(xbgr.mr_n80534816)
print v(xbgr.mr_n80534928)
print v(xbgr.mr_n80535248)
print v(xbgr.mr_n80535360)
print v(xbgr.mr_n80535680)
print v(xbgr.mr_n80535792)
print v(xbgr.mr_n80536224)
print v(xbgr.mr_n80536656)
print v(xbgr.mr_n80537088)
print v(xbgr.mr_n80537520)
print v(xbgr.mr_n80537952)
print v(xbgr.mr_n80538384)
print v(xbgr.mr_n80538816)
print v(xbgr.mr_n80539136)
print v(xbgr.mr_n80539248)
print v(xbgr.mr_n80539568)
print v(xbgr.mr_n80539680)
print v(xbgr.mr_n80540000)
print v(xbgr.mr_n80540112)
print v(xbgr.mr_n80540432)
print v(xbgr.mr_n80540544)
print v(xbgr.mr_n80540864)
print v(xbgr.mr_n80540976)
print v(xbgr.mr_n80541296)
print v(xbgr.mr_n80541408)
print v(xbgr.mr_n80541728)
print v(xbgr.mr_n80541840)
print v(xbgr.mr_n80542160)
print v(xbgr.mr_n80542272)
print v(xbgr.mr_n80542592)
print v(xbgr.mr_n80542704)
print v(xbgr.mr_n80543024)
print v(xbgr.mr_n80543136)
print v(xbgr.mr_n80543456)
print v(xbgr.mr_n80543568)
print v(xbgr.mr_n80543888)
print v(xbgr.mr_n80544000)
print v(xbgr.mr_n80544320)
print v(xbgr.mr_n80544432)
print v(xbgr.mr_n80544864)
print v(xbgr.mr_n80545296)
print v(xbgr.mr_n80545728)
print v(xbgr.mr_n80546160)
print v(xbgr.mr_n80546592)
print v(xbgr.mr_n80547024)
print v(xbgr.mr_n80547456)
print v(xbgr.mr_n80547888)
print v(xbgr.mr_n80548320)
print v(xbgr.mr_n80548752)
print v(xbgr.mr_n80549184)
print v(xbgr.mr_n80549616)
print v(xbgr.mr_n80550048)
print v(xbgr.mr_n80550368)
print v(xbgr.mr_n80550480)
print v(xbgr.mr_n80550800)
print v(xbgr.mr_n80550912)
print v(xbgr.mr_n80551232)
print v(xbgr.mr_n80551344)
print v(xbgr.mr_n80551664)
print v(xbgr.mr_n80551776)
print v(xbgr.mr_n80552096)
print v(xbgr.mr_n80552208)
print v(xbgr.mr_n80552528)
print v(xbgr.mr_n80552640)
print v(xbgr.mr_n80552960)
print v(xbgr.mr_n80553072)
print v(xbgr.mr_n80553392)
print v(xbgr.mr_n80553504)
print v(xbgr.mr_n80553824)
print v(xbgr.mr_n80553936)
print v(xbgr.mr_n80554256)
print v(xbgr.mr_n80554368)
print v(xbgr.mr_n80554688)
print v(xbgr.mr_n80554800)
print v(xbgr.mr_n80555120)
print v(xbgr.mr_n80555232)
print v(xbgr.mr_n80555552)
print v(xbgr.mr_n80555664)
print v(xbgr.mr_n80555984)
print v(xbgr.mr_n80556096)
print v(xbgr.mr_n80556416)
print v(xbgr.mr_n80556528)
print v(xbgr.mr_n80556848)
print v(xbgr.mr_n80556960)
print v(xbgr.mr_n80557392)
print v(xbgr.mr_n80557824)
print v(xbgr.mr_n80558256)
print v(xbgr.mr_n80558688)
print v(xbgr.mr_n80559120)
print v(xbgr.mr_n80559552)
print v(xbgr.mr_n80559872)
print v(xbgr.mr_n80559984)
print v(xbgr.mr_n80560304)
print v(xbgr.mr_n80560416)
print v(xbgr.mr_n80560736)
print v(xbgr.mr_n80560848)
print v(xbgr.mr_n80561168)
print v(xbgr.mr_n80561280)
print v(xbgr.mr_n80561600)
print v(xbgr.mr_n80561712)
print v(xbgr.mr_n80562032)
print v(xbgr.mr_n80562144)
print v(xbgr.mr_n80562464)
print v(xbgr.mr_n80562576)
print v(xbgr.mr_n80562896)
print v(xbgr.mr_n80563008)
print v(xbgr.mr_n80563328)
print v(xbgr.mr_n80563440)
print v(xbgr.mr_n80563760)
print v(xbgr.mr_n80563872)
print v(xbgr.mr_n80564304)
print v(xbgr.mr_n80564736)
print v(xbgr.mr_n80565168)
print v(xbgr.mr_n80565600)
print v(xbgr.mr_n80566032)
print v(xbgr.mr_n80566464)
print v(xbgr.mr_n80566896)
print v(xbgr.mr_n80567328)
print v(xbgr.mr_n80567760)
print v(xbgr.mr_n80568192)
print v(xbgr.mr_n80568624)
print v(xbgr.mr_n80569056)
print v(xbgr.mr_n80569488)
print v(xbgr.mr_n80569920)
print v(xbgr.mr_n80570352)
print v(xbgr.mr_n80570784)
print v(xbgr.mr_n80571216)
print v(xbgr.mr_n80571648)
print v(xbgr.mr_n80572080)
print v(xbgr.mr_n80572512)
print v(xbgr.mr_n80572832)
print v(xbgr.mr_n80572944)
print v(xbgr.mr_n80573264)
print v(xbgr.mr_n80573376)
print v(xbgr.mr_n80573696)
print v(xbgr.mr_n80573808)
print v(xbgr.mr_n80574128)
print v(xbgr.mr_n80574240)
print v(xbgr.mr_n80574560)
print v(xbgr.mr_n80574672)
print v(xbgr.mr_n80574992)
print v(xbgr.mr_n80575104)
print v(xbgr.mr_n80575424)
print v(xbgr.mr_n80575536)
print v(xbgr.mr_n80575856)
print v(xbgr.mr_n80575968)
print v(xbgr.mr_n80576288)
print v(xbgr.mr_n80576400)
print v(xbgr.mr_n80576720)
print v(xbgr.mr_n80576832)
print v(xbgr.mr_n80577152)
print v(xbgr.mr_n80577264)
print v(xbgr.mr_n80577584)
print v(xbgr.mr_n80577696)
print v(xbgr.mr_n80578016)
print v(xbgr.mr_n80578128)
print v(xbgr.mr_n80578448)
print v(xbgr.mr_n80578560)
print v(xbgr.mr_n80578992)
print v(xbgr.mr_n80579424)
print v(xbgr.mr_n80579856)
print v(xbgr.mr_n80580288)
print v(xbgr.mr_n80580608)
print v(xbgr.mr_n80580720)
print v(xbgr.mr_n80581040)
print v(xbgr.mr_n80581152)
print v(xbgr.mr_n80581472)
print v(xbgr.mr_n80581584)
print v(xbgr.mr_n80581904)
print v(xbgr.mr_n80582016)
print v(xbgr.mr_n80582336)
print v(xbgr.mr_n80582448)
print v(xbgr.mr_n80582768)
print v(xbgr.mr_n80582880)
print v(xbgr.mr_n80583312)
print v(xbgr.mr_n80583744)
print v(xbgr.mr_n80584176)
print v(xbgr.mr_n80584608)
print v(xbgr.mr_n80585040)
print v(xbgr.mr_n80585472)
print v(xbgr.mr_n80585904)
print v(xbgr.mr_n80586336)
print v(xbgr.mr_n80586768)
print v(xbgr.mr_n80587200)
print v(xbgr.mr_n80587520)
print v(xbgr.mr_n80587632)
print v(xbgr.mr_n80587952)
print v(xbgr.mr_n80588064)
print v(xbgr.mr_n80588496)
print v(xbgr.mr_n80588928)
print v(xbgr.mr_n80589248)
print v(xbgr.mr_n80589360)
print v(xbgr.mr_n80589680)
print v(xbgr.mr_n80589792)
print v(xbgr.mr_n80590112)
print v(xbgr.mr_n80590224)
print v(xbgr.mr_n80590544)
print v(xbgr.mr_n80590656)
print v(xbgr.mr_n80591088)
print v(xbgr.mr_n80591520)
print v(xbgr.mr_n80591952)
print v(xbgr.mr_n80592384)
print v(xbgr.mr_n80592816)
print v(xbgr.mr_n80593248)
print v(xbgr.mr_n80593680)
print v(xbgr.mr_n80594112)
print v(xbgr.mr_n80594544)
print v(xbgr.mr_n80594976)
print v(xbgr.mr_n80595296)
print v(xbgr.mr_n80595408)
print v(xbgr.mr_n80595728)
print v(xbgr.mr_n80595840)
print v(xbgr.mr_n80596160)
print v(xbgr.mr_n80596272)
print v(xbgr.mr_n80596592)
print v(xbgr.mr_n80596704)
print v(xbgr.mr_n80597024)
print v(xbgr.mr_n80597136)
print v(xbgr.mr_n80597456)
print v(xbgr.mr_n80597568)
print v(xbgr.mr_n80597888)
print v(xbgr.mr_n80598000)
print v(xbgr.mr_n80598320)
print v(xbgr.mr_n80598432)
print v(xbgr.mr_n80598752)
print v(xbgr.mr_n80598864)
print v(xbgr.mr_n80599184)
print v(xbgr.mr_n80599296)
print v(xbgr.mr_n80599616)
print v(xbgr.mr_n80599728)
print v(xbgr.mr_n80600048)
print v(xbgr.mr_n80600160)
print v(xbgr.mr_n80600480)
print v(xbgr.mr_n80600592)
print v(xbgr.mr_n80600912)
print v(xbgr.mr_n80601024)
print v(xbgr.mr_n80601344)
print v(xbgr.mr_n80601456)
print v(xbgr.mr_n80601776)
print v(xbgr.mr_n80601888)
print v(xbgr.mr_n80602208)
print v(xbgr.mr_n80602320)
print v(xbgr.mr_n80602640)
print v(xbgr.mr_n80602752)
print v(xbgr.mr_n80603072)
print v(xbgr.mr_n80603184)
print v(xbgr.mr_n80603504)
print v(xbgr.mr_n80603616)
print v(xbgr.mr_n80603936)
print v(xbgr.mr_n80604048)
print v(xbgr.mr_n80604368)
print v(xbgr.mr_n80604800)
print v(xbgr.mr_n80604912)
print v(xbgr.mr_n80605232)
print v(xbgr.mr_n80605664)
print v(xbgr.mr_n80605776)
print v(xbgr.mr_n80606096)
print v(xbgr.mr_n80606528)
print v(xbgr.mr_n80606640)
print v(xbgr.mr_n80606960)
print v(xbgr.mr_n80607392)
print v(xbgr.mr_n80607504)
print v(xbgr.mr_n80607824)
print v(xbgr.mr_n80608256)
print v(xbgr.mr_n80608368)
print v(xbgr.mr_n80608688)
print v(xbgr.mr_n80608800)
print v(xbgr.mr_n80609120)
print v(xbgr.mr_n80609232)
print v(xbgr.mr_n80609552)
print v(xbgr.mr_n80609664)
print v(xbgr.mr_n80609984)
print v(xbgr.mr_n80610096)
print v(xbgr.mr_n80610416)
print v(xbgr.mr_n80610528)
print v(xbgr.mr_n80610848)
print v(xbgr.mr_n80610960)
print v(xbgr.mr_n80611280)
print v(xbgr.mr_n80611392)
print v(xbgr.mr_n80611712)
print v(xbgr.mr_n80611824)
print v(xbgr.mr_n80612144)
print v(xbgr.mr_n80612256)
print v(xbgr.mr_n80612576)
print v(xbgr.mr_n80612688)
print v(xbgr.mr_n80613008)
print v(xbgr.mr_n80613120)
print v(xbgr.mr_n80613440)
print v(xbgr.mr_n80613552)
print v(xbgr.mr_n80613872)
print v(xbgr.mr_n80613984)
print v(xbgr.mr_n80614304)
print v(xbgr.mr_n80614416)
print v(xbgr.mr_n80614736)
print v(xbgr.mr_n80614848)
print v(xbgr.mr_n80615168)
print v(xbgr.mr_n80615280)
print v(xbgr.mr_n80615600)
print v(xbgr.mr_n80615712)
print v(xbgr.mr_n80616032)
print v(xbgr.mr_n80616144)
print v(xbgr.mr_n80616464)
print v(xbgr.mr_n80616576)
print v(xbgr.mr_n80616896)
print v(xbgr.mr_n80617008)
print v(xbgr.mr_n80617328)
print v(xbgr.mr_n80617440)
print v(xbgr.mr_n80617760)
print v(xbgr.mr_n80617872)
print v(xbgr.mr_n80618192)
print v(xbgr.mr_n80618304)
print v(xbgr.mr_n80618624)
print v(xbgr.mr_n80618736)
print v(xbgr.mr_n80619056)
print v(xbgr.mr_n80619168)
print v(xbgr.mr_n80619488)
print v(xbgr.mr_n80619600)
print v(xbgr.mr_n80619920)
print v(xbgr.mr_n80620032)
print v(xbgr.mr_n80620352)
print v(xbgr.mr_n80620464)
print v(xbgr.mr_n80620784)
print v(xbgr.mr_n80620896)
print v(xbgr.mr_n80621216)
print v(xbgr.mr_n80621328)
print v(xbgr.mr_n80621648)
print v(xbgr.mr_n80621760)
print v(xbgr.mr_n80622080)
print v(xbgr.mr_n80622192)
print v(xbgr.mr_n80622512)
print v(xbgr.mr_n80622624)
print v(xbgr.mr_n80622944)
print v(xbgr.mr_n80623056)
print v(xbgr.mr_n80623376)
print v(xbgr.mr_n80623488)
print v(xbgr.mr_n80623808)
print v(xbgr.mr_n80623920)
print v(xbgr.mr_n80624240)
print v(xbgr.mr_n80624352)
print v(xbgr.mr_n80624672)
print v(xbgr.mr_n80624784)
print v(xbgr.mr_n80625104)
print v(xbgr.mr_n80625216)
print v(xbgr.mr_n80625536)
print v(xbgr.mr_n80625648)
print v(xbgr.mr_n80625968)
print v(xbgr.mr_n80626080)
print v(xbgr.mr_n80626400)
print v(xbgr.mr_n80626512)
print v(xbgr.mr_n80626832)
print v(xbgr.mr_n80626944)
print v(xbgr.mr_n80627264)
print v(xbgr.mr_n80627376)
print v(xbgr.mr_n80627696)
print v(xbgr.mr_n80627808)
print v(xbgr.mr_n80628128)
print v(xbgr.mr_n80628240)
print v(xbgr.mr_n80628560)
print v(xbgr.mr_n80628672)
print v(xbgr.mr_n80628992)
print v(xbgr.mr_n80629104)
print v(xbgr.mr_n80629424)
print v(xbgr.mr_n80629536)
print v(xbgr.mr_n80629856)
print v(xbgr.mr_n80629968)
print v(xbgr.mr_n80630288)
print v(xbgr.mr_n80630400)
print v(xbgr.mr_n80630720)
print v(xbgr.mr_n80630832)
print v(xbgr.mr_n80631152)
print v(xbgr.mr_n80631264)
print v(xbgr.mr_n80631584)
print v(xbgr.mr_n80631696)
print v(xbgr.mr_n80632016)
print v(xbgr.mr_n80632128)
print v(xbgr.mr_n80632448)
print v(xbgr.mr_n80632560)
print v(xbgr.mr_n80632880)
print v(xbgr.mr_n80632992)
print v(xbgr.mr_n80633312)
print v(xbgr.mr_n80633424)
print v(xbgr.mr_n80633744)
print v(xbgr.mr_n80633856)
print v(xbgr.mr_n80634176)
print v(xbgr.mr_n80634288)
print v(xbgr.mr_n80634608)
print v(xbgr.mr_n80634720)
print v(xbgr.mr_n80635040)
print v(xbgr.mr_n80635152)
print v(xbgr.mr_n80635472)
print v(xbgr.mr_n80635584)
print v(xbgr.mr_n80635904)
print v(xbgr.mr_n80636016)
print v(xbgr.mr_n80636336)
print v(xbgr.mr_n80636448)
print v(xbgr.mr_n80636768)
print v(xbgr.mr_n80636880)
print v(xbgr.mr_n80637200)
print v(xbgr.mr_n80637312)
print v(xbgr.mr_n80637632)
print v(xbgr.mr_n80637744)
print v(xbgr.mr_n80638064)
print v(xbgr.mr_n80638176)
print v(xbgr.mr_n80638496)
print v(xbgr.mr_n80638608)
print v(xbgr.mr_n80638928)
print v(xbgr.mr_n80639040)
print v(xbgr.mr_n80639360)
print v(xbgr.mr_n80639792)
print v(xbgr.mr_n80639904)
print v(xbgr.mr_n80640224)
print v(xbgr.mr_n80640656)
print v(xbgr.mr_n80640768)
print v(xbgr.mr_n80641088)
print v(xbgr.mr_n80641520)
print v(xbgr.mr_n80641632)
print v(xbgr.mr_n80641952)
print v(xbgr.mr_n80642384)
print v(xbgr.mr_n80642496)
print v(xbgr.mr_n80642816)
print v(xbgr.mr_n80642928)
print v(xbgr.mr_n80643248)
print v(xbgr.mr_n80643360)
print v(xbgr.mr_n80643680)
print v(xbgr.mr_n80643792)
print v(xbgr.mr_n80644112)
print v(xbgr.mr_n80644544)
print v(xbgr.mr_n80644656)
print v(xbgr.mr_n80644976)
print v(xbgr.mr_n80645408)
print v(xbgr.mr_n80645520)
print v(xbgr.mr_n80645840)
print v(xbgr.mr_n80646272)
print v(xbgr.mr_n80646384)
print v(xbgr.mr_n80646704)
print v(xbgr.mr_n80647136)
print v(xbgr.mr_n80647248)
print v(xbgr.mr_n80647568)
print v(xbgr.mr_n80647680)
print v(xbgr.mr_n80648000)
print v(xbgr.mr_n80648112)
print v(xbgr.mr_n80648432)
print v(xbgr.mr_n80648544)
print v(xbgr.mr_n80648864)
print v(xbgr.mr_n80648976)
print v(xbgr.mr_n80649296)
print v(xbgr.mr_n80649408)
print v(xbgr.mr_n80649728)
print v(xbgr.mr_n80649840)
print v(xbgr.mr_n80650160)
print v(xbgr.mr_n80650272)
print v(xbgr.mr_n80650592)
print v(xbgr.mr_n80650704)
print v(xbgr.mr_n80651024)
print v(xbgr.mr_n80651136)
print v(xbgr.mr_n80651456)
print v(xbgr.mr_n80651568)
print v(xbgr.mr_n80651888)
print v(xbgr.mr_n80652000)
print v(xbgr.mr_n80652320)
print v(xbgr.mr_n80652432)
print v(xbgr.mr_n80652752)
print v(xbgr.mr_n80652864)
print v(xbgr.mr_n80653184)
print v(xbgr.mr_n80653296)
print v(xbgr.mr_n80653616)
print v(xbgr.mr_n80653728)
print v(xbgr.mr_n80654048)
print v(xbgr.mr_n80654160)
print v(xbgr.mr_n80654480)
print v(xbgr.mr_n80654592)
print v(xbgr.mr_n80654912)
print v(xbgr.mr_n80655024)
print v(xbgr.mr_n80655344)
print v(xbgr.mr_n80655456)
print v(xbgr.mr_n80655776)
print v(xbgr.mr_n80655888)
print v(xbgr.mr_n80656208)
print v(xbgr.mr_n80656320)
print v(xbgr.mr_n80656640)
print v(xbgr.mr_n80656752)
print v(xbgr.mr_n80657072)
print v(xbgr.mr_n80657184)
print v(xbgr.mr_n80657504)
print v(xbgr.mr_n80657616)
print v(xbgr.mr_n80657936)
print v(xbgr.mr_n80658048)
print v(xbgr.mr_n80658368)
print v(xbgr.mr_n80658480)
print v(xbgr.mr_n80658800)
print v(xbgr.mr_n80658912)
print v(xbgr.mr_n80659344)
print v(xbgr.mr_n80659776)
print v(xbgr.mr_n80660208)
print v(xbgr.mr_n80660640)
print v(xbgr.mr_n80661072)
print v(xbgr.mr_n80661504)
print v(xbgr.mr_n80661936)
print v(xbgr.mr_n80662368)
print v(xbgr.mr_n80662800)
print v(xbgr.mr_n80663232)
print v(xbgr.mr_n80663664)
print v(xbgr.mr_n80664096)
print v(xbgr.mr_n80664528)
print v(xbgr.mr_n80664960)
print v(xbgr.mr_n80665392)
print v(xbgr.mr_n80665824)
print v(xbgr.mr_n80666256)
print v(xbgr.mr_n80666688)
print v(xbgr.mr_n80667120)
print v(xbgr.mr_n80667552)
print v(xbgr.mr_n80667984)
print v(xbgr.mr_n80668416)
print v(xbgr.mr_n80668848)
print v(xbgr.mr_n80669280)
print v(xbgr.mr_n80669712)
print v(xbgr.mr_n80670144)
print v(xbgr.mr_n80670464)
print v(xbgr.mr_n80670576)
print v(xbgr.mr_n80670896)
print v(xbgr.mr_n80671008)
print v(xbgr.mr_n80671328)
print v(xbgr.mr_n80671440)
print v(xbgr.mr_n80671760)
print v(xbgr.mr_n80671872)
print v(xbgr.mr_n80672192)
print v(xbgr.mr_n80672304)
print v(xbgr.mr_n80672624)
print v(xbgr.mr_n80672736)
print v(xbgr.mr_n80673056)
print v(xbgr.mr_n80673168)
print v(xbgr.mr_n80673488)
print v(xbgr.mr_n80673600)
print v(xbgr.mr_n80673920)
print v(xbgr.mr_n80674032)
print v(xbgr.mr_n80674352)
print v(xbgr.mr_n80674464)
print v(xbgr.mr_n80674784)
print v(xbgr.mr_n80674896)
print v(xbgr.mr_n80675216)
print v(xbgr.mr_n80675328)
print v(xbgr.mr_n80675648)
print v(xbgr.mr_n80675760)
print v(xbgr.mr_n80676080)
print v(xbgr.mr_n80676192)
print v(xbgr.mr_n80676512)
print v(xbgr.mr_n80676624)
print v(xbgr.mr_n80676944)
print v(xbgr.mr_n80677056)
print v(xbgr.mr_n80677376)
print v(xbgr.mr_n80677488)
print v(xbgr.mr_n80677808)
print v(xbgr.mr_n80677920)
print v(xbgr.mr_n80678240)
print v(xbgr.mr_n80678352)
print v(xbgr.mr_n80678672)
print v(xbgr.mr_n80678784)
print v(xbgr.mr_n80679216)
print v(xbgr.mr_n80679648)
print v(xbgr.mr_n80680080)
print v(xbgr.mr_n80680512)
print v(xbgr.mr_n80680944)
print v(xbgr.mr_n80681376)
print v(xbgr.mr_n80681808)
print v(xbgr.mr_n80682240)
print v(xbgr.mr_n80682672)
print v(xbgr.mr_n80683104)
print v(xbgr.mr_n80683536)
print v(xbgr.mr_n80683968)
print v(xbgr.mr_n80684288)
print v(xbgr.mr_n80684400)
print v(xbgr.mr_n80684720)
print v(xbgr.mr_n80684832)
print v(xbgr.mr_n80685264)
print v(xbgr.mr_n80685696)
print v(xbgr.mr_n80686128)
print v(xbgr.mr_n80686560)
print v(xbgr.mr_n80686992)
print v(xbgr.mr_n80687424)
print v(xbgr.mr_n80687856)
print v(xbgr.mr_n80688288)
print v(xbgr.mr_n80688720)
print v(xbgr.mr_n80689152)
print v(xbgr.mr_n80689472)
print v(xbgr.mr_n80689584)
print v(xbgr.mr_n80689904)
print v(xbgr.mr_n80690016)
print v(xbgr.mr_n80690336)
print v(xbgr.mr_n80690448)
print v(xbgr.mr_n80690768)
print v(xbgr.mr_n80690880)
print v(xbgr.mr_n80691200)
print v(xbgr.mr_n80691312)
print v(xbgr.mr_n80691632)
print v(xbgr.mr_n80691744)
print v(xbgr.mr_n80692064)
print v(xbgr.mr_n80692176)
print v(xbgr.mr_n80692496)
print v(xbgr.mr_n80692608)
print v(xbgr.mr_n80692928)
print v(xbgr.mr_n80693040)
print v(xbgr.mr_n80693360)
print v(xbgr.mr_n80693472)
print v(xbgr.mr_n80693792)
print v(xbgr.mr_n80693904)
print v(xbgr.mr_n80694224)
print v(xbgr.mr_n80694336)
print v(xbgr.mr_n80694656)
print v(xbgr.mr_n80694768)
print v(xbgr.mr_n80695088)
print v(xbgr.mr_n80695200)
print v(xbgr.mr_n80695520)
print v(xbgr.mr_n80695632)
print v(xbgr.mr_n80695952)
print v(xbgr.mr_n80696064)
print v(xbgr.mr_n80696384)
print v(xbgr.mr_n80696496)
print v(xbgr.mr_n80696816)
print v(xbgr.mr_n80696928)
print v(xbgr.mr_n80697248)
print v(xbgr.mr_n80697360)
print v(xbgr.mr_n80697680)
print v(xbgr.mr_n80697792)
print v(xbgr.mr_n80698112)
print v(xbgr.mr_n80698224)
print v(xbgr.mr_n80698544)
print v(xbgr.mr_n80698656)
print v(xbgr.mr_n80698976)
print v(xbgr.mr_n80699088)
print v(xbgr.mr_n80699408)
print v(xbgr.mr_n80699520)
print v(xbgr.mr_n80699840)
print v(xbgr.mr_n80699952)
print v(xbgr.mr_n80700272)
print v(xbgr.mr_n80700384)
print v(xbgr.mr_n80700704)
print v(xbgr.mr_n80701136)
print v(xbgr.mr_n80701248)
print v(xbgr.mr_n80701568)
print v(xbgr.mr_n80702000)
print v(xbgr.mr_n80702112)
print v(xbgr.mr_n80702432)
print v(xbgr.mr_n80702864)
print v(xbgr.mr_n80702976)
print v(xbgr.mr_n80703296)
print v(xbgr.mr_n80703728)
print v(xbgr.mr_n80703840)
print v(xbgr.mr_n80704160)
print v(xbgr.mr_n80704592)
print v(xbgr.mr_n80704704)
print v(xbgr.mr_n80705024)
print v(xbgr.mr_n80705136)
print v(xbgr.mr_n80705456)
print v(xbgr.mr_n80705568)
print v(xbgr.mr_n80705888)
print v(xbgr.mr_n80706000)
print v(xbgr.mr_n80706320)
print v(xbgr.mr_n80706432)
print v(xbgr.mr_n80706752)
print v(xbgr.mr_n80706864)
print v(xbgr.mr_n80707184)
print v(xbgr.mr_n80707296)
print v(xbgr.mr_n80707616)
print v(xbgr.mr_n80707728)
print v(xbgr.mr_n80708048)
print v(xbgr.mr_n80708160)
print v(xbgr.mr_n80708480)
print v(xbgr.mr_n80708592)
print v(xbgr.mr_n80708912)
print v(xbgr.mr_n80709024)
print v(xbgr.mr_n80709344)
print v(xbgr.mr_n80709456)
print v(xbgr.mr_n80709776)
print v(xbgr.mr_n80709888)
print v(xbgr.mr_n80710208)
print v(xbgr.mr_n80710320)
print v(xbgr.mr_n80710640)
print v(xbgr.mr_n80710752)
print v(xbgr.mr_n80711072)
print v(xbgr.mr_n80711184)
print v(xbgr.mr_n80711504)
print v(xbgr.mr_n80711616)
print v(xbgr.mr_n80711936)
print v(xbgr.mr_n80712048)
print v(xbgr.mr_n80712368)
print v(xbgr.mr_n80712480)
print v(xbgr.mr_n80712800)
print v(xbgr.mr_n80712912)
print v(xbgr.mr_n80713232)
print v(xbgr.mr_n80713344)
print v(xbgr.mr_n80713664)
print v(xbgr.mr_n80713776)
print v(xbgr.mr_n80714096)
print v(xbgr.mr_n80714208)
print v(xbgr.mr_n80714528)
print v(xbgr.mr_n80714640)
print v(xbgr.mr_n80714960)
print v(xbgr.mr_n80715072)
print v(xbgr.mr_n80715392)
print v(xbgr.mr_n80715504)
print v(xbgr.mr_n80715824)
print v(xbgr.mr_n80715936)
print v(xbgr.mr_n80716256)
print v(xbgr.mr_n80716368)
print v(xbgr.mr_n80716688)
print v(xbgr.mr_n80716800)
print v(xbgr.mr_n80717120)
print v(xbgr.mr_n80717232)
print v(xbgr.mr_n80717552)
print v(xbgr.mr_n80717664)
print v(xbgr.mr_n80717984)
print v(xbgr.mr_n80718096)
print v(xbgr.mr_n80718416)
print v(xbgr.mr_n80718528)
print v(xbgr.mr_n80718848)
print v(xbgr.mr_n80718960)
print v(xbgr.mr_n80719280)
print v(xbgr.mr_n80719392)
print v(xbgr.mr_n80719712)
print v(xbgr.mr_n80719824)
print v(xbgr.mr_n80720144)
print v(xbgr.mr_n80720256)
print v(xbgr.mr_n80720576)
print v(xbgr.mr_n80720688)
print v(xbgr.mr_n80721008)
print v(xbgr.mr_n80721120)
print v(xbgr.mr_n80721440)
print v(xbgr.mr_n80721552)
print v(xbgr.mr_n80721872)
print v(xbgr.mr_n80721984)
print v(xbgr.mr_n80722304)
print v(xbgr.mr_n80722416)
print v(xbgr.mr_n80722736)
print v(xbgr.mr_n80722848)
print v(xbgr.mr_n80723168)
print v(xbgr.mr_n80723600)
print v(xbgr.mr_n80723712)
print v(xbgr.mr_n80724032)
print v(xbgr.mr_n80724144)
print v(xbgr.mr_n80724464)
print v(xbgr.mr_n80724576)
print v(xbgr.mr_n80724896)
print v(xbgr.mr_n80725328)
print v(xbgr.mr_n80725440)
print v(xbgr.mr_n80725760)
print v(xbgr.mr_n80726192)
print v(xbgr.mr_n80726304)
print v(xbgr.mr_n80726624)
print v(xbgr.mr_n80726736)
print v(xbgr.mr_n80727056)
print v(xbgr.mr_n80727168)
print v(xbgr.mr_n80727488)
print v(xbgr.mr_n80727600)
print v(xbgr.mr_n80727920)
print v(xbgr.mr_n80728032)
print v(xbgr.mr_n80728352)
print v(xbgr.mr_n80728464)
print v(xbgr.mr_n80728784)
print v(xbgr.mr_n80728896)
print v(xbgr.mr_n80729216)
print v(xbgr.mr_n80729328)
print v(xbgr.mr_n80729648)
print v(xbgr.mr_n80729760)
print v(xbgr.mr_n80730080)
print v(xbgr.mr_n80730192)
print v(xbgr.mr_n80730512)
print v(xbgr.mr_n80730624)
print v(xbgr.mr_n80730944)
print v(xbgr.mr_n80731056)
print v(xbgr.mr_n80731376)
print v(xbgr.mr_n80731488)
print v(xbgr.mr_n80731808)
print v(xbgr.mr_n80732240)
print v(xbgr.mr_n80732352)
print v(xbgr.mr_n80732672)
print v(xbgr.mr_n80732784)
print v(xbgr.mr_n80733104)
print v(xbgr.mr_n80733216)
print v(xbgr.mr_n80733536)
print v(xbgr.mr_n80733648)
print v(xbgr.mr_n80733968)
print v(xbgr.mr_n80734080)
print v(xbgr.mr_n80734400)
print v(xbgr.mr_n80734512)
print v(xbgr.mr_n80734832)
print v(xbgr.mr_n80734944)
print v(xbgr.mr_n80735264)
print v(xbgr.mr_n80735376)
print v(xbgr.mr_n80735696)
print v(xbgr.mr_n80735808)
print v(xbgr.mr_n80736128)
print v(xbgr.mr_n80736240)
print v(xbgr.mr_n80736560)
print v(xbgr.mr_n80736672)
print v(xbgr.mr_n80736992)
print v(xbgr.mr_n80737104)
print v(xbgr.mr_n80737424)
print v(xbgr.mr_n80737536)
print v(xbgr.mr_n80737856)
print v(xbgr.mr_n80737968)
print v(xbgr.mr_n80738288)
print v(xbgr.mr_n80738400)
print v(xbgr.mr_n80738720)
print v(xbgr.mr_n80738832)
print v(xbgr.mr_n80739152)
print v(xbgr.mr_n80739264)
print v(xbgr.mr_n80739584)
print v(xbgr.mr_n80739696)
print v(xbgr.mr_n80740016)
print v(xbgr.mr_n80740128)
print v(xbgr.mr_n80740448)
print v(xbgr.mr_n80740560)
print v(xbgr.mr_n80740880)
print v(xbgr.mr_n80740992)
print v(xbgr.mr_n80741312)
print v(xbgr.mr_n80741424)
print v(xbgr.mr_n80741744)
print v(xbgr.mr_n80741856)
print v(xbgr.mr_n80742176)
print v(xbgr.mr_n80742288)
print v(xbgr.mr_n80742608)
print v(xbgr.mr_n80742720)
print v(xbgr.mr_n80743040)
print v(xbgr.mr_n80743152)
print v(xbgr.mr_n80743472)
print v(xbgr.mr_n80743584)
print v(xbgr.mr_n80743904)
print v(xbgr.mr_n80744016)
print v(xbgr.mr_n80744336)
print v(xbgr.mr_n80744448)
print v(xbgr.mr_n80744768)
print v(xbgr.mr_n80744880)
print v(xbgr.mr_n80745200)
print v(xbgr.mr_n80745312)
print v(xbgr.mr_n80745632)
print v(xbgr.mr_n80745744)
print v(xbgr.mr_n80746064)
print v(xbgr.mr_n80746176)
print v(xbgr.mr_n80746496)
print v(xbgr.mr_n80746608)
print v(xbgr.mr_n80746928)
print v(xbgr.mr_n80747040)
print v(xbgr.mr_n80747360)
print v(xbgr.mr_n80747472)
print v(xbgr.mr_n80747792)
print v(xbgr.mr_n80747904)
print v(xbgr.mr_n80748224)
print v(xbgr.mr_n80748336)
print v(xbgr.mr_n80748656)
print v(xbgr.mr_n80748768)
print v(xbgr.mr_n80749088)
print v(xbgr.mr_n80749200)
print v(xbgr.mr_n80749520)
print v(xbgr.mr_n80749632)
print v(xbgr.mr_n80749952)
print v(xbgr.mr_n80750064)
print v(xbgr.mr_n80750384)
print v(xbgr.mr_n80750496)
print v(xbgr.mr_n80750816)
print v(xbgr.mr_n80750928)
print v(xbgr.mr_n80751248)
print v(xbgr.mr_n80751360)
print v(xbgr.mr_n80751680)
print v(xbgr.mr_n80751792)
print v(xbgr.mr_n80752112)
print v(xbgr.mr_n80752224)
print v(xbgr.mr_n80752544)
print v(xbgr.mr_n80752656)
print v(xbgr.mr_n80752976)
print v(xbgr.mr_n80753088)
print v(xbgr.mr_n80753408)
print v(xbgr.mr_n80753520)
print v(xbgr.mr_n80753952)
print v(xbgr.mr_n80754384)
print v(xbgr.mr_n80754816)
print v(xbgr.mr_n80755248)
print v(xbgr.mr_n80755680)
print v(xbgr.mr_n80756112)
print v(xbgr.mr_n80756544)
print v(xbgr.mr_n80756976)
print v(xbgr.mr_n80757296)
print v(xbgr.mr_n80757408)
print v(xbgr.mr_n80757728)
print v(xbgr.mr_n80757840)
print v(xbgr.mr_n80758160)
print v(xbgr.mr_n80758272)
print v(xbgr.mr_n80758592)
print v(xbgr.mr_n80758704)
print v(xbgr.mr_n80759024)
print v(xbgr.mr_n80759136)
print v(xbgr.mr_n80759456)
print v(xbgr.mr_n80759568)
print v(xbgr.mr_n80759888)
print v(xbgr.mr_n80760000)
print v(xbgr.mr_n80760320)
print v(xbgr.mr_n80760432)
print v(xbgr.mr_n80760864)
print v(xbgr.mr_n80761296)
print v(xbgr.mr_n80761728)
print v(xbgr.mr_n80762160)
print v(xbgr.mr_n80762592)
print v(xbgr.mr_n80763024)
print v(xbgr.mr_n80763344)
print v(xbgr.mr_n80763456)
print v(xbgr.mr_n80763888)
print v(xbgr.mr_n80764320)
print v(xbgr.mr_n80764752)
print v(xbgr.mr_n80765184)
print v(xbgr.mr_n80765616)
print v(xbgr.mr_n80766048)
print v(xbgr.mr_n80766480)
print v(xbgr.mr_n80766912)
print v(xbgr.mr_n80767344)
print v(xbgr.mr_n80767776)
print v(xbgr.mr_n80768208)
print v(xbgr.mr_n80768640)
print v(xbgr.mr_n80768960)
print v(xbgr.mr_n80769072)
print v(xbgr.mr_n80769392)
print v(xbgr.mr_n80769504)
print v(xbgr.mr_n80769824)
print v(xbgr.mr_n80769936)
print v(xbgr.mr_n80770256)
print v(xbgr.mr_n80770368)
print v(xbgr.mr_n80770688)
print v(xbgr.mr_n80770800)
print v(xbgr.mr_n80771120)
print v(xbgr.mr_n80771232)
print v(xbgr.mr_n80771552)
print v(xbgr.mr_n80771664)
print v(xbgr.mr_n80771984)
print v(xbgr.mr_n80772096)
print v(xbgr.mr_n80772416)
print v(xbgr.mr_n80772528)
print v(xbgr.mr_n80772848)
print v(xbgr.mr_n80772960)
print v(xbgr.mr_n80773280)
print v(xbgr.mr_n80773392)
print v(xbgr.mr_n80773712)
print v(xbgr.mr_n80773824)
print v(xbgr.mr_n80774144)
print v(xbgr.mr_n80774256)
print v(xbgr.mr_n80774576)
print v(xbgr.mr_n80774688)
print v(xbgr.mr_n80775008)
print v(xbgr.mr_n80775120)
print v(xbgr.mr_n80775440)
print v(xbgr.mr_n80775552)
print v(xbgr.mr_n80775872)
print v(xbgr.mr_n80775984)
print v(xbgr.mr_n80776304)
print v(xbgr.mr_n80776416)
print v(xbgr.mr_n80776736)
print v(xbgr.mr_n80776848)
print v(xbgr.mr_n80777168)
print v(xbgr.mr_n80777280)
print v(xbgr.mr_n80777600)
print v(xbgr.mr_n80777712)
print v(xbgr.mr_n80778144)
print v(xbgr.mr_n80778576)
print v(xbgr.mr_n80779008)
print v(xbgr.mr_n80779440)
print v(xbgr.mr_n80779872)
print v(xbgr.mr_n80780304)
print v(xbgr.mr_n80780736)
print v(xbgr.mr_n80781168)
print v(xbgr.mr_n80781600)
print v(xbgr.mr_n80782032)
print v(xbgr.mr_n80782464)
print v(xbgr.mr_n80782896)
print v(xbgr.mr_n80783328)
print v(xbgr.mr_n80783760)
print v(xbgr.mr_n80784192)
print v(xbgr.mr_n80784624)
print v(xbgr.mr_n80785056)
print v(xbgr.mr_n80785488)
print v(xbgr.mr_n80785920)
print v(xbgr.mr_n80786240)
print v(xbgr.mr_n80786352)
print v(xbgr.mr_n80786672)
print v(xbgr.mr_n80786784)
print v(xbgr.mr_n80787104)
print v(xbgr.mr_n80787216)
print v(xbgr.mr_n80787536)
print v(xbgr.mr_n80787648)
print v(xbgr.mr_n80787968)
print v(xbgr.mr_n80788080)
print v(xbgr.mr_n80788512)
print v(xbgr.mr_n80788944)
print v(xbgr.mr_n80789376)
print v(xbgr.mr_n80789808)
print v(xbgr.mr_n80790240)
print v(xbgr.mr_n80790672)
print v(xbgr.mr_n80791104)
print v(xbgr.mr_n80791424)
print v(xbgr.mr_n80791536)
print v(xbgr.mr_n80791856)
print v(xbgr.mr_n80791968)
print v(xbgr.mr_n80792288)
print v(xbgr.mr_n80792400)
print v(xbgr.mr_n80792720)
print v(xbgr.mr_n80792832)
print v(xbgr.mr_n80793152)
print v(xbgr.mr_n80793264)
print v(xbgr.mr_n80793584)
print v(xbgr.mr_n80793696)
print v(xbgr.mr_n80794016)
print v(xbgr.mr_n80794128)
print v(xbgr.mr_n80794448)
print v(xbgr.mr_n80794560)
print v(xbgr.mr_n80794880)
print v(xbgr.mr_n80794992)
print v(xbgr.mr_n80795312)
print v(xbgr.mr_n80795424)
print v(xbgr.mr_n80795744)
print v(xbgr.mr_n80795856)
print v(xbgr.mr_n80796176)
print v(xbgr.mr_n80796288)
print v(xbgr.mr_n80796608)
print v(xbgr.mr_n80796720)
print v(xbgr.mr_n80797152)
print v(xbgr.mr_n80797584)
print v(xbgr.mr_n80798016)
print v(xbgr.mr_n80798448)
print v(xbgr.mr_n80798880)
print v(xbgr.mr_n80799312)
print v(xbgr.mr_n80799744)
print v(xbgr.mr_n80800176)
print v(xbgr.mr_n80800608)
print v(xbgr.mr_n80801040)
print v(xbgr.mr_n80801472)
print v(xbgr.mr_n80801904)
print v(xbgr.mr_n80802336)
print v(xbgr.mr_n80802656)
print v(xbgr.mr_n80802768)
print v(xbgr.mr_n80803088)
print v(xbgr.mr_n80803200)
print v(xbgr.mr_n80803520)
print v(xbgr.mr_n80803632)
print v(xbgr.mr_n80803952)
print v(xbgr.mr_n80804064)
print v(xbgr.mr_n80804384)
print v(xbgr.mr_n80804496)
print v(xbgr.mr_n80804816)
print v(xbgr.mr_n80804928)
print v(xbgr.mr_n80805248)
print v(xbgr.mr_n80805360)
print v(xbgr.mr_n80805680)
print v(xbgr.mr_n80805792)
print v(xbgr.mr_n80806112)
print v(xbgr.mr_n80806224)
print v(xbgr.mr_n80806544)
print v(xbgr.mr_n80806656)
print v(xbgr.mr_n80806976)
print v(xbgr.mr_n80807088)
print v(xbgr.mr_n80807408)
print v(xbgr.mr_n80807520)
print v(xbgr.mr_n80807952)
print v(xbgr.mr_n80808384)
print v(xbgr.mr_n80808816)
print v(xbgr.mr_n80809248)
print v(xbgr.mr_n80809680)
print v(xbgr.mr_n80810112)
print v(xbgr.mr_n80810544)
print v(xbgr.mr_n80810976)
print v(xbgr.mr_n80811408)
print v(xbgr.mr_n80811840)
print v(xbgr.mr_n80812272)
print v(xbgr.mr_n80812704)
print v(xbgr.mr_n80813024)
print v(xbgr.mr_n80813136)
print v(xbgr.mr_n80813568)
print v(xbgr.mr_n80813888)
print v(xbgr.mr_n80814000)
print v(xbgr.mr_n80814320)
print v(xbgr.mr_n80814432)
print v(xbgr.mr_n80814752)
print v(xbgr.mr_n80814864)
print v(xbgr.mr_n80815184)
print v(xbgr.mr_n80815296)
print v(xbgr.mr_n80815616)
print v(xbgr.mr_n80815728)
print v(xbgr.mr_n80816160)
print v(xbgr.mr_n80816592)
print v(xbgr.mr_n80816912)
print v(xbgr.mr_n80817024)
print v(xbgr.mr_n80817344)
print v(xbgr.mr_n80817456)
print v(xbgr.mr_n80817776)
print v(xbgr.mr_n80817888)
print v(xbgr.mr_n80818208)
print v(xbgr.mr_n80818320)
print v(xbgr.mr_n80818640)
print v(xbgr.mr_n80818752)
print v(xbgr.mr_n80819072)
print v(xbgr.mr_n80819184)
print v(xbgr.mr_n80819504)
print v(xbgr.mr_n80819616)
print v(xbgr.mr_n80819936)
print v(xbgr.mr_n80820048)
print v(xbgr.mr_n80820480)
print v(xbgr.mr_n80820912)
print v(xbgr.mr_n80821344)
print v(xbgr.mr_n80821776)
print v(xbgr.mr_n80822208)
print v(xbgr.mr_n80822640)
print v(xbgr.mr_n80823072)
print v(xbgr.mr_n80823504)
print v(xbgr.mr_n80823936)
print v(xbgr.mr_n80824368)
print v(xbgr.mr_n80824800)
print v(xbgr.mr_n80825120)
print v(xbgr.mr_n80825232)
print v(xbgr.mr_n80825552)
print v(xbgr.mr_n80825664)
print v(xbgr.mr_n80825984)
print v(xbgr.mr_n80826096)
print v(xbgr.mr_n80826528)
print v(xbgr.mr_n80826960)
print v(xbgr.mr_n80827280)
print v(xbgr.mr_n80827392)
print v(xbgr.mr_n80827712)
print v(xbgr.mr_n80827824)
print v(xbgr.mr_n80828144)
print v(xbgr.mr_n80828256)
print v(xbgr.mr_n80828576)
print v(xbgr.mr_n80828688)
print v(xbgr.mr_n80829120)
print v(xbgr.mr_n80829440)
print v(xbgr.mr_n80829552)
print v(xbgr.mr_n80829872)
print v(xbgr.mr_n80829984)
print v(xbgr.mr_n80830304)
print v(xbgr.mr_n80830416)
print v(xbgr.mr_n80830736)
print v(xbgr.mr_n80830848)
print v(xbgr.mr_n80831168)
print v(xbgr.mr_n80831280)
print v(xbgr.mr_n80831600)
print v(xbgr.mr_n80831712)
print v(xbgr.mr_n80832144)
print v(xbgr.mr_n80832576)
print v(xbgr.mr_n80833008)
print v(xbgr.mr_n80833440)
print v(xbgr.mr_n80833872)
print v(xbgr.mr_n80834304)
print v(xbgr.mr_n80834736)
print v(xbgr.mr_n80835168)
print v(xbgr.mr_n80835600)
print v(xbgr.mr_n80836032)
print v(xbgr.mr_n80836352)
print v(xbgr.mr_n80836464)
print v(xbgr.mr_n80836784)
print v(xbgr.mr_n80836896)
print v(xbgr.mr_n80837216)
print v(xbgr.mr_n80837328)
print v(xbgr.mr_n80837648)
print v(xbgr.mr_n80837760)
print v(xbgr.mr_n80838080)
print v(xbgr.mr_n80838192)
print v(xbgr.mr_n80838512)
print v(xbgr.mr_n80838624)
print v(xbgr.mr_n80838944)
print v(xbgr.mr_n80839056)
print v(xbgr.mr_n80839376)
print v(xbgr.mr_n80839488)
print v(xbgr.mr_n80839808)
print v(xbgr.mr_n80839920)
print v(xbgr.mr_n80840240)
print v(xbgr.mr_n80840352)
print v(xbgr.mr_n80840672)
print v(xbgr.mr_n80840784)
print v(xbgr.mr_n80841104)
print v(xbgr.mr_n80841216)
print v(xbgr.mr_n80841536)
print v(xbgr.mr_n80841648)
print v(xbgr.mr_n80842080)
print v(xbgr.mr_n80842512)
print v(xbgr.mr_n80842944)
print v(xbgr.mr_n80843376)
print v(xbgr.mr_n80843808)
print v(xbgr.mr_n80844240)
print v(xbgr.mr_n80844672)
print v(xbgr.mr_n80845104)
print v(xbgr.mr_n80845536)
print v(xbgr.mr_n80845968)
print v(xbgr.mr_n80846400)
print v(xbgr.mr_n80846832)
print v(xbgr.mr_n80847264)
print v(xbgr.mr_n80847584)
print v(xbgr.mr_n80847696)
print v(xbgr.mr_n80848016)
print v(xbgr.mr_n80848128)
print v(xbgr.mr_n80848448)
print v(xbgr.mr_n80848560)
print v(xbgr.mr_n80848880)
print v(xbgr.mr_n80848992)
print v(xbgr.mr_n80849312)
print v(xbgr.mr_n80849424)
print v(xbgr.mr_n80849744)
print v(xbgr.mr_n80849856)
print v(xbgr.mr_n80850176)
print v(xbgr.mr_n80850288)
print v(xbgr.mr_n80850608)
print v(xbgr.mr_n80850720)
print v(xbgr.mr_n80851040)
print v(xbgr.mr_n80851152)
print v(xbgr.mr_n80851472)
print v(xbgr.mr_n80851584)
print v(xbgr.mr_n80851904)
print v(xbgr.mr_n80852016)
print v(xbgr.mr_n80852336)
print v(xbgr.mr_n80852448)
print v(xbgr.mr_n80852768)
print v(xbgr.mr_n80852880)
print v(xbgr.mr_n80853312)
print v(xbgr.mr_n80853744)
print v(xbgr.mr_n80854176)
print v(xbgr.mr_n80854608)
print v(xbgr.mr_n80855040)
print v(xbgr.mr_n80855472)
print v(xbgr.mr_n80855904)
print v(xbgr.mr_n80856336)
print v(xbgr.mr_n80856768)
print v(xbgr.mr_n80857200)
print v(xbgr.mr_n80857632)
print v(xbgr.mr_n80858064)
print v(xbgr.mr_n80858496)
print v(xbgr.mr_n80858816)
print v(xbgr.mr_n80858928)
print v(xbgr.mr_n80859248)
print v(xbgr.mr_n80859360)
print v(xbgr.mr_n80859680)
print v(xbgr.mr_n80859792)
print v(xbgr.mr_n80860112)
print v(xbgr.mr_n80860224)
print v(xbgr.mr_n80860544)
print v(xbgr.mr_n80860656)
print v(xbgr.mr_n80860976)
print v(xbgr.mr_n80861088)
print v(xbgr.mr_n80861408)
print v(xbgr.mr_n80861520)
print v(xbgr.mr_n80861840)
print v(xbgr.mr_n80861952)
print v(xbgr.mr_n80862272)
print v(xbgr.mr_n80862384)
print v(xbgr.mr_n80862704)
print v(xbgr.mr_n80862816)
print v(xbgr.mr_n80863136)
print v(xbgr.mr_n80863248)
print v(xbgr.mr_n80863568)
print v(xbgr.mr_n80863680)
print v(xbgr.mr_n80864000)
print v(xbgr.mr_n80864112)
print v(xbgr.mr_n80864544)
print v(xbgr.mr_n80864976)
print v(xbgr.mr_n80865408)
print v(xbgr.mr_n80865840)
print v(xbgr.mr_n80866272)
print v(xbgr.mr_n80866704)
print v(xbgr.mr_n80867136)
print v(xbgr.mr_n80867568)
print v(xbgr.mr_n80868000)
print v(xbgr.mr_n80868432)
print v(xbgr.mr_n80868864)
print v(xbgr.mr_n80869296)
print v(xbgr.mr_n80869728)
print v(xbgr.mr_n80870048)
print v(xbgr.mr_n80870160)
print v(xbgr.mr_n80870480)
print v(xbgr.mr_n80870592)
print v(xbgr.mr_n80871024)
print v(xbgr.mr_n80871344)
print v(xbgr.mr_n80871456)
print v(xbgr.mr_n80871776)
print v(xbgr.mr_n80871888)
print v(xbgr.mr_n80872208)
print v(xbgr.mr_n80872320)
print v(xbgr.mr_n80872640)
print v(xbgr.mr_n80872752)
print v(xbgr.mr_n80873184)
print v(xbgr.mr_n80873616)
print v(xbgr.mr_n80874048)
print v(xbgr.mr_n80874480)
print v(xbgr.mr_n80874800)
print v(xbgr.mr_n80874912)
print v(xbgr.mr_n80875232)
print v(xbgr.mr_n80875344)
print v(xbgr.mr_n80875776)
print v(xbgr.mr_n80876208)
print v(xbgr.mr_n80876528)
print v(xbgr.mr_n80876640)
print v(xbgr.mr_n80876960)
print v(xbgr.mr_n80877072)
print v(xbgr.mr_n80877392)
print v(xbgr.mr_n80877504)
print v(xbgr.mr_n80877824)
print v(xbgr.mr_n80877936)
print v(xbgr.mr_n80878256)
print v(xbgr.mr_n80878368)
print v(xbgr.mr_n80878800)
print v(xbgr.mr_n80879232)
print v(xbgr.mr_n80879664)
print v(xbgr.mr_n80880096)
print v(xbgr.mr_n80880528)
print v(xbgr.mr_n80880960)
print v(xbgr.mr_n80881280)
print v(xbgr.mr_n80881392)
print v(xbgr.mr_n80881712)
print v(xbgr.mr_n80881824)
print v(xbgr.mr_n80882144)
print v(xbgr.mr_n80882256)
print v(xbgr.mr_n80882576)
print v(xbgr.mr_n80882688)
print v(xbgr.mr_n80883008)
print v(xbgr.mr_n80883120)
print v(xbgr.mr_n80883440)
print v(xbgr.mr_n80883552)
print v(xbgr.mr_n80883872)
print v(xbgr.mr_n80883984)
print v(xbgr.mr_n80884304)
print v(xbgr.mr_n80884416)
print v(xbgr.mr_n80884736)
print v(xbgr.mr_n80884848)
print v(xbgr.mr_n80885168)
print v(xbgr.mr_n80885280)
print v(xbgr.mr_n80885600)
print v(xbgr.mr_n80885712)
print v(xbgr.mr_n80886032)
print v(xbgr.mr_n80886144)
print v(xbgr.mr_n80886576)
print v(xbgr.mr_n80887008)
print v(xbgr.mr_n80887440)
print v(xbgr.mr_n80887872)
print v(xbgr.mr_n80888304)
print v(xbgr.mr_n80888736)
print v(xbgr.mr_n80889168)
print v(xbgr.mr_n80889600)
print v(xbgr.mr_n80889920)
print v(xbgr.mr_n80890032)
print v(xbgr.mr_n80890352)
print v(xbgr.mr_n80890464)
print v(xbgr.mr_n80890784)
print v(xbgr.mr_n80890896)
print v(xbgr.mr_n80891216)
print v(xbgr.mr_n80891328)
print v(xbgr.mr_n80891648)
print v(xbgr.mr_n80891760)
print v(xbgr.mr_n80892080)
print v(xbgr.mr_n80892192)
print v(xbgr.mr_n80892512)
print v(xbgr.mr_n80892624)
print v(xbgr.mr_n80892944)
print v(xbgr.mr_n80893056)
print v(xbgr.mr_n80893488)
print v(xbgr.mr_n80893920)
print v(xbgr.mr_n80894240)
print v(xbgr.mr_n80894352)
print v(xbgr.mr_n80894672)
print v(xbgr.mr_n80894784)
print v(xbgr.mr_n80895104)
print v(xbgr.mr_n80895216)
print v(xbgr.mr_n80895536)
print v(xbgr.mr_n80895648)
print v(xbgr.mr_n80895968)
print v(xbgr.mr_n80896080)
print v(xbgr.mr_n80896400)
print v(xbgr.mr_n80896512)
print v(xbgr.mr_n80896944)
print v(xbgr.mr_n80897376)
print v(xbgr.mr_n80897808)
print v(xbgr.mr_n80898240)
print v(xbgr.mr_n80898672)
print v(xbgr.mr_n80899104)
print v(xbgr.mr_n80899536)
print v(xbgr.mr_n80899968)
print v(xbgr.mr_n80900400)
print v(xbgr.mr_n80900832)
print v(xbgr.mr_n80901264)
print v(xbgr.mr_n80901696)
print v(xbgr.mr_n80902128)
print v(xbgr.mr_n80902560)
print v(xbgr.mr_n80902992)
print v(xbgr.mr_n80903424)
print v(xbgr.mr_n80903744)
print v(xbgr.mr_n80903856)
print v(xbgr.mr_n80904176)
print v(xbgr.mr_n80904288)
print v(xbgr.mr_n80904608)
print v(xbgr.mr_n80904720)
print v(xbgr.mr_n80905040)
print v(xbgr.mr_n80905152)
print v(xbgr.mr_n80905472)
print v(xbgr.mr_n80905584)
print v(xbgr.mr_n80905904)
print v(xbgr.mr_n80906016)
print v(xbgr.mr_n80906336)
print v(xbgr.mr_n80906448)
print v(xbgr.mr_n80906768)
print v(xbgr.mr_n80906880)
print v(xbgr.mr_n80907200)
print v(xbgr.mr_n80907312)
print v(xbgr.mr_n80907632)
print v(xbgr.mr_n80907744)
print v(xbgr.mr_n80908064)
print v(xbgr.mr_n80908176)
print v(xbgr.mr_n80908496)
print v(xbgr.mr_n80908608)
print v(xbgr.mr_n80908928)
print v(xbgr.mr_n80909040)
print v(xbgr.mr_n80909360)
print v(xbgr.mr_n80909472)
print v(xbgr.mr_n80909792)
print v(xbgr.mr_n80909904)
print v(xbgr.mr_n80910224)
print v(xbgr.mr_n80910336)
print v(xbgr.mr_n80910656)
print v(xbgr.mr_n80910768)
print v(xbgr.mr_n80911088)
print v(xbgr.mr_n80911200)
print v(xbgr.mr_n80911520)
print v(xbgr.mr_n80911632)
print v(xbgr.mr_n80911952)
print v(xbgr.mr_n80912064)
print v(xbgr.mr_n80912496)
print v(xbgr.mr_n80912928)
print v(xbgr.mr_n80913360)
print v(xbgr.mr_n80913792)
print v(xbgr.mr_n80914224)
print v(xbgr.mr_n80914656)
print v(xbgr.mr_n80914976)
print v(xbgr.mr_n80915088)
print v(xbgr.mr_n80915408)
print v(xbgr.mr_n80915520)
print v(xbgr.mr_n80915840)
print v(xbgr.mr_n80915952)
print v(xbgr.mr_n80916272)
print v(xbgr.mr_n80916384)
print v(xbgr.mr_n80916704)
print v(xbgr.mr_n80916816)
print v(xbgr.mr_n80917136)
print v(xbgr.mr_n80917248)
print v(xbgr.mr_n80917680)
print v(xbgr.mr_n80918112)
print v(xbgr.mr_n80918544)
print v(xbgr.mr_n80918976)
print v(xbgr.mr_n80919408)
print v(xbgr.mr_n80919840)
print v(xbgr.mr_n80920272)
print v(xbgr.mr_n80920704)
print v(xbgr.mr_n80921136)
print v(xbgr.mr_n80921568)
print v(xbgr.mr_n80922000)
print v(xbgr.mr_n80922432)
print v(xbgr.mr_n80922864)
print v(xbgr.mr_n80923296)
print v(xbgr.mr_n80923728)
print v(xbgr.mr_n80924160)
print v(xbgr.mr_n80924592)
print v(xbgr.mr_n80925024)
print v(xbgr.mr_n80925456)
print v(xbgr.mr_n80925888)
print v(xbgr.mr_n80926208)
print v(xbgr.mr_n80926320)
print v(xbgr.mr_n80926640)
print v(xbgr.mr_n80926752)
print v(xbgr.mr_n80927072)
print v(xbgr.mr_n80927184)
print v(xbgr.mr_n80927504)
print v(xbgr.mr_n80927616)
print v(xbgr.mr_n80927936)
print v(xbgr.mr_n80928048)
print v(xbgr.mr_n80928368)
print v(xbgr.mr_n80928480)
print v(xbgr.mr_n80928800)
print v(xbgr.mr_n80928912)
print v(xbgr.mr_n80929232)
print v(xbgr.mr_n80929344)
print v(xbgr.mr_n80929664)
print v(xbgr.mr_n80929776)
print v(xbgr.mr_n80930096)
print v(xbgr.mr_n80930208)
print v(xbgr.mr_n80930528)
print v(xbgr.mr_n80930640)
print v(xbgr.mr_n80930960)
print v(xbgr.mr_n80931072)
print v(xbgr.mr_n80931392)
print v(xbgr.mr_n80931504)
print v(xbgr.mr_n80931824)
print v(xbgr.mr_n80931936)
print v(xbgr.mr_n80932256)
print v(xbgr.mr_n80932368)
print v(xbgr.mr_n80932688)
print v(xbgr.mr_n80932800)
print v(xbgr.mr_n80933120)
print v(xbgr.mr_n80933232)
print v(xbgr.mr_n80933552)
print v(xbgr.mr_n80933664)
print v(xbgr.mr_n80933984)
print v(xbgr.mr_n80934096)
print v(xbgr.mr_n80934416)
print v(xbgr.mr_n80934528)
print v(xbgr.mr_n80934848)
print v(xbgr.mr_n80934960)
print v(xbgr.mr_n80935280)
print v(xbgr.mr_n80935392)
print v(xbgr.mr_n80935712)
print v(xbgr.mr_n80935824)
print v(xbgr.mr_n80936144)
print v(xbgr.mr_n80936256)
print v(xbgr.mr_n80936576)
print v(xbgr.mr_n80936688)
print v(xbgr.mr_n80937008)
print v(xbgr.mr_n80937120)
print v(xbgr.mr_n80937440)
print v(xbgr.mr_n80937552)
print v(xbgr.mr_n80937872)
print v(xbgr.mr_n80937984)
print v(xbgr.mr_n80938304)
print v(xbgr.mr_n80938416)
print v(xbgr.mr_n80938736)
print v(xbgr.mr_n80938848)
print v(xbgr.mr_n80939168)
print v(xbgr.mr_n80939280)
print v(xbgr.mr_n80939600)
print v(xbgr.mr_n80939712)
print v(xbgr.mr_n80940144)
print v(xbgr.mr_n80940576)
print v(xbgr.mr_n80940896)
print v(xbgr.mr_n80941008)
print v(xbgr.mr_n80941328)
print v(xbgr.mr_n80941440)
print v(xbgr.mr_n80941760)
print v(xbgr.mr_n80941872)
print v(xbgr.mr_n80942192)
print v(xbgr.mr_n80942304)
print v(xbgr.mr_n80942624)
print v(xbgr.mr_n80942736)
print v(xbgr.mr_n80943056)
print v(xbgr.mr_n80943168)
print v(xbgr.mr_n80943488)
print v(xbgr.mr_n80943600)
print v(xbgr.mr_n80943920)
print v(xbgr.mr_n80944032)
print v(xbgr.mr_n80944352)
print v(xbgr.mr_n80944464)
print v(xbgr.mr_n80944784)
print v(xbgr.mr_n80944896)
print v(xbgr.mr_n80945328)
print v(xbgr.mr_n80945760)
print v(xbgr.mr_n80946192)
print v(xbgr.mr_n80946512)
print v(xbgr.mr_n80946624)
print v(xbgr.mr_n80946944)
print v(xbgr.mr_n80947056)
print v(xbgr.mr_n80947488)
print v(xbgr.mr_n80947920)
print v(xbgr.mr_n80948352)
print v(xbgr.mr_n80948784)
print v(xbgr.mr_n80949216)
print v(xbgr.mr_n80949648)
print v(xbgr.mr_n80950080)
print v(xbgr.mr_n80950512)
print v(xbgr.mr_n80950944)
print v(xbgr.mr_n80951376)
print v(xbgr.mr_n80951808)
print v(xbgr.mr_n80952128)
print v(xbgr.mr_n80952240)
print v(xbgr.mr_n80952560)
print v(xbgr.mr_n80952672)
print v(xbgr.mr_n80952992)
print v(xbgr.mr_n80953104)
print v(xbgr.mr_n80953424)
print v(xbgr.mr_n80953536)
print v(xbgr.mr_n80953856)
print v(xbgr.mr_n80953968)
print v(xbgr.mr_n80954288)
print v(xbgr.mr_n80954400)
print v(xbgr.mr_n80954720)
print v(xbgr.mr_n80954832)
print v(xbgr.mr_n80955152)
print v(xbgr.mr_n80955264)
print v(xbgr.mr_n80955696)
print v(xbgr.mr_n80956128)
print v(xbgr.mr_n80956560)
print v(xbgr.mr_n80956992)
print v(xbgr.mr_n80957424)
print v(xbgr.mr_n80957856)
print v(xbgr.mr_n80958288)
print v(xbgr.mr_n80958720)
print v(xbgr.mr_n80959152)
print v(xbgr.mr_n80959584)
print v(xbgr.mr_n80960016)
print v(xbgr.mr_n80960448)
print v(xbgr.mr_n80960880)
print v(xbgr.mr_n80961312)
print v(xbgr.mr_n80961744)
print v(xbgr.mr_n80962176)
print v(xbgr.mr_n80962608)
print v(xbgr.mr_n80963040)
print v(xbgr.mr_n80963472)
print v(xbgr.mr_n80963904)
print v(xbgr.mr_n80964224)
print v(xbgr.mr_n80964336)
print v(xbgr.mr_n80964656)
print v(xbgr.mr_n80964768)
print v(xbgr.mr_n80965088)
print v(xbgr.mr_n80965200)
print v(xbgr.mr_n80965520)
print v(xbgr.mr_n80965632)
print v(xbgr.mr_n80965952)
print v(xbgr.mr_n80966064)
print v(xbgr.mr_n80966384)
print v(xbgr.mr_n80966496)
print v(xbgr.mr_n80966816)
print v(xbgr.mr_n80966928)
print v(xbgr.mr_n80967248)
print v(xbgr.mr_n80967360)
print v(xbgr.mr_n80967680)
print v(xbgr.mr_n80967792)
print v(xbgr.mr_n80968112)
print v(xbgr.mr_n80968224)
print v(xbgr.mr_n80968544)
print v(xbgr.mr_n80968656)
print v(xbgr.mr_n80968976)
print v(xbgr.mr_n80969088)
print v(xbgr.mr_n80969408)
print v(xbgr.mr_n80969520)
print v(xbgr.mr_n80969952)
print v(xbgr.mr_n80970384)
print v(xbgr.mr_n80970816)
print v(xbgr.mr_n80971248)
print v(xbgr.mr_n80971680)
print v(xbgr.mr_n80972112)
print v(xbgr.mr_n80972544)
print v(xbgr.mr_n80972976)
print v(xbgr.mr_n80973408)
print v(xbgr.mr_n80973840)
print v(xbgr.mr_n80974272)
print v(xbgr.mr_n80974704)
print v(xbgr.mr_n80975136)
print v(xbgr.mr_n80975456)
print v(xbgr.mr_n80975568)
print v(xbgr.mr_n80975888)
print v(xbgr.mr_n80976000)
print v(xbgr.mr_n80976320)
print v(xbgr.mr_n80976432)
print v(xbgr.mr_n80976752)
print v(xbgr.mr_n80976864)
print v(xbgr.mr_n80977184)
print v(xbgr.mr_n80977296)
print v(xbgr.mr_n80977616)
print v(xbgr.mr_n80977728)
print v(xbgr.mr_n80978048)
print v(xbgr.mr_n80978160)
print v(xbgr.mr_n80978480)
print v(xbgr.mr_n80978592)
print v(xbgr.mr_n80978912)
print v(xbgr.mr_n80979024)
print v(xbgr.mr_n80979344)
print v(xbgr.mr_n80979456)
print v(xbgr.mr_n80979776)
print v(xbgr.mr_n80979888)
print v(xbgr.mr_n80980208)
print v(xbgr.mr_n80980320)
print v(xbgr.mr_n80980752)
print v(xbgr.mr_n80981072)
print v(xbgr.mr_n80981184)
print v(xbgr.mr_n80981616)
print v(xbgr.mr_n80982048)
print v(xbgr.mr_n80982480)
print v(xbgr.mr_n80982912)
print v(xbgr.mr_n80983344)
print v(xbgr.mr_n80983776)
print v(xbgr.mr_n80984208)
print v(xbgr.mr_n80984640)
print v(xbgr.mr_n80985072)
print v(xbgr.mr_n80985504)
print v(xbgr.mr_n80985936)
print v(xbgr.mr_n80986368)
print v(xbgr.mr_n80986688)
print v(xbgr.mr_n80986800)
print v(xbgr.mr_n80987120)
print v(xbgr.mr_n80987232)
print v(xbgr.mr_n80987552)
print v(xbgr.mr_n80987664)
print v(xbgr.mr_n80987984)
print v(xbgr.mr_n80988096)
print v(xbgr.mr_n80988416)
print v(xbgr.mr_n80988528)
print v(xbgr.mr_n80988848)
print v(xbgr.mr_n80988960)
print v(xbgr.mr_n80989280)
print v(xbgr.mr_n80989392)
print v(xbgr.mr_n80989712)
print v(xbgr.mr_n80989824)
print v(xbgr.mr_n80990144)
print v(xbgr.mr_n80990256)
print v(xbgr.mr_n80990576)
print v(xbgr.mr_n80990688)
print v(xbgr.mr_n80991008)
print v(xbgr.mr_n80991120)
print v(xbgr.mr_n80991552)
print v(xbgr.mr_n80991984)
print v(xbgr.mr_n80992416)
print v(xbgr.mr_n80992736)
print v(xbgr.mr_n80992848)
print v(xbgr.mr_n80993168)
print v(xbgr.mr_n80993280)
print v(xbgr.mr_n80993712)
print v(xbgr.mr_n80994144)
print v(xbgr.mr_n80994576)
print v(xbgr.mr_n80995008)
print v(xbgr.mr_n80995440)
print v(xbgr.mr_n80995872)
print v(xbgr.mr_n80996304)
print v(xbgr.mr_n80996736)
print v(xbgr.mr_n80997168)
print v(xbgr.mr_n80997600)
print v(xbgr.mr_n80997920)
print v(xbgr.mr_n80998032)
print v(xbgr.mr_n80998352)
print v(xbgr.mr_n80998464)
print v(xbgr.mr_n80998784)
print v(xbgr.mr_n80998896)
print v(xbgr.mr_n80999216)
print v(xbgr.mr_n80999328)
print v(xbgr.mr_n80999648)
print v(xbgr.mr_n80999760)
print v(xbgr.mr_n81000080)
print v(xbgr.mr_n81000192)
print v(xbgr.mr_n81000512)
print v(xbgr.mr_n81000624)
print v(xbgr.mr_n81000944)
print v(xbgr.mr_n81001056)
print v(xbgr.mr_n81001376)
print v(xbgr.mr_n81001488)
print v(xbgr.mr_n81001808)
print v(xbgr.mr_n81001920)
print v(xbgr.mr_n81002240)
print v(xbgr.mr_n81002352)
print v(xbgr.mr_n81002672)
print v(xbgr.mr_n81002784)
print v(xbgr.mr_n81003216)
print v(xbgr.mr_n81003648)
print v(xbgr.mr_n81004080)
print v(xbgr.mr_n81004512)
print v(xbgr.mr_n81004944)
print v(xbgr.mr_n81005376)
print v(xbgr.mr_n81005808)
print v(xbgr.mr_n81006128)
print v(xbgr.mr_n81006240)
print v(xbgr.mr_n81006672)
print v(xbgr.mr_n81007104)
print v(xbgr.mr_n81007536)
print v(xbgr.mr_n81007968)
print v(xbgr.mr_n81008400)
print v(xbgr.mr_n81008832)
print v(xbgr.mr_n81009152)
print v(xbgr.mr_n81009264)
print v(xbgr.mr_n81009584)
print v(xbgr.mr_n81009696)
print v(xbgr.mr_n81010016)
print v(xbgr.mr_n81010128)
print v(xbgr.mr_n81010448)
print v(xbgr.mr_n81010560)
print v(xbgr.mr_n81010880)
print v(xbgr.mr_n81010992)
print v(xbgr.mr_n81011312)
print v(xbgr.mr_n81011424)
print v(xbgr.mr_n81011744)
print v(xbgr.mr_n81011856)
print v(xbgr.mr_n81012176)
print v(xbgr.mr_n81012288)
print v(xbgr.mr_n81012608)
print v(xbgr.mr_n81012720)
print v(xbgr.mr_n81013040)
print v(xbgr.mr_n81013152)
print v(xbgr.mr_n81013472)
print v(xbgr.mr_n81013584)
print v(xbgr.mr_n81013904)
print v(xbgr.mr_n81014016)
print v(xbgr.mr_n81014336)
print v(xbgr.mr_n81014448)
print v(xbgr.mr_n81014768)
print v(xbgr.mr_n81014880)
print v(xbgr.mr_n81015200)
print v(xbgr.mr_n81015312)
print v(xbgr.mr_n81015632)
print v(xbgr.mr_n81015744)
print v(xbgr.mr_n81016064)
print v(xbgr.mr_n81016176)
print v(xbgr.mr_n81016496)
print v(xbgr.mr_n81016608)
print v(xbgr.mr_n81016928)
print v(xbgr.mr_n81017040)
print v(xbgr.mr_n81017360)
print v(xbgr.mr_n81017472)
print v(xbgr.mr_n81017792)
print v(xbgr.mr_n81017904)
print v(xbgr.mr_n81018224)
print v(xbgr.mr_n81018336)
print v(xbgr.mr_n81018656)
print v(xbgr.mr_n81018768)
print v(xbgr.mr_n81019088)
print v(xbgr.mr_n81019200)
print v(xbgr.mr_n81019632)
print v(xbgr.mr_n81020064)
print v(xbgr.mr_n81020496)
print v(xbgr.mr_n81020816)
print v(xbgr.mr_n81020928)
print v(xbgr.mr_n81021248)
print v(xbgr.mr_n81021360)
print v(xbgr.mr_n81021792)
print v(xbgr.mr_n81022224)
print v(xbgr.mr_n81022656)
print v(xbgr.mr_n81023088)
print v(xbgr.mr_n81023520)
print v(xbgr.mr_n81023952)
print v(xbgr.mr_n81024384)
print v(xbgr.mr_n81024816)
print v(xbgr.mr_n81025248)
print v(xbgr.mr_n81025680)
print v(xbgr.mr_n81026112)
print v(xbgr.mr_n81026544)
print v(xbgr.mr_n81026976)
print v(xbgr.mr_n81027408)
print v(xbgr.mr_n81027840)
print v(xbgr.mr_n81028272)
print v(xbgr.mr_n81028704)
print v(xbgr.mr_n81029136)
print v(xbgr.mr_n81029568)
print v(xbgr.mr_n81030000)
print v(xbgr.mr_n81030432)
print v(xbgr.mr_n81030864)
print v(xbgr.mr_n81031296)
print v(xbgr.mr_n81031616)
print v(xbgr.mr_n81031728)
print v(xbgr.mr_n81032048)
print v(xbgr.mr_n81032160)
print v(xbgr.mr_n81032480)
print v(xbgr.mr_n81032592)
print v(xbgr.mr_n81032912)
print v(xbgr.mr_n81033024)
print v(xbgr.mr_n81033344)
print v(xbgr.mr_n81033456)
print v(xbgr.mr_n81033776)
print v(xbgr.mr_n81033888)
print v(xbgr.mr_n81034208)
print v(xbgr.mr_n81034320)
print v(xbgr.mr_n81034640)
print v(xbgr.mr_n81034752)
print v(xbgr.mr_n81035072)
print v(xbgr.mr_n81035184)
print v(xbgr.mr_n81035504)
print v(xbgr.mr_n81035616)
print v(xbgr.mr_n81035936)
print v(xbgr.mr_n81036048)
print v(xbgr.mr_n81036368)
print v(xbgr.mr_n81036480)
print v(xbgr.mr_n81036800)
print v(xbgr.mr_n81036912)
print v(xbgr.mr_n81037232)
print v(xbgr.mr_n81037344)
print v(xbgr.mr_n81037776)
print v(xbgr.mr_n81038208)
print v(xbgr.mr_n81038528)
print v(xbgr.mr_n81038640)
print v(xbgr.mr_n81038960)
print v(xbgr.mr_n81039072)
print v(xbgr.mr_n81039392)
print v(xbgr.mr_n81039504)
print v(xbgr.mr_n81039824)
print v(xbgr.mr_n81039936)
print v(xbgr.mr_n81040368)
print v(xbgr.mr_n81040800)
print v(xbgr.mr_n81041120)
print v(xbgr.mr_n81041232)
print v(xbgr.mr_n81041552)
print v(xbgr.mr_n81041664)
print v(xbgr.mr_n81041984)
print v(xbgr.mr_n81042096)
print v(xbgr.mr_n81042416)
print v(xbgr.mr_n81042528)
print v(xbgr.mr_n81042848)
print v(xbgr.mr_n81042960)
print v(xbgr.mr_n81043280)
print v(xbgr.mr_n81043392)
print v(xbgr.mr_n81043712)
print v(xbgr.mr_n81043824)
print v(xbgr.mr_n81044144)
print v(xbgr.mr_n81044256)
print v(xbgr.mr_n81044688)
print v(xbgr.mr_n81045120)
print v(xbgr.mr_n81045552)
print v(xbgr.mr_n81045984)
print v(xbgr.mr_n81046416)
print v(xbgr.mr_n81046848)
print v(xbgr.mr_n81047280)
print v(xbgr.mr_n81047712)
print v(xbgr.mr_n81048144)
print v(xbgr.mr_n81048576)
print v(xbgr.mr_n81048896)
print v(xbgr.mr_n81049008)
print v(xbgr.mr_n81049328)
print v(xbgr.mr_n81049440)
print v(xbgr.mr_n81049760)
print v(xbgr.mr_n81049872)
print v(xbgr.mr_n81050192)
print v(xbgr.mr_n81050304)
print v(xbgr.mr_n81055424)
print v(xbgr.mr_n81055536)
print v(xbgr.mr_n81055872)
print v(xbgr.mr_n81055984)
print v(xbgr.mr_n81056304)
print v(xbgr.mr_n81056416)
print v(xbgr.mr_n81056784)
print v(xbgr.mr_n81056896)
print v(xbgr.mr_n81057216)
print v(xbgr.mr_n81057328)
print v(xbgr.mr_n81057648)
print v(xbgr.mr_n81057760)
print v(xbgr.mr_n81058000)
print v(xbgr.mr_n81058112)
print v(xbgr.mr_n81058432)
print v(xbgr.mr_n81058544)
print v(xbgr.mr_n81058864)
print v(xbgr.mr_n81058976)
print v(xbgr.mr_n81059296)
print v(xbgr.mr_n81059408)
print v(xbgr.mr_n81059728)
print v(xbgr.mr_n81059840)
print v(xbgr.mr_n81060160)
print v(xbgr.mr_n81060272)
print v(xbgr.mr_n81060592)
print v(xbgr.mr_n81060704)
print v(xbgr.mr_n81061024)
print v(xbgr.mr_n81061136)
print v(xbgr.mr_n81061456)
print v(xbgr.mr_n81061568)
print v(xbgr.mr_n81061888)
print v(xbgr.mr_n81062000)
print v(xbgr.mr_n81062320)
print v(xbgr.mr_n81062432)
print v(xbgr.mr_n81062752)
print v(xbgr.mr_n81062864)
print v(xbgr.mr_n81063184)
print v(xbgr.mr_n81063296)
print v(xbgr.mr_n81063616)
print v(xbgr.mr_n81063728)
print v(xbgr.mr_n81064048)
print v(xbgr.mr_n81064160)
print v(xbgr.mr_n81064480)
print v(xbgr.mr_n81064592)
print v(xbgr.mr_n81064912)
print v(xbgr.mr_n81065024)
print v(xbgr.mr_n81065344)
print v(xbgr.mr_n81065456)
print v(xbgr.mr_n81065776)
print v(xbgr.mr_n81065888)
print v(xbgr.mr_n81066208)
print v(xbgr.mr_n81066320)
print v(xbgr.mr_n81066640)
print v(xbgr.mr_n81066752)
print v(xbgr.mr_n81067072)
print v(xbgr.mr_n81067184)
print v(xbgr.mr_n81067504)
print v(xbgr.mr_n81067616)
print v(xbgr.mr_n81067936)
print v(xbgr.mr_n81068048)
print v(xbgr.mr_n81068368)
print v(xbgr.mr_n81068480)
print v(xbgr.mr_n81068800)
print v(xbgr.mr_n81068912)
print v(xbgr.mr_n81069232)
print v(xbgr.mr_n81069344)
print v(xbgr.mr_n81069664)
print v(xbgr.mr_n81069776)
print v(xbgr.mr_n81070096)
print v(xbgr.mr_n81070208)
print v(xbgr.mr_n81070528)
print v(xbgr.mr_n81070640)
print v(xbgr.mr_n81070960)
print v(xbgr.mr_n81071072)
print v(xbgr.mr_n81071392)
print v(xbgr.mr_n81071504)
print v(xbgr.mr_n81071824)
print v(xbgr.mr_n81071936)
print v(xbgr.mr_n81072256)
print v(xbgr.mr_n81072368)
print v(xbgr.mr_n81072688)
print v(xbgr.mr_n81072800)
print v(xbgr.mr_n81073120)
print v(xbgr.mr_n81073232)
print v(xbgr.mr_n81073552)
print v(xbgr.mr_n81073664)
print v(xbgr.mr_n81073984)
print v(xbgr.mr_n81074096)
print v(xbgr.mr_n81074416)
print v(xbgr.mr_n81074528)
print v(xbgr.mr_n81074848)
print v(xbgr.mr_n81074960)
print v(xbgr.mr_n81075280)
print v(xbgr.mr_n81075392)
print v(xbgr.mr_n81075712)
print v(xbgr.mr_n81075824)
print v(xbgr.mr_n81076144)
print v(xbgr.mr_n81076256)
print v(xbgr.mr_n81076576)
print v(xbgr.mr_n81076688)
print v(xbgr.mr_n81077008)
print v(xbgr.mr_n81077120)
print v(xbgr.mr_n81077440)
print v(xbgr.mr_n81077552)
print v(xbgr.mr_n81077872)
print v(xbgr.mr_n81077984)
print v(xbgr.mr_n81078304)
print v(xbgr.mr_n81078416)
print v(xbgr.mr_n81078736)
print v(xbgr.mr_n81078848)
print v(xbgr.mr_n81079168)
print v(xbgr.mr_n81079280)
print v(xbgr.mr_n81079600)
print v(xbgr.mr_n81079712)
print v(xbgr.mr_n81080032)
print v(xbgr.mr_n81080144)
print v(xbgr.mr_n81080464)
print v(xbgr.mr_n81080576)
print v(xbgr.mr_n81080896)
print v(xbgr.mr_n81081008)
print v(xbgr.mr_n81081328)
print v(xbgr.mr_n81081440)
print v(xbgr.mr_n81081760)
print v(xbgr.mr_n81081872)
print v(xbgr.mr_n81082192)
print v(xbgr.mr_n81082304)
print v(xbgr.mr_n81082624)
print v(xbgr.mr_n81082736)
print v(xbgr.mr_n81083056)
print v(xbgr.mr_n81083168)
print v(xbgr.mr_n81083488)
print v(xbgr.mr_n81083600)
print v(xbgr.mr_n81083920)
print v(xbgr.mr_n81084032)
print v(xbgr.mr_n81084352)
print v(xbgr.mr_n81084464)
print v(xbgr.mr_n81084784)
print v(xbgr.mr_n81084896)
print v(xbgr.mr_n81085216)
print v(xbgr.mr_n81085328)
print v(xbgr.mr_n81085552)
print v(xbgr.mr_n81085664)
print v(xbgr.mr_n81085920)
print v(xbgr.mr_n81086032)
print v(xbgr.mr_n81086288)
print v(xbgr.mr_n81086400)
print v(xbgr.mr_n81086656)
print v(xbgr.mr_n81086768)
print v(xbgr.mr_n81087024)
print v(xbgr.mr_n81087136)
print v(xbgr.mr_n81087392)
print v(xbgr.mr_n81087504)
print v(xbgr.mr_n81087760)
print v(xbgr.mr_n81087872)
print v(xbgr.mr_n81088128)
print v(xbgr.mr_n81088240)
print v(xbgr.mr_n81088496)
print v(xbgr.mr_n81088608)
print v(xbgr.mr_n81088864)
print v(xbgr.mr_n81088976)
print v(xbgr.mr_n81089232)
print v(xbgr.mr_n81089344)
print v(xbgr.mr_n81089664)
print v(xbgr.mr_n81089776)
print v(xbgr.mr_n81090096)
print v(xbgr.mr_n81090208)
print v(xbgr.mr_n81090528)
print v(xbgr.mr_n81090640)
print v(xbgr.mr_n81090960)
print v(xbgr.mr_n81091072)
print v(xbgr.mr_n81091392)
print v(xbgr.mr_n81091504)
print v(xbgr.mr_n81091824)
print v(xbgr.mr_n81091936)
print v(xbgr.mr_n81092256)
print v(xbgr.mr_n81092368)
print v(xbgr.mr_n81092688)
print v(xbgr.mr_n81092800)
print v(xbgr.mr_n81093120)
print v(xbgr.mr_n81093232)
print v(xbgr.mr_n81093552)
print v(xbgr.mr_n81093664)
print v(xbgr.mr_n81093984)
print v(xbgr.mr_n81094096)
print v(xbgr.mr_n81094416)
print v(xbgr.mr_n81094528)
print v(xbgr.mr_n81094848)
print v(xbgr.mr_n81094960)
print v(xbgr.mr_n81095280)
print v(xbgr.mr_n81095392)
print v(xbgr.mr_n81095712)
print v(xbgr.mr_n81095824)
print v(xbgr.mr_n81096144)
print v(xbgr.mr_n81096256)
print v(xbgr.mr_n81096576)
print v(xbgr.mr_n81096688)
print v(xbgr.mr_n81097008)
print v(xbgr.mr_n81097120)
print v(xbgr.mr_n81097440)
print v(xbgr.mr_n81097552)
print v(xbgr.mr_n81097872)
print v(xbgr.mr_n81097984)
print v(xbgr.mr_n81098304)
print v(xbgr.mr_n81098416)
print v(xbgr.mr_n81098736)
print v(xbgr.mr_n81098848)
print v(xbgr.mr_n81099168)
print v(xbgr.mr_n81099280)
print v(xbgr.mr_n81099600)
print v(xbgr.mr_n81099712)
print v(xbgr.mr_n81100032)
print v(xbgr.mr_n81100144)
print v(xbgr.mr_n81100464)
print v(xbgr.mr_n81100576)
print v(xbgr.mr_n81100896)
print v(xbgr.mr_n81101008)
print v(xbgr.mr_n81101328)
print v(xbgr.mr_n81101440)
print v(xbgr.mr_n81101760)
print v(xbgr.mr_n81101872)
print v(xbgr.mr_n81102192)
print v(xbgr.mr_n81102304)
print v(xbgr.mr_n81102624)
print v(xbgr.mr_n81102736)
print v(xbgr.mr_n81103056)
print v(xbgr.mr_n81103168)
print v(xbgr.mr_n81103488)
print v(xbgr.mr_n81103600)
print v(xbgr.mr_n81103920)
print v(xbgr.mr_n81104032)
print v(xbgr.mr_n81104352)
print v(xbgr.mr_n81104464)
print v(xbgr.mr_n81104784)
print v(xbgr.mr_n81104896)
print v(xbgr.mr_n81105216)
print v(xbgr.mr_n81105328)
print v(xbgr.mr_n81105648)
print v(xbgr.mr_n81105760)
print v(xbgr.mr_n81106080)
print v(xbgr.mr_n81106192)
print v(xbgr.mr_n81106512)
print v(xbgr.mr_n81106624)
print v(xbgr.mr_n81106944)
print v(xbgr.mr_n81107056)
print v(xbgr.mr_n81107376)
print v(xbgr.mr_n81107488)
print v(xbgr.mr_n81107808)
print v(xbgr.mr_n81107920)
print v(xbgr.mr_n81108240)
print v(xbgr.mr_n81108352)
print v(xbgr.mr_n81108672)
print v(xbgr.mr_n81108784)
print v(xbgr.mr_n81109104)
print v(xbgr.mr_n81109216)
print v(xbgr.mr_n81109536)
print v(xbgr.mr_n81109648)
print v(xbgr.mr_n81109968)
print v(xbgr.mr_n81110080)
print v(xbgr.mr_n81110400)
print v(xbgr.mr_n81110512)
print v(xbgr.mr_n81110832)
print v(xbgr.mr_n81110944)
print v(xbgr.mr_n81111264)
print v(xbgr.mr_n81111376)
print v(xbgr.mr_n81111696)
print v(xbgr.mr_n81111808)
print v(xbgr.mr_n81112128)
print v(xbgr.mr_n81112240)
print v(xbgr.mr_n81112560)
print v(xbgr.mr_n81112672)
print v(xbgr.mr_n81112992)
print v(xbgr.mr_n81113104)
print v(xbgr.mr_n81113424)
print v(xbgr.mr_n81113536)
print v(xbgr.mr_n81113856)
print v(xbgr.mr_n81113968)
print v(xbgr.mr_n81114288)
print v(xbgr.mr_n81114400)
print v(xbgr.mr_n81114720)
print v(xbgr.mr_n81114832)
print v(xbgr.mr_n81115152)
print v(xbgr.mr_n81115264)
print v(xbgr.mr_n81115584)
print v(xbgr.mr_n81115696)
print v(xbgr.mr_n81116016)
print v(xbgr.mr_n81116128)
print v(xbgr.mr_n81116448)
print v(xbgr.mr_n81116560)
print v(xbgr.mr_n81116768)
print v(xbgr.mr_n81116880)
print v(xbgr.mr_n81117200)
print v(xbgr.mr_n81117312)
print v(xbgr.mr_n81117632)
print v(xbgr.mr_n81117744)
print v(xbgr.mr_n81118064)
print v(xbgr.mr_n81118176)
print v(xbgr.mr_n81118496)
print v(xbgr.mr_n81118608)
print v(xbgr.mr_n81118928)
print v(xbgr.mr_n81119040)
print v(xbgr.mr_n81119360)
print v(xbgr.mr_n81119472)
print v(xbgr.mr_n81119792)
print v(xbgr.mr_n81119904)
print v(xbgr.mr_n81120224)
print v(xbgr.mr_n81120336)
print v(xbgr.mr_n81120656)
print v(xbgr.mr_n81120768)
print v(xbgr.mr_n81121088)
print v(xbgr.mr_n81121200)
print v(xbgr.mr_n81121520)
print v(xbgr.mr_n81121632)
print v(xbgr.mr_n81121952)
print v(xbgr.mr_n81122064)
print v(xbgr.mr_n81122384)
print v(xbgr.mr_n81122496)
print v(xbgr.mr_n81122816)
print v(xbgr.mr_n81122928)
print v(xbgr.mr_n81123248)
print v(xbgr.mr_n81123360)
print v(xbgr.mr_n81123680)
print v(xbgr.mr_n81123792)
print v(xbgr.mr_n81124112)
print v(xbgr.mr_n81124224)
print v(xbgr.mr_n81124544)
print v(xbgr.mr_n81124656)
print v(xbgr.mr_n81124976)
print v(xbgr.mr_n81125088)
print v(xbgr.mr_n81125408)
print v(xbgr.mr_n81125520)
print v(xbgr.mr_n81125840)
print v(xbgr.mr_n81125952)
print v(xbgr.mr_n81126272)
print v(xbgr.mr_n81126384)
print v(xbgr.mr_n81126704)
print v(xbgr.mr_n81126816)
print v(xbgr.mr_n81127136)
print v(xbgr.mr_n81127248)
print v(xbgr.mr_n81127568)
print v(xbgr.mr_n81127680)
print v(xbgr.mr_n81128000)
print v(xbgr.mr_n81128112)
print v(xbgr.mr_n81128432)
print v(xbgr.mr_n81128544)
print v(xbgr.mr_n81128864)
print v(xbgr.mr_n81128976)
print v(xbgr.mr_n81129296)
print v(xbgr.mr_n81129408)
print v(xbgr.mr_n81129728)
print v(xbgr.mr_n81129840)
print v(xbgr.mr_n81130160)
print v(xbgr.mr_n81130272)
print v(xbgr.mr_n81130592)
print v(xbgr.mr_n81130704)
print v(xbgr.mr_n81131024)
print v(xbgr.mr_n81131136)
print v(xbgr.mr_n81131456)
print v(xbgr.mr_n81131568)
print v(xbgr.mr_n81131888)
print v(xbgr.mr_n81132000)
print v(xbgr.mr_n81132320)
print v(xbgr.mr_n81132432)
print v(xbgr.mr_n81132752)
print v(xbgr.mr_n81132864)
print v(xbgr.mr_n81133184)
print v(xbgr.mr_n81133296)
print v(xbgr.mr_n81133616)
print v(xbgr.mr_n81133728)
print v(xbgr.mr_n81134048)
print v(xbgr.mr_n81134160)
print v(xbgr.mr_n81134480)
print v(xbgr.mr_n81134592)
print v(xbgr.mr_n81134912)
print v(xbgr.mr_n81135024)
print v(xbgr.mr_n81135344)
print v(xbgr.mr_n81135456)
print v(xbgr.mr_n81135776)
print v(xbgr.mr_n81135888)
print v(xbgr.mr_n81136208)
print v(xbgr.mr_n81136320)
print v(xbgr.mr_n81136640)
print v(xbgr.mr_n81136752)
print v(xbgr.mr_n81137072)
print v(xbgr.mr_n81137184)
print v(xbgr.mr_n81137504)
print v(xbgr.mr_n81137616)
print v(xbgr.mr_n81137936)
print v(xbgr.mr_n81138048)
print v(xbgr.mr_n81138368)
print v(xbgr.mr_n81138480)
print v(xbgr.mr_n81138800)
print v(xbgr.mr_n81138912)
print v(xbgr.mr_n81139232)
print v(xbgr.mr_n81139344)
print v(xbgr.mr_n81139664)
print v(xbgr.mr_n81139776)
print v(xbgr.mr_n81140096)
print v(xbgr.mr_n81140208)
print v(xbgr.mr_n81140528)
print v(xbgr.mr_n81140640)
print v(xbgr.mr_n81140960)
print v(xbgr.mr_n81141072)
print v(xbgr.mr_n81141392)
print v(xbgr.mr_n81141504)
print v(xbgr.mr_n81141824)
print v(xbgr.mr_n81141936)
print v(xbgr.mr_n81142256)
print v(xbgr.mr_n81142368)
print v(xbgr.mr_n81142688)
print v(xbgr.mr_n81142800)
print v(xbgr.mr_n81143120)
print v(xbgr.mr_n81143232)
print v(xbgr.mr_n81143552)
print v(xbgr.mr_n81143664)
print v(xbgr.mr_n81143984)
print v(xbgr.mr_n81144096)
print v(xbgr.mr_n81144416)
print v(xbgr.mr_n81144528)
print v(xbgr.mr_n81144848)
print v(xbgr.mr_n81144960)
print v(xbgr.mr_n81145280)
print v(xbgr.mr_n81145392)
print v(xbgr.mr_n81145712)
print v(xbgr.mr_n81145824)
print v(xbgr.mr_n81146144)
print v(xbgr.mr_n81146256)
print v(xbgr.mr_n81146576)
print v(xbgr.mr_n81146688)
print v(xbgr.mr_n81147008)
print v(xbgr.mr_n81147120)
print v(xbgr.mr_n81147440)
print v(xbgr.mr_n81147552)
print v(xbgr.mr_n81147872)
print v(xbgr.mr_n81147984)
print v(xbgr.mr_n81148304)
print v(xbgr.mr_n81148416)
print v(xbgr.mr_n81148736)
print v(xbgr.mr_n81148848)
print v(xbgr.mr_n81149168)
print v(xbgr.mr_n81149280)
print v(xbgr.mr_n81149600)
print v(xbgr.mr_n81149712)
print v(xbgr.mr_n81150032)
print v(xbgr.mr_n81150144)
print v(xbgr.mr_n81150464)
print v(xbgr.mr_n81150576)
print v(xbgr.mr_n81150896)
print v(xbgr.mr_n81151008)
print v(xbgr.mr_n81151328)
print v(xbgr.mr_n81151440)
print v(xbgr.mr_n81151760)
print v(xbgr.mr_n81151872)
print v(xbgr.mr_n81152192)
print v(xbgr.mr_n81152304)
print v(xbgr.mr_n81152624)
print v(xbgr.mr_n81152736)
print v(xbgr.mr_n81153056)
print v(xbgr.mr_n81153168)
print v(xbgr.mr_n81153488)
print v(xbgr.mr_n81153600)
print v(xbgr.mr_n81153920)
print v(xbgr.mr_n81154032)
print v(xbgr.mr_n81154352)
print v(xbgr.mr_n81154464)
print v(xbgr.mr_n81154784)
print v(xbgr.mr_n81154896)
print v(xbgr.mr_n81155216)
print v(xbgr.mr_n81155328)
print v(xbgr.mr_n81155648)
print v(xbgr.mr_n81155760)
print v(xbgr.mr_n81156080)
print v(xbgr.mr_n81156192)
print v(xbgr.mr_n81156512)
print v(xbgr.mr_n81156624)
print v(xbgr.mr_n81156944)
print v(xbgr.mr_n81157056)
print v(xbgr.mr_n81157376)
print v(xbgr.mr_n81157488)
print v(xbgr.mr_n81157808)
print v(xbgr.mr_n81157920)
print v(xbgr.mr_n81158240)
print v(xbgr.mr_n81158352)
print v(xbgr.mr_n81158672)
print v(xbgr.mr_n81158784)
print v(xbgr.mr_n81159104)
print v(xbgr.mr_n81159216)
print v(xbgr.mr_n81159536)
print v(xbgr.mr_n81159648)
print v(xbgr.mr_n81159968)
print v(xbgr.mr_n81160080)
print v(xbgr.mr_n81160400)
print v(xbgr.mr_n81160512)
print v(xbgr.mr_n81160832)
print v(xbgr.mr_n81160944)
print v(xbgr.mr_n81161264)
print v(xbgr.mr_n81161376)
print v(xbgr.mr_n81161696)
print v(xbgr.mr_n81161808)
print v(xbgr.mr_n81162128)
print v(xbgr.mr_n81162240)
print v(xbgr.mr_n81162560)
print v(xbgr.mr_n81162672)
print v(xbgr.mr_n81162992)
print v(xbgr.mr_n81163104)
print v(xbgr.mr_n81163424)
print v(xbgr.mr_n81163536)
print v(xbgr.mr_n81163856)
print v(xbgr.mr_n81163968)
print v(xbgr.mr_n81164288)
print v(xbgr.mr_n81164400)
print v(xbgr.mr_n81164720)
print v(xbgr.mr_n81164832)
print v(xbgr.mr_n81165152)
print v(xbgr.mr_n81165264)
print v(xbgr.mr_n81165584)
print v(xbgr.mr_n81165696)
print v(xbgr.mr_n81166016)
print v(xbgr.mr_n81166128)
print v(xbgr.mr_n81166448)
print v(xbgr.mr_n81166560)
print v(xbgr.mr_n81166880)
print v(xbgr.mr_n81166992)
print v(xbgr.mr_n81167312)
print v(xbgr.mr_n81167424)
print v(xbgr.mr_n81167744)
print v(xbgr.mr_n81167856)
print v(xbgr.mr_n81168176)
print v(xbgr.mr_n81168288)
print v(xbgr.mr_n81168608)
print v(xbgr.mr_n81168720)
print v(xbgr.mr_n81169040)
print v(xbgr.mr_n81169152)
print v(xbgr.mr_n81169472)
print v(xbgr.mr_n81169584)
print v(xbgr.mr_n81169904)
print v(xbgr.mr_n81170016)
print v(xbgr.mr_n81170336)
print v(xbgr.mr_n81170448)
print v(xbgr.mr_n81170768)
print v(xbgr.mr_n81170880)
print v(xbgr.mr_n81171200)
print v(xbgr.mr_n81171312)
print v(xbgr.mr_n81171632)
print v(xbgr.mr_n81171744)
print v(xbgr.mr_n81172064)
print v(xbgr.mr_n81172176)
print v(xbgr.mr_n81172496)
print v(xbgr.mr_n81172608)
print v(xbgr.mr_n81172928)
print v(xbgr.mr_n81173040)
print v(xbgr.mr_n81173360)
print v(xbgr.mr_n81173472)
print v(xbgr.mr_n81173792)
print v(xbgr.mr_n81173904)
print v(xbgr.mr_n81174224)
print v(xbgr.mr_n81174336)
print v(xbgr.mr_n81174656)
print v(xbgr.mr_n81174768)
print v(xbgr.mr_n81175088)
print v(xbgr.mr_n81175200)
print v(xbgr.mr_n81175520)
print v(xbgr.mr_n81175632)
print v(xbgr.mr_n81175952)
print v(xbgr.mr_n81176064)
print v(xbgr.mr_n81176384)
print v(xbgr.mr_n81176496)
print v(xbgr.mr_n81176816)
print v(xbgr.mr_n81176928)
print v(xbgr.mr_n81177248)
print v(xbgr.mr_n81177360)
print v(xbgr.mr_n81177680)
print v(xbgr.mr_n81177792)
print v(xbgr.mr_n81178320)
print v(xbgr.mr_n81178432)
print v(xbgr.mr_n81178752)
print v(xbgr.mr_n81178864)
print v(xbgr.mr_n81179184)
print v(xbgr.mr_n81179296)
print v(xbgr.mr_n81179616)
print v(xbgr.mr_n81179728)
print v(xbgr.mr_n81180048)
print v(xbgr.mr_n81180160)
print v(xbgr.mr_n81180480)
print v(xbgr.mr_n81180592)
print v(xbgr.mr_n81180912)
print v(xbgr.mr_n81181024)
print v(xbgr.mr_n81181344)
print v(xbgr.mr_n81181456)
print v(xbgr.mr_n81181776)
print v(xbgr.mr_n81181888)
print v(xbgr.mr_n81182208)
print v(xbgr.mr_n81182320)
print v(xbgr.mr_n81182640)
print v(xbgr.mr_n81182752)
print v(xbgr.mr_n81183072)
print v(xbgr.mr_n81183184)
print v(xbgr.mr_n81183504)
print v(xbgr.mr_n81183616)
print v(xbgr.mr_n81183936)
print v(xbgr.mr_n81184048)
print v(xbgr.mr_n81184368)
print v(xbgr.mr_n81184480)
print v(xbgr.mr_n81184800)
print v(xbgr.mr_n81184912)
print v(xbgr.mr_n81185232)
print v(xbgr.mr_n81185344)
print v(xbgr.mr_n81185664)
print v(xbgr.mr_n81185776)
print v(xbgr.mr_n81186096)
print v(xbgr.mr_n81186208)
print v(xbgr.mr_n81186528)
print v(xbgr.mr_n81186640)
print v(xbgr.mr_n81186960)
print v(xbgr.mr_n81187072)
print v(xbgr.mr_n81187392)
print v(xbgr.mr_n81187504)
print v(xbgr.mr_n81187824)
print v(xbgr.mr_n81187936)
print v(xbgr.mr_n81188256)
print v(xbgr.mr_n81188368)
print v(xbgr.mr_n81188688)
print v(xbgr.mr_n81188800)
print v(xbgr.mr_n81189120)
print v(xbgr.mr_n81189232)
print v(xbgr.mr_n81189552)
print v(xbgr.mr_n81189664)
print v(xbgr.mr_n81189984)
print v(xbgr.mr_n81190096)
print v(xbgr.mr_n81190416)
print v(xbgr.mr_n81190528)
print v(xbgr.mr_n81190848)
print v(xbgr.mr_n81190960)
print v(xbgr.mr_n81191280)
print v(xbgr.mr_n81191392)
print v(xbgr.mr_n81191712)
print v(xbgr.mr_n81191824)
print v(xbgr.mr_n81192144)
print v(xbgr.mr_n81192256)
print v(xbgr.mr_n81192576)
print v(xbgr.mr_n81192688)
print v(xbgr.mr_n81193008)
print v(xbgr.mr_n81193120)
print v(xbgr.mr_n81193440)
print v(xbgr.mr_n81193552)
print v(xbgr.mr_n81193872)
print v(xbgr.mr_n81193984)
print v(xbgr.mr_n81194304)
print v(xbgr.mr_n81194416)
print v(xbgr.mr_n81194736)
print v(xbgr.mr_n81194848)
print v(xbgr.mr_n81195168)
print v(xbgr.mr_n81195280)
print v(xbgr.mr_n81195600)
print v(xbgr.mr_n81195712)
print v(xbgr.mr_n81196032)
print v(xbgr.mr_n81196144)
print v(xbgr.mr_n81196464)
print v(xbgr.mr_n81196576)
print v(xbgr.mr_n81196896)
print v(xbgr.mr_n81197008)
print v(xbgr.mr_n81197328)
print v(xbgr.mr_n81197440)
print v(xbgr.mr_n81197760)
print v(xbgr.mr_n81197872)
print v(xbgr.mr_n81198192)
print v(xbgr.mr_n81198304)
print v(xbgr.mr_n81198624)
print v(xbgr.mr_n81198736)
print v(xbgr.mr_n81199056)
print v(xbgr.mr_n81199168)
print v(xbgr.mr_n81199488)
print v(xbgr.mr_n81199600)
print v(xbgr.mr_n81199920)
print v(xbgr.mr_n81200032)
print v(xbgr.mr_n81200352)
print v(xbgr.mr_n81200464)
print v(xbgr.mr_n81200784)
print v(xbgr.mr_n81200896)
print v(xbgr.mr_n81201216)
print v(xbgr.mr_n81201328)
print v(xbgr.mr_n81201648)
print v(xbgr.mr_n81201760)
print v(xbgr.mr_n81202080)
print v(xbgr.mr_n81202192)
print v(xbgr.mr_n81202512)
print v(xbgr.mr_n81202624)
print v(xbgr.mr_n81202944)
print v(xbgr.mr_n81203056)
print v(xbgr.mr_n81203376)
print v(xbgr.mr_n81203488)
print v(xbgr.mr_n81203808)
print v(xbgr.mr_n81203920)
print v(xbgr.mr_n81204240)
print v(xbgr.mr_n81204352)
print v(xbgr.mr_n81204672)
print v(xbgr.mr_n81204784)
print v(xbgr.mr_n81205104)
print v(xbgr.mr_n81205216)
print v(xbgr.mr_n81205536)
print v(xbgr.mr_n81205648)
print v(xbgr.mr_n81205968)
print v(xbgr.mr_n81206080)
print v(xbgr.mr_n81206400)
print v(xbgr.mr_n81206512)
print v(xbgr.mr_n81206832)
print v(xbgr.mr_n81206944)
print v(xbgr.mr_n81207264)
print v(xbgr.mr_n81207376)
print v(xbgr.mr_n81207696)
print v(xbgr.mr_n81207808)
print v(xbgr.mr_n81208128)
print v(xbgr.mr_n81208240)
print v(xbgr.mr_n81208560)
print v(xbgr.mr_n81208672)
print v(xbgr.mr_n81208992)
print v(xbgr.mr_n81209104)
print v(xbgr.mr_n81209424)
print v(xbgr.mr_n81209536)
print v(xbgr.mr_n81209856)
print v(xbgr.mr_n81209968)
print v(xbgr.mr_n81210288)
print v(xbgr.mr_n81210400)
print v(xbgr.mr_n81210720)
print v(xbgr.mr_n81210832)
print v(xbgr.mr_n81211152)
print v(xbgr.mr_n81211264)
print v(xbgr.mr_n81211584)
print v(xbgr.mr_n81211696)
print v(xbgr.mr_n81212016)
print v(xbgr.mr_n81212128)
print v(xbgr.mr_n81212448)
print v(xbgr.mr_n81212560)
print v(xbgr.mr_n81212880)
print v(xbgr.mr_n81212992)
print v(xbgr.mr_n81213312)
print v(xbgr.mr_n81213424)
print v(xbgr.mr_n81213744)
print v(xbgr.mr_n81213856)
print v(xbgr.mr_n81214176)
print v(xbgr.mr_n81214288)
print v(xbgr.mr_n81214608)
print v(xbgr.mr_n81214720)
print v(xbgr.mr_n81215040)
print v(xbgr.mr_n81215152)
print v(xbgr.mr_n81215472)
print v(xbgr.mr_n81215584)
print v(xbgr.mr_n81215904)
print v(xbgr.mr_n81216016)
print v(xbgr.mr_n81216336)
print v(xbgr.mr_n81216448)
print v(xbgr.mr_n81216768)
print v(xbgr.mr_n81216880)
print v(xbgr.mr_n81217200)
print v(xbgr.mr_n81217312)
print v(xbgr.mr_n81217632)
print v(xbgr.mr_n81217744)
print v(xbgr.mr_n81480224)
print v(xbgr.mr_n81480464)
print v(xbgr.mr_n81480576)
print v(xbgr.mr_n81480896)
print v(xbgr.mr_n81481008)
print v(xbgr.mr_n81481328)
print v(xbgr.mr_n81481440)
print v(xbgr.mr_n81481760)
print v(xbgr.mr_n81481872)
print v(xbgr.mr_n81482192)
print v(xbgr.mr_n81482304)
print v(xbgr.mr_n81482624)
print v(xbgr.mr_n81482736)
print v(xbgr.mr_n81483056)
print v(xbgr.mr_n81483168)
print v(xbgr.mr_n81483488)
print v(xbgr.mr_n81483600)
print v(xbgr.mr_n81483920)
print v(xbgr.mr_n81484032)
print v(xbgr.mr_n81484352)
print v(xbgr.mr_n81484464)
print v(xbgr.mr_n81484784)
print v(xbgr.mr_n81484896)
print v(xbgr.mr_n81485216)
print v(xbgr.mr_n81485328)
print v(xbgr.mr_n81485648)
print v(xbgr.mr_n81485760)
print v(xbgr.mr_n81486080)
print v(xbgr.mr_n81486192)
print v(xbgr.mr_n81486512)
print v(xbgr.mr_n81486624)
print v(xbgr.mr_n81486944)
print v(xbgr.mr_n81487056)
print v(xbgr.mr_n81487376)
print v(xbgr.mr_n81487488)
print v(xbgr.mr_n81487808)
print v(xbgr.mr_n81487920)
print v(xbgr.mr_n81488240)
print v(xbgr.mr_n81488352)
print v(xbgr.mr_n81488672)
print v(xbgr.mr_n81488784)
print v(xbgr.mr_n81489104)
print v(xbgr.mr_n81489216)
print v(xbgr.mr_n81489536)
print v(xbgr.mr_n81489648)
print v(xbgr.mr_n81489968)
print v(xbgr.mr_n81490080)
print v(xbgr.mr_n81490400)
print v(xbgr.mr_n81490512)
print v(xbgr.mr_n81490832)
print v(xbgr.mr_n81490944)
print v(xbgr.mr_n81491264)
print v(xbgr.mr_n81491376)
print v(xbgr.mr_n81491696)
print v(xbgr.mr_n81491808)
print v(xbgr.mr_n81492128)
print v(xbgr.mr_n81492240)
print v(xbgr.mr_n81492560)
print v(xbgr.mr_n81492672)
print v(xbgr.mr_n81492992)
print v(xbgr.mr_n81493104)
print v(xbgr.mr_n81493424)
print v(xbgr.mr_n81493536)
print v(xbgr.mr_n81493856)
print v(xbgr.mr_n81493968)
print v(xbgr.mr_n81494288)
print v(xbgr.mr_n81494400)
print v(xbgr.mr_n81494720)
print v(xbgr.mr_n81494832)
print v(xbgr.mr_n81495152)
print v(xbgr.mr_n81495264)
print v(xbgr.mr_n81495584)
print v(xbgr.mr_n81495696)
print v(xbgr.mr_n81496016)
print v(xbgr.mr_n81496128)
print v(xbgr.mr_n81496448)
print v(xbgr.mr_n81496560)
print v(xbgr.mr_n81496880)
print v(xbgr.mr_n81496992)
print v(xbgr.mr_n81497312)
print v(xbgr.mr_n81497424)
print v(xbgr.mr_n81497744)
print v(xbgr.mr_n81497856)
print v(xbgr.mr_n81498176)
print v(xbgr.mr_n81498288)
print v(xbgr.mr_n81498608)
print v(xbgr.mr_n81498720)
print v(xbgr.mr_n81499040)
print v(xbgr.mr_n81499152)
print v(xbgr.mr_n81499472)
print v(xbgr.mr_n81499584)
print v(xbgr.mr_n81499904)
print v(xbgr.mr_n81500016)
print v(xbgr.mr_n81500336)
print v(xbgr.mr_n81500448)
print v(xbgr.mr_n81500768)
print v(xbgr.mr_n81500880)
print v(xbgr.mr_n81501200)
print v(xbgr.mr_n81501312)
print v(xbgr.mr_n81501632)
print v(xbgr.mr_n81501744)
print v(xbgr.mr_n81502064)
print v(xbgr.mr_n81502176)
print v(xbgr.mr_n81502496)
print v(xbgr.mr_n81502608)
print v(xbgr.mr_n81502928)
print v(xbgr.mr_n81503040)
print v(xbgr.mr_n81503360)
print v(xbgr.mr_n81503472)
print v(xbgr.mr_n81503792)
print v(xbgr.mr_n81503904)
print v(xbgr.mr_n81504224)
print v(xbgr.mr_n81504336)
print v(xbgr.mr_n81504656)
print v(xbgr.mr_n81504768)
print v(xbgr.mr_n81505088)
print v(xbgr.mr_n81505200)
print v(xbgr.mr_n81505520)
print v(xbgr.mr_n81505632)
print v(xbgr.mr_n81505952)
print v(xbgr.mr_n81506064)
print v(xbgr.mr_n81506384)
print v(xbgr.mr_n81506496)
print v(xbgr.mr_n81506816)
print v(xbgr.mr_n81506928)
print v(xbgr.mr_n81507248)
print v(xbgr.mr_n81507360)
print v(xbgr.mr_n81507680)
print v(xbgr.mr_n81507792)
print v(xbgr.mr_n81508112)
print v(xbgr.mr_n81508224)
print v(xbgr.mr_n81508544)
print v(xbgr.mr_n81508656)
print v(xbgr.mr_n81508976)
print v(xbgr.mr_n81509088)
print v(xbgr.mr_n81509408)
print v(xbgr.mr_n81509520)
print v(xbgr.mr_n81509840)
print v(xbgr.mr_n81509952)
print v(xbgr.mr_n81510272)
print v(xbgr.mr_n81510384)
print v(xbgr.mr_n81510704)
print v(xbgr.mr_n81510816)
print v(xbgr.mr_n81511136)
print v(xbgr.mr_n81511248)
print v(xbgr.mr_n81511568)
print v(xbgr.mr_n81511680)
print v(xbgr.mr_n81512000)
print v(xbgr.mr_n81512112)
print v(xbgr.mr_n81512432)
print v(xbgr.mr_n81512544)
print v(xbgr.mr_n81512864)
print v(xbgr.mr_n81512976)
print v(xbgr.mr_n81513296)
print v(xbgr.mr_n81513408)
print v(xbgr.mr_n81513728)
print v(xbgr.mr_n81513840)
print v(xbgr.mr_n81514160)
print v(xbgr.mr_n81514272)
print v(xbgr.mr_n81514592)
print v(xbgr.mr_n81514704)
print v(xbgr.mr_n81515024)
print v(xbgr.mr_n81515136)
print v(xbgr.mr_n81515456)
print v(xbgr.mr_n81515568)
print v(xbgr.mr_n81515888)
print v(xbgr.mr_n81516000)
print v(xbgr.mr_n81516320)
print v(xbgr.mr_n81516432)
print v(xbgr.mr_n81516752)
print v(xbgr.mr_n81516864)
print v(xbgr.mr_n81517184)
print v(xbgr.mr_n81517296)
print v(xbgr.mr_n81517616)
print v(xbgr.mr_n81517728)
print v(xbgr.mr_n81518048)
print v(xbgr.mr_n81518160)
print v(xbgr.mr_n81518480)
print v(xbgr.mr_n81518592)
print v(xbgr.mr_n81518912)
print v(xbgr.mr_n81519024)
print v(xbgr.mr_n81519344)
print v(xbgr.mr_n81519456)
print v(xbgr.mr_n81519776)
print v(xbgr.mr_n81519888)
print v(xbgr.mr_n81520208)
print v(xbgr.mr_n81520320)
print v(xbgr.mr_n81520640)
print v(xbgr.mr_n81520752)
print v(xbgr.mr_n81521072)
print v(xbgr.mr_n81521184)
print v(xbgr.mr_n81521504)
print v(xbgr.mr_n81521616)
print v(xbgr.mr_n81521936)
print v(xbgr.mr_n81522048)
print v(xbgr.mr_n81522368)
print v(xbgr.mr_n81522480)
print v(xbgr.mr_n81522800)
print v(xbgr.mr_n81522912)
print v(xbgr.mr_n81523232)
print v(xbgr.mr_n81523344)
print v(xbgr.mr_n81523664)
print v(xbgr.mr_n81523776)
print v(xbgr.mr_n81524096)
print v(xbgr.mr_n81524208)
print v(xbgr.mr_n81524528)
print v(xbgr.mr_n81524640)
print v(xbgr.mr_n81524960)
print v(xbgr.mr_n81525072)
print v(xbgr.mr_n81525392)
print v(xbgr.mr_n81525504)
print v(xbgr.mr_n81525824)
print v(xbgr.mr_n81525936)
print v(xbgr.mr_n81526256)
print v(xbgr.mr_n81526368)
print v(xbgr.mr_n81526688)
print v(xbgr.mr_n81526800)
print v(xbgr.mr_n81527120)
print v(xbgr.mr_n81527232)
print v(xbgr.mr_n81527552)
print v(xbgr.mr_n81527664)
print v(xbgr.mr_n81527984)
print v(xbgr.mr_n81528096)
print v(xbgr.mr_n81528416)
print v(xbgr.mr_n81528528)
print v(xbgr.mr_n81528848)
print v(xbgr.mr_n81528960)
print v(xbgr.mr_n81529280)
print v(xbgr.mr_n81529392)
print v(xbgr.mr_n81529712)
print v(xbgr.mr_n81529824)
print v(xbgr.mr_n81530144)
print v(xbgr.mr_n81530256)
print v(xbgr.mr_n81530576)
print v(xbgr.mr_n81530688)
print v(xbgr.mr_n81531008)
print v(xbgr.mr_n81531120)
print v(xbgr.mr_n81531440)
print v(xbgr.mr_n81531552)
print v(xbgr.mr_n81531872)
print v(xbgr.mr_n81531984)
print v(xbgr.mr_n81532304)
print v(xbgr.mr_n81532416)
print v(xbgr.mr_n81532736)
print v(xbgr.mr_n81532848)
print v(xbgr.mr_n81533168)
print v(xbgr.mr_n81533280)
print v(xbgr.mr_n81533600)
print v(xbgr.mr_n81533712)
print v(xbgr.mr_n81534032)
print v(xbgr.mr_n81534144)
print v(xbgr.mr_n81534464)
print v(xbgr.mr_n81534576)
print v(xbgr.mr_n81534896)
print v(xbgr.mr_n81535008)
print v(xbgr.mr_n81535328)
print v(xbgr.mr_n81535440)
print v(xbgr.mr_n81535760)
print v(xbgr.mr_n81535872)
print v(xbgr.mr_n81536192)
print v(xbgr.mr_n81536304)
print v(xbgr.mr_n81536624)
print v(xbgr.mr_n81536736)
print v(xbgr.mr_n81537056)
print v(xbgr.mr_n81537168)
print v(xbgr.mr_n81537488)
print v(xbgr.mr_n81537600)
print v(xbgr.mr_n81537920)
print v(xbgr.mr_n81538032)
print v(xbgr.mr_n81538352)
print v(xbgr.mr_n81538464)
print v(xbgr.mr_n81538784)
print v(xbgr.mr_n81538896)
print v(xbgr.mr_n81539216)
print v(xbgr.mr_n81539328)
print v(xbgr.mr_n81539648)
print v(xbgr.mr_n81539760)
print v(xbgr.mr_n81540080)
print v(xbgr.mr_n81540192)
print v(xbgr.mr_n81540512)
print v(xbgr.mr_n81540624)
print v(xbgr.mr_n81540944)
print v(xbgr.mr_n81541056)
print v(xbgr.mr_n81541376)
print v(xbgr.mr_n81541488)
print v(xbgr.mr_n81541808)
print v(xbgr.mr_n81541920)
print v(xbgr.mr_n81542240)
print v(xbgr.mr_n81542352)
print v(xbgr.mr_n81542672)
print v(xbgr.mr_n81542784)
print v(xbgr.mr_n81543104)
print v(xbgr.mr_n81543216)
print v(xbgr.mr_n81543536)
print v(xbgr.mr_n81543648)
print v(xbgr.mr_n81543968)
print v(xbgr.mr_n81544080)
print v(xbgr.mr_n81544400)
print v(xbgr.mr_n81544512)
print v(xbgr.mr_n81544832)
print v(xbgr.mr_n81544944)
print v(xbgr.mr_n81545264)
print v(xbgr.mr_n81545376)
print v(xbgr.mr_n81545696)
print v(xbgr.mr_n81545808)
print v(xbgr.mr_n81546128)
print v(xbgr.mr_n81546240)
print v(xbgr.mr_n81546560)
print v(xbgr.mr_n81546672)
print v(xbgr.mr_n81546992)
print v(xbgr.mr_n81547104)
print v(xbgr.mr_n81547424)
print v(xbgr.mr_n81547536)
print v(xbgr.mr_n81547856)
print v(xbgr.mr_n81547968)
print v(xbgr.mr_n81548288)
print v(xbgr.mr_n81548400)
print v(xbgr.mr_n81548720)
print v(xbgr.mr_n81548832)
print v(xbgr.mr_n81549152)
print v(xbgr.mr_n81549264)
print v(xbgr.mr_n81549584)
print v(xbgr.mr_n81549696)
print v(xbgr.mr_n81550016)
print v(xbgr.mr_n81550128)
print v(xbgr.mr_n81550448)
print v(xbgr.mr_n81550560)
print v(xbgr.mr_n81550880)
print v(xbgr.mr_n81550992)
print v(xbgr.mr_n81551312)
print v(xbgr.mr_n81551424)
print v(xbgr.mr_n81551744)
print v(xbgr.mr_n81551856)
print v(xbgr.mr_n81552176)
print v(xbgr.mr_n81552288)
print v(xbgr.mr_n81552608)
print v(xbgr.mr_n81552720)
print v(xbgr.mr_n81553040)
print v(xbgr.mr_n81553152)
print v(xbgr.mr_n81553472)
print v(xbgr.mr_n81553584)
print v(xbgr.mr_n81553904)
print v(xbgr.mr_n81554016)
print v(xbgr.mr_n81554336)
print v(xbgr.mr_n81554448)
print v(xbgr.mr_n81554768)
print v(xbgr.mr_n81554880)
print v(xbgr.mr_n81555200)
print v(xbgr.mr_n81555312)
print v(xbgr.mr_n81555632)
print v(xbgr.mr_n81555744)
print v(xbgr.mr_n81556064)
print v(xbgr.mr_n81556176)
print v(xbgr.mr_n81556496)
print v(xbgr.mr_n81556608)
print v(xbgr.mr_n81556928)
print v(xbgr.mr_n81557040)
print v(xbgr.mr_n81557360)
print v(xbgr.mr_n81557472)
print v(xbgr.mr_n81557792)
print v(xbgr.mr_n81557904)
print v(xbgr.mr_n81558224)
print v(xbgr.mr_n81558336)
print v(xbgr.mr_n81558656)
print v(xbgr.mr_n81558768)
print v(xbgr.mr_n81559088)
print v(xbgr.mr_n81559200)
print v(xbgr.mr_n81559520)
print v(xbgr.mr_n81559632)
print v(xbgr.mr_n81559952)
print v(xbgr.mr_n81560064)
print v(xbgr.mr_n81560384)
print v(xbgr.mr_n81560496)
print v(xbgr.mr_n81560816)
print v(xbgr.mr_n81560928)
print v(xbgr.mr_n81561248)
print v(xbgr.mr_n81561360)
print v(xbgr.mr_n81561680)
print v(xbgr.mr_n81561792)
print v(xbgr.mr_n81562112)
print v(xbgr.mr_n81562224)
print v(xbgr.mr_n81562544)
print v(xbgr.mr_n81562656)
print v(xbgr.mr_n81562976)
print v(xbgr.mr_n81563088)
print v(xbgr.mr_n81563408)
print v(xbgr.mr_n81563520)
print v(xbgr.mr_n81563840)
print v(xbgr.mr_n81563952)
print v(xbgr.mr_n81564272)
print v(xbgr.mr_n81564384)
print v(xbgr.mr_n81564704)
print v(xbgr.mr_n81564816)
print v(xbgr.mr_n81565136)
print v(xbgr.mr_n81565248)
print v(xbgr.mr_n81565568)
print v(xbgr.mr_n81565680)
print v(xbgr.mr_n81566000)
print v(xbgr.mr_n81566112)
print v(xbgr.mr_n81566432)
print v(xbgr.mr_n81566544)
print v(xbgr.mr_n81566864)
print v(xbgr.mr_n81566976)
print v(xbgr.mr_n81567296)
print v(xbgr.mr_n81567408)
print v(xbgr.mr_n81567728)
print v(xbgr.mr_n81567840)
print v(xbgr.mr_n81568160)
print v(xbgr.mr_n81568272)
print v(xbgr.mr_n81568592)
print v(xbgr.mr_n81568704)
print v(xbgr.mr_n81569024)
print v(xbgr.mr_n81569136)
print v(xbgr.mr_n81569456)
print v(xbgr.mr_n81569568)
print v(xbgr.mr_n81569888)
print v(xbgr.mr_n81570000)
print v(xbgr.mr_n81570320)
print v(xbgr.mr_n81570432)
print v(xbgr.mr_n81570752)
print v(xbgr.mr_n81570864)
print v(xbgr.mr_n81571184)
print v(xbgr.mr_n81571296)
print v(xbgr.mr_n81571616)
print v(xbgr.mr_n81571728)
print v(xbgr.mr_n81572048)
print v(xbgr.mr_n81572160)
print v(xbgr.mr_n81572480)
print v(xbgr.mr_n81572592)
print v(xbgr.mr_n81572912)
print v(xbgr.mr_n81573024)
print v(xbgr.mr_n81573344)
print v(xbgr.mr_n81573456)
print v(xbgr.mr_n81573776)
print v(xbgr.mr_n81573888)
print v(xbgr.mr_n81574208)
print v(xbgr.mr_n81574320)
print v(xbgr.mr_n81574640)
print v(xbgr.mr_n81574752)
print v(xbgr.mr_n81575072)
print v(xbgr.mr_n81575184)
print v(xbgr.mr_n81575504)
print v(xbgr.mr_n81575616)
print v(xbgr.mr_n81575936)
print v(xbgr.mr_n81576048)
print v(xbgr.mr_n81576368)
print v(xbgr.mr_n81576480)
print v(xbgr.mr_n81576800)
print v(xbgr.mr_n81576912)
print v(xbgr.mr_n81577232)
print v(xbgr.mr_n81577344)
print v(xbgr.mr_n81577664)
print v(xbgr.mr_n81577776)
print v(xbgr.mr_n81578096)
print v(xbgr.mr_n81578208)
print v(xbgr.mr_n81578528)
print v(xbgr.mr_n81578640)
print v(xbgr.mr_n81578960)
print v(xbgr.mr_n81579072)
print v(xbgr.mr_n81579392)
print v(xbgr.mr_n81579504)
print v(xbgr.mr_n81579824)
print v(xbgr.mr_n81579936)
print v(xbgr.mr_n81580256)
print v(xbgr.mr_n81580368)
print v(xbgr.mr_n81580688)
print v(xbgr.mr_n81580800)
print v(xbgr.mr_n81581120)
print v(xbgr.mr_n81581232)
print v(xbgr.mr_n81581552)
print v(xbgr.mr_n81581664)
print v(xbgr.mr_n81581984)
print v(xbgr.mr_n81582096)
print v(xbgr.mr_n81582416)
print v(xbgr.mr_n81582528)
print v(xbgr.mr_n81582848)
print v(xbgr.mr_n81582960)
print v(xbgr.mr_n81583280)
print v(xbgr.mr_n81583392)
print v(xbgr.mr_n81583712)
print v(xbgr.mr_n81583824)
print v(xbgr.mr_n81584144)
print v(xbgr.mr_n81584256)
print v(xbgr.mr_n81584576)
print v(xbgr.mr_n81584688)
print v(xbgr.mr_n81585008)
print v(xbgr.mr_n81585120)
print v(xbgr.mr_n81585440)
print v(xbgr.mr_n81585552)
print v(xbgr.mr_n81585872)
print v(xbgr.mr_n81585984)
print v(xbgr.mr_n81586304)
print v(xbgr.mr_n81586416)
print v(xbgr.mr_n81586736)
print v(xbgr.mr_n81586848)
print v(xbgr.mr_n81587168)
print v(xbgr.mr_n81587280)
print v(xbgr.mr_n81587600)
print v(xbgr.mr_n81587712)
print v(xbgr.mr_n81588032)
print v(xbgr.mr_n81588144)
print v(xbgr.mr_n81588464)
print v(xbgr.mr_n81588576)
print v(xbgr.mr_n81588896)
print v(xbgr.mr_n81589008)
print v(xbgr.mr_n81589328)
print v(xbgr.mr_n81589440)
print v(xbgr.mr_n81589760)
print v(xbgr.mr_n81589872)
print v(xbgr.mr_n81590192)
print v(xbgr.mr_n81590304)
print v(xbgr.mr_n81590624)
print v(xbgr.mr_n81590736)
print v(xbgr.mr_n81591056)
print v(xbgr.mr_n81591168)
print v(xbgr.mr_n81591488)
print v(xbgr.mr_n81591600)
print v(xbgr.mr_n81591920)
print v(xbgr.mr_n81592032)
print v(xbgr.mr_n81592352)
print v(xbgr.mr_n81592464)
print v(xbgr.mr_n81592784)
print v(xbgr.mr_n81592896)
print v(xbgr.mr_n81593216)
print v(xbgr.mr_n81593328)
print v(xbgr.mr_n81593648)
print v(xbgr.mr_n81593760)
print v(xbgr.mr_n81594080)
print v(xbgr.mr_n81594192)
print v(xbgr.mr_n81594512)
print v(xbgr.mr_n81594624)
print v(xbgr.mr_n81594944)
print v(xbgr.mr_n81595056)
print v(xbgr.mr_n81595376)
print v(xbgr.mr_n81595488)
print v(xbgr.mr_n81595808)
print v(xbgr.mr_n81595920)
print v(xbgr.mr_n81596240)
print v(xbgr.mr_n81596352)
print v(xbgr.mr_n81596672)
print v(xbgr.mr_n81596784)
print v(xbgr.mr_n81597104)
print v(xbgr.mr_n81597216)
print v(xbgr.mr_n81597536)
print v(xbgr.mr_n81597648)
print v(xbgr.mr_n81597968)
print v(xbgr.mr_n81598080)
print v(xbgr.mr_n81598400)
print v(xbgr.mr_n81598512)
print v(xbgr.mr_n81598832)
print v(xbgr.mr_n81598944)
print v(xbgr.mr_n81599264)
print v(xbgr.mr_n81599376)
print v(xbgr.mr_n81599696)
print v(xbgr.mr_n81599808)
print v(xbgr.mr_n81600128)
print v(xbgr.mr_n81600240)
print v(xbgr.mr_n81600560)
print v(xbgr.mr_n81600672)
print v(xbgr.mr_n81600992)
print v(xbgr.mr_n81601104)
print v(xbgr.mr_n81601424)
print v(xbgr.mr_n81601536)
print v(xbgr.mr_n81601856)
print v(xbgr.mr_n81601968)
print v(xbgr.mr_n81602288)
print v(xbgr.mr_n81602400)
print v(xbgr.mr_n81602720)
print v(xbgr.mr_n81602832)
print v(xbgr.mr_n81603152)
print v(xbgr.mr_n81603264)
print v(xbgr.mr_n81603584)
print v(xbgr.mr_n81603696)
print v(xbgr.mr_n81604016)
print v(xbgr.mr_n81604128)
print v(xbgr.mr_n81604448)
print v(xbgr.mr_n81604560)
print v(xbgr.mr_n81604880)
print v(xbgr.mr_n81604992)
print v(xbgr.mr_n81605312)
print v(xbgr.mr_n81605424)
print v(xbgr.mr_n81605744)
print v(xbgr.mr_n81605856)
print v(xbgr.mr_n81606176)
print v(xbgr.mr_n81606288)
print v(xbgr.mr_n81606608)
print v(xbgr.mr_n81606720)
print v(xbgr.mr_n81607040)
print v(xbgr.mr_n81607152)
print v(xbgr.mr_n81607472)
print v(xbgr.mr_n81607584)
print v(xbgr.mr_n81607904)
print v(xbgr.mr_n81608016)
print v(xbgr.mr_n81608336)
print v(xbgr.mr_n81608448)
print v(xbgr.mr_n81608768)
print v(xbgr.mr_n81608880)
print v(xbgr.mr_n81609200)
print v(xbgr.mr_n81609312)
print v(xbgr.mr_n81609632)
print v(xbgr.mr_n81609744)
print v(xbgr.mr_n81610064)
print v(xbgr.mr_n81610176)
print v(xbgr.mr_n81610496)
print v(xbgr.mr_n81610608)
print v(xbgr.mr_n81610928)
print v(xbgr.mr_n81611040)
print v(xbgr.mr_n81611360)
print v(xbgr.mr_n81611472)
print v(xbgr.mr_n81611792)
print v(xbgr.mr_n81611904)
print v(xbgr.mr_n81612224)
print v(xbgr.mr_n81612336)
print v(xbgr.mr_n81612656)
print v(xbgr.mr_n81612768)
print v(xbgr.mr_n81613088)
print v(xbgr.mr_n81613200)
print v(xbgr.mr_n81613520)
print v(xbgr.mr_n81613632)
print v(xbgr.mr_n81613952)
print v(xbgr.mr_n81614064)
print v(xbgr.mr_n81614384)
print v(xbgr.mr_n81614496)
print v(xbgr.mr_n81614816)
print v(xbgr.mr_n81614928)
print v(xbgr.mr_n81615248)
print v(xbgr.mr_n81615360)
print v(xbgr.mr_n81615680)
print v(xbgr.mr_n81615792)
print v(xbgr.mr_n81616112)
print v(xbgr.mr_n81616224)
print v(xbgr.mr_n81616544)
print v(xbgr.mr_n81616656)
print v(xbgr.mr_n81616976)
print v(xbgr.mr_n81617088)
print v(xbgr.mr_n81617408)
print v(xbgr.mr_n81617520)
print v(xbgr.mr_n81617840)
print v(xbgr.mr_n81617952)
print v(xbgr.mr_n81618272)
print v(xbgr.mr_n81618384)
print v(xbgr.mr_n81618704)
print v(xbgr.mr_n81618816)
print v(xbgr.mr_n81619136)
print v(xbgr.mr_n81619248)
print v(xbgr.mr_n81619568)
print v(xbgr.mr_n81619680)
print v(xbgr.mr_n81620000)
print v(xbgr.mr_n81620112)
print v(xbgr.mr_n81620432)
print v(xbgr.mr_n81620544)
print v(xbgr.mr_n81620864)
print v(xbgr.mr_n81620976)
print v(xbgr.mr_n81621296)
print v(xbgr.mr_n81621408)
print v(xbgr.mr_n81621728)
print v(xbgr.mr_n81621840)
print v(xbgr.mr_n81622160)
print v(xbgr.mr_n81622272)
print v(xbgr.mr_n81622592)
print v(xbgr.mr_n81622704)
print v(xbgr.mr_n81623024)
print v(xbgr.mr_n81623136)
print v(xbgr.mr_n81623456)
print v(xbgr.mr_n81623568)
print v(xbgr.mr_n81623888)
print v(xbgr.mr_n81624000)
print v(xbgr.mr_n81624320)
print v(xbgr.mr_n81624432)
print v(xbgr.mr_n81624752)
print v(xbgr.mr_n81624864)
print v(xbgr.mr_n81625184)
print v(xbgr.mr_n81625296)
print v(xbgr.mr_n81625616)
print v(xbgr.mr_n81625728)
print v(xbgr.mr_n81626048)
print v(xbgr.mr_n81626160)
print v(xbgr.mr_n81626480)
print v(xbgr.mr_n81626592)
print v(xbgr.mr_n81626912)
print v(xbgr.mr_n81627024)
print v(xbgr.mr_n81627344)
print v(xbgr.mr_n81627456)
print v(xbgr.mr_n81627776)
print v(xbgr.mr_n81627888)
print v(xbgr.mr_n81628208)
print v(xbgr.mr_n81628320)
print v(xbgr.mr_n81628640)
print v(xbgr.mr_n81628752)
print v(xbgr.mr_n81629072)
print v(xbgr.mr_n81629184)
print v(xbgr.mr_n81629504)
print v(xbgr.mr_n81629616)
print v(xbgr.mr_n81629936)
print v(xbgr.mr_n81630048)
print v(xbgr.mr_n81630368)
print v(xbgr.mr_n81630480)
print v(xbgr.mr_n81630800)
print v(xbgr.mr_n81630912)
print v(xbgr.mr_n81631232)
print v(xbgr.mr_n81631344)
print v(xbgr.mr_n81631664)
print v(xbgr.mr_n81631776)
print v(xbgr.mr_n81632096)
print v(xbgr.mr_n81632208)
print v(xbgr.mr_n81632528)
print v(xbgr.mr_n81632640)
print v(xbgr.mr_n81632960)
print v(xbgr.mr_n81633072)
print v(xbgr.mr_n81633392)
print v(xbgr.mr_n81633504)
print v(xbgr.mr_n81633824)
print v(xbgr.mr_n81633936)
print v(xbgr.mr_n81634256)
print v(xbgr.mr_n81634368)
print v(xbgr.mr_n81634688)
print v(xbgr.mr_n81634800)
print v(xbgr.mr_n81635120)
print v(xbgr.mr_n81635232)
print v(xbgr.mr_n81635552)
print v(xbgr.mr_n81635664)
print v(xbgr.mr_n81635984)
print v(xbgr.mr_n81636096)
print v(xbgr.mr_n81636416)
print v(xbgr.mr_n81636528)
print v(xbgr.mr_n81636848)
print v(xbgr.mr_n81636960)
print v(xbgr.mr_n81637280)
print v(xbgr.mr_n81637392)
print v(xbgr.mr_n81637712)
print v(xbgr.mr_n81637824)
print v(xbgr.mr_n81638144)
print v(xbgr.mr_n81638256)
print v(xbgr.mr_n81638576)
print v(xbgr.mr_n81638688)
print v(xbgr.mr_n81639008)
print v(xbgr.mr_n81639120)
print v(xbgr.mr_n81639440)
print v(xbgr.mr_n81639552)
print v(xbgr.mr_n81639872)
print v(xbgr.mr_n81639984)
print v(xbgr.mr_n81640304)
print v(xbgr.mr_n81640416)
print v(xbgr.mr_n81640736)
print v(xbgr.mr_n81640848)
print v(xbgr.mr_n81641168)
print v(xbgr.mr_n81641280)
print v(xbgr.mr_n81641600)
print v(xbgr.mr_n81641712)
print v(xbgr.mr_n81642032)
print v(xbgr.mr_n81642144)
print v(xbgr.mr_n81642464)
print v(xbgr.mr_n81642576)
print v(xbgr.mr_n81642896)
print v(xbgr.mr_n81643008)
print v(xbgr.mr_n81643328)
print v(xbgr.mr_n81643440)
print v(xbgr.mr_n81643760)
print v(xbgr.mr_n81643872)
print v(xbgr.mr_n81644192)
print v(xbgr.mr_n81644304)
print v(xbgr.mr_n81644624)
print v(xbgr.mr_n81644736)
print v(xbgr.mr_n81645056)
print v(xbgr.mr_n81645168)
print v(xbgr.mr_n81645488)
print v(xbgr.mr_n81645600)
print v(xbgr.mr_n81645920)
print v(xbgr.mr_n81646032)
print v(xbgr.mr_n81646352)
print v(xbgr.mr_n81646464)
print v(xbgr.mr_n81646784)
print v(xbgr.mr_n81646896)
print v(xbgr.mr_n81647216)
print v(xbgr.mr_n81647328)
print v(xbgr.mr_n81647648)
print v(xbgr.mr_n81647760)
print v(xbgr.mr_n81648080)
print v(xbgr.mr_n81648192)
print v(xbgr.mr_n81648512)
print v(xbgr.mr_n81648624)
print v(xbgr.mr_n81648944)
print v(xbgr.mr_n81649056)
print v(xbgr.mr_n81649376)
print v(xbgr.mr_n81649488)
print v(xbgr.mr_n81649808)
print v(xbgr.mr_n81649920)
print v(xbgr.mr_n81650240)
print v(xbgr.mr_n81650352)
print v(xbgr.mr_n81650672)
print v(xbgr.mr_n81650784)
print v(xbgr.mr_n81651104)
print v(xbgr.mr_n81651216)
print v(xbgr.mr_n81651536)
print v(xbgr.mr_n81651648)
print v(xbgr.mr_n81651968)
print v(xbgr.mr_n81652080)
print v(xbgr.mr_n81652400)
print v(xbgr.mr_n81652512)
print v(xbgr.mr_n81652832)
print v(xbgr.mr_n81652944)
print v(xbgr.mr_n81653264)
print v(xbgr.mr_n81653376)
print v(xbgr.mr_n81653696)
print v(xbgr.mr_n81653808)
print v(xbgr.mr_n81654128)
print v(xbgr.mr_n81654240)
print v(xbgr.mr_n81654560)
print v(xbgr.mr_n81654672)
print v(xbgr.mr_n81654992)
print v(xbgr.mr_n81655104)
print v(xbgr.mr_n81655424)
print v(xbgr.mr_n81655536)
print v(xbgr.mr_n81655856)
print v(xbgr.mr_n81655968)
print v(xbgr.mr_n81656288)
print v(xbgr.mr_n81656400)
print v(xbgr.mr_n81656720)
print v(xbgr.mr_n81656832)
print v(xbgr.mr_n81657152)
print v(xbgr.mr_n81657264)
print v(xbgr.mr_n81657584)
print v(xbgr.mr_n81657696)
print v(xbgr.mr_n81658016)
print v(xbgr.mr_n81658128)
print v(xbgr.mr_n81658448)
print v(xbgr.mr_n81658560)
print v(xbgr.mr_n81658880)
print v(xbgr.mr_n81658992)
print v(xbgr.mr_n81659312)
print v(xbgr.mr_n81659424)
print v(xbgr.mr_n81659744)
print v(xbgr.mr_n81659856)
print v(xbgr.mr_n81660176)
print v(xbgr.mr_n81660288)
print v(xbgr.mr_n81660608)
print v(xbgr.mr_n81660720)
print v(xbgr.mr_n81661040)
print v(xbgr.mr_n81661152)
print v(xbgr.mr_n81661472)
print v(xbgr.mr_n81661584)
print v(xbgr.mr_n81661904)
print v(xbgr.mr_n81662016)
print v(xbgr.mr_n81662336)
print v(xbgr.mr_n81662448)
print v(xbgr.mr_n81662768)
print v(xbgr.mr_n81662880)
print v(xbgr.mr_n81663200)
print v(xbgr.mr_n81663312)
print v(xbgr.mr_n81663632)
print v(xbgr.mr_n81663744)
print v(xbgr.mr_n81664064)
print v(xbgr.mr_n81664176)
print v(xbgr.mr_n81664496)
print v(xbgr.mr_n81664608)
print v(xbgr.mr_n81664928)
print v(xbgr.mr_n81665040)
print v(xbgr.mr_n81665360)
print v(xbgr.mr_n81665472)
print v(xbgr.mr_n81665792)
print v(xbgr.mr_n81665904)
print v(xbgr.mr_n81666224)
print v(xbgr.mr_n81666336)
print v(xbgr.mr_n81666656)
print v(xbgr.mr_n81666768)
print v(xbgr.mr_n81667088)
print v(xbgr.mr_n81667200)
print v(xbgr.mr_n81667520)
print v(xbgr.mr_n81667632)
print v(xbgr.mr_n81667952)
print v(xbgr.mr_n81668064)
print v(xbgr.mr_n81668384)
print v(xbgr.mr_n81668496)
print v(xbgr.mr_n81668816)
print v(xbgr.mr_n81668928)
print v(xbgr.mr_n81669248)
print v(xbgr.mr_n81669360)
print v(xbgr.mr_n81669680)
print v(xbgr.mr_n81669792)
print v(xbgr.mr_n81670112)
print v(xbgr.mr_n81670224)
print v(xbgr.mr_n81670544)
print v(xbgr.mr_n81670656)
print v(xbgr.mr_n81670976)
print v(xbgr.mr_n81671088)
print v(xbgr.mr_n81671408)
print v(xbgr.mr_n81671520)
print v(xbgr.mr_n81671840)
print v(xbgr.mr_n81671952)
print v(xbgr.mr_n81672272)
print v(xbgr.mr_n81672384)
print v(xbgr.mr_n81672704)
print v(xbgr.mr_n81672816)
print v(xbgr.mr_n81673136)
print v(xbgr.mr_n81673248)
print v(xbgr.mr_n81673568)
print v(xbgr.mr_n81673680)
print v(xbgr.mr_n81674000)
print v(xbgr.mr_n81674112)
print v(xbgr.mr_n81674432)
print v(xbgr.mr_n81674544)
print v(xbgr.mr_n81674864)
print v(xbgr.mr_n81674976)
print v(xbgr.mr_n81675296)
print v(xbgr.mr_n81675408)
print v(xbgr.mr_n81675728)
print v(xbgr.mr_n81675840)
print v(xbgr.mr_n81676160)
print v(xbgr.mr_n81676272)
print v(xbgr.mr_n81676592)
print v(xbgr.mr_n81676704)
print v(xbgr.mr_n81677024)
print v(xbgr.mr_n81677136)
print v(xbgr.mr_n81677456)
print v(xbgr.mr_n81677568)
print v(xbgr.mr_n81677872)
print v(xbgr.mr_n81677984)
print v(xbgr.mr_n81678304)
print v(xbgr.mr_n81678416)
print v(xbgr.mr_n81678736)
print v(xbgr.mr_n81678848)
print v(xbgr.mr_n81679168)
print v(xbgr.mr_n81679280)
print v(xbgr.mr_n81679600)
print v(xbgr.mr_n81679712)
print v(xbgr.mr_n81680032)
print v(xbgr.mr_n81680144)
print v(xbgr.mr_n81680464)
print v(xbgr.mr_n81680576)
print v(xbgr.mr_n81680896)
print v(xbgr.mr_n81681008)
print v(xbgr.mr_n81681328)
print v(xbgr.mr_n81681440)
print v(xbgr.mr_n81681760)
print v(xbgr.mr_n81681872)
print v(xbgr.mr_n81682192)
print v(xbgr.mr_n81682304)
print v(xbgr.mr_n81682624)
print v(xbgr.mr_n81682736)
print v(xbgr.mr_n81683056)
print v(xbgr.mr_n81683168)
print v(xbgr.mr_n81683488)
print v(xbgr.mr_n81683600)
print v(xbgr.mr_n81683920)
print v(xbgr.mr_n81684032)
print v(xbgr.mr_n81684352)
print v(xbgr.mr_n81684464)
print v(xbgr.mr_n81684784)
print v(xbgr.mr_n81684896)
print v(xbgr.mr_n81685216)
print v(xbgr.mr_n81685328)
print v(xbgr.mr_n81685648)
print v(xbgr.mr_n81685760)
print v(xbgr.mr_n81686080)
print v(xbgr.mr_n81686192)
print v(xbgr.mr_n81686512)
print v(xbgr.mr_n81686624)
print v(xbgr.mr_n81686944)
print v(xbgr.mr_n81687056)
print v(xbgr.mr_n81687376)
print v(xbgr.mr_n81687488)
print v(xbgr.mr_n81687808)
print v(xbgr.mr_n81687920)
print v(xbgr.mr_n81688240)
print v(xbgr.mr_n81688352)
print v(xbgr.mr_n81688672)
print v(xbgr.mr_n81688784)
print v(xbgr.mr_n81689104)
print v(xbgr.mr_n81689216)
print v(xbgr.mr_n81689536)
print v(xbgr.mr_n81689648)
print v(xbgr.mr_n81689968)
print v(xbgr.mr_n81690080)
print v(xbgr.mr_n81690400)
print v(xbgr.mr_n81690512)
print v(xbgr.mr_n81690832)
print v(xbgr.mr_n81690944)
print v(xbgr.mr_n81691264)
print v(xbgr.mr_n81691376)
print v(xbgr.mr_n81691696)
print v(xbgr.mr_n81691808)
print v(xbgr.mr_n81692128)
print v(xbgr.mr_n81692240)
print v(xbgr.mr_n81692560)
print v(xbgr.mr_n81692672)
print v(xbgr.mr_n81692992)
print v(xbgr.mr_n81693104)
print v(xbgr.mr_n81693424)
print v(xbgr.mr_n81693536)
print v(xbgr.mr_n81693856)
print v(xbgr.mr_n81693968)
print v(xbgr.mr_n81694288)
print v(xbgr.mr_n81694400)
print v(xbgr.mr_n81694720)
print v(xbgr.mr_n81694832)
print v(xbgr.mr_n81695152)
print v(xbgr.mr_n81695264)
print v(xbgr.mr_n81695584)
print v(xbgr.mr_n81695696)
print v(xbgr.mr_n81696016)
print v(xbgr.mr_n81696128)
print v(xbgr.mr_n81696448)
print v(xbgr.mr_n81696560)
print v(xbgr.mr_n81696880)
print v(xbgr.mr_n81696992)
print v(xbgr.mr_n81697312)
print v(xbgr.mr_n81697424)
print v(xbgr.mr_n81697744)
print v(xbgr.mr_n81697856)
print v(xbgr.mr_n81698176)
print v(xbgr.mr_n81698288)
print v(xbgr.mr_n81698608)
print v(xbgr.mr_n81698720)
print v(xbgr.mr_n81699040)
print v(xbgr.mr_n81699152)
print v(xbgr.mr_n81699472)
print v(xbgr.mr_n81699584)
print v(xbgr.mr_n81699904)
print v(xbgr.mr_n81700016)
print v(xbgr.mr_n81700336)
print v(xbgr.mr_n81700448)
print v(xbgr.mr_n81700768)
print v(xbgr.mr_n81700880)
print v(xbgr.mr_n81701200)
print v(xbgr.mr_n81701312)
print v(xbgr.mr_n81701632)
print v(xbgr.mr_n81701744)
print v(xbgr.mr_n81702064)
print v(xbgr.mr_n81702176)
print v(xbgr.mr_n81702496)
print v(xbgr.mr_n81702608)
print v(xbgr.mr_n81702928)
print v(xbgr.mr_n81703040)
print v(xbgr.mr_n81703360)
print v(xbgr.mr_n81703472)
print v(xbgr.mr_n81703792)
print v(xbgr.mr_n81703904)
print v(xbgr.mr_n81704224)
print v(xbgr.mr_n81704336)
print v(xbgr.mr_n81704656)
print v(xbgr.mr_n81704768)
print v(xbgr.mr_n81705088)
print v(xbgr.mr_n81705200)
print v(xbgr.mr_n81705520)
print v(xbgr.mr_n81705632)
print v(xbgr.mr_n81705952)
print v(xbgr.mr_n81706064)
print v(xbgr.mr_n81706384)
print v(xbgr.mr_n81706496)
print v(xbgr.mr_n81706816)
print v(xbgr.mr_n81706928)
print v(xbgr.mr_n81707248)
print v(xbgr.mr_n81707360)
print v(xbgr.mr_n81707680)
print v(xbgr.mr_n81707792)
print v(xbgr.mr_n81708112)
print v(xbgr.mr_n81708224)
print v(xbgr.mr_n81708544)
print v(xbgr.mr_n81708656)
print v(xbgr.mr_n81708976)
print v(xbgr.mr_n81709088)
print v(xbgr.mr_n81709408)
print v(xbgr.mr_n81709520)
print v(xbgr.mr_n81709840)
print v(xbgr.mr_n81709952)
print v(xbgr.mr_n81710272)
print v(xbgr.mr_n81710384)
print v(xbgr.mr_n81710704)
print v(xbgr.mr_n81710816)
print v(xbgr.mr_n81711136)
print v(xbgr.mr_n81711248)
print v(xbgr.mr_n81711568)
print v(xbgr.mr_n81711680)
print v(xbgr.mr_n81712000)
print v(xbgr.mr_n81712112)
print v(xbgr.mr_n81712432)
print v(xbgr.mr_n81712544)
print v(xbgr.mr_n81712864)
print v(xbgr.mr_n81712976)
print v(xbgr.mr_n81713296)
print v(xbgr.mr_n81713408)
print v(xbgr.mr_n81713728)
print v(xbgr.mr_n81713840)
print v(xbgr.mr_n81714160)
print v(xbgr.mr_n81714272)
print v(xbgr.mr_n81714592)
print v(xbgr.mr_n81714704)
print v(xbgr.mr_n81715024)
print v(xbgr.mr_n81715136)
print v(xbgr.mr_n81715456)
print v(xbgr.mr_n81715568)
print v(xbgr.mr_n81715888)
print v(xbgr.mr_n81716000)
print v(xbgr.mr_n81716320)
print v(xbgr.mr_n81716432)
print v(xbgr.mr_n81716752)
print v(xbgr.mr_n81716864)
print v(xbgr.mr_n81717184)
print v(xbgr.mr_n81717296)
print v(xbgr.mr_n81717616)
print v(xbgr.mr_n81717728)
print v(xbgr.mr_n81718048)
print v(xbgr.mr_n81718160)
print v(xbgr.mr_n81718480)
print v(xbgr.mr_n81718592)
print v(xbgr.mr_n81718912)
print v(xbgr.mr_n81719024)
print v(xbgr.mr_n81719344)
print v(xbgr.mr_n81719456)
print v(xbgr.mr_n81719776)
print v(xbgr.mr_n81719888)
print v(xbgr.mr_n81720208)
print v(xbgr.mr_n81720320)
print v(xbgr.mr_n81720640)
print v(xbgr.mr_n81720752)
print v(xbgr.mr_n81721072)
print v(xbgr.mr_n81721184)
print v(xbgr.mr_n81721504)
print v(xbgr.mr_n81721616)
print v(xbgr.mr_n81721936)
print v(xbgr.mr_n81722048)
print v(xbgr.mr_n81722368)
print v(xbgr.mr_n81722480)
print v(xbgr.mr_n81722800)
print v(xbgr.mr_n81722912)
print v(xbgr.mr_n81723232)
print v(xbgr.mr_n81723344)
print v(xbgr.mr_n81723664)
print v(xbgr.mr_n81723776)
print v(xbgr.mr_n81724096)
print v(xbgr.mr_n81724208)
print v(xbgr.mr_n81724528)
print v(xbgr.mr_n81724640)
print v(xbgr.mr_n81724960)
print v(xbgr.mr_n81725072)
print v(xbgr.mr_n81725392)
print v(xbgr.mr_n81725504)
print v(xbgr.mr_n81725824)
print v(xbgr.mr_n81725936)
print v(xbgr.mr_n81726256)
print v(xbgr.mr_n81726368)
print v(xbgr.mr_n81726688)
print v(xbgr.mr_n81726800)
print v(xbgr.mr_n81727120)
print v(xbgr.mr_n81727232)
print v(xbgr.mr_n81727552)
print v(xbgr.mr_n81727664)
print v(xbgr.mr_n81727984)
print v(xbgr.mr_n81728096)
print v(xbgr.mr_n81728416)
print v(xbgr.mr_n81728528)
print v(xbgr.mr_n81728848)
print v(xbgr.mr_n81728960)
print v(xbgr.mr_n81729280)
print v(xbgr.mr_n81729392)
print v(xbgr.mr_n81729712)
print v(xbgr.mr_n81729824)
print v(xbgr.mr_n81730144)
print v(xbgr.mr_n81730256)
print v(xbgr.mr_n81730576)
print v(xbgr.mr_n81730688)
print v(xbgr.mr_n81731008)
print v(xbgr.mr_n81731120)
print v(xbgr.mr_n81731440)
print v(xbgr.mr_n81731552)
print v(xbgr.mr_n81731872)
print v(xbgr.mr_n81731984)
print v(xbgr.mr_n81732304)
print v(xbgr.mr_n81732416)
print v(xbgr.mr_n81732736)
print v(xbgr.mr_n81732848)
print v(xbgr.mr_n81733168)
print v(xbgr.mr_n81733280)
print v(xbgr.mr_n81733600)
print v(xbgr.mr_n81733712)
print v(xbgr.mr_n81734032)
print v(xbgr.mr_n81734144)
print v(xbgr.mr_n81734464)
print v(xbgr.mr_n81734576)
print v(xbgr.mr_n81734896)
print v(xbgr.mr_n81735008)
print v(xbgr.mr_n81735328)
print v(xbgr.mr_n81735440)
print v(xbgr.mr_n81735760)
print v(xbgr.mr_n81735872)
print v(xbgr.mr_n81736192)
print v(xbgr.mr_n81736304)
print v(xbgr.mr_n81736624)
print v(xbgr.mr_n81736736)
print v(xbgr.mr_n81737056)
print v(xbgr.mr_n81737168)
print v(xbgr.mr_n81737488)
print v(xbgr.mr_n81737600)
print v(xbgr.mr_n81737920)
print v(xbgr.mr_n81738032)
print v(xbgr.mr_n81738352)
print v(xbgr.mr_n81738464)
print v(xbgr.mr_n81738784)
print v(xbgr.mr_n81738896)
print v(xbgr.mr_n81739216)
print v(xbgr.mr_n81739328)
print v(xbgr.mr_n81739648)
print v(xbgr.mr_n81739760)
print v(xbgr.mr_n81740080)
print v(xbgr.mr_n81740192)
print v(xbgr.mr_n81740512)
print v(xbgr.mr_n81740624)
print v(xbgr.mr_n81740944)
print v(xbgr.mr_n81741056)
print v(xbgr.mr_n81741376)
print v(xbgr.mr_n81741488)
print v(xbgr.mr_n81741808)
print v(xbgr.mr_n81741920)
print v(xbgr.mr_n81742240)
print v(xbgr.mr_n81742352)
print v(xbgr.mr_n81742672)
print v(xbgr.mr_n81742784)
print v(xbgr.mr_n81743104)
print v(xbgr.mr_n81743216)
print v(xbgr.mr_n81743536)
print v(xbgr.mr_n81743648)
print v(xbgr.mr_n81743968)
print v(xbgr.mr_n81744080)
print v(xbgr.mr_n81744400)
print v(xbgr.mr_n81744512)
print v(xbgr.mr_n81744832)
print v(xbgr.mr_n81744944)
print v(xbgr.mr_n81745264)
print v(xbgr.mr_n81745376)
print v(xbgr.mr_n81745696)
print v(xbgr.mr_n81745808)
print v(xbgr.mr_n81746128)
print v(xbgr.mr_n81746240)
print v(xbgr.mr_n81746560)
print v(xbgr.mr_n81746672)
print v(xbgr.mr_n81746992)
print v(xbgr.mr_n81747104)
print v(xbgr.mr_n81747424)
print v(xbgr.mr_n81747536)
print v(xbgr.mr_n81747856)
print v(xbgr.mr_n81747968)
print v(xbgr.mr_n81748288)
print v(xbgr.mr_n81748400)
print v(xbgr.mr_n81748720)
print v(xbgr.mr_n81748832)
print v(xbgr.mr_n81749152)
print v(xbgr.mr_n81749264)
print v(xbgr.mr_n81749584)
print v(xbgr.mr_n81749696)
print v(xbgr.mr_n81750016)
print v(xbgr.mr_n81750128)
print v(xbgr.mr_n81750448)
print v(xbgr.mr_n81750560)
print v(xbgr.mr_n81750880)
print v(xbgr.mr_n81750992)
print v(xbgr.mr_n81751312)
print v(xbgr.mr_n81751424)
print v(xbgr.mr_n81751744)
print v(xbgr.mr_n81751856)
print v(xbgr.mr_n81752176)
print v(xbgr.mr_n81752288)
print v(xbgr.mr_n81752608)
print v(xbgr.mr_n81752720)
print v(xbgr.mr_n81753040)
print v(xbgr.mr_n81753152)
print v(xbgr.mr_n81753472)
print v(xbgr.mr_n81753584)
print v(xbgr.mr_n81753904)
print v(xbgr.mr_n81754016)
print v(xbgr.mr_n81754336)
print v(xbgr.mr_n81754448)
print v(xbgr.mr_n81754768)
print v(xbgr.mr_n81754880)
print v(xbgr.mr_n81755200)
print v(xbgr.mr_n81755312)
print v(xbgr.mr_n81755632)
print v(xbgr.mr_n81755744)
print v(xbgr.mr_n81756064)
print v(xbgr.mr_n81756176)
print v(xbgr.mr_n81756496)
print v(xbgr.mr_n81756608)
print v(xbgr.mr_n81756928)
print v(xbgr.mr_n81757040)
print v(xbgr.mr_n81757360)
print v(xbgr.mr_n81757472)
print v(xbgr.mr_n81757792)
print v(xbgr.mr_n81757904)
print v(xbgr.mr_n81758224)
print v(xbgr.mr_n81758336)
print v(xbgr.mr_n81758656)
print v(xbgr.mr_n81758768)
print v(xbgr.mr_n81759088)
print v(xbgr.mr_n81759200)
print v(xbgr.mr_n81759520)
print v(xbgr.mr_n81759632)
print v(xbgr.mr_n81759952)
print v(xbgr.mr_n81760064)
print v(xbgr.mr_n81760384)
print v(xbgr.mr_n81760496)
print v(xbgr.mr_n81760816)
print v(xbgr.mr_n81760928)
print v(xbgr.mr_n81761248)
print v(xbgr.mr_n81761360)
print v(xbgr.mr_n81761680)
print v(xbgr.mr_n81761792)
print v(xbgr.mr_n81762112)
print v(xbgr.mr_n81762224)
print v(xbgr.mr_n81762544)
print v(xbgr.mr_n81762656)
print v(xbgr.mr_n81762976)
print v(xbgr.mr_n81763088)
print v(xbgr.mr_n81763408)
print v(xbgr.mr_n81763520)
print v(xbgr.mr_n81763840)
print v(xbgr.mr_n81763952)
print v(xbgr.mr_n81764272)
print v(xbgr.mr_n81764384)
print v(xbgr.mr_n81764704)
print v(xbgr.mr_n81764816)
print v(xbgr.mr_n81765136)
print v(xbgr.mr_n81765248)
print v(xbgr.mr_n81765568)
print v(xbgr.mr_n81765680)
print v(xbgr.mr_n81766000)
print v(xbgr.mr_n81766112)
print v(xbgr.mr_n81766432)
print v(xbgr.mr_n81766544)
print v(xbgr.mr_n81766864)
print v(xbgr.mr_n81766976)
print v(xbgr.mr_n81767296)
print v(xbgr.mr_n81767408)
print v(xbgr.mr_n81767728)
print v(xbgr.mr_n81767840)
print v(xbgr.mr_n81768160)
print v(xbgr.mr_n81768272)
print v(xbgr.mr_n81768592)
print v(xbgr.mr_n81768704)
print v(xbgr.mr_n81769024)
print v(xbgr.mr_n81769136)
print v(xbgr.mr_n81769456)
print v(xbgr.mr_n81769568)
print v(xbgr.mr_n81769888)
print v(xbgr.mr_n81770000)
print v(xbgr.mr_n81770320)
print v(xbgr.mr_n81770432)
print v(xbgr.mr_n81770752)
print v(xbgr.mr_n81770864)
print v(xbgr.mr_n81771184)
print v(xbgr.mr_n81771296)
print v(xbgr.mr_n81771616)
print v(xbgr.mr_n81771728)
print v(xbgr.mr_n81772048)
print v(xbgr.mr_n81772160)
print v(xbgr.mr_n81772480)
print v(xbgr.mr_n81772592)
print v(xbgr.mr_n81772912)
print v(xbgr.mr_n81773024)
print v(xbgr.mr_n81773344)
print v(xbgr.mr_n81773456)
print v(xbgr.mr_n81773776)
print v(xbgr.mr_n81773888)
print v(xbgr.mr_n81774208)
print v(xbgr.mr_n81774320)
print v(xbgr.mr_n81774640)
print v(xbgr.mr_n81774752)
print v(xbgr.mr_n81775072)
print v(xbgr.mr_n81775184)
print v(xbgr.mr_n81775504)
print v(xbgr.mr_n81775616)
print v(xbgr.mr_n81775936)
print v(xbgr.mr_n81776048)
print v(xbgr.mr_n81776368)
print v(xbgr.mr_n81776480)
print v(xbgr.mr_n81776800)
print v(xbgr.mr_n81776912)
print v(xbgr.mr_n81777232)
print v(xbgr.mr_n81777344)
print v(xbgr.mr_n81777664)
print v(xbgr.mr_n81777776)
print v(xbgr.mr_n81778096)
print v(xbgr.mr_n81778208)
print v(xbgr.mr_n81778528)
print v(xbgr.mr_n81778640)
print v(xbgr.mr_n81778960)
print v(xbgr.mr_n81779072)
print v(xbgr.mr_n81779392)
print v(xbgr.mr_n81779504)
print v(xbgr.mr_n81779824)
print v(xbgr.mr_n81779936)
print v(xbgr.mr_n81780256)
print v(xbgr.mr_n81780368)
print v(xbgr.mr_n81780688)
print v(xbgr.mr_n81780800)
print v(xbgr.mr_n81781120)
print v(xbgr.mr_n81781232)
print v(xbgr.mr_n81781552)
print v(xbgr.mr_n81781664)
print v(xbgr.mr_n81781984)
print v(xbgr.mr_n81782096)
print v(xbgr.mr_n81782416)
print v(xbgr.mr_n81782528)
print v(xbgr.mr_n81782848)
print v(xbgr.mr_n81782960)
print v(xbgr.mr_n81783280)
print v(xbgr.mr_n81783392)
print v(xbgr.mr_n81783712)
print v(xbgr.mr_n81783824)
print v(xbgr.mr_n81784144)
print v(xbgr.mr_n81784256)
print v(xbgr.mr_n81784576)
print v(xbgr.mr_n81784688)
print v(xbgr.mr_n81785008)
print v(xbgr.mr_n81785120)
print v(xbgr.mr_n81785440)
print v(xbgr.mr_n81785552)
print v(xbgr.mr_n81785872)
print v(xbgr.mr_n81785984)
print v(xbgr.mr_n81786304)
print v(xbgr.mr_n81786416)
print v(xbgr.mr_n81786736)
print v(xbgr.mr_n81786848)
print v(xbgr.mr_n81787168)
print v(xbgr.mr_n81787280)
print v(xbgr.mr_n81787600)
print v(xbgr.mr_n81787712)
print v(xbgr.mr_n81788032)
print v(xbgr.mr_n81788144)
print v(xbgr.mr_n81788464)
print v(xbgr.mr_n81788576)
print v(xbgr.mr_n81788896)
print v(xbgr.mr_n81789008)
print v(xbgr.mr_n81789328)
print v(xbgr.mr_n81789440)
print v(xbgr.mr_n81789760)
print v(xbgr.mr_n81789872)
print v(xbgr.mr_n81790192)
print v(xbgr.mr_n81790304)
print v(xbgr.mr_n81790624)
print v(xbgr.mr_n81790736)
print v(xbgr.mr_n81791056)
print v(xbgr.mr_n81791168)
print v(xbgr.mr_n81791488)
print v(xbgr.mr_n81791600)
print v(xbgr.mr_n81791920)
print v(xbgr.mr_n81792032)
print v(xbgr.mr_n81792352)
print v(xbgr.mr_n81792464)
print v(xbgr.mr_n81792784)
print v(xbgr.mr_n81792896)
print v(xbgr.mr_n81793216)
print v(xbgr.mr_n81793328)
print v(xbgr.mr_n81793648)
print v(xbgr.mr_n81793760)
print v(xbgr.mr_n81794080)
print v(xbgr.mr_n81794192)
print v(xbgr.mr_n81794512)
print v(xbgr.mr_n81794624)
print v(xbgr.mr_n81794944)
print v(xbgr.mr_n81795056)
print v(xbgr.mr_n81795376)
print v(xbgr.mr_n81795488)
print v(xbgr.mr_n81795808)
print v(xbgr.mr_n81795920)
print v(xbgr.mr_n81796240)
print v(xbgr.mr_n81796352)
print v(xbgr.mr_n81796672)
print v(xbgr.mr_n81796784)
print v(xbgr.mr_n81797104)
print v(xbgr.mr_n81797216)
print v(xbgr.mr_n81797536)
print v(xbgr.mr_n81797648)
print v(xbgr.mr_n81797968)
print v(xbgr.mr_n81798080)
print v(xbgr.mr_n81798400)
print v(xbgr.mr_n81798512)
print v(xbgr.mr_n81798832)
print v(xbgr.mr_n81798944)
print v(xbgr.mr_n81799264)
print v(xbgr.mr_n81799376)
print v(xbgr.mr_n81799696)
print v(xbgr.mr_n81799808)
print v(xbgr.mr_n81800128)
print v(xbgr.mr_n81800240)
print v(xbgr.mr_n81800560)
print v(xbgr.mr_n81800672)
print v(xbgr.mr_n81800992)
print v(xbgr.mr_n81801104)
print v(xbgr.mr_n81801424)
print v(xbgr.mr_n81801536)
print v(xbgr.mr_n81801856)
print v(xbgr.mr_n81801968)
print v(xbgr.mr_n81802288)
print v(xbgr.mr_n81802400)
print v(xbgr.mr_n81802720)
print v(xbgr.mr_n81802832)
print v(xbgr.mr_n81803152)
print v(xbgr.mr_n81803264)
print v(xbgr.mr_n81803584)
print v(xbgr.mr_n81803696)
print v(xbgr.mr_n81804016)
print v(xbgr.mr_n81804128)
print v(xbgr.mr_n81804448)
print v(xbgr.mr_n81804560)
print v(xbgr.mr_n81804880)
print v(xbgr.mr_n81804992)
print v(xbgr.mr_n81805312)
print v(xbgr.mr_n81805424)
print v(xbgr.mr_n81805744)
print v(xbgr.mr_n81805856)
print v(xbgr.mr_n81806176)
print v(xbgr.mr_n81806288)
print v(xbgr.mr_n81806608)
print v(xbgr.mr_n81806720)
print v(xbgr.mr_n81807040)
print v(xbgr.mr_n81807152)
print v(xbgr.mr_n81807472)
print v(xbgr.mr_n81807584)
print v(xbgr.mr_n81807904)
print v(xbgr.mr_n81808016)
print v(xbgr.mr_n81808336)
print v(xbgr.mr_n81808448)
print v(xbgr.mr_n81808768)
print v(xbgr.mr_n81808880)
print v(xbgr.mr_n81809200)
print v(xbgr.mr_n81809312)
print v(xbgr.mr_n81809632)
print v(xbgr.mr_n81809744)
print v(xbgr.mr_n81810064)
print v(xbgr.mr_n81810176)
print v(xbgr.mr_n81810496)
print v(xbgr.mr_n81810608)
print v(xbgr.mr_n81810928)
print v(xbgr.mr_n81811040)
print v(xbgr.mr_n81811360)
print v(xbgr.mr_n81811472)
print v(xbgr.mr_n81811792)
print v(xbgr.mr_n81811904)
print v(xbgr.mr_n81812224)
print v(xbgr.mr_n81812336)
print v(xbgr.mr_n81812656)
print v(xbgr.mr_n81812768)
print v(xbgr.mr_n81813088)
print v(xbgr.mr_n81813200)
print v(xbgr.mr_n81813520)
print v(xbgr.mr_n81813632)
print v(xbgr.mr_n81813952)
print v(xbgr.mr_n81814064)
print v(xbgr.mr_n81814384)
print v(xbgr.mr_n81814496)
print v(xbgr.mr_n81814816)
print v(xbgr.mr_n81814928)
print v(xbgr.mr_n81815248)
print v(xbgr.mr_n81815360)
print v(xbgr.mr_n81815680)
print v(xbgr.mr_n81815792)
print v(xbgr.mr_n81816112)
print v(xbgr.mr_n81816224)
print v(xbgr.mr_n81816544)
print v(xbgr.mr_n81816656)
print v(xbgr.mr_n81816976)
print v(xbgr.mr_n81817088)
print v(xbgr.mr_n81817408)
print v(xbgr.mr_n81817520)
print v(xbgr.mr_n81817840)
print v(xbgr.mr_n81817952)
print v(xbgr.mr_n81818272)
print v(xbgr.mr_n81818384)
print v(xbgr.mr_n81818704)
print v(xbgr.mr_n81818816)
print v(xbgr.mr_n81819136)
print v(xbgr.mr_n81819248)
print v(xbgr.mr_n81819568)
print v(xbgr.mr_n81819680)
print v(xbgr.mr_n81820000)
print v(xbgr.mr_n81820112)
print v(xbgr.mr_n81820432)
print v(xbgr.mr_n81820544)
print v(xbgr.mr_n81820864)
print v(xbgr.mr_n81820976)
print v(xbgr.mr_n81821296)
print v(xbgr.mr_n81821408)
print v(xbgr.mr_n81821728)
print v(xbgr.mr_n81821840)
print v(xbgr.mr_n81822160)
print v(xbgr.mr_n81822272)
print v(xbgr.mr_n81822592)
print v(xbgr.mr_n81822704)
print v(xbgr.mr_n81823024)
print v(xbgr.mr_n81823136)
print v(xbgr.mr_n81823456)
print v(xbgr.mr_n81823568)
print v(xbgr.mr_n81823888)
print v(xbgr.mr_n81824000)
print v(xbgr.mr_n81824320)
print v(xbgr.mr_n81824432)
print v(xbgr.mr_n81824752)
print v(xbgr.mr_n81824864)
print v(xbgr.mr_n81825184)
print v(xbgr.mr_n81825296)
print v(xbgr.mr_n81825616)
print v(xbgr.mr_n81825728)
print v(xbgr.mr_n81826048)
print v(xbgr.mr_n81826160)
print v(xbgr.mr_n81826480)
print v(xbgr.mr_n81826592)
print v(xbgr.mr_n81826912)
print v(xbgr.mr_n81827024)
print v(xbgr.mr_n81827344)
print v(xbgr.mr_n81827456)
print v(xbgr.mr_n81827776)
print v(xbgr.mr_n81827888)
print v(xbgr.mr_n81828208)
print v(xbgr.mr_n81828320)
print v(xbgr.mr_n81828640)
print v(xbgr.mr_n81828752)
print v(xbgr.mr_n81829072)
print v(xbgr.mr_n81829184)
print v(xbgr.mr_n81829504)
print v(xbgr.mr_n81829616)
print v(xbgr.mr_n81829936)
print v(xbgr.mr_n81830048)
print v(xbgr.mr_n81830368)
print v(xbgr.mr_n81830480)
print v(xbgr.mr_n81830800)
print v(xbgr.mr_n81830912)
print v(xbgr.mr_n81831232)
print v(xbgr.mr_n81831344)
print v(xbgr.mr_n81831664)
print v(xbgr.mr_n81831776)
print v(xbgr.mr_n81832096)
print v(xbgr.mr_n81832208)
print v(xbgr.mr_n81832528)
print v(xbgr.mr_n81832640)
print v(xbgr.mr_n81832960)
print v(xbgr.mr_n81833072)
print v(xbgr.mr_n81833392)
print v(xbgr.mr_n81833504)
print v(xbgr.mr_n81833824)
print v(xbgr.mr_n81833936)
print v(xbgr.mr_n81834256)
print v(xbgr.mr_n81834368)
print v(xbgr.mr_n81834688)
print v(xbgr.mr_n81834800)
print v(xbgr.mr_n81835120)
print v(xbgr.mr_n81835232)
print v(xbgr.mr_n81835552)
print v(xbgr.mr_n81835664)
print v(xbgr.mr_n81835984)
print v(xbgr.mr_n81836096)
print v(xbgr.mr_n81836416)
print v(xbgr.mr_n81836528)
print v(xbgr.mr_n81836848)
print v(xbgr.mr_n81836960)
print v(xbgr.mr_n81837280)
print v(xbgr.mr_n81837392)
print v(xbgr.mr_n81837712)
print v(xbgr.mr_n81837824)
print v(xbgr.mr_n81838144)
print v(xbgr.mr_n81838256)
print v(xbgr.mr_n81838576)
print v(xbgr.mr_n81838688)
print v(xbgr.mr_n81839008)
print v(xbgr.mr_n81839120)
print v(xbgr.mr_n81839440)
print v(xbgr.mr_n81839552)
print v(xbgr.mr_n81839872)
print v(xbgr.mr_n81839984)
print v(xbgr.mr_n81840304)
print v(xbgr.mr_n81840416)
print v(xbgr.mr_n81840736)
print v(xbgr.mr_n81840848)
print v(xbgr.mr_n81841168)
print v(xbgr.mr_n81841280)
print v(xbgr.mr_n81841600)
print v(xbgr.mr_n81841712)
print v(xbgr.mr_n81842032)
print v(xbgr.mr_n81842144)
print v(xbgr.mr_n81842464)
print v(xbgr.mr_n81842576)
print v(xbgr.mr_n81842896)
print v(xbgr.mr_n81843008)
print v(xbgr.mr_n81843328)
print v(xbgr.mr_n81843440)
print v(xbgr.mr_n81843760)
print v(xbgr.mr_n81843872)
print v(xbgr.mr_n81844192)
print v(xbgr.mr_n81844304)
print v(xbgr.mr_n81844624)
print v(xbgr.mr_n81844736)
print v(xbgr.mr_n81845056)
print v(xbgr.mr_n81845168)
print v(xbgr.mr_n81845488)
print v(xbgr.mr_n81845600)
print v(xbgr.mr_n81845920)
print v(xbgr.mr_n81846032)
print v(xbgr.mr_n81846352)
print v(xbgr.mr_n81846464)
print v(xbgr.mr_n81846784)
print v(xbgr.mr_n81846896)
print v(xbgr.mr_n81847216)
print v(xbgr.mr_n81847328)
print v(xbgr.mr_n81847648)
print v(xbgr.mr_n81847760)
print v(xbgr.mr_n81848080)
print v(xbgr.mr_n81848192)
print v(xbgr.mr_n81848512)
print v(xbgr.mr_n81848624)
print v(xbgr.mr_n81848944)
print v(xbgr.mr_n81849056)
print v(xbgr.mr_n81849376)
print v(xbgr.mr_n81849488)
print v(xbgr.mr_n81849808)
print v(xbgr.mr_n81849920)
print v(xbgr.mr_n81850240)
print v(xbgr.mr_n81850352)
print v(xbgr.mr_n81850672)
print v(xbgr.mr_n81850784)
print v(xbgr.mr_n81851104)
print v(xbgr.mr_n81851216)
print v(xbgr.mr_n81851536)
print v(xbgr.mr_n81851648)
print v(xbgr.mr_n81851968)
print v(xbgr.mr_n81852080)
print v(xbgr.mr_n81852400)
print v(xbgr.mr_n81852512)
print v(xbgr.mr_n81852832)
print v(xbgr.mr_n81852944)
print v(xbgr.mr_n81853264)
print v(xbgr.mr_n81853376)
print v(xbgr.mr_n81853696)
print v(xbgr.mr_n81853808)
print v(xbgr.mr_n81854128)
print v(xbgr.mr_n81854240)
print v(xbgr.mr_n81854560)
print v(xbgr.mr_n81854672)
print v(xbgr.mr_n81854992)
print v(xbgr.mr_n81855104)
print v(xbgr.mr_n81855424)
print v(xbgr.mr_n81855536)
print v(xbgr.mr_n81855856)
print v(xbgr.mr_n81855968)
print v(xbgr.mr_n81856288)
print v(xbgr.mr_n81856400)
print v(xbgr.mr_n81856720)
print v(xbgr.mr_n81856832)
print v(xbgr.mr_n81857152)
print v(xbgr.mr_n81857264)
print v(xbgr.mr_n81857584)
print v(xbgr.mr_n81857696)
print v(xbgr.mr_n81858016)
print v(xbgr.mr_n81858128)
print v(xbgr.mr_n81858448)
print v(xbgr.mr_n81858560)
print v(xbgr.mr_n81858880)
print v(xbgr.mr_n81858992)
print v(xbgr.mr_n81859312)
print v(xbgr.mr_n81859424)
print v(xbgr.mr_n81859744)
print v(xbgr.mr_n81859856)
print v(xbgr.mr_n81860176)
print v(xbgr.mr_n81860288)
print v(xbgr.mr_n81860608)
print v(xbgr.mr_n81860720)
print v(xbgr.mr_n81861040)
print v(xbgr.mr_n81861152)
print v(xbgr.mr_n81861472)
print v(xbgr.mr_n81861584)
print v(xbgr.mr_n81861904)
print v(xbgr.mr_n81862016)
print v(xbgr.mr_n81862336)
print v(xbgr.mr_n81862448)
print v(xbgr.mr_n81862768)
print v(xbgr.mr_n81862880)
print v(xbgr.mr_n81863200)
print v(xbgr.mr_n81863312)
print v(xbgr.mr_n81863632)
print v(xbgr.mr_n81863744)
print v(xbgr.mr_n81864064)
print v(xbgr.mr_n81864176)
print v(xbgr.mr_n81864496)
print v(xbgr.mr_n81864608)
print v(xbgr.mr_n81864928)
print v(xbgr.mr_n81865040)
print v(xbgr.mr_n81865360)
print v(xbgr.mr_n81865472)
print v(xbgr.mr_n81865792)
print v(xbgr.mr_n81865904)
print v(xbgr.mr_n81866224)
print v(xbgr.mr_n81866336)
print v(xbgr.mr_n81866656)
print v(xbgr.mr_n81866768)
print v(xbgr.mr_n81867088)
print v(xbgr.mr_n81867200)
print v(xbgr.mr_n81867520)
print v(xbgr.mr_n81867632)
print v(xbgr.mr_n81867952)
print v(xbgr.mr_n81868064)
print v(xbgr.mr_n81868384)
print v(xbgr.mr_n81868496)
print v(xbgr.mr_n81868816)
print v(xbgr.mr_n81868928)
print v(xbgr.mr_n81869248)
print v(xbgr.mr_n81869360)
print v(xbgr.mr_n81869680)
print v(xbgr.mr_n81869792)
print v(xbgr.mr_n81870112)
print v(xbgr.mr_n81870224)
print v(xbgr.mr_n81870544)
print v(xbgr.mr_n81870656)
print v(xbgr.mr_n81870976)
print v(xbgr.mr_n81871088)
print v(xbgr.mr_n81871408)
print v(xbgr.mr_n81871520)
print v(xbgr.mr_n81871840)
print v(xbgr.mr_n81871952)
print v(xbgr.mr_n81872272)
print v(xbgr.mr_n81872384)
print v(xbgr.mr_n81872704)
print v(xbgr.mr_n81872816)
print v(xbgr.mr_n81873136)
print v(xbgr.mr_n81873248)
print v(xbgr.mr_n81873568)
print v(xbgr.mr_n81873680)
print v(xbgr.mr_n81874000)
print v(xbgr.mr_n81874112)
print v(xbgr.mr_n81874432)
print v(xbgr.mr_n81874544)
print v(xbgr.mr_n81874864)
print v(xbgr.mr_n81874976)
print v(xbgr.mr_n81875296)
print v(xbgr.mr_n81875408)
print v(xbgr.mr_n81875728)
print v(xbgr.mr_n81875840)
print v(xbgr.mr_n81876160)
print v(xbgr.mr_n81876272)
print v(xbgr.mr_n81876592)
print v(xbgr.mr_n81876704)
print v(xbgr.mr_n81877024)
print v(xbgr.mr_n81877136)
print v(xbgr.mr_n81877456)
print v(xbgr.mr_n81877568)
print v(xbgr.mr_n81877888)
print v(xbgr.mr_n81878000)
print v(xbgr.mr_n81878320)
print v(xbgr.mr_n81878432)
print v(xbgr.mr_n81878752)
print v(xbgr.mr_n81878864)
print v(xbgr.mr_n81879184)
print v(xbgr.mr_n81879296)
print v(xbgr.mr_n81879616)
print v(xbgr.mr_n81879728)
print v(xbgr.mr_n81880048)
print v(xbgr.mr_n81880160)
print v(xbgr.mr_n81880480)
print v(xbgr.mr_n81880592)
print v(xbgr.mr_n81880912)
print v(xbgr.mr_n81881024)
print v(xbgr.mr_n81881344)
print v(xbgr.mr_n81881456)
print v(xbgr.mr_n81881776)
print v(xbgr.mr_n81881888)
print v(xbgr.mr_n81882208)
print v(xbgr.mr_n81882320)
print v(xbgr.mr_n81882640)
print v(xbgr.mr_n81882752)
print v(xbgr.mr_n81883072)
print v(xbgr.mr_n81883184)
print v(xbgr.mr_n81883504)
print v(xbgr.mr_n81883616)
print v(xbgr.mr_n81883936)
print v(xbgr.mr_n81884048)
print v(xbgr.mr_n81884368)
print v(xbgr.mr_n81884480)
print v(xbgr.mr_n81884800)
print v(xbgr.mr_n81884912)
print v(xbgr.mr_n81885232)
print v(xbgr.mr_n81885344)
print v(xbgr.mr_n81885664)
print v(xbgr.mr_n81885776)
print v(xbgr.mr_n81886096)
print v(xbgr.mr_n81886208)
print v(xbgr.mr_n81886528)
print v(xbgr.mr_n81886640)
print v(xbgr.mr_n81886960)
print v(xbgr.mr_n81887072)
print v(xbgr.mr_n81887392)
print v(xbgr.mr_n81887504)
print v(xbgr.mr_n81887824)
print v(xbgr.mr_n81887936)
print v(xbgr.mr_n81888256)
print v(xbgr.mr_n81888368)
print v(xbgr.mr_n81888688)
print v(xbgr.mr_n81888800)
print v(xbgr.mr_n81889120)
print v(xbgr.mr_n81889232)
print v(xbgr.mr_n81889552)
print v(xbgr.mr_n81889664)
print v(xbgr.mr_n81889984)
print v(xbgr.mr_n81890096)
print v(xbgr.mr_n81890416)
print v(xbgr.mr_n81890528)
print v(xbgr.mr_n81890848)
print v(xbgr.mr_n81890960)
print v(xbgr.mr_n81891280)
print v(xbgr.mr_n81891392)
print v(xbgr.mr_n81891712)
print v(xbgr.mr_n81891824)
print v(xbgr.mr_n81892144)
print v(xbgr.mr_n81892256)
print v(xbgr.mr_n81892576)
print v(xbgr.mr_n81892688)
print v(xbgr.mr_n81893008)
print v(xbgr.mr_n81893120)
print v(xbgr.mr_n81893440)
print v(xbgr.mr_n81893552)
print v(xbgr.mr_n81893872)
print v(xbgr.mr_n81893984)
print v(xbgr.mr_n81894304)
print v(xbgr.mr_n81894416)
print v(xbgr.mr_n81894736)
print v(xbgr.mr_n81894848)
print v(xbgr.mr_n81895168)
print v(xbgr.mr_n81895280)
print v(xbgr.mr_n81895600)
print v(xbgr.mr_n81895712)
print v(xbgr.mr_n81896032)
print v(xbgr.mr_n81896144)
print v(xbgr.mr_n81896464)
print v(xbgr.mr_n81896576)
print v(xbgr.mr_n81896896)
print v(xbgr.mr_n81897008)
print v(xbgr.mr_n81897328)
print v(xbgr.mr_n81897440)
print v(xbgr.mr_n81897760)
print v(xbgr.mr_n81897872)
print v(xbgr.mr_n81898192)
print v(xbgr.mr_n81898304)
print v(xbgr.mr_n81898624)
print v(xbgr.mr_n81898736)
print v(xbgr.mr_n81899056)
print v(xbgr.mr_n81899168)
print v(xbgr.mr_n81899488)
print v(xbgr.mr_n81899600)
print v(xbgr.mr_n81899920)
print v(xbgr.mr_n81900032)
print v(xbgr.mr_n81900352)
print v(xbgr.mr_n81900464)
print v(xbgr.mr_n81900784)
print v(xbgr.mr_n81900896)
print v(xbgr.mr_n81901216)
print v(xbgr.mr_n81901328)
print v(xbgr.mr_n81901648)
print v(xbgr.mr_n81901760)
print v(xbgr.mr_n81902080)
print v(xbgr.mr_n81902192)
print v(xbgr.mr_n81902512)
print v(xbgr.mr_n81902624)
print v(xbgr.mr_n81902944)
print v(xbgr.mr_n81903056)
print v(xbgr.mr_n81903376)
print v(xbgr.mr_n81903488)
print v(xbgr.mr_n81903808)
print v(xbgr.mr_n81903920)
print v(xbgr.mr_n81904240)
print v(xbgr.mr_n81904352)
print v(xbgr.mr_n81904672)
print v(xbgr.mr_n81904784)
print v(xbgr.mr_n81905104)
print v(xbgr.mr_n81905216)
print v(xbgr.mr_n81905536)
print v(xbgr.mr_n81905648)
print v(xbgr.mr_n81905968)
print v(xbgr.mr_n81906080)
print v(xbgr.mr_n81906400)
print v(xbgr.mr_n81906512)
print v(xbgr.mr_n81906832)
print v(xbgr.mr_n81906944)
print v(xbgr.mr_n81907264)
print v(xbgr.mr_n81907376)
print v(xbgr.mr_n81907696)
print v(xbgr.mr_n81907808)
print v(xbgr.mr_n81908128)
print v(xbgr.mr_n81908240)
print v(xbgr.mr_n81908560)
print v(xbgr.mr_n81908672)
print v(xbgr.mr_n81908992)
print v(xbgr.mr_n81909104)
print v(xbgr.mr_n81909424)
print v(xbgr.mr_n81909536)
print v(xbgr.mr_n81909856)
print v(xbgr.mr_n81909968)
print v(xbgr.mr_n81910288)
print v(xbgr.mr_n81910400)
print v(xbgr.mr_n81910720)
print v(xbgr.mr_n81910832)
print v(xbgr.mr_n81911152)
print v(xbgr.mr_n81911264)
print v(xbgr.mr_n81911584)
print v(xbgr.mr_n81911696)
print v(xbgr.mr_n81912016)
print v(xbgr.mr_n81912128)
print v(xbgr.mr_n81912448)
print v(xbgr.mr_n81912560)
print v(xbgr.mr_n81912880)
print v(xbgr.mr_n81912992)
print v(xbgr.mr_n81913312)
print v(xbgr.mr_n81913424)
print v(xbgr.mr_n81913744)
print v(xbgr.mr_n81913856)
print v(xbgr.mr_n81914176)
print v(xbgr.mr_n81914288)
print v(xbgr.mr_n81914608)
print v(xbgr.mr_n81914720)
print v(xbgr.mr_n81915040)
print v(xbgr.mr_n81915152)
print v(xbgr.mr_n81915472)
print v(xbgr.mr_n81915584)
print v(xbgr.mr_n81915904)
print v(xbgr.mr_n81916016)
print v(xbgr.mr_n81916336)
print v(xbgr.mr_n81916448)
print v(xbgr.mr_n81916768)
print v(xbgr.mr_n81916880)
print v(xbgr.mr_n81917200)
print v(xbgr.mr_n81917312)
print v(xbgr.mr_n81917632)
print v(xbgr.mr_n81917744)
print v(xbgr.mr_n81918064)
print v(xbgr.mr_n81918176)
print v(xbgr.mr_n81918496)
print v(xbgr.mr_n81918608)
print v(xbgr.mr_n81918928)
print v(xbgr.mr_n81919040)
print v(xbgr.mr_n81919360)
print v(xbgr.mr_n81919472)
print v(xbgr.mr_n81919792)
print v(xbgr.mr_n81919904)
print v(xbgr.mr_n81920224)
print v(xbgr.mr_n81920336)
print v(xbgr.mr_n81920656)
print v(xbgr.mr_n81920768)
print v(xbgr.mr_n81921088)
print v(xbgr.mr_n81921200)
print v(xbgr.mr_n81921520)
print v(xbgr.mr_n81921632)
print v(xbgr.mr_n81921952)
print v(xbgr.mr_n81922064)
print v(xbgr.mr_n81922384)
print v(xbgr.mr_n81922496)
print v(xbgr.mr_n81922816)
print v(xbgr.mr_n81922928)
print v(xbgr.mr_n81923248)
print v(xbgr.mr_n81923360)
print v(xbgr.mr_n81923680)
print v(xbgr.mr_n81923792)
print v(xbgr.mr_n81924112)
print v(xbgr.mr_n81924224)
print v(xbgr.mr_n81924544)
print v(xbgr.mr_n81924656)
print v(xbgr.mr_n81924976)
print v(xbgr.mr_n81925088)
print v(xbgr.mr_n81925408)
print v(xbgr.mr_n81925520)
print v(xbgr.mr_n81925840)
print v(xbgr.mr_n81925952)
print v(xbgr.mr_n81926272)
print v(xbgr.mr_n81926384)
print v(xbgr.mr_n81926704)
print v(xbgr.mr_n81926816)
print v(xbgr.mr_n81927136)
print v(xbgr.mr_n81927248)
print v(xbgr.mr_n81927568)
print v(xbgr.mr_n81927680)
print v(xbgr.mr_n81928000)
print v(xbgr.mr_n81928112)
print v(xbgr.mr_n81928432)
print v(xbgr.mr_n81928544)
print v(xbgr.mr_n81928864)
print v(xbgr.mr_n81928976)
print v(xbgr.mr_n81929296)
print v(xbgr.mr_n81929408)
print v(xbgr.mr_n81929728)
print v(xbgr.mr_n81929840)
print v(xbgr.mr_n81930160)
print v(xbgr.mr_n81930272)
print v(xbgr.mr_n81930592)
print v(xbgr.mr_n81930704)
print v(xbgr.mr_n81931024)
print v(xbgr.mr_n81931136)
print v(xbgr.mr_n81931456)
print v(xbgr.mr_n81931568)
print v(xbgr.mr_n81931888)
print v(xbgr.mr_n81932000)
print v(xbgr.mr_n81932320)
print v(xbgr.mr_n81932432)
print v(xbgr.mr_n81932752)
print v(xbgr.mr_n81932864)
print v(xbgr.mr_n81933184)
print v(xbgr.mr_n81933296)
print v(xbgr.mr_n81933616)
print v(xbgr.mr_n81933728)
print v(xbgr.mr_n81934048)
print v(xbgr.mr_n81934160)
print v(xbgr.mr_n81934480)
print v(xbgr.mr_n81934592)
print v(xbgr.mr_n81934912)
print v(xbgr.mr_n81935024)
print v(xbgr.mr_n81935344)
print v(xbgr.mr_n81935456)
print v(xbgr.mr_n81935776)
print v(xbgr.mr_n81935888)
print v(xbgr.mr_n81936208)
print v(xbgr.mr_n81936320)
print v(xbgr.mr_n81936640)
print v(xbgr.mr_n81936752)
print v(xbgr.mr_n81937072)
print v(xbgr.mr_n81937184)
print v(xbgr.mr_n81937504)
print v(xbgr.mr_n81937616)
print v(xbgr.mr_n81937936)
print v(xbgr.mr_n81938048)
print v(xbgr.mr_n81938368)
print v(xbgr.mr_n81938480)
print v(xbgr.mr_n81938800)
print v(xbgr.mr_n81938912)
print v(xbgr.mr_n81939232)
print v(xbgr.mr_n81939344)
print v(xbgr.mr_n81939664)
print v(xbgr.mr_n81939776)
print v(xbgr.mr_n81940096)
print v(xbgr.mr_n81940208)
print v(xbgr.mr_n81940528)
print v(xbgr.mr_n81940640)
print v(xbgr.mr_n81940960)
print v(xbgr.mr_n81941072)
print v(xbgr.mr_n81941392)
print v(xbgr.mr_n81941504)
print v(xbgr.mr_n81941824)
print v(xbgr.mr_n81941936)
print v(xbgr.mr_n81942256)
print v(xbgr.mr_n81942368)
print v(xbgr.mr_n81942688)
print v(xbgr.mr_n81942800)
print v(xbgr.mr_n81943120)
print v(xbgr.mr_n81943232)
print v(xbgr.mr_n81943552)
print v(xbgr.mr_n81943664)
print v(xbgr.mr_n81943984)
print v(xbgr.mr_n81944096)
print v(xbgr.mr_n81944416)
print v(xbgr.mr_n81944528)
print v(xbgr.mr_n81944848)
print v(xbgr.mr_n81944960)
print v(xbgr.mr_n81945280)
print v(xbgr.mr_n81945392)
print v(xbgr.mr_n81945712)
print v(xbgr.mr_n81945824)
print v(xbgr.mr_n81946144)
print v(xbgr.mr_n81946256)
print v(xbgr.mr_n81946576)
print v(xbgr.mr_n81946688)
print v(xbgr.mr_n81947008)
print v(xbgr.mr_n81947120)
print v(xbgr.mr_n81947440)
print v(xbgr.mr_n81947552)
print v(xbgr.mr_n81947872)
print v(xbgr.mr_n81947984)
print v(xbgr.mr_n81948304)
print v(xbgr.mr_n81948416)
print v(xbgr.mr_n81948736)
print v(xbgr.mr_n81948848)
print v(xbgr.mr_n81949168)
print v(xbgr.mr_n81949280)
print v(xbgr.mr_n81949600)
print v(xbgr.mr_n81949712)
print v(xbgr.mr_n81950032)
print v(xbgr.mr_n81950144)
print v(xbgr.mr_n81950464)
print v(xbgr.mr_n81950576)
print v(xbgr.mr_n81950896)
print v(xbgr.mr_n81951008)
print v(xbgr.mr_n81951328)
print v(xbgr.mr_n81951440)
print v(xbgr.mr_n81951760)
print v(xbgr.mr_n81951872)
print v(xbgr.mr_n81952192)
print v(xbgr.mr_n81952304)
print v(xbgr.mr_n81952624)
print v(xbgr.mr_n81952736)
print v(xbgr.mr_n81953056)
print v(xbgr.mr_n81953168)
print v(xbgr.mr_n81953488)
print v(xbgr.mr_n81953600)
print v(xbgr.mr_n81953920)
print v(xbgr.mr_n81954032)
print v(xbgr.mr_n81954352)
print v(xbgr.mr_n81954464)
print v(xbgr.mr_n81954784)
print v(xbgr.mr_n81954896)
print v(xbgr.mr_n81955216)
print v(xbgr.mr_n81955328)
print v(xbgr.mr_n81955648)
print v(xbgr.mr_n81955760)
print v(xbgr.mr_n81956080)
print v(xbgr.mr_n81956192)
print v(xbgr.mr_n81956512)
print v(xbgr.mr_n81956624)
print v(xbgr.mr_n81956944)
print v(xbgr.mr_n81957056)
print v(xbgr.mr_n81957376)
print v(xbgr.mr_n81957488)
print v(xbgr.mr_n81957808)
print v(xbgr.mr_n81957920)
print v(xbgr.mr_n81958240)
print v(xbgr.mr_n81958352)
print v(xbgr.mr_n81958672)
print v(xbgr.mr_n81958784)
print v(xbgr.mr_n81959104)
print v(xbgr.mr_n81959216)
print v(xbgr.mr_n81959536)
print v(xbgr.mr_n81959648)
print v(xbgr.mr_n81959968)
print v(xbgr.mr_n81960080)
print v(xbgr.mr_n81960400)
print v(xbgr.mr_n81960512)
print v(xbgr.mr_n81960832)
print v(xbgr.mr_n81960944)
print v(xbgr.mr_n81961264)
print v(xbgr.mr_n81961376)
print v(xbgr.mr_n81961696)
print v(xbgr.mr_n81961808)
print v(xbgr.mr_n81962128)
print v(xbgr.mr_n81962240)
print v(xbgr.mr_n81962560)
print v(xbgr.mr_n81962672)
print v(xbgr.mr_n81962992)
print v(xbgr.mr_n81963104)
print v(xbgr.mr_n81963424)
print v(xbgr.mr_n81963536)
print v(xbgr.mr_n81963856)
print v(xbgr.mr_n81963968)
print v(xbgr.mr_n81964288)
print v(xbgr.mr_n81964400)
print v(xbgr.mr_n81964720)
print v(xbgr.mr_n81964832)
print v(xbgr.mr_n81965152)
print v(xbgr.mr_n81965264)
print v(xbgr.mr_n81965584)
print v(xbgr.mr_n81965696)
print v(xbgr.mr_n81966016)
print v(xbgr.mr_n81966128)
print v(xbgr.mr_n81966448)
print v(xbgr.mr_n81966560)
print v(xbgr.mr_n81966880)
print v(xbgr.mr_n81966992)
print v(xbgr.mr_n81967312)
print v(xbgr.mr_n81967424)
print v(xbgr.mr_n81967744)
print v(xbgr.mr_n81967856)
print v(xbgr.mr_n81968176)
print v(xbgr.mr_n81968288)
print v(xbgr.mr_n81968608)
print v(xbgr.mr_n81968720)
print v(xbgr.mr_n81969040)
print v(xbgr.mr_n81969152)
print v(xbgr.mr_n81969472)
print v(xbgr.mr_n81969584)
print v(xbgr.mr_n81969904)
print v(xbgr.mr_n81970016)
print v(xbgr.mr_n81970336)
print v(xbgr.mr_n81970448)
print v(xbgr.mr_n81970768)
print v(xbgr.mr_n81970880)
print v(xbgr.mr_n81971200)
print v(xbgr.mr_n81971312)
print v(xbgr.mr_n81971632)
print v(xbgr.mr_n81971744)
print v(xbgr.mr_n81972064)
print v(xbgr.mr_n81972176)
print v(xbgr.mr_n81972496)
print v(xbgr.mr_n81972608)
print v(xbgr.mr_n81972928)
print v(xbgr.mr_n81973040)
print v(xbgr.mr_n81973360)
print v(xbgr.mr_n81973472)
print v(xbgr.mr_n81973792)
print v(xbgr.mr_n81973904)
print v(xbgr.mr_n81974224)
print v(xbgr.mr_n81974336)
print v(xbgr.mr_n81974656)
print v(xbgr.mr_n81974768)
print v(xbgr.mr_n81975088)
print v(xbgr.mr_n81975200)
print v(xbgr.mr_n81975520)
print v(xbgr.mr_n81975632)
print v(xbgr.mr_n81975952)
print v(xbgr.mr_n81976064)
print v(xbgr.mr_n81976384)
print v(xbgr.mr_n81976496)
print v(xbgr.mr_n81976816)
print v(xbgr.mr_n81976928)
print v(xbgr.mr_n81977248)
print v(xbgr.mr_n81977360)
print v(xbgr.mr_n81977680)
print v(xbgr.mr_n81977792)
print v(xbgr.mr_n81978112)
print v(xbgr.mr_n81978224)
print v(xbgr.mr_n81978544)
print v(xbgr.mr_n81978656)
print v(xbgr.mr_n81978976)
print v(xbgr.mr_n81979088)
print v(xbgr.mr_n81979408)
print v(xbgr.mr_n81979520)
print v(xbgr.mr_n81979840)
print v(xbgr.mr_n81979952)
print v(xbgr.mr_n81980272)
print v(xbgr.mr_n81980384)
print v(xbgr.mr_n81980704)
print v(xbgr.mr_n81980816)
print v(xbgr.mr_n81981136)
print v(xbgr.mr_n81981248)
print v(xbgr.mr_n81981568)
print v(xbgr.mr_n81981680)
print v(xbgr.mr_n81982000)
print v(xbgr.mr_n81982112)
print v(xbgr.mr_n81982432)
print v(xbgr.mr_n81982544)
print v(xbgr.mr_n81982864)
print v(xbgr.mr_n81982976)
print v(xbgr.mr_n81983296)
print v(xbgr.mr_n81983408)
print v(xbgr.mr_n81983728)
print v(xbgr.mr_n81983840)
print v(xbgr.mr_n81984160)
print v(xbgr.mr_n81984272)
print v(xbgr.mr_n81984592)
print v(xbgr.mr_n81984704)
print v(xbgr.mr_n81985024)
print v(xbgr.mr_n81985136)
print v(xbgr.mr_n81985456)
print v(xbgr.mr_n81985568)
print v(xbgr.mr_n81985888)
print v(xbgr.mr_n81986000)
print v(xbgr.mr_n81986320)
print v(xbgr.mr_n81986432)
print v(xbgr.mr_n81986752)
print v(xbgr.mr_n81986864)
print v(xbgr.mr_n81987184)
print v(xbgr.mr_n81987296)
print v(xbgr.mr_n81987616)
print v(xbgr.mr_n81987728)
print v(xbgr.mr_n81988048)
print v(xbgr.mr_n81988160)
print v(xbgr.mr_n81988480)
print v(xbgr.mr_n81988592)
print v(xbgr.mr_n81988912)
print v(xbgr.mr_n81989024)
print v(xbgr.mr_n81989344)
print v(xbgr.mr_n81989456)
print v(xbgr.mr_n81989776)
print v(xbgr.mr_n81989888)
print v(xbgr.mr_n81990208)
print v(xbgr.mr_n81990320)
print v(xbgr.mr_n81990640)
print v(xbgr.mr_n81990752)
print v(xbgr.mr_n81991072)
print v(xbgr.mr_n81991184)
print v(xbgr.mr_n81991504)
print v(xbgr.mr_n81991616)
print v(xbgr.mr_n81991936)
print v(xbgr.mr_n81992048)
print v(xbgr.mr_n81992368)
print v(xbgr.mr_n81992480)
print v(xbgr.mr_n81992800)
print v(xbgr.mr_n81992912)
print v(xbgr.mr_n81993232)
print v(xbgr.mr_n81993344)
print v(xbgr.mr_n81993664)
print v(xbgr.mr_n81993776)
print v(xbgr.mr_n81994096)
print v(xbgr.mr_n81994208)
print v(xbgr.mr_n81994528)
print v(xbgr.mr_n81994640)
print v(xbgr.mr_n81994960)
print v(xbgr.mr_n81995072)
print v(xbgr.mr_n81995392)
print v(xbgr.mr_n81995504)
print v(xbgr.mr_n81995824)
print v(xbgr.mr_n81995936)
print v(xbgr.mr_n81996256)
print v(xbgr.mr_n81996368)
print v(xbgr.mr_n81996688)
print v(xbgr.mr_n81996800)
print v(xbgr.mr_n81997120)
print v(xbgr.mr_n81997232)
print v(xbgr.mr_n81997552)
print v(xbgr.mr_n81997664)
print v(xbgr.mr_n81997984)
print v(xbgr.mr_n81998096)
print v(xbgr.mr_n81998416)
print v(xbgr.mr_n81998528)
print v(xbgr.mr_n81998848)
print v(xbgr.mr_n81998960)
print v(xbgr.mr_n81999280)
print v(xbgr.mr_n81999392)
print v(xbgr.mr_n81999712)
print v(xbgr.mr_n81999824)
print v(xbgr.mr_n82000144)
print v(xbgr.mr_n82000256)
print v(xbgr.mr_n82000576)
print v(xbgr.mr_n82000688)
print v(xbgr.mr_n82001008)
print v(xbgr.mr_n82001120)
print v(xbgr.mr_n82001440)
print v(xbgr.mr_n82001552)
print v(xbgr.mr_n82001872)
print v(xbgr.mr_n82001984)
print v(xbgr.mr_n82002304)
print v(xbgr.mr_n82002416)
print v(xbgr.mr_n82002736)
print v(xbgr.mr_n82002848)
print v(xbgr.mr_n82003168)
print v(xbgr.mr_n82003280)
print v(xbgr.mr_n82003600)
print v(xbgr.mr_n82003712)
print v(xbgr.mr_n82004032)
print v(xbgr.mr_n82004144)
print v(xbgr.mr_n82004464)
print v(xbgr.mr_n82004576)
print v(xbgr.mr_n82004896)
print v(xbgr.mr_n82005008)
print v(xbgr.mr_n82005328)
print v(xbgr.mr_n82005440)
print v(xbgr.mr_n82005760)
print v(xbgr.mr_n82005872)
print v(xbgr.mr_n82006192)
print v(xbgr.mr_n82006304)
print v(xbgr.mr_n82006624)
print v(xbgr.mr_n82006736)
print v(xbgr.mr_n82007056)
print v(xbgr.mr_n82007168)
print v(xbgr.mr_n82007488)
print v(xbgr.mr_n82007600)
print v(xbgr.mr_n82007920)
print v(xbgr.mr_n82008032)
print v(xbgr.mr_n82008352)
print v(xbgr.mr_n82008464)
print v(xbgr.mr_n82008784)
print v(xbgr.mr_n82008896)
print v(xbgr.mr_n82009216)
print v(xbgr.mr_n82009328)
print v(xbgr.mr_n82009648)
print v(xbgr.mr_n82009760)
print v(xbgr.mr_n82010080)
print v(xbgr.mr_n82010192)
print v(xbgr.mr_n82010512)
print v(xbgr.mr_n82010624)
print v(xbgr.mr_n82010944)
print v(xbgr.mr_n82011056)
print v(xbgr.mr_n82011376)
print v(xbgr.mr_n82011488)
print v(xbgr.mr_n82011808)
print v(xbgr.mr_n82011920)
print v(xbgr.mr_n82012240)
print v(xbgr.mr_n82012352)
print v(xbgr.mr_n82012672)
print v(xbgr.mr_n82012784)
print v(xbgr.mr_n82013104)
print v(xbgr.mr_n82013216)
print v(xbgr.mr_n82013536)
print v(xbgr.mr_n82013648)
print v(xbgr.mr_n82013968)
print v(xbgr.mr_n82014080)
print v(xbgr.mr_n82014400)
print v(xbgr.mr_n82014512)
print v(xbgr.mr_n82014832)
print v(xbgr.mr_n82014944)
print v(xbgr.mr_n82015264)
print v(xbgr.mr_n82015376)
print v(xbgr.mr_n82015696)
print v(xbgr.mr_n82015808)
print v(xbgr.mr_n82016128)
print v(xbgr.mr_n82016240)
print v(xbgr.mr_n82016560)
print v(xbgr.mr_n82016672)
print v(xbgr.mr_n82016992)
print v(xbgr.mr_n82017104)
print v(xbgr.mr_n82017424)
print v(xbgr.mr_n82017536)
print v(xbgr.mr_n82017856)
print v(xbgr.mr_n82017968)
print v(xbgr.mr_n82018288)
print v(xbgr.mr_n82018400)
print v(xbgr.mr_n82018720)
print v(xbgr.mr_n82018832)
print v(xbgr.mr_n82019152)
print v(xbgr.mr_n82019264)
print v(xbgr.mr_n82019584)
print v(xbgr.mr_n82019696)
print v(xbgr.mr_n82020016)
print v(xbgr.mr_n82020128)
print v(xbgr.mr_n82020448)
print v(xbgr.mr_n82020560)
print v(xbgr.mr_n82020880)
print v(xbgr.mr_n82020992)
print v(xbgr.mr_n82021312)
print v(xbgr.mr_n82021424)
print v(xbgr.mr_n82021744)
print v(xbgr.mr_n82021856)
print v(xbgr.mr_n82022176)
print v(xbgr.mr_n82022288)
print v(xbgr.mr_n82022608)
print v(xbgr.mr_n82022720)
print v(xbgr.mr_n82023040)
print v(xbgr.mr_n82023152)
print v(xbgr.mr_n82023472)
print v(xbgr.mr_n82023584)
print v(xbgr.mr_n82023904)
print v(xbgr.mr_n82024016)
print v(xbgr.mr_n82024336)
print v(xbgr.mr_n82024448)
print v(xbgr.mr_n82024768)
print v(xbgr.mr_n82024880)
print v(xbgr.mr_n82025200)
print v(xbgr.mr_n82025312)
print v(xbgr.mr_n82025632)
print v(xbgr.mr_n82025744)
print v(xbgr.mr_n82026064)
print v(xbgr.mr_n82026176)
print v(xbgr.mr_n82026496)
print v(xbgr.mr_n82026608)
print v(xbgr.mr_n82026928)
print v(xbgr.mr_n82027040)
print v(xbgr.mr_n82027360)
print v(xbgr.mr_n82027472)
print v(xbgr.mr_n82027792)
print v(xbgr.mr_n82027904)
print v(xbgr.mr_n82028224)
print v(xbgr.mr_n82028336)
print v(xbgr.mr_n82028656)
print v(xbgr.mr_n82028768)
print v(xbgr.mr_n82029088)
print v(xbgr.mr_n82029200)
print v(xbgr.mr_n82029520)
print v(xbgr.mr_n82029632)
print v(xbgr.mr_n82029952)
print v(xbgr.mr_n82030064)
print v(xbgr.mr_n82030384)
print v(xbgr.mr_n82030496)
print v(xbgr.mr_n82030816)
print v(xbgr.mr_n82030928)
print v(xbgr.mr_n82031248)
print v(xbgr.mr_n82031360)
print v(xbgr.mr_n82031680)
print v(xbgr.mr_n82031792)
print v(xbgr.mr_n82032112)
print v(xbgr.mr_n82032224)
print v(xbgr.mr_n82032544)
print v(xbgr.mr_n82032656)
print v(xbgr.mr_n82032976)
print v(xbgr.mr_n82033088)
print v(xbgr.mr_n82033408)
print v(xbgr.mr_n82033520)
print v(xbgr.mr_n82033840)
print v(xbgr.mr_n82033952)
print v(xbgr.mr_n82034272)
print v(xbgr.mr_n82034384)
print v(xbgr.mr_n82034704)
print v(xbgr.mr_n82034816)
print v(xbgr.mr_n82035136)
print v(xbgr.mr_n82035248)
print v(xbgr.mr_n82035568)
print v(xbgr.mr_n82035680)
print v(xbgr.mr_n82036000)
print v(xbgr.mr_n82036112)
print v(xbgr.mr_n82036432)
print v(xbgr.mr_n82036544)
print v(xbgr.mr_n82036864)
print v(xbgr.mr_n82036976)
print v(xbgr.mr_n82037296)
print v(xbgr.mr_n82037408)
print v(xbgr.mr_n82037728)
print v(xbgr.mr_n82037840)
print v(xbgr.mr_n82038160)
print v(xbgr.mr_n82038272)
print v(xbgr.mr_n82038592)
print v(xbgr.mr_n82038704)
print v(xbgr.mr_n82039024)
print v(xbgr.mr_n82039136)
print v(xbgr.mr_n82039456)
print v(xbgr.mr_n82039568)
print v(xbgr.mr_n82039888)
print v(xbgr.mr_n82040000)
print v(xbgr.mr_n82040320)
print v(xbgr.mr_n82040432)
print v(xbgr.mr_n82040752)
print v(xbgr.mr_n82040864)
print v(xbgr.mr_n82041184)
print v(xbgr.mr_n82041296)
print v(xbgr.mr_n82041616)
print v(xbgr.mr_n82041728)
print v(xbgr.mr_n82042048)
print v(xbgr.mr_n82042160)
print v(xbgr.mr_n82042480)
print v(xbgr.mr_n82042592)
print v(xbgr.mr_n82042912)
print v(xbgr.mr_n82043024)
print v(xbgr.mr_n82043344)
print v(xbgr.mr_n82043456)
print v(xbgr.mr_n82043776)
print v(xbgr.mr_n82043888)
print v(xbgr.mr_n82044208)
print v(xbgr.mr_n82044320)
print v(xbgr.mr_n82044640)
print v(xbgr.mr_n82044752)
print v(xbgr.mr_n82045072)
print v(xbgr.mr_n82045184)
print v(xbgr.mr_n82045504)
print v(xbgr.mr_n82045616)
print v(xbgr.mr_n82045936)
print v(xbgr.mr_n82046048)
print v(xbgr.mr_n82046368)
print v(xbgr.mr_n82046480)
print v(xbgr.mr_n82046800)
print v(xbgr.mr_n82046912)
print v(xbgr.mr_n82047232)
print v(xbgr.mr_n82047344)
print v(xbgr.mr_n82047664)
print v(xbgr.mr_n82047776)
print v(xbgr.mr_n82048096)
print v(xbgr.mr_n82048208)
print v(xbgr.mr_n82048528)
print v(xbgr.mr_n82048640)
print v(xbgr.mr_n82048960)
print v(xbgr.mr_n82049072)
print v(xbgr.mr_n82049392)
print v(xbgr.mr_n82049504)
print v(xbgr.mr_n82049824)
print v(xbgr.mr_n82049936)
print v(xbgr.mr_n82050256)
print v(xbgr.mr_n82050368)
print v(xbgr.mr_n82050688)
print v(xbgr.mr_n82050800)
print v(xbgr.mr_n82051120)
print v(xbgr.mr_n82051232)
print v(xbgr.mr_n82051552)
print v(xbgr.mr_n82051664)
print v(xbgr.mr_n82051984)
print v(xbgr.mr_n82052096)
print v(xbgr.mr_n82052416)
print v(xbgr.mr_n82052528)
print v(xbgr.mr_n82052848)
print v(xbgr.mr_n82052960)
print v(xbgr.mr_n82053280)
print v(xbgr.mr_n82053392)
print v(xbgr.mr_n82053712)
print v(xbgr.mr_n82053824)
print v(xbgr.mr_n82054144)
print v(xbgr.mr_n82054256)
print v(xbgr.mr_n82054576)
print v(xbgr.mr_n82054688)
print v(xbgr.mr_n82055008)
print v(xbgr.mr_n82055120)
print v(xbgr.mr_n82055552)
print v(xbgr.mr_n82055872)
print v(xbgr.mr_n82055984)
print v(xbgr.mr_n82056304)
print v(xbgr.mr_n82056416)
print v(xbgr.mr_n82056736)
print v(xbgr.mr_n82056848)
print v(xbgr.mr_n82057168)
print v(xbgr.mr_n82057280)
print v(xbgr.mr_n82057600)
print v(xbgr.mr_n82057712)
print v(xbgr.mr_n82058032)
print v(xbgr.mr_n82058144)
print v(xbgr.mr_n82058464)
print v(xbgr.mr_n82058576)
print v(xbgr.mr_n82058896)
print v(xbgr.mr_n82059008)
print v(xbgr.mr_n82059328)
print v(xbgr.mr_n82059440)
print v(xbgr.mr_n82059760)
print v(xbgr.mr_n82059872)
print v(xbgr.mr_n82060192)
print v(xbgr.mr_n82060304)
print v(xbgr.mr_n82060624)
print v(xbgr.mr_n82060736)
print v(xbgr.mr_n82061056)
print v(xbgr.mr_n82061168)
print v(xbgr.mr_n82061600)
print v(xbgr.mr_n82061920)
print v(xbgr.mr_n82062032)
print v(xbgr.mr_n82062352)
print v(xbgr.mr_n82062464)
print v(xbgr.mr_n82062784)
print v(xbgr.mr_n82062896)
print v(xbgr.mr_n82063216)
print v(xbgr.mr_n82063328)
print v(xbgr.mr_n82063648)
print v(xbgr.mr_n82063760)
print v(xbgr.mr_n82064080)
print v(xbgr.mr_n82064192)
print v(xbgr.mr_n82064512)
print v(xbgr.mr_n82064624)
print v(xbgr.mr_n82064944)
print v(xbgr.mr_n82065056)
print v(xbgr.mr_n82065376)
print v(xbgr.mr_n82065488)
print v(xbgr.mr_n82065808)
print v(xbgr.mr_n82065920)
print v(xbgr.mr_n82066240)
print v(xbgr.mr_n82066352)
print v(xbgr.mr_n82066672)
print v(xbgr.mr_n82066784)
print v(xbgr.mr_n82067104)
print v(xbgr.mr_n82067216)
print v(xbgr.mr_n82067536)
print v(xbgr.mr_n82067648)
print v(xbgr.mr_n82067968)
print v(xbgr.mr_n82068080)
print v(xbgr.mr_n82068400)
print v(xbgr.mr_n82068512)
print v(xbgr.mr_n82068832)
print v(xbgr.mr_n82068944)
print v(xbgr.mr_n82069264)
print v(xbgr.mr_n82069376)
print v(xbgr.mr_n82069696)
print v(xbgr.mr_n82069808)
print v(xbgr.mr_n82070128)
print v(xbgr.mr_n82070240)
print v(xbgr.mr_n82070560)
print v(xbgr.mr_n82070672)
print v(xbgr.mr_n82070992)
print v(xbgr.mr_n82071104)
print v(xbgr.mr_n82071424)
print v(xbgr.mr_n82071536)
print v(xbgr.mr_n82071856)
print v(xbgr.mr_n82071968)
print v(xbgr.mr_n82072288)
print v(xbgr.mr_n82072400)
print v(xbgr.mr_n82072720)
print v(xbgr.mr_n82072832)
print v(xbgr.mr_n82073152)
print v(xbgr.mr_n82073264)
print v(xbgr.mr_n82073584)
print v(xbgr.mr_n82073696)
print v(xbgr.mr_n82074016)
print v(xbgr.mr_n82074128)
print v(xbgr.mr_n82074448)
print v(xbgr.mr_n82074560)
print v(xbgr.mr_n82074880)
print v(xbgr.mr_n82074992)
print v(xbgr.mr_n82075312)
print v(xbgr.mr_n82075424)
print v(xbgr.mr_n82075744)
print v(xbgr.mr_n82075856)
print v(xbgr.mr_n82076176)
print v(xbgr.mr_n82076288)
print v(xbgr.mr_n82076608)
print v(xbgr.mr_n82076720)
print v(xbgr.mr_n82077040)
print v(xbgr.mr_n82077152)
print v(xbgr.mr_n82077472)
print v(xbgr.mr_n82077584)
print v(xbgr.mr_n82077904)
print v(xbgr.mr_n82078016)
print v(xbgr.mr_n82078336)
print v(xbgr.mr_n82078448)
print v(xbgr.mr_n82078768)
print v(xbgr.mr_n82078880)
print v(xbgr.mr_n82079200)
print v(xbgr.mr_n82079312)
print v(xbgr.mr_n82079632)
print v(xbgr.mr_n82079744)
print v(xbgr.mr_n82080064)
print v(xbgr.mr_n82080176)
print v(xbgr.mr_n82080496)
print v(xbgr.mr_n82080608)
print v(xbgr.mr_n82080928)
print v(xbgr.mr_n82081040)
print v(xbgr.mr_n82081360)
print v(xbgr.mr_n82081472)
print v(xbgr.mr_n82081792)
print v(xbgr.mr_n82081904)
print v(xbgr.mr_n82082224)
print v(xbgr.mr_n82082336)
print v(xbgr.mr_n82082656)
print v(xbgr.mr_n82082768)
print v(xbgr.mr_n82083088)
print v(xbgr.mr_n82083200)
print v(xbgr.mr_n82083520)
print v(xbgr.mr_n82083632)
print v(xbgr.mr_n82083952)
print v(xbgr.mr_n82084064)
print v(xbgr.mr_n82084384)
print v(xbgr.mr_n82084496)
print v(xbgr.mr_n82084816)
print v(xbgr.mr_n82084928)
print v(xbgr.mr_n82085248)
print v(xbgr.mr_n82085360)
print v(xbgr.mr_n82085680)
print v(xbgr.mr_n82085792)
print v(xbgr.mr_n82086112)
print v(xbgr.mr_n82086224)
print v(xbgr.mr_n82086544)
print v(xbgr.mr_n82086656)
print v(xbgr.mr_n82086976)
print v(xbgr.mr_n82087088)
print v(xbgr.mr_n82087408)
print v(xbgr.mr_n82087520)
print v(xbgr.mr_n82087840)
print v(xbgr.mr_n82087952)
print v(xbgr.mr_n82088272)
print v(xbgr.mr_n82088384)
print v(xbgr.mr_n82088704)
print v(xbgr.mr_n82088816)
print v(xbgr.mr_n82089136)
print v(xbgr.mr_n82089248)
print v(xbgr.mr_n82089568)
print v(xbgr.mr_n82089680)
print v(xbgr.mr_n82090000)
print v(xbgr.mr_n82090112)
print v(xbgr.mr_n82090432)
print v(xbgr.mr_n82090544)
print v(xbgr.mr_n82090864)
print v(xbgr.mr_n82090976)
print v(xbgr.mr_n82091296)
print v(xbgr.mr_n82091408)
print v(xbgr.mr_n82091728)
print v(xbgr.mr_n82091840)
print v(xbgr.mr_n82092160)
print v(xbgr.mr_n82092272)
print v(xbgr.mr_n82092592)
print v(xbgr.mr_n82092704)
print v(xbgr.mr_n82093024)
print v(xbgr.mr_n82093136)
print v(xbgr.mr_n82093456)
print v(xbgr.mr_n82093568)
print v(xbgr.mr_n82093888)
print v(xbgr.mr_n82094000)
print v(xbgr.mr_n82094432)
print v(xbgr.mr_n82094752)
print v(xbgr.mr_n82094864)
print v(xbgr.mr_n82095184)
print v(xbgr.mr_n82095296)
print v(xbgr.mr_n82095616)
print v(xbgr.mr_n82095728)
print v(xbgr.mr_n82096160)
print v(xbgr.mr_n82096480)
print v(xbgr.mr_n82096592)
print v(xbgr.mr_n82096912)
print v(xbgr.mr_n82097024)
print v(xbgr.mr_n82097344)
print v(xbgr.mr_n82097456)
print v(xbgr.mr_n82097888)
print v(xbgr.mr_n82098208)
print v(xbgr.mr_n82098320)
print v(xbgr.mr_n82098640)
print v(xbgr.mr_n82098752)
print v(xbgr.mr_n82099072)
print v(xbgr.mr_n82099184)
print v(xbgr.mr_n82099504)
print v(xbgr.mr_n82099616)
print v(xbgr.mr_n82099936)
print v(xbgr.mr_n82100048)
print v(xbgr.mr_n82100368)
print v(xbgr.mr_n82100480)
print v(xbgr.mr_n82100800)
print v(xbgr.mr_n82100912)
print v(xbgr.mr_n82101232)
print v(xbgr.mr_n82101344)
print v(xbgr.mr_n82101664)
print v(xbgr.mr_n82101776)
print v(xbgr.mr_n82102096)
print v(xbgr.mr_n82102208)
print v(xbgr.mr_n82102528)
print v(xbgr.mr_n82102640)
print v(xbgr.mr_n82102960)
print v(xbgr.mr_n82103072)
print v(xbgr.mr_n82103392)
print v(xbgr.mr_n82103504)
print v(xbgr.mr_n82103824)
print v(xbgr.mr_n82103936)
print v(xbgr.mr_n82104256)
print v(xbgr.mr_n82104368)
print v(xbgr.mr_n82104688)
print v(xbgr.mr_n82104800)
print v(xbgr.mr_n82105120)
print v(xbgr.mr_n82105232)
print v(xbgr.mr_n82105552)
print v(xbgr.mr_n82105664)
print v(xbgr.mr_n82105984)
print v(xbgr.mr_n82106096)
print v(xbgr.mr_n82106416)
print v(xbgr.mr_n82106528)
print v(xbgr.mr_n82106848)
print v(xbgr.mr_n82106960)
print v(xbgr.mr_n82107280)
print v(xbgr.mr_n82107392)
print v(xbgr.mr_n82107712)
print v(xbgr.mr_n82107824)
print v(xbgr.mr_n82108144)
print v(xbgr.mr_n82108256)
print v(xbgr.mr_n82108576)
print v(xbgr.mr_n82108688)
print v(xbgr.mr_n82109008)
print v(xbgr.mr_n82109120)
print v(xbgr.mr_n82109440)
print v(xbgr.mr_n82109552)
print v(xbgr.mr_n82109872)
print v(xbgr.mr_n82109984)
print v(xbgr.mr_n82110304)
print v(xbgr.mr_n82110416)
print v(xbgr.mr_n82110736)
print v(xbgr.mr_n82110848)
print v(xbgr.mr_n82111168)
print v(xbgr.mr_n82111280)
print v(xbgr.mr_n82111600)
print v(xbgr.mr_n82111712)
print v(xbgr.mr_n82112032)
print v(xbgr.mr_n82112144)
print v(xbgr.mr_n82112464)
print v(xbgr.mr_n82112576)
print v(xbgr.mr_n82112896)
print v(xbgr.mr_n82113008)
print v(xbgr.mr_n82113328)
print v(xbgr.mr_n82113440)
print v(xbgr.mr_n82113760)
print v(xbgr.mr_n82113872)
print v(xbgr.mr_n82114192)
print v(xbgr.mr_n82114304)
print v(xbgr.mr_n82114624)
print v(xbgr.mr_n82114736)
print v(xbgr.mr_n82115056)
print v(xbgr.mr_n82115168)
print v(xbgr.mr_n82115488)
print v(xbgr.mr_n82115600)
print v(xbgr.mr_n82115920)
print v(xbgr.mr_n82116032)
print v(xbgr.mr_n82116352)
print v(xbgr.mr_n82116464)
print v(xbgr.mr_n82116784)
print v(xbgr.mr_n82116896)
print v(xbgr.mr_n82117216)
print v(xbgr.mr_n82117328)
print v(xbgr.mr_n82117648)
print v(xbgr.mr_n82117760)
print v(xbgr.mr_n82118192)
print v(xbgr.mr_n82118624)
print v(xbgr.mr_n82119056)
print v(xbgr.mr_n82119488)
print v(xbgr.mr_n82119920)
print v(xbgr.mr_n82120352)
print v(xbgr.mr_n82120784)
print v(xbgr.mr_n82121216)
print v(xbgr.mr_n82121648)
print v(xbgr.mr_n82122080)
print v(xbgr.mr_n82122512)
print v(xbgr.mr_n82122944)
print v(xbgr.mr_n82123376)
print v(xbgr.mr_n82123808)
print v(xbgr.mr_n82124240)
print v(xbgr.mr_n82124672)
print v(xbgr.mr_n82125104)
print v(xbgr.mr_n82125536)
print v(xbgr.mr_n82125968)
print v(xbgr.mr_n82126400)
print v(xbgr.mr_n82126832)
print v(xbgr.mr_n82127264)
print v(xbgr.mr_n82127696)
print v(xbgr.mr_n82128128)
print v(xbgr.mr_n82128560)
print v(xbgr.mr_n82128992)
print v(xbgr.mr_n82129424)
print v(xbgr.mr_n82129856)
print v(xbgr.mr_n82130288)
print v(xbgr.mr_n82130720)
print v(xbgr.mr_n82131152)
print v(xbgr.mr_n82131584)
print v(xbgr.mr_n82132016)
print v(xbgr.mr_n82132448)
print v(xbgr.mr_n82132880)
print v(xbgr.mr_n82133312)
print v(xbgr.mr_n82133744)
print v(xbgr.mr_n82134176)
print v(xbgr.mr_n82134608)
print v(xbgr.mr_n82135040)
print v(xbgr.mr_n82135472)
print v(xbgr.mr_n82135904)
print v(xbgr.mr_n82136336)
print v(xbgr.mr_n82136768)
print v(xbgr.mr_n82137200)
print v(xbgr.mr_n82137632)
print v(xbgr.mr_n82138064)
print v(xbgr.mr_n82138496)
print v(xbgr.mr_n82138928)
print v(xbgr.mr_n82139360)
print v(xbgr.mr_n82139792)
print v(xbgr.mr_n82140224)
print v(xbgr.mr_n82140656)
print v(xbgr.mr_n82141088)
print v(xbgr.mr_n82141520)
print v(xbgr.mr_n82141952)
print v(xbgr.mr_n82142384)
print v(xbgr.mr_n82142816)
print v(xbgr.mr_n82143248)
print v(xbgr.mr_n82143680)
print v(xbgr.mr_n82144112)
print v(xbgr.mr_n82144544)
print v(xbgr.mr_n82144976)
print v(xbgr.mr_n82145408)
print v(xbgr.mr_n82145840)
print v(xbgr.mr_n82146272)
print v(xbgr.mr_n82146704)
print v(xbgr.mr_n82147136)
print v(xbgr.mr_n82147568)
print v(xbgr.mr_n82148000)
print v(xbgr.mr_n82148432)
print v(xbgr.mr_n82148864)
print v(xbgr.mr_n82149296)
print v(xbgr.mr_n82149728)
print v(xbgr.mr_n82150160)
print v(xbgr.mr_n82150592)
print v(xbgr.mr_n82151024)
print v(xbgr.mr_n82151456)
print v(xbgr.mr_n82151888)
print v(xbgr.mr_n82152320)
print v(xbgr.mr_n82152640)
print v(xbgr.mr_n82152752)
print v(xbgr.mr_n82153184)
print v(xbgr.mr_n82153504)
print v(xbgr.mr_n82153616)
print v(xbgr.mr_n82153936)
print v(xbgr.mr_n82154048)
print v(xbgr.mr_n82154368)
print v(xbgr.mr_n82154480)
print v(xbgr.mr_n82154800)
print v(xbgr.mr_n82154912)
print v(xbgr.mr_n82155232)
print v(xbgr.mr_n82155344)
print v(xbgr.mr_n82155664)
print v(xbgr.mr_n82155776)
print v(xbgr.mr_n82156096)
print v(xbgr.mr_n82156208)
print v(xbgr.mr_n82156528)
print v(xbgr.mr_n82156640)
print v(xbgr.mr_n82156960)
print v(xbgr.mr_n82157072)
print v(xbgr.mr_n82157392)
print v(xbgr.mr_n82157504)
print v(xbgr.mr_n82157936)
print v(xbgr.mr_n82158368)
print v(xbgr.mr_n82158800)
print v(xbgr.mr_n82159232)
print v(xbgr.mr_n82159664)
print v(xbgr.mr_n82160096)
print v(xbgr.mr_n82160528)
print v(xbgr.mr_n82160960)
print v(xbgr.mr_n82161392)
print v(xbgr.mr_n82161824)
print v(xbgr.mr_n82162256)
print v(xbgr.mr_n82162688)
print v(xbgr.mr_n82163120)
print v(xbgr.mr_n82163552)
print v(xbgr.mr_n82163984)
print v(xbgr.mr_n82164416)
print v(xbgr.mr_n82164848)
print v(xbgr.mr_n82165280)
print v(xbgr.mr_n82165712)
print v(xbgr.mr_n82166144)
print v(xbgr.mr_n82166576)
print v(xbgr.mr_n82167008)
print v(xbgr.mr_n82167440)
print v(xbgr.mr_n82167872)
print v(xbgr.mr_n82168304)
print v(xbgr.mr_n82168736)
print v(xbgr.mr_n82169168)
print v(xbgr.mr_n82169440)
print v(xbgr.mr_n82169552)
print v(xbgr.mr_n82169872)
print v(xbgr.mr_n82169984)
print v(xbgr.mr_n82170304)
print v(xbgr.mr_n82170416)
print v(xbgr.mr_n82170736)
print v(xbgr.mr_n82170848)
print v(xbgr.mr_n82171168)
print v(xbgr.mr_n82171280)
print v(xbgr.mr_n82171600)
print v(xbgr.mr_n82171712)
print v(xbgr.mr_n82172032)
print v(xbgr.mr_n82172144)
print v(xbgr.mr_n82172464)
print v(xbgr.mr_n82172576)
print v(xbgr.mr_n82172896)
print v(xbgr.mr_n82173008)
print v(xbgr.mr_n82173328)
print v(xbgr.mr_n82173440)
print v(xbgr.mr_n82173760)
print v(xbgr.mr_n82173872)
print v(xbgr.mr_n82174192)
print v(xbgr.mr_n82174304)
print v(xbgr.mr_n82174624)
print v(xbgr.mr_n82174736)
print v(xbgr.mr_n82175056)
print v(xbgr.mr_n82175168)
print v(xbgr.mr_n82175488)
print v(xbgr.mr_n82175600)
print v(xbgr.mr_n82175920)
print v(xbgr.mr_n82176032)
print v(xbgr.mr_n82176352)
print v(xbgr.mr_n82176464)
print v(xbgr.mr_n82176784)
print v(xbgr.mr_n82176896)
print v(xbgr.mr_n82177216)
print v(xbgr.mr_n82177328)
print v(xbgr.mr_n82177648)
print v(xbgr.mr_n82177760)
print v(xbgr.mr_n82178080)
print v(xbgr.mr_n82178192)
print v(xbgr.mr_n82178512)
print v(xbgr.mr_n82178624)
print v(xbgr.mr_n82178944)
print v(xbgr.mr_n82179056)
print v(xbgr.mr_n82179376)
print v(xbgr.mr_n82179488)
print v(xbgr.mr_n82179808)
print v(xbgr.mr_n82179920)
print v(xbgr.mr_n82180240)
print v(xbgr.mr_n82180352)
print v(xbgr.mr_n82180672)
print v(xbgr.mr_n82180784)
print v(xbgr.mr_n82181104)
print v(xbgr.mr_n82181216)
print v(xbgr.mr_n82181536)
print v(xbgr.mr_n82181648)
print v(xbgr.mr_n82181968)
print v(xbgr.mr_n82182080)
print v(xbgr.mr_n82182400)
print v(xbgr.mr_n82182512)
print v(xbgr.mr_n82182832)
print v(xbgr.mr_n82182944)
print v(xbgr.mr_n82183264)
print v(xbgr.mr_n82183376)
print v(xbgr.mr_n82183696)
print v(xbgr.mr_n82183808)
print v(xbgr.mr_n82184128)
print v(xbgr.mr_n82184240)
print v(xbgr.mr_n82184560)
print v(xbgr.mr_n82184672)
print v(xbgr.mr_n82184992)
print v(xbgr.mr_n82185104)
print v(xbgr.mr_n82185424)
print v(xbgr.mr_n82185536)
print v(xbgr.mr_n82185856)
print v(xbgr.mr_n82185968)
print v(xbgr.mr_n82186288)
print v(xbgr.mr_n82186400)
print v(xbgr.mr_n82186720)
print v(xbgr.mr_n82186832)
print v(xbgr.mr_n82187152)
print v(xbgr.mr_n82187264)
print v(xbgr.mr_n82187584)
print v(xbgr.mr_n82187696)
print v(xbgr.mr_n82188016)
print v(xbgr.mr_n82188128)
print v(xbgr.mr_n82188448)
print v(xbgr.mr_n82188560)
print v(xbgr.mr_n82188880)
print v(xbgr.mr_n82188992)
print v(xbgr.mr_n82189312)
print v(xbgr.mr_n82189424)
print v(xbgr.mr_n82189744)
print v(xbgr.mr_n82189856)
print v(xbgr.mr_n82190176)
print v(xbgr.mr_n82190288)
print v(xbgr.mr_n82190608)
print v(xbgr.mr_n82190720)
print v(xbgr.mr_n82191040)
print v(xbgr.mr_n82191152)
print v(xbgr.mr_n82191472)
print v(xbgr.mr_n82191584)
print v(xbgr.mr_n82191904)
print v(xbgr.mr_n82192016)
print v(xbgr.mr_n82192336)
print v(xbgr.mr_n82192448)
print v(xbgr.mr_n82192768)
print v(xbgr.mr_n82192880)
print v(xbgr.mr_n82193200)
print v(xbgr.mr_n82193312)
print v(xbgr.mr_n82193632)
print v(xbgr.mr_n82193744)
print v(xbgr.mr_n82194064)
print v(xbgr.mr_n82194176)
print v(xbgr.mr_n82194496)
print v(xbgr.mr_n82194608)
print v(xbgr.mr_n82194928)
print v(xbgr.mr_n82195040)
print v(xbgr.mr_n82195360)
print v(xbgr.mr_n82195472)
print v(xbgr.mr_n82195792)
print v(xbgr.mr_n82195904)
print v(xbgr.mr_n82196224)
print v(xbgr.mr_n82196336)
print v(xbgr.mr_n82196656)
print v(xbgr.mr_n82196768)
print v(xbgr.mr_n82197088)
print v(xbgr.mr_n82197200)
print v(xbgr.mr_n82197520)
print v(xbgr.mr_n82197632)
print v(xbgr.mr_n82197952)
print v(xbgr.mr_n82198064)
print v(xbgr.mr_n82198384)
print v(xbgr.mr_n82198496)
print v(xbgr.mr_n82198816)
print v(xbgr.mr_n82198928)
print v(xbgr.mr_n82199248)
print v(xbgr.mr_n82199360)
print v(xbgr.mr_n82199680)
print v(xbgr.mr_n82199792)
print v(xbgr.mr_n82200112)
print v(xbgr.mr_n82200224)
print v(xbgr.mr_n82200544)
print v(xbgr.mr_n82200656)
print v(xbgr.mr_n82200976)
print v(xbgr.mr_n82201088)
print v(xbgr.mr_n82201408)
print v(xbgr.mr_n82201520)
print v(xbgr.mr_n82201840)
print v(xbgr.mr_n82201952)
print v(xbgr.mr_n82202272)
print v(xbgr.mr_n82202384)
print v(xbgr.mr_n82202704)
print v(xbgr.mr_n82202816)
print v(xbgr.mr_n82203136)
print v(xbgr.mr_n82203248)
print v(xbgr.mr_n82203568)
print v(xbgr.mr_n82203680)
print v(xbgr.mr_n82204000)
print v(xbgr.mr_n82204112)
print v(xbgr.mr_n82204432)
print v(xbgr.mr_n82204544)
print v(xbgr.mr_n82204864)
print v(xbgr.mr_n82204976)
print v(xbgr.mr_n82205296)
print v(xbgr.mr_n82205408)
print v(xbgr.mr_n82205728)
print v(xbgr.mr_n82205840)
print v(xbgr.mr_n82206160)
print v(xbgr.mr_n82206272)
print v(xbgr.mr_n82206592)
print v(xbgr.mr_n82206704)
print v(xbgr.mr_n82207024)
print v(xbgr.mr_n82207136)
print v(xbgr.mr_n82207456)
print v(xbgr.mr_n82207568)
print v(xbgr.mr_n82207888)
print v(xbgr.mr_n82208000)
print v(xbgr.mr_n82208320)
print v(xbgr.mr_n82208432)
print v(xbgr.mr_n82208752)
print v(xbgr.mr_n82208864)
print v(xbgr.mr_n82209184)
print v(xbgr.mr_n82209296)
print v(xbgr.mr_n82209616)
print v(xbgr.mr_n82209728)
print v(xbgr.mr_n82210048)
print v(xbgr.mr_n82210160)
print v(xbgr.mr_n82210480)
print v(xbgr.mr_n82210592)
print v(xbgr.mr_n82210912)
print v(xbgr.mr_n82211024)
print v(xbgr.mr_n82211344)
print v(xbgr.mr_n82211456)
print v(xbgr.mr_n82211776)
print v(xbgr.mr_n82211888)
print v(xbgr.mr_n82212208)
print v(xbgr.mr_n82212320)
print v(xbgr.mr_n82212640)
print v(xbgr.mr_n82212752)
print v(xbgr.mr_n82213072)
print v(xbgr.mr_n82213184)
print v(xbgr.mr_n82213504)
print v(xbgr.mr_n82213616)
print v(xbgr.mr_n82213936)
print v(xbgr.mr_n82214048)
print v(xbgr.mr_n82214368)
print v(xbgr.mr_n82214480)
print v(xbgr.mr_n82214800)
print v(xbgr.mr_n82214912)
print v(xbgr.mr_n82215232)
print v(xbgr.mr_n82215344)
print v(xbgr.mr_n82215664)
print v(xbgr.mr_n82215776)
print v(xbgr.mr_n82216096)
print v(xbgr.mr_n82216208)
print v(xbgr.mr_n82216528)
print v(xbgr.mr_n82216640)
print v(xbgr.mr_n82216960)
print v(xbgr.mr_n82217072)
print v(xbgr.mr_n82217392)
print v(xbgr.mr_n82217504)
print v(xbgr.mr_n82217824)
print v(xbgr.mr_n82217936)
print v(xbgr.mr_n82218256)
print v(xbgr.mr_n82218368)
print v(xbgr.mr_n82218688)
print v(xbgr.mr_n82218800)
print v(xbgr.mr_n82219120)
print v(xbgr.mr_n82219232)
print v(xbgr.mr_n82219552)
print v(xbgr.mr_n82219664)
print v(xbgr.mr_n82219984)
print v(xbgr.mr_n82220096)
print v(xbgr.mr_n82220416)
print v(xbgr.mr_n82220528)
print v(xbgr.mr_n82220848)
print v(xbgr.mr_n82220960)
print v(xbgr.mr_n82221280)
print v(xbgr.mr_n82221392)
print v(xbgr.mr_n82221712)
print v(xbgr.mr_n82221824)
print v(xbgr.mr_n82222144)
print v(xbgr.mr_n82222256)
print v(xbgr.mr_n82222576)
print v(xbgr.mr_n82222688)
print v(xbgr.mr_n82223008)
print v(xbgr.mr_n82223120)
print v(xbgr.mr_n82223440)
print v(xbgr.mr_n82223552)
print v(xbgr.mr_n82223872)
print v(xbgr.mr_n82223984)
print v(xbgr.mr_n82224304)
print v(xbgr.mr_n82224416)
print v(xbgr.mr_n82224736)
print v(xbgr.mr_n82224848)
print v(xbgr.mr_n82225168)
print v(xbgr.mr_n82225280)
print v(xbgr.mr_n82225600)
print v(xbgr.mr_n82225712)
print v(xbgr.mr_n82226032)
print v(xbgr.mr_n82226144)
print v(xbgr.mr_n82226464)
print v(xbgr.mr_n82226576)
print v(xbgr.mr_n82226896)
print v(xbgr.mr_n82227008)
print v(xbgr.mr_n82227328)
print v(xbgr.mr_n82227440)
print v(xbgr.mr_n82227760)
print v(xbgr.mr_n82227872)
print v(xbgr.mr_n82228192)
print v(xbgr.mr_n82228304)
print v(xbgr.mr_n82228624)
print v(xbgr.mr_n82228736)
print v(xbgr.mr_n82229056)
print v(xbgr.mr_n82229168)
print v(xbgr.mr_n82229488)
print v(xbgr.mr_n82229600)
print v(xbgr.mr_n82229920)
print v(xbgr.mr_n82230032)
print v(xbgr.mr_n82230352)
print v(xbgr.mr_n82230464)
print v(xbgr.mr_n82230784)
print v(xbgr.mr_n82230896)
print v(xbgr.mr_n82231216)
print v(xbgr.mr_n82231328)
print v(xbgr.mr_n82231648)
print v(xbgr.mr_n82231760)
print v(xbgr.mr_n82232080)
print v(xbgr.mr_n82232192)
print v(xbgr.mr_n82232512)
print v(xbgr.mr_n82232624)
print v(xbgr.mr_n82232944)
print v(xbgr.mr_n82233056)
print v(xbgr.mr_n82233376)
print v(xbgr.mr_n82233488)
print v(xbgr.mr_n82233808)
print v(xbgr.mr_n82233920)
print v(xbgr.mr_n82234240)
print v(xbgr.mr_n82234352)
print v(xbgr.mr_n82234672)
print v(xbgr.mr_n82234784)
print v(xbgr.mr_n82235104)
print v(xbgr.mr_n82235216)
print v(xbgr.mr_n82235536)
print v(xbgr.mr_n82235648)
print v(xbgr.mr_n82235968)
print v(xbgr.mr_n82236080)
print v(xbgr.mr_n82236400)
print v(xbgr.mr_n82236512)
print v(xbgr.mr_n82236832)
print v(xbgr.mr_n82236944)
print v(xbgr.mr_n82237264)
print v(xbgr.mr_n82237376)
print v(xbgr.mr_n82237696)
print v(xbgr.mr_n82237808)
print v(xbgr.mr_n82238128)
print v(xbgr.mr_n82238240)
print v(xbgr.mr_n82238560)
print v(xbgr.mr_n82238672)
print v(xbgr.mr_n82238992)
print v(xbgr.mr_n82239104)
print v(xbgr.mr_n82239424)
print v(xbgr.mr_n82239536)
print v(xbgr.mr_n82239856)
print v(xbgr.mr_n82239968)
print v(xbgr.mr_n82240288)
print v(xbgr.mr_n82240400)
print v(xbgr.mr_n82240720)
print v(xbgr.mr_n82240832)
print v(xbgr.mr_n82241152)
print v(xbgr.mr_n82241264)
print v(xbgr.mr_n82241584)
print v(xbgr.mr_n82241696)
print v(xbgr.mr_n82242016)
print v(xbgr.mr_n82242128)
print v(xbgr.mr_n82242448)
print v(xbgr.mr_n82242560)
print v(xbgr.mr_n82242880)
print v(xbgr.mr_n82242992)
print v(xbgr.mr_n82243312)
print v(xbgr.mr_n82243424)
print v(xbgr.mr_n82243744)
print v(xbgr.mr_n82243856)
print v(xbgr.mr_n82244176)
print v(xbgr.mr_n82244288)
print v(xbgr.mr_n82244608)
print v(xbgr.mr_n82244720)
print v(xbgr.mr_n82245040)
print v(xbgr.mr_n82245152)
print v(xbgr.mr_n82245472)
print v(xbgr.mr_n82245584)
print v(xbgr.mr_n82245904)
print v(xbgr.mr_n82246016)
print v(xbgr.mr_n82246336)
print v(xbgr.mr_n82246448)
print v(xbgr.mr_n82246768)
print v(xbgr.mr_n82246880)
print v(xbgr.mr_n82247200)
print v(xbgr.mr_n82247312)
print v(xbgr.mr_n82247632)
print v(xbgr.mr_n82247744)
print v(xbgr.mr_n82248064)
print v(xbgr.mr_n82248176)
print v(xbgr.mr_n82248496)
print v(xbgr.mr_n82248608)
print v(xbgr.mr_n82248928)
print v(xbgr.mr_n82249040)
print v(xbgr.mr_n82249360)
print v(xbgr.mr_n82249472)
print v(xbgr.mr_n82249792)
print v(xbgr.mr_n82249904)
print v(xbgr.mr_n82250224)
print v(xbgr.mr_n82250336)
print v(xbgr.mr_n82250656)
print v(xbgr.mr_n82250768)
print v(xbgr.mr_n82251088)
print v(xbgr.mr_n82251200)
print v(xbgr.mr_n82251520)
print v(xbgr.mr_n82251632)
print v(xbgr.mr_n82251952)
print v(xbgr.mr_n82252064)
print v(xbgr.mr_n82252384)
print v(xbgr.mr_n82252496)
print v(xbgr.mr_n82252816)
print v(xbgr.mr_n82252928)
print v(xbgr.mr_n82253248)
print v(xbgr.mr_n82253360)
print v(xbgr.mr_n82253680)
print v(xbgr.mr_n82253792)
print v(xbgr.mr_n82254224)
print v(xbgr.mr_n82254544)
print v(xbgr.mr_n82254656)
print v(xbgr.mr_n82254976)
print v(xbgr.mr_n82255088)
print v(xbgr.mr_n82255408)
print v(xbgr.mr_n82255520)
print v(xbgr.mr_n82255952)
print v(xbgr.mr_n82256272)
print v(xbgr.mr_n82256384)
print v(xbgr.mr_n82256704)
print v(xbgr.mr_n82256816)
print v(xbgr.mr_n82257136)
print v(xbgr.mr_n82257248)
print v(xbgr.mr_n82257680)
print v(xbgr.mr_n82258000)
print v(xbgr.mr_n82258112)
print v(xbgr.mr_n82258432)
print v(xbgr.mr_n82258544)
print v(xbgr.mr_n82258864)
print v(xbgr.mr_n82258976)
print v(xbgr.mr_n82259408)
print v(xbgr.mr_n82259728)
print v(xbgr.mr_n82259840)
print v(xbgr.mr_n82260160)
print v(xbgr.mr_n82260272)
print v(xbgr.mr_n82260592)
print v(xbgr.mr_n82260704)
print v(xbgr.mr_n82261136)
print v(xbgr.mr_n82261456)
print v(xbgr.mr_n82261568)
print v(xbgr.mr_n82261888)
print v(xbgr.mr_n82262000)
print v(xbgr.mr_n82262320)
print v(xbgr.mr_n82262432)
print v(xbgr.mr_n82262864)
print v(xbgr.mr_n82263184)
print v(xbgr.mr_n82263296)
print v(xbgr.mr_n82263616)
print v(xbgr.mr_n82263728)
print v(xbgr.mr_n82264048)
print v(xbgr.mr_n82264160)
print v(xbgr.mr_n82264592)
print v(xbgr.mr_n82264912)
print v(xbgr.mr_n82265024)
print v(xbgr.mr_n82265344)
print v(xbgr.mr_n82265456)
print v(xbgr.mr_n82265776)
print v(xbgr.mr_n82265888)
print v(xbgr.mr_n82266320)
print v(xbgr.mr_n82266640)
print v(xbgr.mr_n82266752)
print v(xbgr.mr_n82267072)
print v(xbgr.mr_n82267184)
print v(xbgr.mr_n82267504)
print v(xbgr.mr_n82267616)
print v(xbgr.mr_n82267936)
print v(xbgr.mr_n82268048)
print v(xbgr.mr_n82268368)
print v(xbgr.mr_n82268480)
print v(xbgr.mr_n82268800)
print v(xbgr.mr_n82268912)
print v(xbgr.mr_n82269232)
print v(xbgr.mr_n82269344)
print v(xbgr.mr_n82269664)
print v(xbgr.mr_n82269776)
print v(xbgr.mr_n82270096)
print v(xbgr.mr_n82270208)
print v(xbgr.mr_n82270528)
print v(xbgr.mr_n82270640)
print v(xbgr.mr_n82270960)
print v(xbgr.mr_n82271072)
print v(xbgr.mr_n82271392)
print v(xbgr.mr_n82271504)
print v(xbgr.mr_n82271824)
print v(xbgr.mr_n82271936)
print v(xbgr.mr_n82272256)
print v(xbgr.mr_n82272368)
print v(xbgr.mr_n82272688)
print v(xbgr.mr_n82272800)
print v(xbgr.mr_n82273120)
print v(xbgr.mr_n82273232)
print v(xbgr.mr_n82273552)
print v(xbgr.mr_n82273664)
print v(xbgr.mr_n82273984)
print v(xbgr.mr_n82274096)
print v(xbgr.mr_n82274416)
print v(xbgr.mr_n82274528)
print v(xbgr.mr_n82274848)
print v(xbgr.mr_n82274960)
print v(xbgr.mr_n82275280)
print v(xbgr.mr_n82275392)
print v(xbgr.mr_n82275712)
print v(xbgr.mr_n82275824)
print v(xbgr.mr_n82276144)
print v(xbgr.mr_n82276256)
print v(xbgr.mr_n82276576)
print v(xbgr.mr_n82276688)
print v(xbgr.mr_n82277008)
print v(xbgr.mr_n82277120)
print v(xbgr.mr_n82277440)
print v(xbgr.mr_n82277552)
print v(xbgr.mr_n82277872)
print v(xbgr.mr_n82277984)
print v(xbgr.mr_n82278304)
print v(xbgr.mr_n82278416)
print v(xbgr.mr_n82278736)
print v(xbgr.mr_n82278848)
print v(xbgr.mr_n82279168)
print v(xbgr.mr_n82279280)
print v(xbgr.mr_n82279600)
print v(xbgr.mr_n82279712)
print v(xbgr.mr_n82280032)
print v(xbgr.mr_n82280144)
print v(xbgr.mr_n82280464)
print v(xbgr.mr_n82280576)
print v(xbgr.mr_n82280896)
print v(xbgr.mr_n82281008)
print v(xbgr.mr_n82281328)
print v(xbgr.mr_n82281440)
print v(xbgr.mr_n82281760)
print v(xbgr.mr_n82281872)
print v(xbgr.mr_n82282192)
print v(xbgr.mr_n82282304)
print v(xbgr.mr_n82282624)
print v(xbgr.mr_n82282736)
print v(xbgr.mr_n82283056)
print v(xbgr.mr_n82283168)
print v(xbgr.mr_n82283488)
print v(xbgr.mr_n82283600)
print v(xbgr.mr_n82283920)
print v(xbgr.mr_n82284032)
print v(xbgr.mr_n82284352)
print v(xbgr.mr_n82284464)
print v(xbgr.mr_n82284784)
print v(xbgr.mr_n82284896)
print v(xbgr.mr_n82285216)
print v(xbgr.mr_n82285328)
print v(xbgr.mr_n82285648)
print v(xbgr.mr_n82285760)
print v(xbgr.mr_n82286080)
print v(xbgr.mr_n82286192)
print v(xbgr.mr_n82286512)
print v(xbgr.mr_n82286624)
print v(xbgr.mr_n82286944)
print v(xbgr.mr_n82287056)
print v(xbgr.mr_n82287376)
print v(xbgr.mr_n82287488)
print v(xbgr.mr_n82287808)
print v(xbgr.mr_n82287920)
print v(xbgr.mr_n82288240)
print v(xbgr.mr_n82288352)
print v(xbgr.mr_n82288672)
print v(xbgr.mr_n82288784)
print v(xbgr.mr_n82289104)
print v(xbgr.mr_n82289216)
print v(xbgr.mr_n82289536)
print v(xbgr.mr_n82289648)
print v(xbgr.mr_n82289968)
print v(xbgr.mr_n82290080)
print v(xbgr.mr_n82290400)
print v(xbgr.mr_n82290512)
print v(xbgr.mr_n82290832)
print v(xbgr.mr_n82290944)
print v(xbgr.mr_n82291264)
print v(xbgr.mr_n82291376)
print v(xbgr.mr_n82291696)
print v(xbgr.mr_n82291808)
print v(xbgr.mr_n82292128)
print v(xbgr.mr_n82292240)
print v(xbgr.mr_n82292560)
print v(xbgr.mr_n82292672)
print v(xbgr.mr_n82292992)
print v(xbgr.mr_n82293104)
print v(xbgr.mr_n82293424)
print v(xbgr.mr_n82293536)
print v(xbgr.mr_n82293856)
print v(xbgr.mr_n82293968)
print v(xbgr.mr_n82294288)
print v(xbgr.mr_n82294400)
print v(xbgr.mr_n82294720)
print v(xbgr.mr_n82294832)
print v(xbgr.mr_n82295152)
print v(xbgr.mr_n82295264)
print v(xbgr.mr_n82295584)
print v(xbgr.mr_n82295696)
print v(xbgr.mr_n82296016)
print v(xbgr.mr_n82296128)
print v(xbgr.mr_n82296560)
print v(xbgr.mr_n82296880)
print v(xbgr.mr_n82296992)
print v(xbgr.mr_n82297312)
print v(xbgr.mr_n82297424)
print v(xbgr.mr_n82297744)
print v(xbgr.mr_n82297856)
print v(xbgr.mr_n82298288)
print v(xbgr.mr_n82298608)
print v(xbgr.mr_n82298720)
print v(xbgr.mr_n82299040)
print v(xbgr.mr_n82299152)
print v(xbgr.mr_n82299472)
print v(xbgr.mr_n82299584)
print v(xbgr.mr_n82300016)
print v(xbgr.mr_n82300336)
print v(xbgr.mr_n82300448)
print v(xbgr.mr_n82300768)
print v(xbgr.mr_n82300880)
print v(xbgr.mr_n82301200)
print v(xbgr.mr_n82301312)
print v(xbgr.mr_n82301632)
print v(xbgr.mr_n82301744)
print v(xbgr.mr_n82302064)
print v(xbgr.mr_n82302176)
print v(xbgr.mr_n82302496)
print v(xbgr.mr_n82302608)
print v(xbgr.mr_n82302928)
print v(xbgr.mr_n82303040)
print v(xbgr.mr_n82303360)
print v(xbgr.mr_n82303472)
print v(xbgr.mr_n82303792)
print v(xbgr.mr_n82303904)
print v(xbgr.mr_n82304336)
print v(xbgr.mr_n82304656)
print v(xbgr.mr_n82304768)
print v(xbgr.mr_n82305200)
print v(xbgr.mr_n82305520)
print v(xbgr.mr_n82305632)
print v(xbgr.mr_n82306064)
print v(xbgr.mr_n82306384)
print v(xbgr.mr_n82306496)
print v(xbgr.mr_n82306816)
print v(xbgr.mr_n82306928)
print v(xbgr.mr_n82307248)
print v(xbgr.mr_n82307360)
print v(xbgr.mr_n82307792)
print v(xbgr.mr_n82308112)
print v(xbgr.mr_n82308224)
print v(xbgr.mr_n82308544)
print v(xbgr.mr_n82308656)
print v(xbgr.mr_n82308976)
print v(xbgr.mr_n82309088)
print v(xbgr.mr_n82309408)
print v(xbgr.mr_n82309520)
print v(xbgr.mr_n82309840)
print v(xbgr.mr_n82309952)
print v(xbgr.mr_n82310384)
print v(xbgr.mr_n82310704)
print v(xbgr.mr_n82310816)
print v(xbgr.mr_n82311136)
print v(xbgr.mr_n82311248)
print v(xbgr.mr_n82311568)
print v(xbgr.mr_n82311680)
print v(xbgr.mr_n82312000)
print v(xbgr.mr_n82312112)
print v(xbgr.mr_n82312432)
print v(xbgr.mr_n82312544)
print v(xbgr.mr_n82312864)
print v(xbgr.mr_n82312976)
print v(xbgr.mr_n82313296)
print v(xbgr.mr_n82313408)
print v(xbgr.mr_n82313728)
print v(xbgr.mr_n82313840)
print v(xbgr.mr_n82314160)
print v(xbgr.mr_n82314272)
print v(xbgr.mr_n82314592)
print v(xbgr.mr_n82314704)
print v(xbgr.mr_n82315024)
print v(xbgr.mr_n82315136)
print v(xbgr.mr_n82315456)
print v(xbgr.mr_n82315568)
print v(xbgr.mr_n82315888)
print v(xbgr.mr_n82316000)
print v(xbgr.mr_n82316320)
print v(xbgr.mr_n82316432)
print v(xbgr.mr_n82316752)
print v(xbgr.mr_n82316864)
print v(xbgr.mr_n82317184)
print v(xbgr.mr_n82317296)
print v(xbgr.mr_n82317616)
print v(xbgr.mr_n82317728)
print v(xbgr.mr_n82318048)
print v(xbgr.mr_n82318160)
print v(xbgr.mr_n82318480)
print v(xbgr.mr_n82318592)
print v(xbgr.mr_n82318912)
print v(xbgr.mr_n82319024)
print v(xbgr.mr_n82319344)
print v(xbgr.mr_n82319456)
print v(xbgr.mr_n82319776)
print v(xbgr.mr_n82319888)
print v(xbgr.mr_n82320208)
print v(xbgr.mr_n82320320)
print v(xbgr.mr_n82320640)
print v(xbgr.mr_n82320752)
print v(xbgr.mr_n82321072)
print v(xbgr.mr_n82321184)
print v(xbgr.mr_n82321504)
print v(xbgr.mr_n82321616)
print v(xbgr.mr_n82321936)
print v(xbgr.mr_n82322048)
print v(xbgr.mr_n82322368)
print v(xbgr.mr_n82322480)
print v(xbgr.mr_n82322800)
print v(xbgr.mr_n82322912)
print v(xbgr.mr_n82323232)
print v(xbgr.mr_n82323344)
print v(xbgr.mr_n82323664)
print v(xbgr.mr_n82323776)
print v(xbgr.mr_n82324096)
print v(xbgr.mr_n82324208)
print v(xbgr.mr_n82324528)
print v(xbgr.mr_n82324640)
print v(xbgr.mr_n82324960)
print v(xbgr.mr_n82325072)
print v(xbgr.mr_n82325392)
print v(xbgr.mr_n82325504)
print v(xbgr.mr_n82325824)
print v(xbgr.mr_n82325936)
print v(xbgr.mr_n82326256)
print v(xbgr.mr_n82326368)
print v(xbgr.mr_n82326688)
print v(xbgr.mr_n82326800)
print v(xbgr.mr_n82327120)
print v(xbgr.mr_n82327232)
print v(xbgr.mr_n82327552)
print v(xbgr.mr_n82327664)
print v(xbgr.mr_n82327984)
print v(xbgr.mr_n82328096)
print v(xbgr.mr_n82328416)
print v(xbgr.mr_n82328528)
print v(xbgr.mr_n82328848)
print v(xbgr.mr_n82328960)
print v(xbgr.mr_n82329280)
print v(xbgr.mr_n82329392)
print v(xbgr.mr_n82329712)
print v(xbgr.mr_n82329824)
print v(xbgr.mr_n82330144)
print v(xbgr.mr_n82330256)
print v(xbgr.mr_n82330576)
print v(xbgr.mr_n82330688)
print v(xbgr.mr_n82331008)
print v(xbgr.mr_n82331120)
print v(xbgr.mr_n82331440)
print v(xbgr.mr_n82331552)
print v(xbgr.mr_n82331872)
print v(xbgr.mr_n82331984)
print v(xbgr.mr_n82332304)
print v(xbgr.mr_n82332416)
print v(xbgr.mr_n82332736)
print v(xbgr.mr_n82332848)
print v(xbgr.mr_n82333168)
print v(xbgr.mr_n82333280)
print v(xbgr.mr_n82333600)
print v(xbgr.mr_n82333712)
print v(xbgr.mr_n82334032)
print v(xbgr.mr_n82334144)
print v(xbgr.mr_n82334464)
print v(xbgr.mr_n82334576)
print v(xbgr.mr_n82334896)
print v(xbgr.mr_n82335008)
print v(xbgr.mr_n82335328)
print v(xbgr.mr_n82335440)
print v(xbgr.mr_n82335760)
print v(xbgr.mr_n82335872)
print v(xbgr.mr_n82336192)
print v(xbgr.mr_n82336304)
print v(xbgr.mr_n82336624)
print v(xbgr.mr_n82336736)
print v(xbgr.mr_n82337056)
print v(xbgr.mr_n82337168)
print v(xbgr.mr_n82337488)
print v(xbgr.mr_n82337600)
print v(xbgr.mr_n82337920)
print v(xbgr.mr_n82338032)
print v(xbgr.mr_n82338352)
print v(xbgr.mr_n82338464)
print v(xbgr.mr_n82338784)
print v(xbgr.mr_n82338896)
print v(xbgr.mr_n82339216)
print v(xbgr.mr_n82339328)
print v(xbgr.mr_n82339648)
print v(xbgr.mr_n82339760)
print v(xbgr.mr_n82340080)
print v(xbgr.mr_n82340192)
print v(xbgr.mr_n82340512)
print v(xbgr.mr_n82340624)
print v(xbgr.mr_n82340944)
print v(xbgr.mr_n82341056)
print v(xbgr.mr_n82341376)
print v(xbgr.mr_n82341488)
print v(xbgr.mr_n82341808)
print v(xbgr.mr_n82341920)
print v(xbgr.mr_n82342240)
print v(xbgr.mr_n82342352)
print v(xbgr.mr_n82342672)
print v(xbgr.mr_n82342784)
print v(xbgr.mr_n82343104)
print v(xbgr.mr_n82343216)
print v(xbgr.mr_n82343536)
print v(xbgr.mr_n82343648)
print v(xbgr.mr_n82343968)
print v(xbgr.mr_n82344080)
print v(xbgr.mr_n82344400)
print v(xbgr.mr_n82344512)
print v(xbgr.mr_n82344832)
print v(xbgr.mr_n82344944)
print v(xbgr.mr_n82345264)
print v(xbgr.mr_n82345376)
print v(xbgr.mr_n82345696)
print v(xbgr.mr_n82345808)
print v(xbgr.mr_n82346128)
print v(xbgr.mr_n82346240)
print v(xbgr.mr_n82346560)
print v(xbgr.mr_n82346672)
print v(xbgr.mr_n82346992)
print v(xbgr.mr_n82347104)
print v(xbgr.mr_n82347424)
print v(xbgr.mr_n82347536)
print v(xbgr.mr_n82347856)
print v(xbgr.mr_n82347968)
print v(xbgr.mr_n82348288)
print v(xbgr.mr_n82348400)
print v(xbgr.mr_n82348720)
print v(xbgr.mr_n82348832)
print v(xbgr.mr_n82349152)
print v(xbgr.mr_n82349264)
print v(xbgr.mr_n82349584)
print v(xbgr.mr_n82349696)
print v(xbgr.mr_n82350016)
print v(xbgr.mr_n82350128)
print v(xbgr.mr_n82350448)
print v(xbgr.mr_n82350560)
print v(xbgr.mr_n82350880)
print v(xbgr.mr_n82350992)
print v(xbgr.mr_n82351312)
print v(xbgr.mr_n82351424)
print v(xbgr.mr_n82351744)
print v(xbgr.mr_n82351856)
print v(xbgr.mr_n82352176)
print v(xbgr.mr_n82352288)
print v(xbgr.mr_n82352608)
print v(xbgr.mr_n82352720)
print v(xbgr.mr_n82353040)
print v(xbgr.mr_n82353152)
print v(xbgr.mr_n82353472)
print v(xbgr.mr_n82353584)
print v(xbgr.mr_n82353904)
print v(xbgr.mr_n82354016)
print v(xbgr.mr_n82354336)
print v(xbgr.mr_n82354448)
print v(xbgr.mr_n82354768)
print v(xbgr.mr_n82354880)
print v(xbgr.mr_n82355200)
print v(xbgr.mr_n82355312)
print v(xbgr.mr_n82355632)
print v(xbgr.mr_n82355744)
print v(xbgr.mr_n82356064)
print v(xbgr.mr_n82356176)
print v(xbgr.mr_n82356496)
print v(xbgr.mr_n82356608)
print v(xbgr.mr_n82356928)
print v(xbgr.mr_n82357040)
print v(xbgr.mr_n82357360)
print v(xbgr.mr_n82357472)
print v(xbgr.mr_n82357792)
print v(xbgr.mr_n82357904)
print v(xbgr.mr_n82358224)
print v(xbgr.mr_n82358336)
print v(xbgr.mr_n82358656)
print v(xbgr.mr_n82358768)
print v(xbgr.mr_n82359088)
print v(xbgr.mr_n82359200)
print v(xbgr.mr_n82359520)
print v(xbgr.mr_n82359632)
print v(xbgr.mr_n82359952)
print v(xbgr.mr_n82360064)
print v(xbgr.mr_n82360384)
print v(xbgr.mr_n82360496)
print v(xbgr.mr_n82360816)
print v(xbgr.mr_n82360928)
print v(xbgr.mr_n82361248)
print v(xbgr.mr_n82361360)
print v(xbgr.mr_n82361680)
print v(xbgr.mr_n82361792)
print v(xbgr.mr_n82362112)
print v(xbgr.mr_n82362224)
print v(xbgr.mr_n82362544)
print v(xbgr.mr_n82362656)
print v(xbgr.mr_n82362976)
print v(xbgr.mr_n82363088)
print v(xbgr.mr_n82363408)
print v(xbgr.mr_n82363520)
print v(xbgr.mr_n82363840)
print v(xbgr.mr_n82363952)
print v(xbgr.mr_n82364272)
print v(xbgr.mr_n82364384)
print v(xbgr.mr_n82364704)
print v(xbgr.mr_n82364816)
print v(xbgr.mr_n82365136)
print v(xbgr.mr_n82365248)
print v(xbgr.mr_n82365568)
print v(xbgr.mr_n82365680)
print v(xbgr.mr_n82366000)
print v(xbgr.mr_n82366112)
print v(xbgr.mr_n82366432)
print v(xbgr.mr_n82366544)
print v(xbgr.mr_n82366864)
print v(xbgr.mr_n82366976)
print v(xbgr.mr_n82367296)
print v(xbgr.mr_n82367408)
print v(xbgr.mr_n82367728)
print v(xbgr.mr_n82367840)
print v(xbgr.mr_n82368160)
print v(xbgr.mr_n82368272)
print v(xbgr.mr_n82368592)
print v(xbgr.mr_n82368704)
print v(xbgr.mr_n82369024)
print v(xbgr.mr_n82369136)
print v(xbgr.mr_n82369456)
print v(xbgr.mr_n82369568)
print v(xbgr.mr_n82369888)
print v(xbgr.mr_n82370000)
print v(xbgr.mr_n82370320)
print v(xbgr.mr_n82370432)
print v(xbgr.mr_n82370752)
print v(xbgr.mr_n82370864)
print v(xbgr.mr_n82371184)
print v(xbgr.mr_n82371296)
print v(xbgr.mr_n82371616)
print v(xbgr.mr_n82371728)
print v(xbgr.mr_n82372048)
print v(xbgr.mr_n82372160)
print v(xbgr.mr_n82372480)
print v(xbgr.mr_n82372592)
print v(xbgr.mr_n82372912)
print v(xbgr.mr_n82373024)
print v(xbgr.mr_n82373344)
print v(xbgr.mr_n82373456)
print v(xbgr.mr_n82373776)
print v(xbgr.mr_n82373888)
print v(xbgr.mr_n82374208)
print v(xbgr.mr_n82374320)
print v(xbgr.mr_n82374640)
print v(xbgr.mr_n82374752)
print v(xbgr.mr_n82375072)
print v(xbgr.mr_n82375184)
print v(xbgr.mr_n82375504)
print v(xbgr.mr_n82375616)
print v(xbgr.mr_n82375936)
print v(xbgr.mr_n82376048)
print v(xbgr.mr_n82376368)
print v(xbgr.mr_n82376480)
print v(xbgr.mr_n82376800)
print v(xbgr.mr_n82376912)
print v(xbgr.mr_n82377232)
print v(xbgr.mr_n82377344)
print v(xbgr.mr_n82377664)
print v(xbgr.mr_n82377776)
print v(xbgr.mr_n82378096)
print v(xbgr.mr_n82378208)
print v(xbgr.mr_n82378528)
print v(xbgr.mr_n82378640)
print v(xbgr.mr_n82378960)
print v(xbgr.mr_n82379072)
print v(xbgr.mr_n82379392)
print v(xbgr.mr_n82379504)
print v(xbgr.mr_n82379824)
print v(xbgr.mr_n82379936)
print v(xbgr.mr_n82380256)
print v(xbgr.mr_n82380368)
print v(xbgr.mr_n82380688)
print v(xbgr.mr_n82380800)
print v(xbgr.mr_n82381120)
print v(xbgr.mr_n82381232)
print v(xbgr.mr_n82381552)
print v(xbgr.mr_n82381664)
print v(xbgr.mr_n82381984)
print v(xbgr.mr_n82382096)
print v(xbgr.mr_n82382416)
print v(xbgr.mr_n82382528)
print v(xbgr.mr_n82382848)
print v(xbgr.mr_n82382960)
print v(xbgr.mr_n82383280)
print v(xbgr.mr_n82383392)
print v(xbgr.mr_n82383712)
print v(xbgr.mr_n82383824)
print v(xbgr.mr_n82384144)
print v(xbgr.mr_n82384256)
print v(xbgr.mr_n82384576)
print v(xbgr.mr_n82384688)
print v(xbgr.mr_n82385008)
print v(xbgr.mr_n82385120)
print v(xbgr.mr_n82385552)
print v(xbgr.mr_n82385872)
print v(xbgr.mr_n82385984)
print v(xbgr.mr_n82386416)
print v(xbgr.mr_n82386736)
print v(xbgr.mr_n82386848)
print v(xbgr.mr_n82387280)
print v(xbgr.mr_n82387600)
print v(xbgr.mr_n82388464)
print v(xbgr.mr_n82388576)
print v(xbgr.mr_n82389008)
print v(xbgr.mr_n82389328)
print v(xbgr.mr_n82389440)
print v(xbgr.mr_n82389760)
print v(xbgr.mr_n82389872)
print v(xbgr.mr_n82390192)
print v(xbgr.mr_n82390304)
print v(xbgr.mr_n82390624)
print v(xbgr.mr_n82390736)
print v(xbgr.mr_n82391056)
print v(xbgr.mr_n82391168)
print v(xbgr.mr_n82391488)
print v(xbgr.mr_n82391600)
print v(xbgr.mr_n82391920)
print v(xbgr.mr_n82392032)
print v(xbgr.mr_n82392352)
print v(xbgr.mr_n82392464)
print v(xbgr.mr_n82392784)
print v(xbgr.mr_n82393648)
print v(xbgr.mr_n82394512)
print v(xbgr.mr_n82394624)
print v(xbgr.mr_n82394944)
print v(xbgr.mr_n82395056)
print v(xbgr.mr_n82395376)
print v(xbgr.mr_n82396240)
print v(xbgr.mr_n82396352)
print v(xbgr.mr_n82396672)
print v(xbgr.mr_n82396784)
print v(xbgr.mr_n82397104)
print v(xbgr.mr_n82397216)
print v(xbgr.mr_n82397536)
print v(xbgr.mr_n82397648)
print v(xbgr.mr_n82397968)
print v(xbgr.mr_n82398080)
print v(xbgr.mr_n82398400)
print v(xbgr.mr_n82398512)
print v(xbgr.mr_n82398832)
print v(xbgr.mr_n82398944)
print v(xbgr.mr_n82399264)
print v(xbgr.mr_n82399376)
print v(xbgr.mr_n82399696)
print v(xbgr.mr_n82399808)
print v(xbgr.mr_n82400128)
print v(xbgr.mr_n82400240)
print v(xbgr.mr_n82400560)
print v(xbgr.mr_n82400672)
print v(xbgr.mr_n82400992)
print v(xbgr.mr_n82401104)
print v(xbgr.mr_n82401424)
print v(xbgr.mr_n82401536)
print v(xbgr.mr_n82401856)
print v(xbgr.mr_n82401968)
print v(xbgr.mr_n82402288)
print v(xbgr.mr_n82402400)
print v(xbgr.mr_n82402720)
print v(xbgr.mr_n82402832)
print v(xbgr.mr_n82403152)
print v(xbgr.mr_n82403264)
print v(xbgr.mr_n82403584)
print v(xbgr.mr_n82403696)
print v(xbgr.mr_n82404016)
print v(xbgr.mr_n82404128)
print v(xbgr.mr_n82404448)
print v(xbgr.mr_n82404560)
print v(xbgr.mr_n82404880)
print v(xbgr.mr_n82404992)
print v(xbgr.mr_n82405312)
print v(xbgr.mr_n82405424)
print v(xbgr.mr_n82405744)
print v(xbgr.mr_n82405856)
print v(xbgr.mr_n82406176)
print v(xbgr.mr_n82406288)
print v(xbgr.mr_n82406608)
print v(xbgr.mr_n82406720)
print v(xbgr.mr_n82407152)
print v(xbgr.mr_n82407472)
print v(xbgr.mr_n82407584)
print v(xbgr.mr_n82407904)
print v(xbgr.mr_n82408016)
print v(xbgr.mr_n82408336)
print v(xbgr.mr_n82408448)
print v(xbgr.mr_n82408768)
print v(xbgr.mr_n82408880)
print v(xbgr.mr_n82409200)
print v(xbgr.mr_n82409312)
print v(xbgr.mr_n82409632)
print v(xbgr.mr_n82409744)
print v(xbgr.mr_n82410064)
print v(xbgr.mr_n82410176)
print v(xbgr.mr_n82410496)
print v(xbgr.mr_n82410608)
print v(xbgr.mr_n82410928)
print v(xbgr.mr_n82411040)
print v(xbgr.mr_n82411360)
print v(xbgr.mr_n82411472)
print v(xbgr.mr_n82411792)
print v(xbgr.mr_n82411904)
print v(xbgr.mr_n82412224)
print v(xbgr.mr_n82412336)
print v(xbgr.mr_n82412656)
print v(xbgr.mr_n82412768)
print v(xbgr.mr_n82413088)
print v(xbgr.mr_n82413200)
print v(xbgr.mr_n82413520)
print v(xbgr.mr_n82414384)
print v(xbgr.mr_n82414496)
print v(xbgr.mr_n82414816)
print v(xbgr.mr_n82414928)
print v(xbgr.mr_n82415248)
print v(xbgr.mr_n82415360)
print v(xbgr.mr_n82415680)
print v(xbgr.mr_n82415792)
print v(xbgr.mr_n82416112)
print v(xbgr.mr_n82416224)
print v(xbgr.mr_n82416544)
print v(xbgr.mr_n82416656)
print v(xbgr.mr_n82416976)
print v(xbgr.mr_n82417088)
print v(xbgr.mr_n82417408)
print v(xbgr.mr_n82417520)
print v(xbgr.mr_n82417840)
print v(xbgr.mr_n82417952)
print v(xbgr.mr_n82418272)
print v(xbgr.mr_n82418384)
print v(xbgr.mr_n82418704)
print v(xbgr.mr_n82418816)
print v(xbgr.mr_n82419136)
print v(xbgr.mr_n82419248)
print v(xbgr.mr_n82419568)
print v(xbgr.mr_n82419680)
print v(xbgr.mr_n82420000)
print v(xbgr.mr_n82420112)
print v(xbgr.mr_n82420432)
print v(xbgr.mr_n82420544)
print v(xbgr.mr_n82420864)
print v(xbgr.mr_n82420976)
print v(xbgr.mr_n82421296)
print v(xbgr.mr_n82421408)
print v(xbgr.mr_n82421728)
print v(xbgr.mr_n82421840)
print v(xbgr.mr_n82422160)
print v(xbgr.mr_n82422272)
print v(xbgr.mr_n82422592)
print v(xbgr.mr_n82422704)
print v(xbgr.mr_n82423024)
print v(xbgr.mr_n82423136)
print v(xbgr.mr_n82423456)
print v(xbgr.mr_n82423568)
print v(xbgr.mr_n82423888)
print v(xbgr.mr_n82424000)
print v(xbgr.mr_n82424320)
print v(xbgr.mr_n82424432)
print v(xbgr.mr_n82424752)
print v(xbgr.mr_n82424864)
print v(xbgr.mr_n82425184)
print v(xbgr.mr_n82425296)
print v(xbgr.mr_n82425616)
print v(xbgr.mr_n82425728)
print v(xbgr.mr_n82426048)
print v(xbgr.mr_n82426160)
print v(xbgr.mr_n82426480)
print v(xbgr.mr_n82426592)
print v(xbgr.mr_n82426912)
print v(xbgr.mr_n82427024)
print v(xbgr.mr_n82427344)
print v(xbgr.mr_n82427456)
print v(xbgr.mr_n82427776)
print v(xbgr.mr_n82427888)
print v(xbgr.mr_n82428208)
print v(xbgr.mr_n82428320)
print v(xbgr.mr_n82428640)
print v(xbgr.mr_n82428752)
print v(xbgr.mr_n82429072)
print v(xbgr.mr_n82429184)
print v(xbgr.mr_n82429504)
print v(xbgr.mr_n82429616)
print v(xbgr.mr_n82429936)
print v(xbgr.mr_n82430048)
print v(xbgr.mr_n82430368)
print v(xbgr.mr_n82430480)
print v(xbgr.mr_n82430800)
print v(xbgr.mr_n82430912)
print v(xbgr.mr_n82431232)
print v(xbgr.mr_n82431344)
print v(xbgr.mr_n82431664)
print v(xbgr.mr_n82431776)
print v(xbgr.mr_n82432096)
print v(xbgr.mr_n82432208)
print v(xbgr.mr_n82432528)
print v(xbgr.mr_n82432640)
print v(xbgr.mr_n82432960)
print v(xbgr.mr_n82433072)
print v(xbgr.mr_n82433392)
print v(xbgr.mr_n82433504)
print v(xbgr.mr_n82433824)
print v(xbgr.mr_n82433936)
print v(xbgr.mr_n82434256)
print v(xbgr.mr_n82434368)
print v(xbgr.mr_n82434688)
print v(xbgr.mr_n82434800)
print v(xbgr.mr_n82435120)
print v(xbgr.mr_n82435232)
print v(xbgr.mr_n82435552)
print v(xbgr.mr_n82435664)
print v(xbgr.mr_n82435984)
print v(xbgr.mr_n82436096)
print v(xbgr.mr_n82436416)
print v(xbgr.mr_n82436528)
print v(xbgr.mr_n82436848)
print v(xbgr.mr_n82436960)
print v(xbgr.mr_n82437280)
print v(xbgr.mr_n82437392)
print v(xbgr.mr_n82437712)
print v(xbgr.mr_n82437824)
print v(xbgr.mr_n82438144)
print v(xbgr.mr_n82438256)
print v(xbgr.mr_n82438576)
print v(xbgr.mr_n82438688)
print v(xbgr.mr_n82439008)
print v(xbgr.mr_n82439120)
print v(xbgr.mr_n82439440)
print v(xbgr.mr_n82439552)
print v(xbgr.mr_n82439872)
print v(xbgr.mr_n82439984)
print v(xbgr.mr_n82440304)
print v(xbgr.mr_n82440416)
print v(xbgr.mr_n82440736)
print v(xbgr.mr_n82440848)
print v(xbgr.mr_n82441168)
print v(xbgr.mr_n82441280)
print v(xbgr.mr_n82441600)
print v(xbgr.mr_n82441712)
print v(xbgr.mr_n82442032)
print v(xbgr.mr_n82442144)
print v(xbgr.mr_n82442464)
print v(xbgr.mr_n82442576)
print v(xbgr.mr_n82442896)
print v(xbgr.mr_n82443008)
print v(xbgr.mr_n82443328)
print v(xbgr.mr_n82443440)
print v(xbgr.mr_n82443760)
print v(xbgr.mr_n82443872)
print v(xbgr.mr_n82444192)
print v(xbgr.mr_n82444304)
print v(xbgr.mr_n82444624)
print v(xbgr.mr_n82444736)
print v(xbgr.mr_n82445056)
print v(xbgr.mr_n82445168)
print v(xbgr.mr_n82445488)
print v(xbgr.mr_n82445600)
print v(xbgr.mr_n82445920)
print v(xbgr.mr_n82446032)
print v(xbgr.mr_n82446352)
print v(xbgr.mr_n82446464)
print v(xbgr.mr_n82446784)
print v(xbgr.mr_n82446896)
print v(xbgr.mr_n82447216)
print v(xbgr.mr_n82447328)
print v(xbgr.mr_n82447648)
print v(xbgr.mr_n82447760)
print v(xbgr.mr_n82448080)
print v(xbgr.mr_n82448192)
print v(xbgr.mr_n82448512)
print v(xbgr.mr_n82448624)
print v(xbgr.mr_n82448944)
print v(xbgr.mr_n82449056)
print v(xbgr.mr_n82449376)
print v(xbgr.mr_n82449488)
print v(xbgr.mr_n82449808)
print v(xbgr.mr_n82449920)
print v(xbgr.mr_n82450240)
print v(xbgr.mr_n82450352)
print v(xbgr.mr_n82450672)
print v(xbgr.mr_n82450784)
print v(xbgr.mr_n82451104)
print v(xbgr.mr_n82451216)
print v(xbgr.mr_n82451536)
print v(xbgr.mr_n82451648)
print v(xbgr.mr_n82451968)
print v(xbgr.mr_n82452080)
print v(xbgr.mr_n82452400)
print v(xbgr.mr_n82452512)
print v(xbgr.mr_n82452832)
print v(xbgr.mr_n82452944)
print v(xbgr.mr_n82453264)
print v(xbgr.mr_n82453376)
print v(xbgr.mr_n82453696)
print v(xbgr.mr_n82453808)
print v(xbgr.mr_n82454128)
print v(xbgr.mr_n82454240)
print v(xbgr.mr_n82454560)
print v(xbgr.mr_n82454672)
print v(xbgr.mr_n82454992)
print v(xbgr.mr_n82455104)
print v(xbgr.mr_n82455424)
print v(xbgr.mr_n82455536)
print v(xbgr.mr_n82455856)
print v(xbgr.mr_n82455968)
print v(xbgr.mr_n82456288)
print v(xbgr.mr_n82456400)
print v(xbgr.mr_n82456720)
print v(xbgr.mr_n82456832)
print v(xbgr.mr_n82457152)
print v(xbgr.mr_n82457264)
print v(xbgr.mr_n82457584)
print v(xbgr.mr_n82457696)
print v(xbgr.mr_n82458016)
print v(xbgr.mr_n82458128)
print v(xbgr.mr_n82458448)
print v(xbgr.mr_n82458560)
print v(xbgr.mr_n82458880)
print v(xbgr.mr_n82458992)
print v(xbgr.mr_n82459312)
print v(xbgr.mr_n82459424)
print v(xbgr.mr_n82459744)
print v(xbgr.mr_n82459856)
print v(xbgr.mr_n82460176)
print v(xbgr.mr_n82460288)
print v(xbgr.mr_n82460608)
print v(xbgr.mr_n82460720)
print v(xbgr.mr_n82461040)
print v(xbgr.mr_n82461152)
print v(xbgr.mr_n82461472)
print v(xbgr.mr_n82461584)
print v(xbgr.mr_n82461904)
print v(xbgr.mr_n82462016)
print v(xbgr.mr_n82462336)
print v(xbgr.mr_n82462448)
print v(xbgr.mr_n82462768)
print v(xbgr.mr_n82462880)
print v(xbgr.mr_n82463200)
print v(xbgr.mr_n82463312)
print v(xbgr.mr_n82463632)
print v(xbgr.mr_n82463744)
print v(xbgr.mr_n82464064)
print v(xbgr.mr_n82464176)
print v(xbgr.mr_n82464496)
print v(xbgr.mr_n82464608)
print v(xbgr.mr_n82464928)
print v(xbgr.mr_n82465040)
print v(xbgr.mr_n82465360)
print v(xbgr.mr_n82465472)
print v(xbgr.mr_n82465792)
print v(xbgr.mr_n82465904)
print v(xbgr.mr_n82466224)
print v(xbgr.mr_n82466336)
print v(xbgr.mr_n82466656)
print v(xbgr.mr_n82466768)
print v(xbgr.mr_n82467088)
print v(xbgr.mr_n82467200)
print v(xbgr.mr_n82467520)
print v(xbgr.mr_n82467632)
print v(xbgr.mr_n82467952)
print v(xbgr.mr_n82468064)
print v(xbgr.mr_n82468384)
print v(xbgr.mr_n82468496)
print v(xbgr.mr_n82468816)
print v(xbgr.mr_n82468928)
print v(xbgr.mr_n82469248)
print v(xbgr.mr_n82469360)
print v(xbgr.mr_n82469680)
print v(xbgr.mr_n82469792)
print v(xbgr.mr_n82470112)
print v(xbgr.mr_n82470224)
print v(xbgr.mr_n82470544)
print v(xbgr.mr_n82470656)
print v(xbgr.mr_n82470976)
print v(xbgr.mr_n82471088)
print v(xbgr.mr_n82471408)
print v(xbgr.mr_n82471520)
print v(xbgr.mr_n82471840)
print v(xbgr.mr_n82471952)
print v(xbgr.mr_n82472272)
print v(xbgr.mr_n82472384)
print v(xbgr.mr_n82472704)
print v(xbgr.mr_n82472816)
print v(xbgr.mr_n82473136)
print v(xbgr.mr_n82473248)
print v(xbgr.mr_n82473568)
print v(xbgr.mr_n82473680)
print v(xbgr.mr_n82474000)
print v(xbgr.mr_n82474112)
print v(xbgr.mr_n82474432)
print v(xbgr.mr_n82474544)
print v(xbgr.mr_n82474864)
print v(xbgr.mr_n82474976)
print v(xbgr.mr_n82475296)
print v(xbgr.mr_n82475408)
print v(xbgr.mr_n82475728)
print v(xbgr.mr_n82475840)
print v(xbgr.mr_n82476160)
print v(xbgr.mr_n82476272)
print v(xbgr.mr_n82476592)
print v(xbgr.mr_n82476704)
print v(xbgr.mr_n82477024)
print v(xbgr.mr_n82477136)
print v(xbgr.mr_n82477456)
print v(xbgr.mr_n82477568)
print v(xbgr.mr_n82477888)
print v(xbgr.mr_n82478000)
print v(xbgr.mr_n82478320)
print v(xbgr.mr_n82478432)
print v(xbgr.mr_n82478752)
print v(xbgr.mr_n82478864)
print v(xbgr.mr_n82479184)
print v(xbgr.mr_n82479296)
print v(xbgr.mr_n82479616)
print v(xbgr.mr_n82479728)
print v(xbgr.mr_n82480048)
print v(xbgr.mr_n82480160)
print v(xbgr.mr_n82480480)
print v(xbgr.mr_n82480592)
print v(xbgr.mr_n82480912)
print v(xbgr.mr_n82481024)
print v(xbgr.mr_n82481344)
print v(xbgr.mr_n82481456)
print v(xbgr.mr_n82481776)
print v(xbgr.mr_n82481888)
print v(xbgr.mr_n82482208)
print v(xbgr.mr_n82482320)
print v(xbgr.mr_n82482640)
print v(xbgr.mr_n82482752)
print v(xbgr.mr_n82483072)
print v(xbgr.mr_n82483184)
print v(xbgr.mr_n82483504)
print v(xbgr.mr_n82483616)
print v(xbgr.mr_n82483936)
print v(xbgr.mr_n82484048)
print v(xbgr.mr_n82484368)
print v(xbgr.mr_n82484480)
print v(xbgr.mr_n82484800)
print v(xbgr.mr_n82484912)
print v(xbgr.mr_n82485232)
print v(xbgr.mr_n82485344)
print v(xbgr.mr_n82485664)
print v(xbgr.mr_n82485776)
print v(xbgr.mr_n82486096)
print v(xbgr.mr_n82486208)
print v(xbgr.mr_n82486528)
print v(xbgr.mr_n82486640)
print v(xbgr.mr_n82486960)
print v(xbgr.mr_n82487072)
print v(xbgr.mr_n82487392)
print v(xbgr.mr_n82487504)
print v(xbgr.mr_n82487824)
print v(xbgr.mr_n82487936)
print v(xbgr.mr_n82488256)
print v(xbgr.mr_n82488368)
print v(xbgr.mr_n82488688)
print v(xbgr.mr_n82488800)
print v(xbgr.mr_n82489120)
print v(xbgr.mr_n82489232)
print v(xbgr.mr_n82489552)
print v(xbgr.mr_n82489664)
print v(xbgr.mr_n82489984)
print v(xbgr.mr_n82490096)
print v(xbgr.mr_n82490416)
print v(xbgr.mr_n82490528)
print v(xbgr.mr_n82490848)
print v(xbgr.mr_n82490960)
print v(xbgr.mr_n82491280)
print v(xbgr.mr_n82491392)
print v(xbgr.mr_n82491712)
print v(xbgr.mr_n82491824)
print v(xbgr.mr_n82492144)
print v(xbgr.mr_n82492256)
print v(xbgr.mr_n82492576)
print v(xbgr.mr_n82492688)
print v(xbgr.mr_n82493008)
print v(xbgr.mr_n82493120)
print v(xbgr.mr_n82493440)
print v(xbgr.mr_n82493552)
print v(xbgr.mr_n82493872)
print v(xbgr.mr_n82493984)
print v(xbgr.mr_n82494304)
print v(xbgr.mr_n82494416)
print v(xbgr.mr_n82494736)
print v(xbgr.mr_n82494848)
print v(xbgr.mr_n82495168)
print v(xbgr.mr_n82495280)
print v(xbgr.mr_n82495600)
print v(xbgr.mr_n82495712)
print v(xbgr.mr_n82496032)
print v(xbgr.mr_n82496144)
print v(xbgr.mr_n82496464)
print v(xbgr.mr_n82496576)
print v(xbgr.mr_n82496896)
print v(xbgr.mr_n82497008)
print v(xbgr.mr_n82497328)
print v(xbgr.mr_n82497440)
print v(xbgr.mr_n82497760)
print v(xbgr.mr_n82497872)
print v(xbgr.mr_n82498192)
print v(xbgr.mr_n82498304)
print v(xbgr.mr_n82498624)
print v(xbgr.mr_n82498736)
print v(xbgr.mr_n82499056)
print v(xbgr.mr_n82499168)
print v(xbgr.mr_n82499488)
print v(xbgr.mr_n82499600)
print v(xbgr.mr_n82499920)
print v(xbgr.mr_n82500032)
print v(xbgr.mr_n82500352)
print v(xbgr.mr_n82500464)
print v(xbgr.mr_n82500784)
print v(xbgr.mr_n82500896)
print v(xbgr.mr_n82501216)
print v(xbgr.mr_n82501328)
print v(xbgr.mr_n82501648)
print v(xbgr.mr_n82501760)
print v(xbgr.mr_n82502080)
print v(xbgr.mr_n82502192)
print v(xbgr.mr_n82502512)
print v(xbgr.mr_n82502624)
print v(xbgr.mr_n82502944)
print v(xbgr.mr_n82503056)
print v(xbgr.mr_n82503376)
print v(xbgr.mr_n82503488)
print v(xbgr.mr_n82503808)
print v(xbgr.mr_n82503920)
print v(xbgr.mr_n82504240)
print v(xbgr.mr_n82504352)
print v(xbgr.mr_n82504672)
print v(xbgr.mr_n82504784)
print v(xbgr.mr_n82505104)
print v(xbgr.mr_n82505216)
print v(xbgr.mr_n82505536)
print v(xbgr.mr_n82505648)
print v(xbgr.mr_n82505968)
print v(xbgr.mr_n82506080)
print v(xbgr.mr_n82506400)
print v(xbgr.mr_n82506512)
print v(xbgr.mr_n82506832)
print v(xbgr.mr_n82506944)
print v(xbgr.mr_n82507264)
print v(xbgr.mr_n82507376)
print v(xbgr.mr_n82507696)
print v(xbgr.mr_n82507808)
print v(xbgr.mr_n82508128)
print v(xbgr.mr_n82508240)
print v(xbgr.mr_n82508560)
print v(xbgr.mr_n82508672)
print v(xbgr.mr_n82508992)
print v(xbgr.mr_n82509104)
print v(xbgr.mr_n82509424)
print v(xbgr.mr_n82509536)
print v(xbgr.mr_n82509856)
print v(xbgr.mr_n82509968)
print v(xbgr.mr_n82510288)
print v(xbgr.mr_n82510400)
print v(xbgr.mr_n82510720)
print v(xbgr.mr_n82510832)
print v(xbgr.mr_n82511152)
print v(xbgr.mr_n82511264)
print v(xbgr.mr_n82511584)
print v(xbgr.mr_n82511696)
print v(xbgr.mr_n82512016)
print v(xbgr.mr_n82512128)
print v(xbgr.mr_n82512448)
print v(xbgr.mr_n82512560)
print v(xbgr.mr_n82512880)
print v(xbgr.mr_n82512992)
print v(xbgr.mr_n82513312)
print v(xbgr.mr_n82513424)
print v(xbgr.mr_n82513744)
print v(xbgr.mr_n82513856)
print v(xbgr.mr_n82514176)
print v(xbgr.mr_n82514288)
print v(xbgr.mr_n82514608)
print v(xbgr.mr_n82514720)
print v(xbgr.mr_n82515040)
print v(xbgr.mr_n82515152)
print v(xbgr.mr_n82515472)
print v(xbgr.mr_n82515584)
print v(xbgr.mr_n82515904)
print v(xbgr.mr_n82516016)
print v(xbgr.mr_n82516336)
print v(xbgr.mr_n82516448)
print v(xbgr.mr_n82516768)
print v(xbgr.mr_n82516880)
print v(xbgr.mr_n82517200)
print v(xbgr.mr_n82517312)
print v(xbgr.mr_n82517632)
print v(xbgr.mr_n82517744)
print v(xbgr.mr_n82518064)
print v(xbgr.mr_n82518176)
print v(xbgr.mr_n82518496)
print v(xbgr.mr_n82518608)
print v(xbgr.mr_n82518928)
print v(xbgr.mr_n82519040)
print v(xbgr.mr_n82519360)
print v(xbgr.mr_n82519472)
print v(xbgr.mr_n82519792)
print v(xbgr.mr_n82519904)
print v(xbgr.mr_n82520224)
print v(xbgr.mr_n82520336)
print v(xbgr.mr_n82520656)
print v(xbgr.mr_n82520768)
print v(xbgr.mr_n82521088)
print v(xbgr.mr_n82521200)
print v(xbgr.mr_n82521520)
print v(xbgr.mr_n82521632)
print v(xbgr.mr_n82521952)
print v(xbgr.mr_n82522064)
print v(xbgr.mr_n82522384)
print v(xbgr.mr_n82522496)
print v(xbgr.mr_n82522816)
print v(xbgr.mr_n82522928)
print v(xbgr.mr_n82523248)
print v(xbgr.mr_n82523360)
print v(xbgr.mr_n82523680)
print v(xbgr.mr_n82523792)
print v(xbgr.mr_n82524112)
print v(xbgr.mr_n82524224)
print v(xbgr.mr_n82524544)
print v(xbgr.mr_n82524656)
print v(xbgr.mr_n82524976)
print v(xbgr.mr_n82525088)
print v(xbgr.mr_n82525408)
print v(xbgr.mr_n82525520)
print v(xbgr.mr_n82525840)
print v(xbgr.mr_n82525952)
print v(xbgr.mr_n82526272)
print v(xbgr.mr_n82526384)
print v(xbgr.mr_n82526704)
print v(xbgr.mr_n82526816)
print v(xbgr.mr_n82527136)
print v(xbgr.mr_n82527248)
print v(xbgr.mr_n82527568)
print v(xbgr.mr_n82527680)
print v(xbgr.mr_n82528000)
print v(xbgr.mr_n82528112)
print v(xbgr.mr_n82528432)
print v(xbgr.mr_n82528544)
print v(xbgr.mr_n82528864)
print v(xbgr.mr_n82528976)
print v(xbgr.mr_n82529296)
print v(xbgr.mr_n82529408)
print v(xbgr.mr_n82529728)
print v(xbgr.mr_n82529840)
print v(xbgr.mr_n82530160)
print v(xbgr.mr_n82530272)
print v(xbgr.mr_n82530592)
print v(xbgr.mr_n82530704)
print v(xbgr.mr_n82531024)
print v(xbgr.mr_n82531136)
print v(xbgr.mr_n82531456)
print v(xbgr.mr_n82531568)
print v(xbgr.mr_n82531888)
print v(xbgr.mr_n82532000)
print v(xbgr.mr_n82532320)
print v(xbgr.mr_n82532432)
print v(xbgr.mr_n82532752)
print v(xbgr.mr_n82532864)
print v(xbgr.mr_n82533184)
print v(xbgr.mr_n82533296)
print v(xbgr.mr_n82533616)
print v(xbgr.mr_n82533728)
print v(xbgr.mr_n82534048)
print v(xbgr.mr_n82534160)
print v(xbgr.mr_n82534480)
print v(xbgr.mr_n82534592)
print v(xbgr.mr_n82534912)
print v(xbgr.mr_n82535024)
print v(xbgr.mr_n82535344)
print v(xbgr.mr_n82535456)
print v(xbgr.mr_n82535776)
print v(xbgr.mr_n82535888)
print v(xbgr.mr_n82536208)
print v(xbgr.mr_n82536320)
print v(xbgr.mr_n82536640)
print v(xbgr.mr_n82536752)
print v(xbgr.mr_n82537072)
print v(xbgr.mr_n82537184)
print v(xbgr.mr_n82537504)
print v(xbgr.mr_n82537616)
print v(xbgr.mr_n82537936)
print v(xbgr.mr_n82538048)
print v(xbgr.mr_n82538368)
print v(xbgr.mr_n82538480)
print v(xbgr.mr_n82538800)
print v(xbgr.mr_n82538912)
print v(xbgr.mr_n82539232)
print v(xbgr.mr_n82539344)
print v(xbgr.mr_n82539664)
print v(xbgr.mr_n82539776)
print v(xbgr.mr_n82540096)
print v(xbgr.mr_n82540208)
print v(xbgr.mr_n82540528)
print v(xbgr.mr_n82540640)
print v(xbgr.mr_n82540960)
print v(xbgr.mr_n82541072)
print v(xbgr.mr_n82541392)
print v(xbgr.mr_n82541504)
print v(xbgr.mr_n82541824)
print v(xbgr.mr_n82541936)
print v(xbgr.mr_n82542256)
print v(xbgr.mr_n82542368)
print v(xbgr.mr_n82542688)
print v(xbgr.mr_n82542800)
print v(xbgr.mr_n82543120)
print v(xbgr.mr_n82543232)
print v(xbgr.mr_n82543552)
print v(xbgr.mr_n82543664)
print v(xbgr.mr_n82543984)
print v(xbgr.mr_n82544096)
print v(xbgr.mr_n82544416)
print v(xbgr.mr_n82544528)
print v(xbgr.mr_n82544848)
print v(xbgr.mr_n82544960)
print v(xbgr.mr_n82545280)
print v(xbgr.mr_n82545392)
print v(xbgr.mr_n82545712)
print v(xbgr.mr_n82545824)
print v(xbgr.mr_n82546144)
print v(xbgr.mr_n82546256)
print v(xbgr.mr_n82546576)
print v(xbgr.mr_n82546688)
print v(xbgr.mr_n82547008)
print v(xbgr.mr_n82547120)
print v(xbgr.mr_n82547440)
print v(xbgr.mr_n82547552)
print v(xbgr.mr_n82547872)
print v(xbgr.mr_n82547984)
print v(xbgr.mr_n82548304)
print v(xbgr.mr_n82548416)
print v(xbgr.mr_n82548736)
print v(xbgr.mr_n82548848)
print v(xbgr.mr_n82549168)
print v(xbgr.mr_n82549280)
print v(xbgr.mr_n82549600)
print v(xbgr.mr_n82549712)
print v(xbgr.mr_n82550032)
print v(xbgr.mr_n82550144)
print v(xbgr.mr_n82550464)
print v(xbgr.mr_n82550576)
print v(xbgr.mr_n82550896)
print v(xbgr.mr_n82551008)
print v(xbgr.mr_n82551328)
print v(xbgr.mr_n82551440)
print v(xbgr.mr_n82551760)
print v(xbgr.mr_n82551872)
print v(xbgr.mr_n82552192)
print v(xbgr.mr_n82552304)
print v(xbgr.mr_n82552624)
print v(xbgr.mr_n82552736)
print v(xbgr.mr_n82553056)
print v(xbgr.mr_n82553168)
print v(xbgr.mr_n82553488)
print v(xbgr.mr_n82553600)
print v(xbgr.mr_n82553920)
print v(xbgr.mr_n82554032)
print v(xbgr.mr_n82554352)
print v(xbgr.mr_n82554464)
print v(xbgr.mr_n82554784)
print v(xbgr.mr_n82554896)
print v(xbgr.mr_n82555216)
print v(xbgr.mr_n82555328)
print v(xbgr.mr_n82555648)
print v(xbgr.mr_n82555760)
print v(xbgr.mr_n82556080)
print v(xbgr.mr_n82556192)
print v(xbgr.mr_n82556512)
print v(xbgr.mr_n82556624)
print v(xbgr.mr_n82556944)
print v(xbgr.mr_n82557056)
print v(xbgr.mr_n82557376)
print v(xbgr.mr_n82557488)
print v(xbgr.mr_n82557808)
print v(xbgr.mr_n82557920)
print v(xbgr.mr_n82558240)
print v(xbgr.mr_n82558352)
print v(xbgr.mr_n82558672)
print v(xbgr.mr_n82558784)
print v(xbgr.mr_n82559104)
print v(xbgr.mr_n82559216)
print v(xbgr.mr_n82559536)
print v(xbgr.mr_n82559648)
print v(xbgr.mr_n82559968)
print v(xbgr.mr_n82560080)
print v(xbgr.mr_n82560400)
print v(xbgr.mr_n82560512)
print v(xbgr.mr_n82560832)
print v(xbgr.mr_n82560944)
print v(xbgr.mr_n82561264)
print v(xbgr.mr_n82561376)
print v(xbgr.mr_n82561696)
print v(xbgr.mr_n82561808)
print v(xbgr.mr_n82562128)
print v(xbgr.mr_n82562240)
print v(xbgr.mr_n82562560)
print v(xbgr.mr_n82562672)
print v(xbgr.mr_n82562992)
print v(xbgr.mr_n82563104)
print v(xbgr.mr_n82563424)
print v(xbgr.mr_n82563536)
print v(xbgr.mr_n82563856)
print v(xbgr.mr_n82563968)
print v(xbgr.mr_n82564288)
print v(xbgr.mr_n82564400)
print v(xbgr.mr_n82564720)
print v(xbgr.mr_n82564832)
print v(xbgr.mr_n82565152)
print v(xbgr.mr_n82565264)
print v(xbgr.mr_n82565584)
print v(xbgr.mr_n82565696)
print v(xbgr.mr_n82566016)
print v(xbgr.mr_n82566128)
print v(xbgr.mr_n82566448)
print v(xbgr.mr_n82566560)
print v(xbgr.mr_n82566880)
print v(xbgr.mr_n82566992)
print v(xbgr.mr_n82567312)
print v(xbgr.mr_n82567424)
print v(xbgr.mr_n82567744)
print v(xbgr.mr_n82567856)
print v(xbgr.mr_n82568176)
print v(xbgr.mr_n82568288)
print v(xbgr.mr_n82568608)
print v(xbgr.mr_n82568720)
print v(xbgr.mr_n82569040)
print v(xbgr.mr_n82569152)
print v(xbgr.mr_n82569472)
print v(xbgr.mr_n82569584)
print v(xbgr.mr_n82569904)
print v(xbgr.mr_n82570016)
print v(xbgr.mr_n82570336)
print v(xbgr.mr_n82570448)
print v(xbgr.mr_n82570768)
print v(xbgr.mr_n82570880)
print v(xbgr.mr_n82571200)
print v(xbgr.mr_n82571312)
print v(xbgr.mr_n82571632)
print v(xbgr.mr_n82571744)
print v(xbgr.mr_n82572064)
print v(xbgr.mr_n82572176)
print v(xbgr.mr_n82572496)
print v(xbgr.mr_n82572608)
print v(xbgr.mr_n82572928)
print v(xbgr.mr_n82573040)
print v(xbgr.mr_n82573360)
print v(xbgr.mr_n82573472)
print v(xbgr.mr_n82573792)
print v(xbgr.mr_n82573904)
print v(xbgr.mr_n82574224)
print v(xbgr.mr_n82574336)
print v(xbgr.mr_n82574656)
print v(xbgr.mr_n82574768)
print v(xbgr.mr_n82575088)
print v(xbgr.mr_n82575200)
print v(xbgr.mr_n82575520)
print v(xbgr.mr_n82575632)
print v(xbgr.mr_n82575952)
print v(xbgr.mr_n82576064)
print v(xbgr.mr_n82576384)
print v(xbgr.mr_n82576496)
print v(xbgr.mr_n82576816)
print v(xbgr.mr_n82576928)
print v(xbgr.mr_n82577248)
print v(xbgr.mr_n82577360)
print v(xbgr.mr_n82577680)
print v(xbgr.mr_n82577792)
print v(xbgr.mr_n82578112)
print v(xbgr.mr_n82578224)
print v(xbgr.mr_n82578544)
print v(xbgr.mr_n82578656)
print v(xbgr.mr_n82578976)
print v(xbgr.mr_n82579088)
print v(xbgr.mr_n82579408)
print v(xbgr.mr_n82579520)
print v(xbgr.mr_n82579840)
print v(xbgr.mr_n82579952)
print v(xbgr.mr_n82580272)
print v(xbgr.mr_n82580384)
print v(xbgr.mr_n82580704)
print v(xbgr.mr_n82580816)
print v(xbgr.mr_n82581136)
print v(xbgr.mr_n82581248)
print v(xbgr.mr_n82581568)
print v(xbgr.mr_n82581680)
print v(xbgr.mr_n82582000)
print v(xbgr.mr_n82582112)
print v(xbgr.mr_n82582432)
print v(xbgr.mr_n82582544)
print v(xbgr.mr_n82582864)
print v(xbgr.mr_n82582976)
print v(xbgr.mr_n82583296)
print v(xbgr.mr_n82583408)
print v(xbgr.mr_n82583728)
print v(xbgr.mr_n82583840)
print v(xbgr.mr_n82584160)
print v(xbgr.mr_n82584272)
print v(xbgr.mr_n82584592)
print v(xbgr.mr_n82584704)
print v(xbgr.mr_n82585024)
print v(xbgr.mr_n82585136)
print v(xbgr.mr_n82585456)
print v(xbgr.mr_n82585568)
print v(xbgr.mr_n82586000)
print v(xbgr.mr_n82586320)
print v(xbgr.mr_n82586432)
print v(xbgr.mr_n82586752)
print v(xbgr.mr_n82586864)
print v(xbgr.mr_n82587184)
print v(xbgr.mr_n82587296)
print v(xbgr.mr_n82587616)
print v(xbgr.mr_n82587728)
print v(xbgr.mr_n82588048)
print v(xbgr.mr_n82588912)
print v(xbgr.mr_n82589024)
print v(xbgr.mr_n82589344)
print v(xbgr.mr_n82589456)
print v(xbgr.mr_n82589776)
print v(xbgr.mr_n82589888)
print v(xbgr.mr_n82590208)
print v(xbgr.mr_n82590320)
print v(xbgr.mr_n82590640)
print v(xbgr.mr_n82590752)
print v(xbgr.mr_n82591072)
print v(xbgr.mr_n82591184)
print v(xbgr.mr_n82591504)
print v(xbgr.mr_n82591616)
print v(xbgr.mr_n82591936)
print v(xbgr.mr_n82592048)
print v(xbgr.mr_n82592368)
print v(xbgr.mr_n82592480)
print v(xbgr.mr_n82592800)
print v(xbgr.mr_n82592912)
print v(xbgr.mr_n82593232)
print v(xbgr.mr_n82593344)
print v(xbgr.mr_n82593776)
print v(xbgr.mr_n82594096)
print v(xbgr.mr_n82594208)
print v(xbgr.mr_n82594528)
print v(xbgr.mr_n82594640)
print v(xbgr.mr_n82594960)
print v(xbgr.mr_n82595072)
print v(xbgr.mr_n82595392)
print v(xbgr.mr_n82595504)
print v(xbgr.mr_n82595824)
print v(xbgr.mr_n82595936)
print v(xbgr.mr_n82596256)
print v(xbgr.mr_n82596368)
print v(xbgr.mr_n82596688)
print v(xbgr.mr_n82596800)
print v(xbgr.mr_n82597120)
print v(xbgr.mr_n82597232)
print v(xbgr.mr_n82597552)
print v(xbgr.mr_n82597664)
print v(xbgr.mr_n82597984)
print v(xbgr.mr_n82598096)
print v(xbgr.mr_n82598416)
print v(xbgr.mr_n82598528)
print v(xbgr.mr_n82598848)
print v(xbgr.mr_n82598960)
print v(xbgr.mr_n82599280)
print v(xbgr.mr_n82599392)
print v(xbgr.mr_n82599712)
print v(xbgr.mr_n82599824)
print v(xbgr.mr_n82600144)
print v(xbgr.mr_n82600256)
print v(xbgr.mr_n82600576)
print v(xbgr.mr_n82600688)
print v(xbgr.mr_n82601008)
print v(xbgr.mr_n82601120)
print v(xbgr.mr_n82601440)
print v(xbgr.mr_n82601552)
print v(xbgr.mr_n82601872)
print v(xbgr.mr_n82601984)
print v(xbgr.mr_n82602304)
print v(xbgr.mr_n82602416)
print v(xbgr.mr_n82602736)
print v(xbgr.mr_n82602848)
print v(xbgr.mr_n82603168)
print v(xbgr.mr_n82603280)
print v(xbgr.mr_n82603600)
print v(xbgr.mr_n82603712)
print v(xbgr.mr_n82604032)
print v(xbgr.mr_n82604144)
print v(xbgr.mr_n82604464)
print v(xbgr.mr_n82604576)
print v(xbgr.mr_n82604896)
print v(xbgr.mr_n82605008)
print v(xbgr.mr_n82605328)
print v(xbgr.mr_n82605440)
print v(xbgr.mr_n82605760)
print v(xbgr.mr_n82605872)
print v(xbgr.mr_n82606192)
print v(xbgr.mr_n82606304)
print v(xbgr.mr_n82606624)
print v(xbgr.mr_n82606736)
print v(xbgr.mr_n82607056)
print v(xbgr.mr_n82607168)
print v(xbgr.mr_n82607488)
print v(xbgr.mr_n82607600)
print v(xbgr.mr_n82607920)
print v(xbgr.mr_n82608032)
print v(xbgr.mr_n82608352)
print v(xbgr.mr_n82608464)
print v(xbgr.mr_n82608784)
print v(xbgr.mr_n82608896)
print v(xbgr.mr_n82609216)
print v(xbgr.mr_n82609328)
print v(xbgr.mr_n82609648)
print v(xbgr.mr_n82609760)
print v(xbgr.mr_n82610080)
print v(xbgr.mr_n82610192)
print v(xbgr.mr_n82610512)
print v(xbgr.mr_n82611376)
print v(xbgr.mr_n82611488)
print v(xbgr.mr_n82611808)
print v(xbgr.mr_n82611920)
print v(xbgr.mr_n82612240)
print v(xbgr.mr_n82612352)
print v(xbgr.mr_n82612672)
print v(xbgr.mr_n82612784)
print v(xbgr.mr_n82613104)
print v(xbgr.mr_n82613216)
print v(xbgr.mr_n82613536)
print v(xbgr.mr_n82613648)
print v(xbgr.mr_n82613968)
print v(xbgr.mr_n82614080)
print v(xbgr.mr_n82614400)
print v(xbgr.mr_n82614512)
print v(xbgr.mr_n82614832)
print v(xbgr.mr_n82614944)
print v(xbgr.mr_n82615264)
print v(xbgr.mr_n82615376)
print v(xbgr.mr_n82615696)
print v(xbgr.mr_n82615808)
print v(xbgr.mr_n82616128)
print v(xbgr.mr_n82616240)
print v(xbgr.mr_n82616560)
print v(xbgr.mr_n82616672)
print v(xbgr.mr_n82616992)
print v(xbgr.mr_n82617104)
print v(xbgr.mr_n82617424)
print v(xbgr.mr_n82617536)
print v(xbgr.mr_n82617856)
print v(xbgr.mr_n82617968)
print v(xbgr.mr_n82618288)
print v(xbgr.mr_n82618400)
print v(xbgr.mr_n82618720)
print v(xbgr.mr_n82618832)
print v(xbgr.mr_n82619152)
print v(xbgr.mr_n82619264)
print v(xbgr.mr_n82619584)
print v(xbgr.mr_n82619696)
print v(xbgr.mr_n82620016)
print v(xbgr.mr_n82620128)
print v(xbgr.mr_n82620448)
print v(xbgr.mr_n82620560)
print v(xbgr.mr_n82620880)
print v(xbgr.mr_n82620992)
print v(xbgr.mr_n82621312)
print v(xbgr.mr_n82621424)
print v(xbgr.mr_n82621744)
print v(xbgr.mr_n82621856)
print v(xbgr.mr_n82622176)
print v(xbgr.mr_n82622288)
print v(xbgr.mr_n82622608)
print v(xbgr.mr_n82622720)
print v(xbgr.mr_n82623040)
print v(xbgr.mr_n82623152)
print v(xbgr.mr_n82623472)
print v(xbgr.mr_n82623584)
print v(xbgr.mr_n82623904)
print v(xbgr.mr_n82624016)
print v(xbgr.mr_n82624336)
print v(xbgr.mr_n82624448)
print v(xbgr.mr_n82624768)
print v(xbgr.mr_n82624880)
print v(xbgr.mr_n82625200)
print v(xbgr.mr_n82625312)
print v(xbgr.mr_n82625632)
print v(xbgr.mr_n82625744)
print v(xbgr.mr_n82626064)
print v(xbgr.mr_n82626176)
print v(xbgr.mr_n82626496)
print v(xbgr.mr_n82626608)
print v(xbgr.mr_n82626928)
print v(xbgr.mr_n82627040)
print v(xbgr.mr_n82627360)
print v(xbgr.mr_n82627472)
print v(xbgr.mr_n82627792)
print v(xbgr.mr_n82627904)
print v(xbgr.mr_n82628224)
print v(xbgr.mr_n82628336)
print v(xbgr.mr_n82628656)
print v(xbgr.mr_n82628768)
print v(xbgr.mr_n82629088)
print v(xbgr.mr_n82629200)
print v(xbgr.mr_n82629520)
print v(xbgr.mr_n82629632)
print v(xbgr.mr_n82629952)
print v(xbgr.mr_n82630064)
print v(xbgr.mr_n82630384)
print v(xbgr.mr_n82630496)
print v(xbgr.mr_n82630816)
print v(xbgr.mr_n82630928)
print v(xbgr.mr_n82631248)
print v(xbgr.mr_n82631360)
print v(xbgr.mr_n82631680)
print v(xbgr.mr_n82631792)
print v(xbgr.mr_n82632112)
print v(xbgr.mr_n82632224)
print v(xbgr.mr_n82632544)
print v(xbgr.mr_n82632656)
print v(xbgr.mr_n82632976)
print v(xbgr.mr_n82633088)
print v(xbgr.mr_n82633408)
print v(xbgr.mr_n82633520)
print v(xbgr.mr_n82633840)
print v(xbgr.mr_n82633952)
print v(xbgr.mr_n82634272)
print v(xbgr.mr_n82634384)
print v(xbgr.mr_n82634704)
print v(xbgr.mr_n82634816)
print v(xbgr.mr_n82635136)
print v(xbgr.mr_n82635248)
print v(xbgr.mr_n82635568)
print v(xbgr.mr_n82635680)
print v(xbgr.mr_n82636000)
print v(xbgr.mr_n82636112)
print v(xbgr.mr_n82636432)
print v(xbgr.mr_n82636544)
print v(xbgr.mr_n82636864)
print v(xbgr.mr_n82636976)
print v(xbgr.mr_n82637296)
print v(xbgr.mr_n82637408)
print v(xbgr.mr_n82637728)
print v(xbgr.mr_n82637840)
print v(xbgr.mr_n82638160)
print v(xbgr.mr_n82638272)
print v(xbgr.mr_n82638592)
print v(xbgr.mr_n82638704)
print v(xbgr.mr_n82639024)
print v(xbgr.mr_n82639136)
print v(xbgr.mr_n82639456)
print v(xbgr.mr_n82639568)
print v(xbgr.mr_n82639888)
print v(xbgr.mr_n82640000)
print v(xbgr.mr_n82640320)
print v(xbgr.mr_n82640432)
print v(xbgr.mr_n82640752)
print v(xbgr.mr_n82640864)
print v(xbgr.mr_n82641184)
print v(xbgr.mr_n82641296)
print v(xbgr.mr_n82641616)
print v(xbgr.mr_n82641728)
print v(xbgr.mr_n82642048)
print v(xbgr.mr_n82642160)
print v(xbgr.mr_n82642480)
print v(xbgr.mr_n82642592)
print v(xbgr.mr_n82642912)
print v(xbgr.mr_n82643024)
print v(xbgr.mr_n82643344)
print v(xbgr.mr_n82643456)
print v(xbgr.mr_n82643776)
print v(xbgr.mr_n82643888)
print v(xbgr.mr_n82644208)
print v(xbgr.mr_n82644320)
print v(xbgr.mr_n82644640)
print v(xbgr.mr_n82644752)
print v(xbgr.mr_n82645072)
print v(xbgr.mr_n82645184)
print v(xbgr.mr_n82645504)
print v(xbgr.mr_n82645616)
print v(xbgr.mr_n82645936)
print v(xbgr.mr_n82646048)
print v(xbgr.mr_n82646368)
print v(xbgr.mr_n82646480)
print v(xbgr.mr_n82646800)
print v(xbgr.mr_n82646912)
print v(xbgr.mr_n82647232)
print v(xbgr.mr_n82647344)
print v(xbgr.mr_n82647664)
print v(xbgr.mr_n82647776)
print v(xbgr.mr_n82648096)
print v(xbgr.mr_n82648208)
print v(xbgr.mr_n82648528)
print v(xbgr.mr_n82648640)
print v(xbgr.mr_n82648960)
print v(xbgr.mr_n82649072)
print v(xbgr.mr_n82649392)
print v(xbgr.mr_n82649504)
print v(xbgr.mr_n82649824)
print v(xbgr.mr_n82649936)
print v(xbgr.mr_n82650256)
print v(xbgr.mr_n82650368)
print v(xbgr.mr_n82650688)
print v(xbgr.mr_n82650800)
print v(xbgr.mr_n82651120)
print v(xbgr.mr_n82651232)
print v(xbgr.mr_n82651552)
print v(xbgr.mr_n82651664)
print v(xbgr.mr_n82651984)
print v(xbgr.mr_n82652096)
print v(xbgr.mr_n82652416)
print v(xbgr.mr_n82652528)
print v(xbgr.mr_n82652848)
print v(xbgr.mr_n82652960)
print v(xbgr.mr_n82653280)
print v(xbgr.mr_n82653392)
print v(xbgr.mr_n82653712)
print v(xbgr.mr_n82653824)
print v(xbgr.mr_n82654144)
print v(xbgr.mr_n82654256)
print v(xbgr.mr_n82654576)
print v(xbgr.mr_n82654688)
print v(xbgr.mr_n82655008)
print v(xbgr.mr_n82655120)
print v(xbgr.mr_n82655440)
print v(xbgr.mr_n82655552)
print v(xbgr.mr_n82655872)
print v(xbgr.mr_n82655984)
print v(xbgr.mr_n82656304)
print v(xbgr.mr_n82656416)
print v(xbgr.mr_n82656736)
print v(xbgr.mr_n82656848)
print v(xbgr.mr_n82657168)
print v(xbgr.mr_n82657280)
print v(xbgr.mr_n82657600)
print v(xbgr.mr_n82657712)
print v(xbgr.mr_n82658032)
print v(xbgr.mr_n82658144)
print v(xbgr.mr_n82658464)
print v(xbgr.mr_n82658576)
print v(xbgr.mr_n82658896)
print v(xbgr.mr_n82659008)
print v(xbgr.mr_n82659328)
print v(xbgr.mr_n82659440)
print v(xbgr.mr_n82659760)
print v(xbgr.mr_n82659872)
print v(xbgr.mr_n82660192)
print v(xbgr.mr_n82660304)
print v(xbgr.mr_n82660624)
print v(xbgr.mr_n82660736)
print v(xbgr.mr_n82661056)
print v(xbgr.mr_n82661168)
print v(xbgr.mr_n82661488)
print v(xbgr.mr_n82661600)
print v(xbgr.mr_n82661920)
print v(xbgr.mr_n82662032)
print v(xbgr.mr_n82662352)
print v(xbgr.mr_n82662464)
print v(xbgr.mr_n82662784)
print v(xbgr.mr_n82662896)
print v(xbgr.mr_n82663216)
print v(xbgr.mr_n82663328)
print v(xbgr.mr_n82663648)
print v(xbgr.mr_n82663760)
print v(xbgr.mr_n82664080)
print v(xbgr.mr_n82664192)
print v(xbgr.mr_n82664512)
print v(xbgr.mr_n82664624)
print v(xbgr.mr_n82664944)
print v(xbgr.mr_n82665056)
print v(xbgr.mr_n82665376)
print v(xbgr.mr_n82665488)
print v(xbgr.mr_n82665808)
print v(xbgr.mr_n82665920)
print v(xbgr.mr_n82666240)
print v(xbgr.mr_n82666352)
print v(xbgr.mr_n82666672)
print v(xbgr.mr_n82666784)
print v(xbgr.mr_n82667104)
print v(xbgr.mr_n82667216)
print v(xbgr.mr_n82667536)
print v(xbgr.mr_n82667648)
print v(xbgr.mr_n82667968)
print v(xbgr.mr_n82668080)
print v(xbgr.mr_n82668400)
print v(xbgr.mr_n82668512)
print v(xbgr.mr_n82668832)
print v(xbgr.mr_n82668944)
print v(xbgr.mr_n82669264)
print v(xbgr.mr_n82669376)
print v(xbgr.mr_n82669696)
print v(xbgr.mr_n82669808)
print v(xbgr.mr_n82670128)
print v(xbgr.mr_n82670240)
print v(xbgr.mr_n82670560)
print v(xbgr.mr_n82670672)
print v(xbgr.mr_n82670992)
print v(xbgr.mr_n82671104)
print v(xbgr.mr_n82671424)
print v(xbgr.mr_n82671536)
print v(xbgr.mr_n82671856)
print v(xbgr.mr_n82671968)
print v(xbgr.mr_n82672288)
print v(xbgr.mr_n82672400)
print v(xbgr.mr_n82672720)
print v(xbgr.mr_n82672832)
print v(xbgr.mr_n82673152)
print v(xbgr.mr_n82673264)
print v(xbgr.mr_n82673584)
print v(xbgr.mr_n82673696)
print v(xbgr.mr_n82674016)
print v(xbgr.mr_n82674128)
print v(xbgr.mr_n82674448)
print v(xbgr.mr_n82674560)
print v(xbgr.mr_n82674880)
print v(xbgr.mr_n82674992)
print v(xbgr.mr_n82675312)
print v(xbgr.mr_n82675424)
print v(xbgr.mr_n82675744)
print v(xbgr.mr_n82675856)
print v(xbgr.mr_n82676176)
print v(xbgr.mr_n82676288)
print v(xbgr.mr_n82676608)
print v(xbgr.mr_n82676720)
print v(xbgr.mr_n82677040)
print v(xbgr.mr_n82677152)
print v(xbgr.mr_n82677472)
print v(xbgr.mr_n82677584)
print v(xbgr.mr_n82677904)
print v(xbgr.mr_n82678016)
print v(xbgr.mr_n82678336)
print v(xbgr.mr_n82678448)
print v(xbgr.mr_n82678768)
print v(xbgr.mr_n82678880)
print v(xbgr.mr_n82679200)
print v(xbgr.mr_n82679312)
print v(xbgr.mr_n82679632)
print v(xbgr.mr_n82679744)
print v(xbgr.mr_n82680064)
print v(xbgr.mr_n82680176)
print v(xbgr.mr_n82680496)
print v(xbgr.mr_n82680608)
print v(xbgr.mr_n82680928)
print v(xbgr.mr_n82681040)
print v(xbgr.mr_n82681360)
print v(xbgr.mr_n82681472)
print v(xbgr.mr_n82681792)
print v(xbgr.mr_n82681904)
print v(xbgr.mr_n82682224)
print v(xbgr.mr_n82682336)
print v(xbgr.mr_n82682656)
print v(xbgr.mr_n82682768)
print v(xbgr.mr_n82683088)
print v(xbgr.mr_n82683200)
print v(xbgr.mr_n82683520)
print v(xbgr.mr_n82683632)
print v(xbgr.mr_n82683952)
print v(xbgr.mr_n82684064)
print v(xbgr.mr_n82684384)
print v(xbgr.mr_n82684496)
print v(xbgr.mr_n82684816)
print v(xbgr.mr_n82684928)
print v(xbgr.mr_n82685248)
print v(xbgr.mr_n82685360)
print v(xbgr.mr_n82685680)
print v(xbgr.mr_n82685792)
print v(xbgr.mr_n82686112)
print v(xbgr.mr_n82686224)
print v(xbgr.mr_n82686544)
print v(xbgr.mr_n82686656)
print v(xbgr.mr_n82686976)
print v(xbgr.mr_n82687088)
print v(xbgr.mr_n82687408)
print v(xbgr.mr_n82687520)
print v(xbgr.mr_n82687840)
print v(xbgr.mr_n82687952)
print v(xbgr.mr_n82688272)
print v(xbgr.mr_n82688384)
print v(xbgr.mr_n82688704)
print v(xbgr.mr_n82688816)
print v(xbgr.mr_n82689136)
print v(xbgr.mr_n82689248)
print v(xbgr.mr_n82689568)
print v(xbgr.mr_n82689680)
print v(xbgr.mr_n82690000)
print v(xbgr.mr_n82690112)
print v(xbgr.mr_n82690432)
print v(xbgr.mr_n82690544)
print v(xbgr.mr_n82690864)
print v(xbgr.mr_n82690976)
print v(xbgr.mr_n82691296)
print v(xbgr.mr_n82691408)
print v(xbgr.mr_n82691728)
print v(xbgr.mr_n82691840)
print v(xbgr.mr_n82692160)
print v(xbgr.mr_n82692272)
print v(xbgr.mr_n82692592)
print v(xbgr.mr_n82692704)
print v(xbgr.mr_n82693024)
print v(xbgr.mr_n82693136)
print v(xbgr.mr_n82693456)
print v(xbgr.mr_n82693568)
print v(xbgr.mr_n82693888)
print v(xbgr.mr_n82694000)
print v(xbgr.mr_n82694320)
print v(xbgr.mr_n82694432)
print v(xbgr.mr_n82694752)
print v(xbgr.mr_n82694864)
print v(xbgr.mr_n82695184)
print v(xbgr.mr_n82695296)
print v(xbgr.mr_n82695616)
print v(xbgr.mr_n82695728)
print v(xbgr.mr_n82696048)
print v(xbgr.mr_n82696160)
print v(xbgr.mr_n82696480)
print v(xbgr.mr_n82696592)
print v(xbgr.mr_n82696912)
print v(xbgr.mr_n82697024)
print v(xbgr.mr_n82697344)
print v(xbgr.mr_n82697456)
print v(xbgr.mr_n82697776)
print v(xbgr.mr_n82697888)
print v(xbgr.mr_n82698208)
print v(xbgr.mr_n82698320)
print v(xbgr.mr_n82698640)
print v(xbgr.mr_n82698752)
print v(xbgr.mr_n82699072)
print v(xbgr.mr_n82699184)
print v(xbgr.mr_n82699504)
print v(xbgr.mr_n82699616)
print v(xbgr.mr_n82699936)
print v(xbgr.mr_n82700048)
print v(xbgr.mr_n82700368)
print v(xbgr.mr_n82700480)
print v(xbgr.mr_n82700800)
print v(xbgr.mr_n82700912)
print v(xbgr.mr_n82701232)
print v(xbgr.mr_n82701344)
print v(xbgr.mr_n82701664)
print v(xbgr.mr_n82701776)
print v(xbgr.mr_n82702096)
print v(xbgr.mr_n82702208)
print v(xbgr.mr_n82702528)
print v(xbgr.mr_n82702640)
print v(xbgr.mr_n82702960)
print v(xbgr.mr_n82703072)
print v(xbgr.mr_n82703392)
print v(xbgr.mr_n82703504)
print v(xbgr.mr_n82703824)
print v(xbgr.mr_n82703936)
print v(xbgr.mr_n82704256)
print v(xbgr.mr_n82704368)
print v(xbgr.mr_n82704688)
print v(xbgr.mr_n82704800)
print v(xbgr.mr_n82705120)
print v(xbgr.mr_n82705232)
print v(xbgr.mr_n82705552)
print v(xbgr.mr_n82705664)
print v(xbgr.mr_n82705984)
print v(xbgr.mr_n82706096)
print v(xbgr.mr_n82706416)
print v(xbgr.mr_n82706528)
print v(xbgr.mr_n82706848)
print v(xbgr.mr_n82706960)
print v(xbgr.mr_n82707280)
print v(xbgr.mr_n82707392)
print v(xbgr.mr_n82707712)
print v(xbgr.mr_n82707824)
print v(xbgr.mr_n82708144)
print v(xbgr.mr_n82708256)
print v(xbgr.mr_n82708576)
print v(xbgr.mr_n82708688)
print v(xbgr.mr_n82709008)
print v(xbgr.mr_n82709120)
print v(xbgr.mr_n82709440)
print v(xbgr.mr_n82709552)
print v(xbgr.mr_n82709872)
print v(xbgr.mr_n82709984)
print v(xbgr.mr_n82710304)
print v(xbgr.mr_n82710416)
print v(xbgr.mr_n82710736)
print v(xbgr.mr_n82710848)
print v(xbgr.mr_n82711168)
print v(xbgr.mr_n82711280)
print v(xbgr.mr_n82711600)
print v(xbgr.mr_n82711712)
print v(xbgr.mr_n82712032)
print v(xbgr.mr_n82712144)
print v(xbgr.mr_n82712464)
print v(xbgr.mr_n82712576)
print v(xbgr.mr_n82712896)
print v(xbgr.mr_n82713008)
print v(xbgr.mr_n82713328)
print v(xbgr.mr_n82713440)
print v(xbgr.mr_n82713760)
print v(xbgr.mr_n82713872)
print v(xbgr.mr_n82714192)
print v(xbgr.mr_n82714304)
print v(xbgr.mr_n82714624)
print v(xbgr.mr_n82714736)
print v(xbgr.mr_n82715056)
print v(xbgr.mr_n82715168)
print v(xbgr.mr_n82715488)
print v(xbgr.mr_n82715600)
print v(xbgr.mr_n82715920)
print v(xbgr.mr_n82716032)
print v(xbgr.mr_n82716352)
print v(xbgr.mr_n82716464)
print v(xbgr.mr_n82716784)
print v(xbgr.mr_n82716896)
print v(xbgr.mr_n82717216)
print v(xbgr.mr_n82717328)
print v(xbgr.mr_n82717648)
print v(xbgr.mr_n82717760)
print v(xbgr.mr_n82718080)
print v(xbgr.mr_n82718192)
print v(xbgr.mr_n82718512)
print v(xbgr.mr_n82718624)
print v(xbgr.mr_n82718944)
print v(xbgr.mr_n82719056)
print v(xbgr.mr_n82719376)
print v(xbgr.mr_n82719488)
print v(xbgr.mr_n82719808)
print v(xbgr.mr_n82719920)
print v(xbgr.mr_n82720240)
print v(xbgr.mr_n82720352)
print v(xbgr.mr_n82720672)
print v(xbgr.mr_n82720784)
print v(xbgr.mr_n82721104)
print v(xbgr.mr_n82721216)
print v(xbgr.mr_n82721536)
print v(xbgr.mr_n82721648)
print v(xbgr.mr_n82721968)
print v(xbgr.mr_n82722080)
print v(xbgr.mr_n82722400)
print v(xbgr.mr_n82722512)
print v(xbgr.mr_n82722832)
print v(xbgr.mr_n82722944)
print v(xbgr.mr_n82723264)
print v(xbgr.mr_n82723376)
print v(xbgr.mr_n82723696)
print v(xbgr.mr_n82723808)
print v(xbgr.mr_n82724128)
print v(xbgr.mr_n82724240)
print v(xbgr.mr_n82724560)
print v(xbgr.mr_n82724672)
print v(xbgr.mr_n82724992)
print v(xbgr.mr_n82725104)
print v(xbgr.mr_n82725424)
print v(xbgr.mr_n82725536)
print v(xbgr.mr_n82725856)
print v(xbgr.mr_n82725968)
print v(xbgr.mr_n82726288)
print v(xbgr.mr_n82726400)
print v(xbgr.mr_n82726720)
print v(xbgr.mr_n82726832)
print v(xbgr.mr_n82727152)
print v(xbgr.mr_n82727264)
print v(xbgr.mr_n82727584)
print v(xbgr.mr_n82727696)
print v(xbgr.mr_n82728016)
print v(xbgr.mr_n82728128)
print v(xbgr.mr_n82728448)
print v(xbgr.mr_n82728560)
print v(xbgr.mr_n82728880)
print v(xbgr.mr_n82728992)
print v(xbgr.mr_n82729312)
print v(xbgr.mr_n82729424)
print v(xbgr.mr_n82729744)
print v(xbgr.mr_n82729856)
print v(xbgr.mr_n82730176)
print v(xbgr.mr_n82730288)
print v(xbgr.mr_n82730608)
print v(xbgr.mr_n82730720)
print v(xbgr.mr_n82731040)
print v(xbgr.mr_n82731152)
print v(xbgr.mr_n82731472)
print v(xbgr.mr_n82731584)
print v(xbgr.mr_n82731904)
print v(xbgr.mr_n82732016)
print v(xbgr.mr_n82732336)
print v(xbgr.mr_n82732448)
print v(xbgr.mr_n82732768)
print v(xbgr.mr_n82732880)
print v(xbgr.mr_n82733200)
print v(xbgr.mr_n82733312)
print v(xbgr.mr_n82733632)
print v(xbgr.mr_n82733744)
print v(xbgr.mr_n82734064)
print v(xbgr.mr_n82734176)
print v(xbgr.mr_n82734496)
print v(xbgr.mr_n82734608)
print v(xbgr.mr_n82734928)
print v(xbgr.mr_n82735040)
print v(xbgr.mr_n82735360)
print v(xbgr.mr_n82735472)
print v(xbgr.mr_n82735792)
print v(xbgr.mr_n82735904)
print v(xbgr.mr_n82736224)
print v(xbgr.mr_n82736336)
print v(xbgr.mr_n82736656)
print v(xbgr.mr_n82736768)
print v(xbgr.mr_n82737088)
print v(xbgr.mr_n82737200)
print v(xbgr.mr_n82737520)
print v(xbgr.mr_n82737632)
print v(xbgr.mr_n82738064)
print v(xbgr.mr_n82738384)
print v(xbgr.mr_n82738496)
print v(xbgr.mr_n82738816)
print v(xbgr.mr_n82738928)
print v(xbgr.mr_n82739248)
print v(xbgr.mr_n82739360)
print v(xbgr.mr_n82739792)
print v(xbgr.mr_n82740112)
print v(xbgr.mr_n82740224)
print v(xbgr.mr_n82740544)
print v(xbgr.mr_n82740656)
print v(xbgr.mr_n82740976)
print v(xbgr.mr_n82741088)
print v(xbgr.mr_n82741408)
print v(xbgr.mr_n82741520)
print v(xbgr.mr_n82741840)
print v(xbgr.mr_n82741952)
print v(xbgr.mr_n82742272)
print v(xbgr.mr_n82742384)
print v(xbgr.mr_n82742704)
print v(xbgr.mr_n82742816)
print v(xbgr.mr_n82743136)
print v(xbgr.mr_n82743248)
print v(xbgr.mr_n82743568)
print v(xbgr.mr_n82743680)
print v(xbgr.mr_n82744000)
print v(xbgr.mr_n82744112)
print v(xbgr.mr_n82744432)
print v(xbgr.mr_n82744544)
print v(xbgr.mr_n82744864)
print v(xbgr.mr_n82744976)
print v(xbgr.mr_n82745296)
print v(xbgr.mr_n82745408)
print v(xbgr.mr_n82745728)
print v(xbgr.mr_n82745840)
print v(xbgr.mr_n82746160)
print v(xbgr.mr_n82746272)
print v(xbgr.mr_n82746704)
print v(xbgr.mr_n82747024)
print v(xbgr.mr_n82747136)
print v(xbgr.mr_n82747456)
print v(xbgr.mr_n82747568)
print v(xbgr.mr_n82747888)
print v(xbgr.mr_n82748000)
print v(xbgr.mr_n82748320)
print v(xbgr.mr_n82748432)
print v(xbgr.mr_n82748752)
print v(xbgr.mr_n82748864)
print v(xbgr.mr_n82749184)
print v(xbgr.mr_n82749296)
print v(xbgr.mr_n82749616)
print v(xbgr.mr_n82749728)
print v(xbgr.mr_n82750160)
print v(xbgr.mr_n82750480)
print v(xbgr.mr_n82750592)
print v(xbgr.mr_n82750912)
print v(xbgr.mr_n82751024)
print v(xbgr.mr_n82751344)
print v(xbgr.mr_n82751456)
print v(xbgr.mr_n82751776)
print v(xbgr.mr_n82751888)
print v(xbgr.mr_n82752208)
print v(xbgr.mr_n82752320)
print v(xbgr.mr_n82752640)
print v(xbgr.mr_n82752752)
print v(xbgr.mr_n82753072)
print v(xbgr.mr_n82753184)
print v(xbgr.mr_n82753504)
print v(xbgr.mr_n82753616)
print v(xbgr.mr_n82753936)
print v(xbgr.mr_n82754048)
print v(xbgr.mr_n82754368)
print v(xbgr.mr_n82754480)
print v(xbgr.mr_n82754800)
print v(xbgr.mr_n82754912)
print v(xbgr.mr_n82755232)
print v(xbgr.mr_n82755344)
print v(xbgr.mr_n82755664)
print v(xbgr.mr_n82755776)
print v(xbgr.mr_n82756208)
print v(xbgr.mr_n82756528)
print v(xbgr.mr_n82756640)
print v(xbgr.mr_n82756960)
print v(xbgr.mr_n82757072)
print v(xbgr.mr_n82757392)
print v(xbgr.mr_n82757504)
print v(xbgr.mr_n82757936)
print v(xbgr.mr_n82758256)
print v(xbgr.mr_n82758368)
print v(xbgr.mr_n82758688)
print v(xbgr.mr_n82758800)
print v(xbgr.mr_n82759120)
print v(xbgr.mr_n82759232)
print v(xbgr.mr_n82759552)
print v(xbgr.mr_n82759664)
print v(xbgr.mr_n82759984)
print v(xbgr.mr_n82760096)
print v(xbgr.mr_n82760528)
print v(xbgr.mr_n82760848)
print v(xbgr.mr_n82760960)
print v(xbgr.mr_n82761280)
print v(xbgr.mr_n82761392)
print v(xbgr.mr_n82761712)
print v(xbgr.mr_n82761824)
print v(xbgr.mr_n82762144)
print v(xbgr.mr_n82762256)
print v(xbgr.mr_n82762576)
print v(xbgr.mr_n82762688)
print v(xbgr.mr_n82763008)
print v(xbgr.mr_n82763120)
print v(xbgr.mr_n82763440)
print v(xbgr.mr_n82763552)
print v(xbgr.mr_n82763872)
print v(xbgr.mr_n82763984)
print v(xbgr.mr_n82764304)
print v(xbgr.mr_n82764416)
print v(xbgr.mr_n82764736)
print v(xbgr.mr_n82764848)
print v(xbgr.mr_n82765168)
print v(xbgr.mr_n82765280)
print v(xbgr.mr_n82765600)
print v(xbgr.mr_n82765712)
print v(xbgr.mr_n82766032)
print v(xbgr.mr_n82766144)
print v(xbgr.mr_n82766576)
print v(xbgr.mr_n82766896)
print v(xbgr.mr_n82767008)
print v(xbgr.mr_n82767328)
print v(xbgr.mr_n82767440)
print v(xbgr.mr_n82767760)
print v(xbgr.mr_n82767872)
print v(xbgr.mr_n82768304)
print v(xbgr.mr_n82768624)
print v(xbgr.mr_n82768736)
print v(xbgr.mr_n82769168)
print v(xbgr.mr_n82769488)
print v(xbgr.mr_n82769600)
print v(xbgr.mr_n82769920)
print v(xbgr.mr_n82770032)
print v(xbgr.mr_n82770352)
print v(xbgr.mr_n82770464)
print v(xbgr.mr_n82770896)
print v(xbgr.mr_n82771216)
print v(xbgr.mr_n82771328)
print v(xbgr.mr_n82771648)
print v(xbgr.mr_n82771760)
print v(xbgr.mr_n82772080)
print v(xbgr.mr_n82772192)
print v(xbgr.mr_n82772512)
print v(xbgr.mr_n82772624)
print v(xbgr.mr_n82772944)
print v(xbgr.mr_n82773056)
print v(xbgr.mr_n82773376)
print v(xbgr.mr_n82773488)
print v(xbgr.mr_n82773808)
print v(xbgr.mr_n82773920)
print v(xbgr.mr_n82774240)
print v(xbgr.mr_n82774352)
print v(xbgr.mr_n82774672)
print v(xbgr.mr_n82774784)
print v(xbgr.mr_n82775216)
print v(xbgr.mr_n82775536)
print v(xbgr.mr_n82775648)
print v(xbgr.mr_n82775968)
print v(xbgr.mr_n82776080)
print v(xbgr.mr_n82776400)
print v(xbgr.mr_n82776512)
print v(xbgr.mr_n82776832)
print v(xbgr.mr_n82776944)
print v(xbgr.mr_n82777264)
print v(xbgr.mr_n82777376)
print v(xbgr.mr_n82777696)
print v(xbgr.mr_n82777808)
print v(xbgr.mr_n82778128)
print v(xbgr.mr_n82778240)
print v(xbgr.mr_n82778560)
print v(xbgr.mr_n82778672)
print v(xbgr.mr_n82778992)
print v(xbgr.mr_n82779104)
print v(xbgr.mr_n82779424)
print v(xbgr.mr_n82779536)
print v(xbgr.mr_n82779856)
print v(xbgr.mr_n82779968)
print v(xbgr.mr_n82780288)
print v(xbgr.mr_n82780400)
print v(xbgr.mr_n82780720)
print v(xbgr.mr_n82780832)
print v(xbgr.mr_n82781152)
print v(xbgr.mr_n82781264)
print v(xbgr.mr_n82781584)
print v(xbgr.mr_n82781696)
print v(xbgr.mr_n82782016)
print v(xbgr.mr_n82782128)
print v(xbgr.mr_n82782448)
print v(xbgr.mr_n82782560)
print v(xbgr.mr_n82782880)
print v(xbgr.mr_n82782992)
print v(xbgr.mr_n82783312)
print v(xbgr.mr_n82783424)
print v(xbgr.mr_n82783744)
print v(xbgr.mr_n82783856)
print v(xbgr.mr_n82784176)
print v(xbgr.mr_n82784288)
print v(xbgr.mr_n82784608)
print v(xbgr.mr_n82784720)
print v(xbgr.mr_n82785040)
print v(xbgr.mr_n82785152)
print v(xbgr.mr_n82785472)
print v(xbgr.mr_n82785584)
print v(xbgr.mr_n82785904)
print v(xbgr.mr_n82786016)
print v(xbgr.mr_n82786336)
print v(xbgr.mr_n82786448)
print v(xbgr.mr_n82786768)
print v(xbgr.mr_n82786880)
print v(xbgr.mr_n82787200)
print v(xbgr.mr_n82787312)
print v(xbgr.mr_n82787632)
print v(xbgr.mr_n82787744)
print v(xbgr.mr_n82788064)
print v(xbgr.mr_n82788176)
print v(xbgr.mr_n82788496)
print v(xbgr.mr_n82788608)
print v(xbgr.mr_n82788928)
print v(xbgr.mr_n82789040)
print v(xbgr.mr_n82789360)
print v(xbgr.mr_n82789472)
print v(xbgr.mr_n82789792)
print v(xbgr.mr_n82789904)
print v(xbgr.mr_n82790224)
print v(xbgr.mr_n82790336)
print v(xbgr.mr_n82790656)
print v(xbgr.mr_n82790768)
print v(xbgr.mr_n82791088)
print v(xbgr.mr_n82791200)
print v(xbgr.mr_n82791520)
print v(xbgr.mr_n82791632)
print v(xbgr.mr_n82791952)
print v(xbgr.mr_n82792064)
print v(xbgr.mr_n82792384)
print v(xbgr.mr_n82792496)
print v(xbgr.mr_n82792816)
print v(xbgr.mr_n82792928)
print v(xbgr.mr_n82793248)
print v(xbgr.mr_n82793360)
print v(xbgr.mr_n82793680)
print v(xbgr.mr_n82793792)
print v(xbgr.mr_n82794112)
print v(xbgr.mr_n82794224)
print v(xbgr.mr_n82794544)
print v(xbgr.mr_n82794656)
print v(xbgr.mr_n82794976)
print v(xbgr.mr_n82795088)
print v(xbgr.mr_n82795408)
print v(xbgr.mr_n82795520)
print v(xbgr.mr_n82795840)
print v(xbgr.mr_n82795952)
print v(xbgr.mr_n82796272)
print v(xbgr.mr_n82796384)
print v(xbgr.mr_n82796704)
print v(xbgr.mr_n82796816)
print v(xbgr.mr_n82797136)
print v(xbgr.mr_n82797248)
print v(xbgr.mr_n82797568)
print v(xbgr.mr_n82797680)
print v(xbgr.mr_n82798000)
print v(xbgr.mr_n82798112)
print v(xbgr.mr_n82798432)
print v(xbgr.mr_n82798544)
print v(xbgr.mr_n82798864)
print v(xbgr.mr_n82798976)
print v(xbgr.mr_n82799296)
print v(xbgr.mr_n82799408)
print v(xbgr.mr_n82799728)
print v(xbgr.mr_n82799840)
print v(xbgr.mr_n82800160)
print v(xbgr.mr_n82800272)
print v(xbgr.mr_n82800592)
print v(xbgr.mr_n82800704)
print v(xbgr.mr_n82801024)
print v(xbgr.mr_n82801136)
print v(xbgr.mr_n82801456)
print v(xbgr.mr_n82801568)
print v(xbgr.mr_n82801888)
print v(xbgr.mr_n82802000)
print v(xbgr.mr_n82802320)
print v(xbgr.mr_n82802432)
print v(xbgr.mr_n82802752)
print v(xbgr.mr_n82802864)
print v(xbgr.mr_n82803184)
print v(xbgr.mr_n82803296)
print v(xbgr.mr_n82803616)
print v(xbgr.mr_n82803728)
print v(xbgr.mr_n82804048)
print v(xbgr.mr_n82804160)
print v(xbgr.mr_n82804480)
print v(xbgr.mr_n82804592)
print v(xbgr.mr_n82804912)
print v(xbgr.mr_n82805024)
print v(xbgr.mr_n82805344)
print v(xbgr.mr_n82805456)
print v(xbgr.mr_n82805776)
print v(xbgr.mr_n82805888)
print v(xbgr.mr_n82806208)
print v(xbgr.mr_n82806320)
print v(xbgr.mr_n82806640)
print v(xbgr.mr_n82806752)
print v(xbgr.mr_n82807072)
print v(xbgr.mr_n82807184)
print v(xbgr.mr_n82807504)
print v(xbgr.mr_n82807616)
print v(xbgr.mr_n82807936)
print v(xbgr.mr_n82808048)
print v(xbgr.mr_n82808368)
print v(xbgr.mr_n82808480)
print v(xbgr.mr_n82808800)
print v(xbgr.mr_n82808912)
print v(xbgr.mr_n82809232)
print v(xbgr.mr_n82809344)
print v(xbgr.mr_n82809664)
print v(xbgr.mr_n82809776)
print v(xbgr.mr_n82810096)
print v(xbgr.mr_n82810208)
print v(xbgr.mr_n82810528)
print v(xbgr.mr_n82810640)
print v(xbgr.mr_n82810960)
print v(xbgr.mr_n82811072)
print v(xbgr.mr_n82811392)
print v(xbgr.mr_n82811504)
print v(xbgr.mr_n82811824)
print v(xbgr.mr_n82811936)
print v(xbgr.mr_n82812256)
print v(xbgr.mr_n82812368)
print v(xbgr.mr_n82812688)
print v(xbgr.mr_n82812800)
print v(xbgr.mr_n82813120)
print v(xbgr.mr_n82813232)
print v(xbgr.mr_n82813552)
print v(xbgr.mr_n82813664)
print v(xbgr.mr_n82813984)
print v(xbgr.mr_n82814096)
print v(xbgr.mr_n82814416)
print v(xbgr.mr_n82814528)
print v(xbgr.mr_n82814848)
print v(xbgr.mr_n82814960)
print v(xbgr.mr_n82815280)
print v(xbgr.mr_n82815392)
print v(xbgr.mr_n82815712)
print v(xbgr.mr_n82815824)
print v(xbgr.mr_n82816144)
print v(xbgr.mr_n82816256)
print v(xbgr.mr_n82816576)
print v(xbgr.mr_n82816688)
print v(xbgr.mr_n82817008)
print v(xbgr.mr_n82817120)
print v(xbgr.mr_n82817440)
print v(xbgr.mr_n82817552)
print v(xbgr.mr_n82817872)
print v(xbgr.mr_n82817984)
print v(xbgr.mr_n82818304)
print v(xbgr.mr_n82818416)
print v(xbgr.mr_n82818736)
print v(xbgr.mr_n82818848)
print v(xbgr.mr_n82819168)
print v(xbgr.mr_n82819280)
print v(xbgr.mr_n82819600)
print v(xbgr.mr_n82819712)
print v(xbgr.mr_n82820032)
print v(xbgr.mr_n82820144)
print v(xbgr.mr_n82820464)
print v(xbgr.mr_n82820576)
print v(xbgr.mr_n82820896)
print v(xbgr.mr_n82821008)
print v(xbgr.mr_n82821328)
print v(xbgr.mr_n82821440)
print v(xbgr.mr_n82821760)
print v(xbgr.mr_n82821872)
print v(xbgr.mr_n82822192)
print v(xbgr.mr_n82822304)
print v(xbgr.mr_n82822624)
print v(xbgr.mr_n82822736)
print v(xbgr.mr_n82823056)
print v(xbgr.mr_n82823168)
print v(xbgr.mr_n82823488)
print v(xbgr.mr_n82823600)
print v(xbgr.mr_n82823920)
print v(xbgr.mr_n82824032)
print v(xbgr.mr_n82824352)
print v(xbgr.mr_n82824464)
print v(xbgr.mr_n82824784)
print v(xbgr.mr_n82824896)
print v(xbgr.mr_n82825216)
print v(xbgr.mr_n82825328)
print v(xbgr.mr_n82825648)
print v(xbgr.mr_n82825760)
print v(xbgr.mr_n82826080)
print v(xbgr.mr_n82826192)
print v(xbgr.mr_n82826512)
print v(xbgr.mr_n82826624)
print v(xbgr.mr_n82826944)
print v(xbgr.mr_n82827056)
print v(xbgr.mr_n82827376)
print v(xbgr.mr_n82827488)
print v(xbgr.mr_n82827808)
print v(xbgr.mr_n82827920)
print v(xbgr.mr_n82828240)
print v(xbgr.mr_n82828352)
print v(xbgr.mr_n82828672)
print v(xbgr.mr_n82828784)
print v(xbgr.mr_n82829104)
print v(xbgr.mr_n82829216)
print v(xbgr.mr_n82829536)
print v(xbgr.mr_n82829648)
print v(xbgr.mr_n82829968)
print v(xbgr.mr_n82830080)
print v(xbgr.mr_n82830400)
print v(xbgr.mr_n82830512)
print v(xbgr.mr_n82830832)
print v(xbgr.mr_n82830944)
print v(xbgr.mr_n82831264)
print v(xbgr.mr_n82831376)
print v(xbgr.mr_n82831696)
print v(xbgr.mr_n82831808)
print v(xbgr.mr_n82832128)
print v(xbgr.mr_n82832240)
print v(xbgr.mr_n82832560)
print v(xbgr.mr_n82832672)
print v(xbgr.mr_n82832992)
print v(xbgr.mr_n82833104)
print v(xbgr.mr_n82833424)
print v(xbgr.mr_n82833536)
print v(xbgr.mr_n82833856)
print v(xbgr.mr_n82833968)
print v(xbgr.mr_n82834288)
print v(xbgr.mr_n82834400)
print v(xbgr.mr_n82834720)
print v(xbgr.mr_n82834832)
print v(xbgr.mr_n82835152)
print v(xbgr.mr_n82835264)
print v(xbgr.mr_n82835584)
print v(xbgr.mr_n82835696)
print v(xbgr.mr_n82836016)
print v(xbgr.mr_n82836128)
print v(xbgr.mr_n82836448)
print v(xbgr.mr_n82836560)
print v(xbgr.mr_n82836880)
print v(xbgr.mr_n82836992)
print v(xbgr.mr_n82837312)
print v(xbgr.mr_n82837424)
print v(xbgr.mr_n82837744)
print v(xbgr.mr_n82837856)
print v(xbgr.mr_n82838176)
print v(xbgr.mr_n82838288)
print v(xbgr.mr_n82838608)
print v(xbgr.mr_n82838720)
print v(xbgr.mr_n82839040)
print v(xbgr.mr_n82839152)
print v(xbgr.mr_n82839472)
print v(xbgr.mr_n82839584)
print v(xbgr.mr_n82839904)
print v(xbgr.mr_n82840016)
print v(xbgr.mr_n82840336)
print v(xbgr.mr_n82840448)
print v(xbgr.mr_n82840768)
print v(xbgr.mr_n82840880)
print v(xbgr.mr_n82841200)
print v(xbgr.mr_n82841312)
print v(xbgr.mr_n82841632)
print v(xbgr.mr_n82841744)
print v(xbgr.mr_n82842064)
print v(xbgr.mr_n82842176)
print v(xbgr.mr_n82842496)
print v(xbgr.mr_n82842608)
print v(xbgr.mr_n82842928)
print v(xbgr.mr_n82843040)
print v(xbgr.mr_n82843360)
print v(xbgr.mr_n82843472)
print v(xbgr.mr_n82843792)
print v(xbgr.mr_n82843904)
print v(xbgr.mr_n82844224)
print v(xbgr.mr_n82844336)
print v(xbgr.mr_n82844656)
print v(xbgr.mr_n82844768)
print v(xbgr.mr_n82845088)
print v(xbgr.mr_n82845200)
print v(xbgr.mr_n82845520)
print v(xbgr.mr_n82845632)
print v(xbgr.mr_n82845952)
print v(xbgr.mr_n82846064)
print v(xbgr.mr_n82846384)
print v(xbgr.mr_n82846496)
print v(xbgr.mr_n82846816)
print v(xbgr.mr_n82846928)
print v(xbgr.mr_n82847248)
print v(xbgr.mr_n82847360)
print v(xbgr.mr_n82847680)
print v(xbgr.mr_n82847792)
print v(xbgr.mr_n82848112)
print v(xbgr.mr_n82848224)
print v(xbgr.mr_n82848544)
print v(xbgr.mr_n82848656)
print v(xbgr.mr_n82848976)
print v(xbgr.mr_n82849088)
print v(xbgr.mr_n82849408)
print v(xbgr.mr_n82849520)
print v(xbgr.mr_n82849840)
print v(xbgr.mr_n82849952)
print v(xbgr.mr_n82850272)
print v(xbgr.mr_n82850384)
print v(xbgr.mr_n82850704)
print v(xbgr.mr_n82850816)
print v(xbgr.mr_n82851136)
print v(xbgr.mr_n82851248)
print v(xbgr.mr_n82851568)
print v(xbgr.mr_n82851680)
print v(xbgr.mr_n82852000)
print v(xbgr.mr_n82852112)
print v(xbgr.mr_n82852432)
print v(xbgr.mr_n82852544)
print v(xbgr.mr_n82852864)
print v(xbgr.mr_n82852976)
print v(xbgr.mr_n82853296)
print v(xbgr.mr_n82853408)
print v(xbgr.mr_n82853728)
print v(xbgr.mr_n82853840)
print v(xbgr.mr_n82854160)
print v(xbgr.mr_n82854272)
print v(xbgr.mr_n82854592)
print v(xbgr.mr_n82854704)
print v(xbgr.mr_n82855024)
print v(xbgr.mr_n82855136)
print v(xbgr.mr_n82855456)
print v(xbgr.mr_n82855568)
print v(xbgr.mr_n82855888)
print v(xbgr.mr_n82856000)
print v(xbgr.mr_n82856320)
print v(xbgr.mr_n82856432)
print v(xbgr.mr_n82856752)
print v(xbgr.mr_n82856864)
print v(xbgr.mr_n82857184)
print v(xbgr.mr_n82857296)
print v(xbgr.mr_n82857616)
print v(xbgr.mr_n82857728)
print v(xbgr.mr_n82858048)
print v(xbgr.mr_n82858160)
print v(xbgr.mr_n82858480)
print v(xbgr.mr_n82858592)
print v(xbgr.mr_n82858912)
print v(xbgr.mr_n82859024)
print v(xbgr.mr_n82859344)
print v(xbgr.mr_n82859456)
print v(xbgr.mr_n82859776)
print v(xbgr.mr_n82859888)
print v(xbgr.mr_n82860208)
print v(xbgr.mr_n82860320)
print v(xbgr.mr_n82860640)
print v(xbgr.mr_n82860752)
print v(xbgr.mr_n82861072)
print v(xbgr.mr_n82861184)
print v(xbgr.mr_n82861504)
print v(xbgr.mr_n82861616)
print v(xbgr.mr_n82861936)
print v(xbgr.mr_n82862048)
print v(xbgr.mr_n82862368)
print v(xbgr.mr_n82862480)
print v(xbgr.mr_n82862800)
print v(xbgr.mr_n82862912)
print v(xbgr.mr_n82863232)
print v(xbgr.mr_n82863344)
print v(xbgr.mr_n82863664)
print v(xbgr.mr_n82863776)
print v(xbgr.mr_n82864096)
print v(xbgr.mr_n82864208)
print v(xbgr.mr_n82864528)
print v(xbgr.mr_n82864640)
print v(xbgr.mr_n82864960)
print v(xbgr.mr_n82865072)
print v(xbgr.mr_n82865392)
print v(xbgr.mr_n82865504)
print v(xbgr.mr_n82865824)
print v(xbgr.mr_n82865936)
print v(xbgr.mr_n82866256)
print v(xbgr.mr_n82866368)
print v(xbgr.mr_n82866688)
print v(xbgr.mr_n82866800)
print v(xbgr.mr_n82867120)
print v(xbgr.mr_n82867232)
print v(xbgr.mr_n82867552)
print v(xbgr.mr_n82867664)
print v(xbgr.mr_n82867984)
print v(xbgr.mr_n82868096)
print v(xbgr.mr_n82868416)
print v(xbgr.mr_n82868528)
print v(xbgr.mr_n82868848)
print v(xbgr.mr_n82868960)
print v(xbgr.mr_n82869280)
print v(xbgr.mr_n82869392)
print v(xbgr.mr_n82869712)
print v(xbgr.mr_n82869824)
print v(xbgr.mr_n82870144)
print v(xbgr.mr_n82870256)
print v(xbgr.mr_n82870576)
print v(xbgr.mr_n82870688)
print v(xbgr.mr_n82871008)
print v(xbgr.mr_n82871120)
print v(xbgr.mr_n82871440)
print v(xbgr.mr_n82871552)
print v(xbgr.mr_n82871872)
print v(xbgr.mr_n82871984)
print v(xbgr.mr_n82872304)
print v(xbgr.mr_n82872416)
print v(xbgr.mr_n82872736)
print v(xbgr.mr_n82872848)
print v(xbgr.mr_n82873168)
print v(xbgr.mr_n82873280)
print v(xbgr.mr_n82873600)
print v(xbgr.mr_n82873712)
print v(xbgr.mr_n82874032)
print v(xbgr.mr_n82874144)
print v(xbgr.mr_n82874464)
print v(xbgr.mr_n82874576)
print v(xbgr.mr_n82874896)
print v(xbgr.mr_n82875008)
print v(xbgr.mr_n82875328)
print v(xbgr.mr_n82875440)
print v(xbgr.mr_n82875760)
print v(xbgr.mr_n82875872)
print v(xbgr.mr_n82876192)
print v(xbgr.mr_n82876304)
print v(xbgr.mr_n82876624)
print v(xbgr.mr_n82876736)
print v(xbgr.mr_n82877056)
print v(xbgr.mr_n82877168)
print v(xbgr.mr_n82877488)
print v(xbgr.mr_n82877600)
print v(xbgr.mr_n82877920)
print v(xbgr.mr_n82878032)
print v(xbgr.mr_n82878352)
print v(xbgr.mr_n82878464)
print v(xbgr.mr_n82878784)
print v(xbgr.mr_n82878896)
print v(xbgr.mr_n82879216)
print v(xbgr.mr_n82879328)
print v(xbgr.mr_n82879760)
print v(xbgr.mr_n82880080)
print v(xbgr.mr_n82880192)
print v(xbgr.mr_n82880512)
print v(xbgr.mr_n82880624)
print v(xbgr.mr_n82880944)
print v(xbgr.mr_n82881056)
print v(xbgr.mr_n82881376)
print v(xbgr.mr_n82881488)
print v(xbgr.mr_n82881808)
print v(xbgr.mr_n82881920)
print v(xbgr.mr_n82882352)
print v(xbgr.mr_n82882672)
print v(xbgr.mr_n82882784)
print v(xbgr.mr_n82883104)
print v(xbgr.mr_n82883216)
print v(xbgr.mr_n82883536)
print v(xbgr.mr_n82883648)
print v(xbgr.mr_n82883968)
print v(xbgr.mr_n82884080)
print v(xbgr.mr_n82884400)
print v(xbgr.mr_n82884512)
print v(xbgr.mr_n82884944)
print v(xbgr.mr_n82885264)
print v(xbgr.mr_n82885376)
print v(xbgr.mr_n82885696)
print v(xbgr.mr_n82885808)
print v(xbgr.mr_n82886128)
print v(xbgr.mr_n82886240)
print v(xbgr.mr_n82886560)
print v(xbgr.mr_n82886672)
print v(xbgr.mr_n82886992)
print v(xbgr.mr_n82887104)
print v(xbgr.mr_n82887424)
print v(xbgr.mr_n82887536)
print v(xbgr.mr_n82887856)
print v(xbgr.mr_n82887968)
print v(xbgr.mr_n82888400)
print v(xbgr.mr_n82888720)
print v(xbgr.mr_n82888832)
print v(xbgr.mr_n82889264)
print v(xbgr.mr_n82889584)
print v(xbgr.mr_n82889696)
print v(xbgr.mr_n82890016)
print v(xbgr.mr_n82890128)
print v(xbgr.mr_n82890448)
print v(xbgr.mr_n82890560)
print v(xbgr.mr_n82890880)
print v(xbgr.mr_n82890992)
print v(xbgr.mr_n82891312)
print v(xbgr.mr_n82891424)
print v(xbgr.mr_n82891856)
print v(xbgr.mr_n82892176)
print v(xbgr.mr_n82892288)
print v(xbgr.mr_n82892720)
print v(xbgr.mr_n82893040)
print v(xbgr.mr_n82893152)
print v(xbgr.mr_n82893472)
print v(xbgr.mr_n82893584)
print v(xbgr.mr_n82893904)
print v(xbgr.mr_n82894016)
print v(xbgr.mr_n82894336)
print v(xbgr.mr_n82894448)
print v(xbgr.mr_n82894768)
print v(xbgr.mr_n82894880)
print v(xbgr.mr_n82895200)
print v(xbgr.mr_n82895312)
print v(xbgr.mr_n82895632)
print v(xbgr.mr_n82895744)
print v(xbgr.mr_n82896064)
print v(xbgr.mr_n82896176)
print v(xbgr.mr_n82896496)
print v(xbgr.mr_n82896608)
print v(xbgr.mr_n82896928)
print v(xbgr.mr_n82897040)
print v(xbgr.mr_n82897360)
print v(xbgr.mr_n82897472)
print v(xbgr.mr_n82897792)
print v(xbgr.mr_n82897904)
print v(xbgr.mr_n82898224)
print v(xbgr.mr_n82898336)
print v(xbgr.mr_n82898656)
print v(xbgr.mr_n82898768)
print v(xbgr.mr_n82899088)
print v(xbgr.mr_n82899200)
print v(xbgr.mr_n82899520)
print v(xbgr.mr_n82899632)
print v(xbgr.mr_n82899952)
print v(xbgr.mr_n82900064)
print v(xbgr.mr_n82900384)
print v(xbgr.mr_n82900496)
print v(xbgr.mr_n82900816)
print v(xbgr.mr_n82900928)
print v(xbgr.mr_n82901248)
print v(xbgr.mr_n82901360)
print v(xbgr.mr_n82901680)
print v(xbgr.mr_n82901792)
print v(xbgr.mr_n82902112)
print v(xbgr.mr_n82902224)
print v(xbgr.mr_n82902544)
print v(xbgr.mr_n82902656)
print v(xbgr.mr_n82902976)
print v(xbgr.mr_n82903088)
print v(xbgr.mr_n82903408)
print v(xbgr.mr_n82903520)
print v(xbgr.mr_n82903840)
print v(xbgr.mr_n82903952)
print v(xbgr.mr_n82904272)
print v(xbgr.mr_n82904384)
print v(xbgr.mr_n82904704)
print v(xbgr.mr_n82904816)
print v(xbgr.mr_n82905136)
print v(xbgr.mr_n82905248)
print v(xbgr.mr_n82905568)
print v(xbgr.mr_n82905680)
print v(xbgr.mr_n82906000)
print v(xbgr.mr_n82906112)
print v(xbgr.mr_n82906432)
print v(xbgr.mr_n82906544)
print v(xbgr.mr_n82906864)
print v(xbgr.mr_n82906976)
print v(xbgr.mr_n82907296)
print v(xbgr.mr_n82907408)
print v(xbgr.mr_n82907728)
print v(xbgr.mr_n82907840)
print v(xbgr.mr_n82908160)
print v(xbgr.mr_n82908272)
print v(xbgr.mr_n82908592)
print v(xbgr.mr_n82908704)
print v(xbgr.mr_n82909024)
print v(xbgr.mr_n82909136)
print v(xbgr.mr_n82909456)
print v(xbgr.mr_n82909568)
print v(xbgr.mr_n82909888)
print v(xbgr.mr_n82910000)
print v(xbgr.mr_n82910320)
print v(xbgr.mr_n82910432)
print v(xbgr.mr_n82910752)
print v(xbgr.mr_n82910864)
print v(xbgr.mr_n82911184)
print v(xbgr.mr_n82911296)
print v(xbgr.mr_n82911616)
print v(xbgr.mr_n82911728)
print v(xbgr.mr_n82912048)
print v(xbgr.mr_n82912160)
print v(xbgr.mr_n82912480)
print v(xbgr.mr_n82912592)
print v(xbgr.mr_n82912912)
print v(xbgr.mr_n82913024)
print v(xbgr.mr_n82913344)
print v(xbgr.mr_n82913456)
print v(xbgr.mr_n82913776)
print v(xbgr.mr_n82913888)
print v(xbgr.mr_n82914208)
print v(xbgr.mr_n82914320)
print v(xbgr.mr_n82914640)
print v(xbgr.mr_n82914752)
print v(xbgr.mr_n82915072)
print v(xbgr.mr_n82915184)
print v(xbgr.mr_n82915504)
print v(xbgr.mr_n82915616)
print v(xbgr.mr_n82915936)
print v(xbgr.mr_n82916048)
print v(xbgr.mr_n82916368)
print v(xbgr.mr_n82916480)
print v(xbgr.mr_n82916800)
print v(xbgr.mr_n82916912)
print v(xbgr.mr_n82917232)
print v(xbgr.mr_n82917344)
print v(xbgr.mr_n82917664)
print v(xbgr.mr_n82917776)
print v(xbgr.mr_n82918096)
print v(xbgr.mr_n82918208)
print v(xbgr.mr_n82918528)
print v(xbgr.mr_n82918640)
print v(xbgr.mr_n82918960)
print v(xbgr.mr_n82919072)
print v(xbgr.mr_n82919392)
print v(xbgr.mr_n82919504)
print v(xbgr.mr_n82919824)
print v(xbgr.mr_n82919936)
print v(xbgr.mr_n82920256)
print v(xbgr.mr_n82920368)
print v(xbgr.mr_n82920688)
print v(xbgr.mr_n82920800)
print v(xbgr.mr_n82921120)
print v(xbgr.mr_n82921232)
print v(xbgr.mr_n82921552)
print v(xbgr.mr_n82921664)
print v(xbgr.mr_n82921984)
print v(xbgr.mr_n82922096)
print v(xbgr.mr_n82922416)
print v(xbgr.mr_n82922528)
print v(xbgr.mr_n82922848)
print v(xbgr.mr_n82922960)
print v(xbgr.mr_n82923280)
print v(xbgr.mr_n82923392)
print v(xbgr.mr_n82923712)
print v(xbgr.mr_n82923824)
print v(xbgr.mr_n82924144)
print v(xbgr.mr_n82924256)
print v(xbgr.mr_n82924576)
print v(xbgr.mr_n82924688)
print v(xbgr.mr_n82925008)
print v(xbgr.mr_n82925120)
print v(xbgr.mr_n82925440)
print v(xbgr.mr_n82925552)
print v(xbgr.mr_n82925872)
print v(xbgr.mr_n82925984)
print v(xbgr.mr_n82926416)
print v(xbgr.mr_n82926736)
print v(xbgr.mr_n82926848)
print v(xbgr.mr_n82927168)
print v(xbgr.mr_n82927280)
print v(xbgr.mr_n82927600)
print v(xbgr.mr_n82927712)
print v(xbgr.mr_n82928144)
print v(xbgr.mr_n82928464)
print v(xbgr.mr_n82928576)
print v(xbgr.mr_n82929008)
print v(xbgr.mr_n82929328)
print v(xbgr.mr_n82929440)
print v(xbgr.mr_n82929760)
print v(xbgr.mr_n82929872)
print v(xbgr.mr_n82930192)
print v(xbgr.mr_n82930304)
print v(xbgr.mr_n82930624)
print v(xbgr.mr_n82930736)
print v(xbgr.mr_n82931056)
print v(xbgr.mr_n82931168)
print v(xbgr.mr_n82931488)
print v(xbgr.mr_n82931600)
print v(xbgr.mr_n82931920)
print v(xbgr.mr_n82932032)
print v(xbgr.mr_n82932352)
print v(xbgr.mr_n82932464)
print v(xbgr.mr_n82932784)
print v(xbgr.mr_n82932896)
print v(xbgr.mr_n82933216)
print v(xbgr.mr_n82933328)
print v(xbgr.mr_n82933648)
print v(xbgr.mr_n82933760)
print v(xbgr.mr_n82934080)
print v(xbgr.mr_n82934192)
print v(xbgr.mr_n82934512)
print v(xbgr.mr_n82934624)
print v(xbgr.mr_n82934944)
print v(xbgr.mr_n82935056)
print v(xbgr.mr_n82935376)
print v(xbgr.mr_n82935488)
print v(xbgr.mr_n82935808)
print v(xbgr.mr_n82935920)
print v(xbgr.mr_n82936240)
print v(xbgr.mr_n82936352)
print v(xbgr.mr_n82936672)
print v(xbgr.mr_n82936784)
print v(xbgr.mr_n82937104)
print v(xbgr.mr_n82937216)
print v(xbgr.mr_n82937536)
print v(xbgr.mr_n82937648)
print v(xbgr.mr_n82937968)
print v(xbgr.mr_n82938080)
print v(xbgr.mr_n82938400)
print v(xbgr.mr_n82938512)
print v(xbgr.mr_n82938832)
print v(xbgr.mr_n82938944)
print v(xbgr.mr_n82939264)
print v(xbgr.mr_n82939376)
print v(xbgr.mr_n82939696)
print v(xbgr.mr_n82939808)
print v(xbgr.mr_n82940128)
print v(xbgr.mr_n82940240)
print v(xbgr.mr_n82940560)
print v(xbgr.mr_n82940672)
print v(xbgr.mr_n82941104)
print v(xbgr.mr_n82941424)
print v(xbgr.mr_n82941536)
print v(xbgr.mr_n82941856)
print v(xbgr.mr_n82941968)
print v(xbgr.mr_n82942288)
print v(xbgr.mr_n82942400)
print v(xbgr.mr_n82942720)
print v(xbgr.mr_n82942832)
print v(xbgr.mr_n82943152)
print v(xbgr.mr_n82943264)
print v(xbgr.mr_n82943584)
print v(xbgr.mr_n82943696)
print v(xbgr.mr_n82944016)
print v(xbgr.mr_n82944128)
print v(xbgr.mr_n82944448)
print v(xbgr.mr_n82944560)
print v(xbgr.mr_n82944880)
print v(xbgr.mr_n82944992)
print v(xbgr.mr_n82945424)
print v(xbgr.mr_n82945744)
print v(xbgr.mr_n82945856)
print v(xbgr.mr_n82946176)
print v(xbgr.mr_n82946288)
print v(xbgr.mr_n82946608)
print v(xbgr.mr_n82946720)
print v(xbgr.mr_n82947152)
print v(xbgr.mr_n82947472)
print v(xbgr.mr_n82947584)
print v(xbgr.mr_n82947904)
print v(xbgr.mr_n82948016)
print v(xbgr.mr_n82948336)
print v(xbgr.mr_n82948448)
print v(xbgr.mr_n82948768)
print v(xbgr.mr_n82948880)
print v(xbgr.mr_n82949200)
print v(xbgr.mr_n82949312)
print v(xbgr.mr_n82949744)
print v(xbgr.mr_n82950064)
print v(xbgr.mr_n82950176)
print v(xbgr.mr_n82950496)
print v(xbgr.mr_n82950608)
print v(xbgr.mr_n82950928)
print v(xbgr.mr_n82951040)
print v(xbgr.mr_n82951360)
print v(xbgr.mr_n82951472)
print v(xbgr.mr_n82951792)
print v(xbgr.mr_n82951904)
print v(xbgr.mr_n82952224)
print v(xbgr.mr_n82952336)
print v(xbgr.mr_n82952656)
print v(xbgr.mr_n82952768)
print v(xbgr.mr_n82953088)
print v(xbgr.mr_n82953200)
print v(xbgr.mr_n82953520)
print v(xbgr.mr_n82953632)
print v(xbgr.mr_n82953952)
print v(xbgr.mr_n82954064)
print v(xbgr.mr_n82954384)
print v(xbgr.mr_n82954496)
print v(xbgr.mr_n82954816)
print v(xbgr.mr_n82954928)
print v(xbgr.mr_n82955248)
print v(xbgr.mr_n82955360)
print v(xbgr.mr_n82955680)
print v(xbgr.mr_n82955792)
print v(xbgr.mr_n82956112)
print v(xbgr.mr_n82956224)
print v(xbgr.mr_n82956544)
print v(xbgr.mr_n82956656)
print v(xbgr.mr_n82956976)
print v(xbgr.mr_n82957088)
print v(xbgr.mr_n82957408)
print v(xbgr.mr_n82957520)
print v(xbgr.mr_n82957840)
print v(xbgr.mr_n82957952)
print v(xbgr.mr_n82958272)
print v(xbgr.mr_n82958384)
print v(xbgr.mr_n82958704)
print v(xbgr.mr_n82958816)
print v(xbgr.mr_n82959136)
print v(xbgr.mr_n82959248)
print v(xbgr.mr_n82959568)
print v(xbgr.mr_n82959680)
print v(xbgr.mr_n82960000)
print v(xbgr.mr_n82960112)
print v(xbgr.mr_n82960432)
print v(xbgr.mr_n82960544)
print v(xbgr.mr_n82960864)
print v(xbgr.mr_n82960976)
print v(xbgr.mr_n82961296)
print v(xbgr.mr_n82961408)
print v(xbgr.mr_n82961728)
print v(xbgr.mr_n82961840)
print v(xbgr.mr_n82962160)
print v(xbgr.mr_n82962272)
print v(xbgr.mr_n82962592)
print v(xbgr.mr_n82962704)
print v(xbgr.mr_n82963024)
print v(xbgr.mr_n82963136)
print v(xbgr.mr_n82963456)
print v(xbgr.mr_n82963568)
print v(xbgr.mr_n82963888)
print v(xbgr.mr_n82964000)
print v(xbgr.mr_n82964320)
print v(xbgr.mr_n82964432)
print v(xbgr.mr_n82964752)
print v(xbgr.mr_n82964864)
print v(xbgr.mr_n82965184)
print v(xbgr.mr_n82965296)
print v(xbgr.mr_n82965616)
print v(xbgr.mr_n82965728)
print v(xbgr.mr_n82966048)
print v(xbgr.mr_n82966160)
print v(xbgr.mr_n82966480)
print v(xbgr.mr_n82966592)
print v(xbgr.mr_n82966912)
print v(xbgr.mr_n82967024)
print v(xbgr.mr_n82967344)
print v(xbgr.mr_n82967456)
print v(xbgr.mr_n82967776)
print v(xbgr.mr_n82967888)
print v(xbgr.mr_n82968208)
print v(xbgr.mr_n82968320)
print v(xbgr.mr_n82968640)
print v(xbgr.mr_n82968752)
print v(xbgr.mr_n82969072)
print v(xbgr.mr_n82969184)
print v(xbgr.mr_n82969504)
print v(xbgr.mr_n82969616)
print v(xbgr.mr_n82969936)
print v(xbgr.mr_n82970048)
print v(xbgr.mr_n82970368)
print v(xbgr.mr_n82970480)
print v(xbgr.mr_n82970800)
print v(xbgr.mr_n82970912)
print v(xbgr.mr_n82971232)
print v(xbgr.mr_n82971344)
print v(xbgr.mr_n82971664)
print v(xbgr.mr_n82971776)
print v(xbgr.mr_n82972096)
print v(xbgr.mr_n82972208)
print v(xbgr.mr_n82972528)
print v(xbgr.mr_n82972640)
print v(xbgr.mr_n82972960)
print v(xbgr.mr_n82973072)
print v(xbgr.mr_n82973392)
print v(xbgr.mr_n82973504)
print v(xbgr.mr_n82973824)
print v(xbgr.mr_n82973936)
print v(xbgr.mr_n82974256)
print v(xbgr.mr_n82974368)
print v(xbgr.mr_n82974688)
print v(xbgr.mr_n82974800)
print v(xbgr.mr_n82975120)
print v(xbgr.mr_n82975232)
print v(xbgr.mr_n82975552)
print v(xbgr.mr_n82975664)
print v(xbgr.mr_n82975984)
print v(xbgr.mr_n82976096)
print v(xbgr.mr_n82976416)
print v(xbgr.mr_n82976528)
print v(xbgr.mr_n82976848)
print v(xbgr.mr_n82976960)
print v(xbgr.mr_n82977280)
print v(xbgr.mr_n82977392)
print v(xbgr.mr_n82977712)
print v(xbgr.mr_n82977824)
print v(xbgr.mr_n82978144)
print v(xbgr.mr_n82978256)
print v(xbgr.mr_n82978576)
print v(xbgr.mr_n82978688)
print v(xbgr.mr_n82979008)
print v(xbgr.mr_n82979120)
print v(xbgr.mr_n82979440)
print v(xbgr.mr_n82979552)
print v(xbgr.mr_n82979984)
print v(xbgr.mr_n82980304)
print v(xbgr.mr_n82980416)
print v(xbgr.mr_n82980736)
print v(xbgr.mr_n82980848)
print v(xbgr.mr_n82981168)
print v(xbgr.mr_n82981280)
print v(xbgr.mr_n82981712)
print v(xbgr.mr_n82982032)
print v(xbgr.mr_n82982144)
print v(xbgr.mr_n82982576)
print v(xbgr.mr_n82982896)
print v(xbgr.mr_n82983008)
print v(xbgr.mr_n82983328)
print v(xbgr.mr_n82983440)
print v(xbgr.mr_n82983760)
print v(xbgr.mr_n82983872)
print v(xbgr.mr_n82984192)
print v(xbgr.mr_n82984304)
print v(xbgr.mr_n82984624)
print v(xbgr.mr_n82984736)
print v(xbgr.mr_n82985056)
print v(xbgr.mr_n82985168)
print v(xbgr.mr_n82985488)
print v(xbgr.mr_n82985600)
print v(xbgr.mr_n82985920)
print v(xbgr.mr_n82986032)
print v(xbgr.mr_n82986352)
print v(xbgr.mr_n82986464)
print v(xbgr.mr_n82986784)
print v(xbgr.mr_n82986896)
print v(xbgr.mr_n82987216)
print v(xbgr.mr_n82987328)
print v(xbgr.mr_n82987648)
print v(xbgr.mr_n82987760)
print v(xbgr.mr_n82988080)
print v(xbgr.mr_n82988192)
print v(xbgr.mr_n82988512)
print v(xbgr.mr_n82988624)
print v(xbgr.mr_n82988944)
print v(xbgr.mr_n82989056)
print v(xbgr.mr_n82989376)
print v(xbgr.mr_n82989488)
print v(xbgr.mr_n82989808)
print v(xbgr.mr_n82989920)
print v(xbgr.mr_n82990240)
print v(xbgr.mr_n82990352)
print v(xbgr.mr_n82990672)
print v(xbgr.mr_n82990784)
print v(xbgr.mr_n82991104)
print v(xbgr.mr_n82991216)
print v(xbgr.mr_n82991536)
print v(xbgr.mr_n82991648)
print v(xbgr.mr_n82991968)
print v(xbgr.mr_n82992080)
print v(xbgr.mr_n82992400)
print v(xbgr.mr_n82992512)
print v(xbgr.mr_n82992832)
print v(xbgr.mr_n82992944)
print v(xbgr.mr_n82993264)
print v(xbgr.mr_n82993376)
print v(xbgr.mr_n82993696)
print v(xbgr.mr_n82993808)
print v(xbgr.mr_n82994128)
print v(xbgr.mr_n82994240)
print v(xbgr.mr_n82994560)
print v(xbgr.mr_n82994672)
print v(xbgr.mr_n82994992)
print v(xbgr.mr_n82995104)
print v(xbgr.mr_n82995424)
print v(xbgr.mr_n82995536)
print v(xbgr.mr_n82995856)
print v(xbgr.mr_n82995968)
print v(xbgr.mr_n82996288)
print v(xbgr.mr_n82996400)
print v(xbgr.mr_n82996720)
print v(xbgr.mr_n82996832)
print v(xbgr.mr_n82997152)
print v(xbgr.mr_n82997264)
print v(xbgr.mr_n82997584)
print v(xbgr.mr_n82997696)
print v(xbgr.mr_n82998016)
print v(xbgr.mr_n82998128)
print v(xbgr.mr_n82998448)
print v(xbgr.mr_n82998560)
print v(xbgr.mr_n82998880)
print v(xbgr.mr_n82998992)
print v(xbgr.mr_n82999312)
print v(xbgr.mr_n82999424)
print v(xbgr.mr_n82999744)
print v(xbgr.mr_n82999856)
print v(xbgr.mr_n83000176)
print v(xbgr.mr_n83000288)
print v(xbgr.mr_n83000608)
print v(xbgr.mr_n83000720)
print v(xbgr.mr_n83001040)
print v(xbgr.mr_n83001152)
print v(xbgr.mr_n83001472)
print v(xbgr.mr_n83001584)
print v(xbgr.mr_n83001904)
print v(xbgr.mr_n83002016)
print v(xbgr.mr_n83002336)
print v(xbgr.mr_n83002448)
print v(xbgr.mr_n83002768)
print v(xbgr.mr_n83002880)
print v(xbgr.mr_n83003200)
print v(xbgr.mr_n83003312)
print v(xbgr.mr_n83003632)
print v(xbgr.mr_n83003744)
print v(xbgr.mr_n83004064)
print v(xbgr.mr_n83004176)
print v(xbgr.mr_n83004496)
print v(xbgr.mr_n83004608)
print v(xbgr.mr_n83004928)
print v(xbgr.mr_n83005040)
print v(xbgr.mr_n83005360)
print v(xbgr.mr_n83005472)
print v(xbgr.mr_n83005792)
print v(xbgr.mr_n83005904)
print v(xbgr.mr_n83006224)
print v(xbgr.mr_n83006336)
print v(xbgr.mr_n83006656)
print v(xbgr.mr_n83006768)
print v(xbgr.mr_n83007088)
print v(xbgr.mr_n83007200)
print v(xbgr.mr_n83007520)
print v(xbgr.mr_n83007632)
print v(xbgr.mr_n83007952)
print v(xbgr.mr_n83008064)
print v(xbgr.mr_n83008384)
print v(xbgr.mr_n83008496)
print v(xbgr.mr_n83008816)
print v(xbgr.mr_n83008928)
print v(xbgr.mr_n83009248)
print v(xbgr.mr_n83009360)
print v(xbgr.mr_n83009680)
print v(xbgr.mr_n83009792)
print v(xbgr.mr_n83010112)
print v(xbgr.mr_n83010224)
print v(xbgr.mr_n83010544)
print v(xbgr.mr_n83010656)
print v(xbgr.mr_n83010976)
print v(xbgr.mr_n83011088)
print v(xbgr.mr_n83011408)
print v(xbgr.mr_n83011520)
print v(xbgr.mr_n83011840)
print v(xbgr.mr_n83011952)
print v(xbgr.mr_n83012272)
print v(xbgr.mr_n83012384)
print v(xbgr.mr_n83012704)
print v(xbgr.mr_n83012816)
print v(xbgr.mr_n83013136)
print v(xbgr.mr_n83013248)
print v(xbgr.mr_n83013568)
print v(xbgr.mr_n83013680)
print v(xbgr.mr_n83014000)
print v(xbgr.mr_n83014112)
print v(xbgr.mr_n83014432)
print v(xbgr.mr_n83014544)
print v(xbgr.mr_n83014864)
print v(xbgr.mr_n83014976)
print v(xbgr.mr_n83015296)
print v(xbgr.mr_n83015408)
print v(xbgr.mr_n83015728)
print v(xbgr.mr_n83015840)
print v(xbgr.mr_n83016160)
print v(xbgr.mr_n83016272)
print v(xbgr.mr_n83016592)
print v(xbgr.mr_n83016704)
print v(xbgr.mr_n83017024)
print v(xbgr.mr_n83017136)
print v(xbgr.mr_n83017456)
print v(xbgr.mr_n83017568)
print v(xbgr.mr_n83017888)
print v(xbgr.mr_n83018000)
print v(xbgr.mr_n83018320)
print v(xbgr.mr_n83018432)
print v(xbgr.mr_n83018752)
print v(xbgr.mr_n83018864)
print v(xbgr.mr_n83019184)
print v(xbgr.mr_n83019296)
print v(xbgr.mr_n83019616)
print v(xbgr.mr_n83019728)
print v(xbgr.mr_n83020048)
print v(xbgr.mr_n83020160)
print v(xbgr.mr_n83020480)
print v(xbgr.mr_n83020592)
print v(xbgr.mr_n83020912)
print v(xbgr.mr_n83021024)
print v(xbgr.mr_n83021344)
print v(xbgr.mr_n83021456)
print v(xbgr.mr_n83021776)
print v(xbgr.mr_n83021888)
print v(xbgr.mr_n83022208)
print v(xbgr.mr_n83022320)
print v(xbgr.mr_n83022640)
print v(xbgr.mr_n83022752)
print v(xbgr.mr_n83023072)
print v(xbgr.mr_n83023184)
print v(xbgr.mr_n83023504)
print v(xbgr.mr_n83023616)
print v(xbgr.mr_n83023936)
print v(xbgr.mr_n83024048)
print v(xbgr.mr_n83024368)
print v(xbgr.mr_n83024480)
print v(xbgr.mr_n83024800)
print v(xbgr.mr_n83024912)
print v(xbgr.mr_n83025232)
print v(xbgr.mr_n83025344)
print v(xbgr.mr_n83025664)
print v(xbgr.mr_n83025776)
print v(xbgr.mr_n83026096)
print v(xbgr.mr_n83026208)
print v(xbgr.mr_n83026528)
print v(xbgr.mr_n83026640)
print v(xbgr.mr_n83026960)
print v(xbgr.mr_n83027072)
print v(xbgr.mr_n83027392)
print v(xbgr.mr_n83027504)
print v(xbgr.mr_n83027824)
print v(xbgr.mr_n83027936)
print v(xbgr.mr_n83028256)
print v(xbgr.mr_n83028368)
print v(xbgr.mr_n83028688)
print v(xbgr.mr_n83028800)
print v(xbgr.mr_n83029120)
print v(xbgr.mr_n83029232)
print v(xbgr.mr_n83029552)
print v(xbgr.mr_n83029664)
print v(xbgr.mr_n83029984)
print v(xbgr.mr_n83030096)
print v(xbgr.mr_n83030416)
print v(xbgr.mr_n83030528)
print v(xbgr.mr_n83030848)
print v(xbgr.mr_n83030960)
print v(xbgr.mr_n83031280)
print v(xbgr.mr_n83031392)
print v(xbgr.mr_n83031712)
print v(xbgr.mr_n83031824)
print v(xbgr.mr_n83032144)
print v(xbgr.mr_n83032256)
print v(xbgr.mr_n83032576)
print v(xbgr.mr_n83032688)
print v(xbgr.mr_n83033008)
print v(xbgr.mr_n83033120)
print v(xbgr.mr_n83033440)
print v(xbgr.mr_n83033552)
print v(xbgr.mr_n83033872)
print v(xbgr.mr_n83033984)
print v(xbgr.mr_n83034304)
print v(xbgr.mr_n83034416)
print v(xbgr.mr_n83034736)
print v(xbgr.mr_n83034848)
print v(xbgr.mr_n83035168)
print v(xbgr.mr_n83035280)
print v(xbgr.mr_n83035600)
print v(xbgr.mr_n83035712)
print v(xbgr.mr_n83036032)
print v(xbgr.mr_n83036144)
print v(xbgr.mr_n83036464)
print v(xbgr.mr_n83036576)
print v(xbgr.mr_n83036896)
print v(xbgr.mr_n83037008)
print v(xbgr.mr_n83037328)
print v(xbgr.mr_n83037440)
print v(xbgr.mr_n83037760)
print v(xbgr.mr_n83037872)
print v(xbgr.mr_n83038192)
print v(xbgr.mr_n83038304)
print v(xbgr.mr_n83038624)
print v(xbgr.mr_n83038736)
print v(xbgr.mr_n83039056)
print v(xbgr.mr_n83039168)
print v(xbgr.mr_n83039488)
print v(xbgr.mr_n83039600)
print v(xbgr.mr_n83039920)
print v(xbgr.mr_n83040032)
print v(xbgr.mr_n83040352)
print v(xbgr.mr_n83040464)
print v(xbgr.mr_n83040784)
print v(xbgr.mr_n83040896)
print v(xbgr.mr_n83041216)
print v(xbgr.mr_n83041328)
print v(xbgr.mr_n83041648)
print v(xbgr.mr_n83041760)
print v(xbgr.mr_n83042080)
print v(xbgr.mr_n83042192)
print v(xbgr.mr_n83042512)
print v(xbgr.mr_n83042624)
print v(xbgr.mr_n83042944)
print v(xbgr.mr_n83043056)
print v(xbgr.mr_n83043376)
print v(xbgr.mr_n83043488)
print v(xbgr.mr_n83043808)
print v(xbgr.mr_n83043920)
print v(xbgr.mr_n83044240)
print v(xbgr.mr_n83044352)
print v(xbgr.mr_n83044672)
print v(xbgr.mr_n83044784)
print v(xbgr.mr_n83045104)
print v(xbgr.mr_n83045216)
print v(xbgr.mr_n83045536)
print v(xbgr.mr_n83045648)
print v(xbgr.mr_n83045968)
print v(xbgr.mr_n83046080)
print v(xbgr.mr_n83046400)
print v(xbgr.mr_n83046512)
print v(xbgr.mr_n83046832)
print v(xbgr.mr_n83046944)
print v(xbgr.mr_n83047264)
print v(xbgr.mr_n83047376)
print v(xbgr.mr_n83047696)
print v(xbgr.mr_n83047808)
print v(xbgr.mr_n83048128)
print v(xbgr.mr_n83048240)
print v(xbgr.mr_n83048560)
print v(xbgr.mr_n83048672)
print v(xbgr.mr_n83048992)
print v(xbgr.mr_n83049104)
print v(xbgr.mr_n83049424)
print v(xbgr.mr_n83049536)
print v(xbgr.mr_n83049856)
print v(xbgr.mr_n83049968)
print v(xbgr.mr_n83050288)
print v(xbgr.mr_n83050400)
print v(xbgr.mr_n83050720)
print v(xbgr.mr_n83050832)
print v(xbgr.mr_n83051152)
print v(xbgr.mr_n83051264)
print v(xbgr.mr_n83051584)
print v(xbgr.mr_n83051696)
print v(xbgr.mr_n83052016)
print v(xbgr.mr_n83052128)
print v(xbgr.mr_n83052448)
print v(xbgr.mr_n83052560)
print v(xbgr.mr_n83052880)
print v(xbgr.mr_n83052992)
print v(xbgr.mr_n83053312)
print v(xbgr.mr_n83053424)
print v(xbgr.mr_n83053744)
print v(xbgr.mr_n83053856)
print v(xbgr.mr_n83054176)
print v(xbgr.mr_n83054288)
print v(xbgr.mr_n83054608)
print v(xbgr.mr_n83054720)
print v(xbgr.mr_n83055040)
print v(xbgr.mr_n83055152)
print v(xbgr.mr_n83055472)
print v(xbgr.mr_n83055584)
print v(xbgr.mr_n83055904)
print v(xbgr.mr_n83056016)
print v(xbgr.mr_n83056336)
print v(xbgr.mr_n83056448)
print v(xbgr.mr_n83056768)
print v(xbgr.mr_n83056880)
print v(xbgr.mr_n83057200)
print v(xbgr.mr_n83057312)
print v(xbgr.mr_n83057632)
print v(xbgr.mr_n83057744)
print v(xbgr.mr_n83058064)
print v(xbgr.mr_n83058176)
print v(xbgr.mr_n83058496)
print v(xbgr.mr_n83058608)
print v(xbgr.mr_n83058928)
print v(xbgr.mr_n83059040)
print v(xbgr.mr_n83059360)
print v(xbgr.mr_n83059472)
print v(xbgr.mr_n83059792)
print v(xbgr.mr_n83059904)
print v(xbgr.mr_n83060224)
print v(xbgr.mr_n83060336)
print v(xbgr.mr_n83060656)
print v(xbgr.mr_n83060768)
print v(xbgr.mr_n83061088)
print v(xbgr.mr_n83061200)
print v(xbgr.mr_n83061520)
print v(xbgr.mr_n83061632)
print v(xbgr.mr_n83061952)
print v(xbgr.mr_n83062064)
print v(xbgr.mr_n83062384)
print v(xbgr.mr_n83062496)
print v(xbgr.mr_n83062816)
print v(xbgr.mr_n83062928)
print v(xbgr.mr_n83063248)
print v(xbgr.mr_n83063360)
print v(xbgr.mr_n83063680)
print v(xbgr.mr_n83063792)
print v(xbgr.mr_n83064112)
print v(xbgr.mr_n83064224)
print v(xbgr.mr_n83064544)
print v(xbgr.mr_n83064656)
print v(xbgr.mr_n83064976)
print v(xbgr.mr_n83065088)
print v(xbgr.mr_n83065408)
print v(xbgr.mr_n83065520)
print v(xbgr.mr_n83065840)
print v(xbgr.mr_n83065952)
print v(xbgr.mr_n83066272)
print v(xbgr.mr_n83066384)
print v(xbgr.mr_n83066704)
print v(xbgr.mr_n83066816)
print v(xbgr.mr_n83067136)
print v(xbgr.mr_n83067248)
print v(xbgr.mr_n83067568)
print v(xbgr.mr_n83067680)
print v(xbgr.mr_n83068000)
print v(xbgr.mr_n83068112)
print v(xbgr.mr_n83068432)
print v(xbgr.mr_n83068544)
print v(xbgr.mr_n83068864)
print v(xbgr.mr_n83068976)
print v(xbgr.mr_n83069296)
print v(xbgr.mr_n83069408)
print v(xbgr.mr_n83069728)
print v(xbgr.mr_n83069840)
print v(xbgr.mr_n83070160)
print v(xbgr.mr_n83070272)
print v(xbgr.mr_n83070592)
print v(xbgr.mr_n83070704)
print v(xbgr.mr_n83071024)
print v(xbgr.mr_n83071136)
print v(xbgr.mr_n83071456)
print v(xbgr.mr_n83071568)
print v(xbgr.mr_n83071888)
print v(xbgr.mr_n83072000)
print v(xbgr.mr_n83072320)
print v(xbgr.mr_n83072432)
print v(xbgr.mr_n83072752)
print v(xbgr.mr_n83072864)
print v(xbgr.mr_n83138736)
print v(xbgr.mr_n83138848)
print v(xbgr.mr_n83139168)
print v(xbgr.mr_n83139280)
print v(xbgr.mr_n83139600)
print v(xbgr.mr_n83139712)
print v(xbgr.mr_n83140144)
print v(xbgr.mr_n83140464)
print v(xbgr.mr_n83140576)
print v(xbgr.mr_n83140896)
print v(xbgr.mr_n83141008)
print v(xbgr.mr_n83141440)
print v(xbgr.mr_n83141872)
print v(xbgr.mr_n83142192)
print v(xbgr.mr_n83142304)
print v(xbgr.mr_n83142624)
print v(xbgr.mr_n83142736)
print v(xbgr.mr_n83143056)
print v(xbgr.mr_n83143168)
print v(xbgr.mr_n83143488)
print v(xbgr.mr_n83143600)
print v(xbgr.mr_n83143920)
print v(xbgr.mr_n83144032)
print v(xbgr.mr_n83144352)
print v(xbgr.mr_n83144464)
print v(xbgr.mr_n83144784)
print v(xbgr.mr_n83144896)
print v(xbgr.mr_n83145216)
print v(xbgr.mr_n83145328)
print v(xbgr.mr_n83145648)
print v(xbgr.mr_n83145760)
print v(xbgr.mr_n83146080)
print v(xbgr.mr_n83146192)
print v(xbgr.mr_n83146512)
print v(xbgr.mr_n83146624)
print v(xbgr.mr_n83146944)
print v(xbgr.mr_n83147056)
print v(xbgr.mr_n83147488)
print v(xbgr.mr_n83147808)
print v(xbgr.mr_n83147920)
print v(xbgr.mr_n83148240)
print v(xbgr.mr_n83148352)
print v(xbgr.mr_n83148672)
print v(xbgr.mr_n83148784)
print v(xbgr.mr_n83149104)
print v(xbgr.mr_n83149216)
print v(xbgr.mr_n83149536)
print v(xbgr.mr_n83149648)
print v(xbgr.mr_n83149968)
print v(xbgr.mr_n83150080)
print v(xbgr.mr_n83150400)
print v(xbgr.mr_n83150512)
print v(xbgr.mr_n83150832)
print v(xbgr.mr_n83150944)
print v(xbgr.mr_n83151264)
print v(xbgr.mr_n83151376)
print v(xbgr.mr_n83151696)
print v(xbgr.mr_n83151808)
print v(xbgr.mr_n83152240)
print v(xbgr.mr_n83152672)
print v(xbgr.mr_n83152992)
print v(xbgr.mr_n83153104)
print v(xbgr.mr_n83153424)
print v(xbgr.mr_n83153536)
print v(xbgr.mr_n83153856)
print v(xbgr.mr_n83153968)
print v(xbgr.mr_n83154288)
print v(xbgr.mr_n83154400)
print v(xbgr.mr_n83154720)
print v(xbgr.mr_n83154832)
print v(xbgr.mr_n83155152)
print v(xbgr.mr_n83155264)
print v(xbgr.mr_n83155584)
print v(xbgr.mr_n83155696)
print v(xbgr.mr_n83156016)
print v(xbgr.mr_n83156128)
print v(xbgr.mr_n83156448)
print v(xbgr.mr_n83156560)
print v(xbgr.mr_n83156880)
print v(xbgr.mr_n83156992)
print v(xbgr.mr_n83157312)
print v(xbgr.mr_n83157424)
print v(xbgr.mr_n83157744)
print v(xbgr.mr_n83157856)
print v(xbgr.mr_n83158176)
print v(xbgr.mr_n83158288)
print v(xbgr.mr_n83158608)
print v(xbgr.mr_n83158720)
print v(xbgr.mr_n83159040)
print v(xbgr.mr_n83159152)
print v(xbgr.mr_n83159472)
print v(xbgr.mr_n83159584)
print v(xbgr.mr_n83159904)
print v(xbgr.mr_n83160016)
print v(xbgr.mr_n83160336)
print v(xbgr.mr_n83160448)
print v(xbgr.mr_n83160768)
print v(xbgr.mr_n83160880)
print v(xbgr.mr_n83161200)
print v(xbgr.mr_n83161312)
print v(xbgr.mr_n83161632)
print v(xbgr.mr_n83161744)
print v(xbgr.mr_n83162064)
print v(xbgr.mr_n83162176)
print v(xbgr.mr_n83162496)
print v(xbgr.mr_n83162608)
print v(xbgr.mr_n83162928)
print v(xbgr.mr_n83163040)
print v(xbgr.mr_n83163360)
print v(xbgr.mr_n83163472)
print v(xbgr.mr_n83163792)
print v(xbgr.mr_n83163904)
print v(xbgr.mr_n83164224)
print v(xbgr.mr_n83164336)
print v(xbgr.mr_n83164656)
print v(xbgr.mr_n83164768)
print v(xbgr.mr_n83165088)
print v(xbgr.mr_n83165200)
print v(xbgr.mr_n83165520)
print v(xbgr.mr_n83165632)
print v(xbgr.mr_n83165952)
print v(xbgr.mr_n83166064)
print v(xbgr.mr_n83166384)
print v(xbgr.mr_n83166496)
print v(xbgr.mr_n83166816)
print v(xbgr.mr_n83166928)
print v(xbgr.mr_n83167248)
print v(xbgr.mr_n83167360)
print v(xbgr.mr_n83167680)
print v(xbgr.mr_n83167792)
print v(xbgr.mr_n83168112)
print v(xbgr.mr_n83168224)
print v(xbgr.mr_n83168544)
print v(xbgr.mr_n83168656)
print v(xbgr.mr_n83168976)
print v(xbgr.mr_n83169088)
print v(xbgr.mr_n83169408)
print v(xbgr.mr_n83169520)
print v(xbgr.mr_n83169840)
print v(xbgr.mr_n83169952)
print v(xbgr.mr_n83170272)
print v(xbgr.mr_n83170384)
print v(xbgr.mr_n83170704)
print v(xbgr.mr_n83170816)
print v(xbgr.mr_n83171136)
print v(xbgr.mr_n83171248)
print v(xbgr.mr_n83171568)
print v(xbgr.mr_n83171680)
print v(xbgr.mr_n83172000)
print v(xbgr.mr_n83172112)
print v(xbgr.mr_n83172432)
print v(xbgr.mr_n83172544)
print v(xbgr.mr_n83172864)
print v(xbgr.mr_n83172976)
print v(xbgr.mr_n83173296)
print v(xbgr.mr_n83173408)
print v(xbgr.mr_n83173728)
print v(xbgr.mr_n83173840)
print v(xbgr.mr_n83174160)
print v(xbgr.mr_n83174272)
print v(xbgr.mr_n83174592)
print v(xbgr.mr_n83174704)
print v(xbgr.mr_n83175024)
print v(xbgr.mr_n83175136)
print v(xbgr.mr_n83175456)
print v(xbgr.mr_n83175568)
print v(xbgr.mr_n83175888)
print v(xbgr.mr_n83176000)
print v(xbgr.mr_n83176320)
print v(xbgr.mr_n83176432)
print v(xbgr.mr_n83176752)
print v(xbgr.mr_n83176864)
print v(xbgr.mr_n83177184)
print v(xbgr.mr_n83177296)
print v(xbgr.mr_n83177616)
print v(xbgr.mr_n83177728)
print v(xbgr.mr_n83178048)
print v(xbgr.mr_n83178160)
print v(xbgr.mr_n83178480)
print v(xbgr.mr_n83178592)
print v(xbgr.mr_n83178912)
print v(xbgr.mr_n83179024)
print v(xbgr.mr_n83179344)
print v(xbgr.mr_n83179456)
print v(xbgr.mr_n83179776)
print v(xbgr.mr_n83179888)
print v(xbgr.mr_n83180208)
print v(xbgr.mr_n83180320)
print v(xbgr.mr_n83180640)
print v(xbgr.mr_n83180752)
print v(xbgr.mr_n83181072)
print v(xbgr.mr_n83181184)
print v(xbgr.mr_n83181504)
print v(xbgr.mr_n83181616)
print v(xbgr.mr_n83181936)
print v(xbgr.mr_n83182048)
print v(xbgr.mr_n83182368)
print v(xbgr.mr_n83182480)
print v(xbgr.mr_n83182800)
print v(xbgr.mr_n83182912)
print v(xbgr.mr_n83183232)
print v(xbgr.mr_n83183344)
print v(xbgr.mr_n83183664)
print v(xbgr.mr_n83183776)
print v(xbgr.mr_n83184096)
print v(xbgr.mr_n83184208)
print v(xbgr.mr_n83184528)
print v(xbgr.mr_n83184640)
print v(xbgr.mr_n83184960)
print v(xbgr.mr_n83185072)
print v(xbgr.mr_n83185392)
print v(xbgr.mr_n83185504)
print v(xbgr.mr_n83185824)
print v(xbgr.mr_n83185936)
print v(xbgr.mr_n83186256)
print v(xbgr.mr_n83186368)
print v(xbgr.mr_n83186688)
print v(xbgr.mr_n83186800)
print v(xbgr.mr_n83187120)
print v(xbgr.mr_n83187232)
print v(xbgr.mr_n83187552)
print v(xbgr.mr_n83187664)
print v(xbgr.mr_n83187984)
print v(xbgr.mr_n83188096)
print v(xbgr.mr_n83188416)
print v(xbgr.mr_n83188528)
print v(xbgr.mr_n83188848)
print v(xbgr.mr_n83188960)
print v(xbgr.mr_n83189280)
print v(xbgr.mr_n83189392)
print v(xbgr.mr_n83189712)
print v(xbgr.mr_n83189824)
print v(xbgr.mr_n83190144)
print v(xbgr.mr_n83190256)
print v(xbgr.mr_n83190576)
print v(xbgr.mr_n83190688)
print v(xbgr.mr_n83191008)
print v(xbgr.mr_n83191120)
print v(xbgr.mr_n83191440)
print v(xbgr.mr_n83191552)
print v(xbgr.mr_n83191872)
print v(xbgr.mr_n83191984)
print v(xbgr.mr_n83192304)
print v(xbgr.mr_n83192416)
print v(xbgr.mr_n83192736)
print v(xbgr.mr_n83192848)
print v(xbgr.mr_n83193168)
print v(xbgr.mr_n83193280)
print v(xbgr.mr_n83193600)
print v(xbgr.mr_n83193712)
print v(xbgr.mr_n83194032)
print v(xbgr.mr_n83194144)
print v(xbgr.mr_n83194464)
print v(xbgr.mr_n83194576)
print v(xbgr.mr_n83194896)
print v(xbgr.mr_n83195008)
print v(xbgr.mr_n83195328)
print v(xbgr.mr_n83195440)
print v(xbgr.mr_n83195760)
print v(xbgr.mr_n83195872)
print v(xbgr.mr_n83196192)
print v(xbgr.mr_n83196304)
print v(xbgr.mr_n83196624)
print v(xbgr.mr_n83196736)
print v(xbgr.mr_n83197056)
print v(xbgr.mr_n83197168)
print v(xbgr.mr_n83197488)
print v(xbgr.mr_n83197600)
print v(xbgr.mr_n83197920)
print v(xbgr.mr_n83198032)
print v(xbgr.mr_n83198352)
print v(xbgr.mr_n83198464)
print v(xbgr.mr_n83198784)
print v(xbgr.mr_n83198896)
print v(xbgr.mr_n83199216)
print v(xbgr.mr_n83199328)
print v(xbgr.mr_n83199648)
print v(xbgr.mr_n83199760)
print v(xbgr.mr_n83200080)
print v(xbgr.mr_n83200192)
print v(xbgr.mr_n83200512)
print v(xbgr.mr_n83200624)
print v(xbgr.mr_n83200944)
print v(xbgr.mr_n83201056)
print v(xbgr.mr_n83201376)
print v(xbgr.mr_n83201488)
print v(xbgr.mr_n83201808)
print v(xbgr.mr_n83201920)
print v(xbgr.mr_n83202240)
print v(xbgr.mr_n83202352)
print v(xbgr.mr_n83202672)
print v(xbgr.mr_n83202784)
print v(xbgr.mr_n83203104)
print v(xbgr.mr_n83203216)
print v(xbgr.mr_n83203536)
print v(xbgr.mr_n83203648)
print v(xbgr.mr_n83203968)
print v(xbgr.mr_n83204080)
print v(xbgr.mr_n83204400)
print v(xbgr.mr_n83204512)
print v(xbgr.mr_n83204832)
print v(xbgr.mr_n83204944)
print v(xbgr.mr_n83205264)
print v(xbgr.mr_n83205376)
print v(xbgr.mr_n83205696)
print v(xbgr.mr_n83205808)
print v(xbgr.mr_n83206128)
print v(xbgr.mr_n83206240)
print v(xbgr.mr_n83206560)
print v(xbgr.mr_n83206672)
print v(xbgr.mr_n83206992)
print v(xbgr.mr_n83207104)
print v(xbgr.mr_n83207424)
print v(xbgr.mr_n83207536)
print v(xbgr.mr_n83207856)
print v(xbgr.mr_n83207968)
print v(xbgr.mr_n83208288)
print v(xbgr.mr_n83208400)
print v(xbgr.mr_n83208720)
print v(xbgr.mr_n83208832)
print v(xbgr.mr_n83209152)
print v(xbgr.mr_n83209264)
print v(xbgr.mr_n83209584)
print v(xbgr.mr_n83209696)
print v(xbgr.mr_n83210016)
print v(xbgr.mr_n83210128)
print v(xbgr.mr_n83210448)
print v(xbgr.mr_n83210560)
print v(xbgr.mr_n83210880)
print v(xbgr.mr_n83210992)
print v(xbgr.mr_n83211312)
print v(xbgr.mr_n83211424)
print v(xbgr.mr_n83211744)
print v(xbgr.mr_n83211856)
print v(xbgr.mr_n83212176)
print v(xbgr.mr_n83212288)
print v(xbgr.mr_n83212608)
print v(xbgr.mr_n83212720)
print v(xbgr.mr_n83213040)
print v(xbgr.mr_n83213152)
print v(xbgr.mr_n83213472)
print v(xbgr.mr_n83213584)
print v(xbgr.mr_n83213904)
print v(xbgr.mr_n83214016)
print v(xbgr.mr_n83214336)
print v(xbgr.mr_n83214448)
print v(xbgr.mr_n83214768)
print v(xbgr.mr_n83214880)
print v(xbgr.mr_n83215200)
print v(xbgr.mr_n83215312)
print v(xbgr.mr_n83215632)
print v(xbgr.mr_n83215744)
print v(xbgr.mr_n83216064)
print v(xbgr.mr_n83216176)
print v(xbgr.mr_n83216496)
print v(xbgr.mr_n83216608)
print v(xbgr.mr_n83216928)
print v(xbgr.mr_n83217040)
print v(xbgr.mr_n83217360)
print v(xbgr.mr_n83217472)
print v(xbgr.mr_n83217792)
print v(xbgr.mr_n83217904)
print v(xbgr.mr_n83218224)
print v(xbgr.mr_n83218336)
print v(xbgr.mr_n83218656)
print v(xbgr.mr_n83218768)
print v(xbgr.mr_n83219088)
print v(xbgr.mr_n83219200)
print v(xbgr.mr_n83219520)
print v(xbgr.mr_n83219632)
print v(xbgr.mr_n83219952)
print v(xbgr.mr_n83220064)
print v(xbgr.mr_n83220384)
print v(xbgr.mr_n83220496)
print v(xbgr.mr_n83220928)
print v(xbgr.mr_n83221248)
print v(xbgr.mr_n83221360)
print v(xbgr.mr_n83221680)
print v(xbgr.mr_n83221792)
print v(xbgr.mr_n83222112)
print v(xbgr.mr_n83222224)
print v(xbgr.mr_n83222544)
print v(xbgr.mr_n83222656)
print v(xbgr.mr_n83222976)
print v(xbgr.mr_n83223840)
print v(xbgr.mr_n83223952)
print v(xbgr.mr_n83224272)
print v(xbgr.mr_n83224384)
print v(xbgr.mr_n83224704)
print v(xbgr.mr_n83224816)
print v(xbgr.mr_n83225136)
print v(xbgr.mr_n83225248)
print v(xbgr.mr_n83225568)
print v(xbgr.mr_n83225680)
print v(xbgr.mr_n83226112)
print v(xbgr.mr_n83226432)
print v(xbgr.mr_n83226544)
print v(xbgr.mr_n83226864)
print v(xbgr.mr_n83226976)
print v(xbgr.mr_n83227296)
print v(xbgr.mr_n83227408)
print v(xbgr.mr_n83227728)
print v(xbgr.mr_n83227840)
print v(xbgr.mr_n83228160)
print v(xbgr.mr_n83228272)
print v(xbgr.mr_n83228704)
print v(xbgr.mr_n83229024)
print v(xbgr.mr_n83229888)
print v(xbgr.mr_n83230000)
print v(xbgr.mr_n83230432)
print v(xbgr.mr_n83230752)
print v(xbgr.mr_n83231616)
print v(xbgr.mr_n83231728)
print v(xbgr.mr_n83232160)
print v(xbgr.mr_n83232480)
print v(xbgr.mr_n83232592)
print v(xbgr.mr_n83232912)
print v(xbgr.mr_n83233024)
print v(xbgr.mr_n83233344)
print v(xbgr.mr_n83233456)
print v(xbgr.mr_n83233776)
print v(xbgr.mr_n83233888)
print v(xbgr.mr_n83234208)
print v(xbgr.mr_n83234320)
print v(xbgr.mr_n83234640)
print v(xbgr.mr_n83234752)
print v(xbgr.mr_n83235072)
print v(xbgr.mr_n83235936)
print v(xbgr.mr_n83236048)
print v(xbgr.mr_n83236368)
print v(xbgr.mr_n83236480)
print v(xbgr.mr_n83236800)
print v(xbgr.mr_n83237664)
print v(xbgr.mr_n83237776)
print v(xbgr.mr_n83238096)
print v(xbgr.mr_n83238208)
print v(xbgr.mr_n83238528)
print v(xbgr.mr_n83238640)
print v(xbgr.mr_n83238960)
print v(xbgr.mr_n83239072)
print v(xbgr.mr_n83239392)
print v(xbgr.mr_n83239504)
print v(xbgr.mr_n83239824)
print v(xbgr.mr_n83239936)
print v(xbgr.mr_n83240256)
print v(xbgr.mr_n83240368)
print v(xbgr.mr_n83240688)
print v(xbgr.mr_n83240800)
print v(xbgr.mr_n83241120)
print v(xbgr.mr_n83241232)
print v(xbgr.mr_n83241552)
print v(xbgr.mr_n83241664)
print v(xbgr.mr_n83241984)
print v(xbgr.mr_n83242096)
print v(xbgr.mr_n83242416)
print v(xbgr.mr_n83242528)
print v(xbgr.mr_n83242848)
print v(xbgr.mr_n83242960)
print v(xbgr.mr_n83243280)
print v(xbgr.mr_n83243392)
print v(xbgr.mr_n83243712)
print v(xbgr.mr_n83243824)
print v(xbgr.mr_n83244144)
print v(xbgr.mr_n83244256)
print v(xbgr.mr_n83244576)
print v(xbgr.mr_n83244688)
print v(xbgr.mr_n83245008)
print v(xbgr.mr_n83245120)
print v(xbgr.mr_n83245440)
print v(xbgr.mr_n83245552)
print v(xbgr.mr_n83245872)
print v(xbgr.mr_n83245984)
print v(xbgr.mr_n83246304)
print v(xbgr.mr_n83246416)
print v(xbgr.mr_n83246736)
print v(xbgr.mr_n83246848)
print v(xbgr.mr_n83247168)
print v(xbgr.mr_n83247280)
print v(xbgr.mr_n83247600)
print v(xbgr.mr_n83247712)
print v(xbgr.mr_n83248032)
print v(xbgr.mr_n83248144)
print v(xbgr.mr_n83248464)
print v(xbgr.mr_n83248576)
print v(xbgr.mr_n83249008)
print v(xbgr.mr_n83249440)
print v(xbgr.mr_n83249872)
print v(xbgr.mr_n83250304)
print v(xbgr.mr_n83250736)
print v(xbgr.mr_n83251168)
print v(xbgr.mr_n83251600)
print v(xbgr.mr_n83252032)
print v(xbgr.mr_n83252464)
print v(xbgr.mr_n83252896)
print v(xbgr.mr_n83253328)
print v(xbgr.mr_n83253760)
print v(xbgr.mr_n83254192)
print v(xbgr.mr_n83254624)
print v(xbgr.mr_n83255056)
print v(xbgr.mr_n83255488)
print v(xbgr.mr_n83255920)
print v(xbgr.mr_n83256352)
print v(xbgr.mr_n83256784)
print v(xbgr.mr_n83257216)
print v(xbgr.mr_n83257648)
print v(xbgr.mr_n83258080)
print v(xbgr.mr_n83258400)
print v(xbgr.mr_n83258512)
print v(xbgr.mr_n83258944)
print v(xbgr.mr_n83259376)
print v(xbgr.mr_n83259808)
print v(xbgr.mr_n83260240)
print v(xbgr.mr_n83260672)
print v(xbgr.mr_n83261104)
print v(xbgr.mr_n83261536)
print v(xbgr.mr_n83261968)
print v(xbgr.mr_n83262400)
print v(xbgr.mr_n83262832)
print v(xbgr.mr_n83263264)
print v(xbgr.mr_n83263696)
print v(xbgr.mr_n83264128)
print v(xbgr.mr_n83264560)
print v(xbgr.mr_n83264992)
print v(xbgr.mr_n83265424)
print v(xbgr.mr_n83265856)
print v(xbgr.mr_n83266288)
print v(xbgr.mr_n83266720)
print v(xbgr.mr_n83267152)
print v(xbgr.mr_n83267584)
print v(xbgr.mr_n83268016)
print v(xbgr.mr_n83268448)
print v(xbgr.mr_n83268880)
print v(xbgr.mr_n83269312)
print v(xbgr.mr_n83269744)
print v(xbgr.mr_n83270176)
print v(xbgr.mr_n83270608)
print v(xbgr.mr_n83271040)
print v(xbgr.mr_n83271472)
print v(xbgr.mr_n83271904)
print v(xbgr.mr_n83272336)
print v(xbgr.mr_n83272768)
print v(xbgr.mr_n83273200)
print v(xbgr.mr_n83273632)
print v(xbgr.mr_n83274064)
print v(xbgr.mr_n83274496)
print v(xbgr.mr_n83274928)
print v(xbgr.mr_n83275360)
print v(xbgr.mr_n83275792)
print v(xbgr.mr_n83276224)
print v(xbgr.mr_n83276656)
print v(xbgr.mr_n83277088)
print v(xbgr.mr_n83277520)
print v(xbgr.mr_n83277952)
print v(xbgr.mr_n83278384)
print v(xbgr.mr_n83278816)
print v(xbgr.mr_n83279248)
print v(xbgr.mr_n83279680)
print v(xbgr.mr_n83280112)
print v(xbgr.mr_n83280544)
print v(xbgr.mr_n83280976)
print v(xbgr.mr_n83281408)
print v(xbgr.mr_n83281840)
print v(xbgr.mr_n83282272)
print v(xbgr.mr_n83282704)
print v(xbgr.mr_n83283136)
print v(xbgr.mr_n83283568)
print v(xbgr.mr_n83284000)
print v(xbgr.mr_n83284432)
print v(xbgr.mr_n83284864)
print v(xbgr.mr_n83285296)
print v(xbgr.mr_n83285728)
print v(xbgr.mr_n83286048)
print v(xbgr.mr_n83286160)
print v(xbgr.mr_n83286480)
print v(xbgr.mr_n83286592)
print v(xbgr.mr_n83286912)
print v(xbgr.mr_n83287024)
print v(xbgr.mr_n83287344)
print v(xbgr.mr_n83287456)
print v(xbgr.mr_n83287776)
print v(xbgr.mr_n83287888)
print v(xbgr.mr_n83288208)
print v(xbgr.mr_n83288320)
print v(xbgr.mr_n83288640)
print v(xbgr.mr_n83288752)
print v(xbgr.mr_n83289072)
print v(xbgr.mr_n83289184)
print v(xbgr.mr_n83289504)
print v(xbgr.mr_n83289616)
print v(xbgr.mr_n83289936)
print v(xbgr.mr_n83290048)
print v(xbgr.mr_n83290368)
print v(xbgr.mr_n83290480)
print v(xbgr.mr_n83290800)
print v(xbgr.mr_n83290912)
print v(xbgr.mr_n83291232)
print v(xbgr.mr_n83291664)
print v(xbgr.mr_n83291776)
print v(xbgr.mr_n83292096)
print v(xbgr.mr_n83292208)
print v(xbgr.mr_n83292528)
print v(xbgr.mr_n83292640)
print v(xbgr.mr_n83292960)
print v(xbgr.mr_n83293072)
print v(xbgr.mr_n83293392)
print v(xbgr.mr_n83293504)
print v(xbgr.mr_n83293824)
print v(xbgr.mr_n83293936)
print v(xbgr.mr_n83294256)
print v(xbgr.mr_n83294368)
print v(xbgr.mr_n83294688)
print v(xbgr.mr_n83294800)
print v(xbgr.mr_n83295120)
print v(xbgr.mr_n83295232)
print v(xbgr.mr_n83295552)
print v(xbgr.mr_n83295664)
print v(xbgr.mr_n83295984)
print v(xbgr.mr_n83296096)
print v(xbgr.mr_n83296528)
print v(xbgr.mr_n83296960)
print v(xbgr.mr_n83297392)
print v(xbgr.mr_n83297824)
print v(xbgr.mr_n83298256)
print v(xbgr.mr_n83298688)
print v(xbgr.mr_n83299120)
print v(xbgr.mr_n83299552)
print v(xbgr.mr_n83299984)
print v(xbgr.mr_n83300416)
print v(xbgr.mr_n83300848)
print v(xbgr.mr_n83301280)
print v(xbgr.mr_n83301712)
print v(xbgr.mr_n83302144)
print v(xbgr.mr_n83302576)
print v(xbgr.mr_n83303008)
print v(xbgr.mr_n83303440)
print v(xbgr.mr_n83303872)
print v(xbgr.mr_n83304304)
print v(xbgr.mr_n83304736)
print v(xbgr.mr_n83305168)
print v(xbgr.mr_n83305600)
print v(xbgr.mr_n83306032)
print v(xbgr.mr_n83306464)
print v(xbgr.mr_n83306896)
print v(xbgr.mr_n83307328)
print v(xbgr.mr_n83307760)
print v(xbgr.mr_n83308192)
print v(xbgr.mr_n83308624)
print v(xbgr.mr_n83309056)
print v(xbgr.mr_n83309488)
print v(xbgr.mr_n83309920)
print v(xbgr.mr_n83310352)
print v(xbgr.mr_n83310784)
print v(xbgr.mr_n83311216)
print v(xbgr.mr_n83311648)
print v(xbgr.mr_n83312080)
print v(xbgr.mr_n83312512)
print v(xbgr.mr_n83312944)
print v(xbgr.mr_n83313376)
print v(xbgr.mr_n83313808)
print v(xbgr.mr_n83314240)
print v(xbgr.mr_n83314672)
print v(xbgr.mr_n83315104)
print v(xbgr.mr_n83315536)
print v(xbgr.mr_n83315968)
print v(xbgr.mr_n83316400)
print v(xbgr.mr_n83316832)
print v(xbgr.mr_n83317264)
print v(xbgr.mr_n83317696)
print v(xbgr.mr_n83318128)
print v(xbgr.mr_n83318560)
print v(xbgr.mr_n83318992)
print v(xbgr.mr_n83319424)
print v(xbgr.mr_n83319856)
print v(xbgr.mr_n83320288)
print v(xbgr.mr_n83320720)
print v(xbgr.mr_n83321152)
print v(xbgr.mr_n83321584)
print v(xbgr.mr_n83322016)
print v(xbgr.mr_n83322448)
print v(xbgr.mr_n83322880)
print v(xbgr.mr_n83323312)
print v(xbgr.mr_n83323744)
print v(xbgr.mr_n83324176)
print v(xbgr.mr_n83324608)
print v(xbgr.mr_n83325040)
print v(xbgr.mr_n83325472)
print v(xbgr.mr_n83325904)
print v(xbgr.mr_n83326336)
print v(xbgr.mr_n83326768)
print v(xbgr.mr_n83327200)
print v(xbgr.mr_n83327632)
print v(xbgr.mr_n83328064)
print v(xbgr.mr_n83328496)
print v(xbgr.mr_n83328928)
print v(xbgr.mr_n83329360)
print v(xbgr.mr_n83329792)
print v(xbgr.mr_n83330224)
print v(xbgr.mr_n83330656)
print v(xbgr.mr_n83331088)
print v(xbgr.mr_n83331520)
print v(xbgr.mr_n83331952)
print v(xbgr.mr_n83332384)
print v(xbgr.mr_n83332816)
print v(xbgr.mr_n83333248)
print v(xbgr.mr_n83333568)
print v(xbgr.mr_n83333680)
print v(xbgr.mr_n83334000)
print v(xbgr.mr_n83334112)
print v(xbgr.mr_n83334432)
print v(xbgr.mr_n83334544)
print v(xbgr.mr_n83334864)
print v(xbgr.mr_n83334976)
print v(xbgr.mr_n83335296)
print v(xbgr.mr_n83335408)
print v(xbgr.mr_n83335728)
print v(xbgr.mr_n83335840)
print v(xbgr.mr_n83336160)
print v(xbgr.mr_n83336272)
print v(xbgr.mr_n83336592)
print v(xbgr.mr_n83336704)
print v(xbgr.mr_n83337024)
print v(xbgr.mr_n83337136)
print v(xbgr.mr_n83337456)
print v(xbgr.mr_n83337568)
print v(xbgr.mr_n83337888)
print v(xbgr.mr_n83338000)
print v(xbgr.mr_n83338320)
print v(xbgr.mr_n83338432)
print v(xbgr.mr_n83338752)
print v(xbgr.mr_n83338864)
print v(xbgr.mr_n83339184)
print v(xbgr.mr_n83339296)
print v(xbgr.mr_n83339616)
print v(xbgr.mr_n83339728)
print v(xbgr.mr_n83340048)
print v(xbgr.mr_n83340160)
print v(xbgr.mr_n83340480)
print v(xbgr.mr_n83340592)
print v(xbgr.mr_n83340912)
print v(xbgr.mr_n83341024)
print v(xbgr.mr_n83341344)
print v(xbgr.mr_n83341888)
print v(xbgr.mr_n83342208)
print v(xbgr.mr_n83342640)
print v(xbgr.mr_n83342752)
print v(xbgr.mr_n83343072)
print v(xbgr.mr_n83343184)
print v(xbgr.mr_n83343616)
print v(xbgr.mr_n83343936)
print v(xbgr.mr_n83344800)
print v(xbgr.mr_n83344912)
print v(xbgr.mr_n83345344)
print v(xbgr.mr_n83345664)
print v(xbgr.mr_n83346528)
print v(xbgr.mr_n83346640)
print v(xbgr.mr_n83347072)
print v(xbgr.mr_n83347392)
print v(xbgr.mr_n83347504)
print v(xbgr.mr_n83347936)
print v(xbgr.mr_n83348368)
print v(xbgr.mr_n83348688)
print v(xbgr.mr_n83349552)
print v(xbgr.mr_n83350528)
print v(xbgr.mr_n83350848)
print v(xbgr.mr_n83350960)
print v(xbgr.mr_n83351392)
print v(xbgr.mr_n83351712)
print v(xbgr.mr_n83351824)
print v(xbgr.mr_n83352256)
print v(xbgr.mr_n83352576)
print v(xbgr.mr_n83352688)
print v(xbgr.mr_n83353008)
print v(xbgr.mr_n83353120)
print v(xbgr.mr_n83353440)
print v(xbgr.mr_n83353552)
print v(xbgr.mr_n83353872)
print v(xbgr.mr_n83353984)
print v(xbgr.mr_n83354304)
print v(xbgr.mr_n83354416)
print v(xbgr.mr_n83354736)
print v(xbgr.mr_n83354848)
print v(xbgr.mr_n83355168)
print v(xbgr.mr_n83355280)
print v(xbgr.mr_n83355600)
print v(xbgr.mr_n83355712)
print v(xbgr.mr_n83356032)
print v(xbgr.mr_n83356144)
print v(xbgr.mr_n83356464)
print v(xbgr.mr_n83356576)
print v(xbgr.mr_n83356896)
print v(xbgr.mr_n83357008)
print v(xbgr.mr_n83357328)
print v(xbgr.mr_n83357440)
print v(xbgr.mr_n83357760)
print v(xbgr.mr_n83358624)
print v(xbgr.mr_n83359488)
print v(xbgr.mr_n83359920)
print v(xbgr.mr_n83360352)
print v(xbgr.mr_n83360784)
print v(xbgr.mr_n83361216)
print v(xbgr.mr_n83361648)
print v(xbgr.mr_n83362080)
print v(xbgr.mr_n83362512)
print v(xbgr.mr_n83362944)
print v(xbgr.mr_n83363376)
print v(xbgr.mr_n83363808)
print v(xbgr.mr_n83364240)
print v(xbgr.mr_n83364672)
print v(xbgr.mr_n83364784)
print v(xbgr.mr_n83365104)
print v(xbgr.mr_n83365216)
print v(xbgr.mr_n83365536)
print v(xbgr.mr_n83365648)
print v(xbgr.mr_n83365968)
print v(xbgr.mr_n83366080)
print v(xbgr.mr_n83366400)
print v(xbgr.mr_n83366512)
print v(xbgr.mr_n83366832)
print v(xbgr.mr_n83366944)
print v(xbgr.mr_n83367264)
print v(xbgr.mr_n83367376)
print v(xbgr.mr_n83367696)
print v(xbgr.mr_n83367808)
print v(xbgr.mr_n83368128)
print v(xbgr.mr_n83368240)
print v(xbgr.mr_n83368560)
print v(xbgr.mr_n83368672)
print v(xbgr.mr_n83368992)
print v(xbgr.mr_n83369104)
print v(xbgr.mr_n83369424)
print v(xbgr.mr_n83369536)
print v(xbgr.mr_n83369856)
print v(xbgr.mr_n83370288)
print v(xbgr.mr_n83370400)
print v(xbgr.mr_n83370720)
print v(xbgr.mr_n83370832)
print v(xbgr.mr_n83371152)
print v(xbgr.mr_n83371264)
print v(xbgr.mr_n83371584)
print v(xbgr.mr_n83371696)
print v(xbgr.mr_n83372016)
print v(xbgr.mr_n83372128)
print v(xbgr.mr_n83372448)
print v(xbgr.mr_n83372560)
print v(xbgr.mr_n83372880)
print v(xbgr.mr_n83372992)
print v(xbgr.mr_n83373312)
print v(xbgr.mr_n83373424)
print v(xbgr.mr_n83373744)
print v(xbgr.mr_n83373856)
print v(xbgr.mr_n83374176)
print v(xbgr.mr_n83374288)
print v(xbgr.mr_n83374608)
print v(xbgr.mr_n83375040)
print v(xbgr.mr_n83375152)
print v(xbgr.mr_n83375472)
print v(xbgr.mr_n83375584)
print v(xbgr.mr_n83375904)
print v(xbgr.mr_n83376016)
print v(xbgr.mr_n83376336)
print v(xbgr.mr_n83376448)
print v(xbgr.mr_n83376768)
print v(xbgr.mr_n83376880)
print v(xbgr.mr_n83377200)
print v(xbgr.mr_n83377312)
print v(xbgr.mr_n83377632)
print v(xbgr.mr_n83377744)
print v(xbgr.mr_n83378064)
print v(xbgr.mr_n83378176)
print v(xbgr.mr_n83378496)
print v(xbgr.mr_n83378608)
print v(xbgr.mr_n83378928)
print v(xbgr.mr_n83379040)
print v(xbgr.mr_n83379360)
print v(xbgr.mr_n83379472)
print v(xbgr.mr_n83379792)
print v(xbgr.mr_n83379904)
print v(xbgr.mr_n83380224)
print v(xbgr.mr_n83380336)
print v(xbgr.mr_n83380656)
print v(xbgr.mr_n83380768)
print v(xbgr.mr_n83381088)
print v(xbgr.mr_n83381200)
print v(xbgr.mr_n83381520)
print v(xbgr.mr_n83381632)
print v(xbgr.mr_n83381952)
print v(xbgr.mr_n83382064)
print v(xbgr.mr_n83382384)
print v(xbgr.mr_n83382496)
print v(xbgr.mr_n83382816)
print v(xbgr.mr_n83382928)
print v(xbgr.mr_n83383248)
print v(xbgr.mr_n83383360)
print v(xbgr.mr_n83383680)
print v(xbgr.mr_n83383792)
print v(xbgr.mr_n83384112)
print v(xbgr.mr_n83384224)
print v(xbgr.mr_n83384544)
print v(xbgr.mr_n83384656)
print v(xbgr.mr_n83384976)
print v(xbgr.mr_n83385088)
print v(xbgr.mr_n83385408)
print v(xbgr.mr_n83385520)
print v(xbgr.mr_n83385840)
print v(xbgr.mr_n83385952)
print v(xbgr.mr_n83386272)
print v(xbgr.mr_n83386384)
print v(xbgr.mr_n83386704)
print v(xbgr.mr_n83386816)
print v(xbgr.mr_n83387136)
print v(xbgr.mr_n83387248)
print v(xbgr.mr_n83387568)
print v(xbgr.mr_n83387680)
print v(xbgr.mr_n83388000)
print v(xbgr.mr_n83388112)
print v(xbgr.mr_n83388432)
print v(xbgr.mr_n83388544)
print v(xbgr.mr_n83388864)
print v(xbgr.mr_n83388976)
print v(xbgr.mr_n83389296)
print v(xbgr.mr_n83389408)
print v(xbgr.mr_n83389728)
print v(xbgr.mr_n83389840)
print v(xbgr.mr_n83390160)
print v(xbgr.mr_n83390272)
print v(xbgr.mr_n83390592)
print v(xbgr.mr_n83390704)
print v(xbgr.mr_n83391024)
print v(xbgr.mr_n83391136)
print v(xbgr.mr_n83391456)
print v(xbgr.mr_n83391568)
print v(xbgr.mr_n83391888)
print v(xbgr.mr_n83392000)
print v(xbgr.mr_n83392320)
print v(xbgr.mr_n83392432)
print v(xbgr.mr_n83392752)
print v(xbgr.mr_n83392864)
print v(xbgr.mr_n83393184)
print v(xbgr.mr_n83393296)
print v(xbgr.mr_n83393616)
print v(xbgr.mr_n83393728)
print v(xbgr.mr_n83394048)
print v(xbgr.mr_n83394160)
print v(xbgr.mr_n83394480)
print v(xbgr.mr_n83394592)
print v(xbgr.mr_n83394912)
print v(xbgr.mr_n83395024)
print v(xbgr.mr_n83395344)
print v(xbgr.mr_n83395456)
print v(xbgr.mr_n83395776)
print v(xbgr.mr_n83395888)
print v(xbgr.mr_n83396208)
print v(xbgr.mr_n83396320)
print v(xbgr.mr_n83396640)
print v(xbgr.mr_n83396752)
print v(xbgr.mr_n83397072)
print v(xbgr.mr_n83397184)
print v(xbgr.mr_n83397504)
print v(xbgr.mr_n83397616)
print v(xbgr.mr_n83397936)
print v(xbgr.mr_n83398048)
print v(xbgr.mr_n83398368)
print v(xbgr.mr_n83398480)
print v(xbgr.mr_n83398800)
print v(xbgr.mr_n83398912)
print v(xbgr.mr_n83399232)
print v(xbgr.mr_n83399344)
print v(xbgr.mr_n83399664)
print v(xbgr.mr_n83399776)
print v(xbgr.mr_n83400096)
print v(xbgr.mr_n83400208)
print v(xbgr.mr_n83400528)
print v(xbgr.mr_n83400640)
print v(xbgr.mr_n83400960)
print v(xbgr.mr_n83401072)
print v(xbgr.mr_n83401392)
print v(xbgr.mr_n83401504)
print v(xbgr.mr_n83401824)
print v(xbgr.mr_n83402256)
print v(xbgr.mr_n83402368)
print v(xbgr.mr_n83402688)
print v(xbgr.mr_n83402800)
print v(xbgr.mr_n83403120)
print v(xbgr.mr_n83403232)
print v(xbgr.mr_n83403552)
print v(xbgr.mr_n83403664)
print v(xbgr.mr_n83403984)
print v(xbgr.mr_n83404096)
print v(xbgr.mr_n83404416)
print v(xbgr.mr_n83404528)
print v(xbgr.mr_n83404848)
print v(xbgr.mr_n83404960)
print v(xbgr.mr_n83405280)
print v(xbgr.mr_n83405392)
print v(xbgr.mr_n83405712)
print v(xbgr.mr_n83405824)
print v(xbgr.mr_n83406144)
print v(xbgr.mr_n83406256)
print v(xbgr.mr_n83406576)
print v(xbgr.mr_n83406688)
print v(xbgr.mr_n83407008)
print v(xbgr.mr_n83407120)
print v(xbgr.mr_n83407440)
print v(xbgr.mr_n83407552)
print v(xbgr.mr_n83407872)
print v(xbgr.mr_n83407984)
print v(xbgr.mr_n83408304)
print v(xbgr.mr_n83408416)
print v(xbgr.mr_n83408736)
print v(xbgr.mr_n83408848)
print v(xbgr.mr_n83409168)
print v(xbgr.mr_n83409280)
print v(xbgr.mr_n83409600)
print v(xbgr.mr_n83409712)
print v(xbgr.mr_n83410032)
print v(xbgr.mr_n83410576)
print v(xbgr.mr_n83410896)
print v(xbgr.mr_n83411008)
print v(xbgr.mr_n83411328)
print v(xbgr.mr_n83411440)
print v(xbgr.mr_n83411872)
print v(xbgr.mr_n83412304)
print v(xbgr.mr_n83412736)
print v(xbgr.mr_n83413168)
print v(xbgr.mr_n83413600)
print v(xbgr.mr_n83414032)
print v(xbgr.mr_n83414464)
print v(xbgr.mr_n83414896)
print v(xbgr.mr_n83415328)
print v(xbgr.mr_n83415760)
print v(xbgr.mr_n83416192)
print v(xbgr.mr_n83416624)
print v(xbgr.mr_n83417056)
print v(xbgr.mr_n83417488)
print v(xbgr.mr_n83417920)
print v(xbgr.mr_n83418352)
print v(xbgr.mr_n83418784)
print v(xbgr.mr_n83419216)
print v(xbgr.mr_n83419648)
print v(xbgr.mr_n83420080)
print v(xbgr.mr_n83420512)
print v(xbgr.mr_n83420944)
print v(xbgr.mr_n83421376)
print v(xbgr.mr_n83421808)
print v(xbgr.mr_n83422240)
print v(xbgr.mr_n83422672)
print v(xbgr.mr_n83423104)
print v(xbgr.mr_n83423536)
print v(xbgr.mr_n83423968)
print v(xbgr.mr_n83424400)
print v(xbgr.mr_n83424832)
print v(xbgr.mr_n83425264)
print v(xbgr.mr_n83425696)
print v(xbgr.mr_n83426128)
print v(xbgr.mr_n83426560)
print v(xbgr.mr_n83426992)
print v(xbgr.mr_n83427424)
print v(xbgr.mr_n83427856)
print v(xbgr.mr_n83428288)
print v(xbgr.mr_n83428720)
print v(xbgr.mr_n83429152)
print v(xbgr.mr_n83429584)
print v(xbgr.mr_n83430016)
print v(xbgr.mr_n83430448)
print v(xbgr.mr_n83430880)
print v(xbgr.mr_n83431312)
print v(xbgr.mr_n83431744)
print v(xbgr.mr_n83432176)
print v(xbgr.mr_n83432608)
print v(xbgr.mr_n83433040)
print v(xbgr.mr_n83433472)
print v(xbgr.mr_n83433904)
print v(xbgr.mr_n83434336)
print v(xbgr.mr_n83434768)
print v(xbgr.mr_n83435200)
print v(xbgr.mr_n83435632)
print v(xbgr.mr_n83436064)
print v(xbgr.mr_n83436496)
print v(xbgr.mr_n83436928)
print v(xbgr.mr_n83437360)
print v(xbgr.mr_n83437792)
print v(xbgr.mr_n83438224)
print v(xbgr.mr_n83438656)
print v(xbgr.mr_n83439088)
print v(xbgr.mr_n83439520)
print v(xbgr.mr_n83439952)
print v(xbgr.mr_n83440384)
print v(xbgr.mr_n83440816)
print v(xbgr.mr_n83441248)
print v(xbgr.mr_n83441680)
print v(xbgr.mr_n83442112)
print v(xbgr.mr_n83442544)
print v(xbgr.mr_n83442976)
print v(xbgr.mr_n83443408)
print v(xbgr.mr_n83443840)
print v(xbgr.mr_n83444272)
print v(xbgr.mr_n83444704)
print v(xbgr.mr_n83445136)
print v(xbgr.mr_n83445568)
print v(xbgr.mr_n83446000)
print v(xbgr.mr_n83446432)
print v(xbgr.mr_n83446864)
print v(xbgr.mr_n83447296)
print v(xbgr.mr_n83447728)
print v(xbgr.mr_n83448160)
print v(xbgr.mr_n83448592)
print v(xbgr.mr_n83449024)
print v(xbgr.mr_n83449456)
print v(xbgr.mr_n83449888)
print v(xbgr.mr_n83450320)
print v(xbgr.mr_n83450752)
print v(xbgr.mr_n83451184)
print v(xbgr.mr_n83451616)
print v(xbgr.mr_n83452048)
print v(xbgr.mr_n83452480)
print v(xbgr.mr_n83452912)
print v(xbgr.mr_n83453344)
print v(xbgr.mr_n83453776)
print v(xbgr.mr_n83454208)
print v(xbgr.mr_n83454640)
print v(xbgr.mr_n83455072)
print v(xbgr.mr_n83455504)
print v(xbgr.mr_n83455936)
print v(xbgr.mr_n83456368)
print v(xbgr.mr_n83456800)
print v(xbgr.mr_n83457120)
print v(xbgr.mr_n83457232)
print v(xbgr.mr_n83457552)
print v(xbgr.mr_n83457664)
print v(xbgr.mr_n83457984)
print v(xbgr.mr_n83458096)
print v(xbgr.mr_n83458416)
print v(xbgr.mr_n83458528)
print v(xbgr.mr_n83458848)
print v(xbgr.mr_n83458960)
print v(xbgr.mr_n83459280)
print v(xbgr.mr_n83459392)
print v(xbgr.mr_n83459712)
print v(xbgr.mr_n83459824)
print v(xbgr.mr_n83460144)
print v(xbgr.mr_n83460256)
print v(xbgr.mr_n83460576)
print v(xbgr.mr_n83460688)
print v(xbgr.mr_n83461008)
print v(xbgr.mr_n83461120)
print v(xbgr.mr_n83461440)
print v(xbgr.mr_n83461552)
print v(xbgr.mr_n83461872)
print v(xbgr.mr_n83461984)
print v(xbgr.mr_n83462304)
print v(xbgr.mr_n83462416)
print v(xbgr.mr_n83462736)
print v(xbgr.mr_n83462848)
print v(xbgr.mr_n83463168)
print v(xbgr.mr_n83463280)
print v(xbgr.mr_n83463600)
print v(xbgr.mr_n83463712)
print v(xbgr.mr_n83464032)
print v(xbgr.mr_n83464144)
print v(xbgr.mr_n83464464)
print v(xbgr.mr_n83464576)
print v(xbgr.mr_n83464896)
print v(xbgr.mr_n83465008)
print v(xbgr.mr_n83465328)
print v(xbgr.mr_n83465440)
print v(xbgr.mr_n83465760)
print v(xbgr.mr_n83465872)
print v(xbgr.mr_n83466192)
print v(xbgr.mr_n83466304)
print v(xbgr.mr_n83466624)
print v(xbgr.mr_n83466736)
print v(xbgr.mr_n83467056)
print v(xbgr.mr_n83467168)
print v(xbgr.mr_n83467488)
print v(xbgr.mr_n83467600)
print v(xbgr.mr_n83467920)
print v(xbgr.mr_n83468032)
print v(xbgr.mr_n83468352)
print v(xbgr.mr_n83468464)
print v(xbgr.mr_n83468784)
print v(xbgr.mr_n83468896)
print v(xbgr.mr_n83469216)
print v(xbgr.mr_n83469328)
print v(xbgr.mr_n83469648)
print v(xbgr.mr_n83469760)
print v(xbgr.mr_n83470080)
print v(xbgr.mr_n83470192)
print v(xbgr.mr_n83470512)
print v(xbgr.mr_n83470624)
print v(xbgr.mr_n83470944)
print v(xbgr.mr_n83471056)
print v(xbgr.mr_n83471376)
print v(xbgr.mr_n83471488)
print v(xbgr.mr_n83471808)
print v(xbgr.mr_n83471920)
print v(xbgr.mr_n83472240)
print v(xbgr.mr_n83472352)
print v(xbgr.mr_n83472672)
print v(xbgr.mr_n83472784)
print v(xbgr.mr_n83473104)
print v(xbgr.mr_n83473216)
print v(xbgr.mr_n83473536)
print v(xbgr.mr_n83473648)
print v(xbgr.mr_n83473968)
print v(xbgr.mr_n83474080)
print v(xbgr.mr_n83474400)
print v(xbgr.mr_n83474512)
print v(xbgr.mr_n83474832)
print v(xbgr.mr_n83474944)
print v(xbgr.mr_n83475264)
print v(xbgr.mr_n83475696)
print v(xbgr.mr_n83475808)
print v(xbgr.mr_n83476128)
print v(xbgr.mr_n83476240)
print v(xbgr.mr_n83476560)
print v(xbgr.mr_n83476672)
print v(xbgr.mr_n83476992)
print v(xbgr.mr_n83477104)
print v(xbgr.mr_n83477424)
print v(xbgr.mr_n83477536)
print v(xbgr.mr_n83477856)
print v(xbgr.mr_n83477968)
print v(xbgr.mr_n83478288)
print v(xbgr.mr_n83478400)
print v(xbgr.mr_n83478720)
print v(xbgr.mr_n83478832)
print v(xbgr.mr_n83479152)
print v(xbgr.mr_n83479264)
print v(xbgr.mr_n83479584)
print v(xbgr.mr_n83479696)
print v(xbgr.mr_n83480016)
print v(xbgr.mr_n83480128)
print v(xbgr.mr_n83480448)
print v(xbgr.mr_n83480560)
print v(xbgr.mr_n83480880)
print v(xbgr.mr_n83480992)
print v(xbgr.mr_n83481312)
print v(xbgr.mr_n83481424)
print v(xbgr.mr_n83481744)
print v(xbgr.mr_n83481856)
print v(xbgr.mr_n83482176)
print v(xbgr.mr_n83482288)
print v(xbgr.mr_n83482608)
print v(xbgr.mr_n83482720)
print v(xbgr.mr_n83483040)
print v(xbgr.mr_n83483152)
print v(xbgr.mr_n83483472)
print v(xbgr.mr_n83483584)
print v(xbgr.mr_n83483904)
print v(xbgr.mr_n83484016)
print v(xbgr.mr_n83484336)
print v(xbgr.mr_n83484448)
print v(xbgr.mr_n83484768)
print v(xbgr.mr_n83484880)
print v(xbgr.mr_n83485200)
print v(xbgr.mr_n83485312)
print v(xbgr.mr_n83485632)
print v(xbgr.mr_n83485744)
print v(xbgr.mr_n83486064)
print v(xbgr.mr_n83486176)
print v(xbgr.mr_n83486496)
print v(xbgr.mr_n83486608)
print v(xbgr.mr_n83486928)
print v(xbgr.mr_n83487040)
print v(xbgr.mr_n83487360)
print v(xbgr.mr_n83487472)
print v(xbgr.mr_n83487792)
print v(xbgr.mr_n83487904)
print v(xbgr.mr_n83488224)
print v(xbgr.mr_n83488336)
print v(xbgr.mr_n83488656)
print v(xbgr.mr_n83488768)
print v(xbgr.mr_n83489088)
print v(xbgr.mr_n83489200)
print v(xbgr.mr_n83489520)
print v(xbgr.mr_n83489632)
print v(xbgr.mr_n83489952)
print v(xbgr.mr_n83490064)
print v(xbgr.mr_n83490384)
print v(xbgr.mr_n83490496)
print v(xbgr.mr_n83490816)
print v(xbgr.mr_n83490928)
print v(xbgr.mr_n83491248)
print v(xbgr.mr_n83491360)
print v(xbgr.mr_n83491680)
print v(xbgr.mr_n83491792)
print v(xbgr.mr_n83492112)
print v(xbgr.mr_n83492224)
print v(xbgr.mr_n83492544)
print v(xbgr.mr_n83492656)
print v(xbgr.mr_n83492976)
print v(xbgr.mr_n83493088)
print v(xbgr.mr_n83493408)
print v(xbgr.mr_n83493520)
print v(xbgr.mr_n83493840)
print v(xbgr.mr_n83493952)
print v(xbgr.mr_n83494272)
print v(xbgr.mr_n83494384)
print v(xbgr.mr_n83494704)
print v(xbgr.mr_n83494816)
print v(xbgr.mr_n83495136)
print v(xbgr.mr_n83495248)
print v(xbgr.mr_n83495568)
print v(xbgr.mr_n83495680)
print v(xbgr.mr_n83496000)
print v(xbgr.mr_n83496112)
print v(xbgr.mr_n83496432)
print v(xbgr.mr_n83496544)
print v(xbgr.mr_n83496864)
print v(xbgr.mr_n83496976)
print v(xbgr.mr_n83497296)
print v(xbgr.mr_n83497408)
print v(xbgr.mr_n83497728)
print v(xbgr.mr_n83497840)
print v(xbgr.mr_n83498160)
print v(xbgr.mr_n83498272)
print v(xbgr.mr_n83498592)
print v(xbgr.mr_n83498704)
print v(xbgr.mr_n83499024)
print v(xbgr.mr_n83499136)
print v(xbgr.mr_n83499456)
print v(xbgr.mr_n83499568)
print v(xbgr.mr_n83499888)
print v(xbgr.mr_n83500000)
print v(xbgr.mr_n83500320)
print v(xbgr.mr_n83500432)
print v(xbgr.mr_n83500752)
print v(xbgr.mr_n83500864)
print v(xbgr.mr_n83501184)
print v(xbgr.mr_n83501296)
print v(xbgr.mr_n83501616)
print v(xbgr.mr_n83501728)
print v(xbgr.mr_n83502048)
print v(xbgr.mr_n83502160)
print v(xbgr.mr_n83502480)
print v(xbgr.mr_n83502592)
print v(xbgr.mr_n83502912)
print v(xbgr.mr_n83503024)
print v(xbgr.mr_n83503344)
print v(xbgr.mr_n83503456)
print v(xbgr.mr_n83503776)
print v(xbgr.mr_n83503888)
print v(xbgr.mr_n83504208)
print v(xbgr.mr_n83504320)
print v(xbgr.mr_n83504640)
print v(xbgr.mr_n83504752)
print v(xbgr.mr_n83505072)
print v(xbgr.mr_n83505184)
print v(xbgr.mr_n83505504)
print v(xbgr.mr_n83505616)
print v(xbgr.mr_n83505936)
print v(xbgr.mr_n83506048)
print v(xbgr.mr_n83506368)
print v(xbgr.mr_n83506480)
print v(xbgr.mr_n83506800)
print v(xbgr.mr_n83506912)
print v(xbgr.mr_n83507232)
print v(xbgr.mr_n83507344)
print v(xbgr.mr_n83507664)
print v(xbgr.mr_n83507776)
print v(xbgr.mr_n83508096)
print v(xbgr.mr_n83508208)
print v(xbgr.mr_n83508528)
print v(xbgr.mr_n83508640)
print v(xbgr.mr_n83508960)
print v(xbgr.mr_n83509072)
print v(xbgr.mr_n83509392)
print v(xbgr.mr_n83509504)
print v(xbgr.mr_n83509824)
print v(xbgr.mr_n83509936)
print v(xbgr.mr_n83510256)
print v(xbgr.mr_n83510368)
print v(xbgr.mr_n83510688)
print v(xbgr.mr_n83510800)
print v(xbgr.mr_n83511120)
print v(xbgr.mr_n83511232)
print v(xbgr.mr_n83511552)
print v(xbgr.mr_n83511664)
print v(xbgr.mr_n83511984)
print v(xbgr.mr_n83512096)
print v(xbgr.mr_n83512416)
print v(xbgr.mr_n83512528)
print v(xbgr.mr_n83512848)
print v(xbgr.mr_n83512960)
print v(xbgr.mr_n83513280)
print v(xbgr.mr_n83513392)
print v(xbgr.mr_n83513712)
print v(xbgr.mr_n83513824)
print v(xbgr.mr_n83514144)
print v(xbgr.mr_n83514256)
print v(xbgr.mr_n83514576)
print v(xbgr.mr_n83514688)
print v(xbgr.mr_n83515008)
print v(xbgr.mr_n83515120)
print v(xbgr.mr_n83515440)
print v(xbgr.mr_n83515552)
print v(xbgr.mr_n83515872)
print v(xbgr.mr_n83515984)
print v(xbgr.mr_n83516304)
print v(xbgr.mr_n83516416)
print v(xbgr.mr_n83516736)
print v(xbgr.mr_n83516848)
print v(xbgr.mr_n83517168)
print v(xbgr.mr_n83517280)
print v(xbgr.mr_n83517600)
print v(xbgr.mr_n83517712)
print v(xbgr.mr_n83518032)
print v(xbgr.mr_n83518144)
print v(xbgr.mr_n83518464)
print v(xbgr.mr_n83518576)
print v(xbgr.mr_n83518896)
print v(xbgr.mr_n83519008)
print v(xbgr.mr_n83519328)
print v(xbgr.mr_n83519440)
print v(xbgr.mr_n83519760)
print v(xbgr.mr_n83519872)
print v(xbgr.mr_n83520192)
print v(xbgr.mr_n83520304)
print v(xbgr.mr_n83520624)
print v(xbgr.mr_n83520736)
print v(xbgr.mr_n83521056)
print v(xbgr.mr_n83521168)
print v(xbgr.mr_n83521488)
print v(xbgr.mr_n83521600)
print v(xbgr.mr_n83521920)
print v(xbgr.mr_n83522032)
print v(xbgr.mr_n83522352)
print v(xbgr.mr_n83522464)
print v(xbgr.mr_n83522784)
print v(xbgr.mr_n83522896)
print v(xbgr.mr_n83523216)
print v(xbgr.mr_n83523328)
print v(xbgr.mr_n83523648)
print v(xbgr.mr_n83523760)
print v(xbgr.mr_n83524080)
print v(xbgr.mr_n83524192)
print v(xbgr.mr_n83524512)
print v(xbgr.mr_n83524624)
print v(xbgr.mr_n83524944)
print v(xbgr.mr_n83525056)
print v(xbgr.mr_n83525376)
print v(xbgr.mr_n83525808)
print v(xbgr.mr_n83525920)
print v(xbgr.mr_n83526240)
print v(xbgr.mr_n83526352)
print v(xbgr.mr_n83526672)
print v(xbgr.mr_n83526784)
print v(xbgr.mr_n83527104)
print v(xbgr.mr_n83527216)
print v(xbgr.mr_n83527536)
print v(xbgr.mr_n83527648)
print v(xbgr.mr_n83527968)
print v(xbgr.mr_n83528080)
print v(xbgr.mr_n83528400)
print v(xbgr.mr_n83528512)
print v(xbgr.mr_n83528832)
print v(xbgr.mr_n83528944)
print v(xbgr.mr_n83529264)
print v(xbgr.mr_n83529376)
print v(xbgr.mr_n83529696)
print v(xbgr.mr_n83529808)
print v(xbgr.mr_n83530128)
print v(xbgr.mr_n83530240)
print v(xbgr.mr_n83530560)
print v(xbgr.mr_n83530672)
print v(xbgr.mr_n83530992)
print v(xbgr.mr_n83531104)
print v(xbgr.mr_n83531424)
print v(xbgr.mr_n83531536)
print v(xbgr.mr_n83531856)
print v(xbgr.mr_n83531968)
print v(xbgr.mr_n83532288)
print v(xbgr.mr_n83532400)
print v(xbgr.mr_n83532720)
print v(xbgr.mr_n83532832)
print v(xbgr.mr_n83533152)
print v(xbgr.mr_n83533264)
print v(xbgr.mr_n83533584)
print v(xbgr.mr_n83533696)
print v(xbgr.mr_n83534016)
print v(xbgr.mr_n83534128)
print v(xbgr.mr_n83534448)
print v(xbgr.mr_n83534560)
print v(xbgr.mr_n83534880)
print v(xbgr.mr_n83534992)
print v(xbgr.mr_n83535312)
print v(xbgr.mr_n83535424)
print v(xbgr.mr_n83535744)
print v(xbgr.mr_n83535856)
print v(xbgr.mr_n83536176)
print v(xbgr.mr_n83536288)
print v(xbgr.mr_n83536608)
print v(xbgr.mr_n83536720)
print v(xbgr.mr_n83537040)
print v(xbgr.mr_n83537152)
print v(xbgr.mr_n83537472)
print v(xbgr.mr_n83537584)
print v(xbgr.mr_n83537904)
print v(xbgr.mr_n83538016)
print v(xbgr.mr_n83538336)
print v(xbgr.mr_n83538448)
print v(xbgr.mr_n83538768)
print v(xbgr.mr_n83538880)
print v(xbgr.mr_n83539200)
print v(xbgr.mr_n83539312)
print v(xbgr.mr_n83539632)
print v(xbgr.mr_n83539744)
print v(xbgr.mr_n83540064)
print v(xbgr.mr_n83540176)
print v(xbgr.mr_n83540496)
print v(xbgr.mr_n83540608)
print v(xbgr.mr_n83540928)
print v(xbgr.mr_n83541040)
print v(xbgr.mr_n83541360)
print v(xbgr.mr_n83541472)
print v(xbgr.mr_n83541792)
print v(xbgr.mr_n83541904)
print v(xbgr.mr_n83542224)
print v(xbgr.mr_n83542336)
print v(xbgr.mr_n83542656)
print v(xbgr.mr_n83542768)
print v(xbgr.mr_n83543088)
print v(xbgr.mr_n83543200)
print v(xbgr.mr_n83543520)
print v(xbgr.mr_n83543632)
print v(xbgr.mr_n83543952)
print v(xbgr.mr_n83544064)
print v(xbgr.mr_n83544384)
print v(xbgr.mr_n83544496)
print v(xbgr.mr_n83544816)
print v(xbgr.mr_n83544928)
print v(xbgr.mr_n83545248)
print v(xbgr.mr_n83545360)
print v(xbgr.mr_n83545680)
print v(xbgr.mr_n83545792)
print v(xbgr.mr_n83546112)
print v(xbgr.mr_n83546544)
print v(xbgr.mr_n83546656)
print v(xbgr.mr_n83546976)
print v(xbgr.mr_n83547088)
print v(xbgr.mr_n83547408)
print v(xbgr.mr_n83547520)
print v(xbgr.mr_n83547840)
print v(xbgr.mr_n83547952)
print v(xbgr.mr_n83548272)
print v(xbgr.mr_n83548384)
print v(xbgr.mr_n83548704)
print v(xbgr.mr_n83548816)
print v(xbgr.mr_n83549248)
print v(xbgr.mr_n83549680)
print v(xbgr.mr_n83550000)
print v(xbgr.mr_n83550112)
print v(xbgr.mr_n83550432)
print v(xbgr.mr_n83550544)
print v(xbgr.mr_n83550864)
print v(xbgr.mr_n83550976)
print v(xbgr.mr_n83551296)
print v(xbgr.mr_n83551408)
print v(xbgr.mr_n83551728)
print v(xbgr.mr_n83551840)
print v(xbgr.mr_n83552160)
print v(xbgr.mr_n83552272)
print v(xbgr.mr_n83552592)
print v(xbgr.mr_n83552704)
print v(xbgr.mr_n83553024)
print v(xbgr.mr_n83553136)
print v(xbgr.mr_n83553456)
print v(xbgr.mr_n83553568)
print v(xbgr.mr_n83553888)
print v(xbgr.mr_n83554000)
print v(xbgr.mr_n83554320)
print v(xbgr.mr_n83554432)
print v(xbgr.mr_n83554752)
print v(xbgr.mr_n83554864)
print v(xbgr.mr_n83555184)
print v(xbgr.mr_n83555296)
print v(xbgr.mr_n83555616)
print v(xbgr.mr_n83555728)
print v(xbgr.mr_n83556048)
print v(xbgr.mr_n83556160)
print v(xbgr.mr_n83556480)
print v(xbgr.mr_n83556592)
print v(xbgr.mr_n83556912)
print v(xbgr.mr_n83557024)
print v(xbgr.mr_n83557344)
print v(xbgr.mr_n83557456)
print v(xbgr.mr_n83557776)
print v(xbgr.mr_n83557888)
print v(xbgr.mr_n83558208)
print v(xbgr.mr_n83558320)
print v(xbgr.mr_n83558640)
print v(xbgr.mr_n83558752)
print v(xbgr.mr_n83559072)
print v(xbgr.mr_n83559184)
print v(xbgr.mr_n83559504)
print v(xbgr.mr_n83559616)
print v(xbgr.mr_n83559936)
print v(xbgr.mr_n83560048)
print v(xbgr.mr_n83560368)
print v(xbgr.mr_n83560480)
print v(xbgr.mr_n83560800)
print v(xbgr.mr_n83560912)
print v(xbgr.mr_n83561232)
print v(xbgr.mr_n83561344)
print v(xbgr.mr_n83561664)
print v(xbgr.mr_n83561776)
print v(xbgr.mr_n83562096)
print v(xbgr.mr_n83562208)
print v(xbgr.mr_n83562528)
print v(xbgr.mr_n83562640)
print v(xbgr.mr_n83562960)
print v(xbgr.mr_n83563072)
print v(xbgr.mr_n83563392)
print v(xbgr.mr_n83563504)
print v(xbgr.mr_n83563824)
print v(xbgr.mr_n83563936)
print v(xbgr.mr_n83564256)
print v(xbgr.mr_n83564368)
print v(xbgr.mr_n83564688)
print v(xbgr.mr_n83564800)
print v(xbgr.mr_n83565120)
print v(xbgr.mr_n83565232)
print v(xbgr.mr_n83565552)
print v(xbgr.mr_n83565664)
print v(xbgr.mr_n83565984)
print v(xbgr.mr_n83566096)
print v(xbgr.mr_n83566416)
print v(xbgr.mr_n83566528)
print v(xbgr.mr_n83566848)
print v(xbgr.mr_n83566960)
print v(xbgr.mr_n83567280)
print v(xbgr.mr_n83567392)
print v(xbgr.mr_n83567712)
print v(xbgr.mr_n83567824)
print v(xbgr.mr_n83568144)
print v(xbgr.mr_n83568256)
print v(xbgr.mr_n83568576)
print v(xbgr.mr_n83568688)
print v(xbgr.mr_n83569008)
print v(xbgr.mr_n83569120)
print v(xbgr.mr_n83569440)
print v(xbgr.mr_n83569552)
print v(xbgr.mr_n83569872)
print v(xbgr.mr_n83569984)
print v(xbgr.mr_n83570304)
print v(xbgr.mr_n83570416)
print v(xbgr.mr_n83570736)
print v(xbgr.mr_n83570848)
print v(xbgr.mr_n83571168)
print v(xbgr.mr_n83571280)
print v(xbgr.mr_n83571600)
print v(xbgr.mr_n83571712)
print v(xbgr.mr_n83572032)
print v(xbgr.mr_n83572144)
print v(xbgr.mr_n83572464)
print v(xbgr.mr_n83572576)
print v(xbgr.mr_n83572896)
print v(xbgr.mr_n83573008)
print v(xbgr.mr_n83573328)
print v(xbgr.mr_n83573440)
print v(xbgr.mr_n83573760)
print v(xbgr.mr_n83573872)
print v(xbgr.mr_n83574192)
print v(xbgr.mr_n83574304)
print v(xbgr.mr_n83574624)
print v(xbgr.mr_n83574736)
print v(xbgr.mr_n83575056)
print v(xbgr.mr_n83575168)
print v(xbgr.mr_n83575488)
print v(xbgr.mr_n83575600)
print v(xbgr.mr_n83575920)
print v(xbgr.mr_n83576032)
print v(xbgr.mr_n83576352)
print v(xbgr.mr_n83576464)
print v(xbgr.mr_n83576784)
print v(xbgr.mr_n83576896)
print v(xbgr.mr_n83577216)
print v(xbgr.mr_n83577328)
print v(xbgr.mr_n83577648)
print v(xbgr.mr_n83577760)
print v(xbgr.mr_n83578080)
print v(xbgr.mr_n83578192)
print v(xbgr.mr_n83578512)
print v(xbgr.mr_n83578624)
print v(xbgr.mr_n83578944)
print v(xbgr.mr_n83579056)
print v(xbgr.mr_n83579376)
print v(xbgr.mr_n83579488)
print v(xbgr.mr_n83579808)
print v(xbgr.mr_n83579920)
print v(xbgr.mr_n83580240)
print v(xbgr.mr_n83580352)
print v(xbgr.mr_n83580672)
print v(xbgr.mr_n83580784)
print v(xbgr.mr_n83581104)
print v(xbgr.mr_n83581216)
print v(xbgr.mr_n83581536)
print v(xbgr.mr_n83581648)
print v(xbgr.mr_n83581968)
print v(xbgr.mr_n83582080)
print v(xbgr.mr_n83582400)
print v(xbgr.mr_n83582512)
print v(xbgr.mr_n83582832)
print v(xbgr.mr_n83582944)
print v(xbgr.mr_n83583264)
print v(xbgr.mr_n83583376)
print v(xbgr.mr_n83583696)
print v(xbgr.mr_n83583808)
print v(xbgr.mr_n83584128)
print v(xbgr.mr_n83584240)
print v(xbgr.mr_n83584560)
print v(xbgr.mr_n83584672)
print v(xbgr.mr_n83584992)
print v(xbgr.mr_n83585104)
print v(xbgr.mr_n83585424)
print v(xbgr.mr_n83585536)
print v(xbgr.mr_n83585856)
print v(xbgr.mr_n83585968)
print v(xbgr.mr_n83586288)
print v(xbgr.mr_n83586400)
print v(xbgr.mr_n83586720)
print v(xbgr.mr_n83586832)
print v(xbgr.mr_n83587152)
print v(xbgr.mr_n83587264)
print v(xbgr.mr_n83587584)
print v(xbgr.mr_n83587696)
print v(xbgr.mr_n83588016)
print v(xbgr.mr_n83588128)
print v(xbgr.mr_n83588448)
print v(xbgr.mr_n83588560)
print v(xbgr.mr_n83588880)
print v(xbgr.mr_n83588992)
print v(xbgr.mr_n83589312)
print v(xbgr.mr_n83589424)
print v(xbgr.mr_n83589744)
print v(xbgr.mr_n83589856)
print v(xbgr.mr_n83590176)
print v(xbgr.mr_n83590288)
print v(xbgr.mr_n83590608)
print v(xbgr.mr_n83590720)
print v(xbgr.mr_n83591040)
print v(xbgr.mr_n83591152)
print v(xbgr.mr_n83591472)
print v(xbgr.mr_n83591584)
print v(xbgr.mr_n83591904)
print v(xbgr.mr_n83592016)
print v(xbgr.mr_n83592336)
print v(xbgr.mr_n83592448)
print v(xbgr.mr_n83592768)
print v(xbgr.mr_n83592880)
print v(xbgr.mr_n83593200)
print v(xbgr.mr_n83593312)
print v(xbgr.mr_n83593632)
print v(xbgr.mr_n83593744)
print v(xbgr.mr_n83594064)
print v(xbgr.mr_n83594176)
print v(xbgr.mr_n83594496)
print v(xbgr.mr_n83594608)
print v(xbgr.mr_n83594928)
print v(xbgr.mr_n83595040)
print v(xbgr.mr_n83595360)
print v(xbgr.mr_n83595472)
print v(xbgr.mr_n83595792)
print v(xbgr.mr_n83595904)
print v(xbgr.mr_n83596224)
print v(xbgr.mr_n83596336)
print v(xbgr.mr_n83596656)
print v(xbgr.mr_n83596768)
print v(xbgr.mr_n83597088)
print v(xbgr.mr_n83597200)
print v(xbgr.mr_n83597520)
print v(xbgr.mr_n83597632)
print v(xbgr.mr_n83597952)
print v(xbgr.mr_n83598064)
print v(xbgr.mr_n83598384)
print v(xbgr.mr_n83598496)
print v(xbgr.mr_n83598816)
print v(xbgr.mr_n83598928)
print v(xbgr.mr_n83599248)
print v(xbgr.mr_n83599360)
print v(xbgr.mr_n83599680)
print v(xbgr.mr_n83599792)
print v(xbgr.mr_n83600112)
print v(xbgr.mr_n83600224)
print v(xbgr.mr_n83600544)
print v(xbgr.mr_n83600656)
print v(xbgr.mr_n83600976)
print v(xbgr.mr_n83601088)
print v(xbgr.mr_n83601408)
print v(xbgr.mr_n83601520)
print v(xbgr.mr_n83601840)
print v(xbgr.mr_n83601952)
print v(xbgr.mr_n83602272)
print v(xbgr.mr_n83602384)
print v(xbgr.mr_n83602704)
print v(xbgr.mr_n83602816)
print v(xbgr.mr_n83603136)
print v(xbgr.mr_n83603248)
print v(xbgr.mr_n83603568)
print v(xbgr.mr_n83603680)
print v(xbgr.mr_n83604000)
print v(xbgr.mr_n83604112)
print v(xbgr.mr_n83604432)
print v(xbgr.mr_n83604544)
print v(xbgr.mr_n83604864)
print v(xbgr.mr_n83604976)
print v(xbgr.mr_n83605296)
print v(xbgr.mr_n83605408)
print v(xbgr.mr_n83605840)
print v(xbgr.mr_n83606272)
print v(xbgr.mr_n83606704)
print v(xbgr.mr_n83607136)
print v(xbgr.mr_n83607568)
print v(xbgr.mr_n83608000)
print v(xbgr.mr_n83608432)
print v(xbgr.mr_n83608864)
print v(xbgr.mr_n83609296)
print v(xbgr.mr_n83609728)
print v(xbgr.mr_n83610160)
print v(xbgr.mr_n83610592)
print v(xbgr.mr_n83611024)
print v(xbgr.mr_n83611456)
print v(xbgr.mr_n83611888)
print v(xbgr.mr_n83612320)
print v(xbgr.mr_n83612752)
print v(xbgr.mr_n83613184)
print v(xbgr.mr_n83613616)
print v(xbgr.mr_n83614048)
print v(xbgr.mr_n83614480)
print v(xbgr.mr_n83614912)
print v(xbgr.mr_n83615344)
print v(xbgr.mr_n83615776)
print v(xbgr.mr_n83616208)
print v(xbgr.mr_n83616640)
print v(xbgr.mr_n83617072)
print v(xbgr.mr_n83617504)
print v(xbgr.mr_n83617936)
print v(xbgr.mr_n83618368)
print v(xbgr.mr_n83618800)
print v(xbgr.mr_n83619232)
print v(xbgr.mr_n83619664)
print v(xbgr.mr_n83620096)
print v(xbgr.mr_n83620528)
print v(xbgr.mr_n83620960)
print v(xbgr.mr_n83621392)
print v(xbgr.mr_n83621824)
print v(xbgr.mr_n83622256)
print v(xbgr.mr_n83622688)
print v(xbgr.mr_n83623120)
print v(xbgr.mr_n83623552)
print v(xbgr.mr_n83623984)
print v(xbgr.mr_n83624416)
print v(xbgr.mr_n83624848)
print v(xbgr.mr_n83625280)
print v(xbgr.mr_n83625712)
print v(xbgr.mr_n83626144)
print v(xbgr.mr_n83626576)
print v(xbgr.mr_n83627008)
print v(xbgr.mr_n83627440)
print v(xbgr.mr_n83627872)
print v(xbgr.mr_n83628304)
print v(xbgr.mr_n83628736)
print v(xbgr.mr_n83629168)
print v(xbgr.mr_n83629600)
print v(xbgr.mr_n83630032)
print v(xbgr.mr_n83630464)
print v(xbgr.mr_n83630896)
print v(xbgr.mr_n83631328)
print v(xbgr.mr_n83631760)
print v(xbgr.mr_n83632192)
print v(xbgr.mr_n83632624)
print v(xbgr.mr_n83633056)
print v(xbgr.mr_n83633488)
print v(xbgr.mr_n83633920)
print v(xbgr.mr_n83634352)
print v(xbgr.mr_n83634784)
print v(xbgr.mr_n83635216)
print v(xbgr.mr_n83635648)
print v(xbgr.mr_n83636080)
print v(xbgr.mr_n83636512)
print v(xbgr.mr_n83636944)
print v(xbgr.mr_n83637376)
print v(xbgr.mr_n83637808)
print v(xbgr.mr_n83638240)
print v(xbgr.mr_n83638672)
print v(xbgr.mr_n83639104)
print v(xbgr.mr_n83639536)
print v(xbgr.mr_n83639968)
print v(xbgr.mr_n83640400)
print v(xbgr.mr_n83640832)
print v(xbgr.mr_n83641264)
print v(xbgr.mr_n83641696)
print v(xbgr.mr_n83642128)
print v(xbgr.mr_n83642560)
print v(xbgr.mr_n83642992)
print v(xbgr.mr_n83643424)
print v(xbgr.mr_n83643856)
print v(xbgr.mr_n83644288)
print v(xbgr.mr_n83644720)
print v(xbgr.mr_n83645152)
print v(xbgr.mr_n83645584)
print v(xbgr.mr_n83646016)
print v(xbgr.mr_n83646448)
print v(xbgr.mr_n83646880)
print v(xbgr.mr_n83647312)
print v(xbgr.mr_n83647744)
print v(xbgr.mr_n83648064)
print v(xbgr.mr_n83648176)
print v(xbgr.mr_n83648496)
print v(xbgr.mr_n83648608)
print v(xbgr.mr_n83648928)
print v(xbgr.mr_n83649040)
print v(xbgr.mr_n83649360)
print v(xbgr.mr_n83649472)
print v(xbgr.mr_n83649792)
print v(xbgr.mr_n83649904)
print v(xbgr.mr_n83650224)
print v(xbgr.mr_n83650336)
print v(xbgr.mr_n83650656)
print v(xbgr.mr_n83650768)
print v(xbgr.mr_n83651088)
print v(xbgr.mr_n83651200)
print v(xbgr.mr_n83651520)
print v(xbgr.mr_n83651632)
print v(xbgr.mr_n83651952)
print v(xbgr.mr_n83652064)
print v(xbgr.mr_n83652384)
print v(xbgr.mr_n83652496)
print v(xbgr.mr_n83652816)
print v(xbgr.mr_n83652928)
print v(xbgr.mr_n83653248)
print v(xbgr.mr_n83653360)
print v(xbgr.mr_n83653680)
print v(xbgr.mr_n83653792)
print v(xbgr.mr_n83654112)
print v(xbgr.mr_n83654224)
print v(xbgr.mr_n83654544)
print v(xbgr.mr_n83654656)
print v(xbgr.mr_n83654976)
print v(xbgr.mr_n83655088)
print v(xbgr.mr_n83655408)
print v(xbgr.mr_n83655520)
print v(xbgr.mr_n83655840)
print v(xbgr.mr_n83655952)
print v(xbgr.mr_n83656272)
print v(xbgr.mr_n83656384)
print v(xbgr.mr_n83656704)
print v(xbgr.mr_n83656816)
print v(xbgr.mr_n83657136)
print v(xbgr.mr_n83657248)
print v(xbgr.mr_n83657568)
print v(xbgr.mr_n83657680)
print v(xbgr.mr_n83658000)
print v(xbgr.mr_n83658112)
print v(xbgr.mr_n83658432)
print v(xbgr.mr_n83658544)
print v(xbgr.mr_n83658864)
print v(xbgr.mr_n83658976)
print v(xbgr.mr_n83659296)
print v(xbgr.mr_n83659408)
print v(xbgr.mr_n83659728)
print v(xbgr.mr_n83659840)
print v(xbgr.mr_n83660160)
print v(xbgr.mr_n83660272)
print v(xbgr.mr_n83660592)
print v(xbgr.mr_n83660704)
print v(xbgr.mr_n83661024)
print v(xbgr.mr_n83661136)
print v(xbgr.mr_n83661456)
print v(xbgr.mr_n83661568)
print v(xbgr.mr_n83661888)
print v(xbgr.mr_n83662000)
print v(xbgr.mr_n83662320)
print v(xbgr.mr_n83662432)
print v(xbgr.mr_n83662752)
print v(xbgr.mr_n83662864)
print v(xbgr.mr_n83663184)
print v(xbgr.mr_n83663296)
print v(xbgr.mr_n83663616)
print v(xbgr.mr_n83663728)
print v(xbgr.mr_n83664048)
print v(xbgr.mr_n83664160)
print v(xbgr.mr_n83664480)
print v(xbgr.mr_n83664592)
print v(xbgr.mr_n83664912)
print v(xbgr.mr_n83665024)
print v(xbgr.mr_n83665344)
print v(xbgr.mr_n83665456)
print v(xbgr.mr_n83665776)
print v(xbgr.mr_n83665888)
print v(xbgr.mr_n83666208)
print v(xbgr.mr_n83666320)
print v(xbgr.mr_n83666640)
print v(xbgr.mr_n83666752)
print v(xbgr.mr_n83667072)
print v(xbgr.mr_n83667184)
print v(xbgr.mr_n83667504)
print v(xbgr.mr_n83667616)
print v(xbgr.mr_n83667936)
print v(xbgr.mr_n83668048)
print v(xbgr.mr_n83668368)
print v(xbgr.mr_n83668480)
print v(xbgr.mr_n83668800)
print v(xbgr.mr_n83668912)
print v(xbgr.mr_n83669232)
print v(xbgr.mr_n83669344)
print v(xbgr.mr_n83669664)
print v(xbgr.mr_n83669776)
print v(xbgr.mr_n83670096)
print v(xbgr.mr_n83670208)
print v(xbgr.mr_n83670528)
print v(xbgr.mr_n83670640)
print v(xbgr.mr_n83670960)
print v(xbgr.mr_n83671072)
print v(xbgr.mr_n83671392)
print v(xbgr.mr_n83671504)
print v(xbgr.mr_n83671824)
print v(xbgr.mr_n83671936)
print v(xbgr.mr_n83672256)
print v(xbgr.mr_n83672368)
print v(xbgr.mr_n83672688)
print v(xbgr.mr_n83672800)
print v(xbgr.mr_n83673120)
print v(xbgr.mr_n83673232)
print v(xbgr.mr_n83673552)
print v(xbgr.mr_n83673664)
print v(xbgr.mr_n83673984)
print v(xbgr.mr_n83674096)
print v(xbgr.mr_n83674416)
print v(xbgr.mr_n83674528)
print v(xbgr.mr_n83674848)
print v(xbgr.mr_n83674960)
print v(xbgr.mr_n83675280)
print v(xbgr.mr_n83675392)
print v(xbgr.mr_n83675712)
print v(xbgr.mr_n83675824)
print v(xbgr.mr_n83676144)
print v(xbgr.mr_n83676256)
print v(xbgr.mr_n83676576)
print v(xbgr.mr_n83676688)
print v(xbgr.mr_n83677008)
print v(xbgr.mr_n83677120)
print v(xbgr.mr_n83677440)
print v(xbgr.mr_n83677552)
print v(xbgr.mr_n83677872)
print v(xbgr.mr_n83677984)
print v(xbgr.mr_n83678304)
print v(xbgr.mr_n83678416)
print v(xbgr.mr_n83678736)
print v(xbgr.mr_n83678848)
print v(xbgr.mr_n83679168)
print v(xbgr.mr_n83679280)
print v(xbgr.mr_n83679600)
print v(xbgr.mr_n83679712)
print v(xbgr.mr_n83680032)
print v(xbgr.mr_n83680144)
print v(xbgr.mr_n83680464)
print v(xbgr.mr_n83680576)
print v(xbgr.mr_n83680896)
print v(xbgr.mr_n83681008)
print v(xbgr.mr_n83681328)
print v(xbgr.mr_n83681440)
print v(xbgr.mr_n83681760)
print v(xbgr.mr_n83681872)
print v(xbgr.mr_n83682192)
print v(xbgr.mr_n83682304)
print v(xbgr.mr_n83682624)
print v(xbgr.mr_n83682736)
print v(xbgr.mr_n83683056)
print v(xbgr.mr_n83683168)
print v(xbgr.mr_n83683488)
print v(xbgr.mr_n83683600)
print v(xbgr.mr_n83683920)
print v(xbgr.mr_n83684032)
print v(xbgr.mr_n83684352)
print v(xbgr.mr_n83684464)
print v(xbgr.mr_n83684784)
print v(xbgr.mr_n83684896)
print v(xbgr.mr_n83685216)
print v(xbgr.mr_n83685328)
print v(xbgr.mr_n83685648)
print v(xbgr.mr_n83685760)
print v(xbgr.mr_n83686080)
print v(xbgr.mr_n83686192)
print v(xbgr.mr_n83686512)
print v(xbgr.mr_n83686624)
print v(xbgr.mr_n83686944)
print v(xbgr.mr_n83687056)
print v(xbgr.mr_n83687376)
print v(xbgr.mr_n83687488)
print v(xbgr.mr_n83687808)
print v(xbgr.mr_n83687920)
print v(xbgr.mr_n83688240)
print v(xbgr.mr_n83688352)
print v(xbgr.mr_n83688672)
print v(xbgr.mr_n83688784)
print v(xbgr.mr_n83689104)
print v(xbgr.mr_n83689216)
print v(xbgr.mr_n83689536)
print v(xbgr.mr_n83689648)
print v(xbgr.mr_n83689968)
print v(xbgr.mr_n83690080)
print v(xbgr.mr_n83690400)
print v(xbgr.mr_n83690512)
print v(xbgr.mr_n83690832)
print v(xbgr.mr_n83690944)
print v(xbgr.mr_n83691264)
print v(xbgr.mr_n83691376)
print v(xbgr.mr_n83691696)
print v(xbgr.mr_n83691808)
print v(xbgr.mr_n83692128)
print v(xbgr.mr_n83692240)
print v(xbgr.mr_n83692560)
print v(xbgr.mr_n83692672)
print v(xbgr.mr_n83692992)
print v(xbgr.mr_n83693104)
print v(xbgr.mr_n83693424)
print v(xbgr.mr_n83693536)
print v(xbgr.mr_n83693856)
print v(xbgr.mr_n83693968)
print v(xbgr.mr_n83694288)
print v(xbgr.mr_n83694400)
print v(xbgr.mr_n83694720)
print v(xbgr.mr_n83694832)
print v(xbgr.mr_n83695152)
print v(xbgr.mr_n83695264)
print v(xbgr.mr_n83695584)
print v(xbgr.mr_n83695696)
print v(xbgr.mr_n83696016)
print v(xbgr.mr_n83696128)
print v(xbgr.mr_n83696448)
print v(xbgr.mr_n83696560)
print v(xbgr.mr_n83696880)
print v(xbgr.mr_n83696992)
print v(xbgr.mr_n83697312)
print v(xbgr.mr_n83697424)
print v(xbgr.mr_n83697744)
print v(xbgr.mr_n83697856)
print v(xbgr.mr_n83698176)
print v(xbgr.mr_n83698288)
print v(xbgr.mr_n83698608)
print v(xbgr.mr_n83698720)
print v(xbgr.mr_n83699040)
print v(xbgr.mr_n83699152)
print v(xbgr.mr_n83699472)
print v(xbgr.mr_n83699584)
print v(xbgr.mr_n83699904)
print v(xbgr.mr_n83700016)
print v(xbgr.mr_n83700336)
print v(xbgr.mr_n83700448)
print v(xbgr.mr_n83700768)
print v(xbgr.mr_n83700880)
print v(xbgr.mr_n83701200)
print v(xbgr.mr_n83701312)
print v(xbgr.mr_n83701632)
print v(xbgr.mr_n83701744)
print v(xbgr.mr_n83702064)
print v(xbgr.mr_n83702176)
print v(xbgr.mr_n83702496)
print v(xbgr.mr_n83702608)
print v(xbgr.mr_n83702928)
print v(xbgr.mr_n83703040)
print v(xbgr.mr_n83703360)
print v(xbgr.mr_n83703472)
print v(xbgr.mr_n83703792)
print v(xbgr.mr_n83703904)
print v(xbgr.mr_n83704224)
print v(xbgr.mr_n83704336)
print v(xbgr.mr_n83704656)
print v(xbgr.mr_n83704768)
print v(xbgr.mr_n83705088)
print v(xbgr.mr_n83705200)
print v(xbgr.mr_n83705520)
print v(xbgr.mr_n83705632)
print v(xbgr.mr_n83705952)
print v(xbgr.mr_n83706064)
print v(xbgr.mr_n83706384)
print v(xbgr.mr_n83706496)
print v(xbgr.mr_n83706816)
print v(xbgr.mr_n83706928)
print v(xbgr.mr_n83707248)
print v(xbgr.mr_n83707360)
print v(xbgr.mr_n83707680)
print v(xbgr.mr_n83707792)
print v(xbgr.mr_n83708112)
print v(xbgr.mr_n83708224)
print v(xbgr.mr_n83708544)
print v(xbgr.mr_n83708656)
print v(xbgr.mr_n83708976)
print v(xbgr.mr_n83709088)
print v(xbgr.mr_n83709408)
print v(xbgr.mr_n83709520)
print v(xbgr.mr_n83709840)
print v(xbgr.mr_n83709952)
print v(xbgr.mr_n83710272)
print v(xbgr.mr_n83710384)
print v(xbgr.mr_n83710704)
print v(xbgr.mr_n83710816)
print v(xbgr.mr_n83711248)
print v(xbgr.mr_n83711680)
print v(xbgr.mr_n83712112)
print v(xbgr.mr_n83712544)
print v(xbgr.mr_n83712976)
print v(xbgr.mr_n83713408)
print v(xbgr.mr_n83713840)
print v(xbgr.mr_n83714272)
print v(xbgr.mr_n83714704)
print v(xbgr.mr_n83715136)
print v(xbgr.mr_n83715568)
print v(xbgr.mr_n83716000)
print v(xbgr.mr_n83716432)
print v(xbgr.mr_n83716864)
print v(xbgr.mr_n83717296)
print v(xbgr.mr_n83717728)
print v(xbgr.mr_n83718160)
print v(xbgr.mr_n83718592)
print v(xbgr.mr_n83719024)
print v(xbgr.mr_n83719456)
print v(xbgr.mr_n83719888)
print v(xbgr.mr_n83720320)
print v(xbgr.mr_n83720752)
print v(xbgr.mr_n83721184)
print v(xbgr.mr_n83721616)
print v(xbgr.mr_n83722048)
print v(xbgr.mr_n83722480)
print v(xbgr.mr_n83722912)
print v(xbgr.mr_n83723344)
print v(xbgr.mr_n83723776)
print v(xbgr.mr_n83724208)
print v(xbgr.mr_n83724640)
print v(xbgr.mr_n83725072)
print v(xbgr.mr_n83725504)
print v(xbgr.mr_n83725936)
print v(xbgr.mr_n83726368)
print v(xbgr.mr_n83726800)
print v(xbgr.mr_n83727232)
print v(xbgr.mr_n83727664)
print v(xbgr.mr_n83728096)
print v(xbgr.mr_n83728528)
print v(xbgr.mr_n83728960)
print v(xbgr.mr_n83729392)
print v(xbgr.mr_n83729824)
print v(xbgr.mr_n83730256)
print v(xbgr.mr_n83730688)
print v(xbgr.mr_n83731120)
print v(xbgr.mr_n83731552)
print v(xbgr.mr_n83731984)
print v(xbgr.mr_n83732416)
print v(xbgr.mr_n83732848)
print v(xbgr.mr_n83733280)
print v(xbgr.mr_n83733712)
print v(xbgr.mr_n83734144)
print v(xbgr.mr_n83734576)
print v(xbgr.mr_n83735008)
print v(xbgr.mr_n83735440)
print v(xbgr.mr_n83735872)
print v(xbgr.mr_n83736304)
print v(xbgr.mr_n83736736)
print v(xbgr.mr_n83737168)
print v(xbgr.mr_n83737600)
print v(xbgr.mr_n83738032)
print v(xbgr.mr_n83738464)
print v(xbgr.mr_n83738896)
print v(xbgr.mr_n83739328)
print v(xbgr.mr_n83739760)
print v(xbgr.mr_n83740192)
print v(xbgr.mr_n83740624)
print v(xbgr.mr_n83741056)
print v(xbgr.mr_n83741488)
print v(xbgr.mr_n83741920)
print v(xbgr.mr_n83742352)
print v(xbgr.mr_n83742784)
print v(xbgr.mr_n83743216)
print v(xbgr.mr_n83743648)
print v(xbgr.mr_n83744080)
print v(xbgr.mr_n83744512)
print v(xbgr.mr_n83744944)
print v(xbgr.mr_n83745376)
print v(xbgr.mr_n83745808)
print v(xbgr.mr_n83746240)
print v(xbgr.mr_n83746672)
print v(xbgr.mr_n83747104)
print v(xbgr.mr_n83747536)
print v(xbgr.mr_n83747968)
print v(xbgr.mr_n83748400)
print v(xbgr.mr_n83748832)
print v(xbgr.mr_n83749264)
print v(xbgr.mr_n83749696)
print v(xbgr.mr_n83750128)
print v(xbgr.mr_n83750560)
print v(xbgr.mr_n83750992)
print v(xbgr.mr_n83751424)
print v(xbgr.mr_n83751856)
print v(xbgr.mr_n83752288)
print v(xbgr.mr_n83752720)
print v(xbgr.mr_n83753152)
print v(xbgr.mr_n83753584)
print v(xbgr.mr_n83754016)
print v(xbgr.mr_n83754448)
print v(xbgr.mr_n83754880)
print v(xbgr.mr_n83755312)
print v(xbgr.mr_n83755744)
print v(xbgr.mr_n83756176)
print v(xbgr.mr_n83756608)
print v(xbgr.mr_n83757040)
print v(xbgr.mr_n83757472)
print v(xbgr.mr_n83757904)
print v(xbgr.mr_n83758336)
print v(xbgr.mr_n83758768)
print v(xbgr.mr_n83759200)
print v(xbgr.mr_n83759632)
print v(xbgr.mr_n83760064)
print v(xbgr.mr_n83760496)
print v(xbgr.mr_n83760928)
print v(xbgr.mr_n83761360)
print v(xbgr.mr_n83761792)
print v(xbgr.mr_n83762224)
print v(xbgr.mr_n83762656)
print v(xbgr.mr_n83763088)
print v(xbgr.mr_n83763520)
print v(xbgr.mr_n83763952)
print v(xbgr.mr_n83764384)
print v(xbgr.mr_n83764816)
print v(xbgr.mr_n83765248)
print v(xbgr.mr_n83765680)
print v(xbgr.mr_n83766112)
print v(xbgr.mr_n83766544)
print v(xbgr.mr_n83766976)
print v(xbgr.mr_n83767408)
print v(xbgr.mr_n83767840)
print v(xbgr.mr_n83768272)
print v(xbgr.mr_n83768704)
print v(xbgr.mr_n83769136)
print v(xbgr.mr_n83769568)
print v(xbgr.mr_n83770000)
print v(xbgr.mr_n83770432)
print v(xbgr.mr_n83770864)
print v(xbgr.mr_n83771296)
print v(xbgr.mr_n83771728)
print v(xbgr.mr_n83772160)
print v(xbgr.mr_n83772592)
print v(xbgr.mr_n83773024)
print v(xbgr.mr_n83773456)
print v(xbgr.mr_n83773888)
print v(xbgr.mr_n83774320)
print v(xbgr.mr_n83774752)
print v(xbgr.mr_n83775184)
print v(xbgr.mr_n83775616)
print v(xbgr.mr_n83776048)
print v(xbgr.mr_n83776480)
print v(xbgr.mr_n83776912)
print v(xbgr.mr_n83777344)
print v(xbgr.mr_n83777776)
print v(xbgr.mr_n83778208)
print v(xbgr.mr_n83778640)
print v(xbgr.mr_n83779072)
print v(xbgr.mr_n83779504)
print v(xbgr.mr_n83779936)
print v(xbgr.mr_n83780368)
print v(xbgr.mr_n83780800)
print v(xbgr.mr_n83781232)
print v(xbgr.mr_n83781664)
print v(xbgr.mr_n83782096)
print v(xbgr.mr_n83782528)
print v(xbgr.mr_n83782960)
print v(xbgr.mr_n83783392)
print v(xbgr.mr_n83783824)
print v(xbgr.mr_n83784256)
print v(xbgr.mr_n83784688)
print v(xbgr.mr_n83785120)
print v(xbgr.mr_n83785552)
print v(xbgr.mr_n83785984)
print v(xbgr.mr_n83786416)
print v(xbgr.mr_n83786848)
print v(xbgr.mr_n83787280)
print v(xbgr.mr_n83787712)
print v(xbgr.mr_n83788144)
print v(xbgr.mr_n83788576)
print v(xbgr.mr_n83789008)
print v(xbgr.mr_n83789440)
print v(xbgr.mr_n83789872)
print v(xbgr.mr_n83790304)
print v(xbgr.mr_n83790736)
print v(xbgr.mr_n83791168)
print v(xbgr.mr_n83791600)
print v(xbgr.mr_n83792032)
print v(xbgr.mr_n83792464)
print v(xbgr.mr_n83792896)
print v(xbgr.mr_n83793328)
print v(xbgr.mr_n83793760)
print v(xbgr.mr_n83794192)
print v(xbgr.mr_n83794624)
print v(xbgr.mr_n83795056)
print v(xbgr.mr_n83795488)
print v(xbgr.mr_n83795920)
print v(xbgr.mr_n83796352)
print v(xbgr.mr_n83796784)
print v(xbgr.mr_n83797216)
print v(xbgr.mr_n83797648)
print v(xbgr.mr_n83798080)
print v(xbgr.mr_n83798512)
print v(xbgr.mr_n83798944)
print v(xbgr.mr_n83799376)
print v(xbgr.mr_n83799808)
print v(xbgr.mr_n83800240)
print v(xbgr.mr_n83800672)
print v(xbgr.mr_n83801104)
print v(xbgr.mr_n83801536)
print v(xbgr.mr_n83801968)
print v(xbgr.mr_n83802400)
print v(xbgr.mr_n83802832)
print v(xbgr.mr_n83803264)
print v(xbgr.mr_n83803584)
print v(xbgr.mr_n83803696)
print v(xbgr.mr_n83804016)
print v(xbgr.mr_n83804128)
print v(xbgr.mr_n83804448)
print v(xbgr.mr_n83804560)
print v(xbgr.mr_n83804880)
print v(xbgr.mr_n83804992)
print v(xbgr.mr_n83805312)
print v(xbgr.mr_n83805424)
print v(xbgr.mr_n83805744)
print v(xbgr.mr_n83805856)
print v(xbgr.mr_n83806176)
print v(xbgr.mr_n83806288)
print v(xbgr.mr_n83806608)
print v(xbgr.mr_n83806720)
print v(xbgr.mr_n83807040)
print v(xbgr.mr_n83807152)
print v(xbgr.mr_n83807472)
print v(xbgr.mr_n83807584)
print v(xbgr.mr_n83807904)
print v(xbgr.mr_n83808016)
print v(xbgr.mr_n83808336)
print v(xbgr.mr_n83808448)
print v(xbgr.mr_n83808768)
print v(xbgr.mr_n83808880)
print v(xbgr.mr_n83809200)
print v(xbgr.mr_n83809312)
print v(xbgr.mr_n83809632)
print v(xbgr.mr_n83809744)
print v(xbgr.mr_n83810064)
print v(xbgr.mr_n83810176)
print v(xbgr.mr_n83810496)
print v(xbgr.mr_n83810608)
print v(xbgr.mr_n83810928)
print v(xbgr.mr_n83811040)
print v(xbgr.mr_n83811360)
print v(xbgr.mr_n83811472)
print v(xbgr.mr_n83811792)
print v(xbgr.mr_n83811904)
print v(xbgr.mr_n83812224)
print v(xbgr.mr_n83812336)
print v(xbgr.mr_n83812656)
print v(xbgr.mr_n83812768)
print v(xbgr.mr_n83813088)
print v(xbgr.mr_n83813200)
print v(xbgr.mr_n83813520)
print v(xbgr.mr_n83813632)
print v(xbgr.mr_n83813952)
print v(xbgr.mr_n83814064)
print v(xbgr.mr_n83814384)
print v(xbgr.mr_n83814496)
print v(xbgr.mr_n83814816)
print v(xbgr.mr_n83814928)
print v(xbgr.mr_n83815248)
print v(xbgr.mr_n83815360)
print v(xbgr.mr_n83815680)
print v(xbgr.mr_n83815792)
print v(xbgr.mr_n83816112)
print v(xbgr.mr_n83816224)
print v(xbgr.mr_n83816544)
print v(xbgr.mr_n83816656)
print v(xbgr.mr_n83816976)
print v(xbgr.mr_n83817088)
print v(xbgr.mr_n83817408)
print v(xbgr.mr_n83817520)
print v(xbgr.mr_n83817840)
print v(xbgr.mr_n83817952)
print v(xbgr.mr_n83818272)
print v(xbgr.mr_n83818384)
print v(xbgr.mr_n83818704)
print v(xbgr.mr_n83818816)
print v(xbgr.mr_n83819136)
print v(xbgr.mr_n83819248)
print v(xbgr.mr_n83819568)
print v(xbgr.mr_n83819680)
print v(xbgr.mr_n83820000)
print v(xbgr.mr_n83820112)
print v(xbgr.mr_n83820432)
print v(xbgr.mr_n83820544)
print v(xbgr.mr_n83820864)
print v(xbgr.mr_n83820976)
print v(xbgr.mr_n83821296)
print v(xbgr.mr_n83821408)
print v(xbgr.mr_n83821728)
print v(xbgr.mr_n83821840)
print v(xbgr.mr_n83822160)
print v(xbgr.mr_n83822272)
print v(xbgr.mr_n83822592)
print v(xbgr.mr_n83822704)
print v(xbgr.mr_n83823024)
print v(xbgr.mr_n83823136)
print v(xbgr.mr_n83823456)
print v(xbgr.mr_n83823568)
print v(xbgr.mr_n83823888)
print v(xbgr.mr_n83824000)
print v(xbgr.mr_n83824320)
print v(xbgr.mr_n83824432)
print v(xbgr.mr_n83824752)
print v(xbgr.mr_n83824864)
print v(xbgr.mr_n83825184)
print v(xbgr.mr_n83825296)
print v(xbgr.mr_n83825616)
print v(xbgr.mr_n83825728)
print v(xbgr.mr_n83826048)
print v(xbgr.mr_n83826160)
print v(xbgr.mr_n83826480)
print v(xbgr.mr_n83826592)
print v(xbgr.mr_n83826912)
print v(xbgr.mr_n83827024)
print v(xbgr.mr_n83827344)
print v(xbgr.mr_n83827456)
print v(xbgr.mr_n83827776)
print v(xbgr.mr_n83827888)
print v(xbgr.mr_n83828208)
print v(xbgr.mr_n83828320)
print v(xbgr.mr_n83828640)
print v(xbgr.mr_n83828752)
print v(xbgr.mr_n83829072)
print v(xbgr.mr_n83829184)
print v(xbgr.mr_n83829504)
print v(xbgr.mr_n83829616)
print v(xbgr.mr_n83829936)
print v(xbgr.mr_n83830048)
print v(xbgr.mr_n83830368)
print v(xbgr.mr_n83830480)
print v(xbgr.mr_n83830800)
print v(xbgr.mr_n83830912)
print v(xbgr.mr_n83831232)
print v(xbgr.mr_n83831344)
print v(xbgr.mr_n83831664)
print v(xbgr.mr_n83831776)
print v(xbgr.mr_n83832096)
print v(xbgr.mr_n83832208)
print v(xbgr.mr_n83832528)
print v(xbgr.mr_n83832640)
print v(xbgr.mr_n83832960)
print v(xbgr.mr_n83833072)
print v(xbgr.mr_n83833392)
print v(xbgr.mr_n83833504)
print v(xbgr.mr_n83833824)
print v(xbgr.mr_n83833936)
print v(xbgr.mr_n83834256)
print v(xbgr.mr_n83834368)
print v(xbgr.mr_n83834688)
print v(xbgr.mr_n83834800)
print v(xbgr.mr_n83835120)
print v(xbgr.mr_n83835232)
print v(xbgr.mr_n83835552)
print v(xbgr.mr_n83835664)
print v(xbgr.mr_n83835984)
print v(xbgr.mr_n83836096)
print v(xbgr.mr_n83836416)
print v(xbgr.mr_n83836528)
print v(xbgr.mr_n83836848)
print v(xbgr.mr_n83836960)
print v(xbgr.mr_n83837280)
print v(xbgr.mr_n83837392)
print v(xbgr.mr_n83837712)
print v(xbgr.mr_n83837824)
print v(xbgr.mr_n83838144)
print v(xbgr.mr_n83838256)
print v(xbgr.mr_n83838576)
print v(xbgr.mr_n83838688)
print v(xbgr.mr_n83839008)
print v(xbgr.mr_n83839120)
print v(xbgr.mr_n83839440)
print v(xbgr.mr_n83839552)
print v(xbgr.mr_n83839872)
print v(xbgr.mr_n83839984)
print v(xbgr.mr_n83840304)
print v(xbgr.mr_n83840416)
print v(xbgr.mr_n83840736)
print v(xbgr.mr_n83840848)
print v(xbgr.mr_n83841168)
print v(xbgr.mr_n83841280)
print v(xbgr.mr_n83841600)
print v(xbgr.mr_n83841712)
print v(xbgr.mr_n83842032)
print v(xbgr.mr_n83842144)
print v(xbgr.mr_n83842464)
print v(xbgr.mr_n83842576)
print v(xbgr.mr_n83842896)
print v(xbgr.mr_n83843008)
print v(xbgr.mr_n83843328)
print v(xbgr.mr_n83843440)
print v(xbgr.mr_n83843760)
print v(xbgr.mr_n83843872)
print v(xbgr.mr_n83844192)
print v(xbgr.mr_n83844304)
print v(xbgr.mr_n83844624)
print v(xbgr.mr_n83844736)
print v(xbgr.mr_n83845056)
print v(xbgr.mr_n83845168)
print v(xbgr.mr_n83845488)
print v(xbgr.mr_n83845600)
print v(xbgr.mr_n83845920)
print v(xbgr.mr_n83846032)
print v(xbgr.mr_n83846352)
print v(xbgr.mr_n83846464)
print v(xbgr.mr_n83846784)
print v(xbgr.mr_n83846896)
print v(xbgr.mr_n83847216)
print v(xbgr.mr_n83847328)
print v(xbgr.mr_n83847648)
print v(xbgr.mr_n83847760)
print v(xbgr.mr_n83848080)
print v(xbgr.mr_n83848192)
print v(xbgr.mr_n83848512)
print v(xbgr.mr_n83848624)
print v(xbgr.mr_n83848944)
print v(xbgr.mr_n83849056)
print v(xbgr.mr_n83849376)
print v(xbgr.mr_n83849488)
print v(xbgr.mr_n83849808)
print v(xbgr.mr_n83849920)
print v(xbgr.mr_n83850240)
print v(xbgr.mr_n83850352)
print v(xbgr.mr_n83850672)
print v(xbgr.mr_n83850784)
print v(xbgr.mr_n83851104)
print v(xbgr.mr_n83851216)
print v(xbgr.mr_n83851536)
print v(xbgr.mr_n83851648)
print v(xbgr.mr_n83851968)
print v(xbgr.mr_n83852080)
print v(xbgr.mr_n83852400)
print v(xbgr.mr_n83852512)
print v(xbgr.mr_n83852832)
print v(xbgr.mr_n83852944)
print v(xbgr.mr_n83853264)
print v(xbgr.mr_n83853376)
print v(xbgr.mr_n83853696)
print v(xbgr.mr_n83853808)
print v(xbgr.mr_n83854128)
print v(xbgr.mr_n83854240)
print v(xbgr.mr_n83854560)
print v(xbgr.mr_n83854672)
print v(xbgr.mr_n83854992)
print v(xbgr.mr_n83855104)
print v(xbgr.mr_n83855424)
print v(xbgr.mr_n83855536)
print v(xbgr.mr_n83855856)
print v(xbgr.mr_n83855968)
print v(xbgr.mr_n83856288)
print v(xbgr.mr_n83856400)
print v(xbgr.mr_n83856720)
print v(xbgr.mr_n83856832)
print v(xbgr.mr_n83857152)
print v(xbgr.mr_n83857264)
print v(xbgr.mr_n83857584)
print v(xbgr.mr_n83857696)
print v(xbgr.mr_n83858016)
print v(xbgr.mr_n83858128)
print v(xbgr.mr_n83858448)
print v(xbgr.mr_n83858560)
print v(xbgr.mr_n83858880)
print v(xbgr.mr_n83858992)
print v(xbgr.mr_n83859312)
print v(xbgr.mr_n83859424)
print v(xbgr.mr_n83859744)
print v(xbgr.mr_n83859856)
print v(xbgr.mr_n83860176)
print v(xbgr.mr_n83860288)
print v(xbgr.mr_n83860608)
print v(xbgr.mr_n83860720)
print v(xbgr.mr_n83861040)
print v(xbgr.mr_n83861152)
print v(xbgr.mr_n83861472)
print v(xbgr.mr_n83861584)
print v(xbgr.mr_n83861904)
print v(xbgr.mr_n83862016)
print v(xbgr.mr_n83862336)
print v(xbgr.mr_n83862448)
print v(xbgr.mr_n83862768)
print v(xbgr.mr_n83862880)
print v(xbgr.mr_n83863200)
print v(xbgr.mr_n83863312)
print v(xbgr.mr_n83863632)
print v(xbgr.mr_n83863744)
print v(xbgr.mr_n83864064)
print v(xbgr.mr_n83864176)
print v(xbgr.mr_n83864496)
print v(xbgr.mr_n83864608)
print v(xbgr.mr_n83864928)
print v(xbgr.mr_n83865040)
print v(xbgr.mr_n83865360)
print v(xbgr.mr_n83865472)
print v(xbgr.mr_n83865792)
print v(xbgr.mr_n83865904)
print v(xbgr.mr_n83866224)
print v(xbgr.mr_n83866336)
print v(xbgr.mr_n83866656)
print v(xbgr.mr_n83866768)
print v(xbgr.mr_n83867088)
print v(xbgr.mr_n83867200)
print v(xbgr.mr_n83867520)
print v(xbgr.mr_n83867632)
print v(xbgr.mr_n83867952)
print v(xbgr.mr_n83868064)
print v(xbgr.mr_n83868384)
print v(xbgr.mr_n83868496)
print v(xbgr.mr_n83868816)
print v(xbgr.mr_n83868928)
print v(xbgr.mr_n83869248)
print v(xbgr.mr_n83869360)
print v(xbgr.mr_n83869680)
print v(xbgr.mr_n83869792)
print v(xbgr.mr_n83870112)
print v(xbgr.mr_n83870224)
print v(xbgr.mr_n83870544)
print v(xbgr.mr_n83870656)
print v(xbgr.mr_n83870976)
print v(xbgr.mr_n83871088)
print v(xbgr.mr_n83871408)
print v(xbgr.mr_n83871520)
print v(xbgr.mr_n83871840)
print v(xbgr.mr_n83871952)
print v(xbgr.mr_n83872272)
print v(xbgr.mr_n83872384)
print v(xbgr.mr_n83872704)
print v(xbgr.mr_n83872816)
print v(xbgr.mr_n83873136)
print v(xbgr.mr_n83873248)
print v(xbgr.mr_n83873568)
print v(xbgr.mr_n83873680)
print v(xbgr.mr_n83874000)
print v(xbgr.mr_n83874112)
print v(xbgr.mr_n83874432)
print v(xbgr.mr_n83874544)
print v(xbgr.mr_n83874864)
print v(xbgr.mr_n83874976)
print v(xbgr.mr_n83875296)
print v(xbgr.mr_n83875408)
print v(xbgr.mr_n83875728)
print v(xbgr.mr_n83875840)
print v(xbgr.mr_n83876160)
print v(xbgr.mr_n83876272)
print v(xbgr.mr_n83876592)
print v(xbgr.mr_n83876704)
print v(xbgr.mr_n83877024)
print v(xbgr.mr_n83877136)
print v(xbgr.mr_n83877456)
print v(xbgr.mr_n83877568)
print v(xbgr.mr_n83877888)
print v(xbgr.mr_n83878000)
print v(xbgr.mr_n83878320)
print v(xbgr.mr_n83878432)
print v(xbgr.mr_n83878752)
print v(xbgr.mr_n83878864)
print v(xbgr.mr_n83879184)
print v(xbgr.mr_n83879296)
print v(xbgr.mr_n83879616)
print v(xbgr.mr_n83879728)
print v(xbgr.mr_n83880048)
print v(xbgr.mr_n83880160)
print v(xbgr.mr_n83880480)
print v(xbgr.mr_n83880592)
print v(xbgr.mr_n83880912)
print v(xbgr.mr_n83881024)
print v(xbgr.mr_n83881344)
print v(xbgr.mr_n83881456)
print v(xbgr.mr_n83881776)
print v(xbgr.mr_n83881888)
print v(xbgr.mr_n83882208)
print v(xbgr.mr_n83882320)
print v(xbgr.mr_n83882640)
print v(xbgr.mr_n83882752)
print v(xbgr.mr_n83883072)
print v(xbgr.mr_n83883184)
print v(xbgr.mr_n83883504)
print v(xbgr.mr_n83883616)
print v(xbgr.mr_n83883936)
print v(xbgr.mr_n83884048)
print v(xbgr.mr_n83884368)
print v(xbgr.mr_n83884480)
print v(xbgr.mr_n83884800)
print v(xbgr.mr_n83884912)
print v(xbgr.mr_n83885232)
print v(xbgr.mr_n83885344)
print v(xbgr.mr_n83885664)
print v(xbgr.mr_n83885776)
print v(xbgr.mr_n83886096)
print v(xbgr.mr_n83886208)
print v(xbgr.mr_n83886528)
print v(xbgr.mr_n83886640)
print v(xbgr.mr_n83886960)
print v(xbgr.mr_n83887072)
print v(xbgr.mr_n83887392)
print v(xbgr.mr_n83887504)
print v(xbgr.mr_n83887824)
print v(xbgr.mr_n83887936)
print v(xbgr.mr_n83888256)
print v(xbgr.mr_n83888368)
print v(xbgr.mr_n83888688)
print v(xbgr.mr_n83888800)
print v(xbgr.mr_n83889120)
print v(xbgr.mr_n83889232)
print v(xbgr.mr_n83889552)
print v(xbgr.mr_n83889664)
print v(xbgr.mr_n83889984)
print v(xbgr.mr_n83890096)
print v(xbgr.mr_n83890416)
print v(xbgr.mr_n83890528)
print v(xbgr.mr_n83890848)
print v(xbgr.mr_n83890960)
print v(xbgr.mr_n83891280)
print v(xbgr.mr_n83891392)
print v(xbgr.mr_n83891712)
print v(xbgr.mr_n83891824)
print v(xbgr.mr_n83892144)
print v(xbgr.mr_n83892256)
print v(xbgr.mr_n83892576)
print v(xbgr.mr_n83892688)
print v(xbgr.mr_n83893008)
print v(xbgr.mr_n83893120)
print v(xbgr.mr_n83893440)
print v(xbgr.mr_n83893552)
print v(xbgr.mr_n83893872)
print v(xbgr.mr_n83893984)
print v(xbgr.mr_n83894304)
print v(xbgr.mr_n83894416)
print v(xbgr.mr_n83894736)
print v(xbgr.mr_n83894848)
print v(xbgr.mr_n83895168)
print v(xbgr.mr_n83895280)
print v(xbgr.mr_n83895600)
print v(xbgr.mr_n83895712)
print v(xbgr.mr_n83896032)
print v(xbgr.mr_n83896144)
print v(xbgr.mr_n83896464)
print v(xbgr.mr_n83896576)
print v(xbgr.mr_n83896896)
print v(xbgr.mr_n83897008)
print v(xbgr.mr_n83897328)
print v(xbgr.mr_n83897440)
print v(xbgr.mr_n83898304)
print v(xbgr.mr_n83898736)
print v(xbgr.mr_n83899168)
print v(xbgr.mr_n83899600)
print v(xbgr.mr_n83900032)
print v(xbgr.mr_n83900464)
print v(xbgr.mr_n83900896)
print v(xbgr.mr_n83901328)
print v(xbgr.mr_n83901760)
print v(xbgr.mr_n83902192)
print v(xbgr.mr_n83902624)
print v(xbgr.mr_n83903056)
print v(xbgr.mr_n83903488)
print v(xbgr.mr_n83903920)
print v(xbgr.mr_n83904352)
print v(xbgr.mr_n83904784)
print v(xbgr.mr_n83905216)
print v(xbgr.mr_n83905648)
print v(xbgr.mr_n83906080)
print v(xbgr.mr_n83906512)
print v(xbgr.mr_n83906944)
print v(xbgr.mr_n83907376)
print v(xbgr.mr_n83907808)
print v(xbgr.mr_n83908240)
print v(xbgr.mr_n83910400)
print v(xbgr.mr_n83910832)
print v(xbgr.mr_n83911264)
print v(xbgr.mr_n83911696)
print v(xbgr.mr_n83912128)
print v(xbgr.mr_n83912560)
print v(xbgr.mr_n83912992)
print v(xbgr.mr_n83913424)
print v(xbgr.mr_n83913856)
print v(xbgr.mr_n83914288)
print v(xbgr.mr_n83914720)
print v(xbgr.mr_n83915152)
print v(xbgr.mr_n83915584)
print v(xbgr.mr_n83916016)
print v(xbgr.mr_n83916448)
print v(xbgr.mr_n83916880)
print v(xbgr.mr_n83917312)
print v(xbgr.mr_n83917744)
print v(xbgr.mr_n83918176)
print v(xbgr.mr_n83918608)
print v(xbgr.mr_n83919040)
print v(xbgr.mr_n83919472)
print v(xbgr.mr_n83919904)
print v(xbgr.mr_n83920336)
print v(xbgr.mr_n83924224)
print v(xbgr.mr_n83924656)
print v(xbgr.mr_n83925088)
print v(xbgr.mr_n83925520)
print v(xbgr.mr_n83925952)
print v(xbgr.mr_n83926384)
print v(xbgr.mr_n83926816)
print v(xbgr.mr_n83927248)
print v(xbgr.mr_n83927680)
print v(xbgr.mr_n83928112)
print v(xbgr.mr_n83928544)
print v(xbgr.mr_n83928976)
print v(xbgr.mr_n83929408)
print v(xbgr.mr_n83929840)
print v(xbgr.mr_n83930272)
print v(xbgr.mr_n83931568)
print v(xbgr.mr_n83932000)
print v(xbgr.mr_n83932432)
print v(xbgr.mr_n83932864)
print v(xbgr.mr_n83933296)
print v(xbgr.mr_n83933728)
print v(xbgr.mr_n83934160)
print v(xbgr.mr_n83934592)
print v(xbgr.mr_n83935024)
print v(xbgr.mr_n83935456)
print v(xbgr.mr_n83936752)
print v(xbgr.mr_n83937184)
print v(xbgr.mr_n83937616)
print v(xbgr.mr_n83938048)
print v(xbgr.mr_n83938480)
print v(xbgr.mr_n83938912)
print v(xbgr.mr_n83939344)
print v(xbgr.mr_n83939776)
print v(xbgr.mr_n83940096)
print v(xbgr.mr_n83940208)
print v(xbgr.mr_n83940528)
print v(xbgr.mr_n83940640)
print v(xbgr.mr_n83940960)
print v(xbgr.mr_n83941072)
print v(xbgr.mr_n83941392)
print v(xbgr.mr_n83941504)
print v(xbgr.mr_n83941824)
print v(xbgr.mr_n83941936)
print v(xbgr.mr_n83942256)
print v(xbgr.mr_n83942368)
print v(xbgr.mr_n83942688)
print v(xbgr.mr_n83942800)
print v(xbgr.mr_n83943120)
print v(xbgr.mr_n83943232)
print v(xbgr.mr_n83943552)
print v(xbgr.mr_n83943664)
print v(xbgr.mr_n83943984)
print v(xbgr.mr_n83944096)
print v(xbgr.mr_n83944416)
print v(xbgr.mr_n83944528)
print v(xbgr.mr_n83944848)
print v(xbgr.mr_n83944960)
print v(xbgr.mr_n83945280)
print v(xbgr.mr_n83945392)
print v(xbgr.mr_n83945712)
print v(xbgr.mr_n83945824)
print v(xbgr.mr_n83946144)
print v(xbgr.mr_n83946256)
print v(xbgr.mr_n83946576)
print v(xbgr.mr_n83946688)
print v(xbgr.mr_n83947008)
print v(xbgr.mr_n83947120)
print v(xbgr.mr_n83947440)
print v(xbgr.mr_n83947552)
print v(xbgr.mr_n83947872)
print v(xbgr.mr_n83947984)
print v(xbgr.mr_n83948304)
print v(xbgr.mr_n83948416)
print v(xbgr.mr_n83948736)
print v(xbgr.mr_n83948848)
print v(xbgr.mr_n83949168)
print v(xbgr.mr_n83949280)
print v(xbgr.mr_n83949600)
print v(xbgr.mr_n83949712)
print v(xbgr.mr_n83950032)
print v(xbgr.mr_n83950144)
print v(xbgr.mr_n83950464)
print v(xbgr.mr_n83950576)
print v(xbgr.mr_n83950896)
print v(xbgr.mr_n83951008)
print v(xbgr.mr_n83951328)
print v(xbgr.mr_n83951440)
print v(xbgr.mr_n83951760)
print v(xbgr.mr_n83951872)
print v(xbgr.mr_n83952192)
print v(xbgr.mr_n83952304)
print v(xbgr.mr_n83952624)
print v(xbgr.mr_n83952736)
print v(xbgr.mr_n83953056)
print v(xbgr.mr_n83953168)
print v(xbgr.mr_n83953488)
print v(xbgr.mr_n83953600)
print v(xbgr.mr_n83953920)
print v(xbgr.mr_n83954032)
print v(xbgr.mr_n83954352)
print v(xbgr.mr_n83954464)
print v(xbgr.mr_n83954784)
print v(xbgr.mr_n83954896)
print v(xbgr.mr_n83955216)
print v(xbgr.mr_n83955328)
print v(xbgr.mr_n83955648)
print v(xbgr.mr_n83955760)
print v(xbgr.mr_n83956080)
print v(xbgr.mr_n83956192)
print v(xbgr.mr_n83956512)
print v(xbgr.mr_n83956624)
print v(xbgr.mr_n83956944)
print v(xbgr.mr_n83957056)
print v(xbgr.mr_n83957376)
print v(xbgr.mr_n83957488)
print v(xbgr.mr_n83957808)
print v(xbgr.mr_n83957920)
print v(xbgr.mr_n83958240)
print v(xbgr.mr_n83958352)
print v(xbgr.mr_n83958672)
print v(xbgr.mr_n83958784)
print v(xbgr.mr_n83959104)
print v(xbgr.mr_n83959216)
print v(xbgr.mr_n83959536)
print v(xbgr.mr_n83959648)
print v(xbgr.mr_n83959968)
print v(xbgr.mr_n83960080)
print v(xbgr.mr_n83960400)
print v(xbgr.mr_n83960512)
print v(xbgr.mr_n83960832)
print v(xbgr.mr_n83960944)
print v(xbgr.mr_n83961264)
print v(xbgr.mr_n83961376)
print v(xbgr.mr_n83961696)
print v(xbgr.mr_n83961808)
print v(xbgr.mr_n83962128)
print v(xbgr.mr_n83962240)
print v(xbgr.mr_n83962560)
print v(xbgr.mr_n83962672)
print v(xbgr.mr_n83962992)
print v(xbgr.mr_n83963104)
print v(xbgr.mr_n83963424)
print v(xbgr.mr_n83963536)
print v(xbgr.mr_n83963856)
print v(xbgr.mr_n83963968)
print v(xbgr.mr_n83964288)
print v(xbgr.mr_n83964400)
print v(xbgr.mr_n83964720)
print v(xbgr.mr_n83964832)
print v(xbgr.mr_n83965152)
print v(xbgr.mr_n83965264)
print v(xbgr.mr_n83965584)
print v(xbgr.mr_n83965696)
print v(xbgr.mr_n83966016)
print v(xbgr.mr_n83966128)
print v(xbgr.mr_n83966448)
print v(xbgr.mr_n83966560)
print v(xbgr.mr_n83966880)
print v(xbgr.mr_n83966992)
print v(xbgr.mr_n83967312)
print v(xbgr.mr_n83967424)
print v(xbgr.mr_n83967744)
print v(xbgr.mr_n83967856)
print v(xbgr.mr_n83968176)
print v(xbgr.mr_n83968288)
print v(xbgr.mr_n83968608)
print v(xbgr.mr_n83968720)
print v(xbgr.mr_n83969040)
print v(xbgr.mr_n83969152)
print v(xbgr.mr_n83969472)
print v(xbgr.mr_n83969584)
print v(xbgr.mr_n83969904)
print v(xbgr.mr_n83970016)
print v(xbgr.mr_n83970336)
print v(xbgr.mr_n83970448)
print v(xbgr.mr_n83970768)
print v(xbgr.mr_n83970880)
print v(xbgr.mr_n83971200)
print v(xbgr.mr_n83971312)
print v(xbgr.mr_n83971632)
print v(xbgr.mr_n83971744)
print v(xbgr.mr_n83972064)
print v(xbgr.mr_n83972176)
print v(xbgr.mr_n83972496)
print v(xbgr.mr_n83972608)
print v(xbgr.mr_n83972928)
print v(xbgr.mr_n83973040)
print v(xbgr.mr_n83973360)
print v(xbgr.mr_n83973472)
print v(xbgr.mr_n83973792)
print v(xbgr.mr_n83973904)
print v(xbgr.mr_n83974224)
print v(xbgr.mr_n83974336)
print v(xbgr.mr_n83974656)
print v(xbgr.mr_n83974768)
print v(xbgr.mr_n83975088)
print v(xbgr.mr_n83975200)
print v(xbgr.mr_n83975520)
print v(xbgr.mr_n83975632)
print v(xbgr.mr_n83975952)
print v(xbgr.mr_n83976064)
print v(xbgr.mr_n83976384)
print v(xbgr.mr_n83976496)
print v(xbgr.mr_n83976816)
print v(xbgr.mr_n83976928)
print v(xbgr.mr_n83977248)
print v(xbgr.mr_n83977360)
print v(xbgr.mr_n83977680)
print v(xbgr.mr_n83977792)
print v(xbgr.mr_n83978112)
print v(xbgr.mr_n83978224)
print v(xbgr.mr_n83978544)
print v(xbgr.mr_n83978656)
print v(xbgr.mr_n83978976)
print v(xbgr.mr_n83979088)
print v(xbgr.mr_n83979408)
print v(xbgr.mr_n83979520)
print v(xbgr.mr_n83979840)
print v(xbgr.mr_n83979952)
print v(xbgr.mr_n83980272)
print v(xbgr.mr_n83980384)
print v(xbgr.mr_n83980704)
print v(xbgr.mr_n83980816)
print v(xbgr.mr_n83981136)
print v(xbgr.mr_n83981248)
print v(xbgr.mr_n83981568)
print v(xbgr.mr_n83981680)
print v(xbgr.mr_n83982000)
print v(xbgr.mr_n83982112)
print v(xbgr.mr_n83982432)
print v(xbgr.mr_n83982544)
print v(xbgr.mr_n83982864)
print v(xbgr.mr_n83982976)
print v(xbgr.mr_n83983296)
print v(xbgr.mr_n83983408)
print v(xbgr.mr_n83983728)
print v(xbgr.mr_n83983840)
print v(xbgr.mr_n83984160)
print v(xbgr.mr_n83984272)
print v(xbgr.mr_n83984592)
print v(xbgr.mr_n83984704)
print v(xbgr.mr_n83985024)
print v(xbgr.mr_n83985136)
print v(xbgr.mr_n83985456)
print v(xbgr.mr_n83985568)
print v(xbgr.mr_n83985888)
print v(xbgr.mr_n83986000)
print v(xbgr.mr_n83986320)
print v(xbgr.mr_n83986432)
print v(xbgr.mr_n83986752)
print v(xbgr.mr_n83987184)
print v(xbgr.mr_n83987296)
print v(xbgr.mr_n83987616)
print v(xbgr.mr_n83987728)
print v(xbgr.mr_n83988048)
print v(xbgr.mr_n83988160)
print v(xbgr.mr_n83988480)
print v(xbgr.mr_n83988592)
print v(xbgr.mr_n83988912)
print v(xbgr.mr_n83989024)
print v(xbgr.mr_n83989344)
print v(xbgr.mr_n83989456)
print v(xbgr.mr_n83989776)
print v(xbgr.mr_n83989888)
print v(xbgr.mr_n83990208)
print v(xbgr.mr_n83990320)
print v(xbgr.mr_n83990640)
print v(xbgr.mr_n83990752)
print v(xbgr.mr_n83991072)
print v(xbgr.mr_n83991184)
print v(xbgr.mr_n83991504)
print v(xbgr.mr_n83991616)
print v(xbgr.mr_n83991936)
print v(xbgr.mr_n83992048)
print v(xbgr.mr_n83992368)
print v(xbgr.mr_n83992480)
print v(xbgr.mr_n83992800)
print v(xbgr.mr_n83992912)
print v(xbgr.mr_n83993232)
print v(xbgr.mr_n83993344)
print v(xbgr.mr_n83993664)
print v(xbgr.mr_n83993776)
print v(xbgr.mr_n83994096)
print v(xbgr.mr_n83994208)
print v(xbgr.mr_n83994528)
print v(xbgr.mr_n83994640)
print v(xbgr.mr_n83994960)
print v(xbgr.mr_n83995072)
print v(xbgr.mr_n83995392)
print v(xbgr.mr_n83995504)
print v(xbgr.mr_n83995824)
print v(xbgr.mr_n83995936)
print v(xbgr.mr_n83996256)
print v(xbgr.mr_n83996368)
print v(xbgr.mr_n83996688)
print v(xbgr.mr_n83996800)
print v(xbgr.mr_n83997120)
print v(xbgr.mr_n83997232)
print v(xbgr.mr_n83997552)
print v(xbgr.mr_n83997664)
print v(xbgr.mr_n83997984)
print v(xbgr.mr_n83998096)
print v(xbgr.mr_n83998416)
print v(xbgr.mr_n83998528)
print v(xbgr.mr_n83998848)
print v(xbgr.mr_n83998960)
print v(xbgr.mr_n83999280)
print v(xbgr.mr_n83999392)
print v(xbgr.mr_n83999712)
print v(xbgr.mr_n83999824)
print v(xbgr.mr_n84000144)
print v(xbgr.mr_n84000256)
print v(xbgr.mr_n84000576)
print v(xbgr.mr_n84000688)
print v(xbgr.mr_n84001008)
print v(xbgr.mr_n84001120)
print v(xbgr.mr_n84001440)
print v(xbgr.mr_n84001552)
print v(xbgr.mr_n84001872)
print v(xbgr.mr_n84001984)
print v(xbgr.mr_n84002304)
print v(xbgr.mr_n84002736)
print v(xbgr.mr_n84002848)
print v(xbgr.mr_n84003168)
print v(xbgr.mr_n84003280)
print v(xbgr.mr_n84003600)
print v(xbgr.mr_n84003712)
print v(xbgr.mr_n84004032)
print v(xbgr.mr_n84004464)
print v(xbgr.mr_n84004576)
print v(xbgr.mr_n84004896)
print v(xbgr.mr_n84005008)
print v(xbgr.mr_n84005328)
print v(xbgr.mr_n84005440)
print v(xbgr.mr_n84005760)
print v(xbgr.mr_n84006192)
print v(xbgr.mr_n84006304)
print v(xbgr.mr_n84006624)
print v(xbgr.mr_n84006736)
print v(xbgr.mr_n84007056)
print v(xbgr.mr_n84007168)
print v(xbgr.mr_n84007488)
print v(xbgr.mr_n84007600)
print v(xbgr.mr_n84007920)
print v(xbgr.mr_n84008032)
print v(xbgr.mr_n84008352)
print v(xbgr.mr_n84008464)
print v(xbgr.mr_n84008784)
print v(xbgr.mr_n84008896)
print v(xbgr.mr_n84009216)
print v(xbgr.mr_n84009328)
print v(xbgr.mr_n84009648)
print v(xbgr.mr_n84009760)
print v(xbgr.mr_n84010080)
print v(xbgr.mr_n84010192)
print v(xbgr.mr_n84010512)
print v(xbgr.mr_n84010624)
print v(xbgr.mr_n84010944)
print v(xbgr.mr_n84011056)
print v(xbgr.mr_n84011376)
print v(xbgr.mr_n84011488)
print v(xbgr.mr_n84011808)
print v(xbgr.mr_n84011920)
print v(xbgr.mr_n84012240)
print v(xbgr.mr_n84012352)
print v(xbgr.mr_n84012672)
print v(xbgr.mr_n84012784)
print v(xbgr.mr_n84013104)
print v(xbgr.mr_n84013536)
print v(xbgr.mr_n84013648)
print v(xbgr.mr_n84013968)
print v(xbgr.mr_n84014080)
print v(xbgr.mr_n84014400)
print v(xbgr.mr_n84014512)
print v(xbgr.mr_n84014832)
print v(xbgr.mr_n84014944)
print v(xbgr.mr_n84015264)
print v(xbgr.mr_n84015376)
print v(xbgr.mr_n84015696)
print v(xbgr.mr_n84015808)
print v(xbgr.mr_n84016128)
print v(xbgr.mr_n84016240)
print v(xbgr.mr_n84016560)
print v(xbgr.mr_n84016672)
print v(xbgr.mr_n84016992)
print v(xbgr.mr_n84017104)
print v(xbgr.mr_n84017424)
print v(xbgr.mr_n84017536)
print v(xbgr.mr_n84017856)
print v(xbgr.mr_n84018288)
print v(xbgr.mr_n84018400)
print v(xbgr.mr_n84018720)
print v(xbgr.mr_n84019152)
print v(xbgr.mr_n84019264)
print v(xbgr.mr_n84019584)
print v(xbgr.mr_n84019696)
print v(xbgr.mr_n84020016)
print v(xbgr.mr_n84020128)
print v(xbgr.mr_n84020448)
print v(xbgr.mr_n84020560)
print v(xbgr.mr_n84020880)
print v(xbgr.mr_n84020992)
print v(xbgr.mr_n84021312)
print v(xbgr.mr_n84021744)
print v(xbgr.mr_n84021856)
print v(xbgr.mr_n84022176)
print v(xbgr.mr_n84022288)
print v(xbgr.mr_n84022608)
print v(xbgr.mr_n84022720)
print v(xbgr.mr_n84026496)
print v(xbgr.mr_n84026608)
print v(xbgr.mr_n84026944)
print v(xbgr.mr_n84027056)
print v(xbgr.mr_n84027376)
print v(xbgr.mr_n84027488)
print v(xbgr.mr_n84027856)
print v(xbgr.mr_n84027968)
print v(xbgr.mr_n84028288)
print v(xbgr.mr_n84028400)
print v(xbgr.mr_n84028720)
print v(xbgr.mr_n84029072)
print v(xbgr.mr_n84029184)
print v(xbgr.mr_n84029504)
print v(xbgr.mr_n84029936)
print v(xbgr.mr_n84030048)
print v(xbgr.mr_n84030368)
print v(xbgr.mr_n84030480)
print v(xbgr.mr_n84030800)
print v(xbgr.mr_n84030912)
print v(xbgr.mr_n84031232)
print v(xbgr.mr_n84031344)
print v(xbgr.mr_n84031664)
print v(xbgr.mr_n84031776)
print v(xbgr.mr_n84032096)
print v(xbgr.mr_n84032528)
print v(xbgr.mr_n84032640)
print v(xbgr.mr_n84032960)
print v(xbgr.mr_n84033392)
print v(xbgr.mr_n84033504)
print v(xbgr.mr_n84033824)
print v(xbgr.mr_n84033936)
print v(xbgr.mr_n84034256)
print v(xbgr.mr_n84034368)
print v(xbgr.mr_n84034688)
print v(xbgr.mr_n84034800)
print v(xbgr.mr_n84035120)
print v(xbgr.mr_n84035232)
print v(xbgr.mr_n84035552)
print v(xbgr.mr_n84035664)
print v(xbgr.mr_n84035984)
print v(xbgr.mr_n84036096)
print v(xbgr.mr_n84036416)
print v(xbgr.mr_n84036848)
print v(xbgr.mr_n84036960)
print v(xbgr.mr_n84037280)
print v(xbgr.mr_n84037392)
print v(xbgr.mr_n84037712)
print v(xbgr.mr_n84037824)
print v(xbgr.mr_n84038144)
print v(xbgr.mr_n84038256)
print v(xbgr.mr_n84038576)
print v(xbgr.mr_n84038688)
print v(xbgr.mr_n84039008)
print v(xbgr.mr_n84039120)
print v(xbgr.mr_n84039440)
print v(xbgr.mr_n84039552)
print v(xbgr.mr_n84039872)
print v(xbgr.mr_n84040304)
print v(xbgr.mr_n84040416)
print v(xbgr.mr_n84040736)
print v(xbgr.mr_n84041168)
print v(xbgr.mr_n84041280)
print v(xbgr.mr_n84041600)
print v(xbgr.mr_n84041712)
print v(xbgr.mr_n84042032)
print v(xbgr.mr_n84042144)
print v(xbgr.mr_n84042464)
print v(xbgr.mr_n84042576)
print v(xbgr.mr_n84042896)
print v(xbgr.mr_n84043008)
print v(xbgr.mr_n84043328)
print v(xbgr.mr_n84043440)
print v(xbgr.mr_n84043760)
print v(xbgr.mr_n84043872)
print v(xbgr.mr_n84044192)
print v(xbgr.mr_n84044624)
print v(xbgr.mr_n84044736)
print v(xbgr.mr_n84045056)
print v(xbgr.mr_n84045168)
print v(xbgr.mr_n84045488)
print v(xbgr.mr_n84045600)
print v(xbgr.mr_n84045920)
print v(xbgr.mr_n84046352)
print v(xbgr.mr_n84046464)
print v(xbgr.mr_n84046784)
print v(xbgr.mr_n84046896)
print v(xbgr.mr_n84047216)
print v(xbgr.mr_n84047328)
print v(xbgr.mr_n84047648)
print v(xbgr.mr_n84047760)
print v(xbgr.mr_n84048080)
print v(xbgr.mr_n84048192)
print v(xbgr.mr_n84048512)
print v(xbgr.mr_n84048624)
print v(xbgr.mr_n84048944)
print v(xbgr.mr_n84049056)
print v(xbgr.mr_n84049376)
print v(xbgr.mr_n84049808)
print v(xbgr.mr_n84049920)
print v(xbgr.mr_n84050240)
print v(xbgr.mr_n84050352)
print v(xbgr.mr_n84050672)
print v(xbgr.mr_n84050784)
print v(xbgr.mr_n84051104)
print v(xbgr.mr_n84051536)
print v(xbgr.mr_n84051648)
print v(xbgr.mr_n84051968)
print v(xbgr.mr_n84052080)
print v(xbgr.mr_n84052400)
print v(xbgr.mr_n84052512)
print v(xbgr.mr_n84052832)
print v(xbgr.mr_n84052944)
print v(xbgr.mr_n84053264)
print v(xbgr.mr_n84053376)
print v(xbgr.mr_n84053696)
print v(xbgr.mr_n84053808)
print v(xbgr.mr_n84054128)
print v(xbgr.mr_n84054240)
print v(xbgr.mr_n84054560)
print v(xbgr.mr_n84054672)
print v(xbgr.mr_n84054992)
print v(xbgr.mr_n84055104)
print v(xbgr.mr_n84055424)
print v(xbgr.mr_n84055856)
print v(xbgr.mr_n84055968)
print v(xbgr.mr_n84056288)
print v(xbgr.mr_n84056400)
print v(xbgr.mr_n84056624)
print v(xbgr.mr_n84056992)
print v(xbgr.mr_n84057104)
print v(xbgr.mr_n84057360)
print v(xbgr.mr_n84057472)
print v(xbgr.mr_n84057728)
print v(xbgr.mr_n84057840)
print v(xbgr.mr_n84058096)
print v(xbgr.mr_n84058208)
print v(xbgr.mr_n84058464)
print v(xbgr.mr_n84058576)
print v(xbgr.mr_n84058832)
print v(xbgr.mr_n84059200)
print v(xbgr.mr_n84059312)
print v(xbgr.mr_n84059568)
print v(xbgr.mr_n84059936)
print v(xbgr.mr_n84060048)
print v(xbgr.mr_n84060304)
print v(xbgr.mr_n84060672)
print v(xbgr.mr_n84060784)
print v(xbgr.mr_n84061040)
print v(xbgr.mr_n84061152)
print v(xbgr.mr_n84061408)
print v(xbgr.mr_n84061520)
print v(xbgr.mr_n84061776)
print v(xbgr.mr_n84062144)
print v(xbgr.mr_n84062256)
print v(xbgr.mr_n84062512)
print v(xbgr.mr_n84062880)
print v(xbgr.mr_n84062992)
print v(xbgr.mr_n84063248)
print v(xbgr.mr_n84063616)
print v(xbgr.mr_n84063728)
print v(xbgr.mr_n84063984)
print v(xbgr.mr_n84064096)
print v(xbgr.mr_n84064352)
print v(xbgr.mr_n84064464)
print v(xbgr.mr_n84064720)
print v(xbgr.mr_n84064832)
print v(xbgr.mr_n84065088)
print v(xbgr.mr_n84065200)
print v(xbgr.mr_n84065456)
print v(xbgr.mr_n84065824)
print v(xbgr.mr_n84065936)
print v(xbgr.mr_n84066192)
print v(xbgr.mr_n84066304)
print v(xbgr.mr_n84066560)
print v(xbgr.mr_n84066672)
print v(xbgr.mr_n84066928)
print v(xbgr.mr_n84067040)
print v(xbgr.mr_n84067296)
print v(xbgr.mr_n84067408)
print v(xbgr.mr_n84067664)
print v(xbgr.mr_n84068096)
print v(xbgr.mr_n84068208)
print v(xbgr.mr_n84068528)
print v(xbgr.mr_n84068960)
print v(xbgr.mr_n84069072)
print v(xbgr.mr_n84069392)
print v(xbgr.mr_n84069504)
print v(xbgr.mr_n84069824)
print v(xbgr.mr_n84069936)
print v(xbgr.mr_n84070256)
print v(xbgr.mr_n84070688)
print v(xbgr.mr_n84070800)
print v(xbgr.mr_n84071120)
print v(xbgr.mr_n84071552)
print v(xbgr.mr_n84071664)
print v(xbgr.mr_n84071984)
print v(xbgr.mr_n84072096)
print v(xbgr.mr_n84072416)
print v(xbgr.mr_n84072528)
print v(xbgr.mr_n84072848)
print v(xbgr.mr_n84072960)
print v(xbgr.mr_n84073280)
print v(xbgr.mr_n84073392)
print v(xbgr.mr_n84073712)
print v(xbgr.mr_n84073824)
print v(xbgr.mr_n84074144)
print v(xbgr.mr_n84074256)
print v(xbgr.mr_n84074576)
print v(xbgr.mr_n84075008)
print v(xbgr.mr_n84075120)
print v(xbgr.mr_n84075440)
print v(xbgr.mr_n84075552)
print v(xbgr.mr_n84075872)
print v(xbgr.mr_n84075984)
print v(xbgr.mr_n84076304)
print v(xbgr.mr_n84076416)
print v(xbgr.mr_n84076736)
print v(xbgr.mr_n84076848)
print v(xbgr.mr_n84077168)
print v(xbgr.mr_n84077600)
print v(xbgr.mr_n84077712)
print v(xbgr.mr_n84078032)
print v(xbgr.mr_n84078464)
print v(xbgr.mr_n84078576)
print v(xbgr.mr_n84078896)
print v(xbgr.mr_n84079008)
print v(xbgr.mr_n84079328)
print v(xbgr.mr_n84079440)
print v(xbgr.mr_n84079760)
print v(xbgr.mr_n84079872)
print v(xbgr.mr_n84080192)
print v(xbgr.mr_n84080304)
print v(xbgr.mr_n84080624)
print v(xbgr.mr_n84080736)
print v(xbgr.mr_n84081056)
print v(xbgr.mr_n84081168)
print v(xbgr.mr_n84081488)
print v(xbgr.mr_n84081600)
print v(xbgr.mr_n84081920)
print v(xbgr.mr_n84082464)
print v(xbgr.mr_n84082896)
print v(xbgr.mr_n84083328)
print v(xbgr.mr_n84083760)
print v(xbgr.mr_n84084192)
print v(xbgr.mr_n84084624)
print v(xbgr.mr_n84085056)
print v(xbgr.mr_n84085488)
print v(xbgr.mr_n84085920)
print v(xbgr.mr_n84086352)
print v(xbgr.mr_n84086672)
print v(xbgr.mr_n84087104)
print v(xbgr.mr_n84087536)
print v(xbgr.mr_n84087968)
print v(xbgr.mr_n84088400)
print v(xbgr.mr_n84088832)
print v(xbgr.mr_n84089264)
print v(xbgr.mr_n84089696)
print v(xbgr.mr_n84090128)
print v(xbgr.mr_n84090560)
print v(xbgr.mr_n84090992)
print v(xbgr.mr_n84091424)
print v(xbgr.mr_n84091856)
print v(xbgr.mr_n84092288)
print v(xbgr.mr_n84092720)
print v(xbgr.mr_n84093152)
print v(xbgr.mr_n84093584)
print v(xbgr.mr_n84094016)
print v(xbgr.mr_n84094448)
print v(xbgr.mr_n84094880)
print v(xbgr.mr_n84095312)
print v(xbgr.mr_n84095744)
print v(xbgr.mr_n84096176)
print v(xbgr.mr_n84096608)
print v(xbgr.mr_n84097040)
print v(xbgr.mr_n84097472)
print v(xbgr.mr_n84097904)
print v(xbgr.mr_n84098336)
print v(xbgr.mr_n84098768)
print v(xbgr.mr_n84099200)
print v(xbgr.mr_n84099632)
print v(xbgr.mr_n84100064)
print v(xbgr.mr_n84100496)
print v(xbgr.mr_n84100928)
print v(xbgr.mr_n84101360)
print v(xbgr.mr_n84101792)
print v(xbgr.mr_n84102224)
print v(xbgr.mr_n84102656)
print v(xbgr.mr_n84103088)
print v(xbgr.mr_n84103520)
print v(xbgr.mr_n84103952)
print v(xbgr.mr_n84104384)
print v(xbgr.mr_n84104816)
print v(xbgr.mr_n84105248)
print v(xbgr.mr_n84105680)
print v(xbgr.mr_n84106112)
print v(xbgr.mr_n84106544)
print v(xbgr.mr_n84106976)
print v(xbgr.mr_n84108272)
print v(xbgr.mr_n84108704)
print v(xbgr.mr_n84109136)
print v(xbgr.mr_n84109568)
print v(xbgr.mr_n84110000)
print v(xbgr.mr_n84110432)
print v(xbgr.mr_n84110864)
print v(xbgr.mr_n84111296)
print v(xbgr.mr_n84111728)
print v(xbgr.mr_n84112160)
print v(xbgr.mr_n84112592)
print v(xbgr.mr_n84113024)
print v(xbgr.mr_n84115184)
print v(xbgr.mr_n84115616)
print v(xbgr.mr_n84116048)
print v(xbgr.mr_n84116480)
print v(xbgr.mr_n84116912)
print v(xbgr.mr_n84117344)
print v(xbgr.mr_n84117776)
print v(xbgr.mr_n84118208)
print v(xbgr.mr_n84118640)
print v(xbgr.mr_n84119072)
print v(xbgr.mr_n84120368)
print v(xbgr.mr_n84120800)
print v(xbgr.mr_n84121232)
print v(xbgr.mr_n84121664)
print v(xbgr.mr_n84122096)
print v(xbgr.mr_n84122528)
print v(xbgr.mr_n84122960)
print v(xbgr.mr_n84123392)
print v(xbgr.mr_n84123824)
print v(xbgr.mr_n84124256)
print v(xbgr.mr_n84124688)
print v(xbgr.mr_n84125120)
print v(xbgr.mr_n84126416)
print v(xbgr.mr_n84126848)
print v(xbgr.mr_n84128144)
print v(xbgr.mr_n84128576)
print v(xbgr.mr_n84129008)
print v(xbgr.mr_n84129440)
print v(xbgr.mr_n84129872)
print v(xbgr.mr_n84130304)
print v(xbgr.mr_n84130736)
print v(xbgr.mr_n84131168)
print v(xbgr.mr_n84132464)
print v(xbgr.mr_n84132896)
print v(xbgr.mr_n84133216)
print v(xbgr.mr_n84133328)
print v(xbgr.mr_n84133648)
print v(xbgr.mr_n84133760)
print v(xbgr.mr_n84134080)
print v(xbgr.mr_n84134192)
print v(xbgr.mr_n84134512)
print v(xbgr.mr_n84134624)
print v(xbgr.mr_n84134944)
print v(xbgr.mr_n84135056)
print v(xbgr.mr_n84135376)
print v(xbgr.mr_n84135488)
print v(xbgr.mr_n84135808)
print v(xbgr.mr_n84135920)
print v(xbgr.mr_n84136240)
print v(xbgr.mr_n84136352)
print v(xbgr.mr_n84136784)
print v(xbgr.mr_n84137216)
print v(xbgr.mr_n84137648)
print v(xbgr.mr_n84138080)
print v(xbgr.mr_n84138512)
print v(xbgr.mr_n84138944)
print v(xbgr.mr_n84139376)
print v(xbgr.mr_n84139808)
print v(xbgr.mr_n84140240)
print v(xbgr.mr_n84140672)
print v(xbgr.mr_n84141104)
print v(xbgr.mr_n84141536)
print v(xbgr.mr_n84141968)
print v(xbgr.mr_n84142400)
print v(xbgr.mr_n84142832)
print v(xbgr.mr_n84143264)
print v(xbgr.mr_n84143696)
print v(xbgr.mr_n84144128)
print v(xbgr.mr_n84144560)
print v(xbgr.mr_n84144992)
print v(xbgr.mr_n84145424)
print v(xbgr.mr_n84145856)
print v(xbgr.mr_n84146288)
print v(xbgr.mr_n84146720)
print v(xbgr.mr_n84147152)
print v(xbgr.mr_n84147584)
print v(xbgr.mr_n84148224)
print v(xbgr.mr_n84148656)
print v(xbgr.mr_n84149088)
print v(xbgr.mr_n84149520)
print v(xbgr.mr_n84149952)
print v(xbgr.mr_n84150384)
print v(xbgr.mr_n84150816)
print v(xbgr.mr_n84151248)
print v(xbgr.mr_n84151680)
print v(xbgr.mr_n84152112)
print v(xbgr.mr_n84152544)
print v(xbgr.mr_n84152976)
print v(xbgr.mr_n84153408)
print v(xbgr.mr_n84153840)
print v(xbgr.mr_n84154272)
print v(xbgr.mr_n84154704)
print v(xbgr.mr_n84155136)
print v(xbgr.mr_n84155568)
print v(xbgr.mr_n84156000)
print v(xbgr.mr_n84156432)
print v(xbgr.mr_n84156864)
print v(xbgr.mr_n84157296)
print v(xbgr.mr_n84157728)
print v(xbgr.mr_n84158160)
print v(xbgr.mr_n84158592)
print v(xbgr.mr_n84159024)
print v(xbgr.mr_n84159456)
print v(xbgr.mr_n84159888)
print v(xbgr.mr_n84160320)
print v(xbgr.mr_n84160752)
print v(xbgr.mr_n84161184)
print v(xbgr.mr_n84161616)
print v(xbgr.mr_n84162048)
print v(xbgr.mr_n84162480)
print v(xbgr.mr_n84162912)
print v(xbgr.mr_n84163344)
print v(xbgr.mr_n84163776)
print v(xbgr.mr_n84164208)
print v(xbgr.mr_n84164640)
print v(xbgr.mr_n84165072)
print v(xbgr.mr_n84165504)
print v(xbgr.mr_n84165936)
print v(xbgr.mr_n84166368)
print v(xbgr.mr_n84166800)
print v(xbgr.mr_n84167232)
print v(xbgr.mr_n84167664)
print v(xbgr.mr_n84168096)
print v(xbgr.mr_n84168528)
print v(xbgr.mr_n84168960)
print v(xbgr.mr_n84169392)
print v(xbgr.mr_n84169824)
print v(xbgr.mr_n84170256)
print v(xbgr.mr_n84170688)
print v(xbgr.mr_n84171120)
print v(xbgr.mr_n84171552)
print v(xbgr.mr_n84171984)
print v(xbgr.mr_n84172416)
print v(xbgr.mr_n84172848)
print v(xbgr.mr_n84173280)
print v(xbgr.mr_n84173712)
print v(xbgr.mr_n84174144)
print v(xbgr.mr_n84174576)
print v(xbgr.mr_n84175008)
print v(xbgr.mr_n84175440)
print v(xbgr.mr_n84175872)
print v(xbgr.mr_n84176304)
print v(xbgr.mr_n84176736)
print v(xbgr.mr_n84177168)
print v(xbgr.mr_n84177600)
print v(xbgr.mr_n84178032)
print v(xbgr.mr_n84178464)
print v(xbgr.mr_n84178896)
print v(xbgr.mr_n84179328)
print v(xbgr.mr_n84179760)
print v(xbgr.mr_n84180192)
print v(xbgr.mr_n84180624)
print v(xbgr.mr_n84181056)
print v(xbgr.mr_n84181488)
print v(xbgr.mr_n84181920)
print v(xbgr.mr_n84182352)
print v(xbgr.mr_n84182784)
print v(xbgr.mr_n84183216)
print v(xbgr.mr_n84183648)
print v(xbgr.mr_n84184080)
print v(xbgr.mr_n84184512)
print v(xbgr.mr_n84184832)
print v(xbgr.mr_n84184944)
print v(xbgr.mr_n84185264)
print v(xbgr.mr_n84185376)
print v(xbgr.mr_n84185696)
print v(xbgr.mr_n84185808)
print v(xbgr.mr_n84186128)
print v(xbgr.mr_n84186240)
print v(xbgr.mr_n84186672)
print v(xbgr.mr_n84187104)
print v(xbgr.mr_n84187536)
print v(xbgr.mr_n84187968)
print v(xbgr.mr_n84188400)
print v(xbgr.mr_n84188832)
print v(xbgr.mr_n84189264)
print v(xbgr.mr_n84189696)
print v(xbgr.mr_n84190128)
print v(xbgr.mr_n84190560)
print v(xbgr.mr_n84190992)
print v(xbgr.mr_n84191424)
print v(xbgr.mr_n84191856)
print v(xbgr.mr_n84192288)
print v(xbgr.mr_n84192720)
print v(xbgr.mr_n84193152)
print v(xbgr.mr_n84193584)
print v(xbgr.mr_n84194016)
print v(xbgr.mr_n84194448)
print v(xbgr.mr_n84194880)
print v(xbgr.mr_n84195312)
print v(xbgr.mr_n84195744)
print v(xbgr.mr_n84196176)
print v(xbgr.mr_n84196608)
print v(xbgr.mr_n84197040)
print v(xbgr.mr_n84197472)
print v(xbgr.mr_n84197904)
print v(xbgr.mr_n84198336)
print v(xbgr.mr_n84198768)
print v(xbgr.mr_n84199200)
print v(xbgr.mr_n84199632)
print v(xbgr.mr_n84200064)
print v(xbgr.mr_n84200496)
print v(xbgr.mr_n84200928)
print v(xbgr.mr_n84201360)
print v(xbgr.mr_n84201792)
print v(xbgr.mr_n84202224)
print v(xbgr.mr_n84202656)
print v(xbgr.mr_n84203088)
print v(xbgr.mr_n84203520)
print v(xbgr.mr_n84203952)
print v(xbgr.mr_n84204384)
print v(xbgr.mr_n84204816)
print v(xbgr.mr_n84205248)
print v(xbgr.mr_n84205680)
print v(xbgr.mr_n84206112)
print v(xbgr.mr_n84206544)
print v(xbgr.mr_n84206976)
print v(xbgr.mr_n84207408)
print v(xbgr.mr_n84207840)
print v(xbgr.mr_n84208272)
print v(xbgr.mr_n84208704)
print v(xbgr.mr_n84209136)
print v(xbgr.mr_n84209568)
print v(xbgr.mr_n84210000)
print v(xbgr.mr_n84210432)
print v(xbgr.mr_n84210864)
print v(xbgr.mr_n84211296)
print v(xbgr.mr_n84211728)
print v(xbgr.mr_n84212160)
print v(xbgr.mr_n84212592)
print v(xbgr.mr_n84213024)
print v(xbgr.mr_n84213456)
print v(xbgr.mr_n84213888)
print v(xbgr.mr_n84215184)
print v(xbgr.mr_n84215616)
print v(xbgr.mr_n84216912)
print v(xbgr.mr_n84217344)
print v(xbgr.mr_n84218640)
print v(xbgr.mr_n84219072)
print v(xbgr.mr_n84219504)
print v(xbgr.mr_n84219936)
print v(xbgr.mr_n84220368)
print v(xbgr.mr_n84220800)
print v(xbgr.mr_n84221232)
print v(xbgr.mr_n84221664)
print v(xbgr.mr_n84222096)
print v(xbgr.mr_n84222528)
print v(xbgr.mr_n84222960)
print v(xbgr.mr_n84223392)
print v(xbgr.mr_n84223824)
print v(xbgr.mr_n84224256)
print v(xbgr.mr_n84224688)
print v(xbgr.mr_n84225120)
print v(xbgr.mr_n84226416)
print v(xbgr.mr_n84226848)
print v(xbgr.mr_n84227280)
print v(xbgr.mr_n84227712)
print v(xbgr.mr_n84228144)
print v(xbgr.mr_n84228576)
print v(xbgr.mr_n84229872)
print v(xbgr.mr_n84230304)
print v(xbgr.mr_n84230736)
print v(xbgr.mr_n84231168)
print v(xbgr.mr_n84231600)
print v(xbgr.mr_n84232032)
print v(xbgr.mr_n84232464)
print v(xbgr.mr_n84232896)
print v(xbgr.mr_n84233328)
print v(xbgr.mr_n84233760)
print v(xbgr.mr_n84234192)
print v(xbgr.mr_n84234624)
print v(xbgr.mr_n84235056)
print v(xbgr.mr_n84235488)
print v(xbgr.mr_n84235920)
print v(xbgr.mr_n84236352)
print v(xbgr.mr_n84236784)
print v(xbgr.mr_n84237216)
print v(xbgr.mr_n84237648)
print v(xbgr.mr_n84238080)
print v(xbgr.mr_n84238512)
print v(xbgr.mr_n84238944)
print v(xbgr.mr_n84239376)
print v(xbgr.mr_n84239808)
print v(xbgr.mr_n84240240)
print v(xbgr.mr_n84240672)
print v(xbgr.mr_n84241104)
print v(xbgr.mr_n84241536)
print v(xbgr.mr_n84241968)
print v(xbgr.mr_n84242400)
print v(xbgr.mr_n84242832)
print v(xbgr.mr_n84243264)
print v(xbgr.mr_n84243696)
print v(xbgr.mr_n84244128)
print v(xbgr.mr_n84244560)
print v(xbgr.mr_n84244992)
print v(xbgr.mr_n84245424)
print v(xbgr.mr_n84245856)
print v(xbgr.mr_n84246288)
print v(xbgr.mr_n84246720)
print v(xbgr.mr_n84247152)
print v(xbgr.mr_n84247584)
print v(xbgr.mr_n84248016)
print v(xbgr.mr_n84248448)
print v(xbgr.mr_n84248880)
print v(xbgr.mr_n84249312)
print v(xbgr.mr_n84249744)
print v(xbgr.mr_n84250176)
print v(xbgr.mr_n84250608)
print v(xbgr.mr_n84251040)
print v(xbgr.mr_n84251472)
print v(xbgr.mr_n84251904)
print v(xbgr.mr_n84252336)
print v(xbgr.mr_n84252768)
print v(xbgr.mr_n84253200)
print v(xbgr.mr_n84253632)
print v(xbgr.mr_n84254064)
print v(xbgr.mr_n84254384)
print v(xbgr.mr_n84254496)
print v(xbgr.mr_n84254816)
print v(xbgr.mr_n84254928)
print v(xbgr.mr_n84255248)
print v(xbgr.mr_n84255360)
print v(xbgr.mr_n84255680)
print v(xbgr.mr_n84255792)
print v(xbgr.mr_n84256112)
print v(xbgr.mr_n84256224)
print v(xbgr.mr_n84256544)
print v(xbgr.mr_n84256656)
print v(xbgr.mr_n84256976)
print v(xbgr.mr_n84257088)
print v(xbgr.mr_n84257408)
print v(xbgr.mr_n84257520)
print v(xbgr.mr_n84257840)
print v(xbgr.mr_n84257952)
print v(xbgr.mr_n84258272)
print v(xbgr.mr_n84258384)
print v(xbgr.mr_n84258704)
print v(xbgr.mr_n84258816)
print v(xbgr.mr_n84259136)
print v(xbgr.mr_n84259248)
print v(xbgr.mr_n84259568)
print v(xbgr.mr_n84259680)
print v(xbgr.mr_n84260000)
print v(xbgr.mr_n84260112)
print v(xbgr.mr_n84260432)
print v(xbgr.mr_n84260544)
print v(xbgr.mr_n84260864)
print v(xbgr.mr_n84260976)
print v(xbgr.mr_n84261296)
print v(xbgr.mr_n84261408)
print v(xbgr.mr_n84261728)
print v(xbgr.mr_n84261840)
print v(xbgr.mr_n84262160)
print v(xbgr.mr_n84262272)
print v(xbgr.mr_n84262592)
print v(xbgr.mr_n84262704)
print v(xbgr.mr_n84263024)
print v(xbgr.mr_n84263136)
print v(xbgr.mr_n84263456)
print v(xbgr.mr_n84263568)
print v(xbgr.mr_n84263888)
print v(xbgr.mr_n84264000)
print v(xbgr.mr_n84264320)
print v(xbgr.mr_n84264432)
print v(xbgr.mr_n84264752)
print v(xbgr.mr_n84264864)
print v(xbgr.mr_n84265184)
print v(xbgr.mr_n84265296)
print v(xbgr.mr_n84265616)
print v(xbgr.mr_n84265728)
print v(xbgr.mr_n84266048)
print v(xbgr.mr_n84266160)
print v(xbgr.mr_n84266480)
print v(xbgr.mr_n84266592)
print v(xbgr.mr_n84266912)
print v(xbgr.mr_n84267024)
print v(xbgr.mr_n84267344)
print v(xbgr.mr_n84267456)
print v(xbgr.mr_n84267776)
print v(xbgr.mr_n84267888)
print v(xbgr.mr_n84268208)
print v(xbgr.mr_n84268320)
print v(xbgr.mr_n84268640)
print v(xbgr.mr_n84268752)
print v(xbgr.mr_n84269072)
print v(xbgr.mr_n84269184)
print v(xbgr.mr_n84269504)
print v(xbgr.mr_n84269616)
print v(xbgr.mr_n84269936)
print v(xbgr.mr_n84270048)
print v(xbgr.mr_n84270368)
print v(xbgr.mr_n84270480)
print v(xbgr.mr_n84270896)
print v(xbgr.mr_n84271328)
print v(xbgr.mr_n84271760)
print v(xbgr.mr_n84272192)
print v(xbgr.mr_n84272624)
print v(xbgr.mr_n84273056)
print v(xbgr.mr_n84273488)
print v(xbgr.mr_n84273920)
print v(xbgr.mr_n84274352)
print v(xbgr.mr_n84274784)
print v(xbgr.mr_n84275216)
print v(xbgr.mr_n84275648)
print v(xbgr.mr_n84275968)
print v(xbgr.mr_n84276080)
print v(xbgr.mr_n84276400)
print v(xbgr.mr_n84276512)
print v(xbgr.mr_n84276944)
print v(xbgr.mr_n84277376)
print v(xbgr.mr_n84277808)
print v(xbgr.mr_n84278240)
print v(xbgr.mr_n84278672)
print v(xbgr.mr_n84279104)
print v(xbgr.mr_n84279536)
print v(xbgr.mr_n84279968)
print v(xbgr.mr_n84280400)
print v(xbgr.mr_n84280832)
print v(xbgr.mr_n84281264)
print v(xbgr.mr_n84281696)
print v(xbgr.mr_n84282128)
print v(xbgr.mr_n84282560)
print v(xbgr.mr_n84282992)
print v(xbgr.mr_n84283424)
print v(xbgr.mr_n84283856)
print v(xbgr.mr_n84284288)
print v(xbgr.mr_n84284720)
print v(xbgr.mr_n84285152)
print v(xbgr.mr_n84285584)
print v(xbgr.mr_n84286016)
print v(xbgr.mr_n84286448)
print v(xbgr.mr_n84286880)
print v(xbgr.mr_n84287312)
print v(xbgr.mr_n84287744)
print v(xbgr.mr_n84288176)
print v(xbgr.mr_n84288608)
print v(xbgr.mr_n84289040)
print v(xbgr.mr_n84289472)
print v(xbgr.mr_n84289904)
print v(xbgr.mr_n84290336)
print v(xbgr.mr_n84290768)
print v(xbgr.mr_n84291200)
print v(xbgr.mr_n84291632)
print v(xbgr.mr_n84292064)
print v(xbgr.mr_n84292496)
print v(xbgr.mr_n84292928)
print v(xbgr.mr_n84293360)
print v(xbgr.mr_n84293792)
print v(xbgr.mr_n84294112)
print v(xbgr.mr_n84294224)
print v(xbgr.mr_n84294544)
print v(xbgr.mr_n84294656)
print v(xbgr.mr_n84295088)
print v(xbgr.mr_n84295408)
print v(xbgr.mr_n84295520)
print v(xbgr.mr_n84295952)
print v(xbgr.mr_n84296384)
print v(xbgr.mr_n84296816)
print v(xbgr.mr_n84297248)
print v(xbgr.mr_n84297680)
print v(xbgr.mr_n84298112)
print v(xbgr.mr_n84298544)
print v(xbgr.mr_n84298976)
print v(xbgr.mr_n84299408)
print v(xbgr.mr_n84299840)
print v(xbgr.mr_n84300272)
print v(xbgr.mr_n84300704)
print v(xbgr.mr_n84301136)
print v(xbgr.mr_n84301568)
print v(xbgr.mr_n84302000)
print v(xbgr.mr_n84302432)
print v(xbgr.mr_n84302864)
print v(xbgr.mr_n84303296)
print v(xbgr.mr_n84303728)
print v(xbgr.mr_n84304160)
print v(xbgr.mr_n84304592)
print v(xbgr.mr_n84305024)
print v(xbgr.mr_n84305456)
print v(xbgr.mr_n84305888)
print v(xbgr.mr_n84306320)
print v(xbgr.mr_n84306752)
print v(xbgr.mr_n84307184)
print v(xbgr.mr_n84307616)
print v(xbgr.mr_n84308048)
print v(xbgr.mr_n84308480)
print v(xbgr.mr_n84308912)
print v(xbgr.mr_n84309344)
print v(xbgr.mr_n84309776)
print v(xbgr.mr_n84310208)
print v(xbgr.mr_n84310640)
print v(xbgr.mr_n84311072)
print v(xbgr.mr_n84311504)
print v(xbgr.mr_n84311936)
print v(xbgr.mr_n84312368)
print v(xbgr.mr_n84312800)
print v(xbgr.mr_n84313232)
print v(xbgr.mr_n84313664)
print v(xbgr.mr_n84314096)
print v(xbgr.mr_n84314528)
print v(xbgr.mr_n84314960)
print v(xbgr.mr_n84315392)
print v(xbgr.mr_n84315824)
print v(xbgr.mr_n84316144)
print v(xbgr.mr_n84316256)
print v(xbgr.mr_n84316688)
print v(xbgr.mr_n84317120)
print v(xbgr.mr_n84317440)
print v(xbgr.mr_n84317552)
print v(xbgr.mr_n84317872)
print v(xbgr.mr_n84317984)
print v(xbgr.mr_n84318304)
print v(xbgr.mr_n84318416)
print v(xbgr.mr_n84318736)
print v(xbgr.mr_n84318848)
print v(xbgr.mr_n84319168)
print v(xbgr.mr_n84319280)
print v(xbgr.mr_n84319600)
print v(xbgr.mr_n84319712)
print v(xbgr.mr_n84320144)
print v(xbgr.mr_n84320464)
print v(xbgr.mr_n84320576)
print v(xbgr.mr_n84320896)
print v(xbgr.mr_n84321008)
print v(xbgr.mr_n84321328)
print v(xbgr.mr_n84321440)
print v(xbgr.mr_n84321760)
print v(xbgr.mr_n84321872)
print v(xbgr.mr_n84322192)
print v(xbgr.mr_n84322304)
print v(xbgr.mr_n84322624)
print v(xbgr.mr_n84322736)
print v(xbgr.mr_n84323168)
print v(xbgr.mr_n84323488)
print v(xbgr.mr_n84323600)
print v(xbgr.mr_n84323920)
print v(xbgr.mr_n84324032)
print v(xbgr.mr_n84324352)
print v(xbgr.mr_n84324464)
print v(xbgr.mr_n84324784)
print v(xbgr.mr_n84324896)
print v(xbgr.mr_n84325216)
print v(xbgr.mr_n84325328)
print v(xbgr.mr_n84325648)
print v(xbgr.mr_n84325760)
print v(xbgr.mr_n84326192)
print v(xbgr.mr_n84326512)
print v(xbgr.mr_n84326624)
print v(xbgr.mr_n84326944)
print v(xbgr.mr_n84327056)
print v(xbgr.mr_n84327376)
print v(xbgr.mr_n84327488)
print v(xbgr.mr_n84327920)
print v(xbgr.mr_n84328240)
print v(xbgr.mr_n84328352)
print v(xbgr.mr_n84328784)
print v(xbgr.mr_n84329216)
print v(xbgr.mr_n84329648)
print v(xbgr.mr_n84330080)
print v(xbgr.mr_n84331376)
print v(xbgr.mr_n84331808)
print v(xbgr.mr_n84333104)
print v(xbgr.mr_n84333536)
print v(xbgr.mr_n84333856)
print v(xbgr.mr_n84333968)
print v(xbgr.mr_n84334288)
print v(xbgr.mr_n84334400)
print v(xbgr.mr_n84334720)
print v(xbgr.mr_n84334832)
print v(xbgr.mr_n84335152)
print v(xbgr.mr_n84335696)
print v(xbgr.mr_n84336448)
print v(xbgr.mr_n84336560)
print v(xbgr.mr_n84336880)
print v(xbgr.mr_n84339152)
print v(xbgr.mr_n84340016)
print v(xbgr.mr_n84340880)
print v(xbgr.mr_n84341312)
print v(xbgr.mr_n84341744)
print v(xbgr.mr_n84342176)
print v(xbgr.mr_n84344224)
print v(xbgr.mr_n84344336)
print v(xbgr.mr_n84344768)
print v(xbgr.mr_n84345088)
print v(xbgr.mr_n84345200)
print v(xbgr.mr_n84345520)
print v(xbgr.mr_n84345632)
print v(xbgr.mr_n84346064)
print v(xbgr.mr_n84346384)
print v(xbgr.mr_n84346496)
print v(xbgr.mr_n84346816)
print v(xbgr.mr_n84346928)
print v(xbgr.mr_n84347248)
print v(xbgr.mr_n84347360)
print v(xbgr.mr_n84347792)
print v(xbgr.mr_n84348112)
print v(xbgr.mr_n84348224)
print v(xbgr.mr_n84348544)
print v(xbgr.mr_n84348656)
print v(xbgr.mr_n84348976)
print v(xbgr.mr_n84349088)
print v(xbgr.mr_n84349520)
print v(xbgr.mr_n84349840)
print v(xbgr.mr_n84349952)
print v(xbgr.mr_n84350272)
print v(xbgr.mr_n84350384)
print v(xbgr.mr_n84350704)
print v(xbgr.mr_n84350816)
print v(xbgr.mr_n84351136)
print v(xbgr.mr_n84351248)
print v(xbgr.mr_n84351568)
print v(xbgr.mr_n84351680)
print v(xbgr.mr_n84352112)
print v(xbgr.mr_n84352432)
print v(xbgr.mr_n84352544)
print v(xbgr.mr_n84352864)
print v(xbgr.mr_n84352976)
print v(xbgr.mr_n84353296)
print v(xbgr.mr_n84353408)
print v(xbgr.mr_n84353728)
print v(xbgr.mr_n84353840)
print v(xbgr.mr_n84354272)
print v(xbgr.mr_n84354592)
print v(xbgr.mr_n84354704)
print v(xbgr.mr_n84355024)
print v(xbgr.mr_n84355136)
print v(xbgr.mr_n84355568)
print v(xbgr.mr_n84355888)
print v(xbgr.mr_n84356000)
print v(xbgr.mr_n84356320)
print v(xbgr.mr_n84356432)
print v(xbgr.mr_n84356752)
print v(xbgr.mr_n84356864)
print v(xbgr.mr_n84357296)
print v(xbgr.mr_n84357616)
print v(xbgr.mr_n84357728)
print v(xbgr.mr_n84358048)
print v(xbgr.mr_n84358160)
print v(xbgr.mr_n84358480)
print v(xbgr.mr_n84358592)
print v(xbgr.mr_n84359024)
print v(xbgr.mr_n84359344)
print v(xbgr.mr_n84359456)
print v(xbgr.mr_n84359776)
print v(xbgr.mr_n84359888)
print v(xbgr.mr_n84360208)
print v(xbgr.mr_n84360320)
print v(xbgr.mr_n84360640)
print v(xbgr.mr_n84360752)
print v(xbgr.mr_n84361072)
print v(xbgr.mr_n84361184)
print v(xbgr.mr_n84361504)
print v(xbgr.mr_n84361616)
print v(xbgr.mr_n84361936)
print v(xbgr.mr_n84362048)
print v(xbgr.mr_n84362368)
print v(xbgr.mr_n84362480)
print v(xbgr.mr_n84362800)
print v(xbgr.mr_n84362912)
print v(xbgr.mr_n84363232)
print v(xbgr.mr_n84363344)
print v(xbgr.mr_n84363664)
print v(xbgr.mr_n84363776)
print v(xbgr.mr_n84364096)
print v(xbgr.mr_n84364208)
print v(xbgr.mr_n84364528)
print v(xbgr.mr_n84364640)
print v(xbgr.mr_n84365072)
print v(xbgr.mr_n84365392)
print v(xbgr.mr_n84365504)
print v(xbgr.mr_n84365824)
print v(xbgr.mr_n84365936)
print v(xbgr.mr_n84366256)
print v(xbgr.mr_n84366368)
print v(xbgr.mr_n84366688)
print v(xbgr.mr_n84366800)
print v(xbgr.mr_n84367120)
print v(xbgr.mr_n84367232)
print v(xbgr.mr_n84367552)
print v(xbgr.mr_n84367664)
print v(xbgr.mr_n84367984)
print v(xbgr.mr_n84368096)
print v(xbgr.mr_n84368416)
print v(xbgr.mr_n84368528)
print v(xbgr.mr_n84368848)
print v(xbgr.mr_n84368960)
print v(xbgr.mr_n84369280)
print v(xbgr.mr_n84369392)
print v(xbgr.mr_n84369824)
print v(xbgr.mr_n84370144)
print v(xbgr.mr_n84370256)
print v(xbgr.mr_n84370576)
print v(xbgr.mr_n84370688)
print v(xbgr.mr_n84371008)
print v(xbgr.mr_n84371120)
print v(xbgr.mr_n84371440)
print v(xbgr.mr_n84371552)
print v(xbgr.mr_n84371872)
print v(xbgr.mr_n84371984)
print v(xbgr.mr_n84372304)
print v(xbgr.mr_n84372416)
print v(xbgr.mr_n84372736)
print v(xbgr.mr_n84372848)
print v(xbgr.mr_n84373168)
print v(xbgr.mr_n84373280)
print v(xbgr.mr_n84373600)
print v(xbgr.mr_n84373712)
print v(xbgr.mr_n84374032)
print v(xbgr.mr_n84374144)
print v(xbgr.mr_n84374464)
print v(xbgr.mr_n84374576)
print v(xbgr.mr_n84374896)
print v(xbgr.mr_n84375008)
print v(xbgr.mr_n84375328)
print v(xbgr.mr_n84375440)
print v(xbgr.mr_n84375760)
print v(xbgr.mr_n84375872)
print v(xbgr.mr_n84376192)
print v(xbgr.mr_n84376304)
print v(xbgr.mr_n84376624)
print v(xbgr.mr_n84376736)
print v(xbgr.mr_n84377168)
print v(xbgr.mr_n84377488)
print v(xbgr.mr_n84377600)
print v(xbgr.mr_n84377920)
print v(xbgr.mr_n84378032)
print v(xbgr.mr_n84378352)
print v(xbgr.mr_n84378464)
print v(xbgr.mr_n84378784)
print v(xbgr.mr_n84378896)
print v(xbgr.mr_n84379216)
print v(xbgr.mr_n84379328)
print v(xbgr.mr_n84379648)
print v(xbgr.mr_n84379760)
print v(xbgr.mr_n84380080)
print v(xbgr.mr_n84380192)
print v(xbgr.mr_n84380512)
print v(xbgr.mr_n84380624)
print v(xbgr.mr_n84380944)
print v(xbgr.mr_n84381056)
print v(xbgr.mr_n84381376)
print v(xbgr.mr_n84381488)
print v(xbgr.mr_n84381808)
print v(xbgr.mr_n84381920)
print v(xbgr.mr_n84382240)
print v(xbgr.mr_n84382352)
print v(xbgr.mr_n84382784)
print v(xbgr.mr_n84383104)
print v(xbgr.mr_n84383216)
print v(xbgr.mr_n84383536)
print v(xbgr.mr_n84383648)
print v(xbgr.mr_n84383968)
print v(xbgr.mr_n84384080)
print v(xbgr.mr_n84384400)
print v(xbgr.mr_n84384512)
print v(xbgr.mr_n84384832)
print v(xbgr.mr_n84384944)
print v(xbgr.mr_n84385264)
print v(xbgr.mr_n84385376)
print v(xbgr.mr_n84385696)
print v(xbgr.mr_n84385808)
print v(xbgr.mr_n84386128)
print v(xbgr.mr_n84386240)
print v(xbgr.mr_n84386560)
print v(xbgr.mr_n84386672)
print v(xbgr.mr_n84386992)
print v(xbgr.mr_n84387104)
print v(xbgr.mr_n84387424)
print v(xbgr.mr_n84387536)
print v(xbgr.mr_n84387856)
print v(xbgr.mr_n84387968)
print v(xbgr.mr_n84388288)
print v(xbgr.mr_n84388400)
print v(xbgr.mr_n84388720)
print v(xbgr.mr_n84388832)
print v(xbgr.mr_n84389152)
print v(xbgr.mr_n84389264)
print v(xbgr.mr_n84389584)
print v(xbgr.mr_n84389696)
print v(xbgr.mr_n84390016)
print v(xbgr.mr_n84390128)
print v(xbgr.mr_n84390448)
print v(xbgr.mr_n84390560)
print v(xbgr.mr_n84390880)
print v(xbgr.mr_n84390992)
print v(xbgr.mr_n84391312)
print v(xbgr.mr_n84391424)
print v(xbgr.mr_n84391856)
print v(xbgr.mr_n84392176)
print v(xbgr.mr_n84392288)
print v(xbgr.mr_n84392608)
print v(xbgr.mr_n84392720)
print v(xbgr.mr_n84393040)
print v(xbgr.mr_n84393152)
print v(xbgr.mr_n84393472)
print v(xbgr.mr_n84393584)
print v(xbgr.mr_n84393904)
print v(xbgr.mr_n84394016)
print v(xbgr.mr_n84394336)
print v(xbgr.mr_n84394448)
print v(xbgr.mr_n84394768)
print v(xbgr.mr_n84394880)
print v(xbgr.mr_n84395200)
print v(xbgr.mr_n84395312)
print v(xbgr.mr_n84395632)
print v(xbgr.mr_n84395744)
print v(xbgr.mr_n84396064)
print v(xbgr.mr_n84396176)
print v(xbgr.mr_n84396496)
print v(xbgr.mr_n84396608)
print v(xbgr.mr_n84396928)
print v(xbgr.mr_n84397040)
print v(xbgr.mr_n84397360)
print v(xbgr.mr_n84397472)
print v(xbgr.mr_n84397792)
print v(xbgr.mr_n84397904)
print v(xbgr.mr_n84398224)
print v(xbgr.mr_n84398336)
print v(xbgr.mr_n84398656)
print v(xbgr.mr_n84398768)
print v(xbgr.mr_n84399088)
print v(xbgr.mr_n84399200)
print v(xbgr.mr_n84399520)
print v(xbgr.mr_n84399632)
print v(xbgr.mr_n84399952)
print v(xbgr.mr_n84400064)
print v(xbgr.mr_n84400384)
print v(xbgr.mr_n84400496)
print v(xbgr.mr_n84400816)
print v(xbgr.mr_n84400928)
print v(xbgr.mr_n84401248)
print v(xbgr.mr_n84401360)
print v(xbgr.mr_n84401792)
print v(xbgr.mr_n84402112)
print v(xbgr.mr_n84402224)
print v(xbgr.mr_n84402544)
print v(xbgr.mr_n84402656)
print v(xbgr.mr_n84402976)
print v(xbgr.mr_n84403088)
print v(xbgr.mr_n84403408)
print v(xbgr.mr_n84403520)
print v(xbgr.mr_n84403840)
print v(xbgr.mr_n84403952)
print v(xbgr.mr_n84404272)
print v(xbgr.mr_n84404384)
print v(xbgr.mr_n84404704)
print v(xbgr.mr_n84404816)
print v(xbgr.mr_n84405136)
print v(xbgr.mr_n84405248)
print v(xbgr.mr_n84405568)
print v(xbgr.mr_n84405680)
print v(xbgr.mr_n84406000)
print v(xbgr.mr_n84406112)
print v(xbgr.mr_n84406432)
print v(xbgr.mr_n84406544)
print v(xbgr.mr_n84406864)
print v(xbgr.mr_n84406976)
print v(xbgr.mr_n84407408)
print v(xbgr.mr_n84407840)
print v(xbgr.mr_n84408272)
print v(xbgr.mr_n84408704)
print v(xbgr.mr_n84409136)
print v(xbgr.mr_n84409568)
print v(xbgr.mr_n84410000)
print v(xbgr.mr_n84410432)
print v(xbgr.mr_n84410864)
print v(xbgr.mr_n84411296)
print v(xbgr.mr_n84411728)
print v(xbgr.mr_n84412160)
print v(xbgr.mr_n84412592)
print v(xbgr.mr_n84413024)
print v(xbgr.mr_n84413456)
print v(xbgr.mr_n84413888)
print v(xbgr.mr_n84414320)
print v(xbgr.mr_n84414752)
print v(xbgr.mr_n84415184)
print v(xbgr.mr_n84415616)
print v(xbgr.mr_n84416048)
print v(xbgr.mr_n84416480)
print v(xbgr.mr_n84416912)
print v(xbgr.mr_n84417344)
print v(xbgr.mr_n84417776)
print v(xbgr.mr_n84418208)
print v(xbgr.mr_n84418640)
print v(xbgr.mr_n84419072)
print v(xbgr.mr_n84419504)
print v(xbgr.mr_n84419936)
print v(xbgr.mr_n84420368)
print v(xbgr.mr_n84420800)
print v(xbgr.mr_n84421232)
print v(xbgr.mr_n84421664)
print v(xbgr.mr_n84422096)
print v(xbgr.mr_n84422528)
print v(xbgr.mr_n84422960)
print v(xbgr.mr_n84423392)
print v(xbgr.mr_n84423824)
print v(xbgr.mr_n84424256)
print v(xbgr.mr_n84424688)
print v(xbgr.mr_n84425120)
print v(xbgr.mr_n84425552)
print v(xbgr.mr_n84425984)
print v(xbgr.mr_n84426416)
print v(xbgr.mr_n84426848)
print v(xbgr.mr_n84427280)
print v(xbgr.mr_n84427712)
print v(xbgr.mr_n84428144)
print v(xbgr.mr_n84428576)
print v(xbgr.mr_n84429008)
print v(xbgr.mr_n84429440)
print v(xbgr.mr_n84429872)
print v(xbgr.mr_n84430304)
print v(xbgr.mr_n84430736)
print v(xbgr.mr_n84431168)
print v(xbgr.mr_n84431600)
print v(xbgr.mr_n84432032)
print v(xbgr.mr_n84432464)
print v(xbgr.mr_n84432896)
print v(xbgr.mr_n84433328)
print v(xbgr.mr_n84433760)
print v(xbgr.mr_n84434192)
print v(xbgr.mr_n84434624)
print v(xbgr.mr_n84435056)
print v(xbgr.mr_n84435488)
print v(xbgr.mr_n84435920)
print v(xbgr.mr_n84436352)
print v(xbgr.mr_n84436784)
print v(xbgr.mr_n84437216)
print v(xbgr.mr_n84437648)
print v(xbgr.mr_n84438080)
print v(xbgr.mr_n84438512)
print v(xbgr.mr_n84438944)
print v(xbgr.mr_n84439376)
print v(xbgr.mr_n84439808)
print v(xbgr.mr_n84440240)
print v(xbgr.mr_n84440672)
print v(xbgr.mr_n84441104)
print v(xbgr.mr_n84441536)
print v(xbgr.mr_n84441968)
print v(xbgr.mr_n84442400)
print v(xbgr.mr_n84442832)
print v(xbgr.mr_n84443264)
print v(xbgr.mr_n84443696)
print v(xbgr.mr_n84444128)
print v(xbgr.mr_n84444560)
print v(xbgr.mr_n84444992)
print v(xbgr.mr_n84445424)
print v(xbgr.mr_n84445856)
print v(xbgr.mr_n84446288)
print v(xbgr.mr_n84446720)
print v(xbgr.mr_n84447152)
print v(xbgr.mr_n84447584)
print v(xbgr.mr_n84448016)
print v(xbgr.mr_n84448448)
print v(xbgr.mr_n84448880)
print v(xbgr.mr_n84449312)
print v(xbgr.mr_n84449744)
print v(xbgr.mr_n84450176)
print v(xbgr.mr_n84450608)
print v(xbgr.mr_n84451040)
print v(xbgr.mr_n84451472)
print v(xbgr.mr_n84451904)
print v(xbgr.mr_n84452336)
print v(xbgr.mr_n84452768)
print v(xbgr.mr_n84453200)
print v(xbgr.mr_n84453632)
print v(xbgr.mr_n84454064)
print v(xbgr.mr_n84454496)
print v(xbgr.mr_n84454816)
print v(xbgr.mr_n84454928)
print v(xbgr.mr_n84455248)
print v(xbgr.mr_n84455360)
print v(xbgr.mr_n84455680)
print v(xbgr.mr_n84455792)
print v(xbgr.mr_n84456112)
print v(xbgr.mr_n84456224)
print v(xbgr.mr_n84456544)
print v(xbgr.mr_n84456656)
print v(xbgr.mr_n84456976)
print v(xbgr.mr_n84457088)
print v(xbgr.mr_n84457408)
print v(xbgr.mr_n84457520)
print v(xbgr.mr_n84457840)
print v(xbgr.mr_n84457952)
print v(xbgr.mr_n84458272)
print v(xbgr.mr_n84458384)
print v(xbgr.mr_n84458704)
print v(xbgr.mr_n84458816)
print v(xbgr.mr_n84459136)
print v(xbgr.mr_n84459248)
print v(xbgr.mr_n84459568)
print v(xbgr.mr_n84459680)
print v(xbgr.mr_n84460000)
print v(xbgr.mr_n84460112)
print v(xbgr.mr_n84460432)
print v(xbgr.mr_n84460544)
print v(xbgr.mr_n84460864)
print v(xbgr.mr_n84460976)
print v(xbgr.mr_n84461296)
print v(xbgr.mr_n84461408)
print v(xbgr.mr_n84461728)
print v(xbgr.mr_n84461840)
print v(xbgr.mr_n84462160)
print v(xbgr.mr_n84462272)
print v(xbgr.mr_n84462592)
print v(xbgr.mr_n84462704)
print v(xbgr.mr_n84463024)
print v(xbgr.mr_n84463136)
print v(xbgr.mr_n84463456)
print v(xbgr.mr_n84463568)
print v(xbgr.mr_n84463888)
print v(xbgr.mr_n84464000)
print v(xbgr.mr_n84464320)
print v(xbgr.mr_n84464432)
print v(xbgr.mr_n84464752)
print v(xbgr.mr_n84464864)
print v(xbgr.mr_n84465184)
print v(xbgr.mr_n84465296)
print v(xbgr.mr_n84465616)
print v(xbgr.mr_n84465728)
print v(xbgr.mr_n84466048)
print v(xbgr.mr_n84466160)
print v(xbgr.mr_n84466480)
print v(xbgr.mr_n84466592)
print v(xbgr.mr_n84466912)
print v(xbgr.mr_n84467024)
print v(xbgr.mr_n84467344)
print v(xbgr.mr_n84467456)
print v(xbgr.mr_n84467776)
print v(xbgr.mr_n84467888)
print v(xbgr.mr_n84468208)
print v(xbgr.mr_n84468320)
print v(xbgr.mr_n84468640)
print v(xbgr.mr_n84468752)
print v(xbgr.mr_n84469072)
print v(xbgr.mr_n84469184)
print v(xbgr.mr_n84469504)
print v(xbgr.mr_n84469616)
print v(xbgr.mr_n84469936)
print v(xbgr.mr_n84470048)
print v(xbgr.mr_n84470368)
print v(xbgr.mr_n84470480)
print v(xbgr.mr_n84470800)
print v(xbgr.mr_n84470912)
print v(xbgr.mr_n84471232)
print v(xbgr.mr_n84471344)
print v(xbgr.mr_n84471664)
print v(xbgr.mr_n84471776)
print v(xbgr.mr_n84472096)
print v(xbgr.mr_n84472208)
print v(xbgr.mr_n84472528)
print v(xbgr.mr_n84472640)
print v(xbgr.mr_n84472960)
print v(xbgr.mr_n84473072)
print v(xbgr.mr_n84473392)
print v(xbgr.mr_n84473504)
print v(xbgr.mr_n84473824)
print v(xbgr.mr_n84473936)
print v(xbgr.mr_n84474256)
print v(xbgr.mr_n84474368)
print v(xbgr.mr_n84474688)
print v(xbgr.mr_n84474800)
print v(xbgr.mr_n84475120)
print v(xbgr.mr_n84475232)
print v(xbgr.mr_n84475552)
print v(xbgr.mr_n84475664)
print v(xbgr.mr_n84475984)
print v(xbgr.mr_n84476096)
print v(xbgr.mr_n84476528)
print v(xbgr.mr_n84476848)
print v(xbgr.mr_n84476960)
print v(xbgr.mr_n84477280)
print v(xbgr.mr_n84477392)
print v(xbgr.mr_n84477712)
print v(xbgr.mr_n84477824)
print v(xbgr.mr_n84478144)
print v(xbgr.mr_n84478256)
print v(xbgr.mr_n84478576)
print v(xbgr.mr_n84478688)
print v(xbgr.mr_n84479008)
print v(xbgr.mr_n84479120)
print v(xbgr.mr_n84479440)
print v(xbgr.mr_n84479552)
print v(xbgr.mr_n84479872)
print v(xbgr.mr_n84479984)
print v(xbgr.mr_n84480304)
print v(xbgr.mr_n84480416)
print v(xbgr.mr_n84480736)
print v(xbgr.mr_n84480848)
print v(xbgr.mr_n84481168)
print v(xbgr.mr_n84481280)
print v(xbgr.mr_n84481600)
print v(xbgr.mr_n84481712)
print v(xbgr.mr_n84482032)
print v(xbgr.mr_n84482144)
print v(xbgr.mr_n84482464)
print v(xbgr.mr_n84482576)
print v(xbgr.mr_n84482896)
print v(xbgr.mr_n84483008)
print v(xbgr.mr_n84483328)
print v(xbgr.mr_n84483440)
print v(xbgr.mr_n84483888)
print v(xbgr.mr_n84484000)
print v(xbgr.mr_n84484320)
print v(xbgr.mr_n84484432)
print v(xbgr.mr_n84484752)
print v(xbgr.mr_n84484864)
print v(xbgr.mr_n84485184)
print v(xbgr.mr_n84485296)
print v(xbgr.mr_n84485616)
print v(xbgr.mr_n84485728)
print v(xbgr.mr_n84486048)
print v(xbgr.mr_n84486160)
print v(xbgr.mr_n84486480)
print v(xbgr.mr_n84486592)
print v(xbgr.mr_n84486912)
print v(xbgr.mr_n84487024)
print v(xbgr.mr_n84487344)
print v(xbgr.mr_n84487456)
print v(xbgr.mr_n84487776)
print v(xbgr.mr_n84487888)
print v(xbgr.mr_n84488208)
print v(xbgr.mr_n84488320)
print v(xbgr.mr_n84488752)
print v(xbgr.mr_n84489072)
print v(xbgr.mr_n84489184)
print v(xbgr.mr_n84489504)
print v(xbgr.mr_n84489616)
print v(xbgr.mr_n84489936)
print v(xbgr.mr_n84490048)
print v(xbgr.mr_n84490368)
print v(xbgr.mr_n84490480)
print v(xbgr.mr_n84490912)
print v(xbgr.mr_n84491344)
print v(xbgr.mr_n84491664)
print v(xbgr.mr_n84491776)
print v(xbgr.mr_n84492096)
print v(xbgr.mr_n84492208)
print v(xbgr.mr_n84492528)
print v(xbgr.mr_n84492640)
print v(xbgr.mr_n84492960)
print v(xbgr.mr_n84493072)
print v(xbgr.mr_n84493392)
print v(xbgr.mr_n84493504)
print v(xbgr.mr_n84493824)
print v(xbgr.mr_n84493936)
print v(xbgr.mr_n84494368)
print v(xbgr.mr_n84494688)
print v(xbgr.mr_n84494800)
print v(xbgr.mr_n84495120)
print v(xbgr.mr_n84495232)
print v(xbgr.mr_n84495552)
print v(xbgr.mr_n84495664)
print v(xbgr.mr_n84495984)
print v(xbgr.mr_n84496096)
print v(xbgr.mr_n84496416)
print v(xbgr.mr_n84496528)
print v(xbgr.mr_n84496848)
print v(xbgr.mr_n84496960)
print v(xbgr.mr_n84497280)
print v(xbgr.mr_n84497392)
print v(xbgr.mr_n84497712)
print v(xbgr.mr_n84497824)
print v(xbgr.mr_n84498144)
print v(xbgr.mr_n84498256)
print v(xbgr.mr_n84498576)
print v(xbgr.mr_n84498688)
print v(xbgr.mr_n84499008)
print v(xbgr.mr_n84499120)
print v(xbgr.mr_n84499440)
print v(xbgr.mr_n84499552)
print v(xbgr.mr_n84499984)
print v(xbgr.mr_n84500416)
print v(xbgr.mr_n84500848)
print v(xbgr.mr_n84501280)
print v(xbgr.mr_n84501776)
print v(xbgr.mr_n84501888)
print v(xbgr.mr_n84502224)
print v(xbgr.mr_n84502336)
print v(xbgr.mr_n84502656)
print v(xbgr.mr_n84502768)
print v(xbgr.mr_n84503136)
print v(xbgr.mr_n84503248)
print v(xbgr.mr_n84503568)
print v(xbgr.mr_n84503680)
print v(xbgr.mr_n84504000)
print v(xbgr.mr_n84504112)
print v(xbgr.mr_n84504352)
print v(xbgr.mr_n84504464)
print v(xbgr.mr_n84504784)
print v(xbgr.mr_n84504896)
print v(xbgr.mr_n84505216)
print v(xbgr.mr_n84505328)
print v(xbgr.mr_n84505648)
print v(xbgr.mr_n84505760)
print v(xbgr.mr_n84506080)
print v(xbgr.mr_n84506192)
print v(xbgr.mr_n84506512)
print v(xbgr.mr_n84506624)
print v(xbgr.mr_n84506944)
print v(xbgr.mr_n84507056)
print v(xbgr.mr_n84507376)
print v(xbgr.mr_n84507488)
print v(xbgr.mr_n84507808)
print v(xbgr.mr_n84507920)
print v(xbgr.mr_n84508240)
print v(xbgr.mr_n84508352)
print v(xbgr.mr_n84508672)
print v(xbgr.mr_n84508784)
print v(xbgr.mr_n84509104)
print v(xbgr.mr_n84509216)
print v(xbgr.mr_n84509536)
print v(xbgr.mr_n84509648)
print v(xbgr.mr_n84509968)
print v(xbgr.mr_n84510080)
print v(xbgr.mr_n84510400)
print v(xbgr.mr_n84510512)
print v(xbgr.mr_n84510832)
print v(xbgr.mr_n84510944)
print v(xbgr.mr_n84511264)
print v(xbgr.mr_n84511376)
print v(xbgr.mr_n84511696)
print v(xbgr.mr_n84511808)
print v(xbgr.mr_n84512128)
print v(xbgr.mr_n84512240)
print v(xbgr.mr_n84512560)
print v(xbgr.mr_n84512672)
print v(xbgr.mr_n84512992)
print v(xbgr.mr_n84513104)
print v(xbgr.mr_n84513424)
print v(xbgr.mr_n84513536)
print v(xbgr.mr_n84513856)
print v(xbgr.mr_n84513968)
print v(xbgr.mr_n84514288)
print v(xbgr.mr_n84514400)
print v(xbgr.mr_n84514720)
print v(xbgr.mr_n84514832)
print v(xbgr.mr_n84515264)
print v(xbgr.mr_n84515584)
print v(xbgr.mr_n84516576)
print v(xbgr.mr_n84516688)
print v(xbgr.mr_n84517008)
print v(xbgr.mr_n84517120)
print v(xbgr.mr_n84517440)
print v(xbgr.mr_n84517552)
print v(xbgr.mr_n84517984)
print v(xbgr.mr_n84518304)
print v(xbgr.mr_n84518416)
print v(xbgr.mr_n84518736)
print v(xbgr.mr_n84518848)
print v(xbgr.mr_n84519168)
print v(xbgr.mr_n84519280)
print v(xbgr.mr_n84519600)
print v(xbgr.mr_n84519712)
print v(xbgr.mr_n84520032)
print v(xbgr.mr_n84520144)
print v(xbgr.mr_n84520576)
print v(xbgr.mr_n84521008)
print v(xbgr.mr_n84521440)
print v(xbgr.mr_n84521872)
print v(xbgr.mr_n84522192)
print v(xbgr.mr_n84522304)
print v(xbgr.mr_n84522624)
print v(xbgr.mr_n84522736)
print v(xbgr.mr_n84523056)
print v(xbgr.mr_n84523168)
print v(xbgr.mr_n84523600)
print v(xbgr.mr_n84524032)
print v(xbgr.mr_n84524352)
print v(xbgr.mr_n84524464)
print v(xbgr.mr_n84524784)
print v(xbgr.mr_n84524896)
print v(xbgr.mr_n84525216)
print v(xbgr.mr_n84525328)
print v(xbgr.mr_n84525648)
print v(xbgr.mr_n84525760)
print v(xbgr.mr_n84526192)
print v(xbgr.mr_n84526624)
print v(xbgr.mr_n84527056)
print v(xbgr.mr_n84527488)
print v(xbgr.mr_n84527920)
print v(xbgr.mr_n84528240)
print v(xbgr.mr_n84528352)
print v(xbgr.mr_n84528672)
print v(xbgr.mr_n84528784)
print v(xbgr.mr_n84529104)
print v(xbgr.mr_n84529216)
print v(xbgr.mr_n84529536)
print v(xbgr.mr_n84529648)
print v(xbgr.mr_n84529968)
print v(xbgr.mr_n84530080)
print v(xbgr.mr_n84530400)
print v(xbgr.mr_n84530512)
print v(xbgr.mr_n84530832)
print v(xbgr.mr_n84530944)
print v(xbgr.mr_n84531264)
print v(xbgr.mr_n84531376)
print v(xbgr.mr_n84531696)
print v(xbgr.mr_n84531808)
print v(xbgr.mr_n84532128)
print v(xbgr.mr_n84532240)
print v(xbgr.mr_n84532560)
print v(xbgr.mr_n84532672)
print v(xbgr.mr_n84532992)
print v(xbgr.mr_n84533104)
print v(xbgr.mr_n84533536)
print v(xbgr.mr_n84533856)
print v(xbgr.mr_n84533968)
print v(xbgr.mr_n84534288)
print v(xbgr.mr_n84534400)
print v(xbgr.mr_n84534720)
print v(xbgr.mr_n84534832)
print v(xbgr.mr_n84535152)
print v(xbgr.mr_n84535264)
print v(xbgr.mr_n84535584)
print v(xbgr.mr_n84535696)
print v(xbgr.mr_n84536128)
print v(xbgr.mr_n84536560)
print v(xbgr.mr_n84536992)
print v(xbgr.mr_n84537424)
print v(xbgr.mr_n84537744)
print v(xbgr.mr_n84537856)
print v(xbgr.mr_n84538176)
print v(xbgr.mr_n84538288)
print v(xbgr.mr_n84538608)
print v(xbgr.mr_n84538720)
print v(xbgr.mr_n84539040)
print v(xbgr.mr_n84539152)
print v(xbgr.mr_n84539472)
print v(xbgr.mr_n84539584)
print v(xbgr.mr_n84539904)
print v(xbgr.mr_n84540016)
print v(xbgr.mr_n84540336)
print v(xbgr.mr_n84540448)
print v(xbgr.mr_n84540768)
print v(xbgr.mr_n84540880)
print v(xbgr.mr_n84541200)
print v(xbgr.mr_n84541312)
print v(xbgr.mr_n84541632)
print v(xbgr.mr_n84541744)
print v(xbgr.mr_n84542064)
print v(xbgr.mr_n84542176)
print v(xbgr.mr_n84542496)
print v(xbgr.mr_n84542608)
print v(xbgr.mr_n84542928)
print v(xbgr.mr_n84543040)
print v(xbgr.mr_n84543360)
print v(xbgr.mr_n84543472)
print v(xbgr.mr_n84543792)
print v(xbgr.mr_n84543904)
print v(xbgr.mr_n84544224)
print v(xbgr.mr_n84544336)
print v(xbgr.mr_n84544656)
print v(xbgr.mr_n84544768)
print v(xbgr.mr_n84545088)
print v(xbgr.mr_n84545200)
print v(xbgr.mr_n84545520)
print v(xbgr.mr_n84545632)
print v(xbgr.mr_n84545952)
print v(xbgr.mr_n84546064)
print v(xbgr.mr_n84546384)
print v(xbgr.mr_n84546496)
print v(xbgr.mr_n84546816)
print v(xbgr.mr_n84546928)
print v(xbgr.mr_n84547248)
print v(xbgr.mr_n84547360)
print v(xbgr.mr_n84547680)
print v(xbgr.mr_n84547792)
print v(xbgr.mr_n84548112)
print v(xbgr.mr_n84548224)
print v(xbgr.mr_n84548544)
print v(xbgr.mr_n84548656)
print v(xbgr.mr_n84548976)
print v(xbgr.mr_n84549088)
print v(xbgr.mr_n84549408)
print v(xbgr.mr_n84549520)
print v(xbgr.mr_n84549840)
print v(xbgr.mr_n84549952)
print v(xbgr.mr_n84550272)
print v(xbgr.mr_n84550384)
print v(xbgr.mr_n84550704)
print v(xbgr.mr_n84550816)
print v(xbgr.mr_n84551136)
print v(xbgr.mr_n84551248)
print v(xbgr.mr_n84551568)
print v(xbgr.mr_n84551680)
print v(xbgr.mr_n84552000)
print v(xbgr.mr_n84552112)
print v(xbgr.mr_n84552432)
print v(xbgr.mr_n84552544)
print v(xbgr.mr_n84552864)
print v(xbgr.mr_n84552976)
print v(xbgr.mr_n84553296)
print v(xbgr.mr_n84553408)
print v(xbgr.mr_n84553728)
print v(xbgr.mr_n84553840)
print v(xbgr.mr_n84554160)
print v(xbgr.mr_n84554272)
print v(xbgr.mr_n84554592)
print v(xbgr.mr_n84554704)
print v(xbgr.mr_n84555024)
print v(xbgr.mr_n84555136)
print v(xbgr.mr_n84555456)
print v(xbgr.mr_n84555568)
print v(xbgr.mr_n84555888)
print v(xbgr.mr_n84556000)
print v(xbgr.mr_n84556320)
print v(xbgr.mr_n84556432)
print v(xbgr.mr_n84556864)
print v(xbgr.mr_n84557296)
print v(xbgr.mr_n84557616)
print v(xbgr.mr_n84557728)
print v(xbgr.mr_n84558048)
print v(xbgr.mr_n84558160)
print v(xbgr.mr_n84558480)
print v(xbgr.mr_n84558592)
print v(xbgr.mr_n84558912)
print v(xbgr.mr_n84559024)
print v(xbgr.mr_n84559456)
print v(xbgr.mr_n84559888)
print v(xbgr.mr_n84560208)
print v(xbgr.mr_n84560320)
print v(xbgr.mr_n84560640)
print v(xbgr.mr_n84560752)
print v(xbgr.mr_n84561072)
print v(xbgr.mr_n84561184)
print v(xbgr.mr_n84561616)
print v(xbgr.mr_n84562048)
print v(xbgr.mr_n84562480)
print v(xbgr.mr_n84562912)
print v(xbgr.mr_n84563344)
print v(xbgr.mr_n84563776)
print v(xbgr.mr_n84564208)
print v(xbgr.mr_n84564640)
print v(xbgr.mr_n84565072)
print v(xbgr.mr_n84565504)
print v(xbgr.mr_n84565936)
print v(xbgr.mr_n84566368)
print v(xbgr.mr_n84566800)
print v(xbgr.mr_n84567120)
print v(xbgr.mr_n84567552)
print v(xbgr.mr_n84567984)
print v(xbgr.mr_n84568416)
print v(xbgr.mr_n84568848)
print v(xbgr.mr_n84569280)
print v(xbgr.mr_n84569712)
print v(xbgr.mr_n84570144)
print v(xbgr.mr_n84570576)
print v(xbgr.mr_n84570688)
print v(xbgr.mr_n84571008)
print v(xbgr.mr_n84571120)
print v(xbgr.mr_n84571440)
print v(xbgr.mr_n84571552)
print v(xbgr.mr_n84571872)
print v(xbgr.mr_n84571984)
print v(xbgr.mr_n84572304)
print v(xbgr.mr_n84572416)
print v(xbgr.mr_n84572736)
print v(xbgr.mr_n84572848)
print v(xbgr.mr_n84573168)
print v(xbgr.mr_n84573280)
print v(xbgr.mr_n84573600)
print v(xbgr.mr_n84573712)
print v(xbgr.mr_n84574032)
print v(xbgr.mr_n84574464)
print v(xbgr.mr_n84574896)
print v(xbgr.mr_n84575328)
print v(xbgr.mr_n84575760)
print v(xbgr.mr_n84576192)
print v(xbgr.mr_n84576624)
print v(xbgr.mr_n84577056)
print v(xbgr.mr_n84577488)
print v(xbgr.mr_n84577920)
print v(xbgr.mr_n84578464)
print v(xbgr.mr_n84578896)
print v(xbgr.mr_n84579328)
print v(xbgr.mr_n84579760)
print v(xbgr.mr_n84580192)
print v(xbgr.mr_n84580624)
print v(xbgr.mr_n84581056)
print v(xbgr.mr_n84581488)
print v(xbgr.mr_n84581920)
print v(xbgr.mr_n84582352)
print v(xbgr.mr_n84582784)
print v(xbgr.mr_n84583216)
print v(xbgr.mr_n84583648)
print v(xbgr.mr_n84584080)
print v(xbgr.mr_n84584512)
print v(xbgr.mr_n84584944)
print v(xbgr.mr_n84585376)
print v(xbgr.mr_n84585808)
print v(xbgr.mr_n84586240)
print v(xbgr.mr_n84586672)
print v(xbgr.mr_n84587104)
print v(xbgr.mr_n84587536)
print v(xbgr.mr_n84587968)
print v(xbgr.mr_n84588400)
print v(xbgr.mr_n84588832)
print v(xbgr.mr_n84589264)
print v(xbgr.mr_n84589696)
print v(xbgr.mr_n84590128)
print v(xbgr.mr_n84590560)
print v(xbgr.mr_n84590992)
print v(xbgr.mr_n84591424)
print v(xbgr.mr_n84591856)
print v(xbgr.mr_n84592288)
print v(xbgr.mr_n84592720)
print v(xbgr.mr_n84593152)
print v(xbgr.mr_n84593584)
print v(xbgr.mr_n84594016)
print v(xbgr.mr_n84594448)
print v(xbgr.mr_n84594880)
print v(xbgr.mr_n84595312)
print v(xbgr.mr_n84595744)
print v(xbgr.mr_n84596176)
print v(xbgr.mr_n84596608)
print v(xbgr.mr_n84597040)
print v(xbgr.mr_n84597472)
print v(xbgr.mr_n84597904)
print v(xbgr.mr_n84598336)
print v(xbgr.mr_n84598768)
print v(xbgr.mr_n84599200)
print v(xbgr.mr_n84599632)
print v(xbgr.mr_n84600064)
print v(xbgr.mr_n84600496)
print v(xbgr.mr_n84600928)
print v(xbgr.mr_n84601360)
print v(xbgr.mr_n84601792)
print v(xbgr.mr_n84602224)
print v(xbgr.mr_n84602656)
print v(xbgr.mr_n84603088)
print v(xbgr.mr_n84603520)
print v(xbgr.mr_n84603952)
print v(xbgr.mr_n84604384)
print v(xbgr.mr_n84604816)
print v(xbgr.mr_n84605248)
print v(xbgr.mr_n84605680)
print v(xbgr.mr_n84606000)
print v(xbgr.mr_n84606432)
print v(xbgr.mr_n84606864)
print v(xbgr.mr_n84607296)
print v(xbgr.mr_n84607728)
print v(xbgr.mr_n84608160)
print v(xbgr.mr_n84608704)
print v(xbgr.mr_n84609136)
print v(xbgr.mr_n84609568)
print v(xbgr.mr_n84610000)
print v(xbgr.mr_n84610432)
print v(xbgr.mr_n84610864)
print v(xbgr.mr_n84611296)
print v(xbgr.mr_n84611728)
print v(xbgr.mr_n84612160)
print v(xbgr.mr_n84612592)
print v(xbgr.mr_n84613024)
print v(xbgr.mr_n84613456)
print v(xbgr.mr_n84613888)
print v(xbgr.mr_n84614320)
print v(xbgr.mr_n84614752)
print v(xbgr.mr_n84615184)
print v(xbgr.mr_n84615616)
print v(xbgr.mr_n84616048)
print v(xbgr.mr_n84616480)
print v(xbgr.mr_n84616912)
print v(xbgr.mr_n84617344)
print v(xbgr.mr_n84617776)
print v(xbgr.mr_n84618208)
print v(xbgr.mr_n84618640)
print v(xbgr.mr_n84619072)
print v(xbgr.mr_n84619504)
print v(xbgr.mr_n84619824)
print v(xbgr.mr_n84619936)
print v(xbgr.mr_n84620256)
print v(xbgr.mr_n84620368)
print v(xbgr.mr_n84620688)
print v(xbgr.mr_n84620800)
print v(xbgr.mr_n84621120)
print v(xbgr.mr_n84621232)
print v(xbgr.mr_n84621552)
print v(xbgr.mr_n84621664)
print v(xbgr.mr_n84621984)
print v(xbgr.mr_n84622096)
print v(xbgr.mr_n84622416)
print v(xbgr.mr_n84622528)
print v(xbgr.mr_n84622848)
print v(xbgr.mr_n84622960)
print v(xbgr.mr_n84623280)
print v(xbgr.mr_n84623392)
print v(xbgr.mr_n84623712)
print v(xbgr.mr_n84623824)
print v(xbgr.mr_n84624144)
print v(xbgr.mr_n84624256)
print v(xbgr.mr_n84624576)
print v(xbgr.mr_n84624688)
print v(xbgr.mr_n84625008)
print v(xbgr.mr_n84625120)
print v(xbgr.mr_n84625440)
print v(xbgr.mr_n84625552)
print v(xbgr.mr_n84625872)
print v(xbgr.mr_n84625984)
print v(xbgr.mr_n84626304)
print v(xbgr.mr_n84626736)
print v(xbgr.mr_n84626848)
print v(xbgr.mr_n84627168)
print v(xbgr.mr_n84627600)
print v(xbgr.mr_n84627712)
print v(xbgr.mr_n84628032)
print v(xbgr.mr_n84628144)
print v(xbgr.mr_n84628464)
print v(xbgr.mr_n84628576)
print v(xbgr.mr_n84628896)
print v(xbgr.mr_n84629008)
print v(xbgr.mr_n84629328)
print v(xbgr.mr_n84629440)
print v(xbgr.mr_n84629760)
print v(xbgr.mr_n84629872)
print v(xbgr.mr_n84630192)
print v(xbgr.mr_n84630304)
print v(xbgr.mr_n84630624)
print v(xbgr.mr_n84631056)
print v(xbgr.mr_n84631168)
print v(xbgr.mr_n84631488)
print v(xbgr.mr_n84631600)
print v(xbgr.mr_n84631920)
print v(xbgr.mr_n84632032)
print v(xbgr.mr_n84632352)
print v(xbgr.mr_n84632464)
print v(xbgr.mr_n84632784)
print v(xbgr.mr_n84632896)
print v(xbgr.mr_n84633216)
print v(xbgr.mr_n84633328)
print v(xbgr.mr_n84633648)
print v(xbgr.mr_n84633760)
print v(xbgr.mr_n84634080)
print v(xbgr.mr_n84634192)
print v(xbgr.mr_n84634512)
print v(xbgr.mr_n84634624)
print v(xbgr.mr_n84634944)
print v(xbgr.mr_n84635056)
print v(xbgr.mr_n84635376)
print v(xbgr.mr_n84635488)
print v(xbgr.mr_n84635808)
print v(xbgr.mr_n84636240)
print v(xbgr.mr_n84636352)
print v(xbgr.mr_n84636672)
print v(xbgr.mr_n84636784)
print v(xbgr.mr_n84637104)
print v(xbgr.mr_n84637216)
print v(xbgr.mr_n84637536)
print v(xbgr.mr_n84637648)
print v(xbgr.mr_n84637968)
print v(xbgr.mr_n84638080)
print v(xbgr.mr_n84638400)
print v(xbgr.mr_n84638512)
print v(xbgr.mr_n84638832)
print v(xbgr.mr_n84638944)
print v(xbgr.mr_n84639264)
print v(xbgr.mr_n84639376)
print v(xbgr.mr_n84639696)
print v(xbgr.mr_n84639808)
print v(xbgr.mr_n84640128)
print v(xbgr.mr_n84640240)
print v(xbgr.mr_n84640560)
print v(xbgr.mr_n84640672)
print v(xbgr.mr_n84640992)
print v(xbgr.mr_n84641104)
print v(xbgr.mr_n84641424)
print v(xbgr.mr_n84641536)
print v(xbgr.mr_n84641856)
print v(xbgr.mr_n84642288)
print v(xbgr.mr_n84642400)
print v(xbgr.mr_n84642720)
print v(xbgr.mr_n84642832)
print v(xbgr.mr_n84643152)
print v(xbgr.mr_n84643264)
print v(xbgr.mr_n84643584)
print v(xbgr.mr_n84643696)
print v(xbgr.mr_n84644016)
print v(xbgr.mr_n84644128)
print v(xbgr.mr_n84644448)
print v(xbgr.mr_n84644560)
print v(xbgr.mr_n84644880)
print v(xbgr.mr_n84644992)
print v(xbgr.mr_n84645312)
print v(xbgr.mr_n84645744)
print v(xbgr.mr_n84645856)
print v(xbgr.mr_n84646176)
print v(xbgr.mr_n84646608)
print v(xbgr.mr_n84646720)
print v(xbgr.mr_n84647040)
print v(xbgr.mr_n84647152)
print v(xbgr.mr_n84647472)
print v(xbgr.mr_n84647584)
print v(xbgr.mr_n84647904)
print v(xbgr.mr_n84648016)
print v(xbgr.mr_n84648336)
print v(xbgr.mr_n84648448)
print v(xbgr.mr_n84648768)
print v(xbgr.mr_n84648880)
print v(xbgr.mr_n84649200)
print v(xbgr.mr_n84649312)
print v(xbgr.mr_n84649632)
print v(xbgr.mr_n84649744)
print v(xbgr.mr_n84650064)
print v(xbgr.mr_n84650176)
print v(xbgr.mr_n84650496)
print v(xbgr.mr_n84650608)
print v(xbgr.mr_n84650928)
print v(xbgr.mr_n84651040)
print v(xbgr.mr_n84651360)
print v(xbgr.mr_n84651472)
print v(xbgr.mr_n84651904)
print v(xbgr.mr_n84652336)
print v(xbgr.mr_n84652768)
print v(xbgr.mr_n84653200)
print v(xbgr.mr_n84653632)
print v(xbgr.mr_n84654064)
print v(xbgr.mr_n84654496)
print v(xbgr.mr_n84654928)
print v(xbgr.mr_n84655360)
print v(xbgr.mr_n84655792)
print v(xbgr.mr_n84656224)
print v(xbgr.mr_n84656656)
print v(xbgr.mr_n84657088)
print v(xbgr.mr_n84657520)
print v(xbgr.mr_n84657952)
print v(xbgr.mr_n84658384)
print v(xbgr.mr_n84658816)
print v(xbgr.mr_n84659248)
print v(xbgr.mr_n84659680)
print v(xbgr.mr_n84660112)
print v(xbgr.mr_n84660544)
print v(xbgr.mr_n84660976)
print v(xbgr.mr_n84661408)
print v(xbgr.mr_n84661840)
print v(xbgr.mr_n84662272)
print v(xbgr.mr_n84662704)
print v(xbgr.mr_n84663136)
print v(xbgr.mr_n84663568)
print v(xbgr.mr_n84664000)
print v(xbgr.mr_n84664432)
print v(xbgr.mr_n84664864)
print v(xbgr.mr_n84665296)
print v(xbgr.mr_n84665728)
print v(xbgr.mr_n84666160)
print v(xbgr.mr_n84666592)
print v(xbgr.mr_n84667024)
print v(xbgr.mr_n84667456)
print v(xbgr.mr_n84667888)
print v(xbgr.mr_n84668320)
print v(xbgr.mr_n84668752)
print v(xbgr.mr_n84669184)
print v(xbgr.mr_n84669616)
print v(xbgr.mr_n84670048)
print v(xbgr.mr_n84670480)
print v(xbgr.mr_n84670912)
print v(xbgr.mr_n84671344)
print v(xbgr.mr_n84671776)
print v(xbgr.mr_n84672208)
print v(xbgr.mr_n84672640)
print v(xbgr.mr_n84673072)
print v(xbgr.mr_n84673504)
print v(xbgr.mr_n84673936)
print v(xbgr.mr_n84674368)
print v(xbgr.mr_n84674800)
print v(xbgr.mr_n84675232)
print v(xbgr.mr_n84675664)
print v(xbgr.mr_n84676096)
print v(xbgr.mr_n84676528)
print v(xbgr.mr_n84676960)
print v(xbgr.mr_n84677392)
print v(xbgr.mr_n84677824)
print v(xbgr.mr_n84678256)
print v(xbgr.mr_n84678688)
print v(xbgr.mr_n84679120)
print v(xbgr.mr_n84679552)
print v(xbgr.mr_n84679984)
print v(xbgr.mr_n84680416)
print v(xbgr.mr_n84680848)
print v(xbgr.mr_n84681280)
print v(xbgr.mr_n84681712)
print v(xbgr.mr_n84682144)
print v(xbgr.mr_n84682576)
print v(xbgr.mr_n84683008)
print v(xbgr.mr_n84683440)
print v(xbgr.mr_n84683872)
print v(xbgr.mr_n84684304)
print v(xbgr.mr_n84684736)
print v(xbgr.mr_n84685168)
print v(xbgr.mr_n84685488)
print v(xbgr.mr_n84685600)
print v(xbgr.mr_n84685920)
print v(xbgr.mr_n84686032)
print v(xbgr.mr_n84686464)
print v(xbgr.mr_n84686896)
print v(xbgr.mr_n84687216)
print v(xbgr.mr_n84687328)
print v(xbgr.mr_n84687648)
print v(xbgr.mr_n84688192)
print v(xbgr.mr_n84688624)
print v(xbgr.mr_n84688944)
print v(xbgr.mr_n84689056)
print v(xbgr.mr_n84689376)
print v(xbgr.mr_n84689488)
print v(xbgr.mr_n84689808)
print v(xbgr.mr_n84689920)
print v(xbgr.mr_n84690240)
print v(xbgr.mr_n84690352)
print v(xbgr.mr_n84690672)
print v(xbgr.mr_n84690784)
print v(xbgr.mr_n84691104)
print v(xbgr.mr_n84691216)
print v(xbgr.mr_n84691536)
print v(xbgr.mr_n84691648)
print v(xbgr.mr_n84691968)
print v(xbgr.mr_n84692080)
print v(xbgr.mr_n84692400)
print v(xbgr.mr_n84692512)
print v(xbgr.mr_n84692832)
print v(xbgr.mr_n84692944)
print v(xbgr.mr_n84693264)
print v(xbgr.mr_n84693376)
print v(xbgr.mr_n84693696)
print v(xbgr.mr_n84693808)
print v(xbgr.mr_n84694240)
print v(xbgr.mr_n84694672)
print v(xbgr.mr_n84694992)
print v(xbgr.mr_n84695104)
print v(xbgr.mr_n84695424)
print v(xbgr.mr_n84695536)
print v(xbgr.mr_n84695968)
print v(xbgr.mr_n84696400)
print v(xbgr.mr_n84696832)
print v(xbgr.mr_n84697264)
print v(xbgr.mr_n84697696)
print v(xbgr.mr_n84698128)
print v(xbgr.mr_n84698560)
print v(xbgr.mr_n84698992)
print v(xbgr.mr_n84699424)
print v(xbgr.mr_n84699856)
print v(xbgr.mr_n84700288)
print v(xbgr.mr_n84700720)
print v(xbgr.mr_n84701152)
print v(xbgr.mr_n84701584)
print v(xbgr.mr_n84702016)
print v(xbgr.mr_n84702448)
print v(xbgr.mr_n84702880)
print v(xbgr.mr_n84703312)
print v(xbgr.mr_n84703744)
print v(xbgr.mr_n84704176)
print v(xbgr.mr_n84704608)
print v(xbgr.mr_n84705040)
print v(xbgr.mr_n84705472)
print v(xbgr.mr_n84705904)
print v(xbgr.mr_n84706336)
print v(xbgr.mr_n84706768)
print v(xbgr.mr_n84707200)
print v(xbgr.mr_n84707632)
print v(xbgr.mr_n84708064)
print v(xbgr.mr_n84708496)
print v(xbgr.mr_n84708928)
print v(xbgr.mr_n84709360)
print v(xbgr.mr_n84709792)
print v(xbgr.mr_n84710224)
print v(xbgr.mr_n84710656)
print v(xbgr.mr_n84711088)
print v(xbgr.mr_n84711520)
print v(xbgr.mr_n84711952)
print v(xbgr.mr_n84712384)
print v(xbgr.mr_n84712816)
print v(xbgr.mr_n84713248)
print v(xbgr.mr_n84713680)
print v(xbgr.mr_n84714112)
print v(xbgr.mr_n84714544)
print v(xbgr.mr_n84714976)
print v(xbgr.mr_n84715408)
print v(xbgr.mr_n84715840)
print v(xbgr.mr_n84716272)
print v(xbgr.mr_n84716704)
print v(xbgr.mr_n84717136)
print v(xbgr.mr_n84717568)
print v(xbgr.mr_n84718000)
print v(xbgr.mr_n84718432)
print v(xbgr.mr_n84718864)
print v(xbgr.mr_n84719296)
print v(xbgr.mr_n84719728)
print v(xbgr.mr_n84720160)
print v(xbgr.mr_n84720592)
print v(xbgr.mr_n84721024)
print v(xbgr.mr_n84721456)
print v(xbgr.mr_n84721888)
print v(xbgr.mr_n84722320)
print v(xbgr.mr_n84722752)
print v(xbgr.mr_n84723184)
print v(xbgr.mr_n84723616)
print v(xbgr.mr_n84724048)
print v(xbgr.mr_n84724480)
print v(xbgr.mr_n84724912)
print v(xbgr.mr_n84725344)
print v(xbgr.mr_n84725776)
print v(xbgr.mr_n84726208)
print v(xbgr.mr_n84726640)
print v(xbgr.mr_n84727072)
print v(xbgr.mr_n84727504)
print v(xbgr.mr_n84727936)
print v(xbgr.mr_n84728368)
print v(xbgr.mr_n84728800)
print v(xbgr.mr_n84729232)
print v(xbgr.mr_n84729664)
print v(xbgr.mr_n84730096)
print v(xbgr.mr_n84730528)
print v(xbgr.mr_n84730960)
print v(xbgr.mr_n84731392)
print v(xbgr.mr_n84731824)
print v(xbgr.mr_n84732256)
print v(xbgr.mr_n84732688)
print v(xbgr.mr_n84733120)
print v(xbgr.mr_n84733552)
print v(xbgr.mr_n84733984)
print v(xbgr.mr_n84734416)
print v(xbgr.mr_n84734848)
print v(xbgr.mr_n84735280)
print v(xbgr.mr_n84735712)
print v(xbgr.mr_n84736144)
print v(xbgr.mr_n84736576)
print v(xbgr.mr_n84737008)
print v(xbgr.mr_n84737440)
print v(xbgr.mr_n84737872)
print v(xbgr.mr_n84738304)
print v(xbgr.mr_n84738736)
print v(xbgr.mr_n84739168)
print v(xbgr.mr_n84739600)
print v(xbgr.mr_n84740032)
print v(xbgr.mr_n84740464)
print v(xbgr.mr_n84740896)
print v(xbgr.mr_n84741328)
print v(xbgr.mr_n84741760)
print v(xbgr.mr_n84742192)
print v(xbgr.mr_n84742624)
print v(xbgr.mr_n84743056)
print v(xbgr.mr_n84743488)
print v(xbgr.mr_n84743920)
print v(xbgr.mr_n84744352)
print v(xbgr.mr_n84744784)
print v(xbgr.mr_n84745216)
print v(xbgr.mr_n84745648)
print v(xbgr.mr_n84746080)
print v(xbgr.mr_n84746512)
print v(xbgr.mr_n84746944)
print v(xbgr.mr_n84747376)
print v(xbgr.mr_n84747808)
print v(xbgr.mr_n84748240)
print v(xbgr.mr_n84748672)
print v(xbgr.mr_n84749104)
print v(xbgr.mr_n84749536)
print v(xbgr.mr_n84749968)
print v(xbgr.mr_n84750400)
print v(xbgr.mr_n84750832)
print v(xbgr.mr_n84751264)
print v(xbgr.mr_n84751696)
print v(xbgr.mr_n84752128)
print v(xbgr.mr_n84752560)
print v(xbgr.mr_n84752992)
print v(xbgr.mr_n84753424)
print v(xbgr.mr_n84753856)
print v(xbgr.mr_n84754288)
print v(xbgr.mr_n84754608)
print v(xbgr.mr_n84754720)
print v(xbgr.mr_n84755040)
print v(xbgr.mr_n84755152)
print v(xbgr.mr_n84755472)
print v(xbgr.mr_n84755584)
print v(xbgr.mr_n84755904)
print v(xbgr.mr_n84756016)
print v(xbgr.mr_n84756336)
print v(xbgr.mr_n84756448)
print v(xbgr.mr_n84756768)
print v(xbgr.mr_n84756880)
print v(xbgr.mr_n84757200)
print v(xbgr.mr_n84757312)
print v(xbgr.mr_n84757632)
print v(xbgr.mr_n84757744)
print v(xbgr.mr_n84758064)
print v(xbgr.mr_n84758176)
print v(xbgr.mr_n84758496)
print v(xbgr.mr_n84758608)
print v(xbgr.mr_n84758928)
print v(xbgr.mr_n84759040)
print v(xbgr.mr_n84759360)
print v(xbgr.mr_n84759472)
print v(xbgr.mr_n84759792)
print v(xbgr.mr_n84759904)
print v(xbgr.mr_n84760224)
print v(xbgr.mr_n84760336)
print v(xbgr.mr_n84760656)
print v(xbgr.mr_n84760768)
print v(xbgr.mr_n84761088)
print v(xbgr.mr_n84761200)
print v(xbgr.mr_n84761520)
print v(xbgr.mr_n84761632)
print v(xbgr.mr_n84761952)
print v(xbgr.mr_n84762064)
print v(xbgr.mr_n84762384)
print v(xbgr.mr_n84762496)
print v(xbgr.mr_n84762816)
print v(xbgr.mr_n84762928)
print v(xbgr.mr_n84763248)
print v(xbgr.mr_n84763360)
print v(xbgr.mr_n84763680)
print v(xbgr.mr_n84763792)
print v(xbgr.mr_n84764112)
print v(xbgr.mr_n84764224)
print v(xbgr.mr_n84764544)
print v(xbgr.mr_n84764656)
print v(xbgr.mr_n84764976)
print v(xbgr.mr_n84765088)
print v(xbgr.mr_n84765408)
print v(xbgr.mr_n84765520)
print v(xbgr.mr_n84765840)
print v(xbgr.mr_n84765952)
print v(xbgr.mr_n84766272)
print v(xbgr.mr_n84766384)
print v(xbgr.mr_n84766704)
print v(xbgr.mr_n84766816)
print v(xbgr.mr_n84767136)
print v(xbgr.mr_n84767248)
print v(xbgr.mr_n84767680)
print v(xbgr.mr_n84768112)
print v(xbgr.mr_n84768544)
print v(xbgr.mr_n84768976)
print v(xbgr.mr_n84769296)
print v(xbgr.mr_n84769408)
print v(xbgr.mr_n84769728)
print v(xbgr.mr_n84769840)
print v(xbgr.mr_n84770160)
print v(xbgr.mr_n84770272)
print v(xbgr.mr_n84770592)
print v(xbgr.mr_n84770704)
print v(xbgr.mr_n84771024)
print v(xbgr.mr_n84771136)
print v(xbgr.mr_n84771456)
print v(xbgr.mr_n84771568)
print v(xbgr.mr_n84772000)
print v(xbgr.mr_n84772432)
print v(xbgr.mr_n84772864)
print v(xbgr.mr_n84773184)
print v(xbgr.mr_n84773296)
print v(xbgr.mr_n84773616)
print v(xbgr.mr_n84773728)
print v(xbgr.mr_n84774048)
print v(xbgr.mr_n84774160)
print v(xbgr.mr_n84774480)
print v(xbgr.mr_n84774592)
print v(xbgr.mr_n84774912)
print v(xbgr.mr_n84775024)
print v(xbgr.mr_n84775344)
print v(xbgr.mr_n84775456)
print v(xbgr.mr_n84775776)
print v(xbgr.mr_n84775888)
print v(xbgr.mr_n84776208)
print v(xbgr.mr_n84776320)
print v(xbgr.mr_n84776640)
print v(xbgr.mr_n84776752)
print v(xbgr.mr_n84777072)
print v(xbgr.mr_n84777184)
print v(xbgr.mr_n84777616)
print v(xbgr.mr_n84778048)
print v(xbgr.mr_n84778480)
print v(xbgr.mr_n84778912)
print v(xbgr.mr_n84779344)
print v(xbgr.mr_n84779776)
print v(xbgr.mr_n84780208)
print v(xbgr.mr_n84780640)
print v(xbgr.mr_n84781072)
print v(xbgr.mr_n84781504)
print v(xbgr.mr_n84781936)
print v(xbgr.mr_n84782368)
print v(xbgr.mr_n84782800)
print v(xbgr.mr_n84783120)
print v(xbgr.mr_n84783232)
print v(xbgr.mr_n84783552)
print v(xbgr.mr_n84783664)
print v(xbgr.mr_n84783984)
print v(xbgr.mr_n84784096)
print v(xbgr.mr_n84784416)
print v(xbgr.mr_n84784528)
print v(xbgr.mr_n84784848)
print v(xbgr.mr_n84784960)
print v(xbgr.mr_n84785392)
print v(xbgr.mr_n84785824)
print v(xbgr.mr_n84786256)
print v(xbgr.mr_n84786688)
print v(xbgr.mr_n84787120)
print v(xbgr.mr_n84787552)
print v(xbgr.mr_n84787872)
print v(xbgr.mr_n84787984)
print v(xbgr.mr_n84788304)
print v(xbgr.mr_n84788416)
print v(xbgr.mr_n84788848)
print v(xbgr.mr_n84789280)
print v(xbgr.mr_n84789600)
print v(xbgr.mr_n84789712)
print v(xbgr.mr_n84790032)
print v(xbgr.mr_n84790144)
print v(xbgr.mr_n84790464)
print v(xbgr.mr_n84790576)
print v(xbgr.mr_n84790896)
print v(xbgr.mr_n84791008)
print v(xbgr.mr_n84791328)
print v(xbgr.mr_n84791440)
print v(xbgr.mr_n84791760)
print v(xbgr.mr_n84791872)
print v(xbgr.mr_n84792192)
print v(xbgr.mr_n84792304)
print v(xbgr.mr_n84792624)
print v(xbgr.mr_n84792736)
print v(xbgr.mr_n84793056)
print v(xbgr.mr_n84793168)
print v(xbgr.mr_n84793488)
print v(xbgr.mr_n84793600)
print v(xbgr.mr_n84793920)
print v(xbgr.mr_n84794032)
print v(xbgr.mr_n84794352)
print v(xbgr.mr_n84794464)
print v(xbgr.mr_n84794784)
print v(xbgr.mr_n84794896)
print v(xbgr.mr_n84795216)
print v(xbgr.mr_n84795328)
print v(xbgr.mr_n84795760)
print v(xbgr.mr_n84796192)
print v(xbgr.mr_n84796512)
print v(xbgr.mr_n84796624)
print v(xbgr.mr_n84796944)
print v(xbgr.mr_n84797056)
print v(xbgr.mr_n84797376)
print v(xbgr.mr_n84797488)
print v(xbgr.mr_n84797808)
print v(xbgr.mr_n84797920)
print v(xbgr.mr_n84798240)
print v(xbgr.mr_n84798352)
print v(xbgr.mr_n84798672)
print v(xbgr.mr_n84798784)
print v(xbgr.mr_n84799216)
print v(xbgr.mr_n84799648)
print v(xbgr.mr_n84799968)
print v(xbgr.mr_n84800080)
print v(xbgr.mr_n84800400)
print v(xbgr.mr_n84800512)
print v(xbgr.mr_n84800832)
print v(xbgr.mr_n84800944)
print v(xbgr.mr_n84801264)
print v(xbgr.mr_n84801376)
print v(xbgr.mr_n84801696)
print v(xbgr.mr_n84801808)
print v(xbgr.mr_n84802128)
print v(xbgr.mr_n84802240)
print v(xbgr.mr_n84802560)
print v(xbgr.mr_n84802672)
print v(xbgr.mr_n84802992)
print v(xbgr.mr_n84803104)
print v(xbgr.mr_n84803424)
print v(xbgr.mr_n84803536)
print v(xbgr.mr_n84803856)
print v(xbgr.mr_n84803968)
print v(xbgr.mr_n84804288)
print v(xbgr.mr_n84804400)
print v(xbgr.mr_n84804720)
print v(xbgr.mr_n84804832)
print v(xbgr.mr_n84805152)
print v(xbgr.mr_n84805264)
print v(xbgr.mr_n84805584)
print v(xbgr.mr_n84805696)
print v(xbgr.mr_n84806016)
print v(xbgr.mr_n84806128)
print v(xbgr.mr_n84806448)
print v(xbgr.mr_n84806560)
print v(xbgr.mr_n84806880)
print v(xbgr.mr_n84806992)
print v(xbgr.mr_n84807312)
print v(xbgr.mr_n84807424)
print v(xbgr.mr_n84807744)
print v(xbgr.mr_n84807856)
print v(xbgr.mr_n84808176)
print v(xbgr.mr_n84808288)
print v(xbgr.mr_n84808608)
print v(xbgr.mr_n84808720)
print v(xbgr.mr_n84809040)
print v(xbgr.mr_n84809152)
print v(xbgr.mr_n84809472)
print v(xbgr.mr_n84809584)
print v(xbgr.mr_n84809904)
print v(xbgr.mr_n84810016)
print v(xbgr.mr_n84810336)
print v(xbgr.mr_n84810448)
print v(xbgr.mr_n84810768)
print v(xbgr.mr_n84810880)
print v(xbgr.mr_n84811200)
print v(xbgr.mr_n84811312)
print v(xbgr.mr_n84811632)
print v(xbgr.mr_n84811744)
print v(xbgr.mr_n84812064)
print v(xbgr.mr_n84812176)
print v(xbgr.mr_n84812496)
print v(xbgr.mr_n84812608)
print v(xbgr.mr_n84812928)
print v(xbgr.mr_n84813040)
print v(xbgr.mr_n84813360)
print v(xbgr.mr_n84813472)
print v(xbgr.mr_n84813792)
print v(xbgr.mr_n84813904)
print v(xbgr.mr_n84814224)
print v(xbgr.mr_n84814336)
print v(xbgr.mr_n84814656)
print v(xbgr.mr_n84814768)
print v(xbgr.mr_n84815088)
print v(xbgr.mr_n84815200)
print v(xbgr.mr_n84815520)
print v(xbgr.mr_n84815632)
print v(xbgr.mr_n84815952)
print v(xbgr.mr_n84816064)
print v(xbgr.mr_n84816384)
print v(xbgr.mr_n84816496)
print v(xbgr.mr_n84816816)
print v(xbgr.mr_n84816928)
print v(xbgr.mr_n84817248)
print v(xbgr.mr_n84817360)
print v(xbgr.mr_n84817680)
print v(xbgr.mr_n84817792)
print v(xbgr.mr_n84818112)
print v(xbgr.mr_n84818224)
print v(xbgr.mr_n84818544)
print v(xbgr.mr_n84818656)
print v(xbgr.mr_n84818976)
print v(xbgr.mr_n84819088)
print v(xbgr.mr_n84819408)
print v(xbgr.mr_n84819520)
print v(xbgr.mr_n84819840)
print v(xbgr.mr_n84819952)
print v(xbgr.mr_n84820272)
print v(xbgr.mr_n84820384)
print v(xbgr.mr_n84820704)
print v(xbgr.mr_n84820816)
print v(xbgr.mr_n84821136)
print v(xbgr.mr_n84821248)
print v(xbgr.mr_n84821568)
print v(xbgr.mr_n84821680)
print v(xbgr.mr_n84822000)
print v(xbgr.mr_n84822112)
print v(xbgr.mr_n84822432)
print v(xbgr.mr_n84822544)
print v(xbgr.mr_n84822864)
print v(xbgr.mr_n84822976)
print v(xbgr.mr_n84823296)
print v(xbgr.mr_n84823408)
print v(xbgr.mr_n84823728)
print v(xbgr.mr_n84823840)
print v(xbgr.mr_n84824160)
print v(xbgr.mr_n84824272)
print v(xbgr.mr_n84824592)
print v(xbgr.mr_n84824704)
print v(xbgr.mr_n84825024)
print v(xbgr.mr_n84825136)
print v(xbgr.mr_n84825456)
print v(xbgr.mr_n84825568)
print v(xbgr.mr_n84825888)
print v(xbgr.mr_n84826000)
print v(xbgr.mr_n84826320)
print v(xbgr.mr_n84826432)
print v(xbgr.mr_n84826752)
print v(xbgr.mr_n84826864)
print v(xbgr.mr_n84827184)
print v(xbgr.mr_n84827296)
print v(xbgr.mr_n84827616)
print v(xbgr.mr_n84827728)
print v(xbgr.mr_n84828048)
print v(xbgr.mr_n84828160)
print v(xbgr.mr_n84828480)
print v(xbgr.mr_n84828592)
print v(xbgr.mr_n84828912)
print v(xbgr.mr_n84829024)
print v(xbgr.mr_n84829344)
print v(xbgr.mr_n84829456)
print v(xbgr.mr_n84829776)
print v(xbgr.mr_n84829888)
print v(xbgr.mr_n84830208)
print v(xbgr.mr_n84830320)
print v(xbgr.mr_n84830640)
print v(xbgr.mr_n84830752)
print v(xbgr.mr_n84831072)
print v(xbgr.mr_n84831184)
print v(xbgr.mr_n84831504)
print v(xbgr.mr_n84831616)
print v(xbgr.mr_n84831936)
print v(xbgr.mr_n84832048)
print v(xbgr.mr_n84832368)
print v(xbgr.mr_n84832480)
print v(xbgr.mr_n84832800)
print v(xbgr.mr_n84832912)
print v(xbgr.mr_n84833232)
print v(xbgr.mr_n84833344)
print v(xbgr.mr_n84833664)
print v(xbgr.mr_n84833776)
print v(xbgr.mr_n84834096)
print v(xbgr.mr_n84834208)
print v(xbgr.mr_n84834528)
print v(xbgr.mr_n84834640)
print v(xbgr.mr_n84834960)
print v(xbgr.mr_n84835072)
print v(xbgr.mr_n84835392)
print v(xbgr.mr_n84835504)
print v(xbgr.mr_n84835824)
print v(xbgr.mr_n84835936)
print v(xbgr.mr_n84836256)
print v(xbgr.mr_n84836368)
print v(xbgr.mr_n84836688)
print v(xbgr.mr_n84836800)
print v(xbgr.mr_n84837120)
print v(xbgr.mr_n84837232)
print v(xbgr.mr_n84837552)
print v(xbgr.mr_n84837664)
print v(xbgr.mr_n84837984)
print v(xbgr.mr_n84838096)
print v(xbgr.mr_n84838416)
print v(xbgr.mr_n84838528)
print v(xbgr.mr_n84838848)
print v(xbgr.mr_n84838960)
print v(xbgr.mr_n84839280)
print v(xbgr.mr_n84839392)
print v(xbgr.mr_n84839712)
print v(xbgr.mr_n84839824)
print v(xbgr.mr_n84840144)
print v(xbgr.mr_n84840256)
print v(xbgr.mr_n84840576)
print v(xbgr.mr_n84840688)
print v(xbgr.mr_n84841008)
print v(xbgr.mr_n84841120)
print v(xbgr.mr_n84841440)
print v(xbgr.mr_n84841552)
print v(xbgr.mr_n84841872)
print v(xbgr.mr_n84841984)
print v(xbgr.mr_n84842304)
print v(xbgr.mr_n84842416)
print v(xbgr.mr_n84842736)
print v(xbgr.mr_n84842848)
print v(xbgr.mr_n84843168)
print v(xbgr.mr_n84843280)
print v(xbgr.mr_n84843600)
print v(xbgr.mr_n84843712)
print v(xbgr.mr_n84844032)
print v(xbgr.mr_n84844144)
print v(xbgr.mr_n84844464)
print v(xbgr.mr_n84844576)
print v(xbgr.mr_n84844896)
print v(xbgr.mr_n84845008)
print v(xbgr.mr_n84845328)
print v(xbgr.mr_n84845440)
print v(xbgr.mr_n84845760)
print v(xbgr.mr_n84845872)
print v(xbgr.mr_n84846192)
print v(xbgr.mr_n84846304)
print v(xbgr.mr_n84846624)
print v(xbgr.mr_n84846736)
print v(xbgr.mr_n84847056)
print v(xbgr.mr_n84847168)
print v(xbgr.mr_n84847488)
print v(xbgr.mr_n84847600)
print v(xbgr.mr_n84847920)
print v(xbgr.mr_n84848032)
print v(xbgr.mr_n84848352)
print v(xbgr.mr_n84848464)
print v(xbgr.mr_n84848784)
print v(xbgr.mr_n84848896)
print v(xbgr.mr_n84849216)
print v(xbgr.mr_n84849328)
print v(xbgr.mr_n84849648)
print v(xbgr.mr_n84849760)
print v(xbgr.mr_n84850080)
print v(xbgr.mr_n84850192)
print v(xbgr.mr_n84850624)
print v(xbgr.mr_n84851056)
print v(xbgr.mr_n84851488)
print v(xbgr.mr_n84851920)
print v(xbgr.mr_n84852352)
print v(xbgr.mr_n84852784)
print v(xbgr.mr_n84853216)
print v(xbgr.mr_n84853648)
print v(xbgr.mr_n84854080)
print v(xbgr.mr_n84854512)
print v(xbgr.mr_n84854944)
print v(xbgr.mr_n84855376)
print v(xbgr.mr_n84855808)
print v(xbgr.mr_n84856240)
print v(xbgr.mr_n84856672)
print v(xbgr.mr_n84857104)
print v(xbgr.mr_n84857536)
print v(xbgr.mr_n84857968)
print v(xbgr.mr_n84858400)
print v(xbgr.mr_n84858832)
print v(xbgr.mr_n84859264)
print v(xbgr.mr_n84859696)
print v(xbgr.mr_n84860128)
print v(xbgr.mr_n84860560)
print v(xbgr.mr_n84860992)
print v(xbgr.mr_n84861424)
print v(xbgr.mr_n84861856)
print v(xbgr.mr_n84862288)
print v(xbgr.mr_n84862720)
print v(xbgr.mr_n84863152)
print v(xbgr.mr_n84863584)
print v(xbgr.mr_n84864016)
print v(xbgr.mr_n84864448)
print v(xbgr.mr_n84864880)
print v(xbgr.mr_n84865200)
print v(xbgr.mr_n84865312)
print v(xbgr.mr_n84865632)
print v(xbgr.mr_n84865744)
print v(xbgr.mr_n84866176)
print v(xbgr.mr_n84866496)
print v(xbgr.mr_n84866608)
print v(xbgr.mr_n84866928)
print v(xbgr.mr_n84867040)
print v(xbgr.mr_n84867360)
print v(xbgr.mr_n84867472)
print v(xbgr.mr_n84867792)
print v(xbgr.mr_n84867904)
print v(xbgr.mr_n84868224)
print v(xbgr.mr_n84868336)
print v(xbgr.mr_n84868656)
print v(xbgr.mr_n84868768)
print v(xbgr.mr_n84869088)
print v(xbgr.mr_n84869200)
print v(xbgr.mr_n84869520)
print v(xbgr.mr_n84869632)
print v(xbgr.mr_n84870064)
print v(xbgr.mr_n84870496)
print v(xbgr.mr_n84870928)
print v(xbgr.mr_n84871360)
print v(xbgr.mr_n84871792)
print v(xbgr.mr_n84872224)
print v(xbgr.mr_n84872656)
print v(xbgr.mr_n84873088)
print v(xbgr.mr_n84873520)
print v(xbgr.mr_n84873840)
print v(xbgr.mr_n84873952)
print v(xbgr.mr_n84874272)
print v(xbgr.mr_n84874384)
print v(xbgr.mr_n84874704)
print v(xbgr.mr_n84874816)
print v(xbgr.mr_n84875136)
print v(xbgr.mr_n84875248)
print v(xbgr.mr_n84875680)
print v(xbgr.mr_n84876112)
print v(xbgr.mr_n84876544)
print v(xbgr.mr_n84876976)
print v(xbgr.mr_n84877408)
print v(xbgr.mr_n84877840)
print v(xbgr.mr_n84878272)
print v(xbgr.mr_n84878704)
print v(xbgr.mr_n84879136)
print v(xbgr.mr_n84879568)
print v(xbgr.mr_n84880000)
print v(xbgr.mr_n84880432)
print v(xbgr.mr_n84880864)
print v(xbgr.mr_n84881296)
print v(xbgr.mr_n84881728)
print v(xbgr.mr_n84882160)
print v(xbgr.mr_n84882592)
print v(xbgr.mr_n84883024)
print v(xbgr.mr_n84883456)
print v(xbgr.mr_n84883888)
print v(xbgr.mr_n84884320)
print v(xbgr.mr_n84884752)
print v(xbgr.mr_n84885184)
print v(xbgr.mr_n84885616)
print v(xbgr.mr_n84886048)
print v(xbgr.mr_n84886480)
print v(xbgr.mr_n84886912)
print v(xbgr.mr_n84887344)
print v(xbgr.mr_n84887776)
print v(xbgr.mr_n84888096)
print v(xbgr.mr_n84888208)
print v(xbgr.mr_n84888528)
print v(xbgr.mr_n84888640)
print v(xbgr.mr_n84888960)
print v(xbgr.mr_n84889072)
print v(xbgr.mr_n84889392)
print v(xbgr.mr_n84889504)
print v(xbgr.mr_n84889824)
print v(xbgr.mr_n84889936)
print v(xbgr.mr_n84890256)
print v(xbgr.mr_n84890368)
print v(xbgr.mr_n85152848)
print v(xbgr.mr_n85153632)
print v(xbgr.mr_n85154496)
print v(xbgr.mr_n85154608)
print v(xbgr.mr_n85154928)
print v(xbgr.mr_n85155360)
print v(xbgr.mr_n85155792)
print v(xbgr.mr_n85156224)
print v(xbgr.mr_n85156336)
print v(xbgr.mr_n85156656)
print v(xbgr.mr_n85157088)
print v(xbgr.mr_n85157520)
print v(xbgr.mr_n85157952)
print v(xbgr.mr_n85158064)
print v(xbgr.mr_n85158384)
print v(xbgr.mr_n85158496)
print v(xbgr.mr_n85158816)
print v(xbgr.mr_n85158928)
print v(xbgr.mr_n85159360)
print v(xbgr.mr_n85159792)
print v(xbgr.mr_n85160224)
print v(xbgr.mr_n85160544)
print v(xbgr.mr_n85161408)
print v(xbgr.mr_n85161520)
print v(xbgr.mr_n85161840)
print v(xbgr.mr_n85161952)
print v(xbgr.mr_n85162272)
print v(xbgr.mr_n85163248)
print v(xbgr.mr_n85163680)
print v(xbgr.mr_n85164000)
print v(xbgr.mr_n85164864)
print v(xbgr.mr_n85164976)
print v(xbgr.mr_n85165296)
print v(xbgr.mr_n85165408)
print v(xbgr.mr_n85165728)
print v(xbgr.mr_n85165840)
print v(xbgr.mr_n85168336)
print v(xbgr.mr_n85168768)
print v(xbgr.mr_n85169088)
print v(xbgr.mr_n85170064)
print v(xbgr.mr_n85170384)
print v(xbgr.mr_n85171360)
print v(xbgr.mr_n85171680)
print v(xbgr.mr_n85172656)
print v(xbgr.mr_n85172976)
print v(xbgr.mr_n85173088)
print v(xbgr.mr_n85173520)
print v(xbgr.mr_n85173952)
print v(xbgr.mr_n85174272)
print v(xbgr.mr_n85175248)
print v(xbgr.mr_n85175568)
print v(xbgr.mr_n85176544)
print v(xbgr.mr_n85176864)
print v(xbgr.mr_n85177840)
print v(xbgr.mr_n85178272)
print v(xbgr.mr_n85178704)
print v(xbgr.mr_n85179136)
print v(xbgr.mr_n85179568)
print v(xbgr.mr_n85180000)
print v(xbgr.mr_n85180432)
print v(xbgr.mr_n85180864)
print v(xbgr.mr_n85181296)
print v(xbgr.mr_n85181728)
print v(xbgr.mr_n85182160)
print v(xbgr.mr_n85182592)
print v(xbgr.mr_n85183024)
print v(xbgr.mr_n85183456)
print v(xbgr.mr_n85183888)
print v(xbgr.mr_n85184320)
print v(xbgr.mr_n85184752)
print v(xbgr.mr_n85185184)
print v(xbgr.mr_n85185616)
print v(xbgr.mr_n85186048)
print v(xbgr.mr_n85186480)
print v(xbgr.mr_n85186912)
print v(xbgr.mr_n85187344)
print v(xbgr.mr_n85187776)
print v(xbgr.mr_n85188208)
print v(xbgr.mr_n85247712)
print v(xbgr.mr_n85247856)
print v(xbgr.mr_n85248096)
print v(xbgr.mr_n85248288)
print v(xbgr.mr_n85249184)
print v(xbgr.mr_n85249584)
print v(xbgr.mr_n85249968)
print v(xbgr.mr_n85251040)
print v(xbgr.mr_n85251424)
print v(xbgr.mr_n85252768)
print v(xbgr.mr_n85253216)
print v(xbgr.mr_n85254896)
print v(xbgr.mr_n85257472)
print v(xbgr.mr_n85257648)
print v(xbgr.mr_n85258224)
print v(xbgr.mr_n85258480)
print v(xbgr.mr_n85259792)
print v(xbgr.mr_n85260720)
print v(xbgr.mr_n85261584)
print v(xbgr.mr_n85261888)
print v(xbgr.mr_n85262640)
print v(xbgr.mr_n85262752)
print v(xbgr.mr_n85262960)
print v(xbgr.mr_n85263296)
print v(xbgr.mr_n85264880)
print v(xbgr.mr_n85265264)
print v(xbgr.mr_n85266368)
print v(xbgr.mr_n85267232)
print v(xbgr.mr_n85267504)
print v(xbgr.mr_n85267904)
print v(xbgr.mr_n85268112)
print v(xbgr.mr_n85268720)
print v(xbgr.mr_n85270000)
print v(xbgr.mr_n85270944)
print v(xbgr.mr_n85272544)
print v(xbgr.mr_n85274416)
print v(xbgr.mr_n85274864)
print v(xbgr.mr_n85275264)
print v(xbgr.mr_n85276208)
print v(xbgr.mr_n85277488)
print v(xbgr.mr_n85278384)
print v(xbgr.mr_n85278896)
print v(xbgr.mr_n85279536)
print v(xbgr.mr_n85280752)
print v(xbgr.mr_n85280928)
print v(xbgr.mr_n85283824)
print v(xbgr.mr_n85284336)
print v(xbgr.mr_n85285232)
print v(xbgr.mr_n85286064)
print v(xbgr.mr_n85286304)
print v(xbgr.mr_n85288752)
print v(xbgr.mr_n85288992)
print v(xbgr.mr_n85289136)
print v(xbgr.mr_n85289440)
print v(xbgr.mr_n85382544)
print v(xbgr.mr_n85386400)
print v(xbgr.mr_n85394528)
print v(xbgr.mr_n85403728)
print v(xbgr.mr_n85404384)
print v(xbgr.mr_n85410848)
print v(xbgr.mr_n85412240)
print v(xbgr.mr_n85416848)
print v(xbgr.mr_n85419296)
print v(xbgr.mr_n85425424)
print v(xbgr.mr_n85430032)
print v(xbgr.mr_n85503248)
print v(xbgr.mr_n85503696)
print v(xbgr.mr_n85504832)
print v(xbgr.mr_n85506832)
print v(xbgr.mr_n85507280)
print v(xbgr.mr_n85507968)
print v(xbgr.mr_n85508240)
print v(xbgr.mr_n85508416)
print v(xbgr.mr_n85509072)
print v(xbgr.mr_n85509520)
print v(xbgr.mr_n85509760)
print v(xbgr.mr_n85512240)
print v(xbgr.mr_n85514240)
print v(xbgr.mr_n85518304)
print v(xbgr.mr_n85518480)
print v(xbgr.mr_n85519824)
print v(xbgr.mr_n85520512)
print v(xbgr.mr_n85520960)
print v(xbgr.mr_n85521168)
print v(xbgr.mr_n85521408)
print v(xbgr.mr_n85522064)
print v(xbgr.mr_n85522304)
print v(xbgr.mr_n85522848)
print v(xbgr.mr_n85523824)
print v(xbgr.mr_n85524816)
print v(xbgr.mr_n85525328)
print v(xbgr.mr_n85526544)
print v(xbgr.mr_n85526880)
print v(xbgr.mr_n85527232)
print v(xbgr.mr_n85528336)
print v(xbgr.mr_n85528672)
print v(xbgr.mr_n85529120)
print v(xbgr.mr_n85530640)
print v(xbgr.mr_n85531088)
print v(xbgr.mr_n85532880)
print v(xbgr.mr_n85533392)
print v(xbgr.mr_n85534160)
print v(xbgr.mr_n85535504)
print v(xbgr.mr_n85549984)
print v(xbgr.mr_n85550640)
print v(xbgr.mr_n85550784)
print v(xbgr.mr_n85551856)
print v(xbgr.mr_n85556432)
print v(xbgr.mr_n85561616)
print v(xbgr.mr_n85563888)
print v(xbgr.mr_n85564432)
print v(xbgr.mr_n85601952)
print v(xbgr.mr_n85604704)
print v(xbgr.mr_n85605424)
print v(xbgr.mr_n85610576)
print v(xbgr.mr_n85611552)
print v(xbgr.mr_n85612352)
print v(xbgr.mr_n85614080)
print v(xbgr.mr_n85622832)
print v(xbgr.mr_n85624416)
print v(xbgr.mr_n85628720)
print v(xbgr.mr_n85631520)
print v(xbgr.mr_n85632064)
print v(xbgr.mr_n85632320)
print v(xbgr.mr_n85632656)
print v(xbgr.mr_n85632880)
print v(xbgr.mr_n85636752)
print v(xbgr.mr_n85636928)
print v(xbgr.mr_n85637168)
print v(xbgr.mr_n85637776)
print v(xbgr.mr_n85637984)
print v(xbgr.mr_n85639328)
print v(xbgr.mr_n85639600)
print v(xbgr.mr_n85668496)
print v(xbgr.mr_n85669424)
print v(xbgr.mr_n85669632)
print v(xbgr.mr_n85672816)
print v(xbgr.mr_n85688672)
print v(xbgr.mr_n85690016)
print v(xbgr.mr_n85690416)
print v(xbgr.mr_n85693920)
print v(xbgr.mr_n85695200)
print v(xbgr.mr_n85699024)
print v(xbgr.mr_n85929968)
print v(xbgr.mr_n85931008)
print v(xbgr.mr_n85963088)
print v(xbgr.mr_n85963856)
print v(xbgr.mr_n85964144)
print v(xbgr.mr_n85965088)
print v(xbgr.mr_n85965888)
print v(xbgr.mr_n85966144)
print v(xbgr.mr_n86017488)
print v(xbgr.mr_n86025824)
print v(xbgr.mr_n86026256)
print v(xbgr.mr_n86030432)
print v(xbgr.mr_n86032992)
print v(xbgr.mr_n86034208)
print v(xbgr.mr_n86038416)
print v(xbgr.mr_n86039376)
print v(xbgr.mr_n86062992)
print v(xbgr.mr_n86064176)
print v(xbgr.mr_n86067808)
print v(xbgr.mr_n86069648)
print v(xbgr.mr_n86070944)
print v(xbgr.mr_n86074528)
print v(xbgr.mr_n86078304)
print v(xbgr.mr_n86080192)
print v(xbgr.mr_n86080368)
print v(xbgr.mr_n86093488)
print v(xbgr.mr_n86094560)
print v(xbgr.mr_n86095792)
print v(xbgr.mr_n86100848)
print v(xbgr.mr_n86103360)
print v(xbgr.mr_n86104208)
print v(xbgr.mr_n86106448)
print v(xbgr.mr_n86108784)
print v(xbgr.mr_n86109584)
print v(xbgr.mr_n86111248)
print v(xbgr.mr_n86111360)
print v(xbgr.mr_n86111472)
print v(xbgr.mr_n86111584)
print v(xbgr.mr_n86111888)
print v(xbgr.mr_n86112160)
print v(xbgr.mr_n86112432)
print v(xbgr.mr_n86114544)
print v(xbgr.mr_n86115008)
print v(xbgr.mr_n86115472)
print v(xbgr.mr_n86115936)
print v(xbgr.mr_n86116400)
print v(xbgr.mr_n86116864)
print v(xbgr.mr_n86117328)
print v(xbgr.mr_n86117792)
print v(xbgr.mr_n86118256)
print v(xbgr.mr_n86118720)
print v(xbgr.mr_n86119184)
print v(xbgr.mr_n86125232)
print v(xbgr.mr_n86126272)
print v(xbgr.mr_n86126992)
print v(xbgr.mr_n86127664)
print v(xbgr.mr_n86128704)
print v(xbgr.mr_n86128880)
print v(xbgr.mr_n86133792)
print v(xbgr.mr_n86134288)
print v(xbgr.mr_n86135504)
print v(xbgr.mr_n86135936)
print v(xbgr.mr_n86137152)
print v(xbgr.mr_n86137936)
print v(xbgr.mr_n86138608)
print v(xbgr.mr_n86140464)
print v(xbgr.mr_n86141872)
print v(xbgr.mr_n86142816)
print v(xbgr.mr_n86143072)
print v(xbgr.mr_n86143280)
print v(xbgr.mr_n86146096)
print v(xbgr.mr_n86147296)
print v(xbgr.mr_n86147504)
print v(xbgr.mr_n86149408)
print v(xbgr.mr_n86152496)
print v(xbgr.mr_n86153136)
print v(xbgr.mr_n86153632)
print v(xbgr.mr_n86154544)
print v(xbgr.mr_n86160768)
print v(xbgr.mr_n86163488)
print v(xbgr.mr_n86165600)
print v(xbgr.mr_n86166576)
print v(xbgr.mr_n86167584)
print v(xbgr.mr_n86167920)
print v(xbgr.mr_n86168224)
print v(xbgr.mr_n86168416)
print v(xbgr.mr_n86168624)
print v(xbgr.mr_n86170800)
print v(xbgr.mr_n86170976)
print v(xbgr.mr_n86173616)
print v(xbgr.mr_n86175456)
print v(xbgr.mr_n86175632)
print v(xbgr.mr_n86177216)
print v(xbgr.mr_n86177872)
print v(xbgr.mr_n86178480)
print v(xbgr.mr_n86178864)
print v(xbgr.mr_n86179680)
print v(xbgr.mr_n86179952)
print v(xbgr.mr_n86182064)
print v(xbgr.mr_n86182528)
print v(xbgr.mr_n86186016)
print v(xbgr.mr_n86186928)
print v(xbgr.mr_n86187504)
print v(xbgr.mr_n86188400)
print v(xbgr.mr_n86189536)
print v(xbgr.mr_n86191952)
print v(xbgr.mr_n86192384)
print v(xbgr.mr_n86194352)
print v(xbgr.mr_n86199456)
print v(xbgr.mr_n86201328)
print v(xbgr.mr_n86201792)
print v(xbgr.mr_n86202256)
print v(xbgr.mr_n86202720)
print v(xbgr.mr_n86203184)
print v(xbgr.mr_n86203648)
print v(xbgr.mr_n86204112)
print v(xbgr.mr_n86204576)
print v(xbgr.mr_n86205040)
print v(xbgr.mr_n86205504)
print v(xbgr.mr_n86205968)
print v(xbgr.mr_n86206512)
print v(xbgr.mr_n86207312)
print v(xbgr.mr_n86207680)
print v(xbgr.mr_n86208352)
print v(xbgr.mr_n86210720)
print v(xbgr.mr_n86212000)
print v(xbgr.mr_n86213424)
print v(xbgr.mr_n86213760)
print v(xbgr.mr_n86214432)
print v(xbgr.mr_n86215984)
print v(xbgr.mr_n86216192)
print v(xbgr.mr_n86216800)
print v(xbgr.mr_n86217408)
print v(xbgr.mr_n86219536)
print v(xbgr.mr_n86220320)
print v(xbgr.mr_n86222272)
print v(xbgr.mr_n86225552)
print v(xbgr.mr_n86225728)
print v(xbgr.mr_n86226464)
print v(xbgr.mr_n86227072)
print v(xbgr.mr_n86227248)
print v(xbgr.mr_n86229200)
print v(xbgr.mr_n86230176)
print v(xbgr.mr_n86230720)
print v(xbgr.mr_n86231088)
print v(xbgr.mr_n86231936)
print v(xbgr.mr_n86233488)
print v(xbgr.mr_n86235040)
print v(xbgr.mr_n86235584)
print v(xbgr.mr_n86236256)
print v(xbgr.mr_n86236864)
print v(xbgr.mr_n86238304)
print v(xbgr.mr_n86240976)
print v(xbgr.mr_n86243344)
print v(xbgr.mr_n86247504)
print v(xbgr.mr_n86249424)
print v(xbgr.mr_n86250096)
print v(xbgr.mr_n86250288)
print v(xbgr.mr_n86252400)
print v(xbgr.mr_n86252864)
print v(xbgr.mr_n86253328)
print v(xbgr.mr_n86253792)
print v(xbgr.mr_n86254256)
print v(xbgr.mr_n86254720)
print v(xbgr.mr_n86255184)
print v(xbgr.mr_n86255648)
print v(xbgr.mr_n86256112)
print v(xbgr.mr_n86256576)
print v(xbgr.mr_n86257040)
print v(xbgr.mr_n86257504)
print v(xbgr.mr_n86257968)
print v(xbgr.mr_n86258240)
print v(xbgr.mr_n86258432)
print v(xbgr.mr_n86258896)
print v(xbgr.mr_n86259360)
print v(xbgr.mr_n86259824)
print v(xbgr.mr_n86260288)
print v(xbgr.mr_n86260752)
print v(xbgr.mr_n86261216)
print v(xbgr.mr_n86261680)
print v(xbgr.mr_n86262144)
print v(xbgr.mr_n86262608)
print v(xbgr.mr_n86263072)
print v(xbgr.mr_n86263536)
print v(xbgr.mr_n86264000)
print v(xbgr.mr_n86264464)
print v(xbgr.mr_n86264928)
print v(xbgr.mr_n86265392)
print v(xbgr.mr_n86265856)
print v(xbgr.mr_n86266320)
print v(xbgr.mr_n86266784)
print v(xbgr.mr_n86267248)
print v(xbgr.mr_n86267712)
print v(xbgr.mr_n86268176)
print v(xbgr.mr_n86268640)
print v(xbgr.mr_n86269104)
print v(xbgr.mr_n86269568)
print v(xbgr.mr_n86270032)
print v(xbgr.mr_n86270496)
print v(xbgr.mr_n86270960)
print v(xbgr.mr_n86271424)
print v(xbgr.mr_n86271888)
print v(xbgr.mr_n86272352)
print v(xbgr.mr_n86272816)
print v(xbgr.mr_n86273200)
print v(xbgr.mr_n86273664)
print v(xbgr.mr_n86274128)
print v(xbgr.mr_n86274592)
print v(xbgr.mr_n86275056)
print v(xbgr.mr_n86275408)
print v(xbgr.mr_n86275520)
print v(xbgr.mr_n86275984)
print v(xbgr.mr_n86276448)
print v(xbgr.mr_n86276912)
print v(xbgr.mr_n86277376)
print v(xbgr.mr_n86277840)
print v(xbgr.mr_n86278304)
print v(xbgr.mr_n86278768)
print v(xbgr.mr_n86279232)
print v(xbgr.mr_n86279696)
print v(xbgr.mr_n86280160)
print v(xbgr.mr_n86280624)
print v(xbgr.mr_n86281088)
print v(xbgr.mr_n86281552)
print v(xbgr.mr_n86282016)
print v(xbgr.mr_n86282480)
print v(xbgr.mr_n86282944)
print v(xbgr.mr_n86283408)
print v(xbgr.mr_n86283872)
print v(xbgr.mr_n86284336)
print v(xbgr.mr_n86284800)
print v(xbgr.mr_n86285264)
print v(xbgr.mr_n86285728)
print v(xbgr.mr_n86286192)
print v(xbgr.mr_n86286656)
print v(xbgr.mr_n86287120)
print v(xbgr.mr_n86287584)
print v(xbgr.mr_n86288048)
print v(xbgr.mr_n86288512)
print v(xbgr.mr_n86288976)
print v(xbgr.mr_n86289440)
print v(xbgr.mr_n86289904)
print v(xbgr.mr_n86290368)
print v(xbgr.mr_n86290640)
print v(xbgr.mr_n86290832)
print v(xbgr.mr_n86291296)
print v(xbgr.mr_n86291760)
print v(xbgr.mr_n86292224)
print v(xbgr.mr_n86292688)
print v(xbgr.mr_n86293152)
print v(xbgr.mr_n86293616)
print v(xbgr.mr_n86294080)
print v(xbgr.mr_n86294544)
print v(xbgr.mr_n86295008)
print v(xbgr.mr_n86295472)
print v(xbgr.mr_n86295936)
print v(xbgr.mr_n86296400)
print v(xbgr.mr_n86296864)
print v(xbgr.mr_n86297328)
print v(xbgr.mr_n86297792)
print v(xbgr.mr_n86298256)
print v(xbgr.mr_n86298720)
print v(xbgr.mr_n86299184)
print v(xbgr.mr_n86299648)
print v(xbgr.mr_n86300112)
print v(xbgr.mr_n86300576)
print v(xbgr.mr_n86301040)
print v(xbgr.mr_n86301504)
print v(xbgr.mr_n86301968)
print v(xbgr.mr_n86302432)
print v(xbgr.mr_n86302896)
print v(xbgr.mr_n86303360)
print v(xbgr.mr_n86303824)
print v(xbgr.mr_n86304288)
print v(xbgr.mr_n86304752)
print v(xbgr.mr_n86305216)
print v(xbgr.mr_n86305680)
print v(xbgr.mr_n86306144)
print v(xbgr.mr_n86306608)
print v(xbgr.mr_n86307072)
print v(xbgr.mr_n86307536)
print v(xbgr.mr_n86307648)
print v(xbgr.mr_n86308192)
print v(xbgr.mr_n86308416)
print v(xbgr.mr_n86308928)
print v(xbgr.mr_n86309152)
print v(xbgr.mr_n86309664)
print v(xbgr.mr_n86309888)
print v(xbgr.mr_n86310400)
print v(xbgr.mr_n86310512)
print v(xbgr.mr_n86310624)
print v(xbgr.mr_n86311136)
print v(xbgr.mr_n86311248)
print v(xbgr.mr_n86311360)
print v(xbgr.mr_n86311872)
print v(xbgr.mr_n86311984)
print v(xbgr.mr_n86312096)
print v(xbgr.mr_n86312608)
print v(xbgr.mr_n86312880)
print v(xbgr.mr_n86313152)
print v(xbgr.mr_n86313424)
print v(xbgr.mr_n86313536)
print v(xbgr.mr_n86313648)
print v(xbgr.mr_n86314160)
print v(xbgr.mr_n86314432)
print v(xbgr.mr_n86314704)
print v(xbgr.mr_n86314976)
print v(xbgr.mr_n86315248)
print v(xbgr.mr_n86315792)
print v(xbgr.mr_n86316064)
print v(xbgr.mr_n86316336)
print v(xbgr.mr_n86316608)
print v(xbgr.mr_n86316880)
print v(xbgr.mr_n86317152)
print v(xbgr.mr_n86317696)
print v(xbgr.mr_n86317968)
print v(xbgr.mr_n86318240)
print v(xbgr.mr_n86318512)
print v(xbgr.mr_n86318784)
print v(xbgr.mr_n86319056)
print v(xbgr.mr_n86319328)
print v(xbgr.mr_n86319600)
print v(xbgr.mr_n86319872)
print v(xbgr.mr_n86320144)
print v(xbgr.mr_n86320416)
print v(xbgr.mr_n86320688)
print v(xbgr.mr_n86321024)
print v(xbgr.mr_n86321488)
print v(xbgr.mr_n86321952)
print v(xbgr.mr_n86322416)
print v(xbgr.mr_n86322880)
print v(xbgr.mr_n86323344)
print v(xbgr.mr_n86323808)
print v(xbgr.mr_n86324272)
print v(xbgr.mr_n86324736)
print v(xbgr.mr_n86325200)
print v(xbgr.mr_n86325664)
print v(xbgr.mr_n86326128)
print v(xbgr.mr_n86327616)
print v(xbgr.mr_n86330176)
print v(xbgr.mr_n86330944)
print v(xbgr.mr_n86336016)
print v(xbgr.mr_n86337792)
print v(xbgr.mr_n86339904)
print v(xbgr.mr_n86341760)
print v(xbgr.mr_n86343232)
print v(xbgr.mr_n86343904)
print v(xbgr.mr_n86344416)
print v(xbgr.mr_n86345088)
print v(xbgr.mr_n86345680)
print v(xbgr.mr_n86346192)
print v(xbgr.mr_n86346864)
print v(xbgr.mr_n86347376)
print v(xbgr.mr_n86348048)
print v(xbgr.mr_n86348640)
print v(xbgr.mr_n86349152)
print v(xbgr.mr_n86349824)
print v(xbgr.mr_n86350416)
print v(xbgr.mr_n86351008)
print v(xbgr.mr_n86351520)
print v(xbgr.mr_n86352112)
print v(xbgr.mr_n86352784)
print v(xbgr.mr_n86353376)
print v(xbgr.mr_n86353968)
print v(xbgr.mr_n86354384)
print v(xbgr.mr_n86354560)
print v(xbgr.mr_n86355152)
print v(xbgr.mr_n86356256)
print v(xbgr.mr_n86357520)
print v(xbgr.mr_n86358032)
print v(xbgr.mr_n86358704)
print v(xbgr.mr_n86359296)
print v(xbgr.mr_n86359888)
print v(xbgr.mr_n86364896)
print v(xbgr.mr_n86365728)
print v(xbgr.mr_n86367104)
print v(xbgr.mr_n86380384)
print v(xbgr.mr_n86382144)
print v(xbgr.mr_n86387616)
print v(xbgr.mr_n86391872)
print v(xbgr.mr_n86394976)
print v(xbgr.mr_n86399712)
print v(xbgr.mr_n86404512)
print v(xbgr.mr_n86405888)
print v(xbgr.mr_n86406336)
print v(xbgr.mr_n86407376)
print v(xbgr.mr_n86407984)
print v(xbgr.mr_n86408096)
print v(xbgr.mr_n86408704)
print v(xbgr.mr_n86408816)
print v(xbgr.mr_n86409424)
print v(xbgr.mr_n86409536)
print v(xbgr.mr_n86410144)
print v(xbgr.mr_n86410864)
print v(xbgr.mr_n86410976)
print v(xbgr.mr_n86411584)
print v(xbgr.mr_n86412304)
print v(xbgr.mr_n86415024)
print v(xbgr.mr_n86416560)
print v(xbgr.mr_n86421120)
print v(xbgr.mr_n86421536)
print v(xbgr.mr_n86423792)
print v(xbgr.mr_n86424272)
print v(xbgr.mr_n86425376)
print v(xbgr.mr_n86427440)
print v(xbgr.mr_n86427744)
print v(xbgr.mr_n86430240)
print v(xbgr.mr_n86434192)
print v(xbgr.mr_n86435344)
print v(xbgr.mr_n86436672)
print v(xbgr.mr_n86441216)
print v(xbgr.mr_n86441424)
print v(xbgr.mr_n86442400)
print v(xbgr.mr_n86445488)
print v(xbgr.mr_n86446176)
print v(xbgr.mr_n86446288)
print v(xbgr.mr_n86447872)
print v(xbgr.mr_n86448640)
print v(xbgr.mr_n86448880)
print v(xbgr.mr_n86450144)
print v(xbgr.mr_n86450832)
print v(xbgr.mr_n86451456)
print v(xbgr.mr_n86453280)
print v(xbgr.mr_n86453472)
print v(xbgr.mr_n86455696)
print v(xbgr.mr_n86456496)
print v(xbgr.mr_n86458784)
print v(xbgr.mr_n86460032)
print v(xbgr.mr_n86464336)
print v(xbgr.mr_n86464512)
print v(xbgr.mr_n86464688)
print v(xbgr.mr_n86465632)
print v(xbgr.mr_n86465776)
print v(xbgr.mr_n86466752)
print v(xbgr.mr_n86467280)
print v(xbgr.mr_n86467936)
print v(xbgr.mr_n86468448)
print v(xbgr.mr_n86469040)
print v(xbgr.mr_n86469712)
print v(xbgr.mr_n86470304)
print v(xbgr.mr_n86470960)
print v(xbgr.mr_n86471488)
print v(xbgr.mr_n86472016)
print v(xbgr.mr_n86472672)
print v(xbgr.mr_n86473264)
print v(xbgr.mr_n86473856)
print v(xbgr.mr_n86474384)
print v(xbgr.mr_n86475104)
print v(xbgr.mr_n86475568)
print v(xbgr.mr_n86476224)
print v(xbgr.mr_n86476816)
print v(xbgr.mr_n86477328)
print v(xbgr.mr_n86477920)
print v(xbgr.mr_n86478528)
print v(xbgr.mr_n86479248)
print v(xbgr.mr_n86479712)
print v(xbgr.mr_n86480288)
print v(xbgr.mr_n86480960)
print v(xbgr.mr_n86481552)
print v(xbgr.mr_n86482064)
print v(xbgr.mr_n86482656)
print v(xbgr.mr_n86483248)
print v(xbgr.mr_n86483856)
print v(xbgr.mr_n86484512)
print v(xbgr.mr_n86485040)
print v(xbgr.mr_n86485696)
print v(xbgr.mr_n86486208)
print v(xbgr.mr_n86486800)
print v(xbgr.mr_n86487808)
print v(xbgr.mr_n86488064)
print v(xbgr.mr_n86488592)
print v(xbgr.mr_n86489168)
print v(xbgr.mr_n86489760)
print v(xbgr.mr_n86490432)
print v(xbgr.mr_n86490944)
print v(xbgr.mr_n86491680)
print v(xbgr.mr_n86492208)
print v(xbgr.mr_n86492736)
print v(xbgr.mr_n86493392)
print v(xbgr.mr_n86493984)
print v(xbgr.mr_n86494496)
print v(xbgr.mr_n86495424)
print v(xbgr.mr_n86495536)
print v(xbgr.mr_n86495952)
print v(xbgr.mr_n86496720)
print v(xbgr.mr_n86497440)
print v(xbgr.mr_n86498480)
print v(xbgr.mr_n86499072)
print v(xbgr.mr_n86499664)
print v(xbgr.mr_n86500256)
print v(xbgr.mr_n86500848)
print v(xbgr.mr_n86501408)
print v(xbgr.mr_n86502000)
print v(xbgr.mr_n86502592)
print v(xbgr.mr_n86503184)
print v(xbgr.mr_n86503776)
print v(xbgr.mr_n86504112)
print v(xbgr.mr_n86504368)
print v(xbgr.mr_n86504960)
print v(xbgr.mr_n86505552)
print v(xbgr.mr_n86506144)
print v(xbgr.mr_n86506736)
print v(xbgr.mr_n86507248)
print v(xbgr.mr_n86507920)
print v(xbgr.mr_n86508256)
print v(xbgr.mr_n86508512)
print v(xbgr.mr_n86509104)
print v(xbgr.mr_n86509696)
print v(xbgr.mr_n86510288)
print v(xbgr.mr_n86510880)
print v(xbgr.mr_n86511472)
print v(xbgr.mr_n86512064)
print v(xbgr.mr_n86512656)
print v(xbgr.mr_n86513184)
print v(xbgr.mr_n86513840)
print v(xbgr.mr_n86514368)
print v(xbgr.mr_n86515024)
print v(xbgr.mr_n86515616)
print v(xbgr.mr_n86516128)
print v(xbgr.mr_n86516800)
print v(xbgr.mr_n86517392)
print v(xbgr.mr_n86517984)
print v(xbgr.mr_n86518576)
print v(xbgr.mr_n86519168)
print v(xbgr.mr_n86519760)
print v(xbgr.mr_n86520352)
print v(xbgr.mr_n86520944)
print v(xbgr.mr_n86521472)
print v(xbgr.mr_n86522128)
print v(xbgr.mr_n86522720)
print v(xbgr.mr_n86523312)
print v(xbgr.mr_n86523904)
print v(xbgr.mr_n86524496)
print v(xbgr.mr_n86525088)
print v(xbgr.mr_n86525680)
print v(xbgr.mr_n86526272)
print v(xbgr.mr_n86526864)
print v(xbgr.mr_n86527456)
print v(xbgr.mr_n86527968)
print v(xbgr.mr_n86528640)
print v(xbgr.mr_n86529232)
print v(xbgr.mr_n86529824)
print v(xbgr.mr_n86530416)
print v(xbgr.mr_n86530944)
print v(xbgr.mr_n86531600)
print v(xbgr.mr_n86532192)
print v(xbgr.mr_n86532784)
print v(xbgr.mr_n86533376)
print v(xbgr.mr_n86533968)
print v(xbgr.mr_n86534560)
print v(xbgr.mr_n86535152)
print v(xbgr.mr_n86535744)
print v(xbgr.mr_n86536336)
print v(xbgr.mr_n86536928)
print v(xbgr.mr_n86538048)
print v(xbgr.mr_n86539232)
print v(xbgr.mr_n86539888)
print v(xbgr.mr_n86540480)
print v(xbgr.mr_n86541072)
print v(xbgr.mr_n86541664)
print v(xbgr.mr_n86542256)
print v(xbgr.mr_n86542848)
print v(xbgr.mr_n86543440)
print v(xbgr.mr_n86543776)
print v(xbgr.mr_n86544032)
print v(xbgr.mr_n86544624)
print v(xbgr.mr_n86545456)
print v(xbgr.mr_n86545696)
print v(xbgr.mr_n86545936)
print v(xbgr.mr_n86546256)
print v(xbgr.mr_n86546656)
print v(xbgr.mr_n86547456)
print v(xbgr.mr_n86547856)
print v(xbgr.mr_n86548256)
print v(xbgr.mr_n86548656)
print v(xbgr.mr_n86549056)
print v(xbgr.mr_n86550464)
print v(xbgr.mr_n86553936)
print v(xbgr.mr_n86575072)
print v(xbgr.mr_n86576256)
print v(xbgr.mr_n86576752)
print v(xbgr.mr_n86578160)
print v(xbgr.mr_n86580064)
print v(xbgr.mr_n86580656)
print v(xbgr.mr_n86581248)
print v(xbgr.mr_n86581840)
print v(xbgr.mr_n86582432)
print v(xbgr.mr_n86583024)
print v(xbgr.mr_n86583616)
print v(xbgr.mr_n86584208)
print v(xbgr.mr_n86584800)
print v(xbgr.mr_n86585392)
print v(xbgr.mr_n86585984)
print v(xbgr.mr_n86586848)
print v(xbgr.mr_n86604640)
print v(xbgr.mr_n86610912)
print v(xbgr.mr_n86622464)
print v(xbgr.mr_n86623344)
print v(xbgr.mr_n86624464)
print v(xbgr.mr_n86625056)
print v(xbgr.mr_n86625648)
print v(xbgr.mr_n86626240)
print v(xbgr.mr_n86626832)
print v(xbgr.mr_n86627424)
print v(xbgr.mr_n86628608)
print v(xbgr.mr_n86629200)
print v(xbgr.mr_n86629536)
print v(xbgr.mr_n86629792)
print v(xbgr.mr_n86630384)
print v(xbgr.mr_n86630496)
print v(xbgr.mr_n86630880)
print v(xbgr.mr_n86631728)
print v(xbgr.mr_n86632480)
print v(xbgr.mr_n86633072)
print v(xbgr.mr_n86633664)
print v(xbgr.mr_n86634848)
print v(xbgr.mr_n86635440)
print v(xbgr.mr_n86636032)
print v(xbgr.mr_n86636624)
print v(xbgr.mr_n86637216)
print v(xbgr.mr_n86637808)
print v(xbgr.mr_n86638400)
print v(xbgr.mr_n86638992)
print v(xbgr.mr_n86639584)
print v(xbgr.mr_n86640176)
print v(xbgr.mr_n86640768)
print v(xbgr.mr_n86641952)
print v(xbgr.mr_n86642544)
print v(xbgr.mr_n86643136)
print v(xbgr.mr_n86643728)
print v(xbgr.mr_n86644320)
print v(xbgr.mr_n86644912)
print v(xbgr.mr_n86645504)
print v(xbgr.mr_n86646096)
print v(xbgr.mr_n86646688)
print v(xbgr.mr_n86647104)
print v(xbgr.mr_n86647280)
print v(xbgr.mr_n86647872)
print v(xbgr.mr_n86649056)
print v(xbgr.mr_n86649648)
print v(xbgr.mr_n86650240)
print v(xbgr.mr_n86650832)
print v(xbgr.mr_n86651424)
print v(xbgr.mr_n86652016)
print v(xbgr.mr_n86653200)
print v(xbgr.mr_n86653792)
print v(xbgr.mr_n86654384)
print v(xbgr.mr_n86654976)
print v(xbgr.mr_n86655568)
print v(xbgr.mr_n86656160)
print v(xbgr.mr_n86656752)
print v(xbgr.mr_n86657344)
print v(xbgr.mr_n86657936)
print v(xbgr.mr_n86658528)
print v(xbgr.mr_n86659120)
print v(xbgr.mr_n86659712)
print v(xbgr.mr_n86660304)
print v(xbgr.mr_n86660896)
print v(xbgr.mr_n86661488)
print v(xbgr.mr_n86662080)
print v(xbgr.mr_n86663264)
print v(xbgr.mr_n86663856)
print v(xbgr.mr_n86664448)
print v(xbgr.mr_n86665040)
print v(xbgr.mr_n86665632)
print v(xbgr.mr_n86666224)
print v(xbgr.mr_n86666816)
print v(xbgr.mr_n86667408)
print v(xbgr.mr_n86668000)
print v(xbgr.mr_n86668592)
print v(xbgr.mr_n86669184)
print v(xbgr.mr_n86669776)
print v(xbgr.mr_n86670368)
print v(xbgr.mr_n86670960)
print v(xbgr.mr_n86671552)
print v(xbgr.mr_n86672144)
print v(xbgr.mr_n86672560)
print v(xbgr.mr_n86672736)
print v(xbgr.mr_n86673328)
print v(xbgr.mr_n86673920)
print v(xbgr.mr_n86674512)
print v(xbgr.mr_n86675104)
print v(xbgr.mr_n86675696)
print v(xbgr.mr_n86676288)
print v(xbgr.mr_n86676880)
print v(xbgr.mr_n86677472)
print v(xbgr.mr_n86678064)
print v(xbgr.mr_n86678656)
print v(xbgr.mr_n86679248)
print v(xbgr.mr_n86679840)
print v(xbgr.mr_n86680432)
print v(xbgr.mr_n86681024)
print v(xbgr.mr_n86681616)
print v(xbgr.mr_n86682208)
print v(xbgr.mr_n86682800)
print v(xbgr.mr_n86683392)
print v(xbgr.mr_n86683984)
print v(xbgr.mr_n86684576)
print v(xbgr.mr_n86685168)
print v(xbgr.mr_n86685760)
print v(xbgr.mr_n86686352)
print v(xbgr.mr_n86686944)
print v(xbgr.mr_n86687536)
print v(xbgr.mr_n86688128)
print v(xbgr.mr_n86688720)
print v(xbgr.mr_n86689312)
print v(xbgr.mr_n86689904)
print v(xbgr.mr_n86690496)
print v(xbgr.mr_n86691088)
print v(xbgr.mr_n86691680)
print v(xbgr.mr_n86692272)
print v(xbgr.mr_n86692864)
print v(xbgr.mr_n86693456)
print v(xbgr.mr_n86693856)
print v(xbgr.mr_n86693984)
print v(xbgr.mr_n86694448)
print v(xbgr.mr_n86694912)
print v(xbgr.mr_n86695024)
print v(xbgr.mr_n86695376)
print v(xbgr.mr_n86695840)
print v(xbgr.mr_n86695952)
print v(xbgr.mr_n86696304)
print v(xbgr.mr_n86696416)
print v(xbgr.mr_n86697808)
print v(xbgr.mr_n86698400)
print v(xbgr.mr_n86699040)
print v(xbgr.mr_n86699440)
print v(xbgr.mr_n86699840)
print v(xbgr.mr_n86700240)
print v(xbgr.mr_n86700640)
print v(xbgr.mr_n86701040)
print v(xbgr.mr_n86701440)
print v(xbgr.mr_n86701840)
print v(xbgr.mr_n86702240)
print v(xbgr.mr_n86702640)
print v(xbgr.mr_n86703040)
print v(xbgr.mr_n86703440)
print v(xbgr.mr_n86703840)
print v(xbgr.mr_n86704240)
print v(xbgr.mr_n86704640)
print v(xbgr.mr_n86705040)
print v(xbgr.mr_n86705440)
print v(xbgr.mr_n86705840)
print v(xbgr.mr_n86706240)
print v(xbgr.mr_n86706640)
print v(xbgr.mr_n86707040)
print v(xbgr.mr_n86707440)
print v(xbgr.mr_n86707840)
print v(xbgr.mr_n86708240)
print v(xbgr.mr_n86708640)
print v(xbgr.mr_n86709040)
print v(xbgr.mr_n86709440)
print v(xbgr.mr_n86709840)
print v(xbgr.mr_n86710240)
print v(xbgr.mr_n86710640)
print v(xbgr.mr_n86711040)
print v(xbgr.mr_n86711440)
print v(xbgr.mr_n86711840)
print v(xbgr.mr_n86712240)
print v(xbgr.mr_n86712640)
print v(xbgr.mr_n86713040)
print v(xbgr.mr_n86713504)
print v(xbgr.mr_n86714096)
print v(xbgr.mr_n86714688)
print v(xbgr.mr_n86715280)
print v(xbgr.mr_n86715872)
print v(xbgr.mr_n86716464)
print v(xbgr.mr_n86717056)
print v(xbgr.mr_n86717648)
print v(xbgr.mr_n86718240)
print v(xbgr.mr_n86718832)
print v(xbgr.mr_n86719424)
print v(xbgr.mr_n86728400)
print v(xbgr.mr_n86728784)
print v(xbgr.mr_n86728896)
print v(xbgr.mr_n86731216)
print v(xbgr.mr_n86733712)
print v(xbgr.mr_n86734800)
print v(xbgr.mr_n86735616)
print v(xbgr.mr_n86736480)
print v(xbgr.mr_n86737072)
print v(xbgr.mr_n86737728)
print v(xbgr.mr_n86738256)
print v(xbgr.mr_n86738848)
print v(xbgr.mr_n86739440)
print v(xbgr.mr_n86740032)
print v(xbgr.mr_n86740624)
print v(xbgr.mr_n86741216)
print v(xbgr.mr_n86741872)
print v(xbgr.mr_n86742400)
print v(xbgr.mr_n86742992)
print v(xbgr.mr_n86743584)
print v(xbgr.mr_n86744176)
print v(xbgr.mr_n86744768)
print v(xbgr.mr_n86745280)
print v(xbgr.mr_n86746016)
print v(xbgr.mr_n86746464)
print v(xbgr.mr_n86747136)
print v(xbgr.mr_n86747728)
print v(xbgr.mr_n86748320)
print v(xbgr.mr_n86748912)
print v(xbgr.mr_n86749424)
print v(xbgr.mr_n86750096)
print v(xbgr.mr_n86750688)
print v(xbgr.mr_n86751280)
print v(xbgr.mr_n86751792)
print v(xbgr.mr_n86752464)
print v(xbgr.mr_n86753056)
print v(xbgr.mr_n86753568)
print v(xbgr.mr_n86754240)
print v(xbgr.mr_n86754752)
print v(xbgr.mr_n86755424)
print v(xbgr.mr_n86756016)
print v(xbgr.mr_n86756608)
print v(xbgr.mr_n86757200)
print v(xbgr.mr_n86757792)
print v(xbgr.mr_n86758448)
print v(xbgr.mr_n86758976)
print v(xbgr.mr_n86759568)
print v(xbgr.mr_n86760160)
print v(xbgr.mr_n86760752)
print v(xbgr.mr_n86761344)
print v(xbgr.mr_n86761936)
print v(xbgr.mr_n86762592)
print v(xbgr.mr_n86763120)
print v(xbgr.mr_n86763712)
print v(xbgr.mr_n86765408)
print v(xbgr.mr_n86769520)
print v(xbgr.mr_n86772144)
print v(xbgr.mr_n86774576)
print v(xbgr.mr_n86775184)
print v(xbgr.mr_n86776272)
print v(xbgr.mr_n86785344)
print v(xbgr.mr_n86805648)
print v(xbgr.mr_n86805792)
print v(xbgr.mr_n86806960)
print v(xbgr.mr_n86807296)
print v(xbgr.mr_n86809728)
print v(xbgr.mr_n86809840)
print v(xbgr.mr_n86810448)
print v(xbgr.mr_n86811168)
print v(xbgr.mr_n86811280)
print v(xbgr.mr_n86811888)
print v(xbgr.mr_n86812608)
print v(xbgr.mr_n86812720)
print v(xbgr.mr_n86813328)
print v(xbgr.mr_n86815360)
print v(xbgr.mr_n86842128)
print v(xbgr.mr_n86845648)
print v(xbgr.mr_n86846656)
print v(xbgr.mr_n86847408)
print v(xbgr.mr_n86847760)
print v(xbgr.mr_n86848272)
print v(xbgr.mr_n86849216)
print v(xbgr.mr_n86851200)
print v(xbgr.mr_n86852112)
print v(xbgr.mr_n86853056)
print v(xbgr.mr_n86853712)
print v(xbgr.mr_n86854688)
print v(xbgr.mr_n86854896)
print v(xbgr.mr_n86855104)
print v(xbgr.mr_n86855392)
print v(xbgr.mr_n86855504)
print v(xbgr.mr_n86856656)
print v(xbgr.mr_n86856800)
print v(xbgr.mr_n86857952)
print v(xbgr.mr_n86858880)
print v(xbgr.mr_n86859344)
print v(xbgr.mr_n86859808)
print v(xbgr.mr_n86860768)
print v(xbgr.mr_n86861360)
print v(xbgr.mr_n86861952)
print v(xbgr.mr_n86862544)
print v(xbgr.mr_n86863136)
print v(xbgr.mr_n86863728)
print v(xbgr.mr_n86864320)
print v(xbgr.mr_n86864912)
print v(xbgr.mr_n86865504)
print v(xbgr.mr_n86866096)
print v(xbgr.mr_n86866688)
print v(xbgr.mr_n86867280)
print v(xbgr.mr_n86867872)
print v(xbgr.mr_n86868464)
print v(xbgr.mr_n86869056)
print v(xbgr.mr_n86869648)
print v(xbgr.mr_n86870240)
print v(xbgr.mr_n86871424)
print v(xbgr.mr_n86872016)
print v(xbgr.mr_n86872352)
print v(xbgr.mr_n86872608)
print v(xbgr.mr_n86873136)
print v(xbgr.mr_n86873792)
print v(xbgr.mr_n86874384)
print v(xbgr.mr_n86874976)
print v(xbgr.mr_n86875568)
print v(xbgr.mr_n86876160)
print v(xbgr.mr_n86876752)
print v(xbgr.mr_n86877344)
print v(xbgr.mr_n86878528)
print v(xbgr.mr_n86879120)
print v(xbgr.mr_n86879712)
print v(xbgr.mr_n86880304)
print v(xbgr.mr_n86880896)
print v(xbgr.mr_n86881424)
print v(xbgr.mr_n86882080)
print v(xbgr.mr_n86882672)
print v(xbgr.mr_n86883264)
print v(xbgr.mr_n86883840)
print v(xbgr.mr_n86884432)
print v(xbgr.mr_n86885024)
print v(xbgr.mr_n86885616)
print v(xbgr.mr_n86886208)
print v(xbgr.mr_n86886800)
print v(xbgr.mr_n86887392)
print v(xbgr.mr_n86887984)
print v(xbgr.mr_n86888576)
print v(xbgr.mr_n86889168)
print v(xbgr.mr_n86889760)
print v(xbgr.mr_n86890352)
print v(xbgr.mr_n86890880)
print v(xbgr.mr_n86891536)
print v(xbgr.mr_n86892672)
print v(xbgr.mr_n86893264)
print v(xbgr.mr_n86893856)
print v(xbgr.mr_n86894448)
print v(xbgr.mr_n86895040)
print v(xbgr.mr_n86895632)
print v(xbgr.mr_n86895968)
print v(xbgr.mr_n86896224)
print v(xbgr.mr_n86896816)
print v(xbgr.mr_n86897408)
print v(xbgr.mr_n86897936)
print v(xbgr.mr_n86898592)
print v(xbgr.mr_n86899184)
print v(xbgr.mr_n86899776)
print v(xbgr.mr_n86900368)
print v(xbgr.mr_n86900704)
print v(xbgr.mr_n86900816)
print v(xbgr.mr_n86902160)
print v(xbgr.mr_n86902624)
print v(xbgr.mr_n86903088)
print v(xbgr.mr_n86903552)
print v(xbgr.mr_n86904016)
print v(xbgr.mr_n86904688)
print v(xbgr.mr_n86905904)
print v(xbgr.mr_n86906496)
print v(xbgr.mr_n86907088)
print v(xbgr.mr_n86907680)
print v(xbgr.mr_n86908272)
print v(xbgr.mr_n86908864)
print v(xbgr.mr_n86909456)
print v(xbgr.mr_n86909792)
print v(xbgr.mr_n86910048)
print v(xbgr.mr_n86910720)
print v(xbgr.mr_n86911632)
print v(xbgr.mr_n86914144)
print v(xbgr.mr_n86915760)
print v(xbgr.mr_n86915872)
print v(xbgr.mr_n86915984)
print v(xbgr.mr_n86916096)
print v(xbgr.mr_n86916208)
print v(xbgr.mr_n86916320)
print v(xbgr.mr_n86916432)
print v(xbgr.mr_n86916544)
print v(xbgr.mr_n86916736)
print v(xbgr.mr_n86916928)
print v(xbgr.mr_n86917280)
print v(xbgr.mr_n86917552)
print v(xbgr.mr_n86917824)
print v(xbgr.mr_n86918096)
print v(xbgr.mr_n86918368)
print v(xbgr.mr_n86918640)
print v(xbgr.mr_n86918944)
print v(xbgr.mr_n86919264)
print v(xbgr.mr_n86919744)
print v(xbgr.mr_n86920144)
print v(xbgr.mr_n86920544)
print v(xbgr.mr_n86920864)
print v(xbgr.mr_n86921344)
print v(xbgr.mr_n86921744)
print v(xbgr.mr_n86922144)
print v(xbgr.mr_n86922464)
print v(xbgr.mr_n86922944)
print v(xbgr.mr_n86923344)
print v(xbgr.mr_n86923744)
print v(xbgr.mr_n86924144)
print v(xbgr.mr_n86924544)
print v(xbgr.mr_n86924944)
print v(xbgr.mr_n86925344)
print v(xbgr.mr_n86925744)
print v(xbgr.mr_n86926144)
print v(xbgr.mr_n86926464)
print v(xbgr.mr_n86926944)
print v(xbgr.mr_n86927344)
print v(xbgr.mr_n86927744)
print v(xbgr.mr_n86928144)
print v(xbgr.mr_n86928544)
print v(xbgr.mr_n86928944)
print v(xbgr.mr_n86929344)
print v(xbgr.mr_n86929744)
print v(xbgr.mr_n86930144)
print v(xbgr.mr_n86930480)
print v(xbgr.mr_n86930752)
print v(xbgr.mr_n86931024)
print v(xbgr.mr_n86931296)
print v(xbgr.mr_n86931568)
print v(xbgr.mr_n86931840)
print v(xbgr.mr_n86932112)
print v(xbgr.mr_n86932384)
print v(xbgr.mr_n86932656)
print v(xbgr.mr_n86932928)
print v(xbgr.mr_n86933200)
print v(xbgr.mr_n86933472)
print v(xbgr.mr_n86933744)
print v(xbgr.mr_n86934016)
print v(xbgr.mr_n86934288)
print v(xbgr.mr_n86934560)
print v(xbgr.mr_n86934832)
print v(xbgr.mr_n86935104)
print v(xbgr.mr_n86935552)
print v(xbgr.mr_n86935744)
print v(xbgr.mr_n86935936)
print v(xbgr.mr_n86936128)
print v(xbgr.mr_n86937072)
print v(xbgr.mr_n86940832)
print v(xbgr.mr_n86940944)
print v(xbgr.mr_n86941136)
print v(xbgr.mr_n86941888)
print v(xbgr.mr_n86942800)
print v(xbgr.mr_n86943552)
print v(xbgr.mr_n86945824)
print v(xbgr.mr_n86945936)
print v(xbgr.mr_n86946128)
print v(xbgr.mr_n86946880)
print v(xbgr.mr_n86947792)
print v(xbgr.mr_n86948544)
print v(xbgr.mr_n86950816)
print v(xbgr.mr_n86950928)
print v(xbgr.mr_n86951120)
print v(xbgr.mr_n86951872)
print v(xbgr.mr_n86952784)
print v(xbgr.mr_n86953536)
print v(xbgr.mr_n86955808)
print v(xbgr.mr_n86955920)
print v(xbgr.mr_n86956112)
print v(xbgr.mr_n86956864)
print v(xbgr.mr_n86957776)
print v(xbgr.mr_n86958528)
print v(xbgr.mr_n86960800)
print v(xbgr.mr_n86960912)
print v(xbgr.mr_n86961104)
print v(xbgr.mr_n86961856)
print v(xbgr.mr_n86962768)
print v(xbgr.mr_n86963520)
print v(xbgr.mr_n86965792)
print v(xbgr.mr_n86965904)
print v(xbgr.mr_n86966096)
print v(xbgr.mr_n86966848)
print v(xbgr.mr_n86970368)
print v(xbgr.mr_n86970880)
print v(xbgr.mr_n86971312)
print v(xbgr.mr_n86971488)
print v(xbgr.mr_n86971744)
print v(xbgr.mr_n86972336)
print v(xbgr.mr_n86972768)
print v(xbgr.mr_n86972944)
print v(xbgr.mr_n86973280)
print v(xbgr.mr_n86973984)
print v(xbgr.mr_n86974160)
print v(xbgr.mr_n86974336)
print v(xbgr.mr_n86974848)
print v(xbgr.mr_n86974960)
print v(xbgr.mr_n86975520)
print v(xbgr.mr_n86975696)
print v(xbgr.mr_n86975952)
print v(xbgr.mr_n86976896)
print v(xbgr.mr_n86977072)
print v(xbgr.mr_n86977248)
print v(xbgr.mr_n86977760)
print v(xbgr.mr_n86977872)
print v(xbgr.mr_n86978432)
print v(xbgr.mr_n86978608)
print v(xbgr.mr_n86979104)
print v(xbgr.mr_n86979616)
print v(xbgr.mr_n86980048)
print v(xbgr.mr_n86980224)
print v(xbgr.mr_n86980560)
print v(xbgr.mr_n86981264)
print v(xbgr.mr_n86981440)
print v(xbgr.mr_n86981616)
print v(xbgr.mr_n86982128)
print v(xbgr.mr_n86982240)
print v(xbgr.mr_n86982800)
print v(xbgr.mr_n86982976)
print v(xbgr.mr_n86983472)
print v(xbgr.mr_n86983984)
print v(xbgr.mr_n86984416)
print v(xbgr.mr_n86984592)
print v(xbgr.mr_n86984928)
print v(xbgr.mr_n86985440)
print v(xbgr.mr_n86985872)
print v(xbgr.mr_n86986048)
print v(xbgr.mr_n86986304)
print v(xbgr.mr_n86987088)
print v(xbgr.mr_n86987264)
print v(xbgr.mr_n86987440)
print v(xbgr.mr_n86988384)
print v(xbgr.mr_n86988560)
print v(xbgr.mr_n86988896)
print v(xbgr.mr_n86989408)
print v(xbgr.mr_n86989840)
print v(xbgr.mr_n86990016)
print v(xbgr.mr_n86990272)
print v(xbgr.mr_n86990864)
print v(xbgr.mr_n86990976)
print v(xbgr.mr_n86991536)
print v(xbgr.mr_n86991712)
print v(xbgr.mr_n86992128)
print v(xbgr.mr_n86992912)
print v(xbgr.mr_n86993088)
print v(xbgr.mr_n86993264)
print v(xbgr.mr_n86993776)
print v(xbgr.mr_n86993888)
print v(xbgr.mr_n86994000)
print v(xbgr.mr_n86994112)
print v(xbgr.mr_n86994224)
print v(xbgr.mr_n86994496)
print v(xbgr.mr_n86994848)
print v(xbgr.mr_n86994960)
print v(xbgr.mr_n86995232)
print v(xbgr.mr_n86995584)
print v(xbgr.mr_n86995824)
print v(xbgr.mr_n86996160)
print v(xbgr.mr_n86996512)
print v(xbgr.mr_n86996624)
print v(xbgr.mr_n86996816)
print v(xbgr.mr_n86997088)
print v(xbgr.mr_n86997360)
print v(xbgr.mr_n86997632)
print v(xbgr.mr_n86997904)
print v(xbgr.mr_n86998176)
print v(xbgr.mr_n86998800)
print v(xbgr.mr_n86998992)
print v(xbgr.mr_n86999184)
print v(xbgr.mr_n86999376)
print v(xbgr.mr_n87000128)
print v(xbgr.mr_n87018272)
print v(xbgr.mr_n87018448)
print v(xbgr.mr_n87019152)
print v(xbgr.mr_n87019328)
print v(xbgr.mr_n87019504)
print v(xbgr.mr_n87020208)
print v(xbgr.mr_n87020384)
print v(xbgr.mr_n87020560)
print v(xbgr.mr_n87021264)
print v(xbgr.mr_n87021440)
print v(xbgr.mr_n87021616)
print v(xbgr.mr_n87022320)
print v(xbgr.mr_n87022496)
print v(xbgr.mr_n87022672)
print v(xbgr.mr_n87023376)
print v(xbgr.mr_n87023552)
print v(xbgr.mr_n87023728)
print v(xbgr.mr_n87024304)
print v(xbgr.mr_n87024496)
print v(xbgr.mr_n87024768)
print v(xbgr.mr_n87025040)
print v(xbgr.mr_n87025312)
print v(xbgr.mr_n87025584)
print v(xbgr.mr_n87025856)
print v(xbgr.mr_n87026128)
print v(xbgr.mr_n87026400)
print v(xbgr.mr_n87026672)
print v(xbgr.mr_n87030208)
print v(xbgr.mr_n87030544)
print v(xbgr.mr_n87030880)
print v(xbgr.mr_n87031216)
print v(xbgr.mr_n87031872)
print v(xbgr.mr_n87032512)
print v(xbgr.mr_n87032912)
print v(xbgr.mr_n87033312)
print v(xbgr.mr_n87033712)
print v(xbgr.mr_n87034112)
print v(xbgr.mr_n87034512)
print v(xbgr.mr_n87034912)
print v(xbgr.mr_n87035376)
print v(xbgr.mr_n87035552)
print v(xbgr.mr_n87036464)
print v(xbgr.mr_n87036576)
print v(xbgr.mr_n87036976)
print v(xbgr.mr_n87038096)
print v(xbgr.mr_n87040624)
print v(xbgr.mr_n87041136)
print v(xbgr.mr_n87042432)
print v(xbgr.mr_n87042944)
print v(xbgr.mr_n87044240)
print v(xbgr.mr_n87044752)
print v(xbgr.mr_n87045968)
print v(xbgr.mr_n87046560)
print v(xbgr.mr_n87047856)
print v(xbgr.mr_n87048368)
print v(xbgr.mr_n87049504)
print v(xbgr.mr_n87051472)
print v(xbgr.mr_n87051984)
print v(xbgr.mr_n87053200)
print v(xbgr.mr_n87053792)
print v(xbgr.mr_n87055008)
print v(xbgr.mr_n87055600)
print v(xbgr.mr_n87056896)
print v(xbgr.mr_n87057408)
print v(xbgr.mr_n87058624)
print v(xbgr.mr_n87059216)
print v(xbgr.mr_n87060512)
print v(xbgr.mr_n87061024)
print v(xbgr.mr_n87062320)
print v(xbgr.mr_n87062832)
print v(xbgr.mr_n87062944)
print v(xbgr.mr_n87063056)
print v(xbgr.mr_n87063168)
print v(xbgr.mr_n87063440)
print v(xbgr.mr_n87063552)
print v(xbgr.mr_n87063904)
print v(xbgr.mr_n87064016)
print v(xbgr.mr_n87064288)
print v(xbgr.mr_n87064640)
print v(xbgr.mr_n87064752)
print v(xbgr.mr_n87065120)
print v(xbgr.mr_n87065680)
print v(xbgr.mr_n87066224)
print v(xbgr.mr_n87066720)
print v(xbgr.mr_n87067072)
print v(xbgr.mr_n87067760)
print v(xbgr.mr_n87068288)
print v(xbgr.mr_n87068640)
print v(xbgr.mr_n87069328)
print v(xbgr.mr_n87069792)
print v(xbgr.mr_n87070208)
print v(xbgr.mr_n87070896)
print v(xbgr.mr_n87071424)
print v(xbgr.mr_n87071776)
print v(xbgr.mr_n87072464)
print v(xbgr.mr_n87072992)
print v(xbgr.mr_n87073344)
print v(xbgr.mr_n87074032)
print v(xbgr.mr_n87074496)
print v(xbgr.mr_n87074912)
print v(xbgr.mr_n87075600)
print v(xbgr.mr_n87076128)
print v(xbgr.mr_n87076480)
print v(xbgr.mr_n87077168)
print v(xbgr.mr_n87077696)
print v(xbgr.mr_n87078048)
print v(xbgr.mr_n87078736)
print v(xbgr.mr_n87079200)
print v(xbgr.mr_n87079616)
print v(xbgr.mr_n87080304)
print v(xbgr.mr_n87080832)
print v(xbgr.mr_n87081184)
print v(xbgr.mr_n87081872)
print v(xbgr.mr_n87082336)
print v(xbgr.mr_n87082752)
print v(xbgr.mr_n87083440)
print v(xbgr.mr_n87083968)
print v(xbgr.mr_n87084320)
print v(xbgr.mr_n87085008)
print v(xbgr.mr_n87085472)
print v(xbgr.mr_n87085888)
print v(xbgr.mr_n87086320)
print v(xbgr.mr_n87087040)
print v(xbgr.mr_n87087936)
print v(xbgr.mr_n87088368)
print v(xbgr.mr_n87088816)
print v(xbgr.mr_n87089840)
print v(xbgr.mr_n87090368)
print v(xbgr.mr_n87090560)
print v(xbgr.mr_n87091392)
print v(xbgr.mr_n87092016)
print v(xbgr.mr_n87092208)
print v(xbgr.mr_n87092736)
print v(xbgr.mr_n87092976)
print v(xbgr.mr_n87096432)
print v(xbgr.mr_n87097840)
print v(xbgr.mr_n87099376)
print v(xbgr.mr_n87100080)
print v(xbgr.mr_n87100592)
print v(xbgr.mr_n87102016)
print v(xbgr.mr_n87105024)
print v(xbgr.mr_n87108016)
print v(xbgr.mr_n87108944)
print v(xbgr.mr_n87109408)
print v(xbgr.mr_n87109872)
print v(xbgr.mr_n87110336)
print v(xbgr.mr_n87110800)
print v(xbgr.mr_n87111264)
print v(xbgr.mr_n87111728)
print v(xbgr.mr_n87112192)
print v(xbgr.mr_n87112656)
print v(xbgr.mr_n87113120)
print v(xbgr.mr_n87113584)
print v(xbgr.mr_n87114048)
print v(xbgr.mr_n87114512)
print v(xbgr.mr_n87114976)
print v(xbgr.mr_n87115440)
print v(xbgr.mr_n87115904)
print v(xbgr.mr_n87116464)
print v(xbgr.mr_n87119760)
print v(xbgr.mr_n87119968)
print v(xbgr.mr_n87120304)
print v(xbgr.mr_n87120976)
print v(xbgr.mr_n87123296)
print v(xbgr.mr_n87123888)
print v(xbgr.mr_n87124512)
print v(xbgr.mr_n87124976)
print v(xbgr.mr_n87126176)
print v(xbgr.mr_n87128240)
print v(xbgr.mr_n87129776)
print v(xbgr.mr_n87134432)
print v(xbgr.mr_n87134544)
print v(xbgr.mr_n87134816)
print v(xbgr.mr_n87135200)
print v(xbgr.mr_n87137888)
print v(xbgr.mr_n87138032)
print v(xbgr.mr_n87142896)
print v(xbgr.mr_n87143456)
print v(xbgr.mr_n87144224)
print v(xbgr.mr_n87144496)
print v(xbgr.mr_n87145072)
print v(xbgr.mr_n87145456)
print v(xbgr.mr_n87146208)
print v(xbgr.mr_n87146320)
print v(xbgr.mr_n87146912)
print v(xbgr.mr_n87147184)
print v(xbgr.mr_n87147696)
print v(xbgr.mr_n87167184)
print v(xbgr.mr_n87167888)
print v(xbgr.mr_n87168064)
print v(xbgr.mr_n87168624)
print v(xbgr.mr_n87169152)
print v(xbgr.mr_n87169328)
print v(xbgr.mr_n87169504)
print v(xbgr.mr_n87170288)
print v(xbgr.mr_n87170464)
print v(xbgr.mr_n87177440)
print v(xbgr.mr_n87179312)
print v(xbgr.mr_n87179776)
print v(xbgr.mr_n87180240)
print v(xbgr.mr_n87180704)
print v(xbgr.mr_n87181136)
print v(xbgr.mr_n87181600)
print v(xbgr.mr_n87182064)
print v(xbgr.mr_n87182528)
print v(xbgr.mr_n87182992)
print v(xbgr.mr_n87183456)
print v(xbgr.mr_n87183920)
print v(xbgr.mr_n87184384)
print v(xbgr.mr_n87184848)
print v(xbgr.mr_n87185312)
print v(xbgr.mr_n87185776)
print v(xbgr.mr_n87186240)
print v(xbgr.mr_n87186704)
print v(xbgr.mr_n87187792)
print v(xbgr.mr_n87191952)
print v(xbgr.mr_n87203488)
print v(xbgr.mr_n87214496)
print v(xbgr.mr_n87221056)
print v(xbgr.mr_n87221200)
print v(xbgr.mr_n87221312)
print v(xbgr.mr_n87222224)
print v(xbgr.mr_n87222416)
print v(xbgr.mr_n87222672)
print v(xbgr.mr_n87222928)
print v(xbgr.mr_n87224896)
print v(xbgr.mr_n87225680)
print v(xbgr.mr_n87225952)
print v(xbgr.mr_n87228544)
print v(xbgr.mr_n87229872)
print v(xbgr.mr_n87231920)
print v(xbgr.mr_n87234688)
print v(xbgr.mr_n87236016)
print v(xbgr.mr_n87238064)
print v(xbgr.mr_n87240832)
print v(xbgr.mr_n87242160)
print v(xbgr.mr_n87244208)
print v(xbgr.mr_n87246976)
print v(xbgr.mr_n87248304)
print v(xbgr.mr_n87250352)
print v(xbgr.mr_n87253120)
print v(xbgr.mr_n87254448)
print v(xbgr.mr_n87256496)
print v(xbgr.mr_n87259264)
print v(xbgr.mr_n87260592)
print v(xbgr.mr_n87264416)
print v(xbgr.mr_n87267904)
print v(xbgr.mr_n87268304)
print v(xbgr.mr_n87268704)
print v(xbgr.mr_n87269104)
print v(xbgr.mr_n87269504)
print v(xbgr.mr_n87269824)
print v(xbgr.mr_n87270224)
print v(xbgr.mr_n87270624)
print v(xbgr.mr_n87271024)
print v(xbgr.mr_n87271424)
print v(xbgr.mr_n87271824)
print v(xbgr.mr_n87272224)
print v(xbgr.mr_n87272624)
print v(xbgr.mr_n87273024)
print v(xbgr.mr_n87273424)
print v(xbgr.mr_n87273824)
print v(xbgr.mr_n87274096)
print v(xbgr.mr_n87274208)
print v(xbgr.mr_n87274320)
print v(xbgr.mr_n87274432)
print v(xbgr.mr_n87274544)
print v(xbgr.mr_n87274736)
print v(xbgr.mr_n87275008)
print v(xbgr.mr_n87275280)
print v(xbgr.mr_n87275552)
print v(xbgr.mr_n87275824)
print v(xbgr.mr_n87276096)
print v(xbgr.mr_n87276368)
print v(xbgr.mr_n87276640)
print v(xbgr.mr_n87276976)
print v(xbgr.mr_n87277376)
print v(xbgr.mr_n87288400)
print v(xbgr.mr_n87289936)
print v(xbgr.mr_n87291600)
print v(xbgr.mr_n87292208)
print v(xbgr.mr_n87292384)
print v(xbgr.mr_n87293232)
print v(xbgr.mr_n87293712)
print v(xbgr.mr_n87294144)
print v(xbgr.mr_n87294752)
print v(xbgr.mr_n87294928)
print v(xbgr.mr_n87295776)
print v(xbgr.mr_n87296256)
print v(xbgr.mr_n87296752)
print v(xbgr.mr_n87297296)
print v(xbgr.mr_n87297472)
print v(xbgr.mr_n87298320)
print v(xbgr.mr_n87298800)
print v(xbgr.mr_n87299232)
print v(xbgr.mr_n87299840)
print v(xbgr.mr_n87300016)
print v(xbgr.mr_n87300864)
print v(xbgr.mr_n87301344)
print v(xbgr.mr_n87301840)
print v(xbgr.mr_n87302384)
print v(xbgr.mr_n87302560)
print v(xbgr.mr_n87303408)
print v(xbgr.mr_n87303888)
print v(xbgr.mr_n87304384)
print v(xbgr.mr_n87304928)
print v(xbgr.mr_n87305104)
print v(xbgr.mr_n87305888)
print v(xbgr.mr_n87306224)
print v(xbgr.mr_n87306336)
print v(xbgr.mr_n87306560)
print v(xbgr.mr_n87307168)
print v(xbgr.mr_n87307680)
print v(xbgr.mr_n87308448)
print v(xbgr.mr_n87308864)
print v(xbgr.mr_n87308976)
print v(xbgr.mr_n87309168)
print v(xbgr.mr_n87309632)
print v(xbgr.mr_n87310096)
print v(xbgr.mr_n87310560)
print v(xbgr.mr_n87311024)
print v(xbgr.mr_n87312112)
print v(xbgr.mr_n87316656)
print v(xbgr.mr_n87317408)
print v(xbgr.mr_n87323152)
print v(xbgr.mr_n87323344)
print v(xbgr.mr_n87323600)
print v(xbgr.mr_n87323856)
print v(xbgr.mr_n87325824)
print v(xbgr.mr_n87349552)
print v(xbgr.mr_n87350048)
print v(xbgr.mr_n87350352)
print v(xbgr.mr_n87350848)
print v(xbgr.mr_n87351152)
print v(xbgr.mr_n87351712)
print v(xbgr.mr_n87352016)
print v(xbgr.mr_n87352896)
print v(xbgr.mr_n87353200)
print v(xbgr.mr_n87354080)
print v(xbgr.mr_n87354384)
print v(xbgr.mr_n87355264)
print v(xbgr.mr_n87355568)
print v(xbgr.mr_n87356448)
print v(xbgr.mr_n87356752)
print v(xbgr.mr_n87357632)
print v(xbgr.mr_n87357936)
print v(xbgr.mr_n87358816)
print v(xbgr.mr_n87359120)
print v(xbgr.mr_n87360000)
print v(xbgr.mr_n87360304)
print v(xbgr.mr_n87361184)
print v(xbgr.mr_n87361488)
print v(xbgr.mr_n87362368)
print v(xbgr.mr_n87362672)
print v(xbgr.mr_n87363552)
print v(xbgr.mr_n87363856)
print v(xbgr.mr_n87364736)
print v(xbgr.mr_n87365040)
print v(xbgr.mr_n87365920)
print v(xbgr.mr_n87366112)
print v(xbgr.mr_n87366384)
print v(xbgr.mr_n87366848)
print v(xbgr.mr_n87380624)
print v(xbgr.mr_n87380960)
print v(xbgr.mr_n87381296)
print v(xbgr.mr_n87381632)
print v(xbgr.mr_n87383520)
print v(xbgr.mr_n87384432)
print v(xbgr.mr_n87384832)
print v(xbgr.mr_n87385232)
print v(xbgr.mr_n87385632)
print v(xbgr.mr_n87386032)
print v(xbgr.mr_n87386432)
print v(xbgr.mr_n87386832)
print v(xbgr.mr_n87387232)
print v(xbgr.mr_n87387632)
print v(xbgr.mr_n87388032)
print v(xbgr.mr_n87388432)
print v(xbgr.mr_n87388832)
print v(xbgr.mr_n87389232)
print v(xbgr.mr_n87389632)
print v(xbgr.mr_n87390032)
print v(xbgr.mr_n87390432)
print v(xbgr.mr_n87417136)
print v(xbgr.mr_n87417600)
print v(xbgr.mr_n87420848)
print v(xbgr.mr_n87421152)
print v(xbgr.mr_n87421456)
print v(xbgr.mr_n87421760)
print v(xbgr.mr_n87422144)
print v(xbgr.mr_n87422608)
print v(xbgr.mr_n87423072)
print v(xbgr.mr_n87423536)
print v(xbgr.mr_n87424000)
print v(xbgr.mr_n87424464)
print v(xbgr.mr_n87424928)
print v(xbgr.mr_n87425392)
print v(xbgr.mr_n87425856)
print v(xbgr.mr_n87430144)
print v(xbgr.mr_n87430496)
print v(xbgr.mr_n87431776)
print v(xbgr.mr_n87431952)
print v(xbgr.mr_n87432160)
print v(xbgr.mr_n87437104)
print v(xbgr.mr_n87437328)
print v(xbgr.mr_n87437664)
print v(xbgr.mr_n87437808)
print v(xbgr.mr_n87438000)
print v(xbgr.mr_n87438336)
print v(xbgr.mr_n87440512)
print v(xbgr.mr_n87442592)
print v(xbgr.mr_n87442928)
print v(xbgr.mr_n87444368)
print v(xbgr.mr_n87445152)
print v(xbgr.mr_n87447424)
print v(xbgr.mr_n87447536)
print v(xbgr.mr_n87447648)
print v(xbgr.mr_n87447920)
print v(xbgr.mr_n87450032)
print v(xbgr.mr_n87450672)
print v(xbgr.mr_n87450784)
print v(xbgr.mr_n87452480)
print v(xbgr.mr_n87452592)
print v(xbgr.mr_n87452704)
print v(xbgr.mr_n87452976)
print v(xbgr.mr_n87454944)
print v(xbgr.mr_n87455728)
print v(xbgr.mr_n87455840)
print v(xbgr.mr_n87457104)
print v(xbgr.mr_n87457808)
print v(xbgr.mr_n87458448)
print v(xbgr.mr_n87458560)
print v(xbgr.mr_n87460144)
print v(xbgr.mr_n87460784)
print v(xbgr.mr_n87460896)
print v(xbgr.mr_n87462592)
print v(xbgr.mr_n87462704)
print v(xbgr.mr_n87462816)
print v(xbgr.mr_n87463088)
print v(xbgr.mr_n87465248)
print v(xbgr.mr_n87465360)
print v(xbgr.mr_n87465552)
print v(xbgr.mr_n87467024)
print v(xbgr.mr_n87467776)
print v(xbgr.mr_n87468560)
print v(xbgr.mr_n87468672)
print v(xbgr.mr_n87470176)
print v(xbgr.mr_n87470896)
print v(xbgr.mr_n87471008)
print v(xbgr.mr_n87472704)
print v(xbgr.mr_n87472816)
print v(xbgr.mr_n87472928)
print v(xbgr.mr_n87473200)
print v(xbgr.mr_n87475360)
print v(xbgr.mr_n87475472)
print v(xbgr.mr_n87475664)
print v(xbgr.mr_n87477696)
print v(xbgr.mr_n87477808)
print v(xbgr.mr_n87477920)
print v(xbgr.mr_n87478192)
print v(xbgr.mr_n87480416)
print v(xbgr.mr_n87480528)
print v(xbgr.mr_n87480720)
print v(xbgr.mr_n87481232)
print v(xbgr.mr_n87481504)
print v(xbgr.mr_n87481920)
print v(xbgr.mr_n87482544)
print v(xbgr.mr_n87483008)
print v(xbgr.mr_n87483424)
print v(xbgr.mr_n87484112)
print v(xbgr.mr_n87484640)
print v(xbgr.mr_n87484992)
print v(xbgr.mr_n87485248)
print v(xbgr.mr_n87485680)
print v(xbgr.mr_n87486144)
print v(xbgr.mr_n87486560)
print v(xbgr.mr_n87487248)
print v(xbgr.mr_n87487712)
print v(xbgr.mr_n87488128)
print v(xbgr.mr_n87488816)
print v(xbgr.mr_n87489344)
print v(xbgr.mr_n87489696)
print v(xbgr.mr_n87490384)
print v(xbgr.mr_n87490848)
print v(xbgr.mr_n87491264)
print v(xbgr.mr_n87491952)
print v(xbgr.mr_n87492480)
print v(xbgr.mr_n87492832)
print v(xbgr.mr_n87493520)
print v(xbgr.mr_n87493984)
print v(xbgr.mr_n87494400)
print v(xbgr.mr_n87495088)
print v(xbgr.mr_n87495616)
print v(xbgr.mr_n87495968)
print v(xbgr.mr_n87496656)
print v(xbgr.mr_n87497120)
print v(xbgr.mr_n87497536)
print v(xbgr.mr_n87498224)
print v(xbgr.mr_n87498752)
print v(xbgr.mr_n87502304)
print v(xbgr.mr_n87503968)
print v(xbgr.mr_n87504272)
print v(xbgr.mr_n87504656)
print v(xbgr.mr_n87505024)
print v(xbgr.mr_n87511040)
print v(xbgr.mr_n87519584)
print v(xbgr.mr_n87520048)
print v(xbgr.mr_n87520512)
print v(xbgr.mr_n87520976)
print v(xbgr.mr_n87521440)
print v(xbgr.mr_n87521904)
print v(xbgr.mr_n87522368)
print v(xbgr.mr_n87522832)
print v(xbgr.mr_n87523296)
print v(xbgr.mr_n87523760)
print v(xbgr.mr_n87524224)
print v(xbgr.mr_n87524688)
print v(xbgr.mr_n87525152)
print v(xbgr.mr_n87525616)
print v(xbgr.mr_n87526080)
print v(xbgr.mr_n87526544)
print v(xbgr.mr_n87527008)
print v(xbgr.mr_n87527472)
print v(xbgr.mr_n87527936)
print v(xbgr.mr_n87528400)
print v(xbgr.mr_n87537216)
print v(xbgr.mr_n87538240)
print v(xbgr.mr_n87542928)
print v(xbgr.mr_n87543552)
print v(xbgr.mr_n87544272)
print v(xbgr.mr_n87548176)
print v(xbgr.mr_n87548928)
print v(xbgr.mr_n87551472)
print v(xbgr.mr_n87551664)
print v(xbgr.mr_n87551920)
print v(xbgr.mr_n87552176)
print v(xbgr.mr_n87554144)
print v(xbgr.mr_n87576896)
print v(xbgr.mr_n87577600)
print v(xbgr.mr_n87577712)
print v(xbgr.mr_n87578224)
print v(xbgr.mr_n87578336)
print v(xbgr.mr_n87578448)
print v(xbgr.mr_n87578960)
print v(xbgr.mr_n87579072)
print v(xbgr.mr_n87579424)
print v(xbgr.mr_n87579536)
print v(xbgr.mr_n87579888)
print v(xbgr.mr_n87580000)
print v(xbgr.mr_n87580352)
print v(xbgr.mr_n87580464)
print v(xbgr.mr_n87580816)
print v(xbgr.mr_n87580992)
print v(xbgr.mr_n87581472)
print v(xbgr.mr_n87581648)
print v(xbgr.mr_n87582128)
print v(xbgr.mr_n87582304)
print v(xbgr.mr_n87582784)
print v(xbgr.mr_n87582960)
print v(xbgr.mr_n87583440)
print v(xbgr.mr_n87583616)
print v(xbgr.mr_n87584096)
print v(xbgr.mr_n87584272)
print v(xbgr.mr_n87586256)
print v(xbgr.mr_n87587632)
print v(xbgr.mr_n87587968)
print v(xbgr.mr_n87588544)
print v(xbgr.mr_n87589456)
print v(xbgr.mr_n87589632)
print v(xbgr.mr_n87589808)
print v(xbgr.mr_n87590512)
print v(xbgr.mr_n87590688)
print v(xbgr.mr_n87591248)
print v(xbgr.mr_n87591712)
print v(xbgr.mr_n87591888)
print v(xbgr.mr_n87592064)
print v(xbgr.mr_n87592768)
print v(xbgr.mr_n87592944)
print v(xbgr.mr_n87593568)
print v(xbgr.mr_n87593744)
print v(xbgr.mr_n87593920)
print v(xbgr.mr_n87594432)
print v(xbgr.mr_n87594864)
print v(xbgr.mr_n87595040)
print v(xbgr.mr_n87595296)
print v(xbgr.mr_n87596080)
print v(xbgr.mr_n87596256)
print v(xbgr.mr_n87596880)
print v(xbgr.mr_n87597056)
print v(xbgr.mr_n87597232)
print v(xbgr.mr_n87597936)
print v(xbgr.mr_n87598112)
print v(xbgr.mr_n87598736)
print v(xbgr.mr_n87598912)
print v(xbgr.mr_n87599088)
print v(xbgr.mr_n87599728)
print v(xbgr.mr_n87600000)
print v(xbgr.mr_n87600432)
print v(xbgr.mr_n87600608)
print v(xbgr.mr_n87600864)
print v(xbgr.mr_n87601648)
print v(xbgr.mr_n87601824)
print v(xbgr.mr_n87602448)
print v(xbgr.mr_n87602624)
print v(xbgr.mr_n87602800)
print v(xbgr.mr_n87603440)
print v(xbgr.mr_n87603712)
print v(xbgr.mr_n87603824)
print v(xbgr.mr_n87603936)
print v(xbgr.mr_n87604048)
print v(xbgr.mr_n87604160)
print v(xbgr.mr_n87604432)
print v(xbgr.mr_n87604784)
print v(xbgr.mr_n87604896)
print v(xbgr.mr_n87605008)
print v(xbgr.mr_n87605440)
print v(xbgr.mr_n87605920)
print v(xbgr.mr_n87606096)
print v(xbgr.mr_n87606448)
print v(xbgr.mr_n87606816)
print v(xbgr.mr_n87607152)
print v(xbgr.mr_n87607504)
print v(xbgr.mr_n87607616)
print v(xbgr.mr_n87608112)
print v(xbgr.mr_n87608608)
print v(xbgr.mr_n87609088)
print v(xbgr.mr_n87609264)
print v(xbgr.mr_n87609616)
print v(xbgr.mr_n87609984)
print v(xbgr.mr_n87610320)
print v(xbgr.mr_n87610672)
print v(xbgr.mr_n87610784)
print v(xbgr.mr_n87611280)
print v(xbgr.mr_n87611776)
print v(xbgr.mr_n87612256)
print v(xbgr.mr_n87612432)
print v(xbgr.mr_n87612784)
print v(xbgr.mr_n87613152)
print v(xbgr.mr_n87613488)
print v(xbgr.mr_n87613840)
print v(xbgr.mr_n87615984)
print v(xbgr.mr_n87625728)
print v(xbgr.mr_n87626112)
print v(xbgr.mr_n87626576)
print v(xbgr.mr_n87627040)
print v(xbgr.mr_n87627504)
print v(xbgr.mr_n87627968)
print v(xbgr.mr_n87628432)
print v(xbgr.mr_n87628896)
print v(xbgr.mr_n87629360)
print v(xbgr.mr_n87629824)
print v(xbgr.mr_n87630288)
print v(xbgr.mr_n87630752)
print v(xbgr.mr_n87631216)
print v(xbgr.mr_n87631680)
print v(xbgr.mr_n87632144)
print v(xbgr.mr_n87632608)
print v(xbgr.mr_n87633072)
print v(xbgr.mr_n87633536)
print v(xbgr.mr_n87634000)
print v(xbgr.mr_n87634464)
print v(xbgr.mr_n87634928)
print v(xbgr.mr_n87635392)
print v(xbgr.mr_n87635856)
print v(xbgr.mr_n87636320)
print v(xbgr.mr_n87636848)
print v(xbgr.mr_n87637440)
print v(xbgr.mr_n87662720)
print v(xbgr.mr_n87663104)
print v(xbgr.mr_n87669968)
print v(xbgr.mr_n87670144)
print v(xbgr.mr_n87670480)
print v(xbgr.mr_n87672544)
print v(xbgr.mr_n87672656)
print v(xbgr.mr_n87672848)
print v(xbgr.mr_n87673600)
print v(xbgr.mr_n87675888)
print v(xbgr.mr_n87676224)
print v(xbgr.mr_n87676976)
print v(xbgr.mr_n87686768)
print v(xbgr.mr_n87686880)
print v(xbgr.mr_n87687312)
print v(xbgr.mr_n87687504)
print v(xbgr.mr_n87690880)
print v(xbgr.mr_n87691760)
print v(xbgr.mr_n87691936)
print v(xbgr.mr_n87692320)
print v(xbgr.mr_n87693168)
print v(xbgr.mr_n87693648)
print v(xbgr.mr_n87694016)
print v(xbgr.mr_n87694448)
print v(xbgr.mr_n87694624)
print v(xbgr.mr_n87694960)
print v(xbgr.mr_n87695664)
print v(xbgr.mr_n87695840)
print v(xbgr.mr_n87696464)
print v(xbgr.mr_n87696640)
print v(xbgr.mr_n87697152)
print v(xbgr.mr_n87697264)
print v(xbgr.mr_n87697440)
print v(xbgr.mr_n87698064)
print v(xbgr.mr_n87698240)
print v(xbgr.mr_n87698864)
print v(xbgr.mr_n87699040)
print v(xbgr.mr_n87699664)
print v(xbgr.mr_n87699840)
print v(xbgr.mr_n87700320)
print v(xbgr.mr_n87700464)
print v(xbgr.mr_n87700640)
print v(xbgr.mr_n87701200)
print v(xbgr.mr_n87701312)
print v(xbgr.mr_n87701584)
print v(xbgr.mr_n87701856)
print v(xbgr.mr_n87702048)
print v(xbgr.mr_n87702304)
print v(xbgr.mr_n87702656)
print v(xbgr.mr_n87704352)
print v(xbgr.mr_n87704928)
print v(xbgr.mr_n87705952)
print v(xbgr.mr_n87706176)
print v(xbgr.mr_n87707232)
print v(xbgr.mr_n87707872)
print v(xbgr.mr_n87708384)
print v(xbgr.mr_n87711024)
print v(xbgr.mr_n87711296)
print v(xbgr.mr_n87711568)
print v(xbgr.mr_n87712032)
print v(xbgr.mr_n87712224)
print v(xbgr.mr_n87712464)
print v(xbgr.mr_n87712656)
print v(xbgr.mr_n87712928)
print v(xbgr.mr_n87713168)
print v(xbgr.mr_n87714976)
print v(xbgr.mr_n87715280)
print v(xbgr.mr_n87716368)
print v(xbgr.mr_n87716912)
print v(xbgr.mr_n87717088)
print v(xbgr.mr_n87718112)
print v(xbgr.mr_n87718224)
print v(xbgr.mr_n87718336)
print v(xbgr.mr_n87718480)
print v(xbgr.mr_n87720112)
print v(xbgr.mr_n87720336)
print v(xbgr.mr_n87721776)
print v(xbgr.mr_n87721920)
print v(xbgr.mr_n87722112)
print v(xbgr.mr_n87722256)
print v(xbgr.mr_n87722448)
print v(xbgr.mr_n87722592)
print v(xbgr.mr_n87722784)
print v(xbgr.mr_n87723600)
print v(xbgr.mr_n87724096)
print v(xbgr.mr_n87724576)
print v(xbgr.mr_n87724800)
print v(xbgr.mr_n87726416)
print v(xbgr.mr_n87727888)
print v(xbgr.mr_n87728880)
print v(xbgr.mr_n87729056)
print v(xbgr.mr_n87730192)
print v(xbgr.mr_n87730768)
print v(xbgr.mr_n87730960)
print v(xbgr.mr_n87731152)
print v(xbgr.mr_n87731504)
print v(xbgr.mr_n87731680)
print v(xbgr.mr_n87733008)
print v(xbgr.mr_n87733232)
print v(xbgr.mr_n87733936)
print v(xbgr.mr_n87734512)
print v(xbgr.mr_n87735264)
print v(xbgr.mr_n87735456)
print v(xbgr.mr_n87735856)
print v(xbgr.mr_n87736880)
print v(xbgr.mr_n87737408)
print v(xbgr.mr_n87737792)
print v(xbgr.mr_n87738752)
print v(xbgr.mr_n87739456)
print v(xbgr.mr_n87739744)
print v(xbgr.mr_n87740160)
print v(xbgr.mr_n87740672)
print v(xbgr.mr_n87740816)
print v(xbgr.mr_n87742480)
print v(xbgr.mr_n87742768)
print v(xbgr.mr_n87743120)
print v(xbgr.mr_n87743712)
print v(xbgr.mr_n87744192)
print v(xbgr.mr_n87744560)
print v(xbgr.mr_n87744672)
print v(xbgr.mr_n87746912)
print v(xbgr.mr_n87747472)
print v(xbgr.mr_n87747584)
print v(xbgr.mr_n87748192)
print v(xbgr.mr_n87748768)
print v(xbgr.mr_n87749184)
print v(xbgr.mr_n87750800)
print v(xbgr.mr_n87751408)
print v(xbgr.mr_n87751600)
print v(xbgr.mr_n87752224)
print v(xbgr.mr_n87752976)
print v(xbgr.mr_n87753152)
print v(xbgr.mr_n87753632)
print v(xbgr.mr_n87754400)
print v(xbgr.mr_n87755488)
print v(xbgr.mr_n87756096)
print v(xbgr.mr_n87756288)
print v(xbgr.mr_n87756480)
print v(xbgr.mr_n87756672)
print v(xbgr.mr_n87757632)
print v(xbgr.mr_n87758048)
print v(xbgr.mr_n87759152)
print v(xbgr.mr_n87759504)
print v(xbgr.mr_n87759776)
print v(xbgr.mr_n87760048)
print v(xbgr.mr_n87760320)
print v(xbgr.mr_n87760592)
print v(xbgr.mr_n87760864)
print v(xbgr.mr_n87761136)
print v(xbgr.mr_n87761408)
print v(xbgr.mr_n87761680)
print v(xbgr.mr_n87761952)
print v(xbgr.mr_n87762416)
print v(xbgr.mr_n87762880)
print v(xbgr.mr_n87769968)
print v(xbgr.mr_n87773360)
print v(xbgr.mr_n87777072)
print v(xbgr.mr_n87778544)
print v(xbgr.mr_n87780624)
print v(xbgr.mr_n87787184)
print v(xbgr.mr_n87793552)
print v(xbgr.mr_n87797136)
print v(xbgr.mr_n87803152)
print v(xbgr.mr_n87808944)
print v(xbgr.mr_n87809584)
print v(xbgr.mr_n87809920)
print v(xbgr.mr_n87810256)
print v(xbgr.mr_n87810592)
print v(xbgr.mr_n87810768)
print v(xbgr.mr_n87810880)
print v(xbgr.mr_n87810992)
print v(xbgr.mr_n87811104)
print v(xbgr.mr_n87811216)
print v(xbgr.mr_n87811328)
print v(xbgr.mr_n87811440)
print v(xbgr.mr_n87811552)
print v(xbgr.mr_n87811664)
print v(xbgr.mr_n87811776)
print v(xbgr.mr_n87811888)
print v(xbgr.mr_n87812240)
print v(xbgr.mr_n87812592)
print v(xbgr.mr_n87812704)
print v(xbgr.mr_n87813056)
print v(xbgr.mr_n87813376)
print v(xbgr.mr_n87813648)
print v(xbgr.mr_n87813920)
print v(xbgr.mr_n87814192)
print v(xbgr.mr_n87814432)
print v(xbgr.mr_n87814544)
print v(xbgr.mr_n87814832)
print v(xbgr.mr_n87814944)
print v(xbgr.mr_n87817456)
print v(xbgr.mr_n87818992)
print v(xbgr.mr_n87819184)
print v(xbgr.mr_n87819376)
print v(xbgr.mr_n87820112)
print v(xbgr.mr_n87820288)
print v(xbgr.mr_n87820400)
print v(xbgr.mr_n87820512)
print v(xbgr.mr_n87824016)
print v(xbgr.mr_n87824800)
print v(xbgr.mr_n87825216)
print v(xbgr.mr_n87825408)
print v(xbgr.mr_n87825600)
print v(xbgr.mr_n87826640)
print v(xbgr.mr_n87826912)
print v(xbgr.mr_n87827872)
print v(xbgr.mr_n87828272)
print v(xbgr.mr_n87828624)
print v(xbgr.mr_n87829056)
print v(xbgr.mr_n87829360)
print v(xbgr.mr_n87829920)
print v(xbgr.mr_n87830336)
print v(xbgr.mr_n87830512)
print v(xbgr.mr_n87830768)
print v(xbgr.mr_n87831120)
print v(xbgr.mr_n87831552)
print v(xbgr.mr_n87832016)
print v(xbgr.mr_n87832368)
print v(xbgr.mr_n87832800)
print v(xbgr.mr_n87833104)
print v(xbgr.mr_n87833728)
print v(xbgr.mr_n87834080)
print v(xbgr.mr_n87834512)
print v(xbgr.mr_n87834864)
print v(xbgr.mr_n87835296)
print v(xbgr.mr_n87835760)
print v(xbgr.mr_n87836112)
print v(xbgr.mr_n87836544)
print v(xbgr.mr_n87836848)
print v(xbgr.mr_n87837408)
print v(xbgr.mr_n87837824)
print v(xbgr.mr_n87838256)
print v(xbgr.mr_n87838608)
print v(xbgr.mr_n87839040)
print v(xbgr.mr_n87839440)
print v(xbgr.mr_n87839856)
print v(xbgr.mr_n87840288)
print v(xbgr.mr_n87840592)
print v(xbgr.mr_n87841152)
print v(xbgr.mr_n87841568)
print v(xbgr.mr_n87841680)
print v(xbgr.mr_n87841872)
print v(xbgr.mr_n87842144)
print v(xbgr.mr_n87842416)
print v(xbgr.mr_n87842688)
print v(xbgr.mr_n87842960)
print v(xbgr.mr_n87843232)
print v(xbgr.mr_n87843504)
print v(xbgr.mr_n87843776)
print v(xbgr.mr_n87844048)
print v(xbgr.mr_n87844320)
print v(xbgr.mr_n87844592)
print v(xbgr.mr_n87844864)
print v(xbgr.mr_n87845136)
print v(xbgr.mr_n87845408)
print v(xbgr.mr_n87845680)
print v(xbgr.mr_n87846144)
print v(xbgr.mr_n87847280)
print v(xbgr.mr_n87849456)
print v(xbgr.mr_n87855712)
print v(xbgr.mr_n87857840)
print v(xbgr.mr_n87859728)
print v(xbgr.mr_n87860736)
print v(xbgr.mr_n87867152)
print v(xbgr.mr_n87867344)
print v(xbgr.mr_n87867536)
print v(xbgr.mr_n87867792)
print v(xbgr.mr_n87868048)
print v(xbgr.mr_n87870016)
print v(xbgr.mr_n87873232)
print v(xbgr.mr_n87875216)
print v(xbgr.mr_n87875408)
print v(xbgr.mr_n87875552)
print v(xbgr.mr_n87877520)
print v(xbgr.mr_n87878448)
print v(xbgr.mr_n87879232)
print v(xbgr.mr_n87881376)
print v(xbgr.mr_n87882032)
print v(xbgr.mr_n87882544)
print v(xbgr.mr_n87883840)
print v(xbgr.mr_n87884352)
print v(xbgr.mr_n87885568)
print v(xbgr.mr_n87886160)
print v(xbgr.mr_n87887456)
print v(xbgr.mr_n87887968)
print v(xbgr.mr_n87889024)
print v(xbgr.mr_n87889776)
print v(xbgr.mr_n87891072)
print v(xbgr.mr_n87891584)
print v(xbgr.mr_n87892880)
print v(xbgr.mr_n87893392)
print v(xbgr.mr_n87894688)
print v(xbgr.mr_n87895200)
print v(xbgr.mr_n87896416)
print v(xbgr.mr_n87897008)
print v(xbgr.mr_n87897120)
print v(xbgr.mr_n87897232)
print v(xbgr.mr_n87897344)
print v(xbgr.mr_n87897456)
print v(xbgr.mr_n87897648)
print v(xbgr.mr_n87898080)
print v(xbgr.mr_n87898192)
print v(xbgr.mr_n87898464)
print v(xbgr.mr_n87898816)
print v(xbgr.mr_n87899056)
print v(xbgr.mr_n87899456)
print v(xbgr.mr_n87899808)
print v(xbgr.mr_n87900240)
print v(xbgr.mr_n87900928)
print v(xbgr.mr_n87901552)
print v(xbgr.mr_n87902096)
print v(xbgr.mr_n87902528)
print v(xbgr.mr_n87902944)
print v(xbgr.mr_n87903632)
print v(xbgr.mr_n87904096)
print v(xbgr.mr_n87904512)
print v(xbgr.mr_n87904944)
print v(xbgr.mr_n87905632)
print v(xbgr.mr_n87906320)
print v(xbgr.mr_n87906800)
print v(xbgr.mr_n87907232)
print v(xbgr.mr_n87907648)
print v(xbgr.mr_n87908336)
print v(xbgr.mr_n87908864)
print v(xbgr.mr_n87909216)
print v(xbgr.mr_n87909648)
print v(xbgr.mr_n87910336)
print v(xbgr.mr_n87911024)
print v(xbgr.mr_n87911504)
print v(xbgr.mr_n87912352)
print v(xbgr.mr_n87913040)
print v(xbgr.mr_n87913568)
print v(xbgr.mr_n87913920)
print v(xbgr.mr_n87914352)
print v(xbgr.mr_n87915040)
print v(xbgr.mr_n87915664)
print v(xbgr.mr_n87916208)
print v(xbgr.mr_n87916640)
print v(xbgr.mr_n87917056)
print v(xbgr.mr_n87917744)
print v(xbgr.mr_n87918272)
print v(xbgr.mr_n87918624)
print v(xbgr.mr_n87919056)
print v(xbgr.mr_n87919744)
print v(xbgr.mr_n87920368)
print v(xbgr.mr_n87920912)
print v(xbgr.mr_n87921344)
print v(xbgr.mr_n87921760)
print v(xbgr.mr_n87921936)
print v(xbgr.mr_n87922448)
print v(xbgr.mr_n87922912)
print v(xbgr.mr_n87923328)
print v(xbgr.mr_n87923760)
print v(xbgr.mr_n87923952)
print v(xbgr.mr_n87924224)
print v(xbgr.mr_n87924496)
print v(xbgr.mr_n87924768)
print v(xbgr.mr_n87925040)
print v(xbgr.mr_n87925312)
print v(xbgr.mr_n87925584)
print v(xbgr.mr_n87925856)
print v(xbgr.mr_n87926128)
print v(xbgr.mr_n87926400)
print v(xbgr.mr_n87926672)
print v(xbgr.mr_n87926944)
print v(xbgr.mr_n87927216)
print v(xbgr.mr_n87928432)
print v(xbgr.mr_n87929696)
print v(xbgr.mr_n87930656)
print v(xbgr.mr_n87941168)
print v(xbgr.mr_n87944672)
print v(xbgr.mr_n87948400)
print v(xbgr.mr_n87950368)
print v(xbgr.mr_n87951328)
print v(xbgr.mr_n87951936)
print v(xbgr.mr_n87952400)
print v(xbgr.mr_n87952864)
print v(xbgr.mr_n87953328)
print v(xbgr.mr_n87953792)
print v(xbgr.mr_n87976896)
print v(xbgr.mr_n87977456)
print v(xbgr.mr_n87982224)
print v(xbgr.mr_n87982416)
print v(xbgr.mr_n87982672)
print v(xbgr.mr_n87982928)
print v(xbgr.mr_n87985568)
print v(xbgr.mr_n87990688)
print v(xbgr.mr_n87997232)
print v(xbgr.mr_n87997872)
print v(xbgr.mr_n87999168)
print v(xbgr.mr_n87999680)
print v(xbgr.mr_n88000976)
print v(xbgr.mr_n88001488)
print v(xbgr.mr_n88002784)
print v(xbgr.mr_n88003296)
print v(xbgr.mr_n88004192)
print v(xbgr.mr_n88004848)
print v(xbgr.mr_n88005360)
print v(xbgr.mr_n88006256)
print v(xbgr.mr_n88006832)
print v(xbgr.mr_n88007424)
print v(xbgr.mr_n88008320)
print v(xbgr.mr_n88008976)
print v(xbgr.mr_n88009488)
print v(xbgr.mr_n88010384)
print v(xbgr.mr_n88011040)
print v(xbgr.mr_n88011552)
print v(xbgr.mr_n88012448)
print v(xbgr.mr_n88013104)
print v(xbgr.mr_n88013616)
print v(xbgr.mr_n88014512)
print v(xbgr.mr_n88015168)
print v(xbgr.mr_n88015680)
print v(xbgr.mr_n88016576)
print v(xbgr.mr_n88017152)
print v(xbgr.mr_n88017744)
print v(xbgr.mr_n88018640)
print v(xbgr.mr_n88019296)
print v(xbgr.mr_n88019808)
print v(xbgr.mr_n88020704)
print v(xbgr.mr_n88021360)
print v(xbgr.mr_n88021872)
print v(xbgr.mr_n88022768)
print v(xbgr.mr_n88023424)
print v(xbgr.mr_n88023936)
print v(xbgr.mr_n88024832)
print v(xbgr.mr_n88025488)
print v(xbgr.mr_n88026000)
print v(xbgr.mr_n88026896)
print v(xbgr.mr_n88027312)
print v(xbgr.mr_n88028064)
print v(xbgr.mr_n88029360)
print v(xbgr.mr_n88029872)
print v(xbgr.mr_n88029984)
print v(xbgr.mr_n88030096)
print v(xbgr.mr_n88030208)
print v(xbgr.mr_n88030480)
print v(xbgr.mr_n88030592)
print v(xbgr.mr_n88030944)
print v(xbgr.mr_n88031056)
print v(xbgr.mr_n88031168)
print v(xbgr.mr_n88031600)
print v(xbgr.mr_n88032080)
print v(xbgr.mr_n88032256)
print v(xbgr.mr_n88032608)
print v(xbgr.mr_n88032976)
print v(xbgr.mr_n88033312)
print v(xbgr.mr_n88033664)
print v(xbgr.mr_n88033776)
print v(xbgr.mr_n88034272)
print v(xbgr.mr_n88034768)
print v(xbgr.mr_n88035248)
print v(xbgr.mr_n88035424)
print v(xbgr.mr_n88035776)
print v(xbgr.mr_n88036144)
print v(xbgr.mr_n88036480)
print v(xbgr.mr_n88036832)
print v(xbgr.mr_n88036944)
print v(xbgr.mr_n88037440)
print v(xbgr.mr_n88037936)
print v(xbgr.mr_n88038416)
print v(xbgr.mr_n88038592)
print v(xbgr.mr_n88038944)
print v(xbgr.mr_n88039376)
print v(xbgr.mr_n88039904)
print v(xbgr.mr_n88040256)
print v(xbgr.mr_n88040688)
print v(xbgr.mr_n88041376)
print v(xbgr.mr_n88042000)
print v(xbgr.mr_n88042544)
print v(xbgr.mr_n88042976)
print v(xbgr.mr_n88043392)
print v(xbgr.mr_n88044080)
print v(xbgr.mr_n88044608)
print v(xbgr.mr_n88044960)
print v(xbgr.mr_n88045216)
print v(xbgr.mr_n88045392)
print v(xbgr.mr_n88046080)
print v(xbgr.mr_n88046704)
print v(xbgr.mr_n88047120)
print v(xbgr.mr_n88047232)
print v(xbgr.mr_n88047424)
print v(xbgr.mr_n88047696)
print v(xbgr.mr_n88047968)
print v(xbgr.mr_n88048240)
print v(xbgr.mr_n88048512)
print v(xbgr.mr_n88048784)
print v(xbgr.mr_n88049056)
print v(xbgr.mr_n88049328)
print v(xbgr.mr_n88049600)
print v(xbgr.mr_n88049872)
print v(xbgr.mr_n88050144)
print v(xbgr.mr_n88050416)
print v(xbgr.mr_n88050688)
print v(xbgr.mr_n88050960)
print v(xbgr.mr_n88051232)
print v(xbgr.mr_n88051504)
print v(xbgr.mr_n88053744)
print v(xbgr.mr_n88067312)
print v(xbgr.mr_n88068848)
print v(xbgr.mr_n88069376)
print v(xbgr.mr_n88069840)
print v(xbgr.mr_n88070304)
print v(xbgr.mr_n88070768)
print v(xbgr.mr_n88071232)
print v(xbgr.mr_n88071696)
print v(xbgr.mr_n88072160)
print v(xbgr.mr_n88072688)
print v(xbgr.mr_n88073280)
print v(xbgr.mr_n88073872)
print v(xbgr.mr_n88074464)
print v(xbgr.mr_n88075056)
print v(xbgr.mr_n88075648)
print v(xbgr.mr_n88076240)
print v(xbgr.mr_n88076832)
print v(xbgr.mr_n88077424)
print v(xbgr.mr_n88077664)
print v(xbgr.mr_n88078016)
print v(xbgr.mr_n88080896)
print v(xbgr.mr_n88088448)
print v(xbgr.mr_n88089616)
print v(xbgr.mr_n88100848)
print v(xbgr.mr_n88102720)
print v(xbgr.mr_n88105264)
print v(xbgr.mr_n88106976)
print v(xbgr.mr_n88107168)
print v(xbgr.mr_n88107424)
print v(xbgr.mr_n88107680)
print v(xbgr.mr_n88109840)
print v(xbgr.mr_n88116928)
print v(xbgr.mr_n88117440)
print v(xbgr.mr_n88117872)
print v(xbgr.mr_n88117984)
print v(xbgr.mr_n88118912)
print v(xbgr.mr_n88122688)
print v(xbgr.mr_n88123200)
print v(xbgr.mr_n88124496)
print v(xbgr.mr_n88125008)
print v(xbgr.mr_n88126304)
print v(xbgr.mr_n88126816)
print v(xbgr.mr_n88127872)
print v(xbgr.mr_n88128624)
print v(xbgr.mr_n88129920)
print v(xbgr.mr_n88130432)
print v(xbgr.mr_n88131728)
print v(xbgr.mr_n88132240)
print v(xbgr.mr_n88133376)
print v(xbgr.mr_n88134048)
print v(xbgr.mr_n88135344)
print v(xbgr.mr_n88135856)
print v(xbgr.mr_n88137152)
print v(xbgr.mr_n88137664)
print v(xbgr.mr_n88138960)
print v(xbgr.mr_n88139472)
print v(xbgr.mr_n88140768)
print v(xbgr.mr_n88141280)
print v(xbgr.mr_n88142336)
print v(xbgr.mr_n88143088)
print v(xbgr.mr_n88144384)
print v(xbgr.mr_n88144896)
print v(xbgr.mr_n88146192)
print v(xbgr.mr_n88146704)
print v(xbgr.mr_n88146816)
print v(xbgr.mr_n88146928)
print v(xbgr.mr_n88147040)
print v(xbgr.mr_n88147312)
print v(xbgr.mr_n88147424)
print v(xbgr.mr_n88147776)
print v(xbgr.mr_n88147888)
print v(xbgr.mr_n88148160)
print v(xbgr.mr_n88148512)
print v(xbgr.mr_n88148624)
print v(xbgr.mr_n88148992)
print v(xbgr.mr_n88149552)
print v(xbgr.mr_n88150032)
print v(xbgr.mr_n88150464)
print v(xbgr.mr_n88150880)
print v(xbgr.mr_n88151568)
print v(xbgr.mr_n88152032)
print v(xbgr.mr_n88152448)
print v(xbgr.mr_n88152880)
print v(xbgr.mr_n88153568)
print v(xbgr.mr_n88154192)
print v(xbgr.mr_n88154736)
print v(xbgr.mr_n88155232)
print v(xbgr.mr_n88155584)
print v(xbgr.mr_n88155760)
print v(xbgr.mr_n88156272)
print v(xbgr.mr_n88156800)
print v(xbgr.mr_n88157152)
print v(xbgr.mr_n88157584)
print v(xbgr.mr_n88158272)
print v(xbgr.mr_n88158960)
print v(xbgr.mr_n88159440)
print v(xbgr.mr_n88159936)
print v(xbgr.mr_n88160288)
print v(xbgr.mr_n88160976)
print v(xbgr.mr_n88161440)
print v(xbgr.mr_n88161856)
print v(xbgr.mr_n88162288)
print v(xbgr.mr_n88162976)
print v(xbgr.mr_n88163664)
print v(xbgr.mr_n88164144)
print v(xbgr.mr_n88164640)
print v(xbgr.mr_n88164992)
print v(xbgr.mr_n88165680)
print v(xbgr.mr_n88166208)
print v(xbgr.mr_n88166560)
print v(xbgr.mr_n88166992)
print v(xbgr.mr_n88167680)
print v(xbgr.mr_n88168368)
print v(xbgr.mr_n88168848)
print v(xbgr.mr_n88169344)
print v(xbgr.mr_n88169696)
print v(xbgr.mr_n88170384)
print v(xbgr.mr_n88170912)
print v(xbgr.mr_n88171264)
print v(xbgr.mr_n88171696)
print v(xbgr.mr_n88172384)
print v(xbgr.mr_n88173072)
print v(xbgr.mr_n88173424)
print v(xbgr.mr_n88173536)
print v(xbgr.mr_n88173728)
print v(xbgr.mr_n88174000)
print v(xbgr.mr_n88174272)
print v(xbgr.mr_n88174544)
print v(xbgr.mr_n88174816)
print v(xbgr.mr_n88175088)
print v(xbgr.mr_n88175360)
print v(xbgr.mr_n88175632)
print v(xbgr.mr_n88175904)
print v(xbgr.mr_n88176176)
print v(xbgr.mr_n88176448)
print v(xbgr.mr_n88176720)
print v(xbgr.mr_n88176992)
print v(xbgr.mr_n88177264)
print v(xbgr.mr_n88177536)
print v(xbgr.mr_n88177808)
print v(xbgr.mr_n88178448)
print v(xbgr.mr_n88178832)
print v(xbgr.mr_n88193984)
print v(xbgr.mr_n88199040)
print v(xbgr.mr_n88201040)
print v(xbgr.mr_n88201568)
print v(xbgr.mr_n88202032)
print v(xbgr.mr_n88202496)
print v(xbgr.mr_n88202960)
print v(xbgr.mr_n88203424)
print v(xbgr.mr_n88203888)
print v(xbgr.mr_n88204352)
print v(xbgr.mr_n88204880)
print v(xbgr.mr_n88205472)
print v(xbgr.mr_n88206064)
print v(xbgr.mr_n88206656)
print v(xbgr.mr_n88207248)
print v(xbgr.mr_n88207840)
print v(xbgr.mr_n88208432)
print v(xbgr.mr_n88209024)
print v(xbgr.mr_n88209616)
print v(xbgr.mr_n88210208)
print v(xbgr.mr_n88211680)
print v(xbgr.mr_n88212496)
print v(xbgr.mr_n88222352)
print v(xbgr.mr_n88228048)
print v(xbgr.mr_n88228224)
print v(xbgr.mr_n88228560)
print v(xbgr.mr_n88229328)
print v(xbgr.mr_n88230336)
print v(xbgr.mr_n88230928)
print v(xbgr.mr_n88231520)
print v(xbgr.mr_n88232112)
print v(xbgr.mr_n88232704)
print v(xbgr.mr_n88233296)
print v(xbgr.mr_n88233888)
print v(xbgr.mr_n88234480)
print v(xbgr.mr_n88235072)
print v(xbgr.mr_n88235664)
print v(xbgr.mr_n88236256)
print v(xbgr.mr_n88236848)
print v(xbgr.mr_n88237440)
print v(xbgr.mr_n88238032)
print v(xbgr.mr_n88238624)
print v(xbgr.mr_n88239216)
print v(xbgr.mr_n88239808)
print v(xbgr.mr_n88240400)
print v(xbgr.mr_n88240992)
print v(xbgr.mr_n88243456)
print v(xbgr.mr_n88248240)
print v(xbgr.mr_n88248880)
print v(xbgr.mr_n88249904)
print v(xbgr.mr_n88250448)
print v(xbgr.mr_n88250944)
print v(xbgr.mr_n88251296)
print v(xbgr.mr_n88251408)
print v(xbgr.mr_n88252112)
print v(xbgr.mr_n88253040)
print v(xbgr.mr_n88253248)
print v(xbgr.mr_n88253360)
print v(xbgr.mr_n88253472)
print v(xbgr.mr_n88255152)
print v(xbgr.mr_n88257552)
print v(xbgr.mr_n88257984)
print v(xbgr.mr_n88258400)
print v(xbgr.mr_n88258512)
print v(xbgr.mr_n88259216)
print v(xbgr.mr_n88261456)
print v(xbgr.mr_n88261808)
print v(xbgr.mr_n88261920)
print v(xbgr.mr_n88262624)
print v(xbgr.mr_n88264800)
print v(xbgr.mr_n88265216)
print v(xbgr.mr_n88265328)
print v(xbgr.mr_n88266032)
print v(xbgr.mr_n88268272)
print v(xbgr.mr_n88268624)
print v(xbgr.mr_n88268736)
print v(xbgr.mr_n88269440)
print v(xbgr.mr_n88271616)
print v(xbgr.mr_n88272032)
print v(xbgr.mr_n88272144)
print v(xbgr.mr_n88272848)
print v(xbgr.mr_n88275088)
print v(xbgr.mr_n88275440)
print v(xbgr.mr_n88275552)
print v(xbgr.mr_n88276256)
print v(xbgr.mr_n88278432)
print v(xbgr.mr_n88278848)
print v(xbgr.mr_n88278960)
print v(xbgr.mr_n88279664)
print v(xbgr.mr_n88293616)
print v(xbgr.mr_n88293792)
print v(xbgr.mr_n88294416)
print v(xbgr.mr_n88294592)
print v(xbgr.mr_n88295216)
print v(xbgr.mr_n88295392)
print v(xbgr.mr_n88296016)
print v(xbgr.mr_n88296192)
print v(xbgr.mr_n88296816)
print v(xbgr.mr_n88296992)
print v(xbgr.mr_n88297616)
print v(xbgr.mr_n88297792)
print v(xbgr.mr_n88298416)
print v(xbgr.mr_n88298592)
print v(xbgr.mr_n88299216)
print v(xbgr.mr_n88299392)
print v(xbgr.mr_n88300016)
print v(xbgr.mr_n88300192)
print v(xbgr.mr_n88300816)
print v(xbgr.mr_n88300992)
print v(xbgr.mr_n88301616)
print v(xbgr.mr_n88301792)
print v(xbgr.mr_n88302416)
print v(xbgr.mr_n88302592)
print v(xbgr.mr_n88303216)
print v(xbgr.mr_n88303392)
print v(xbgr.mr_n88304016)
print v(xbgr.mr_n88304192)
print v(xbgr.mr_n88304816)
print v(xbgr.mr_n88304992)
print v(xbgr.mr_n88305616)
print v(xbgr.mr_n88305792)
print v(xbgr.mr_n88306224)
print v(xbgr.mr_n88306336)
print v(xbgr.mr_n88306448)
print v(xbgr.mr_n88306560)
print v(xbgr.mr_n88306752)
print v(xbgr.mr_n88307024)
print v(xbgr.mr_n88307296)
print v(xbgr.mr_n88307568)
print v(xbgr.mr_n88307840)
print v(xbgr.mr_n88308112)
print v(xbgr.mr_n88308384)
print v(xbgr.mr_n88308656)
print v(xbgr.mr_n88308928)
print v(xbgr.mr_n88309200)
print v(xbgr.mr_n88309472)
print v(xbgr.mr_n88309744)
print v(xbgr.mr_n88310016)
print v(xbgr.mr_n88310448)
print v(xbgr.mr_n88319408)
print v(xbgr.mr_n88323776)
print v(xbgr.mr_n88327744)
print v(xbgr.mr_n88340464)
print v(xbgr.mr_n88343552)
print v(xbgr.mr_n88346160)
print v(xbgr.mr_n88347504)
print v(xbgr.mr_n88347680)
print v(xbgr.mr_n88348016)
print v(xbgr.mr_n88349856)
print v(xbgr.mr_n88350032)
print v(xbgr.mr_n88350976)
print v(xbgr.mr_n88351632)
print v(xbgr.mr_n88351808)
print v(xbgr.mr_n88352752)
print v(xbgr.mr_n88353408)
print v(xbgr.mr_n88353584)
print v(xbgr.mr_n88354528)
print v(xbgr.mr_n88355184)
print v(xbgr.mr_n88355360)
print v(xbgr.mr_n88356304)
print v(xbgr.mr_n88356960)
print v(xbgr.mr_n88357136)
print v(xbgr.mr_n88358080)
print v(xbgr.mr_n88358736)
print v(xbgr.mr_n88358912)
print v(xbgr.mr_n88359856)
print v(xbgr.mr_n88360512)
print v(xbgr.mr_n88360688)
print v(xbgr.mr_n88361632)
print v(xbgr.mr_n88362288)
print v(xbgr.mr_n88362464)
print v(xbgr.mr_n88363408)
print v(xbgr.mr_n88364064)
print v(xbgr.mr_n88364240)
print v(xbgr.mr_n88365184)
print v(xbgr.mr_n88365840)
print v(xbgr.mr_n88366016)
print v(xbgr.mr_n88367056)
print v(xbgr.mr_n88367328)
print v(xbgr.mr_n88367600)
print v(xbgr.mr_n88367936)
print v(xbgr.mr_n88368400)
print v(xbgr.mr_n88368752)
print v(xbgr.mr_n88368944)
print v(xbgr.mr_n88369136)
print v(xbgr.mr_n88369328)
print v(xbgr.mr_n88370080)
print v(xbgr.mr_n88373664)
print v(xbgr.mr_n88374080)
print v(xbgr.mr_n88374192)
print v(xbgr.mr_n88374896)
print v(xbgr.mr_n88377072)
print v(xbgr.mr_n88377488)
print v(xbgr.mr_n88377600)
print v(xbgr.mr_n88378304)
print v(xbgr.mr_n88380544)
print v(xbgr.mr_n88380896)
print v(xbgr.mr_n88381008)
print v(xbgr.mr_n88381712)
print v(xbgr.mr_n88383952)
print v(xbgr.mr_n88384304)
print v(xbgr.mr_n88384416)
print v(xbgr.mr_n88385120)
print v(xbgr.mr_n88387296)
print v(xbgr.mr_n88388336)
print v(xbgr.mr_n88388448)
print v(xbgr.mr_n88388560)
print v(xbgr.mr_n88388976)
print v(xbgr.mr_n88389952)
print v(xbgr.mr_n88390304)
print v(xbgr.mr_n88390416)
print v(xbgr.mr_n88391120)
print v(xbgr.mr_n88393456)
print v(xbgr.mr_n88394608)
print v(xbgr.mr_n88395024)
print v(xbgr.mr_n88395136)
print v(xbgr.mr_n88395840)
print v(xbgr.mr_n88398016)
print v(xbgr.mr_n88398432)
print v(xbgr.mr_n88398544)
print v(xbgr.mr_n88399248)
print v(xbgr.mr_n88401424)
print v(xbgr.mr_n88401840)
print v(xbgr.mr_n88401952)
print v(xbgr.mr_n88402656)
print v(xbgr.mr_n88415216)
print v(xbgr.mr_n88415392)
print v(xbgr.mr_n88416016)
print v(xbgr.mr_n88416192)
print v(xbgr.mr_n88416816)
print v(xbgr.mr_n88416992)
print v(xbgr.mr_n88417616)
print v(xbgr.mr_n88417792)
print v(xbgr.mr_n88418416)
print v(xbgr.mr_n88418592)
print v(xbgr.mr_n88419216)
print v(xbgr.mr_n88419392)
print v(xbgr.mr_n88420016)
print v(xbgr.mr_n88420192)
print v(xbgr.mr_n88420816)
print v(xbgr.mr_n88420992)
print v(xbgr.mr_n88421616)
print v(xbgr.mr_n88421792)
print v(xbgr.mr_n88422416)
print v(xbgr.mr_n88422592)
print v(xbgr.mr_n88423216)
print v(xbgr.mr_n88423392)
print v(xbgr.mr_n88424016)
print v(xbgr.mr_n88424192)
print v(xbgr.mr_n88424816)
print v(xbgr.mr_n88424992)
print v(xbgr.mr_n88425616)
print v(xbgr.mr_n88425792)
print v(xbgr.mr_n88426416)
print v(xbgr.mr_n88426592)
print v(xbgr.mr_n88427216)
print v(xbgr.mr_n88427392)
print v(xbgr.mr_n88428992)
print v(xbgr.mr_n88431872)
print v(xbgr.mr_n88434304)
print v(xbgr.mr_n88434480)
print v(xbgr.mr_n88435328)
print v(xbgr.mr_n88439024)
print v(xbgr.mr_n88439328)
print v(xbgr.mr_n88439632)
print v(xbgr.mr_n88439936)
print v(xbgr.mr_n88440320)
print v(xbgr.mr_n88440784)
print v(xbgr.mr_n88441248)
print v(xbgr.mr_n88441712)
print v(xbgr.mr_n88442176)
print v(xbgr.mr_n88442640)
print v(xbgr.mr_n88443104)
print v(xbgr.mr_n88443568)
print v(xbgr.mr_n88444032)
print v(xbgr.mr_n88444496)
print v(xbgr.mr_n88444960)
print v(xbgr.mr_n88445424)
print v(xbgr.mr_n88445888)
print v(xbgr.mr_n88446352)
print v(xbgr.mr_n88446816)
print v(xbgr.mr_n88447280)
print v(xbgr.mr_n88447744)
print v(xbgr.mr_n88448208)
print v(xbgr.mr_n88448672)
print v(xbgr.mr_n88449136)
print v(xbgr.mr_n88449600)
print v(xbgr.mr_n88450064)
print v(xbgr.mr_n88450528)
print v(xbgr.mr_n88450992)
print v(xbgr.mr_n88451456)
print v(xbgr.mr_n88451920)
print v(xbgr.mr_n88458304)
print v(xbgr.mr_n88460096)
print v(xbgr.mr_n88469584)
print v(xbgr.mr_n88476512)
print v(xbgr.mr_n88476976)
print v(xbgr.mr_n88477440)
print v(xbgr.mr_n88477968)
print v(xbgr.mr_n88478560)
print v(xbgr.mr_n88479152)
print v(xbgr.mr_n88479744)
print v(xbgr.mr_n88480336)
print v(xbgr.mr_n88480928)
print v(xbgr.mr_n88481520)
print v(xbgr.mr_n88482112)
print v(xbgr.mr_n88482704)
print v(xbgr.mr_n88483296)
print v(xbgr.mr_n88483888)
print v(xbgr.mr_n88484480)
print v(xbgr.mr_n88485072)
print v(xbgr.mr_n88485664)
print v(xbgr.mr_n88503056)
print v(xbgr.mr_n88508192)
print v(xbgr.mr_n88508576)
print v(xbgr.mr_n88508768)
print v(xbgr.mr_n88509024)
print v(xbgr.mr_n88509280)
print v(xbgr.mr_n88511440)
print v(xbgr.mr_n88537584)
print v(xbgr.mr_n88538976)
print v(xbgr.mr_n88541248)
print v(xbgr.mr_n88555536)
print v(xbgr.mr_n88555936)
print v(xbgr.mr_n88576736)
print v(xbgr.mr_n88577328)
print v(xbgr.mr_n88577920)
print v(xbgr.mr_n88578512)
print v(xbgr.mr_n88579104)
print v(xbgr.mr_n88579696)
print v(xbgr.mr_n88580288)
print v(xbgr.mr_n88580880)
print v(xbgr.mr_n88581472)
print v(xbgr.mr_n88582064)
print v(xbgr.mr_n88582656)
print v(xbgr.mr_n88583248)
print v(xbgr.mr_n88584592)
print v(xbgr.mr_n88586304)
print v(xbgr.mr_n88586768)
print v(xbgr.mr_n88588016)
print v(xbgr.mr_n88590432)
print v(xbgr.mr_n88590608)
print v(xbgr.mr_n88590784)
print v(xbgr.mr_n88591040)
print v(xbgr.mr_n88592576)
print v(xbgr.mr_n88593104)
print v(xbgr.mr_n88595088)
print v(xbgr.mr_n88597040)
print v(xbgr.mr_n88597376)
print v(xbgr.mr_n88597712)
print v(xbgr.mr_n88599152)
print v(xbgr.mr_n88600192)
print v(xbgr.mr_n88600368)
print v(xbgr.mr_n88600880)
print v(xbgr.mr_n88601376)
print v(xbgr.mr_n88601552)
print v(xbgr.mr_n88601888)
print v(xbgr.mr_n88602480)
print v(xbgr.mr_n88602976)
print v(xbgr.mr_n88603312)
print v(xbgr.mr_n88603824)
print v(xbgr.mr_n88603936)
print v(xbgr.mr_n88604048)
print v(xbgr.mr_n88605040)
print v(xbgr.mr_n88605376)
print v(xbgr.mr_n88605968)
print v(xbgr.mr_n88606464)
print v(xbgr.mr_n88606640)
print v(xbgr.mr_n88607056)
print v(xbgr.mr_n88607568)
print v(xbgr.mr_n88608128)
print v(xbgr.mr_n88608304)
print v(xbgr.mr_n88608800)
print v(xbgr.mr_n88609568)
print v(xbgr.mr_n88609744)
print v(xbgr.mr_n88609920)
print v(xbgr.mr_n88610512)
print v(xbgr.mr_n88610624)
print v(xbgr.mr_n88610736)
print v(xbgr.mr_n88610848)
print v(xbgr.mr_n88612336)
print v(xbgr.mr_n88612512)
print v(xbgr.mr_n88613008)
print v(xbgr.mr_n88613792)
print v(xbgr.mr_n88613968)
print v(xbgr.mr_n88614400)
print v(xbgr.mr_n88614512)
print v(xbgr.mr_n88615344)
print v(xbgr.mr_n88615520)
print v(xbgr.mr_n88615776)
print v(xbgr.mr_n88616432)
print v(xbgr.mr_n88617136)
print v(xbgr.mr_n88617312)
print v(xbgr.mr_n88617744)
print v(xbgr.mr_n88618304)
print v(xbgr.mr_n88618480)
print v(xbgr.mr_n88618976)
print v(xbgr.mr_n88619488)
print v(xbgr.mr_n88619600)
print v(xbgr.mr_n88620304)
print v(xbgr.mr_n88620720)
print v(xbgr.mr_n88621232)
print v(xbgr.mr_n88621728)
print v(xbgr.mr_n88621904)
print v(xbgr.mr_n88622320)
print v(xbgr.mr_n88622832)
print v(xbgr.mr_n88623328)
print v(xbgr.mr_n88623664)
print v(xbgr.mr_n88624176)
print v(xbgr.mr_n88624288)
print v(xbgr.mr_n88624400)
print v(xbgr.mr_n88625520)
print v(xbgr.mr_n88625696)
print v(xbgr.mr_n88625952)
print v(xbgr.mr_n88626528)
print v(xbgr.mr_n88627120)
print v(xbgr.mr_n88627232)
print v(xbgr.mr_n88627424)
print v(xbgr.mr_n88627776)
print v(xbgr.mr_n88627888)
print v(xbgr.mr_n88628400)
print v(xbgr.mr_n88628512)
print v(xbgr.mr_n88628624)
print v(xbgr.mr_n88628976)
print v(xbgr.mr_n88629312)
print v(xbgr.mr_n88630256)
print v(xbgr.mr_n88630672)
print v(xbgr.mr_n88630784)
print v(xbgr.mr_n88631344)
print v(xbgr.mr_n88631600)
print v(xbgr.mr_n88632416)
print v(xbgr.mr_n88632848)
print v(xbgr.mr_n88633024)
print v(xbgr.mr_n88633952)
print v(xbgr.mr_n88634128)
print v(xbgr.mr_n88634704)
print v(xbgr.mr_n88634816)
print v(xbgr.mr_n88634928)
print v(xbgr.mr_n88635696)
print v(xbgr.mr_n88636032)
print v(xbgr.mr_n88636976)
print v(xbgr.mr_n88637392)
print v(xbgr.mr_n88637504)
print v(xbgr.mr_n88638064)
print v(xbgr.mr_n88638320)
print v(xbgr.mr_n88639264)
print v(xbgr.mr_n88639680)
print v(xbgr.mr_n88639792)
print v(xbgr.mr_n88639904)
print v(xbgr.mr_n88640672)
print v(xbgr.mr_n88641008)
print v(xbgr.mr_n88642016)
print v(xbgr.mr_n88642192)
print v(xbgr.mr_n88642768)
print v(xbgr.mr_n88643200)
print v(xbgr.mr_n88643376)
print v(xbgr.mr_n88644112)
print v(xbgr.mr_n88644224)
print v(xbgr.mr_n88644784)
print v(xbgr.mr_n88645040)
print v(xbgr.mr_n88645984)
print v(xbgr.mr_n88646400)
print v(xbgr.mr_n88646512)
print v(xbgr.mr_n88646624)
print v(xbgr.mr_n88647392)
print v(xbgr.mr_n88647728)
print v(xbgr.mr_n88648544)
print v(xbgr.mr_n88648656)
print v(xbgr.mr_n88649216)
print v(xbgr.mr_n88649472)
print v(xbgr.mr_n88650416)
print v(xbgr.mr_n88650832)
print v(xbgr.mr_n88650944)
print v(xbgr.mr_n88651504)
print v(xbgr.mr_n88651760)
print v(xbgr.mr_n88652576)
print v(xbgr.mr_n88653008)
print v(xbgr.mr_n88653184)
print v(xbgr.mr_n88657952)
print v(xbgr.mr_n88658576)
print v(xbgr.mr_n88659040)
print v(xbgr.mr_n88659504)
print v(xbgr.mr_n88659968)
print v(xbgr.mr_n88660432)
print v(xbgr.mr_n88660896)
print v(xbgr.mr_n88661360)
print v(xbgr.mr_n88661824)
print v(xbgr.mr_n88662288)
print v(xbgr.mr_n88662752)
print v(xbgr.mr_n88663216)
print v(xbgr.mr_n88663680)
print v(xbgr.mr_n88664144)
print v(xbgr.mr_n88664608)
print v(xbgr.mr_n88665072)
print v(xbgr.mr_n88665536)
print v(xbgr.mr_n88666000)
print v(xbgr.mr_n88666464)
print v(xbgr.mr_n88666912)
print v(xbgr.mr_n88667376)
print v(xbgr.mr_n88667840)
print v(xbgr.mr_n88668304)
print v(xbgr.mr_n88668768)
print v(xbgr.mr_n88669232)
print v(xbgr.mr_n88669696)
print v(xbgr.mr_n88677632)
print v(xbgr.mr_n88678976)
print v(xbgr.mr_n88680944)
print v(xbgr.mr_n88681776)
print v(xbgr.mr_n88682112)
print v(xbgr.mr_n88684240)
print v(xbgr.mr_n88686896)
print v(xbgr.mr_n88689104)
print v(xbgr.mr_n88690128)
print v(xbgr.mr_n88698160)
print v(xbgr.mr_n88700160)
print v(xbgr.mr_n88701392)
print v(xbgr.mr_n88708400)
print v(xbgr.mr_n88710064)
print v(xbgr.mr_n88711184)
print v(xbgr.mr_n88712976)
print v(xbgr.mr_n88713152)
print v(xbgr.mr_n88713488)
print v(xbgr.mr_n88713824)
print v(xbgr.mr_n88715792)
print v(xbgr.mr_n88716496)
print v(xbgr.mr_n88716608)
print v(xbgr.mr_n88718368)
print v(xbgr.mr_n88718480)
print v(xbgr.mr_n88720176)
print v(xbgr.mr_n88720288)
print v(xbgr.mr_n88721984)
print v(xbgr.mr_n88722096)
print v(xbgr.mr_n88723792)
print v(xbgr.mr_n88723904)
print v(xbgr.mr_n88725600)
print v(xbgr.mr_n88725712)
print v(xbgr.mr_n88727408)
print v(xbgr.mr_n88727520)
print v(xbgr.mr_n88729216)
print v(xbgr.mr_n88729328)
print v(xbgr.mr_n88731024)
print v(xbgr.mr_n88731136)
print v(xbgr.mr_n88732832)
print v(xbgr.mr_n88732944)
print v(xbgr.mr_n88734640)
print v(xbgr.mr_n88734752)
print v(xbgr.mr_n88736448)
print v(xbgr.mr_n88736560)
print v(xbgr.mr_n88738256)
print v(xbgr.mr_n88738368)
print v(xbgr.mr_n88740064)
print v(xbgr.mr_n88740176)
print v(xbgr.mr_n88741872)
print v(xbgr.mr_n88741984)
print v(xbgr.mr_n88743680)
print v(xbgr.mr_n88743792)
print v(xbgr.mr_n88745488)
print v(xbgr.mr_n88745600)
print v(xbgr.mr_n88746432)
print v(xbgr.mr_n88746608)
print v(xbgr.mr_n88768496)
print v(xbgr.mr_n88770112)
print v(xbgr.mr_n88771600)
print v(xbgr.mr_n88772064)
print v(xbgr.mr_n88772176)
print v(xbgr.mr_n88772992)
print v(xbgr.mr_n88773456)
print v(xbgr.mr_n88773568)
print v(xbgr.mr_n88774384)
print v(xbgr.mr_n88774912)
print v(xbgr.mr_n88775088)
print v(xbgr.mr_n88776032)
print v(xbgr.mr_n88776688)
print v(xbgr.mr_n88776864)
print v(xbgr.mr_n88777808)
print v(xbgr.mr_n88778464)
print v(xbgr.mr_n88778640)
print v(xbgr.mr_n88779584)
print v(xbgr.mr_n88780240)
print v(xbgr.mr_n88780416)
print v(xbgr.mr_n88781360)
print v(xbgr.mr_n88782016)
print v(xbgr.mr_n88782192)
print v(xbgr.mr_n88783136)
print v(xbgr.mr_n88783792)
print v(xbgr.mr_n88783968)
print v(xbgr.mr_n88784912)
print v(xbgr.mr_n88785568)
print v(xbgr.mr_n88785744)
print v(xbgr.mr_n88786688)
print v(xbgr.mr_n88787280)
print v(xbgr.mr_n88787872)
print v(xbgr.mr_n88788464)
print v(xbgr.mr_n88789056)
print v(xbgr.mr_n88789648)
print v(xbgr.mr_n88790240)
print v(xbgr.mr_n88790832)
print v(xbgr.mr_n88791424)
print v(xbgr.mr_n88792016)
print v(xbgr.mr_n88792608)
print v(xbgr.mr_n88793072)
print v(xbgr.mr_n88793184)
print v(xbgr.mr_n88793296)
print v(xbgr.mr_n88793808)
print v(xbgr.mr_n88794080)
print v(xbgr.mr_n88794704)
print v(xbgr.mr_n88795680)
print v(xbgr.mr_n88796560)
print v(xbgr.mr_n88797152)
print v(xbgr.mr_n88797744)
print v(xbgr.mr_n88798336)
print v(xbgr.mr_n88798928)
print v(xbgr.mr_n88799520)
print v(xbgr.mr_n88800112)
print v(xbgr.mr_n88800704)
print v(xbgr.mr_n88801296)
print v(xbgr.mr_n88801888)
print v(xbgr.mr_n88802480)
print v(xbgr.mr_n88803072)
print v(xbgr.mr_n88803664)
print v(xbgr.mr_n88804256)
print v(xbgr.mr_n88804848)
print v(xbgr.mr_n88806464)
print v(xbgr.mr_n88807040)
print v(xbgr.mr_n88813312)
print v(xbgr.mr_n88821536)
print v(xbgr.mr_n88821872)
print v(xbgr.mr_n88822528)
print v(xbgr.mr_n88823040)
print v(xbgr.mr_n88823152)
print v(xbgr.mr_n88824848)
print v(xbgr.mr_n88824960)
print v(xbgr.mr_n88826656)
print v(xbgr.mr_n88826768)
print v(xbgr.mr_n88828464)
print v(xbgr.mr_n88828576)
print v(xbgr.mr_n88830272)
print v(xbgr.mr_n88830384)
print v(xbgr.mr_n88832080)
print v(xbgr.mr_n88832192)
print v(xbgr.mr_n88833888)
print v(xbgr.mr_n88834000)
print v(xbgr.mr_n88835696)
print v(xbgr.mr_n88835808)
print v(xbgr.mr_n88837504)
print v(xbgr.mr_n88837616)
print v(xbgr.mr_n88839312)
print v(xbgr.mr_n88839424)
print v(xbgr.mr_n88841120)
print v(xbgr.mr_n88841232)
print v(xbgr.mr_n88841344)
print v(xbgr.mr_n88843184)
print v(xbgr.mr_n88843296)
print v(xbgr.mr_n88843408)
print v(xbgr.mr_n88845248)
print v(xbgr.mr_n88845360)
print v(xbgr.mr_n88845472)
print v(xbgr.mr_n88847312)
print v(xbgr.mr_n88847424)
print v(xbgr.mr_n88847536)
print v(xbgr.mr_n88849376)
print v(xbgr.mr_n88849488)
print v(xbgr.mr_n88849600)
print v(xbgr.mr_n88851440)
print v(xbgr.mr_n88851552)
print v(xbgr.mr_n88851664)
print v(xbgr.mr_n88853504)
print v(xbgr.mr_n88853616)
print v(xbgr.mr_n88853728)
print v(xbgr.mr_n88854640)
print v(xbgr.mr_n88854912)
print v(xbgr.mr_n88855424)
print v(xbgr.mr_n88855968)
print v(xbgr.mr_n88856512)
print v(xbgr.mr_n88857056)
print v(xbgr.mr_n88857600)
print v(xbgr.mr_n88858144)
print v(xbgr.mr_n88858688)
print v(xbgr.mr_n88859232)
print v(xbgr.mr_n88859776)
print v(xbgr.mr_n88860320)
print v(xbgr.mr_n88860864)
print v(xbgr.mr_n88861408)
print v(xbgr.mr_n88861952)
print v(xbgr.mr_n88862496)
print v(xbgr.mr_n88863040)
print v(xbgr.mr_n88863584)
print v(xbgr.mr_n88864128)
print v(xbgr.mr_n88864672)
print v(xbgr.mr_n88865216)
print v(xbgr.mr_n88865760)
print v(xbgr.mr_n88866224)
print v(xbgr.mr_n88866768)
print v(xbgr.mr_n88867312)
print v(xbgr.mr_n88867856)
print v(xbgr.mr_n88868400)
print v(xbgr.mr_n88868944)
print v(xbgr.mr_n88869680)
print v(xbgr.mr_n88869984)
print v(xbgr.mr_n88870368)
print v(xbgr.mr_n88870832)
print v(xbgr.mr_n88871296)
print v(xbgr.mr_n88871760)
print v(xbgr.mr_n88872224)
print v(xbgr.mr_n88872688)
print v(xbgr.mr_n88873152)
print v(xbgr.mr_n88873616)
print v(xbgr.mr_n88874080)
print v(xbgr.mr_n88874544)
print v(xbgr.mr_n88875008)
print v(xbgr.mr_n88875472)
print v(xbgr.mr_n88875936)
print v(xbgr.mr_n88876400)
print v(xbgr.mr_n88876864)
print v(xbgr.mr_n88877328)
print v(xbgr.mr_n88877792)
print v(xbgr.mr_n88878256)
print v(xbgr.mr_n88878720)
print v(xbgr.mr_n88879184)
print v(xbgr.mr_n88879648)
print v(xbgr.mr_n88880144)
print v(xbgr.mr_n88880736)
print v(xbgr.mr_n88881328)
print v(xbgr.mr_n88881920)
print v(xbgr.mr_n88882512)
print v(xbgr.mr_n88883104)
print v(xbgr.mr_n88883696)
print v(xbgr.mr_n88885216)
print v(xbgr.mr_n88885328)
print v(xbgr.mr_n88886368)
print v(xbgr.mr_n88886944)
print v(xbgr.mr_n88906896)
print v(xbgr.mr_n88907872)
print v(xbgr.mr_n88908256)
print v(xbgr.mr_n88909984)
print v(xbgr.mr_n88916944)
print v(xbgr.mr_n88921632)
print v(xbgr.mr_n88921984)
print v(xbgr.mr_n88922160)
print v(xbgr.mr_n88923312)
print v(xbgr.mr_n88928096)
print v(xbgr.mr_n88937200)
print v(xbgr.mr_n88937872)
print v(xbgr.mr_n88940288)
print v(xbgr.mr_n88941152)
print v(xbgr.mr_n88946208)
print v(xbgr.mr_n88948816)
print v(xbgr.mr_n88949952)
print v(xbgr.mr_n88958304)
print v(xbgr.mr_n88959168)
print v(xbgr.mr_n88962032)
print v(xbgr.mr_n88963344)
print v(xbgr.mr_n88963520)
print v(xbgr.mr_n88964080)
print v(xbgr.mr_n88964992)
print v(xbgr.mr_n88966480)
print v(xbgr.mr_n88966656)
print v(xbgr.mr_n88966912)
print v(xbgr.mr_n88968384)
print v(xbgr.mr_n88970656)
print v(xbgr.mr_n88970960)
print v(xbgr.mr_n88971872)
print v(xbgr.mr_n88973696)
print v(xbgr.mr_n88973872)
print v(xbgr.mr_n88974560)
print v(xbgr.mr_n88977424)
print v(xbgr.mr_n88978048)
print v(xbgr.mr_n88978736)
print v(xbgr.mr_n88981552)
print v(xbgr.mr_n88981728)
print v(xbgr.mr_n88982560)
print v(xbgr.mr_n88983584)
print v(xbgr.mr_n88985792)
print v(xbgr.mr_n88987472)
print v(xbgr.mr_n88988800)
print v(xbgr.mr_n88992928)
print v(xbgr.mr_n88993264)
print v(xbgr.mr_n88993600)
print v(xbgr.mr_n88993936)
print v(xbgr.mr_n88994352)
print v(xbgr.mr_n88994592)
print v(xbgr.mr_n88994976)
print v(xbgr.mr_n88995488)
print v(xbgr.mr_n88995600)
print v(xbgr.mr_n88995712)
print v(xbgr.mr_n88997552)
print v(xbgr.mr_n88997664)
print v(xbgr.mr_n88997776)
print v(xbgr.mr_n88999616)
print v(xbgr.mr_n88999728)
print v(xbgr.mr_n88999840)
print v(xbgr.mr_n89001680)
print v(xbgr.mr_n89001792)
print v(xbgr.mr_n89001904)
print v(xbgr.mr_n89003744)
print v(xbgr.mr_n89003856)
print v(xbgr.mr_n89003968)
print v(xbgr.mr_n89005808)
print v(xbgr.mr_n89005920)
print v(xbgr.mr_n89006032)
print v(xbgr.mr_n89007872)
print v(xbgr.mr_n89007984)
print v(xbgr.mr_n89008096)
print v(xbgr.mr_n89009936)
print v(xbgr.mr_n89010048)
print v(xbgr.mr_n89010160)
print v(xbgr.mr_n89012000)
print v(xbgr.mr_n89012112)
print v(xbgr.mr_n89012224)
print v(xbgr.mr_n89014064)
print v(xbgr.mr_n89014176)
print v(xbgr.mr_n89014288)
print v(xbgr.mr_n89016128)
print v(xbgr.mr_n89016240)
print v(xbgr.mr_n89016352)
print v(xbgr.mr_n89018192)
print v(xbgr.mr_n89018304)
print v(xbgr.mr_n89018416)
print v(xbgr.mr_n89020256)
print v(xbgr.mr_n89020368)
print v(xbgr.mr_n89020480)
print v(xbgr.mr_n89023024)
print v(xbgr.mr_n89023136)
print v(xbgr.mr_n89023504)
print v(xbgr.mr_n89027008)
print v(xbgr.mr_n89027120)
print v(xbgr.mr_n89027488)
print v(xbgr.mr_n89027664)
print v(xbgr.mr_n89030992)
print v(xbgr.mr_n89031104)
print v(xbgr.mr_n89031472)
print v(xbgr.mr_n89034976)
print v(xbgr.mr_n89035088)
print v(xbgr.mr_n89035456)
print v(xbgr.mr_n89038048)
print v(xbgr.mr_n89038160)
print v(xbgr.mr_n89039664)
print v(xbgr.mr_n89040384)
print v(xbgr.mr_n89040560)
print v(xbgr.mr_n89041248)
print v(xbgr.mr_n89042128)
print v(xbgr.mr_n89042944)
print v(xbgr.mr_n89043120)
print v(xbgr.mr_n89044688)
print v(xbgr.mr_n89045504)
print v(xbgr.mr_n89045680)
print v(xbgr.mr_n89046256)
print v(xbgr.mr_n89047248)
print v(xbgr.mr_n89048064)
print v(xbgr.mr_n89048240)
print v(xbgr.mr_n89049808)
print v(xbgr.mr_n89050624)
print v(xbgr.mr_n89050800)
print v(xbgr.mr_n89052368)
print v(xbgr.mr_n89053184)
print v(xbgr.mr_n89053360)
print v(xbgr.mr_n89054928)
print v(xbgr.mr_n89055744)
print v(xbgr.mr_n89055920)
print v(xbgr.mr_n89057488)
print v(xbgr.mr_n89058304)
print v(xbgr.mr_n89058480)
print v(xbgr.mr_n89060048)
print v(xbgr.mr_n89060864)
print v(xbgr.mr_n89061040)
print v(xbgr.mr_n89062608)
print v(xbgr.mr_n89063392)
print v(xbgr.mr_n89063504)
print v(xbgr.mr_n89063616)
print v(xbgr.mr_n89064720)
print v(xbgr.mr_n89064992)
print v(xbgr.mr_n89066512)
print v(xbgr.mr_n89066832)
print v(xbgr.mr_n89067008)
print v(xbgr.mr_n89067120)
print v(xbgr.mr_n89068624)
print v(xbgr.mr_n89069120)
print v(xbgr.mr_n89069232)
print v(xbgr.mr_n89071856)
print v(xbgr.mr_n89073024)
print v(xbgr.mr_n89073200)
print v(xbgr.mr_n89074768)
print v(xbgr.mr_n89075584)
print v(xbgr.mr_n89075760)
print v(xbgr.mr_n89077328)
print v(xbgr.mr_n89078144)
print v(xbgr.mr_n89078320)
print v(xbgr.mr_n89079888)
print v(xbgr.mr_n89080704)
print v(xbgr.mr_n89080880)
print v(xbgr.mr_n89082448)
print v(xbgr.mr_n89083264)
print v(xbgr.mr_n89083440)
print v(xbgr.mr_n89083872)
print v(xbgr.mr_n89085008)
print v(xbgr.mr_n89085824)
print v(xbgr.mr_n89086000)
print v(xbgr.mr_n89087568)
print v(xbgr.mr_n89088384)
print v(xbgr.mr_n89088560)
print v(xbgr.mr_n89090128)
print v(xbgr.mr_n89090944)
print v(xbgr.mr_n89091120)
print v(xbgr.mr_n89092688)
print v(xbgr.mr_n89093504)
print v(xbgr.mr_n89093680)
print v(xbgr.mr_n89095248)
print v(xbgr.mr_n89096064)
print v(xbgr.mr_n89096240)
print v(xbgr.mr_n89096624)
print v(xbgr.mr_n89097808)
print v(xbgr.mr_n89098624)
print v(xbgr.mr_n89098800)
print v(xbgr.mr_n89100368)
print v(xbgr.mr_n89100944)
print v(xbgr.mr_n89101184)
print v(xbgr.mr_n89101360)
print v(xbgr.mr_n89102928)
print v(xbgr.mr_n89103744)
print v(xbgr.mr_n89103920)
print v(xbgr.mr_n89105488)
print v(xbgr.mr_n89146448)
print v(xbgr.mr_n89176704)
print v(xbgr.mr_n89177536)
print v(xbgr.mr_n89178256)
print v(xbgr.mr_n89184832)
print v(xbgr.mr_n89191568)
print v(xbgr.mr_n89199120)
print v(xbgr.mr_n89203216)
print v(xbgr.mr_n89214224)
print v(xbgr.mr_n89215216)
print v(xbgr.mr_n89216304)
print v(xbgr.mr_n89217104)
print v(xbgr.mr_n89217328)
print v(xbgr.mr_n89217440)
print v(xbgr.mr_n89217552)
print v(xbgr.mr_n89218880)
print v(xbgr.mr_n89220816)
print v(xbgr.mr_n89221456)
print v(xbgr.mr_n89223952)
print v(xbgr.mr_n89254544)
print v(xbgr.mr_n89255728)
print v(xbgr.mr_n89256912)
print v(xbgr.mr_n89257504)
print v(xbgr.mr_n89321728)
print v(xbgr.mr_n89322992)
print v(xbgr.mr_n89323104)
print v(xbgr.mr_n89323936)
print v(xbgr.mr_n89324048)
print v(xbgr.mr_n89324880)
print v(xbgr.mr_n89324992)
print v(xbgr.mr_n89325824)
print v(xbgr.mr_n89325936)
print v(xbgr.mr_n89326768)
print v(xbgr.mr_n89326880)
print v(xbgr.mr_n89327712)
print v(xbgr.mr_n89327824)
print v(xbgr.mr_n89328656)
print v(xbgr.mr_n89328768)
print v(xbgr.mr_n89329600)
print v(xbgr.mr_n89329712)
print v(xbgr.mr_n89330544)
print v(xbgr.mr_n89330656)
print v(xbgr.mr_n89331488)
print v(xbgr.mr_n89331600)
print v(xbgr.mr_n89332432)
print v(xbgr.mr_n89332544)
print v(xbgr.mr_n89333376)
print v(xbgr.mr_n89333488)
print v(xbgr.mr_n89334816)
print v(xbgr.mr_n89334928)
print v(xbgr.mr_n89336448)
print v(xbgr.mr_n89337664)
print v(xbgr.mr_n89338768)
print v(xbgr.mr_n89342016)
print v(xbgr.mr_n89346272)
print v(xbgr.mr_n89346464)
print v(xbgr.mr_n89349008)
print v(xbgr.mr_n89350624)
print v(xbgr.mr_n89352304)
print v(xbgr.mr_n89354560)
print v(xbgr.mr_n89356816)
print v(xbgr.mr_n89359072)
print v(xbgr.mr_n89361328)
print v(xbgr.mr_n89363584)
print v(xbgr.mr_n89365840)
print v(xbgr.mr_n89368096)
print v(xbgr.mr_n89383056)
print v(xbgr.mr_n89388864)
print v(xbgr.mr_n89392944)
print v(xbgr.mr_n89394160)
print v(xbgr.mr_n89394272)
print v(xbgr.mr_n89394896)
print v(xbgr.mr_n89396432)
print v(xbgr.mr_n89397296)
print v(xbgr.mr_n89398256)
print v(xbgr.mr_n89398368)
print v(xbgr.mr_n89399312)
print v(xbgr.mr_n89400464)
print v(xbgr.mr_n89400576)
print v(xbgr.mr_n89401200)
print v(xbgr.mr_n89402736)
print v(xbgr.mr_n89403600)
print v(xbgr.mr_n89404560)
print v(xbgr.mr_n89404672)
print v(xbgr.mr_n89405616)
print v(xbgr.mr_n89406768)
print v(xbgr.mr_n89406880)
print v(xbgr.mr_n89407504)
print v(xbgr.mr_n89409040)
print v(xbgr.mr_n89409904)
print v(xbgr.mr_n89410864)
print v(xbgr.mr_n89410976)
print v(xbgr.mr_n89411920)
print v(xbgr.mr_n89413008)
print v(xbgr.mr_n89413120)
print v(xbgr.mr_n89413744)
print v(xbgr.mr_n89415344)
print v(xbgr.mr_n89416208)
print v(xbgr.mr_n89417168)
print v(xbgr.mr_n89417280)
print v(xbgr.mr_n89418224)
print v(xbgr.mr_n89419376)
print v(xbgr.mr_n89419488)
print v(xbgr.mr_n89420112)
print v(xbgr.mr_n89421648)
print v(xbgr.mr_n89422512)
print v(xbgr.mr_n89423472)
print v(xbgr.mr_n89423584)
print v(xbgr.mr_n89424528)
print v(xbgr.mr_n89425680)
print v(xbgr.mr_n89425792)
print v(xbgr.mr_n89426416)
print v(xbgr.mr_n89428592)
print v(xbgr.mr_n89428928)
print v(xbgr.mr_n89430848)
print v(xbgr.mr_n89431408)
print v(xbgr.mr_n89432096)
print v(xbgr.mr_n89432848)
print v(xbgr.mr_n89433792)
print v(xbgr.mr_n89434736)
print v(xbgr.mr_n89435680)
print v(xbgr.mr_n89436624)
print v(xbgr.mr_n89437568)
print v(xbgr.mr_n89438512)
print v(xbgr.mr_n89439456)
print v(xbgr.mr_n89440400)
print v(xbgr.mr_n89441344)
print v(xbgr.mr_n89442288)
print v(xbgr.mr_n89443232)
print v(xbgr.mr_n89444176)
print v(xbgr.mr_n89445120)
print v(xbgr.mr_n89446064)
print v(xbgr.mr_n89447008)
print v(xbgr.mr_n89447952)
print v(xbgr.mr_n89448896)
print v(xbgr.mr_n89449840)
print v(xbgr.mr_n89450784)
print v(xbgr.mr_n89451728)
print v(xbgr.mr_n89452672)
print v(xbgr.mr_n89453616)
print v(xbgr.mr_n89454560)
print v(xbgr.mr_n89455504)
print v(xbgr.mr_n89456448)
print v(xbgr.mr_n89457392)
print v(xbgr.mr_n89458336)
print v(xbgr.mr_n89459280)
print v(xbgr.mr_n89460224)
print v(xbgr.mr_n89461168)
print v(xbgr.mr_n89462112)
print v(xbgr.mr_n89463056)
print v(xbgr.mr_n89465488)
print v(xbgr.mr_n89467072)
print v(xbgr.mr_n89468320)
print v(xbgr.mr_n89469024)
print v(xbgr.mr_n89469872)
print v(xbgr.mr_n89471248)
print v(xbgr.mr_n89471360)
print v(xbgr.mr_n89474400)
print v(xbgr.mr_n89474512)
print v(xbgr.mr_n89475664)
print v(xbgr.mr_n89475776)
print v(xbgr.mr_n89476928)
print v(xbgr.mr_n89477040)
print v(xbgr.mr_n89478192)
print v(xbgr.mr_n89478304)
print v(xbgr.mr_n89479456)
print v(xbgr.mr_n89479568)
print v(xbgr.mr_n89480720)
print v(xbgr.mr_n89480832)
print v(xbgr.mr_n89481984)
print v(xbgr.mr_n89482096)
print v(xbgr.mr_n89483248)
print v(xbgr.mr_n89483360)
print v(xbgr.mr_n89486752)
print v(xbgr.mr_n89490992)
print v(xbgr.mr_n89491344)
print v(xbgr.mr_n89492432)
print v(xbgr.mr_n89500624)
print v(xbgr.mr_n89500880)
print v(xbgr.mr_n89501136)
print v(xbgr.mr_n89501392)
print v(xbgr.mr_n89503984)
print v(xbgr.mr_n89504096)
print v(xbgr.mr_n89505168)
print v(xbgr.mr_n89505456)
print v(xbgr.mr_n89507856)
print v(xbgr.mr_n89508048)
print v(xbgr.mr_n89509456)
print v(xbgr.mr_n89509936)
print v(xbgr.mr_n89512336)
print v(xbgr.mr_n89513584)
print v(xbgr.mr_n89513696)
print v(xbgr.mr_n89515696)
print v(xbgr.mr_n89517440)
print v(xbgr.mr_n89517712)
print v(xbgr.mr_n89517904)
print v(xbgr.mr_n89519328)
print v(xbgr.mr_n89521200)
print v(xbgr.mr_n89521392)
print v(xbgr.mr_n89525472)
print v(xbgr.mr_n89525744)
print v(xbgr.mr_n89525936)
print v(xbgr.mr_n89527360)
print v(xbgr.mr_n89527824)
print v(xbgr.mr_n89529168)
print v(xbgr.mr_n89529360)
print v(xbgr.mr_n89532112)
print v(xbgr.mr_n89533840)
print v(xbgr.mr_n89534032)
print v(xbgr.mr_n89537200)
print v(xbgr.mr_n89537392)
print v(xbgr.mr_n89540352)
print v(xbgr.mr_n89541536)
print v(xbgr.mr_n89541808)
print v(xbgr.mr_n89542000)
print v(xbgr.mr_n89544912)
print v(xbgr.mr_n89545728)
print v(xbgr.mr_n89546976)
print v(xbgr.mr_n89547088)
print v(xbgr.mr_n89550128)
print v(xbgr.mr_n89550320)
print v(xbgr.mr_n89550512)
print v(xbgr.mr_n89551760)
print v(xbgr.mr_n89551872)
print v(xbgr.mr_n89553488)
print v(xbgr.mr_n89555456)
print v(xbgr.mr_n89556288)
print v(xbgr.mr_n89557536)
print v(xbgr.mr_n89557648)
print v(xbgr.mr_n89561776)
print v(xbgr.mr_n89564528)
print v(xbgr.mr_n89565616)
print v(xbgr.mr_n89569584)
print v(xbgr.mr_n89570352)
print v(xbgr.mr_n89570464)
print v(xbgr.mr_n89571360)
print v(xbgr.mr_n89571472)
print v(xbgr.mr_n89572304)
print v(xbgr.mr_n89572416)
print v(xbgr.mr_n89573504)
print v(xbgr.mr_n89573616)
print v(xbgr.mr_n89574768)
print v(xbgr.mr_n89574880)
print v(xbgr.mr_n89575968)
print v(xbgr.mr_n89576080)
print v(xbgr.mr_n89577296)
print v(xbgr.mr_n89577408)
print v(xbgr.mr_n89578560)
print v(xbgr.mr_n89578672)
print v(xbgr.mr_n89579824)
print v(xbgr.mr_n89579936)
print v(xbgr.mr_n89581088)
print v(xbgr.mr_n89581200)
print v(xbgr.mr_n89582352)
print v(xbgr.mr_n89582464)
print v(xbgr.mr_n89583616)
print v(xbgr.mr_n89583728)
print v(xbgr.mr_n89584816)
print v(xbgr.mr_n89584928)
print v(xbgr.mr_n89586144)
print v(xbgr.mr_n89586256)
print v(xbgr.mr_n89587408)
print v(xbgr.mr_n89587520)
print v(xbgr.mr_n89591168)
print v(xbgr.mr_n89594928)
print v(xbgr.mr_n89595616)
print v(xbgr.mr_n89596304)
print v(xbgr.mr_n89597024)
print v(xbgr.mr_n89598640)
print v(xbgr.mr_n89599920)
print v(xbgr.mr_n89600032)
print v(xbgr.mr_n89600976)
print v(xbgr.mr_n89602128)
print v(xbgr.mr_n89602240)
print v(xbgr.mr_n89602864)
print v(xbgr.mr_n89604048)
print v(xbgr.mr_n89604640)
print v(xbgr.mr_n89605648)
print v(xbgr.mr_n89606848)
print v(xbgr.mr_n89608800)
print v(xbgr.mr_n89609344)
print v(xbgr.mr_n89610752)
print v(xbgr.mr_n89611296)
print v(xbgr.mr_n89612640)
print v(xbgr.mr_n89613184)
print v(xbgr.mr_n89614528)
print v(xbgr.mr_n89615072)
print v(xbgr.mr_n89616416)
print v(xbgr.mr_n89616960)
print v(xbgr.mr_n89618240)
print v(xbgr.mr_n89618784)
print v(xbgr.mr_n89619504)
print v(xbgr.mr_n89620192)
print v(xbgr.mr_n89620736)
print v(xbgr.mr_n89622080)
print v(xbgr.mr_n89622624)
print v(xbgr.mr_n89623968)
print v(xbgr.mr_n89624832)
print v(xbgr.mr_n89625792)
print v(xbgr.mr_n89625904)
print v(xbgr.mr_n89626848)
print v(xbgr.mr_n89628000)
print v(xbgr.mr_n89628112)
print v(xbgr.mr_n89629056)
print v(xbgr.mr_n89630208)
print v(xbgr.mr_n89630320)
print v(xbgr.mr_n89637920)
print v(xbgr.mr_n89641632)
print v(xbgr.mr_n89643760)
print v(xbgr.mr_n89644000)
print v(xbgr.mr_n89644912)
print v(xbgr.mr_n89645856)
print v(xbgr.mr_n89646544)
print v(xbgr.mr_n89647232)
print v(xbgr.mr_n89647952)
print v(xbgr.mr_n89648896)
print v(xbgr.mr_n89649088)
print v(xbgr.mr_n89649280)
print v(xbgr.mr_n89649472)
print v(xbgr.mr_n89649664)
print v(xbgr.mr_n89649856)
print v(xbgr.mr_n89652000)
print v(xbgr.mr_n89652112)
print v(xbgr.mr_n89654128)
print v(xbgr.mr_n89656144)
print v(xbgr.mr_n89656256)
print v(xbgr.mr_n89661904)
print v(xbgr.mr_n89662848)
print v(xbgr.mr_n89667712)
print v(xbgr.mr_n89677872)
print v(xbgr.mr_n89678816)
print v(xbgr.mr_n89679760)
print v(xbgr.mr_n89680704)
print v(xbgr.mr_n89681648)
print v(xbgr.mr_n89682592)
print v(xbgr.mr_n89683536)
print v(xbgr.mr_n89684480)
print v(xbgr.mr_n89686544)
print v(xbgr.mr_n89690032)
print v(xbgr.mr_n89690224)
print v(xbgr.mr_n89691056)
print v(xbgr.mr_n89691568)
print v(xbgr.mr_n89693184)
print v(xbgr.mr_n89693376)
print v(xbgr.mr_n89694208)
print v(xbgr.mr_n89694720)
print v(xbgr.mr_n89695824)
print v(xbgr.mr_n89696480)
print v(xbgr.mr_n89696672)
print v(xbgr.mr_n89697360)
print v(xbgr.mr_n89697872)
print v(xbgr.mr_n89699488)
print v(xbgr.mr_n89699680)
print v(xbgr.mr_n89700512)
print v(xbgr.mr_n89701024)
print v(xbgr.mr_n89702464)
print v(xbgr.mr_n89702576)
print v(xbgr.mr_n89703104)
print v(xbgr.mr_n89703664)
print v(xbgr.mr_n89704176)
print v(xbgr.mr_n89705792)
print v(xbgr.mr_n89705984)
print v(xbgr.mr_n89706816)
print v(xbgr.mr_n89707328)
print v(xbgr.mr_n89709088)
print v(xbgr.mr_n89709280)
print v(xbgr.mr_n89709968)
print v(xbgr.mr_n89710480)
print v(xbgr.mr_n89712096)
print v(xbgr.mr_n89712288)
print v(xbgr.mr_n89713120)
print v(xbgr.mr_n89713824)
print v(xbgr.mr_n89714384)
print v(xbgr.mr_n89715088)
print v(xbgr.mr_n89715648)
print v(xbgr.mr_n89716224)
print v(xbgr.mr_n89716912)
print v(xbgr.mr_n89717616)
print v(xbgr.mr_n89718176)
print v(xbgr.mr_n89718752)
print v(xbgr.mr_n89719440)
print v(xbgr.mr_n89720016)
print v(xbgr.mr_n89720704)
print v(xbgr.mr_n89721136)
print v(xbgr.mr_n89721968)
print v(xbgr.mr_n89722976)
print v(xbgr.mr_n89724400)
print v(xbgr.mr_n89725088)
print v(xbgr.mr_n89725776)
print v(xbgr.mr_n89727728)
print v(xbgr.mr_n89728096)
print v(xbgr.mr_n89728288)
print v(xbgr.mr_n89728480)
print v(xbgr.mr_n89729312)
print v(xbgr.mr_n89729504)
print v(xbgr.mr_n89730080)
print v(xbgr.mr_n89730192)
print v(xbgr.mr_n89731952)
print v(xbgr.mr_n89732784)
print v(xbgr.mr_n89733056)
print v(xbgr.mr_n89733168)
print v(xbgr.mr_n89733808)
print v(xbgr.mr_n89733920)
print v(xbgr.mr_n89734032)
print v(xbgr.mr_n89734224)
print v(xbgr.mr_n89734416)
print v(xbgr.mr_n89734608)
print v(xbgr.mr_n89736864)
print v(xbgr.mr_n89737136)
print v(xbgr.mr_n89737328)
print v(xbgr.mr_n89737840)
print v(xbgr.mr_n89738464)
print v(xbgr.mr_n89740256)
print v(xbgr.mr_n89740528)
print v(xbgr.mr_n89740720)
print v(xbgr.mr_n89741232)
print v(xbgr.mr_n89741936)
print v(xbgr.mr_n89744480)
print v(xbgr.mr_n89744752)
print v(xbgr.mr_n89744944)
print v(xbgr.mr_n89745712)
print v(xbgr.mr_n89749856)
print v(xbgr.mr_n89750128)
print v(xbgr.mr_n89750320)
print v(xbgr.mr_n89750832)
print v(xbgr.mr_n89752528)
print v(xbgr.mr_n89752720)
print v(xbgr.mr_n89752912)
print v(xbgr.mr_n89755168)
print v(xbgr.mr_n89755360)
print v(xbgr.mr_n89755872)
print v(xbgr.mr_n89757808)
print v(xbgr.mr_n89758320)
print v(xbgr.mr_n89760992)
print v(xbgr.mr_n89761264)
print v(xbgr.mr_n89761456)
print v(xbgr.mr_n89761968)
print v(xbgr.mr_n89763584)
print v(xbgr.mr_n89763776)
print v(xbgr.mr_n89765968)
print v(xbgr.mr_n89766240)
print v(xbgr.mr_n89766432)
print v(xbgr.mr_n89766944)
print v(xbgr.mr_n89768880)
print v(xbgr.mr_n89769392)
print v(xbgr.mr_n89770528)
print v(xbgr.mr_n89772464)
print v(xbgr.mr_n89772656)
print v(xbgr.mr_n89773168)
print v(xbgr.mr_n89774784)
print v(xbgr.mr_n89774976)
print v(xbgr.mr_n89777104)
print v(xbgr.mr_n89777376)
print v(xbgr.mr_n89777568)
print v(xbgr.mr_n89778080)
print v(xbgr.mr_n89778896)
print v(xbgr.mr_n89780016)
print v(xbgr.mr_n89780528)
print v(xbgr.mr_n89781744)
print v(xbgr.mr_n89783264)
print v(xbgr.mr_n89783536)
print v(xbgr.mr_n89783728)
print v(xbgr.mr_n89784240)
print v(xbgr.mr_n89787952)
print v(xbgr.mr_n89789104)
print v(xbgr.mr_n89789216)
print v(xbgr.mr_n89790368)
print v(xbgr.mr_n89790480)
print v(xbgr.mr_n89791632)
print v(xbgr.mr_n89791744)
print v(xbgr.mr_n89792896)
print v(xbgr.mr_n89793008)
print v(xbgr.mr_n89794160)
print v(xbgr.mr_n89794272)
print v(xbgr.mr_n89795424)
print v(xbgr.mr_n89795536)
print v(xbgr.mr_n89796688)
print v(xbgr.mr_n89796800)
print v(xbgr.mr_n89797888)
print v(xbgr.mr_n89798000)
print v(xbgr.mr_n89799216)
print v(xbgr.mr_n89799328)
print v(xbgr.mr_n89800480)
print v(xbgr.mr_n89800592)
print v(xbgr.mr_n89801744)
print v(xbgr.mr_n89801856)
print v(xbgr.mr_n89803008)
print v(xbgr.mr_n89803120)
print v(xbgr.mr_n89804272)
print v(xbgr.mr_n89804384)
print v(xbgr.mr_n89805536)
print v(xbgr.mr_n89805648)
print v(xbgr.mr_n89806800)
print v(xbgr.mr_n89806912)
print v(xbgr.mr_n89813232)
print v(xbgr.mr_n89814672)
print v(xbgr.mr_n89815008)
print v(xbgr.mr_n89831328)
print v(xbgr.mr_n89836304)
print v(xbgr.mr_n89839328)
print v(xbgr.mr_n89840592)
print v(xbgr.mr_n89841280)
print v(xbgr.mr_n89842032)
print v(xbgr.mr_n89842976)
print v(xbgr.mr_n89844880)
print v(xbgr.mr_n89847696)
print v(xbgr.mr_n89847888)
print v(xbgr.mr_n89849712)
print v(xbgr.mr_n89849904)
print v(xbgr.mr_n89850736)
print v(xbgr.mr_n89850848)
print v(xbgr.mr_n89850960)
print v(xbgr.mr_n89851072)
print v(xbgr.mr_n89851184)
print v(xbgr.mr_n89852928)
print v(xbgr.mr_n89853200)
print v(xbgr.mr_n89853392)
print v(xbgr.mr_n89853904)
print v(xbgr.mr_n89855504)
print v(xbgr.mr_n89855840)
print v(xbgr.mr_n89856032)
print v(xbgr.mr_n89857584)
print v(xbgr.mr_n89857856)
print v(xbgr.mr_n89858048)
print v(xbgr.mr_n89858560)
print v(xbgr.mr_n89860496)
print v(xbgr.mr_n89862240)
print v(xbgr.mr_n89862512)
print v(xbgr.mr_n89862704)
print v(xbgr.mr_n89863216)
print v(xbgr.mr_n89864448)
print v(xbgr.mr_n89864960)
print v(xbgr.mr_n89866880)
print v(xbgr.mr_n89868400)
print v(xbgr.mr_n89868672)
print v(xbgr.mr_n89868864)
print v(xbgr.mr_n89869376)
print v(xbgr.mr_n89869616)
print v(xbgr.mr_n89870160)
print v(xbgr.mr_n89873376)
print v(xbgr.mr_n89873648)
print v(xbgr.mr_n89873840)
print v(xbgr.mr_n89875008)
print v(xbgr.mr_n89875120)
print v(xbgr.mr_n89876864)
print v(xbgr.mr_n89877136)
print v(xbgr.mr_n89877328)
print v(xbgr.mr_n89877840)
print v(xbgr.mr_n89881232)
print v(xbgr.mr_n89881344)
print v(xbgr.mr_n89883088)
print v(xbgr.mr_n89883360)
print v(xbgr.mr_n89883552)
print v(xbgr.mr_n89884064)
print v(xbgr.mr_n89885296)
print v(xbgr.mr_n89885808)
print v(xbgr.mr_n89889248)
print v(xbgr.mr_n89889520)
print v(xbgr.mr_n89889712)
print v(xbgr.mr_n89890224)
print v(xbgr.mr_n89892368)
print v(xbgr.mr_n89892480)
print v(xbgr.mr_n89894224)
print v(xbgr.mr_n89894496)
print v(xbgr.mr_n89894688)
print v(xbgr.mr_n89895200)
print v(xbgr.mr_n89895584)
print v(xbgr.mr_n89896432)
print v(xbgr.mr_n89896944)
print v(xbgr.mr_n89900384)
print v(xbgr.mr_n89900656)
print v(xbgr.mr_n89900848)
print v(xbgr.mr_n89901360)
print v(xbgr.mr_n89903504)
print v(xbgr.mr_n89903616)
print v(xbgr.mr_n89903888)
print v(xbgr.mr_n89905360)
print v(xbgr.mr_n89905632)
print v(xbgr.mr_n89905824)
print v(xbgr.mr_n89906336)
print v(xbgr.mr_n89907568)
print v(xbgr.mr_n89908080)
print v(xbgr.mr_n89911520)
print v(xbgr.mr_n89911792)
print v(xbgr.mr_n89911984)
print v(xbgr.mr_n89912496)
print v(xbgr.mr_n89914560)
print v(xbgr.mr_n89914672)
print v(xbgr.mr_n89915184)
print v(xbgr.mr_n89915296)
print v(xbgr.mr_n89915808)
print v(xbgr.mr_n89915920)
print v(xbgr.mr_n89916688)
print v(xbgr.mr_n89916800)
print v(xbgr.mr_n89917632)
print v(xbgr.mr_n89917744)
print v(xbgr.mr_n89918576)
print v(xbgr.mr_n89918688)
print v(xbgr.mr_n89919520)
print v(xbgr.mr_n89919632)
print v(xbgr.mr_n89920464)
print v(xbgr.mr_n89920576)
print v(xbgr.mr_n89921472)
print v(xbgr.mr_n89921584)
print v(xbgr.mr_n89922736)
print v(xbgr.mr_n89922848)
print v(xbgr.mr_n89924000)
print v(xbgr.mr_n89924112)
print v(xbgr.mr_n89925264)
print v(xbgr.mr_n89925376)
print v(xbgr.mr_n89926528)
print v(xbgr.mr_n89926640)
print v(xbgr.mr_n89927792)
print v(xbgr.mr_n89927904)
print v(xbgr.mr_n89929056)
print v(xbgr.mr_n89929168)
print v(xbgr.mr_n89932752)
print v(xbgr.mr_n89935104)
print v(xbgr.mr_n89937024)
print v(xbgr.mr_n89940976)
print v(xbgr.mr_n89941088)
print v(xbgr.mr_n89942304)
print v(xbgr.mr_n89942416)
print v(xbgr.mr_n89943568)
print v(xbgr.mr_n89943680)
print v(xbgr.mr_n89944832)
print v(xbgr.mr_n89944944)
print v(xbgr.mr_n89946096)
print v(xbgr.mr_n89946208)
print v(xbgr.mr_n89947360)
print v(xbgr.mr_n89947472)
print v(xbgr.mr_n89948624)
print v(xbgr.mr_n89948736)
print v(xbgr.mr_n89949888)
print v(xbgr.mr_n89950000)
print v(xbgr.mr_n89951152)
print v(xbgr.mr_n89951264)
print v(xbgr.mr_n89952416)
print v(xbgr.mr_n89952528)
print v(xbgr.mr_n89953680)
print v(xbgr.mr_n89953792)
print v(xbgr.mr_n89954944)
print v(xbgr.mr_n89955056)
print v(xbgr.mr_n89956144)
print v(xbgr.mr_n89956256)
print v(xbgr.mr_n89957472)
print v(xbgr.mr_n89957584)
print v(xbgr.mr_n89958736)
print v(xbgr.mr_n89958848)
print v(xbgr.mr_n89960000)
print v(xbgr.mr_n89960112)
print v(xbgr.mr_n89961264)
print v(xbgr.mr_n89961376)
print v(xbgr.mr_n89964320)
print v(xbgr.mr_n89972240)
print v(xbgr.mr_n89975328)
print v(xbgr.mr_n89978464)
print v(xbgr.mr_n89981872)
print v(xbgr.mr_n89984192)
print v(xbgr.mr_n89984432)
print v(xbgr.mr_n89985248)
print v(xbgr.mr_n89986304)
print v(xbgr.mr_n89986720)
print v(xbgr.mr_n89987072)
print v(xbgr.mr_n89987248)
print v(xbgr.mr_n89987360)
print v(xbgr.mr_n89988240)
print v(xbgr.mr_n89988832)
print v(xbgr.mr_n89991472)
print v(xbgr.mr_n89991824)
print v(xbgr.mr_n89992000)
print v(xbgr.mr_n89992176)
print v(xbgr.mr_n89993056)
print v(xbgr.mr_n89993232)
print v(xbgr.mr_n89994112)
print v(xbgr.mr_n89996752)
print v(xbgr.mr_n90000208)
print v(xbgr.mr_n90000384)
print v(xbgr.mr_n90000560)
print v(xbgr.mr_n90002560)
print v(xbgr.mr_n90003440)
print v(xbgr.mr_n90005168)
print v(xbgr.mr_n90005472)
print v(xbgr.mr_n90008256)
print v(xbgr.mr_n90008944)
print v(xbgr.mr_n90009568)
print v(xbgr.mr_n90009680)
print v(xbgr.mr_n90013136)
print v(xbgr.mr_n90013808)
print v(xbgr.mr_n90015392)
print v(xbgr.mr_n90015584)
print v(xbgr.mr_n90016416)
print v(xbgr.mr_n90016528)
print v(xbgr.mr_n90016640)
print v(xbgr.mr_n90016752)
print v(xbgr.mr_n90016864)
print v(xbgr.mr_n90018608)
print v(xbgr.mr_n90018800)
print v(xbgr.mr_n90018992)
print v(xbgr.mr_n90019584)
print v(xbgr.mr_n90021712)
print v(xbgr.mr_n90023456)
print v(xbgr.mr_n90023728)
print v(xbgr.mr_n90023920)
print v(xbgr.mr_n90024432)
print v(xbgr.mr_n90026368)
print v(xbgr.mr_n90028112)
print v(xbgr.mr_n90028384)
print v(xbgr.mr_n90028576)
print v(xbgr.mr_n90029088)
print v(xbgr.mr_n90031024)
print v(xbgr.mr_n90032768)
print v(xbgr.mr_n90033040)
print v(xbgr.mr_n90033232)
print v(xbgr.mr_n90033744)
print v(xbgr.mr_n90035680)
print v(xbgr.mr_n90037424)
print v(xbgr.mr_n90037696)
print v(xbgr.mr_n90037888)
print v(xbgr.mr_n90038400)
print v(xbgr.mr_n90040336)
print v(xbgr.mr_n90042080)
print v(xbgr.mr_n90042352)
print v(xbgr.mr_n90042544)
print v(xbgr.mr_n90043056)
print v(xbgr.mr_n90045072)
print v(xbgr.mr_n90045264)
print v(xbgr.mr_n90047072)
print v(xbgr.mr_n90047264)
print v(xbgr.mr_n90047776)
print v(xbgr.mr_n90049648)
print v(xbgr.mr_n90051392)
print v(xbgr.mr_n90051664)
print v(xbgr.mr_n90051856)
print v(xbgr.mr_n90052368)
print v(xbgr.mr_n90054304)
print v(xbgr.mr_n90056048)
print v(xbgr.mr_n90056320)
print v(xbgr.mr_n90056512)
print v(xbgr.mr_n90057024)
print v(xbgr.mr_n90058960)
print v(xbgr.mr_n90060704)
print v(xbgr.mr_n90060976)
print v(xbgr.mr_n90061168)
print v(xbgr.mr_n90061680)
print v(xbgr.mr_n90063616)
print v(xbgr.mr_n90065360)
print v(xbgr.mr_n90065632)
print v(xbgr.mr_n90065824)
print v(xbgr.mr_n90066336)
print v(xbgr.mr_n90068272)
print v(xbgr.mr_n90070016)
print v(xbgr.mr_n90070288)
print v(xbgr.mr_n90070480)
print v(xbgr.mr_n90070992)
print v(xbgr.mr_n90072928)
print v(xbgr.mr_n90074672)
print v(xbgr.mr_n90074944)
print v(xbgr.mr_n90075136)
print v(xbgr.mr_n90075648)
print v(xbgr.mr_n90077584)
print v(xbgr.mr_n90079328)
print v(xbgr.mr_n90079600)
print v(xbgr.mr_n90079792)
print v(xbgr.mr_n90080304)
print v(xbgr.mr_n90082240)
print v(xbgr.mr_n90083984)
print v(xbgr.mr_n90084256)
print v(xbgr.mr_n90084448)
print v(xbgr.mr_n90084960)
print v(xbgr.mr_n90086896)
print v(xbgr.mr_n90088640)
print v(xbgr.mr_n90088912)
print v(xbgr.mr_n90089104)
print v(xbgr.mr_n90089616)
print v(xbgr.mr_n90091552)
print v(xbgr.mr_n90093296)
print v(xbgr.mr_n90093568)
print v(xbgr.mr_n90093760)
print v(xbgr.mr_n90094272)
print v(xbgr.mr_n90097104)
print v(xbgr.mr_n90097888)
print v(xbgr.mr_n90099536)
print v(xbgr.mr_n90099872)
print v(xbgr.mr_n90102080)
print v(xbgr.mr_n90103008)
print v(xbgr.mr_n90103744)
print v(xbgr.mr_n90104176)
print v(xbgr.mr_n90104608)
print v(xbgr.mr_n90106032)
print v(xbgr.mr_n90106608)
print v(xbgr.mr_n90106720)
print v(xbgr.mr_n90107664)
print v(xbgr.mr_n90108496)
print v(xbgr.mr_n90108608)
print v(xbgr.mr_n90109552)
print v(xbgr.mr_n90110704)
print v(xbgr.mr_n90110816)
print v(xbgr.mr_n90111760)
print v(xbgr.mr_n90112912)
print v(xbgr.mr_n90113024)
print v(xbgr.mr_n90113968)
print v(xbgr.mr_n90115120)
print v(xbgr.mr_n90115232)
print v(xbgr.mr_n90116176)
print v(xbgr.mr_n90117328)
print v(xbgr.mr_n90117440)
print v(xbgr.mr_n90118384)
print v(xbgr.mr_n90119536)
print v(xbgr.mr_n90119648)
print v(xbgr.mr_n90120592)
print v(xbgr.mr_n90120912)
print v(xbgr.mr_n90121680)
print v(xbgr.mr_n90121792)
print v(xbgr.mr_n90122736)
print v(xbgr.mr_n90123952)
print v(xbgr.mr_n90124064)
print v(xbgr.mr_n90125008)
print v(xbgr.mr_n90126160)
print v(xbgr.mr_n90126272)
print v(xbgr.mr_n90127216)
print v(xbgr.mr_n90128368)
print v(xbgr.mr_n90128480)
print v(xbgr.mr_n90129424)
print v(xbgr.mr_n90130512)
print v(xbgr.mr_n90130624)
print v(xbgr.mr_n90131568)
print v(xbgr.mr_n90131808)
print v(xbgr.mr_n90132784)
print v(xbgr.mr_n90132896)
print v(xbgr.mr_n90133840)
print v(xbgr.mr_n90134992)
print v(xbgr.mr_n90135104)
print v(xbgr.mr_n90136048)
print v(xbgr.mr_n90137200)
print v(xbgr.mr_n90137312)
print v(xbgr.mr_n90138464)
print v(xbgr.mr_n90138576)
print v(xbgr.mr_n90139728)
print v(xbgr.mr_n90139840)
print v(xbgr.mr_n90142928)
print v(xbgr.mr_n90144704)
print v(xbgr.mr_n90146672)
print v(xbgr.mr_n90146784)
print v(xbgr.mr_n90148224)
print v(xbgr.mr_n90148336)
print v(xbgr.mr_n90150704)
print v(xbgr.mr_n90150816)
print v(xbgr.mr_n90151968)
print v(xbgr.mr_n90152080)
print v(xbgr.mr_n90153232)
print v(xbgr.mr_n90153344)
print v(xbgr.mr_n90154496)
print v(xbgr.mr_n90154608)
print v(xbgr.mr_n90155760)
print v(xbgr.mr_n90155872)
print v(xbgr.mr_n90159520)
print v(xbgr.mr_n90162400)
print v(xbgr.mr_n90173456)
print v(xbgr.mr_n90185424)
print v(xbgr.mr_n90185616)
print v(xbgr.mr_n90185808)
print v(xbgr.mr_n90186000)
print v(xbgr.mr_n90188320)
print v(xbgr.mr_n90188592)
print v(xbgr.mr_n90188784)
print v(xbgr.mr_n90189296)
print v(xbgr.mr_n90194976)
print v(xbgr.mr_n90195248)
print v(xbgr.mr_n90195440)
print v(xbgr.mr_n90195952)
print v(xbgr.mr_n90198256)
print v(xbgr.mr_n90198448)
print v(xbgr.mr_n90198640)
print v(xbgr.mr_n90198832)
print v(xbgr.mr_n90199024)
print v(xbgr.mr_n90201248)
print v(xbgr.mr_n90202224)
print v(xbgr.mr_n90202736)
print v(xbgr.mr_n90206112)
print v(xbgr.mr_n90206384)
print v(xbgr.mr_n90206576)
print v(xbgr.mr_n90207088)
print v(xbgr.mr_n90209232)
print v(xbgr.mr_n90209344)
print v(xbgr.mr_n90211088)
print v(xbgr.mr_n90211360)
print v(xbgr.mr_n90211552)
print v(xbgr.mr_n90212064)
print v(xbgr.mr_n90212176)
print v(xbgr.mr_n90213296)
print v(xbgr.mr_n90213808)
print v(xbgr.mr_n90217248)
print v(xbgr.mr_n90217520)
print v(xbgr.mr_n90217712)
print v(xbgr.mr_n90218224)
print v(xbgr.mr_n90220368)
print v(xbgr.mr_n90220480)
print v(xbgr.mr_n90222224)
print v(xbgr.mr_n90222496)
print v(xbgr.mr_n90222688)
print v(xbgr.mr_n90223200)
print v(xbgr.mr_n90224432)
print v(xbgr.mr_n90224944)
print v(xbgr.mr_n90228384)
print v(xbgr.mr_n90228656)
print v(xbgr.mr_n90228848)
print v(xbgr.mr_n90229360)
print v(xbgr.mr_n90231504)
print v(xbgr.mr_n90231616)
print v(xbgr.mr_n90233360)
print v(xbgr.mr_n90233632)
print v(xbgr.mr_n90233824)
print v(xbgr.mr_n90234336)
print v(xbgr.mr_n90235568)
print v(xbgr.mr_n90236080)
print v(xbgr.mr_n90239520)
print v(xbgr.mr_n90239792)
print v(xbgr.mr_n90239984)
print v(xbgr.mr_n90240496)
print v(xbgr.mr_n90242640)
print v(xbgr.mr_n90242832)
print v(xbgr.mr_n90243024)
print v(xbgr.mr_n90244832)
print v(xbgr.mr_n90245024)
print v(xbgr.mr_n90245536)
print v(xbgr.mr_n90246704)
print v(xbgr.mr_n90247216)
print v(xbgr.mr_n90250656)
print v(xbgr.mr_n90250928)
print v(xbgr.mr_n90251120)
print v(xbgr.mr_n90251632)
print v(xbgr.mr_n90256832)
print v(xbgr.mr_n90256944)
print v(xbgr.mr_n90257776)
print v(xbgr.mr_n90257888)
print v(xbgr.mr_n90258720)
print v(xbgr.mr_n90258832)
print v(xbgr.mr_n90259920)
print v(xbgr.mr_n90260032)
print v(xbgr.mr_n90261184)
print v(xbgr.mr_n90261296)
print v(xbgr.mr_n90262448)
print v(xbgr.mr_n90262560)
print v(xbgr.mr_n90263712)
print v(xbgr.mr_n90263824)
print v(xbgr.mr_n90264976)
print v(xbgr.mr_n90265088)
print v(xbgr.mr_n90266240)
print v(xbgr.mr_n90266352)
print v(xbgr.mr_n90267504)
print v(xbgr.mr_n90267616)
print v(xbgr.mr_n90268768)
print v(xbgr.mr_n90268880)
print v(xbgr.mr_n90270032)
print v(xbgr.mr_n90270144)
print v(xbgr.mr_n90271296)
print v(xbgr.mr_n90271408)
print v(xbgr.mr_n90272560)
print v(xbgr.mr_n90272672)
print v(xbgr.mr_n90273824)
print v(xbgr.mr_n90273936)
print v(xbgr.mr_n90281728)
print v(xbgr.mr_n90284224)
print v(xbgr.mr_n90284912)
print v(xbgr.mr_n90285600)
print v(xbgr.mr_n90286288)
print v(xbgr.mr_n90287392)
print v(xbgr.mr_n90288976)
print v(xbgr.mr_n90289920)
print v(xbgr.mr_n90290864)
print v(xbgr.mr_n90291808)
print v(xbgr.mr_n90292752)
print v(xbgr.mr_n90293696)
print v(xbgr.mr_n90296112)
print v(xbgr.mr_n90296448)
print v(xbgr.mr_n90298656)
print v(xbgr.mr_n90299728)
print v(xbgr.mr_n90300224)
print v(xbgr.mr_n90301728)
print v(xbgr.mr_n90303360)
print v(xbgr.mr_n90304928)
print v(xbgr.mr_n90306496)
print v(xbgr.mr_n90308064)
print v(xbgr.mr_n90309632)
print v(xbgr.mr_n90311648)
print v(xbgr.mr_n90314112)
print v(xbgr.mr_n90314800)
print v(xbgr.mr_n90315488)
print v(xbgr.mr_n90316240)
print v(xbgr.mr_n90317856)
print v(xbgr.mr_n90319136)
print v(xbgr.mr_n90319248)
print v(xbgr.mr_n90320192)
print v(xbgr.mr_n90320512)
print v(xbgr.mr_n90321344)
print v(xbgr.mr_n90321456)
print v(xbgr.mr_n90322400)
print v(xbgr.mr_n90323552)
print v(xbgr.mr_n90323664)
print v(xbgr.mr_n90324608)
print v(xbgr.mr_n90324784)
print v(xbgr.mr_n90325760)
print v(xbgr.mr_n90325872)
print v(xbgr.mr_n90326816)
print v(xbgr.mr_n90327968)
print v(xbgr.mr_n90328080)
print v(xbgr.mr_n90329024)
print v(xbgr.mr_n90330176)
print v(xbgr.mr_n90330288)
print v(xbgr.mr_n90331232)
print v(xbgr.mr_n90331488)
print v(xbgr.mr_n90332384)
print v(xbgr.mr_n90332496)
print v(xbgr.mr_n90333440)
print v(xbgr.mr_n90334592)
print v(xbgr.mr_n90334704)
print v(xbgr.mr_n90335648)
print v(xbgr.mr_n90336800)
print v(xbgr.mr_n90336912)
print v(xbgr.mr_n90337856)
print v(xbgr.mr_n90339008)
print v(xbgr.mr_n90339120)
print v(xbgr.mr_n90340064)
print v(xbgr.mr_n90341216)
print v(xbgr.mr_n90341328)
print v(xbgr.mr_n90342272)
print v(xbgr.mr_n90343424)
print v(xbgr.mr_n90343536)
print v(xbgr.mr_n90344480)
print v(xbgr.mr_n90345632)
print v(xbgr.mr_n90345744)
print v(xbgr.mr_n90346688)
print v(xbgr.mr_n90347840)
print v(xbgr.mr_n90347952)
print v(xbgr.mr_n90348896)
print v(xbgr.mr_n90350048)
print v(xbgr.mr_n90350160)
print v(xbgr.mr_n90351104)
print v(xbgr.mr_n90352256)
print v(xbgr.mr_n90352368)
print v(xbgr.mr_n90353312)
print v(xbgr.mr_n90354464)
print v(xbgr.mr_n90354576)
print v(xbgr.mr_n90355456)
print v(xbgr.mr_n90356144)
print v(xbgr.mr_n90356832)
print v(xbgr.mr_n90357552)
print v(xbgr.mr_n90358496)
print v(xbgr.mr_n90359440)
print v(xbgr.mr_n90360384)
print v(xbgr.mr_n90361328)
print v(xbgr.mr_n90362272)
print v(xbgr.mr_n90363216)
print v(xbgr.mr_n90364160)
print v(xbgr.mr_n90365888)
print v(xbgr.mr_n90370304)
print v(xbgr.mr_n90372736)
print v(xbgr.mr_n90373184)
print v(xbgr.mr_n90375616)
print v(xbgr.mr_n90376512)
print v(xbgr.mr_n90381680)
print v(xbgr.mr_n90382336)
print v(xbgr.mr_n90384720)
print v(xbgr.mr_n90387280)
print v(xbgr.mr_n90388352)
print v(xbgr.mr_n90388544)
print v(xbgr.mr_n90388736)
print v(xbgr.mr_n90388928)
print v(xbgr.mr_n90391520)
print v(xbgr.mr_n90391712)
print v(xbgr.mr_n90392224)
print v(xbgr.mr_n90396944)
print v(xbgr.mr_n90397216)
print v(xbgr.mr_n90397408)
print v(xbgr.mr_n90397920)
print v(xbgr.mr_n90400064)
print v(xbgr.mr_n90400176)
print v(xbgr.mr_n90401920)
print v(xbgr.mr_n90402384)
print v(xbgr.mr_n90402896)
print v(xbgr.mr_n90403008)
print v(xbgr.mr_n90404128)
print v(xbgr.mr_n90404640)
print v(xbgr.mr_n90408080)
print v(xbgr.mr_n90408352)
print v(xbgr.mr_n90408544)
print v(xbgr.mr_n90409056)
print v(xbgr.mr_n90411200)
print v(xbgr.mr_n90411312)
print v(xbgr.mr_n90411568)
print v(xbgr.mr_n90413056)
print v(xbgr.mr_n90413328)
print v(xbgr.mr_n90413520)
print v(xbgr.mr_n90414032)
print v(xbgr.mr_n90416320)
print v(xbgr.mr_n90416944)
print v(xbgr.mr_n90419280)
print v(xbgr.mr_n90419968)
print v(xbgr.mr_n90420080)
print v(xbgr.mr_n90420192)
print v(xbgr.mr_n90420304)
print v(xbgr.mr_n90420416)
print v(xbgr.mr_n90420608)
print v(xbgr.mr_n90422160)
print v(xbgr.mr_n90422432)
print v(xbgr.mr_n90422624)
print v(xbgr.mr_n90423136)
print v(xbgr.mr_n90424464)
print v(xbgr.mr_n90424976)
print v(xbgr.mr_n90428800)
print v(xbgr.mr_n90429072)
print v(xbgr.mr_n90429264)
print v(xbgr.mr_n90429776)
print v(xbgr.mr_n90431920)
print v(xbgr.mr_n90432032)
print v(xbgr.mr_n90433776)
print v(xbgr.mr_n90434048)
print v(xbgr.mr_n90434240)
print v(xbgr.mr_n90434752)
print v(xbgr.mr_n90435984)
print v(xbgr.mr_n90436496)
print v(xbgr.mr_n90439936)
print v(xbgr.mr_n90440208)
print v(xbgr.mr_n90440400)
print v(xbgr.mr_n90440912)
print v(xbgr.mr_n90443056)
print v(xbgr.mr_n90443168)
print v(xbgr.mr_n90444912)
print v(xbgr.mr_n90445184)
print v(xbgr.mr_n90445376)
print v(xbgr.mr_n90445888)
print v(xbgr.mr_n90447120)
print v(xbgr.mr_n90447632)
print v(xbgr.mr_n90451072)
print v(xbgr.mr_n90451344)
print v(xbgr.mr_n90451536)
print v(xbgr.mr_n90452048)
print v(xbgr.mr_n90453248)
print v(xbgr.mr_n90454336)
print v(xbgr.mr_n90456992)
print v(xbgr.mr_n90457104)
print v(xbgr.mr_n90457872)
print v(xbgr.mr_n90457984)
print v(xbgr.mr_n90458880)
print v(xbgr.mr_n90458992)
print v(xbgr.mr_n90460016)
print v(xbgr.mr_n90460128)
print v(xbgr.mr_n90461344)
print v(xbgr.mr_n90461456)
print v(xbgr.mr_n90462608)
print v(xbgr.mr_n90462720)
print v(xbgr.mr_n90463872)
print v(xbgr.mr_n90463984)
print v(xbgr.mr_n90465136)
print v(xbgr.mr_n90465248)
print v(xbgr.mr_n90466400)
print v(xbgr.mr_n90466512)
print v(xbgr.mr_n90467664)
print v(xbgr.mr_n90467776)
print v(xbgr.mr_n90468928)
print v(xbgr.mr_n90469040)
print v(xbgr.mr_n90470192)
print v(xbgr.mr_n90470304)
print v(xbgr.mr_n90471456)
print v(xbgr.mr_n90471568)
print v(xbgr.mr_n90472656)
print v(xbgr.mr_n90472768)
print v(xbgr.mr_n90473984)
print v(xbgr.mr_n90474096)
print v(xbgr.mr_n90475568)
print v(xbgr.mr_n90475680)
print v(xbgr.mr_n90476896)
print v(xbgr.mr_n90477008)
print v(xbgr.mr_n90478160)
print v(xbgr.mr_n90478272)
print v(xbgr.mr_n90479424)
print v(xbgr.mr_n90479536)
print v(xbgr.mr_n90480688)
print v(xbgr.mr_n90480800)
print v(xbgr.mr_n90481952)
print v(xbgr.mr_n90482064)
print v(xbgr.mr_n90483216)
print v(xbgr.mr_n90483328)
print v(xbgr.mr_n90484480)
print v(xbgr.mr_n90484592)
print v(xbgr.mr_n90485744)
print v(xbgr.mr_n90485856)
print v(xbgr.mr_n90487008)
print v(xbgr.mr_n90487120)
print v(xbgr.mr_n90488208)
print v(xbgr.mr_n90488320)
print v(xbgr.mr_n90489536)
print v(xbgr.mr_n90489648)
print v(xbgr.mr_n90490736)
print v(xbgr.mr_n90490848)
print v(xbgr.mr_n90492064)
print v(xbgr.mr_n90492176)
print v(xbgr.mr_n90493328)
print v(xbgr.mr_n90493440)
print v(xbgr.mr_n90494592)
print v(xbgr.mr_n90494704)
print v(xbgr.mr_n90495856)
print v(xbgr.mr_n90495968)
print v(xbgr.mr_n90508240)
print v(xbgr.mr_n90514576)
print v(xbgr.mr_n90523264)
print v(xbgr.mr_n90527264)
print v(xbgr.mr_n90529440)
print v(xbgr.mr_n90529984)
print v(xbgr.mr_n90533520)
print v(xbgr.mr_n90534208)
print v(xbgr.mr_n90534896)
print v(xbgr.mr_n90535616)
print v(xbgr.mr_n90536560)
print v(xbgr.mr_n90537504)
print v(xbgr.mr_n90538448)
print v(xbgr.mr_n90539392)
print v(xbgr.mr_n90540336)
print v(xbgr.mr_n90541280)
print v(xbgr.mr_n90542224)
print v(xbgr.mr_n90543168)
print v(xbgr.mr_n90544112)
print v(xbgr.mr_n90545056)
print v(xbgr.mr_n90546000)
print v(xbgr.mr_n90546944)
print v(xbgr.mr_n90547888)
print v(xbgr.mr_n90548832)
print v(xbgr.mr_n90549776)
print v(xbgr.mr_n90552704)
print v(xbgr.mr_n90554528)
print v(xbgr.mr_n90563376)
print v(xbgr.mr_n90563488)
print v(xbgr.mr_n90564320)
print v(xbgr.mr_n90564432)
print v(xbgr.mr_n90564624)
print v(xbgr.mr_n90564816)
print v(xbgr.mr_n90565008)
print v(xbgr.mr_n90565200)
print v(xbgr.mr_n90565392)
print v(xbgr.mr_n90565584)
print v(xbgr.mr_n90567808)
print v(xbgr.mr_n90568272)
print v(xbgr.mr_n90570080)
print v(xbgr.mr_n90570352)
print v(xbgr.mr_n90570544)
print v(xbgr.mr_n90571056)
print v(xbgr.mr_n90574544)
print v(xbgr.mr_n90574816)
print v(xbgr.mr_n90575008)
print v(xbgr.mr_n90575520)
print v(xbgr.mr_n90577072)
print v(xbgr.mr_n90579328)
print v(xbgr.mr_n90579600)
print v(xbgr.mr_n90579792)
print v(xbgr.mr_n90580304)
print v(xbgr.mr_n90583792)
print v(xbgr.mr_n90584064)
print v(xbgr.mr_n90584256)
print v(xbgr.mr_n90584768)
print v(xbgr.mr_n90586320)
print v(xbgr.mr_n90588576)
print v(xbgr.mr_n90588848)
print v(xbgr.mr_n90589040)
print v(xbgr.mr_n90589552)
print v(xbgr.mr_n90593040)
print v(xbgr.mr_n90593312)
print v(xbgr.mr_n90593504)
print v(xbgr.mr_n90594016)
print v(xbgr.mr_n90595648)
print v(xbgr.mr_n90595840)
print v(xbgr.mr_n90598160)
print v(xbgr.mr_n90598352)
print v(xbgr.mr_n90598864)
print v(xbgr.mr_n90600800)
print v(xbgr.mr_n90602288)
print v(xbgr.mr_n90602560)
print v(xbgr.mr_n90602752)
print v(xbgr.mr_n90603264)
print v(xbgr.mr_n90604816)
print v(xbgr.mr_n90605392)
print v(xbgr.mr_n90607072)
print v(xbgr.mr_n90607344)
print v(xbgr.mr_n90607536)
print v(xbgr.mr_n90608048)
print v(xbgr.mr_n90609616)
print v(xbgr.mr_n90611872)
print v(xbgr.mr_n90612064)
print v(xbgr.mr_n90612576)
print v(xbgr.mr_n90614048)
print v(xbgr.mr_n90615376)
print v(xbgr.mr_n90615648)
print v(xbgr.mr_n90615840)
print v(xbgr.mr_n90616352)
print v(xbgr.mr_n90619216)
print v(xbgr.mr_n90619488)
print v(xbgr.mr_n90619680)
print v(xbgr.mr_n90620192)
print v(xbgr.mr_n90623552)
print v(xbgr.mr_n90623664)
print v(xbgr.mr_n90625408)
print v(xbgr.mr_n90625680)
print v(xbgr.mr_n90625872)
print v(xbgr.mr_n90626384)
print v(xbgr.mr_n90628528)
print v(xbgr.mr_n90628640)
print v(xbgr.mr_n90630384)
print v(xbgr.mr_n90630656)
print v(xbgr.mr_n90630848)
print v(xbgr.mr_n90631360)
print v(xbgr.mr_n90633504)
print v(xbgr.mr_n90633616)
print v(xbgr.mr_n90635360)
print v(xbgr.mr_n90635632)
print v(xbgr.mr_n90635824)
print v(xbgr.mr_n90636336)
print v(xbgr.mr_n90638480)
print v(xbgr.mr_n90638592)
print v(xbgr.mr_n90640336)
print v(xbgr.mr_n90640608)
print v(xbgr.mr_n90640800)
print v(xbgr.mr_n90641312)
print v(xbgr.mr_n90646480)
print v(xbgr.mr_n90648672)
print v(xbgr.mr_n90650240)
print v(xbgr.mr_n90651184)
print v(xbgr.mr_n90653376)
print v(xbgr.mr_n90654944)
print v(xbgr.mr_n90655888)
print v(xbgr.mr_n90658080)
print v(xbgr.mr_n90659696)
print v(xbgr.mr_n90660272)
print v(xbgr.mr_n90660384)
print v(xbgr.mr_n90661216)
print v(xbgr.mr_n90661328)
print v(xbgr.mr_n90662160)
print v(xbgr.mr_n90662272)
print v(xbgr.mr_n90663104)
print v(xbgr.mr_n90663216)
print v(xbgr.mr_n90664048)
print v(xbgr.mr_n90664160)
print v(xbgr.mr_n90664992)
print v(xbgr.mr_n90665104)
print v(xbgr.mr_n90665936)
print v(xbgr.mr_n90666048)
print v(xbgr.mr_n90666880)
print v(xbgr.mr_n90666992)
print v(xbgr.mr_n90667824)
print v(xbgr.mr_n90667936)
print v(xbgr.mr_n90668896)
print v(xbgr.mr_n90669008)
print v(xbgr.mr_n90670208)
print v(xbgr.mr_n90673472)
print v(xbgr.mr_n90673936)
print v(xbgr.mr_n90675072)
print v(xbgr.mr_n90676496)
print v(xbgr.mr_n90681040)
print v(xbgr.mr_n90689488)
print v(xbgr.mr_n90689760)
print v(xbgr.mr_n90690848)
print v(xbgr.mr_n90693216)
print v(xbgr.mr_n90693904)
print v(xbgr.mr_n90694592)
print v(xbgr.mr_n90695632)
print v(xbgr.mr_n90697120)
print v(xbgr.mr_n90698064)
print v(xbgr.mr_n90699008)
print v(xbgr.mr_n90699952)
print v(xbgr.mr_n90700896)
print v(xbgr.mr_n90701840)
print v(xbgr.mr_n90702784)
print v(xbgr.mr_n90703728)
print v(xbgr.mr_n90704672)
print v(xbgr.mr_n90705616)
print v(xbgr.mr_n90706560)
print v(xbgr.mr_n90707504)
print v(xbgr.mr_n90708448)
print v(xbgr.mr_n90709392)
print v(xbgr.mr_n90710336)
print v(xbgr.mr_n90710528)
print v(xbgr.mr_n90710720)
print v(xbgr.mr_n90710912)
print v(xbgr.mr_n90711104)
print v(xbgr.mr_n90711296)
print v(xbgr.mr_n90713440)
print v(xbgr.mr_n90713552)
print v(xbgr.mr_n90716864)
print v(xbgr.mr_n90716976)
print v(xbgr.mr_n90721856)
print v(xbgr.mr_n90723696)
print v(xbgr.mr_n90725536)
print v(xbgr.mr_n90727376)
print v(xbgr.mr_n90730112)
print v(xbgr.mr_n90733328)
print v(xbgr.mr_n90744544)
print v(xbgr.mr_n90746112)
print v(xbgr.mr_n90747680)
print v(xbgr.mr_n90749248)
print v(xbgr.mr_n90750816)
print v(xbgr.mr_n90752384)
print v(xbgr.mr_n90753952)
print v(xbgr.mr_n90755520)
print v(xbgr.mr_n90757088)
print v(xbgr.mr_n90758656)
print v(xbgr.mr_n90760224)
print v(xbgr.mr_n90761792)
print v(xbgr.mr_n90763360)
print v(xbgr.mr_n90764928)
print v(xbgr.mr_n90766496)
print v(xbgr.mr_n90768064)
print v(xbgr.mr_n90771312)
print v(xbgr.mr_n90771648)
print v(xbgr.mr_n90771760)
print v(xbgr.mr_n90772592)
print v(xbgr.mr_n90772704)
print v(xbgr.mr_n90773536)
print v(xbgr.mr_n90773648)
print v(xbgr.mr_n90774480)
print v(xbgr.mr_n90774592)
print v(xbgr.mr_n90774736)
print v(xbgr.mr_n90778080)
print v(xbgr.mr_n90778592)
print v(xbgr.mr_n90778704)
print v(xbgr.mr_n90778896)
print v(xbgr.mr_n90779088)
print v(xbgr.mr_n90779280)
print v(xbgr.mr_n90779472)
print v(xbgr.mr_n90779664)
print v(xbgr.mr_n90779856)
print v(xbgr.mr_n90781760)
print v(xbgr.mr_n90783584)
print v(xbgr.mr_n90783696)
print v(xbgr.mr_n90785440)
print v(xbgr.mr_n90785712)
print v(xbgr.mr_n90785904)
print v(xbgr.mr_n90786416)
print v(xbgr.mr_n90788560)
print v(xbgr.mr_n90788672)
print v(xbgr.mr_n90790416)
print v(xbgr.mr_n90790688)
print v(xbgr.mr_n90790880)
print v(xbgr.mr_n90791392)
print v(xbgr.mr_n90793536)
print v(xbgr.mr_n90793648)
print v(xbgr.mr_n90793840)
print v(xbgr.mr_n90795392)
print v(xbgr.mr_n90795664)
print v(xbgr.mr_n90795856)
print v(xbgr.mr_n90796368)
print v(xbgr.mr_n90798512)
print v(xbgr.mr_n90798624)
print v(xbgr.mr_n90800368)
print v(xbgr.mr_n90800640)
print v(xbgr.mr_n90800832)
print v(xbgr.mr_n90801344)
print v(xbgr.mr_n90803488)
print v(xbgr.mr_n90803600)
print v(xbgr.mr_n90803792)
print v(xbgr.mr_n90805344)
print v(xbgr.mr_n90805616)
print v(xbgr.mr_n90805808)
print v(xbgr.mr_n90806320)
print v(xbgr.mr_n90808544)
print v(xbgr.mr_n90808736)
print v(xbgr.mr_n90808928)
print v(xbgr.mr_n90809120)
print v(xbgr.mr_n90809312)
print v(xbgr.mr_n90811552)
print v(xbgr.mr_n90813440)
print v(xbgr.mr_n90813552)
print v(xbgr.mr_n90815296)
print v(xbgr.mr_n90815488)
print v(xbgr.mr_n90815680)
print v(xbgr.mr_n90816272)
print v(xbgr.mr_n90818080)
print v(xbgr.mr_n90818192)
print v(xbgr.mr_n90819344)
print v(xbgr.mr_n90819456)
print v(xbgr.mr_n90820544)
print v(xbgr.mr_n90821072)
print v(xbgr.mr_n90822464)
print v(xbgr.mr_n90823152)
print v(xbgr.mr_n90823840)
print v(xbgr.mr_n90824528)
print v(xbgr.mr_n90825216)
print v(xbgr.mr_n90825904)
print v(xbgr.mr_n90826592)
print v(xbgr.mr_n90827280)
print v(xbgr.mr_n90827968)
print v(xbgr.mr_n90828656)
print v(xbgr.mr_n90829344)
print v(xbgr.mr_n90830032)
print v(xbgr.mr_n90832128)
print v(xbgr.mr_n90833136)
print v(xbgr.mr_n90834080)
print v(xbgr.mr_n90835024)
print v(xbgr.mr_n90835968)
print v(xbgr.mr_n90836912)
print v(xbgr.mr_n90837856)
print v(xbgr.mr_n90838800)
print v(xbgr.mr_n90847376)
print v(xbgr.mr_n90852304)
print v(xbgr.mr_n90855696)
print v(xbgr.mr_n90857264)
print v(xbgr.mr_n90858304)
print v(xbgr.mr_n90858416)
print v(xbgr.mr_n90858528)
print v(xbgr.mr_n90860128)
print v(xbgr.mr_n90860240)
print v(xbgr.mr_n90863552)
print v(xbgr.mr_n90864448)
print v(xbgr.mr_n90865664)
print v(xbgr.mr_n90865776)
print v(xbgr.mr_n90866864)
print v(xbgr.mr_n90869520)
print v(xbgr.mr_n90870992)
print v(xbgr.mr_n90872560)
print v(xbgr.mr_n90874128)
print v(xbgr.mr_n90875696)
print v(xbgr.mr_n90878464)
print v(xbgr.mr_n90879584)
print v(xbgr.mr_n90881776)
print v(xbgr.mr_n90882048)
print v(xbgr.mr_n90883120)
print v(xbgr.mr_n90883936)
print v(xbgr.mr_n90884608)
print v(xbgr.mr_n90884800)
print v(xbgr.mr_n90885840)
print v(xbgr.mr_n90885952)
print v(xbgr.mr_n90888192)
print v(xbgr.mr_n90889744)
print v(xbgr.mr_n90890864)
print v(xbgr.mr_n90891552)
print v(xbgr.mr_n90894448)
print v(xbgr.mr_n90896016)
print v(xbgr.mr_n90896960)
print v(xbgr.mr_n90899152)
print v(xbgr.mr_n90904112)
print v(xbgr.mr_n90905728)
print v(xbgr.mr_n90905840)
print v(xbgr.mr_n90906992)
print v(xbgr.mr_n90907104)
print v(xbgr.mr_n90908256)
print v(xbgr.mr_n90908368)
print v(xbgr.mr_n90909520)
print v(xbgr.mr_n90909632)
print v(xbgr.mr_n90910720)
print v(xbgr.mr_n90910832)
print v(xbgr.mr_n90912048)
print v(xbgr.mr_n90912160)
print v(xbgr.mr_n90913312)
print v(xbgr.mr_n90913424)
print v(xbgr.mr_n90914512)
print v(xbgr.mr_n90914624)
print v(xbgr.mr_n90915840)
print v(xbgr.mr_n90915952)
print v(xbgr.mr_n90917040)
print v(xbgr.mr_n90917152)
print v(xbgr.mr_n90919008)
print v(xbgr.mr_n90929248)
print v(xbgr.mr_n90929952)
print v(xbgr.mr_n90934608)
print v(xbgr.mr_n90935856)
print v(xbgr.mr_n90936720)
print v(xbgr.mr_n90936832)
print v(xbgr.mr_n90937024)
print v(xbgr.mr_n90937216)
print v(xbgr.mr_n90937408)
print v(xbgr.mr_n90939824)
print v(xbgr.mr_n90945664)
print v(xbgr.mr_n90946608)
print v(xbgr.mr_n90947552)
print v(xbgr.mr_n90948496)
print v(xbgr.mr_n90949440)
print v(xbgr.mr_n90950384)
print v(xbgr.mr_n90951328)
print v(xbgr.mr_n90952272)
print v(xbgr.mr_n90953216)
print v(xbgr.mr_n90954160)
print v(xbgr.mr_n90955104)
print v(xbgr.mr_n90955760)
print v(xbgr.mr_n90955952)
print v(xbgr.mr_n90956368)
print v(xbgr.mr_n90956976)
print v(xbgr.mr_n90957744)
print v(xbgr.mr_n90958848)
print v(xbgr.mr_n90961200)
print v(xbgr.mr_n90962144)
print v(xbgr.mr_n90963088)
print v(xbgr.mr_n90964032)
print v(xbgr.mr_n90964976)
print v(xbgr.mr_n90965920)
print v(xbgr.mr_n90966864)
print v(xbgr.mr_n90967808)
print v(xbgr.mr_n90968752)
print v(xbgr.mr_n90969696)
print v(xbgr.mr_n90970640)
print v(xbgr.mr_n90971904)
print v(xbgr.mr_n90973568)
print v(xbgr.mr_n90974400)
print v(xbgr.mr_n90975344)
print v(xbgr.mr_n90976288)
print v(xbgr.mr_n90976480)
print v(xbgr.mr_n90976672)
print v(xbgr.mr_n90976864)
print v(xbgr.mr_n90977056)
print v(xbgr.mr_n90977248)
print v(xbgr.mr_n90979392)
print v(xbgr.mr_n90979504)
print v(xbgr.mr_n90982592)
print v(xbgr.mr_n90982704)
print v(xbgr.mr_n90988352)
print v(xbgr.mr_n90989296)
print v(xbgr.mr_n90990240)
print v(xbgr.mr_n90991184)
print v(xbgr.mr_n90992128)
print v(xbgr.mr_n90993072)
print v(xbgr.mr_n90994016)
print v(xbgr.mr_n90994960)
print v(xbgr.mr_n90995904)
print v(xbgr.mr_n90996848)
print v(xbgr.mr_n90998592)
print v(xbgr.mr_n90999168)
print v(xbgr.mr_n90999280)
print v(xbgr.mr_n91000224)
print v(xbgr.mr_n91000416)
print v(xbgr.mr_n91000608)
print v(xbgr.mr_n91000800)
print v(xbgr.mr_n91002992)
print v(xbgr.mr_n91003456)
print v(xbgr.mr_n91003968)
print v(xbgr.mr_n91006320)
print v(xbgr.mr_n91009456)
print v(xbgr.mr_n91010288)
print v(xbgr.mr_n91010400)
print v(xbgr.mr_n91010512)
print v(xbgr.mr_n91010624)
print v(xbgr.mr_n91010736)
print v(xbgr.mr_n91010928)
print v(xbgr.mr_n91012480)
print v(xbgr.mr_n91012752)
print v(xbgr.mr_n91012944)
print v(xbgr.mr_n91013456)
print v(xbgr.mr_n91015600)
print v(xbgr.mr_n91015712)
print v(xbgr.mr_n91017456)
print v(xbgr.mr_n91017728)
print v(xbgr.mr_n91017920)
print v(xbgr.mr_n91018432)
print v(xbgr.mr_n91020576)
print v(xbgr.mr_n91020688)
print v(xbgr.mr_n91022432)
print v(xbgr.mr_n91022704)
print v(xbgr.mr_n91022896)
print v(xbgr.mr_n91023408)
print v(xbgr.mr_n91025552)
print v(xbgr.mr_n91025664)
print v(xbgr.mr_n91027408)
print v(xbgr.mr_n91027680)
print v(xbgr.mr_n91027872)
print v(xbgr.mr_n91028384)
print v(xbgr.mr_n91030528)
print v(xbgr.mr_n91030640)
print v(xbgr.mr_n91032384)
print v(xbgr.mr_n91032656)
print v(xbgr.mr_n91032848)
print v(xbgr.mr_n91033360)
print v(xbgr.mr_n91035504)
print v(xbgr.mr_n91035616)
print v(xbgr.mr_n91037632)
print v(xbgr.mr_n91038336)
print v(xbgr.mr_n91040480)
print v(xbgr.mr_n91040592)
print v(xbgr.mr_n91042336)
print v(xbgr.mr_n91042608)
print v(xbgr.mr_n91042800)
print v(xbgr.mr_n91043312)
print v(xbgr.mr_n91051296)
print v(xbgr.mr_n91051744)
print v(xbgr.mr_n91053792)
print v(xbgr.mr_n91053984)
print v(xbgr.mr_n91054176)
print v(xbgr.mr_n91055072)
print v(xbgr.mr_n91055184)
print v(xbgr.mr_n91057424)
print v(xbgr.mr_n91057872)
print v(xbgr.mr_n91061584)
print v(xbgr.mr_n91062272)
print v(xbgr.mr_n91062960)
print v(xbgr.mr_n91063648)
print v(xbgr.mr_n91064336)
print v(xbgr.mr_n91065024)
print v(xbgr.mr_n91065712)
print v(xbgr.mr_n91066400)
print v(xbgr.mr_n91067088)
print v(xbgr.mr_n91067776)
print v(xbgr.mr_n91068464)
print v(xbgr.mr_n91069152)
print v(xbgr.mr_n91080304)
print v(xbgr.mr_n91082160)
print v(xbgr.mr_n91082272)
print v(xbgr.mr_n91084384)
print v(xbgr.mr_n91084496)
print v(xbgr.mr_n91085648)
print v(xbgr.mr_n91085760)
print v(xbgr.mr_n91086912)
print v(xbgr.mr_n91087024)
print v(xbgr.mr_n91088176)
print v(xbgr.mr_n91088288)
print v(xbgr.mr_n91089440)
print v(xbgr.mr_n91089552)
print v(xbgr.mr_n91090640)
print v(xbgr.mr_n91090752)
print v(xbgr.mr_n91090928)
print v(xbgr.mr_n91091040)
print v(xbgr.mr_n91091568)
print v(xbgr.mr_n91091680)
print v(xbgr.mr_n91092912)
print v(xbgr.mr_n91093024)
print v(xbgr.mr_n91093856)
print v(xbgr.mr_n91093968)
print v(xbgr.mr_n91096432)
print v(xbgr.mr_n91096544)
print v(xbgr.mr_n91097888)
print v(xbgr.mr_n91098000)
print v(xbgr.mr_n91099152)
print v(xbgr.mr_n91099264)
print v(xbgr.mr_n91100416)
print v(xbgr.mr_n91100528)
print v(xbgr.mr_n91104272)
print v(xbgr.mr_n91105392)
print v(xbgr.mr_n91106864)
print v(xbgr.mr_n91108432)
print v(xbgr.mr_n91110000)
print v(xbgr.mr_n91111568)
print v(xbgr.mr_n91113136)
print v(xbgr.mr_n91114704)
print v(xbgr.mr_n91116272)
print v(xbgr.mr_n91117840)
print v(xbgr.mr_n91119408)
print v(xbgr.mr_n91120976)
print v(xbgr.mr_n91123168)
print v(xbgr.mr_n91124736)
print v(xbgr.mr_n91126304)
print v(xbgr.mr_n91130080)
print v(xbgr.mr_n91133216)
print v(xbgr.mr_n91134496)
print v(xbgr.mr_n91135584)
print v(xbgr.mr_n91138032)
print v(xbgr.mr_n91139184)
print v(xbgr.mr_n91139376)
print v(xbgr.mr_n91139568)
print v(xbgr.mr_n91139760)
print v(xbgr.mr_n91139952)
print v(xbgr.mr_n91142336)
print v(xbgr.mr_n91142528)
print v(xbgr.mr_n91143040)
print v(xbgr.mr_n91146624)
print v(xbgr.mr_n91147888)
print v(xbgr.mr_n91148080)
print v(xbgr.mr_n91148272)
print v(xbgr.mr_n91148864)
print v(xbgr.mr_n91151600)
print v(xbgr.mr_n91151872)
print v(xbgr.mr_n91152064)
print v(xbgr.mr_n91152576)
print v(xbgr.mr_n91154880)
print v(xbgr.mr_n91155072)
print v(xbgr.mr_n91155264)
print v(xbgr.mr_n91155456)
print v(xbgr.mr_n91155648)
print v(xbgr.mr_n91157872)
print v(xbgr.mr_n91158784)
print v(xbgr.mr_n91159296)
print v(xbgr.mr_n91167088)
print v(xbgr.mr_n91167360)
print v(xbgr.mr_n91167552)
print v(xbgr.mr_n91168064)
print v(xbgr.mr_n91169488)
print v(xbgr.mr_n91170000)
print v(xbgr.mr_n91170688)
print v(xbgr.mr_n91171616)
print v(xbgr.mr_n91172128)
print v(xbgr.mr_n91174192)
print v(xbgr.mr_n91174704)
print v(xbgr.mr_n91176768)
print v(xbgr.mr_n91177280)
print v(xbgr.mr_n91178480)
print v(xbgr.mr_n91179344)
print v(xbgr.mr_n91179856)
print v(xbgr.mr_n91181920)
print v(xbgr.mr_n91182432)
print v(xbgr.mr_n91184416)
print v(xbgr.mr_n91185008)
print v(xbgr.mr_n91187072)
print v(xbgr.mr_n91187584)
print v(xbgr.mr_n91189568)
print v(xbgr.mr_n91190160)
print v(xbgr.mr_n91192224)
print v(xbgr.mr_n91192736)
print v(xbgr.mr_n91194800)
print v(xbgr.mr_n91195312)
print v(xbgr.mr_n91196128)
print v(xbgr.mr_n91203648)
print v(xbgr.mr_n91203760)
print v(xbgr.mr_n91204912)
print v(xbgr.mr_n91205024)
print v(xbgr.mr_n91206176)
print v(xbgr.mr_n91206288)
print v(xbgr.mr_n91207440)
print v(xbgr.mr_n91207552)
print v(xbgr.mr_n91208704)
print v(xbgr.mr_n91208816)
print v(xbgr.mr_n91209968)
print v(xbgr.mr_n91210080)
print v(xbgr.mr_n91211232)
print v(xbgr.mr_n91211344)
print v(xbgr.mr_n91212496)
print v(xbgr.mr_n91212608)
print v(xbgr.mr_n91213760)
print v(xbgr.mr_n91213872)
print v(xbgr.mr_n91215024)
print v(xbgr.mr_n91215136)
print v(xbgr.mr_n91216288)
print v(xbgr.mr_n91216400)
print v(xbgr.mr_n91217552)
print v(xbgr.mr_n91217664)
print v(xbgr.mr_n91218816)
print v(xbgr.mr_n91218928)
print v(xbgr.mr_n91220080)
print v(xbgr.mr_n91220192)
print v(xbgr.mr_n91220384)
print v(xbgr.mr_n91221968)
print v(xbgr.mr_n91227872)
print v(xbgr.mr_n91231392)
print v(xbgr.mr_n91231648)
print v(xbgr.mr_n91233232)
print v(xbgr.mr_n91235696)
print v(xbgr.mr_n91236384)
print v(xbgr.mr_n91237072)
print v(xbgr.mr_n91238176)
print v(xbgr.mr_n91239792)
print v(xbgr.mr_n91240736)
print v(xbgr.mr_n91241680)
print v(xbgr.mr_n91242624)
print v(xbgr.mr_n91243568)
print v(xbgr.mr_n91244512)
print v(xbgr.mr_n91245456)
print v(xbgr.mr_n91246400)
print v(xbgr.mr_n91247344)
print v(xbgr.mr_n91248288)
print v(xbgr.mr_n91249232)
print v(xbgr.mr_n91250176)
print v(xbgr.mr_n91251120)
print v(xbgr.mr_n91252064)
print v(xbgr.mr_n91253008)
print v(xbgr.mr_n91259328)
print v(xbgr.mr_n91260896)
print v(xbgr.mr_n91262160)
print v(xbgr.mr_n91264240)
print v(xbgr.mr_n91265472)
print v(xbgr.mr_n91265584)
print v(xbgr.mr_n91266528)
print v(xbgr.mr_n91267616)
print v(xbgr.mr_n91267728)
print v(xbgr.mr_n91269568)
print v(xbgr.mr_n91269680)
print v(xbgr.mr_n91270624)
print v(xbgr.mr_n91271776)
print v(xbgr.mr_n91271888)
print v(xbgr.mr_n91273664)
print v(xbgr.mr_n91273776)
print v(xbgr.mr_n91274720)
print v(xbgr.mr_n91275872)
print v(xbgr.mr_n91275984)
print v(xbgr.mr_n91277232)
print v(xbgr.mr_n91277760)
print v(xbgr.mr_n91277872)
print v(xbgr.mr_n91278816)
print v(xbgr.mr_n91279968)
print v(xbgr.mr_n91280080)
print v(xbgr.mr_n91281792)
print v(xbgr.mr_n91281904)
print v(xbgr.mr_n91282848)
print v(xbgr.mr_n91284064)
print v(xbgr.mr_n91284176)
print v(xbgr.mr_n91285952)
print v(xbgr.mr_n91286064)
print v(xbgr.mr_n91287008)
print v(xbgr.mr_n91288160)
print v(xbgr.mr_n91288272)
print v(xbgr.mr_n91290048)
print v(xbgr.mr_n91290160)
print v(xbgr.mr_n91291104)
print v(xbgr.mr_n91292256)
print v(xbgr.mr_n91292368)
print v(xbgr.mr_n91293552)
print v(xbgr.mr_n91294080)
print v(xbgr.mr_n91294192)
print v(xbgr.mr_n91295136)
print v(xbgr.mr_n91296352)
print v(xbgr.mr_n91296464)
print v(xbgr.mr_n91298240)
print v(xbgr.mr_n91298352)
print v(xbgr.mr_n91299664)
print v(xbgr.mr_n91300784)
print v(xbgr.mr_n91302880)
print v(xbgr.mr_n91304448)
print v(xbgr.mr_n91306016)
print v(xbgr.mr_n91307584)
print v(xbgr.mr_n91309152)
print v(xbgr.mr_n91310720)
print v(xbgr.mr_n91312288)
print v(xbgr.mr_n91316432)
print v(xbgr.mr_n91318224)
print v(xbgr.mr_n91318992)
print v(xbgr.mr_n91321376)
print v(xbgr.mr_n91325776)
print v(xbgr.mr_n91328544)
print v(xbgr.mr_n91331152)
print v(xbgr.mr_n91331648)
print v(xbgr.mr_n91332416)
print v(xbgr.mr_n91332608)
print v(xbgr.mr_n91332800)
print v(xbgr.mr_n91332992)
print v(xbgr.mr_n91335312)
print v(xbgr.mr_n91335584)
print v(xbgr.mr_n91335776)
print v(xbgr.mr_n91336288)
print v(xbgr.mr_n91340704)
print v(xbgr.mr_n91341968)
print v(xbgr.mr_n91342160)
print v(xbgr.mr_n91342352)
print v(xbgr.mr_n91342944)
print v(xbgr.mr_n91345680)
print v(xbgr.mr_n91345952)
print v(xbgr.mr_n91346144)
print v(xbgr.mr_n91346656)
print v(xbgr.mr_n91348800)
print v(xbgr.mr_n91348912)
print v(xbgr.mr_n91350656)
print v(xbgr.mr_n91350928)
print v(xbgr.mr_n91351120)
print v(xbgr.mr_n91351632)
print v(xbgr.mr_n91352864)
print v(xbgr.mr_n91353376)
print v(xbgr.mr_n91356816)
print v(xbgr.mr_n91357088)
print v(xbgr.mr_n91357280)
print v(xbgr.mr_n91357792)
print v(xbgr.mr_n91360048)
print v(xbgr.mr_n91361616)
print v(xbgr.mr_n91362672)
print v(xbgr.mr_n91364592)
print v(xbgr.mr_n91364784)
print v(xbgr.mr_n91364976)
print v(xbgr.mr_n91365168)
print v(xbgr.mr_n91366912)
print v(xbgr.mr_n91367184)
print v(xbgr.mr_n91367376)
print v(xbgr.mr_n91367888)
print v(xbgr.mr_n91371120)
print v(xbgr.mr_n91371232)
print v(xbgr.mr_n91372976)
print v(xbgr.mr_n91373248)
print v(xbgr.mr_n91373440)
print v(xbgr.mr_n91373952)
print v(xbgr.mr_n91375184)
print v(xbgr.mr_n91375696)
print v(xbgr.mr_n91377664)
print v(xbgr.mr_n91379472)
print v(xbgr.mr_n91379664)
print v(xbgr.mr_n91380176)
print v(xbgr.mr_n91382256)
print v(xbgr.mr_n91382368)
print v(xbgr.mr_n91384112)
print v(xbgr.mr_n91384384)
print v(xbgr.mr_n91384576)
print v(xbgr.mr_n91385088)
print v(xbgr.mr_n91386320)
print v(xbgr.mr_n91386832)
print v(xbgr.mr_n91388800)
print v(xbgr.mr_n91390608)
print v(xbgr.mr_n91390800)
print v(xbgr.mr_n91391312)
print v(xbgr.mr_n91393392)
print v(xbgr.mr_n91393504)
print v(xbgr.mr_n91395248)
print v(xbgr.mr_n91395520)
print v(xbgr.mr_n91395712)
print v(xbgr.mr_n91396224)
print v(xbgr.mr_n91397456)
print v(xbgr.mr_n91397968)
print v(xbgr.mr_n91403216)
print v(xbgr.mr_n91405024)
print v(xbgr.mr_n91405136)
print v(xbgr.mr_n91405968)
print v(xbgr.mr_n91406080)
print v(xbgr.mr_n91406912)
print v(xbgr.mr_n91407024)
print v(xbgr.mr_n91408112)
print v(xbgr.mr_n91408224)
print v(xbgr.mr_n91409376)
print v(xbgr.mr_n91409488)
print v(xbgr.mr_n91410640)
print v(xbgr.mr_n91410752)
print v(xbgr.mr_n91411904)
print v(xbgr.mr_n91412016)
print v(xbgr.mr_n91413168)
print v(xbgr.mr_n91413280)
print v(xbgr.mr_n91414432)
print v(xbgr.mr_n91414544)
print v(xbgr.mr_n91415696)
print v(xbgr.mr_n91415808)
print v(xbgr.mr_n91416960)
print v(xbgr.mr_n91417072)
print v(xbgr.mr_n91418224)
print v(xbgr.mr_n91418336)
print v(xbgr.mr_n91419488)
print v(xbgr.mr_n91419600)
print v(xbgr.mr_n91420752)
print v(xbgr.mr_n91420864)
print v(xbgr.mr_n91422016)
print v(xbgr.mr_n91422128)
print v(xbgr.mr_n91428640)
print v(xbgr.mr_n91429328)
print v(xbgr.mr_n91430016)
print v(xbgr.mr_n91430736)
print v(xbgr.mr_n91431680)
print v(xbgr.mr_n91432624)
print v(xbgr.mr_n91433568)
print v(xbgr.mr_n91434512)
print v(xbgr.mr_n91435456)
print v(xbgr.mr_n91436400)
print v(xbgr.mr_n91437344)
print v(xbgr.mr_n91438288)
print v(xbgr.mr_n91439232)
print v(xbgr.mr_n91440176)
print v(xbgr.mr_n91441120)
print v(xbgr.mr_n91442064)
print v(xbgr.mr_n91443008)
print v(xbgr.mr_n91443952)
print v(xbgr.mr_n91444896)
print v(xbgr.mr_n91449104)
print v(xbgr.mr_n91456608)
print v(xbgr.mr_n91456992)
print v(xbgr.mr_n91459024)
print v(xbgr.mr_n91460432)
print v(xbgr.mr_n91462000)
print v(xbgr.mr_n91464480)
print v(xbgr.mr_n91464912)
print v(xbgr.mr_n91465520)
print v(xbgr.mr_n91465632)
print v(xbgr.mr_n91466576)
print v(xbgr.mr_n91467728)
print v(xbgr.mr_n91467840)
print v(xbgr.mr_n91469616)
print v(xbgr.mr_n91469728)
print v(xbgr.mr_n91470672)
print v(xbgr.mr_n91471824)
print v(xbgr.mr_n91471936)
print v(xbgr.mr_n91473712)
print v(xbgr.mr_n91473824)
print v(xbgr.mr_n91474768)
print v(xbgr.mr_n91475920)
print v(xbgr.mr_n91476032)
print v(xbgr.mr_n91477808)
print v(xbgr.mr_n91477920)
print v(xbgr.mr_n91478864)
print v(xbgr.mr_n91480016)
print v(xbgr.mr_n91480128)
print v(xbgr.mr_n91481376)
print v(xbgr.mr_n91481904)
print v(xbgr.mr_n91482016)
print v(xbgr.mr_n91482960)
print v(xbgr.mr_n91484112)
print v(xbgr.mr_n91484224)
print v(xbgr.mr_n91486000)
print v(xbgr.mr_n91486112)
print v(xbgr.mr_n91487056)
print v(xbgr.mr_n91488208)
print v(xbgr.mr_n91488320)
print v(xbgr.mr_n91489568)
print v(xbgr.mr_n91490096)
print v(xbgr.mr_n91490208)
print v(xbgr.mr_n91491152)
print v(xbgr.mr_n91492304)
print v(xbgr.mr_n91492416)
print v(xbgr.mr_n91494192)
print v(xbgr.mr_n91494304)
print v(xbgr.mr_n91495088)
print v(xbgr.mr_n91495248)
print v(xbgr.mr_n91495504)
print v(xbgr.mr_n91496432)
print v(xbgr.mr_n91496608)
print v(xbgr.mr_n91497856)
print v(xbgr.mr_n91498976)
print v(xbgr.mr_n91501888)
print v(xbgr.mr_n91503456)
print v(xbgr.mr_n91505024)
print v(xbgr.mr_n91506592)
print v(xbgr.mr_n91507856)
print v(xbgr.mr_n91514656)
print v(xbgr.mr_n91518096)
print v(xbgr.mr_n91523984)
print v(xbgr.mr_n91525232)
print v(xbgr.mr_n91527456)
print v(xbgr.mr_n91531280)
print v(xbgr.mr_n91534112)
print v(xbgr.mr_n91534368)
print v(xbgr.mr_n91534560)
print v(xbgr.mr_n91535248)
print v(xbgr.mr_n91535824)
print v(xbgr.mr_n91536512)
print v(xbgr.mr_n91537088)
print v(xbgr.mr_n91537776)
print v(xbgr.mr_n91538352)
print v(xbgr.mr_n91539040)
print v(xbgr.mr_n91539472)
print v(xbgr.mr_n91540304)
print v(xbgr.mr_n91540736)
print v(xbgr.mr_n91541568)
print v(xbgr.mr_n91542000)
print v(xbgr.mr_n91542832)
print v(xbgr.mr_n91543264)
print v(xbgr.mr_n91544096)
print v(xbgr.mr_n91544672)
print v(xbgr.mr_n91545360)
print v(xbgr.mr_n91545792)
print v(xbgr.mr_n91546624)
print v(xbgr.mr_n91547200)
print v(xbgr.mr_n91547888)
print v(xbgr.mr_n91548592)
print v(xbgr.mr_n91549152)
print v(xbgr.mr_n91549728)
print v(xbgr.mr_n91550416)
print v(xbgr.mr_n91550992)
print v(xbgr.mr_n91551680)
print v(xbgr.mr_n91552112)
print v(xbgr.mr_n91552944)
print v(xbgr.mr_n91553376)
print v(xbgr.mr_n91554208)
print v(xbgr.mr_n91554784)
print v(xbgr.mr_n91555472)
print v(xbgr.mr_n91556352)
print v(xbgr.mr_n91558976)
print v(xbgr.mr_n91559088)
print v(xbgr.mr_n91559200)
print v(xbgr.mr_n91559312)
print v(xbgr.mr_n91561632)
print v(xbgr.mr_n91561904)
print v(xbgr.mr_n91562096)
print v(xbgr.mr_n91562608)
print v(xbgr.mr_n91563840)
print v(xbgr.mr_n91564352)
print v(xbgr.mr_n91565120)
print v(xbgr.mr_n91565904)
print v(xbgr.mr_n91566416)
print v(xbgr.mr_n91567232)
print v(xbgr.mr_n91568352)
print v(xbgr.mr_n91568864)
print v(xbgr.mr_n91570864)
print v(xbgr.mr_n91571376)
print v(xbgr.mr_n91572384)
print v(xbgr.mr_n91573248)
print v(xbgr.mr_n91573760)
print v(xbgr.mr_n91575696)
print v(xbgr.mr_n91576208)
print v(xbgr.mr_n91577024)
print v(xbgr.mr_n91578144)
print v(xbgr.mr_n91578656)
print v(xbgr.mr_n91580592)
print v(xbgr.mr_n91581104)
print v(xbgr.mr_n91583040)
print v(xbgr.mr_n91583552)
print v(xbgr.mr_n91585552)
print v(xbgr.mr_n91586064)
print v(xbgr.mr_n91587936)
print v(xbgr.mr_n91588448)
print v(xbgr.mr_n91590384)
print v(xbgr.mr_n91590896)
print v(xbgr.mr_n91592832)
print v(xbgr.mr_n91593344)
print v(xbgr.mr_n91595280)
print v(xbgr.mr_n91595792)
print v(xbgr.mr_n91597728)
print v(xbgr.mr_n91598240)
print v(xbgr.mr_n91600176)
print v(xbgr.mr_n91600688)
print v(xbgr.mr_n91602672)
print v(xbgr.mr_n91608608)
print v(xbgr.mr_n91609760)
print v(xbgr.mr_n91609872)
print v(xbgr.mr_n91611024)
print v(xbgr.mr_n91611136)
print v(xbgr.mr_n91612288)
print v(xbgr.mr_n91612400)
print v(xbgr.mr_n91613552)
print v(xbgr.mr_n91613664)
print v(xbgr.mr_n91614816)
print v(xbgr.mr_n91614928)
print v(xbgr.mr_n91616080)
print v(xbgr.mr_n91616192)
print v(xbgr.mr_n91617344)
print v(xbgr.mr_n91617456)
print v(xbgr.mr_n91618608)
print v(xbgr.mr_n91618720)
print v(xbgr.mr_n91619872)
print v(xbgr.mr_n91619984)
print v(xbgr.mr_n91621136)
print v(xbgr.mr_n91621248)
print v(xbgr.mr_n91622400)
print v(xbgr.mr_n91622512)
print v(xbgr.mr_n91623664)
print v(xbgr.mr_n91623776)
print v(xbgr.mr_n91624928)
print v(xbgr.mr_n91625040)
print v(xbgr.mr_n91626192)
print v(xbgr.mr_n91626304)
print v(xbgr.mr_n91627456)
print v(xbgr.mr_n91627568)
print v(xbgr.mr_n91628448)
print v(xbgr.mr_n91629136)
print v(xbgr.mr_n91629824)
print v(xbgr.mr_n91630544)
print v(xbgr.mr_n91631488)
print v(xbgr.mr_n91631600)
print v(xbgr.mr_n91631712)
print v(xbgr.mr_n91631824)
print v(xbgr.mr_n91631936)
print v(xbgr.mr_n91632256)
print v(xbgr.mr_n91633504)
print v(xbgr.mr_n91634192)
print v(xbgr.mr_n91636672)
print v(xbgr.mr_n91639376)
print v(xbgr.mr_n91644416)
print v(xbgr.mr_n91652192)
print v(xbgr.mr_n91654432)
print v(xbgr.mr_n91655040)
print v(xbgr.mr_n91657680)
print v(xbgr.mr_n91658368)
print v(xbgr.mr_n91661344)
print v(xbgr.mr_n91663856)
print v(xbgr.mr_n91664464)
print v(xbgr.mr_n91665696)
print v(xbgr.mr_n91665808)
print v(xbgr.mr_n91666752)
print v(xbgr.mr_n91667904)
print v(xbgr.mr_n91668016)
print v(xbgr.mr_n91669184)
print v(xbgr.mr_n91669792)
print v(xbgr.mr_n91669904)
print v(xbgr.mr_n91670848)
print v(xbgr.mr_n91672000)
print v(xbgr.mr_n91672112)
print v(xbgr.mr_n91673888)
print v(xbgr.mr_n91674000)
print v(xbgr.mr_n91674944)
print v(xbgr.mr_n91676096)
print v(xbgr.mr_n91676208)
print v(xbgr.mr_n91677456)
print v(xbgr.mr_n91677984)
print v(xbgr.mr_n91678096)
print v(xbgr.mr_n91679040)
print v(xbgr.mr_n91680192)
print v(xbgr.mr_n91680304)
print v(xbgr.mr_n91682080)
print v(xbgr.mr_n91682192)
print v(xbgr.mr_n91683136)
print v(xbgr.mr_n91684288)
print v(xbgr.mr_n91684400)
print v(xbgr.mr_n91686176)
print v(xbgr.mr_n91686288)
print v(xbgr.mr_n91687232)
print v(xbgr.mr_n91688320)
print v(xbgr.mr_n91688432)
print v(xbgr.mr_n91690272)
print v(xbgr.mr_n91690384)
print v(xbgr.mr_n91691328)
print v(xbgr.mr_n91692480)
print v(xbgr.mr_n91692592)
print v(xbgr.mr_n91694368)
print v(xbgr.mr_n91694480)
print v(xbgr.mr_n91695424)
print v(xbgr.mr_n91696576)
print v(xbgr.mr_n91696688)
print v(xbgr.mr_n91698464)
print v(xbgr.mr_n91698576)
print v(xbgr.mr_n91699888)
print v(xbgr.mr_n91701008)
print v(xbgr.mr_n91703104)
print v(xbgr.mr_n91704672)
print v(xbgr.mr_n91706240)
print v(xbgr.mr_n91707808)
print v(xbgr.mr_n91709376)
print v(xbgr.mr_n91710944)
print v(xbgr.mr_n91712512)
print v(xbgr.mr_n91718320)
print v(xbgr.mr_n91720912)
print v(xbgr.mr_n91721968)
print v(xbgr.mr_n91725104)
print v(xbgr.mr_n91725552)
print v(xbgr.mr_n91730256)
print v(xbgr.mr_n91732112)
print v(xbgr.mr_n91732224)
print v(xbgr.mr_n91733248)
print v(xbgr.mr_n91733440)
print v(xbgr.mr_n91733632)
print v(xbgr.mr_n91733824)
print v(xbgr.mr_n91734016)
print v(xbgr.mr_n91736336)
print v(xbgr.mr_n91736528)
print v(xbgr.mr_n91737040)
print v(xbgr.mr_n91741104)
print v(xbgr.mr_n91741216)
print v(xbgr.mr_n91742960)
print v(xbgr.mr_n91743152)
print v(xbgr.mr_n91743344)
print v(xbgr.mr_n91743936)
print v(xbgr.mr_n91746080)
print v(xbgr.mr_n91746192)
print v(xbgr.mr_n91747936)
print v(xbgr.mr_n91748208)
print v(xbgr.mr_n91748400)
print v(xbgr.mr_n91748912)
print v(xbgr.mr_n91751056)
print v(xbgr.mr_n91751168)
print v(xbgr.mr_n91752912)
print v(xbgr.mr_n91753184)
print v(xbgr.mr_n91753376)
print v(xbgr.mr_n91753888)
print v(xbgr.mr_n91756032)
print v(xbgr.mr_n91756144)
print v(xbgr.mr_n91756336)
print v(xbgr.mr_n91757888)
print v(xbgr.mr_n91758160)
print v(xbgr.mr_n91758352)
print v(xbgr.mr_n91758864)
print v(xbgr.mr_n91759040)
print v(xbgr.mr_n91761008)
print v(xbgr.mr_n91761120)
print v(xbgr.mr_n91762864)
print v(xbgr.mr_n91763136)
print v(xbgr.mr_n91763328)
print v(xbgr.mr_n91763840)
print v(xbgr.mr_n91764560)
print v(xbgr.mr_n91765984)
print v(xbgr.mr_n91766096)
print v(xbgr.mr_n91767360)
print v(xbgr.mr_n91767728)
print v(xbgr.mr_n91768576)
print v(xbgr.mr_n91769040)
print v(xbgr.mr_n91771920)
print v(xbgr.mr_n91772032)
print v(xbgr.mr_n91772144)
print v(xbgr.mr_n91773888)
print v(xbgr.mr_n91774160)
print v(xbgr.mr_n91774352)
print v(xbgr.mr_n91774864)
print v(xbgr.mr_n91778480)
print v(xbgr.mr_n91778592)
print v(xbgr.mr_n91780336)
print v(xbgr.mr_n91780608)
print v(xbgr.mr_n91780800)
print v(xbgr.mr_n91781312)
print v(xbgr.mr_n91783456)
print v(xbgr.mr_n91783568)
print v(xbgr.mr_n91785312)
print v(xbgr.mr_n91785584)
print v(xbgr.mr_n91785776)
print v(xbgr.mr_n91786288)
print v(xbgr.mr_n91788432)
print v(xbgr.mr_n91788544)
print v(xbgr.mr_n91790288)
print v(xbgr.mr_n91790560)
print v(xbgr.mr_n91790752)
print v(xbgr.mr_n91791264)
print v(xbgr.mr_n91793408)
print v(xbgr.mr_n91793520)
print v(xbgr.mr_n91795264)
print v(xbgr.mr_n91795536)
print v(xbgr.mr_n91795728)
print v(xbgr.mr_n91796240)
print v(xbgr.mr_n91798384)
print v(xbgr.mr_n91798496)
print v(xbgr.mr_n91800240)
print v(xbgr.mr_n91800512)
print v(xbgr.mr_n91800704)
print v(xbgr.mr_n91801216)
print v(xbgr.mr_n91803360)
print v(xbgr.mr_n91803472)
print v(xbgr.mr_n91805216)
print v(xbgr.mr_n91805488)
print v(xbgr.mr_n91805680)
print v(xbgr.mr_n91806192)
print v(xbgr.mr_n91808336)
print v(xbgr.mr_n91808448)
print v(xbgr.mr_n91810192)
print v(xbgr.mr_n91810464)
print v(xbgr.mr_n91810656)
print v(xbgr.mr_n91811168)
print v(xbgr.mr_n91813312)
print v(xbgr.mr_n91813424)
print v(xbgr.mr_n91815168)
print v(xbgr.mr_n91815360)
print v(xbgr.mr_n91815552)
print v(xbgr.mr_n91816144)
print v(xbgr.mr_n91836576)
print v(xbgr.mr_n91841728)
print v(xbgr.mr_n91847904)
print v(xbgr.mr_n91848384)
print v(xbgr.mr_n91849856)
print v(xbgr.mr_n91850288)
print v(xbgr.mr_n91854400)
print v(xbgr.mr_n91854512)
print v(xbgr.mr_n91855664)
print v(xbgr.mr_n91855776)
print v(xbgr.mr_n91856928)
print v(xbgr.mr_n91857040)
print v(xbgr.mr_n91858192)
print v(xbgr.mr_n91858304)
print v(xbgr.mr_n91859456)
print v(xbgr.mr_n91859568)
print v(xbgr.mr_n91860720)
print v(xbgr.mr_n91860832)
print v(xbgr.mr_n91861984)
print v(xbgr.mr_n91862096)
print v(xbgr.mr_n91863184)
print v(xbgr.mr_n91863296)
print v(xbgr.mr_n91864512)
print v(xbgr.mr_n91864624)
print v(xbgr.mr_n91865776)
print v(xbgr.mr_n91865888)
print v(xbgr.mr_n91867040)
print v(xbgr.mr_n91867152)
print v(xbgr.mr_n91868304)
print v(xbgr.mr_n91868416)
print v(xbgr.mr_n91869568)
print v(xbgr.mr_n91869680)
print v(xbgr.mr_n91870832)
print v(xbgr.mr_n91870944)
print v(xbgr.mr_n91872096)
print v(xbgr.mr_n91872208)
print v(xbgr.mr_n91873920)
print v(xbgr.mr_n91874384)
print v(xbgr.mr_n91882368)
print v(xbgr.mr_n91883056)
print v(xbgr.mr_n91883744)
print v(xbgr.mr_n91884464)
print v(xbgr.mr_n91885408)
print v(xbgr.mr_n91886352)
print v(xbgr.mr_n91887296)
print v(xbgr.mr_n91888240)
print v(xbgr.mr_n91889184)
print v(xbgr.mr_n91890128)
print v(xbgr.mr_n91891072)
print v(xbgr.mr_n91892016)
print v(xbgr.mr_n91892960)
print v(xbgr.mr_n91893904)
print v(xbgr.mr_n91894848)
print v(xbgr.mr_n91895792)
print v(xbgr.mr_n91896736)
print v(xbgr.mr_n91897680)
print v(xbgr.mr_n91898624)
print v(xbgr.mr_n91899568)
print v(xbgr.mr_n91900512)
print v(xbgr.mr_n91901456)
print v(xbgr.mr_n91902400)
print v(xbgr.mr_n91902672)
print v(xbgr.mr_n91902944)
print v(xbgr.mr_n91903552)
print v(xbgr.mr_n91917040)
print v(xbgr.mr_n91919184)
print v(xbgr.mr_n91919632)
print v(xbgr.mr_n91920240)
print v(xbgr.mr_n91920800)
print v(xbgr.mr_n91921296)
print v(xbgr.mr_n91921568)
print v(xbgr.mr_n91922944)
print v(xbgr.mr_n91923408)
print v(xbgr.mr_n91923584)
print v(xbgr.mr_n91924048)
print v(xbgr.mr_n91924816)
print v(xbgr.mr_n91924992)
print v(xbgr.mr_n91926864)
print v(xbgr.mr_n91927568)
print v(xbgr.mr_n91927920)
print v(xbgr.mr_n91930272)
print v(xbgr.mr_n91930624)
print v(xbgr.mr_n91930800)
print v(xbgr.mr_n91930976)
print v(xbgr.mr_n91931152)
print v(xbgr.mr_n91931440)
print v(xbgr.mr_n91932496)
print v(xbgr.mr_n91932736)
print v(xbgr.mr_n91933904)
print v(xbgr.mr_n91934848)
print v(xbgr.mr_n91935136)
print v(xbgr.mr_n91936256)
print v(xbgr.mr_n91936720)
print v(xbgr.mr_n91937952)
print v(xbgr.mr_n91938656)
print v(xbgr.mr_n91939184)
print v(xbgr.mr_n91940592)
print v(xbgr.mr_n91940832)
print v(xbgr.mr_n91941008)
print v(xbgr.mr_n91942240)
print v(xbgr.mr_n91942416)
print v(xbgr.mr_n91942880)
print v(xbgr.mr_n91945760)
print v(xbgr.mr_n91946592)
print v(xbgr.mr_n91946816)
print v(xbgr.mr_n91948128)
print v(xbgr.mr_n91948800)
print v(xbgr.mr_n91949472)
print v(xbgr.mr_n91950704)
print v(xbgr.mr_n91951472)
print v(xbgr.mr_n91952416)
print v(xbgr.mr_n91953360)
print v(xbgr.mr_n91954304)
print v(xbgr.mr_n91955248)
print v(xbgr.mr_n91956192)
print v(xbgr.mr_n91957136)
print v(xbgr.mr_n91958080)
print v(xbgr.mr_n91959024)
print v(xbgr.mr_n91959968)
print v(xbgr.mr_n91960912)
print v(xbgr.mr_n91961856)
print v(xbgr.mr_n91962800)
print v(xbgr.mr_n91963744)
print v(xbgr.mr_n91964688)
print v(xbgr.mr_n91965632)
print v(xbgr.mr_n91966576)
print v(xbgr.mr_n91967520)
print v(xbgr.mr_n91968464)
print v(xbgr.mr_n91969408)
print v(xbgr.mr_n91970352)
print v(xbgr.mr_n91971296)
print v(xbgr.mr_n91972240)
print v(xbgr.mr_n91973184)
print v(xbgr.mr_n91974128)
print v(xbgr.mr_n91975072)
print v(xbgr.mr_n91976016)
print v(xbgr.mr_n91976960)
print v(xbgr.mr_n91977904)
print v(xbgr.mr_n91978848)
print v(xbgr.mr_n91979792)
print v(xbgr.mr_n91980736)
print v(xbgr.mr_n91981680)
print v(xbgr.mr_n91982624)
print v(xbgr.mr_n91983568)
print v(xbgr.mr_n91984512)
print v(xbgr.mr_n91985456)
print v(xbgr.mr_n91986400)
print v(xbgr.mr_n91987344)
print v(xbgr.mr_n91988288)
print v(xbgr.mr_n91989232)
print v(xbgr.mr_n91990176)
print v(xbgr.mr_n91991120)
print v(xbgr.mr_n91992064)
print v(xbgr.mr_n91993008)
print v(xbgr.mr_n91993952)
print v(xbgr.mr_n91994896)
print v(xbgr.mr_n91995840)
print v(xbgr.mr_n91996784)
print v(xbgr.mr_n91997728)
print v(xbgr.mr_n91998672)
print v(xbgr.mr_n91999616)
print v(xbgr.mr_n92000560)
print v(xbgr.mr_n92001504)
print v(xbgr.mr_n92002448)
print v(xbgr.mr_n92003392)
print v(xbgr.mr_n92004336)
print v(xbgr.mr_n92005280)
print v(xbgr.mr_n92006224)
print v(xbgr.mr_n92007168)
print v(xbgr.mr_n92008112)
print v(xbgr.mr_n92009056)
print v(xbgr.mr_n92010000)
print v(xbgr.mr_n92010944)
print v(xbgr.mr_n92011888)
print v(xbgr.mr_n92012832)
print v(xbgr.mr_n92013776)
print v(xbgr.mr_n92014720)
print v(xbgr.mr_n92015664)
print v(xbgr.mr_n92016608)
print v(xbgr.mr_n92017552)
print v(xbgr.mr_n92018496)
print v(xbgr.mr_n92019440)
print v(xbgr.mr_n92020384)
print v(xbgr.mr_n92021328)
print v(xbgr.mr_n92022272)
print v(xbgr.mr_n92023216)
print v(xbgr.mr_n92024160)
print v(xbgr.mr_n92025104)
print v(xbgr.mr_n92026048)
print v(xbgr.mr_n92026992)
print v(xbgr.mr_n92027936)
print v(xbgr.mr_n92028880)
print v(xbgr.mr_n92029824)
print v(xbgr.mr_n92030768)
print v(xbgr.mr_n92031712)
print v(xbgr.mr_n92032656)
print v(xbgr.mr_n92033600)
print v(xbgr.mr_n92034544)
print v(xbgr.mr_n92035488)
print v(xbgr.mr_n92036432)
print v(xbgr.mr_n92037952)
print v(xbgr.mr_n92038064)
print v(xbgr.mr_n92038432)
print v(xbgr.mr_n92038624)
print v(xbgr.mr_n92038816)
print v(xbgr.mr_n92039008)
print v(xbgr.mr_n92039920)
print v(xbgr.mr_n92040192)
print v(xbgr.mr_n92040384)
print v(xbgr.mr_n92040960)
print v(xbgr.mr_n92045200)
print v(xbgr.mr_n92046720)
print v(xbgr.mr_n92046832)
print v(xbgr.mr_n92047088)
print v(xbgr.mr_n92048576)
print v(xbgr.mr_n92048848)
print v(xbgr.mr_n92049040)
print v(xbgr.mr_n92049552)
print v(xbgr.mr_n92052736)
print v(xbgr.mr_n92052848)
print v(xbgr.mr_n92052960)
print v(xbgr.mr_n92053072)
print v(xbgr.mr_n92054816)
print v(xbgr.mr_n92055008)
print v(xbgr.mr_n92055200)
print v(xbgr.mr_n92055792)
print v(xbgr.mr_n92057024)
print v(xbgr.mr_n92057536)
print v(xbgr.mr_n92060384)
print v(xbgr.mr_n92060496)
print v(xbgr.mr_n92062240)
print v(xbgr.mr_n92062512)
print v(xbgr.mr_n92062704)
print v(xbgr.mr_n92063216)
print v(xbgr.mr_n92066400)
print v(xbgr.mr_n92066512)
print v(xbgr.mr_n92066624)
print v(xbgr.mr_n92066736)
print v(xbgr.mr_n92068480)
print v(xbgr.mr_n92068752)
print v(xbgr.mr_n92068944)
print v(xbgr.mr_n92069456)
print v(xbgr.mr_n92072640)
print v(xbgr.mr_n92072752)
print v(xbgr.mr_n92072864)
print v(xbgr.mr_n92072976)
print v(xbgr.mr_n92074720)
print v(xbgr.mr_n92074992)
print v(xbgr.mr_n92075184)
print v(xbgr.mr_n92075696)
print v(xbgr.mr_n92076928)
print v(xbgr.mr_n92077440)
print v(xbgr.mr_n92080288)
print v(xbgr.mr_n92080400)
print v(xbgr.mr_n92082144)
print v(xbgr.mr_n92082416)
print v(xbgr.mr_n92082608)
print v(xbgr.mr_n92083120)
print v(xbgr.mr_n92086304)
print v(xbgr.mr_n92086496)
print v(xbgr.mr_n92086688)
print v(xbgr.mr_n92086880)
print v(xbgr.mr_n92087072)
print v(xbgr.mr_n92087264)
print v(xbgr.mr_n92087456)
print v(xbgr.mr_n92089680)
print v(xbgr.mr_n92092544)
print v(xbgr.mr_n92092656)
print v(xbgr.mr_n92092768)
print v(xbgr.mr_n92092960)
print v(xbgr.mr_n92093152)
print v(xbgr.mr_n92094960)
print v(xbgr.mr_n92095152)
print v(xbgr.mr_n92095664)
print v(xbgr.mr_n92096832)
print v(xbgr.mr_n92097344)
print v(xbgr.mr_n92099584)
print v(xbgr.mr_n92100192)
print v(xbgr.mr_n92100384)
print v(xbgr.mr_n92100576)
print v(xbgr.mr_n92102384)
print v(xbgr.mr_n92102576)
print v(xbgr.mr_n92103088)
print v(xbgr.mr_n92106208)
print v(xbgr.mr_n92106320)
print v(xbgr.mr_n92106432)
print v(xbgr.mr_n92106544)
print v(xbgr.mr_n92108288)
print v(xbgr.mr_n92108560)
print v(xbgr.mr_n92108752)
print v(xbgr.mr_n92109264)
print v(xbgr.mr_n92112448)
print v(xbgr.mr_n92112560)
print v(xbgr.mr_n92112672)
print v(xbgr.mr_n92112784)
print v(xbgr.mr_n92114528)
print v(xbgr.mr_n92114800)
print v(xbgr.mr_n92114992)
print v(xbgr.mr_n92115504)
print v(xbgr.mr_n92115616)
print v(xbgr.mr_n92117568)
print v(xbgr.mr_n92120096)
print v(xbgr.mr_n92120208)
print v(xbgr.mr_n92121952)
print v(xbgr.mr_n92122224)
print v(xbgr.mr_n92122416)
print v(xbgr.mr_n92122928)
print v(xbgr.mr_n92124992)
print v(xbgr.mr_n92125104)
print v(xbgr.mr_n92125616)
print v(xbgr.mr_n92125728)
print v(xbgr.mr_n92126240)
print v(xbgr.mr_n92126352)
print v(xbgr.mr_n92127120)
print v(xbgr.mr_n92127232)
print v(xbgr.mr_n92128064)
print v(xbgr.mr_n92128176)
print v(xbgr.mr_n92129200)
print v(xbgr.mr_n92129312)
print v(xbgr.mr_n92130528)
print v(xbgr.mr_n92130640)
print v(xbgr.mr_n92131792)
print v(xbgr.mr_n92131904)
print v(xbgr.mr_n92133056)
print v(xbgr.mr_n92133168)
print v(xbgr.mr_n92134320)
print v(xbgr.mr_n92134432)
print v(xbgr.mr_n92135584)
print v(xbgr.mr_n92135696)
print v(xbgr.mr_n92136848)
print v(xbgr.mr_n92136960)
print v(xbgr.mr_n92138112)
print v(xbgr.mr_n92138224)
print v(xbgr.mr_n92139312)
print v(xbgr.mr_n92139424)
print v(xbgr.mr_n92140640)
print v(xbgr.mr_n92140752)
print v(xbgr.mr_n92141904)
print v(xbgr.mr_n92142016)
print v(xbgr.mr_n92148592)
print v(xbgr.mr_n92159408)
print v(xbgr.mr_n92166224)
print v(xbgr.mr_n92169008)
print v(xbgr.mr_n92170320)
print v(xbgr.mr_n92170576)
print v(xbgr.mr_n92170832)
print v(xbgr.mr_n92171088)
print v(xbgr.mr_n92178448)
print v(xbgr.mr_n92178560)
print v(xbgr.mr_n92183136)
print v(xbgr.mr_n92185680)
print v(xbgr.mr_n92186288)
print v(xbgr.mr_n92187264)
print v(xbgr.mr_n92191760)
print v(xbgr.mr_n92198320)
print v(xbgr.mr_n92198672)
print v(xbgr.mr_n92199024)
print v(xbgr.mr_n92206320)
print v(xbgr.mr_n92207264)
print v(xbgr.mr_n92208208)
print v(xbgr.mr_n92209152)
print v(xbgr.mr_n92210096)
print v(xbgr.mr_n92211040)
print v(xbgr.mr_n92211984)
print v(xbgr.mr_n92212928)
print v(xbgr.mr_n92213872)
print v(xbgr.mr_n92214816)
print v(xbgr.mr_n92215760)
print v(xbgr.mr_n92216704)
print v(xbgr.mr_n92217648)
print v(xbgr.mr_n92218592)
print v(xbgr.mr_n92219536)
print v(xbgr.mr_n92220480)
print v(xbgr.mr_n92221424)
print v(xbgr.mr_n92222368)
print v(xbgr.mr_n92223312)
print v(xbgr.mr_n92224256)
print v(xbgr.mr_n92225200)
print v(xbgr.mr_n92226144)
print v(xbgr.mr_n92227088)
print v(xbgr.mr_n92228032)
print v(xbgr.mr_n92228976)
print v(xbgr.mr_n92234912)
print v(xbgr.mr_n92235856)
print v(xbgr.mr_n92236800)
print v(xbgr.mr_n92243264)
print v(xbgr.mr_n92243456)
print v(xbgr.mr_n92244144)
print v(xbgr.mr_n92244256)
print v(xbgr.mr_n92244368)
print v(xbgr.mr_n92244480)
print v(xbgr.mr_n92244592)
print v(xbgr.mr_n92246336)
print v(xbgr.mr_n92246608)
print v(xbgr.mr_n92246800)
print v(xbgr.mr_n92247312)
print v(xbgr.mr_n92249248)
print v(xbgr.mr_n92250992)
print v(xbgr.mr_n92251264)
print v(xbgr.mr_n92251456)
print v(xbgr.mr_n92251968)
print v(xbgr.mr_n92253904)
print v(xbgr.mr_n92255648)
print v(xbgr.mr_n92255920)
print v(xbgr.mr_n92256112)
print v(xbgr.mr_n92256624)
print v(xbgr.mr_n92258560)
print v(xbgr.mr_n92260304)
print v(xbgr.mr_n92260576)
print v(xbgr.mr_n92260768)
print v(xbgr.mr_n92261280)
print v(xbgr.mr_n92263216)
print v(xbgr.mr_n92264960)
print v(xbgr.mr_n92265232)
print v(xbgr.mr_n92265424)
print v(xbgr.mr_n92265936)
print v(xbgr.mr_n92267872)
print v(xbgr.mr_n92269616)
print v(xbgr.mr_n92269888)
print v(xbgr.mr_n92270080)
print v(xbgr.mr_n92270592)
print v(xbgr.mr_n92272608)
print v(xbgr.mr_n92272800)
print v(xbgr.mr_n92274608)
print v(xbgr.mr_n92274800)
print v(xbgr.mr_n92275312)
print v(xbgr.mr_n92277184)
print v(xbgr.mr_n92278928)
print v(xbgr.mr_n92279200)
print v(xbgr.mr_n92279392)
print v(xbgr.mr_n92279904)
print v(xbgr.mr_n92281840)
print v(xbgr.mr_n92283584)
print v(xbgr.mr_n92283856)
print v(xbgr.mr_n92284048)
print v(xbgr.mr_n92284560)
print v(xbgr.mr_n92286496)
print v(xbgr.mr_n92288240)
print v(xbgr.mr_n92288512)
print v(xbgr.mr_n92288704)
print v(xbgr.mr_n92289216)
print v(xbgr.mr_n92291152)
print v(xbgr.mr_n92292896)
print v(xbgr.mr_n92293088)
print v(xbgr.mr_n92293280)
print v(xbgr.mr_n92293872)
print v(xbgr.mr_n92295808)
print v(xbgr.mr_n92296000)
print v(xbgr.mr_n92297552)
print v(xbgr.mr_n92297824)
print v(xbgr.mr_n92298016)
print v(xbgr.mr_n92298528)
print v(xbgr.mr_n92299568)
print v(xbgr.mr_n92300544)
print v(xbgr.mr_n92300736)
print v(xbgr.mr_n92302544)
print v(xbgr.mr_n92302736)
print v(xbgr.mr_n92303248)
print v(xbgr.mr_n92305120)
print v(xbgr.mr_n92306864)
print v(xbgr.mr_n92307056)
print v(xbgr.mr_n92307248)
print v(xbgr.mr_n92307696)
print v(xbgr.mr_n92313536)
print v(xbgr.mr_n92314592)
print v(xbgr.mr_n92314784)
print v(xbgr.mr_n92314976)
print v(xbgr.mr_n92315168)
print v(xbgr.mr_n92318656)
print v(xbgr.mr_n92319808)
print v(xbgr.mr_n92320592)
print v(xbgr.mr_n92321168)
print v(xbgr.mr_n92321392)
print v(xbgr.mr_n92323520)
print v(xbgr.mr_n92324656)
print v(xbgr.mr_n92325776)
print v(xbgr.mr_n92325968)
print v(xbgr.mr_n92326928)
print v(xbgr.mr_n92328800)
print v(xbgr.mr_n92330960)
print v(xbgr.mr_n92331536)
print v(xbgr.mr_n92333648)
print v(xbgr.mr_n92335216)
print v(xbgr.mr_n92335664)
print v(xbgr.mr_n92338032)
print v(xbgr.mr_n92338288)
print v(xbgr.mr_n92339504)
print v(xbgr.mr_n92341840)
print v(xbgr.mr_n92343056)
print v(xbgr.mr_n92344336)
print v(xbgr.mr_n92349552)
print v(xbgr.mr_n92350176)
print v(xbgr.mr_n92351856)
print v(xbgr.mr_n92356256)
print v(xbgr.mr_n92356368)
print v(xbgr.mr_n92357360)
print v(xbgr.mr_n92358496)
print v(xbgr.mr_n92360576)
print v(xbgr.mr_n92361344)
print v(xbgr.mr_n92361504)
print v(xbgr.mr_n92362560)
print v(xbgr.mr_n92363072)
print v(xbgr.mr_n92363552)
print v(xbgr.mr_n92363888)
print v(xbgr.mr_n92366816)
print v(xbgr.mr_n92372096)
print v(xbgr.mr_n92372320)
print v(xbgr.mr_n92373568)
print v(xbgr.mr_n92376544)
print v(xbgr.mr_n92377312)
print v(xbgr.mr_n92380880)
print v(xbgr.mr_n92380992)
print v(xbgr.mr_n92381424)
print v(xbgr.mr_n92382512)
print v(xbgr.mr_n92382624)
print v(xbgr.mr_n92383136)
print v(xbgr.mr_n92383328)
print v(xbgr.mr_n92383872)
print v(xbgr.mr_n92383984)
print v(xbgr.mr_n92385120)
print v(xbgr.mr_n92385776)
print v(xbgr.mr_n92386592)
print v(xbgr.mr_n92386704)
print v(xbgr.mr_n92387040)
print v(xbgr.mr_n92387232)
print v(xbgr.mr_n92388400)
print v(xbgr.mr_n92388592)
print v(xbgr.mr_n92388928)
print v(xbgr.mr_n92389408)
print v(xbgr.mr_n92392624)
print v(xbgr.mr_n92392816)
print v(xbgr.mr_n92393120)
print v(xbgr.mr_n92393856)
print v(xbgr.mr_n92395760)
print v(xbgr.mr_n92396464)
print v(xbgr.mr_n92397328)
print v(xbgr.mr_n92398976)
print v(xbgr.mr_n92399616)
print v(xbgr.mr_n92400064)
print v(xbgr.mr_n92400256)
print v(xbgr.mr_n92401040)
print v(xbgr.mr_n92401344)
print v(xbgr.mr_n92401744)
print v(xbgr.mr_n92402144)
print v(xbgr.mr_n92402608)
print v(xbgr.mr_n92404640)
print v(xbgr.mr_n92404832)
print v(xbgr.mr_n92405808)
print v(xbgr.mr_n92406528)
print v(xbgr.mr_n92406960)
print v(xbgr.mr_n92407616)
print v(xbgr.mr_n92412448)
print v(xbgr.mr_n92413104)
print v(xbgr.mr_n92413568)
print v(xbgr.mr_n92414032)
print v(xbgr.mr_n92414976)
print v(xbgr.mr_n92415312)
print v(xbgr.mr_n92415504)
print v(xbgr.mr_n92415696)
print v(xbgr.mr_n92416640)
print v(xbgr.mr_n92416976)
print v(xbgr.mr_n92417440)
print v(xbgr.mr_n92417904)
print v(xbgr.mr_n92419664)
print v(xbgr.mr_n92420400)
print v(xbgr.mr_n92420960)
print v(xbgr.mr_n92421360)
print v(xbgr.mr_n92421824)
print v(xbgr.mr_n92422320)
print v(xbgr.mr_n92428928)
print v(xbgr.mr_n92429696)
print v(xbgr.mr_n92430384)
print v(xbgr.mr_n92431072)
print v(xbgr.mr_n92431760)
print v(xbgr.mr_n92432448)
print v(xbgr.mr_n92433136)
print v(xbgr.mr_n92433824)
print v(xbgr.mr_n92434512)
print v(xbgr.mr_n92435200)
print v(xbgr.mr_n92435888)
print v(xbgr.mr_n92436576)
print v(xbgr.mr_n92437264)
print v(xbgr.mr_n92437952)
print v(xbgr.mr_n92438640)
print v(xbgr.mr_n92439328)
print v(xbgr.mr_n92440016)
print v(xbgr.mr_n92440704)
print v(xbgr.mr_n92441392)
print v(xbgr.mr_n92442080)
print v(xbgr.mr_n92442832)
print v(xbgr.mr_n92442944)
print v(xbgr.mr_n92443456)
print v(xbgr.mr_n92443568)
print v(xbgr.mr_n92444080)
print v(xbgr.mr_n92444192)
print v(xbgr.mr_n92444704)
print v(xbgr.mr_n92444816)
print v(xbgr.mr_n92445488)
print v(xbgr.mr_n92445600)
print v(xbgr.mr_n92447520)
print v(xbgr.mr_n92447632)
print v(xbgr.mr_n92448464)
print v(xbgr.mr_n92448576)
print v(xbgr.mr_n92449408)
print v(xbgr.mr_n92449520)
print v(xbgr.mr_n92450352)
print v(xbgr.mr_n92450464)
print v(xbgr.mr_n92451296)
print v(xbgr.mr_n92451408)
print v(xbgr.mr_n92452240)
print v(xbgr.mr_n92452352)
print v(xbgr.mr_n92453440)
print v(xbgr.mr_n92453552)
print v(xbgr.mr_n92454704)
print v(xbgr.mr_n92454816)
print v(xbgr.mr_n92455968)
print v(xbgr.mr_n92456080)
print v(xbgr.mr_n92457232)
print v(xbgr.mr_n92457344)
print v(xbgr.mr_n92461872)
print v(xbgr.mr_n92466608)
print v(xbgr.mr_n92475328)
print v(xbgr.mr_n92475952)
print v(xbgr.mr_n92476144)
print v(xbgr.mr_n92476336)
print v(xbgr.mr_n92476528)
print v(xbgr.mr_n92478848)
print v(xbgr.mr_n92479120)
print v(xbgr.mr_n92479312)
print v(xbgr.mr_n92479824)
print v(xbgr.mr_n92479936)
print v(xbgr.mr_n92480048)
print v(xbgr.mr_n92480160)
print v(xbgr.mr_n92480352)
print v(xbgr.mr_n92480544)
print v(xbgr.mr_n92480736)
print v(xbgr.mr_n92484304)
print v(xbgr.mr_n92491360)
print v(xbgr.mr_n92503856)
print v(xbgr.mr_n92505472)
print v(xbgr.mr_n92507152)
print v(xbgr.mr_n92509408)
print v(xbgr.mr_n92511664)
print v(xbgr.mr_n92513920)
print v(xbgr.mr_n92516176)
print v(xbgr.mr_n92534160)
print v(xbgr.mr_n92537472)
print v(xbgr.mr_n92538048)
print v(xbgr.mr_n92538736)
print v(xbgr.mr_n92539168)
print v(xbgr.mr_n92540000)
print v(xbgr.mr_n92540576)
print v(xbgr.mr_n92541264)
print v(xbgr.mr_n92541696)
print v(xbgr.mr_n92542528)
print v(xbgr.mr_n92543104)
print v(xbgr.mr_n92543792)
print v(xbgr.mr_n92544368)
print v(xbgr.mr_n92545056)
print v(xbgr.mr_n92545488)
print v(xbgr.mr_n92546320)
print v(xbgr.mr_n92548688)
print v(xbgr.mr_n92550656)
print v(xbgr.mr_n92554176)
print v(xbgr.mr_n92557072)
print v(xbgr.mr_n92558528)
print v(xbgr.mr_n92564656)
print v(xbgr.mr_n92564912)
print v(xbgr.mr_n92569264)
print v(xbgr.mr_n92573280)
print v(xbgr.mr_n92573664)
print v(xbgr.mr_n92578496)
print v(xbgr.mr_n92578704)
print v(xbgr.mr_n92580176)
print v(xbgr.mr_n92580496)
print v(xbgr.mr_n92581232)
print v(xbgr.mr_n92581968)
print v(xbgr.mr_n92582080)
print v(xbgr.mr_n92582192)
print v(xbgr.mr_n92582304)
print v(xbgr.mr_n92582416)
print v(xbgr.mr_n92582528)
print v(xbgr.mr_n92582640)
print v(xbgr.mr_n92582752)
print v(xbgr.mr_n92582864)
print v(xbgr.mr_n92583216)
print v(xbgr.mr_n92583328)
print v(xbgr.mr_n92583664)
print v(xbgr.mr_n92584064)
print v(xbgr.mr_n92584256)
print v(xbgr.mr_n92584448)
print v(xbgr.mr_n92586848)
print v(xbgr.mr_n92587120)
print v(xbgr.mr_n92587520)
print v(xbgr.mr_n92587920)
print v(xbgr.mr_n92588256)
print v(xbgr.mr_n92588448)
print v(xbgr.mr_n92589344)
print v(xbgr.mr_n92589680)
print v(xbgr.mr_n92592384)
print v(xbgr.mr_n92592496)
print v(xbgr.mr_n92593008)
print v(xbgr.mr_n92593120)
print v(xbgr.mr_n92593632)
print v(xbgr.mr_n92593744)
print v(xbgr.mr_n92594256)
print v(xbgr.mr_n92594368)
print v(xbgr.mr_n92594880)
print v(xbgr.mr_n92594992)
print v(xbgr.mr_n92595504)
print v(xbgr.mr_n92595616)
print v(xbgr.mr_n92596128)
print v(xbgr.mr_n92596240)
print v(xbgr.mr_n92596752)
print v(xbgr.mr_n92596864)
print v(xbgr.mr_n92600816)
print v(xbgr.mr_n92607664)
print v(xbgr.mr_n92610416)
print v(xbgr.mr_n92611104)
print v(xbgr.mr_n92611792)
print v(xbgr.mr_n92612480)
print v(xbgr.mr_n92613168)
print v(xbgr.mr_n92613856)
print v(xbgr.mr_n92614544)
print v(xbgr.mr_n92615232)
print v(xbgr.mr_n92615920)
print v(xbgr.mr_n92617536)
print v(xbgr.mr_n92618896)
print v(xbgr.mr_n92619840)
print v(xbgr.mr_n92620784)
print v(xbgr.mr_n92621728)
print v(xbgr.mr_n92622672)
print v(xbgr.mr_n92623616)
print v(xbgr.mr_n92624560)
print v(xbgr.mr_n92625504)
print v(xbgr.mr_n92633280)
print v(xbgr.mr_n92634736)
print v(xbgr.mr_n92635120)
print v(xbgr.mr_n92635584)
print v(xbgr.mr_n92637040)
print v(xbgr.mr_n92637424)
print v(xbgr.mr_n92637808)
print v(xbgr.mr_n92638960)
print v(xbgr.mr_n92639344)
print v(xbgr.mr_n92639728)
print v(xbgr.mr_n92640112)
print v(xbgr.mr_n92641344)
print v(xbgr.mr_n92642032)
print v(xbgr.mr_n92642416)
print v(xbgr.mr_n92642800)
print v(xbgr.mr_n92643184)
print v(xbgr.mr_n92643856)
print v(xbgr.mr_n92645568)
print v(xbgr.mr_n92646032)
print v(xbgr.mr_n92646832)
print v(xbgr.mr_n92647328)
print v(xbgr.mr_n92647600)
print v(xbgr.mr_n92650736)
print v(xbgr.mr_n92655120)
print v(xbgr.mr_n92655616)
print v(xbgr.mr_n92656880)
print v(xbgr.mr_n92657376)
print v(xbgr.mr_n92657488)
print v(xbgr.mr_n92657776)
print v(xbgr.mr_n92658592)
print v(xbgr.mr_n92658704)
print v(xbgr.mr_n92667360)
print v(xbgr.mr_n92668512)
print v(xbgr.mr_n92670752)
print v(xbgr.mr_n92672112)
print v(xbgr.mr_n92675584)
print v(xbgr.mr_n92675776)
print v(xbgr.mr_n92677280)
print v(xbgr.mr_n92680544)
print v(xbgr.mr_n92681808)
print v(xbgr.mr_n92682320)
print v(xbgr.mr_n92682432)
print v(xbgr.mr_n92682864)
print v(xbgr.mr_n92683376)
print v(xbgr.mr_n92683488)
print v(xbgr.mr_n92683920)
print v(xbgr.mr_n92684432)
print v(xbgr.mr_n92684544)
print v(xbgr.mr_n92684976)
print v(xbgr.mr_n92685968)
print v(xbgr.mr_n92687296)
print v(xbgr.mr_n92689840)
print v(xbgr.mr_n92691856)
print v(xbgr.mr_n92693072)
print v(xbgr.mr_n92693296)
print v(xbgr.mr_n92693808)
print v(xbgr.mr_n92694400)
print v(xbgr.mr_n92694864)
print v(xbgr.mr_n92695056)
print v(xbgr.mr_n92696048)
print v(xbgr.mr_n92696384)
print v(xbgr.mr_n92696592)
print v(xbgr.mr_n92697872)
print v(xbgr.mr_n92699904)
print v(xbgr.mr_n92702816)
print v(xbgr.mr_n92703040)
print v(xbgr.mr_n92703440)
print v(xbgr.mr_n92704576)
print v(xbgr.mr_n92706544)
print v(xbgr.mr_n92706848)
print v(xbgr.mr_n92711056)
print v(xbgr.mr_n92711648)
print v(xbgr.mr_n92711856)
print v(xbgr.mr_n92716240)
print v(xbgr.mr_n92719616)
print v(xbgr.mr_n92722096)
print v(xbgr.mr_n92722608)
print v(xbgr.mr_n92723120)
print v(xbgr.mr_n92723632)
print v(xbgr.mr_n92724624)
print v(xbgr.mr_n92725136)
print v(xbgr.mr_n92726064)
print v(xbgr.mr_n92726656)
print v(xbgr.mr_n92727184)
print v(xbgr.mr_n92728016)
print v(xbgr.mr_n92729520)
print v(xbgr.mr_n92730000)
print v(xbgr.mr_n92730544)
print v(xbgr.mr_n92736064)
print v(xbgr.mr_n92736528)
print v(xbgr.mr_n92736720)
print v(xbgr.mr_n92737664)
print v(xbgr.mr_n92738000)
print v(xbgr.mr_n92738192)
print v(xbgr.mr_n92738640)
print v(xbgr.mr_n92738752)
print v(xbgr.mr_n92738864)
print v(xbgr.mr_n92739808)
print v(xbgr.mr_n92741248)
print v(xbgr.mr_n92741584)
print v(xbgr.mr_n92741776)
print v(xbgr.mr_n92742240)
print v(xbgr.mr_n92742704)
print v(xbgr.mr_n92743376)
print v(xbgr.mr_n92743840)
print v(xbgr.mr_n92744928)
print v(xbgr.mr_n92745488)
print v(xbgr.mr_n92745600)
print v(xbgr.mr_n92751184)
print v(xbgr.mr_n92751584)
print v(xbgr.mr_n92751776)
print v(xbgr.mr_n92752240)
print v(xbgr.mr_n92752432)
print v(xbgr.mr_n92752624)
print v(xbgr.mr_n92753568)
print v(xbgr.mr_n92753904)
print v(xbgr.mr_n92754096)
print v(xbgr.mr_n92754560)
print v(xbgr.mr_n92755024)
print v(xbgr.mr_n92755488)
print v(xbgr.mr_n92756496)
print v(xbgr.mr_n92756832)
print v(xbgr.mr_n92757520)
print v(xbgr.mr_n92758528)
print v(xbgr.mr_n92763088)
print v(xbgr.mr_n92766800)
print v(xbgr.mr_n92766912)
print v(xbgr.mr_n92767344)
print v(xbgr.mr_n92767856)
print v(xbgr.mr_n92767968)
print v(xbgr.mr_n92768400)
print v(xbgr.mr_n92768912)
print v(xbgr.mr_n92769024)
print v(xbgr.mr_n92769456)
print v(xbgr.mr_n92769968)
print v(xbgr.mr_n92770080)
print v(xbgr.mr_n92770512)
print v(xbgr.mr_n92771024)
print v(xbgr.mr_n92771136)
print v(xbgr.mr_n92771568)
print v(xbgr.mr_n92772080)
print v(xbgr.mr_n92772192)
print v(xbgr.mr_n92772624)
print v(xbgr.mr_n92773136)
print v(xbgr.mr_n92773248)
print v(xbgr.mr_n92773680)
print v(xbgr.mr_n92774192)
print v(xbgr.mr_n92774304)
print v(xbgr.mr_n92774736)
print v(xbgr.mr_n92775248)
print v(xbgr.mr_n92775360)
print v(xbgr.mr_n92775792)
print v(xbgr.mr_n92776560)
print v(xbgr.mr_n92776672)
print v(xbgr.mr_n92777552)
print v(xbgr.mr_n92778240)
print v(xbgr.mr_n92778928)
print v(xbgr.mr_n92779616)
print v(xbgr.mr_n92780304)
print v(xbgr.mr_n92780992)
print v(xbgr.mr_n92781680)
print v(xbgr.mr_n92782368)
print v(xbgr.mr_n92783056)
print v(xbgr.mr_n92783744)
print v(xbgr.mr_n92784432)
print v(xbgr.mr_n92785120)
print v(xbgr.mr_n92785808)
print v(xbgr.mr_n92786496)
print v(xbgr.mr_n92787184)
print v(xbgr.mr_n92787872)
print v(xbgr.mr_n92788560)
print v(xbgr.mr_n92789248)
print v(xbgr.mr_n92789936)
print v(xbgr.mr_n92790624)
print v(xbgr.mr_n92791728)
print v(xbgr.mr_n92792960)
print v(xbgr.mr_n92793904)
print v(xbgr.mr_n92794848)
print v(xbgr.mr_n92795792)
print v(xbgr.mr_n92796736)
print v(xbgr.mr_n92797680)
print v(xbgr.mr_n92798624)
print v(xbgr.mr_n92799568)
print v(xbgr.mr_n92800512)
print v(xbgr.mr_n92801456)
print v(xbgr.mr_n92802400)
print v(xbgr.mr_n92803344)
print v(xbgr.mr_n92804288)
print v(xbgr.mr_n92805232)
print v(xbgr.mr_n92806176)
print v(xbgr.mr_n92807120)
print v(xbgr.mr_n92808064)
print v(xbgr.mr_n92809008)
print v(xbgr.mr_n92809952)
print v(xbgr.mr_n92810896)
print v(xbgr.mr_n92811840)
print v(xbgr.mr_n92812784)
print v(xbgr.mr_n92813728)
print v(xbgr.mr_n92814672)
print v(xbgr.mr_n92815616)
print v(xbgr.mr_n92820416)
print v(xbgr.mr_n92820672)
print v(xbgr.mr_n92820928)
print v(xbgr.mr_n92821184)
print v(xbgr.mr_n92821440)
print v(xbgr.mr_n92821696)
print v(xbgr.mr_n92822016)
print v(xbgr.mr_n92824496)
print v(xbgr.mr_n92824944)
print v(xbgr.mr_n92825136)
print v(xbgr.mr_n92825328)
print v(xbgr.mr_n92825520)
print v(xbgr.mr_n92825712)
print v(xbgr.mr_n92825904)
print v(xbgr.mr_n92826160)
print v(xbgr.mr_n92831168)
print v(xbgr.mr_n92842640)
print v(xbgr.mr_n92846128)
print v(xbgr.mr_n92851664)
print v(xbgr.mr_n92852688)
print v(xbgr.mr_n92853456)
print v(xbgr.mr_n92865968)
print v(xbgr.mr_n92866144)
print v(xbgr.mr_n92866448)
print v(xbgr.mr_n92866944)
print v(xbgr.mr_n92867328)
print v(xbgr.mr_n92868240)
print v(xbgr.mr_n92870352)
print v(xbgr.mr_n92871248)
print v(xbgr.mr_n92871504)
print v(xbgr.mr_n92873424)
print v(xbgr.mr_n92874064)
print v(xbgr.mr_n92875344)
print v(xbgr.mr_n92875744)
print v(xbgr.mr_n92876944)
print v(xbgr.mr_n92878064)
print v(xbgr.mr_n92878320)
print v(xbgr.mr_n92879216)
print v(xbgr.mr_n92880000)
print v(xbgr.mr_n92880384)
print v(xbgr.mr_n92882064)
print v(xbgr.mr_n92882208)
print v(xbgr.mr_n93164976)
print v(xbgr.mr_n93165088)
print v(xbgr.mr_n93165280)
print v(xbgr.mr_n93165472)
print v(xbgr.mr_n93208640)
print v(xbgr.mr_n93226896)
print v(xbgr.mr_n93271632)
print v(xbgr.mr_n93271904)
print v(xbgr.mr_n93272096)
print v(xbgr.mr_n93272288)
print v(xbgr.mr_n93272720)
print v(xbgr.mr_n93273072)
print v(xbgr.mr_n93273184)
print v(xbgr.mr_n93299568)
print v(xbgr.mr_n93299760)
print v(xbgr.mr_n93299952)
print v(xbgr.mr_n93300144)
print v(xbgr.mr_n93300496)
print v(xbgr.mr_n93300928)
print v(xbgr.mr_n93301040)
print v(xbgr.mr_n93301152)
print v(xbgr.mr_n93314432)
print v(xbgr.mr_n93316960)
print v(xbgr.mr_n93317360)
print v(xbgr.mr_n93382192)
print v(xbgr.mr_n93387664)
print v(xbgr.mr_n93420032)
print v(xbgr.mr_n93420144)
print v(xbgr.mr_n93420608)
print v(xbgr.mr_n93489024)
print v(xbgr.mr_n93489184)
print v(xbgr.mr_n93543440)
print v(xbgr.mr_n93551296)
print v(xbgr.mr_n93579280)
print v(xbgr.mr_n93590112)
print v(xbgr.mr_n93596464)
print v(xbgr.mr_n93637696)
print v(xbgr.mr_n93646608)
print v(xbgr.mr_n93648976)
print v(xbgr.mr_n93663824)
print v(xbgr.mr_n93679024)
print v(xbgr.mr_n93679472)
print v(xbgr.mr_n93684688)
print v(xbgr.mr_n93704192)
print v(xbgr.mr_n93711696)
print v(xbgr.mr_n93738208)
print v(xbgr.mr_n93739600)
print v(xbgr.mr_n93741584)
print v(xbgr.mr_n93746016)
print v(xbgr.mr_n93762640)
print v(xbgr.mr_n93798944)
print v(xbgr.mr_n93799280)
print v(xbgr.mr_n93799648)
print v(xbgr.mr_n93799984)
print v(xbgr.mr_n93800544)
print v(xbgr.mr_n93800928)
print v(xbgr.mr_n93801120)
print v(xbgr.mr_n93830352)
print v(xbgr.mr_n93830672)
print v(xbgr.mr_n93831280)
print v(xbgr.mr_n93831632)
print v(xbgr.mr_n93835296)
print v(xbgr.mr_n93858432)
print v(xbgr.mr_n93869648)
print v(xbgr.mr_n93869840)
print v(xbgr.mr_n93879776)
print v(xbgr.mr_n93880112)
print v(xbgr.mr_n93921008)
print v(xbgr.mr_n93952064)
print v(xbgr.mr_n93972496)
print v(xbgr.n1)
print v(xbgr.n_10)
print v(xbgr.n_11)
print v(xbgr.n_12)
print v(xbgr.n_13)
print v(xbgr.n_14)
print v(xbgr.n_15)
print v(xbgr.n_16)
print v(xbgr.n_17)
print v(xbgr.n_18)
print v(xbgr.n_19)
print v(xbgr.n_2)
print v(xbgr.n_21)
print v(xbgr.n_22)
print v(xbgr.n_23)
print v(xbgr.n_24)
print v(xbgr.n_25)
print v(xbgr.n_26)
print v(xbgr.n_27)
print v(xbgr.n_3)
print v(xbgr.n_30)
print v(xbgr.n_31)
print v(xbgr.n_33)
print v(xbgr.n_34)
print v(xbgr.n_36)
print v(xbgr.n_37)
print v(xbgr.n_4)
print v(xbgr.n_5)
print v(xbgr.n_6)
print v(xbgr.n_7)
print v(xbgr.n_8)
print v(xbgr.n_9)
print v(pbias)
print v(pcasc)
print v(r4)
print v(xbgr.r4n)
print v(xbgr.vb2)
print v(vbe)
print v(xbgr.vbe3)
print v(xbgr.vd1)
print v(xbgr.vd2)
print v(vdd)
print v(vref)
print v(vdd)-v(vdd)
echo METALLIC_ALL_NODE_VOLTAGES_END
quit
.endc
.end
