* G1_BGR standalone capacitance-PEX qualification
.lib /foss/pdks/ihp-sg13g2/libs.tech/ngspice/models/cornerHBT.lib hbt_typ
.lib /foss/pdks/ihp-sg13g2/libs.tech/ngspice/models/cornerMOShv.lib mos_tt
.lib /foss/pdks/ihp-sg13g2/libs.tech/ngspice/models/cornerRES.lib res_typ
.include conditional_metal.spice
.option seed=44001 gmin=1e-15 abstol=1e-14 reltol=1e-5 vntol=1e-7
.global sub!
Vsub sub! 0 0
Vdd vdd 0 3.3
Vr4 r4 0 0
Xbgr vdd 0 r4 vref iptat pbias pcasc vbe dvbe g1_bgr
Vload iptat 0 1
Cload vref 0 1e-12
.control
set num_threads=1
set numdgt=15
set wr_singlescale
set wr_vecnames
op
echo RAW_CURRENT_LEDGER_BEGIN
print @n.xbgr.xr1.nr1[ibody]
print @n.xbgr.xr2.nr1[ibody]
print @n.xbgr.xr3.nr1[ibody]
print @n.xbgr.xr4.nr1[ibody]
print @n.xbgr.xr5.nr1[ibody]
print @n.xbgr.xr6.nr1[ibody]
print @n.xbgr.xr7.nr1[ibody]
print @n.xbgr.xr8.nr1[ibody]
print @n.xbgr.xr9.nr1[ibody]
print @n.xbgr.xr10.nr1[ibody]
print @n.xbgr.xr11.nr1[ibody]
print @n.xbgr.xr12.nr1[ibody]
print @n.xbgr.xr13.nr1[ibody]
print @n.xbgr.xr14.nr1[ibody]
print @n.xbgr.xr15.nr1[ibody]
print @n.xbgr.xr16.nr1[ibody]
print @n.xbgr.xr17.nr1[ibody]
print @n.xbgr.xr18.nr1[ibody]
print @n.xbgr.xr19.nr1[ibody]
print @n.xbgr.xr20.nr1[ibody]
print @n.xbgr.xr21.nr1[ibody]
print @n.xbgr.xr22.nr1[ibody]
print @n.xbgr.xr23.nr1[ibody]
print @n.xbgr.xr24.nr1[ibody]
print @n.xbgr.xr25.nr1[ibody]
print @n.xbgr.xr26.nr1[ibody]
print @n.xbgr.xm27.nsg13_hv_pmos[ide]
print @n.xbgr.xm27.nsg13_hv_pmos[ige]
print @n.xbgr.xm27.nsg13_hv_pmos[ise]
print @n.xbgr.xm27.nsg13_hv_pmos[ibe]
print @n.xbgr.xm27.nsg13_hv_pmos[ctype]
print @n.xbgr.xm28.nsg13_hv_pmos[ide]
print @n.xbgr.xm28.nsg13_hv_pmos[ige]
print @n.xbgr.xm28.nsg13_hv_pmos[ise]
print @n.xbgr.xm28.nsg13_hv_pmos[ibe]
print @n.xbgr.xm28.nsg13_hv_pmos[ctype]
print @n.xbgr.xm29.nsg13_hv_nmos[ide]
print @n.xbgr.xm29.nsg13_hv_nmos[ige]
print @n.xbgr.xm29.nsg13_hv_nmos[ise]
print @n.xbgr.xm29.nsg13_hv_nmos[ibe]
print @n.xbgr.xm29.nsg13_hv_nmos[ctype]
print @n.xbgr.xm30.nsg13_hv_nmos[ide]
print @n.xbgr.xm30.nsg13_hv_nmos[ige]
print @n.xbgr.xm30.nsg13_hv_nmos[ise]
print @n.xbgr.xm30.nsg13_hv_nmos[ibe]
print @n.xbgr.xm30.nsg13_hv_nmos[ctype]
print @n.xbgr.xm31.nsg13_hv_nmos[ide]
print @n.xbgr.xm31.nsg13_hv_nmos[ige]
print @n.xbgr.xm31.nsg13_hv_nmos[ise]
print @n.xbgr.xm31.nsg13_hv_nmos[ibe]
print @n.xbgr.xm31.nsg13_hv_nmos[ctype]
print @n.xbgr.xm32.nsg13_hv_nmos[ide]
print @n.xbgr.xm32.nsg13_hv_nmos[ige]
print @n.xbgr.xm32.nsg13_hv_nmos[ise]
print @n.xbgr.xm32.nsg13_hv_nmos[ibe]
print @n.xbgr.xm32.nsg13_hv_nmos[ctype]
print @n.xbgr.xm33.nsg13_hv_nmos[ide]
print @n.xbgr.xm33.nsg13_hv_nmos[ige]
print @n.xbgr.xm33.nsg13_hv_nmos[ise]
print @n.xbgr.xm33.nsg13_hv_nmos[ibe]
print @n.xbgr.xm33.nsg13_hv_nmos[ctype]
print @n.xbgr.xm34.nsg13_hv_nmos[ide]
print @n.xbgr.xm34.nsg13_hv_nmos[ige]
print @n.xbgr.xm34.nsg13_hv_nmos[ise]
print @n.xbgr.xm34.nsg13_hv_nmos[ibe]
print @n.xbgr.xm34.nsg13_hv_nmos[ctype]
print @n.xbgr.xm35.nsg13_hv_nmos[ide]
print @n.xbgr.xm35.nsg13_hv_nmos[ige]
print @n.xbgr.xm35.nsg13_hv_nmos[ise]
print @n.xbgr.xm35.nsg13_hv_nmos[ibe]
print @n.xbgr.xm35.nsg13_hv_nmos[ctype]
print @n.xbgr.xm36.nsg13_hv_nmos[ide]
print @n.xbgr.xm36.nsg13_hv_nmos[ige]
print @n.xbgr.xm36.nsg13_hv_nmos[ise]
print @n.xbgr.xm36.nsg13_hv_nmos[ibe]
print @n.xbgr.xm36.nsg13_hv_nmos[ctype]
print @n.xbgr.xm37.nsg13_hv_nmos[ide]
print @n.xbgr.xm37.nsg13_hv_nmos[ige]
print @n.xbgr.xm37.nsg13_hv_nmos[ise]
print @n.xbgr.xm37.nsg13_hv_nmos[ibe]
print @n.xbgr.xm37.nsg13_hv_nmos[ctype]
print @n.xbgr.xm38.nsg13_hv_pmos[ide]
print @n.xbgr.xm38.nsg13_hv_pmos[ige]
print @n.xbgr.xm38.nsg13_hv_pmos[ise]
print @n.xbgr.xm38.nsg13_hv_pmos[ibe]
print @n.xbgr.xm38.nsg13_hv_pmos[ctype]
print @n.xbgr.xm39.nsg13_hv_pmos[ide]
print @n.xbgr.xm39.nsg13_hv_pmos[ige]
print @n.xbgr.xm39.nsg13_hv_pmos[ise]
print @n.xbgr.xm39.nsg13_hv_pmos[ibe]
print @n.xbgr.xm39.nsg13_hv_pmos[ctype]
print @n.xbgr.xm40.nsg13_hv_pmos[ide]
print @n.xbgr.xm40.nsg13_hv_pmos[ige]
print @n.xbgr.xm40.nsg13_hv_pmos[ise]
print @n.xbgr.xm40.nsg13_hv_pmos[ibe]
print @n.xbgr.xm40.nsg13_hv_pmos[ctype]
print @n.xbgr.xm41.nsg13_hv_pmos[ide]
print @n.xbgr.xm41.nsg13_hv_pmos[ige]
print @n.xbgr.xm41.nsg13_hv_pmos[ise]
print @n.xbgr.xm41.nsg13_hv_pmos[ibe]
print @n.xbgr.xm41.nsg13_hv_pmos[ctype]
print @n.xbgr.xm42.nsg13_hv_pmos[ide]
print @n.xbgr.xm42.nsg13_hv_pmos[ige]
print @n.xbgr.xm42.nsg13_hv_pmos[ise]
print @n.xbgr.xm42.nsg13_hv_pmos[ibe]
print @n.xbgr.xm42.nsg13_hv_pmos[ctype]
print @n.xbgr.xm43.nsg13_hv_pmos[ide]
print @n.xbgr.xm43.nsg13_hv_pmos[ige]
print @n.xbgr.xm43.nsg13_hv_pmos[ise]
print @n.xbgr.xm43.nsg13_hv_pmos[ibe]
print @n.xbgr.xm43.nsg13_hv_pmos[ctype]
print @n.xbgr.xm44.nsg13_hv_pmos[ide]
print @n.xbgr.xm44.nsg13_hv_pmos[ige]
print @n.xbgr.xm44.nsg13_hv_pmos[ise]
print @n.xbgr.xm44.nsg13_hv_pmos[ibe]
print @n.xbgr.xm44.nsg13_hv_pmos[ctype]
print @n.xbgr.xm45.nsg13_hv_pmos[ide]
print @n.xbgr.xm45.nsg13_hv_pmos[ige]
print @n.xbgr.xm45.nsg13_hv_pmos[ise]
print @n.xbgr.xm45.nsg13_hv_pmos[ibe]
print @n.xbgr.xm45.nsg13_hv_pmos[ctype]
print @n.xbgr.xm46.nsg13_hv_pmos[ide]
print @n.xbgr.xm46.nsg13_hv_pmos[ige]
print @n.xbgr.xm46.nsg13_hv_pmos[ise]
print @n.xbgr.xm46.nsg13_hv_pmos[ibe]
print @n.xbgr.xm46.nsg13_hv_pmos[ctype]
print @n.xbgr.xm47.nsg13_hv_pmos[ide]
print @n.xbgr.xm47.nsg13_hv_pmos[ige]
print @n.xbgr.xm47.nsg13_hv_pmos[ise]
print @n.xbgr.xm47.nsg13_hv_pmos[ibe]
print @n.xbgr.xm47.nsg13_hv_pmos[ctype]
print @n.xbgr.xm48.nsg13_hv_pmos[ide]
print @n.xbgr.xm48.nsg13_hv_pmos[ige]
print @n.xbgr.xm48.nsg13_hv_pmos[ise]
print @n.xbgr.xm48.nsg13_hv_pmos[ibe]
print @n.xbgr.xm48.nsg13_hv_pmos[ctype]
print @n.xbgr.xm49.nsg13_hv_pmos[ide]
print @n.xbgr.xm49.nsg13_hv_pmos[ige]
print @n.xbgr.xm49.nsg13_hv_pmos[ise]
print @n.xbgr.xm49.nsg13_hv_pmos[ibe]
print @n.xbgr.xm49.nsg13_hv_pmos[ctype]
print @n.xbgr.xm50.nsg13_hv_pmos[ide]
print @n.xbgr.xm50.nsg13_hv_pmos[ige]
print @n.xbgr.xm50.nsg13_hv_pmos[ise]
print @n.xbgr.xm50.nsg13_hv_pmos[ibe]
print @n.xbgr.xm50.nsg13_hv_pmos[ctype]
print @n.xbgr.xm51.nsg13_hv_pmos[ide]
print @n.xbgr.xm51.nsg13_hv_pmos[ige]
print @n.xbgr.xm51.nsg13_hv_pmos[ise]
print @n.xbgr.xm51.nsg13_hv_pmos[ibe]
print @n.xbgr.xm51.nsg13_hv_pmos[ctype]
print @n.xbgr.xm52.nsg13_hv_pmos[ide]
print @n.xbgr.xm52.nsg13_hv_pmos[ige]
print @n.xbgr.xm52.nsg13_hv_pmos[ise]
print @n.xbgr.xm52.nsg13_hv_pmos[ibe]
print @n.xbgr.xm52.nsg13_hv_pmos[ctype]
print @n.xbgr.xm53.nsg13_hv_pmos[ide]
print @n.xbgr.xm53.nsg13_hv_pmos[ige]
print @n.xbgr.xm53.nsg13_hv_pmos[ise]
print @n.xbgr.xm53.nsg13_hv_pmos[ibe]
print @n.xbgr.xm53.nsg13_hv_pmos[ctype]
print @n.xbgr.xm54.nsg13_hv_pmos[ide]
print @n.xbgr.xm54.nsg13_hv_pmos[ige]
print @n.xbgr.xm54.nsg13_hv_pmos[ise]
print @n.xbgr.xm54.nsg13_hv_pmos[ibe]
print @n.xbgr.xm54.nsg13_hv_pmos[ctype]
print @q.xbgr.xq55.qnpn13g2[ic]
print @q.xbgr.xq55.qnpn13g2[ib]
print @q.xbgr.xq55.qnpn13g2[ie]
print @q.xbgr.xq55.qnpn13g2[is]
print @r.xbgr.xq55.rsub[i]
print @c.xbgr.xq55.csub[i]
print @q.xbgr.xq56.qnpn13g2[ic]
print @q.xbgr.xq56.qnpn13g2[ib]
print @q.xbgr.xq56.qnpn13g2[ie]
print @q.xbgr.xq56.qnpn13g2[is]
print @r.xbgr.xq56.rsub[i]
print @c.xbgr.xq56.csub[i]
print @q.xbgr.xq57.qnpn13g2[ic]
print @q.xbgr.xq57.qnpn13g2[ib]
print @q.xbgr.xq57.qnpn13g2[ie]
print @q.xbgr.xq57.qnpn13g2[is]
print @r.xbgr.xq57.rsub[i]
print @c.xbgr.xq57.csub[i]
print @q.xbgr.xq58.qnpn13g2[ic]
print @q.xbgr.xq58.qnpn13g2[ib]
print @q.xbgr.xq58.qnpn13g2[ie]
print @q.xbgr.xq58.qnpn13g2[is]
print @r.xbgr.xq58.rsub[i]
print @c.xbgr.xq58.csub[i]
print @q.xbgr.xq59.qnpn13g2[ic]
print @q.xbgr.xq59.qnpn13g2[ib]
print @q.xbgr.xq59.qnpn13g2[ie]
print @q.xbgr.xq59.qnpn13g2[is]
print @r.xbgr.xq59.rsub[i]
print @c.xbgr.xq59.csub[i]
print @q.xbgr.xq60.qnpn13g2[ic]
print @q.xbgr.xq60.qnpn13g2[ib]
print @q.xbgr.xq60.qnpn13g2[ie]
print @q.xbgr.xq60.qnpn13g2[is]
print @r.xbgr.xq60.rsub[i]
print @c.xbgr.xq60.csub[i]
print @q.xbgr.xq61.qnpn13g2[ic]
print @q.xbgr.xq61.qnpn13g2[ib]
print @q.xbgr.xq61.qnpn13g2[ie]
print @q.xbgr.xq61.qnpn13g2[is]
print @r.xbgr.xq61.rsub[i]
print @c.xbgr.xq61.csub[i]
print @q.xbgr.xq62.qnpn13g2[ic]
print @q.xbgr.xq62.qnpn13g2[ib]
print @q.xbgr.xq62.qnpn13g2[ie]
print @q.xbgr.xq62.qnpn13g2[is]
print @r.xbgr.xq62.rsub[i]
print @c.xbgr.xq62.csub[i]
print @q.xbgr.xq63.qnpn13g2[ic]
print @q.xbgr.xq63.qnpn13g2[ib]
print @q.xbgr.xq63.qnpn13g2[ie]
print @q.xbgr.xq63.qnpn13g2[is]
print @r.xbgr.xq63.rsub[i]
print @c.xbgr.xq63.csub[i]
print @q.xbgr.xq64.qnpn13g2[ic]
print @q.xbgr.xq64.qnpn13g2[ib]
print @q.xbgr.xq64.qnpn13g2[ie]
print @q.xbgr.xq64.qnpn13g2[is]
print @r.xbgr.xq64.rsub[i]
print @c.xbgr.xq64.csub[i]
print @q.xbgr.xq65.qnpn13g2[ic]
print @q.xbgr.xq65.qnpn13g2[ib]
print @q.xbgr.xq65.qnpn13g2[ie]
print @q.xbgr.xq65.qnpn13g2[is]
print @r.xbgr.xq65.rsub[i]
print @c.xbgr.xq65.csub[i]
print @q.xbgr.xq66.qnpn13g2[ic]
print @q.xbgr.xq66.qnpn13g2[ib]
print @q.xbgr.xq66.qnpn13g2[ie]
print @q.xbgr.xq66.qnpn13g2[is]
print @r.xbgr.xq66.rsub[i]
print @c.xbgr.xq66.csub[i]
print @q.xbgr.xq67.qnpn13g2[ic]
print @q.xbgr.xq67.qnpn13g2[ib]
print @q.xbgr.xq67.qnpn13g2[ie]
print @q.xbgr.xq67.qnpn13g2[is]
print @r.xbgr.xq67.rsub[i]
print @c.xbgr.xq67.csub[i]
print @q.xbgr.xq68.qnpn13g2[ic]
print @q.xbgr.xq68.qnpn13g2[ib]
print @q.xbgr.xq68.qnpn13g2[ie]
print @q.xbgr.xq68.qnpn13g2[is]
print @r.xbgr.xq68.rsub[i]
print @c.xbgr.xq68.csub[i]
print @q.xbgr.xq69.qnpn13g2[ic]
print @q.xbgr.xq69.qnpn13g2[ib]
print @q.xbgr.xq69.qnpn13g2[ie]
print @q.xbgr.xq69.qnpn13g2[is]
print @r.xbgr.xq69.rsub[i]
print @c.xbgr.xq69.csub[i]
print @q.xbgr.xq70.qnpn13g2[ic]
print @q.xbgr.xq70.qnpn13g2[ib]
print @q.xbgr.xq70.qnpn13g2[ie]
print @q.xbgr.xq70.qnpn13g2[is]
print @r.xbgr.xq70.rsub[i]
print @c.xbgr.xq70.csub[i]
print @q.xbgr.xq71.qnpn13g2[ic]
print @q.xbgr.xq71.qnpn13g2[ib]
print @q.xbgr.xq71.qnpn13g2[ie]
print @q.xbgr.xq71.qnpn13g2[is]
print @r.xbgr.xq71.rsub[i]
print @c.xbgr.xq71.csub[i]
print @q.xbgr.xq72.qnpn13g2[ic]
print @q.xbgr.xq72.qnpn13g2[ib]
print @q.xbgr.xq72.qnpn13g2[ie]
print @q.xbgr.xq72.qnpn13g2[is]
print @r.xbgr.xq72.rsub[i]
print @c.xbgr.xq72.csub[i]
print @q.xbgr.xq73.qnpn13g2[ic]
print @q.xbgr.xq73.qnpn13g2[ib]
print @q.xbgr.xq73.qnpn13g2[ie]
print @q.xbgr.xq73.qnpn13g2[is]
print @r.xbgr.xq73.rsub[i]
print @c.xbgr.xq73.csub[i]
print @q.xbgr.xq74.qnpn13g2[ic]
print @q.xbgr.xq74.qnpn13g2[ib]
print @q.xbgr.xq74.qnpn13g2[ie]
print @q.xbgr.xq74.qnpn13g2[is]
print @r.xbgr.xq74.rsub[i]
print @c.xbgr.xq74.csub[i]
print @q.xbgr.xq75.qnpn13g2[ic]
print @q.xbgr.xq75.qnpn13g2[ib]
print @q.xbgr.xq75.qnpn13g2[ie]
print @q.xbgr.xq75.qnpn13g2[is]
print @r.xbgr.xq75.rsub[i]
print @c.xbgr.xq75.csub[i]
print @q.xbgr.xq76.qnpn13g2[ic]
print @q.xbgr.xq76.qnpn13g2[ib]
print @q.xbgr.xq76.qnpn13g2[ie]
print @q.xbgr.xq76.qnpn13g2[is]
print @r.xbgr.xq76.rsub[i]
print @c.xbgr.xq76.csub[i]
print @n.xbgr.xr77.nr1[ibody]
print @n.xbgr.xr78.nr1[ibody]
print @n.xbgr.xr79.nr1[ibody]
print @n.xbgr.xr80.nr1[ibody]
print @n.xbgr.xr81.nr1[ibody]
print @n.xbgr.xr82.nr1[ibody]
print @n.xbgr.xr83.nr1[ibody]
print @n.xbgr.xr84.nr1[ibody]
print @n.xbgr.xr85.nr1[ibody]
print @n.xbgr.xr86.nr1[ibody]
print @n.xbgr.xr16_u2.nr1[ibody]
print @n.xbgr.xr16_u3.nr1[ibody]
print @n.xbgr.xr16_u4.nr1[ibody]
print @n.xbgr.xr16_u5.nr1[ibody]
print @n.xbgr.xr16_u6.nr1[ibody]
print @n.xbgr.xr16_u7.nr1[ibody]
print @n.xbgr.xr16_u8.nr1[ibody]
print @n.xbgr.xr16_u9.nr1[ibody]
print @n.xbgr.xr16_u10.nr1[ibody]
print @n.xbgr.xr16_u11.nr1[ibody]
print @n.xbgr.xr16_u12.nr1[ibody]
print @n.xbgr.xr16_u13.nr1[ibody]
print @n.xbgr.xr16_u14.nr1[ibody]
print @n.xbgr.xr16_u15.nr1[ibody]
print @n.xbgr.xr16_u16.nr1[ibody]
print @n.xbgr.xr16_u17.nr1[ibody]
print @n.xbgr.xr16_u18.nr1[ibody]
print @n.xbgr.xr16_u19.nr1[ibody]
print @n.xbgr.xr16_u20.nr1[ibody]
print @n.xbgr.xr16_u21.nr1[ibody]
print @n.xbgr.xr16_u22.nr1[ibody]
print @n.xbgr.xr16_u23.nr1[ibody]
print @n.xbgr.xr16_u24.nr1[ibody]
print @n.xbgr.xr17_u2.nr1[ibody]
print @n.xbgr.xr17_u3.nr1[ibody]
print @n.xbgr.xr17_u4.nr1[ibody]
print @n.xbgr.xr18_u2.nr1[ibody]
print @n.xbgr.xr18_u3.nr1[ibody]
print @n.xbgr.xr18_u4.nr1[ibody]
print @n.xbgr.xr19_u2.nr1[ibody]
print @n.xbgr.xr19_u3.nr1[ibody]
print @n.xbgr.xr19_u4.nr1[ibody]
print @n.xbgr.xr20_u2.nr1[ibody]
print @n.xbgr.xr20_u3.nr1[ibody]
print @n.xbgr.xr20_u4.nr1[ibody]
print @n.xbgr.xr21_u2.nr1[ibody]
print @n.xbgr.xr21_u3.nr1[ibody]
print @n.xbgr.xr21_u4.nr1[ibody]
print @n.xbgr.xr22_u2.nr1[ibody]
print @n.xbgr.xr22_u3.nr1[ibody]
print @n.xbgr.xr22_u4.nr1[ibody]
print @n.xbgr.xr23_u2.nr1[ibody]
print @n.xbgr.xr23_u3.nr1[ibody]
print @n.xbgr.xr23_u4.nr1[ibody]
print @n.xbgr.xr23_u5.nr1[ibody]
print @n.xbgr.xr23_u6.nr1[ibody]
print @n.xbgr.xr23_u7.nr1[ibody]
print @n.xbgr.xr23_u8.nr1[ibody]
print @n.xbgr.xr23_u9.nr1[ibody]
print @n.xbgr.xr23_u10.nr1[ibody]
print @n.xbgr.xr23_u11.nr1[ibody]
print @n.xbgr.xr23_u12.nr1[ibody]
print @n.xbgr.xr23_u13.nr1[ibody]
print @n.xbgr.xr23_u14.nr1[ibody]
print @n.xbgr.xr23_u15.nr1[ibody]
print @n.xbgr.xr23_u16.nr1[ibody]
print @n.xbgr.xr23_u17.nr1[ibody]
print @n.xbgr.xr23_u18.nr1[ibody]
print @n.xbgr.xr23_u19.nr1[ibody]
print @n.xbgr.xr23_u20.nr1[ibody]
print @n.xbgr.xr23_u21.nr1[ibody]
print @n.xbgr.xr23_u22.nr1[ibody]
print @n.xbgr.xr23_u23.nr1[ibody]
print @n.xbgr.xr23_u24.nr1[ibody]
print @n.xbgr.xr24_u2.nr1[ibody]
print @n.xbgr.xr24_u3.nr1[ibody]
print @n.xbgr.xr24_u4.nr1[ibody]
print @n.xbgr.xr24_u5.nr1[ibody]
print @n.xbgr.xr24_u6.nr1[ibody]
print @n.xbgr.xr24_u7.nr1[ibody]
print @n.xbgr.xr24_u8.nr1[ibody]
print @n.xbgr.xr24_u9.nr1[ibody]
print @n.xbgr.xr24_u10.nr1[ibody]
print @n.xbgr.xr24_u11.nr1[ibody]
print @n.xbgr.xr24_u12.nr1[ibody]
print @n.xbgr.xr24_u13.nr1[ibody]
print @n.xbgr.xr24_u14.nr1[ibody]
print @n.xbgr.xr24_u15.nr1[ibody]
print @n.xbgr.xr24_u16.nr1[ibody]
print @n.xbgr.xr24_u17.nr1[ibody]
print @n.xbgr.xr24_u18.nr1[ibody]
print @n.xbgr.xr24_u19.nr1[ibody]
print @n.xbgr.xr24_u20.nr1[ibody]
print @n.xbgr.xr24_u21.nr1[ibody]
print @n.xbgr.xr24_u22.nr1[ibody]
print @n.xbgr.xr24_u23.nr1[ibody]
print @n.xbgr.xr24_u24.nr1[ibody]
print @n.xbgr.xr25_u2.nr1[ibody]
print @n.xbgr.xr25_u3.nr1[ibody]
print @n.xbgr.xr25_u4.nr1[ibody]
print @n.xbgr.xr25_u5.nr1[ibody]
print @n.xbgr.xr25_u6.nr1[ibody]
print @n.xbgr.xr25_u7.nr1[ibody]
print @n.xbgr.xr25_u8.nr1[ibody]
print @n.xbgr.xr25_u9.nr1[ibody]
print @n.xbgr.xr25_u10.nr1[ibody]
print @n.xbgr.xr25_u11.nr1[ibody]
print @n.xbgr.xr25_u12.nr1[ibody]
print @n.xbgr.xr25_u13.nr1[ibody]
print @n.xbgr.xr25_u14.nr1[ibody]
print @n.xbgr.xr25_u15.nr1[ibody]
print @n.xbgr.xr25_u16.nr1[ibody]
print @n.xbgr.xr25_u17.nr1[ibody]
print @n.xbgr.xr25_u18.nr1[ibody]
print @n.xbgr.xr25_u19.nr1[ibody]
print @n.xbgr.xr25_u20.nr1[ibody]
print @n.xbgr.xr25_u21.nr1[ibody]
print @n.xbgr.xr25_u22.nr1[ibody]
print @n.xbgr.xr25_u23.nr1[ibody]
print @n.xbgr.xr25_u24.nr1[ibody]
print @n.xbgr.xr26_u2.nr1[ibody]
print @n.xbgr.xr26_u3.nr1[ibody]
print @n.xbgr.xr26_u4.nr1[ibody]
print @n.xbgr.xr26_u5.nr1[ibody]
print @n.xbgr.xr26_u6.nr1[ibody]
print @n.xbgr.xr26_u7.nr1[ibody]
print @n.xbgr.xr26_u8.nr1[ibody]
print @n.xbgr.xr26_u9.nr1[ibody]
print @n.xbgr.xr26_u10.nr1[ibody]
print @n.xbgr.xr26_u11.nr1[ibody]
print @n.xbgr.xr26_u12.nr1[ibody]
print @n.xbgr.xr26_u13.nr1[ibody]
print @n.xbgr.xr26_u14.nr1[ibody]
print @n.xbgr.xr26_u15.nr1[ibody]
print @n.xbgr.xr26_u16.nr1[ibody]
print @n.xbgr.xr26_u17.nr1[ibody]
print @n.xbgr.xr26_u18.nr1[ibody]
print @n.xbgr.xr26_u19.nr1[ibody]
print @n.xbgr.xr26_u20.nr1[ibody]
print @n.xbgr.xr26_u21.nr1[ibody]
print @n.xbgr.xr26_u22.nr1[ibody]
print @n.xbgr.xr26_u23.nr1[ibody]
print @n.xbgr.xr26_u24.nr1[ibody]
print @n.xbgr.xm34_u2.nsg13_hv_nmos[ide]
print @n.xbgr.xm34_u2.nsg13_hv_nmos[ige]
print @n.xbgr.xm34_u2.nsg13_hv_nmos[ise]
print @n.xbgr.xm34_u2.nsg13_hv_nmos[ibe]
print @n.xbgr.xm34_u2.nsg13_hv_nmos[ctype]
print @n.xbgr.xm34_u3.nsg13_hv_nmos[ide]
print @n.xbgr.xm34_u3.nsg13_hv_nmos[ige]
print @n.xbgr.xm34_u3.nsg13_hv_nmos[ise]
print @n.xbgr.xm34_u3.nsg13_hv_nmos[ibe]
print @n.xbgr.xm34_u3.nsg13_hv_nmos[ctype]
print @n.xbgr.xm34_u4.nsg13_hv_nmos[ide]
print @n.xbgr.xm34_u4.nsg13_hv_nmos[ige]
print @n.xbgr.xm34_u4.nsg13_hv_nmos[ise]
print @n.xbgr.xm34_u4.nsg13_hv_nmos[ibe]
print @n.xbgr.xm34_u4.nsg13_hv_nmos[ctype]
print @n.xbgr.xm34_u5.nsg13_hv_nmos[ide]
print @n.xbgr.xm34_u5.nsg13_hv_nmos[ige]
print @n.xbgr.xm34_u5.nsg13_hv_nmos[ise]
print @n.xbgr.xm34_u5.nsg13_hv_nmos[ibe]
print @n.xbgr.xm34_u5.nsg13_hv_nmos[ctype]
print @n.xbgr.xm34_u6.nsg13_hv_nmos[ide]
print @n.xbgr.xm34_u6.nsg13_hv_nmos[ige]
print @n.xbgr.xm34_u6.nsg13_hv_nmos[ise]
print @n.xbgr.xm34_u6.nsg13_hv_nmos[ibe]
print @n.xbgr.xm34_u6.nsg13_hv_nmos[ctype]
print @n.xbgr.xm34_u7.nsg13_hv_nmos[ide]
print @n.xbgr.xm34_u7.nsg13_hv_nmos[ige]
print @n.xbgr.xm34_u7.nsg13_hv_nmos[ise]
print @n.xbgr.xm34_u7.nsg13_hv_nmos[ibe]
print @n.xbgr.xm34_u7.nsg13_hv_nmos[ctype]
print @n.xbgr.xm34_u8.nsg13_hv_nmos[ide]
print @n.xbgr.xm34_u8.nsg13_hv_nmos[ige]
print @n.xbgr.xm34_u8.nsg13_hv_nmos[ise]
print @n.xbgr.xm34_u8.nsg13_hv_nmos[ibe]
print @n.xbgr.xm34_u8.nsg13_hv_nmos[ctype]
print @n.xbgr.xm34_u9.nsg13_hv_nmos[ide]
print @n.xbgr.xm34_u9.nsg13_hv_nmos[ige]
print @n.xbgr.xm34_u9.nsg13_hv_nmos[ise]
print @n.xbgr.xm34_u9.nsg13_hv_nmos[ibe]
print @n.xbgr.xm34_u9.nsg13_hv_nmos[ctype]
print @n.xbgr.xm34_u10.nsg13_hv_nmos[ide]
print @n.xbgr.xm34_u10.nsg13_hv_nmos[ige]
print @n.xbgr.xm34_u10.nsg13_hv_nmos[ise]
print @n.xbgr.xm34_u10.nsg13_hv_nmos[ibe]
print @n.xbgr.xm34_u10.nsg13_hv_nmos[ctype]
print @n.xbgr.xm34_u11.nsg13_hv_nmos[ide]
print @n.xbgr.xm34_u11.nsg13_hv_nmos[ige]
print @n.xbgr.xm34_u11.nsg13_hv_nmos[ise]
print @n.xbgr.xm34_u11.nsg13_hv_nmos[ibe]
print @n.xbgr.xm34_u11.nsg13_hv_nmos[ctype]
print @n.xbgr.xm34_u12.nsg13_hv_nmos[ide]
print @n.xbgr.xm34_u12.nsg13_hv_nmos[ige]
print @n.xbgr.xm34_u12.nsg13_hv_nmos[ise]
print @n.xbgr.xm34_u12.nsg13_hv_nmos[ibe]
print @n.xbgr.xm34_u12.nsg13_hv_nmos[ctype]
print @n.xbgr.xm34_u13.nsg13_hv_nmos[ide]
print @n.xbgr.xm34_u13.nsg13_hv_nmos[ige]
print @n.xbgr.xm34_u13.nsg13_hv_nmos[ise]
print @n.xbgr.xm34_u13.nsg13_hv_nmos[ibe]
print @n.xbgr.xm34_u13.nsg13_hv_nmos[ctype]
print @n.xbgr.xm34_u14.nsg13_hv_nmos[ide]
print @n.xbgr.xm34_u14.nsg13_hv_nmos[ige]
print @n.xbgr.xm34_u14.nsg13_hv_nmos[ise]
print @n.xbgr.xm34_u14.nsg13_hv_nmos[ibe]
print @n.xbgr.xm34_u14.nsg13_hv_nmos[ctype]
print @n.xbgr.xm34_u15.nsg13_hv_nmos[ide]
print @n.xbgr.xm34_u15.nsg13_hv_nmos[ige]
print @n.xbgr.xm34_u15.nsg13_hv_nmos[ise]
print @n.xbgr.xm34_u15.nsg13_hv_nmos[ibe]
print @n.xbgr.xm34_u15.nsg13_hv_nmos[ctype]
print @n.xbgr.xm34_u16.nsg13_hv_nmos[ide]
print @n.xbgr.xm34_u16.nsg13_hv_nmos[ige]
print @n.xbgr.xm34_u16.nsg13_hv_nmos[ise]
print @n.xbgr.xm34_u16.nsg13_hv_nmos[ibe]
print @n.xbgr.xm34_u16.nsg13_hv_nmos[ctype]
print @n.xbgr.xm34_u17.nsg13_hv_nmos[ide]
print @n.xbgr.xm34_u17.nsg13_hv_nmos[ige]
print @n.xbgr.xm34_u17.nsg13_hv_nmos[ise]
print @n.xbgr.xm34_u17.nsg13_hv_nmos[ibe]
print @n.xbgr.xm34_u17.nsg13_hv_nmos[ctype]
print @n.xbgr.xm34_u18.nsg13_hv_nmos[ide]
print @n.xbgr.xm34_u18.nsg13_hv_nmos[ige]
print @n.xbgr.xm34_u18.nsg13_hv_nmos[ise]
print @n.xbgr.xm34_u18.nsg13_hv_nmos[ibe]
print @n.xbgr.xm34_u18.nsg13_hv_nmos[ctype]
print @n.xbgr.xm34_u19.nsg13_hv_nmos[ide]
print @n.xbgr.xm34_u19.nsg13_hv_nmos[ige]
print @n.xbgr.xm34_u19.nsg13_hv_nmos[ise]
print @n.xbgr.xm34_u19.nsg13_hv_nmos[ibe]
print @n.xbgr.xm34_u19.nsg13_hv_nmos[ctype]
print @n.xbgr.xm34_u20.nsg13_hv_nmos[ide]
print @n.xbgr.xm34_u20.nsg13_hv_nmos[ige]
print @n.xbgr.xm34_u20.nsg13_hv_nmos[ise]
print @n.xbgr.xm34_u20.nsg13_hv_nmos[ibe]
print @n.xbgr.xm34_u20.nsg13_hv_nmos[ctype]
print @n.xbgr.xm34_u21.nsg13_hv_nmos[ide]
print @n.xbgr.xm34_u21.nsg13_hv_nmos[ige]
print @n.xbgr.xm34_u21.nsg13_hv_nmos[ise]
print @n.xbgr.xm34_u21.nsg13_hv_nmos[ibe]
print @n.xbgr.xm34_u21.nsg13_hv_nmos[ctype]
print @n.xbgr.xm34_u22.nsg13_hv_nmos[ide]
print @n.xbgr.xm34_u22.nsg13_hv_nmos[ige]
print @n.xbgr.xm34_u22.nsg13_hv_nmos[ise]
print @n.xbgr.xm34_u22.nsg13_hv_nmos[ibe]
print @n.xbgr.xm34_u22.nsg13_hv_nmos[ctype]
print @n.xbgr.xm34_u23.nsg13_hv_nmos[ide]
print @n.xbgr.xm34_u23.nsg13_hv_nmos[ige]
print @n.xbgr.xm34_u23.nsg13_hv_nmos[ise]
print @n.xbgr.xm34_u23.nsg13_hv_nmos[ibe]
print @n.xbgr.xm34_u23.nsg13_hv_nmos[ctype]
print @n.xbgr.xm34_u24.nsg13_hv_nmos[ide]
print @n.xbgr.xm34_u24.nsg13_hv_nmos[ige]
print @n.xbgr.xm34_u24.nsg13_hv_nmos[ise]
print @n.xbgr.xm34_u24.nsg13_hv_nmos[ibe]
print @n.xbgr.xm34_u24.nsg13_hv_nmos[ctype]
print @n.xbgr.xm35_u2.nsg13_hv_nmos[ide]
print @n.xbgr.xm35_u2.nsg13_hv_nmos[ige]
print @n.xbgr.xm35_u2.nsg13_hv_nmos[ise]
print @n.xbgr.xm35_u2.nsg13_hv_nmos[ibe]
print @n.xbgr.xm35_u2.nsg13_hv_nmos[ctype]
print @n.xbgr.xm35_u3.nsg13_hv_nmos[ide]
print @n.xbgr.xm35_u3.nsg13_hv_nmos[ige]
print @n.xbgr.xm35_u3.nsg13_hv_nmos[ise]
print @n.xbgr.xm35_u3.nsg13_hv_nmos[ibe]
print @n.xbgr.xm35_u3.nsg13_hv_nmos[ctype]
print @n.xbgr.xm35_u4.nsg13_hv_nmos[ide]
print @n.xbgr.xm35_u4.nsg13_hv_nmos[ige]
print @n.xbgr.xm35_u4.nsg13_hv_nmos[ise]
print @n.xbgr.xm35_u4.nsg13_hv_nmos[ibe]
print @n.xbgr.xm35_u4.nsg13_hv_nmos[ctype]
print @n.xbgr.xm35_u5.nsg13_hv_nmos[ide]
print @n.xbgr.xm35_u5.nsg13_hv_nmos[ige]
print @n.xbgr.xm35_u5.nsg13_hv_nmos[ise]
print @n.xbgr.xm35_u5.nsg13_hv_nmos[ibe]
print @n.xbgr.xm35_u5.nsg13_hv_nmos[ctype]
print @n.xbgr.xm35_u6.nsg13_hv_nmos[ide]
print @n.xbgr.xm35_u6.nsg13_hv_nmos[ige]
print @n.xbgr.xm35_u6.nsg13_hv_nmos[ise]
print @n.xbgr.xm35_u6.nsg13_hv_nmos[ibe]
print @n.xbgr.xm35_u6.nsg13_hv_nmos[ctype]
print @n.xbgr.xm35_u7.nsg13_hv_nmos[ide]
print @n.xbgr.xm35_u7.nsg13_hv_nmos[ige]
print @n.xbgr.xm35_u7.nsg13_hv_nmos[ise]
print @n.xbgr.xm35_u7.nsg13_hv_nmos[ibe]
print @n.xbgr.xm35_u7.nsg13_hv_nmos[ctype]
print @n.xbgr.xm35_u8.nsg13_hv_nmos[ide]
print @n.xbgr.xm35_u8.nsg13_hv_nmos[ige]
print @n.xbgr.xm35_u8.nsg13_hv_nmos[ise]
print @n.xbgr.xm35_u8.nsg13_hv_nmos[ibe]
print @n.xbgr.xm35_u8.nsg13_hv_nmos[ctype]
print @n.xbgr.xm35_u9.nsg13_hv_nmos[ide]
print @n.xbgr.xm35_u9.nsg13_hv_nmos[ige]
print @n.xbgr.xm35_u9.nsg13_hv_nmos[ise]
print @n.xbgr.xm35_u9.nsg13_hv_nmos[ibe]
print @n.xbgr.xm35_u9.nsg13_hv_nmos[ctype]
print @n.xbgr.xm35_u10.nsg13_hv_nmos[ide]
print @n.xbgr.xm35_u10.nsg13_hv_nmos[ige]
print @n.xbgr.xm35_u10.nsg13_hv_nmos[ise]
print @n.xbgr.xm35_u10.nsg13_hv_nmos[ibe]
print @n.xbgr.xm35_u10.nsg13_hv_nmos[ctype]
print @n.xbgr.xm35_u11.nsg13_hv_nmos[ide]
print @n.xbgr.xm35_u11.nsg13_hv_nmos[ige]
print @n.xbgr.xm35_u11.nsg13_hv_nmos[ise]
print @n.xbgr.xm35_u11.nsg13_hv_nmos[ibe]
print @n.xbgr.xm35_u11.nsg13_hv_nmos[ctype]
print @n.xbgr.xm35_u12.nsg13_hv_nmos[ide]
print @n.xbgr.xm35_u12.nsg13_hv_nmos[ige]
print @n.xbgr.xm35_u12.nsg13_hv_nmos[ise]
print @n.xbgr.xm35_u12.nsg13_hv_nmos[ibe]
print @n.xbgr.xm35_u12.nsg13_hv_nmos[ctype]
print @n.xbgr.xm35_u13.nsg13_hv_nmos[ide]
print @n.xbgr.xm35_u13.nsg13_hv_nmos[ige]
print @n.xbgr.xm35_u13.nsg13_hv_nmos[ise]
print @n.xbgr.xm35_u13.nsg13_hv_nmos[ibe]
print @n.xbgr.xm35_u13.nsg13_hv_nmos[ctype]
print @n.xbgr.xm35_u14.nsg13_hv_nmos[ide]
print @n.xbgr.xm35_u14.nsg13_hv_nmos[ige]
print @n.xbgr.xm35_u14.nsg13_hv_nmos[ise]
print @n.xbgr.xm35_u14.nsg13_hv_nmos[ibe]
print @n.xbgr.xm35_u14.nsg13_hv_nmos[ctype]
print @n.xbgr.xm35_u15.nsg13_hv_nmos[ide]
print @n.xbgr.xm35_u15.nsg13_hv_nmos[ige]
print @n.xbgr.xm35_u15.nsg13_hv_nmos[ise]
print @n.xbgr.xm35_u15.nsg13_hv_nmos[ibe]
print @n.xbgr.xm35_u15.nsg13_hv_nmos[ctype]
print @n.xbgr.xm35_u16.nsg13_hv_nmos[ide]
print @n.xbgr.xm35_u16.nsg13_hv_nmos[ige]
print @n.xbgr.xm35_u16.nsg13_hv_nmos[ise]
print @n.xbgr.xm35_u16.nsg13_hv_nmos[ibe]
print @n.xbgr.xm35_u16.nsg13_hv_nmos[ctype]
print @n.xbgr.xm35_u17.nsg13_hv_nmos[ide]
print @n.xbgr.xm35_u17.nsg13_hv_nmos[ige]
print @n.xbgr.xm35_u17.nsg13_hv_nmos[ise]
print @n.xbgr.xm35_u17.nsg13_hv_nmos[ibe]
print @n.xbgr.xm35_u17.nsg13_hv_nmos[ctype]
print @n.xbgr.xm35_u18.nsg13_hv_nmos[ide]
print @n.xbgr.xm35_u18.nsg13_hv_nmos[ige]
print @n.xbgr.xm35_u18.nsg13_hv_nmos[ise]
print @n.xbgr.xm35_u18.nsg13_hv_nmos[ibe]
print @n.xbgr.xm35_u18.nsg13_hv_nmos[ctype]
print @n.xbgr.xm35_u19.nsg13_hv_nmos[ide]
print @n.xbgr.xm35_u19.nsg13_hv_nmos[ige]
print @n.xbgr.xm35_u19.nsg13_hv_nmos[ise]
print @n.xbgr.xm35_u19.nsg13_hv_nmos[ibe]
print @n.xbgr.xm35_u19.nsg13_hv_nmos[ctype]
print @n.xbgr.xm35_u20.nsg13_hv_nmos[ide]
print @n.xbgr.xm35_u20.nsg13_hv_nmos[ige]
print @n.xbgr.xm35_u20.nsg13_hv_nmos[ise]
print @n.xbgr.xm35_u20.nsg13_hv_nmos[ibe]
print @n.xbgr.xm35_u20.nsg13_hv_nmos[ctype]
print @n.xbgr.xm35_u21.nsg13_hv_nmos[ide]
print @n.xbgr.xm35_u21.nsg13_hv_nmos[ige]
print @n.xbgr.xm35_u21.nsg13_hv_nmos[ise]
print @n.xbgr.xm35_u21.nsg13_hv_nmos[ibe]
print @n.xbgr.xm35_u21.nsg13_hv_nmos[ctype]
print @n.xbgr.xm35_u22.nsg13_hv_nmos[ide]
print @n.xbgr.xm35_u22.nsg13_hv_nmos[ige]
print @n.xbgr.xm35_u22.nsg13_hv_nmos[ise]
print @n.xbgr.xm35_u22.nsg13_hv_nmos[ibe]
print @n.xbgr.xm35_u22.nsg13_hv_nmos[ctype]
print @n.xbgr.xm35_u23.nsg13_hv_nmos[ide]
print @n.xbgr.xm35_u23.nsg13_hv_nmos[ige]
print @n.xbgr.xm35_u23.nsg13_hv_nmos[ise]
print @n.xbgr.xm35_u23.nsg13_hv_nmos[ibe]
print @n.xbgr.xm35_u23.nsg13_hv_nmos[ctype]
print @n.xbgr.xm35_u24.nsg13_hv_nmos[ide]
print @n.xbgr.xm35_u24.nsg13_hv_nmos[ige]
print @n.xbgr.xm35_u24.nsg13_hv_nmos[ise]
print @n.xbgr.xm35_u24.nsg13_hv_nmos[ibe]
print @n.xbgr.xm35_u24.nsg13_hv_nmos[ctype]
print @n.xbgr.xm36_u2.nsg13_hv_nmos[ide]
print @n.xbgr.xm36_u2.nsg13_hv_nmos[ige]
print @n.xbgr.xm36_u2.nsg13_hv_nmos[ise]
print @n.xbgr.xm36_u2.nsg13_hv_nmos[ibe]
print @n.xbgr.xm36_u2.nsg13_hv_nmos[ctype]
print @n.xbgr.xm36_u3.nsg13_hv_nmos[ide]
print @n.xbgr.xm36_u3.nsg13_hv_nmos[ige]
print @n.xbgr.xm36_u3.nsg13_hv_nmos[ise]
print @n.xbgr.xm36_u3.nsg13_hv_nmos[ibe]
print @n.xbgr.xm36_u3.nsg13_hv_nmos[ctype]
print @n.xbgr.xm36_u4.nsg13_hv_nmos[ide]
print @n.xbgr.xm36_u4.nsg13_hv_nmos[ige]
print @n.xbgr.xm36_u4.nsg13_hv_nmos[ise]
print @n.xbgr.xm36_u4.nsg13_hv_nmos[ibe]
print @n.xbgr.xm36_u4.nsg13_hv_nmos[ctype]
print @n.xbgr.xm36_u5.nsg13_hv_nmos[ide]
print @n.xbgr.xm36_u5.nsg13_hv_nmos[ige]
print @n.xbgr.xm36_u5.nsg13_hv_nmos[ise]
print @n.xbgr.xm36_u5.nsg13_hv_nmos[ibe]
print @n.xbgr.xm36_u5.nsg13_hv_nmos[ctype]
print @n.xbgr.xm36_u6.nsg13_hv_nmos[ide]
print @n.xbgr.xm36_u6.nsg13_hv_nmos[ige]
print @n.xbgr.xm36_u6.nsg13_hv_nmos[ise]
print @n.xbgr.xm36_u6.nsg13_hv_nmos[ibe]
print @n.xbgr.xm36_u6.nsg13_hv_nmos[ctype]
print @n.xbgr.xm36_u7.nsg13_hv_nmos[ide]
print @n.xbgr.xm36_u7.nsg13_hv_nmos[ige]
print @n.xbgr.xm36_u7.nsg13_hv_nmos[ise]
print @n.xbgr.xm36_u7.nsg13_hv_nmos[ibe]
print @n.xbgr.xm36_u7.nsg13_hv_nmos[ctype]
print @n.xbgr.xm36_u8.nsg13_hv_nmos[ide]
print @n.xbgr.xm36_u8.nsg13_hv_nmos[ige]
print @n.xbgr.xm36_u8.nsg13_hv_nmos[ise]
print @n.xbgr.xm36_u8.nsg13_hv_nmos[ibe]
print @n.xbgr.xm36_u8.nsg13_hv_nmos[ctype]
print @n.xbgr.xm36_u9.nsg13_hv_nmos[ide]
print @n.xbgr.xm36_u9.nsg13_hv_nmos[ige]
print @n.xbgr.xm36_u9.nsg13_hv_nmos[ise]
print @n.xbgr.xm36_u9.nsg13_hv_nmos[ibe]
print @n.xbgr.xm36_u9.nsg13_hv_nmos[ctype]
print @n.xbgr.xm36_u10.nsg13_hv_nmos[ide]
print @n.xbgr.xm36_u10.nsg13_hv_nmos[ige]
print @n.xbgr.xm36_u10.nsg13_hv_nmos[ise]
print @n.xbgr.xm36_u10.nsg13_hv_nmos[ibe]
print @n.xbgr.xm36_u10.nsg13_hv_nmos[ctype]
print @n.xbgr.xm36_u11.nsg13_hv_nmos[ide]
print @n.xbgr.xm36_u11.nsg13_hv_nmos[ige]
print @n.xbgr.xm36_u11.nsg13_hv_nmos[ise]
print @n.xbgr.xm36_u11.nsg13_hv_nmos[ibe]
print @n.xbgr.xm36_u11.nsg13_hv_nmos[ctype]
print @n.xbgr.xm36_u12.nsg13_hv_nmos[ide]
print @n.xbgr.xm36_u12.nsg13_hv_nmos[ige]
print @n.xbgr.xm36_u12.nsg13_hv_nmos[ise]
print @n.xbgr.xm36_u12.nsg13_hv_nmos[ibe]
print @n.xbgr.xm36_u12.nsg13_hv_nmos[ctype]
print @n.xbgr.xm36_u13.nsg13_hv_nmos[ide]
print @n.xbgr.xm36_u13.nsg13_hv_nmos[ige]
print @n.xbgr.xm36_u13.nsg13_hv_nmos[ise]
print @n.xbgr.xm36_u13.nsg13_hv_nmos[ibe]
print @n.xbgr.xm36_u13.nsg13_hv_nmos[ctype]
print @n.xbgr.xm36_u14.nsg13_hv_nmos[ide]
print @n.xbgr.xm36_u14.nsg13_hv_nmos[ige]
print @n.xbgr.xm36_u14.nsg13_hv_nmos[ise]
print @n.xbgr.xm36_u14.nsg13_hv_nmos[ibe]
print @n.xbgr.xm36_u14.nsg13_hv_nmos[ctype]
print @n.xbgr.xm36_u15.nsg13_hv_nmos[ide]
print @n.xbgr.xm36_u15.nsg13_hv_nmos[ige]
print @n.xbgr.xm36_u15.nsg13_hv_nmos[ise]
print @n.xbgr.xm36_u15.nsg13_hv_nmos[ibe]
print @n.xbgr.xm36_u15.nsg13_hv_nmos[ctype]
print @n.xbgr.xm36_u16.nsg13_hv_nmos[ide]
print @n.xbgr.xm36_u16.nsg13_hv_nmos[ige]
print @n.xbgr.xm36_u16.nsg13_hv_nmos[ise]
print @n.xbgr.xm36_u16.nsg13_hv_nmos[ibe]
print @n.xbgr.xm36_u16.nsg13_hv_nmos[ctype]
print @n.xbgr.xm36_u17.nsg13_hv_nmos[ide]
print @n.xbgr.xm36_u17.nsg13_hv_nmos[ige]
print @n.xbgr.xm36_u17.nsg13_hv_nmos[ise]
print @n.xbgr.xm36_u17.nsg13_hv_nmos[ibe]
print @n.xbgr.xm36_u17.nsg13_hv_nmos[ctype]
print @n.xbgr.xm36_u18.nsg13_hv_nmos[ide]
print @n.xbgr.xm36_u18.nsg13_hv_nmos[ige]
print @n.xbgr.xm36_u18.nsg13_hv_nmos[ise]
print @n.xbgr.xm36_u18.nsg13_hv_nmos[ibe]
print @n.xbgr.xm36_u18.nsg13_hv_nmos[ctype]
print @n.xbgr.xm36_u19.nsg13_hv_nmos[ide]
print @n.xbgr.xm36_u19.nsg13_hv_nmos[ige]
print @n.xbgr.xm36_u19.nsg13_hv_nmos[ise]
print @n.xbgr.xm36_u19.nsg13_hv_nmos[ibe]
print @n.xbgr.xm36_u19.nsg13_hv_nmos[ctype]
print @n.xbgr.xm36_u20.nsg13_hv_nmos[ide]
print @n.xbgr.xm36_u20.nsg13_hv_nmos[ige]
print @n.xbgr.xm36_u20.nsg13_hv_nmos[ise]
print @n.xbgr.xm36_u20.nsg13_hv_nmos[ibe]
print @n.xbgr.xm36_u20.nsg13_hv_nmos[ctype]
print @n.xbgr.xm36_u21.nsg13_hv_nmos[ide]
print @n.xbgr.xm36_u21.nsg13_hv_nmos[ige]
print @n.xbgr.xm36_u21.nsg13_hv_nmos[ise]
print @n.xbgr.xm36_u21.nsg13_hv_nmos[ibe]
print @n.xbgr.xm36_u21.nsg13_hv_nmos[ctype]
print @n.xbgr.xm36_u22.nsg13_hv_nmos[ide]
print @n.xbgr.xm36_u22.nsg13_hv_nmos[ige]
print @n.xbgr.xm36_u22.nsg13_hv_nmos[ise]
print @n.xbgr.xm36_u22.nsg13_hv_nmos[ibe]
print @n.xbgr.xm36_u22.nsg13_hv_nmos[ctype]
print @n.xbgr.xm36_u23.nsg13_hv_nmos[ide]
print @n.xbgr.xm36_u23.nsg13_hv_nmos[ige]
print @n.xbgr.xm36_u23.nsg13_hv_nmos[ise]
print @n.xbgr.xm36_u23.nsg13_hv_nmos[ibe]
print @n.xbgr.xm36_u23.nsg13_hv_nmos[ctype]
print @n.xbgr.xm36_u24.nsg13_hv_nmos[ide]
print @n.xbgr.xm36_u24.nsg13_hv_nmos[ige]
print @n.xbgr.xm36_u24.nsg13_hv_nmos[ise]
print @n.xbgr.xm36_u24.nsg13_hv_nmos[ibe]
print @n.xbgr.xm36_u24.nsg13_hv_nmos[ctype]
print @n.xbgr.xm37_u2.nsg13_hv_nmos[ide]
print @n.xbgr.xm37_u2.nsg13_hv_nmos[ige]
print @n.xbgr.xm37_u2.nsg13_hv_nmos[ise]
print @n.xbgr.xm37_u2.nsg13_hv_nmos[ibe]
print @n.xbgr.xm37_u2.nsg13_hv_nmos[ctype]
print @n.xbgr.xm37_u3.nsg13_hv_nmos[ide]
print @n.xbgr.xm37_u3.nsg13_hv_nmos[ige]
print @n.xbgr.xm37_u3.nsg13_hv_nmos[ise]
print @n.xbgr.xm37_u3.nsg13_hv_nmos[ibe]
print @n.xbgr.xm37_u3.nsg13_hv_nmos[ctype]
print @n.xbgr.xm37_u4.nsg13_hv_nmos[ide]
print @n.xbgr.xm37_u4.nsg13_hv_nmos[ige]
print @n.xbgr.xm37_u4.nsg13_hv_nmos[ise]
print @n.xbgr.xm37_u4.nsg13_hv_nmos[ibe]
print @n.xbgr.xm37_u4.nsg13_hv_nmos[ctype]
print @n.xbgr.xm37_u5.nsg13_hv_nmos[ide]
print @n.xbgr.xm37_u5.nsg13_hv_nmos[ige]
print @n.xbgr.xm37_u5.nsg13_hv_nmos[ise]
print @n.xbgr.xm37_u5.nsg13_hv_nmos[ibe]
print @n.xbgr.xm37_u5.nsg13_hv_nmos[ctype]
print @n.xbgr.xm37_u6.nsg13_hv_nmos[ide]
print @n.xbgr.xm37_u6.nsg13_hv_nmos[ige]
print @n.xbgr.xm37_u6.nsg13_hv_nmos[ise]
print @n.xbgr.xm37_u6.nsg13_hv_nmos[ibe]
print @n.xbgr.xm37_u6.nsg13_hv_nmos[ctype]
print @n.xbgr.xm37_u7.nsg13_hv_nmos[ide]
print @n.xbgr.xm37_u7.nsg13_hv_nmos[ige]
print @n.xbgr.xm37_u7.nsg13_hv_nmos[ise]
print @n.xbgr.xm37_u7.nsg13_hv_nmos[ibe]
print @n.xbgr.xm37_u7.nsg13_hv_nmos[ctype]
print @n.xbgr.xm37_u8.nsg13_hv_nmos[ide]
print @n.xbgr.xm37_u8.nsg13_hv_nmos[ige]
print @n.xbgr.xm37_u8.nsg13_hv_nmos[ise]
print @n.xbgr.xm37_u8.nsg13_hv_nmos[ibe]
print @n.xbgr.xm37_u8.nsg13_hv_nmos[ctype]
print @n.xbgr.xm37_u9.nsg13_hv_nmos[ide]
print @n.xbgr.xm37_u9.nsg13_hv_nmos[ige]
print @n.xbgr.xm37_u9.nsg13_hv_nmos[ise]
print @n.xbgr.xm37_u9.nsg13_hv_nmos[ibe]
print @n.xbgr.xm37_u9.nsg13_hv_nmos[ctype]
print @n.xbgr.xm37_u10.nsg13_hv_nmos[ide]
print @n.xbgr.xm37_u10.nsg13_hv_nmos[ige]
print @n.xbgr.xm37_u10.nsg13_hv_nmos[ise]
print @n.xbgr.xm37_u10.nsg13_hv_nmos[ibe]
print @n.xbgr.xm37_u10.nsg13_hv_nmos[ctype]
print @n.xbgr.xm37_u11.nsg13_hv_nmos[ide]
print @n.xbgr.xm37_u11.nsg13_hv_nmos[ige]
print @n.xbgr.xm37_u11.nsg13_hv_nmos[ise]
print @n.xbgr.xm37_u11.nsg13_hv_nmos[ibe]
print @n.xbgr.xm37_u11.nsg13_hv_nmos[ctype]
print @n.xbgr.xm37_u12.nsg13_hv_nmos[ide]
print @n.xbgr.xm37_u12.nsg13_hv_nmos[ige]
print @n.xbgr.xm37_u12.nsg13_hv_nmos[ise]
print @n.xbgr.xm37_u12.nsg13_hv_nmos[ibe]
print @n.xbgr.xm37_u12.nsg13_hv_nmos[ctype]
print @n.xbgr.xm37_u13.nsg13_hv_nmos[ide]
print @n.xbgr.xm37_u13.nsg13_hv_nmos[ige]
print @n.xbgr.xm37_u13.nsg13_hv_nmos[ise]
print @n.xbgr.xm37_u13.nsg13_hv_nmos[ibe]
print @n.xbgr.xm37_u13.nsg13_hv_nmos[ctype]
print @n.xbgr.xm37_u14.nsg13_hv_nmos[ide]
print @n.xbgr.xm37_u14.nsg13_hv_nmos[ige]
print @n.xbgr.xm37_u14.nsg13_hv_nmos[ise]
print @n.xbgr.xm37_u14.nsg13_hv_nmos[ibe]
print @n.xbgr.xm37_u14.nsg13_hv_nmos[ctype]
print @n.xbgr.xm37_u15.nsg13_hv_nmos[ide]
print @n.xbgr.xm37_u15.nsg13_hv_nmos[ige]
print @n.xbgr.xm37_u15.nsg13_hv_nmos[ise]
print @n.xbgr.xm37_u15.nsg13_hv_nmos[ibe]
print @n.xbgr.xm37_u15.nsg13_hv_nmos[ctype]
print @n.xbgr.xm37_u16.nsg13_hv_nmos[ide]
print @n.xbgr.xm37_u16.nsg13_hv_nmos[ige]
print @n.xbgr.xm37_u16.nsg13_hv_nmos[ise]
print @n.xbgr.xm37_u16.nsg13_hv_nmos[ibe]
print @n.xbgr.xm37_u16.nsg13_hv_nmos[ctype]
print @n.xbgr.xm37_u17.nsg13_hv_nmos[ide]
print @n.xbgr.xm37_u17.nsg13_hv_nmos[ige]
print @n.xbgr.xm37_u17.nsg13_hv_nmos[ise]
print @n.xbgr.xm37_u17.nsg13_hv_nmos[ibe]
print @n.xbgr.xm37_u17.nsg13_hv_nmos[ctype]
print @n.xbgr.xm37_u18.nsg13_hv_nmos[ide]
print @n.xbgr.xm37_u18.nsg13_hv_nmos[ige]
print @n.xbgr.xm37_u18.nsg13_hv_nmos[ise]
print @n.xbgr.xm37_u18.nsg13_hv_nmos[ibe]
print @n.xbgr.xm37_u18.nsg13_hv_nmos[ctype]
print @n.xbgr.xm37_u19.nsg13_hv_nmos[ide]
print @n.xbgr.xm37_u19.nsg13_hv_nmos[ige]
print @n.xbgr.xm37_u19.nsg13_hv_nmos[ise]
print @n.xbgr.xm37_u19.nsg13_hv_nmos[ibe]
print @n.xbgr.xm37_u19.nsg13_hv_nmos[ctype]
print @n.xbgr.xm37_u20.nsg13_hv_nmos[ide]
print @n.xbgr.xm37_u20.nsg13_hv_nmos[ige]
print @n.xbgr.xm37_u20.nsg13_hv_nmos[ise]
print @n.xbgr.xm37_u20.nsg13_hv_nmos[ibe]
print @n.xbgr.xm37_u20.nsg13_hv_nmos[ctype]
print @n.xbgr.xm37_u21.nsg13_hv_nmos[ide]
print @n.xbgr.xm37_u21.nsg13_hv_nmos[ige]
print @n.xbgr.xm37_u21.nsg13_hv_nmos[ise]
print @n.xbgr.xm37_u21.nsg13_hv_nmos[ibe]
print @n.xbgr.xm37_u21.nsg13_hv_nmos[ctype]
print @n.xbgr.xm37_u22.nsg13_hv_nmos[ide]
print @n.xbgr.xm37_u22.nsg13_hv_nmos[ige]
print @n.xbgr.xm37_u22.nsg13_hv_nmos[ise]
print @n.xbgr.xm37_u22.nsg13_hv_nmos[ibe]
print @n.xbgr.xm37_u22.nsg13_hv_nmos[ctype]
print @n.xbgr.xm37_u23.nsg13_hv_nmos[ide]
print @n.xbgr.xm37_u23.nsg13_hv_nmos[ige]
print @n.xbgr.xm37_u23.nsg13_hv_nmos[ise]
print @n.xbgr.xm37_u23.nsg13_hv_nmos[ibe]
print @n.xbgr.xm37_u23.nsg13_hv_nmos[ctype]
print @n.xbgr.xm37_u24.nsg13_hv_nmos[ide]
print @n.xbgr.xm37_u24.nsg13_hv_nmos[ige]
print @n.xbgr.xm37_u24.nsg13_hv_nmos[ise]
print @n.xbgr.xm37_u24.nsg13_hv_nmos[ibe]
print @n.xbgr.xm37_u24.nsg13_hv_nmos[ctype]
print @n.xbgr.xm38_u2.nsg13_hv_pmos[ide]
print @n.xbgr.xm38_u2.nsg13_hv_pmos[ige]
print @n.xbgr.xm38_u2.nsg13_hv_pmos[ise]
print @n.xbgr.xm38_u2.nsg13_hv_pmos[ibe]
print @n.xbgr.xm38_u2.nsg13_hv_pmos[ctype]
print @n.xbgr.xm38_u3.nsg13_hv_pmos[ide]
print @n.xbgr.xm38_u3.nsg13_hv_pmos[ige]
print @n.xbgr.xm38_u3.nsg13_hv_pmos[ise]
print @n.xbgr.xm38_u3.nsg13_hv_pmos[ibe]
print @n.xbgr.xm38_u3.nsg13_hv_pmos[ctype]
print @n.xbgr.xm38_u4.nsg13_hv_pmos[ide]
print @n.xbgr.xm38_u4.nsg13_hv_pmos[ige]
print @n.xbgr.xm38_u4.nsg13_hv_pmos[ise]
print @n.xbgr.xm38_u4.nsg13_hv_pmos[ibe]
print @n.xbgr.xm38_u4.nsg13_hv_pmos[ctype]
print @n.xbgr.xm38_u5.nsg13_hv_pmos[ide]
print @n.xbgr.xm38_u5.nsg13_hv_pmos[ige]
print @n.xbgr.xm38_u5.nsg13_hv_pmos[ise]
print @n.xbgr.xm38_u5.nsg13_hv_pmos[ibe]
print @n.xbgr.xm38_u5.nsg13_hv_pmos[ctype]
print @n.xbgr.xm38_u6.nsg13_hv_pmos[ide]
print @n.xbgr.xm38_u6.nsg13_hv_pmos[ige]
print @n.xbgr.xm38_u6.nsg13_hv_pmos[ise]
print @n.xbgr.xm38_u6.nsg13_hv_pmos[ibe]
print @n.xbgr.xm38_u6.nsg13_hv_pmos[ctype]
print @n.xbgr.xm38_u7.nsg13_hv_pmos[ide]
print @n.xbgr.xm38_u7.nsg13_hv_pmos[ige]
print @n.xbgr.xm38_u7.nsg13_hv_pmos[ise]
print @n.xbgr.xm38_u7.nsg13_hv_pmos[ibe]
print @n.xbgr.xm38_u7.nsg13_hv_pmos[ctype]
print @n.xbgr.xm38_u8.nsg13_hv_pmos[ide]
print @n.xbgr.xm38_u8.nsg13_hv_pmos[ige]
print @n.xbgr.xm38_u8.nsg13_hv_pmos[ise]
print @n.xbgr.xm38_u8.nsg13_hv_pmos[ibe]
print @n.xbgr.xm38_u8.nsg13_hv_pmos[ctype]
print @n.xbgr.xm38_u9.nsg13_hv_pmos[ide]
print @n.xbgr.xm38_u9.nsg13_hv_pmos[ige]
print @n.xbgr.xm38_u9.nsg13_hv_pmos[ise]
print @n.xbgr.xm38_u9.nsg13_hv_pmos[ibe]
print @n.xbgr.xm38_u9.nsg13_hv_pmos[ctype]
print @n.xbgr.xm38_u10.nsg13_hv_pmos[ide]
print @n.xbgr.xm38_u10.nsg13_hv_pmos[ige]
print @n.xbgr.xm38_u10.nsg13_hv_pmos[ise]
print @n.xbgr.xm38_u10.nsg13_hv_pmos[ibe]
print @n.xbgr.xm38_u10.nsg13_hv_pmos[ctype]
print @n.xbgr.xm38_u11.nsg13_hv_pmos[ide]
print @n.xbgr.xm38_u11.nsg13_hv_pmos[ige]
print @n.xbgr.xm38_u11.nsg13_hv_pmos[ise]
print @n.xbgr.xm38_u11.nsg13_hv_pmos[ibe]
print @n.xbgr.xm38_u11.nsg13_hv_pmos[ctype]
print @n.xbgr.xm38_u12.nsg13_hv_pmos[ide]
print @n.xbgr.xm38_u12.nsg13_hv_pmos[ige]
print @n.xbgr.xm38_u12.nsg13_hv_pmos[ise]
print @n.xbgr.xm38_u12.nsg13_hv_pmos[ibe]
print @n.xbgr.xm38_u12.nsg13_hv_pmos[ctype]
print @n.xbgr.xm38_u13.nsg13_hv_pmos[ide]
print @n.xbgr.xm38_u13.nsg13_hv_pmos[ige]
print @n.xbgr.xm38_u13.nsg13_hv_pmos[ise]
print @n.xbgr.xm38_u13.nsg13_hv_pmos[ibe]
print @n.xbgr.xm38_u13.nsg13_hv_pmos[ctype]
print @n.xbgr.xm38_u14.nsg13_hv_pmos[ide]
print @n.xbgr.xm38_u14.nsg13_hv_pmos[ige]
print @n.xbgr.xm38_u14.nsg13_hv_pmos[ise]
print @n.xbgr.xm38_u14.nsg13_hv_pmos[ibe]
print @n.xbgr.xm38_u14.nsg13_hv_pmos[ctype]
print @n.xbgr.xm38_u15.nsg13_hv_pmos[ide]
print @n.xbgr.xm38_u15.nsg13_hv_pmos[ige]
print @n.xbgr.xm38_u15.nsg13_hv_pmos[ise]
print @n.xbgr.xm38_u15.nsg13_hv_pmos[ibe]
print @n.xbgr.xm38_u15.nsg13_hv_pmos[ctype]
print @n.xbgr.xm38_u16.nsg13_hv_pmos[ide]
print @n.xbgr.xm38_u16.nsg13_hv_pmos[ige]
print @n.xbgr.xm38_u16.nsg13_hv_pmos[ise]
print @n.xbgr.xm38_u16.nsg13_hv_pmos[ibe]
print @n.xbgr.xm38_u16.nsg13_hv_pmos[ctype]
print @n.xbgr.xm38_u17.nsg13_hv_pmos[ide]
print @n.xbgr.xm38_u17.nsg13_hv_pmos[ige]
print @n.xbgr.xm38_u17.nsg13_hv_pmos[ise]
print @n.xbgr.xm38_u17.nsg13_hv_pmos[ibe]
print @n.xbgr.xm38_u17.nsg13_hv_pmos[ctype]
print @n.xbgr.xm38_u18.nsg13_hv_pmos[ide]
print @n.xbgr.xm38_u18.nsg13_hv_pmos[ige]
print @n.xbgr.xm38_u18.nsg13_hv_pmos[ise]
print @n.xbgr.xm38_u18.nsg13_hv_pmos[ibe]
print @n.xbgr.xm38_u18.nsg13_hv_pmos[ctype]
print @n.xbgr.xm38_u19.nsg13_hv_pmos[ide]
print @n.xbgr.xm38_u19.nsg13_hv_pmos[ige]
print @n.xbgr.xm38_u19.nsg13_hv_pmos[ise]
print @n.xbgr.xm38_u19.nsg13_hv_pmos[ibe]
print @n.xbgr.xm38_u19.nsg13_hv_pmos[ctype]
print @n.xbgr.xm38_u20.nsg13_hv_pmos[ide]
print @n.xbgr.xm38_u20.nsg13_hv_pmos[ige]
print @n.xbgr.xm38_u20.nsg13_hv_pmos[ise]
print @n.xbgr.xm38_u20.nsg13_hv_pmos[ibe]
print @n.xbgr.xm38_u20.nsg13_hv_pmos[ctype]
print @n.xbgr.xm38_u21.nsg13_hv_pmos[ide]
print @n.xbgr.xm38_u21.nsg13_hv_pmos[ige]
print @n.xbgr.xm38_u21.nsg13_hv_pmos[ise]
print @n.xbgr.xm38_u21.nsg13_hv_pmos[ibe]
print @n.xbgr.xm38_u21.nsg13_hv_pmos[ctype]
print @n.xbgr.xm38_u22.nsg13_hv_pmos[ide]
print @n.xbgr.xm38_u22.nsg13_hv_pmos[ige]
print @n.xbgr.xm38_u22.nsg13_hv_pmos[ise]
print @n.xbgr.xm38_u22.nsg13_hv_pmos[ibe]
print @n.xbgr.xm38_u22.nsg13_hv_pmos[ctype]
print @n.xbgr.xm38_u23.nsg13_hv_pmos[ide]
print @n.xbgr.xm38_u23.nsg13_hv_pmos[ige]
print @n.xbgr.xm38_u23.nsg13_hv_pmos[ise]
print @n.xbgr.xm38_u23.nsg13_hv_pmos[ibe]
print @n.xbgr.xm38_u23.nsg13_hv_pmos[ctype]
print @n.xbgr.xm38_u24.nsg13_hv_pmos[ide]
print @n.xbgr.xm38_u24.nsg13_hv_pmos[ige]
print @n.xbgr.xm38_u24.nsg13_hv_pmos[ise]
print @n.xbgr.xm38_u24.nsg13_hv_pmos[ibe]
print @n.xbgr.xm38_u24.nsg13_hv_pmos[ctype]
print @n.xbgr.xm39_u2.nsg13_hv_pmos[ide]
print @n.xbgr.xm39_u2.nsg13_hv_pmos[ige]
print @n.xbgr.xm39_u2.nsg13_hv_pmos[ise]
print @n.xbgr.xm39_u2.nsg13_hv_pmos[ibe]
print @n.xbgr.xm39_u2.nsg13_hv_pmos[ctype]
print @n.xbgr.xm39_u3.nsg13_hv_pmos[ide]
print @n.xbgr.xm39_u3.nsg13_hv_pmos[ige]
print @n.xbgr.xm39_u3.nsg13_hv_pmos[ise]
print @n.xbgr.xm39_u3.nsg13_hv_pmos[ibe]
print @n.xbgr.xm39_u3.nsg13_hv_pmos[ctype]
print @n.xbgr.xm39_u4.nsg13_hv_pmos[ide]
print @n.xbgr.xm39_u4.nsg13_hv_pmos[ige]
print @n.xbgr.xm39_u4.nsg13_hv_pmos[ise]
print @n.xbgr.xm39_u4.nsg13_hv_pmos[ibe]
print @n.xbgr.xm39_u4.nsg13_hv_pmos[ctype]
print @n.xbgr.xm39_u5.nsg13_hv_pmos[ide]
print @n.xbgr.xm39_u5.nsg13_hv_pmos[ige]
print @n.xbgr.xm39_u5.nsg13_hv_pmos[ise]
print @n.xbgr.xm39_u5.nsg13_hv_pmos[ibe]
print @n.xbgr.xm39_u5.nsg13_hv_pmos[ctype]
print @n.xbgr.xm39_u6.nsg13_hv_pmos[ide]
print @n.xbgr.xm39_u6.nsg13_hv_pmos[ige]
print @n.xbgr.xm39_u6.nsg13_hv_pmos[ise]
print @n.xbgr.xm39_u6.nsg13_hv_pmos[ibe]
print @n.xbgr.xm39_u6.nsg13_hv_pmos[ctype]
print @n.xbgr.xm39_u7.nsg13_hv_pmos[ide]
print @n.xbgr.xm39_u7.nsg13_hv_pmos[ige]
print @n.xbgr.xm39_u7.nsg13_hv_pmos[ise]
print @n.xbgr.xm39_u7.nsg13_hv_pmos[ibe]
print @n.xbgr.xm39_u7.nsg13_hv_pmos[ctype]
print @n.xbgr.xm39_u8.nsg13_hv_pmos[ide]
print @n.xbgr.xm39_u8.nsg13_hv_pmos[ige]
print @n.xbgr.xm39_u8.nsg13_hv_pmos[ise]
print @n.xbgr.xm39_u8.nsg13_hv_pmos[ibe]
print @n.xbgr.xm39_u8.nsg13_hv_pmos[ctype]
print @n.xbgr.xm39_u9.nsg13_hv_pmos[ide]
print @n.xbgr.xm39_u9.nsg13_hv_pmos[ige]
print @n.xbgr.xm39_u9.nsg13_hv_pmos[ise]
print @n.xbgr.xm39_u9.nsg13_hv_pmos[ibe]
print @n.xbgr.xm39_u9.nsg13_hv_pmos[ctype]
print @n.xbgr.xm39_u10.nsg13_hv_pmos[ide]
print @n.xbgr.xm39_u10.nsg13_hv_pmos[ige]
print @n.xbgr.xm39_u10.nsg13_hv_pmos[ise]
print @n.xbgr.xm39_u10.nsg13_hv_pmos[ibe]
print @n.xbgr.xm39_u10.nsg13_hv_pmos[ctype]
print @n.xbgr.xm39_u11.nsg13_hv_pmos[ide]
print @n.xbgr.xm39_u11.nsg13_hv_pmos[ige]
print @n.xbgr.xm39_u11.nsg13_hv_pmos[ise]
print @n.xbgr.xm39_u11.nsg13_hv_pmos[ibe]
print @n.xbgr.xm39_u11.nsg13_hv_pmos[ctype]
print @n.xbgr.xm39_u12.nsg13_hv_pmos[ide]
print @n.xbgr.xm39_u12.nsg13_hv_pmos[ige]
print @n.xbgr.xm39_u12.nsg13_hv_pmos[ise]
print @n.xbgr.xm39_u12.nsg13_hv_pmos[ibe]
print @n.xbgr.xm39_u12.nsg13_hv_pmos[ctype]
print @n.xbgr.xm39_u13.nsg13_hv_pmos[ide]
print @n.xbgr.xm39_u13.nsg13_hv_pmos[ige]
print @n.xbgr.xm39_u13.nsg13_hv_pmos[ise]
print @n.xbgr.xm39_u13.nsg13_hv_pmos[ibe]
print @n.xbgr.xm39_u13.nsg13_hv_pmos[ctype]
print @n.xbgr.xm39_u14.nsg13_hv_pmos[ide]
print @n.xbgr.xm39_u14.nsg13_hv_pmos[ige]
print @n.xbgr.xm39_u14.nsg13_hv_pmos[ise]
print @n.xbgr.xm39_u14.nsg13_hv_pmos[ibe]
print @n.xbgr.xm39_u14.nsg13_hv_pmos[ctype]
print @n.xbgr.xm39_u15.nsg13_hv_pmos[ide]
print @n.xbgr.xm39_u15.nsg13_hv_pmos[ige]
print @n.xbgr.xm39_u15.nsg13_hv_pmos[ise]
print @n.xbgr.xm39_u15.nsg13_hv_pmos[ibe]
print @n.xbgr.xm39_u15.nsg13_hv_pmos[ctype]
print @n.xbgr.xm39_u16.nsg13_hv_pmos[ide]
print @n.xbgr.xm39_u16.nsg13_hv_pmos[ige]
print @n.xbgr.xm39_u16.nsg13_hv_pmos[ise]
print @n.xbgr.xm39_u16.nsg13_hv_pmos[ibe]
print @n.xbgr.xm39_u16.nsg13_hv_pmos[ctype]
print @n.xbgr.xm39_u17.nsg13_hv_pmos[ide]
print @n.xbgr.xm39_u17.nsg13_hv_pmos[ige]
print @n.xbgr.xm39_u17.nsg13_hv_pmos[ise]
print @n.xbgr.xm39_u17.nsg13_hv_pmos[ibe]
print @n.xbgr.xm39_u17.nsg13_hv_pmos[ctype]
print @n.xbgr.xm39_u18.nsg13_hv_pmos[ide]
print @n.xbgr.xm39_u18.nsg13_hv_pmos[ige]
print @n.xbgr.xm39_u18.nsg13_hv_pmos[ise]
print @n.xbgr.xm39_u18.nsg13_hv_pmos[ibe]
print @n.xbgr.xm39_u18.nsg13_hv_pmos[ctype]
print @n.xbgr.xm39_u19.nsg13_hv_pmos[ide]
print @n.xbgr.xm39_u19.nsg13_hv_pmos[ige]
print @n.xbgr.xm39_u19.nsg13_hv_pmos[ise]
print @n.xbgr.xm39_u19.nsg13_hv_pmos[ibe]
print @n.xbgr.xm39_u19.nsg13_hv_pmos[ctype]
print @n.xbgr.xm39_u20.nsg13_hv_pmos[ide]
print @n.xbgr.xm39_u20.nsg13_hv_pmos[ige]
print @n.xbgr.xm39_u20.nsg13_hv_pmos[ise]
print @n.xbgr.xm39_u20.nsg13_hv_pmos[ibe]
print @n.xbgr.xm39_u20.nsg13_hv_pmos[ctype]
print @n.xbgr.xm39_u21.nsg13_hv_pmos[ide]
print @n.xbgr.xm39_u21.nsg13_hv_pmos[ige]
print @n.xbgr.xm39_u21.nsg13_hv_pmos[ise]
print @n.xbgr.xm39_u21.nsg13_hv_pmos[ibe]
print @n.xbgr.xm39_u21.nsg13_hv_pmos[ctype]
print @n.xbgr.xm39_u22.nsg13_hv_pmos[ide]
print @n.xbgr.xm39_u22.nsg13_hv_pmos[ige]
print @n.xbgr.xm39_u22.nsg13_hv_pmos[ise]
print @n.xbgr.xm39_u22.nsg13_hv_pmos[ibe]
print @n.xbgr.xm39_u22.nsg13_hv_pmos[ctype]
print @n.xbgr.xm39_u23.nsg13_hv_pmos[ide]
print @n.xbgr.xm39_u23.nsg13_hv_pmos[ige]
print @n.xbgr.xm39_u23.nsg13_hv_pmos[ise]
print @n.xbgr.xm39_u23.nsg13_hv_pmos[ibe]
print @n.xbgr.xm39_u23.nsg13_hv_pmos[ctype]
print @n.xbgr.xm39_u24.nsg13_hv_pmos[ide]
print @n.xbgr.xm39_u24.nsg13_hv_pmos[ige]
print @n.xbgr.xm39_u24.nsg13_hv_pmos[ise]
print @n.xbgr.xm39_u24.nsg13_hv_pmos[ibe]
print @n.xbgr.xm39_u24.nsg13_hv_pmos[ctype]
print @n.xbgr.xm41_u2.nsg13_hv_pmos[ide]
print @n.xbgr.xm41_u2.nsg13_hv_pmos[ige]
print @n.xbgr.xm41_u2.nsg13_hv_pmos[ise]
print @n.xbgr.xm41_u2.nsg13_hv_pmos[ibe]
print @n.xbgr.xm41_u2.nsg13_hv_pmos[ctype]
print @n.xbgr.xm41_u3.nsg13_hv_pmos[ide]
print @n.xbgr.xm41_u3.nsg13_hv_pmos[ige]
print @n.xbgr.xm41_u3.nsg13_hv_pmos[ise]
print @n.xbgr.xm41_u3.nsg13_hv_pmos[ibe]
print @n.xbgr.xm41_u3.nsg13_hv_pmos[ctype]
print @n.xbgr.xm41_u4.nsg13_hv_pmos[ide]
print @n.xbgr.xm41_u4.nsg13_hv_pmos[ige]
print @n.xbgr.xm41_u4.nsg13_hv_pmos[ise]
print @n.xbgr.xm41_u4.nsg13_hv_pmos[ibe]
print @n.xbgr.xm41_u4.nsg13_hv_pmos[ctype]
print @n.xbgr.xm41_u5.nsg13_hv_pmos[ide]
print @n.xbgr.xm41_u5.nsg13_hv_pmos[ige]
print @n.xbgr.xm41_u5.nsg13_hv_pmos[ise]
print @n.xbgr.xm41_u5.nsg13_hv_pmos[ibe]
print @n.xbgr.xm41_u5.nsg13_hv_pmos[ctype]
print @n.xbgr.xm41_u6.nsg13_hv_pmos[ide]
print @n.xbgr.xm41_u6.nsg13_hv_pmos[ige]
print @n.xbgr.xm41_u6.nsg13_hv_pmos[ise]
print @n.xbgr.xm41_u6.nsg13_hv_pmos[ibe]
print @n.xbgr.xm41_u6.nsg13_hv_pmos[ctype]
print @n.xbgr.xm41_u7.nsg13_hv_pmos[ide]
print @n.xbgr.xm41_u7.nsg13_hv_pmos[ige]
print @n.xbgr.xm41_u7.nsg13_hv_pmos[ise]
print @n.xbgr.xm41_u7.nsg13_hv_pmos[ibe]
print @n.xbgr.xm41_u7.nsg13_hv_pmos[ctype]
print @n.xbgr.xm41_u8.nsg13_hv_pmos[ide]
print @n.xbgr.xm41_u8.nsg13_hv_pmos[ige]
print @n.xbgr.xm41_u8.nsg13_hv_pmos[ise]
print @n.xbgr.xm41_u8.nsg13_hv_pmos[ibe]
print @n.xbgr.xm41_u8.nsg13_hv_pmos[ctype]
print @n.xbgr.xm41_u9.nsg13_hv_pmos[ide]
print @n.xbgr.xm41_u9.nsg13_hv_pmos[ige]
print @n.xbgr.xm41_u9.nsg13_hv_pmos[ise]
print @n.xbgr.xm41_u9.nsg13_hv_pmos[ibe]
print @n.xbgr.xm41_u9.nsg13_hv_pmos[ctype]
print @n.xbgr.xm41_u10.nsg13_hv_pmos[ide]
print @n.xbgr.xm41_u10.nsg13_hv_pmos[ige]
print @n.xbgr.xm41_u10.nsg13_hv_pmos[ise]
print @n.xbgr.xm41_u10.nsg13_hv_pmos[ibe]
print @n.xbgr.xm41_u10.nsg13_hv_pmos[ctype]
print @n.xbgr.xm41_u11.nsg13_hv_pmos[ide]
print @n.xbgr.xm41_u11.nsg13_hv_pmos[ige]
print @n.xbgr.xm41_u11.nsg13_hv_pmos[ise]
print @n.xbgr.xm41_u11.nsg13_hv_pmos[ibe]
print @n.xbgr.xm41_u11.nsg13_hv_pmos[ctype]
print @n.xbgr.xm41_u12.nsg13_hv_pmos[ide]
print @n.xbgr.xm41_u12.nsg13_hv_pmos[ige]
print @n.xbgr.xm41_u12.nsg13_hv_pmos[ise]
print @n.xbgr.xm41_u12.nsg13_hv_pmos[ibe]
print @n.xbgr.xm41_u12.nsg13_hv_pmos[ctype]
print @n.xbgr.xm41_u13.nsg13_hv_pmos[ide]
print @n.xbgr.xm41_u13.nsg13_hv_pmos[ige]
print @n.xbgr.xm41_u13.nsg13_hv_pmos[ise]
print @n.xbgr.xm41_u13.nsg13_hv_pmos[ibe]
print @n.xbgr.xm41_u13.nsg13_hv_pmos[ctype]
print @n.xbgr.xm41_u14.nsg13_hv_pmos[ide]
print @n.xbgr.xm41_u14.nsg13_hv_pmos[ige]
print @n.xbgr.xm41_u14.nsg13_hv_pmos[ise]
print @n.xbgr.xm41_u14.nsg13_hv_pmos[ibe]
print @n.xbgr.xm41_u14.nsg13_hv_pmos[ctype]
print @n.xbgr.xm41_u15.nsg13_hv_pmos[ide]
print @n.xbgr.xm41_u15.nsg13_hv_pmos[ige]
print @n.xbgr.xm41_u15.nsg13_hv_pmos[ise]
print @n.xbgr.xm41_u15.nsg13_hv_pmos[ibe]
print @n.xbgr.xm41_u15.nsg13_hv_pmos[ctype]
print @n.xbgr.xm41_u16.nsg13_hv_pmos[ide]
print @n.xbgr.xm41_u16.nsg13_hv_pmos[ige]
print @n.xbgr.xm41_u16.nsg13_hv_pmos[ise]
print @n.xbgr.xm41_u16.nsg13_hv_pmos[ibe]
print @n.xbgr.xm41_u16.nsg13_hv_pmos[ctype]
print @n.xbgr.xm41_u17.nsg13_hv_pmos[ide]
print @n.xbgr.xm41_u17.nsg13_hv_pmos[ige]
print @n.xbgr.xm41_u17.nsg13_hv_pmos[ise]
print @n.xbgr.xm41_u17.nsg13_hv_pmos[ibe]
print @n.xbgr.xm41_u17.nsg13_hv_pmos[ctype]
print @n.xbgr.xm41_u18.nsg13_hv_pmos[ide]
print @n.xbgr.xm41_u18.nsg13_hv_pmos[ige]
print @n.xbgr.xm41_u18.nsg13_hv_pmos[ise]
print @n.xbgr.xm41_u18.nsg13_hv_pmos[ibe]
print @n.xbgr.xm41_u18.nsg13_hv_pmos[ctype]
print @n.xbgr.xm41_u19.nsg13_hv_pmos[ide]
print @n.xbgr.xm41_u19.nsg13_hv_pmos[ige]
print @n.xbgr.xm41_u19.nsg13_hv_pmos[ise]
print @n.xbgr.xm41_u19.nsg13_hv_pmos[ibe]
print @n.xbgr.xm41_u19.nsg13_hv_pmos[ctype]
print @n.xbgr.xm41_u20.nsg13_hv_pmos[ide]
print @n.xbgr.xm41_u20.nsg13_hv_pmos[ige]
print @n.xbgr.xm41_u20.nsg13_hv_pmos[ise]
print @n.xbgr.xm41_u20.nsg13_hv_pmos[ibe]
print @n.xbgr.xm41_u20.nsg13_hv_pmos[ctype]
print @n.xbgr.xm41_u21.nsg13_hv_pmos[ide]
print @n.xbgr.xm41_u21.nsg13_hv_pmos[ige]
print @n.xbgr.xm41_u21.nsg13_hv_pmos[ise]
print @n.xbgr.xm41_u21.nsg13_hv_pmos[ibe]
print @n.xbgr.xm41_u21.nsg13_hv_pmos[ctype]
print @n.xbgr.xm41_u22.nsg13_hv_pmos[ide]
print @n.xbgr.xm41_u22.nsg13_hv_pmos[ige]
print @n.xbgr.xm41_u22.nsg13_hv_pmos[ise]
print @n.xbgr.xm41_u22.nsg13_hv_pmos[ibe]
print @n.xbgr.xm41_u22.nsg13_hv_pmos[ctype]
print @n.xbgr.xm41_u23.nsg13_hv_pmos[ide]
print @n.xbgr.xm41_u23.nsg13_hv_pmos[ige]
print @n.xbgr.xm41_u23.nsg13_hv_pmos[ise]
print @n.xbgr.xm41_u23.nsg13_hv_pmos[ibe]
print @n.xbgr.xm41_u23.nsg13_hv_pmos[ctype]
print @n.xbgr.xm41_u24.nsg13_hv_pmos[ide]
print @n.xbgr.xm41_u24.nsg13_hv_pmos[ige]
print @n.xbgr.xm41_u24.nsg13_hv_pmos[ise]
print @n.xbgr.xm41_u24.nsg13_hv_pmos[ibe]
print @n.xbgr.xm41_u24.nsg13_hv_pmos[ctype]
print @n.xbgr.xm43_u2.nsg13_hv_pmos[ide]
print @n.xbgr.xm43_u2.nsg13_hv_pmos[ige]
print @n.xbgr.xm43_u2.nsg13_hv_pmos[ise]
print @n.xbgr.xm43_u2.nsg13_hv_pmos[ibe]
print @n.xbgr.xm43_u2.nsg13_hv_pmos[ctype]
print @n.xbgr.xm43_u3.nsg13_hv_pmos[ide]
print @n.xbgr.xm43_u3.nsg13_hv_pmos[ige]
print @n.xbgr.xm43_u3.nsg13_hv_pmos[ise]
print @n.xbgr.xm43_u3.nsg13_hv_pmos[ibe]
print @n.xbgr.xm43_u3.nsg13_hv_pmos[ctype]
print @n.xbgr.xm43_u4.nsg13_hv_pmos[ide]
print @n.xbgr.xm43_u4.nsg13_hv_pmos[ige]
print @n.xbgr.xm43_u4.nsg13_hv_pmos[ise]
print @n.xbgr.xm43_u4.nsg13_hv_pmos[ibe]
print @n.xbgr.xm43_u4.nsg13_hv_pmos[ctype]
print @n.xbgr.xm44_u2.nsg13_hv_pmos[ide]
print @n.xbgr.xm44_u2.nsg13_hv_pmos[ige]
print @n.xbgr.xm44_u2.nsg13_hv_pmos[ise]
print @n.xbgr.xm44_u2.nsg13_hv_pmos[ibe]
print @n.xbgr.xm44_u2.nsg13_hv_pmos[ctype]
print @n.xbgr.xm44_u3.nsg13_hv_pmos[ide]
print @n.xbgr.xm44_u3.nsg13_hv_pmos[ige]
print @n.xbgr.xm44_u3.nsg13_hv_pmos[ise]
print @n.xbgr.xm44_u3.nsg13_hv_pmos[ibe]
print @n.xbgr.xm44_u3.nsg13_hv_pmos[ctype]
print @n.xbgr.xm44_u4.nsg13_hv_pmos[ide]
print @n.xbgr.xm44_u4.nsg13_hv_pmos[ige]
print @n.xbgr.xm44_u4.nsg13_hv_pmos[ise]
print @n.xbgr.xm44_u4.nsg13_hv_pmos[ibe]
print @n.xbgr.xm44_u4.nsg13_hv_pmos[ctype]
print @n.xbgr.xm45_u2.nsg13_hv_pmos[ide]
print @n.xbgr.xm45_u2.nsg13_hv_pmos[ige]
print @n.xbgr.xm45_u2.nsg13_hv_pmos[ise]
print @n.xbgr.xm45_u2.nsg13_hv_pmos[ibe]
print @n.xbgr.xm45_u2.nsg13_hv_pmos[ctype]
print @n.xbgr.xm45_u3.nsg13_hv_pmos[ide]
print @n.xbgr.xm45_u3.nsg13_hv_pmos[ige]
print @n.xbgr.xm45_u3.nsg13_hv_pmos[ise]
print @n.xbgr.xm45_u3.nsg13_hv_pmos[ibe]
print @n.xbgr.xm45_u3.nsg13_hv_pmos[ctype]
print @n.xbgr.xm45_u4.nsg13_hv_pmos[ide]
print @n.xbgr.xm45_u4.nsg13_hv_pmos[ige]
print @n.xbgr.xm45_u4.nsg13_hv_pmos[ise]
print @n.xbgr.xm45_u4.nsg13_hv_pmos[ibe]
print @n.xbgr.xm45_u4.nsg13_hv_pmos[ctype]
print @n.xbgr.xm45_u5.nsg13_hv_pmos[ide]
print @n.xbgr.xm45_u5.nsg13_hv_pmos[ige]
print @n.xbgr.xm45_u5.nsg13_hv_pmos[ise]
print @n.xbgr.xm45_u5.nsg13_hv_pmos[ibe]
print @n.xbgr.xm45_u5.nsg13_hv_pmos[ctype]
print @n.xbgr.xm45_u6.nsg13_hv_pmos[ide]
print @n.xbgr.xm45_u6.nsg13_hv_pmos[ige]
print @n.xbgr.xm45_u6.nsg13_hv_pmos[ise]
print @n.xbgr.xm45_u6.nsg13_hv_pmos[ibe]
print @n.xbgr.xm45_u6.nsg13_hv_pmos[ctype]
print @n.xbgr.xm45_u7.nsg13_hv_pmos[ide]
print @n.xbgr.xm45_u7.nsg13_hv_pmos[ige]
print @n.xbgr.xm45_u7.nsg13_hv_pmos[ise]
print @n.xbgr.xm45_u7.nsg13_hv_pmos[ibe]
print @n.xbgr.xm45_u7.nsg13_hv_pmos[ctype]
print @n.xbgr.xm45_u8.nsg13_hv_pmos[ide]
print @n.xbgr.xm45_u8.nsg13_hv_pmos[ige]
print @n.xbgr.xm45_u8.nsg13_hv_pmos[ise]
print @n.xbgr.xm45_u8.nsg13_hv_pmos[ibe]
print @n.xbgr.xm45_u8.nsg13_hv_pmos[ctype]
print @n.xbgr.xm45_u9.nsg13_hv_pmos[ide]
print @n.xbgr.xm45_u9.nsg13_hv_pmos[ige]
print @n.xbgr.xm45_u9.nsg13_hv_pmos[ise]
print @n.xbgr.xm45_u9.nsg13_hv_pmos[ibe]
print @n.xbgr.xm45_u9.nsg13_hv_pmos[ctype]
print @n.xbgr.xm45_u10.nsg13_hv_pmos[ide]
print @n.xbgr.xm45_u10.nsg13_hv_pmos[ige]
print @n.xbgr.xm45_u10.nsg13_hv_pmos[ise]
print @n.xbgr.xm45_u10.nsg13_hv_pmos[ibe]
print @n.xbgr.xm45_u10.nsg13_hv_pmos[ctype]
print @n.xbgr.xm45_u11.nsg13_hv_pmos[ide]
print @n.xbgr.xm45_u11.nsg13_hv_pmos[ige]
print @n.xbgr.xm45_u11.nsg13_hv_pmos[ise]
print @n.xbgr.xm45_u11.nsg13_hv_pmos[ibe]
print @n.xbgr.xm45_u11.nsg13_hv_pmos[ctype]
print @n.xbgr.xm45_u12.nsg13_hv_pmos[ide]
print @n.xbgr.xm45_u12.nsg13_hv_pmos[ige]
print @n.xbgr.xm45_u12.nsg13_hv_pmos[ise]
print @n.xbgr.xm45_u12.nsg13_hv_pmos[ibe]
print @n.xbgr.xm45_u12.nsg13_hv_pmos[ctype]
print @n.xbgr.xm45_u13.nsg13_hv_pmos[ide]
print @n.xbgr.xm45_u13.nsg13_hv_pmos[ige]
print @n.xbgr.xm45_u13.nsg13_hv_pmos[ise]
print @n.xbgr.xm45_u13.nsg13_hv_pmos[ibe]
print @n.xbgr.xm45_u13.nsg13_hv_pmos[ctype]
print @n.xbgr.xm45_u14.nsg13_hv_pmos[ide]
print @n.xbgr.xm45_u14.nsg13_hv_pmos[ige]
print @n.xbgr.xm45_u14.nsg13_hv_pmos[ise]
print @n.xbgr.xm45_u14.nsg13_hv_pmos[ibe]
print @n.xbgr.xm45_u14.nsg13_hv_pmos[ctype]
print @n.xbgr.xm45_u15.nsg13_hv_pmos[ide]
print @n.xbgr.xm45_u15.nsg13_hv_pmos[ige]
print @n.xbgr.xm45_u15.nsg13_hv_pmos[ise]
print @n.xbgr.xm45_u15.nsg13_hv_pmos[ibe]
print @n.xbgr.xm45_u15.nsg13_hv_pmos[ctype]
print @n.xbgr.xm45_u16.nsg13_hv_pmos[ide]
print @n.xbgr.xm45_u16.nsg13_hv_pmos[ige]
print @n.xbgr.xm45_u16.nsg13_hv_pmos[ise]
print @n.xbgr.xm45_u16.nsg13_hv_pmos[ibe]
print @n.xbgr.xm45_u16.nsg13_hv_pmos[ctype]
print @n.xbgr.xm45_u17.nsg13_hv_pmos[ide]
print @n.xbgr.xm45_u17.nsg13_hv_pmos[ige]
print @n.xbgr.xm45_u17.nsg13_hv_pmos[ise]
print @n.xbgr.xm45_u17.nsg13_hv_pmos[ibe]
print @n.xbgr.xm45_u17.nsg13_hv_pmos[ctype]
print @n.xbgr.xm45_u18.nsg13_hv_pmos[ide]
print @n.xbgr.xm45_u18.nsg13_hv_pmos[ige]
print @n.xbgr.xm45_u18.nsg13_hv_pmos[ise]
print @n.xbgr.xm45_u18.nsg13_hv_pmos[ibe]
print @n.xbgr.xm45_u18.nsg13_hv_pmos[ctype]
print @n.xbgr.xm45_u19.nsg13_hv_pmos[ide]
print @n.xbgr.xm45_u19.nsg13_hv_pmos[ige]
print @n.xbgr.xm45_u19.nsg13_hv_pmos[ise]
print @n.xbgr.xm45_u19.nsg13_hv_pmos[ibe]
print @n.xbgr.xm45_u19.nsg13_hv_pmos[ctype]
print @n.xbgr.xm45_u20.nsg13_hv_pmos[ide]
print @n.xbgr.xm45_u20.nsg13_hv_pmos[ige]
print @n.xbgr.xm45_u20.nsg13_hv_pmos[ise]
print @n.xbgr.xm45_u20.nsg13_hv_pmos[ibe]
print @n.xbgr.xm45_u20.nsg13_hv_pmos[ctype]
print @n.xbgr.xm45_u21.nsg13_hv_pmos[ide]
print @n.xbgr.xm45_u21.nsg13_hv_pmos[ige]
print @n.xbgr.xm45_u21.nsg13_hv_pmos[ise]
print @n.xbgr.xm45_u21.nsg13_hv_pmos[ibe]
print @n.xbgr.xm45_u21.nsg13_hv_pmos[ctype]
print @n.xbgr.xm45_u22.nsg13_hv_pmos[ide]
print @n.xbgr.xm45_u22.nsg13_hv_pmos[ige]
print @n.xbgr.xm45_u22.nsg13_hv_pmos[ise]
print @n.xbgr.xm45_u22.nsg13_hv_pmos[ibe]
print @n.xbgr.xm45_u22.nsg13_hv_pmos[ctype]
print @n.xbgr.xm45_u23.nsg13_hv_pmos[ide]
print @n.xbgr.xm45_u23.nsg13_hv_pmos[ige]
print @n.xbgr.xm45_u23.nsg13_hv_pmos[ise]
print @n.xbgr.xm45_u23.nsg13_hv_pmos[ibe]
print @n.xbgr.xm45_u23.nsg13_hv_pmos[ctype]
print @n.xbgr.xm45_u24.nsg13_hv_pmos[ide]
print @n.xbgr.xm45_u24.nsg13_hv_pmos[ige]
print @n.xbgr.xm45_u24.nsg13_hv_pmos[ise]
print @n.xbgr.xm45_u24.nsg13_hv_pmos[ibe]
print @n.xbgr.xm45_u24.nsg13_hv_pmos[ctype]
print @n.xbgr.xm47_u2.nsg13_hv_pmos[ide]
print @n.xbgr.xm47_u2.nsg13_hv_pmos[ige]
print @n.xbgr.xm47_u2.nsg13_hv_pmos[ise]
print @n.xbgr.xm47_u2.nsg13_hv_pmos[ibe]
print @n.xbgr.xm47_u2.nsg13_hv_pmos[ctype]
print @n.xbgr.xm47_u3.nsg13_hv_pmos[ide]
print @n.xbgr.xm47_u3.nsg13_hv_pmos[ige]
print @n.xbgr.xm47_u3.nsg13_hv_pmos[ise]
print @n.xbgr.xm47_u3.nsg13_hv_pmos[ibe]
print @n.xbgr.xm47_u3.nsg13_hv_pmos[ctype]
print @n.xbgr.xm47_u4.nsg13_hv_pmos[ide]
print @n.xbgr.xm47_u4.nsg13_hv_pmos[ige]
print @n.xbgr.xm47_u4.nsg13_hv_pmos[ise]
print @n.xbgr.xm47_u4.nsg13_hv_pmos[ibe]
print @n.xbgr.xm47_u4.nsg13_hv_pmos[ctype]
print @n.xbgr.xm47_u5.nsg13_hv_pmos[ide]
print @n.xbgr.xm47_u5.nsg13_hv_pmos[ige]
print @n.xbgr.xm47_u5.nsg13_hv_pmos[ise]
print @n.xbgr.xm47_u5.nsg13_hv_pmos[ibe]
print @n.xbgr.xm47_u5.nsg13_hv_pmos[ctype]
print @n.xbgr.xm47_u6.nsg13_hv_pmos[ide]
print @n.xbgr.xm47_u6.nsg13_hv_pmos[ige]
print @n.xbgr.xm47_u6.nsg13_hv_pmos[ise]
print @n.xbgr.xm47_u6.nsg13_hv_pmos[ibe]
print @n.xbgr.xm47_u6.nsg13_hv_pmos[ctype]
print @n.xbgr.xm47_u7.nsg13_hv_pmos[ide]
print @n.xbgr.xm47_u7.nsg13_hv_pmos[ige]
print @n.xbgr.xm47_u7.nsg13_hv_pmos[ise]
print @n.xbgr.xm47_u7.nsg13_hv_pmos[ibe]
print @n.xbgr.xm47_u7.nsg13_hv_pmos[ctype]
print @n.xbgr.xm47_u8.nsg13_hv_pmos[ide]
print @n.xbgr.xm47_u8.nsg13_hv_pmos[ige]
print @n.xbgr.xm47_u8.nsg13_hv_pmos[ise]
print @n.xbgr.xm47_u8.nsg13_hv_pmos[ibe]
print @n.xbgr.xm47_u8.nsg13_hv_pmos[ctype]
print @n.xbgr.xm47_u9.nsg13_hv_pmos[ide]
print @n.xbgr.xm47_u9.nsg13_hv_pmos[ige]
print @n.xbgr.xm47_u9.nsg13_hv_pmos[ise]
print @n.xbgr.xm47_u9.nsg13_hv_pmos[ibe]
print @n.xbgr.xm47_u9.nsg13_hv_pmos[ctype]
print @n.xbgr.xm47_u10.nsg13_hv_pmos[ide]
print @n.xbgr.xm47_u10.nsg13_hv_pmos[ige]
print @n.xbgr.xm47_u10.nsg13_hv_pmos[ise]
print @n.xbgr.xm47_u10.nsg13_hv_pmos[ibe]
print @n.xbgr.xm47_u10.nsg13_hv_pmos[ctype]
print @n.xbgr.xm47_u11.nsg13_hv_pmos[ide]
print @n.xbgr.xm47_u11.nsg13_hv_pmos[ige]
print @n.xbgr.xm47_u11.nsg13_hv_pmos[ise]
print @n.xbgr.xm47_u11.nsg13_hv_pmos[ibe]
print @n.xbgr.xm47_u11.nsg13_hv_pmos[ctype]
print @n.xbgr.xm47_u12.nsg13_hv_pmos[ide]
print @n.xbgr.xm47_u12.nsg13_hv_pmos[ige]
print @n.xbgr.xm47_u12.nsg13_hv_pmos[ise]
print @n.xbgr.xm47_u12.nsg13_hv_pmos[ibe]
print @n.xbgr.xm47_u12.nsg13_hv_pmos[ctype]
print @n.xbgr.xm47_u13.nsg13_hv_pmos[ide]
print @n.xbgr.xm47_u13.nsg13_hv_pmos[ige]
print @n.xbgr.xm47_u13.nsg13_hv_pmos[ise]
print @n.xbgr.xm47_u13.nsg13_hv_pmos[ibe]
print @n.xbgr.xm47_u13.nsg13_hv_pmos[ctype]
print @n.xbgr.xm47_u14.nsg13_hv_pmos[ide]
print @n.xbgr.xm47_u14.nsg13_hv_pmos[ige]
print @n.xbgr.xm47_u14.nsg13_hv_pmos[ise]
print @n.xbgr.xm47_u14.nsg13_hv_pmos[ibe]
print @n.xbgr.xm47_u14.nsg13_hv_pmos[ctype]
print @n.xbgr.xm47_u15.nsg13_hv_pmos[ide]
print @n.xbgr.xm47_u15.nsg13_hv_pmos[ige]
print @n.xbgr.xm47_u15.nsg13_hv_pmos[ise]
print @n.xbgr.xm47_u15.nsg13_hv_pmos[ibe]
print @n.xbgr.xm47_u15.nsg13_hv_pmos[ctype]
print @n.xbgr.xm47_u16.nsg13_hv_pmos[ide]
print @n.xbgr.xm47_u16.nsg13_hv_pmos[ige]
print @n.xbgr.xm47_u16.nsg13_hv_pmos[ise]
print @n.xbgr.xm47_u16.nsg13_hv_pmos[ibe]
print @n.xbgr.xm47_u16.nsg13_hv_pmos[ctype]
print @n.xbgr.xm47_u17.nsg13_hv_pmos[ide]
print @n.xbgr.xm47_u17.nsg13_hv_pmos[ige]
print @n.xbgr.xm47_u17.nsg13_hv_pmos[ise]
print @n.xbgr.xm47_u17.nsg13_hv_pmos[ibe]
print @n.xbgr.xm47_u17.nsg13_hv_pmos[ctype]
print @n.xbgr.xm47_u18.nsg13_hv_pmos[ide]
print @n.xbgr.xm47_u18.nsg13_hv_pmos[ige]
print @n.xbgr.xm47_u18.nsg13_hv_pmos[ise]
print @n.xbgr.xm47_u18.nsg13_hv_pmos[ibe]
print @n.xbgr.xm47_u18.nsg13_hv_pmos[ctype]
print @n.xbgr.xm47_u19.nsg13_hv_pmos[ide]
print @n.xbgr.xm47_u19.nsg13_hv_pmos[ige]
print @n.xbgr.xm47_u19.nsg13_hv_pmos[ise]
print @n.xbgr.xm47_u19.nsg13_hv_pmos[ibe]
print @n.xbgr.xm47_u19.nsg13_hv_pmos[ctype]
print @n.xbgr.xm47_u20.nsg13_hv_pmos[ide]
print @n.xbgr.xm47_u20.nsg13_hv_pmos[ige]
print @n.xbgr.xm47_u20.nsg13_hv_pmos[ise]
print @n.xbgr.xm47_u20.nsg13_hv_pmos[ibe]
print @n.xbgr.xm47_u20.nsg13_hv_pmos[ctype]
print @n.xbgr.xm47_u21.nsg13_hv_pmos[ide]
print @n.xbgr.xm47_u21.nsg13_hv_pmos[ige]
print @n.xbgr.xm47_u21.nsg13_hv_pmos[ise]
print @n.xbgr.xm47_u21.nsg13_hv_pmos[ibe]
print @n.xbgr.xm47_u21.nsg13_hv_pmos[ctype]
print @n.xbgr.xm47_u22.nsg13_hv_pmos[ide]
print @n.xbgr.xm47_u22.nsg13_hv_pmos[ige]
print @n.xbgr.xm47_u22.nsg13_hv_pmos[ise]
print @n.xbgr.xm47_u22.nsg13_hv_pmos[ibe]
print @n.xbgr.xm47_u22.nsg13_hv_pmos[ctype]
print @n.xbgr.xm47_u23.nsg13_hv_pmos[ide]
print @n.xbgr.xm47_u23.nsg13_hv_pmos[ige]
print @n.xbgr.xm47_u23.nsg13_hv_pmos[ise]
print @n.xbgr.xm47_u23.nsg13_hv_pmos[ibe]
print @n.xbgr.xm47_u23.nsg13_hv_pmos[ctype]
print @n.xbgr.xm47_u24.nsg13_hv_pmos[ide]
print @n.xbgr.xm47_u24.nsg13_hv_pmos[ige]
print @n.xbgr.xm47_u24.nsg13_hv_pmos[ise]
print @n.xbgr.xm47_u24.nsg13_hv_pmos[ibe]
print @n.xbgr.xm47_u24.nsg13_hv_pmos[ctype]
print @n.xbgr.xm48_u2.nsg13_hv_pmos[ide]
print @n.xbgr.xm48_u2.nsg13_hv_pmos[ige]
print @n.xbgr.xm48_u2.nsg13_hv_pmos[ise]
print @n.xbgr.xm48_u2.nsg13_hv_pmos[ibe]
print @n.xbgr.xm48_u2.nsg13_hv_pmos[ctype]
print @n.xbgr.xm48_u3.nsg13_hv_pmos[ide]
print @n.xbgr.xm48_u3.nsg13_hv_pmos[ige]
print @n.xbgr.xm48_u3.nsg13_hv_pmos[ise]
print @n.xbgr.xm48_u3.nsg13_hv_pmos[ibe]
print @n.xbgr.xm48_u3.nsg13_hv_pmos[ctype]
print @n.xbgr.xm48_u4.nsg13_hv_pmos[ide]
print @n.xbgr.xm48_u4.nsg13_hv_pmos[ige]
print @n.xbgr.xm48_u4.nsg13_hv_pmos[ise]
print @n.xbgr.xm48_u4.nsg13_hv_pmos[ibe]
print @n.xbgr.xm48_u4.nsg13_hv_pmos[ctype]
print @n.xbgr.xm48_u5.nsg13_hv_pmos[ide]
print @n.xbgr.xm48_u5.nsg13_hv_pmos[ige]
print @n.xbgr.xm48_u5.nsg13_hv_pmos[ise]
print @n.xbgr.xm48_u5.nsg13_hv_pmos[ibe]
print @n.xbgr.xm48_u5.nsg13_hv_pmos[ctype]
print @n.xbgr.xm48_u6.nsg13_hv_pmos[ide]
print @n.xbgr.xm48_u6.nsg13_hv_pmos[ige]
print @n.xbgr.xm48_u6.nsg13_hv_pmos[ise]
print @n.xbgr.xm48_u6.nsg13_hv_pmos[ibe]
print @n.xbgr.xm48_u6.nsg13_hv_pmos[ctype]
print @n.xbgr.xm48_u7.nsg13_hv_pmos[ide]
print @n.xbgr.xm48_u7.nsg13_hv_pmos[ige]
print @n.xbgr.xm48_u7.nsg13_hv_pmos[ise]
print @n.xbgr.xm48_u7.nsg13_hv_pmos[ibe]
print @n.xbgr.xm48_u7.nsg13_hv_pmos[ctype]
print @n.xbgr.xm48_u8.nsg13_hv_pmos[ide]
print @n.xbgr.xm48_u8.nsg13_hv_pmos[ige]
print @n.xbgr.xm48_u8.nsg13_hv_pmos[ise]
print @n.xbgr.xm48_u8.nsg13_hv_pmos[ibe]
print @n.xbgr.xm48_u8.nsg13_hv_pmos[ctype]
print @n.xbgr.xm48_u9.nsg13_hv_pmos[ide]
print @n.xbgr.xm48_u9.nsg13_hv_pmos[ige]
print @n.xbgr.xm48_u9.nsg13_hv_pmos[ise]
print @n.xbgr.xm48_u9.nsg13_hv_pmos[ibe]
print @n.xbgr.xm48_u9.nsg13_hv_pmos[ctype]
print @n.xbgr.xm48_u10.nsg13_hv_pmos[ide]
print @n.xbgr.xm48_u10.nsg13_hv_pmos[ige]
print @n.xbgr.xm48_u10.nsg13_hv_pmos[ise]
print @n.xbgr.xm48_u10.nsg13_hv_pmos[ibe]
print @n.xbgr.xm48_u10.nsg13_hv_pmos[ctype]
print @n.xbgr.xm48_u11.nsg13_hv_pmos[ide]
print @n.xbgr.xm48_u11.nsg13_hv_pmos[ige]
print @n.xbgr.xm48_u11.nsg13_hv_pmos[ise]
print @n.xbgr.xm48_u11.nsg13_hv_pmos[ibe]
print @n.xbgr.xm48_u11.nsg13_hv_pmos[ctype]
print @n.xbgr.xm48_u12.nsg13_hv_pmos[ide]
print @n.xbgr.xm48_u12.nsg13_hv_pmos[ige]
print @n.xbgr.xm48_u12.nsg13_hv_pmos[ise]
print @n.xbgr.xm48_u12.nsg13_hv_pmos[ibe]
print @n.xbgr.xm48_u12.nsg13_hv_pmos[ctype]
print @n.xbgr.xm48_u13.nsg13_hv_pmos[ide]
print @n.xbgr.xm48_u13.nsg13_hv_pmos[ige]
print @n.xbgr.xm48_u13.nsg13_hv_pmos[ise]
print @n.xbgr.xm48_u13.nsg13_hv_pmos[ibe]
print @n.xbgr.xm48_u13.nsg13_hv_pmos[ctype]
print @n.xbgr.xm48_u14.nsg13_hv_pmos[ide]
print @n.xbgr.xm48_u14.nsg13_hv_pmos[ige]
print @n.xbgr.xm48_u14.nsg13_hv_pmos[ise]
print @n.xbgr.xm48_u14.nsg13_hv_pmos[ibe]
print @n.xbgr.xm48_u14.nsg13_hv_pmos[ctype]
print @n.xbgr.xm48_u15.nsg13_hv_pmos[ide]
print @n.xbgr.xm48_u15.nsg13_hv_pmos[ige]
print @n.xbgr.xm48_u15.nsg13_hv_pmos[ise]
print @n.xbgr.xm48_u15.nsg13_hv_pmos[ibe]
print @n.xbgr.xm48_u15.nsg13_hv_pmos[ctype]
print @n.xbgr.xm48_u16.nsg13_hv_pmos[ide]
print @n.xbgr.xm48_u16.nsg13_hv_pmos[ige]
print @n.xbgr.xm48_u16.nsg13_hv_pmos[ise]
print @n.xbgr.xm48_u16.nsg13_hv_pmos[ibe]
print @n.xbgr.xm48_u16.nsg13_hv_pmos[ctype]
print @n.xbgr.xm48_u17.nsg13_hv_pmos[ide]
print @n.xbgr.xm48_u17.nsg13_hv_pmos[ige]
print @n.xbgr.xm48_u17.nsg13_hv_pmos[ise]
print @n.xbgr.xm48_u17.nsg13_hv_pmos[ibe]
print @n.xbgr.xm48_u17.nsg13_hv_pmos[ctype]
print @n.xbgr.xm48_u18.nsg13_hv_pmos[ide]
print @n.xbgr.xm48_u18.nsg13_hv_pmos[ige]
print @n.xbgr.xm48_u18.nsg13_hv_pmos[ise]
print @n.xbgr.xm48_u18.nsg13_hv_pmos[ibe]
print @n.xbgr.xm48_u18.nsg13_hv_pmos[ctype]
print @n.xbgr.xm48_u19.nsg13_hv_pmos[ide]
print @n.xbgr.xm48_u19.nsg13_hv_pmos[ige]
print @n.xbgr.xm48_u19.nsg13_hv_pmos[ise]
print @n.xbgr.xm48_u19.nsg13_hv_pmos[ibe]
print @n.xbgr.xm48_u19.nsg13_hv_pmos[ctype]
print @n.xbgr.xm48_u20.nsg13_hv_pmos[ide]
print @n.xbgr.xm48_u20.nsg13_hv_pmos[ige]
print @n.xbgr.xm48_u20.nsg13_hv_pmos[ise]
print @n.xbgr.xm48_u20.nsg13_hv_pmos[ibe]
print @n.xbgr.xm48_u20.nsg13_hv_pmos[ctype]
print @n.xbgr.xm48_u21.nsg13_hv_pmos[ide]
print @n.xbgr.xm48_u21.nsg13_hv_pmos[ige]
print @n.xbgr.xm48_u21.nsg13_hv_pmos[ise]
print @n.xbgr.xm48_u21.nsg13_hv_pmos[ibe]
print @n.xbgr.xm48_u21.nsg13_hv_pmos[ctype]
print @n.xbgr.xm48_u22.nsg13_hv_pmos[ide]
print @n.xbgr.xm48_u22.nsg13_hv_pmos[ige]
print @n.xbgr.xm48_u22.nsg13_hv_pmos[ise]
print @n.xbgr.xm48_u22.nsg13_hv_pmos[ibe]
print @n.xbgr.xm48_u22.nsg13_hv_pmos[ctype]
print @n.xbgr.xm48_u23.nsg13_hv_pmos[ide]
print @n.xbgr.xm48_u23.nsg13_hv_pmos[ige]
print @n.xbgr.xm48_u23.nsg13_hv_pmos[ise]
print @n.xbgr.xm48_u23.nsg13_hv_pmos[ibe]
print @n.xbgr.xm48_u23.nsg13_hv_pmos[ctype]
print @n.xbgr.xm48_u24.nsg13_hv_pmos[ide]
print @n.xbgr.xm48_u24.nsg13_hv_pmos[ige]
print @n.xbgr.xm48_u24.nsg13_hv_pmos[ise]
print @n.xbgr.xm48_u24.nsg13_hv_pmos[ibe]
print @n.xbgr.xm48_u24.nsg13_hv_pmos[ctype]
print @n.xbgr.xm50_u2.nsg13_hv_pmos[ide]
print @n.xbgr.xm50_u2.nsg13_hv_pmos[ige]
print @n.xbgr.xm50_u2.nsg13_hv_pmos[ise]
print @n.xbgr.xm50_u2.nsg13_hv_pmos[ibe]
print @n.xbgr.xm50_u2.nsg13_hv_pmos[ctype]
print @n.xbgr.xm50_u3.nsg13_hv_pmos[ide]
print @n.xbgr.xm50_u3.nsg13_hv_pmos[ige]
print @n.xbgr.xm50_u3.nsg13_hv_pmos[ise]
print @n.xbgr.xm50_u3.nsg13_hv_pmos[ibe]
print @n.xbgr.xm50_u3.nsg13_hv_pmos[ctype]
print @n.xbgr.xm50_u4.nsg13_hv_pmos[ide]
print @n.xbgr.xm50_u4.nsg13_hv_pmos[ige]
print @n.xbgr.xm50_u4.nsg13_hv_pmos[ise]
print @n.xbgr.xm50_u4.nsg13_hv_pmos[ibe]
print @n.xbgr.xm50_u4.nsg13_hv_pmos[ctype]
print @n.xbgr.xm50_u5.nsg13_hv_pmos[ide]
print @n.xbgr.xm50_u5.nsg13_hv_pmos[ige]
print @n.xbgr.xm50_u5.nsg13_hv_pmos[ise]
print @n.xbgr.xm50_u5.nsg13_hv_pmos[ibe]
print @n.xbgr.xm50_u5.nsg13_hv_pmos[ctype]
print @n.xbgr.xm50_u6.nsg13_hv_pmos[ide]
print @n.xbgr.xm50_u6.nsg13_hv_pmos[ige]
print @n.xbgr.xm50_u6.nsg13_hv_pmos[ise]
print @n.xbgr.xm50_u6.nsg13_hv_pmos[ibe]
print @n.xbgr.xm50_u6.nsg13_hv_pmos[ctype]
print @n.xbgr.xm50_u7.nsg13_hv_pmos[ide]
print @n.xbgr.xm50_u7.nsg13_hv_pmos[ige]
print @n.xbgr.xm50_u7.nsg13_hv_pmos[ise]
print @n.xbgr.xm50_u7.nsg13_hv_pmos[ibe]
print @n.xbgr.xm50_u7.nsg13_hv_pmos[ctype]
print @n.xbgr.xm50_u8.nsg13_hv_pmos[ide]
print @n.xbgr.xm50_u8.nsg13_hv_pmos[ige]
print @n.xbgr.xm50_u8.nsg13_hv_pmos[ise]
print @n.xbgr.xm50_u8.nsg13_hv_pmos[ibe]
print @n.xbgr.xm50_u8.nsg13_hv_pmos[ctype]
print @n.xbgr.xm50_u9.nsg13_hv_pmos[ide]
print @n.xbgr.xm50_u9.nsg13_hv_pmos[ige]
print @n.xbgr.xm50_u9.nsg13_hv_pmos[ise]
print @n.xbgr.xm50_u9.nsg13_hv_pmos[ibe]
print @n.xbgr.xm50_u9.nsg13_hv_pmos[ctype]
print @n.xbgr.xm50_u10.nsg13_hv_pmos[ide]
print @n.xbgr.xm50_u10.nsg13_hv_pmos[ige]
print @n.xbgr.xm50_u10.nsg13_hv_pmos[ise]
print @n.xbgr.xm50_u10.nsg13_hv_pmos[ibe]
print @n.xbgr.xm50_u10.nsg13_hv_pmos[ctype]
print @n.xbgr.xm50_u11.nsg13_hv_pmos[ide]
print @n.xbgr.xm50_u11.nsg13_hv_pmos[ige]
print @n.xbgr.xm50_u11.nsg13_hv_pmos[ise]
print @n.xbgr.xm50_u11.nsg13_hv_pmos[ibe]
print @n.xbgr.xm50_u11.nsg13_hv_pmos[ctype]
print @n.xbgr.xm50_u12.nsg13_hv_pmos[ide]
print @n.xbgr.xm50_u12.nsg13_hv_pmos[ige]
print @n.xbgr.xm50_u12.nsg13_hv_pmos[ise]
print @n.xbgr.xm50_u12.nsg13_hv_pmos[ibe]
print @n.xbgr.xm50_u12.nsg13_hv_pmos[ctype]
print @n.xbgr.xm50_u13.nsg13_hv_pmos[ide]
print @n.xbgr.xm50_u13.nsg13_hv_pmos[ige]
print @n.xbgr.xm50_u13.nsg13_hv_pmos[ise]
print @n.xbgr.xm50_u13.nsg13_hv_pmos[ibe]
print @n.xbgr.xm50_u13.nsg13_hv_pmos[ctype]
print @n.xbgr.xm50_u14.nsg13_hv_pmos[ide]
print @n.xbgr.xm50_u14.nsg13_hv_pmos[ige]
print @n.xbgr.xm50_u14.nsg13_hv_pmos[ise]
print @n.xbgr.xm50_u14.nsg13_hv_pmos[ibe]
print @n.xbgr.xm50_u14.nsg13_hv_pmos[ctype]
print @n.xbgr.xm50_u15.nsg13_hv_pmos[ide]
print @n.xbgr.xm50_u15.nsg13_hv_pmos[ige]
print @n.xbgr.xm50_u15.nsg13_hv_pmos[ise]
print @n.xbgr.xm50_u15.nsg13_hv_pmos[ibe]
print @n.xbgr.xm50_u15.nsg13_hv_pmos[ctype]
print @n.xbgr.xm50_u16.nsg13_hv_pmos[ide]
print @n.xbgr.xm50_u16.nsg13_hv_pmos[ige]
print @n.xbgr.xm50_u16.nsg13_hv_pmos[ise]
print @n.xbgr.xm50_u16.nsg13_hv_pmos[ibe]
print @n.xbgr.xm50_u16.nsg13_hv_pmos[ctype]
print @n.xbgr.xm50_u17.nsg13_hv_pmos[ide]
print @n.xbgr.xm50_u17.nsg13_hv_pmos[ige]
print @n.xbgr.xm50_u17.nsg13_hv_pmos[ise]
print @n.xbgr.xm50_u17.nsg13_hv_pmos[ibe]
print @n.xbgr.xm50_u17.nsg13_hv_pmos[ctype]
print @n.xbgr.xm50_u18.nsg13_hv_pmos[ide]
print @n.xbgr.xm50_u18.nsg13_hv_pmos[ige]
print @n.xbgr.xm50_u18.nsg13_hv_pmos[ise]
print @n.xbgr.xm50_u18.nsg13_hv_pmos[ibe]
print @n.xbgr.xm50_u18.nsg13_hv_pmos[ctype]
print @n.xbgr.xm50_u19.nsg13_hv_pmos[ide]
print @n.xbgr.xm50_u19.nsg13_hv_pmos[ige]
print @n.xbgr.xm50_u19.nsg13_hv_pmos[ise]
print @n.xbgr.xm50_u19.nsg13_hv_pmos[ibe]
print @n.xbgr.xm50_u19.nsg13_hv_pmos[ctype]
print @n.xbgr.xm50_u20.nsg13_hv_pmos[ide]
print @n.xbgr.xm50_u20.nsg13_hv_pmos[ige]
print @n.xbgr.xm50_u20.nsg13_hv_pmos[ise]
print @n.xbgr.xm50_u20.nsg13_hv_pmos[ibe]
print @n.xbgr.xm50_u20.nsg13_hv_pmos[ctype]
print @n.xbgr.xm50_u21.nsg13_hv_pmos[ide]
print @n.xbgr.xm50_u21.nsg13_hv_pmos[ige]
print @n.xbgr.xm50_u21.nsg13_hv_pmos[ise]
print @n.xbgr.xm50_u21.nsg13_hv_pmos[ibe]
print @n.xbgr.xm50_u21.nsg13_hv_pmos[ctype]
print @n.xbgr.xm50_u22.nsg13_hv_pmos[ide]
print @n.xbgr.xm50_u22.nsg13_hv_pmos[ige]
print @n.xbgr.xm50_u22.nsg13_hv_pmos[ise]
print @n.xbgr.xm50_u22.nsg13_hv_pmos[ibe]
print @n.xbgr.xm50_u22.nsg13_hv_pmos[ctype]
print @n.xbgr.xm50_u23.nsg13_hv_pmos[ide]
print @n.xbgr.xm50_u23.nsg13_hv_pmos[ige]
print @n.xbgr.xm50_u23.nsg13_hv_pmos[ise]
print @n.xbgr.xm50_u23.nsg13_hv_pmos[ibe]
print @n.xbgr.xm50_u23.nsg13_hv_pmos[ctype]
print @n.xbgr.xm50_u24.nsg13_hv_pmos[ide]
print @n.xbgr.xm50_u24.nsg13_hv_pmos[ige]
print @n.xbgr.xm50_u24.nsg13_hv_pmos[ise]
print @n.xbgr.xm50_u24.nsg13_hv_pmos[ibe]
print @n.xbgr.xm50_u24.nsg13_hv_pmos[ctype]
print @n.xbgr.xm51_u2.nsg13_hv_pmos[ide]
print @n.xbgr.xm51_u2.nsg13_hv_pmos[ige]
print @n.xbgr.xm51_u2.nsg13_hv_pmos[ise]
print @n.xbgr.xm51_u2.nsg13_hv_pmos[ibe]
print @n.xbgr.xm51_u2.nsg13_hv_pmos[ctype]
print @n.xbgr.xm51_u3.nsg13_hv_pmos[ide]
print @n.xbgr.xm51_u3.nsg13_hv_pmos[ige]
print @n.xbgr.xm51_u3.nsg13_hv_pmos[ise]
print @n.xbgr.xm51_u3.nsg13_hv_pmos[ibe]
print @n.xbgr.xm51_u3.nsg13_hv_pmos[ctype]
print @n.xbgr.xm51_u4.nsg13_hv_pmos[ide]
print @n.xbgr.xm51_u4.nsg13_hv_pmos[ige]
print @n.xbgr.xm51_u4.nsg13_hv_pmos[ise]
print @n.xbgr.xm51_u4.nsg13_hv_pmos[ibe]
print @n.xbgr.xm51_u4.nsg13_hv_pmos[ctype]
print @n.xbgr.xm52_u2.nsg13_hv_pmos[ide]
print @n.xbgr.xm52_u2.nsg13_hv_pmos[ige]
print @n.xbgr.xm52_u2.nsg13_hv_pmos[ise]
print @n.xbgr.xm52_u2.nsg13_hv_pmos[ibe]
print @n.xbgr.xm52_u2.nsg13_hv_pmos[ctype]
print @n.xbgr.xm52_u3.nsg13_hv_pmos[ide]
print @n.xbgr.xm52_u3.nsg13_hv_pmos[ige]
print @n.xbgr.xm52_u3.nsg13_hv_pmos[ise]
print @n.xbgr.xm52_u3.nsg13_hv_pmos[ibe]
print @n.xbgr.xm52_u3.nsg13_hv_pmos[ctype]
print @n.xbgr.xm52_u4.nsg13_hv_pmos[ide]
print @n.xbgr.xm52_u4.nsg13_hv_pmos[ige]
print @n.xbgr.xm52_u4.nsg13_hv_pmos[ise]
print @n.xbgr.xm52_u4.nsg13_hv_pmos[ibe]
print @n.xbgr.xm52_u4.nsg13_hv_pmos[ctype]
print @n.xbgr.xm52_u5.nsg13_hv_pmos[ide]
print @n.xbgr.xm52_u5.nsg13_hv_pmos[ige]
print @n.xbgr.xm52_u5.nsg13_hv_pmos[ise]
print @n.xbgr.xm52_u5.nsg13_hv_pmos[ibe]
print @n.xbgr.xm52_u5.nsg13_hv_pmos[ctype]
print @n.xbgr.xm52_u6.nsg13_hv_pmos[ide]
print @n.xbgr.xm52_u6.nsg13_hv_pmos[ige]
print @n.xbgr.xm52_u6.nsg13_hv_pmos[ise]
print @n.xbgr.xm52_u6.nsg13_hv_pmos[ibe]
print @n.xbgr.xm52_u6.nsg13_hv_pmos[ctype]
print @n.xbgr.xm52_u7.nsg13_hv_pmos[ide]
print @n.xbgr.xm52_u7.nsg13_hv_pmos[ige]
print @n.xbgr.xm52_u7.nsg13_hv_pmos[ise]
print @n.xbgr.xm52_u7.nsg13_hv_pmos[ibe]
print @n.xbgr.xm52_u7.nsg13_hv_pmos[ctype]
print @n.xbgr.xm52_u8.nsg13_hv_pmos[ide]
print @n.xbgr.xm52_u8.nsg13_hv_pmos[ige]
print @n.xbgr.xm52_u8.nsg13_hv_pmos[ise]
print @n.xbgr.xm52_u8.nsg13_hv_pmos[ibe]
print @n.xbgr.xm52_u8.nsg13_hv_pmos[ctype]
print @n.xbgr.xm52_u9.nsg13_hv_pmos[ide]
print @n.xbgr.xm52_u9.nsg13_hv_pmos[ige]
print @n.xbgr.xm52_u9.nsg13_hv_pmos[ise]
print @n.xbgr.xm52_u9.nsg13_hv_pmos[ibe]
print @n.xbgr.xm52_u9.nsg13_hv_pmos[ctype]
print @n.xbgr.xm52_u10.nsg13_hv_pmos[ide]
print @n.xbgr.xm52_u10.nsg13_hv_pmos[ige]
print @n.xbgr.xm52_u10.nsg13_hv_pmos[ise]
print @n.xbgr.xm52_u10.nsg13_hv_pmos[ibe]
print @n.xbgr.xm52_u10.nsg13_hv_pmos[ctype]
print @n.xbgr.xm52_u11.nsg13_hv_pmos[ide]
print @n.xbgr.xm52_u11.nsg13_hv_pmos[ige]
print @n.xbgr.xm52_u11.nsg13_hv_pmos[ise]
print @n.xbgr.xm52_u11.nsg13_hv_pmos[ibe]
print @n.xbgr.xm52_u11.nsg13_hv_pmos[ctype]
print @n.xbgr.xm52_u12.nsg13_hv_pmos[ide]
print @n.xbgr.xm52_u12.nsg13_hv_pmos[ige]
print @n.xbgr.xm52_u12.nsg13_hv_pmos[ise]
print @n.xbgr.xm52_u12.nsg13_hv_pmos[ibe]
print @n.xbgr.xm52_u12.nsg13_hv_pmos[ctype]
print @n.xbgr.xm52_u13.nsg13_hv_pmos[ide]
print @n.xbgr.xm52_u13.nsg13_hv_pmos[ige]
print @n.xbgr.xm52_u13.nsg13_hv_pmos[ise]
print @n.xbgr.xm52_u13.nsg13_hv_pmos[ibe]
print @n.xbgr.xm52_u13.nsg13_hv_pmos[ctype]
print @n.xbgr.xm52_u14.nsg13_hv_pmos[ide]
print @n.xbgr.xm52_u14.nsg13_hv_pmos[ige]
print @n.xbgr.xm52_u14.nsg13_hv_pmos[ise]
print @n.xbgr.xm52_u14.nsg13_hv_pmos[ibe]
print @n.xbgr.xm52_u14.nsg13_hv_pmos[ctype]
print @n.xbgr.xm52_u15.nsg13_hv_pmos[ide]
print @n.xbgr.xm52_u15.nsg13_hv_pmos[ige]
print @n.xbgr.xm52_u15.nsg13_hv_pmos[ise]
print @n.xbgr.xm52_u15.nsg13_hv_pmos[ibe]
print @n.xbgr.xm52_u15.nsg13_hv_pmos[ctype]
print @n.xbgr.xm52_u16.nsg13_hv_pmos[ide]
print @n.xbgr.xm52_u16.nsg13_hv_pmos[ige]
print @n.xbgr.xm52_u16.nsg13_hv_pmos[ise]
print @n.xbgr.xm52_u16.nsg13_hv_pmos[ibe]
print @n.xbgr.xm52_u16.nsg13_hv_pmos[ctype]
print @n.xbgr.xm52_u17.nsg13_hv_pmos[ide]
print @n.xbgr.xm52_u17.nsg13_hv_pmos[ige]
print @n.xbgr.xm52_u17.nsg13_hv_pmos[ise]
print @n.xbgr.xm52_u17.nsg13_hv_pmos[ibe]
print @n.xbgr.xm52_u17.nsg13_hv_pmos[ctype]
print @n.xbgr.xm52_u18.nsg13_hv_pmos[ide]
print @n.xbgr.xm52_u18.nsg13_hv_pmos[ige]
print @n.xbgr.xm52_u18.nsg13_hv_pmos[ise]
print @n.xbgr.xm52_u18.nsg13_hv_pmos[ibe]
print @n.xbgr.xm52_u18.nsg13_hv_pmos[ctype]
print @n.xbgr.xm52_u19.nsg13_hv_pmos[ide]
print @n.xbgr.xm52_u19.nsg13_hv_pmos[ige]
print @n.xbgr.xm52_u19.nsg13_hv_pmos[ise]
print @n.xbgr.xm52_u19.nsg13_hv_pmos[ibe]
print @n.xbgr.xm52_u19.nsg13_hv_pmos[ctype]
print @n.xbgr.xm52_u20.nsg13_hv_pmos[ide]
print @n.xbgr.xm52_u20.nsg13_hv_pmos[ige]
print @n.xbgr.xm52_u20.nsg13_hv_pmos[ise]
print @n.xbgr.xm52_u20.nsg13_hv_pmos[ibe]
print @n.xbgr.xm52_u20.nsg13_hv_pmos[ctype]
print @n.xbgr.xm52_u21.nsg13_hv_pmos[ide]
print @n.xbgr.xm52_u21.nsg13_hv_pmos[ige]
print @n.xbgr.xm52_u21.nsg13_hv_pmos[ise]
print @n.xbgr.xm52_u21.nsg13_hv_pmos[ibe]
print @n.xbgr.xm52_u21.nsg13_hv_pmos[ctype]
print @n.xbgr.xm52_u22.nsg13_hv_pmos[ide]
print @n.xbgr.xm52_u22.nsg13_hv_pmos[ige]
print @n.xbgr.xm52_u22.nsg13_hv_pmos[ise]
print @n.xbgr.xm52_u22.nsg13_hv_pmos[ibe]
print @n.xbgr.xm52_u22.nsg13_hv_pmos[ctype]
print @n.xbgr.xm52_u23.nsg13_hv_pmos[ide]
print @n.xbgr.xm52_u23.nsg13_hv_pmos[ige]
print @n.xbgr.xm52_u23.nsg13_hv_pmos[ise]
print @n.xbgr.xm52_u23.nsg13_hv_pmos[ibe]
print @n.xbgr.xm52_u23.nsg13_hv_pmos[ctype]
print @n.xbgr.xm52_u24.nsg13_hv_pmos[ide]
print @n.xbgr.xm52_u24.nsg13_hv_pmos[ige]
print @n.xbgr.xm52_u24.nsg13_hv_pmos[ise]
print @n.xbgr.xm52_u24.nsg13_hv_pmos[ibe]
print @n.xbgr.xm52_u24.nsg13_hv_pmos[ctype]
print @n.xbgr.xm54_u2.nsg13_hv_pmos[ide]
print @n.xbgr.xm54_u2.nsg13_hv_pmos[ige]
print @n.xbgr.xm54_u2.nsg13_hv_pmos[ise]
print @n.xbgr.xm54_u2.nsg13_hv_pmos[ibe]
print @n.xbgr.xm54_u2.nsg13_hv_pmos[ctype]
print @n.xbgr.xm54_u3.nsg13_hv_pmos[ide]
print @n.xbgr.xm54_u3.nsg13_hv_pmos[ige]
print @n.xbgr.xm54_u3.nsg13_hv_pmos[ise]
print @n.xbgr.xm54_u3.nsg13_hv_pmos[ibe]
print @n.xbgr.xm54_u3.nsg13_hv_pmos[ctype]
print @n.xbgr.xm54_u4.nsg13_hv_pmos[ide]
print @n.xbgr.xm54_u4.nsg13_hv_pmos[ige]
print @n.xbgr.xm54_u4.nsg13_hv_pmos[ise]
print @n.xbgr.xm54_u4.nsg13_hv_pmos[ibe]
print @n.xbgr.xm54_u4.nsg13_hv_pmos[ctype]
print @n.xbgr.xm54_u5.nsg13_hv_pmos[ide]
print @n.xbgr.xm54_u5.nsg13_hv_pmos[ige]
print @n.xbgr.xm54_u5.nsg13_hv_pmos[ise]
print @n.xbgr.xm54_u5.nsg13_hv_pmos[ibe]
print @n.xbgr.xm54_u5.nsg13_hv_pmos[ctype]
print @n.xbgr.xm54_u6.nsg13_hv_pmos[ide]
print @n.xbgr.xm54_u6.nsg13_hv_pmos[ige]
print @n.xbgr.xm54_u6.nsg13_hv_pmos[ise]
print @n.xbgr.xm54_u6.nsg13_hv_pmos[ibe]
print @n.xbgr.xm54_u6.nsg13_hv_pmos[ctype]
print @n.xbgr.xm54_u7.nsg13_hv_pmos[ide]
print @n.xbgr.xm54_u7.nsg13_hv_pmos[ige]
print @n.xbgr.xm54_u7.nsg13_hv_pmos[ise]
print @n.xbgr.xm54_u7.nsg13_hv_pmos[ibe]
print @n.xbgr.xm54_u7.nsg13_hv_pmos[ctype]
print @n.xbgr.xm54_u8.nsg13_hv_pmos[ide]
print @n.xbgr.xm54_u8.nsg13_hv_pmos[ige]
print @n.xbgr.xm54_u8.nsg13_hv_pmos[ise]
print @n.xbgr.xm54_u8.nsg13_hv_pmos[ibe]
print @n.xbgr.xm54_u8.nsg13_hv_pmos[ctype]
print @n.xbgr.xm54_u9.nsg13_hv_pmos[ide]
print @n.xbgr.xm54_u9.nsg13_hv_pmos[ige]
print @n.xbgr.xm54_u9.nsg13_hv_pmos[ise]
print @n.xbgr.xm54_u9.nsg13_hv_pmos[ibe]
print @n.xbgr.xm54_u9.nsg13_hv_pmos[ctype]
print @n.xbgr.xm54_u10.nsg13_hv_pmos[ide]
print @n.xbgr.xm54_u10.nsg13_hv_pmos[ige]
print @n.xbgr.xm54_u10.nsg13_hv_pmos[ise]
print @n.xbgr.xm54_u10.nsg13_hv_pmos[ibe]
print @n.xbgr.xm54_u10.nsg13_hv_pmos[ctype]
print @n.xbgr.xm54_u11.nsg13_hv_pmos[ide]
print @n.xbgr.xm54_u11.nsg13_hv_pmos[ige]
print @n.xbgr.xm54_u11.nsg13_hv_pmos[ise]
print @n.xbgr.xm54_u11.nsg13_hv_pmos[ibe]
print @n.xbgr.xm54_u11.nsg13_hv_pmos[ctype]
print @n.xbgr.xm54_u12.nsg13_hv_pmos[ide]
print @n.xbgr.xm54_u12.nsg13_hv_pmos[ige]
print @n.xbgr.xm54_u12.nsg13_hv_pmos[ise]
print @n.xbgr.xm54_u12.nsg13_hv_pmos[ibe]
print @n.xbgr.xm54_u12.nsg13_hv_pmos[ctype]
print @n.xbgr.xm54_u13.nsg13_hv_pmos[ide]
print @n.xbgr.xm54_u13.nsg13_hv_pmos[ige]
print @n.xbgr.xm54_u13.nsg13_hv_pmos[ise]
print @n.xbgr.xm54_u13.nsg13_hv_pmos[ibe]
print @n.xbgr.xm54_u13.nsg13_hv_pmos[ctype]
print @n.xbgr.xm54_u14.nsg13_hv_pmos[ide]
print @n.xbgr.xm54_u14.nsg13_hv_pmos[ige]
print @n.xbgr.xm54_u14.nsg13_hv_pmos[ise]
print @n.xbgr.xm54_u14.nsg13_hv_pmos[ibe]
print @n.xbgr.xm54_u14.nsg13_hv_pmos[ctype]
print @n.xbgr.xm54_u15.nsg13_hv_pmos[ide]
print @n.xbgr.xm54_u15.nsg13_hv_pmos[ige]
print @n.xbgr.xm54_u15.nsg13_hv_pmos[ise]
print @n.xbgr.xm54_u15.nsg13_hv_pmos[ibe]
print @n.xbgr.xm54_u15.nsg13_hv_pmos[ctype]
print @n.xbgr.xm54_u16.nsg13_hv_pmos[ide]
print @n.xbgr.xm54_u16.nsg13_hv_pmos[ige]
print @n.xbgr.xm54_u16.nsg13_hv_pmos[ise]
print @n.xbgr.xm54_u16.nsg13_hv_pmos[ibe]
print @n.xbgr.xm54_u16.nsg13_hv_pmos[ctype]
print @n.xbgr.xm54_u17.nsg13_hv_pmos[ide]
print @n.xbgr.xm54_u17.nsg13_hv_pmos[ige]
print @n.xbgr.xm54_u17.nsg13_hv_pmos[ise]
print @n.xbgr.xm54_u17.nsg13_hv_pmos[ibe]
print @n.xbgr.xm54_u17.nsg13_hv_pmos[ctype]
print @n.xbgr.xm54_u18.nsg13_hv_pmos[ide]
print @n.xbgr.xm54_u18.nsg13_hv_pmos[ige]
print @n.xbgr.xm54_u18.nsg13_hv_pmos[ise]
print @n.xbgr.xm54_u18.nsg13_hv_pmos[ibe]
print @n.xbgr.xm54_u18.nsg13_hv_pmos[ctype]
print @n.xbgr.xm54_u19.nsg13_hv_pmos[ide]
print @n.xbgr.xm54_u19.nsg13_hv_pmos[ige]
print @n.xbgr.xm54_u19.nsg13_hv_pmos[ise]
print @n.xbgr.xm54_u19.nsg13_hv_pmos[ibe]
print @n.xbgr.xm54_u19.nsg13_hv_pmos[ctype]
print @n.xbgr.xm54_u20.nsg13_hv_pmos[ide]
print @n.xbgr.xm54_u20.nsg13_hv_pmos[ige]
print @n.xbgr.xm54_u20.nsg13_hv_pmos[ise]
print @n.xbgr.xm54_u20.nsg13_hv_pmos[ibe]
print @n.xbgr.xm54_u20.nsg13_hv_pmos[ctype]
print @n.xbgr.xm54_u21.nsg13_hv_pmos[ide]
print @n.xbgr.xm54_u21.nsg13_hv_pmos[ige]
print @n.xbgr.xm54_u21.nsg13_hv_pmos[ise]
print @n.xbgr.xm54_u21.nsg13_hv_pmos[ibe]
print @n.xbgr.xm54_u21.nsg13_hv_pmos[ctype]
print @n.xbgr.xm54_u22.nsg13_hv_pmos[ide]
print @n.xbgr.xm54_u22.nsg13_hv_pmos[ige]
print @n.xbgr.xm54_u22.nsg13_hv_pmos[ise]
print @n.xbgr.xm54_u22.nsg13_hv_pmos[ibe]
print @n.xbgr.xm54_u22.nsg13_hv_pmos[ctype]
print @n.xbgr.xm54_u23.nsg13_hv_pmos[ide]
print @n.xbgr.xm54_u23.nsg13_hv_pmos[ige]
print @n.xbgr.xm54_u23.nsg13_hv_pmos[ise]
print @n.xbgr.xm54_u23.nsg13_hv_pmos[ibe]
print @n.xbgr.xm54_u23.nsg13_hv_pmos[ctype]
print @n.xbgr.xm54_u24.nsg13_hv_pmos[ide]
print @n.xbgr.xm54_u24.nsg13_hv_pmos[ige]
print @n.xbgr.xm54_u24.nsg13_hv_pmos[ise]
print @n.xbgr.xm54_u24.nsg13_hv_pmos[ibe]
print @n.xbgr.xm54_u24.nsg13_hv_pmos[ctype]
print @q.xbgr.xq56_u2.qnpn13g2[ic]
print @q.xbgr.xq56_u2.qnpn13g2[ib]
print @q.xbgr.xq56_u2.qnpn13g2[ie]
print @q.xbgr.xq56_u2.qnpn13g2[is]
print @r.xbgr.xq56_u2.rsub[i]
print @c.xbgr.xq56_u2.csub[i]
print @q.xbgr.xq56_u3.qnpn13g2[ic]
print @q.xbgr.xq56_u3.qnpn13g2[ib]
print @q.xbgr.xq56_u3.qnpn13g2[ie]
print @q.xbgr.xq56_u3.qnpn13g2[is]
print @r.xbgr.xq56_u3.rsub[i]
print @c.xbgr.xq56_u3.csub[i]
print @q.xbgr.xq56_u4.qnpn13g2[ic]
print @q.xbgr.xq56_u4.qnpn13g2[ib]
print @q.xbgr.xq56_u4.qnpn13g2[ie]
print @q.xbgr.xq56_u4.qnpn13g2[is]
print @r.xbgr.xq56_u4.rsub[i]
print @c.xbgr.xq56_u4.csub[i]
print @q.xbgr.xq56_u5.qnpn13g2[ic]
print @q.xbgr.xq56_u5.qnpn13g2[ib]
print @q.xbgr.xq56_u5.qnpn13g2[ie]
print @q.xbgr.xq56_u5.qnpn13g2[is]
print @r.xbgr.xq56_u5.rsub[i]
print @c.xbgr.xq56_u5.csub[i]
print @q.xbgr.xq56_u6.qnpn13g2[ic]
print @q.xbgr.xq56_u6.qnpn13g2[ib]
print @q.xbgr.xq56_u6.qnpn13g2[ie]
print @q.xbgr.xq56_u6.qnpn13g2[is]
print @r.xbgr.xq56_u6.rsub[i]
print @c.xbgr.xq56_u6.csub[i]
print @q.xbgr.xq56_u7.qnpn13g2[ic]
print @q.xbgr.xq56_u7.qnpn13g2[ib]
print @q.xbgr.xq56_u7.qnpn13g2[ie]
print @q.xbgr.xq56_u7.qnpn13g2[is]
print @r.xbgr.xq56_u7.rsub[i]
print @c.xbgr.xq56_u7.csub[i]
print @q.xbgr.xq56_u8.qnpn13g2[ic]
print @q.xbgr.xq56_u8.qnpn13g2[ib]
print @q.xbgr.xq56_u8.qnpn13g2[ie]
print @q.xbgr.xq56_u8.qnpn13g2[is]
print @r.xbgr.xq56_u8.rsub[i]
print @c.xbgr.xq56_u8.csub[i]
print @q.xbgr.xq56_u9.qnpn13g2[ic]
print @q.xbgr.xq56_u9.qnpn13g2[ib]
print @q.xbgr.xq56_u9.qnpn13g2[ie]
print @q.xbgr.xq56_u9.qnpn13g2[is]
print @r.xbgr.xq56_u9.rsub[i]
print @c.xbgr.xq56_u9.csub[i]
print @q.xbgr.xq56_u10.qnpn13g2[ic]
print @q.xbgr.xq56_u10.qnpn13g2[ib]
print @q.xbgr.xq56_u10.qnpn13g2[ie]
print @q.xbgr.xq56_u10.qnpn13g2[is]
print @r.xbgr.xq56_u10.rsub[i]
print @c.xbgr.xq56_u10.csub[i]
print @q.xbgr.xq56_u11.qnpn13g2[ic]
print @q.xbgr.xq56_u11.qnpn13g2[ib]
print @q.xbgr.xq56_u11.qnpn13g2[ie]
print @q.xbgr.xq56_u11.qnpn13g2[is]
print @r.xbgr.xq56_u11.rsub[i]
print @c.xbgr.xq56_u11.csub[i]
print @q.xbgr.xq56_u12.qnpn13g2[ic]
print @q.xbgr.xq56_u12.qnpn13g2[ib]
print @q.xbgr.xq56_u12.qnpn13g2[ie]
print @q.xbgr.xq56_u12.qnpn13g2[is]
print @r.xbgr.xq56_u12.rsub[i]
print @c.xbgr.xq56_u12.csub[i]
print @q.xbgr.xq56_u13.qnpn13g2[ic]
print @q.xbgr.xq56_u13.qnpn13g2[ib]
print @q.xbgr.xq56_u13.qnpn13g2[ie]
print @q.xbgr.xq56_u13.qnpn13g2[is]
print @r.xbgr.xq56_u13.rsub[i]
print @c.xbgr.xq56_u13.csub[i]
print @q.xbgr.xq56_u14.qnpn13g2[ic]
print @q.xbgr.xq56_u14.qnpn13g2[ib]
print @q.xbgr.xq56_u14.qnpn13g2[ie]
print @q.xbgr.xq56_u14.qnpn13g2[is]
print @r.xbgr.xq56_u14.rsub[i]
print @c.xbgr.xq56_u14.csub[i]
print @q.xbgr.xq56_u15.qnpn13g2[ic]
print @q.xbgr.xq56_u15.qnpn13g2[ib]
print @q.xbgr.xq56_u15.qnpn13g2[ie]
print @q.xbgr.xq56_u15.qnpn13g2[is]
print @r.xbgr.xq56_u15.rsub[i]
print @c.xbgr.xq56_u15.csub[i]
print @q.xbgr.xq56_u16.qnpn13g2[ic]
print @q.xbgr.xq56_u16.qnpn13g2[ib]
print @q.xbgr.xq56_u16.qnpn13g2[ie]
print @q.xbgr.xq56_u16.qnpn13g2[is]
print @r.xbgr.xq56_u16.rsub[i]
print @c.xbgr.xq56_u16.csub[i]
print @q.xbgr.xq56_u17.qnpn13g2[ic]
print @q.xbgr.xq56_u17.qnpn13g2[ib]
print @q.xbgr.xq56_u17.qnpn13g2[ie]
print @q.xbgr.xq56_u17.qnpn13g2[is]
print @r.xbgr.xq56_u17.rsub[i]
print @c.xbgr.xq56_u17.csub[i]
print @q.xbgr.xq56_u18.qnpn13g2[ic]
print @q.xbgr.xq56_u18.qnpn13g2[ib]
print @q.xbgr.xq56_u18.qnpn13g2[ie]
print @q.xbgr.xq56_u18.qnpn13g2[is]
print @r.xbgr.xq56_u18.rsub[i]
print @c.xbgr.xq56_u18.csub[i]
print @q.xbgr.xq56_u19.qnpn13g2[ic]
print @q.xbgr.xq56_u19.qnpn13g2[ib]
print @q.xbgr.xq56_u19.qnpn13g2[ie]
print @q.xbgr.xq56_u19.qnpn13g2[is]
print @r.xbgr.xq56_u19.rsub[i]
print @c.xbgr.xq56_u19.csub[i]
print @q.xbgr.xq56_u20.qnpn13g2[ic]
print @q.xbgr.xq56_u20.qnpn13g2[ib]
print @q.xbgr.xq56_u20.qnpn13g2[ie]
print @q.xbgr.xq56_u20.qnpn13g2[is]
print @r.xbgr.xq56_u20.rsub[i]
print @c.xbgr.xq56_u20.csub[i]
print @q.xbgr.xq56_u21.qnpn13g2[ic]
print @q.xbgr.xq56_u21.qnpn13g2[ib]
print @q.xbgr.xq56_u21.qnpn13g2[ie]
print @q.xbgr.xq56_u21.qnpn13g2[is]
print @r.xbgr.xq56_u21.rsub[i]
print @c.xbgr.xq56_u21.csub[i]
print @q.xbgr.xq56_u22.qnpn13g2[ic]
print @q.xbgr.xq56_u22.qnpn13g2[ib]
print @q.xbgr.xq56_u22.qnpn13g2[ie]
print @q.xbgr.xq56_u22.qnpn13g2[is]
print @r.xbgr.xq56_u22.rsub[i]
print @c.xbgr.xq56_u22.csub[i]
print @q.xbgr.xq56_u23.qnpn13g2[ic]
print @q.xbgr.xq56_u23.qnpn13g2[ib]
print @q.xbgr.xq56_u23.qnpn13g2[ie]
print @q.xbgr.xq56_u23.qnpn13g2[is]
print @r.xbgr.xq56_u23.rsub[i]
print @c.xbgr.xq56_u23.csub[i]
print @q.xbgr.xq56_u24.qnpn13g2[ic]
print @q.xbgr.xq56_u24.qnpn13g2[ib]
print @q.xbgr.xq56_u24.qnpn13g2[ie]
print @q.xbgr.xq56_u24.qnpn13g2[is]
print @r.xbgr.xq56_u24.rsub[i]
print @c.xbgr.xq56_u24.csub[i]
print @q.xbgr.xq60_u2.qnpn13g2[ic]
print @q.xbgr.xq60_u2.qnpn13g2[ib]
print @q.xbgr.xq60_u2.qnpn13g2[ie]
print @q.xbgr.xq60_u2.qnpn13g2[is]
print @r.xbgr.xq60_u2.rsub[i]
print @c.xbgr.xq60_u2.csub[i]
print @q.xbgr.xq60_u3.qnpn13g2[ic]
print @q.xbgr.xq60_u3.qnpn13g2[ib]
print @q.xbgr.xq60_u3.qnpn13g2[ie]
print @q.xbgr.xq60_u3.qnpn13g2[is]
print @r.xbgr.xq60_u3.rsub[i]
print @c.xbgr.xq60_u3.csub[i]
print @q.xbgr.xq60_u4.qnpn13g2[ic]
print @q.xbgr.xq60_u4.qnpn13g2[ib]
print @q.xbgr.xq60_u4.qnpn13g2[ie]
print @q.xbgr.xq60_u4.qnpn13g2[is]
print @r.xbgr.xq60_u4.rsub[i]
print @c.xbgr.xq60_u4.csub[i]
print @q.xbgr.xq62_u2.qnpn13g2[ic]
print @q.xbgr.xq62_u2.qnpn13g2[ib]
print @q.xbgr.xq62_u2.qnpn13g2[ie]
print @q.xbgr.xq62_u2.qnpn13g2[is]
print @r.xbgr.xq62_u2.rsub[i]
print @c.xbgr.xq62_u2.csub[i]
print @q.xbgr.xq62_u3.qnpn13g2[ic]
print @q.xbgr.xq62_u3.qnpn13g2[ib]
print @q.xbgr.xq62_u3.qnpn13g2[ie]
print @q.xbgr.xq62_u3.qnpn13g2[is]
print @r.xbgr.xq62_u3.rsub[i]
print @c.xbgr.xq62_u3.csub[i]
print @q.xbgr.xq62_u4.qnpn13g2[ic]
print @q.xbgr.xq62_u4.qnpn13g2[ib]
print @q.xbgr.xq62_u4.qnpn13g2[ie]
print @q.xbgr.xq62_u4.qnpn13g2[is]
print @r.xbgr.xq62_u4.rsub[i]
print @c.xbgr.xq62_u4.csub[i]
print @q.xbgr.xq62_u5.qnpn13g2[ic]
print @q.xbgr.xq62_u5.qnpn13g2[ib]
print @q.xbgr.xq62_u5.qnpn13g2[ie]
print @q.xbgr.xq62_u5.qnpn13g2[is]
print @r.xbgr.xq62_u5.rsub[i]
print @c.xbgr.xq62_u5.csub[i]
print @q.xbgr.xq62_u6.qnpn13g2[ic]
print @q.xbgr.xq62_u6.qnpn13g2[ib]
print @q.xbgr.xq62_u6.qnpn13g2[ie]
print @q.xbgr.xq62_u6.qnpn13g2[is]
print @r.xbgr.xq62_u6.rsub[i]
print @c.xbgr.xq62_u6.csub[i]
print @q.xbgr.xq62_u7.qnpn13g2[ic]
print @q.xbgr.xq62_u7.qnpn13g2[ib]
print @q.xbgr.xq62_u7.qnpn13g2[ie]
print @q.xbgr.xq62_u7.qnpn13g2[is]
print @r.xbgr.xq62_u7.rsub[i]
print @c.xbgr.xq62_u7.csub[i]
print @q.xbgr.xq62_u8.qnpn13g2[ic]
print @q.xbgr.xq62_u8.qnpn13g2[ib]
print @q.xbgr.xq62_u8.qnpn13g2[ie]
print @q.xbgr.xq62_u8.qnpn13g2[is]
print @r.xbgr.xq62_u8.rsub[i]
print @c.xbgr.xq62_u8.csub[i]
print @q.xbgr.xq62_u9.qnpn13g2[ic]
print @q.xbgr.xq62_u9.qnpn13g2[ib]
print @q.xbgr.xq62_u9.qnpn13g2[ie]
print @q.xbgr.xq62_u9.qnpn13g2[is]
print @r.xbgr.xq62_u9.rsub[i]
print @c.xbgr.xq62_u9.csub[i]
print @q.xbgr.xq62_u10.qnpn13g2[ic]
print @q.xbgr.xq62_u10.qnpn13g2[ib]
print @q.xbgr.xq62_u10.qnpn13g2[ie]
print @q.xbgr.xq62_u10.qnpn13g2[is]
print @r.xbgr.xq62_u10.rsub[i]
print @c.xbgr.xq62_u10.csub[i]
print @q.xbgr.xq62_u11.qnpn13g2[ic]
print @q.xbgr.xq62_u11.qnpn13g2[ib]
print @q.xbgr.xq62_u11.qnpn13g2[ie]
print @q.xbgr.xq62_u11.qnpn13g2[is]
print @r.xbgr.xq62_u11.rsub[i]
print @c.xbgr.xq62_u11.csub[i]
print @q.xbgr.xq62_u12.qnpn13g2[ic]
print @q.xbgr.xq62_u12.qnpn13g2[ib]
print @q.xbgr.xq62_u12.qnpn13g2[ie]
print @q.xbgr.xq62_u12.qnpn13g2[is]
print @r.xbgr.xq62_u12.rsub[i]
print @c.xbgr.xq62_u12.csub[i]
print @q.xbgr.xq62_u13.qnpn13g2[ic]
print @q.xbgr.xq62_u13.qnpn13g2[ib]
print @q.xbgr.xq62_u13.qnpn13g2[ie]
print @q.xbgr.xq62_u13.qnpn13g2[is]
print @r.xbgr.xq62_u13.rsub[i]
print @c.xbgr.xq62_u13.csub[i]
print @q.xbgr.xq62_u14.qnpn13g2[ic]
print @q.xbgr.xq62_u14.qnpn13g2[ib]
print @q.xbgr.xq62_u14.qnpn13g2[ie]
print @q.xbgr.xq62_u14.qnpn13g2[is]
print @r.xbgr.xq62_u14.rsub[i]
print @c.xbgr.xq62_u14.csub[i]
print @q.xbgr.xq62_u15.qnpn13g2[ic]
print @q.xbgr.xq62_u15.qnpn13g2[ib]
print @q.xbgr.xq62_u15.qnpn13g2[ie]
print @q.xbgr.xq62_u15.qnpn13g2[is]
print @r.xbgr.xq62_u15.rsub[i]
print @c.xbgr.xq62_u15.csub[i]
print @q.xbgr.xq62_u16.qnpn13g2[ic]
print @q.xbgr.xq62_u16.qnpn13g2[ib]
print @q.xbgr.xq62_u16.qnpn13g2[ie]
print @q.xbgr.xq62_u16.qnpn13g2[is]
print @r.xbgr.xq62_u16.rsub[i]
print @c.xbgr.xq62_u16.csub[i]
print @q.xbgr.xq62_u17.qnpn13g2[ic]
print @q.xbgr.xq62_u17.qnpn13g2[ib]
print @q.xbgr.xq62_u17.qnpn13g2[ie]
print @q.xbgr.xq62_u17.qnpn13g2[is]
print @r.xbgr.xq62_u17.rsub[i]
print @c.xbgr.xq62_u17.csub[i]
print @q.xbgr.xq62_u18.qnpn13g2[ic]
print @q.xbgr.xq62_u18.qnpn13g2[ib]
print @q.xbgr.xq62_u18.qnpn13g2[ie]
print @q.xbgr.xq62_u18.qnpn13g2[is]
print @r.xbgr.xq62_u18.rsub[i]
print @c.xbgr.xq62_u18.csub[i]
print @q.xbgr.xq62_u19.qnpn13g2[ic]
print @q.xbgr.xq62_u19.qnpn13g2[ib]
print @q.xbgr.xq62_u19.qnpn13g2[ie]
print @q.xbgr.xq62_u19.qnpn13g2[is]
print @r.xbgr.xq62_u19.rsub[i]
print @c.xbgr.xq62_u19.csub[i]
print @q.xbgr.xq62_u20.qnpn13g2[ic]
print @q.xbgr.xq62_u20.qnpn13g2[ib]
print @q.xbgr.xq62_u20.qnpn13g2[ie]
print @q.xbgr.xq62_u20.qnpn13g2[is]
print @r.xbgr.xq62_u20.rsub[i]
print @c.xbgr.xq62_u20.csub[i]
print @q.xbgr.xq62_u21.qnpn13g2[ic]
print @q.xbgr.xq62_u21.qnpn13g2[ib]
print @q.xbgr.xq62_u21.qnpn13g2[ie]
print @q.xbgr.xq62_u21.qnpn13g2[is]
print @r.xbgr.xq62_u21.rsub[i]
print @c.xbgr.xq62_u21.csub[i]
print @q.xbgr.xq62_u22.qnpn13g2[ic]
print @q.xbgr.xq62_u22.qnpn13g2[ib]
print @q.xbgr.xq62_u22.qnpn13g2[ie]
print @q.xbgr.xq62_u22.qnpn13g2[is]
print @r.xbgr.xq62_u22.rsub[i]
print @c.xbgr.xq62_u22.csub[i]
print @q.xbgr.xq62_u23.qnpn13g2[ic]
print @q.xbgr.xq62_u23.qnpn13g2[ib]
print @q.xbgr.xq62_u23.qnpn13g2[ie]
print @q.xbgr.xq62_u23.qnpn13g2[is]
print @r.xbgr.xq62_u23.rsub[i]
print @c.xbgr.xq62_u23.csub[i]
print @q.xbgr.xq62_u24.qnpn13g2[ic]
print @q.xbgr.xq62_u24.qnpn13g2[ib]
print @q.xbgr.xq62_u24.qnpn13g2[ie]
print @q.xbgr.xq62_u24.qnpn13g2[is]
print @r.xbgr.xq62_u24.rsub[i]
print @c.xbgr.xq62_u24.csub[i]
print @q.xbgr.xq67_u2.qnpn13g2[ic]
print @q.xbgr.xq67_u2.qnpn13g2[ib]
print @q.xbgr.xq67_u2.qnpn13g2[ie]
print @q.xbgr.xq67_u2.qnpn13g2[is]
print @r.xbgr.xq67_u2.rsub[i]
print @c.xbgr.xq67_u2.csub[i]
print @q.xbgr.xq67_u3.qnpn13g2[ic]
print @q.xbgr.xq67_u3.qnpn13g2[ib]
print @q.xbgr.xq67_u3.qnpn13g2[ie]
print @q.xbgr.xq67_u3.qnpn13g2[is]
print @r.xbgr.xq67_u3.rsub[i]
print @c.xbgr.xq67_u3.csub[i]
print @q.xbgr.xq67_u4.qnpn13g2[ic]
print @q.xbgr.xq67_u4.qnpn13g2[ib]
print @q.xbgr.xq67_u4.qnpn13g2[ie]
print @q.xbgr.xq67_u4.qnpn13g2[is]
print @r.xbgr.xq67_u4.rsub[i]
print @c.xbgr.xq67_u4.csub[i]
print @q.xbgr.xq67_u5.qnpn13g2[ic]
print @q.xbgr.xq67_u5.qnpn13g2[ib]
print @q.xbgr.xq67_u5.qnpn13g2[ie]
print @q.xbgr.xq67_u5.qnpn13g2[is]
print @r.xbgr.xq67_u5.rsub[i]
print @c.xbgr.xq67_u5.csub[i]
print @q.xbgr.xq67_u6.qnpn13g2[ic]
print @q.xbgr.xq67_u6.qnpn13g2[ib]
print @q.xbgr.xq67_u6.qnpn13g2[ie]
print @q.xbgr.xq67_u6.qnpn13g2[is]
print @r.xbgr.xq67_u6.rsub[i]
print @c.xbgr.xq67_u6.csub[i]
print @q.xbgr.xq67_u7.qnpn13g2[ic]
print @q.xbgr.xq67_u7.qnpn13g2[ib]
print @q.xbgr.xq67_u7.qnpn13g2[ie]
print @q.xbgr.xq67_u7.qnpn13g2[is]
print @r.xbgr.xq67_u7.rsub[i]
print @c.xbgr.xq67_u7.csub[i]
print @q.xbgr.xq67_u8.qnpn13g2[ic]
print @q.xbgr.xq67_u8.qnpn13g2[ib]
print @q.xbgr.xq67_u8.qnpn13g2[ie]
print @q.xbgr.xq67_u8.qnpn13g2[is]
print @r.xbgr.xq67_u8.rsub[i]
print @c.xbgr.xq67_u8.csub[i]
print @q.xbgr.xq67_u9.qnpn13g2[ic]
print @q.xbgr.xq67_u9.qnpn13g2[ib]
print @q.xbgr.xq67_u9.qnpn13g2[ie]
print @q.xbgr.xq67_u9.qnpn13g2[is]
print @r.xbgr.xq67_u9.rsub[i]
print @c.xbgr.xq67_u9.csub[i]
print @q.xbgr.xq67_u10.qnpn13g2[ic]
print @q.xbgr.xq67_u10.qnpn13g2[ib]
print @q.xbgr.xq67_u10.qnpn13g2[ie]
print @q.xbgr.xq67_u10.qnpn13g2[is]
print @r.xbgr.xq67_u10.rsub[i]
print @c.xbgr.xq67_u10.csub[i]
print @q.xbgr.xq67_u11.qnpn13g2[ic]
print @q.xbgr.xq67_u11.qnpn13g2[ib]
print @q.xbgr.xq67_u11.qnpn13g2[ie]
print @q.xbgr.xq67_u11.qnpn13g2[is]
print @r.xbgr.xq67_u11.rsub[i]
print @c.xbgr.xq67_u11.csub[i]
print @q.xbgr.xq67_u12.qnpn13g2[ic]
print @q.xbgr.xq67_u12.qnpn13g2[ib]
print @q.xbgr.xq67_u12.qnpn13g2[ie]
print @q.xbgr.xq67_u12.qnpn13g2[is]
print @r.xbgr.xq67_u12.rsub[i]
print @c.xbgr.xq67_u12.csub[i]
print @q.xbgr.xq67_u13.qnpn13g2[ic]
print @q.xbgr.xq67_u13.qnpn13g2[ib]
print @q.xbgr.xq67_u13.qnpn13g2[ie]
print @q.xbgr.xq67_u13.qnpn13g2[is]
print @r.xbgr.xq67_u13.rsub[i]
print @c.xbgr.xq67_u13.csub[i]
print @q.xbgr.xq67_u14.qnpn13g2[ic]
print @q.xbgr.xq67_u14.qnpn13g2[ib]
print @q.xbgr.xq67_u14.qnpn13g2[ie]
print @q.xbgr.xq67_u14.qnpn13g2[is]
print @r.xbgr.xq67_u14.rsub[i]
print @c.xbgr.xq67_u14.csub[i]
print @q.xbgr.xq67_u15.qnpn13g2[ic]
print @q.xbgr.xq67_u15.qnpn13g2[ib]
print @q.xbgr.xq67_u15.qnpn13g2[ie]
print @q.xbgr.xq67_u15.qnpn13g2[is]
print @r.xbgr.xq67_u15.rsub[i]
print @c.xbgr.xq67_u15.csub[i]
print @q.xbgr.xq67_u16.qnpn13g2[ic]
print @q.xbgr.xq67_u16.qnpn13g2[ib]
print @q.xbgr.xq67_u16.qnpn13g2[ie]
print @q.xbgr.xq67_u16.qnpn13g2[is]
print @r.xbgr.xq67_u16.rsub[i]
print @c.xbgr.xq67_u16.csub[i]
print @q.xbgr.xq67_u17.qnpn13g2[ic]
print @q.xbgr.xq67_u17.qnpn13g2[ib]
print @q.xbgr.xq67_u17.qnpn13g2[ie]
print @q.xbgr.xq67_u17.qnpn13g2[is]
print @r.xbgr.xq67_u17.rsub[i]
print @c.xbgr.xq67_u17.csub[i]
print @q.xbgr.xq67_u18.qnpn13g2[ic]
print @q.xbgr.xq67_u18.qnpn13g2[ib]
print @q.xbgr.xq67_u18.qnpn13g2[ie]
print @q.xbgr.xq67_u18.qnpn13g2[is]
print @r.xbgr.xq67_u18.rsub[i]
print @c.xbgr.xq67_u18.csub[i]
print @q.xbgr.xq67_u19.qnpn13g2[ic]
print @q.xbgr.xq67_u19.qnpn13g2[ib]
print @q.xbgr.xq67_u19.qnpn13g2[ie]
print @q.xbgr.xq67_u19.qnpn13g2[is]
print @r.xbgr.xq67_u19.rsub[i]
print @c.xbgr.xq67_u19.csub[i]
print @q.xbgr.xq67_u20.qnpn13g2[ic]
print @q.xbgr.xq67_u20.qnpn13g2[ib]
print @q.xbgr.xq67_u20.qnpn13g2[ie]
print @q.xbgr.xq67_u20.qnpn13g2[is]
print @r.xbgr.xq67_u20.rsub[i]
print @c.xbgr.xq67_u20.csub[i]
print @q.xbgr.xq67_u21.qnpn13g2[ic]
print @q.xbgr.xq67_u21.qnpn13g2[ib]
print @q.xbgr.xq67_u21.qnpn13g2[ie]
print @q.xbgr.xq67_u21.qnpn13g2[is]
print @r.xbgr.xq67_u21.rsub[i]
print @c.xbgr.xq67_u21.csub[i]
print @q.xbgr.xq67_u22.qnpn13g2[ic]
print @q.xbgr.xq67_u22.qnpn13g2[ib]
print @q.xbgr.xq67_u22.qnpn13g2[ie]
print @q.xbgr.xq67_u22.qnpn13g2[is]
print @r.xbgr.xq67_u22.rsub[i]
print @c.xbgr.xq67_u22.csub[i]
print @q.xbgr.xq67_u23.qnpn13g2[ic]
print @q.xbgr.xq67_u23.qnpn13g2[ib]
print @q.xbgr.xq67_u23.qnpn13g2[ie]
print @q.xbgr.xq67_u23.qnpn13g2[is]
print @r.xbgr.xq67_u23.rsub[i]
print @c.xbgr.xq67_u23.csub[i]
print @q.xbgr.xq67_u24.qnpn13g2[ic]
print @q.xbgr.xq67_u24.qnpn13g2[ib]
print @q.xbgr.xq67_u24.qnpn13g2[ie]
print @q.xbgr.xq67_u24.qnpn13g2[is]
print @r.xbgr.xq67_u24.rsub[i]
print @c.xbgr.xq67_u24.csub[i]
print @q.xbgr.xq68_u2.qnpn13g2[ic]
print @q.xbgr.xq68_u2.qnpn13g2[ib]
print @q.xbgr.xq68_u2.qnpn13g2[ie]
print @q.xbgr.xq68_u2.qnpn13g2[is]
print @r.xbgr.xq68_u2.rsub[i]
print @c.xbgr.xq68_u2.csub[i]
print @q.xbgr.xq68_u3.qnpn13g2[ic]
print @q.xbgr.xq68_u3.qnpn13g2[ib]
print @q.xbgr.xq68_u3.qnpn13g2[ie]
print @q.xbgr.xq68_u3.qnpn13g2[is]
print @r.xbgr.xq68_u3.rsub[i]
print @c.xbgr.xq68_u3.csub[i]
print @q.xbgr.xq68_u4.qnpn13g2[ic]
print @q.xbgr.xq68_u4.qnpn13g2[ib]
print @q.xbgr.xq68_u4.qnpn13g2[ie]
print @q.xbgr.xq68_u4.qnpn13g2[is]
print @r.xbgr.xq68_u4.rsub[i]
print @c.xbgr.xq68_u4.csub[i]
print @q.xbgr.xq68_u5.qnpn13g2[ic]
print @q.xbgr.xq68_u5.qnpn13g2[ib]
print @q.xbgr.xq68_u5.qnpn13g2[ie]
print @q.xbgr.xq68_u5.qnpn13g2[is]
print @r.xbgr.xq68_u5.rsub[i]
print @c.xbgr.xq68_u5.csub[i]
print @q.xbgr.xq68_u6.qnpn13g2[ic]
print @q.xbgr.xq68_u6.qnpn13g2[ib]
print @q.xbgr.xq68_u6.qnpn13g2[ie]
print @q.xbgr.xq68_u6.qnpn13g2[is]
print @r.xbgr.xq68_u6.rsub[i]
print @c.xbgr.xq68_u6.csub[i]
print @q.xbgr.xq68_u7.qnpn13g2[ic]
print @q.xbgr.xq68_u7.qnpn13g2[ib]
print @q.xbgr.xq68_u7.qnpn13g2[ie]
print @q.xbgr.xq68_u7.qnpn13g2[is]
print @r.xbgr.xq68_u7.rsub[i]
print @c.xbgr.xq68_u7.csub[i]
print @q.xbgr.xq68_u8.qnpn13g2[ic]
print @q.xbgr.xq68_u8.qnpn13g2[ib]
print @q.xbgr.xq68_u8.qnpn13g2[ie]
print @q.xbgr.xq68_u8.qnpn13g2[is]
print @r.xbgr.xq68_u8.rsub[i]
print @c.xbgr.xq68_u8.csub[i]
print @q.xbgr.xq68_u9.qnpn13g2[ic]
print @q.xbgr.xq68_u9.qnpn13g2[ib]
print @q.xbgr.xq68_u9.qnpn13g2[ie]
print @q.xbgr.xq68_u9.qnpn13g2[is]
print @r.xbgr.xq68_u9.rsub[i]
print @c.xbgr.xq68_u9.csub[i]
print @q.xbgr.xq68_u10.qnpn13g2[ic]
print @q.xbgr.xq68_u10.qnpn13g2[ib]
print @q.xbgr.xq68_u10.qnpn13g2[ie]
print @q.xbgr.xq68_u10.qnpn13g2[is]
print @r.xbgr.xq68_u10.rsub[i]
print @c.xbgr.xq68_u10.csub[i]
print @q.xbgr.xq68_u11.qnpn13g2[ic]
print @q.xbgr.xq68_u11.qnpn13g2[ib]
print @q.xbgr.xq68_u11.qnpn13g2[ie]
print @q.xbgr.xq68_u11.qnpn13g2[is]
print @r.xbgr.xq68_u11.rsub[i]
print @c.xbgr.xq68_u11.csub[i]
print @q.xbgr.xq68_u12.qnpn13g2[ic]
print @q.xbgr.xq68_u12.qnpn13g2[ib]
print @q.xbgr.xq68_u12.qnpn13g2[ie]
print @q.xbgr.xq68_u12.qnpn13g2[is]
print @r.xbgr.xq68_u12.rsub[i]
print @c.xbgr.xq68_u12.csub[i]
print @q.xbgr.xq68_u13.qnpn13g2[ic]
print @q.xbgr.xq68_u13.qnpn13g2[ib]
print @q.xbgr.xq68_u13.qnpn13g2[ie]
print @q.xbgr.xq68_u13.qnpn13g2[is]
print @r.xbgr.xq68_u13.rsub[i]
print @c.xbgr.xq68_u13.csub[i]
print @q.xbgr.xq68_u14.qnpn13g2[ic]
print @q.xbgr.xq68_u14.qnpn13g2[ib]
print @q.xbgr.xq68_u14.qnpn13g2[ie]
print @q.xbgr.xq68_u14.qnpn13g2[is]
print @r.xbgr.xq68_u14.rsub[i]
print @c.xbgr.xq68_u14.csub[i]
print @q.xbgr.xq68_u15.qnpn13g2[ic]
print @q.xbgr.xq68_u15.qnpn13g2[ib]
print @q.xbgr.xq68_u15.qnpn13g2[ie]
print @q.xbgr.xq68_u15.qnpn13g2[is]
print @r.xbgr.xq68_u15.rsub[i]
print @c.xbgr.xq68_u15.csub[i]
print @q.xbgr.xq68_u16.qnpn13g2[ic]
print @q.xbgr.xq68_u16.qnpn13g2[ib]
print @q.xbgr.xq68_u16.qnpn13g2[ie]
print @q.xbgr.xq68_u16.qnpn13g2[is]
print @r.xbgr.xq68_u16.rsub[i]
print @c.xbgr.xq68_u16.csub[i]
print @q.xbgr.xq68_u17.qnpn13g2[ic]
print @q.xbgr.xq68_u17.qnpn13g2[ib]
print @q.xbgr.xq68_u17.qnpn13g2[ie]
print @q.xbgr.xq68_u17.qnpn13g2[is]
print @r.xbgr.xq68_u17.rsub[i]
print @c.xbgr.xq68_u17.csub[i]
print @q.xbgr.xq68_u18.qnpn13g2[ic]
print @q.xbgr.xq68_u18.qnpn13g2[ib]
print @q.xbgr.xq68_u18.qnpn13g2[ie]
print @q.xbgr.xq68_u18.qnpn13g2[is]
print @r.xbgr.xq68_u18.rsub[i]
print @c.xbgr.xq68_u18.csub[i]
print @q.xbgr.xq68_u19.qnpn13g2[ic]
print @q.xbgr.xq68_u19.qnpn13g2[ib]
print @q.xbgr.xq68_u19.qnpn13g2[ie]
print @q.xbgr.xq68_u19.qnpn13g2[is]
print @r.xbgr.xq68_u19.rsub[i]
print @c.xbgr.xq68_u19.csub[i]
print @q.xbgr.xq68_u20.qnpn13g2[ic]
print @q.xbgr.xq68_u20.qnpn13g2[ib]
print @q.xbgr.xq68_u20.qnpn13g2[ie]
print @q.xbgr.xq68_u20.qnpn13g2[is]
print @r.xbgr.xq68_u20.rsub[i]
print @c.xbgr.xq68_u20.csub[i]
print @q.xbgr.xq68_u21.qnpn13g2[ic]
print @q.xbgr.xq68_u21.qnpn13g2[ib]
print @q.xbgr.xq68_u21.qnpn13g2[ie]
print @q.xbgr.xq68_u21.qnpn13g2[is]
print @r.xbgr.xq68_u21.rsub[i]
print @c.xbgr.xq68_u21.csub[i]
print @q.xbgr.xq68_u22.qnpn13g2[ic]
print @q.xbgr.xq68_u22.qnpn13g2[ib]
print @q.xbgr.xq68_u22.qnpn13g2[ie]
print @q.xbgr.xq68_u22.qnpn13g2[is]
print @r.xbgr.xq68_u22.rsub[i]
print @c.xbgr.xq68_u22.csub[i]
print @q.xbgr.xq68_u23.qnpn13g2[ic]
print @q.xbgr.xq68_u23.qnpn13g2[ib]
print @q.xbgr.xq68_u23.qnpn13g2[ie]
print @q.xbgr.xq68_u23.qnpn13g2[is]
print @r.xbgr.xq68_u23.rsub[i]
print @c.xbgr.xq68_u23.csub[i]
print @q.xbgr.xq68_u24.qnpn13g2[ic]
print @q.xbgr.xq68_u24.qnpn13g2[ib]
print @q.xbgr.xq68_u24.qnpn13g2[ie]
print @q.xbgr.xq68_u24.qnpn13g2[is]
print @r.xbgr.xq68_u24.rsub[i]
print @c.xbgr.xq68_u24.csub[i]
print @q.xbgr.xq69_u2.qnpn13g2[ic]
print @q.xbgr.xq69_u2.qnpn13g2[ib]
print @q.xbgr.xq69_u2.qnpn13g2[ie]
print @q.xbgr.xq69_u2.qnpn13g2[is]
print @r.xbgr.xq69_u2.rsub[i]
print @c.xbgr.xq69_u2.csub[i]
print @q.xbgr.xq69_u3.qnpn13g2[ic]
print @q.xbgr.xq69_u3.qnpn13g2[ib]
print @q.xbgr.xq69_u3.qnpn13g2[ie]
print @q.xbgr.xq69_u3.qnpn13g2[is]
print @r.xbgr.xq69_u3.rsub[i]
print @c.xbgr.xq69_u3.csub[i]
print @q.xbgr.xq69_u4.qnpn13g2[ic]
print @q.xbgr.xq69_u4.qnpn13g2[ib]
print @q.xbgr.xq69_u4.qnpn13g2[ie]
print @q.xbgr.xq69_u4.qnpn13g2[is]
print @r.xbgr.xq69_u4.rsub[i]
print @c.xbgr.xq69_u4.csub[i]
print @q.xbgr.xq69_u5.qnpn13g2[ic]
print @q.xbgr.xq69_u5.qnpn13g2[ib]
print @q.xbgr.xq69_u5.qnpn13g2[ie]
print @q.xbgr.xq69_u5.qnpn13g2[is]
print @r.xbgr.xq69_u5.rsub[i]
print @c.xbgr.xq69_u5.csub[i]
print @q.xbgr.xq69_u6.qnpn13g2[ic]
print @q.xbgr.xq69_u6.qnpn13g2[ib]
print @q.xbgr.xq69_u6.qnpn13g2[ie]
print @q.xbgr.xq69_u6.qnpn13g2[is]
print @r.xbgr.xq69_u6.rsub[i]
print @c.xbgr.xq69_u6.csub[i]
print @q.xbgr.xq69_u7.qnpn13g2[ic]
print @q.xbgr.xq69_u7.qnpn13g2[ib]
print @q.xbgr.xq69_u7.qnpn13g2[ie]
print @q.xbgr.xq69_u7.qnpn13g2[is]
print @r.xbgr.xq69_u7.rsub[i]
print @c.xbgr.xq69_u7.csub[i]
print @q.xbgr.xq69_u8.qnpn13g2[ic]
print @q.xbgr.xq69_u8.qnpn13g2[ib]
print @q.xbgr.xq69_u8.qnpn13g2[ie]
print @q.xbgr.xq69_u8.qnpn13g2[is]
print @r.xbgr.xq69_u8.rsub[i]
print @c.xbgr.xq69_u8.csub[i]
print @q.xbgr.xq69_u9.qnpn13g2[ic]
print @q.xbgr.xq69_u9.qnpn13g2[ib]
print @q.xbgr.xq69_u9.qnpn13g2[ie]
print @q.xbgr.xq69_u9.qnpn13g2[is]
print @r.xbgr.xq69_u9.rsub[i]
print @c.xbgr.xq69_u9.csub[i]
print @q.xbgr.xq69_u10.qnpn13g2[ic]
print @q.xbgr.xq69_u10.qnpn13g2[ib]
print @q.xbgr.xq69_u10.qnpn13g2[ie]
print @q.xbgr.xq69_u10.qnpn13g2[is]
print @r.xbgr.xq69_u10.rsub[i]
print @c.xbgr.xq69_u10.csub[i]
print @q.xbgr.xq69_u11.qnpn13g2[ic]
print @q.xbgr.xq69_u11.qnpn13g2[ib]
print @q.xbgr.xq69_u11.qnpn13g2[ie]
print @q.xbgr.xq69_u11.qnpn13g2[is]
print @r.xbgr.xq69_u11.rsub[i]
print @c.xbgr.xq69_u11.csub[i]
print @q.xbgr.xq69_u12.qnpn13g2[ic]
print @q.xbgr.xq69_u12.qnpn13g2[ib]
print @q.xbgr.xq69_u12.qnpn13g2[ie]
print @q.xbgr.xq69_u12.qnpn13g2[is]
print @r.xbgr.xq69_u12.rsub[i]
print @c.xbgr.xq69_u12.csub[i]
print @q.xbgr.xq69_u13.qnpn13g2[ic]
print @q.xbgr.xq69_u13.qnpn13g2[ib]
print @q.xbgr.xq69_u13.qnpn13g2[ie]
print @q.xbgr.xq69_u13.qnpn13g2[is]
print @r.xbgr.xq69_u13.rsub[i]
print @c.xbgr.xq69_u13.csub[i]
print @q.xbgr.xq69_u14.qnpn13g2[ic]
print @q.xbgr.xq69_u14.qnpn13g2[ib]
print @q.xbgr.xq69_u14.qnpn13g2[ie]
print @q.xbgr.xq69_u14.qnpn13g2[is]
print @r.xbgr.xq69_u14.rsub[i]
print @c.xbgr.xq69_u14.csub[i]
print @q.xbgr.xq69_u15.qnpn13g2[ic]
print @q.xbgr.xq69_u15.qnpn13g2[ib]
print @q.xbgr.xq69_u15.qnpn13g2[ie]
print @q.xbgr.xq69_u15.qnpn13g2[is]
print @r.xbgr.xq69_u15.rsub[i]
print @c.xbgr.xq69_u15.csub[i]
print @q.xbgr.xq69_u16.qnpn13g2[ic]
print @q.xbgr.xq69_u16.qnpn13g2[ib]
print @q.xbgr.xq69_u16.qnpn13g2[ie]
print @q.xbgr.xq69_u16.qnpn13g2[is]
print @r.xbgr.xq69_u16.rsub[i]
print @c.xbgr.xq69_u16.csub[i]
print @q.xbgr.xq69_u17.qnpn13g2[ic]
print @q.xbgr.xq69_u17.qnpn13g2[ib]
print @q.xbgr.xq69_u17.qnpn13g2[ie]
print @q.xbgr.xq69_u17.qnpn13g2[is]
print @r.xbgr.xq69_u17.rsub[i]
print @c.xbgr.xq69_u17.csub[i]
print @q.xbgr.xq69_u18.qnpn13g2[ic]
print @q.xbgr.xq69_u18.qnpn13g2[ib]
print @q.xbgr.xq69_u18.qnpn13g2[ie]
print @q.xbgr.xq69_u18.qnpn13g2[is]
print @r.xbgr.xq69_u18.rsub[i]
print @c.xbgr.xq69_u18.csub[i]
print @q.xbgr.xq69_u19.qnpn13g2[ic]
print @q.xbgr.xq69_u19.qnpn13g2[ib]
print @q.xbgr.xq69_u19.qnpn13g2[ie]
print @q.xbgr.xq69_u19.qnpn13g2[is]
print @r.xbgr.xq69_u19.rsub[i]
print @c.xbgr.xq69_u19.csub[i]
print @q.xbgr.xq69_u20.qnpn13g2[ic]
print @q.xbgr.xq69_u20.qnpn13g2[ib]
print @q.xbgr.xq69_u20.qnpn13g2[ie]
print @q.xbgr.xq69_u20.qnpn13g2[is]
print @r.xbgr.xq69_u20.rsub[i]
print @c.xbgr.xq69_u20.csub[i]
print @q.xbgr.xq69_u21.qnpn13g2[ic]
print @q.xbgr.xq69_u21.qnpn13g2[ib]
print @q.xbgr.xq69_u21.qnpn13g2[ie]
print @q.xbgr.xq69_u21.qnpn13g2[is]
print @r.xbgr.xq69_u21.rsub[i]
print @c.xbgr.xq69_u21.csub[i]
print @q.xbgr.xq69_u22.qnpn13g2[ic]
print @q.xbgr.xq69_u22.qnpn13g2[ib]
print @q.xbgr.xq69_u22.qnpn13g2[ie]
print @q.xbgr.xq69_u22.qnpn13g2[is]
print @r.xbgr.xq69_u22.rsub[i]
print @c.xbgr.xq69_u22.csub[i]
print @q.xbgr.xq69_u23.qnpn13g2[ic]
print @q.xbgr.xq69_u23.qnpn13g2[ib]
print @q.xbgr.xq69_u23.qnpn13g2[ie]
print @q.xbgr.xq69_u23.qnpn13g2[is]
print @r.xbgr.xq69_u23.rsub[i]
print @c.xbgr.xq69_u23.csub[i]
print @q.xbgr.xq69_u24.qnpn13g2[ic]
print @q.xbgr.xq69_u24.qnpn13g2[ib]
print @q.xbgr.xq69_u24.qnpn13g2[ie]
print @q.xbgr.xq69_u24.qnpn13g2[is]
print @r.xbgr.xq69_u24.rsub[i]
print @c.xbgr.xq69_u24.csub[i]
print @q.xbgr.xq70_u2.qnpn13g2[ic]
print @q.xbgr.xq70_u2.qnpn13g2[ib]
print @q.xbgr.xq70_u2.qnpn13g2[ie]
print @q.xbgr.xq70_u2.qnpn13g2[is]
print @r.xbgr.xq70_u2.rsub[i]
print @c.xbgr.xq70_u2.csub[i]
print @q.xbgr.xq70_u3.qnpn13g2[ic]
print @q.xbgr.xq70_u3.qnpn13g2[ib]
print @q.xbgr.xq70_u3.qnpn13g2[ie]
print @q.xbgr.xq70_u3.qnpn13g2[is]
print @r.xbgr.xq70_u3.rsub[i]
print @c.xbgr.xq70_u3.csub[i]
print @q.xbgr.xq70_u4.qnpn13g2[ic]
print @q.xbgr.xq70_u4.qnpn13g2[ib]
print @q.xbgr.xq70_u4.qnpn13g2[ie]
print @q.xbgr.xq70_u4.qnpn13g2[is]
print @r.xbgr.xq70_u4.rsub[i]
print @c.xbgr.xq70_u4.csub[i]
print @q.xbgr.xq70_u5.qnpn13g2[ic]
print @q.xbgr.xq70_u5.qnpn13g2[ib]
print @q.xbgr.xq70_u5.qnpn13g2[ie]
print @q.xbgr.xq70_u5.qnpn13g2[is]
print @r.xbgr.xq70_u5.rsub[i]
print @c.xbgr.xq70_u5.csub[i]
print @q.xbgr.xq70_u6.qnpn13g2[ic]
print @q.xbgr.xq70_u6.qnpn13g2[ib]
print @q.xbgr.xq70_u6.qnpn13g2[ie]
print @q.xbgr.xq70_u6.qnpn13g2[is]
print @r.xbgr.xq70_u6.rsub[i]
print @c.xbgr.xq70_u6.csub[i]
print @q.xbgr.xq70_u7.qnpn13g2[ic]
print @q.xbgr.xq70_u7.qnpn13g2[ib]
print @q.xbgr.xq70_u7.qnpn13g2[ie]
print @q.xbgr.xq70_u7.qnpn13g2[is]
print @r.xbgr.xq70_u7.rsub[i]
print @c.xbgr.xq70_u7.csub[i]
print @q.xbgr.xq70_u8.qnpn13g2[ic]
print @q.xbgr.xq70_u8.qnpn13g2[ib]
print @q.xbgr.xq70_u8.qnpn13g2[ie]
print @q.xbgr.xq70_u8.qnpn13g2[is]
print @r.xbgr.xq70_u8.rsub[i]
print @c.xbgr.xq70_u8.csub[i]
print @q.xbgr.xq70_u9.qnpn13g2[ic]
print @q.xbgr.xq70_u9.qnpn13g2[ib]
print @q.xbgr.xq70_u9.qnpn13g2[ie]
print @q.xbgr.xq70_u9.qnpn13g2[is]
print @r.xbgr.xq70_u9.rsub[i]
print @c.xbgr.xq70_u9.csub[i]
print @q.xbgr.xq70_u10.qnpn13g2[ic]
print @q.xbgr.xq70_u10.qnpn13g2[ib]
print @q.xbgr.xq70_u10.qnpn13g2[ie]
print @q.xbgr.xq70_u10.qnpn13g2[is]
print @r.xbgr.xq70_u10.rsub[i]
print @c.xbgr.xq70_u10.csub[i]
print @q.xbgr.xq70_u11.qnpn13g2[ic]
print @q.xbgr.xq70_u11.qnpn13g2[ib]
print @q.xbgr.xq70_u11.qnpn13g2[ie]
print @q.xbgr.xq70_u11.qnpn13g2[is]
print @r.xbgr.xq70_u11.rsub[i]
print @c.xbgr.xq70_u11.csub[i]
print @q.xbgr.xq70_u12.qnpn13g2[ic]
print @q.xbgr.xq70_u12.qnpn13g2[ib]
print @q.xbgr.xq70_u12.qnpn13g2[ie]
print @q.xbgr.xq70_u12.qnpn13g2[is]
print @r.xbgr.xq70_u12.rsub[i]
print @c.xbgr.xq70_u12.csub[i]
print @q.xbgr.xq70_u13.qnpn13g2[ic]
print @q.xbgr.xq70_u13.qnpn13g2[ib]
print @q.xbgr.xq70_u13.qnpn13g2[ie]
print @q.xbgr.xq70_u13.qnpn13g2[is]
print @r.xbgr.xq70_u13.rsub[i]
print @c.xbgr.xq70_u13.csub[i]
print @q.xbgr.xq70_u14.qnpn13g2[ic]
print @q.xbgr.xq70_u14.qnpn13g2[ib]
print @q.xbgr.xq70_u14.qnpn13g2[ie]
print @q.xbgr.xq70_u14.qnpn13g2[is]
print @r.xbgr.xq70_u14.rsub[i]
print @c.xbgr.xq70_u14.csub[i]
print @q.xbgr.xq70_u15.qnpn13g2[ic]
print @q.xbgr.xq70_u15.qnpn13g2[ib]
print @q.xbgr.xq70_u15.qnpn13g2[ie]
print @q.xbgr.xq70_u15.qnpn13g2[is]
print @r.xbgr.xq70_u15.rsub[i]
print @c.xbgr.xq70_u15.csub[i]
print @q.xbgr.xq70_u16.qnpn13g2[ic]
print @q.xbgr.xq70_u16.qnpn13g2[ib]
print @q.xbgr.xq70_u16.qnpn13g2[ie]
print @q.xbgr.xq70_u16.qnpn13g2[is]
print @r.xbgr.xq70_u16.rsub[i]
print @c.xbgr.xq70_u16.csub[i]
print @q.xbgr.xq70_u17.qnpn13g2[ic]
print @q.xbgr.xq70_u17.qnpn13g2[ib]
print @q.xbgr.xq70_u17.qnpn13g2[ie]
print @q.xbgr.xq70_u17.qnpn13g2[is]
print @r.xbgr.xq70_u17.rsub[i]
print @c.xbgr.xq70_u17.csub[i]
print @q.xbgr.xq70_u18.qnpn13g2[ic]
print @q.xbgr.xq70_u18.qnpn13g2[ib]
print @q.xbgr.xq70_u18.qnpn13g2[ie]
print @q.xbgr.xq70_u18.qnpn13g2[is]
print @r.xbgr.xq70_u18.rsub[i]
print @c.xbgr.xq70_u18.csub[i]
print @q.xbgr.xq70_u19.qnpn13g2[ic]
print @q.xbgr.xq70_u19.qnpn13g2[ib]
print @q.xbgr.xq70_u19.qnpn13g2[ie]
print @q.xbgr.xq70_u19.qnpn13g2[is]
print @r.xbgr.xq70_u19.rsub[i]
print @c.xbgr.xq70_u19.csub[i]
print @q.xbgr.xq70_u20.qnpn13g2[ic]
print @q.xbgr.xq70_u20.qnpn13g2[ib]
print @q.xbgr.xq70_u20.qnpn13g2[ie]
print @q.xbgr.xq70_u20.qnpn13g2[is]
print @r.xbgr.xq70_u20.rsub[i]
print @c.xbgr.xq70_u20.csub[i]
print @q.xbgr.xq70_u21.qnpn13g2[ic]
print @q.xbgr.xq70_u21.qnpn13g2[ib]
print @q.xbgr.xq70_u21.qnpn13g2[ie]
print @q.xbgr.xq70_u21.qnpn13g2[is]
print @r.xbgr.xq70_u21.rsub[i]
print @c.xbgr.xq70_u21.csub[i]
print @q.xbgr.xq70_u22.qnpn13g2[ic]
print @q.xbgr.xq70_u22.qnpn13g2[ib]
print @q.xbgr.xq70_u22.qnpn13g2[ie]
print @q.xbgr.xq70_u22.qnpn13g2[is]
print @r.xbgr.xq70_u22.rsub[i]
print @c.xbgr.xq70_u22.csub[i]
print @q.xbgr.xq70_u23.qnpn13g2[ic]
print @q.xbgr.xq70_u23.qnpn13g2[ib]
print @q.xbgr.xq70_u23.qnpn13g2[ie]
print @q.xbgr.xq70_u23.qnpn13g2[is]
print @r.xbgr.xq70_u23.rsub[i]
print @c.xbgr.xq70_u23.csub[i]
print @q.xbgr.xq70_u24.qnpn13g2[ic]
print @q.xbgr.xq70_u24.qnpn13g2[ib]
print @q.xbgr.xq70_u24.qnpn13g2[ie]
print @q.xbgr.xq70_u24.qnpn13g2[is]
print @r.xbgr.xq70_u24.rsub[i]
print @c.xbgr.xq70_u24.csub[i]
print @q.xbgr.xq71_u2.qnpn13g2[ic]
print @q.xbgr.xq71_u2.qnpn13g2[ib]
print @q.xbgr.xq71_u2.qnpn13g2[ie]
print @q.xbgr.xq71_u2.qnpn13g2[is]
print @r.xbgr.xq71_u2.rsub[i]
print @c.xbgr.xq71_u2.csub[i]
print @q.xbgr.xq71_u3.qnpn13g2[ic]
print @q.xbgr.xq71_u3.qnpn13g2[ib]
print @q.xbgr.xq71_u3.qnpn13g2[ie]
print @q.xbgr.xq71_u3.qnpn13g2[is]
print @r.xbgr.xq71_u3.rsub[i]
print @c.xbgr.xq71_u3.csub[i]
print @q.xbgr.xq71_u4.qnpn13g2[ic]
print @q.xbgr.xq71_u4.qnpn13g2[ib]
print @q.xbgr.xq71_u4.qnpn13g2[ie]
print @q.xbgr.xq71_u4.qnpn13g2[is]
print @r.xbgr.xq71_u4.rsub[i]
print @c.xbgr.xq71_u4.csub[i]
print @q.xbgr.xq71_u5.qnpn13g2[ic]
print @q.xbgr.xq71_u5.qnpn13g2[ib]
print @q.xbgr.xq71_u5.qnpn13g2[ie]
print @q.xbgr.xq71_u5.qnpn13g2[is]
print @r.xbgr.xq71_u5.rsub[i]
print @c.xbgr.xq71_u5.csub[i]
print @q.xbgr.xq71_u6.qnpn13g2[ic]
print @q.xbgr.xq71_u6.qnpn13g2[ib]
print @q.xbgr.xq71_u6.qnpn13g2[ie]
print @q.xbgr.xq71_u6.qnpn13g2[is]
print @r.xbgr.xq71_u6.rsub[i]
print @c.xbgr.xq71_u6.csub[i]
print @q.xbgr.xq71_u7.qnpn13g2[ic]
print @q.xbgr.xq71_u7.qnpn13g2[ib]
print @q.xbgr.xq71_u7.qnpn13g2[ie]
print @q.xbgr.xq71_u7.qnpn13g2[is]
print @r.xbgr.xq71_u7.rsub[i]
print @c.xbgr.xq71_u7.csub[i]
print @q.xbgr.xq71_u8.qnpn13g2[ic]
print @q.xbgr.xq71_u8.qnpn13g2[ib]
print @q.xbgr.xq71_u8.qnpn13g2[ie]
print @q.xbgr.xq71_u8.qnpn13g2[is]
print @r.xbgr.xq71_u8.rsub[i]
print @c.xbgr.xq71_u8.csub[i]
print @q.xbgr.xq71_u9.qnpn13g2[ic]
print @q.xbgr.xq71_u9.qnpn13g2[ib]
print @q.xbgr.xq71_u9.qnpn13g2[ie]
print @q.xbgr.xq71_u9.qnpn13g2[is]
print @r.xbgr.xq71_u9.rsub[i]
print @c.xbgr.xq71_u9.csub[i]
print @q.xbgr.xq71_u10.qnpn13g2[ic]
print @q.xbgr.xq71_u10.qnpn13g2[ib]
print @q.xbgr.xq71_u10.qnpn13g2[ie]
print @q.xbgr.xq71_u10.qnpn13g2[is]
print @r.xbgr.xq71_u10.rsub[i]
print @c.xbgr.xq71_u10.csub[i]
print @q.xbgr.xq71_u11.qnpn13g2[ic]
print @q.xbgr.xq71_u11.qnpn13g2[ib]
print @q.xbgr.xq71_u11.qnpn13g2[ie]
print @q.xbgr.xq71_u11.qnpn13g2[is]
print @r.xbgr.xq71_u11.rsub[i]
print @c.xbgr.xq71_u11.csub[i]
print @q.xbgr.xq71_u12.qnpn13g2[ic]
print @q.xbgr.xq71_u12.qnpn13g2[ib]
print @q.xbgr.xq71_u12.qnpn13g2[ie]
print @q.xbgr.xq71_u12.qnpn13g2[is]
print @r.xbgr.xq71_u12.rsub[i]
print @c.xbgr.xq71_u12.csub[i]
print @q.xbgr.xq71_u13.qnpn13g2[ic]
print @q.xbgr.xq71_u13.qnpn13g2[ib]
print @q.xbgr.xq71_u13.qnpn13g2[ie]
print @q.xbgr.xq71_u13.qnpn13g2[is]
print @r.xbgr.xq71_u13.rsub[i]
print @c.xbgr.xq71_u13.csub[i]
print @q.xbgr.xq71_u14.qnpn13g2[ic]
print @q.xbgr.xq71_u14.qnpn13g2[ib]
print @q.xbgr.xq71_u14.qnpn13g2[ie]
print @q.xbgr.xq71_u14.qnpn13g2[is]
print @r.xbgr.xq71_u14.rsub[i]
print @c.xbgr.xq71_u14.csub[i]
print @q.xbgr.xq71_u15.qnpn13g2[ic]
print @q.xbgr.xq71_u15.qnpn13g2[ib]
print @q.xbgr.xq71_u15.qnpn13g2[ie]
print @q.xbgr.xq71_u15.qnpn13g2[is]
print @r.xbgr.xq71_u15.rsub[i]
print @c.xbgr.xq71_u15.csub[i]
print @q.xbgr.xq71_u16.qnpn13g2[ic]
print @q.xbgr.xq71_u16.qnpn13g2[ib]
print @q.xbgr.xq71_u16.qnpn13g2[ie]
print @q.xbgr.xq71_u16.qnpn13g2[is]
print @r.xbgr.xq71_u16.rsub[i]
print @c.xbgr.xq71_u16.csub[i]
print @q.xbgr.xq71_u17.qnpn13g2[ic]
print @q.xbgr.xq71_u17.qnpn13g2[ib]
print @q.xbgr.xq71_u17.qnpn13g2[ie]
print @q.xbgr.xq71_u17.qnpn13g2[is]
print @r.xbgr.xq71_u17.rsub[i]
print @c.xbgr.xq71_u17.csub[i]
print @q.xbgr.xq71_u18.qnpn13g2[ic]
print @q.xbgr.xq71_u18.qnpn13g2[ib]
print @q.xbgr.xq71_u18.qnpn13g2[ie]
print @q.xbgr.xq71_u18.qnpn13g2[is]
print @r.xbgr.xq71_u18.rsub[i]
print @c.xbgr.xq71_u18.csub[i]
print @q.xbgr.xq71_u19.qnpn13g2[ic]
print @q.xbgr.xq71_u19.qnpn13g2[ib]
print @q.xbgr.xq71_u19.qnpn13g2[ie]
print @q.xbgr.xq71_u19.qnpn13g2[is]
print @r.xbgr.xq71_u19.rsub[i]
print @c.xbgr.xq71_u19.csub[i]
print @q.xbgr.xq71_u20.qnpn13g2[ic]
print @q.xbgr.xq71_u20.qnpn13g2[ib]
print @q.xbgr.xq71_u20.qnpn13g2[ie]
print @q.xbgr.xq71_u20.qnpn13g2[is]
print @r.xbgr.xq71_u20.rsub[i]
print @c.xbgr.xq71_u20.csub[i]
print @q.xbgr.xq71_u21.qnpn13g2[ic]
print @q.xbgr.xq71_u21.qnpn13g2[ib]
print @q.xbgr.xq71_u21.qnpn13g2[ie]
print @q.xbgr.xq71_u21.qnpn13g2[is]
print @r.xbgr.xq71_u21.rsub[i]
print @c.xbgr.xq71_u21.csub[i]
print @q.xbgr.xq71_u22.qnpn13g2[ic]
print @q.xbgr.xq71_u22.qnpn13g2[ib]
print @q.xbgr.xq71_u22.qnpn13g2[ie]
print @q.xbgr.xq71_u22.qnpn13g2[is]
print @r.xbgr.xq71_u22.rsub[i]
print @c.xbgr.xq71_u22.csub[i]
print @q.xbgr.xq71_u23.qnpn13g2[ic]
print @q.xbgr.xq71_u23.qnpn13g2[ib]
print @q.xbgr.xq71_u23.qnpn13g2[ie]
print @q.xbgr.xq71_u23.qnpn13g2[is]
print @r.xbgr.xq71_u23.rsub[i]
print @c.xbgr.xq71_u23.csub[i]
print @q.xbgr.xq71_u24.qnpn13g2[ic]
print @q.xbgr.xq71_u24.qnpn13g2[ib]
print @q.xbgr.xq71_u24.qnpn13g2[ie]
print @q.xbgr.xq71_u24.qnpn13g2[is]
print @r.xbgr.xq71_u24.rsub[i]
print @c.xbgr.xq71_u24.csub[i]
print @q.xbgr.xq72_u2.qnpn13g2[ic]
print @q.xbgr.xq72_u2.qnpn13g2[ib]
print @q.xbgr.xq72_u2.qnpn13g2[ie]
print @q.xbgr.xq72_u2.qnpn13g2[is]
print @r.xbgr.xq72_u2.rsub[i]
print @c.xbgr.xq72_u2.csub[i]
print @q.xbgr.xq72_u3.qnpn13g2[ic]
print @q.xbgr.xq72_u3.qnpn13g2[ib]
print @q.xbgr.xq72_u3.qnpn13g2[ie]
print @q.xbgr.xq72_u3.qnpn13g2[is]
print @r.xbgr.xq72_u3.rsub[i]
print @c.xbgr.xq72_u3.csub[i]
print @q.xbgr.xq72_u4.qnpn13g2[ic]
print @q.xbgr.xq72_u4.qnpn13g2[ib]
print @q.xbgr.xq72_u4.qnpn13g2[ie]
print @q.xbgr.xq72_u4.qnpn13g2[is]
print @r.xbgr.xq72_u4.rsub[i]
print @c.xbgr.xq72_u4.csub[i]
print @q.xbgr.xq72_u5.qnpn13g2[ic]
print @q.xbgr.xq72_u5.qnpn13g2[ib]
print @q.xbgr.xq72_u5.qnpn13g2[ie]
print @q.xbgr.xq72_u5.qnpn13g2[is]
print @r.xbgr.xq72_u5.rsub[i]
print @c.xbgr.xq72_u5.csub[i]
print @q.xbgr.xq72_u6.qnpn13g2[ic]
print @q.xbgr.xq72_u6.qnpn13g2[ib]
print @q.xbgr.xq72_u6.qnpn13g2[ie]
print @q.xbgr.xq72_u6.qnpn13g2[is]
print @r.xbgr.xq72_u6.rsub[i]
print @c.xbgr.xq72_u6.csub[i]
print @q.xbgr.xq72_u7.qnpn13g2[ic]
print @q.xbgr.xq72_u7.qnpn13g2[ib]
print @q.xbgr.xq72_u7.qnpn13g2[ie]
print @q.xbgr.xq72_u7.qnpn13g2[is]
print @r.xbgr.xq72_u7.rsub[i]
print @c.xbgr.xq72_u7.csub[i]
print @q.xbgr.xq72_u8.qnpn13g2[ic]
print @q.xbgr.xq72_u8.qnpn13g2[ib]
print @q.xbgr.xq72_u8.qnpn13g2[ie]
print @q.xbgr.xq72_u8.qnpn13g2[is]
print @r.xbgr.xq72_u8.rsub[i]
print @c.xbgr.xq72_u8.csub[i]
print @q.xbgr.xq72_u9.qnpn13g2[ic]
print @q.xbgr.xq72_u9.qnpn13g2[ib]
print @q.xbgr.xq72_u9.qnpn13g2[ie]
print @q.xbgr.xq72_u9.qnpn13g2[is]
print @r.xbgr.xq72_u9.rsub[i]
print @c.xbgr.xq72_u9.csub[i]
print @q.xbgr.xq72_u10.qnpn13g2[ic]
print @q.xbgr.xq72_u10.qnpn13g2[ib]
print @q.xbgr.xq72_u10.qnpn13g2[ie]
print @q.xbgr.xq72_u10.qnpn13g2[is]
print @r.xbgr.xq72_u10.rsub[i]
print @c.xbgr.xq72_u10.csub[i]
print @q.xbgr.xq72_u11.qnpn13g2[ic]
print @q.xbgr.xq72_u11.qnpn13g2[ib]
print @q.xbgr.xq72_u11.qnpn13g2[ie]
print @q.xbgr.xq72_u11.qnpn13g2[is]
print @r.xbgr.xq72_u11.rsub[i]
print @c.xbgr.xq72_u11.csub[i]
print @q.xbgr.xq72_u12.qnpn13g2[ic]
print @q.xbgr.xq72_u12.qnpn13g2[ib]
print @q.xbgr.xq72_u12.qnpn13g2[ie]
print @q.xbgr.xq72_u12.qnpn13g2[is]
print @r.xbgr.xq72_u12.rsub[i]
print @c.xbgr.xq72_u12.csub[i]
print @q.xbgr.xq72_u13.qnpn13g2[ic]
print @q.xbgr.xq72_u13.qnpn13g2[ib]
print @q.xbgr.xq72_u13.qnpn13g2[ie]
print @q.xbgr.xq72_u13.qnpn13g2[is]
print @r.xbgr.xq72_u13.rsub[i]
print @c.xbgr.xq72_u13.csub[i]
print @q.xbgr.xq72_u14.qnpn13g2[ic]
print @q.xbgr.xq72_u14.qnpn13g2[ib]
print @q.xbgr.xq72_u14.qnpn13g2[ie]
print @q.xbgr.xq72_u14.qnpn13g2[is]
print @r.xbgr.xq72_u14.rsub[i]
print @c.xbgr.xq72_u14.csub[i]
print @q.xbgr.xq72_u15.qnpn13g2[ic]
print @q.xbgr.xq72_u15.qnpn13g2[ib]
print @q.xbgr.xq72_u15.qnpn13g2[ie]
print @q.xbgr.xq72_u15.qnpn13g2[is]
print @r.xbgr.xq72_u15.rsub[i]
print @c.xbgr.xq72_u15.csub[i]
print @q.xbgr.xq72_u16.qnpn13g2[ic]
print @q.xbgr.xq72_u16.qnpn13g2[ib]
print @q.xbgr.xq72_u16.qnpn13g2[ie]
print @q.xbgr.xq72_u16.qnpn13g2[is]
print @r.xbgr.xq72_u16.rsub[i]
print @c.xbgr.xq72_u16.csub[i]
print @q.xbgr.xq72_u17.qnpn13g2[ic]
print @q.xbgr.xq72_u17.qnpn13g2[ib]
print @q.xbgr.xq72_u17.qnpn13g2[ie]
print @q.xbgr.xq72_u17.qnpn13g2[is]
print @r.xbgr.xq72_u17.rsub[i]
print @c.xbgr.xq72_u17.csub[i]
print @q.xbgr.xq72_u18.qnpn13g2[ic]
print @q.xbgr.xq72_u18.qnpn13g2[ib]
print @q.xbgr.xq72_u18.qnpn13g2[ie]
print @q.xbgr.xq72_u18.qnpn13g2[is]
print @r.xbgr.xq72_u18.rsub[i]
print @c.xbgr.xq72_u18.csub[i]
print @q.xbgr.xq72_u19.qnpn13g2[ic]
print @q.xbgr.xq72_u19.qnpn13g2[ib]
print @q.xbgr.xq72_u19.qnpn13g2[ie]
print @q.xbgr.xq72_u19.qnpn13g2[is]
print @r.xbgr.xq72_u19.rsub[i]
print @c.xbgr.xq72_u19.csub[i]
print @q.xbgr.xq72_u20.qnpn13g2[ic]
print @q.xbgr.xq72_u20.qnpn13g2[ib]
print @q.xbgr.xq72_u20.qnpn13g2[ie]
print @q.xbgr.xq72_u20.qnpn13g2[is]
print @r.xbgr.xq72_u20.rsub[i]
print @c.xbgr.xq72_u20.csub[i]
print @q.xbgr.xq72_u21.qnpn13g2[ic]
print @q.xbgr.xq72_u21.qnpn13g2[ib]
print @q.xbgr.xq72_u21.qnpn13g2[ie]
print @q.xbgr.xq72_u21.qnpn13g2[is]
print @r.xbgr.xq72_u21.rsub[i]
print @c.xbgr.xq72_u21.csub[i]
print @q.xbgr.xq72_u22.qnpn13g2[ic]
print @q.xbgr.xq72_u22.qnpn13g2[ib]
print @q.xbgr.xq72_u22.qnpn13g2[ie]
print @q.xbgr.xq72_u22.qnpn13g2[is]
print @r.xbgr.xq72_u22.rsub[i]
print @c.xbgr.xq72_u22.csub[i]
print @q.xbgr.xq72_u23.qnpn13g2[ic]
print @q.xbgr.xq72_u23.qnpn13g2[ib]
print @q.xbgr.xq72_u23.qnpn13g2[ie]
print @q.xbgr.xq72_u23.qnpn13g2[is]
print @r.xbgr.xq72_u23.rsub[i]
print @c.xbgr.xq72_u23.csub[i]
print @q.xbgr.xq72_u24.qnpn13g2[ic]
print @q.xbgr.xq72_u24.qnpn13g2[ib]
print @q.xbgr.xq72_u24.qnpn13g2[ie]
print @q.xbgr.xq72_u24.qnpn13g2[is]
print @r.xbgr.xq72_u24.rsub[i]
print @c.xbgr.xq72_u24.csub[i]
print @q.xbgr.xq73_u2.qnpn13g2[ic]
print @q.xbgr.xq73_u2.qnpn13g2[ib]
print @q.xbgr.xq73_u2.qnpn13g2[ie]
print @q.xbgr.xq73_u2.qnpn13g2[is]
print @r.xbgr.xq73_u2.rsub[i]
print @c.xbgr.xq73_u2.csub[i]
print @q.xbgr.xq73_u3.qnpn13g2[ic]
print @q.xbgr.xq73_u3.qnpn13g2[ib]
print @q.xbgr.xq73_u3.qnpn13g2[ie]
print @q.xbgr.xq73_u3.qnpn13g2[is]
print @r.xbgr.xq73_u3.rsub[i]
print @c.xbgr.xq73_u3.csub[i]
print @q.xbgr.xq73_u4.qnpn13g2[ic]
print @q.xbgr.xq73_u4.qnpn13g2[ib]
print @q.xbgr.xq73_u4.qnpn13g2[ie]
print @q.xbgr.xq73_u4.qnpn13g2[is]
print @r.xbgr.xq73_u4.rsub[i]
print @c.xbgr.xq73_u4.csub[i]
print @q.xbgr.xq73_u5.qnpn13g2[ic]
print @q.xbgr.xq73_u5.qnpn13g2[ib]
print @q.xbgr.xq73_u5.qnpn13g2[ie]
print @q.xbgr.xq73_u5.qnpn13g2[is]
print @r.xbgr.xq73_u5.rsub[i]
print @c.xbgr.xq73_u5.csub[i]
print @q.xbgr.xq73_u6.qnpn13g2[ic]
print @q.xbgr.xq73_u6.qnpn13g2[ib]
print @q.xbgr.xq73_u6.qnpn13g2[ie]
print @q.xbgr.xq73_u6.qnpn13g2[is]
print @r.xbgr.xq73_u6.rsub[i]
print @c.xbgr.xq73_u6.csub[i]
print @q.xbgr.xq73_u7.qnpn13g2[ic]
print @q.xbgr.xq73_u7.qnpn13g2[ib]
print @q.xbgr.xq73_u7.qnpn13g2[ie]
print @q.xbgr.xq73_u7.qnpn13g2[is]
print @r.xbgr.xq73_u7.rsub[i]
print @c.xbgr.xq73_u7.csub[i]
print @q.xbgr.xq73_u8.qnpn13g2[ic]
print @q.xbgr.xq73_u8.qnpn13g2[ib]
print @q.xbgr.xq73_u8.qnpn13g2[ie]
print @q.xbgr.xq73_u8.qnpn13g2[is]
print @r.xbgr.xq73_u8.rsub[i]
print @c.xbgr.xq73_u8.csub[i]
print @q.xbgr.xq73_u9.qnpn13g2[ic]
print @q.xbgr.xq73_u9.qnpn13g2[ib]
print @q.xbgr.xq73_u9.qnpn13g2[ie]
print @q.xbgr.xq73_u9.qnpn13g2[is]
print @r.xbgr.xq73_u9.rsub[i]
print @c.xbgr.xq73_u9.csub[i]
print @q.xbgr.xq73_u10.qnpn13g2[ic]
print @q.xbgr.xq73_u10.qnpn13g2[ib]
print @q.xbgr.xq73_u10.qnpn13g2[ie]
print @q.xbgr.xq73_u10.qnpn13g2[is]
print @r.xbgr.xq73_u10.rsub[i]
print @c.xbgr.xq73_u10.csub[i]
print @q.xbgr.xq73_u11.qnpn13g2[ic]
print @q.xbgr.xq73_u11.qnpn13g2[ib]
print @q.xbgr.xq73_u11.qnpn13g2[ie]
print @q.xbgr.xq73_u11.qnpn13g2[is]
print @r.xbgr.xq73_u11.rsub[i]
print @c.xbgr.xq73_u11.csub[i]
print @q.xbgr.xq73_u12.qnpn13g2[ic]
print @q.xbgr.xq73_u12.qnpn13g2[ib]
print @q.xbgr.xq73_u12.qnpn13g2[ie]
print @q.xbgr.xq73_u12.qnpn13g2[is]
print @r.xbgr.xq73_u12.rsub[i]
print @c.xbgr.xq73_u12.csub[i]
print @q.xbgr.xq73_u13.qnpn13g2[ic]
print @q.xbgr.xq73_u13.qnpn13g2[ib]
print @q.xbgr.xq73_u13.qnpn13g2[ie]
print @q.xbgr.xq73_u13.qnpn13g2[is]
print @r.xbgr.xq73_u13.rsub[i]
print @c.xbgr.xq73_u13.csub[i]
print @q.xbgr.xq73_u14.qnpn13g2[ic]
print @q.xbgr.xq73_u14.qnpn13g2[ib]
print @q.xbgr.xq73_u14.qnpn13g2[ie]
print @q.xbgr.xq73_u14.qnpn13g2[is]
print @r.xbgr.xq73_u14.rsub[i]
print @c.xbgr.xq73_u14.csub[i]
print @q.xbgr.xq73_u15.qnpn13g2[ic]
print @q.xbgr.xq73_u15.qnpn13g2[ib]
print @q.xbgr.xq73_u15.qnpn13g2[ie]
print @q.xbgr.xq73_u15.qnpn13g2[is]
print @r.xbgr.xq73_u15.rsub[i]
print @c.xbgr.xq73_u15.csub[i]
print @q.xbgr.xq73_u16.qnpn13g2[ic]
print @q.xbgr.xq73_u16.qnpn13g2[ib]
print @q.xbgr.xq73_u16.qnpn13g2[ie]
print @q.xbgr.xq73_u16.qnpn13g2[is]
print @r.xbgr.xq73_u16.rsub[i]
print @c.xbgr.xq73_u16.csub[i]
print @q.xbgr.xq73_u17.qnpn13g2[ic]
print @q.xbgr.xq73_u17.qnpn13g2[ib]
print @q.xbgr.xq73_u17.qnpn13g2[ie]
print @q.xbgr.xq73_u17.qnpn13g2[is]
print @r.xbgr.xq73_u17.rsub[i]
print @c.xbgr.xq73_u17.csub[i]
print @q.xbgr.xq73_u18.qnpn13g2[ic]
print @q.xbgr.xq73_u18.qnpn13g2[ib]
print @q.xbgr.xq73_u18.qnpn13g2[ie]
print @q.xbgr.xq73_u18.qnpn13g2[is]
print @r.xbgr.xq73_u18.rsub[i]
print @c.xbgr.xq73_u18.csub[i]
print @q.xbgr.xq73_u19.qnpn13g2[ic]
print @q.xbgr.xq73_u19.qnpn13g2[ib]
print @q.xbgr.xq73_u19.qnpn13g2[ie]
print @q.xbgr.xq73_u19.qnpn13g2[is]
print @r.xbgr.xq73_u19.rsub[i]
print @c.xbgr.xq73_u19.csub[i]
print @q.xbgr.xq73_u20.qnpn13g2[ic]
print @q.xbgr.xq73_u20.qnpn13g2[ib]
print @q.xbgr.xq73_u20.qnpn13g2[ie]
print @q.xbgr.xq73_u20.qnpn13g2[is]
print @r.xbgr.xq73_u20.rsub[i]
print @c.xbgr.xq73_u20.csub[i]
print @q.xbgr.xq73_u21.qnpn13g2[ic]
print @q.xbgr.xq73_u21.qnpn13g2[ib]
print @q.xbgr.xq73_u21.qnpn13g2[ie]
print @q.xbgr.xq73_u21.qnpn13g2[is]
print @r.xbgr.xq73_u21.rsub[i]
print @c.xbgr.xq73_u21.csub[i]
print @q.xbgr.xq73_u22.qnpn13g2[ic]
print @q.xbgr.xq73_u22.qnpn13g2[ib]
print @q.xbgr.xq73_u22.qnpn13g2[ie]
print @q.xbgr.xq73_u22.qnpn13g2[is]
print @r.xbgr.xq73_u22.rsub[i]
print @c.xbgr.xq73_u22.csub[i]
print @q.xbgr.xq73_u23.qnpn13g2[ic]
print @q.xbgr.xq73_u23.qnpn13g2[ib]
print @q.xbgr.xq73_u23.qnpn13g2[ie]
print @q.xbgr.xq73_u23.qnpn13g2[is]
print @r.xbgr.xq73_u23.rsub[i]
print @c.xbgr.xq73_u23.csub[i]
print @q.xbgr.xq73_u24.qnpn13g2[ic]
print @q.xbgr.xq73_u24.qnpn13g2[ib]
print @q.xbgr.xq73_u24.qnpn13g2[ie]
print @q.xbgr.xq73_u24.qnpn13g2[is]
print @r.xbgr.xq73_u24.rsub[i]
print @c.xbgr.xq73_u24.csub[i]
print @q.xbgr.xq74_u2.qnpn13g2[ic]
print @q.xbgr.xq74_u2.qnpn13g2[ib]
print @q.xbgr.xq74_u2.qnpn13g2[ie]
print @q.xbgr.xq74_u2.qnpn13g2[is]
print @r.xbgr.xq74_u2.rsub[i]
print @c.xbgr.xq74_u2.csub[i]
print @q.xbgr.xq74_u3.qnpn13g2[ic]
print @q.xbgr.xq74_u3.qnpn13g2[ib]
print @q.xbgr.xq74_u3.qnpn13g2[ie]
print @q.xbgr.xq74_u3.qnpn13g2[is]
print @r.xbgr.xq74_u3.rsub[i]
print @c.xbgr.xq74_u3.csub[i]
print @q.xbgr.xq74_u4.qnpn13g2[ic]
print @q.xbgr.xq74_u4.qnpn13g2[ib]
print @q.xbgr.xq74_u4.qnpn13g2[ie]
print @q.xbgr.xq74_u4.qnpn13g2[is]
print @r.xbgr.xq74_u4.rsub[i]
print @c.xbgr.xq74_u4.csub[i]
print @q.xbgr.xq74_u5.qnpn13g2[ic]
print @q.xbgr.xq74_u5.qnpn13g2[ib]
print @q.xbgr.xq74_u5.qnpn13g2[ie]
print @q.xbgr.xq74_u5.qnpn13g2[is]
print @r.xbgr.xq74_u5.rsub[i]
print @c.xbgr.xq74_u5.csub[i]
print @q.xbgr.xq74_u6.qnpn13g2[ic]
print @q.xbgr.xq74_u6.qnpn13g2[ib]
print @q.xbgr.xq74_u6.qnpn13g2[ie]
print @q.xbgr.xq74_u6.qnpn13g2[is]
print @r.xbgr.xq74_u6.rsub[i]
print @c.xbgr.xq74_u6.csub[i]
print @q.xbgr.xq74_u7.qnpn13g2[ic]
print @q.xbgr.xq74_u7.qnpn13g2[ib]
print @q.xbgr.xq74_u7.qnpn13g2[ie]
print @q.xbgr.xq74_u7.qnpn13g2[is]
print @r.xbgr.xq74_u7.rsub[i]
print @c.xbgr.xq74_u7.csub[i]
print @q.xbgr.xq74_u8.qnpn13g2[ic]
print @q.xbgr.xq74_u8.qnpn13g2[ib]
print @q.xbgr.xq74_u8.qnpn13g2[ie]
print @q.xbgr.xq74_u8.qnpn13g2[is]
print @r.xbgr.xq74_u8.rsub[i]
print @c.xbgr.xq74_u8.csub[i]
print @q.xbgr.xq74_u9.qnpn13g2[ic]
print @q.xbgr.xq74_u9.qnpn13g2[ib]
print @q.xbgr.xq74_u9.qnpn13g2[ie]
print @q.xbgr.xq74_u9.qnpn13g2[is]
print @r.xbgr.xq74_u9.rsub[i]
print @c.xbgr.xq74_u9.csub[i]
print @q.xbgr.xq74_u10.qnpn13g2[ic]
print @q.xbgr.xq74_u10.qnpn13g2[ib]
print @q.xbgr.xq74_u10.qnpn13g2[ie]
print @q.xbgr.xq74_u10.qnpn13g2[is]
print @r.xbgr.xq74_u10.rsub[i]
print @c.xbgr.xq74_u10.csub[i]
print @q.xbgr.xq74_u11.qnpn13g2[ic]
print @q.xbgr.xq74_u11.qnpn13g2[ib]
print @q.xbgr.xq74_u11.qnpn13g2[ie]
print @q.xbgr.xq74_u11.qnpn13g2[is]
print @r.xbgr.xq74_u11.rsub[i]
print @c.xbgr.xq74_u11.csub[i]
print @q.xbgr.xq74_u12.qnpn13g2[ic]
print @q.xbgr.xq74_u12.qnpn13g2[ib]
print @q.xbgr.xq74_u12.qnpn13g2[ie]
print @q.xbgr.xq74_u12.qnpn13g2[is]
print @r.xbgr.xq74_u12.rsub[i]
print @c.xbgr.xq74_u12.csub[i]
print @q.xbgr.xq74_u13.qnpn13g2[ic]
print @q.xbgr.xq74_u13.qnpn13g2[ib]
print @q.xbgr.xq74_u13.qnpn13g2[ie]
print @q.xbgr.xq74_u13.qnpn13g2[is]
print @r.xbgr.xq74_u13.rsub[i]
print @c.xbgr.xq74_u13.csub[i]
print @q.xbgr.xq74_u14.qnpn13g2[ic]
print @q.xbgr.xq74_u14.qnpn13g2[ib]
print @q.xbgr.xq74_u14.qnpn13g2[ie]
print @q.xbgr.xq74_u14.qnpn13g2[is]
print @r.xbgr.xq74_u14.rsub[i]
print @c.xbgr.xq74_u14.csub[i]
print @q.xbgr.xq74_u15.qnpn13g2[ic]
print @q.xbgr.xq74_u15.qnpn13g2[ib]
print @q.xbgr.xq74_u15.qnpn13g2[ie]
print @q.xbgr.xq74_u15.qnpn13g2[is]
print @r.xbgr.xq74_u15.rsub[i]
print @c.xbgr.xq74_u15.csub[i]
print @q.xbgr.xq74_u16.qnpn13g2[ic]
print @q.xbgr.xq74_u16.qnpn13g2[ib]
print @q.xbgr.xq74_u16.qnpn13g2[ie]
print @q.xbgr.xq74_u16.qnpn13g2[is]
print @r.xbgr.xq74_u16.rsub[i]
print @c.xbgr.xq74_u16.csub[i]
print @q.xbgr.xq74_u17.qnpn13g2[ic]
print @q.xbgr.xq74_u17.qnpn13g2[ib]
print @q.xbgr.xq74_u17.qnpn13g2[ie]
print @q.xbgr.xq74_u17.qnpn13g2[is]
print @r.xbgr.xq74_u17.rsub[i]
print @c.xbgr.xq74_u17.csub[i]
print @q.xbgr.xq74_u18.qnpn13g2[ic]
print @q.xbgr.xq74_u18.qnpn13g2[ib]
print @q.xbgr.xq74_u18.qnpn13g2[ie]
print @q.xbgr.xq74_u18.qnpn13g2[is]
print @r.xbgr.xq74_u18.rsub[i]
print @c.xbgr.xq74_u18.csub[i]
print @q.xbgr.xq74_u19.qnpn13g2[ic]
print @q.xbgr.xq74_u19.qnpn13g2[ib]
print @q.xbgr.xq74_u19.qnpn13g2[ie]
print @q.xbgr.xq74_u19.qnpn13g2[is]
print @r.xbgr.xq74_u19.rsub[i]
print @c.xbgr.xq74_u19.csub[i]
print @q.xbgr.xq74_u20.qnpn13g2[ic]
print @q.xbgr.xq74_u20.qnpn13g2[ib]
print @q.xbgr.xq74_u20.qnpn13g2[ie]
print @q.xbgr.xq74_u20.qnpn13g2[is]
print @r.xbgr.xq74_u20.rsub[i]
print @c.xbgr.xq74_u20.csub[i]
print @q.xbgr.xq74_u21.qnpn13g2[ic]
print @q.xbgr.xq74_u21.qnpn13g2[ib]
print @q.xbgr.xq74_u21.qnpn13g2[ie]
print @q.xbgr.xq74_u21.qnpn13g2[is]
print @r.xbgr.xq74_u21.rsub[i]
print @c.xbgr.xq74_u21.csub[i]
print @q.xbgr.xq74_u22.qnpn13g2[ic]
print @q.xbgr.xq74_u22.qnpn13g2[ib]
print @q.xbgr.xq74_u22.qnpn13g2[ie]
print @q.xbgr.xq74_u22.qnpn13g2[is]
print @r.xbgr.xq74_u22.rsub[i]
print @c.xbgr.xq74_u22.csub[i]
print @q.xbgr.xq74_u23.qnpn13g2[ic]
print @q.xbgr.xq74_u23.qnpn13g2[ib]
print @q.xbgr.xq74_u23.qnpn13g2[ie]
print @q.xbgr.xq74_u23.qnpn13g2[is]
print @r.xbgr.xq74_u23.rsub[i]
print @c.xbgr.xq74_u23.csub[i]
print @q.xbgr.xq74_u24.qnpn13g2[ic]
print @q.xbgr.xq74_u24.qnpn13g2[ib]
print @q.xbgr.xq74_u24.qnpn13g2[ie]
print @q.xbgr.xq74_u24.qnpn13g2[is]
print @r.xbgr.xq74_u24.rsub[i]
print @c.xbgr.xq74_u24.csub[i]
print @q.xbgr.xq75_u2.qnpn13g2[ic]
print @q.xbgr.xq75_u2.qnpn13g2[ib]
print @q.xbgr.xq75_u2.qnpn13g2[ie]
print @q.xbgr.xq75_u2.qnpn13g2[is]
print @r.xbgr.xq75_u2.rsub[i]
print @c.xbgr.xq75_u2.csub[i]
print @q.xbgr.xq75_u3.qnpn13g2[ic]
print @q.xbgr.xq75_u3.qnpn13g2[ib]
print @q.xbgr.xq75_u3.qnpn13g2[ie]
print @q.xbgr.xq75_u3.qnpn13g2[is]
print @r.xbgr.xq75_u3.rsub[i]
print @c.xbgr.xq75_u3.csub[i]
print @q.xbgr.xq75_u4.qnpn13g2[ic]
print @q.xbgr.xq75_u4.qnpn13g2[ib]
print @q.xbgr.xq75_u4.qnpn13g2[ie]
print @q.xbgr.xq75_u4.qnpn13g2[is]
print @r.xbgr.xq75_u4.rsub[i]
print @c.xbgr.xq75_u4.csub[i]
print @q.xbgr.xq75_u5.qnpn13g2[ic]
print @q.xbgr.xq75_u5.qnpn13g2[ib]
print @q.xbgr.xq75_u5.qnpn13g2[ie]
print @q.xbgr.xq75_u5.qnpn13g2[is]
print @r.xbgr.xq75_u5.rsub[i]
print @c.xbgr.xq75_u5.csub[i]
print @q.xbgr.xq75_u6.qnpn13g2[ic]
print @q.xbgr.xq75_u6.qnpn13g2[ib]
print @q.xbgr.xq75_u6.qnpn13g2[ie]
print @q.xbgr.xq75_u6.qnpn13g2[is]
print @r.xbgr.xq75_u6.rsub[i]
print @c.xbgr.xq75_u6.csub[i]
print @q.xbgr.xq75_u7.qnpn13g2[ic]
print @q.xbgr.xq75_u7.qnpn13g2[ib]
print @q.xbgr.xq75_u7.qnpn13g2[ie]
print @q.xbgr.xq75_u7.qnpn13g2[is]
print @r.xbgr.xq75_u7.rsub[i]
print @c.xbgr.xq75_u7.csub[i]
print @q.xbgr.xq75_u8.qnpn13g2[ic]
print @q.xbgr.xq75_u8.qnpn13g2[ib]
print @q.xbgr.xq75_u8.qnpn13g2[ie]
print @q.xbgr.xq75_u8.qnpn13g2[is]
print @r.xbgr.xq75_u8.rsub[i]
print @c.xbgr.xq75_u8.csub[i]
print @q.xbgr.xq75_u9.qnpn13g2[ic]
print @q.xbgr.xq75_u9.qnpn13g2[ib]
print @q.xbgr.xq75_u9.qnpn13g2[ie]
print @q.xbgr.xq75_u9.qnpn13g2[is]
print @r.xbgr.xq75_u9.rsub[i]
print @c.xbgr.xq75_u9.csub[i]
print @q.xbgr.xq75_u10.qnpn13g2[ic]
print @q.xbgr.xq75_u10.qnpn13g2[ib]
print @q.xbgr.xq75_u10.qnpn13g2[ie]
print @q.xbgr.xq75_u10.qnpn13g2[is]
print @r.xbgr.xq75_u10.rsub[i]
print @c.xbgr.xq75_u10.csub[i]
print @q.xbgr.xq75_u11.qnpn13g2[ic]
print @q.xbgr.xq75_u11.qnpn13g2[ib]
print @q.xbgr.xq75_u11.qnpn13g2[ie]
print @q.xbgr.xq75_u11.qnpn13g2[is]
print @r.xbgr.xq75_u11.rsub[i]
print @c.xbgr.xq75_u11.csub[i]
print @q.xbgr.xq75_u12.qnpn13g2[ic]
print @q.xbgr.xq75_u12.qnpn13g2[ib]
print @q.xbgr.xq75_u12.qnpn13g2[ie]
print @q.xbgr.xq75_u12.qnpn13g2[is]
print @r.xbgr.xq75_u12.rsub[i]
print @c.xbgr.xq75_u12.csub[i]
print @q.xbgr.xq75_u13.qnpn13g2[ic]
print @q.xbgr.xq75_u13.qnpn13g2[ib]
print @q.xbgr.xq75_u13.qnpn13g2[ie]
print @q.xbgr.xq75_u13.qnpn13g2[is]
print @r.xbgr.xq75_u13.rsub[i]
print @c.xbgr.xq75_u13.csub[i]
print @q.xbgr.xq75_u14.qnpn13g2[ic]
print @q.xbgr.xq75_u14.qnpn13g2[ib]
print @q.xbgr.xq75_u14.qnpn13g2[ie]
print @q.xbgr.xq75_u14.qnpn13g2[is]
print @r.xbgr.xq75_u14.rsub[i]
print @c.xbgr.xq75_u14.csub[i]
print @q.xbgr.xq75_u15.qnpn13g2[ic]
print @q.xbgr.xq75_u15.qnpn13g2[ib]
print @q.xbgr.xq75_u15.qnpn13g2[ie]
print @q.xbgr.xq75_u15.qnpn13g2[is]
print @r.xbgr.xq75_u15.rsub[i]
print @c.xbgr.xq75_u15.csub[i]
print @q.xbgr.xq75_u16.qnpn13g2[ic]
print @q.xbgr.xq75_u16.qnpn13g2[ib]
print @q.xbgr.xq75_u16.qnpn13g2[ie]
print @q.xbgr.xq75_u16.qnpn13g2[is]
print @r.xbgr.xq75_u16.rsub[i]
print @c.xbgr.xq75_u16.csub[i]
print @q.xbgr.xq75_u17.qnpn13g2[ic]
print @q.xbgr.xq75_u17.qnpn13g2[ib]
print @q.xbgr.xq75_u17.qnpn13g2[ie]
print @q.xbgr.xq75_u17.qnpn13g2[is]
print @r.xbgr.xq75_u17.rsub[i]
print @c.xbgr.xq75_u17.csub[i]
print @q.xbgr.xq75_u18.qnpn13g2[ic]
print @q.xbgr.xq75_u18.qnpn13g2[ib]
print @q.xbgr.xq75_u18.qnpn13g2[ie]
print @q.xbgr.xq75_u18.qnpn13g2[is]
print @r.xbgr.xq75_u18.rsub[i]
print @c.xbgr.xq75_u18.csub[i]
print @q.xbgr.xq75_u19.qnpn13g2[ic]
print @q.xbgr.xq75_u19.qnpn13g2[ib]
print @q.xbgr.xq75_u19.qnpn13g2[ie]
print @q.xbgr.xq75_u19.qnpn13g2[is]
print @r.xbgr.xq75_u19.rsub[i]
print @c.xbgr.xq75_u19.csub[i]
print @q.xbgr.xq75_u20.qnpn13g2[ic]
print @q.xbgr.xq75_u20.qnpn13g2[ib]
print @q.xbgr.xq75_u20.qnpn13g2[ie]
print @q.xbgr.xq75_u20.qnpn13g2[is]
print @r.xbgr.xq75_u20.rsub[i]
print @c.xbgr.xq75_u20.csub[i]
print @q.xbgr.xq75_u21.qnpn13g2[ic]
print @q.xbgr.xq75_u21.qnpn13g2[ib]
print @q.xbgr.xq75_u21.qnpn13g2[ie]
print @q.xbgr.xq75_u21.qnpn13g2[is]
print @r.xbgr.xq75_u21.rsub[i]
print @c.xbgr.xq75_u21.csub[i]
print @q.xbgr.xq75_u22.qnpn13g2[ic]
print @q.xbgr.xq75_u22.qnpn13g2[ib]
print @q.xbgr.xq75_u22.qnpn13g2[ie]
print @q.xbgr.xq75_u22.qnpn13g2[is]
print @r.xbgr.xq75_u22.rsub[i]
print @c.xbgr.xq75_u22.csub[i]
print @q.xbgr.xq75_u23.qnpn13g2[ic]
print @q.xbgr.xq75_u23.qnpn13g2[ib]
print @q.xbgr.xq75_u23.qnpn13g2[ie]
print @q.xbgr.xq75_u23.qnpn13g2[is]
print @r.xbgr.xq75_u23.rsub[i]
print @c.xbgr.xq75_u23.csub[i]
print @q.xbgr.xq75_u24.qnpn13g2[ic]
print @q.xbgr.xq75_u24.qnpn13g2[ib]
print @q.xbgr.xq75_u24.qnpn13g2[ie]
print @q.xbgr.xq75_u24.qnpn13g2[is]
print @r.xbgr.xq75_u24.rsub[i]
print @c.xbgr.xq75_u24.csub[i]
print @q.xbgr.xq76_u2.qnpn13g2[ic]
print @q.xbgr.xq76_u2.qnpn13g2[ib]
print @q.xbgr.xq76_u2.qnpn13g2[ie]
print @q.xbgr.xq76_u2.qnpn13g2[is]
print @r.xbgr.xq76_u2.rsub[i]
print @c.xbgr.xq76_u2.csub[i]
print @q.xbgr.xq76_u3.qnpn13g2[ic]
print @q.xbgr.xq76_u3.qnpn13g2[ib]
print @q.xbgr.xq76_u3.qnpn13g2[ie]
print @q.xbgr.xq76_u3.qnpn13g2[is]
print @r.xbgr.xq76_u3.rsub[i]
print @c.xbgr.xq76_u3.csub[i]
print @q.xbgr.xq76_u4.qnpn13g2[ic]
print @q.xbgr.xq76_u4.qnpn13g2[ib]
print @q.xbgr.xq76_u4.qnpn13g2[ie]
print @q.xbgr.xq76_u4.qnpn13g2[is]
print @r.xbgr.xq76_u4.rsub[i]
print @c.xbgr.xq76_u4.csub[i]
print @q.xbgr.xq76_u5.qnpn13g2[ic]
print @q.xbgr.xq76_u5.qnpn13g2[ib]
print @q.xbgr.xq76_u5.qnpn13g2[ie]
print @q.xbgr.xq76_u5.qnpn13g2[is]
print @r.xbgr.xq76_u5.rsub[i]
print @c.xbgr.xq76_u5.csub[i]
print @q.xbgr.xq76_u6.qnpn13g2[ic]
print @q.xbgr.xq76_u6.qnpn13g2[ib]
print @q.xbgr.xq76_u6.qnpn13g2[ie]
print @q.xbgr.xq76_u6.qnpn13g2[is]
print @r.xbgr.xq76_u6.rsub[i]
print @c.xbgr.xq76_u6.csub[i]
print @q.xbgr.xq76_u7.qnpn13g2[ic]
print @q.xbgr.xq76_u7.qnpn13g2[ib]
print @q.xbgr.xq76_u7.qnpn13g2[ie]
print @q.xbgr.xq76_u7.qnpn13g2[is]
print @r.xbgr.xq76_u7.rsub[i]
print @c.xbgr.xq76_u7.csub[i]
print @q.xbgr.xq76_u8.qnpn13g2[ic]
print @q.xbgr.xq76_u8.qnpn13g2[ib]
print @q.xbgr.xq76_u8.qnpn13g2[ie]
print @q.xbgr.xq76_u8.qnpn13g2[is]
print @r.xbgr.xq76_u8.rsub[i]
print @c.xbgr.xq76_u8.csub[i]
print @q.xbgr.xq76_u9.qnpn13g2[ic]
print @q.xbgr.xq76_u9.qnpn13g2[ib]
print @q.xbgr.xq76_u9.qnpn13g2[ie]
print @q.xbgr.xq76_u9.qnpn13g2[is]
print @r.xbgr.xq76_u9.rsub[i]
print @c.xbgr.xq76_u9.csub[i]
print @q.xbgr.xq76_u10.qnpn13g2[ic]
print @q.xbgr.xq76_u10.qnpn13g2[ib]
print @q.xbgr.xq76_u10.qnpn13g2[ie]
print @q.xbgr.xq76_u10.qnpn13g2[is]
print @r.xbgr.xq76_u10.rsub[i]
print @c.xbgr.xq76_u10.csub[i]
print @q.xbgr.xq76_u11.qnpn13g2[ic]
print @q.xbgr.xq76_u11.qnpn13g2[ib]
print @q.xbgr.xq76_u11.qnpn13g2[ie]
print @q.xbgr.xq76_u11.qnpn13g2[is]
print @r.xbgr.xq76_u11.rsub[i]
print @c.xbgr.xq76_u11.csub[i]
print @q.xbgr.xq76_u12.qnpn13g2[ic]
print @q.xbgr.xq76_u12.qnpn13g2[ib]
print @q.xbgr.xq76_u12.qnpn13g2[ie]
print @q.xbgr.xq76_u12.qnpn13g2[is]
print @r.xbgr.xq76_u12.rsub[i]
print @c.xbgr.xq76_u12.csub[i]
print @q.xbgr.xq76_u13.qnpn13g2[ic]
print @q.xbgr.xq76_u13.qnpn13g2[ib]
print @q.xbgr.xq76_u13.qnpn13g2[ie]
print @q.xbgr.xq76_u13.qnpn13g2[is]
print @r.xbgr.xq76_u13.rsub[i]
print @c.xbgr.xq76_u13.csub[i]
print @q.xbgr.xq76_u14.qnpn13g2[ic]
print @q.xbgr.xq76_u14.qnpn13g2[ib]
print @q.xbgr.xq76_u14.qnpn13g2[ie]
print @q.xbgr.xq76_u14.qnpn13g2[is]
print @r.xbgr.xq76_u14.rsub[i]
print @c.xbgr.xq76_u14.csub[i]
print @q.xbgr.xq76_u15.qnpn13g2[ic]
print @q.xbgr.xq76_u15.qnpn13g2[ib]
print @q.xbgr.xq76_u15.qnpn13g2[ie]
print @q.xbgr.xq76_u15.qnpn13g2[is]
print @r.xbgr.xq76_u15.rsub[i]
print @c.xbgr.xq76_u15.csub[i]
print @q.xbgr.xq76_u16.qnpn13g2[ic]
print @q.xbgr.xq76_u16.qnpn13g2[ib]
print @q.xbgr.xq76_u16.qnpn13g2[ie]
print @q.xbgr.xq76_u16.qnpn13g2[is]
print @r.xbgr.xq76_u16.rsub[i]
print @c.xbgr.xq76_u16.csub[i]
print @q.xbgr.xq76_u17.qnpn13g2[ic]
print @q.xbgr.xq76_u17.qnpn13g2[ib]
print @q.xbgr.xq76_u17.qnpn13g2[ie]
print @q.xbgr.xq76_u17.qnpn13g2[is]
print @r.xbgr.xq76_u17.rsub[i]
print @c.xbgr.xq76_u17.csub[i]
print @q.xbgr.xq76_u18.qnpn13g2[ic]
print @q.xbgr.xq76_u18.qnpn13g2[ib]
print @q.xbgr.xq76_u18.qnpn13g2[ie]
print @q.xbgr.xq76_u18.qnpn13g2[is]
print @r.xbgr.xq76_u18.rsub[i]
print @c.xbgr.xq76_u18.csub[i]
print @q.xbgr.xq76_u19.qnpn13g2[ic]
print @q.xbgr.xq76_u19.qnpn13g2[ib]
print @q.xbgr.xq76_u19.qnpn13g2[ie]
print @q.xbgr.xq76_u19.qnpn13g2[is]
print @r.xbgr.xq76_u19.rsub[i]
print @c.xbgr.xq76_u19.csub[i]
print @q.xbgr.xq76_u20.qnpn13g2[ic]
print @q.xbgr.xq76_u20.qnpn13g2[ib]
print @q.xbgr.xq76_u20.qnpn13g2[ie]
print @q.xbgr.xq76_u20.qnpn13g2[is]
print @r.xbgr.xq76_u20.rsub[i]
print @c.xbgr.xq76_u20.csub[i]
print @q.xbgr.xq76_u21.qnpn13g2[ic]
print @q.xbgr.xq76_u21.qnpn13g2[ib]
print @q.xbgr.xq76_u21.qnpn13g2[ie]
print @q.xbgr.xq76_u21.qnpn13g2[is]
print @r.xbgr.xq76_u21.rsub[i]
print @c.xbgr.xq76_u21.csub[i]
print @q.xbgr.xq76_u22.qnpn13g2[ic]
print @q.xbgr.xq76_u22.qnpn13g2[ib]
print @q.xbgr.xq76_u22.qnpn13g2[ie]
print @q.xbgr.xq76_u22.qnpn13g2[is]
print @r.xbgr.xq76_u22.rsub[i]
print @c.xbgr.xq76_u22.csub[i]
print @q.xbgr.xq76_u23.qnpn13g2[ic]
print @q.xbgr.xq76_u23.qnpn13g2[ib]
print @q.xbgr.xq76_u23.qnpn13g2[ie]
print @q.xbgr.xq76_u23.qnpn13g2[is]
print @r.xbgr.xq76_u23.rsub[i]
print @c.xbgr.xq76_u23.csub[i]
print @q.xbgr.xq76_u24.qnpn13g2[ic]
print @q.xbgr.xq76_u24.qnpn13g2[ib]
print @q.xbgr.xq76_u24.qnpn13g2[ie]
print @q.xbgr.xq76_u24.qnpn13g2[is]
print @r.xbgr.xq76_u24.rsub[i]
print @c.xbgr.xq76_u24.csub[i]
print @n.xbgr.xr77_u2.nr1[ibody]
print @n.xbgr.xr77_u3.nr1[ibody]
print @n.xbgr.xr77_u4.nr1[ibody]
print @n.xbgr.xr77_u5.nr1[ibody]
print @n.xbgr.xr77_u6.nr1[ibody]
print @n.xbgr.xr77_u7.nr1[ibody]
print @n.xbgr.xr77_u8.nr1[ibody]
print @n.xbgr.xr77_u9.nr1[ibody]
print @n.xbgr.xr77_u10.nr1[ibody]
print @n.xbgr.xr77_u11.nr1[ibody]
print @n.xbgr.xr77_u12.nr1[ibody]
print @n.xbgr.xr77_u13.nr1[ibody]
print @n.xbgr.xr77_u14.nr1[ibody]
print @n.xbgr.xr77_u15.nr1[ibody]
print @n.xbgr.xr77_u16.nr1[ibody]
print @n.xbgr.xr77_u17.nr1[ibody]
print @n.xbgr.xr77_u18.nr1[ibody]
print @n.xbgr.xr77_u19.nr1[ibody]
print @n.xbgr.xr77_u20.nr1[ibody]
print @n.xbgr.xr77_u21.nr1[ibody]
print @n.xbgr.xr77_u22.nr1[ibody]
print @n.xbgr.xr77_u23.nr1[ibody]
print @n.xbgr.xr77_u24.nr1[ibody]
print @n.xbgr.xr78_u2.nr1[ibody]
print @n.xbgr.xr78_u3.nr1[ibody]
print @n.xbgr.xr78_u4.nr1[ibody]
print @n.xbgr.xr78_u5.nr1[ibody]
print @n.xbgr.xr78_u6.nr1[ibody]
print @n.xbgr.xr78_u7.nr1[ibody]
print @n.xbgr.xr78_u8.nr1[ibody]
print @n.xbgr.xr78_u9.nr1[ibody]
print @n.xbgr.xr78_u10.nr1[ibody]
print @n.xbgr.xr78_u11.nr1[ibody]
print @n.xbgr.xr78_u12.nr1[ibody]
print @n.xbgr.xr78_u13.nr1[ibody]
print @n.xbgr.xr78_u14.nr1[ibody]
print @n.xbgr.xr78_u15.nr1[ibody]
print @n.xbgr.xr78_u16.nr1[ibody]
print @n.xbgr.xr78_u17.nr1[ibody]
print @n.xbgr.xr78_u18.nr1[ibody]
print @n.xbgr.xr78_u19.nr1[ibody]
print @n.xbgr.xr78_u20.nr1[ibody]
print @n.xbgr.xr78_u21.nr1[ibody]
print @n.xbgr.xr78_u22.nr1[ibody]
print @n.xbgr.xr78_u23.nr1[ibody]
print @n.xbgr.xr78_u24.nr1[ibody]
print @n.xbgr.xr79_u2.nr1[ibody]
print @n.xbgr.xr79_u3.nr1[ibody]
print @n.xbgr.xr79_u4.nr1[ibody]
print @n.xbgr.xr79_u5.nr1[ibody]
print @n.xbgr.xr79_u6.nr1[ibody]
print @n.xbgr.xr79_u7.nr1[ibody]
print @n.xbgr.xr79_u8.nr1[ibody]
print @n.xbgr.xr79_u9.nr1[ibody]
print @n.xbgr.xr79_u10.nr1[ibody]
print @n.xbgr.xr79_u11.nr1[ibody]
print @n.xbgr.xr79_u12.nr1[ibody]
print @n.xbgr.xr79_u13.nr1[ibody]
print @n.xbgr.xr79_u14.nr1[ibody]
print @n.xbgr.xr79_u15.nr1[ibody]
print @n.xbgr.xr79_u16.nr1[ibody]
print @n.xbgr.xr79_u17.nr1[ibody]
print @n.xbgr.xr79_u18.nr1[ibody]
print @n.xbgr.xr79_u19.nr1[ibody]
print @n.xbgr.xr79_u20.nr1[ibody]
print @n.xbgr.xr79_u21.nr1[ibody]
print @n.xbgr.xr79_u22.nr1[ibody]
print @n.xbgr.xr79_u23.nr1[ibody]
print @n.xbgr.xr79_u24.nr1[ibody]
print @n.xbgr.xr80_u2.nr1[ibody]
print @n.xbgr.xr80_u3.nr1[ibody]
print @n.xbgr.xr80_u4.nr1[ibody]
print @n.xbgr.xr80_u5.nr1[ibody]
print @n.xbgr.xr80_u6.nr1[ibody]
print @n.xbgr.xr80_u7.nr1[ibody]
print @n.xbgr.xr80_u8.nr1[ibody]
print @n.xbgr.xr80_u9.nr1[ibody]
print @n.xbgr.xr80_u10.nr1[ibody]
print @n.xbgr.xr80_u11.nr1[ibody]
print @n.xbgr.xr80_u12.nr1[ibody]
print @n.xbgr.xr80_u13.nr1[ibody]
print @n.xbgr.xr80_u14.nr1[ibody]
print @n.xbgr.xr80_u15.nr1[ibody]
print @n.xbgr.xr80_u16.nr1[ibody]
print @n.xbgr.xr80_u17.nr1[ibody]
print @n.xbgr.xr80_u18.nr1[ibody]
print @n.xbgr.xr80_u19.nr1[ibody]
print @n.xbgr.xr80_u20.nr1[ibody]
print @n.xbgr.xr80_u21.nr1[ibody]
print @n.xbgr.xr80_u22.nr1[ibody]
print @n.xbgr.xr80_u23.nr1[ibody]
print @n.xbgr.xr80_u24.nr1[ibody]
print @n.xbgr.xr81_u2.nr1[ibody]
print @n.xbgr.xr81_u3.nr1[ibody]
print @n.xbgr.xr81_u4.nr1[ibody]
print @n.xbgr.xr81_u5.nr1[ibody]
print @n.xbgr.xr81_u6.nr1[ibody]
print @n.xbgr.xr81_u7.nr1[ibody]
print @n.xbgr.xr81_u8.nr1[ibody]
print @n.xbgr.xr81_u9.nr1[ibody]
print @n.xbgr.xr81_u10.nr1[ibody]
print @n.xbgr.xr81_u11.nr1[ibody]
print @n.xbgr.xr81_u12.nr1[ibody]
print @n.xbgr.xr81_u13.nr1[ibody]
print @n.xbgr.xr81_u14.nr1[ibody]
print @n.xbgr.xr81_u15.nr1[ibody]
print @n.xbgr.xr81_u16.nr1[ibody]
print @n.xbgr.xr81_u17.nr1[ibody]
print @n.xbgr.xr81_u18.nr1[ibody]
print @n.xbgr.xr81_u19.nr1[ibody]
print @n.xbgr.xr81_u20.nr1[ibody]
print @n.xbgr.xr81_u21.nr1[ibody]
print @n.xbgr.xr81_u22.nr1[ibody]
print @n.xbgr.xr81_u23.nr1[ibody]
print @n.xbgr.xr81_u24.nr1[ibody]
print @n.xbgr.xr82_u2.nr1[ibody]
print @n.xbgr.xr82_u3.nr1[ibody]
print @n.xbgr.xr82_u4.nr1[ibody]
print @n.xbgr.xr82_u5.nr1[ibody]
print @n.xbgr.xr82_u6.nr1[ibody]
print @n.xbgr.xr82_u7.nr1[ibody]
print @n.xbgr.xr82_u8.nr1[ibody]
print @n.xbgr.xr82_u9.nr1[ibody]
print @n.xbgr.xr82_u10.nr1[ibody]
print @n.xbgr.xr82_u11.nr1[ibody]
print @n.xbgr.xr82_u12.nr1[ibody]
print @n.xbgr.xr82_u13.nr1[ibody]
print @n.xbgr.xr82_u14.nr1[ibody]
print @n.xbgr.xr82_u15.nr1[ibody]
print @n.xbgr.xr82_u16.nr1[ibody]
print @n.xbgr.xr82_u17.nr1[ibody]
print @n.xbgr.xr82_u18.nr1[ibody]
print @n.xbgr.xr82_u19.nr1[ibody]
print @n.xbgr.xr82_u20.nr1[ibody]
print @n.xbgr.xr82_u21.nr1[ibody]
print @n.xbgr.xr82_u22.nr1[ibody]
print @n.xbgr.xr82_u23.nr1[ibody]
print @n.xbgr.xr82_u24.nr1[ibody]
print @n.xbgr.xr83_u2.nr1[ibody]
print @n.xbgr.xr83_u3.nr1[ibody]
print @n.xbgr.xr83_u4.nr1[ibody]
print @n.xbgr.xr83_u5.nr1[ibody]
print @n.xbgr.xr83_u6.nr1[ibody]
print @n.xbgr.xr83_u7.nr1[ibody]
print @n.xbgr.xr83_u8.nr1[ibody]
print @n.xbgr.xr83_u9.nr1[ibody]
print @n.xbgr.xr83_u10.nr1[ibody]
print @n.xbgr.xr83_u11.nr1[ibody]
print @n.xbgr.xr83_u12.nr1[ibody]
print @n.xbgr.xr83_u13.nr1[ibody]
print @n.xbgr.xr83_u14.nr1[ibody]
print @n.xbgr.xr83_u15.nr1[ibody]
print @n.xbgr.xr83_u16.nr1[ibody]
print @n.xbgr.xr83_u17.nr1[ibody]
print @n.xbgr.xr83_u18.nr1[ibody]
print @n.xbgr.xr83_u19.nr1[ibody]
print @n.xbgr.xr83_u20.nr1[ibody]
print @n.xbgr.xr83_u21.nr1[ibody]
print @n.xbgr.xr83_u22.nr1[ibody]
print @n.xbgr.xr83_u23.nr1[ibody]
print @n.xbgr.xr83_u24.nr1[ibody]
print @n.xbgr.xr84_u2.nr1[ibody]
print @n.xbgr.xr84_u3.nr1[ibody]
print @n.xbgr.xr84_u4.nr1[ibody]
print @n.xbgr.xr84_u5.nr1[ibody]
print @n.xbgr.xr84_u6.nr1[ibody]
print @n.xbgr.xr84_u7.nr1[ibody]
print @n.xbgr.xr84_u8.nr1[ibody]
print @n.xbgr.xr84_u9.nr1[ibody]
print @n.xbgr.xr84_u10.nr1[ibody]
print @n.xbgr.xr84_u11.nr1[ibody]
print @n.xbgr.xr84_u12.nr1[ibody]
print @n.xbgr.xr84_u13.nr1[ibody]
print @n.xbgr.xr84_u14.nr1[ibody]
print @n.xbgr.xr84_u15.nr1[ibody]
print @n.xbgr.xr84_u16.nr1[ibody]
print @n.xbgr.xr84_u17.nr1[ibody]
print @n.xbgr.xr84_u18.nr1[ibody]
print @n.xbgr.xr84_u19.nr1[ibody]
print @n.xbgr.xr84_u20.nr1[ibody]
print @n.xbgr.xr84_u21.nr1[ibody]
print @n.xbgr.xr84_u22.nr1[ibody]
print @n.xbgr.xr84_u23.nr1[ibody]
print @n.xbgr.xr84_u24.nr1[ibody]
print @n.xbgr.xr85_u2.nr1[ibody]
print @n.xbgr.xr85_u3.nr1[ibody]
print @n.xbgr.xr85_u4.nr1[ibody]
print @n.xbgr.xr85_u5.nr1[ibody]
print @n.xbgr.xr85_u6.nr1[ibody]
print @n.xbgr.xr85_u7.nr1[ibody]
print @n.xbgr.xr85_u8.nr1[ibody]
print @n.xbgr.xr85_u9.nr1[ibody]
print @n.xbgr.xr85_u10.nr1[ibody]
print @n.xbgr.xr85_u11.nr1[ibody]
print @n.xbgr.xr85_u12.nr1[ibody]
print @n.xbgr.xr85_u13.nr1[ibody]
print @n.xbgr.xr85_u14.nr1[ibody]
print @n.xbgr.xr85_u15.nr1[ibody]
print @n.xbgr.xr85_u16.nr1[ibody]
print @n.xbgr.xr85_u17.nr1[ibody]
print @n.xbgr.xr85_u18.nr1[ibody]
print @n.xbgr.xr85_u19.nr1[ibody]
print @n.xbgr.xr85_u20.nr1[ibody]
print @n.xbgr.xr85_u21.nr1[ibody]
print @n.xbgr.xr85_u22.nr1[ibody]
print @n.xbgr.xr85_u23.nr1[ibody]
print @n.xbgr.xr85_u24.nr1[ibody]
print @n.xbgr.xr86_u2.nr1[ibody]
print @n.xbgr.xr86_u3.nr1[ibody]
print @n.xbgr.xr86_u4.nr1[ibody]
print @n.xbgr.xr86_u5.nr1[ibody]
print @n.xbgr.xr86_u6.nr1[ibody]
print @n.xbgr.xr86_u7.nr1[ibody]
print @n.xbgr.xr86_u8.nr1[ibody]
print @n.xbgr.xr86_u9.nr1[ibody]
print @n.xbgr.xr86_u10.nr1[ibody]
print @n.xbgr.xr86_u11.nr1[ibody]
print @n.xbgr.xr86_u12.nr1[ibody]
print @n.xbgr.xr86_u13.nr1[ibody]
print @n.xbgr.xr86_u14.nr1[ibody]
print @n.xbgr.xr86_u15.nr1[ibody]
print @n.xbgr.xr86_u16.nr1[ibody]
print @n.xbgr.xr86_u17.nr1[ibody]
print @n.xbgr.xr86_u18.nr1[ibody]
print @n.xbgr.xr86_u19.nr1[ibody]
print @n.xbgr.xr86_u20.nr1[ibody]
print @n.xbgr.xr86_u21.nr1[ibody]
print @n.xbgr.xr86_u22.nr1[ibody]
print @n.xbgr.xr86_u23.nr1[ibody]
print @n.xbgr.xr86_u24.nr1[ibody]
echo RAW_CURRENT_LEDGER_END
wrdata op_nodes.dat v(xbgr.b1b) v(xbgr.c2) v(xbgr.d1) v(xbgr.d2) v(xbgr.d3) v(xbgr.d4) v(xbgr.d5) v(xbgr.det) v(dvbe) v(iptat) v(xbgr.kick) v(xbgr.n1) v(xbgr.n_10) v(xbgr.n_11) v(xbgr.n_12) v(xbgr.n_13) v(xbgr.n_14) v(xbgr.n_15) v(xbgr.n_16) v(xbgr.n_17) v(xbgr.n_18) v(xbgr.n_19) v(xbgr.n_2) v(xbgr.n_21) v(xbgr.n_22) v(xbgr.n_23) v(xbgr.n_24) v(xbgr.n_25) v(xbgr.n_26) v(xbgr.n_27) v(xbgr.n_3) v(xbgr.n_30) v(xbgr.n_31) v(xbgr.n_33) v(xbgr.n_34) v(xbgr.n_36) v(xbgr.n_37) v(xbgr.n_4) v(xbgr.n_5) v(xbgr.n_6) v(xbgr.n_7) v(xbgr.n_8) v(xbgr.n_9) v(pbias) v(pcasc) v(r4) v(xbgr.r4n) v(xbgr.vb2) v(vbe) v(xbgr.vbe3) v(xbgr.vd1) v(xbgr.vd2) v(vdd) v(vref) v(vdd)-v(vdd) i(vdd) i(vload) i(vr4) i(vsub)
print @n.xbgr.xr1.nr1[nsmm_rsh]
print @n.xbgr.xr1.nr1[nsmm_w]
print @n.xbgr.xr1.nr1[nsmm_l]
print @n.xbgr.xr2.nr1[nsmm_rsh]
print @n.xbgr.xr2.nr1[nsmm_w]
print @n.xbgr.xr2.nr1[nsmm_l]
print @n.xbgr.xr3.nr1[nsmm_rsh]
print @n.xbgr.xr3.nr1[nsmm_w]
print @n.xbgr.xr3.nr1[nsmm_l]
print @n.xbgr.xr4.nr1[nsmm_rsh]
print @n.xbgr.xr4.nr1[nsmm_w]
print @n.xbgr.xr4.nr1[nsmm_l]
print @n.xbgr.xr5.nr1[nsmm_rsh]
print @n.xbgr.xr5.nr1[nsmm_w]
print @n.xbgr.xr5.nr1[nsmm_l]
print @n.xbgr.xr6.nr1[nsmm_rsh]
print @n.xbgr.xr6.nr1[nsmm_w]
print @n.xbgr.xr6.nr1[nsmm_l]
print @n.xbgr.xr7.nr1[nsmm_rsh]
print @n.xbgr.xr7.nr1[nsmm_w]
print @n.xbgr.xr7.nr1[nsmm_l]
print @n.xbgr.xr8.nr1[nsmm_rsh]
print @n.xbgr.xr8.nr1[nsmm_w]
print @n.xbgr.xr8.nr1[nsmm_l]
print @n.xbgr.xr9.nr1[nsmm_rsh]
print @n.xbgr.xr9.nr1[nsmm_w]
print @n.xbgr.xr9.nr1[nsmm_l]
print @n.xbgr.xr10.nr1[nsmm_rsh]
print @n.xbgr.xr10.nr1[nsmm_w]
print @n.xbgr.xr10.nr1[nsmm_l]
print @n.xbgr.xr11.nr1[nsmm_rsh]
print @n.xbgr.xr11.nr1[nsmm_w]
print @n.xbgr.xr11.nr1[nsmm_l]
print @n.xbgr.xr12.nr1[nsmm_rsh]
print @n.xbgr.xr12.nr1[nsmm_w]
print @n.xbgr.xr12.nr1[nsmm_l]
print @n.xbgr.xr13.nr1[nsmm_rsh]
print @n.xbgr.xr13.nr1[nsmm_w]
print @n.xbgr.xr13.nr1[nsmm_l]
print @n.xbgr.xr14.nr1[nsmm_rsh]
print @n.xbgr.xr14.nr1[nsmm_w]
print @n.xbgr.xr14.nr1[nsmm_l]
print @n.xbgr.xr15.nr1[nsmm_rsh]
print @n.xbgr.xr15.nr1[nsmm_w]
print @n.xbgr.xr15.nr1[nsmm_l]
print @n.xbgr.xr16.nr1[nsmm_rsh]
print @n.xbgr.xr16.nr1[nsmm_w]
print @n.xbgr.xr16.nr1[nsmm_l]
print @n.xbgr.xr17.nr1[nsmm_rsh]
print @n.xbgr.xr17.nr1[nsmm_w]
print @n.xbgr.xr17.nr1[nsmm_l]
print @n.xbgr.xr18.nr1[nsmm_rsh]
print @n.xbgr.xr18.nr1[nsmm_w]
print @n.xbgr.xr18.nr1[nsmm_l]
print @n.xbgr.xr19.nr1[nsmm_rsh]
print @n.xbgr.xr19.nr1[nsmm_w]
print @n.xbgr.xr19.nr1[nsmm_l]
print @n.xbgr.xr20.nr1[nsmm_rsh]
print @n.xbgr.xr20.nr1[nsmm_w]
print @n.xbgr.xr20.nr1[nsmm_l]
print @n.xbgr.xr21.nr1[nsmm_rsh]
print @n.xbgr.xr21.nr1[nsmm_w]
print @n.xbgr.xr21.nr1[nsmm_l]
print @n.xbgr.xr22.nr1[nsmm_rsh]
print @n.xbgr.xr22.nr1[nsmm_w]
print @n.xbgr.xr22.nr1[nsmm_l]
print @n.xbgr.xr23.nr1[nsmm_rsh]
print @n.xbgr.xr23.nr1[nsmm_w]
print @n.xbgr.xr23.nr1[nsmm_l]
print @n.xbgr.xr24.nr1[nsmm_rsh]
print @n.xbgr.xr24.nr1[nsmm_w]
print @n.xbgr.xr24.nr1[nsmm_l]
print @n.xbgr.xr25.nr1[nsmm_rsh]
print @n.xbgr.xr25.nr1[nsmm_w]
print @n.xbgr.xr25.nr1[nsmm_l]
print @n.xbgr.xr26.nr1[nsmm_rsh]
print @n.xbgr.xr26.nr1[nsmm_w]
print @n.xbgr.xr26.nr1[nsmm_l]
print @n.xbgr.xm27.nsg13_hv_pmos[w]
print @n.xbgr.xm27.nsg13_hv_pmos[l]
print @n.xbgr.xm27.nsg13_hv_pmos[delvto]
print @n.xbgr.xm27.nsg13_hv_pmos[factuo]
print @n.xbgr.xm28.nsg13_hv_pmos[w]
print @n.xbgr.xm28.nsg13_hv_pmos[l]
print @n.xbgr.xm28.nsg13_hv_pmos[delvto]
print @n.xbgr.xm28.nsg13_hv_pmos[factuo]
print @n.xbgr.xm29.nsg13_hv_nmos[w]
print @n.xbgr.xm29.nsg13_hv_nmos[l]
print @n.xbgr.xm29.nsg13_hv_nmos[delvto]
print @n.xbgr.xm29.nsg13_hv_nmos[factuo]
print @n.xbgr.xm30.nsg13_hv_nmos[w]
print @n.xbgr.xm30.nsg13_hv_nmos[l]
print @n.xbgr.xm30.nsg13_hv_nmos[delvto]
print @n.xbgr.xm30.nsg13_hv_nmos[factuo]
print @n.xbgr.xm31.nsg13_hv_nmos[w]
print @n.xbgr.xm31.nsg13_hv_nmos[l]
print @n.xbgr.xm31.nsg13_hv_nmos[delvto]
print @n.xbgr.xm31.nsg13_hv_nmos[factuo]
print @n.xbgr.xm32.nsg13_hv_nmos[w]
print @n.xbgr.xm32.nsg13_hv_nmos[l]
print @n.xbgr.xm32.nsg13_hv_nmos[delvto]
print @n.xbgr.xm32.nsg13_hv_nmos[factuo]
print @n.xbgr.xm33.nsg13_hv_nmos[w]
print @n.xbgr.xm33.nsg13_hv_nmos[l]
print @n.xbgr.xm33.nsg13_hv_nmos[delvto]
print @n.xbgr.xm33.nsg13_hv_nmos[factuo]
print @n.xbgr.xm34.nsg13_hv_nmos[w]
print @n.xbgr.xm34.nsg13_hv_nmos[l]
print @n.xbgr.xm34.nsg13_hv_nmos[delvto]
print @n.xbgr.xm34.nsg13_hv_nmos[factuo]
print @n.xbgr.xm35.nsg13_hv_nmos[w]
print @n.xbgr.xm35.nsg13_hv_nmos[l]
print @n.xbgr.xm35.nsg13_hv_nmos[delvto]
print @n.xbgr.xm35.nsg13_hv_nmos[factuo]
print @n.xbgr.xm36.nsg13_hv_nmos[w]
print @n.xbgr.xm36.nsg13_hv_nmos[l]
print @n.xbgr.xm36.nsg13_hv_nmos[delvto]
print @n.xbgr.xm36.nsg13_hv_nmos[factuo]
print @n.xbgr.xm37.nsg13_hv_nmos[w]
print @n.xbgr.xm37.nsg13_hv_nmos[l]
print @n.xbgr.xm37.nsg13_hv_nmos[delvto]
print @n.xbgr.xm37.nsg13_hv_nmos[factuo]
print @n.xbgr.xm38.nsg13_hv_pmos[w]
print @n.xbgr.xm38.nsg13_hv_pmos[l]
print @n.xbgr.xm38.nsg13_hv_pmos[delvto]
print @n.xbgr.xm38.nsg13_hv_pmos[factuo]
print @n.xbgr.xm39.nsg13_hv_pmos[w]
print @n.xbgr.xm39.nsg13_hv_pmos[l]
print @n.xbgr.xm39.nsg13_hv_pmos[delvto]
print @n.xbgr.xm39.nsg13_hv_pmos[factuo]
print @n.xbgr.xm40.nsg13_hv_pmos[w]
print @n.xbgr.xm40.nsg13_hv_pmos[l]
print @n.xbgr.xm40.nsg13_hv_pmos[delvto]
print @n.xbgr.xm40.nsg13_hv_pmos[factuo]
print @n.xbgr.xm41.nsg13_hv_pmos[w]
print @n.xbgr.xm41.nsg13_hv_pmos[l]
print @n.xbgr.xm41.nsg13_hv_pmos[delvto]
print @n.xbgr.xm41.nsg13_hv_pmos[factuo]
print @n.xbgr.xm42.nsg13_hv_pmos[w]
print @n.xbgr.xm42.nsg13_hv_pmos[l]
print @n.xbgr.xm42.nsg13_hv_pmos[delvto]
print @n.xbgr.xm42.nsg13_hv_pmos[factuo]
print @n.xbgr.xm43.nsg13_hv_pmos[w]
print @n.xbgr.xm43.nsg13_hv_pmos[l]
print @n.xbgr.xm43.nsg13_hv_pmos[delvto]
print @n.xbgr.xm43.nsg13_hv_pmos[factuo]
print @n.xbgr.xm44.nsg13_hv_pmos[w]
print @n.xbgr.xm44.nsg13_hv_pmos[l]
print @n.xbgr.xm44.nsg13_hv_pmos[delvto]
print @n.xbgr.xm44.nsg13_hv_pmos[factuo]
print @n.xbgr.xm45.nsg13_hv_pmos[w]
print @n.xbgr.xm45.nsg13_hv_pmos[l]
print @n.xbgr.xm45.nsg13_hv_pmos[delvto]
print @n.xbgr.xm45.nsg13_hv_pmos[factuo]
print @n.xbgr.xm46.nsg13_hv_pmos[w]
print @n.xbgr.xm46.nsg13_hv_pmos[l]
print @n.xbgr.xm46.nsg13_hv_pmos[delvto]
print @n.xbgr.xm46.nsg13_hv_pmos[factuo]
print @n.xbgr.xm47.nsg13_hv_pmos[w]
print @n.xbgr.xm47.nsg13_hv_pmos[l]
print @n.xbgr.xm47.nsg13_hv_pmos[delvto]
print @n.xbgr.xm47.nsg13_hv_pmos[factuo]
print @n.xbgr.xm48.nsg13_hv_pmos[w]
print @n.xbgr.xm48.nsg13_hv_pmos[l]
print @n.xbgr.xm48.nsg13_hv_pmos[delvto]
print @n.xbgr.xm48.nsg13_hv_pmos[factuo]
print @n.xbgr.xm49.nsg13_hv_pmos[w]
print @n.xbgr.xm49.nsg13_hv_pmos[l]
print @n.xbgr.xm49.nsg13_hv_pmos[delvto]
print @n.xbgr.xm49.nsg13_hv_pmos[factuo]
print @n.xbgr.xm50.nsg13_hv_pmos[w]
print @n.xbgr.xm50.nsg13_hv_pmos[l]
print @n.xbgr.xm50.nsg13_hv_pmos[delvto]
print @n.xbgr.xm50.nsg13_hv_pmos[factuo]
print @n.xbgr.xm51.nsg13_hv_pmos[w]
print @n.xbgr.xm51.nsg13_hv_pmos[l]
print @n.xbgr.xm51.nsg13_hv_pmos[delvto]
print @n.xbgr.xm51.nsg13_hv_pmos[factuo]
print @n.xbgr.xm52.nsg13_hv_pmos[w]
print @n.xbgr.xm52.nsg13_hv_pmos[l]
print @n.xbgr.xm52.nsg13_hv_pmos[delvto]
print @n.xbgr.xm52.nsg13_hv_pmos[factuo]
print @n.xbgr.xm53.nsg13_hv_pmos[w]
print @n.xbgr.xm53.nsg13_hv_pmos[l]
print @n.xbgr.xm53.nsg13_hv_pmos[delvto]
print @n.xbgr.xm53.nsg13_hv_pmos[factuo]
print @n.xbgr.xm54.nsg13_hv_pmos[w]
print @n.xbgr.xm54.nsg13_hv_pmos[l]
print @n.xbgr.xm54.nsg13_hv_pmos[delvto]
print @n.xbgr.xm54.nsg13_hv_pmos[factuo]
print @q.xbgr.xq55.qnpn13g2[area]
print @q.xbgr.xq56.qnpn13g2[area]
print @q.xbgr.xq57.qnpn13g2[area]
print @q.xbgr.xq58.qnpn13g2[area]
print @q.xbgr.xq59.qnpn13g2[area]
print @q.xbgr.xq60.qnpn13g2[area]
print @q.xbgr.xq61.qnpn13g2[area]
print @q.xbgr.xq62.qnpn13g2[area]
print @q.xbgr.xq63.qnpn13g2[area]
print @q.xbgr.xq64.qnpn13g2[area]
print @q.xbgr.xq65.qnpn13g2[area]
print @q.xbgr.xq66.qnpn13g2[area]
print @q.xbgr.xq67.qnpn13g2[area]
print @q.xbgr.xq68.qnpn13g2[area]
print @q.xbgr.xq69.qnpn13g2[area]
print @q.xbgr.xq70.qnpn13g2[area]
print @q.xbgr.xq71.qnpn13g2[area]
print @q.xbgr.xq72.qnpn13g2[area]
print @q.xbgr.xq73.qnpn13g2[area]
print @q.xbgr.xq74.qnpn13g2[area]
print @q.xbgr.xq75.qnpn13g2[area]
print @q.xbgr.xq76.qnpn13g2[area]
print @n.xbgr.xr77.nr1[nsmm_rsh]
print @n.xbgr.xr77.nr1[nsmm_w]
print @n.xbgr.xr77.nr1[nsmm_l]
print @n.xbgr.xr78.nr1[nsmm_rsh]
print @n.xbgr.xr78.nr1[nsmm_w]
print @n.xbgr.xr78.nr1[nsmm_l]
print @n.xbgr.xr79.nr1[nsmm_rsh]
print @n.xbgr.xr79.nr1[nsmm_w]
print @n.xbgr.xr79.nr1[nsmm_l]
print @n.xbgr.xr80.nr1[nsmm_rsh]
print @n.xbgr.xr80.nr1[nsmm_w]
print @n.xbgr.xr80.nr1[nsmm_l]
print @n.xbgr.xr81.nr1[nsmm_rsh]
print @n.xbgr.xr81.nr1[nsmm_w]
print @n.xbgr.xr81.nr1[nsmm_l]
print @n.xbgr.xr82.nr1[nsmm_rsh]
print @n.xbgr.xr82.nr1[nsmm_w]
print @n.xbgr.xr82.nr1[nsmm_l]
print @n.xbgr.xr83.nr1[nsmm_rsh]
print @n.xbgr.xr83.nr1[nsmm_w]
print @n.xbgr.xr83.nr1[nsmm_l]
print @n.xbgr.xr84.nr1[nsmm_rsh]
print @n.xbgr.xr84.nr1[nsmm_w]
print @n.xbgr.xr84.nr1[nsmm_l]
print @n.xbgr.xr85.nr1[nsmm_rsh]
print @n.xbgr.xr85.nr1[nsmm_w]
print @n.xbgr.xr85.nr1[nsmm_l]
print @n.xbgr.xr86.nr1[nsmm_rsh]
print @n.xbgr.xr86.nr1[nsmm_w]
print @n.xbgr.xr86.nr1[nsmm_l]
print @n.xbgr.xr16_u2.nr1[nsmm_rsh]
print @n.xbgr.xr16_u2.nr1[nsmm_w]
print @n.xbgr.xr16_u2.nr1[nsmm_l]
print @n.xbgr.xr16_u3.nr1[nsmm_rsh]
print @n.xbgr.xr16_u3.nr1[nsmm_w]
print @n.xbgr.xr16_u3.nr1[nsmm_l]
print @n.xbgr.xr16_u4.nr1[nsmm_rsh]
print @n.xbgr.xr16_u4.nr1[nsmm_w]
print @n.xbgr.xr16_u4.nr1[nsmm_l]
print @n.xbgr.xr16_u5.nr1[nsmm_rsh]
print @n.xbgr.xr16_u5.nr1[nsmm_w]
print @n.xbgr.xr16_u5.nr1[nsmm_l]
print @n.xbgr.xr16_u6.nr1[nsmm_rsh]
print @n.xbgr.xr16_u6.nr1[nsmm_w]
print @n.xbgr.xr16_u6.nr1[nsmm_l]
print @n.xbgr.xr16_u7.nr1[nsmm_rsh]
print @n.xbgr.xr16_u7.nr1[nsmm_w]
print @n.xbgr.xr16_u7.nr1[nsmm_l]
print @n.xbgr.xr16_u8.nr1[nsmm_rsh]
print @n.xbgr.xr16_u8.nr1[nsmm_w]
print @n.xbgr.xr16_u8.nr1[nsmm_l]
print @n.xbgr.xr16_u9.nr1[nsmm_rsh]
print @n.xbgr.xr16_u9.nr1[nsmm_w]
print @n.xbgr.xr16_u9.nr1[nsmm_l]
print @n.xbgr.xr16_u10.nr1[nsmm_rsh]
print @n.xbgr.xr16_u10.nr1[nsmm_w]
print @n.xbgr.xr16_u10.nr1[nsmm_l]
print @n.xbgr.xr16_u11.nr1[nsmm_rsh]
print @n.xbgr.xr16_u11.nr1[nsmm_w]
print @n.xbgr.xr16_u11.nr1[nsmm_l]
print @n.xbgr.xr16_u12.nr1[nsmm_rsh]
print @n.xbgr.xr16_u12.nr1[nsmm_w]
print @n.xbgr.xr16_u12.nr1[nsmm_l]
print @n.xbgr.xr16_u13.nr1[nsmm_rsh]
print @n.xbgr.xr16_u13.nr1[nsmm_w]
print @n.xbgr.xr16_u13.nr1[nsmm_l]
print @n.xbgr.xr16_u14.nr1[nsmm_rsh]
print @n.xbgr.xr16_u14.nr1[nsmm_w]
print @n.xbgr.xr16_u14.nr1[nsmm_l]
print @n.xbgr.xr16_u15.nr1[nsmm_rsh]
print @n.xbgr.xr16_u15.nr1[nsmm_w]
print @n.xbgr.xr16_u15.nr1[nsmm_l]
print @n.xbgr.xr16_u16.nr1[nsmm_rsh]
print @n.xbgr.xr16_u16.nr1[nsmm_w]
print @n.xbgr.xr16_u16.nr1[nsmm_l]
print @n.xbgr.xr16_u17.nr1[nsmm_rsh]
print @n.xbgr.xr16_u17.nr1[nsmm_w]
print @n.xbgr.xr16_u17.nr1[nsmm_l]
print @n.xbgr.xr16_u18.nr1[nsmm_rsh]
print @n.xbgr.xr16_u18.nr1[nsmm_w]
print @n.xbgr.xr16_u18.nr1[nsmm_l]
print @n.xbgr.xr16_u19.nr1[nsmm_rsh]
print @n.xbgr.xr16_u19.nr1[nsmm_w]
print @n.xbgr.xr16_u19.nr1[nsmm_l]
print @n.xbgr.xr16_u20.nr1[nsmm_rsh]
print @n.xbgr.xr16_u20.nr1[nsmm_w]
print @n.xbgr.xr16_u20.nr1[nsmm_l]
print @n.xbgr.xr16_u21.nr1[nsmm_rsh]
print @n.xbgr.xr16_u21.nr1[nsmm_w]
print @n.xbgr.xr16_u21.nr1[nsmm_l]
print @n.xbgr.xr16_u22.nr1[nsmm_rsh]
print @n.xbgr.xr16_u22.nr1[nsmm_w]
print @n.xbgr.xr16_u22.nr1[nsmm_l]
print @n.xbgr.xr16_u23.nr1[nsmm_rsh]
print @n.xbgr.xr16_u23.nr1[nsmm_w]
print @n.xbgr.xr16_u23.nr1[nsmm_l]
print @n.xbgr.xr16_u24.nr1[nsmm_rsh]
print @n.xbgr.xr16_u24.nr1[nsmm_w]
print @n.xbgr.xr16_u24.nr1[nsmm_l]
print @n.xbgr.xr17_u2.nr1[nsmm_rsh]
print @n.xbgr.xr17_u2.nr1[nsmm_w]
print @n.xbgr.xr17_u2.nr1[nsmm_l]
print @n.xbgr.xr17_u3.nr1[nsmm_rsh]
print @n.xbgr.xr17_u3.nr1[nsmm_w]
print @n.xbgr.xr17_u3.nr1[nsmm_l]
print @n.xbgr.xr17_u4.nr1[nsmm_rsh]
print @n.xbgr.xr17_u4.nr1[nsmm_w]
print @n.xbgr.xr17_u4.nr1[nsmm_l]
print @n.xbgr.xr18_u2.nr1[nsmm_rsh]
print @n.xbgr.xr18_u2.nr1[nsmm_w]
print @n.xbgr.xr18_u2.nr1[nsmm_l]
print @n.xbgr.xr18_u3.nr1[nsmm_rsh]
print @n.xbgr.xr18_u3.nr1[nsmm_w]
print @n.xbgr.xr18_u3.nr1[nsmm_l]
print @n.xbgr.xr18_u4.nr1[nsmm_rsh]
print @n.xbgr.xr18_u4.nr1[nsmm_w]
print @n.xbgr.xr18_u4.nr1[nsmm_l]
print @n.xbgr.xr19_u2.nr1[nsmm_rsh]
print @n.xbgr.xr19_u2.nr1[nsmm_w]
print @n.xbgr.xr19_u2.nr1[nsmm_l]
print @n.xbgr.xr19_u3.nr1[nsmm_rsh]
print @n.xbgr.xr19_u3.nr1[nsmm_w]
print @n.xbgr.xr19_u3.nr1[nsmm_l]
print @n.xbgr.xr19_u4.nr1[nsmm_rsh]
print @n.xbgr.xr19_u4.nr1[nsmm_w]
print @n.xbgr.xr19_u4.nr1[nsmm_l]
print @n.xbgr.xr20_u2.nr1[nsmm_rsh]
print @n.xbgr.xr20_u2.nr1[nsmm_w]
print @n.xbgr.xr20_u2.nr1[nsmm_l]
print @n.xbgr.xr20_u3.nr1[nsmm_rsh]
print @n.xbgr.xr20_u3.nr1[nsmm_w]
print @n.xbgr.xr20_u3.nr1[nsmm_l]
print @n.xbgr.xr20_u4.nr1[nsmm_rsh]
print @n.xbgr.xr20_u4.nr1[nsmm_w]
print @n.xbgr.xr20_u4.nr1[nsmm_l]
print @n.xbgr.xr21_u2.nr1[nsmm_rsh]
print @n.xbgr.xr21_u2.nr1[nsmm_w]
print @n.xbgr.xr21_u2.nr1[nsmm_l]
print @n.xbgr.xr21_u3.nr1[nsmm_rsh]
print @n.xbgr.xr21_u3.nr1[nsmm_w]
print @n.xbgr.xr21_u3.nr1[nsmm_l]
print @n.xbgr.xr21_u4.nr1[nsmm_rsh]
print @n.xbgr.xr21_u4.nr1[nsmm_w]
print @n.xbgr.xr21_u4.nr1[nsmm_l]
print @n.xbgr.xr22_u2.nr1[nsmm_rsh]
print @n.xbgr.xr22_u2.nr1[nsmm_w]
print @n.xbgr.xr22_u2.nr1[nsmm_l]
print @n.xbgr.xr22_u3.nr1[nsmm_rsh]
print @n.xbgr.xr22_u3.nr1[nsmm_w]
print @n.xbgr.xr22_u3.nr1[nsmm_l]
print @n.xbgr.xr22_u4.nr1[nsmm_rsh]
print @n.xbgr.xr22_u4.nr1[nsmm_w]
print @n.xbgr.xr22_u4.nr1[nsmm_l]
print @n.xbgr.xr23_u2.nr1[nsmm_rsh]
print @n.xbgr.xr23_u2.nr1[nsmm_w]
print @n.xbgr.xr23_u2.nr1[nsmm_l]
print @n.xbgr.xr23_u3.nr1[nsmm_rsh]
print @n.xbgr.xr23_u3.nr1[nsmm_w]
print @n.xbgr.xr23_u3.nr1[nsmm_l]
print @n.xbgr.xr23_u4.nr1[nsmm_rsh]
print @n.xbgr.xr23_u4.nr1[nsmm_w]
print @n.xbgr.xr23_u4.nr1[nsmm_l]
print @n.xbgr.xr23_u5.nr1[nsmm_rsh]
print @n.xbgr.xr23_u5.nr1[nsmm_w]
print @n.xbgr.xr23_u5.nr1[nsmm_l]
print @n.xbgr.xr23_u6.nr1[nsmm_rsh]
print @n.xbgr.xr23_u6.nr1[nsmm_w]
print @n.xbgr.xr23_u6.nr1[nsmm_l]
print @n.xbgr.xr23_u7.nr1[nsmm_rsh]
print @n.xbgr.xr23_u7.nr1[nsmm_w]
print @n.xbgr.xr23_u7.nr1[nsmm_l]
print @n.xbgr.xr23_u8.nr1[nsmm_rsh]
print @n.xbgr.xr23_u8.nr1[nsmm_w]
print @n.xbgr.xr23_u8.nr1[nsmm_l]
print @n.xbgr.xr23_u9.nr1[nsmm_rsh]
print @n.xbgr.xr23_u9.nr1[nsmm_w]
print @n.xbgr.xr23_u9.nr1[nsmm_l]
print @n.xbgr.xr23_u10.nr1[nsmm_rsh]
print @n.xbgr.xr23_u10.nr1[nsmm_w]
print @n.xbgr.xr23_u10.nr1[nsmm_l]
print @n.xbgr.xr23_u11.nr1[nsmm_rsh]
print @n.xbgr.xr23_u11.nr1[nsmm_w]
print @n.xbgr.xr23_u11.nr1[nsmm_l]
print @n.xbgr.xr23_u12.nr1[nsmm_rsh]
print @n.xbgr.xr23_u12.nr1[nsmm_w]
print @n.xbgr.xr23_u12.nr1[nsmm_l]
print @n.xbgr.xr23_u13.nr1[nsmm_rsh]
print @n.xbgr.xr23_u13.nr1[nsmm_w]
print @n.xbgr.xr23_u13.nr1[nsmm_l]
print @n.xbgr.xr23_u14.nr1[nsmm_rsh]
print @n.xbgr.xr23_u14.nr1[nsmm_w]
print @n.xbgr.xr23_u14.nr1[nsmm_l]
print @n.xbgr.xr23_u15.nr1[nsmm_rsh]
print @n.xbgr.xr23_u15.nr1[nsmm_w]
print @n.xbgr.xr23_u15.nr1[nsmm_l]
print @n.xbgr.xr23_u16.nr1[nsmm_rsh]
print @n.xbgr.xr23_u16.nr1[nsmm_w]
print @n.xbgr.xr23_u16.nr1[nsmm_l]
print @n.xbgr.xr23_u17.nr1[nsmm_rsh]
print @n.xbgr.xr23_u17.nr1[nsmm_w]
print @n.xbgr.xr23_u17.nr1[nsmm_l]
print @n.xbgr.xr23_u18.nr1[nsmm_rsh]
print @n.xbgr.xr23_u18.nr1[nsmm_w]
print @n.xbgr.xr23_u18.nr1[nsmm_l]
print @n.xbgr.xr23_u19.nr1[nsmm_rsh]
print @n.xbgr.xr23_u19.nr1[nsmm_w]
print @n.xbgr.xr23_u19.nr1[nsmm_l]
print @n.xbgr.xr23_u20.nr1[nsmm_rsh]
print @n.xbgr.xr23_u20.nr1[nsmm_w]
print @n.xbgr.xr23_u20.nr1[nsmm_l]
print @n.xbgr.xr23_u21.nr1[nsmm_rsh]
print @n.xbgr.xr23_u21.nr1[nsmm_w]
print @n.xbgr.xr23_u21.nr1[nsmm_l]
print @n.xbgr.xr23_u22.nr1[nsmm_rsh]
print @n.xbgr.xr23_u22.nr1[nsmm_w]
print @n.xbgr.xr23_u22.nr1[nsmm_l]
print @n.xbgr.xr23_u23.nr1[nsmm_rsh]
print @n.xbgr.xr23_u23.nr1[nsmm_w]
print @n.xbgr.xr23_u23.nr1[nsmm_l]
print @n.xbgr.xr23_u24.nr1[nsmm_rsh]
print @n.xbgr.xr23_u24.nr1[nsmm_w]
print @n.xbgr.xr23_u24.nr1[nsmm_l]
print @n.xbgr.xr24_u2.nr1[nsmm_rsh]
print @n.xbgr.xr24_u2.nr1[nsmm_w]
print @n.xbgr.xr24_u2.nr1[nsmm_l]
print @n.xbgr.xr24_u3.nr1[nsmm_rsh]
print @n.xbgr.xr24_u3.nr1[nsmm_w]
print @n.xbgr.xr24_u3.nr1[nsmm_l]
print @n.xbgr.xr24_u4.nr1[nsmm_rsh]
print @n.xbgr.xr24_u4.nr1[nsmm_w]
print @n.xbgr.xr24_u4.nr1[nsmm_l]
print @n.xbgr.xr24_u5.nr1[nsmm_rsh]
print @n.xbgr.xr24_u5.nr1[nsmm_w]
print @n.xbgr.xr24_u5.nr1[nsmm_l]
print @n.xbgr.xr24_u6.nr1[nsmm_rsh]
print @n.xbgr.xr24_u6.nr1[nsmm_w]
print @n.xbgr.xr24_u6.nr1[nsmm_l]
print @n.xbgr.xr24_u7.nr1[nsmm_rsh]
print @n.xbgr.xr24_u7.nr1[nsmm_w]
print @n.xbgr.xr24_u7.nr1[nsmm_l]
print @n.xbgr.xr24_u8.nr1[nsmm_rsh]
print @n.xbgr.xr24_u8.nr1[nsmm_w]
print @n.xbgr.xr24_u8.nr1[nsmm_l]
print @n.xbgr.xr24_u9.nr1[nsmm_rsh]
print @n.xbgr.xr24_u9.nr1[nsmm_w]
print @n.xbgr.xr24_u9.nr1[nsmm_l]
print @n.xbgr.xr24_u10.nr1[nsmm_rsh]
print @n.xbgr.xr24_u10.nr1[nsmm_w]
print @n.xbgr.xr24_u10.nr1[nsmm_l]
print @n.xbgr.xr24_u11.nr1[nsmm_rsh]
print @n.xbgr.xr24_u11.nr1[nsmm_w]
print @n.xbgr.xr24_u11.nr1[nsmm_l]
print @n.xbgr.xr24_u12.nr1[nsmm_rsh]
print @n.xbgr.xr24_u12.nr1[nsmm_w]
print @n.xbgr.xr24_u12.nr1[nsmm_l]
print @n.xbgr.xr24_u13.nr1[nsmm_rsh]
print @n.xbgr.xr24_u13.nr1[nsmm_w]
print @n.xbgr.xr24_u13.nr1[nsmm_l]
print @n.xbgr.xr24_u14.nr1[nsmm_rsh]
print @n.xbgr.xr24_u14.nr1[nsmm_w]
print @n.xbgr.xr24_u14.nr1[nsmm_l]
print @n.xbgr.xr24_u15.nr1[nsmm_rsh]
print @n.xbgr.xr24_u15.nr1[nsmm_w]
print @n.xbgr.xr24_u15.nr1[nsmm_l]
print @n.xbgr.xr24_u16.nr1[nsmm_rsh]
print @n.xbgr.xr24_u16.nr1[nsmm_w]
print @n.xbgr.xr24_u16.nr1[nsmm_l]
print @n.xbgr.xr24_u17.nr1[nsmm_rsh]
print @n.xbgr.xr24_u17.nr1[nsmm_w]
print @n.xbgr.xr24_u17.nr1[nsmm_l]
print @n.xbgr.xr24_u18.nr1[nsmm_rsh]
print @n.xbgr.xr24_u18.nr1[nsmm_w]
print @n.xbgr.xr24_u18.nr1[nsmm_l]
print @n.xbgr.xr24_u19.nr1[nsmm_rsh]
print @n.xbgr.xr24_u19.nr1[nsmm_w]
print @n.xbgr.xr24_u19.nr1[nsmm_l]
print @n.xbgr.xr24_u20.nr1[nsmm_rsh]
print @n.xbgr.xr24_u20.nr1[nsmm_w]
print @n.xbgr.xr24_u20.nr1[nsmm_l]
print @n.xbgr.xr24_u21.nr1[nsmm_rsh]
print @n.xbgr.xr24_u21.nr1[nsmm_w]
print @n.xbgr.xr24_u21.nr1[nsmm_l]
print @n.xbgr.xr24_u22.nr1[nsmm_rsh]
print @n.xbgr.xr24_u22.nr1[nsmm_w]
print @n.xbgr.xr24_u22.nr1[nsmm_l]
print @n.xbgr.xr24_u23.nr1[nsmm_rsh]
print @n.xbgr.xr24_u23.nr1[nsmm_w]
print @n.xbgr.xr24_u23.nr1[nsmm_l]
print @n.xbgr.xr24_u24.nr1[nsmm_rsh]
print @n.xbgr.xr24_u24.nr1[nsmm_w]
print @n.xbgr.xr24_u24.nr1[nsmm_l]
print @n.xbgr.xr25_u2.nr1[nsmm_rsh]
print @n.xbgr.xr25_u2.nr1[nsmm_w]
print @n.xbgr.xr25_u2.nr1[nsmm_l]
print @n.xbgr.xr25_u3.nr1[nsmm_rsh]
print @n.xbgr.xr25_u3.nr1[nsmm_w]
print @n.xbgr.xr25_u3.nr1[nsmm_l]
print @n.xbgr.xr25_u4.nr1[nsmm_rsh]
print @n.xbgr.xr25_u4.nr1[nsmm_w]
print @n.xbgr.xr25_u4.nr1[nsmm_l]
print @n.xbgr.xr25_u5.nr1[nsmm_rsh]
print @n.xbgr.xr25_u5.nr1[nsmm_w]
print @n.xbgr.xr25_u5.nr1[nsmm_l]
print @n.xbgr.xr25_u6.nr1[nsmm_rsh]
print @n.xbgr.xr25_u6.nr1[nsmm_w]
print @n.xbgr.xr25_u6.nr1[nsmm_l]
print @n.xbgr.xr25_u7.nr1[nsmm_rsh]
print @n.xbgr.xr25_u7.nr1[nsmm_w]
print @n.xbgr.xr25_u7.nr1[nsmm_l]
print @n.xbgr.xr25_u8.nr1[nsmm_rsh]
print @n.xbgr.xr25_u8.nr1[nsmm_w]
print @n.xbgr.xr25_u8.nr1[nsmm_l]
print @n.xbgr.xr25_u9.nr1[nsmm_rsh]
print @n.xbgr.xr25_u9.nr1[nsmm_w]
print @n.xbgr.xr25_u9.nr1[nsmm_l]
print @n.xbgr.xr25_u10.nr1[nsmm_rsh]
print @n.xbgr.xr25_u10.nr1[nsmm_w]
print @n.xbgr.xr25_u10.nr1[nsmm_l]
print @n.xbgr.xr25_u11.nr1[nsmm_rsh]
print @n.xbgr.xr25_u11.nr1[nsmm_w]
print @n.xbgr.xr25_u11.nr1[nsmm_l]
print @n.xbgr.xr25_u12.nr1[nsmm_rsh]
print @n.xbgr.xr25_u12.nr1[nsmm_w]
print @n.xbgr.xr25_u12.nr1[nsmm_l]
print @n.xbgr.xr25_u13.nr1[nsmm_rsh]
print @n.xbgr.xr25_u13.nr1[nsmm_w]
print @n.xbgr.xr25_u13.nr1[nsmm_l]
print @n.xbgr.xr25_u14.nr1[nsmm_rsh]
print @n.xbgr.xr25_u14.nr1[nsmm_w]
print @n.xbgr.xr25_u14.nr1[nsmm_l]
print @n.xbgr.xr25_u15.nr1[nsmm_rsh]
print @n.xbgr.xr25_u15.nr1[nsmm_w]
print @n.xbgr.xr25_u15.nr1[nsmm_l]
print @n.xbgr.xr25_u16.nr1[nsmm_rsh]
print @n.xbgr.xr25_u16.nr1[nsmm_w]
print @n.xbgr.xr25_u16.nr1[nsmm_l]
print @n.xbgr.xr25_u17.nr1[nsmm_rsh]
print @n.xbgr.xr25_u17.nr1[nsmm_w]
print @n.xbgr.xr25_u17.nr1[nsmm_l]
print @n.xbgr.xr25_u18.nr1[nsmm_rsh]
print @n.xbgr.xr25_u18.nr1[nsmm_w]
print @n.xbgr.xr25_u18.nr1[nsmm_l]
print @n.xbgr.xr25_u19.nr1[nsmm_rsh]
print @n.xbgr.xr25_u19.nr1[nsmm_w]
print @n.xbgr.xr25_u19.nr1[nsmm_l]
print @n.xbgr.xr25_u20.nr1[nsmm_rsh]
print @n.xbgr.xr25_u20.nr1[nsmm_w]
print @n.xbgr.xr25_u20.nr1[nsmm_l]
print @n.xbgr.xr25_u21.nr1[nsmm_rsh]
print @n.xbgr.xr25_u21.nr1[nsmm_w]
print @n.xbgr.xr25_u21.nr1[nsmm_l]
print @n.xbgr.xr25_u22.nr1[nsmm_rsh]
print @n.xbgr.xr25_u22.nr1[nsmm_w]
print @n.xbgr.xr25_u22.nr1[nsmm_l]
print @n.xbgr.xr25_u23.nr1[nsmm_rsh]
print @n.xbgr.xr25_u23.nr1[nsmm_w]
print @n.xbgr.xr25_u23.nr1[nsmm_l]
print @n.xbgr.xr25_u24.nr1[nsmm_rsh]
print @n.xbgr.xr25_u24.nr1[nsmm_w]
print @n.xbgr.xr25_u24.nr1[nsmm_l]
print @n.xbgr.xr26_u2.nr1[nsmm_rsh]
print @n.xbgr.xr26_u2.nr1[nsmm_w]
print @n.xbgr.xr26_u2.nr1[nsmm_l]
print @n.xbgr.xr26_u3.nr1[nsmm_rsh]
print @n.xbgr.xr26_u3.nr1[nsmm_w]
print @n.xbgr.xr26_u3.nr1[nsmm_l]
print @n.xbgr.xr26_u4.nr1[nsmm_rsh]
print @n.xbgr.xr26_u4.nr1[nsmm_w]
print @n.xbgr.xr26_u4.nr1[nsmm_l]
print @n.xbgr.xr26_u5.nr1[nsmm_rsh]
print @n.xbgr.xr26_u5.nr1[nsmm_w]
print @n.xbgr.xr26_u5.nr1[nsmm_l]
print @n.xbgr.xr26_u6.nr1[nsmm_rsh]
print @n.xbgr.xr26_u6.nr1[nsmm_w]
print @n.xbgr.xr26_u6.nr1[nsmm_l]
print @n.xbgr.xr26_u7.nr1[nsmm_rsh]
print @n.xbgr.xr26_u7.nr1[nsmm_w]
print @n.xbgr.xr26_u7.nr1[nsmm_l]
print @n.xbgr.xr26_u8.nr1[nsmm_rsh]
print @n.xbgr.xr26_u8.nr1[nsmm_w]
print @n.xbgr.xr26_u8.nr1[nsmm_l]
print @n.xbgr.xr26_u9.nr1[nsmm_rsh]
print @n.xbgr.xr26_u9.nr1[nsmm_w]
print @n.xbgr.xr26_u9.nr1[nsmm_l]
print @n.xbgr.xr26_u10.nr1[nsmm_rsh]
print @n.xbgr.xr26_u10.nr1[nsmm_w]
print @n.xbgr.xr26_u10.nr1[nsmm_l]
print @n.xbgr.xr26_u11.nr1[nsmm_rsh]
print @n.xbgr.xr26_u11.nr1[nsmm_w]
print @n.xbgr.xr26_u11.nr1[nsmm_l]
print @n.xbgr.xr26_u12.nr1[nsmm_rsh]
print @n.xbgr.xr26_u12.nr1[nsmm_w]
print @n.xbgr.xr26_u12.nr1[nsmm_l]
print @n.xbgr.xr26_u13.nr1[nsmm_rsh]
print @n.xbgr.xr26_u13.nr1[nsmm_w]
print @n.xbgr.xr26_u13.nr1[nsmm_l]
print @n.xbgr.xr26_u14.nr1[nsmm_rsh]
print @n.xbgr.xr26_u14.nr1[nsmm_w]
print @n.xbgr.xr26_u14.nr1[nsmm_l]
print @n.xbgr.xr26_u15.nr1[nsmm_rsh]
print @n.xbgr.xr26_u15.nr1[nsmm_w]
print @n.xbgr.xr26_u15.nr1[nsmm_l]
print @n.xbgr.xr26_u16.nr1[nsmm_rsh]
print @n.xbgr.xr26_u16.nr1[nsmm_w]
print @n.xbgr.xr26_u16.nr1[nsmm_l]
print @n.xbgr.xr26_u17.nr1[nsmm_rsh]
print @n.xbgr.xr26_u17.nr1[nsmm_w]
print @n.xbgr.xr26_u17.nr1[nsmm_l]
print @n.xbgr.xr26_u18.nr1[nsmm_rsh]
print @n.xbgr.xr26_u18.nr1[nsmm_w]
print @n.xbgr.xr26_u18.nr1[nsmm_l]
print @n.xbgr.xr26_u19.nr1[nsmm_rsh]
print @n.xbgr.xr26_u19.nr1[nsmm_w]
print @n.xbgr.xr26_u19.nr1[nsmm_l]
print @n.xbgr.xr26_u20.nr1[nsmm_rsh]
print @n.xbgr.xr26_u20.nr1[nsmm_w]
print @n.xbgr.xr26_u20.nr1[nsmm_l]
print @n.xbgr.xr26_u21.nr1[nsmm_rsh]
print @n.xbgr.xr26_u21.nr1[nsmm_w]
print @n.xbgr.xr26_u21.nr1[nsmm_l]
print @n.xbgr.xr26_u22.nr1[nsmm_rsh]
print @n.xbgr.xr26_u22.nr1[nsmm_w]
print @n.xbgr.xr26_u22.nr1[nsmm_l]
print @n.xbgr.xr26_u23.nr1[nsmm_rsh]
print @n.xbgr.xr26_u23.nr1[nsmm_w]
print @n.xbgr.xr26_u23.nr1[nsmm_l]
print @n.xbgr.xr26_u24.nr1[nsmm_rsh]
print @n.xbgr.xr26_u24.nr1[nsmm_w]
print @n.xbgr.xr26_u24.nr1[nsmm_l]
print @n.xbgr.xm34_u2.nsg13_hv_nmos[w]
print @n.xbgr.xm34_u2.nsg13_hv_nmos[l]
print @n.xbgr.xm34_u2.nsg13_hv_nmos[delvto]
print @n.xbgr.xm34_u2.nsg13_hv_nmos[factuo]
print @n.xbgr.xm34_u3.nsg13_hv_nmos[w]
print @n.xbgr.xm34_u3.nsg13_hv_nmos[l]
print @n.xbgr.xm34_u3.nsg13_hv_nmos[delvto]
print @n.xbgr.xm34_u3.nsg13_hv_nmos[factuo]
print @n.xbgr.xm34_u4.nsg13_hv_nmos[w]
print @n.xbgr.xm34_u4.nsg13_hv_nmos[l]
print @n.xbgr.xm34_u4.nsg13_hv_nmos[delvto]
print @n.xbgr.xm34_u4.nsg13_hv_nmos[factuo]
print @n.xbgr.xm34_u5.nsg13_hv_nmos[w]
print @n.xbgr.xm34_u5.nsg13_hv_nmos[l]
print @n.xbgr.xm34_u5.nsg13_hv_nmos[delvto]
print @n.xbgr.xm34_u5.nsg13_hv_nmos[factuo]
print @n.xbgr.xm34_u6.nsg13_hv_nmos[w]
print @n.xbgr.xm34_u6.nsg13_hv_nmos[l]
print @n.xbgr.xm34_u6.nsg13_hv_nmos[delvto]
print @n.xbgr.xm34_u6.nsg13_hv_nmos[factuo]
print @n.xbgr.xm34_u7.nsg13_hv_nmos[w]
print @n.xbgr.xm34_u7.nsg13_hv_nmos[l]
print @n.xbgr.xm34_u7.nsg13_hv_nmos[delvto]
print @n.xbgr.xm34_u7.nsg13_hv_nmos[factuo]
print @n.xbgr.xm34_u8.nsg13_hv_nmos[w]
print @n.xbgr.xm34_u8.nsg13_hv_nmos[l]
print @n.xbgr.xm34_u8.nsg13_hv_nmos[delvto]
print @n.xbgr.xm34_u8.nsg13_hv_nmos[factuo]
print @n.xbgr.xm34_u9.nsg13_hv_nmos[w]
print @n.xbgr.xm34_u9.nsg13_hv_nmos[l]
print @n.xbgr.xm34_u9.nsg13_hv_nmos[delvto]
print @n.xbgr.xm34_u9.nsg13_hv_nmos[factuo]
print @n.xbgr.xm34_u10.nsg13_hv_nmos[w]
print @n.xbgr.xm34_u10.nsg13_hv_nmos[l]
print @n.xbgr.xm34_u10.nsg13_hv_nmos[delvto]
print @n.xbgr.xm34_u10.nsg13_hv_nmos[factuo]
print @n.xbgr.xm34_u11.nsg13_hv_nmos[w]
print @n.xbgr.xm34_u11.nsg13_hv_nmos[l]
print @n.xbgr.xm34_u11.nsg13_hv_nmos[delvto]
print @n.xbgr.xm34_u11.nsg13_hv_nmos[factuo]
print @n.xbgr.xm34_u12.nsg13_hv_nmos[w]
print @n.xbgr.xm34_u12.nsg13_hv_nmos[l]
print @n.xbgr.xm34_u12.nsg13_hv_nmos[delvto]
print @n.xbgr.xm34_u12.nsg13_hv_nmos[factuo]
print @n.xbgr.xm34_u13.nsg13_hv_nmos[w]
print @n.xbgr.xm34_u13.nsg13_hv_nmos[l]
print @n.xbgr.xm34_u13.nsg13_hv_nmos[delvto]
print @n.xbgr.xm34_u13.nsg13_hv_nmos[factuo]
print @n.xbgr.xm34_u14.nsg13_hv_nmos[w]
print @n.xbgr.xm34_u14.nsg13_hv_nmos[l]
print @n.xbgr.xm34_u14.nsg13_hv_nmos[delvto]
print @n.xbgr.xm34_u14.nsg13_hv_nmos[factuo]
print @n.xbgr.xm34_u15.nsg13_hv_nmos[w]
print @n.xbgr.xm34_u15.nsg13_hv_nmos[l]
print @n.xbgr.xm34_u15.nsg13_hv_nmos[delvto]
print @n.xbgr.xm34_u15.nsg13_hv_nmos[factuo]
print @n.xbgr.xm34_u16.nsg13_hv_nmos[w]
print @n.xbgr.xm34_u16.nsg13_hv_nmos[l]
print @n.xbgr.xm34_u16.nsg13_hv_nmos[delvto]
print @n.xbgr.xm34_u16.nsg13_hv_nmos[factuo]
print @n.xbgr.xm34_u17.nsg13_hv_nmos[w]
print @n.xbgr.xm34_u17.nsg13_hv_nmos[l]
print @n.xbgr.xm34_u17.nsg13_hv_nmos[delvto]
print @n.xbgr.xm34_u17.nsg13_hv_nmos[factuo]
print @n.xbgr.xm34_u18.nsg13_hv_nmos[w]
print @n.xbgr.xm34_u18.nsg13_hv_nmos[l]
print @n.xbgr.xm34_u18.nsg13_hv_nmos[delvto]
print @n.xbgr.xm34_u18.nsg13_hv_nmos[factuo]
print @n.xbgr.xm34_u19.nsg13_hv_nmos[w]
print @n.xbgr.xm34_u19.nsg13_hv_nmos[l]
print @n.xbgr.xm34_u19.nsg13_hv_nmos[delvto]
print @n.xbgr.xm34_u19.nsg13_hv_nmos[factuo]
print @n.xbgr.xm34_u20.nsg13_hv_nmos[w]
print @n.xbgr.xm34_u20.nsg13_hv_nmos[l]
print @n.xbgr.xm34_u20.nsg13_hv_nmos[delvto]
print @n.xbgr.xm34_u20.nsg13_hv_nmos[factuo]
print @n.xbgr.xm34_u21.nsg13_hv_nmos[w]
print @n.xbgr.xm34_u21.nsg13_hv_nmos[l]
print @n.xbgr.xm34_u21.nsg13_hv_nmos[delvto]
print @n.xbgr.xm34_u21.nsg13_hv_nmos[factuo]
print @n.xbgr.xm34_u22.nsg13_hv_nmos[w]
print @n.xbgr.xm34_u22.nsg13_hv_nmos[l]
print @n.xbgr.xm34_u22.nsg13_hv_nmos[delvto]
print @n.xbgr.xm34_u22.nsg13_hv_nmos[factuo]
print @n.xbgr.xm34_u23.nsg13_hv_nmos[w]
print @n.xbgr.xm34_u23.nsg13_hv_nmos[l]
print @n.xbgr.xm34_u23.nsg13_hv_nmos[delvto]
print @n.xbgr.xm34_u23.nsg13_hv_nmos[factuo]
print @n.xbgr.xm34_u24.nsg13_hv_nmos[w]
print @n.xbgr.xm34_u24.nsg13_hv_nmos[l]
print @n.xbgr.xm34_u24.nsg13_hv_nmos[delvto]
print @n.xbgr.xm34_u24.nsg13_hv_nmos[factuo]
print @n.xbgr.xm35_u2.nsg13_hv_nmos[w]
print @n.xbgr.xm35_u2.nsg13_hv_nmos[l]
print @n.xbgr.xm35_u2.nsg13_hv_nmos[delvto]
print @n.xbgr.xm35_u2.nsg13_hv_nmos[factuo]
print @n.xbgr.xm35_u3.nsg13_hv_nmos[w]
print @n.xbgr.xm35_u3.nsg13_hv_nmos[l]
print @n.xbgr.xm35_u3.nsg13_hv_nmos[delvto]
print @n.xbgr.xm35_u3.nsg13_hv_nmos[factuo]
print @n.xbgr.xm35_u4.nsg13_hv_nmos[w]
print @n.xbgr.xm35_u4.nsg13_hv_nmos[l]
print @n.xbgr.xm35_u4.nsg13_hv_nmos[delvto]
print @n.xbgr.xm35_u4.nsg13_hv_nmos[factuo]
print @n.xbgr.xm35_u5.nsg13_hv_nmos[w]
print @n.xbgr.xm35_u5.nsg13_hv_nmos[l]
print @n.xbgr.xm35_u5.nsg13_hv_nmos[delvto]
print @n.xbgr.xm35_u5.nsg13_hv_nmos[factuo]
print @n.xbgr.xm35_u6.nsg13_hv_nmos[w]
print @n.xbgr.xm35_u6.nsg13_hv_nmos[l]
print @n.xbgr.xm35_u6.nsg13_hv_nmos[delvto]
print @n.xbgr.xm35_u6.nsg13_hv_nmos[factuo]
print @n.xbgr.xm35_u7.nsg13_hv_nmos[w]
print @n.xbgr.xm35_u7.nsg13_hv_nmos[l]
print @n.xbgr.xm35_u7.nsg13_hv_nmos[delvto]
print @n.xbgr.xm35_u7.nsg13_hv_nmos[factuo]
print @n.xbgr.xm35_u8.nsg13_hv_nmos[w]
print @n.xbgr.xm35_u8.nsg13_hv_nmos[l]
print @n.xbgr.xm35_u8.nsg13_hv_nmos[delvto]
print @n.xbgr.xm35_u8.nsg13_hv_nmos[factuo]
print @n.xbgr.xm35_u9.nsg13_hv_nmos[w]
print @n.xbgr.xm35_u9.nsg13_hv_nmos[l]
print @n.xbgr.xm35_u9.nsg13_hv_nmos[delvto]
print @n.xbgr.xm35_u9.nsg13_hv_nmos[factuo]
print @n.xbgr.xm35_u10.nsg13_hv_nmos[w]
print @n.xbgr.xm35_u10.nsg13_hv_nmos[l]
print @n.xbgr.xm35_u10.nsg13_hv_nmos[delvto]
print @n.xbgr.xm35_u10.nsg13_hv_nmos[factuo]
print @n.xbgr.xm35_u11.nsg13_hv_nmos[w]
print @n.xbgr.xm35_u11.nsg13_hv_nmos[l]
print @n.xbgr.xm35_u11.nsg13_hv_nmos[delvto]
print @n.xbgr.xm35_u11.nsg13_hv_nmos[factuo]
print @n.xbgr.xm35_u12.nsg13_hv_nmos[w]
print @n.xbgr.xm35_u12.nsg13_hv_nmos[l]
print @n.xbgr.xm35_u12.nsg13_hv_nmos[delvto]
print @n.xbgr.xm35_u12.nsg13_hv_nmos[factuo]
print @n.xbgr.xm35_u13.nsg13_hv_nmos[w]
print @n.xbgr.xm35_u13.nsg13_hv_nmos[l]
print @n.xbgr.xm35_u13.nsg13_hv_nmos[delvto]
print @n.xbgr.xm35_u13.nsg13_hv_nmos[factuo]
print @n.xbgr.xm35_u14.nsg13_hv_nmos[w]
print @n.xbgr.xm35_u14.nsg13_hv_nmos[l]
print @n.xbgr.xm35_u14.nsg13_hv_nmos[delvto]
print @n.xbgr.xm35_u14.nsg13_hv_nmos[factuo]
print @n.xbgr.xm35_u15.nsg13_hv_nmos[w]
print @n.xbgr.xm35_u15.nsg13_hv_nmos[l]
print @n.xbgr.xm35_u15.nsg13_hv_nmos[delvto]
print @n.xbgr.xm35_u15.nsg13_hv_nmos[factuo]
print @n.xbgr.xm35_u16.nsg13_hv_nmos[w]
print @n.xbgr.xm35_u16.nsg13_hv_nmos[l]
print @n.xbgr.xm35_u16.nsg13_hv_nmos[delvto]
print @n.xbgr.xm35_u16.nsg13_hv_nmos[factuo]
print @n.xbgr.xm35_u17.nsg13_hv_nmos[w]
print @n.xbgr.xm35_u17.nsg13_hv_nmos[l]
print @n.xbgr.xm35_u17.nsg13_hv_nmos[delvto]
print @n.xbgr.xm35_u17.nsg13_hv_nmos[factuo]
print @n.xbgr.xm35_u18.nsg13_hv_nmos[w]
print @n.xbgr.xm35_u18.nsg13_hv_nmos[l]
print @n.xbgr.xm35_u18.nsg13_hv_nmos[delvto]
print @n.xbgr.xm35_u18.nsg13_hv_nmos[factuo]
print @n.xbgr.xm35_u19.nsg13_hv_nmos[w]
print @n.xbgr.xm35_u19.nsg13_hv_nmos[l]
print @n.xbgr.xm35_u19.nsg13_hv_nmos[delvto]
print @n.xbgr.xm35_u19.nsg13_hv_nmos[factuo]
print @n.xbgr.xm35_u20.nsg13_hv_nmos[w]
print @n.xbgr.xm35_u20.nsg13_hv_nmos[l]
print @n.xbgr.xm35_u20.nsg13_hv_nmos[delvto]
print @n.xbgr.xm35_u20.nsg13_hv_nmos[factuo]
print @n.xbgr.xm35_u21.nsg13_hv_nmos[w]
print @n.xbgr.xm35_u21.nsg13_hv_nmos[l]
print @n.xbgr.xm35_u21.nsg13_hv_nmos[delvto]
print @n.xbgr.xm35_u21.nsg13_hv_nmos[factuo]
print @n.xbgr.xm35_u22.nsg13_hv_nmos[w]
print @n.xbgr.xm35_u22.nsg13_hv_nmos[l]
print @n.xbgr.xm35_u22.nsg13_hv_nmos[delvto]
print @n.xbgr.xm35_u22.nsg13_hv_nmos[factuo]
print @n.xbgr.xm35_u23.nsg13_hv_nmos[w]
print @n.xbgr.xm35_u23.nsg13_hv_nmos[l]
print @n.xbgr.xm35_u23.nsg13_hv_nmos[delvto]
print @n.xbgr.xm35_u23.nsg13_hv_nmos[factuo]
print @n.xbgr.xm35_u24.nsg13_hv_nmos[w]
print @n.xbgr.xm35_u24.nsg13_hv_nmos[l]
print @n.xbgr.xm35_u24.nsg13_hv_nmos[delvto]
print @n.xbgr.xm35_u24.nsg13_hv_nmos[factuo]
print @n.xbgr.xm36_u2.nsg13_hv_nmos[w]
print @n.xbgr.xm36_u2.nsg13_hv_nmos[l]
print @n.xbgr.xm36_u2.nsg13_hv_nmos[delvto]
print @n.xbgr.xm36_u2.nsg13_hv_nmos[factuo]
print @n.xbgr.xm36_u3.nsg13_hv_nmos[w]
print @n.xbgr.xm36_u3.nsg13_hv_nmos[l]
print @n.xbgr.xm36_u3.nsg13_hv_nmos[delvto]
print @n.xbgr.xm36_u3.nsg13_hv_nmos[factuo]
print @n.xbgr.xm36_u4.nsg13_hv_nmos[w]
print @n.xbgr.xm36_u4.nsg13_hv_nmos[l]
print @n.xbgr.xm36_u4.nsg13_hv_nmos[delvto]
print @n.xbgr.xm36_u4.nsg13_hv_nmos[factuo]
print @n.xbgr.xm36_u5.nsg13_hv_nmos[w]
print @n.xbgr.xm36_u5.nsg13_hv_nmos[l]
print @n.xbgr.xm36_u5.nsg13_hv_nmos[delvto]
print @n.xbgr.xm36_u5.nsg13_hv_nmos[factuo]
print @n.xbgr.xm36_u6.nsg13_hv_nmos[w]
print @n.xbgr.xm36_u6.nsg13_hv_nmos[l]
print @n.xbgr.xm36_u6.nsg13_hv_nmos[delvto]
print @n.xbgr.xm36_u6.nsg13_hv_nmos[factuo]
print @n.xbgr.xm36_u7.nsg13_hv_nmos[w]
print @n.xbgr.xm36_u7.nsg13_hv_nmos[l]
print @n.xbgr.xm36_u7.nsg13_hv_nmos[delvto]
print @n.xbgr.xm36_u7.nsg13_hv_nmos[factuo]
print @n.xbgr.xm36_u8.nsg13_hv_nmos[w]
print @n.xbgr.xm36_u8.nsg13_hv_nmos[l]
print @n.xbgr.xm36_u8.nsg13_hv_nmos[delvto]
print @n.xbgr.xm36_u8.nsg13_hv_nmos[factuo]
print @n.xbgr.xm36_u9.nsg13_hv_nmos[w]
print @n.xbgr.xm36_u9.nsg13_hv_nmos[l]
print @n.xbgr.xm36_u9.nsg13_hv_nmos[delvto]
print @n.xbgr.xm36_u9.nsg13_hv_nmos[factuo]
print @n.xbgr.xm36_u10.nsg13_hv_nmos[w]
print @n.xbgr.xm36_u10.nsg13_hv_nmos[l]
print @n.xbgr.xm36_u10.nsg13_hv_nmos[delvto]
print @n.xbgr.xm36_u10.nsg13_hv_nmos[factuo]
print @n.xbgr.xm36_u11.nsg13_hv_nmos[w]
print @n.xbgr.xm36_u11.nsg13_hv_nmos[l]
print @n.xbgr.xm36_u11.nsg13_hv_nmos[delvto]
print @n.xbgr.xm36_u11.nsg13_hv_nmos[factuo]
print @n.xbgr.xm36_u12.nsg13_hv_nmos[w]
print @n.xbgr.xm36_u12.nsg13_hv_nmos[l]
print @n.xbgr.xm36_u12.nsg13_hv_nmos[delvto]
print @n.xbgr.xm36_u12.nsg13_hv_nmos[factuo]
print @n.xbgr.xm36_u13.nsg13_hv_nmos[w]
print @n.xbgr.xm36_u13.nsg13_hv_nmos[l]
print @n.xbgr.xm36_u13.nsg13_hv_nmos[delvto]
print @n.xbgr.xm36_u13.nsg13_hv_nmos[factuo]
print @n.xbgr.xm36_u14.nsg13_hv_nmos[w]
print @n.xbgr.xm36_u14.nsg13_hv_nmos[l]
print @n.xbgr.xm36_u14.nsg13_hv_nmos[delvto]
print @n.xbgr.xm36_u14.nsg13_hv_nmos[factuo]
print @n.xbgr.xm36_u15.nsg13_hv_nmos[w]
print @n.xbgr.xm36_u15.nsg13_hv_nmos[l]
print @n.xbgr.xm36_u15.nsg13_hv_nmos[delvto]
print @n.xbgr.xm36_u15.nsg13_hv_nmos[factuo]
print @n.xbgr.xm36_u16.nsg13_hv_nmos[w]
print @n.xbgr.xm36_u16.nsg13_hv_nmos[l]
print @n.xbgr.xm36_u16.nsg13_hv_nmos[delvto]
print @n.xbgr.xm36_u16.nsg13_hv_nmos[factuo]
print @n.xbgr.xm36_u17.nsg13_hv_nmos[w]
print @n.xbgr.xm36_u17.nsg13_hv_nmos[l]
print @n.xbgr.xm36_u17.nsg13_hv_nmos[delvto]
print @n.xbgr.xm36_u17.nsg13_hv_nmos[factuo]
print @n.xbgr.xm36_u18.nsg13_hv_nmos[w]
print @n.xbgr.xm36_u18.nsg13_hv_nmos[l]
print @n.xbgr.xm36_u18.nsg13_hv_nmos[delvto]
print @n.xbgr.xm36_u18.nsg13_hv_nmos[factuo]
print @n.xbgr.xm36_u19.nsg13_hv_nmos[w]
print @n.xbgr.xm36_u19.nsg13_hv_nmos[l]
print @n.xbgr.xm36_u19.nsg13_hv_nmos[delvto]
print @n.xbgr.xm36_u19.nsg13_hv_nmos[factuo]
print @n.xbgr.xm36_u20.nsg13_hv_nmos[w]
print @n.xbgr.xm36_u20.nsg13_hv_nmos[l]
print @n.xbgr.xm36_u20.nsg13_hv_nmos[delvto]
print @n.xbgr.xm36_u20.nsg13_hv_nmos[factuo]
print @n.xbgr.xm36_u21.nsg13_hv_nmos[w]
print @n.xbgr.xm36_u21.nsg13_hv_nmos[l]
print @n.xbgr.xm36_u21.nsg13_hv_nmos[delvto]
print @n.xbgr.xm36_u21.nsg13_hv_nmos[factuo]
print @n.xbgr.xm36_u22.nsg13_hv_nmos[w]
print @n.xbgr.xm36_u22.nsg13_hv_nmos[l]
print @n.xbgr.xm36_u22.nsg13_hv_nmos[delvto]
print @n.xbgr.xm36_u22.nsg13_hv_nmos[factuo]
print @n.xbgr.xm36_u23.nsg13_hv_nmos[w]
print @n.xbgr.xm36_u23.nsg13_hv_nmos[l]
print @n.xbgr.xm36_u23.nsg13_hv_nmos[delvto]
print @n.xbgr.xm36_u23.nsg13_hv_nmos[factuo]
print @n.xbgr.xm36_u24.nsg13_hv_nmos[w]
print @n.xbgr.xm36_u24.nsg13_hv_nmos[l]
print @n.xbgr.xm36_u24.nsg13_hv_nmos[delvto]
print @n.xbgr.xm36_u24.nsg13_hv_nmos[factuo]
print @n.xbgr.xm37_u2.nsg13_hv_nmos[w]
print @n.xbgr.xm37_u2.nsg13_hv_nmos[l]
print @n.xbgr.xm37_u2.nsg13_hv_nmos[delvto]
print @n.xbgr.xm37_u2.nsg13_hv_nmos[factuo]
print @n.xbgr.xm37_u3.nsg13_hv_nmos[w]
print @n.xbgr.xm37_u3.nsg13_hv_nmos[l]
print @n.xbgr.xm37_u3.nsg13_hv_nmos[delvto]
print @n.xbgr.xm37_u3.nsg13_hv_nmos[factuo]
print @n.xbgr.xm37_u4.nsg13_hv_nmos[w]
print @n.xbgr.xm37_u4.nsg13_hv_nmos[l]
print @n.xbgr.xm37_u4.nsg13_hv_nmos[delvto]
print @n.xbgr.xm37_u4.nsg13_hv_nmos[factuo]
print @n.xbgr.xm37_u5.nsg13_hv_nmos[w]
print @n.xbgr.xm37_u5.nsg13_hv_nmos[l]
print @n.xbgr.xm37_u5.nsg13_hv_nmos[delvto]
print @n.xbgr.xm37_u5.nsg13_hv_nmos[factuo]
print @n.xbgr.xm37_u6.nsg13_hv_nmos[w]
print @n.xbgr.xm37_u6.nsg13_hv_nmos[l]
print @n.xbgr.xm37_u6.nsg13_hv_nmos[delvto]
print @n.xbgr.xm37_u6.nsg13_hv_nmos[factuo]
print @n.xbgr.xm37_u7.nsg13_hv_nmos[w]
print @n.xbgr.xm37_u7.nsg13_hv_nmos[l]
print @n.xbgr.xm37_u7.nsg13_hv_nmos[delvto]
print @n.xbgr.xm37_u7.nsg13_hv_nmos[factuo]
print @n.xbgr.xm37_u8.nsg13_hv_nmos[w]
print @n.xbgr.xm37_u8.nsg13_hv_nmos[l]
print @n.xbgr.xm37_u8.nsg13_hv_nmos[delvto]
print @n.xbgr.xm37_u8.nsg13_hv_nmos[factuo]
print @n.xbgr.xm37_u9.nsg13_hv_nmos[w]
print @n.xbgr.xm37_u9.nsg13_hv_nmos[l]
print @n.xbgr.xm37_u9.nsg13_hv_nmos[delvto]
print @n.xbgr.xm37_u9.nsg13_hv_nmos[factuo]
print @n.xbgr.xm37_u10.nsg13_hv_nmos[w]
print @n.xbgr.xm37_u10.nsg13_hv_nmos[l]
print @n.xbgr.xm37_u10.nsg13_hv_nmos[delvto]
print @n.xbgr.xm37_u10.nsg13_hv_nmos[factuo]
print @n.xbgr.xm37_u11.nsg13_hv_nmos[w]
print @n.xbgr.xm37_u11.nsg13_hv_nmos[l]
print @n.xbgr.xm37_u11.nsg13_hv_nmos[delvto]
print @n.xbgr.xm37_u11.nsg13_hv_nmos[factuo]
print @n.xbgr.xm37_u12.nsg13_hv_nmos[w]
print @n.xbgr.xm37_u12.nsg13_hv_nmos[l]
print @n.xbgr.xm37_u12.nsg13_hv_nmos[delvto]
print @n.xbgr.xm37_u12.nsg13_hv_nmos[factuo]
print @n.xbgr.xm37_u13.nsg13_hv_nmos[w]
print @n.xbgr.xm37_u13.nsg13_hv_nmos[l]
print @n.xbgr.xm37_u13.nsg13_hv_nmos[delvto]
print @n.xbgr.xm37_u13.nsg13_hv_nmos[factuo]
print @n.xbgr.xm37_u14.nsg13_hv_nmos[w]
print @n.xbgr.xm37_u14.nsg13_hv_nmos[l]
print @n.xbgr.xm37_u14.nsg13_hv_nmos[delvto]
print @n.xbgr.xm37_u14.nsg13_hv_nmos[factuo]
print @n.xbgr.xm37_u15.nsg13_hv_nmos[w]
print @n.xbgr.xm37_u15.nsg13_hv_nmos[l]
print @n.xbgr.xm37_u15.nsg13_hv_nmos[delvto]
print @n.xbgr.xm37_u15.nsg13_hv_nmos[factuo]
print @n.xbgr.xm37_u16.nsg13_hv_nmos[w]
print @n.xbgr.xm37_u16.nsg13_hv_nmos[l]
print @n.xbgr.xm37_u16.nsg13_hv_nmos[delvto]
print @n.xbgr.xm37_u16.nsg13_hv_nmos[factuo]
print @n.xbgr.xm37_u17.nsg13_hv_nmos[w]
print @n.xbgr.xm37_u17.nsg13_hv_nmos[l]
print @n.xbgr.xm37_u17.nsg13_hv_nmos[delvto]
print @n.xbgr.xm37_u17.nsg13_hv_nmos[factuo]
print @n.xbgr.xm37_u18.nsg13_hv_nmos[w]
print @n.xbgr.xm37_u18.nsg13_hv_nmos[l]
print @n.xbgr.xm37_u18.nsg13_hv_nmos[delvto]
print @n.xbgr.xm37_u18.nsg13_hv_nmos[factuo]
print @n.xbgr.xm37_u19.nsg13_hv_nmos[w]
print @n.xbgr.xm37_u19.nsg13_hv_nmos[l]
print @n.xbgr.xm37_u19.nsg13_hv_nmos[delvto]
print @n.xbgr.xm37_u19.nsg13_hv_nmos[factuo]
print @n.xbgr.xm37_u20.nsg13_hv_nmos[w]
print @n.xbgr.xm37_u20.nsg13_hv_nmos[l]
print @n.xbgr.xm37_u20.nsg13_hv_nmos[delvto]
print @n.xbgr.xm37_u20.nsg13_hv_nmos[factuo]
print @n.xbgr.xm37_u21.nsg13_hv_nmos[w]
print @n.xbgr.xm37_u21.nsg13_hv_nmos[l]
print @n.xbgr.xm37_u21.nsg13_hv_nmos[delvto]
print @n.xbgr.xm37_u21.nsg13_hv_nmos[factuo]
print @n.xbgr.xm37_u22.nsg13_hv_nmos[w]
print @n.xbgr.xm37_u22.nsg13_hv_nmos[l]
print @n.xbgr.xm37_u22.nsg13_hv_nmos[delvto]
print @n.xbgr.xm37_u22.nsg13_hv_nmos[factuo]
print @n.xbgr.xm37_u23.nsg13_hv_nmos[w]
print @n.xbgr.xm37_u23.nsg13_hv_nmos[l]
print @n.xbgr.xm37_u23.nsg13_hv_nmos[delvto]
print @n.xbgr.xm37_u23.nsg13_hv_nmos[factuo]
print @n.xbgr.xm37_u24.nsg13_hv_nmos[w]
print @n.xbgr.xm37_u24.nsg13_hv_nmos[l]
print @n.xbgr.xm37_u24.nsg13_hv_nmos[delvto]
print @n.xbgr.xm37_u24.nsg13_hv_nmos[factuo]
print @n.xbgr.xm38_u2.nsg13_hv_pmos[w]
print @n.xbgr.xm38_u2.nsg13_hv_pmos[l]
print @n.xbgr.xm38_u2.nsg13_hv_pmos[delvto]
print @n.xbgr.xm38_u2.nsg13_hv_pmos[factuo]
print @n.xbgr.xm38_u3.nsg13_hv_pmos[w]
print @n.xbgr.xm38_u3.nsg13_hv_pmos[l]
print @n.xbgr.xm38_u3.nsg13_hv_pmos[delvto]
print @n.xbgr.xm38_u3.nsg13_hv_pmos[factuo]
print @n.xbgr.xm38_u4.nsg13_hv_pmos[w]
print @n.xbgr.xm38_u4.nsg13_hv_pmos[l]
print @n.xbgr.xm38_u4.nsg13_hv_pmos[delvto]
print @n.xbgr.xm38_u4.nsg13_hv_pmos[factuo]
print @n.xbgr.xm38_u5.nsg13_hv_pmos[w]
print @n.xbgr.xm38_u5.nsg13_hv_pmos[l]
print @n.xbgr.xm38_u5.nsg13_hv_pmos[delvto]
print @n.xbgr.xm38_u5.nsg13_hv_pmos[factuo]
print @n.xbgr.xm38_u6.nsg13_hv_pmos[w]
print @n.xbgr.xm38_u6.nsg13_hv_pmos[l]
print @n.xbgr.xm38_u6.nsg13_hv_pmos[delvto]
print @n.xbgr.xm38_u6.nsg13_hv_pmos[factuo]
print @n.xbgr.xm38_u7.nsg13_hv_pmos[w]
print @n.xbgr.xm38_u7.nsg13_hv_pmos[l]
print @n.xbgr.xm38_u7.nsg13_hv_pmos[delvto]
print @n.xbgr.xm38_u7.nsg13_hv_pmos[factuo]
print @n.xbgr.xm38_u8.nsg13_hv_pmos[w]
print @n.xbgr.xm38_u8.nsg13_hv_pmos[l]
print @n.xbgr.xm38_u8.nsg13_hv_pmos[delvto]
print @n.xbgr.xm38_u8.nsg13_hv_pmos[factuo]
print @n.xbgr.xm38_u9.nsg13_hv_pmos[w]
print @n.xbgr.xm38_u9.nsg13_hv_pmos[l]
print @n.xbgr.xm38_u9.nsg13_hv_pmos[delvto]
print @n.xbgr.xm38_u9.nsg13_hv_pmos[factuo]
print @n.xbgr.xm38_u10.nsg13_hv_pmos[w]
print @n.xbgr.xm38_u10.nsg13_hv_pmos[l]
print @n.xbgr.xm38_u10.nsg13_hv_pmos[delvto]
print @n.xbgr.xm38_u10.nsg13_hv_pmos[factuo]
print @n.xbgr.xm38_u11.nsg13_hv_pmos[w]
print @n.xbgr.xm38_u11.nsg13_hv_pmos[l]
print @n.xbgr.xm38_u11.nsg13_hv_pmos[delvto]
print @n.xbgr.xm38_u11.nsg13_hv_pmos[factuo]
print @n.xbgr.xm38_u12.nsg13_hv_pmos[w]
print @n.xbgr.xm38_u12.nsg13_hv_pmos[l]
print @n.xbgr.xm38_u12.nsg13_hv_pmos[delvto]
print @n.xbgr.xm38_u12.nsg13_hv_pmos[factuo]
print @n.xbgr.xm38_u13.nsg13_hv_pmos[w]
print @n.xbgr.xm38_u13.nsg13_hv_pmos[l]
print @n.xbgr.xm38_u13.nsg13_hv_pmos[delvto]
print @n.xbgr.xm38_u13.nsg13_hv_pmos[factuo]
print @n.xbgr.xm38_u14.nsg13_hv_pmos[w]
print @n.xbgr.xm38_u14.nsg13_hv_pmos[l]
print @n.xbgr.xm38_u14.nsg13_hv_pmos[delvto]
print @n.xbgr.xm38_u14.nsg13_hv_pmos[factuo]
print @n.xbgr.xm38_u15.nsg13_hv_pmos[w]
print @n.xbgr.xm38_u15.nsg13_hv_pmos[l]
print @n.xbgr.xm38_u15.nsg13_hv_pmos[delvto]
print @n.xbgr.xm38_u15.nsg13_hv_pmos[factuo]
print @n.xbgr.xm38_u16.nsg13_hv_pmos[w]
print @n.xbgr.xm38_u16.nsg13_hv_pmos[l]
print @n.xbgr.xm38_u16.nsg13_hv_pmos[delvto]
print @n.xbgr.xm38_u16.nsg13_hv_pmos[factuo]
print @n.xbgr.xm38_u17.nsg13_hv_pmos[w]
print @n.xbgr.xm38_u17.nsg13_hv_pmos[l]
print @n.xbgr.xm38_u17.nsg13_hv_pmos[delvto]
print @n.xbgr.xm38_u17.nsg13_hv_pmos[factuo]
print @n.xbgr.xm38_u18.nsg13_hv_pmos[w]
print @n.xbgr.xm38_u18.nsg13_hv_pmos[l]
print @n.xbgr.xm38_u18.nsg13_hv_pmos[delvto]
print @n.xbgr.xm38_u18.nsg13_hv_pmos[factuo]
print @n.xbgr.xm38_u19.nsg13_hv_pmos[w]
print @n.xbgr.xm38_u19.nsg13_hv_pmos[l]
print @n.xbgr.xm38_u19.nsg13_hv_pmos[delvto]
print @n.xbgr.xm38_u19.nsg13_hv_pmos[factuo]
print @n.xbgr.xm38_u20.nsg13_hv_pmos[w]
print @n.xbgr.xm38_u20.nsg13_hv_pmos[l]
print @n.xbgr.xm38_u20.nsg13_hv_pmos[delvto]
print @n.xbgr.xm38_u20.nsg13_hv_pmos[factuo]
print @n.xbgr.xm38_u21.nsg13_hv_pmos[w]
print @n.xbgr.xm38_u21.nsg13_hv_pmos[l]
print @n.xbgr.xm38_u21.nsg13_hv_pmos[delvto]
print @n.xbgr.xm38_u21.nsg13_hv_pmos[factuo]
print @n.xbgr.xm38_u22.nsg13_hv_pmos[w]
print @n.xbgr.xm38_u22.nsg13_hv_pmos[l]
print @n.xbgr.xm38_u22.nsg13_hv_pmos[delvto]
print @n.xbgr.xm38_u22.nsg13_hv_pmos[factuo]
print @n.xbgr.xm38_u23.nsg13_hv_pmos[w]
print @n.xbgr.xm38_u23.nsg13_hv_pmos[l]
print @n.xbgr.xm38_u23.nsg13_hv_pmos[delvto]
print @n.xbgr.xm38_u23.nsg13_hv_pmos[factuo]
print @n.xbgr.xm38_u24.nsg13_hv_pmos[w]
print @n.xbgr.xm38_u24.nsg13_hv_pmos[l]
print @n.xbgr.xm38_u24.nsg13_hv_pmos[delvto]
print @n.xbgr.xm38_u24.nsg13_hv_pmos[factuo]
print @n.xbgr.xm39_u2.nsg13_hv_pmos[w]
print @n.xbgr.xm39_u2.nsg13_hv_pmos[l]
print @n.xbgr.xm39_u2.nsg13_hv_pmos[delvto]
print @n.xbgr.xm39_u2.nsg13_hv_pmos[factuo]
print @n.xbgr.xm39_u3.nsg13_hv_pmos[w]
print @n.xbgr.xm39_u3.nsg13_hv_pmos[l]
print @n.xbgr.xm39_u3.nsg13_hv_pmos[delvto]
print @n.xbgr.xm39_u3.nsg13_hv_pmos[factuo]
print @n.xbgr.xm39_u4.nsg13_hv_pmos[w]
print @n.xbgr.xm39_u4.nsg13_hv_pmos[l]
print @n.xbgr.xm39_u4.nsg13_hv_pmos[delvto]
print @n.xbgr.xm39_u4.nsg13_hv_pmos[factuo]
print @n.xbgr.xm39_u5.nsg13_hv_pmos[w]
print @n.xbgr.xm39_u5.nsg13_hv_pmos[l]
print @n.xbgr.xm39_u5.nsg13_hv_pmos[delvto]
print @n.xbgr.xm39_u5.nsg13_hv_pmos[factuo]
print @n.xbgr.xm39_u6.nsg13_hv_pmos[w]
print @n.xbgr.xm39_u6.nsg13_hv_pmos[l]
print @n.xbgr.xm39_u6.nsg13_hv_pmos[delvto]
print @n.xbgr.xm39_u6.nsg13_hv_pmos[factuo]
print @n.xbgr.xm39_u7.nsg13_hv_pmos[w]
print @n.xbgr.xm39_u7.nsg13_hv_pmos[l]
print @n.xbgr.xm39_u7.nsg13_hv_pmos[delvto]
print @n.xbgr.xm39_u7.nsg13_hv_pmos[factuo]
print @n.xbgr.xm39_u8.nsg13_hv_pmos[w]
print @n.xbgr.xm39_u8.nsg13_hv_pmos[l]
print @n.xbgr.xm39_u8.nsg13_hv_pmos[delvto]
print @n.xbgr.xm39_u8.nsg13_hv_pmos[factuo]
print @n.xbgr.xm39_u9.nsg13_hv_pmos[w]
print @n.xbgr.xm39_u9.nsg13_hv_pmos[l]
print @n.xbgr.xm39_u9.nsg13_hv_pmos[delvto]
print @n.xbgr.xm39_u9.nsg13_hv_pmos[factuo]
print @n.xbgr.xm39_u10.nsg13_hv_pmos[w]
print @n.xbgr.xm39_u10.nsg13_hv_pmos[l]
print @n.xbgr.xm39_u10.nsg13_hv_pmos[delvto]
print @n.xbgr.xm39_u10.nsg13_hv_pmos[factuo]
print @n.xbgr.xm39_u11.nsg13_hv_pmos[w]
print @n.xbgr.xm39_u11.nsg13_hv_pmos[l]
print @n.xbgr.xm39_u11.nsg13_hv_pmos[delvto]
print @n.xbgr.xm39_u11.nsg13_hv_pmos[factuo]
print @n.xbgr.xm39_u12.nsg13_hv_pmos[w]
print @n.xbgr.xm39_u12.nsg13_hv_pmos[l]
print @n.xbgr.xm39_u12.nsg13_hv_pmos[delvto]
print @n.xbgr.xm39_u12.nsg13_hv_pmos[factuo]
print @n.xbgr.xm39_u13.nsg13_hv_pmos[w]
print @n.xbgr.xm39_u13.nsg13_hv_pmos[l]
print @n.xbgr.xm39_u13.nsg13_hv_pmos[delvto]
print @n.xbgr.xm39_u13.nsg13_hv_pmos[factuo]
print @n.xbgr.xm39_u14.nsg13_hv_pmos[w]
print @n.xbgr.xm39_u14.nsg13_hv_pmos[l]
print @n.xbgr.xm39_u14.nsg13_hv_pmos[delvto]
print @n.xbgr.xm39_u14.nsg13_hv_pmos[factuo]
print @n.xbgr.xm39_u15.nsg13_hv_pmos[w]
print @n.xbgr.xm39_u15.nsg13_hv_pmos[l]
print @n.xbgr.xm39_u15.nsg13_hv_pmos[delvto]
print @n.xbgr.xm39_u15.nsg13_hv_pmos[factuo]
print @n.xbgr.xm39_u16.nsg13_hv_pmos[w]
print @n.xbgr.xm39_u16.nsg13_hv_pmos[l]
print @n.xbgr.xm39_u16.nsg13_hv_pmos[delvto]
print @n.xbgr.xm39_u16.nsg13_hv_pmos[factuo]
print @n.xbgr.xm39_u17.nsg13_hv_pmos[w]
print @n.xbgr.xm39_u17.nsg13_hv_pmos[l]
print @n.xbgr.xm39_u17.nsg13_hv_pmos[delvto]
print @n.xbgr.xm39_u17.nsg13_hv_pmos[factuo]
print @n.xbgr.xm39_u18.nsg13_hv_pmos[w]
print @n.xbgr.xm39_u18.nsg13_hv_pmos[l]
print @n.xbgr.xm39_u18.nsg13_hv_pmos[delvto]
print @n.xbgr.xm39_u18.nsg13_hv_pmos[factuo]
print @n.xbgr.xm39_u19.nsg13_hv_pmos[w]
print @n.xbgr.xm39_u19.nsg13_hv_pmos[l]
print @n.xbgr.xm39_u19.nsg13_hv_pmos[delvto]
print @n.xbgr.xm39_u19.nsg13_hv_pmos[factuo]
print @n.xbgr.xm39_u20.nsg13_hv_pmos[w]
print @n.xbgr.xm39_u20.nsg13_hv_pmos[l]
print @n.xbgr.xm39_u20.nsg13_hv_pmos[delvto]
print @n.xbgr.xm39_u20.nsg13_hv_pmos[factuo]
print @n.xbgr.xm39_u21.nsg13_hv_pmos[w]
print @n.xbgr.xm39_u21.nsg13_hv_pmos[l]
print @n.xbgr.xm39_u21.nsg13_hv_pmos[delvto]
print @n.xbgr.xm39_u21.nsg13_hv_pmos[factuo]
print @n.xbgr.xm39_u22.nsg13_hv_pmos[w]
print @n.xbgr.xm39_u22.nsg13_hv_pmos[l]
print @n.xbgr.xm39_u22.nsg13_hv_pmos[delvto]
print @n.xbgr.xm39_u22.nsg13_hv_pmos[factuo]
print @n.xbgr.xm39_u23.nsg13_hv_pmos[w]
print @n.xbgr.xm39_u23.nsg13_hv_pmos[l]
print @n.xbgr.xm39_u23.nsg13_hv_pmos[delvto]
print @n.xbgr.xm39_u23.nsg13_hv_pmos[factuo]
print @n.xbgr.xm39_u24.nsg13_hv_pmos[w]
print @n.xbgr.xm39_u24.nsg13_hv_pmos[l]
print @n.xbgr.xm39_u24.nsg13_hv_pmos[delvto]
print @n.xbgr.xm39_u24.nsg13_hv_pmos[factuo]
print @n.xbgr.xm41_u2.nsg13_hv_pmos[w]
print @n.xbgr.xm41_u2.nsg13_hv_pmos[l]
print @n.xbgr.xm41_u2.nsg13_hv_pmos[delvto]
print @n.xbgr.xm41_u2.nsg13_hv_pmos[factuo]
print @n.xbgr.xm41_u3.nsg13_hv_pmos[w]
print @n.xbgr.xm41_u3.nsg13_hv_pmos[l]
print @n.xbgr.xm41_u3.nsg13_hv_pmos[delvto]
print @n.xbgr.xm41_u3.nsg13_hv_pmos[factuo]
print @n.xbgr.xm41_u4.nsg13_hv_pmos[w]
print @n.xbgr.xm41_u4.nsg13_hv_pmos[l]
print @n.xbgr.xm41_u4.nsg13_hv_pmos[delvto]
print @n.xbgr.xm41_u4.nsg13_hv_pmos[factuo]
print @n.xbgr.xm41_u5.nsg13_hv_pmos[w]
print @n.xbgr.xm41_u5.nsg13_hv_pmos[l]
print @n.xbgr.xm41_u5.nsg13_hv_pmos[delvto]
print @n.xbgr.xm41_u5.nsg13_hv_pmos[factuo]
print @n.xbgr.xm41_u6.nsg13_hv_pmos[w]
print @n.xbgr.xm41_u6.nsg13_hv_pmos[l]
print @n.xbgr.xm41_u6.nsg13_hv_pmos[delvto]
print @n.xbgr.xm41_u6.nsg13_hv_pmos[factuo]
print @n.xbgr.xm41_u7.nsg13_hv_pmos[w]
print @n.xbgr.xm41_u7.nsg13_hv_pmos[l]
print @n.xbgr.xm41_u7.nsg13_hv_pmos[delvto]
print @n.xbgr.xm41_u7.nsg13_hv_pmos[factuo]
print @n.xbgr.xm41_u8.nsg13_hv_pmos[w]
print @n.xbgr.xm41_u8.nsg13_hv_pmos[l]
print @n.xbgr.xm41_u8.nsg13_hv_pmos[delvto]
print @n.xbgr.xm41_u8.nsg13_hv_pmos[factuo]
print @n.xbgr.xm41_u9.nsg13_hv_pmos[w]
print @n.xbgr.xm41_u9.nsg13_hv_pmos[l]
print @n.xbgr.xm41_u9.nsg13_hv_pmos[delvto]
print @n.xbgr.xm41_u9.nsg13_hv_pmos[factuo]
print @n.xbgr.xm41_u10.nsg13_hv_pmos[w]
print @n.xbgr.xm41_u10.nsg13_hv_pmos[l]
print @n.xbgr.xm41_u10.nsg13_hv_pmos[delvto]
print @n.xbgr.xm41_u10.nsg13_hv_pmos[factuo]
print @n.xbgr.xm41_u11.nsg13_hv_pmos[w]
print @n.xbgr.xm41_u11.nsg13_hv_pmos[l]
print @n.xbgr.xm41_u11.nsg13_hv_pmos[delvto]
print @n.xbgr.xm41_u11.nsg13_hv_pmos[factuo]
print @n.xbgr.xm41_u12.nsg13_hv_pmos[w]
print @n.xbgr.xm41_u12.nsg13_hv_pmos[l]
print @n.xbgr.xm41_u12.nsg13_hv_pmos[delvto]
print @n.xbgr.xm41_u12.nsg13_hv_pmos[factuo]
print @n.xbgr.xm41_u13.nsg13_hv_pmos[w]
print @n.xbgr.xm41_u13.nsg13_hv_pmos[l]
print @n.xbgr.xm41_u13.nsg13_hv_pmos[delvto]
print @n.xbgr.xm41_u13.nsg13_hv_pmos[factuo]
print @n.xbgr.xm41_u14.nsg13_hv_pmos[w]
print @n.xbgr.xm41_u14.nsg13_hv_pmos[l]
print @n.xbgr.xm41_u14.nsg13_hv_pmos[delvto]
print @n.xbgr.xm41_u14.nsg13_hv_pmos[factuo]
print @n.xbgr.xm41_u15.nsg13_hv_pmos[w]
print @n.xbgr.xm41_u15.nsg13_hv_pmos[l]
print @n.xbgr.xm41_u15.nsg13_hv_pmos[delvto]
print @n.xbgr.xm41_u15.nsg13_hv_pmos[factuo]
print @n.xbgr.xm41_u16.nsg13_hv_pmos[w]
print @n.xbgr.xm41_u16.nsg13_hv_pmos[l]
print @n.xbgr.xm41_u16.nsg13_hv_pmos[delvto]
print @n.xbgr.xm41_u16.nsg13_hv_pmos[factuo]
print @n.xbgr.xm41_u17.nsg13_hv_pmos[w]
print @n.xbgr.xm41_u17.nsg13_hv_pmos[l]
print @n.xbgr.xm41_u17.nsg13_hv_pmos[delvto]
print @n.xbgr.xm41_u17.nsg13_hv_pmos[factuo]
print @n.xbgr.xm41_u18.nsg13_hv_pmos[w]
print @n.xbgr.xm41_u18.nsg13_hv_pmos[l]
print @n.xbgr.xm41_u18.nsg13_hv_pmos[delvto]
print @n.xbgr.xm41_u18.nsg13_hv_pmos[factuo]
print @n.xbgr.xm41_u19.nsg13_hv_pmos[w]
print @n.xbgr.xm41_u19.nsg13_hv_pmos[l]
print @n.xbgr.xm41_u19.nsg13_hv_pmos[delvto]
print @n.xbgr.xm41_u19.nsg13_hv_pmos[factuo]
print @n.xbgr.xm41_u20.nsg13_hv_pmos[w]
print @n.xbgr.xm41_u20.nsg13_hv_pmos[l]
print @n.xbgr.xm41_u20.nsg13_hv_pmos[delvto]
print @n.xbgr.xm41_u20.nsg13_hv_pmos[factuo]
print @n.xbgr.xm41_u21.nsg13_hv_pmos[w]
print @n.xbgr.xm41_u21.nsg13_hv_pmos[l]
print @n.xbgr.xm41_u21.nsg13_hv_pmos[delvto]
print @n.xbgr.xm41_u21.nsg13_hv_pmos[factuo]
print @n.xbgr.xm41_u22.nsg13_hv_pmos[w]
print @n.xbgr.xm41_u22.nsg13_hv_pmos[l]
print @n.xbgr.xm41_u22.nsg13_hv_pmos[delvto]
print @n.xbgr.xm41_u22.nsg13_hv_pmos[factuo]
print @n.xbgr.xm41_u23.nsg13_hv_pmos[w]
print @n.xbgr.xm41_u23.nsg13_hv_pmos[l]
print @n.xbgr.xm41_u23.nsg13_hv_pmos[delvto]
print @n.xbgr.xm41_u23.nsg13_hv_pmos[factuo]
print @n.xbgr.xm41_u24.nsg13_hv_pmos[w]
print @n.xbgr.xm41_u24.nsg13_hv_pmos[l]
print @n.xbgr.xm41_u24.nsg13_hv_pmos[delvto]
print @n.xbgr.xm41_u24.nsg13_hv_pmos[factuo]
print @n.xbgr.xm43_u2.nsg13_hv_pmos[w]
print @n.xbgr.xm43_u2.nsg13_hv_pmos[l]
print @n.xbgr.xm43_u2.nsg13_hv_pmos[delvto]
print @n.xbgr.xm43_u2.nsg13_hv_pmos[factuo]
print @n.xbgr.xm43_u3.nsg13_hv_pmos[w]
print @n.xbgr.xm43_u3.nsg13_hv_pmos[l]
print @n.xbgr.xm43_u3.nsg13_hv_pmos[delvto]
print @n.xbgr.xm43_u3.nsg13_hv_pmos[factuo]
print @n.xbgr.xm43_u4.nsg13_hv_pmos[w]
print @n.xbgr.xm43_u4.nsg13_hv_pmos[l]
print @n.xbgr.xm43_u4.nsg13_hv_pmos[delvto]
print @n.xbgr.xm43_u4.nsg13_hv_pmos[factuo]
print @n.xbgr.xm44_u2.nsg13_hv_pmos[w]
print @n.xbgr.xm44_u2.nsg13_hv_pmos[l]
print @n.xbgr.xm44_u2.nsg13_hv_pmos[delvto]
print @n.xbgr.xm44_u2.nsg13_hv_pmos[factuo]
print @n.xbgr.xm44_u3.nsg13_hv_pmos[w]
print @n.xbgr.xm44_u3.nsg13_hv_pmos[l]
print @n.xbgr.xm44_u3.nsg13_hv_pmos[delvto]
print @n.xbgr.xm44_u3.nsg13_hv_pmos[factuo]
print @n.xbgr.xm44_u4.nsg13_hv_pmos[w]
print @n.xbgr.xm44_u4.nsg13_hv_pmos[l]
print @n.xbgr.xm44_u4.nsg13_hv_pmos[delvto]
print @n.xbgr.xm44_u4.nsg13_hv_pmos[factuo]
print @n.xbgr.xm45_u2.nsg13_hv_pmos[w]
print @n.xbgr.xm45_u2.nsg13_hv_pmos[l]
print @n.xbgr.xm45_u2.nsg13_hv_pmos[delvto]
print @n.xbgr.xm45_u2.nsg13_hv_pmos[factuo]
print @n.xbgr.xm45_u3.nsg13_hv_pmos[w]
print @n.xbgr.xm45_u3.nsg13_hv_pmos[l]
print @n.xbgr.xm45_u3.nsg13_hv_pmos[delvto]
print @n.xbgr.xm45_u3.nsg13_hv_pmos[factuo]
print @n.xbgr.xm45_u4.nsg13_hv_pmos[w]
print @n.xbgr.xm45_u4.nsg13_hv_pmos[l]
print @n.xbgr.xm45_u4.nsg13_hv_pmos[delvto]
print @n.xbgr.xm45_u4.nsg13_hv_pmos[factuo]
print @n.xbgr.xm45_u5.nsg13_hv_pmos[w]
print @n.xbgr.xm45_u5.nsg13_hv_pmos[l]
print @n.xbgr.xm45_u5.nsg13_hv_pmos[delvto]
print @n.xbgr.xm45_u5.nsg13_hv_pmos[factuo]
print @n.xbgr.xm45_u6.nsg13_hv_pmos[w]
print @n.xbgr.xm45_u6.nsg13_hv_pmos[l]
print @n.xbgr.xm45_u6.nsg13_hv_pmos[delvto]
print @n.xbgr.xm45_u6.nsg13_hv_pmos[factuo]
print @n.xbgr.xm45_u7.nsg13_hv_pmos[w]
print @n.xbgr.xm45_u7.nsg13_hv_pmos[l]
print @n.xbgr.xm45_u7.nsg13_hv_pmos[delvto]
print @n.xbgr.xm45_u7.nsg13_hv_pmos[factuo]
print @n.xbgr.xm45_u8.nsg13_hv_pmos[w]
print @n.xbgr.xm45_u8.nsg13_hv_pmos[l]
print @n.xbgr.xm45_u8.nsg13_hv_pmos[delvto]
print @n.xbgr.xm45_u8.nsg13_hv_pmos[factuo]
print @n.xbgr.xm45_u9.nsg13_hv_pmos[w]
print @n.xbgr.xm45_u9.nsg13_hv_pmos[l]
print @n.xbgr.xm45_u9.nsg13_hv_pmos[delvto]
print @n.xbgr.xm45_u9.nsg13_hv_pmos[factuo]
print @n.xbgr.xm45_u10.nsg13_hv_pmos[w]
print @n.xbgr.xm45_u10.nsg13_hv_pmos[l]
print @n.xbgr.xm45_u10.nsg13_hv_pmos[delvto]
print @n.xbgr.xm45_u10.nsg13_hv_pmos[factuo]
print @n.xbgr.xm45_u11.nsg13_hv_pmos[w]
print @n.xbgr.xm45_u11.nsg13_hv_pmos[l]
print @n.xbgr.xm45_u11.nsg13_hv_pmos[delvto]
print @n.xbgr.xm45_u11.nsg13_hv_pmos[factuo]
print @n.xbgr.xm45_u12.nsg13_hv_pmos[w]
print @n.xbgr.xm45_u12.nsg13_hv_pmos[l]
print @n.xbgr.xm45_u12.nsg13_hv_pmos[delvto]
print @n.xbgr.xm45_u12.nsg13_hv_pmos[factuo]
print @n.xbgr.xm45_u13.nsg13_hv_pmos[w]
print @n.xbgr.xm45_u13.nsg13_hv_pmos[l]
print @n.xbgr.xm45_u13.nsg13_hv_pmos[delvto]
print @n.xbgr.xm45_u13.nsg13_hv_pmos[factuo]
print @n.xbgr.xm45_u14.nsg13_hv_pmos[w]
print @n.xbgr.xm45_u14.nsg13_hv_pmos[l]
print @n.xbgr.xm45_u14.nsg13_hv_pmos[delvto]
print @n.xbgr.xm45_u14.nsg13_hv_pmos[factuo]
print @n.xbgr.xm45_u15.nsg13_hv_pmos[w]
print @n.xbgr.xm45_u15.nsg13_hv_pmos[l]
print @n.xbgr.xm45_u15.nsg13_hv_pmos[delvto]
print @n.xbgr.xm45_u15.nsg13_hv_pmos[factuo]
print @n.xbgr.xm45_u16.nsg13_hv_pmos[w]
print @n.xbgr.xm45_u16.nsg13_hv_pmos[l]
print @n.xbgr.xm45_u16.nsg13_hv_pmos[delvto]
print @n.xbgr.xm45_u16.nsg13_hv_pmos[factuo]
print @n.xbgr.xm45_u17.nsg13_hv_pmos[w]
print @n.xbgr.xm45_u17.nsg13_hv_pmos[l]
print @n.xbgr.xm45_u17.nsg13_hv_pmos[delvto]
print @n.xbgr.xm45_u17.nsg13_hv_pmos[factuo]
print @n.xbgr.xm45_u18.nsg13_hv_pmos[w]
print @n.xbgr.xm45_u18.nsg13_hv_pmos[l]
print @n.xbgr.xm45_u18.nsg13_hv_pmos[delvto]
print @n.xbgr.xm45_u18.nsg13_hv_pmos[factuo]
print @n.xbgr.xm45_u19.nsg13_hv_pmos[w]
print @n.xbgr.xm45_u19.nsg13_hv_pmos[l]
print @n.xbgr.xm45_u19.nsg13_hv_pmos[delvto]
print @n.xbgr.xm45_u19.nsg13_hv_pmos[factuo]
print @n.xbgr.xm45_u20.nsg13_hv_pmos[w]
print @n.xbgr.xm45_u20.nsg13_hv_pmos[l]
print @n.xbgr.xm45_u20.nsg13_hv_pmos[delvto]
print @n.xbgr.xm45_u20.nsg13_hv_pmos[factuo]
print @n.xbgr.xm45_u21.nsg13_hv_pmos[w]
print @n.xbgr.xm45_u21.nsg13_hv_pmos[l]
print @n.xbgr.xm45_u21.nsg13_hv_pmos[delvto]
print @n.xbgr.xm45_u21.nsg13_hv_pmos[factuo]
print @n.xbgr.xm45_u22.nsg13_hv_pmos[w]
print @n.xbgr.xm45_u22.nsg13_hv_pmos[l]
print @n.xbgr.xm45_u22.nsg13_hv_pmos[delvto]
print @n.xbgr.xm45_u22.nsg13_hv_pmos[factuo]
print @n.xbgr.xm45_u23.nsg13_hv_pmos[w]
print @n.xbgr.xm45_u23.nsg13_hv_pmos[l]
print @n.xbgr.xm45_u23.nsg13_hv_pmos[delvto]
print @n.xbgr.xm45_u23.nsg13_hv_pmos[factuo]
print @n.xbgr.xm45_u24.nsg13_hv_pmos[w]
print @n.xbgr.xm45_u24.nsg13_hv_pmos[l]
print @n.xbgr.xm45_u24.nsg13_hv_pmos[delvto]
print @n.xbgr.xm45_u24.nsg13_hv_pmos[factuo]
print @n.xbgr.xm47_u2.nsg13_hv_pmos[w]
print @n.xbgr.xm47_u2.nsg13_hv_pmos[l]
print @n.xbgr.xm47_u2.nsg13_hv_pmos[delvto]
print @n.xbgr.xm47_u2.nsg13_hv_pmos[factuo]
print @n.xbgr.xm47_u3.nsg13_hv_pmos[w]
print @n.xbgr.xm47_u3.nsg13_hv_pmos[l]
print @n.xbgr.xm47_u3.nsg13_hv_pmos[delvto]
print @n.xbgr.xm47_u3.nsg13_hv_pmos[factuo]
print @n.xbgr.xm47_u4.nsg13_hv_pmos[w]
print @n.xbgr.xm47_u4.nsg13_hv_pmos[l]
print @n.xbgr.xm47_u4.nsg13_hv_pmos[delvto]
print @n.xbgr.xm47_u4.nsg13_hv_pmos[factuo]
print @n.xbgr.xm47_u5.nsg13_hv_pmos[w]
print @n.xbgr.xm47_u5.nsg13_hv_pmos[l]
print @n.xbgr.xm47_u5.nsg13_hv_pmos[delvto]
print @n.xbgr.xm47_u5.nsg13_hv_pmos[factuo]
print @n.xbgr.xm47_u6.nsg13_hv_pmos[w]
print @n.xbgr.xm47_u6.nsg13_hv_pmos[l]
print @n.xbgr.xm47_u6.nsg13_hv_pmos[delvto]
print @n.xbgr.xm47_u6.nsg13_hv_pmos[factuo]
print @n.xbgr.xm47_u7.nsg13_hv_pmos[w]
print @n.xbgr.xm47_u7.nsg13_hv_pmos[l]
print @n.xbgr.xm47_u7.nsg13_hv_pmos[delvto]
print @n.xbgr.xm47_u7.nsg13_hv_pmos[factuo]
print @n.xbgr.xm47_u8.nsg13_hv_pmos[w]
print @n.xbgr.xm47_u8.nsg13_hv_pmos[l]
print @n.xbgr.xm47_u8.nsg13_hv_pmos[delvto]
print @n.xbgr.xm47_u8.nsg13_hv_pmos[factuo]
print @n.xbgr.xm47_u9.nsg13_hv_pmos[w]
print @n.xbgr.xm47_u9.nsg13_hv_pmos[l]
print @n.xbgr.xm47_u9.nsg13_hv_pmos[delvto]
print @n.xbgr.xm47_u9.nsg13_hv_pmos[factuo]
print @n.xbgr.xm47_u10.nsg13_hv_pmos[w]
print @n.xbgr.xm47_u10.nsg13_hv_pmos[l]
print @n.xbgr.xm47_u10.nsg13_hv_pmos[delvto]
print @n.xbgr.xm47_u10.nsg13_hv_pmos[factuo]
print @n.xbgr.xm47_u11.nsg13_hv_pmos[w]
print @n.xbgr.xm47_u11.nsg13_hv_pmos[l]
print @n.xbgr.xm47_u11.nsg13_hv_pmos[delvto]
print @n.xbgr.xm47_u11.nsg13_hv_pmos[factuo]
print @n.xbgr.xm47_u12.nsg13_hv_pmos[w]
print @n.xbgr.xm47_u12.nsg13_hv_pmos[l]
print @n.xbgr.xm47_u12.nsg13_hv_pmos[delvto]
print @n.xbgr.xm47_u12.nsg13_hv_pmos[factuo]
print @n.xbgr.xm47_u13.nsg13_hv_pmos[w]
print @n.xbgr.xm47_u13.nsg13_hv_pmos[l]
print @n.xbgr.xm47_u13.nsg13_hv_pmos[delvto]
print @n.xbgr.xm47_u13.nsg13_hv_pmos[factuo]
print @n.xbgr.xm47_u14.nsg13_hv_pmos[w]
print @n.xbgr.xm47_u14.nsg13_hv_pmos[l]
print @n.xbgr.xm47_u14.nsg13_hv_pmos[delvto]
print @n.xbgr.xm47_u14.nsg13_hv_pmos[factuo]
print @n.xbgr.xm47_u15.nsg13_hv_pmos[w]
print @n.xbgr.xm47_u15.nsg13_hv_pmos[l]
print @n.xbgr.xm47_u15.nsg13_hv_pmos[delvto]
print @n.xbgr.xm47_u15.nsg13_hv_pmos[factuo]
print @n.xbgr.xm47_u16.nsg13_hv_pmos[w]
print @n.xbgr.xm47_u16.nsg13_hv_pmos[l]
print @n.xbgr.xm47_u16.nsg13_hv_pmos[delvto]
print @n.xbgr.xm47_u16.nsg13_hv_pmos[factuo]
print @n.xbgr.xm47_u17.nsg13_hv_pmos[w]
print @n.xbgr.xm47_u17.nsg13_hv_pmos[l]
print @n.xbgr.xm47_u17.nsg13_hv_pmos[delvto]
print @n.xbgr.xm47_u17.nsg13_hv_pmos[factuo]
print @n.xbgr.xm47_u18.nsg13_hv_pmos[w]
print @n.xbgr.xm47_u18.nsg13_hv_pmos[l]
print @n.xbgr.xm47_u18.nsg13_hv_pmos[delvto]
print @n.xbgr.xm47_u18.nsg13_hv_pmos[factuo]
print @n.xbgr.xm47_u19.nsg13_hv_pmos[w]
print @n.xbgr.xm47_u19.nsg13_hv_pmos[l]
print @n.xbgr.xm47_u19.nsg13_hv_pmos[delvto]
print @n.xbgr.xm47_u19.nsg13_hv_pmos[factuo]
print @n.xbgr.xm47_u20.nsg13_hv_pmos[w]
print @n.xbgr.xm47_u20.nsg13_hv_pmos[l]
print @n.xbgr.xm47_u20.nsg13_hv_pmos[delvto]
print @n.xbgr.xm47_u20.nsg13_hv_pmos[factuo]
print @n.xbgr.xm47_u21.nsg13_hv_pmos[w]
print @n.xbgr.xm47_u21.nsg13_hv_pmos[l]
print @n.xbgr.xm47_u21.nsg13_hv_pmos[delvto]
print @n.xbgr.xm47_u21.nsg13_hv_pmos[factuo]
print @n.xbgr.xm47_u22.nsg13_hv_pmos[w]
print @n.xbgr.xm47_u22.nsg13_hv_pmos[l]
print @n.xbgr.xm47_u22.nsg13_hv_pmos[delvto]
print @n.xbgr.xm47_u22.nsg13_hv_pmos[factuo]
print @n.xbgr.xm47_u23.nsg13_hv_pmos[w]
print @n.xbgr.xm47_u23.nsg13_hv_pmos[l]
print @n.xbgr.xm47_u23.nsg13_hv_pmos[delvto]
print @n.xbgr.xm47_u23.nsg13_hv_pmos[factuo]
print @n.xbgr.xm47_u24.nsg13_hv_pmos[w]
print @n.xbgr.xm47_u24.nsg13_hv_pmos[l]
print @n.xbgr.xm47_u24.nsg13_hv_pmos[delvto]
print @n.xbgr.xm47_u24.nsg13_hv_pmos[factuo]
print @n.xbgr.xm48_u2.nsg13_hv_pmos[w]
print @n.xbgr.xm48_u2.nsg13_hv_pmos[l]
print @n.xbgr.xm48_u2.nsg13_hv_pmos[delvto]
print @n.xbgr.xm48_u2.nsg13_hv_pmos[factuo]
print @n.xbgr.xm48_u3.nsg13_hv_pmos[w]
print @n.xbgr.xm48_u3.nsg13_hv_pmos[l]
print @n.xbgr.xm48_u3.nsg13_hv_pmos[delvto]
print @n.xbgr.xm48_u3.nsg13_hv_pmos[factuo]
print @n.xbgr.xm48_u4.nsg13_hv_pmos[w]
print @n.xbgr.xm48_u4.nsg13_hv_pmos[l]
print @n.xbgr.xm48_u4.nsg13_hv_pmos[delvto]
print @n.xbgr.xm48_u4.nsg13_hv_pmos[factuo]
print @n.xbgr.xm48_u5.nsg13_hv_pmos[w]
print @n.xbgr.xm48_u5.nsg13_hv_pmos[l]
print @n.xbgr.xm48_u5.nsg13_hv_pmos[delvto]
print @n.xbgr.xm48_u5.nsg13_hv_pmos[factuo]
print @n.xbgr.xm48_u6.nsg13_hv_pmos[w]
print @n.xbgr.xm48_u6.nsg13_hv_pmos[l]
print @n.xbgr.xm48_u6.nsg13_hv_pmos[delvto]
print @n.xbgr.xm48_u6.nsg13_hv_pmos[factuo]
print @n.xbgr.xm48_u7.nsg13_hv_pmos[w]
print @n.xbgr.xm48_u7.nsg13_hv_pmos[l]
print @n.xbgr.xm48_u7.nsg13_hv_pmos[delvto]
print @n.xbgr.xm48_u7.nsg13_hv_pmos[factuo]
print @n.xbgr.xm48_u8.nsg13_hv_pmos[w]
print @n.xbgr.xm48_u8.nsg13_hv_pmos[l]
print @n.xbgr.xm48_u8.nsg13_hv_pmos[delvto]
print @n.xbgr.xm48_u8.nsg13_hv_pmos[factuo]
print @n.xbgr.xm48_u9.nsg13_hv_pmos[w]
print @n.xbgr.xm48_u9.nsg13_hv_pmos[l]
print @n.xbgr.xm48_u9.nsg13_hv_pmos[delvto]
print @n.xbgr.xm48_u9.nsg13_hv_pmos[factuo]
print @n.xbgr.xm48_u10.nsg13_hv_pmos[w]
print @n.xbgr.xm48_u10.nsg13_hv_pmos[l]
print @n.xbgr.xm48_u10.nsg13_hv_pmos[delvto]
print @n.xbgr.xm48_u10.nsg13_hv_pmos[factuo]
print @n.xbgr.xm48_u11.nsg13_hv_pmos[w]
print @n.xbgr.xm48_u11.nsg13_hv_pmos[l]
print @n.xbgr.xm48_u11.nsg13_hv_pmos[delvto]
print @n.xbgr.xm48_u11.nsg13_hv_pmos[factuo]
print @n.xbgr.xm48_u12.nsg13_hv_pmos[w]
print @n.xbgr.xm48_u12.nsg13_hv_pmos[l]
print @n.xbgr.xm48_u12.nsg13_hv_pmos[delvto]
print @n.xbgr.xm48_u12.nsg13_hv_pmos[factuo]
print @n.xbgr.xm48_u13.nsg13_hv_pmos[w]
print @n.xbgr.xm48_u13.nsg13_hv_pmos[l]
print @n.xbgr.xm48_u13.nsg13_hv_pmos[delvto]
print @n.xbgr.xm48_u13.nsg13_hv_pmos[factuo]
print @n.xbgr.xm48_u14.nsg13_hv_pmos[w]
print @n.xbgr.xm48_u14.nsg13_hv_pmos[l]
print @n.xbgr.xm48_u14.nsg13_hv_pmos[delvto]
print @n.xbgr.xm48_u14.nsg13_hv_pmos[factuo]
print @n.xbgr.xm48_u15.nsg13_hv_pmos[w]
print @n.xbgr.xm48_u15.nsg13_hv_pmos[l]
print @n.xbgr.xm48_u15.nsg13_hv_pmos[delvto]
print @n.xbgr.xm48_u15.nsg13_hv_pmos[factuo]
print @n.xbgr.xm48_u16.nsg13_hv_pmos[w]
print @n.xbgr.xm48_u16.nsg13_hv_pmos[l]
print @n.xbgr.xm48_u16.nsg13_hv_pmos[delvto]
print @n.xbgr.xm48_u16.nsg13_hv_pmos[factuo]
print @n.xbgr.xm48_u17.nsg13_hv_pmos[w]
print @n.xbgr.xm48_u17.nsg13_hv_pmos[l]
print @n.xbgr.xm48_u17.nsg13_hv_pmos[delvto]
print @n.xbgr.xm48_u17.nsg13_hv_pmos[factuo]
print @n.xbgr.xm48_u18.nsg13_hv_pmos[w]
print @n.xbgr.xm48_u18.nsg13_hv_pmos[l]
print @n.xbgr.xm48_u18.nsg13_hv_pmos[delvto]
print @n.xbgr.xm48_u18.nsg13_hv_pmos[factuo]
print @n.xbgr.xm48_u19.nsg13_hv_pmos[w]
print @n.xbgr.xm48_u19.nsg13_hv_pmos[l]
print @n.xbgr.xm48_u19.nsg13_hv_pmos[delvto]
print @n.xbgr.xm48_u19.nsg13_hv_pmos[factuo]
print @n.xbgr.xm48_u20.nsg13_hv_pmos[w]
print @n.xbgr.xm48_u20.nsg13_hv_pmos[l]
print @n.xbgr.xm48_u20.nsg13_hv_pmos[delvto]
print @n.xbgr.xm48_u20.nsg13_hv_pmos[factuo]
print @n.xbgr.xm48_u21.nsg13_hv_pmos[w]
print @n.xbgr.xm48_u21.nsg13_hv_pmos[l]
print @n.xbgr.xm48_u21.nsg13_hv_pmos[delvto]
print @n.xbgr.xm48_u21.nsg13_hv_pmos[factuo]
print @n.xbgr.xm48_u22.nsg13_hv_pmos[w]
print @n.xbgr.xm48_u22.nsg13_hv_pmos[l]
print @n.xbgr.xm48_u22.nsg13_hv_pmos[delvto]
print @n.xbgr.xm48_u22.nsg13_hv_pmos[factuo]
print @n.xbgr.xm48_u23.nsg13_hv_pmos[w]
print @n.xbgr.xm48_u23.nsg13_hv_pmos[l]
print @n.xbgr.xm48_u23.nsg13_hv_pmos[delvto]
print @n.xbgr.xm48_u23.nsg13_hv_pmos[factuo]
print @n.xbgr.xm48_u24.nsg13_hv_pmos[w]
print @n.xbgr.xm48_u24.nsg13_hv_pmos[l]
print @n.xbgr.xm48_u24.nsg13_hv_pmos[delvto]
print @n.xbgr.xm48_u24.nsg13_hv_pmos[factuo]
print @n.xbgr.xm50_u2.nsg13_hv_pmos[w]
print @n.xbgr.xm50_u2.nsg13_hv_pmos[l]
print @n.xbgr.xm50_u2.nsg13_hv_pmos[delvto]
print @n.xbgr.xm50_u2.nsg13_hv_pmos[factuo]
print @n.xbgr.xm50_u3.nsg13_hv_pmos[w]
print @n.xbgr.xm50_u3.nsg13_hv_pmos[l]
print @n.xbgr.xm50_u3.nsg13_hv_pmos[delvto]
print @n.xbgr.xm50_u3.nsg13_hv_pmos[factuo]
print @n.xbgr.xm50_u4.nsg13_hv_pmos[w]
print @n.xbgr.xm50_u4.nsg13_hv_pmos[l]
print @n.xbgr.xm50_u4.nsg13_hv_pmos[delvto]
print @n.xbgr.xm50_u4.nsg13_hv_pmos[factuo]
print @n.xbgr.xm50_u5.nsg13_hv_pmos[w]
print @n.xbgr.xm50_u5.nsg13_hv_pmos[l]
print @n.xbgr.xm50_u5.nsg13_hv_pmos[delvto]
print @n.xbgr.xm50_u5.nsg13_hv_pmos[factuo]
print @n.xbgr.xm50_u6.nsg13_hv_pmos[w]
print @n.xbgr.xm50_u6.nsg13_hv_pmos[l]
print @n.xbgr.xm50_u6.nsg13_hv_pmos[delvto]
print @n.xbgr.xm50_u6.nsg13_hv_pmos[factuo]
print @n.xbgr.xm50_u7.nsg13_hv_pmos[w]
print @n.xbgr.xm50_u7.nsg13_hv_pmos[l]
print @n.xbgr.xm50_u7.nsg13_hv_pmos[delvto]
print @n.xbgr.xm50_u7.nsg13_hv_pmos[factuo]
print @n.xbgr.xm50_u8.nsg13_hv_pmos[w]
print @n.xbgr.xm50_u8.nsg13_hv_pmos[l]
print @n.xbgr.xm50_u8.nsg13_hv_pmos[delvto]
print @n.xbgr.xm50_u8.nsg13_hv_pmos[factuo]
print @n.xbgr.xm50_u9.nsg13_hv_pmos[w]
print @n.xbgr.xm50_u9.nsg13_hv_pmos[l]
print @n.xbgr.xm50_u9.nsg13_hv_pmos[delvto]
print @n.xbgr.xm50_u9.nsg13_hv_pmos[factuo]
print @n.xbgr.xm50_u10.nsg13_hv_pmos[w]
print @n.xbgr.xm50_u10.nsg13_hv_pmos[l]
print @n.xbgr.xm50_u10.nsg13_hv_pmos[delvto]
print @n.xbgr.xm50_u10.nsg13_hv_pmos[factuo]
print @n.xbgr.xm50_u11.nsg13_hv_pmos[w]
print @n.xbgr.xm50_u11.nsg13_hv_pmos[l]
print @n.xbgr.xm50_u11.nsg13_hv_pmos[delvto]
print @n.xbgr.xm50_u11.nsg13_hv_pmos[factuo]
print @n.xbgr.xm50_u12.nsg13_hv_pmos[w]
print @n.xbgr.xm50_u12.nsg13_hv_pmos[l]
print @n.xbgr.xm50_u12.nsg13_hv_pmos[delvto]
print @n.xbgr.xm50_u12.nsg13_hv_pmos[factuo]
print @n.xbgr.xm50_u13.nsg13_hv_pmos[w]
print @n.xbgr.xm50_u13.nsg13_hv_pmos[l]
print @n.xbgr.xm50_u13.nsg13_hv_pmos[delvto]
print @n.xbgr.xm50_u13.nsg13_hv_pmos[factuo]
print @n.xbgr.xm50_u14.nsg13_hv_pmos[w]
print @n.xbgr.xm50_u14.nsg13_hv_pmos[l]
print @n.xbgr.xm50_u14.nsg13_hv_pmos[delvto]
print @n.xbgr.xm50_u14.nsg13_hv_pmos[factuo]
print @n.xbgr.xm50_u15.nsg13_hv_pmos[w]
print @n.xbgr.xm50_u15.nsg13_hv_pmos[l]
print @n.xbgr.xm50_u15.nsg13_hv_pmos[delvto]
print @n.xbgr.xm50_u15.nsg13_hv_pmos[factuo]
print @n.xbgr.xm50_u16.nsg13_hv_pmos[w]
print @n.xbgr.xm50_u16.nsg13_hv_pmos[l]
print @n.xbgr.xm50_u16.nsg13_hv_pmos[delvto]
print @n.xbgr.xm50_u16.nsg13_hv_pmos[factuo]
print @n.xbgr.xm50_u17.nsg13_hv_pmos[w]
print @n.xbgr.xm50_u17.nsg13_hv_pmos[l]
print @n.xbgr.xm50_u17.nsg13_hv_pmos[delvto]
print @n.xbgr.xm50_u17.nsg13_hv_pmos[factuo]
print @n.xbgr.xm50_u18.nsg13_hv_pmos[w]
print @n.xbgr.xm50_u18.nsg13_hv_pmos[l]
print @n.xbgr.xm50_u18.nsg13_hv_pmos[delvto]
print @n.xbgr.xm50_u18.nsg13_hv_pmos[factuo]
print @n.xbgr.xm50_u19.nsg13_hv_pmos[w]
print @n.xbgr.xm50_u19.nsg13_hv_pmos[l]
print @n.xbgr.xm50_u19.nsg13_hv_pmos[delvto]
print @n.xbgr.xm50_u19.nsg13_hv_pmos[factuo]
print @n.xbgr.xm50_u20.nsg13_hv_pmos[w]
print @n.xbgr.xm50_u20.nsg13_hv_pmos[l]
print @n.xbgr.xm50_u20.nsg13_hv_pmos[delvto]
print @n.xbgr.xm50_u20.nsg13_hv_pmos[factuo]
print @n.xbgr.xm50_u21.nsg13_hv_pmos[w]
print @n.xbgr.xm50_u21.nsg13_hv_pmos[l]
print @n.xbgr.xm50_u21.nsg13_hv_pmos[delvto]
print @n.xbgr.xm50_u21.nsg13_hv_pmos[factuo]
print @n.xbgr.xm50_u22.nsg13_hv_pmos[w]
print @n.xbgr.xm50_u22.nsg13_hv_pmos[l]
print @n.xbgr.xm50_u22.nsg13_hv_pmos[delvto]
print @n.xbgr.xm50_u22.nsg13_hv_pmos[factuo]
print @n.xbgr.xm50_u23.nsg13_hv_pmos[w]
print @n.xbgr.xm50_u23.nsg13_hv_pmos[l]
print @n.xbgr.xm50_u23.nsg13_hv_pmos[delvto]
print @n.xbgr.xm50_u23.nsg13_hv_pmos[factuo]
print @n.xbgr.xm50_u24.nsg13_hv_pmos[w]
print @n.xbgr.xm50_u24.nsg13_hv_pmos[l]
print @n.xbgr.xm50_u24.nsg13_hv_pmos[delvto]
print @n.xbgr.xm50_u24.nsg13_hv_pmos[factuo]
print @n.xbgr.xm51_u2.nsg13_hv_pmos[w]
print @n.xbgr.xm51_u2.nsg13_hv_pmos[l]
print @n.xbgr.xm51_u2.nsg13_hv_pmos[delvto]
print @n.xbgr.xm51_u2.nsg13_hv_pmos[factuo]
print @n.xbgr.xm51_u3.nsg13_hv_pmos[w]
print @n.xbgr.xm51_u3.nsg13_hv_pmos[l]
print @n.xbgr.xm51_u3.nsg13_hv_pmos[delvto]
print @n.xbgr.xm51_u3.nsg13_hv_pmos[factuo]
print @n.xbgr.xm51_u4.nsg13_hv_pmos[w]
print @n.xbgr.xm51_u4.nsg13_hv_pmos[l]
print @n.xbgr.xm51_u4.nsg13_hv_pmos[delvto]
print @n.xbgr.xm51_u4.nsg13_hv_pmos[factuo]
print @n.xbgr.xm52_u2.nsg13_hv_pmos[w]
print @n.xbgr.xm52_u2.nsg13_hv_pmos[l]
print @n.xbgr.xm52_u2.nsg13_hv_pmos[delvto]
print @n.xbgr.xm52_u2.nsg13_hv_pmos[factuo]
print @n.xbgr.xm52_u3.nsg13_hv_pmos[w]
print @n.xbgr.xm52_u3.nsg13_hv_pmos[l]
print @n.xbgr.xm52_u3.nsg13_hv_pmos[delvto]
print @n.xbgr.xm52_u3.nsg13_hv_pmos[factuo]
print @n.xbgr.xm52_u4.nsg13_hv_pmos[w]
print @n.xbgr.xm52_u4.nsg13_hv_pmos[l]
print @n.xbgr.xm52_u4.nsg13_hv_pmos[delvto]
print @n.xbgr.xm52_u4.nsg13_hv_pmos[factuo]
print @n.xbgr.xm52_u5.nsg13_hv_pmos[w]
print @n.xbgr.xm52_u5.nsg13_hv_pmos[l]
print @n.xbgr.xm52_u5.nsg13_hv_pmos[delvto]
print @n.xbgr.xm52_u5.nsg13_hv_pmos[factuo]
print @n.xbgr.xm52_u6.nsg13_hv_pmos[w]
print @n.xbgr.xm52_u6.nsg13_hv_pmos[l]
print @n.xbgr.xm52_u6.nsg13_hv_pmos[delvto]
print @n.xbgr.xm52_u6.nsg13_hv_pmos[factuo]
print @n.xbgr.xm52_u7.nsg13_hv_pmos[w]
print @n.xbgr.xm52_u7.nsg13_hv_pmos[l]
print @n.xbgr.xm52_u7.nsg13_hv_pmos[delvto]
print @n.xbgr.xm52_u7.nsg13_hv_pmos[factuo]
print @n.xbgr.xm52_u8.nsg13_hv_pmos[w]
print @n.xbgr.xm52_u8.nsg13_hv_pmos[l]
print @n.xbgr.xm52_u8.nsg13_hv_pmos[delvto]
print @n.xbgr.xm52_u8.nsg13_hv_pmos[factuo]
print @n.xbgr.xm52_u9.nsg13_hv_pmos[w]
print @n.xbgr.xm52_u9.nsg13_hv_pmos[l]
print @n.xbgr.xm52_u9.nsg13_hv_pmos[delvto]
print @n.xbgr.xm52_u9.nsg13_hv_pmos[factuo]
print @n.xbgr.xm52_u10.nsg13_hv_pmos[w]
print @n.xbgr.xm52_u10.nsg13_hv_pmos[l]
print @n.xbgr.xm52_u10.nsg13_hv_pmos[delvto]
print @n.xbgr.xm52_u10.nsg13_hv_pmos[factuo]
print @n.xbgr.xm52_u11.nsg13_hv_pmos[w]
print @n.xbgr.xm52_u11.nsg13_hv_pmos[l]
print @n.xbgr.xm52_u11.nsg13_hv_pmos[delvto]
print @n.xbgr.xm52_u11.nsg13_hv_pmos[factuo]
print @n.xbgr.xm52_u12.nsg13_hv_pmos[w]
print @n.xbgr.xm52_u12.nsg13_hv_pmos[l]
print @n.xbgr.xm52_u12.nsg13_hv_pmos[delvto]
print @n.xbgr.xm52_u12.nsg13_hv_pmos[factuo]
print @n.xbgr.xm52_u13.nsg13_hv_pmos[w]
print @n.xbgr.xm52_u13.nsg13_hv_pmos[l]
print @n.xbgr.xm52_u13.nsg13_hv_pmos[delvto]
print @n.xbgr.xm52_u13.nsg13_hv_pmos[factuo]
print @n.xbgr.xm52_u14.nsg13_hv_pmos[w]
print @n.xbgr.xm52_u14.nsg13_hv_pmos[l]
print @n.xbgr.xm52_u14.nsg13_hv_pmos[delvto]
print @n.xbgr.xm52_u14.nsg13_hv_pmos[factuo]
print @n.xbgr.xm52_u15.nsg13_hv_pmos[w]
print @n.xbgr.xm52_u15.nsg13_hv_pmos[l]
print @n.xbgr.xm52_u15.nsg13_hv_pmos[delvto]
print @n.xbgr.xm52_u15.nsg13_hv_pmos[factuo]
print @n.xbgr.xm52_u16.nsg13_hv_pmos[w]
print @n.xbgr.xm52_u16.nsg13_hv_pmos[l]
print @n.xbgr.xm52_u16.nsg13_hv_pmos[delvto]
print @n.xbgr.xm52_u16.nsg13_hv_pmos[factuo]
print @n.xbgr.xm52_u17.nsg13_hv_pmos[w]
print @n.xbgr.xm52_u17.nsg13_hv_pmos[l]
print @n.xbgr.xm52_u17.nsg13_hv_pmos[delvto]
print @n.xbgr.xm52_u17.nsg13_hv_pmos[factuo]
print @n.xbgr.xm52_u18.nsg13_hv_pmos[w]
print @n.xbgr.xm52_u18.nsg13_hv_pmos[l]
print @n.xbgr.xm52_u18.nsg13_hv_pmos[delvto]
print @n.xbgr.xm52_u18.nsg13_hv_pmos[factuo]
print @n.xbgr.xm52_u19.nsg13_hv_pmos[w]
print @n.xbgr.xm52_u19.nsg13_hv_pmos[l]
print @n.xbgr.xm52_u19.nsg13_hv_pmos[delvto]
print @n.xbgr.xm52_u19.nsg13_hv_pmos[factuo]
print @n.xbgr.xm52_u20.nsg13_hv_pmos[w]
print @n.xbgr.xm52_u20.nsg13_hv_pmos[l]
print @n.xbgr.xm52_u20.nsg13_hv_pmos[delvto]
print @n.xbgr.xm52_u20.nsg13_hv_pmos[factuo]
print @n.xbgr.xm52_u21.nsg13_hv_pmos[w]
print @n.xbgr.xm52_u21.nsg13_hv_pmos[l]
print @n.xbgr.xm52_u21.nsg13_hv_pmos[delvto]
print @n.xbgr.xm52_u21.nsg13_hv_pmos[factuo]
print @n.xbgr.xm52_u22.nsg13_hv_pmos[w]
print @n.xbgr.xm52_u22.nsg13_hv_pmos[l]
print @n.xbgr.xm52_u22.nsg13_hv_pmos[delvto]
print @n.xbgr.xm52_u22.nsg13_hv_pmos[factuo]
print @n.xbgr.xm52_u23.nsg13_hv_pmos[w]
print @n.xbgr.xm52_u23.nsg13_hv_pmos[l]
print @n.xbgr.xm52_u23.nsg13_hv_pmos[delvto]
print @n.xbgr.xm52_u23.nsg13_hv_pmos[factuo]
print @n.xbgr.xm52_u24.nsg13_hv_pmos[w]
print @n.xbgr.xm52_u24.nsg13_hv_pmos[l]
print @n.xbgr.xm52_u24.nsg13_hv_pmos[delvto]
print @n.xbgr.xm52_u24.nsg13_hv_pmos[factuo]
print @n.xbgr.xm54_u2.nsg13_hv_pmos[w]
print @n.xbgr.xm54_u2.nsg13_hv_pmos[l]
print @n.xbgr.xm54_u2.nsg13_hv_pmos[delvto]
print @n.xbgr.xm54_u2.nsg13_hv_pmos[factuo]
print @n.xbgr.xm54_u3.nsg13_hv_pmos[w]
print @n.xbgr.xm54_u3.nsg13_hv_pmos[l]
print @n.xbgr.xm54_u3.nsg13_hv_pmos[delvto]
print @n.xbgr.xm54_u3.nsg13_hv_pmos[factuo]
print @n.xbgr.xm54_u4.nsg13_hv_pmos[w]
print @n.xbgr.xm54_u4.nsg13_hv_pmos[l]
print @n.xbgr.xm54_u4.nsg13_hv_pmos[delvto]
print @n.xbgr.xm54_u4.nsg13_hv_pmos[factuo]
print @n.xbgr.xm54_u5.nsg13_hv_pmos[w]
print @n.xbgr.xm54_u5.nsg13_hv_pmos[l]
print @n.xbgr.xm54_u5.nsg13_hv_pmos[delvto]
print @n.xbgr.xm54_u5.nsg13_hv_pmos[factuo]
print @n.xbgr.xm54_u6.nsg13_hv_pmos[w]
print @n.xbgr.xm54_u6.nsg13_hv_pmos[l]
print @n.xbgr.xm54_u6.nsg13_hv_pmos[delvto]
print @n.xbgr.xm54_u6.nsg13_hv_pmos[factuo]
print @n.xbgr.xm54_u7.nsg13_hv_pmos[w]
print @n.xbgr.xm54_u7.nsg13_hv_pmos[l]
print @n.xbgr.xm54_u7.nsg13_hv_pmos[delvto]
print @n.xbgr.xm54_u7.nsg13_hv_pmos[factuo]
print @n.xbgr.xm54_u8.nsg13_hv_pmos[w]
print @n.xbgr.xm54_u8.nsg13_hv_pmos[l]
print @n.xbgr.xm54_u8.nsg13_hv_pmos[delvto]
print @n.xbgr.xm54_u8.nsg13_hv_pmos[factuo]
print @n.xbgr.xm54_u9.nsg13_hv_pmos[w]
print @n.xbgr.xm54_u9.nsg13_hv_pmos[l]
print @n.xbgr.xm54_u9.nsg13_hv_pmos[delvto]
print @n.xbgr.xm54_u9.nsg13_hv_pmos[factuo]
print @n.xbgr.xm54_u10.nsg13_hv_pmos[w]
print @n.xbgr.xm54_u10.nsg13_hv_pmos[l]
print @n.xbgr.xm54_u10.nsg13_hv_pmos[delvto]
print @n.xbgr.xm54_u10.nsg13_hv_pmos[factuo]
print @n.xbgr.xm54_u11.nsg13_hv_pmos[w]
print @n.xbgr.xm54_u11.nsg13_hv_pmos[l]
print @n.xbgr.xm54_u11.nsg13_hv_pmos[delvto]
print @n.xbgr.xm54_u11.nsg13_hv_pmos[factuo]
print @n.xbgr.xm54_u12.nsg13_hv_pmos[w]
print @n.xbgr.xm54_u12.nsg13_hv_pmos[l]
print @n.xbgr.xm54_u12.nsg13_hv_pmos[delvto]
print @n.xbgr.xm54_u12.nsg13_hv_pmos[factuo]
print @n.xbgr.xm54_u13.nsg13_hv_pmos[w]
print @n.xbgr.xm54_u13.nsg13_hv_pmos[l]
print @n.xbgr.xm54_u13.nsg13_hv_pmos[delvto]
print @n.xbgr.xm54_u13.nsg13_hv_pmos[factuo]
print @n.xbgr.xm54_u14.nsg13_hv_pmos[w]
print @n.xbgr.xm54_u14.nsg13_hv_pmos[l]
print @n.xbgr.xm54_u14.nsg13_hv_pmos[delvto]
print @n.xbgr.xm54_u14.nsg13_hv_pmos[factuo]
print @n.xbgr.xm54_u15.nsg13_hv_pmos[w]
print @n.xbgr.xm54_u15.nsg13_hv_pmos[l]
print @n.xbgr.xm54_u15.nsg13_hv_pmos[delvto]
print @n.xbgr.xm54_u15.nsg13_hv_pmos[factuo]
print @n.xbgr.xm54_u16.nsg13_hv_pmos[w]
print @n.xbgr.xm54_u16.nsg13_hv_pmos[l]
print @n.xbgr.xm54_u16.nsg13_hv_pmos[delvto]
print @n.xbgr.xm54_u16.nsg13_hv_pmos[factuo]
print @n.xbgr.xm54_u17.nsg13_hv_pmos[w]
print @n.xbgr.xm54_u17.nsg13_hv_pmos[l]
print @n.xbgr.xm54_u17.nsg13_hv_pmos[delvto]
print @n.xbgr.xm54_u17.nsg13_hv_pmos[factuo]
print @n.xbgr.xm54_u18.nsg13_hv_pmos[w]
print @n.xbgr.xm54_u18.nsg13_hv_pmos[l]
print @n.xbgr.xm54_u18.nsg13_hv_pmos[delvto]
print @n.xbgr.xm54_u18.nsg13_hv_pmos[factuo]
print @n.xbgr.xm54_u19.nsg13_hv_pmos[w]
print @n.xbgr.xm54_u19.nsg13_hv_pmos[l]
print @n.xbgr.xm54_u19.nsg13_hv_pmos[delvto]
print @n.xbgr.xm54_u19.nsg13_hv_pmos[factuo]
print @n.xbgr.xm54_u20.nsg13_hv_pmos[w]
print @n.xbgr.xm54_u20.nsg13_hv_pmos[l]
print @n.xbgr.xm54_u20.nsg13_hv_pmos[delvto]
print @n.xbgr.xm54_u20.nsg13_hv_pmos[factuo]
print @n.xbgr.xm54_u21.nsg13_hv_pmos[w]
print @n.xbgr.xm54_u21.nsg13_hv_pmos[l]
print @n.xbgr.xm54_u21.nsg13_hv_pmos[delvto]
print @n.xbgr.xm54_u21.nsg13_hv_pmos[factuo]
print @n.xbgr.xm54_u22.nsg13_hv_pmos[w]
print @n.xbgr.xm54_u22.nsg13_hv_pmos[l]
print @n.xbgr.xm54_u22.nsg13_hv_pmos[delvto]
print @n.xbgr.xm54_u22.nsg13_hv_pmos[factuo]
print @n.xbgr.xm54_u23.nsg13_hv_pmos[w]
print @n.xbgr.xm54_u23.nsg13_hv_pmos[l]
print @n.xbgr.xm54_u23.nsg13_hv_pmos[delvto]
print @n.xbgr.xm54_u23.nsg13_hv_pmos[factuo]
print @n.xbgr.xm54_u24.nsg13_hv_pmos[w]
print @n.xbgr.xm54_u24.nsg13_hv_pmos[l]
print @n.xbgr.xm54_u24.nsg13_hv_pmos[delvto]
print @n.xbgr.xm54_u24.nsg13_hv_pmos[factuo]
print @q.xbgr.xq56_u2.qnpn13g2[area]
print @q.xbgr.xq56_u3.qnpn13g2[area]
print @q.xbgr.xq56_u4.qnpn13g2[area]
print @q.xbgr.xq56_u5.qnpn13g2[area]
print @q.xbgr.xq56_u6.qnpn13g2[area]
print @q.xbgr.xq56_u7.qnpn13g2[area]
print @q.xbgr.xq56_u8.qnpn13g2[area]
print @q.xbgr.xq56_u9.qnpn13g2[area]
print @q.xbgr.xq56_u10.qnpn13g2[area]
print @q.xbgr.xq56_u11.qnpn13g2[area]
print @q.xbgr.xq56_u12.qnpn13g2[area]
print @q.xbgr.xq56_u13.qnpn13g2[area]
print @q.xbgr.xq56_u14.qnpn13g2[area]
print @q.xbgr.xq56_u15.qnpn13g2[area]
print @q.xbgr.xq56_u16.qnpn13g2[area]
print @q.xbgr.xq56_u17.qnpn13g2[area]
print @q.xbgr.xq56_u18.qnpn13g2[area]
print @q.xbgr.xq56_u19.qnpn13g2[area]
print @q.xbgr.xq56_u20.qnpn13g2[area]
print @q.xbgr.xq56_u21.qnpn13g2[area]
print @q.xbgr.xq56_u22.qnpn13g2[area]
print @q.xbgr.xq56_u23.qnpn13g2[area]
print @q.xbgr.xq56_u24.qnpn13g2[area]
print @q.xbgr.xq60_u2.qnpn13g2[area]
print @q.xbgr.xq60_u3.qnpn13g2[area]
print @q.xbgr.xq60_u4.qnpn13g2[area]
print @q.xbgr.xq62_u2.qnpn13g2[area]
print @q.xbgr.xq62_u3.qnpn13g2[area]
print @q.xbgr.xq62_u4.qnpn13g2[area]
print @q.xbgr.xq62_u5.qnpn13g2[area]
print @q.xbgr.xq62_u6.qnpn13g2[area]
print @q.xbgr.xq62_u7.qnpn13g2[area]
print @q.xbgr.xq62_u8.qnpn13g2[area]
print @q.xbgr.xq62_u9.qnpn13g2[area]
print @q.xbgr.xq62_u10.qnpn13g2[area]
print @q.xbgr.xq62_u11.qnpn13g2[area]
print @q.xbgr.xq62_u12.qnpn13g2[area]
print @q.xbgr.xq62_u13.qnpn13g2[area]
print @q.xbgr.xq62_u14.qnpn13g2[area]
print @q.xbgr.xq62_u15.qnpn13g2[area]
print @q.xbgr.xq62_u16.qnpn13g2[area]
print @q.xbgr.xq62_u17.qnpn13g2[area]
print @q.xbgr.xq62_u18.qnpn13g2[area]
print @q.xbgr.xq62_u19.qnpn13g2[area]
print @q.xbgr.xq62_u20.qnpn13g2[area]
print @q.xbgr.xq62_u21.qnpn13g2[area]
print @q.xbgr.xq62_u22.qnpn13g2[area]
print @q.xbgr.xq62_u23.qnpn13g2[area]
print @q.xbgr.xq62_u24.qnpn13g2[area]
print @q.xbgr.xq67_u2.qnpn13g2[area]
print @q.xbgr.xq67_u3.qnpn13g2[area]
print @q.xbgr.xq67_u4.qnpn13g2[area]
print @q.xbgr.xq67_u5.qnpn13g2[area]
print @q.xbgr.xq67_u6.qnpn13g2[area]
print @q.xbgr.xq67_u7.qnpn13g2[area]
print @q.xbgr.xq67_u8.qnpn13g2[area]
print @q.xbgr.xq67_u9.qnpn13g2[area]
print @q.xbgr.xq67_u10.qnpn13g2[area]
print @q.xbgr.xq67_u11.qnpn13g2[area]
print @q.xbgr.xq67_u12.qnpn13g2[area]
print @q.xbgr.xq67_u13.qnpn13g2[area]
print @q.xbgr.xq67_u14.qnpn13g2[area]
print @q.xbgr.xq67_u15.qnpn13g2[area]
print @q.xbgr.xq67_u16.qnpn13g2[area]
print @q.xbgr.xq67_u17.qnpn13g2[area]
print @q.xbgr.xq67_u18.qnpn13g2[area]
print @q.xbgr.xq67_u19.qnpn13g2[area]
print @q.xbgr.xq67_u20.qnpn13g2[area]
print @q.xbgr.xq67_u21.qnpn13g2[area]
print @q.xbgr.xq67_u22.qnpn13g2[area]
print @q.xbgr.xq67_u23.qnpn13g2[area]
print @q.xbgr.xq67_u24.qnpn13g2[area]
print @q.xbgr.xq68_u2.qnpn13g2[area]
print @q.xbgr.xq68_u3.qnpn13g2[area]
print @q.xbgr.xq68_u4.qnpn13g2[area]
print @q.xbgr.xq68_u5.qnpn13g2[area]
print @q.xbgr.xq68_u6.qnpn13g2[area]
print @q.xbgr.xq68_u7.qnpn13g2[area]
print @q.xbgr.xq68_u8.qnpn13g2[area]
print @q.xbgr.xq68_u9.qnpn13g2[area]
print @q.xbgr.xq68_u10.qnpn13g2[area]
print @q.xbgr.xq68_u11.qnpn13g2[area]
print @q.xbgr.xq68_u12.qnpn13g2[area]
print @q.xbgr.xq68_u13.qnpn13g2[area]
print @q.xbgr.xq68_u14.qnpn13g2[area]
print @q.xbgr.xq68_u15.qnpn13g2[area]
print @q.xbgr.xq68_u16.qnpn13g2[area]
print @q.xbgr.xq68_u17.qnpn13g2[area]
print @q.xbgr.xq68_u18.qnpn13g2[area]
print @q.xbgr.xq68_u19.qnpn13g2[area]
print @q.xbgr.xq68_u20.qnpn13g2[area]
print @q.xbgr.xq68_u21.qnpn13g2[area]
print @q.xbgr.xq68_u22.qnpn13g2[area]
print @q.xbgr.xq68_u23.qnpn13g2[area]
print @q.xbgr.xq68_u24.qnpn13g2[area]
print @q.xbgr.xq69_u2.qnpn13g2[area]
print @q.xbgr.xq69_u3.qnpn13g2[area]
print @q.xbgr.xq69_u4.qnpn13g2[area]
print @q.xbgr.xq69_u5.qnpn13g2[area]
print @q.xbgr.xq69_u6.qnpn13g2[area]
print @q.xbgr.xq69_u7.qnpn13g2[area]
print @q.xbgr.xq69_u8.qnpn13g2[area]
print @q.xbgr.xq69_u9.qnpn13g2[area]
print @q.xbgr.xq69_u10.qnpn13g2[area]
print @q.xbgr.xq69_u11.qnpn13g2[area]
print @q.xbgr.xq69_u12.qnpn13g2[area]
print @q.xbgr.xq69_u13.qnpn13g2[area]
print @q.xbgr.xq69_u14.qnpn13g2[area]
print @q.xbgr.xq69_u15.qnpn13g2[area]
print @q.xbgr.xq69_u16.qnpn13g2[area]
print @q.xbgr.xq69_u17.qnpn13g2[area]
print @q.xbgr.xq69_u18.qnpn13g2[area]
print @q.xbgr.xq69_u19.qnpn13g2[area]
print @q.xbgr.xq69_u20.qnpn13g2[area]
print @q.xbgr.xq69_u21.qnpn13g2[area]
print @q.xbgr.xq69_u22.qnpn13g2[area]
print @q.xbgr.xq69_u23.qnpn13g2[area]
print @q.xbgr.xq69_u24.qnpn13g2[area]
print @q.xbgr.xq70_u2.qnpn13g2[area]
print @q.xbgr.xq70_u3.qnpn13g2[area]
print @q.xbgr.xq70_u4.qnpn13g2[area]
print @q.xbgr.xq70_u5.qnpn13g2[area]
print @q.xbgr.xq70_u6.qnpn13g2[area]
print @q.xbgr.xq70_u7.qnpn13g2[area]
print @q.xbgr.xq70_u8.qnpn13g2[area]
print @q.xbgr.xq70_u9.qnpn13g2[area]
print @q.xbgr.xq70_u10.qnpn13g2[area]
print @q.xbgr.xq70_u11.qnpn13g2[area]
print @q.xbgr.xq70_u12.qnpn13g2[area]
print @q.xbgr.xq70_u13.qnpn13g2[area]
print @q.xbgr.xq70_u14.qnpn13g2[area]
print @q.xbgr.xq70_u15.qnpn13g2[area]
print @q.xbgr.xq70_u16.qnpn13g2[area]
print @q.xbgr.xq70_u17.qnpn13g2[area]
print @q.xbgr.xq70_u18.qnpn13g2[area]
print @q.xbgr.xq70_u19.qnpn13g2[area]
print @q.xbgr.xq70_u20.qnpn13g2[area]
print @q.xbgr.xq70_u21.qnpn13g2[area]
print @q.xbgr.xq70_u22.qnpn13g2[area]
print @q.xbgr.xq70_u23.qnpn13g2[area]
print @q.xbgr.xq70_u24.qnpn13g2[area]
print @q.xbgr.xq71_u2.qnpn13g2[area]
print @q.xbgr.xq71_u3.qnpn13g2[area]
print @q.xbgr.xq71_u4.qnpn13g2[area]
print @q.xbgr.xq71_u5.qnpn13g2[area]
print @q.xbgr.xq71_u6.qnpn13g2[area]
print @q.xbgr.xq71_u7.qnpn13g2[area]
print @q.xbgr.xq71_u8.qnpn13g2[area]
print @q.xbgr.xq71_u9.qnpn13g2[area]
print @q.xbgr.xq71_u10.qnpn13g2[area]
print @q.xbgr.xq71_u11.qnpn13g2[area]
print @q.xbgr.xq71_u12.qnpn13g2[area]
print @q.xbgr.xq71_u13.qnpn13g2[area]
print @q.xbgr.xq71_u14.qnpn13g2[area]
print @q.xbgr.xq71_u15.qnpn13g2[area]
print @q.xbgr.xq71_u16.qnpn13g2[area]
print @q.xbgr.xq71_u17.qnpn13g2[area]
print @q.xbgr.xq71_u18.qnpn13g2[area]
print @q.xbgr.xq71_u19.qnpn13g2[area]
print @q.xbgr.xq71_u20.qnpn13g2[area]
print @q.xbgr.xq71_u21.qnpn13g2[area]
print @q.xbgr.xq71_u22.qnpn13g2[area]
print @q.xbgr.xq71_u23.qnpn13g2[area]
print @q.xbgr.xq71_u24.qnpn13g2[area]
print @q.xbgr.xq72_u2.qnpn13g2[area]
print @q.xbgr.xq72_u3.qnpn13g2[area]
print @q.xbgr.xq72_u4.qnpn13g2[area]
print @q.xbgr.xq72_u5.qnpn13g2[area]
print @q.xbgr.xq72_u6.qnpn13g2[area]
print @q.xbgr.xq72_u7.qnpn13g2[area]
print @q.xbgr.xq72_u8.qnpn13g2[area]
print @q.xbgr.xq72_u9.qnpn13g2[area]
print @q.xbgr.xq72_u10.qnpn13g2[area]
print @q.xbgr.xq72_u11.qnpn13g2[area]
print @q.xbgr.xq72_u12.qnpn13g2[area]
print @q.xbgr.xq72_u13.qnpn13g2[area]
print @q.xbgr.xq72_u14.qnpn13g2[area]
print @q.xbgr.xq72_u15.qnpn13g2[area]
print @q.xbgr.xq72_u16.qnpn13g2[area]
print @q.xbgr.xq72_u17.qnpn13g2[area]
print @q.xbgr.xq72_u18.qnpn13g2[area]
print @q.xbgr.xq72_u19.qnpn13g2[area]
print @q.xbgr.xq72_u20.qnpn13g2[area]
print @q.xbgr.xq72_u21.qnpn13g2[area]
print @q.xbgr.xq72_u22.qnpn13g2[area]
print @q.xbgr.xq72_u23.qnpn13g2[area]
print @q.xbgr.xq72_u24.qnpn13g2[area]
print @q.xbgr.xq73_u2.qnpn13g2[area]
print @q.xbgr.xq73_u3.qnpn13g2[area]
print @q.xbgr.xq73_u4.qnpn13g2[area]
print @q.xbgr.xq73_u5.qnpn13g2[area]
print @q.xbgr.xq73_u6.qnpn13g2[area]
print @q.xbgr.xq73_u7.qnpn13g2[area]
print @q.xbgr.xq73_u8.qnpn13g2[area]
print @q.xbgr.xq73_u9.qnpn13g2[area]
print @q.xbgr.xq73_u10.qnpn13g2[area]
print @q.xbgr.xq73_u11.qnpn13g2[area]
print @q.xbgr.xq73_u12.qnpn13g2[area]
print @q.xbgr.xq73_u13.qnpn13g2[area]
print @q.xbgr.xq73_u14.qnpn13g2[area]
print @q.xbgr.xq73_u15.qnpn13g2[area]
print @q.xbgr.xq73_u16.qnpn13g2[area]
print @q.xbgr.xq73_u17.qnpn13g2[area]
print @q.xbgr.xq73_u18.qnpn13g2[area]
print @q.xbgr.xq73_u19.qnpn13g2[area]
print @q.xbgr.xq73_u20.qnpn13g2[area]
print @q.xbgr.xq73_u21.qnpn13g2[area]
print @q.xbgr.xq73_u22.qnpn13g2[area]
print @q.xbgr.xq73_u23.qnpn13g2[area]
print @q.xbgr.xq73_u24.qnpn13g2[area]
print @q.xbgr.xq74_u2.qnpn13g2[area]
print @q.xbgr.xq74_u3.qnpn13g2[area]
print @q.xbgr.xq74_u4.qnpn13g2[area]
print @q.xbgr.xq74_u5.qnpn13g2[area]
print @q.xbgr.xq74_u6.qnpn13g2[area]
print @q.xbgr.xq74_u7.qnpn13g2[area]
print @q.xbgr.xq74_u8.qnpn13g2[area]
print @q.xbgr.xq74_u9.qnpn13g2[area]
print @q.xbgr.xq74_u10.qnpn13g2[area]
print @q.xbgr.xq74_u11.qnpn13g2[area]
print @q.xbgr.xq74_u12.qnpn13g2[area]
print @q.xbgr.xq74_u13.qnpn13g2[area]
print @q.xbgr.xq74_u14.qnpn13g2[area]
print @q.xbgr.xq74_u15.qnpn13g2[area]
print @q.xbgr.xq74_u16.qnpn13g2[area]
print @q.xbgr.xq74_u17.qnpn13g2[area]
print @q.xbgr.xq74_u18.qnpn13g2[area]
print @q.xbgr.xq74_u19.qnpn13g2[area]
print @q.xbgr.xq74_u20.qnpn13g2[area]
print @q.xbgr.xq74_u21.qnpn13g2[area]
print @q.xbgr.xq74_u22.qnpn13g2[area]
print @q.xbgr.xq74_u23.qnpn13g2[area]
print @q.xbgr.xq74_u24.qnpn13g2[area]
print @q.xbgr.xq75_u2.qnpn13g2[area]
print @q.xbgr.xq75_u3.qnpn13g2[area]
print @q.xbgr.xq75_u4.qnpn13g2[area]
print @q.xbgr.xq75_u5.qnpn13g2[area]
print @q.xbgr.xq75_u6.qnpn13g2[area]
print @q.xbgr.xq75_u7.qnpn13g2[area]
print @q.xbgr.xq75_u8.qnpn13g2[area]
print @q.xbgr.xq75_u9.qnpn13g2[area]
print @q.xbgr.xq75_u10.qnpn13g2[area]
print @q.xbgr.xq75_u11.qnpn13g2[area]
print @q.xbgr.xq75_u12.qnpn13g2[area]
print @q.xbgr.xq75_u13.qnpn13g2[area]
print @q.xbgr.xq75_u14.qnpn13g2[area]
print @q.xbgr.xq75_u15.qnpn13g2[area]
print @q.xbgr.xq75_u16.qnpn13g2[area]
print @q.xbgr.xq75_u17.qnpn13g2[area]
print @q.xbgr.xq75_u18.qnpn13g2[area]
print @q.xbgr.xq75_u19.qnpn13g2[area]
print @q.xbgr.xq75_u20.qnpn13g2[area]
print @q.xbgr.xq75_u21.qnpn13g2[area]
print @q.xbgr.xq75_u22.qnpn13g2[area]
print @q.xbgr.xq75_u23.qnpn13g2[area]
print @q.xbgr.xq75_u24.qnpn13g2[area]
print @q.xbgr.xq76_u2.qnpn13g2[area]
print @q.xbgr.xq76_u3.qnpn13g2[area]
print @q.xbgr.xq76_u4.qnpn13g2[area]
print @q.xbgr.xq76_u5.qnpn13g2[area]
print @q.xbgr.xq76_u6.qnpn13g2[area]
print @q.xbgr.xq76_u7.qnpn13g2[area]
print @q.xbgr.xq76_u8.qnpn13g2[area]
print @q.xbgr.xq76_u9.qnpn13g2[area]
print @q.xbgr.xq76_u10.qnpn13g2[area]
print @q.xbgr.xq76_u11.qnpn13g2[area]
print @q.xbgr.xq76_u12.qnpn13g2[area]
print @q.xbgr.xq76_u13.qnpn13g2[area]
print @q.xbgr.xq76_u14.qnpn13g2[area]
print @q.xbgr.xq76_u15.qnpn13g2[area]
print @q.xbgr.xq76_u16.qnpn13g2[area]
print @q.xbgr.xq76_u17.qnpn13g2[area]
print @q.xbgr.xq76_u18.qnpn13g2[area]
print @q.xbgr.xq76_u19.qnpn13g2[area]
print @q.xbgr.xq76_u20.qnpn13g2[area]
print @q.xbgr.xq76_u21.qnpn13g2[area]
print @q.xbgr.xq76_u22.qnpn13g2[area]
print @q.xbgr.xq76_u23.qnpn13g2[area]
print @q.xbgr.xq76_u24.qnpn13g2[area]
print @n.xbgr.xr77_u2.nr1[nsmm_rsh]
print @n.xbgr.xr77_u2.nr1[nsmm_w]
print @n.xbgr.xr77_u2.nr1[nsmm_l]
print @n.xbgr.xr77_u3.nr1[nsmm_rsh]
print @n.xbgr.xr77_u3.nr1[nsmm_w]
print @n.xbgr.xr77_u3.nr1[nsmm_l]
print @n.xbgr.xr77_u4.nr1[nsmm_rsh]
print @n.xbgr.xr77_u4.nr1[nsmm_w]
print @n.xbgr.xr77_u4.nr1[nsmm_l]
print @n.xbgr.xr77_u5.nr1[nsmm_rsh]
print @n.xbgr.xr77_u5.nr1[nsmm_w]
print @n.xbgr.xr77_u5.nr1[nsmm_l]
print @n.xbgr.xr77_u6.nr1[nsmm_rsh]
print @n.xbgr.xr77_u6.nr1[nsmm_w]
print @n.xbgr.xr77_u6.nr1[nsmm_l]
print @n.xbgr.xr77_u7.nr1[nsmm_rsh]
print @n.xbgr.xr77_u7.nr1[nsmm_w]
print @n.xbgr.xr77_u7.nr1[nsmm_l]
print @n.xbgr.xr77_u8.nr1[nsmm_rsh]
print @n.xbgr.xr77_u8.nr1[nsmm_w]
print @n.xbgr.xr77_u8.nr1[nsmm_l]
print @n.xbgr.xr77_u9.nr1[nsmm_rsh]
print @n.xbgr.xr77_u9.nr1[nsmm_w]
print @n.xbgr.xr77_u9.nr1[nsmm_l]
print @n.xbgr.xr77_u10.nr1[nsmm_rsh]
print @n.xbgr.xr77_u10.nr1[nsmm_w]
print @n.xbgr.xr77_u10.nr1[nsmm_l]
print @n.xbgr.xr77_u11.nr1[nsmm_rsh]
print @n.xbgr.xr77_u11.nr1[nsmm_w]
print @n.xbgr.xr77_u11.nr1[nsmm_l]
print @n.xbgr.xr77_u12.nr1[nsmm_rsh]
print @n.xbgr.xr77_u12.nr1[nsmm_w]
print @n.xbgr.xr77_u12.nr1[nsmm_l]
print @n.xbgr.xr77_u13.nr1[nsmm_rsh]
print @n.xbgr.xr77_u13.nr1[nsmm_w]
print @n.xbgr.xr77_u13.nr1[nsmm_l]
print @n.xbgr.xr77_u14.nr1[nsmm_rsh]
print @n.xbgr.xr77_u14.nr1[nsmm_w]
print @n.xbgr.xr77_u14.nr1[nsmm_l]
print @n.xbgr.xr77_u15.nr1[nsmm_rsh]
print @n.xbgr.xr77_u15.nr1[nsmm_w]
print @n.xbgr.xr77_u15.nr1[nsmm_l]
print @n.xbgr.xr77_u16.nr1[nsmm_rsh]
print @n.xbgr.xr77_u16.nr1[nsmm_w]
print @n.xbgr.xr77_u16.nr1[nsmm_l]
print @n.xbgr.xr77_u17.nr1[nsmm_rsh]
print @n.xbgr.xr77_u17.nr1[nsmm_w]
print @n.xbgr.xr77_u17.nr1[nsmm_l]
print @n.xbgr.xr77_u18.nr1[nsmm_rsh]
print @n.xbgr.xr77_u18.nr1[nsmm_w]
print @n.xbgr.xr77_u18.nr1[nsmm_l]
print @n.xbgr.xr77_u19.nr1[nsmm_rsh]
print @n.xbgr.xr77_u19.nr1[nsmm_w]
print @n.xbgr.xr77_u19.nr1[nsmm_l]
print @n.xbgr.xr77_u20.nr1[nsmm_rsh]
print @n.xbgr.xr77_u20.nr1[nsmm_w]
print @n.xbgr.xr77_u20.nr1[nsmm_l]
print @n.xbgr.xr77_u21.nr1[nsmm_rsh]
print @n.xbgr.xr77_u21.nr1[nsmm_w]
print @n.xbgr.xr77_u21.nr1[nsmm_l]
print @n.xbgr.xr77_u22.nr1[nsmm_rsh]
print @n.xbgr.xr77_u22.nr1[nsmm_w]
print @n.xbgr.xr77_u22.nr1[nsmm_l]
print @n.xbgr.xr77_u23.nr1[nsmm_rsh]
print @n.xbgr.xr77_u23.nr1[nsmm_w]
print @n.xbgr.xr77_u23.nr1[nsmm_l]
print @n.xbgr.xr77_u24.nr1[nsmm_rsh]
print @n.xbgr.xr77_u24.nr1[nsmm_w]
print @n.xbgr.xr77_u24.nr1[nsmm_l]
print @n.xbgr.xr78_u2.nr1[nsmm_rsh]
print @n.xbgr.xr78_u2.nr1[nsmm_w]
print @n.xbgr.xr78_u2.nr1[nsmm_l]
print @n.xbgr.xr78_u3.nr1[nsmm_rsh]
print @n.xbgr.xr78_u3.nr1[nsmm_w]
print @n.xbgr.xr78_u3.nr1[nsmm_l]
print @n.xbgr.xr78_u4.nr1[nsmm_rsh]
print @n.xbgr.xr78_u4.nr1[nsmm_w]
print @n.xbgr.xr78_u4.nr1[nsmm_l]
print @n.xbgr.xr78_u5.nr1[nsmm_rsh]
print @n.xbgr.xr78_u5.nr1[nsmm_w]
print @n.xbgr.xr78_u5.nr1[nsmm_l]
print @n.xbgr.xr78_u6.nr1[nsmm_rsh]
print @n.xbgr.xr78_u6.nr1[nsmm_w]
print @n.xbgr.xr78_u6.nr1[nsmm_l]
print @n.xbgr.xr78_u7.nr1[nsmm_rsh]
print @n.xbgr.xr78_u7.nr1[nsmm_w]
print @n.xbgr.xr78_u7.nr1[nsmm_l]
print @n.xbgr.xr78_u8.nr1[nsmm_rsh]
print @n.xbgr.xr78_u8.nr1[nsmm_w]
print @n.xbgr.xr78_u8.nr1[nsmm_l]
print @n.xbgr.xr78_u9.nr1[nsmm_rsh]
print @n.xbgr.xr78_u9.nr1[nsmm_w]
print @n.xbgr.xr78_u9.nr1[nsmm_l]
print @n.xbgr.xr78_u10.nr1[nsmm_rsh]
print @n.xbgr.xr78_u10.nr1[nsmm_w]
print @n.xbgr.xr78_u10.nr1[nsmm_l]
print @n.xbgr.xr78_u11.nr1[nsmm_rsh]
print @n.xbgr.xr78_u11.nr1[nsmm_w]
print @n.xbgr.xr78_u11.nr1[nsmm_l]
print @n.xbgr.xr78_u12.nr1[nsmm_rsh]
print @n.xbgr.xr78_u12.nr1[nsmm_w]
print @n.xbgr.xr78_u12.nr1[nsmm_l]
print @n.xbgr.xr78_u13.nr1[nsmm_rsh]
print @n.xbgr.xr78_u13.nr1[nsmm_w]
print @n.xbgr.xr78_u13.nr1[nsmm_l]
print @n.xbgr.xr78_u14.nr1[nsmm_rsh]
print @n.xbgr.xr78_u14.nr1[nsmm_w]
print @n.xbgr.xr78_u14.nr1[nsmm_l]
print @n.xbgr.xr78_u15.nr1[nsmm_rsh]
print @n.xbgr.xr78_u15.nr1[nsmm_w]
print @n.xbgr.xr78_u15.nr1[nsmm_l]
print @n.xbgr.xr78_u16.nr1[nsmm_rsh]
print @n.xbgr.xr78_u16.nr1[nsmm_w]
print @n.xbgr.xr78_u16.nr1[nsmm_l]
print @n.xbgr.xr78_u17.nr1[nsmm_rsh]
print @n.xbgr.xr78_u17.nr1[nsmm_w]
print @n.xbgr.xr78_u17.nr1[nsmm_l]
print @n.xbgr.xr78_u18.nr1[nsmm_rsh]
print @n.xbgr.xr78_u18.nr1[nsmm_w]
print @n.xbgr.xr78_u18.nr1[nsmm_l]
print @n.xbgr.xr78_u19.nr1[nsmm_rsh]
print @n.xbgr.xr78_u19.nr1[nsmm_w]
print @n.xbgr.xr78_u19.nr1[nsmm_l]
print @n.xbgr.xr78_u20.nr1[nsmm_rsh]
print @n.xbgr.xr78_u20.nr1[nsmm_w]
print @n.xbgr.xr78_u20.nr1[nsmm_l]
print @n.xbgr.xr78_u21.nr1[nsmm_rsh]
print @n.xbgr.xr78_u21.nr1[nsmm_w]
print @n.xbgr.xr78_u21.nr1[nsmm_l]
print @n.xbgr.xr78_u22.nr1[nsmm_rsh]
print @n.xbgr.xr78_u22.nr1[nsmm_w]
print @n.xbgr.xr78_u22.nr1[nsmm_l]
print @n.xbgr.xr78_u23.nr1[nsmm_rsh]
print @n.xbgr.xr78_u23.nr1[nsmm_w]
print @n.xbgr.xr78_u23.nr1[nsmm_l]
print @n.xbgr.xr78_u24.nr1[nsmm_rsh]
print @n.xbgr.xr78_u24.nr1[nsmm_w]
print @n.xbgr.xr78_u24.nr1[nsmm_l]
print @n.xbgr.xr79_u2.nr1[nsmm_rsh]
print @n.xbgr.xr79_u2.nr1[nsmm_w]
print @n.xbgr.xr79_u2.nr1[nsmm_l]
print @n.xbgr.xr79_u3.nr1[nsmm_rsh]
print @n.xbgr.xr79_u3.nr1[nsmm_w]
print @n.xbgr.xr79_u3.nr1[nsmm_l]
print @n.xbgr.xr79_u4.nr1[nsmm_rsh]
print @n.xbgr.xr79_u4.nr1[nsmm_w]
print @n.xbgr.xr79_u4.nr1[nsmm_l]
print @n.xbgr.xr79_u5.nr1[nsmm_rsh]
print @n.xbgr.xr79_u5.nr1[nsmm_w]
print @n.xbgr.xr79_u5.nr1[nsmm_l]
print @n.xbgr.xr79_u6.nr1[nsmm_rsh]
print @n.xbgr.xr79_u6.nr1[nsmm_w]
print @n.xbgr.xr79_u6.nr1[nsmm_l]
print @n.xbgr.xr79_u7.nr1[nsmm_rsh]
print @n.xbgr.xr79_u7.nr1[nsmm_w]
print @n.xbgr.xr79_u7.nr1[nsmm_l]
print @n.xbgr.xr79_u8.nr1[nsmm_rsh]
print @n.xbgr.xr79_u8.nr1[nsmm_w]
print @n.xbgr.xr79_u8.nr1[nsmm_l]
print @n.xbgr.xr79_u9.nr1[nsmm_rsh]
print @n.xbgr.xr79_u9.nr1[nsmm_w]
print @n.xbgr.xr79_u9.nr1[nsmm_l]
print @n.xbgr.xr79_u10.nr1[nsmm_rsh]
print @n.xbgr.xr79_u10.nr1[nsmm_w]
print @n.xbgr.xr79_u10.nr1[nsmm_l]
print @n.xbgr.xr79_u11.nr1[nsmm_rsh]
print @n.xbgr.xr79_u11.nr1[nsmm_w]
print @n.xbgr.xr79_u11.nr1[nsmm_l]
print @n.xbgr.xr79_u12.nr1[nsmm_rsh]
print @n.xbgr.xr79_u12.nr1[nsmm_w]
print @n.xbgr.xr79_u12.nr1[nsmm_l]
print @n.xbgr.xr79_u13.nr1[nsmm_rsh]
print @n.xbgr.xr79_u13.nr1[nsmm_w]
print @n.xbgr.xr79_u13.nr1[nsmm_l]
print @n.xbgr.xr79_u14.nr1[nsmm_rsh]
print @n.xbgr.xr79_u14.nr1[nsmm_w]
print @n.xbgr.xr79_u14.nr1[nsmm_l]
print @n.xbgr.xr79_u15.nr1[nsmm_rsh]
print @n.xbgr.xr79_u15.nr1[nsmm_w]
print @n.xbgr.xr79_u15.nr1[nsmm_l]
print @n.xbgr.xr79_u16.nr1[nsmm_rsh]
print @n.xbgr.xr79_u16.nr1[nsmm_w]
print @n.xbgr.xr79_u16.nr1[nsmm_l]
print @n.xbgr.xr79_u17.nr1[nsmm_rsh]
print @n.xbgr.xr79_u17.nr1[nsmm_w]
print @n.xbgr.xr79_u17.nr1[nsmm_l]
print @n.xbgr.xr79_u18.nr1[nsmm_rsh]
print @n.xbgr.xr79_u18.nr1[nsmm_w]
print @n.xbgr.xr79_u18.nr1[nsmm_l]
print @n.xbgr.xr79_u19.nr1[nsmm_rsh]
print @n.xbgr.xr79_u19.nr1[nsmm_w]
print @n.xbgr.xr79_u19.nr1[nsmm_l]
print @n.xbgr.xr79_u20.nr1[nsmm_rsh]
print @n.xbgr.xr79_u20.nr1[nsmm_w]
print @n.xbgr.xr79_u20.nr1[nsmm_l]
print @n.xbgr.xr79_u21.nr1[nsmm_rsh]
print @n.xbgr.xr79_u21.nr1[nsmm_w]
print @n.xbgr.xr79_u21.nr1[nsmm_l]
print @n.xbgr.xr79_u22.nr1[nsmm_rsh]
print @n.xbgr.xr79_u22.nr1[nsmm_w]
print @n.xbgr.xr79_u22.nr1[nsmm_l]
print @n.xbgr.xr79_u23.nr1[nsmm_rsh]
print @n.xbgr.xr79_u23.nr1[nsmm_w]
print @n.xbgr.xr79_u23.nr1[nsmm_l]
print @n.xbgr.xr79_u24.nr1[nsmm_rsh]
print @n.xbgr.xr79_u24.nr1[nsmm_w]
print @n.xbgr.xr79_u24.nr1[nsmm_l]
print @n.xbgr.xr80_u2.nr1[nsmm_rsh]
print @n.xbgr.xr80_u2.nr1[nsmm_w]
print @n.xbgr.xr80_u2.nr1[nsmm_l]
print @n.xbgr.xr80_u3.nr1[nsmm_rsh]
print @n.xbgr.xr80_u3.nr1[nsmm_w]
print @n.xbgr.xr80_u3.nr1[nsmm_l]
print @n.xbgr.xr80_u4.nr1[nsmm_rsh]
print @n.xbgr.xr80_u4.nr1[nsmm_w]
print @n.xbgr.xr80_u4.nr1[nsmm_l]
print @n.xbgr.xr80_u5.nr1[nsmm_rsh]
print @n.xbgr.xr80_u5.nr1[nsmm_w]
print @n.xbgr.xr80_u5.nr1[nsmm_l]
print @n.xbgr.xr80_u6.nr1[nsmm_rsh]
print @n.xbgr.xr80_u6.nr1[nsmm_w]
print @n.xbgr.xr80_u6.nr1[nsmm_l]
print @n.xbgr.xr80_u7.nr1[nsmm_rsh]
print @n.xbgr.xr80_u7.nr1[nsmm_w]
print @n.xbgr.xr80_u7.nr1[nsmm_l]
print @n.xbgr.xr80_u8.nr1[nsmm_rsh]
print @n.xbgr.xr80_u8.nr1[nsmm_w]
print @n.xbgr.xr80_u8.nr1[nsmm_l]
print @n.xbgr.xr80_u9.nr1[nsmm_rsh]
print @n.xbgr.xr80_u9.nr1[nsmm_w]
print @n.xbgr.xr80_u9.nr1[nsmm_l]
print @n.xbgr.xr80_u10.nr1[nsmm_rsh]
print @n.xbgr.xr80_u10.nr1[nsmm_w]
print @n.xbgr.xr80_u10.nr1[nsmm_l]
print @n.xbgr.xr80_u11.nr1[nsmm_rsh]
print @n.xbgr.xr80_u11.nr1[nsmm_w]
print @n.xbgr.xr80_u11.nr1[nsmm_l]
print @n.xbgr.xr80_u12.nr1[nsmm_rsh]
print @n.xbgr.xr80_u12.nr1[nsmm_w]
print @n.xbgr.xr80_u12.nr1[nsmm_l]
print @n.xbgr.xr80_u13.nr1[nsmm_rsh]
print @n.xbgr.xr80_u13.nr1[nsmm_w]
print @n.xbgr.xr80_u13.nr1[nsmm_l]
print @n.xbgr.xr80_u14.nr1[nsmm_rsh]
print @n.xbgr.xr80_u14.nr1[nsmm_w]
print @n.xbgr.xr80_u14.nr1[nsmm_l]
print @n.xbgr.xr80_u15.nr1[nsmm_rsh]
print @n.xbgr.xr80_u15.nr1[nsmm_w]
print @n.xbgr.xr80_u15.nr1[nsmm_l]
print @n.xbgr.xr80_u16.nr1[nsmm_rsh]
print @n.xbgr.xr80_u16.nr1[nsmm_w]
print @n.xbgr.xr80_u16.nr1[nsmm_l]
print @n.xbgr.xr80_u17.nr1[nsmm_rsh]
print @n.xbgr.xr80_u17.nr1[nsmm_w]
print @n.xbgr.xr80_u17.nr1[nsmm_l]
print @n.xbgr.xr80_u18.nr1[nsmm_rsh]
print @n.xbgr.xr80_u18.nr1[nsmm_w]
print @n.xbgr.xr80_u18.nr1[nsmm_l]
print @n.xbgr.xr80_u19.nr1[nsmm_rsh]
print @n.xbgr.xr80_u19.nr1[nsmm_w]
print @n.xbgr.xr80_u19.nr1[nsmm_l]
print @n.xbgr.xr80_u20.nr1[nsmm_rsh]
print @n.xbgr.xr80_u20.nr1[nsmm_w]
print @n.xbgr.xr80_u20.nr1[nsmm_l]
print @n.xbgr.xr80_u21.nr1[nsmm_rsh]
print @n.xbgr.xr80_u21.nr1[nsmm_w]
print @n.xbgr.xr80_u21.nr1[nsmm_l]
print @n.xbgr.xr80_u22.nr1[nsmm_rsh]
print @n.xbgr.xr80_u22.nr1[nsmm_w]
print @n.xbgr.xr80_u22.nr1[nsmm_l]
print @n.xbgr.xr80_u23.nr1[nsmm_rsh]
print @n.xbgr.xr80_u23.nr1[nsmm_w]
print @n.xbgr.xr80_u23.nr1[nsmm_l]
print @n.xbgr.xr80_u24.nr1[nsmm_rsh]
print @n.xbgr.xr80_u24.nr1[nsmm_w]
print @n.xbgr.xr80_u24.nr1[nsmm_l]
print @n.xbgr.xr81_u2.nr1[nsmm_rsh]
print @n.xbgr.xr81_u2.nr1[nsmm_w]
print @n.xbgr.xr81_u2.nr1[nsmm_l]
print @n.xbgr.xr81_u3.nr1[nsmm_rsh]
print @n.xbgr.xr81_u3.nr1[nsmm_w]
print @n.xbgr.xr81_u3.nr1[nsmm_l]
print @n.xbgr.xr81_u4.nr1[nsmm_rsh]
print @n.xbgr.xr81_u4.nr1[nsmm_w]
print @n.xbgr.xr81_u4.nr1[nsmm_l]
print @n.xbgr.xr81_u5.nr1[nsmm_rsh]
print @n.xbgr.xr81_u5.nr1[nsmm_w]
print @n.xbgr.xr81_u5.nr1[nsmm_l]
print @n.xbgr.xr81_u6.nr1[nsmm_rsh]
print @n.xbgr.xr81_u6.nr1[nsmm_w]
print @n.xbgr.xr81_u6.nr1[nsmm_l]
print @n.xbgr.xr81_u7.nr1[nsmm_rsh]
print @n.xbgr.xr81_u7.nr1[nsmm_w]
print @n.xbgr.xr81_u7.nr1[nsmm_l]
print @n.xbgr.xr81_u8.nr1[nsmm_rsh]
print @n.xbgr.xr81_u8.nr1[nsmm_w]
print @n.xbgr.xr81_u8.nr1[nsmm_l]
print @n.xbgr.xr81_u9.nr1[nsmm_rsh]
print @n.xbgr.xr81_u9.nr1[nsmm_w]
print @n.xbgr.xr81_u9.nr1[nsmm_l]
print @n.xbgr.xr81_u10.nr1[nsmm_rsh]
print @n.xbgr.xr81_u10.nr1[nsmm_w]
print @n.xbgr.xr81_u10.nr1[nsmm_l]
print @n.xbgr.xr81_u11.nr1[nsmm_rsh]
print @n.xbgr.xr81_u11.nr1[nsmm_w]
print @n.xbgr.xr81_u11.nr1[nsmm_l]
print @n.xbgr.xr81_u12.nr1[nsmm_rsh]
print @n.xbgr.xr81_u12.nr1[nsmm_w]
print @n.xbgr.xr81_u12.nr1[nsmm_l]
print @n.xbgr.xr81_u13.nr1[nsmm_rsh]
print @n.xbgr.xr81_u13.nr1[nsmm_w]
print @n.xbgr.xr81_u13.nr1[nsmm_l]
print @n.xbgr.xr81_u14.nr1[nsmm_rsh]
print @n.xbgr.xr81_u14.nr1[nsmm_w]
print @n.xbgr.xr81_u14.nr1[nsmm_l]
print @n.xbgr.xr81_u15.nr1[nsmm_rsh]
print @n.xbgr.xr81_u15.nr1[nsmm_w]
print @n.xbgr.xr81_u15.nr1[nsmm_l]
print @n.xbgr.xr81_u16.nr1[nsmm_rsh]
print @n.xbgr.xr81_u16.nr1[nsmm_w]
print @n.xbgr.xr81_u16.nr1[nsmm_l]
print @n.xbgr.xr81_u17.nr1[nsmm_rsh]
print @n.xbgr.xr81_u17.nr1[nsmm_w]
print @n.xbgr.xr81_u17.nr1[nsmm_l]
print @n.xbgr.xr81_u18.nr1[nsmm_rsh]
print @n.xbgr.xr81_u18.nr1[nsmm_w]
print @n.xbgr.xr81_u18.nr1[nsmm_l]
print @n.xbgr.xr81_u19.nr1[nsmm_rsh]
print @n.xbgr.xr81_u19.nr1[nsmm_w]
print @n.xbgr.xr81_u19.nr1[nsmm_l]
print @n.xbgr.xr81_u20.nr1[nsmm_rsh]
print @n.xbgr.xr81_u20.nr1[nsmm_w]
print @n.xbgr.xr81_u20.nr1[nsmm_l]
print @n.xbgr.xr81_u21.nr1[nsmm_rsh]
print @n.xbgr.xr81_u21.nr1[nsmm_w]
print @n.xbgr.xr81_u21.nr1[nsmm_l]
print @n.xbgr.xr81_u22.nr1[nsmm_rsh]
print @n.xbgr.xr81_u22.nr1[nsmm_w]
print @n.xbgr.xr81_u22.nr1[nsmm_l]
print @n.xbgr.xr81_u23.nr1[nsmm_rsh]
print @n.xbgr.xr81_u23.nr1[nsmm_w]
print @n.xbgr.xr81_u23.nr1[nsmm_l]
print @n.xbgr.xr81_u24.nr1[nsmm_rsh]
print @n.xbgr.xr81_u24.nr1[nsmm_w]
print @n.xbgr.xr81_u24.nr1[nsmm_l]
print @n.xbgr.xr82_u2.nr1[nsmm_rsh]
print @n.xbgr.xr82_u2.nr1[nsmm_w]
print @n.xbgr.xr82_u2.nr1[nsmm_l]
print @n.xbgr.xr82_u3.nr1[nsmm_rsh]
print @n.xbgr.xr82_u3.nr1[nsmm_w]
print @n.xbgr.xr82_u3.nr1[nsmm_l]
print @n.xbgr.xr82_u4.nr1[nsmm_rsh]
print @n.xbgr.xr82_u4.nr1[nsmm_w]
print @n.xbgr.xr82_u4.nr1[nsmm_l]
print @n.xbgr.xr82_u5.nr1[nsmm_rsh]
print @n.xbgr.xr82_u5.nr1[nsmm_w]
print @n.xbgr.xr82_u5.nr1[nsmm_l]
print @n.xbgr.xr82_u6.nr1[nsmm_rsh]
print @n.xbgr.xr82_u6.nr1[nsmm_w]
print @n.xbgr.xr82_u6.nr1[nsmm_l]
print @n.xbgr.xr82_u7.nr1[nsmm_rsh]
print @n.xbgr.xr82_u7.nr1[nsmm_w]
print @n.xbgr.xr82_u7.nr1[nsmm_l]
print @n.xbgr.xr82_u8.nr1[nsmm_rsh]
print @n.xbgr.xr82_u8.nr1[nsmm_w]
print @n.xbgr.xr82_u8.nr1[nsmm_l]
print @n.xbgr.xr82_u9.nr1[nsmm_rsh]
print @n.xbgr.xr82_u9.nr1[nsmm_w]
print @n.xbgr.xr82_u9.nr1[nsmm_l]
print @n.xbgr.xr82_u10.nr1[nsmm_rsh]
print @n.xbgr.xr82_u10.nr1[nsmm_w]
print @n.xbgr.xr82_u10.nr1[nsmm_l]
print @n.xbgr.xr82_u11.nr1[nsmm_rsh]
print @n.xbgr.xr82_u11.nr1[nsmm_w]
print @n.xbgr.xr82_u11.nr1[nsmm_l]
print @n.xbgr.xr82_u12.nr1[nsmm_rsh]
print @n.xbgr.xr82_u12.nr1[nsmm_w]
print @n.xbgr.xr82_u12.nr1[nsmm_l]
print @n.xbgr.xr82_u13.nr1[nsmm_rsh]
print @n.xbgr.xr82_u13.nr1[nsmm_w]
print @n.xbgr.xr82_u13.nr1[nsmm_l]
print @n.xbgr.xr82_u14.nr1[nsmm_rsh]
print @n.xbgr.xr82_u14.nr1[nsmm_w]
print @n.xbgr.xr82_u14.nr1[nsmm_l]
print @n.xbgr.xr82_u15.nr1[nsmm_rsh]
print @n.xbgr.xr82_u15.nr1[nsmm_w]
print @n.xbgr.xr82_u15.nr1[nsmm_l]
print @n.xbgr.xr82_u16.nr1[nsmm_rsh]
print @n.xbgr.xr82_u16.nr1[nsmm_w]
print @n.xbgr.xr82_u16.nr1[nsmm_l]
print @n.xbgr.xr82_u17.nr1[nsmm_rsh]
print @n.xbgr.xr82_u17.nr1[nsmm_w]
print @n.xbgr.xr82_u17.nr1[nsmm_l]
print @n.xbgr.xr82_u18.nr1[nsmm_rsh]
print @n.xbgr.xr82_u18.nr1[nsmm_w]
print @n.xbgr.xr82_u18.nr1[nsmm_l]
print @n.xbgr.xr82_u19.nr1[nsmm_rsh]
print @n.xbgr.xr82_u19.nr1[nsmm_w]
print @n.xbgr.xr82_u19.nr1[nsmm_l]
print @n.xbgr.xr82_u20.nr1[nsmm_rsh]
print @n.xbgr.xr82_u20.nr1[nsmm_w]
print @n.xbgr.xr82_u20.nr1[nsmm_l]
print @n.xbgr.xr82_u21.nr1[nsmm_rsh]
print @n.xbgr.xr82_u21.nr1[nsmm_w]
print @n.xbgr.xr82_u21.nr1[nsmm_l]
print @n.xbgr.xr82_u22.nr1[nsmm_rsh]
print @n.xbgr.xr82_u22.nr1[nsmm_w]
print @n.xbgr.xr82_u22.nr1[nsmm_l]
print @n.xbgr.xr82_u23.nr1[nsmm_rsh]
print @n.xbgr.xr82_u23.nr1[nsmm_w]
print @n.xbgr.xr82_u23.nr1[nsmm_l]
print @n.xbgr.xr82_u24.nr1[nsmm_rsh]
print @n.xbgr.xr82_u24.nr1[nsmm_w]
print @n.xbgr.xr82_u24.nr1[nsmm_l]
print @n.xbgr.xr83_u2.nr1[nsmm_rsh]
print @n.xbgr.xr83_u2.nr1[nsmm_w]
print @n.xbgr.xr83_u2.nr1[nsmm_l]
print @n.xbgr.xr83_u3.nr1[nsmm_rsh]
print @n.xbgr.xr83_u3.nr1[nsmm_w]
print @n.xbgr.xr83_u3.nr1[nsmm_l]
print @n.xbgr.xr83_u4.nr1[nsmm_rsh]
print @n.xbgr.xr83_u4.nr1[nsmm_w]
print @n.xbgr.xr83_u4.nr1[nsmm_l]
print @n.xbgr.xr83_u5.nr1[nsmm_rsh]
print @n.xbgr.xr83_u5.nr1[nsmm_w]
print @n.xbgr.xr83_u5.nr1[nsmm_l]
print @n.xbgr.xr83_u6.nr1[nsmm_rsh]
print @n.xbgr.xr83_u6.nr1[nsmm_w]
print @n.xbgr.xr83_u6.nr1[nsmm_l]
print @n.xbgr.xr83_u7.nr1[nsmm_rsh]
print @n.xbgr.xr83_u7.nr1[nsmm_w]
print @n.xbgr.xr83_u7.nr1[nsmm_l]
print @n.xbgr.xr83_u8.nr1[nsmm_rsh]
print @n.xbgr.xr83_u8.nr1[nsmm_w]
print @n.xbgr.xr83_u8.nr1[nsmm_l]
print @n.xbgr.xr83_u9.nr1[nsmm_rsh]
print @n.xbgr.xr83_u9.nr1[nsmm_w]
print @n.xbgr.xr83_u9.nr1[nsmm_l]
print @n.xbgr.xr83_u10.nr1[nsmm_rsh]
print @n.xbgr.xr83_u10.nr1[nsmm_w]
print @n.xbgr.xr83_u10.nr1[nsmm_l]
print @n.xbgr.xr83_u11.nr1[nsmm_rsh]
print @n.xbgr.xr83_u11.nr1[nsmm_w]
print @n.xbgr.xr83_u11.nr1[nsmm_l]
print @n.xbgr.xr83_u12.nr1[nsmm_rsh]
print @n.xbgr.xr83_u12.nr1[nsmm_w]
print @n.xbgr.xr83_u12.nr1[nsmm_l]
print @n.xbgr.xr83_u13.nr1[nsmm_rsh]
print @n.xbgr.xr83_u13.nr1[nsmm_w]
print @n.xbgr.xr83_u13.nr1[nsmm_l]
print @n.xbgr.xr83_u14.nr1[nsmm_rsh]
print @n.xbgr.xr83_u14.nr1[nsmm_w]
print @n.xbgr.xr83_u14.nr1[nsmm_l]
print @n.xbgr.xr83_u15.nr1[nsmm_rsh]
print @n.xbgr.xr83_u15.nr1[nsmm_w]
print @n.xbgr.xr83_u15.nr1[nsmm_l]
print @n.xbgr.xr83_u16.nr1[nsmm_rsh]
print @n.xbgr.xr83_u16.nr1[nsmm_w]
print @n.xbgr.xr83_u16.nr1[nsmm_l]
print @n.xbgr.xr83_u17.nr1[nsmm_rsh]
print @n.xbgr.xr83_u17.nr1[nsmm_w]
print @n.xbgr.xr83_u17.nr1[nsmm_l]
print @n.xbgr.xr83_u18.nr1[nsmm_rsh]
print @n.xbgr.xr83_u18.nr1[nsmm_w]
print @n.xbgr.xr83_u18.nr1[nsmm_l]
print @n.xbgr.xr83_u19.nr1[nsmm_rsh]
print @n.xbgr.xr83_u19.nr1[nsmm_w]
print @n.xbgr.xr83_u19.nr1[nsmm_l]
print @n.xbgr.xr83_u20.nr1[nsmm_rsh]
print @n.xbgr.xr83_u20.nr1[nsmm_w]
print @n.xbgr.xr83_u20.nr1[nsmm_l]
print @n.xbgr.xr83_u21.nr1[nsmm_rsh]
print @n.xbgr.xr83_u21.nr1[nsmm_w]
print @n.xbgr.xr83_u21.nr1[nsmm_l]
print @n.xbgr.xr83_u22.nr1[nsmm_rsh]
print @n.xbgr.xr83_u22.nr1[nsmm_w]
print @n.xbgr.xr83_u22.nr1[nsmm_l]
print @n.xbgr.xr83_u23.nr1[nsmm_rsh]
print @n.xbgr.xr83_u23.nr1[nsmm_w]
print @n.xbgr.xr83_u23.nr1[nsmm_l]
print @n.xbgr.xr83_u24.nr1[nsmm_rsh]
print @n.xbgr.xr83_u24.nr1[nsmm_w]
print @n.xbgr.xr83_u24.nr1[nsmm_l]
print @n.xbgr.xr84_u2.nr1[nsmm_rsh]
print @n.xbgr.xr84_u2.nr1[nsmm_w]
print @n.xbgr.xr84_u2.nr1[nsmm_l]
print @n.xbgr.xr84_u3.nr1[nsmm_rsh]
print @n.xbgr.xr84_u3.nr1[nsmm_w]
print @n.xbgr.xr84_u3.nr1[nsmm_l]
print @n.xbgr.xr84_u4.nr1[nsmm_rsh]
print @n.xbgr.xr84_u4.nr1[nsmm_w]
print @n.xbgr.xr84_u4.nr1[nsmm_l]
print @n.xbgr.xr84_u5.nr1[nsmm_rsh]
print @n.xbgr.xr84_u5.nr1[nsmm_w]
print @n.xbgr.xr84_u5.nr1[nsmm_l]
print @n.xbgr.xr84_u6.nr1[nsmm_rsh]
print @n.xbgr.xr84_u6.nr1[nsmm_w]
print @n.xbgr.xr84_u6.nr1[nsmm_l]
print @n.xbgr.xr84_u7.nr1[nsmm_rsh]
print @n.xbgr.xr84_u7.nr1[nsmm_w]
print @n.xbgr.xr84_u7.nr1[nsmm_l]
print @n.xbgr.xr84_u8.nr1[nsmm_rsh]
print @n.xbgr.xr84_u8.nr1[nsmm_w]
print @n.xbgr.xr84_u8.nr1[nsmm_l]
print @n.xbgr.xr84_u9.nr1[nsmm_rsh]
print @n.xbgr.xr84_u9.nr1[nsmm_w]
print @n.xbgr.xr84_u9.nr1[nsmm_l]
print @n.xbgr.xr84_u10.nr1[nsmm_rsh]
print @n.xbgr.xr84_u10.nr1[nsmm_w]
print @n.xbgr.xr84_u10.nr1[nsmm_l]
print @n.xbgr.xr84_u11.nr1[nsmm_rsh]
print @n.xbgr.xr84_u11.nr1[nsmm_w]
print @n.xbgr.xr84_u11.nr1[nsmm_l]
print @n.xbgr.xr84_u12.nr1[nsmm_rsh]
print @n.xbgr.xr84_u12.nr1[nsmm_w]
print @n.xbgr.xr84_u12.nr1[nsmm_l]
print @n.xbgr.xr84_u13.nr1[nsmm_rsh]
print @n.xbgr.xr84_u13.nr1[nsmm_w]
print @n.xbgr.xr84_u13.nr1[nsmm_l]
print @n.xbgr.xr84_u14.nr1[nsmm_rsh]
print @n.xbgr.xr84_u14.nr1[nsmm_w]
print @n.xbgr.xr84_u14.nr1[nsmm_l]
print @n.xbgr.xr84_u15.nr1[nsmm_rsh]
print @n.xbgr.xr84_u15.nr1[nsmm_w]
print @n.xbgr.xr84_u15.nr1[nsmm_l]
print @n.xbgr.xr84_u16.nr1[nsmm_rsh]
print @n.xbgr.xr84_u16.nr1[nsmm_w]
print @n.xbgr.xr84_u16.nr1[nsmm_l]
print @n.xbgr.xr84_u17.nr1[nsmm_rsh]
print @n.xbgr.xr84_u17.nr1[nsmm_w]
print @n.xbgr.xr84_u17.nr1[nsmm_l]
print @n.xbgr.xr84_u18.nr1[nsmm_rsh]
print @n.xbgr.xr84_u18.nr1[nsmm_w]
print @n.xbgr.xr84_u18.nr1[nsmm_l]
print @n.xbgr.xr84_u19.nr1[nsmm_rsh]
print @n.xbgr.xr84_u19.nr1[nsmm_w]
print @n.xbgr.xr84_u19.nr1[nsmm_l]
print @n.xbgr.xr84_u20.nr1[nsmm_rsh]
print @n.xbgr.xr84_u20.nr1[nsmm_w]
print @n.xbgr.xr84_u20.nr1[nsmm_l]
print @n.xbgr.xr84_u21.nr1[nsmm_rsh]
print @n.xbgr.xr84_u21.nr1[nsmm_w]
print @n.xbgr.xr84_u21.nr1[nsmm_l]
print @n.xbgr.xr84_u22.nr1[nsmm_rsh]
print @n.xbgr.xr84_u22.nr1[nsmm_w]
print @n.xbgr.xr84_u22.nr1[nsmm_l]
print @n.xbgr.xr84_u23.nr1[nsmm_rsh]
print @n.xbgr.xr84_u23.nr1[nsmm_w]
print @n.xbgr.xr84_u23.nr1[nsmm_l]
print @n.xbgr.xr84_u24.nr1[nsmm_rsh]
print @n.xbgr.xr84_u24.nr1[nsmm_w]
print @n.xbgr.xr84_u24.nr1[nsmm_l]
print @n.xbgr.xr85_u2.nr1[nsmm_rsh]
print @n.xbgr.xr85_u2.nr1[nsmm_w]
print @n.xbgr.xr85_u2.nr1[nsmm_l]
print @n.xbgr.xr85_u3.nr1[nsmm_rsh]
print @n.xbgr.xr85_u3.nr1[nsmm_w]
print @n.xbgr.xr85_u3.nr1[nsmm_l]
print @n.xbgr.xr85_u4.nr1[nsmm_rsh]
print @n.xbgr.xr85_u4.nr1[nsmm_w]
print @n.xbgr.xr85_u4.nr1[nsmm_l]
print @n.xbgr.xr85_u5.nr1[nsmm_rsh]
print @n.xbgr.xr85_u5.nr1[nsmm_w]
print @n.xbgr.xr85_u5.nr1[nsmm_l]
print @n.xbgr.xr85_u6.nr1[nsmm_rsh]
print @n.xbgr.xr85_u6.nr1[nsmm_w]
print @n.xbgr.xr85_u6.nr1[nsmm_l]
print @n.xbgr.xr85_u7.nr1[nsmm_rsh]
print @n.xbgr.xr85_u7.nr1[nsmm_w]
print @n.xbgr.xr85_u7.nr1[nsmm_l]
print @n.xbgr.xr85_u8.nr1[nsmm_rsh]
print @n.xbgr.xr85_u8.nr1[nsmm_w]
print @n.xbgr.xr85_u8.nr1[nsmm_l]
print @n.xbgr.xr85_u9.nr1[nsmm_rsh]
print @n.xbgr.xr85_u9.nr1[nsmm_w]
print @n.xbgr.xr85_u9.nr1[nsmm_l]
print @n.xbgr.xr85_u10.nr1[nsmm_rsh]
print @n.xbgr.xr85_u10.nr1[nsmm_w]
print @n.xbgr.xr85_u10.nr1[nsmm_l]
print @n.xbgr.xr85_u11.nr1[nsmm_rsh]
print @n.xbgr.xr85_u11.nr1[nsmm_w]
print @n.xbgr.xr85_u11.nr1[nsmm_l]
print @n.xbgr.xr85_u12.nr1[nsmm_rsh]
print @n.xbgr.xr85_u12.nr1[nsmm_w]
print @n.xbgr.xr85_u12.nr1[nsmm_l]
print @n.xbgr.xr85_u13.nr1[nsmm_rsh]
print @n.xbgr.xr85_u13.nr1[nsmm_w]
print @n.xbgr.xr85_u13.nr1[nsmm_l]
print @n.xbgr.xr85_u14.nr1[nsmm_rsh]
print @n.xbgr.xr85_u14.nr1[nsmm_w]
print @n.xbgr.xr85_u14.nr1[nsmm_l]
print @n.xbgr.xr85_u15.nr1[nsmm_rsh]
print @n.xbgr.xr85_u15.nr1[nsmm_w]
print @n.xbgr.xr85_u15.nr1[nsmm_l]
print @n.xbgr.xr85_u16.nr1[nsmm_rsh]
print @n.xbgr.xr85_u16.nr1[nsmm_w]
print @n.xbgr.xr85_u16.nr1[nsmm_l]
print @n.xbgr.xr85_u17.nr1[nsmm_rsh]
print @n.xbgr.xr85_u17.nr1[nsmm_w]
print @n.xbgr.xr85_u17.nr1[nsmm_l]
print @n.xbgr.xr85_u18.nr1[nsmm_rsh]
print @n.xbgr.xr85_u18.nr1[nsmm_w]
print @n.xbgr.xr85_u18.nr1[nsmm_l]
print @n.xbgr.xr85_u19.nr1[nsmm_rsh]
print @n.xbgr.xr85_u19.nr1[nsmm_w]
print @n.xbgr.xr85_u19.nr1[nsmm_l]
print @n.xbgr.xr85_u20.nr1[nsmm_rsh]
print @n.xbgr.xr85_u20.nr1[nsmm_w]
print @n.xbgr.xr85_u20.nr1[nsmm_l]
print @n.xbgr.xr85_u21.nr1[nsmm_rsh]
print @n.xbgr.xr85_u21.nr1[nsmm_w]
print @n.xbgr.xr85_u21.nr1[nsmm_l]
print @n.xbgr.xr85_u22.nr1[nsmm_rsh]
print @n.xbgr.xr85_u22.nr1[nsmm_w]
print @n.xbgr.xr85_u22.nr1[nsmm_l]
print @n.xbgr.xr85_u23.nr1[nsmm_rsh]
print @n.xbgr.xr85_u23.nr1[nsmm_w]
print @n.xbgr.xr85_u23.nr1[nsmm_l]
print @n.xbgr.xr85_u24.nr1[nsmm_rsh]
print @n.xbgr.xr85_u24.nr1[nsmm_w]
print @n.xbgr.xr85_u24.nr1[nsmm_l]
print @n.xbgr.xr86_u2.nr1[nsmm_rsh]
print @n.xbgr.xr86_u2.nr1[nsmm_w]
print @n.xbgr.xr86_u2.nr1[nsmm_l]
print @n.xbgr.xr86_u3.nr1[nsmm_rsh]
print @n.xbgr.xr86_u3.nr1[nsmm_w]
print @n.xbgr.xr86_u3.nr1[nsmm_l]
print @n.xbgr.xr86_u4.nr1[nsmm_rsh]
print @n.xbgr.xr86_u4.nr1[nsmm_w]
print @n.xbgr.xr86_u4.nr1[nsmm_l]
print @n.xbgr.xr86_u5.nr1[nsmm_rsh]
print @n.xbgr.xr86_u5.nr1[nsmm_w]
print @n.xbgr.xr86_u5.nr1[nsmm_l]
print @n.xbgr.xr86_u6.nr1[nsmm_rsh]
print @n.xbgr.xr86_u6.nr1[nsmm_w]
print @n.xbgr.xr86_u6.nr1[nsmm_l]
print @n.xbgr.xr86_u7.nr1[nsmm_rsh]
print @n.xbgr.xr86_u7.nr1[nsmm_w]
print @n.xbgr.xr86_u7.nr1[nsmm_l]
print @n.xbgr.xr86_u8.nr1[nsmm_rsh]
print @n.xbgr.xr86_u8.nr1[nsmm_w]
print @n.xbgr.xr86_u8.nr1[nsmm_l]
print @n.xbgr.xr86_u9.nr1[nsmm_rsh]
print @n.xbgr.xr86_u9.nr1[nsmm_w]
print @n.xbgr.xr86_u9.nr1[nsmm_l]
print @n.xbgr.xr86_u10.nr1[nsmm_rsh]
print @n.xbgr.xr86_u10.nr1[nsmm_w]
print @n.xbgr.xr86_u10.nr1[nsmm_l]
print @n.xbgr.xr86_u11.nr1[nsmm_rsh]
print @n.xbgr.xr86_u11.nr1[nsmm_w]
print @n.xbgr.xr86_u11.nr1[nsmm_l]
print @n.xbgr.xr86_u12.nr1[nsmm_rsh]
print @n.xbgr.xr86_u12.nr1[nsmm_w]
print @n.xbgr.xr86_u12.nr1[nsmm_l]
print @n.xbgr.xr86_u13.nr1[nsmm_rsh]
print @n.xbgr.xr86_u13.nr1[nsmm_w]
print @n.xbgr.xr86_u13.nr1[nsmm_l]
print @n.xbgr.xr86_u14.nr1[nsmm_rsh]
print @n.xbgr.xr86_u14.nr1[nsmm_w]
print @n.xbgr.xr86_u14.nr1[nsmm_l]
print @n.xbgr.xr86_u15.nr1[nsmm_rsh]
print @n.xbgr.xr86_u15.nr1[nsmm_w]
print @n.xbgr.xr86_u15.nr1[nsmm_l]
print @n.xbgr.xr86_u16.nr1[nsmm_rsh]
print @n.xbgr.xr86_u16.nr1[nsmm_w]
print @n.xbgr.xr86_u16.nr1[nsmm_l]
print @n.xbgr.xr86_u17.nr1[nsmm_rsh]
print @n.xbgr.xr86_u17.nr1[nsmm_w]
print @n.xbgr.xr86_u17.nr1[nsmm_l]
print @n.xbgr.xr86_u18.nr1[nsmm_rsh]
print @n.xbgr.xr86_u18.nr1[nsmm_w]
print @n.xbgr.xr86_u18.nr1[nsmm_l]
print @n.xbgr.xr86_u19.nr1[nsmm_rsh]
print @n.xbgr.xr86_u19.nr1[nsmm_w]
print @n.xbgr.xr86_u19.nr1[nsmm_l]
print @n.xbgr.xr86_u20.nr1[nsmm_rsh]
print @n.xbgr.xr86_u20.nr1[nsmm_w]
print @n.xbgr.xr86_u20.nr1[nsmm_l]
print @n.xbgr.xr86_u21.nr1[nsmm_rsh]
print @n.xbgr.xr86_u21.nr1[nsmm_w]
print @n.xbgr.xr86_u21.nr1[nsmm_l]
print @n.xbgr.xr86_u22.nr1[nsmm_rsh]
print @n.xbgr.xr86_u22.nr1[nsmm_w]
print @n.xbgr.xr86_u22.nr1[nsmm_l]
print @n.xbgr.xr86_u23.nr1[nsmm_rsh]
print @n.xbgr.xr86_u23.nr1[nsmm_w]
print @n.xbgr.xr86_u23.nr1[nsmm_l]
print @n.xbgr.xr86_u24.nr1[nsmm_rsh]
print @n.xbgr.xr86_u24.nr1[nsmm_w]
print @n.xbgr.xr86_u24.nr1[nsmm_l]
set numdgt=17
echo METALLIC_POINT_VOLTAGES_BEGIN
print v(xbgr.mr_n65396208)
print v(xbgr.vd2)
print v(xbgr.mr_n64591248)
print v(xbgr.c2)
print v(xbgr.mr_n65686544)
print v(xbgr.mr_n65784144)
print v(xbgr.mr_n65902496)
print v(xbgr.mr_n65953808)
print v(xbgr.mr_n66138320)
print v(xbgr.mr_n66273264)
print v(xbgr.mr_n66383744)
print v(xbgr.mr_n66570640)
print v(xbgr.mr_n66737904)
print v(xbgr.mr_n66857280)
print v(xbgr.mr_n66885712)
print v(xbgr.mr_n67177952)
print v(xbgr.mr_n67268288)
print v(xbgr.mr_n67331296)
print v(xbgr.mr_n63730128)
print v(xbgr.mr_n67944896)
print v(xbgr.mr_n68118000)
print v(xbgr.mr_n68306464)
print v(xbgr.mr_n68480976)
print v(xbgr.mr_n68620256)
print v(xbgr.mr_n68829824)
print v(xbgr.mr_n69028912)
print v(xbgr.mr_n69239952)
print v(xbgr.mr_n66232848)
print v(xbgr.mr_n69325920)
print v(xbgr.mr_n69608736)
print v(xbgr.mr_n69801472)
print v(xbgr.mr_n70034816)
print v(xbgr.mr_n70199472)
print v(xbgr.mr_n70515984)
print v(xbgr.mr_n70708672)
print v(xbgr.mr_n70919376)
print v(xbgr.mr_n71276752)
print v(xbgr.mr_n65396656)
print v(xbgr.mr_n65460960)
print v(xbgr.b1b)
print v(xbgr.mr_n65544272)
print v(xbgr.mr_n65643600)
print v(xbgr.mr_n65738960)
print v(xbgr.mr_n65848912)
print v(xbgr.mr_n65963216)
print v(xbgr.mr_n66073952)
print v(xbgr.mr_n66415312)
print v(xbgr.mr_n66533040)
print v(xbgr.mr_n66664608)
print v(xbgr.mr_n66766480)
print v(xbgr.mr_n66939808)
print v(xbgr.mr_n67055712)
print v(xbgr.mr_n67208944)
print v(xbgr.mr_n67458000)
print v(xbgr.mr_n65432336)
print v(xbgr.mr_n65493840)
print v(xbgr.mr_n65196208)
print v(xbgr.mr_n65631424)
print v(xbgr.mr_n65731584)
print v(xbgr.mr_n65847344)
print v(xbgr.mr_n65905680)
print v(xbgr.mr_n66054928)
print v(xbgr.mr_n66158672)
print v(xbgr.mr_n66273600)
print v(xbgr.mr_n66460800)
print v(xbgr.mr_n66580736)
print v(xbgr.mr_n66740896)
print v(xbgr.mr_n66861840)
print v(xbgr.mr_n67064224)
print v(xbgr.mr_n67180768)
print v(xbgr.mr_n67286352)
print v(xbgr.mr_n67459968)
print v(xbgr.mr_n64666800)
print v(xbgr.mr_n64930496)
print v(xbgr.n_13)
print v(xbgr.n_24)
print v(xbgr.mr_n64664928)
print v(xbgr.mr_n64932400)
print v(xbgr.n_14)
print v(xbgr.mr_n65274480)
print v(xbgr.mr_n65397232)
print v(xbgr.mr_n65461152)
print v(xbgr.mr_n64602192)
print v(xbgr.mr_n65632128)
print v(xbgr.mr_n65689216)
print v(xbgr.mr_n65771824)
print v(xbgr.mr_n65828256)
print v(xbgr.vd1)
print v(xbgr.mr_n66142752)
print v(xbgr.mr_n66273936)
print v(xbgr.mr_n66385824)
print v(xbgr.mr_n66510432)
print v(xbgr.mr_n66734608)
print v(xbgr.mr_n66865952)
print v(xbgr.mr_n66974736)
print v(xbgr.mr_n67116688)
print v(xbgr.mr_n67267696)
print v(xbgr.mr_n67458672)
print v(xbgr.mr_n67807296)
print v(xbgr.mr_n67946160)
print v(xbgr.mr_n68122144)
print v(xbgr.mr_n68315520)
print v(xbgr.mr_n68427472)
print v(xbgr.mr_n68672912)
print v(xbgr.mr_n68868048)
print v(xbgr.mr_n69030016)
print v(xbgr.mr_n69251952)
print v(xbgr.mr_n66274944)
print v(xbgr.mr_n69331456)
print v(xbgr.mr_n69608544)
print v(xbgr.mr_n69801008)
print v(xbgr.mr_n70019264)
print v(xbgr.mr_n70207024)
print v(xbgr.mr_n70506848)
print v(xbgr.mr_n70709808)
print v(xbgr.mr_n70941936)
print v(xbgr.mr_n71279584)
print v(xbgr.mr_n65378496)
print v(xbgr.mr_n65462096)
print v(xbgr.mr_n64892288)
print v(xbgr.mr_n65571456)
print v(xbgr.mr_n65644992)
print v(xbgr.mr_n65740048)
print v(xbgr.mr_n65848512)
print v(xbgr.mr_n66019824)
print v(xbgr.mr_n66079232)
print v(xbgr.mr_n66416704)
print v(xbgr.mr_n66534432)
print v(xbgr.mr_n66666000)
print v(xbgr.mr_n66813072)
print v(xbgr.mr_n66941264)
print v(xbgr.mr_n66972064)
print v(xbgr.mr_n67203408)
print v(xbgr.mr_n67327568)
print v(xbgr.mr_n64667728)
print v(xbgr.mr_n64932832)
print v(xbgr.mr_n65160208)
print v(xbgr.n_26)
print v(xbgr.mr_n64667264)
print v(xbgr.mr_n64933264)
print v(xbgr.n_15)
print v(xbgr.mr_n65275920)
print v(xbgr.mr_n65433792)
print v(xbgr.mr_n65494480)
print v(xbgr.mr_n65183840)
print v(xbgr.mr_n65632864)
print v(xbgr.mr_n65732384)
print v(xbgr.mr_n65848112)
print v(xbgr.mr_n65826448)
print v(xbgr.mr_n66056256)
print v(xbgr.mr_n66142000)
print v(xbgr.mr_n66277936)
print v(xbgr.mr_n66462832)
print v(xbgr.mr_n66582592)
print v(xbgr.mr_n66756256)
print v(xbgr.mr_n66878688)
print v(xbgr.mr_n67065296)
print v(xbgr.mr_n67178544)
print v(xbgr.mr_n67263232)
print v(xbgr.mr_n67332384)
print v(xbgr.mr_n64668656)
print v(xbgr.mr_n64776768)
print v(xbgr.mr_n65161136)
print v(xbgr.n_27)
print v(xbgr.mr_n64668192)
print v(xbgr.mr_n64934368)
print v(xbgr.n_16)
print v(xbgr.mr_n65277360)
print v(xbgr.mr_n64669584)
print v(xbgr.mr_n64934960)
print v(xbgr.mr_n65161600)
print v(xbgr.n_21)
print v(xbgr.mr_n65403856)
print v(xbgr.mr_n65460768)
print v(xbgr.mr_n64631280)
print v(xbgr.mr_n65609472)
print v(xbgr.mr_n65636592)
print v(xbgr.mr_n65784848)
print v(xbgr.mr_n65903168)
print v(xbgr.mr_n65964432)
print v(xbgr.mr_n66078224)
print v(xbgr.mr_n66458224)
print v(xbgr.mr_n66571088)
print v(xbgr.mr_n66717744)
print v(xbgr.mr_n66878512)
print v(xbgr.mr_n66972320)
print v(xbgr.mr_n67178880)
print v(xbgr.mr_n67264736)
print v(xbgr.mr_n67458336)
print v(xbgr.mr_n64669120)
print v(xbgr.mr_n64935552)
print v(xbgr.mr_n67814672)
print v(xbgr.mr_n67927632)
print v(xbgr.mr_n68195504)
print v(xbgr.mr_n68307904)
print v(xbgr.mr_n68481168)
print v(xbgr.mr_n68678144)
print v(xbgr.mr_n68826048)
print v(xbgr.mr_n69015248)
print v(xbgr.mr_n69249056)
print v(xbgr.mr_n69592768)
print v(xbgr.mr_n69816816)
print v(xbgr.mr_n70024864)
print v(xbgr.mr_n70212000)
print v(xbgr.mr_n70519328)
print v(xbgr.mr_n70709920)
print v(xbgr.mr_n70942128)
print v(xbgr.mr_n71290800)
print v(xbgr.mr_n65368368)
print v(xbgr.mr_n65480416)
print v(xbgr.mr_n64696128)
print v(xbgr.mr_n65572848)
print v(xbgr.mr_n65646384)
print v(xbgr.mr_n65759936)
print v(xbgr.mr_n65885136)
print v(xbgr.mr_n66040832)
print v(xbgr.mr_n66093024)
print v(xbgr.mr_n66416240)
print v(xbgr.mr_n66535824)
print v(xbgr.mr_n66667392)
print v(xbgr.mr_n66814848)
print v(xbgr.mr_n66943040)
print v(xbgr.mr_n67057504)
print v(xbgr.mr_n67237328)
print v(xbgr.mr_n67460560)
print v(xbgr.mr_n64670512)
print v(xbgr.mr_n64877632)
print v(xbgr.n_8)
print v(xbgr.vbe3)
print v(xbgr.mr_n65435248)
print v(xbgr.mr_n65494880)
print v(xbgr.mr_n65231104)
print v(xbgr.mr_n65633744)
print v(xbgr.mr_n65733184)
print v(xbgr.mr_n65844304)
print v(xbgr.mr_n65910224)
print v(xbgr.mr_n66057136)
print v(xbgr.mr_n66161136)
print v(xbgr.mr_n66464640)
print v(xbgr.mr_n66570832)
print v(xbgr.mr_n66757056)
print v(xbgr.mr_n66879488)
print v(xbgr.mr_n67066896)
print v(xbgr.mr_n67178208)
print v(xbgr.mr_n67285440)
print v(xbgr.mr_n67459008)
print v(xbgr.mr_n64670048)
print v(xbgr.mr_n64937328)
print v(xbgr.mr_n65010544)
print v(xbgr.mr_n65322800)
print v(xbgr.mr_n64671440)
print v(xbgr.mr_n64939104)
print v(xbgr.mr_n64970176)
print v(xbgr.n_37)
print v(xbgr.mr_n64670976)
print v(xbgr.mr_n64930144)
print v(xbgr.mr_n65011024)
print v(xbgr.mr_n65323984)
print v(xbgr.n_6)
print v(xbgr.vb2)
print v(xbgr.n_2)
print v(xbgr.mr_n65324576)
print v(xbgr.mr_n65396848)
print v(xbgr.mr_n65481120)
print v(xbgr.mr_n65186288)
print v(xbgr.mr_n65633392)
print v(xbgr.mr_n65692096)
print v(xbgr.mr_n65810960)
print v(xbgr.mr_n65906768)
print v(xbgr.mr_n65900816)
print v(xbgr.mr_n66138624)
print v(xbgr.mr_n66417168)
print v(xbgr.mr_n66541680)
print v(xbgr.mr_n66756080)
print v(xbgr.mr_n66856752)
print v(xbgr.mr_n67041968)
print v(xbgr.mr_n67183632)
print v(xbgr.mr_n67288752)
print v(xbgr.mr_n67462848)
print v(xbgr.mr_n67801392)
print v(xbgr.mr_n67983648)
print v(xbgr.mr_n63984560)
print v(xbgr.mr_n68307152)
print v(xbgr.mr_n68474432)
print v(xbgr.mr_n68684048)
print v(xbgr.mr_n68867584)
print v(xbgr.mr_n69029104)
print v(xbgr.mr_n69261904)
print v(xbgr.mr_n69605392)
print v(xbgr.mr_n69824880)
print v(xbgr.mr_n70029728)
print v(xbgr.mr_n70216976)
print v(xbgr.mr_n70535888)
print v(xbgr.mr_n70727152)
print v(xbgr.mr_n70920672)
print v(xbgr.mr_n71278640)
print v(xbgr.mr_n64772016)
print v(xbgr.mr_n64808720)
print v(xbgr.mr_n65011504)
print v(xbgr.mr_n65325168)
print v(xbgr.mr_n65404768)
print v(xbgr.mr_n65481472)
print v(xbgr.mr_n64569376)
print v(xbgr.mr_n65574240)
print v(xbgr.mr_n65647776)
print v(xbgr.mr_n65762480)
print v(xbgr.mr_n65886288)
print v(xbgr.mr_n66017856)
print v(xbgr.mr_n66094416)
print v(xbgr.mr_n66415776)
print v(xbgr.mr_n66537536)
print v(xbgr.mr_n66669104)
print v(xbgr.mr_n66816624)
print v(xbgr.mr_n66944816)
print v(xbgr.mr_n67062640)
print v(xbgr.mr_n67238720)
print v(xbgr.mr_n67460672)
print v(xbgr.mr_n64774560)
print v(xbgr.mr_n64809184)
print v(xbgr.n_7)
print v(xbgr.n_36)
print v(xbgr.mr_n65436304)
print v(xbgr.mr_n65495280)
print v(xbgr.mr_n64628464)
print v(xbgr.mr_n65634704)
print v(xbgr.mr_n65733984)
print v(xbgr.mr_n65845312)
print v(xbgr.mr_n65898832)
print v(xbgr.mr_n66057696)
print v(xbgr.mr_n66161936)
print v(xbgr.mr_n66466448)
print v(xbgr.mr_n66584784)
print v(xbgr.mr_n66757856)
print v(xbgr.mr_n66880288)
print v(xbgr.mr_n67068240)
print v(xbgr.mr_n67183520)
print v(xbgr.mr_n67265920)
print v(xbgr.mr_n67460784)
print v(xbgr.mr_n64775296)
print v(xbgr.mr_n64809648)
print v(xbgr.mr_n65010784)
print v(xbgr.mr_n65326352)
print v(xbgr.mr_n64776032)
print v(xbgr.mr_n64810208)
print v(xbgr.mr_n64914496)
print v(xbgr.mr_n65326944)
print v(xbgr.mr_n64776656)
print v(xbgr.mr_n64810800)
print v(xbgr.mr_n65012864)
print v(xbgr.mr_n65327536)
print v(xbgr.mr_n64777504)
print v(xbgr.mr_n64811392)
print v(xbgr.mr_n65005568)
print v(xbgr.mr_n65328128)
print v(xbgr.mr_n65397040)
print v(xbgr.mr_n65482176)
print v(xbgr.mr_n64697040)
print v(xbgr.mr_n65608288)
print v(xbgr.mr_n65693424)
print v(xbgr.mr_n65811760)
print v(xbgr.mr_n65908720)
print v(xbgr.mr_n65809712)
print v(xbgr.mr_n66161760)
print v(xbgr.mr_n66458048)
print v(xbgr.mr_n66581376)
print v(xbgr.mr_n66756880)
print v(xbgr.mr_n66861376)
print v(xbgr.mr_n67043152)
print v(xbgr.mr_n67181552)
print v(xbgr.mr_n67290672)
print v(xbgr.mr_n67322672)
print v(xbgr.mr_n67814480)
print v(xbgr.mr_n67978544)
print v(xbgr.mr_n68202864)
print v(xbgr.mr_n68340288)
print v(xbgr.mr_n68484192)
print v(xbgr.mr_n68689280)
print v(xbgr.mr_n68876944)
print v(xbgr.mr_n69035824)
print v(xbgr.mr_n69266880)
print v(xbgr.mr_n69624592)
print v(xbgr.mr_n69807664)
print v(xbgr.mr_n70034304)
print v(xbgr.mr_n70221952)
print v(xbgr.mr_n70526864)
print v(xbgr.mr_n70711888)
print v(xbgr.mr_n70945920)
print v(xbgr.mr_n71291568)
print v(xbgr.mr_n65408848)
print v(xbgr.mr_n65482528)
print v(xbgr.mr_n64632688)
print v(xbgr.mr_n65575632)
print v(xbgr.mr_n65649168)
print v(xbgr.mr_n65740656)
print v(xbgr.mr_n65887680)
print v(xbgr.mr_n65904704)
print v(xbgr.mr_n66095808)
print v(xbgr.mr_n66386704)
print v(xbgr.mr_n66539312)
print v(xbgr.mr_n66670880)
print v(xbgr.mr_n66818400)
print v(xbgr.mr_n66946592)
print v(xbgr.mr_n67066480)
print v(xbgr.mr_n67240240)
print v(xbgr.mr_n67462624)
print v(xbgr.mr_n64778016)
print v(xbgr.mr_n64786896)
print v(xbgr.mr_n65013664)
print v(xbgr.mr_n65329312)
print v(xbgr.mr_n64739072)
print v(xbgr.mr_n64812576)
print v(xbgr.n_11)
print v(xbgr.mr_n65328720)
print v(xbgr.mr_n65438160)
print v(xbgr.mr_n65495680)
print v(xbgr.mr_n65503424)
print v(xbgr.mr_n65635904)
print v(xbgr.mr_n65734784)
print v(xbgr.mr_n65849312)
print v(xbgr.mr_n65915712)
print v(xbgr.mr_n66058512)
print v(xbgr.mr_n66162736)
print v(xbgr.mr_n66468512)
print v(xbgr.mr_n66587344)
print v(xbgr.mr_n66758656)
print v(xbgr.mr_n66881088)
print v(xbgr.mr_n67070304)
print v(xbgr.mr_n67181664)
print v(xbgr.mr_n67290560)
print v(xbgr.mr_n67464688)
print v(xbgr.mr_n64779056)
print v(xbgr.mr_n64813168)
print v(xbgr.mr_n65012064)
print v(xbgr.mr_n65181648)
print v(xbgr.mr_n64777280)
print v(xbgr.mr_n64813760)
print v(xbgr.mr_n65094768)
print v(xbgr.mr_n65277968)
print v(xbgr.mr_n64780384)
print v(xbgr.mr_n64814352)
print v(xbgr.mr_n65011264)
print v(xbgr.mr_n65331008)
print v(xbgr.mr_n65403104)
print v(xbgr.mr_n65483232)
print v(xbgr.mr_n65375792)
print v(xbgr.mr_n65611616)
print v(xbgr.mr_n65698400)
print v(xbgr.mr_n65812560)
print v(xbgr.mr_n65912928)
print v(xbgr.mr_n65890832)
print v(xbgr.mr_n66135936)
print v(xbgr.mr_n66463344)
print v(xbgr.mr_n66584592)
print v(xbgr.mr_n66758480)
print v(xbgr.mr_n66854272)
print v(xbgr.mr_n67044336)
print v(xbgr.mr_n67117504)
print v(xbgr.mr_n67287056)
print v(xbgr.mr_n67462736)
print v(xbgr.n_9)
print v(xbgr.mr_n64814944)
print v(xbgr.mr_n65095952)
print v(xbgr.mr_n65331680)
print v(xbgr.mr_n67818832)
print v(xbgr.mr_n67929520)
print v(xbgr.mr_n68199744)
print v(xbgr.mr_n68328576)
print v(xbgr.mr_n68482224)
print v(xbgr.mr_n68687056)
print v(xbgr.mr_n68887680)
print v(xbgr.mr_n69030128)
print v(xbgr.mr_n69263984)
print v(xbgr.mr_n69635232)
print v(xbgr.mr_n69829552)
print v(xbgr.mr_n70059296)
print v(xbgr.mr_n70226928)
print v(xbgr.mr_n70539344)
print v(xbgr.mr_n70708864)
print v(xbgr.mr_n70969840)
print v(xbgr.mr_n71190400)
print v(xbgr.mr_n65409760)
print v(xbgr.mr_n65483408)
print v(xbgr.mr_n64600192)
print v(xbgr.mr_n65577024)
print v(xbgr.mr_n65650560)
print v(xbgr.mr_n65755888)
print v(xbgr.mr_n65889072)
print v(xbgr.mr_n66043888)
print v(xbgr.mr_n66097200)
print v(xbgr.mr_n66467856)
print v(xbgr.mr_n66541088)
print v(xbgr.mr_n66672656)
print v(xbgr.mr_n66820176)
print v(xbgr.mr_n66948368)
print v(xbgr.mr_n67070896)
print v(xbgr.mr_n67242016)
print v(xbgr.mr_n67468816)
print v(xbgr.mr_n64781472)
print v(xbgr.mr_n64815536)
print v(xbgr.mr_n65096544)
print v(xbgr.mr_n65332272)
print v(xbgr.mr_n65439216)
print v(xbgr.mr_n65496080)
print v(xbgr.mr_n65505776)
print v(xbgr.mr_n65637024)
print v(xbgr.mr_n65735584)
print v(xbgr.mr_n65849712)
print v(xbgr.mr_n65913040)
print v(xbgr.mr_n66059392)
print v(xbgr.mr_n66163536)
print v(xbgr.mr_n66470496)
print v(xbgr.mr_n66589600)
print v(xbgr.mr_n66759456)
print v(xbgr.mr_n66881888)
print v(xbgr.mr_n67071904)
print v(xbgr.mr_n67185328)
print v(xbgr.mr_n67292368)
print v(xbgr.mr_n67466752)
print v(xbgr.mr_n64782016)
print v(xbgr.mr_n64816128)
print v(xbgr.mr_n65097136)
print v(xbgr.mr_n65332864)
print v(xbgr.mr_n64782560)
print v(xbgr.mr_n64811984)
print v(xbgr.mr_n65012464)
print v(xbgr.mr_n65333456)
print v(xbgr.mr_n64783104)
print v(xbgr.mr_n64817376)
print v(xbgr.mr_n65085488)
print v(xbgr.mr_n65334048)
print v(xbgr.mr_n64779568)
print v(xbgr.mr_n64786096)
print v(xbgr.mr_n65050864)
print v(xbgr.mr_n65334640)
print v(xbgr.mr_n65405520)
print v(xbgr.mr_n65484288)
print v(xbgr.mr_n65503200)
print v(xbgr.mr_n65638128)
print v(xbgr.mr_n65699728)
print v(xbgr.mr_n65813424)
print v(xbgr.mr_n65916352)
print v(xbgr.mr_n66044000)
print v(xbgr.mr_n66160960)
print v(xbgr.mr_n66458896)
print v(xbgr.mr_n66508624)
print v(xbgr.mr_n66742128)
print v(xbgr.mr_n66881712)
print v(xbgr.mr_n67045520)
print v(xbgr.mr_n67187248)
print v(xbgr.mr_n67285776)
print v(xbgr.mr_n67471104)
print v(xbgr.mr_n67822768)
print v(xbgr.mr_n67992144)
print v(xbgr.mr_n68205328)
print v(xbgr.mr_n68339776)
print v(xbgr.mr_n68482112)
print v(xbgr.mr_n68675728)
print v(xbgr.mr_n68863072)
print v(xbgr.mr_n69045072)
print v(xbgr.mr_n69277088)
print v(xbgr.mr_n69640080)
print v(xbgr.mr_n69838400)
print v(xbgr.mr_n70044032)
print v(xbgr.mr_n70232016)
print v(xbgr.mr_n70535184)
print v(xbgr.mr_n70721200)
print v(xbgr.mr_n70950288)
print v(xbgr.mr_n71195072)
print v(xbgr.mr_n64784192)
print v(xbgr.mr_n64818496)
print v(xbgr.mr_n65049680)
print v(xbgr.mr_n65335232)
print v(xbgr.mr_n65413840)
print v(xbgr.mr_n65484464)
print v(xbgr.mr_n64629872)
print v(xbgr.mr_n65578416)
print v(xbgr.mr_n65650096)
print v(xbgr.mr_n65770112)
print v(xbgr.mr_n65888608)
print v(xbgr.mr_n66046992)
print v(xbgr.mr_n66098592)
print v(xbgr.mr_n66461504)
print v(xbgr.mr_n66540496)
print v(xbgr.mr_n66672064)
print v(xbgr.mr_n66821952)
print v(xbgr.mr_n66947776)
print v(xbgr.mr_n67072496)
print v(xbgr.mr_n67243792)
print v(xbgr.mr_n67466864)
print v(xbgr.mr_n64785008)
print v(xbgr.mr_n64789680)
print v(xbgr.mr_n65088992)
print v(xbgr.mr_n65335824)
print v(xbgr.mr_n65439728)
print v(xbgr.mr_n65496480)
print v(xbgr.mr_n65508000)
print v(xbgr.mr_n64615792)
print v(xbgr.mr_n65736384)
print v(xbgr.mr_n65850112)
print v(xbgr.mr_n64606432)
print v(xbgr.mr_n66060368)
print v(xbgr.mr_n66164336)
print v(xbgr.mr_n66472640)
print v(xbgr.mr_n66591408)
print v(xbgr.mr_n66760256)
print v(xbgr.mr_n66882688)
print v(xbgr.mr_n67073728)
print v(xbgr.mr_n67189056)
print v(xbgr.mr_n67268880)
print v(xbgr.mr_n67464912)
print v(xbgr.mr_n64785280)
print v(xbgr.mr_n64819616)
print v(xbgr.n_3)
print v(xbgr.n_33)
print v(xbgr.mr_n64785824)
print v(xbgr.mr_n64820272)
print v(xbgr.mr_n65100032)
print v(xbgr.mr_n65336928)
print v(xbgr.mr_n64786432)
print v(xbgr.mr_n64820864)
print v(xbgr.mr_n65100624)
print v(xbgr.mr_n65337600)
print v(xbgr.mr_n64787824)
print v(xbgr.mr_n64816720)
print v(xbgr.mr_n65101216)
print v(xbgr.mr_n65338192)
print v(xbgr.mr_n65410512)
print v(xbgr.mr_n65492848)
print v(xbgr.mr_n64593680)
print v(xbgr.mr_n65611040)
print v(xbgr.mr_n65704544)
print v(xbgr.mr_n65814608)
print v(xbgr.mr_n65889536)
print v(xbgr.mr_n66044112)
print v(xbgr.mr_n66162560)
print v(xbgr.mr_n66331936)
print v(xbgr.mr_n66469024)
print v(xbgr.mr_n66573504)
print v(xbgr.mr_n66741312)
print v(xbgr.mr_n66865136)
print v(xbgr.mr_n67046704)
print v(xbgr.mr_n67134256)
print v(xbgr.mr_n67296096)
print v(xbgr.mr_n67464800)
print v(xbgr.mr_n67820512)
print v(xbgr.mr_n68013184)
print v(xbgr.mr_n68216000)
print v(xbgr.mr_n68347216)
print v(xbgr.mr_n68484656)
print v(xbgr.mr_n68699584)
print v(xbgr.mr_n68900480)
print v(xbgr.mr_n69064336)
print v(xbgr.mr_n69274096)
print v(xbgr.mr_n69444256)
print v(xbgr.mr_n69637424)
print v(xbgr.mr_n69829744)
print v(xbgr.mr_n70066640)
print v(xbgr.mr_n64615584)
print v(xbgr.mr_n70546768)
print v(xbgr.mr_n70716544)
print v(xbgr.mr_n70945296)
print v(xbgr.mr_n71190240)
print v(xbgr.mr_n65408096)
print v(xbgr.mr_n65460144)
print v(xbgr.mr_n64600800)
print v(xbgr.mr_n65578880)
print v(xbgr.mr_n65649632)
print v(xbgr.mr_n65763520)
print v(xbgr.mr_n65888144)
print v(xbgr.mr_n66048304)
print v(xbgr.mr_n66099984)
print v(xbgr.mr_n66332128)
print v(xbgr.mr_n66471984)
print v(xbgr.mr_n66539904)
print v(xbgr.mr_n66671472)
print v(xbgr.mr_n66823728)
print v(xbgr.mr_n66947184)
print v(xbgr.mr_n67071568)
print v(xbgr.mr_n67245568)
print v(xbgr.mr_n67472944)
print v(xbgr.mr_n64788288)
print v(xbgr.n_19)
print v(xbgr.mr_n65098256)
print v(xbgr.mr_n65338784)
print v(xbgr.mr_n65442528)
print v(xbgr.mr_n65496880)
print v(xbgr.mr_n65509808)
print v(xbgr.mr_n64643952)
print v(xbgr.mr_n65737104)
print v(xbgr.mr_n65850512)
print v(xbgr.mr_n65918272)
print v(xbgr.mr_n66061744)
print v(xbgr.mr_n66165136)
print v(xbgr.mr_n66342112)
print v(xbgr.mr_n66474704)
print v(xbgr.mr_n66593216)
print v(xbgr.mr_n66761056)
print v(xbgr.mr_n66883488)
print v(xbgr.mr_n66948960)
print v(xbgr.mr_n67188944)
print v(xbgr.mr_n67292480)
print v(xbgr.mr_n67466976)
print v(xbgr.mr_n64789216)
print v(xbgr.mr_n64791536)
print v(xbgr.mr_n65099440)
print v(xbgr.mr_n65339376)
print v(xbgr.mr_n64790144)
print v(xbgr.mr_n64823168)
print v(xbgr.mr_n65096880)
print v(xbgr.mr_n65339968)
print v(xbgr.mr_n64781200)
print v(xbgr.mr_n64783648)
print v(xbgr.mr_n65095360)
print v(xbgr.mr_n65340560)
print v(xbgr.mr_n64791072)
print v(xbgr.mr_n64824416)
print v(xbgr.mr_n65104112)
print v(xbgr.mr_n65341152)
print v(xbgr.mr_n65415504)
print v(xbgr.mr_n65485344)
print v(xbgr.mr_n65503312)
print v(xbgr.mr_n65580368)
print v(xbgr.mr_n65705872)
print v(xbgr.mr_n65815792)
print v(xbgr.mr_n65921408)
print v(xbgr.mr_n66046816)
print v(xbgr.mr_n66103888)
print v(xbgr.mr_n66332832)
print v(xbgr.mr_n66469920)
print v(xbgr.mr_n66584480)
print v(xbgr.mr_n66738016)
print v(xbgr.mr_n66865248)
print v(xbgr.mr_n67047296)
print v(xbgr.mr_n67192560)
print v(xbgr.mr_n67297904)
print v(xbgr.mr_n67470992)
print v(xbgr.mr_n64790608)
print v(xbgr.mr_n64825008)
print v(xbgr.mr_n65091808)
print v(xbgr.mr_n65341744)
print v(xbgr.mr_n67817216)
print v(xbgr.mr_n68017968)
print v(xbgr.mr_n68210912)
print v(xbgr.mr_n68355456)
print v(xbgr.mr_n68522576)
print v(xbgr.mr_n68686672)
print v(xbgr.mr_n68887216)
print v(xbgr.mr_n69054320)
print v(xbgr.mr_n69178912)
print v(xbgr.mr_n69447456)
print v(xbgr.mr_n69653536)
print v(xbgr.mr_n69849536)
print v(xbgr.mr_n70041584)
print v(xbgr.mr_n70238224)
print v(xbgr.mr_n70569456)
print v(xbgr.mr_n70730512)
print v(xbgr.mr_n70923216)
print v(xbgr.mr_n71143728)
print v(xbgr.mr_n65418832)
print v(xbgr.mr_n65459872)
print v(xbgr.mr_n65314176)
print v(xbgr.mr_n65577952)
print v(xbgr.mr_n65648704)
print v(xbgr.mr_n65772112)
print v(xbgr.mr_n65887216)
print v(xbgr.mr_n66048960)
print v(xbgr.mr_n66136448)
print v(xbgr.mr_n66300800)
print v(xbgr.mr_n66473152)
print v(xbgr.mr_n66538720)
print v(xbgr.mr_n66670288)
print v(xbgr.mr_n66825504)
print v(xbgr.mr_n66946000)
print v(xbgr.mr_n67075552)
print v(xbgr.mr_n67247344)
print v(xbgr.mr_n67468928)
print v(xbgr.mr_n64783376)
print v(xbgr.mr_n64825600)
print v(xbgr.mr_n65101808)
print v(xbgr.mr_n65342336)
print v(xbgr.mr_n65443584)
print v(xbgr.mr_n65497520)
print v(xbgr.mr_n65511536)
print v(xbgr.mr_n65588592)
print v(xbgr.mr_n65737504)
print v(xbgr.mr_n65850912)
print v(xbgr.mr_n65925744)
print v(xbgr.mr_n66062704)
print v(xbgr.mr_n66165936)
print v(xbgr.mr_n66345408)
print v(xbgr.mr_n66476688)
print v(xbgr.mr_n66594944)
print v(xbgr.mr_n66761856)
print v(xbgr.mr_n66884288)
print v(xbgr.mr_n67078016)
print v(xbgr.mr_n67111552)
print v(xbgr.mr_n67297792)
print v(xbgr.mr_n67470880)
print v(xbgr.mr_n64788752)
print v(xbgr.mr_n64826192)
print v(xbgr.mr_n65102992)
print v(xbgr.mr_n65342928)
print v(xbgr.mr_n64787360)
print v(xbgr.mr_n64826784)
print v(xbgr.n_4)
print v(xbgr.n_30)
print v(xbgr.mr_n64778944)
print v(xbgr.mr_n64821456)
print v(xbgr.mr_n65107136)
print v(xbgr.mr_n65344112)
print v(xbgr.mr_n64778832)
print v(xbgr.mr_n64782832)
print v(xbgr.mr_n65107728)
print v(xbgr.mr_n65344704)
print v(xbgr.mr_n65413088)
print v(xbgr.mr_n65492176)
print v(xbgr.mr_n65504096)
print v(xbgr.mr_n65552256)
print v(xbgr.mr_n65710688)
print v(xbgr.mr_n65816976)
print v(xbgr.mr_n65924128)
print v(xbgr.mr_n65979216)
print v(xbgr.mr_n66077120)
print v(xbgr.mr_n66304464)
print v(xbgr.mr_n66475216)
print v(xbgr.mr_n66571344)
print v(xbgr.mr_n66760080)
print v(xbgr.mr_n66883312)
print v(xbgr.mr_n67046112)
print v(xbgr.mr_n67194368)
print v(xbgr.mr_n67299600)
print v(xbgr.mr_n67469040)
print v(xbgr.mr_n67567232)
print v(xbgr.mr_n68023744)
print v(xbgr.mr_n68227136)
print v(xbgr.mr_n68355920)
print v(xbgr.mr_n68493600)
print v(xbgr.mr_n68717456)
print v(xbgr.mr_n68911616)
print v(xbgr.mr_n69020000)
print v(xbgr.mr_n69182336)
print v(xbgr.mr_n69466304)
print v(xbgr.mr_n69614240)
print v(xbgr.mr_n69831952)
print v(xbgr.mr_n70056848)
print v(xbgr.mr_n70245088)
print v(xbgr.mr_n70559136)
print v(xbgr.mr_n70735168)
print v(xbgr.mr_n70942320)
print v(xbgr.mr_n71112624)
print v(xbgr.mr_n64785552)
print v(xbgr.mr_n64571264)
print v(xbgr.mr_n65108320)
print v(xbgr.mr_n65345296)
print v(xbgr.mr_n65419744)
print v(xbgr.mr_n65459600)
print v(xbgr.mr_n64884448)
print v(xbgr.mr_n65577488)
print v(xbgr.mr_n65648240)
print v(xbgr.mr_n65755760)
print v(xbgr.mr_n65886752)
print v(xbgr.mr_n66047648)
print v(xbgr.mr_n66080288)
print v(xbgr.mr_n66190208)
print v(xbgr.mr_n66476112)
print v(xbgr.mr_n66538128)
print v(xbgr.mr_n66669696)
print v(xbgr.mr_n66827280)
print v(xbgr.mr_n66945408)
print v(xbgr.mr_n67077264)
print v(xbgr.mr_n67249120)
print v(xbgr.mr_n67475008)
print v(xbgr.mr_n64784736)
print v(xbgr.mr_n64573632)
print v(xbgr.mr_n65102400)
print v(xbgr.mr_n65345888)
print v(xbgr.mr_n65445440)
print v(xbgr.mr_n65498320)
print v(xbgr.mr_n65513424)
print v(xbgr.mr_n65598256)
print v(xbgr.mr_n65736704)
print v(xbgr.mr_n65844976)
print v(xbgr.mr_n65920272)
print v(xbgr.mr_n66063680)
print v(xbgr.mr_n66166496)
print v(xbgr.mr_n66347216)
print v(xbgr.mr_n66478832)
print v(xbgr.mr_n66585616)
print v(xbgr.mr_n66762656)
print v(xbgr.mr_n66885088)
print v(xbgr.mr_n67078896)
print v(xbgr.mr_n67190752)
print v(xbgr.mr_n67299712)
print v(xbgr.mr_n67473056)
print v(xbgr.mr_n64784464)
print v(xbgr.mr_n64566320)
print v(xbgr.mr_n65105952)
print v(xbgr.mr_n65346480)
print v(xbgr.mr_n64783920)
print v(xbgr.mr_n64822640)
print v(xbgr.mr_n65106544)
print v(xbgr.mr_n65347072)
print v(xbgr.mr_n64768768)
print v(xbgr.mr_n64612064)
print v(xbgr.mr_n65097792)
print v(xbgr.mr_n65347664)
print v(xbgr.mr_n65423824)
print v(xbgr.mr_n65485696)
print v(xbgr.mr_n65506288)
print v(xbgr.mr_n65598368)
print v(xbgr.mr_n65712016)
print v(xbgr.mr_n65818160)
print v(xbgr.mr_n65923200)
print v(xbgr.mr_n65889696)
print v(xbgr.mr_n66160096)
print v(xbgr.mr_n66332320)
print v(xbgr.mr_n66474048)
print v(xbgr.mr_n66505664)
print v(xbgr.mr_n66759280)
print v(xbgr.mr_n66880912)
print v(xbgr.mr_n67044928)
print v(xbgr.mr_n67192672)
print v(xbgr.mr_n67295984)
print v(xbgr.mr_n67477184)
print v(xbgr.mr_n64780112)
print v(xbgr.mr_n64608544)
print v(xbgr.mr_n65111216)
print v(xbgr.mr_n65348256)
print v(xbgr.mr_n67810160)
print v(xbgr.mr_n68016528)
print v(xbgr.mr_n68223616)
print v(xbgr.mr_n68346272)
print v(xbgr.mr_n68498256)
print v(xbgr.mr_n68705744)
print v(xbgr.mr_n68883152)
print v(xbgr.mr_n69063632)
print v(xbgr.mr_n66163360)
print v(xbgr.mr_n69182448)
print v(xbgr.mr_n69476240)
print v(xbgr.mr_n69622464)
print v(xbgr.mr_n69862992)
print v(xbgr.mr_n70031792)
print v(xbgr.mr_n70249952)
print v(xbgr.mr_n70560992)
print v(xbgr.mr_n70749600)
print v(xbgr.mr_n70942512)
print v(xbgr.mr_n71175456)
print v(xbgr.mr_n65418080)
print v(xbgr.mr_n65459328)
print v(xbgr.mr_n64685920)
print v(xbgr.mr_n65576560)
print v(xbgr.mr_n65647312)
print v(xbgr.mr_n65725728)
print v(xbgr.mr_n65885824)
print v(xbgr.mr_n66044304)
print v(xbgr.mr_n66051936)
print v(xbgr.mr_n66466960)
print v(xbgr.mr_n66536944)
print v(xbgr.mr_n66668512)
print v(xbgr.mr_n66826448)
print v(xbgr.mr_n66944224)
print v(xbgr.mr_n67075664)
print v(xbgr.mr_n67286944)
print v(xbgr.mr_n67477072)
print v(xbgr.mr_n64782288)
print v(xbgr.mr_n64605728)
print v(xbgr.mr_n65111872)
print v(xbgr.mr_n65348848)
print v(xbgr.mr_n65444208)
print v(xbgr.mr_n65499120)
print v(xbgr.mr_n65515232)
print v(xbgr.mr_n65584080)
print v(xbgr.mr_n65735984)
print v(xbgr.mr_n65851712)
print v(xbgr.mr_n65928272)
print v(xbgr.mr_n66064560)
print v(xbgr.mr_n66159312)
print v(xbgr.mr_n66349024)
print v(xbgr.mr_n66458560)
print v(xbgr.mr_n66598560)
print v(xbgr.mr_n66763456)
print v(xbgr.mr_n66885888)
print v(xbgr.mr_n67081280)
print v(xbgr.mr_n67196288)
print v(xbgr.mr_n67301408)
print v(xbgr.mr_n67475232)
print v(xbgr.mr_n64781744)
print v(xbgr.mr_n64562672)
print v(xbgr.mr_n65104768)
print v(xbgr.mr_n65349440)
print v(xbgr.mr_n64773712)
print v(xbgr.mr_n64563376)
print v(xbgr.mr_n65110032)
print v(xbgr.mr_n65350032)
print v(xbgr.mr_n64780656)
print v(xbgr.mr_n64629664)
print v(xbgr.n_5)
print v(xbgr.mr_n65350624)
print v(xbgr.mr_n64779840)
print v(xbgr.mr_n64597152)
print v(xbgr.mr_n65114240)
print v(xbgr.mr_n65336416)
print v(xbgr.mr_n65414752)
print v(xbgr.mr_n65498144)
print v(xbgr.mr_n65311440)
print v(xbgr.mr_n65554752)
print v(xbgr.mr_n65686992)
print v(xbgr.mr_n65819344)
print v(xbgr.mr_n65913312)
print v(xbgr.mr_n65899456)
print v(xbgr.mr_n66189712)
print v(xbgr.mr_n66334800)
print v(xbgr.mr_n66339808)
print v(xbgr.mr_n66591920)
print v(xbgr.mr_n66738720)
print v(xbgr.mr_n66864784)
print v(xbgr.mr_n67043744)
print v(xbgr.mr_n67185440)
print v(xbgr.mr_n67303216)
print v(xbgr.mr_n67479360)
print v(xbgr.mr_n67800048)
print v(xbgr.mr_n68006352)
print v(xbgr.mr_n68238272)
print v(xbgr.mr_n68367056)
print v(xbgr.mr_n68502912)
print v(xbgr.mr_n68683536)
print v(xbgr.mr_n68895504)
print v(xbgr.mr_n69072544)
print v(xbgr.mr_n66189040)
print v(xbgr.mr_n69171088)
print v(xbgr.mr_n69481104)
print v(xbgr.mr_n69617952)
print v(xbgr.mr_n69844096)
print v(xbgr.mr_n70027984)
print v(xbgr.mr_n70255040)
print v(xbgr.mr_n70579040)
print v(xbgr.mr_n70744944)
print v(xbgr.mr_n70944832)
print v(xbgr.mr_n71120128)
print v(xbgr.mr_n64778560)
print v(xbgr.mr_n64639552)
print v(xbgr.mr_n65114832)
print v(xbgr.mr_n65351728)
print v(xbgr.mr_n65422880)
print v(xbgr.mr_n65459056)
print v(xbgr.mr_n64569680)
print v(xbgr.mr_n65576096)
print v(xbgr.mr_n65646848)
print v(xbgr.mr_n65726240)
print v(xbgr.mr_n65885440)
print v(xbgr.mr_n65900704)
print v(xbgr.mr_n66194848)
print v(xbgr.mr_n66465152)
print v(xbgr.mr_n66536352)
print v(xbgr.mr_n66667920)
print v(xbgr.mr_n66830368)
print v(xbgr.mr_n66943632)
print v(xbgr.mr_n67077440)
print v(xbgr.mr_n67294176)
print v(xbgr.mr_n67473168)
print v(xbgr.mr_n64778288)
print v(xbgr.mr_n64643744)
print v(xbgr.mr_n65110688)
print v(xbgr.mr_n65352400)
print v(xbgr.mr_n65448272)
print v(xbgr.mr_n65497344)
print v(xbgr.mr_n65517040)
print v(xbgr.mr_n65551296)
print v(xbgr.mr_n65735184)
print v(xbgr.mr_n65852112)
print v(xbgr.mr_n65933600)
print v(xbgr.mr_n66064384)
print v(xbgr.mr_n66159920)
print v(xbgr.mr_n66350832)
print v(xbgr.mr_n66482960)
print v(xbgr.mr_n66600368)
print v(xbgr.mr_n66764256)
print v(xbgr.mr_n66886688)
print v(xbgr.mr_n67082240)
print v(xbgr.mr_n67197984)
print v(xbgr.mr_n67288864)
print v(xbgr.mr_n67477296)
print v(xbgr.mr_n64739536)
print v(xbgr.mr_n64945616)
print v(xbgr.mr_n65112464)
print v(xbgr.mr_n65352992)
print v(xbgr.mr_n64740000)
print v(xbgr.mr_n64946208)
print v(xbgr.mr_n65113056)
print v(xbgr.mr_n65353584)
print v(xbgr.mr_n64715504)
print v(xbgr.mr_n64946800)
print v(xbgr.mr_n65113648)
print v(xbgr.mr_n65351216)
print v(xbgr.mr_n64740928)
print v(xbgr.mr_n64947392)
print v(xbgr.mr_n65117792)
print v(xbgr.mr_n65354688)
print v(xbgr.mr_n65417776)
print v(xbgr.mr_n65493184)
print v(xbgr.mr_n64592464)
print v(xbgr.mr_n65636768)
print v(xbgr.mr_n65687248)
print v(xbgr.mr_n65820528)
print v(xbgr.mr_n65924240)
print v(xbgr.mr_n66043680)
print v(xbgr.mr_n66159744)
print v(xbgr.mr_n66301584)
print v(xbgr.mr_n66480240)
print v(xbgr.mr_n66587856)
print v(xbgr.mr_n66763280)
print v(xbgr.mr_n66884112)
print v(xbgr.mr_n67042560)
print v(xbgr.mr_n67198096)
print v(xbgr.mr_n67303328)
print v(xbgr.mr_n67481312)
print v(xbgr.mr_n67568224)
print v(xbgr.mr_n67998320)
print v(xbgr.mr_n68229456)
print v(xbgr.mr_n68360432)
print v(xbgr.mr_n68520064)
print v(xbgr.mr_n68681536)
print v(xbgr.mr_n68878992)
print v(xbgr.mr_n69077008)
print v(xbgr.mr_n66204144)
print v(xbgr.mr_n69176768)
print v(xbgr.mr_n69486080)
print v(xbgr.mr_n69622736)
print v(xbgr.mr_n69831488)
print v(xbgr.mr_n70020672)
print v(xbgr.mr_n70267776)
print v(xbgr.mr_n70568944)
print v(xbgr.mr_n70758912)
print v(xbgr.mr_n70945808)
print v(xbgr.mr_n71121552)
print v(xbgr.mr_n65417888)
print v(xbgr.mr_n65458784)
print v(xbgr.mr_n64562176)
print v(xbgr.mr_n65575168)
print v(xbgr.mr_n65645920)
print v(xbgr.mr_n65727424)
print v(xbgr.mr_n65884832)
print v(xbgr.mr_n65837744)
print v(xbgr.mr_n65725120)
print v(xbgr.mr_n66482304)
print v(xbgr.mr_n66535360)
print v(xbgr.mr_n66666928)
print v(xbgr.mr_n66830976)
print v(xbgr.mr_n66942448)
print v(xbgr.mr_n67080448)
print v(xbgr.mr_n67294288)
print v(xbgr.mr_n67475120)
print v(xbgr.mr_n64741392)
print v(xbgr.mr_n64947984)
print v(xbgr.mr_n65118384)
print v(xbgr.mr_n65355360)
print v(xbgr.mr_n64741856)
print v(xbgr.mr_n64948576)
print v(xbgr.mr_n65118976)
print v(xbgr.mr_n65355952)
print v(xbgr.mr_n65449408)
print v(xbgr.mr_n65500720)
print v(xbgr.mr_n65518848)
print v(xbgr.mr_n65635728)
print v(xbgr.mr_n65734384)
print v(xbgr.mr_n65852512)
print v(xbgr.mr_n65931040)
print v(xbgr.mr_n66066176)
print v(xbgr.mr_n66189376)
print v(xbgr.mr_n66349536)
print v(xbgr.mr_n66485024)
print v(xbgr.mr_n66602256)
print v(xbgr.mr_n66765056)
print v(xbgr.mr_n66887488)
print v(xbgr.mr_n67083904)
print v(xbgr.mr_n67187136)
print v(xbgr.mr_n67305024)
print v(xbgr.mr_n67481200)
print v(xbgr.mr_n64742320)
print v(xbgr.mr_n64949168)
print v(xbgr.mr_n65116608)
print v(xbgr.mr_n65356544)
print v(xbgr.mr_n64742784)
print v(xbgr.mr_n64940880)
print v(xbgr.mr_n65117200)
print v(xbgr.mr_n65357136)
print v(xbgr.mr_n64733120)
print v(xbgr.mr_n64876720)
print v(xbgr.mr_n65105296)
print v(xbgr.n_31)
print v(xbgr.mr_n65412784)
print v(xbgr.mr_n65500544)
print v(xbgr.mr_n65515744)
print v(xbgr.mr_n65634528)
print v(xbgr.mr_n64679840)
print v(xbgr.mr_n65821712)
print v(xbgr.mr_n65926464)
print v(xbgr.mr_n66017600)
print v(xbgr.mr_n66201344)
print v(xbgr.mr_n66341248)
print v(xbgr.mr_n66481408)
print v(xbgr.mr_n66597344)
print v(xbgr.mr_n66764080)
print v(xbgr.mr_n66884912)
print v(xbgr.mr_n67041376)
print v(xbgr.mr_n67194480)
print v(xbgr.mr_n67309376)
print v(xbgr.mr_n67483376)
print v(xbgr.mr_n64743712)
print v(xbgr.mr_n64950944)
print v(xbgr.mr_n65108912)
print v(xbgr.mr_n65358320)
print v(xbgr.mr_n67797600)
print v(xbgr.mr_n67947424)
print v(xbgr.mr_n68218320)
print v(xbgr.mr_n68349296)
print v(xbgr.mr_n68535968)
print v(xbgr.mr_n68670400)
print v(xbgr.mr_n68873744)
print v(xbgr.mr_n69077472)
print v(xbgr.mr_n66198272)
print v(xbgr.mr_n69179024)
print v(xbgr.mr_n69491168)
print v(xbgr.mr_n69620608)
print v(xbgr.mr_n69822512)
print v(xbgr.mr_n69970560)
print v(xbgr.mr_n70264880)
print v(xbgr.mr_n70541088)
print v(xbgr.mr_n70744480)
print v(xbgr.mr_n70946528)
print v(xbgr.mr_n71180736)
print v(xbgr.mr_n65412896)
print v(xbgr.mr_n65458592)
print v(xbgr.mr_n64638320)
print v(xbgr.mr_n65574704)
print v(xbgr.mr_n65645456)
print v(xbgr.mr_n65568256)
print v(xbgr.mr_n65884528)
print v(xbgr.mr_n65969952)
print v(xbgr.mr_n65726848)
print v(xbgr.mr_n66478176)
print v(xbgr.mr_n66534896)
print v(xbgr.mr_n66666464)
print v(xbgr.mr_n66830640)
print v(xbgr.mr_n66941856)
print v(xbgr.mr_n67078720)
print v(xbgr.mr_n67305248)
print v(xbgr.mr_n67479136)
print v(xbgr.mr_n64734960)
print v(xbgr.mr_n64951536)
print v(xbgr.mr_n65121872)
print v(xbgr.mr_n65320176)
print v(xbgr.mr_n65450864)
print v(xbgr.mr_n65501520)
print v(xbgr.mr_n65513936)
print v(xbgr.mr_n65600912)
print v(xbgr.mr_n65716832)
print v(xbgr.mr_n65852912)
print v(xbgr.mr_n65932704)
print v(xbgr.mr_n66067392)
print v(xbgr.mr_n66198944)
print v(xbgr.mr_n66354448)
print v(xbgr.mr_n66484368)
print v(xbgr.mr_n66603984)
print v(xbgr.mr_n66765856)
print v(xbgr.mr_n66888288)
print v(xbgr.mr_n67085648)
print v(xbgr.mr_n67196176)
print v(xbgr.mr_n67307088)
print v(xbgr.mr_n67483264)
print v(xbgr.mr_n64744640)
print v(xbgr.mr_n64952128)
print v(xbgr.mr_n65109504)
print v(xbgr.mr_n65359424)
print v(xbgr.mr_n64745104)
print v(xbgr.n_34)
print v(xbgr.mr_n65119568)
print v(xbgr.mr_n65354176)
print v(xbgr.mr_n64745568)
print v(xbgr.mr_n64953248)
print v(xbgr.mr_n65120752)
print v(xbgr.mr_n65360656)
print v(xbgr.mr_n64746032)
print v(xbgr.mr_n64953904)
print v(xbgr.mr_n65115424)
print v(xbgr.mr_n65361216)
print v(xbgr.mr_n65407792)
print v(xbgr.mr_n65501344)
print v(xbgr.mr_n65508512)
print v(xbgr.mr_n65633568)
print v(xbgr.mr_n65651024)
print v(xbgr.mr_n65822896)
print v(xbgr.mr_n65938608)
print v(xbgr.mr_n66017344)
print v(xbgr.mr_n66188544)
print v(xbgr.mr_n66342896)
print v(xbgr.mr_n66483472)
print v(xbgr.mr_n66595536)
print v(xbgr.mr_n66762480)
print v(xbgr.mr_n66886512)
print v(xbgr.mr_n66972576)
print v(xbgr.mr_n67201712)
print v(xbgr.mr_n67307200)
print v(xbgr.mr_n67483488)
print v(xbgr.mr_n67787344)
print v(xbgr.mr_n67981904)
print v(xbgr.mr_n68072176)
print v(xbgr.mr_n68343152)
print v(xbgr.mr_n68530848)
print v(xbgr.mr_n68661200)
print v(xbgr.mr_n68862608)
print v(xbgr.mr_n69089024)
print v(xbgr.mr_n66190592)
print v(xbgr.mr_n69176576)
print v(xbgr.mr_n69496032)
print v(xbgr.mr_n69620720)
print v(xbgr.mr_n69801280)
print v(xbgr.mr_n70006768)
print v(xbgr.mr_n70269968)
print v(xbgr.mr_n70529072)
print v(xbgr.mr_n70753792)
print v(xbgr.mr_n70650384)
print v(xbgr.mr_n71133168)
print v(xbgr.mr_n64746496)
print v(xbgr.mr_n64954496)
print v(xbgr.mr_n65124896)
print v(xbgr.mr_n65361808)
print v(xbgr.mr_n65407904)
print v(xbgr.mr_n65457200)
print v(xbgr.mr_n64600432)
print v(xbgr.mr_n65573776)
print v(xbgr.mr_n65644528)
print v(xbgr.mr_n65680256)
print v(xbgr.mr_n65851312)
print v(xbgr.mr_n65969648)
print v(xbgr.mr_n66155872)
print v(xbgr.mr_n66471088)
print v(xbgr.mr_n66533968)
print v(xbgr.mr_n66665536)
print v(xbgr.mr_n66830096)
print v(xbgr.mr_n66940736)
print v(xbgr.mr_n67080704)
print v(xbgr.mr_n67301520)
print v(xbgr.mr_n67485328)
print v(xbgr.mr_n64729408)
print v(xbgr.mr_n64949760)
print v(xbgr.mr_n65125488)
print v(xbgr.mr_n65362400)
print v(xbgr.mr_n65452320)
print v(xbgr.mr_n65502320)
print v(xbgr.mr_n65522384)
print v(xbgr.mr_n65637664)
print v(xbgr.mr_n65718160)
print v(xbgr.mr_n65853312)
print v(xbgr.mr_n65938384)
print v(xbgr.mr_n66068272)
print v(xbgr.mr_n66210848)
print v(xbgr.mr_n66356256)
print v(xbgr.mr_n66489152)
print v(xbgr.mr_n66605872)
print v(xbgr.mr_n66766656)
print v(xbgr.mr_n66889088)
print v(xbgr.mr_n67087248)
print v(xbgr.mr_n67190864)
print v(xbgr.mr_n67309152)
print v(xbgr.mr_n67479248)
print v(xbgr.mr_n64747424)
print v(xbgr.mr_n64955616)
print v(xbgr.mr_n65126080)
print v(xbgr.mr_n65362992)
print v(xbgr.mr_n64747888)
print v(xbgr.mr_n64956272)
print v(xbgr.mr_n65120160)
print v(xbgr.mr_n65363584)
print v(xbgr.mr_n64748352)
print v(xbgr.mr_n64956864)
print v(xbgr.mr_n65123712)
print v(xbgr.mr_n65364176)
print v(xbgr.mr_n64744176)
print v(xbgr.mr_n64957456)
print v(xbgr.n_10)
print v(xbgr.mr_n65364768)
print v(xbgr.mr_n65402800)
print v(xbgr.mr_n64895696)
print v(xbgr.mr_n64647472)
print v(xbgr.mr_n65546880)
print v(xbgr.mr_n65686736)
print v(xbgr.mr_n65824080)
print v(xbgr.mr_n65936688)
print v(xbgr.mr_n65960080)
print v(xbgr.mr_n66188032)
print v(xbgr.mr_n66352400)
print v(xbgr.mr_n66486848)
print v(xbgr.mr_n66599152)
print v(xbgr.mr_n66765680)
print v(xbgr.mr_n66888912)
print v(xbgr.mr_n66882512)
print v(xbgr.mr_n67203520)
print v(xbgr.mr_n67307312)
print v(xbgr.mr_n67485440)
print v(xbgr.mr_n67798160)
print v(xbgr.mr_n67979792)
print v(xbgr.mr_n68200352)
print v(xbgr.mr_n68328112)
print v(xbgr.mr_n68512224)
print v(xbgr.mr_n68651184)
print v(xbgr.mr_n68854016)
print v(xbgr.mr_n69094000)
print v(xbgr.mr_n66217392)
print v(xbgr.mr_n69176000)
print v(xbgr.mr_n69501008)
print v(xbgr.mr_n69622928)
print v(xbgr.mr_n69798112)
print v(xbgr.mr_n70011680)
print v(xbgr.mr_n70274944)
print v(xbgr.mr_n70409328)
print v(xbgr.mr_n70636144)
print v(xbgr.mr_n70642448)
print v(xbgr.mr_n71120768)
print v(xbgr.mr_n65402912)
print v(xbgr.mr_n65458128)
print v(xbgr.mr_n64710032)
print v(xbgr.mr_n65573312)
print v(xbgr.mr_n65644064)
print v(xbgr.mr_n65680064)
print v(xbgr.mr_n65690512)
print v(xbgr.mr_n65943488)
print v(xbgr.mr_n66261296)
print v(xbgr.mr_n66477280)
print v(xbgr.mr_n66533504)
print v(xbgr.mr_n66665072)
print v(xbgr.mr_n66821120)
print v(xbgr.mr_n66940272)
print v(xbgr.mr_n67087760)
print v(xbgr.mr_n67309264)
print v(xbgr.mr_n67488096)
print v(xbgr.mr_n64749280)
print v(xbgr.mr_n64958048)
print v(xbgr.mr_n65115952)
print v(xbgr.mr_n65365360)
print v(xbgr.mr_n64749744)
print v(xbgr.mr_n64958640)
print v(xbgr.mr_n65128976)
print v(xbgr.mr_n65365952)
print v(xbgr.mr_n65454176)
print v(xbgr.mr_n64911504)
print v(xbgr.mr_n65524192)
print v(xbgr.mr_n65635264)
print v(xbgr.mr_n65731984)
print v(xbgr.mr_n65853712)
print v(xbgr.mr_n65938496)
print v(xbgr.mr_n66069248)
print v(xbgr.mr_n66204688)
print v(xbgr.mr_n66357984)
print v(xbgr.mr_n66491216)
print v(xbgr.mr_n66607680)
print v(xbgr.mr_n66767456)
print v(xbgr.mr_n66889888)
print v(xbgr.mr_n67088592)
print v(xbgr.mr_n67205216)
print v(xbgr.mr_n67305136)
print v(xbgr.mr_n67485552)
print v(xbgr.mr_n64750208)
print v(xbgr.mr_n64959232)
print v(xbgr.mr_n65129632)
print v(xbgr.mr_n65366544)
print v(xbgr.mr_n64750672)
print v(xbgr.mr_n64959824)
print v(xbgr.mr_n65122528)
print v(xbgr.mr_n65367136)
print v(xbgr.mr_n64751136)
print v(xbgr.mr_n64960416)
print v(xbgr.mr_n65130816)
print v(xbgr.mr_n65367728)
print v(xbgr.mr_n65386848)
print v(xbgr.mr_n65499920)
print v(xbgr.mr_n65517552)
print v(xbgr.mr_n65583744)
print v(xbgr.mr_n64703712)
print v(xbgr.mr_n65825264)
print v(xbgr.mr_n65943600)
print v(xbgr.mr_n66017152)
print v(xbgr.mr_n66212464)
print v(xbgr.mr_n66351344)
print v(xbgr.mr_n66487600)
print v(xbgr.mr_n66604576)
print v(xbgr.mr_n66757680)
print v(xbgr.mr_n66888112)
print v(xbgr.mr_n66971872)
print v(xbgr.mr_n67199904)
print v(xbgr.mr_n67315568)
print v(xbgr.mr_n67488576)
print v(xbgr.mr_n64738608)
print v(xbgr.mr_n64930320)
print v(xbgr.mr_n65121344)
print v(xbgr.mr_n64919536)
print v(xbgr.mr_n67797216)
print v(xbgr.mr_n67970192)
print v(xbgr.mr_n68191088)
print v(xbgr.mr_n68323456)
print v(xbgr.mr_n68559824)
print v(xbgr.mr_n68617504)
print v(xbgr.mr_n68825104)
print v(xbgr.mr_n69098976)
print v(xbgr.mr_n66193936)
print v(xbgr.mr_n69176192)
print v(xbgr.mr_n69461712)
print v(xbgr.mr_n69609248)
print v(xbgr.mr_n69765360)
print v(xbgr.mr_n70016880)
print v(xbgr.mr_n70178432)
print v(xbgr.mr_n70410800)
print v(xbgr.mr_n70638992)
print v(xbgr.mr_n70918432)
print v(xbgr.mr_n71122992)
print v(xbgr.mr_n65398176)
print v(xbgr.mr_n65456464)
print v(xbgr.mr_n64889856)
print v(xbgr.mr_n65572384)
print v(xbgr.mr_n65586880)
print v(xbgr.mr_n65727904)
print v(xbgr.mr_n65667808)
print v(xbgr.mr_n65961648)
print v(xbgr.mr_n66307168)
print v(xbgr.mr_n66382432)
print v(xbgr.mr_n66508272)
print v(xbgr.mr_n66635424)
print v(xbgr.mr_n66828224)
print v(xbgr.mr_n66880112)
print v(xbgr.mr_n67088256)
print v(xbgr.mr_n67311440)
print v(xbgr.mr_n67496064)
print v(xbgr.mr_n64740464)
print v(xbgr.mr_n64961536)
print v(xbgr.mr_n65132000)
print v(xbgr.mr_n65086688)
print v(xbgr.mr_n65455232)
print v(xbgr.mr_n65488640)
print v(xbgr.mr_n65526080)
print v(xbgr.mr_n65632304)
print v(xbgr.mr_n65714064)
print v(xbgr.mr_n65854112)
print v(xbgr.mr_n65943376)
print v(xbgr.mr_n66069888)
print v(xbgr.mr_n66197296)
print v(xbgr.mr_n66345920)
print v(xbgr.mr_n66493024)
print v(xbgr.mr_n66609408)
print v(xbgr.mr_n66768256)
print v(xbgr.mr_n66890688)
print v(xbgr.mr_n67091456)
print v(xbgr.mr_n67207024)
print v(xbgr.mr_n67313280)
print v(xbgr.mr_n67492080)
print v(xbgr.mr_n64737680)
print v(xbgr.mr_n64962192)
print v(xbgr.mr_n65132592)
print v(xbgr.mr_n65271408)
print v(xbgr.mr_n64752992)
print v(xbgr.mr_n64565520)
print v(xbgr.mr_n65128448)
print v(xbgr.mr_n65273424)
print v(xbgr.mr_n64753456)
print v(xbgr.mr_n64918528)
print v(xbgr.mr_n65130224)
print v(xbgr.mr_n65270288)
print v(xbgr.mr_n64753920)
print v(xbgr.mr_n51462800)
print v(xbgr.mr_n65127792)
print v(xbgr.mr_n65329904)
print v(xbgr.mr_n64754384)
print v(xbgr.mr_n64922560)
print v(xbgr.mr_n65131408)
print v(xbgr.mr_n65222304)
print v(xbgr.mr_n64752528)
print v(xbgr.mr_n64931440)
print v(xbgr.mr_n65135552)
print v(xbgr.mr_n65320000)
print v(xbgr.mr_n64755312)
print v(xbgr.mr_n64955088)
print v(xbgr.mr_n65136144)
print v(xbgr.mr_n65315888)
print v(xbgr.mr_n64755776)
print v(xbgr.mr_n64870096)
print v(xbgr.mr_n65136736)
print v(xbgr.mr_n65175824)
print v(xbgr.mr_n65610848)
print v(xbgr.mr_n67090448)
print v(xbgr.mr_n67311328)
print v(xbgr.mr_n67496544)
print v(xbgr.mr_n64756240)
print v(xbgr.mr_n64620512)
print v(xbgr.mr_n65134368)
print v(xbgr.mr_n65241296)
print v(xbgr.d5)
print v(xbgr.d1)
print v(xbgr.mr_n65583200)
print v(xbgr.mr_n65943872)
print v(xbgr.mr_n65452944)
print v(xbgr.mr_n65520496)
print v(xbgr.mr_n65946400)
print v(xbgr.mr_n67089328)
print v(xbgr.n1)
print v(xbgr.mr_n67496176)
print v(xbgr.mr_n64756704)
print v(xbgr.mr_n64619104)
print v(xbgr.mr_n65134960)
print v(xbgr.mr_n65243120)
print v(xbgr.mr_n66887312)
print v(xbgr.mr_n67116432)
print v(xbgr.mr_n67330752)
print v(xbgr.mr_n65395392)
print v(xbgr.mr_n65488368)
print v(xbgr.kick)
print v(xbgr.mr_n65784336)
print v(xbgr.mr_n67089216)
print v(xbgr.mr_n67032256)
print v(xbgr.mr_n67488208)
print v(xbgr.mr_n64746960)
print v(xbgr.mr_n64619808)
print v(xbgr.mr_n65123056)
print v(xbgr.mr_n65277248)
print v(xbgr.mr_n64757632)
print v(xbgr.mr_n64621920)
print v(xbgr.mr_n65126672)
print v(xbgr.mr_n65319472)
print v(xbgr.mr_n65451984)
print v(xbgr.mr_n65526592)
print v(xbgr.mr_n65587328)
print v(xbgr.mr_n65934352)
print v(xbgr.mr_n67092048)
print v(xbgr.mr_n67313392)
print v(xbgr.mr_n67481424)
print v(xbgr.mr_n66069072)
print v(xbgr.mr_n66181776)
print v(xbgr.mr_n66257680)
print v(xbgr.mr_n66353152)
print v(xbgr.mr_n66590112)
print v(xbgr.mr_n66704032)
print v(xbgr.mr_n66850864)
print v(xbgr.mr_n66066448)
print v(xbgr.mr_n66220992)
print v(xbgr.mr_n66282656)
print v(xbgr.mr_n66347728)
print v(xbgr.mr_n66602768)
print v(xbgr.mr_n66737488)
print v(xbgr.mr_n66861728)
print v(xbgr.mr_n64758096)
print v(xbgr.mr_n64936144)
print v(xbgr.mr_n65139632)
print v(xbgr.mr_n65085744)
print v(xbgr.mr_n67092160)
print v(xbgr.mr_n67257760)
print v(xbgr.mr_n67500528)
print v(xbgr.mr_n65970336)
print v(xbgr.mr_n66101376)
print v(xbgr.mr_n66231184)
print v(xbgr.mr_n66303984)
print v(xbgr.mr_n66507056)
print v(xbgr.mr_n66632736)
print v(xbgr.mr_n66764880)
print v(xbgr.mr_n66903232)
print v(xbgr.mr_n67133792)
print v(xbgr.mr_n67334752)
print v(xbgr.mr_n64758560)
print v(xbgr.mr_n64961008)
print v(xbgr.mr_n65127264)
print v(xbgr.mr_n65368480)
print v(xbgr.mr_n67090880)
print v(xbgr.mr_n67174944)
print v(xbgr.mr_n67500160)
print v(xbgr.mr_n65609792)
print v(xbgr.mr_n66062528)
print v(xbgr.d2)
print v(xbgr.mr_n66283760)
print v(xbgr.mr_n66358576)
print v(xbgr.mr_n66606384)
print v(xbgr.mr_n66700480)
print v(xbgr.mr_n66819344)
print v(xbgr.mr_n65456080)
print v(xbgr.mr_n65526704)
print v(xbgr.mr_n65946096)
print v(xbgr.mr_n64759024)
print v(xbgr.mr_n64963280)
print v(xbgr.mr_n65137328)
print v(xbgr.mr_n65369184)
print v(xbgr.mr_n65456192)
print v(xbgr.mr_n65526816)
print v(xbgr.mr_n65946912)
print v(xbgr.mr_n67093440)
print v(xbgr.mr_n67313504)
print v(xbgr.mr_n67492192)
print v(xbgr.mr_n65608800)
print v(xbgr.mr_n64759488)
print v(xbgr.mr_n64963984)
print v(xbgr.mr_n65138512)
print v(xbgr.mr_n65370352)
print v(xbgr.mr_n65395936)
print v(xbgr.mr_n65488096)
print v(xbgr.mr_n65827520)
print v(xbgr.det)
print v(xbgr.mr_n67094240)
print v(xbgr.mr_n67260704)
print v(xbgr.mr_n67492560)
print v(xbgr.mr_n65586736)
print v(xbgr.mr_n64759952)
print v(xbgr.mr_n64965152)
print v(xbgr.mr_n65133184)
print v(xbgr.mr_n65369888)
print v(xbgr.mr_n66905008)
print v(xbgr.mr_n67133328)
print v(xbgr.mr_n67336608)
print v(xbgr.mr_n65455056)
print v(xbgr.mr_n65512128)
print v(xbgr.mr_n65946208)
print v(xbgr.mr_n67071392)
print v(xbgr.mr_n67261296)
print v(xbgr.mr_n67503232)
print v(xbgr.mr_n66070496)
print v(xbgr.mr_n66181440)
print v(xbgr.mr_n66283648)
print v(xbgr.mr_n66344752)
print v(xbgr.mr_n66596592)
print v(xbgr.mr_n66731200)
print v(xbgr.mr_n66855632)
print v(xbgr.mr_n66070272)
print v(xbgr.mr_n66181664)
print v(xbgr.mr_n66283872)
print v(xbgr.mr_n66360496)
print v(xbgr.mr_n66610224)
print v(xbgr.mr_n66734496)
print v(xbgr.mr_n66862544)
print v(xbgr.mr_n64760416)
print v(xbgr.mr_n64966064)
print v(xbgr.mr_n65142656)
print v(xbgr.mr_n65319792)
print v(xbgr.mr_n65993616)
print v(xbgr.mr_n66103296)
print v(xbgr.mr_n66238032)
print v(xbgr.mr_n66307984)
print v(xbgr.mr_n66511088)
print v(xbgr.mr_n66636768)
print v(xbgr.mr_n66768800)
print v(xbgr.mr_n67095600)
print v(xbgr.mr_n67319952)
print v(xbgr.mr_n67500048)
print v(xbgr.mr_n64743248)
print v(xbgr.mr_n64966656)
print v(xbgr.mr_n65143248)
print v(xbgr.mr_n65376864)
print v(xbgr.mr_n67090624)
print v(xbgr.mr_n67260480)
print v(xbgr.mr_n67504736)
print v(xbgr.mr_n64761344)
print v(xbgr.mr_n64967248)
print v(xbgr.mr_n65143840)
print v(xbgr.mr_n65375312)
print v(xbgr.mr_n65608096)
print v(xbgr.mr_n66070608)
print v(xbgr.mr_n66223440)
print v(xbgr.mr_n66284384)
print v(xbgr.mr_n66360608)
print v(xbgr.mr_n66610720)
print v(xbgr.mr_n66699888)
print v(xbgr.mr_n66827104)
print v(xbgr.mr_n65456816)
print v(xbgr.mr_n65527664)
print v(xbgr.mr_n65947600)
print v(xbgr.mr_n66906864)
print v(xbgr.mr_n67132864)
print v(xbgr.mr_n67338464)
print v(xbgr.mr_n65450528)
print v(xbgr.mr_n65527776)
print v(xbgr.mr_n65948224)
print v(xbgr.mr_n67095712)
print v(xbgr.mr_n67173088)
print v(xbgr.mr_n67503120)
print v(xbgr.mr_n64761808)
print v(xbgr.mr_n64967840)
print v(xbgr.mr_n65137920)
print v(xbgr.mr_n65377200)
print v(xbgr.mr_n65584416)
print v(xbgr.mr_n65395664)
print v(xbgr.mr_n65487824)
print v(xbgr.mr_n65548448)
print v(xbgr.mr_n65827792)
print v(xbgr.r4n)
print v(xbgr.mr_n64762272)
print v(xbgr.mr_n64968432)
print v(xbgr.mr_n65141472)
print v(xbgr.mr_n65377312)
print v(xbgr.mr_n67096272)
print v(xbgr.mr_n67321584)
print v(xbgr.mr_n67505632)
print v(xbgr.mr_n65455968)
print v(xbgr.mr_n65528400)
print v(xbgr.mr_n65941344)
print v(xbgr.mr_n66071232)
print v(xbgr.mr_n66164960)
print v(xbgr.mr_n66287056)
print v(xbgr.mr_n66356768)
print v(xbgr.mr_n66610608)
print v(xbgr.mr_n66734144)
print v(xbgr.mr_n66832368)
print v(xbgr.mr_n66066880)
print v(xbgr.mr_n66164688)
print v(xbgr.mr_n66289104)
print v(xbgr.mr_n66354960)
print v(xbgr.mr_n66611184)
print v(xbgr.mr_n66730736)
print v(xbgr.mr_n66857168)
print v(xbgr.mr_n64748816)
print v(xbgr.mr_n64969024)
print v(xbgr.mr_n65142064)
print v(xbgr.mr_n65377424)
print v(xbgr.mr_n67097344)
print v(xbgr.mr_n67264144)
print v(xbgr.mr_n67507200)
print v(xbgr.mr_n66908720)
print v(xbgr.mr_n67132400)
print v(xbgr.mr_n67340320)
print v(xbgr.mr_n65993152)
print v(xbgr.mr_n66102768)
print v(xbgr.mr_n66238848)
print v(xbgr.mr_n66308800)
print v(xbgr.mr_n66511904)
print v(xbgr.mr_n66637584)
print v(xbgr.mr_n66769216)
print v(xbgr.mr_n64763200)
print v(xbgr.mr_n64969616)
print v(xbgr.mr_n65133712)
print v(xbgr.mr_n65377536)
print v(xbgr.mr_n67097776)
print v(xbgr.mr_n67262192)
print v(xbgr.mr_n67508192)
print v(xbgr.mr_n64763664)
print v(xbgr.mr_n64950272)
print v(xbgr.mr_n65146736)
print v(xbgr.mr_n65360096)
print v(xbgr.mr_n65606992)
print v(xbgr.mr_n66072544)
print v(xbgr.mr_n66224528)
print v(xbgr.mr_n66286432)
print v(xbgr.mr_n66361024)
print v(xbgr.mr_n66610000)
print v(xbgr.mr_n66699296)
print v(xbgr.mr_n66824672)
print v(xbgr.mr_n67099744)
print v(xbgr.mr_n67323216)
print v(xbgr.mr_n67505456)
print v(xbgr.mr_n65457552)
print v(xbgr.mr_n65528512)
print v(xbgr.mr_n65947248)
print v(xbgr.mr_n65456928)
print v(xbgr.mr_n65528048)
print v(xbgr.mr_n65941152)
print v(xbgr.mr_n64764128)
print v(xbgr.mr_n64970768)
print v(xbgr.mr_n65147392)
print v(xbgr.mr_n65377952)
print v(xbgr.mr_n67093904)
print v(xbgr.mr_n67261568)
print v(xbgr.mr_n67509760)
print v(xbgr.mr_n65601472)
print v(xbgr.mr_n65395120)
print v(xbgr.mr_n65487552)
print v(xbgr.mr_n65827328)
print v(xbgr.mr_n65548976)
print v(xbgr.mr_n66910576)
print v(xbgr.mr_n67131936)
print v(xbgr.mr_n67342176)
print v(xbgr.mr_n64764592)
print v(xbgr.mr_n64971360)
print v(xbgr.mr_n65140288)
print v(xbgr.mr_n65378224)
print v(xbgr.mr_n65579344)
print v(xbgr.mr_n67101904)
print v(xbgr.mr_n67266512)
print v(xbgr.mr_n67512320)
print v(xbgr.mr_n65455856)
print v(xbgr.mr_n65528880)
print v(xbgr.mr_n65935696)
print v(xbgr.mr_n64765056)
print v(xbgr.mr_n64971952)
print v(xbgr.mr_n65145552)
print v(xbgr.mr_n65358912)
print v(xbgr.mr_n66072368)
print v(xbgr.mr_n66221808)
print v(xbgr.mr_n66289296)
print v(xbgr.mr_n66360832)
print v(xbgr.mr_n66611808)
print v(xbgr.mr_n66727792)
print v(xbgr.mr_n66855984)
print v(xbgr.mr_n66073264)
print v(xbgr.mr_n66203376)
print v(xbgr.mr_n66288912)
print v(xbgr.mr_n66361568)
print v(xbgr.mr_n66610112)
print v(xbgr.mr_n66735312)
print v(xbgr.mr_n66857984)
print v(xbgr.mr_n67102320)
print v(xbgr.mr_n67324848)
print v(xbgr.mr_n67510752)
print v(xbgr.mr_n64754848)
print v(xbgr.mr_n64962528)
print v(xbgr.mr_n65139104)
print v(xbgr.mr_n65378768)
print v(xbgr.mr_n65992688)
print v(xbgr.mr_n66102304)
print v(xbgr.mr_n66239664)
print v(xbgr.mr_n66309536)
print v(xbgr.mr_n66512720)
print v(xbgr.mr_n66638400)
print v(xbgr.mr_n66770032)
print v(xbgr.mr_n67100624)
print v(xbgr.mr_n67267104)
print v(xbgr.mr_n67508016)
print v(xbgr.mr_n64765984)
print v(xbgr.mr_n64973008)
print v(xbgr.mr_n65149760)
print v(xbgr.mr_n65379040)
print v(xbgr.mr_n66912432)
print v(xbgr.mr_n67131472)
print v(xbgr.mr_n67344064)
print v(xbgr.mr_n66071808)
print v(xbgr.mr_n66216160)
print v(xbgr.mr_n66275120)
print v(xbgr.mr_n66361840)
print v(xbgr.mr_n66611072)
print v(xbgr.mr_n66693376)
print v(xbgr.mr_n66825328)
print v(xbgr.mr_n67104192)
print v(xbgr.mr_n67265328)
print v(xbgr.mr_n67513312)
print v(xbgr.mr_n65454880)
print v(xbgr.mr_n65530576)
print v(xbgr.d3)
print v(xbgr.mr_n65948752)
print v(xbgr.mr_n65453680)
print v(xbgr.mr_n65531200)
print v(xbgr.mr_n65769632)
print v(xbgr.mr_n65949792)
print v(xbgr.mr_n64751600)
print v(xbgr.mr_n64973600)
print v(xbgr.mr_n65150352)
print v(xbgr.mr_n65379312)
print v(xbgr.mr_n65394848)
print v(xbgr.mr_n65487280)
print v(xbgr.mr_n65603696)
print v(xbgr.mr_n65826144)
print v(xbgr.mr_n67104720)
print v(xbgr.mr_n67326480)
print v(xbgr.mr_n67510576)
print v(xbgr.mr_n64766912)
print v(xbgr.mr_n64974192)
print v(xbgr.mr_n65146208)
print v(xbgr.mr_n65379648)
print v(xbgr.mr_n67103248)
print v(xbgr.mr_n67260368)
print v(xbgr.mr_n67514880)
print v(xbgr.mr_n64767376)
print v(xbgr.mr_n64974784)
print v(xbgr.mr_n65147984)
print v(xbgr.mr_n65380448)
print v(xbgr.mr_n65451376)
print v(xbgr.mr_n65530224)
print v(xbgr.mr_n65738416)
print v(xbgr.mr_n65951824)
print v(xbgr.mr_n66074560)
print v(xbgr.mr_n66217776)
print v(xbgr.mr_n66274272)
print v(xbgr.mr_n66359632)
print v(xbgr.mr_n66491728)
print v(xbgr.mr_n66613264)
print v(xbgr.mr_n66728496)
print v(xbgr.mr_n66854832)
print v(xbgr.mr_n66071344)
print v(xbgr.mr_n66176016)
print v(xbgr.mr_n66275344)
print v(xbgr.mr_n66360720)
print v(xbgr.mr_n66479344)
print v(xbgr.mr_n66614608)
print v(xbgr.mr_n66731088)
print v(xbgr.mr_n66853808)
print v(xbgr.mr_n66914288)
print v(xbgr.mr_n67131008)
print v(xbgr.mr_n67346432)
print v(xbgr.mr_n67105600)
print v(xbgr.mr_n67260592)
print v(xbgr.mr_n67515872)
print v(xbgr.mr_n64767840)
print v(xbgr.mr_n64975376)
print v(xbgr.mr_n65148576)
print v(xbgr.mr_n65380848)
print v(xbgr.mr_n65992224)
print v(xbgr.mr_n66101840)
print v(xbgr.mr_n66240480)
print v(xbgr.mr_n66309072)
print v(xbgr.mr_n66385136)
print v(xbgr.mr_n66513536)
print v(xbgr.mr_n66639216)
print v(xbgr.mr_n66770848)
print v(xbgr.mr_n64768304)
print v(xbgr.mr_n64975968)
print v(xbgr.mr_n65149168)
print v(xbgr.mr_n65381248)
print v(xbgr.mr_n67097952)
print v(xbgr.mr_n67318896)
print v(xbgr.mr_n67513136)
print v(xbgr.mr_n66075712)
print v(xbgr.mr_n66221184)
print v(xbgr.mr_n66282848)
print v(xbgr.mr_n66332576)
print v(xbgr.mr_n66493872)
print v(xbgr.mr_n66610336)
print v(xbgr.mr_n66698112)
print v(xbgr.mr_n66822896)
print v(xbgr.mr_n65449920)
print v(xbgr.mr_n65532080)
print v(xbgr.mr_n65773152)
print v(xbgr.mr_n65951360)
print v(xbgr.mr_n65452832)
print v(xbgr.mr_n65527312)
print v(xbgr.mr_n65766064)
print v(xbgr.mr_n65952928)
print v(xbgr.mr_n64766448)
print v(xbgr.mr_n64976560)
print v(xbgr.mr_n65153312)
print v(xbgr.mr_n65381648)
print v(xbgr.mr_n67108128)
print v(xbgr.mr_n67260128)
print v(xbgr.mr_n67517440)
print v(xbgr.mr_n66915216)
print v(xbgr.mr_n67130544)
print v(xbgr.mr_n67347616)
print v(xbgr.mr_n64769232)
print v(xbgr.mr_n64977152)
print v(xbgr.mr_n65153904)
print v(xbgr.mr_n65382448)
print v(xbgr.mr_n65394576)
print v(xbgr.mr_n65487008)
print v(xbgr.mr_n65242864)
print v(xbgr.mr_n65824960)
print v(xbgr.mr_n67108304)
print v(xbgr.mr_n67168320)
print v(xbgr.mr_n67515696)
print v(xbgr.mr_n64769696)
print v(xbgr.mr_n64977744)
print v(xbgr.mr_n65154496)
print v(xbgr.mr_n65382848)
print v(xbgr.mr_n65446560)
print v(xbgr.mr_n65531728)
print v(xbgr.mr_n65739776)
print v(xbgr.mr_n65953456)
print v(xbgr.mr_n67109152)
print v(xbgr.mr_n67329744)
print v(xbgr.mr_n67518432)
print v(xbgr.mr_n66070384)
print v(xbgr.mr_n66217968)
print v(xbgr.mr_n66281200)
print v(xbgr.mr_n66363184)
print v(xbgr.mr_n66493648)
print v(xbgr.mr_n66615488)
print v(xbgr.mr_n66724384)
print v(xbgr.mr_n66854944)
print v(xbgr.mr_n66072896)
print v(xbgr.mr_n66179056)
print v(xbgr.mr_n66275792)
print v(xbgr.mr_n66360384)
print v(xbgr.mr_n66494832)
print v(xbgr.mr_n66611920)
print v(xbgr.mr_n66731904)
print v(xbgr.mr_n66854160)
print v(xbgr.mr_n64770160)
print v(xbgr.mr_n64978336)
print v(xbgr.mr_n65145024)
print v(xbgr.mr_n65383248)
print v(xbgr.mr_n67109968)
print v(xbgr.mr_n67166416)
print v(xbgr.mr_n67520000)
print v(xbgr.mr_n65991760)
print v(xbgr.mr_n66100912)
print v(xbgr.mr_n66241552)
print v(xbgr.mr_n66308528)
print v(xbgr.mr_n66387600)
print v(xbgr.mr_n66514352)
print v(xbgr.mr_n66640032)
print v(xbgr.mr_n66771664)
print v(xbgr.mr_n66914752)
print v(xbgr.mr_n67130080)
print v(xbgr.mr_n67347024)
print v(xbgr.mr_n64770624)
print v(xbgr.mr_n64978928)
print v(xbgr.mr_n65155680)
print v(xbgr.mr_n65377648)
print v(xbgr.mr_n67110912)
print v(xbgr.mr_n67258352)
print v(xbgr.mr_n67518256)
print v(xbgr.mr_n66076432)
print v(xbgr.mr_n66179872)
print v(xbgr.mr_n66276608)
print v(xbgr.mr_n66365904)
print v(xbgr.mr_n66495920)
print v(xbgr.mr_n66618208)
print v(xbgr.mr_n66697520)
print v(xbgr.mr_n66820000)
print v(xbgr.mr_n64760880)
print v(xbgr.mr_n64979520)
print v(xbgr.mr_n65140816)
print v(xbgr.mr_n65384048)
print v(xbgr.mr_n65451808)
print v(xbgr.mr_n65533648)
print v(xbgr.mr_n65771152)
print v(xbgr.mr_n65950256)
print v(xbgr.mr_n65448016)
print v(xbgr.mr_n65534336)
print v(xbgr.mr_n65772656)
print v(xbgr.mr_n65950672)
print v(xbgr.mr_n67111440)
print v(xbgr.mr_n67330288)
print v(xbgr.mr_n67520992)
print v(xbgr.mr_n64771552)
print v(xbgr.mr_n64980112)
print v(xbgr.mr_n65144432)
print v(xbgr.mr_n65376976)
print v(xbgr.mr_n65394304)
print v(xbgr.mr_n65486736)
print v(xbgr.mr_n65562560)
print v(xbgr.mr_n65823776)
print v(xbgr.mr_n67109712)
print v(xbgr.mr_n67048416)
print v(xbgr.mr_n67522560)
print v(xbgr.mr_n64762736)
print v(xbgr.mr_n64823824)
print v(xbgr.mr_n65157392)
print v(xbgr.mr_n65385168)
print v(xbgr.mr_n66913824)
print v(xbgr.mr_n67129616)
print v(xbgr.mr_n67345840)
print v(xbgr.mr_n65449232)
print v(xbgr.mr_n65533152)
print v(xbgr.mr_n65739504)
print v(xbgr.mr_n65952240)
print v(xbgr.mr_n66074064)
print v(xbgr.mr_n66222224)
print v(xbgr.mr_n66275680)
print v(xbgr.mr_n66367008)
print v(xbgr.mr_n66494720)
print v(xbgr.mr_n66617776)
print v(xbgr.mr_n66727264)
print v(xbgr.mr_n66850336)
print v(xbgr.mr_n67105936)
print v(xbgr.mr_n67034336)
print v(xbgr.mr_n67520816)
print v(xbgr.mr_n66077728)
print v(xbgr.mr_n66179760)
print v(xbgr.mr_n66276496)
print v(xbgr.mr_n66365472)
print v(xbgr.mr_n66495744)
print v(xbgr.mr_n66619312)
print v(xbgr.mr_n66727680)
print v(xbgr.mr_n66719776)
print v(xbgr.mr_n64772480)
print v(xbgr.mr_n64981296)
print v(xbgr.mr_n65152128)
print v(xbgr.mr_n65385648)
print v(xbgr.mr_n65991296)
print v(xbgr.mr_n66100448)
print v(xbgr.mr_n66242016)
print v(xbgr.mr_n66308256)
print v(xbgr.mr_n66388416)
print v(xbgr.mr_n66515168)
print v(xbgr.mr_n66640848)
print v(xbgr.mr_n66772480)
print v(xbgr.mr_n64576832)
print v(xbgr.mr_n64981888)
print v(xbgr.mr_n65155088)
print v(xbgr.mr_n65386048)
print v(xbgr.mr_n67113472)
print v(xbgr.mr_n67329200)
print v(xbgr.mr_n67523552)
print v(xbgr.mr_n67114400)
print v(xbgr.mr_n67258944)
print v(xbgr.mr_n67525120)
print v(xbgr.mr_n64723840)
print v(xbgr.mr_n64982480)
print v(xbgr.mr_n65092992)
print v(xbgr.mr_n65386448)
print v(xbgr.mr_n66078880)
print v(xbgr.mr_n66179408)
print v(xbgr.mr_n66276144)
print v(xbgr.mr_n66362432)
print v(xbgr.mr_n66495264)
print v(xbgr.mr_n66617232)
print v(xbgr.mr_n66698704)
print v(xbgr.mr_n66760880)
print v(xbgr.mr_n65450352)
print v(xbgr.mr_n65535216)
print v(xbgr.mr_n65741056)
print v(xbgr.mr_n65949104)
print v(xbgr.mr_n65442192)
print v(xbgr.mr_n65521168)
print v(xbgr.mr_n65770544)
print v(xbgr.mr_n65954496)
print v(xbgr.mr_n66913360)
print v(xbgr.mr_n67129152)
print v(xbgr.mr_n67345248)
print v(xbgr.mr_n67112320)
print v(xbgr.mr_n67259536)
print v(xbgr.mr_n67527680)
print v(xbgr.mr_n64738144)
print v(xbgr.mr_n64983072)
print v(xbgr.mr_n65092400)
print v(xbgr.mr_n65387248)
print v(xbgr.mr_n65394032)
print v(xbgr.mr_n65486464)
print v(xbgr.mr_n65555312)
print v(xbgr.mr_n65822592)
print v(xbgr.mr_n64727088)
print v(xbgr.mr_n64983664)
print v(xbgr.mr_n64997280)
print v(xbgr.mr_n65387648)
print v(xbgr.mr_n67115760)
print v(xbgr.mr_n67328656)
print v(xbgr.mr_n67530240)
print v(xbgr.mr_n65446384)
print v(xbgr.mr_n65519360)
print v(xbgr.mr_n65739232)
print v(xbgr.mr_n65956528)
print v(xbgr.mr_n66076064)
print v(xbgr.mr_n66225424)
print v(xbgr.mr_n66275232)
print v(xbgr.mr_n66367888)
print v(xbgr.mr_n66497328)
print v(xbgr.mr_n66621312)
print v(xbgr.mr_n66721280)
print v(xbgr.mr_n66847456)
print v(xbgr.mr_n64737216)
print v(xbgr.mr_n64984256)
print v(xbgr.mr_n65091216)
print v(xbgr.mr_n65388048)
print v(xbgr.mr_n66079600)
print v(xbgr.mr_n66209024)
print v(xbgr.mr_n66292752)
print v(xbgr.mr_n66363616)
print v(xbgr.mr_n66490560)
print v(xbgr.mr_n66615920)
print v(xbgr.mr_n66724272)
print v(xbgr.mr_n66844048)
print v(xbgr.mr_n67114144)
print v(xbgr.mr_n67257168)
print v(xbgr.mr_n67526112)
print v(xbgr.mr_n66912896)
print v(xbgr.mr_n67128688)
print v(xbgr.mr_n67344656)
print v(xbgr.mr_n64736752)
print v(xbgr.mr_n64984848)
print v(xbgr.mr_n65090624)
print v(xbgr.mr_n65384848)
print v(xbgr.mr_n65990832)
print v(xbgr.mr_n66099520)
print v(xbgr.mr_n66241088)
print v(xbgr.mr_n66307712)
print v(xbgr.mr_n66389232)
print v(xbgr.mr_n66514896)
print v(xbgr.mr_n66640576)
print v(xbgr.mr_n66772208)
print v(xbgr.mr_n67115872)
print v(xbgr.mr_n67256576)
print v(xbgr.mr_n67528672)
print v(xbgr.mr_n64736288)
print v(xbgr.mr_n64985440)
print v(xbgr.mr_n65090032)
print v(xbgr.mr_n65388848)
print v(xbgr.mr_n66077232)
print v(xbgr.mr_n66225792)
print v(xbgr.mr_n66292448)
print v(xbgr.mr_n66370672)
print v(xbgr.mr_n66499088)
print v(xbgr.mr_n66620624)
print v(xbgr.mr_n66694560)
print v(xbgr.mr_n66821776)
print v(xbgr.mr_n65449056)
print v(xbgr.mr_n65536784)
print v(xbgr.mr_n65768608)
print v(xbgr.mr_n65956064)
print v(xbgr.mr_n67107120)
print v(xbgr.mr_n67328112)
print v(xbgr.mr_n67402464)
print v(xbgr.mr_n65445952)
print v(xbgr.mr_n65535904)
print v(xbgr.mr_n65767088)
print v(xbgr.mr_n65957632)
print v(xbgr.mr_n64735824)
print v(xbgr.mr_n64986032)
print v(xbgr.mr_n65088032)
print v(xbgr.mr_n65383648)
print v(xbgr.mr_n67115344)
print v(xbgr.mr_n67254208)
print v(xbgr.mr_n67525936)
print v(xbgr.mr_n65393760)
print v(xbgr.mr_n65486272)
print v(xbgr.mr_n65555200)
print v(xbgr.mr_n65821408)
print v(xbgr.mr_n64735360)
print v(xbgr.mr_n64952720)
print v(xbgr.mr_n65152656)
print v(xbgr.mr_n65228896)
print v(xbgr.mr_n66911968)
print v(xbgr.mr_n67128224)
print v(xbgr.mr_n67343568)
print v(xbgr.mr_n67112656)
print v(xbgr.mr_n67255392)
print v(xbgr.mr_n67523376)
print v(xbgr.mr_n65447408)
print v(xbgr.mr_n65536368)
print v(xbgr.mr_n65737888)
print v(xbgr.mr_n65958160)
print v(xbgr.mr_n64730336)
print v(xbgr.mr_n64987216)
print v(xbgr.mr_n65165024)
print v(xbgr.mr_n65228304)
print v(xbgr.mr_n66075056)
print v(xbgr.mr_n66180224)
print v(xbgr.mr_n66291600)
print v(xbgr.mr_n66371712)
print v(xbgr.mr_n66497440)
print v(xbgr.mr_n66613920)
print v(xbgr.mr_n66725088)
print v(xbgr.mr_n66840112)
print v(xbgr.mr_n66078704)
print v(xbgr.mr_n66228288)
print v(xbgr.mr_n66276960)
print v(xbgr.mr_n66366320)
print v(xbgr.mr_n66498912)
print v(xbgr.mr_n66618624)
print v(xbgr.mr_n66723856)
print v(xbgr.mr_n66850752)
print v(xbgr.mr_n67113584)
print v(xbgr.mr_n67327024)
print v(xbgr.mr_n67459664)
print v(xbgr.mr_n64734496)
print v(xbgr.mr_n64987808)
print v(xbgr.mr_n65165424)
print v(xbgr.mr_n65227648)
print v(xbgr.mr_n65990368)
print v(xbgr.mr_n66099056)
print v(xbgr.mr_n66240752)
print v(xbgr.mr_n66307440)
print v(xbgr.mr_n66390048)
print v(xbgr.mr_n66514624)
print v(xbgr.mr_n66640304)
print v(xbgr.mr_n66771936)
print v(xbgr.mr_n67111328)
print v(xbgr.mr_n67254800)
print v(xbgr.mr_n67459424)
print v(xbgr.mr_n64734032)
print v(xbgr.mr_n64988400)
print v(xbgr.mr_n65166624)
print v(xbgr.mr_n65208096)
print v(xbgr.mr_n66911504)
print v(xbgr.mr_n67127776)
print v(xbgr.mr_n67343104)
print v(xbgr.mr_n66076768)
print v(xbgr.mr_n66180336)
print v(xbgr.mr_n66294944)
print v(xbgr.mr_n66364928)
print v(xbgr.mr_n66499808)
print v(xbgr.mr_n66622000)
print v(xbgr.mr_n66695744)
print v(xbgr.mr_n66815792)
print v(xbgr.mr_n65446736)
print v(xbgr.mr_n65538352)
print v(xbgr.mr_n65768064)
print v(xbgr.mr_n65955376)
print v(xbgr.mr_n67104608)
print v(xbgr.mr_n67255984)
print v(xbgr.mr_n67442304)
print v(xbgr.mr_n65447840)
print v(xbgr.mr_n65539040)
print v(xbgr.mr_n65768784)
print v(xbgr.mr_n65959200)
print v(xbgr.mr_n64733568)
print v(xbgr.mr_n64980704)
print v(xbgr.mr_n65167424)
print v(xbgr.mr_n65226528)
print v(xbgr.mr_n65393488)
print v(xbgr.mr_n65484640)
print v(xbgr.mr_n64635744)
print v(xbgr.mr_n65820224)
print v(xbgr.mr_n64577632)
print v(xbgr.mr_n64989584)
print v(xbgr.mr_n65158048)
print v(xbgr.mr_n65225936)
print v(xbgr.mr_n67109040)
print v(xbgr.mr_n67528496)
print v(xbgr.mr_n64732656)
print v(xbgr.mr_n64990176)
print v(xbgr.mr_n65169024)
print v(xbgr.mr_n65225344)
print v(xbgr.mr_n67106944)
print v(xbgr.mr_n67401936)
print v(xbgr.mr_n65441584)
print v(xbgr.mr_n65534864)
print v(xbgr.mr_n65738112)
print v(xbgr.mr_n65959728)
print v(xbgr.mr_n66070160)
print v(xbgr.mr_n66229104)
print v(xbgr.mr_n66294160)
print v(xbgr.mr_n66369008)
print v(xbgr.mr_n66496272)
print v(xbgr.mr_n66622976)
print v(xbgr.mr_n66335808)
print v(xbgr.mr_n66847344)
print v(xbgr.mr_n66075536)
print v(xbgr.mr_n66226096)
print v(xbgr.mr_n66296496)
print v(xbgr.mr_n66373712)
print v(xbgr.mr_n66501104)
print v(xbgr.mr_n66626016)
print v(xbgr.mr_n66723264)
print v(xbgr.mr_n66851568)
print v(xbgr.mr_n66911040)
print v(xbgr.mr_n67342640)
print v(xbgr.mr_n64732192)
print v(xbgr.mr_n64990768)
print v(xbgr.mr_n65169424)
print v(xbgr.mr_n65224752)
print v(xbgr.mr_n67107696)
print v(xbgr.mr_n67453472)
print v(xbgr.mr_n65989904)
print v(xbgr.mr_n66098128)
print v(xbgr.mr_n66240208)
print v(xbgr.mr_n66306896)
print v(xbgr.mr_n66390592)
print v(xbgr.mr_n66514080)
print v(xbgr.mr_n66639760)
print v(xbgr.mr_n66771392)
print v(xbgr.mr_n64731728)
print v(xbgr.mr_n64991360)
print v(xbgr.mr_n65170624)
print v(xbgr.mr_n65224160)
print v(xbgr.mr_n67100960)
print v(xbgr.mr_n67529360)
print v(xbgr.mr_n66073600)
print v(xbgr.mr_n66227856)
print v(xbgr.mr_n66294512)
print v(xbgr.mr_n66373024)
print v(xbgr.mr_n66502256)
print v(xbgr.mr_n66627616)
print v(xbgr.mr_n66696928)
print v(xbgr.mr_n66816448)
print v(xbgr.mr_n65444944)
print v(xbgr.mr_n65539920)
print v(xbgr.mr_n65764544)
print v(xbgr.mr_n65956944)
print v(xbgr.mr_n64731264)
print v(xbgr.mr_n64991952)
print v(xbgr.mr_n65171424)
print v(xbgr.mr_n65223568)
print v(xbgr.mr_n65443408)
print v(xbgr.mr_n65532768)
print v(xbgr.mr_n65767568)
print v(xbgr.mr_n65960768)
print v(xbgr.mr_n67104832)
print v(xbgr.mr_n67413072)
print v(xbgr.mr_n66910112)
print v(xbgr.mr_n67341712)
print v(xbgr.mr_n64730800)
print v(xbgr.mr_n64992544)
print v(xbgr.mr_n65165824)
print v(xbgr.mr_n65222976)
print v(xbgr.mr_n65393216)
print v(xbgr.mr_n65483584)
print v(xbgr.mr_n65552640)
print v(xbgr.mr_n65819040)
print v(xbgr.mr_n67102992)
print v(xbgr.mr_n67426912)
print v(xbgr.mr_n64577360)
print v(xbgr.mr_n64993136)
print v(xbgr.mr_n65172624)
print v(xbgr.mr_n65207504)
print v(xbgr.mr_n65440576)
print v(xbgr.mr_n65537936)
print v(xbgr.mr_n65722944)
print v(xbgr.mr_n65961296)
print v(xbgr.mr_n66071456)
print v(xbgr.mr_n66230816)
print v(xbgr.mr_n66297472)
print v(xbgr.mr_n66371024)
print v(xbgr.mr_n66502080)
print v(xbgr.mr_n66625328)
print v(xbgr.mr_n66720592)
print v(xbgr.mr_n66846992)
print v(xbgr.mr_n67102432)
print v(xbgr.mr_n67402176)
print v(xbgr.mr_n66070880)
print v(xbgr.mr_n66232032)
print v(xbgr.mr_n66298688)
print v(xbgr.mr_n66376416)
print v(xbgr.mr_n66503040)
print v(xbgr.mr_n66627184)
print v(xbgr.mr_n66338528)
print v(xbgr.mr_n66844752)
print v(xbgr.mr_n64729872)
print v(xbgr.mr_n64993728)
print v(xbgr.mr_n65162992)
print v(xbgr.mr_n65206992)
print v(xbgr.mr_n67099632)
print v(xbgr.mr_n67450864)
print v(xbgr.mr_n65989440)
print v(xbgr.mr_n66097664)
print v(xbgr.mr_n66239936)
print v(xbgr.mr_n66306624)
print v(xbgr.mr_n66390320)
print v(xbgr.mr_n66513808)
print v(xbgr.mr_n66639488)
print v(xbgr.mr_n66771120)
print v(xbgr.mr_n64719200)
print v(xbgr.mr_n64994320)
print v(xbgr.mr_n65168624)
print v(xbgr.mr_n65221120)
print v(xbgr.mr_n66909648)
print v(xbgr.mr_n67341248)
print v(xbgr.mr_n67096528)
print v(xbgr.mr_n67422736)
print v(xbgr.mr_n64728944)
print v(xbgr.mr_n64661568)
print v(xbgr.mr_n65175024)
print v(xbgr.mr_n65174224)
print v(xbgr.mr_n66068896)
print v(xbgr.mr_n66230400)
print v(xbgr.mr_n66297120)
print v(xbgr.mr_n66374400)
print v(xbgr.mr_n66500496)
print v(xbgr.mr_n66628720)
print v(xbgr.mr_n66696336)
print v(xbgr.mr_n66817568)
print v(xbgr.mr_n65444096)
print v(xbgr.mr_n65541488)
print v(xbgr.mr_n65765520)
print v(xbgr.mr_n65954960)
print v(xbgr.mr_n65444768)
print v(xbgr.mr_n65540608)
print v(xbgr.mr_n65766240)
print v(xbgr.mr_n65958512)
print v(xbgr.mr_n67099856)
print v(xbgr.mr_n67325936)
print v(xbgr.mr_n67530736)
print v(xbgr.mr_n64728480)
print v(xbgr.mr_n64995504)
print v(xbgr.mr_n65169824)
print v(xbgr.mr_n65220016)
print v(xbgr.mr_n65392944)
print v(xbgr.mr_n65481296)
print v(xbgr.mr_n65319184)
print v(xbgr.mr_n65817856)
print v(xbgr.mr_n67099056)
print v(xbgr.mr_n67253616)
print v(xbgr.mr_n67033712)
print v(xbgr.mr_n64728016)
print v(xbgr.mr_n64996096)
print v(xbgr.mr_n65177024)
print v(xbgr.mr_n65219424)
print v(xbgr.mr_n66909184)
print v(xbgr.mr_n67127312)
print v(xbgr.mr_n67340784)
print v(xbgr.mr_n65438864)
print v(xbgr.mr_n65541072)
print v(xbgr.mr_n65738224)
print v(xbgr.mr_n65962800)
print v(xbgr.mr_n66067056)
print v(xbgr.mr_n66229536)
print v(xbgr.mr_n66299504)
print v(xbgr.mr_n66377296)
print v(xbgr.mr_n66503920)
print v(xbgr.mr_n66623328)
print v(xbgr.mr_n66715152)
print v(xbgr.mr_n66840640)
print v(xbgr.mr_n67098880)
print v(xbgr.mr_n67253024)
print v(xbgr.mr_n67530848)
print v(xbgr.mr_n66065536)
print v(xbgr.mr_n66233584)
print v(xbgr.mr_n66296192)
print v(xbgr.mr_n66372240)
print v(xbgr.mr_n66500608)
print v(xbgr.mr_n66630720)
print v(xbgr.mr_n66703440)
print v(xbgr.mr_n66848160)
print v(xbgr.mr_n64727552)
print v(xbgr.mr_n64996688)
print v(xbgr.mr_n65177424)
print v(xbgr.mr_n65218832)
print v(xbgr.mr_n65988976)
print v(xbgr.mr_n66096736)
print v(xbgr.mr_n66239392)
print v(xbgr.mr_n66306352)
print v(xbgr.mr_n66389776)
print v(xbgr.mr_n66513264)
print v(xbgr.mr_n66638944)
print v(xbgr.mr_n66770576)
print v(xbgr.mr_n64724768)
print v(xbgr.mr_n64988992)
print v(xbgr.mr_n65178688)
print v(xbgr.mr_n65218240)
print v(xbgr.mr_n67093328)
print v(xbgr.mr_n67325392)
print v(xbgr.mr_n67445888)
print v(xbgr.mr_n64726624)
print v(xbgr.mr_n64997872)
print v(xbgr.mr_n65179280)
print v(xbgr.mr_n65217648)
print v(xbgr.mr_n67095184)
print v(xbgr.mr_n67199792)
print v(xbgr.mr_n67429776)
print v(xbgr.mr_n66063328)
print v(xbgr.mr_n66233280)
print v(xbgr.mr_n66298256)
print v(xbgr.mr_n66375728)
print v(xbgr.mr_n66504352)
print v(xbgr.mr_n66632384)
print v(xbgr.mr_n66693968)
print v(xbgr.mr_n66818224)
print v(xbgr.mr_n65443232)
print v(xbgr.mr_n65543056)
print v(xbgr.mr_n65762000)
print v(xbgr.mr_n65962336)
print v(xbgr.mr_n65439840)
print v(xbgr.mr_n65543744)
print v(xbgr.mr_n65765024)
print v(xbgr.mr_n65963904)
print v(xbgr.mr_n66908256)
print v(xbgr.mr_n67126848)
print v(xbgr.mr_n67339856)
print v(xbgr.mr_n64726160)
print v(xbgr.mr_n64998464)
print v(xbgr.mr_n65181056)
print v(xbgr.mr_n65217056)
print v(xbgr.mr_n67092352)
print v(xbgr.mr_n67251840)
print v(xbgr.mr_n67533344)
print v(xbgr.mr_n65392672)
print v(xbgr.mr_n65482352)
print v(xbgr.mr_n65599728)
print v(xbgr.mr_n65816672)
print v(xbgr.mr_n64725696)
print v(xbgr.mr_n64999056)
print v(xbgr.mr_n65182240)
print v(xbgr.mr_n65216464)
print v(xbgr.mr_n67093552)
print v(xbgr.mr_n67324304)
print v(xbgr.mr_n67531760)
print v(xbgr.mr_n65440400)
print v(xbgr.mr_n65542640)
print v(xbgr.mr_n65737776)
print v(xbgr.mr_n65941040)
print v(xbgr.mr_n64725232)
print v(xbgr.mr_n64999648)
print v(xbgr.mr_n65182832)
print v(xbgr.mr_n65215872)
print v(xbgr.mr_n66068096)
print v(xbgr.mr_n66231600)
print v(xbgr.mr_n66301216)
print v(xbgr.mr_n66379584)
print v(xbgr.mr_n66502608)
print v(xbgr.mr_n66624896)
print v(xbgr.mr_n66718896)
print v(xbgr.mr_n66843584)
print v(xbgr.mr_n66065184)
print v(xbgr.mr_n66235776)
print v(xbgr.mr_n66302432)
print v(xbgr.mr_n66381120)
print v(xbgr.mr_n66507744)
print v(xbgr.mr_n66628032)
print v(xbgr.mr_n66717856)
print v(xbgr.mr_n66843936)
print v(xbgr.mr_n67092816)
print v(xbgr.mr_n67250896)
print v(xbgr.mr_n67535952)
print v(xbgr.mr_n66907792)
print v(xbgr.mr_n67126384)
print v(xbgr.mr_n67339392)
print v(xbgr.mr_n64576720)
print v(xbgr.mr_n65000240)
print v(xbgr.mr_n65184016)
print v(xbgr.mr_n65215280)
print v(xbgr.mr_n65988512)
print v(xbgr.mr_n66096272)
print v(xbgr.mr_n66239120)
print v(xbgr.mr_n66306080)
print v(xbgr.mr_n66389504)
print v(xbgr.mr_n66512992)
print v(xbgr.mr_n66638672)
print v(xbgr.mr_n66770304)
print v(xbgr.mr_n67092704)
print v(xbgr.mr_n67252432)
print v(xbgr.mr_n67533952)
print v(xbgr.mr_n64724304)
print v(xbgr.mr_n65000832)
print v(xbgr.mr_n65184608)
print v(xbgr.mr_n65214688)
print v(xbgr.mr_n66061488)
print v(xbgr.mr_n66234992)
print v(xbgr.mr_n66295760)
print v(xbgr.mr_n66379040)
print v(xbgr.mr_n66501600)
print v(xbgr.mr_n66633424)
print v(xbgr.mr_n66695152)
print v(xbgr.mr_n66810448)
print v(xbgr.mr_n65440912)
print v(xbgr.mr_n65544624)
print v(xbgr.mr_n65762912)
print v(xbgr.mr_n65938880)
print v(xbgr.mr_n65442016)
print v(xbgr.mr_n65545312)
print v(xbgr.mr_n65763696)
print v(xbgr.mr_n65936576)
print v(xbgr.mr_n67089104)
print v(xbgr.mr_n67323760)
print v(xbgr.mr_n67531488)
print v(xbgr.mr_n64577056)
print v(xbgr.mr_n65001424)
print v(xbgr.mr_n65171824)
print v(xbgr.mr_n65214096)
print v(xbgr.mr_n67086160)
print v(xbgr.mr_n67245392)
print v(xbgr.mr_n67535456)
print v(xbgr.mr_n65392400)
print v(xbgr.mr_n65480240)
print v(xbgr.mr_n64842384)
print v(xbgr.mr_n65815488)
print v(xbgr.mr_n64723376)
print v(xbgr.mr_n65002016)
print v(xbgr.mr_n65180464)
print v(xbgr.mr_n65213504)
print v(xbgr.mr_n66907328)
print v(xbgr.mr_n67125920)
print v(xbgr.mr_n67338928)
print v(xbgr.mr_n67084528)
print v(xbgr.mr_n67238144)
print v(xbgr.mr_n67536064)
print v(xbgr.mr_n64722912)
print v(xbgr.mr_n65002608)
print v(xbgr.mr_n65161488)
print v(xbgr.mr_n65212912)
print v(xbgr.mr_n65436816)
print v(xbgr.mr_n65539568)
print v(xbgr.mr_n65738000)
print v(xbgr.mr_n65928496)
print v(xbgr.mr_n66049616)
print v(xbgr.mr_n66226656)
print v(xbgr.mr_n66303248)
print v(xbgr.mr_n66382000)
print v(xbgr.mr_n66505040)
print v(xbgr.mr_n66634304)
print v(xbgr.mr_n66714448)
print v(xbgr.mr_n66831792)
print v(xbgr.mr_n66053504)
print v(xbgr.mr_n66234560)
print v(xbgr.mr_n66299936)
print v(xbgr.mr_n66377728)
print v(xbgr.mr_n66509744)
print v(xbgr.mr_n66630032)
print v(xbgr.mr_n66335920)
print v(xbgr.mr_n66837232)
print v(xbgr.mr_n64722448)
print v(xbgr.mr_n65003200)
print v(xbgr.mr_n65179872)
print v(xbgr.mr_n65212320)
print v(xbgr.mr_n67086832)
print v(xbgr.mr_n67315344)
print v(xbgr.mr_n67533840)
print v(xbgr.mr_n65988048)
print v(xbgr.mr_n66095344)
print v(xbgr.mr_n66238576)
print v(xbgr.mr_n66305808)
print v(xbgr.mr_n66388960)
print v(xbgr.mr_n66512448)
print v(xbgr.mr_n66638128)
print v(xbgr.mr_n66769760)
print v(xbgr.mr_n67086656)
print v(xbgr.mr_n67250064)
print v(xbgr.mr_n67538720)
print v(xbgr.mr_n64721984)
print v(xbgr.mr_n65003792)
print v(xbgr.mr_n65178224)
print v(xbgr.mr_n65211728)
print v(xbgr.mr_n66906400)
print v(xbgr.mr_n67125296)
print v(xbgr.mr_n67338000)
print v(xbgr.mr_n66065360)
print v(xbgr.mr_n66232496)
print v(xbgr.mr_n66302896)
print v(xbgr.mr_n66384784)
print v(xbgr.mr_n66506704)
print v(xbgr.mr_n66633888)
print v(xbgr.mr_n66691600)
print v(xbgr.mr_n66812896)
print v(xbgr.mr_n65439040)
print v(xbgr.mr_n65546192)
print v(xbgr.mr_n65760976)
print v(xbgr.mr_n65922784)
print v(xbgr.mr_n65435952)
print v(xbgr.mr_n65542176)
print v(xbgr.mr_n65759456)
print v(xbgr.mr_n65934240)
print v(xbgr.mr_n67084416)
print v(xbgr.mr_n67250720)
print v(xbgr.mr_n67541632)
print v(xbgr.mr_n64721520)
print v(xbgr.mr_n65004384)
print v(xbgr.mr_n65177824)
print v(xbgr.mr_n65211072)
print v(xbgr.mr_n65392128)
print v(xbgr.mr_n65455744)
print v(xbgr.mr_n64832592)
print v(xbgr.mr_n65814304)
print v(xbgr.mr_n64721056)
print v(xbgr.mr_n65004976)
print v(xbgr.mr_n65176624)
print v(xbgr.mr_n65183424)
print v(xbgr.mr_n67085232)
print v(xbgr.mr_n67322128)
print v(xbgr.mr_n67414384)
print v(xbgr.mr_n64720592)
print v(xbgr.mr_n64933776)
print v(xbgr.mr_n65176224)
print v(xbgr.mr_n65209952)
print v(xbgr.mr_n67083232)
print v(xbgr.mr_n67248288)
print v(xbgr.mr_n67540064)
print v(xbgr.mr_n65437664)
print v(xbgr.mr_n65545840)
print v(xbgr.mr_n65701776)
print v(xbgr.mr_n65930928)
print v(xbgr.mr_n66061312)
print v(xbgr.mr_n66229840)
print v(xbgr.mr_n66300240)
print v(xbgr.mr_n66383120)
print v(xbgr.mr_n66503568)
print v(xbgr.mr_n66626704)
print v(xbgr.mr_n66717392)
print v(xbgr.mr_n66828880)
print v(xbgr.mr_n66063504)
print v(xbgr.mr_n66228752)
print v(xbgr.mr_n66297840)
print v(xbgr.mr_n66380432)
print v(xbgr.mr_n66506208)
print v(xbgr.mr_n66631888)
print v(xbgr.mr_n66336336)
print v(xbgr.mr_n66840528)
print v(xbgr.mr_n66905936)
print v(xbgr.mr_n67125184)
print v(xbgr.mr_n67337536)
print v(xbgr.mr_n64720128)
print v(xbgr.mr_n65006160)
print v(xbgr.mr_n65175424)
print v(xbgr.mr_n65209360)
print v(xbgr.mr_n67083408)
print v(xbgr.mr_n67248944)
print v(xbgr.mr_n67539888)
print v(xbgr.mr_n65987584)
print v(xbgr.mr_n66094880)
print v(xbgr.mr_n66238304)
print v(xbgr.mr_n66305536)
print v(xbgr.mr_n66388688)
print v(xbgr.mr_n66512176)
print v(xbgr.mr_n66637856)
print v(xbgr.mr_n66769488)
print v(xbgr.mr_n64719664)
print v(xbgr.mr_n65006752)
print v(xbgr.mr_n65161024)
print v(xbgr.mr_n65208688)
print v(xbgr.mr_n67082064)
print v(xbgr.mr_n67321040)
print v(xbgr.mr_n67542624)
print v(xbgr.mr_n66060192)
print v(xbgr.mr_n66227504)
print v(xbgr.mr_n66299152)
print v(xbgr.mr_n66386288)
print v(xbgr.mr_n66499440)
print v(xbgr.mr_n66629184)
print v(xbgr.mr_n66631408)
print v(xbgr.mr_n66814016)
print v(xbgr.mr_n64576944)
print v(xbgr.mr_n65007344)
print v(xbgr.mr_n65173824)
print v(xbgr.mr_n65174624)
print v(xbgr.mr_n65434304)
print v(xbgr.mr_n65547760)
print v(xbgr.mr_n65760368)
print v(xbgr.mr_n65928768)
print v(xbgr.mr_n65436128)
print v(xbgr.mr_n65537472)
print v(xbgr.mr_n65761152)
print v(xbgr.mr_n65931232)
print v(xbgr.mr_n67079440)
print v(xbgr.mr_n67246512)
print v(xbgr.mr_n67547568)
print v(xbgr.mr_n64718736)
print v(xbgr.mr_n65007936)
print v(xbgr.mr_n65173024)
print v(xbgr.mr_n65173424)
print v(xbgr.mr_n66905472)
print v(xbgr.mr_n67051568)
print v(xbgr.mr_n67337072)
print v(xbgr.mr_n65391856)
print v(xbgr.mr_n65461344)
print v(xbgr.mr_n65243472)
print v(xbgr.mr_n65813120)
print v(xbgr.mr_n67080272)
print v(xbgr.mr_n67247168)
print v(xbgr.mr_n67546752)
print v(xbgr.mr_n64718272)
print v(xbgr.mr_n65008528)
print v(xbgr.mr_n65172224)
print v(xbgr.mr_n65167024)
print v(xbgr.mr_n65437488)
print v(xbgr.mr_n65547408)
print v(xbgr.mr_n65732784)
print v(xbgr.mr_n65928384)
print v(xbgr.mr_n66055904)
print v(xbgr.mr_n66180608)
print v(xbgr.mr_n66292016)
print v(xbgr.mr_n66384288)
print v(xbgr.mr_n66500144)
print v(xbgr.mr_n66620192)
print v(xbgr.mr_n66718560)
print v(xbgr.mr_n66837120)
print v(xbgr.mr_n66060880)
print v(xbgr.mr_n66227072)
print v(xbgr.mr_n66293376)
print v(xbgr.mr_n66380016)
print v(xbgr.mr_n66498352)
print v(xbgr.mr_n66624016)
print v(xbgr.mr_n66713008)
print v(xbgr.mr_n66841344)
print v(xbgr.mr_n67082672)
print v(xbgr.mr_n67320496)
print v(xbgr.mr_n67542448)
print v(xbgr.mr_n64717808)
print v(xbgr.mr_n65009120)
print v(xbgr.mr_n65171024)
print v(xbgr.mr_n65206400)
print v(xbgr.mr_n67079328)
print v(xbgr.mr_n67244736)
print v(xbgr.mr_n67550128)
print v(xbgr.mr_n65987120)
print v(xbgr.mr_n66093952)
print v(xbgr.mr_n66237760)
print v(xbgr.mr_n66305264)
print v(xbgr.mr_n66388144)
print v(xbgr.mr_n66511632)
print v(xbgr.mr_n66637312)
print v(xbgr.mr_n66769024)
print v(xbgr.mr_n64715696)
print v(xbgr.mr_n65009712)
print v(xbgr.mr_n65170224)
print v(xbgr.mr_n65205808)
print v(xbgr.mr_n66904544)
print v(xbgr.mr_n67051104)
print v(xbgr.mr_n67336144)
print v(xbgr.mr_n67075776)
print v(xbgr.mr_n67243616)
print v(xbgr.mr_n67549312)
print v(xbgr.mr_n64584656)
print v(xbgr.mr_n64945024)
print v(xbgr.mr_n65167824)
print v(xbgr.mr_n65205216)
print v(xbgr.mr_n66060016)
print v(xbgr.mr_n66210064)
print v(xbgr.mr_n66295344)
print v(xbgr.mr_n66381648)
print v(xbgr.mr_n66496640)
print v(xbgr.mr_n66624400)
print v(xbgr.mr_n66691264)
print v(xbgr.mr_n66814672)
print v(xbgr.mr_n65434912)
print v(xbgr.mr_n65526928)
print v(xbgr.mr_n65758432)
print v(xbgr.mr_n65926576)
print v(xbgr.mr_n65436928)
print v(xbgr.mr_n65529856)
print v(xbgr.mr_n65756912)
print v(xbgr.mr_n65903504)
print v(xbgr.mr_n64584192)
print v(xbgr.mr_n64944432)
print v(xbgr.mr_n65163248)
print v(xbgr.mr_n65204624)
print v(xbgr.mr_n67068864)
print v(xbgr.mr_n67319408)
print v(xbgr.mr_n67547744)
print v(xbgr.mr_n65391584)
print v(xbgr.mr_n65458480)
print v(xbgr.mr_n65288624)
print v(xbgr.mr_n65812256)
print v(xbgr.mr_n64583728)
print v(xbgr.mr_n64943840)
print v(xbgr.mr_n65168224)
print v(xbgr.mr_n65204032)
print v(xbgr.mr_n67073056)
print v(xbgr.mr_n67242960)
print v(xbgr.mr_n67545008)
print v(xbgr.mr_n66904080)
print v(xbgr.mr_n67050640)
print v(xbgr.mr_n67335680)
print v(xbgr.mr_n65428064)
print v(xbgr.mr_n65069968)
print v(xbgr.mr_n65707920)
print v(xbgr.mr_n65918384)
print v(xbgr.mr_n66058336)
print v(xbgr.mr_n66173632)
print v(xbgr.mr_n66277072)
print v(xbgr.mr_n66378416)
print v(xbgr.mr_n66497936)
print v(xbgr.mr_n66612784)
print v(xbgr.mr_n66713920)
print v(xbgr.mr_n66836768)
print v(xbgr.mr_n64583264)
print v(xbgr.mr_n64943248)
print v(xbgr.mr_n65150944)
print v(xbgr.mr_n65203440)
print v(xbgr.mr_n66053840)
print v(xbgr.mr_n66223248)
print v(xbgr.mr_n66293728)
print v(xbgr.mr_n66376944)
print v(xbgr.mr_n66496976)
print v(xbgr.mr_n66622480)
print v(xbgr.mr_n66714336)
print v(xbgr.mr_n66823552)
print v(xbgr.mr_n67074848)
print v(xbgr.mr_n67240064)
print v(xbgr.mr_n67550304)
print v(xbgr.mr_n64582800)
print v(xbgr.mr_n64942656)
print v(xbgr.mr_n65166224)
print v(xbgr.mr_n65202848)
print v(xbgr.mr_n65986656)
print v(xbgr.mr_n66093488)
print v(xbgr.mr_n66237488)
print v(xbgr.mr_n66305072)
print v(xbgr.mr_n66387872)
print v(xbgr.mr_n66511360)
print v(xbgr.mr_n66637040)
print v(xbgr.mr_n66768912)
print v(xbgr.mr_n67075440)
print v(xbgr.mr_n67317408)
print v(xbgr.mr_n67544192)
print v(xbgr.mr_n64582336)
print v(xbgr.mr_n64942064)
print v(xbgr.mr_n65163584)
print v(xbgr.mr_n65202256)
print v(xbgr.mr_n67073232)
print v(xbgr.mr_n67241184)
print v(xbgr.mr_n67551872)
print v(xbgr.mr_n66059216)
print v(xbgr.mr_n66205600)
print v(xbgr.mr_n66275568)
print v(xbgr.d4)
print v(xbgr.mr_n66494608)
print v(xbgr.mr_n66619840)
print v(xbgr.mr_n66636048)
print v(xbgr.mr_n66810960)
print v(xbgr.mr_n65434736)
print v(xbgr.mr_n65510320)
print v(xbgr.mr_n65757888)
print v(xbgr.mr_n65918656)
print v(xbgr.mr_n65420496)
print v(xbgr.mr_n65527200)
print v(xbgr.mr_n65758608)
print v(xbgr.mr_n65921520)
print v(xbgr.mr_n66903616)
print v(xbgr.mr_n67050176)
print v(xbgr.mr_n67335216)
print v(xbgr.mr_n64581872)
print v(xbgr.mr_n64941408)
print v(xbgr.mr_n65164624)
print v(xbgr.mr_n65201664)
print v(xbgr.mr_n67074672)
print v(xbgr.mr_n67241840)
print v(xbgr.mr_n67552864)
print v(xbgr.mr_n65389648)
print v(xbgr.mr_n65457792)
print v(xbgr.mr_n64650016)
print v(xbgr.mr_n65811456)
print v(xbgr.mr_n64581408)
print v(xbgr.mr_n64940288)
print v(xbgr.mr_n65164224)
print v(xbgr.mr_n65199984)
print v(xbgr.mr_n67074496)
print v(xbgr.mr_n67318544)
print v(xbgr.mr_n67545184)
print v(xbgr.mr_n65433280)
print v(xbgr.mr_n65524784)
print v(xbgr.mr_n65695632)
print v(xbgr.mr_n65918160)
print v(xbgr.mr_n64580944)
print v(xbgr.mr_n64939696)
print v(xbgr.mr_n64986624)
print v(xbgr.mr_n65391248)
print v(xbgr.mr_n66058160)
print v(xbgr.mr_n66223632)
print v(xbgr.mr_n66275456)
print v(xbgr.mr_n66369632)
print v(xbgr.mr_n66485536)
print v(xbgr.mr_n66616608)
print v(xbgr.mr_n66701072)
print v(xbgr.mr_n66831984)
print v(xbgr.mr_n66049440)
print v(xbgr.mr_n66222496)
print v(xbgr.mr_n66236592)
print v(xbgr.mr_n66374880)
print v(xbgr.mr_n66494144)
print v(xbgr.mr_n66615136)
print v(xbgr.mr_n66713488)
print v(xbgr.mr_n66837936)
print v(xbgr.mr_n67068976)
print v(xbgr.mr_n67239536)
print v(xbgr.mr_n67554432)
print v(xbgr.mr_n64580480)
print v(xbgr.mr_n64817904)
print v(xbgr.mr_n65051456)
print v(xbgr.mr_n65390848)
print v(xbgr.mr_n66902928)
print v(xbgr.mr_n67049712)
print v(xbgr.mr_n67334288)
print v(xbgr.mr_n65986192)
print v(xbgr.mr_n66092560)
print v(xbgr.mr_n66237024)
print v(xbgr.mr_n66304960)
print v(xbgr.mr_n66387328)
print v(xbgr.mr_n66510896)
print v(xbgr.mr_n66636576)
print v(xbgr.mr_n66768688)
print v(xbgr.mr_n67069968)
print v(xbgr.mr_n67238608)
print v(xbgr.mr_n67556992)
print v(xbgr.mr_n64580016)
print v(xbgr.mr_n64937920)
print v(xbgr.mr_n65013264)
print v(xbgr.mr_n65390448)
print v(xbgr.mr_n66050272)
print v(xbgr.mr_n66176544)
print v(xbgr.mr_n66288112)
print v(xbgr.mr_n66368320)
print v(xbgr.mr_n66494256)
print v(xbgr.mr_n66613504)
print v(xbgr.mr_n66691088)
print v(xbgr.mr_n66741424)
print v(xbgr.mr_n65425488)
print v(xbgr.mr_n65738688)
print v(xbgr.mr_n65916464)
print v(xbgr.mr_n65433456)
print v(xbgr.mr_n65757392)
print v(xbgr.mr_n65902832)
print v(xbgr.mr_n67066304)
print v(xbgr.mr_n67317520)
print v(xbgr.mr_n67552688)
print v(xbgr.mr_n64577904)
print v(xbgr.mr_n64936672)
print v(xbgr.mr_n65050272)
print v(xbgr.mr_n65389968)
print v(xbgr.mr_n65313936)
print v(xbgr.mr_n65492512)
print v(xbgr.mr_n67065808)
print v(xbgr.mr_n67208832)
print v(xbgr.mr_n67555424)
print v(xbgr.mr_n65388448)
print v(xbgr.mr_n64884144)
print v(xbgr.mr_n65554368)
print v(xbgr.mr_n65784592)
print v(xbgr.mr_n64775920)
print v(xbgr.n_23)
print v(xbgr.mr_n65048496)
print v(xbgr.mr_n65317952)
print v(xbgr.mr_n65311888)
print v(xbgr.mr_n66902624)
print v(xbgr.mr_n67117824)
print v(xbgr.mr_n67333904)
print v(xbgr.mr_n67068752)
print v(xbgr.mr_n67205328)
print v(xbgr.mr_n67555248)
print v(xbgr.n_12)
print v(xbgr.n_25)
print v(xbgr.mr_n65049088)
print v(xbgr.mr_n65315008)
print v(xbgr.mr_n65432848)
print v(xbgr.mr_n65724272)
print v(xbgr.mr_n65912816)
print v(xbgr.mr_n66056960)
print v(xbgr.mr_n66219904)
print v(xbgr.mr_n66274112)
print v(xbgr.mr_n66370176)
print v(xbgr.mr_n66489664)
print v(xbgr.mr_n66612288)
print v(xbgr.mr_n66701664)
print v(xbgr.mr_n66829056)
print v(xbgr.mr_n66056080)
print v(xbgr.mr_n66218448)
print v(xbgr.mr_n66284928)
print v(xbgr.mr_n66362192)
print v(xbgr.mr_n66493760)
print v(xbgr.mr_n66608192)
print v(xbgr.mr_n66702256)
print v(xbgr.mr_n66832176)
print v(xbgr.mr_n64757168)
print v(xbgr.mr_n64875920)
print v(xbgr.mr_n65047312)
print v(xbgr.mr_n65384448)
print v(xbgr.mr_n67067408)
print v(xbgr.mr_n67311216)
print v(xbgr.mr_n67557984)
print v(xbgr.mr_n65985728)
print v(xbgr.mr_n66092176)
print v(xbgr.mr_n66235344)
print v(xbgr.mr_n66302000)
print v(xbgr.mr_n66387136)
print v(xbgr.mr_n66510784)
print v(xbgr.mr_n66636464)
print v(xbgr.mr_n66761680)
print v(xbgr.n_17)
print v(xbgr.n_22)
print v(xbgr.mr_n65047904)
print v(xbgr.mr_n65382048)
print v(xbgr.mr_n67067904)
print v(xbgr.mr_n67236752)
print v(xbgr.mr_n67559552)
print v(xbgr.mr_n66902320)
print v(xbgr.mr_n67054656)
print v(xbgr.mr_n67333600)
print v(xbgr.mr_n66047472)
print v(xbgr.mr_n66181888)
print v(xbgr.mr_n66290416)
print v(xbgr.mr_n66367536)
print v(xbgr.mr_n66493536)
print v(xbgr.mr_n66611456)
print v(xbgr.mr_n66673248)
print v(xbgr.mr_n66810624)
print v(xbgr.mr_n65427872)
print v(xbgr.mr_n65755344)
print v(xbgr.mr_n65838416)
print v(xbgr.n_18)
print v(xbgr.mr_n64873968)
print v(xbgr.mr_n65046128)
print v(xbgr.mr_n65380048)
print v(xbgr.mr_n65422768)
print v(xbgr.mr_n65756064)
print v(xbgr.mr_n65910864)
print v(xbgr.mr_n67047888)
print v(xbgr.mr_n67237216)
print v(xbgr.mr_n67562112)
print v(xbgr.mr_n64709024)
print v(xbgr.mr_n64890464)
print v(xbgr.mr_n64773056)
print v(xbgr.mr_n64873248)
print v(xbgr.mr_n65046720)
print v(xbgr.mr_n65377760)
print v(xbgr.mr_n65389248)
print v(xbgr.mr_n65502944)
print v(xbgr.mr_n65588144)
print v(xbgr.mr_n65786816)
print v(xbgr.mr_n67065120)
print v(xbgr.mr_n67315456)
print v(xbgr.mr_n67563104)
print v(xbgr.mr_n64880800)
print v(xbgr.mr_n64765520)
print v(xbgr.mr_n64872528)
print v(xbgr.mr_n65045536)
print v(xbgr.mr_n65377088)
print v(xbgr.mr_n65428816)
print v(xbgr.mr_n65733584)
print v(xbgr.mr_n65907296)
print v(xbgr.mr_n67055360)
print v(xbgr.mr_n67210752)
print v(xbgr.mr_n67560544)
print v(xbgr.mr_n66048128)
print v(xbgr.mr_n66139376)
print v(xbgr.mr_n66284576)
print v(xbgr.mr_n66364304)
print v(xbgr.mr_n66488496)
print v(xbgr.mr_n66600960)
print v(xbgr.mr_n66702848)
print v(xbgr.mr_n66831440)
print v(xbgr.mr_n66050096)
print v(xbgr.mr_n66138432)
print v(xbgr.mr_n66277664)
print v(xbgr.mr_n66361456)
print v(xbgr.mr_n66480736)
print v(xbgr.mr_n66593728)
print v(xbgr.mr_n66711280)
print v(xbgr.mr_n66833120)
print v(xbgr.mr_n66890512)
print v(xbgr.mr_n67118112)
print v(xbgr.mr_n67331840)
print v(xbgr.mr_n64752064)
print v(xbgr.mr_n64871808)
print v(xbgr.mr_n65043632)
print v(xbgr.mr_n65320288)
print v(xbgr.mr_n67062304)
print v(xbgr.mr_n67210640)
print v(xbgr.mr_n67560368)
print v(xbgr.mr_n65985264)
print v(xbgr.mr_n66079936)
print v(xbgr.mr_n66236240)
print v(xbgr.mr_n66303680)
print v(xbgr.mr_n66372592)
print v(xbgr.mr_n66509056)
print v(xbgr.mr_n66634736)
print v(xbgr.mr_n66768080)
print v(xbgr.mr_n67061968)
print v(xbgr.mr_n67317632)
print v(xbgr.mr_n67557808)
print v(xbgr.mr_n64908096)
print v(xbgr.mr_n66048784)
print v(xbgr.mr_n66136112)
print v(xbgr.mr_n66257792)
print v(xbgr.mr_n66362768)
print v(xbgr.mr_n66486432)
print v(xbgr.mr_n66583184)
print v(xbgr.mr_n66629600)
print v(xbgr.mr_n66767280)
print v(xbgr.mr_n65427760)
print v(xbgr.mr_n65740320)
print v(xbgr.mr_n65906464)
print v(xbgr.mr_n65423072)
print v(xbgr.mr_n65753616)
print v(xbgr.mr_n65906576)
print v(xbgr.mr_n67055536)
print v(xbgr.mr_n67207136)
print v(xbgr.mr_n67564672)
print v(xbgr.mr_n65502144)
print v(xbgr.mr_n66879312)
print v(xbgr.mr_n67117936)
print v(xbgr.mr_n67332928)
print v(xbgr.mr_n65317232)
print v(xbgr.mr_n65498944)
print v(xbgr.mr_n65549696)
print v(xbgr.mr_n65685632)
print v(xbgr.mr_n65485520)
print v(xbgr.mr_n66889712)
print v(xbgr.mr_n67201600)
print v(xbgr.mr_n67562928)
print v(xbgr.mr_n65424736)
print v(xbgr.mr_n65720176)
print v(xbgr.mr_n65844640)
print v(dvbe)
print v(iptat)
print v(pbias)
print v(pcasc)
print v(r4)
print v(vbe)
print v(vdd)
print v(vref)
print v(vdd)-v(vdd)
echo METALLIC_POINT_VOLTAGES_END
echo METALLIC_ALL_NODE_VOLTAGES_BEGIN
print v(xbgr.b1b)
print v(xbgr.c2)
print v(xbgr.d1)
print v(xbgr.d2)
print v(xbgr.d3)
print v(xbgr.d4)
print v(xbgr.d5)
print v(xbgr.det)
print v(dvbe)
print v(iptat)
print v(xbgr.kick)
print v(xbgr.mr_n51456384)
print v(xbgr.mr_n51462800)
print v(xbgr.mr_n51502000)
print v(xbgr.mr_n53895104)
print v(xbgr.mr_n53940912)
print v(xbgr.mr_n53947840)
print v(xbgr.mr_n53993376)
print v(xbgr.mr_n54863408)
print v(xbgr.mr_n54863520)
print v(xbgr.mr_n54866304)
print v(xbgr.mr_n54866416)
print v(xbgr.mr_n54866832)
print v(xbgr.mr_n54866944)
print v(xbgr.mr_n54867264)
print v(xbgr.mr_n54867376)
print v(xbgr.mr_n54867808)
print v(xbgr.mr_n54868048)
print v(xbgr.mr_n54868160)
print v(xbgr.mr_n54868512)
print v(xbgr.mr_n54868832)
print v(xbgr.mr_n54868944)
print v(xbgr.mr_n54869376)
print v(xbgr.mr_n54869696)
print v(xbgr.mr_n54869808)
print v(xbgr.mr_n54870240)
print v(xbgr.mr_n54870560)
print v(xbgr.mr_n54870672)
print v(xbgr.mr_n54871104)
print v(xbgr.mr_n54871424)
print v(xbgr.mr_n54871536)
print v(xbgr.mr_n54871968)
print v(xbgr.mr_n54872288)
print v(xbgr.mr_n54872400)
print v(xbgr.mr_n54872832)
print v(xbgr.mr_n54873152)
print v(xbgr.mr_n54873264)
print v(xbgr.mr_n54873696)
print v(xbgr.mr_n54874016)
print v(xbgr.mr_n54874128)
print v(xbgr.mr_n54874560)
print v(xbgr.mr_n54874880)
print v(xbgr.mr_n54874992)
print v(xbgr.mr_n54875424)
print v(xbgr.mr_n54875744)
print v(xbgr.mr_n54875856)
print v(xbgr.mr_n54876288)
print v(xbgr.mr_n54876608)
print v(xbgr.mr_n54876720)
print v(xbgr.mr_n54877152)
print v(xbgr.mr_n54877472)
print v(xbgr.mr_n54877584)
print v(xbgr.mr_n54878016)
print v(xbgr.mr_n54878336)
print v(xbgr.mr_n54878448)
print v(xbgr.mr_n54878880)
print v(xbgr.mr_n54879200)
print v(xbgr.mr_n54879312)
print v(xbgr.mr_n54879744)
print v(xbgr.mr_n54880064)
print v(xbgr.mr_n54880176)
print v(xbgr.mr_n54880608)
print v(xbgr.mr_n54880928)
print v(xbgr.mr_n54881040)
print v(xbgr.mr_n54881472)
print v(xbgr.mr_n54881792)
print v(xbgr.mr_n54881904)
print v(xbgr.mr_n54882224)
print v(xbgr.mr_n54882336)
print v(xbgr.mr_n54882656)
print v(xbgr.mr_n54882768)
print v(xbgr.mr_n54883088)
print v(xbgr.mr_n54883200)
print v(xbgr.mr_n54883520)
print v(xbgr.mr_n54883632)
print v(xbgr.mr_n54883952)
print v(xbgr.mr_n54884064)
print v(xbgr.mr_n54884384)
print v(xbgr.mr_n54884496)
print v(xbgr.mr_n54884816)
print v(xbgr.mr_n54884928)
print v(xbgr.mr_n54885248)
print v(xbgr.mr_n54885360)
print v(xbgr.mr_n54885680)
print v(xbgr.mr_n54885792)
print v(xbgr.mr_n54886112)
print v(xbgr.mr_n54886224)
print v(xbgr.mr_n54886544)
print v(xbgr.mr_n54886656)
print v(xbgr.mr_n54886976)
print v(xbgr.mr_n54887088)
print v(xbgr.mr_n54887408)
print v(xbgr.mr_n54887520)
print v(xbgr.mr_n54887840)
print v(xbgr.mr_n54887952)
print v(xbgr.mr_n54888272)
print v(xbgr.mr_n54888384)
print v(xbgr.mr_n54888704)
print v(xbgr.mr_n54888816)
print v(xbgr.mr_n54889136)
print v(xbgr.mr_n54889248)
print v(xbgr.mr_n54889568)
print v(xbgr.mr_n54889680)
print v(xbgr.mr_n54890000)
print v(xbgr.mr_n54890112)
print v(xbgr.mr_n54890432)
print v(xbgr.mr_n54890544)
print v(xbgr.mr_n54890864)
print v(xbgr.mr_n54890976)
print v(xbgr.mr_n54891296)
print v(xbgr.mr_n54891408)
print v(xbgr.mr_n54891728)
print v(xbgr.mr_n54891840)
print v(xbgr.mr_n54892160)
print v(xbgr.mr_n54892272)
print v(xbgr.mr_n54892592)
print v(xbgr.mr_n54892704)
print v(xbgr.mr_n54893024)
print v(xbgr.mr_n54893136)
print v(xbgr.mr_n54893456)
print v(xbgr.mr_n54893568)
print v(xbgr.mr_n54893888)
print v(xbgr.mr_n54894000)
print v(xbgr.mr_n54894320)
print v(xbgr.mr_n54894432)
print v(xbgr.mr_n54894752)
print v(xbgr.mr_n54894864)
print v(xbgr.mr_n54895184)
print v(xbgr.mr_n54895296)
print v(xbgr.mr_n54895616)
print v(xbgr.mr_n54895728)
print v(xbgr.mr_n54896048)
print v(xbgr.mr_n54896160)
print v(xbgr.mr_n54896480)
print v(xbgr.mr_n54896592)
print v(xbgr.mr_n54896912)
print v(xbgr.mr_n54897024)
print v(xbgr.mr_n54897344)
print v(xbgr.mr_n54897456)
print v(xbgr.mr_n54897584)
print v(xbgr.mr_n54897696)
print v(xbgr.mr_n54898016)
print v(xbgr.mr_n54898128)
print v(xbgr.mr_n54898448)
print v(xbgr.mr_n54898560)
print v(xbgr.mr_n54898880)
print v(xbgr.mr_n54898992)
print v(xbgr.mr_n54899312)
print v(xbgr.mr_n54899424)
print v(xbgr.mr_n54899744)
print v(xbgr.mr_n54899856)
print v(xbgr.mr_n54900176)
print v(xbgr.mr_n54900288)
print v(xbgr.mr_n54900608)
print v(xbgr.mr_n54900720)
print v(xbgr.mr_n54901040)
print v(xbgr.mr_n54901152)
print v(xbgr.mr_n54901472)
print v(xbgr.mr_n54901584)
print v(xbgr.mr_n54901904)
print v(xbgr.mr_n54902016)
print v(xbgr.mr_n54902336)
print v(xbgr.mr_n54902448)
print v(xbgr.mr_n54902768)
print v(xbgr.mr_n54902880)
print v(xbgr.mr_n54903200)
print v(xbgr.mr_n54903312)
print v(xbgr.mr_n54903632)
print v(xbgr.mr_n54903744)
print v(xbgr.mr_n54904064)
print v(xbgr.mr_n54904176)
print v(xbgr.mr_n54904496)
print v(xbgr.mr_n54904608)
print v(xbgr.mr_n54904928)
print v(xbgr.mr_n54905040)
print v(xbgr.mr_n54905360)
print v(xbgr.mr_n54905472)
print v(xbgr.mr_n54905792)
print v(xbgr.mr_n54905904)
print v(xbgr.mr_n54906224)
print v(xbgr.mr_n54906336)
print v(xbgr.mr_n54906656)
print v(xbgr.mr_n54906768)
print v(xbgr.mr_n54907088)
print v(xbgr.mr_n54907200)
print v(xbgr.mr_n54907520)
print v(xbgr.mr_n54907632)
print v(xbgr.mr_n54907952)
print v(xbgr.mr_n54908064)
print v(xbgr.mr_n54908384)
print v(xbgr.mr_n54908496)
print v(xbgr.mr_n54908816)
print v(xbgr.mr_n54908928)
print v(xbgr.mr_n54909248)
print v(xbgr.mr_n54909360)
print v(xbgr.mr_n54909680)
print v(xbgr.mr_n54909792)
print v(xbgr.mr_n54910112)
print v(xbgr.mr_n54910224)
print v(xbgr.mr_n54910544)
print v(xbgr.mr_n54910656)
print v(xbgr.mr_n54910976)
print v(xbgr.mr_n54911088)
print v(xbgr.mr_n54911408)
print v(xbgr.mr_n54911520)
print v(xbgr.mr_n54911840)
print v(xbgr.mr_n54911952)
print v(xbgr.mr_n54912272)
print v(xbgr.mr_n54912384)
print v(xbgr.mr_n54912704)
print v(xbgr.mr_n54912816)
print v(xbgr.mr_n54913136)
print v(xbgr.mr_n54913248)
print v(xbgr.mr_n54913568)
print v(xbgr.mr_n54913680)
print v(xbgr.mr_n54914000)
print v(xbgr.mr_n54914112)
print v(xbgr.mr_n54914432)
print v(xbgr.mr_n54914544)
print v(xbgr.mr_n54914864)
print v(xbgr.mr_n54914976)
print v(xbgr.mr_n54915296)
print v(xbgr.mr_n54915408)
print v(xbgr.mr_n54915728)
print v(xbgr.mr_n54915840)
print v(xbgr.mr_n54916160)
print v(xbgr.mr_n54916272)
print v(xbgr.mr_n54916592)
print v(xbgr.mr_n54916704)
print v(xbgr.mr_n54917024)
print v(xbgr.mr_n54917136)
print v(xbgr.mr_n54917456)
print v(xbgr.mr_n54917568)
print v(xbgr.mr_n54917888)
print v(xbgr.mr_n54918000)
print v(xbgr.mr_n54918320)
print v(xbgr.mr_n54918432)
print v(xbgr.mr_n54918752)
print v(xbgr.mr_n54918864)
print v(xbgr.mr_n54919184)
print v(xbgr.mr_n54919296)
print v(xbgr.mr_n54919616)
print v(xbgr.mr_n54919728)
print v(xbgr.mr_n54920048)
print v(xbgr.mr_n54920160)
print v(xbgr.mr_n54920480)
print v(xbgr.mr_n54920592)
print v(xbgr.mr_n54920912)
print v(xbgr.mr_n54921024)
print v(xbgr.mr_n54921344)
print v(xbgr.mr_n54921456)
print v(xbgr.mr_n54921776)
print v(xbgr.mr_n54921888)
print v(xbgr.mr_n54922208)
print v(xbgr.mr_n54922320)
print v(xbgr.mr_n54922640)
print v(xbgr.mr_n54922752)
print v(xbgr.mr_n54923072)
print v(xbgr.mr_n54923184)
print v(xbgr.mr_n54923504)
print v(xbgr.mr_n54923616)
print v(xbgr.mr_n54923936)
print v(xbgr.mr_n54924048)
print v(xbgr.mr_n54924368)
print v(xbgr.mr_n54924480)
print v(xbgr.mr_n54924800)
print v(xbgr.mr_n54924912)
print v(xbgr.mr_n54925232)
print v(xbgr.mr_n54925344)
print v(xbgr.mr_n54925664)
print v(xbgr.mr_n54925776)
print v(xbgr.mr_n54926096)
print v(xbgr.mr_n54926208)
print v(xbgr.mr_n54926528)
print v(xbgr.mr_n54926640)
print v(xbgr.mr_n54926960)
print v(xbgr.mr_n54927072)
print v(xbgr.mr_n54927392)
print v(xbgr.mr_n54927504)
print v(xbgr.mr_n54927824)
print v(xbgr.mr_n54927936)
print v(xbgr.mr_n54928256)
print v(xbgr.mr_n54928368)
print v(xbgr.mr_n54928688)
print v(xbgr.mr_n54928800)
print v(xbgr.mr_n54929120)
print v(xbgr.mr_n54929232)
print v(xbgr.mr_n54929552)
print v(xbgr.mr_n54929664)
print v(xbgr.mr_n54929984)
print v(xbgr.mr_n54930096)
print v(xbgr.mr_n54930416)
print v(xbgr.mr_n54930528)
print v(xbgr.mr_n54930848)
print v(xbgr.mr_n54930960)
print v(xbgr.mr_n54931280)
print v(xbgr.mr_n54931392)
print v(xbgr.mr_n54931712)
print v(xbgr.mr_n54931824)
print v(xbgr.mr_n54932144)
print v(xbgr.mr_n54932256)
print v(xbgr.mr_n54932576)
print v(xbgr.mr_n54932688)
print v(xbgr.mr_n54933008)
print v(xbgr.mr_n54933120)
print v(xbgr.mr_n54933664)
print v(xbgr.mr_n54933776)
print v(xbgr.mr_n54934096)
print v(xbgr.mr_n54934208)
print v(xbgr.mr_n54934528)
print v(xbgr.mr_n54934640)
print v(xbgr.mr_n54934960)
print v(xbgr.mr_n54935072)
print v(xbgr.mr_n54935392)
print v(xbgr.mr_n54935504)
print v(xbgr.mr_n54935824)
print v(xbgr.mr_n54935936)
print v(xbgr.mr_n54936256)
print v(xbgr.mr_n54936368)
print v(xbgr.mr_n54936688)
print v(xbgr.mr_n54936800)
print v(xbgr.mr_n54937120)
print v(xbgr.mr_n54937232)
print v(xbgr.mr_n54937552)
print v(xbgr.mr_n54937664)
print v(xbgr.mr_n54937984)
print v(xbgr.mr_n54938096)
print v(xbgr.mr_n54938416)
print v(xbgr.mr_n54938528)
print v(xbgr.mr_n54938848)
print v(xbgr.mr_n54938960)
print v(xbgr.mr_n54939280)
print v(xbgr.mr_n54939392)
print v(xbgr.mr_n54939712)
print v(xbgr.mr_n54939824)
print v(xbgr.mr_n54940144)
print v(xbgr.mr_n54940256)
print v(xbgr.mr_n54940576)
print v(xbgr.mr_n54940688)
print v(xbgr.mr_n54941008)
print v(xbgr.mr_n54941120)
print v(xbgr.mr_n54941440)
print v(xbgr.mr_n54941552)
print v(xbgr.mr_n54941872)
print v(xbgr.mr_n54941984)
print v(xbgr.mr_n54942304)
print v(xbgr.mr_n54942416)
print v(xbgr.mr_n54942736)
print v(xbgr.mr_n54942848)
print v(xbgr.mr_n54943168)
print v(xbgr.mr_n54943280)
print v(xbgr.mr_n54943600)
print v(xbgr.mr_n54943712)
print v(xbgr.mr_n54944032)
print v(xbgr.mr_n54944144)
print v(xbgr.mr_n54944464)
print v(xbgr.mr_n54944576)
print v(xbgr.mr_n54944896)
print v(xbgr.mr_n54945008)
print v(xbgr.mr_n54945328)
print v(xbgr.mr_n54945440)
print v(xbgr.mr_n54945760)
print v(xbgr.mr_n54945872)
print v(xbgr.mr_n54946192)
print v(xbgr.mr_n54946304)
print v(xbgr.mr_n54946624)
print v(xbgr.mr_n54946736)
print v(xbgr.mr_n54947056)
print v(xbgr.mr_n54947168)
print v(xbgr.mr_n54947488)
print v(xbgr.mr_n54947600)
print v(xbgr.mr_n54947920)
print v(xbgr.mr_n54948032)
print v(xbgr.mr_n54948352)
print v(xbgr.mr_n54948464)
print v(xbgr.mr_n54948784)
print v(xbgr.mr_n54948896)
print v(xbgr.mr_n54949216)
print v(xbgr.mr_n54949328)
print v(xbgr.mr_n54949648)
print v(xbgr.mr_n54949760)
print v(xbgr.mr_n54950080)
print v(xbgr.mr_n54950192)
print v(xbgr.mr_n54950512)
print v(xbgr.mr_n54950624)
print v(xbgr.mr_n54950944)
print v(xbgr.mr_n54951056)
print v(xbgr.mr_n54951376)
print v(xbgr.mr_n54951488)
print v(xbgr.mr_n54951808)
print v(xbgr.mr_n54951920)
print v(xbgr.mr_n54952240)
print v(xbgr.mr_n54952352)
print v(xbgr.mr_n54952672)
print v(xbgr.mr_n54952784)
print v(xbgr.mr_n54953104)
print v(xbgr.mr_n54953216)
print v(xbgr.mr_n54953536)
print v(xbgr.mr_n54953648)
print v(xbgr.mr_n54953968)
print v(xbgr.mr_n54954080)
print v(xbgr.mr_n54954400)
print v(xbgr.mr_n54954512)
print v(xbgr.mr_n54954832)
print v(xbgr.mr_n54954944)
print v(xbgr.mr_n54955264)
print v(xbgr.mr_n54955376)
print v(xbgr.mr_n54955696)
print v(xbgr.mr_n54955808)
print v(xbgr.mr_n54956128)
print v(xbgr.mr_n54956240)
print v(xbgr.mr_n54956560)
print v(xbgr.mr_n54956672)
print v(xbgr.mr_n54956992)
print v(xbgr.mr_n54957104)
print v(xbgr.mr_n54957424)
print v(xbgr.mr_n54957536)
print v(xbgr.mr_n54957856)
print v(xbgr.mr_n54957968)
print v(xbgr.mr_n54958288)
print v(xbgr.mr_n54958400)
print v(xbgr.mr_n54958720)
print v(xbgr.mr_n54958832)
print v(xbgr.mr_n54959152)
print v(xbgr.mr_n54959264)
print v(xbgr.mr_n54959584)
print v(xbgr.mr_n54959696)
print v(xbgr.mr_n54960016)
print v(xbgr.mr_n54960128)
print v(xbgr.mr_n54960448)
print v(xbgr.mr_n54960560)
print v(xbgr.mr_n54960880)
print v(xbgr.mr_n54960992)
print v(xbgr.mr_n54961312)
print v(xbgr.mr_n54961424)
print v(xbgr.mr_n54961744)
print v(xbgr.mr_n54961856)
print v(xbgr.mr_n54962176)
print v(xbgr.mr_n54962288)
print v(xbgr.mr_n54962608)
print v(xbgr.mr_n54962720)
print v(xbgr.mr_n54963040)
print v(xbgr.mr_n54963152)
print v(xbgr.mr_n54963472)
print v(xbgr.mr_n54963584)
print v(xbgr.mr_n54963904)
print v(xbgr.mr_n54964016)
print v(xbgr.mr_n54964336)
print v(xbgr.mr_n54964448)
print v(xbgr.mr_n54964768)
print v(xbgr.mr_n54964880)
print v(xbgr.mr_n54965200)
print v(xbgr.mr_n54965312)
print v(xbgr.mr_n54965632)
print v(xbgr.mr_n54965744)
print v(xbgr.mr_n54966064)
print v(xbgr.mr_n54966176)
print v(xbgr.mr_n54966496)
print v(xbgr.mr_n54966608)
print v(xbgr.mr_n54966928)
print v(xbgr.mr_n54967040)
print v(xbgr.mr_n54967360)
print v(xbgr.mr_n54967472)
print v(xbgr.mr_n54967792)
print v(xbgr.mr_n54967904)
print v(xbgr.mr_n54968224)
print v(xbgr.mr_n54968336)
print v(xbgr.mr_n54968656)
print v(xbgr.mr_n54968768)
print v(xbgr.mr_n54969088)
print v(xbgr.mr_n54969200)
print v(xbgr.mr_n54969520)
print v(xbgr.mr_n54969632)
print v(xbgr.mr_n54969952)
print v(xbgr.mr_n54970064)
print v(xbgr.mr_n54970384)
print v(xbgr.mr_n54970496)
print v(xbgr.mr_n54970816)
print v(xbgr.mr_n54970928)
print v(xbgr.mr_n54971248)
print v(xbgr.mr_n54971360)
print v(xbgr.mr_n54971680)
print v(xbgr.mr_n54971792)
print v(xbgr.mr_n54972112)
print v(xbgr.mr_n54972224)
print v(xbgr.mr_n54972544)
print v(xbgr.mr_n54972656)
print v(xbgr.mr_n54972976)
print v(xbgr.mr_n54973088)
print v(xbgr.mr_n54973408)
print v(xbgr.mr_n54973520)
print v(xbgr.mr_n54973840)
print v(xbgr.mr_n54973952)
print v(xbgr.mr_n54974272)
print v(xbgr.mr_n54974384)
print v(xbgr.mr_n54974704)
print v(xbgr.mr_n54974816)
print v(xbgr.mr_n54975136)
print v(xbgr.mr_n54975248)
print v(xbgr.mr_n54975568)
print v(xbgr.mr_n54975680)
print v(xbgr.mr_n54976000)
print v(xbgr.mr_n54976112)
print v(xbgr.mr_n54976432)
print v(xbgr.mr_n54976544)
print v(xbgr.mr_n54976864)
print v(xbgr.mr_n54976976)
print v(xbgr.mr_n54977296)
print v(xbgr.mr_n54977408)
print v(xbgr.mr_n54977728)
print v(xbgr.mr_n54977840)
print v(xbgr.mr_n54978160)
print v(xbgr.mr_n54978272)
print v(xbgr.mr_n54978592)
print v(xbgr.mr_n54978704)
print v(xbgr.mr_n54979024)
print v(xbgr.mr_n54979136)
print v(xbgr.mr_n54979456)
print v(xbgr.mr_n54979568)
print v(xbgr.mr_n54979888)
print v(xbgr.mr_n54980000)
print v(xbgr.mr_n54980320)
print v(xbgr.mr_n54980432)
print v(xbgr.mr_n54980752)
print v(xbgr.mr_n54980864)
print v(xbgr.mr_n54981184)
print v(xbgr.mr_n54981296)
print v(xbgr.mr_n54981616)
print v(xbgr.mr_n54981728)
print v(xbgr.mr_n54982048)
print v(xbgr.mr_n54982160)
print v(xbgr.mr_n54982480)
print v(xbgr.mr_n54982592)
print v(xbgr.mr_n54982912)
print v(xbgr.mr_n54983024)
print v(xbgr.mr_n54983344)
print v(xbgr.mr_n54983456)
print v(xbgr.mr_n54983776)
print v(xbgr.mr_n54983888)
print v(xbgr.mr_n54984208)
print v(xbgr.mr_n54984320)
print v(xbgr.mr_n54984640)
print v(xbgr.mr_n54984752)
print v(xbgr.mr_n54985072)
print v(xbgr.mr_n54985184)
print v(xbgr.mr_n54985504)
print v(xbgr.mr_n54985616)
print v(xbgr.mr_n54985936)
print v(xbgr.mr_n54986048)
print v(xbgr.mr_n54986368)
print v(xbgr.mr_n54986480)
print v(xbgr.mr_n54986800)
print v(xbgr.mr_n54986912)
print v(xbgr.mr_n54987232)
print v(xbgr.mr_n54987344)
print v(xbgr.mr_n54987664)
print v(xbgr.mr_n54987776)
print v(xbgr.mr_n54988096)
print v(xbgr.mr_n54988208)
print v(xbgr.mr_n54988528)
print v(xbgr.mr_n54988640)
print v(xbgr.mr_n54988960)
print v(xbgr.mr_n54989072)
print v(xbgr.mr_n54989392)
print v(xbgr.mr_n54989504)
print v(xbgr.mr_n54989824)
print v(xbgr.mr_n54989936)
print v(xbgr.mr_n54990256)
print v(xbgr.mr_n54990368)
print v(xbgr.mr_n54990688)
print v(xbgr.mr_n54990800)
print v(xbgr.mr_n54991120)
print v(xbgr.mr_n54991232)
print v(xbgr.mr_n54991552)
print v(xbgr.mr_n54991664)
print v(xbgr.mr_n54991984)
print v(xbgr.mr_n54992096)
print v(xbgr.mr_n54992416)
print v(xbgr.mr_n54992528)
print v(xbgr.mr_n54992848)
print v(xbgr.mr_n54992960)
print v(xbgr.mr_n54993280)
print v(xbgr.mr_n54993392)
print v(xbgr.mr_n54993712)
print v(xbgr.mr_n54993824)
print v(xbgr.mr_n54994144)
print v(xbgr.mr_n54994256)
print v(xbgr.mr_n54994576)
print v(xbgr.mr_n54994688)
print v(xbgr.mr_n54995008)
print v(xbgr.mr_n54995120)
print v(xbgr.mr_n54995440)
print v(xbgr.mr_n54995552)
print v(xbgr.mr_n54995872)
print v(xbgr.mr_n54995984)
print v(xbgr.mr_n54996304)
print v(xbgr.mr_n54996416)
print v(xbgr.mr_n54996736)
print v(xbgr.mr_n54996848)
print v(xbgr.mr_n54997168)
print v(xbgr.mr_n54997280)
print v(xbgr.mr_n54997600)
print v(xbgr.mr_n54997712)
print v(xbgr.mr_n54998032)
print v(xbgr.mr_n54998144)
print v(xbgr.mr_n54998464)
print v(xbgr.mr_n54998576)
print v(xbgr.mr_n54998896)
print v(xbgr.mr_n54999008)
print v(xbgr.mr_n54999328)
print v(xbgr.mr_n54999440)
print v(xbgr.mr_n54999760)
print v(xbgr.mr_n54999872)
print v(xbgr.mr_n55000192)
print v(xbgr.mr_n55000304)
print v(xbgr.mr_n55000624)
print v(xbgr.mr_n55000736)
print v(xbgr.mr_n55001056)
print v(xbgr.mr_n55001168)
print v(xbgr.mr_n55001488)
print v(xbgr.mr_n55001600)
print v(xbgr.mr_n55001920)
print v(xbgr.mr_n55002032)
print v(xbgr.mr_n55002352)
print v(xbgr.mr_n55002464)
print v(xbgr.mr_n55002784)
print v(xbgr.mr_n55002896)
print v(xbgr.mr_n55003216)
print v(xbgr.mr_n55003328)
print v(xbgr.mr_n55003648)
print v(xbgr.mr_n55003760)
print v(xbgr.mr_n55004080)
print v(xbgr.mr_n55004192)
print v(xbgr.mr_n55004512)
print v(xbgr.mr_n55004624)
print v(xbgr.mr_n55004944)
print v(xbgr.mr_n55005056)
print v(xbgr.mr_n55005376)
print v(xbgr.mr_n55005488)
print v(xbgr.mr_n55005808)
print v(xbgr.mr_n55005920)
print v(xbgr.mr_n55006240)
print v(xbgr.mr_n55006352)
print v(xbgr.mr_n55006672)
print v(xbgr.mr_n55006784)
print v(xbgr.mr_n55007104)
print v(xbgr.mr_n55007216)
print v(xbgr.mr_n55007536)
print v(xbgr.mr_n55007648)
print v(xbgr.mr_n55007968)
print v(xbgr.mr_n55008080)
print v(xbgr.mr_n55008400)
print v(xbgr.mr_n55008512)
print v(xbgr.mr_n55008832)
print v(xbgr.mr_n55008944)
print v(xbgr.mr_n55009264)
print v(xbgr.mr_n55009376)
print v(xbgr.mr_n55009696)
print v(xbgr.mr_n55009808)
print v(xbgr.mr_n55010128)
print v(xbgr.mr_n55010240)
print v(xbgr.mr_n55010560)
print v(xbgr.mr_n55010672)
print v(xbgr.mr_n55010992)
print v(xbgr.mr_n55011104)
print v(xbgr.mr_n55011424)
print v(xbgr.mr_n55011536)
print v(xbgr.mr_n55011856)
print v(xbgr.mr_n55011968)
print v(xbgr.mr_n55012288)
print v(xbgr.mr_n55012400)
print v(xbgr.mr_n55012720)
print v(xbgr.mr_n55012832)
print v(xbgr.mr_n55013152)
print v(xbgr.mr_n55013264)
print v(xbgr.mr_n55013584)
print v(xbgr.mr_n55013696)
print v(xbgr.mr_n55014016)
print v(xbgr.mr_n55014128)
print v(xbgr.mr_n55014448)
print v(xbgr.mr_n55014560)
print v(xbgr.mr_n55014880)
print v(xbgr.mr_n55014992)
print v(xbgr.mr_n55015312)
print v(xbgr.mr_n55015424)
print v(xbgr.mr_n55015744)
print v(xbgr.mr_n55015856)
print v(xbgr.mr_n55016176)
print v(xbgr.mr_n55016288)
print v(xbgr.mr_n55016608)
print v(xbgr.mr_n55016720)
print v(xbgr.mr_n55017040)
print v(xbgr.mr_n55017152)
print v(xbgr.mr_n55017472)
print v(xbgr.mr_n55017584)
print v(xbgr.mr_n55017904)
print v(xbgr.mr_n55018016)
print v(xbgr.mr_n55018336)
print v(xbgr.mr_n55018448)
print v(xbgr.mr_n55018768)
print v(xbgr.mr_n55018880)
print v(xbgr.mr_n55019200)
print v(xbgr.mr_n55019312)
print v(xbgr.mr_n55019632)
print v(xbgr.mr_n55019744)
print v(xbgr.mr_n55020064)
print v(xbgr.mr_n55020176)
print v(xbgr.mr_n55020496)
print v(xbgr.mr_n55020608)
print v(xbgr.mr_n55020928)
print v(xbgr.mr_n55021040)
print v(xbgr.mr_n55021360)
print v(xbgr.mr_n55021472)
print v(xbgr.mr_n55021792)
print v(xbgr.mr_n55021904)
print v(xbgr.mr_n55022224)
print v(xbgr.mr_n55022336)
print v(xbgr.mr_n55022656)
print v(xbgr.mr_n55022768)
print v(xbgr.mr_n55023088)
print v(xbgr.mr_n55023200)
print v(xbgr.mr_n55023520)
print v(xbgr.mr_n55023632)
print v(xbgr.mr_n55023952)
print v(xbgr.mr_n55024064)
print v(xbgr.mr_n55024384)
print v(xbgr.mr_n55024496)
print v(xbgr.mr_n55024816)
print v(xbgr.mr_n55024928)
print v(xbgr.mr_n55025248)
print v(xbgr.mr_n55025360)
print v(xbgr.mr_n55025680)
print v(xbgr.mr_n55025792)
print v(xbgr.mr_n55026112)
print v(xbgr.mr_n55026224)
print v(xbgr.mr_n55026544)
print v(xbgr.mr_n55026656)
print v(xbgr.mr_n55026976)
print v(xbgr.mr_n55027088)
print v(xbgr.mr_n55027408)
print v(xbgr.mr_n55027520)
print v(xbgr.mr_n55027840)
print v(xbgr.mr_n55027952)
print v(xbgr.mr_n55028272)
print v(xbgr.mr_n55028384)
print v(xbgr.mr_n55028704)
print v(xbgr.mr_n55028816)
print v(xbgr.mr_n55029136)
print v(xbgr.mr_n55029248)
print v(xbgr.mr_n55029568)
print v(xbgr.mr_n55029680)
print v(xbgr.mr_n55030000)
print v(xbgr.mr_n55030112)
print v(xbgr.mr_n55030432)
print v(xbgr.mr_n55030544)
print v(xbgr.mr_n55030864)
print v(xbgr.mr_n55030976)
print v(xbgr.mr_n55031296)
print v(xbgr.mr_n55031408)
print v(xbgr.mr_n56036064)
print v(xbgr.mr_n56036176)
print v(xbgr.mr_n56036432)
print v(xbgr.mr_n56036544)
print v(xbgr.mr_n56036800)
print v(xbgr.mr_n56036912)
print v(xbgr.mr_n56037168)
print v(xbgr.mr_n56037280)
print v(xbgr.mr_n56037536)
print v(xbgr.mr_n56037648)
print v(xbgr.mr_n56037904)
print v(xbgr.mr_n56038016)
print v(xbgr.mr_n56038272)
print v(xbgr.mr_n56038384)
print v(xbgr.mr_n56038640)
print v(xbgr.mr_n56038752)
print v(xbgr.mr_n56039008)
print v(xbgr.mr_n56039120)
print v(xbgr.mr_n56039376)
print v(xbgr.mr_n56039488)
print v(xbgr.mr_n56039808)
print v(xbgr.mr_n56039920)
print v(xbgr.mr_n56040240)
print v(xbgr.mr_n56040352)
print v(xbgr.mr_n56040672)
print v(xbgr.mr_n56040784)
print v(xbgr.mr_n56041104)
print v(xbgr.mr_n56041216)
print v(xbgr.mr_n56041536)
print v(xbgr.mr_n56041648)
print v(xbgr.mr_n56041968)
print v(xbgr.mr_n56042080)
print v(xbgr.mr_n56042400)
print v(xbgr.mr_n56042512)
print v(xbgr.mr_n56042832)
print v(xbgr.mr_n56042944)
print v(xbgr.mr_n56043264)
print v(xbgr.mr_n56043376)
print v(xbgr.mr_n56043696)
print v(xbgr.mr_n56043808)
print v(xbgr.mr_n56044128)
print v(xbgr.mr_n56044240)
print v(xbgr.mr_n56044560)
print v(xbgr.mr_n56044672)
print v(xbgr.mr_n56044992)
print v(xbgr.mr_n56045104)
print v(xbgr.mr_n56045424)
print v(xbgr.mr_n56045536)
print v(xbgr.mr_n56045856)
print v(xbgr.mr_n56045968)
print v(xbgr.mr_n56046288)
print v(xbgr.mr_n56046400)
print v(xbgr.mr_n56046720)
print v(xbgr.mr_n56046832)
print v(xbgr.mr_n56047152)
print v(xbgr.mr_n56047264)
print v(xbgr.mr_n56047584)
print v(xbgr.mr_n56047696)
print v(xbgr.mr_n56048016)
print v(xbgr.mr_n56048128)
print v(xbgr.mr_n56048448)
print v(xbgr.mr_n56048560)
print v(xbgr.mr_n56048880)
print v(xbgr.mr_n56048992)
print v(xbgr.mr_n56049312)
print v(xbgr.mr_n56049424)
print v(xbgr.mr_n56049744)
print v(xbgr.mr_n56049856)
print v(xbgr.mr_n56050176)
print v(xbgr.mr_n56050288)
print v(xbgr.mr_n56050608)
print v(xbgr.mr_n56050720)
print v(xbgr.mr_n56051040)
print v(xbgr.mr_n56051152)
print v(xbgr.mr_n56051472)
print v(xbgr.mr_n56051584)
print v(xbgr.mr_n56051904)
print v(xbgr.mr_n56052016)
print v(xbgr.mr_n56052336)
print v(xbgr.mr_n56052448)
print v(xbgr.mr_n56052768)
print v(xbgr.mr_n56052880)
print v(xbgr.mr_n56053200)
print v(xbgr.mr_n56053312)
print v(xbgr.mr_n56053632)
print v(xbgr.mr_n56053744)
print v(xbgr.mr_n56054064)
print v(xbgr.mr_n56054176)
print v(xbgr.mr_n56054496)
print v(xbgr.mr_n56054608)
print v(xbgr.mr_n56054928)
print v(xbgr.mr_n56055040)
print v(xbgr.mr_n56055360)
print v(xbgr.mr_n56055472)
print v(xbgr.mr_n56055792)
print v(xbgr.mr_n56055904)
print v(xbgr.mr_n56056224)
print v(xbgr.mr_n56056336)
print v(xbgr.mr_n56056656)
print v(xbgr.mr_n56056768)
print v(xbgr.mr_n56057088)
print v(xbgr.mr_n56057200)
print v(xbgr.mr_n56057520)
print v(xbgr.mr_n56057632)
print v(xbgr.mr_n56057952)
print v(xbgr.mr_n56058064)
print v(xbgr.mr_n56058384)
print v(xbgr.mr_n56058496)
print v(xbgr.mr_n56058816)
print v(xbgr.mr_n56058928)
print v(xbgr.mr_n56059248)
print v(xbgr.mr_n56059360)
print v(xbgr.mr_n56059680)
print v(xbgr.mr_n56059792)
print v(xbgr.mr_n56060112)
print v(xbgr.mr_n56060224)
print v(xbgr.mr_n56060544)
print v(xbgr.mr_n56060656)
print v(xbgr.mr_n56060976)
print v(xbgr.mr_n56061088)
print v(xbgr.mr_n56061408)
print v(xbgr.mr_n56061520)
print v(xbgr.mr_n56061840)
print v(xbgr.mr_n56061952)
print v(xbgr.mr_n56062272)
print v(xbgr.mr_n56062384)
print v(xbgr.mr_n56062704)
print v(xbgr.mr_n56062816)
print v(xbgr.mr_n56063136)
print v(xbgr.mr_n56063248)
print v(xbgr.mr_n56063568)
print v(xbgr.mr_n56063680)
print v(xbgr.mr_n56064000)
print v(xbgr.mr_n56064112)
print v(xbgr.mr_n56064432)
print v(xbgr.mr_n56064544)
print v(xbgr.mr_n56064864)
print v(xbgr.mr_n56064976)
print v(xbgr.mr_n56065296)
print v(xbgr.mr_n56065408)
print v(xbgr.mr_n56065728)
print v(xbgr.mr_n56065840)
print v(xbgr.mr_n56066160)
print v(xbgr.mr_n56066272)
print v(xbgr.mr_n56066592)
print v(xbgr.mr_n56066704)
print v(xbgr.mr_n56067024)
print v(xbgr.mr_n56067136)
print v(xbgr.mr_n56067456)
print v(xbgr.mr_n56067568)
print v(xbgr.mr_n56067888)
print v(xbgr.mr_n56068000)
print v(xbgr.mr_n56068320)
print v(xbgr.mr_n56068432)
print v(xbgr.mr_n56068752)
print v(xbgr.mr_n56068864)
print v(xbgr.mr_n56069184)
print v(xbgr.mr_n56069296)
print v(xbgr.mr_n56069616)
print v(xbgr.mr_n56069728)
print v(xbgr.mr_n56070048)
print v(xbgr.mr_n56070160)
print v(xbgr.mr_n56070480)
print v(xbgr.mr_n56070592)
print v(xbgr.mr_n56070912)
print v(xbgr.mr_n56071024)
print v(xbgr.mr_n56071344)
print v(xbgr.mr_n56071456)
print v(xbgr.mr_n56071776)
print v(xbgr.mr_n56071888)
print v(xbgr.mr_n56072208)
print v(xbgr.mr_n56072320)
print v(xbgr.mr_n56072640)
print v(xbgr.mr_n56072752)
print v(xbgr.mr_n56073072)
print v(xbgr.mr_n56073184)
print v(xbgr.mr_n56073504)
print v(xbgr.mr_n56073616)
print v(xbgr.mr_n56073936)
print v(xbgr.mr_n56074048)
print v(xbgr.mr_n56074368)
print v(xbgr.mr_n56074480)
print v(xbgr.mr_n56074800)
print v(xbgr.mr_n56074912)
print v(xbgr.mr_n56075232)
print v(xbgr.mr_n56075344)
print v(xbgr.mr_n56075664)
print v(xbgr.mr_n56075776)
print v(xbgr.mr_n56076096)
print v(xbgr.mr_n56076208)
print v(xbgr.mr_n56076528)
print v(xbgr.mr_n56076640)
print v(xbgr.mr_n56076960)
print v(xbgr.mr_n56077072)
print v(xbgr.mr_n56077392)
print v(xbgr.mr_n56077504)
print v(xbgr.mr_n56077824)
print v(xbgr.mr_n56077936)
print v(xbgr.mr_n56078256)
print v(xbgr.mr_n56078368)
print v(xbgr.mr_n56078688)
print v(xbgr.mr_n56078800)
print v(xbgr.mr_n56079120)
print v(xbgr.mr_n56079232)
print v(xbgr.mr_n56079552)
print v(xbgr.mr_n56079664)
print v(xbgr.mr_n56079984)
print v(xbgr.mr_n56080096)
print v(xbgr.mr_n56080416)
print v(xbgr.mr_n56080528)
print v(xbgr.mr_n56080848)
print v(xbgr.mr_n56080960)
print v(xbgr.mr_n56081280)
print v(xbgr.mr_n56081392)
print v(xbgr.mr_n56081712)
print v(xbgr.mr_n56081824)
print v(xbgr.mr_n56082144)
print v(xbgr.mr_n56082256)
print v(xbgr.mr_n56082576)
print v(xbgr.mr_n56082688)
print v(xbgr.mr_n56083008)
print v(xbgr.mr_n56083120)
print v(xbgr.mr_n56083440)
print v(xbgr.mr_n56083552)
print v(xbgr.mr_n56083872)
print v(xbgr.mr_n56083984)
print v(xbgr.mr_n56084304)
print v(xbgr.mr_n56084416)
print v(xbgr.mr_n56084736)
print v(xbgr.mr_n56084848)
print v(xbgr.mr_n56085168)
print v(xbgr.mr_n56085280)
print v(xbgr.mr_n56085600)
print v(xbgr.mr_n56085712)
print v(xbgr.mr_n56086032)
print v(xbgr.mr_n56086144)
print v(xbgr.mr_n56086464)
print v(xbgr.mr_n56086576)
print v(xbgr.mr_n56086896)
print v(xbgr.mr_n56087008)
print v(xbgr.mr_n56087328)
print v(xbgr.mr_n56087440)
print v(xbgr.mr_n56087760)
print v(xbgr.mr_n56087872)
print v(xbgr.mr_n56088192)
print v(xbgr.mr_n56088304)
print v(xbgr.mr_n56088624)
print v(xbgr.mr_n56088736)
print v(xbgr.mr_n56089056)
print v(xbgr.mr_n56089168)
print v(xbgr.mr_n56089488)
print v(xbgr.mr_n56089600)
print v(xbgr.mr_n56089920)
print v(xbgr.mr_n56090032)
print v(xbgr.mr_n56090352)
print v(xbgr.mr_n56090464)
print v(xbgr.mr_n56090784)
print v(xbgr.mr_n56090896)
print v(xbgr.mr_n56091216)
print v(xbgr.mr_n56091328)
print v(xbgr.mr_n56091648)
print v(xbgr.mr_n56091760)
print v(xbgr.mr_n56092080)
print v(xbgr.mr_n56092192)
print v(xbgr.mr_n56092512)
print v(xbgr.mr_n56092624)
print v(xbgr.mr_n56092944)
print v(xbgr.mr_n56093056)
print v(xbgr.mr_n56093376)
print v(xbgr.mr_n56093488)
print v(xbgr.mr_n56093808)
print v(xbgr.mr_n56093920)
print v(xbgr.mr_n56094240)
print v(xbgr.mr_n56094352)
print v(xbgr.mr_n56094672)
print v(xbgr.mr_n56094784)
print v(xbgr.mr_n56095104)
print v(xbgr.mr_n56095216)
print v(xbgr.mr_n56095536)
print v(xbgr.mr_n56095648)
print v(xbgr.mr_n56095968)
print v(xbgr.mr_n56096080)
print v(xbgr.mr_n56096400)
print v(xbgr.mr_n56096512)
print v(xbgr.mr_n56096832)
print v(xbgr.mr_n56096944)
print v(xbgr.mr_n56097264)
print v(xbgr.mr_n56097376)
print v(xbgr.mr_n56097696)
print v(xbgr.mr_n56097808)
print v(xbgr.mr_n56098128)
print v(xbgr.mr_n56098240)
print v(xbgr.mr_n56098560)
print v(xbgr.mr_n56098672)
print v(xbgr.mr_n56098992)
print v(xbgr.mr_n56099104)
print v(xbgr.mr_n56099424)
print v(xbgr.mr_n56099536)
print v(xbgr.mr_n56099856)
print v(xbgr.mr_n56099968)
print v(xbgr.mr_n56100288)
print v(xbgr.mr_n56100400)
print v(xbgr.mr_n56100720)
print v(xbgr.mr_n56100832)
print v(xbgr.mr_n56101152)
print v(xbgr.mr_n56101264)
print v(xbgr.mr_n56101584)
print v(xbgr.mr_n56101696)
print v(xbgr.mr_n56102016)
print v(xbgr.mr_n56102128)
print v(xbgr.mr_n56102448)
print v(xbgr.mr_n56102560)
print v(xbgr.mr_n56102880)
print v(xbgr.mr_n56102992)
print v(xbgr.mr_n56103312)
print v(xbgr.mr_n56103424)
print v(xbgr.mr_n56103744)
print v(xbgr.mr_n56103856)
print v(xbgr.mr_n56104176)
print v(xbgr.mr_n56104288)
print v(xbgr.mr_n56104608)
print v(xbgr.mr_n56104720)
print v(xbgr.mr_n56105040)
print v(xbgr.mr_n56105152)
print v(xbgr.mr_n56105472)
print v(xbgr.mr_n56105584)
print v(xbgr.mr_n56105904)
print v(xbgr.mr_n56106016)
print v(xbgr.mr_n56106336)
print v(xbgr.mr_n56106448)
print v(xbgr.mr_n56106768)
print v(xbgr.mr_n56106880)
print v(xbgr.mr_n56107200)
print v(xbgr.mr_n56107312)
print v(xbgr.mr_n56107632)
print v(xbgr.mr_n56107744)
print v(xbgr.mr_n56108064)
print v(xbgr.mr_n56108176)
print v(xbgr.mr_n56108496)
print v(xbgr.mr_n56108608)
print v(xbgr.mr_n56108928)
print v(xbgr.mr_n56109040)
print v(xbgr.mr_n56109360)
print v(xbgr.mr_n56109472)
print v(xbgr.mr_n56109792)
print v(xbgr.mr_n56109904)
print v(xbgr.mr_n56110224)
print v(xbgr.mr_n56110336)
print v(xbgr.mr_n56110656)
print v(xbgr.mr_n56110768)
print v(xbgr.mr_n56111088)
print v(xbgr.mr_n56111200)
print v(xbgr.mr_n56111520)
print v(xbgr.mr_n56111632)
print v(xbgr.mr_n56111952)
print v(xbgr.mr_n56112064)
print v(xbgr.mr_n56112384)
print v(xbgr.mr_n56112496)
print v(xbgr.mr_n56112816)
print v(xbgr.mr_n56112928)
print v(xbgr.mr_n56113248)
print v(xbgr.mr_n56113360)
print v(xbgr.mr_n56113680)
print v(xbgr.mr_n56113792)
print v(xbgr.mr_n56114112)
print v(xbgr.mr_n56114224)
print v(xbgr.mr_n56114544)
print v(xbgr.mr_n56114656)
print v(xbgr.mr_n56114976)
print v(xbgr.mr_n56115088)
print v(xbgr.mr_n56115408)
print v(xbgr.mr_n56115520)
print v(xbgr.mr_n56115840)
print v(xbgr.mr_n56115952)
print v(xbgr.mr_n56116272)
print v(xbgr.mr_n56116384)
print v(xbgr.mr_n56116704)
print v(xbgr.mr_n56116816)
print v(xbgr.mr_n56117136)
print v(xbgr.mr_n56117248)
print v(xbgr.mr_n56117568)
print v(xbgr.mr_n56117680)
print v(xbgr.mr_n56118000)
print v(xbgr.mr_n56118112)
print v(xbgr.mr_n56118432)
print v(xbgr.mr_n56118544)
print v(xbgr.mr_n56118864)
print v(xbgr.mr_n56118976)
print v(xbgr.mr_n56119296)
print v(xbgr.mr_n56119408)
print v(xbgr.mr_n56119728)
print v(xbgr.mr_n56119840)
print v(xbgr.mr_n56120160)
print v(xbgr.mr_n56120272)
print v(xbgr.mr_n56120592)
print v(xbgr.mr_n56120704)
print v(xbgr.mr_n56121024)
print v(xbgr.mr_n56121136)
print v(xbgr.mr_n56121456)
print v(xbgr.mr_n56121568)
print v(xbgr.mr_n56121888)
print v(xbgr.mr_n56122000)
print v(xbgr.mr_n56122320)
print v(xbgr.mr_n56122432)
print v(xbgr.mr_n56122752)
print v(xbgr.mr_n56122864)
print v(xbgr.mr_n56123184)
print v(xbgr.mr_n56123296)
print v(xbgr.mr_n56123616)
print v(xbgr.mr_n56123728)
print v(xbgr.mr_n56124048)
print v(xbgr.mr_n56124160)
print v(xbgr.mr_n56124480)
print v(xbgr.mr_n56124592)
print v(xbgr.mr_n56124912)
print v(xbgr.mr_n56125024)
print v(xbgr.mr_n56125344)
print v(xbgr.mr_n56125456)
print v(xbgr.mr_n56125776)
print v(xbgr.mr_n56125888)
print v(xbgr.mr_n56126208)
print v(xbgr.mr_n56126320)
print v(xbgr.mr_n56126640)
print v(xbgr.mr_n56126752)
print v(xbgr.mr_n56127072)
print v(xbgr.mr_n56127184)
print v(xbgr.mr_n56127504)
print v(xbgr.mr_n56127616)
print v(xbgr.mr_n56127936)
print v(xbgr.mr_n56128048)
print v(xbgr.mr_n56128368)
print v(xbgr.mr_n56128480)
print v(xbgr.mr_n56128800)
print v(xbgr.mr_n56128912)
print v(xbgr.mr_n56129232)
print v(xbgr.mr_n56129344)
print v(xbgr.mr_n56129664)
print v(xbgr.mr_n56129776)
print v(xbgr.mr_n56130096)
print v(xbgr.mr_n56130208)
print v(xbgr.mr_n56130528)
print v(xbgr.mr_n56130640)
print v(xbgr.mr_n56130960)
print v(xbgr.mr_n56131072)
print v(xbgr.mr_n56131392)
print v(xbgr.mr_n56131504)
print v(xbgr.mr_n56131824)
print v(xbgr.mr_n56131936)
print v(xbgr.mr_n56132256)
print v(xbgr.mr_n56132368)
print v(xbgr.mr_n56132688)
print v(xbgr.mr_n56132800)
print v(xbgr.mr_n56133120)
print v(xbgr.mr_n56133232)
print v(xbgr.mr_n56133552)
print v(xbgr.mr_n56133664)
print v(xbgr.mr_n56133984)
print v(xbgr.mr_n56134096)
print v(xbgr.mr_n56134416)
print v(xbgr.mr_n56134528)
print v(xbgr.mr_n56134848)
print v(xbgr.mr_n56134960)
print v(xbgr.mr_n56135280)
print v(xbgr.mr_n56135392)
print v(xbgr.mr_n56135712)
print v(xbgr.mr_n56135824)
print v(xbgr.mr_n56136144)
print v(xbgr.mr_n56136256)
print v(xbgr.mr_n56136576)
print v(xbgr.mr_n56136688)
print v(xbgr.mr_n56137008)
print v(xbgr.mr_n56137120)
print v(xbgr.mr_n56137440)
print v(xbgr.mr_n56137552)
print v(xbgr.mr_n56137872)
print v(xbgr.mr_n56137984)
print v(xbgr.mr_n56138304)
print v(xbgr.mr_n56138416)
print v(xbgr.mr_n56138736)
print v(xbgr.mr_n56138848)
print v(xbgr.mr_n56139168)
print v(xbgr.mr_n56139280)
print v(xbgr.mr_n56139600)
print v(xbgr.mr_n56139712)
print v(xbgr.mr_n56140000)
print v(xbgr.mr_n56140112)
print v(xbgr.mr_n56140432)
print v(xbgr.mr_n56140544)
print v(xbgr.mr_n56140864)
print v(xbgr.mr_n56140976)
print v(xbgr.mr_n56141296)
print v(xbgr.mr_n56141408)
print v(xbgr.mr_n56141728)
print v(xbgr.mr_n56141840)
print v(xbgr.mr_n56142160)
print v(xbgr.mr_n56142272)
print v(xbgr.mr_n56142592)
print v(xbgr.mr_n56142704)
print v(xbgr.mr_n56143024)
print v(xbgr.mr_n56143136)
print v(xbgr.mr_n56143456)
print v(xbgr.mr_n56143568)
print v(xbgr.mr_n56143888)
print v(xbgr.mr_n56144000)
print v(xbgr.mr_n56144320)
print v(xbgr.mr_n56144432)
print v(xbgr.mr_n56144752)
print v(xbgr.mr_n56144864)
print v(xbgr.mr_n56145184)
print v(xbgr.mr_n56145296)
print v(xbgr.mr_n56145616)
print v(xbgr.mr_n56145728)
print v(xbgr.mr_n56146048)
print v(xbgr.mr_n56146160)
print v(xbgr.mr_n56146480)
print v(xbgr.mr_n56146592)
print v(xbgr.mr_n56146912)
print v(xbgr.mr_n56147024)
print v(xbgr.mr_n56147344)
print v(xbgr.mr_n56147456)
print v(xbgr.mr_n56147776)
print v(xbgr.mr_n56147888)
print v(xbgr.mr_n56148208)
print v(xbgr.mr_n56148320)
print v(xbgr.mr_n56148640)
print v(xbgr.mr_n56148752)
print v(xbgr.mr_n56149072)
print v(xbgr.mr_n56149184)
print v(xbgr.mr_n56149504)
print v(xbgr.mr_n56149616)
print v(xbgr.mr_n56149936)
print v(xbgr.mr_n56150048)
print v(xbgr.mr_n56150368)
print v(xbgr.mr_n56150480)
print v(xbgr.mr_n56150800)
print v(xbgr.mr_n56150912)
print v(xbgr.mr_n56151232)
print v(xbgr.mr_n56151344)
print v(xbgr.mr_n56151664)
print v(xbgr.mr_n56151776)
print v(xbgr.mr_n56152096)
print v(xbgr.mr_n56152208)
print v(xbgr.mr_n56152528)
print v(xbgr.mr_n56152640)
print v(xbgr.mr_n56152960)
print v(xbgr.mr_n56153072)
print v(xbgr.mr_n56153392)
print v(xbgr.mr_n56153504)
print v(xbgr.mr_n56153824)
print v(xbgr.mr_n56153936)
print v(xbgr.mr_n56154256)
print v(xbgr.mr_n56154368)
print v(xbgr.mr_n56154688)
print v(xbgr.mr_n56154800)
print v(xbgr.mr_n56155120)
print v(xbgr.mr_n56155232)
print v(xbgr.mr_n56155552)
print v(xbgr.mr_n56155664)
print v(xbgr.mr_n56155984)
print v(xbgr.mr_n56156096)
print v(xbgr.mr_n56156416)
print v(xbgr.mr_n56156528)
print v(xbgr.mr_n56156848)
print v(xbgr.mr_n56156960)
print v(xbgr.mr_n56157280)
print v(xbgr.mr_n56157392)
print v(xbgr.mr_n56157712)
print v(xbgr.mr_n56157824)
print v(xbgr.mr_n56158144)
print v(xbgr.mr_n56158256)
print v(xbgr.mr_n56158576)
print v(xbgr.mr_n56158688)
print v(xbgr.mr_n56159008)
print v(xbgr.mr_n56159120)
print v(xbgr.mr_n56159440)
print v(xbgr.mr_n56159552)
print v(xbgr.mr_n56159872)
print v(xbgr.mr_n56159984)
print v(xbgr.mr_n56160304)
print v(xbgr.mr_n56160416)
print v(xbgr.mr_n56160736)
print v(xbgr.mr_n56160848)
print v(xbgr.mr_n56161168)
print v(xbgr.mr_n56161280)
print v(xbgr.mr_n56161600)
print v(xbgr.mr_n56161712)
print v(xbgr.mr_n56162032)
print v(xbgr.mr_n56162144)
print v(xbgr.mr_n56162464)
print v(xbgr.mr_n56162576)
print v(xbgr.mr_n56162896)
print v(xbgr.mr_n56163008)
print v(xbgr.mr_n56163328)
print v(xbgr.mr_n56163440)
print v(xbgr.mr_n56163760)
print v(xbgr.mr_n56163872)
print v(xbgr.mr_n56164192)
print v(xbgr.mr_n56164304)
print v(xbgr.mr_n56164624)
print v(xbgr.mr_n56164736)
print v(xbgr.mr_n56165056)
print v(xbgr.mr_n56165168)
print v(xbgr.mr_n56165488)
print v(xbgr.mr_n56165600)
print v(xbgr.mr_n56165920)
print v(xbgr.mr_n56166032)
print v(xbgr.mr_n56166352)
print v(xbgr.mr_n56166464)
print v(xbgr.mr_n56166784)
print v(xbgr.mr_n56166896)
print v(xbgr.mr_n56167216)
print v(xbgr.mr_n56167328)
print v(xbgr.mr_n56167648)
print v(xbgr.mr_n56167760)
print v(xbgr.mr_n56168080)
print v(xbgr.mr_n56168192)
print v(xbgr.mr_n56168512)
print v(xbgr.mr_n56168624)
print v(xbgr.mr_n56168944)
print v(xbgr.mr_n56169056)
print v(xbgr.mr_n56169376)
print v(xbgr.mr_n56169488)
print v(xbgr.mr_n56169808)
print v(xbgr.mr_n56169920)
print v(xbgr.mr_n56170240)
print v(xbgr.mr_n56170352)
print v(xbgr.mr_n56170672)
print v(xbgr.mr_n56170784)
print v(xbgr.mr_n56171104)
print v(xbgr.mr_n56171216)
print v(xbgr.mr_n56171536)
print v(xbgr.mr_n56171648)
print v(xbgr.mr_n56171968)
print v(xbgr.mr_n56172080)
print v(xbgr.mr_n56172400)
print v(xbgr.mr_n56172512)
print v(xbgr.mr_n56172832)
print v(xbgr.mr_n56172944)
print v(xbgr.mr_n56173264)
print v(xbgr.mr_n56173376)
print v(xbgr.mr_n56173696)
print v(xbgr.mr_n56173808)
print v(xbgr.mr_n56174128)
print v(xbgr.mr_n56174240)
print v(xbgr.mr_n56174560)
print v(xbgr.mr_n56174672)
print v(xbgr.mr_n56174992)
print v(xbgr.mr_n56175104)
print v(xbgr.mr_n56175424)
print v(xbgr.mr_n56175536)
print v(xbgr.mr_n56175856)
print v(xbgr.mr_n56175968)
print v(xbgr.mr_n56176288)
print v(xbgr.mr_n56176400)
print v(xbgr.mr_n56176720)
print v(xbgr.mr_n56176832)
print v(xbgr.mr_n56177152)
print v(xbgr.mr_n56177264)
print v(xbgr.mr_n56177584)
print v(xbgr.mr_n56177696)
print v(xbgr.mr_n56178016)
print v(xbgr.mr_n56178128)
print v(xbgr.mr_n56178448)
print v(xbgr.mr_n56178560)
print v(xbgr.mr_n56178880)
print v(xbgr.mr_n56178992)
print v(xbgr.mr_n56179312)
print v(xbgr.mr_n56179424)
print v(xbgr.mr_n56179744)
print v(xbgr.mr_n56179856)
print v(xbgr.mr_n56180176)
print v(xbgr.mr_n56180288)
print v(xbgr.mr_n56180608)
print v(xbgr.mr_n56180720)
print v(xbgr.mr_n56181040)
print v(xbgr.mr_n56181152)
print v(xbgr.mr_n56181472)
print v(xbgr.mr_n56181584)
print v(xbgr.mr_n56181904)
print v(xbgr.mr_n56182016)
print v(xbgr.mr_n56182336)
print v(xbgr.mr_n56182448)
print v(xbgr.mr_n56182768)
print v(xbgr.mr_n56182880)
print v(xbgr.mr_n56183200)
print v(xbgr.mr_n56183312)
print v(xbgr.mr_n56183632)
print v(xbgr.mr_n56183744)
print v(xbgr.mr_n56184064)
print v(xbgr.mr_n56184176)
print v(xbgr.mr_n56184496)
print v(xbgr.mr_n56184608)
print v(xbgr.mr_n56184928)
print v(xbgr.mr_n56185040)
print v(xbgr.mr_n56185360)
print v(xbgr.mr_n56185472)
print v(xbgr.mr_n56185792)
print v(xbgr.mr_n56185904)
print v(xbgr.mr_n56186224)
print v(xbgr.mr_n56186336)
print v(xbgr.mr_n56186656)
print v(xbgr.mr_n56186768)
print v(xbgr.mr_n56187088)
print v(xbgr.mr_n56187200)
print v(xbgr.mr_n56187520)
print v(xbgr.mr_n56187632)
print v(xbgr.mr_n56187952)
print v(xbgr.mr_n56188064)
print v(xbgr.mr_n56188384)
print v(xbgr.mr_n56188496)
print v(xbgr.mr_n56188816)
print v(xbgr.mr_n56188928)
print v(xbgr.mr_n56189248)
print v(xbgr.mr_n56189360)
print v(xbgr.mr_n56189680)
print v(xbgr.mr_n56189792)
print v(xbgr.mr_n56190112)
print v(xbgr.mr_n56190224)
print v(xbgr.mr_n56190544)
print v(xbgr.mr_n56190656)
print v(xbgr.mr_n56190976)
print v(xbgr.mr_n56191088)
print v(xbgr.mr_n56191408)
print v(xbgr.mr_n56191520)
print v(xbgr.mr_n56191840)
print v(xbgr.mr_n56191952)
print v(xbgr.mr_n56192272)
print v(xbgr.mr_n56192384)
print v(xbgr.mr_n56192704)
print v(xbgr.mr_n56192816)
print v(xbgr.mr_n56193136)
print v(xbgr.mr_n56193248)
print v(xbgr.mr_n56193568)
print v(xbgr.mr_n56193680)
print v(xbgr.mr_n56194000)
print v(xbgr.mr_n56194112)
print v(xbgr.mr_n56194432)
print v(xbgr.mr_n56194544)
print v(xbgr.mr_n56194864)
print v(xbgr.mr_n56194976)
print v(xbgr.mr_n56195296)
print v(xbgr.mr_n56195408)
print v(xbgr.mr_n56195728)
print v(xbgr.mr_n56195840)
print v(xbgr.mr_n56196160)
print v(xbgr.mr_n56196272)
print v(xbgr.mr_n56196592)
print v(xbgr.mr_n56196704)
print v(xbgr.mr_n56197024)
print v(xbgr.mr_n56197136)
print v(xbgr.mr_n56197456)
print v(xbgr.mr_n56197568)
print v(xbgr.mr_n56197888)
print v(xbgr.mr_n56198000)
print v(xbgr.mr_n56198320)
print v(xbgr.mr_n56198432)
print v(xbgr.mr_n56198752)
print v(xbgr.mr_n56198864)
print v(xbgr.mr_n56199184)
print v(xbgr.mr_n56199296)
print v(xbgr.mr_n56199616)
print v(xbgr.mr_n56199728)
print v(xbgr.mr_n56200048)
print v(xbgr.mr_n56200160)
print v(xbgr.mr_n56200480)
print v(xbgr.mr_n56200592)
print v(xbgr.mr_n56200912)
print v(xbgr.mr_n56201024)
print v(xbgr.mr_n56201344)
print v(xbgr.mr_n56201456)
print v(xbgr.mr_n56201776)
print v(xbgr.mr_n56201888)
print v(xbgr.mr_n56202208)
print v(xbgr.mr_n56202320)
print v(xbgr.mr_n56202640)
print v(xbgr.mr_n56202752)
print v(xbgr.mr_n56203072)
print v(xbgr.mr_n56203184)
print v(xbgr.mr_n56203504)
print v(xbgr.mr_n56203616)
print v(xbgr.mr_n56203936)
print v(xbgr.mr_n56204048)
print v(xbgr.mr_n56204368)
print v(xbgr.mr_n56204480)
print v(xbgr.mr_n56204800)
print v(xbgr.mr_n56204912)
print v(xbgr.mr_n56205232)
print v(xbgr.mr_n56205344)
print v(xbgr.mr_n56205664)
print v(xbgr.mr_n56205776)
print v(xbgr.mr_n56206096)
print v(xbgr.mr_n56206208)
print v(xbgr.mr_n56206528)
print v(xbgr.mr_n56206640)
print v(xbgr.mr_n56206960)
print v(xbgr.mr_n56207072)
print v(xbgr.mr_n56207392)
print v(xbgr.mr_n56207504)
print v(xbgr.mr_n56207824)
print v(xbgr.mr_n56207936)
print v(xbgr.mr_n56208256)
print v(xbgr.mr_n56208368)
print v(xbgr.mr_n56208688)
print v(xbgr.mr_n56208800)
print v(xbgr.mr_n56209120)
print v(xbgr.mr_n56209232)
print v(xbgr.mr_n56209552)
print v(xbgr.mr_n56209664)
print v(xbgr.mr_n56209984)
print v(xbgr.mr_n56210096)
print v(xbgr.mr_n56210416)
print v(xbgr.mr_n56210528)
print v(xbgr.mr_n56210848)
print v(xbgr.mr_n56210960)
print v(xbgr.mr_n56211280)
print v(xbgr.mr_n56211392)
print v(xbgr.mr_n56211712)
print v(xbgr.mr_n56211824)
print v(xbgr.mr_n56212144)
print v(xbgr.mr_n56212256)
print v(xbgr.mr_n56212576)
print v(xbgr.mr_n56212688)
print v(xbgr.mr_n56213008)
print v(xbgr.mr_n56213120)
print v(xbgr.mr_n56213440)
print v(xbgr.mr_n56213552)
print v(xbgr.mr_n56213872)
print v(xbgr.mr_n56213984)
print v(xbgr.mr_n56214304)
print v(xbgr.mr_n56214416)
print v(xbgr.mr_n56214736)
print v(xbgr.mr_n56214848)
print v(xbgr.mr_n56215168)
print v(xbgr.mr_n56215280)
print v(xbgr.mr_n56215600)
print v(xbgr.mr_n56215712)
print v(xbgr.mr_n56216032)
print v(xbgr.mr_n56216144)
print v(xbgr.mr_n56216464)
print v(xbgr.mr_n56216576)
print v(xbgr.mr_n56216896)
print v(xbgr.mr_n56217008)
print v(xbgr.mr_n56217328)
print v(xbgr.mr_n56217440)
print v(xbgr.mr_n56217760)
print v(xbgr.mr_n56217872)
print v(xbgr.mr_n56218192)
print v(xbgr.mr_n56218304)
print v(xbgr.mr_n56218624)
print v(xbgr.mr_n56218736)
print v(xbgr.mr_n56219056)
print v(xbgr.mr_n56219168)
print v(xbgr.mr_n56219488)
print v(xbgr.mr_n56219600)
print v(xbgr.mr_n56219920)
print v(xbgr.mr_n56220032)
print v(xbgr.mr_n56220352)
print v(xbgr.mr_n56220464)
print v(xbgr.mr_n56220784)
print v(xbgr.mr_n56220896)
print v(xbgr.mr_n56221216)
print v(xbgr.mr_n56221328)
print v(xbgr.mr_n56221648)
print v(xbgr.mr_n56221760)
print v(xbgr.mr_n56222080)
print v(xbgr.mr_n56222192)
print v(xbgr.mr_n56222512)
print v(xbgr.mr_n56222624)
print v(xbgr.mr_n56222944)
print v(xbgr.mr_n56223056)
print v(xbgr.mr_n56223376)
print v(xbgr.mr_n56223488)
print v(xbgr.mr_n56223808)
print v(xbgr.mr_n56223920)
print v(xbgr.mr_n56224240)
print v(xbgr.mr_n56224352)
print v(xbgr.mr_n56224672)
print v(xbgr.mr_n56224784)
print v(xbgr.mr_n56225104)
print v(xbgr.mr_n56225216)
print v(xbgr.mr_n56225536)
print v(xbgr.mr_n56225648)
print v(xbgr.mr_n56225968)
print v(xbgr.mr_n56226080)
print v(xbgr.mr_n56226400)
print v(xbgr.mr_n56226512)
print v(xbgr.mr_n56226832)
print v(xbgr.mr_n56226944)
print v(xbgr.mr_n56227264)
print v(xbgr.mr_n56227376)
print v(xbgr.mr_n56227696)
print v(xbgr.mr_n56227808)
print v(xbgr.mr_n56228128)
print v(xbgr.mr_n56228240)
print v(xbgr.mr_n56228560)
print v(xbgr.mr_n56228672)
print v(xbgr.mr_n56228992)
print v(xbgr.mr_n56229104)
print v(xbgr.mr_n56229424)
print v(xbgr.mr_n56229536)
print v(xbgr.mr_n56229856)
print v(xbgr.mr_n56229968)
print v(xbgr.mr_n56230288)
print v(xbgr.mr_n56230400)
print v(xbgr.mr_n56230720)
print v(xbgr.mr_n56230832)
print v(xbgr.mr_n56231152)
print v(xbgr.mr_n56231264)
print v(xbgr.mr_n56231584)
print v(xbgr.mr_n56231696)
print v(xbgr.mr_n56232016)
print v(xbgr.mr_n56232128)
print v(xbgr.mr_n56232448)
print v(xbgr.mr_n56232560)
print v(xbgr.mr_n56232880)
print v(xbgr.mr_n56232992)
print v(xbgr.mr_n56233312)
print v(xbgr.mr_n56233424)
print v(xbgr.mr_n56233744)
print v(xbgr.mr_n56233856)
print v(xbgr.mr_n56234176)
print v(xbgr.mr_n56234288)
print v(xbgr.mr_n56234608)
print v(xbgr.mr_n56234720)
print v(xbgr.mr_n56235040)
print v(xbgr.mr_n56235152)
print v(xbgr.mr_n56235472)
print v(xbgr.mr_n56235584)
print v(xbgr.mr_n56235904)
print v(xbgr.mr_n56236016)
print v(xbgr.mr_n56236336)
print v(xbgr.mr_n56236448)
print v(xbgr.mr_n56236768)
print v(xbgr.mr_n56236880)
print v(xbgr.mr_n56237200)
print v(xbgr.mr_n56237312)
print v(xbgr.mr_n56237632)
print v(xbgr.mr_n56237744)
print v(xbgr.mr_n56238064)
print v(xbgr.mr_n56238176)
print v(xbgr.mr_n56238496)
print v(xbgr.mr_n56238608)
print v(xbgr.mr_n56238928)
print v(xbgr.mr_n56239040)
print v(xbgr.mr_n56239360)
print v(xbgr.mr_n56239472)
print v(xbgr.mr_n56239792)
print v(xbgr.mr_n56239904)
print v(xbgr.mr_n56240224)
print v(xbgr.mr_n56240336)
print v(xbgr.mr_n56240656)
print v(xbgr.mr_n56240768)
print v(xbgr.mr_n56241088)
print v(xbgr.mr_n56241200)
print v(xbgr.mr_n56241520)
print v(xbgr.mr_n56241632)
print v(xbgr.mr_n56241952)
print v(xbgr.mr_n56242064)
print v(xbgr.mr_n56242384)
print v(xbgr.mr_n56242496)
print v(xbgr.mr_n56242816)
print v(xbgr.mr_n56242928)
print v(xbgr.mr_n56243248)
print v(xbgr.mr_n56243360)
print v(xbgr.mr_n56243680)
print v(xbgr.mr_n56243792)
print v(xbgr.mr_n56244112)
print v(xbgr.mr_n56244224)
print v(xbgr.mr_n56244544)
print v(xbgr.mr_n56244656)
print v(xbgr.mr_n56244976)
print v(xbgr.mr_n56245088)
print v(xbgr.mr_n56245408)
print v(xbgr.mr_n56245520)
print v(xbgr.mr_n56245840)
print v(xbgr.mr_n56245952)
print v(xbgr.mr_n56246272)
print v(xbgr.mr_n56246384)
print v(xbgr.mr_n56246704)
print v(xbgr.mr_n56246816)
print v(xbgr.mr_n56247136)
print v(xbgr.mr_n56247248)
print v(xbgr.mr_n56247568)
print v(xbgr.mr_n56247680)
print v(xbgr.mr_n56248000)
print v(xbgr.mr_n56248112)
print v(xbgr.mr_n56248432)
print v(xbgr.mr_n56248544)
print v(xbgr.mr_n56248864)
print v(xbgr.mr_n56248976)
print v(xbgr.mr_n56249296)
print v(xbgr.mr_n56249408)
print v(xbgr.mr_n56249728)
print v(xbgr.mr_n56249840)
print v(xbgr.mr_n56250160)
print v(xbgr.mr_n56250272)
print v(xbgr.mr_n56250592)
print v(xbgr.mr_n56250704)
print v(xbgr.mr_n56251024)
print v(xbgr.mr_n56251136)
print v(xbgr.mr_n56251456)
print v(xbgr.mr_n56251568)
print v(xbgr.mr_n56251888)
print v(xbgr.mr_n56252000)
print v(xbgr.mr_n56252320)
print v(xbgr.mr_n56252432)
print v(xbgr.mr_n56252752)
print v(xbgr.mr_n56252864)
print v(xbgr.mr_n56253184)
print v(xbgr.mr_n56253296)
print v(xbgr.mr_n56253616)
print v(xbgr.mr_n56253728)
print v(xbgr.mr_n56254048)
print v(xbgr.mr_n56254160)
print v(xbgr.mr_n56254480)
print v(xbgr.mr_n56254592)
print v(xbgr.mr_n56254912)
print v(xbgr.mr_n56255024)
print v(xbgr.mr_n56255344)
print v(xbgr.mr_n56255456)
print v(xbgr.mr_n56255776)
print v(xbgr.mr_n56255888)
print v(xbgr.mr_n56256208)
print v(xbgr.mr_n56256320)
print v(xbgr.mr_n56256640)
print v(xbgr.mr_n56256752)
print v(xbgr.mr_n56257072)
print v(xbgr.mr_n56257184)
print v(xbgr.mr_n56257504)
print v(xbgr.mr_n56257616)
print v(xbgr.mr_n56257936)
print v(xbgr.mr_n56258048)
print v(xbgr.mr_n56258368)
print v(xbgr.mr_n56258480)
print v(xbgr.mr_n56258800)
print v(xbgr.mr_n56258912)
print v(xbgr.mr_n56259232)
print v(xbgr.mr_n56259344)
print v(xbgr.mr_n56259664)
print v(xbgr.mr_n56259776)
print v(xbgr.mr_n56260096)
print v(xbgr.mr_n56260208)
print v(xbgr.mr_n56260528)
print v(xbgr.mr_n56260640)
print v(xbgr.mr_n56260960)
print v(xbgr.mr_n56261072)
print v(xbgr.mr_n56261392)
print v(xbgr.mr_n56261504)
print v(xbgr.mr_n56261824)
print v(xbgr.mr_n56261936)
print v(xbgr.mr_n56262256)
print v(xbgr.mr_n56262368)
print v(xbgr.mr_n56262688)
print v(xbgr.mr_n56262800)
print v(xbgr.mr_n56263120)
print v(xbgr.mr_n56263232)
print v(xbgr.mr_n56263552)
print v(xbgr.mr_n56263664)
print v(xbgr.mr_n56263984)
print v(xbgr.mr_n56264096)
print v(xbgr.mr_n56264416)
print v(xbgr.mr_n56264528)
print v(xbgr.mr_n56264848)
print v(xbgr.mr_n56264960)
print v(xbgr.mr_n56265280)
print v(xbgr.mr_n56265392)
print v(xbgr.mr_n56265712)
print v(xbgr.mr_n56265824)
print v(xbgr.mr_n56266144)
print v(xbgr.mr_n56266256)
print v(xbgr.mr_n56266576)
print v(xbgr.mr_n56266688)
print v(xbgr.mr_n56267008)
print v(xbgr.mr_n56267120)
print v(xbgr.mr_n56267440)
print v(xbgr.mr_n56267552)
print v(xbgr.mr_n56267872)
print v(xbgr.mr_n56267984)
print v(xbgr.mr_n56268304)
print v(xbgr.mr_n56268416)
print v(xbgr.mr_n56268736)
print v(xbgr.mr_n56268848)
print v(xbgr.mr_n56269168)
print v(xbgr.mr_n56269280)
print v(xbgr.mr_n56269600)
print v(xbgr.mr_n56269712)
print v(xbgr.mr_n56270032)
print v(xbgr.mr_n56270144)
print v(xbgr.mr_n56270464)
print v(xbgr.mr_n56270576)
print v(xbgr.mr_n56270896)
print v(xbgr.mr_n56271008)
print v(xbgr.mr_n56271328)
print v(xbgr.mr_n56271440)
print v(xbgr.mr_n56271760)
print v(xbgr.mr_n56271872)
print v(xbgr.mr_n56272192)
print v(xbgr.mr_n56272304)
print v(xbgr.mr_n56272624)
print v(xbgr.mr_n56272736)
print v(xbgr.mr_n56273056)
print v(xbgr.mr_n56273168)
print v(xbgr.mr_n56273488)
print v(xbgr.mr_n56273600)
print v(xbgr.mr_n56273920)
print v(xbgr.mr_n56274032)
print v(xbgr.mr_n56274352)
print v(xbgr.mr_n56274464)
print v(xbgr.mr_n56274784)
print v(xbgr.mr_n56274896)
print v(xbgr.mr_n56275216)
print v(xbgr.mr_n56275328)
print v(xbgr.mr_n56275648)
print v(xbgr.mr_n56275760)
print v(xbgr.mr_n56276080)
print v(xbgr.mr_n56276192)
print v(xbgr.mr_n56276512)
print v(xbgr.mr_n56276624)
print v(xbgr.mr_n56276944)
print v(xbgr.mr_n56277056)
print v(xbgr.mr_n56277376)
print v(xbgr.mr_n56277488)
print v(xbgr.mr_n56277808)
print v(xbgr.mr_n56277920)
print v(xbgr.mr_n56278240)
print v(xbgr.mr_n56278352)
print v(xbgr.mr_n56278672)
print v(xbgr.mr_n56278784)
print v(xbgr.mr_n56279104)
print v(xbgr.mr_n56279216)
print v(xbgr.mr_n56279536)
print v(xbgr.mr_n56279648)
print v(xbgr.mr_n56279968)
print v(xbgr.mr_n56280080)
print v(xbgr.mr_n56280400)
print v(xbgr.mr_n56280512)
print v(xbgr.mr_n56280832)
print v(xbgr.mr_n56280944)
print v(xbgr.mr_n56281264)
print v(xbgr.mr_n56281376)
print v(xbgr.mr_n56281696)
print v(xbgr.mr_n56281808)
print v(xbgr.mr_n56282128)
print v(xbgr.mr_n56282240)
print v(xbgr.mr_n56282560)
print v(xbgr.mr_n56282672)
print v(xbgr.mr_n56282992)
print v(xbgr.mr_n56283104)
print v(xbgr.mr_n56283424)
print v(xbgr.mr_n56283536)
print v(xbgr.mr_n56283856)
print v(xbgr.mr_n56283968)
print v(xbgr.mr_n56284288)
print v(xbgr.mr_n56284400)
print v(xbgr.mr_n56284720)
print v(xbgr.mr_n56284832)
print v(xbgr.mr_n56285152)
print v(xbgr.mr_n56285264)
print v(xbgr.mr_n56285584)
print v(xbgr.mr_n56285696)
print v(xbgr.mr_n56286016)
print v(xbgr.mr_n56286128)
print v(xbgr.mr_n56286448)
print v(xbgr.mr_n56286560)
print v(xbgr.mr_n56286880)
print v(xbgr.mr_n56286992)
print v(xbgr.mr_n56287312)
print v(xbgr.mr_n56287424)
print v(xbgr.mr_n56287744)
print v(xbgr.mr_n56287856)
print v(xbgr.mr_n56288176)
print v(xbgr.mr_n56288288)
print v(xbgr.mr_n56288608)
print v(xbgr.mr_n56288720)
print v(xbgr.mr_n56289040)
print v(xbgr.mr_n56289152)
print v(xbgr.mr_n56289472)
print v(xbgr.mr_n56289584)
print v(xbgr.mr_n56289904)
print v(xbgr.mr_n56290016)
print v(xbgr.mr_n56290336)
print v(xbgr.mr_n56290448)
print v(xbgr.mr_n56290768)
print v(xbgr.mr_n56290880)
print v(xbgr.mr_n56291200)
print v(xbgr.mr_n56291312)
print v(xbgr.mr_n56291632)
print v(xbgr.mr_n56291744)
print v(xbgr.mr_n56292064)
print v(xbgr.mr_n56292176)
print v(xbgr.mr_n56292496)
print v(xbgr.mr_n56292608)
print v(xbgr.mr_n56292928)
print v(xbgr.mr_n56293040)
print v(xbgr.mr_n56293360)
print v(xbgr.mr_n56293472)
print v(xbgr.mr_n56293792)
print v(xbgr.mr_n56293904)
print v(xbgr.mr_n56294224)
print v(xbgr.mr_n56294336)
print v(xbgr.mr_n56294656)
print v(xbgr.mr_n56294768)
print v(xbgr.mr_n56295088)
print v(xbgr.mr_n56295200)
print v(xbgr.mr_n56295520)
print v(xbgr.mr_n56295632)
print v(xbgr.mr_n56295952)
print v(xbgr.mr_n56296064)
print v(xbgr.mr_n56296384)
print v(xbgr.mr_n56296496)
print v(xbgr.mr_n56296816)
print v(xbgr.mr_n56296928)
print v(xbgr.mr_n56297248)
print v(xbgr.mr_n56297360)
print v(xbgr.mr_n56297680)
print v(xbgr.mr_n56297792)
print v(xbgr.mr_n56298112)
print v(xbgr.mr_n56298224)
print v(xbgr.mr_n56298544)
print v(xbgr.mr_n56298656)
print v(xbgr.mr_n56298976)
print v(xbgr.mr_n56299088)
print v(xbgr.mr_n56299408)
print v(xbgr.mr_n56299520)
print v(xbgr.mr_n56299840)
print v(xbgr.mr_n56299952)
print v(xbgr.mr_n56300272)
print v(xbgr.mr_n56300384)
print v(xbgr.mr_n56300704)
print v(xbgr.mr_n56300816)
print v(xbgr.mr_n56301136)
print v(xbgr.mr_n56301248)
print v(xbgr.mr_n56301568)
print v(xbgr.mr_n56301680)
print v(xbgr.mr_n56302000)
print v(xbgr.mr_n56302112)
print v(xbgr.mr_n56302432)
print v(xbgr.mr_n56302544)
print v(xbgr.mr_n56302864)
print v(xbgr.mr_n56302976)
print v(xbgr.mr_n56303296)
print v(xbgr.mr_n56303408)
print v(xbgr.mr_n56303728)
print v(xbgr.mr_n56303840)
print v(xbgr.mr_n56304160)
print v(xbgr.mr_n56304272)
print v(xbgr.mr_n56304592)
print v(xbgr.mr_n56304704)
print v(xbgr.mr_n56305024)
print v(xbgr.mr_n56305136)
print v(xbgr.mr_n56305456)
print v(xbgr.mr_n56305568)
print v(xbgr.mr_n56305888)
print v(xbgr.mr_n56306000)
print v(xbgr.mr_n56306320)
print v(xbgr.mr_n56306432)
print v(xbgr.mr_n56306752)
print v(xbgr.mr_n56306864)
print v(xbgr.mr_n56307184)
print v(xbgr.mr_n56307296)
print v(xbgr.mr_n56307616)
print v(xbgr.mr_n56307728)
print v(xbgr.mr_n56308048)
print v(xbgr.mr_n56308160)
print v(xbgr.mr_n56308480)
print v(xbgr.mr_n56308592)
print v(xbgr.mr_n56308912)
print v(xbgr.mr_n56309024)
print v(xbgr.mr_n56309344)
print v(xbgr.mr_n56309456)
print v(xbgr.mr_n56309776)
print v(xbgr.mr_n56309888)
print v(xbgr.mr_n56310208)
print v(xbgr.mr_n56310320)
print v(xbgr.mr_n56310640)
print v(xbgr.mr_n56310752)
print v(xbgr.mr_n56311072)
print v(xbgr.mr_n56311184)
print v(xbgr.mr_n56311504)
print v(xbgr.mr_n56311616)
print v(xbgr.mr_n56311936)
print v(xbgr.mr_n56312048)
print v(xbgr.mr_n56312368)
print v(xbgr.mr_n56312480)
print v(xbgr.mr_n56312800)
print v(xbgr.mr_n56312912)
print v(xbgr.mr_n56313232)
print v(xbgr.mr_n56313344)
print v(xbgr.mr_n56313664)
print v(xbgr.mr_n56313776)
print v(xbgr.mr_n56314096)
print v(xbgr.mr_n56314208)
print v(xbgr.mr_n56314528)
print v(xbgr.mr_n56314640)
print v(xbgr.mr_n56314960)
print v(xbgr.mr_n56315072)
print v(xbgr.mr_n56315392)
print v(xbgr.mr_n56315504)
print v(xbgr.mr_n56315824)
print v(xbgr.mr_n56315936)
print v(xbgr.mr_n56316256)
print v(xbgr.mr_n56316368)
print v(xbgr.mr_n56316688)
print v(xbgr.mr_n56316800)
print v(xbgr.mr_n56317120)
print v(xbgr.mr_n56317232)
print v(xbgr.mr_n56317552)
print v(xbgr.mr_n56317664)
print v(xbgr.mr_n56317984)
print v(xbgr.mr_n56318096)
print v(xbgr.mr_n56318416)
print v(xbgr.mr_n56318528)
print v(xbgr.mr_n56318848)
print v(xbgr.mr_n56318960)
print v(xbgr.mr_n56319280)
print v(xbgr.mr_n56319392)
print v(xbgr.mr_n56319712)
print v(xbgr.mr_n56319824)
print v(xbgr.mr_n56320144)
print v(xbgr.mr_n56320256)
print v(xbgr.mr_n56320576)
print v(xbgr.mr_n56320688)
print v(xbgr.mr_n56321008)
print v(xbgr.mr_n56321120)
print v(xbgr.mr_n56321440)
print v(xbgr.mr_n56321552)
print v(xbgr.mr_n56321872)
print v(xbgr.mr_n56321984)
print v(xbgr.mr_n56322304)
print v(xbgr.mr_n56322416)
print v(xbgr.mr_n56322736)
print v(xbgr.mr_n56322848)
print v(xbgr.mr_n56323168)
print v(xbgr.mr_n56323280)
print v(xbgr.mr_n56323600)
print v(xbgr.mr_n56323712)
print v(xbgr.mr_n56324032)
print v(xbgr.mr_n56324144)
print v(xbgr.mr_n56324464)
print v(xbgr.mr_n56324576)
print v(xbgr.mr_n56324896)
print v(xbgr.mr_n56325008)
print v(xbgr.mr_n56325328)
print v(xbgr.mr_n56325440)
print v(xbgr.mr_n56325760)
print v(xbgr.mr_n56325872)
print v(xbgr.mr_n56326192)
print v(xbgr.mr_n56326304)
print v(xbgr.mr_n56326624)
print v(xbgr.mr_n56326736)
print v(xbgr.mr_n56327056)
print v(xbgr.mr_n56327168)
print v(xbgr.mr_n56327488)
print v(xbgr.mr_n56327600)
print v(xbgr.mr_n56327920)
print v(xbgr.mr_n56328032)
print v(xbgr.mr_n56328352)
print v(xbgr.mr_n56328464)
print v(xbgr.mr_n56328784)
print v(xbgr.mr_n56328896)
print v(xbgr.mr_n56329216)
print v(xbgr.mr_n56329328)
print v(xbgr.mr_n56329648)
print v(xbgr.mr_n56329760)
print v(xbgr.mr_n56330080)
print v(xbgr.mr_n56330192)
print v(xbgr.mr_n56330512)
print v(xbgr.mr_n56330624)
print v(xbgr.mr_n56330944)
print v(xbgr.mr_n56331056)
print v(xbgr.mr_n56331376)
print v(xbgr.mr_n56331488)
print v(xbgr.mr_n56331808)
print v(xbgr.mr_n56331920)
print v(xbgr.mr_n56332240)
print v(xbgr.mr_n56332352)
print v(xbgr.mr_n56332672)
print v(xbgr.mr_n56332784)
print v(xbgr.mr_n56333104)
print v(xbgr.mr_n56333216)
print v(xbgr.mr_n56333536)
print v(xbgr.mr_n56333648)
print v(xbgr.mr_n56333968)
print v(xbgr.mr_n56334080)
print v(xbgr.mr_n56334400)
print v(xbgr.mr_n56334512)
print v(xbgr.mr_n56334832)
print v(xbgr.mr_n56334944)
print v(xbgr.mr_n56335264)
print v(xbgr.mr_n56335376)
print v(xbgr.mr_n56335696)
print v(xbgr.mr_n56335808)
print v(xbgr.mr_n56336128)
print v(xbgr.mr_n56336240)
print v(xbgr.mr_n56336560)
print v(xbgr.mr_n56336672)
print v(xbgr.mr_n56336992)
print v(xbgr.mr_n56337104)
print v(xbgr.mr_n56337424)
print v(xbgr.mr_n56337536)
print v(xbgr.mr_n56337856)
print v(xbgr.mr_n56337968)
print v(xbgr.mr_n56338288)
print v(xbgr.mr_n56338400)
print v(xbgr.mr_n56338720)
print v(xbgr.mr_n56338832)
print v(xbgr.mr_n56339152)
print v(xbgr.mr_n56339264)
print v(xbgr.mr_n56339584)
print v(xbgr.mr_n56339696)
print v(xbgr.mr_n56340016)
print v(xbgr.mr_n56340128)
print v(xbgr.mr_n56340448)
print v(xbgr.mr_n56340560)
print v(xbgr.mr_n56340880)
print v(xbgr.mr_n56340992)
print v(xbgr.mr_n56341312)
print v(xbgr.mr_n56341424)
print v(xbgr.mr_n56341744)
print v(xbgr.mr_n56341856)
print v(xbgr.mr_n56342176)
print v(xbgr.mr_n56342288)
print v(xbgr.mr_n56342608)
print v(xbgr.mr_n56342720)
print v(xbgr.mr_n56343040)
print v(xbgr.mr_n56343152)
print v(xbgr.mr_n56343472)
print v(xbgr.mr_n56343584)
print v(xbgr.mr_n56343904)
print v(xbgr.mr_n56344016)
print v(xbgr.mr_n56344336)
print v(xbgr.mr_n56344448)
print v(xbgr.mr_n56344768)
print v(xbgr.mr_n56344880)
print v(xbgr.mr_n56345312)
print v(xbgr.mr_n56345632)
print v(xbgr.mr_n56345744)
print v(xbgr.mr_n56346176)
print v(xbgr.mr_n56346496)
print v(xbgr.mr_n56346608)
print v(xbgr.mr_n56347040)
print v(xbgr.mr_n56347360)
print v(xbgr.mr_n56348224)
print v(xbgr.mr_n56349088)
print v(xbgr.mr_n56349952)
print v(xbgr.mr_n56350816)
print v(xbgr.mr_n56351680)
print v(xbgr.mr_n56352544)
print v(xbgr.mr_n56352656)
print v(xbgr.mr_n56352976)
print v(xbgr.mr_n56353088)
print v(xbgr.mr_n56353408)
print v(xbgr.mr_n56353520)
print v(xbgr.mr_n56353840)
print v(xbgr.mr_n56353952)
print v(xbgr.mr_n56354272)
print v(xbgr.mr_n56355136)
print v(xbgr.mr_n56356000)
print v(xbgr.mr_n56356864)
print v(xbgr.mr_n56356976)
print v(xbgr.mr_n56357296)
print v(xbgr.mr_n56357408)
print v(xbgr.mr_n56357728)
print v(xbgr.mr_n56357840)
print v(xbgr.mr_n56358272)
print v(xbgr.mr_n56358704)
print v(xbgr.mr_n56359136)
print v(xbgr.mr_n56359456)
print v(xbgr.mr_n56359568)
print v(xbgr.mr_n56359888)
print v(xbgr.mr_n56360000)
print v(xbgr.mr_n56360320)
print v(xbgr.mr_n56360432)
print v(xbgr.mr_n56360752)
print v(xbgr.mr_n56360864)
print v(xbgr.mr_n56361184)
print v(xbgr.mr_n56361296)
print v(xbgr.mr_n56361616)
print v(xbgr.mr_n56361728)
print v(xbgr.mr_n56362048)
print v(xbgr.mr_n56362160)
print v(xbgr.mr_n56362480)
print v(xbgr.mr_n56362592)
print v(xbgr.mr_n56362912)
print v(xbgr.mr_n56363024)
print v(xbgr.mr_n56363344)
print v(xbgr.mr_n56363456)
print v(xbgr.mr_n56363776)
print v(xbgr.mr_n56363888)
print v(xbgr.mr_n56364208)
print v(xbgr.mr_n56364320)
print v(xbgr.mr_n56364640)
print v(xbgr.mr_n56364752)
print v(xbgr.mr_n56365072)
print v(xbgr.mr_n56365184)
print v(xbgr.mr_n56365504)
print v(xbgr.mr_n56365616)
print v(xbgr.mr_n56365936)
print v(xbgr.mr_n56366048)
print v(xbgr.mr_n56366368)
print v(xbgr.mr_n56366480)
print v(xbgr.mr_n56366800)
print v(xbgr.mr_n56366912)
print v(xbgr.mr_n56367232)
print v(xbgr.mr_n56367344)
print v(xbgr.mr_n56367664)
print v(xbgr.mr_n56367776)
print v(xbgr.mr_n56368096)
print v(xbgr.mr_n56368208)
print v(xbgr.mr_n56368528)
print v(xbgr.mr_n56368640)
print v(xbgr.mr_n56368960)
print v(xbgr.mr_n56369072)
print v(xbgr.mr_n56369392)
print v(xbgr.mr_n56369504)
print v(xbgr.mr_n56369824)
print v(xbgr.mr_n56369936)
print v(xbgr.mr_n56370256)
print v(xbgr.mr_n56370368)
print v(xbgr.mr_n56370688)
print v(xbgr.mr_n56370800)
print v(xbgr.mr_n56371120)
print v(xbgr.mr_n56371232)
print v(xbgr.mr_n56371552)
print v(xbgr.mr_n56371664)
print v(xbgr.mr_n56371984)
print v(xbgr.mr_n56372096)
print v(xbgr.mr_n56372416)
print v(xbgr.mr_n56372528)
print v(xbgr.mr_n56372960)
print v(xbgr.mr_n56373280)
print v(xbgr.mr_n56373392)
print v(xbgr.mr_n56373824)
print v(xbgr.mr_n56374144)
print v(xbgr.mr_n56375008)
print v(xbgr.mr_n56375872)
print v(xbgr.mr_n56376736)
print v(xbgr.mr_n56377600)
print v(xbgr.mr_n56377712)
print v(xbgr.mr_n56378032)
print v(xbgr.mr_n56378144)
print v(xbgr.mr_n56378464)
print v(xbgr.mr_n56378576)
print v(xbgr.mr_n56378896)
print v(xbgr.mr_n56379008)
print v(xbgr.mr_n56379328)
print v(xbgr.mr_n56380192)
print v(xbgr.mr_n56381056)
print v(xbgr.mr_n56381168)
print v(xbgr.mr_n56381488)
print v(xbgr.mr_n56381600)
print v(xbgr.mr_n56381920)
print v(xbgr.mr_n56382032)
print v(xbgr.mr_n56382352)
print v(xbgr.mr_n56382464)
print v(xbgr.mr_n56382784)
print v(xbgr.mr_n56382896)
print v(xbgr.mr_n56383328)
print v(xbgr.mr_n56383648)
print v(xbgr.mr_n56383760)
print v(xbgr.mr_n56384192)
print v(xbgr.mr_n56384512)
print v(xbgr.mr_n56385376)
print v(xbgr.mr_n56386240)
print v(xbgr.mr_n56387104)
print v(xbgr.mr_n56387968)
print v(xbgr.mr_n56388080)
print v(xbgr.mr_n56388400)
print v(xbgr.mr_n56388512)
print v(xbgr.mr_n56388832)
print v(xbgr.mr_n56388944)
print v(xbgr.mr_n56389264)
print v(xbgr.mr_n56389376)
print v(xbgr.mr_n56389696)
print v(xbgr.mr_n56390560)
print v(xbgr.mr_n56391424)
print v(xbgr.mr_n56391536)
print v(xbgr.mr_n56391968)
print v(xbgr.mr_n56392288)
print v(xbgr.mr_n56392400)
print v(xbgr.mr_n56392720)
print v(xbgr.mr_n56392832)
print v(xbgr.mr_n56393152)
print v(xbgr.mr_n56393264)
print v(xbgr.mr_n56393584)
print v(xbgr.mr_n56393696)
print v(xbgr.mr_n56394016)
print v(xbgr.mr_n56394128)
print v(xbgr.mr_n56394560)
print v(xbgr.mr_n56394880)
print v(xbgr.mr_n56395744)
print v(xbgr.mr_n56395856)
print v(xbgr.mr_n56396288)
print v(xbgr.mr_n56396608)
print v(xbgr.mr_n56396720)
print v(xbgr.mr_n56397152)
print v(xbgr.mr_n56397472)
print v(xbgr.mr_n56397584)
print v(xbgr.mr_n56397904)
print v(xbgr.mr_n56398016)
print v(xbgr.mr_n56398336)
print v(xbgr.mr_n56398448)
print v(xbgr.mr_n56398768)
print v(xbgr.mr_n56398880)
print v(xbgr.mr_n56399200)
print v(xbgr.mr_n56400064)
print v(xbgr.mr_n56400928)
print v(xbgr.mr_n56401040)
print v(xbgr.mr_n56401360)
print v(xbgr.mr_n56401472)
print v(xbgr.mr_n56401792)
print v(xbgr.mr_n56401904)
print v(xbgr.mr_n56402224)
print v(xbgr.mr_n56402336)
print v(xbgr.mr_n56402656)
print v(xbgr.mr_n56403520)
print v(xbgr.mr_n56404384)
print v(xbgr.mr_n56404496)
print v(xbgr.mr_n56404816)
print v(xbgr.mr_n56404928)
print v(xbgr.mr_n56405248)
print v(xbgr.mr_n56406112)
print v(xbgr.mr_n56406224)
print v(xbgr.mr_n56406544)
print v(xbgr.mr_n56406656)
print v(xbgr.mr_n56406976)
print v(xbgr.mr_n56407088)
print v(xbgr.mr_n56407408)
print v(xbgr.mr_n56407520)
print v(xbgr.mr_n56407840)
print v(xbgr.mr_n56407952)
print v(xbgr.mr_n56408272)
print v(xbgr.mr_n56408384)
print v(xbgr.mr_n56408704)
print v(xbgr.mr_n56409568)
print v(xbgr.mr_n56410368)
print v(xbgr.mr_n56410480)
print v(xbgr.mr_n56410800)
print v(xbgr.mr_n56410912)
print v(xbgr.mr_n56411232)
print v(xbgr.mr_n56411344)
print v(xbgr.mr_n56411664)
print v(xbgr.mr_n56411776)
print v(xbgr.mr_n56412096)
print v(xbgr.mr_n56412208)
print v(xbgr.mr_n56412528)
print v(xbgr.mr_n56412640)
print v(xbgr.mr_n56412960)
print v(xbgr.mr_n56413072)
print v(xbgr.mr_n56413392)
print v(xbgr.mr_n56413504)
print v(xbgr.mr_n56413824)
print v(xbgr.mr_n56413936)
print v(xbgr.mr_n56414256)
print v(xbgr.mr_n56414368)
print v(xbgr.mr_n56414688)
print v(xbgr.mr_n56414800)
print v(xbgr.mr_n56415120)
print v(xbgr.mr_n56415232)
print v(xbgr.mr_n56415552)
print v(xbgr.mr_n56415664)
print v(xbgr.mr_n56415984)
print v(xbgr.mr_n56416096)
print v(xbgr.mr_n56416416)
print v(xbgr.mr_n56416528)
print v(xbgr.mr_n56416848)
print v(xbgr.mr_n56416960)
print v(xbgr.mr_n56417280)
print v(xbgr.mr_n56417392)
print v(xbgr.mr_n56417712)
print v(xbgr.mr_n56417824)
print v(xbgr.mr_n56418144)
print v(xbgr.mr_n56418256)
print v(xbgr.mr_n56418576)
print v(xbgr.mr_n56418688)
print v(xbgr.mr_n56419008)
print v(xbgr.mr_n56419120)
print v(xbgr.mr_n56419440)
print v(xbgr.mr_n56419552)
print v(xbgr.mr_n56419872)
print v(xbgr.mr_n56419984)
print v(xbgr.mr_n56420304)
print v(xbgr.mr_n56420416)
print v(xbgr.mr_n56420736)
print v(xbgr.mr_n56420848)
print v(xbgr.mr_n56421168)
print v(xbgr.mr_n56421280)
print v(xbgr.mr_n56421600)
print v(xbgr.mr_n56421712)
print v(xbgr.mr_n56422032)
print v(xbgr.mr_n56422144)
print v(xbgr.mr_n56422464)
print v(xbgr.mr_n56422576)
print v(xbgr.mr_n56422896)
print v(xbgr.mr_n56423008)
print v(xbgr.mr_n56423328)
print v(xbgr.mr_n56423440)
print v(xbgr.mr_n56423760)
print v(xbgr.mr_n56423872)
print v(xbgr.mr_n56424192)
print v(xbgr.mr_n56424304)
print v(xbgr.mr_n56424624)
print v(xbgr.mr_n56424736)
print v(xbgr.mr_n56425056)
print v(xbgr.mr_n56425168)
print v(xbgr.mr_n56425488)
print v(xbgr.mr_n56425600)
print v(xbgr.mr_n56425920)
print v(xbgr.mr_n56426032)
print v(xbgr.mr_n56426352)
print v(xbgr.mr_n56426464)
print v(xbgr.mr_n56426784)
print v(xbgr.mr_n56426896)
print v(xbgr.mr_n56427216)
print v(xbgr.mr_n56427328)
print v(xbgr.mr_n56427648)
print v(xbgr.mr_n56427760)
print v(xbgr.mr_n56428080)
print v(xbgr.mr_n56428192)
print v(xbgr.mr_n56428512)
print v(xbgr.mr_n56428624)
print v(xbgr.mr_n56428944)
print v(xbgr.mr_n56429056)
print v(xbgr.mr_n56429376)
print v(xbgr.mr_n56429488)
print v(xbgr.mr_n56429808)
print v(xbgr.mr_n56429920)
print v(xbgr.mr_n56430240)
print v(xbgr.mr_n56430352)
print v(xbgr.mr_n56430672)
print v(xbgr.mr_n56430784)
print v(xbgr.mr_n56431104)
print v(xbgr.mr_n56431216)
print v(xbgr.mr_n56431536)
print v(xbgr.mr_n56431648)
print v(xbgr.mr_n56431968)
print v(xbgr.mr_n56432080)
print v(xbgr.mr_n56432400)
print v(xbgr.mr_n56432512)
print v(xbgr.mr_n56432832)
print v(xbgr.mr_n56432944)
print v(xbgr.mr_n56433264)
print v(xbgr.mr_n56433376)
print v(xbgr.mr_n56433696)
print v(xbgr.mr_n56433808)
print v(xbgr.mr_n56434128)
print v(xbgr.mr_n56434240)
print v(xbgr.mr_n56434560)
print v(xbgr.mr_n56434672)
print v(xbgr.mr_n56434992)
print v(xbgr.mr_n56435104)
print v(xbgr.mr_n56435424)
print v(xbgr.mr_n56435536)
print v(xbgr.mr_n56435856)
print v(xbgr.mr_n56435968)
print v(xbgr.mr_n56436288)
print v(xbgr.mr_n56436400)
print v(xbgr.mr_n56436720)
print v(xbgr.mr_n56436832)
print v(xbgr.mr_n56437152)
print v(xbgr.mr_n56437264)
print v(xbgr.mr_n56437584)
print v(xbgr.mr_n56437696)
print v(xbgr.mr_n56438016)
print v(xbgr.mr_n56438128)
print v(xbgr.mr_n56438448)
print v(xbgr.mr_n56438560)
print v(xbgr.mr_n56438880)
print v(xbgr.mr_n56438992)
print v(xbgr.mr_n56439312)
print v(xbgr.mr_n56439424)
print v(xbgr.mr_n56439744)
print v(xbgr.mr_n56439856)
print v(xbgr.mr_n56440176)
print v(xbgr.mr_n56440288)
print v(xbgr.mr_n56440608)
print v(xbgr.mr_n56440720)
print v(xbgr.mr_n56441040)
print v(xbgr.mr_n56441152)
print v(xbgr.mr_n56441472)
print v(xbgr.mr_n56441584)
print v(xbgr.mr_n56441904)
print v(xbgr.mr_n56442016)
print v(xbgr.mr_n56442336)
print v(xbgr.mr_n56442448)
print v(xbgr.mr_n56442768)
print v(xbgr.mr_n56442880)
print v(xbgr.mr_n56443200)
print v(xbgr.mr_n56443312)
print v(xbgr.mr_n56443632)
print v(xbgr.mr_n56443744)
print v(xbgr.mr_n56444064)
print v(xbgr.mr_n56444176)
print v(xbgr.mr_n56444496)
print v(xbgr.mr_n56444608)
print v(xbgr.mr_n56444928)
print v(xbgr.mr_n56445040)
print v(xbgr.mr_n56445360)
print v(xbgr.mr_n56445472)
print v(xbgr.mr_n56445792)
print v(xbgr.mr_n56445904)
print v(xbgr.mr_n56446224)
print v(xbgr.mr_n56446336)
print v(xbgr.mr_n56446656)
print v(xbgr.mr_n56446768)
print v(xbgr.mr_n56447088)
print v(xbgr.mr_n56447200)
print v(xbgr.mr_n56447520)
print v(xbgr.mr_n56447632)
print v(xbgr.mr_n56447952)
print v(xbgr.mr_n56448064)
print v(xbgr.mr_n56448384)
print v(xbgr.mr_n56448496)
print v(xbgr.mr_n56448816)
print v(xbgr.mr_n56448928)
print v(xbgr.mr_n56449248)
print v(xbgr.mr_n56449360)
print v(xbgr.mr_n56449680)
print v(xbgr.mr_n56449792)
print v(xbgr.mr_n56450112)
print v(xbgr.mr_n56450224)
print v(xbgr.mr_n56450544)
print v(xbgr.mr_n56450656)
print v(xbgr.mr_n56450976)
print v(xbgr.mr_n56451088)
print v(xbgr.mr_n56451408)
print v(xbgr.mr_n56451520)
print v(xbgr.mr_n56451840)
print v(xbgr.mr_n56451952)
print v(xbgr.mr_n56452272)
print v(xbgr.mr_n56452384)
print v(xbgr.mr_n56452704)
print v(xbgr.mr_n56452816)
print v(xbgr.mr_n56453136)
print v(xbgr.mr_n56453248)
print v(xbgr.mr_n56453568)
print v(xbgr.mr_n56453680)
print v(xbgr.mr_n56454000)
print v(xbgr.mr_n56454112)
print v(xbgr.mr_n56454432)
print v(xbgr.mr_n56454544)
print v(xbgr.mr_n56454864)
print v(xbgr.mr_n56454976)
print v(xbgr.mr_n56455296)
print v(xbgr.mr_n56455408)
print v(xbgr.mr_n56455728)
print v(xbgr.mr_n56455840)
print v(xbgr.mr_n56456160)
print v(xbgr.mr_n56456272)
print v(xbgr.mr_n56456592)
print v(xbgr.mr_n56456704)
print v(xbgr.mr_n56457024)
print v(xbgr.mr_n56457136)
print v(xbgr.mr_n56457456)
print v(xbgr.mr_n56457568)
print v(xbgr.mr_n56457888)
print v(xbgr.mr_n56458000)
print v(xbgr.mr_n56458320)
print v(xbgr.mr_n56458432)
print v(xbgr.mr_n56458752)
print v(xbgr.mr_n56458864)
print v(xbgr.mr_n56459184)
print v(xbgr.mr_n56459296)
print v(xbgr.mr_n56459616)
print v(xbgr.mr_n56459728)
print v(xbgr.mr_n56460048)
print v(xbgr.mr_n56460160)
print v(xbgr.mr_n56460480)
print v(xbgr.mr_n56460592)
print v(xbgr.mr_n56460912)
print v(xbgr.mr_n56461024)
print v(xbgr.mr_n56461344)
print v(xbgr.mr_n56461456)
print v(xbgr.mr_n56461776)
print v(xbgr.mr_n56461888)
print v(xbgr.mr_n56462208)
print v(xbgr.mr_n56462320)
print v(xbgr.mr_n56462640)
print v(xbgr.mr_n56462752)
print v(xbgr.mr_n56463072)
print v(xbgr.mr_n56463184)
print v(xbgr.mr_n56463504)
print v(xbgr.mr_n56463616)
print v(xbgr.mr_n56463936)
print v(xbgr.mr_n56464048)
print v(xbgr.mr_n56464368)
print v(xbgr.mr_n56464480)
print v(xbgr.mr_n56464800)
print v(xbgr.mr_n56464912)
print v(xbgr.mr_n56465232)
print v(xbgr.mr_n56465344)
print v(xbgr.mr_n56465664)
print v(xbgr.mr_n56465776)
print v(xbgr.mr_n56466096)
print v(xbgr.mr_n56466208)
print v(xbgr.mr_n56466528)
print v(xbgr.mr_n56466640)
print v(xbgr.mr_n56466960)
print v(xbgr.mr_n56467072)
print v(xbgr.mr_n56467392)
print v(xbgr.mr_n56467504)
print v(xbgr.mr_n56467824)
print v(xbgr.mr_n56467936)
print v(xbgr.mr_n56468256)
print v(xbgr.mr_n56468368)
print v(xbgr.mr_n56468688)
print v(xbgr.mr_n56468800)
print v(xbgr.mr_n56469120)
print v(xbgr.mr_n56469232)
print v(xbgr.mr_n56469552)
print v(xbgr.mr_n56469664)
print v(xbgr.mr_n56469984)
print v(xbgr.mr_n56470096)
print v(xbgr.mr_n56470416)
print v(xbgr.mr_n56470528)
print v(xbgr.mr_n56470848)
print v(xbgr.mr_n56470960)
print v(xbgr.mr_n56471280)
print v(xbgr.mr_n56471392)
print v(xbgr.mr_n56471712)
print v(xbgr.mr_n56471824)
print v(xbgr.mr_n56472144)
print v(xbgr.mr_n56472256)
print v(xbgr.mr_n56472576)
print v(xbgr.mr_n56472688)
print v(xbgr.mr_n56473008)
print v(xbgr.mr_n56473120)
print v(xbgr.mr_n56473440)
print v(xbgr.mr_n56473552)
print v(xbgr.mr_n56473872)
print v(xbgr.mr_n56473984)
print v(xbgr.mr_n56474304)
print v(xbgr.mr_n56474416)
print v(xbgr.mr_n56474736)
print v(xbgr.mr_n56474848)
print v(xbgr.mr_n56475168)
print v(xbgr.mr_n56475280)
print v(xbgr.mr_n56475600)
print v(xbgr.mr_n56475712)
print v(xbgr.mr_n56476032)
print v(xbgr.mr_n56476144)
print v(xbgr.mr_n56476464)
print v(xbgr.mr_n56476576)
print v(xbgr.mr_n56476896)
print v(xbgr.mr_n56477008)
print v(xbgr.mr_n56477328)
print v(xbgr.mr_n56477440)
print v(xbgr.mr_n56477760)
print v(xbgr.mr_n56477872)
print v(xbgr.mr_n56478192)
print v(xbgr.mr_n56478304)
print v(xbgr.mr_n56478624)
print v(xbgr.mr_n56478736)
print v(xbgr.mr_n56479056)
print v(xbgr.mr_n56479168)
print v(xbgr.mr_n56479488)
print v(xbgr.mr_n56479600)
print v(xbgr.mr_n56479920)
print v(xbgr.mr_n56480032)
print v(xbgr.mr_n56480352)
print v(xbgr.mr_n56480464)
print v(xbgr.mr_n56480784)
print v(xbgr.mr_n56480896)
print v(xbgr.mr_n56481216)
print v(xbgr.mr_n56481328)
print v(xbgr.mr_n56481648)
print v(xbgr.mr_n56481760)
print v(xbgr.mr_n56482080)
print v(xbgr.mr_n56482192)
print v(xbgr.mr_n56482512)
print v(xbgr.mr_n56482624)
print v(xbgr.mr_n56482944)
print v(xbgr.mr_n56483056)
print v(xbgr.mr_n56483376)
print v(xbgr.mr_n56483488)
print v(xbgr.mr_n56483808)
print v(xbgr.mr_n56483920)
print v(xbgr.mr_n56484240)
print v(xbgr.mr_n56484352)
print v(xbgr.mr_n56484672)
print v(xbgr.mr_n56484784)
print v(xbgr.mr_n56485104)
print v(xbgr.mr_n56485216)
print v(xbgr.mr_n56485536)
print v(xbgr.mr_n56485648)
print v(xbgr.mr_n56485968)
print v(xbgr.mr_n56486080)
print v(xbgr.mr_n56486400)
print v(xbgr.mr_n56486512)
print v(xbgr.mr_n56486832)
print v(xbgr.mr_n56486944)
print v(xbgr.mr_n56487264)
print v(xbgr.mr_n56487376)
print v(xbgr.mr_n56487696)
print v(xbgr.mr_n56487808)
print v(xbgr.mr_n56488128)
print v(xbgr.mr_n56488240)
print v(xbgr.mr_n56488560)
print v(xbgr.mr_n56488672)
print v(xbgr.mr_n56488992)
print v(xbgr.mr_n56489104)
print v(xbgr.mr_n56489424)
print v(xbgr.mr_n56489536)
print v(xbgr.mr_n56489856)
print v(xbgr.mr_n56489968)
print v(xbgr.mr_n56490288)
print v(xbgr.mr_n56490400)
print v(xbgr.mr_n56490720)
print v(xbgr.mr_n56490832)
print v(xbgr.mr_n56491152)
print v(xbgr.mr_n56491264)
print v(xbgr.mr_n56491584)
print v(xbgr.mr_n56491696)
print v(xbgr.mr_n56492016)
print v(xbgr.mr_n56492128)
print v(xbgr.mr_n56492448)
print v(xbgr.mr_n56492560)
print v(xbgr.mr_n56492880)
print v(xbgr.mr_n56492992)
print v(xbgr.mr_n56493312)
print v(xbgr.mr_n56493424)
print v(xbgr.mr_n56493744)
print v(xbgr.mr_n56493856)
print v(xbgr.mr_n56494176)
print v(xbgr.mr_n56494288)
print v(xbgr.mr_n56494608)
print v(xbgr.mr_n56494720)
print v(xbgr.mr_n56495040)
print v(xbgr.mr_n56495152)
print v(xbgr.mr_n56495472)
print v(xbgr.mr_n56495584)
print v(xbgr.mr_n56495904)
print v(xbgr.mr_n56496016)
print v(xbgr.mr_n56496336)
print v(xbgr.mr_n56496448)
print v(xbgr.mr_n56496768)
print v(xbgr.mr_n56496880)
print v(xbgr.mr_n56497200)
print v(xbgr.mr_n56497312)
print v(xbgr.mr_n56497632)
print v(xbgr.mr_n56497744)
print v(xbgr.mr_n56498064)
print v(xbgr.mr_n56498176)
print v(xbgr.mr_n56498496)
print v(xbgr.mr_n56498608)
print v(xbgr.mr_n56498928)
print v(xbgr.mr_n56499040)
print v(xbgr.mr_n56499360)
print v(xbgr.mr_n56499472)
print v(xbgr.mr_n56499792)
print v(xbgr.mr_n56499904)
print v(xbgr.mr_n56500224)
print v(xbgr.mr_n56500336)
print v(xbgr.mr_n56500656)
print v(xbgr.mr_n56500768)
print v(xbgr.mr_n56501088)
print v(xbgr.mr_n56501200)
print v(xbgr.mr_n56501520)
print v(xbgr.mr_n56501632)
print v(xbgr.mr_n56501952)
print v(xbgr.mr_n56502064)
print v(xbgr.mr_n56502384)
print v(xbgr.mr_n56502496)
print v(xbgr.mr_n56502816)
print v(xbgr.mr_n56502928)
print v(xbgr.mr_n56503248)
print v(xbgr.mr_n56503360)
print v(xbgr.mr_n56503680)
print v(xbgr.mr_n56503792)
print v(xbgr.mr_n56504112)
print v(xbgr.mr_n56504224)
print v(xbgr.mr_n56504544)
print v(xbgr.mr_n56504656)
print v(xbgr.mr_n56504976)
print v(xbgr.mr_n56505088)
print v(xbgr.mr_n56505408)
print v(xbgr.mr_n56505520)
print v(xbgr.mr_n56505840)
print v(xbgr.mr_n56505952)
print v(xbgr.mr_n56506272)
print v(xbgr.mr_n56506384)
print v(xbgr.mr_n56506704)
print v(xbgr.mr_n56506816)
print v(xbgr.mr_n56507136)
print v(xbgr.mr_n56507248)
print v(xbgr.mr_n56507568)
print v(xbgr.mr_n56507680)
print v(xbgr.mr_n56508000)
print v(xbgr.mr_n56508112)
print v(xbgr.mr_n56508432)
print v(xbgr.mr_n56508544)
print v(xbgr.mr_n56508864)
print v(xbgr.mr_n56508976)
print v(xbgr.mr_n56509296)
print v(xbgr.mr_n56509408)
print v(xbgr.mr_n56509728)
print v(xbgr.mr_n56509840)
print v(xbgr.mr_n56510160)
print v(xbgr.mr_n56510272)
print v(xbgr.mr_n56510592)
print v(xbgr.mr_n56510704)
print v(xbgr.mr_n56511024)
print v(xbgr.mr_n56511136)
print v(xbgr.mr_n56511456)
print v(xbgr.mr_n56511568)
print v(xbgr.mr_n56511888)
print v(xbgr.mr_n56512000)
print v(xbgr.mr_n56512320)
print v(xbgr.mr_n56512432)
print v(xbgr.mr_n56512752)
print v(xbgr.mr_n56512864)
print v(xbgr.mr_n56513184)
print v(xbgr.mr_n56513296)
print v(xbgr.mr_n56513616)
print v(xbgr.mr_n56513728)
print v(xbgr.mr_n56514048)
print v(xbgr.mr_n56514160)
print v(xbgr.mr_n56514480)
print v(xbgr.mr_n56514592)
print v(xbgr.mr_n56514912)
print v(xbgr.mr_n56515024)
print v(xbgr.mr_n56515344)
print v(xbgr.mr_n56515456)
print v(xbgr.mr_n56515776)
print v(xbgr.mr_n56515888)
print v(xbgr.mr_n56516208)
print v(xbgr.mr_n56516320)
print v(xbgr.mr_n56516640)
print v(xbgr.mr_n56516752)
print v(xbgr.mr_n56517072)
print v(xbgr.mr_n56517184)
print v(xbgr.mr_n56517504)
print v(xbgr.mr_n56517616)
print v(xbgr.mr_n56517936)
print v(xbgr.mr_n56518048)
print v(xbgr.mr_n56518368)
print v(xbgr.mr_n56518480)
print v(xbgr.mr_n56518800)
print v(xbgr.mr_n56518912)
print v(xbgr.mr_n56519232)
print v(xbgr.mr_n56519344)
print v(xbgr.mr_n56519664)
print v(xbgr.mr_n56519776)
print v(xbgr.mr_n56520096)
print v(xbgr.mr_n56520208)
print v(xbgr.mr_n56520528)
print v(xbgr.mr_n56520640)
print v(xbgr.mr_n56520960)
print v(xbgr.mr_n56521072)
print v(xbgr.mr_n56521392)
print v(xbgr.mr_n56521504)
print v(xbgr.mr_n56521824)
print v(xbgr.mr_n56521936)
print v(xbgr.mr_n56522256)
print v(xbgr.mr_n56522368)
print v(xbgr.mr_n56522688)
print v(xbgr.mr_n56522800)
print v(xbgr.mr_n56523120)
print v(xbgr.mr_n56523232)
print v(xbgr.mr_n56523552)
print v(xbgr.mr_n56523664)
print v(xbgr.mr_n56523984)
print v(xbgr.mr_n56524096)
print v(xbgr.mr_n56524416)
print v(xbgr.mr_n56524528)
print v(xbgr.mr_n56524848)
print v(xbgr.mr_n56524960)
print v(xbgr.mr_n56525280)
print v(xbgr.mr_n56525392)
print v(xbgr.mr_n56525712)
print v(xbgr.mr_n56525824)
print v(xbgr.mr_n56526144)
print v(xbgr.mr_n56526256)
print v(xbgr.mr_n56526576)
print v(xbgr.mr_n56526688)
print v(xbgr.mr_n56527008)
print v(xbgr.mr_n56527120)
print v(xbgr.mr_n56527440)
print v(xbgr.mr_n56527552)
print v(xbgr.mr_n56527872)
print v(xbgr.mr_n56527984)
print v(xbgr.mr_n56528304)
print v(xbgr.mr_n56528416)
print v(xbgr.mr_n56528736)
print v(xbgr.mr_n56528848)
print v(xbgr.mr_n56529168)
print v(xbgr.mr_n56529280)
print v(xbgr.mr_n56529600)
print v(xbgr.mr_n56529712)
print v(xbgr.mr_n56530032)
print v(xbgr.mr_n56530144)
print v(xbgr.mr_n56530464)
print v(xbgr.mr_n56530576)
print v(xbgr.mr_n56530896)
print v(xbgr.mr_n56531008)
print v(xbgr.mr_n56531328)
print v(xbgr.mr_n56531440)
print v(xbgr.mr_n56531760)
print v(xbgr.mr_n56531872)
print v(xbgr.mr_n56532192)
print v(xbgr.mr_n56532304)
print v(xbgr.mr_n56532624)
print v(xbgr.mr_n56532736)
print v(xbgr.mr_n56533056)
print v(xbgr.mr_n56533168)
print v(xbgr.mr_n56533488)
print v(xbgr.mr_n56533600)
print v(xbgr.mr_n56533920)
print v(xbgr.mr_n56534032)
print v(xbgr.mr_n56534352)
print v(xbgr.mr_n56534464)
print v(xbgr.mr_n56534784)
print v(xbgr.mr_n56534896)
print v(xbgr.mr_n56535216)
print v(xbgr.mr_n56535328)
print v(xbgr.mr_n56535648)
print v(xbgr.mr_n56535760)
print v(xbgr.mr_n56536080)
print v(xbgr.mr_n56536192)
print v(xbgr.mr_n56536512)
print v(xbgr.mr_n56536624)
print v(xbgr.mr_n56536944)
print v(xbgr.mr_n56537056)
print v(xbgr.mr_n56537376)
print v(xbgr.mr_n56537488)
print v(xbgr.mr_n56537808)
print v(xbgr.mr_n56537920)
print v(xbgr.mr_n56538240)
print v(xbgr.mr_n56538352)
print v(xbgr.mr_n56538672)
print v(xbgr.mr_n56538784)
print v(xbgr.mr_n56539104)
print v(xbgr.mr_n56539216)
print v(xbgr.mr_n56539536)
print v(xbgr.mr_n56539648)
print v(xbgr.mr_n56539968)
print v(xbgr.mr_n56540080)
print v(xbgr.mr_n56540400)
print v(xbgr.mr_n56540512)
print v(xbgr.mr_n56540832)
print v(xbgr.mr_n56540944)
print v(xbgr.mr_n56541264)
print v(xbgr.mr_n56541376)
print v(xbgr.mr_n56541696)
print v(xbgr.mr_n56541808)
print v(xbgr.mr_n56542128)
print v(xbgr.mr_n56542240)
print v(xbgr.mr_n56542560)
print v(xbgr.mr_n56542672)
print v(xbgr.mr_n56542992)
print v(xbgr.mr_n56543104)
print v(xbgr.mr_n56543424)
print v(xbgr.mr_n56543536)
print v(xbgr.mr_n56543856)
print v(xbgr.mr_n56543968)
print v(xbgr.mr_n56544288)
print v(xbgr.mr_n56544400)
print v(xbgr.mr_n56544720)
print v(xbgr.mr_n56544832)
print v(xbgr.mr_n56545152)
print v(xbgr.mr_n56545264)
print v(xbgr.mr_n56545584)
print v(xbgr.mr_n56545696)
print v(xbgr.mr_n56546016)
print v(xbgr.mr_n56546128)
print v(xbgr.mr_n56546448)
print v(xbgr.mr_n56546560)
print v(xbgr.mr_n56546880)
print v(xbgr.mr_n56546992)
print v(xbgr.mr_n56547312)
print v(xbgr.mr_n56547424)
print v(xbgr.mr_n56547744)
print v(xbgr.mr_n56547856)
print v(xbgr.mr_n56548176)
print v(xbgr.mr_n56548288)
print v(xbgr.mr_n56548608)
print v(xbgr.mr_n56548720)
print v(xbgr.mr_n56549040)
print v(xbgr.mr_n56549152)
print v(xbgr.mr_n56549472)
print v(xbgr.mr_n56549584)
print v(xbgr.mr_n56549904)
print v(xbgr.mr_n56550016)
print v(xbgr.mr_n56550336)
print v(xbgr.mr_n56550448)
print v(xbgr.mr_n56550768)
print v(xbgr.mr_n56550880)
print v(xbgr.mr_n56551200)
print v(xbgr.mr_n56551312)
print v(xbgr.mr_n56551632)
print v(xbgr.mr_n56551744)
print v(xbgr.mr_n56552064)
print v(xbgr.mr_n56552176)
print v(xbgr.mr_n56552496)
print v(xbgr.mr_n56552608)
print v(xbgr.mr_n56552928)
print v(xbgr.mr_n56553040)
print v(xbgr.mr_n56553360)
print v(xbgr.mr_n56553472)
print v(xbgr.mr_n56553792)
print v(xbgr.mr_n56553904)
print v(xbgr.mr_n56554224)
print v(xbgr.mr_n56554336)
print v(xbgr.mr_n56554656)
print v(xbgr.mr_n56554768)
print v(xbgr.mr_n56555088)
print v(xbgr.mr_n56555200)
print v(xbgr.mr_n56555520)
print v(xbgr.mr_n56555632)
print v(xbgr.mr_n56555952)
print v(xbgr.mr_n56556064)
print v(xbgr.mr_n56556384)
print v(xbgr.mr_n56556496)
print v(xbgr.mr_n56556816)
print v(xbgr.mr_n56556928)
print v(xbgr.mr_n56557248)
print v(xbgr.mr_n56557360)
print v(xbgr.mr_n56557680)
print v(xbgr.mr_n56557792)
print v(xbgr.mr_n56558112)
print v(xbgr.mr_n56558224)
print v(xbgr.mr_n56558544)
print v(xbgr.mr_n56558656)
print v(xbgr.mr_n56558976)
print v(xbgr.mr_n56559088)
print v(xbgr.mr_n56559408)
print v(xbgr.mr_n56559520)
print v(xbgr.mr_n56559840)
print v(xbgr.mr_n56559952)
print v(xbgr.mr_n56560272)
print v(xbgr.mr_n56560384)
print v(xbgr.mr_n56560704)
print v(xbgr.mr_n56560816)
print v(xbgr.mr_n56561136)
print v(xbgr.mr_n56561248)
print v(xbgr.mr_n56561568)
print v(xbgr.mr_n56561680)
print v(xbgr.mr_n56562000)
print v(xbgr.mr_n56562112)
print v(xbgr.mr_n56562432)
print v(xbgr.mr_n56562544)
print v(xbgr.mr_n56562864)
print v(xbgr.mr_n56562976)
print v(xbgr.mr_n56563296)
print v(xbgr.mr_n56563408)
print v(xbgr.mr_n56563728)
print v(xbgr.mr_n56563840)
print v(xbgr.mr_n56564160)
print v(xbgr.mr_n56564272)
print v(xbgr.mr_n56564592)
print v(xbgr.mr_n56564704)
print v(xbgr.mr_n56565024)
print v(xbgr.mr_n56565136)
print v(xbgr.mr_n56565456)
print v(xbgr.mr_n56565568)
print v(xbgr.mr_n56565888)
print v(xbgr.mr_n56566000)
print v(xbgr.mr_n56566320)
print v(xbgr.mr_n56566432)
print v(xbgr.mr_n56566752)
print v(xbgr.mr_n56566864)
print v(xbgr.mr_n56567184)
print v(xbgr.mr_n56567296)
print v(xbgr.mr_n56567616)
print v(xbgr.mr_n56567728)
print v(xbgr.mr_n56568048)
print v(xbgr.mr_n56568160)
print v(xbgr.mr_n56568480)
print v(xbgr.mr_n56568592)
print v(xbgr.mr_n56568912)
print v(xbgr.mr_n56569024)
print v(xbgr.mr_n56569344)
print v(xbgr.mr_n56569456)
print v(xbgr.mr_n56569776)
print v(xbgr.mr_n56569888)
print v(xbgr.mr_n56570208)
print v(xbgr.mr_n56570320)
print v(xbgr.mr_n56570640)
print v(xbgr.mr_n56570752)
print v(xbgr.mr_n56571072)
print v(xbgr.mr_n56571184)
print v(xbgr.mr_n56571504)
print v(xbgr.mr_n56571936)
print v(xbgr.mr_n56572048)
print v(xbgr.mr_n56572368)
print v(xbgr.mr_n56572800)
print v(xbgr.mr_n56572912)
print v(xbgr.mr_n56573232)
print v(xbgr.mr_n56573344)
print v(xbgr.mr_n56573664)
print v(xbgr.mr_n56573776)
print v(xbgr.mr_n56574096)
print v(xbgr.mr_n56574208)
print v(xbgr.mr_n56574528)
print v(xbgr.mr_n56574640)
print v(xbgr.mr_n56574960)
print v(xbgr.mr_n56575072)
print v(xbgr.mr_n56575392)
print v(xbgr.mr_n56575504)
print v(xbgr.mr_n56575824)
print v(xbgr.mr_n56575936)
print v(xbgr.mr_n56576256)
print v(xbgr.mr_n56576368)
print v(xbgr.mr_n56576688)
print v(xbgr.mr_n56576800)
print v(xbgr.mr_n56577120)
print v(xbgr.mr_n56577232)
print v(xbgr.mr_n56577552)
print v(xbgr.mr_n56577664)
print v(xbgr.mr_n56577984)
print v(xbgr.mr_n56578096)
print v(xbgr.mr_n56578416)
print v(xbgr.mr_n56578528)
print v(xbgr.mr_n56578848)
print v(xbgr.mr_n56578960)
print v(xbgr.mr_n56579280)
print v(xbgr.mr_n56579392)
print v(xbgr.mr_n56579712)
print v(xbgr.mr_n56579824)
print v(xbgr.mr_n56580144)
print v(xbgr.mr_n56580256)
print v(xbgr.mr_n56580576)
print v(xbgr.mr_n56580688)
print v(xbgr.mr_n56581008)
print v(xbgr.mr_n56581120)
print v(xbgr.mr_n56581440)
print v(xbgr.mr_n56581552)
print v(xbgr.mr_n56581872)
print v(xbgr.mr_n56581984)
print v(xbgr.mr_n56582304)
print v(xbgr.mr_n56582736)
print v(xbgr.mr_n56582848)
print v(xbgr.mr_n56583168)
print v(xbgr.mr_n56583600)
print v(xbgr.mr_n56583712)
print v(xbgr.mr_n56584032)
print v(xbgr.mr_n56584464)
print v(xbgr.mr_n56584576)
print v(xbgr.mr_n56584896)
print v(xbgr.mr_n56585328)
print v(xbgr.mr_n56585440)
print v(xbgr.mr_n56585760)
print v(xbgr.mr_n56586192)
print v(xbgr.mr_n56586304)
print v(xbgr.mr_n56586624)
print v(xbgr.mr_n56586736)
print v(xbgr.mr_n56587056)
print v(xbgr.mr_n56587168)
print v(xbgr.mr_n56587488)
print v(xbgr.mr_n56587600)
print v(xbgr.mr_n56587920)
print v(xbgr.mr_n56588032)
print v(xbgr.mr_n56588352)
print v(xbgr.mr_n56588464)
print v(xbgr.mr_n56588784)
print v(xbgr.mr_n56588896)
print v(xbgr.mr_n56589216)
print v(xbgr.mr_n56589328)
print v(xbgr.mr_n56589648)
print v(xbgr.mr_n56589760)
print v(xbgr.mr_n56590080)
print v(xbgr.mr_n56590192)
print v(xbgr.mr_n56590512)
print v(xbgr.mr_n56590624)
print v(xbgr.mr_n56590944)
print v(xbgr.mr_n56591056)
print v(xbgr.mr_n56591376)
print v(xbgr.mr_n56591488)
print v(xbgr.mr_n56591808)
print v(xbgr.mr_n56591920)
print v(xbgr.mr_n56592240)
print v(xbgr.mr_n56592352)
print v(xbgr.mr_n56592672)
print v(xbgr.mr_n56592784)
print v(xbgr.mr_n56593104)
print v(xbgr.mr_n56593216)
print v(xbgr.mr_n56593536)
print v(xbgr.mr_n56593648)
print v(xbgr.mr_n56593968)
print v(xbgr.mr_n56594080)
print v(xbgr.mr_n56594400)
print v(xbgr.mr_n56594512)
print v(xbgr.mr_n56594832)
print v(xbgr.mr_n56594944)
print v(xbgr.mr_n56595264)
print v(xbgr.mr_n56595376)
print v(xbgr.mr_n56595696)
print v(xbgr.mr_n56595808)
print v(xbgr.mr_n56596128)
print v(xbgr.mr_n56596240)
print v(xbgr.mr_n56596560)
print v(xbgr.mr_n56596672)
print v(xbgr.mr_n56596992)
print v(xbgr.mr_n56597104)
print v(xbgr.mr_n56597424)
print v(xbgr.mr_n56597536)
print v(xbgr.mr_n56597856)
print v(xbgr.mr_n56597968)
print v(xbgr.mr_n56598288)
print v(xbgr.mr_n56598400)
print v(xbgr.mr_n56598720)
print v(xbgr.mr_n56598832)
print v(xbgr.mr_n56599152)
print v(xbgr.mr_n56599264)
print v(xbgr.mr_n56599584)
print v(xbgr.mr_n56599696)
print v(xbgr.mr_n56600016)
print v(xbgr.mr_n56600128)
print v(xbgr.mr_n56600448)
print v(xbgr.mr_n56600560)
print v(xbgr.mr_n56600880)
print v(xbgr.mr_n56600992)
print v(xbgr.mr_n56601312)
print v(xbgr.mr_n56601424)
print v(xbgr.mr_n56601744)
print v(xbgr.mr_n56601856)
print v(xbgr.mr_n56602176)
print v(xbgr.mr_n56602288)
print v(xbgr.mr_n56602608)
print v(xbgr.mr_n56602720)
print v(xbgr.mr_n56603040)
print v(xbgr.mr_n56603152)
print v(xbgr.mr_n56603472)
print v(xbgr.mr_n56603584)
print v(xbgr.mr_n56603904)
print v(xbgr.mr_n56604016)
print v(xbgr.mr_n56604336)
print v(xbgr.mr_n56604448)
print v(xbgr.mr_n56604768)
print v(xbgr.mr_n56604880)
print v(xbgr.mr_n56605200)
print v(xbgr.mr_n56605312)
print v(xbgr.mr_n56605632)
print v(xbgr.mr_n56605744)
print v(xbgr.mr_n56606064)
print v(xbgr.mr_n56606496)
print v(xbgr.mr_n56606608)
print v(xbgr.mr_n56606928)
print v(xbgr.mr_n56607360)
print v(xbgr.mr_n56607472)
print v(xbgr.mr_n56607792)
print v(xbgr.mr_n56608224)
print v(xbgr.mr_n56608336)
print v(xbgr.mr_n56608656)
print v(xbgr.mr_n56608768)
print v(xbgr.mr_n56609088)
print v(xbgr.mr_n56609200)
print v(xbgr.mr_n56609520)
print v(xbgr.mr_n56609632)
print v(xbgr.mr_n56609952)
print v(xbgr.mr_n56610064)
print v(xbgr.mr_n56610384)
print v(xbgr.mr_n56610496)
print v(xbgr.mr_n56610816)
print v(xbgr.mr_n56610928)
print v(xbgr.mr_n56611248)
print v(xbgr.mr_n56611360)
print v(xbgr.mr_n56611680)
print v(xbgr.mr_n56611792)
print v(xbgr.mr_n56612112)
print v(xbgr.mr_n56612224)
print v(xbgr.mr_n56612544)
print v(xbgr.mr_n56612656)
print v(xbgr.mr_n56612976)
print v(xbgr.mr_n56613088)
print v(xbgr.mr_n56613408)
print v(xbgr.mr_n56613520)
print v(xbgr.mr_n56613840)
print v(xbgr.mr_n56613952)
print v(xbgr.mr_n56614272)
print v(xbgr.mr_n56614384)
print v(xbgr.mr_n56614704)
print v(xbgr.mr_n56614816)
print v(xbgr.mr_n56615136)
print v(xbgr.mr_n56615248)
print v(xbgr.mr_n56615568)
print v(xbgr.mr_n56615680)
print v(xbgr.mr_n56616000)
print v(xbgr.mr_n56616112)
print v(xbgr.mr_n56616432)
print v(xbgr.mr_n56616544)
print v(xbgr.mr_n56616864)
print v(xbgr.mr_n56616976)
print v(xbgr.mr_n56617296)
print v(xbgr.mr_n56617408)
print v(xbgr.mr_n56617728)
print v(xbgr.mr_n56617840)
print v(xbgr.mr_n56618160)
print v(xbgr.mr_n56618272)
print v(xbgr.mr_n56618592)
print v(xbgr.mr_n56618704)
print v(xbgr.mr_n56619024)
print v(xbgr.mr_n56619136)
print v(xbgr.mr_n56619456)
print v(xbgr.mr_n56619568)
print v(xbgr.mr_n56619888)
print v(xbgr.mr_n56620000)
print v(xbgr.mr_n56620320)
print v(xbgr.mr_n56620432)
print v(xbgr.mr_n56620752)
print v(xbgr.mr_n56620864)
print v(xbgr.mr_n56621184)
print v(xbgr.mr_n56621296)
print v(xbgr.mr_n56621616)
print v(xbgr.mr_n56621728)
print v(xbgr.mr_n56622048)
print v(xbgr.mr_n56622160)
print v(xbgr.mr_n56622480)
print v(xbgr.mr_n56622592)
print v(xbgr.mr_n56622912)
print v(xbgr.mr_n56623024)
print v(xbgr.mr_n56623344)
print v(xbgr.mr_n56623456)
print v(xbgr.mr_n56623776)
print v(xbgr.mr_n56623888)
print v(xbgr.mr_n56624208)
print v(xbgr.mr_n56624320)
print v(xbgr.mr_n56624640)
print v(xbgr.mr_n56624752)
print v(xbgr.mr_n56625072)
print v(xbgr.mr_n56625184)
print v(xbgr.mr_n56625504)
print v(xbgr.mr_n56625616)
print v(xbgr.mr_n56625936)
print v(xbgr.mr_n56626048)
print v(xbgr.mr_n56626368)
print v(xbgr.mr_n56626480)
print v(xbgr.mr_n56626800)
print v(xbgr.mr_n56626912)
print v(xbgr.mr_n56627232)
print v(xbgr.mr_n56627344)
print v(xbgr.mr_n56627664)
print v(xbgr.mr_n56627776)
print v(xbgr.mr_n56628096)
print v(xbgr.mr_n56628208)
print v(xbgr.mr_n56628528)
print v(xbgr.mr_n56628640)
print v(xbgr.mr_n56628960)
print v(xbgr.mr_n56629072)
print v(xbgr.mr_n56629392)
print v(xbgr.mr_n56629504)
print v(xbgr.mr_n56629824)
print v(xbgr.mr_n56629936)
print v(xbgr.mr_n56630256)
print v(xbgr.mr_n56630368)
print v(xbgr.mr_n56630688)
print v(xbgr.mr_n56630800)
print v(xbgr.mr_n56631120)
print v(xbgr.mr_n56631232)
print v(xbgr.mr_n56631552)
print v(xbgr.mr_n56631664)
print v(xbgr.mr_n56631984)
print v(xbgr.mr_n56632096)
print v(xbgr.mr_n56632416)
print v(xbgr.mr_n56632528)
print v(xbgr.mr_n56632848)
print v(xbgr.mr_n56632960)
print v(xbgr.mr_n56633280)
print v(xbgr.mr_n56633392)
print v(xbgr.mr_n56633712)
print v(xbgr.mr_n56633824)
print v(xbgr.mr_n56634144)
print v(xbgr.mr_n56634256)
print v(xbgr.mr_n56634576)
print v(xbgr.mr_n56634688)
print v(xbgr.mr_n56635008)
print v(xbgr.mr_n56635120)
print v(xbgr.mr_n56635440)
print v(xbgr.mr_n56635552)
print v(xbgr.mr_n56635872)
print v(xbgr.mr_n56635984)
print v(xbgr.mr_n56636304)
print v(xbgr.mr_n56636416)
print v(xbgr.mr_n56636736)
print v(xbgr.mr_n56636848)
print v(xbgr.mr_n56637168)
print v(xbgr.mr_n56637280)
print v(xbgr.mr_n56637600)
print v(xbgr.mr_n56637712)
print v(xbgr.mr_n56638032)
print v(xbgr.mr_n56638144)
print v(xbgr.mr_n56638464)
print v(xbgr.mr_n56638576)
print v(xbgr.mr_n56638896)
print v(xbgr.mr_n56639008)
print v(xbgr.mr_n56639328)
print v(xbgr.mr_n56639440)
print v(xbgr.mr_n56639760)
print v(xbgr.mr_n56639872)
print v(xbgr.mr_n56640192)
print v(xbgr.mr_n56640304)
print v(xbgr.mr_n56640624)
print v(xbgr.mr_n56640736)
print v(xbgr.mr_n56641056)
print v(xbgr.mr_n56641168)
print v(xbgr.mr_n56641488)
print v(xbgr.mr_n56641600)
print v(xbgr.mr_n56641920)
print v(xbgr.mr_n56642032)
print v(xbgr.mr_n56642352)
print v(xbgr.mr_n56642464)
print v(xbgr.mr_n56642784)
print v(xbgr.mr_n56642896)
print v(xbgr.mr_n56643216)
print v(xbgr.mr_n56643328)
print v(xbgr.mr_n56643648)
print v(xbgr.mr_n56643760)
print v(xbgr.mr_n56644080)
print v(xbgr.mr_n56644192)
print v(xbgr.mr_n56644512)
print v(xbgr.mr_n56644624)
print v(xbgr.mr_n56644944)
print v(xbgr.mr_n56645056)
print v(xbgr.mr_n56645376)
print v(xbgr.mr_n56645488)
print v(xbgr.mr_n56645808)
print v(xbgr.mr_n56645920)
print v(xbgr.mr_n56646240)
print v(xbgr.mr_n56646352)
print v(xbgr.mr_n56646672)
print v(xbgr.mr_n56646784)
print v(xbgr.mr_n56647104)
print v(xbgr.mr_n56647216)
print v(xbgr.mr_n56647536)
print v(xbgr.mr_n56647648)
print v(xbgr.mr_n56647968)
print v(xbgr.mr_n56648080)
print v(xbgr.mr_n56648400)
print v(xbgr.mr_n56648512)
print v(xbgr.mr_n56648832)
print v(xbgr.mr_n56648944)
print v(xbgr.mr_n56649264)
print v(xbgr.mr_n56649376)
print v(xbgr.mr_n56649696)
print v(xbgr.mr_n56649808)
print v(xbgr.mr_n56650128)
print v(xbgr.mr_n56650240)
print v(xbgr.mr_n56650560)
print v(xbgr.mr_n56650672)
print v(xbgr.mr_n56650992)
print v(xbgr.mr_n56651104)
print v(xbgr.mr_n56651424)
print v(xbgr.mr_n56651536)
print v(xbgr.mr_n56651856)
print v(xbgr.mr_n56651968)
print v(xbgr.mr_n56652288)
print v(xbgr.mr_n56652400)
print v(xbgr.mr_n56652720)
print v(xbgr.mr_n56652832)
print v(xbgr.mr_n56653152)
print v(xbgr.mr_n56653264)
print v(xbgr.mr_n56653584)
print v(xbgr.mr_n56653696)
print v(xbgr.mr_n56654016)
print v(xbgr.mr_n56654128)
print v(xbgr.mr_n56654448)
print v(xbgr.mr_n56654560)
print v(xbgr.mr_n56654880)
print v(xbgr.mr_n56654992)
print v(xbgr.mr_n56655312)
print v(xbgr.mr_n56655424)
print v(xbgr.mr_n56655744)
print v(xbgr.mr_n56655856)
print v(xbgr.mr_n56656176)
print v(xbgr.mr_n56656288)
print v(xbgr.mr_n56656608)
print v(xbgr.mr_n56656720)
print v(xbgr.mr_n56657040)
print v(xbgr.mr_n56657152)
print v(xbgr.mr_n56657472)
print v(xbgr.mr_n56657584)
print v(xbgr.mr_n56657904)
print v(xbgr.mr_n56658016)
print v(xbgr.mr_n56658336)
print v(xbgr.mr_n56658448)
print v(xbgr.mr_n56658768)
print v(xbgr.mr_n56658880)
print v(xbgr.mr_n56659200)
print v(xbgr.mr_n56659312)
print v(xbgr.mr_n56659632)
print v(xbgr.mr_n56659744)
print v(xbgr.mr_n56660064)
print v(xbgr.mr_n56660176)
print v(xbgr.mr_n56660496)
print v(xbgr.mr_n56660608)
print v(xbgr.mr_n56660928)
print v(xbgr.mr_n56661040)
print v(xbgr.mr_n56661360)
print v(xbgr.mr_n56661472)
print v(xbgr.mr_n56661792)
print v(xbgr.mr_n56661904)
print v(xbgr.mr_n56662224)
print v(xbgr.mr_n56662336)
print v(xbgr.mr_n56662656)
print v(xbgr.mr_n56662768)
print v(xbgr.mr_n56663088)
print v(xbgr.mr_n56663200)
print v(xbgr.mr_n56663520)
print v(xbgr.mr_n56663632)
print v(xbgr.mr_n56663952)
print v(xbgr.mr_n56664064)
print v(xbgr.mr_n56664384)
print v(xbgr.mr_n56664496)
print v(xbgr.mr_n56664816)
print v(xbgr.mr_n56664928)
print v(xbgr.mr_n56665248)
print v(xbgr.mr_n56665360)
print v(xbgr.mr_n56665680)
print v(xbgr.mr_n56665792)
print v(xbgr.mr_n56666112)
print v(xbgr.mr_n56666224)
print v(xbgr.mr_n56666544)
print v(xbgr.mr_n56666656)
print v(xbgr.mr_n56666976)
print v(xbgr.mr_n56667088)
print v(xbgr.mr_n56667408)
print v(xbgr.mr_n56667520)
print v(xbgr.mr_n56667840)
print v(xbgr.mr_n56667952)
print v(xbgr.mr_n56668272)
print v(xbgr.mr_n56668384)
print v(xbgr.mr_n56668704)
print v(xbgr.mr_n56668816)
print v(xbgr.mr_n56669136)
print v(xbgr.mr_n56669248)
print v(xbgr.mr_n56669568)
print v(xbgr.mr_n56669680)
print v(xbgr.mr_n56670000)
print v(xbgr.mr_n56670112)
print v(xbgr.mr_n56670432)
print v(xbgr.mr_n56670544)
print v(xbgr.mr_n56670864)
print v(xbgr.mr_n56670976)
print v(xbgr.mr_n56671296)
print v(xbgr.mr_n56671408)
print v(xbgr.mr_n56671728)
print v(xbgr.mr_n56671840)
print v(xbgr.mr_n56672160)
print v(xbgr.mr_n56672272)
print v(xbgr.mr_n56672592)
print v(xbgr.mr_n56672704)
print v(xbgr.mr_n56673024)
print v(xbgr.mr_n56673136)
print v(xbgr.mr_n56673456)
print v(xbgr.mr_n56673568)
print v(xbgr.mr_n56673888)
print v(xbgr.mr_n56674000)
print v(xbgr.mr_n56674320)
print v(xbgr.mr_n56674432)
print v(xbgr.mr_n56674752)
print v(xbgr.mr_n56674864)
print v(xbgr.mr_n56675184)
print v(xbgr.mr_n56675296)
print v(xbgr.mr_n56675616)
print v(xbgr.mr_n56675728)
print v(xbgr.mr_n56676048)
print v(xbgr.mr_n56676160)
print v(xbgr.mr_n56676480)
print v(xbgr.mr_n56676592)
print v(xbgr.mr_n56676912)
print v(xbgr.mr_n56677024)
print v(xbgr.mr_n56677344)
print v(xbgr.mr_n56677456)
print v(xbgr.mr_n56677776)
print v(xbgr.mr_n56677888)
print v(xbgr.mr_n56678208)
print v(xbgr.mr_n56678320)
print v(xbgr.mr_n56678640)
print v(xbgr.mr_n56678752)
print v(xbgr.mr_n56679072)
print v(xbgr.mr_n56679184)
print v(xbgr.mr_n56679504)
print v(xbgr.mr_n56679616)
print v(xbgr.mr_n56679936)
print v(xbgr.mr_n56680048)
print v(xbgr.mr_n56680368)
print v(xbgr.mr_n56680480)
print v(xbgr.mr_n56680800)
print v(xbgr.mr_n56680912)
print v(xbgr.mr_n56681232)
print v(xbgr.mr_n56681344)
print v(xbgr.mr_n56681664)
print v(xbgr.mr_n56681776)
print v(xbgr.mr_n56682096)
print v(xbgr.mr_n56682208)
print v(xbgr.mr_n56682528)
print v(xbgr.mr_n56682640)
print v(xbgr.mr_n56682960)
print v(xbgr.mr_n56683072)
print v(xbgr.mr_n56683392)
print v(xbgr.mr_n56683504)
print v(xbgr.mr_n56683824)
print v(xbgr.mr_n56683936)
print v(xbgr.mr_n56684256)
print v(xbgr.mr_n56684368)
print v(xbgr.mr_n56684688)
print v(xbgr.mr_n56684800)
print v(xbgr.mr_n56685120)
print v(xbgr.mr_n56685232)
print v(xbgr.mr_n56685552)
print v(xbgr.mr_n56685664)
print v(xbgr.mr_n56685984)
print v(xbgr.mr_n56686096)
print v(xbgr.mr_n56686416)
print v(xbgr.mr_n56686528)
print v(xbgr.mr_n56686848)
print v(xbgr.mr_n56686960)
print v(xbgr.mr_n56687280)
print v(xbgr.mr_n56687392)
print v(xbgr.mr_n56687712)
print v(xbgr.mr_n56687824)
print v(xbgr.mr_n56688144)
print v(xbgr.mr_n56688256)
print v(xbgr.mr_n56688576)
print v(xbgr.mr_n56688688)
print v(xbgr.mr_n56689008)
print v(xbgr.mr_n56689120)
print v(xbgr.mr_n56689440)
print v(xbgr.mr_n56689552)
print v(xbgr.mr_n56689872)
print v(xbgr.mr_n56689984)
print v(xbgr.mr_n56690304)
print v(xbgr.mr_n56690416)
print v(xbgr.mr_n56690736)
print v(xbgr.mr_n56690848)
print v(xbgr.mr_n56691168)
print v(xbgr.mr_n56691280)
print v(xbgr.mr_n56691600)
print v(xbgr.mr_n56691712)
print v(xbgr.mr_n56692032)
print v(xbgr.mr_n56692144)
print v(xbgr.mr_n56692464)
print v(xbgr.mr_n56692576)
print v(xbgr.mr_n56692896)
print v(xbgr.mr_n56693008)
print v(xbgr.mr_n56693328)
print v(xbgr.mr_n56693440)
print v(xbgr.mr_n56693760)
print v(xbgr.mr_n56693872)
print v(xbgr.mr_n56694192)
print v(xbgr.mr_n56694304)
print v(xbgr.mr_n56694624)
print v(xbgr.mr_n56694736)
print v(xbgr.mr_n56695056)
print v(xbgr.mr_n56695168)
print v(xbgr.mr_n56695488)
print v(xbgr.mr_n56695600)
print v(xbgr.mr_n56695920)
print v(xbgr.mr_n56696032)
print v(xbgr.mr_n56696352)
print v(xbgr.mr_n56696464)
print v(xbgr.mr_n56696784)
print v(xbgr.mr_n56696896)
print v(xbgr.mr_n56697216)
print v(xbgr.mr_n56697328)
print v(xbgr.mr_n56697648)
print v(xbgr.mr_n56697760)
print v(xbgr.mr_n56698080)
print v(xbgr.mr_n56698192)
print v(xbgr.mr_n56698512)
print v(xbgr.mr_n56698624)
print v(xbgr.mr_n56698944)
print v(xbgr.mr_n56699056)
print v(xbgr.mr_n56699376)
print v(xbgr.mr_n56699488)
print v(xbgr.mr_n56699808)
print v(xbgr.mr_n56699920)
print v(xbgr.mr_n56700240)
print v(xbgr.mr_n56700352)
print v(xbgr.mr_n56700672)
print v(xbgr.mr_n56700784)
print v(xbgr.mr_n56701104)
print v(xbgr.mr_n56701216)
print v(xbgr.mr_n56701536)
print v(xbgr.mr_n56701648)
print v(xbgr.mr_n56701968)
print v(xbgr.mr_n56702080)
print v(xbgr.mr_n56702400)
print v(xbgr.mr_n56702512)
print v(xbgr.mr_n56702832)
print v(xbgr.mr_n56702944)
print v(xbgr.mr_n56703264)
print v(xbgr.mr_n56703376)
print v(xbgr.mr_n56703696)
print v(xbgr.mr_n56703808)
print v(xbgr.mr_n56704128)
print v(xbgr.mr_n56704240)
print v(xbgr.mr_n56704560)
print v(xbgr.mr_n56704672)
print v(xbgr.mr_n56704992)
print v(xbgr.mr_n56705104)
print v(xbgr.mr_n56705424)
print v(xbgr.mr_n56705536)
print v(xbgr.mr_n56705856)
print v(xbgr.mr_n56705968)
print v(xbgr.mr_n56706288)
print v(xbgr.mr_n56706400)
print v(xbgr.mr_n56706720)
print v(xbgr.mr_n56706832)
print v(xbgr.mr_n56707152)
print v(xbgr.mr_n56707264)
print v(xbgr.mr_n56707584)
print v(xbgr.mr_n56707696)
print v(xbgr.mr_n56708016)
print v(xbgr.mr_n56708128)
print v(xbgr.mr_n56708448)
print v(xbgr.mr_n56708560)
print v(xbgr.mr_n56708880)
print v(xbgr.mr_n56708992)
print v(xbgr.mr_n56709312)
print v(xbgr.mr_n56709424)
print v(xbgr.mr_n56709744)
print v(xbgr.mr_n56709856)
print v(xbgr.mr_n56710176)
print v(xbgr.mr_n56710288)
print v(xbgr.mr_n56710608)
print v(xbgr.mr_n56710720)
print v(xbgr.mr_n56711040)
print v(xbgr.mr_n56711152)
print v(xbgr.mr_n56711472)
print v(xbgr.mr_n56711584)
print v(xbgr.mr_n56711904)
print v(xbgr.mr_n56712016)
print v(xbgr.mr_n56712336)
print v(xbgr.mr_n56712448)
print v(xbgr.mr_n56712768)
print v(xbgr.mr_n56712880)
print v(xbgr.mr_n56713200)
print v(xbgr.mr_n56713312)
print v(xbgr.mr_n56713632)
print v(xbgr.mr_n56713744)
print v(xbgr.mr_n56714064)
print v(xbgr.mr_n56714176)
print v(xbgr.mr_n56714496)
print v(xbgr.mr_n56714608)
print v(xbgr.mr_n56714928)
print v(xbgr.mr_n56715040)
print v(xbgr.mr_n56715360)
print v(xbgr.mr_n56715472)
print v(xbgr.mr_n56715792)
print v(xbgr.mr_n56715904)
print v(xbgr.mr_n56716224)
print v(xbgr.mr_n56716336)
print v(xbgr.mr_n56716656)
print v(xbgr.mr_n56716768)
print v(xbgr.mr_n56717088)
print v(xbgr.mr_n56717200)
print v(xbgr.mr_n56717520)
print v(xbgr.mr_n56717632)
print v(xbgr.mr_n56717952)
print v(xbgr.mr_n56718064)
print v(xbgr.mr_n56718384)
print v(xbgr.mr_n56718496)
print v(xbgr.mr_n56718816)
print v(xbgr.mr_n56718928)
print v(xbgr.mr_n56719248)
print v(xbgr.mr_n56719360)
print v(xbgr.mr_n56719680)
print v(xbgr.mr_n56719792)
print v(xbgr.mr_n56720112)
print v(xbgr.mr_n56720224)
print v(xbgr.mr_n56720544)
print v(xbgr.mr_n56720656)
print v(xbgr.mr_n56720976)
print v(xbgr.mr_n56721088)
print v(xbgr.mr_n56721408)
print v(xbgr.mr_n56721520)
print v(xbgr.mr_n56721840)
print v(xbgr.mr_n56721952)
print v(xbgr.mr_n56722272)
print v(xbgr.mr_n56722384)
print v(xbgr.mr_n56722704)
print v(xbgr.mr_n56722816)
print v(xbgr.mr_n56723136)
print v(xbgr.mr_n56723248)
print v(xbgr.mr_n56723568)
print v(xbgr.mr_n56723680)
print v(xbgr.mr_n56724000)
print v(xbgr.mr_n56724112)
print v(xbgr.mr_n56724432)
print v(xbgr.mr_n56724544)
print v(xbgr.mr_n56724864)
print v(xbgr.mr_n56724976)
print v(xbgr.mr_n56725296)
print v(xbgr.mr_n56725408)
print v(xbgr.mr_n56725728)
print v(xbgr.mr_n56725840)
print v(xbgr.mr_n56726160)
print v(xbgr.mr_n56726272)
print v(xbgr.mr_n56726592)
print v(xbgr.mr_n56726704)
print v(xbgr.mr_n56727024)
print v(xbgr.mr_n56727136)
print v(xbgr.mr_n56727456)
print v(xbgr.mr_n56727568)
print v(xbgr.mr_n56727888)
print v(xbgr.mr_n56728000)
print v(xbgr.mr_n56728320)
print v(xbgr.mr_n56728432)
print v(xbgr.mr_n56728752)
print v(xbgr.mr_n56728864)
print v(xbgr.mr_n56729184)
print v(xbgr.mr_n56729296)
print v(xbgr.mr_n56729616)
print v(xbgr.mr_n56729728)
print v(xbgr.mr_n56730048)
print v(xbgr.mr_n56730160)
print v(xbgr.mr_n56730480)
print v(xbgr.mr_n56730592)
print v(xbgr.mr_n56730912)
print v(xbgr.mr_n56731024)
print v(xbgr.mr_n56731344)
print v(xbgr.mr_n56731456)
print v(xbgr.mr_n56731776)
print v(xbgr.mr_n56731888)
print v(xbgr.mr_n56732208)
print v(xbgr.mr_n56732320)
print v(xbgr.mr_n56732640)
print v(xbgr.mr_n56732752)
print v(xbgr.mr_n56733072)
print v(xbgr.mr_n56733184)
print v(xbgr.mr_n56733504)
print v(xbgr.mr_n56733616)
print v(xbgr.mr_n56733936)
print v(xbgr.mr_n56734048)
print v(xbgr.mr_n56734368)
print v(xbgr.mr_n56734480)
print v(xbgr.mr_n56734800)
print v(xbgr.mr_n56734912)
print v(xbgr.mr_n56735232)
print v(xbgr.mr_n56735344)
print v(xbgr.mr_n56735664)
print v(xbgr.mr_n56735776)
print v(xbgr.mr_n56736096)
print v(xbgr.mr_n56736208)
print v(xbgr.mr_n56736528)
print v(xbgr.mr_n56736640)
print v(xbgr.mr_n56736960)
print v(xbgr.mr_n56737072)
print v(xbgr.mr_n56737392)
print v(xbgr.mr_n56737504)
print v(xbgr.mr_n56737824)
print v(xbgr.mr_n56737936)
print v(xbgr.mr_n56738256)
print v(xbgr.mr_n56738368)
print v(xbgr.mr_n56738688)
print v(xbgr.mr_n56738800)
print v(xbgr.mr_n56739120)
print v(xbgr.mr_n56739232)
print v(xbgr.mr_n56739552)
print v(xbgr.mr_n56739664)
print v(xbgr.mr_n56739984)
print v(xbgr.mr_n56740096)
print v(xbgr.mr_n56740416)
print v(xbgr.mr_n56740528)
print v(xbgr.mr_n56740848)
print v(xbgr.mr_n56740960)
print v(xbgr.mr_n56741280)
print v(xbgr.mr_n56741392)
print v(xbgr.mr_n56741712)
print v(xbgr.mr_n56741824)
print v(xbgr.mr_n56742144)
print v(xbgr.mr_n56742256)
print v(xbgr.mr_n56742576)
print v(xbgr.mr_n56742688)
print v(xbgr.mr_n56743008)
print v(xbgr.mr_n56743120)
print v(xbgr.mr_n56743440)
print v(xbgr.mr_n56743552)
print v(xbgr.mr_n56743872)
print v(xbgr.mr_n56743984)
print v(xbgr.mr_n56744304)
print v(xbgr.mr_n56744416)
print v(xbgr.mr_n56744736)
print v(xbgr.mr_n56744848)
print v(xbgr.mr_n56745168)
print v(xbgr.mr_n56745280)
print v(xbgr.mr_n56745600)
print v(xbgr.mr_n56745712)
print v(xbgr.mr_n56746032)
print v(xbgr.mr_n56746144)
print v(xbgr.mr_n56746464)
print v(xbgr.mr_n56746576)
print v(xbgr.mr_n56746896)
print v(xbgr.mr_n56747008)
print v(xbgr.mr_n56747328)
print v(xbgr.mr_n56747440)
print v(xbgr.mr_n56747760)
print v(xbgr.mr_n56747872)
print v(xbgr.mr_n56748192)
print v(xbgr.mr_n56748304)
print v(xbgr.mr_n56748624)
print v(xbgr.mr_n56748736)
print v(xbgr.mr_n56749056)
print v(xbgr.mr_n56749168)
print v(xbgr.mr_n56749488)
print v(xbgr.mr_n56749600)
print v(xbgr.mr_n56749920)
print v(xbgr.mr_n56750032)
print v(xbgr.mr_n56750352)
print v(xbgr.mr_n56750464)
print v(xbgr.mr_n56750784)
print v(xbgr.mr_n56750896)
print v(xbgr.mr_n56751216)
print v(xbgr.mr_n56751328)
print v(xbgr.mr_n56751648)
print v(xbgr.mr_n56751760)
print v(xbgr.mr_n56752080)
print v(xbgr.mr_n56752192)
print v(xbgr.mr_n56752512)
print v(xbgr.mr_n56752624)
print v(xbgr.mr_n56752944)
print v(xbgr.mr_n56753056)
print v(xbgr.mr_n56753376)
print v(xbgr.mr_n56753488)
print v(xbgr.mr_n56753808)
print v(xbgr.mr_n56753920)
print v(xbgr.mr_n56754240)
print v(xbgr.mr_n56754352)
print v(xbgr.mr_n56754672)
print v(xbgr.mr_n56754784)
print v(xbgr.mr_n56755104)
print v(xbgr.mr_n56755216)
print v(xbgr.mr_n56755536)
print v(xbgr.mr_n56755648)
print v(xbgr.mr_n56755968)
print v(xbgr.mr_n56756080)
print v(xbgr.mr_n56756400)
print v(xbgr.mr_n56756512)
print v(xbgr.mr_n56756832)
print v(xbgr.mr_n56756944)
print v(xbgr.mr_n56757264)
print v(xbgr.mr_n56757376)
print v(xbgr.mr_n56757696)
print v(xbgr.mr_n56757808)
print v(xbgr.mr_n56758128)
print v(xbgr.mr_n56758240)
print v(xbgr.mr_n56758560)
print v(xbgr.mr_n56758672)
print v(xbgr.mr_n56758992)
print v(xbgr.mr_n56759104)
print v(xbgr.mr_n56759424)
print v(xbgr.mr_n56759536)
print v(xbgr.mr_n56759856)
print v(xbgr.mr_n56759968)
print v(xbgr.mr_n56760288)
print v(xbgr.mr_n56760400)
print v(xbgr.mr_n56760720)
print v(xbgr.mr_n56760832)
print v(xbgr.mr_n56761152)
print v(xbgr.mr_n56761264)
print v(xbgr.mr_n56761584)
print v(xbgr.mr_n56761696)
print v(xbgr.mr_n56762016)
print v(xbgr.mr_n56762128)
print v(xbgr.mr_n56762448)
print v(xbgr.mr_n56762560)
print v(xbgr.mr_n56762880)
print v(xbgr.mr_n56762992)
print v(xbgr.mr_n56763312)
print v(xbgr.mr_n56763424)
print v(xbgr.mr_n56763744)
print v(xbgr.mr_n56763856)
print v(xbgr.mr_n56764176)
print v(xbgr.mr_n56764288)
print v(xbgr.mr_n56764608)
print v(xbgr.mr_n56764720)
print v(xbgr.mr_n56765040)
print v(xbgr.mr_n56765152)
print v(xbgr.mr_n56765472)
print v(xbgr.mr_n56765584)
print v(xbgr.mr_n56765904)
print v(xbgr.mr_n56766016)
print v(xbgr.mr_n56766336)
print v(xbgr.mr_n56766448)
print v(xbgr.mr_n56766768)
print v(xbgr.mr_n56766880)
print v(xbgr.mr_n56767200)
print v(xbgr.mr_n56767312)
print v(xbgr.mr_n56767632)
print v(xbgr.mr_n56767744)
print v(xbgr.mr_n56768064)
print v(xbgr.mr_n56768176)
print v(xbgr.mr_n56768496)
print v(xbgr.mr_n56768608)
print v(xbgr.mr_n56768928)
print v(xbgr.mr_n56769040)
print v(xbgr.mr_n56769360)
print v(xbgr.mr_n56769472)
print v(xbgr.mr_n56769792)
print v(xbgr.mr_n56769904)
print v(xbgr.mr_n56770224)
print v(xbgr.mr_n56770336)
print v(xbgr.mr_n56770656)
print v(xbgr.mr_n56770768)
print v(xbgr.mr_n56771088)
print v(xbgr.mr_n56771200)
print v(xbgr.mr_n56771520)
print v(xbgr.mr_n56771632)
print v(xbgr.mr_n56771952)
print v(xbgr.mr_n56772064)
print v(xbgr.mr_n56772384)
print v(xbgr.mr_n56772496)
print v(xbgr.mr_n56772816)
print v(xbgr.mr_n56772928)
print v(xbgr.mr_n56773248)
print v(xbgr.mr_n56773360)
print v(xbgr.mr_n56773792)
print v(xbgr.mr_n56774112)
print v(xbgr.mr_n56774224)
print v(xbgr.mr_n56774656)
print v(xbgr.mr_n56774976)
print v(xbgr.mr_n56775088)
print v(xbgr.mr_n56775520)
print v(xbgr.mr_n56775840)
print v(xbgr.mr_n56776704)
print v(xbgr.mr_n56777568)
print v(xbgr.mr_n56777680)
print v(xbgr.mr_n56778000)
print v(xbgr.mr_n56778112)
print v(xbgr.mr_n56778432)
print v(xbgr.mr_n56778544)
print v(xbgr.mr_n56778864)
print v(xbgr.mr_n56778976)
print v(xbgr.mr_n56779296)
print v(xbgr.mr_n56779408)
print v(xbgr.mr_n56779728)
print v(xbgr.mr_n56779840)
print v(xbgr.mr_n56780160)
print v(xbgr.mr_n56781024)
print v(xbgr.mr_n56781888)
print v(xbgr.mr_n56782752)
print v(xbgr.mr_n56782864)
print v(xbgr.mr_n56783184)
print v(xbgr.mr_n56783296)
print v(xbgr.mr_n56783616)
print v(xbgr.mr_n56783728)
print v(xbgr.mr_n56784048)
print v(xbgr.mr_n56784160)
print v(xbgr.mr_n56784480)
print v(xbgr.mr_n56785344)
print v(xbgr.mr_n56786208)
print v(xbgr.mr_n56786320)
print v(xbgr.mr_n56786640)
print v(xbgr.mr_n56786752)
print v(xbgr.mr_n56787072)
print v(xbgr.mr_n56787184)
print v(xbgr.mr_n56787504)
print v(xbgr.mr_n56787616)
print v(xbgr.mr_n56787936)
print v(xbgr.mr_n56788048)
print v(xbgr.mr_n56788368)
print v(xbgr.mr_n56788480)
print v(xbgr.mr_n56788800)
print v(xbgr.mr_n56789664)
print v(xbgr.mr_n56789776)
print v(xbgr.mr_n56790208)
print v(xbgr.mr_n56790528)
print v(xbgr.mr_n56790640)
print v(xbgr.mr_n56791072)
print v(xbgr.mr_n56791392)
print v(xbgr.mr_n56791504)
print v(xbgr.mr_n56791936)
print v(xbgr.mr_n56792256)
print v(xbgr.mr_n56793120)
print v(xbgr.mr_n56793984)
print v(xbgr.mr_n56794848)
print v(xbgr.mr_n56795712)
print v(xbgr.mr_n56796576)
print v(xbgr.mr_n56797440)
print v(xbgr.mr_n56797552)
print v(xbgr.mr_n56797872)
print v(xbgr.mr_n56797984)
print v(xbgr.mr_n56798304)
print v(xbgr.mr_n56798416)
print v(xbgr.mr_n56798736)
print v(xbgr.mr_n56798848)
print v(xbgr.mr_n56799168)
print v(xbgr.mr_n56800032)
print v(xbgr.mr_n56800896)
print v(xbgr.mr_n56801760)
print v(xbgr.mr_n56802624)
print v(xbgr.mr_n56802736)
print v(xbgr.mr_n56803168)
print v(xbgr.mr_n56803488)
print v(xbgr.mr_n56803600)
print v(xbgr.mr_n56804032)
print v(xbgr.mr_n56804352)
print v(xbgr.mr_n56804464)
print v(xbgr.mr_n56804896)
print v(xbgr.mr_n56805216)
print v(xbgr.mr_n56806080)
print v(xbgr.mr_n56806944)
print v(xbgr.mr_n56807808)
print v(xbgr.mr_n56808672)
print v(xbgr.mr_n56809536)
print v(xbgr.mr_n56810400)
print v(xbgr.mr_n56810512)
print v(xbgr.mr_n56810832)
print v(xbgr.mr_n56810944)
print v(xbgr.mr_n56811264)
print v(xbgr.mr_n56811376)
print v(xbgr.mr_n56811696)
print v(xbgr.mr_n56811808)
print v(xbgr.mr_n56812128)
print v(xbgr.mr_n56812992)
print v(xbgr.mr_n56813856)
print v(xbgr.mr_n56814720)
print v(xbgr.mr_n56814832)
print v(xbgr.mr_n56815152)
print v(xbgr.mr_n56815264)
print v(xbgr.mr_n56815584)
print v(xbgr.mr_n56815696)
print v(xbgr.mr_n56816128)
print v(xbgr.mr_n56816560)
print v(xbgr.mr_n56816992)
print v(xbgr.mr_n56817312)
print v(xbgr.mr_n56817424)
print v(xbgr.mr_n56817744)
print v(xbgr.mr_n56817856)
print v(xbgr.mr_n56818176)
print v(xbgr.mr_n56818288)
print v(xbgr.mr_n56818608)
print v(xbgr.mr_n56818720)
print v(xbgr.mr_n56819040)
print v(xbgr.mr_n56819152)
print v(xbgr.mr_n56819472)
print v(xbgr.mr_n56819584)
print v(xbgr.mr_n56819904)
print v(xbgr.mr_n56820016)
print v(xbgr.mr_n56820448)
print v(xbgr.mr_n56820768)
print v(xbgr.mr_n56821200)
print v(xbgr.mr_n56821312)
print v(xbgr.mr_n56821632)
print v(xbgr.mr_n56821744)
print v(xbgr.mr_n56822064)
print v(xbgr.mr_n56822176)
print v(xbgr.mr_n56822496)
print v(xbgr.mr_n56822608)
print v(xbgr.mr_n56822928)
print v(xbgr.mr_n56823040)
print v(xbgr.mr_n56823360)
print v(xbgr.mr_n56823472)
print v(xbgr.mr_n56823792)
print v(xbgr.mr_n56823904)
print v(xbgr.mr_n56824336)
print v(xbgr.mr_n56824656)
print v(xbgr.mr_n56824768)
print v(xbgr.mr_n56825200)
print v(xbgr.mr_n56825520)
print v(xbgr.mr_n56825632)
print v(xbgr.mr_n56825952)
print v(xbgr.mr_n56826064)
print v(xbgr.mr_n56826384)
print v(xbgr.mr_n56826496)
print v(xbgr.mr_n56826928)
print v(xbgr.mr_n56827360)
print v(xbgr.mr_n56827680)
print v(xbgr.mr_n56827792)
print v(xbgr.mr_n56828112)
print v(xbgr.mr_n56828224)
print v(xbgr.mr_n56828544)
print v(xbgr.mr_n56828656)
print v(xbgr.mr_n56828976)
print v(xbgr.mr_n56829088)
print v(xbgr.mr_n56829408)
print v(xbgr.mr_n56829520)
print v(xbgr.mr_n56829840)
print v(xbgr.mr_n56829952)
print v(xbgr.mr_n56830272)
print v(xbgr.mr_n56830384)
print v(xbgr.mr_n56830704)
print v(xbgr.mr_n56830816)
print v(xbgr.mr_n56831136)
print v(xbgr.mr_n56831248)
print v(xbgr.mr_n56831568)
print v(xbgr.mr_n56831680)
print v(xbgr.mr_n56832000)
print v(xbgr.mr_n56832112)
print v(xbgr.mr_n56832432)
print v(xbgr.mr_n56833296)
print v(xbgr.mr_n56834160)
print v(xbgr.mr_n56834272)
print v(xbgr.mr_n56834704)
print v(xbgr.mr_n56835024)
print v(xbgr.mr_n56835136)
print v(xbgr.mr_n56835888)
print v(xbgr.mr_n56836320)
print v(xbgr.mr_n56836432)
print v(xbgr.mr_n56836752)
print v(xbgr.mr_n56836864)
print v(xbgr.mr_n56837184)
print v(xbgr.mr_n56837296)
print v(xbgr.mr_n56837616)
print v(xbgr.mr_n56837728)
print v(xbgr.mr_n56838048)
print v(xbgr.mr_n56838912)
print v(xbgr.mr_n56839344)
print v(xbgr.mr_n56839456)
print v(xbgr.mr_n56839776)
print v(xbgr.mr_n56839888)
print v(xbgr.mr_n56840208)
print v(xbgr.mr_n56841072)
print v(xbgr.mr_n56842368)
print v(xbgr.mr_n56843232)
print v(xbgr.mr_n56844096)
print v(xbgr.mr_n56844208)
print v(xbgr.mr_n56844960)
print v(xbgr.mr_n56845072)
print v(xbgr.mr_n56845504)
print v(xbgr.mr_n56845936)
print v(xbgr.mr_n56846688)
print v(xbgr.mr_n56847552)
print v(xbgr.mr_n56848416)
print v(xbgr.mr_n56848528)
print v(xbgr.mr_n56848848)
print v(xbgr.mr_n56848960)
print v(xbgr.mr_n56849392)
print v(xbgr.mr_n56849712)
print v(xbgr.mr_n56849824)
print v(xbgr.mr_n56850256)
print v(xbgr.mr_n56850576)
print v(xbgr.mr_n56850688)
print v(xbgr.mr_n56851008)
print v(xbgr.mr_n56851120)
print v(xbgr.mr_n56851440)
print v(xbgr.mr_n56852304)
print v(xbgr.mr_n56852416)
print v(xbgr.mr_n56852848)
print v(xbgr.mr_n56853168)
print v(xbgr.mr_n56854144)
print v(xbgr.mr_n56854464)
print v(xbgr.mr_n56854576)
print v(xbgr.mr_n56855008)
print v(xbgr.mr_n56855328)
print v(xbgr.mr_n56855760)
print v(xbgr.mr_n56855872)
print v(xbgr.mr_n56856192)
print v(xbgr.mr_n56856304)
print v(xbgr.mr_n56856624)
print v(xbgr.mr_n56857056)
print v(xbgr.mr_n56857168)
print v(xbgr.mr_n56857488)
print v(xbgr.mr_n56857600)
print v(xbgr.mr_n56857920)
print v(xbgr.mr_n56858032)
print v(xbgr.mr_n56858352)
print v(xbgr.mr_n56858464)
print v(xbgr.mr_n56858784)
print v(xbgr.mr_n56858896)
print v(xbgr.mr_n56859328)
print v(xbgr.mr_n56859648)
print v(xbgr.mr_n56859760)
print v(xbgr.mr_n56860080)
print v(xbgr.mr_n56860192)
print v(xbgr.mr_n56860512)
print v(xbgr.mr_n56861056)
print v(xbgr.mr_n56861808)
print v(xbgr.mr_n56863104)
print v(xbgr.mr_n56863216)
print v(xbgr.mr_n56863536)
print v(xbgr.mr_n56863648)
print v(xbgr.mr_n56863968)
print v(xbgr.mr_n56864832)
print v(xbgr.mr_n56865696)
print v(xbgr.mr_n56866560)
print v(xbgr.mr_n56866672)
print v(xbgr.mr_n56866992)
print v(xbgr.mr_n56867104)
print v(xbgr.mr_n56867424)
print v(xbgr.mr_n56867536)
print v(xbgr.mr_n56867856)
print v(xbgr.mr_n56867968)
print v(xbgr.mr_n56868288)
print v(xbgr.mr_n56868400)
print v(xbgr.mr_n56868720)
print v(xbgr.mr_n56869584)
print v(xbgr.mr_n56870448)
print v(xbgr.mr_n56871312)
print v(xbgr.mr_n56871424)
print v(xbgr.mr_n56871744)
print v(xbgr.mr_n56871856)
print v(xbgr.mr_n56872176)
print v(xbgr.mr_n56872288)
print v(xbgr.mr_n56872608)
print v(xbgr.mr_n56872720)
print v(xbgr.mr_n56873152)
print v(xbgr.mr_n56873472)
print v(xbgr.mr_n56873584)
print v(xbgr.mr_n56873904)
print v(xbgr.mr_n56874016)
print v(xbgr.mr_n56874336)
print v(xbgr.mr_n56874448)
print v(xbgr.mr_n56874768)
print v(xbgr.mr_n56874880)
print v(xbgr.mr_n56875632)
print v(xbgr.mr_n56876176)
print v(xbgr.mr_n56876608)
print v(xbgr.mr_n56877040)
print v(xbgr.mr_n56877472)
print v(xbgr.mr_n56877792)
print v(xbgr.mr_n56877904)
print v(xbgr.mr_n56878656)
print v(xbgr.mr_n56879520)
print v(xbgr.mr_n56880384)
print v(xbgr.mr_n56881248)
print v(xbgr.mr_n56882112)
print v(xbgr.mr_n56882976)
print v(xbgr.mr_n56883840)
print v(xbgr.mr_n56883952)
print v(xbgr.mr_n56884272)
print v(xbgr.mr_n56884384)
print v(xbgr.mr_n56884816)
print v(xbgr.mr_n56885136)
print v(xbgr.mr_n56885248)
print v(xbgr.mr_n56885680)
print v(xbgr.mr_n56886000)
print v(xbgr.mr_n56886112)
print v(xbgr.mr_n56886432)
print v(xbgr.mr_n56886544)
print v(xbgr.mr_n56886864)
print v(xbgr.mr_n56886976)
print v(xbgr.mr_n56887296)
print v(xbgr.mr_n56887408)
print v(xbgr.mr_n56887728)
print v(xbgr.mr_n56887840)
print v(xbgr.mr_n56888160)
print v(xbgr.mr_n56888272)
print v(xbgr.mr_n56888592)
print v(xbgr.mr_n56889456)
print v(xbgr.mr_n56889888)
print v(xbgr.mr_n56890864)
print v(xbgr.mr_n56891296)
print v(xbgr.mr_n56891728)
print v(xbgr.mr_n56892160)
print v(xbgr.mr_n56892480)
print v(xbgr.mr_n56893344)
print v(xbgr.mr_n56894208)
print v(xbgr.mr_n56895072)
print v(xbgr.mr_n56895936)
print v(xbgr.mr_n56896800)
print v(xbgr.mr_n56897664)
print v(xbgr.mr_n56898960)
print v(xbgr.mr_n56899392)
print v(xbgr.mr_n56900688)
print v(xbgr.mr_n56900800)
print v(xbgr.mr_n56901120)
print v(xbgr.mr_n56901232)
print v(xbgr.mr_n56901552)
print v(xbgr.mr_n56901664)
print v(xbgr.mr_n56902096)
print v(xbgr.mr_n56902528)
print v(xbgr.mr_n56902848)
print v(xbgr.mr_n56902960)
print v(xbgr.mr_n56903280)
print v(xbgr.mr_n56903392)
print v(xbgr.mr_n56903712)
print v(xbgr.mr_n56903824)
print v(xbgr.mr_n56904144)
print v(xbgr.mr_n56904256)
print v(xbgr.mr_n56904688)
print v(xbgr.mr_n56905008)
print v(xbgr.mr_n56905872)
print v(xbgr.mr_n56905984)
print v(xbgr.mr_n56906304)
print v(xbgr.mr_n56906416)
print v(xbgr.mr_n56906736)
print v(xbgr.mr_n56906848)
print v(xbgr.mr_n56907168)
print v(xbgr.mr_n56907280)
print v(xbgr.mr_n56907600)
print v(xbgr.mr_n56908464)
print v(xbgr.mr_n56908896)
print v(xbgr.mr_n56910192)
print v(xbgr.mr_n56910304)
print v(xbgr.mr_n56910624)
print v(xbgr.mr_n56910736)
print v(xbgr.mr_n56911056)
print v(xbgr.mr_n56911168)
print v(xbgr.mr_n56911488)
print v(xbgr.mr_n56912352)
print v(xbgr.mr_n56912464)
print v(xbgr.mr_n56912896)
print v(xbgr.mr_n56913216)
print v(xbgr.mr_n56913328)
print v(xbgr.mr_n56913648)
print v(xbgr.mr_n56913760)
print v(xbgr.mr_n56914080)
print v(xbgr.mr_n56914192)
print v(xbgr.mr_n56914512)
print v(xbgr.mr_n56914624)
print v(xbgr.mr_n56915056)
print v(xbgr.mr_n56915376)
print v(xbgr.mr_n56916240)
print v(xbgr.mr_n56916352)
print v(xbgr.mr_n56916672)
print v(xbgr.mr_n56917536)
print v(xbgr.mr_n56917648)
print v(xbgr.mr_n56917968)
print v(xbgr.mr_n56918080)
print v(xbgr.mr_n56918400)
print v(xbgr.mr_n56918944)
print v(xbgr.mr_n56919376)
print v(xbgr.mr_n56919696)
print v(xbgr.mr_n56920128)
print v(xbgr.mr_n56920240)
print v(xbgr.mr_n56920560)
print v(xbgr.mr_n56920672)
print v(xbgr.mr_n56920992)
print v(xbgr.mr_n56921104)
print v(xbgr.mr_n56921424)
print v(xbgr.mr_n56921536)
print v(xbgr.mr_n56921856)
print v(xbgr.mr_n56921968)
print v(xbgr.mr_n56922720)
print v(xbgr.mr_n56922832)
print v(xbgr.mr_n56923152)
print v(xbgr.mr_n56923264)
print v(xbgr.mr_n56923584)
print v(xbgr.mr_n56924880)
print v(xbgr.mr_n56924992)
print v(xbgr.mr_n56925312)
print v(xbgr.mr_n56925424)
print v(xbgr.mr_n56925744)
print v(xbgr.mr_n56926720)
print v(xbgr.mr_n56927040)
print v(xbgr.mr_n56927904)
print v(xbgr.mr_n56928336)
print v(xbgr.mr_n56928448)
print v(xbgr.mr_n56928768)
print v(xbgr.mr_n56928880)
print v(xbgr.mr_n56929200)
print v(xbgr.mr_n56929312)
print v(xbgr.mr_n56929632)
print v(xbgr.mr_n56930496)
print v(xbgr.mr_n56931792)
print v(xbgr.mr_n56932656)
print v(xbgr.mr_n56933632)
print v(xbgr.mr_n56933952)
print v(xbgr.mr_n56934064)
print v(xbgr.mr_n56934496)
print v(xbgr.mr_n56934816)
print v(xbgr.mr_n56934928)
print v(xbgr.mr_n56935248)
print v(xbgr.mr_n56935360)
print v(xbgr.mr_n56935680)
print v(xbgr.mr_n56935792)
print v(xbgr.mr_n56936112)
print v(xbgr.mr_n56936224)
print v(xbgr.mr_n56936544)
print v(xbgr.mr_n56936656)
print v(xbgr.mr_n56936976)
print v(xbgr.mr_n56937088)
print v(xbgr.mr_n56937408)
print v(xbgr.mr_n56937520)
print v(xbgr.mr_n56937840)
print v(xbgr.mr_n56937952)
print v(xbgr.mr_n56938384)
print v(xbgr.mr_n56938704)
print v(xbgr.mr_n56938816)
print v(xbgr.mr_n56939248)
print v(xbgr.mr_n56939568)
print v(xbgr.mr_n56940432)
print v(xbgr.mr_n56941296)
print v(xbgr.mr_n56942160)
print v(xbgr.mr_n56942272)
print v(xbgr.mr_n56942592)
print v(xbgr.mr_n56942704)
print v(xbgr.mr_n56943024)
print v(xbgr.mr_n56943136)
print v(xbgr.mr_n56943456)
print v(xbgr.mr_n56943568)
print v(xbgr.mr_n56944000)
print v(xbgr.mr_n56944432)
print v(xbgr.mr_n56944864)
print v(xbgr.mr_n56945296)
print v(xbgr.mr_n56945616)
print v(xbgr.mr_n56945728)
print v(xbgr.mr_n56946048)
print v(xbgr.mr_n56946160)
print v(xbgr.mr_n56946480)
print v(xbgr.mr_n56946592)
print v(xbgr.mr_n56946912)
print v(xbgr.mr_n56947024)
print v(xbgr.mr_n56947344)
print v(xbgr.mr_n56947456)
print v(xbgr.mr_n56947776)
print v(xbgr.mr_n56947888)
print v(xbgr.mr_n56948208)
print v(xbgr.mr_n56948320)
print v(xbgr.mr_n56948752)
print v(xbgr.mr_n56949072)
print v(xbgr.mr_n56949184)
print v(xbgr.mr_n56949504)
print v(xbgr.mr_n56950368)
print v(xbgr.mr_n56951104)
print v(xbgr.mr_n56951968)
print v(xbgr.mr_n56952832)
print v(xbgr.mr_n56953696)
print v(xbgr.mr_n56954560)
print v(xbgr.mr_n56954672)
print v(xbgr.mr_n56955104)
print v(xbgr.mr_n56955424)
print v(xbgr.mr_n56955536)
print v(xbgr.mr_n56955968)
print v(xbgr.mr_n56956288)
print v(xbgr.mr_n56956400)
print v(xbgr.mr_n56956720)
print v(xbgr.mr_n56956832)
print v(xbgr.mr_n56957152)
print v(xbgr.mr_n56957264)
print v(xbgr.mr_n56957696)
print v(xbgr.mr_n56958016)
print v(xbgr.mr_n56958880)
print v(xbgr.mr_n56958992)
print v(xbgr.mr_n56959312)
print v(xbgr.mr_n56959424)
print v(xbgr.mr_n56959744)
print v(xbgr.mr_n56959856)
print v(xbgr.mr_n56960176)
print v(xbgr.mr_n56960288)
print v(xbgr.mr_n56960608)
print v(xbgr.mr_n56960720)
print v(xbgr.mr_n56961040)
print v(xbgr.mr_n56961152)
print v(xbgr.mr_n56961472)
print v(xbgr.mr_n56961584)
print v(xbgr.mr_n56961904)
print v(xbgr.mr_n56962336)
print v(xbgr.mr_n56962448)
print v(xbgr.mr_n56962768)
print v(xbgr.mr_n56962880)
print v(xbgr.mr_n56963200)
print v(xbgr.mr_n56963312)
print v(xbgr.mr_n56963632)
print v(xbgr.mr_n56963744)
print v(xbgr.mr_n56964064)
print v(xbgr.mr_n56965360)
print v(xbgr.mr_n56966224)
print v(xbgr.mr_n56966768)
print v(xbgr.mr_n56967200)
print v(xbgr.mr_n56967520)
print v(xbgr.mr_n56967632)
print v(xbgr.mr_n56967952)
print v(xbgr.mr_n56968064)
print v(xbgr.mr_n56968384)
print v(xbgr.mr_n56968496)
print v(xbgr.mr_n56968816)
print v(xbgr.mr_n56968928)
print v(xbgr.mr_n56969248)
print v(xbgr.mr_n56969360)
print v(xbgr.mr_n56969680)
print v(xbgr.mr_n56969792)
print v(xbgr.mr_n56970112)
print v(xbgr.mr_n56970224)
print v(xbgr.mr_n56970544)
print v(xbgr.mr_n56970656)
print v(xbgr.mr_n56970976)
print v(xbgr.mr_n56971088)
print v(xbgr.mr_n56971408)
print v(xbgr.mr_n56972272)
print v(xbgr.mr_n56973136)
print v(xbgr.mr_n56973248)
print v(xbgr.mr_n56973680)
print v(xbgr.mr_n56974432)
print v(xbgr.mr_n56975296)
print v(xbgr.mr_n56976160)
print v(xbgr.mr_n56977136)
print v(xbgr.mr_n56977568)
print v(xbgr.mr_n56977888)
print v(xbgr.mr_n56978000)
print v(xbgr.mr_n56978320)
print v(xbgr.mr_n56978432)
print v(xbgr.mr_n56978752)
print v(xbgr.mr_n56979616)
print v(xbgr.mr_n56980480)
print v(xbgr.mr_n56980592)
print v(xbgr.mr_n56980912)
print v(xbgr.mr_n56981024)
print v(xbgr.mr_n56981344)
print v(xbgr.mr_n56981456)
print v(xbgr.mr_n56981776)
print v(xbgr.mr_n56981888)
print v(xbgr.mr_n56982208)
print v(xbgr.mr_n56982320)
print v(xbgr.mr_n56982640)
print v(xbgr.mr_n56982752)
print v(xbgr.mr_n56983072)
print v(xbgr.mr_n56983184)
print v(xbgr.mr_n56983504)
print v(xbgr.mr_n56983616)
print v(xbgr.mr_n56983936)
print v(xbgr.mr_n56984048)
print v(xbgr.mr_n56984480)
print v(xbgr.mr_n56984800)
print v(xbgr.mr_n56985232)
print v(xbgr.mr_n56985344)
print v(xbgr.mr_n56986096)
print v(xbgr.mr_n56986208)
print v(xbgr.mr_n56986640)
print v(xbgr.mr_n56987392)
print v(xbgr.mr_n56987504)
print v(xbgr.mr_n56987824)
print v(xbgr.mr_n56987936)
print v(xbgr.mr_n56988368)
print v(xbgr.mr_n56988800)
print v(xbgr.mr_n56989232)
print v(xbgr.mr_n56989552)
print v(xbgr.mr_n56989664)
print v(xbgr.mr_n56989984)
print v(xbgr.mr_n56990096)
print v(xbgr.mr_n56990528)
print v(xbgr.mr_n56990848)
print v(xbgr.mr_n56991712)
print v(xbgr.mr_n56991824)
print v(xbgr.mr_n56992144)
print v(xbgr.mr_n56992256)
print v(xbgr.mr_n56992576)
print v(xbgr.mr_n56992688)
print v(xbgr.mr_n56993008)
print v(xbgr.mr_n56993120)
print v(xbgr.mr_n56993440)
print v(xbgr.mr_n56993552)
print v(xbgr.mr_n56993872)
print v(xbgr.mr_n56993984)
print v(xbgr.mr_n56994304)
print v(xbgr.mr_n56995168)
print v(xbgr.mr_n56996032)
print v(xbgr.mr_n56996144)
print v(xbgr.mr_n56996464)
print v(xbgr.mr_n56996576)
print v(xbgr.mr_n56996896)
print v(xbgr.mr_n56997008)
print v(xbgr.mr_n56997328)
print v(xbgr.mr_n56997440)
print v(xbgr.mr_n56997760)
print v(xbgr.mr_n56998624)
print v(xbgr.mr_n56999488)
print v(xbgr.mr_n57000352)
print v(xbgr.mr_n57001216)
print v(xbgr.mr_n57002624)
print v(xbgr.mr_n57002944)
print v(xbgr.mr_n57003808)
print v(xbgr.mr_n57004672)
print v(xbgr.mr_n57004784)
print v(xbgr.mr_n57005216)
print v(xbgr.mr_n57005536)
print v(xbgr.mr_n57005648)
print v(xbgr.mr_n57006080)
print v(xbgr.mr_n57006400)
print v(xbgr.mr_n57007264)
print v(xbgr.mr_n57008128)
print v(xbgr.mr_n57008992)
print v(xbgr.mr_n57009856)
print v(xbgr.mr_n57009968)
print v(xbgr.mr_n57010288)
print v(xbgr.mr_n57010400)
print v(xbgr.mr_n57010720)
print v(xbgr.mr_n57010832)
print v(xbgr.mr_n57011152)
print v(xbgr.mr_n57011264)
print v(xbgr.mr_n57011584)
print v(xbgr.mr_n57012448)
print v(xbgr.mr_n57013312)
print v(xbgr.mr_n57013424)
print v(xbgr.mr_n57013744)
print v(xbgr.mr_n57013856)
print v(xbgr.mr_n57014288)
print v(xbgr.mr_n57014720)
print v(xbgr.mr_n57015040)
print v(xbgr.mr_n57015152)
print v(xbgr.mr_n57015472)
print v(xbgr.mr_n57015584)
print v(xbgr.mr_n57015904)
print v(xbgr.mr_n57016016)
print v(xbgr.mr_n57016336)
print v(xbgr.mr_n57016448)
print v(xbgr.mr_n57016768)
print v(xbgr.mr_n57016880)
print v(xbgr.mr_n57017312)
print v(xbgr.mr_n57017632)
print v(xbgr.mr_n57017744)
print v(xbgr.mr_n57018176)
print v(xbgr.mr_n57018496)
print v(xbgr.mr_n57019360)
print v(xbgr.mr_n57020224)
print v(xbgr.mr_n57021088)
print v(xbgr.mr_n57021952)
print v(xbgr.mr_n57022064)
print v(xbgr.mr_n57022384)
print v(xbgr.mr_n57022496)
print v(xbgr.mr_n57022816)
print v(xbgr.mr_n57022928)
print v(xbgr.mr_n57023248)
print v(xbgr.mr_n57023360)
print v(xbgr.mr_n57023680)
print v(xbgr.mr_n57024544)
print v(xbgr.mr_n57025408)
print v(xbgr.mr_n57025520)
print v(xbgr.mr_n57025840)
print v(xbgr.mr_n57025952)
print v(xbgr.mr_n57026384)
print v(xbgr.mr_n57026816)
print v(xbgr.mr_n57027136)
print v(xbgr.mr_n57027248)
print v(xbgr.mr_n57027568)
print v(xbgr.mr_n57027680)
print v(xbgr.mr_n57028000)
print v(xbgr.mr_n57028112)
print v(xbgr.mr_n57028432)
print v(xbgr.mr_n57028544)
print v(xbgr.mr_n57028864)
print v(xbgr.mr_n57028976)
print v(xbgr.mr_n57029408)
print v(xbgr.mr_n57029728)
print v(xbgr.mr_n57029840)
print v(xbgr.mr_n57030272)
print v(xbgr.mr_n57030592)
print v(xbgr.mr_n57030704)
print v(xbgr.mr_n57031136)
print v(xbgr.mr_n57031456)
print v(xbgr.mr_n57031568)
print v(xbgr.mr_n57032000)
print v(xbgr.mr_n57032320)
print v(xbgr.mr_n57033184)
print v(xbgr.mr_n57034048)
print v(xbgr.mr_n57034912)
print v(xbgr.mr_n57035776)
print v(xbgr.mr_n57036640)
print v(xbgr.mr_n57037504)
print v(xbgr.mr_n57037616)
print v(xbgr.mr_n57037936)
print v(xbgr.mr_n57038048)
print v(xbgr.mr_n57038368)
print v(xbgr.mr_n57038480)
print v(xbgr.mr_n57038800)
print v(xbgr.mr_n57038912)
print v(xbgr.mr_n57039232)
print v(xbgr.mr_n57039344)
print v(xbgr.mr_n57039664)
print v(xbgr.mr_n57039776)
print v(xbgr.mr_n57040096)
print v(xbgr.mr_n57040208)
print v(xbgr.mr_n57040528)
print v(xbgr.mr_n57040640)
print v(xbgr.mr_n57040960)
print v(xbgr.mr_n57041072)
print v(xbgr.mr_n57041392)
print v(xbgr.mr_n57041504)
print v(xbgr.mr_n57041936)
print v(xbgr.mr_n57042368)
print v(xbgr.mr_n57042688)
print v(xbgr.mr_n57043552)
print v(xbgr.mr_n57044416)
print v(xbgr.mr_n57044528)
print v(xbgr.mr_n57044848)
print v(xbgr.mr_n57044960)
print v(xbgr.mr_n57045280)
print v(xbgr.mr_n57045392)
print v(xbgr.mr_n57045712)
print v(xbgr.mr_n57045824)
print v(xbgr.mr_n57046144)
print v(xbgr.mr_n57046256)
print v(xbgr.mr_n57046576)
print v(xbgr.mr_n57046688)
print v(xbgr.mr_n57047008)
print v(xbgr.mr_n57047120)
print v(xbgr.mr_n57047440)
print v(xbgr.mr_n57047552)
print v(xbgr.mr_n57047984)
print v(xbgr.mr_n57048416)
print v(xbgr.mr_n57048736)
print v(xbgr.mr_n57048848)
print v(xbgr.mr_n57049168)
print v(xbgr.mr_n57049280)
print v(xbgr.mr_n57049600)
print v(xbgr.mr_n57049712)
print v(xbgr.mr_n57050032)
print v(xbgr.mr_n57050144)
print v(xbgr.mr_n57050464)
print v(xbgr.mr_n57050576)
print v(xbgr.mr_n57050896)
print v(xbgr.mr_n57051008)
print v(xbgr.mr_n57051328)
print v(xbgr.mr_n57052192)
print v(xbgr.mr_n57053056)
print v(xbgr.mr_n57053920)
print v(xbgr.mr_n57054784)
print v(xbgr.mr_n57054896)
print v(xbgr.mr_n57055328)
print v(xbgr.mr_n57055648)
print v(xbgr.mr_n57055760)
print v(xbgr.mr_n57056080)
print v(xbgr.mr_n57056192)
print v(xbgr.mr_n57056512)
print v(xbgr.mr_n57056624)
print v(xbgr.mr_n57056944)
print v(xbgr.mr_n57057056)
print v(xbgr.mr_n57057376)
print v(xbgr.mr_n57057488)
print v(xbgr.mr_n57057808)
print v(xbgr.mr_n57057920)
print v(xbgr.mr_n57058240)
print v(xbgr.mr_n57058352)
print v(xbgr.mr_n57058784)
print v(xbgr.mr_n57059104)
print v(xbgr.mr_n57059968)
print v(xbgr.mr_n57060080)
print v(xbgr.mr_n57060400)
print v(xbgr.mr_n57060512)
print v(xbgr.mr_n57060832)
print v(xbgr.mr_n57060944)
print v(xbgr.mr_n57061264)
print v(xbgr.mr_n57061376)
print v(xbgr.mr_n57061696)
print v(xbgr.mr_n57061808)
print v(xbgr.mr_n57062240)
print v(xbgr.mr_n57062560)
print v(xbgr.mr_n57062672)
print v(xbgr.mr_n57063104)
print v(xbgr.mr_n57063424)
print v(xbgr.mr_n57064288)
print v(xbgr.mr_n57065152)
print v(xbgr.mr_n57066016)
print v(xbgr.mr_n57066880)
print v(xbgr.mr_n57066992)
print v(xbgr.mr_n57067312)
print v(xbgr.mr_n57067424)
print v(xbgr.mr_n57067744)
print v(xbgr.mr_n57067856)
print v(xbgr.mr_n57068176)
print v(xbgr.mr_n57068288)
print v(xbgr.mr_n57068608)
print v(xbgr.mr_n57068720)
print v(xbgr.mr_n57069040)
print v(xbgr.mr_n57069152)
print v(xbgr.mr_n57069472)
print v(xbgr.mr_n57070336)
print v(xbgr.mr_n57071200)
print v(xbgr.mr_n57071312)
print v(xbgr.mr_n57071632)
print v(xbgr.mr_n57071744)
print v(xbgr.mr_n57072176)
print v(xbgr.mr_n57072608)
print v(xbgr.mr_n57072928)
print v(xbgr.mr_n57073040)
print v(xbgr.mr_n57073360)
print v(xbgr.mr_n57073472)
print v(xbgr.mr_n57073792)
print v(xbgr.mr_n57073904)
print v(xbgr.mr_n57074224)
print v(xbgr.mr_n57074336)
print v(xbgr.mr_n57074656)
print v(xbgr.mr_n57075520)
print v(xbgr.mr_n57076384)
print v(xbgr.mr_n57077248)
print v(xbgr.mr_n57078112)
print v(xbgr.mr_n57078976)
print v(xbgr.mr_n57079088)
print v(xbgr.mr_n57079408)
print v(xbgr.mr_n57079520)
print v(xbgr.mr_n57079840)
print v(xbgr.mr_n57079952)
print v(xbgr.mr_n57080272)
print v(xbgr.mr_n57080384)
print v(xbgr.mr_n57080704)
print v(xbgr.mr_n57080816)
print v(xbgr.mr_n57081248)
print v(xbgr.mr_n57081568)
print v(xbgr.mr_n57081680)
print v(xbgr.mr_n57082112)
print v(xbgr.mr_n57082432)
print v(xbgr.mr_n57082544)
print v(xbgr.mr_n57082976)
print v(xbgr.mr_n57083296)
print v(xbgr.mr_n57083408)
print v(xbgr.mr_n57083840)
print v(xbgr.mr_n57084160)
print v(xbgr.mr_n57085024)
print v(xbgr.mr_n57085136)
print v(xbgr.mr_n57085456)
print v(xbgr.mr_n57085568)
print v(xbgr.mr_n57085888)
print v(xbgr.mr_n57086000)
print v(xbgr.mr_n57086320)
print v(xbgr.mr_n57086432)
print v(xbgr.mr_n57086752)
print v(xbgr.mr_n57087616)
print v(xbgr.mr_n57088480)
print v(xbgr.mr_n57089344)
print v(xbgr.mr_n57090208)
print v(xbgr.mr_n57091072)
print v(xbgr.mr_n57091184)
print v(xbgr.mr_n57091504)
print v(xbgr.mr_n57091616)
print v(xbgr.mr_n57091936)
print v(xbgr.mr_n57092048)
print v(xbgr.mr_n57092368)
print v(xbgr.mr_n57092480)
print v(xbgr.mr_n57092912)
print v(xbgr.mr_n57093344)
print v(xbgr.mr_n57093664)
print v(xbgr.mr_n57093776)
print v(xbgr.mr_n57094096)
print v(xbgr.mr_n57094208)
print v(xbgr.mr_n57094528)
print v(xbgr.mr_n57095392)
print v(xbgr.mr_n57095504)
print v(xbgr.mr_n57095824)
print v(xbgr.mr_n57095936)
print v(xbgr.mr_n57096256)
print v(xbgr.mr_n57097120)
print v(xbgr.mr_n57097984)
print v(xbgr.mr_n57098096)
print v(xbgr.mr_n57098416)
print v(xbgr.mr_n57098528)
print v(xbgr.mr_n57098848)
print v(xbgr.mr_n57099712)
print v(xbgr.mr_n57100576)
print v(xbgr.mr_n57101440)
print v(xbgr.mr_n57101552)
print v(xbgr.mr_n57101872)
print v(xbgr.mr_n57101984)
print v(xbgr.mr_n57102304)
print v(xbgr.mr_n57102416)
print v(xbgr.mr_n57102736)
print v(xbgr.mr_n57102848)
print v(xbgr.mr_n57103168)
print v(xbgr.mr_n57103280)
print v(xbgr.mr_n57103600)
print v(xbgr.mr_n57103712)
print v(xbgr.mr_n57104032)
print v(xbgr.mr_n57104144)
print v(xbgr.mr_n57104464)
print v(xbgr.mr_n57104576)
print v(xbgr.mr_n57104896)
print v(xbgr.mr_n57105008)
print v(xbgr.mr_n57105328)
print v(xbgr.mr_n57105440)
print v(xbgr.mr_n57105760)
print v(xbgr.mr_n57105872)
print v(xbgr.mr_n57106192)
print v(xbgr.mr_n57106304)
print v(xbgr.mr_n57106736)
print v(xbgr.mr_n57107056)
print v(xbgr.mr_n57107168)
print v(xbgr.mr_n57107600)
print v(xbgr.mr_n57107920)
print v(xbgr.mr_n57108032)
print v(xbgr.mr_n57108464)
print v(xbgr.mr_n57108784)
print v(xbgr.mr_n57109648)
print v(xbgr.mr_n57110512)
print v(xbgr.mr_n57111376)
print v(xbgr.mr_n57111488)
print v(xbgr.mr_n57111808)
print v(xbgr.mr_n57111920)
print v(xbgr.mr_n57112240)
print v(xbgr.mr_n57113104)
print v(xbgr.mr_n57113968)
print v(xbgr.mr_n57114832)
print v(xbgr.mr_n57114944)
print v(xbgr.mr_n57115264)
print v(xbgr.mr_n57115376)
print v(xbgr.mr_n57115696)
print v(xbgr.mr_n57115808)
print v(xbgr.mr_n57116128)
print v(xbgr.mr_n57116240)
print v(xbgr.mr_n57116560)
print v(xbgr.mr_n57116672)
print v(xbgr.mr_n57116992)
print v(xbgr.mr_n57117104)
print v(xbgr.mr_n57117424)
print v(xbgr.mr_n57117536)
print v(xbgr.mr_n57117856)
print v(xbgr.mr_n57117968)
print v(xbgr.mr_n57118288)
print v(xbgr.mr_n57118400)
print v(xbgr.mr_n57118720)
print v(xbgr.mr_n57118832)
print v(xbgr.mr_n57119152)
print v(xbgr.mr_n57119264)
print v(xbgr.mr_n57119584)
print v(xbgr.mr_n57119696)
print v(xbgr.mr_n57120016)
print v(xbgr.mr_n57120128)
print v(xbgr.mr_n57120560)
print v(xbgr.mr_n57120880)
print v(xbgr.mr_n57121744)
print v(xbgr.mr_n57122608)
print v(xbgr.mr_n57123472)
print v(xbgr.mr_n57123584)
print v(xbgr.mr_n57124016)
print v(xbgr.mr_n57124336)
print v(xbgr.mr_n57124448)
print v(xbgr.mr_n57124880)
print v(xbgr.mr_n57125200)
print v(xbgr.mr_n57125312)
print v(xbgr.mr_n57125632)
print v(xbgr.mr_n57125744)
print v(xbgr.mr_n57126064)
print v(xbgr.mr_n57126176)
print v(xbgr.mr_n57126608)
print v(xbgr.mr_n57127040)
print v(xbgr.mr_n57127472)
print v(xbgr.mr_n57127792)
print v(xbgr.mr_n57128656)
print v(xbgr.mr_n57129520)
print v(xbgr.mr_n57130384)
print v(xbgr.mr_n57131248)
print v(xbgr.mr_n57132112)
print v(xbgr.mr_n57132976)
print v(xbgr.mr_n57133088)
print v(xbgr.mr_n57133408)
print v(xbgr.mr_n57133520)
print v(xbgr.mr_n57133840)
print v(xbgr.mr_n57133952)
print v(xbgr.mr_n57134272)
print v(xbgr.mr_n57134384)
print v(xbgr.mr_n57134704)
print v(xbgr.mr_n57134816)
print v(xbgr.mr_n57135136)
print v(xbgr.mr_n57135248)
print v(xbgr.mr_n57135568)
print v(xbgr.mr_n57136432)
print v(xbgr.mr_n57137296)
print v(xbgr.mr_n57138272)
print v(xbgr.mr_n57138704)
print v(xbgr.mr_n57139136)
print v(xbgr.mr_n57139456)
print v(xbgr.mr_n57139568)
print v(xbgr.mr_n57139888)
print v(xbgr.mr_n57140000)
print v(xbgr.mr_n57140320)
print v(xbgr.mr_n57140432)
print v(xbgr.mr_n57140864)
print v(xbgr.mr_n57141184)
print v(xbgr.mr_n57141296)
print v(xbgr.mr_n57141616)
print v(xbgr.mr_n57141728)
print v(xbgr.mr_n57142160)
print v(xbgr.mr_n57142480)
print v(xbgr.mr_n57142592)
print v(xbgr.mr_n57143024)
print v(xbgr.mr_n57143344)
print v(xbgr.mr_n57143456)
print v(xbgr.mr_n57143888)
print v(xbgr.mr_n57144208)
print v(xbgr.mr_n57145072)
print v(xbgr.mr_n57145936)
print v(xbgr.mr_n57146048)
print v(xbgr.mr_n57146368)
print v(xbgr.mr_n57146480)
print v(xbgr.mr_n57146800)
print v(xbgr.mr_n57146912)
print v(xbgr.mr_n57147232)
print v(xbgr.mr_n57147344)
print v(xbgr.mr_n57147776)
print v(xbgr.mr_n57148096)
print v(xbgr.mr_n57148960)
print v(xbgr.mr_n57149072)
print v(xbgr.mr_n57149392)
print v(xbgr.mr_n57149504)
print v(xbgr.mr_n57149824)
print v(xbgr.mr_n57149936)
print v(xbgr.mr_n57150256)
print v(xbgr.mr_n57151120)
print v(xbgr.mr_n57151552)
print v(xbgr.mr_n57152416)
print v(xbgr.mr_n57152528)
print v(xbgr.mr_n57152848)
print v(xbgr.mr_n57152960)
print v(xbgr.mr_n57153280)
print v(xbgr.mr_n57153392)
print v(xbgr.mr_n57153712)
print v(xbgr.mr_n57153824)
print v(xbgr.mr_n57154144)
print v(xbgr.mr_n57154256)
print v(xbgr.mr_n57154688)
print v(xbgr.mr_n57155440)
print v(xbgr.mr_n57156304)
print v(xbgr.mr_n57156736)
print v(xbgr.mr_n57156848)
print v(xbgr.mr_n57157168)
print v(xbgr.mr_n57157600)
print v(xbgr.mr_n57158464)
print v(xbgr.mr_n57159328)
print v(xbgr.mr_n57160192)
print v(xbgr.mr_n57161056)
print v(xbgr.mr_n57162352)
print v(xbgr.mr_n57163216)
print v(xbgr.mr_n57164192)
print v(xbgr.mr_n57164512)
print v(xbgr.mr_n57164624)
print v(xbgr.mr_n57165056)
print v(xbgr.mr_n57165376)
print v(xbgr.mr_n57166240)
print v(xbgr.mr_n57166352)
print v(xbgr.mr_n57166672)
print v(xbgr.mr_n57166784)
print v(xbgr.mr_n57167216)
print v(xbgr.mr_n57167536)
print v(xbgr.mr_n57167648)
print v(xbgr.mr_n57167968)
print v(xbgr.mr_n57168080)
print v(xbgr.mr_n57168400)
print v(xbgr.mr_n57168512)
print v(xbgr.mr_n57168832)
print v(xbgr.mr_n57168944)
print v(xbgr.mr_n57169376)
print v(xbgr.mr_n57169696)
print v(xbgr.mr_n57169808)
print v(xbgr.mr_n57170128)
print v(xbgr.mr_n57170240)
print v(xbgr.mr_n57170560)
print v(xbgr.mr_n57171424)
print v(xbgr.mr_n57171536)
print v(xbgr.mr_n57172288)
print v(xbgr.mr_n57172400)
print v(xbgr.mr_n57172720)
print v(xbgr.mr_n57172832)
print v(xbgr.mr_n57173152)
print v(xbgr.mr_n57173264)
print v(xbgr.mr_n57173584)
print v(xbgr.mr_n57173696)
print v(xbgr.mr_n57174016)
print v(xbgr.mr_n57174128)
print v(xbgr.mr_n57174448)
print v(xbgr.mr_n57174560)
print v(xbgr.mr_n57174880)
print v(xbgr.mr_n57174992)
print v(xbgr.mr_n57175312)
print v(xbgr.mr_n57175424)
print v(xbgr.mr_n57175744)
print v(xbgr.mr_n57175856)
print v(xbgr.mr_n57176176)
print v(xbgr.mr_n57176288)
print v(xbgr.mr_n57176608)
print v(xbgr.mr_n57176720)
print v(xbgr.mr_n57177040)
print v(xbgr.mr_n57177152)
print v(xbgr.mr_n57177472)
print v(xbgr.mr_n57177584)
print v(xbgr.mr_n57178016)
print v(xbgr.mr_n57178336)
print v(xbgr.mr_n57178448)
print v(xbgr.mr_n57178880)
print v(xbgr.mr_n57179200)
print v(xbgr.mr_n57179312)
print v(xbgr.mr_n57179744)
print v(xbgr.mr_n57180064)
print v(xbgr.mr_n57180928)
print v(xbgr.mr_n57181792)
print v(xbgr.mr_n57182656)
print v(xbgr.mr_n57183520)
print v(xbgr.mr_n57184384)
print v(xbgr.mr_n57185248)
print v(xbgr.mr_n57185360)
print v(xbgr.mr_n57185680)
print v(xbgr.mr_n57185792)
print v(xbgr.mr_n57186112)
print v(xbgr.mr_n57186224)
print v(xbgr.mr_n57186544)
print v(xbgr.mr_n57186656)
print v(xbgr.mr_n57186976)
print v(xbgr.mr_n57187840)
print v(xbgr.mr_n57188704)
print v(xbgr.mr_n57189568)
print v(xbgr.mr_n57189680)
print v(xbgr.mr_n57190000)
print v(xbgr.mr_n57190112)
print v(xbgr.mr_n57190432)
print v(xbgr.mr_n57190544)
print v(xbgr.mr_n57190976)
print v(xbgr.mr_n57191408)
print v(xbgr.mr_n57191840)
print v(xbgr.mr_n57192160)
print v(xbgr.mr_n57192272)
print v(xbgr.mr_n57192592)
print v(xbgr.mr_n57192704)
print v(xbgr.mr_n57193024)
print v(xbgr.mr_n57193136)
print v(xbgr.mr_n57193456)
print v(xbgr.mr_n57193568)
print v(xbgr.mr_n57193888)
print v(xbgr.mr_n57194000)
print v(xbgr.mr_n57194320)
print v(xbgr.mr_n57194432)
print v(xbgr.mr_n57194752)
print v(xbgr.mr_n57194864)
print v(xbgr.mr_n57195296)
print v(xbgr.mr_n57195616)
print v(xbgr.mr_n57195728)
print v(xbgr.mr_n57196160)
print v(xbgr.mr_n57196480)
print v(xbgr.mr_n57196592)
print v(xbgr.mr_n57197024)
print v(xbgr.mr_n57197344)
print v(xbgr.mr_n57198208)
print v(xbgr.mr_n57199072)
print v(xbgr.mr_n57199936)
print v(xbgr.mr_n57200800)
print v(xbgr.mr_n57201664)
print v(xbgr.mr_n57202528)
print v(xbgr.mr_n57202640)
print v(xbgr.mr_n57202960)
print v(xbgr.mr_n57203072)
print v(xbgr.mr_n57203392)
print v(xbgr.mr_n57203504)
print v(xbgr.mr_n57203824)
print v(xbgr.mr_n57203936)
print v(xbgr.mr_n57204256)
print v(xbgr.mr_n57205120)
print v(xbgr.mr_n57205984)
print v(xbgr.mr_n57206848)
print v(xbgr.mr_n57206960)
print v(xbgr.mr_n57207280)
print v(xbgr.mr_n57207392)
print v(xbgr.mr_n57207712)
print v(xbgr.mr_n57207824)
print v(xbgr.mr_n57208256)
print v(xbgr.mr_n57208576)
print v(xbgr.mr_n57208688)
print v(xbgr.mr_n57209120)
print v(xbgr.mr_n57209440)
print v(xbgr.mr_n57209552)
print v(xbgr.mr_n57209984)
print v(xbgr.mr_n57210304)
print v(xbgr.mr_n57210416)
print v(xbgr.mr_n57210736)
print v(xbgr.mr_n57210848)
print v(xbgr.mr_n57211168)
print v(xbgr.mr_n57211280)
print v(xbgr.mr_n57211712)
print v(xbgr.mr_n57212032)
print v(xbgr.mr_n57212896)
print v(xbgr.mr_n57213760)
print v(xbgr.mr_n57214624)
print v(xbgr.mr_n57214736)
print v(xbgr.mr_n57215056)
print v(xbgr.mr_n57215168)
print v(xbgr.mr_n57215488)
print v(xbgr.mr_n57216352)
print v(xbgr.mr_n57217216)
print v(xbgr.mr_n57218080)
print v(xbgr.mr_n57218944)
print v(xbgr.mr_n57219056)
print v(xbgr.mr_n57219376)
print v(xbgr.mr_n57219488)
print v(xbgr.mr_n57219808)
print v(xbgr.mr_n57220672)
print v(xbgr.mr_n57221216)
print v(xbgr.mr_n57221536)
print v(xbgr.mr_n57221648)
print v(xbgr.mr_n57221968)
print v(xbgr.mr_n57222080)
print v(xbgr.mr_n57222400)
print v(xbgr.mr_n57222512)
print v(xbgr.mr_n57222832)
print v(xbgr.mr_n57222944)
print v(xbgr.mr_n57223376)
print v(xbgr.mr_n57224128)
print v(xbgr.mr_n57224992)
print v(xbgr.mr_n57225856)
print v(xbgr.mr_n57226720)
print v(xbgr.mr_n57226832)
print v(xbgr.mr_n57227152)
print v(xbgr.mr_n57227264)
print v(xbgr.mr_n57227584)
print v(xbgr.mr_n57227696)
print v(xbgr.mr_n57228016)
print v(xbgr.mr_n57228128)
print v(xbgr.mr_n57228448)
print v(xbgr.mr_n57228560)
print v(xbgr.mr_n57228880)
print v(xbgr.mr_n57228992)
print v(xbgr.mr_n57229312)
print v(xbgr.mr_n57229424)
print v(xbgr.mr_n57229856)
print v(xbgr.mr_n57230176)
print v(xbgr.mr_n57230288)
print v(xbgr.mr_n57230608)
print v(xbgr.mr_n57230720)
print v(xbgr.mr_n57231040)
print v(xbgr.mr_n57231152)
print v(xbgr.mr_n57231472)
print v(xbgr.mr_n57231584)
print v(xbgr.mr_n57231904)
print v(xbgr.mr_n57232016)
print v(xbgr.mr_n57232448)
print v(xbgr.mr_n57232768)
print v(xbgr.mr_n57233632)
print v(xbgr.mr_n57233744)
print v(xbgr.mr_n57234064)
print v(xbgr.mr_n57234176)
print v(xbgr.mr_n57234608)
print v(xbgr.mr_n57235040)
print v(xbgr.mr_n57235360)
print v(xbgr.mr_n57235472)
print v(xbgr.mr_n57235792)
print v(xbgr.mr_n57235904)
print v(xbgr.mr_n57236224)
print v(xbgr.mr_n57236336)
print v(xbgr.mr_n57236656)
print v(xbgr.mr_n57236768)
print v(xbgr.mr_n57237088)
print v(xbgr.mr_n57237200)
print v(xbgr.mr_n57237632)
print v(xbgr.mr_n57237952)
print v(xbgr.mr_n57238064)
print v(xbgr.mr_n57238496)
print v(xbgr.mr_n57238816)
print v(xbgr.mr_n57239680)
print v(xbgr.mr_n57240544)
print v(xbgr.mr_n57241408)
print v(xbgr.mr_n57242272)
print v(xbgr.mr_n57242384)
print v(xbgr.mr_n57242704)
print v(xbgr.mr_n57242816)
print v(xbgr.mr_n57243136)
print v(xbgr.mr_n57243248)
print v(xbgr.mr_n57243568)
print v(xbgr.mr_n57243680)
print v(xbgr.mr_n57244000)
print v(xbgr.mr_n57244864)
print v(xbgr.mr_n57245728)
print v(xbgr.mr_n57245840)
print v(xbgr.mr_n57246160)
print v(xbgr.mr_n57246272)
print v(xbgr.mr_n57246704)
print v(xbgr.mr_n57247136)
print v(xbgr.mr_n57247456)
print v(xbgr.mr_n57247568)
print v(xbgr.mr_n57247888)
print v(xbgr.mr_n57248000)
print v(xbgr.mr_n57248320)
print v(xbgr.mr_n57248432)
print v(xbgr.mr_n57248752)
print v(xbgr.mr_n57248864)
print v(xbgr.mr_n57249184)
print v(xbgr.mr_n57250048)
print v(xbgr.mr_n57250912)
print v(xbgr.mr_n57251776)
print v(xbgr.mr_n57252640)
print v(xbgr.mr_n57253504)
print v(xbgr.mr_n57253616)
print v(xbgr.mr_n57254048)
print v(xbgr.mr_n57254368)
print v(xbgr.mr_n57254480)
print v(xbgr.mr_n57254912)
print v(xbgr.mr_n57255232)
print v(xbgr.mr_n57255344)
print v(xbgr.mr_n57255776)
print v(xbgr.mr_n57256096)
print v(xbgr.mr_n57256208)
print v(xbgr.mr_n57256528)
print v(xbgr.mr_n57256640)
print v(xbgr.mr_n57256960)
print v(xbgr.mr_n57257072)
print v(xbgr.mr_n57257392)
print v(xbgr.mr_n57257504)
print v(xbgr.mr_n57257824)
print v(xbgr.mr_n57257936)
print v(xbgr.mr_n57258256)
print v(xbgr.mr_n57258368)
print v(xbgr.mr_n57258688)
print v(xbgr.mr_n57258800)
print v(xbgr.mr_n57259120)
print v(xbgr.mr_n57259232)
print v(xbgr.mr_n57259552)
print v(xbgr.mr_n57259664)
print v(xbgr.mr_n57259984)
print v(xbgr.mr_n57260096)
print v(xbgr.mr_n57260416)
print v(xbgr.mr_n57260528)
print v(xbgr.mr_n57260848)
print v(xbgr.mr_n57260960)
print v(xbgr.mr_n57261280)
print v(xbgr.mr_n57262144)
print v(xbgr.mr_n57263008)
print v(xbgr.mr_n57263872)
print v(xbgr.mr_n57263984)
print v(xbgr.mr_n57264416)
print v(xbgr.mr_n57264736)
print v(xbgr.mr_n57264848)
print v(xbgr.mr_n57265168)
print v(xbgr.mr_n57265280)
print v(xbgr.mr_n57265600)
print v(xbgr.mr_n57265712)
print v(xbgr.mr_n57266032)
print v(xbgr.mr_n57266144)
print v(xbgr.mr_n57266576)
print v(xbgr.mr_n57267008)
print v(xbgr.mr_n57267440)
print v(xbgr.mr_n57267872)
print v(xbgr.mr_n57268192)
print v(xbgr.mr_n57268304)
print v(xbgr.mr_n57268736)
print v(xbgr.mr_n57269056)
print v(xbgr.mr_n57269920)
print v(xbgr.mr_n57270032)
print v(xbgr.mr_n57270352)
print v(xbgr.mr_n57270464)
print v(xbgr.mr_n57270784)
print v(xbgr.mr_n57270896)
print v(xbgr.mr_n57271216)
print v(xbgr.mr_n57272192)
print v(xbgr.mr_n57272624)
print v(xbgr.mr_n57273056)
print v(xbgr.mr_n57273376)
print v(xbgr.mr_n57274240)
print v(xbgr.mr_n57274352)
print v(xbgr.mr_n57274672)
print v(xbgr.mr_n57274784)
print v(xbgr.mr_n57275104)
print v(xbgr.mr_n57275216)
print v(xbgr.mr_n57275536)
print v(xbgr.mr_n57275648)
print v(xbgr.mr_n57275968)
print v(xbgr.mr_n57276080)
print v(xbgr.mr_n57276400)
print v(xbgr.mr_n57276512)
print v(xbgr.mr_n57276832)
print v(xbgr.mr_n57276944)
print v(xbgr.mr_n57277264)
print v(xbgr.mr_n57277376)
print v(xbgr.mr_n57277696)
print v(xbgr.mr_n57278560)
print v(xbgr.mr_n57279424)
print v(xbgr.mr_n57280288)
print v(xbgr.mr_n57281152)
print v(xbgr.mr_n57282016)
print v(xbgr.mr_n57282880)
print v(xbgr.mr_n57283744)
print v(xbgr.mr_n57284608)
print v(xbgr.mr_n57285472)
print v(xbgr.mr_n57286336)
print v(xbgr.mr_n57287200)
print v(xbgr.mr_n57288064)
print v(xbgr.mr_n57288176)
print v(xbgr.mr_n57288496)
print v(xbgr.mr_n57288608)
print v(xbgr.mr_n57288928)
print v(xbgr.mr_n57289040)
print v(xbgr.mr_n57289360)
print v(xbgr.mr_n57289472)
print v(xbgr.mr_n57289792)
print v(xbgr.mr_n57289904)
print v(xbgr.mr_n57290336)
print v(xbgr.mr_n57290656)
print v(xbgr.mr_n57290768)
print v(xbgr.mr_n57291200)
print v(xbgr.mr_n57291520)
print v(xbgr.mr_n57292384)
print v(xbgr.mr_n57293248)
print v(xbgr.mr_n57294112)
print v(xbgr.mr_n57294976)
print v(xbgr.mr_n57295088)
print v(xbgr.mr_n57295408)
print v(xbgr.mr_n57295520)
print v(xbgr.mr_n57295840)
print v(xbgr.mr_n57295952)
print v(xbgr.mr_n57296272)
print v(xbgr.mr_n57296384)
print v(xbgr.mr_n57296704)
print v(xbgr.mr_n57296816)
print v(xbgr.mr_n57297136)
print v(xbgr.mr_n57297248)
print v(xbgr.mr_n57297568)
print v(xbgr.mr_n57297680)
print v(xbgr.mr_n57298000)
print v(xbgr.mr_n57298864)
print v(xbgr.mr_n57299728)
print v(xbgr.mr_n57299840)
print v(xbgr.mr_n57300160)
print v(xbgr.mr_n57300272)
print v(xbgr.mr_n57300704)
print v(xbgr.mr_n57301136)
print v(xbgr.mr_n57301456)
print v(xbgr.mr_n57301568)
print v(xbgr.mr_n57301888)
print v(xbgr.mr_n57302000)
print v(xbgr.mr_n57302320)
print v(xbgr.mr_n57302432)
print v(xbgr.mr_n57302752)
print v(xbgr.mr_n57302864)
print v(xbgr.mr_n57303184)
print v(xbgr.mr_n57303296)
print v(xbgr.mr_n57303728)
print v(xbgr.mr_n57304048)
print v(xbgr.mr_n57304160)
print v(xbgr.mr_n57304592)
print v(xbgr.mr_n57304912)
print v(xbgr.mr_n57305024)
print v(xbgr.mr_n57305344)
print v(xbgr.mr_n57306208)
print v(xbgr.mr_n57307072)
print v(xbgr.mr_n57307936)
print v(xbgr.mr_n57308800)
print v(xbgr.mr_n57308912)
print v(xbgr.mr_n57309232)
print v(xbgr.mr_n57309344)
print v(xbgr.mr_n57309664)
print v(xbgr.mr_n57309776)
print v(xbgr.mr_n57310096)
print v(xbgr.mr_n57310208)
print v(xbgr.mr_n57310528)
print v(xbgr.mr_n57310640)
print v(xbgr.mr_n57310960)
print v(xbgr.mr_n57311072)
print v(xbgr.mr_n57311392)
print v(xbgr.mr_n57312256)
print v(xbgr.mr_n57313120)
print v(xbgr.mr_n57313232)
print v(xbgr.mr_n57313664)
print v(xbgr.mr_n57313984)
print v(xbgr.mr_n57314096)
print v(xbgr.mr_n57314416)
print v(xbgr.mr_n57314528)
print v(xbgr.mr_n57314848)
print v(xbgr.mr_n57314960)
print v(xbgr.mr_n57315280)
print v(xbgr.mr_n57315392)
print v(xbgr.mr_n57315712)
print v(xbgr.mr_n57315824)
print v(xbgr.mr_n57316144)
print v(xbgr.mr_n57316256)
print v(xbgr.mr_n57316688)
print v(xbgr.mr_n57317120)
print v(xbgr.mr_n57317552)
print v(xbgr.mr_n57317984)
print v(xbgr.mr_n57318304)
print v(xbgr.mr_n57318736)
print v(xbgr.mr_n57318848)
print v(xbgr.mr_n57319168)
print v(xbgr.mr_n57319280)
print v(xbgr.mr_n57319600)
print v(xbgr.mr_n57319712)
print v(xbgr.mr_n57320032)
print v(xbgr.mr_n57320144)
print v(xbgr.mr_n57320464)
print v(xbgr.mr_n57320576)
print v(xbgr.mr_n57320896)
print v(xbgr.mr_n57321008)
print v(xbgr.mr_n57321760)
print v(xbgr.mr_n57321872)
print v(xbgr.mr_n57322304)
print v(xbgr.mr_n57322624)
print v(xbgr.mr_n57323056)
print v(xbgr.mr_n57323168)
print v(xbgr.mr_n57323600)
print v(xbgr.mr_n57323920)
print v(xbgr.mr_n57324032)
print v(xbgr.mr_n57324464)
print v(xbgr.mr_n57324784)
print v(xbgr.mr_n57324896)
print v(xbgr.mr_n57325328)
print v(xbgr.mr_n57326080)
print v(xbgr.mr_n57326944)
print v(xbgr.mr_n57327808)
print v(xbgr.mr_n57328672)
print v(xbgr.mr_n57329536)
print v(xbgr.mr_n57330400)
print v(xbgr.mr_n57330512)
print v(xbgr.mr_n57330832)
print v(xbgr.mr_n57330944)
print v(xbgr.mr_n57331264)
print v(xbgr.mr_n57331376)
print v(xbgr.mr_n57331696)
print v(xbgr.mr_n57331808)
print v(xbgr.mr_n57332128)
print v(xbgr.mr_n57332992)
print v(xbgr.mr_n57333856)
print v(xbgr.mr_n57334720)
print v(xbgr.mr_n57334832)
print v(xbgr.mr_n57335152)
print v(xbgr.mr_n57335264)
print v(xbgr.mr_n57335584)
print v(xbgr.mr_n57335696)
print v(xbgr.mr_n57336016)
print v(xbgr.mr_n57336128)
print v(xbgr.mr_n57336448)
print v(xbgr.mr_n57336560)
print v(xbgr.mr_n57336880)
print v(xbgr.mr_n57336992)
print v(xbgr.mr_n57337312)
print v(xbgr.mr_n57337424)
print v(xbgr.mr_n57337744)
print v(xbgr.mr_n57337856)
print v(xbgr.mr_n57338176)
print v(xbgr.mr_n57339040)
print v(xbgr.mr_n57339472)
print v(xbgr.mr_n57340336)
print v(xbgr.mr_n57340768)
print v(xbgr.mr_n57341632)
print v(xbgr.mr_n57342496)
print v(xbgr.mr_n57343792)
print v(xbgr.mr_n57345088)
print v(xbgr.mr_n57345200)
print v(xbgr.mr_n57345520)
print v(xbgr.mr_n57345632)
print v(xbgr.mr_n57346064)
print v(xbgr.mr_n57346384)
print v(xbgr.mr_n57346496)
print v(xbgr.mr_n57346928)
print v(xbgr.mr_n57347248)
print v(xbgr.mr_n57347360)
print v(xbgr.mr_n57347680)
print v(xbgr.mr_n57347792)
print v(xbgr.mr_n57348112)
print v(xbgr.mr_n57348224)
print v(xbgr.mr_n57348656)
print v(xbgr.mr_n57348976)
print v(xbgr.mr_n57349088)
print v(xbgr.mr_n57349520)
print v(xbgr.mr_n57349840)
print v(xbgr.mr_n57349952)
print v(xbgr.mr_n57350384)
print v(xbgr.mr_n57350704)
print v(xbgr.mr_n57350816)
print v(xbgr.mr_n57351136)
print v(xbgr.mr_n57351568)
print v(xbgr.mr_n57351680)
print v(xbgr.mr_n57352000)
print v(xbgr.mr_n57352112)
print v(xbgr.mr_n57352432)
print v(xbgr.mr_n57352544)
print v(xbgr.mr_n57352864)
print v(xbgr.mr_n57352976)
print v(xbgr.mr_n57353728)
print v(xbgr.mr_n57354592)
print v(xbgr.mr_n57355456)
print v(xbgr.mr_n57355568)
print v(xbgr.mr_n57355888)
print v(xbgr.mr_n57356000)
print v(xbgr.mr_n57356320)
print v(xbgr.mr_n57356432)
print v(xbgr.mr_n57356752)
print v(xbgr.mr_n57356864)
print v(xbgr.mr_n57357616)
print v(xbgr.mr_n57358048)
print v(xbgr.mr_n57358912)
print v(xbgr.mr_n57360208)
print v(xbgr.mr_n57360640)
print v(xbgr.mr_n57361504)
print v(xbgr.mr_n57361616)
print v(xbgr.mr_n57361936)
print v(xbgr.mr_n57362048)
print v(xbgr.mr_n57362368)
print v(xbgr.mr_n57363232)
print v(xbgr.mr_n57363664)
print v(xbgr.mr_n57363776)
print v(xbgr.mr_n57364096)
print v(xbgr.mr_n57364960)
print v(xbgr.mr_n57365824)
print v(xbgr.mr_n57366688)
print v(xbgr.mr_n57367552)
print v(xbgr.mr_n57367664)
print v(xbgr.mr_n57367984)
print v(xbgr.mr_n57368096)
print v(xbgr.mr_n57368416)
print v(xbgr.mr_n57368528)
print v(xbgr.mr_n57368848)
print v(xbgr.mr_n57368960)
print v(xbgr.mr_n57369712)
print v(xbgr.mr_n57370576)
print v(xbgr.mr_n57371440)
print v(xbgr.mr_n57371552)
print v(xbgr.mr_n57371984)
print v(xbgr.mr_n57372416)
print v(xbgr.mr_n57372848)
print v(xbgr.mr_n57373168)
print v(xbgr.mr_n57373280)
print v(xbgr.mr_n57373600)
print v(xbgr.mr_n57373712)
print v(xbgr.mr_n57374032)
print v(xbgr.mr_n57374144)
print v(xbgr.mr_n57374464)
print v(xbgr.mr_n57374576)
print v(xbgr.mr_n57374896)
print v(xbgr.mr_n57375008)
print v(xbgr.mr_n57375328)
print v(xbgr.mr_n57375440)
print v(xbgr.mr_n57375760)
print v(xbgr.mr_n57375872)
print v(xbgr.mr_n57376192)
print v(xbgr.mr_n57376304)
print v(xbgr.mr_n57377488)
print v(xbgr.mr_n57378032)
print v(xbgr.mr_n57378464)
print v(xbgr.mr_n57378896)
print v(xbgr.mr_n57379648)
print v(xbgr.mr_n57379760)
print v(xbgr.mr_n57380080)
print v(xbgr.mr_n57380192)
print v(xbgr.mr_n57380512)
print v(xbgr.mr_n57380624)
print v(xbgr.mr_n57380944)
print v(xbgr.mr_n57381056)
print v(xbgr.mr_n57381376)
print v(xbgr.mr_n57381488)
print v(xbgr.mr_n57381808)
print v(xbgr.mr_n57381920)
print v(xbgr.mr_n57382352)
print v(xbgr.mr_n57382672)
print v(xbgr.mr_n57382784)
print v(xbgr.mr_n57383104)
print v(xbgr.mr_n57383216)
print v(xbgr.mr_n57383648)
print v(xbgr.mr_n57383968)
print v(xbgr.mr_n57384080)
print v(xbgr.mr_n57384400)
print v(xbgr.mr_n57384512)
print v(xbgr.mr_n57384832)
print v(xbgr.mr_n57384944)
print v(xbgr.mr_n57385264)
print v(xbgr.mr_n57385376)
print v(xbgr.mr_n57385696)
print v(xbgr.mr_n57385808)
print v(xbgr.mr_n57386128)
print v(xbgr.mr_n57386240)
print v(xbgr.mr_n57386560)
print v(xbgr.mr_n57387424)
print v(xbgr.mr_n57387968)
print v(xbgr.mr_n57388288)
print v(xbgr.mr_n57388400)
print v(xbgr.mr_n57388832)
print v(xbgr.mr_n57389152)
print v(xbgr.mr_n57389264)
print v(xbgr.mr_n57390016)
print v(xbgr.mr_n57390880)
print v(xbgr.mr_n57390992)
print v(xbgr.mr_n57391312)
print v(xbgr.mr_n57391424)
print v(xbgr.mr_n57391744)
print v(xbgr.mr_n57391856)
print v(xbgr.mr_n57392176)
print v(xbgr.mr_n57392608)
print v(xbgr.mr_n57393472)
print v(xbgr.mr_n57394768)
print v(xbgr.mr_n57395744)
print v(xbgr.mr_n57396064)
print v(xbgr.mr_n57396176)
print v(xbgr.mr_n57396496)
print v(xbgr.mr_n57396608)
print v(xbgr.mr_n57396928)
print v(xbgr.mr_n57397792)
print v(xbgr.mr_n57397904)
print v(xbgr.mr_n57398224)
print v(xbgr.mr_n57398336)
print v(xbgr.mr_n57398656)
print v(xbgr.mr_n57398768)
print v(xbgr.mr_n57399088)
print v(xbgr.mr_n57399200)
print v(xbgr.mr_n57399520)
print v(xbgr.mr_n57399632)
print v(xbgr.mr_n57399952)
print v(xbgr.mr_n57400496)
print v(xbgr.mr_n57400816)
print v(xbgr.mr_n57402112)
print v(xbgr.mr_n57402976)
print v(xbgr.mr_n57403520)
print v(xbgr.mr_n57403952)
print v(xbgr.mr_n57404704)
print v(xbgr.mr_n57404816)
print v(xbgr.mr_n57405136)
print v(xbgr.mr_n57405248)
print v(xbgr.mr_n57405568)
print v(xbgr.mr_n57405680)
print v(xbgr.mr_n57406000)
print v(xbgr.mr_n57406112)
print v(xbgr.mr_n57406432)
print v(xbgr.mr_n57406544)
print v(xbgr.mr_n57406864)
print v(xbgr.mr_n57406976)
print v(xbgr.mr_n57407408)
print v(xbgr.mr_n57407728)
print v(xbgr.mr_n57407840)
print v(xbgr.mr_n57408160)
print v(xbgr.mr_n57408272)
print v(xbgr.mr_n57408592)
print v(xbgr.mr_n57408704)
print v(xbgr.mr_n57409024)
print v(xbgr.mr_n57409136)
print v(xbgr.mr_n57409456)
print v(xbgr.mr_n57409568)
print v(xbgr.mr_n57409888)
print v(xbgr.mr_n57410000)
print v(xbgr.mr_n57410320)
print v(xbgr.mr_n57410432)
print v(xbgr.mr_n57410752)
print v(xbgr.mr_n57410864)
print v(xbgr.mr_n57411296)
print v(xbgr.mr_n57411728)
print v(xbgr.mr_n57412160)
print v(xbgr.mr_n57412480)
print v(xbgr.mr_n57412592)
print v(xbgr.mr_n57412912)
print v(xbgr.mr_n57413024)
print v(xbgr.mr_n57413344)
print v(xbgr.mr_n57413456)
print v(xbgr.mr_n57413776)
print v(xbgr.mr_n57413888)
print v(xbgr.mr_n57414208)
print v(xbgr.mr_n57414320)
print v(xbgr.mr_n57414752)
print v(xbgr.mr_n57415072)
print v(xbgr.mr_n57415936)
print v(xbgr.mr_n57416800)
print v(xbgr.mr_n57416912)
print v(xbgr.mr_n57417232)
print v(xbgr.mr_n57417344)
print v(xbgr.mr_n57417664)
print v(xbgr.mr_n57417776)
print v(xbgr.mr_n57418096)
print v(xbgr.mr_n57418208)
print v(xbgr.mr_n57418528)
print v(xbgr.mr_n57419504)
print v(xbgr.mr_n57419824)
print v(xbgr.mr_n57419936)
print v(xbgr.mr_n57420256)
print v(xbgr.mr_n57420368)
print v(xbgr.mr_n57420688)
print v(xbgr.mr_n57420800)
print v(xbgr.mr_n57421120)
print v(xbgr.mr_n57421232)
print v(xbgr.mr_n57421552)
print v(xbgr.mr_n57421664)
print v(xbgr.mr_n57421984)
print v(xbgr.mr_n57422848)
print v(xbgr.mr_n57423712)
print v(xbgr.mr_n57424576)
print v(xbgr.mr_n57425440)
print v(xbgr.mr_n57425552)
print v(xbgr.mr_n57425872)
print v(xbgr.mr_n57425984)
print v(xbgr.mr_n57426304)
print v(xbgr.mr_n57427280)
print v(xbgr.mr_n57427712)
print v(xbgr.mr_n57428032)
print v(xbgr.mr_n57428896)
print v(xbgr.mr_n57429760)
print v(xbgr.mr_n57430624)
print v(xbgr.mr_n57431488)
print v(xbgr.mr_n57431600)
print v(xbgr.mr_n57432032)
print v(xbgr.mr_n57432352)
print v(xbgr.mr_n57432464)
print v(xbgr.mr_n57432784)
print v(xbgr.mr_n57432896)
print v(xbgr.mr_n57433216)
print v(xbgr.mr_n57433328)
print v(xbgr.mr_n57433760)
print v(xbgr.mr_n57434080)
print v(xbgr.mr_n57434192)
print v(xbgr.mr_n57434624)
print v(xbgr.mr_n57434944)
print v(xbgr.mr_n57435056)
print v(xbgr.mr_n57435376)
print v(xbgr.mr_n57435488)
print v(xbgr.mr_n57435808)
print v(xbgr.mr_n57435920)
print v(xbgr.mr_n57436240)
print v(xbgr.mr_n57436352)
print v(xbgr.mr_n57436672)
print v(xbgr.mr_n57436784)
print v(xbgr.mr_n57437104)
print v(xbgr.mr_n57437216)
print v(xbgr.mr_n57437648)
print v(xbgr.mr_n57437968)
print v(xbgr.mr_n57438832)
print v(xbgr.mr_n57439376)
print v(xbgr.mr_n57439696)
print v(xbgr.mr_n57439808)
print v(xbgr.mr_n57440128)
print v(xbgr.mr_n57440240)
print v(xbgr.mr_n57440560)
print v(xbgr.mr_n57440672)
print v(xbgr.mr_n57440992)
print v(xbgr.mr_n57441104)
print v(xbgr.mr_n57441424)
print v(xbgr.mr_n57441536)
print v(xbgr.mr_n57441856)
print v(xbgr.mr_n57441968)
print v(xbgr.mr_n57442400)
print v(xbgr.mr_n57442720)
print v(xbgr.mr_n57443584)
print v(xbgr.mr_n57444016)
print v(xbgr.mr_n57444880)
print v(xbgr.mr_n57445744)
print v(xbgr.mr_n57447152)
print v(xbgr.mr_n57448016)
print v(xbgr.mr_n57448448)
print v(xbgr.mr_n57448768)
print v(xbgr.mr_n57449632)
print v(xbgr.mr_n57449744)
print v(xbgr.mr_n57450064)
print v(xbgr.mr_n57450176)
print v(xbgr.mr_n57450496)
print v(xbgr.mr_n57450608)
print v(xbgr.mr_n57450928)
print v(xbgr.mr_n57451040)
print v(xbgr.mr_n57451360)
print v(xbgr.mr_n57451472)
print v(xbgr.mr_n57451792)
print v(xbgr.mr_n57451904)
print v(xbgr.mr_n57452224)
print v(xbgr.mr_n57452336)
print v(xbgr.mr_n57452656)
print v(xbgr.mr_n57453520)
print v(xbgr.mr_n57454496)
print v(xbgr.mr_n57454928)
print v(xbgr.mr_n57455360)
print v(xbgr.mr_n57455680)
print v(xbgr.mr_n57455792)
print v(xbgr.mr_n57456112)
print v(xbgr.mr_n57456224)
print v(xbgr.mr_n57456544)
print v(xbgr.mr_n57457408)
print v(xbgr.mr_n57458272)
print v(xbgr.mr_n57459136)
print v(xbgr.mr_n57459248)
print v(xbgr.mr_n57459568)
print v(xbgr.mr_n57459680)
print v(xbgr.mr_n57460000)
print v(xbgr.mr_n57460864)
print v(xbgr.mr_n57461728)
print v(xbgr.mr_n57462592)
print v(xbgr.mr_n57462704)
print v(xbgr.mr_n57463024)
print v(xbgr.mr_n57463136)
print v(xbgr.mr_n57463456)
print v(xbgr.mr_n57463568)
print v(xbgr.mr_n57463888)
print v(xbgr.mr_n57464000)
print v(xbgr.mr_n57464320)
print v(xbgr.mr_n57465184)
print v(xbgr.mr_n57466048)
print v(xbgr.mr_n57466160)
print v(xbgr.mr_n57466480)
print v(xbgr.mr_n57466592)
print v(xbgr.mr_n57466912)
print v(xbgr.mr_n57467024)
print v(xbgr.mr_n57467344)
print v(xbgr.mr_n57467456)
print v(xbgr.mr_n57467776)
print v(xbgr.mr_n57467888)
print v(xbgr.mr_n57468320)
print v(xbgr.mr_n57468640)
print v(xbgr.mr_n57468752)
print v(xbgr.mr_n57469072)
print v(xbgr.mr_n57469184)
print v(xbgr.mr_n57469504)
print v(xbgr.mr_n57469616)
print v(xbgr.mr_n57469936)
print v(xbgr.mr_n57470048)
print v(xbgr.mr_n57470368)
print v(xbgr.mr_n57471232)
print v(xbgr.mr_n57471344)
print v(xbgr.mr_n57471776)
print v(xbgr.mr_n57472096)
print v(xbgr.mr_n57472208)
print v(xbgr.mr_n57472528)
print v(xbgr.mr_n57472640)
print v(xbgr.mr_n57472960)
print v(xbgr.mr_n57473072)
print v(xbgr.mr_n57473392)
print v(xbgr.mr_n57473504)
print v(xbgr.mr_n57473824)
print v(xbgr.mr_n57473936)
print v(xbgr.mr_n57474256)
print v(xbgr.mr_n57474368)
print v(xbgr.mr_n57474688)
print v(xbgr.mr_n57475120)
print v(xbgr.mr_n57475232)
print v(xbgr.mr_n57475552)
print v(xbgr.mr_n57476096)
print v(xbgr.mr_n57476416)
print v(xbgr.mr_n57476528)
print v(xbgr.mr_n57476960)
print v(xbgr.mr_n57477392)
print v(xbgr.mr_n57477824)
print v(xbgr.mr_n57478256)
print v(xbgr.mr_n57478688)
print v(xbgr.mr_n57479008)
print v(xbgr.mr_n57479120)
print v(xbgr.mr_n57479552)
print v(xbgr.mr_n57479872)
print v(xbgr.mr_n57479984)
print v(xbgr.mr_n57480416)
print v(xbgr.mr_n57480736)
print v(xbgr.mr_n57481600)
print v(xbgr.mr_n57482896)
print v(xbgr.mr_n57483440)
print v(xbgr.mr_n57483760)
print v(xbgr.mr_n57484304)
print v(xbgr.mr_n57484624)
print v(xbgr.mr_n57484736)
print v(xbgr.mr_n57485488)
print v(xbgr.mr_n57485920)
print v(xbgr.mr_n57486784)
print v(xbgr.mr_n57487648)
print v(xbgr.mr_n57488944)
print v(xbgr.mr_n57489808)
print v(xbgr.mr_n57490240)
print v(xbgr.mr_n57490352)
print v(xbgr.mr_n57491104)
print v(xbgr.mr_n57491216)
print v(xbgr.mr_n57491536)
print v(xbgr.mr_n57491648)
print v(xbgr.mr_n57491968)
print v(xbgr.mr_n57492080)
print v(xbgr.mr_n57492832)
print v(xbgr.mr_n57494128)
print v(xbgr.mr_n57494992)
print v(xbgr.mr_n57495856)
print v(xbgr.mr_n57496288)
print v(xbgr.mr_n57496400)
print v(xbgr.mr_n57496720)
print v(xbgr.mr_n57496832)
print v(xbgr.mr_n57497152)
print v(xbgr.mr_n57497264)
print v(xbgr.mr_n57497584)
print v(xbgr.mr_n57497696)
print v(xbgr.mr_n57498448)
print v(xbgr.mr_n57498560)
print v(xbgr.mr_n57498880)
print v(xbgr.mr_n57498992)
print v(xbgr.mr_n57499312)
print v(xbgr.mr_n57499424)
print v(xbgr.mr_n57499744)
print v(xbgr.mr_n57500608)
print v(xbgr.mr_n57500720)
print v(xbgr.mr_n57501040)
print v(xbgr.mr_n57501152)
print v(xbgr.mr_n57501584)
print v(xbgr.mr_n57501904)
print v(xbgr.mr_n57502016)
print v(xbgr.mr_n57502336)
print v(xbgr.mr_n57502448)
print v(xbgr.mr_n57502768)
print v(xbgr.mr_n57502880)
print v(xbgr.mr_n57503312)
print v(xbgr.mr_n57503744)
print v(xbgr.mr_n57504064)
print v(xbgr.mr_n57504176)
print v(xbgr.mr_n57504496)
print v(xbgr.mr_n57504608)
print v(xbgr.mr_n57504928)
print v(xbgr.mr_n57505040)
print v(xbgr.mr_n57505472)
print v(xbgr.mr_n57505792)
print v(xbgr.mr_n57505904)
print v(xbgr.mr_n57506336)
print v(xbgr.mr_n57506656)
print v(xbgr.mr_n57506768)
print v(xbgr.mr_n57507088)
print v(xbgr.mr_n57507200)
print v(xbgr.mr_n57507520)
print v(xbgr.mr_n57507632)
print v(xbgr.mr_n57507952)
print v(xbgr.mr_n57508064)
print v(xbgr.mr_n57508384)
print v(xbgr.mr_n57509248)
print v(xbgr.mr_n57510112)
print v(xbgr.mr_n57510224)
print v(xbgr.mr_n57510544)
print v(xbgr.mr_n57511088)
print v(xbgr.mr_n57511408)
print v(xbgr.mr_n57511840)
print v(xbgr.mr_n57513136)
print v(xbgr.mr_n57514432)
print v(xbgr.mr_n57514544)
print v(xbgr.mr_n57514864)
print v(xbgr.mr_n57514976)
print v(xbgr.mr_n57515296)
print v(xbgr.mr_n57515408)
print v(xbgr.mr_n57515728)
print v(xbgr.mr_n57515840)
print v(xbgr.mr_n57516160)
print v(xbgr.mr_n57516272)
print v(xbgr.mr_n57516592)
print v(xbgr.mr_n57516704)
print v(xbgr.mr_n57517024)
print v(xbgr.mr_n57517136)
print v(xbgr.mr_n57517568)
print v(xbgr.mr_n57517888)
print v(xbgr.mr_n57518752)
print v(xbgr.mr_n57518864)
print v(xbgr.mr_n57519184)
print v(xbgr.mr_n57519296)
print v(xbgr.mr_n57519616)
print v(xbgr.mr_n57519728)
print v(xbgr.mr_n57520048)
print v(xbgr.mr_n57520160)
print v(xbgr.mr_n57520480)
print v(xbgr.mr_n57521344)
print v(xbgr.mr_n57522208)
print v(xbgr.mr_n57523072)
print v(xbgr.mr_n57523936)
print v(xbgr.mr_n57524800)
print v(xbgr.mr_n57524912)
print v(xbgr.mr_n57525232)
print v(xbgr.mr_n57525344)
print v(xbgr.mr_n57525664)
print v(xbgr.mr_n57525776)
print v(xbgr.mr_n57526096)
print v(xbgr.mr_n57526208)
print v(xbgr.mr_n57526528)
print v(xbgr.mr_n57526640)
print v(xbgr.mr_n57526960)
print v(xbgr.mr_n57527072)
print v(xbgr.mr_n57527392)
print v(xbgr.mr_n57527504)
print v(xbgr.mr_n57527824)
print v(xbgr.mr_n57527936)
print v(xbgr.mr_n57528256)
print v(xbgr.mr_n57528368)
print v(xbgr.mr_n57528688)
print v(xbgr.mr_n57528800)
print v(xbgr.mr_n57529232)
print v(xbgr.mr_n57529552)
print v(xbgr.mr_n57529664)
print v(xbgr.mr_n57529984)
print v(xbgr.mr_n57530096)
print v(xbgr.mr_n57530528)
print v(xbgr.mr_n57530848)
print v(xbgr.mr_n57530960)
print v(xbgr.mr_n57531392)
print v(xbgr.mr_n57531712)
print v(xbgr.mr_n57531824)
print v(xbgr.mr_n57532256)
print v(xbgr.mr_n57532688)
print v(xbgr.mr_n57533008)
print v(xbgr.mr_n57533120)
print v(xbgr.mr_n57533552)
print v(xbgr.mr_n57533872)
print v(xbgr.mr_n57533984)
print v(xbgr.mr_n57534304)
print v(xbgr.mr_n57534416)
print v(xbgr.mr_n57534736)
print v(xbgr.mr_n57534848)
print v(xbgr.mr_n57535168)
print v(xbgr.mr_n57535280)
print v(xbgr.mr_n57535600)
print v(xbgr.mr_n57535712)
print v(xbgr.mr_n57536032)
print v(xbgr.mr_n57536144)
print v(xbgr.mr_n57536464)
print v(xbgr.mr_n57536576)
print v(xbgr.mr_n57536896)
print v(xbgr.mr_n57537008)
print v(xbgr.mr_n57537328)
print v(xbgr.mr_n57538192)
print v(xbgr.mr_n57538304)
print v(xbgr.mr_n57538624)
print v(xbgr.mr_n57538736)
print v(xbgr.mr_n57539056)
print v(xbgr.mr_n57539920)
print v(xbgr.mr_n57540784)
print v(xbgr.mr_n57541648)
print v(xbgr.mr_n57542512)
print v(xbgr.mr_n57543376)
print v(xbgr.mr_n57543488)
print v(xbgr.mr_n57543808)
print v(xbgr.mr_n57543920)
print v(xbgr.mr_n57544240)
print v(xbgr.mr_n57544352)
print v(xbgr.mr_n57544672)
print v(xbgr.mr_n57545536)
print v(xbgr.mr_n57546400)
print v(xbgr.mr_n57547264)
print v(xbgr.mr_n57548128)
print v(xbgr.mr_n57548992)
print v(xbgr.mr_n57549856)
print v(xbgr.mr_n57550720)
print v(xbgr.mr_n57550832)
print v(xbgr.mr_n57551152)
print v(xbgr.mr_n57551264)
print v(xbgr.mr_n57551696)
print v(xbgr.mr_n57552016)
print v(xbgr.mr_n57552880)
print v(xbgr.mr_n57553424)
print v(xbgr.mr_n57553856)
print v(xbgr.mr_n57554288)
print v(xbgr.mr_n57555040)
print v(xbgr.mr_n57555904)
print v(xbgr.mr_n57556768)
print v(xbgr.mr_n57556880)
print v(xbgr.mr_n57557200)
print v(xbgr.mr_n57557312)
print v(xbgr.mr_n57557744)
print v(xbgr.mr_n57558176)
print v(xbgr.mr_n57558496)
print v(xbgr.mr_n57559360)
print v(xbgr.mr_n57559472)
print v(xbgr.mr_n57559904)
print v(xbgr.mr_n57560224)
print v(xbgr.mr_n57560336)
print v(xbgr.mr_n57560768)
print v(xbgr.mr_n57561088)
print v(xbgr.mr_n57561952)
print v(xbgr.mr_n57562064)
print v(xbgr.mr_n57562384)
print v(xbgr.mr_n57563248)
print v(xbgr.mr_n57564112)
print v(xbgr.mr_n57564224)
print v(xbgr.mr_n57564544)
print v(xbgr.mr_n57564656)
print v(xbgr.mr_n57564976)
print v(xbgr.mr_n57565840)
print v(xbgr.mr_n57566272)
print v(xbgr.mr_n57566384)
print v(xbgr.mr_n57566816)
print v(xbgr.mr_n57567136)
print v(xbgr.mr_n57567248)
print v(xbgr.mr_n57567680)
print v(xbgr.mr_n57568432)
print v(xbgr.mr_n57568544)
print v(xbgr.mr_n57568864)
print v(xbgr.mr_n57568976)
print v(xbgr.mr_n57569296)
print v(xbgr.mr_n57569408)
print v(xbgr.mr_n57569728)
print v(xbgr.mr_n57570160)
print v(xbgr.mr_n57570272)
print v(xbgr.mr_n57571024)
print v(xbgr.mr_n57571456)
print v(xbgr.mr_n57571568)
print v(xbgr.mr_n57572432)
print v(xbgr.mr_n57572752)
print v(xbgr.mr_n57572864)
print v(xbgr.mr_n57573184)
print v(xbgr.mr_n57574048)
print v(xbgr.mr_n57574912)
print v(xbgr.mr_n57575776)
print v(xbgr.mr_n57576640)
print v(xbgr.mr_n57576752)
print v(xbgr.mr_n57577072)
print v(xbgr.mr_n57577184)
print v(xbgr.mr_n57577504)
print v(xbgr.mr_n57577616)
print v(xbgr.mr_n57577936)
print v(xbgr.mr_n57578048)
print v(xbgr.mr_n57578368)
print v(xbgr.mr_n57578480)
print v(xbgr.mr_n57578800)
print v(xbgr.mr_n57578912)
print v(xbgr.mr_n57579232)
print v(xbgr.mr_n57579344)
print v(xbgr.mr_n57579664)
print v(xbgr.mr_n57579776)
print v(xbgr.mr_n57580096)
print v(xbgr.mr_n57580208)
print v(xbgr.mr_n57580528)
print v(xbgr.mr_n57580640)
print v(xbgr.mr_n57581072)
print v(xbgr.mr_n57581504)
print v(xbgr.mr_n57581936)
print v(xbgr.mr_n57582256)
print v(xbgr.mr_n57582368)
print v(xbgr.mr_n57582688)
print v(xbgr.mr_n57583552)
print v(xbgr.mr_n57583664)
print v(xbgr.mr_n57583984)
print v(xbgr.mr_n57584096)
print v(xbgr.mr_n57584416)
print v(xbgr.mr_n57584528)
print v(xbgr.mr_n57584960)
print v(xbgr.mr_n57585280)
print v(xbgr.mr_n57585392)
print v(xbgr.mr_n57585712)
print v(xbgr.mr_n57585824)
print v(xbgr.mr_n57586256)
print v(xbgr.mr_n57586576)
print v(xbgr.mr_n57587008)
print v(xbgr.mr_n57587120)
print v(xbgr.mr_n57587440)
print v(xbgr.mr_n57587552)
print v(xbgr.mr_n57587872)
print v(xbgr.mr_n57587984)
print v(xbgr.mr_n57588304)
print v(xbgr.mr_n57588416)
print v(xbgr.mr_n57588848)
print v(xbgr.mr_n57589168)
print v(xbgr.mr_n57589280)
print v(xbgr.mr_n57589600)
print v(xbgr.mr_n57589712)
print v(xbgr.mr_n57590032)
print v(xbgr.mr_n57590144)
print v(xbgr.mr_n57590464)
print v(xbgr.mr_n57590576)
print v(xbgr.mr_n57590896)
print v(xbgr.mr_n57591008)
print v(xbgr.mr_n57591328)
print v(xbgr.mr_n57591440)
print v(xbgr.mr_n57591760)
print v(xbgr.mr_n57591872)
print v(xbgr.mr_n57592624)
print v(xbgr.mr_n57593056)
print v(xbgr.mr_n57593920)
print v(xbgr.mr_n57594032)
print v(xbgr.mr_n57594352)
print v(xbgr.mr_n57594896)
print v(xbgr.mr_n57595328)
print v(xbgr.mr_n57595760)
print v(xbgr.mr_n57596080)
print v(xbgr.mr_n57596512)
print v(xbgr.mr_n57597376)
print v(xbgr.mr_n57599536)
print v(xbgr.mr_n57600400)
print v(xbgr.mr_n57600512)
print v(xbgr.mr_n57600832)
print v(xbgr.mr_n57601696)
print v(xbgr.mr_n57602560)
print v(xbgr.mr_n57602672)
print v(xbgr.mr_n57602992)
print v(xbgr.mr_n57603104)
print v(xbgr.mr_n57603424)
print v(xbgr.mr_n57603536)
print v(xbgr.mr_n57603856)
print v(xbgr.mr_n57603968)
print v(xbgr.mr_n57604288)
print v(xbgr.mr_n57605152)
print v(xbgr.mr_n57606016)
print v(xbgr.mr_n57606128)
print v(xbgr.mr_n57606448)
print v(xbgr.mr_n57606560)
print v(xbgr.mr_n57606880)
print v(xbgr.mr_n57606992)
print v(xbgr.mr_n57607312)
print v(xbgr.mr_n57607424)
print v(xbgr.mr_n57607744)
print v(xbgr.mr_n57607856)
print v(xbgr.mr_n57608176)
print v(xbgr.mr_n57608288)
print v(xbgr.mr_n57608608)
print v(xbgr.mr_n57608720)
print v(xbgr.mr_n57609152)
print v(xbgr.mr_n57609472)
print v(xbgr.mr_n57609584)
print v(xbgr.mr_n57610016)
print v(xbgr.mr_n57610336)
print v(xbgr.mr_n57610880)
print v(xbgr.mr_n57611744)
print v(xbgr.mr_n57612064)
print v(xbgr.mr_n57612176)
print v(xbgr.mr_n57613360)
print v(xbgr.mr_n57613472)
print v(xbgr.mr_n57613792)
print v(xbgr.mr_n57613904)
print v(xbgr.mr_n57614224)
print v(xbgr.mr_n57614336)
print v(xbgr.mr_n57614656)
print v(xbgr.mr_n57614768)
print v(xbgr.mr_n57615088)
print v(xbgr.mr_n57615952)
print v(xbgr.mr_n57616816)
print v(xbgr.mr_n57616928)
print v(xbgr.mr_n57617360)
print v(xbgr.mr_n57617792)
print v(xbgr.mr_n57618224)
print v(xbgr.mr_n57618544)
print v(xbgr.mr_n57618656)
print v(xbgr.mr_n57618976)
print v(xbgr.mr_n57619088)
print v(xbgr.mr_n57619408)
print v(xbgr.mr_n57619520)
print v(xbgr.mr_n57619840)
print v(xbgr.mr_n57619952)
print v(xbgr.mr_n57620272)
print v(xbgr.mr_n57620384)
print v(xbgr.mr_n57620704)
print v(xbgr.mr_n57620816)
print v(xbgr.mr_n57621136)
print v(xbgr.mr_n57622000)
print v(xbgr.mr_n57622112)
print v(xbgr.mr_n57622432)
print v(xbgr.mr_n57622544)
print v(xbgr.mr_n57622864)
print v(xbgr.mr_n57622976)
print v(xbgr.mr_n57623296)
print v(xbgr.mr_n57623408)
print v(xbgr.mr_n57623728)
print v(xbgr.mr_n57624272)
print v(xbgr.mr_n57625024)
print v(xbgr.mr_n57625888)
print v(xbgr.mr_n57626752)
print v(xbgr.mr_n57627616)
print v(xbgr.mr_n57628480)
print v(xbgr.mr_n57629344)
print v(xbgr.mr_n57629456)
print v(xbgr.mr_n57629776)
print v(xbgr.mr_n57629888)
print v(xbgr.mr_n57630208)
print v(xbgr.mr_n57630320)
print v(xbgr.mr_n57630640)
print v(xbgr.mr_n57630752)
print v(xbgr.mr_n57631072)
print v(xbgr.mr_n57631184)
print v(xbgr.mr_n57631504)
print v(xbgr.mr_n57631616)
print v(xbgr.mr_n57631936)
print v(xbgr.mr_n57632800)
print v(xbgr.mr_n57633664)
print v(xbgr.mr_n57634528)
print v(xbgr.mr_n57635392)
print v(xbgr.mr_n57636256)
print v(xbgr.mr_n57637120)
print v(xbgr.mr_n57637984)
print v(xbgr.mr_n57638096)
print v(xbgr.mr_n57638416)
print v(xbgr.mr_n57638528)
print v(xbgr.mr_n57638848)
print v(xbgr.mr_n57638960)
print v(xbgr.mr_n57639280)
print v(xbgr.mr_n57639392)
print v(xbgr.mr_n57639712)
print v(xbgr.mr_n57639824)
print v(xbgr.mr_n57640144)
print v(xbgr.mr_n57640256)
print v(xbgr.mr_n57640576)
print v(xbgr.mr_n57640688)
print v(xbgr.mr_n57641120)
print v(xbgr.mr_n57641440)
print v(xbgr.mr_n57641552)
print v(xbgr.mr_n57641984)
print v(xbgr.mr_n57642304)
print v(xbgr.mr_n57642416)
print v(xbgr.mr_n57642848)
print v(xbgr.mr_n57643168)
print v(xbgr.mr_n57644032)
print v(xbgr.mr_n57644896)
print v(xbgr.mr_n57645760)
print v(xbgr.mr_n57646624)
print v(xbgr.mr_n57647488)
print v(xbgr.mr_n57648352)
print v(xbgr.mr_n57648464)
print v(xbgr.mr_n57648784)
print v(xbgr.mr_n57648896)
print v(xbgr.mr_n57649216)
print v(xbgr.mr_n57649328)
print v(xbgr.mr_n57649648)
print v(xbgr.mr_n57649760)
print v(xbgr.mr_n57650080)
print v(xbgr.mr_n57650944)
print v(xbgr.mr_n57651808)
print v(xbgr.mr_n57652672)
print v(xbgr.mr_n57652784)
print v(xbgr.mr_n57653216)
print v(xbgr.mr_n57653536)
print v(xbgr.mr_n57653648)
print v(xbgr.mr_n57653968)
print v(xbgr.mr_n57654080)
print v(xbgr.mr_n57654400)
print v(xbgr.mr_n57654512)
print v(xbgr.mr_n57654832)
print v(xbgr.mr_n57654944)
print v(xbgr.mr_n57655264)
print v(xbgr.mr_n57655376)
print v(xbgr.mr_n57655808)
print v(xbgr.mr_n57656128)
print v(xbgr.mr_n57656240)
print v(xbgr.mr_n57656672)
print v(xbgr.mr_n57656992)
print v(xbgr.mr_n57657104)
print v(xbgr.mr_n57657424)
print v(xbgr.mr_n57657536)
print v(xbgr.mr_n57657968)
print v(xbgr.mr_n57658400)
print v(xbgr.mr_n57658720)
print v(xbgr.mr_n57658832)
print v(xbgr.mr_n57659264)
print v(xbgr.mr_n57659584)
print v(xbgr.mr_n57659696)
print v(xbgr.mr_n57660128)
print v(xbgr.mr_n57660448)
print v(xbgr.mr_n57661312)
print v(xbgr.mr_n57662176)
print v(xbgr.mr_n57663040)
print v(xbgr.mr_n57663904)
print v(xbgr.mr_n57664016)
print v(xbgr.mr_n57664336)
print v(xbgr.mr_n57664448)
print v(xbgr.mr_n57664768)
print v(xbgr.mr_n57664880)
print v(xbgr.mr_n57665200)
print v(xbgr.mr_n57665312)
print v(xbgr.mr_n57665632)
print v(xbgr.mr_n57666496)
print v(xbgr.mr_n57667360)
print v(xbgr.mr_n57668224)
print v(xbgr.mr_n57669088)
print v(xbgr.mr_n57669952)
print v(xbgr.mr_n57670816)
print v(xbgr.mr_n57671680)
print v(xbgr.mr_n57672544)
print v(xbgr.mr_n57672656)
print v(xbgr.mr_n57672976)
print v(xbgr.mr_n57673088)
print v(xbgr.mr_n57673408)
print v(xbgr.mr_n57673520)
print v(xbgr.mr_n57673840)
print v(xbgr.mr_n57673952)
print v(xbgr.mr_n57674272)
print v(xbgr.mr_n57674384)
print v(xbgr.mr_n57674704)
print v(xbgr.mr_n57674816)
print v(xbgr.mr_n57675136)
print v(xbgr.mr_n57675248)
print v(xbgr.mr_n57675568)
print v(xbgr.mr_n57675680)
print v(xbgr.mr_n57676000)
print v(xbgr.mr_n57676112)
print v(xbgr.mr_n57676432)
print v(xbgr.mr_n57676544)
print v(xbgr.mr_n57676976)
print v(xbgr.mr_n57677296)
print v(xbgr.mr_n57677408)
print v(xbgr.mr_n57677728)
print v(xbgr.mr_n57677840)
print v(xbgr.mr_n57678160)
print v(xbgr.mr_n57678272)
print v(xbgr.mr_n57678592)
print v(xbgr.mr_n57678704)
print v(xbgr.mr_n57679024)
print v(xbgr.mr_n57679136)
print v(xbgr.mr_n57679568)
print v(xbgr.mr_n57679888)
print v(xbgr.mr_n57680000)
print v(xbgr.mr_n57680432)
print v(xbgr.mr_n57680752)
print v(xbgr.mr_n57680864)
print v(xbgr.mr_n57681184)
print v(xbgr.mr_n57682048)
print v(xbgr.mr_n57682912)
print v(xbgr.mr_n57683456)
print v(xbgr.mr_n57684208)
print v(xbgr.mr_n57684640)
print v(xbgr.mr_n57684752)
print v(xbgr.mr_n57685504)
print v(xbgr.mr_n57685616)
print v(xbgr.mr_n57686048)
print v(xbgr.mr_n57686480)
print v(xbgr.mr_n57686800)
print v(xbgr.mr_n57687664)
print v(xbgr.mr_n57688096)
print v(xbgr.mr_n57688960)
print v(xbgr.mr_n57689072)
print v(xbgr.mr_n57689824)
print v(xbgr.mr_n57691120)
print v(xbgr.mr_n57691984)
print v(xbgr.mr_n57692096)
print v(xbgr.mr_n57692416)
print v(xbgr.mr_n57692528)
print v(xbgr.mr_n57692848)
print v(xbgr.mr_n57692960)
print v(xbgr.mr_n57693280)
print v(xbgr.mr_n57693392)
print v(xbgr.mr_n57693712)
print v(xbgr.mr_n57694576)
print v(xbgr.mr_n57695440)
print v(xbgr.mr_n57696304)
print v(xbgr.mr_n57696416)
print v(xbgr.mr_n57696736)
print v(xbgr.mr_n57696848)
print v(xbgr.mr_n57697168)
print v(xbgr.mr_n57698032)
print v(xbgr.mr_n57698144)
print v(xbgr.mr_n57698464)
print v(xbgr.mr_n57698576)
print v(xbgr.mr_n57698896)
print v(xbgr.mr_n57699008)
print v(xbgr.mr_n57699328)
print v(xbgr.mr_n57699440)
print v(xbgr.mr_n57699760)
print v(xbgr.mr_n57700624)
print v(xbgr.mr_n57701488)
print v(xbgr.mr_n57701600)
print v(xbgr.mr_n57701920)
print v(xbgr.mr_n57702032)
print v(xbgr.mr_n57702352)
print v(xbgr.mr_n57702464)
print v(xbgr.mr_n57702784)
print v(xbgr.mr_n57702896)
print v(xbgr.mr_n57703216)
print v(xbgr.mr_n57703328)
print v(xbgr.mr_n57703648)
print v(xbgr.mr_n57703760)
print v(xbgr.mr_n57704512)
print v(xbgr.mr_n57705376)
print v(xbgr.mr_n57706240)
print v(xbgr.mr_n57706352)
print v(xbgr.mr_n57706672)
print v(xbgr.mr_n57706784)
print v(xbgr.mr_n57707104)
print v(xbgr.mr_n57707216)
print v(xbgr.mr_n57707536)
print v(xbgr.mr_n57707648)
print v(xbgr.mr_n57708080)
print v(xbgr.mr_n57708400)
print v(xbgr.mr_n57708512)
print v(xbgr.mr_n57709264)
print v(xbgr.mr_n57710128)
print v(xbgr.mr_n57710992)
print v(xbgr.mr_n57711856)
print v(xbgr.mr_n57711968)
print v(xbgr.mr_n57712288)
print v(xbgr.mr_n57712400)
print v(xbgr.mr_n57712720)
print v(xbgr.mr_n57712832)
print v(xbgr.mr_n57713152)
print v(xbgr.mr_n57713264)
print v(xbgr.mr_n57713584)
print v(xbgr.mr_n57714448)
print v(xbgr.mr_n57715744)
print v(xbgr.mr_n57715856)
print v(xbgr.mr_n57716176)
print v(xbgr.mr_n57716288)
print v(xbgr.mr_n57716720)
print v(xbgr.mr_n57717040)
print v(xbgr.mr_n57717152)
print v(xbgr.mr_n57717584)
print v(xbgr.mr_n57717904)
print v(xbgr.mr_n57718336)
print v(xbgr.mr_n57719200)
print v(xbgr.mr_n57720064)
print v(xbgr.mr_n57720176)
print v(xbgr.mr_n57720496)
print v(xbgr.mr_n57720608)
print v(xbgr.mr_n57721040)
print v(xbgr.mr_n57721360)
print v(xbgr.mr_n57721472)
print v(xbgr.mr_n57721792)
print v(xbgr.mr_n57721904)
print v(xbgr.mr_n57722224)
print v(xbgr.mr_n57722336)
print v(xbgr.mr_n57722656)
print v(xbgr.mr_n57722768)
print v(xbgr.mr_n57723200)
print v(xbgr.mr_n57723632)
print v(xbgr.mr_n57724064)
print v(xbgr.mr_n57724496)
print v(xbgr.mr_n57724816)
print v(xbgr.mr_n57724928)
print v(xbgr.mr_n57725360)
print v(xbgr.mr_n57725680)
print v(xbgr.mr_n57726544)
print v(xbgr.mr_n57727408)
print v(xbgr.mr_n57727840)
print v(xbgr.mr_n57728704)
print v(xbgr.mr_n57729136)
print v(xbgr.mr_n57729248)
print v(xbgr.mr_n57730000)
print v(xbgr.mr_n57730864)
print v(xbgr.mr_n57731728)
print v(xbgr.mr_n57731840)
print v(xbgr.mr_n57732272)
print v(xbgr.mr_n57732592)
print v(xbgr.mr_n57733456)
print v(xbgr.mr_n57733568)
print v(xbgr.mr_n57733888)
print v(xbgr.mr_n57734000)
print v(xbgr.mr_n57734320)
print v(xbgr.mr_n57734432)
print v(xbgr.mr_n57734752)
print v(xbgr.mr_n57734864)
print v(xbgr.mr_n57735184)
print v(xbgr.mr_n57735296)
print v(xbgr.mr_n57735616)
print v(xbgr.mr_n57735728)
print v(xbgr.mr_n57736048)
print v(xbgr.mr_n57736160)
print v(xbgr.mr_n57736480)
print v(xbgr.mr_n57736592)
print v(xbgr.mr_n57736912)
print v(xbgr.mr_n57737024)
print v(xbgr.mr_n57737344)
print v(xbgr.mr_n57737456)
print v(xbgr.mr_n57738208)
print v(xbgr.mr_n57739504)
print v(xbgr.mr_n57740368)
print v(xbgr.mr_n57741664)
print v(xbgr.mr_n57741776)
print v(xbgr.mr_n57742096)
print v(xbgr.mr_n57742208)
print v(xbgr.mr_n57742528)
print v(xbgr.mr_n57742640)
print v(xbgr.mr_n57742960)
print v(xbgr.mr_n57743072)
print v(xbgr.mr_n57743824)
print v(xbgr.mr_n57744688)
print v(xbgr.mr_n57745552)
print v(xbgr.mr_n57746416)
print v(xbgr.mr_n57746528)
print v(xbgr.mr_n57746848)
print v(xbgr.mr_n57746960)
print v(xbgr.mr_n57747280)
print v(xbgr.mr_n57747392)
print v(xbgr.mr_n57747712)
print v(xbgr.mr_n57747824)
print v(xbgr.mr_n57748144)
print v(xbgr.mr_n57748256)
print v(xbgr.mr_n57748576)
print v(xbgr.mr_n57749120)
print v(xbgr.mr_n57749872)
print v(xbgr.mr_n57750736)
print v(xbgr.mr_n57750848)
print v(xbgr.mr_n57751168)
print v(xbgr.mr_n57751280)
print v(xbgr.mr_n57751712)
print v(xbgr.mr_n57752032)
print v(xbgr.mr_n57752144)
print v(xbgr.mr_n57752464)
print v(xbgr.mr_n57752576)
print v(xbgr.mr_n57752896)
print v(xbgr.mr_n57753008)
print v(xbgr.mr_n57753328)
print v(xbgr.mr_n57753440)
print v(xbgr.mr_n57753760)
print v(xbgr.mr_n57754192)
print v(xbgr.mr_n57754304)
print v(xbgr.mr_n57754624)
print v(xbgr.mr_n57754736)
print v(xbgr.mr_n57755488)
print v(xbgr.mr_n57755600)
print v(xbgr.mr_n57755920)
print v(xbgr.mr_n57756032)
print v(xbgr.mr_n57756784)
print v(xbgr.mr_n57757648)
print v(xbgr.mr_n57757760)
print v(xbgr.mr_n57758080)
print v(xbgr.mr_n57758944)
print v(xbgr.mr_n57759488)
print v(xbgr.mr_n57759808)
print v(xbgr.mr_n57760352)
print v(xbgr.mr_n57760784)
print v(xbgr.mr_n57761104)
print v(xbgr.mr_n57761216)
print v(xbgr.mr_n57761968)
print v(xbgr.mr_n57762080)
print v(xbgr.mr_n57762400)
print v(xbgr.mr_n57762512)
print v(xbgr.mr_n57762832)
print v(xbgr.mr_n57763696)
print v(xbgr.mr_n57764128)
print v(xbgr.mr_n57764240)
print v(xbgr.mr_n57764560)
print v(xbgr.mr_n57764672)
print v(xbgr.mr_n57764992)
print v(xbgr.mr_n57765104)
print v(xbgr.mr_n57765424)
print v(xbgr.mr_n57765536)
print v(xbgr.mr_n57765856)
print v(xbgr.mr_n57765968)
print v(xbgr.mr_n57767152)
print v(xbgr.mr_n57767264)
print v(xbgr.mr_n57767584)
print v(xbgr.mr_n57767696)
print v(xbgr.mr_n57768016)
print v(xbgr.mr_n57768128)
print v(xbgr.mr_n57768448)
print v(xbgr.mr_n57768880)
print v(xbgr.mr_n57901264)
print v(xbgr.mr_n57901376)
print v(xbgr.mr_n57901696)
print v(xbgr.mr_n57901808)
print v(xbgr.mr_n57902128)
print v(xbgr.mr_n57902240)
print v(xbgr.mr_n57902560)
print v(xbgr.mr_n57902672)
print v(xbgr.mr_n57902992)
print v(xbgr.mr_n57903104)
print v(xbgr.mr_n57903424)
print v(xbgr.mr_n57903536)
print v(xbgr.mr_n57903856)
print v(xbgr.mr_n57903968)
print v(xbgr.mr_n57904288)
print v(xbgr.mr_n57904400)
print v(xbgr.mr_n57904720)
print v(xbgr.mr_n57904832)
print v(xbgr.mr_n57905152)
print v(xbgr.mr_n57905264)
print v(xbgr.mr_n57905584)
print v(xbgr.mr_n57905696)
print v(xbgr.mr_n57906016)
print v(xbgr.mr_n57906128)
print v(xbgr.mr_n57906448)
print v(xbgr.mr_n57906560)
print v(xbgr.mr_n57906880)
print v(xbgr.mr_n57906992)
print v(xbgr.mr_n57907312)
print v(xbgr.mr_n57907424)
print v(xbgr.mr_n57907744)
print v(xbgr.mr_n57907856)
print v(xbgr.mr_n57908176)
print v(xbgr.mr_n57908288)
print v(xbgr.mr_n57908608)
print v(xbgr.mr_n57908720)
print v(xbgr.mr_n57909040)
print v(xbgr.mr_n57909152)
print v(xbgr.mr_n57909472)
print v(xbgr.mr_n57909584)
print v(xbgr.mr_n57909904)
print v(xbgr.mr_n57910016)
print v(xbgr.mr_n57910336)
print v(xbgr.mr_n57910448)
print v(xbgr.mr_n57910768)
print v(xbgr.mr_n57910880)
print v(xbgr.mr_n57911200)
print v(xbgr.mr_n57911312)
print v(xbgr.mr_n57911632)
print v(xbgr.mr_n57911744)
print v(xbgr.mr_n57912064)
print v(xbgr.mr_n57912176)
print v(xbgr.mr_n57912496)
print v(xbgr.mr_n57912608)
print v(xbgr.mr_n57912928)
print v(xbgr.mr_n57913040)
print v(xbgr.mr_n57913360)
print v(xbgr.mr_n57913472)
print v(xbgr.mr_n57913792)
print v(xbgr.mr_n57913904)
print v(xbgr.mr_n57914224)
print v(xbgr.mr_n57914336)
print v(xbgr.mr_n57914656)
print v(xbgr.mr_n57914768)
print v(xbgr.mr_n57915088)
print v(xbgr.mr_n57915200)
print v(xbgr.mr_n57915520)
print v(xbgr.mr_n57915632)
print v(xbgr.mr_n57915952)
print v(xbgr.mr_n57916064)
print v(xbgr.mr_n57916384)
print v(xbgr.mr_n57916496)
print v(xbgr.mr_n57916816)
print v(xbgr.mr_n57916928)
print v(xbgr.mr_n57917248)
print v(xbgr.mr_n57917360)
print v(xbgr.mr_n57917680)
print v(xbgr.mr_n57917792)
print v(xbgr.mr_n57918112)
print v(xbgr.mr_n57918224)
print v(xbgr.mr_n57918544)
print v(xbgr.mr_n57918656)
print v(xbgr.mr_n57918976)
print v(xbgr.mr_n57919088)
print v(xbgr.mr_n57919408)
print v(xbgr.mr_n57919520)
print v(xbgr.mr_n57919840)
print v(xbgr.mr_n57919952)
print v(xbgr.mr_n57920272)
print v(xbgr.mr_n57920384)
print v(xbgr.mr_n57920704)
print v(xbgr.mr_n57920816)
print v(xbgr.mr_n57921136)
print v(xbgr.mr_n57921248)
print v(xbgr.mr_n57921568)
print v(xbgr.mr_n57921680)
print v(xbgr.mr_n57922000)
print v(xbgr.mr_n57922112)
print v(xbgr.mr_n57922432)
print v(xbgr.mr_n57922544)
print v(xbgr.mr_n57922864)
print v(xbgr.mr_n57922976)
print v(xbgr.mr_n57923296)
print v(xbgr.mr_n57923408)
print v(xbgr.mr_n57923728)
print v(xbgr.mr_n57923840)
print v(xbgr.mr_n57924160)
print v(xbgr.mr_n57924272)
print v(xbgr.mr_n57924592)
print v(xbgr.mr_n57924704)
print v(xbgr.mr_n57925024)
print v(xbgr.mr_n57925136)
print v(xbgr.mr_n57925456)
print v(xbgr.mr_n57925568)
print v(xbgr.mr_n57925888)
print v(xbgr.mr_n57926000)
print v(xbgr.mr_n57926320)
print v(xbgr.mr_n57926432)
print v(xbgr.mr_n57926752)
print v(xbgr.mr_n57926864)
print v(xbgr.mr_n57927184)
print v(xbgr.mr_n57927296)
print v(xbgr.mr_n57927616)
print v(xbgr.mr_n57927728)
print v(xbgr.mr_n57928048)
print v(xbgr.mr_n57928160)
print v(xbgr.mr_n57928480)
print v(xbgr.mr_n57928592)
print v(xbgr.mr_n57928912)
print v(xbgr.mr_n57929024)
print v(xbgr.mr_n57929344)
print v(xbgr.mr_n57929456)
print v(xbgr.mr_n57929776)
print v(xbgr.mr_n57929888)
print v(xbgr.mr_n57930208)
print v(xbgr.mr_n57930320)
print v(xbgr.mr_n57930640)
print v(xbgr.mr_n57930752)
print v(xbgr.mr_n57931072)
print v(xbgr.mr_n57931184)
print v(xbgr.mr_n57931504)
print v(xbgr.mr_n57931616)
print v(xbgr.mr_n57931936)
print v(xbgr.mr_n57932048)
print v(xbgr.mr_n57932368)
print v(xbgr.mr_n57932480)
print v(xbgr.mr_n57932800)
print v(xbgr.mr_n57932912)
print v(xbgr.mr_n57933232)
print v(xbgr.mr_n57933344)
print v(xbgr.mr_n57933664)
print v(xbgr.mr_n57933776)
print v(xbgr.mr_n57934096)
print v(xbgr.mr_n57934208)
print v(xbgr.mr_n57934528)
print v(xbgr.mr_n57934640)
print v(xbgr.mr_n57934960)
print v(xbgr.mr_n57935072)
print v(xbgr.mr_n57935392)
print v(xbgr.mr_n57935504)
print v(xbgr.mr_n57935824)
print v(xbgr.mr_n57935936)
print v(xbgr.mr_n57936256)
print v(xbgr.mr_n57936368)
print v(xbgr.mr_n57936688)
print v(xbgr.mr_n57936800)
print v(xbgr.mr_n57937120)
print v(xbgr.mr_n57937232)
print v(xbgr.mr_n57937552)
print v(xbgr.mr_n57937664)
print v(xbgr.mr_n57937984)
print v(xbgr.mr_n57938096)
print v(xbgr.mr_n57938416)
print v(xbgr.mr_n57938528)
print v(xbgr.mr_n57938848)
print v(xbgr.mr_n57938960)
print v(xbgr.mr_n57939280)
print v(xbgr.mr_n57939392)
print v(xbgr.mr_n57939712)
print v(xbgr.mr_n57939824)
print v(xbgr.mr_n57940144)
print v(xbgr.mr_n57940256)
print v(xbgr.mr_n57940576)
print v(xbgr.mr_n57940688)
print v(xbgr.mr_n57941008)
print v(xbgr.mr_n57941120)
print v(xbgr.mr_n57941440)
print v(xbgr.mr_n57941552)
print v(xbgr.mr_n57941872)
print v(xbgr.mr_n57941984)
print v(xbgr.mr_n57942304)
print v(xbgr.mr_n57942416)
print v(xbgr.mr_n57942736)
print v(xbgr.mr_n57942848)
print v(xbgr.mr_n57943168)
print v(xbgr.mr_n57943280)
print v(xbgr.mr_n57943600)
print v(xbgr.mr_n57943712)
print v(xbgr.mr_n57944032)
print v(xbgr.mr_n57944144)
print v(xbgr.mr_n57944464)
print v(xbgr.mr_n57944576)
print v(xbgr.mr_n57944896)
print v(xbgr.mr_n57945008)
print v(xbgr.mr_n57945328)
print v(xbgr.mr_n57945440)
print v(xbgr.mr_n57945760)
print v(xbgr.mr_n57945872)
print v(xbgr.mr_n57946192)
print v(xbgr.mr_n57946304)
print v(xbgr.mr_n57946624)
print v(xbgr.mr_n57946736)
print v(xbgr.mr_n57947056)
print v(xbgr.mr_n57947168)
print v(xbgr.mr_n57947488)
print v(xbgr.mr_n57947600)
print v(xbgr.mr_n57947920)
print v(xbgr.mr_n57948032)
print v(xbgr.mr_n57948352)
print v(xbgr.mr_n57948464)
print v(xbgr.mr_n57948784)
print v(xbgr.mr_n57948896)
print v(xbgr.mr_n57949216)
print v(xbgr.mr_n57949328)
print v(xbgr.mr_n57949648)
print v(xbgr.mr_n57949760)
print v(xbgr.mr_n57950080)
print v(xbgr.mr_n57950192)
print v(xbgr.mr_n57950512)
print v(xbgr.mr_n57950624)
print v(xbgr.mr_n57950944)
print v(xbgr.mr_n57951056)
print v(xbgr.mr_n57951376)
print v(xbgr.mr_n57951488)
print v(xbgr.mr_n57951808)
print v(xbgr.mr_n57951920)
print v(xbgr.mr_n57952240)
print v(xbgr.mr_n57952352)
print v(xbgr.mr_n57952672)
print v(xbgr.mr_n57952784)
print v(xbgr.mr_n57953104)
print v(xbgr.mr_n57953216)
print v(xbgr.mr_n57953536)
print v(xbgr.mr_n57953648)
print v(xbgr.mr_n57953968)
print v(xbgr.mr_n57954080)
print v(xbgr.mr_n57954400)
print v(xbgr.mr_n57954512)
print v(xbgr.mr_n57954832)
print v(xbgr.mr_n57954944)
print v(xbgr.mr_n57955264)
print v(xbgr.mr_n57955376)
print v(xbgr.mr_n57955696)
print v(xbgr.mr_n57955808)
print v(xbgr.mr_n57956128)
print v(xbgr.mr_n57956240)
print v(xbgr.mr_n57956560)
print v(xbgr.mr_n57956672)
print v(xbgr.mr_n57956992)
print v(xbgr.mr_n57957104)
print v(xbgr.mr_n57957424)
print v(xbgr.mr_n57957536)
print v(xbgr.mr_n57957856)
print v(xbgr.mr_n57957968)
print v(xbgr.mr_n57958288)
print v(xbgr.mr_n57958400)
print v(xbgr.mr_n57958720)
print v(xbgr.mr_n57958832)
print v(xbgr.mr_n57959152)
print v(xbgr.mr_n57959264)
print v(xbgr.mr_n57959584)
print v(xbgr.mr_n57959696)
print v(xbgr.mr_n57960016)
print v(xbgr.mr_n57960128)
print v(xbgr.mr_n57960448)
print v(xbgr.mr_n57960560)
print v(xbgr.mr_n57960880)
print v(xbgr.mr_n57960992)
print v(xbgr.mr_n57961312)
print v(xbgr.mr_n57961424)
print v(xbgr.mr_n57961744)
print v(xbgr.mr_n57961856)
print v(xbgr.mr_n57962176)
print v(xbgr.mr_n57962288)
print v(xbgr.mr_n57962608)
print v(xbgr.mr_n57962720)
print v(xbgr.mr_n57963040)
print v(xbgr.mr_n57963152)
print v(xbgr.mr_n57963472)
print v(xbgr.mr_n57963584)
print v(xbgr.mr_n57963904)
print v(xbgr.mr_n57964016)
print v(xbgr.mr_n57964336)
print v(xbgr.mr_n57964448)
print v(xbgr.mr_n57964768)
print v(xbgr.mr_n57964880)
print v(xbgr.mr_n57965200)
print v(xbgr.mr_n57965312)
print v(xbgr.mr_n57965632)
print v(xbgr.mr_n57965744)
print v(xbgr.mr_n57966064)
print v(xbgr.mr_n57966176)
print v(xbgr.mr_n57966496)
print v(xbgr.mr_n57966608)
print v(xbgr.mr_n57966928)
print v(xbgr.mr_n57967040)
print v(xbgr.mr_n57967360)
print v(xbgr.mr_n57967472)
print v(xbgr.mr_n57967792)
print v(xbgr.mr_n57967904)
print v(xbgr.mr_n57968224)
print v(xbgr.mr_n57968336)
print v(xbgr.mr_n57968656)
print v(xbgr.mr_n57968768)
print v(xbgr.mr_n57969088)
print v(xbgr.mr_n57969200)
print v(xbgr.mr_n57969520)
print v(xbgr.mr_n57969632)
print v(xbgr.mr_n57969952)
print v(xbgr.mr_n57970064)
print v(xbgr.mr_n57970384)
print v(xbgr.mr_n57970496)
print v(xbgr.mr_n57970816)
print v(xbgr.mr_n57970928)
print v(xbgr.mr_n57971248)
print v(xbgr.mr_n57971360)
print v(xbgr.mr_n57971680)
print v(xbgr.mr_n57971792)
print v(xbgr.mr_n57972112)
print v(xbgr.mr_n57972224)
print v(xbgr.mr_n57972544)
print v(xbgr.mr_n57972656)
print v(xbgr.mr_n57972976)
print v(xbgr.mr_n57973088)
print v(xbgr.mr_n57973408)
print v(xbgr.mr_n57973520)
print v(xbgr.mr_n57973840)
print v(xbgr.mr_n57973952)
print v(xbgr.mr_n57974272)
print v(xbgr.mr_n57974384)
print v(xbgr.mr_n57974704)
print v(xbgr.mr_n57974816)
print v(xbgr.mr_n57975136)
print v(xbgr.mr_n57975248)
print v(xbgr.mr_n57975568)
print v(xbgr.mr_n57975680)
print v(xbgr.mr_n57976000)
print v(xbgr.mr_n57976112)
print v(xbgr.mr_n57976432)
print v(xbgr.mr_n57976544)
print v(xbgr.mr_n57976864)
print v(xbgr.mr_n57976976)
print v(xbgr.mr_n57977296)
print v(xbgr.mr_n57977408)
print v(xbgr.mr_n57977728)
print v(xbgr.mr_n57977840)
print v(xbgr.mr_n57978160)
print v(xbgr.mr_n57978272)
print v(xbgr.mr_n57978592)
print v(xbgr.mr_n57978704)
print v(xbgr.mr_n57979024)
print v(xbgr.mr_n57979136)
print v(xbgr.mr_n57979456)
print v(xbgr.mr_n57979568)
print v(xbgr.mr_n57979888)
print v(xbgr.mr_n57980000)
print v(xbgr.mr_n57980320)
print v(xbgr.mr_n57980432)
print v(xbgr.mr_n57980752)
print v(xbgr.mr_n57980864)
print v(xbgr.mr_n57981184)
print v(xbgr.mr_n57981296)
print v(xbgr.mr_n57981616)
print v(xbgr.mr_n57981728)
print v(xbgr.mr_n57982048)
print v(xbgr.mr_n57982160)
print v(xbgr.mr_n57982480)
print v(xbgr.mr_n57982592)
print v(xbgr.mr_n57982912)
print v(xbgr.mr_n57983024)
print v(xbgr.mr_n57983344)
print v(xbgr.mr_n57983456)
print v(xbgr.mr_n57983776)
print v(xbgr.mr_n57983888)
print v(xbgr.mr_n57984192)
print v(xbgr.mr_n57984304)
print v(xbgr.mr_n57984624)
print v(xbgr.mr_n57984736)
print v(xbgr.mr_n57985056)
print v(xbgr.mr_n57985168)
print v(xbgr.mr_n57985488)
print v(xbgr.mr_n57985600)
print v(xbgr.mr_n57985920)
print v(xbgr.mr_n57986032)
print v(xbgr.mr_n57986352)
print v(xbgr.mr_n57986464)
print v(xbgr.mr_n57986784)
print v(xbgr.mr_n57986896)
print v(xbgr.mr_n57987216)
print v(xbgr.mr_n57987328)
print v(xbgr.mr_n57987648)
print v(xbgr.mr_n57987760)
print v(xbgr.mr_n57988080)
print v(xbgr.mr_n57988192)
print v(xbgr.mr_n57988512)
print v(xbgr.mr_n57988624)
print v(xbgr.mr_n57988944)
print v(xbgr.mr_n57989056)
print v(xbgr.mr_n57989376)
print v(xbgr.mr_n57989488)
print v(xbgr.mr_n57989808)
print v(xbgr.mr_n57989920)
print v(xbgr.mr_n57990240)
print v(xbgr.mr_n57990352)
print v(xbgr.mr_n57990672)
print v(xbgr.mr_n57990784)
print v(xbgr.mr_n57991104)
print v(xbgr.mr_n57991216)
print v(xbgr.mr_n57991536)
print v(xbgr.mr_n57991648)
print v(xbgr.mr_n57991968)
print v(xbgr.mr_n57992080)
print v(xbgr.mr_n57992400)
print v(xbgr.mr_n57992512)
print v(xbgr.mr_n57992832)
print v(xbgr.mr_n57992944)
print v(xbgr.mr_n57993264)
print v(xbgr.mr_n57993376)
print v(xbgr.mr_n57993696)
print v(xbgr.mr_n57993808)
print v(xbgr.mr_n57994128)
print v(xbgr.mr_n57994240)
print v(xbgr.mr_n57994560)
print v(xbgr.mr_n57994672)
print v(xbgr.mr_n57994992)
print v(xbgr.mr_n57995104)
print v(xbgr.mr_n57995424)
print v(xbgr.mr_n57995536)
print v(xbgr.mr_n57995856)
print v(xbgr.mr_n57995968)
print v(xbgr.mr_n57996288)
print v(xbgr.mr_n57996400)
print v(xbgr.mr_n57996720)
print v(xbgr.mr_n57996832)
print v(xbgr.mr_n57997152)
print v(xbgr.mr_n57997264)
print v(xbgr.mr_n57997584)
print v(xbgr.mr_n57997696)
print v(xbgr.mr_n57998016)
print v(xbgr.mr_n57998128)
print v(xbgr.mr_n57998448)
print v(xbgr.mr_n57998560)
print v(xbgr.mr_n57998880)
print v(xbgr.mr_n57998992)
print v(xbgr.mr_n57999312)
print v(xbgr.mr_n57999424)
print v(xbgr.mr_n57999744)
print v(xbgr.mr_n57999856)
print v(xbgr.mr_n58000176)
print v(xbgr.mr_n58000288)
print v(xbgr.mr_n58000608)
print v(xbgr.mr_n58000720)
print v(xbgr.mr_n58001040)
print v(xbgr.mr_n58001152)
print v(xbgr.mr_n58001472)
print v(xbgr.mr_n58001584)
print v(xbgr.mr_n58001904)
print v(xbgr.mr_n58002016)
print v(xbgr.mr_n58002336)
print v(xbgr.mr_n58002448)
print v(xbgr.mr_n58002768)
print v(xbgr.mr_n58002880)
print v(xbgr.mr_n58003200)
print v(xbgr.mr_n58003312)
print v(xbgr.mr_n58003632)
print v(xbgr.mr_n58003744)
print v(xbgr.mr_n58004064)
print v(xbgr.mr_n58004176)
print v(xbgr.mr_n58004496)
print v(xbgr.mr_n58004608)
print v(xbgr.mr_n58004928)
print v(xbgr.mr_n58005040)
print v(xbgr.mr_n58005360)
print v(xbgr.mr_n58005472)
print v(xbgr.mr_n58005792)
print v(xbgr.mr_n58005904)
print v(xbgr.mr_n58006224)
print v(xbgr.mr_n58006336)
print v(xbgr.mr_n58006656)
print v(xbgr.mr_n58006768)
print v(xbgr.mr_n58007088)
print v(xbgr.mr_n58007200)
print v(xbgr.mr_n58007520)
print v(xbgr.mr_n58007632)
print v(xbgr.mr_n58007952)
print v(xbgr.mr_n58008064)
print v(xbgr.mr_n58008384)
print v(xbgr.mr_n58008496)
print v(xbgr.mr_n58008816)
print v(xbgr.mr_n58008928)
print v(xbgr.mr_n58009248)
print v(xbgr.mr_n58009360)
print v(xbgr.mr_n58009680)
print v(xbgr.mr_n58009792)
print v(xbgr.mr_n58010112)
print v(xbgr.mr_n58010224)
print v(xbgr.mr_n58010544)
print v(xbgr.mr_n58010656)
print v(xbgr.mr_n58010976)
print v(xbgr.mr_n58011088)
print v(xbgr.mr_n58011408)
print v(xbgr.mr_n58011520)
print v(xbgr.mr_n58011840)
print v(xbgr.mr_n58011952)
print v(xbgr.mr_n58012272)
print v(xbgr.mr_n58012384)
print v(xbgr.mr_n58012704)
print v(xbgr.mr_n58012816)
print v(xbgr.mr_n58013136)
print v(xbgr.mr_n58013248)
print v(xbgr.mr_n58013568)
print v(xbgr.mr_n58013680)
print v(xbgr.mr_n58014000)
print v(xbgr.mr_n58014112)
print v(xbgr.mr_n58014432)
print v(xbgr.mr_n58014544)
print v(xbgr.mr_n58014864)
print v(xbgr.mr_n58014976)
print v(xbgr.mr_n58015296)
print v(xbgr.mr_n58015408)
print v(xbgr.mr_n58015728)
print v(xbgr.mr_n58015840)
print v(xbgr.mr_n58016160)
print v(xbgr.mr_n58016272)
print v(xbgr.mr_n58016592)
print v(xbgr.mr_n58016704)
print v(xbgr.mr_n58017024)
print v(xbgr.mr_n58017136)
print v(xbgr.mr_n58017456)
print v(xbgr.mr_n58017568)
print v(xbgr.mr_n58017888)
print v(xbgr.mr_n58018000)
print v(xbgr.mr_n58018320)
print v(xbgr.mr_n58018432)
print v(xbgr.mr_n58018752)
print v(xbgr.mr_n58018864)
print v(xbgr.mr_n58019184)
print v(xbgr.mr_n58019296)
print v(xbgr.mr_n58019616)
print v(xbgr.mr_n58019728)
print v(xbgr.mr_n58020048)
print v(xbgr.mr_n58020160)
print v(xbgr.mr_n58020480)
print v(xbgr.mr_n58020592)
print v(xbgr.mr_n58020912)
print v(xbgr.mr_n58021024)
print v(xbgr.mr_n58021344)
print v(xbgr.mr_n58021456)
print v(xbgr.mr_n58021776)
print v(xbgr.mr_n58021888)
print v(xbgr.mr_n58022208)
print v(xbgr.mr_n58022320)
print v(xbgr.mr_n58022640)
print v(xbgr.mr_n58022752)
print v(xbgr.mr_n58023072)
print v(xbgr.mr_n58023184)
print v(xbgr.mr_n58023504)
print v(xbgr.mr_n58023616)
print v(xbgr.mr_n58023936)
print v(xbgr.mr_n58024048)
print v(xbgr.mr_n58024368)
print v(xbgr.mr_n58024480)
print v(xbgr.mr_n58024800)
print v(xbgr.mr_n58024912)
print v(xbgr.mr_n58025232)
print v(xbgr.mr_n58025344)
print v(xbgr.mr_n58025664)
print v(xbgr.mr_n58025776)
print v(xbgr.mr_n58026096)
print v(xbgr.mr_n58026208)
print v(xbgr.mr_n58026528)
print v(xbgr.mr_n58026640)
print v(xbgr.mr_n58026960)
print v(xbgr.mr_n58027072)
print v(xbgr.mr_n58027392)
print v(xbgr.mr_n58027504)
print v(xbgr.mr_n58027824)
print v(xbgr.mr_n58027936)
print v(xbgr.mr_n58028256)
print v(xbgr.mr_n58028368)
print v(xbgr.mr_n58028688)
print v(xbgr.mr_n58028800)
print v(xbgr.mr_n58029120)
print v(xbgr.mr_n58029232)
print v(xbgr.mr_n58029552)
print v(xbgr.mr_n58029664)
print v(xbgr.mr_n58029984)
print v(xbgr.mr_n58030096)
print v(xbgr.mr_n58030416)
print v(xbgr.mr_n58030528)
print v(xbgr.mr_n58030848)
print v(xbgr.mr_n58030960)
print v(xbgr.mr_n58031280)
print v(xbgr.mr_n58031392)
print v(xbgr.mr_n58031712)
print v(xbgr.mr_n58031824)
print v(xbgr.mr_n58032144)
print v(xbgr.mr_n58032352)
print v(xbgr.mr_n58032592)
print v(xbgr.mr_n58033456)
print v(xbgr.mr_n58033568)
print v(xbgr.mr_n58033888)
print v(xbgr.mr_n58034000)
print v(xbgr.mr_n58034320)
print v(xbgr.mr_n58034432)
print v(xbgr.mr_n58034752)
print v(xbgr.mr_n58034864)
print v(xbgr.mr_n58035184)
print v(xbgr.mr_n58035296)
print v(xbgr.mr_n58035616)
print v(xbgr.mr_n58035728)
print v(xbgr.mr_n58036048)
print v(xbgr.mr_n58036912)
print v(xbgr.mr_n58037776)
print v(xbgr.mr_n58038640)
print v(xbgr.mr_n58038752)
print v(xbgr.mr_n58039504)
print v(xbgr.mr_n58039616)
print v(xbgr.mr_n58039936)
print v(xbgr.mr_n58040800)
print v(xbgr.mr_n58041664)
print v(xbgr.mr_n58042528)
print v(xbgr.mr_n58043392)
print v(xbgr.mr_n58043936)
print v(xbgr.mr_n58044688)
print v(xbgr.mr_n58045232)
print v(xbgr.mr_n58045664)
print v(xbgr.mr_n58046416)
print v(xbgr.mr_n58046528)
print v(xbgr.mr_n58046848)
print v(xbgr.mr_n58046960)
print v(xbgr.mr_n58047280)
print v(xbgr.mr_n58048144)
print v(xbgr.mr_n58049008)
print v(xbgr.mr_n58049872)
print v(xbgr.mr_n58049984)
print v(xbgr.mr_n58050304)
print v(xbgr.mr_n58050416)
print v(xbgr.mr_n58050848)
print v(xbgr.mr_n58051168)
print v(xbgr.mr_n58051280)
print v(xbgr.mr_n58051600)
print v(xbgr.mr_n58052464)
print v(xbgr.mr_n58052576)
print v(xbgr.mr_n58053008)
print v(xbgr.mr_n58053328)
print v(xbgr.mr_n58053440)
print v(xbgr.mr_n58053760)
print v(xbgr.mr_n58053872)
print v(xbgr.mr_n58054192)
print v(xbgr.mr_n58054304)
print v(xbgr.mr_n58054624)
print v(xbgr.mr_n58054736)
print v(xbgr.mr_n58055056)
print v(xbgr.mr_n58056032)
print v(xbgr.mr_n58056352)
print v(xbgr.mr_n58056464)
print v(xbgr.mr_n58056784)
print v(xbgr.mr_n58056896)
print v(xbgr.mr_n58057216)
print v(xbgr.mr_n58057328)
print v(xbgr.mr_n58057648)
print v(xbgr.mr_n58057760)
print v(xbgr.mr_n58058080)
print v(xbgr.mr_n58058512)
print v(xbgr.mr_n58059488)
print v(xbgr.mr_n58059808)
print v(xbgr.mr_n58060672)
print v(xbgr.mr_n58061536)
print v(xbgr.mr_n58061648)
print v(xbgr.mr_n58062400)
print v(xbgr.mr_n58063264)
print v(xbgr.mr_n58063376)
print v(xbgr.mr_n58063696)
print v(xbgr.mr_n58064560)
print v(xbgr.mr_n58064672)
print v(xbgr.mr_n58064992)
print v(xbgr.mr_n58065104)
print v(xbgr.mr_n58065424)
print v(xbgr.mr_n58066288)
print v(xbgr.mr_n58066400)
print v(xbgr.mr_n58066720)
print v(xbgr.mr_n58066832)
print v(xbgr.mr_n58067152)
print v(xbgr.mr_n58067264)
print v(xbgr.mr_n58067584)
print v(xbgr.mr_n58067696)
print v(xbgr.mr_n58068016)
print v(xbgr.mr_n58068992)
print v(xbgr.mr_n58069424)
print v(xbgr.mr_n58069744)
print v(xbgr.mr_n58070608)
print v(xbgr.mr_n58071472)
print v(xbgr.mr_n58071584)
print v(xbgr.mr_n58071904)
print v(xbgr.mr_n58072016)
print v(xbgr.mr_n58072336)
print v(xbgr.mr_n58072448)
print v(xbgr.mr_n58072768)
print v(xbgr.mr_n58072880)
print v(xbgr.mr_n58073312)
print v(xbgr.mr_n58073744)
print v(xbgr.mr_n58074064)
print v(xbgr.mr_n58074176)
print v(xbgr.mr_n58074496)
print v(xbgr.mr_n58074608)
print v(xbgr.mr_n58074928)
print v(xbgr.mr_n58075040)
print v(xbgr.mr_n58075360)
print v(xbgr.mr_n58075472)
print v(xbgr.mr_n58075792)
print v(xbgr.mr_n58076656)
print v(xbgr.mr_n58077520)
print v(xbgr.mr_n58077632)
print v(xbgr.mr_n58077952)
print v(xbgr.mr_n58078816)
print v(xbgr.mr_n58079680)
print v(xbgr.mr_n58079792)
print v(xbgr.mr_n58080112)
print v(xbgr.mr_n58080224)
print v(xbgr.mr_n58080656)
print v(xbgr.mr_n58080976)
print v(xbgr.mr_n58081088)
print v(xbgr.mr_n58081520)
print v(xbgr.mr_n58081840)
print v(xbgr.mr_n58082272)
print v(xbgr.mr_n58082384)
print v(xbgr.mr_n58082704)
print v(xbgr.mr_n58082816)
print v(xbgr.mr_n58083136)
print v(xbgr.mr_n58083568)
print v(xbgr.mr_n58083680)
print v(xbgr.mr_n58084432)
print v(xbgr.mr_n58084544)
print v(xbgr.mr_n58084864)
print v(xbgr.mr_n58084976)
print v(xbgr.mr_n58085296)
print v(xbgr.mr_n58085728)
print v(xbgr.mr_n58085840)
print v(xbgr.mr_n58086160)
print v(xbgr.mr_n58086592)
print v(xbgr.mr_n58087456)
print v(xbgr.mr_n58089184)
print v(xbgr.mr_n58089296)
print v(xbgr.mr_n58089616)
print v(xbgr.mr_n58089728)
print v(xbgr.mr_n58090048)
print v(xbgr.mr_n58090160)
print v(xbgr.mr_n58090592)
print v(xbgr.mr_n58091024)
print v(xbgr.mr_n58091344)
print v(xbgr.mr_n58091456)
print v(xbgr.mr_n58091776)
print v(xbgr.mr_n58093184)
print v(xbgr.mr_n58093504)
print v(xbgr.mr_n58094480)
print v(xbgr.mr_n58094800)
print v(xbgr.mr_n58094912)
print v(xbgr.mr_n58095232)
print v(xbgr.mr_n58095344)
print v(xbgr.mr_n58095776)
print v(xbgr.mr_n58096096)
print v(xbgr.mr_n58096208)
print v(xbgr.mr_n58096640)
print v(xbgr.mr_n58096960)
print v(xbgr.mr_n58097072)
print v(xbgr.mr_n58097392)
print v(xbgr.mr_n58097504)
print v(xbgr.mr_n58097824)
print v(xbgr.mr_n58098688)
print v(xbgr.mr_n58099120)
print v(xbgr.mr_n58099984)
print v(xbgr.mr_n58100096)
print v(xbgr.mr_n58100416)
print v(xbgr.mr_n58100528)
print v(xbgr.mr_n58100848)
print v(xbgr.mr_n58100960)
print v(xbgr.mr_n58101712)
print v(xbgr.mr_n58102144)
print v(xbgr.mr_n58102256)
print v(xbgr.mr_n58102576)
print v(xbgr.mr_n58103008)
print v(xbgr.mr_n58103120)
print v(xbgr.mr_n58103440)
print v(xbgr.mr_n58103552)
print v(xbgr.mr_n58103872)
print v(xbgr.mr_n58103984)
print v(xbgr.mr_n58104304)
print v(xbgr.mr_n58104416)
print v(xbgr.mr_n58104736)
print v(xbgr.mr_n58104848)
print v(xbgr.mr_n58105168)
print v(xbgr.mr_n58106576)
print v(xbgr.mr_n58106896)
print v(xbgr.mr_n58107008)
print v(xbgr.mr_n58107440)
print v(xbgr.mr_n58107760)
print v(xbgr.mr_n58107872)
print v(xbgr.mr_n58108192)
print v(xbgr.mr_n58108624)
print v(xbgr.mr_n58109488)
print v(xbgr.mr_n58110352)
print v(xbgr.mr_n58111216)
print v(xbgr.mr_n58112080)
print v(xbgr.mr_n58112944)
print v(xbgr.mr_n58114240)
print v(xbgr.mr_n58114672)
print v(xbgr.mr_n58114784)
print v(xbgr.mr_n58115104)
print v(xbgr.mr_n58115536)
print v(xbgr.mr_n58115648)
print v(xbgr.mr_n58115968)
print v(xbgr.mr_n58116832)
print v(xbgr.mr_n58116944)
print v(xbgr.mr_n58117264)
print v(xbgr.mr_n58117376)
print v(xbgr.mr_n58117696)
print v(xbgr.mr_n58118560)
print v(xbgr.mr_n58118672)
print v(xbgr.mr_n58119536)
print v(xbgr.mr_n58119968)
print v(xbgr.mr_n58120400)
print v(xbgr.mr_n58121152)
print v(xbgr.mr_n58121264)
print v(xbgr.mr_n58121696)
print v(xbgr.mr_n58122448)
print v(xbgr.mr_n58122880)
print v(xbgr.mr_n58122992)
print v(xbgr.mr_n58123424)
print v(xbgr.mr_n58124176)
print v(xbgr.mr_n58124288)
print v(xbgr.mr_n58124608)
print v(xbgr.mr_n58124720)
print v(xbgr.mr_n58125040)
print v(xbgr.mr_n58125152)
print v(xbgr.mr_n58125472)
print v(xbgr.mr_n58125584)
print v(xbgr.mr_n58125904)
print v(xbgr.mr_n58126016)
print v(xbgr.mr_n58126336)
print v(xbgr.mr_n58126448)
print v(xbgr.mr_n58126768)
print v(xbgr.mr_n58126880)
print v(xbgr.mr_n58127200)
print v(xbgr.mr_n58127312)
print v(xbgr.mr_n58127632)
print v(xbgr.mr_n58127744)
print v(xbgr.mr_n58128064)
print v(xbgr.mr_n58128176)
print v(xbgr.mr_n58128496)
print v(xbgr.mr_n58128608)
print v(xbgr.mr_n58128928)
print v(xbgr.mr_n58129040)
print v(xbgr.mr_n58129360)
print v(xbgr.mr_n58129472)
print v(xbgr.mr_n58129792)
print v(xbgr.mr_n58129904)
print v(xbgr.mr_n58130336)
print v(xbgr.mr_n58130656)
print v(xbgr.mr_n58130768)
print v(xbgr.mr_n58131200)
print v(xbgr.mr_n58131520)
print v(xbgr.mr_n58131632)
print v(xbgr.mr_n58132384)
print v(xbgr.mr_n58132816)
print v(xbgr.mr_n58133680)
print v(xbgr.mr_n58134544)
print v(xbgr.mr_n58135408)
print v(xbgr.mr_n58135520)
print v(xbgr.mr_n58135840)
print v(xbgr.mr_n58135952)
print v(xbgr.mr_n58136272)
print v(xbgr.mr_n58136384)
print v(xbgr.mr_n58136704)
print v(xbgr.mr_n58136816)
print v(xbgr.mr_n58137568)
print v(xbgr.mr_n58138432)
print v(xbgr.mr_n58139296)
print v(xbgr.mr_n58140160)
print v(xbgr.mr_n58141456)
print v(xbgr.mr_n58141568)
print v(xbgr.mr_n58141888)
print v(xbgr.mr_n58142000)
print v(xbgr.mr_n58142320)
print v(xbgr.mr_n58142432)
print v(xbgr.mr_n58142864)
print v(xbgr.mr_n58143296)
print v(xbgr.mr_n58143728)
print v(xbgr.mr_n58144048)
print v(xbgr.mr_n58144160)
print v(xbgr.mr_n58144592)
print v(xbgr.mr_n58144912)
print v(xbgr.mr_n58145024)
print v(xbgr.mr_n58145344)
print v(xbgr.mr_n58145456)
print v(xbgr.mr_n58145776)
print v(xbgr.mr_n58145888)
print v(xbgr.mr_n58146208)
print v(xbgr.mr_n58146320)
print v(xbgr.mr_n58146640)
print v(xbgr.mr_n58146752)
print v(xbgr.mr_n58147184)
print v(xbgr.mr_n58147504)
print v(xbgr.mr_n58147616)
print v(xbgr.mr_n58148048)
print v(xbgr.mr_n58148368)
print v(xbgr.mr_n58148800)
print v(xbgr.mr_n58148912)
print v(xbgr.mr_n58149344)
print v(xbgr.mr_n58149664)
print v(xbgr.mr_n58149776)
print v(xbgr.mr_n58150208)
print v(xbgr.mr_n58150528)
print v(xbgr.mr_n58150640)
print v(xbgr.mr_n58151072)
print v(xbgr.mr_n58151392)
print v(xbgr.mr_n58151504)
print v(xbgr.mr_n58151824)
print v(xbgr.mr_n58151936)
print v(xbgr.mr_n58152256)
print v(xbgr.mr_n58153120)
print v(xbgr.mr_n58153984)
print v(xbgr.mr_n58154848)
print v(xbgr.mr_n58155712)
print v(xbgr.mr_n58156576)
print v(xbgr.mr_n58157440)
print v(xbgr.mr_n58157552)
print v(xbgr.mr_n58158304)
print v(xbgr.mr_n58159168)
print v(xbgr.mr_n58160032)
print v(xbgr.mr_n58160896)
print v(xbgr.mr_n58161760)
print v(xbgr.mr_n58162624)
print v(xbgr.mr_n58162736)
print v(xbgr.mr_n58163056)
print v(xbgr.mr_n58163168)
print v(xbgr.mr_n58163488)
print v(xbgr.mr_n58163600)
print v(xbgr.mr_n58163920)
print v(xbgr.mr_n58164032)
print v(xbgr.mr_n58164352)
print v(xbgr.mr_n58165216)
print v(xbgr.mr_n58166080)
print v(xbgr.mr_n58166944)
print v(xbgr.mr_n58167056)
print v(xbgr.mr_n58167376)
print v(xbgr.mr_n58167488)
print v(xbgr.mr_n58167808)
print v(xbgr.mr_n58167920)
print v(xbgr.mr_n58168240)
print v(xbgr.mr_n58169104)
print v(xbgr.mr_n58169968)
print v(xbgr.mr_n58170832)
print v(xbgr.mr_n58170944)
print v(xbgr.mr_n58171264)
print v(xbgr.mr_n58171376)
print v(xbgr.mr_n58171696)
print v(xbgr.mr_n58171808)
print v(xbgr.mr_n58172240)
print v(xbgr.mr_n58172672)
print v(xbgr.mr_n58173104)
print v(xbgr.mr_n58173424)
print v(xbgr.mr_n58173536)
print v(xbgr.mr_n58173856)
print v(xbgr.mr_n58173968)
print v(xbgr.mr_n58174288)
print v(xbgr.mr_n58174400)
print v(xbgr.mr_n58174720)
print v(xbgr.mr_n58174832)
print v(xbgr.mr_n58175152)
print v(xbgr.mr_n58175264)
print v(xbgr.mr_n58175584)
print v(xbgr.mr_n58175696)
print v(xbgr.mr_n58176016)
print v(xbgr.mr_n58176128)
print v(xbgr.mr_n58176448)
print v(xbgr.mr_n58176560)
print v(xbgr.mr_n58176880)
print v(xbgr.mr_n58176992)
print v(xbgr.mr_n58177424)
print v(xbgr.mr_n58177744)
print v(xbgr.mr_n58177856)
print v(xbgr.mr_n58178176)
print v(xbgr.mr_n58178608)
print v(xbgr.mr_n58178720)
print v(xbgr.mr_n58179040)
print v(xbgr.mr_n58179152)
print v(xbgr.mr_n58179472)
print v(xbgr.mr_n58179584)
print v(xbgr.mr_n58179904)
print v(xbgr.mr_n58180016)
print v(xbgr.mr_n58180768)
print v(xbgr.mr_n58180880)
print v(xbgr.mr_n58181632)
print v(xbgr.mr_n58182496)
print v(xbgr.mr_n58182608)
print v(xbgr.mr_n58182928)
print v(xbgr.mr_n58183040)
print v(xbgr.mr_n58183360)
print v(xbgr.mr_n58183472)
print v(xbgr.mr_n58183792)
print v(xbgr.mr_n58183904)
print v(xbgr.mr_n58184336)
print v(xbgr.mr_n58184768)
print v(xbgr.mr_n58185088)
print v(xbgr.mr_n58185200)
print v(xbgr.mr_n58185520)
print v(xbgr.mr_n58185632)
print v(xbgr.mr_n58185952)
print v(xbgr.mr_n58186816)
print v(xbgr.mr_n58188112)
print v(xbgr.mr_n58188976)
print v(xbgr.mr_n58189088)
print v(xbgr.mr_n58189408)
print v(xbgr.mr_n58189520)
print v(xbgr.mr_n58189840)
print v(xbgr.mr_n58189952)
print v(xbgr.mr_n58190272)
print v(xbgr.mr_n58190384)
print v(xbgr.mr_n58190816)
print v(xbgr.mr_n58191136)
print v(xbgr.mr_n58191248)
print v(xbgr.mr_n58191568)
print v(xbgr.mr_n58191680)
print v(xbgr.mr_n58192000)
print v(xbgr.mr_n58192112)
print v(xbgr.mr_n58192544)
print v(xbgr.mr_n58192864)
print v(xbgr.mr_n58192976)
print v(xbgr.mr_n58193296)
print v(xbgr.mr_n58193408)
print v(xbgr.mr_n58193728)
print v(xbgr.mr_n58194592)
print v(xbgr.mr_n58195456)
print v(xbgr.mr_n58196320)
print v(xbgr.mr_n58197184)
print v(xbgr.mr_n58197296)
print v(xbgr.mr_n58197616)
print v(xbgr.mr_n58197728)
print v(xbgr.mr_n58198160)
print v(xbgr.mr_n58198592)
print v(xbgr.mr_n58198912)
print v(xbgr.mr_n58199024)
print v(xbgr.mr_n58199344)
print v(xbgr.mr_n58200208)
print v(xbgr.mr_n58201072)
print v(xbgr.mr_n58201184)
print v(xbgr.mr_n58201504)
print v(xbgr.mr_n58201616)
print v(xbgr.mr_n58201936)
print v(xbgr.mr_n58202048)
print v(xbgr.mr_n58202368)
print v(xbgr.mr_n58202480)
print v(xbgr.mr_n58202800)
print v(xbgr.mr_n58202912)
print v(xbgr.mr_n58203344)
print v(xbgr.mr_n58203664)
print v(xbgr.mr_n58203776)
print v(xbgr.mr_n58204528)
print v(xbgr.mr_n58205392)
print v(xbgr.mr_n58205504)
print v(xbgr.mr_n58205824)
print v(xbgr.mr_n58205936)
print v(xbgr.mr_n58206368)
print v(xbgr.mr_n58206688)
print v(xbgr.mr_n58206800)
print v(xbgr.mr_n58207120)
print v(xbgr.mr_n58207232)
print v(xbgr.mr_n58207552)
print v(xbgr.mr_n58207664)
print v(xbgr.mr_n58207984)
print v(xbgr.mr_n58208096)
print v(xbgr.mr_n58208416)
print v(xbgr.mr_n58208528)
print v(xbgr.mr_n58208848)
print v(xbgr.mr_n58209712)
print v(xbgr.mr_n58210688)
print v(xbgr.mr_n58211008)
print v(xbgr.mr_n58211872)
print v(xbgr.mr_n58212736)
print v(xbgr.mr_n58213600)
print v(xbgr.mr_n58214032)
print v(xbgr.mr_n58214464)
print v(xbgr.mr_n58214576)
print v(xbgr.mr_n58214896)
print v(xbgr.mr_n58215008)
print v(xbgr.mr_n58215328)
print v(xbgr.mr_n58215440)
print v(xbgr.mr_n58215760)
print v(xbgr.mr_n58215872)
print v(xbgr.mr_n58216192)
print v(xbgr.mr_n58216304)
print v(xbgr.mr_n58216624)
print v(xbgr.mr_n58216736)
print v(xbgr.mr_n58217056)
print v(xbgr.mr_n58217920)
print v(xbgr.mr_n58218784)
print v(xbgr.mr_n58218896)
print v(xbgr.mr_n58219216)
print v(xbgr.mr_n58219328)
print v(xbgr.mr_n58219648)
print v(xbgr.mr_n58219760)
print v(xbgr.mr_n58220080)
print v(xbgr.mr_n58220192)
print v(xbgr.mr_n58221808)
print v(xbgr.mr_n58222672)
print v(xbgr.mr_n58222784)
print v(xbgr.mr_n58223104)
print v(xbgr.mr_n58223216)
print v(xbgr.mr_n58223536)
print v(xbgr.mr_n58223968)
print v(xbgr.mr_n58224080)
print v(xbgr.mr_n58224400)
print v(xbgr.mr_n58224512)
print v(xbgr.mr_n58224832)
print v(xbgr.mr_n58224944)
print v(xbgr.mr_n58225376)
print v(xbgr.mr_n58225696)
print v(xbgr.mr_n58225808)
print v(xbgr.mr_n58226240)
print v(xbgr.mr_n58226992)
print v(xbgr.mr_n58227856)
print v(xbgr.mr_n58229152)
print v(xbgr.mr_n58229264)
print v(xbgr.mr_n58229696)
print v(xbgr.mr_n58230016)
print v(xbgr.mr_n58230880)
print v(xbgr.mr_n58231744)
print v(xbgr.mr_n58232176)
print v(xbgr.mr_n58233472)
print v(xbgr.mr_n58234336)
print v(xbgr.mr_n58234768)
print v(xbgr.mr_n58235632)
print v(xbgr.mr_n58236928)
print v(xbgr.mr_n58237040)
print v(xbgr.mr_n58237360)
print v(xbgr.mr_n58237472)
print v(xbgr.mr_n58237792)
print v(xbgr.mr_n58237904)
print v(xbgr.mr_n58238224)
print v(xbgr.mr_n58238336)
print v(xbgr.mr_n58238656)
print v(xbgr.mr_n58238768)
print v(xbgr.mr_n58239088)
print v(xbgr.mr_n58239200)
print v(xbgr.mr_n58239520)
print v(xbgr.mr_n58239632)
print v(xbgr.mr_n58240384)
print v(xbgr.mr_n58240496)
print v(xbgr.mr_n58240928)
print v(xbgr.mr_n58241248)
print v(xbgr.mr_n58241360)
print v(xbgr.mr_n58241680)
print v(xbgr.mr_n58241792)
print v(xbgr.mr_n58242112)
print v(xbgr.mr_n58242224)
print v(xbgr.mr_n58242544)
print v(xbgr.mr_n58242656)
print v(xbgr.mr_n58242976)
print v(xbgr.mr_n58243088)
print v(xbgr.mr_n58243520)
print v(xbgr.mr_n58243840)
print v(xbgr.mr_n58244384)
print v(xbgr.mr_n58244704)
print v(xbgr.mr_n58244816)
print v(xbgr.mr_n58245248)
print v(xbgr.mr_n58245568)
print v(xbgr.mr_n58245680)
print v(xbgr.mr_n58246112)
print v(xbgr.mr_n58246432)
print v(xbgr.mr_n58246544)
print v(xbgr.mr_n58246864)
print v(xbgr.mr_n58246976)
print v(xbgr.mr_n58247296)
print v(xbgr.mr_n58247408)
print v(xbgr.mr_n58247728)
print v(xbgr.mr_n58247840)
print v(xbgr.mr_n58248160)
print v(xbgr.mr_n58248272)
print v(xbgr.mr_n58248592)
print v(xbgr.mr_n58248704)
print v(xbgr.mr_n58249024)
print v(xbgr.mr_n58249136)
print v(xbgr.mr_n58249456)
print v(xbgr.mr_n58249568)
print v(xbgr.mr_n58249888)
print v(xbgr.mr_n58250752)
print v(xbgr.mr_n58250864)
print v(xbgr.mr_n58251184)
print v(xbgr.mr_n58251296)
print v(xbgr.mr_n58251616)
print v(xbgr.mr_n58251728)
print v(xbgr.mr_n58252048)
print v(xbgr.mr_n58252160)
print v(xbgr.mr_n58252480)
print v(xbgr.mr_n58253344)
print v(xbgr.mr_n58254208)
print v(xbgr.mr_n58255072)
print v(xbgr.mr_n58255616)
print v(xbgr.mr_n58256048)
print v(xbgr.mr_n58256368)
print v(xbgr.mr_n58256480)
print v(xbgr.mr_n58256800)
print v(xbgr.mr_n58256912)
print v(xbgr.mr_n58257232)
print v(xbgr.mr_n58257344)
print v(xbgr.mr_n58257664)
print v(xbgr.mr_n58257776)
print v(xbgr.mr_n58258096)
print v(xbgr.mr_n58259392)
print v(xbgr.mr_n58260256)
print v(xbgr.mr_n58261232)
print v(xbgr.mr_n58261664)
print v(xbgr.mr_n58261984)
print v(xbgr.mr_n58262416)
print v(xbgr.mr_n58263280)
print v(xbgr.mr_n58264144)
print v(xbgr.mr_n58264256)
print v(xbgr.mr_n58264576)
print v(xbgr.mr_n58264688)
print v(xbgr.mr_n58265008)
print v(xbgr.mr_n58265120)
print v(xbgr.mr_n58265440)
print v(xbgr.mr_n58265552)
print v(xbgr.mr_n58266736)
print v(xbgr.mr_n58266848)
print v(xbgr.mr_n58267168)
print v(xbgr.mr_n58267280)
print v(xbgr.mr_n58267600)
print v(xbgr.mr_n58267712)
print v(xbgr.mr_n58268144)
print v(xbgr.mr_n58268464)
print v(xbgr.mr_n58268896)
print v(xbgr.mr_n58269008)
print v(xbgr.mr_n58269440)
print v(xbgr.mr_n58269760)
print v(xbgr.mr_n58270624)
print v(xbgr.mr_n58270736)
print v(xbgr.mr_n58271168)
print v(xbgr.mr_n58271488)
print v(xbgr.mr_n58271600)
print v(xbgr.mr_n58272352)
print v(xbgr.mr_n58272896)
print v(xbgr.mr_n58273216)
print v(xbgr.mr_n58273328)
print v(xbgr.mr_n58273648)
print v(xbgr.mr_n58273760)
print v(xbgr.mr_n58274080)
print v(xbgr.mr_n58274192)
print v(xbgr.mr_n58274512)
print v(xbgr.mr_n58274944)
print v(xbgr.mr_n58275056)
print v(xbgr.mr_n58275376)
print v(xbgr.mr_n58275488)
print v(xbgr.mr_n58275808)
print v(xbgr.mr_n58275920)
print v(xbgr.mr_n58276672)
print v(xbgr.mr_n58276784)
print v(xbgr.mr_n58277216)
print v(xbgr.mr_n58277536)
print v(xbgr.mr_n58277648)
print v(xbgr.mr_n58277968)
print v(xbgr.mr_n58278080)
print v(xbgr.mr_n58278400)
print v(xbgr.mr_n58278512)
print v(xbgr.mr_n58278832)
print v(xbgr.mr_n58279696)
print v(xbgr.mr_n58280128)
print v(xbgr.mr_n58280560)
print v(xbgr.mr_n58280672)
print v(xbgr.mr_n58280992)
print v(xbgr.mr_n58281104)
print v(xbgr.mr_n58281856)
print v(xbgr.mr_n58281968)
print v(xbgr.mr_n58282288)
print v(xbgr.mr_n58282400)
print v(xbgr.mr_n58283152)
print v(xbgr.mr_n58284016)
print v(xbgr.mr_n58284128)
print v(xbgr.mr_n58284448)
print v(xbgr.mr_n58285312)
print v(xbgr.mr_n58285424)
print v(xbgr.mr_n58285744)
print v(xbgr.mr_n58285856)
print v(xbgr.mr_n58286176)
print v(xbgr.mr_n58286288)
print v(xbgr.mr_n58286608)
print v(xbgr.mr_n58286720)
print v(xbgr.mr_n58287040)
print v(xbgr.mr_n58287152)
print v(xbgr.mr_n58287472)
print v(xbgr.mr_n58287584)
print v(xbgr.mr_n58287904)
print v(xbgr.mr_n58288016)
print v(xbgr.mr_n58288448)
print v(xbgr.mr_n58288880)
print v(xbgr.mr_n58289200)
print v(xbgr.mr_n58289632)
print v(xbgr.mr_n58289744)
print v(xbgr.mr_n58290928)
print v(xbgr.mr_n58292656)
print v(xbgr.mr_n58292768)
print v(xbgr.mr_n58293200)
print v(xbgr.mr_n58293520)
print v(xbgr.mr_n58293632)
print v(xbgr.mr_n58293952)
print v(xbgr.mr_n58294064)
print v(xbgr.mr_n58294496)
print v(xbgr.mr_n58294816)
print v(xbgr.mr_n58294928)
print v(xbgr.mr_n58295248)
print v(xbgr.mr_n58295680)
print v(xbgr.mr_n58295792)
print v(xbgr.mr_n58296544)
print v(xbgr.mr_n58296656)
print v(xbgr.mr_n58296976)
print v(xbgr.mr_n58297088)
print v(xbgr.mr_n58297408)
print v(xbgr.mr_n58297520)
print v(xbgr.mr_n58297840)
print v(xbgr.mr_n58297952)
print v(xbgr.mr_n58298272)
print v(xbgr.mr_n58298384)
print v(xbgr.mr_n58298704)
print v(xbgr.mr_n58299568)
print v(xbgr.mr_n58300432)
print v(xbgr.mr_n58301296)
print v(xbgr.mr_n58301408)
print v(xbgr.mr_n58301728)
print v(xbgr.mr_n58302160)
print v(xbgr.mr_n58302272)
print v(xbgr.mr_n58302592)
print v(xbgr.mr_n58302704)
print v(xbgr.mr_n58303024)
print v(xbgr.mr_n58303136)
print v(xbgr.mr_n58303456)
print v(xbgr.mr_n58304320)
print v(xbgr.mr_n58305296)
print v(xbgr.mr_n58305616)
print v(xbgr.mr_n58305728)
print v(xbgr.mr_n58306048)
print v(xbgr.mr_n58306160)
print v(xbgr.mr_n58306480)
print v(xbgr.mr_n58306592)
print v(xbgr.mr_n58306912)
print v(xbgr.mr_n58307024)
print v(xbgr.mr_n58307344)
print v(xbgr.mr_n58307888)
print v(xbgr.mr_n58308320)
print v(xbgr.mr_n58308752)
print v(xbgr.mr_n58309936)
print v(xbgr.mr_n58310048)
print v(xbgr.mr_n58310368)
print v(xbgr.mr_n58310480)
print v(xbgr.mr_n58310800)
print v(xbgr.mr_n58311664)
print v(xbgr.mr_n58311776)
print v(xbgr.mr_n58312096)
print v(xbgr.mr_n58312208)
print v(xbgr.mr_n58312528)
print v(xbgr.mr_n58312960)
print v(xbgr.mr_n58313824)
print v(xbgr.mr_n58315120)
print v(xbgr.mr_n58315232)
print v(xbgr.mr_n58315552)
print v(xbgr.mr_n58315664)
print v(xbgr.mr_n58315984)
print v(xbgr.mr_n58316416)
print v(xbgr.mr_n58317280)
print v(xbgr.mr_n58317712)
print v(xbgr.mr_n58317824)
print v(xbgr.mr_n58318144)
print v(xbgr.mr_n58318256)
print v(xbgr.mr_n58318576)
print v(xbgr.mr_n58318688)
print v(xbgr.mr_n58319008)
print v(xbgr.mr_n58319120)
print v(xbgr.mr_n58319872)
print v(xbgr.mr_n58319984)
print v(xbgr.mr_n58320736)
print v(xbgr.mr_n58321712)
print v(xbgr.mr_n58322032)
print v(xbgr.mr_n58322144)
print v(xbgr.mr_n58322464)
print v(xbgr.mr_n58322576)
print v(xbgr.mr_n58322896)
print v(xbgr.mr_n58323328)
print v(xbgr.mr_n58324192)
print v(xbgr.mr_n58324304)
print v(xbgr.mr_n58324624)
print v(xbgr.mr_n58324736)
print v(xbgr.mr_n58325056)
print v(xbgr.mr_n58325168)
print v(xbgr.mr_n58325488)
print v(xbgr.mr_n58325600)
print v(xbgr.mr_n58325920)
print v(xbgr.mr_n58326032)
print v(xbgr.mr_n58326464)
print v(xbgr.mr_n58327216)
print v(xbgr.mr_n58328192)
print v(xbgr.mr_n58328624)
print v(xbgr.mr_n58328944)
print v(xbgr.mr_n58329376)
print v(xbgr.mr_n58330352)
print v(xbgr.mr_n58330784)
print v(xbgr.mr_n58331104)
print v(xbgr.mr_n58331536)
print v(xbgr.mr_n58331648)
print v(xbgr.mr_n58331968)
print v(xbgr.mr_n58332080)
print v(xbgr.mr_n58332400)
print v(xbgr.mr_n58332512)
print v(xbgr.mr_n58332832)
print v(xbgr.mr_n58332944)
print v(xbgr.mr_n58333696)
print v(xbgr.mr_n58334560)
print v(xbgr.mr_n58335856)
print v(xbgr.mr_n58335968)
print v(xbgr.mr_n58336288)
print v(xbgr.mr_n58336400)
print v(xbgr.mr_n58336720)
print v(xbgr.mr_n58336832)
print v(xbgr.mr_n58337152)
print v(xbgr.mr_n58337264)
print v(xbgr.mr_n58337584)
print v(xbgr.mr_n58337696)
print v(xbgr.mr_n58338016)
print v(xbgr.mr_n58338448)
print v(xbgr.mr_n58338560)
print v(xbgr.mr_n58338880)
print v(xbgr.mr_n58338992)
print v(xbgr.mr_n58339312)
print v(xbgr.mr_n58339424)
print v(xbgr.mr_n58339744)
print v(xbgr.mr_n58339856)
print v(xbgr.mr_n58340176)
print v(xbgr.mr_n58340288)
print v(xbgr.mr_n58340608)
print v(xbgr.mr_n58340720)
print v(xbgr.mr_n58341040)
print v(xbgr.mr_n58341152)
print v(xbgr.mr_n58341472)
print v(xbgr.mr_n58341584)
print v(xbgr.mr_n58341904)
print v(xbgr.mr_n58342016)
print v(xbgr.mr_n58342448)
print v(xbgr.mr_n58342768)
print v(xbgr.mr_n58342880)
print v(xbgr.mr_n58343312)
print v(xbgr.mr_n58343744)
print v(xbgr.mr_n58344064)
print v(xbgr.mr_n58344176)
print v(xbgr.mr_n58344496)
print v(xbgr.mr_n58344608)
print v(xbgr.mr_n58344928)
print v(xbgr.mr_n58345040)
print v(xbgr.mr_n58345360)
print v(xbgr.mr_n58345472)
print v(xbgr.mr_n58346224)
print v(xbgr.mr_n58346336)
print v(xbgr.mr_n58346768)
print v(xbgr.mr_n58347088)
print v(xbgr.mr_n58347632)
print v(xbgr.mr_n58347952)
print v(xbgr.mr_n58348816)
print v(xbgr.mr_n58348928)
print v(xbgr.mr_n58349248)
print v(xbgr.mr_n58349680)
print v(xbgr.mr_n58350112)
print v(xbgr.mr_n58350544)
print v(xbgr.mr_n58350656)
print v(xbgr.mr_n58351408)
print v(xbgr.mr_n58351520)
print v(xbgr.mr_n58351840)
print v(xbgr.mr_n58351952)
print v(xbgr.mr_n58352272)
print v(xbgr.mr_n58352704)
print v(xbgr.mr_n58352816)
print v(xbgr.mr_n58353136)
print v(xbgr.mr_n58353248)
print v(xbgr.mr_n58353568)
print v(xbgr.mr_n58353680)
print v(xbgr.mr_n58354000)
print v(xbgr.mr_n58354432)
print v(xbgr.mr_n58355296)
print v(xbgr.mr_n58356160)
print v(xbgr.mr_n58357456)
print v(xbgr.mr_n58358320)
print v(xbgr.mr_n58359184)
print v(xbgr.mr_n58360048)
print v(xbgr.mr_n58360160)
print v(xbgr.mr_n58360480)
print v(xbgr.mr_n58361344)
print v(xbgr.mr_n58362208)
print v(xbgr.mr_n58363072)
print v(xbgr.mr_n58363184)
print v(xbgr.mr_n58363504)
print v(xbgr.mr_n58363616)
print v(xbgr.mr_n58363936)
print v(xbgr.mr_n58364048)
print v(xbgr.mr_n58364368)
print v(xbgr.mr_n58364480)
print v(xbgr.mr_n58364800)
print v(xbgr.mr_n58364912)
print v(xbgr.mr_n58365232)
print v(xbgr.mr_n58365344)
print v(xbgr.mr_n58366960)
print v(xbgr.mr_n58367936)
print v(xbgr.mr_n58368368)
print v(xbgr.mr_n58368800)
print v(xbgr.mr_n58369120)
print v(xbgr.mr_n58369232)
print v(xbgr.mr_n58369552)
print v(xbgr.mr_n58369664)
print v(xbgr.mr_n58369984)
print v(xbgr.mr_n58370096)
print v(xbgr.mr_n58370416)
print v(xbgr.mr_n58370528)
print v(xbgr.mr_n58370848)
print v(xbgr.mr_n58370960)
print v(xbgr.mr_n58371280)
print v(xbgr.mr_n58371392)
print v(xbgr.mr_n58371712)
print v(xbgr.mr_n58371824)
print v(xbgr.mr_n58372256)
print v(xbgr.mr_n58372576)
print v(xbgr.mr_n58372688)
print v(xbgr.mr_n58373120)
print v(xbgr.mr_n58373552)
print v(xbgr.mr_n58374736)
print v(xbgr.mr_n58374848)
print v(xbgr.mr_n58375168)
print v(xbgr.mr_n58375280)
print v(xbgr.mr_n58375600)
print v(xbgr.mr_n58375712)
print v(xbgr.mr_n58376032)
print v(xbgr.mr_n58376144)
print v(xbgr.mr_n58376464)
print v(xbgr.mr_n58376576)
print v(xbgr.mr_n58376896)
print v(xbgr.mr_n58377328)
print v(xbgr.mr_n58377440)
print v(xbgr.mr_n58377760)
print v(xbgr.mr_n58377872)
print v(xbgr.mr_n58378192)
print v(xbgr.mr_n58378304)
print v(xbgr.mr_n58378624)
print v(xbgr.mr_n58378736)
print v(xbgr.mr_n58379168)
print v(xbgr.mr_n58379488)
print v(xbgr.mr_n58379920)
print v(xbgr.mr_n58380784)
print v(xbgr.mr_n58380896)
print v(xbgr.mr_n58381216)
print v(xbgr.mr_n58381648)
print v(xbgr.mr_n58382080)
print v(xbgr.mr_n58382624)
print v(xbgr.mr_n58382944)
print v(xbgr.mr_n58383808)
print v(xbgr.mr_n58383920)
print v(xbgr.mr_n58384240)
print v(xbgr.mr_n58384352)
print v(xbgr.mr_n58384784)
print v(xbgr.mr_n58385536)
print v(xbgr.mr_n58385968)
print v(xbgr.mr_n58386400)
print v(xbgr.mr_n58386832)
print v(xbgr.mr_n58386944)
print v(xbgr.mr_n58388128)
print v(xbgr.mr_n58388992)
print v(xbgr.mr_n58389968)
print v(xbgr.mr_n58390288)
print v(xbgr.mr_n58390400)
print v(xbgr.mr_n58390832)
print v(xbgr.mr_n58391152)
print v(xbgr.mr_n58391264)
print v(xbgr.mr_n58391584)
print v(xbgr.mr_n58391696)
print v(xbgr.mr_n58392016)
print v(xbgr.mr_n58392128)
print v(xbgr.mr_n58392448)
print v(xbgr.mr_n58392560)
print v(xbgr.mr_n58392880)
print v(xbgr.mr_n58392992)
print v(xbgr.mr_n58393312)
print v(xbgr.mr_n58393424)
print v(xbgr.mr_n58393856)
print v(xbgr.mr_n58394288)
print v(xbgr.mr_n58394720)
print v(xbgr.mr_n58395472)
print v(xbgr.mr_n58395904)
print v(xbgr.mr_n58396768)
print v(xbgr.mr_n58397632)
print v(xbgr.mr_n58399360)
print v(xbgr.mr_n58400224)
print v(xbgr.mr_n58400336)
print v(xbgr.mr_n58401088)
print v(xbgr.mr_n58401200)
print v(xbgr.mr_n58401520)
print v(xbgr.mr_n58401632)
print v(xbgr.mr_n58401952)
print v(xbgr.mr_n58402064)
print v(xbgr.mr_n58404112)
print v(xbgr.mr_n58404224)
print v(xbgr.mr_n58404544)
print v(xbgr.mr_n58404656)
print v(xbgr.mr_n58404976)
print v(xbgr.mr_n58405088)
print v(xbgr.mr_n58405408)
print v(xbgr.mr_n58405520)
print v(xbgr.mr_n58405840)
print v(xbgr.mr_n58405952)
print v(xbgr.mr_n58406272)
print v(xbgr.mr_n58406384)
print v(xbgr.mr_n58406704)
print v(xbgr.mr_n58406816)
print v(xbgr.mr_n58407248)
print v(xbgr.mr_n58407568)
print v(xbgr.mr_n58407680)
print v(xbgr.mr_n58408112)
print v(xbgr.mr_n58408432)
print v(xbgr.mr_n58408544)
print v(xbgr.mr_n58408976)
print v(xbgr.mr_n58409296)
print v(xbgr.mr_n58409408)
print v(xbgr.mr_n58409728)
print v(xbgr.mr_n58409840)
print v(xbgr.mr_n58410160)
print v(xbgr.mr_n58410272)
print v(xbgr.mr_n58410592)
print v(xbgr.mr_n58410704)
print v(xbgr.mr_n58411024)
print v(xbgr.mr_n58411136)
print v(xbgr.mr_n58411456)
print v(xbgr.mr_n58411568)
print v(xbgr.mr_n58411888)
print v(xbgr.mr_n58412000)
print v(xbgr.mr_n58412320)
print v(xbgr.mr_n58412432)
print v(xbgr.mr_n58412752)
print v(xbgr.mr_n58412864)
print v(xbgr.mr_n58413184)
print v(xbgr.mr_n58413296)
print v(xbgr.mr_n58413616)
print v(xbgr.mr_n58413728)
print v(xbgr.mr_n58414048)
print v(xbgr.mr_n58414160)
print v(xbgr.mr_n58414480)
print v(xbgr.mr_n58414592)
print v(xbgr.mr_n58414912)
print v(xbgr.mr_n58415024)
print v(xbgr.mr_n58415344)
print v(xbgr.mr_n58415456)
print v(xbgr.mr_n58415776)
print v(xbgr.mr_n58415888)
print v(xbgr.mr_n58416208)
print v(xbgr.mr_n58416320)
print v(xbgr.mr_n58416640)
print v(xbgr.mr_n58416752)
print v(xbgr.mr_n58417184)
print v(xbgr.mr_n58417504)
print v(xbgr.mr_n58417616)
print v(xbgr.mr_n58418048)
print v(xbgr.mr_n58418368)
print v(xbgr.mr_n58418480)
print v(xbgr.mr_n58418912)
print v(xbgr.mr_n58419232)
print v(xbgr.mr_n58420096)
print v(xbgr.mr_n58420960)
print v(xbgr.mr_n58421824)
print v(xbgr.mr_n58422688)
print v(xbgr.mr_n58423552)
print v(xbgr.mr_n58424416)
print v(xbgr.mr_n58424528)
print v(xbgr.mr_n58424848)
print v(xbgr.mr_n58424960)
print v(xbgr.mr_n58425280)
print v(xbgr.mr_n58425392)
print v(xbgr.mr_n58425712)
print v(xbgr.mr_n58425824)
print v(xbgr.mr_n58426144)
print v(xbgr.mr_n58426256)
print v(xbgr.mr_n58426576)
print v(xbgr.mr_n58426688)
print v(xbgr.mr_n58427008)
print v(xbgr.mr_n58427872)
print v(xbgr.mr_n58428736)
print v(xbgr.mr_n58429600)
print v(xbgr.mr_n58429712)
print v(xbgr.mr_n58430032)
print v(xbgr.mr_n58430144)
print v(xbgr.mr_n58430464)
print v(xbgr.mr_n58430576)
print v(xbgr.mr_n58431008)
print v(xbgr.mr_n58431440)
print v(xbgr.mr_n58431872)
print v(xbgr.mr_n58432192)
print v(xbgr.mr_n58432304)
print v(xbgr.mr_n58432736)
print v(xbgr.mr_n58433056)
print v(xbgr.mr_n58433168)
print v(xbgr.mr_n58433488)
print v(xbgr.mr_n58433600)
print v(xbgr.mr_n58433920)
print v(xbgr.mr_n58434032)
print v(xbgr.mr_n58434352)
print v(xbgr.mr_n58434464)
print v(xbgr.mr_n58434784)
print v(xbgr.mr_n58434896)
print v(xbgr.mr_n58435216)
print v(xbgr.mr_n58435328)
print v(xbgr.mr_n58435760)
print v(xbgr.mr_n58436192)
print v(xbgr.mr_n58436512)
print v(xbgr.mr_n58436624)
print v(xbgr.mr_n58437056)
print v(xbgr.mr_n58437376)
print v(xbgr.mr_n58437488)
print v(xbgr.mr_n58437920)
print v(xbgr.mr_n58438240)
print v(xbgr.mr_n58438352)
print v(xbgr.mr_n58438784)
print v(xbgr.mr_n58439104)
print v(xbgr.mr_n58439968)
print v(xbgr.mr_n58440832)
print v(xbgr.mr_n58441696)
print v(xbgr.mr_n58442560)
print v(xbgr.mr_n58443424)
print v(xbgr.mr_n58443536)
print v(xbgr.mr_n58443856)
print v(xbgr.mr_n58443968)
print v(xbgr.mr_n58444288)
print v(xbgr.mr_n58444400)
print v(xbgr.mr_n58444720)
print v(xbgr.mr_n58444832)
print v(xbgr.mr_n58445152)
print v(xbgr.mr_n58446016)
print v(xbgr.mr_n58446880)
print v(xbgr.mr_n58447744)
print v(xbgr.mr_n58447856)
print v(xbgr.mr_n58448176)
print v(xbgr.mr_n58448288)
print v(xbgr.mr_n58448608)
print v(xbgr.mr_n58448720)
print v(xbgr.mr_n58449040)
print v(xbgr.mr_n58449152)
print v(xbgr.mr_n58449472)
print v(xbgr.mr_n58449584)
print v(xbgr.mr_n58449904)
print v(xbgr.mr_n58450016)
print v(xbgr.mr_n58450336)
print v(xbgr.mr_n58451200)
print v(xbgr.mr_n58452064)
print v(xbgr.mr_n58452928)
print v(xbgr.mr_n58453792)
print v(xbgr.mr_n58454656)
print v(xbgr.mr_n58455520)
print v(xbgr.mr_n58456384)
print v(xbgr.mr_n58457248)
print v(xbgr.mr_n58458112)
print v(xbgr.mr_n58458224)
print v(xbgr.mr_n58458544)
print v(xbgr.mr_n58458656)
print v(xbgr.mr_n58458976)
print v(xbgr.mr_n58459088)
print v(xbgr.mr_n58459408)
print v(xbgr.mr_n58459520)
print v(xbgr.mr_n58459840)
print v(xbgr.mr_n58459952)
print v(xbgr.mr_n58460272)
print v(xbgr.mr_n58460384)
print v(xbgr.mr_n58460704)
print v(xbgr.mr_n58460816)
print v(xbgr.mr_n58461136)
print v(xbgr.mr_n58461248)
print v(xbgr.mr_n58461568)
print v(xbgr.mr_n58461680)
print v(xbgr.mr_n58462000)
print v(xbgr.mr_n58462112)
print v(xbgr.mr_n58462432)
print v(xbgr.mr_n58463296)
print v(xbgr.mr_n58463408)
print v(xbgr.mr_n58463728)
print v(xbgr.mr_n58463840)
print v(xbgr.mr_n58464160)
print v(xbgr.mr_n58464272)
print v(xbgr.mr_n58464592)
print v(xbgr.mr_n58464704)
print v(xbgr.mr_n58465024)
print v(xbgr.mr_n58465136)
print v(xbgr.mr_n58465456)
print v(xbgr.mr_n58465568)
print v(xbgr.mr_n58465888)
print v(xbgr.mr_n58466000)
print v(xbgr.mr_n58466320)
print v(xbgr.mr_n58466432)
print v(xbgr.mr_n58466752)
print v(xbgr.mr_n58466864)
print v(xbgr.mr_n58467184)
print v(xbgr.mr_n58467296)
print v(xbgr.mr_n58467616)
print v(xbgr.mr_n58467728)
print v(xbgr.mr_n58468160)
print v(xbgr.mr_n58468480)
print v(xbgr.mr_n58468592)
print v(xbgr.mr_n58469024)
print v(xbgr.mr_n58469344)
print v(xbgr.mr_n58469456)
print v(xbgr.mr_n58469888)
print v(xbgr.mr_n58470208)
print v(xbgr.mr_n58470320)
print v(xbgr.mr_n58470752)
print v(xbgr.mr_n58471072)
print v(xbgr.mr_n58471184)
print v(xbgr.mr_n58471504)
print v(xbgr.mr_n58471616)
print v(xbgr.mr_n58472048)
print v(xbgr.mr_n58472480)
print v(xbgr.mr_n58472800)
print v(xbgr.mr_n58472912)
print v(xbgr.mr_n58473232)
print v(xbgr.mr_n58473344)
print v(xbgr.mr_n58473664)
print v(xbgr.mr_n58473776)
print v(xbgr.mr_n58474096)
print v(xbgr.mr_n58474208)
print v(xbgr.mr_n58474528)
print v(xbgr.mr_n58474640)
print v(xbgr.mr_n58475072)
print v(xbgr.mr_n58475392)
print v(xbgr.mr_n58475504)
print v(xbgr.mr_n58475936)
print v(xbgr.mr_n58476256)
print v(xbgr.mr_n58477120)
print v(xbgr.mr_n58477984)
print v(xbgr.mr_n58478848)
print v(xbgr.mr_n58479712)
print v(xbgr.mr_n58479824)
print v(xbgr.mr_n58480144)
print v(xbgr.mr_n58480256)
print v(xbgr.mr_n58480576)
print v(xbgr.mr_n58480688)
print v(xbgr.mr_n58481008)
print v(xbgr.mr_n58481120)
print v(xbgr.mr_n58481440)
print v(xbgr.mr_n58482304)
print v(xbgr.mr_n58483168)
print v(xbgr.mr_n58483280)
print v(xbgr.mr_n58483600)
print v(xbgr.mr_n58483712)
print v(xbgr.mr_n58484144)
print v(xbgr.mr_n58484576)
print v(xbgr.mr_n58484896)
print v(xbgr.mr_n58485008)
print v(xbgr.mr_n58485328)
print v(xbgr.mr_n58485440)
print v(xbgr.mr_n58485760)
print v(xbgr.mr_n58485872)
print v(xbgr.mr_n58486192)
print v(xbgr.mr_n58486304)
print v(xbgr.mr_n58486624)
print v(xbgr.mr_n58486736)
print v(xbgr.mr_n58487168)
print v(xbgr.mr_n58487488)
print v(xbgr.mr_n58487600)
print v(xbgr.mr_n58488032)
print v(xbgr.mr_n58488352)
print v(xbgr.mr_n58488464)
print v(xbgr.mr_n58488784)
print v(xbgr.mr_n58488896)
print v(xbgr.mr_n58489216)
print v(xbgr.mr_n58489328)
print v(xbgr.mr_n58489648)
print v(xbgr.mr_n58489760)
print v(xbgr.mr_n58490080)
print v(xbgr.mr_n58490192)
print v(xbgr.mr_n58490512)
print v(xbgr.mr_n58490624)
print v(xbgr.mr_n58490944)
print v(xbgr.mr_n58491056)
print v(xbgr.mr_n58491376)
print v(xbgr.mr_n58491488)
print v(xbgr.mr_n58491808)
print v(xbgr.mr_n58491920)
print v(xbgr.mr_n58492240)
print v(xbgr.mr_n58492352)
print v(xbgr.mr_n58492672)
print v(xbgr.mr_n58493536)
print v(xbgr.mr_n58494400)
print v(xbgr.mr_n58495264)
print v(xbgr.mr_n58496128)
print v(xbgr.mr_n58496240)
print v(xbgr.mr_n58496560)
print v(xbgr.mr_n58496672)
print v(xbgr.mr_n58496992)
print v(xbgr.mr_n58497104)
print v(xbgr.mr_n58497424)
print v(xbgr.mr_n58497536)
print v(xbgr.mr_n58497968)
print v(xbgr.mr_n58498400)
print v(xbgr.mr_n58498832)
print v(xbgr.mr_n58499264)
print v(xbgr.mr_n58499584)
print v(xbgr.mr_n58499696)
print v(xbgr.mr_n58500016)
print v(xbgr.mr_n58500128)
print v(xbgr.mr_n58500448)
print v(xbgr.mr_n58500560)
print v(xbgr.mr_n58500880)
print v(xbgr.mr_n58500992)
print v(xbgr.mr_n58501312)
print v(xbgr.mr_n58502176)
print v(xbgr.mr_n58503040)
print v(xbgr.mr_n58503152)
print v(xbgr.mr_n58503584)
print v(xbgr.mr_n58503904)
print v(xbgr.mr_n58504768)
print v(xbgr.mr_n58504880)
print v(xbgr.mr_n58505200)
print v(xbgr.mr_n58505312)
print v(xbgr.mr_n58505632)
print v(xbgr.mr_n58505744)
print v(xbgr.mr_n58506064)
print v(xbgr.mr_n58506176)
print v(xbgr.mr_n58506496)
print v(xbgr.mr_n58507360)
print v(xbgr.mr_n58507472)
print v(xbgr.mr_n58507904)
print v(xbgr.mr_n58508224)
print v(xbgr.mr_n58508336)
print v(xbgr.mr_n58508656)
print v(xbgr.mr_n58508768)
print v(xbgr.mr_n58509088)
print v(xbgr.mr_n58509200)
print v(xbgr.mr_n58509520)
print v(xbgr.mr_n58509632)
print v(xbgr.mr_n58509952)
print v(xbgr.mr_n58510816)
print v(xbgr.mr_n58511248)
print v(xbgr.mr_n58511360)
print v(xbgr.mr_n58511680)
print v(xbgr.mr_n58511792)
print v(xbgr.mr_n58512112)
print v(xbgr.mr_n58512544)
print v(xbgr.mr_n58513408)
print v(xbgr.mr_n58514272)
print v(xbgr.mr_n58514384)
print v(xbgr.mr_n58515136)
print v(xbgr.mr_n58515248)
print v(xbgr.mr_n58515568)
print v(xbgr.mr_n58515680)
print v(xbgr.mr_n58516000)
print v(xbgr.mr_n58516864)
print v(xbgr.mr_n58517728)
print v(xbgr.mr_n58517840)
print v(xbgr.mr_n58518160)
print v(xbgr.mr_n58518272)
print v(xbgr.mr_n58518592)
print v(xbgr.mr_n58519456)
print v(xbgr.mr_n58519568)
print v(xbgr.mr_n58519888)
print v(xbgr.mr_n58520000)
print v(xbgr.mr_n58520320)
print v(xbgr.mr_n58520432)
print v(xbgr.mr_n58520752)
print v(xbgr.mr_n58520864)
print v(xbgr.mr_n58521184)
print v(xbgr.mr_n58521296)
print v(xbgr.mr_n58522048)
print v(xbgr.mr_n58522912)
print v(xbgr.mr_n58523776)
print v(xbgr.mr_n58523888)
print v(xbgr.mr_n58524208)
print v(xbgr.mr_n58524320)
print v(xbgr.mr_n58524640)
print v(xbgr.mr_n58524752)
print v(xbgr.mr_n58525072)
print v(xbgr.mr_n58525184)
print v(xbgr.mr_n58525504)
print v(xbgr.mr_n58525616)
print v(xbgr.mr_n58525936)
print v(xbgr.mr_n58526048)
print v(xbgr.mr_n58526368)
print v(xbgr.mr_n58526480)
print v(xbgr.mr_n58526912)
print v(xbgr.mr_n58527232)
print v(xbgr.mr_n58527344)
print v(xbgr.mr_n58527664)
print v(xbgr.mr_n58527776)
print v(xbgr.mr_n58528096)
print v(xbgr.mr_n58528960)
print v(xbgr.mr_n58529824)
print v(xbgr.mr_n58530688)
print v(xbgr.mr_n58531552)
print v(xbgr.mr_n58531984)
print v(xbgr.mr_n58532096)
print v(xbgr.mr_n58532416)
print v(xbgr.mr_n58532528)
print v(xbgr.mr_n58532848)
print v(xbgr.mr_n58532960)
print v(xbgr.mr_n58533392)
print v(xbgr.mr_n58534144)
print v(xbgr.mr_n58534256)
print v(xbgr.mr_n58534576)
print v(xbgr.mr_n58534688)
print v(xbgr.mr_n58535008)
print v(xbgr.mr_n58535872)
print v(xbgr.mr_n58536736)
print v(xbgr.mr_n58536848)
print v(xbgr.mr_n58537168)
print v(xbgr.mr_n58537280)
print v(xbgr.mr_n58537600)
print v(xbgr.mr_n58538464)
print v(xbgr.mr_n58539328)
print v(xbgr.mr_n58540192)
print v(xbgr.mr_n58540304)
print v(xbgr.mr_n58540624)
print v(xbgr.mr_n58540736)
print v(xbgr.mr_n58541056)
print v(xbgr.mr_n58541920)
print v(xbgr.mr_n58542784)
print v(xbgr.mr_n58542896)
print v(xbgr.mr_n58543216)
print v(xbgr.mr_n58543328)
print v(xbgr.mr_n58543648)
print v(xbgr.mr_n58543760)
print v(xbgr.mr_n58544080)
print v(xbgr.mr_n58544192)
print v(xbgr.mr_n58544512)
print v(xbgr.mr_n58544624)
print v(xbgr.mr_n58544944)
print v(xbgr.mr_n58545056)
print v(xbgr.mr_n58545376)
print v(xbgr.mr_n58545488)
print v(xbgr.mr_n58545808)
print v(xbgr.mr_n58545920)
print v(xbgr.mr_n58546240)
print v(xbgr.mr_n58546352)
print v(xbgr.mr_n58546672)
print v(xbgr.mr_n58546784)
print v(xbgr.mr_n58547104)
print v(xbgr.mr_n58547216)
print v(xbgr.mr_n58547536)
print v(xbgr.mr_n58547648)
print v(xbgr.mr_n58547968)
print v(xbgr.mr_n58548080)
print v(xbgr.mr_n58548400)
print v(xbgr.mr_n58548512)
print v(xbgr.mr_n58548832)
print v(xbgr.mr_n58548944)
print v(xbgr.mr_n58549264)
print v(xbgr.mr_n58549376)
print v(xbgr.mr_n58549696)
print v(xbgr.mr_n58549808)
print v(xbgr.mr_n58550128)
print v(xbgr.mr_n58550240)
print v(xbgr.mr_n58550560)
print v(xbgr.mr_n58550672)
print v(xbgr.mr_n58550992)
print v(xbgr.mr_n58551104)
print v(xbgr.mr_n58551424)
print v(xbgr.mr_n58551536)
print v(xbgr.mr_n58551856)
print v(xbgr.mr_n58551968)
print v(xbgr.mr_n58552288)
print v(xbgr.mr_n58552400)
print v(xbgr.mr_n58552720)
print v(xbgr.mr_n58552832)
print v(xbgr.mr_n58553152)
print v(xbgr.mr_n58553264)
print v(xbgr.mr_n58553584)
print v(xbgr.mr_n58553696)
print v(xbgr.mr_n58554128)
print v(xbgr.mr_n58554560)
print v(xbgr.mr_n58554992)
print v(xbgr.mr_n58555424)
print v(xbgr.mr_n58555856)
print v(xbgr.mr_n58556288)
print v(xbgr.mr_n58556720)
print v(xbgr.mr_n58557152)
print v(xbgr.mr_n58557584)
print v(xbgr.mr_n58558016)
print v(xbgr.mr_n58558448)
print v(xbgr.mr_n58558880)
print v(xbgr.mr_n58559312)
print v(xbgr.mr_n58559744)
print v(xbgr.mr_n58560176)
print v(xbgr.mr_n58560608)
print v(xbgr.mr_n58561040)
print v(xbgr.mr_n58561472)
print v(xbgr.mr_n58561904)
print v(xbgr.mr_n58562336)
print v(xbgr.mr_n58562768)
print v(xbgr.mr_n58563200)
print v(xbgr.mr_n58563632)
print v(xbgr.mr_n58564064)
print v(xbgr.mr_n58564496)
print v(xbgr.mr_n58564928)
print v(xbgr.mr_n58565248)
print v(xbgr.mr_n58565360)
print v(xbgr.mr_n58565680)
print v(xbgr.mr_n58565792)
print v(xbgr.mr_n58566112)
print v(xbgr.mr_n58566224)
print v(xbgr.mr_n58566544)
print v(xbgr.mr_n58566656)
print v(xbgr.mr_n58566976)
print v(xbgr.mr_n58567088)
print v(xbgr.mr_n58567408)
print v(xbgr.mr_n58567520)
print v(xbgr.mr_n58567840)
print v(xbgr.mr_n58567952)
print v(xbgr.mr_n58568272)
print v(xbgr.mr_n58568384)
print v(xbgr.mr_n58568704)
print v(xbgr.mr_n58568816)
print v(xbgr.mr_n58569136)
print v(xbgr.mr_n58569248)
print v(xbgr.mr_n58569568)
print v(xbgr.mr_n58569680)
print v(xbgr.mr_n58570000)
print v(xbgr.mr_n58570112)
print v(xbgr.mr_n58570432)
print v(xbgr.mr_n58570544)
print v(xbgr.mr_n58570864)
print v(xbgr.mr_n58570976)
print v(xbgr.mr_n58571296)
print v(xbgr.mr_n58571408)
print v(xbgr.mr_n58571728)
print v(xbgr.mr_n58571840)
print v(xbgr.mr_n58572160)
print v(xbgr.mr_n58572272)
print v(xbgr.mr_n58572592)
print v(xbgr.mr_n58572704)
print v(xbgr.mr_n58573024)
print v(xbgr.mr_n58573136)
print v(xbgr.mr_n58573456)
print v(xbgr.mr_n58573568)
print v(xbgr.mr_n58573888)
print v(xbgr.mr_n58574000)
print v(xbgr.mr_n58574320)
print v(xbgr.mr_n58574432)
print v(xbgr.mr_n58574752)
print v(xbgr.mr_n58574864)
print v(xbgr.mr_n58575184)
print v(xbgr.mr_n58575296)
print v(xbgr.mr_n58575728)
print v(xbgr.mr_n58576160)
print v(xbgr.mr_n58576592)
print v(xbgr.mr_n58577024)
print v(xbgr.mr_n58577344)
print v(xbgr.mr_n58577456)
print v(xbgr.mr_n58577776)
print v(xbgr.mr_n58577888)
print v(xbgr.mr_n58578320)
print v(xbgr.mr_n58578752)
print v(xbgr.mr_n58579184)
print v(xbgr.mr_n58579616)
print v(xbgr.mr_n58580048)
print v(xbgr.mr_n58580480)
print v(xbgr.mr_n58580912)
print v(xbgr.mr_n58581344)
print v(xbgr.mr_n58581776)
print v(xbgr.mr_n58582208)
print v(xbgr.mr_n58582640)
print v(xbgr.mr_n58583072)
print v(xbgr.mr_n58583504)
print v(xbgr.mr_n58583936)
print v(xbgr.mr_n58584368)
print v(xbgr.mr_n58584800)
print v(xbgr.mr_n58585232)
print v(xbgr.mr_n58585664)
print v(xbgr.mr_n58586096)
print v(xbgr.mr_n58586528)
print v(xbgr.mr_n58586960)
print v(xbgr.mr_n58587392)
print v(xbgr.mr_n58587712)
print v(xbgr.mr_n58587824)
print v(xbgr.mr_n58588256)
print v(xbgr.mr_n58588576)
print v(xbgr.mr_n58588688)
print v(xbgr.mr_n58589120)
print v(xbgr.mr_n58589440)
print v(xbgr.mr_n58589552)
print v(xbgr.mr_n58589984)
print v(xbgr.mr_n58590304)
print v(xbgr.mr_n58590416)
print v(xbgr.mr_n58590848)
print v(xbgr.mr_n58591168)
print v(xbgr.mr_n58591280)
print v(xbgr.mr_n58591712)
print v(xbgr.mr_n58592032)
print v(xbgr.mr_n58592144)
print v(xbgr.mr_n58592464)
print v(xbgr.mr_n58592576)
print v(xbgr.mr_n58592896)
print v(xbgr.mr_n58593008)
print v(xbgr.mr_n58593440)
print v(xbgr.mr_n58593872)
print v(xbgr.mr_n58594304)
print v(xbgr.mr_n58594624)
print v(xbgr.mr_n58594736)
print v(xbgr.mr_n58595056)
print v(xbgr.mr_n58595168)
print v(xbgr.mr_n58595488)
print v(xbgr.mr_n58595600)
print v(xbgr.mr_n58595920)
print v(xbgr.mr_n58596032)
print v(xbgr.mr_n58596352)
print v(xbgr.mr_n58596464)
print v(xbgr.mr_n58596784)
print v(xbgr.mr_n58596896)
print v(xbgr.mr_n58597216)
print v(xbgr.mr_n58597328)
print v(xbgr.mr_n58597760)
print v(xbgr.mr_n58598080)
print v(xbgr.mr_n58598192)
print v(xbgr.mr_n58598624)
print v(xbgr.mr_n58598944)
print v(xbgr.mr_n58599056)
print v(xbgr.mr_n58599488)
print v(xbgr.mr_n58599808)
print v(xbgr.mr_n58600672)
print v(xbgr.mr_n58601536)
print v(xbgr.mr_n58602400)
print v(xbgr.mr_n58603264)
print v(xbgr.mr_n58604128)
print v(xbgr.mr_n58604992)
print v(xbgr.mr_n58605104)
print v(xbgr.mr_n58605424)
print v(xbgr.mr_n58605536)
print v(xbgr.mr_n58605856)
print v(xbgr.mr_n58605968)
print v(xbgr.mr_n58606288)
print v(xbgr.mr_n58606400)
print v(xbgr.mr_n58606720)
print v(xbgr.mr_n58607584)
print v(xbgr.mr_n58608448)
print v(xbgr.mr_n58609312)
print v(xbgr.mr_n58609424)
print v(xbgr.mr_n58609744)
print v(xbgr.mr_n58609856)
print v(xbgr.mr_n58610176)
print v(xbgr.mr_n58610288)
print v(xbgr.mr_n58610720)
print v(xbgr.mr_n58611152)
print v(xbgr.mr_n58611584)
print v(xbgr.mr_n58611904)
print v(xbgr.mr_n58612016)
print v(xbgr.mr_n58612336)
print v(xbgr.mr_n58612448)
print v(xbgr.mr_n58612768)
print v(xbgr.mr_n58612880)
print v(xbgr.mr_n58613200)
print v(xbgr.mr_n58613312)
print v(xbgr.mr_n58613632)
print v(xbgr.mr_n58613744)
print v(xbgr.mr_n58614064)
print v(xbgr.mr_n58614176)
print v(xbgr.mr_n58614496)
print v(xbgr.mr_n58614608)
print v(xbgr.mr_n58614928)
print v(xbgr.mr_n58615040)
print v(xbgr.mr_n58615360)
print v(xbgr.mr_n58615472)
print v(xbgr.mr_n58615904)
print v(xbgr.mr_n58616224)
print v(xbgr.mr_n58616336)
print v(xbgr.mr_n58616768)
print v(xbgr.mr_n58617088)
print v(xbgr.mr_n58617200)
print v(xbgr.mr_n58617520)
print v(xbgr.mr_n58617632)
print v(xbgr.mr_n58617952)
print v(xbgr.mr_n58618816)
print v(xbgr.mr_n58619680)
print v(xbgr.mr_n58619792)
print v(xbgr.mr_n58620112)
print v(xbgr.mr_n58620224)
print v(xbgr.mr_n58620544)
print v(xbgr.mr_n58621408)
print v(xbgr.mr_n58621952)
print v(xbgr.mr_n58622384)
print v(xbgr.mr_n58623136)
print v(xbgr.mr_n58624000)
print v(xbgr.mr_n58624112)
print v(xbgr.mr_n58624432)
print v(xbgr.mr_n58624544)
print v(xbgr.mr_n58624864)
print v(xbgr.mr_n58624976)
print v(xbgr.mr_n58625296)
print v(xbgr.mr_n58625408)
print v(xbgr.mr_n58625728)
print v(xbgr.mr_n58625840)
print v(xbgr.mr_n58626160)
print v(xbgr.mr_n58626272)
print v(xbgr.mr_n58626592)
print v(xbgr.mr_n58626704)
print v(xbgr.mr_n58627024)
print v(xbgr.mr_n58627136)
print v(xbgr.mr_n58627456)
print v(xbgr.mr_n58628320)
print v(xbgr.mr_n58628432)
print v(xbgr.mr_n58628752)
print v(xbgr.mr_n58628864)
print v(xbgr.mr_n58629184)
print v(xbgr.mr_n58630048)
print v(xbgr.mr_n58630912)
print v(xbgr.mr_n58631024)
print v(xbgr.mr_n58631344)
print v(xbgr.mr_n58631456)
print v(xbgr.mr_n58631776)
print v(xbgr.mr_n58631888)
print v(xbgr.mr_n58632320)
print v(xbgr.mr_n58632640)
print v(xbgr.mr_n58633072)
print v(xbgr.mr_n58634368)
print v(xbgr.mr_n58634480)
print v(xbgr.mr_n58634800)
print v(xbgr.mr_n58634912)
print v(xbgr.mr_n58635232)
print v(xbgr.mr_n58635344)
print v(xbgr.mr_n58635664)
print v(xbgr.mr_n58635776)
print v(xbgr.mr_n58636096)
print v(xbgr.mr_n58636208)
print v(xbgr.mr_n58636640)
print v(xbgr.mr_n58636960)
print v(xbgr.mr_n58637072)
print v(xbgr.mr_n58637392)
print v(xbgr.mr_n58637504)
print v(xbgr.mr_n58637824)
print v(xbgr.mr_n58637936)
print v(xbgr.mr_n58638256)
print v(xbgr.mr_n58638368)
print v(xbgr.mr_n58638688)
print v(xbgr.mr_n58639552)
print v(xbgr.mr_n58640416)
print v(xbgr.mr_n58641280)
print v(xbgr.mr_n58642144)
print v(xbgr.mr_n58642256)
print v(xbgr.mr_n58642576)
print v(xbgr.mr_n58642688)
print v(xbgr.mr_n58643008)
print v(xbgr.mr_n58643120)
print v(xbgr.mr_n58643440)
print v(xbgr.mr_n58643552)
print v(xbgr.mr_n58643872)
print v(xbgr.mr_n58644736)
print v(xbgr.mr_n58645600)
print v(xbgr.mr_n58646464)
print v(xbgr.mr_n58647328)
print v(xbgr.mr_n58647760)
print v(xbgr.mr_n58647872)
print v(xbgr.mr_n58648192)
print v(xbgr.mr_n58648304)
print v(xbgr.mr_n58648624)
print v(xbgr.mr_n58648736)
print v(xbgr.mr_n58649056)
print v(xbgr.mr_n58649168)
print v(xbgr.mr_n58649488)
print v(xbgr.mr_n58649600)
print v(xbgr.mr_n58649920)
print v(xbgr.mr_n58650032)
print v(xbgr.mr_n58650352)
print v(xbgr.mr_n58650464)
print v(xbgr.mr_n58650784)
print v(xbgr.mr_n58650896)
print v(xbgr.mr_n58651328)
print v(xbgr.mr_n58651648)
print v(xbgr.mr_n58651760)
print v(xbgr.mr_n58652192)
print v(xbgr.mr_n58652512)
print v(xbgr.mr_n58652624)
print v(xbgr.mr_n58653056)
print v(xbgr.mr_n58653376)
print v(xbgr.mr_n58653488)
print v(xbgr.mr_n58653808)
print v(xbgr.mr_n58653920)
print v(xbgr.mr_n58654240)
print v(xbgr.mr_n58655104)
print v(xbgr.mr_n58655968)
print v(xbgr.mr_n58656832)
print v(xbgr.mr_n58657696)
print v(xbgr.mr_n58658560)
print v(xbgr.mr_n58659424)
print v(xbgr.mr_n58660288)
print v(xbgr.mr_n58661152)
print v(xbgr.mr_n58662016)
print v(xbgr.mr_n58662128)
print v(xbgr.mr_n58662448)
print v(xbgr.mr_n58662560)
print v(xbgr.mr_n58662880)
print v(xbgr.mr_n58663744)
print v(xbgr.mr_n58663856)
print v(xbgr.mr_n58664176)
print v(xbgr.mr_n58664288)
print v(xbgr.mr_n58664608)
print v(xbgr.mr_n58664720)
print v(xbgr.mr_n58665040)
print v(xbgr.mr_n58665152)
print v(xbgr.mr_n58665472)
print v(xbgr.mr_n58665584)
print v(xbgr.mr_n58665904)
print v(xbgr.mr_n58666016)
print v(xbgr.mr_n58666336)
print v(xbgr.mr_n58666448)
print v(xbgr.mr_n58666768)
print v(xbgr.mr_n58666880)
print v(xbgr.mr_n58667200)
print v(xbgr.mr_n58668064)
print v(xbgr.mr_n58668928)
print v(xbgr.mr_n58669792)
print v(xbgr.mr_n58669904)
print v(xbgr.mr_n58670224)
print v(xbgr.mr_n58671520)
print v(xbgr.mr_n58672384)
print v(xbgr.mr_n58673248)
print v(xbgr.mr_n58674112)
print v(xbgr.mr_n58674224)
print v(xbgr.mr_n58674544)
print v(xbgr.mr_n58674656)
print v(xbgr.mr_n58675088)
print v(xbgr.mr_n58675408)
print v(xbgr.mr_n58675520)
print v(xbgr.mr_n58675952)
print v(xbgr.mr_n58676272)
print v(xbgr.mr_n58676384)
print v(xbgr.mr_n58676816)
print v(xbgr.mr_n58677136)
print v(xbgr.mr_n58677248)
print v(xbgr.mr_n58677680)
print v(xbgr.mr_n58678000)
print v(xbgr.mr_n58678112)
print v(xbgr.mr_n58678544)
print v(xbgr.mr_n58678864)
print v(xbgr.mr_n58678976)
print v(xbgr.mr_n58679296)
print v(xbgr.mr_n58679408)
print v(xbgr.mr_n58679728)
print v(xbgr.mr_n58679840)
print v(xbgr.mr_n58680272)
print v(xbgr.mr_n58680592)
print v(xbgr.mr_n58680704)
print v(xbgr.mr_n58681024)
print v(xbgr.mr_n58681136)
print v(xbgr.mr_n58681456)
print v(xbgr.mr_n58681568)
print v(xbgr.mr_n58681888)
print v(xbgr.mr_n58682000)
print v(xbgr.mr_n58682320)
print v(xbgr.mr_n58682432)
print v(xbgr.mr_n58682752)
print v(xbgr.mr_n58682864)
print v(xbgr.mr_n58683184)
print v(xbgr.mr_n58683296)
print v(xbgr.mr_n58683616)
print v(xbgr.mr_n58683728)
print v(xbgr.mr_n58684160)
print v(xbgr.mr_n58684480)
print v(xbgr.mr_n58685456)
print v(xbgr.mr_n58685888)
print v(xbgr.mr_n58686208)
print v(xbgr.mr_n58687072)
print v(xbgr.mr_n58687184)
print v(xbgr.mr_n58687504)
print v(xbgr.mr_n58687616)
print v(xbgr.mr_n58687936)
print v(xbgr.mr_n58688048)
print v(xbgr.mr_n58688368)
print v(xbgr.mr_n58688480)
print v(xbgr.mr_n58688800)
print v(xbgr.mr_n58689664)
print v(xbgr.mr_n58690096)
print v(xbgr.mr_n58690960)
print v(xbgr.mr_n58691824)
print v(xbgr.mr_n58691936)
print v(xbgr.mr_n58692256)
print v(xbgr.mr_n58692368)
print v(xbgr.mr_n58692688)
print v(xbgr.mr_n58692800)
print v(xbgr.mr_n58693120)
print v(xbgr.mr_n58693232)
print v(xbgr.mr_n58693984)
print v(xbgr.mr_n58694096)
print v(xbgr.mr_n58694416)
print v(xbgr.mr_n58694528)
print v(xbgr.mr_n58694848)
print v(xbgr.mr_n58694960)
print v(xbgr.mr_n58695280)
print v(xbgr.mr_n58695392)
print v(xbgr.mr_n58695712)
print v(xbgr.mr_n58696256)
print v(xbgr.mr_n58696576)
print v(xbgr.mr_n58696688)
print v(xbgr.mr_n58697120)
print v(xbgr.mr_n58697440)
print v(xbgr.mr_n58697552)
print v(xbgr.mr_n58698736)
print v(xbgr.mr_n58699168)
print v(xbgr.mr_n58699280)
print v(xbgr.mr_n58699600)
print v(xbgr.mr_n58699712)
print v(xbgr.mr_n58700032)
print v(xbgr.mr_n58700144)
print v(xbgr.mr_n58700464)
print v(xbgr.mr_n58700576)
print v(xbgr.mr_n58700896)
print v(xbgr.mr_n58701008)
print v(xbgr.mr_n58701328)
print v(xbgr.mr_n58701440)
print v(xbgr.mr_n58702192)
print v(xbgr.mr_n58703056)
print v(xbgr.mr_n58703168)
print v(xbgr.mr_n58703488)
print v(xbgr.mr_n58703600)
print v(xbgr.mr_n58703920)
print v(xbgr.mr_n58704032)
print v(xbgr.mr_n58704352)
print v(xbgr.mr_n58704464)
print v(xbgr.mr_n58704784)
print v(xbgr.mr_n58704896)
print v(xbgr.mr_n58705216)
print v(xbgr.mr_n58705328)
print v(xbgr.mr_n58705648)
print v(xbgr.mr_n58705760)
print v(xbgr.mr_n58706080)
print v(xbgr.mr_n58706192)
print v(xbgr.mr_n58706512)
print v(xbgr.mr_n58707376)
print v(xbgr.mr_n58708240)
print v(xbgr.mr_n58709104)
print v(xbgr.mr_n58709216)
print v(xbgr.mr_n58709648)
print v(xbgr.mr_n58710080)
print v(xbgr.mr_n58710400)
print v(xbgr.mr_n58710832)
print v(xbgr.mr_n58710944)
print v(xbgr.mr_n58711264)
print v(xbgr.mr_n58711376)
print v(xbgr.mr_n58712128)
print v(xbgr.mr_n58713536)
print v(xbgr.mr_n58713856)
print v(xbgr.mr_n58713968)
print v(xbgr.mr_n58714288)
print v(xbgr.mr_n58714400)
print v(xbgr.mr_n58714720)
print v(xbgr.mr_n58714832)
print v(xbgr.mr_n58715264)
print v(xbgr.mr_n58715584)
print v(xbgr.mr_n58715696)
print v(xbgr.mr_n58716128)
print v(xbgr.mr_n58716448)
print v(xbgr.mr_n58716880)
print v(xbgr.mr_n58717312)
print v(xbgr.mr_n58717424)
print v(xbgr.mr_n58717744)
print v(xbgr.mr_n58717856)
print v(xbgr.mr_n58718176)
print v(xbgr.mr_n58718288)
print v(xbgr.mr_n58719040)
print v(xbgr.mr_n58719904)
print v(xbgr.mr_n58720016)
print v(xbgr.mr_n58720448)
print v(xbgr.mr_n58720768)
print v(xbgr.mr_n58721632)
print v(xbgr.mr_n58722496)
print v(xbgr.mr_n58723792)
print v(xbgr.mr_n58724224)
print v(xbgr.mr_n58724336)
print v(xbgr.mr_n58724656)
print v(xbgr.mr_n58724768)
print v(xbgr.mr_n58725088)
print v(xbgr.mr_n58725200)
print v(xbgr.mr_n58725520)
print v(xbgr.mr_n58725632)
print v(xbgr.mr_n58725952)
print v(xbgr.mr_n58726064)
print v(xbgr.mr_n58726384)
print v(xbgr.mr_n58726496)
print v(xbgr.mr_n58726816)
print v(xbgr.mr_n58726928)
print v(xbgr.mr_n58727248)
print v(xbgr.mr_n58727360)
print v(xbgr.mr_n58728112)
print v(xbgr.mr_n58728976)
print v(xbgr.mr_n58729840)
print v(xbgr.mr_n58729952)
print v(xbgr.mr_n58730272)
print v(xbgr.mr_n58730384)
print v(xbgr.mr_n58730704)
print v(xbgr.mr_n58730816)
print v(xbgr.mr_n58731136)
print v(xbgr.mr_n58732000)
print v(xbgr.mr_n58732864)
print v(xbgr.mr_n58733728)
print v(xbgr.mr_n58734592)
print v(xbgr.mr_n58735456)
print v(xbgr.mr_n58736320)
print v(xbgr.mr_n58736432)
print v(xbgr.mr_n58736752)
print v(xbgr.mr_n58737616)
print v(xbgr.mr_n58737728)
print v(xbgr.mr_n58738048)
print v(xbgr.mr_n58738160)
print v(xbgr.mr_n58738480)
print v(xbgr.mr_n58739344)
print v(xbgr.mr_n58739776)
print v(xbgr.mr_n58739888)
print v(xbgr.mr_n58740640)
print v(xbgr.mr_n58740752)
print v(xbgr.mr_n58741072)
print v(xbgr.mr_n58741184)
print v(xbgr.mr_n58741504)
print v(xbgr.mr_n58741616)
print v(xbgr.mr_n58741936)
print v(xbgr.mr_n58742048)
print v(xbgr.mr_n58742368)
print v(xbgr.mr_n58742480)
print v(xbgr.mr_n58742800)
print v(xbgr.mr_n58742912)
print v(xbgr.mr_n58743232)
print v(xbgr.mr_n58743344)
print v(xbgr.mr_n58743664)
print v(xbgr.mr_n58743776)
print v(xbgr.mr_n58744096)
print v(xbgr.mr_n58744208)
print v(xbgr.mr_n58744528)
print v(xbgr.mr_n58745072)
print v(xbgr.mr_n58745824)
print v(xbgr.mr_n58746688)
print v(xbgr.mr_n58747552)
print v(xbgr.mr_n58747664)
print v(xbgr.mr_n58748096)
print v(xbgr.mr_n58748416)
print v(xbgr.mr_n58749280)
print v(xbgr.mr_n58750144)
print v(xbgr.mr_n58751008)
print v(xbgr.mr_n58751872)
print v(xbgr.mr_n58752736)
print v(xbgr.mr_n58753600)
print v(xbgr.mr_n58753712)
print v(xbgr.mr_n58754032)
print v(xbgr.mr_n58754144)
print v(xbgr.mr_n58754464)
print v(xbgr.mr_n58755328)
print v(xbgr.mr_n58756192)
print v(xbgr.mr_n58756304)
print v(xbgr.mr_n58756624)
print v(xbgr.mr_n58756736)
print v(xbgr.mr_n58757056)
print v(xbgr.mr_n58757168)
print v(xbgr.mr_n58757488)
print v(xbgr.mr_n58757600)
print v(xbgr.mr_n58757920)
print v(xbgr.mr_n58758032)
print v(xbgr.mr_n58758352)
print v(xbgr.mr_n58758464)
print v(xbgr.mr_n58758784)
print v(xbgr.mr_n58758896)
print v(xbgr.mr_n58759216)
print v(xbgr.mr_n58760080)
print v(xbgr.mr_n58760192)
print v(xbgr.mr_n58760512)
print v(xbgr.mr_n58760624)
print v(xbgr.mr_n58760944)
print v(xbgr.mr_n58761056)
print v(xbgr.mr_n58761376)
print v(xbgr.mr_n58761488)
print v(xbgr.mr_n58761808)
print v(xbgr.mr_n58761920)
print v(xbgr.mr_n58762240)
print v(xbgr.mr_n58762352)
print v(xbgr.mr_n58762672)
print v(xbgr.mr_n58762784)
print v(xbgr.mr_n58763104)
print v(xbgr.mr_n58763216)
print v(xbgr.mr_n58763648)
print v(xbgr.mr_n58764080)
print v(xbgr.mr_n58764512)
print v(xbgr.mr_n58764832)
print v(xbgr.mr_n58764944)
print v(xbgr.mr_n58765264)
print v(xbgr.mr_n58765376)
print v(xbgr.mr_n58765696)
print v(xbgr.mr_n58765808)
print v(xbgr.mr_n58766128)
print v(xbgr.mr_n58766240)
print v(xbgr.mr_n58766560)
print v(xbgr.mr_n58766672)
print v(xbgr.mr_n58766992)
print v(xbgr.mr_n58767104)
print v(xbgr.mr_n58767424)
print v(xbgr.mr_n58767536)
print v(xbgr.mr_n58767856)
print v(xbgr.mr_n58767968)
print v(xbgr.mr_n58768288)
print v(xbgr.mr_n58768400)
print v(xbgr.mr_n58768720)
print v(xbgr.mr_n58768832)
print v(xbgr.mr_n58769152)
print v(xbgr.mr_n58769264)
print v(xbgr.mr_n58769584)
print v(xbgr.mr_n58769696)
print v(xbgr.mr_n58770016)
print v(xbgr.mr_n58770128)
print v(xbgr.mr_n58770448)
print v(xbgr.mr_n58770560)
print v(xbgr.mr_n58770880)
print v(xbgr.mr_n58770992)
print v(xbgr.mr_n58771312)
print v(xbgr.mr_n58771424)
print v(xbgr.mr_n58771856)
print v(xbgr.mr_n58772176)
print v(xbgr.mr_n58772288)
print v(xbgr.mr_n58772720)
print v(xbgr.mr_n58773152)
print v(xbgr.mr_n58773472)
print v(xbgr.mr_n58773584)
print v(xbgr.mr_n58773904)
print v(xbgr.mr_n58774016)
print v(xbgr.mr_n58774336)
print v(xbgr.mr_n58774448)
print v(xbgr.mr_n58774768)
print v(xbgr.mr_n58774880)
print v(xbgr.mr_n58775312)
print v(xbgr.mr_n58775744)
print v(xbgr.mr_n58776176)
print v(xbgr.mr_n58776608)
print v(xbgr.mr_n58777040)
print v(xbgr.mr_n58777472)
print v(xbgr.mr_n58777904)
print v(xbgr.mr_n58778336)
print v(xbgr.mr_n58778656)
print v(xbgr.mr_n58778768)
print v(xbgr.mr_n58779088)
print v(xbgr.mr_n58779200)
print v(xbgr.mr_n58779520)
print v(xbgr.mr_n58779632)
print v(xbgr.mr_n58779952)
print v(xbgr.mr_n58780064)
print v(xbgr.mr_n58780384)
print v(xbgr.mr_n58780496)
print v(xbgr.mr_n58780816)
print v(xbgr.mr_n58780928)
print v(xbgr.mr_n58781248)
print v(xbgr.mr_n58781360)
print v(xbgr.mr_n58781680)
print v(xbgr.mr_n58781792)
print v(xbgr.mr_n58782112)
print v(xbgr.mr_n58782224)
print v(xbgr.mr_n58782544)
print v(xbgr.mr_n58782656)
print v(xbgr.mr_n58782976)
print v(xbgr.mr_n58783088)
print v(xbgr.mr_n58783408)
print v(xbgr.mr_n58783520)
print v(xbgr.mr_n58783840)
print v(xbgr.mr_n58783952)
print v(xbgr.mr_n58784272)
print v(xbgr.mr_n58784384)
print v(xbgr.mr_n58784704)
print v(xbgr.mr_n58784816)
print v(xbgr.mr_n58785136)
print v(xbgr.mr_n58785248)
print v(xbgr.mr_n58785568)
print v(xbgr.mr_n58785680)
print v(xbgr.mr_n58786000)
print v(xbgr.mr_n58786112)
print v(xbgr.mr_n58786432)
print v(xbgr.mr_n58786544)
print v(xbgr.mr_n58786864)
print v(xbgr.mr_n58786976)
print v(xbgr.mr_n58787296)
print v(xbgr.mr_n58787408)
print v(xbgr.mr_n58787728)
print v(xbgr.mr_n58787840)
print v(xbgr.mr_n58788160)
print v(xbgr.mr_n58788272)
print v(xbgr.mr_n58788592)
print v(xbgr.mr_n58788704)
print v(xbgr.mr_n58789136)
print v(xbgr.mr_n58789568)
print v(xbgr.mr_n58789888)
print v(xbgr.mr_n58790000)
print v(xbgr.mr_n58790320)
print v(xbgr.mr_n58790432)
print v(xbgr.mr_n58790864)
print v(xbgr.mr_n58791296)
print v(xbgr.mr_n58791728)
print v(xbgr.mr_n58792160)
print v(xbgr.mr_n58792592)
print v(xbgr.mr_n58793024)
print v(xbgr.mr_n58793456)
print v(xbgr.mr_n58793888)
print v(xbgr.mr_n58794320)
print v(xbgr.mr_n58794752)
print v(xbgr.mr_n58795184)
print v(xbgr.mr_n58795616)
print v(xbgr.mr_n58796048)
print v(xbgr.mr_n58796480)
print v(xbgr.mr_n58796912)
print v(xbgr.mr_n58797344)
print v(xbgr.mr_n58797776)
print v(xbgr.mr_n58798208)
print v(xbgr.mr_n58798640)
print v(xbgr.mr_n58799072)
print v(xbgr.mr_n58799504)
print v(xbgr.mr_n58799936)
print v(xbgr.mr_n58800368)
print v(xbgr.mr_n58800800)
print v(xbgr.mr_n58801120)
print v(xbgr.mr_n58801232)
print v(xbgr.mr_n58801552)
print v(xbgr.mr_n58801664)
print v(xbgr.mr_n58801984)
print v(xbgr.mr_n58802096)
print v(xbgr.mr_n58802416)
print v(xbgr.mr_n58802528)
print v(xbgr.mr_n58802848)
print v(xbgr.mr_n58802960)
print v(xbgr.mr_n58803280)
print v(xbgr.mr_n58803392)
print v(xbgr.mr_n58803712)
print v(xbgr.mr_n58803824)
print v(xbgr.mr_n58804144)
print v(xbgr.mr_n58804256)
print v(xbgr.mr_n58804576)
print v(xbgr.mr_n58804688)
print v(xbgr.mr_n58805008)
print v(xbgr.mr_n58805120)
print v(xbgr.mr_n58805440)
print v(xbgr.mr_n58805552)
print v(xbgr.mr_n58805872)
print v(xbgr.mr_n58805984)
print v(xbgr.mr_n58806304)
print v(xbgr.mr_n58806416)
print v(xbgr.mr_n58806848)
print v(xbgr.mr_n58807280)
print v(xbgr.mr_n58807712)
print v(xbgr.mr_n58808144)
print v(xbgr.mr_n58808576)
print v(xbgr.mr_n58809008)
print v(xbgr.mr_n58809440)
print v(xbgr.mr_n58809872)
print v(xbgr.mr_n58810304)
print v(xbgr.mr_n58810736)
print v(xbgr.mr_n58811168)
print v(xbgr.mr_n58811600)
print v(xbgr.mr_n58812032)
print v(xbgr.mr_n58812352)
print v(xbgr.mr_n58812464)
print v(xbgr.mr_n58812784)
print v(xbgr.mr_n58812896)
print v(xbgr.mr_n58813216)
print v(xbgr.mr_n58813328)
print v(xbgr.mr_n58813648)
print v(xbgr.mr_n58813760)
print v(xbgr.mr_n58814080)
print v(xbgr.mr_n58814192)
print v(xbgr.mr_n58814512)
print v(xbgr.mr_n58814624)
print v(xbgr.mr_n58814944)
print v(xbgr.mr_n58815056)
print v(xbgr.mr_n58815376)
print v(xbgr.mr_n58815488)
print v(xbgr.mr_n58815808)
print v(xbgr.mr_n58815920)
print v(xbgr.mr_n58816240)
print v(xbgr.mr_n58816352)
print v(xbgr.mr_n58816672)
print v(xbgr.mr_n58816784)
print v(xbgr.mr_n58817104)
print v(xbgr.mr_n58817216)
print v(xbgr.mr_n58817536)
print v(xbgr.mr_n58817648)
print v(xbgr.mr_n58818080)
print v(xbgr.mr_n58818512)
print v(xbgr.mr_n58818944)
print v(xbgr.mr_n58819376)
print v(xbgr.mr_n58819808)
print v(xbgr.mr_n58820240)
print v(xbgr.mr_n58820672)
print v(xbgr.mr_n58821104)
print v(xbgr.mr_n58821536)
print v(xbgr.mr_n58821968)
print v(xbgr.mr_n58822400)
print v(xbgr.mr_n58822832)
print v(xbgr.mr_n58823264)
print v(xbgr.mr_n58823584)
print v(xbgr.mr_n58823696)
print v(xbgr.mr_n58824016)
print v(xbgr.mr_n58824128)
print v(xbgr.mr_n58824448)
print v(xbgr.mr_n58824560)
print v(xbgr.mr_n58824880)
print v(xbgr.mr_n58824992)
print v(xbgr.mr_n58825312)
print v(xbgr.mr_n58825424)
print v(xbgr.mr_n58825744)
print v(xbgr.mr_n58825856)
print v(xbgr.mr_n58826176)
print v(xbgr.mr_n58826288)
print v(xbgr.mr_n58826608)
print v(xbgr.mr_n58826720)
print v(xbgr.mr_n58827040)
print v(xbgr.mr_n58827152)
print v(xbgr.mr_n58827472)
print v(xbgr.mr_n58827584)
print v(xbgr.mr_n58827904)
print v(xbgr.mr_n58828016)
print v(xbgr.mr_n58828336)
print v(xbgr.mr_n58828448)
print v(xbgr.mr_n58828768)
print v(xbgr.mr_n58828880)
print v(xbgr.mr_n58829312)
print v(xbgr.mr_n58829744)
print v(xbgr.mr_n58830176)
print v(xbgr.mr_n58830608)
print v(xbgr.mr_n58831040)
print v(xbgr.mr_n58831472)
print v(xbgr.mr_n58831904)
print v(xbgr.mr_n58832336)
print v(xbgr.mr_n58832768)
print v(xbgr.mr_n58833200)
print v(xbgr.mr_n58833632)
print v(xbgr.mr_n58834064)
print v(xbgr.mr_n58834496)
print v(xbgr.mr_n58834816)
print v(xbgr.mr_n58834928)
print v(xbgr.mr_n58835248)
print v(xbgr.mr_n58835360)
print v(xbgr.mr_n58835680)
print v(xbgr.mr_n58835792)
print v(xbgr.mr_n58836112)
print v(xbgr.mr_n58836224)
print v(xbgr.mr_n58836544)
print v(xbgr.mr_n58836656)
print v(xbgr.mr_n58836976)
print v(xbgr.mr_n58837088)
print v(xbgr.mr_n58837408)
print v(xbgr.mr_n58837520)
print v(xbgr.mr_n58837952)
print v(xbgr.mr_n58838384)
print v(xbgr.mr_n58838816)
print v(xbgr.mr_n58839248)
print v(xbgr.mr_n58839568)
print v(xbgr.mr_n58839680)
print v(xbgr.mr_n58840000)
print v(xbgr.mr_n58840112)
print v(xbgr.mr_n58840432)
print v(xbgr.mr_n58840544)
print v(xbgr.mr_n58840864)
print v(xbgr.mr_n58840976)
print v(xbgr.mr_n58841296)
print v(xbgr.mr_n58841408)
print v(xbgr.mr_n58841728)
print v(xbgr.mr_n58841840)
print v(xbgr.mr_n58842272)
print v(xbgr.mr_n58842704)
print v(xbgr.mr_n58843136)
print v(xbgr.mr_n58843568)
print v(xbgr.mr_n58844000)
print v(xbgr.mr_n58844432)
print v(xbgr.mr_n58844864)
print v(xbgr.mr_n58845296)
print v(xbgr.mr_n58845728)
print v(xbgr.mr_n58846048)
print v(xbgr.mr_n58846160)
print v(xbgr.mr_n58846480)
print v(xbgr.mr_n58846592)
print v(xbgr.mr_n58846912)
print v(xbgr.mr_n58847024)
print v(xbgr.mr_n58847344)
print v(xbgr.mr_n58847456)
print v(xbgr.mr_n58847776)
print v(xbgr.mr_n58847888)
print v(xbgr.mr_n58848208)
print v(xbgr.mr_n58848320)
print v(xbgr.mr_n58848640)
print v(xbgr.mr_n58848752)
print v(xbgr.mr_n58849072)
print v(xbgr.mr_n58849184)
print v(xbgr.mr_n58849504)
print v(xbgr.mr_n58849616)
print v(xbgr.mr_n58849936)
print v(xbgr.mr_n58850048)
print v(xbgr.mr_n58850368)
print v(xbgr.mr_n58850480)
print v(xbgr.mr_n58850800)
print v(xbgr.mr_n58850912)
print v(xbgr.mr_n58851232)
print v(xbgr.mr_n58851344)
print v(xbgr.mr_n58851664)
print v(xbgr.mr_n58851776)
print v(xbgr.mr_n58852208)
print v(xbgr.mr_n58852640)
print v(xbgr.mr_n58853072)
print v(xbgr.mr_n58853504)
print v(xbgr.mr_n58853824)
print v(xbgr.mr_n58853936)
print v(xbgr.mr_n58854256)
print v(xbgr.mr_n58854368)
print v(xbgr.mr_n58854800)
print v(xbgr.mr_n58855232)
print v(xbgr.mr_n58855664)
print v(xbgr.mr_n58856096)
print v(xbgr.mr_n58856528)
print v(xbgr.mr_n58856960)
print v(xbgr.mr_n58857392)
print v(xbgr.mr_n58857824)
print v(xbgr.mr_n58858144)
print v(xbgr.mr_n58858256)
print v(xbgr.mr_n58858576)
print v(xbgr.mr_n58858688)
print v(xbgr.mr_n58859008)
print v(xbgr.mr_n58859120)
print v(xbgr.mr_n58859440)
print v(xbgr.mr_n58859552)
print v(xbgr.mr_n58859872)
print v(xbgr.mr_n58859984)
print v(xbgr.mr_n58860304)
print v(xbgr.mr_n58860416)
print v(xbgr.mr_n58860736)
print v(xbgr.mr_n58860848)
print v(xbgr.mr_n58861168)
print v(xbgr.mr_n58861280)
print v(xbgr.mr_n58861600)
print v(xbgr.mr_n58861712)
print v(xbgr.mr_n58862032)
print v(xbgr.mr_n58862144)
print v(xbgr.mr_n58862464)
print v(xbgr.mr_n58862576)
print v(xbgr.mr_n58862896)
print v(xbgr.mr_n58863008)
print v(xbgr.mr_n58863440)
print v(xbgr.mr_n58863872)
print v(xbgr.mr_n58864304)
print v(xbgr.mr_n58864736)
print v(xbgr.mr_n58865168)
print v(xbgr.mr_n58865600)
print v(xbgr.mr_n58865920)
print v(xbgr.mr_n58866032)
print v(xbgr.mr_n58866352)
print v(xbgr.mr_n58866464)
print v(xbgr.mr_n58866784)
print v(xbgr.mr_n58866896)
print v(xbgr.mr_n58867216)
print v(xbgr.mr_n58867328)
print v(xbgr.mr_n58867648)
print v(xbgr.mr_n58867760)
print v(xbgr.mr_n58868080)
print v(xbgr.mr_n58868192)
print v(xbgr.mr_n58868512)
print v(xbgr.mr_n58868624)
print v(xbgr.mr_n58868944)
print v(xbgr.mr_n58869056)
print v(xbgr.mr_n58869376)
print v(xbgr.mr_n58869488)
print v(xbgr.mr_n58869808)
print v(xbgr.mr_n58869920)
print v(xbgr.mr_n58870240)
print v(xbgr.mr_n58870352)
print v(xbgr.mr_n58870672)
print v(xbgr.mr_n58870784)
print v(xbgr.mr_n58871104)
print v(xbgr.mr_n58871216)
print v(xbgr.mr_n58871536)
print v(xbgr.mr_n58871648)
print v(xbgr.mr_n58871968)
print v(xbgr.mr_n58872080)
print v(xbgr.mr_n58872400)
print v(xbgr.mr_n58872512)
print v(xbgr.mr_n58872832)
print v(xbgr.mr_n58872944)
print v(xbgr.mr_n58873264)
print v(xbgr.mr_n58873376)
print v(xbgr.mr_n58873808)
print v(xbgr.mr_n58874240)
print v(xbgr.mr_n58874560)
print v(xbgr.mr_n58874672)
print v(xbgr.mr_n58874992)
print v(xbgr.mr_n58875104)
print v(xbgr.mr_n58875424)
print v(xbgr.mr_n58875536)
print v(xbgr.mr_n58875856)
print v(xbgr.mr_n58875968)
print v(xbgr.mr_n58876400)
print v(xbgr.mr_n58876832)
print v(xbgr.mr_n58877264)
print v(xbgr.mr_n58877696)
print v(xbgr.mr_n58878128)
print v(xbgr.mr_n58878560)
print v(xbgr.mr_n58878992)
print v(xbgr.mr_n58879424)
print v(xbgr.mr_n58879856)
print v(xbgr.mr_n58880288)
print v(xbgr.mr_n58880720)
print v(xbgr.mr_n58881152)
print v(xbgr.mr_n58881584)
print v(xbgr.mr_n58882016)
print v(xbgr.mr_n58882448)
print v(xbgr.mr_n58882880)
print v(xbgr.mr_n58883200)
print v(xbgr.mr_n58883312)
print v(xbgr.mr_n58883632)
print v(xbgr.mr_n58883744)
print v(xbgr.mr_n58884064)
print v(xbgr.mr_n58884176)
print v(xbgr.mr_n58884496)
print v(xbgr.mr_n58884608)
print v(xbgr.mr_n58884928)
print v(xbgr.mr_n58885040)
print v(xbgr.mr_n58885360)
print v(xbgr.mr_n58885472)
print v(xbgr.mr_n58885792)
print v(xbgr.mr_n58885904)
print v(xbgr.mr_n58886224)
print v(xbgr.mr_n58886336)
print v(xbgr.mr_n58886656)
print v(xbgr.mr_n58886768)
print v(xbgr.mr_n58887088)
print v(xbgr.mr_n58887200)
print v(xbgr.mr_n58887632)
print v(xbgr.mr_n58888064)
print v(xbgr.mr_n58888496)
print v(xbgr.mr_n58888928)
print v(xbgr.mr_n58889360)
print v(xbgr.mr_n58889792)
print v(xbgr.mr_n58890224)
print v(xbgr.mr_n58890656)
print v(xbgr.mr_n58890976)
print v(xbgr.mr_n58891088)
print v(xbgr.mr_n58891408)
print v(xbgr.mr_n58891520)
print v(xbgr.mr_n58891840)
print v(xbgr.mr_n58891952)
print v(xbgr.mr_n58892272)
print v(xbgr.mr_n58892384)
print v(xbgr.mr_n58892704)
print v(xbgr.mr_n58892816)
print v(xbgr.mr_n58893136)
print v(xbgr.mr_n58893248)
print v(xbgr.mr_n58893568)
print v(xbgr.mr_n58893680)
print v(xbgr.mr_n58894000)
print v(xbgr.mr_n58894112)
print v(xbgr.mr_n58894432)
print v(xbgr.mr_n58894544)
print v(xbgr.mr_n58894864)
print v(xbgr.mr_n58894976)
print v(xbgr.mr_n58895296)
print v(xbgr.mr_n58895408)
print v(xbgr.mr_n58895728)
print v(xbgr.mr_n58895840)
print v(xbgr.mr_n58896160)
print v(xbgr.mr_n58896272)
print v(xbgr.mr_n58896592)
print v(xbgr.mr_n58896704)
print v(xbgr.mr_n58897136)
print v(xbgr.mr_n58897568)
print v(xbgr.mr_n58898000)
print v(xbgr.mr_n58898432)
print v(xbgr.mr_n58898864)
print v(xbgr.mr_n58899296)
print v(xbgr.mr_n58899728)
print v(xbgr.mr_n58900160)
print v(xbgr.mr_n58900592)
print v(xbgr.mr_n58901024)
print v(xbgr.mr_n58901456)
print v(xbgr.mr_n58901888)
print v(xbgr.mr_n58902320)
print v(xbgr.mr_n58902752)
print v(xbgr.mr_n58903072)
print v(xbgr.mr_n58903184)
print v(xbgr.mr_n58903504)
print v(xbgr.mr_n58903616)
print v(xbgr.mr_n58903936)
print v(xbgr.mr_n58904048)
print v(xbgr.mr_n58904368)
print v(xbgr.mr_n58904480)
print v(xbgr.mr_n58904800)
print v(xbgr.mr_n58904912)
print v(xbgr.mr_n58905232)
print v(xbgr.mr_n58905344)
print v(xbgr.mr_n58905664)
print v(xbgr.mr_n58905776)
print v(xbgr.mr_n58906096)
print v(xbgr.mr_n58906208)
print v(xbgr.mr_n58906528)
print v(xbgr.mr_n58906640)
print v(xbgr.mr_n58906960)
print v(xbgr.mr_n58907072)
print v(xbgr.mr_n58907392)
print v(xbgr.mr_n58907504)
print v(xbgr.mr_n58907824)
print v(xbgr.mr_n58907936)
print v(xbgr.mr_n58908256)
print v(xbgr.mr_n58908368)
print v(xbgr.mr_n58908688)
print v(xbgr.mr_n58908800)
print v(xbgr.mr_n58909120)
print v(xbgr.mr_n58909232)
print v(xbgr.mr_n58909552)
print v(xbgr.mr_n58909664)
print v(xbgr.mr_n58909984)
print v(xbgr.mr_n58910096)
print v(xbgr.mr_n58910416)
print v(xbgr.mr_n58910528)
print v(xbgr.mr_n58910848)
print v(xbgr.mr_n58910960)
print v(xbgr.mr_n58911280)
print v(xbgr.mr_n58911392)
print v(xbgr.mr_n58911712)
print v(xbgr.mr_n58911824)
print v(xbgr.mr_n58912144)
print v(xbgr.mr_n58912256)
print v(xbgr.mr_n58912576)
print v(xbgr.mr_n58912688)
print v(xbgr.mr_n58913008)
print v(xbgr.mr_n58913120)
print v(xbgr.mr_n58913552)
print v(xbgr.mr_n58913984)
print v(xbgr.mr_n58914416)
print v(xbgr.mr_n58914848)
print v(xbgr.mr_n58915280)
print v(xbgr.mr_n58915712)
print v(xbgr.mr_n58916144)
print v(xbgr.mr_n58916576)
print v(xbgr.mr_n58917008)
print v(xbgr.mr_n58917440)
print v(xbgr.mr_n58917872)
print v(xbgr.mr_n58918304)
print v(xbgr.mr_n58918736)
print v(xbgr.mr_n58919168)
print v(xbgr.mr_n58919600)
print v(xbgr.mr_n58920032)
print v(xbgr.mr_n58920352)
print v(xbgr.mr_n58920464)
print v(xbgr.mr_n58920784)
print v(xbgr.mr_n58920896)
print v(xbgr.mr_n58921328)
print v(xbgr.mr_n58921760)
print v(xbgr.mr_n58922192)
print v(xbgr.mr_n58922624)
print v(xbgr.mr_n58923056)
print v(xbgr.mr_n58923488)
print v(xbgr.mr_n58923920)
print v(xbgr.mr_n58924352)
print v(xbgr.mr_n58924784)
print v(xbgr.mr_n58925216)
print v(xbgr.mr_n58925536)
print v(xbgr.mr_n58925648)
print v(xbgr.mr_n58925968)
print v(xbgr.mr_n58926080)
print v(xbgr.mr_n58926400)
print v(xbgr.mr_n58926512)
print v(xbgr.mr_n58926832)
print v(xbgr.mr_n58926944)
print v(xbgr.mr_n58927264)
print v(xbgr.mr_n58927376)
print v(xbgr.mr_n58927696)
print v(xbgr.mr_n58927808)
print v(xbgr.mr_n58928128)
print v(xbgr.mr_n58928240)
print v(xbgr.mr_n58928560)
print v(xbgr.mr_n58928672)
print v(xbgr.mr_n58928992)
print v(xbgr.mr_n58929104)
print v(xbgr.mr_n58929424)
print v(xbgr.mr_n58929536)
print v(xbgr.mr_n58929856)
print v(xbgr.mr_n58929968)
print v(xbgr.mr_n58930288)
print v(xbgr.mr_n58930400)
print v(xbgr.mr_n58930720)
print v(xbgr.mr_n58930832)
print v(xbgr.mr_n58931264)
print v(xbgr.mr_n58931696)
print v(xbgr.mr_n58932128)
print v(xbgr.mr_n58932560)
print v(xbgr.mr_n58932992)
print v(xbgr.mr_n58933424)
print v(xbgr.mr_n58933856)
print v(xbgr.mr_n58934288)
print v(xbgr.mr_n58934720)
print v(xbgr.mr_n58935152)
print v(xbgr.mr_n58935584)
print v(xbgr.mr_n58936016)
print v(xbgr.mr_n58936448)
print v(xbgr.mr_n58936768)
print v(xbgr.mr_n58936880)
print v(xbgr.mr_n58937200)
print v(xbgr.mr_n58937312)
print v(xbgr.mr_n58937632)
print v(xbgr.mr_n58937744)
print v(xbgr.mr_n58938064)
print v(xbgr.mr_n58938176)
print v(xbgr.mr_n58938496)
print v(xbgr.mr_n58938608)
print v(xbgr.mr_n58938928)
print v(xbgr.mr_n58939040)
print v(xbgr.mr_n58939360)
print v(xbgr.mr_n58939472)
print v(xbgr.mr_n58939792)
print v(xbgr.mr_n58939904)
print v(xbgr.mr_n58940224)
print v(xbgr.mr_n58940336)
print v(xbgr.mr_n58940656)
print v(xbgr.mr_n58940768)
print v(xbgr.mr_n58941088)
print v(xbgr.mr_n58941200)
print v(xbgr.mr_n58941520)
print v(xbgr.mr_n58941632)
print v(xbgr.mr_n58941952)
print v(xbgr.mr_n58942064)
print v(xbgr.mr_n58942496)
print v(xbgr.mr_n58942928)
print v(xbgr.mr_n58943360)
print v(xbgr.mr_n58943792)
print v(xbgr.mr_n58944224)
print v(xbgr.mr_n58944656)
print v(xbgr.mr_n58945088)
print v(xbgr.mr_n58945520)
print v(xbgr.mr_n58945952)
print v(xbgr.mr_n58946384)
print v(xbgr.mr_n58946816)
print v(xbgr.mr_n58947248)
print v(xbgr.mr_n58947680)
print v(xbgr.mr_n58948000)
print v(xbgr.mr_n58948112)
print v(xbgr.mr_n58948432)
print v(xbgr.mr_n58948544)
print v(xbgr.mr_n58948864)
print v(xbgr.mr_n58948976)
print v(xbgr.mr_n58949296)
print v(xbgr.mr_n58949408)
print v(xbgr.mr_n58949728)
print v(xbgr.mr_n58949840)
print v(xbgr.mr_n58950160)
print v(xbgr.mr_n58950272)
print v(xbgr.mr_n58950592)
print v(xbgr.mr_n58950704)
print v(xbgr.mr_n58951024)
print v(xbgr.mr_n58951136)
print v(xbgr.mr_n58951456)
print v(xbgr.mr_n58951568)
print v(xbgr.mr_n58951888)
print v(xbgr.mr_n58952000)
print v(xbgr.mr_n58952320)
print v(xbgr.mr_n58952432)
print v(xbgr.mr_n58952752)
print v(xbgr.mr_n58952864)
print v(xbgr.mr_n58953184)
print v(xbgr.mr_n58953296)
print v(xbgr.mr_n58953728)
print v(xbgr.mr_n58954160)
print v(xbgr.mr_n58954592)
print v(xbgr.mr_n58955024)
print v(xbgr.mr_n58955456)
print v(xbgr.mr_n58955888)
print v(xbgr.mr_n58956320)
print v(xbgr.mr_n58956752)
print v(xbgr.mr_n58957184)
print v(xbgr.mr_n58957616)
print v(xbgr.mr_n58958048)
print v(xbgr.mr_n58958480)
print v(xbgr.mr_n58958912)
print v(xbgr.mr_n58959232)
print v(xbgr.mr_n58959344)
print v(xbgr.mr_n58959664)
print v(xbgr.mr_n58959776)
print v(xbgr.mr_n58960096)
print v(xbgr.mr_n58960208)
print v(xbgr.mr_n58960528)
print v(xbgr.mr_n58960640)
print v(xbgr.mr_n58960960)
print v(xbgr.mr_n58961072)
print v(xbgr.mr_n58961392)
print v(xbgr.mr_n58961504)
print v(xbgr.mr_n58961824)
print v(xbgr.mr_n58961936)
print v(xbgr.mr_n58962256)
print v(xbgr.mr_n58962368)
print v(xbgr.mr_n58962688)
print v(xbgr.mr_n58962800)
print v(xbgr.mr_n58963120)
print v(xbgr.mr_n58963232)
print v(xbgr.mr_n58963552)
print v(xbgr.mr_n58963664)
print v(xbgr.mr_n58963984)
print v(xbgr.mr_n58964096)
print v(xbgr.mr_n58964416)
print v(xbgr.mr_n58964528)
print v(xbgr.mr_n58964960)
print v(xbgr.mr_n58965392)
print v(xbgr.mr_n58965824)
print v(xbgr.mr_n58966256)
print v(xbgr.mr_n58966688)
print v(xbgr.mr_n58967120)
print v(xbgr.mr_n58967552)
print v(xbgr.mr_n58967984)
print v(xbgr.mr_n58968416)
print v(xbgr.mr_n58968848)
print v(xbgr.mr_n58969280)
print v(xbgr.mr_n58969712)
print v(xbgr.mr_n58970144)
print v(xbgr.mr_n58970464)
print v(xbgr.mr_n58970576)
print v(xbgr.mr_n58970896)
print v(xbgr.mr_n58971008)
print v(xbgr.mr_n58971328)
print v(xbgr.mr_n58971440)
print v(xbgr.mr_n58971760)
print v(xbgr.mr_n58971872)
print v(xbgr.mr_n58972192)
print v(xbgr.mr_n58972304)
print v(xbgr.mr_n58972736)
print v(xbgr.mr_n58973168)
print v(xbgr.mr_n58973600)
print v(xbgr.mr_n58974032)
print v(xbgr.mr_n58974464)
print v(xbgr.mr_n58974784)
print v(xbgr.mr_n58974896)
print v(xbgr.mr_n58975216)
print v(xbgr.mr_n58975328)
print v(xbgr.mr_n58975648)
print v(xbgr.mr_n58975760)
print v(xbgr.mr_n58976080)
print v(xbgr.mr_n58976192)
print v(xbgr.mr_n58976512)
print v(xbgr.mr_n58976624)
print v(xbgr.mr_n58976944)
print v(xbgr.mr_n58977056)
print v(xbgr.mr_n58977376)
print v(xbgr.mr_n58977488)
print v(xbgr.mr_n58977808)
print v(xbgr.mr_n58977920)
print v(xbgr.mr_n58978352)
print v(xbgr.mr_n58978784)
print v(xbgr.mr_n58979216)
print v(xbgr.mr_n58979648)
print v(xbgr.mr_n58980080)
print v(xbgr.mr_n58980512)
print v(xbgr.mr_n58980944)
print v(xbgr.mr_n58981376)
print v(xbgr.mr_n58981696)
print v(xbgr.mr_n58981808)
print v(xbgr.mr_n58982128)
print v(xbgr.mr_n58982240)
print v(xbgr.mr_n58982560)
print v(xbgr.mr_n58982672)
print v(xbgr.mr_n58982992)
print v(xbgr.mr_n58983104)
print v(xbgr.mr_n58983424)
print v(xbgr.mr_n58983536)
print v(xbgr.mr_n58983856)
print v(xbgr.mr_n58983968)
print v(xbgr.mr_n58984288)
print v(xbgr.mr_n58984400)
print v(xbgr.mr_n58984720)
print v(xbgr.mr_n58984832)
print v(xbgr.mr_n58985264)
print v(xbgr.mr_n58985696)
print v(xbgr.mr_n58986128)
print v(xbgr.mr_n58986560)
print v(xbgr.mr_n58986992)
print v(xbgr.mr_n58987312)
print v(xbgr.mr_n58987424)
print v(xbgr.mr_n58987744)
print v(xbgr.mr_n58987856)
print v(xbgr.mr_n58988176)
print v(xbgr.mr_n58988288)
print v(xbgr.mr_n58988608)
print v(xbgr.mr_n58988720)
print v(xbgr.mr_n58989040)
print v(xbgr.mr_n58989152)
print v(xbgr.mr_n58989584)
print v(xbgr.mr_n58990016)
print v(xbgr.mr_n58990448)
print v(xbgr.mr_n58990880)
print v(xbgr.mr_n58991312)
print v(xbgr.mr_n58991744)
print v(xbgr.mr_n58992176)
print v(xbgr.mr_n58992608)
print v(xbgr.mr_n58992928)
print v(xbgr.mr_n58993040)
print v(xbgr.mr_n58993360)
print v(xbgr.mr_n58993472)
print v(xbgr.mr_n58993792)
print v(xbgr.mr_n58993904)
print v(xbgr.mr_n58994224)
print v(xbgr.mr_n58994336)
print v(xbgr.mr_n58994656)
print v(xbgr.mr_n58994768)
print v(xbgr.mr_n58995088)
print v(xbgr.mr_n58995200)
print v(xbgr.mr_n58995520)
print v(xbgr.mr_n58995632)
print v(xbgr.mr_n58996064)
print v(xbgr.mr_n58996496)
print v(xbgr.mr_n58996928)
print v(xbgr.mr_n58997360)
print v(xbgr.mr_n58997680)
print v(xbgr.mr_n58997792)
print v(xbgr.mr_n58998224)
print v(xbgr.mr_n58998656)
print v(xbgr.mr_n58998976)
print v(xbgr.mr_n58999088)
print v(xbgr.mr_n58999408)
print v(xbgr.mr_n58999520)
print v(xbgr.mr_n58999840)
print v(xbgr.mr_n58999952)
print v(xbgr.mr_n59000272)
print v(xbgr.mr_n59000384)
print v(xbgr.mr_n59000704)
print v(xbgr.mr_n59000816)
print v(xbgr.mr_n59001248)
print v(xbgr.mr_n59001680)
print v(xbgr.mr_n59002112)
print v(xbgr.mr_n59002544)
print v(xbgr.mr_n59002976)
print v(xbgr.mr_n59003408)
print v(xbgr.mr_n59003840)
print v(xbgr.mr_n59004160)
print v(xbgr.mr_n59004272)
print v(xbgr.mr_n59004592)
print v(xbgr.mr_n59004704)
print v(xbgr.mr_n59005024)
print v(xbgr.mr_n59005136)
print v(xbgr.mr_n59005456)
print v(xbgr.mr_n59005568)
print v(xbgr.mr_n59005888)
print v(xbgr.mr_n59006000)
print v(xbgr.mr_n59006320)
print v(xbgr.mr_n59006432)
print v(xbgr.mr_n59006752)
print v(xbgr.mr_n59006864)
print v(xbgr.mr_n59007184)
print v(xbgr.mr_n59007296)
print v(xbgr.mr_n59007616)
print v(xbgr.mr_n59007728)
print v(xbgr.mr_n59008048)
print v(xbgr.mr_n59008160)
print v(xbgr.mr_n59008480)
print v(xbgr.mr_n59008592)
print v(xbgr.mr_n59008912)
print v(xbgr.mr_n59009024)
print v(xbgr.mr_n59009344)
print v(xbgr.mr_n59009456)
print v(xbgr.mr_n59009888)
print v(xbgr.mr_n59010320)
print v(xbgr.mr_n59010752)
print v(xbgr.mr_n59011184)
print v(xbgr.mr_n59011616)
print v(xbgr.mr_n59012048)
print v(xbgr.mr_n59012480)
print v(xbgr.mr_n59012912)
print v(xbgr.mr_n59013344)
print v(xbgr.mr_n59013776)
print v(xbgr.mr_n59014208)
print v(xbgr.mr_n59014640)
print v(xbgr.mr_n59015072)
print v(xbgr.mr_n59015392)
print v(xbgr.mr_n59015504)
print v(xbgr.mr_n59015824)
print v(xbgr.mr_n59015936)
print v(xbgr.mr_n59016256)
print v(xbgr.mr_n59016368)
print v(xbgr.mr_n59016688)
print v(xbgr.mr_n59016800)
print v(xbgr.mr_n59017120)
print v(xbgr.mr_n59017232)
print v(xbgr.mr_n59017552)
print v(xbgr.mr_n59017664)
print v(xbgr.mr_n59017984)
print v(xbgr.mr_n59018096)
print v(xbgr.mr_n59018416)
print v(xbgr.mr_n59018528)
print v(xbgr.mr_n59018848)
print v(xbgr.mr_n59018960)
print v(xbgr.mr_n59019280)
print v(xbgr.mr_n59019392)
print v(xbgr.mr_n59019712)
print v(xbgr.mr_n59019824)
print v(xbgr.mr_n59020144)
print v(xbgr.mr_n59020256)
print v(xbgr.mr_n59020576)
print v(xbgr.mr_n59020688)
print v(xbgr.mr_n59021008)
print v(xbgr.mr_n59021120)
print v(xbgr.mr_n59021440)
print v(xbgr.mr_n59021552)
print v(xbgr.mr_n59021872)
print v(xbgr.mr_n59021984)
print v(xbgr.mr_n59022416)
print v(xbgr.mr_n59022848)
print v(xbgr.mr_n59023280)
print v(xbgr.mr_n59023712)
print v(xbgr.mr_n59024144)
print v(xbgr.mr_n59024576)
print v(xbgr.mr_n59024896)
print v(xbgr.mr_n59025008)
print v(xbgr.mr_n59025328)
print v(xbgr.mr_n59025440)
print v(xbgr.mr_n59025760)
print v(xbgr.mr_n59025872)
print v(xbgr.mr_n59026192)
print v(xbgr.mr_n59026304)
print v(xbgr.mr_n59026624)
print v(xbgr.mr_n59026736)
print v(xbgr.mr_n59027056)
print v(xbgr.mr_n59027168)
print v(xbgr.mr_n59027488)
print v(xbgr.mr_n59027600)
print v(xbgr.mr_n59027920)
print v(xbgr.mr_n59028032)
print v(xbgr.mr_n59028352)
print v(xbgr.mr_n59028464)
print v(xbgr.mr_n59028784)
print v(xbgr.mr_n59028896)
print v(xbgr.mr_n59029328)
print v(xbgr.mr_n59029760)
print v(xbgr.mr_n59030192)
print v(xbgr.mr_n59030624)
print v(xbgr.mr_n59031056)
print v(xbgr.mr_n59031488)
print v(xbgr.mr_n59031920)
print v(xbgr.mr_n59032352)
print v(xbgr.mr_n59032784)
print v(xbgr.mr_n59033216)
print v(xbgr.mr_n59033648)
print v(xbgr.mr_n59034080)
print v(xbgr.mr_n59034512)
print v(xbgr.mr_n59034944)
print v(xbgr.mr_n59035376)
print v(xbgr.mr_n59035808)
print v(xbgr.mr_n59036240)
print v(xbgr.mr_n59036672)
print v(xbgr.mr_n59037104)
print v(xbgr.mr_n59037536)
print v(xbgr.mr_n59037856)
print v(xbgr.mr_n59037968)
print v(xbgr.mr_n59038288)
print v(xbgr.mr_n59038400)
print v(xbgr.mr_n59038720)
print v(xbgr.mr_n59038832)
print v(xbgr.mr_n59039152)
print v(xbgr.mr_n59039264)
print v(xbgr.mr_n59039584)
print v(xbgr.mr_n59039696)
print v(xbgr.mr_n59040016)
print v(xbgr.mr_n59040128)
print v(xbgr.mr_n59040448)
print v(xbgr.mr_n59040560)
print v(xbgr.mr_n59040880)
print v(xbgr.mr_n59040992)
print v(xbgr.mr_n59041312)
print v(xbgr.mr_n59041424)
print v(xbgr.mr_n59041744)
print v(xbgr.mr_n59041856)
print v(xbgr.mr_n59042176)
print v(xbgr.mr_n59042288)
print v(xbgr.mr_n59042608)
print v(xbgr.mr_n59042720)
print v(xbgr.mr_n59043040)
print v(xbgr.mr_n59043152)
print v(xbgr.mr_n59043472)
print v(xbgr.mr_n59043584)
print v(xbgr.mr_n59044016)
print v(xbgr.mr_n59044448)
print v(xbgr.mr_n59044880)
print v(xbgr.mr_n59045312)
print v(xbgr.mr_n59045632)
print v(xbgr.mr_n59045744)
print v(xbgr.mr_n59046064)
print v(xbgr.mr_n59046176)
print v(xbgr.mr_n59046496)
print v(xbgr.mr_n59046608)
print v(xbgr.mr_n59046928)
print v(xbgr.mr_n59047040)
print v(xbgr.mr_n59047360)
print v(xbgr.mr_n59047472)
print v(xbgr.mr_n59047792)
print v(xbgr.mr_n59047904)
print v(xbgr.mr_n59048336)
print v(xbgr.mr_n59048768)
print v(xbgr.mr_n59049200)
print v(xbgr.mr_n59049632)
print v(xbgr.mr_n59050064)
print v(xbgr.mr_n59050496)
print v(xbgr.mr_n59050928)
print v(xbgr.mr_n59051360)
print v(xbgr.mr_n59051792)
print v(xbgr.mr_n59052224)
print v(xbgr.mr_n59052544)
print v(xbgr.mr_n59052656)
print v(xbgr.mr_n59052976)
print v(xbgr.mr_n59053088)
print v(xbgr.mr_n59053520)
print v(xbgr.mr_n59053952)
print v(xbgr.mr_n59054272)
print v(xbgr.mr_n59054384)
print v(xbgr.mr_n59054704)
print v(xbgr.mr_n59054816)
print v(xbgr.mr_n59055136)
print v(xbgr.mr_n59055248)
print v(xbgr.mr_n59055568)
print v(xbgr.mr_n59055680)
print v(xbgr.mr_n59056112)
print v(xbgr.mr_n59056544)
print v(xbgr.mr_n59056976)
print v(xbgr.mr_n59057408)
print v(xbgr.mr_n59057840)
print v(xbgr.mr_n59058272)
print v(xbgr.mr_n59058704)
print v(xbgr.mr_n59059136)
print v(xbgr.mr_n59059568)
print v(xbgr.mr_n59060000)
print v(xbgr.mr_n59060320)
print v(xbgr.mr_n59060432)
print v(xbgr.mr_n59060752)
print v(xbgr.mr_n59060864)
print v(xbgr.mr_n59061184)
print v(xbgr.mr_n59061296)
print v(xbgr.mr_n59061616)
print v(xbgr.mr_n59061728)
print v(xbgr.mr_n59062048)
print v(xbgr.mr_n59062160)
print v(xbgr.mr_n59062480)
print v(xbgr.mr_n59062592)
print v(xbgr.mr_n59062912)
print v(xbgr.mr_n59063024)
print v(xbgr.mr_n59063344)
print v(xbgr.mr_n59063456)
print v(xbgr.mr_n59063776)
print v(xbgr.mr_n59063888)
print v(xbgr.mr_n59064208)
print v(xbgr.mr_n59064320)
print v(xbgr.mr_n59064640)
print v(xbgr.mr_n59064752)
print v(xbgr.mr_n59065072)
print v(xbgr.mr_n59065184)
print v(xbgr.mr_n59065504)
print v(xbgr.mr_n59065616)
print v(xbgr.mr_n59065936)
print v(xbgr.mr_n59066048)
print v(xbgr.mr_n59066368)
print v(xbgr.mr_n59066480)
print v(xbgr.mr_n59066800)
print v(xbgr.mr_n59066912)
print v(xbgr.mr_n59067232)
print v(xbgr.mr_n59067344)
print v(xbgr.mr_n59067664)
print v(xbgr.mr_n59067776)
print v(xbgr.mr_n59068096)
print v(xbgr.mr_n59068208)
print v(xbgr.mr_n59068528)
print v(xbgr.mr_n59068640)
print v(xbgr.mr_n59068960)
print v(xbgr.mr_n59069072)
print v(xbgr.mr_n59069392)
print v(xbgr.mr_n59069824)
print v(xbgr.mr_n59069936)
print v(xbgr.mr_n59070256)
print v(xbgr.mr_n59070688)
print v(xbgr.mr_n59070800)
print v(xbgr.mr_n59071120)
print v(xbgr.mr_n59071552)
print v(xbgr.mr_n59071664)
print v(xbgr.mr_n59071984)
print v(xbgr.mr_n59072416)
print v(xbgr.mr_n59072528)
print v(xbgr.mr_n59072848)
print v(xbgr.mr_n59073280)
print v(xbgr.mr_n59073392)
print v(xbgr.mr_n59073712)
print v(xbgr.mr_n59073824)
print v(xbgr.mr_n59074144)
print v(xbgr.mr_n59074256)
print v(xbgr.mr_n59074576)
print v(xbgr.mr_n59074688)
print v(xbgr.mr_n59075008)
print v(xbgr.mr_n59075120)
print v(xbgr.mr_n59075440)
print v(xbgr.mr_n59075552)
print v(xbgr.mr_n59075872)
print v(xbgr.mr_n59075984)
print v(xbgr.mr_n59076304)
print v(xbgr.mr_n59076416)
print v(xbgr.mr_n59076736)
print v(xbgr.mr_n59076848)
print v(xbgr.mr_n59077168)
print v(xbgr.mr_n59077280)
print v(xbgr.mr_n59077600)
print v(xbgr.mr_n59077712)
print v(xbgr.mr_n59078032)
print v(xbgr.mr_n59078144)
print v(xbgr.mr_n59078464)
print v(xbgr.mr_n59078576)
print v(xbgr.mr_n59078896)
print v(xbgr.mr_n59079008)
print v(xbgr.mr_n59079328)
print v(xbgr.mr_n59079440)
print v(xbgr.mr_n59079760)
print v(xbgr.mr_n59079872)
print v(xbgr.mr_n59080192)
print v(xbgr.mr_n59080304)
print v(xbgr.mr_n59080624)
print v(xbgr.mr_n59080736)
print v(xbgr.mr_n59081056)
print v(xbgr.mr_n59081168)
print v(xbgr.mr_n59081488)
print v(xbgr.mr_n59081600)
print v(xbgr.mr_n59081920)
print v(xbgr.mr_n59082032)
print v(xbgr.mr_n59082352)
print v(xbgr.mr_n59082464)
print v(xbgr.mr_n59082784)
print v(xbgr.mr_n59082896)
print v(xbgr.mr_n59083216)
print v(xbgr.mr_n59083328)
print v(xbgr.mr_n59083648)
print v(xbgr.mr_n59083760)
print v(xbgr.mr_n59084080)
print v(xbgr.mr_n59084192)
print v(xbgr.mr_n59084512)
print v(xbgr.mr_n59084624)
print v(xbgr.mr_n59084944)
print v(xbgr.mr_n59085056)
print v(xbgr.mr_n59085376)
print v(xbgr.mr_n59085488)
print v(xbgr.mr_n59085808)
print v(xbgr.mr_n59085920)
print v(xbgr.mr_n59086240)
print v(xbgr.mr_n59086352)
print v(xbgr.mr_n59086672)
print v(xbgr.mr_n59086784)
print v(xbgr.mr_n59087104)
print v(xbgr.mr_n59087216)
print v(xbgr.mr_n59087536)
print v(xbgr.mr_n59087648)
print v(xbgr.mr_n59087968)
print v(xbgr.mr_n59088080)
print v(xbgr.mr_n59088400)
print v(xbgr.mr_n59088512)
print v(xbgr.mr_n59088832)
print v(xbgr.mr_n59088944)
print v(xbgr.mr_n59089264)
print v(xbgr.mr_n59089376)
print v(xbgr.mr_n59089696)
print v(xbgr.mr_n59089808)
print v(xbgr.mr_n59090128)
print v(xbgr.mr_n59090240)
print v(xbgr.mr_n59090560)
print v(xbgr.mr_n59090672)
print v(xbgr.mr_n59090992)
print v(xbgr.mr_n59091104)
print v(xbgr.mr_n59091424)
print v(xbgr.mr_n59091536)
print v(xbgr.mr_n59091856)
print v(xbgr.mr_n59091968)
print v(xbgr.mr_n59092288)
print v(xbgr.mr_n59092400)
print v(xbgr.mr_n59092720)
print v(xbgr.mr_n59092832)
print v(xbgr.mr_n59093152)
print v(xbgr.mr_n59093264)
print v(xbgr.mr_n59093584)
print v(xbgr.mr_n59093696)
print v(xbgr.mr_n59094016)
print v(xbgr.mr_n59094128)
print v(xbgr.mr_n59094448)
print v(xbgr.mr_n59094560)
print v(xbgr.mr_n59094880)
print v(xbgr.mr_n59094992)
print v(xbgr.mr_n59095312)
print v(xbgr.mr_n59095424)
print v(xbgr.mr_n59095744)
print v(xbgr.mr_n59095856)
print v(xbgr.mr_n59096176)
print v(xbgr.mr_n59096288)
print v(xbgr.mr_n59096608)
print v(xbgr.mr_n59096720)
print v(xbgr.mr_n59097040)
print v(xbgr.mr_n59097152)
print v(xbgr.mr_n59097472)
print v(xbgr.mr_n59097584)
print v(xbgr.mr_n59097904)
print v(xbgr.mr_n59098016)
print v(xbgr.mr_n59098336)
print v(xbgr.mr_n59098448)
print v(xbgr.mr_n59098768)
print v(xbgr.mr_n59098880)
print v(xbgr.mr_n59099200)
print v(xbgr.mr_n59099312)
print v(xbgr.mr_n59099632)
print v(xbgr.mr_n59099744)
print v(xbgr.mr_n59100064)
print v(xbgr.mr_n59100176)
print v(xbgr.mr_n59100496)
print v(xbgr.mr_n59100608)
print v(xbgr.mr_n59100928)
print v(xbgr.mr_n59101040)
print v(xbgr.mr_n59101360)
print v(xbgr.mr_n59101472)
print v(xbgr.mr_n59101792)
print v(xbgr.mr_n59101904)
print v(xbgr.mr_n59102224)
print v(xbgr.mr_n59102336)
print v(xbgr.mr_n59102656)
print v(xbgr.mr_n59102768)
print v(xbgr.mr_n59103088)
print v(xbgr.mr_n59103200)
print v(xbgr.mr_n59103520)
print v(xbgr.mr_n59103632)
print v(xbgr.mr_n59103952)
print v(xbgr.mr_n59104064)
print v(xbgr.mr_n59104384)
print v(xbgr.mr_n59104816)
print v(xbgr.mr_n59104928)
print v(xbgr.mr_n59105248)
print v(xbgr.mr_n59105680)
print v(xbgr.mr_n59105792)
print v(xbgr.mr_n59106112)
print v(xbgr.mr_n59106544)
print v(xbgr.mr_n59106656)
print v(xbgr.mr_n59106976)
print v(xbgr.mr_n59107408)
print v(xbgr.mr_n59107520)
print v(xbgr.mr_n59107840)
print v(xbgr.mr_n59107952)
print v(xbgr.mr_n59108272)
print v(xbgr.mr_n59108384)
print v(xbgr.mr_n59108704)
print v(xbgr.mr_n59108816)
print v(xbgr.mr_n59109136)
print v(xbgr.mr_n59109568)
print v(xbgr.mr_n59109680)
print v(xbgr.mr_n59110000)
print v(xbgr.mr_n59110432)
print v(xbgr.mr_n59110544)
print v(xbgr.mr_n59110864)
print v(xbgr.mr_n59111296)
print v(xbgr.mr_n59111408)
print v(xbgr.mr_n59111728)
print v(xbgr.mr_n59112160)
print v(xbgr.mr_n59112272)
print v(xbgr.mr_n59112592)
print v(xbgr.mr_n59112704)
print v(xbgr.mr_n59113024)
print v(xbgr.mr_n59113136)
print v(xbgr.mr_n59113456)
print v(xbgr.mr_n59113568)
print v(xbgr.mr_n59113888)
print v(xbgr.mr_n59114000)
print v(xbgr.mr_n59114320)
print v(xbgr.mr_n59114432)
print v(xbgr.mr_n59114752)
print v(xbgr.mr_n59114864)
print v(xbgr.mr_n59115184)
print v(xbgr.mr_n59115296)
print v(xbgr.mr_n59115616)
print v(xbgr.mr_n59115728)
print v(xbgr.mr_n59116048)
print v(xbgr.mr_n59116160)
print v(xbgr.mr_n59116480)
print v(xbgr.mr_n59116592)
print v(xbgr.mr_n59116912)
print v(xbgr.mr_n59117024)
print v(xbgr.mr_n59117344)
print v(xbgr.mr_n59117456)
print v(xbgr.mr_n59117776)
print v(xbgr.mr_n59117888)
print v(xbgr.mr_n59118208)
print v(xbgr.mr_n59118320)
print v(xbgr.mr_n59118640)
print v(xbgr.mr_n59118752)
print v(xbgr.mr_n59119072)
print v(xbgr.mr_n59119184)
print v(xbgr.mr_n59119504)
print v(xbgr.mr_n59119616)
print v(xbgr.mr_n59119936)
print v(xbgr.mr_n59120048)
print v(xbgr.mr_n59120368)
print v(xbgr.mr_n59120480)
print v(xbgr.mr_n59120800)
print v(xbgr.mr_n59120912)
print v(xbgr.mr_n59121232)
print v(xbgr.mr_n59121344)
print v(xbgr.mr_n59121664)
print v(xbgr.mr_n59121776)
print v(xbgr.mr_n59122096)
print v(xbgr.mr_n59122208)
print v(xbgr.mr_n59122528)
print v(xbgr.mr_n59122640)
print v(xbgr.mr_n59122960)
print v(xbgr.mr_n59123072)
print v(xbgr.mr_n59123392)
print v(xbgr.mr_n59123504)
print v(xbgr.mr_n59123824)
print v(xbgr.mr_n59123936)
print v(xbgr.mr_n59124368)
print v(xbgr.mr_n59124800)
print v(xbgr.mr_n59125232)
print v(xbgr.mr_n59125664)
print v(xbgr.mr_n59126096)
print v(xbgr.mr_n59126528)
print v(xbgr.mr_n59126960)
print v(xbgr.mr_n59127392)
print v(xbgr.mr_n59127824)
print v(xbgr.mr_n59128256)
print v(xbgr.mr_n59128688)
print v(xbgr.mr_n59129120)
print v(xbgr.mr_n59129552)
print v(xbgr.mr_n59129984)
print v(xbgr.mr_n59130416)
print v(xbgr.mr_n59130848)
print v(xbgr.mr_n59131280)
print v(xbgr.mr_n59131712)
print v(xbgr.mr_n59132144)
print v(xbgr.mr_n59132576)
print v(xbgr.mr_n59133008)
print v(xbgr.mr_n59133440)
print v(xbgr.mr_n59133872)
print v(xbgr.mr_n59134304)
print v(xbgr.mr_n59134736)
print v(xbgr.mr_n59135168)
print v(xbgr.mr_n59135488)
print v(xbgr.mr_n59135600)
print v(xbgr.mr_n59135920)
print v(xbgr.mr_n59136032)
print v(xbgr.mr_n59136352)
print v(xbgr.mr_n59136464)
print v(xbgr.mr_n59136784)
print v(xbgr.mr_n59136896)
print v(xbgr.mr_n59137216)
print v(xbgr.mr_n59137328)
print v(xbgr.mr_n59137648)
print v(xbgr.mr_n59137760)
print v(xbgr.mr_n59138080)
print v(xbgr.mr_n59138192)
print v(xbgr.mr_n59138512)
print v(xbgr.mr_n59138624)
print v(xbgr.mr_n59138944)
print v(xbgr.mr_n59139056)
print v(xbgr.mr_n59139376)
print v(xbgr.mr_n59139488)
print v(xbgr.mr_n59139808)
print v(xbgr.mr_n59139920)
print v(xbgr.mr_n59140240)
print v(xbgr.mr_n59140352)
print v(xbgr.mr_n59140672)
print v(xbgr.mr_n59140784)
print v(xbgr.mr_n59141104)
print v(xbgr.mr_n59141216)
print v(xbgr.mr_n59141536)
print v(xbgr.mr_n59141648)
print v(xbgr.mr_n59141968)
print v(xbgr.mr_n59142080)
print v(xbgr.mr_n59142400)
print v(xbgr.mr_n59142512)
print v(xbgr.mr_n59142832)
print v(xbgr.mr_n59142944)
print v(xbgr.mr_n59143264)
print v(xbgr.mr_n59143376)
print v(xbgr.mr_n59143696)
print v(xbgr.mr_n59143808)
print v(xbgr.mr_n59144240)
print v(xbgr.mr_n59144672)
print v(xbgr.mr_n59145104)
print v(xbgr.mr_n59145536)
print v(xbgr.mr_n59145968)
print v(xbgr.mr_n59146400)
print v(xbgr.mr_n59146832)
print v(xbgr.mr_n59147264)
print v(xbgr.mr_n59147696)
print v(xbgr.mr_n59148128)
print v(xbgr.mr_n59148560)
print v(xbgr.mr_n59148992)
print v(xbgr.mr_n59149312)
print v(xbgr.mr_n59149424)
print v(xbgr.mr_n59149744)
print v(xbgr.mr_n59149856)
print v(xbgr.mr_n59150288)
print v(xbgr.mr_n59150720)
print v(xbgr.mr_n59151152)
print v(xbgr.mr_n59151584)
print v(xbgr.mr_n59152016)
print v(xbgr.mr_n59152448)
print v(xbgr.mr_n59152880)
print v(xbgr.mr_n59153312)
print v(xbgr.mr_n59153744)
print v(xbgr.mr_n59154176)
print v(xbgr.mr_n59154496)
print v(xbgr.mr_n59154608)
print v(xbgr.mr_n59154928)
print v(xbgr.mr_n59155040)
print v(xbgr.mr_n59155360)
print v(xbgr.mr_n59155472)
print v(xbgr.mr_n59155792)
print v(xbgr.mr_n59155904)
print v(xbgr.mr_n59156224)
print v(xbgr.mr_n59156336)
print v(xbgr.mr_n59156656)
print v(xbgr.mr_n59156768)
print v(xbgr.mr_n59157088)
print v(xbgr.mr_n59157200)
print v(xbgr.mr_n59157520)
print v(xbgr.mr_n59157632)
print v(xbgr.mr_n59157952)
print v(xbgr.mr_n59158064)
print v(xbgr.mr_n59158384)
print v(xbgr.mr_n59158496)
print v(xbgr.mr_n59158816)
print v(xbgr.mr_n59158928)
print v(xbgr.mr_n59159248)
print v(xbgr.mr_n59159360)
print v(xbgr.mr_n59159680)
print v(xbgr.mr_n59159792)
print v(xbgr.mr_n59160112)
print v(xbgr.mr_n59160224)
print v(xbgr.mr_n59160544)
print v(xbgr.mr_n59160656)
print v(xbgr.mr_n59160976)
print v(xbgr.mr_n59161088)
print v(xbgr.mr_n59161408)
print v(xbgr.mr_n59161520)
print v(xbgr.mr_n59161840)
print v(xbgr.mr_n59161952)
print v(xbgr.mr_n59162272)
print v(xbgr.mr_n59162384)
print v(xbgr.mr_n59162704)
print v(xbgr.mr_n59162816)
print v(xbgr.mr_n59163136)
print v(xbgr.mr_n59163248)
print v(xbgr.mr_n59163568)
print v(xbgr.mr_n59163680)
print v(xbgr.mr_n59164000)
print v(xbgr.mr_n59164112)
print v(xbgr.mr_n59164432)
print v(xbgr.mr_n59164544)
print v(xbgr.mr_n59164864)
print v(xbgr.mr_n59164976)
print v(xbgr.mr_n59165296)
print v(xbgr.mr_n59165408)
print v(xbgr.mr_n59165728)
print v(xbgr.mr_n59166160)
print v(xbgr.mr_n59166272)
print v(xbgr.mr_n59166592)
print v(xbgr.mr_n59167024)
print v(xbgr.mr_n59167136)
print v(xbgr.mr_n59167456)
print v(xbgr.mr_n59167888)
print v(xbgr.mr_n59168000)
print v(xbgr.mr_n59168320)
print v(xbgr.mr_n59168752)
print v(xbgr.mr_n59168864)
print v(xbgr.mr_n59169184)
print v(xbgr.mr_n59169616)
print v(xbgr.mr_n59169728)
print v(xbgr.mr_n59170048)
print v(xbgr.mr_n59170160)
print v(xbgr.mr_n59170480)
print v(xbgr.mr_n59170592)
print v(xbgr.mr_n59170912)
print v(xbgr.mr_n59171024)
print v(xbgr.mr_n59171344)
print v(xbgr.mr_n59171456)
print v(xbgr.mr_n59171776)
print v(xbgr.mr_n59171888)
print v(xbgr.mr_n59172208)
print v(xbgr.mr_n59172320)
print v(xbgr.mr_n59172640)
print v(xbgr.mr_n59172752)
print v(xbgr.mr_n59173072)
print v(xbgr.mr_n59173184)
print v(xbgr.mr_n59173504)
print v(xbgr.mr_n59173616)
print v(xbgr.mr_n59173936)
print v(xbgr.mr_n59174048)
print v(xbgr.mr_n59174368)
print v(xbgr.mr_n59174480)
print v(xbgr.mr_n59174800)
print v(xbgr.mr_n59174912)
print v(xbgr.mr_n59175232)
print v(xbgr.mr_n59175344)
print v(xbgr.mr_n59175664)
print v(xbgr.mr_n59175776)
print v(xbgr.mr_n59176096)
print v(xbgr.mr_n59176208)
print v(xbgr.mr_n59176528)
print v(xbgr.mr_n59176640)
print v(xbgr.mr_n59176960)
print v(xbgr.mr_n59177072)
print v(xbgr.mr_n59177392)
print v(xbgr.mr_n59177504)
print v(xbgr.mr_n59177824)
print v(xbgr.mr_n59177936)
print v(xbgr.mr_n59178256)
print v(xbgr.mr_n59178368)
print v(xbgr.mr_n59178688)
print v(xbgr.mr_n59178800)
print v(xbgr.mr_n59179120)
print v(xbgr.mr_n59179232)
print v(xbgr.mr_n59179552)
print v(xbgr.mr_n59179664)
print v(xbgr.mr_n59179984)
print v(xbgr.mr_n59180096)
print v(xbgr.mr_n59180416)
print v(xbgr.mr_n59180528)
print v(xbgr.mr_n59180848)
print v(xbgr.mr_n59180960)
print v(xbgr.mr_n59181280)
print v(xbgr.mr_n59181392)
print v(xbgr.mr_n59181712)
print v(xbgr.mr_n59181824)
print v(xbgr.mr_n59182144)
print v(xbgr.mr_n59182256)
print v(xbgr.mr_n59182576)
print v(xbgr.mr_n59182688)
print v(xbgr.mr_n59183008)
print v(xbgr.mr_n59183120)
print v(xbgr.mr_n59183440)
print v(xbgr.mr_n59183552)
print v(xbgr.mr_n59183872)
print v(xbgr.mr_n59183984)
print v(xbgr.mr_n59184304)
print v(xbgr.mr_n59184416)
print v(xbgr.mr_n59184736)
print v(xbgr.mr_n59184848)
print v(xbgr.mr_n59185168)
print v(xbgr.mr_n59185280)
print v(xbgr.mr_n59185600)
print v(xbgr.mr_n59185712)
print v(xbgr.mr_n59186032)
print v(xbgr.mr_n59186144)
print v(xbgr.mr_n59186464)
print v(xbgr.mr_n59186576)
print v(xbgr.mr_n59186896)
print v(xbgr.mr_n59187008)
print v(xbgr.mr_n59187328)
print v(xbgr.mr_n59187440)
print v(xbgr.mr_n59187760)
print v(xbgr.mr_n59187872)
print v(xbgr.mr_n59188192)
print v(xbgr.mr_n59188624)
print v(xbgr.mr_n59188736)
print v(xbgr.mr_n59189056)
print v(xbgr.mr_n59189168)
print v(xbgr.mr_n59189488)
print v(xbgr.mr_n59189600)
print v(xbgr.mr_n59189920)
print v(xbgr.mr_n59190352)
print v(xbgr.mr_n59190464)
print v(xbgr.mr_n59190784)
print v(xbgr.mr_n59191216)
print v(xbgr.mr_n59191328)
print v(xbgr.mr_n59191648)
print v(xbgr.mr_n59191760)
print v(xbgr.mr_n59192080)
print v(xbgr.mr_n59192192)
print v(xbgr.mr_n59192512)
print v(xbgr.mr_n59192624)
print v(xbgr.mr_n59192944)
print v(xbgr.mr_n59193056)
print v(xbgr.mr_n59193376)
print v(xbgr.mr_n59193488)
print v(xbgr.mr_n59193808)
print v(xbgr.mr_n59193920)
print v(xbgr.mr_n59194240)
print v(xbgr.mr_n59194352)
print v(xbgr.mr_n59194672)
print v(xbgr.mr_n59194784)
print v(xbgr.mr_n59195104)
print v(xbgr.mr_n59195216)
print v(xbgr.mr_n59195536)
print v(xbgr.mr_n59195648)
print v(xbgr.mr_n59195968)
print v(xbgr.mr_n59196080)
print v(xbgr.mr_n59196400)
print v(xbgr.mr_n59196512)
print v(xbgr.mr_n59196832)
print v(xbgr.mr_n59197264)
print v(xbgr.mr_n59197376)
print v(xbgr.mr_n59197696)
print v(xbgr.mr_n59197808)
print v(xbgr.mr_n59198128)
print v(xbgr.mr_n59198240)
print v(xbgr.mr_n59198560)
print v(xbgr.mr_n59198672)
print v(xbgr.mr_n59198992)
print v(xbgr.mr_n59199104)
print v(xbgr.mr_n59199424)
print v(xbgr.mr_n59199536)
print v(xbgr.mr_n59199856)
print v(xbgr.mr_n59199968)
print v(xbgr.mr_n59200288)
print v(xbgr.mr_n59200400)
print v(xbgr.mr_n59200720)
print v(xbgr.mr_n59200832)
print v(xbgr.mr_n59201152)
print v(xbgr.mr_n59201264)
print v(xbgr.mr_n59201584)
print v(xbgr.mr_n59201696)
print v(xbgr.mr_n59202016)
print v(xbgr.mr_n59202128)
print v(xbgr.mr_n59202448)
print v(xbgr.mr_n59202560)
print v(xbgr.mr_n59202880)
print v(xbgr.mr_n59202992)
print v(xbgr.mr_n59203312)
print v(xbgr.mr_n59203424)
print v(xbgr.mr_n59203744)
print v(xbgr.mr_n59203856)
print v(xbgr.mr_n59204176)
print v(xbgr.mr_n59204288)
print v(xbgr.mr_n59204608)
print v(xbgr.mr_n59204720)
print v(xbgr.mr_n59205040)
print v(xbgr.mr_n59205152)
print v(xbgr.mr_n59205472)
print v(xbgr.mr_n59205584)
print v(xbgr.mr_n59205904)
print v(xbgr.mr_n59206016)
print v(xbgr.mr_n59206336)
print v(xbgr.mr_n59206448)
print v(xbgr.mr_n59206768)
print v(xbgr.mr_n59206880)
print v(xbgr.mr_n59207200)
print v(xbgr.mr_n59207312)
print v(xbgr.mr_n59207632)
print v(xbgr.mr_n59207744)
print v(xbgr.mr_n59208064)
print v(xbgr.mr_n59208176)
print v(xbgr.mr_n59208496)
print v(xbgr.mr_n59208608)
print v(xbgr.mr_n59208928)
print v(xbgr.mr_n59209040)
print v(xbgr.mr_n59209360)
print v(xbgr.mr_n59209472)
print v(xbgr.mr_n59209792)
print v(xbgr.mr_n59209904)
print v(xbgr.mr_n59210224)
print v(xbgr.mr_n59210336)
print v(xbgr.mr_n59210656)
print v(xbgr.mr_n59210768)
print v(xbgr.mr_n59211088)
print v(xbgr.mr_n59211200)
print v(xbgr.mr_n59211520)
print v(xbgr.mr_n59211632)
print v(xbgr.mr_n59211952)
print v(xbgr.mr_n59212064)
print v(xbgr.mr_n59212384)
print v(xbgr.mr_n59212496)
print v(xbgr.mr_n59212816)
print v(xbgr.mr_n59212928)
print v(xbgr.mr_n59213248)
print v(xbgr.mr_n59213360)
print v(xbgr.mr_n59213680)
print v(xbgr.mr_n59213792)
print v(xbgr.mr_n59214112)
print v(xbgr.mr_n59214224)
print v(xbgr.mr_n59214544)
print v(xbgr.mr_n59214656)
print v(xbgr.mr_n59214976)
print v(xbgr.mr_n59215088)
print v(xbgr.mr_n59215408)
print v(xbgr.mr_n59215520)
print v(xbgr.mr_n59215840)
print v(xbgr.mr_n59215952)
print v(xbgr.mr_n59216272)
print v(xbgr.mr_n59216384)
print v(xbgr.mr_n59216704)
print v(xbgr.mr_n59216816)
print v(xbgr.mr_n59217136)
print v(xbgr.mr_n59217248)
print v(xbgr.mr_n59217568)
print v(xbgr.mr_n59217680)
print v(xbgr.mr_n59218000)
print v(xbgr.mr_n59218112)
print v(xbgr.mr_n59218432)
print v(xbgr.mr_n59218544)
print v(xbgr.mr_n59218976)
print v(xbgr.mr_n59219408)
print v(xbgr.mr_n59219840)
print v(xbgr.mr_n59220272)
print v(xbgr.mr_n59220704)
print v(xbgr.mr_n59221136)
print v(xbgr.mr_n59221568)
print v(xbgr.mr_n59222000)
print v(xbgr.mr_n59222320)
print v(xbgr.mr_n59222432)
print v(xbgr.mr_n59222752)
print v(xbgr.mr_n59222864)
print v(xbgr.mr_n59223184)
print v(xbgr.mr_n59223296)
print v(xbgr.mr_n59223616)
print v(xbgr.mr_n59223728)
print v(xbgr.mr_n59224048)
print v(xbgr.mr_n59224160)
print v(xbgr.mr_n59224480)
print v(xbgr.mr_n59224592)
print v(xbgr.mr_n59224912)
print v(xbgr.mr_n59225024)
print v(xbgr.mr_n59225344)
print v(xbgr.mr_n59225456)
print v(xbgr.mr_n59225888)
print v(xbgr.mr_n59226320)
print v(xbgr.mr_n59226752)
print v(xbgr.mr_n59227184)
print v(xbgr.mr_n59227616)
print v(xbgr.mr_n59228048)
print v(xbgr.mr_n59228368)
print v(xbgr.mr_n59228480)
print v(xbgr.mr_n59228912)
print v(xbgr.mr_n59229344)
print v(xbgr.mr_n59229776)
print v(xbgr.mr_n59230208)
print v(xbgr.mr_n59230640)
print v(xbgr.mr_n59231072)
print v(xbgr.mr_n59231504)
print v(xbgr.mr_n59231936)
print v(xbgr.mr_n59232368)
print v(xbgr.mr_n59232800)
print v(xbgr.mr_n59233232)
print v(xbgr.mr_n59233664)
print v(xbgr.mr_n59233984)
print v(xbgr.mr_n59234096)
print v(xbgr.mr_n59234416)
print v(xbgr.mr_n59234528)
print v(xbgr.mr_n59234848)
print v(xbgr.mr_n59234960)
print v(xbgr.mr_n59235280)
print v(xbgr.mr_n59235392)
print v(xbgr.mr_n59235712)
print v(xbgr.mr_n59235824)
print v(xbgr.mr_n59236144)
print v(xbgr.mr_n59236256)
print v(xbgr.mr_n59236576)
print v(xbgr.mr_n59236688)
print v(xbgr.mr_n59237008)
print v(xbgr.mr_n59237120)
print v(xbgr.mr_n59237440)
print v(xbgr.mr_n59237552)
print v(xbgr.mr_n59237872)
print v(xbgr.mr_n59237984)
print v(xbgr.mr_n59238304)
print v(xbgr.mr_n59238416)
print v(xbgr.mr_n59238736)
print v(xbgr.mr_n59238848)
print v(xbgr.mr_n59239168)
print v(xbgr.mr_n59239280)
print v(xbgr.mr_n59239600)
print v(xbgr.mr_n59239712)
print v(xbgr.mr_n59240032)
print v(xbgr.mr_n59240144)
print v(xbgr.mr_n59240464)
print v(xbgr.mr_n59240576)
print v(xbgr.mr_n59240896)
print v(xbgr.mr_n59241008)
print v(xbgr.mr_n59241328)
print v(xbgr.mr_n59241440)
print v(xbgr.mr_n59241760)
print v(xbgr.mr_n59241872)
print v(xbgr.mr_n59242192)
print v(xbgr.mr_n59242304)
print v(xbgr.mr_n59242624)
print v(xbgr.mr_n59242736)
print v(xbgr.mr_n59243168)
print v(xbgr.mr_n59243600)
print v(xbgr.mr_n59244032)
print v(xbgr.mr_n59244464)
print v(xbgr.mr_n59244896)
print v(xbgr.mr_n59245328)
print v(xbgr.mr_n59245760)
print v(xbgr.mr_n59246192)
print v(xbgr.mr_n59246624)
print v(xbgr.mr_n59247056)
print v(xbgr.mr_n59247488)
print v(xbgr.mr_n59247920)
print v(xbgr.mr_n59248352)
print v(xbgr.mr_n59248784)
print v(xbgr.mr_n59249216)
print v(xbgr.mr_n59249648)
print v(xbgr.mr_n59250080)
print v(xbgr.mr_n59250512)
print v(xbgr.mr_n59250944)
print v(xbgr.mr_n59251264)
print v(xbgr.mr_n59251376)
print v(xbgr.mr_n59251696)
print v(xbgr.mr_n59251808)
print v(xbgr.mr_n59252128)
print v(xbgr.mr_n59252240)
print v(xbgr.mr_n59252560)
print v(xbgr.mr_n59252672)
print v(xbgr.mr_n59252992)
print v(xbgr.mr_n59253104)
print v(xbgr.mr_n59253536)
print v(xbgr.mr_n59253968)
print v(xbgr.mr_n59254400)
print v(xbgr.mr_n59254832)
print v(xbgr.mr_n59255264)
print v(xbgr.mr_n59255696)
print v(xbgr.mr_n59256128)
print v(xbgr.mr_n59256448)
print v(xbgr.mr_n59256560)
print v(xbgr.mr_n59256880)
print v(xbgr.mr_n59256992)
print v(xbgr.mr_n59257312)
print v(xbgr.mr_n59257424)
print v(xbgr.mr_n59257744)
print v(xbgr.mr_n59257856)
print v(xbgr.mr_n59258176)
print v(xbgr.mr_n59258288)
print v(xbgr.mr_n59258608)
print v(xbgr.mr_n59258720)
print v(xbgr.mr_n59259040)
print v(xbgr.mr_n59259152)
print v(xbgr.mr_n59259472)
print v(xbgr.mr_n59259584)
print v(xbgr.mr_n59259904)
print v(xbgr.mr_n59260016)
print v(xbgr.mr_n59260336)
print v(xbgr.mr_n59260448)
print v(xbgr.mr_n59260768)
print v(xbgr.mr_n59260880)
print v(xbgr.mr_n59261200)
print v(xbgr.mr_n59261312)
print v(xbgr.mr_n59261632)
print v(xbgr.mr_n59261744)
print v(xbgr.mr_n59262176)
print v(xbgr.mr_n59262608)
print v(xbgr.mr_n59263040)
print v(xbgr.mr_n59263472)
print v(xbgr.mr_n59263904)
print v(xbgr.mr_n59264336)
print v(xbgr.mr_n59264768)
print v(xbgr.mr_n59265200)
print v(xbgr.mr_n59265632)
print v(xbgr.mr_n59266064)
print v(xbgr.mr_n59266496)
print v(xbgr.mr_n59266928)
print v(xbgr.mr_n59267360)
print v(xbgr.mr_n59267680)
print v(xbgr.mr_n59267792)
print v(xbgr.mr_n59268112)
print v(xbgr.mr_n59268224)
print v(xbgr.mr_n59268544)
print v(xbgr.mr_n59268656)
print v(xbgr.mr_n59268976)
print v(xbgr.mr_n59269088)
print v(xbgr.mr_n59269408)
print v(xbgr.mr_n59269520)
print v(xbgr.mr_n59269840)
print v(xbgr.mr_n59269952)
print v(xbgr.mr_n59270272)
print v(xbgr.mr_n59270384)
print v(xbgr.mr_n59270704)
print v(xbgr.mr_n59270816)
print v(xbgr.mr_n59271136)
print v(xbgr.mr_n59271248)
print v(xbgr.mr_n59271568)
print v(xbgr.mr_n59271680)
print v(xbgr.mr_n59272000)
print v(xbgr.mr_n59272112)
print v(xbgr.mr_n59272432)
print v(xbgr.mr_n59272544)
print v(xbgr.mr_n59272976)
print v(xbgr.mr_n59273408)
print v(xbgr.mr_n59273840)
print v(xbgr.mr_n59274272)
print v(xbgr.mr_n59274704)
print v(xbgr.mr_n59275136)
print v(xbgr.mr_n59275568)
print v(xbgr.mr_n59276000)
print v(xbgr.mr_n59276432)
print v(xbgr.mr_n59276864)
print v(xbgr.mr_n59277296)
print v(xbgr.mr_n59277728)
print v(xbgr.mr_n59278048)
print v(xbgr.mr_n59278160)
print v(xbgr.mr_n59278592)
print v(xbgr.mr_n59278912)
print v(xbgr.mr_n59279024)
print v(xbgr.mr_n59279344)
print v(xbgr.mr_n59279456)
print v(xbgr.mr_n59279776)
print v(xbgr.mr_n59279888)
print v(xbgr.mr_n59280208)
print v(xbgr.mr_n59280320)
print v(xbgr.mr_n59280640)
print v(xbgr.mr_n59280752)
print v(xbgr.mr_n59281184)
print v(xbgr.mr_n59281616)
print v(xbgr.mr_n59281936)
print v(xbgr.mr_n59282048)
print v(xbgr.mr_n59282368)
print v(xbgr.mr_n59282480)
print v(xbgr.mr_n59282800)
print v(xbgr.mr_n59282912)
print v(xbgr.mr_n59283232)
print v(xbgr.mr_n59283344)
print v(xbgr.mr_n59283664)
print v(xbgr.mr_n59283776)
print v(xbgr.mr_n59284096)
print v(xbgr.mr_n59284208)
print v(xbgr.mr_n59284528)
print v(xbgr.mr_n59284640)
print v(xbgr.mr_n59284960)
print v(xbgr.mr_n59285072)
print v(xbgr.mr_n59285504)
print v(xbgr.mr_n59285936)
print v(xbgr.mr_n59286368)
print v(xbgr.mr_n59286800)
print v(xbgr.mr_n59287232)
print v(xbgr.mr_n59287664)
print v(xbgr.mr_n59288096)
print v(xbgr.mr_n59288528)
print v(xbgr.mr_n59288960)
print v(xbgr.mr_n59289392)
print v(xbgr.mr_n59289824)
print v(xbgr.mr_n59290144)
print v(xbgr.mr_n59290256)
print v(xbgr.mr_n59290576)
print v(xbgr.mr_n59290688)
print v(xbgr.mr_n59291008)
print v(xbgr.mr_n59291120)
print v(xbgr.mr_n59291552)
print v(xbgr.mr_n59291984)
print v(xbgr.mr_n59292304)
print v(xbgr.mr_n59292416)
print v(xbgr.mr_n59292736)
print v(xbgr.mr_n59292848)
print v(xbgr.mr_n59293168)
print v(xbgr.mr_n59293280)
print v(xbgr.mr_n59293600)
print v(xbgr.mr_n59293712)
print v(xbgr.mr_n59294144)
print v(xbgr.mr_n59294464)
print v(xbgr.mr_n59294576)
print v(xbgr.mr_n59294896)
print v(xbgr.mr_n59295008)
print v(xbgr.mr_n59295328)
print v(xbgr.mr_n59295440)
print v(xbgr.mr_n59295760)
print v(xbgr.mr_n59295872)
print v(xbgr.mr_n59296192)
print v(xbgr.mr_n59296304)
print v(xbgr.mr_n59296624)
print v(xbgr.mr_n59296736)
print v(xbgr.mr_n59297168)
print v(xbgr.mr_n59297600)
print v(xbgr.mr_n59298032)
print v(xbgr.mr_n59298464)
print v(xbgr.mr_n59298896)
print v(xbgr.mr_n59299328)
print v(xbgr.mr_n59299760)
print v(xbgr.mr_n59300192)
print v(xbgr.mr_n59300624)
print v(xbgr.mr_n59301056)
print v(xbgr.mr_n59301376)
print v(xbgr.mr_n59301488)
print v(xbgr.mr_n59301808)
print v(xbgr.mr_n59301920)
print v(xbgr.mr_n59302240)
print v(xbgr.mr_n59302352)
print v(xbgr.mr_n59302672)
print v(xbgr.mr_n59302784)
print v(xbgr.mr_n59303104)
print v(xbgr.mr_n59303216)
print v(xbgr.mr_n59303536)
print v(xbgr.mr_n59303648)
print v(xbgr.mr_n59303968)
print v(xbgr.mr_n59304080)
print v(xbgr.mr_n59304400)
print v(xbgr.mr_n59304512)
print v(xbgr.mr_n59304832)
print v(xbgr.mr_n59304944)
print v(xbgr.mr_n59305264)
print v(xbgr.mr_n59305376)
print v(xbgr.mr_n59305696)
print v(xbgr.mr_n59305808)
print v(xbgr.mr_n59306128)
print v(xbgr.mr_n59306240)
print v(xbgr.mr_n59306560)
print v(xbgr.mr_n59306672)
print v(xbgr.mr_n59307104)
print v(xbgr.mr_n59307536)
print v(xbgr.mr_n59307968)
print v(xbgr.mr_n59308400)
print v(xbgr.mr_n59308832)
print v(xbgr.mr_n59309264)
print v(xbgr.mr_n59309696)
print v(xbgr.mr_n59310128)
print v(xbgr.mr_n59310560)
print v(xbgr.mr_n59310992)
print v(xbgr.mr_n59311424)
print v(xbgr.mr_n59311856)
print v(xbgr.mr_n59312288)
print v(xbgr.mr_n59312608)
print v(xbgr.mr_n59312720)
print v(xbgr.mr_n59313040)
print v(xbgr.mr_n59313152)
print v(xbgr.mr_n59313472)
print v(xbgr.mr_n59313584)
print v(xbgr.mr_n59313904)
print v(xbgr.mr_n59314016)
print v(xbgr.mr_n59314336)
print v(xbgr.mr_n59314448)
print v(xbgr.mr_n59314768)
print v(xbgr.mr_n59314880)
print v(xbgr.mr_n59315200)
print v(xbgr.mr_n59315312)
print v(xbgr.mr_n59315632)
print v(xbgr.mr_n59315744)
print v(xbgr.mr_n59316064)
print v(xbgr.mr_n59316176)
print v(xbgr.mr_n59316496)
print v(xbgr.mr_n59316608)
print v(xbgr.mr_n59316928)
print v(xbgr.mr_n59317040)
print v(xbgr.mr_n59317360)
print v(xbgr.mr_n59317472)
print v(xbgr.mr_n59317792)
print v(xbgr.mr_n59317904)
print v(xbgr.mr_n59318336)
print v(xbgr.mr_n59318768)
print v(xbgr.mr_n59319200)
print v(xbgr.mr_n59319632)
print v(xbgr.mr_n59320064)
print v(xbgr.mr_n59320496)
print v(xbgr.mr_n59320928)
print v(xbgr.mr_n59321360)
print v(xbgr.mr_n59321792)
print v(xbgr.mr_n59322224)
print v(xbgr.mr_n59322656)
print v(xbgr.mr_n59323088)
print v(xbgr.mr_n59323520)
print v(xbgr.mr_n59323840)
print v(xbgr.mr_n59323952)
print v(xbgr.mr_n59324272)
print v(xbgr.mr_n59324384)
print v(xbgr.mr_n59324704)
print v(xbgr.mr_n59324816)
print v(xbgr.mr_n59325136)
print v(xbgr.mr_n59325248)
print v(xbgr.mr_n59325568)
print v(xbgr.mr_n59325680)
print v(xbgr.mr_n59326000)
print v(xbgr.mr_n59326112)
print v(xbgr.mr_n59326432)
print v(xbgr.mr_n59326544)
print v(xbgr.mr_n59326864)
print v(xbgr.mr_n59326976)
print v(xbgr.mr_n59327296)
print v(xbgr.mr_n59327408)
print v(xbgr.mr_n59327728)
print v(xbgr.mr_n59327840)
print v(xbgr.mr_n59328160)
print v(xbgr.mr_n59328272)
print v(xbgr.mr_n59328592)
print v(xbgr.mr_n59328704)
print v(xbgr.mr_n59329024)
print v(xbgr.mr_n59329136)
print v(xbgr.mr_n59329568)
print v(xbgr.mr_n59330000)
print v(xbgr.mr_n59330432)
print v(xbgr.mr_n59330864)
print v(xbgr.mr_n59331296)
print v(xbgr.mr_n59331728)
print v(xbgr.mr_n59332160)
print v(xbgr.mr_n59332592)
print v(xbgr.mr_n59333024)
print v(xbgr.mr_n59333456)
print v(xbgr.mr_n59333888)
print v(xbgr.mr_n59334320)
print v(xbgr.mr_n59334752)
print v(xbgr.mr_n59335072)
print v(xbgr.mr_n59335184)
print v(xbgr.mr_n59335504)
print v(xbgr.mr_n59335616)
print v(xbgr.mr_n59336048)
print v(xbgr.mr_n59336368)
print v(xbgr.mr_n59336480)
print v(xbgr.mr_n59336800)
print v(xbgr.mr_n59336912)
print v(xbgr.mr_n59337232)
print v(xbgr.mr_n59337344)
print v(xbgr.mr_n59337664)
print v(xbgr.mr_n59337776)
print v(xbgr.mr_n59338208)
print v(xbgr.mr_n59338640)
print v(xbgr.mr_n59339072)
print v(xbgr.mr_n59339504)
print v(xbgr.mr_n59339824)
print v(xbgr.mr_n59339936)
print v(xbgr.mr_n59340256)
print v(xbgr.mr_n59340368)
print v(xbgr.mr_n59340800)
print v(xbgr.mr_n59341232)
print v(xbgr.mr_n59341552)
print v(xbgr.mr_n59341664)
print v(xbgr.mr_n59341984)
print v(xbgr.mr_n59342096)
print v(xbgr.mr_n59342416)
print v(xbgr.mr_n59342528)
print v(xbgr.mr_n59342848)
print v(xbgr.mr_n59342960)
print v(xbgr.mr_n59343280)
print v(xbgr.mr_n59343392)
print v(xbgr.mr_n59343824)
print v(xbgr.mr_n59344256)
print v(xbgr.mr_n59344688)
print v(xbgr.mr_n59345120)
print v(xbgr.mr_n59345552)
print v(xbgr.mr_n59345984)
print v(xbgr.mr_n59346304)
print v(xbgr.mr_n59346416)
print v(xbgr.mr_n59346736)
print v(xbgr.mr_n59346848)
print v(xbgr.mr_n59347168)
print v(xbgr.mr_n59347280)
print v(xbgr.mr_n59347600)
print v(xbgr.mr_n59347712)
print v(xbgr.mr_n59348032)
print v(xbgr.mr_n59348144)
print v(xbgr.mr_n59348464)
print v(xbgr.mr_n59348576)
print v(xbgr.mr_n59348896)
print v(xbgr.mr_n59349008)
print v(xbgr.mr_n59349328)
print v(xbgr.mr_n59349440)
print v(xbgr.mr_n59349760)
print v(xbgr.mr_n59349872)
print v(xbgr.mr_n59350192)
print v(xbgr.mr_n59350304)
print v(xbgr.mr_n59350624)
print v(xbgr.mr_n59350736)
print v(xbgr.mr_n59351056)
print v(xbgr.mr_n59351168)
print v(xbgr.mr_n59351600)
print v(xbgr.mr_n59352032)
print v(xbgr.mr_n59352464)
print v(xbgr.mr_n59352896)
print v(xbgr.mr_n59353328)
print v(xbgr.mr_n59353760)
print v(xbgr.mr_n59354192)
print v(xbgr.mr_n59354624)
print v(xbgr.mr_n59354944)
print v(xbgr.mr_n59355056)
print v(xbgr.mr_n59355376)
print v(xbgr.mr_n59355488)
print v(xbgr.mr_n59355808)
print v(xbgr.mr_n59355920)
print v(xbgr.mr_n59356240)
print v(xbgr.mr_n59356352)
print v(xbgr.mr_n59356672)
print v(xbgr.mr_n59356784)
print v(xbgr.mr_n59357104)
print v(xbgr.mr_n59357216)
print v(xbgr.mr_n59357536)
print v(xbgr.mr_n59357648)
print v(xbgr.mr_n59357968)
print v(xbgr.mr_n59358080)
print v(xbgr.mr_n59358512)
print v(xbgr.mr_n59358944)
print v(xbgr.mr_n59359264)
print v(xbgr.mr_n59359376)
print v(xbgr.mr_n59359696)
print v(xbgr.mr_n59359808)
print v(xbgr.mr_n59360128)
print v(xbgr.mr_n59360240)
print v(xbgr.mr_n59360560)
print v(xbgr.mr_n59360672)
print v(xbgr.mr_n59360992)
print v(xbgr.mr_n59361104)
print v(xbgr.mr_n59361424)
print v(xbgr.mr_n59361536)
print v(xbgr.mr_n59361968)
print v(xbgr.mr_n59362400)
print v(xbgr.mr_n59362832)
print v(xbgr.mr_n59363264)
print v(xbgr.mr_n59363696)
print v(xbgr.mr_n59364128)
print v(xbgr.mr_n59364560)
print v(xbgr.mr_n59364992)
print v(xbgr.mr_n59365424)
print v(xbgr.mr_n59365856)
print v(xbgr.mr_n59366288)
print v(xbgr.mr_n59366720)
print v(xbgr.mr_n59367152)
print v(xbgr.mr_n59367584)
print v(xbgr.mr_n59368016)
print v(xbgr.mr_n59368448)
print v(xbgr.mr_n59368768)
print v(xbgr.mr_n59368880)
print v(xbgr.mr_n59369200)
print v(xbgr.mr_n59369312)
print v(xbgr.mr_n59369632)
print v(xbgr.mr_n59369744)
print v(xbgr.mr_n59370064)
print v(xbgr.mr_n59370176)
print v(xbgr.mr_n59370496)
print v(xbgr.mr_n59370608)
print v(xbgr.mr_n59370928)
print v(xbgr.mr_n59371040)
print v(xbgr.mr_n59371360)
print v(xbgr.mr_n59371472)
print v(xbgr.mr_n59371792)
print v(xbgr.mr_n59371904)
print v(xbgr.mr_n59372224)
print v(xbgr.mr_n59372336)
print v(xbgr.mr_n59372656)
print v(xbgr.mr_n59372768)
print v(xbgr.mr_n59373088)
print v(xbgr.mr_n59373200)
print v(xbgr.mr_n59373520)
print v(xbgr.mr_n59373632)
print v(xbgr.mr_n59373952)
print v(xbgr.mr_n59374064)
print v(xbgr.mr_n59374384)
print v(xbgr.mr_n59374496)
print v(xbgr.mr_n59374816)
print v(xbgr.mr_n59374928)
print v(xbgr.mr_n59375248)
print v(xbgr.mr_n59375360)
print v(xbgr.mr_n59375680)
print v(xbgr.mr_n59375792)
print v(xbgr.mr_n59376112)
print v(xbgr.mr_n59376224)
print v(xbgr.mr_n59376544)
print v(xbgr.mr_n59376656)
print v(xbgr.mr_n59376976)
print v(xbgr.mr_n59377088)
print v(xbgr.mr_n59377520)
print v(xbgr.mr_n59377952)
print v(xbgr.mr_n59378384)
print v(xbgr.mr_n59378816)
print v(xbgr.mr_n59379248)
print v(xbgr.mr_n59379680)
print v(xbgr.mr_n59380000)
print v(xbgr.mr_n59380112)
print v(xbgr.mr_n59380432)
print v(xbgr.mr_n59380544)
print v(xbgr.mr_n59380864)
print v(xbgr.mr_n59380976)
print v(xbgr.mr_n59381296)
print v(xbgr.mr_n59381408)
print v(xbgr.mr_n59381728)
print v(xbgr.mr_n59381840)
print v(xbgr.mr_n59382160)
print v(xbgr.mr_n59382272)
print v(xbgr.mr_n59382704)
print v(xbgr.mr_n59383136)
print v(xbgr.mr_n59383568)
print v(xbgr.mr_n59384000)
print v(xbgr.mr_n59384432)
print v(xbgr.mr_n59384864)
print v(xbgr.mr_n59385296)
print v(xbgr.mr_n59385728)
print v(xbgr.mr_n59386160)
print v(xbgr.mr_n59386592)
print v(xbgr.mr_n59387024)
print v(xbgr.mr_n59387456)
print v(xbgr.mr_n59387888)
print v(xbgr.mr_n59388320)
print v(xbgr.mr_n59388752)
print v(xbgr.mr_n59389184)
print v(xbgr.mr_n59389616)
print v(xbgr.mr_n59390048)
print v(xbgr.mr_n59390480)
print v(xbgr.mr_n59390912)
print v(xbgr.mr_n59391232)
print v(xbgr.mr_n59391344)
print v(xbgr.mr_n59391664)
print v(xbgr.mr_n59391776)
print v(xbgr.mr_n59392096)
print v(xbgr.mr_n59392208)
print v(xbgr.mr_n59392528)
print v(xbgr.mr_n59392640)
print v(xbgr.mr_n59392960)
print v(xbgr.mr_n59393072)
print v(xbgr.mr_n59393392)
print v(xbgr.mr_n59393504)
print v(xbgr.mr_n59393824)
print v(xbgr.mr_n59393936)
print v(xbgr.mr_n59394256)
print v(xbgr.mr_n59394368)
print v(xbgr.mr_n59394688)
print v(xbgr.mr_n59394800)
print v(xbgr.mr_n59395120)
print v(xbgr.mr_n59395232)
print v(xbgr.mr_n59395552)
print v(xbgr.mr_n59395664)
print v(xbgr.mr_n59395984)
print v(xbgr.mr_n59396096)
print v(xbgr.mr_n59396416)
print v(xbgr.mr_n59396528)
print v(xbgr.mr_n59396848)
print v(xbgr.mr_n59396960)
print v(xbgr.mr_n59397280)
print v(xbgr.mr_n59397392)
print v(xbgr.mr_n59397712)
print v(xbgr.mr_n59397824)
print v(xbgr.mr_n59398144)
print v(xbgr.mr_n59398256)
print v(xbgr.mr_n59398576)
print v(xbgr.mr_n59398688)
print v(xbgr.mr_n59399008)
print v(xbgr.mr_n59399120)
print v(xbgr.mr_n59399440)
print v(xbgr.mr_n59399552)
print v(xbgr.mr_n59399872)
print v(xbgr.mr_n59399984)
print v(xbgr.mr_n59400304)
print v(xbgr.mr_n59400416)
print v(xbgr.mr_n59400736)
print v(xbgr.mr_n59400848)
print v(xbgr.mr_n59401168)
print v(xbgr.mr_n59401280)
print v(xbgr.mr_n59401600)
print v(xbgr.mr_n59401712)
print v(xbgr.mr_n59402032)
print v(xbgr.mr_n59402144)
print v(xbgr.mr_n59402464)
print v(xbgr.mr_n59402576)
print v(xbgr.mr_n59402896)
print v(xbgr.mr_n59403008)
print v(xbgr.mr_n59403328)
print v(xbgr.mr_n59403440)
print v(xbgr.mr_n59403760)
print v(xbgr.mr_n59403872)
print v(xbgr.mr_n59404192)
print v(xbgr.mr_n59404304)
print v(xbgr.mr_n59404624)
print v(xbgr.mr_n59404736)
print v(xbgr.mr_n59405168)
print v(xbgr.mr_n59405600)
print v(xbgr.mr_n59405920)
print v(xbgr.mr_n59406032)
print v(xbgr.mr_n59406352)
print v(xbgr.mr_n59406464)
print v(xbgr.mr_n59406784)
print v(xbgr.mr_n59406896)
print v(xbgr.mr_n59407216)
print v(xbgr.mr_n59407328)
print v(xbgr.mr_n59407648)
print v(xbgr.mr_n59407760)
print v(xbgr.mr_n59408080)
print v(xbgr.mr_n59408192)
print v(xbgr.mr_n59408512)
print v(xbgr.mr_n59408624)
print v(xbgr.mr_n59408944)
print v(xbgr.mr_n59409056)
print v(xbgr.mr_n59409376)
print v(xbgr.mr_n59409488)
print v(xbgr.mr_n59409808)
print v(xbgr.mr_n59409920)
print v(xbgr.mr_n59410352)
print v(xbgr.mr_n59410784)
print v(xbgr.mr_n59411216)
print v(xbgr.mr_n59411536)
print v(xbgr.mr_n59411648)
print v(xbgr.mr_n59411968)
print v(xbgr.mr_n59412080)
print v(xbgr.mr_n59412512)
print v(xbgr.mr_n59412944)
print v(xbgr.mr_n59413376)
print v(xbgr.mr_n59413808)
print v(xbgr.mr_n59414240)
print v(xbgr.mr_n59414672)
print v(xbgr.mr_n59415104)
print v(xbgr.mr_n59415536)
print v(xbgr.mr_n59415968)
print v(xbgr.mr_n59416400)
print v(xbgr.mr_n59416832)
print v(xbgr.mr_n59417152)
print v(xbgr.mr_n59417264)
print v(xbgr.mr_n59417584)
print v(xbgr.mr_n59417696)
print v(xbgr.mr_n59418016)
print v(xbgr.mr_n59418128)
print v(xbgr.mr_n59418448)
print v(xbgr.mr_n59418560)
print v(xbgr.mr_n59418880)
print v(xbgr.mr_n59418992)
print v(xbgr.mr_n59419312)
print v(xbgr.mr_n59419424)
print v(xbgr.mr_n59419744)
print v(xbgr.mr_n59419856)
print v(xbgr.mr_n59420176)
print v(xbgr.mr_n59420288)
print v(xbgr.mr_n59420720)
print v(xbgr.mr_n59421152)
print v(xbgr.mr_n59421584)
print v(xbgr.mr_n59422016)
print v(xbgr.mr_n59422448)
print v(xbgr.mr_n59422880)
print v(xbgr.mr_n59423312)
print v(xbgr.mr_n59423744)
print v(xbgr.mr_n59424176)
print v(xbgr.mr_n59424608)
print v(xbgr.mr_n59425040)
print v(xbgr.mr_n59425472)
print v(xbgr.mr_n59425904)
print v(xbgr.mr_n59426336)
print v(xbgr.mr_n59426768)
print v(xbgr.mr_n59427200)
print v(xbgr.mr_n59427632)
print v(xbgr.mr_n59428064)
print v(xbgr.mr_n59428496)
print v(xbgr.mr_n59428928)
print v(xbgr.mr_n59429248)
print v(xbgr.mr_n59429360)
print v(xbgr.mr_n59429680)
print v(xbgr.mr_n59429792)
print v(xbgr.mr_n59430112)
print v(xbgr.mr_n59430224)
print v(xbgr.mr_n59430544)
print v(xbgr.mr_n59430656)
print v(xbgr.mr_n59430976)
print v(xbgr.mr_n59431088)
print v(xbgr.mr_n59431408)
print v(xbgr.mr_n59431520)
print v(xbgr.mr_n59431840)
print v(xbgr.mr_n59431952)
print v(xbgr.mr_n59432272)
print v(xbgr.mr_n59432384)
print v(xbgr.mr_n59432704)
print v(xbgr.mr_n59432816)
print v(xbgr.mr_n59433136)
print v(xbgr.mr_n59433248)
print v(xbgr.mr_n59433568)
print v(xbgr.mr_n59433680)
print v(xbgr.mr_n59434000)
print v(xbgr.mr_n59434112)
print v(xbgr.mr_n59434432)
print v(xbgr.mr_n59434544)
print v(xbgr.mr_n59434976)
print v(xbgr.mr_n59435408)
print v(xbgr.mr_n59435840)
print v(xbgr.mr_n59436272)
print v(xbgr.mr_n59436704)
print v(xbgr.mr_n59437136)
print v(xbgr.mr_n59437568)
print v(xbgr.mr_n59438000)
print v(xbgr.mr_n59438432)
print v(xbgr.mr_n59438864)
print v(xbgr.mr_n59439296)
print v(xbgr.mr_n59439728)
print v(xbgr.mr_n59440160)
print v(xbgr.mr_n59440480)
print v(xbgr.mr_n59440592)
print v(xbgr.mr_n59440912)
print v(xbgr.mr_n59441024)
print v(xbgr.mr_n59441344)
print v(xbgr.mr_n59441456)
print v(xbgr.mr_n59441776)
print v(xbgr.mr_n59441888)
print v(xbgr.mr_n59442208)
print v(xbgr.mr_n59442320)
print v(xbgr.mr_n59442640)
print v(xbgr.mr_n59442752)
print v(xbgr.mr_n59443072)
print v(xbgr.mr_n59443184)
print v(xbgr.mr_n59443504)
print v(xbgr.mr_n59443616)
print v(xbgr.mr_n59443936)
print v(xbgr.mr_n59444048)
print v(xbgr.mr_n59444368)
print v(xbgr.mr_n59444480)
print v(xbgr.mr_n59444800)
print v(xbgr.mr_n59444912)
print v(xbgr.mr_n59445232)
print v(xbgr.mr_n59445344)
print v(xbgr.mr_n59445776)
print v(xbgr.mr_n59446096)
print v(xbgr.mr_n59446208)
print v(xbgr.mr_n59446640)
print v(xbgr.mr_n59447072)
print v(xbgr.mr_n59447504)
print v(xbgr.mr_n59447936)
print v(xbgr.mr_n59448368)
print v(xbgr.mr_n59448800)
print v(xbgr.mr_n59449232)
print v(xbgr.mr_n59449664)
print v(xbgr.mr_n59450096)
print v(xbgr.mr_n59450528)
print v(xbgr.mr_n59450960)
print v(xbgr.mr_n59451392)
print v(xbgr.mr_n59451712)
print v(xbgr.mr_n59451824)
print v(xbgr.mr_n59452144)
print v(xbgr.mr_n59452256)
print v(xbgr.mr_n59452576)
print v(xbgr.mr_n59452688)
print v(xbgr.mr_n59453008)
print v(xbgr.mr_n59453120)
print v(xbgr.mr_n59453440)
print v(xbgr.mr_n59453552)
print v(xbgr.mr_n59453872)
print v(xbgr.mr_n59453984)
print v(xbgr.mr_n59454304)
print v(xbgr.mr_n59454416)
print v(xbgr.mr_n59454736)
print v(xbgr.mr_n59454848)
print v(xbgr.mr_n59455168)
print v(xbgr.mr_n59455280)
print v(xbgr.mr_n59455600)
print v(xbgr.mr_n59455712)
print v(xbgr.mr_n59456032)
print v(xbgr.mr_n59456144)
print v(xbgr.mr_n59456576)
print v(xbgr.mr_n59457008)
print v(xbgr.mr_n59457440)
print v(xbgr.mr_n59457760)
print v(xbgr.mr_n59457872)
print v(xbgr.mr_n59458192)
print v(xbgr.mr_n59458304)
print v(xbgr.mr_n59458736)
print v(xbgr.mr_n59459168)
print v(xbgr.mr_n59459600)
print v(xbgr.mr_n59460032)
print v(xbgr.mr_n59460464)
print v(xbgr.mr_n59460896)
print v(xbgr.mr_n59461328)
print v(xbgr.mr_n59461760)
print v(xbgr.mr_n59462192)
print v(xbgr.mr_n59462624)
print v(xbgr.mr_n59462944)
print v(xbgr.mr_n59463056)
print v(xbgr.mr_n59463376)
print v(xbgr.mr_n59463488)
print v(xbgr.mr_n59463808)
print v(xbgr.mr_n59463920)
print v(xbgr.mr_n59464240)
print v(xbgr.mr_n59464352)
print v(xbgr.mr_n59464672)
print v(xbgr.mr_n59464784)
print v(xbgr.mr_n59465104)
print v(xbgr.mr_n59465216)
print v(xbgr.mr_n59465536)
print v(xbgr.mr_n59465648)
print v(xbgr.mr_n59465968)
print v(xbgr.mr_n59466080)
print v(xbgr.mr_n59466400)
print v(xbgr.mr_n59466512)
print v(xbgr.mr_n59466832)
print v(xbgr.mr_n59466944)
print v(xbgr.mr_n59467264)
print v(xbgr.mr_n59467376)
print v(xbgr.mr_n59467696)
print v(xbgr.mr_n59467808)
print v(xbgr.mr_n59468240)
print v(xbgr.mr_n59468672)
print v(xbgr.mr_n59469104)
print v(xbgr.mr_n59469536)
print v(xbgr.mr_n59469968)
print v(xbgr.mr_n59470400)
print v(xbgr.mr_n59470832)
print v(xbgr.mr_n59471152)
print v(xbgr.mr_n59471264)
print v(xbgr.mr_n59471696)
print v(xbgr.mr_n59472128)
print v(xbgr.mr_n59472560)
print v(xbgr.mr_n59472992)
print v(xbgr.mr_n59473424)
print v(xbgr.mr_n59473856)
print v(xbgr.mr_n59474176)
print v(xbgr.mr_n59474288)
print v(xbgr.mr_n59474608)
print v(xbgr.mr_n59474720)
print v(xbgr.mr_n59475040)
print v(xbgr.mr_n59475152)
print v(xbgr.mr_n59475472)
print v(xbgr.mr_n59475584)
print v(xbgr.mr_n59475904)
print v(xbgr.mr_n59476016)
print v(xbgr.mr_n59476336)
print v(xbgr.mr_n59476448)
print v(xbgr.mr_n59476768)
print v(xbgr.mr_n59476880)
print v(xbgr.mr_n59477200)
print v(xbgr.mr_n59477312)
print v(xbgr.mr_n59477632)
print v(xbgr.mr_n59477744)
print v(xbgr.mr_n59478064)
print v(xbgr.mr_n59478176)
print v(xbgr.mr_n59478496)
print v(xbgr.mr_n59478608)
print v(xbgr.mr_n59478928)
print v(xbgr.mr_n59479040)
print v(xbgr.mr_n59479360)
print v(xbgr.mr_n59479472)
print v(xbgr.mr_n59479792)
print v(xbgr.mr_n59479904)
print v(xbgr.mr_n59480224)
print v(xbgr.mr_n59480336)
print v(xbgr.mr_n59480656)
print v(xbgr.mr_n59480768)
print v(xbgr.mr_n59481088)
print v(xbgr.mr_n59481200)
print v(xbgr.mr_n59481520)
print v(xbgr.mr_n59481632)
print v(xbgr.mr_n59481952)
print v(xbgr.mr_n59482064)
print v(xbgr.mr_n59482384)
print v(xbgr.mr_n59482496)
print v(xbgr.mr_n59482816)
print v(xbgr.mr_n59482928)
print v(xbgr.mr_n59483248)
print v(xbgr.mr_n59483360)
print v(xbgr.mr_n59483680)
print v(xbgr.mr_n59483792)
print v(xbgr.mr_n59484112)
print v(xbgr.mr_n59484224)
print v(xbgr.mr_n59484656)
print v(xbgr.mr_n59485088)
print v(xbgr.mr_n59485520)
print v(xbgr.mr_n59485840)
print v(xbgr.mr_n59485952)
print v(xbgr.mr_n59486272)
print v(xbgr.mr_n59486384)
print v(xbgr.mr_n59486816)
print v(xbgr.mr_n59487248)
print v(xbgr.mr_n59487680)
print v(xbgr.mr_n59488112)
print v(xbgr.mr_n59488544)
print v(xbgr.mr_n59488976)
print v(xbgr.mr_n59489408)
print v(xbgr.mr_n59489840)
print v(xbgr.mr_n59490272)
print v(xbgr.mr_n59490704)
print v(xbgr.mr_n59491136)
print v(xbgr.mr_n59491568)
print v(xbgr.mr_n59492000)
print v(xbgr.mr_n59492432)
print v(xbgr.mr_n59492864)
print v(xbgr.mr_n59493296)
print v(xbgr.mr_n59493728)
print v(xbgr.mr_n59494160)
print v(xbgr.mr_n59494592)
print v(xbgr.mr_n59495024)
print v(xbgr.mr_n59495456)
print v(xbgr.mr_n59495888)
print v(xbgr.mr_n59496320)
print v(xbgr.mr_n59496640)
print v(xbgr.mr_n59496752)
print v(xbgr.mr_n59497072)
print v(xbgr.mr_n59497184)
print v(xbgr.mr_n59497504)
print v(xbgr.mr_n59497616)
print v(xbgr.mr_n59497936)
print v(xbgr.mr_n59498048)
print v(xbgr.mr_n59498368)
print v(xbgr.mr_n59498480)
print v(xbgr.mr_n59498800)
print v(xbgr.mr_n59498912)
print v(xbgr.mr_n59499232)
print v(xbgr.mr_n59499344)
print v(xbgr.mr_n59499664)
print v(xbgr.mr_n59499776)
print v(xbgr.mr_n59500096)
print v(xbgr.mr_n59500208)
print v(xbgr.mr_n59500528)
print v(xbgr.mr_n59500640)
print v(xbgr.mr_n59500960)
print v(xbgr.mr_n59501072)
print v(xbgr.mr_n59501392)
print v(xbgr.mr_n59501504)
print v(xbgr.mr_n59501824)
print v(xbgr.mr_n59501936)
print v(xbgr.mr_n59502256)
print v(xbgr.mr_n59502368)
print v(xbgr.mr_n59502800)
print v(xbgr.mr_n59503232)
print v(xbgr.mr_n59503552)
print v(xbgr.mr_n59503664)
print v(xbgr.mr_n59503984)
print v(xbgr.mr_n59504096)
print v(xbgr.mr_n59504416)
print v(xbgr.mr_n59504528)
print v(xbgr.mr_n59504848)
print v(xbgr.mr_n59504960)
print v(xbgr.mr_n59505392)
print v(xbgr.mr_n59505824)
print v(xbgr.mr_n59506144)
print v(xbgr.mr_n59506256)
print v(xbgr.mr_n59506576)
print v(xbgr.mr_n59506688)
print v(xbgr.mr_n59507008)
print v(xbgr.mr_n59507120)
print v(xbgr.mr_n59507440)
print v(xbgr.mr_n59507552)
print v(xbgr.mr_n59507872)
print v(xbgr.mr_n59507984)
print v(xbgr.mr_n59508304)
print v(xbgr.mr_n59508416)
print v(xbgr.mr_n59508736)
print v(xbgr.mr_n59508848)
print v(xbgr.mr_n59509168)
print v(xbgr.mr_n59509280)
print v(xbgr.mr_n59509712)
print v(xbgr.mr_n59510144)
print v(xbgr.mr_n59510576)
print v(xbgr.mr_n59511008)
print v(xbgr.mr_n59511440)
print v(xbgr.mr_n59511872)
print v(xbgr.mr_n59512304)
print v(xbgr.mr_n59512736)
print v(xbgr.mr_n59513168)
print v(xbgr.mr_n59513600)
print v(xbgr.mr_n59513920)
print v(xbgr.mr_n59514032)
print v(xbgr.mr_n59514352)
print v(xbgr.mr_n59514464)
print v(xbgr.mr_n59514784)
print v(xbgr.mr_n59514896)
print v(xbgr.mr_n59515216)
print v(xbgr.mr_n59515328)
print v(xbgr.mr_n59520352)
print v(xbgr.mr_n59520464)
print v(xbgr.mr_n59520800)
print v(xbgr.mr_n59520912)
print v(xbgr.mr_n59521232)
print v(xbgr.mr_n59521344)
print v(xbgr.mr_n59521712)
print v(xbgr.mr_n59521824)
print v(xbgr.mr_n59522144)
print v(xbgr.mr_n59522256)
print v(xbgr.mr_n59522576)
print v(xbgr.mr_n59522688)
print v(xbgr.mr_n59522928)
print v(xbgr.mr_n59523040)
print v(xbgr.mr_n59523360)
print v(xbgr.mr_n59523472)
print v(xbgr.mr_n59523792)
print v(xbgr.mr_n59523904)
print v(xbgr.mr_n59524224)
print v(xbgr.mr_n59524336)
print v(xbgr.mr_n59524656)
print v(xbgr.mr_n59524768)
print v(xbgr.mr_n59525088)
print v(xbgr.mr_n59525200)
print v(xbgr.mr_n59525520)
print v(xbgr.mr_n59525632)
print v(xbgr.mr_n59525952)
print v(xbgr.mr_n59526064)
print v(xbgr.mr_n59526384)
print v(xbgr.mr_n59526496)
print v(xbgr.mr_n59526816)
print v(xbgr.mr_n59526928)
print v(xbgr.mr_n59527248)
print v(xbgr.mr_n59527360)
print v(xbgr.mr_n59527680)
print v(xbgr.mr_n59527792)
print v(xbgr.mr_n59528112)
print v(xbgr.mr_n59528224)
print v(xbgr.mr_n59528544)
print v(xbgr.mr_n59528656)
print v(xbgr.mr_n59528976)
print v(xbgr.mr_n59529088)
print v(xbgr.mr_n59529408)
print v(xbgr.mr_n59529520)
print v(xbgr.mr_n59529840)
print v(xbgr.mr_n59529952)
print v(xbgr.mr_n59530272)
print v(xbgr.mr_n59530384)
print v(xbgr.mr_n59530704)
print v(xbgr.mr_n59530816)
print v(xbgr.mr_n59531136)
print v(xbgr.mr_n59531248)
print v(xbgr.mr_n59531568)
print v(xbgr.mr_n59531680)
print v(xbgr.mr_n59532000)
print v(xbgr.mr_n59532112)
print v(xbgr.mr_n59532432)
print v(xbgr.mr_n59532544)
print v(xbgr.mr_n59532864)
print v(xbgr.mr_n59532976)
print v(xbgr.mr_n59533296)
print v(xbgr.mr_n59533408)
print v(xbgr.mr_n59533728)
print v(xbgr.mr_n59533840)
print v(xbgr.mr_n59534160)
print v(xbgr.mr_n59534272)
print v(xbgr.mr_n59534592)
print v(xbgr.mr_n59534704)
print v(xbgr.mr_n59535024)
print v(xbgr.mr_n59535136)
print v(xbgr.mr_n59535456)
print v(xbgr.mr_n59535568)
print v(xbgr.mr_n59535888)
print v(xbgr.mr_n59536000)
print v(xbgr.mr_n59536320)
print v(xbgr.mr_n59536432)
print v(xbgr.mr_n59536752)
print v(xbgr.mr_n59536864)
print v(xbgr.mr_n59537184)
print v(xbgr.mr_n59537296)
print v(xbgr.mr_n59537616)
print v(xbgr.mr_n59537728)
print v(xbgr.mr_n59538048)
print v(xbgr.mr_n59538160)
print v(xbgr.mr_n59538480)
print v(xbgr.mr_n59538592)
print v(xbgr.mr_n59538912)
print v(xbgr.mr_n59539024)
print v(xbgr.mr_n59539344)
print v(xbgr.mr_n59539456)
print v(xbgr.mr_n59539776)
print v(xbgr.mr_n59539888)
print v(xbgr.mr_n59540208)
print v(xbgr.mr_n59540320)
print v(xbgr.mr_n59540640)
print v(xbgr.mr_n59540752)
print v(xbgr.mr_n59541072)
print v(xbgr.mr_n59541184)
print v(xbgr.mr_n59541504)
print v(xbgr.mr_n59541616)
print v(xbgr.mr_n59541936)
print v(xbgr.mr_n59542048)
print v(xbgr.mr_n59542368)
print v(xbgr.mr_n59542480)
print v(xbgr.mr_n59542800)
print v(xbgr.mr_n59542912)
print v(xbgr.mr_n59543232)
print v(xbgr.mr_n59543344)
print v(xbgr.mr_n59543664)
print v(xbgr.mr_n59543776)
print v(xbgr.mr_n59544096)
print v(xbgr.mr_n59544208)
print v(xbgr.mr_n59544528)
print v(xbgr.mr_n59544640)
print v(xbgr.mr_n59544960)
print v(xbgr.mr_n59545072)
print v(xbgr.mr_n59545392)
print v(xbgr.mr_n59545504)
print v(xbgr.mr_n59545824)
print v(xbgr.mr_n59545936)
print v(xbgr.mr_n59546256)
print v(xbgr.mr_n59546368)
print v(xbgr.mr_n59546688)
print v(xbgr.mr_n59546800)
print v(xbgr.mr_n59547120)
print v(xbgr.mr_n59547232)
print v(xbgr.mr_n59547552)
print v(xbgr.mr_n59547664)
print v(xbgr.mr_n59547984)
print v(xbgr.mr_n59548096)
print v(xbgr.mr_n59548416)
print v(xbgr.mr_n59548528)
print v(xbgr.mr_n59548848)
print v(xbgr.mr_n59548960)
print v(xbgr.mr_n59549280)
print v(xbgr.mr_n59549392)
print v(xbgr.mr_n59549712)
print v(xbgr.mr_n59549824)
print v(xbgr.mr_n59550144)
print v(xbgr.mr_n59550256)
print v(xbgr.mr_n59550480)
print v(xbgr.mr_n59550592)
print v(xbgr.mr_n59550848)
print v(xbgr.mr_n59550960)
print v(xbgr.mr_n59551216)
print v(xbgr.mr_n59551328)
print v(xbgr.mr_n59551584)
print v(xbgr.mr_n59551696)
print v(xbgr.mr_n59551952)
print v(xbgr.mr_n59552064)
print v(xbgr.mr_n59552320)
print v(xbgr.mr_n59552432)
print v(xbgr.mr_n59552688)
print v(xbgr.mr_n59552800)
print v(xbgr.mr_n59553056)
print v(xbgr.mr_n59553168)
print v(xbgr.mr_n59553424)
print v(xbgr.mr_n59553536)
print v(xbgr.mr_n59553824)
print v(xbgr.mr_n59553936)
print v(xbgr.mr_n59554256)
print v(xbgr.mr_n59554368)
print v(xbgr.mr_n59554688)
print v(xbgr.mr_n59554800)
print v(xbgr.mr_n59555120)
print v(xbgr.mr_n59555232)
print v(xbgr.mr_n59555552)
print v(xbgr.mr_n59555664)
print v(xbgr.mr_n59555984)
print v(xbgr.mr_n59556096)
print v(xbgr.mr_n59556416)
print v(xbgr.mr_n59556528)
print v(xbgr.mr_n59556848)
print v(xbgr.mr_n59556960)
print v(xbgr.mr_n59557280)
print v(xbgr.mr_n59557392)
print v(xbgr.mr_n59557712)
print v(xbgr.mr_n59557824)
print v(xbgr.mr_n59558144)
print v(xbgr.mr_n59558256)
print v(xbgr.mr_n59558576)
print v(xbgr.mr_n59558688)
print v(xbgr.mr_n59559008)
print v(xbgr.mr_n59559120)
print v(xbgr.mr_n59559440)
print v(xbgr.mr_n59559552)
print v(xbgr.mr_n59559872)
print v(xbgr.mr_n59559984)
print v(xbgr.mr_n59560304)
print v(xbgr.mr_n59560416)
print v(xbgr.mr_n59560736)
print v(xbgr.mr_n59560848)
print v(xbgr.mr_n59561168)
print v(xbgr.mr_n59561280)
print v(xbgr.mr_n59561600)
print v(xbgr.mr_n59561712)
print v(xbgr.mr_n59562032)
print v(xbgr.mr_n59562144)
print v(xbgr.mr_n59562464)
print v(xbgr.mr_n59562576)
print v(xbgr.mr_n59562896)
print v(xbgr.mr_n59563008)
print v(xbgr.mr_n59563328)
print v(xbgr.mr_n59563440)
print v(xbgr.mr_n59563760)
print v(xbgr.mr_n59563872)
print v(xbgr.mr_n59564192)
print v(xbgr.mr_n59564304)
print v(xbgr.mr_n59564624)
print v(xbgr.mr_n59564736)
print v(xbgr.mr_n59565056)
print v(xbgr.mr_n59565168)
print v(xbgr.mr_n59565488)
print v(xbgr.mr_n59565600)
print v(xbgr.mr_n59565920)
print v(xbgr.mr_n59566032)
print v(xbgr.mr_n59566352)
print v(xbgr.mr_n59566464)
print v(xbgr.mr_n59566784)
print v(xbgr.mr_n59566896)
print v(xbgr.mr_n59567216)
print v(xbgr.mr_n59567328)
print v(xbgr.mr_n59567648)
print v(xbgr.mr_n59567760)
print v(xbgr.mr_n59568080)
print v(xbgr.mr_n59568192)
print v(xbgr.mr_n59568512)
print v(xbgr.mr_n59568624)
print v(xbgr.mr_n59568944)
print v(xbgr.mr_n59569056)
print v(xbgr.mr_n59569376)
print v(xbgr.mr_n59569488)
print v(xbgr.mr_n59569808)
print v(xbgr.mr_n59569920)
print v(xbgr.mr_n59570240)
print v(xbgr.mr_n59570352)
print v(xbgr.mr_n59570672)
print v(xbgr.mr_n59570784)
print v(xbgr.mr_n59571104)
print v(xbgr.mr_n59571216)
print v(xbgr.mr_n59571536)
print v(xbgr.mr_n59571648)
print v(xbgr.mr_n59571968)
print v(xbgr.mr_n59572080)
print v(xbgr.mr_n59572400)
print v(xbgr.mr_n59572512)
print v(xbgr.mr_n59572832)
print v(xbgr.mr_n59572944)
print v(xbgr.mr_n59573264)
print v(xbgr.mr_n59573376)
print v(xbgr.mr_n59573696)
print v(xbgr.mr_n59573808)
print v(xbgr.mr_n59574128)
print v(xbgr.mr_n59574240)
print v(xbgr.mr_n59574560)
print v(xbgr.mr_n59574672)
print v(xbgr.mr_n59574992)
print v(xbgr.mr_n59575104)
print v(xbgr.mr_n59575424)
print v(xbgr.mr_n59575536)
print v(xbgr.mr_n59575856)
print v(xbgr.mr_n59575968)
print v(xbgr.mr_n59576288)
print v(xbgr.mr_n59576400)
print v(xbgr.mr_n59576720)
print v(xbgr.mr_n59576832)
print v(xbgr.mr_n59577152)
print v(xbgr.mr_n59577264)
print v(xbgr.mr_n59577584)
print v(xbgr.mr_n59577696)
print v(xbgr.mr_n59578016)
print v(xbgr.mr_n59578128)
print v(xbgr.mr_n59578448)
print v(xbgr.mr_n59578560)
print v(xbgr.mr_n59578880)
print v(xbgr.mr_n59578992)
print v(xbgr.mr_n59579312)
print v(xbgr.mr_n59579424)
print v(xbgr.mr_n59579744)
print v(xbgr.mr_n59579856)
print v(xbgr.mr_n59580176)
print v(xbgr.mr_n59580288)
print v(xbgr.mr_n59580608)
print v(xbgr.mr_n59580720)
print v(xbgr.mr_n59581040)
print v(xbgr.mr_n59581152)
print v(xbgr.mr_n59581472)
print v(xbgr.mr_n59581584)
print v(xbgr.mr_n59581792)
print v(xbgr.mr_n59581904)
print v(xbgr.mr_n59582224)
print v(xbgr.mr_n59582336)
print v(xbgr.mr_n59582656)
print v(xbgr.mr_n59582768)
print v(xbgr.mr_n59583088)
print v(xbgr.mr_n59583200)
print v(xbgr.mr_n59583520)
print v(xbgr.mr_n59583632)
print v(xbgr.mr_n59583952)
print v(xbgr.mr_n59584064)
print v(xbgr.mr_n59584384)
print v(xbgr.mr_n59584496)
print v(xbgr.mr_n59584816)
print v(xbgr.mr_n59584928)
print v(xbgr.mr_n59585248)
print v(xbgr.mr_n59585360)
print v(xbgr.mr_n59585680)
print v(xbgr.mr_n59585792)
print v(xbgr.mr_n59586112)
print v(xbgr.mr_n59586224)
print v(xbgr.mr_n59586544)
print v(xbgr.mr_n59586656)
print v(xbgr.mr_n59586976)
print v(xbgr.mr_n59587088)
print v(xbgr.mr_n59587408)
print v(xbgr.mr_n59587520)
print v(xbgr.mr_n59587840)
print v(xbgr.mr_n59587952)
print v(xbgr.mr_n59588272)
print v(xbgr.mr_n59588384)
print v(xbgr.mr_n59588704)
print v(xbgr.mr_n59588816)
print v(xbgr.mr_n59589136)
print v(xbgr.mr_n59589248)
print v(xbgr.mr_n59589568)
print v(xbgr.mr_n59589680)
print v(xbgr.mr_n59590000)
print v(xbgr.mr_n59590112)
print v(xbgr.mr_n59590432)
print v(xbgr.mr_n59590544)
print v(xbgr.mr_n59590864)
print v(xbgr.mr_n59590976)
print v(xbgr.mr_n59591296)
print v(xbgr.mr_n59591408)
print v(xbgr.mr_n59591728)
print v(xbgr.mr_n59591840)
print v(xbgr.mr_n59592160)
print v(xbgr.mr_n59592272)
print v(xbgr.mr_n59592592)
print v(xbgr.mr_n59592704)
print v(xbgr.mr_n59593024)
print v(xbgr.mr_n59593136)
print v(xbgr.mr_n59593456)
print v(xbgr.mr_n59593568)
print v(xbgr.mr_n59593888)
print v(xbgr.mr_n59594000)
print v(xbgr.mr_n59594320)
print v(xbgr.mr_n59594432)
print v(xbgr.mr_n59594752)
print v(xbgr.mr_n59594864)
print v(xbgr.mr_n59595184)
print v(xbgr.mr_n59595296)
print v(xbgr.mr_n59595616)
print v(xbgr.mr_n59595728)
print v(xbgr.mr_n59596048)
print v(xbgr.mr_n59596160)
print v(xbgr.mr_n59596480)
print v(xbgr.mr_n59596592)
print v(xbgr.mr_n59596912)
print v(xbgr.mr_n59597024)
print v(xbgr.mr_n59597344)
print v(xbgr.mr_n59597456)
print v(xbgr.mr_n59597776)
print v(xbgr.mr_n59597888)
print v(xbgr.mr_n59598208)
print v(xbgr.mr_n59598320)
print v(xbgr.mr_n59598640)
print v(xbgr.mr_n59598752)
print v(xbgr.mr_n59599072)
print v(xbgr.mr_n59599184)
print v(xbgr.mr_n59599504)
print v(xbgr.mr_n59599616)
print v(xbgr.mr_n59599936)
print v(xbgr.mr_n59600048)
print v(xbgr.mr_n59600368)
print v(xbgr.mr_n59600480)
print v(xbgr.mr_n59600800)
print v(xbgr.mr_n59600912)
print v(xbgr.mr_n59601232)
print v(xbgr.mr_n59601344)
print v(xbgr.mr_n59601664)
print v(xbgr.mr_n59601776)
print v(xbgr.mr_n59602096)
print v(xbgr.mr_n59602208)
print v(xbgr.mr_n59602528)
print v(xbgr.mr_n59602640)
print v(xbgr.mr_n59602960)
print v(xbgr.mr_n59603072)
print v(xbgr.mr_n59603392)
print v(xbgr.mr_n59603504)
print v(xbgr.mr_n59603824)
print v(xbgr.mr_n59603936)
print v(xbgr.mr_n59604256)
print v(xbgr.mr_n59604368)
print v(xbgr.mr_n59604688)
print v(xbgr.mr_n59604800)
print v(xbgr.mr_n59605120)
print v(xbgr.mr_n59605232)
print v(xbgr.mr_n59605552)
print v(xbgr.mr_n59605664)
print v(xbgr.mr_n59605984)
print v(xbgr.mr_n59606096)
print v(xbgr.mr_n59606416)
print v(xbgr.mr_n59606528)
print v(xbgr.mr_n59606848)
print v(xbgr.mr_n59606960)
print v(xbgr.mr_n59607280)
print v(xbgr.mr_n59607392)
print v(xbgr.mr_n59607712)
print v(xbgr.mr_n59607824)
print v(xbgr.mr_n59608144)
print v(xbgr.mr_n59608256)
print v(xbgr.mr_n59608576)
print v(xbgr.mr_n59608688)
print v(xbgr.mr_n59609008)
print v(xbgr.mr_n59609120)
print v(xbgr.mr_n59609440)
print v(xbgr.mr_n59609552)
print v(xbgr.mr_n59609872)
print v(xbgr.mr_n59609984)
print v(xbgr.mr_n59610304)
print v(xbgr.mr_n59610416)
print v(xbgr.mr_n59610736)
print v(xbgr.mr_n59610848)
print v(xbgr.mr_n59611168)
print v(xbgr.mr_n59611280)
print v(xbgr.mr_n59611600)
print v(xbgr.mr_n59611712)
print v(xbgr.mr_n59612032)
print v(xbgr.mr_n59612144)
print v(xbgr.mr_n59612464)
print v(xbgr.mr_n59612576)
print v(xbgr.mr_n59612896)
print v(xbgr.mr_n59613008)
print v(xbgr.mr_n59613328)
print v(xbgr.mr_n59613440)
print v(xbgr.mr_n59613760)
print v(xbgr.mr_n59613872)
print v(xbgr.mr_n59614192)
print v(xbgr.mr_n59614304)
print v(xbgr.mr_n59614624)
print v(xbgr.mr_n59614736)
print v(xbgr.mr_n59615056)
print v(xbgr.mr_n59615168)
print v(xbgr.mr_n59615488)
print v(xbgr.mr_n59615600)
print v(xbgr.mr_n59615920)
print v(xbgr.mr_n59616032)
print v(xbgr.mr_n59616352)
print v(xbgr.mr_n59616464)
print v(xbgr.mr_n59616784)
print v(xbgr.mr_n59616896)
print v(xbgr.mr_n59617216)
print v(xbgr.mr_n59617328)
print v(xbgr.mr_n59617648)
print v(xbgr.mr_n59617760)
print v(xbgr.mr_n59618080)
print v(xbgr.mr_n59618192)
print v(xbgr.mr_n59618512)
print v(xbgr.mr_n59618624)
print v(xbgr.mr_n59618944)
print v(xbgr.mr_n59619056)
print v(xbgr.mr_n59619376)
print v(xbgr.mr_n59619488)
print v(xbgr.mr_n59619808)
print v(xbgr.mr_n59619920)
print v(xbgr.mr_n59620240)
print v(xbgr.mr_n59620352)
print v(xbgr.mr_n59620672)
print v(xbgr.mr_n59620784)
print v(xbgr.mr_n59621104)
print v(xbgr.mr_n59621216)
print v(xbgr.mr_n59621536)
print v(xbgr.mr_n59621648)
print v(xbgr.mr_n59621968)
print v(xbgr.mr_n59622080)
print v(xbgr.mr_n59622400)
print v(xbgr.mr_n59622512)
print v(xbgr.mr_n59622832)
print v(xbgr.mr_n59622944)
print v(xbgr.mr_n59623264)
print v(xbgr.mr_n59623376)
print v(xbgr.mr_n59623696)
print v(xbgr.mr_n59623808)
print v(xbgr.mr_n59624128)
print v(xbgr.mr_n59624240)
print v(xbgr.mr_n59624560)
print v(xbgr.mr_n59624672)
print v(xbgr.mr_n59624992)
print v(xbgr.mr_n59625104)
print v(xbgr.mr_n59625424)
print v(xbgr.mr_n59625536)
print v(xbgr.mr_n59625856)
print v(xbgr.mr_n59625968)
print v(xbgr.mr_n59626288)
print v(xbgr.mr_n59626400)
print v(xbgr.mr_n59626720)
print v(xbgr.mr_n59626832)
print v(xbgr.mr_n59627152)
print v(xbgr.mr_n59627264)
print v(xbgr.mr_n59627584)
print v(xbgr.mr_n59627696)
print v(xbgr.mr_n59628016)
print v(xbgr.mr_n59628128)
print v(xbgr.mr_n59628448)
print v(xbgr.mr_n59628560)
print v(xbgr.mr_n59628880)
print v(xbgr.mr_n59628992)
print v(xbgr.mr_n59629312)
print v(xbgr.mr_n59629424)
print v(xbgr.mr_n59629744)
print v(xbgr.mr_n59629856)
print v(xbgr.mr_n59630176)
print v(xbgr.mr_n59630288)
print v(xbgr.mr_n59630608)
print v(xbgr.mr_n59630720)
print v(xbgr.mr_n59631040)
print v(xbgr.mr_n59631152)
print v(xbgr.mr_n59631472)
print v(xbgr.mr_n59631584)
print v(xbgr.mr_n59631904)
print v(xbgr.mr_n59632016)
print v(xbgr.mr_n59632336)
print v(xbgr.mr_n59632448)
print v(xbgr.mr_n59632768)
print v(xbgr.mr_n59632880)
print v(xbgr.mr_n59633200)
print v(xbgr.mr_n59633312)
print v(xbgr.mr_n59633632)
print v(xbgr.mr_n59633744)
print v(xbgr.mr_n59634064)
print v(xbgr.mr_n59634176)
print v(xbgr.mr_n59634496)
print v(xbgr.mr_n59634608)
print v(xbgr.mr_n59634928)
print v(xbgr.mr_n59635040)
print v(xbgr.mr_n59635360)
print v(xbgr.mr_n59635472)
print v(xbgr.mr_n59635792)
print v(xbgr.mr_n59635904)
print v(xbgr.mr_n59636224)
print v(xbgr.mr_n59636336)
print v(xbgr.mr_n59636656)
print v(xbgr.mr_n59636768)
print v(xbgr.mr_n59637088)
print v(xbgr.mr_n59637200)
print v(xbgr.mr_n59637520)
print v(xbgr.mr_n59637632)
print v(xbgr.mr_n59637952)
print v(xbgr.mr_n59638064)
print v(xbgr.mr_n59638384)
print v(xbgr.mr_n59638496)
print v(xbgr.mr_n59638816)
print v(xbgr.mr_n59638928)
print v(xbgr.mr_n59639248)
print v(xbgr.mr_n59639360)
print v(xbgr.mr_n59639680)
print v(xbgr.mr_n59639792)
print v(xbgr.mr_n59640112)
print v(xbgr.mr_n59640224)
print v(xbgr.mr_n59640544)
print v(xbgr.mr_n59640656)
print v(xbgr.mr_n59640976)
print v(xbgr.mr_n59641088)
print v(xbgr.mr_n59641408)
print v(xbgr.mr_n59641520)
print v(xbgr.mr_n59641840)
print v(xbgr.mr_n59641952)
print v(xbgr.mr_n59642272)
print v(xbgr.mr_n59642384)
print v(xbgr.mr_n59642704)
print v(xbgr.mr_n59642816)
print v(xbgr.mr_n59643344)
print v(xbgr.mr_n59643456)
print v(xbgr.mr_n59643776)
print v(xbgr.mr_n59643888)
print v(xbgr.mr_n59644208)
print v(xbgr.mr_n59644320)
print v(xbgr.mr_n59644640)
print v(xbgr.mr_n59644752)
print v(xbgr.mr_n59645072)
print v(xbgr.mr_n59645184)
print v(xbgr.mr_n59645504)
print v(xbgr.mr_n59645616)
print v(xbgr.mr_n59645936)
print v(xbgr.mr_n59646048)
print v(xbgr.mr_n59646368)
print v(xbgr.mr_n59646480)
print v(xbgr.mr_n59646800)
print v(xbgr.mr_n59646912)
print v(xbgr.mr_n59647232)
print v(xbgr.mr_n59647344)
print v(xbgr.mr_n59647664)
print v(xbgr.mr_n59647776)
print v(xbgr.mr_n59648096)
print v(xbgr.mr_n59648208)
print v(xbgr.mr_n59648528)
print v(xbgr.mr_n59648640)
print v(xbgr.mr_n59648960)
print v(xbgr.mr_n59649072)
print v(xbgr.mr_n59649392)
print v(xbgr.mr_n59649504)
print v(xbgr.mr_n59649824)
print v(xbgr.mr_n59649936)
print v(xbgr.mr_n59650256)
print v(xbgr.mr_n59650368)
print v(xbgr.mr_n59650688)
print v(xbgr.mr_n59650800)
print v(xbgr.mr_n59651120)
print v(xbgr.mr_n59651232)
print v(xbgr.mr_n59651552)
print v(xbgr.mr_n59651664)
print v(xbgr.mr_n59651984)
print v(xbgr.mr_n59652096)
print v(xbgr.mr_n59652416)
print v(xbgr.mr_n59652528)
print v(xbgr.mr_n59652848)
print v(xbgr.mr_n59652960)
print v(xbgr.mr_n59653280)
print v(xbgr.mr_n59653392)
print v(xbgr.mr_n59653712)
print v(xbgr.mr_n59653824)
print v(xbgr.mr_n59654144)
print v(xbgr.mr_n59654256)
print v(xbgr.mr_n59654576)
print v(xbgr.mr_n59654688)
print v(xbgr.mr_n59655008)
print v(xbgr.mr_n59655120)
print v(xbgr.mr_n59655440)
print v(xbgr.mr_n59655552)
print v(xbgr.mr_n59655872)
print v(xbgr.mr_n59655984)
print v(xbgr.mr_n59656304)
print v(xbgr.mr_n59656416)
print v(xbgr.mr_n59656736)
print v(xbgr.mr_n59656848)
print v(xbgr.mr_n59657168)
print v(xbgr.mr_n59657280)
print v(xbgr.mr_n59657600)
print v(xbgr.mr_n59657712)
print v(xbgr.mr_n59658032)
print v(xbgr.mr_n59658144)
print v(xbgr.mr_n59658464)
print v(xbgr.mr_n59658576)
print v(xbgr.mr_n59658896)
print v(xbgr.mr_n59659008)
print v(xbgr.mr_n59659328)
print v(xbgr.mr_n59659440)
print v(xbgr.mr_n59659760)
print v(xbgr.mr_n59659872)
print v(xbgr.mr_n59660192)
print v(xbgr.mr_n59660304)
print v(xbgr.mr_n59660624)
print v(xbgr.mr_n59660736)
print v(xbgr.mr_n59661056)
print v(xbgr.mr_n59661168)
print v(xbgr.mr_n59661488)
print v(xbgr.mr_n59661600)
print v(xbgr.mr_n59661920)
print v(xbgr.mr_n59662032)
print v(xbgr.mr_n59662352)
print v(xbgr.mr_n59662464)
print v(xbgr.mr_n59662784)
print v(xbgr.mr_n59662896)
print v(xbgr.mr_n59663216)
print v(xbgr.mr_n59663328)
print v(xbgr.mr_n59663648)
print v(xbgr.mr_n59663760)
print v(xbgr.mr_n59664080)
print v(xbgr.mr_n59664192)
print v(xbgr.mr_n59664512)
print v(xbgr.mr_n59664624)
print v(xbgr.mr_n59664944)
print v(xbgr.mr_n59665056)
print v(xbgr.mr_n59665376)
print v(xbgr.mr_n59665488)
print v(xbgr.mr_n59665808)
print v(xbgr.mr_n59665920)
print v(xbgr.mr_n59666240)
print v(xbgr.mr_n59666352)
print v(xbgr.mr_n59666672)
print v(xbgr.mr_n59666784)
print v(xbgr.mr_n59667104)
print v(xbgr.mr_n59667216)
print v(xbgr.mr_n59667536)
print v(xbgr.mr_n59667648)
print v(xbgr.mr_n59667968)
print v(xbgr.mr_n59668080)
print v(xbgr.mr_n59668400)
print v(xbgr.mr_n59668512)
print v(xbgr.mr_n59668832)
print v(xbgr.mr_n59668944)
print v(xbgr.mr_n59669264)
print v(xbgr.mr_n59669376)
print v(xbgr.mr_n59669696)
print v(xbgr.mr_n59669808)
print v(xbgr.mr_n59670128)
print v(xbgr.mr_n59670240)
print v(xbgr.mr_n59670560)
print v(xbgr.mr_n59670672)
print v(xbgr.mr_n59670992)
print v(xbgr.mr_n59671104)
print v(xbgr.mr_n59671424)
print v(xbgr.mr_n59671536)
print v(xbgr.mr_n59671856)
print v(xbgr.mr_n59671968)
print v(xbgr.mr_n59672288)
print v(xbgr.mr_n59672400)
print v(xbgr.mr_n59672720)
print v(xbgr.mr_n59672832)
print v(xbgr.mr_n59673152)
print v(xbgr.mr_n59673264)
print v(xbgr.mr_n59673584)
print v(xbgr.mr_n59673696)
print v(xbgr.mr_n59674016)
print v(xbgr.mr_n59674128)
print v(xbgr.mr_n59674448)
print v(xbgr.mr_n59674560)
print v(xbgr.mr_n59674880)
print v(xbgr.mr_n59674992)
print v(xbgr.mr_n59675312)
print v(xbgr.mr_n59675424)
print v(xbgr.mr_n59675744)
print v(xbgr.mr_n59675856)
print v(xbgr.mr_n59676176)
print v(xbgr.mr_n59676288)
print v(xbgr.mr_n59676608)
print v(xbgr.mr_n59676720)
print v(xbgr.mr_n59677040)
print v(xbgr.mr_n59677152)
print v(xbgr.mr_n59677472)
print v(xbgr.mr_n59677584)
print v(xbgr.mr_n59677904)
print v(xbgr.mr_n59678016)
print v(xbgr.mr_n59678336)
print v(xbgr.mr_n59678448)
print v(xbgr.mr_n59678768)
print v(xbgr.mr_n59678880)
print v(xbgr.mr_n59679200)
print v(xbgr.mr_n59679312)
print v(xbgr.mr_n59679632)
print v(xbgr.mr_n59679744)
print v(xbgr.mr_n59680064)
print v(xbgr.mr_n59680176)
print v(xbgr.mr_n59680496)
print v(xbgr.mr_n59680608)
print v(xbgr.mr_n59680928)
print v(xbgr.mr_n59681040)
print v(xbgr.mr_n59681360)
print v(xbgr.mr_n59681472)
print v(xbgr.mr_n59681792)
print v(xbgr.mr_n59681904)
print v(xbgr.mr_n59682224)
print v(xbgr.mr_n59682336)
print v(xbgr.mr_n59682656)
print v(xbgr.mr_n59682768)
print v(xbgr.mr_n59945248)
print v(xbgr.mr_n59945488)
print v(xbgr.mr_n59945600)
print v(xbgr.mr_n59945920)
print v(xbgr.mr_n59946032)
print v(xbgr.mr_n59946352)
print v(xbgr.mr_n59946464)
print v(xbgr.mr_n59946784)
print v(xbgr.mr_n59946896)
print v(xbgr.mr_n59947216)
print v(xbgr.mr_n59947328)
print v(xbgr.mr_n59947648)
print v(xbgr.mr_n59947760)
print v(xbgr.mr_n59948080)
print v(xbgr.mr_n59948192)
print v(xbgr.mr_n59948512)
print v(xbgr.mr_n59948624)
print v(xbgr.mr_n59948944)
print v(xbgr.mr_n59949056)
print v(xbgr.mr_n59949376)
print v(xbgr.mr_n59949488)
print v(xbgr.mr_n59949808)
print v(xbgr.mr_n59949920)
print v(xbgr.mr_n59950240)
print v(xbgr.mr_n59950352)
print v(xbgr.mr_n59950672)
print v(xbgr.mr_n59950784)
print v(xbgr.mr_n59951104)
print v(xbgr.mr_n59951216)
print v(xbgr.mr_n59951536)
print v(xbgr.mr_n59951648)
print v(xbgr.mr_n59951968)
print v(xbgr.mr_n59952080)
print v(xbgr.mr_n59952400)
print v(xbgr.mr_n59952512)
print v(xbgr.mr_n59952832)
print v(xbgr.mr_n59952944)
print v(xbgr.mr_n59953264)
print v(xbgr.mr_n59953376)
print v(xbgr.mr_n59953696)
print v(xbgr.mr_n59953808)
print v(xbgr.mr_n59954128)
print v(xbgr.mr_n59954240)
print v(xbgr.mr_n59954560)
print v(xbgr.mr_n59954672)
print v(xbgr.mr_n59954992)
print v(xbgr.mr_n59955104)
print v(xbgr.mr_n59955424)
print v(xbgr.mr_n59955536)
print v(xbgr.mr_n59955856)
print v(xbgr.mr_n59955968)
print v(xbgr.mr_n59956288)
print v(xbgr.mr_n59956400)
print v(xbgr.mr_n59956720)
print v(xbgr.mr_n59956832)
print v(xbgr.mr_n59957152)
print v(xbgr.mr_n59957264)
print v(xbgr.mr_n59957584)
print v(xbgr.mr_n59957696)
print v(xbgr.mr_n59958016)
print v(xbgr.mr_n59958128)
print v(xbgr.mr_n59958448)
print v(xbgr.mr_n59958560)
print v(xbgr.mr_n59958880)
print v(xbgr.mr_n59958992)
print v(xbgr.mr_n59959312)
print v(xbgr.mr_n59959424)
print v(xbgr.mr_n59959744)
print v(xbgr.mr_n59959856)
print v(xbgr.mr_n59960176)
print v(xbgr.mr_n59960288)
print v(xbgr.mr_n59960608)
print v(xbgr.mr_n59960720)
print v(xbgr.mr_n59961040)
print v(xbgr.mr_n59961152)
print v(xbgr.mr_n59961472)
print v(xbgr.mr_n59961584)
print v(xbgr.mr_n59961904)
print v(xbgr.mr_n59962016)
print v(xbgr.mr_n59962336)
print v(xbgr.mr_n59962448)
print v(xbgr.mr_n59962768)
print v(xbgr.mr_n59962880)
print v(xbgr.mr_n59963200)
print v(xbgr.mr_n59963312)
print v(xbgr.mr_n59963632)
print v(xbgr.mr_n59963744)
print v(xbgr.mr_n59964064)
print v(xbgr.mr_n59964176)
print v(xbgr.mr_n59964496)
print v(xbgr.mr_n59964608)
print v(xbgr.mr_n59964928)
print v(xbgr.mr_n59965040)
print v(xbgr.mr_n59965360)
print v(xbgr.mr_n59965472)
print v(xbgr.mr_n59965792)
print v(xbgr.mr_n59965904)
print v(xbgr.mr_n59966224)
print v(xbgr.mr_n59966336)
print v(xbgr.mr_n59966656)
print v(xbgr.mr_n59966768)
print v(xbgr.mr_n59967088)
print v(xbgr.mr_n59967200)
print v(xbgr.mr_n59967520)
print v(xbgr.mr_n59967632)
print v(xbgr.mr_n59967952)
print v(xbgr.mr_n59968064)
print v(xbgr.mr_n59968384)
print v(xbgr.mr_n59968496)
print v(xbgr.mr_n59968816)
print v(xbgr.mr_n59968928)
print v(xbgr.mr_n59969248)
print v(xbgr.mr_n59969360)
print v(xbgr.mr_n59969680)
print v(xbgr.mr_n59969792)
print v(xbgr.mr_n59970112)
print v(xbgr.mr_n59970224)
print v(xbgr.mr_n59970544)
print v(xbgr.mr_n59970656)
print v(xbgr.mr_n59970976)
print v(xbgr.mr_n59971088)
print v(xbgr.mr_n59971408)
print v(xbgr.mr_n59971520)
print v(xbgr.mr_n59971840)
print v(xbgr.mr_n59971952)
print v(xbgr.mr_n59972272)
print v(xbgr.mr_n59972384)
print v(xbgr.mr_n59972704)
print v(xbgr.mr_n59972816)
print v(xbgr.mr_n59973136)
print v(xbgr.mr_n59973248)
print v(xbgr.mr_n59973568)
print v(xbgr.mr_n59973680)
print v(xbgr.mr_n59974000)
print v(xbgr.mr_n59974112)
print v(xbgr.mr_n59974432)
print v(xbgr.mr_n59974544)
print v(xbgr.mr_n59974864)
print v(xbgr.mr_n59974976)
print v(xbgr.mr_n59975296)
print v(xbgr.mr_n59975408)
print v(xbgr.mr_n59975728)
print v(xbgr.mr_n59975840)
print v(xbgr.mr_n59976160)
print v(xbgr.mr_n59976272)
print v(xbgr.mr_n59976592)
print v(xbgr.mr_n59976704)
print v(xbgr.mr_n59977024)
print v(xbgr.mr_n59977136)
print v(xbgr.mr_n59977456)
print v(xbgr.mr_n59977568)
print v(xbgr.mr_n59977888)
print v(xbgr.mr_n59978000)
print v(xbgr.mr_n59978320)
print v(xbgr.mr_n59978432)
print v(xbgr.mr_n59978752)
print v(xbgr.mr_n59978864)
print v(xbgr.mr_n59979184)
print v(xbgr.mr_n59979296)
print v(xbgr.mr_n59979616)
print v(xbgr.mr_n59979728)
print v(xbgr.mr_n59980048)
print v(xbgr.mr_n59980160)
print v(xbgr.mr_n59980480)
print v(xbgr.mr_n59980592)
print v(xbgr.mr_n59980912)
print v(xbgr.mr_n59981024)
print v(xbgr.mr_n59981344)
print v(xbgr.mr_n59981456)
print v(xbgr.mr_n59981776)
print v(xbgr.mr_n59981888)
print v(xbgr.mr_n59982208)
print v(xbgr.mr_n59982320)
print v(xbgr.mr_n59982640)
print v(xbgr.mr_n59982752)
print v(xbgr.mr_n59983072)
print v(xbgr.mr_n59983184)
print v(xbgr.mr_n59983504)
print v(xbgr.mr_n59983616)
print v(xbgr.mr_n59983936)
print v(xbgr.mr_n59984048)
print v(xbgr.mr_n59984368)
print v(xbgr.mr_n59984480)
print v(xbgr.mr_n59984800)
print v(xbgr.mr_n59984912)
print v(xbgr.mr_n59985232)
print v(xbgr.mr_n59985344)
print v(xbgr.mr_n59985664)
print v(xbgr.mr_n59985776)
print v(xbgr.mr_n59986096)
print v(xbgr.mr_n59986208)
print v(xbgr.mr_n59986528)
print v(xbgr.mr_n59986640)
print v(xbgr.mr_n59986960)
print v(xbgr.mr_n59987072)
print v(xbgr.mr_n59987392)
print v(xbgr.mr_n59987504)
print v(xbgr.mr_n59987824)
print v(xbgr.mr_n59987936)
print v(xbgr.mr_n59988256)
print v(xbgr.mr_n59988368)
print v(xbgr.mr_n59988688)
print v(xbgr.mr_n59988800)
print v(xbgr.mr_n59989120)
print v(xbgr.mr_n59989232)
print v(xbgr.mr_n59989552)
print v(xbgr.mr_n59989664)
print v(xbgr.mr_n59989984)
print v(xbgr.mr_n59990096)
print v(xbgr.mr_n59990416)
print v(xbgr.mr_n59990528)
print v(xbgr.mr_n59990848)
print v(xbgr.mr_n59990960)
print v(xbgr.mr_n59991280)
print v(xbgr.mr_n59991392)
print v(xbgr.mr_n59991712)
print v(xbgr.mr_n59991824)
print v(xbgr.mr_n59992144)
print v(xbgr.mr_n59992256)
print v(xbgr.mr_n59992576)
print v(xbgr.mr_n59992688)
print v(xbgr.mr_n59993008)
print v(xbgr.mr_n59993120)
print v(xbgr.mr_n59993440)
print v(xbgr.mr_n59993552)
print v(xbgr.mr_n59993872)
print v(xbgr.mr_n59993984)
print v(xbgr.mr_n59994304)
print v(xbgr.mr_n59994416)
print v(xbgr.mr_n59994736)
print v(xbgr.mr_n59994848)
print v(xbgr.mr_n59995168)
print v(xbgr.mr_n59995280)
print v(xbgr.mr_n59995600)
print v(xbgr.mr_n59995712)
print v(xbgr.mr_n59996032)
print v(xbgr.mr_n59996144)
print v(xbgr.mr_n59996464)
print v(xbgr.mr_n59996576)
print v(xbgr.mr_n59996896)
print v(xbgr.mr_n59997008)
print v(xbgr.mr_n59997328)
print v(xbgr.mr_n59997440)
print v(xbgr.mr_n59997760)
print v(xbgr.mr_n59997872)
print v(xbgr.mr_n59998192)
print v(xbgr.mr_n59998304)
print v(xbgr.mr_n59998624)
print v(xbgr.mr_n59998736)
print v(xbgr.mr_n59999056)
print v(xbgr.mr_n59999168)
print v(xbgr.mr_n59999488)
print v(xbgr.mr_n59999600)
print v(xbgr.mr_n59999920)
print v(xbgr.mr_n60000032)
print v(xbgr.mr_n60000352)
print v(xbgr.mr_n60000464)
print v(xbgr.mr_n60000784)
print v(xbgr.mr_n60000896)
print v(xbgr.mr_n60001216)
print v(xbgr.mr_n60001328)
print v(xbgr.mr_n60001648)
print v(xbgr.mr_n60001760)
print v(xbgr.mr_n60002080)
print v(xbgr.mr_n60002192)
print v(xbgr.mr_n60002512)
print v(xbgr.mr_n60002624)
print v(xbgr.mr_n60002944)
print v(xbgr.mr_n60003056)
print v(xbgr.mr_n60003376)
print v(xbgr.mr_n60003488)
print v(xbgr.mr_n60003808)
print v(xbgr.mr_n60003920)
print v(xbgr.mr_n60004240)
print v(xbgr.mr_n60004352)
print v(xbgr.mr_n60004672)
print v(xbgr.mr_n60004784)
print v(xbgr.mr_n60005104)
print v(xbgr.mr_n60005216)
print v(xbgr.mr_n60005536)
print v(xbgr.mr_n60005648)
print v(xbgr.mr_n60005968)
print v(xbgr.mr_n60006080)
print v(xbgr.mr_n60006400)
print v(xbgr.mr_n60006512)
print v(xbgr.mr_n60006832)
print v(xbgr.mr_n60006944)
print v(xbgr.mr_n60007264)
print v(xbgr.mr_n60007376)
print v(xbgr.mr_n60007696)
print v(xbgr.mr_n60007808)
print v(xbgr.mr_n60008128)
print v(xbgr.mr_n60008240)
print v(xbgr.mr_n60008560)
print v(xbgr.mr_n60008672)
print v(xbgr.mr_n60008992)
print v(xbgr.mr_n60009104)
print v(xbgr.mr_n60009424)
print v(xbgr.mr_n60009536)
print v(xbgr.mr_n60009856)
print v(xbgr.mr_n60009968)
print v(xbgr.mr_n60010288)
print v(xbgr.mr_n60010400)
print v(xbgr.mr_n60010720)
print v(xbgr.mr_n60010832)
print v(xbgr.mr_n60011152)
print v(xbgr.mr_n60011264)
print v(xbgr.mr_n60011584)
print v(xbgr.mr_n60011696)
print v(xbgr.mr_n60012016)
print v(xbgr.mr_n60012128)
print v(xbgr.mr_n60012448)
print v(xbgr.mr_n60012560)
print v(xbgr.mr_n60012880)
print v(xbgr.mr_n60012992)
print v(xbgr.mr_n60013312)
print v(xbgr.mr_n60013424)
print v(xbgr.mr_n60013744)
print v(xbgr.mr_n60013856)
print v(xbgr.mr_n60014176)
print v(xbgr.mr_n60014288)
print v(xbgr.mr_n60014608)
print v(xbgr.mr_n60014720)
print v(xbgr.mr_n60015040)
print v(xbgr.mr_n60015152)
print v(xbgr.mr_n60015472)
print v(xbgr.mr_n60015584)
print v(xbgr.mr_n60015904)
print v(xbgr.mr_n60016016)
print v(xbgr.mr_n60016336)
print v(xbgr.mr_n60016448)
print v(xbgr.mr_n60016768)
print v(xbgr.mr_n60016880)
print v(xbgr.mr_n60017200)
print v(xbgr.mr_n60017312)
print v(xbgr.mr_n60017632)
print v(xbgr.mr_n60017744)
print v(xbgr.mr_n60018064)
print v(xbgr.mr_n60018176)
print v(xbgr.mr_n60018496)
print v(xbgr.mr_n60018608)
print v(xbgr.mr_n60018928)
print v(xbgr.mr_n60019040)
print v(xbgr.mr_n60019360)
print v(xbgr.mr_n60019472)
print v(xbgr.mr_n60019792)
print v(xbgr.mr_n60019904)
print v(xbgr.mr_n60020224)
print v(xbgr.mr_n60020336)
print v(xbgr.mr_n60020656)
print v(xbgr.mr_n60020768)
print v(xbgr.mr_n60021088)
print v(xbgr.mr_n60021200)
print v(xbgr.mr_n60021520)
print v(xbgr.mr_n60021632)
print v(xbgr.mr_n60021952)
print v(xbgr.mr_n60022064)
print v(xbgr.mr_n60022384)
print v(xbgr.mr_n60022496)
print v(xbgr.mr_n60022816)
print v(xbgr.mr_n60022928)
print v(xbgr.mr_n60023248)
print v(xbgr.mr_n60023360)
print v(xbgr.mr_n60023680)
print v(xbgr.mr_n60023792)
print v(xbgr.mr_n60024112)
print v(xbgr.mr_n60024224)
print v(xbgr.mr_n60024544)
print v(xbgr.mr_n60024656)
print v(xbgr.mr_n60024976)
print v(xbgr.mr_n60025088)
print v(xbgr.mr_n60025408)
print v(xbgr.mr_n60025520)
print v(xbgr.mr_n60025840)
print v(xbgr.mr_n60025952)
print v(xbgr.mr_n60026272)
print v(xbgr.mr_n60026384)
print v(xbgr.mr_n60026704)
print v(xbgr.mr_n60026816)
print v(xbgr.mr_n60027136)
print v(xbgr.mr_n60027248)
print v(xbgr.mr_n60027568)
print v(xbgr.mr_n60027680)
print v(xbgr.mr_n60028000)
print v(xbgr.mr_n60028112)
print v(xbgr.mr_n60028432)
print v(xbgr.mr_n60028544)
print v(xbgr.mr_n60028864)
print v(xbgr.mr_n60028976)
print v(xbgr.mr_n60029296)
print v(xbgr.mr_n60029408)
print v(xbgr.mr_n60029728)
print v(xbgr.mr_n60029840)
print v(xbgr.mr_n60030160)
print v(xbgr.mr_n60030272)
print v(xbgr.mr_n60030592)
print v(xbgr.mr_n60030704)
print v(xbgr.mr_n60031024)
print v(xbgr.mr_n60031136)
print v(xbgr.mr_n60031456)
print v(xbgr.mr_n60031568)
print v(xbgr.mr_n60031888)
print v(xbgr.mr_n60032000)
print v(xbgr.mr_n60032320)
print v(xbgr.mr_n60032432)
print v(xbgr.mr_n60032752)
print v(xbgr.mr_n60032864)
print v(xbgr.mr_n60033184)
print v(xbgr.mr_n60033296)
print v(xbgr.mr_n60033616)
print v(xbgr.mr_n60033728)
print v(xbgr.mr_n60034048)
print v(xbgr.mr_n60034160)
print v(xbgr.mr_n60034480)
print v(xbgr.mr_n60034592)
print v(xbgr.mr_n60034912)
print v(xbgr.mr_n60035024)
print v(xbgr.mr_n60035344)
print v(xbgr.mr_n60035456)
print v(xbgr.mr_n60035776)
print v(xbgr.mr_n60035888)
print v(xbgr.mr_n60036208)
print v(xbgr.mr_n60036320)
print v(xbgr.mr_n60036640)
print v(xbgr.mr_n60036752)
print v(xbgr.mr_n60037072)
print v(xbgr.mr_n60037184)
print v(xbgr.mr_n60037504)
print v(xbgr.mr_n60037616)
print v(xbgr.mr_n60037936)
print v(xbgr.mr_n60038048)
print v(xbgr.mr_n60038368)
print v(xbgr.mr_n60038480)
print v(xbgr.mr_n60038800)
print v(xbgr.mr_n60038912)
print v(xbgr.mr_n60039232)
print v(xbgr.mr_n60039344)
print v(xbgr.mr_n60039664)
print v(xbgr.mr_n60039776)
print v(xbgr.mr_n60040096)
print v(xbgr.mr_n60040208)
print v(xbgr.mr_n60040528)
print v(xbgr.mr_n60040640)
print v(xbgr.mr_n60040960)
print v(xbgr.mr_n60041072)
print v(xbgr.mr_n60041392)
print v(xbgr.mr_n60041504)
print v(xbgr.mr_n60041824)
print v(xbgr.mr_n60041936)
print v(xbgr.mr_n60042256)
print v(xbgr.mr_n60042368)
print v(xbgr.mr_n60042688)
print v(xbgr.mr_n60042800)
print v(xbgr.mr_n60043120)
print v(xbgr.mr_n60043232)
print v(xbgr.mr_n60043552)
print v(xbgr.mr_n60043664)
print v(xbgr.mr_n60043984)
print v(xbgr.mr_n60044096)
print v(xbgr.mr_n60044416)
print v(xbgr.mr_n60044528)
print v(xbgr.mr_n60044848)
print v(xbgr.mr_n60044960)
print v(xbgr.mr_n60045280)
print v(xbgr.mr_n60045392)
print v(xbgr.mr_n60045712)
print v(xbgr.mr_n60045824)
print v(xbgr.mr_n60046144)
print v(xbgr.mr_n60046256)
print v(xbgr.mr_n60046576)
print v(xbgr.mr_n60046688)
print v(xbgr.mr_n60047008)
print v(xbgr.mr_n60047120)
print v(xbgr.mr_n60047440)
print v(xbgr.mr_n60047552)
print v(xbgr.mr_n60047872)
print v(xbgr.mr_n60047984)
print v(xbgr.mr_n60048304)
print v(xbgr.mr_n60048416)
print v(xbgr.mr_n60048736)
print v(xbgr.mr_n60048848)
print v(xbgr.mr_n60049168)
print v(xbgr.mr_n60049280)
print v(xbgr.mr_n60049600)
print v(xbgr.mr_n60049712)
print v(xbgr.mr_n60050032)
print v(xbgr.mr_n60050144)
print v(xbgr.mr_n60050464)
print v(xbgr.mr_n60050576)
print v(xbgr.mr_n60050896)
print v(xbgr.mr_n60051008)
print v(xbgr.mr_n60051328)
print v(xbgr.mr_n60051440)
print v(xbgr.mr_n60051760)
print v(xbgr.mr_n60051872)
print v(xbgr.mr_n60052192)
print v(xbgr.mr_n60052304)
print v(xbgr.mr_n60052624)
print v(xbgr.mr_n60052736)
print v(xbgr.mr_n60053056)
print v(xbgr.mr_n60053168)
print v(xbgr.mr_n60053488)
print v(xbgr.mr_n60053600)
print v(xbgr.mr_n60053920)
print v(xbgr.mr_n60054032)
print v(xbgr.mr_n60054352)
print v(xbgr.mr_n60054464)
print v(xbgr.mr_n60054784)
print v(xbgr.mr_n60054896)
print v(xbgr.mr_n60055216)
print v(xbgr.mr_n60055328)
print v(xbgr.mr_n60055648)
print v(xbgr.mr_n60055760)
print v(xbgr.mr_n60056080)
print v(xbgr.mr_n60056192)
print v(xbgr.mr_n60056512)
print v(xbgr.mr_n60056624)
print v(xbgr.mr_n60056944)
print v(xbgr.mr_n60057056)
print v(xbgr.mr_n60057376)
print v(xbgr.mr_n60057488)
print v(xbgr.mr_n60057808)
print v(xbgr.mr_n60057920)
print v(xbgr.mr_n60058240)
print v(xbgr.mr_n60058352)
print v(xbgr.mr_n60058672)
print v(xbgr.mr_n60058784)
print v(xbgr.mr_n60059104)
print v(xbgr.mr_n60059216)
print v(xbgr.mr_n60059536)
print v(xbgr.mr_n60059648)
print v(xbgr.mr_n60059968)
print v(xbgr.mr_n60060080)
print v(xbgr.mr_n60060400)
print v(xbgr.mr_n60060512)
print v(xbgr.mr_n60060832)
print v(xbgr.mr_n60060944)
print v(xbgr.mr_n60061264)
print v(xbgr.mr_n60061376)
print v(xbgr.mr_n60061696)
print v(xbgr.mr_n60061808)
print v(xbgr.mr_n60062128)
print v(xbgr.mr_n60062240)
print v(xbgr.mr_n60062560)
print v(xbgr.mr_n60062672)
print v(xbgr.mr_n60062992)
print v(xbgr.mr_n60063104)
print v(xbgr.mr_n60063424)
print v(xbgr.mr_n60063536)
print v(xbgr.mr_n60063856)
print v(xbgr.mr_n60063968)
print v(xbgr.mr_n60064288)
print v(xbgr.mr_n60064400)
print v(xbgr.mr_n60064720)
print v(xbgr.mr_n60064832)
print v(xbgr.mr_n60065152)
print v(xbgr.mr_n60065264)
print v(xbgr.mr_n60065584)
print v(xbgr.mr_n60065696)
print v(xbgr.mr_n60066016)
print v(xbgr.mr_n60066128)
print v(xbgr.mr_n60066448)
print v(xbgr.mr_n60066560)
print v(xbgr.mr_n60066880)
print v(xbgr.mr_n60066992)
print v(xbgr.mr_n60067312)
print v(xbgr.mr_n60067424)
print v(xbgr.mr_n60067744)
print v(xbgr.mr_n60067856)
print v(xbgr.mr_n60068176)
print v(xbgr.mr_n60068288)
print v(xbgr.mr_n60068608)
print v(xbgr.mr_n60068720)
print v(xbgr.mr_n60069040)
print v(xbgr.mr_n60069152)
print v(xbgr.mr_n60069472)
print v(xbgr.mr_n60069584)
print v(xbgr.mr_n60069904)
print v(xbgr.mr_n60070016)
print v(xbgr.mr_n60070336)
print v(xbgr.mr_n60070448)
print v(xbgr.mr_n60070768)
print v(xbgr.mr_n60070880)
print v(xbgr.mr_n60071200)
print v(xbgr.mr_n60071312)
print v(xbgr.mr_n60071632)
print v(xbgr.mr_n60071744)
print v(xbgr.mr_n60072064)
print v(xbgr.mr_n60072176)
print v(xbgr.mr_n60072496)
print v(xbgr.mr_n60072608)
print v(xbgr.mr_n60072928)
print v(xbgr.mr_n60073040)
print v(xbgr.mr_n60073360)
print v(xbgr.mr_n60073472)
print v(xbgr.mr_n60073792)
print v(xbgr.mr_n60073904)
print v(xbgr.mr_n60074224)
print v(xbgr.mr_n60074336)
print v(xbgr.mr_n60074656)
print v(xbgr.mr_n60074768)
print v(xbgr.mr_n60075088)
print v(xbgr.mr_n60075200)
print v(xbgr.mr_n60075520)
print v(xbgr.mr_n60075632)
print v(xbgr.mr_n60075952)
print v(xbgr.mr_n60076064)
print v(xbgr.mr_n60076384)
print v(xbgr.mr_n60076496)
print v(xbgr.mr_n60076816)
print v(xbgr.mr_n60076928)
print v(xbgr.mr_n60077248)
print v(xbgr.mr_n60077360)
print v(xbgr.mr_n60077680)
print v(xbgr.mr_n60077792)
print v(xbgr.mr_n60078112)
print v(xbgr.mr_n60078224)
print v(xbgr.mr_n60078544)
print v(xbgr.mr_n60078656)
print v(xbgr.mr_n60078976)
print v(xbgr.mr_n60079088)
print v(xbgr.mr_n60079408)
print v(xbgr.mr_n60079520)
print v(xbgr.mr_n60079840)
print v(xbgr.mr_n60079952)
print v(xbgr.mr_n60080272)
print v(xbgr.mr_n60080384)
print v(xbgr.mr_n60080704)
print v(xbgr.mr_n60080816)
print v(xbgr.mr_n60081136)
print v(xbgr.mr_n60081248)
print v(xbgr.mr_n60081568)
print v(xbgr.mr_n60081680)
print v(xbgr.mr_n60082000)
print v(xbgr.mr_n60082112)
print v(xbgr.mr_n60082432)
print v(xbgr.mr_n60082544)
print v(xbgr.mr_n60082864)
print v(xbgr.mr_n60082976)
print v(xbgr.mr_n60083296)
print v(xbgr.mr_n60083408)
print v(xbgr.mr_n60083728)
print v(xbgr.mr_n60083840)
print v(xbgr.mr_n60084160)
print v(xbgr.mr_n60084272)
print v(xbgr.mr_n60084592)
print v(xbgr.mr_n60084704)
print v(xbgr.mr_n60085024)
print v(xbgr.mr_n60085136)
print v(xbgr.mr_n60085456)
print v(xbgr.mr_n60085568)
print v(xbgr.mr_n60085888)
print v(xbgr.mr_n60086000)
print v(xbgr.mr_n60086320)
print v(xbgr.mr_n60086432)
print v(xbgr.mr_n60086752)
print v(xbgr.mr_n60086864)
print v(xbgr.mr_n60087184)
print v(xbgr.mr_n60087296)
print v(xbgr.mr_n60087616)
print v(xbgr.mr_n60087728)
print v(xbgr.mr_n60088048)
print v(xbgr.mr_n60088160)
print v(xbgr.mr_n60088480)
print v(xbgr.mr_n60088592)
print v(xbgr.mr_n60088912)
print v(xbgr.mr_n60089024)
print v(xbgr.mr_n60089344)
print v(xbgr.mr_n60089456)
print v(xbgr.mr_n60089776)
print v(xbgr.mr_n60089888)
print v(xbgr.mr_n60090208)
print v(xbgr.mr_n60090320)
print v(xbgr.mr_n60090640)
print v(xbgr.mr_n60090752)
print v(xbgr.mr_n60091072)
print v(xbgr.mr_n60091184)
print v(xbgr.mr_n60091504)
print v(xbgr.mr_n60091616)
print v(xbgr.mr_n60091936)
print v(xbgr.mr_n60092048)
print v(xbgr.mr_n60092368)
print v(xbgr.mr_n60092480)
print v(xbgr.mr_n60092800)
print v(xbgr.mr_n60092912)
print v(xbgr.mr_n60093232)
print v(xbgr.mr_n60093344)
print v(xbgr.mr_n60093664)
print v(xbgr.mr_n60093776)
print v(xbgr.mr_n60094096)
print v(xbgr.mr_n60094208)
print v(xbgr.mr_n60094528)
print v(xbgr.mr_n60094640)
print v(xbgr.mr_n60094960)
print v(xbgr.mr_n60095072)
print v(xbgr.mr_n60095392)
print v(xbgr.mr_n60095504)
print v(xbgr.mr_n60095824)
print v(xbgr.mr_n60095936)
print v(xbgr.mr_n60096256)
print v(xbgr.mr_n60096368)
print v(xbgr.mr_n60096688)
print v(xbgr.mr_n60096800)
print v(xbgr.mr_n60097120)
print v(xbgr.mr_n60097232)
print v(xbgr.mr_n60097552)
print v(xbgr.mr_n60097664)
print v(xbgr.mr_n60097984)
print v(xbgr.mr_n60098096)
print v(xbgr.mr_n60098416)
print v(xbgr.mr_n60098528)
print v(xbgr.mr_n60098848)
print v(xbgr.mr_n60098960)
print v(xbgr.mr_n60099280)
print v(xbgr.mr_n60099392)
print v(xbgr.mr_n60099712)
print v(xbgr.mr_n60099824)
print v(xbgr.mr_n60100144)
print v(xbgr.mr_n60100256)
print v(xbgr.mr_n60100576)
print v(xbgr.mr_n60100688)
print v(xbgr.mr_n60101008)
print v(xbgr.mr_n60101120)
print v(xbgr.mr_n60101440)
print v(xbgr.mr_n60101552)
print v(xbgr.mr_n60101872)
print v(xbgr.mr_n60101984)
print v(xbgr.mr_n60102304)
print v(xbgr.mr_n60102416)
print v(xbgr.mr_n60102736)
print v(xbgr.mr_n60102848)
print v(xbgr.mr_n60103168)
print v(xbgr.mr_n60103280)
print v(xbgr.mr_n60103600)
print v(xbgr.mr_n60103712)
print v(xbgr.mr_n60104032)
print v(xbgr.mr_n60104144)
print v(xbgr.mr_n60104464)
print v(xbgr.mr_n60104576)
print v(xbgr.mr_n60104896)
print v(xbgr.mr_n60105008)
print v(xbgr.mr_n60105328)
print v(xbgr.mr_n60105440)
print v(xbgr.mr_n60105760)
print v(xbgr.mr_n60105872)
print v(xbgr.mr_n60106192)
print v(xbgr.mr_n60106304)
print v(xbgr.mr_n60106624)
print v(xbgr.mr_n60106736)
print v(xbgr.mr_n60107056)
print v(xbgr.mr_n60107168)
print v(xbgr.mr_n60107488)
print v(xbgr.mr_n60107600)
print v(xbgr.mr_n60107920)
print v(xbgr.mr_n60108032)
print v(xbgr.mr_n60108352)
print v(xbgr.mr_n60108464)
print v(xbgr.mr_n60108784)
print v(xbgr.mr_n60108896)
print v(xbgr.mr_n60109216)
print v(xbgr.mr_n60109328)
print v(xbgr.mr_n60109648)
print v(xbgr.mr_n60109760)
print v(xbgr.mr_n60110080)
print v(xbgr.mr_n60110192)
print v(xbgr.mr_n60110512)
print v(xbgr.mr_n60110624)
print v(xbgr.mr_n60110944)
print v(xbgr.mr_n60111056)
print v(xbgr.mr_n60111376)
print v(xbgr.mr_n60111488)
print v(xbgr.mr_n60111808)
print v(xbgr.mr_n60111920)
print v(xbgr.mr_n60112240)
print v(xbgr.mr_n60112352)
print v(xbgr.mr_n60112672)
print v(xbgr.mr_n60112784)
print v(xbgr.mr_n60113104)
print v(xbgr.mr_n60113216)
print v(xbgr.mr_n60113536)
print v(xbgr.mr_n60113648)
print v(xbgr.mr_n60113968)
print v(xbgr.mr_n60114080)
print v(xbgr.mr_n60114400)
print v(xbgr.mr_n60114512)
print v(xbgr.mr_n60114832)
print v(xbgr.mr_n60114944)
print v(xbgr.mr_n60115264)
print v(xbgr.mr_n60115376)
print v(xbgr.mr_n60115696)
print v(xbgr.mr_n60115808)
print v(xbgr.mr_n60116128)
print v(xbgr.mr_n60116240)
print v(xbgr.mr_n60116560)
print v(xbgr.mr_n60116672)
print v(xbgr.mr_n60116992)
print v(xbgr.mr_n60117104)
print v(xbgr.mr_n60117424)
print v(xbgr.mr_n60117536)
print v(xbgr.mr_n60117856)
print v(xbgr.mr_n60117968)
print v(xbgr.mr_n60118288)
print v(xbgr.mr_n60118400)
print v(xbgr.mr_n60118720)
print v(xbgr.mr_n60118832)
print v(xbgr.mr_n60119152)
print v(xbgr.mr_n60119264)
print v(xbgr.mr_n60119584)
print v(xbgr.mr_n60119696)
print v(xbgr.mr_n60120016)
print v(xbgr.mr_n60120128)
print v(xbgr.mr_n60120448)
print v(xbgr.mr_n60120560)
print v(xbgr.mr_n60120880)
print v(xbgr.mr_n60120992)
print v(xbgr.mr_n60121312)
print v(xbgr.mr_n60121424)
print v(xbgr.mr_n60121744)
print v(xbgr.mr_n60121856)
print v(xbgr.mr_n60122176)
print v(xbgr.mr_n60122288)
print v(xbgr.mr_n60122608)
print v(xbgr.mr_n60122720)
print v(xbgr.mr_n60123040)
print v(xbgr.mr_n60123152)
print v(xbgr.mr_n60123472)
print v(xbgr.mr_n60123584)
print v(xbgr.mr_n60123904)
print v(xbgr.mr_n60124016)
print v(xbgr.mr_n60124336)
print v(xbgr.mr_n60124448)
print v(xbgr.mr_n60124768)
print v(xbgr.mr_n60124880)
print v(xbgr.mr_n60125200)
print v(xbgr.mr_n60125312)
print v(xbgr.mr_n60125632)
print v(xbgr.mr_n60125744)
print v(xbgr.mr_n60126064)
print v(xbgr.mr_n60126176)
print v(xbgr.mr_n60126496)
print v(xbgr.mr_n60126608)
print v(xbgr.mr_n60126928)
print v(xbgr.mr_n60127040)
print v(xbgr.mr_n60127360)
print v(xbgr.mr_n60127472)
print v(xbgr.mr_n60127792)
print v(xbgr.mr_n60127904)
print v(xbgr.mr_n60128224)
print v(xbgr.mr_n60128336)
print v(xbgr.mr_n60128656)
print v(xbgr.mr_n60128768)
print v(xbgr.mr_n60129088)
print v(xbgr.mr_n60129200)
print v(xbgr.mr_n60129520)
print v(xbgr.mr_n60129632)
print v(xbgr.mr_n60129952)
print v(xbgr.mr_n60130064)
print v(xbgr.mr_n60130384)
print v(xbgr.mr_n60130496)
print v(xbgr.mr_n60130816)
print v(xbgr.mr_n60130928)
print v(xbgr.mr_n60131248)
print v(xbgr.mr_n60131360)
print v(xbgr.mr_n60131680)
print v(xbgr.mr_n60131792)
print v(xbgr.mr_n60132112)
print v(xbgr.mr_n60132224)
print v(xbgr.mr_n60132544)
print v(xbgr.mr_n60132656)
print v(xbgr.mr_n60132976)
print v(xbgr.mr_n60133088)
print v(xbgr.mr_n60133408)
print v(xbgr.mr_n60133520)
print v(xbgr.mr_n60133840)
print v(xbgr.mr_n60133952)
print v(xbgr.mr_n60134272)
print v(xbgr.mr_n60134384)
print v(xbgr.mr_n60134704)
print v(xbgr.mr_n60134816)
print v(xbgr.mr_n60135136)
print v(xbgr.mr_n60135248)
print v(xbgr.mr_n60135568)
print v(xbgr.mr_n60135680)
print v(xbgr.mr_n60136000)
print v(xbgr.mr_n60136112)
print v(xbgr.mr_n60136432)
print v(xbgr.mr_n60136544)
print v(xbgr.mr_n60136864)
print v(xbgr.mr_n60136976)
print v(xbgr.mr_n60137296)
print v(xbgr.mr_n60137408)
print v(xbgr.mr_n60137728)
print v(xbgr.mr_n60137840)
print v(xbgr.mr_n60138160)
print v(xbgr.mr_n60138272)
print v(xbgr.mr_n60138592)
print v(xbgr.mr_n60138704)
print v(xbgr.mr_n60139024)
print v(xbgr.mr_n60139136)
print v(xbgr.mr_n60139456)
print v(xbgr.mr_n60139568)
print v(xbgr.mr_n60139888)
print v(xbgr.mr_n60140000)
print v(xbgr.mr_n60140320)
print v(xbgr.mr_n60140432)
print v(xbgr.mr_n60140752)
print v(xbgr.mr_n60140864)
print v(xbgr.mr_n60141184)
print v(xbgr.mr_n60141296)
print v(xbgr.mr_n60141616)
print v(xbgr.mr_n60141728)
print v(xbgr.mr_n60142048)
print v(xbgr.mr_n60142160)
print v(xbgr.mr_n60142480)
print v(xbgr.mr_n60142592)
print v(xbgr.mr_n60142896)
print v(xbgr.mr_n60143008)
print v(xbgr.mr_n60143328)
print v(xbgr.mr_n60143440)
print v(xbgr.mr_n60143760)
print v(xbgr.mr_n60143872)
print v(xbgr.mr_n60144192)
print v(xbgr.mr_n60144304)
print v(xbgr.mr_n60144624)
print v(xbgr.mr_n60144736)
print v(xbgr.mr_n60145056)
print v(xbgr.mr_n60145168)
print v(xbgr.mr_n60145488)
print v(xbgr.mr_n60145600)
print v(xbgr.mr_n60145920)
print v(xbgr.mr_n60146032)
print v(xbgr.mr_n60146352)
print v(xbgr.mr_n60146464)
print v(xbgr.mr_n60146784)
print v(xbgr.mr_n60146896)
print v(xbgr.mr_n60147216)
print v(xbgr.mr_n60147328)
print v(xbgr.mr_n60147648)
print v(xbgr.mr_n60147760)
print v(xbgr.mr_n60148080)
print v(xbgr.mr_n60148192)
print v(xbgr.mr_n60148512)
print v(xbgr.mr_n60148624)
print v(xbgr.mr_n60148944)
print v(xbgr.mr_n60149056)
print v(xbgr.mr_n60149376)
print v(xbgr.mr_n60149488)
print v(xbgr.mr_n60149808)
print v(xbgr.mr_n60149920)
print v(xbgr.mr_n60150240)
print v(xbgr.mr_n60150352)
print v(xbgr.mr_n60150672)
print v(xbgr.mr_n60150784)
print v(xbgr.mr_n60151104)
print v(xbgr.mr_n60151216)
print v(xbgr.mr_n60151536)
print v(xbgr.mr_n60151648)
print v(xbgr.mr_n60151968)
print v(xbgr.mr_n60152080)
print v(xbgr.mr_n60152400)
print v(xbgr.mr_n60152512)
print v(xbgr.mr_n60152832)
print v(xbgr.mr_n60152944)
print v(xbgr.mr_n60153264)
print v(xbgr.mr_n60153376)
print v(xbgr.mr_n60153696)
print v(xbgr.mr_n60153808)
print v(xbgr.mr_n60154128)
print v(xbgr.mr_n60154240)
print v(xbgr.mr_n60154560)
print v(xbgr.mr_n60154672)
print v(xbgr.mr_n60154992)
print v(xbgr.mr_n60155104)
print v(xbgr.mr_n60155424)
print v(xbgr.mr_n60155536)
print v(xbgr.mr_n60155856)
print v(xbgr.mr_n60155968)
print v(xbgr.mr_n60156288)
print v(xbgr.mr_n60156400)
print v(xbgr.mr_n60156720)
print v(xbgr.mr_n60156832)
print v(xbgr.mr_n60157152)
print v(xbgr.mr_n60157264)
print v(xbgr.mr_n60157584)
print v(xbgr.mr_n60157696)
print v(xbgr.mr_n60158016)
print v(xbgr.mr_n60158128)
print v(xbgr.mr_n60158448)
print v(xbgr.mr_n60158560)
print v(xbgr.mr_n60158880)
print v(xbgr.mr_n60158992)
print v(xbgr.mr_n60159312)
print v(xbgr.mr_n60159424)
print v(xbgr.mr_n60159744)
print v(xbgr.mr_n60159856)
print v(xbgr.mr_n60160176)
print v(xbgr.mr_n60160288)
print v(xbgr.mr_n60160608)
print v(xbgr.mr_n60160720)
print v(xbgr.mr_n60161040)
print v(xbgr.mr_n60161152)
print v(xbgr.mr_n60161472)
print v(xbgr.mr_n60161584)
print v(xbgr.mr_n60161904)
print v(xbgr.mr_n60162016)
print v(xbgr.mr_n60162336)
print v(xbgr.mr_n60162448)
print v(xbgr.mr_n60162768)
print v(xbgr.mr_n60162880)
print v(xbgr.mr_n60163200)
print v(xbgr.mr_n60163312)
print v(xbgr.mr_n60163632)
print v(xbgr.mr_n60163744)
print v(xbgr.mr_n60164064)
print v(xbgr.mr_n60164176)
print v(xbgr.mr_n60164496)
print v(xbgr.mr_n60164608)
print v(xbgr.mr_n60164928)
print v(xbgr.mr_n60165040)
print v(xbgr.mr_n60165360)
print v(xbgr.mr_n60165472)
print v(xbgr.mr_n60165792)
print v(xbgr.mr_n60165904)
print v(xbgr.mr_n60166224)
print v(xbgr.mr_n60166336)
print v(xbgr.mr_n60166656)
print v(xbgr.mr_n60166768)
print v(xbgr.mr_n60167088)
print v(xbgr.mr_n60167200)
print v(xbgr.mr_n60167520)
print v(xbgr.mr_n60167632)
print v(xbgr.mr_n60167952)
print v(xbgr.mr_n60168064)
print v(xbgr.mr_n60168384)
print v(xbgr.mr_n60168496)
print v(xbgr.mr_n60168816)
print v(xbgr.mr_n60168928)
print v(xbgr.mr_n60169248)
print v(xbgr.mr_n60169360)
print v(xbgr.mr_n60169680)
print v(xbgr.mr_n60169792)
print v(xbgr.mr_n60170112)
print v(xbgr.mr_n60170224)
print v(xbgr.mr_n60170544)
print v(xbgr.mr_n60170656)
print v(xbgr.mr_n60170976)
print v(xbgr.mr_n60171088)
print v(xbgr.mr_n60171408)
print v(xbgr.mr_n60171520)
print v(xbgr.mr_n60171840)
print v(xbgr.mr_n60171952)
print v(xbgr.mr_n60172272)
print v(xbgr.mr_n60172384)
print v(xbgr.mr_n60172704)
print v(xbgr.mr_n60172816)
print v(xbgr.mr_n60173136)
print v(xbgr.mr_n60173248)
print v(xbgr.mr_n60173568)
print v(xbgr.mr_n60173680)
print v(xbgr.mr_n60174000)
print v(xbgr.mr_n60174112)
print v(xbgr.mr_n60174432)
print v(xbgr.mr_n60174544)
print v(xbgr.mr_n60174864)
print v(xbgr.mr_n60174976)
print v(xbgr.mr_n60175296)
print v(xbgr.mr_n60175408)
print v(xbgr.mr_n60175728)
print v(xbgr.mr_n60175840)
print v(xbgr.mr_n60176160)
print v(xbgr.mr_n60176272)
print v(xbgr.mr_n60176592)
print v(xbgr.mr_n60176704)
print v(xbgr.mr_n60177024)
print v(xbgr.mr_n60177136)
print v(xbgr.mr_n60177456)
print v(xbgr.mr_n60177568)
print v(xbgr.mr_n60177888)
print v(xbgr.mr_n60178000)
print v(xbgr.mr_n60178320)
print v(xbgr.mr_n60178432)
print v(xbgr.mr_n60178752)
print v(xbgr.mr_n60178864)
print v(xbgr.mr_n60179184)
print v(xbgr.mr_n60179296)
print v(xbgr.mr_n60179616)
print v(xbgr.mr_n60179728)
print v(xbgr.mr_n60180048)
print v(xbgr.mr_n60180160)
print v(xbgr.mr_n60180480)
print v(xbgr.mr_n60180592)
print v(xbgr.mr_n60180912)
print v(xbgr.mr_n60181024)
print v(xbgr.mr_n60181344)
print v(xbgr.mr_n60181456)
print v(xbgr.mr_n60181776)
print v(xbgr.mr_n60181888)
print v(xbgr.mr_n60182208)
print v(xbgr.mr_n60182320)
print v(xbgr.mr_n60182640)
print v(xbgr.mr_n60182752)
print v(xbgr.mr_n60183072)
print v(xbgr.mr_n60183184)
print v(xbgr.mr_n60183504)
print v(xbgr.mr_n60183616)
print v(xbgr.mr_n60183936)
print v(xbgr.mr_n60184048)
print v(xbgr.mr_n60184368)
print v(xbgr.mr_n60184480)
print v(xbgr.mr_n60184800)
print v(xbgr.mr_n60184912)
print v(xbgr.mr_n60185232)
print v(xbgr.mr_n60185344)
print v(xbgr.mr_n60185664)
print v(xbgr.mr_n60185776)
print v(xbgr.mr_n60186096)
print v(xbgr.mr_n60186208)
print v(xbgr.mr_n60186528)
print v(xbgr.mr_n60186640)
print v(xbgr.mr_n60186960)
print v(xbgr.mr_n60187072)
print v(xbgr.mr_n60187392)
print v(xbgr.mr_n60187504)
print v(xbgr.mr_n60187824)
print v(xbgr.mr_n60187936)
print v(xbgr.mr_n60188256)
print v(xbgr.mr_n60188368)
print v(xbgr.mr_n60188688)
print v(xbgr.mr_n60188800)
print v(xbgr.mr_n60189120)
print v(xbgr.mr_n60189232)
print v(xbgr.mr_n60189552)
print v(xbgr.mr_n60189664)
print v(xbgr.mr_n60189984)
print v(xbgr.mr_n60190096)
print v(xbgr.mr_n60190416)
print v(xbgr.mr_n60190528)
print v(xbgr.mr_n60190848)
print v(xbgr.mr_n60190960)
print v(xbgr.mr_n60191280)
print v(xbgr.mr_n60191392)
print v(xbgr.mr_n60191712)
print v(xbgr.mr_n60191824)
print v(xbgr.mr_n60192144)
print v(xbgr.mr_n60192256)
print v(xbgr.mr_n60192576)
print v(xbgr.mr_n60192688)
print v(xbgr.mr_n60193008)
print v(xbgr.mr_n60193120)
print v(xbgr.mr_n60193440)
print v(xbgr.mr_n60193552)
print v(xbgr.mr_n60193872)
print v(xbgr.mr_n60193984)
print v(xbgr.mr_n60194304)
print v(xbgr.mr_n60194416)
print v(xbgr.mr_n60194736)
print v(xbgr.mr_n60194848)
print v(xbgr.mr_n60195168)
print v(xbgr.mr_n60195280)
print v(xbgr.mr_n60195600)
print v(xbgr.mr_n60195712)
print v(xbgr.mr_n60196032)
print v(xbgr.mr_n60196144)
print v(xbgr.mr_n60196464)
print v(xbgr.mr_n60196576)
print v(xbgr.mr_n60196896)
print v(xbgr.mr_n60197008)
print v(xbgr.mr_n60197328)
print v(xbgr.mr_n60197440)
print v(xbgr.mr_n60197760)
print v(xbgr.mr_n60197872)
print v(xbgr.mr_n60198192)
print v(xbgr.mr_n60198304)
print v(xbgr.mr_n60198624)
print v(xbgr.mr_n60198736)
print v(xbgr.mr_n60199056)
print v(xbgr.mr_n60199168)
print v(xbgr.mr_n60199488)
print v(xbgr.mr_n60199600)
print v(xbgr.mr_n60199920)
print v(xbgr.mr_n60200032)
print v(xbgr.mr_n60200352)
print v(xbgr.mr_n60200464)
print v(xbgr.mr_n60200784)
print v(xbgr.mr_n60200896)
print v(xbgr.mr_n60201216)
print v(xbgr.mr_n60201328)
print v(xbgr.mr_n60201648)
print v(xbgr.mr_n60201760)
print v(xbgr.mr_n60202080)
print v(xbgr.mr_n60202192)
print v(xbgr.mr_n60202512)
print v(xbgr.mr_n60202624)
print v(xbgr.mr_n60202944)
print v(xbgr.mr_n60203056)
print v(xbgr.mr_n60203376)
print v(xbgr.mr_n60203488)
print v(xbgr.mr_n60203808)
print v(xbgr.mr_n60203920)
print v(xbgr.mr_n60204240)
print v(xbgr.mr_n60204352)
print v(xbgr.mr_n60204672)
print v(xbgr.mr_n60204784)
print v(xbgr.mr_n60205104)
print v(xbgr.mr_n60205216)
print v(xbgr.mr_n60205536)
print v(xbgr.mr_n60205648)
print v(xbgr.mr_n60205968)
print v(xbgr.mr_n60206080)
print v(xbgr.mr_n60206400)
print v(xbgr.mr_n60206512)
print v(xbgr.mr_n60206832)
print v(xbgr.mr_n60206944)
print v(xbgr.mr_n60207264)
print v(xbgr.mr_n60207376)
print v(xbgr.mr_n60207696)
print v(xbgr.mr_n60207808)
print v(xbgr.mr_n60208128)
print v(xbgr.mr_n60208240)
print v(xbgr.mr_n60208560)
print v(xbgr.mr_n60208672)
print v(xbgr.mr_n60208992)
print v(xbgr.mr_n60209104)
print v(xbgr.mr_n60209424)
print v(xbgr.mr_n60209536)
print v(xbgr.mr_n60209856)
print v(xbgr.mr_n60209968)
print v(xbgr.mr_n60210288)
print v(xbgr.mr_n60210400)
print v(xbgr.mr_n60210720)
print v(xbgr.mr_n60210832)
print v(xbgr.mr_n60211152)
print v(xbgr.mr_n60211264)
print v(xbgr.mr_n60211584)
print v(xbgr.mr_n60211696)
print v(xbgr.mr_n60212016)
print v(xbgr.mr_n60212128)
print v(xbgr.mr_n60212448)
print v(xbgr.mr_n60212560)
print v(xbgr.mr_n60212880)
print v(xbgr.mr_n60212992)
print v(xbgr.mr_n60213312)
print v(xbgr.mr_n60213424)
print v(xbgr.mr_n60213744)
print v(xbgr.mr_n60213856)
print v(xbgr.mr_n60214176)
print v(xbgr.mr_n60214288)
print v(xbgr.mr_n60214608)
print v(xbgr.mr_n60214720)
print v(xbgr.mr_n60215040)
print v(xbgr.mr_n60215152)
print v(xbgr.mr_n60215472)
print v(xbgr.mr_n60215584)
print v(xbgr.mr_n60215904)
print v(xbgr.mr_n60216016)
print v(xbgr.mr_n60216336)
print v(xbgr.mr_n60216448)
print v(xbgr.mr_n60216768)
print v(xbgr.mr_n60216880)
print v(xbgr.mr_n60217200)
print v(xbgr.mr_n60217312)
print v(xbgr.mr_n60217632)
print v(xbgr.mr_n60217744)
print v(xbgr.mr_n60218064)
print v(xbgr.mr_n60218176)
print v(xbgr.mr_n60218496)
print v(xbgr.mr_n60218608)
print v(xbgr.mr_n60218928)
print v(xbgr.mr_n60219040)
print v(xbgr.mr_n60219360)
print v(xbgr.mr_n60219472)
print v(xbgr.mr_n60219792)
print v(xbgr.mr_n60219904)
print v(xbgr.mr_n60220224)
print v(xbgr.mr_n60220336)
print v(xbgr.mr_n60220656)
print v(xbgr.mr_n60220768)
print v(xbgr.mr_n60221088)
print v(xbgr.mr_n60221200)
print v(xbgr.mr_n60221520)
print v(xbgr.mr_n60221632)
print v(xbgr.mr_n60221952)
print v(xbgr.mr_n60222064)
print v(xbgr.mr_n60222384)
print v(xbgr.mr_n60222496)
print v(xbgr.mr_n60222816)
print v(xbgr.mr_n60222928)
print v(xbgr.mr_n60223248)
print v(xbgr.mr_n60223360)
print v(xbgr.mr_n60223680)
print v(xbgr.mr_n60223792)
print v(xbgr.mr_n60224112)
print v(xbgr.mr_n60224224)
print v(xbgr.mr_n60224544)
print v(xbgr.mr_n60224656)
print v(xbgr.mr_n60224976)
print v(xbgr.mr_n60225088)
print v(xbgr.mr_n60225408)
print v(xbgr.mr_n60225520)
print v(xbgr.mr_n60225840)
print v(xbgr.mr_n60225952)
print v(xbgr.mr_n60226272)
print v(xbgr.mr_n60226384)
print v(xbgr.mr_n60226704)
print v(xbgr.mr_n60226816)
print v(xbgr.mr_n60227136)
print v(xbgr.mr_n60227248)
print v(xbgr.mr_n60227568)
print v(xbgr.mr_n60227680)
print v(xbgr.mr_n60228000)
print v(xbgr.mr_n60228112)
print v(xbgr.mr_n60228432)
print v(xbgr.mr_n60228544)
print v(xbgr.mr_n60228864)
print v(xbgr.mr_n60228976)
print v(xbgr.mr_n60229296)
print v(xbgr.mr_n60229408)
print v(xbgr.mr_n60229728)
print v(xbgr.mr_n60229840)
print v(xbgr.mr_n60230160)
print v(xbgr.mr_n60230272)
print v(xbgr.mr_n60230592)
print v(xbgr.mr_n60230704)
print v(xbgr.mr_n60231024)
print v(xbgr.mr_n60231136)
print v(xbgr.mr_n60231456)
print v(xbgr.mr_n60231568)
print v(xbgr.mr_n60231888)
print v(xbgr.mr_n60232000)
print v(xbgr.mr_n60232320)
print v(xbgr.mr_n60232432)
print v(xbgr.mr_n60232752)
print v(xbgr.mr_n60232864)
print v(xbgr.mr_n60233184)
print v(xbgr.mr_n60233296)
print v(xbgr.mr_n60233616)
print v(xbgr.mr_n60233728)
print v(xbgr.mr_n60234048)
print v(xbgr.mr_n60234160)
print v(xbgr.mr_n60234480)
print v(xbgr.mr_n60234592)
print v(xbgr.mr_n60234912)
print v(xbgr.mr_n60235024)
print v(xbgr.mr_n60235344)
print v(xbgr.mr_n60235456)
print v(xbgr.mr_n60235776)
print v(xbgr.mr_n60235888)
print v(xbgr.mr_n60236208)
print v(xbgr.mr_n60236320)
print v(xbgr.mr_n60236640)
print v(xbgr.mr_n60236752)
print v(xbgr.mr_n60237072)
print v(xbgr.mr_n60237184)
print v(xbgr.mr_n60237504)
print v(xbgr.mr_n60237616)
print v(xbgr.mr_n60237936)
print v(xbgr.mr_n60238048)
print v(xbgr.mr_n60238368)
print v(xbgr.mr_n60238480)
print v(xbgr.mr_n60238800)
print v(xbgr.mr_n60238912)
print v(xbgr.mr_n60239232)
print v(xbgr.mr_n60239344)
print v(xbgr.mr_n60239664)
print v(xbgr.mr_n60239776)
print v(xbgr.mr_n60240096)
print v(xbgr.mr_n60240208)
print v(xbgr.mr_n60240528)
print v(xbgr.mr_n60240640)
print v(xbgr.mr_n60240960)
print v(xbgr.mr_n60241072)
print v(xbgr.mr_n60241392)
print v(xbgr.mr_n60241504)
print v(xbgr.mr_n60241824)
print v(xbgr.mr_n60241936)
print v(xbgr.mr_n60242256)
print v(xbgr.mr_n60242368)
print v(xbgr.mr_n60242688)
print v(xbgr.mr_n60242800)
print v(xbgr.mr_n60243120)
print v(xbgr.mr_n60243232)
print v(xbgr.mr_n60243552)
print v(xbgr.mr_n60243664)
print v(xbgr.mr_n60243984)
print v(xbgr.mr_n60244096)
print v(xbgr.mr_n60244416)
print v(xbgr.mr_n60244528)
print v(xbgr.mr_n60244848)
print v(xbgr.mr_n60244960)
print v(xbgr.mr_n60245280)
print v(xbgr.mr_n60245392)
print v(xbgr.mr_n60245712)
print v(xbgr.mr_n60245824)
print v(xbgr.mr_n60246144)
print v(xbgr.mr_n60246256)
print v(xbgr.mr_n60246576)
print v(xbgr.mr_n60246688)
print v(xbgr.mr_n60247008)
print v(xbgr.mr_n60247120)
print v(xbgr.mr_n60247440)
print v(xbgr.mr_n60247552)
print v(xbgr.mr_n60247872)
print v(xbgr.mr_n60247984)
print v(xbgr.mr_n60248304)
print v(xbgr.mr_n60248416)
print v(xbgr.mr_n60248736)
print v(xbgr.mr_n60248848)
print v(xbgr.mr_n60249168)
print v(xbgr.mr_n60249280)
print v(xbgr.mr_n60249600)
print v(xbgr.mr_n60249712)
print v(xbgr.mr_n60250032)
print v(xbgr.mr_n60250144)
print v(xbgr.mr_n60250464)
print v(xbgr.mr_n60250576)
print v(xbgr.mr_n60250896)
print v(xbgr.mr_n60251008)
print v(xbgr.mr_n60251328)
print v(xbgr.mr_n60251440)
print v(xbgr.mr_n60251760)
print v(xbgr.mr_n60251872)
print v(xbgr.mr_n60252192)
print v(xbgr.mr_n60252304)
print v(xbgr.mr_n60252624)
print v(xbgr.mr_n60252736)
print v(xbgr.mr_n60253056)
print v(xbgr.mr_n60253168)
print v(xbgr.mr_n60253488)
print v(xbgr.mr_n60253600)
print v(xbgr.mr_n60253920)
print v(xbgr.mr_n60254032)
print v(xbgr.mr_n60254352)
print v(xbgr.mr_n60254464)
print v(xbgr.mr_n60254784)
print v(xbgr.mr_n60254896)
print v(xbgr.mr_n60255216)
print v(xbgr.mr_n60255328)
print v(xbgr.mr_n60255648)
print v(xbgr.mr_n60255760)
print v(xbgr.mr_n60256080)
print v(xbgr.mr_n60256192)
print v(xbgr.mr_n60256512)
print v(xbgr.mr_n60256624)
print v(xbgr.mr_n60256944)
print v(xbgr.mr_n60257056)
print v(xbgr.mr_n60257376)
print v(xbgr.mr_n60257488)
print v(xbgr.mr_n60257808)
print v(xbgr.mr_n60257920)
print v(xbgr.mr_n60258240)
print v(xbgr.mr_n60258352)
print v(xbgr.mr_n60258672)
print v(xbgr.mr_n60258784)
print v(xbgr.mr_n60259104)
print v(xbgr.mr_n60259216)
print v(xbgr.mr_n60259536)
print v(xbgr.mr_n60259648)
print v(xbgr.mr_n60259968)
print v(xbgr.mr_n60260080)
print v(xbgr.mr_n60260400)
print v(xbgr.mr_n60260512)
print v(xbgr.mr_n60260832)
print v(xbgr.mr_n60260944)
print v(xbgr.mr_n60261264)
print v(xbgr.mr_n60261376)
print v(xbgr.mr_n60261696)
print v(xbgr.mr_n60261808)
print v(xbgr.mr_n60262128)
print v(xbgr.mr_n60262240)
print v(xbgr.mr_n60262560)
print v(xbgr.mr_n60262672)
print v(xbgr.mr_n60262992)
print v(xbgr.mr_n60263104)
print v(xbgr.mr_n60263424)
print v(xbgr.mr_n60263536)
print v(xbgr.mr_n60263856)
print v(xbgr.mr_n60263968)
print v(xbgr.mr_n60264288)
print v(xbgr.mr_n60264400)
print v(xbgr.mr_n60264720)
print v(xbgr.mr_n60264832)
print v(xbgr.mr_n60265152)
print v(xbgr.mr_n60265264)
print v(xbgr.mr_n60265584)
print v(xbgr.mr_n60265696)
print v(xbgr.mr_n60266016)
print v(xbgr.mr_n60266128)
print v(xbgr.mr_n60266448)
print v(xbgr.mr_n60266560)
print v(xbgr.mr_n60266880)
print v(xbgr.mr_n60266992)
print v(xbgr.mr_n60267312)
print v(xbgr.mr_n60267424)
print v(xbgr.mr_n60267744)
print v(xbgr.mr_n60267856)
print v(xbgr.mr_n60268176)
print v(xbgr.mr_n60268288)
print v(xbgr.mr_n60268608)
print v(xbgr.mr_n60268720)
print v(xbgr.mr_n60269040)
print v(xbgr.mr_n60269152)
print v(xbgr.mr_n60269472)
print v(xbgr.mr_n60269584)
print v(xbgr.mr_n60269904)
print v(xbgr.mr_n60270016)
print v(xbgr.mr_n60270336)
print v(xbgr.mr_n60270448)
print v(xbgr.mr_n60270768)
print v(xbgr.mr_n60270880)
print v(xbgr.mr_n60271200)
print v(xbgr.mr_n60271312)
print v(xbgr.mr_n60271632)
print v(xbgr.mr_n60271744)
print v(xbgr.mr_n60272064)
print v(xbgr.mr_n60272176)
print v(xbgr.mr_n60272496)
print v(xbgr.mr_n60272608)
print v(xbgr.mr_n60272928)
print v(xbgr.mr_n60273040)
print v(xbgr.mr_n60273360)
print v(xbgr.mr_n60273472)
print v(xbgr.mr_n60273792)
print v(xbgr.mr_n60273904)
print v(xbgr.mr_n60274224)
print v(xbgr.mr_n60274336)
print v(xbgr.mr_n60274656)
print v(xbgr.mr_n60274768)
print v(xbgr.mr_n60275088)
print v(xbgr.mr_n60275200)
print v(xbgr.mr_n60275520)
print v(xbgr.mr_n60275632)
print v(xbgr.mr_n60275952)
print v(xbgr.mr_n60276064)
print v(xbgr.mr_n60276384)
print v(xbgr.mr_n60276496)
print v(xbgr.mr_n60276816)
print v(xbgr.mr_n60276928)
print v(xbgr.mr_n60277248)
print v(xbgr.mr_n60277360)
print v(xbgr.mr_n60277680)
print v(xbgr.mr_n60277792)
print v(xbgr.mr_n60278112)
print v(xbgr.mr_n60278224)
print v(xbgr.mr_n60278544)
print v(xbgr.mr_n60278656)
print v(xbgr.mr_n60278976)
print v(xbgr.mr_n60279088)
print v(xbgr.mr_n60279408)
print v(xbgr.mr_n60279520)
print v(xbgr.mr_n60279840)
print v(xbgr.mr_n60279952)
print v(xbgr.mr_n60280272)
print v(xbgr.mr_n60280384)
print v(xbgr.mr_n60280704)
print v(xbgr.mr_n60280816)
print v(xbgr.mr_n60281136)
print v(xbgr.mr_n60281248)
print v(xbgr.mr_n60281568)
print v(xbgr.mr_n60281680)
print v(xbgr.mr_n60282000)
print v(xbgr.mr_n60282112)
print v(xbgr.mr_n60282432)
print v(xbgr.mr_n60282544)
print v(xbgr.mr_n60282864)
print v(xbgr.mr_n60282976)
print v(xbgr.mr_n60283296)
print v(xbgr.mr_n60283408)
print v(xbgr.mr_n60283728)
print v(xbgr.mr_n60283840)
print v(xbgr.mr_n60284160)
print v(xbgr.mr_n60284272)
print v(xbgr.mr_n60284592)
print v(xbgr.mr_n60284704)
print v(xbgr.mr_n60285024)
print v(xbgr.mr_n60285136)
print v(xbgr.mr_n60285456)
print v(xbgr.mr_n60285568)
print v(xbgr.mr_n60285888)
print v(xbgr.mr_n60286000)
print v(xbgr.mr_n60286320)
print v(xbgr.mr_n60286432)
print v(xbgr.mr_n60286752)
print v(xbgr.mr_n60286864)
print v(xbgr.mr_n60287184)
print v(xbgr.mr_n60287296)
print v(xbgr.mr_n60287616)
print v(xbgr.mr_n60287728)
print v(xbgr.mr_n60288048)
print v(xbgr.mr_n60288160)
print v(xbgr.mr_n60288480)
print v(xbgr.mr_n60288592)
print v(xbgr.mr_n60288912)
print v(xbgr.mr_n60289024)
print v(xbgr.mr_n60289344)
print v(xbgr.mr_n60289456)
print v(xbgr.mr_n60289776)
print v(xbgr.mr_n60289888)
print v(xbgr.mr_n60290208)
print v(xbgr.mr_n60290320)
print v(xbgr.mr_n60290640)
print v(xbgr.mr_n60290752)
print v(xbgr.mr_n60291072)
print v(xbgr.mr_n60291184)
print v(xbgr.mr_n60291504)
print v(xbgr.mr_n60291616)
print v(xbgr.mr_n60291936)
print v(xbgr.mr_n60292048)
print v(xbgr.mr_n60292368)
print v(xbgr.mr_n60292480)
print v(xbgr.mr_n60292800)
print v(xbgr.mr_n60292912)
print v(xbgr.mr_n60293232)
print v(xbgr.mr_n60293344)
print v(xbgr.mr_n60293664)
print v(xbgr.mr_n60293776)
print v(xbgr.mr_n60294096)
print v(xbgr.mr_n60294208)
print v(xbgr.mr_n60294528)
print v(xbgr.mr_n60294640)
print v(xbgr.mr_n60294960)
print v(xbgr.mr_n60295072)
print v(xbgr.mr_n60295392)
print v(xbgr.mr_n60295504)
print v(xbgr.mr_n60295824)
print v(xbgr.mr_n60295936)
print v(xbgr.mr_n60296256)
print v(xbgr.mr_n60296368)
print v(xbgr.mr_n60296688)
print v(xbgr.mr_n60296800)
print v(xbgr.mr_n60297120)
print v(xbgr.mr_n60297232)
print v(xbgr.mr_n60297552)
print v(xbgr.mr_n60297664)
print v(xbgr.mr_n60297984)
print v(xbgr.mr_n60298096)
print v(xbgr.mr_n60298416)
print v(xbgr.mr_n60298528)
print v(xbgr.mr_n60298848)
print v(xbgr.mr_n60298960)
print v(xbgr.mr_n60299280)
print v(xbgr.mr_n60299392)
print v(xbgr.mr_n60299712)
print v(xbgr.mr_n60299824)
print v(xbgr.mr_n60300144)
print v(xbgr.mr_n60300256)
print v(xbgr.mr_n60300576)
print v(xbgr.mr_n60300688)
print v(xbgr.mr_n60301008)
print v(xbgr.mr_n60301120)
print v(xbgr.mr_n60301440)
print v(xbgr.mr_n60301552)
print v(xbgr.mr_n60301872)
print v(xbgr.mr_n60301984)
print v(xbgr.mr_n60302304)
print v(xbgr.mr_n60302416)
print v(xbgr.mr_n60302736)
print v(xbgr.mr_n60302848)
print v(xbgr.mr_n60303168)
print v(xbgr.mr_n60303280)
print v(xbgr.mr_n60303600)
print v(xbgr.mr_n60303712)
print v(xbgr.mr_n60304032)
print v(xbgr.mr_n60304144)
print v(xbgr.mr_n60304464)
print v(xbgr.mr_n60304576)
print v(xbgr.mr_n60304896)
print v(xbgr.mr_n60305008)
print v(xbgr.mr_n60305328)
print v(xbgr.mr_n60305440)
print v(xbgr.mr_n60305760)
print v(xbgr.mr_n60305872)
print v(xbgr.mr_n60306192)
print v(xbgr.mr_n60306304)
print v(xbgr.mr_n60306624)
print v(xbgr.mr_n60306736)
print v(xbgr.mr_n60307056)
print v(xbgr.mr_n60307168)
print v(xbgr.mr_n60307488)
print v(xbgr.mr_n60307600)
print v(xbgr.mr_n60307920)
print v(xbgr.mr_n60308032)
print v(xbgr.mr_n60308352)
print v(xbgr.mr_n60308464)
print v(xbgr.mr_n60308784)
print v(xbgr.mr_n60308896)
print v(xbgr.mr_n60309216)
print v(xbgr.mr_n60309328)
print v(xbgr.mr_n60309648)
print v(xbgr.mr_n60309760)
print v(xbgr.mr_n60310080)
print v(xbgr.mr_n60310192)
print v(xbgr.mr_n60310512)
print v(xbgr.mr_n60310624)
print v(xbgr.mr_n60310944)
print v(xbgr.mr_n60311056)
print v(xbgr.mr_n60311376)
print v(xbgr.mr_n60311488)
print v(xbgr.mr_n60311808)
print v(xbgr.mr_n60311920)
print v(xbgr.mr_n60312240)
print v(xbgr.mr_n60312352)
print v(xbgr.mr_n60312672)
print v(xbgr.mr_n60312784)
print v(xbgr.mr_n60313104)
print v(xbgr.mr_n60313216)
print v(xbgr.mr_n60313536)
print v(xbgr.mr_n60313648)
print v(xbgr.mr_n60313968)
print v(xbgr.mr_n60314080)
print v(xbgr.mr_n60314400)
print v(xbgr.mr_n60314512)
print v(xbgr.mr_n60314832)
print v(xbgr.mr_n60314944)
print v(xbgr.mr_n60315264)
print v(xbgr.mr_n60315376)
print v(xbgr.mr_n60315696)
print v(xbgr.mr_n60315808)
print v(xbgr.mr_n60316128)
print v(xbgr.mr_n60316240)
print v(xbgr.mr_n60316560)
print v(xbgr.mr_n60316672)
print v(xbgr.mr_n60316992)
print v(xbgr.mr_n60317104)
print v(xbgr.mr_n60317424)
print v(xbgr.mr_n60317536)
print v(xbgr.mr_n60317856)
print v(xbgr.mr_n60317968)
print v(xbgr.mr_n60318288)
print v(xbgr.mr_n60318400)
print v(xbgr.mr_n60318720)
print v(xbgr.mr_n60318832)
print v(xbgr.mr_n60319152)
print v(xbgr.mr_n60319264)
print v(xbgr.mr_n60319584)
print v(xbgr.mr_n60319696)
print v(xbgr.mr_n60320016)
print v(xbgr.mr_n60320128)
print v(xbgr.mr_n60320448)
print v(xbgr.mr_n60320560)
print v(xbgr.mr_n60320880)
print v(xbgr.mr_n60320992)
print v(xbgr.mr_n60321312)
print v(xbgr.mr_n60321424)
print v(xbgr.mr_n60321744)
print v(xbgr.mr_n60321856)
print v(xbgr.mr_n60322176)
print v(xbgr.mr_n60322288)
print v(xbgr.mr_n60322608)
print v(xbgr.mr_n60322720)
print v(xbgr.mr_n60323040)
print v(xbgr.mr_n60323152)
print v(xbgr.mr_n60323472)
print v(xbgr.mr_n60323584)
print v(xbgr.mr_n60323904)
print v(xbgr.mr_n60324016)
print v(xbgr.mr_n60324336)
print v(xbgr.mr_n60324448)
print v(xbgr.mr_n60324768)
print v(xbgr.mr_n60324880)
print v(xbgr.mr_n60325200)
print v(xbgr.mr_n60325312)
print v(xbgr.mr_n60325632)
print v(xbgr.mr_n60325744)
print v(xbgr.mr_n60326064)
print v(xbgr.mr_n60326176)
print v(xbgr.mr_n60326496)
print v(xbgr.mr_n60326608)
print v(xbgr.mr_n60326928)
print v(xbgr.mr_n60327040)
print v(xbgr.mr_n60327360)
print v(xbgr.mr_n60327472)
print v(xbgr.mr_n60327792)
print v(xbgr.mr_n60327904)
print v(xbgr.mr_n60328224)
print v(xbgr.mr_n60328336)
print v(xbgr.mr_n60328656)
print v(xbgr.mr_n60328768)
print v(xbgr.mr_n60329088)
print v(xbgr.mr_n60329200)
print v(xbgr.mr_n60329520)
print v(xbgr.mr_n60329632)
print v(xbgr.mr_n60329952)
print v(xbgr.mr_n60330064)
print v(xbgr.mr_n60330384)
print v(xbgr.mr_n60330496)
print v(xbgr.mr_n60330816)
print v(xbgr.mr_n60330928)
print v(xbgr.mr_n60331248)
print v(xbgr.mr_n60331360)
print v(xbgr.mr_n60331680)
print v(xbgr.mr_n60331792)
print v(xbgr.mr_n60332112)
print v(xbgr.mr_n60332224)
print v(xbgr.mr_n60332544)
print v(xbgr.mr_n60332656)
print v(xbgr.mr_n60332976)
print v(xbgr.mr_n60333088)
print v(xbgr.mr_n60333408)
print v(xbgr.mr_n60333520)
print v(xbgr.mr_n60333840)
print v(xbgr.mr_n60333952)
print v(xbgr.mr_n60334272)
print v(xbgr.mr_n60334384)
print v(xbgr.mr_n60334704)
print v(xbgr.mr_n60334816)
print v(xbgr.mr_n60335136)
print v(xbgr.mr_n60335248)
print v(xbgr.mr_n60335568)
print v(xbgr.mr_n60335680)
print v(xbgr.mr_n60336000)
print v(xbgr.mr_n60336112)
print v(xbgr.mr_n60336432)
print v(xbgr.mr_n60336544)
print v(xbgr.mr_n60336864)
print v(xbgr.mr_n60336976)
print v(xbgr.mr_n60337296)
print v(xbgr.mr_n60337408)
print v(xbgr.mr_n60337728)
print v(xbgr.mr_n60337840)
print v(xbgr.mr_n60338160)
print v(xbgr.mr_n60338272)
print v(xbgr.mr_n60338592)
print v(xbgr.mr_n60338704)
print v(xbgr.mr_n60339024)
print v(xbgr.mr_n60339136)
print v(xbgr.mr_n60339456)
print v(xbgr.mr_n60339568)
print v(xbgr.mr_n60339888)
print v(xbgr.mr_n60340000)
print v(xbgr.mr_n60340320)
print v(xbgr.mr_n60340432)
print v(xbgr.mr_n60340752)
print v(xbgr.mr_n60340864)
print v(xbgr.mr_n60341184)
print v(xbgr.mr_n60341296)
print v(xbgr.mr_n60341616)
print v(xbgr.mr_n60341728)
print v(xbgr.mr_n60342048)
print v(xbgr.mr_n60342160)
print v(xbgr.mr_n60342480)
print v(xbgr.mr_n60342592)
print v(xbgr.mr_n60342912)
print v(xbgr.mr_n60343024)
print v(xbgr.mr_n60343344)
print v(xbgr.mr_n60343456)
print v(xbgr.mr_n60343776)
print v(xbgr.mr_n60343888)
print v(xbgr.mr_n60344208)
print v(xbgr.mr_n60344320)
print v(xbgr.mr_n60344640)
print v(xbgr.mr_n60344752)
print v(xbgr.mr_n60345072)
print v(xbgr.mr_n60345184)
print v(xbgr.mr_n60345504)
print v(xbgr.mr_n60345616)
print v(xbgr.mr_n60345936)
print v(xbgr.mr_n60346048)
print v(xbgr.mr_n60346368)
print v(xbgr.mr_n60346480)
print v(xbgr.mr_n60346800)
print v(xbgr.mr_n60346912)
print v(xbgr.mr_n60347232)
print v(xbgr.mr_n60347344)
print v(xbgr.mr_n60347664)
print v(xbgr.mr_n60347776)
print v(xbgr.mr_n60348096)
print v(xbgr.mr_n60348208)
print v(xbgr.mr_n60348528)
print v(xbgr.mr_n60348640)
print v(xbgr.mr_n60348960)
print v(xbgr.mr_n60349072)
print v(xbgr.mr_n60349392)
print v(xbgr.mr_n60349504)
print v(xbgr.mr_n60349824)
print v(xbgr.mr_n60349936)
print v(xbgr.mr_n60350256)
print v(xbgr.mr_n60350368)
print v(xbgr.mr_n60350688)
print v(xbgr.mr_n60350800)
print v(xbgr.mr_n60351120)
print v(xbgr.mr_n60351232)
print v(xbgr.mr_n60351552)
print v(xbgr.mr_n60351664)
print v(xbgr.mr_n60351984)
print v(xbgr.mr_n60352096)
print v(xbgr.mr_n60352416)
print v(xbgr.mr_n60352528)
print v(xbgr.mr_n60352848)
print v(xbgr.mr_n60352960)
print v(xbgr.mr_n60353280)
print v(xbgr.mr_n60353392)
print v(xbgr.mr_n60353712)
print v(xbgr.mr_n60353824)
print v(xbgr.mr_n60354144)
print v(xbgr.mr_n60354256)
print v(xbgr.mr_n60354576)
print v(xbgr.mr_n60354688)
print v(xbgr.mr_n60355008)
print v(xbgr.mr_n60355120)
print v(xbgr.mr_n60355440)
print v(xbgr.mr_n60355552)
print v(xbgr.mr_n60355872)
print v(xbgr.mr_n60355984)
print v(xbgr.mr_n60356304)
print v(xbgr.mr_n60356416)
print v(xbgr.mr_n60356736)
print v(xbgr.mr_n60356848)
print v(xbgr.mr_n60357168)
print v(xbgr.mr_n60357280)
print v(xbgr.mr_n60357600)
print v(xbgr.mr_n60357712)
print v(xbgr.mr_n60358032)
print v(xbgr.mr_n60358144)
print v(xbgr.mr_n60358464)
print v(xbgr.mr_n60358576)
print v(xbgr.mr_n60358896)
print v(xbgr.mr_n60359008)
print v(xbgr.mr_n60359328)
print v(xbgr.mr_n60359440)
print v(xbgr.mr_n60359760)
print v(xbgr.mr_n60359872)
print v(xbgr.mr_n60360192)
print v(xbgr.mr_n60360304)
print v(xbgr.mr_n60360624)
print v(xbgr.mr_n60360736)
print v(xbgr.mr_n60361056)
print v(xbgr.mr_n60361168)
print v(xbgr.mr_n60361488)
print v(xbgr.mr_n60361600)
print v(xbgr.mr_n60361920)
print v(xbgr.mr_n60362032)
print v(xbgr.mr_n60362352)
print v(xbgr.mr_n60362464)
print v(xbgr.mr_n60362784)
print v(xbgr.mr_n60362896)
print v(xbgr.mr_n60363216)
print v(xbgr.mr_n60363328)
print v(xbgr.mr_n60363648)
print v(xbgr.mr_n60363760)
print v(xbgr.mr_n60364080)
print v(xbgr.mr_n60364192)
print v(xbgr.mr_n60364512)
print v(xbgr.mr_n60364624)
print v(xbgr.mr_n60364944)
print v(xbgr.mr_n60365056)
print v(xbgr.mr_n60365376)
print v(xbgr.mr_n60365488)
print v(xbgr.mr_n60365808)
print v(xbgr.mr_n60365920)
print v(xbgr.mr_n60366240)
print v(xbgr.mr_n60366352)
print v(xbgr.mr_n60366672)
print v(xbgr.mr_n60366784)
print v(xbgr.mr_n60367104)
print v(xbgr.mr_n60367216)
print v(xbgr.mr_n60367536)
print v(xbgr.mr_n60367648)
print v(xbgr.mr_n60367968)
print v(xbgr.mr_n60368080)
print v(xbgr.mr_n60368400)
print v(xbgr.mr_n60368512)
print v(xbgr.mr_n60368832)
print v(xbgr.mr_n60368944)
print v(xbgr.mr_n60369264)
print v(xbgr.mr_n60369376)
print v(xbgr.mr_n60369696)
print v(xbgr.mr_n60369808)
print v(xbgr.mr_n60370128)
print v(xbgr.mr_n60370240)
print v(xbgr.mr_n60370560)
print v(xbgr.mr_n60370672)
print v(xbgr.mr_n60370992)
print v(xbgr.mr_n60371104)
print v(xbgr.mr_n60371424)
print v(xbgr.mr_n60371536)
print v(xbgr.mr_n60371856)
print v(xbgr.mr_n60371968)
print v(xbgr.mr_n60372288)
print v(xbgr.mr_n60372400)
print v(xbgr.mr_n60372720)
print v(xbgr.mr_n60372832)
print v(xbgr.mr_n60373152)
print v(xbgr.mr_n60373264)
print v(xbgr.mr_n60373584)
print v(xbgr.mr_n60373696)
print v(xbgr.mr_n60374016)
print v(xbgr.mr_n60374128)
print v(xbgr.mr_n60374448)
print v(xbgr.mr_n60374560)
print v(xbgr.mr_n60374880)
print v(xbgr.mr_n60374992)
print v(xbgr.mr_n60375312)
print v(xbgr.mr_n60375424)
print v(xbgr.mr_n60375744)
print v(xbgr.mr_n60375856)
print v(xbgr.mr_n60376176)
print v(xbgr.mr_n60376288)
print v(xbgr.mr_n60376608)
print v(xbgr.mr_n60376720)
print v(xbgr.mr_n60377040)
print v(xbgr.mr_n60377152)
print v(xbgr.mr_n60377472)
print v(xbgr.mr_n60377584)
print v(xbgr.mr_n60377904)
print v(xbgr.mr_n60378016)
print v(xbgr.mr_n60378336)
print v(xbgr.mr_n60378448)
print v(xbgr.mr_n60378768)
print v(xbgr.mr_n60378880)
print v(xbgr.mr_n60379200)
print v(xbgr.mr_n60379312)
print v(xbgr.mr_n60379632)
print v(xbgr.mr_n60379744)
print v(xbgr.mr_n60380064)
print v(xbgr.mr_n60380176)
print v(xbgr.mr_n60380496)
print v(xbgr.mr_n60380608)
print v(xbgr.mr_n60380928)
print v(xbgr.mr_n60381040)
print v(xbgr.mr_n60381360)
print v(xbgr.mr_n60381472)
print v(xbgr.mr_n60381792)
print v(xbgr.mr_n60381904)
print v(xbgr.mr_n60382224)
print v(xbgr.mr_n60382336)
print v(xbgr.mr_n60382656)
print v(xbgr.mr_n60382768)
print v(xbgr.mr_n60383088)
print v(xbgr.mr_n60383200)
print v(xbgr.mr_n60383520)
print v(xbgr.mr_n60383632)
print v(xbgr.mr_n60383952)
print v(xbgr.mr_n60384064)
print v(xbgr.mr_n60384384)
print v(xbgr.mr_n60384496)
print v(xbgr.mr_n60384816)
print v(xbgr.mr_n60384928)
print v(xbgr.mr_n60385248)
print v(xbgr.mr_n60385360)
print v(xbgr.mr_n60385680)
print v(xbgr.mr_n60385792)
print v(xbgr.mr_n60386112)
print v(xbgr.mr_n60386224)
print v(xbgr.mr_n60386544)
print v(xbgr.mr_n60386656)
print v(xbgr.mr_n60386976)
print v(xbgr.mr_n60387088)
print v(xbgr.mr_n60387408)
print v(xbgr.mr_n60387520)
print v(xbgr.mr_n60387840)
print v(xbgr.mr_n60387952)
print v(xbgr.mr_n60388272)
print v(xbgr.mr_n60388384)
print v(xbgr.mr_n60388704)
print v(xbgr.mr_n60388816)
print v(xbgr.mr_n60389136)
print v(xbgr.mr_n60389248)
print v(xbgr.mr_n60389568)
print v(xbgr.mr_n60389680)
print v(xbgr.mr_n60390000)
print v(xbgr.mr_n60390112)
print v(xbgr.mr_n60390432)
print v(xbgr.mr_n60390544)
print v(xbgr.mr_n60390864)
print v(xbgr.mr_n60390976)
print v(xbgr.mr_n60391296)
print v(xbgr.mr_n60391408)
print v(xbgr.mr_n60391728)
print v(xbgr.mr_n60391840)
print v(xbgr.mr_n60392160)
print v(xbgr.mr_n60392272)
print v(xbgr.mr_n60392592)
print v(xbgr.mr_n60392704)
print v(xbgr.mr_n60393024)
print v(xbgr.mr_n60393136)
print v(xbgr.mr_n60393456)
print v(xbgr.mr_n60393568)
print v(xbgr.mr_n60393888)
print v(xbgr.mr_n60394000)
print v(xbgr.mr_n60394320)
print v(xbgr.mr_n60394432)
print v(xbgr.mr_n60394752)
print v(xbgr.mr_n60394864)
print v(xbgr.mr_n60395184)
print v(xbgr.mr_n60395296)
print v(xbgr.mr_n60395616)
print v(xbgr.mr_n60395728)
print v(xbgr.mr_n60396048)
print v(xbgr.mr_n60396160)
print v(xbgr.mr_n60396480)
print v(xbgr.mr_n60396592)
print v(xbgr.mr_n60396912)
print v(xbgr.mr_n60397024)
print v(xbgr.mr_n60397344)
print v(xbgr.mr_n60397456)
print v(xbgr.mr_n60397776)
print v(xbgr.mr_n60397888)
print v(xbgr.mr_n60398208)
print v(xbgr.mr_n60398320)
print v(xbgr.mr_n60398640)
print v(xbgr.mr_n60398752)
print v(xbgr.mr_n60399072)
print v(xbgr.mr_n60399184)
print v(xbgr.mr_n60399504)
print v(xbgr.mr_n60399616)
print v(xbgr.mr_n60399936)
print v(xbgr.mr_n60400048)
print v(xbgr.mr_n60400368)
print v(xbgr.mr_n60400480)
print v(xbgr.mr_n60400800)
print v(xbgr.mr_n60400912)
print v(xbgr.mr_n60401232)
print v(xbgr.mr_n60401344)
print v(xbgr.mr_n60401664)
print v(xbgr.mr_n60401776)
print v(xbgr.mr_n60402096)
print v(xbgr.mr_n60402208)
print v(xbgr.mr_n60402528)
print v(xbgr.mr_n60402640)
print v(xbgr.mr_n60402960)
print v(xbgr.mr_n60403072)
print v(xbgr.mr_n60403392)
print v(xbgr.mr_n60403504)
print v(xbgr.mr_n60403824)
print v(xbgr.mr_n60403936)
print v(xbgr.mr_n60404256)
print v(xbgr.mr_n60404368)
print v(xbgr.mr_n60404688)
print v(xbgr.mr_n60404800)
print v(xbgr.mr_n60405120)
print v(xbgr.mr_n60405232)
print v(xbgr.mr_n60405552)
print v(xbgr.mr_n60405664)
print v(xbgr.mr_n60405984)
print v(xbgr.mr_n60406096)
print v(xbgr.mr_n60406416)
print v(xbgr.mr_n60406528)
print v(xbgr.mr_n60406848)
print v(xbgr.mr_n60406960)
print v(xbgr.mr_n60407280)
print v(xbgr.mr_n60407392)
print v(xbgr.mr_n60407712)
print v(xbgr.mr_n60407824)
print v(xbgr.mr_n60408144)
print v(xbgr.mr_n60408256)
print v(xbgr.mr_n60408576)
print v(xbgr.mr_n60408688)
print v(xbgr.mr_n60409008)
print v(xbgr.mr_n60409120)
print v(xbgr.mr_n60409440)
print v(xbgr.mr_n60409552)
print v(xbgr.mr_n60409872)
print v(xbgr.mr_n60409984)
print v(xbgr.mr_n60410304)
print v(xbgr.mr_n60410416)
print v(xbgr.mr_n60410736)
print v(xbgr.mr_n60410848)
print v(xbgr.mr_n60411168)
print v(xbgr.mr_n60411280)
print v(xbgr.mr_n60411600)
print v(xbgr.mr_n60411712)
print v(xbgr.mr_n60412032)
print v(xbgr.mr_n60412144)
print v(xbgr.mr_n60412464)
print v(xbgr.mr_n60412576)
print v(xbgr.mr_n60412896)
print v(xbgr.mr_n60413008)
print v(xbgr.mr_n60413328)
print v(xbgr.mr_n60413440)
print v(xbgr.mr_n60413760)
print v(xbgr.mr_n60413872)
print v(xbgr.mr_n60414192)
print v(xbgr.mr_n60414304)
print v(xbgr.mr_n60414624)
print v(xbgr.mr_n60414736)
print v(xbgr.mr_n60415056)
print v(xbgr.mr_n60415168)
print v(xbgr.mr_n60415488)
print v(xbgr.mr_n60415600)
print v(xbgr.mr_n60415920)
print v(xbgr.mr_n60416032)
print v(xbgr.mr_n60416352)
print v(xbgr.mr_n60416464)
print v(xbgr.mr_n60416784)
print v(xbgr.mr_n60416896)
print v(xbgr.mr_n60417216)
print v(xbgr.mr_n60417328)
print v(xbgr.mr_n60417648)
print v(xbgr.mr_n60417760)
print v(xbgr.mr_n60418080)
print v(xbgr.mr_n60418192)
print v(xbgr.mr_n60418512)
print v(xbgr.mr_n60418624)
print v(xbgr.mr_n60418944)
print v(xbgr.mr_n60419056)
print v(xbgr.mr_n60419376)
print v(xbgr.mr_n60419488)
print v(xbgr.mr_n60419808)
print v(xbgr.mr_n60419920)
print v(xbgr.mr_n60420240)
print v(xbgr.mr_n60420352)
print v(xbgr.mr_n60420672)
print v(xbgr.mr_n60420784)
print v(xbgr.mr_n60421104)
print v(xbgr.mr_n60421216)
print v(xbgr.mr_n60421536)
print v(xbgr.mr_n60421648)
print v(xbgr.mr_n60421968)
print v(xbgr.mr_n60422080)
print v(xbgr.mr_n60422400)
print v(xbgr.mr_n60422512)
print v(xbgr.mr_n60422832)
print v(xbgr.mr_n60422944)
print v(xbgr.mr_n60423264)
print v(xbgr.mr_n60423376)
print v(xbgr.mr_n60423696)
print v(xbgr.mr_n60423808)
print v(xbgr.mr_n60424128)
print v(xbgr.mr_n60424240)
print v(xbgr.mr_n60424560)
print v(xbgr.mr_n60424672)
print v(xbgr.mr_n60424992)
print v(xbgr.mr_n60425104)
print v(xbgr.mr_n60425424)
print v(xbgr.mr_n60425536)
print v(xbgr.mr_n60425856)
print v(xbgr.mr_n60425968)
print v(xbgr.mr_n60426288)
print v(xbgr.mr_n60426400)
print v(xbgr.mr_n60426720)
print v(xbgr.mr_n60426832)
print v(xbgr.mr_n60427152)
print v(xbgr.mr_n60427264)
print v(xbgr.mr_n60427584)
print v(xbgr.mr_n60427696)
print v(xbgr.mr_n60428016)
print v(xbgr.mr_n60428128)
print v(xbgr.mr_n60428448)
print v(xbgr.mr_n60428560)
print v(xbgr.mr_n60428880)
print v(xbgr.mr_n60428992)
print v(xbgr.mr_n60429312)
print v(xbgr.mr_n60429424)
print v(xbgr.mr_n60429744)
print v(xbgr.mr_n60429856)
print v(xbgr.mr_n60430176)
print v(xbgr.mr_n60430288)
print v(xbgr.mr_n60430608)
print v(xbgr.mr_n60430720)
print v(xbgr.mr_n60431040)
print v(xbgr.mr_n60431152)
print v(xbgr.mr_n60431472)
print v(xbgr.mr_n60431584)
print v(xbgr.mr_n60431904)
print v(xbgr.mr_n60432016)
print v(xbgr.mr_n60432336)
print v(xbgr.mr_n60432448)
print v(xbgr.mr_n60432768)
print v(xbgr.mr_n60432880)
print v(xbgr.mr_n60433200)
print v(xbgr.mr_n60433312)
print v(xbgr.mr_n60433632)
print v(xbgr.mr_n60433744)
print v(xbgr.mr_n60434064)
print v(xbgr.mr_n60434176)
print v(xbgr.mr_n60434496)
print v(xbgr.mr_n60434608)
print v(xbgr.mr_n60434928)
print v(xbgr.mr_n60435040)
print v(xbgr.mr_n60435360)
print v(xbgr.mr_n60435472)
print v(xbgr.mr_n60435792)
print v(xbgr.mr_n60435904)
print v(xbgr.mr_n60436224)
print v(xbgr.mr_n60436336)
print v(xbgr.mr_n60436656)
print v(xbgr.mr_n60436768)
print v(xbgr.mr_n60437088)
print v(xbgr.mr_n60437200)
print v(xbgr.mr_n60437520)
print v(xbgr.mr_n60437632)
print v(xbgr.mr_n60437952)
print v(xbgr.mr_n60438064)
print v(xbgr.mr_n60438384)
print v(xbgr.mr_n60438496)
print v(xbgr.mr_n60438816)
print v(xbgr.mr_n60438928)
print v(xbgr.mr_n60439248)
print v(xbgr.mr_n60439360)
print v(xbgr.mr_n60439680)
print v(xbgr.mr_n60439792)
print v(xbgr.mr_n60440112)
print v(xbgr.mr_n60440224)
print v(xbgr.mr_n60440544)
print v(xbgr.mr_n60440656)
print v(xbgr.mr_n60440976)
print v(xbgr.mr_n60441088)
print v(xbgr.mr_n60441408)
print v(xbgr.mr_n60441520)
print v(xbgr.mr_n60441840)
print v(xbgr.mr_n60441952)
print v(xbgr.mr_n60442272)
print v(xbgr.mr_n60442384)
print v(xbgr.mr_n60442704)
print v(xbgr.mr_n60442816)
print v(xbgr.mr_n60443136)
print v(xbgr.mr_n60443248)
print v(xbgr.mr_n60443568)
print v(xbgr.mr_n60443680)
print v(xbgr.mr_n60444000)
print v(xbgr.mr_n60444112)
print v(xbgr.mr_n60444432)
print v(xbgr.mr_n60444544)
print v(xbgr.mr_n60444864)
print v(xbgr.mr_n60444976)
print v(xbgr.mr_n60445296)
print v(xbgr.mr_n60445408)
print v(xbgr.mr_n60445728)
print v(xbgr.mr_n60445840)
print v(xbgr.mr_n60446160)
print v(xbgr.mr_n60446272)
print v(xbgr.mr_n60446592)
print v(xbgr.mr_n60446704)
print v(xbgr.mr_n60447024)
print v(xbgr.mr_n60447136)
print v(xbgr.mr_n60447456)
print v(xbgr.mr_n60447568)
print v(xbgr.mr_n60447888)
print v(xbgr.mr_n60448000)
print v(xbgr.mr_n60448320)
print v(xbgr.mr_n60448432)
print v(xbgr.mr_n60448752)
print v(xbgr.mr_n60448864)
print v(xbgr.mr_n60449184)
print v(xbgr.mr_n60449296)
print v(xbgr.mr_n60449616)
print v(xbgr.mr_n60449728)
print v(xbgr.mr_n60450048)
print v(xbgr.mr_n60450160)
print v(xbgr.mr_n60450480)
print v(xbgr.mr_n60450592)
print v(xbgr.mr_n60450912)
print v(xbgr.mr_n60451024)
print v(xbgr.mr_n60451344)
print v(xbgr.mr_n60451456)
print v(xbgr.mr_n60451776)
print v(xbgr.mr_n60451888)
print v(xbgr.mr_n60452208)
print v(xbgr.mr_n60452320)
print v(xbgr.mr_n60452640)
print v(xbgr.mr_n60452752)
print v(xbgr.mr_n60453072)
print v(xbgr.mr_n60453184)
print v(xbgr.mr_n60453504)
print v(xbgr.mr_n60453616)
print v(xbgr.mr_n60453936)
print v(xbgr.mr_n60454048)
print v(xbgr.mr_n60454368)
print v(xbgr.mr_n60454480)
print v(xbgr.mr_n60454800)
print v(xbgr.mr_n60454912)
print v(xbgr.mr_n60455232)
print v(xbgr.mr_n60455344)
print v(xbgr.mr_n60455664)
print v(xbgr.mr_n60455776)
print v(xbgr.mr_n60456096)
print v(xbgr.mr_n60456208)
print v(xbgr.mr_n60456528)
print v(xbgr.mr_n60456640)
print v(xbgr.mr_n60456960)
print v(xbgr.mr_n60457072)
print v(xbgr.mr_n60457392)
print v(xbgr.mr_n60457504)
print v(xbgr.mr_n60457824)
print v(xbgr.mr_n60457936)
print v(xbgr.mr_n60458256)
print v(xbgr.mr_n60458368)
print v(xbgr.mr_n60458688)
print v(xbgr.mr_n60458800)
print v(xbgr.mr_n60459120)
print v(xbgr.mr_n60459232)
print v(xbgr.mr_n60459552)
print v(xbgr.mr_n60459664)
print v(xbgr.mr_n60459984)
print v(xbgr.mr_n60460096)
print v(xbgr.mr_n60460416)
print v(xbgr.mr_n60460528)
print v(xbgr.mr_n60460848)
print v(xbgr.mr_n60460960)
print v(xbgr.mr_n60461280)
print v(xbgr.mr_n60461392)
print v(xbgr.mr_n60461712)
print v(xbgr.mr_n60461824)
print v(xbgr.mr_n60462144)
print v(xbgr.mr_n60462256)
print v(xbgr.mr_n60462576)
print v(xbgr.mr_n60462688)
print v(xbgr.mr_n60463008)
print v(xbgr.mr_n60463120)
print v(xbgr.mr_n60463440)
print v(xbgr.mr_n60463552)
print v(xbgr.mr_n60463872)
print v(xbgr.mr_n60463984)
print v(xbgr.mr_n60464304)
print v(xbgr.mr_n60464416)
print v(xbgr.mr_n60464736)
print v(xbgr.mr_n60464848)
print v(xbgr.mr_n60465168)
print v(xbgr.mr_n60465280)
print v(xbgr.mr_n60465600)
print v(xbgr.mr_n60465712)
print v(xbgr.mr_n60466032)
print v(xbgr.mr_n60466144)
print v(xbgr.mr_n60466464)
print v(xbgr.mr_n60466576)
print v(xbgr.mr_n60466896)
print v(xbgr.mr_n60467008)
print v(xbgr.mr_n60467328)
print v(xbgr.mr_n60467440)
print v(xbgr.mr_n60467760)
print v(xbgr.mr_n60467872)
print v(xbgr.mr_n60468192)
print v(xbgr.mr_n60468304)
print v(xbgr.mr_n60468624)
print v(xbgr.mr_n60468736)
print v(xbgr.mr_n60469056)
print v(xbgr.mr_n60469168)
print v(xbgr.mr_n60469488)
print v(xbgr.mr_n60469600)
print v(xbgr.mr_n60469920)
print v(xbgr.mr_n60470032)
print v(xbgr.mr_n60470352)
print v(xbgr.mr_n60470464)
print v(xbgr.mr_n60470784)
print v(xbgr.mr_n60470896)
print v(xbgr.mr_n60471216)
print v(xbgr.mr_n60471328)
print v(xbgr.mr_n60471648)
print v(xbgr.mr_n60471760)
print v(xbgr.mr_n60472080)
print v(xbgr.mr_n60472192)
print v(xbgr.mr_n60472512)
print v(xbgr.mr_n60472624)
print v(xbgr.mr_n60472944)
print v(xbgr.mr_n60473056)
print v(xbgr.mr_n60473376)
print v(xbgr.mr_n60473488)
print v(xbgr.mr_n60473808)
print v(xbgr.mr_n60473920)
print v(xbgr.mr_n60474240)
print v(xbgr.mr_n60474352)
print v(xbgr.mr_n60474672)
print v(xbgr.mr_n60474784)
print v(xbgr.mr_n60475104)
print v(xbgr.mr_n60475216)
print v(xbgr.mr_n60475536)
print v(xbgr.mr_n60475648)
print v(xbgr.mr_n60475968)
print v(xbgr.mr_n60476080)
print v(xbgr.mr_n60476400)
print v(xbgr.mr_n60476512)
print v(xbgr.mr_n60476832)
print v(xbgr.mr_n60476944)
print v(xbgr.mr_n60477264)
print v(xbgr.mr_n60477376)
print v(xbgr.mr_n60477696)
print v(xbgr.mr_n60477808)
print v(xbgr.mr_n60478128)
print v(xbgr.mr_n60478240)
print v(xbgr.mr_n60478560)
print v(xbgr.mr_n60478672)
print v(xbgr.mr_n60478992)
print v(xbgr.mr_n60479104)
print v(xbgr.mr_n60479424)
print v(xbgr.mr_n60479536)
print v(xbgr.mr_n60479856)
print v(xbgr.mr_n60479968)
print v(xbgr.mr_n60480288)
print v(xbgr.mr_n60480400)
print v(xbgr.mr_n60480720)
print v(xbgr.mr_n60480832)
print v(xbgr.mr_n60481152)
print v(xbgr.mr_n60481264)
print v(xbgr.mr_n60481584)
print v(xbgr.mr_n60481696)
print v(xbgr.mr_n60482016)
print v(xbgr.mr_n60482128)
print v(xbgr.mr_n60482448)
print v(xbgr.mr_n60482560)
print v(xbgr.mr_n60482880)
print v(xbgr.mr_n60482992)
print v(xbgr.mr_n60483312)
print v(xbgr.mr_n60483424)
print v(xbgr.mr_n60483744)
print v(xbgr.mr_n60483856)
print v(xbgr.mr_n60484176)
print v(xbgr.mr_n60484288)
print v(xbgr.mr_n60484608)
print v(xbgr.mr_n60484720)
print v(xbgr.mr_n60485040)
print v(xbgr.mr_n60485152)
print v(xbgr.mr_n60485472)
print v(xbgr.mr_n60485584)
print v(xbgr.mr_n60485904)
print v(xbgr.mr_n60486016)
print v(xbgr.mr_n60486336)
print v(xbgr.mr_n60486448)
print v(xbgr.mr_n60486768)
print v(xbgr.mr_n60486880)
print v(xbgr.mr_n60487200)
print v(xbgr.mr_n60487312)
print v(xbgr.mr_n60487632)
print v(xbgr.mr_n60487744)
print v(xbgr.mr_n60488064)
print v(xbgr.mr_n60488176)
print v(xbgr.mr_n60488496)
print v(xbgr.mr_n60488608)
print v(xbgr.mr_n60488928)
print v(xbgr.mr_n60489040)
print v(xbgr.mr_n60489360)
print v(xbgr.mr_n60489472)
print v(xbgr.mr_n60489792)
print v(xbgr.mr_n60489904)
print v(xbgr.mr_n60490224)
print v(xbgr.mr_n60490336)
print v(xbgr.mr_n60490656)
print v(xbgr.mr_n60490768)
print v(xbgr.mr_n60491088)
print v(xbgr.mr_n60491200)
print v(xbgr.mr_n60491520)
print v(xbgr.mr_n60491632)
print v(xbgr.mr_n60491952)
print v(xbgr.mr_n60492064)
print v(xbgr.mr_n60492384)
print v(xbgr.mr_n60492496)
print v(xbgr.mr_n60492816)
print v(xbgr.mr_n60492928)
print v(xbgr.mr_n60493248)
print v(xbgr.mr_n60493360)
print v(xbgr.mr_n60493680)
print v(xbgr.mr_n60493792)
print v(xbgr.mr_n60494112)
print v(xbgr.mr_n60494224)
print v(xbgr.mr_n60494544)
print v(xbgr.mr_n60494656)
print v(xbgr.mr_n60494976)
print v(xbgr.mr_n60495088)
print v(xbgr.mr_n60495408)
print v(xbgr.mr_n60495520)
print v(xbgr.mr_n60495840)
print v(xbgr.mr_n60495952)
print v(xbgr.mr_n60496272)
print v(xbgr.mr_n60496384)
print v(xbgr.mr_n60496704)
print v(xbgr.mr_n60496816)
print v(xbgr.mr_n60497136)
print v(xbgr.mr_n60497248)
print v(xbgr.mr_n60497568)
print v(xbgr.mr_n60497680)
print v(xbgr.mr_n60498000)
print v(xbgr.mr_n60498112)
print v(xbgr.mr_n60498432)
print v(xbgr.mr_n60498544)
print v(xbgr.mr_n60498864)
print v(xbgr.mr_n60498976)
print v(xbgr.mr_n60499296)
print v(xbgr.mr_n60499408)
print v(xbgr.mr_n60499728)
print v(xbgr.mr_n60499840)
print v(xbgr.mr_n60500160)
print v(xbgr.mr_n60500272)
print v(xbgr.mr_n60500592)
print v(xbgr.mr_n60500704)
print v(xbgr.mr_n60501024)
print v(xbgr.mr_n60501136)
print v(xbgr.mr_n60501456)
print v(xbgr.mr_n60501568)
print v(xbgr.mr_n60501888)
print v(xbgr.mr_n60502000)
print v(xbgr.mr_n60502320)
print v(xbgr.mr_n60502432)
print v(xbgr.mr_n60502752)
print v(xbgr.mr_n60502864)
print v(xbgr.mr_n60503184)
print v(xbgr.mr_n60503296)
print v(xbgr.mr_n60503616)
print v(xbgr.mr_n60503728)
print v(xbgr.mr_n60504048)
print v(xbgr.mr_n60504160)
print v(xbgr.mr_n60504480)
print v(xbgr.mr_n60504592)
print v(xbgr.mr_n60504912)
print v(xbgr.mr_n60505024)
print v(xbgr.mr_n60505344)
print v(xbgr.mr_n60505456)
print v(xbgr.mr_n60505776)
print v(xbgr.mr_n60505888)
print v(xbgr.mr_n60506208)
print v(xbgr.mr_n60506320)
print v(xbgr.mr_n60506640)
print v(xbgr.mr_n60506752)
print v(xbgr.mr_n60507072)
print v(xbgr.mr_n60507184)
print v(xbgr.mr_n60507504)
print v(xbgr.mr_n60507616)
print v(xbgr.mr_n60507936)
print v(xbgr.mr_n60508048)
print v(xbgr.mr_n60508368)
print v(xbgr.mr_n60508480)
print v(xbgr.mr_n60508800)
print v(xbgr.mr_n60508912)
print v(xbgr.mr_n60509232)
print v(xbgr.mr_n60509344)
print v(xbgr.mr_n60509664)
print v(xbgr.mr_n60509776)
print v(xbgr.mr_n60510096)
print v(xbgr.mr_n60510208)
print v(xbgr.mr_n60510528)
print v(xbgr.mr_n60510640)
print v(xbgr.mr_n60510960)
print v(xbgr.mr_n60511072)
print v(xbgr.mr_n60511392)
print v(xbgr.mr_n60511504)
print v(xbgr.mr_n60511824)
print v(xbgr.mr_n60511936)
print v(xbgr.mr_n60512256)
print v(xbgr.mr_n60512368)
print v(xbgr.mr_n60512688)
print v(xbgr.mr_n60512800)
print v(xbgr.mr_n60513120)
print v(xbgr.mr_n60513232)
print v(xbgr.mr_n60513552)
print v(xbgr.mr_n60513664)
print v(xbgr.mr_n60513984)
print v(xbgr.mr_n60514096)
print v(xbgr.mr_n60514416)
print v(xbgr.mr_n60514528)
print v(xbgr.mr_n60514848)
print v(xbgr.mr_n60514960)
print v(xbgr.mr_n60515280)
print v(xbgr.mr_n60515392)
print v(xbgr.mr_n60515712)
print v(xbgr.mr_n60515824)
print v(xbgr.mr_n60516144)
print v(xbgr.mr_n60516256)
print v(xbgr.mr_n60516576)
print v(xbgr.mr_n60516688)
print v(xbgr.mr_n60517008)
print v(xbgr.mr_n60517120)
print v(xbgr.mr_n60517440)
print v(xbgr.mr_n60517552)
print v(xbgr.mr_n60517872)
print v(xbgr.mr_n60517984)
print v(xbgr.mr_n60518304)
print v(xbgr.mr_n60518416)
print v(xbgr.mr_n60518736)
print v(xbgr.mr_n60518848)
print v(xbgr.mr_n60519168)
print v(xbgr.mr_n60519280)
print v(xbgr.mr_n60519600)
print v(xbgr.mr_n60519712)
print v(xbgr.mr_n60520032)
print v(xbgr.mr_n60520144)
print v(xbgr.mr_n60520576)
print v(xbgr.mr_n60520896)
print v(xbgr.mr_n60521008)
print v(xbgr.mr_n60521328)
print v(xbgr.mr_n60521440)
print v(xbgr.mr_n60521760)
print v(xbgr.mr_n60521872)
print v(xbgr.mr_n60522192)
print v(xbgr.mr_n60522304)
print v(xbgr.mr_n60522624)
print v(xbgr.mr_n60522736)
print v(xbgr.mr_n60523056)
print v(xbgr.mr_n60523168)
print v(xbgr.mr_n60523488)
print v(xbgr.mr_n60523600)
print v(xbgr.mr_n60523920)
print v(xbgr.mr_n60524032)
print v(xbgr.mr_n60524352)
print v(xbgr.mr_n60524464)
print v(xbgr.mr_n60524784)
print v(xbgr.mr_n60524896)
print v(xbgr.mr_n60525216)
print v(xbgr.mr_n60525328)
print v(xbgr.mr_n60525648)
print v(xbgr.mr_n60525760)
print v(xbgr.mr_n60526080)
print v(xbgr.mr_n60526192)
print v(xbgr.mr_n60526624)
print v(xbgr.mr_n60526944)
print v(xbgr.mr_n60527056)
print v(xbgr.mr_n60527376)
print v(xbgr.mr_n60527488)
print v(xbgr.mr_n60527808)
print v(xbgr.mr_n60527920)
print v(xbgr.mr_n60528240)
print v(xbgr.mr_n60528352)
print v(xbgr.mr_n60528672)
print v(xbgr.mr_n60528784)
print v(xbgr.mr_n60529104)
print v(xbgr.mr_n60529216)
print v(xbgr.mr_n60529536)
print v(xbgr.mr_n60529648)
print v(xbgr.mr_n60529968)
print v(xbgr.mr_n60530080)
print v(xbgr.mr_n60530400)
print v(xbgr.mr_n60530512)
print v(xbgr.mr_n60530832)
print v(xbgr.mr_n60530944)
print v(xbgr.mr_n60531264)
print v(xbgr.mr_n60531376)
print v(xbgr.mr_n60531696)
print v(xbgr.mr_n60531808)
print v(xbgr.mr_n60532128)
print v(xbgr.mr_n60532240)
print v(xbgr.mr_n60532560)
print v(xbgr.mr_n60532672)
print v(xbgr.mr_n60532992)
print v(xbgr.mr_n60533104)
print v(xbgr.mr_n60533424)
print v(xbgr.mr_n60533536)
print v(xbgr.mr_n60533856)
print v(xbgr.mr_n60533968)
print v(xbgr.mr_n60534288)
print v(xbgr.mr_n60534400)
print v(xbgr.mr_n60534720)
print v(xbgr.mr_n60534832)
print v(xbgr.mr_n60535152)
print v(xbgr.mr_n60535264)
print v(xbgr.mr_n60535584)
print v(xbgr.mr_n60535696)
print v(xbgr.mr_n60536016)
print v(xbgr.mr_n60536128)
print v(xbgr.mr_n60536448)
print v(xbgr.mr_n60536560)
print v(xbgr.mr_n60536880)
print v(xbgr.mr_n60536992)
print v(xbgr.mr_n60537312)
print v(xbgr.mr_n60537424)
print v(xbgr.mr_n60537744)
print v(xbgr.mr_n60537856)
print v(xbgr.mr_n60538176)
print v(xbgr.mr_n60538288)
print v(xbgr.mr_n60538608)
print v(xbgr.mr_n60538720)
print v(xbgr.mr_n60539040)
print v(xbgr.mr_n60539152)
print v(xbgr.mr_n60539472)
print v(xbgr.mr_n60539584)
print v(xbgr.mr_n60539904)
print v(xbgr.mr_n60540016)
print v(xbgr.mr_n60540336)
print v(xbgr.mr_n60540448)
print v(xbgr.mr_n60540768)
print v(xbgr.mr_n60540880)
print v(xbgr.mr_n60541200)
print v(xbgr.mr_n60541312)
print v(xbgr.mr_n60541632)
print v(xbgr.mr_n60541744)
print v(xbgr.mr_n60542064)
print v(xbgr.mr_n60542176)
print v(xbgr.mr_n60542496)
print v(xbgr.mr_n60542608)
print v(xbgr.mr_n60542928)
print v(xbgr.mr_n60543040)
print v(xbgr.mr_n60543360)
print v(xbgr.mr_n60543472)
print v(xbgr.mr_n60543792)
print v(xbgr.mr_n60543904)
print v(xbgr.mr_n60544224)
print v(xbgr.mr_n60544336)
print v(xbgr.mr_n60544656)
print v(xbgr.mr_n60544768)
print v(xbgr.mr_n60545088)
print v(xbgr.mr_n60545200)
print v(xbgr.mr_n60545520)
print v(xbgr.mr_n60545632)
print v(xbgr.mr_n60545952)
print v(xbgr.mr_n60546064)
print v(xbgr.mr_n60546384)
print v(xbgr.mr_n60546496)
print v(xbgr.mr_n60546816)
print v(xbgr.mr_n60546928)
print v(xbgr.mr_n60547248)
print v(xbgr.mr_n60547360)
print v(xbgr.mr_n60547680)
print v(xbgr.mr_n60547792)
print v(xbgr.mr_n60548112)
print v(xbgr.mr_n60548224)
print v(xbgr.mr_n60548544)
print v(xbgr.mr_n60548656)
print v(xbgr.mr_n60548976)
print v(xbgr.mr_n60549088)
print v(xbgr.mr_n60549408)
print v(xbgr.mr_n60549520)
print v(xbgr.mr_n60549840)
print v(xbgr.mr_n60549952)
print v(xbgr.mr_n60550272)
print v(xbgr.mr_n60550384)
print v(xbgr.mr_n60550704)
print v(xbgr.mr_n60550816)
print v(xbgr.mr_n60551136)
print v(xbgr.mr_n60551248)
print v(xbgr.mr_n60551568)
print v(xbgr.mr_n60551680)
print v(xbgr.mr_n60552000)
print v(xbgr.mr_n60552112)
print v(xbgr.mr_n60552432)
print v(xbgr.mr_n60552544)
print v(xbgr.mr_n60552864)
print v(xbgr.mr_n60552976)
print v(xbgr.mr_n60553296)
print v(xbgr.mr_n60553408)
print v(xbgr.mr_n60553728)
print v(xbgr.mr_n60553840)
print v(xbgr.mr_n60554160)
print v(xbgr.mr_n60554272)
print v(xbgr.mr_n60554592)
print v(xbgr.mr_n60554704)
print v(xbgr.mr_n60555024)
print v(xbgr.mr_n60555136)
print v(xbgr.mr_n60555456)
print v(xbgr.mr_n60555568)
print v(xbgr.mr_n60555888)
print v(xbgr.mr_n60556000)
print v(xbgr.mr_n60556320)
print v(xbgr.mr_n60556432)
print v(xbgr.mr_n60556752)
print v(xbgr.mr_n60556864)
print v(xbgr.mr_n60557184)
print v(xbgr.mr_n60557296)
print v(xbgr.mr_n60557616)
print v(xbgr.mr_n60557728)
print v(xbgr.mr_n60558048)
print v(xbgr.mr_n60558160)
print v(xbgr.mr_n60558480)
print v(xbgr.mr_n60558592)
print v(xbgr.mr_n60558912)
print v(xbgr.mr_n60559024)
print v(xbgr.mr_n60559456)
print v(xbgr.mr_n60559776)
print v(xbgr.mr_n60559888)
print v(xbgr.mr_n60560208)
print v(xbgr.mr_n60560320)
print v(xbgr.mr_n60560640)
print v(xbgr.mr_n60560752)
print v(xbgr.mr_n60561184)
print v(xbgr.mr_n60561504)
print v(xbgr.mr_n60561616)
print v(xbgr.mr_n60561936)
print v(xbgr.mr_n60562048)
print v(xbgr.mr_n60562368)
print v(xbgr.mr_n60562480)
print v(xbgr.mr_n60562912)
print v(xbgr.mr_n60563232)
print v(xbgr.mr_n60563344)
print v(xbgr.mr_n60563664)
print v(xbgr.mr_n60563776)
print v(xbgr.mr_n60564096)
print v(xbgr.mr_n60564208)
print v(xbgr.mr_n60564528)
print v(xbgr.mr_n60564640)
print v(xbgr.mr_n60564960)
print v(xbgr.mr_n60565072)
print v(xbgr.mr_n60565392)
print v(xbgr.mr_n60565504)
print v(xbgr.mr_n60565824)
print v(xbgr.mr_n60565936)
print v(xbgr.mr_n60566256)
print v(xbgr.mr_n60566368)
print v(xbgr.mr_n60566688)
print v(xbgr.mr_n60566800)
print v(xbgr.mr_n60567120)
print v(xbgr.mr_n60567232)
print v(xbgr.mr_n60567552)
print v(xbgr.mr_n60567664)
print v(xbgr.mr_n60567984)
print v(xbgr.mr_n60568096)
print v(xbgr.mr_n60568416)
print v(xbgr.mr_n60568528)
print v(xbgr.mr_n60568848)
print v(xbgr.mr_n60568960)
print v(xbgr.mr_n60569280)
print v(xbgr.mr_n60569392)
print v(xbgr.mr_n60569712)
print v(xbgr.mr_n60569824)
print v(xbgr.mr_n60570144)
print v(xbgr.mr_n60570256)
print v(xbgr.mr_n60570576)
print v(xbgr.mr_n60570688)
print v(xbgr.mr_n60571008)
print v(xbgr.mr_n60571120)
print v(xbgr.mr_n60571440)
print v(xbgr.mr_n60571552)
print v(xbgr.mr_n60571872)
print v(xbgr.mr_n60571984)
print v(xbgr.mr_n60572304)
print v(xbgr.mr_n60572416)
print v(xbgr.mr_n60572736)
print v(xbgr.mr_n60572848)
print v(xbgr.mr_n60573168)
print v(xbgr.mr_n60573280)
print v(xbgr.mr_n60573600)
print v(xbgr.mr_n60573712)
print v(xbgr.mr_n60574032)
print v(xbgr.mr_n60574144)
print v(xbgr.mr_n60574464)
print v(xbgr.mr_n60574576)
print v(xbgr.mr_n60574896)
print v(xbgr.mr_n60575008)
print v(xbgr.mr_n60575328)
print v(xbgr.mr_n60575440)
print v(xbgr.mr_n60575760)
print v(xbgr.mr_n60575872)
print v(xbgr.mr_n60576192)
print v(xbgr.mr_n60576304)
print v(xbgr.mr_n60576624)
print v(xbgr.mr_n60576736)
print v(xbgr.mr_n60577056)
print v(xbgr.mr_n60577168)
print v(xbgr.mr_n60577488)
print v(xbgr.mr_n60577600)
print v(xbgr.mr_n60577920)
print v(xbgr.mr_n60578032)
print v(xbgr.mr_n60578352)
print v(xbgr.mr_n60578464)
print v(xbgr.mr_n60578784)
print v(xbgr.mr_n60578896)
print v(xbgr.mr_n60579216)
print v(xbgr.mr_n60579328)
print v(xbgr.mr_n60579648)
print v(xbgr.mr_n60579760)
print v(xbgr.mr_n60580080)
print v(xbgr.mr_n60580192)
print v(xbgr.mr_n60580512)
print v(xbgr.mr_n60580624)
print v(xbgr.mr_n60580944)
print v(xbgr.mr_n60581056)
print v(xbgr.mr_n60581376)
print v(xbgr.mr_n60581488)
print v(xbgr.mr_n60581808)
print v(xbgr.mr_n60581920)
print v(xbgr.mr_n60582240)
print v(xbgr.mr_n60582352)
print v(xbgr.mr_n60582672)
print v(xbgr.mr_n60582784)
print v(xbgr.mr_n60583216)
print v(xbgr.mr_n60583648)
print v(xbgr.mr_n60584080)
print v(xbgr.mr_n60584512)
print v(xbgr.mr_n60584944)
print v(xbgr.mr_n60585376)
print v(xbgr.mr_n60585808)
print v(xbgr.mr_n60586240)
print v(xbgr.mr_n60586672)
print v(xbgr.mr_n60587104)
print v(xbgr.mr_n60587536)
print v(xbgr.mr_n60587968)
print v(xbgr.mr_n60588400)
print v(xbgr.mr_n60588832)
print v(xbgr.mr_n60589264)
print v(xbgr.mr_n60589696)
print v(xbgr.mr_n60590128)
print v(xbgr.mr_n60590560)
print v(xbgr.mr_n60590992)
print v(xbgr.mr_n60591424)
print v(xbgr.mr_n60591856)
print v(xbgr.mr_n60592288)
print v(xbgr.mr_n60592720)
print v(xbgr.mr_n60593152)
print v(xbgr.mr_n60593584)
print v(xbgr.mr_n60594016)
print v(xbgr.mr_n60594448)
print v(xbgr.mr_n60594880)
print v(xbgr.mr_n60595312)
print v(xbgr.mr_n60595744)
print v(xbgr.mr_n60596176)
print v(xbgr.mr_n60596608)
print v(xbgr.mr_n60597040)
print v(xbgr.mr_n60597472)
print v(xbgr.mr_n60597904)
print v(xbgr.mr_n60598336)
print v(xbgr.mr_n60598768)
print v(xbgr.mr_n60599200)
print v(xbgr.mr_n60599632)
print v(xbgr.mr_n60600064)
print v(xbgr.mr_n60600496)
print v(xbgr.mr_n60600928)
print v(xbgr.mr_n60601360)
print v(xbgr.mr_n60601792)
print v(xbgr.mr_n60602224)
print v(xbgr.mr_n60602656)
print v(xbgr.mr_n60603088)
print v(xbgr.mr_n60603520)
print v(xbgr.mr_n60603952)
print v(xbgr.mr_n60604384)
print v(xbgr.mr_n60604816)
print v(xbgr.mr_n60605248)
print v(xbgr.mr_n60605680)
print v(xbgr.mr_n60606112)
print v(xbgr.mr_n60606544)
print v(xbgr.mr_n60606976)
print v(xbgr.mr_n60607408)
print v(xbgr.mr_n60607840)
print v(xbgr.mr_n60608272)
print v(xbgr.mr_n60608704)
print v(xbgr.mr_n60609136)
print v(xbgr.mr_n60609568)
print v(xbgr.mr_n60610000)
print v(xbgr.mr_n60610432)
print v(xbgr.mr_n60610864)
print v(xbgr.mr_n60611296)
print v(xbgr.mr_n60611728)
print v(xbgr.mr_n60612160)
print v(xbgr.mr_n60612592)
print v(xbgr.mr_n60613024)
print v(xbgr.mr_n60613456)
print v(xbgr.mr_n60613888)
print v(xbgr.mr_n60614320)
print v(xbgr.mr_n60614752)
print v(xbgr.mr_n60615184)
print v(xbgr.mr_n60615616)
print v(xbgr.mr_n60616048)
print v(xbgr.mr_n60616480)
print v(xbgr.mr_n60616912)
print v(xbgr.mr_n60617344)
print v(xbgr.mr_n60617664)
print v(xbgr.mr_n60617776)
print v(xbgr.mr_n60618208)
print v(xbgr.mr_n60618528)
print v(xbgr.mr_n60618640)
print v(xbgr.mr_n60618960)
print v(xbgr.mr_n60619072)
print v(xbgr.mr_n60619392)
print v(xbgr.mr_n60619504)
print v(xbgr.mr_n60619824)
print v(xbgr.mr_n60619936)
print v(xbgr.mr_n60620256)
print v(xbgr.mr_n60620368)
print v(xbgr.mr_n60620688)
print v(xbgr.mr_n60620800)
print v(xbgr.mr_n60621120)
print v(xbgr.mr_n60621232)
print v(xbgr.mr_n60621552)
print v(xbgr.mr_n60621664)
print v(xbgr.mr_n60621984)
print v(xbgr.mr_n60622096)
print v(xbgr.mr_n60622416)
print v(xbgr.mr_n60622528)
print v(xbgr.mr_n60622960)
print v(xbgr.mr_n60623392)
print v(xbgr.mr_n60623824)
print v(xbgr.mr_n60624256)
print v(xbgr.mr_n60624688)
print v(xbgr.mr_n60625120)
print v(xbgr.mr_n60625552)
print v(xbgr.mr_n60625984)
print v(xbgr.mr_n60626416)
print v(xbgr.mr_n60626848)
print v(xbgr.mr_n60627280)
print v(xbgr.mr_n60627712)
print v(xbgr.mr_n60628144)
print v(xbgr.mr_n60628576)
print v(xbgr.mr_n60629008)
print v(xbgr.mr_n60629440)
print v(xbgr.mr_n60629872)
print v(xbgr.mr_n60630304)
print v(xbgr.mr_n60630736)
print v(xbgr.mr_n60631168)
print v(xbgr.mr_n60631600)
print v(xbgr.mr_n60632032)
print v(xbgr.mr_n60632464)
print v(xbgr.mr_n60632896)
print v(xbgr.mr_n60633328)
print v(xbgr.mr_n60633760)
print v(xbgr.mr_n60634192)
print v(xbgr.mr_n60634464)
print v(xbgr.mr_n60634576)
print v(xbgr.mr_n60634896)
print v(xbgr.mr_n60635008)
print v(xbgr.mr_n60635328)
print v(xbgr.mr_n60635440)
print v(xbgr.mr_n60635760)
print v(xbgr.mr_n60635872)
print v(xbgr.mr_n60636192)
print v(xbgr.mr_n60636304)
print v(xbgr.mr_n60636624)
print v(xbgr.mr_n60636736)
print v(xbgr.mr_n60637056)
print v(xbgr.mr_n60637168)
print v(xbgr.mr_n60637488)
print v(xbgr.mr_n60637600)
print v(xbgr.mr_n60637920)
print v(xbgr.mr_n60638032)
print v(xbgr.mr_n60638352)
print v(xbgr.mr_n60638464)
print v(xbgr.mr_n60638784)
print v(xbgr.mr_n60638896)
print v(xbgr.mr_n60639216)
print v(xbgr.mr_n60639328)
print v(xbgr.mr_n60639648)
print v(xbgr.mr_n60639760)
print v(xbgr.mr_n60640080)
print v(xbgr.mr_n60640192)
print v(xbgr.mr_n60640512)
print v(xbgr.mr_n60640624)
print v(xbgr.mr_n60640944)
print v(xbgr.mr_n60641056)
print v(xbgr.mr_n60641376)
print v(xbgr.mr_n60641488)
print v(xbgr.mr_n60641808)
print v(xbgr.mr_n60641920)
print v(xbgr.mr_n60642240)
print v(xbgr.mr_n60642352)
print v(xbgr.mr_n60642672)
print v(xbgr.mr_n60642784)
print v(xbgr.mr_n60643104)
print v(xbgr.mr_n60643216)
print v(xbgr.mr_n60643536)
print v(xbgr.mr_n60643648)
print v(xbgr.mr_n60643968)
print v(xbgr.mr_n60644080)
print v(xbgr.mr_n60644400)
print v(xbgr.mr_n60644512)
print v(xbgr.mr_n60644832)
print v(xbgr.mr_n60644944)
print v(xbgr.mr_n60645264)
print v(xbgr.mr_n60645376)
print v(xbgr.mr_n60645696)
print v(xbgr.mr_n60645808)
print v(xbgr.mr_n60646128)
print v(xbgr.mr_n60646240)
print v(xbgr.mr_n60646560)
print v(xbgr.mr_n60646672)
print v(xbgr.mr_n60646992)
print v(xbgr.mr_n60647104)
print v(xbgr.mr_n60647424)
print v(xbgr.mr_n60647536)
print v(xbgr.mr_n60647856)
print v(xbgr.mr_n60647968)
print v(xbgr.mr_n60648288)
print v(xbgr.mr_n60648400)
print v(xbgr.mr_n60648720)
print v(xbgr.mr_n60648832)
print v(xbgr.mr_n60649152)
print v(xbgr.mr_n60649264)
print v(xbgr.mr_n60649584)
print v(xbgr.mr_n60649696)
print v(xbgr.mr_n60650016)
print v(xbgr.mr_n60650128)
print v(xbgr.mr_n60650448)
print v(xbgr.mr_n60650560)
print v(xbgr.mr_n60650880)
print v(xbgr.mr_n60650992)
print v(xbgr.mr_n60651312)
print v(xbgr.mr_n60651424)
print v(xbgr.mr_n60651744)
print v(xbgr.mr_n60651856)
print v(xbgr.mr_n60652176)
print v(xbgr.mr_n60652288)
print v(xbgr.mr_n60652608)
print v(xbgr.mr_n60652720)
print v(xbgr.mr_n60653040)
print v(xbgr.mr_n60653152)
print v(xbgr.mr_n60653472)
print v(xbgr.mr_n60653584)
print v(xbgr.mr_n60653904)
print v(xbgr.mr_n60654016)
print v(xbgr.mr_n60654336)
print v(xbgr.mr_n60654448)
print v(xbgr.mr_n60654768)
print v(xbgr.mr_n60654880)
print v(xbgr.mr_n60655200)
print v(xbgr.mr_n60655312)
print v(xbgr.mr_n60655632)
print v(xbgr.mr_n60655744)
print v(xbgr.mr_n60656064)
print v(xbgr.mr_n60656176)
print v(xbgr.mr_n60656496)
print v(xbgr.mr_n60656608)
print v(xbgr.mr_n60656928)
print v(xbgr.mr_n60657040)
print v(xbgr.mr_n60657360)
print v(xbgr.mr_n60657472)
print v(xbgr.mr_n60657792)
print v(xbgr.mr_n60657904)
print v(xbgr.mr_n60658224)
print v(xbgr.mr_n60658336)
print v(xbgr.mr_n60658656)
print v(xbgr.mr_n60658768)
print v(xbgr.mr_n60659088)
print v(xbgr.mr_n60659200)
print v(xbgr.mr_n60659520)
print v(xbgr.mr_n60659632)
print v(xbgr.mr_n60659952)
print v(xbgr.mr_n60660064)
print v(xbgr.mr_n60660384)
print v(xbgr.mr_n60660496)
print v(xbgr.mr_n60660816)
print v(xbgr.mr_n60660928)
print v(xbgr.mr_n60661248)
print v(xbgr.mr_n60661360)
print v(xbgr.mr_n60661680)
print v(xbgr.mr_n60661792)
print v(xbgr.mr_n60662112)
print v(xbgr.mr_n60662224)
print v(xbgr.mr_n60662544)
print v(xbgr.mr_n60662656)
print v(xbgr.mr_n60662976)
print v(xbgr.mr_n60663088)
print v(xbgr.mr_n60663408)
print v(xbgr.mr_n60663520)
print v(xbgr.mr_n60663840)
print v(xbgr.mr_n60663952)
print v(xbgr.mr_n60664272)
print v(xbgr.mr_n60664384)
print v(xbgr.mr_n60664704)
print v(xbgr.mr_n60664816)
print v(xbgr.mr_n60665136)
print v(xbgr.mr_n60665248)
print v(xbgr.mr_n60665568)
print v(xbgr.mr_n60665680)
print v(xbgr.mr_n60666000)
print v(xbgr.mr_n60666112)
print v(xbgr.mr_n60666432)
print v(xbgr.mr_n60666544)
print v(xbgr.mr_n60666864)
print v(xbgr.mr_n60666976)
print v(xbgr.mr_n60667296)
print v(xbgr.mr_n60667408)
print v(xbgr.mr_n60667728)
print v(xbgr.mr_n60667840)
print v(xbgr.mr_n60668160)
print v(xbgr.mr_n60668272)
print v(xbgr.mr_n60668592)
print v(xbgr.mr_n60668704)
print v(xbgr.mr_n60669024)
print v(xbgr.mr_n60669136)
print v(xbgr.mr_n60669456)
print v(xbgr.mr_n60669568)
print v(xbgr.mr_n60669888)
print v(xbgr.mr_n60670000)
print v(xbgr.mr_n60670320)
print v(xbgr.mr_n60670432)
print v(xbgr.mr_n60670752)
print v(xbgr.mr_n60670864)
print v(xbgr.mr_n60671184)
print v(xbgr.mr_n60671296)
print v(xbgr.mr_n60671616)
print v(xbgr.mr_n60671728)
print v(xbgr.mr_n60672048)
print v(xbgr.mr_n60672160)
print v(xbgr.mr_n60672480)
print v(xbgr.mr_n60672592)
print v(xbgr.mr_n60672912)
print v(xbgr.mr_n60673024)
print v(xbgr.mr_n60673344)
print v(xbgr.mr_n60673456)
print v(xbgr.mr_n60673776)
print v(xbgr.mr_n60673888)
print v(xbgr.mr_n60674208)
print v(xbgr.mr_n60674320)
print v(xbgr.mr_n60674640)
print v(xbgr.mr_n60674752)
print v(xbgr.mr_n60675072)
print v(xbgr.mr_n60675184)
print v(xbgr.mr_n60675504)
print v(xbgr.mr_n60675616)
print v(xbgr.mr_n60675936)
print v(xbgr.mr_n60676048)
print v(xbgr.mr_n60676368)
print v(xbgr.mr_n60676480)
print v(xbgr.mr_n60676800)
print v(xbgr.mr_n60676912)
print v(xbgr.mr_n60677232)
print v(xbgr.mr_n60677344)
print v(xbgr.mr_n60677664)
print v(xbgr.mr_n60677776)
print v(xbgr.mr_n60678096)
print v(xbgr.mr_n60678208)
print v(xbgr.mr_n60678528)
print v(xbgr.mr_n60678640)
print v(xbgr.mr_n60678960)
print v(xbgr.mr_n60679072)
print v(xbgr.mr_n60679392)
print v(xbgr.mr_n60679504)
print v(xbgr.mr_n60679824)
print v(xbgr.mr_n60679936)
print v(xbgr.mr_n60680256)
print v(xbgr.mr_n60680368)
print v(xbgr.mr_n60680688)
print v(xbgr.mr_n60680800)
print v(xbgr.mr_n60681120)
print v(xbgr.mr_n60681232)
print v(xbgr.mr_n60681552)
print v(xbgr.mr_n60681664)
print v(xbgr.mr_n60681984)
print v(xbgr.mr_n60682096)
print v(xbgr.mr_n60682416)
print v(xbgr.mr_n60682528)
print v(xbgr.mr_n60682848)
print v(xbgr.mr_n60682960)
print v(xbgr.mr_n60683280)
print v(xbgr.mr_n60683392)
print v(xbgr.mr_n60683712)
print v(xbgr.mr_n60683824)
print v(xbgr.mr_n60684144)
print v(xbgr.mr_n60684256)
print v(xbgr.mr_n60684576)
print v(xbgr.mr_n60684688)
print v(xbgr.mr_n60685008)
print v(xbgr.mr_n60685120)
print v(xbgr.mr_n60685440)
print v(xbgr.mr_n60685552)
print v(xbgr.mr_n60685872)
print v(xbgr.mr_n60685984)
print v(xbgr.mr_n60686304)
print v(xbgr.mr_n60686416)
print v(xbgr.mr_n60686736)
print v(xbgr.mr_n60686848)
print v(xbgr.mr_n60687168)
print v(xbgr.mr_n60687280)
print v(xbgr.mr_n60687600)
print v(xbgr.mr_n60687712)
print v(xbgr.mr_n60688032)
print v(xbgr.mr_n60688144)
print v(xbgr.mr_n60688464)
print v(xbgr.mr_n60688576)
print v(xbgr.mr_n60688896)
print v(xbgr.mr_n60689008)
print v(xbgr.mr_n60689328)
print v(xbgr.mr_n60689440)
print v(xbgr.mr_n60689760)
print v(xbgr.mr_n60689872)
print v(xbgr.mr_n60690192)
print v(xbgr.mr_n60690304)
print v(xbgr.mr_n60690624)
print v(xbgr.mr_n60690736)
print v(xbgr.mr_n60691056)
print v(xbgr.mr_n60691168)
print v(xbgr.mr_n60691488)
print v(xbgr.mr_n60691600)
print v(xbgr.mr_n60691920)
print v(xbgr.mr_n60692032)
print v(xbgr.mr_n60692352)
print v(xbgr.mr_n60692464)
print v(xbgr.mr_n60692784)
print v(xbgr.mr_n60692896)
print v(xbgr.mr_n60693216)
print v(xbgr.mr_n60693328)
print v(xbgr.mr_n60693648)
print v(xbgr.mr_n60693760)
print v(xbgr.mr_n60694080)
print v(xbgr.mr_n60694192)
print v(xbgr.mr_n60694512)
print v(xbgr.mr_n60694624)
print v(xbgr.mr_n60694944)
print v(xbgr.mr_n60695056)
print v(xbgr.mr_n60695376)
print v(xbgr.mr_n60695488)
print v(xbgr.mr_n60695808)
print v(xbgr.mr_n60695920)
print v(xbgr.mr_n60696240)
print v(xbgr.mr_n60696352)
print v(xbgr.mr_n60696672)
print v(xbgr.mr_n60696784)
print v(xbgr.mr_n60697104)
print v(xbgr.mr_n60697216)
print v(xbgr.mr_n60697536)
print v(xbgr.mr_n60697648)
print v(xbgr.mr_n60697968)
print v(xbgr.mr_n60698080)
print v(xbgr.mr_n60698400)
print v(xbgr.mr_n60698512)
print v(xbgr.mr_n60698832)
print v(xbgr.mr_n60698944)
print v(xbgr.mr_n60699264)
print v(xbgr.mr_n60699376)
print v(xbgr.mr_n60699696)
print v(xbgr.mr_n60699808)
print v(xbgr.mr_n60700128)
print v(xbgr.mr_n60700240)
print v(xbgr.mr_n60700560)
print v(xbgr.mr_n60700672)
print v(xbgr.mr_n60700992)
print v(xbgr.mr_n60701104)
print v(xbgr.mr_n60701424)
print v(xbgr.mr_n60701536)
print v(xbgr.mr_n60701856)
print v(xbgr.mr_n60701968)
print v(xbgr.mr_n60702288)
print v(xbgr.mr_n60702400)
print v(xbgr.mr_n60702720)
print v(xbgr.mr_n60702832)
print v(xbgr.mr_n60703152)
print v(xbgr.mr_n60703264)
print v(xbgr.mr_n60703584)
print v(xbgr.mr_n60703696)
print v(xbgr.mr_n60704016)
print v(xbgr.mr_n60704128)
print v(xbgr.mr_n60704448)
print v(xbgr.mr_n60704560)
print v(xbgr.mr_n60704880)
print v(xbgr.mr_n60704992)
print v(xbgr.mr_n60705312)
print v(xbgr.mr_n60705424)
print v(xbgr.mr_n60705744)
print v(xbgr.mr_n60705856)
print v(xbgr.mr_n60706176)
print v(xbgr.mr_n60706288)
print v(xbgr.mr_n60706608)
print v(xbgr.mr_n60706720)
print v(xbgr.mr_n60707040)
print v(xbgr.mr_n60707152)
print v(xbgr.mr_n60707472)
print v(xbgr.mr_n60707584)
print v(xbgr.mr_n60707904)
print v(xbgr.mr_n60708016)
print v(xbgr.mr_n60708336)
print v(xbgr.mr_n60708448)
print v(xbgr.mr_n60708768)
print v(xbgr.mr_n60708880)
print v(xbgr.mr_n60709200)
print v(xbgr.mr_n60709312)
print v(xbgr.mr_n60709632)
print v(xbgr.mr_n60709744)
print v(xbgr.mr_n60710064)
print v(xbgr.mr_n60710176)
print v(xbgr.mr_n60710496)
print v(xbgr.mr_n60710608)
print v(xbgr.mr_n60710928)
print v(xbgr.mr_n60711040)
print v(xbgr.mr_n60711360)
print v(xbgr.mr_n60711472)
print v(xbgr.mr_n60711792)
print v(xbgr.mr_n60711904)
print v(xbgr.mr_n60712224)
print v(xbgr.mr_n60712336)
print v(xbgr.mr_n60712656)
print v(xbgr.mr_n60712768)
print v(xbgr.mr_n60713088)
print v(xbgr.mr_n60713200)
print v(xbgr.mr_n60713520)
print v(xbgr.mr_n60713632)
print v(xbgr.mr_n60713952)
print v(xbgr.mr_n60714064)
print v(xbgr.mr_n60714384)
print v(xbgr.mr_n60714496)
print v(xbgr.mr_n60714816)
print v(xbgr.mr_n60714928)
print v(xbgr.mr_n60715248)
print v(xbgr.mr_n60715360)
print v(xbgr.mr_n60715680)
print v(xbgr.mr_n60715792)
print v(xbgr.mr_n60716112)
print v(xbgr.mr_n60716224)
print v(xbgr.mr_n60716544)
print v(xbgr.mr_n60716656)
print v(xbgr.mr_n60716976)
print v(xbgr.mr_n60717088)
print v(xbgr.mr_n60717408)
print v(xbgr.mr_n60717520)
print v(xbgr.mr_n60717840)
print v(xbgr.mr_n60717952)
print v(xbgr.mr_n60718272)
print v(xbgr.mr_n60718384)
print v(xbgr.mr_n60718704)
print v(xbgr.mr_n60718816)
print v(xbgr.mr_n60719248)
print v(xbgr.mr_n60719568)
print v(xbgr.mr_n60719680)
print v(xbgr.mr_n60720000)
print v(xbgr.mr_n60720112)
print v(xbgr.mr_n60720432)
print v(xbgr.mr_n60720544)
print v(xbgr.mr_n60720976)
print v(xbgr.mr_n60721296)
print v(xbgr.mr_n60721408)
print v(xbgr.mr_n60721728)
print v(xbgr.mr_n60721840)
print v(xbgr.mr_n60722160)
print v(xbgr.mr_n60722272)
print v(xbgr.mr_n60722704)
print v(xbgr.mr_n60723024)
print v(xbgr.mr_n60723136)
print v(xbgr.mr_n60723456)
print v(xbgr.mr_n60723568)
print v(xbgr.mr_n60723888)
print v(xbgr.mr_n60724000)
print v(xbgr.mr_n60724432)
print v(xbgr.mr_n60724752)
print v(xbgr.mr_n60724864)
print v(xbgr.mr_n60725184)
print v(xbgr.mr_n60725296)
print v(xbgr.mr_n60725616)
print v(xbgr.mr_n60725728)
print v(xbgr.mr_n60726160)
print v(xbgr.mr_n60726480)
print v(xbgr.mr_n60726592)
print v(xbgr.mr_n60726912)
print v(xbgr.mr_n60727024)
print v(xbgr.mr_n60727344)
print v(xbgr.mr_n60727456)
print v(xbgr.mr_n60727888)
print v(xbgr.mr_n60728208)
print v(xbgr.mr_n60728320)
print v(xbgr.mr_n60728640)
print v(xbgr.mr_n60728752)
print v(xbgr.mr_n60729072)
print v(xbgr.mr_n60729184)
print v(xbgr.mr_n60729616)
print v(xbgr.mr_n60729936)
print v(xbgr.mr_n60730048)
print v(xbgr.mr_n60730368)
print v(xbgr.mr_n60730480)
print v(xbgr.mr_n60730800)
print v(xbgr.mr_n60730912)
print v(xbgr.mr_n60731344)
print v(xbgr.mr_n60731664)
print v(xbgr.mr_n60731776)
print v(xbgr.mr_n60732096)
print v(xbgr.mr_n60732208)
print v(xbgr.mr_n60732528)
print v(xbgr.mr_n60732640)
print v(xbgr.mr_n60732960)
print v(xbgr.mr_n60733072)
print v(xbgr.mr_n60733392)
print v(xbgr.mr_n60733504)
print v(xbgr.mr_n60733824)
print v(xbgr.mr_n60733936)
print v(xbgr.mr_n60734256)
print v(xbgr.mr_n60734368)
print v(xbgr.mr_n60734688)
print v(xbgr.mr_n60734800)
print v(xbgr.mr_n60735120)
print v(xbgr.mr_n60735232)
print v(xbgr.mr_n60735552)
print v(xbgr.mr_n60735664)
print v(xbgr.mr_n60735984)
print v(xbgr.mr_n60736096)
print v(xbgr.mr_n60736416)
print v(xbgr.mr_n60736528)
print v(xbgr.mr_n60736848)
print v(xbgr.mr_n60736960)
print v(xbgr.mr_n60737280)
print v(xbgr.mr_n60737392)
print v(xbgr.mr_n60737712)
print v(xbgr.mr_n60737824)
print v(xbgr.mr_n60738144)
print v(xbgr.mr_n60738256)
print v(xbgr.mr_n60738576)
print v(xbgr.mr_n60738688)
print v(xbgr.mr_n60739008)
print v(xbgr.mr_n60739120)
print v(xbgr.mr_n60739440)
print v(xbgr.mr_n60739552)
print v(xbgr.mr_n60739872)
print v(xbgr.mr_n60739984)
print v(xbgr.mr_n60740304)
print v(xbgr.mr_n60740416)
print v(xbgr.mr_n60740736)
print v(xbgr.mr_n60740848)
print v(xbgr.mr_n60741168)
print v(xbgr.mr_n60741280)
print v(xbgr.mr_n60741600)
print v(xbgr.mr_n60741712)
print v(xbgr.mr_n60742032)
print v(xbgr.mr_n60742144)
print v(xbgr.mr_n60742464)
print v(xbgr.mr_n60742576)
print v(xbgr.mr_n60742896)
print v(xbgr.mr_n60743008)
print v(xbgr.mr_n60743328)
print v(xbgr.mr_n60743440)
print v(xbgr.mr_n60743760)
print v(xbgr.mr_n60743872)
print v(xbgr.mr_n60744192)
print v(xbgr.mr_n60744304)
print v(xbgr.mr_n60744624)
print v(xbgr.mr_n60744736)
print v(xbgr.mr_n60745056)
print v(xbgr.mr_n60745168)
print v(xbgr.mr_n60745488)
print v(xbgr.mr_n60745600)
print v(xbgr.mr_n60745920)
print v(xbgr.mr_n60746032)
print v(xbgr.mr_n60746352)
print v(xbgr.mr_n60746464)
print v(xbgr.mr_n60746784)
print v(xbgr.mr_n60746896)
print v(xbgr.mr_n60747216)
print v(xbgr.mr_n60747328)
print v(xbgr.mr_n60747648)
print v(xbgr.mr_n60747760)
print v(xbgr.mr_n60748080)
print v(xbgr.mr_n60748192)
print v(xbgr.mr_n60748512)
print v(xbgr.mr_n60748624)
print v(xbgr.mr_n60748944)
print v(xbgr.mr_n60749056)
print v(xbgr.mr_n60749376)
print v(xbgr.mr_n60749488)
print v(xbgr.mr_n60749808)
print v(xbgr.mr_n60749920)
print v(xbgr.mr_n60750240)
print v(xbgr.mr_n60750352)
print v(xbgr.mr_n60750672)
print v(xbgr.mr_n60750784)
print v(xbgr.mr_n60751104)
print v(xbgr.mr_n60751216)
print v(xbgr.mr_n60751536)
print v(xbgr.mr_n60751648)
print v(xbgr.mr_n60751968)
print v(xbgr.mr_n60752080)
print v(xbgr.mr_n60752400)
print v(xbgr.mr_n60752512)
print v(xbgr.mr_n60752832)
print v(xbgr.mr_n60752944)
print v(xbgr.mr_n60753264)
print v(xbgr.mr_n60753376)
print v(xbgr.mr_n60753696)
print v(xbgr.mr_n60753808)
print v(xbgr.mr_n60754128)
print v(xbgr.mr_n60754240)
print v(xbgr.mr_n60754560)
print v(xbgr.mr_n60754672)
print v(xbgr.mr_n60754992)
print v(xbgr.mr_n60755104)
print v(xbgr.mr_n60755424)
print v(xbgr.mr_n60755536)
print v(xbgr.mr_n60755856)
print v(xbgr.mr_n60755968)
print v(xbgr.mr_n60756288)
print v(xbgr.mr_n60756400)
print v(xbgr.mr_n60756720)
print v(xbgr.mr_n60756832)
print v(xbgr.mr_n60757152)
print v(xbgr.mr_n60757264)
print v(xbgr.mr_n60757584)
print v(xbgr.mr_n60757696)
print v(xbgr.mr_n60758016)
print v(xbgr.mr_n60758128)
print v(xbgr.mr_n60758448)
print v(xbgr.mr_n60758560)
print v(xbgr.mr_n60758880)
print v(xbgr.mr_n60758992)
print v(xbgr.mr_n60759312)
print v(xbgr.mr_n60759424)
print v(xbgr.mr_n60759744)
print v(xbgr.mr_n60759856)
print v(xbgr.mr_n60760176)
print v(xbgr.mr_n60760288)
print v(xbgr.mr_n60760608)
print v(xbgr.mr_n60760720)
print v(xbgr.mr_n60761040)
print v(xbgr.mr_n60761152)
print v(xbgr.mr_n60761584)
print v(xbgr.mr_n60761904)
print v(xbgr.mr_n60762016)
print v(xbgr.mr_n60762336)
print v(xbgr.mr_n60762448)
print v(xbgr.mr_n60762768)
print v(xbgr.mr_n60762880)
print v(xbgr.mr_n60763312)
print v(xbgr.mr_n60763632)
print v(xbgr.mr_n60763744)
print v(xbgr.mr_n60764064)
print v(xbgr.mr_n60764176)
print v(xbgr.mr_n60764496)
print v(xbgr.mr_n60764608)
print v(xbgr.mr_n60765040)
print v(xbgr.mr_n60765360)
print v(xbgr.mr_n60765472)
print v(xbgr.mr_n60765792)
print v(xbgr.mr_n60765904)
print v(xbgr.mr_n60766224)
print v(xbgr.mr_n60766336)
print v(xbgr.mr_n60766656)
print v(xbgr.mr_n60766768)
print v(xbgr.mr_n60767088)
print v(xbgr.mr_n60767200)
print v(xbgr.mr_n60767520)
print v(xbgr.mr_n60767632)
print v(xbgr.mr_n60767952)
print v(xbgr.mr_n60768064)
print v(xbgr.mr_n60768384)
print v(xbgr.mr_n60768496)
print v(xbgr.mr_n60768816)
print v(xbgr.mr_n60768928)
print v(xbgr.mr_n60769360)
print v(xbgr.mr_n60769680)
print v(xbgr.mr_n60769792)
print v(xbgr.mr_n60770224)
print v(xbgr.mr_n60770544)
print v(xbgr.mr_n60770656)
print v(xbgr.mr_n60771088)
print v(xbgr.mr_n60771408)
print v(xbgr.mr_n60771520)
print v(xbgr.mr_n60771840)
print v(xbgr.mr_n60771952)
print v(xbgr.mr_n60772272)
print v(xbgr.mr_n60772384)
print v(xbgr.mr_n60772816)
print v(xbgr.mr_n60773136)
print v(xbgr.mr_n60773248)
print v(xbgr.mr_n60773568)
print v(xbgr.mr_n60773680)
print v(xbgr.mr_n60774000)
print v(xbgr.mr_n60774112)
print v(xbgr.mr_n60774432)
print v(xbgr.mr_n60774544)
print v(xbgr.mr_n60774864)
print v(xbgr.mr_n60774976)
print v(xbgr.mr_n60775408)
print v(xbgr.mr_n60775728)
print v(xbgr.mr_n60775840)
print v(xbgr.mr_n60776160)
print v(xbgr.mr_n60776272)
print v(xbgr.mr_n60776592)
print v(xbgr.mr_n60776704)
print v(xbgr.mr_n60777024)
print v(xbgr.mr_n60777136)
print v(xbgr.mr_n60777456)
print v(xbgr.mr_n60777568)
print v(xbgr.mr_n60777888)
print v(xbgr.mr_n60778000)
print v(xbgr.mr_n60778320)
print v(xbgr.mr_n60778432)
print v(xbgr.mr_n60778752)
print v(xbgr.mr_n60778864)
print v(xbgr.mr_n60779184)
print v(xbgr.mr_n60779296)
print v(xbgr.mr_n60779616)
print v(xbgr.mr_n60779728)
print v(xbgr.mr_n60780048)
print v(xbgr.mr_n60780160)
print v(xbgr.mr_n60780480)
print v(xbgr.mr_n60780592)
print v(xbgr.mr_n60780912)
print v(xbgr.mr_n60781024)
print v(xbgr.mr_n60781344)
print v(xbgr.mr_n60781456)
print v(xbgr.mr_n60781776)
print v(xbgr.mr_n60781888)
print v(xbgr.mr_n60782208)
print v(xbgr.mr_n60782320)
print v(xbgr.mr_n60782640)
print v(xbgr.mr_n60782752)
print v(xbgr.mr_n60783072)
print v(xbgr.mr_n60783184)
print v(xbgr.mr_n60783504)
print v(xbgr.mr_n60783616)
print v(xbgr.mr_n60783936)
print v(xbgr.mr_n60784048)
print v(xbgr.mr_n60784368)
print v(xbgr.mr_n60784480)
print v(xbgr.mr_n60784800)
print v(xbgr.mr_n60784912)
print v(xbgr.mr_n60785232)
print v(xbgr.mr_n60785344)
print v(xbgr.mr_n60785664)
print v(xbgr.mr_n60785776)
print v(xbgr.mr_n60786096)
print v(xbgr.mr_n60786208)
print v(xbgr.mr_n60786528)
print v(xbgr.mr_n60786640)
print v(xbgr.mr_n60786960)
print v(xbgr.mr_n60787072)
print v(xbgr.mr_n60787392)
print v(xbgr.mr_n60787504)
print v(xbgr.mr_n60787824)
print v(xbgr.mr_n60787936)
print v(xbgr.mr_n60788256)
print v(xbgr.mr_n60788368)
print v(xbgr.mr_n60788688)
print v(xbgr.mr_n60788800)
print v(xbgr.mr_n60789120)
print v(xbgr.mr_n60789232)
print v(xbgr.mr_n60789552)
print v(xbgr.mr_n60789664)
print v(xbgr.mr_n60789984)
print v(xbgr.mr_n60790096)
print v(xbgr.mr_n60790416)
print v(xbgr.mr_n60790528)
print v(xbgr.mr_n60790848)
print v(xbgr.mr_n60790960)
print v(xbgr.mr_n60791280)
print v(xbgr.mr_n60791392)
print v(xbgr.mr_n60791712)
print v(xbgr.mr_n60791824)
print v(xbgr.mr_n60792144)
print v(xbgr.mr_n60792256)
print v(xbgr.mr_n60792576)
print v(xbgr.mr_n60792688)
print v(xbgr.mr_n60793008)
print v(xbgr.mr_n60793120)
print v(xbgr.mr_n60793440)
print v(xbgr.mr_n60793552)
print v(xbgr.mr_n60793872)
print v(xbgr.mr_n60793984)
print v(xbgr.mr_n60794304)
print v(xbgr.mr_n60794416)
print v(xbgr.mr_n60794736)
print v(xbgr.mr_n60794848)
print v(xbgr.mr_n60795168)
print v(xbgr.mr_n60795280)
print v(xbgr.mr_n60795600)
print v(xbgr.mr_n60795712)
print v(xbgr.mr_n60796032)
print v(xbgr.mr_n60796144)
print v(xbgr.mr_n60796464)
print v(xbgr.mr_n60796576)
print v(xbgr.mr_n60796896)
print v(xbgr.mr_n60797008)
print v(xbgr.mr_n60797328)
print v(xbgr.mr_n60797440)
print v(xbgr.mr_n60797760)
print v(xbgr.mr_n60797872)
print v(xbgr.mr_n60798192)
print v(xbgr.mr_n60798304)
print v(xbgr.mr_n60798624)
print v(xbgr.mr_n60798736)
print v(xbgr.mr_n60799056)
print v(xbgr.mr_n60799168)
print v(xbgr.mr_n60799488)
print v(xbgr.mr_n60799600)
print v(xbgr.mr_n60799920)
print v(xbgr.mr_n60800032)
print v(xbgr.mr_n60800352)
print v(xbgr.mr_n60800464)
print v(xbgr.mr_n60800784)
print v(xbgr.mr_n60800896)
print v(xbgr.mr_n60801216)
print v(xbgr.mr_n60801328)
print v(xbgr.mr_n60801648)
print v(xbgr.mr_n60801760)
print v(xbgr.mr_n60802080)
print v(xbgr.mr_n60802192)
print v(xbgr.mr_n60802512)
print v(xbgr.mr_n60802624)
print v(xbgr.mr_n60802944)
print v(xbgr.mr_n60803056)
print v(xbgr.mr_n60803376)
print v(xbgr.mr_n60803488)
print v(xbgr.mr_n60803808)
print v(xbgr.mr_n60803920)
print v(xbgr.mr_n60804240)
print v(xbgr.mr_n60804352)
print v(xbgr.mr_n60804672)
print v(xbgr.mr_n60804784)
print v(xbgr.mr_n60805104)
print v(xbgr.mr_n60805216)
print v(xbgr.mr_n60805536)
print v(xbgr.mr_n60805648)
print v(xbgr.mr_n60805968)
print v(xbgr.mr_n60806080)
print v(xbgr.mr_n60806400)
print v(xbgr.mr_n60806512)
print v(xbgr.mr_n60806832)
print v(xbgr.mr_n60806944)
print v(xbgr.mr_n60807264)
print v(xbgr.mr_n60807376)
print v(xbgr.mr_n60807696)
print v(xbgr.mr_n60807808)
print v(xbgr.mr_n60808128)
print v(xbgr.mr_n60808240)
print v(xbgr.mr_n60808560)
print v(xbgr.mr_n60808672)
print v(xbgr.mr_n60808992)
print v(xbgr.mr_n60809104)
print v(xbgr.mr_n60809424)
print v(xbgr.mr_n60809536)
print v(xbgr.mr_n60809856)
print v(xbgr.mr_n60809968)
print v(xbgr.mr_n60810288)
print v(xbgr.mr_n60810400)
print v(xbgr.mr_n60810720)
print v(xbgr.mr_n60810832)
print v(xbgr.mr_n60811152)
print v(xbgr.mr_n60811264)
print v(xbgr.mr_n60811584)
print v(xbgr.mr_n60811696)
print v(xbgr.mr_n60812016)
print v(xbgr.mr_n60812128)
print v(xbgr.mr_n60812448)
print v(xbgr.mr_n60812560)
print v(xbgr.mr_n60812880)
print v(xbgr.mr_n60812992)
print v(xbgr.mr_n60813312)
print v(xbgr.mr_n60813424)
print v(xbgr.mr_n60813744)
print v(xbgr.mr_n60813856)
print v(xbgr.mr_n60814176)
print v(xbgr.mr_n60814288)
print v(xbgr.mr_n60814608)
print v(xbgr.mr_n60814720)
print v(xbgr.mr_n60815040)
print v(xbgr.mr_n60815152)
print v(xbgr.mr_n60815472)
print v(xbgr.mr_n60815584)
print v(xbgr.mr_n60815904)
print v(xbgr.mr_n60816016)
print v(xbgr.mr_n60816336)
print v(xbgr.mr_n60816448)
print v(xbgr.mr_n60816768)
print v(xbgr.mr_n60816880)
print v(xbgr.mr_n60817200)
print v(xbgr.mr_n60817312)
print v(xbgr.mr_n60817632)
print v(xbgr.mr_n60817744)
print v(xbgr.mr_n60818064)
print v(xbgr.mr_n60818176)
print v(xbgr.mr_n60818496)
print v(xbgr.mr_n60818608)
print v(xbgr.mr_n60818928)
print v(xbgr.mr_n60819040)
print v(xbgr.mr_n60819360)
print v(xbgr.mr_n60819472)
print v(xbgr.mr_n60819792)
print v(xbgr.mr_n60819904)
print v(xbgr.mr_n60820224)
print v(xbgr.mr_n60820336)
print v(xbgr.mr_n60820656)
print v(xbgr.mr_n60820768)
print v(xbgr.mr_n60821088)
print v(xbgr.mr_n60821200)
print v(xbgr.mr_n60821520)
print v(xbgr.mr_n60821632)
print v(xbgr.mr_n60821952)
print v(xbgr.mr_n60822064)
print v(xbgr.mr_n60822384)
print v(xbgr.mr_n60822496)
print v(xbgr.mr_n60822816)
print v(xbgr.mr_n60822928)
print v(xbgr.mr_n60823248)
print v(xbgr.mr_n60823360)
print v(xbgr.mr_n60823680)
print v(xbgr.mr_n60823792)
print v(xbgr.mr_n60824112)
print v(xbgr.mr_n60824224)
print v(xbgr.mr_n60824544)
print v(xbgr.mr_n60824656)
print v(xbgr.mr_n60824976)
print v(xbgr.mr_n60825088)
print v(xbgr.mr_n60825408)
print v(xbgr.mr_n60825520)
print v(xbgr.mr_n60825840)
print v(xbgr.mr_n60825952)
print v(xbgr.mr_n60826272)
print v(xbgr.mr_n60826384)
print v(xbgr.mr_n60826704)
print v(xbgr.mr_n60826816)
print v(xbgr.mr_n60827136)
print v(xbgr.mr_n60827248)
print v(xbgr.mr_n60827568)
print v(xbgr.mr_n60827680)
print v(xbgr.mr_n60828000)
print v(xbgr.mr_n60828112)
print v(xbgr.mr_n60828432)
print v(xbgr.mr_n60828544)
print v(xbgr.mr_n60828864)
print v(xbgr.mr_n60828976)
print v(xbgr.mr_n60829296)
print v(xbgr.mr_n60829408)
print v(xbgr.mr_n60829728)
print v(xbgr.mr_n60829840)
print v(xbgr.mr_n60830160)
print v(xbgr.mr_n60830272)
print v(xbgr.mr_n60830592)
print v(xbgr.mr_n60830704)
print v(xbgr.mr_n60831024)
print v(xbgr.mr_n60831136)
print v(xbgr.mr_n60831456)
print v(xbgr.mr_n60831568)
print v(xbgr.mr_n60831888)
print v(xbgr.mr_n60832000)
print v(xbgr.mr_n60832320)
print v(xbgr.mr_n60832432)
print v(xbgr.mr_n60832752)
print v(xbgr.mr_n60832864)
print v(xbgr.mr_n60833184)
print v(xbgr.mr_n60833296)
print v(xbgr.mr_n60833616)
print v(xbgr.mr_n60833728)
print v(xbgr.mr_n60834048)
print v(xbgr.mr_n60834160)
print v(xbgr.mr_n60834480)
print v(xbgr.mr_n60834592)
print v(xbgr.mr_n60834912)
print v(xbgr.mr_n60835024)
print v(xbgr.mr_n60835344)
print v(xbgr.mr_n60835456)
print v(xbgr.mr_n60835776)
print v(xbgr.mr_n60835888)
print v(xbgr.mr_n60836208)
print v(xbgr.mr_n60836320)
print v(xbgr.mr_n60836640)
print v(xbgr.mr_n60836752)
print v(xbgr.mr_n60837072)
print v(xbgr.mr_n60837184)
print v(xbgr.mr_n60837504)
print v(xbgr.mr_n60837616)
print v(xbgr.mr_n60837936)
print v(xbgr.mr_n60838048)
print v(xbgr.mr_n60838368)
print v(xbgr.mr_n60838480)
print v(xbgr.mr_n60838800)
print v(xbgr.mr_n60838912)
print v(xbgr.mr_n60839232)
print v(xbgr.mr_n60839344)
print v(xbgr.mr_n60839664)
print v(xbgr.mr_n60839776)
print v(xbgr.mr_n60840096)
print v(xbgr.mr_n60840208)
print v(xbgr.mr_n60840528)
print v(xbgr.mr_n60840640)
print v(xbgr.mr_n60840960)
print v(xbgr.mr_n60841072)
print v(xbgr.mr_n60841392)
print v(xbgr.mr_n60841504)
print v(xbgr.mr_n60841824)
print v(xbgr.mr_n60841936)
print v(xbgr.mr_n60842256)
print v(xbgr.mr_n60842368)
print v(xbgr.mr_n60842688)
print v(xbgr.mr_n60842800)
print v(xbgr.mr_n60843120)
print v(xbgr.mr_n60843232)
print v(xbgr.mr_n60843552)
print v(xbgr.mr_n60843664)
print v(xbgr.mr_n60843984)
print v(xbgr.mr_n60844096)
print v(xbgr.mr_n60844416)
print v(xbgr.mr_n60844528)
print v(xbgr.mr_n60844848)
print v(xbgr.mr_n60844960)
print v(xbgr.mr_n60845280)
print v(xbgr.mr_n60845392)
print v(xbgr.mr_n60845712)
print v(xbgr.mr_n60845824)
print v(xbgr.mr_n60846144)
print v(xbgr.mr_n60846256)
print v(xbgr.mr_n60846576)
print v(xbgr.mr_n60846688)
print v(xbgr.mr_n60847008)
print v(xbgr.mr_n60847120)
print v(xbgr.mr_n60847440)
print v(xbgr.mr_n60847552)
print v(xbgr.mr_n60847872)
print v(xbgr.mr_n60847984)
print v(xbgr.mr_n60848304)
print v(xbgr.mr_n60848416)
print v(xbgr.mr_n60848736)
print v(xbgr.mr_n60848848)
print v(xbgr.mr_n60849168)
print v(xbgr.mr_n60849280)
print v(xbgr.mr_n60849600)
print v(xbgr.mr_n60849712)
print v(xbgr.mr_n60850032)
print v(xbgr.mr_n60850144)
print v(xbgr.mr_n60850576)
print v(xbgr.mr_n60850896)
print v(xbgr.mr_n60851008)
print v(xbgr.mr_n60851440)
print v(xbgr.mr_n60851760)
print v(xbgr.mr_n60851872)
print v(xbgr.mr_n60852304)
print v(xbgr.mr_n60852624)
print v(xbgr.mr_n60853488)
print v(xbgr.mr_n60853600)
print v(xbgr.mr_n60854032)
print v(xbgr.mr_n60854352)
print v(xbgr.mr_n60854464)
print v(xbgr.mr_n60854784)
print v(xbgr.mr_n60854896)
print v(xbgr.mr_n60855216)
print v(xbgr.mr_n60855328)
print v(xbgr.mr_n60855648)
print v(xbgr.mr_n60855760)
print v(xbgr.mr_n60856080)
print v(xbgr.mr_n60856192)
print v(xbgr.mr_n60856512)
print v(xbgr.mr_n60856624)
print v(xbgr.mr_n60856944)
print v(xbgr.mr_n60857056)
print v(xbgr.mr_n60857376)
print v(xbgr.mr_n60857488)
print v(xbgr.mr_n60857808)
print v(xbgr.mr_n60858672)
print v(xbgr.mr_n60859536)
print v(xbgr.mr_n60859648)
print v(xbgr.mr_n60859968)
print v(xbgr.mr_n60860080)
print v(xbgr.mr_n60860400)
print v(xbgr.mr_n60861264)
print v(xbgr.mr_n60861376)
print v(xbgr.mr_n60861696)
print v(xbgr.mr_n60861808)
print v(xbgr.mr_n60862128)
print v(xbgr.mr_n60862240)
print v(xbgr.mr_n60862560)
print v(xbgr.mr_n60862672)
print v(xbgr.mr_n60862992)
print v(xbgr.mr_n60863104)
print v(xbgr.mr_n60863424)
print v(xbgr.mr_n60863536)
print v(xbgr.mr_n60863856)
print v(xbgr.mr_n60863968)
print v(xbgr.mr_n60864288)
print v(xbgr.mr_n60864400)
print v(xbgr.mr_n60864720)
print v(xbgr.mr_n60864832)
print v(xbgr.mr_n60865152)
print v(xbgr.mr_n60865264)
print v(xbgr.mr_n60865584)
print v(xbgr.mr_n60865696)
print v(xbgr.mr_n60866016)
print v(xbgr.mr_n60866128)
print v(xbgr.mr_n60866448)
print v(xbgr.mr_n60866560)
print v(xbgr.mr_n60866880)
print v(xbgr.mr_n60866992)
print v(xbgr.mr_n60867312)
print v(xbgr.mr_n60867424)
print v(xbgr.mr_n60867744)
print v(xbgr.mr_n60867856)
print v(xbgr.mr_n60868176)
print v(xbgr.mr_n60868288)
print v(xbgr.mr_n60868608)
print v(xbgr.mr_n60868720)
print v(xbgr.mr_n60869040)
print v(xbgr.mr_n60869152)
print v(xbgr.mr_n60869472)
print v(xbgr.mr_n60869584)
print v(xbgr.mr_n60869904)
print v(xbgr.mr_n60870016)
print v(xbgr.mr_n60870336)
print v(xbgr.mr_n60870448)
print v(xbgr.mr_n60870768)
print v(xbgr.mr_n60870880)
print v(xbgr.mr_n60871200)
print v(xbgr.mr_n60871312)
print v(xbgr.mr_n60871632)
print v(xbgr.mr_n60871744)
print v(xbgr.mr_n60872176)
print v(xbgr.mr_n60872496)
print v(xbgr.mr_n60872608)
print v(xbgr.mr_n60872928)
print v(xbgr.mr_n60873040)
print v(xbgr.mr_n60873360)
print v(xbgr.mr_n60873472)
print v(xbgr.mr_n60873792)
print v(xbgr.mr_n60873904)
print v(xbgr.mr_n60874224)
print v(xbgr.mr_n60874336)
print v(xbgr.mr_n60874656)
print v(xbgr.mr_n60874768)
print v(xbgr.mr_n60875088)
print v(xbgr.mr_n60875200)
print v(xbgr.mr_n60875520)
print v(xbgr.mr_n60875632)
print v(xbgr.mr_n60875952)
print v(xbgr.mr_n60876064)
print v(xbgr.mr_n60876384)
print v(xbgr.mr_n60876496)
print v(xbgr.mr_n60876816)
print v(xbgr.mr_n60876928)
print v(xbgr.mr_n60877248)
print v(xbgr.mr_n60877360)
print v(xbgr.mr_n60877680)
print v(xbgr.mr_n60877792)
print v(xbgr.mr_n60878112)
print v(xbgr.mr_n60878224)
print v(xbgr.mr_n60878544)
print v(xbgr.mr_n60879408)
print v(xbgr.mr_n60879520)
print v(xbgr.mr_n60879840)
print v(xbgr.mr_n60879952)
print v(xbgr.mr_n60880272)
print v(xbgr.mr_n60880384)
print v(xbgr.mr_n60880704)
print v(xbgr.mr_n60880816)
print v(xbgr.mr_n60881136)
print v(xbgr.mr_n60881248)
print v(xbgr.mr_n60881568)
print v(xbgr.mr_n60881680)
print v(xbgr.mr_n60882000)
print v(xbgr.mr_n60882112)
print v(xbgr.mr_n60882432)
print v(xbgr.mr_n60882544)
print v(xbgr.mr_n60882864)
print v(xbgr.mr_n60882976)
print v(xbgr.mr_n60883296)
print v(xbgr.mr_n60883408)
print v(xbgr.mr_n60883728)
print v(xbgr.mr_n60883840)
print v(xbgr.mr_n60884160)
print v(xbgr.mr_n60884272)
print v(xbgr.mr_n60884592)
print v(xbgr.mr_n60884704)
print v(xbgr.mr_n60885024)
print v(xbgr.mr_n60885136)
print v(xbgr.mr_n60885456)
print v(xbgr.mr_n60885568)
print v(xbgr.mr_n60885888)
print v(xbgr.mr_n60886000)
print v(xbgr.mr_n60886320)
print v(xbgr.mr_n60886432)
print v(xbgr.mr_n60886752)
print v(xbgr.mr_n60886864)
print v(xbgr.mr_n60887184)
print v(xbgr.mr_n60887296)
print v(xbgr.mr_n60887616)
print v(xbgr.mr_n60887728)
print v(xbgr.mr_n60888048)
print v(xbgr.mr_n60888160)
print v(xbgr.mr_n60888480)
print v(xbgr.mr_n60888592)
print v(xbgr.mr_n60888912)
print v(xbgr.mr_n60889024)
print v(xbgr.mr_n60889344)
print v(xbgr.mr_n60889456)
print v(xbgr.mr_n60889776)
print v(xbgr.mr_n60889888)
print v(xbgr.mr_n60890208)
print v(xbgr.mr_n60890320)
print v(xbgr.mr_n60890640)
print v(xbgr.mr_n60890752)
print v(xbgr.mr_n60891072)
print v(xbgr.mr_n60891184)
print v(xbgr.mr_n60891504)
print v(xbgr.mr_n60891616)
print v(xbgr.mr_n60891936)
print v(xbgr.mr_n60892048)
print v(xbgr.mr_n60892368)
print v(xbgr.mr_n60892480)
print v(xbgr.mr_n60892800)
print v(xbgr.mr_n60892912)
print v(xbgr.mr_n60893232)
print v(xbgr.mr_n60893344)
print v(xbgr.mr_n60893664)
print v(xbgr.mr_n60893776)
print v(xbgr.mr_n60894096)
print v(xbgr.mr_n60894208)
print v(xbgr.mr_n60894528)
print v(xbgr.mr_n60894640)
print v(xbgr.mr_n60894960)
print v(xbgr.mr_n60895072)
print v(xbgr.mr_n60895392)
print v(xbgr.mr_n60895504)
print v(xbgr.mr_n60895824)
print v(xbgr.mr_n60895936)
print v(xbgr.mr_n60896256)
print v(xbgr.mr_n60896368)
print v(xbgr.mr_n60896688)
print v(xbgr.mr_n60896800)
print v(xbgr.mr_n60897120)
print v(xbgr.mr_n60897232)
print v(xbgr.mr_n60897552)
print v(xbgr.mr_n60897664)
print v(xbgr.mr_n60897984)
print v(xbgr.mr_n60898096)
print v(xbgr.mr_n60898416)
print v(xbgr.mr_n60898528)
print v(xbgr.mr_n60898848)
print v(xbgr.mr_n60898960)
print v(xbgr.mr_n60899280)
print v(xbgr.mr_n60899392)
print v(xbgr.mr_n60899712)
print v(xbgr.mr_n60899824)
print v(xbgr.mr_n60900144)
print v(xbgr.mr_n60900256)
print v(xbgr.mr_n60900576)
print v(xbgr.mr_n60900688)
print v(xbgr.mr_n60901008)
print v(xbgr.mr_n60901120)
print v(xbgr.mr_n60901440)
print v(xbgr.mr_n60901552)
print v(xbgr.mr_n60901872)
print v(xbgr.mr_n60901984)
print v(xbgr.mr_n60902304)
print v(xbgr.mr_n60902416)
print v(xbgr.mr_n60902736)
print v(xbgr.mr_n60902848)
print v(xbgr.mr_n60903168)
print v(xbgr.mr_n60903280)
print v(xbgr.mr_n60903600)
print v(xbgr.mr_n60903712)
print v(xbgr.mr_n60904032)
print v(xbgr.mr_n60904144)
print v(xbgr.mr_n60904464)
print v(xbgr.mr_n60904576)
print v(xbgr.mr_n60904896)
print v(xbgr.mr_n60905008)
print v(xbgr.mr_n60905328)
print v(xbgr.mr_n60905440)
print v(xbgr.mr_n60905760)
print v(xbgr.mr_n60905872)
print v(xbgr.mr_n60906192)
print v(xbgr.mr_n60906304)
print v(xbgr.mr_n60906624)
print v(xbgr.mr_n60906736)
print v(xbgr.mr_n60907056)
print v(xbgr.mr_n60907168)
print v(xbgr.mr_n60907488)
print v(xbgr.mr_n60907600)
print v(xbgr.mr_n60907920)
print v(xbgr.mr_n60908032)
print v(xbgr.mr_n60908352)
print v(xbgr.mr_n60908464)
print v(xbgr.mr_n60908784)
print v(xbgr.mr_n60908896)
print v(xbgr.mr_n60909216)
print v(xbgr.mr_n60909328)
print v(xbgr.mr_n60909648)
print v(xbgr.mr_n60909760)
print v(xbgr.mr_n60910080)
print v(xbgr.mr_n60910192)
print v(xbgr.mr_n60910512)
print v(xbgr.mr_n60910624)
print v(xbgr.mr_n60910944)
print v(xbgr.mr_n60911056)
print v(xbgr.mr_n60911376)
print v(xbgr.mr_n60911488)
print v(xbgr.mr_n60911808)
print v(xbgr.mr_n60911920)
print v(xbgr.mr_n60912240)
print v(xbgr.mr_n60912352)
print v(xbgr.mr_n60912672)
print v(xbgr.mr_n60912784)
print v(xbgr.mr_n60913104)
print v(xbgr.mr_n60913216)
print v(xbgr.mr_n60913536)
print v(xbgr.mr_n60913648)
print v(xbgr.mr_n60913968)
print v(xbgr.mr_n60914080)
print v(xbgr.mr_n60914400)
print v(xbgr.mr_n60914512)
print v(xbgr.mr_n60914832)
print v(xbgr.mr_n60914944)
print v(xbgr.mr_n60915264)
print v(xbgr.mr_n60915376)
print v(xbgr.mr_n60915696)
print v(xbgr.mr_n60915808)
print v(xbgr.mr_n60916128)
print v(xbgr.mr_n60916240)
print v(xbgr.mr_n60916560)
print v(xbgr.mr_n60916672)
print v(xbgr.mr_n60916992)
print v(xbgr.mr_n60917104)
print v(xbgr.mr_n60917424)
print v(xbgr.mr_n60917536)
print v(xbgr.mr_n60917856)
print v(xbgr.mr_n60917968)
print v(xbgr.mr_n60918288)
print v(xbgr.mr_n60918400)
print v(xbgr.mr_n60918720)
print v(xbgr.mr_n60918832)
print v(xbgr.mr_n60919152)
print v(xbgr.mr_n60919264)
print v(xbgr.mr_n60919584)
print v(xbgr.mr_n60919696)
print v(xbgr.mr_n60920016)
print v(xbgr.mr_n60920128)
print v(xbgr.mr_n60920448)
print v(xbgr.mr_n60920560)
print v(xbgr.mr_n60920880)
print v(xbgr.mr_n60920992)
print v(xbgr.mr_n60921312)
print v(xbgr.mr_n60921424)
print v(xbgr.mr_n60921744)
print v(xbgr.mr_n60921856)
print v(xbgr.mr_n60922176)
print v(xbgr.mr_n60922288)
print v(xbgr.mr_n60922608)
print v(xbgr.mr_n60922720)
print v(xbgr.mr_n60923040)
print v(xbgr.mr_n60923152)
print v(xbgr.mr_n60923472)
print v(xbgr.mr_n60923584)
print v(xbgr.mr_n60923904)
print v(xbgr.mr_n60924016)
print v(xbgr.mr_n60924336)
print v(xbgr.mr_n60924448)
print v(xbgr.mr_n60924768)
print v(xbgr.mr_n60924880)
print v(xbgr.mr_n60925200)
print v(xbgr.mr_n60925312)
print v(xbgr.mr_n60925632)
print v(xbgr.mr_n60925744)
print v(xbgr.mr_n60926064)
print v(xbgr.mr_n60926176)
print v(xbgr.mr_n60926496)
print v(xbgr.mr_n60926608)
print v(xbgr.mr_n60926928)
print v(xbgr.mr_n60927040)
print v(xbgr.mr_n60927360)
print v(xbgr.mr_n60927472)
print v(xbgr.mr_n60927792)
print v(xbgr.mr_n60927904)
print v(xbgr.mr_n60928224)
print v(xbgr.mr_n60928336)
print v(xbgr.mr_n60928656)
print v(xbgr.mr_n60928768)
print v(xbgr.mr_n60929088)
print v(xbgr.mr_n60929200)
print v(xbgr.mr_n60929520)
print v(xbgr.mr_n60929632)
print v(xbgr.mr_n60929952)
print v(xbgr.mr_n60930064)
print v(xbgr.mr_n60930384)
print v(xbgr.mr_n60930496)
print v(xbgr.mr_n60930816)
print v(xbgr.mr_n60930928)
print v(xbgr.mr_n60931248)
print v(xbgr.mr_n60931360)
print v(xbgr.mr_n60931680)
print v(xbgr.mr_n60931792)
print v(xbgr.mr_n60932112)
print v(xbgr.mr_n60932224)
print v(xbgr.mr_n60932544)
print v(xbgr.mr_n60932656)
print v(xbgr.mr_n60932976)
print v(xbgr.mr_n60933088)
print v(xbgr.mr_n60933408)
print v(xbgr.mr_n60933520)
print v(xbgr.mr_n60933840)
print v(xbgr.mr_n60933952)
print v(xbgr.mr_n60934272)
print v(xbgr.mr_n60934384)
print v(xbgr.mr_n60934704)
print v(xbgr.mr_n60934816)
print v(xbgr.mr_n60935136)
print v(xbgr.mr_n60935248)
print v(xbgr.mr_n60935568)
print v(xbgr.mr_n60935680)
print v(xbgr.mr_n60936000)
print v(xbgr.mr_n60936112)
print v(xbgr.mr_n60936432)
print v(xbgr.mr_n60936544)
print v(xbgr.mr_n60936864)
print v(xbgr.mr_n60936976)
print v(xbgr.mr_n60937296)
print v(xbgr.mr_n60937408)
print v(xbgr.mr_n60937728)
print v(xbgr.mr_n60937840)
print v(xbgr.mr_n60938160)
print v(xbgr.mr_n60938272)
print v(xbgr.mr_n60938592)
print v(xbgr.mr_n60938704)
print v(xbgr.mr_n60939024)
print v(xbgr.mr_n60939136)
print v(xbgr.mr_n60939456)
print v(xbgr.mr_n60939568)
print v(xbgr.mr_n60939888)
print v(xbgr.mr_n60940000)
print v(xbgr.mr_n60940320)
print v(xbgr.mr_n60940432)
print v(xbgr.mr_n60940752)
print v(xbgr.mr_n60940864)
print v(xbgr.mr_n60941184)
print v(xbgr.mr_n60941296)
print v(xbgr.mr_n60941616)
print v(xbgr.mr_n60941728)
print v(xbgr.mr_n60942048)
print v(xbgr.mr_n60942160)
print v(xbgr.mr_n60942480)
print v(xbgr.mr_n60942592)
print v(xbgr.mr_n60942912)
print v(xbgr.mr_n60943024)
print v(xbgr.mr_n60943344)
print v(xbgr.mr_n60943456)
print v(xbgr.mr_n60943776)
print v(xbgr.mr_n60943888)
print v(xbgr.mr_n60944208)
print v(xbgr.mr_n60944320)
print v(xbgr.mr_n60944640)
print v(xbgr.mr_n60944752)
print v(xbgr.mr_n60945072)
print v(xbgr.mr_n60945184)
print v(xbgr.mr_n60945504)
print v(xbgr.mr_n60945616)
print v(xbgr.mr_n60945936)
print v(xbgr.mr_n60946048)
print v(xbgr.mr_n60946368)
print v(xbgr.mr_n60946480)
print v(xbgr.mr_n60946800)
print v(xbgr.mr_n60946912)
print v(xbgr.mr_n60947232)
print v(xbgr.mr_n60947344)
print v(xbgr.mr_n60947664)
print v(xbgr.mr_n60947776)
print v(xbgr.mr_n60948096)
print v(xbgr.mr_n60948208)
print v(xbgr.mr_n60948528)
print v(xbgr.mr_n60948640)
print v(xbgr.mr_n60948960)
print v(xbgr.mr_n60949072)
print v(xbgr.mr_n60949392)
print v(xbgr.mr_n60949504)
print v(xbgr.mr_n60949824)
print v(xbgr.mr_n60949936)
print v(xbgr.mr_n60950256)
print v(xbgr.mr_n60950368)
print v(xbgr.mr_n60950688)
print v(xbgr.mr_n60950800)
print v(xbgr.mr_n60951120)
print v(xbgr.mr_n60951232)
print v(xbgr.mr_n60951552)
print v(xbgr.mr_n60951664)
print v(xbgr.mr_n60951984)
print v(xbgr.mr_n60952096)
print v(xbgr.mr_n60952416)
print v(xbgr.mr_n60952528)
print v(xbgr.mr_n60952848)
print v(xbgr.mr_n60952960)
print v(xbgr.mr_n60953280)
print v(xbgr.mr_n60953392)
print v(xbgr.mr_n60953712)
print v(xbgr.mr_n60953824)
print v(xbgr.mr_n60954144)
print v(xbgr.mr_n60954256)
print v(xbgr.mr_n60954576)
print v(xbgr.mr_n60954688)
print v(xbgr.mr_n60955008)
print v(xbgr.mr_n60955120)
print v(xbgr.mr_n60955440)
print v(xbgr.mr_n60955552)
print v(xbgr.mr_n60955872)
print v(xbgr.mr_n60955984)
print v(xbgr.mr_n60956304)
print v(xbgr.mr_n60956416)
print v(xbgr.mr_n60956736)
print v(xbgr.mr_n60956848)
print v(xbgr.mr_n60957168)
print v(xbgr.mr_n60957280)
print v(xbgr.mr_n60957600)
print v(xbgr.mr_n60957712)
print v(xbgr.mr_n60958032)
print v(xbgr.mr_n60958144)
print v(xbgr.mr_n60958464)
print v(xbgr.mr_n60958576)
print v(xbgr.mr_n60958896)
print v(xbgr.mr_n60959008)
print v(xbgr.mr_n60959328)
print v(xbgr.mr_n60959440)
print v(xbgr.mr_n60959760)
print v(xbgr.mr_n60959872)
print v(xbgr.mr_n60960192)
print v(xbgr.mr_n60960304)
print v(xbgr.mr_n60960624)
print v(xbgr.mr_n60960736)
print v(xbgr.mr_n60961056)
print v(xbgr.mr_n60961168)
print v(xbgr.mr_n60961488)
print v(xbgr.mr_n60961600)
print v(xbgr.mr_n60961920)
print v(xbgr.mr_n60962032)
print v(xbgr.mr_n60962352)
print v(xbgr.mr_n60962464)
print v(xbgr.mr_n60962784)
print v(xbgr.mr_n60962896)
print v(xbgr.mr_n60963216)
print v(xbgr.mr_n60963328)
print v(xbgr.mr_n60963648)
print v(xbgr.mr_n60963760)
print v(xbgr.mr_n60964080)
print v(xbgr.mr_n60964192)
print v(xbgr.mr_n60964512)
print v(xbgr.mr_n60964624)
print v(xbgr.mr_n60964944)
print v(xbgr.mr_n60965056)
print v(xbgr.mr_n60965376)
print v(xbgr.mr_n60965488)
print v(xbgr.mr_n60965808)
print v(xbgr.mr_n60965920)
print v(xbgr.mr_n60966240)
print v(xbgr.mr_n60966352)
print v(xbgr.mr_n60966672)
print v(xbgr.mr_n60966784)
print v(xbgr.mr_n60967104)
print v(xbgr.mr_n60967216)
print v(xbgr.mr_n60967536)
print v(xbgr.mr_n60967648)
print v(xbgr.mr_n60967968)
print v(xbgr.mr_n60968080)
print v(xbgr.mr_n60968400)
print v(xbgr.mr_n60968512)
print v(xbgr.mr_n60968832)
print v(xbgr.mr_n60968944)
print v(xbgr.mr_n60969264)
print v(xbgr.mr_n60969376)
print v(xbgr.mr_n60969696)
print v(xbgr.mr_n60969808)
print v(xbgr.mr_n60970128)
print v(xbgr.mr_n60970240)
print v(xbgr.mr_n60970560)
print v(xbgr.mr_n60970672)
print v(xbgr.mr_n60970992)
print v(xbgr.mr_n60971104)
print v(xbgr.mr_n60971424)
print v(xbgr.mr_n60971536)
print v(xbgr.mr_n60971856)
print v(xbgr.mr_n60971968)
print v(xbgr.mr_n60972288)
print v(xbgr.mr_n60972400)
print v(xbgr.mr_n60972720)
print v(xbgr.mr_n60972832)
print v(xbgr.mr_n60973152)
print v(xbgr.mr_n60973264)
print v(xbgr.mr_n60973584)
print v(xbgr.mr_n60973696)
print v(xbgr.mr_n60974016)
print v(xbgr.mr_n60974128)
print v(xbgr.mr_n60974448)
print v(xbgr.mr_n60974560)
print v(xbgr.mr_n60974880)
print v(xbgr.mr_n60974992)
print v(xbgr.mr_n60975312)
print v(xbgr.mr_n60975424)
print v(xbgr.mr_n60975744)
print v(xbgr.mr_n60975856)
print v(xbgr.mr_n60976176)
print v(xbgr.mr_n60976288)
print v(xbgr.mr_n60976608)
print v(xbgr.mr_n60976720)
print v(xbgr.mr_n60977040)
print v(xbgr.mr_n60977152)
print v(xbgr.mr_n60977472)
print v(xbgr.mr_n60977584)
print v(xbgr.mr_n60977904)
print v(xbgr.mr_n60978016)
print v(xbgr.mr_n60978336)
print v(xbgr.mr_n60978448)
print v(xbgr.mr_n60978768)
print v(xbgr.mr_n60978880)
print v(xbgr.mr_n60979200)
print v(xbgr.mr_n60979312)
print v(xbgr.mr_n60979632)
print v(xbgr.mr_n60979744)
print v(xbgr.mr_n60980064)
print v(xbgr.mr_n60980176)
print v(xbgr.mr_n60980496)
print v(xbgr.mr_n60980608)
print v(xbgr.mr_n60980928)
print v(xbgr.mr_n60981040)
print v(xbgr.mr_n60981360)
print v(xbgr.mr_n60981472)
print v(xbgr.mr_n60981792)
print v(xbgr.mr_n60981904)
print v(xbgr.mr_n60982224)
print v(xbgr.mr_n60982336)
print v(xbgr.mr_n60982656)
print v(xbgr.mr_n60982768)
print v(xbgr.mr_n60983088)
print v(xbgr.mr_n60983200)
print v(xbgr.mr_n60983520)
print v(xbgr.mr_n60983632)
print v(xbgr.mr_n60983952)
print v(xbgr.mr_n60984064)
print v(xbgr.mr_n60984384)
print v(xbgr.mr_n60984496)
print v(xbgr.mr_n60984816)
print v(xbgr.mr_n60984928)
print v(xbgr.mr_n60985248)
print v(xbgr.mr_n60985360)
print v(xbgr.mr_n60985680)
print v(xbgr.mr_n60985792)
print v(xbgr.mr_n60986112)
print v(xbgr.mr_n60986224)
print v(xbgr.mr_n60986544)
print v(xbgr.mr_n60986656)
print v(xbgr.mr_n60986976)
print v(xbgr.mr_n60987088)
print v(xbgr.mr_n60987408)
print v(xbgr.mr_n60987520)
print v(xbgr.mr_n60987840)
print v(xbgr.mr_n60987952)
print v(xbgr.mr_n60988272)
print v(xbgr.mr_n60988384)
print v(xbgr.mr_n60988704)
print v(xbgr.mr_n60988816)
print v(xbgr.mr_n60989136)
print v(xbgr.mr_n60989248)
print v(xbgr.mr_n60989568)
print v(xbgr.mr_n60989680)
print v(xbgr.mr_n60990000)
print v(xbgr.mr_n60990112)
print v(xbgr.mr_n60990432)
print v(xbgr.mr_n60990544)
print v(xbgr.mr_n60990864)
print v(xbgr.mr_n60990976)
print v(xbgr.mr_n60991296)
print v(xbgr.mr_n60991408)
print v(xbgr.mr_n60991728)
print v(xbgr.mr_n60991840)
print v(xbgr.mr_n60992160)
print v(xbgr.mr_n60992272)
print v(xbgr.mr_n60992592)
print v(xbgr.mr_n60992704)
print v(xbgr.mr_n60993024)
print v(xbgr.mr_n60993136)
print v(xbgr.mr_n60993456)
print v(xbgr.mr_n60993568)
print v(xbgr.mr_n60993888)
print v(xbgr.mr_n60994000)
print v(xbgr.mr_n60994320)
print v(xbgr.mr_n60994432)
print v(xbgr.mr_n60994752)
print v(xbgr.mr_n60994864)
print v(xbgr.mr_n60995184)
print v(xbgr.mr_n60995296)
print v(xbgr.mr_n60995616)
print v(xbgr.mr_n60995728)
print v(xbgr.mr_n60996048)
print v(xbgr.mr_n60996160)
print v(xbgr.mr_n60996480)
print v(xbgr.mr_n60996592)
print v(xbgr.mr_n60996912)
print v(xbgr.mr_n60997024)
print v(xbgr.mr_n60997344)
print v(xbgr.mr_n60997456)
print v(xbgr.mr_n60997776)
print v(xbgr.mr_n60997888)
print v(xbgr.mr_n60998208)
print v(xbgr.mr_n60998320)
print v(xbgr.mr_n60998640)
print v(xbgr.mr_n60998752)
print v(xbgr.mr_n60999072)
print v(xbgr.mr_n60999184)
print v(xbgr.mr_n60999504)
print v(xbgr.mr_n60999616)
print v(xbgr.mr_n60999936)
print v(xbgr.mr_n61000048)
print v(xbgr.mr_n61000368)
print v(xbgr.mr_n61000480)
print v(xbgr.mr_n61000800)
print v(xbgr.mr_n61000912)
print v(xbgr.mr_n61001232)
print v(xbgr.mr_n61001344)
print v(xbgr.mr_n61001664)
print v(xbgr.mr_n61001776)
print v(xbgr.mr_n61002096)
print v(xbgr.mr_n61002208)
print v(xbgr.mr_n61002528)
print v(xbgr.mr_n61002640)
print v(xbgr.mr_n61002960)
print v(xbgr.mr_n61003072)
print v(xbgr.mr_n61003392)
print v(xbgr.mr_n61003504)
print v(xbgr.mr_n61003824)
print v(xbgr.mr_n61003936)
print v(xbgr.mr_n61004256)
print v(xbgr.mr_n61004368)
print v(xbgr.mr_n61004688)
print v(xbgr.mr_n61004800)
print v(xbgr.mr_n61005120)
print v(xbgr.mr_n61005232)
print v(xbgr.mr_n61005552)
print v(xbgr.mr_n61005664)
print v(xbgr.mr_n61005984)
print v(xbgr.mr_n61006096)
print v(xbgr.mr_n61006416)
print v(xbgr.mr_n61006528)
print v(xbgr.mr_n61006848)
print v(xbgr.mr_n61006960)
print v(xbgr.mr_n61007280)
print v(xbgr.mr_n61007392)
print v(xbgr.mr_n61007712)
print v(xbgr.mr_n61007824)
print v(xbgr.mr_n61008144)
print v(xbgr.mr_n61008256)
print v(xbgr.mr_n61008576)
print v(xbgr.mr_n61008688)
print v(xbgr.mr_n61009008)
print v(xbgr.mr_n61009120)
print v(xbgr.mr_n61009440)
print v(xbgr.mr_n61009552)
print v(xbgr.mr_n61009872)
print v(xbgr.mr_n61009984)
print v(xbgr.mr_n61010304)
print v(xbgr.mr_n61010416)
print v(xbgr.mr_n61010736)
print v(xbgr.mr_n61010848)
print v(xbgr.mr_n61011168)
print v(xbgr.mr_n61011280)
print v(xbgr.mr_n61011600)
print v(xbgr.mr_n61011712)
print v(xbgr.mr_n61012032)
print v(xbgr.mr_n61012144)
print v(xbgr.mr_n61012464)
print v(xbgr.mr_n61012576)
print v(xbgr.mr_n61012896)
print v(xbgr.mr_n61013008)
print v(xbgr.mr_n61013328)
print v(xbgr.mr_n61013440)
print v(xbgr.mr_n61013760)
print v(xbgr.mr_n61013872)
print v(xbgr.mr_n61014192)
print v(xbgr.mr_n61014304)
print v(xbgr.mr_n61014624)
print v(xbgr.mr_n61014736)
print v(xbgr.mr_n61015056)
print v(xbgr.mr_n61015168)
print v(xbgr.mr_n61015488)
print v(xbgr.mr_n61015600)
print v(xbgr.mr_n61015920)
print v(xbgr.mr_n61016032)
print v(xbgr.mr_n61016352)
print v(xbgr.mr_n61016464)
print v(xbgr.mr_n61016784)
print v(xbgr.mr_n61016896)
print v(xbgr.mr_n61017216)
print v(xbgr.mr_n61017328)
print v(xbgr.mr_n61017648)
print v(xbgr.mr_n61017760)
print v(xbgr.mr_n61018080)
print v(xbgr.mr_n61018192)
print v(xbgr.mr_n61018512)
print v(xbgr.mr_n61018624)
print v(xbgr.mr_n61018944)
print v(xbgr.mr_n61019056)
print v(xbgr.mr_n61019376)
print v(xbgr.mr_n61019488)
print v(xbgr.mr_n61019808)
print v(xbgr.mr_n61019920)
print v(xbgr.mr_n61020240)
print v(xbgr.mr_n61020352)
print v(xbgr.mr_n61020672)
print v(xbgr.mr_n61020784)
print v(xbgr.mr_n61021104)
print v(xbgr.mr_n61021216)
print v(xbgr.mr_n61021536)
print v(xbgr.mr_n61021648)
print v(xbgr.mr_n61021968)
print v(xbgr.mr_n61022080)
print v(xbgr.mr_n61022400)
print v(xbgr.mr_n61022512)
print v(xbgr.mr_n61022832)
print v(xbgr.mr_n61022944)
print v(xbgr.mr_n61023264)
print v(xbgr.mr_n61023376)
print v(xbgr.mr_n61023696)
print v(xbgr.mr_n61023808)
print v(xbgr.mr_n61024128)
print v(xbgr.mr_n61024240)
print v(xbgr.mr_n61024560)
print v(xbgr.mr_n61024672)
print v(xbgr.mr_n61024992)
print v(xbgr.mr_n61025104)
print v(xbgr.mr_n61025424)
print v(xbgr.mr_n61025536)
print v(xbgr.mr_n61025856)
print v(xbgr.mr_n61025968)
print v(xbgr.mr_n61026288)
print v(xbgr.mr_n61026400)
print v(xbgr.mr_n61026720)
print v(xbgr.mr_n61026832)
print v(xbgr.mr_n61027152)
print v(xbgr.mr_n61027264)
print v(xbgr.mr_n61027584)
print v(xbgr.mr_n61027696)
print v(xbgr.mr_n61028016)
print v(xbgr.mr_n61028128)
print v(xbgr.mr_n61028448)
print v(xbgr.mr_n61028560)
print v(xbgr.mr_n61028880)
print v(xbgr.mr_n61028992)
print v(xbgr.mr_n61029312)
print v(xbgr.mr_n61029424)
print v(xbgr.mr_n61029744)
print v(xbgr.mr_n61029856)
print v(xbgr.mr_n61030176)
print v(xbgr.mr_n61030288)
print v(xbgr.mr_n61030608)
print v(xbgr.mr_n61030720)
print v(xbgr.mr_n61031040)
print v(xbgr.mr_n61031152)
print v(xbgr.mr_n61031472)
print v(xbgr.mr_n61031584)
print v(xbgr.mr_n61031904)
print v(xbgr.mr_n61032016)
print v(xbgr.mr_n61032336)
print v(xbgr.mr_n61032448)
print v(xbgr.mr_n61032768)
print v(xbgr.mr_n61032880)
print v(xbgr.mr_n61033200)
print v(xbgr.mr_n61033312)
print v(xbgr.mr_n61033632)
print v(xbgr.mr_n61033744)
print v(xbgr.mr_n61034064)
print v(xbgr.mr_n61034176)
print v(xbgr.mr_n61034496)
print v(xbgr.mr_n61034608)
print v(xbgr.mr_n61034928)
print v(xbgr.mr_n61035040)
print v(xbgr.mr_n61035360)
print v(xbgr.mr_n61035472)
print v(xbgr.mr_n61035792)
print v(xbgr.mr_n61035904)
print v(xbgr.mr_n61036224)
print v(xbgr.mr_n61036336)
print v(xbgr.mr_n61036656)
print v(xbgr.mr_n61036768)
print v(xbgr.mr_n61037088)
print v(xbgr.mr_n61037200)
print v(xbgr.mr_n61037520)
print v(xbgr.mr_n61037632)
print v(xbgr.mr_n61037952)
print v(xbgr.mr_n61038064)
print v(xbgr.mr_n61038384)
print v(xbgr.mr_n61038496)
print v(xbgr.mr_n61038816)
print v(xbgr.mr_n61038928)
print v(xbgr.mr_n61039248)
print v(xbgr.mr_n61039360)
print v(xbgr.mr_n61039680)
print v(xbgr.mr_n61039792)
print v(xbgr.mr_n61040112)
print v(xbgr.mr_n61040224)
print v(xbgr.mr_n61040544)
print v(xbgr.mr_n61040656)
print v(xbgr.mr_n61040976)
print v(xbgr.mr_n61041088)
print v(xbgr.mr_n61041408)
print v(xbgr.mr_n61041520)
print v(xbgr.mr_n61041840)
print v(xbgr.mr_n61041952)
print v(xbgr.mr_n61042272)
print v(xbgr.mr_n61042384)
print v(xbgr.mr_n61042704)
print v(xbgr.mr_n61042816)
print v(xbgr.mr_n61043136)
print v(xbgr.mr_n61043248)
print v(xbgr.mr_n61043568)
print v(xbgr.mr_n61043680)
print v(xbgr.mr_n61044000)
print v(xbgr.mr_n61044112)
print v(xbgr.mr_n61044432)
print v(xbgr.mr_n61044544)
print v(xbgr.mr_n61044864)
print v(xbgr.mr_n61044976)
print v(xbgr.mr_n61045296)
print v(xbgr.mr_n61045408)
print v(xbgr.mr_n61045728)
print v(xbgr.mr_n61045840)
print v(xbgr.mr_n61046160)
print v(xbgr.mr_n61046272)
print v(xbgr.mr_n61046592)
print v(xbgr.mr_n61046704)
print v(xbgr.mr_n61047024)
print v(xbgr.mr_n61047136)
print v(xbgr.mr_n61047456)
print v(xbgr.mr_n61047568)
print v(xbgr.mr_n61047888)
print v(xbgr.mr_n61048000)
print v(xbgr.mr_n61048320)
print v(xbgr.mr_n61048432)
print v(xbgr.mr_n61048752)
print v(xbgr.mr_n61048864)
print v(xbgr.mr_n61049184)
print v(xbgr.mr_n61049296)
print v(xbgr.mr_n61049616)
print v(xbgr.mr_n61049728)
print v(xbgr.mr_n61050048)
print v(xbgr.mr_n61050160)
print v(xbgr.mr_n61050480)
print v(xbgr.mr_n61050592)
print v(xbgr.mr_n61051024)
print v(xbgr.mr_n61051344)
print v(xbgr.mr_n61051456)
print v(xbgr.mr_n61051776)
print v(xbgr.mr_n61051888)
print v(xbgr.mr_n61052208)
print v(xbgr.mr_n61052320)
print v(xbgr.mr_n61052640)
print v(xbgr.mr_n61052752)
print v(xbgr.mr_n61053072)
print v(xbgr.mr_n61053936)
print v(xbgr.mr_n61054048)
print v(xbgr.mr_n61054368)
print v(xbgr.mr_n61054480)
print v(xbgr.mr_n61054800)
print v(xbgr.mr_n61054912)
print v(xbgr.mr_n61055232)
print v(xbgr.mr_n61055344)
print v(xbgr.mr_n61055664)
print v(xbgr.mr_n61055776)
print v(xbgr.mr_n61056096)
print v(xbgr.mr_n61056208)
print v(xbgr.mr_n61056528)
print v(xbgr.mr_n61056640)
print v(xbgr.mr_n61056960)
print v(xbgr.mr_n61057072)
print v(xbgr.mr_n61057392)
print v(xbgr.mr_n61057504)
print v(xbgr.mr_n61057824)
print v(xbgr.mr_n61057936)
print v(xbgr.mr_n61058256)
print v(xbgr.mr_n61058368)
print v(xbgr.mr_n61058800)
print v(xbgr.mr_n61059120)
print v(xbgr.mr_n61059232)
print v(xbgr.mr_n61059552)
print v(xbgr.mr_n61059664)
print v(xbgr.mr_n61059984)
print v(xbgr.mr_n61060096)
print v(xbgr.mr_n61060416)
print v(xbgr.mr_n61060528)
print v(xbgr.mr_n61060848)
print v(xbgr.mr_n61060960)
print v(xbgr.mr_n61061280)
print v(xbgr.mr_n61061392)
print v(xbgr.mr_n61061712)
print v(xbgr.mr_n61061824)
print v(xbgr.mr_n61062144)
print v(xbgr.mr_n61062256)
print v(xbgr.mr_n61062576)
print v(xbgr.mr_n61062688)
print v(xbgr.mr_n61063008)
print v(xbgr.mr_n61063120)
print v(xbgr.mr_n61063440)
print v(xbgr.mr_n61063552)
print v(xbgr.mr_n61063872)
print v(xbgr.mr_n61063984)
print v(xbgr.mr_n61064304)
print v(xbgr.mr_n61064416)
print v(xbgr.mr_n61064736)
print v(xbgr.mr_n61064848)
print v(xbgr.mr_n61065168)
print v(xbgr.mr_n61065280)
print v(xbgr.mr_n61065600)
print v(xbgr.mr_n61065712)
print v(xbgr.mr_n61066032)
print v(xbgr.mr_n61066144)
print v(xbgr.mr_n61066464)
print v(xbgr.mr_n61066576)
print v(xbgr.mr_n61066896)
print v(xbgr.mr_n61067008)
print v(xbgr.mr_n61067328)
print v(xbgr.mr_n61067440)
print v(xbgr.mr_n61067760)
print v(xbgr.mr_n61067872)
print v(xbgr.mr_n61068192)
print v(xbgr.mr_n61068304)
print v(xbgr.mr_n61068624)
print v(xbgr.mr_n61068736)
print v(xbgr.mr_n61069056)
print v(xbgr.mr_n61069168)
print v(xbgr.mr_n61069488)
print v(xbgr.mr_n61069600)
print v(xbgr.mr_n61069920)
print v(xbgr.mr_n61070032)
print v(xbgr.mr_n61070352)
print v(xbgr.mr_n61070464)
print v(xbgr.mr_n61070784)
print v(xbgr.mr_n61070896)
print v(xbgr.mr_n61071216)
print v(xbgr.mr_n61071328)
print v(xbgr.mr_n61071648)
print v(xbgr.mr_n61071760)
print v(xbgr.mr_n61072080)
print v(xbgr.mr_n61072192)
print v(xbgr.mr_n61072512)
print v(xbgr.mr_n61072624)
print v(xbgr.mr_n61072944)
print v(xbgr.mr_n61073056)
print v(xbgr.mr_n61073376)
print v(xbgr.mr_n61073488)
print v(xbgr.mr_n61073808)
print v(xbgr.mr_n61073920)
print v(xbgr.mr_n61074240)
print v(xbgr.mr_n61074352)
print v(xbgr.mr_n61074672)
print v(xbgr.mr_n61074784)
print v(xbgr.mr_n61075104)
print v(xbgr.mr_n61075216)
print v(xbgr.mr_n61075536)
print v(xbgr.mr_n61076400)
print v(xbgr.mr_n61076512)
print v(xbgr.mr_n61076832)
print v(xbgr.mr_n61076944)
print v(xbgr.mr_n61077264)
print v(xbgr.mr_n61077376)
print v(xbgr.mr_n61077696)
print v(xbgr.mr_n61077808)
print v(xbgr.mr_n61078128)
print v(xbgr.mr_n61078240)
print v(xbgr.mr_n61078560)
print v(xbgr.mr_n61078672)
print v(xbgr.mr_n61078992)
print v(xbgr.mr_n61079104)
print v(xbgr.mr_n61079424)
print v(xbgr.mr_n61079536)
print v(xbgr.mr_n61079856)
print v(xbgr.mr_n61079968)
print v(xbgr.mr_n61080288)
print v(xbgr.mr_n61080400)
print v(xbgr.mr_n61080720)
print v(xbgr.mr_n61080832)
print v(xbgr.mr_n61081152)
print v(xbgr.mr_n61081264)
print v(xbgr.mr_n61081584)
print v(xbgr.mr_n61081696)
print v(xbgr.mr_n61082016)
print v(xbgr.mr_n61082128)
print v(xbgr.mr_n61082448)
print v(xbgr.mr_n61082560)
print v(xbgr.mr_n61082880)
print v(xbgr.mr_n61082992)
print v(xbgr.mr_n61083312)
print v(xbgr.mr_n61083424)
print v(xbgr.mr_n61083744)
print v(xbgr.mr_n61083856)
print v(xbgr.mr_n61084176)
print v(xbgr.mr_n61084288)
print v(xbgr.mr_n61084608)
print v(xbgr.mr_n61084720)
print v(xbgr.mr_n61085040)
print v(xbgr.mr_n61085152)
print v(xbgr.mr_n61085472)
print v(xbgr.mr_n61085584)
print v(xbgr.mr_n61085904)
print v(xbgr.mr_n61086016)
print v(xbgr.mr_n61086336)
print v(xbgr.mr_n61086448)
print v(xbgr.mr_n61086768)
print v(xbgr.mr_n61086880)
print v(xbgr.mr_n61087200)
print v(xbgr.mr_n61087312)
print v(xbgr.mr_n61087632)
print v(xbgr.mr_n61087744)
print v(xbgr.mr_n61088064)
print v(xbgr.mr_n61088176)
print v(xbgr.mr_n61088496)
print v(xbgr.mr_n61088608)
print v(xbgr.mr_n61088928)
print v(xbgr.mr_n61089040)
print v(xbgr.mr_n61089360)
print v(xbgr.mr_n61089472)
print v(xbgr.mr_n61089792)
print v(xbgr.mr_n61089904)
print v(xbgr.mr_n61090224)
print v(xbgr.mr_n61090336)
print v(xbgr.mr_n61090656)
print v(xbgr.mr_n61090768)
print v(xbgr.mr_n61091088)
print v(xbgr.mr_n61091200)
print v(xbgr.mr_n61091520)
print v(xbgr.mr_n61091632)
print v(xbgr.mr_n61091952)
print v(xbgr.mr_n61092064)
print v(xbgr.mr_n61092384)
print v(xbgr.mr_n61092496)
print v(xbgr.mr_n61092816)
print v(xbgr.mr_n61092928)
print v(xbgr.mr_n61093248)
print v(xbgr.mr_n61093360)
print v(xbgr.mr_n61093680)
print v(xbgr.mr_n61093792)
print v(xbgr.mr_n61094112)
print v(xbgr.mr_n61094224)
print v(xbgr.mr_n61094544)
print v(xbgr.mr_n61094656)
print v(xbgr.mr_n61094976)
print v(xbgr.mr_n61095088)
print v(xbgr.mr_n61095408)
print v(xbgr.mr_n61095520)
print v(xbgr.mr_n61095840)
print v(xbgr.mr_n61095952)
print v(xbgr.mr_n61096272)
print v(xbgr.mr_n61096384)
print v(xbgr.mr_n61096704)
print v(xbgr.mr_n61096816)
print v(xbgr.mr_n61097136)
print v(xbgr.mr_n61097248)
print v(xbgr.mr_n61097568)
print v(xbgr.mr_n61097680)
print v(xbgr.mr_n61098000)
print v(xbgr.mr_n61098112)
print v(xbgr.mr_n61098432)
print v(xbgr.mr_n61098544)
print v(xbgr.mr_n61098864)
print v(xbgr.mr_n61098976)
print v(xbgr.mr_n61099296)
print v(xbgr.mr_n61099408)
print v(xbgr.mr_n61099728)
print v(xbgr.mr_n61099840)
print v(xbgr.mr_n61100160)
print v(xbgr.mr_n61100272)
print v(xbgr.mr_n61100592)
print v(xbgr.mr_n61100704)
print v(xbgr.mr_n61101024)
print v(xbgr.mr_n61101136)
print v(xbgr.mr_n61101456)
print v(xbgr.mr_n61101568)
print v(xbgr.mr_n61101888)
print v(xbgr.mr_n61102000)
print v(xbgr.mr_n61102320)
print v(xbgr.mr_n61102432)
print v(xbgr.mr_n61102752)
print v(xbgr.mr_n61102864)
print v(xbgr.mr_n61103184)
print v(xbgr.mr_n61103296)
print v(xbgr.mr_n61103616)
print v(xbgr.mr_n61103728)
print v(xbgr.mr_n61104048)
print v(xbgr.mr_n61104160)
print v(xbgr.mr_n61104480)
print v(xbgr.mr_n61104592)
print v(xbgr.mr_n61104912)
print v(xbgr.mr_n61105024)
print v(xbgr.mr_n61105344)
print v(xbgr.mr_n61105456)
print v(xbgr.mr_n61105776)
print v(xbgr.mr_n61105888)
print v(xbgr.mr_n61106208)
print v(xbgr.mr_n61106320)
print v(xbgr.mr_n61106640)
print v(xbgr.mr_n61106752)
print v(xbgr.mr_n61107072)
print v(xbgr.mr_n61107184)
print v(xbgr.mr_n61107504)
print v(xbgr.mr_n61107616)
print v(xbgr.mr_n61107936)
print v(xbgr.mr_n61108048)
print v(xbgr.mr_n61108368)
print v(xbgr.mr_n61108480)
print v(xbgr.mr_n61108800)
print v(xbgr.mr_n61108912)
print v(xbgr.mr_n61109232)
print v(xbgr.mr_n61109344)
print v(xbgr.mr_n61109664)
print v(xbgr.mr_n61109776)
print v(xbgr.mr_n61110096)
print v(xbgr.mr_n61110208)
print v(xbgr.mr_n61110528)
print v(xbgr.mr_n61110640)
print v(xbgr.mr_n61110960)
print v(xbgr.mr_n61111072)
print v(xbgr.mr_n61111392)
print v(xbgr.mr_n61111504)
print v(xbgr.mr_n61111824)
print v(xbgr.mr_n61111936)
print v(xbgr.mr_n61112256)
print v(xbgr.mr_n61112368)
print v(xbgr.mr_n61112688)
print v(xbgr.mr_n61112800)
print v(xbgr.mr_n61113120)
print v(xbgr.mr_n61113232)
print v(xbgr.mr_n61113552)
print v(xbgr.mr_n61113664)
print v(xbgr.mr_n61113984)
print v(xbgr.mr_n61114096)
print v(xbgr.mr_n61114416)
print v(xbgr.mr_n61114528)
print v(xbgr.mr_n61114848)
print v(xbgr.mr_n61114960)
print v(xbgr.mr_n61115280)
print v(xbgr.mr_n61115392)
print v(xbgr.mr_n61115712)
print v(xbgr.mr_n61115824)
print v(xbgr.mr_n61116144)
print v(xbgr.mr_n61116256)
print v(xbgr.mr_n61116576)
print v(xbgr.mr_n61116688)
print v(xbgr.mr_n61117008)
print v(xbgr.mr_n61117120)
print v(xbgr.mr_n61117440)
print v(xbgr.mr_n61117552)
print v(xbgr.mr_n61117872)
print v(xbgr.mr_n61117984)
print v(xbgr.mr_n61118304)
print v(xbgr.mr_n61118416)
print v(xbgr.mr_n61118736)
print v(xbgr.mr_n61118848)
print v(xbgr.mr_n61119168)
print v(xbgr.mr_n61119280)
print v(xbgr.mr_n61119600)
print v(xbgr.mr_n61119712)
print v(xbgr.mr_n61120032)
print v(xbgr.mr_n61120144)
print v(xbgr.mr_n61120464)
print v(xbgr.mr_n61120576)
print v(xbgr.mr_n61120896)
print v(xbgr.mr_n61121008)
print v(xbgr.mr_n61121328)
print v(xbgr.mr_n61121440)
print v(xbgr.mr_n61121760)
print v(xbgr.mr_n61121872)
print v(xbgr.mr_n61122192)
print v(xbgr.mr_n61122304)
print v(xbgr.mr_n61122624)
print v(xbgr.mr_n61122736)
print v(xbgr.mr_n61123056)
print v(xbgr.mr_n61123168)
print v(xbgr.mr_n61123488)
print v(xbgr.mr_n61123600)
print v(xbgr.mr_n61123920)
print v(xbgr.mr_n61124032)
print v(xbgr.mr_n61124352)
print v(xbgr.mr_n61124464)
print v(xbgr.mr_n61124784)
print v(xbgr.mr_n61124896)
print v(xbgr.mr_n61125216)
print v(xbgr.mr_n61125328)
print v(xbgr.mr_n61125648)
print v(xbgr.mr_n61125760)
print v(xbgr.mr_n61126080)
print v(xbgr.mr_n61126192)
print v(xbgr.mr_n61126512)
print v(xbgr.mr_n61126624)
print v(xbgr.mr_n61126944)
print v(xbgr.mr_n61127056)
print v(xbgr.mr_n61127376)
print v(xbgr.mr_n61127488)
print v(xbgr.mr_n61127808)
print v(xbgr.mr_n61127920)
print v(xbgr.mr_n61128240)
print v(xbgr.mr_n61128352)
print v(xbgr.mr_n61128672)
print v(xbgr.mr_n61128784)
print v(xbgr.mr_n61129104)
print v(xbgr.mr_n61129216)
print v(xbgr.mr_n61129536)
print v(xbgr.mr_n61129648)
print v(xbgr.mr_n61129968)
print v(xbgr.mr_n61130080)
print v(xbgr.mr_n61130400)
print v(xbgr.mr_n61130512)
print v(xbgr.mr_n61130832)
print v(xbgr.mr_n61130944)
print v(xbgr.mr_n61131264)
print v(xbgr.mr_n61131376)
print v(xbgr.mr_n61131696)
print v(xbgr.mr_n61131808)
print v(xbgr.mr_n61132128)
print v(xbgr.mr_n61132240)
print v(xbgr.mr_n61132560)
print v(xbgr.mr_n61132672)
print v(xbgr.mr_n61132992)
print v(xbgr.mr_n61133104)
print v(xbgr.mr_n61133424)
print v(xbgr.mr_n61133536)
print v(xbgr.mr_n61133856)
print v(xbgr.mr_n61133968)
print v(xbgr.mr_n61134288)
print v(xbgr.mr_n61134400)
print v(xbgr.mr_n61134720)
print v(xbgr.mr_n61134832)
print v(xbgr.mr_n61135152)
print v(xbgr.mr_n61135264)
print v(xbgr.mr_n61135584)
print v(xbgr.mr_n61135696)
print v(xbgr.mr_n61136016)
print v(xbgr.mr_n61136128)
print v(xbgr.mr_n61136448)
print v(xbgr.mr_n61136560)
print v(xbgr.mr_n61136880)
print v(xbgr.mr_n61136992)
print v(xbgr.mr_n61137312)
print v(xbgr.mr_n61137424)
print v(xbgr.mr_n61137744)
print v(xbgr.mr_n61137856)
print v(xbgr.mr_n61138176)
print v(xbgr.mr_n61138288)
print v(xbgr.mr_n61138608)
print v(xbgr.mr_n61138720)
print v(xbgr.mr_n61139040)
print v(xbgr.mr_n61139152)
print v(xbgr.mr_n61139472)
print v(xbgr.mr_n61139584)
print v(xbgr.mr_n61139904)
print v(xbgr.mr_n61140016)
print v(xbgr.mr_n61140336)
print v(xbgr.mr_n61140448)
print v(xbgr.mr_n61140768)
print v(xbgr.mr_n61140880)
print v(xbgr.mr_n61141200)
print v(xbgr.mr_n61141312)
print v(xbgr.mr_n61141632)
print v(xbgr.mr_n61141744)
print v(xbgr.mr_n61142064)
print v(xbgr.mr_n61142176)
print v(xbgr.mr_n61142496)
print v(xbgr.mr_n61142608)
print v(xbgr.mr_n61142928)
print v(xbgr.mr_n61143040)
print v(xbgr.mr_n61143360)
print v(xbgr.mr_n61143472)
print v(xbgr.mr_n61143792)
print v(xbgr.mr_n61143904)
print v(xbgr.mr_n61144224)
print v(xbgr.mr_n61144336)
print v(xbgr.mr_n61144656)
print v(xbgr.mr_n61144768)
print v(xbgr.mr_n61145088)
print v(xbgr.mr_n61145200)
print v(xbgr.mr_n61145520)
print v(xbgr.mr_n61145632)
print v(xbgr.mr_n61145952)
print v(xbgr.mr_n61146064)
print v(xbgr.mr_n61146384)
print v(xbgr.mr_n61146496)
print v(xbgr.mr_n61146816)
print v(xbgr.mr_n61146928)
print v(xbgr.mr_n61147248)
print v(xbgr.mr_n61147360)
print v(xbgr.mr_n61147680)
print v(xbgr.mr_n61147792)
print v(xbgr.mr_n61148112)
print v(xbgr.mr_n61148224)
print v(xbgr.mr_n61148544)
print v(xbgr.mr_n61148656)
print v(xbgr.mr_n61148976)
print v(xbgr.mr_n61149088)
print v(xbgr.mr_n61149408)
print v(xbgr.mr_n61149520)
print v(xbgr.mr_n61149840)
print v(xbgr.mr_n61149952)
print v(xbgr.mr_n61150272)
print v(xbgr.mr_n61150384)
print v(xbgr.mr_n61150704)
print v(xbgr.mr_n61150816)
print v(xbgr.mr_n61151136)
print v(xbgr.mr_n61151248)
print v(xbgr.mr_n61151568)
print v(xbgr.mr_n61151680)
print v(xbgr.mr_n61152000)
print v(xbgr.mr_n61152112)
print v(xbgr.mr_n61152432)
print v(xbgr.mr_n61152544)
print v(xbgr.mr_n61152864)
print v(xbgr.mr_n61152976)
print v(xbgr.mr_n61153296)
print v(xbgr.mr_n61153408)
print v(xbgr.mr_n61153728)
print v(xbgr.mr_n61153840)
print v(xbgr.mr_n61154160)
print v(xbgr.mr_n61154272)
print v(xbgr.mr_n61154592)
print v(xbgr.mr_n61154704)
print v(xbgr.mr_n61155024)
print v(xbgr.mr_n61155136)
print v(xbgr.mr_n61155456)
print v(xbgr.mr_n61155568)
print v(xbgr.mr_n61155888)
print v(xbgr.mr_n61156000)
print v(xbgr.mr_n61156320)
print v(xbgr.mr_n61156432)
print v(xbgr.mr_n61156752)
print v(xbgr.mr_n61156864)
print v(xbgr.mr_n61157184)
print v(xbgr.mr_n61157296)
print v(xbgr.mr_n61157616)
print v(xbgr.mr_n61157728)
print v(xbgr.mr_n61158048)
print v(xbgr.mr_n61158160)
print v(xbgr.mr_n61158480)
print v(xbgr.mr_n61158592)
print v(xbgr.mr_n61158912)
print v(xbgr.mr_n61159024)
print v(xbgr.mr_n61159344)
print v(xbgr.mr_n61159456)
print v(xbgr.mr_n61159776)
print v(xbgr.mr_n61159888)
print v(xbgr.mr_n61160208)
print v(xbgr.mr_n61160320)
print v(xbgr.mr_n61160640)
print v(xbgr.mr_n61160752)
print v(xbgr.mr_n61161072)
print v(xbgr.mr_n61161184)
print v(xbgr.mr_n61161504)
print v(xbgr.mr_n61161616)
print v(xbgr.mr_n61161936)
print v(xbgr.mr_n61162048)
print v(xbgr.mr_n61162368)
print v(xbgr.mr_n61162480)
print v(xbgr.mr_n61162800)
print v(xbgr.mr_n61162912)
print v(xbgr.mr_n61163232)
print v(xbgr.mr_n61163344)
print v(xbgr.mr_n61163664)
print v(xbgr.mr_n61163776)
print v(xbgr.mr_n61164096)
print v(xbgr.mr_n61164208)
print v(xbgr.mr_n61164528)
print v(xbgr.mr_n61164640)
print v(xbgr.mr_n61164960)
print v(xbgr.mr_n61165072)
print v(xbgr.mr_n61165392)
print v(xbgr.mr_n61165504)
print v(xbgr.mr_n61165824)
print v(xbgr.mr_n61165936)
print v(xbgr.mr_n61166256)
print v(xbgr.mr_n61166368)
print v(xbgr.mr_n61166688)
print v(xbgr.mr_n61166800)
print v(xbgr.mr_n61167120)
print v(xbgr.mr_n61167232)
print v(xbgr.mr_n61167552)
print v(xbgr.mr_n61167664)
print v(xbgr.mr_n61167984)
print v(xbgr.mr_n61168096)
print v(xbgr.mr_n61168416)
print v(xbgr.mr_n61168528)
print v(xbgr.mr_n61168848)
print v(xbgr.mr_n61168960)
print v(xbgr.mr_n61169280)
print v(xbgr.mr_n61169392)
print v(xbgr.mr_n61169712)
print v(xbgr.mr_n61169824)
print v(xbgr.mr_n61170144)
print v(xbgr.mr_n61170256)
print v(xbgr.mr_n61170576)
print v(xbgr.mr_n61170688)
print v(xbgr.mr_n61171008)
print v(xbgr.mr_n61171120)
print v(xbgr.mr_n61171440)
print v(xbgr.mr_n61171552)
print v(xbgr.mr_n61171872)
print v(xbgr.mr_n61171984)
print v(xbgr.mr_n61172304)
print v(xbgr.mr_n61172416)
print v(xbgr.mr_n61172736)
print v(xbgr.mr_n61172848)
print v(xbgr.mr_n61173168)
print v(xbgr.mr_n61173280)
print v(xbgr.mr_n61173600)
print v(xbgr.mr_n61173712)
print v(xbgr.mr_n61174032)
print v(xbgr.mr_n61174144)
print v(xbgr.mr_n61174464)
print v(xbgr.mr_n61174576)
print v(xbgr.mr_n61174896)
print v(xbgr.mr_n61175008)
print v(xbgr.mr_n61175328)
print v(xbgr.mr_n61175440)
print v(xbgr.mr_n61175760)
print v(xbgr.mr_n61175872)
print v(xbgr.mr_n61176192)
print v(xbgr.mr_n61176304)
print v(xbgr.mr_n61176624)
print v(xbgr.mr_n61176736)
print v(xbgr.mr_n61177056)
print v(xbgr.mr_n61177168)
print v(xbgr.mr_n61177488)
print v(xbgr.mr_n61177600)
print v(xbgr.mr_n61177920)
print v(xbgr.mr_n61178032)
print v(xbgr.mr_n61178352)
print v(xbgr.mr_n61178464)
print v(xbgr.mr_n61178784)
print v(xbgr.mr_n61178896)
print v(xbgr.mr_n61179216)
print v(xbgr.mr_n61179328)
print v(xbgr.mr_n61179648)
print v(xbgr.mr_n61179760)
print v(xbgr.mr_n61180080)
print v(xbgr.mr_n61180192)
print v(xbgr.mr_n61180512)
print v(xbgr.mr_n61180624)
print v(xbgr.mr_n61180944)
print v(xbgr.mr_n61181056)
print v(xbgr.mr_n61181376)
print v(xbgr.mr_n61181488)
print v(xbgr.mr_n61181808)
print v(xbgr.mr_n61181920)
print v(xbgr.mr_n61182240)
print v(xbgr.mr_n61182352)
print v(xbgr.mr_n61182672)
print v(xbgr.mr_n61182784)
print v(xbgr.mr_n61183104)
print v(xbgr.mr_n61183216)
print v(xbgr.mr_n61183536)
print v(xbgr.mr_n61183648)
print v(xbgr.mr_n61183968)
print v(xbgr.mr_n61184080)
print v(xbgr.mr_n61184400)
print v(xbgr.mr_n61184512)
print v(xbgr.mr_n61184832)
print v(xbgr.mr_n61184944)
print v(xbgr.mr_n61185264)
print v(xbgr.mr_n61185376)
print v(xbgr.mr_n61185696)
print v(xbgr.mr_n61185808)
print v(xbgr.mr_n61186128)
print v(xbgr.mr_n61186240)
print v(xbgr.mr_n61186560)
print v(xbgr.mr_n61186672)
print v(xbgr.mr_n61186992)
print v(xbgr.mr_n61187104)
print v(xbgr.mr_n61187424)
print v(xbgr.mr_n61187536)
print v(xbgr.mr_n61187856)
print v(xbgr.mr_n61187968)
print v(xbgr.mr_n61188288)
print v(xbgr.mr_n61188400)
print v(xbgr.mr_n61188720)
print v(xbgr.mr_n61188832)
print v(xbgr.mr_n61189152)
print v(xbgr.mr_n61189264)
print v(xbgr.mr_n61189584)
print v(xbgr.mr_n61189696)
print v(xbgr.mr_n61190016)
print v(xbgr.mr_n61190128)
print v(xbgr.mr_n61190448)
print v(xbgr.mr_n61190560)
print v(xbgr.mr_n61190880)
print v(xbgr.mr_n61190992)
print v(xbgr.mr_n61191312)
print v(xbgr.mr_n61191424)
print v(xbgr.mr_n61191744)
print v(xbgr.mr_n61191856)
print v(xbgr.mr_n61192176)
print v(xbgr.mr_n61192288)
print v(xbgr.mr_n61192608)
print v(xbgr.mr_n61192720)
print v(xbgr.mr_n61193040)
print v(xbgr.mr_n61193152)
print v(xbgr.mr_n61193472)
print v(xbgr.mr_n61193584)
print v(xbgr.mr_n61193904)
print v(xbgr.mr_n61194016)
print v(xbgr.mr_n61194336)
print v(xbgr.mr_n61194448)
print v(xbgr.mr_n61194768)
print v(xbgr.mr_n61194880)
print v(xbgr.mr_n61195200)
print v(xbgr.mr_n61195312)
print v(xbgr.mr_n61195632)
print v(xbgr.mr_n61195744)
print v(xbgr.mr_n61196064)
print v(xbgr.mr_n61196176)
print v(xbgr.mr_n61196496)
print v(xbgr.mr_n61196608)
print v(xbgr.mr_n61196928)
print v(xbgr.mr_n61197040)
print v(xbgr.mr_n61197360)
print v(xbgr.mr_n61197472)
print v(xbgr.mr_n61197792)
print v(xbgr.mr_n61197904)
print v(xbgr.mr_n61198224)
print v(xbgr.mr_n61198336)
print v(xbgr.mr_n61198656)
print v(xbgr.mr_n61198768)
print v(xbgr.mr_n61199088)
print v(xbgr.mr_n61199200)
print v(xbgr.mr_n61199520)
print v(xbgr.mr_n61199632)
print v(xbgr.mr_n61199952)
print v(xbgr.mr_n61200064)
print v(xbgr.mr_n61200384)
print v(xbgr.mr_n61200496)
print v(xbgr.mr_n61200816)
print v(xbgr.mr_n61200928)
print v(xbgr.mr_n61201248)
print v(xbgr.mr_n61201360)
print v(xbgr.mr_n61201680)
print v(xbgr.mr_n61201792)
print v(xbgr.mr_n61202112)
print v(xbgr.mr_n61202224)
print v(xbgr.mr_n61202544)
print v(xbgr.mr_n61202656)
print v(xbgr.mr_n61203088)
print v(xbgr.mr_n61203408)
print v(xbgr.mr_n61203520)
print v(xbgr.mr_n61203840)
print v(xbgr.mr_n61203952)
print v(xbgr.mr_n61204272)
print v(xbgr.mr_n61204384)
print v(xbgr.mr_n61204816)
print v(xbgr.mr_n61205136)
print v(xbgr.mr_n61205248)
print v(xbgr.mr_n61205568)
print v(xbgr.mr_n61205680)
print v(xbgr.mr_n61206000)
print v(xbgr.mr_n61206112)
print v(xbgr.mr_n61206432)
print v(xbgr.mr_n61206544)
print v(xbgr.mr_n61206864)
print v(xbgr.mr_n61206976)
print v(xbgr.mr_n61207296)
print v(xbgr.mr_n61207408)
print v(xbgr.mr_n61207728)
print v(xbgr.mr_n61207840)
print v(xbgr.mr_n61208160)
print v(xbgr.mr_n61208272)
print v(xbgr.mr_n61208592)
print v(xbgr.mr_n61208704)
print v(xbgr.mr_n61209024)
print v(xbgr.mr_n61209136)
print v(xbgr.mr_n61209456)
print v(xbgr.mr_n61209568)
print v(xbgr.mr_n61209888)
print v(xbgr.mr_n61210000)
print v(xbgr.mr_n61210320)
print v(xbgr.mr_n61210432)
print v(xbgr.mr_n61210752)
print v(xbgr.mr_n61210864)
print v(xbgr.mr_n61211184)
print v(xbgr.mr_n61211296)
print v(xbgr.mr_n61211728)
print v(xbgr.mr_n61212048)
print v(xbgr.mr_n61212160)
print v(xbgr.mr_n61212480)
print v(xbgr.mr_n61212592)
print v(xbgr.mr_n61212912)
print v(xbgr.mr_n61213024)
print v(xbgr.mr_n61213344)
print v(xbgr.mr_n61213456)
print v(xbgr.mr_n61213776)
print v(xbgr.mr_n61213888)
print v(xbgr.mr_n61214208)
print v(xbgr.mr_n61214320)
print v(xbgr.mr_n61214640)
print v(xbgr.mr_n61214752)
print v(xbgr.mr_n61215184)
print v(xbgr.mr_n61215504)
print v(xbgr.mr_n61215616)
print v(xbgr.mr_n61215936)
print v(xbgr.mr_n61216048)
print v(xbgr.mr_n61216368)
print v(xbgr.mr_n61216480)
print v(xbgr.mr_n61216800)
print v(xbgr.mr_n61216912)
print v(xbgr.mr_n61217232)
print v(xbgr.mr_n61217344)
print v(xbgr.mr_n61217664)
print v(xbgr.mr_n61217776)
print v(xbgr.mr_n61218096)
print v(xbgr.mr_n61218208)
print v(xbgr.mr_n61218528)
print v(xbgr.mr_n61218640)
print v(xbgr.mr_n61218960)
print v(xbgr.mr_n61219072)
print v(xbgr.mr_n61219392)
print v(xbgr.mr_n61219504)
print v(xbgr.mr_n61219824)
print v(xbgr.mr_n61219936)
print v(xbgr.mr_n61220256)
print v(xbgr.mr_n61220368)
print v(xbgr.mr_n61220688)
print v(xbgr.mr_n61220800)
print v(xbgr.mr_n61221232)
print v(xbgr.mr_n61221552)
print v(xbgr.mr_n61221664)
print v(xbgr.mr_n61221984)
print v(xbgr.mr_n61222096)
print v(xbgr.mr_n61222416)
print v(xbgr.mr_n61222528)
print v(xbgr.mr_n61222960)
print v(xbgr.mr_n61223280)
print v(xbgr.mr_n61223392)
print v(xbgr.mr_n61223712)
print v(xbgr.mr_n61223824)
print v(xbgr.mr_n61224144)
print v(xbgr.mr_n61224256)
print v(xbgr.mr_n61224576)
print v(xbgr.mr_n61224688)
print v(xbgr.mr_n61225008)
print v(xbgr.mr_n61225120)
print v(xbgr.mr_n61225552)
print v(xbgr.mr_n61225872)
print v(xbgr.mr_n61225984)
print v(xbgr.mr_n61226304)
print v(xbgr.mr_n61226416)
print v(xbgr.mr_n61226736)
print v(xbgr.mr_n61226848)
print v(xbgr.mr_n61227168)
print v(xbgr.mr_n61227280)
print v(xbgr.mr_n61227600)
print v(xbgr.mr_n61227712)
print v(xbgr.mr_n61228032)
print v(xbgr.mr_n61228144)
print v(xbgr.mr_n61228464)
print v(xbgr.mr_n61228576)
print v(xbgr.mr_n61228896)
print v(xbgr.mr_n61229008)
print v(xbgr.mr_n61229328)
print v(xbgr.mr_n61229440)
print v(xbgr.mr_n61229760)
print v(xbgr.mr_n61229872)
print v(xbgr.mr_n61230192)
print v(xbgr.mr_n61230304)
print v(xbgr.mr_n61230624)
print v(xbgr.mr_n61230736)
print v(xbgr.mr_n61231056)
print v(xbgr.mr_n61231168)
print v(xbgr.mr_n61231600)
print v(xbgr.mr_n61231920)
print v(xbgr.mr_n61232032)
print v(xbgr.mr_n61232352)
print v(xbgr.mr_n61232464)
print v(xbgr.mr_n61232784)
print v(xbgr.mr_n61232896)
print v(xbgr.mr_n61233328)
print v(xbgr.mr_n61233648)
print v(xbgr.mr_n61233760)
print v(xbgr.mr_n61234192)
print v(xbgr.mr_n61234512)
print v(xbgr.mr_n61234624)
print v(xbgr.mr_n61234944)
print v(xbgr.mr_n61235056)
print v(xbgr.mr_n61235376)
print v(xbgr.mr_n61235488)
print v(xbgr.mr_n61235920)
print v(xbgr.mr_n61236240)
print v(xbgr.mr_n61236352)
print v(xbgr.mr_n61236672)
print v(xbgr.mr_n61236784)
print v(xbgr.mr_n61237104)
print v(xbgr.mr_n61237216)
print v(xbgr.mr_n61237536)
print v(xbgr.mr_n61237648)
print v(xbgr.mr_n61237968)
print v(xbgr.mr_n61238080)
print v(xbgr.mr_n61238400)
print v(xbgr.mr_n61238512)
print v(xbgr.mr_n61238832)
print v(xbgr.mr_n61238944)
print v(xbgr.mr_n61239264)
print v(xbgr.mr_n61239376)
print v(xbgr.mr_n61239696)
print v(xbgr.mr_n61239808)
print v(xbgr.mr_n61240240)
print v(xbgr.mr_n61240560)
print v(xbgr.mr_n61240672)
print v(xbgr.mr_n61240992)
print v(xbgr.mr_n61241104)
print v(xbgr.mr_n61241424)
print v(xbgr.mr_n61241536)
print v(xbgr.mr_n61241856)
print v(xbgr.mr_n61241968)
print v(xbgr.mr_n61242288)
print v(xbgr.mr_n61242400)
print v(xbgr.mr_n61242720)
print v(xbgr.mr_n61242832)
print v(xbgr.mr_n61243152)
print v(xbgr.mr_n61243264)
print v(xbgr.mr_n61243584)
print v(xbgr.mr_n61243696)
print v(xbgr.mr_n61244016)
print v(xbgr.mr_n61244128)
print v(xbgr.mr_n61244448)
print v(xbgr.mr_n61244560)
print v(xbgr.mr_n61244880)
print v(xbgr.mr_n61244992)
print v(xbgr.mr_n61245312)
print v(xbgr.mr_n61245424)
print v(xbgr.mr_n61245744)
print v(xbgr.mr_n61245856)
print v(xbgr.mr_n61246176)
print v(xbgr.mr_n61246288)
print v(xbgr.mr_n61246608)
print v(xbgr.mr_n61246720)
print v(xbgr.mr_n61247040)
print v(xbgr.mr_n61247152)
print v(xbgr.mr_n61247472)
print v(xbgr.mr_n61247584)
print v(xbgr.mr_n61247904)
print v(xbgr.mr_n61248016)
print v(xbgr.mr_n61248336)
print v(xbgr.mr_n61248448)
print v(xbgr.mr_n61248768)
print v(xbgr.mr_n61248880)
print v(xbgr.mr_n61249200)
print v(xbgr.mr_n61249312)
print v(xbgr.mr_n61249632)
print v(xbgr.mr_n61249744)
print v(xbgr.mr_n61250064)
print v(xbgr.mr_n61250176)
print v(xbgr.mr_n61250496)
print v(xbgr.mr_n61250608)
print v(xbgr.mr_n61250928)
print v(xbgr.mr_n61251040)
print v(xbgr.mr_n61251360)
print v(xbgr.mr_n61251472)
print v(xbgr.mr_n61251792)
print v(xbgr.mr_n61251904)
print v(xbgr.mr_n61252224)
print v(xbgr.mr_n61252336)
print v(xbgr.mr_n61252656)
print v(xbgr.mr_n61252768)
print v(xbgr.mr_n61253088)
print v(xbgr.mr_n61253200)
print v(xbgr.mr_n61253520)
print v(xbgr.mr_n61253632)
print v(xbgr.mr_n61253952)
print v(xbgr.mr_n61254064)
print v(xbgr.mr_n61254384)
print v(xbgr.mr_n61254496)
print v(xbgr.mr_n61254816)
print v(xbgr.mr_n61254928)
print v(xbgr.mr_n61255248)
print v(xbgr.mr_n61255360)
print v(xbgr.mr_n61255680)
print v(xbgr.mr_n61255792)
print v(xbgr.mr_n61256112)
print v(xbgr.mr_n61256224)
print v(xbgr.mr_n61256544)
print v(xbgr.mr_n61256656)
print v(xbgr.mr_n61256976)
print v(xbgr.mr_n61257088)
print v(xbgr.mr_n61257408)
print v(xbgr.mr_n61257520)
print v(xbgr.mr_n61257840)
print v(xbgr.mr_n61257952)
print v(xbgr.mr_n61258272)
print v(xbgr.mr_n61258384)
print v(xbgr.mr_n61258704)
print v(xbgr.mr_n61258816)
print v(xbgr.mr_n61259136)
print v(xbgr.mr_n61259248)
print v(xbgr.mr_n61259568)
print v(xbgr.mr_n61259680)
print v(xbgr.mr_n61260000)
print v(xbgr.mr_n61260112)
print v(xbgr.mr_n61260432)
print v(xbgr.mr_n61260544)
print v(xbgr.mr_n61260864)
print v(xbgr.mr_n61260976)
print v(xbgr.mr_n61261296)
print v(xbgr.mr_n61261408)
print v(xbgr.mr_n61261728)
print v(xbgr.mr_n61261840)
print v(xbgr.mr_n61262160)
print v(xbgr.mr_n61262272)
print v(xbgr.mr_n61262592)
print v(xbgr.mr_n61262704)
print v(xbgr.mr_n61263024)
print v(xbgr.mr_n61263136)
print v(xbgr.mr_n61263456)
print v(xbgr.mr_n61263568)
print v(xbgr.mr_n61263888)
print v(xbgr.mr_n61264000)
print v(xbgr.mr_n61264320)
print v(xbgr.mr_n61264432)
print v(xbgr.mr_n61264752)
print v(xbgr.mr_n61264864)
print v(xbgr.mr_n61265184)
print v(xbgr.mr_n61265296)
print v(xbgr.mr_n61265616)
print v(xbgr.mr_n61265728)
print v(xbgr.mr_n61266048)
print v(xbgr.mr_n61266160)
print v(xbgr.mr_n61266480)
print v(xbgr.mr_n61266592)
print v(xbgr.mr_n61266912)
print v(xbgr.mr_n61267024)
print v(xbgr.mr_n61267344)
print v(xbgr.mr_n61267456)
print v(xbgr.mr_n61267776)
print v(xbgr.mr_n61267888)
print v(xbgr.mr_n61268208)
print v(xbgr.mr_n61268320)
print v(xbgr.mr_n61268640)
print v(xbgr.mr_n61268752)
print v(xbgr.mr_n61269072)
print v(xbgr.mr_n61269184)
print v(xbgr.mr_n61269504)
print v(xbgr.mr_n61269616)
print v(xbgr.mr_n61269936)
print v(xbgr.mr_n61270048)
print v(xbgr.mr_n61270368)
print v(xbgr.mr_n61270480)
print v(xbgr.mr_n61270800)
print v(xbgr.mr_n61270912)
print v(xbgr.mr_n61271232)
print v(xbgr.mr_n61271344)
print v(xbgr.mr_n61271664)
print v(xbgr.mr_n61271776)
print v(xbgr.mr_n61272096)
print v(xbgr.mr_n61272208)
print v(xbgr.mr_n61272528)
print v(xbgr.mr_n61272640)
print v(xbgr.mr_n61272960)
print v(xbgr.mr_n61273072)
print v(xbgr.mr_n61273392)
print v(xbgr.mr_n61273504)
print v(xbgr.mr_n61273824)
print v(xbgr.mr_n61273936)
print v(xbgr.mr_n61274256)
print v(xbgr.mr_n61274368)
print v(xbgr.mr_n61274688)
print v(xbgr.mr_n61274800)
print v(xbgr.mr_n61275120)
print v(xbgr.mr_n61275232)
print v(xbgr.mr_n61275552)
print v(xbgr.mr_n61275664)
print v(xbgr.mr_n61275984)
print v(xbgr.mr_n61276096)
print v(xbgr.mr_n61276416)
print v(xbgr.mr_n61276528)
print v(xbgr.mr_n61276848)
print v(xbgr.mr_n61276960)
print v(xbgr.mr_n61277280)
print v(xbgr.mr_n61277392)
print v(xbgr.mr_n61277712)
print v(xbgr.mr_n61277824)
print v(xbgr.mr_n61278144)
print v(xbgr.mr_n61278256)
print v(xbgr.mr_n61278576)
print v(xbgr.mr_n61278688)
print v(xbgr.mr_n61279008)
print v(xbgr.mr_n61279120)
print v(xbgr.mr_n61279440)
print v(xbgr.mr_n61279552)
print v(xbgr.mr_n61279872)
print v(xbgr.mr_n61279984)
print v(xbgr.mr_n61280304)
print v(xbgr.mr_n61280416)
print v(xbgr.mr_n61280736)
print v(xbgr.mr_n61280848)
print v(xbgr.mr_n61281168)
print v(xbgr.mr_n61281280)
print v(xbgr.mr_n61281600)
print v(xbgr.mr_n61281712)
print v(xbgr.mr_n61282032)
print v(xbgr.mr_n61282144)
print v(xbgr.mr_n61282464)
print v(xbgr.mr_n61282576)
print v(xbgr.mr_n61282896)
print v(xbgr.mr_n61283008)
print v(xbgr.mr_n61283328)
print v(xbgr.mr_n61283440)
print v(xbgr.mr_n61283760)
print v(xbgr.mr_n61283872)
print v(xbgr.mr_n61284192)
print v(xbgr.mr_n61284304)
print v(xbgr.mr_n61284624)
print v(xbgr.mr_n61284736)
print v(xbgr.mr_n61285056)
print v(xbgr.mr_n61285168)
print v(xbgr.mr_n61285488)
print v(xbgr.mr_n61285600)
print v(xbgr.mr_n61285920)
print v(xbgr.mr_n61286032)
print v(xbgr.mr_n61286352)
print v(xbgr.mr_n61286464)
print v(xbgr.mr_n61286784)
print v(xbgr.mr_n61286896)
print v(xbgr.mr_n61287216)
print v(xbgr.mr_n61287328)
print v(xbgr.mr_n61287648)
print v(xbgr.mr_n61287760)
print v(xbgr.mr_n61288080)
print v(xbgr.mr_n61288192)
print v(xbgr.mr_n61288512)
print v(xbgr.mr_n61288624)
print v(xbgr.mr_n61288944)
print v(xbgr.mr_n61289056)
print v(xbgr.mr_n61289376)
print v(xbgr.mr_n61289488)
print v(xbgr.mr_n61289808)
print v(xbgr.mr_n61289920)
print v(xbgr.mr_n61290240)
print v(xbgr.mr_n61290352)
print v(xbgr.mr_n61290672)
print v(xbgr.mr_n61290784)
print v(xbgr.mr_n61291104)
print v(xbgr.mr_n61291216)
print v(xbgr.mr_n61291536)
print v(xbgr.mr_n61291648)
print v(xbgr.mr_n61291968)
print v(xbgr.mr_n61292080)
print v(xbgr.mr_n61292400)
print v(xbgr.mr_n61292512)
print v(xbgr.mr_n61292832)
print v(xbgr.mr_n61292944)
print v(xbgr.mr_n61293264)
print v(xbgr.mr_n61293376)
print v(xbgr.mr_n61293696)
print v(xbgr.mr_n61293808)
print v(xbgr.mr_n61294128)
print v(xbgr.mr_n61294240)
print v(xbgr.mr_n61294560)
print v(xbgr.mr_n61294672)
print v(xbgr.mr_n61294992)
print v(xbgr.mr_n61295104)
print v(xbgr.mr_n61295424)
print v(xbgr.mr_n61295536)
print v(xbgr.mr_n61295856)
print v(xbgr.mr_n61295968)
print v(xbgr.mr_n61296288)
print v(xbgr.mr_n61296400)
print v(xbgr.mr_n61296720)
print v(xbgr.mr_n61296832)
print v(xbgr.mr_n61297152)
print v(xbgr.mr_n61297264)
print v(xbgr.mr_n61297584)
print v(xbgr.mr_n61297696)
print v(xbgr.mr_n61298016)
print v(xbgr.mr_n61298128)
print v(xbgr.mr_n61298448)
print v(xbgr.mr_n61298560)
print v(xbgr.mr_n61298880)
print v(xbgr.mr_n61298992)
print v(xbgr.mr_n61299312)
print v(xbgr.mr_n61299424)
print v(xbgr.mr_n61299744)
print v(xbgr.mr_n61299856)
print v(xbgr.mr_n61300176)
print v(xbgr.mr_n61300288)
print v(xbgr.mr_n61300608)
print v(xbgr.mr_n61300720)
print v(xbgr.mr_n61301040)
print v(xbgr.mr_n61301152)
print v(xbgr.mr_n61301472)
print v(xbgr.mr_n61301584)
print v(xbgr.mr_n61301904)
print v(xbgr.mr_n61302016)
print v(xbgr.mr_n61302336)
print v(xbgr.mr_n61302448)
print v(xbgr.mr_n61302768)
print v(xbgr.mr_n61302880)
print v(xbgr.mr_n61303200)
print v(xbgr.mr_n61303312)
print v(xbgr.mr_n61303632)
print v(xbgr.mr_n61303744)
print v(xbgr.mr_n61304064)
print v(xbgr.mr_n61304176)
print v(xbgr.mr_n61304496)
print v(xbgr.mr_n61304608)
print v(xbgr.mr_n61304928)
print v(xbgr.mr_n61305040)
print v(xbgr.mr_n61305360)
print v(xbgr.mr_n61305472)
print v(xbgr.mr_n61305792)
print v(xbgr.mr_n61305904)
print v(xbgr.mr_n61306224)
print v(xbgr.mr_n61306336)
print v(xbgr.mr_n61306656)
print v(xbgr.mr_n61306768)
print v(xbgr.mr_n61307088)
print v(xbgr.mr_n61307200)
print v(xbgr.mr_n61307520)
print v(xbgr.mr_n61307632)
print v(xbgr.mr_n61307952)
print v(xbgr.mr_n61308064)
print v(xbgr.mr_n61308384)
print v(xbgr.mr_n61308496)
print v(xbgr.mr_n61308816)
print v(xbgr.mr_n61308928)
print v(xbgr.mr_n61309248)
print v(xbgr.mr_n61309360)
print v(xbgr.mr_n61309680)
print v(xbgr.mr_n61309792)
print v(xbgr.mr_n61310112)
print v(xbgr.mr_n61310224)
print v(xbgr.mr_n61310544)
print v(xbgr.mr_n61310656)
print v(xbgr.mr_n61310976)
print v(xbgr.mr_n61311088)
print v(xbgr.mr_n61311408)
print v(xbgr.mr_n61311520)
print v(xbgr.mr_n61311840)
print v(xbgr.mr_n61311952)
print v(xbgr.mr_n61312272)
print v(xbgr.mr_n61312384)
print v(xbgr.mr_n61312704)
print v(xbgr.mr_n61312816)
print v(xbgr.mr_n61313136)
print v(xbgr.mr_n61313248)
print v(xbgr.mr_n61313568)
print v(xbgr.mr_n61313680)
print v(xbgr.mr_n61314000)
print v(xbgr.mr_n61314112)
print v(xbgr.mr_n61314432)
print v(xbgr.mr_n61314544)
print v(xbgr.mr_n61314864)
print v(xbgr.mr_n61314976)
print v(xbgr.mr_n61315296)
print v(xbgr.mr_n61315408)
print v(xbgr.mr_n61315728)
print v(xbgr.mr_n61315840)
print v(xbgr.mr_n61316160)
print v(xbgr.mr_n61316272)
print v(xbgr.mr_n61316592)
print v(xbgr.mr_n61316704)
print v(xbgr.mr_n61317024)
print v(xbgr.mr_n61317136)
print v(xbgr.mr_n61317456)
print v(xbgr.mr_n61317568)
print v(xbgr.mr_n61317888)
print v(xbgr.mr_n61318000)
print v(xbgr.mr_n61318320)
print v(xbgr.mr_n61318432)
print v(xbgr.mr_n61318752)
print v(xbgr.mr_n61318864)
print v(xbgr.mr_n61319184)
print v(xbgr.mr_n61319296)
print v(xbgr.mr_n61319616)
print v(xbgr.mr_n61319728)
print v(xbgr.mr_n61320048)
print v(xbgr.mr_n61320160)
print v(xbgr.mr_n61320480)
print v(xbgr.mr_n61320592)
print v(xbgr.mr_n61320912)
print v(xbgr.mr_n61321024)
print v(xbgr.mr_n61321344)
print v(xbgr.mr_n61321456)
print v(xbgr.mr_n61321776)
print v(xbgr.mr_n61321888)
print v(xbgr.mr_n61322208)
print v(xbgr.mr_n61322320)
print v(xbgr.mr_n61322640)
print v(xbgr.mr_n61322752)
print v(xbgr.mr_n61323072)
print v(xbgr.mr_n61323184)
print v(xbgr.mr_n61323504)
print v(xbgr.mr_n61323616)
print v(xbgr.mr_n61323936)
print v(xbgr.mr_n61324048)
print v(xbgr.mr_n61324368)
print v(xbgr.mr_n61324480)
print v(xbgr.mr_n61324800)
print v(xbgr.mr_n61324912)
print v(xbgr.mr_n61325232)
print v(xbgr.mr_n61325344)
print v(xbgr.mr_n61325664)
print v(xbgr.mr_n61325776)
print v(xbgr.mr_n61326096)
print v(xbgr.mr_n61326208)
print v(xbgr.mr_n61326528)
print v(xbgr.mr_n61326640)
print v(xbgr.mr_n61326960)
print v(xbgr.mr_n61327072)
print v(xbgr.mr_n61327392)
print v(xbgr.mr_n61327504)
print v(xbgr.mr_n61327824)
print v(xbgr.mr_n61327936)
print v(xbgr.mr_n61328256)
print v(xbgr.mr_n61328368)
print v(xbgr.mr_n61328688)
print v(xbgr.mr_n61328800)
print v(xbgr.mr_n61329120)
print v(xbgr.mr_n61329232)
print v(xbgr.mr_n61329552)
print v(xbgr.mr_n61329664)
print v(xbgr.mr_n61329984)
print v(xbgr.mr_n61330096)
print v(xbgr.mr_n61330416)
print v(xbgr.mr_n61330528)
print v(xbgr.mr_n61330848)
print v(xbgr.mr_n61330960)
print v(xbgr.mr_n61331280)
print v(xbgr.mr_n61331392)
print v(xbgr.mr_n61331712)
print v(xbgr.mr_n61331824)
print v(xbgr.mr_n61332144)
print v(xbgr.mr_n61332256)
print v(xbgr.mr_n61332576)
print v(xbgr.mr_n61332688)
print v(xbgr.mr_n61333008)
print v(xbgr.mr_n61333120)
print v(xbgr.mr_n61333440)
print v(xbgr.mr_n61333552)
print v(xbgr.mr_n61333872)
print v(xbgr.mr_n61333984)
print v(xbgr.mr_n61334304)
print v(xbgr.mr_n61334416)
print v(xbgr.mr_n61334736)
print v(xbgr.mr_n61334848)
print v(xbgr.mr_n61335168)
print v(xbgr.mr_n61335280)
print v(xbgr.mr_n61335600)
print v(xbgr.mr_n61335712)
print v(xbgr.mr_n61336032)
print v(xbgr.mr_n61336144)
print v(xbgr.mr_n61336464)
print v(xbgr.mr_n61336576)
print v(xbgr.mr_n61336896)
print v(xbgr.mr_n61337008)
print v(xbgr.mr_n61337328)
print v(xbgr.mr_n61337440)
print v(xbgr.mr_n61337760)
print v(xbgr.mr_n61337872)
print v(xbgr.mr_n61338192)
print v(xbgr.mr_n61338304)
print v(xbgr.mr_n61338624)
print v(xbgr.mr_n61338736)
print v(xbgr.mr_n61339056)
print v(xbgr.mr_n61339168)
print v(xbgr.mr_n61339488)
print v(xbgr.mr_n61339600)
print v(xbgr.mr_n61339920)
print v(xbgr.mr_n61340032)
print v(xbgr.mr_n61340352)
print v(xbgr.mr_n61340464)
print v(xbgr.mr_n61340784)
print v(xbgr.mr_n61340896)
print v(xbgr.mr_n61341216)
print v(xbgr.mr_n61341328)
print v(xbgr.mr_n61341648)
print v(xbgr.mr_n61341760)
print v(xbgr.mr_n61342080)
print v(xbgr.mr_n61342192)
print v(xbgr.mr_n61342512)
print v(xbgr.mr_n61342624)
print v(xbgr.mr_n61342944)
print v(xbgr.mr_n61343056)
print v(xbgr.mr_n61343376)
print v(xbgr.mr_n61343488)
print v(xbgr.mr_n61343808)
print v(xbgr.mr_n61343920)
print v(xbgr.mr_n61344240)
print v(xbgr.mr_n61344352)
print v(xbgr.mr_n61344784)
print v(xbgr.mr_n61345104)
print v(xbgr.mr_n61345216)
print v(xbgr.mr_n61345536)
print v(xbgr.mr_n61345648)
print v(xbgr.mr_n61345968)
print v(xbgr.mr_n61346080)
print v(xbgr.mr_n61346400)
print v(xbgr.mr_n61346512)
print v(xbgr.mr_n61346832)
print v(xbgr.mr_n61346944)
print v(xbgr.mr_n61347376)
print v(xbgr.mr_n61347696)
print v(xbgr.mr_n61347808)
print v(xbgr.mr_n61348128)
print v(xbgr.mr_n61348240)
print v(xbgr.mr_n61348560)
print v(xbgr.mr_n61348672)
print v(xbgr.mr_n61348992)
print v(xbgr.mr_n61349104)
print v(xbgr.mr_n61349424)
print v(xbgr.mr_n61349536)
print v(xbgr.mr_n61349968)
print v(xbgr.mr_n61350288)
print v(xbgr.mr_n61350400)
print v(xbgr.mr_n61350720)
print v(xbgr.mr_n61350832)
print v(xbgr.mr_n61351152)
print v(xbgr.mr_n61351264)
print v(xbgr.mr_n61351584)
print v(xbgr.mr_n61351696)
print v(xbgr.mr_n61352016)
print v(xbgr.mr_n61352128)
print v(xbgr.mr_n61352448)
print v(xbgr.mr_n61352560)
print v(xbgr.mr_n61352880)
print v(xbgr.mr_n61352992)
print v(xbgr.mr_n61353424)
print v(xbgr.mr_n61353744)
print v(xbgr.mr_n61353856)
print v(xbgr.mr_n61354288)
print v(xbgr.mr_n61354608)
print v(xbgr.mr_n61354720)
print v(xbgr.mr_n61355040)
print v(xbgr.mr_n61355152)
print v(xbgr.mr_n61355472)
print v(xbgr.mr_n61355584)
print v(xbgr.mr_n61355904)
print v(xbgr.mr_n61356016)
print v(xbgr.mr_n61356336)
print v(xbgr.mr_n61356448)
print v(xbgr.mr_n61356880)
print v(xbgr.mr_n61357200)
print v(xbgr.mr_n61357312)
print v(xbgr.mr_n61357744)
print v(xbgr.mr_n61358064)
print v(xbgr.mr_n61358176)
print v(xbgr.mr_n61358496)
print v(xbgr.mr_n61358608)
print v(xbgr.mr_n61358928)
print v(xbgr.mr_n61359040)
print v(xbgr.mr_n61359360)
print v(xbgr.mr_n61359472)
print v(xbgr.mr_n61359792)
print v(xbgr.mr_n61359904)
print v(xbgr.mr_n61360224)
print v(xbgr.mr_n61360336)
print v(xbgr.mr_n61360656)
print v(xbgr.mr_n61360768)
print v(xbgr.mr_n61361088)
print v(xbgr.mr_n61361200)
print v(xbgr.mr_n61361520)
print v(xbgr.mr_n61361632)
print v(xbgr.mr_n61361952)
print v(xbgr.mr_n61362064)
print v(xbgr.mr_n61362384)
print v(xbgr.mr_n61362496)
print v(xbgr.mr_n61362816)
print v(xbgr.mr_n61362928)
print v(xbgr.mr_n61363248)
print v(xbgr.mr_n61363360)
print v(xbgr.mr_n61363680)
print v(xbgr.mr_n61363792)
print v(xbgr.mr_n61364112)
print v(xbgr.mr_n61364224)
print v(xbgr.mr_n61364544)
print v(xbgr.mr_n61364656)
print v(xbgr.mr_n61364976)
print v(xbgr.mr_n61365088)
print v(xbgr.mr_n61365408)
print v(xbgr.mr_n61365520)
print v(xbgr.mr_n61365840)
print v(xbgr.mr_n61365952)
print v(xbgr.mr_n61366272)
print v(xbgr.mr_n61366384)
print v(xbgr.mr_n61366704)
print v(xbgr.mr_n61366816)
print v(xbgr.mr_n61367136)
print v(xbgr.mr_n61367248)
print v(xbgr.mr_n61367568)
print v(xbgr.mr_n61367680)
print v(xbgr.mr_n61368000)
print v(xbgr.mr_n61368112)
print v(xbgr.mr_n61368432)
print v(xbgr.mr_n61368544)
print v(xbgr.mr_n61368864)
print v(xbgr.mr_n61368976)
print v(xbgr.mr_n61369296)
print v(xbgr.mr_n61369408)
print v(xbgr.mr_n61369728)
print v(xbgr.mr_n61369840)
print v(xbgr.mr_n61370160)
print v(xbgr.mr_n61370272)
print v(xbgr.mr_n61370592)
print v(xbgr.mr_n61370704)
print v(xbgr.mr_n61371024)
print v(xbgr.mr_n61371136)
print v(xbgr.mr_n61371456)
print v(xbgr.mr_n61371568)
print v(xbgr.mr_n61371888)
print v(xbgr.mr_n61372000)
print v(xbgr.mr_n61372320)
print v(xbgr.mr_n61372432)
print v(xbgr.mr_n61372752)
print v(xbgr.mr_n61372864)
print v(xbgr.mr_n61373184)
print v(xbgr.mr_n61373296)
print v(xbgr.mr_n61373616)
print v(xbgr.mr_n61373728)
print v(xbgr.mr_n61374048)
print v(xbgr.mr_n61374160)
print v(xbgr.mr_n61374480)
print v(xbgr.mr_n61374592)
print v(xbgr.mr_n61374912)
print v(xbgr.mr_n61375024)
print v(xbgr.mr_n61375344)
print v(xbgr.mr_n61375456)
print v(xbgr.mr_n61375776)
print v(xbgr.mr_n61375888)
print v(xbgr.mr_n61376208)
print v(xbgr.mr_n61376320)
print v(xbgr.mr_n61376640)
print v(xbgr.mr_n61376752)
print v(xbgr.mr_n61377072)
print v(xbgr.mr_n61377184)
print v(xbgr.mr_n61377504)
print v(xbgr.mr_n61377616)
print v(xbgr.mr_n61377936)
print v(xbgr.mr_n61378048)
print v(xbgr.mr_n61378368)
print v(xbgr.mr_n61378480)
print v(xbgr.mr_n61378800)
print v(xbgr.mr_n61378912)
print v(xbgr.mr_n61379232)
print v(xbgr.mr_n61379344)
print v(xbgr.mr_n61379664)
print v(xbgr.mr_n61379776)
print v(xbgr.mr_n61380096)
print v(xbgr.mr_n61380208)
print v(xbgr.mr_n61380528)
print v(xbgr.mr_n61380640)
print v(xbgr.mr_n61380960)
print v(xbgr.mr_n61381072)
print v(xbgr.mr_n61381392)
print v(xbgr.mr_n61381504)
print v(xbgr.mr_n61381824)
print v(xbgr.mr_n61381936)
print v(xbgr.mr_n61382256)
print v(xbgr.mr_n61382368)
print v(xbgr.mr_n61382688)
print v(xbgr.mr_n61382800)
print v(xbgr.mr_n61383120)
print v(xbgr.mr_n61383232)
print v(xbgr.mr_n61383552)
print v(xbgr.mr_n61383664)
print v(xbgr.mr_n61383984)
print v(xbgr.mr_n61384096)
print v(xbgr.mr_n61384416)
print v(xbgr.mr_n61384528)
print v(xbgr.mr_n61384848)
print v(xbgr.mr_n61384960)
print v(xbgr.mr_n61385280)
print v(xbgr.mr_n61385392)
print v(xbgr.mr_n61385712)
print v(xbgr.mr_n61385824)
print v(xbgr.mr_n61386144)
print v(xbgr.mr_n61386256)
print v(xbgr.mr_n61386576)
print v(xbgr.mr_n61386688)
print v(xbgr.mr_n61387008)
print v(xbgr.mr_n61387120)
print v(xbgr.mr_n61387440)
print v(xbgr.mr_n61387552)
print v(xbgr.mr_n61387872)
print v(xbgr.mr_n61387984)
print v(xbgr.mr_n61388304)
print v(xbgr.mr_n61388416)
print v(xbgr.mr_n61388736)
print v(xbgr.mr_n61388848)
print v(xbgr.mr_n61389168)
print v(xbgr.mr_n61389280)
print v(xbgr.mr_n61389600)
print v(xbgr.mr_n61389712)
print v(xbgr.mr_n61390032)
print v(xbgr.mr_n61390144)
print v(xbgr.mr_n61390464)
print v(xbgr.mr_n61390576)
print v(xbgr.mr_n61390896)
print v(xbgr.mr_n61391008)
print v(xbgr.mr_n61391440)
print v(xbgr.mr_n61391760)
print v(xbgr.mr_n61391872)
print v(xbgr.mr_n61392192)
print v(xbgr.mr_n61392304)
print v(xbgr.mr_n61392624)
print v(xbgr.mr_n61392736)
print v(xbgr.mr_n61393168)
print v(xbgr.mr_n61393488)
print v(xbgr.mr_n61393600)
print v(xbgr.mr_n61394032)
print v(xbgr.mr_n61394352)
print v(xbgr.mr_n61394464)
print v(xbgr.mr_n61394784)
print v(xbgr.mr_n61394896)
print v(xbgr.mr_n61395216)
print v(xbgr.mr_n61395328)
print v(xbgr.mr_n61395648)
print v(xbgr.mr_n61395760)
print v(xbgr.mr_n61396080)
print v(xbgr.mr_n61396192)
print v(xbgr.mr_n61396512)
print v(xbgr.mr_n61396624)
print v(xbgr.mr_n61396944)
print v(xbgr.mr_n61397056)
print v(xbgr.mr_n61397376)
print v(xbgr.mr_n61397488)
print v(xbgr.mr_n61397808)
print v(xbgr.mr_n61397920)
print v(xbgr.mr_n61398240)
print v(xbgr.mr_n61398352)
print v(xbgr.mr_n61398672)
print v(xbgr.mr_n61398784)
print v(xbgr.mr_n61399104)
print v(xbgr.mr_n61399216)
print v(xbgr.mr_n61399536)
print v(xbgr.mr_n61399648)
print v(xbgr.mr_n61399968)
print v(xbgr.mr_n61400080)
print v(xbgr.mr_n61400400)
print v(xbgr.mr_n61400512)
print v(xbgr.mr_n61400832)
print v(xbgr.mr_n61400944)
print v(xbgr.mr_n61401264)
print v(xbgr.mr_n61401376)
print v(xbgr.mr_n61401696)
print v(xbgr.mr_n61401808)
print v(xbgr.mr_n61402128)
print v(xbgr.mr_n61402240)
print v(xbgr.mr_n61402560)
print v(xbgr.mr_n61402672)
print v(xbgr.mr_n61402992)
print v(xbgr.mr_n61403104)
print v(xbgr.mr_n61403424)
print v(xbgr.mr_n61403536)
print v(xbgr.mr_n61403856)
print v(xbgr.mr_n61403968)
print v(xbgr.mr_n61404288)
print v(xbgr.mr_n61404400)
print v(xbgr.mr_n61404720)
print v(xbgr.mr_n61404832)
print v(xbgr.mr_n61405152)
print v(xbgr.mr_n61405264)
print v(xbgr.mr_n61405584)
print v(xbgr.mr_n61405696)
print v(xbgr.mr_n61406128)
print v(xbgr.mr_n61406448)
print v(xbgr.mr_n61406560)
print v(xbgr.mr_n61406880)
print v(xbgr.mr_n61406992)
print v(xbgr.mr_n61407312)
print v(xbgr.mr_n61407424)
print v(xbgr.mr_n61407744)
print v(xbgr.mr_n61407856)
print v(xbgr.mr_n61408176)
print v(xbgr.mr_n61408288)
print v(xbgr.mr_n61408608)
print v(xbgr.mr_n61408720)
print v(xbgr.mr_n61409040)
print v(xbgr.mr_n61409152)
print v(xbgr.mr_n61409472)
print v(xbgr.mr_n61409584)
print v(xbgr.mr_n61409904)
print v(xbgr.mr_n61410016)
print v(xbgr.mr_n61410448)
print v(xbgr.mr_n61410768)
print v(xbgr.mr_n61410880)
print v(xbgr.mr_n61411200)
print v(xbgr.mr_n61411312)
print v(xbgr.mr_n61411632)
print v(xbgr.mr_n61411744)
print v(xbgr.mr_n61412176)
print v(xbgr.mr_n61412496)
print v(xbgr.mr_n61412608)
print v(xbgr.mr_n61412928)
print v(xbgr.mr_n61413040)
print v(xbgr.mr_n61413360)
print v(xbgr.mr_n61413472)
print v(xbgr.mr_n61413792)
print v(xbgr.mr_n61413904)
print v(xbgr.mr_n61414224)
print v(xbgr.mr_n61414336)
print v(xbgr.mr_n61414768)
print v(xbgr.mr_n61415088)
print v(xbgr.mr_n61415200)
print v(xbgr.mr_n61415520)
print v(xbgr.mr_n61415632)
print v(xbgr.mr_n61415952)
print v(xbgr.mr_n61416064)
print v(xbgr.mr_n61416384)
print v(xbgr.mr_n61416496)
print v(xbgr.mr_n61416816)
print v(xbgr.mr_n61416928)
print v(xbgr.mr_n61417248)
print v(xbgr.mr_n61417360)
print v(xbgr.mr_n61417680)
print v(xbgr.mr_n61417792)
print v(xbgr.mr_n61418112)
print v(xbgr.mr_n61418224)
print v(xbgr.mr_n61418544)
print v(xbgr.mr_n61418656)
print v(xbgr.mr_n61418976)
print v(xbgr.mr_n61419088)
print v(xbgr.mr_n61419408)
print v(xbgr.mr_n61419520)
print v(xbgr.mr_n61419840)
print v(xbgr.mr_n61419952)
print v(xbgr.mr_n61420272)
print v(xbgr.mr_n61420384)
print v(xbgr.mr_n61420704)
print v(xbgr.mr_n61420816)
print v(xbgr.mr_n61421136)
print v(xbgr.mr_n61421248)
print v(xbgr.mr_n61421568)
print v(xbgr.mr_n61421680)
print v(xbgr.mr_n61422000)
print v(xbgr.mr_n61422112)
print v(xbgr.mr_n61422432)
print v(xbgr.mr_n61422544)
print v(xbgr.mr_n61422864)
print v(xbgr.mr_n61422976)
print v(xbgr.mr_n61423296)
print v(xbgr.mr_n61423408)
print v(xbgr.mr_n61423728)
print v(xbgr.mr_n61423840)
print v(xbgr.mr_n61424160)
print v(xbgr.mr_n61424272)
print v(xbgr.mr_n61424592)
print v(xbgr.mr_n61424704)
print v(xbgr.mr_n61425024)
print v(xbgr.mr_n61425136)
print v(xbgr.mr_n61425456)
print v(xbgr.mr_n61425568)
print v(xbgr.mr_n61425888)
print v(xbgr.mr_n61426000)
print v(xbgr.mr_n61426320)
print v(xbgr.mr_n61426432)
print v(xbgr.mr_n61426752)
print v(xbgr.mr_n61426864)
print v(xbgr.mr_n61427184)
print v(xbgr.mr_n61427296)
print v(xbgr.mr_n61427616)
print v(xbgr.mr_n61427728)
print v(xbgr.mr_n61428048)
print v(xbgr.mr_n61428160)
print v(xbgr.mr_n61428480)
print v(xbgr.mr_n61428592)
print v(xbgr.mr_n61428912)
print v(xbgr.mr_n61429024)
print v(xbgr.mr_n61429344)
print v(xbgr.mr_n61429456)
print v(xbgr.mr_n61429776)
print v(xbgr.mr_n61429888)
print v(xbgr.mr_n61430208)
print v(xbgr.mr_n61430320)
print v(xbgr.mr_n61430640)
print v(xbgr.mr_n61430752)
print v(xbgr.mr_n61431072)
print v(xbgr.mr_n61431184)
print v(xbgr.mr_n61431504)
print v(xbgr.mr_n61431616)
print v(xbgr.mr_n61431936)
print v(xbgr.mr_n61432048)
print v(xbgr.mr_n61432368)
print v(xbgr.mr_n61432480)
print v(xbgr.mr_n61432800)
print v(xbgr.mr_n61432912)
print v(xbgr.mr_n61433232)
print v(xbgr.mr_n61433344)
print v(xbgr.mr_n61433664)
print v(xbgr.mr_n61433776)
print v(xbgr.mr_n61434096)
print v(xbgr.mr_n61434208)
print v(xbgr.mr_n61434528)
print v(xbgr.mr_n61434640)
print v(xbgr.mr_n61434960)
print v(xbgr.mr_n61435072)
print v(xbgr.mr_n61435392)
print v(xbgr.mr_n61435504)
print v(xbgr.mr_n61435824)
print v(xbgr.mr_n61435936)
print v(xbgr.mr_n61436256)
print v(xbgr.mr_n61436368)
print v(xbgr.mr_n61436688)
print v(xbgr.mr_n61436800)
print v(xbgr.mr_n61437120)
print v(xbgr.mr_n61437232)
print v(xbgr.mr_n61437552)
print v(xbgr.mr_n61437664)
print v(xbgr.mr_n61437984)
print v(xbgr.mr_n61438096)
print v(xbgr.mr_n61438416)
print v(xbgr.mr_n61438528)
print v(xbgr.mr_n61438848)
print v(xbgr.mr_n61438960)
print v(xbgr.mr_n61439280)
print v(xbgr.mr_n61439392)
print v(xbgr.mr_n61439712)
print v(xbgr.mr_n61439824)
print v(xbgr.mr_n61440144)
print v(xbgr.mr_n61440256)
print v(xbgr.mr_n61440576)
print v(xbgr.mr_n61440688)
print v(xbgr.mr_n61441008)
print v(xbgr.mr_n61441120)
print v(xbgr.mr_n61441440)
print v(xbgr.mr_n61441552)
print v(xbgr.mr_n61441872)
print v(xbgr.mr_n61441984)
print v(xbgr.mr_n61442304)
print v(xbgr.mr_n61442416)
print v(xbgr.mr_n61442736)
print v(xbgr.mr_n61442848)
print v(xbgr.mr_n61443168)
print v(xbgr.mr_n61443280)
print v(xbgr.mr_n61443600)
print v(xbgr.mr_n61443712)
print v(xbgr.mr_n61444032)
print v(xbgr.mr_n61444144)
print v(xbgr.mr_n61444464)
print v(xbgr.mr_n61444576)
print v(xbgr.mr_n61445008)
print v(xbgr.mr_n61445328)
print v(xbgr.mr_n61445440)
print v(xbgr.mr_n61445760)
print v(xbgr.mr_n61445872)
print v(xbgr.mr_n61446192)
print v(xbgr.mr_n61446304)
print v(xbgr.mr_n61446736)
print v(xbgr.mr_n61447056)
print v(xbgr.mr_n61447168)
print v(xbgr.mr_n61447600)
print v(xbgr.mr_n61447920)
print v(xbgr.mr_n61448032)
print v(xbgr.mr_n61448352)
print v(xbgr.mr_n61448464)
print v(xbgr.mr_n61448784)
print v(xbgr.mr_n61448896)
print v(xbgr.mr_n61449216)
print v(xbgr.mr_n61449328)
print v(xbgr.mr_n61449648)
print v(xbgr.mr_n61449760)
print v(xbgr.mr_n61450080)
print v(xbgr.mr_n61450192)
print v(xbgr.mr_n61450512)
print v(xbgr.mr_n61450624)
print v(xbgr.mr_n61450944)
print v(xbgr.mr_n61451056)
print v(xbgr.mr_n61451376)
print v(xbgr.mr_n61451488)
print v(xbgr.mr_n61451808)
print v(xbgr.mr_n61451920)
print v(xbgr.mr_n61452240)
print v(xbgr.mr_n61452352)
print v(xbgr.mr_n61452672)
print v(xbgr.mr_n61452784)
print v(xbgr.mr_n61453104)
print v(xbgr.mr_n61453216)
print v(xbgr.mr_n61453536)
print v(xbgr.mr_n61453648)
print v(xbgr.mr_n61453968)
print v(xbgr.mr_n61454080)
print v(xbgr.mr_n61454400)
print v(xbgr.mr_n61454512)
print v(xbgr.mr_n61454832)
print v(xbgr.mr_n61454944)
print v(xbgr.mr_n61455264)
print v(xbgr.mr_n61455376)
print v(xbgr.mr_n61455696)
print v(xbgr.mr_n61455808)
print v(xbgr.mr_n61456128)
print v(xbgr.mr_n61456240)
print v(xbgr.mr_n61456560)
print v(xbgr.mr_n61456672)
print v(xbgr.mr_n61456992)
print v(xbgr.mr_n61457104)
print v(xbgr.mr_n61457424)
print v(xbgr.mr_n61457536)
print v(xbgr.mr_n61457856)
print v(xbgr.mr_n61457968)
print v(xbgr.mr_n61458288)
print v(xbgr.mr_n61458400)
print v(xbgr.mr_n61458720)
print v(xbgr.mr_n61458832)
print v(xbgr.mr_n61459152)
print v(xbgr.mr_n61459264)
print v(xbgr.mr_n61459584)
print v(xbgr.mr_n61459696)
print v(xbgr.mr_n61460016)
print v(xbgr.mr_n61460128)
print v(xbgr.mr_n61460448)
print v(xbgr.mr_n61460560)
print v(xbgr.mr_n61460880)
print v(xbgr.mr_n61460992)
print v(xbgr.mr_n61461312)
print v(xbgr.mr_n61461424)
print v(xbgr.mr_n61461744)
print v(xbgr.mr_n61461856)
print v(xbgr.mr_n61462176)
print v(xbgr.mr_n61462288)
print v(xbgr.mr_n61462608)
print v(xbgr.mr_n61462720)
print v(xbgr.mr_n61463040)
print v(xbgr.mr_n61463152)
print v(xbgr.mr_n61463472)
print v(xbgr.mr_n61463584)
print v(xbgr.mr_n61463904)
print v(xbgr.mr_n61464016)
print v(xbgr.mr_n61464336)
print v(xbgr.mr_n61464448)
print v(xbgr.mr_n61464768)
print v(xbgr.mr_n61464880)
print v(xbgr.mr_n61465200)
print v(xbgr.mr_n61465312)
print v(xbgr.mr_n61465632)
print v(xbgr.mr_n61465744)
print v(xbgr.mr_n61466064)
print v(xbgr.mr_n61466176)
print v(xbgr.mr_n61466496)
print v(xbgr.mr_n61466608)
print v(xbgr.mr_n61466928)
print v(xbgr.mr_n61467040)
print v(xbgr.mr_n61467360)
print v(xbgr.mr_n61467472)
print v(xbgr.mr_n61467792)
print v(xbgr.mr_n61467904)
print v(xbgr.mr_n61468224)
print v(xbgr.mr_n61468336)
print v(xbgr.mr_n61468656)
print v(xbgr.mr_n61468768)
print v(xbgr.mr_n61469088)
print v(xbgr.mr_n61469200)
print v(xbgr.mr_n61469520)
print v(xbgr.mr_n61469632)
print v(xbgr.mr_n61469952)
print v(xbgr.mr_n61470064)
print v(xbgr.mr_n61470384)
print v(xbgr.mr_n61470496)
print v(xbgr.mr_n61470816)
print v(xbgr.mr_n61470928)
print v(xbgr.mr_n61471248)
print v(xbgr.mr_n61471360)
print v(xbgr.mr_n61471680)
print v(xbgr.mr_n61471792)
print v(xbgr.mr_n61472112)
print v(xbgr.mr_n61472224)
print v(xbgr.mr_n61472544)
print v(xbgr.mr_n61472656)
print v(xbgr.mr_n61472976)
print v(xbgr.mr_n61473088)
print v(xbgr.mr_n61473408)
print v(xbgr.mr_n61473520)
print v(xbgr.mr_n61473840)
print v(xbgr.mr_n61473952)
print v(xbgr.mr_n61474272)
print v(xbgr.mr_n61474384)
print v(xbgr.mr_n61474704)
print v(xbgr.mr_n61474816)
print v(xbgr.mr_n61475136)
print v(xbgr.mr_n61475248)
print v(xbgr.mr_n61475568)
print v(xbgr.mr_n61475680)
print v(xbgr.mr_n61476000)
print v(xbgr.mr_n61476112)
print v(xbgr.mr_n61476432)
print v(xbgr.mr_n61476544)
print v(xbgr.mr_n61476864)
print v(xbgr.mr_n61476976)
print v(xbgr.mr_n61477296)
print v(xbgr.mr_n61477408)
print v(xbgr.mr_n61477728)
print v(xbgr.mr_n61477840)
print v(xbgr.mr_n61478160)
print v(xbgr.mr_n61478272)
print v(xbgr.mr_n61478592)
print v(xbgr.mr_n61478704)
print v(xbgr.mr_n61479024)
print v(xbgr.mr_n61479136)
print v(xbgr.mr_n61479456)
print v(xbgr.mr_n61479568)
print v(xbgr.mr_n61479888)
print v(xbgr.mr_n61480000)
print v(xbgr.mr_n61480320)
print v(xbgr.mr_n61480432)
print v(xbgr.mr_n61480752)
print v(xbgr.mr_n61480864)
print v(xbgr.mr_n61481184)
print v(xbgr.mr_n61481296)
print v(xbgr.mr_n61481616)
print v(xbgr.mr_n61481728)
print v(xbgr.mr_n61482048)
print v(xbgr.mr_n61482160)
print v(xbgr.mr_n61482480)
print v(xbgr.mr_n61482592)
print v(xbgr.mr_n61482912)
print v(xbgr.mr_n61483024)
print v(xbgr.mr_n61483344)
print v(xbgr.mr_n61483456)
print v(xbgr.mr_n61483776)
print v(xbgr.mr_n61483888)
print v(xbgr.mr_n61484208)
print v(xbgr.mr_n61484320)
print v(xbgr.mr_n61484640)
print v(xbgr.mr_n61484752)
print v(xbgr.mr_n61485072)
print v(xbgr.mr_n61485184)
print v(xbgr.mr_n61485504)
print v(xbgr.mr_n61485616)
print v(xbgr.mr_n61485936)
print v(xbgr.mr_n61486048)
print v(xbgr.mr_n61486368)
print v(xbgr.mr_n61486480)
print v(xbgr.mr_n61486800)
print v(xbgr.mr_n61486912)
print v(xbgr.mr_n61487232)
print v(xbgr.mr_n61487344)
print v(xbgr.mr_n61487664)
print v(xbgr.mr_n61487776)
print v(xbgr.mr_n61488096)
print v(xbgr.mr_n61488208)
print v(xbgr.mr_n61488528)
print v(xbgr.mr_n61488640)
print v(xbgr.mr_n61488960)
print v(xbgr.mr_n61489072)
print v(xbgr.mr_n61489392)
print v(xbgr.mr_n61489504)
print v(xbgr.mr_n61489824)
print v(xbgr.mr_n61489936)
print v(xbgr.mr_n61490256)
print v(xbgr.mr_n61490368)
print v(xbgr.mr_n61490688)
print v(xbgr.mr_n61490800)
print v(xbgr.mr_n61491120)
print v(xbgr.mr_n61491232)
print v(xbgr.mr_n61491552)
print v(xbgr.mr_n61491664)
print v(xbgr.mr_n61491984)
print v(xbgr.mr_n61492096)
print v(xbgr.mr_n61492416)
print v(xbgr.mr_n61492528)
print v(xbgr.mr_n61492848)
print v(xbgr.mr_n61492960)
print v(xbgr.mr_n61493280)
print v(xbgr.mr_n61493392)
print v(xbgr.mr_n61493712)
print v(xbgr.mr_n61493824)
print v(xbgr.mr_n61494144)
print v(xbgr.mr_n61494256)
print v(xbgr.mr_n61494576)
print v(xbgr.mr_n61494688)
print v(xbgr.mr_n61495008)
print v(xbgr.mr_n61495120)
print v(xbgr.mr_n61495440)
print v(xbgr.mr_n61495552)
print v(xbgr.mr_n61495872)
print v(xbgr.mr_n61495984)
print v(xbgr.mr_n61496304)
print v(xbgr.mr_n61496416)
print v(xbgr.mr_n61496736)
print v(xbgr.mr_n61496848)
print v(xbgr.mr_n61497168)
print v(xbgr.mr_n61497280)
print v(xbgr.mr_n61497600)
print v(xbgr.mr_n61497712)
print v(xbgr.mr_n61498032)
print v(xbgr.mr_n61498144)
print v(xbgr.mr_n61498464)
print v(xbgr.mr_n61498576)
print v(xbgr.mr_n61498896)
print v(xbgr.mr_n61499008)
print v(xbgr.mr_n61499328)
print v(xbgr.mr_n61499440)
print v(xbgr.mr_n61499760)
print v(xbgr.mr_n61499872)
print v(xbgr.mr_n61500192)
print v(xbgr.mr_n61500304)
print v(xbgr.mr_n61500624)
print v(xbgr.mr_n61500736)
print v(xbgr.mr_n61501056)
print v(xbgr.mr_n61501168)
print v(xbgr.mr_n61501488)
print v(xbgr.mr_n61501600)
print v(xbgr.mr_n61501920)
print v(xbgr.mr_n61502032)
print v(xbgr.mr_n61502352)
print v(xbgr.mr_n61502464)
print v(xbgr.mr_n61502784)
print v(xbgr.mr_n61502896)
print v(xbgr.mr_n61503216)
print v(xbgr.mr_n61503328)
print v(xbgr.mr_n61503648)
print v(xbgr.mr_n61503760)
print v(xbgr.mr_n61504080)
print v(xbgr.mr_n61504192)
print v(xbgr.mr_n61504512)
print v(xbgr.mr_n61504624)
print v(xbgr.mr_n61504944)
print v(xbgr.mr_n61505056)
print v(xbgr.mr_n61505376)
print v(xbgr.mr_n61505488)
print v(xbgr.mr_n61505808)
print v(xbgr.mr_n61505920)
print v(xbgr.mr_n61506240)
print v(xbgr.mr_n61506352)
print v(xbgr.mr_n61506672)
print v(xbgr.mr_n61506784)
print v(xbgr.mr_n61507104)
print v(xbgr.mr_n61507216)
print v(xbgr.mr_n61507536)
print v(xbgr.mr_n61507648)
print v(xbgr.mr_n61507968)
print v(xbgr.mr_n61508080)
print v(xbgr.mr_n61508400)
print v(xbgr.mr_n61508512)
print v(xbgr.mr_n61508832)
print v(xbgr.mr_n61508944)
print v(xbgr.mr_n61509264)
print v(xbgr.mr_n61509376)
print v(xbgr.mr_n61509696)
print v(xbgr.mr_n61509808)
print v(xbgr.mr_n61510128)
print v(xbgr.mr_n61510240)
print v(xbgr.mr_n61510560)
print v(xbgr.mr_n61510672)
print v(xbgr.mr_n61510992)
print v(xbgr.mr_n61511104)
print v(xbgr.mr_n61511424)
print v(xbgr.mr_n61511536)
print v(xbgr.mr_n61511856)
print v(xbgr.mr_n61511968)
print v(xbgr.mr_n61512288)
print v(xbgr.mr_n61512400)
print v(xbgr.mr_n61512720)
print v(xbgr.mr_n61512832)
print v(xbgr.mr_n61513152)
print v(xbgr.mr_n61513264)
print v(xbgr.mr_n61513584)
print v(xbgr.mr_n61513696)
print v(xbgr.mr_n61514016)
print v(xbgr.mr_n61514128)
print v(xbgr.mr_n61514448)
print v(xbgr.mr_n61514560)
print v(xbgr.mr_n61514880)
print v(xbgr.mr_n61514992)
print v(xbgr.mr_n61515312)
print v(xbgr.mr_n61515424)
print v(xbgr.mr_n61515744)
print v(xbgr.mr_n61515856)
print v(xbgr.mr_n61516176)
print v(xbgr.mr_n61516288)
print v(xbgr.mr_n61516608)
print v(xbgr.mr_n61516720)
print v(xbgr.mr_n61517040)
print v(xbgr.mr_n61517152)
print v(xbgr.mr_n61517472)
print v(xbgr.mr_n61517584)
print v(xbgr.mr_n61517904)
print v(xbgr.mr_n61518016)
print v(xbgr.mr_n61518336)
print v(xbgr.mr_n61518448)
print v(xbgr.mr_n61518768)
print v(xbgr.mr_n61518880)
print v(xbgr.mr_n61519200)
print v(xbgr.mr_n61519312)
print v(xbgr.mr_n61519632)
print v(xbgr.mr_n61519744)
print v(xbgr.mr_n61520064)
print v(xbgr.mr_n61520176)
print v(xbgr.mr_n61520496)
print v(xbgr.mr_n61520608)
print v(xbgr.mr_n61520928)
print v(xbgr.mr_n61521040)
print v(xbgr.mr_n61521360)
print v(xbgr.mr_n61521472)
print v(xbgr.mr_n61521792)
print v(xbgr.mr_n61521904)
print v(xbgr.mr_n61522224)
print v(xbgr.mr_n61522336)
print v(xbgr.mr_n61522656)
print v(xbgr.mr_n61522768)
print v(xbgr.mr_n61523088)
print v(xbgr.mr_n61523200)
print v(xbgr.mr_n61523520)
print v(xbgr.mr_n61523632)
print v(xbgr.mr_n61523952)
print v(xbgr.mr_n61524064)
print v(xbgr.mr_n61524384)
print v(xbgr.mr_n61524496)
print v(xbgr.mr_n61524816)
print v(xbgr.mr_n61524928)
print v(xbgr.mr_n61525248)
print v(xbgr.mr_n61525360)
print v(xbgr.mr_n61525680)
print v(xbgr.mr_n61525792)
print v(xbgr.mr_n61526112)
print v(xbgr.mr_n61526224)
print v(xbgr.mr_n61526544)
print v(xbgr.mr_n61526656)
print v(xbgr.mr_n61526976)
print v(xbgr.mr_n61527088)
print v(xbgr.mr_n61527408)
print v(xbgr.mr_n61527520)
print v(xbgr.mr_n61527840)
print v(xbgr.mr_n61527952)
print v(xbgr.mr_n61528272)
print v(xbgr.mr_n61528384)
print v(xbgr.mr_n61528704)
print v(xbgr.mr_n61528816)
print v(xbgr.mr_n61529136)
print v(xbgr.mr_n61529248)
print v(xbgr.mr_n61529568)
print v(xbgr.mr_n61529680)
print v(xbgr.mr_n61530000)
print v(xbgr.mr_n61530112)
print v(xbgr.mr_n61530432)
print v(xbgr.mr_n61530544)
print v(xbgr.mr_n61530864)
print v(xbgr.mr_n61530976)
print v(xbgr.mr_n61531296)
print v(xbgr.mr_n61531408)
print v(xbgr.mr_n61531728)
print v(xbgr.mr_n61531840)
print v(xbgr.mr_n61532160)
print v(xbgr.mr_n61532272)
print v(xbgr.mr_n61532592)
print v(xbgr.mr_n61532704)
print v(xbgr.mr_n61533024)
print v(xbgr.mr_n61533136)
print v(xbgr.mr_n61533456)
print v(xbgr.mr_n61533568)
print v(xbgr.mr_n61533888)
print v(xbgr.mr_n61534000)
print v(xbgr.mr_n61534320)
print v(xbgr.mr_n61534432)
print v(xbgr.mr_n61534752)
print v(xbgr.mr_n61534864)
print v(xbgr.mr_n61535184)
print v(xbgr.mr_n61535296)
print v(xbgr.mr_n61535616)
print v(xbgr.mr_n61535728)
print v(xbgr.mr_n61536048)
print v(xbgr.mr_n61536160)
print v(xbgr.mr_n61536480)
print v(xbgr.mr_n61536592)
print v(xbgr.mr_n61536912)
print v(xbgr.mr_n61537024)
print v(xbgr.mr_n61537344)
print v(xbgr.mr_n61537456)
print v(xbgr.mr_n61537776)
print v(xbgr.mr_n61537888)
print v(xbgr.mr_n61603760)
print v(xbgr.mr_n61603872)
print v(xbgr.mr_n61604192)
print v(xbgr.mr_n61604304)
print v(xbgr.mr_n61604624)
print v(xbgr.mr_n61604736)
print v(xbgr.mr_n61605168)
print v(xbgr.mr_n61605488)
print v(xbgr.mr_n61605600)
print v(xbgr.mr_n61605920)
print v(xbgr.mr_n61606032)
print v(xbgr.mr_n61606464)
print v(xbgr.mr_n61606896)
print v(xbgr.mr_n61607216)
print v(xbgr.mr_n61607328)
print v(xbgr.mr_n61607648)
print v(xbgr.mr_n61607760)
print v(xbgr.mr_n61608080)
print v(xbgr.mr_n61608192)
print v(xbgr.mr_n61608512)
print v(xbgr.mr_n61608624)
print v(xbgr.mr_n61608944)
print v(xbgr.mr_n61609056)
print v(xbgr.mr_n61609376)
print v(xbgr.mr_n61609488)
print v(xbgr.mr_n61609808)
print v(xbgr.mr_n61609920)
print v(xbgr.mr_n61610240)
print v(xbgr.mr_n61610352)
print v(xbgr.mr_n61610672)
print v(xbgr.mr_n61610784)
print v(xbgr.mr_n61611104)
print v(xbgr.mr_n61611216)
print v(xbgr.mr_n61611536)
print v(xbgr.mr_n61611648)
print v(xbgr.mr_n61611968)
print v(xbgr.mr_n61612080)
print v(xbgr.mr_n61612512)
print v(xbgr.mr_n61612832)
print v(xbgr.mr_n61612944)
print v(xbgr.mr_n61613264)
print v(xbgr.mr_n61613376)
print v(xbgr.mr_n61613696)
print v(xbgr.mr_n61613808)
print v(xbgr.mr_n61614128)
print v(xbgr.mr_n61614240)
print v(xbgr.mr_n61614560)
print v(xbgr.mr_n61614672)
print v(xbgr.mr_n61614992)
print v(xbgr.mr_n61615104)
print v(xbgr.mr_n61615424)
print v(xbgr.mr_n61615536)
print v(xbgr.mr_n61615856)
print v(xbgr.mr_n61615968)
print v(xbgr.mr_n61616288)
print v(xbgr.mr_n61616400)
print v(xbgr.mr_n61616720)
print v(xbgr.mr_n61616832)
print v(xbgr.mr_n61617264)
print v(xbgr.mr_n61617696)
print v(xbgr.mr_n61618016)
print v(xbgr.mr_n61618128)
print v(xbgr.mr_n61618448)
print v(xbgr.mr_n61618560)
print v(xbgr.mr_n61618880)
print v(xbgr.mr_n61618992)
print v(xbgr.mr_n61619312)
print v(xbgr.mr_n61619424)
print v(xbgr.mr_n61619744)
print v(xbgr.mr_n61619856)
print v(xbgr.mr_n61620176)
print v(xbgr.mr_n61620288)
print v(xbgr.mr_n61620608)
print v(xbgr.mr_n61620720)
print v(xbgr.mr_n61621040)
print v(xbgr.mr_n61621152)
print v(xbgr.mr_n61621472)
print v(xbgr.mr_n61621584)
print v(xbgr.mr_n61621904)
print v(xbgr.mr_n61622016)
print v(xbgr.mr_n61622336)
print v(xbgr.mr_n61622448)
print v(xbgr.mr_n61622768)
print v(xbgr.mr_n61622880)
print v(xbgr.mr_n61623200)
print v(xbgr.mr_n61623312)
print v(xbgr.mr_n61623632)
print v(xbgr.mr_n61623744)
print v(xbgr.mr_n61624064)
print v(xbgr.mr_n61624176)
print v(xbgr.mr_n61624496)
print v(xbgr.mr_n61624608)
print v(xbgr.mr_n61624928)
print v(xbgr.mr_n61625040)
print v(xbgr.mr_n61625360)
print v(xbgr.mr_n61625472)
print v(xbgr.mr_n61625792)
print v(xbgr.mr_n61625904)
print v(xbgr.mr_n61626224)
print v(xbgr.mr_n61626336)
print v(xbgr.mr_n61626656)
print v(xbgr.mr_n61626768)
print v(xbgr.mr_n61627088)
print v(xbgr.mr_n61627200)
print v(xbgr.mr_n61627520)
print v(xbgr.mr_n61627632)
print v(xbgr.mr_n61627952)
print v(xbgr.mr_n61628064)
print v(xbgr.mr_n61628384)
print v(xbgr.mr_n61628496)
print v(xbgr.mr_n61628816)
print v(xbgr.mr_n61628928)
print v(xbgr.mr_n61629248)
print v(xbgr.mr_n61629360)
print v(xbgr.mr_n61629680)
print v(xbgr.mr_n61629792)
print v(xbgr.mr_n61630112)
print v(xbgr.mr_n61630224)
print v(xbgr.mr_n61630544)
print v(xbgr.mr_n61630656)
print v(xbgr.mr_n61630976)
print v(xbgr.mr_n61631088)
print v(xbgr.mr_n61631408)
print v(xbgr.mr_n61631520)
print v(xbgr.mr_n61631840)
print v(xbgr.mr_n61631952)
print v(xbgr.mr_n61632272)
print v(xbgr.mr_n61632384)
print v(xbgr.mr_n61632704)
print v(xbgr.mr_n61632816)
print v(xbgr.mr_n61633136)
print v(xbgr.mr_n61633248)
print v(xbgr.mr_n61633568)
print v(xbgr.mr_n61633680)
print v(xbgr.mr_n61634000)
print v(xbgr.mr_n61634112)
print v(xbgr.mr_n61634432)
print v(xbgr.mr_n61634544)
print v(xbgr.mr_n61634864)
print v(xbgr.mr_n61634976)
print v(xbgr.mr_n61635296)
print v(xbgr.mr_n61635408)
print v(xbgr.mr_n61635728)
print v(xbgr.mr_n61635840)
print v(xbgr.mr_n61636160)
print v(xbgr.mr_n61636272)
print v(xbgr.mr_n61636592)
print v(xbgr.mr_n61636704)
print v(xbgr.mr_n61637024)
print v(xbgr.mr_n61637136)
print v(xbgr.mr_n61637456)
print v(xbgr.mr_n61637568)
print v(xbgr.mr_n61637888)
print v(xbgr.mr_n61638000)
print v(xbgr.mr_n61638320)
print v(xbgr.mr_n61638432)
print v(xbgr.mr_n61638752)
print v(xbgr.mr_n61638864)
print v(xbgr.mr_n61639184)
print v(xbgr.mr_n61639296)
print v(xbgr.mr_n61639616)
print v(xbgr.mr_n61639728)
print v(xbgr.mr_n61640048)
print v(xbgr.mr_n61640160)
print v(xbgr.mr_n61640480)
print v(xbgr.mr_n61640592)
print v(xbgr.mr_n61640912)
print v(xbgr.mr_n61641024)
print v(xbgr.mr_n61641344)
print v(xbgr.mr_n61641456)
print v(xbgr.mr_n61641776)
print v(xbgr.mr_n61641888)
print v(xbgr.mr_n61642208)
print v(xbgr.mr_n61642320)
print v(xbgr.mr_n61642640)
print v(xbgr.mr_n61642752)
print v(xbgr.mr_n61643072)
print v(xbgr.mr_n61643184)
print v(xbgr.mr_n61643504)
print v(xbgr.mr_n61643616)
print v(xbgr.mr_n61643936)
print v(xbgr.mr_n61644048)
print v(xbgr.mr_n61644368)
print v(xbgr.mr_n61644480)
print v(xbgr.mr_n61644800)
print v(xbgr.mr_n61644912)
print v(xbgr.mr_n61645232)
print v(xbgr.mr_n61645344)
print v(xbgr.mr_n61645664)
print v(xbgr.mr_n61645776)
print v(xbgr.mr_n61646096)
print v(xbgr.mr_n61646208)
print v(xbgr.mr_n61646528)
print v(xbgr.mr_n61646640)
print v(xbgr.mr_n61646960)
print v(xbgr.mr_n61647072)
print v(xbgr.mr_n61647392)
print v(xbgr.mr_n61647504)
print v(xbgr.mr_n61647824)
print v(xbgr.mr_n61647936)
print v(xbgr.mr_n61648256)
print v(xbgr.mr_n61648368)
print v(xbgr.mr_n61648688)
print v(xbgr.mr_n61648800)
print v(xbgr.mr_n61649120)
print v(xbgr.mr_n61649232)
print v(xbgr.mr_n61649552)
print v(xbgr.mr_n61649664)
print v(xbgr.mr_n61649984)
print v(xbgr.mr_n61650096)
print v(xbgr.mr_n61650416)
print v(xbgr.mr_n61650528)
print v(xbgr.mr_n61650848)
print v(xbgr.mr_n61650960)
print v(xbgr.mr_n61651280)
print v(xbgr.mr_n61651392)
print v(xbgr.mr_n61651712)
print v(xbgr.mr_n61651824)
print v(xbgr.mr_n61652144)
print v(xbgr.mr_n61652256)
print v(xbgr.mr_n61652576)
print v(xbgr.mr_n61652688)
print v(xbgr.mr_n61653008)
print v(xbgr.mr_n61653120)
print v(xbgr.mr_n61653440)
print v(xbgr.mr_n61653552)
print v(xbgr.mr_n61653872)
print v(xbgr.mr_n61653984)
print v(xbgr.mr_n61654304)
print v(xbgr.mr_n61654416)
print v(xbgr.mr_n61654736)
print v(xbgr.mr_n61654848)
print v(xbgr.mr_n61655168)
print v(xbgr.mr_n61655280)
print v(xbgr.mr_n61655600)
print v(xbgr.mr_n61655712)
print v(xbgr.mr_n61656032)
print v(xbgr.mr_n61656144)
print v(xbgr.mr_n61656464)
print v(xbgr.mr_n61656576)
print v(xbgr.mr_n61656896)
print v(xbgr.mr_n61657008)
print v(xbgr.mr_n61657328)
print v(xbgr.mr_n61657440)
print v(xbgr.mr_n61657760)
print v(xbgr.mr_n61657872)
print v(xbgr.mr_n61658192)
print v(xbgr.mr_n61658304)
print v(xbgr.mr_n61658624)
print v(xbgr.mr_n61658736)
print v(xbgr.mr_n61659056)
print v(xbgr.mr_n61659168)
print v(xbgr.mr_n61659488)
print v(xbgr.mr_n61659600)
print v(xbgr.mr_n61659920)
print v(xbgr.mr_n61660032)
print v(xbgr.mr_n61660352)
print v(xbgr.mr_n61660464)
print v(xbgr.mr_n61660784)
print v(xbgr.mr_n61660896)
print v(xbgr.mr_n61661216)
print v(xbgr.mr_n61661328)
print v(xbgr.mr_n61661648)
print v(xbgr.mr_n61661760)
print v(xbgr.mr_n61662080)
print v(xbgr.mr_n61662192)
print v(xbgr.mr_n61662512)
print v(xbgr.mr_n61662624)
print v(xbgr.mr_n61662944)
print v(xbgr.mr_n61663056)
print v(xbgr.mr_n61663376)
print v(xbgr.mr_n61663488)
print v(xbgr.mr_n61663808)
print v(xbgr.mr_n61663920)
print v(xbgr.mr_n61664240)
print v(xbgr.mr_n61664352)
print v(xbgr.mr_n61664672)
print v(xbgr.mr_n61664784)
print v(xbgr.mr_n61665104)
print v(xbgr.mr_n61665216)
print v(xbgr.mr_n61665536)
print v(xbgr.mr_n61665648)
print v(xbgr.mr_n61665968)
print v(xbgr.mr_n61666080)
print v(xbgr.mr_n61666400)
print v(xbgr.mr_n61666512)
print v(xbgr.mr_n61666832)
print v(xbgr.mr_n61666944)
print v(xbgr.mr_n61667264)
print v(xbgr.mr_n61667376)
print v(xbgr.mr_n61667696)
print v(xbgr.mr_n61667808)
print v(xbgr.mr_n61668128)
print v(xbgr.mr_n61668240)
print v(xbgr.mr_n61668560)
print v(xbgr.mr_n61668672)
print v(xbgr.mr_n61668992)
print v(xbgr.mr_n61669104)
print v(xbgr.mr_n61669424)
print v(xbgr.mr_n61669536)
print v(xbgr.mr_n61669856)
print v(xbgr.mr_n61669968)
print v(xbgr.mr_n61670288)
print v(xbgr.mr_n61670400)
print v(xbgr.mr_n61670720)
print v(xbgr.mr_n61670832)
print v(xbgr.mr_n61671152)
print v(xbgr.mr_n61671264)
print v(xbgr.mr_n61671584)
print v(xbgr.mr_n61671696)
print v(xbgr.mr_n61672016)
print v(xbgr.mr_n61672128)
print v(xbgr.mr_n61672448)
print v(xbgr.mr_n61672560)
print v(xbgr.mr_n61672880)
print v(xbgr.mr_n61672992)
print v(xbgr.mr_n61673312)
print v(xbgr.mr_n61673424)
print v(xbgr.mr_n61673744)
print v(xbgr.mr_n61673856)
print v(xbgr.mr_n61674176)
print v(xbgr.mr_n61674288)
print v(xbgr.mr_n61674608)
print v(xbgr.mr_n61674720)
print v(xbgr.mr_n61675040)
print v(xbgr.mr_n61675152)
print v(xbgr.mr_n61675472)
print v(xbgr.mr_n61675584)
print v(xbgr.mr_n61675904)
print v(xbgr.mr_n61676016)
print v(xbgr.mr_n61676336)
print v(xbgr.mr_n61676448)
print v(xbgr.mr_n61676768)
print v(xbgr.mr_n61676880)
print v(xbgr.mr_n61677200)
print v(xbgr.mr_n61677312)
print v(xbgr.mr_n61677632)
print v(xbgr.mr_n61677744)
print v(xbgr.mr_n61678064)
print v(xbgr.mr_n61678176)
print v(xbgr.mr_n61678496)
print v(xbgr.mr_n61678608)
print v(xbgr.mr_n61678928)
print v(xbgr.mr_n61679040)
print v(xbgr.mr_n61679360)
print v(xbgr.mr_n61679472)
print v(xbgr.mr_n61679792)
print v(xbgr.mr_n61679904)
print v(xbgr.mr_n61680224)
print v(xbgr.mr_n61680336)
print v(xbgr.mr_n61680656)
print v(xbgr.mr_n61680768)
print v(xbgr.mr_n61681088)
print v(xbgr.mr_n61681200)
print v(xbgr.mr_n61681520)
print v(xbgr.mr_n61681632)
print v(xbgr.mr_n61681952)
print v(xbgr.mr_n61682064)
print v(xbgr.mr_n61682384)
print v(xbgr.mr_n61682496)
print v(xbgr.mr_n61682816)
print v(xbgr.mr_n61682928)
print v(xbgr.mr_n61683248)
print v(xbgr.mr_n61683360)
print v(xbgr.mr_n61683680)
print v(xbgr.mr_n61683792)
print v(xbgr.mr_n61684112)
print v(xbgr.mr_n61684224)
print v(xbgr.mr_n61684544)
print v(xbgr.mr_n61684656)
print v(xbgr.mr_n61684976)
print v(xbgr.mr_n61685088)
print v(xbgr.mr_n61685408)
print v(xbgr.mr_n61685520)
print v(xbgr.mr_n61685952)
print v(xbgr.mr_n61686272)
print v(xbgr.mr_n61686384)
print v(xbgr.mr_n61686704)
print v(xbgr.mr_n61686816)
print v(xbgr.mr_n61687136)
print v(xbgr.mr_n61687248)
print v(xbgr.mr_n61687568)
print v(xbgr.mr_n61687680)
print v(xbgr.mr_n61688000)
print v(xbgr.mr_n61688864)
print v(xbgr.mr_n61688976)
print v(xbgr.mr_n61689296)
print v(xbgr.mr_n61689408)
print v(xbgr.mr_n61689728)
print v(xbgr.mr_n61689840)
print v(xbgr.mr_n61690160)
print v(xbgr.mr_n61690272)
print v(xbgr.mr_n61690592)
print v(xbgr.mr_n61690704)
print v(xbgr.mr_n61691136)
print v(xbgr.mr_n61691456)
print v(xbgr.mr_n61691568)
print v(xbgr.mr_n61691888)
print v(xbgr.mr_n61692000)
print v(xbgr.mr_n61692320)
print v(xbgr.mr_n61692432)
print v(xbgr.mr_n61692752)
print v(xbgr.mr_n61692864)
print v(xbgr.mr_n61693184)
print v(xbgr.mr_n61693296)
print v(xbgr.mr_n61693728)
print v(xbgr.mr_n61694048)
print v(xbgr.mr_n61694912)
print v(xbgr.mr_n61695024)
print v(xbgr.mr_n61695456)
print v(xbgr.mr_n61695776)
print v(xbgr.mr_n61696640)
print v(xbgr.mr_n61696752)
print v(xbgr.mr_n61697184)
print v(xbgr.mr_n61697504)
print v(xbgr.mr_n61697616)
print v(xbgr.mr_n61697936)
print v(xbgr.mr_n61698048)
print v(xbgr.mr_n61698368)
print v(xbgr.mr_n61698480)
print v(xbgr.mr_n61698800)
print v(xbgr.mr_n61698912)
print v(xbgr.mr_n61699232)
print v(xbgr.mr_n61699344)
print v(xbgr.mr_n61699664)
print v(xbgr.mr_n61699776)
print v(xbgr.mr_n61700096)
print v(xbgr.mr_n61700960)
print v(xbgr.mr_n61701072)
print v(xbgr.mr_n61701392)
print v(xbgr.mr_n61701504)
print v(xbgr.mr_n61701824)
print v(xbgr.mr_n61702688)
print v(xbgr.mr_n61702800)
print v(xbgr.mr_n61703120)
print v(xbgr.mr_n61703232)
print v(xbgr.mr_n61703552)
print v(xbgr.mr_n61703664)
print v(xbgr.mr_n61703984)
print v(xbgr.mr_n61704096)
print v(xbgr.mr_n61704416)
print v(xbgr.mr_n61704528)
print v(xbgr.mr_n61704848)
print v(xbgr.mr_n61704960)
print v(xbgr.mr_n61705280)
print v(xbgr.mr_n61705392)
print v(xbgr.mr_n61705712)
print v(xbgr.mr_n61705824)
print v(xbgr.mr_n61706144)
print v(xbgr.mr_n61706256)
print v(xbgr.mr_n61706576)
print v(xbgr.mr_n61706688)
print v(xbgr.mr_n61707008)
print v(xbgr.mr_n61707120)
print v(xbgr.mr_n61707440)
print v(xbgr.mr_n61707552)
print v(xbgr.mr_n61707872)
print v(xbgr.mr_n61707984)
print v(xbgr.mr_n61708304)
print v(xbgr.mr_n61708416)
print v(xbgr.mr_n61708736)
print v(xbgr.mr_n61708848)
print v(xbgr.mr_n61709168)
print v(xbgr.mr_n61709280)
print v(xbgr.mr_n61709600)
print v(xbgr.mr_n61709712)
print v(xbgr.mr_n61710032)
print v(xbgr.mr_n61710144)
print v(xbgr.mr_n61710464)
print v(xbgr.mr_n61710576)
print v(xbgr.mr_n61710896)
print v(xbgr.mr_n61711008)
print v(xbgr.mr_n61711328)
print v(xbgr.mr_n61711440)
print v(xbgr.mr_n61711760)
print v(xbgr.mr_n61711872)
print v(xbgr.mr_n61712192)
print v(xbgr.mr_n61712304)
print v(xbgr.mr_n61712624)
print v(xbgr.mr_n61712736)
print v(xbgr.mr_n61713056)
print v(xbgr.mr_n61713168)
print v(xbgr.mr_n61713488)
print v(xbgr.mr_n61713600)
print v(xbgr.mr_n61714032)
print v(xbgr.mr_n61714464)
print v(xbgr.mr_n61714896)
print v(xbgr.mr_n61715328)
print v(xbgr.mr_n61715760)
print v(xbgr.mr_n61716192)
print v(xbgr.mr_n61716624)
print v(xbgr.mr_n61717056)
print v(xbgr.mr_n61717488)
print v(xbgr.mr_n61717920)
print v(xbgr.mr_n61718352)
print v(xbgr.mr_n61718784)
print v(xbgr.mr_n61719216)
print v(xbgr.mr_n61719648)
print v(xbgr.mr_n61720080)
print v(xbgr.mr_n61720512)
print v(xbgr.mr_n61720944)
print v(xbgr.mr_n61721376)
print v(xbgr.mr_n61721808)
print v(xbgr.mr_n61722240)
print v(xbgr.mr_n61722672)
print v(xbgr.mr_n61723104)
print v(xbgr.mr_n61723424)
print v(xbgr.mr_n61723536)
print v(xbgr.mr_n61723968)
print v(xbgr.mr_n61724400)
print v(xbgr.mr_n61724832)
print v(xbgr.mr_n61725264)
print v(xbgr.mr_n61725696)
print v(xbgr.mr_n61726128)
print v(xbgr.mr_n61726560)
print v(xbgr.mr_n61726992)
print v(xbgr.mr_n61727424)
print v(xbgr.mr_n61727856)
print v(xbgr.mr_n61728288)
print v(xbgr.mr_n61728720)
print v(xbgr.mr_n61729152)
print v(xbgr.mr_n61729584)
print v(xbgr.mr_n61730016)
print v(xbgr.mr_n61730448)
print v(xbgr.mr_n61730880)
print v(xbgr.mr_n61731312)
print v(xbgr.mr_n61731744)
print v(xbgr.mr_n61732176)
print v(xbgr.mr_n61732608)
print v(xbgr.mr_n61733040)
print v(xbgr.mr_n61733472)
print v(xbgr.mr_n61733904)
print v(xbgr.mr_n61734336)
print v(xbgr.mr_n61734768)
print v(xbgr.mr_n61735200)
print v(xbgr.mr_n61735632)
print v(xbgr.mr_n61736064)
print v(xbgr.mr_n61736496)
print v(xbgr.mr_n61736928)
print v(xbgr.mr_n61737360)
print v(xbgr.mr_n61737792)
print v(xbgr.mr_n61738224)
print v(xbgr.mr_n61738656)
print v(xbgr.mr_n61739088)
print v(xbgr.mr_n61739520)
print v(xbgr.mr_n61739952)
print v(xbgr.mr_n61740384)
print v(xbgr.mr_n61740816)
print v(xbgr.mr_n61741248)
print v(xbgr.mr_n61741680)
print v(xbgr.mr_n61742112)
print v(xbgr.mr_n61742544)
print v(xbgr.mr_n61742976)
print v(xbgr.mr_n61743408)
print v(xbgr.mr_n61743840)
print v(xbgr.mr_n61744272)
print v(xbgr.mr_n61744704)
print v(xbgr.mr_n61745136)
print v(xbgr.mr_n61745568)
print v(xbgr.mr_n61746000)
print v(xbgr.mr_n61746432)
print v(xbgr.mr_n61746864)
print v(xbgr.mr_n61747296)
print v(xbgr.mr_n61747728)
print v(xbgr.mr_n61748160)
print v(xbgr.mr_n61748592)
print v(xbgr.mr_n61749024)
print v(xbgr.mr_n61749456)
print v(xbgr.mr_n61749888)
print v(xbgr.mr_n61750320)
print v(xbgr.mr_n61750752)
print v(xbgr.mr_n61751072)
print v(xbgr.mr_n61751184)
print v(xbgr.mr_n61751504)
print v(xbgr.mr_n61751616)
print v(xbgr.mr_n61751936)
print v(xbgr.mr_n61752048)
print v(xbgr.mr_n61752368)
print v(xbgr.mr_n61752480)
print v(xbgr.mr_n61752800)
print v(xbgr.mr_n61752912)
print v(xbgr.mr_n61753232)
print v(xbgr.mr_n61753344)
print v(xbgr.mr_n61753664)
print v(xbgr.mr_n61753776)
print v(xbgr.mr_n61754096)
print v(xbgr.mr_n61754208)
print v(xbgr.mr_n61754528)
print v(xbgr.mr_n61754640)
print v(xbgr.mr_n61754960)
print v(xbgr.mr_n61755072)
print v(xbgr.mr_n61755392)
print v(xbgr.mr_n61755504)
print v(xbgr.mr_n61755824)
print v(xbgr.mr_n61755936)
print v(xbgr.mr_n61756256)
print v(xbgr.mr_n61756688)
print v(xbgr.mr_n61756800)
print v(xbgr.mr_n61757120)
print v(xbgr.mr_n61757232)
print v(xbgr.mr_n61757552)
print v(xbgr.mr_n61757664)
print v(xbgr.mr_n61757984)
print v(xbgr.mr_n61758096)
print v(xbgr.mr_n61758416)
print v(xbgr.mr_n61758528)
print v(xbgr.mr_n61758848)
print v(xbgr.mr_n61758960)
print v(xbgr.mr_n61759280)
print v(xbgr.mr_n61759392)
print v(xbgr.mr_n61759712)
print v(xbgr.mr_n61759824)
print v(xbgr.mr_n61760144)
print v(xbgr.mr_n61760256)
print v(xbgr.mr_n61760576)
print v(xbgr.mr_n61760688)
print v(xbgr.mr_n61761008)
print v(xbgr.mr_n61761120)
print v(xbgr.mr_n61761552)
print v(xbgr.mr_n61761984)
print v(xbgr.mr_n61762416)
print v(xbgr.mr_n61762848)
print v(xbgr.mr_n61763280)
print v(xbgr.mr_n61763712)
print v(xbgr.mr_n61764144)
print v(xbgr.mr_n61764576)
print v(xbgr.mr_n61765008)
print v(xbgr.mr_n61765440)
print v(xbgr.mr_n61765872)
print v(xbgr.mr_n61766304)
print v(xbgr.mr_n61766736)
print v(xbgr.mr_n61767168)
print v(xbgr.mr_n61767600)
print v(xbgr.mr_n61768032)
print v(xbgr.mr_n61768464)
print v(xbgr.mr_n61768896)
print v(xbgr.mr_n61769328)
print v(xbgr.mr_n61769760)
print v(xbgr.mr_n61770192)
print v(xbgr.mr_n61770624)
print v(xbgr.mr_n61771056)
print v(xbgr.mr_n61771488)
print v(xbgr.mr_n61771920)
print v(xbgr.mr_n61772352)
print v(xbgr.mr_n61772784)
print v(xbgr.mr_n61773216)
print v(xbgr.mr_n61773648)
print v(xbgr.mr_n61774080)
print v(xbgr.mr_n61774512)
print v(xbgr.mr_n61774944)
print v(xbgr.mr_n61775376)
print v(xbgr.mr_n61775808)
print v(xbgr.mr_n61776240)
print v(xbgr.mr_n61776672)
print v(xbgr.mr_n61777104)
print v(xbgr.mr_n61777536)
print v(xbgr.mr_n61777968)
print v(xbgr.mr_n61778400)
print v(xbgr.mr_n61778832)
print v(xbgr.mr_n61779264)
print v(xbgr.mr_n61779696)
print v(xbgr.mr_n61780128)
print v(xbgr.mr_n61780560)
print v(xbgr.mr_n61780992)
print v(xbgr.mr_n61781424)
print v(xbgr.mr_n61781856)
print v(xbgr.mr_n61782288)
print v(xbgr.mr_n61782720)
print v(xbgr.mr_n61783152)
print v(xbgr.mr_n61783584)
print v(xbgr.mr_n61784016)
print v(xbgr.mr_n61784448)
print v(xbgr.mr_n61784880)
print v(xbgr.mr_n61785312)
print v(xbgr.mr_n61785744)
print v(xbgr.mr_n61786176)
print v(xbgr.mr_n61786608)
print v(xbgr.mr_n61787040)
print v(xbgr.mr_n61787472)
print v(xbgr.mr_n61787904)
print v(xbgr.mr_n61788336)
print v(xbgr.mr_n61788768)
print v(xbgr.mr_n61789200)
print v(xbgr.mr_n61789632)
print v(xbgr.mr_n61790064)
print v(xbgr.mr_n61790496)
print v(xbgr.mr_n61790928)
print v(xbgr.mr_n61791360)
print v(xbgr.mr_n61791792)
print v(xbgr.mr_n61792224)
print v(xbgr.mr_n61792656)
print v(xbgr.mr_n61793088)
print v(xbgr.mr_n61793520)
print v(xbgr.mr_n61793952)
print v(xbgr.mr_n61794384)
print v(xbgr.mr_n61794816)
print v(xbgr.mr_n61795248)
print v(xbgr.mr_n61795680)
print v(xbgr.mr_n61796112)
print v(xbgr.mr_n61796544)
print v(xbgr.mr_n61796976)
print v(xbgr.mr_n61797408)
print v(xbgr.mr_n61797840)
print v(xbgr.mr_n61798272)
print v(xbgr.mr_n61798592)
print v(xbgr.mr_n61798704)
print v(xbgr.mr_n61799024)
print v(xbgr.mr_n61799136)
print v(xbgr.mr_n61799456)
print v(xbgr.mr_n61799568)
print v(xbgr.mr_n61799888)
print v(xbgr.mr_n61800000)
print v(xbgr.mr_n61800320)
print v(xbgr.mr_n61800432)
print v(xbgr.mr_n61800752)
print v(xbgr.mr_n61800864)
print v(xbgr.mr_n61801184)
print v(xbgr.mr_n61801296)
print v(xbgr.mr_n61801616)
print v(xbgr.mr_n61801728)
print v(xbgr.mr_n61802048)
print v(xbgr.mr_n61802160)
print v(xbgr.mr_n61802480)
print v(xbgr.mr_n61802592)
print v(xbgr.mr_n61802912)
print v(xbgr.mr_n61803024)
print v(xbgr.mr_n61803344)
print v(xbgr.mr_n61803456)
print v(xbgr.mr_n61803776)
print v(xbgr.mr_n61803888)
print v(xbgr.mr_n61804208)
print v(xbgr.mr_n61804320)
print v(xbgr.mr_n61804640)
print v(xbgr.mr_n61804752)
print v(xbgr.mr_n61805072)
print v(xbgr.mr_n61805184)
print v(xbgr.mr_n61805504)
print v(xbgr.mr_n61805616)
print v(xbgr.mr_n61805936)
print v(xbgr.mr_n61806048)
print v(xbgr.mr_n61806368)
print v(xbgr.mr_n61806912)
print v(xbgr.mr_n61807232)
print v(xbgr.mr_n61807664)
print v(xbgr.mr_n61807776)
print v(xbgr.mr_n61808096)
print v(xbgr.mr_n61808208)
print v(xbgr.mr_n61808640)
print v(xbgr.mr_n61808960)
print v(xbgr.mr_n61809824)
print v(xbgr.mr_n61809936)
print v(xbgr.mr_n61810368)
print v(xbgr.mr_n61810688)
print v(xbgr.mr_n61811552)
print v(xbgr.mr_n61811664)
print v(xbgr.mr_n61812096)
print v(xbgr.mr_n61812416)
print v(xbgr.mr_n61812528)
print v(xbgr.mr_n61812960)
print v(xbgr.mr_n61813392)
print v(xbgr.mr_n61813712)
print v(xbgr.mr_n61814576)
print v(xbgr.mr_n61815552)
print v(xbgr.mr_n61815872)
print v(xbgr.mr_n61815984)
print v(xbgr.mr_n61816416)
print v(xbgr.mr_n61816736)
print v(xbgr.mr_n61816848)
print v(xbgr.mr_n61817280)
print v(xbgr.mr_n61817600)
print v(xbgr.mr_n61817712)
print v(xbgr.mr_n61818032)
print v(xbgr.mr_n61818144)
print v(xbgr.mr_n61818464)
print v(xbgr.mr_n61818576)
print v(xbgr.mr_n61818896)
print v(xbgr.mr_n61819008)
print v(xbgr.mr_n61819328)
print v(xbgr.mr_n61819440)
print v(xbgr.mr_n61819760)
print v(xbgr.mr_n61819872)
print v(xbgr.mr_n61820192)
print v(xbgr.mr_n61820304)
print v(xbgr.mr_n61820624)
print v(xbgr.mr_n61820736)
print v(xbgr.mr_n61821056)
print v(xbgr.mr_n61821168)
print v(xbgr.mr_n61821488)
print v(xbgr.mr_n61821600)
print v(xbgr.mr_n61821920)
print v(xbgr.mr_n61822032)
print v(xbgr.mr_n61822352)
print v(xbgr.mr_n61822464)
print v(xbgr.mr_n61822784)
print v(xbgr.mr_n61823648)
print v(xbgr.mr_n61824512)
print v(xbgr.mr_n61824944)
print v(xbgr.mr_n61825376)
print v(xbgr.mr_n61825808)
print v(xbgr.mr_n61826240)
print v(xbgr.mr_n61826672)
print v(xbgr.mr_n61827104)
print v(xbgr.mr_n61827536)
print v(xbgr.mr_n61827968)
print v(xbgr.mr_n61828400)
print v(xbgr.mr_n61828832)
print v(xbgr.mr_n61829264)
print v(xbgr.mr_n61829696)
print v(xbgr.mr_n61829808)
print v(xbgr.mr_n61830128)
print v(xbgr.mr_n61830240)
print v(xbgr.mr_n61830560)
print v(xbgr.mr_n61830672)
print v(xbgr.mr_n61830992)
print v(xbgr.mr_n61831104)
print v(xbgr.mr_n61831424)
print v(xbgr.mr_n61831536)
print v(xbgr.mr_n61831856)
print v(xbgr.mr_n61831968)
print v(xbgr.mr_n61832288)
print v(xbgr.mr_n61832400)
print v(xbgr.mr_n61832720)
print v(xbgr.mr_n61832832)
print v(xbgr.mr_n61833152)
print v(xbgr.mr_n61833264)
print v(xbgr.mr_n61833584)
print v(xbgr.mr_n61833696)
print v(xbgr.mr_n61834016)
print v(xbgr.mr_n61834128)
print v(xbgr.mr_n61834448)
print v(xbgr.mr_n61834560)
print v(xbgr.mr_n61834880)
print v(xbgr.mr_n61835312)
print v(xbgr.mr_n61835424)
print v(xbgr.mr_n61835744)
print v(xbgr.mr_n61835856)
print v(xbgr.mr_n61836176)
print v(xbgr.mr_n61836288)
print v(xbgr.mr_n61836608)
print v(xbgr.mr_n61836720)
print v(xbgr.mr_n61837040)
print v(xbgr.mr_n61837152)
print v(xbgr.mr_n61837472)
print v(xbgr.mr_n61837584)
print v(xbgr.mr_n61837904)
print v(xbgr.mr_n61838016)
print v(xbgr.mr_n61838336)
print v(xbgr.mr_n61838448)
print v(xbgr.mr_n61838768)
print v(xbgr.mr_n61838880)
print v(xbgr.mr_n61839200)
print v(xbgr.mr_n61839312)
print v(xbgr.mr_n61839632)
print v(xbgr.mr_n61839744)
print v(xbgr.mr_n61840064)
print v(xbgr.mr_n61840176)
print v(xbgr.mr_n61840496)
print v(xbgr.mr_n61840608)
print v(xbgr.mr_n61840928)
print v(xbgr.mr_n61841040)
print v(xbgr.mr_n61841360)
print v(xbgr.mr_n61841472)
print v(xbgr.mr_n61841792)
print v(xbgr.mr_n61841904)
print v(xbgr.mr_n61842224)
print v(xbgr.mr_n61842336)
print v(xbgr.mr_n61842656)
print v(xbgr.mr_n61842768)
print v(xbgr.mr_n61843088)
print v(xbgr.mr_n61843200)
print v(xbgr.mr_n61843520)
print v(xbgr.mr_n61843632)
print v(xbgr.mr_n61843952)
print v(xbgr.mr_n61844064)
print v(xbgr.mr_n61844384)
print v(xbgr.mr_n61844496)
print v(xbgr.mr_n61844816)
print v(xbgr.mr_n61844928)
print v(xbgr.mr_n61845248)
print v(xbgr.mr_n61845360)
print v(xbgr.mr_n61845680)
print v(xbgr.mr_n61845792)
print v(xbgr.mr_n61846112)
print v(xbgr.mr_n61846224)
print v(xbgr.mr_n61846544)
print v(xbgr.mr_n61846656)
print v(xbgr.mr_n61846976)
print v(xbgr.mr_n61847088)
print v(xbgr.mr_n61847408)
print v(xbgr.mr_n61847520)
print v(xbgr.mr_n61847840)
print v(xbgr.mr_n61847952)
print v(xbgr.mr_n61848272)
print v(xbgr.mr_n61848384)
print v(xbgr.mr_n61848704)
print v(xbgr.mr_n61848816)
print v(xbgr.mr_n61849136)
print v(xbgr.mr_n61849248)
print v(xbgr.mr_n61849568)
print v(xbgr.mr_n61849680)
print v(xbgr.mr_n61850000)
print v(xbgr.mr_n61850112)
print v(xbgr.mr_n61850432)
print v(xbgr.mr_n61850544)
print v(xbgr.mr_n61850864)
print v(xbgr.mr_n61850976)
print v(xbgr.mr_n61851296)
print v(xbgr.mr_n61851408)
print v(xbgr.mr_n61851728)
print v(xbgr.mr_n61851840)
print v(xbgr.mr_n61852160)
print v(xbgr.mr_n61852272)
print v(xbgr.mr_n61852592)
print v(xbgr.mr_n61852704)
print v(xbgr.mr_n61853024)
print v(xbgr.mr_n61853136)
print v(xbgr.mr_n61853456)
print v(xbgr.mr_n61853568)
print v(xbgr.mr_n61853888)
print v(xbgr.mr_n61854000)
print v(xbgr.mr_n61854320)
print v(xbgr.mr_n61854432)
print v(xbgr.mr_n61854752)
print v(xbgr.mr_n61854864)
print v(xbgr.mr_n61855184)
print v(xbgr.mr_n61855296)
print v(xbgr.mr_n61855616)
print v(xbgr.mr_n61855728)
print v(xbgr.mr_n61856048)
print v(xbgr.mr_n61856160)
print v(xbgr.mr_n61856480)
print v(xbgr.mr_n61856592)
print v(xbgr.mr_n61856912)
print v(xbgr.mr_n61857024)
print v(xbgr.mr_n61857344)
print v(xbgr.mr_n61857456)
print v(xbgr.mr_n61857776)
print v(xbgr.mr_n61857888)
print v(xbgr.mr_n61858208)
print v(xbgr.mr_n61858320)
print v(xbgr.mr_n61858640)
print v(xbgr.mr_n61858752)
print v(xbgr.mr_n61859072)
print v(xbgr.mr_n61859184)
print v(xbgr.mr_n61859504)
print v(xbgr.mr_n61859616)
print v(xbgr.mr_n61859936)
print v(xbgr.mr_n61860048)
print v(xbgr.mr_n61860368)
print v(xbgr.mr_n61860480)
print v(xbgr.mr_n61860800)
print v(xbgr.mr_n61860912)
print v(xbgr.mr_n61861232)
print v(xbgr.mr_n61861344)
print v(xbgr.mr_n61861664)
print v(xbgr.mr_n61861776)
print v(xbgr.mr_n61862096)
print v(xbgr.mr_n61862208)
print v(xbgr.mr_n61862528)
print v(xbgr.mr_n61862640)
print v(xbgr.mr_n61862960)
print v(xbgr.mr_n61863072)
print v(xbgr.mr_n61863392)
print v(xbgr.mr_n61863504)
print v(xbgr.mr_n61863824)
print v(xbgr.mr_n61863936)
print v(xbgr.mr_n61864256)
print v(xbgr.mr_n61864368)
print v(xbgr.mr_n61864688)
print v(xbgr.mr_n61864800)
print v(xbgr.mr_n61865120)
print v(xbgr.mr_n61865232)
print v(xbgr.mr_n61865552)
print v(xbgr.mr_n61865664)
print v(xbgr.mr_n61865984)
print v(xbgr.mr_n61866096)
print v(xbgr.mr_n61866416)
print v(xbgr.mr_n61866528)
print v(xbgr.mr_n61866848)
print v(xbgr.mr_n61867280)
print v(xbgr.mr_n61867392)
print v(xbgr.mr_n61867712)
print v(xbgr.mr_n61867824)
print v(xbgr.mr_n61868144)
print v(xbgr.mr_n61868256)
print v(xbgr.mr_n61868576)
print v(xbgr.mr_n61868688)
print v(xbgr.mr_n61869008)
print v(xbgr.mr_n61869120)
print v(xbgr.mr_n61869440)
print v(xbgr.mr_n61869552)
print v(xbgr.mr_n61869872)
print v(xbgr.mr_n61869984)
print v(xbgr.mr_n61870304)
print v(xbgr.mr_n61870416)
print v(xbgr.mr_n61870736)
print v(xbgr.mr_n61870848)
print v(xbgr.mr_n61871168)
print v(xbgr.mr_n61871280)
print v(xbgr.mr_n61871600)
print v(xbgr.mr_n61871712)
print v(xbgr.mr_n61872032)
print v(xbgr.mr_n61872144)
print v(xbgr.mr_n61872464)
print v(xbgr.mr_n61872576)
print v(xbgr.mr_n61872896)
print v(xbgr.mr_n61873008)
print v(xbgr.mr_n61873328)
print v(xbgr.mr_n61873440)
print v(xbgr.mr_n61873760)
print v(xbgr.mr_n61873872)
print v(xbgr.mr_n61874192)
print v(xbgr.mr_n61874304)
print v(xbgr.mr_n61874624)
print v(xbgr.mr_n61874736)
print v(xbgr.mr_n61875056)
print v(xbgr.mr_n61875600)
print v(xbgr.mr_n61875920)
print v(xbgr.mr_n61876032)
print v(xbgr.mr_n61876352)
print v(xbgr.mr_n61876464)
print v(xbgr.mr_n61876896)
print v(xbgr.mr_n61877328)
print v(xbgr.mr_n61877760)
print v(xbgr.mr_n61878192)
print v(xbgr.mr_n61878624)
print v(xbgr.mr_n61879056)
print v(xbgr.mr_n61879488)
print v(xbgr.mr_n61879920)
print v(xbgr.mr_n61880352)
print v(xbgr.mr_n61880784)
print v(xbgr.mr_n61881216)
print v(xbgr.mr_n61881648)
print v(xbgr.mr_n61882080)
print v(xbgr.mr_n61882512)
print v(xbgr.mr_n61882944)
print v(xbgr.mr_n61883376)
print v(xbgr.mr_n61883808)
print v(xbgr.mr_n61884240)
print v(xbgr.mr_n61884672)
print v(xbgr.mr_n61885104)
print v(xbgr.mr_n61885536)
print v(xbgr.mr_n61885968)
print v(xbgr.mr_n61886400)
print v(xbgr.mr_n61886832)
print v(xbgr.mr_n61887264)
print v(xbgr.mr_n61887696)
print v(xbgr.mr_n61888128)
print v(xbgr.mr_n61888560)
print v(xbgr.mr_n61888992)
print v(xbgr.mr_n61889424)
print v(xbgr.mr_n61889856)
print v(xbgr.mr_n61890288)
print v(xbgr.mr_n61890720)
print v(xbgr.mr_n61891152)
print v(xbgr.mr_n61891584)
print v(xbgr.mr_n61892016)
print v(xbgr.mr_n61892448)
print v(xbgr.mr_n61892880)
print v(xbgr.mr_n61893312)
print v(xbgr.mr_n61893744)
print v(xbgr.mr_n61894176)
print v(xbgr.mr_n61894608)
print v(xbgr.mr_n61895040)
print v(xbgr.mr_n61895472)
print v(xbgr.mr_n61895904)
print v(xbgr.mr_n61896336)
print v(xbgr.mr_n61896768)
print v(xbgr.mr_n61897200)
print v(xbgr.mr_n61897632)
print v(xbgr.mr_n61898064)
print v(xbgr.mr_n61898496)
print v(xbgr.mr_n61898928)
print v(xbgr.mr_n61899360)
print v(xbgr.mr_n61899792)
print v(xbgr.mr_n61900224)
print v(xbgr.mr_n61900656)
print v(xbgr.mr_n61901088)
print v(xbgr.mr_n61901520)
print v(xbgr.mr_n61901952)
print v(xbgr.mr_n61902384)
print v(xbgr.mr_n61902816)
print v(xbgr.mr_n61903248)
print v(xbgr.mr_n61903680)
print v(xbgr.mr_n61904112)
print v(xbgr.mr_n61904544)
print v(xbgr.mr_n61904976)
print v(xbgr.mr_n61905408)
print v(xbgr.mr_n61905840)
print v(xbgr.mr_n61906272)
print v(xbgr.mr_n61906704)
print v(xbgr.mr_n61907136)
print v(xbgr.mr_n61907568)
print v(xbgr.mr_n61908000)
print v(xbgr.mr_n61908432)
print v(xbgr.mr_n61908864)
print v(xbgr.mr_n61909296)
print v(xbgr.mr_n61909728)
print v(xbgr.mr_n61910160)
print v(xbgr.mr_n61910592)
print v(xbgr.mr_n61911024)
print v(xbgr.mr_n61911456)
print v(xbgr.mr_n61911888)
print v(xbgr.mr_n61912320)
print v(xbgr.mr_n61912752)
print v(xbgr.mr_n61913184)
print v(xbgr.mr_n61913616)
print v(xbgr.mr_n61914048)
print v(xbgr.mr_n61914480)
print v(xbgr.mr_n61914912)
print v(xbgr.mr_n61915344)
print v(xbgr.mr_n61915776)
print v(xbgr.mr_n61916208)
print v(xbgr.mr_n61916640)
print v(xbgr.mr_n61917072)
print v(xbgr.mr_n61917504)
print v(xbgr.mr_n61917936)
print v(xbgr.mr_n61918368)
print v(xbgr.mr_n61918800)
print v(xbgr.mr_n61919232)
print v(xbgr.mr_n61919664)
print v(xbgr.mr_n61920096)
print v(xbgr.mr_n61920528)
print v(xbgr.mr_n61920960)
print v(xbgr.mr_n61921392)
print v(xbgr.mr_n61921824)
print v(xbgr.mr_n61922144)
print v(xbgr.mr_n61922256)
print v(xbgr.mr_n61922576)
print v(xbgr.mr_n61922688)
print v(xbgr.mr_n61923008)
print v(xbgr.mr_n61923120)
print v(xbgr.mr_n61923440)
print v(xbgr.mr_n61923552)
print v(xbgr.mr_n61923872)
print v(xbgr.mr_n61923984)
print v(xbgr.mr_n61924304)
print v(xbgr.mr_n61924416)
print v(xbgr.mr_n61924736)
print v(xbgr.mr_n61924848)
print v(xbgr.mr_n61925168)
print v(xbgr.mr_n61925280)
print v(xbgr.mr_n61925600)
print v(xbgr.mr_n61925712)
print v(xbgr.mr_n61926032)
print v(xbgr.mr_n61926144)
print v(xbgr.mr_n61926464)
print v(xbgr.mr_n61926576)
print v(xbgr.mr_n61926896)
print v(xbgr.mr_n61927008)
print v(xbgr.mr_n61927328)
print v(xbgr.mr_n61927440)
print v(xbgr.mr_n61927760)
print v(xbgr.mr_n61927872)
print v(xbgr.mr_n61928192)
print v(xbgr.mr_n61928304)
print v(xbgr.mr_n61928624)
print v(xbgr.mr_n61928736)
print v(xbgr.mr_n61929056)
print v(xbgr.mr_n61929168)
print v(xbgr.mr_n61929488)
print v(xbgr.mr_n61929600)
print v(xbgr.mr_n61929920)
print v(xbgr.mr_n61930032)
print v(xbgr.mr_n61930352)
print v(xbgr.mr_n61930464)
print v(xbgr.mr_n61930784)
print v(xbgr.mr_n61930896)
print v(xbgr.mr_n61931216)
print v(xbgr.mr_n61931328)
print v(xbgr.mr_n61931648)
print v(xbgr.mr_n61931760)
print v(xbgr.mr_n61932080)
print v(xbgr.mr_n61932192)
print v(xbgr.mr_n61932512)
print v(xbgr.mr_n61932624)
print v(xbgr.mr_n61932944)
print v(xbgr.mr_n61933056)
print v(xbgr.mr_n61933376)
print v(xbgr.mr_n61933488)
print v(xbgr.mr_n61933808)
print v(xbgr.mr_n61933920)
print v(xbgr.mr_n61934240)
print v(xbgr.mr_n61934352)
print v(xbgr.mr_n61934672)
print v(xbgr.mr_n61934784)
print v(xbgr.mr_n61935104)
print v(xbgr.mr_n61935216)
print v(xbgr.mr_n61935536)
print v(xbgr.mr_n61935648)
print v(xbgr.mr_n61935968)
print v(xbgr.mr_n61936080)
print v(xbgr.mr_n61936400)
print v(xbgr.mr_n61936512)
print v(xbgr.mr_n61936832)
print v(xbgr.mr_n61936944)
print v(xbgr.mr_n61937264)
print v(xbgr.mr_n61937376)
print v(xbgr.mr_n61937696)
print v(xbgr.mr_n61937808)
print v(xbgr.mr_n61938128)
print v(xbgr.mr_n61938240)
print v(xbgr.mr_n61938560)
print v(xbgr.mr_n61938672)
print v(xbgr.mr_n61938992)
print v(xbgr.mr_n61939104)
print v(xbgr.mr_n61939424)
print v(xbgr.mr_n61939536)
print v(xbgr.mr_n61939856)
print v(xbgr.mr_n61939968)
print v(xbgr.mr_n61940288)
print v(xbgr.mr_n61940720)
print v(xbgr.mr_n61940832)
print v(xbgr.mr_n61941152)
print v(xbgr.mr_n61941264)
print v(xbgr.mr_n61941584)
print v(xbgr.mr_n61941696)
print v(xbgr.mr_n61942016)
print v(xbgr.mr_n61942128)
print v(xbgr.mr_n61942448)
print v(xbgr.mr_n61942560)
print v(xbgr.mr_n61942880)
print v(xbgr.mr_n61942992)
print v(xbgr.mr_n61943312)
print v(xbgr.mr_n61943424)
print v(xbgr.mr_n61943744)
print v(xbgr.mr_n61943856)
print v(xbgr.mr_n61944176)
print v(xbgr.mr_n61944288)
print v(xbgr.mr_n61944608)
print v(xbgr.mr_n61944720)
print v(xbgr.mr_n61945040)
print v(xbgr.mr_n61945152)
print v(xbgr.mr_n61945472)
print v(xbgr.mr_n61945584)
print v(xbgr.mr_n61945904)
print v(xbgr.mr_n61946016)
print v(xbgr.mr_n61946336)
print v(xbgr.mr_n61946448)
print v(xbgr.mr_n61946768)
print v(xbgr.mr_n61946880)
print v(xbgr.mr_n61947200)
print v(xbgr.mr_n61947312)
print v(xbgr.mr_n61947632)
print v(xbgr.mr_n61947744)
print v(xbgr.mr_n61948064)
print v(xbgr.mr_n61948176)
print v(xbgr.mr_n61948496)
print v(xbgr.mr_n61948608)
print v(xbgr.mr_n61948928)
print v(xbgr.mr_n61949040)
print v(xbgr.mr_n61949360)
print v(xbgr.mr_n61949472)
print v(xbgr.mr_n61949792)
print v(xbgr.mr_n61949904)
print v(xbgr.mr_n61950224)
print v(xbgr.mr_n61950336)
print v(xbgr.mr_n61950656)
print v(xbgr.mr_n61950768)
print v(xbgr.mr_n61951088)
print v(xbgr.mr_n61951200)
print v(xbgr.mr_n61951520)
print v(xbgr.mr_n61951632)
print v(xbgr.mr_n61951952)
print v(xbgr.mr_n61952064)
print v(xbgr.mr_n61952384)
print v(xbgr.mr_n61952496)
print v(xbgr.mr_n61952816)
print v(xbgr.mr_n61952928)
print v(xbgr.mr_n61953248)
print v(xbgr.mr_n61953360)
print v(xbgr.mr_n61953680)
print v(xbgr.mr_n61953792)
print v(xbgr.mr_n61954112)
print v(xbgr.mr_n61954224)
print v(xbgr.mr_n61954544)
print v(xbgr.mr_n61954656)
print v(xbgr.mr_n61954976)
print v(xbgr.mr_n61955088)
print v(xbgr.mr_n61955408)
print v(xbgr.mr_n61955520)
print v(xbgr.mr_n61955840)
print v(xbgr.mr_n61955952)
print v(xbgr.mr_n61956272)
print v(xbgr.mr_n61956384)
print v(xbgr.mr_n61956704)
print v(xbgr.mr_n61956816)
print v(xbgr.mr_n61957136)
print v(xbgr.mr_n61957248)
print v(xbgr.mr_n61957568)
print v(xbgr.mr_n61957680)
print v(xbgr.mr_n61958000)
print v(xbgr.mr_n61958112)
print v(xbgr.mr_n61958432)
print v(xbgr.mr_n61958544)
print v(xbgr.mr_n61958864)
print v(xbgr.mr_n61958976)
print v(xbgr.mr_n61959296)
print v(xbgr.mr_n61959408)
print v(xbgr.mr_n61959728)
print v(xbgr.mr_n61959840)
print v(xbgr.mr_n61960160)
print v(xbgr.mr_n61960272)
print v(xbgr.mr_n61960592)
print v(xbgr.mr_n61960704)
print v(xbgr.mr_n61961024)
print v(xbgr.mr_n61961136)
print v(xbgr.mr_n61961456)
print v(xbgr.mr_n61961568)
print v(xbgr.mr_n61961888)
print v(xbgr.mr_n61962000)
print v(xbgr.mr_n61962320)
print v(xbgr.mr_n61962432)
print v(xbgr.mr_n61962752)
print v(xbgr.mr_n61962864)
print v(xbgr.mr_n61963184)
print v(xbgr.mr_n61963296)
print v(xbgr.mr_n61963616)
print v(xbgr.mr_n61963728)
print v(xbgr.mr_n61964048)
print v(xbgr.mr_n61964160)
print v(xbgr.mr_n61964480)
print v(xbgr.mr_n61964592)
print v(xbgr.mr_n61964912)
print v(xbgr.mr_n61965024)
print v(xbgr.mr_n61965344)
print v(xbgr.mr_n61965456)
print v(xbgr.mr_n61965776)
print v(xbgr.mr_n61965888)
print v(xbgr.mr_n61966208)
print v(xbgr.mr_n61966320)
print v(xbgr.mr_n61966640)
print v(xbgr.mr_n61966752)
print v(xbgr.mr_n61967072)
print v(xbgr.mr_n61967184)
print v(xbgr.mr_n61967504)
print v(xbgr.mr_n61967616)
print v(xbgr.mr_n61967936)
print v(xbgr.mr_n61968048)
print v(xbgr.mr_n61968368)
print v(xbgr.mr_n61968480)
print v(xbgr.mr_n61968800)
print v(xbgr.mr_n61968912)
print v(xbgr.mr_n61969232)
print v(xbgr.mr_n61969344)
print v(xbgr.mr_n61969664)
print v(xbgr.mr_n61969776)
print v(xbgr.mr_n61970096)
print v(xbgr.mr_n61970208)
print v(xbgr.mr_n61970528)
print v(xbgr.mr_n61970640)
print v(xbgr.mr_n61970960)
print v(xbgr.mr_n61971072)
print v(xbgr.mr_n61971392)
print v(xbgr.mr_n61971504)
print v(xbgr.mr_n61971824)
print v(xbgr.mr_n61971936)
print v(xbgr.mr_n61972256)
print v(xbgr.mr_n61972368)
print v(xbgr.mr_n61972688)
print v(xbgr.mr_n61972800)
print v(xbgr.mr_n61973120)
print v(xbgr.mr_n61973232)
print v(xbgr.mr_n61973552)
print v(xbgr.mr_n61973664)
print v(xbgr.mr_n61973984)
print v(xbgr.mr_n61974096)
print v(xbgr.mr_n61974416)
print v(xbgr.mr_n61974528)
print v(xbgr.mr_n61974848)
print v(xbgr.mr_n61974960)
print v(xbgr.mr_n61975280)
print v(xbgr.mr_n61975392)
print v(xbgr.mr_n61975712)
print v(xbgr.mr_n61975824)
print v(xbgr.mr_n61976144)
print v(xbgr.mr_n61976256)
print v(xbgr.mr_n61976576)
print v(xbgr.mr_n61976688)
print v(xbgr.mr_n61977008)
print v(xbgr.mr_n61977120)
print v(xbgr.mr_n61977440)
print v(xbgr.mr_n61977552)
print v(xbgr.mr_n61977872)
print v(xbgr.mr_n61977984)
print v(xbgr.mr_n61978304)
print v(xbgr.mr_n61978416)
print v(xbgr.mr_n61978736)
print v(xbgr.mr_n61978848)
print v(xbgr.mr_n61979168)
print v(xbgr.mr_n61979280)
print v(xbgr.mr_n61979600)
print v(xbgr.mr_n61979712)
print v(xbgr.mr_n61980032)
print v(xbgr.mr_n61980144)
print v(xbgr.mr_n61980464)
print v(xbgr.mr_n61980576)
print v(xbgr.mr_n61980896)
print v(xbgr.mr_n61981008)
print v(xbgr.mr_n61981328)
print v(xbgr.mr_n61981440)
print v(xbgr.mr_n61981760)
print v(xbgr.mr_n61981872)
print v(xbgr.mr_n61982192)
print v(xbgr.mr_n61982304)
print v(xbgr.mr_n61982624)
print v(xbgr.mr_n61982736)
print v(xbgr.mr_n61983056)
print v(xbgr.mr_n61983168)
print v(xbgr.mr_n61983488)
print v(xbgr.mr_n61983600)
print v(xbgr.mr_n61983920)
print v(xbgr.mr_n61984032)
print v(xbgr.mr_n61984352)
print v(xbgr.mr_n61984464)
print v(xbgr.mr_n61984784)
print v(xbgr.mr_n61984896)
print v(xbgr.mr_n61985216)
print v(xbgr.mr_n61985328)
print v(xbgr.mr_n61985648)
print v(xbgr.mr_n61985760)
print v(xbgr.mr_n61986080)
print v(xbgr.mr_n61986192)
print v(xbgr.mr_n61986512)
print v(xbgr.mr_n61986624)
print v(xbgr.mr_n61986944)
print v(xbgr.mr_n61987056)
print v(xbgr.mr_n61987376)
print v(xbgr.mr_n61987488)
print v(xbgr.mr_n61987808)
print v(xbgr.mr_n61987920)
print v(xbgr.mr_n61988240)
print v(xbgr.mr_n61988352)
print v(xbgr.mr_n61988672)
print v(xbgr.mr_n61988784)
print v(xbgr.mr_n61989104)
print v(xbgr.mr_n61989216)
print v(xbgr.mr_n61989536)
print v(xbgr.mr_n61989648)
print v(xbgr.mr_n61989968)
print v(xbgr.mr_n61990080)
print v(xbgr.mr_n61990400)
print v(xbgr.mr_n61990832)
print v(xbgr.mr_n61990944)
print v(xbgr.mr_n61991264)
print v(xbgr.mr_n61991376)
print v(xbgr.mr_n61991696)
print v(xbgr.mr_n61991808)
print v(xbgr.mr_n61992128)
print v(xbgr.mr_n61992240)
print v(xbgr.mr_n61992560)
print v(xbgr.mr_n61992672)
print v(xbgr.mr_n61992992)
print v(xbgr.mr_n61993104)
print v(xbgr.mr_n61993424)
print v(xbgr.mr_n61993536)
print v(xbgr.mr_n61993856)
print v(xbgr.mr_n61993968)
print v(xbgr.mr_n61994288)
print v(xbgr.mr_n61994400)
print v(xbgr.mr_n61994720)
print v(xbgr.mr_n61994832)
print v(xbgr.mr_n61995152)
print v(xbgr.mr_n61995264)
print v(xbgr.mr_n61995584)
print v(xbgr.mr_n61995696)
print v(xbgr.mr_n61996016)
print v(xbgr.mr_n61996128)
print v(xbgr.mr_n61996448)
print v(xbgr.mr_n61996560)
print v(xbgr.mr_n61996880)
print v(xbgr.mr_n61996992)
print v(xbgr.mr_n61997312)
print v(xbgr.mr_n61997424)
print v(xbgr.mr_n61997744)
print v(xbgr.mr_n61997856)
print v(xbgr.mr_n61998176)
print v(xbgr.mr_n61998288)
print v(xbgr.mr_n61998608)
print v(xbgr.mr_n61998720)
print v(xbgr.mr_n61999040)
print v(xbgr.mr_n61999152)
print v(xbgr.mr_n61999472)
print v(xbgr.mr_n61999584)
print v(xbgr.mr_n61999904)
print v(xbgr.mr_n62000016)
print v(xbgr.mr_n62000336)
print v(xbgr.mr_n62000448)
print v(xbgr.mr_n62000768)
print v(xbgr.mr_n62000880)
print v(xbgr.mr_n62001200)
print v(xbgr.mr_n62001312)
print v(xbgr.mr_n62001632)
print v(xbgr.mr_n62001744)
print v(xbgr.mr_n62002064)
print v(xbgr.mr_n62002176)
print v(xbgr.mr_n62002496)
print v(xbgr.mr_n62002608)
print v(xbgr.mr_n62002928)
print v(xbgr.mr_n62003040)
print v(xbgr.mr_n62003360)
print v(xbgr.mr_n62003472)
print v(xbgr.mr_n62003792)
print v(xbgr.mr_n62003904)
print v(xbgr.mr_n62004224)
print v(xbgr.mr_n62004336)
print v(xbgr.mr_n62004656)
print v(xbgr.mr_n62004768)
print v(xbgr.mr_n62005088)
print v(xbgr.mr_n62005200)
print v(xbgr.mr_n62005520)
print v(xbgr.mr_n62005632)
print v(xbgr.mr_n62005952)
print v(xbgr.mr_n62006064)
print v(xbgr.mr_n62006384)
print v(xbgr.mr_n62006496)
print v(xbgr.mr_n62006816)
print v(xbgr.mr_n62006928)
print v(xbgr.mr_n62007248)
print v(xbgr.mr_n62007360)
print v(xbgr.mr_n62007680)
print v(xbgr.mr_n62007792)
print v(xbgr.mr_n62008112)
print v(xbgr.mr_n62008224)
print v(xbgr.mr_n62008544)
print v(xbgr.mr_n62008656)
print v(xbgr.mr_n62008976)
print v(xbgr.mr_n62009088)
print v(xbgr.mr_n62009408)
print v(xbgr.mr_n62009520)
print v(xbgr.mr_n62009840)
print v(xbgr.mr_n62009952)
print v(xbgr.mr_n62010272)
print v(xbgr.mr_n62010384)
print v(xbgr.mr_n62010704)
print v(xbgr.mr_n62010816)
print v(xbgr.mr_n62011136)
print v(xbgr.mr_n62011568)
print v(xbgr.mr_n62011680)
print v(xbgr.mr_n62012000)
print v(xbgr.mr_n62012112)
print v(xbgr.mr_n62012432)
print v(xbgr.mr_n62012544)
print v(xbgr.mr_n62012864)
print v(xbgr.mr_n62012976)
print v(xbgr.mr_n62013296)
print v(xbgr.mr_n62013408)
print v(xbgr.mr_n62013728)
print v(xbgr.mr_n62013840)
print v(xbgr.mr_n62014272)
print v(xbgr.mr_n62014704)
print v(xbgr.mr_n62015024)
print v(xbgr.mr_n62015136)
print v(xbgr.mr_n62015456)
print v(xbgr.mr_n62015568)
print v(xbgr.mr_n62015888)
print v(xbgr.mr_n62016000)
print v(xbgr.mr_n62016320)
print v(xbgr.mr_n62016432)
print v(xbgr.mr_n62016752)
print v(xbgr.mr_n62016864)
print v(xbgr.mr_n62017184)
print v(xbgr.mr_n62017296)
print v(xbgr.mr_n62017616)
print v(xbgr.mr_n62017728)
print v(xbgr.mr_n62018048)
print v(xbgr.mr_n62018160)
print v(xbgr.mr_n62018480)
print v(xbgr.mr_n62018592)
print v(xbgr.mr_n62018912)
print v(xbgr.mr_n62019024)
print v(xbgr.mr_n62019344)
print v(xbgr.mr_n62019456)
print v(xbgr.mr_n62019776)
print v(xbgr.mr_n62019888)
print v(xbgr.mr_n62020208)
print v(xbgr.mr_n62020320)
print v(xbgr.mr_n62020640)
print v(xbgr.mr_n62020752)
print v(xbgr.mr_n62021072)
print v(xbgr.mr_n62021184)
print v(xbgr.mr_n62021504)
print v(xbgr.mr_n62021616)
print v(xbgr.mr_n62021936)
print v(xbgr.mr_n62022048)
print v(xbgr.mr_n62022368)
print v(xbgr.mr_n62022480)
print v(xbgr.mr_n62022800)
print v(xbgr.mr_n62022912)
print v(xbgr.mr_n62023232)
print v(xbgr.mr_n62023344)
print v(xbgr.mr_n62023664)
print v(xbgr.mr_n62023776)
print v(xbgr.mr_n62024096)
print v(xbgr.mr_n62024208)
print v(xbgr.mr_n62024528)
print v(xbgr.mr_n62024640)
print v(xbgr.mr_n62024960)
print v(xbgr.mr_n62025072)
print v(xbgr.mr_n62025392)
print v(xbgr.mr_n62025504)
print v(xbgr.mr_n62025824)
print v(xbgr.mr_n62025936)
print v(xbgr.mr_n62026256)
print v(xbgr.mr_n62026368)
print v(xbgr.mr_n62026688)
print v(xbgr.mr_n62026800)
print v(xbgr.mr_n62027120)
print v(xbgr.mr_n62027232)
print v(xbgr.mr_n62027552)
print v(xbgr.mr_n62027664)
print v(xbgr.mr_n62027984)
print v(xbgr.mr_n62028096)
print v(xbgr.mr_n62028416)
print v(xbgr.mr_n62028528)
print v(xbgr.mr_n62028848)
print v(xbgr.mr_n62028960)
print v(xbgr.mr_n62029280)
print v(xbgr.mr_n62029392)
print v(xbgr.mr_n62029712)
print v(xbgr.mr_n62029824)
print v(xbgr.mr_n62030144)
print v(xbgr.mr_n62030256)
print v(xbgr.mr_n62030576)
print v(xbgr.mr_n62030688)
print v(xbgr.mr_n62031008)
print v(xbgr.mr_n62031120)
print v(xbgr.mr_n62031440)
print v(xbgr.mr_n62031552)
print v(xbgr.mr_n62031872)
print v(xbgr.mr_n62031984)
print v(xbgr.mr_n62032304)
print v(xbgr.mr_n62032416)
print v(xbgr.mr_n62032736)
print v(xbgr.mr_n62032848)
print v(xbgr.mr_n62033168)
print v(xbgr.mr_n62033280)
print v(xbgr.mr_n62033600)
print v(xbgr.mr_n62033712)
print v(xbgr.mr_n62034032)
print v(xbgr.mr_n62034144)
print v(xbgr.mr_n62034464)
print v(xbgr.mr_n62034576)
print v(xbgr.mr_n62034896)
print v(xbgr.mr_n62035008)
print v(xbgr.mr_n62035328)
print v(xbgr.mr_n62035440)
print v(xbgr.mr_n62035760)
print v(xbgr.mr_n62035872)
print v(xbgr.mr_n62036192)
print v(xbgr.mr_n62036304)
print v(xbgr.mr_n62036624)
print v(xbgr.mr_n62036736)
print v(xbgr.mr_n62037056)
print v(xbgr.mr_n62037168)
print v(xbgr.mr_n62037488)
print v(xbgr.mr_n62037600)
print v(xbgr.mr_n62037920)
print v(xbgr.mr_n62038032)
print v(xbgr.mr_n62038352)
print v(xbgr.mr_n62038464)
print v(xbgr.mr_n62038784)
print v(xbgr.mr_n62038896)
print v(xbgr.mr_n62039216)
print v(xbgr.mr_n62039328)
print v(xbgr.mr_n62039648)
print v(xbgr.mr_n62039760)
print v(xbgr.mr_n62040080)
print v(xbgr.mr_n62040192)
print v(xbgr.mr_n62040512)
print v(xbgr.mr_n62040624)
print v(xbgr.mr_n62040944)
print v(xbgr.mr_n62041056)
print v(xbgr.mr_n62041376)
print v(xbgr.mr_n62041488)
print v(xbgr.mr_n62041808)
print v(xbgr.mr_n62041920)
print v(xbgr.mr_n62042240)
print v(xbgr.mr_n62042352)
print v(xbgr.mr_n62042672)
print v(xbgr.mr_n62042784)
print v(xbgr.mr_n62043104)
print v(xbgr.mr_n62043216)
print v(xbgr.mr_n62043536)
print v(xbgr.mr_n62043648)
print v(xbgr.mr_n62043968)
print v(xbgr.mr_n62044080)
print v(xbgr.mr_n62044400)
print v(xbgr.mr_n62044512)
print v(xbgr.mr_n62044832)
print v(xbgr.mr_n62044944)
print v(xbgr.mr_n62045264)
print v(xbgr.mr_n62045376)
print v(xbgr.mr_n62045696)
print v(xbgr.mr_n62045808)
print v(xbgr.mr_n62046128)
print v(xbgr.mr_n62046240)
print v(xbgr.mr_n62046560)
print v(xbgr.mr_n62046672)
print v(xbgr.mr_n62046992)
print v(xbgr.mr_n62047104)
print v(xbgr.mr_n62047424)
print v(xbgr.mr_n62047536)
print v(xbgr.mr_n62047856)
print v(xbgr.mr_n62047968)
print v(xbgr.mr_n62048288)
print v(xbgr.mr_n62048400)
print v(xbgr.mr_n62048720)
print v(xbgr.mr_n62048832)
print v(xbgr.mr_n62049152)
print v(xbgr.mr_n62049264)
print v(xbgr.mr_n62049584)
print v(xbgr.mr_n62049696)
print v(xbgr.mr_n62050016)
print v(xbgr.mr_n62050128)
print v(xbgr.mr_n62050448)
print v(xbgr.mr_n62050560)
print v(xbgr.mr_n62050880)
print v(xbgr.mr_n62050992)
print v(xbgr.mr_n62051312)
print v(xbgr.mr_n62051424)
print v(xbgr.mr_n62051744)
print v(xbgr.mr_n62051856)
print v(xbgr.mr_n62052176)
print v(xbgr.mr_n62052288)
print v(xbgr.mr_n62052608)
print v(xbgr.mr_n62052720)
print v(xbgr.mr_n62053040)
print v(xbgr.mr_n62053152)
print v(xbgr.mr_n62053472)
print v(xbgr.mr_n62053584)
print v(xbgr.mr_n62053904)
print v(xbgr.mr_n62054016)
print v(xbgr.mr_n62054336)
print v(xbgr.mr_n62054448)
print v(xbgr.mr_n62054768)
print v(xbgr.mr_n62054880)
print v(xbgr.mr_n62055200)
print v(xbgr.mr_n62055312)
print v(xbgr.mr_n62055632)
print v(xbgr.mr_n62055744)
print v(xbgr.mr_n62056064)
print v(xbgr.mr_n62056176)
print v(xbgr.mr_n62056496)
print v(xbgr.mr_n62056608)
print v(xbgr.mr_n62056928)
print v(xbgr.mr_n62057040)
print v(xbgr.mr_n62057360)
print v(xbgr.mr_n62057472)
print v(xbgr.mr_n62057792)
print v(xbgr.mr_n62057904)
print v(xbgr.mr_n62058224)
print v(xbgr.mr_n62058336)
print v(xbgr.mr_n62058656)
print v(xbgr.mr_n62058768)
print v(xbgr.mr_n62059088)
print v(xbgr.mr_n62059200)
print v(xbgr.mr_n62059520)
print v(xbgr.mr_n62059632)
print v(xbgr.mr_n62059952)
print v(xbgr.mr_n62060064)
print v(xbgr.mr_n62060384)
print v(xbgr.mr_n62060496)
print v(xbgr.mr_n62060816)
print v(xbgr.mr_n62060928)
print v(xbgr.mr_n62061248)
print v(xbgr.mr_n62061360)
print v(xbgr.mr_n62061680)
print v(xbgr.mr_n62061792)
print v(xbgr.mr_n62062112)
print v(xbgr.mr_n62062224)
print v(xbgr.mr_n62062544)
print v(xbgr.mr_n62062656)
print v(xbgr.mr_n62062976)
print v(xbgr.mr_n62063088)
print v(xbgr.mr_n62063408)
print v(xbgr.mr_n62063520)
print v(xbgr.mr_n62063840)
print v(xbgr.mr_n62063952)
print v(xbgr.mr_n62064272)
print v(xbgr.mr_n62064384)
print v(xbgr.mr_n62064704)
print v(xbgr.mr_n62064816)
print v(xbgr.mr_n62065136)
print v(xbgr.mr_n62065248)
print v(xbgr.mr_n62065568)
print v(xbgr.mr_n62065680)
print v(xbgr.mr_n62066000)
print v(xbgr.mr_n62066112)
print v(xbgr.mr_n62066432)
print v(xbgr.mr_n62066544)
print v(xbgr.mr_n62066864)
print v(xbgr.mr_n62066976)
print v(xbgr.mr_n62067296)
print v(xbgr.mr_n62067408)
print v(xbgr.mr_n62067728)
print v(xbgr.mr_n62067840)
print v(xbgr.mr_n62068160)
print v(xbgr.mr_n62068272)
print v(xbgr.mr_n62068592)
print v(xbgr.mr_n62068704)
print v(xbgr.mr_n62069024)
print v(xbgr.mr_n62069136)
print v(xbgr.mr_n62069456)
print v(xbgr.mr_n62069568)
print v(xbgr.mr_n62069888)
print v(xbgr.mr_n62070000)
print v(xbgr.mr_n62070320)
print v(xbgr.mr_n62070432)
print v(xbgr.mr_n62070864)
print v(xbgr.mr_n62071296)
print v(xbgr.mr_n62071728)
print v(xbgr.mr_n62072160)
print v(xbgr.mr_n62072592)
print v(xbgr.mr_n62073024)
print v(xbgr.mr_n62073456)
print v(xbgr.mr_n62073888)
print v(xbgr.mr_n62074320)
print v(xbgr.mr_n62074752)
print v(xbgr.mr_n62075184)
print v(xbgr.mr_n62075616)
print v(xbgr.mr_n62076048)
print v(xbgr.mr_n62076480)
print v(xbgr.mr_n62076912)
print v(xbgr.mr_n62077344)
print v(xbgr.mr_n62077776)
print v(xbgr.mr_n62078208)
print v(xbgr.mr_n62078640)
print v(xbgr.mr_n62079072)
print v(xbgr.mr_n62079504)
print v(xbgr.mr_n62079936)
print v(xbgr.mr_n62080368)
print v(xbgr.mr_n62080800)
print v(xbgr.mr_n62081232)
print v(xbgr.mr_n62081664)
print v(xbgr.mr_n62082096)
print v(xbgr.mr_n62082528)
print v(xbgr.mr_n62082960)
print v(xbgr.mr_n62083392)
print v(xbgr.mr_n62083824)
print v(xbgr.mr_n62084256)
print v(xbgr.mr_n62084688)
print v(xbgr.mr_n62085120)
print v(xbgr.mr_n62085552)
print v(xbgr.mr_n62085984)
print v(xbgr.mr_n62086416)
print v(xbgr.mr_n62086848)
print v(xbgr.mr_n62087280)
print v(xbgr.mr_n62087712)
print v(xbgr.mr_n62088144)
print v(xbgr.mr_n62088576)
print v(xbgr.mr_n62089008)
print v(xbgr.mr_n62089440)
print v(xbgr.mr_n62089872)
print v(xbgr.mr_n62090304)
print v(xbgr.mr_n62090736)
print v(xbgr.mr_n62091168)
print v(xbgr.mr_n62091600)
print v(xbgr.mr_n62092032)
print v(xbgr.mr_n62092464)
print v(xbgr.mr_n62092896)
print v(xbgr.mr_n62093328)
print v(xbgr.mr_n62093760)
print v(xbgr.mr_n62094192)
print v(xbgr.mr_n62094624)
print v(xbgr.mr_n62095056)
print v(xbgr.mr_n62095488)
print v(xbgr.mr_n62095920)
print v(xbgr.mr_n62096352)
print v(xbgr.mr_n62096784)
print v(xbgr.mr_n62097216)
print v(xbgr.mr_n62097648)
print v(xbgr.mr_n62098080)
print v(xbgr.mr_n62098512)
print v(xbgr.mr_n62098944)
print v(xbgr.mr_n62099376)
print v(xbgr.mr_n62099808)
print v(xbgr.mr_n62100240)
print v(xbgr.mr_n62100672)
print v(xbgr.mr_n62101104)
print v(xbgr.mr_n62101536)
print v(xbgr.mr_n62101968)
print v(xbgr.mr_n62102400)
print v(xbgr.mr_n62102832)
print v(xbgr.mr_n62103264)
print v(xbgr.mr_n62103696)
print v(xbgr.mr_n62104128)
print v(xbgr.mr_n62104560)
print v(xbgr.mr_n62104992)
print v(xbgr.mr_n62105424)
print v(xbgr.mr_n62105856)
print v(xbgr.mr_n62106288)
print v(xbgr.mr_n62106720)
print v(xbgr.mr_n62107152)
print v(xbgr.mr_n62107584)
print v(xbgr.mr_n62108016)
print v(xbgr.mr_n62108448)
print v(xbgr.mr_n62108880)
print v(xbgr.mr_n62109312)
print v(xbgr.mr_n62109744)
print v(xbgr.mr_n62110176)
print v(xbgr.mr_n62110608)
print v(xbgr.mr_n62111040)
print v(xbgr.mr_n62111472)
print v(xbgr.mr_n62111904)
print v(xbgr.mr_n62112336)
print v(xbgr.mr_n62112768)
print v(xbgr.mr_n62113088)
print v(xbgr.mr_n62113200)
print v(xbgr.mr_n62113520)
print v(xbgr.mr_n62113632)
print v(xbgr.mr_n62113952)
print v(xbgr.mr_n62114064)
print v(xbgr.mr_n62114384)
print v(xbgr.mr_n62114496)
print v(xbgr.mr_n62114816)
print v(xbgr.mr_n62114928)
print v(xbgr.mr_n62115248)
print v(xbgr.mr_n62115360)
print v(xbgr.mr_n62115680)
print v(xbgr.mr_n62115792)
print v(xbgr.mr_n62116112)
print v(xbgr.mr_n62116224)
print v(xbgr.mr_n62116544)
print v(xbgr.mr_n62116656)
print v(xbgr.mr_n62116976)
print v(xbgr.mr_n62117088)
print v(xbgr.mr_n62117408)
print v(xbgr.mr_n62117520)
print v(xbgr.mr_n62117840)
print v(xbgr.mr_n62117952)
print v(xbgr.mr_n62118272)
print v(xbgr.mr_n62118384)
print v(xbgr.mr_n62118704)
print v(xbgr.mr_n62118816)
print v(xbgr.mr_n62119136)
print v(xbgr.mr_n62119248)
print v(xbgr.mr_n62119568)
print v(xbgr.mr_n62119680)
print v(xbgr.mr_n62120000)
print v(xbgr.mr_n62120112)
print v(xbgr.mr_n62120432)
print v(xbgr.mr_n62120544)
print v(xbgr.mr_n62120864)
print v(xbgr.mr_n62120976)
print v(xbgr.mr_n62121296)
print v(xbgr.mr_n62121408)
print v(xbgr.mr_n62121728)
print v(xbgr.mr_n62121840)
print v(xbgr.mr_n62122160)
print v(xbgr.mr_n62122272)
print v(xbgr.mr_n62122592)
print v(xbgr.mr_n62122704)
print v(xbgr.mr_n62123024)
print v(xbgr.mr_n62123136)
print v(xbgr.mr_n62123456)
print v(xbgr.mr_n62123568)
print v(xbgr.mr_n62123888)
print v(xbgr.mr_n62124000)
print v(xbgr.mr_n62124320)
print v(xbgr.mr_n62124432)
print v(xbgr.mr_n62124752)
print v(xbgr.mr_n62124864)
print v(xbgr.mr_n62125184)
print v(xbgr.mr_n62125296)
print v(xbgr.mr_n62125616)
print v(xbgr.mr_n62125728)
print v(xbgr.mr_n62126048)
print v(xbgr.mr_n62126160)
print v(xbgr.mr_n62126480)
print v(xbgr.mr_n62126592)
print v(xbgr.mr_n62126912)
print v(xbgr.mr_n62127024)
print v(xbgr.mr_n62127344)
print v(xbgr.mr_n62127456)
print v(xbgr.mr_n62127776)
print v(xbgr.mr_n62127888)
print v(xbgr.mr_n62128208)
print v(xbgr.mr_n62128320)
print v(xbgr.mr_n62128640)
print v(xbgr.mr_n62128752)
print v(xbgr.mr_n62129072)
print v(xbgr.mr_n62129184)
print v(xbgr.mr_n62129504)
print v(xbgr.mr_n62129616)
print v(xbgr.mr_n62129936)
print v(xbgr.mr_n62130048)
print v(xbgr.mr_n62130368)
print v(xbgr.mr_n62130480)
print v(xbgr.mr_n62130800)
print v(xbgr.mr_n62130912)
print v(xbgr.mr_n62131232)
print v(xbgr.mr_n62131344)
print v(xbgr.mr_n62131664)
print v(xbgr.mr_n62131776)
print v(xbgr.mr_n62132096)
print v(xbgr.mr_n62132208)
print v(xbgr.mr_n62132528)
print v(xbgr.mr_n62132640)
print v(xbgr.mr_n62132960)
print v(xbgr.mr_n62133072)
print v(xbgr.mr_n62133392)
print v(xbgr.mr_n62133504)
print v(xbgr.mr_n62133824)
print v(xbgr.mr_n62133936)
print v(xbgr.mr_n62134256)
print v(xbgr.mr_n62134368)
print v(xbgr.mr_n62134688)
print v(xbgr.mr_n62134800)
print v(xbgr.mr_n62135120)
print v(xbgr.mr_n62135232)
print v(xbgr.mr_n62135552)
print v(xbgr.mr_n62135664)
print v(xbgr.mr_n62135984)
print v(xbgr.mr_n62136096)
print v(xbgr.mr_n62136416)
print v(xbgr.mr_n62136528)
print v(xbgr.mr_n62136848)
print v(xbgr.mr_n62136960)
print v(xbgr.mr_n62137280)
print v(xbgr.mr_n62137392)
print v(xbgr.mr_n62137712)
print v(xbgr.mr_n62137824)
print v(xbgr.mr_n62138144)
print v(xbgr.mr_n62138256)
print v(xbgr.mr_n62138576)
print v(xbgr.mr_n62138688)
print v(xbgr.mr_n62139008)
print v(xbgr.mr_n62139120)
print v(xbgr.mr_n62139440)
print v(xbgr.mr_n62139552)
print v(xbgr.mr_n62139872)
print v(xbgr.mr_n62139984)
print v(xbgr.mr_n62140304)
print v(xbgr.mr_n62140416)
print v(xbgr.mr_n62140736)
print v(xbgr.mr_n62140848)
print v(xbgr.mr_n62141168)
print v(xbgr.mr_n62141280)
print v(xbgr.mr_n62141600)
print v(xbgr.mr_n62141712)
print v(xbgr.mr_n62142032)
print v(xbgr.mr_n62142144)
print v(xbgr.mr_n62142464)
print v(xbgr.mr_n62142576)
print v(xbgr.mr_n62142896)
print v(xbgr.mr_n62143008)
print v(xbgr.mr_n62143328)
print v(xbgr.mr_n62143440)
print v(xbgr.mr_n62143760)
print v(xbgr.mr_n62143872)
print v(xbgr.mr_n62144192)
print v(xbgr.mr_n62144304)
print v(xbgr.mr_n62144624)
print v(xbgr.mr_n62144736)
print v(xbgr.mr_n62145056)
print v(xbgr.mr_n62145168)
print v(xbgr.mr_n62145488)
print v(xbgr.mr_n62145600)
print v(xbgr.mr_n62145920)
print v(xbgr.mr_n62146032)
print v(xbgr.mr_n62146352)
print v(xbgr.mr_n62146464)
print v(xbgr.mr_n62146784)
print v(xbgr.mr_n62146896)
print v(xbgr.mr_n62147216)
print v(xbgr.mr_n62147328)
print v(xbgr.mr_n62147648)
print v(xbgr.mr_n62147760)
print v(xbgr.mr_n62148080)
print v(xbgr.mr_n62148192)
print v(xbgr.mr_n62148512)
print v(xbgr.mr_n62148624)
print v(xbgr.mr_n62148944)
print v(xbgr.mr_n62149056)
print v(xbgr.mr_n62149376)
print v(xbgr.mr_n62149488)
print v(xbgr.mr_n62149808)
print v(xbgr.mr_n62149920)
print v(xbgr.mr_n62150240)
print v(xbgr.mr_n62150352)
print v(xbgr.mr_n62150672)
print v(xbgr.mr_n62150784)
print v(xbgr.mr_n62151104)
print v(xbgr.mr_n62151216)
print v(xbgr.mr_n62151536)
print v(xbgr.mr_n62151648)
print v(xbgr.mr_n62151968)
print v(xbgr.mr_n62152080)
print v(xbgr.mr_n62152400)
print v(xbgr.mr_n62152512)
print v(xbgr.mr_n62152832)
print v(xbgr.mr_n62152944)
print v(xbgr.mr_n62153264)
print v(xbgr.mr_n62153376)
print v(xbgr.mr_n62153696)
print v(xbgr.mr_n62153808)
print v(xbgr.mr_n62154128)
print v(xbgr.mr_n62154240)
print v(xbgr.mr_n62154560)
print v(xbgr.mr_n62154672)
print v(xbgr.mr_n62154992)
print v(xbgr.mr_n62155104)
print v(xbgr.mr_n62155424)
print v(xbgr.mr_n62155536)
print v(xbgr.mr_n62155856)
print v(xbgr.mr_n62155968)
print v(xbgr.mr_n62156288)
print v(xbgr.mr_n62156400)
print v(xbgr.mr_n62156720)
print v(xbgr.mr_n62156832)
print v(xbgr.mr_n62157152)
print v(xbgr.mr_n62157264)
print v(xbgr.mr_n62157584)
print v(xbgr.mr_n62157696)
print v(xbgr.mr_n62158016)
print v(xbgr.mr_n62158128)
print v(xbgr.mr_n62158448)
print v(xbgr.mr_n62158560)
print v(xbgr.mr_n62158880)
print v(xbgr.mr_n62158992)
print v(xbgr.mr_n62159312)
print v(xbgr.mr_n62159424)
print v(xbgr.mr_n62159744)
print v(xbgr.mr_n62159856)
print v(xbgr.mr_n62160176)
print v(xbgr.mr_n62160288)
print v(xbgr.mr_n62160608)
print v(xbgr.mr_n62160720)
print v(xbgr.mr_n62161040)
print v(xbgr.mr_n62161152)
print v(xbgr.mr_n62161472)
print v(xbgr.mr_n62161584)
print v(xbgr.mr_n62161904)
print v(xbgr.mr_n62162016)
print v(xbgr.mr_n62162336)
print v(xbgr.mr_n62162448)
print v(xbgr.mr_n62162768)
print v(xbgr.mr_n62162880)
print v(xbgr.mr_n62163200)
print v(xbgr.mr_n62163312)
print v(xbgr.mr_n62163632)
print v(xbgr.mr_n62163744)
print v(xbgr.mr_n62164064)
print v(xbgr.mr_n62164176)
print v(xbgr.mr_n62164496)
print v(xbgr.mr_n62164608)
print v(xbgr.mr_n62164928)
print v(xbgr.mr_n62165040)
print v(xbgr.mr_n62165360)
print v(xbgr.mr_n62165472)
print v(xbgr.mr_n62165792)
print v(xbgr.mr_n62165904)
print v(xbgr.mr_n62166224)
print v(xbgr.mr_n62166336)
print v(xbgr.mr_n62166656)
print v(xbgr.mr_n62166768)
print v(xbgr.mr_n62167088)
print v(xbgr.mr_n62167200)
print v(xbgr.mr_n62167520)
print v(xbgr.mr_n62167632)
print v(xbgr.mr_n62167952)
print v(xbgr.mr_n62168064)
print v(xbgr.mr_n62168384)
print v(xbgr.mr_n62168496)
print v(xbgr.mr_n62168816)
print v(xbgr.mr_n62168928)
print v(xbgr.mr_n62169248)
print v(xbgr.mr_n62169360)
print v(xbgr.mr_n62169680)
print v(xbgr.mr_n62169792)
print v(xbgr.mr_n62170112)
print v(xbgr.mr_n62170224)
print v(xbgr.mr_n62170544)
print v(xbgr.mr_n62170656)
print v(xbgr.mr_n62170976)
print v(xbgr.mr_n62171088)
print v(xbgr.mr_n62171408)
print v(xbgr.mr_n62171520)
print v(xbgr.mr_n62171840)
print v(xbgr.mr_n62171952)
print v(xbgr.mr_n62172272)
print v(xbgr.mr_n62172384)
print v(xbgr.mr_n62172704)
print v(xbgr.mr_n62172816)
print v(xbgr.mr_n62173136)
print v(xbgr.mr_n62173248)
print v(xbgr.mr_n62173568)
print v(xbgr.mr_n62173680)
print v(xbgr.mr_n62174000)
print v(xbgr.mr_n62174112)
print v(xbgr.mr_n62174432)
print v(xbgr.mr_n62174544)
print v(xbgr.mr_n62174864)
print v(xbgr.mr_n62174976)
print v(xbgr.mr_n62175296)
print v(xbgr.mr_n62175408)
print v(xbgr.mr_n62175728)
print v(xbgr.mr_n62175840)
print v(xbgr.mr_n62176272)
print v(xbgr.mr_n62176704)
print v(xbgr.mr_n62177136)
print v(xbgr.mr_n62177568)
print v(xbgr.mr_n62178000)
print v(xbgr.mr_n62178432)
print v(xbgr.mr_n62178864)
print v(xbgr.mr_n62179296)
print v(xbgr.mr_n62179728)
print v(xbgr.mr_n62180160)
print v(xbgr.mr_n62180592)
print v(xbgr.mr_n62181024)
print v(xbgr.mr_n62181456)
print v(xbgr.mr_n62181888)
print v(xbgr.mr_n62182320)
print v(xbgr.mr_n62182752)
print v(xbgr.mr_n62183184)
print v(xbgr.mr_n62183616)
print v(xbgr.mr_n62184048)
print v(xbgr.mr_n62184480)
print v(xbgr.mr_n62184912)
print v(xbgr.mr_n62185344)
print v(xbgr.mr_n62185776)
print v(xbgr.mr_n62186208)
print v(xbgr.mr_n62186640)
print v(xbgr.mr_n62187072)
print v(xbgr.mr_n62187504)
print v(xbgr.mr_n62187936)
print v(xbgr.mr_n62188368)
print v(xbgr.mr_n62188800)
print v(xbgr.mr_n62189232)
print v(xbgr.mr_n62189664)
print v(xbgr.mr_n62190096)
print v(xbgr.mr_n62190528)
print v(xbgr.mr_n62190960)
print v(xbgr.mr_n62191392)
print v(xbgr.mr_n62191824)
print v(xbgr.mr_n62192256)
print v(xbgr.mr_n62192688)
print v(xbgr.mr_n62193120)
print v(xbgr.mr_n62193552)
print v(xbgr.mr_n62193984)
print v(xbgr.mr_n62194416)
print v(xbgr.mr_n62194848)
print v(xbgr.mr_n62195280)
print v(xbgr.mr_n62195712)
print v(xbgr.mr_n62196144)
print v(xbgr.mr_n62196576)
print v(xbgr.mr_n62197008)
print v(xbgr.mr_n62197440)
print v(xbgr.mr_n62197872)
print v(xbgr.mr_n62198304)
print v(xbgr.mr_n62198736)
print v(xbgr.mr_n62199168)
print v(xbgr.mr_n62199600)
print v(xbgr.mr_n62200032)
print v(xbgr.mr_n62200464)
print v(xbgr.mr_n62200896)
print v(xbgr.mr_n62201328)
print v(xbgr.mr_n62201760)
print v(xbgr.mr_n62202192)
print v(xbgr.mr_n62202624)
print v(xbgr.mr_n62203056)
print v(xbgr.mr_n62203488)
print v(xbgr.mr_n62203920)
print v(xbgr.mr_n62204352)
print v(xbgr.mr_n62204784)
print v(xbgr.mr_n62205216)
print v(xbgr.mr_n62205648)
print v(xbgr.mr_n62206080)
print v(xbgr.mr_n62206512)
print v(xbgr.mr_n62206944)
print v(xbgr.mr_n62207376)
print v(xbgr.mr_n62207808)
print v(xbgr.mr_n62208240)
print v(xbgr.mr_n62208672)
print v(xbgr.mr_n62209104)
print v(xbgr.mr_n62209536)
print v(xbgr.mr_n62209968)
print v(xbgr.mr_n62210400)
print v(xbgr.mr_n62210832)
print v(xbgr.mr_n62211264)
print v(xbgr.mr_n62211696)
print v(xbgr.mr_n62212128)
print v(xbgr.mr_n62212560)
print v(xbgr.mr_n62212992)
print v(xbgr.mr_n62213424)
print v(xbgr.mr_n62213856)
print v(xbgr.mr_n62214288)
print v(xbgr.mr_n62214720)
print v(xbgr.mr_n62215152)
print v(xbgr.mr_n62215584)
print v(xbgr.mr_n62216016)
print v(xbgr.mr_n62216448)
print v(xbgr.mr_n62216880)
print v(xbgr.mr_n62217312)
print v(xbgr.mr_n62217744)
print v(xbgr.mr_n62218176)
print v(xbgr.mr_n62218608)
print v(xbgr.mr_n62219040)
print v(xbgr.mr_n62219472)
print v(xbgr.mr_n62219904)
print v(xbgr.mr_n62220336)
print v(xbgr.mr_n62220768)
print v(xbgr.mr_n62221200)
print v(xbgr.mr_n62221632)
print v(xbgr.mr_n62222064)
print v(xbgr.mr_n62222496)
print v(xbgr.mr_n62222928)
print v(xbgr.mr_n62223360)
print v(xbgr.mr_n62223792)
print v(xbgr.mr_n62224224)
print v(xbgr.mr_n62224656)
print v(xbgr.mr_n62225088)
print v(xbgr.mr_n62225520)
print v(xbgr.mr_n62225952)
print v(xbgr.mr_n62226384)
print v(xbgr.mr_n62226816)
print v(xbgr.mr_n62227248)
print v(xbgr.mr_n62227680)
print v(xbgr.mr_n62228112)
print v(xbgr.mr_n62228544)
print v(xbgr.mr_n62228976)
print v(xbgr.mr_n62229408)
print v(xbgr.mr_n62229840)
print v(xbgr.mr_n62230272)
print v(xbgr.mr_n62230704)
print v(xbgr.mr_n62231136)
print v(xbgr.mr_n62231568)
print v(xbgr.mr_n62232000)
print v(xbgr.mr_n62232432)
print v(xbgr.mr_n62232864)
print v(xbgr.mr_n62233296)
print v(xbgr.mr_n62233728)
print v(xbgr.mr_n62234160)
print v(xbgr.mr_n62234592)
print v(xbgr.mr_n62235024)
print v(xbgr.mr_n62235456)
print v(xbgr.mr_n62235888)
print v(xbgr.mr_n62236320)
print v(xbgr.mr_n62236752)
print v(xbgr.mr_n62237184)
print v(xbgr.mr_n62237616)
print v(xbgr.mr_n62238048)
print v(xbgr.mr_n62238480)
print v(xbgr.mr_n62238912)
print v(xbgr.mr_n62239344)
print v(xbgr.mr_n62239776)
print v(xbgr.mr_n62240208)
print v(xbgr.mr_n62240640)
print v(xbgr.mr_n62241072)
print v(xbgr.mr_n62241504)
print v(xbgr.mr_n62241936)
print v(xbgr.mr_n62242368)
print v(xbgr.mr_n62242800)
print v(xbgr.mr_n62243232)
print v(xbgr.mr_n62243664)
print v(xbgr.mr_n62244096)
print v(xbgr.mr_n62244528)
print v(xbgr.mr_n62244960)
print v(xbgr.mr_n62245392)
print v(xbgr.mr_n62245824)
print v(xbgr.mr_n62246256)
print v(xbgr.mr_n62246688)
print v(xbgr.mr_n62247120)
print v(xbgr.mr_n62247552)
print v(xbgr.mr_n62247984)
print v(xbgr.mr_n62248416)
print v(xbgr.mr_n62248848)
print v(xbgr.mr_n62249280)
print v(xbgr.mr_n62249712)
print v(xbgr.mr_n62250144)
print v(xbgr.mr_n62250576)
print v(xbgr.mr_n62251008)
print v(xbgr.mr_n62251440)
print v(xbgr.mr_n62251872)
print v(xbgr.mr_n62252304)
print v(xbgr.mr_n62252736)
print v(xbgr.mr_n62253168)
print v(xbgr.mr_n62253600)
print v(xbgr.mr_n62254032)
print v(xbgr.mr_n62254464)
print v(xbgr.mr_n62254896)
print v(xbgr.mr_n62255328)
print v(xbgr.mr_n62255760)
print v(xbgr.mr_n62256192)
print v(xbgr.mr_n62256624)
print v(xbgr.mr_n62257056)
print v(xbgr.mr_n62257488)
print v(xbgr.mr_n62257920)
print v(xbgr.mr_n62258352)
print v(xbgr.mr_n62258784)
print v(xbgr.mr_n62259216)
print v(xbgr.mr_n62259648)
print v(xbgr.mr_n62260080)
print v(xbgr.mr_n62260512)
print v(xbgr.mr_n62260944)
print v(xbgr.mr_n62261376)
print v(xbgr.mr_n62261808)
print v(xbgr.mr_n62262240)
print v(xbgr.mr_n62262672)
print v(xbgr.mr_n62263104)
print v(xbgr.mr_n62263536)
print v(xbgr.mr_n62263968)
print v(xbgr.mr_n62264400)
print v(xbgr.mr_n62264832)
print v(xbgr.mr_n62265264)
print v(xbgr.mr_n62265696)
print v(xbgr.mr_n62266128)
print v(xbgr.mr_n62266560)
print v(xbgr.mr_n62266992)
print v(xbgr.mr_n62267424)
print v(xbgr.mr_n62267856)
print v(xbgr.mr_n62268288)
print v(xbgr.mr_n62268608)
print v(xbgr.mr_n62268720)
print v(xbgr.mr_n62269040)
print v(xbgr.mr_n62269152)
print v(xbgr.mr_n62269472)
print v(xbgr.mr_n62269584)
print v(xbgr.mr_n62269904)
print v(xbgr.mr_n62270016)
print v(xbgr.mr_n62270336)
print v(xbgr.mr_n62270448)
print v(xbgr.mr_n62270768)
print v(xbgr.mr_n62270880)
print v(xbgr.mr_n62271200)
print v(xbgr.mr_n62271312)
print v(xbgr.mr_n62271632)
print v(xbgr.mr_n62271744)
print v(xbgr.mr_n62272064)
print v(xbgr.mr_n62272176)
print v(xbgr.mr_n62272496)
print v(xbgr.mr_n62272608)
print v(xbgr.mr_n62272928)
print v(xbgr.mr_n62273040)
print v(xbgr.mr_n62273360)
print v(xbgr.mr_n62273472)
print v(xbgr.mr_n62273792)
print v(xbgr.mr_n62273904)
print v(xbgr.mr_n62274224)
print v(xbgr.mr_n62274336)
print v(xbgr.mr_n62274656)
print v(xbgr.mr_n62274768)
print v(xbgr.mr_n62275088)
print v(xbgr.mr_n62275200)
print v(xbgr.mr_n62275520)
print v(xbgr.mr_n62275632)
print v(xbgr.mr_n62275952)
print v(xbgr.mr_n62276064)
print v(xbgr.mr_n62276384)
print v(xbgr.mr_n62276496)
print v(xbgr.mr_n62276816)
print v(xbgr.mr_n62276928)
print v(xbgr.mr_n62277248)
print v(xbgr.mr_n62277360)
print v(xbgr.mr_n62277680)
print v(xbgr.mr_n62277792)
print v(xbgr.mr_n62278112)
print v(xbgr.mr_n62278224)
print v(xbgr.mr_n62278544)
print v(xbgr.mr_n62278656)
print v(xbgr.mr_n62278976)
print v(xbgr.mr_n62279088)
print v(xbgr.mr_n62279408)
print v(xbgr.mr_n62279520)
print v(xbgr.mr_n62279840)
print v(xbgr.mr_n62279952)
print v(xbgr.mr_n62280272)
print v(xbgr.mr_n62280384)
print v(xbgr.mr_n62280704)
print v(xbgr.mr_n62280816)
print v(xbgr.mr_n62281136)
print v(xbgr.mr_n62281248)
print v(xbgr.mr_n62281568)
print v(xbgr.mr_n62281680)
print v(xbgr.mr_n62282000)
print v(xbgr.mr_n62282112)
print v(xbgr.mr_n62282432)
print v(xbgr.mr_n62282544)
print v(xbgr.mr_n62282864)
print v(xbgr.mr_n62282976)
print v(xbgr.mr_n62283296)
print v(xbgr.mr_n62283408)
print v(xbgr.mr_n62283728)
print v(xbgr.mr_n62283840)
print v(xbgr.mr_n62284160)
print v(xbgr.mr_n62284272)
print v(xbgr.mr_n62284592)
print v(xbgr.mr_n62284704)
print v(xbgr.mr_n62285024)
print v(xbgr.mr_n62285136)
print v(xbgr.mr_n62285456)
print v(xbgr.mr_n62285568)
print v(xbgr.mr_n62285888)
print v(xbgr.mr_n62286000)
print v(xbgr.mr_n62286320)
print v(xbgr.mr_n62286432)
print v(xbgr.mr_n62286752)
print v(xbgr.mr_n62286864)
print v(xbgr.mr_n62287184)
print v(xbgr.mr_n62287296)
print v(xbgr.mr_n62287616)
print v(xbgr.mr_n62287728)
print v(xbgr.mr_n62288048)
print v(xbgr.mr_n62288160)
print v(xbgr.mr_n62288480)
print v(xbgr.mr_n62288592)
print v(xbgr.mr_n62288912)
print v(xbgr.mr_n62289024)
print v(xbgr.mr_n62289344)
print v(xbgr.mr_n62289456)
print v(xbgr.mr_n62289776)
print v(xbgr.mr_n62289888)
print v(xbgr.mr_n62290208)
print v(xbgr.mr_n62290320)
print v(xbgr.mr_n62290640)
print v(xbgr.mr_n62290752)
print v(xbgr.mr_n62291072)
print v(xbgr.mr_n62291184)
print v(xbgr.mr_n62291504)
print v(xbgr.mr_n62291616)
print v(xbgr.mr_n62291936)
print v(xbgr.mr_n62292048)
print v(xbgr.mr_n62292368)
print v(xbgr.mr_n62292480)
print v(xbgr.mr_n62292800)
print v(xbgr.mr_n62292912)
print v(xbgr.mr_n62293232)
print v(xbgr.mr_n62293344)
print v(xbgr.mr_n62293664)
print v(xbgr.mr_n62293776)
print v(xbgr.mr_n62294096)
print v(xbgr.mr_n62294208)
print v(xbgr.mr_n62294528)
print v(xbgr.mr_n62294640)
print v(xbgr.mr_n62294960)
print v(xbgr.mr_n62295072)
print v(xbgr.mr_n62295392)
print v(xbgr.mr_n62295504)
print v(xbgr.mr_n62295824)
print v(xbgr.mr_n62295936)
print v(xbgr.mr_n62296256)
print v(xbgr.mr_n62296368)
print v(xbgr.mr_n62296688)
print v(xbgr.mr_n62296800)
print v(xbgr.mr_n62297120)
print v(xbgr.mr_n62297232)
print v(xbgr.mr_n62297552)
print v(xbgr.mr_n62297664)
print v(xbgr.mr_n62297984)
print v(xbgr.mr_n62298096)
print v(xbgr.mr_n62298416)
print v(xbgr.mr_n62298528)
print v(xbgr.mr_n62298848)
print v(xbgr.mr_n62298960)
print v(xbgr.mr_n62299280)
print v(xbgr.mr_n62299392)
print v(xbgr.mr_n62299712)
print v(xbgr.mr_n62299824)
print v(xbgr.mr_n62300144)
print v(xbgr.mr_n62300256)
print v(xbgr.mr_n62300576)
print v(xbgr.mr_n62300688)
print v(xbgr.mr_n62301008)
print v(xbgr.mr_n62301120)
print v(xbgr.mr_n62301440)
print v(xbgr.mr_n62301552)
print v(xbgr.mr_n62301872)
print v(xbgr.mr_n62301984)
print v(xbgr.mr_n62302304)
print v(xbgr.mr_n62302416)
print v(xbgr.mr_n62302736)
print v(xbgr.mr_n62302848)
print v(xbgr.mr_n62303168)
print v(xbgr.mr_n62303280)
print v(xbgr.mr_n62303600)
print v(xbgr.mr_n62303712)
print v(xbgr.mr_n62304032)
print v(xbgr.mr_n62304144)
print v(xbgr.mr_n62304464)
print v(xbgr.mr_n62304576)
print v(xbgr.mr_n62304896)
print v(xbgr.mr_n62305008)
print v(xbgr.mr_n62305328)
print v(xbgr.mr_n62305440)
print v(xbgr.mr_n62305760)
print v(xbgr.mr_n62305872)
print v(xbgr.mr_n62306192)
print v(xbgr.mr_n62306304)
print v(xbgr.mr_n62306624)
print v(xbgr.mr_n62306736)
print v(xbgr.mr_n62307056)
print v(xbgr.mr_n62307168)
print v(xbgr.mr_n62307488)
print v(xbgr.mr_n62307600)
print v(xbgr.mr_n62307920)
print v(xbgr.mr_n62308032)
print v(xbgr.mr_n62308352)
print v(xbgr.mr_n62308464)
print v(xbgr.mr_n62308784)
print v(xbgr.mr_n62308896)
print v(xbgr.mr_n62309216)
print v(xbgr.mr_n62309328)
print v(xbgr.mr_n62309648)
print v(xbgr.mr_n62309760)
print v(xbgr.mr_n62310080)
print v(xbgr.mr_n62310192)
print v(xbgr.mr_n62310512)
print v(xbgr.mr_n62310624)
print v(xbgr.mr_n62310944)
print v(xbgr.mr_n62311056)
print v(xbgr.mr_n62311376)
print v(xbgr.mr_n62311488)
print v(xbgr.mr_n62311808)
print v(xbgr.mr_n62311920)
print v(xbgr.mr_n62312240)
print v(xbgr.mr_n62312352)
print v(xbgr.mr_n62312672)
print v(xbgr.mr_n62312784)
print v(xbgr.mr_n62313104)
print v(xbgr.mr_n62313216)
print v(xbgr.mr_n62313536)
print v(xbgr.mr_n62313648)
print v(xbgr.mr_n62313968)
print v(xbgr.mr_n62314080)
print v(xbgr.mr_n62314400)
print v(xbgr.mr_n62314512)
print v(xbgr.mr_n62314832)
print v(xbgr.mr_n62314944)
print v(xbgr.mr_n62315264)
print v(xbgr.mr_n62315376)
print v(xbgr.mr_n62315696)
print v(xbgr.mr_n62315808)
print v(xbgr.mr_n62316128)
print v(xbgr.mr_n62316240)
print v(xbgr.mr_n62316560)
print v(xbgr.mr_n62316672)
print v(xbgr.mr_n62316992)
print v(xbgr.mr_n62317104)
print v(xbgr.mr_n62317424)
print v(xbgr.mr_n62317536)
print v(xbgr.mr_n62317856)
print v(xbgr.mr_n62317968)
print v(xbgr.mr_n62318288)
print v(xbgr.mr_n62318400)
print v(xbgr.mr_n62318720)
print v(xbgr.mr_n62318832)
print v(xbgr.mr_n62319152)
print v(xbgr.mr_n62319264)
print v(xbgr.mr_n62319584)
print v(xbgr.mr_n62319696)
print v(xbgr.mr_n62320016)
print v(xbgr.mr_n62320128)
print v(xbgr.mr_n62320448)
print v(xbgr.mr_n62320560)
print v(xbgr.mr_n62320880)
print v(xbgr.mr_n62320992)
print v(xbgr.mr_n62321312)
print v(xbgr.mr_n62321424)
print v(xbgr.mr_n62321744)
print v(xbgr.mr_n62321856)
print v(xbgr.mr_n62322176)
print v(xbgr.mr_n62322288)
print v(xbgr.mr_n62322608)
print v(xbgr.mr_n62322720)
print v(xbgr.mr_n62323040)
print v(xbgr.mr_n62323152)
print v(xbgr.mr_n62323472)
print v(xbgr.mr_n62323584)
print v(xbgr.mr_n62323904)
print v(xbgr.mr_n62324016)
print v(xbgr.mr_n62324336)
print v(xbgr.mr_n62324448)
print v(xbgr.mr_n62324768)
print v(xbgr.mr_n62324880)
print v(xbgr.mr_n62325200)
print v(xbgr.mr_n62325312)
print v(xbgr.mr_n62325632)
print v(xbgr.mr_n62325744)
print v(xbgr.mr_n62326064)
print v(xbgr.mr_n62326176)
print v(xbgr.mr_n62326496)
print v(xbgr.mr_n62326608)
print v(xbgr.mr_n62326928)
print v(xbgr.mr_n62327040)
print v(xbgr.mr_n62327360)
print v(xbgr.mr_n62327472)
print v(xbgr.mr_n62327792)
print v(xbgr.mr_n62327904)
print v(xbgr.mr_n62328224)
print v(xbgr.mr_n62328336)
print v(xbgr.mr_n62328656)
print v(xbgr.mr_n62328768)
print v(xbgr.mr_n62329088)
print v(xbgr.mr_n62329200)
print v(xbgr.mr_n62329520)
print v(xbgr.mr_n62329632)
print v(xbgr.mr_n62329952)
print v(xbgr.mr_n62330064)
print v(xbgr.mr_n62330384)
print v(xbgr.mr_n62330496)
print v(xbgr.mr_n62330816)
print v(xbgr.mr_n62330928)
print v(xbgr.mr_n62331248)
print v(xbgr.mr_n62331360)
print v(xbgr.mr_n62331680)
print v(xbgr.mr_n62331792)
print v(xbgr.mr_n62332112)
print v(xbgr.mr_n62332224)
print v(xbgr.mr_n62332544)
print v(xbgr.mr_n62332656)
print v(xbgr.mr_n62332976)
print v(xbgr.mr_n62333088)
print v(xbgr.mr_n62333408)
print v(xbgr.mr_n62333520)
print v(xbgr.mr_n62333840)
print v(xbgr.mr_n62333952)
print v(xbgr.mr_n62334272)
print v(xbgr.mr_n62334384)
print v(xbgr.mr_n62334704)
print v(xbgr.mr_n62334816)
print v(xbgr.mr_n62335136)
print v(xbgr.mr_n62335248)
print v(xbgr.mr_n62335568)
print v(xbgr.mr_n62335680)
print v(xbgr.mr_n62336000)
print v(xbgr.mr_n62336112)
print v(xbgr.mr_n62336432)
print v(xbgr.mr_n62336544)
print v(xbgr.mr_n62336864)
print v(xbgr.mr_n62336976)
print v(xbgr.mr_n62337296)
print v(xbgr.mr_n62337408)
print v(xbgr.mr_n62337728)
print v(xbgr.mr_n62337840)
print v(xbgr.mr_n62338160)
print v(xbgr.mr_n62338272)
print v(xbgr.mr_n62338592)
print v(xbgr.mr_n62338704)
print v(xbgr.mr_n62339024)
print v(xbgr.mr_n62339136)
print v(xbgr.mr_n62339456)
print v(xbgr.mr_n62339568)
print v(xbgr.mr_n62339888)
print v(xbgr.mr_n62340000)
print v(xbgr.mr_n62340320)
print v(xbgr.mr_n62340432)
print v(xbgr.mr_n62340752)
print v(xbgr.mr_n62340864)
print v(xbgr.mr_n62341184)
print v(xbgr.mr_n62341296)
print v(xbgr.mr_n62341616)
print v(xbgr.mr_n62341728)
print v(xbgr.mr_n62342048)
print v(xbgr.mr_n62342160)
print v(xbgr.mr_n62342480)
print v(xbgr.mr_n62342592)
print v(xbgr.mr_n62342912)
print v(xbgr.mr_n62343024)
print v(xbgr.mr_n62343344)
print v(xbgr.mr_n62343456)
print v(xbgr.mr_n62343776)
print v(xbgr.mr_n62343888)
print v(xbgr.mr_n62344208)
print v(xbgr.mr_n62344320)
print v(xbgr.mr_n62344640)
print v(xbgr.mr_n62344752)
print v(xbgr.mr_n62345072)
print v(xbgr.mr_n62345184)
print v(xbgr.mr_n62345504)
print v(xbgr.mr_n62345616)
print v(xbgr.mr_n62345936)
print v(xbgr.mr_n62346048)
print v(xbgr.mr_n62346368)
print v(xbgr.mr_n62346480)
print v(xbgr.mr_n62346800)
print v(xbgr.mr_n62346912)
print v(xbgr.mr_n62347232)
print v(xbgr.mr_n62347344)
print v(xbgr.mr_n62347664)
print v(xbgr.mr_n62347776)
print v(xbgr.mr_n62348096)
print v(xbgr.mr_n62348208)
print v(xbgr.mr_n62348528)
print v(xbgr.mr_n62348640)
print v(xbgr.mr_n62348960)
print v(xbgr.mr_n62349072)
print v(xbgr.mr_n62349392)
print v(xbgr.mr_n62349504)
print v(xbgr.mr_n62349824)
print v(xbgr.mr_n62349936)
print v(xbgr.mr_n62350256)
print v(xbgr.mr_n62350368)
print v(xbgr.mr_n62350688)
print v(xbgr.mr_n62350800)
print v(xbgr.mr_n62351120)
print v(xbgr.mr_n62351232)
print v(xbgr.mr_n62351552)
print v(xbgr.mr_n62351664)
print v(xbgr.mr_n62351984)
print v(xbgr.mr_n62352096)
print v(xbgr.mr_n62352416)
print v(xbgr.mr_n62352528)
print v(xbgr.mr_n62352848)
print v(xbgr.mr_n62352960)
print v(xbgr.mr_n62353280)
print v(xbgr.mr_n62353392)
print v(xbgr.mr_n62353712)
print v(xbgr.mr_n62353824)
print v(xbgr.mr_n62354144)
print v(xbgr.mr_n62354256)
print v(xbgr.mr_n62354576)
print v(xbgr.mr_n62354688)
print v(xbgr.mr_n62355008)
print v(xbgr.mr_n62355120)
print v(xbgr.mr_n62355440)
print v(xbgr.mr_n62355552)
print v(xbgr.mr_n62355872)
print v(xbgr.mr_n62355984)
print v(xbgr.mr_n62356304)
print v(xbgr.mr_n62356416)
print v(xbgr.mr_n62356736)
print v(xbgr.mr_n62356848)
print v(xbgr.mr_n62357168)
print v(xbgr.mr_n62357280)
print v(xbgr.mr_n62357600)
print v(xbgr.mr_n62357712)
print v(xbgr.mr_n62358032)
print v(xbgr.mr_n62358144)
print v(xbgr.mr_n62358464)
print v(xbgr.mr_n62358576)
print v(xbgr.mr_n62358896)
print v(xbgr.mr_n62359008)
print v(xbgr.mr_n62359328)
print v(xbgr.mr_n62359440)
print v(xbgr.mr_n62359760)
print v(xbgr.mr_n62359872)
print v(xbgr.mr_n62360192)
print v(xbgr.mr_n62360304)
print v(xbgr.mr_n62360624)
print v(xbgr.mr_n62360736)
print v(xbgr.mr_n62361056)
print v(xbgr.mr_n62361168)
print v(xbgr.mr_n62361488)
print v(xbgr.mr_n62361600)
print v(xbgr.mr_n62361920)
print v(xbgr.mr_n62362032)
print v(xbgr.mr_n62362352)
print v(xbgr.mr_n62362464)
print v(xbgr.mr_n62363328)
print v(xbgr.mr_n62363760)
print v(xbgr.mr_n62364192)
print v(xbgr.mr_n62364624)
print v(xbgr.mr_n62365056)
print v(xbgr.mr_n62365488)
print v(xbgr.mr_n62365920)
print v(xbgr.mr_n62366352)
print v(xbgr.mr_n62366784)
print v(xbgr.mr_n62367216)
print v(xbgr.mr_n62367648)
print v(xbgr.mr_n62368080)
print v(xbgr.mr_n62368512)
print v(xbgr.mr_n62368944)
print v(xbgr.mr_n62369376)
print v(xbgr.mr_n62369808)
print v(xbgr.mr_n62370240)
print v(xbgr.mr_n62370672)
print v(xbgr.mr_n62371104)
print v(xbgr.mr_n62371536)
print v(xbgr.mr_n62371968)
print v(xbgr.mr_n62372400)
print v(xbgr.mr_n62372832)
print v(xbgr.mr_n62373264)
print v(xbgr.mr_n62375424)
print v(xbgr.mr_n62375856)
print v(xbgr.mr_n62376288)
print v(xbgr.mr_n62376720)
print v(xbgr.mr_n62377152)
print v(xbgr.mr_n62377584)
print v(xbgr.mr_n62378016)
print v(xbgr.mr_n62378448)
print v(xbgr.mr_n62378880)
print v(xbgr.mr_n62379312)
print v(xbgr.mr_n62379744)
print v(xbgr.mr_n62380176)
print v(xbgr.mr_n62380608)
print v(xbgr.mr_n62381040)
print v(xbgr.mr_n62381472)
print v(xbgr.mr_n62381904)
print v(xbgr.mr_n62382336)
print v(xbgr.mr_n62382768)
print v(xbgr.mr_n62383200)
print v(xbgr.mr_n62383632)
print v(xbgr.mr_n62384064)
print v(xbgr.mr_n62384496)
print v(xbgr.mr_n62384928)
print v(xbgr.mr_n62385360)
print v(xbgr.mr_n62389248)
print v(xbgr.mr_n62389680)
print v(xbgr.mr_n62390112)
print v(xbgr.mr_n62390544)
print v(xbgr.mr_n62390976)
print v(xbgr.mr_n62391408)
print v(xbgr.mr_n62391840)
print v(xbgr.mr_n62392272)
print v(xbgr.mr_n62392704)
print v(xbgr.mr_n62393136)
print v(xbgr.mr_n62393568)
print v(xbgr.mr_n62394000)
print v(xbgr.mr_n62394432)
print v(xbgr.mr_n62394864)
print v(xbgr.mr_n62395296)
print v(xbgr.mr_n62396592)
print v(xbgr.mr_n62397024)
print v(xbgr.mr_n62397456)
print v(xbgr.mr_n62397888)
print v(xbgr.mr_n62398320)
print v(xbgr.mr_n62398752)
print v(xbgr.mr_n62399184)
print v(xbgr.mr_n62399616)
print v(xbgr.mr_n62400048)
print v(xbgr.mr_n62400480)
print v(xbgr.mr_n62401776)
print v(xbgr.mr_n62402208)
print v(xbgr.mr_n62402640)
print v(xbgr.mr_n62403072)
print v(xbgr.mr_n62403504)
print v(xbgr.mr_n62403936)
print v(xbgr.mr_n62404368)
print v(xbgr.mr_n62404800)
print v(xbgr.mr_n62405120)
print v(xbgr.mr_n62405232)
print v(xbgr.mr_n62405552)
print v(xbgr.mr_n62405664)
print v(xbgr.mr_n62405984)
print v(xbgr.mr_n62406096)
print v(xbgr.mr_n62406416)
print v(xbgr.mr_n62406528)
print v(xbgr.mr_n62406848)
print v(xbgr.mr_n62406960)
print v(xbgr.mr_n62407280)
print v(xbgr.mr_n62407392)
print v(xbgr.mr_n62407712)
print v(xbgr.mr_n62407824)
print v(xbgr.mr_n62408144)
print v(xbgr.mr_n62408256)
print v(xbgr.mr_n62408576)
print v(xbgr.mr_n62408688)
print v(xbgr.mr_n62409008)
print v(xbgr.mr_n62409120)
print v(xbgr.mr_n62409440)
print v(xbgr.mr_n62409552)
print v(xbgr.mr_n62409872)
print v(xbgr.mr_n62409984)
print v(xbgr.mr_n62410304)
print v(xbgr.mr_n62410416)
print v(xbgr.mr_n62410736)
print v(xbgr.mr_n62410848)
print v(xbgr.mr_n62411168)
print v(xbgr.mr_n62411280)
print v(xbgr.mr_n62411600)
print v(xbgr.mr_n62411712)
print v(xbgr.mr_n62412032)
print v(xbgr.mr_n62412144)
print v(xbgr.mr_n62412464)
print v(xbgr.mr_n62412576)
print v(xbgr.mr_n62412896)
print v(xbgr.mr_n62413008)
print v(xbgr.mr_n62413328)
print v(xbgr.mr_n62413440)
print v(xbgr.mr_n62413760)
print v(xbgr.mr_n62413872)
print v(xbgr.mr_n62414192)
print v(xbgr.mr_n62414304)
print v(xbgr.mr_n62414624)
print v(xbgr.mr_n62414736)
print v(xbgr.mr_n62415056)
print v(xbgr.mr_n62415168)
print v(xbgr.mr_n62415488)
print v(xbgr.mr_n62415600)
print v(xbgr.mr_n62415920)
print v(xbgr.mr_n62416032)
print v(xbgr.mr_n62416352)
print v(xbgr.mr_n62416464)
print v(xbgr.mr_n62416784)
print v(xbgr.mr_n62416896)
print v(xbgr.mr_n62417216)
print v(xbgr.mr_n62417328)
print v(xbgr.mr_n62417648)
print v(xbgr.mr_n62417760)
print v(xbgr.mr_n62418080)
print v(xbgr.mr_n62418192)
print v(xbgr.mr_n62418512)
print v(xbgr.mr_n62418624)
print v(xbgr.mr_n62418944)
print v(xbgr.mr_n62419056)
print v(xbgr.mr_n62419376)
print v(xbgr.mr_n62419488)
print v(xbgr.mr_n62419808)
print v(xbgr.mr_n62419920)
print v(xbgr.mr_n62420240)
print v(xbgr.mr_n62420352)
print v(xbgr.mr_n62420672)
print v(xbgr.mr_n62420784)
print v(xbgr.mr_n62421104)
print v(xbgr.mr_n62421216)
print v(xbgr.mr_n62421536)
print v(xbgr.mr_n62421648)
print v(xbgr.mr_n62421968)
print v(xbgr.mr_n62422080)
print v(xbgr.mr_n62422400)
print v(xbgr.mr_n62422512)
print v(xbgr.mr_n62422832)
print v(xbgr.mr_n62422944)
print v(xbgr.mr_n62423264)
print v(xbgr.mr_n62423376)
print v(xbgr.mr_n62423696)
print v(xbgr.mr_n62423808)
print v(xbgr.mr_n62424128)
print v(xbgr.mr_n62424240)
print v(xbgr.mr_n62424560)
print v(xbgr.mr_n62424672)
print v(xbgr.mr_n62424992)
print v(xbgr.mr_n62425104)
print v(xbgr.mr_n62425424)
print v(xbgr.mr_n62425536)
print v(xbgr.mr_n62425856)
print v(xbgr.mr_n62425968)
print v(xbgr.mr_n62426288)
print v(xbgr.mr_n62426400)
print v(xbgr.mr_n62426720)
print v(xbgr.mr_n62426832)
print v(xbgr.mr_n62427152)
print v(xbgr.mr_n62427264)
print v(xbgr.mr_n62427584)
print v(xbgr.mr_n62427696)
print v(xbgr.mr_n62428016)
print v(xbgr.mr_n62428128)
print v(xbgr.mr_n62428448)
print v(xbgr.mr_n62428560)
print v(xbgr.mr_n62428880)
print v(xbgr.mr_n62428992)
print v(xbgr.mr_n62429312)
print v(xbgr.mr_n62429424)
print v(xbgr.mr_n62429744)
print v(xbgr.mr_n62429856)
print v(xbgr.mr_n62430176)
print v(xbgr.mr_n62430288)
print v(xbgr.mr_n62430608)
print v(xbgr.mr_n62430720)
print v(xbgr.mr_n62431040)
print v(xbgr.mr_n62431152)
print v(xbgr.mr_n62431472)
print v(xbgr.mr_n62431584)
print v(xbgr.mr_n62431904)
print v(xbgr.mr_n62432016)
print v(xbgr.mr_n62432336)
print v(xbgr.mr_n62432448)
print v(xbgr.mr_n62432768)
print v(xbgr.mr_n62432880)
print v(xbgr.mr_n62433200)
print v(xbgr.mr_n62433312)
print v(xbgr.mr_n62433632)
print v(xbgr.mr_n62433744)
print v(xbgr.mr_n62434064)
print v(xbgr.mr_n62434176)
print v(xbgr.mr_n62434496)
print v(xbgr.mr_n62434608)
print v(xbgr.mr_n62434928)
print v(xbgr.mr_n62435040)
print v(xbgr.mr_n62435360)
print v(xbgr.mr_n62435472)
print v(xbgr.mr_n62435792)
print v(xbgr.mr_n62435904)
print v(xbgr.mr_n62436224)
print v(xbgr.mr_n62436336)
print v(xbgr.mr_n62436656)
print v(xbgr.mr_n62436768)
print v(xbgr.mr_n62437088)
print v(xbgr.mr_n62437200)
print v(xbgr.mr_n62437520)
print v(xbgr.mr_n62437632)
print v(xbgr.mr_n62437952)
print v(xbgr.mr_n62438064)
print v(xbgr.mr_n62438384)
print v(xbgr.mr_n62438496)
print v(xbgr.mr_n62438816)
print v(xbgr.mr_n62438928)
print v(xbgr.mr_n62439248)
print v(xbgr.mr_n62439360)
print v(xbgr.mr_n62439680)
print v(xbgr.mr_n62439792)
print v(xbgr.mr_n62440112)
print v(xbgr.mr_n62440224)
print v(xbgr.mr_n62440544)
print v(xbgr.mr_n62440656)
print v(xbgr.mr_n62440976)
print v(xbgr.mr_n62441088)
print v(xbgr.mr_n62441408)
print v(xbgr.mr_n62441520)
print v(xbgr.mr_n62441840)
print v(xbgr.mr_n62441952)
print v(xbgr.mr_n62442272)
print v(xbgr.mr_n62442384)
print v(xbgr.mr_n62442704)
print v(xbgr.mr_n62442816)
print v(xbgr.mr_n62443136)
print v(xbgr.mr_n62443248)
print v(xbgr.mr_n62443568)
print v(xbgr.mr_n62443680)
print v(xbgr.mr_n62444000)
print v(xbgr.mr_n62444112)
print v(xbgr.mr_n62444432)
print v(xbgr.mr_n62444544)
print v(xbgr.mr_n62444864)
print v(xbgr.mr_n62444976)
print v(xbgr.mr_n62445296)
print v(xbgr.mr_n62445408)
print v(xbgr.mr_n62445728)
print v(xbgr.mr_n62445840)
print v(xbgr.mr_n62446160)
print v(xbgr.mr_n62446272)
print v(xbgr.mr_n62446592)
print v(xbgr.mr_n62446704)
print v(xbgr.mr_n62447024)
print v(xbgr.mr_n62447136)
print v(xbgr.mr_n62447456)
print v(xbgr.mr_n62447568)
print v(xbgr.mr_n62447888)
print v(xbgr.mr_n62448000)
print v(xbgr.mr_n62448320)
print v(xbgr.mr_n62448432)
print v(xbgr.mr_n62448752)
print v(xbgr.mr_n62448864)
print v(xbgr.mr_n62449184)
print v(xbgr.mr_n62449296)
print v(xbgr.mr_n62449616)
print v(xbgr.mr_n62449728)
print v(xbgr.mr_n62450048)
print v(xbgr.mr_n62450160)
print v(xbgr.mr_n62450480)
print v(xbgr.mr_n62450592)
print v(xbgr.mr_n62450912)
print v(xbgr.mr_n62451024)
print v(xbgr.mr_n62451344)
print v(xbgr.mr_n62451456)
print v(xbgr.mr_n62451776)
print v(xbgr.mr_n62452208)
print v(xbgr.mr_n62452320)
print v(xbgr.mr_n62452640)
print v(xbgr.mr_n62452752)
print v(xbgr.mr_n62453072)
print v(xbgr.mr_n62453184)
print v(xbgr.mr_n62453504)
print v(xbgr.mr_n62453616)
print v(xbgr.mr_n62453936)
print v(xbgr.mr_n62454048)
print v(xbgr.mr_n62454368)
print v(xbgr.mr_n62454480)
print v(xbgr.mr_n62454800)
print v(xbgr.mr_n62454912)
print v(xbgr.mr_n62455232)
print v(xbgr.mr_n62455344)
print v(xbgr.mr_n62455664)
print v(xbgr.mr_n62455776)
print v(xbgr.mr_n62456096)
print v(xbgr.mr_n62456208)
print v(xbgr.mr_n62456528)
print v(xbgr.mr_n62456640)
print v(xbgr.mr_n62456960)
print v(xbgr.mr_n62457072)
print v(xbgr.mr_n62457392)
print v(xbgr.mr_n62457504)
print v(xbgr.mr_n62457824)
print v(xbgr.mr_n62457936)
print v(xbgr.mr_n62458256)
print v(xbgr.mr_n62458368)
print v(xbgr.mr_n62458688)
print v(xbgr.mr_n62458800)
print v(xbgr.mr_n62459120)
print v(xbgr.mr_n62459232)
print v(xbgr.mr_n62459552)
print v(xbgr.mr_n62459664)
print v(xbgr.mr_n62459984)
print v(xbgr.mr_n62460096)
print v(xbgr.mr_n62460416)
print v(xbgr.mr_n62460528)
print v(xbgr.mr_n62460848)
print v(xbgr.mr_n62460960)
print v(xbgr.mr_n62461280)
print v(xbgr.mr_n62461392)
print v(xbgr.mr_n62461712)
print v(xbgr.mr_n62461824)
print v(xbgr.mr_n62462144)
print v(xbgr.mr_n62462256)
print v(xbgr.mr_n62462576)
print v(xbgr.mr_n62462688)
print v(xbgr.mr_n62463008)
print v(xbgr.mr_n62463120)
print v(xbgr.mr_n62463440)
print v(xbgr.mr_n62463552)
print v(xbgr.mr_n62463872)
print v(xbgr.mr_n62463984)
print v(xbgr.mr_n62464304)
print v(xbgr.mr_n62464416)
print v(xbgr.mr_n62464736)
print v(xbgr.mr_n62464848)
print v(xbgr.mr_n62465168)
print v(xbgr.mr_n62465280)
print v(xbgr.mr_n62465600)
print v(xbgr.mr_n62465712)
print v(xbgr.mr_n62466032)
print v(xbgr.mr_n62466144)
print v(xbgr.mr_n62466464)
print v(xbgr.mr_n62466576)
print v(xbgr.mr_n62466896)
print v(xbgr.mr_n62467008)
print v(xbgr.mr_n62467328)
print v(xbgr.mr_n62467760)
print v(xbgr.mr_n62467872)
print v(xbgr.mr_n62468192)
print v(xbgr.mr_n62468304)
print v(xbgr.mr_n62468624)
print v(xbgr.mr_n62468736)
print v(xbgr.mr_n62469056)
print v(xbgr.mr_n62469488)
print v(xbgr.mr_n62469600)
print v(xbgr.mr_n62469920)
print v(xbgr.mr_n62470032)
print v(xbgr.mr_n62470352)
print v(xbgr.mr_n62470464)
print v(xbgr.mr_n62470784)
print v(xbgr.mr_n62471216)
print v(xbgr.mr_n62471328)
print v(xbgr.mr_n62471648)
print v(xbgr.mr_n62471760)
print v(xbgr.mr_n62472080)
print v(xbgr.mr_n62472192)
print v(xbgr.mr_n62472512)
print v(xbgr.mr_n62472624)
print v(xbgr.mr_n62472944)
print v(xbgr.mr_n62473056)
print v(xbgr.mr_n62473376)
print v(xbgr.mr_n62473488)
print v(xbgr.mr_n62473808)
print v(xbgr.mr_n62473920)
print v(xbgr.mr_n62474240)
print v(xbgr.mr_n62474352)
print v(xbgr.mr_n62474672)
print v(xbgr.mr_n62474784)
print v(xbgr.mr_n62475104)
print v(xbgr.mr_n62475216)
print v(xbgr.mr_n62475536)
print v(xbgr.mr_n62475648)
print v(xbgr.mr_n62475968)
print v(xbgr.mr_n62476080)
print v(xbgr.mr_n62476400)
print v(xbgr.mr_n62476512)
print v(xbgr.mr_n62476832)
print v(xbgr.mr_n62476944)
print v(xbgr.mr_n62477264)
print v(xbgr.mr_n62477376)
print v(xbgr.mr_n62477696)
print v(xbgr.mr_n62477808)
print v(xbgr.mr_n62478128)
print v(xbgr.mr_n62478560)
print v(xbgr.mr_n62478672)
print v(xbgr.mr_n62478992)
print v(xbgr.mr_n62479104)
print v(xbgr.mr_n62479424)
print v(xbgr.mr_n62479536)
print v(xbgr.mr_n62479856)
print v(xbgr.mr_n62479968)
print v(xbgr.mr_n62480288)
print v(xbgr.mr_n62480400)
print v(xbgr.mr_n62480720)
print v(xbgr.mr_n62480832)
print v(xbgr.mr_n62481152)
print v(xbgr.mr_n62481264)
print v(xbgr.mr_n62481584)
print v(xbgr.mr_n62481696)
print v(xbgr.mr_n62482016)
print v(xbgr.mr_n62482128)
print v(xbgr.mr_n62482448)
print v(xbgr.mr_n62482560)
print v(xbgr.mr_n62482880)
print v(xbgr.mr_n62483312)
print v(xbgr.mr_n62483424)
print v(xbgr.mr_n62483744)
print v(xbgr.mr_n62484176)
print v(xbgr.mr_n62484288)
print v(xbgr.mr_n62484608)
print v(xbgr.mr_n62484720)
print v(xbgr.mr_n62485040)
print v(xbgr.mr_n62485152)
print v(xbgr.mr_n62485472)
print v(xbgr.mr_n62485584)
print v(xbgr.mr_n62485904)
print v(xbgr.mr_n62486016)
print v(xbgr.mr_n62486336)
print v(xbgr.mr_n62486768)
print v(xbgr.mr_n62486880)
print v(xbgr.mr_n62487200)
print v(xbgr.mr_n62487312)
print v(xbgr.mr_n62487632)
print v(xbgr.mr_n62487744)
print v(xbgr.mr_n62491904)
print v(xbgr.mr_n62492016)
print v(xbgr.mr_n62492352)
print v(xbgr.mr_n62492464)
print v(xbgr.mr_n62492784)
print v(xbgr.mr_n62492896)
print v(xbgr.mr_n62493264)
print v(xbgr.mr_n62493376)
print v(xbgr.mr_n62493696)
print v(xbgr.mr_n62493808)
print v(xbgr.mr_n62494128)
print v(xbgr.mr_n62494480)
print v(xbgr.mr_n62494592)
print v(xbgr.mr_n62494912)
print v(xbgr.mr_n62495344)
print v(xbgr.mr_n62495456)
print v(xbgr.mr_n62495776)
print v(xbgr.mr_n62495888)
print v(xbgr.mr_n62496208)
print v(xbgr.mr_n62496320)
print v(xbgr.mr_n62496640)
print v(xbgr.mr_n62496752)
print v(xbgr.mr_n62497072)
print v(xbgr.mr_n62497184)
print v(xbgr.mr_n62497504)
print v(xbgr.mr_n62497936)
print v(xbgr.mr_n62498048)
print v(xbgr.mr_n62498368)
print v(xbgr.mr_n62498800)
print v(xbgr.mr_n62498912)
print v(xbgr.mr_n62499232)
print v(xbgr.mr_n62499344)
print v(xbgr.mr_n62499664)
print v(xbgr.mr_n62499776)
print v(xbgr.mr_n62500096)
print v(xbgr.mr_n62500208)
print v(xbgr.mr_n62500528)
print v(xbgr.mr_n62500640)
print v(xbgr.mr_n62500960)
print v(xbgr.mr_n62501072)
print v(xbgr.mr_n62501392)
print v(xbgr.mr_n62501504)
print v(xbgr.mr_n62501824)
print v(xbgr.mr_n62502256)
print v(xbgr.mr_n62502368)
print v(xbgr.mr_n62502688)
print v(xbgr.mr_n62502800)
print v(xbgr.mr_n62503120)
print v(xbgr.mr_n62503232)
print v(xbgr.mr_n62503552)
print v(xbgr.mr_n62503664)
print v(xbgr.mr_n62503984)
print v(xbgr.mr_n62504096)
print v(xbgr.mr_n62504416)
print v(xbgr.mr_n62504528)
print v(xbgr.mr_n62504848)
print v(xbgr.mr_n62504960)
print v(xbgr.mr_n62505280)
print v(xbgr.mr_n62505712)
print v(xbgr.mr_n62505824)
print v(xbgr.mr_n62506144)
print v(xbgr.mr_n62506576)
print v(xbgr.mr_n62506688)
print v(xbgr.mr_n62507008)
print v(xbgr.mr_n62507120)
print v(xbgr.mr_n62507440)
print v(xbgr.mr_n62507552)
print v(xbgr.mr_n62507872)
print v(xbgr.mr_n62507984)
print v(xbgr.mr_n62508304)
print v(xbgr.mr_n62508416)
print v(xbgr.mr_n62508736)
print v(xbgr.mr_n62508848)
print v(xbgr.mr_n62509168)
print v(xbgr.mr_n62509280)
print v(xbgr.mr_n62509600)
print v(xbgr.mr_n62510032)
print v(xbgr.mr_n62510144)
print v(xbgr.mr_n62510464)
print v(xbgr.mr_n62510576)
print v(xbgr.mr_n62510896)
print v(xbgr.mr_n62511008)
print v(xbgr.mr_n62511328)
print v(xbgr.mr_n62511760)
print v(xbgr.mr_n62511872)
print v(xbgr.mr_n62512192)
print v(xbgr.mr_n62512304)
print v(xbgr.mr_n62512624)
print v(xbgr.mr_n62512736)
print v(xbgr.mr_n62513056)
print v(xbgr.mr_n62513168)
print v(xbgr.mr_n62513488)
print v(xbgr.mr_n62513600)
print v(xbgr.mr_n62513920)
print v(xbgr.mr_n62514032)
print v(xbgr.mr_n62514352)
print v(xbgr.mr_n62514464)
print v(xbgr.mr_n62514784)
print v(xbgr.mr_n62515216)
print v(xbgr.mr_n62515328)
print v(xbgr.mr_n62515648)
print v(xbgr.mr_n62515760)
print v(xbgr.mr_n62516080)
print v(xbgr.mr_n62516192)
print v(xbgr.mr_n62516512)
print v(xbgr.mr_n62516944)
print v(xbgr.mr_n62517056)
print v(xbgr.mr_n62517376)
print v(xbgr.mr_n62517488)
print v(xbgr.mr_n62517808)
print v(xbgr.mr_n62517920)
print v(xbgr.mr_n62518240)
print v(xbgr.mr_n62518352)
print v(xbgr.mr_n62518672)
print v(xbgr.mr_n62518784)
print v(xbgr.mr_n62519104)
print v(xbgr.mr_n62519216)
print v(xbgr.mr_n62519536)
print v(xbgr.mr_n62519648)
print v(xbgr.mr_n62519968)
print v(xbgr.mr_n62520080)
print v(xbgr.mr_n62520400)
print v(xbgr.mr_n62520512)
print v(xbgr.mr_n62520832)
print v(xbgr.mr_n62521264)
print v(xbgr.mr_n62521376)
print v(xbgr.mr_n62521696)
print v(xbgr.mr_n62521808)
print v(xbgr.mr_n62522032)
print v(xbgr.mr_n62522400)
print v(xbgr.mr_n62522512)
print v(xbgr.mr_n62522768)
print v(xbgr.mr_n62522880)
print v(xbgr.mr_n62523136)
print v(xbgr.mr_n62523248)
print v(xbgr.mr_n62523504)
print v(xbgr.mr_n62523616)
print v(xbgr.mr_n62523872)
print v(xbgr.mr_n62523984)
print v(xbgr.mr_n62524240)
print v(xbgr.mr_n62524608)
print v(xbgr.mr_n62524720)
print v(xbgr.mr_n62524976)
print v(xbgr.mr_n62525344)
print v(xbgr.mr_n62525456)
print v(xbgr.mr_n62525712)
print v(xbgr.mr_n62526080)
print v(xbgr.mr_n62526192)
print v(xbgr.mr_n62526448)
print v(xbgr.mr_n62526560)
print v(xbgr.mr_n62526816)
print v(xbgr.mr_n62526928)
print v(xbgr.mr_n62527184)
print v(xbgr.mr_n62527552)
print v(xbgr.mr_n62527664)
print v(xbgr.mr_n62527920)
print v(xbgr.mr_n62528288)
print v(xbgr.mr_n62528400)
print v(xbgr.mr_n62528656)
print v(xbgr.mr_n62529024)
print v(xbgr.mr_n62529136)
print v(xbgr.mr_n62529392)
print v(xbgr.mr_n62529504)
print v(xbgr.mr_n62529760)
print v(xbgr.mr_n62529872)
print v(xbgr.mr_n62530128)
print v(xbgr.mr_n62530240)
print v(xbgr.mr_n62530496)
print v(xbgr.mr_n62530608)
print v(xbgr.mr_n62530864)
print v(xbgr.mr_n62531232)
print v(xbgr.mr_n62531344)
print v(xbgr.mr_n62531600)
print v(xbgr.mr_n62531712)
print v(xbgr.mr_n62531968)
print v(xbgr.mr_n62532080)
print v(xbgr.mr_n62532336)
print v(xbgr.mr_n62532448)
print v(xbgr.mr_n62532704)
print v(xbgr.mr_n62532816)
print v(xbgr.mr_n62533072)
print v(xbgr.mr_n62533440)
print v(xbgr.mr_n62533552)
print v(xbgr.mr_n62533808)
print v(xbgr.mr_n62534176)
print v(xbgr.mr_n62534288)
print v(xbgr.mr_n62534544)
print v(xbgr.mr_n62534656)
print v(xbgr.mr_n62534912)
print v(xbgr.mr_n62535024)
print v(xbgr.mr_n62535280)
print v(xbgr.mr_n62535712)
print v(xbgr.mr_n62535824)
print v(xbgr.mr_n62536144)
print v(xbgr.mr_n62536576)
print v(xbgr.mr_n62536688)
print v(xbgr.mr_n62537008)
print v(xbgr.mr_n62537120)
print v(xbgr.mr_n62537440)
print v(xbgr.mr_n62537552)
print v(xbgr.mr_n62537872)
print v(xbgr.mr_n62537984)
print v(xbgr.mr_n62538304)
print v(xbgr.mr_n62538416)
print v(xbgr.mr_n62538736)
print v(xbgr.mr_n62538848)
print v(xbgr.mr_n62539168)
print v(xbgr.mr_n62539280)
print v(xbgr.mr_n62539600)
print v(xbgr.mr_n62540032)
print v(xbgr.mr_n62540144)
print v(xbgr.mr_n62540464)
print v(xbgr.mr_n62540576)
print v(xbgr.mr_n62540896)
print v(xbgr.mr_n62541008)
print v(xbgr.mr_n62541328)
print v(xbgr.mr_n62541440)
print v(xbgr.mr_n62541760)
print v(xbgr.mr_n62541872)
print v(xbgr.mr_n62542192)
print v(xbgr.mr_n62542624)
print v(xbgr.mr_n62542736)
print v(xbgr.mr_n62543056)
print v(xbgr.mr_n62543488)
print v(xbgr.mr_n62543600)
print v(xbgr.mr_n62543920)
print v(xbgr.mr_n62544032)
print v(xbgr.mr_n62544352)
print v(xbgr.mr_n62544464)
print v(xbgr.mr_n62544784)
print v(xbgr.mr_n62544896)
print v(xbgr.mr_n62545216)
print v(xbgr.mr_n62545328)
print v(xbgr.mr_n62545648)
print v(xbgr.mr_n62545760)
print v(xbgr.mr_n62546080)
print v(xbgr.mr_n62546192)
print v(xbgr.mr_n62546512)
print v(xbgr.mr_n62546624)
print v(xbgr.mr_n62546944)
print v(xbgr.mr_n62547488)
print v(xbgr.mr_n62547920)
print v(xbgr.mr_n62548352)
print v(xbgr.mr_n62548784)
print v(xbgr.mr_n62549216)
print v(xbgr.mr_n62549648)
print v(xbgr.mr_n62550080)
print v(xbgr.mr_n62550512)
print v(xbgr.mr_n62550944)
print v(xbgr.mr_n62551376)
print v(xbgr.mr_n62551696)
print v(xbgr.mr_n62552128)
print v(xbgr.mr_n62552560)
print v(xbgr.mr_n62552992)
print v(xbgr.mr_n62553424)
print v(xbgr.mr_n62553856)
print v(xbgr.mr_n62554288)
print v(xbgr.mr_n62554720)
print v(xbgr.mr_n62555152)
print v(xbgr.mr_n62555584)
print v(xbgr.mr_n62556016)
print v(xbgr.mr_n62556448)
print v(xbgr.mr_n62556880)
print v(xbgr.mr_n62557312)
print v(xbgr.mr_n62557744)
print v(xbgr.mr_n62558176)
print v(xbgr.mr_n62558608)
print v(xbgr.mr_n62559040)
print v(xbgr.mr_n62559472)
print v(xbgr.mr_n62559904)
print v(xbgr.mr_n62560336)
print v(xbgr.mr_n62560768)
print v(xbgr.mr_n62561200)
print v(xbgr.mr_n62561632)
print v(xbgr.mr_n62562064)
print v(xbgr.mr_n62562496)
print v(xbgr.mr_n62562928)
print v(xbgr.mr_n62563360)
print v(xbgr.mr_n62563792)
print v(xbgr.mr_n62564224)
print v(xbgr.mr_n62564656)
print v(xbgr.mr_n62565088)
print v(xbgr.mr_n62565520)
print v(xbgr.mr_n62565952)
print v(xbgr.mr_n62566384)
print v(xbgr.mr_n62566816)
print v(xbgr.mr_n62567248)
print v(xbgr.mr_n62567680)
print v(xbgr.mr_n62568112)
print v(xbgr.mr_n62568544)
print v(xbgr.mr_n62568976)
print v(xbgr.mr_n62569408)
print v(xbgr.mr_n62569840)
print v(xbgr.mr_n62570272)
print v(xbgr.mr_n62570704)
print v(xbgr.mr_n62571136)
print v(xbgr.mr_n62571568)
print v(xbgr.mr_n62572000)
print v(xbgr.mr_n62573296)
print v(xbgr.mr_n62573728)
print v(xbgr.mr_n62574160)
print v(xbgr.mr_n62574592)
print v(xbgr.mr_n62575024)
print v(xbgr.mr_n62575456)
print v(xbgr.mr_n62575888)
print v(xbgr.mr_n62576320)
print v(xbgr.mr_n62576752)
print v(xbgr.mr_n62577184)
print v(xbgr.mr_n62577616)
print v(xbgr.mr_n62578048)
print v(xbgr.mr_n62580208)
print v(xbgr.mr_n62580640)
print v(xbgr.mr_n62581072)
print v(xbgr.mr_n62581504)
print v(xbgr.mr_n62581936)
print v(xbgr.mr_n62582368)
print v(xbgr.mr_n62582800)
print v(xbgr.mr_n62583232)
print v(xbgr.mr_n62583664)
print v(xbgr.mr_n62584096)
print v(xbgr.mr_n62585392)
print v(xbgr.mr_n62585824)
print v(xbgr.mr_n62586256)
print v(xbgr.mr_n62586688)
print v(xbgr.mr_n62587120)
print v(xbgr.mr_n62587552)
print v(xbgr.mr_n62587984)
print v(xbgr.mr_n62588416)
print v(xbgr.mr_n62588848)
print v(xbgr.mr_n62589280)
print v(xbgr.mr_n62589712)
print v(xbgr.mr_n62590144)
print v(xbgr.mr_n62591440)
print v(xbgr.mr_n62591872)
print v(xbgr.mr_n62593168)
print v(xbgr.mr_n62593600)
print v(xbgr.mr_n62594032)
print v(xbgr.mr_n62594464)
print v(xbgr.mr_n62594896)
print v(xbgr.mr_n62595328)
print v(xbgr.mr_n62595760)
print v(xbgr.mr_n62596192)
print v(xbgr.mr_n62597488)
print v(xbgr.mr_n62597920)
print v(xbgr.mr_n62598240)
print v(xbgr.mr_n62598352)
print v(xbgr.mr_n62598672)
print v(xbgr.mr_n62598784)
print v(xbgr.mr_n62599104)
print v(xbgr.mr_n62599216)
print v(xbgr.mr_n62599536)
print v(xbgr.mr_n62599648)
print v(xbgr.mr_n62599968)
print v(xbgr.mr_n62600080)
print v(xbgr.mr_n62600400)
print v(xbgr.mr_n62600512)
print v(xbgr.mr_n62600832)
print v(xbgr.mr_n62600944)
print v(xbgr.mr_n62601264)
print v(xbgr.mr_n62601376)
print v(xbgr.mr_n62601808)
print v(xbgr.mr_n62602240)
print v(xbgr.mr_n62602672)
print v(xbgr.mr_n62603104)
print v(xbgr.mr_n62603536)
print v(xbgr.mr_n62603968)
print v(xbgr.mr_n62604400)
print v(xbgr.mr_n62604832)
print v(xbgr.mr_n62605264)
print v(xbgr.mr_n62605696)
print v(xbgr.mr_n62606128)
print v(xbgr.mr_n62606560)
print v(xbgr.mr_n62606992)
print v(xbgr.mr_n62607424)
print v(xbgr.mr_n62607856)
print v(xbgr.mr_n62608288)
print v(xbgr.mr_n62608720)
print v(xbgr.mr_n62609152)
print v(xbgr.mr_n62609584)
print v(xbgr.mr_n62610016)
print v(xbgr.mr_n62610448)
print v(xbgr.mr_n62610880)
print v(xbgr.mr_n62611312)
print v(xbgr.mr_n62611744)
print v(xbgr.mr_n62612176)
print v(xbgr.mr_n62612608)
print v(xbgr.mr_n62613248)
print v(xbgr.mr_n62613680)
print v(xbgr.mr_n62614112)
print v(xbgr.mr_n62614544)
print v(xbgr.mr_n62614976)
print v(xbgr.mr_n62615408)
print v(xbgr.mr_n62615840)
print v(xbgr.mr_n62616272)
print v(xbgr.mr_n62616704)
print v(xbgr.mr_n62617136)
print v(xbgr.mr_n62617568)
print v(xbgr.mr_n62618000)
print v(xbgr.mr_n62618432)
print v(xbgr.mr_n62618864)
print v(xbgr.mr_n62619296)
print v(xbgr.mr_n62619728)
print v(xbgr.mr_n62620160)
print v(xbgr.mr_n62620592)
print v(xbgr.mr_n62621024)
print v(xbgr.mr_n62621456)
print v(xbgr.mr_n62621888)
print v(xbgr.mr_n62622320)
print v(xbgr.mr_n62622752)
print v(xbgr.mr_n62623184)
print v(xbgr.mr_n62623616)
print v(xbgr.mr_n62624048)
print v(xbgr.mr_n62624480)
print v(xbgr.mr_n62624912)
print v(xbgr.mr_n62625344)
print v(xbgr.mr_n62625776)
print v(xbgr.mr_n62626208)
print v(xbgr.mr_n62626640)
print v(xbgr.mr_n62627072)
print v(xbgr.mr_n62627504)
print v(xbgr.mr_n62627936)
print v(xbgr.mr_n62628368)
print v(xbgr.mr_n62628800)
print v(xbgr.mr_n62629232)
print v(xbgr.mr_n62629664)
print v(xbgr.mr_n62630096)
print v(xbgr.mr_n62630528)
print v(xbgr.mr_n62630960)
print v(xbgr.mr_n62631392)
print v(xbgr.mr_n62631824)
print v(xbgr.mr_n62632256)
print v(xbgr.mr_n62632688)
print v(xbgr.mr_n62633120)
print v(xbgr.mr_n62633552)
print v(xbgr.mr_n62633984)
print v(xbgr.mr_n62634416)
print v(xbgr.mr_n62634848)
print v(xbgr.mr_n62635280)
print v(xbgr.mr_n62635712)
print v(xbgr.mr_n62636144)
print v(xbgr.mr_n62636576)
print v(xbgr.mr_n62637008)
print v(xbgr.mr_n62637440)
print v(xbgr.mr_n62637872)
print v(xbgr.mr_n62638304)
print v(xbgr.mr_n62638736)
print v(xbgr.mr_n62639168)
print v(xbgr.mr_n62639600)
print v(xbgr.mr_n62640032)
print v(xbgr.mr_n62640464)
print v(xbgr.mr_n62640896)
print v(xbgr.mr_n62641328)
print v(xbgr.mr_n62641760)
print v(xbgr.mr_n62642192)
print v(xbgr.mr_n62642624)
print v(xbgr.mr_n62643056)
print v(xbgr.mr_n62643488)
print v(xbgr.mr_n62643920)
print v(xbgr.mr_n62644352)
print v(xbgr.mr_n62644784)
print v(xbgr.mr_n62645216)
print v(xbgr.mr_n62645648)
print v(xbgr.mr_n62646080)
print v(xbgr.mr_n62646512)
print v(xbgr.mr_n62646944)
print v(xbgr.mr_n62647376)
print v(xbgr.mr_n62647808)
print v(xbgr.mr_n62648240)
print v(xbgr.mr_n62648672)
print v(xbgr.mr_n62649104)
print v(xbgr.mr_n62649536)
print v(xbgr.mr_n62649856)
print v(xbgr.mr_n62649968)
print v(xbgr.mr_n62650288)
print v(xbgr.mr_n62650400)
print v(xbgr.mr_n62650720)
print v(xbgr.mr_n62650832)
print v(xbgr.mr_n62651152)
print v(xbgr.mr_n62651264)
print v(xbgr.mr_n62651696)
print v(xbgr.mr_n62652128)
print v(xbgr.mr_n62652560)
print v(xbgr.mr_n62652992)
print v(xbgr.mr_n62653424)
print v(xbgr.mr_n62653856)
print v(xbgr.mr_n62654288)
print v(xbgr.mr_n62654720)
print v(xbgr.mr_n62655152)
print v(xbgr.mr_n62655584)
print v(xbgr.mr_n62656016)
print v(xbgr.mr_n62656448)
print v(xbgr.mr_n62656880)
print v(xbgr.mr_n62657312)
print v(xbgr.mr_n62657744)
print v(xbgr.mr_n62658176)
print v(xbgr.mr_n62658608)
print v(xbgr.mr_n62659040)
print v(xbgr.mr_n62659472)
print v(xbgr.mr_n62659904)
print v(xbgr.mr_n62660336)
print v(xbgr.mr_n62660768)
print v(xbgr.mr_n62661200)
print v(xbgr.mr_n62661632)
print v(xbgr.mr_n62662064)
print v(xbgr.mr_n62662496)
print v(xbgr.mr_n62662928)
print v(xbgr.mr_n62663360)
print v(xbgr.mr_n62663792)
print v(xbgr.mr_n62664224)
print v(xbgr.mr_n62664656)
print v(xbgr.mr_n62665088)
print v(xbgr.mr_n62665520)
print v(xbgr.mr_n62665952)
print v(xbgr.mr_n62666384)
print v(xbgr.mr_n62666816)
print v(xbgr.mr_n62667248)
print v(xbgr.mr_n62667680)
print v(xbgr.mr_n62668112)
print v(xbgr.mr_n62668544)
print v(xbgr.mr_n62668976)
print v(xbgr.mr_n62669408)
print v(xbgr.mr_n62669840)
print v(xbgr.mr_n62670272)
print v(xbgr.mr_n62670704)
print v(xbgr.mr_n62671136)
print v(xbgr.mr_n62671568)
print v(xbgr.mr_n62672000)
print v(xbgr.mr_n62672432)
print v(xbgr.mr_n62672864)
print v(xbgr.mr_n62673296)
print v(xbgr.mr_n62673728)
print v(xbgr.mr_n62674160)
print v(xbgr.mr_n62674592)
print v(xbgr.mr_n62675024)
print v(xbgr.mr_n62675456)
print v(xbgr.mr_n62675888)
print v(xbgr.mr_n62676320)
print v(xbgr.mr_n62676752)
print v(xbgr.mr_n62677184)
print v(xbgr.mr_n62677616)
print v(xbgr.mr_n62678048)
print v(xbgr.mr_n62678480)
print v(xbgr.mr_n62678912)
print v(xbgr.mr_n62680208)
print v(xbgr.mr_n62680640)
print v(xbgr.mr_n62681936)
print v(xbgr.mr_n62682368)
print v(xbgr.mr_n62683664)
print v(xbgr.mr_n62684096)
print v(xbgr.mr_n62684528)
print v(xbgr.mr_n62684960)
print v(xbgr.mr_n62685392)
print v(xbgr.mr_n62685824)
print v(xbgr.mr_n62686256)
print v(xbgr.mr_n62686688)
print v(xbgr.mr_n62687120)
print v(xbgr.mr_n62687552)
print v(xbgr.mr_n62687984)
print v(xbgr.mr_n62688416)
print v(xbgr.mr_n62688848)
print v(xbgr.mr_n62689280)
print v(xbgr.mr_n62689712)
print v(xbgr.mr_n62690144)
print v(xbgr.mr_n62691440)
print v(xbgr.mr_n62691872)
print v(xbgr.mr_n62692304)
print v(xbgr.mr_n62692736)
print v(xbgr.mr_n62693168)
print v(xbgr.mr_n62693600)
print v(xbgr.mr_n62694896)
print v(xbgr.mr_n62695328)
print v(xbgr.mr_n62695760)
print v(xbgr.mr_n62696192)
print v(xbgr.mr_n62696624)
print v(xbgr.mr_n62697056)
print v(xbgr.mr_n62697488)
print v(xbgr.mr_n62697920)
print v(xbgr.mr_n62698352)
print v(xbgr.mr_n62698784)
print v(xbgr.mr_n62699216)
print v(xbgr.mr_n62699648)
print v(xbgr.mr_n62700080)
print v(xbgr.mr_n62700512)
print v(xbgr.mr_n62700944)
print v(xbgr.mr_n62701376)
print v(xbgr.mr_n62701808)
print v(xbgr.mr_n62702240)
print v(xbgr.mr_n62702672)
print v(xbgr.mr_n62703104)
print v(xbgr.mr_n62703536)
print v(xbgr.mr_n62703968)
print v(xbgr.mr_n62704400)
print v(xbgr.mr_n62704832)
print v(xbgr.mr_n62705264)
print v(xbgr.mr_n62705696)
print v(xbgr.mr_n62706128)
print v(xbgr.mr_n62706560)
print v(xbgr.mr_n62706992)
print v(xbgr.mr_n62707424)
print v(xbgr.mr_n62707856)
print v(xbgr.mr_n62708288)
print v(xbgr.mr_n62708720)
print v(xbgr.mr_n62709152)
print v(xbgr.mr_n62709584)
print v(xbgr.mr_n62710016)
print v(xbgr.mr_n62710448)
print v(xbgr.mr_n62710880)
print v(xbgr.mr_n62711312)
print v(xbgr.mr_n62711744)
print v(xbgr.mr_n62712176)
print v(xbgr.mr_n62712608)
print v(xbgr.mr_n62713040)
print v(xbgr.mr_n62713472)
print v(xbgr.mr_n62713904)
print v(xbgr.mr_n62714336)
print v(xbgr.mr_n62714768)
print v(xbgr.mr_n62715200)
print v(xbgr.mr_n62715632)
print v(xbgr.mr_n62716064)
print v(xbgr.mr_n62716496)
print v(xbgr.mr_n62716928)
print v(xbgr.mr_n62717360)
print v(xbgr.mr_n62717792)
print v(xbgr.mr_n62718224)
print v(xbgr.mr_n62718656)
print v(xbgr.mr_n62719088)
print v(xbgr.mr_n62719408)
print v(xbgr.mr_n62719520)
print v(xbgr.mr_n62719840)
print v(xbgr.mr_n62719952)
print v(xbgr.mr_n62720272)
print v(xbgr.mr_n62720384)
print v(xbgr.mr_n62720704)
print v(xbgr.mr_n62720816)
print v(xbgr.mr_n62721136)
print v(xbgr.mr_n62721248)
print v(xbgr.mr_n62721568)
print v(xbgr.mr_n62721680)
print v(xbgr.mr_n62722000)
print v(xbgr.mr_n62722112)
print v(xbgr.mr_n62722432)
print v(xbgr.mr_n62722544)
print v(xbgr.mr_n62722864)
print v(xbgr.mr_n62722976)
print v(xbgr.mr_n62723296)
print v(xbgr.mr_n62723408)
print v(xbgr.mr_n62723728)
print v(xbgr.mr_n62723840)
print v(xbgr.mr_n62724160)
print v(xbgr.mr_n62724272)
print v(xbgr.mr_n62724592)
print v(xbgr.mr_n62724704)
print v(xbgr.mr_n62725024)
print v(xbgr.mr_n62725136)
print v(xbgr.mr_n62725456)
print v(xbgr.mr_n62725568)
print v(xbgr.mr_n62725888)
print v(xbgr.mr_n62726000)
print v(xbgr.mr_n62726320)
print v(xbgr.mr_n62726432)
print v(xbgr.mr_n62726752)
print v(xbgr.mr_n62726864)
print v(xbgr.mr_n62727184)
print v(xbgr.mr_n62727296)
print v(xbgr.mr_n62727616)
print v(xbgr.mr_n62727728)
print v(xbgr.mr_n62728048)
print v(xbgr.mr_n62728160)
print v(xbgr.mr_n62728480)
print v(xbgr.mr_n62728592)
print v(xbgr.mr_n62728912)
print v(xbgr.mr_n62729024)
print v(xbgr.mr_n62729344)
print v(xbgr.mr_n62729456)
print v(xbgr.mr_n62729776)
print v(xbgr.mr_n62729888)
print v(xbgr.mr_n62730208)
print v(xbgr.mr_n62730320)
print v(xbgr.mr_n62730640)
print v(xbgr.mr_n62730752)
print v(xbgr.mr_n62731072)
print v(xbgr.mr_n62731184)
print v(xbgr.mr_n62731504)
print v(xbgr.mr_n62731616)
print v(xbgr.mr_n62731936)
print v(xbgr.mr_n62732048)
print v(xbgr.mr_n62732368)
print v(xbgr.mr_n62732480)
print v(xbgr.mr_n62732800)
print v(xbgr.mr_n62732912)
print v(xbgr.mr_n62733232)
print v(xbgr.mr_n62733344)
print v(xbgr.mr_n62733664)
print v(xbgr.mr_n62733776)
print v(xbgr.mr_n62734096)
print v(xbgr.mr_n62734208)
print v(xbgr.mr_n62734528)
print v(xbgr.mr_n62734640)
print v(xbgr.mr_n62734960)
print v(xbgr.mr_n62735072)
print v(xbgr.mr_n62735392)
print v(xbgr.mr_n62735504)
print v(xbgr.mr_n62735920)
print v(xbgr.mr_n62736352)
print v(xbgr.mr_n62736784)
print v(xbgr.mr_n62737216)
print v(xbgr.mr_n62737648)
print v(xbgr.mr_n62738080)
print v(xbgr.mr_n62738512)
print v(xbgr.mr_n62738944)
print v(xbgr.mr_n62739376)
print v(xbgr.mr_n62739808)
print v(xbgr.mr_n62740240)
print v(xbgr.mr_n62740672)
print v(xbgr.mr_n62740992)
print v(xbgr.mr_n62741104)
print v(xbgr.mr_n62741424)
print v(xbgr.mr_n62741536)
print v(xbgr.mr_n62741968)
print v(xbgr.mr_n62742400)
print v(xbgr.mr_n62742832)
print v(xbgr.mr_n62743264)
print v(xbgr.mr_n62743696)
print v(xbgr.mr_n62744128)
print v(xbgr.mr_n62744560)
print v(xbgr.mr_n62744992)
print v(xbgr.mr_n62745424)
print v(xbgr.mr_n62745856)
print v(xbgr.mr_n62746288)
print v(xbgr.mr_n62746720)
print v(xbgr.mr_n62747152)
print v(xbgr.mr_n62747584)
print v(xbgr.mr_n62748016)
print v(xbgr.mr_n62748448)
print v(xbgr.mr_n62748880)
print v(xbgr.mr_n62749312)
print v(xbgr.mr_n62749744)
print v(xbgr.mr_n62750176)
print v(xbgr.mr_n62750608)
print v(xbgr.mr_n62751040)
print v(xbgr.mr_n62751472)
print v(xbgr.mr_n62751904)
print v(xbgr.mr_n62752336)
print v(xbgr.mr_n62752768)
print v(xbgr.mr_n62753200)
print v(xbgr.mr_n62753632)
print v(xbgr.mr_n62754064)
print v(xbgr.mr_n62754496)
print v(xbgr.mr_n62754928)
print v(xbgr.mr_n62755360)
print v(xbgr.mr_n62755792)
print v(xbgr.mr_n62756224)
print v(xbgr.mr_n62756656)
print v(xbgr.mr_n62757088)
print v(xbgr.mr_n62757520)
print v(xbgr.mr_n62757952)
print v(xbgr.mr_n62758384)
print v(xbgr.mr_n62758816)
print v(xbgr.mr_n62759136)
print v(xbgr.mr_n62759248)
print v(xbgr.mr_n62759568)
print v(xbgr.mr_n62759680)
print v(xbgr.mr_n62760112)
print v(xbgr.mr_n62760432)
print v(xbgr.mr_n62760544)
print v(xbgr.mr_n62760976)
print v(xbgr.mr_n62761408)
print v(xbgr.mr_n62761840)
print v(xbgr.mr_n62762272)
print v(xbgr.mr_n62762704)
print v(xbgr.mr_n62763136)
print v(xbgr.mr_n62763568)
print v(xbgr.mr_n62764000)
print v(xbgr.mr_n62764432)
print v(xbgr.mr_n62764864)
print v(xbgr.mr_n62765296)
print v(xbgr.mr_n62765728)
print v(xbgr.mr_n62766160)
print v(xbgr.mr_n62766592)
print v(xbgr.mr_n62767024)
print v(xbgr.mr_n62767456)
print v(xbgr.mr_n62767888)
print v(xbgr.mr_n62768320)
print v(xbgr.mr_n62768752)
print v(xbgr.mr_n62769184)
print v(xbgr.mr_n62769616)
print v(xbgr.mr_n62770048)
print v(xbgr.mr_n62770480)
print v(xbgr.mr_n62770912)
print v(xbgr.mr_n62771344)
print v(xbgr.mr_n62771776)
print v(xbgr.mr_n62772208)
print v(xbgr.mr_n62772640)
print v(xbgr.mr_n62773072)
print v(xbgr.mr_n62773504)
print v(xbgr.mr_n62773936)
print v(xbgr.mr_n62774368)
print v(xbgr.mr_n62774800)
print v(xbgr.mr_n62775232)
print v(xbgr.mr_n62775664)
print v(xbgr.mr_n62776096)
print v(xbgr.mr_n62776528)
print v(xbgr.mr_n62776960)
print v(xbgr.mr_n62777392)
print v(xbgr.mr_n62777824)
print v(xbgr.mr_n62778256)
print v(xbgr.mr_n62778688)
print v(xbgr.mr_n62779120)
print v(xbgr.mr_n62779552)
print v(xbgr.mr_n62779984)
print v(xbgr.mr_n62780416)
print v(xbgr.mr_n62780848)
print v(xbgr.mr_n62781168)
print v(xbgr.mr_n62781280)
print v(xbgr.mr_n62781712)
print v(xbgr.mr_n62782144)
print v(xbgr.mr_n62782464)
print v(xbgr.mr_n62782576)
print v(xbgr.mr_n62782896)
print v(xbgr.mr_n62783008)
print v(xbgr.mr_n62783328)
print v(xbgr.mr_n62783440)
print v(xbgr.mr_n62783760)
print v(xbgr.mr_n62783872)
print v(xbgr.mr_n62784192)
print v(xbgr.mr_n62784304)
print v(xbgr.mr_n62784624)
print v(xbgr.mr_n62784736)
print v(xbgr.mr_n62785168)
print v(xbgr.mr_n62785488)
print v(xbgr.mr_n62785600)
print v(xbgr.mr_n62785920)
print v(xbgr.mr_n62786032)
print v(xbgr.mr_n62786352)
print v(xbgr.mr_n62786464)
print v(xbgr.mr_n62786784)
print v(xbgr.mr_n62786896)
print v(xbgr.mr_n62787216)
print v(xbgr.mr_n62787328)
print v(xbgr.mr_n62787648)
print v(xbgr.mr_n62787760)
print v(xbgr.mr_n62788192)
print v(xbgr.mr_n62788512)
print v(xbgr.mr_n62788624)
print v(xbgr.mr_n62788944)
print v(xbgr.mr_n62789056)
print v(xbgr.mr_n62789376)
print v(xbgr.mr_n62789488)
print v(xbgr.mr_n62789808)
print v(xbgr.mr_n62789920)
print v(xbgr.mr_n62790240)
print v(xbgr.mr_n62790352)
print v(xbgr.mr_n62790672)
print v(xbgr.mr_n62790784)
print v(xbgr.mr_n62791216)
print v(xbgr.mr_n62791536)
print v(xbgr.mr_n62791648)
print v(xbgr.mr_n62791968)
print v(xbgr.mr_n62792080)
print v(xbgr.mr_n62792400)
print v(xbgr.mr_n62792512)
print v(xbgr.mr_n62792944)
print v(xbgr.mr_n62793264)
print v(xbgr.mr_n62793376)
print v(xbgr.mr_n62793808)
print v(xbgr.mr_n62794240)
print v(xbgr.mr_n62794672)
print v(xbgr.mr_n62795104)
print v(xbgr.mr_n62796400)
print v(xbgr.mr_n62796832)
print v(xbgr.mr_n62798128)
print v(xbgr.mr_n62798560)
print v(xbgr.mr_n62798880)
print v(xbgr.mr_n62798992)
print v(xbgr.mr_n62799312)
print v(xbgr.mr_n62799424)
print v(xbgr.mr_n62799744)
print v(xbgr.mr_n62799856)
print v(xbgr.mr_n62800176)
print v(xbgr.mr_n62800720)
print v(xbgr.mr_n62801472)
print v(xbgr.mr_n62801584)
print v(xbgr.mr_n62801904)
print v(xbgr.mr_n62804176)
print v(xbgr.mr_n62805040)
print v(xbgr.mr_n62805904)
print v(xbgr.mr_n62806336)
print v(xbgr.mr_n62806768)
print v(xbgr.mr_n62807200)
print v(xbgr.mr_n62809248)
print v(xbgr.mr_n62809360)
print v(xbgr.mr_n62809792)
print v(xbgr.mr_n62810112)
print v(xbgr.mr_n62810224)
print v(xbgr.mr_n62810544)
print v(xbgr.mr_n62810656)
print v(xbgr.mr_n62811088)
print v(xbgr.mr_n62811408)
print v(xbgr.mr_n62811520)
print v(xbgr.mr_n62811840)
print v(xbgr.mr_n62811952)
print v(xbgr.mr_n62812272)
print v(xbgr.mr_n62812384)
print v(xbgr.mr_n62812816)
print v(xbgr.mr_n62813136)
print v(xbgr.mr_n62813248)
print v(xbgr.mr_n62813568)
print v(xbgr.mr_n62813680)
print v(xbgr.mr_n62814000)
print v(xbgr.mr_n62814112)
print v(xbgr.mr_n62814544)
print v(xbgr.mr_n62814864)
print v(xbgr.mr_n62814976)
print v(xbgr.mr_n62815296)
print v(xbgr.mr_n62815408)
print v(xbgr.mr_n62815728)
print v(xbgr.mr_n62815840)
print v(xbgr.mr_n62816160)
print v(xbgr.mr_n62816272)
print v(xbgr.mr_n62816592)
print v(xbgr.mr_n62816704)
print v(xbgr.mr_n62817136)
print v(xbgr.mr_n62817456)
print v(xbgr.mr_n62817568)
print v(xbgr.mr_n62817888)
print v(xbgr.mr_n62818000)
print v(xbgr.mr_n62818320)
print v(xbgr.mr_n62818432)
print v(xbgr.mr_n62818752)
print v(xbgr.mr_n62818864)
print v(xbgr.mr_n62819296)
print v(xbgr.mr_n62819616)
print v(xbgr.mr_n62819728)
print v(xbgr.mr_n62820048)
print v(xbgr.mr_n62820160)
print v(xbgr.mr_n62820592)
print v(xbgr.mr_n62820912)
print v(xbgr.mr_n62821024)
print v(xbgr.mr_n62821344)
print v(xbgr.mr_n62821456)
print v(xbgr.mr_n62821776)
print v(xbgr.mr_n62821888)
print v(xbgr.mr_n62822320)
print v(xbgr.mr_n62822640)
print v(xbgr.mr_n62822752)
print v(xbgr.mr_n62823072)
print v(xbgr.mr_n62823184)
print v(xbgr.mr_n62823504)
print v(xbgr.mr_n62823616)
print v(xbgr.mr_n62824048)
print v(xbgr.mr_n62824368)
print v(xbgr.mr_n62824480)
print v(xbgr.mr_n62824800)
print v(xbgr.mr_n62824912)
print v(xbgr.mr_n62825232)
print v(xbgr.mr_n62825344)
print v(xbgr.mr_n62825664)
print v(xbgr.mr_n62825776)
print v(xbgr.mr_n62826096)
print v(xbgr.mr_n62826208)
print v(xbgr.mr_n62826528)
print v(xbgr.mr_n62826640)
print v(xbgr.mr_n62826960)
print v(xbgr.mr_n62827072)
print v(xbgr.mr_n62827392)
print v(xbgr.mr_n62827504)
print v(xbgr.mr_n62827824)
print v(xbgr.mr_n62827936)
print v(xbgr.mr_n62828256)
print v(xbgr.mr_n62828368)
print v(xbgr.mr_n62828688)
print v(xbgr.mr_n62828800)
print v(xbgr.mr_n62829120)
print v(xbgr.mr_n62829232)
print v(xbgr.mr_n62829552)
print v(xbgr.mr_n62829664)
print v(xbgr.mr_n62830096)
print v(xbgr.mr_n62830416)
print v(xbgr.mr_n62830528)
print v(xbgr.mr_n62830848)
print v(xbgr.mr_n62830960)
print v(xbgr.mr_n62831280)
print v(xbgr.mr_n62831392)
print v(xbgr.mr_n62831712)
print v(xbgr.mr_n62831824)
print v(xbgr.mr_n62832144)
print v(xbgr.mr_n62832256)
print v(xbgr.mr_n62832576)
print v(xbgr.mr_n62832688)
print v(xbgr.mr_n62833008)
print v(xbgr.mr_n62833120)
print v(xbgr.mr_n62833440)
print v(xbgr.mr_n62833552)
print v(xbgr.mr_n62833872)
print v(xbgr.mr_n62833984)
print v(xbgr.mr_n62834304)
print v(xbgr.mr_n62834416)
print v(xbgr.mr_n62834848)
print v(xbgr.mr_n62835168)
print v(xbgr.mr_n62835280)
print v(xbgr.mr_n62835600)
print v(xbgr.mr_n62835712)
print v(xbgr.mr_n62836032)
print v(xbgr.mr_n62836144)
print v(xbgr.mr_n62836464)
print v(xbgr.mr_n62836576)
print v(xbgr.mr_n62836896)
print v(xbgr.mr_n62837008)
print v(xbgr.mr_n62837328)
print v(xbgr.mr_n62837440)
print v(xbgr.mr_n62837760)
print v(xbgr.mr_n62837872)
print v(xbgr.mr_n62838192)
print v(xbgr.mr_n62838304)
print v(xbgr.mr_n62838624)
print v(xbgr.mr_n62838736)
print v(xbgr.mr_n62839056)
print v(xbgr.mr_n62839168)
print v(xbgr.mr_n62839488)
print v(xbgr.mr_n62839600)
print v(xbgr.mr_n62839920)
print v(xbgr.mr_n62840032)
print v(xbgr.mr_n62840352)
print v(xbgr.mr_n62840464)
print v(xbgr.mr_n62840784)
print v(xbgr.mr_n62840896)
print v(xbgr.mr_n62841216)
print v(xbgr.mr_n62841328)
print v(xbgr.mr_n62841648)
print v(xbgr.mr_n62841760)
print v(xbgr.mr_n62842192)
print v(xbgr.mr_n62842512)
print v(xbgr.mr_n62842624)
print v(xbgr.mr_n62842944)
print v(xbgr.mr_n62843056)
print v(xbgr.mr_n62843376)
print v(xbgr.mr_n62843488)
print v(xbgr.mr_n62843808)
print v(xbgr.mr_n62843920)
print v(xbgr.mr_n62844240)
print v(xbgr.mr_n62844352)
print v(xbgr.mr_n62844672)
print v(xbgr.mr_n62844784)
print v(xbgr.mr_n62845104)
print v(xbgr.mr_n62845216)
print v(xbgr.mr_n62845536)
print v(xbgr.mr_n62845648)
print v(xbgr.mr_n62845968)
print v(xbgr.mr_n62846080)
print v(xbgr.mr_n62846400)
print v(xbgr.mr_n62846512)
print v(xbgr.mr_n62846832)
print v(xbgr.mr_n62846944)
print v(xbgr.mr_n62847264)
print v(xbgr.mr_n62847376)
print v(xbgr.mr_n62847808)
print v(xbgr.mr_n62848128)
print v(xbgr.mr_n62848240)
print v(xbgr.mr_n62848560)
print v(xbgr.mr_n62848672)
print v(xbgr.mr_n62848992)
print v(xbgr.mr_n62849104)
print v(xbgr.mr_n62849424)
print v(xbgr.mr_n62849536)
print v(xbgr.mr_n62849856)
print v(xbgr.mr_n62849968)
print v(xbgr.mr_n62850288)
print v(xbgr.mr_n62850400)
print v(xbgr.mr_n62850720)
print v(xbgr.mr_n62850832)
print v(xbgr.mr_n62851152)
print v(xbgr.mr_n62851264)
print v(xbgr.mr_n62851584)
print v(xbgr.mr_n62851696)
print v(xbgr.mr_n62852016)
print v(xbgr.mr_n62852128)
print v(xbgr.mr_n62852448)
print v(xbgr.mr_n62852560)
print v(xbgr.mr_n62852880)
print v(xbgr.mr_n62852992)
print v(xbgr.mr_n62853312)
print v(xbgr.mr_n62853424)
print v(xbgr.mr_n62853744)
print v(xbgr.mr_n62853856)
print v(xbgr.mr_n62854176)
print v(xbgr.mr_n62854288)
print v(xbgr.mr_n62854608)
print v(xbgr.mr_n62854720)
print v(xbgr.mr_n62855040)
print v(xbgr.mr_n62855152)
print v(xbgr.mr_n62855472)
print v(xbgr.mr_n62855584)
print v(xbgr.mr_n62855904)
print v(xbgr.mr_n62856016)
print v(xbgr.mr_n62856336)
print v(xbgr.mr_n62856448)
print v(xbgr.mr_n62856880)
print v(xbgr.mr_n62857200)
print v(xbgr.mr_n62857312)
print v(xbgr.mr_n62857632)
print v(xbgr.mr_n62857744)
print v(xbgr.mr_n62858064)
print v(xbgr.mr_n62858176)
print v(xbgr.mr_n62858496)
print v(xbgr.mr_n62858608)
print v(xbgr.mr_n62858928)
print v(xbgr.mr_n62859040)
print v(xbgr.mr_n62859360)
print v(xbgr.mr_n62859472)
print v(xbgr.mr_n62859792)
print v(xbgr.mr_n62859904)
print v(xbgr.mr_n62860224)
print v(xbgr.mr_n62860336)
print v(xbgr.mr_n62860656)
print v(xbgr.mr_n62860768)
print v(xbgr.mr_n62861088)
print v(xbgr.mr_n62861200)
print v(xbgr.mr_n62861520)
print v(xbgr.mr_n62861632)
print v(xbgr.mr_n62861952)
print v(xbgr.mr_n62862064)
print v(xbgr.mr_n62862384)
print v(xbgr.mr_n62862496)
print v(xbgr.mr_n62862816)
print v(xbgr.mr_n62862928)
print v(xbgr.mr_n62863248)
print v(xbgr.mr_n62863360)
print v(xbgr.mr_n62863680)
print v(xbgr.mr_n62863792)
print v(xbgr.mr_n62864112)
print v(xbgr.mr_n62864224)
print v(xbgr.mr_n62864544)
print v(xbgr.mr_n62864656)
print v(xbgr.mr_n62864976)
print v(xbgr.mr_n62865088)
print v(xbgr.mr_n62865408)
print v(xbgr.mr_n62865520)
print v(xbgr.mr_n62865840)
print v(xbgr.mr_n62865952)
print v(xbgr.mr_n62866272)
print v(xbgr.mr_n62866384)
print v(xbgr.mr_n62866816)
print v(xbgr.mr_n62867136)
print v(xbgr.mr_n62867248)
print v(xbgr.mr_n62867568)
print v(xbgr.mr_n62867680)
print v(xbgr.mr_n62868000)
print v(xbgr.mr_n62868112)
print v(xbgr.mr_n62868432)
print v(xbgr.mr_n62868544)
print v(xbgr.mr_n62868864)
print v(xbgr.mr_n62868976)
print v(xbgr.mr_n62869296)
print v(xbgr.mr_n62869408)
print v(xbgr.mr_n62869728)
print v(xbgr.mr_n62869840)
print v(xbgr.mr_n62870160)
print v(xbgr.mr_n62870272)
print v(xbgr.mr_n62870592)
print v(xbgr.mr_n62870704)
print v(xbgr.mr_n62871024)
print v(xbgr.mr_n62871136)
print v(xbgr.mr_n62871456)
print v(xbgr.mr_n62871568)
print v(xbgr.mr_n62871888)
print v(xbgr.mr_n62872000)
print v(xbgr.mr_n62872432)
print v(xbgr.mr_n62872864)
print v(xbgr.mr_n62873296)
print v(xbgr.mr_n62873728)
print v(xbgr.mr_n62874160)
print v(xbgr.mr_n62874592)
print v(xbgr.mr_n62875024)
print v(xbgr.mr_n62875456)
print v(xbgr.mr_n62875888)
print v(xbgr.mr_n62876320)
print v(xbgr.mr_n62876752)
print v(xbgr.mr_n62877184)
print v(xbgr.mr_n62877616)
print v(xbgr.mr_n62878048)
print v(xbgr.mr_n62878480)
print v(xbgr.mr_n62878912)
print v(xbgr.mr_n62879344)
print v(xbgr.mr_n62879776)
print v(xbgr.mr_n62880208)
print v(xbgr.mr_n62880640)
print v(xbgr.mr_n62881072)
print v(xbgr.mr_n62881504)
print v(xbgr.mr_n62881936)
print v(xbgr.mr_n62882368)
print v(xbgr.mr_n62882800)
print v(xbgr.mr_n62883232)
print v(xbgr.mr_n62883664)
print v(xbgr.mr_n62884096)
print v(xbgr.mr_n62884528)
print v(xbgr.mr_n62884960)
print v(xbgr.mr_n62885392)
print v(xbgr.mr_n62885824)
print v(xbgr.mr_n62886256)
print v(xbgr.mr_n62886688)
print v(xbgr.mr_n62887120)
print v(xbgr.mr_n62887552)
print v(xbgr.mr_n62887984)
print v(xbgr.mr_n62888416)
print v(xbgr.mr_n62888848)
print v(xbgr.mr_n62889280)
print v(xbgr.mr_n62889712)
print v(xbgr.mr_n62890144)
print v(xbgr.mr_n62890576)
print v(xbgr.mr_n62891008)
print v(xbgr.mr_n62891440)
print v(xbgr.mr_n62891872)
print v(xbgr.mr_n62892304)
print v(xbgr.mr_n62892736)
print v(xbgr.mr_n62893168)
print v(xbgr.mr_n62893600)
print v(xbgr.mr_n62894032)
print v(xbgr.mr_n62894464)
print v(xbgr.mr_n62894896)
print v(xbgr.mr_n62895328)
print v(xbgr.mr_n62895760)
print v(xbgr.mr_n62896192)
print v(xbgr.mr_n62896624)
print v(xbgr.mr_n62897056)
print v(xbgr.mr_n62897488)
print v(xbgr.mr_n62897920)
print v(xbgr.mr_n62898352)
print v(xbgr.mr_n62898784)
print v(xbgr.mr_n62899216)
print v(xbgr.mr_n62899648)
print v(xbgr.mr_n62900080)
print v(xbgr.mr_n62900512)
print v(xbgr.mr_n62900944)
print v(xbgr.mr_n62901376)
print v(xbgr.mr_n62901808)
print v(xbgr.mr_n62902240)
print v(xbgr.mr_n62902672)
print v(xbgr.mr_n62903104)
print v(xbgr.mr_n62903536)
print v(xbgr.mr_n62903968)
print v(xbgr.mr_n62904400)
print v(xbgr.mr_n62904832)
print v(xbgr.mr_n62905264)
print v(xbgr.mr_n62905696)
print v(xbgr.mr_n62906128)
print v(xbgr.mr_n62906560)
print v(xbgr.mr_n62906992)
print v(xbgr.mr_n62907424)
print v(xbgr.mr_n62907856)
print v(xbgr.mr_n62908288)
print v(xbgr.mr_n62908720)
print v(xbgr.mr_n62909152)
print v(xbgr.mr_n62909584)
print v(xbgr.mr_n62910016)
print v(xbgr.mr_n62910448)
print v(xbgr.mr_n62910880)
print v(xbgr.mr_n62911312)
print v(xbgr.mr_n62911744)
print v(xbgr.mr_n62912176)
print v(xbgr.mr_n62912608)
print v(xbgr.mr_n62913040)
print v(xbgr.mr_n62913472)
print v(xbgr.mr_n62913904)
print v(xbgr.mr_n62914336)
print v(xbgr.mr_n62914768)
print v(xbgr.mr_n62915200)
print v(xbgr.mr_n62915632)
print v(xbgr.mr_n62916064)
print v(xbgr.mr_n62916496)
print v(xbgr.mr_n62916928)
print v(xbgr.mr_n62917360)
print v(xbgr.mr_n62917792)
print v(xbgr.mr_n62918224)
print v(xbgr.mr_n62918656)
print v(xbgr.mr_n62919088)
print v(xbgr.mr_n62919520)
print v(xbgr.mr_n62919840)
print v(xbgr.mr_n62919952)
print v(xbgr.mr_n62920272)
print v(xbgr.mr_n62920384)
print v(xbgr.mr_n62920704)
print v(xbgr.mr_n62920816)
print v(xbgr.mr_n62921136)
print v(xbgr.mr_n62921248)
print v(xbgr.mr_n62921568)
print v(xbgr.mr_n62921680)
print v(xbgr.mr_n62922000)
print v(xbgr.mr_n62922112)
print v(xbgr.mr_n62922432)
print v(xbgr.mr_n62922544)
print v(xbgr.mr_n62922864)
print v(xbgr.mr_n62922976)
print v(xbgr.mr_n62923296)
print v(xbgr.mr_n62923408)
print v(xbgr.mr_n62923728)
print v(xbgr.mr_n62923840)
print v(xbgr.mr_n62924160)
print v(xbgr.mr_n62924272)
print v(xbgr.mr_n62924592)
print v(xbgr.mr_n62924704)
print v(xbgr.mr_n62925024)
print v(xbgr.mr_n62925136)
print v(xbgr.mr_n62925456)
print v(xbgr.mr_n62925568)
print v(xbgr.mr_n62925888)
print v(xbgr.mr_n62926000)
print v(xbgr.mr_n62926320)
print v(xbgr.mr_n62926432)
print v(xbgr.mr_n62926752)
print v(xbgr.mr_n62926864)
print v(xbgr.mr_n62927184)
print v(xbgr.mr_n62927296)
print v(xbgr.mr_n62927616)
print v(xbgr.mr_n62927728)
print v(xbgr.mr_n62928048)
print v(xbgr.mr_n62928160)
print v(xbgr.mr_n62928480)
print v(xbgr.mr_n62928592)
print v(xbgr.mr_n62928912)
print v(xbgr.mr_n62929024)
print v(xbgr.mr_n62929344)
print v(xbgr.mr_n62929456)
print v(xbgr.mr_n62929776)
print v(xbgr.mr_n62929888)
print v(xbgr.mr_n62930208)
print v(xbgr.mr_n62930320)
print v(xbgr.mr_n62930640)
print v(xbgr.mr_n62930752)
print v(xbgr.mr_n62931072)
print v(xbgr.mr_n62931184)
print v(xbgr.mr_n62931504)
print v(xbgr.mr_n62931616)
print v(xbgr.mr_n62931936)
print v(xbgr.mr_n62932048)
print v(xbgr.mr_n62932368)
print v(xbgr.mr_n62932480)
print v(xbgr.mr_n62932800)
print v(xbgr.mr_n62932912)
print v(xbgr.mr_n62933232)
print v(xbgr.mr_n62933344)
print v(xbgr.mr_n62933664)
print v(xbgr.mr_n62933776)
print v(xbgr.mr_n62934096)
print v(xbgr.mr_n62934208)
print v(xbgr.mr_n62934528)
print v(xbgr.mr_n62934640)
print v(xbgr.mr_n62934960)
print v(xbgr.mr_n62935072)
print v(xbgr.mr_n62935392)
print v(xbgr.mr_n62935504)
print v(xbgr.mr_n62935824)
print v(xbgr.mr_n62935936)
print v(xbgr.mr_n62936256)
print v(xbgr.mr_n62936368)
print v(xbgr.mr_n62936688)
print v(xbgr.mr_n62936800)
print v(xbgr.mr_n62937120)
print v(xbgr.mr_n62937232)
print v(xbgr.mr_n62937552)
print v(xbgr.mr_n62937664)
print v(xbgr.mr_n62937984)
print v(xbgr.mr_n62938096)
print v(xbgr.mr_n62938416)
print v(xbgr.mr_n62938528)
print v(xbgr.mr_n62938848)
print v(xbgr.mr_n62938960)
print v(xbgr.mr_n62939280)
print v(xbgr.mr_n62939392)
print v(xbgr.mr_n62939712)
print v(xbgr.mr_n62939824)
print v(xbgr.mr_n62940144)
print v(xbgr.mr_n62940256)
print v(xbgr.mr_n62940576)
print v(xbgr.mr_n62940688)
print v(xbgr.mr_n62941008)
print v(xbgr.mr_n62941120)
print v(xbgr.mr_n62941552)
print v(xbgr.mr_n62941872)
print v(xbgr.mr_n62941984)
print v(xbgr.mr_n62942304)
print v(xbgr.mr_n62942416)
print v(xbgr.mr_n62942736)
print v(xbgr.mr_n62942848)
print v(xbgr.mr_n62943168)
print v(xbgr.mr_n62943280)
print v(xbgr.mr_n62943600)
print v(xbgr.mr_n62943712)
print v(xbgr.mr_n62944032)
print v(xbgr.mr_n62944144)
print v(xbgr.mr_n62944464)
print v(xbgr.mr_n62944576)
print v(xbgr.mr_n62944896)
print v(xbgr.mr_n62945008)
print v(xbgr.mr_n62945328)
print v(xbgr.mr_n62945440)
print v(xbgr.mr_n62945760)
print v(xbgr.mr_n62945872)
print v(xbgr.mr_n62946192)
print v(xbgr.mr_n62946304)
print v(xbgr.mr_n62946624)
print v(xbgr.mr_n62946736)
print v(xbgr.mr_n62947056)
print v(xbgr.mr_n62947168)
print v(xbgr.mr_n62947488)
print v(xbgr.mr_n62947600)
print v(xbgr.mr_n62947920)
print v(xbgr.mr_n62948032)
print v(xbgr.mr_n62948352)
print v(xbgr.mr_n62948464)
print v(xbgr.mr_n62948912)
print v(xbgr.mr_n62949024)
print v(xbgr.mr_n62949344)
print v(xbgr.mr_n62949456)
print v(xbgr.mr_n62949776)
print v(xbgr.mr_n62949888)
print v(xbgr.mr_n62950208)
print v(xbgr.mr_n62950320)
print v(xbgr.mr_n62950640)
print v(xbgr.mr_n62950752)
print v(xbgr.mr_n62951072)
print v(xbgr.mr_n62951184)
print v(xbgr.mr_n62951504)
print v(xbgr.mr_n62951616)
print v(xbgr.mr_n62951936)
print v(xbgr.mr_n62952048)
print v(xbgr.mr_n62952368)
print v(xbgr.mr_n62952480)
print v(xbgr.mr_n62952800)
print v(xbgr.mr_n62952912)
print v(xbgr.mr_n62953232)
print v(xbgr.mr_n62953344)
print v(xbgr.mr_n62953664)
print v(xbgr.mr_n62953776)
print v(xbgr.mr_n62954096)
print v(xbgr.mr_n62954208)
print v(xbgr.mr_n62954528)
print v(xbgr.mr_n62954640)
print v(xbgr.mr_n62954960)
print v(xbgr.mr_n62955072)
print v(xbgr.mr_n62955392)
print v(xbgr.mr_n62955504)
print v(xbgr.mr_n62955936)
print v(xbgr.mr_n62956368)
print v(xbgr.mr_n62956688)
print v(xbgr.mr_n62956800)
print v(xbgr.mr_n62957120)
print v(xbgr.mr_n62957232)
print v(xbgr.mr_n62957552)
print v(xbgr.mr_n62957664)
print v(xbgr.mr_n62957984)
print v(xbgr.mr_n62958096)
print v(xbgr.mr_n62958416)
print v(xbgr.mr_n62958528)
print v(xbgr.mr_n62958848)
print v(xbgr.mr_n62958960)
print v(xbgr.mr_n62959392)
print v(xbgr.mr_n62959712)
print v(xbgr.mr_n62959824)
print v(xbgr.mr_n62960144)
print v(xbgr.mr_n62960256)
print v(xbgr.mr_n62960576)
print v(xbgr.mr_n62960688)
print v(xbgr.mr_n62961008)
print v(xbgr.mr_n62961120)
print v(xbgr.mr_n62961440)
print v(xbgr.mr_n62961552)
print v(xbgr.mr_n62961872)
print v(xbgr.mr_n62961984)
print v(xbgr.mr_n62962304)
print v(xbgr.mr_n62962416)
print v(xbgr.mr_n62962736)
print v(xbgr.mr_n62962848)
print v(xbgr.mr_n62963168)
print v(xbgr.mr_n62963280)
print v(xbgr.mr_n62963600)
print v(xbgr.mr_n62963712)
print v(xbgr.mr_n62964032)
print v(xbgr.mr_n62964144)
print v(xbgr.mr_n62964464)
print v(xbgr.mr_n62964576)
print v(xbgr.mr_n62965008)
print v(xbgr.mr_n62965440)
print v(xbgr.mr_n62965872)
print v(xbgr.mr_n62966304)
print v(xbgr.mr_n62966800)
print v(xbgr.mr_n62966912)
print v(xbgr.mr_n62967248)
print v(xbgr.mr_n62967360)
print v(xbgr.mr_n62967680)
print v(xbgr.mr_n62967792)
print v(xbgr.mr_n62968160)
print v(xbgr.mr_n62968272)
print v(xbgr.mr_n62968592)
print v(xbgr.mr_n62968704)
print v(xbgr.mr_n62969024)
print v(xbgr.mr_n62969136)
print v(xbgr.mr_n62969376)
print v(xbgr.mr_n62969488)
print v(xbgr.mr_n62969808)
print v(xbgr.mr_n62969920)
print v(xbgr.mr_n62970240)
print v(xbgr.mr_n62970352)
print v(xbgr.mr_n62970672)
print v(xbgr.mr_n62970784)
print v(xbgr.mr_n62971104)
print v(xbgr.mr_n62971216)
print v(xbgr.mr_n62971536)
print v(xbgr.mr_n62971648)
print v(xbgr.mr_n62971968)
print v(xbgr.mr_n62972080)
print v(xbgr.mr_n62972400)
print v(xbgr.mr_n62972512)
print v(xbgr.mr_n62972832)
print v(xbgr.mr_n62972944)
print v(xbgr.mr_n62973264)
print v(xbgr.mr_n62973376)
print v(xbgr.mr_n62973696)
print v(xbgr.mr_n62973808)
print v(xbgr.mr_n62974128)
print v(xbgr.mr_n62974240)
print v(xbgr.mr_n62974560)
print v(xbgr.mr_n62974672)
print v(xbgr.mr_n62974992)
print v(xbgr.mr_n62975104)
print v(xbgr.mr_n62975424)
print v(xbgr.mr_n62975536)
print v(xbgr.mr_n62975856)
print v(xbgr.mr_n62975968)
print v(xbgr.mr_n62976288)
print v(xbgr.mr_n62976400)
print v(xbgr.mr_n62976720)
print v(xbgr.mr_n62976832)
print v(xbgr.mr_n62977152)
print v(xbgr.mr_n62977264)
print v(xbgr.mr_n62977584)
print v(xbgr.mr_n62977696)
print v(xbgr.mr_n62978016)
print v(xbgr.mr_n62978128)
print v(xbgr.mr_n62978448)
print v(xbgr.mr_n62978560)
print v(xbgr.mr_n62978880)
print v(xbgr.mr_n62978992)
print v(xbgr.mr_n62979312)
print v(xbgr.mr_n62979424)
print v(xbgr.mr_n62979744)
print v(xbgr.mr_n62979856)
print v(xbgr.mr_n62980288)
print v(xbgr.mr_n62980608)
print v(xbgr.mr_n62981600)
print v(xbgr.mr_n62981712)
print v(xbgr.mr_n62982032)
print v(xbgr.mr_n62982144)
print v(xbgr.mr_n62982464)
print v(xbgr.mr_n62982576)
print v(xbgr.mr_n62983008)
print v(xbgr.mr_n62983328)
print v(xbgr.mr_n62983440)
print v(xbgr.mr_n62983760)
print v(xbgr.mr_n62983872)
print v(xbgr.mr_n62984192)
print v(xbgr.mr_n62984304)
print v(xbgr.mr_n62984624)
print v(xbgr.mr_n62984736)
print v(xbgr.mr_n62985056)
print v(xbgr.mr_n62985168)
print v(xbgr.mr_n62985600)
print v(xbgr.mr_n62986032)
print v(xbgr.mr_n62986464)
print v(xbgr.mr_n62986896)
print v(xbgr.mr_n62987216)
print v(xbgr.mr_n62987328)
print v(xbgr.mr_n62987648)
print v(xbgr.mr_n62987760)
print v(xbgr.mr_n62988080)
print v(xbgr.mr_n62988192)
print v(xbgr.mr_n62988624)
print v(xbgr.mr_n62989056)
print v(xbgr.mr_n62989376)
print v(xbgr.mr_n62989488)
print v(xbgr.mr_n62989808)
print v(xbgr.mr_n62989920)
print v(xbgr.mr_n62990240)
print v(xbgr.mr_n62990352)
print v(xbgr.mr_n62990672)
print v(xbgr.mr_n62990784)
print v(xbgr.mr_n62991216)
print v(xbgr.mr_n62991648)
print v(xbgr.mr_n62992080)
print v(xbgr.mr_n62992512)
print v(xbgr.mr_n62992944)
print v(xbgr.mr_n62993264)
print v(xbgr.mr_n62993376)
print v(xbgr.mr_n62993696)
print v(xbgr.mr_n62993808)
print v(xbgr.mr_n62994128)
print v(xbgr.mr_n62994240)
print v(xbgr.mr_n62994560)
print v(xbgr.mr_n62994672)
print v(xbgr.mr_n62994992)
print v(xbgr.mr_n62995104)
print v(xbgr.mr_n62995424)
print v(xbgr.mr_n62995536)
print v(xbgr.mr_n62995856)
print v(xbgr.mr_n62995968)
print v(xbgr.mr_n62996288)
print v(xbgr.mr_n62996400)
print v(xbgr.mr_n62996720)
print v(xbgr.mr_n62996832)
print v(xbgr.mr_n62997152)
print v(xbgr.mr_n62997264)
print v(xbgr.mr_n62997584)
print v(xbgr.mr_n62997696)
print v(xbgr.mr_n62998016)
print v(xbgr.mr_n62998128)
print v(xbgr.mr_n62998560)
print v(xbgr.mr_n62998880)
print v(xbgr.mr_n62998992)
print v(xbgr.mr_n62999312)
print v(xbgr.mr_n62999424)
print v(xbgr.mr_n62999744)
print v(xbgr.mr_n62999856)
print v(xbgr.mr_n63000176)
print v(xbgr.mr_n63000288)
print v(xbgr.mr_n63000608)
print v(xbgr.mr_n63000720)
print v(xbgr.mr_n63001152)
print v(xbgr.mr_n63001584)
print v(xbgr.mr_n63002016)
print v(xbgr.mr_n63002448)
print v(xbgr.mr_n63002768)
print v(xbgr.mr_n63002880)
print v(xbgr.mr_n63003200)
print v(xbgr.mr_n63003312)
print v(xbgr.mr_n63003632)
print v(xbgr.mr_n63003744)
print v(xbgr.mr_n63004064)
print v(xbgr.mr_n63004176)
print v(xbgr.mr_n63004496)
print v(xbgr.mr_n63004608)
print v(xbgr.mr_n63004928)
print v(xbgr.mr_n63005040)
print v(xbgr.mr_n63005360)
print v(xbgr.mr_n63005472)
print v(xbgr.mr_n63005792)
print v(xbgr.mr_n63005904)
print v(xbgr.mr_n63006224)
print v(xbgr.mr_n63006336)
print v(xbgr.mr_n63006656)
print v(xbgr.mr_n63006768)
print v(xbgr.mr_n63007088)
print v(xbgr.mr_n63007200)
print v(xbgr.mr_n63007520)
print v(xbgr.mr_n63007632)
print v(xbgr.mr_n63007952)
print v(xbgr.mr_n63008064)
print v(xbgr.mr_n63008384)
print v(xbgr.mr_n63008496)
print v(xbgr.mr_n63008816)
print v(xbgr.mr_n63008928)
print v(xbgr.mr_n63009248)
print v(xbgr.mr_n63009360)
print v(xbgr.mr_n63009680)
print v(xbgr.mr_n63009792)
print v(xbgr.mr_n63010112)
print v(xbgr.mr_n63010224)
print v(xbgr.mr_n63010544)
print v(xbgr.mr_n63010656)
print v(xbgr.mr_n63010976)
print v(xbgr.mr_n63011088)
print v(xbgr.mr_n63011408)
print v(xbgr.mr_n63011520)
print v(xbgr.mr_n63011840)
print v(xbgr.mr_n63011952)
print v(xbgr.mr_n63012272)
print v(xbgr.mr_n63012384)
print v(xbgr.mr_n63012704)
print v(xbgr.mr_n63012816)
print v(xbgr.mr_n63013136)
print v(xbgr.mr_n63013248)
print v(xbgr.mr_n63013568)
print v(xbgr.mr_n63013680)
print v(xbgr.mr_n63014000)
print v(xbgr.mr_n63014112)
print v(xbgr.mr_n63014432)
print v(xbgr.mr_n63014544)
print v(xbgr.mr_n63014864)
print v(xbgr.mr_n63014976)
print v(xbgr.mr_n63015296)
print v(xbgr.mr_n63015408)
print v(xbgr.mr_n63015728)
print v(xbgr.mr_n63015840)
print v(xbgr.mr_n63016160)
print v(xbgr.mr_n63016272)
print v(xbgr.mr_n63016592)
print v(xbgr.mr_n63016704)
print v(xbgr.mr_n63017024)
print v(xbgr.mr_n63017136)
print v(xbgr.mr_n63017456)
print v(xbgr.mr_n63017568)
print v(xbgr.mr_n63017888)
print v(xbgr.mr_n63018000)
print v(xbgr.mr_n63018320)
print v(xbgr.mr_n63018432)
print v(xbgr.mr_n63018752)
print v(xbgr.mr_n63018864)
print v(xbgr.mr_n63019184)
print v(xbgr.mr_n63019296)
print v(xbgr.mr_n63019616)
print v(xbgr.mr_n63019728)
print v(xbgr.mr_n63020048)
print v(xbgr.mr_n63020160)
print v(xbgr.mr_n63020480)
print v(xbgr.mr_n63020592)
print v(xbgr.mr_n63020912)
print v(xbgr.mr_n63021024)
print v(xbgr.mr_n63021344)
print v(xbgr.mr_n63021456)
print v(xbgr.mr_n63021888)
print v(xbgr.mr_n63022320)
print v(xbgr.mr_n63022640)
print v(xbgr.mr_n63022752)
print v(xbgr.mr_n63023072)
print v(xbgr.mr_n63023184)
print v(xbgr.mr_n63023504)
print v(xbgr.mr_n63023616)
print v(xbgr.mr_n63023936)
print v(xbgr.mr_n63024048)
print v(xbgr.mr_n63024480)
print v(xbgr.mr_n63024912)
print v(xbgr.mr_n63025232)
print v(xbgr.mr_n63025344)
print v(xbgr.mr_n63025664)
print v(xbgr.mr_n63025776)
print v(xbgr.mr_n63026096)
print v(xbgr.mr_n63026208)
print v(xbgr.mr_n63026528)
print v(xbgr.mr_n63026640)
print v(xbgr.mr_n63027072)
print v(xbgr.mr_n63027504)
print v(xbgr.mr_n63027936)
print v(xbgr.mr_n63028368)
print v(xbgr.mr_n63028800)
print v(xbgr.mr_n63029232)
print v(xbgr.mr_n63029664)
print v(xbgr.mr_n63030096)
print v(xbgr.mr_n63030528)
print v(xbgr.mr_n63030960)
print v(xbgr.mr_n63031392)
print v(xbgr.mr_n63031824)
print v(xbgr.mr_n63032144)
print v(xbgr.mr_n63032576)
print v(xbgr.mr_n63033008)
print v(xbgr.mr_n63033440)
print v(xbgr.mr_n63033872)
print v(xbgr.mr_n63034304)
print v(xbgr.mr_n63034736)
print v(xbgr.mr_n63035168)
print v(xbgr.mr_n63035600)
print v(xbgr.mr_n63035712)
print v(xbgr.mr_n63036032)
print v(xbgr.mr_n63036144)
print v(xbgr.mr_n63036464)
print v(xbgr.mr_n63036576)
print v(xbgr.mr_n63036896)
print v(xbgr.mr_n63037008)
print v(xbgr.mr_n63037328)
print v(xbgr.mr_n63037440)
print v(xbgr.mr_n63037760)
print v(xbgr.mr_n63037872)
print v(xbgr.mr_n63038192)
print v(xbgr.mr_n63038304)
print v(xbgr.mr_n63038624)
print v(xbgr.mr_n63038736)
print v(xbgr.mr_n63039056)
print v(xbgr.mr_n63039488)
print v(xbgr.mr_n63039920)
print v(xbgr.mr_n63040352)
print v(xbgr.mr_n63040784)
print v(xbgr.mr_n63041216)
print v(xbgr.mr_n63041648)
print v(xbgr.mr_n63042080)
print v(xbgr.mr_n63042512)
print v(xbgr.mr_n63042944)
print v(xbgr.mr_n63043488)
print v(xbgr.mr_n63043920)
print v(xbgr.mr_n63044352)
print v(xbgr.mr_n63044784)
print v(xbgr.mr_n63045216)
print v(xbgr.mr_n63045648)
print v(xbgr.mr_n63046080)
print v(xbgr.mr_n63046512)
print v(xbgr.mr_n63046944)
print v(xbgr.mr_n63047376)
print v(xbgr.mr_n63047808)
print v(xbgr.mr_n63048240)
print v(xbgr.mr_n63048672)
print v(xbgr.mr_n63049104)
print v(xbgr.mr_n63049536)
print v(xbgr.mr_n63049968)
print v(xbgr.mr_n63050400)
print v(xbgr.mr_n63050832)
print v(xbgr.mr_n63051264)
print v(xbgr.mr_n63051696)
print v(xbgr.mr_n63052128)
print v(xbgr.mr_n63052560)
print v(xbgr.mr_n63052992)
print v(xbgr.mr_n63053424)
print v(xbgr.mr_n63053856)
print v(xbgr.mr_n63054288)
print v(xbgr.mr_n63054720)
print v(xbgr.mr_n63055152)
print v(xbgr.mr_n63055584)
print v(xbgr.mr_n63056016)
print v(xbgr.mr_n63056448)
print v(xbgr.mr_n63056880)
print v(xbgr.mr_n63057312)
print v(xbgr.mr_n63057744)
print v(xbgr.mr_n63058176)
print v(xbgr.mr_n63058608)
print v(xbgr.mr_n63059040)
print v(xbgr.mr_n63059472)
print v(xbgr.mr_n63059904)
print v(xbgr.mr_n63060336)
print v(xbgr.mr_n63060768)
print v(xbgr.mr_n63061200)
print v(xbgr.mr_n63061632)
print v(xbgr.mr_n63062064)
print v(xbgr.mr_n63062496)
print v(xbgr.mr_n63062928)
print v(xbgr.mr_n63063360)
print v(xbgr.mr_n63063792)
print v(xbgr.mr_n63064224)
print v(xbgr.mr_n63064656)
print v(xbgr.mr_n63065088)
print v(xbgr.mr_n63065520)
print v(xbgr.mr_n63065952)
print v(xbgr.mr_n63066384)
print v(xbgr.mr_n63066816)
print v(xbgr.mr_n63067248)
print v(xbgr.mr_n63067680)
print v(xbgr.mr_n63068112)
print v(xbgr.mr_n63068544)
print v(xbgr.mr_n63068976)
print v(xbgr.mr_n63069408)
print v(xbgr.mr_n63069840)
print v(xbgr.mr_n63070272)
print v(xbgr.mr_n63070704)
print v(xbgr.mr_n63071024)
print v(xbgr.mr_n63071456)
print v(xbgr.mr_n63071888)
print v(xbgr.mr_n63072320)
print v(xbgr.mr_n63072752)
print v(xbgr.mr_n63073184)
print v(xbgr.mr_n63073728)
print v(xbgr.mr_n63074160)
print v(xbgr.mr_n63074592)
print v(xbgr.mr_n63075024)
print v(xbgr.mr_n63075456)
print v(xbgr.mr_n63075888)
print v(xbgr.mr_n63076320)
print v(xbgr.mr_n63076752)
print v(xbgr.mr_n63077184)
print v(xbgr.mr_n63077616)
print v(xbgr.mr_n63078048)
print v(xbgr.mr_n63078480)
print v(xbgr.mr_n63078912)
print v(xbgr.mr_n63079344)
print v(xbgr.mr_n63079776)
print v(xbgr.mr_n63080208)
print v(xbgr.mr_n63080640)
print v(xbgr.mr_n63081072)
print v(xbgr.mr_n63081504)
print v(xbgr.mr_n63081936)
print v(xbgr.mr_n63082368)
print v(xbgr.mr_n63082800)
print v(xbgr.mr_n63083232)
print v(xbgr.mr_n63083664)
print v(xbgr.mr_n63084096)
print v(xbgr.mr_n63084528)
print v(xbgr.mr_n63084848)
print v(xbgr.mr_n63084960)
print v(xbgr.mr_n63085280)
print v(xbgr.mr_n63085392)
print v(xbgr.mr_n63085712)
print v(xbgr.mr_n63085824)
print v(xbgr.mr_n63086144)
print v(xbgr.mr_n63086256)
print v(xbgr.mr_n63086576)
print v(xbgr.mr_n63086688)
print v(xbgr.mr_n63087008)
print v(xbgr.mr_n63087120)
print v(xbgr.mr_n63087440)
print v(xbgr.mr_n63087552)
print v(xbgr.mr_n63087872)
print v(xbgr.mr_n63087984)
print v(xbgr.mr_n63088304)
print v(xbgr.mr_n63088416)
print v(xbgr.mr_n63088736)
print v(xbgr.mr_n63088848)
print v(xbgr.mr_n63089168)
print v(xbgr.mr_n63089280)
print v(xbgr.mr_n63089600)
print v(xbgr.mr_n63089712)
print v(xbgr.mr_n63090032)
print v(xbgr.mr_n63090144)
print v(xbgr.mr_n63090464)
print v(xbgr.mr_n63090576)
print v(xbgr.mr_n63090896)
print v(xbgr.mr_n63091008)
print v(xbgr.mr_n63091328)
print v(xbgr.mr_n63091760)
print v(xbgr.mr_n63091872)
print v(xbgr.mr_n63092192)
print v(xbgr.mr_n63092624)
print v(xbgr.mr_n63092736)
print v(xbgr.mr_n63093056)
print v(xbgr.mr_n63093168)
print v(xbgr.mr_n63093488)
print v(xbgr.mr_n63093600)
print v(xbgr.mr_n63093920)
print v(xbgr.mr_n63094032)
print v(xbgr.mr_n63094352)
print v(xbgr.mr_n63094464)
print v(xbgr.mr_n63094784)
print v(xbgr.mr_n63094896)
print v(xbgr.mr_n63095216)
print v(xbgr.mr_n63095328)
print v(xbgr.mr_n63095648)
print v(xbgr.mr_n63096080)
print v(xbgr.mr_n63096192)
print v(xbgr.mr_n63096512)
print v(xbgr.mr_n63096624)
print v(xbgr.mr_n63096944)
print v(xbgr.mr_n63097056)
print v(xbgr.mr_n63097376)
print v(xbgr.mr_n63097488)
print v(xbgr.mr_n63097808)
print v(xbgr.mr_n63097920)
print v(xbgr.mr_n63098240)
print v(xbgr.mr_n63098352)
print v(xbgr.mr_n63098672)
print v(xbgr.mr_n63098784)
print v(xbgr.mr_n63099104)
print v(xbgr.mr_n63099216)
print v(xbgr.mr_n63099536)
print v(xbgr.mr_n63099648)
print v(xbgr.mr_n63099968)
print v(xbgr.mr_n63100080)
print v(xbgr.mr_n63100400)
print v(xbgr.mr_n63100512)
print v(xbgr.mr_n63100832)
print v(xbgr.mr_n63101264)
print v(xbgr.mr_n63101376)
print v(xbgr.mr_n63101696)
print v(xbgr.mr_n63101808)
print v(xbgr.mr_n63102128)
print v(xbgr.mr_n63102240)
print v(xbgr.mr_n63102560)
print v(xbgr.mr_n63102672)
print v(xbgr.mr_n63102992)
print v(xbgr.mr_n63103104)
print v(xbgr.mr_n63103424)
print v(xbgr.mr_n63103536)
print v(xbgr.mr_n63103856)
print v(xbgr.mr_n63103968)
print v(xbgr.mr_n63104288)
print v(xbgr.mr_n63104400)
print v(xbgr.mr_n63104720)
print v(xbgr.mr_n63104832)
print v(xbgr.mr_n63105152)
print v(xbgr.mr_n63105264)
print v(xbgr.mr_n63105584)
print v(xbgr.mr_n63105696)
print v(xbgr.mr_n63106016)
print v(xbgr.mr_n63106128)
print v(xbgr.mr_n63106448)
print v(xbgr.mr_n63106560)
print v(xbgr.mr_n63106880)
print v(xbgr.mr_n63107312)
print v(xbgr.mr_n63107424)
print v(xbgr.mr_n63107744)
print v(xbgr.mr_n63107856)
print v(xbgr.mr_n63108176)
print v(xbgr.mr_n63108288)
print v(xbgr.mr_n63108608)
print v(xbgr.mr_n63108720)
print v(xbgr.mr_n63109040)
print v(xbgr.mr_n63109152)
print v(xbgr.mr_n63109472)
print v(xbgr.mr_n63109584)
print v(xbgr.mr_n63109904)
print v(xbgr.mr_n63110016)
print v(xbgr.mr_n63110336)
print v(xbgr.mr_n63110768)
print v(xbgr.mr_n63110880)
print v(xbgr.mr_n63111200)
print v(xbgr.mr_n63111632)
print v(xbgr.mr_n63111744)
print v(xbgr.mr_n63112064)
print v(xbgr.mr_n63112176)
print v(xbgr.mr_n63112496)
print v(xbgr.mr_n63112608)
print v(xbgr.mr_n63112928)
print v(xbgr.mr_n63113040)
print v(xbgr.mr_n63113360)
print v(xbgr.mr_n63113472)
print v(xbgr.mr_n63113792)
print v(xbgr.mr_n63113904)
print v(xbgr.mr_n63114224)
print v(xbgr.mr_n63114336)
print v(xbgr.mr_n63114656)
print v(xbgr.mr_n63114768)
print v(xbgr.mr_n63115088)
print v(xbgr.mr_n63115200)
print v(xbgr.mr_n63115520)
print v(xbgr.mr_n63115632)
print v(xbgr.mr_n63115952)
print v(xbgr.mr_n63116064)
print v(xbgr.mr_n63116384)
print v(xbgr.mr_n63116496)
print v(xbgr.mr_n63116928)
print v(xbgr.mr_n63117360)
print v(xbgr.mr_n63117792)
print v(xbgr.mr_n63118224)
print v(xbgr.mr_n63118656)
print v(xbgr.mr_n63119088)
print v(xbgr.mr_n63119520)
print v(xbgr.mr_n63119952)
print v(xbgr.mr_n63120384)
print v(xbgr.mr_n63120816)
print v(xbgr.mr_n63121248)
print v(xbgr.mr_n63121680)
print v(xbgr.mr_n63122112)
print v(xbgr.mr_n63122544)
print v(xbgr.mr_n63122976)
print v(xbgr.mr_n63123408)
print v(xbgr.mr_n63123840)
print v(xbgr.mr_n63124272)
print v(xbgr.mr_n63124704)
print v(xbgr.mr_n63125136)
print v(xbgr.mr_n63125568)
print v(xbgr.mr_n63126000)
print v(xbgr.mr_n63126432)
print v(xbgr.mr_n63126864)
print v(xbgr.mr_n63127296)
print v(xbgr.mr_n63127728)
print v(xbgr.mr_n63128160)
print v(xbgr.mr_n63128592)
print v(xbgr.mr_n63129024)
print v(xbgr.mr_n63129456)
print v(xbgr.mr_n63129888)
print v(xbgr.mr_n63130320)
print v(xbgr.mr_n63130752)
print v(xbgr.mr_n63131184)
print v(xbgr.mr_n63131616)
print v(xbgr.mr_n63132048)
print v(xbgr.mr_n63132480)
print v(xbgr.mr_n63132912)
print v(xbgr.mr_n63133344)
print v(xbgr.mr_n63133776)
print v(xbgr.mr_n63134208)
print v(xbgr.mr_n63134640)
print v(xbgr.mr_n63135072)
print v(xbgr.mr_n63135504)
print v(xbgr.mr_n63135936)
print v(xbgr.mr_n63136368)
print v(xbgr.mr_n63136800)
print v(xbgr.mr_n63137232)
print v(xbgr.mr_n63137664)
print v(xbgr.mr_n63138096)
print v(xbgr.mr_n63138528)
print v(xbgr.mr_n63138960)
print v(xbgr.mr_n63139392)
print v(xbgr.mr_n63139824)
print v(xbgr.mr_n63140256)
print v(xbgr.mr_n63140688)
print v(xbgr.mr_n63141120)
print v(xbgr.mr_n63141552)
print v(xbgr.mr_n63141984)
print v(xbgr.mr_n63142416)
print v(xbgr.mr_n63142848)
print v(xbgr.mr_n63143280)
print v(xbgr.mr_n63143712)
print v(xbgr.mr_n63144144)
print v(xbgr.mr_n63144576)
print v(xbgr.mr_n63145008)
print v(xbgr.mr_n63145440)
print v(xbgr.mr_n63145872)
print v(xbgr.mr_n63146304)
print v(xbgr.mr_n63146736)
print v(xbgr.mr_n63147168)
print v(xbgr.mr_n63147600)
print v(xbgr.mr_n63148032)
print v(xbgr.mr_n63148464)
print v(xbgr.mr_n63148896)
print v(xbgr.mr_n63149328)
print v(xbgr.mr_n63149760)
print v(xbgr.mr_n63150192)
print v(xbgr.mr_n63150512)
print v(xbgr.mr_n63150624)
print v(xbgr.mr_n63150944)
print v(xbgr.mr_n63151056)
print v(xbgr.mr_n63151488)
print v(xbgr.mr_n63151920)
print v(xbgr.mr_n63152240)
print v(xbgr.mr_n63152352)
print v(xbgr.mr_n63152672)
print v(xbgr.mr_n63153216)
print v(xbgr.mr_n63153648)
print v(xbgr.mr_n63153968)
print v(xbgr.mr_n63154080)
print v(xbgr.mr_n63154400)
print v(xbgr.mr_n63154512)
print v(xbgr.mr_n63154832)
print v(xbgr.mr_n63154944)
print v(xbgr.mr_n63155264)
print v(xbgr.mr_n63155376)
print v(xbgr.mr_n63155696)
print v(xbgr.mr_n63155808)
print v(xbgr.mr_n63156128)
print v(xbgr.mr_n63156240)
print v(xbgr.mr_n63156560)
print v(xbgr.mr_n63156672)
print v(xbgr.mr_n63156992)
print v(xbgr.mr_n63157104)
print v(xbgr.mr_n63157424)
print v(xbgr.mr_n63157536)
print v(xbgr.mr_n63157856)
print v(xbgr.mr_n63157968)
print v(xbgr.mr_n63158288)
print v(xbgr.mr_n63158400)
print v(xbgr.mr_n63158720)
print v(xbgr.mr_n63158832)
print v(xbgr.mr_n63159264)
print v(xbgr.mr_n63159696)
print v(xbgr.mr_n63160016)
print v(xbgr.mr_n63160128)
print v(xbgr.mr_n63160448)
print v(xbgr.mr_n63160560)
print v(xbgr.mr_n63160992)
print v(xbgr.mr_n63161424)
print v(xbgr.mr_n63161856)
print v(xbgr.mr_n63162288)
print v(xbgr.mr_n63162720)
print v(xbgr.mr_n63163152)
print v(xbgr.mr_n63163584)
print v(xbgr.mr_n63164016)
print v(xbgr.mr_n63164448)
print v(xbgr.mr_n63164880)
print v(xbgr.mr_n63165312)
print v(xbgr.mr_n63165744)
print v(xbgr.mr_n63166176)
print v(xbgr.mr_n63166608)
print v(xbgr.mr_n63167040)
print v(xbgr.mr_n63167472)
print v(xbgr.mr_n63167904)
print v(xbgr.mr_n63168336)
print v(xbgr.mr_n63168768)
print v(xbgr.mr_n63169200)
print v(xbgr.mr_n63169632)
print v(xbgr.mr_n63170064)
print v(xbgr.mr_n63170496)
print v(xbgr.mr_n63170928)
print v(xbgr.mr_n63171360)
print v(xbgr.mr_n63171792)
print v(xbgr.mr_n63172224)
print v(xbgr.mr_n63172656)
print v(xbgr.mr_n63173088)
print v(xbgr.mr_n63173520)
print v(xbgr.mr_n63173952)
print v(xbgr.mr_n63174384)
print v(xbgr.mr_n63174816)
print v(xbgr.mr_n63175248)
print v(xbgr.mr_n63175680)
print v(xbgr.mr_n63176112)
print v(xbgr.mr_n63176544)
print v(xbgr.mr_n63176976)
print v(xbgr.mr_n63177408)
print v(xbgr.mr_n63177840)
print v(xbgr.mr_n63178272)
print v(xbgr.mr_n63178704)
print v(xbgr.mr_n63179136)
print v(xbgr.mr_n63179568)
print v(xbgr.mr_n63180000)
print v(xbgr.mr_n63180432)
print v(xbgr.mr_n63180864)
print v(xbgr.mr_n63181296)
print v(xbgr.mr_n63181728)
print v(xbgr.mr_n63182160)
print v(xbgr.mr_n63182592)
print v(xbgr.mr_n63183024)
print v(xbgr.mr_n63183456)
print v(xbgr.mr_n63183888)
print v(xbgr.mr_n63184320)
print v(xbgr.mr_n63184752)
print v(xbgr.mr_n63185184)
print v(xbgr.mr_n63185616)
print v(xbgr.mr_n63186048)
print v(xbgr.mr_n63186480)
print v(xbgr.mr_n63186912)
print v(xbgr.mr_n63187344)
print v(xbgr.mr_n63187776)
print v(xbgr.mr_n63188208)
print v(xbgr.mr_n63188640)
print v(xbgr.mr_n63189072)
print v(xbgr.mr_n63189504)
print v(xbgr.mr_n63189936)
print v(xbgr.mr_n63190368)
print v(xbgr.mr_n63190800)
print v(xbgr.mr_n63191232)
print v(xbgr.mr_n63191664)
print v(xbgr.mr_n63192096)
print v(xbgr.mr_n63192528)
print v(xbgr.mr_n63192960)
print v(xbgr.mr_n63193392)
print v(xbgr.mr_n63193824)
print v(xbgr.mr_n63194256)
print v(xbgr.mr_n63194688)
print v(xbgr.mr_n63195120)
print v(xbgr.mr_n63195552)
print v(xbgr.mr_n63195984)
print v(xbgr.mr_n63196416)
print v(xbgr.mr_n63196848)
print v(xbgr.mr_n63197280)
print v(xbgr.mr_n63197712)
print v(xbgr.mr_n63198144)
print v(xbgr.mr_n63198576)
print v(xbgr.mr_n63199008)
print v(xbgr.mr_n63199440)
print v(xbgr.mr_n63199872)
print v(xbgr.mr_n63200304)
print v(xbgr.mr_n63200736)
print v(xbgr.mr_n63201168)
print v(xbgr.mr_n63201600)
print v(xbgr.mr_n63202032)
print v(xbgr.mr_n63202464)
print v(xbgr.mr_n63202896)
print v(xbgr.mr_n63203328)
print v(xbgr.mr_n63203760)
print v(xbgr.mr_n63204192)
print v(xbgr.mr_n63204624)
print v(xbgr.mr_n63205056)
print v(xbgr.mr_n63205488)
print v(xbgr.mr_n63205920)
print v(xbgr.mr_n63206352)
print v(xbgr.mr_n63206784)
print v(xbgr.mr_n63207216)
print v(xbgr.mr_n63207648)
print v(xbgr.mr_n63208080)
print v(xbgr.mr_n63208512)
print v(xbgr.mr_n63208944)
print v(xbgr.mr_n63209376)
print v(xbgr.mr_n63209808)
print v(xbgr.mr_n63210240)
print v(xbgr.mr_n63210672)
print v(xbgr.mr_n63211104)
print v(xbgr.mr_n63211536)
print v(xbgr.mr_n63211968)
print v(xbgr.mr_n63212400)
print v(xbgr.mr_n63212832)
print v(xbgr.mr_n63213264)
print v(xbgr.mr_n63213696)
print v(xbgr.mr_n63214128)
print v(xbgr.mr_n63214560)
print v(xbgr.mr_n63214992)
print v(xbgr.mr_n63215424)
print v(xbgr.mr_n63215856)
print v(xbgr.mr_n63216288)
print v(xbgr.mr_n63216720)
print v(xbgr.mr_n63217152)
print v(xbgr.mr_n63217584)
print v(xbgr.mr_n63218016)
print v(xbgr.mr_n63218448)
print v(xbgr.mr_n63218880)
print v(xbgr.mr_n63219312)
print v(xbgr.mr_n63219632)
print v(xbgr.mr_n63219744)
print v(xbgr.mr_n63220064)
print v(xbgr.mr_n63220176)
print v(xbgr.mr_n63220496)
print v(xbgr.mr_n63220608)
print v(xbgr.mr_n63220928)
print v(xbgr.mr_n63221040)
print v(xbgr.mr_n63221360)
print v(xbgr.mr_n63221472)
print v(xbgr.mr_n63221792)
print v(xbgr.mr_n63221904)
print v(xbgr.mr_n63222224)
print v(xbgr.mr_n63222336)
print v(xbgr.mr_n63222656)
print v(xbgr.mr_n63222768)
print v(xbgr.mr_n63223088)
print v(xbgr.mr_n63223200)
print v(xbgr.mr_n63223520)
print v(xbgr.mr_n63223632)
print v(xbgr.mr_n63223952)
print v(xbgr.mr_n63224064)
print v(xbgr.mr_n63224384)
print v(xbgr.mr_n63224496)
print v(xbgr.mr_n63224816)
print v(xbgr.mr_n63224928)
print v(xbgr.mr_n63225248)
print v(xbgr.mr_n63225360)
print v(xbgr.mr_n63225680)
print v(xbgr.mr_n63225792)
print v(xbgr.mr_n63226112)
print v(xbgr.mr_n63226224)
print v(xbgr.mr_n63226544)
print v(xbgr.mr_n63226656)
print v(xbgr.mr_n63226976)
print v(xbgr.mr_n63227088)
print v(xbgr.mr_n63227408)
print v(xbgr.mr_n63227520)
print v(xbgr.mr_n63227840)
print v(xbgr.mr_n63227952)
print v(xbgr.mr_n63228272)
print v(xbgr.mr_n63228384)
print v(xbgr.mr_n63228704)
print v(xbgr.mr_n63228816)
print v(xbgr.mr_n63229136)
print v(xbgr.mr_n63229248)
print v(xbgr.mr_n63229568)
print v(xbgr.mr_n63229680)
print v(xbgr.mr_n63230000)
print v(xbgr.mr_n63230112)
print v(xbgr.mr_n63230432)
print v(xbgr.mr_n63230544)
print v(xbgr.mr_n63230864)
print v(xbgr.mr_n63230976)
print v(xbgr.mr_n63231296)
print v(xbgr.mr_n63231408)
print v(xbgr.mr_n63231728)
print v(xbgr.mr_n63231840)
print v(xbgr.mr_n63232160)
print v(xbgr.mr_n63232272)
print v(xbgr.mr_n63232704)
print v(xbgr.mr_n63233136)
print v(xbgr.mr_n63233568)
print v(xbgr.mr_n63234000)
print v(xbgr.mr_n63234320)
print v(xbgr.mr_n63234432)
print v(xbgr.mr_n63234752)
print v(xbgr.mr_n63234864)
print v(xbgr.mr_n63235184)
print v(xbgr.mr_n63235296)
print v(xbgr.mr_n63235616)
print v(xbgr.mr_n63235728)
print v(xbgr.mr_n63236048)
print v(xbgr.mr_n63236160)
print v(xbgr.mr_n63236480)
print v(xbgr.mr_n63236592)
print v(xbgr.mr_n63237024)
print v(xbgr.mr_n63237456)
print v(xbgr.mr_n63237888)
print v(xbgr.mr_n63238208)
print v(xbgr.mr_n63238320)
print v(xbgr.mr_n63238640)
print v(xbgr.mr_n63238752)
print v(xbgr.mr_n63239072)
print v(xbgr.mr_n63239184)
print v(xbgr.mr_n63239504)
print v(xbgr.mr_n63239616)
print v(xbgr.mr_n63239936)
print v(xbgr.mr_n63240048)
print v(xbgr.mr_n63240368)
print v(xbgr.mr_n63240480)
print v(xbgr.mr_n63240800)
print v(xbgr.mr_n63240912)
print v(xbgr.mr_n63241232)
print v(xbgr.mr_n63241344)
print v(xbgr.mr_n63241664)
print v(xbgr.mr_n63241776)
print v(xbgr.mr_n63242096)
print v(xbgr.mr_n63242208)
print v(xbgr.mr_n63242640)
print v(xbgr.mr_n63243072)
print v(xbgr.mr_n63243504)
print v(xbgr.mr_n63243936)
print v(xbgr.mr_n63244368)
print v(xbgr.mr_n63244800)
print v(xbgr.mr_n63245232)
print v(xbgr.mr_n63245664)
print v(xbgr.mr_n63246096)
print v(xbgr.mr_n63246528)
print v(xbgr.mr_n63246960)
print v(xbgr.mr_n63247392)
print v(xbgr.mr_n63247824)
print v(xbgr.mr_n63248144)
print v(xbgr.mr_n63248256)
print v(xbgr.mr_n63248576)
print v(xbgr.mr_n63248688)
print v(xbgr.mr_n63249008)
print v(xbgr.mr_n63249120)
print v(xbgr.mr_n63249440)
print v(xbgr.mr_n63249552)
print v(xbgr.mr_n63249872)
print v(xbgr.mr_n63249984)
print v(xbgr.mr_n63250416)
print v(xbgr.mr_n63250848)
print v(xbgr.mr_n63251280)
print v(xbgr.mr_n63251712)
print v(xbgr.mr_n63252144)
print v(xbgr.mr_n63252576)
print v(xbgr.mr_n63252896)
print v(xbgr.mr_n63253008)
print v(xbgr.mr_n63253328)
print v(xbgr.mr_n63253440)
print v(xbgr.mr_n63253872)
print v(xbgr.mr_n63254304)
print v(xbgr.mr_n63254624)
print v(xbgr.mr_n63254736)
print v(xbgr.mr_n63255056)
print v(xbgr.mr_n63255168)
print v(xbgr.mr_n63255488)
print v(xbgr.mr_n63255600)
print v(xbgr.mr_n63255920)
print v(xbgr.mr_n63256032)
print v(xbgr.mr_n63256352)
print v(xbgr.mr_n63256464)
print v(xbgr.mr_n63256784)
print v(xbgr.mr_n63256896)
print v(xbgr.mr_n63257216)
print v(xbgr.mr_n63257328)
print v(xbgr.mr_n63257648)
print v(xbgr.mr_n63257760)
print v(xbgr.mr_n63258080)
print v(xbgr.mr_n63258192)
print v(xbgr.mr_n63258512)
print v(xbgr.mr_n63258624)
print v(xbgr.mr_n63258944)
print v(xbgr.mr_n63259056)
print v(xbgr.mr_n63259376)
print v(xbgr.mr_n63259488)
print v(xbgr.mr_n63259808)
print v(xbgr.mr_n63259920)
print v(xbgr.mr_n63260240)
print v(xbgr.mr_n63260352)
print v(xbgr.mr_n63260784)
print v(xbgr.mr_n63261216)
print v(xbgr.mr_n63261536)
print v(xbgr.mr_n63261648)
print v(xbgr.mr_n63261968)
print v(xbgr.mr_n63262080)
print v(xbgr.mr_n63262400)
print v(xbgr.mr_n63262512)
print v(xbgr.mr_n63262832)
print v(xbgr.mr_n63262944)
print v(xbgr.mr_n63263264)
print v(xbgr.mr_n63263376)
print v(xbgr.mr_n63263696)
print v(xbgr.mr_n63263808)
print v(xbgr.mr_n63264240)
print v(xbgr.mr_n63264672)
print v(xbgr.mr_n63264992)
print v(xbgr.mr_n63265104)
print v(xbgr.mr_n63265424)
print v(xbgr.mr_n63265536)
print v(xbgr.mr_n63265856)
print v(xbgr.mr_n63265968)
print v(xbgr.mr_n63266288)
print v(xbgr.mr_n63266400)
print v(xbgr.mr_n63266720)
print v(xbgr.mr_n63266832)
print v(xbgr.mr_n63267152)
print v(xbgr.mr_n63267264)
print v(xbgr.mr_n63267584)
print v(xbgr.mr_n63267696)
print v(xbgr.mr_n63268016)
print v(xbgr.mr_n63268128)
print v(xbgr.mr_n63268448)
print v(xbgr.mr_n63268560)
print v(xbgr.mr_n63268880)
print v(xbgr.mr_n63268992)
print v(xbgr.mr_n63269312)
print v(xbgr.mr_n63269424)
print v(xbgr.mr_n63269744)
print v(xbgr.mr_n63269856)
print v(xbgr.mr_n63270176)
print v(xbgr.mr_n63270288)
print v(xbgr.mr_n63270608)
print v(xbgr.mr_n63270720)
print v(xbgr.mr_n63271040)
print v(xbgr.mr_n63271152)
print v(xbgr.mr_n63271472)
print v(xbgr.mr_n63271584)
print v(xbgr.mr_n63271904)
print v(xbgr.mr_n63272016)
print v(xbgr.mr_n63272336)
print v(xbgr.mr_n63272448)
print v(xbgr.mr_n63272768)
print v(xbgr.mr_n63272880)
print v(xbgr.mr_n63273200)
print v(xbgr.mr_n63273312)
print v(xbgr.mr_n63273632)
print v(xbgr.mr_n63273744)
print v(xbgr.mr_n63274064)
print v(xbgr.mr_n63274176)
print v(xbgr.mr_n63274496)
print v(xbgr.mr_n63274608)
print v(xbgr.mr_n63274928)
print v(xbgr.mr_n63275040)
print v(xbgr.mr_n63275360)
print v(xbgr.mr_n63275472)
print v(xbgr.mr_n63275792)
print v(xbgr.mr_n63275904)
print v(xbgr.mr_n63276224)
print v(xbgr.mr_n63276336)
print v(xbgr.mr_n63276656)
print v(xbgr.mr_n63276768)
print v(xbgr.mr_n63277088)
print v(xbgr.mr_n63277200)
print v(xbgr.mr_n63277520)
print v(xbgr.mr_n63277632)
print v(xbgr.mr_n63277952)
print v(xbgr.mr_n63278064)
print v(xbgr.mr_n63278384)
print v(xbgr.mr_n63278496)
print v(xbgr.mr_n63278816)
print v(xbgr.mr_n63278928)
print v(xbgr.mr_n63279248)
print v(xbgr.mr_n63279360)
print v(xbgr.mr_n63279680)
print v(xbgr.mr_n63279792)
print v(xbgr.mr_n63280112)
print v(xbgr.mr_n63280224)
print v(xbgr.mr_n63280544)
print v(xbgr.mr_n63280656)
print v(xbgr.mr_n63280976)
print v(xbgr.mr_n63281088)
print v(xbgr.mr_n63281408)
print v(xbgr.mr_n63281520)
print v(xbgr.mr_n63281840)
print v(xbgr.mr_n63281952)
print v(xbgr.mr_n63282272)
print v(xbgr.mr_n63282384)
print v(xbgr.mr_n63282704)
print v(xbgr.mr_n63282816)
print v(xbgr.mr_n63283136)
print v(xbgr.mr_n63283248)
print v(xbgr.mr_n63283568)
print v(xbgr.mr_n63283680)
print v(xbgr.mr_n63284000)
print v(xbgr.mr_n63284112)
print v(xbgr.mr_n63284432)
print v(xbgr.mr_n63284544)
print v(xbgr.mr_n63284864)
print v(xbgr.mr_n63284976)
print v(xbgr.mr_n63285296)
print v(xbgr.mr_n63285408)
print v(xbgr.mr_n63285728)
print v(xbgr.mr_n63285840)
print v(xbgr.mr_n63286160)
print v(xbgr.mr_n63286272)
print v(xbgr.mr_n63286592)
print v(xbgr.mr_n63286704)
print v(xbgr.mr_n63287024)
print v(xbgr.mr_n63287136)
print v(xbgr.mr_n63287456)
print v(xbgr.mr_n63287568)
print v(xbgr.mr_n63287888)
print v(xbgr.mr_n63288000)
print v(xbgr.mr_n63288320)
print v(xbgr.mr_n63288432)
print v(xbgr.mr_n63288752)
print v(xbgr.mr_n63288864)
print v(xbgr.mr_n63289184)
print v(xbgr.mr_n63289296)
print v(xbgr.mr_n63289616)
print v(xbgr.mr_n63289728)
print v(xbgr.mr_n63290048)
print v(xbgr.mr_n63290160)
print v(xbgr.mr_n63290480)
print v(xbgr.mr_n63290592)
print v(xbgr.mr_n63290912)
print v(xbgr.mr_n63291024)
print v(xbgr.mr_n63291344)
print v(xbgr.mr_n63291456)
print v(xbgr.mr_n63291776)
print v(xbgr.mr_n63291888)
print v(xbgr.mr_n63292208)
print v(xbgr.mr_n63292320)
print v(xbgr.mr_n63292640)
print v(xbgr.mr_n63292752)
print v(xbgr.mr_n63293072)
print v(xbgr.mr_n63293184)
print v(xbgr.mr_n63293504)
print v(xbgr.mr_n63293616)
print v(xbgr.mr_n63293936)
print v(xbgr.mr_n63294048)
print v(xbgr.mr_n63294368)
print v(xbgr.mr_n63294480)
print v(xbgr.mr_n63294800)
print v(xbgr.mr_n63294912)
print v(xbgr.mr_n63295232)
print v(xbgr.mr_n63295344)
print v(xbgr.mr_n63295664)
print v(xbgr.mr_n63295776)
print v(xbgr.mr_n63296096)
print v(xbgr.mr_n63296208)
print v(xbgr.mr_n63296528)
print v(xbgr.mr_n63296640)
print v(xbgr.mr_n63296960)
print v(xbgr.mr_n63297072)
print v(xbgr.mr_n63297392)
print v(xbgr.mr_n63297504)
print v(xbgr.mr_n63297824)
print v(xbgr.mr_n63297936)
print v(xbgr.mr_n63298256)
print v(xbgr.mr_n63298368)
print v(xbgr.mr_n63298688)
print v(xbgr.mr_n63298800)
print v(xbgr.mr_n63299120)
print v(xbgr.mr_n63299232)
print v(xbgr.mr_n63299552)
print v(xbgr.mr_n63299664)
print v(xbgr.mr_n63299984)
print v(xbgr.mr_n63300096)
print v(xbgr.mr_n63300416)
print v(xbgr.mr_n63300528)
print v(xbgr.mr_n63300848)
print v(xbgr.mr_n63300960)
print v(xbgr.mr_n63301280)
print v(xbgr.mr_n63301392)
print v(xbgr.mr_n63301712)
print v(xbgr.mr_n63301824)
print v(xbgr.mr_n63302144)
print v(xbgr.mr_n63302256)
print v(xbgr.mr_n63302576)
print v(xbgr.mr_n63302688)
print v(xbgr.mr_n63303008)
print v(xbgr.mr_n63303120)
print v(xbgr.mr_n63303440)
print v(xbgr.mr_n63303552)
print v(xbgr.mr_n63303872)
print v(xbgr.mr_n63303984)
print v(xbgr.mr_n63304304)
print v(xbgr.mr_n63304416)
print v(xbgr.mr_n63304736)
print v(xbgr.mr_n63304848)
print v(xbgr.mr_n63305168)
print v(xbgr.mr_n63305280)
print v(xbgr.mr_n63305600)
print v(xbgr.mr_n63305712)
print v(xbgr.mr_n63306032)
print v(xbgr.mr_n63306144)
print v(xbgr.mr_n63306464)
print v(xbgr.mr_n63306576)
print v(xbgr.mr_n63306896)
print v(xbgr.mr_n63307008)
print v(xbgr.mr_n63307328)
print v(xbgr.mr_n63307440)
print v(xbgr.mr_n63307760)
print v(xbgr.mr_n63307872)
print v(xbgr.mr_n63308192)
print v(xbgr.mr_n63308304)
print v(xbgr.mr_n63308624)
print v(xbgr.mr_n63308736)
print v(xbgr.mr_n63309056)
print v(xbgr.mr_n63309168)
print v(xbgr.mr_n63309488)
print v(xbgr.mr_n63309600)
print v(xbgr.mr_n63309920)
print v(xbgr.mr_n63310032)
print v(xbgr.mr_n63310352)
print v(xbgr.mr_n63310464)
print v(xbgr.mr_n63310784)
print v(xbgr.mr_n63310896)
print v(xbgr.mr_n63311216)
print v(xbgr.mr_n63311328)
print v(xbgr.mr_n63311648)
print v(xbgr.mr_n63311760)
print v(xbgr.mr_n63312080)
print v(xbgr.mr_n63312192)
print v(xbgr.mr_n63312512)
print v(xbgr.mr_n63312624)
print v(xbgr.mr_n63312944)
print v(xbgr.mr_n63313056)
print v(xbgr.mr_n63313376)
print v(xbgr.mr_n63313488)
print v(xbgr.mr_n63313808)
print v(xbgr.mr_n63313920)
print v(xbgr.mr_n63314240)
print v(xbgr.mr_n63314352)
print v(xbgr.mr_n63314672)
print v(xbgr.mr_n63314784)
print v(xbgr.mr_n63315104)
print v(xbgr.mr_n63315216)
print v(xbgr.mr_n63315648)
print v(xbgr.mr_n63316080)
print v(xbgr.mr_n63316512)
print v(xbgr.mr_n63316944)
print v(xbgr.mr_n63317376)
print v(xbgr.mr_n63317808)
print v(xbgr.mr_n63318240)
print v(xbgr.mr_n63318672)
print v(xbgr.mr_n63319104)
print v(xbgr.mr_n63319536)
print v(xbgr.mr_n63319968)
print v(xbgr.mr_n63320400)
print v(xbgr.mr_n63320832)
print v(xbgr.mr_n63321264)
print v(xbgr.mr_n63321696)
print v(xbgr.mr_n63322128)
print v(xbgr.mr_n63322560)
print v(xbgr.mr_n63322992)
print v(xbgr.mr_n63323424)
print v(xbgr.mr_n63323856)
print v(xbgr.mr_n63324288)
print v(xbgr.mr_n63324720)
print v(xbgr.mr_n63325152)
print v(xbgr.mr_n63325584)
print v(xbgr.mr_n63326016)
print v(xbgr.mr_n63326448)
print v(xbgr.mr_n63326880)
print v(xbgr.mr_n63327312)
print v(xbgr.mr_n63327744)
print v(xbgr.mr_n63328176)
print v(xbgr.mr_n63328608)
print v(xbgr.mr_n63329040)
print v(xbgr.mr_n63329472)
print v(xbgr.mr_n63329904)
print v(xbgr.mr_n63330224)
print v(xbgr.mr_n63330336)
print v(xbgr.mr_n63330656)
print v(xbgr.mr_n63330768)
print v(xbgr.mr_n63331200)
print v(xbgr.mr_n63331520)
print v(xbgr.mr_n63331632)
print v(xbgr.mr_n63331952)
print v(xbgr.mr_n63332064)
print v(xbgr.mr_n63332384)
print v(xbgr.mr_n63332496)
print v(xbgr.mr_n63332816)
print v(xbgr.mr_n63332928)
print v(xbgr.mr_n63333248)
print v(xbgr.mr_n63333360)
print v(xbgr.mr_n63333680)
print v(xbgr.mr_n63333792)
print v(xbgr.mr_n63334112)
print v(xbgr.mr_n63334224)
print v(xbgr.mr_n63334544)
print v(xbgr.mr_n63334656)
print v(xbgr.mr_n63335088)
print v(xbgr.mr_n63335520)
print v(xbgr.mr_n63335952)
print v(xbgr.mr_n63336384)
print v(xbgr.mr_n63336816)
print v(xbgr.mr_n63337248)
print v(xbgr.mr_n63337680)
print v(xbgr.mr_n63338112)
print v(xbgr.mr_n63338544)
print v(xbgr.mr_n63338864)
print v(xbgr.mr_n63338976)
print v(xbgr.mr_n63339296)
print v(xbgr.mr_n63339408)
print v(xbgr.mr_n63339728)
print v(xbgr.mr_n63339840)
print v(xbgr.mr_n63340160)
print v(xbgr.mr_n63340272)
print v(xbgr.mr_n63340704)
print v(xbgr.mr_n63341136)
print v(xbgr.mr_n63341568)
print v(xbgr.mr_n63342000)
print v(xbgr.mr_n63342432)
print v(xbgr.mr_n63342864)
print v(xbgr.mr_n63343296)
print v(xbgr.mr_n63343728)
print v(xbgr.mr_n63344160)
print v(xbgr.mr_n63344592)
print v(xbgr.mr_n63345024)
print v(xbgr.mr_n63345456)
print v(xbgr.mr_n63345888)
print v(xbgr.mr_n63346320)
print v(xbgr.mr_n63346752)
print v(xbgr.mr_n63347184)
print v(xbgr.mr_n63347616)
print v(xbgr.mr_n63348048)
print v(xbgr.mr_n63348480)
print v(xbgr.mr_n63348912)
print v(xbgr.mr_n63349344)
print v(xbgr.mr_n63349776)
print v(xbgr.mr_n63350208)
print v(xbgr.mr_n63350640)
print v(xbgr.mr_n63351072)
print v(xbgr.mr_n63351504)
print v(xbgr.mr_n63351936)
print v(xbgr.mr_n63352368)
print v(xbgr.mr_n63352800)
print v(xbgr.mr_n63353120)
print v(xbgr.mr_n63353232)
print v(xbgr.mr_n63353552)
print v(xbgr.mr_n63353664)
print v(xbgr.mr_n63353984)
print v(xbgr.mr_n63354096)
print v(xbgr.mr_n63354416)
print v(xbgr.mr_n63354528)
print v(xbgr.mr_n63354848)
print v(xbgr.mr_n63354960)
print v(xbgr.mr_n63355280)
print v(xbgr.mr_n63355392)
print v(xbgr.mr_n63617872)
print v(xbgr.mr_n63618656)
print v(xbgr.mr_n63619520)
print v(xbgr.mr_n63619632)
print v(xbgr.mr_n63619952)
print v(xbgr.mr_n63620384)
print v(xbgr.mr_n63620816)
print v(xbgr.mr_n63621248)
print v(xbgr.mr_n63621360)
print v(xbgr.mr_n63621680)
print v(xbgr.mr_n63622112)
print v(xbgr.mr_n63622544)
print v(xbgr.mr_n63622976)
print v(xbgr.mr_n63623088)
print v(xbgr.mr_n63623408)
print v(xbgr.mr_n63623520)
print v(xbgr.mr_n63623840)
print v(xbgr.mr_n63623952)
print v(xbgr.mr_n63624384)
print v(xbgr.mr_n63624816)
print v(xbgr.mr_n63625248)
print v(xbgr.mr_n63625568)
print v(xbgr.mr_n63626432)
print v(xbgr.mr_n63626544)
print v(xbgr.mr_n63626864)
print v(xbgr.mr_n63626976)
print v(xbgr.mr_n63627296)
print v(xbgr.mr_n63628272)
print v(xbgr.mr_n63628704)
print v(xbgr.mr_n63629024)
print v(xbgr.mr_n63629888)
print v(xbgr.mr_n63630000)
print v(xbgr.mr_n63630320)
print v(xbgr.mr_n63630432)
print v(xbgr.mr_n63630752)
print v(xbgr.mr_n63630864)
print v(xbgr.mr_n63633360)
print v(xbgr.mr_n63633792)
print v(xbgr.mr_n63634112)
print v(xbgr.mr_n63635088)
print v(xbgr.mr_n63635408)
print v(xbgr.mr_n63636384)
print v(xbgr.mr_n63636704)
print v(xbgr.mr_n63637680)
print v(xbgr.mr_n63638000)
print v(xbgr.mr_n63638112)
print v(xbgr.mr_n63638544)
print v(xbgr.mr_n63638976)
print v(xbgr.mr_n63639296)
print v(xbgr.mr_n63640272)
print v(xbgr.mr_n63640592)
print v(xbgr.mr_n63641568)
print v(xbgr.mr_n63641888)
print v(xbgr.mr_n63642864)
print v(xbgr.mr_n63643296)
print v(xbgr.mr_n63643728)
print v(xbgr.mr_n63644160)
print v(xbgr.mr_n63644592)
print v(xbgr.mr_n63645024)
print v(xbgr.mr_n63645456)
print v(xbgr.mr_n63645888)
print v(xbgr.mr_n63646320)
print v(xbgr.mr_n63646752)
print v(xbgr.mr_n63647184)
print v(xbgr.mr_n63647616)
print v(xbgr.mr_n63648048)
print v(xbgr.mr_n63648480)
print v(xbgr.mr_n63648912)
print v(xbgr.mr_n63649344)
print v(xbgr.mr_n63649776)
print v(xbgr.mr_n63650208)
print v(xbgr.mr_n63650640)
print v(xbgr.mr_n63651072)
print v(xbgr.mr_n63651504)
print v(xbgr.mr_n63651936)
print v(xbgr.mr_n63652368)
print v(xbgr.mr_n63652800)
print v(xbgr.mr_n63653232)
print v(xbgr.mr_n63712864)
print v(xbgr.mr_n63713360)
print v(xbgr.mr_n63713808)
print v(xbgr.mr_n63714144)
print v(xbgr.mr_n63714496)
print v(xbgr.mr_n63715040)
print v(xbgr.mr_n63715840)
print v(xbgr.mr_n63716048)
print v(xbgr.mr_n63716944)
print v(xbgr.mr_n63717632)
print v(xbgr.mr_n63719584)
print v(xbgr.mr_n63722000)
print v(xbgr.mr_n63722336)
print v(xbgr.mr_n63723168)
print v(xbgr.mr_n63723504)
print v(xbgr.mr_n63727600)
print v(xbgr.mr_n63728432)
print v(xbgr.mr_n63729968)
print v(xbgr.mr_n63730128)
print v(xbgr.mr_n63730336)
print v(xbgr.mr_n63731472)
print v(xbgr.mr_n63732000)
print v(xbgr.mr_n63735488)
print v(xbgr.mr_n63736496)
print v(xbgr.mr_n63737472)
print v(xbgr.mr_n63740784)
print v(xbgr.mr_n63741792)
print v(xbgr.mr_n63744272)
print v(xbgr.mr_n63745168)
print v(xbgr.mr_n63745616)
print v(xbgr.mr_n63746064)
print v(xbgr.mr_n63746208)
print v(xbgr.mr_n63746784)
print v(xbgr.mr_n63748128)
print v(xbgr.mr_n63751648)
print v(xbgr.mr_n63752784)
print v(xbgr.mr_n63753680)
print v(xbgr.mr_n63754848)
print v(xbgr.mr_n63862960)
print v(xbgr.mr_n63867184)
print v(xbgr.mr_n63888000)
print v(xbgr.mr_n63895168)
print v(xbgr.mr_n63902976)
print v(xbgr.mr_n63969600)
print v(xbgr.mr_n63970176)
print v(xbgr.mr_n63971328)
print v(xbgr.mr_n63972464)
print v(xbgr.mr_n63972672)
print v(xbgr.mr_n63973184)
print v(xbgr.mr_n63975808)
print v(xbgr.mr_n63977152)
print v(xbgr.mr_n63977536)
print v(xbgr.mr_n63978048)
print v(xbgr.mr_n63978832)
print v(xbgr.mr_n63979008)
print v(xbgr.mr_n63979184)
print v(xbgr.mr_n63979392)
print v(xbgr.mr_n63979840)
print v(xbgr.mr_n63983488)
print v(xbgr.mr_n63983664)
print v(xbgr.mr_n63983872)
print v(xbgr.mr_n63984560)
print v(xbgr.mr_n63984704)
print v(xbgr.mr_n63985456)
print v(xbgr.mr_n63986624)
print v(xbgr.mr_n63987904)
print v(xbgr.mr_n63989696)
print v(xbgr.mr_n63990384)
print v(xbgr.mr_n63990656)
print v(xbgr.mr_n63991168)
print v(xbgr.mr_n63992000)
print v(xbgr.mr_n63992944)
print v(xbgr.mr_n63995408)
print v(xbgr.mr_n63996528)
print v(xbgr.mr_n63997760)
print v(xbgr.mr_n64000448)
print v(xbgr.mr_n64000784)
print v(xbgr.mr_n64013680)
print v(xbgr.mr_n64014592)
print v(xbgr.mr_n64014784)
print v(xbgr.mr_n64014896)
print v(xbgr.mr_n64016752)
print v(xbgr.mr_n64017680)
print v(xbgr.mr_n64022352)
print v(xbgr.mr_n64027472)
print v(xbgr.mr_n64027808)
print v(xbgr.mr_n64028560)
print v(xbgr.mr_n64029072)
print v(xbgr.mr_n64070256)
print v(xbgr.mr_n64071680)
print v(xbgr.mr_n64072208)
print v(xbgr.mr_n64072384)
print v(xbgr.mr_n64072976)
print v(xbgr.mr_n64075440)
print v(xbgr.mr_n64078656)
print v(xbgr.mr_n64079968)
print v(xbgr.mr_n64081504)
print v(xbgr.mr_n64087184)
print v(xbgr.mr_n64087888)
print v(xbgr.mr_n64093072)
print v(xbgr.mr_n64095456)
print v(xbgr.mr_n64095616)
print v(xbgr.mr_n64097120)
print v(xbgr.mr_n64097408)
print v(xbgr.mr_n64097824)
print v(xbgr.mr_n64098464)
print v(xbgr.mr_n64099408)
print v(xbgr.mr_n64102336)
print v(xbgr.mr_n64102688)
print v(xbgr.mr_n64103104)
print v(xbgr.mr_n64103392)
print v(xbgr.mr_n64103696)
print v(xbgr.mr_n64131936)
print v(xbgr.mr_n64133984)
print v(xbgr.mr_n64150544)
print v(xbgr.mr_n64151744)
print v(xbgr.mr_n64154432)
print v(xbgr.mr_n64154688)
print v(xbgr.mr_n64156736)
print v(xbgr.mr_n64157440)
print v(xbgr.mr_n64163280)
print v(xbgr.mr_n64163776)
print v(xbgr.mr_n64164704)
print v(xbgr.mr_n64227040)
print v(xbgr.mr_n64227232)
print v(xbgr.mr_n64227424)
print v(xbgr.mr_n64227616)
print v(xbgr.mr_n64227808)
print v(xbgr.mr_n64228096)
print v(xbgr.mr_n64278800)
print v(xbgr.mr_n64279072)
print v(xbgr.mr_n64317360)
print v(xbgr.mr_n64427520)
print v(xbgr.mr_n64427760)
print v(xbgr.mr_n64428112)
print v(xbgr.mr_n64428400)
print v(xbgr.mr_n64428656)
print v(xbgr.mr_n64429104)
print v(xbgr.mr_n64431120)
print v(xbgr.mr_n64488336)
print v(xbgr.mr_n64492432)
print v(xbgr.mr_n64502096)
print v(xbgr.mr_n64531408)
print v(xbgr.mr_n64532048)
print v(xbgr.mr_n64544080)
print v(xbgr.mr_n64547856)
print v(xbgr.mr_n64550080)
print v(xbgr.mr_n64550624)
print v(xbgr.mr_n64559040)
print v(xbgr.mr_n64562176)
print v(xbgr.mr_n64562352)
print v(xbgr.mr_n64562672)
print v(xbgr.mr_n64563376)
print v(xbgr.mr_n64563648)
print v(xbgr.mr_n64565520)
print v(xbgr.mr_n64566016)
print v(xbgr.mr_n64566320)
print v(xbgr.mr_n64568128)
print v(xbgr.mr_n64568720)
print v(xbgr.mr_n64568880)
print v(xbgr.mr_n64569376)
print v(xbgr.mr_n64569680)
print v(xbgr.mr_n64570384)
print v(xbgr.mr_n64571264)
print v(xbgr.mr_n64571856)
print v(xbgr.mr_n64573632)
print v(xbgr.mr_n64573968)
print v(xbgr.mr_n64576720)
print v(xbgr.mr_n64576832)
print v(xbgr.mr_n64576944)
print v(xbgr.mr_n64577056)
print v(xbgr.mr_n64577360)
print v(xbgr.mr_n64577632)
print v(xbgr.mr_n64577904)
print v(xbgr.mr_n64580016)
print v(xbgr.mr_n64580480)
print v(xbgr.mr_n64580944)
print v(xbgr.mr_n64581408)
print v(xbgr.mr_n64581872)
print v(xbgr.mr_n64582336)
print v(xbgr.mr_n64582800)
print v(xbgr.mr_n64583264)
print v(xbgr.mr_n64583728)
print v(xbgr.mr_n64584192)
print v(xbgr.mr_n64584544)
print v(xbgr.mr_n64584656)
print v(xbgr.mr_n64588000)
print v(xbgr.mr_n64589312)
print v(xbgr.mr_n64589488)
print v(xbgr.mr_n64591248)
print v(xbgr.mr_n64592464)
print v(xbgr.mr_n64593680)
print v(xbgr.mr_n64596608)
print v(xbgr.mr_n64597152)
print v(xbgr.mr_n64598800)
print v(xbgr.mr_n64600192)
print v(xbgr.mr_n64600432)
print v(xbgr.mr_n64600800)
print v(xbgr.mr_n64602192)
print v(xbgr.mr_n64604512)
print v(xbgr.mr_n64605728)
print v(xbgr.mr_n64606432)
print v(xbgr.mr_n64606960)
print v(xbgr.mr_n64608544)
print v(xbgr.mr_n64608944)
print v(xbgr.mr_n64612064)
print v(xbgr.mr_n64613936)
print v(xbgr.mr_n64615392)
print v(xbgr.mr_n64615584)
print v(xbgr.mr_n64615792)
print v(xbgr.mr_n64616384)
print v(xbgr.mr_n64619104)
print v(xbgr.mr_n64619808)
print v(xbgr.mr_n64620512)
print v(xbgr.mr_n64620896)
print v(xbgr.mr_n64621920)
print v(xbgr.mr_n64623536)
print v(xbgr.mr_n64625008)
print v(xbgr.mr_n64628464)
print v(xbgr.mr_n64628912)
print v(xbgr.mr_n64629664)
print v(xbgr.mr_n64629872)
print v(xbgr.mr_n64631280)
print v(xbgr.mr_n64632688)
print v(xbgr.mr_n64634096)
print v(xbgr.mr_n64634592)
print v(xbgr.mr_n64635744)
print v(xbgr.mr_n64638320)
print v(xbgr.mr_n64639552)
print v(xbgr.mr_n64640320)
print v(xbgr.mr_n64640432)
print v(xbgr.mr_n64643744)
print v(xbgr.mr_n64643952)
print v(xbgr.mr_n64647472)
print v(xbgr.mr_n64650016)
print v(xbgr.mr_n64653408)
print v(xbgr.mr_n64653808)
print v(xbgr.mr_n64657968)
print v(xbgr.mr_n64660320)
print v(xbgr.mr_n64660848)
print v(xbgr.mr_n64661568)
print v(xbgr.mr_n64664928)
print v(xbgr.mr_n64666800)
print v(xbgr.mr_n64667264)
print v(xbgr.mr_n64667728)
print v(xbgr.mr_n64668192)
print v(xbgr.mr_n64668656)
print v(xbgr.mr_n64669120)
print v(xbgr.mr_n64669584)
print v(xbgr.mr_n64670048)
print v(xbgr.mr_n64670512)
print v(xbgr.mr_n64670976)
print v(xbgr.mr_n64671440)
print v(xbgr.mr_n64673520)
print v(xbgr.mr_n64674320)
print v(xbgr.mr_n64677376)
print v(xbgr.mr_n64679840)
print v(xbgr.mr_n64680816)
print v(xbgr.mr_n64682400)
print v(xbgr.mr_n64682576)
print v(xbgr.mr_n64683248)
print v(xbgr.mr_n64685920)
print v(xbgr.mr_n64686096)
print v(xbgr.mr_n64687440)
print v(xbgr.mr_n64694000)
print v(xbgr.mr_n64695216)
print v(xbgr.mr_n64696128)
print v(xbgr.mr_n64696928)
print v(xbgr.mr_n64697040)
print v(xbgr.mr_n64698016)
print v(xbgr.mr_n64698192)
print v(xbgr.mr_n64700992)
print v(xbgr.mr_n64703712)
print v(xbgr.mr_n64709024)
print v(xbgr.mr_n64710032)
print v(xbgr.mr_n64715504)
print v(xbgr.mr_n64715696)
print v(xbgr.mr_n64717808)
print v(xbgr.mr_n64718272)
print v(xbgr.mr_n64718736)
print v(xbgr.mr_n64719200)
print v(xbgr.mr_n64719664)
print v(xbgr.mr_n64720128)
print v(xbgr.mr_n64720592)
print v(xbgr.mr_n64721056)
print v(xbgr.mr_n64721520)
print v(xbgr.mr_n64721984)
print v(xbgr.mr_n64722448)
print v(xbgr.mr_n64722912)
print v(xbgr.mr_n64723376)
print v(xbgr.mr_n64723840)
print v(xbgr.mr_n64724304)
print v(xbgr.mr_n64724768)
print v(xbgr.mr_n64725232)
print v(xbgr.mr_n64725696)
print v(xbgr.mr_n64726160)
print v(xbgr.mr_n64726624)
print v(xbgr.mr_n64727088)
print v(xbgr.mr_n64727552)
print v(xbgr.mr_n64728016)
print v(xbgr.mr_n64728480)
print v(xbgr.mr_n64728944)
print v(xbgr.mr_n64729408)
print v(xbgr.mr_n64729872)
print v(xbgr.mr_n64730336)
print v(xbgr.mr_n64730800)
print v(xbgr.mr_n64731264)
print v(xbgr.mr_n64731728)
print v(xbgr.mr_n64732192)
print v(xbgr.mr_n64732656)
print v(xbgr.mr_n64733120)
print v(xbgr.mr_n64733568)
print v(xbgr.mr_n64734032)
print v(xbgr.mr_n64734496)
print v(xbgr.mr_n64734960)
print v(xbgr.mr_n64735360)
print v(xbgr.mr_n64735824)
print v(xbgr.mr_n64736288)
print v(xbgr.mr_n64736752)
print v(xbgr.mr_n64737216)
print v(xbgr.mr_n64737680)
print v(xbgr.mr_n64738144)
print v(xbgr.mr_n64738608)
print v(xbgr.mr_n64739072)
print v(xbgr.mr_n64739536)
print v(xbgr.mr_n64740000)
print v(xbgr.mr_n64740464)
print v(xbgr.mr_n64740928)
print v(xbgr.mr_n64741392)
print v(xbgr.mr_n64741856)
print v(xbgr.mr_n64742320)
print v(xbgr.mr_n64742784)
print v(xbgr.mr_n64743248)
print v(xbgr.mr_n64743712)
print v(xbgr.mr_n64744176)
print v(xbgr.mr_n64744640)
print v(xbgr.mr_n64745104)
print v(xbgr.mr_n64745568)
print v(xbgr.mr_n64746032)
print v(xbgr.mr_n64746496)
print v(xbgr.mr_n64746960)
print v(xbgr.mr_n64747312)
print v(xbgr.mr_n64747424)
print v(xbgr.mr_n64747888)
print v(xbgr.mr_n64748352)
print v(xbgr.mr_n64748816)
print v(xbgr.mr_n64749280)
print v(xbgr.mr_n64749744)
print v(xbgr.mr_n64750208)
print v(xbgr.mr_n64750672)
print v(xbgr.mr_n64751136)
print v(xbgr.mr_n64751600)
print v(xbgr.mr_n64752064)
print v(xbgr.mr_n64752528)
print v(xbgr.mr_n64752992)
print v(xbgr.mr_n64753456)
print v(xbgr.mr_n64753920)
print v(xbgr.mr_n64754384)
print v(xbgr.mr_n64754848)
print v(xbgr.mr_n64755312)
print v(xbgr.mr_n64755776)
print v(xbgr.mr_n64756240)
print v(xbgr.mr_n64756704)
print v(xbgr.mr_n64757168)
print v(xbgr.mr_n64757632)
print v(xbgr.mr_n64758096)
print v(xbgr.mr_n64758560)
print v(xbgr.mr_n64759024)
print v(xbgr.mr_n64759488)
print v(xbgr.mr_n64759952)
print v(xbgr.mr_n64760416)
print v(xbgr.mr_n64760880)
print v(xbgr.mr_n64761344)
print v(xbgr.mr_n64761808)
print v(xbgr.mr_n64762272)
print v(xbgr.mr_n64762736)
print v(xbgr.mr_n64763200)
print v(xbgr.mr_n64763664)
print v(xbgr.mr_n64764128)
print v(xbgr.mr_n64764592)
print v(xbgr.mr_n64765056)
print v(xbgr.mr_n64765408)
print v(xbgr.mr_n64765520)
print v(xbgr.mr_n64765984)
print v(xbgr.mr_n64766448)
print v(xbgr.mr_n64766912)
print v(xbgr.mr_n64767376)
print v(xbgr.mr_n64767840)
print v(xbgr.mr_n64768304)
print v(xbgr.mr_n64768768)
print v(xbgr.mr_n64769232)
print v(xbgr.mr_n64769696)
print v(xbgr.mr_n64770160)
print v(xbgr.mr_n64770624)
print v(xbgr.mr_n64771088)
print v(xbgr.mr_n64771552)
print v(xbgr.mr_n64772016)
print v(xbgr.mr_n64772480)
print v(xbgr.mr_n64772944)
print v(xbgr.mr_n64773056)
print v(xbgr.mr_n64773600)
print v(xbgr.mr_n64773712)
print v(xbgr.mr_n64774336)
print v(xbgr.mr_n64774560)
print v(xbgr.mr_n64775072)
print v(xbgr.mr_n64775296)
print v(xbgr.mr_n64775808)
print v(xbgr.mr_n64775920)
print v(xbgr.mr_n64776032)
print v(xbgr.mr_n64776544)
print v(xbgr.mr_n64776656)
print v(xbgr.mr_n64776768)
print v(xbgr.mr_n64777280)
print v(xbgr.mr_n64777392)
print v(xbgr.mr_n64777504)
print v(xbgr.mr_n64778016)
print v(xbgr.mr_n64778288)
print v(xbgr.mr_n64778560)
print v(xbgr.mr_n64778832)
print v(xbgr.mr_n64778944)
print v(xbgr.mr_n64779056)
print v(xbgr.mr_n64779568)
print v(xbgr.mr_n64779840)
print v(xbgr.mr_n64780112)
print v(xbgr.mr_n64780384)
print v(xbgr.mr_n64780656)
print v(xbgr.mr_n64781200)
print v(xbgr.mr_n64781472)
print v(xbgr.mr_n64781744)
print v(xbgr.mr_n64782016)
print v(xbgr.mr_n64782288)
print v(xbgr.mr_n64782560)
print v(xbgr.mr_n64782832)
print v(xbgr.mr_n64783104)
print v(xbgr.mr_n64783376)
print v(xbgr.mr_n64783648)
print v(xbgr.mr_n64783920)
print v(xbgr.mr_n64784192)
print v(xbgr.mr_n64784464)
print v(xbgr.mr_n64784736)
print v(xbgr.mr_n64785008)
print v(xbgr.mr_n64785280)
print v(xbgr.mr_n64785552)
print v(xbgr.mr_n64785824)
print v(xbgr.mr_n64786096)
print v(xbgr.mr_n64786432)
print v(xbgr.mr_n64786896)
print v(xbgr.mr_n64787360)
print v(xbgr.mr_n64787824)
print v(xbgr.mr_n64788288)
print v(xbgr.mr_n64788752)
print v(xbgr.mr_n64789216)
print v(xbgr.mr_n64789680)
print v(xbgr.mr_n64790144)
print v(xbgr.mr_n64790608)
print v(xbgr.mr_n64791072)
print v(xbgr.mr_n64791536)
print v(xbgr.mr_n64793216)
print v(xbgr.mr_n64796288)
print v(xbgr.mr_n64799056)
print v(xbgr.mr_n64800848)
print v(xbgr.mr_n64804112)
print v(xbgr.mr_n64807056)
print v(xbgr.mr_n64808720)
print v(xbgr.mr_n64809184)
print v(xbgr.mr_n64809648)
print v(xbgr.mr_n64810208)
print v(xbgr.mr_n64810800)
print v(xbgr.mr_n64811392)
print v(xbgr.mr_n64811984)
print v(xbgr.mr_n64812576)
print v(xbgr.mr_n64813168)
print v(xbgr.mr_n64813760)
print v(xbgr.mr_n64814352)
print v(xbgr.mr_n64814944)
print v(xbgr.mr_n64815536)
print v(xbgr.mr_n64816128)
print v(xbgr.mr_n64816720)
print v(xbgr.mr_n64817376)
print v(xbgr.mr_n64817904)
print v(xbgr.mr_n64818496)
print v(xbgr.mr_n64819088)
print v(xbgr.mr_n64819616)
print v(xbgr.mr_n64820272)
print v(xbgr.mr_n64820864)
print v(xbgr.mr_n64821456)
print v(xbgr.mr_n64822640)
print v(xbgr.mr_n64823168)
print v(xbgr.mr_n64823824)
print v(xbgr.mr_n64824416)
print v(xbgr.mr_n64825008)
print v(xbgr.mr_n64825600)
print v(xbgr.mr_n64826192)
print v(xbgr.mr_n64826784)
print v(xbgr.mr_n64830096)
print v(xbgr.mr_n64832592)
print v(xbgr.mr_n64840096)
print v(xbgr.mr_n64841712)
print v(xbgr.mr_n64842384)
print v(xbgr.mr_n64842640)
print v(xbgr.mr_n64852176)
print v(xbgr.mr_n64860672)
print v(xbgr.mr_n64861984)
print v(xbgr.mr_n64868624)
print v(xbgr.mr_n64870096)
print v(xbgr.mr_n64871808)
print v(xbgr.mr_n64872416)
print v(xbgr.mr_n64872528)
print v(xbgr.mr_n64873136)
print v(xbgr.mr_n64873248)
print v(xbgr.mr_n64873856)
print v(xbgr.mr_n64873968)
print v(xbgr.mr_n64874608)
print v(xbgr.mr_n64875808)
print v(xbgr.mr_n64875920)
print v(xbgr.mr_n64876720)
print v(xbgr.mr_n64877632)
print v(xbgr.mr_n64880800)
print v(xbgr.mr_n64881104)
print v(xbgr.mr_n64882624)
print v(xbgr.mr_n64882800)
print v(xbgr.mr_n64883536)
print v(xbgr.mr_n64884144)
print v(xbgr.mr_n64884448)
print v(xbgr.mr_n64886208)
print v(xbgr.mr_n64886608)
print v(xbgr.mr_n64888896)
print v(xbgr.mr_n64889856)
print v(xbgr.mr_n64890464)
print v(xbgr.mr_n64892288)
print v(xbgr.mr_n64894416)
print v(xbgr.mr_n64895696)
print v(xbgr.mr_n64897088)
print v(xbgr.mr_n64897520)
print v(xbgr.mr_n64900256)
print v(xbgr.mr_n64900496)
print v(xbgr.mr_n64903296)
print v(xbgr.mr_n64906640)
print v(xbgr.mr_n64908096)
print v(xbgr.mr_n64908512)
print v(xbgr.mr_n64910592)
print v(xbgr.mr_n64911504)
print v(xbgr.mr_n64911808)
print v(xbgr.mr_n64914496)
print v(xbgr.mr_n64916256)
print v(xbgr.mr_n64918528)
print v(xbgr.mr_n64919536)
print v(xbgr.mr_n64922560)
print v(xbgr.mr_n64930144)
print v(xbgr.mr_n64930320)
print v(xbgr.mr_n64930496)
print v(xbgr.mr_n64931440)
print v(xbgr.mr_n64932400)
print v(xbgr.mr_n64932832)
print v(xbgr.mr_n64933264)
print v(xbgr.mr_n64933776)
print v(xbgr.mr_n64934368)
print v(xbgr.mr_n64934960)
print v(xbgr.mr_n64935552)
print v(xbgr.mr_n64935888)
print v(xbgr.mr_n64936144)
print v(xbgr.mr_n64936672)
print v(xbgr.mr_n64937328)
print v(xbgr.mr_n64937920)
print v(xbgr.mr_n64939104)
print v(xbgr.mr_n64939696)
print v(xbgr.mr_n64940288)
print v(xbgr.mr_n64940880)
print v(xbgr.mr_n64941408)
print v(xbgr.mr_n64942064)
print v(xbgr.mr_n64942656)
print v(xbgr.mr_n64943248)
print v(xbgr.mr_n64943840)
print v(xbgr.mr_n64944432)
print v(xbgr.mr_n64945024)
print v(xbgr.mr_n64945616)
print v(xbgr.mr_n64946208)
print v(xbgr.mr_n64946800)
print v(xbgr.mr_n64947392)
print v(xbgr.mr_n64947984)
print v(xbgr.mr_n64948576)
print v(xbgr.mr_n64949168)
print v(xbgr.mr_n64949760)
print v(xbgr.mr_n64950272)
print v(xbgr.mr_n64950944)
print v(xbgr.mr_n64951536)
print v(xbgr.mr_n64951952)
print v(xbgr.mr_n64952128)
print v(xbgr.mr_n64952720)
print v(xbgr.mr_n64953248)
print v(xbgr.mr_n64953648)
print v(xbgr.mr_n64953904)
print v(xbgr.mr_n64954496)
print v(xbgr.mr_n64955088)
print v(xbgr.mr_n64955616)
print v(xbgr.mr_n64956272)
print v(xbgr.mr_n64956864)
print v(xbgr.mr_n64957456)
print v(xbgr.mr_n64958048)
print v(xbgr.mr_n64958640)
print v(xbgr.mr_n64959232)
print v(xbgr.mr_n64959824)
print v(xbgr.mr_n64960416)
print v(xbgr.mr_n64961008)
print v(xbgr.mr_n64961536)
print v(xbgr.mr_n64962192)
print v(xbgr.mr_n64962528)
print v(xbgr.mr_n64963280)
print v(xbgr.mr_n64963984)
print v(xbgr.mr_n64965152)
print v(xbgr.mr_n64966064)
print v(xbgr.mr_n64966656)
print v(xbgr.mr_n64967248)
print v(xbgr.mr_n64967840)
print v(xbgr.mr_n64968432)
print v(xbgr.mr_n64969024)
print v(xbgr.mr_n64969616)
print v(xbgr.mr_n64970176)
print v(xbgr.mr_n64970768)
print v(xbgr.mr_n64971360)
print v(xbgr.mr_n64971952)
print v(xbgr.mr_n64973008)
print v(xbgr.mr_n64973600)
print v(xbgr.mr_n64974192)
print v(xbgr.mr_n64974784)
print v(xbgr.mr_n64975120)
print v(xbgr.mr_n64975376)
print v(xbgr.mr_n64975968)
print v(xbgr.mr_n64976560)
print v(xbgr.mr_n64977152)
print v(xbgr.mr_n64977744)
print v(xbgr.mr_n64978336)
print v(xbgr.mr_n64978928)
print v(xbgr.mr_n64979520)
print v(xbgr.mr_n64980112)
print v(xbgr.mr_n64980704)
print v(xbgr.mr_n64981296)
print v(xbgr.mr_n64981888)
print v(xbgr.mr_n64982480)
print v(xbgr.mr_n64983072)
print v(xbgr.mr_n64983664)
print v(xbgr.mr_n64984256)
print v(xbgr.mr_n64984848)
print v(xbgr.mr_n64985440)
print v(xbgr.mr_n64986032)
print v(xbgr.mr_n64986624)
print v(xbgr.mr_n64987216)
print v(xbgr.mr_n64987808)
print v(xbgr.mr_n64988400)
print v(xbgr.mr_n64988992)
print v(xbgr.mr_n64989584)
print v(xbgr.mr_n64990176)
print v(xbgr.mr_n64990768)
print v(xbgr.mr_n64991360)
print v(xbgr.mr_n64991952)
print v(xbgr.mr_n64992544)
print v(xbgr.mr_n64993136)
print v(xbgr.mr_n64993728)
print v(xbgr.mr_n64994320)
print v(xbgr.mr_n64995504)
print v(xbgr.mr_n64996096)
print v(xbgr.mr_n64996688)
print v(xbgr.mr_n64997280)
print v(xbgr.mr_n64997872)
print v(xbgr.mr_n64998464)
print v(xbgr.mr_n64999056)
print v(xbgr.mr_n64999648)
print v(xbgr.mr_n65000240)
print v(xbgr.mr_n65000832)
print v(xbgr.mr_n65001424)
print v(xbgr.mr_n65002016)
print v(xbgr.mr_n65002608)
print v(xbgr.mr_n65003200)
print v(xbgr.mr_n65003792)
print v(xbgr.mr_n65004384)
print v(xbgr.mr_n65004976)
print v(xbgr.mr_n65005568)
print v(xbgr.mr_n65006160)
print v(xbgr.mr_n65006752)
print v(xbgr.mr_n65007344)
print v(xbgr.mr_n65007936)
print v(xbgr.mr_n65008528)
print v(xbgr.mr_n65009120)
print v(xbgr.mr_n65009712)
print v(xbgr.mr_n65010544)
print v(xbgr.mr_n65010784)
print v(xbgr.mr_n65011024)
print v(xbgr.mr_n65011264)
print v(xbgr.mr_n65011504)
print v(xbgr.mr_n65012064)
print v(xbgr.mr_n65012464)
print v(xbgr.mr_n65012864)
print v(xbgr.mr_n65013264)
print v(xbgr.mr_n65013664)
print v(xbgr.mr_n65019376)
print v(xbgr.mr_n65024176)
print v(xbgr.mr_n65025536)
print v(xbgr.mr_n65032384)
print v(xbgr.mr_n65039520)
print v(xbgr.mr_n65040672)
print v(xbgr.mr_n65041184)
print v(xbgr.mr_n65043632)
print v(xbgr.mr_n65045536)
print v(xbgr.mr_n65046128)
print v(xbgr.mr_n65046720)
print v(xbgr.mr_n65047312)
print v(xbgr.mr_n65047904)
print v(xbgr.mr_n65048496)
print v(xbgr.mr_n65049088)
print v(xbgr.mr_n65049680)
print v(xbgr.mr_n65050272)
print v(xbgr.mr_n65050864)
print v(xbgr.mr_n65051456)
print v(xbgr.mr_n65053328)
print v(xbgr.mr_n65054032)
print v(xbgr.mr_n65057488)
print v(xbgr.mr_n65061152)
print v(xbgr.mr_n65062288)
print v(xbgr.mr_n65063584)
print v(xbgr.mr_n65069968)
print v(xbgr.mr_n65085488)
print v(xbgr.mr_n65085744)
print v(xbgr.mr_n65086688)
print v(xbgr.mr_n65088032)
print v(xbgr.mr_n65088992)
print v(xbgr.mr_n65090032)
print v(xbgr.mr_n65090624)
print v(xbgr.mr_n65091216)
print v(xbgr.mr_n65091808)
print v(xbgr.mr_n65092400)
print v(xbgr.mr_n65092736)
print v(xbgr.mr_n65092992)
print v(xbgr.mr_n65094000)
print v(xbgr.mr_n65094768)
print v(xbgr.mr_n65095360)
print v(xbgr.mr_n65095952)
print v(xbgr.mr_n65096544)
print v(xbgr.mr_n65096880)
print v(xbgr.mr_n65097136)
print v(xbgr.mr_n65097792)
print v(xbgr.mr_n65098256)
print v(xbgr.mr_n65099440)
print v(xbgr.mr_n65100032)
print v(xbgr.mr_n65100624)
print v(xbgr.mr_n65101216)
print v(xbgr.mr_n65101808)
print v(xbgr.mr_n65102400)
print v(xbgr.mr_n65102992)
print v(xbgr.mr_n65104112)
print v(xbgr.mr_n65104768)
print v(xbgr.mr_n65105296)
print v(xbgr.mr_n65105952)
print v(xbgr.mr_n65106544)
print v(xbgr.mr_n65107136)
print v(xbgr.mr_n65107728)
print v(xbgr.mr_n65108320)
print v(xbgr.mr_n65108912)
print v(xbgr.mr_n65109504)
print v(xbgr.mr_n65110032)
print v(xbgr.mr_n65110688)
print v(xbgr.mr_n65111216)
print v(xbgr.mr_n65111872)
print v(xbgr.mr_n65112464)
print v(xbgr.mr_n65113056)
print v(xbgr.mr_n65113648)
print v(xbgr.mr_n65114240)
print v(xbgr.mr_n65114832)
print v(xbgr.mr_n65115248)
print v(xbgr.mr_n65115424)
print v(xbgr.mr_n65115952)
print v(xbgr.mr_n65116608)
print v(xbgr.mr_n65117200)
print v(xbgr.mr_n65117792)
print v(xbgr.mr_n65118384)
print v(xbgr.mr_n65118976)
print v(xbgr.mr_n65119568)
print v(xbgr.mr_n65120160)
print v(xbgr.mr_n65120752)
print v(xbgr.mr_n65121344)
print v(xbgr.mr_n65121872)
print v(xbgr.mr_n65122528)
print v(xbgr.mr_n65123056)
print v(xbgr.mr_n65123712)
print v(xbgr.mr_n65124896)
print v(xbgr.mr_n65125488)
print v(xbgr.mr_n65126080)
print v(xbgr.mr_n65126672)
print v(xbgr.mr_n65127088)
print v(xbgr.mr_n65127264)
print v(xbgr.mr_n65127792)
print v(xbgr.mr_n65128448)
print v(xbgr.mr_n65128976)
print v(xbgr.mr_n65129632)
print v(xbgr.mr_n65130224)
print v(xbgr.mr_n65130816)
print v(xbgr.mr_n65131408)
print v(xbgr.mr_n65132000)
print v(xbgr.mr_n65132592)
print v(xbgr.mr_n65133008)
print v(xbgr.mr_n65133184)
print v(xbgr.mr_n65133712)
print v(xbgr.mr_n65134368)
print v(xbgr.mr_n65134960)
print v(xbgr.mr_n65135552)
print v(xbgr.mr_n65136144)
print v(xbgr.mr_n65136736)
print v(xbgr.mr_n65137328)
print v(xbgr.mr_n65137920)
print v(xbgr.mr_n65138512)
print v(xbgr.mr_n65139104)
print v(xbgr.mr_n65139632)
print v(xbgr.mr_n65140288)
print v(xbgr.mr_n65140816)
print v(xbgr.mr_n65141472)
print v(xbgr.mr_n65142064)
print v(xbgr.mr_n65142656)
print v(xbgr.mr_n65143248)
print v(xbgr.mr_n65143840)
print v(xbgr.mr_n65144432)
print v(xbgr.mr_n65145024)
print v(xbgr.mr_n65145552)
print v(xbgr.mr_n65145952)
print v(xbgr.mr_n65146208)
print v(xbgr.mr_n65146736)
print v(xbgr.mr_n65147392)
print v(xbgr.mr_n65147984)
print v(xbgr.mr_n65148576)
print v(xbgr.mr_n65149168)
print v(xbgr.mr_n65149760)
print v(xbgr.mr_n65150352)
print v(xbgr.mr_n65150944)
print v(xbgr.mr_n65151472)
print v(xbgr.mr_n65152128)
print v(xbgr.mr_n65152656)
print v(xbgr.mr_n65153312)
print v(xbgr.mr_n65153904)
print v(xbgr.mr_n65154496)
print v(xbgr.mr_n65155088)
print v(xbgr.mr_n65155680)
print v(xbgr.mr_n65156864)
print v(xbgr.mr_n65157392)
print v(xbgr.mr_n65158048)
print v(xbgr.mr_n65158576)
print v(xbgr.mr_n65159168)
print v(xbgr.mr_n65159632)
print v(xbgr.mr_n65160096)
print v(xbgr.mr_n65160208)
print v(xbgr.mr_n65160560)
print v(xbgr.mr_n65161024)
print v(xbgr.mr_n65161136)
print v(xbgr.mr_n65161488)
print v(xbgr.mr_n65161600)
print v(xbgr.mr_n65162992)
print v(xbgr.mr_n65163248)
print v(xbgr.mr_n65163584)
print v(xbgr.mr_n65164224)
print v(xbgr.mr_n65164624)
print v(xbgr.mr_n65165024)
print v(xbgr.mr_n65165424)
print v(xbgr.mr_n65165824)
print v(xbgr.mr_n65166224)
print v(xbgr.mr_n65166624)
print v(xbgr.mr_n65167024)
print v(xbgr.mr_n65167424)
print v(xbgr.mr_n65167824)
print v(xbgr.mr_n65168224)
print v(xbgr.mr_n65168624)
print v(xbgr.mr_n65169024)
print v(xbgr.mr_n65169424)
print v(xbgr.mr_n65169824)
print v(xbgr.mr_n65170224)
print v(xbgr.mr_n65170624)
print v(xbgr.mr_n65171024)
print v(xbgr.mr_n65171424)
print v(xbgr.mr_n65171824)
print v(xbgr.mr_n65172224)
print v(xbgr.mr_n65172624)
print v(xbgr.mr_n65173024)
print v(xbgr.mr_n65173424)
print v(xbgr.mr_n65173824)
print v(xbgr.mr_n65174224)
print v(xbgr.mr_n65174624)
print v(xbgr.mr_n65175024)
print v(xbgr.mr_n65175424)
print v(xbgr.mr_n65175824)
print v(xbgr.mr_n65176224)
print v(xbgr.mr_n65176624)
print v(xbgr.mr_n65177024)
print v(xbgr.mr_n65177424)
print v(xbgr.mr_n65177824)
print v(xbgr.mr_n65178224)
print v(xbgr.mr_n65178688)
print v(xbgr.mr_n65179280)
print v(xbgr.mr_n65179872)
print v(xbgr.mr_n65180464)
print v(xbgr.mr_n65181056)
print v(xbgr.mr_n65181648)
print v(xbgr.mr_n65182240)
print v(xbgr.mr_n65182832)
print v(xbgr.mr_n65183424)
print v(xbgr.mr_n65183840)
print v(xbgr.mr_n65184016)
print v(xbgr.mr_n65184608)
print v(xbgr.mr_n65185200)
print v(xbgr.mr_n65186288)
print v(xbgr.mr_n65186432)
print v(xbgr.mr_n65196208)
print v(xbgr.mr_n65198400)
print v(xbgr.mr_n65199984)
print v(xbgr.mr_n65201664)
print v(xbgr.mr_n65202256)
print v(xbgr.mr_n65202848)
print v(xbgr.mr_n65203440)
print v(xbgr.mr_n65204032)
print v(xbgr.mr_n65204624)
print v(xbgr.mr_n65205216)
print v(xbgr.mr_n65205808)
print v(xbgr.mr_n65206400)
print v(xbgr.mr_n65206992)
print v(xbgr.mr_n65207504)
print v(xbgr.mr_n65208096)
print v(xbgr.mr_n65208688)
print v(xbgr.mr_n65209360)
print v(xbgr.mr_n65209952)
print v(xbgr.mr_n65210544)
print v(xbgr.mr_n65211072)
print v(xbgr.mr_n65211728)
print v(xbgr.mr_n65212320)
print v(xbgr.mr_n65212912)
print v(xbgr.mr_n65213504)
print v(xbgr.mr_n65214096)
print v(xbgr.mr_n65214688)
print v(xbgr.mr_n65215280)
print v(xbgr.mr_n65215872)
print v(xbgr.mr_n65216464)
print v(xbgr.mr_n65217056)
print v(xbgr.mr_n65217648)
print v(xbgr.mr_n65218240)
print v(xbgr.mr_n65218832)
print v(xbgr.mr_n65219424)
print v(xbgr.mr_n65220016)
print v(xbgr.mr_n65220672)
print v(xbgr.mr_n65221120)
print v(xbgr.mr_n65221792)
print v(xbgr.mr_n65222304)
print v(xbgr.mr_n65222976)
print v(xbgr.mr_n65223568)
print v(xbgr.mr_n65224160)
print v(xbgr.mr_n65224752)
print v(xbgr.mr_n65225344)
print v(xbgr.mr_n65225936)
print v(xbgr.mr_n65226528)
print v(xbgr.mr_n65227120)
print v(xbgr.mr_n65227648)
print v(xbgr.mr_n65228304)
print v(xbgr.mr_n65228896)
print v(xbgr.mr_n65231104)
print v(xbgr.mr_n65238064)
print v(xbgr.mr_n65240400)
print v(xbgr.mr_n65241296)
print v(xbgr.mr_n65242864)
print v(xbgr.mr_n65243120)
print v(xbgr.mr_n65243232)
print v(xbgr.mr_n65243472)
print v(xbgr.mr_n65247136)
print v(xbgr.mr_n65247728)
print v(xbgr.mr_n65257344)
print v(xbgr.mr_n65262944)
print v(xbgr.mr_n65265792)
print v(xbgr.mr_n65265968)
print v(xbgr.mr_n65270288)
print v(xbgr.mr_n65271408)
print v(xbgr.mr_n65272800)
print v(xbgr.mr_n65273424)
print v(xbgr.mr_n65274368)
print v(xbgr.mr_n65274480)
print v(xbgr.mr_n65275088)
print v(xbgr.mr_n65275808)
print v(xbgr.mr_n65275920)
print v(xbgr.mr_n65276528)
print v(xbgr.mr_n65276832)
print v(xbgr.mr_n65277248)
print v(xbgr.mr_n65277360)
print v(xbgr.mr_n65277968)
print v(xbgr.mr_n65278528)
print v(xbgr.mr_n65284400)
print v(xbgr.mr_n65287664)
print v(xbgr.mr_n65288624)
print v(xbgr.mr_n65299072)
print v(xbgr.mr_n65303888)
print v(xbgr.mr_n65310704)
print v(xbgr.mr_n65311440)
print v(xbgr.mr_n65311888)
print v(xbgr.mr_n65312672)
print v(xbgr.mr_n65313232)
print v(xbgr.mr_n65313936)
print v(xbgr.mr_n65314176)
print v(xbgr.mr_n65315008)
print v(xbgr.mr_n65315888)
print v(xbgr.mr_n65317232)
print v(xbgr.mr_n65317952)
print v(xbgr.mr_n65319184)
print v(xbgr.mr_n65319472)
print v(xbgr.mr_n65319792)
print v(xbgr.mr_n65320000)
print v(xbgr.mr_n65320176)
print v(xbgr.mr_n65320288)
print v(xbgr.mr_n65321136)
print v(xbgr.mr_n65322800)
print v(xbgr.mr_n65323984)
print v(xbgr.mr_n65324576)
print v(xbgr.mr_n65325168)
print v(xbgr.mr_n65326352)
print v(xbgr.mr_n65326944)
print v(xbgr.mr_n65327536)
print v(xbgr.mr_n65328128)
print v(xbgr.mr_n65328720)
print v(xbgr.mr_n65329312)
print v(xbgr.mr_n65329904)
print v(xbgr.mr_n65331008)
print v(xbgr.mr_n65331680)
print v(xbgr.mr_n65332272)
print v(xbgr.mr_n65332864)
print v(xbgr.mr_n65333456)
print v(xbgr.mr_n65334048)
print v(xbgr.mr_n65334640)
print v(xbgr.mr_n65335232)
print v(xbgr.mr_n65335824)
print v(xbgr.mr_n65336416)
print v(xbgr.mr_n65336928)
print v(xbgr.mr_n65337600)
print v(xbgr.mr_n65338192)
print v(xbgr.mr_n65338784)
print v(xbgr.mr_n65339376)
print v(xbgr.mr_n65339968)
print v(xbgr.mr_n65340560)
print v(xbgr.mr_n65340976)
print v(xbgr.mr_n65341152)
print v(xbgr.mr_n65341744)
print v(xbgr.mr_n65342336)
print v(xbgr.mr_n65342928)
print v(xbgr.mr_n65344112)
print v(xbgr.mr_n65344704)
print v(xbgr.mr_n65345296)
print v(xbgr.mr_n65345888)
print v(xbgr.mr_n65346480)
print v(xbgr.mr_n65347072)
print v(xbgr.mr_n65347664)
print v(xbgr.mr_n65348256)
print v(xbgr.mr_n65348848)
print v(xbgr.mr_n65349440)
print v(xbgr.mr_n65350032)
print v(xbgr.mr_n65350624)
print v(xbgr.mr_n65351216)
print v(xbgr.mr_n65351728)
print v(xbgr.mr_n65352400)
print v(xbgr.mr_n65352992)
print v(xbgr.mr_n65353584)
print v(xbgr.mr_n65354176)
print v(xbgr.mr_n65354688)
print v(xbgr.mr_n65355360)
print v(xbgr.mr_n65355952)
print v(xbgr.mr_n65356544)
print v(xbgr.mr_n65357136)
print v(xbgr.mr_n65358320)
print v(xbgr.mr_n65358912)
print v(xbgr.mr_n65359424)
print v(xbgr.mr_n65360096)
print v(xbgr.mr_n65360656)
print v(xbgr.mr_n65361216)
print v(xbgr.mr_n65361808)
print v(xbgr.mr_n65362400)
print v(xbgr.mr_n65362992)
print v(xbgr.mr_n65363584)
print v(xbgr.mr_n65364176)
print v(xbgr.mr_n65364592)
print v(xbgr.mr_n65364768)
print v(xbgr.mr_n65365360)
print v(xbgr.mr_n65365952)
print v(xbgr.mr_n65366544)
print v(xbgr.mr_n65367136)
print v(xbgr.mr_n65367728)
print v(xbgr.mr_n65368368)
print v(xbgr.mr_n65368480)
print v(xbgr.mr_n65369184)
print v(xbgr.mr_n65369888)
print v(xbgr.mr_n65370352)
print v(xbgr.mr_n65375312)
print v(xbgr.mr_n65375792)
print v(xbgr.mr_n65376864)
print v(xbgr.mr_n65376976)
print v(xbgr.mr_n65377088)
print v(xbgr.mr_n65377200)
print v(xbgr.mr_n65377312)
print v(xbgr.mr_n65377424)
print v(xbgr.mr_n65377536)
print v(xbgr.mr_n65377648)
print v(xbgr.mr_n65377760)
print v(xbgr.mr_n65377952)
print v(xbgr.mr_n65378224)
print v(xbgr.mr_n65378496)
print v(xbgr.mr_n65378768)
print v(xbgr.mr_n65379040)
print v(xbgr.mr_n65379312)
print v(xbgr.mr_n65379648)
print v(xbgr.mr_n65380048)
print v(xbgr.mr_n65380448)
print v(xbgr.mr_n65380848)
print v(xbgr.mr_n65381248)
print v(xbgr.mr_n65381648)
print v(xbgr.mr_n65382048)
print v(xbgr.mr_n65382448)
print v(xbgr.mr_n65382848)
print v(xbgr.mr_n65383248)
print v(xbgr.mr_n65383648)
print v(xbgr.mr_n65384048)
print v(xbgr.mr_n65384448)
print v(xbgr.mr_n65384848)
print v(xbgr.mr_n65385168)
print v(xbgr.mr_n65385648)
print v(xbgr.mr_n65386048)
print v(xbgr.mr_n65386448)
print v(xbgr.mr_n65386848)
print v(xbgr.mr_n65387248)
print v(xbgr.mr_n65387648)
print v(xbgr.mr_n65388048)
print v(xbgr.mr_n65388448)
print v(xbgr.mr_n65388848)
print v(xbgr.mr_n65389248)
print v(xbgr.mr_n65389648)
print v(xbgr.mr_n65389968)
print v(xbgr.mr_n65390448)
print v(xbgr.mr_n65390848)
print v(xbgr.mr_n65391248)
print v(xbgr.mr_n65391584)
print v(xbgr.mr_n65391856)
print v(xbgr.mr_n65392128)
print v(xbgr.mr_n65392400)
print v(xbgr.mr_n65392672)
print v(xbgr.mr_n65392944)
print v(xbgr.mr_n65393216)
print v(xbgr.mr_n65393488)
print v(xbgr.mr_n65393760)
print v(xbgr.mr_n65394032)
print v(xbgr.mr_n65394304)
print v(xbgr.mr_n65394576)
print v(xbgr.mr_n65394848)
print v(xbgr.mr_n65395120)
print v(xbgr.mr_n65395392)
print v(xbgr.mr_n65395664)
print v(xbgr.mr_n65395936)
print v(xbgr.mr_n65396208)
print v(xbgr.mr_n65396656)
print v(xbgr.mr_n65396848)
print v(xbgr.mr_n65397040)
print v(xbgr.mr_n65397232)
print v(xbgr.mr_n65398176)
print v(xbgr.mr_n65402800)
print v(xbgr.mr_n65402912)
print v(xbgr.mr_n65403104)
print v(xbgr.mr_n65403856)
print v(xbgr.mr_n65404768)
print v(xbgr.mr_n65405520)
print v(xbgr.mr_n65407792)
print v(xbgr.mr_n65407904)
print v(xbgr.mr_n65408096)
print v(xbgr.mr_n65408848)
print v(xbgr.mr_n65409760)
print v(xbgr.mr_n65410512)
print v(xbgr.mr_n65412784)
print v(xbgr.mr_n65412896)
print v(xbgr.mr_n65413088)
print v(xbgr.mr_n65413840)
print v(xbgr.mr_n65414752)
print v(xbgr.mr_n65415504)
print v(xbgr.mr_n65417776)
print v(xbgr.mr_n65417888)
print v(xbgr.mr_n65418080)
print v(xbgr.mr_n65418832)
print v(xbgr.mr_n65419744)
print v(xbgr.mr_n65420496)
print v(xbgr.mr_n65422768)
print v(xbgr.mr_n65422880)
print v(xbgr.mr_n65423072)
print v(xbgr.mr_n65423824)
print v(xbgr.mr_n65424736)
print v(xbgr.mr_n65425488)
print v(xbgr.mr_n65427760)
print v(xbgr.mr_n65427872)
print v(xbgr.mr_n65428064)
print v(xbgr.mr_n65428816)
print v(xbgr.mr_n65432336)
print v(xbgr.mr_n65432848)
print v(xbgr.mr_n65433280)
print v(xbgr.mr_n65433456)
print v(xbgr.mr_n65433792)
print v(xbgr.mr_n65434304)
print v(xbgr.mr_n65434736)
print v(xbgr.mr_n65434912)
print v(xbgr.mr_n65435248)
print v(xbgr.mr_n65435952)
print v(xbgr.mr_n65436128)
print v(xbgr.mr_n65436304)
print v(xbgr.mr_n65436816)
print v(xbgr.mr_n65436928)
print v(xbgr.mr_n65437488)
print v(xbgr.mr_n65437664)
print v(xbgr.mr_n65438160)
print v(xbgr.mr_n65438864)
print v(xbgr.mr_n65439040)
print v(xbgr.mr_n65439216)
print v(xbgr.mr_n65439728)
print v(xbgr.mr_n65439840)
print v(xbgr.mr_n65440400)
print v(xbgr.mr_n65440576)
print v(xbgr.mr_n65440912)
print v(xbgr.mr_n65441584)
print v(xbgr.mr_n65442016)
print v(xbgr.mr_n65442192)
print v(xbgr.mr_n65442528)
print v(xbgr.mr_n65443232)
print v(xbgr.mr_n65443408)
print v(xbgr.mr_n65443584)
print v(xbgr.mr_n65444096)
print v(xbgr.mr_n65444208)
print v(xbgr.mr_n65444768)
print v(xbgr.mr_n65444944)
print v(xbgr.mr_n65445440)
print v(xbgr.mr_n65445952)
print v(xbgr.mr_n65446384)
print v(xbgr.mr_n65446560)
print v(xbgr.mr_n65446736)
print v(xbgr.mr_n65447408)
print v(xbgr.mr_n65447840)
print v(xbgr.mr_n65448016)
print v(xbgr.mr_n65448272)
print v(xbgr.mr_n65449056)
print v(xbgr.mr_n65449232)
print v(xbgr.mr_n65449408)
print v(xbgr.mr_n65449920)
print v(xbgr.mr_n65450352)
print v(xbgr.mr_n65450528)
print v(xbgr.mr_n65450864)
print v(xbgr.mr_n65451376)
print v(xbgr.mr_n65451808)
print v(xbgr.mr_n65451984)
print v(xbgr.mr_n65452320)
print v(xbgr.mr_n65452832)
print v(xbgr.mr_n65452944)
print v(xbgr.mr_n65453680)
print v(xbgr.mr_n65454176)
print v(xbgr.mr_n65454880)
print v(xbgr.mr_n65455056)
print v(xbgr.mr_n65455232)
print v(xbgr.mr_n65455744)
print v(xbgr.mr_n65455856)
print v(xbgr.mr_n65455968)
print v(xbgr.mr_n65456080)
print v(xbgr.mr_n65456192)
print v(xbgr.mr_n65456464)
print v(xbgr.mr_n65456816)
print v(xbgr.mr_n65456928)
print v(xbgr.mr_n65457200)
print v(xbgr.mr_n65457552)
print v(xbgr.mr_n65457792)
print v(xbgr.mr_n65458128)
print v(xbgr.mr_n65458480)
print v(xbgr.mr_n65458592)
print v(xbgr.mr_n65458784)
print v(xbgr.mr_n65459056)
print v(xbgr.mr_n65459328)
print v(xbgr.mr_n65459600)
print v(xbgr.mr_n65459872)
print v(xbgr.mr_n65460144)
print v(xbgr.mr_n65460768)
print v(xbgr.mr_n65460960)
print v(xbgr.mr_n65461152)
print v(xbgr.mr_n65461344)
print v(xbgr.mr_n65462096)
print v(xbgr.mr_n65480240)
print v(xbgr.mr_n65480416)
print v(xbgr.mr_n65481120)
print v(xbgr.mr_n65481296)
print v(xbgr.mr_n65481472)
print v(xbgr.mr_n65482176)
print v(xbgr.mr_n65482352)
print v(xbgr.mr_n65482528)
print v(xbgr.mr_n65483232)
print v(xbgr.mr_n65483408)
print v(xbgr.mr_n65483584)
print v(xbgr.mr_n65484288)
print v(xbgr.mr_n65484464)
print v(xbgr.mr_n65484640)
print v(xbgr.mr_n65485344)
print v(xbgr.mr_n65485520)
print v(xbgr.mr_n65485696)
print v(xbgr.mr_n65486272)
print v(xbgr.mr_n65486464)
print v(xbgr.mr_n65486736)
print v(xbgr.mr_n65487008)
print v(xbgr.mr_n65487280)
print v(xbgr.mr_n65487552)
print v(xbgr.mr_n65487824)
print v(xbgr.mr_n65488096)
print v(xbgr.mr_n65488368)
print v(xbgr.mr_n65488640)
print v(xbgr.mr_n65492176)
print v(xbgr.mr_n65492512)
print v(xbgr.mr_n65492848)
print v(xbgr.mr_n65493184)
print v(xbgr.mr_n65493840)
print v(xbgr.mr_n65494480)
print v(xbgr.mr_n65494880)
print v(xbgr.mr_n65495280)
print v(xbgr.mr_n65495680)
print v(xbgr.mr_n65496080)
print v(xbgr.mr_n65496480)
print v(xbgr.mr_n65496880)
print v(xbgr.mr_n65497344)
print v(xbgr.mr_n65497520)
print v(xbgr.mr_n65498144)
print v(xbgr.mr_n65498320)
print v(xbgr.mr_n65498944)
print v(xbgr.mr_n65499120)
print v(xbgr.mr_n65499920)
print v(xbgr.mr_n65500544)
print v(xbgr.mr_n65500720)
print v(xbgr.mr_n65501344)
print v(xbgr.mr_n65501520)
print v(xbgr.mr_n65502144)
print v(xbgr.mr_n65502320)
print v(xbgr.mr_n65502944)
print v(xbgr.mr_n65503200)
print v(xbgr.mr_n65503312)
print v(xbgr.mr_n65503424)
print v(xbgr.mr_n65504096)
print v(xbgr.mr_n65505776)
print v(xbgr.mr_n65506288)
print v(xbgr.mr_n65508000)
print v(xbgr.mr_n65508512)
print v(xbgr.mr_n65509808)
print v(xbgr.mr_n65510320)
print v(xbgr.mr_n65511536)
print v(xbgr.mr_n65512128)
print v(xbgr.mr_n65513424)
print v(xbgr.mr_n65513936)
print v(xbgr.mr_n65515232)
print v(xbgr.mr_n65515744)
print v(xbgr.mr_n65517040)
print v(xbgr.mr_n65517552)
print v(xbgr.mr_n65518848)
print v(xbgr.mr_n65519360)
print v(xbgr.mr_n65520496)
print v(xbgr.mr_n65521168)
print v(xbgr.mr_n65522384)
print v(xbgr.mr_n65524192)
print v(xbgr.mr_n65524784)
print v(xbgr.mr_n65526080)
print v(xbgr.mr_n65526592)
print v(xbgr.mr_n65526704)
print v(xbgr.mr_n65526816)
print v(xbgr.mr_n65526928)
print v(xbgr.mr_n65527200)
print v(xbgr.mr_n65527312)
print v(xbgr.mr_n65527664)
print v(xbgr.mr_n65527776)
print v(xbgr.mr_n65528048)
print v(xbgr.mr_n65528400)
print v(xbgr.mr_n65528512)
print v(xbgr.mr_n65528880)
print v(xbgr.mr_n65529376)
print v(xbgr.mr_n65529856)
print v(xbgr.mr_n65530224)
print v(xbgr.mr_n65530576)
print v(xbgr.mr_n65531200)
print v(xbgr.mr_n65531728)
print v(xbgr.mr_n65532080)
print v(xbgr.mr_n65532768)
print v(xbgr.mr_n65533152)
print v(xbgr.mr_n65533648)
print v(xbgr.mr_n65534336)
print v(xbgr.mr_n65534864)
print v(xbgr.mr_n65535216)
print v(xbgr.mr_n65535904)
print v(xbgr.mr_n65536368)
print v(xbgr.mr_n65536784)
print v(xbgr.mr_n65537472)
print v(xbgr.mr_n65537936)
print v(xbgr.mr_n65538352)
print v(xbgr.mr_n65539040)
print v(xbgr.mr_n65539568)
print v(xbgr.mr_n65539920)
print v(xbgr.mr_n65540608)
print v(xbgr.mr_n65541072)
print v(xbgr.mr_n65541488)
print v(xbgr.mr_n65542176)
print v(xbgr.mr_n65542640)
print v(xbgr.mr_n65543056)
print v(xbgr.mr_n65543744)
print v(xbgr.mr_n65544272)
print v(xbgr.mr_n65544624)
print v(xbgr.mr_n65544944)
print v(xbgr.mr_n65545312)
print v(xbgr.mr_n65545840)
print v(xbgr.mr_n65546192)
print v(xbgr.mr_n65546880)
print v(xbgr.mr_n65547408)
print v(xbgr.mr_n65547760)
print v(xbgr.mr_n65548000)
print v(xbgr.mr_n65548448)
print v(xbgr.mr_n65548976)
print v(xbgr.mr_n65549328)
print v(xbgr.mr_n65549696)
print v(xbgr.mr_n65551296)
print v(xbgr.mr_n65552256)
print v(xbgr.mr_n65552640)
print v(xbgr.mr_n65553216)
print v(xbgr.mr_n65554368)
print v(xbgr.mr_n65554752)
print v(xbgr.mr_n65555200)
print v(xbgr.mr_n65555312)
print v(xbgr.mr_n65556688)
print v(xbgr.mr_n65560144)
print v(xbgr.mr_n65562560)
print v(xbgr.mr_n65567232)
print v(xbgr.mr_n65568256)
print v(xbgr.mr_n65571456)
print v(xbgr.mr_n65572384)
print v(xbgr.mr_n65572848)
print v(xbgr.mr_n65573312)
print v(xbgr.mr_n65573776)
print v(xbgr.mr_n65574240)
print v(xbgr.mr_n65574704)
print v(xbgr.mr_n65575168)
print v(xbgr.mr_n65575632)
print v(xbgr.mr_n65576096)
print v(xbgr.mr_n65576560)
print v(xbgr.mr_n65577024)
print v(xbgr.mr_n65577488)
print v(xbgr.mr_n65577952)
print v(xbgr.mr_n65578416)
print v(xbgr.mr_n65578880)
print v(xbgr.mr_n65579344)
print v(xbgr.mr_n65580368)
print v(xbgr.mr_n65580624)
print v(xbgr.mr_n65583200)
print v(xbgr.mr_n65583744)
print v(xbgr.mr_n65584080)
print v(xbgr.mr_n65584416)
print v(xbgr.mr_n65586144)
print v(xbgr.mr_n65586736)
print v(xbgr.mr_n65586880)
print v(xbgr.mr_n65587328)
print v(xbgr.mr_n65588144)
print v(xbgr.mr_n65588592)
print v(xbgr.mr_n65589040)
print v(xbgr.mr_n65589552)
print v(xbgr.mr_n65591600)
print v(xbgr.mr_n65598256)
print v(xbgr.mr_n65598368)
print v(xbgr.mr_n65598720)
print v(xbgr.mr_n65599728)
print v(xbgr.mr_n65600912)
print v(xbgr.mr_n65601472)
print v(xbgr.mr_n65603696)
print v(xbgr.mr_n65606992)
print v(xbgr.mr_n65607184)
print v(xbgr.mr_n65608096)
print v(xbgr.mr_n65608288)
print v(xbgr.mr_n65608800)
print v(xbgr.mr_n65609472)
print v(xbgr.mr_n65609792)
print v(xbgr.mr_n65610848)
print v(xbgr.mr_n65611040)
print v(xbgr.mr_n65611616)
print v(xbgr.mr_n65631424)
print v(xbgr.mr_n65632128)
print v(xbgr.mr_n65632304)
print v(xbgr.mr_n65632864)
print v(xbgr.mr_n65633392)
print v(xbgr.mr_n65633568)
print v(xbgr.mr_n65633744)
print v(xbgr.mr_n65634528)
print v(xbgr.mr_n65634704)
print v(xbgr.mr_n65635264)
print v(xbgr.mr_n65635728)
print v(xbgr.mr_n65635904)
print v(xbgr.mr_n65636592)
print v(xbgr.mr_n65636768)
print v(xbgr.mr_n65637024)
print v(xbgr.mr_n65637664)
print v(xbgr.mr_n65638128)
print v(xbgr.mr_n65640784)
print v(xbgr.mr_n65643600)
print v(xbgr.mr_n65644064)
print v(xbgr.mr_n65644528)
print v(xbgr.mr_n65644992)
print v(xbgr.mr_n65645456)
print v(xbgr.mr_n65645920)
print v(xbgr.mr_n65646384)
print v(xbgr.mr_n65646848)
print v(xbgr.mr_n65647312)
print v(xbgr.mr_n65647776)
print v(xbgr.mr_n65648240)
print v(xbgr.mr_n65648704)
print v(xbgr.mr_n65649168)
print v(xbgr.mr_n65649632)
print v(xbgr.mr_n65650096)
print v(xbgr.mr_n65650560)
print v(xbgr.mr_n65651024)
print v(xbgr.mr_n65652608)
print v(xbgr.mr_n65654544)
print v(xbgr.mr_n65655312)
print v(xbgr.mr_n65660176)
print v(xbgr.mr_n65662928)
print v(xbgr.mr_n65667808)
print v(xbgr.mr_n65672032)
print v(xbgr.mr_n65680064)
print v(xbgr.mr_n65680256)
print v(xbgr.mr_n65683968)
print v(xbgr.mr_n65685632)
print v(xbgr.mr_n65686544)
print v(xbgr.mr_n65686736)
print v(xbgr.mr_n65686992)
print v(xbgr.mr_n65687248)
print v(xbgr.mr_n65689216)
print v(xbgr.mr_n65689776)
print v(xbgr.mr_n65690512)
print v(xbgr.mr_n65692096)
print v(xbgr.mr_n65693424)
print v(xbgr.mr_n65695632)
print v(xbgr.mr_n65698400)
print v(xbgr.mr_n65699728)
print v(xbgr.mr_n65701776)
print v(xbgr.mr_n65704544)
print v(xbgr.mr_n65705872)
print v(xbgr.mr_n65707920)
print v(xbgr.mr_n65710688)
print v(xbgr.mr_n65712016)
print v(xbgr.mr_n65714064)
print v(xbgr.mr_n65716832)
print v(xbgr.mr_n65718160)
print v(xbgr.mr_n65720176)
print v(xbgr.mr_n65722944)
print v(xbgr.mr_n65724272)
print v(xbgr.mr_n65725120)
print v(xbgr.mr_n65725728)
print v(xbgr.mr_n65726240)
print v(xbgr.mr_n65726848)
print v(xbgr.mr_n65727424)
print v(xbgr.mr_n65727904)
print v(xbgr.mr_n65731584)
print v(xbgr.mr_n65731984)
print v(xbgr.mr_n65732384)
print v(xbgr.mr_n65732784)
print v(xbgr.mr_n65733184)
print v(xbgr.mr_n65733584)
print v(xbgr.mr_n65733984)
print v(xbgr.mr_n65734384)
print v(xbgr.mr_n65734784)
print v(xbgr.mr_n65735184)
print v(xbgr.mr_n65735584)
print v(xbgr.mr_n65735984)
print v(xbgr.mr_n65736384)
print v(xbgr.mr_n65736704)
print v(xbgr.mr_n65737104)
print v(xbgr.mr_n65737504)
print v(xbgr.mr_n65737776)
print v(xbgr.mr_n65737888)
print v(xbgr.mr_n65738000)
print v(xbgr.mr_n65738112)
print v(xbgr.mr_n65738224)
print v(xbgr.mr_n65738416)
print v(xbgr.mr_n65738688)
print v(xbgr.mr_n65738960)
print v(xbgr.mr_n65739232)
print v(xbgr.mr_n65739504)
print v(xbgr.mr_n65739776)
print v(xbgr.mr_n65740048)
print v(xbgr.mr_n65740320)
print v(xbgr.mr_n65740656)
print v(xbgr.mr_n65741056)
print v(xbgr.mr_n65749984)
print v(xbgr.mr_n65753616)
print v(xbgr.mr_n65755344)
print v(xbgr.mr_n65755760)
print v(xbgr.mr_n65755888)
print v(xbgr.mr_n65756064)
print v(xbgr.mr_n65756912)
print v(xbgr.mr_n65757392)
print v(xbgr.mr_n65757888)
print v(xbgr.mr_n65758432)
print v(xbgr.mr_n65758608)
print v(xbgr.mr_n65759456)
print v(xbgr.mr_n65759936)
print v(xbgr.mr_n65760368)
print v(xbgr.mr_n65760976)
print v(xbgr.mr_n65761152)
print v(xbgr.mr_n65762000)
print v(xbgr.mr_n65762480)
print v(xbgr.mr_n65762912)
print v(xbgr.mr_n65763520)
print v(xbgr.mr_n65763696)
print v(xbgr.mr_n65764544)
print v(xbgr.mr_n65765024)
print v(xbgr.mr_n65765520)
print v(xbgr.mr_n65766064)
print v(xbgr.mr_n65766240)
print v(xbgr.mr_n65767088)
print v(xbgr.mr_n65767568)
print v(xbgr.mr_n65768064)
print v(xbgr.mr_n65768608)
print v(xbgr.mr_n65768784)
print v(xbgr.mr_n65769632)
print v(xbgr.mr_n65770112)
print v(xbgr.mr_n65770544)
print v(xbgr.mr_n65771152)
print v(xbgr.mr_n65771824)
print v(xbgr.mr_n65772112)
print v(xbgr.mr_n65772656)
print v(xbgr.mr_n65773152)
print v(xbgr.mr_n65774064)
print v(xbgr.mr_n65776048)
print v(xbgr.mr_n65776576)
print v(xbgr.mr_n65784144)
print v(xbgr.mr_n65784336)
print v(xbgr.mr_n65784592)
print v(xbgr.mr_n65784848)
print v(xbgr.mr_n65786816)
print v(xbgr.mr_n65807200)
print v(xbgr.mr_n65809712)
print v(xbgr.mr_n65810960)
print v(xbgr.mr_n65811456)
print v(xbgr.mr_n65811760)
print v(xbgr.mr_n65812256)
print v(xbgr.mr_n65812560)
print v(xbgr.mr_n65813120)
print v(xbgr.mr_n65813424)
print v(xbgr.mr_n65814304)
print v(xbgr.mr_n65814608)
print v(xbgr.mr_n65815488)
print v(xbgr.mr_n65815792)
print v(xbgr.mr_n65816672)
print v(xbgr.mr_n65816976)
print v(xbgr.mr_n65817856)
print v(xbgr.mr_n65818160)
print v(xbgr.mr_n65819040)
print v(xbgr.mr_n65819344)
print v(xbgr.mr_n65820224)
print v(xbgr.mr_n65820528)
print v(xbgr.mr_n65821408)
print v(xbgr.mr_n65821712)
print v(xbgr.mr_n65822592)
print v(xbgr.mr_n65822896)
print v(xbgr.mr_n65823776)
print v(xbgr.mr_n65824080)
print v(xbgr.mr_n65824960)
print v(xbgr.mr_n65825264)
print v(xbgr.mr_n65826144)
print v(xbgr.mr_n65826448)
print v(xbgr.mr_n65827328)
print v(xbgr.mr_n65827520)
print v(xbgr.mr_n65827792)
print v(xbgr.mr_n65828256)
print v(xbgr.mr_n65829600)
print v(xbgr.mr_n65837744)
print v(xbgr.mr_n65838416)
print v(xbgr.mr_n65844304)
print v(xbgr.mr_n65844640)
print v(xbgr.mr_n65844976)
print v(xbgr.mr_n65845312)
print v(xbgr.mr_n65847344)
print v(xbgr.mr_n65848112)
print v(xbgr.mr_n65848512)
print v(xbgr.mr_n65848912)
print v(xbgr.mr_n65849312)
print v(xbgr.mr_n65849712)
print v(xbgr.mr_n65850112)
print v(xbgr.mr_n65850512)
print v(xbgr.mr_n65850912)
print v(xbgr.mr_n65851312)
print v(xbgr.mr_n65851712)
print v(xbgr.mr_n65852112)
print v(xbgr.mr_n65852512)
print v(xbgr.mr_n65852912)
print v(xbgr.mr_n65853312)
print v(xbgr.mr_n65853712)
print v(xbgr.mr_n65854112)
print v(xbgr.mr_n65865472)
print v(xbgr.mr_n65866064)
print v(xbgr.mr_n65875712)
print v(xbgr.mr_n65877056)
print v(xbgr.mr_n65878720)
print v(xbgr.mr_n65882480)
print v(xbgr.mr_n65883456)
print v(xbgr.mr_n65884528)
print v(xbgr.mr_n65884832)
print v(xbgr.mr_n65885136)
print v(xbgr.mr_n65885440)
print v(xbgr.mr_n65885824)
print v(xbgr.mr_n65886288)
print v(xbgr.mr_n65886752)
print v(xbgr.mr_n65887216)
print v(xbgr.mr_n65887680)
print v(xbgr.mr_n65888144)
print v(xbgr.mr_n65888608)
print v(xbgr.mr_n65889072)
print v(xbgr.mr_n65889536)
print v(xbgr.mr_n65889696)
print v(xbgr.mr_n65890832)
print v(xbgr.mr_n65894128)
print v(xbgr.mr_n65894544)
print v(xbgr.mr_n65894896)
print v(xbgr.mr_n65895904)
print v(xbgr.mr_n65898832)
print v(xbgr.mr_n65899456)
print v(xbgr.mr_n65900704)
print v(xbgr.mr_n65900816)
print v(xbgr.mr_n65902496)
print v(xbgr.mr_n65902832)
print v(xbgr.mr_n65903168)
print v(xbgr.mr_n65903504)
print v(xbgr.mr_n65903840)
print v(xbgr.mr_n65904704)
print v(xbgr.mr_n65905680)
print v(xbgr.mr_n65906464)
print v(xbgr.mr_n65906576)
print v(xbgr.mr_n65906768)
print v(xbgr.mr_n65907296)
print v(xbgr.mr_n65908720)
print v(xbgr.mr_n65910224)
print v(xbgr.mr_n65910864)
print v(xbgr.mr_n65912816)
print v(xbgr.mr_n65912928)
print v(xbgr.mr_n65913040)
print v(xbgr.mr_n65913312)
print v(xbgr.mr_n65915712)
print v(xbgr.mr_n65916352)
print v(xbgr.mr_n65916464)
print v(xbgr.mr_n65918160)
print v(xbgr.mr_n65918272)
print v(xbgr.mr_n65918384)
print v(xbgr.mr_n65918656)
print v(xbgr.mr_n65920272)
print v(xbgr.mr_n65921408)
print v(xbgr.mr_n65921520)
print v(xbgr.mr_n65922784)
print v(xbgr.mr_n65923200)
print v(xbgr.mr_n65924128)
print v(xbgr.mr_n65924240)
print v(xbgr.mr_n65925744)
print v(xbgr.mr_n65926464)
print v(xbgr.mr_n65926576)
print v(xbgr.mr_n65928272)
print v(xbgr.mr_n65928384)
print v(xbgr.mr_n65928496)
print v(xbgr.mr_n65928768)
print v(xbgr.mr_n65930928)
print v(xbgr.mr_n65931040)
print v(xbgr.mr_n65931232)
print v(xbgr.mr_n65932704)
print v(xbgr.mr_n65933600)
print v(xbgr.mr_n65934240)
print v(xbgr.mr_n65934352)
print v(xbgr.mr_n65935696)
print v(xbgr.mr_n65936576)
print v(xbgr.mr_n65936688)
print v(xbgr.mr_n65938384)
print v(xbgr.mr_n65938496)
print v(xbgr.mr_n65938608)
print v(xbgr.mr_n65938880)
print v(xbgr.mr_n65941040)
print v(xbgr.mr_n65941152)
print v(xbgr.mr_n65941344)
print v(xbgr.mr_n65943376)
print v(xbgr.mr_n65943488)
print v(xbgr.mr_n65943600)
print v(xbgr.mr_n65943872)
print v(xbgr.mr_n65946096)
print v(xbgr.mr_n65946208)
print v(xbgr.mr_n65946400)
print v(xbgr.mr_n65946912)
print v(xbgr.mr_n65947248)
print v(xbgr.mr_n65947600)
print v(xbgr.mr_n65948224)
print v(xbgr.mr_n65948752)
print v(xbgr.mr_n65949104)
print v(xbgr.mr_n65949792)
print v(xbgr.mr_n65950256)
print v(xbgr.mr_n65950672)
print v(xbgr.mr_n65951360)
print v(xbgr.mr_n65951824)
print v(xbgr.mr_n65952240)
print v(xbgr.mr_n65952928)
print v(xbgr.mr_n65953456)
print v(xbgr.mr_n65953808)
print v(xbgr.mr_n65954128)
print v(xbgr.mr_n65954496)
print v(xbgr.mr_n65954960)
print v(xbgr.mr_n65955376)
print v(xbgr.mr_n65956064)
print v(xbgr.mr_n65956528)
print v(xbgr.mr_n65956944)
print v(xbgr.mr_n65957632)
print v(xbgr.mr_n65958160)
print v(xbgr.mr_n65958512)
print v(xbgr.mr_n65959200)
print v(xbgr.mr_n65959728)
print v(xbgr.mr_n65960080)
print v(xbgr.mr_n65960768)
print v(xbgr.mr_n65961296)
print v(xbgr.mr_n65961648)
print v(xbgr.mr_n65962336)
print v(xbgr.mr_n65962800)
print v(xbgr.mr_n65963216)
print v(xbgr.mr_n65963904)
print v(xbgr.mr_n65964432)
print v(xbgr.mr_n65965232)
print v(xbgr.mr_n65967984)
print v(xbgr.mr_n65969648)
print v(xbgr.mr_n65969952)
print v(xbgr.mr_n65970336)
print v(xbgr.mr_n65973904)
print v(xbgr.mr_n65979216)
print v(xbgr.mr_n65985264)
print v(xbgr.mr_n65985728)
print v(xbgr.mr_n65986192)
print v(xbgr.mr_n65986656)
print v(xbgr.mr_n65987120)
print v(xbgr.mr_n65987584)
print v(xbgr.mr_n65988048)
print v(xbgr.mr_n65988512)
print v(xbgr.mr_n65988976)
print v(xbgr.mr_n65989440)
print v(xbgr.mr_n65989904)
print v(xbgr.mr_n65990368)
print v(xbgr.mr_n65990832)
print v(xbgr.mr_n65991296)
print v(xbgr.mr_n65991760)
print v(xbgr.mr_n65992224)
print v(xbgr.mr_n65992688)
print v(xbgr.mr_n65993152)
print v(xbgr.mr_n65993616)
print v(xbgr.mr_n66007072)
print v(xbgr.mr_n66009056)
print v(xbgr.mr_n66011408)
print v(xbgr.mr_n66013024)
print v(xbgr.mr_n66015888)
print v(xbgr.mr_n66017152)
print v(xbgr.mr_n66017344)
print v(xbgr.mr_n66017600)
print v(xbgr.mr_n66017856)
print v(xbgr.mr_n66019824)
print v(xbgr.mr_n66040832)
print v(xbgr.mr_n66043680)
print v(xbgr.mr_n66043888)
print v(xbgr.mr_n66044000)
print v(xbgr.mr_n66044112)
print v(xbgr.mr_n66044304)
print v(xbgr.mr_n66046816)
print v(xbgr.mr_n66046992)
print v(xbgr.mr_n66047472)
print v(xbgr.mr_n66047648)
print v(xbgr.mr_n66048128)
print v(xbgr.mr_n66048304)
print v(xbgr.mr_n66048784)
print v(xbgr.mr_n66048960)
print v(xbgr.mr_n66049440)
print v(xbgr.mr_n66049616)
print v(xbgr.mr_n66050096)
print v(xbgr.mr_n66050272)
print v(xbgr.mr_n66051936)
print v(xbgr.mr_n66053504)
print v(xbgr.mr_n66053840)
print v(xbgr.mr_n66054928)
print v(xbgr.mr_n66055904)
print v(xbgr.mr_n66056080)
print v(xbgr.mr_n66056256)
print v(xbgr.mr_n66056960)
print v(xbgr.mr_n66057136)
print v(xbgr.mr_n66057696)
print v(xbgr.mr_n66058160)
print v(xbgr.mr_n66058336)
print v(xbgr.mr_n66058512)
print v(xbgr.mr_n66059216)
print v(xbgr.mr_n66059392)
print v(xbgr.mr_n66060016)
print v(xbgr.mr_n66060192)
print v(xbgr.mr_n66060368)
print v(xbgr.mr_n66060880)
print v(xbgr.mr_n66061312)
print v(xbgr.mr_n66061488)
print v(xbgr.mr_n66061744)
print v(xbgr.mr_n66062528)
print v(xbgr.mr_n66062704)
print v(xbgr.mr_n66063328)
print v(xbgr.mr_n66063504)
print v(xbgr.mr_n66063680)
print v(xbgr.mr_n66064384)
print v(xbgr.mr_n66064560)
print v(xbgr.mr_n66065184)
print v(xbgr.mr_n66065360)
print v(xbgr.mr_n66065536)
print v(xbgr.mr_n66066176)
print v(xbgr.mr_n66066448)
print v(xbgr.mr_n66066880)
print v(xbgr.mr_n66067056)
print v(xbgr.mr_n66067392)
print v(xbgr.mr_n66068096)
print v(xbgr.mr_n66068272)
print v(xbgr.mr_n66068896)
print v(xbgr.mr_n66069072)
print v(xbgr.mr_n66069248)
print v(xbgr.mr_n66069888)
print v(xbgr.mr_n66070160)
print v(xbgr.mr_n66070272)
print v(xbgr.mr_n66070384)
print v(xbgr.mr_n66070496)
print v(xbgr.mr_n66070608)
print v(xbgr.mr_n66070880)
print v(xbgr.mr_n66071232)
print v(xbgr.mr_n66071344)
print v(xbgr.mr_n66071456)
print v(xbgr.mr_n66071808)
print v(xbgr.mr_n66072368)
print v(xbgr.mr_n66072544)
print v(xbgr.mr_n66072896)
print v(xbgr.mr_n66073264)
print v(xbgr.mr_n66073600)
print v(xbgr.mr_n66073952)
print v(xbgr.mr_n66074064)
print v(xbgr.mr_n66074560)
print v(xbgr.mr_n66075056)
print v(xbgr.mr_n66075536)
print v(xbgr.mr_n66075712)
print v(xbgr.mr_n66076064)
print v(xbgr.mr_n66076432)
print v(xbgr.mr_n66076768)
print v(xbgr.mr_n66077120)
print v(xbgr.mr_n66077232)
print v(xbgr.mr_n66077728)
print v(xbgr.mr_n66078224)
print v(xbgr.mr_n66078704)
print v(xbgr.mr_n66078880)
print v(xbgr.mr_n66079232)
print v(xbgr.mr_n66079600)
print v(xbgr.mr_n66079936)
print v(xbgr.mr_n66080288)
print v(xbgr.mr_n66081488)
print v(xbgr.mr_n66084576)
print v(xbgr.mr_n66085856)
print v(xbgr.mr_n66092176)
print v(xbgr.mr_n66092560)
print v(xbgr.mr_n66093024)
print v(xbgr.mr_n66093488)
print v(xbgr.mr_n66093952)
print v(xbgr.mr_n66094416)
print v(xbgr.mr_n66094880)
print v(xbgr.mr_n66095344)
print v(xbgr.mr_n66095808)
print v(xbgr.mr_n66096272)
print v(xbgr.mr_n66096736)
print v(xbgr.mr_n66097200)
print v(xbgr.mr_n66097664)
print v(xbgr.mr_n66098128)
print v(xbgr.mr_n66098592)
print v(xbgr.mr_n66099056)
print v(xbgr.mr_n66099520)
print v(xbgr.mr_n66099984)
print v(xbgr.mr_n66100448)
print v(xbgr.mr_n66100912)
print v(xbgr.mr_n66101376)
print v(xbgr.mr_n66101840)
print v(xbgr.mr_n66102304)
print v(xbgr.mr_n66102768)
print v(xbgr.mr_n66103296)
print v(xbgr.mr_n66103888)
print v(xbgr.mr_n66106176)
print v(xbgr.mr_n66108480)
print v(xbgr.mr_n66114592)
print v(xbgr.mr_n66126096)
print v(xbgr.mr_n66126528)
print v(xbgr.mr_n66129488)
print v(xbgr.mr_n66135936)
print v(xbgr.mr_n66136112)
print v(xbgr.mr_n66136448)
print v(xbgr.mr_n66137152)
print v(xbgr.mr_n66137328)
print v(xbgr.mr_n66138320)
print v(xbgr.mr_n66138432)
print v(xbgr.mr_n66138624)
print v(xbgr.mr_n66139376)
print v(xbgr.mr_n66142000)
print v(xbgr.mr_n66142752)
print v(xbgr.mr_n66155872)
print v(xbgr.mr_n66158672)
print v(xbgr.mr_n66159312)
print v(xbgr.mr_n66159744)
print v(xbgr.mr_n66159920)
print v(xbgr.mr_n66160096)
print v(xbgr.mr_n66160960)
print v(xbgr.mr_n66161136)
print v(xbgr.mr_n66161760)
print v(xbgr.mr_n66161936)
print v(xbgr.mr_n66162560)
print v(xbgr.mr_n66162736)
print v(xbgr.mr_n66163360)
print v(xbgr.mr_n66163536)
print v(xbgr.mr_n66164160)
print v(xbgr.mr_n66164336)
print v(xbgr.mr_n66164688)
print v(xbgr.mr_n66164960)
print v(xbgr.mr_n66165136)
print v(xbgr.mr_n66165760)
print v(xbgr.mr_n66165936)
print v(xbgr.mr_n66166496)
print v(xbgr.mr_n66173632)
print v(xbgr.mr_n66176016)
print v(xbgr.mr_n66176544)
print v(xbgr.mr_n66179056)
print v(xbgr.mr_n66179408)
print v(xbgr.mr_n66179760)
print v(xbgr.mr_n66179872)
print v(xbgr.mr_n66180224)
print v(xbgr.mr_n66180336)
print v(xbgr.mr_n66180608)
print v(xbgr.mr_n66181440)
print v(xbgr.mr_n66181664)
print v(xbgr.mr_n66181776)
print v(xbgr.mr_n66181888)
print v(xbgr.mr_n66188032)
print v(xbgr.mr_n66188544)
print v(xbgr.mr_n66188704)
print v(xbgr.mr_n66188848)
print v(xbgr.mr_n66189040)
print v(xbgr.mr_n66189376)
print v(xbgr.mr_n66189712)
print v(xbgr.mr_n66190208)
print v(xbgr.mr_n66190400)
print v(xbgr.mr_n66190592)
print v(xbgr.mr_n66190784)
print v(xbgr.mr_n66191680)
print v(xbgr.mr_n66192928)
print v(xbgr.mr_n66193520)
print v(xbgr.mr_n66193632)
print v(xbgr.mr_n66193936)
print v(xbgr.mr_n66194848)
print v(xbgr.mr_n66195904)
print v(xbgr.mr_n66196352)
print v(xbgr.mr_n66196848)
print v(xbgr.mr_n66197296)
print v(xbgr.mr_n66197408)
print v(xbgr.mr_n66197648)
print v(xbgr.mr_n66198272)
print v(xbgr.mr_n66198944)
print v(xbgr.mr_n66200480)
print v(xbgr.mr_n66201344)
print v(xbgr.mr_n66202160)
print v(xbgr.mr_n66202272)
print v(xbgr.mr_n66203376)
print v(xbgr.mr_n66204144)
print v(xbgr.mr_n66204688)
print v(xbgr.mr_n66204800)
print v(xbgr.mr_n66205600)
print v(xbgr.mr_n66205712)
print v(xbgr.mr_n66209024)
print v(xbgr.mr_n66210064)
print v(xbgr.mr_n66210848)
print v(xbgr.mr_n66211552)
print v(xbgr.mr_n66212464)
print v(xbgr.mr_n66215984)
print v(xbgr.mr_n66216160)
print v(xbgr.mr_n66217392)
print v(xbgr.mr_n66217776)
print v(xbgr.mr_n66217968)
print v(xbgr.mr_n66218448)
print v(xbgr.mr_n66219904)
print v(xbgr.mr_n66220992)
print v(xbgr.mr_n66221184)
print v(xbgr.mr_n66221376)
print v(xbgr.mr_n66221808)
print v(xbgr.mr_n66222224)
print v(xbgr.mr_n66222496)
print v(xbgr.mr_n66223248)
print v(xbgr.mr_n66223440)
print v(xbgr.mr_n66223632)
print v(xbgr.mr_n66224528)
print v(xbgr.mr_n66225424)
print v(xbgr.mr_n66225792)
print v(xbgr.mr_n66226096)
print v(xbgr.mr_n66226656)
print v(xbgr.mr_n66227072)
print v(xbgr.mr_n66227504)
print v(xbgr.mr_n66227856)
print v(xbgr.mr_n66228288)
print v(xbgr.mr_n66228752)
print v(xbgr.mr_n66229104)
print v(xbgr.mr_n66229536)
print v(xbgr.mr_n66229840)
print v(xbgr.mr_n66230400)
print v(xbgr.mr_n66230816)
print v(xbgr.mr_n66231184)
print v(xbgr.mr_n66231600)
print v(xbgr.mr_n66232032)
print v(xbgr.mr_n66232496)
print v(xbgr.mr_n66232848)
print v(xbgr.mr_n66233280)
print v(xbgr.mr_n66233584)
print v(xbgr.mr_n66234208)
print v(xbgr.mr_n66234560)
print v(xbgr.mr_n66234992)
print v(xbgr.mr_n66235344)
print v(xbgr.mr_n66235776)
print v(xbgr.mr_n66236240)
print v(xbgr.mr_n66236592)
print v(xbgr.mr_n66236768)
print v(xbgr.mr_n66237024)
print v(xbgr.mr_n66237216)
print v(xbgr.mr_n66237488)
print v(xbgr.mr_n66237760)
print v(xbgr.mr_n66238032)
print v(xbgr.mr_n66238304)
print v(xbgr.mr_n66238576)
print v(xbgr.mr_n66238848)
print v(xbgr.mr_n66239120)
print v(xbgr.mr_n66239392)
print v(xbgr.mr_n66239664)
print v(xbgr.mr_n66239936)
print v(xbgr.mr_n66240208)
print v(xbgr.mr_n66240480)
print v(xbgr.mr_n66240752)
print v(xbgr.mr_n66241088)
print v(xbgr.mr_n66241552)
print v(xbgr.mr_n66242016)
print v(xbgr.mr_n66242192)
print v(xbgr.mr_n66245600)
print v(xbgr.mr_n66248608)
print v(xbgr.mr_n66252192)
print v(xbgr.mr_n66255584)
print v(xbgr.mr_n66257680)
print v(xbgr.mr_n66257792)
print v(xbgr.mr_n66261296)
print v(xbgr.mr_n66273264)
print v(xbgr.mr_n66273600)
print v(xbgr.mr_n66273936)
print v(xbgr.mr_n66274112)
print v(xbgr.mr_n66274272)
print v(xbgr.mr_n66274944)
print v(xbgr.mr_n66275120)
print v(xbgr.mr_n66275232)
print v(xbgr.mr_n66275344)
print v(xbgr.mr_n66275456)
print v(xbgr.mr_n66275568)
print v(xbgr.mr_n66275680)
print v(xbgr.mr_n66275792)
print v(xbgr.mr_n66276144)
print v(xbgr.mr_n66276496)
print v(xbgr.mr_n66276608)
print v(xbgr.mr_n66276960)
print v(xbgr.mr_n66277072)
print v(xbgr.mr_n66277392)
print v(xbgr.mr_n66277664)
print v(xbgr.mr_n66277936)
print v(xbgr.mr_n66281200)
print v(xbgr.mr_n66282656)
print v(xbgr.mr_n66282848)
print v(xbgr.mr_n66283040)
print v(xbgr.mr_n66283648)
print v(xbgr.mr_n66283760)
print v(xbgr.mr_n66283872)
print v(xbgr.mr_n66284032)
print v(xbgr.mr_n66284384)
print v(xbgr.mr_n66284576)
print v(xbgr.mr_n66284928)
print v(xbgr.mr_n66286432)
print v(xbgr.mr_n66287056)
print v(xbgr.mr_n66288112)
print v(xbgr.mr_n66288720)
print v(xbgr.mr_n66288912)
print v(xbgr.mr_n66289104)
print v(xbgr.mr_n66289296)
print v(xbgr.mr_n66290416)
print v(xbgr.mr_n66291600)
print v(xbgr.mr_n66292016)
print v(xbgr.mr_n66292448)
print v(xbgr.mr_n66292752)
print v(xbgr.mr_n66293376)
print v(xbgr.mr_n66293728)
print v(xbgr.mr_n66294160)
print v(xbgr.mr_n66294512)
print v(xbgr.mr_n66294944)
print v(xbgr.mr_n66295344)
print v(xbgr.mr_n66295760)
print v(xbgr.mr_n66296192)
print v(xbgr.mr_n66296496)
print v(xbgr.mr_n66297120)
print v(xbgr.mr_n66297472)
print v(xbgr.mr_n66297840)
print v(xbgr.mr_n66298256)
print v(xbgr.mr_n66298576)
print v(xbgr.mr_n66298688)
print v(xbgr.mr_n66299152)
print v(xbgr.mr_n66299504)
print v(xbgr.mr_n66299936)
print v(xbgr.mr_n66300240)
print v(xbgr.mr_n66300800)
print v(xbgr.mr_n66301216)
print v(xbgr.mr_n66301584)
print v(xbgr.mr_n66302000)
print v(xbgr.mr_n66302432)
print v(xbgr.mr_n66302896)
print v(xbgr.mr_n66303248)
print v(xbgr.mr_n66303680)
print v(xbgr.mr_n66303984)
print v(xbgr.mr_n66304464)
print v(xbgr.mr_n66304960)
print v(xbgr.mr_n66305072)
print v(xbgr.mr_n66305264)
print v(xbgr.mr_n66305536)
print v(xbgr.mr_n66305808)
print v(xbgr.mr_n66306080)
print v(xbgr.mr_n66306352)
print v(xbgr.mr_n66306624)
print v(xbgr.mr_n66306896)
print v(xbgr.mr_n66307168)
print v(xbgr.mr_n66307440)
print v(xbgr.mr_n66307712)
print v(xbgr.mr_n66307984)
print v(xbgr.mr_n66308256)
print v(xbgr.mr_n66308528)
print v(xbgr.mr_n66308800)
print v(xbgr.mr_n66309072)
print v(xbgr.mr_n66309536)
print v(xbgr.mr_n66309648)
print v(xbgr.mr_n66310816)
print v(xbgr.mr_n66317856)
print v(xbgr.mr_n66323840)
print v(xbgr.mr_n66331936)
print v(xbgr.mr_n66332128)
print v(xbgr.mr_n66332320)
print v(xbgr.mr_n66332576)
print v(xbgr.mr_n66332832)
print v(xbgr.mr_n66334800)
print v(xbgr.mr_n66335168)
print v(xbgr.mr_n66335808)
print v(xbgr.mr_n66335920)
print v(xbgr.mr_n66336336)
print v(xbgr.mr_n66338528)
print v(xbgr.mr_n66339808)
print v(xbgr.mr_n66341248)
print v(xbgr.mr_n66342112)
print v(xbgr.mr_n66342896)
print v(xbgr.mr_n66344752)
print v(xbgr.mr_n66345408)
print v(xbgr.mr_n66345920)
print v(xbgr.mr_n66347216)
print v(xbgr.mr_n66347728)
print v(xbgr.mr_n66349024)
print v(xbgr.mr_n66349536)
print v(xbgr.mr_n66350832)
print v(xbgr.mr_n66351344)
print v(xbgr.mr_n66352400)
print v(xbgr.mr_n66353152)
print v(xbgr.mr_n66354448)
print v(xbgr.mr_n66354960)
print v(xbgr.mr_n66356256)
print v(xbgr.mr_n66356768)
print v(xbgr.mr_n66357984)
print v(xbgr.mr_n66358576)
print v(xbgr.mr_n66359632)
print v(xbgr.mr_n66360384)
print v(xbgr.mr_n66360496)
print v(xbgr.mr_n66360608)
print v(xbgr.mr_n66360720)
print v(xbgr.mr_n66360832)
print v(xbgr.mr_n66361024)
print v(xbgr.mr_n66361456)
print v(xbgr.mr_n66361568)
print v(xbgr.mr_n66361840)
print v(xbgr.mr_n66362192)
print v(xbgr.mr_n66362432)
print v(xbgr.mr_n66362768)
print v(xbgr.mr_n66363184)
print v(xbgr.mr_n66363616)
print v(xbgr.mr_n66364304)
print v(xbgr.mr_n66364928)
print v(xbgr.mr_n66365472)
print v(xbgr.mr_n66365904)
print v(xbgr.mr_n66366320)
print v(xbgr.mr_n66367008)
print v(xbgr.mr_n66367536)
print v(xbgr.mr_n66367888)
print v(xbgr.mr_n66368320)
print v(xbgr.mr_n66369008)
print v(xbgr.mr_n66369632)
print v(xbgr.mr_n66370176)
print v(xbgr.mr_n66370672)
print v(xbgr.mr_n66371024)
print v(xbgr.mr_n66371712)
print v(xbgr.mr_n66372240)
print v(xbgr.mr_n66372592)
print v(xbgr.mr_n66373024)
print v(xbgr.mr_n66373712)
print v(xbgr.mr_n66374400)
print v(xbgr.mr_n66374880)
print v(xbgr.mr_n66375728)
print v(xbgr.mr_n66376416)
print v(xbgr.mr_n66376944)
print v(xbgr.mr_n66377296)
print v(xbgr.mr_n66377728)
print v(xbgr.mr_n66378416)
print v(xbgr.mr_n66379040)
print v(xbgr.mr_n66379584)
print v(xbgr.mr_n66380016)
print v(xbgr.mr_n66380432)
print v(xbgr.mr_n66381120)
print v(xbgr.mr_n66381648)
print v(xbgr.mr_n66382000)
print v(xbgr.mr_n66382320)
print v(xbgr.mr_n66382432)
print v(xbgr.mr_n66383120)
print v(xbgr.mr_n66383744)
print v(xbgr.mr_n66384288)
print v(xbgr.mr_n66384784)
print v(xbgr.mr_n66385136)
print v(xbgr.mr_n66385824)
print v(xbgr.mr_n66386288)
print v(xbgr.mr_n66386704)
print v(xbgr.mr_n66387136)
print v(xbgr.mr_n66387328)
print v(xbgr.mr_n66387600)
print v(xbgr.mr_n66387872)
print v(xbgr.mr_n66388144)
print v(xbgr.mr_n66388416)
print v(xbgr.mr_n66388688)
print v(xbgr.mr_n66388960)
print v(xbgr.mr_n66389232)
print v(xbgr.mr_n66389504)
print v(xbgr.mr_n66389776)
print v(xbgr.mr_n66390048)
print v(xbgr.mr_n66390320)
print v(xbgr.mr_n66390592)
print v(xbgr.mr_n66393136)
print v(xbgr.mr_n66395456)
print v(xbgr.mr_n66401024)
print v(xbgr.mr_n66402480)
print v(xbgr.mr_n66414784)
print v(xbgr.mr_n66415312)
print v(xbgr.mr_n66415776)
print v(xbgr.mr_n66416240)
print v(xbgr.mr_n66416704)
print v(xbgr.mr_n66416912)
print v(xbgr.mr_n66417168)
print v(xbgr.mr_n66418496)
print v(xbgr.mr_n66425040)
print v(xbgr.mr_n66427152)
print v(xbgr.mr_n66432960)
print v(xbgr.mr_n66438656)
print v(xbgr.mr_n66440528)
print v(xbgr.mr_n66442496)
print v(xbgr.mr_n66447120)
print v(xbgr.mr_n66448256)
print v(xbgr.mr_n66458048)
print v(xbgr.mr_n66458224)
print v(xbgr.mr_n66458560)
print v(xbgr.mr_n66458896)
print v(xbgr.mr_n66460800)
print v(xbgr.mr_n66461504)
print v(xbgr.mr_n66462832)
print v(xbgr.mr_n66463344)
print v(xbgr.mr_n66464640)
print v(xbgr.mr_n66465152)
print v(xbgr.mr_n66466448)
print v(xbgr.mr_n66466960)
print v(xbgr.mr_n66467856)
print v(xbgr.mr_n66468512)
print v(xbgr.mr_n66469024)
print v(xbgr.mr_n66469920)
print v(xbgr.mr_n66470496)
print v(xbgr.mr_n66471088)
print v(xbgr.mr_n66471984)
print v(xbgr.mr_n66472640)
print v(xbgr.mr_n66473152)
print v(xbgr.mr_n66474048)
print v(xbgr.mr_n66474704)
print v(xbgr.mr_n66475216)
print v(xbgr.mr_n66476112)
print v(xbgr.mr_n66476688)
print v(xbgr.mr_n66477280)
print v(xbgr.mr_n66478176)
print v(xbgr.mr_n66478832)
print v(xbgr.mr_n66479344)
print v(xbgr.mr_n66480240)
print v(xbgr.mr_n66480736)
print v(xbgr.mr_n66481408)
print v(xbgr.mr_n66482304)
print v(xbgr.mr_n66482960)
print v(xbgr.mr_n66483472)
print v(xbgr.mr_n66484368)
print v(xbgr.mr_n66485024)
print v(xbgr.mr_n66485536)
print v(xbgr.mr_n66486432)
print v(xbgr.mr_n66486848)
print v(xbgr.mr_n66487600)
print v(xbgr.mr_n66488496)
print v(xbgr.mr_n66489152)
print v(xbgr.mr_n66489664)
print v(xbgr.mr_n66490560)
print v(xbgr.mr_n66491216)
print v(xbgr.mr_n66491728)
print v(xbgr.mr_n66493024)
print v(xbgr.mr_n66493536)
print v(xbgr.mr_n66493648)
print v(xbgr.mr_n66493760)
print v(xbgr.mr_n66493872)
print v(xbgr.mr_n66494144)
print v(xbgr.mr_n66494256)
print v(xbgr.mr_n66494608)
print v(xbgr.mr_n66494720)
print v(xbgr.mr_n66494832)
print v(xbgr.mr_n66495264)
print v(xbgr.mr_n66495744)
print v(xbgr.mr_n66495920)
print v(xbgr.mr_n66496272)
print v(xbgr.mr_n66496640)
print v(xbgr.mr_n66496976)
print v(xbgr.mr_n66497328)
print v(xbgr.mr_n66497440)
print v(xbgr.mr_n66497936)
print v(xbgr.mr_n66498352)
print v(xbgr.mr_n66498912)
print v(xbgr.mr_n66499088)
print v(xbgr.mr_n66499440)
print v(xbgr.mr_n66499808)
print v(xbgr.mr_n66500144)
print v(xbgr.mr_n66500496)
print v(xbgr.mr_n66500608)
print v(xbgr.mr_n66501104)
print v(xbgr.mr_n66501600)
print v(xbgr.mr_n66502080)
print v(xbgr.mr_n66502256)
print v(xbgr.mr_n66502608)
print v(xbgr.mr_n66503040)
print v(xbgr.mr_n66503568)
print v(xbgr.mr_n66503920)
print v(xbgr.mr_n66504352)
print v(xbgr.mr_n66505040)
print v(xbgr.mr_n66505664)
print v(xbgr.mr_n66506208)
print v(xbgr.mr_n66506704)
print v(xbgr.mr_n66507056)
print v(xbgr.mr_n66507744)
print v(xbgr.mr_n66508272)
print v(xbgr.mr_n66508624)
print v(xbgr.mr_n66509056)
print v(xbgr.mr_n66509744)
print v(xbgr.mr_n66510432)
print v(xbgr.mr_n66510784)
print v(xbgr.mr_n66510896)
print v(xbgr.mr_n66511088)
print v(xbgr.mr_n66511360)
print v(xbgr.mr_n66511632)
print v(xbgr.mr_n66511904)
print v(xbgr.mr_n66512176)
print v(xbgr.mr_n66512448)
print v(xbgr.mr_n66512720)
print v(xbgr.mr_n66512992)
print v(xbgr.mr_n66513264)
print v(xbgr.mr_n66513536)
print v(xbgr.mr_n66513808)
print v(xbgr.mr_n66514080)
print v(xbgr.mr_n66514352)
print v(xbgr.mr_n66514624)
print v(xbgr.mr_n66514896)
print v(xbgr.mr_n66515168)
print v(xbgr.mr_n66533040)
print v(xbgr.mr_n66533504)
print v(xbgr.mr_n66533968)
print v(xbgr.mr_n66534432)
print v(xbgr.mr_n66534896)
print v(xbgr.mr_n66535360)
print v(xbgr.mr_n66535824)
print v(xbgr.mr_n66536352)
print v(xbgr.mr_n66536944)
print v(xbgr.mr_n66537536)
print v(xbgr.mr_n66538128)
print v(xbgr.mr_n66538720)
print v(xbgr.mr_n66539312)
print v(xbgr.mr_n66539904)
print v(xbgr.mr_n66540496)
print v(xbgr.mr_n66541088)
print v(xbgr.mr_n66541680)
print v(xbgr.mr_n66542368)
print v(xbgr.mr_n66543072)
print v(xbgr.mr_n66547168)
print v(xbgr.mr_n66547696)
print v(xbgr.mr_n66551392)
print v(xbgr.mr_n66553392)
print v(xbgr.mr_n66554544)
print v(xbgr.mr_n66555424)
print v(xbgr.mr_n66558368)
print v(xbgr.mr_n66561696)
print v(xbgr.mr_n66567280)
print v(xbgr.mr_n66568048)
print v(xbgr.mr_n66570640)
print v(xbgr.mr_n66570832)
print v(xbgr.mr_n66571088)
print v(xbgr.mr_n66571344)
print v(xbgr.mr_n66573504)
print v(xbgr.mr_n66580736)
print v(xbgr.mr_n66581376)
print v(xbgr.mr_n66582592)
print v(xbgr.mr_n66583184)
print v(xbgr.mr_n66584480)
print v(xbgr.mr_n66584592)
print v(xbgr.mr_n66584784)
print v(xbgr.mr_n66585616)
print v(xbgr.mr_n66587344)
print v(xbgr.mr_n66587856)
print v(xbgr.mr_n66589600)
print v(xbgr.mr_n66590112)
print v(xbgr.mr_n66591408)
print v(xbgr.mr_n66591920)
print v(xbgr.mr_n66593216)
print v(xbgr.mr_n66593728)
print v(xbgr.mr_n66594944)
print v(xbgr.mr_n66595536)
print v(xbgr.mr_n66596592)
print v(xbgr.mr_n66597344)
print v(xbgr.mr_n66598560)
print v(xbgr.mr_n66599152)
print v(xbgr.mr_n66600368)
print v(xbgr.mr_n66600960)
print v(xbgr.mr_n66602256)
print v(xbgr.mr_n66602768)
print v(xbgr.mr_n66603984)
print v(xbgr.mr_n66604576)
print v(xbgr.mr_n66605872)
print v(xbgr.mr_n66606384)
print v(xbgr.mr_n66607680)
print v(xbgr.mr_n66608192)
print v(xbgr.mr_n66609408)
print v(xbgr.mr_n66610000)
print v(xbgr.mr_n66610112)
print v(xbgr.mr_n66610224)
print v(xbgr.mr_n66610336)
print v(xbgr.mr_n66610608)
print v(xbgr.mr_n66610720)
print v(xbgr.mr_n66611072)
print v(xbgr.mr_n66611184)
print v(xbgr.mr_n66611456)
print v(xbgr.mr_n66611808)
print v(xbgr.mr_n66611920)
print v(xbgr.mr_n66612288)
print v(xbgr.mr_n66612784)
print v(xbgr.mr_n66613264)
print v(xbgr.mr_n66613504)
print v(xbgr.mr_n66613920)
print v(xbgr.mr_n66614608)
print v(xbgr.mr_n66615136)
print v(xbgr.mr_n66615488)
print v(xbgr.mr_n66615920)
print v(xbgr.mr_n66616608)
print v(xbgr.mr_n66617232)
print v(xbgr.mr_n66617776)
print v(xbgr.mr_n66618208)
print v(xbgr.mr_n66618624)
print v(xbgr.mr_n66618864)
print v(xbgr.mr_n66619312)
print v(xbgr.mr_n66619840)
print v(xbgr.mr_n66620192)
print v(xbgr.mr_n66620624)
print v(xbgr.mr_n66621312)
print v(xbgr.mr_n66622000)
print v(xbgr.mr_n66622480)
print v(xbgr.mr_n66622976)
print v(xbgr.mr_n66623328)
print v(xbgr.mr_n66624016)
print v(xbgr.mr_n66624400)
print v(xbgr.mr_n66624896)
print v(xbgr.mr_n66625328)
print v(xbgr.mr_n66626016)
print v(xbgr.mr_n66626704)
print v(xbgr.mr_n66627184)
print v(xbgr.mr_n66627616)
print v(xbgr.mr_n66628032)
print v(xbgr.mr_n66628720)
print v(xbgr.mr_n66629184)
print v(xbgr.mr_n66629600)
print v(xbgr.mr_n66630032)
print v(xbgr.mr_n66630720)
print v(xbgr.mr_n66631408)
print v(xbgr.mr_n66631888)
print v(xbgr.mr_n66632384)
print v(xbgr.mr_n66632736)
print v(xbgr.mr_n66633424)
print v(xbgr.mr_n66633888)
print v(xbgr.mr_n66634304)
print v(xbgr.mr_n66634736)
print v(xbgr.mr_n66635424)
print v(xbgr.mr_n66636048)
print v(xbgr.mr_n66636464)
print v(xbgr.mr_n66636576)
print v(xbgr.mr_n66636768)
print v(xbgr.mr_n66637040)
print v(xbgr.mr_n66637312)
print v(xbgr.mr_n66637584)
print v(xbgr.mr_n66637856)
print v(xbgr.mr_n66638128)
print v(xbgr.mr_n66638400)
print v(xbgr.mr_n66638672)
print v(xbgr.mr_n66638944)
print v(xbgr.mr_n66639216)
print v(xbgr.mr_n66639488)
print v(xbgr.mr_n66639760)
print v(xbgr.mr_n66640032)
print v(xbgr.mr_n66640304)
print v(xbgr.mr_n66640576)
print v(xbgr.mr_n66640848)
print v(xbgr.mr_n66646416)
print v(xbgr.mr_n66647056)
print v(xbgr.mr_n66654928)
print v(xbgr.mr_n66664000)
print v(xbgr.mr_n66664608)
print v(xbgr.mr_n66665072)
print v(xbgr.mr_n66665536)
print v(xbgr.mr_n66666000)
print v(xbgr.mr_n66666464)
print v(xbgr.mr_n66666928)
print v(xbgr.mr_n66667392)
print v(xbgr.mr_n66667920)
print v(xbgr.mr_n66668512)
print v(xbgr.mr_n66669104)
print v(xbgr.mr_n66669696)
print v(xbgr.mr_n66670288)
print v(xbgr.mr_n66670880)
print v(xbgr.mr_n66671472)
print v(xbgr.mr_n66672064)
print v(xbgr.mr_n66672656)
print v(xbgr.mr_n66673248)
print v(xbgr.mr_n66687072)
print v(xbgr.mr_n66687376)
print v(xbgr.mr_n66691088)
print v(xbgr.mr_n66691264)
print v(xbgr.mr_n66691600)
print v(xbgr.mr_n66692240)
print v(xbgr.mr_n66692416)
print v(xbgr.mr_n66693376)
print v(xbgr.mr_n66693968)
print v(xbgr.mr_n66694560)
print v(xbgr.mr_n66695152)
print v(xbgr.mr_n66695744)
print v(xbgr.mr_n66696336)
print v(xbgr.mr_n66696928)
print v(xbgr.mr_n66697520)
print v(xbgr.mr_n66698112)
print v(xbgr.mr_n66698704)
print v(xbgr.mr_n66699296)
print v(xbgr.mr_n66699888)
print v(xbgr.mr_n66700480)
print v(xbgr.mr_n66701072)
print v(xbgr.mr_n66701664)
print v(xbgr.mr_n66702256)
print v(xbgr.mr_n66702848)
print v(xbgr.mr_n66703440)
print v(xbgr.mr_n66704032)
print v(xbgr.mr_n66711280)
print v(xbgr.mr_n66713008)
print v(xbgr.mr_n66713488)
print v(xbgr.mr_n66713920)
print v(xbgr.mr_n66714336)
print v(xbgr.mr_n66714448)
print v(xbgr.mr_n66715152)
print v(xbgr.mr_n66717392)
print v(xbgr.mr_n66717744)
print v(xbgr.mr_n66717856)
print v(xbgr.mr_n66718560)
print v(xbgr.mr_n66718896)
print v(xbgr.mr_n66719776)
print v(xbgr.mr_n66720592)
print v(xbgr.mr_n66721280)
print v(xbgr.mr_n66723264)
print v(xbgr.mr_n66723856)
print v(xbgr.mr_n66724272)
print v(xbgr.mr_n66724384)
print v(xbgr.mr_n66725088)
print v(xbgr.mr_n66727264)
print v(xbgr.mr_n66727680)
print v(xbgr.mr_n66727792)
print v(xbgr.mr_n66728496)
print v(xbgr.mr_n66730736)
print v(xbgr.mr_n66731088)
print v(xbgr.mr_n66731200)
print v(xbgr.mr_n66731904)
print v(xbgr.mr_n66734144)
print v(xbgr.mr_n66734496)
print v(xbgr.mr_n66734608)
print v(xbgr.mr_n66735312)
print v(xbgr.mr_n66737488)
print v(xbgr.mr_n66737904)
print v(xbgr.mr_n66738016)
print v(xbgr.mr_n66738720)
print v(xbgr.mr_n66740896)
print v(xbgr.mr_n66741312)
print v(xbgr.mr_n66741424)
print v(xbgr.mr_n66742128)
print v(xbgr.mr_n66756080)
print v(xbgr.mr_n66756256)
print v(xbgr.mr_n66756880)
print v(xbgr.mr_n66757056)
print v(xbgr.mr_n66757680)
print v(xbgr.mr_n66757856)
print v(xbgr.mr_n66758480)
print v(xbgr.mr_n66758656)
print v(xbgr.mr_n66759280)
print v(xbgr.mr_n66759456)
print v(xbgr.mr_n66760080)
print v(xbgr.mr_n66760256)
print v(xbgr.mr_n66760880)
print v(xbgr.mr_n66761056)
print v(xbgr.mr_n66761680)
print v(xbgr.mr_n66761856)
print v(xbgr.mr_n66762480)
print v(xbgr.mr_n66762656)
print v(xbgr.mr_n66763280)
print v(xbgr.mr_n66763456)
print v(xbgr.mr_n66764080)
print v(xbgr.mr_n66764256)
print v(xbgr.mr_n66764880)
print v(xbgr.mr_n66765056)
print v(xbgr.mr_n66765680)
print v(xbgr.mr_n66765856)
print v(xbgr.mr_n66766480)
print v(xbgr.mr_n66766656)
print v(xbgr.mr_n66767280)
print v(xbgr.mr_n66767456)
print v(xbgr.mr_n66768080)
print v(xbgr.mr_n66768256)
print v(xbgr.mr_n66768688)
print v(xbgr.mr_n66768800)
print v(xbgr.mr_n66768912)
print v(xbgr.mr_n66769024)
print v(xbgr.mr_n66769216)
print v(xbgr.mr_n66769488)
print v(xbgr.mr_n66769760)
print v(xbgr.mr_n66770032)
print v(xbgr.mr_n66770304)
print v(xbgr.mr_n66770576)
print v(xbgr.mr_n66770848)
print v(xbgr.mr_n66771120)
print v(xbgr.mr_n66771392)
print v(xbgr.mr_n66771664)
print v(xbgr.mr_n66771936)
print v(xbgr.mr_n66772208)
print v(xbgr.mr_n66772480)
print v(xbgr.mr_n66773056)
print v(xbgr.mr_n66782784)
print v(xbgr.mr_n66785392)
print v(xbgr.mr_n66786160)
print v(xbgr.mr_n66787184)
print v(xbgr.mr_n66792304)
print v(xbgr.mr_n66796208)
print v(xbgr.mr_n66800880)
print v(xbgr.mr_n66807296)
print v(xbgr.mr_n66810448)
print v(xbgr.mr_n66810624)
print v(xbgr.mr_n66810960)
print v(xbgr.mr_n66812896)
print v(xbgr.mr_n66813072)
print v(xbgr.mr_n66814016)
print v(xbgr.mr_n66814672)
print v(xbgr.mr_n66814848)
print v(xbgr.mr_n66815792)
print v(xbgr.mr_n66816448)
print v(xbgr.mr_n66816624)
print v(xbgr.mr_n66817568)
print v(xbgr.mr_n66818224)
print v(xbgr.mr_n66818400)
print v(xbgr.mr_n66819344)
print v(xbgr.mr_n66820000)
print v(xbgr.mr_n66820176)
print v(xbgr.mr_n66821120)
print v(xbgr.mr_n66821776)
print v(xbgr.mr_n66821952)
print v(xbgr.mr_n66822896)
print v(xbgr.mr_n66823552)
print v(xbgr.mr_n66823728)
print v(xbgr.mr_n66824672)
print v(xbgr.mr_n66825328)
print v(xbgr.mr_n66825504)
print v(xbgr.mr_n66826448)
print v(xbgr.mr_n66827104)
print v(xbgr.mr_n66827280)
print v(xbgr.mr_n66828224)
print v(xbgr.mr_n66828880)
print v(xbgr.mr_n66829056)
print v(xbgr.mr_n66830096)
print v(xbgr.mr_n66830368)
print v(xbgr.mr_n66830640)
print v(xbgr.mr_n66830976)
print v(xbgr.mr_n66831440)
print v(xbgr.mr_n66831792)
print v(xbgr.mr_n66831984)
print v(xbgr.mr_n66832176)
print v(xbgr.mr_n66832368)
print v(xbgr.mr_n66833120)
print v(xbgr.mr_n66836768)
print v(xbgr.mr_n66837120)
print v(xbgr.mr_n66837232)
print v(xbgr.mr_n66837936)
print v(xbgr.mr_n66840112)
print v(xbgr.mr_n66840528)
print v(xbgr.mr_n66840640)
print v(xbgr.mr_n66841344)
print v(xbgr.mr_n66843584)
print v(xbgr.mr_n66843936)
print v(xbgr.mr_n66844048)
print v(xbgr.mr_n66844752)
print v(xbgr.mr_n66846992)
print v(xbgr.mr_n66847344)
print v(xbgr.mr_n66847456)
print v(xbgr.mr_n66848160)
print v(xbgr.mr_n66850336)
print v(xbgr.mr_n66850752)
print v(xbgr.mr_n66850864)
print v(xbgr.mr_n66851568)
print v(xbgr.mr_n66853808)
print v(xbgr.mr_n66854160)
print v(xbgr.mr_n66854272)
print v(xbgr.mr_n66854832)
print v(xbgr.mr_n66854944)
print v(xbgr.mr_n66855632)
print v(xbgr.mr_n66855984)
print v(xbgr.mr_n66856752)
print v(xbgr.mr_n66857168)
print v(xbgr.mr_n66857280)
print v(xbgr.mr_n66857984)
print v(xbgr.mr_n66861264)
print v(xbgr.mr_n66861376)
print v(xbgr.mr_n66861728)
print v(xbgr.mr_n66861840)
print v(xbgr.mr_n66862544)
print v(xbgr.mr_n66864464)
print v(xbgr.mr_n66864784)
print v(xbgr.mr_n66865136)
print v(xbgr.mr_n66865248)
print v(xbgr.mr_n66865952)
print v(xbgr.mr_n66878512)
print v(xbgr.mr_n66878688)
print v(xbgr.mr_n66879312)
print v(xbgr.mr_n66879488)
print v(xbgr.mr_n66880112)
print v(xbgr.mr_n66880288)
print v(xbgr.mr_n66880912)
print v(xbgr.mr_n66881088)
print v(xbgr.mr_n66881712)
print v(xbgr.mr_n66881888)
print v(xbgr.mr_n66882512)
print v(xbgr.mr_n66882688)
print v(xbgr.mr_n66883312)
print v(xbgr.mr_n66883488)
print v(xbgr.mr_n66884112)
print v(xbgr.mr_n66884288)
print v(xbgr.mr_n66884912)
print v(xbgr.mr_n66885088)
print v(xbgr.mr_n66885712)
print v(xbgr.mr_n66885888)
print v(xbgr.mr_n66886512)
print v(xbgr.mr_n66886688)
print v(xbgr.mr_n66887312)
print v(xbgr.mr_n66887488)
print v(xbgr.mr_n66888112)
print v(xbgr.mr_n66888288)
print v(xbgr.mr_n66888912)
print v(xbgr.mr_n66889088)
print v(xbgr.mr_n66889712)
print v(xbgr.mr_n66889888)
print v(xbgr.mr_n66890512)
print v(xbgr.mr_n66890688)
print v(xbgr.mr_n66892032)
print v(xbgr.mr_n66892208)
print v(xbgr.mr_n66893696)
print v(xbgr.mr_n66894032)
print v(xbgr.mr_n66900208)
print v(xbgr.mr_n66902320)
print v(xbgr.mr_n66902624)
print v(xbgr.mr_n66902928)
print v(xbgr.mr_n66903232)
print v(xbgr.mr_n66903616)
print v(xbgr.mr_n66904080)
print v(xbgr.mr_n66904544)
print v(xbgr.mr_n66905008)
print v(xbgr.mr_n66905472)
print v(xbgr.mr_n66905936)
print v(xbgr.mr_n66906400)
print v(xbgr.mr_n66906864)
print v(xbgr.mr_n66907328)
print v(xbgr.mr_n66907792)
print v(xbgr.mr_n66908256)
print v(xbgr.mr_n66908720)
print v(xbgr.mr_n66909184)
print v(xbgr.mr_n66909648)
print v(xbgr.mr_n66910112)
print v(xbgr.mr_n66910576)
print v(xbgr.mr_n66911040)
print v(xbgr.mr_n66911504)
print v(xbgr.mr_n66911968)
print v(xbgr.mr_n66912432)
print v(xbgr.mr_n66912896)
print v(xbgr.mr_n66913360)
print v(xbgr.mr_n66913824)
print v(xbgr.mr_n66914288)
print v(xbgr.mr_n66914752)
print v(xbgr.mr_n66915216)
print v(xbgr.mr_n66922512)
print v(xbgr.mr_n66923024)
print v(xbgr.mr_n66924432)
print v(xbgr.mr_n66936016)
print v(xbgr.mr_n66937792)
print v(xbgr.mr_n66939280)
print v(xbgr.mr_n66939808)
print v(xbgr.mr_n66940272)
print v(xbgr.mr_n66940736)
print v(xbgr.mr_n66941264)
print v(xbgr.mr_n66941856)
print v(xbgr.mr_n66942448)
print v(xbgr.mr_n66943040)
print v(xbgr.mr_n66943632)
print v(xbgr.mr_n66944224)
print v(xbgr.mr_n66944816)
print v(xbgr.mr_n66945408)
print v(xbgr.mr_n66946000)
print v(xbgr.mr_n66946592)
print v(xbgr.mr_n66947184)
print v(xbgr.mr_n66947776)
print v(xbgr.mr_n66948368)
print v(xbgr.mr_n66948960)
print v(xbgr.mr_n66950032)
print v(xbgr.mr_n66950944)
print v(xbgr.mr_n66955728)
print v(xbgr.mr_n66957008)
print v(xbgr.mr_n66967520)
print v(xbgr.mr_n66971488)
print v(xbgr.mr_n66971872)
print v(xbgr.mr_n66972064)
print v(xbgr.mr_n66972320)
print v(xbgr.mr_n66972576)
print v(xbgr.mr_n66974736)
print v(xbgr.mr_n66994016)
print v(xbgr.mr_n66994240)
print v(xbgr.mr_n66998688)
print v(xbgr.mr_n66998800)
print v(xbgr.mr_n67007792)
print v(xbgr.mr_n67008096)
print v(xbgr.mr_n67010656)
print v(xbgr.mr_n67012048)
print v(xbgr.mr_n67020880)
print v(xbgr.mr_n67021664)
print v(xbgr.mr_n67022096)
print v(xbgr.mr_n67022400)
print v(xbgr.mr_n67031632)
print v(xbgr.mr_n67031808)
print v(xbgr.mr_n67032256)
print v(xbgr.mr_n67033712)
print v(xbgr.mr_n67034336)
print v(xbgr.mr_n67035872)
print v(xbgr.mr_n67041376)
print v(xbgr.mr_n67041968)
print v(xbgr.mr_n67042560)
print v(xbgr.mr_n67043152)
print v(xbgr.mr_n67043744)
print v(xbgr.mr_n67044336)
print v(xbgr.mr_n67044928)
print v(xbgr.mr_n67045520)
print v(xbgr.mr_n67046112)
print v(xbgr.mr_n67046704)
print v(xbgr.mr_n67047296)
print v(xbgr.mr_n67047888)
print v(xbgr.mr_n67048416)
print v(xbgr.mr_n67049712)
print v(xbgr.mr_n67050176)
print v(xbgr.mr_n67050640)
print v(xbgr.mr_n67051104)
print v(xbgr.mr_n67051568)
print v(xbgr.mr_n67054656)
print v(xbgr.mr_n67055360)
print v(xbgr.mr_n67055536)
print v(xbgr.mr_n67055712)
print v(xbgr.mr_n67057504)
print v(xbgr.mr_n67061968)
print v(xbgr.mr_n67062304)
print v(xbgr.mr_n67062640)
print v(xbgr.mr_n67064224)
print v(xbgr.mr_n67065120)
print v(xbgr.mr_n67065296)
print v(xbgr.mr_n67065808)
print v(xbgr.mr_n67066304)
print v(xbgr.mr_n67066480)
print v(xbgr.mr_n67066896)
print v(xbgr.mr_n67067408)
print v(xbgr.mr_n67067904)
print v(xbgr.mr_n67068240)
print v(xbgr.mr_n67068752)
print v(xbgr.mr_n67068864)
print v(xbgr.mr_n67068976)
print v(xbgr.mr_n67069968)
print v(xbgr.mr_n67070304)
print v(xbgr.mr_n67070896)
print v(xbgr.mr_n67071392)
print v(xbgr.mr_n67071568)
print v(xbgr.mr_n67071904)
print v(xbgr.mr_n67072496)
print v(xbgr.mr_n67073056)
print v(xbgr.mr_n67073232)
print v(xbgr.mr_n67073728)
print v(xbgr.mr_n67074496)
print v(xbgr.mr_n67074672)
print v(xbgr.mr_n67074848)
print v(xbgr.mr_n67075440)
print v(xbgr.mr_n67075552)
print v(xbgr.mr_n67075664)
print v(xbgr.mr_n67075776)
print v(xbgr.mr_n67077264)
print v(xbgr.mr_n67077440)
print v(xbgr.mr_n67078016)
print v(xbgr.mr_n67078720)
print v(xbgr.mr_n67078896)
print v(xbgr.mr_n67079328)
print v(xbgr.mr_n67079440)
print v(xbgr.mr_n67080272)
print v(xbgr.mr_n67080448)
print v(xbgr.mr_n67080704)
print v(xbgr.mr_n67081280)
print v(xbgr.mr_n67082064)
print v(xbgr.mr_n67082240)
print v(xbgr.mr_n67082672)
print v(xbgr.mr_n67083232)
print v(xbgr.mr_n67083408)
print v(xbgr.mr_n67083904)
print v(xbgr.mr_n67084416)
print v(xbgr.mr_n67084528)
print v(xbgr.mr_n67085232)
print v(xbgr.mr_n67085648)
print v(xbgr.mr_n67086160)
print v(xbgr.mr_n67086656)
print v(xbgr.mr_n67086832)
print v(xbgr.mr_n67087248)
print v(xbgr.mr_n67087760)
print v(xbgr.mr_n67088256)
print v(xbgr.mr_n67088592)
print v(xbgr.mr_n67089104)
print v(xbgr.mr_n67089216)
print v(xbgr.mr_n67089328)
print v(xbgr.mr_n67090448)
print v(xbgr.mr_n67090624)
print v(xbgr.mr_n67090880)
print v(xbgr.mr_n67091456)
print v(xbgr.mr_n67092048)
print v(xbgr.mr_n67092160)
print v(xbgr.mr_n67092352)
print v(xbgr.mr_n67092704)
print v(xbgr.mr_n67092816)
print v(xbgr.mr_n67093328)
print v(xbgr.mr_n67093440)
print v(xbgr.mr_n67093552)
print v(xbgr.mr_n67093904)
print v(xbgr.mr_n67094240)
print v(xbgr.mr_n67095184)
print v(xbgr.mr_n67095600)
print v(xbgr.mr_n67095712)
print v(xbgr.mr_n67096272)
print v(xbgr.mr_n67096528)
print v(xbgr.mr_n67097344)
print v(xbgr.mr_n67097776)
print v(xbgr.mr_n67097952)
print v(xbgr.mr_n67098880)
print v(xbgr.mr_n67099056)
print v(xbgr.mr_n67099632)
print v(xbgr.mr_n67099744)
print v(xbgr.mr_n67099856)
print v(xbgr.mr_n67100624)
print v(xbgr.mr_n67100960)
print v(xbgr.mr_n67101904)
print v(xbgr.mr_n67102320)
print v(xbgr.mr_n67102432)
print v(xbgr.mr_n67102992)
print v(xbgr.mr_n67103248)
print v(xbgr.mr_n67104192)
print v(xbgr.mr_n67104608)
print v(xbgr.mr_n67104720)
print v(xbgr.mr_n67104832)
print v(xbgr.mr_n67105600)
print v(xbgr.mr_n67105936)
print v(xbgr.mr_n67106944)
print v(xbgr.mr_n67107120)
print v(xbgr.mr_n67107696)
print v(xbgr.mr_n67108128)
print v(xbgr.mr_n67108304)
print v(xbgr.mr_n67109040)
print v(xbgr.mr_n67109152)
print v(xbgr.mr_n67109712)
print v(xbgr.mr_n67109968)
print v(xbgr.mr_n67110912)
print v(xbgr.mr_n67111328)
print v(xbgr.mr_n67111440)
print v(xbgr.mr_n67111552)
print v(xbgr.mr_n67112320)
print v(xbgr.mr_n67112656)
print v(xbgr.mr_n67113472)
print v(xbgr.mr_n67113584)
print v(xbgr.mr_n67114144)
print v(xbgr.mr_n67114400)
print v(xbgr.mr_n67115344)
print v(xbgr.mr_n67115760)
print v(xbgr.mr_n67115872)
print v(xbgr.mr_n67116432)
print v(xbgr.mr_n67116688)
print v(xbgr.mr_n67117504)
print v(xbgr.mr_n67117824)
print v(xbgr.mr_n67117936)
print v(xbgr.mr_n67118112)
print v(xbgr.mr_n67119936)
print v(xbgr.mr_n67122176)
print v(xbgr.mr_n67125184)
print v(xbgr.mr_n67125296)
print v(xbgr.mr_n67125920)
print v(xbgr.mr_n67126384)
print v(xbgr.mr_n67126848)
print v(xbgr.mr_n67127312)
print v(xbgr.mr_n67127776)
print v(xbgr.mr_n67128224)
print v(xbgr.mr_n67128688)
print v(xbgr.mr_n67129152)
print v(xbgr.mr_n67129616)
print v(xbgr.mr_n67130080)
print v(xbgr.mr_n67130544)
print v(xbgr.mr_n67131008)
print v(xbgr.mr_n67131472)
print v(xbgr.mr_n67131936)
print v(xbgr.mr_n67132400)
print v(xbgr.mr_n67132864)
print v(xbgr.mr_n67133328)
print v(xbgr.mr_n67133792)
print v(xbgr.mr_n67134256)
print v(xbgr.mr_n67137392)
print v(xbgr.mr_n67140000)
print v(xbgr.mr_n67143328)
print v(xbgr.mr_n67150976)
print v(xbgr.mr_n67151936)
print v(xbgr.mr_n67153104)
print v(xbgr.mr_n67160160)
print v(xbgr.mr_n67166416)
print v(xbgr.mr_n67168320)
print v(xbgr.mr_n67173088)
print v(xbgr.mr_n67174944)
print v(xbgr.mr_n67177952)
print v(xbgr.mr_n67178208)
print v(xbgr.mr_n67178544)
print v(xbgr.mr_n67178880)
print v(xbgr.mr_n67180768)
print v(xbgr.mr_n67181552)
print v(xbgr.mr_n67181664)
print v(xbgr.mr_n67183520)
print v(xbgr.mr_n67183632)
print v(xbgr.mr_n67185328)
print v(xbgr.mr_n67185440)
print v(xbgr.mr_n67187136)
print v(xbgr.mr_n67187248)
print v(xbgr.mr_n67188944)
print v(xbgr.mr_n67189056)
print v(xbgr.mr_n67190752)
print v(xbgr.mr_n67190864)
print v(xbgr.mr_n67192560)
print v(xbgr.mr_n67192672)
print v(xbgr.mr_n67194368)
print v(xbgr.mr_n67194480)
print v(xbgr.mr_n67196176)
print v(xbgr.mr_n67196288)
print v(xbgr.mr_n67197984)
print v(xbgr.mr_n67198096)
print v(xbgr.mr_n67199792)
print v(xbgr.mr_n67199904)
print v(xbgr.mr_n67201600)
print v(xbgr.mr_n67201712)
print v(xbgr.mr_n67203408)
print v(xbgr.mr_n67203520)
print v(xbgr.mr_n67205216)
print v(xbgr.mr_n67205328)
print v(xbgr.mr_n67207024)
print v(xbgr.mr_n67207136)
print v(xbgr.mr_n67208832)
print v(xbgr.mr_n67208944)
print v(xbgr.mr_n67210640)
print v(xbgr.mr_n67210752)
print v(xbgr.mr_n67211632)
print v(xbgr.mr_n67216048)
print v(xbgr.mr_n67217904)
print v(xbgr.mr_n67219440)
print v(xbgr.mr_n67220032)
print v(xbgr.mr_n67223024)
print v(xbgr.mr_n67230512)
print v(xbgr.mr_n67232656)
print v(xbgr.mr_n67233856)
print v(xbgr.mr_n67236752)
print v(xbgr.mr_n67237216)
print v(xbgr.mr_n67237328)
print v(xbgr.mr_n67238144)
print v(xbgr.mr_n67238608)
print v(xbgr.mr_n67238720)
print v(xbgr.mr_n67239536)
print v(xbgr.mr_n67240064)
print v(xbgr.mr_n67240240)
print v(xbgr.mr_n67241184)
print v(xbgr.mr_n67241840)
print v(xbgr.mr_n67242016)
print v(xbgr.mr_n67242960)
print v(xbgr.mr_n67243616)
print v(xbgr.mr_n67243792)
print v(xbgr.mr_n67244736)
print v(xbgr.mr_n67245392)
print v(xbgr.mr_n67245568)
print v(xbgr.mr_n67246512)
print v(xbgr.mr_n67247168)
print v(xbgr.mr_n67247344)
print v(xbgr.mr_n67248288)
print v(xbgr.mr_n67248944)
print v(xbgr.mr_n67249120)
print v(xbgr.mr_n67250064)
print v(xbgr.mr_n67250720)
print v(xbgr.mr_n67250896)
print v(xbgr.mr_n67251840)
print v(xbgr.mr_n67252432)
print v(xbgr.mr_n67253024)
print v(xbgr.mr_n67253616)
print v(xbgr.mr_n67254208)
print v(xbgr.mr_n67254800)
print v(xbgr.mr_n67255392)
print v(xbgr.mr_n67255984)
print v(xbgr.mr_n67256576)
print v(xbgr.mr_n67257168)
print v(xbgr.mr_n67257760)
print v(xbgr.mr_n67258352)
print v(xbgr.mr_n67258944)
print v(xbgr.mr_n67259536)
print v(xbgr.mr_n67260128)
print v(xbgr.mr_n67260368)
print v(xbgr.mr_n67260480)
print v(xbgr.mr_n67260592)
print v(xbgr.mr_n67260704)
print v(xbgr.mr_n67261296)
print v(xbgr.mr_n67261568)
print v(xbgr.mr_n67262192)
print v(xbgr.mr_n67263232)
print v(xbgr.mr_n67264144)
print v(xbgr.mr_n67264736)
print v(xbgr.mr_n67265328)
print v(xbgr.mr_n67265920)
print v(xbgr.mr_n67266512)
print v(xbgr.mr_n67267104)
print v(xbgr.mr_n67267696)
print v(xbgr.mr_n67268288)
print v(xbgr.mr_n67268880)
print v(xbgr.mr_n67269856)
print v(xbgr.mr_n67271456)
print v(xbgr.mr_n67273888)
print v(xbgr.mr_n67276192)
print v(xbgr.mr_n67280096)
print v(xbgr.mr_n67282016)
print v(xbgr.mr_n67285440)
print v(xbgr.mr_n67285776)
print v(xbgr.mr_n67286352)
print v(xbgr.mr_n67286944)
print v(xbgr.mr_n67287056)
print v(xbgr.mr_n67288752)
print v(xbgr.mr_n67288864)
print v(xbgr.mr_n67290560)
print v(xbgr.mr_n67290672)
print v(xbgr.mr_n67292368)
print v(xbgr.mr_n67292480)
print v(xbgr.mr_n67294176)
print v(xbgr.mr_n67294288)
print v(xbgr.mr_n67295984)
print v(xbgr.mr_n67296096)
print v(xbgr.mr_n67297792)
print v(xbgr.mr_n67297904)
print v(xbgr.mr_n67299600)
print v(xbgr.mr_n67299712)
print v(xbgr.mr_n67301408)
print v(xbgr.mr_n67301520)
print v(xbgr.mr_n67303216)
print v(xbgr.mr_n67303328)
print v(xbgr.mr_n67305024)
print v(xbgr.mr_n67305136)
print v(xbgr.mr_n67305248)
print v(xbgr.mr_n67307088)
print v(xbgr.mr_n67307200)
print v(xbgr.mr_n67307312)
print v(xbgr.mr_n67309152)
print v(xbgr.mr_n67309264)
print v(xbgr.mr_n67309376)
print v(xbgr.mr_n67311216)
print v(xbgr.mr_n67311328)
print v(xbgr.mr_n67311440)
print v(xbgr.mr_n67313280)
print v(xbgr.mr_n67313392)
print v(xbgr.mr_n67313504)
print v(xbgr.mr_n67315344)
print v(xbgr.mr_n67315456)
print v(xbgr.mr_n67315568)
print v(xbgr.mr_n67317408)
print v(xbgr.mr_n67317520)
print v(xbgr.mr_n67317632)
print v(xbgr.mr_n67318544)
print v(xbgr.mr_n67318896)
print v(xbgr.mr_n67319408)
print v(xbgr.mr_n67319952)
print v(xbgr.mr_n67320496)
print v(xbgr.mr_n67321040)
print v(xbgr.mr_n67321584)
print v(xbgr.mr_n67322128)
print v(xbgr.mr_n67322672)
print v(xbgr.mr_n67323216)
print v(xbgr.mr_n67323760)
print v(xbgr.mr_n67324304)
print v(xbgr.mr_n67324848)
print v(xbgr.mr_n67325392)
print v(xbgr.mr_n67325936)
print v(xbgr.mr_n67326480)
print v(xbgr.mr_n67327024)
print v(xbgr.mr_n67327568)
print v(xbgr.mr_n67328112)
print v(xbgr.mr_n67328656)
print v(xbgr.mr_n67329200)
print v(xbgr.mr_n67329744)
print v(xbgr.mr_n67330288)
print v(xbgr.mr_n67330752)
print v(xbgr.mr_n67331296)
print v(xbgr.mr_n67331840)
print v(xbgr.mr_n67332384)
print v(xbgr.mr_n67332928)
print v(xbgr.mr_n67333600)
print v(xbgr.mr_n67333904)
print v(xbgr.mr_n67334288)
print v(xbgr.mr_n67334752)
print v(xbgr.mr_n67335216)
print v(xbgr.mr_n67335680)
print v(xbgr.mr_n67336144)
print v(xbgr.mr_n67336608)
print v(xbgr.mr_n67337072)
print v(xbgr.mr_n67337536)
print v(xbgr.mr_n67338000)
print v(xbgr.mr_n67338464)
print v(xbgr.mr_n67338928)
print v(xbgr.mr_n67339392)
print v(xbgr.mr_n67339856)
print v(xbgr.mr_n67340320)
print v(xbgr.mr_n67340784)
print v(xbgr.mr_n67341248)
print v(xbgr.mr_n67341712)
print v(xbgr.mr_n67342176)
print v(xbgr.mr_n67342640)
print v(xbgr.mr_n67343104)
print v(xbgr.mr_n67343568)
print v(xbgr.mr_n67344064)
print v(xbgr.mr_n67344656)
print v(xbgr.mr_n67345248)
print v(xbgr.mr_n67345840)
print v(xbgr.mr_n67346432)
print v(xbgr.mr_n67347024)
print v(xbgr.mr_n67347616)
print v(xbgr.mr_n67350416)
print v(xbgr.mr_n67350864)
print v(xbgr.mr_n67351248)
print v(xbgr.mr_n67351936)
print v(xbgr.mr_n67352176)
print v(xbgr.mr_n67352736)
print v(xbgr.mr_n67355408)
print v(xbgr.mr_n67360560)
print v(xbgr.mr_n67361616)
print v(xbgr.mr_n67368576)
print v(xbgr.mr_n67373984)
print v(xbgr.mr_n67380976)
print v(xbgr.mr_n67382656)
print v(xbgr.mr_n67382944)
print v(xbgr.mr_n67383120)
print v(xbgr.mr_n67387792)
print v(xbgr.mr_n67390480)
print v(xbgr.mr_n67395728)
print v(xbgr.mr_n67396368)
print v(xbgr.mr_n67401936)
print v(xbgr.mr_n67402176)
print v(xbgr.mr_n67402352)
print v(xbgr.mr_n67402464)
print v(xbgr.mr_n67403168)
print v(xbgr.mr_n67406304)
print v(xbgr.mr_n67406480)
print v(xbgr.mr_n67408000)
print v(xbgr.mr_n67409520)
print v(xbgr.mr_n67411872)
print v(xbgr.mr_n67412432)
print v(xbgr.mr_n67412768)
print v(xbgr.mr_n67413072)
print v(xbgr.mr_n67413696)
print v(xbgr.mr_n67414384)
print v(xbgr.mr_n67414656)
print v(xbgr.mr_n67419696)
print v(xbgr.mr_n67420352)
print v(xbgr.mr_n67422224)
print v(xbgr.mr_n67422736)
print v(xbgr.mr_n67423184)
print v(xbgr.mr_n67423360)
print v(xbgr.mr_n67426912)
print v(xbgr.mr_n67428400)
print v(xbgr.mr_n67428576)
print v(xbgr.mr_n67429776)
print v(xbgr.mr_n67430400)
print v(xbgr.mr_n67439888)
print v(xbgr.mr_n67442304)
print v(xbgr.mr_n67444064)
print v(xbgr.mr_n67445888)
print v(xbgr.mr_n67448928)
print v(xbgr.mr_n67450864)
print v(xbgr.mr_n67453472)
print v(xbgr.mr_n67458000)
print v(xbgr.mr_n67458336)
print v(xbgr.mr_n67458672)
print v(xbgr.mr_n67459008)
print v(xbgr.mr_n67459424)
print v(xbgr.mr_n67459664)
print v(xbgr.mr_n67459968)
print v(xbgr.mr_n67460560)
print v(xbgr.mr_n67460672)
print v(xbgr.mr_n67460784)
print v(xbgr.mr_n67462624)
print v(xbgr.mr_n67462736)
print v(xbgr.mr_n67462848)
print v(xbgr.mr_n67464688)
print v(xbgr.mr_n67464800)
print v(xbgr.mr_n67464912)
print v(xbgr.mr_n67466752)
print v(xbgr.mr_n67466864)
print v(xbgr.mr_n67466976)
print v(xbgr.mr_n67468816)
print v(xbgr.mr_n67468928)
print v(xbgr.mr_n67469040)
print v(xbgr.mr_n67470880)
print v(xbgr.mr_n67470992)
print v(xbgr.mr_n67471104)
print v(xbgr.mr_n67472944)
print v(xbgr.mr_n67473056)
print v(xbgr.mr_n67473168)
print v(xbgr.mr_n67475008)
print v(xbgr.mr_n67475120)
print v(xbgr.mr_n67475232)
print v(xbgr.mr_n67477072)
print v(xbgr.mr_n67477184)
print v(xbgr.mr_n67477296)
print v(xbgr.mr_n67479136)
print v(xbgr.mr_n67479248)
print v(xbgr.mr_n67479360)
print v(xbgr.mr_n67481200)
print v(xbgr.mr_n67481312)
print v(xbgr.mr_n67481424)
print v(xbgr.mr_n67483264)
print v(xbgr.mr_n67483376)
print v(xbgr.mr_n67483488)
print v(xbgr.mr_n67485328)
print v(xbgr.mr_n67485440)
print v(xbgr.mr_n67485552)
print v(xbgr.mr_n67488096)
print v(xbgr.mr_n67488208)
print v(xbgr.mr_n67488576)
print v(xbgr.mr_n67492080)
print v(xbgr.mr_n67492192)
print v(xbgr.mr_n67492560)
print v(xbgr.mr_n67496064)
print v(xbgr.mr_n67496176)
print v(xbgr.mr_n67496544)
print v(xbgr.mr_n67500048)
print v(xbgr.mr_n67500160)
print v(xbgr.mr_n67500528)
print v(xbgr.mr_n67500960)
print v(xbgr.mr_n67501856)
print v(xbgr.mr_n67503120)
print v(xbgr.mr_n67503232)
print v(xbgr.mr_n67504736)
print v(xbgr.mr_n67505456)
print v(xbgr.mr_n67505632)
print v(xbgr.mr_n67507200)
print v(xbgr.mr_n67508016)
print v(xbgr.mr_n67508192)
print v(xbgr.mr_n67508688)
print v(xbgr.mr_n67509760)
print v(xbgr.mr_n67510576)
print v(xbgr.mr_n67510752)
print v(xbgr.mr_n67512320)
print v(xbgr.mr_n67513136)
print v(xbgr.mr_n67513312)
print v(xbgr.mr_n67514880)
print v(xbgr.mr_n67515696)
print v(xbgr.mr_n67515872)
print v(xbgr.mr_n67517440)
print v(xbgr.mr_n67518256)
print v(xbgr.mr_n67518432)
print v(xbgr.mr_n67518608)
print v(xbgr.mr_n67520000)
print v(xbgr.mr_n67520816)
print v(xbgr.mr_n67520992)
print v(xbgr.mr_n67522560)
print v(xbgr.mr_n67523376)
print v(xbgr.mr_n67523552)
print v(xbgr.mr_n67525120)
print v(xbgr.mr_n67525936)
print v(xbgr.mr_n67526112)
print v(xbgr.mr_n67527680)
print v(xbgr.mr_n67528496)
print v(xbgr.mr_n67528672)
print v(xbgr.mr_n67529360)
print v(xbgr.mr_n67530240)
print v(xbgr.mr_n67530736)
print v(xbgr.mr_n67530848)
print v(xbgr.mr_n67531488)
print v(xbgr.mr_n67531760)
print v(xbgr.mr_n67533344)
print v(xbgr.mr_n67533840)
print v(xbgr.mr_n67533952)
print v(xbgr.mr_n67535456)
print v(xbgr.mr_n67535952)
print v(xbgr.mr_n67536064)
print v(xbgr.mr_n67538720)
print v(xbgr.mr_n67539888)
print v(xbgr.mr_n67540064)
print v(xbgr.mr_n67541632)
print v(xbgr.mr_n67542448)
print v(xbgr.mr_n67542624)
print v(xbgr.mr_n67543264)
print v(xbgr.mr_n67544192)
print v(xbgr.mr_n67545008)
print v(xbgr.mr_n67545184)
print v(xbgr.mr_n67545568)
print v(xbgr.mr_n67546752)
print v(xbgr.mr_n67547568)
print v(xbgr.mr_n67547744)
print v(xbgr.mr_n67549312)
print v(xbgr.mr_n67550128)
print v(xbgr.mr_n67550304)
print v(xbgr.mr_n67550800)
print v(xbgr.mr_n67551872)
print v(xbgr.mr_n67552688)
print v(xbgr.mr_n67552864)
print v(xbgr.mr_n67554432)
print v(xbgr.mr_n67555248)
print v(xbgr.mr_n67555424)
print v(xbgr.mr_n67556992)
print v(xbgr.mr_n67557808)
print v(xbgr.mr_n67557984)
print v(xbgr.mr_n67559552)
print v(xbgr.mr_n67559792)
print v(xbgr.mr_n67560368)
print v(xbgr.mr_n67560544)
print v(xbgr.mr_n67562112)
print v(xbgr.mr_n67562928)
print v(xbgr.mr_n67563104)
print v(xbgr.mr_n67563872)
print v(xbgr.mr_n67564672)
print v(xbgr.mr_n67565488)
print v(xbgr.mr_n67565664)
print v(xbgr.mr_n67567232)
print v(xbgr.mr_n67568048)
print v(xbgr.mr_n67568224)
print v(xbgr.mr_n67568528)
print v(xbgr.mr_n67569792)
print v(xbgr.mr_n67648160)
print v(xbgr.mr_n67660256)
print v(xbgr.mr_n67675808)
print v(xbgr.mr_n67680784)
print v(xbgr.mr_n67680960)
print v(xbgr.mr_n67681136)
print v(xbgr.mr_n67682976)
print v(xbgr.mr_n67683888)
print v(xbgr.mr_n67684576)
print v(xbgr.mr_n67685136)
print v(xbgr.mr_n67685312)
print v(xbgr.mr_n67685760)
print v(xbgr.mr_n67686912)
print v(xbgr.mr_n67688160)
print v(xbgr.mr_n67688688)
print v(xbgr.mr_n67689760)
print v(xbgr.mr_n67689936)
print v(xbgr.mr_n67690112)
print v(xbgr.mr_n67787344)
print v(xbgr.mr_n67789104)
print v(xbgr.mr_n67789216)
print v(xbgr.mr_n67789648)
print v(xbgr.mr_n67789760)
print v(xbgr.mr_n67790192)
print v(xbgr.mr_n67790304)
print v(xbgr.mr_n67790736)
print v(xbgr.mr_n67790848)
print v(xbgr.mr_n67791280)
print v(xbgr.mr_n67791392)
print v(xbgr.mr_n67791824)
print v(xbgr.mr_n67791936)
print v(xbgr.mr_n67792368)
print v(xbgr.mr_n67792480)
print v(xbgr.mr_n67792912)
print v(xbgr.mr_n67793024)
print v(xbgr.mr_n67793456)
print v(xbgr.mr_n67793568)
print v(xbgr.mr_n67794000)
print v(xbgr.mr_n67794112)
print v(xbgr.mr_n67794544)
print v(xbgr.mr_n67794656)
print v(xbgr.mr_n67795328)
print v(xbgr.mr_n67795440)
print v(xbgr.mr_n67796272)
print v(xbgr.mr_n67796384)
print v(xbgr.mr_n67797216)
print v(xbgr.mr_n67797328)
print v(xbgr.mr_n67797600)
print v(xbgr.mr_n67798160)
print v(xbgr.mr_n67798272)
print v(xbgr.mr_n67799104)
print v(xbgr.mr_n67799216)
print v(xbgr.mr_n67800048)
print v(xbgr.mr_n67800160)
print v(xbgr.mr_n67800656)
print v(xbgr.mr_n67801200)
print v(xbgr.mr_n67801392)
print v(xbgr.mr_n67802640)
print v(xbgr.mr_n67803392)
print v(xbgr.mr_n67803648)
print v(xbgr.mr_n67804336)
print v(xbgr.mr_n67807296)
print v(xbgr.mr_n67809200)
print v(xbgr.mr_n67810160)
print v(xbgr.mr_n67814480)
print v(xbgr.mr_n67814672)
print v(xbgr.mr_n67817216)
print v(xbgr.mr_n67818832)
print v(xbgr.mr_n67820512)
print v(xbgr.mr_n67822768)
print v(xbgr.mr_n67825024)
print v(xbgr.mr_n67827280)
print v(xbgr.mr_n67829536)
print v(xbgr.mr_n67831792)
print v(xbgr.mr_n67834048)
print v(xbgr.mr_n67836304)
print v(xbgr.mr_n67850128)
print v(xbgr.mr_n67854448)
print v(xbgr.mr_n67855808)
print v(xbgr.mr_n67855920)
print v(xbgr.mr_n67856272)
print v(xbgr.mr_n67861360)
print v(xbgr.mr_n67862512)
print v(xbgr.mr_n67862624)
print v(xbgr.mr_n67863248)
print v(xbgr.mr_n67864784)
print v(xbgr.mr_n67865648)
print v(xbgr.mr_n67866608)
print v(xbgr.mr_n67866720)
print v(xbgr.mr_n67867664)
print v(xbgr.mr_n67868816)
print v(xbgr.mr_n67868928)
print v(xbgr.mr_n67869552)
print v(xbgr.mr_n67871088)
print v(xbgr.mr_n67871952)
print v(xbgr.mr_n67872912)
print v(xbgr.mr_n67873024)
print v(xbgr.mr_n67873968)
print v(xbgr.mr_n67875120)
print v(xbgr.mr_n67875232)
print v(xbgr.mr_n67875856)
print v(xbgr.mr_n67877392)
print v(xbgr.mr_n67878256)
print v(xbgr.mr_n67879216)
print v(xbgr.mr_n67879328)
print v(xbgr.mr_n67880272)
print v(xbgr.mr_n67881424)
print v(xbgr.mr_n67881536)
print v(xbgr.mr_n67882160)
print v(xbgr.mr_n67883696)
print v(xbgr.mr_n67884560)
print v(xbgr.mr_n67885520)
print v(xbgr.mr_n67885632)
print v(xbgr.mr_n67886576)
print v(xbgr.mr_n67887728)
print v(xbgr.mr_n67887840)
print v(xbgr.mr_n67888464)
print v(xbgr.mr_n67890000)
print v(xbgr.mr_n67890864)
print v(xbgr.mr_n67891824)
print v(xbgr.mr_n67891936)
print v(xbgr.mr_n67892880)
print v(xbgr.mr_n67894032)
print v(xbgr.mr_n67894144)
print v(xbgr.mr_n67894768)
print v(xbgr.mr_n67896944)
print v(xbgr.mr_n67897280)
print v(xbgr.mr_n67899200)
print v(xbgr.mr_n67899760)
print v(xbgr.mr_n67900448)
print v(xbgr.mr_n67901200)
print v(xbgr.mr_n67902144)
print v(xbgr.mr_n67903088)
print v(xbgr.mr_n67904032)
print v(xbgr.mr_n67904976)
print v(xbgr.mr_n67905920)
print v(xbgr.mr_n67906864)
print v(xbgr.mr_n67907808)
print v(xbgr.mr_n67908752)
print v(xbgr.mr_n67909696)
print v(xbgr.mr_n67910640)
print v(xbgr.mr_n67911584)
print v(xbgr.mr_n67912528)
print v(xbgr.mr_n67913472)
print v(xbgr.mr_n67914416)
print v(xbgr.mr_n67915360)
print v(xbgr.mr_n67916304)
print v(xbgr.mr_n67917248)
print v(xbgr.mr_n67918192)
print v(xbgr.mr_n67919136)
print v(xbgr.mr_n67920080)
print v(xbgr.mr_n67921024)
print v(xbgr.mr_n67921968)
print v(xbgr.mr_n67922912)
print v(xbgr.mr_n67923856)
print v(xbgr.mr_n67924800)
print v(xbgr.mr_n67925744)
print v(xbgr.mr_n67926688)
print v(xbgr.mr_n67927632)
print v(xbgr.mr_n67928576)
print v(xbgr.mr_n67929520)
print v(xbgr.mr_n67930464)
print v(xbgr.mr_n67931408)
print v(xbgr.mr_n67934656)
print v(xbgr.mr_n67936224)
print v(xbgr.mr_n67936512)
print v(xbgr.mr_n67936992)
print v(xbgr.mr_n67937904)
print v(xbgr.mr_n67939312)
print v(xbgr.mr_n67939424)
print v(xbgr.mr_n67942368)
print v(xbgr.mr_n67942480)
print v(xbgr.mr_n67943632)
print v(xbgr.mr_n67943744)
print v(xbgr.mr_n67944896)
print v(xbgr.mr_n67945008)
print v(xbgr.mr_n67946160)
print v(xbgr.mr_n67946272)
print v(xbgr.mr_n67947424)
print v(xbgr.mr_n67947536)
print v(xbgr.mr_n67948688)
print v(xbgr.mr_n67948800)
print v(xbgr.mr_n67963152)
print v(xbgr.mr_n67963296)
print v(xbgr.mr_n67966832)
print v(xbgr.mr_n67967088)
print v(xbgr.mr_n67967344)
print v(xbgr.mr_n67967600)
print v(xbgr.mr_n67970192)
print v(xbgr.mr_n67970304)
print v(xbgr.mr_n67971376)
print v(xbgr.mr_n67974512)
print v(xbgr.mr_n67978544)
print v(xbgr.mr_n67979792)
print v(xbgr.mr_n67979904)
print v(xbgr.mr_n67981904)
print v(xbgr.mr_n67982240)
print v(xbgr.mr_n67983648)
print v(xbgr.mr_n67983840)
print v(xbgr.mr_n67984032)
print v(xbgr.mr_n67987344)
print v(xbgr.mr_n67987536)
print v(xbgr.mr_n67991680)
print v(xbgr.mr_n67991952)
print v(xbgr.mr_n67992144)
print v(xbgr.mr_n67995376)
print v(xbgr.mr_n67995568)
print v(xbgr.mr_n67998320)
print v(xbgr.mr_n68000048)
print v(xbgr.mr_n68000240)
print v(xbgr.mr_n68003408)
print v(xbgr.mr_n68003600)
print v(xbgr.mr_n68006352)
print v(xbgr.mr_n68008080)
print v(xbgr.mr_n68008272)
print v(xbgr.mr_n68011200)
print v(xbgr.mr_n68011936)
print v(xbgr.mr_n68013184)
print v(xbgr.mr_n68013296)
print v(xbgr.mr_n68016336)
print v(xbgr.mr_n68016528)
print v(xbgr.mr_n68016720)
print v(xbgr.mr_n68017968)
print v(xbgr.mr_n68018080)
print v(xbgr.mr_n68019696)
print v(xbgr.mr_n68022496)
print v(xbgr.mr_n68023744)
print v(xbgr.mr_n68023856)
print v(xbgr.mr_n68028032)
print v(xbgr.mr_n68028304)
print v(xbgr.mr_n68031680)
print v(xbgr.mr_n68035792)
print v(xbgr.mr_n68036624)
print v(xbgr.mr_n68036736)
print v(xbgr.mr_n68037568)
print v(xbgr.mr_n68037680)
print v(xbgr.mr_n68038512)
print v(xbgr.mr_n68038624)
print v(xbgr.mr_n68039712)
print v(xbgr.mr_n68039824)
print v(xbgr.mr_n68040976)
print v(xbgr.mr_n68041088)
print v(xbgr.mr_n68042240)
print v(xbgr.mr_n68042352)
print v(xbgr.mr_n68043504)
print v(xbgr.mr_n68043616)
print v(xbgr.mr_n68044768)
print v(xbgr.mr_n68044880)
print v(xbgr.mr_n68046032)
print v(xbgr.mr_n68046144)
print v(xbgr.mr_n68047296)
print v(xbgr.mr_n68047408)
print v(xbgr.mr_n68048560)
print v(xbgr.mr_n68048672)
print v(xbgr.mr_n68049824)
print v(xbgr.mr_n68049936)
print v(xbgr.mr_n68051088)
print v(xbgr.mr_n68051200)
print v(xbgr.mr_n68052352)
print v(xbgr.mr_n68052464)
print v(xbgr.mr_n68053616)
print v(xbgr.mr_n68053728)
print v(xbgr.mr_n68057120)
print v(xbgr.mr_n68061136)
print v(xbgr.mr_n68061824)
print v(xbgr.mr_n68062512)
print v(xbgr.mr_n68063232)
print v(xbgr.mr_n68064848)
print v(xbgr.mr_n68066128)
print v(xbgr.mr_n68066240)
print v(xbgr.mr_n68067184)
print v(xbgr.mr_n68068272)
print v(xbgr.mr_n68068384)
print v(xbgr.mr_n68070608)
print v(xbgr.mr_n68071152)
print v(xbgr.mr_n68072176)
print v(xbgr.mr_n68072880)
print v(xbgr.mr_n68073280)
print v(xbgr.mr_n68074064)
print v(xbgr.mr_n68076368)
print v(xbgr.mr_n68076912)
print v(xbgr.mr_n68078256)
print v(xbgr.mr_n68078800)
print v(xbgr.mr_n68080144)
print v(xbgr.mr_n68080688)
print v(xbgr.mr_n68082032)
print v(xbgr.mr_n68082576)
print v(xbgr.mr_n68083920)
print v(xbgr.mr_n68084464)
print v(xbgr.mr_n68085808)
print v(xbgr.mr_n68086352)
print v(xbgr.mr_n68087696)
print v(xbgr.mr_n68088240)
print v(xbgr.mr_n68088896)
print v(xbgr.mr_n68089584)
print v(xbgr.mr_n68090448)
print v(xbgr.mr_n68091408)
print v(xbgr.mr_n68091520)
print v(xbgr.mr_n68092464)
print v(xbgr.mr_n68093616)
print v(xbgr.mr_n68093728)
print v(xbgr.mr_n68094672)
print v(xbgr.mr_n68095824)
print v(xbgr.mr_n68095936)
print v(xbgr.mr_n68100208)
print v(xbgr.mr_n68109648)
print v(xbgr.mr_n68111856)
print v(xbgr.mr_n68112544)
print v(xbgr.mr_n68113232)
print v(xbgr.mr_n68113952)
print v(xbgr.mr_n68114896)
print v(xbgr.mr_n68115088)
print v(xbgr.mr_n68115280)
print v(xbgr.mr_n68115472)
print v(xbgr.mr_n68115664)
print v(xbgr.mr_n68115856)
print v(xbgr.mr_n68118000)
print v(xbgr.mr_n68118112)
print v(xbgr.mr_n68120128)
print v(xbgr.mr_n68122144)
print v(xbgr.mr_n68122256)
print v(xbgr.mr_n68127904)
print v(xbgr.mr_n68128848)
print v(xbgr.mr_n68140368)
print v(xbgr.mr_n68141376)
print v(xbgr.mr_n68143872)
print v(xbgr.mr_n68144816)
print v(xbgr.mr_n68145760)
print v(xbgr.mr_n68146704)
print v(xbgr.mr_n68147648)
print v(xbgr.mr_n68148592)
print v(xbgr.mr_n68149536)
print v(xbgr.mr_n68150480)
print v(xbgr.mr_n68156176)
print v(xbgr.mr_n68156368)
print v(xbgr.mr_n68157056)
print v(xbgr.mr_n68157568)
print v(xbgr.mr_n68159184)
print v(xbgr.mr_n68159376)
print v(xbgr.mr_n68160208)
print v(xbgr.mr_n68160720)
print v(xbgr.mr_n68162480)
print v(xbgr.mr_n68162672)
print v(xbgr.mr_n68163360)
print v(xbgr.mr_n68163872)
print v(xbgr.mr_n68165488)
print v(xbgr.mr_n68165680)
print v(xbgr.mr_n68166512)
print v(xbgr.mr_n68167024)
print v(xbgr.mr_n68168784)
print v(xbgr.mr_n68168976)
print v(xbgr.mr_n68169664)
print v(xbgr.mr_n68170176)
print v(xbgr.mr_n68171792)
print v(xbgr.mr_n68171984)
print v(xbgr.mr_n68172816)
print v(xbgr.mr_n68173328)
print v(xbgr.mr_n68174880)
print v(xbgr.mr_n68175408)
print v(xbgr.mr_n68175968)
print v(xbgr.mr_n68176480)
print v(xbgr.mr_n68178096)
print v(xbgr.mr_n68178288)
print v(xbgr.mr_n68179120)
print v(xbgr.mr_n68179552)
print v(xbgr.mr_n68180384)
print v(xbgr.mr_n68181088)
print v(xbgr.mr_n68181648)
print v(xbgr.mr_n68182224)
print v(xbgr.mr_n68182912)
print v(xbgr.mr_n68183344)
print v(xbgr.mr_n68184176)
print v(xbgr.mr_n68184880)
print v(xbgr.mr_n68185440)
print v(xbgr.mr_n68185872)
print v(xbgr.mr_n68186704)
print v(xbgr.mr_n68187280)
print v(xbgr.mr_n68187968)
print v(xbgr.mr_n68191088)
print v(xbgr.mr_n68191776)
print v(xbgr.mr_n68194432)
print v(xbgr.mr_n68194624)
print v(xbgr.mr_n68195312)
print v(xbgr.mr_n68195504)
print v(xbgr.mr_n68196080)
print v(xbgr.mr_n68196192)
print v(xbgr.mr_n68198096)
print v(xbgr.mr_n68198784)
print v(xbgr.mr_n68199168)
print v(xbgr.mr_n68199744)
print v(xbgr.mr_n68199856)
print v(xbgr.mr_n68200160)
print v(xbgr.mr_n68200352)
print v(xbgr.mr_n68200544)
print v(xbgr.mr_n68202864)
print v(xbgr.mr_n68203136)
print v(xbgr.mr_n68203328)
print v(xbgr.mr_n68203840)
print v(xbgr.mr_n68205328)
print v(xbgr.mr_n68205840)
print v(xbgr.mr_n68206592)
print v(xbgr.mr_n68206784)
print v(xbgr.mr_n68207296)
print v(xbgr.mr_n68207408)
print v(xbgr.mr_n68207616)
print v(xbgr.mr_n68207824)
print v(xbgr.mr_n68208368)
print v(xbgr.mr_n68210384)
print v(xbgr.mr_n68210720)
print v(xbgr.mr_n68210912)
print v(xbgr.mr_n68211744)
print v(xbgr.mr_n68215728)
print v(xbgr.mr_n68216000)
print v(xbgr.mr_n68216192)
print v(xbgr.mr_n68216704)
print v(xbgr.mr_n68218320)
print v(xbgr.mr_n68218512)
print v(xbgr.mr_n68220704)
print v(xbgr.mr_n68220976)
print v(xbgr.mr_n68221168)
print v(xbgr.mr_n68221680)
print v(xbgr.mr_n68223616)
print v(xbgr.mr_n68224128)
print v(xbgr.mr_n68226864)
print v(xbgr.mr_n68227136)
print v(xbgr.mr_n68227328)
print v(xbgr.mr_n68227840)
print v(xbgr.mr_n68229456)
print v(xbgr.mr_n68229648)
print v(xbgr.mr_n68231840)
print v(xbgr.mr_n68232112)
print v(xbgr.mr_n68232304)
print v(xbgr.mr_n68232816)
print v(xbgr.mr_n68234672)
print v(xbgr.mr_n68235264)
print v(xbgr.mr_n68238000)
print v(xbgr.mr_n68238272)
print v(xbgr.mr_n68238464)
print v(xbgr.mr_n68238976)
print v(xbgr.mr_n68240592)
print v(xbgr.mr_n68240784)
print v(xbgr.mr_n68242976)
print v(xbgr.mr_n68243248)
print v(xbgr.mr_n68243440)
print v(xbgr.mr_n68243952)
print v(xbgr.mr_n68245888)
print v(xbgr.mr_n68246400)
print v(xbgr.mr_n68249136)
print v(xbgr.mr_n68249408)
print v(xbgr.mr_n68249600)
print v(xbgr.mr_n68250112)
print v(xbgr.mr_n68253824)
print v(xbgr.mr_n68254976)
print v(xbgr.mr_n68255088)
print v(xbgr.mr_n68256240)
print v(xbgr.mr_n68256352)
print v(xbgr.mr_n68257504)
print v(xbgr.mr_n68257616)
print v(xbgr.mr_n68258768)
print v(xbgr.mr_n68258880)
print v(xbgr.mr_n68260032)
print v(xbgr.mr_n68260144)
print v(xbgr.mr_n68261296)
print v(xbgr.mr_n68261408)
print v(xbgr.mr_n68262560)
print v(xbgr.mr_n68262672)
print v(xbgr.mr_n68263824)
print v(xbgr.mr_n68263936)
print v(xbgr.mr_n68265088)
print v(xbgr.mr_n68265200)
print v(xbgr.mr_n68266352)
print v(xbgr.mr_n68266464)
print v(xbgr.mr_n68267616)
print v(xbgr.mr_n68267728)
print v(xbgr.mr_n68268880)
print v(xbgr.mr_n68268992)
print v(xbgr.mr_n68270144)
print v(xbgr.mr_n68270256)
print v(xbgr.mr_n68271408)
print v(xbgr.mr_n68271520)
print v(xbgr.mr_n68272672)
print v(xbgr.mr_n68272784)
print v(xbgr.mr_n68273984)
print v(xbgr.mr_n68275264)
print v(xbgr.mr_n68277184)
print v(xbgr.mr_n68277696)
print v(xbgr.mr_n68278608)
print v(xbgr.mr_n68280544)
print v(xbgr.mr_n68280880)
print v(xbgr.mr_n68293456)
print v(xbgr.mr_n68297200)
print v(xbgr.mr_n68301488)
print v(xbgr.mr_n68306464)
print v(xbgr.mr_n68307152)
print v(xbgr.mr_n68307904)
print v(xbgr.mr_n68308848)
print v(xbgr.mr_n68311680)
print v(xbgr.mr_n68315520)
print v(xbgr.mr_n68316048)
print v(xbgr.mr_n68316608)
print v(xbgr.mr_n68316720)
print v(xbgr.mr_n68316832)
print v(xbgr.mr_n68316944)
print v(xbgr.mr_n68317056)
print v(xbgr.mr_n68318800)
print v(xbgr.mr_n68319072)
print v(xbgr.mr_n68319264)
print v(xbgr.mr_n68319776)
print v(xbgr.mr_n68321712)
print v(xbgr.mr_n68323456)
print v(xbgr.mr_n68323728)
print v(xbgr.mr_n68323920)
print v(xbgr.mr_n68324432)
print v(xbgr.mr_n68326368)
print v(xbgr.mr_n68326560)
print v(xbgr.mr_n68328112)
print v(xbgr.mr_n68328384)
print v(xbgr.mr_n68328576)
print v(xbgr.mr_n68329088)
print v(xbgr.mr_n68330320)
print v(xbgr.mr_n68330832)
print v(xbgr.mr_n68334544)
print v(xbgr.mr_n68334736)
print v(xbgr.mr_n68335248)
print v(xbgr.mr_n68337776)
print v(xbgr.mr_n68339584)
print v(xbgr.mr_n68339776)
print v(xbgr.mr_n68340288)
print v(xbgr.mr_n68340480)
print v(xbgr.mr_n68341456)
print v(xbgr.mr_n68341648)
print v(xbgr.mr_n68342480)
print v(xbgr.mr_n68343152)
print v(xbgr.mr_n68343984)
print v(xbgr.mr_n68346272)
print v(xbgr.mr_n68347104)
print v(xbgr.mr_n68347216)
print v(xbgr.mr_n68347328)
print v(xbgr.mr_n68347440)
print v(xbgr.mr_n68347552)
print v(xbgr.mr_n68349296)
print v(xbgr.mr_n68349568)
print v(xbgr.mr_n68349760)
print v(xbgr.mr_n68350272)
print v(xbgr.mr_n68351504)
print v(xbgr.mr_n68352016)
print v(xbgr.mr_n68355456)
print v(xbgr.mr_n68355728)
print v(xbgr.mr_n68355920)
print v(xbgr.mr_n68356432)
print v(xbgr.mr_n68358576)
print v(xbgr.mr_n68358688)
print v(xbgr.mr_n68360432)
print v(xbgr.mr_n68360704)
print v(xbgr.mr_n68360896)
print v(xbgr.mr_n68361408)
print v(xbgr.mr_n68362640)
print v(xbgr.mr_n68363152)
print v(xbgr.mr_n68366592)
print v(xbgr.mr_n68366864)
print v(xbgr.mr_n68367056)
print v(xbgr.mr_n68367568)
print v(xbgr.mr_n68369712)
print v(xbgr.mr_n68369824)
print v(xbgr.mr_n68371568)
print v(xbgr.mr_n68371840)
print v(xbgr.mr_n68372032)
print v(xbgr.mr_n68372544)
print v(xbgr.mr_n68373776)
print v(xbgr.mr_n68374288)
print v(xbgr.mr_n68376192)
print v(xbgr.mr_n68377728)
print v(xbgr.mr_n68378000)
print v(xbgr.mr_n68378192)
print v(xbgr.mr_n68378704)
print v(xbgr.mr_n68380768)
print v(xbgr.mr_n68380880)
print v(xbgr.mr_n68381392)
print v(xbgr.mr_n68381504)
print v(xbgr.mr_n68382016)
print v(xbgr.mr_n68382128)
print v(xbgr.mr_n68382896)
print v(xbgr.mr_n68383008)
print v(xbgr.mr_n68383840)
print v(xbgr.mr_n68383952)
print v(xbgr.mr_n68384784)
print v(xbgr.mr_n68384896)
print v(xbgr.mr_n68385728)
print v(xbgr.mr_n68385840)
print v(xbgr.mr_n68386672)
print v(xbgr.mr_n68386784)
print v(xbgr.mr_n68387680)
print v(xbgr.mr_n68387792)
print v(xbgr.mr_n68388944)
print v(xbgr.mr_n68389056)
print v(xbgr.mr_n68390208)
print v(xbgr.mr_n68390320)
print v(xbgr.mr_n68391472)
print v(xbgr.mr_n68391584)
print v(xbgr.mr_n68392736)
print v(xbgr.mr_n68392848)
print v(xbgr.mr_n68394000)
print v(xbgr.mr_n68394112)
print v(xbgr.mr_n68395264)
print v(xbgr.mr_n68395376)
print v(xbgr.mr_n68403168)
print v(xbgr.mr_n68407248)
print v(xbgr.mr_n68407360)
print v(xbgr.mr_n68408512)
print v(xbgr.mr_n68408624)
print v(xbgr.mr_n68409776)
print v(xbgr.mr_n68409888)
print v(xbgr.mr_n68411040)
print v(xbgr.mr_n68411152)
print v(xbgr.mr_n68412304)
print v(xbgr.mr_n68412416)
print v(xbgr.mr_n68413568)
print v(xbgr.mr_n68413680)
print v(xbgr.mr_n68414832)
print v(xbgr.mr_n68414944)
print v(xbgr.mr_n68416096)
print v(xbgr.mr_n68416208)
print v(xbgr.mr_n68417360)
print v(xbgr.mr_n68417472)
print v(xbgr.mr_n68418624)
print v(xbgr.mr_n68418736)
print v(xbgr.mr_n68419888)
print v(xbgr.mr_n68420000)
print v(xbgr.mr_n68421152)
print v(xbgr.mr_n68421264)
print v(xbgr.mr_n68422416)
print v(xbgr.mr_n68422528)
print v(xbgr.mr_n68423680)
print v(xbgr.mr_n68423792)
print v(xbgr.mr_n68424944)
print v(xbgr.mr_n68425056)
print v(xbgr.mr_n68426208)
print v(xbgr.mr_n68426320)
print v(xbgr.mr_n68427472)
print v(xbgr.mr_n68427584)
print v(xbgr.mr_n68429680)
print v(xbgr.mr_n68430256)
print v(xbgr.mr_n68433792)
print v(xbgr.mr_n68436208)
print v(xbgr.mr_n68440576)
print v(xbgr.mr_n68443792)
print v(xbgr.mr_n68452848)
print v(xbgr.mr_n68453152)
print v(xbgr.mr_n68453552)
print v(xbgr.mr_n68454144)
print v(xbgr.mr_n68454608)
print v(xbgr.mr_n68454960)
print v(xbgr.mr_n68455312)
print v(xbgr.mr_n68456016)
print v(xbgr.mr_n68456256)
print v(xbgr.mr_n68456896)
print v(xbgr.mr_n68457072)
print v(xbgr.mr_n68457776)
print v(xbgr.mr_n68459712)
print v(xbgr.mr_n68459888)
print v(xbgr.mr_n68460064)
print v(xbgr.mr_n68461120)
print v(xbgr.mr_n68461888)
print v(xbgr.mr_n68462176)
print v(xbgr.mr_n68462416)
print v(xbgr.mr_n68462768)
print v(xbgr.mr_n68466112)
print v(xbgr.mr_n68466752)
print v(xbgr.mr_n68467280)
print v(xbgr.mr_n68467984)
print v(xbgr.mr_n68468656)
print v(xbgr.mr_n68468928)
print v(xbgr.mr_n68469264)
print v(xbgr.mr_n68470000)
print v(xbgr.mr_n68470512)
print v(xbgr.mr_n68473744)
print v(xbgr.mr_n68474432)
print v(xbgr.mr_n68475120)
print v(xbgr.mr_n68475744)
print v(xbgr.mr_n68476128)
print v(xbgr.mr_n68477088)
print v(xbgr.mr_n68477696)
print v(xbgr.mr_n68480976)
print v(xbgr.mr_n68481168)
print v(xbgr.mr_n68482000)
print v(xbgr.mr_n68482112)
print v(xbgr.mr_n68482224)
print v(xbgr.mr_n68482336)
print v(xbgr.mr_n68482448)
print v(xbgr.mr_n68484192)
print v(xbgr.mr_n68484464)
print v(xbgr.mr_n68484656)
print v(xbgr.mr_n68485168)
print v(xbgr.mr_n68487200)
print v(xbgr.mr_n68488944)
print v(xbgr.mr_n68489216)
print v(xbgr.mr_n68489408)
print v(xbgr.mr_n68489920)
print v(xbgr.mr_n68491856)
print v(xbgr.mr_n68493600)
print v(xbgr.mr_n68493872)
print v(xbgr.mr_n68494064)
print v(xbgr.mr_n68494576)
print v(xbgr.mr_n68496512)
print v(xbgr.mr_n68498256)
print v(xbgr.mr_n68498528)
print v(xbgr.mr_n68498720)
print v(xbgr.mr_n68499232)
print v(xbgr.mr_n68501168)
print v(xbgr.mr_n68502912)
print v(xbgr.mr_n68503184)
print v(xbgr.mr_n68503376)
print v(xbgr.mr_n68503888)
print v(xbgr.mr_n68505824)
print v(xbgr.mr_n68507568)
print v(xbgr.mr_n68507840)
print v(xbgr.mr_n68508032)
print v(xbgr.mr_n68508544)
print v(xbgr.mr_n68510480)
print v(xbgr.mr_n68512224)
print v(xbgr.mr_n68512496)
print v(xbgr.mr_n68512688)
print v(xbgr.mr_n68513200)
print v(xbgr.mr_n68515136)
print v(xbgr.mr_n68516880)
print v(xbgr.mr_n68517152)
print v(xbgr.mr_n68517344)
print v(xbgr.mr_n68517856)
print v(xbgr.mr_n68519872)
print v(xbgr.mr_n68520064)
print v(xbgr.mr_n68521872)
print v(xbgr.mr_n68522064)
print v(xbgr.mr_n68522576)
print v(xbgr.mr_n68524448)
print v(xbgr.mr_n68526192)
print v(xbgr.mr_n68526464)
print v(xbgr.mr_n68526656)
print v(xbgr.mr_n68527168)
print v(xbgr.mr_n68529104)
print v(xbgr.mr_n68530848)
print v(xbgr.mr_n68531120)
print v(xbgr.mr_n68531312)
print v(xbgr.mr_n68531824)
print v(xbgr.mr_n68533760)
print v(xbgr.mr_n68535504)
print v(xbgr.mr_n68535776)
print v(xbgr.mr_n68535968)
print v(xbgr.mr_n68536480)
print v(xbgr.mr_n68538416)
print v(xbgr.mr_n68538672)
print v(xbgr.mr_n68540160)
print v(xbgr.mr_n68540432)
print v(xbgr.mr_n68540624)
print v(xbgr.mr_n68541136)
print v(xbgr.mr_n68543072)
print v(xbgr.mr_n68544816)
print v(xbgr.mr_n68545088)
print v(xbgr.mr_n68545280)
print v(xbgr.mr_n68545792)
print v(xbgr.mr_n68547728)
print v(xbgr.mr_n68549472)
print v(xbgr.mr_n68549744)
print v(xbgr.mr_n68549936)
print v(xbgr.mr_n68550448)
print v(xbgr.mr_n68552384)
print v(xbgr.mr_n68554128)
print v(xbgr.mr_n68554400)
print v(xbgr.mr_n68554592)
print v(xbgr.mr_n68555104)
print v(xbgr.mr_n68557120)
print v(xbgr.mr_n68557312)
print v(xbgr.mr_n68559120)
print v(xbgr.mr_n68559312)
print v(xbgr.mr_n68559824)
print v(xbgr.mr_n68562592)
print v(xbgr.mr_n68563376)
print v(xbgr.mr_n68565024)
print v(xbgr.mr_n68565360)
print v(xbgr.mr_n68565536)
print v(xbgr.mr_n68567568)
print v(xbgr.mr_n68569168)
print v(xbgr.mr_n68569600)
print v(xbgr.mr_n68570032)
print v(xbgr.mr_n68571456)
print v(xbgr.mr_n68572032)
print v(xbgr.mr_n68572144)
print v(xbgr.mr_n68573088)
print v(xbgr.mr_n68573984)
print v(xbgr.mr_n68574096)
print v(xbgr.mr_n68575040)
print v(xbgr.mr_n68576192)
print v(xbgr.mr_n68576304)
print v(xbgr.mr_n68577248)
print v(xbgr.mr_n68578400)
print v(xbgr.mr_n68578512)
print v(xbgr.mr_n68579456)
print v(xbgr.mr_n68580608)
print v(xbgr.mr_n68580720)
print v(xbgr.mr_n68581664)
print v(xbgr.mr_n68581920)
print v(xbgr.mr_n68582816)
print v(xbgr.mr_n68582928)
print v(xbgr.mr_n68583872)
print v(xbgr.mr_n68585024)
print v(xbgr.mr_n68585136)
print v(xbgr.mr_n68586080)
print v(xbgr.mr_n68587232)
print v(xbgr.mr_n68587344)
print v(xbgr.mr_n68588288)
print v(xbgr.mr_n68589440)
print v(xbgr.mr_n68589552)
print v(xbgr.mr_n68590496)
print v(xbgr.mr_n68591648)
print v(xbgr.mr_n68591760)
print v(xbgr.mr_n68592704)
print v(xbgr.mr_n68593856)
print v(xbgr.mr_n68593968)
print v(xbgr.mr_n68594912)
print v(xbgr.mr_n68596064)
print v(xbgr.mr_n68596176)
print v(xbgr.mr_n68597120)
print v(xbgr.mr_n68598208)
print v(xbgr.mr_n68598320)
print v(xbgr.mr_n68599264)
print v(xbgr.mr_n68600480)
print v(xbgr.mr_n68600592)
print v(xbgr.mr_n68601536)
print v(xbgr.mr_n68602688)
print v(xbgr.mr_n68602800)
print v(xbgr.mr_n68603952)
print v(xbgr.mr_n68604064)
print v(xbgr.mr_n68605216)
print v(xbgr.mr_n68605328)
print v(xbgr.mr_n68606848)
print v(xbgr.mr_n68609104)
print v(xbgr.mr_n68609408)
print v(xbgr.mr_n68610320)
print v(xbgr.mr_n68610432)
print v(xbgr.mr_n68611584)
print v(xbgr.mr_n68611696)
print v(xbgr.mr_n68614064)
print v(xbgr.mr_n68614896)
print v(xbgr.mr_n68615008)
print v(xbgr.mr_n68617504)
print v(xbgr.mr_n68617616)
print v(xbgr.mr_n68618992)
print v(xbgr.mr_n68619104)
print v(xbgr.mr_n68620256)
print v(xbgr.mr_n68620368)
print v(xbgr.mr_n68621520)
print v(xbgr.mr_n68621632)
print v(xbgr.mr_n68629184)
print v(xbgr.mr_n68634672)
print v(xbgr.mr_n68651184)
print v(xbgr.mr_n68651376)
print v(xbgr.mr_n68651568)
print v(xbgr.mr_n68651760)
print v(xbgr.mr_n68654080)
print v(xbgr.mr_n68654272)
print v(xbgr.mr_n68654464)
print v(xbgr.mr_n68655056)
print v(xbgr.mr_n68660736)
print v(xbgr.mr_n68661008)
print v(xbgr.mr_n68661200)
print v(xbgr.mr_n68661712)
print v(xbgr.mr_n68663856)
print v(xbgr.mr_n68663968)
print v(xbgr.mr_n68665712)
print v(xbgr.mr_n68665904)
print v(xbgr.mr_n68666096)
print v(xbgr.mr_n68666688)
print v(xbgr.mr_n68667920)
print v(xbgr.mr_n68668432)
print v(xbgr.mr_n68670400)
print v(xbgr.mr_n68672208)
print v(xbgr.mr_n68672400)
print v(xbgr.mr_n68672912)
print v(xbgr.mr_n68675152)
print v(xbgr.mr_n68675344)
print v(xbgr.mr_n68675536)
print v(xbgr.mr_n68675728)
print v(xbgr.mr_n68675920)
print v(xbgr.mr_n68678144)
print v(xbgr.mr_n68679056)
print v(xbgr.mr_n68679568)
print v(xbgr.mr_n68681536)
print v(xbgr.mr_n68683344)
print v(xbgr.mr_n68683536)
print v(xbgr.mr_n68684048)
print v(xbgr.mr_n68686288)
print v(xbgr.mr_n68686480)
print v(xbgr.mr_n68686672)
print v(xbgr.mr_n68686864)
print v(xbgr.mr_n68687056)
print v(xbgr.mr_n68689280)
print v(xbgr.mr_n68690192)
print v(xbgr.mr_n68690704)
print v(xbgr.mr_n68694144)
print v(xbgr.mr_n68694416)
print v(xbgr.mr_n68694608)
print v(xbgr.mr_n68695120)
print v(xbgr.mr_n68697264)
print v(xbgr.mr_n68697376)
print v(xbgr.mr_n68699120)
print v(xbgr.mr_n68699392)
print v(xbgr.mr_n68699584)
print v(xbgr.mr_n68700096)
print v(xbgr.mr_n68701328)
print v(xbgr.mr_n68701840)
print v(xbgr.mr_n68704016)
print v(xbgr.mr_n68705280)
print v(xbgr.mr_n68705552)
print v(xbgr.mr_n68705744)
print v(xbgr.mr_n68706256)
print v(xbgr.mr_n68708400)
print v(xbgr.mr_n68708512)
print v(xbgr.mr_n68710256)
print v(xbgr.mr_n68710528)
print v(xbgr.mr_n68710720)
print v(xbgr.mr_n68711232)
print v(xbgr.mr_n68712384)
print v(xbgr.mr_n68712976)
print v(xbgr.mr_n68714944)
print v(xbgr.mr_n68716752)
print v(xbgr.mr_n68716944)
print v(xbgr.mr_n68717456)
print v(xbgr.mr_n68722592)
print v(xbgr.mr_n68722704)
print v(xbgr.mr_n68723536)
print v(xbgr.mr_n68723648)
print v(xbgr.mr_n68724480)
print v(xbgr.mr_n68724592)
print v(xbgr.mr_n68725680)
print v(xbgr.mr_n68725792)
print v(xbgr.mr_n68726944)
print v(xbgr.mr_n68727056)
print v(xbgr.mr_n68728208)
print v(xbgr.mr_n68728320)
print v(xbgr.mr_n68729472)
print v(xbgr.mr_n68729584)
print v(xbgr.mr_n68730736)
print v(xbgr.mr_n68730848)
print v(xbgr.mr_n68732000)
print v(xbgr.mr_n68732112)
print v(xbgr.mr_n68733264)
print v(xbgr.mr_n68733376)
print v(xbgr.mr_n68734528)
print v(xbgr.mr_n68734640)
print v(xbgr.mr_n68735728)
print v(xbgr.mr_n68735840)
print v(xbgr.mr_n68737056)
print v(xbgr.mr_n68737168)
print v(xbgr.mr_n68738320)
print v(xbgr.mr_n68738432)
print v(xbgr.mr_n68738720)
print v(xbgr.mr_n68739584)
print v(xbgr.mr_n68739696)
print v(xbgr.mr_n68742112)
print v(xbgr.mr_n68743024)
print v(xbgr.mr_n68745520)
print v(xbgr.mr_n68749728)
print v(xbgr.mr_n68750416)
print v(xbgr.mr_n68751104)
print v(xbgr.mr_n68751824)
print v(xbgr.mr_n68753696)
print v(xbgr.mr_n68754640)
print v(xbgr.mr_n68755584)
print v(xbgr.mr_n68756528)
print v(xbgr.mr_n68757472)
print v(xbgr.mr_n68758416)
print v(xbgr.mr_n68759360)
print v(xbgr.mr_n68761776)
print v(xbgr.mr_n68762112)
print v(xbgr.mr_n68764320)
print v(xbgr.mr_n68765888)
print v(xbgr.mr_n68767456)
print v(xbgr.mr_n68768448)
print v(xbgr.mr_n68769024)
print v(xbgr.mr_n68770592)
print v(xbgr.mr_n68772160)
print v(xbgr.mr_n68773728)
print v(xbgr.mr_n68775296)
print v(xbgr.mr_n68779776)
print v(xbgr.mr_n68780464)
print v(xbgr.mr_n68781152)
print v(xbgr.mr_n68781904)
print v(xbgr.mr_n68783520)
print v(xbgr.mr_n68784800)
print v(xbgr.mr_n68784912)
print v(xbgr.mr_n68785856)
print v(xbgr.mr_n68787008)
print v(xbgr.mr_n68787120)
print v(xbgr.mr_n68788064)
print v(xbgr.mr_n68789216)
print v(xbgr.mr_n68789328)
print v(xbgr.mr_n68790272)
print v(xbgr.mr_n68791424)
print v(xbgr.mr_n68791536)
print v(xbgr.mr_n68792480)
print v(xbgr.mr_n68793632)
print v(xbgr.mr_n68793744)
print v(xbgr.mr_n68794688)
print v(xbgr.mr_n68795840)
print v(xbgr.mr_n68795952)
print v(xbgr.mr_n68796896)
print v(xbgr.mr_n68798048)
print v(xbgr.mr_n68798160)
print v(xbgr.mr_n68799104)
print v(xbgr.mr_n68800256)
print v(xbgr.mr_n68800368)
print v(xbgr.mr_n68801312)
print v(xbgr.mr_n68801568)
print v(xbgr.mr_n68802464)
print v(xbgr.mr_n68802576)
print v(xbgr.mr_n68803520)
print v(xbgr.mr_n68804672)
print v(xbgr.mr_n68804784)
print v(xbgr.mr_n68805728)
print v(xbgr.mr_n68806880)
print v(xbgr.mr_n68806992)
print v(xbgr.mr_n68807936)
print v(xbgr.mr_n68809088)
print v(xbgr.mr_n68809200)
print v(xbgr.mr_n68810144)
print v(xbgr.mr_n68811296)
print v(xbgr.mr_n68811408)
print v(xbgr.mr_n68812352)
print v(xbgr.mr_n68813504)
print v(xbgr.mr_n68813616)
print v(xbgr.mr_n68814560)
print v(xbgr.mr_n68815712)
print v(xbgr.mr_n68815824)
print v(xbgr.mr_n68816768)
print v(xbgr.mr_n68817920)
print v(xbgr.mr_n68818032)
print v(xbgr.mr_n68818976)
print v(xbgr.mr_n68820128)
print v(xbgr.mr_n68820240)
print v(xbgr.mr_n68821120)
print v(xbgr.mr_n68821808)
print v(xbgr.mr_n68822496)
print v(xbgr.mr_n68823216)
print v(xbgr.mr_n68824160)
print v(xbgr.mr_n68825104)
print v(xbgr.mr_n68826048)
print v(xbgr.mr_n68826992)
print v(xbgr.mr_n68827936)
print v(xbgr.mr_n68828880)
print v(xbgr.mr_n68829824)
print v(xbgr.mr_n68846208)
print v(xbgr.mr_n68852944)
print v(xbgr.mr_n68854016)
print v(xbgr.mr_n68854208)
print v(xbgr.mr_n68854400)
print v(xbgr.mr_n68854592)
print v(xbgr.mr_n68856912)
print v(xbgr.mr_n68857184)
print v(xbgr.mr_n68857376)
print v(xbgr.mr_n68857888)
print v(xbgr.mr_n68862608)
print v(xbgr.mr_n68862880)
print v(xbgr.mr_n68863072)
print v(xbgr.mr_n68863584)
print v(xbgr.mr_n68865728)
print v(xbgr.mr_n68865840)
print v(xbgr.mr_n68867584)
print v(xbgr.mr_n68867856)
print v(xbgr.mr_n68868048)
print v(xbgr.mr_n68868560)
print v(xbgr.mr_n68869792)
print v(xbgr.mr_n68870304)
print v(xbgr.mr_n68873744)
print v(xbgr.mr_n68874016)
print v(xbgr.mr_n68874208)
print v(xbgr.mr_n68874720)
print v(xbgr.mr_n68876944)
print v(xbgr.mr_n68878720)
print v(xbgr.mr_n68878992)
print v(xbgr.mr_n68879184)
print v(xbgr.mr_n68879696)
print v(xbgr.mr_n68880928)
print v(xbgr.mr_n68881440)
print v(xbgr.mr_n68883152)
print v(xbgr.mr_n68883840)
print v(xbgr.mr_n68884896)
print v(xbgr.mr_n68885088)
print v(xbgr.mr_n68885280)
print v(xbgr.mr_n68885472)
print v(xbgr.mr_n68887216)
print v(xbgr.mr_n68887488)
print v(xbgr.mr_n68887680)
print v(xbgr.mr_n68888192)
print v(xbgr.mr_n68890704)
print v(xbgr.mr_n68891216)
print v(xbgr.mr_n68895040)
print v(xbgr.mr_n68895312)
print v(xbgr.mr_n68895504)
print v(xbgr.mr_n68896016)
print v(xbgr.mr_n68898160)
print v(xbgr.mr_n68898272)
print v(xbgr.mr_n68900016)
print v(xbgr.mr_n68900288)
print v(xbgr.mr_n68900480)
print v(xbgr.mr_n68900992)
print v(xbgr.mr_n68902224)
print v(xbgr.mr_n68902736)
print v(xbgr.mr_n68904576)
print v(xbgr.mr_n68906176)
print v(xbgr.mr_n68906448)
print v(xbgr.mr_n68906640)
print v(xbgr.mr_n68907152)
print v(xbgr.mr_n68909296)
print v(xbgr.mr_n68909408)
print v(xbgr.mr_n68911152)
print v(xbgr.mr_n68911424)
print v(xbgr.mr_n68911616)
print v(xbgr.mr_n68912128)
print v(xbgr.mr_n68913360)
print v(xbgr.mr_n68913872)
print v(xbgr.mr_n68917312)
print v(xbgr.mr_n68917584)
print v(xbgr.mr_n68917776)
print v(xbgr.mr_n68918288)
print v(xbgr.mr_n68923232)
print v(xbgr.mr_n68923344)
print v(xbgr.mr_n68924176)
print v(xbgr.mr_n68924288)
print v(xbgr.mr_n68925120)
print v(xbgr.mr_n68925232)
print v(xbgr.mr_n68926320)
print v(xbgr.mr_n68926432)
print v(xbgr.mr_n68927584)
print v(xbgr.mr_n68927696)
print v(xbgr.mr_n68928848)
print v(xbgr.mr_n68928960)
print v(xbgr.mr_n68930112)
print v(xbgr.mr_n68930224)
print v(xbgr.mr_n68931376)
print v(xbgr.mr_n68931488)
print v(xbgr.mr_n68932640)
print v(xbgr.mr_n68932752)
print v(xbgr.mr_n68933904)
print v(xbgr.mr_n68934016)
print v(xbgr.mr_n68935168)
print v(xbgr.mr_n68935280)
print v(xbgr.mr_n68936432)
print v(xbgr.mr_n68936544)
print v(xbgr.mr_n68937696)
print v(xbgr.mr_n68937808)
print v(xbgr.mr_n68938960)
print v(xbgr.mr_n68939072)
print v(xbgr.mr_n68940224)
print v(xbgr.mr_n68940336)
print v(xbgr.mr_n68941872)
print v(xbgr.mr_n68941984)
print v(xbgr.mr_n68943136)
print v(xbgr.mr_n68943248)
print v(xbgr.mr_n68944400)
print v(xbgr.mr_n68944512)
print v(xbgr.mr_n68945664)
print v(xbgr.mr_n68945776)
print v(xbgr.mr_n68946928)
print v(xbgr.mr_n68947040)
print v(xbgr.mr_n68948192)
print v(xbgr.mr_n68948304)
print v(xbgr.mr_n68949456)
print v(xbgr.mr_n68949568)
print v(xbgr.mr_n68950720)
print v(xbgr.mr_n68950832)
print v(xbgr.mr_n68951984)
print v(xbgr.mr_n68952096)
print v(xbgr.mr_n68953248)
print v(xbgr.mr_n68953360)
print v(xbgr.mr_n68954512)
print v(xbgr.mr_n68954624)
print v(xbgr.mr_n68955776)
print v(xbgr.mr_n68955888)
print v(xbgr.mr_n68957040)
print v(xbgr.mr_n68957152)
print v(xbgr.mr_n68958304)
print v(xbgr.mr_n68958416)
print v(xbgr.mr_n68959568)
print v(xbgr.mr_n68959680)
print v(xbgr.mr_n68960832)
print v(xbgr.mr_n68960944)
print v(xbgr.mr_n68962096)
print v(xbgr.mr_n68962208)
print v(xbgr.mr_n68963744)
print v(xbgr.mr_n68975984)
print v(xbgr.mr_n68977184)
print v(xbgr.mr_n68998992)
print v(xbgr.mr_n68999680)
print v(xbgr.mr_n69000368)
print v(xbgr.mr_n69001088)
print v(xbgr.mr_n69002032)
print v(xbgr.mr_n69002976)
print v(xbgr.mr_n69003920)
print v(xbgr.mr_n69004864)
print v(xbgr.mr_n69005808)
print v(xbgr.mr_n69006752)
print v(xbgr.mr_n69007696)
print v(xbgr.mr_n69008640)
print v(xbgr.mr_n69009584)
print v(xbgr.mr_n69010528)
print v(xbgr.mr_n69011472)
print v(xbgr.mr_n69012416)
print v(xbgr.mr_n69013360)
print v(xbgr.mr_n69014304)
print v(xbgr.mr_n69015248)
print v(xbgr.mr_n69017824)
print v(xbgr.mr_n69020000)
print v(xbgr.mr_n69028912)
print v(xbgr.mr_n69029104)
print v(xbgr.mr_n69029792)
print v(xbgr.mr_n69029904)
print v(xbgr.mr_n69030016)
print v(xbgr.mr_n69030128)
print v(xbgr.mr_n69030240)
print v(xbgr.mr_n69031984)
print v(xbgr.mr_n69032256)
print v(xbgr.mr_n69032448)
print v(xbgr.mr_n69032960)
print v(xbgr.mr_n69033424)
print v(xbgr.mr_n69035552)
print v(xbgr.mr_n69035824)
print v(xbgr.mr_n69036016)
print v(xbgr.mr_n69036528)
print v(xbgr.mr_n69040016)
print v(xbgr.mr_n69040208)
print v(xbgr.mr_n69040400)
print v(xbgr.mr_n69040992)
print v(xbgr.mr_n69042544)
print v(xbgr.mr_n69044800)
print v(xbgr.mr_n69045072)
print v(xbgr.mr_n69045264)
print v(xbgr.mr_n69045776)
print v(xbgr.mr_n69049264)
print v(xbgr.mr_n69049536)
print v(xbgr.mr_n69049728)
print v(xbgr.mr_n69050240)
print v(xbgr.mr_n69051792)
print v(xbgr.mr_n69054048)
print v(xbgr.mr_n69054320)
print v(xbgr.mr_n69054512)
print v(xbgr.mr_n69055024)
print v(xbgr.mr_n69058512)
print v(xbgr.mr_n69058784)
print v(xbgr.mr_n69058976)
print v(xbgr.mr_n69059488)
print v(xbgr.mr_n69061120)
print v(xbgr.mr_n69061312)
print v(xbgr.mr_n69063632)
print v(xbgr.mr_n69063824)
print v(xbgr.mr_n69064336)
print v(xbgr.mr_n69065824)
print v(xbgr.mr_n69067760)
print v(xbgr.mr_n69068032)
print v(xbgr.mr_n69068224)
print v(xbgr.mr_n69068736)
print v(xbgr.mr_n69070288)
print v(xbgr.mr_n69072544)
print v(xbgr.mr_n69072816)
print v(xbgr.mr_n69073008)
print v(xbgr.mr_n69073520)
print v(xbgr.mr_n69077008)
print v(xbgr.mr_n69077280)
print v(xbgr.mr_n69077472)
print v(xbgr.mr_n69077984)
print v(xbgr.mr_n69079520)
print v(xbgr.mr_n69080848)
print v(xbgr.mr_n69081120)
print v(xbgr.mr_n69081312)
print v(xbgr.mr_n69081824)
print v(xbgr.mr_n69084688)
print v(xbgr.mr_n69084960)
print v(xbgr.mr_n69085152)
print v(xbgr.mr_n69085664)
print v(xbgr.mr_n69089024)
print v(xbgr.mr_n69089136)
print v(xbgr.mr_n69090880)
print v(xbgr.mr_n69091152)
print v(xbgr.mr_n69091344)
print v(xbgr.mr_n69091856)
print v(xbgr.mr_n69094000)
print v(xbgr.mr_n69094112)
print v(xbgr.mr_n69095856)
print v(xbgr.mr_n69096128)
print v(xbgr.mr_n69096320)
print v(xbgr.mr_n69096832)
print v(xbgr.mr_n69098976)
print v(xbgr.mr_n69099088)
print v(xbgr.mr_n69100832)
print v(xbgr.mr_n69101104)
print v(xbgr.mr_n69101296)
print v(xbgr.mr_n69101808)
print v(xbgr.mr_n69103952)
print v(xbgr.mr_n69104064)
print v(xbgr.mr_n69105808)
print v(xbgr.mr_n69106080)
print v(xbgr.mr_n69106272)
print v(xbgr.mr_n69106784)
print v(xbgr.mr_n69111952)
print v(xbgr.mr_n69114144)
print v(xbgr.mr_n69115712)
print v(xbgr.mr_n69116656)
print v(xbgr.mr_n69117888)
print v(xbgr.mr_n69118848)
print v(xbgr.mr_n69120416)
print v(xbgr.mr_n69121360)
print v(xbgr.mr_n69123552)
print v(xbgr.mr_n69125168)
print v(xbgr.mr_n69125744)
print v(xbgr.mr_n69125856)
print v(xbgr.mr_n69126688)
print v(xbgr.mr_n69126800)
print v(xbgr.mr_n69127632)
print v(xbgr.mr_n69127744)
print v(xbgr.mr_n69128576)
print v(xbgr.mr_n69128688)
print v(xbgr.mr_n69129520)
print v(xbgr.mr_n69129632)
print v(xbgr.mr_n69130464)
print v(xbgr.mr_n69130576)
print v(xbgr.mr_n69131408)
print v(xbgr.mr_n69131520)
print v(xbgr.mr_n69132352)
print v(xbgr.mr_n69132464)
print v(xbgr.mr_n69133296)
print v(xbgr.mr_n69133408)
print v(xbgr.mr_n69134368)
print v(xbgr.mr_n69134480)
print v(xbgr.mr_n69147984)
print v(xbgr.mr_n69150400)
print v(xbgr.mr_n69154736)
print v(xbgr.mr_n69156112)
print v(xbgr.mr_n69158848)
print v(xbgr.mr_n69159536)
print v(xbgr.mr_n69160224)
print v(xbgr.mr_n69160944)
print v(xbgr.mr_n69162592)
print v(xbgr.mr_n69163536)
print v(xbgr.mr_n69164480)
print v(xbgr.mr_n69165424)
print v(xbgr.mr_n69166368)
print v(xbgr.mr_n69167312)
print v(xbgr.mr_n69168256)
print v(xbgr.mr_n69169200)
print v(xbgr.mr_n69170144)
print v(xbgr.mr_n69171088)
print v(xbgr.mr_n69172032)
print v(xbgr.mr_n69172976)
print v(xbgr.mr_n69173920)
print v(xbgr.mr_n69174864)
print v(xbgr.mr_n69175808)
print v(xbgr.mr_n69176000)
print v(xbgr.mr_n69176192)
print v(xbgr.mr_n69176384)
print v(xbgr.mr_n69176576)
print v(xbgr.mr_n69176768)
print v(xbgr.mr_n69178912)
print v(xbgr.mr_n69179024)
print v(xbgr.mr_n69182336)
print v(xbgr.mr_n69182448)
print v(xbgr.mr_n69187328)
print v(xbgr.mr_n69189168)
print v(xbgr.mr_n69191008)
print v(xbgr.mr_n69192848)
print v(xbgr.mr_n69194944)
print v(xbgr.mr_n69198080)
print v(xbgr.mr_n69210016)
print v(xbgr.mr_n69211584)
print v(xbgr.mr_n69213152)
print v(xbgr.mr_n69214720)
print v(xbgr.mr_n69216288)
print v(xbgr.mr_n69217856)
print v(xbgr.mr_n69219424)
print v(xbgr.mr_n69220992)
print v(xbgr.mr_n69222560)
print v(xbgr.mr_n69224128)
print v(xbgr.mr_n69225696)
print v(xbgr.mr_n69227264)
print v(xbgr.mr_n69228832)
print v(xbgr.mr_n69230400)
print v(xbgr.mr_n69231968)
print v(xbgr.mr_n69233536)
print v(xbgr.mr_n69236784)
print v(xbgr.mr_n69237120)
print v(xbgr.mr_n69237232)
print v(xbgr.mr_n69238064)
print v(xbgr.mr_n69238176)
print v(xbgr.mr_n69239008)
print v(xbgr.mr_n69239120)
print v(xbgr.mr_n69239952)
print v(xbgr.mr_n69240064)
print v(xbgr.mr_n69243552)
print v(xbgr.mr_n69244064)
print v(xbgr.mr_n69244176)
print v(xbgr.mr_n69244288)
print v(xbgr.mr_n69244400)
print v(xbgr.mr_n69244512)
print v(xbgr.mr_n69245936)
print v(xbgr.mr_n69246208)
print v(xbgr.mr_n69246400)
print v(xbgr.mr_n69246912)
print v(xbgr.mr_n69249056)
print v(xbgr.mr_n69249248)
print v(xbgr.mr_n69249440)
print v(xbgr.mr_n69251248)
print v(xbgr.mr_n69251440)
print v(xbgr.mr_n69251952)
print v(xbgr.mr_n69254032)
print v(xbgr.mr_n69254144)
print v(xbgr.mr_n69255888)
print v(xbgr.mr_n69256160)
print v(xbgr.mr_n69256352)
print v(xbgr.mr_n69256864)
print v(xbgr.mr_n69259008)
print v(xbgr.mr_n69259200)
print v(xbgr.mr_n69259392)
print v(xbgr.mr_n69261200)
print v(xbgr.mr_n69261392)
print v(xbgr.mr_n69261904)
print v(xbgr.mr_n69263984)
print v(xbgr.mr_n69264176)
print v(xbgr.mr_n69264368)
print v(xbgr.mr_n69266176)
print v(xbgr.mr_n69266368)
print v(xbgr.mr_n69266880)
print v(xbgr.mr_n69268960)
print v(xbgr.mr_n69269072)
print v(xbgr.mr_n69270816)
print v(xbgr.mr_n69271088)
print v(xbgr.mr_n69271280)
print v(xbgr.mr_n69271792)
print v(xbgr.mr_n69274096)
print v(xbgr.mr_n69274288)
print v(xbgr.mr_n69274480)
print v(xbgr.mr_n69274672)
print v(xbgr.mr_n69274864)
print v(xbgr.mr_n69277088)
print v(xbgr.mr_n69278912)
print v(xbgr.mr_n69279024)
print v(xbgr.mr_n69280768)
print v(xbgr.mr_n69281040)
print v(xbgr.mr_n69281232)
print v(xbgr.mr_n69281744)
print v(xbgr.mr_n69282672)
print v(xbgr.mr_n69283552)
print v(xbgr.mr_n69283664)
print v(xbgr.mr_n69284816)
print v(xbgr.mr_n69284928)
print v(xbgr.mr_n69286080)
print v(xbgr.mr_n69286192)
print v(xbgr.mr_n69288400)
print v(xbgr.mr_n69288720)
print v(xbgr.mr_n69289472)
print v(xbgr.mr_n69290160)
print v(xbgr.mr_n69290848)
print v(xbgr.mr_n69291536)
print v(xbgr.mr_n69292224)
print v(xbgr.mr_n69292912)
print v(xbgr.mr_n69293856)
print v(xbgr.mr_n69295856)
print v(xbgr.mr_n69296800)
print v(xbgr.mr_n69297744)
print v(xbgr.mr_n69298688)
print v(xbgr.mr_n69299632)
print v(xbgr.mr_n69300576)
print v(xbgr.mr_n69301520)
print v(xbgr.mr_n69302464)
print v(xbgr.mr_n69303408)
print v(xbgr.mr_n69304352)
print v(xbgr.mr_n69310416)
print v(xbgr.mr_n69317792)
print v(xbgr.mr_n69318816)
print v(xbgr.mr_n69319024)
print v(xbgr.mr_n69319376)
print v(xbgr.mr_n69321488)
print v(xbgr.mr_n69323056)
print v(xbgr.mr_n69324096)
print v(xbgr.mr_n69324208)
print v(xbgr.mr_n69324320)
print v(xbgr.mr_n69325920)
print v(xbgr.mr_n69326032)
print v(xbgr.mr_n69330240)
print v(xbgr.mr_n69331456)
print v(xbgr.mr_n69331568)
print v(xbgr.mr_n69335312)
print v(xbgr.mr_n69336784)
print v(xbgr.mr_n69338352)
print v(xbgr.mr_n69339920)
print v(xbgr.mr_n69341488)
print v(xbgr.mr_n69347568)
print v(xbgr.mr_n69347840)
print v(xbgr.mr_n69348976)
print v(xbgr.mr_n69350224)
print v(xbgr.mr_n69350416)
print v(xbgr.mr_n69350608)
print v(xbgr.mr_n69351712)
print v(xbgr.mr_n69351824)
print v(xbgr.mr_n69353984)
print v(xbgr.mr_n69355536)
print v(xbgr.mr_n69356656)
print v(xbgr.mr_n69357344)
print v(xbgr.mr_n69360240)
print v(xbgr.mr_n69361808)
print v(xbgr.mr_n69362752)
print v(xbgr.mr_n69364320)
print v(xbgr.mr_n69369904)
print v(xbgr.mr_n69371520)
print v(xbgr.mr_n69371632)
print v(xbgr.mr_n69372784)
print v(xbgr.mr_n69372896)
print v(xbgr.mr_n69374048)
print v(xbgr.mr_n69374160)
print v(xbgr.mr_n69375312)
print v(xbgr.mr_n69375424)
print v(xbgr.mr_n69376576)
print v(xbgr.mr_n69376688)
print v(xbgr.mr_n69377840)
print v(xbgr.mr_n69377952)
print v(xbgr.mr_n69379104)
print v(xbgr.mr_n69379216)
print v(xbgr.mr_n69380304)
print v(xbgr.mr_n69380416)
print v(xbgr.mr_n69381632)
print v(xbgr.mr_n69381744)
print v(xbgr.mr_n69382896)
print v(xbgr.mr_n69383008)
print v(xbgr.mr_n69387472)
print v(xbgr.mr_n69399648)
print v(xbgr.mr_n69401648)
print v(xbgr.mr_n69402512)
print v(xbgr.mr_n69402624)
print v(xbgr.mr_n69402816)
print v(xbgr.mr_n69403008)
print v(xbgr.mr_n69403200)
print v(xbgr.mr_n69405616)
print v(xbgr.mr_n69411456)
print v(xbgr.mr_n69412400)
print v(xbgr.mr_n69413344)
print v(xbgr.mr_n69414288)
print v(xbgr.mr_n69415232)
print v(xbgr.mr_n69416176)
print v(xbgr.mr_n69417120)
print v(xbgr.mr_n69418064)
print v(xbgr.mr_n69419008)
print v(xbgr.mr_n69419952)
print v(xbgr.mr_n69420896)
print v(xbgr.mr_n69421840)
print v(xbgr.mr_n69422784)
print v(xbgr.mr_n69423504)
print v(xbgr.mr_n69423616)
print v(xbgr.mr_n69423888)
print v(xbgr.mr_n69424496)
print v(xbgr.mr_n69425600)
print v(xbgr.mr_n69427952)
print v(xbgr.mr_n69428896)
print v(xbgr.mr_n69429840)
print v(xbgr.mr_n69430784)
print v(xbgr.mr_n69431728)
print v(xbgr.mr_n69432672)
print v(xbgr.mr_n69433616)
print v(xbgr.mr_n69434560)
print v(xbgr.mr_n69435504)
print v(xbgr.mr_n69439264)
print v(xbgr.mr_n69440208)
print v(xbgr.mr_n69441152)
print v(xbgr.mr_n69441344)
print v(xbgr.mr_n69441536)
print v(xbgr.mr_n69441728)
print v(xbgr.mr_n69441920)
print v(xbgr.mr_n69442112)
print v(xbgr.mr_n69444256)
print v(xbgr.mr_n69444368)
print v(xbgr.mr_n69447456)
print v(xbgr.mr_n69447568)
print v(xbgr.mr_n69453216)
print v(xbgr.mr_n69454160)
print v(xbgr.mr_n69455104)
print v(xbgr.mr_n69456048)
print v(xbgr.mr_n69456992)
print v(xbgr.mr_n69457936)
print v(xbgr.mr_n69458880)
print v(xbgr.mr_n69459824)
print v(xbgr.mr_n69460768)
print v(xbgr.mr_n69461712)
print v(xbgr.mr_n69464096)
print v(xbgr.mr_n69464672)
print v(xbgr.mr_n69464784)
print v(xbgr.mr_n69465728)
print v(xbgr.mr_n69465920)
print v(xbgr.mr_n69466112)
print v(xbgr.mr_n69466304)
print v(xbgr.mr_n69468496)
print v(xbgr.mr_n69468768)
print v(xbgr.mr_n69468960)
print v(xbgr.mr_n69469472)
print v(xbgr.mr_n69471824)
print v(xbgr.mr_n69474960)
print v(xbgr.mr_n69475792)
print v(xbgr.mr_n69475904)
print v(xbgr.mr_n69476016)
print v(xbgr.mr_n69476128)
print v(xbgr.mr_n69476240)
print v(xbgr.mr_n69477984)
print v(xbgr.mr_n69478368)
print v(xbgr.mr_n69478960)
print v(xbgr.mr_n69481104)
print v(xbgr.mr_n69481216)
print v(xbgr.mr_n69482960)
print v(xbgr.mr_n69483152)
print v(xbgr.mr_n69483344)
print v(xbgr.mr_n69483936)
print v(xbgr.mr_n69486080)
print v(xbgr.mr_n69486192)
print v(xbgr.mr_n69487936)
print v(xbgr.mr_n69488208)
print v(xbgr.mr_n69488400)
print v(xbgr.mr_n69488912)
print v(xbgr.mr_n69491056)
print v(xbgr.mr_n69491168)
print v(xbgr.mr_n69492912)
print v(xbgr.mr_n69493184)
print v(xbgr.mr_n69493376)
print v(xbgr.mr_n69493888)
print v(xbgr.mr_n69496032)
print v(xbgr.mr_n69496144)
print v(xbgr.mr_n69497888)
print v(xbgr.mr_n69498160)
print v(xbgr.mr_n69498352)
print v(xbgr.mr_n69498864)
print v(xbgr.mr_n69501008)
print v(xbgr.mr_n69502864)
print v(xbgr.mr_n69503136)
print v(xbgr.mr_n69503840)
print v(xbgr.mr_n69505984)
print v(xbgr.mr_n69506096)
print v(xbgr.mr_n69507840)
print v(xbgr.mr_n69508112)
print v(xbgr.mr_n69508304)
print v(xbgr.mr_n69508816)
print v(xbgr.mr_n69513664)
print v(xbgr.mr_n69514720)
print v(xbgr.mr_n69515968)
print v(xbgr.mr_n69516544)
print v(xbgr.mr_n69518304)
print v(xbgr.mr_n69519584)
print v(xbgr.mr_n69519776)
print v(xbgr.mr_n69519968)
print v(xbgr.mr_n69520864)
print v(xbgr.mr_n69520976)
print v(xbgr.mr_n69522880)
print v(xbgr.mr_n69524992)
print v(xbgr.mr_n69527376)
print v(xbgr.mr_n69528064)
print v(xbgr.mr_n69528752)
print v(xbgr.mr_n69529440)
print v(xbgr.mr_n69530128)
print v(xbgr.mr_n69530816)
print v(xbgr.mr_n69531504)
print v(xbgr.mr_n69532192)
print v(xbgr.mr_n69532880)
print v(xbgr.mr_n69533568)
print v(xbgr.mr_n69534256)
print v(xbgr.mr_n69534944)
print v(xbgr.mr_n69542272)
print v(xbgr.mr_n69546064)
print v(xbgr.mr_n69547920)
print v(xbgr.mr_n69548032)
print v(xbgr.mr_n69550176)
print v(xbgr.mr_n69550288)
print v(xbgr.mr_n69551440)
print v(xbgr.mr_n69551552)
print v(xbgr.mr_n69552704)
print v(xbgr.mr_n69552816)
print v(xbgr.mr_n69553968)
print v(xbgr.mr_n69554080)
print v(xbgr.mr_n69555232)
print v(xbgr.mr_n69555344)
print v(xbgr.mr_n69556496)
print v(xbgr.mr_n69556608)
print v(xbgr.mr_n69557760)
print v(xbgr.mr_n69557872)
print v(xbgr.mr_n69558240)
print v(xbgr.mr_n69558352)
print v(xbgr.mr_n69558944)
print v(xbgr.mr_n69559056)
print v(xbgr.mr_n69560448)
print v(xbgr.mr_n69560560)
print v(xbgr.mr_n69561392)
print v(xbgr.mr_n69561504)
print v(xbgr.mr_n69564288)
print v(xbgr.mr_n69564400)
print v(xbgr.mr_n69565616)
print v(xbgr.mr_n69565728)
print v(xbgr.mr_n69566880)
print v(xbgr.mr_n69566992)
print v(xbgr.mr_n69570736)
print v(xbgr.mr_n69571856)
print v(xbgr.mr_n69573328)
print v(xbgr.mr_n69574896)
print v(xbgr.mr_n69576464)
print v(xbgr.mr_n69578032)
print v(xbgr.mr_n69579600)
print v(xbgr.mr_n69581168)
print v(xbgr.mr_n69582736)
print v(xbgr.mr_n69584304)
print v(xbgr.mr_n69585872)
print v(xbgr.mr_n69587440)
print v(xbgr.mr_n69589632)
print v(xbgr.mr_n69591200)
print v(xbgr.mr_n69592768)
print v(xbgr.mr_n69604240)
print v(xbgr.mr_n69605392)
print v(xbgr.mr_n69605584)
print v(xbgr.mr_n69605776)
print v(xbgr.mr_n69605968)
print v(xbgr.mr_n69606160)
print v(xbgr.mr_n69606416)
print v(xbgr.mr_n69606528)
print v(xbgr.mr_n69608544)
print v(xbgr.mr_n69608736)
print v(xbgr.mr_n69609248)
print v(xbgr.mr_n69613776)
print v(xbgr.mr_n69614048)
print v(xbgr.mr_n69614240)
print v(xbgr.mr_n69614752)
print v(xbgr.mr_n69617488)
print v(xbgr.mr_n69617760)
print v(xbgr.mr_n69617952)
print v(xbgr.mr_n69618464)
print v(xbgr.mr_n69620608)
print v(xbgr.mr_n69620720)
print v(xbgr.mr_n69622464)
print v(xbgr.mr_n69622736)
print v(xbgr.mr_n69622928)
print v(xbgr.mr_n69623440)
print v(xbgr.mr_n69624592)
print v(xbgr.mr_n69625184)
print v(xbgr.mr_n69628192)
print v(xbgr.mr_n69631136)
print v(xbgr.mr_n69632976)
print v(xbgr.mr_n69633168)
print v(xbgr.mr_n69633360)
print v(xbgr.mr_n69633952)
print v(xbgr.mr_n69635232)
print v(xbgr.mr_n69635824)
print v(xbgr.mr_n69637424)
print v(xbgr.mr_n69638016)
print v(xbgr.mr_n69640080)
print v(xbgr.mr_n69640592)
print v(xbgr.mr_n69642576)
print v(xbgr.mr_n69643168)
print v(xbgr.mr_n69644112)
print v(xbgr.mr_n69645232)
print v(xbgr.mr_n69645744)
print v(xbgr.mr_n69647808)
print v(xbgr.mr_n69648320)
print v(xbgr.mr_n69650304)
print v(xbgr.mr_n69650896)
print v(xbgr.mr_n69652032)
print v(xbgr.mr_n69653024)
print v(xbgr.mr_n69653536)
print v(xbgr.mr_n69655536)
print v(xbgr.mr_n69656048)
print v(xbgr.mr_n69658032)
print v(xbgr.mr_n69658624)
print v(xbgr.mr_n69660688)
print v(xbgr.mr_n69661200)
print v(xbgr.mr_n69669344)
print v(xbgr.mr_n69669456)
print v(xbgr.mr_n69670608)
print v(xbgr.mr_n69670720)
print v(xbgr.mr_n69671872)
print v(xbgr.mr_n69671984)
print v(xbgr.mr_n69673136)
print v(xbgr.mr_n69673248)
print v(xbgr.mr_n69674400)
print v(xbgr.mr_n69674512)
print v(xbgr.mr_n69675600)
print v(xbgr.mr_n69675712)
print v(xbgr.mr_n69676928)
print v(xbgr.mr_n69677040)
print v(xbgr.mr_n69678128)
print v(xbgr.mr_n69678240)
print v(xbgr.mr_n69679456)
print v(xbgr.mr_n69679568)
print v(xbgr.mr_n69680656)
print v(xbgr.mr_n69680768)
print v(xbgr.mr_n69681984)
print v(xbgr.mr_n69682096)
print v(xbgr.mr_n69683184)
print v(xbgr.mr_n69683296)
print v(xbgr.mr_n69684512)
print v(xbgr.mr_n69684624)
print v(xbgr.mr_n69685776)
print v(xbgr.mr_n69685888)
print v(xbgr.mr_n69686208)
print v(xbgr.mr_n69690864)
print v(xbgr.mr_n69697504)
print v(xbgr.mr_n69697616)
print v(xbgr.mr_n69697968)
print v(xbgr.mr_n69701136)
print v(xbgr.mr_n69701824)
print v(xbgr.mr_n69702864)
print v(xbgr.mr_n69704544)
print v(xbgr.mr_n69705488)
print v(xbgr.mr_n69706432)
print v(xbgr.mr_n69707376)
print v(xbgr.mr_n69708320)
print v(xbgr.mr_n69709264)
print v(xbgr.mr_n69710208)
print v(xbgr.mr_n69711152)
print v(xbgr.mr_n69712096)
print v(xbgr.mr_n69713040)
print v(xbgr.mr_n69713984)
print v(xbgr.mr_n69714928)
print v(xbgr.mr_n69715872)
print v(xbgr.mr_n69716816)
print v(xbgr.mr_n69717760)
print v(xbgr.mr_n69718704)
print v(xbgr.mr_n69721136)
print v(xbgr.mr_n69723696)
print v(xbgr.mr_n69724192)
print v(xbgr.mr_n69725024)
print v(xbgr.mr_n69726592)
print v(xbgr.mr_n69729328)
print v(xbgr.mr_n69729936)
print v(xbgr.mr_n69731168)
print v(xbgr.mr_n69731280)
print v(xbgr.mr_n69732224)
print v(xbgr.mr_n69733312)
print v(xbgr.mr_n69733424)
print v(xbgr.mr_n69735264)
print v(xbgr.mr_n69735376)
print v(xbgr.mr_n69736320)
print v(xbgr.mr_n69737472)
print v(xbgr.mr_n69737584)
print v(xbgr.mr_n69739360)
print v(xbgr.mr_n69739472)
print v(xbgr.mr_n69740416)
print v(xbgr.mr_n69741568)
print v(xbgr.mr_n69741680)
print v(xbgr.mr_n69742848)
print v(xbgr.mr_n69743456)
print v(xbgr.mr_n69743568)
print v(xbgr.mr_n69744512)
print v(xbgr.mr_n69745664)
print v(xbgr.mr_n69745776)
print v(xbgr.mr_n69747488)
print v(xbgr.mr_n69747600)
print v(xbgr.mr_n69748544)
print v(xbgr.mr_n69749760)
print v(xbgr.mr_n69749872)
print v(xbgr.mr_n69751648)
print v(xbgr.mr_n69751760)
print v(xbgr.mr_n69752704)
print v(xbgr.mr_n69753856)
print v(xbgr.mr_n69753968)
print v(xbgr.mr_n69755744)
print v(xbgr.mr_n69755856)
print v(xbgr.mr_n69756800)
print v(xbgr.mr_n69757952)
print v(xbgr.mr_n69758064)
print v(xbgr.mr_n69759168)
print v(xbgr.mr_n69759776)
print v(xbgr.mr_n69759888)
print v(xbgr.mr_n69760832)
print v(xbgr.mr_n69762048)
print v(xbgr.mr_n69762160)
print v(xbgr.mr_n69763936)
print v(xbgr.mr_n69764048)
print v(xbgr.mr_n69765360)
print v(xbgr.mr_n69766480)
print v(xbgr.mr_n69768576)
print v(xbgr.mr_n69770144)
print v(xbgr.mr_n69771712)
print v(xbgr.mr_n69773280)
print v(xbgr.mr_n69774848)
print v(xbgr.mr_n69776416)
print v(xbgr.mr_n69777984)
print v(xbgr.mr_n69783856)
print v(xbgr.mr_n69796848)
print v(xbgr.mr_n69798112)
print v(xbgr.mr_n69798304)
print v(xbgr.mr_n69798496)
print v(xbgr.mr_n69798688)
print v(xbgr.mr_n69801008)
print v(xbgr.mr_n69801280)
print v(xbgr.mr_n69801472)
print v(xbgr.mr_n69801984)
print v(xbgr.mr_n69805376)
print v(xbgr.mr_n69807664)
print v(xbgr.mr_n69807936)
print v(xbgr.mr_n69808128)
print v(xbgr.mr_n69808640)
print v(xbgr.mr_n69811376)
print v(xbgr.mr_n69811648)
print v(xbgr.mr_n69811840)
print v(xbgr.mr_n69812352)
print v(xbgr.mr_n69814496)
print v(xbgr.mr_n69814608)
print v(xbgr.mr_n69816352)
print v(xbgr.mr_n69816624)
print v(xbgr.mr_n69816816)
print v(xbgr.mr_n69817328)
print v(xbgr.mr_n69818560)
print v(xbgr.mr_n69819072)
print v(xbgr.mr_n69822512)
print v(xbgr.mr_n69822784)
print v(xbgr.mr_n69822976)
print v(xbgr.mr_n69823488)
print v(xbgr.mr_n69824880)
print v(xbgr.mr_n69825632)
print v(xbgr.mr_n69828016)
print v(xbgr.mr_n69829168)
print v(xbgr.mr_n69829360)
print v(xbgr.mr_n69829552)
print v(xbgr.mr_n69829744)
print v(xbgr.mr_n69831488)
print v(xbgr.mr_n69831760)
print v(xbgr.mr_n69831952)
print v(xbgr.mr_n69832464)
print v(xbgr.mr_n69836080)
print v(xbgr.mr_n69836192)
print v(xbgr.mr_n69837936)
print v(xbgr.mr_n69838208)
print v(xbgr.mr_n69838400)
print v(xbgr.mr_n69838912)
print v(xbgr.mr_n69840144)
print v(xbgr.mr_n69840656)
print v(xbgr.mr_n69844096)
print v(xbgr.mr_n69844368)
print v(xbgr.mr_n69844560)
print v(xbgr.mr_n69845072)
print v(xbgr.mr_n69847216)
print v(xbgr.mr_n69847328)
print v(xbgr.mr_n69849072)
print v(xbgr.mr_n69849344)
print v(xbgr.mr_n69849536)
print v(xbgr.mr_n69850048)
print v(xbgr.mr_n69851280)
print v(xbgr.mr_n69851792)
print v(xbgr.mr_n69855232)
print v(xbgr.mr_n69855504)
print v(xbgr.mr_n69855696)
print v(xbgr.mr_n69856208)
print v(xbgr.mr_n69858352)
print v(xbgr.mr_n69858464)
print v(xbgr.mr_n69860208)
print v(xbgr.mr_n69860480)
print v(xbgr.mr_n69860672)
print v(xbgr.mr_n69861184)
print v(xbgr.mr_n69862480)
print v(xbgr.mr_n69862992)
print v(xbgr.mr_n69869984)
print v(xbgr.mr_n69870096)
print v(xbgr.mr_n69870928)
print v(xbgr.mr_n69871040)
print v(xbgr.mr_n69871872)
print v(xbgr.mr_n69871984)
print v(xbgr.mr_n69873072)
print v(xbgr.mr_n69873184)
print v(xbgr.mr_n69874336)
print v(xbgr.mr_n69874448)
print v(xbgr.mr_n69875600)
print v(xbgr.mr_n69875712)
print v(xbgr.mr_n69876864)
print v(xbgr.mr_n69876976)
print v(xbgr.mr_n69878128)
print v(xbgr.mr_n69878240)
print v(xbgr.mr_n69879392)
print v(xbgr.mr_n69879504)
print v(xbgr.mr_n69880656)
print v(xbgr.mr_n69880768)
print v(xbgr.mr_n69881920)
print v(xbgr.mr_n69882032)
print v(xbgr.mr_n69883184)
print v(xbgr.mr_n69883296)
print v(xbgr.mr_n69884448)
print v(xbgr.mr_n69884560)
print v(xbgr.mr_n69885712)
print v(xbgr.mr_n69885824)
print v(xbgr.mr_n69886976)
print v(xbgr.mr_n69887088)
print v(xbgr.mr_n69888352)
print v(xbgr.mr_n69893600)
print v(xbgr.mr_n69894288)
print v(xbgr.mr_n69894976)
print v(xbgr.mr_n69895696)
print v(xbgr.mr_n69896640)
print v(xbgr.mr_n69897584)
print v(xbgr.mr_n69898528)
print v(xbgr.mr_n69899472)
print v(xbgr.mr_n69900416)
print v(xbgr.mr_n69901360)
print v(xbgr.mr_n69902304)
print v(xbgr.mr_n69903248)
print v(xbgr.mr_n69904192)
print v(xbgr.mr_n69905136)
print v(xbgr.mr_n69906080)
print v(xbgr.mr_n69907024)
print v(xbgr.mr_n69907968)
print v(xbgr.mr_n69908912)
print v(xbgr.mr_n69909856)
print v(xbgr.mr_n69910816)
print v(xbgr.mr_n69911440)
print v(xbgr.mr_n69915600)
print v(xbgr.mr_n69918608)
print v(xbgr.mr_n69921360)
print v(xbgr.mr_n69923984)
print v(xbgr.mr_n69925392)
print v(xbgr.mr_n69926960)
print v(xbgr.mr_n69929440)
print v(xbgr.mr_n69929872)
print v(xbgr.mr_n69930480)
print v(xbgr.mr_n69930592)
print v(xbgr.mr_n69931536)
print v(xbgr.mr_n69932624)
print v(xbgr.mr_n69932736)
print v(xbgr.mr_n69934576)
print v(xbgr.mr_n69934688)
print v(xbgr.mr_n69935632)
print v(xbgr.mr_n69936784)
print v(xbgr.mr_n69936896)
print v(xbgr.mr_n69938672)
print v(xbgr.mr_n69938784)
print v(xbgr.mr_n69939728)
print v(xbgr.mr_n69940880)
print v(xbgr.mr_n69940992)
print v(xbgr.mr_n69942768)
print v(xbgr.mr_n69942880)
print v(xbgr.mr_n69943824)
print v(xbgr.mr_n69944976)
print v(xbgr.mr_n69945088)
print v(xbgr.mr_n69946864)
print v(xbgr.mr_n69946976)
print v(xbgr.mr_n69947920)
print v(xbgr.mr_n69949072)
print v(xbgr.mr_n69949184)
print v(xbgr.mr_n69950432)
print v(xbgr.mr_n69950960)
print v(xbgr.mr_n69951072)
print v(xbgr.mr_n69952016)
print v(xbgr.mr_n69953168)
print v(xbgr.mr_n69953280)
print v(xbgr.mr_n69955056)
print v(xbgr.mr_n69955168)
print v(xbgr.mr_n69956112)
print v(xbgr.mr_n69957200)
print v(xbgr.mr_n69957312)
print v(xbgr.mr_n69959152)
print v(xbgr.mr_n69959264)
print v(xbgr.mr_n69960208)
print v(xbgr.mr_n69961360)
print v(xbgr.mr_n69961472)
print v(xbgr.mr_n69963184)
print v(xbgr.mr_n69963296)
print v(xbgr.mr_n69963856)
print v(xbgr.mr_n69965024)
print v(xbgr.mr_n69966144)
print v(xbgr.mr_n69968992)
print v(xbgr.mr_n69970560)
print v(xbgr.mr_n69972128)
print v(xbgr.mr_n69973136)
print v(xbgr.mr_n69973472)
print v(xbgr.mr_n69976928)
print v(xbgr.mr_n69984464)
print v(xbgr.mr_n69984576)
print v(xbgr.mr_n69990864)
print v(xbgr.mr_n69991632)
print v(xbgr.mr_n69993344)
print v(xbgr.mr_n70000112)
print v(xbgr.mr_n70000304)
print v(xbgr.mr_n70001136)
print v(xbgr.mr_n70001568)
print v(xbgr.mr_n70002400)
print v(xbgr.mr_n70002976)
print v(xbgr.mr_n70003664)
print v(xbgr.mr_n70004240)
print v(xbgr.mr_n70004928)
print v(xbgr.mr_n70005360)
print v(xbgr.mr_n70006192)
print v(xbgr.mr_n70006768)
print v(xbgr.mr_n70007456)
print v(xbgr.mr_n70007888)
print v(xbgr.mr_n70008720)
print v(xbgr.mr_n70009424)
print v(xbgr.mr_n70009984)
print v(xbgr.mr_n70010560)
print v(xbgr.mr_n70011248)
print v(xbgr.mr_n70011680)
print v(xbgr.mr_n70012512)
print v(xbgr.mr_n70013088)
print v(xbgr.mr_n70013776)
print v(xbgr.mr_n70014480)
print v(xbgr.mr_n70015040)
print v(xbgr.mr_n70015616)
print v(xbgr.mr_n70016304)
print v(xbgr.mr_n70016880)
print v(xbgr.mr_n70017568)
print v(xbgr.mr_n70018000)
print v(xbgr.mr_n70018832)
print v(xbgr.mr_n70019264)
print v(xbgr.mr_n70020096)
print v(xbgr.mr_n70020672)
print v(xbgr.mr_n70021360)
print v(xbgr.mr_n70021808)
print v(xbgr.mr_n70024864)
print v(xbgr.mr_n70024976)
print v(xbgr.mr_n70025088)
print v(xbgr.mr_n70025200)
print v(xbgr.mr_n70027520)
print v(xbgr.mr_n70027792)
print v(xbgr.mr_n70027984)
print v(xbgr.mr_n70028496)
print v(xbgr.mr_n70029728)
print v(xbgr.mr_n70030240)
print v(xbgr.mr_n70031792)
print v(xbgr.mr_n70032304)
print v(xbgr.mr_n70034304)
print v(xbgr.mr_n70034816)
print v(xbgr.mr_n70036688)
print v(xbgr.mr_n70037200)
print v(xbgr.mr_n70039136)
print v(xbgr.mr_n70039648)
print v(xbgr.mr_n70041584)
print v(xbgr.mr_n70042096)
print v(xbgr.mr_n70044032)
print v(xbgr.mr_n70044544)
print v(xbgr.mr_n70046480)
print v(xbgr.mr_n70046992)
print v(xbgr.mr_n70048928)
print v(xbgr.mr_n70049440)
print v(xbgr.mr_n70051376)
print v(xbgr.mr_n70051888)
print v(xbgr.mr_n70053824)
print v(xbgr.mr_n70054336)
print v(xbgr.mr_n70056336)
print v(xbgr.mr_n70056848)
print v(xbgr.mr_n70058784)
print v(xbgr.mr_n70059296)
print v(xbgr.mr_n70061168)
print v(xbgr.mr_n70061680)
print v(xbgr.mr_n70063616)
print v(xbgr.mr_n70064128)
print v(xbgr.mr_n70065216)
print v(xbgr.mr_n70066128)
print v(xbgr.mr_n70066640)
print v(xbgr.mr_n70068608)
print v(xbgr.mr_n70074496)
print v(xbgr.mr_n70075648)
print v(xbgr.mr_n70075760)
print v(xbgr.mr_n70076912)
print v(xbgr.mr_n70077024)
print v(xbgr.mr_n70078176)
print v(xbgr.mr_n70078288)
print v(xbgr.mr_n70079440)
print v(xbgr.mr_n70079552)
print v(xbgr.mr_n70080704)
print v(xbgr.mr_n70080816)
print v(xbgr.mr_n70081968)
print v(xbgr.mr_n70082080)
print v(xbgr.mr_n70083232)
print v(xbgr.mr_n70083344)
print v(xbgr.mr_n70084432)
print v(xbgr.mr_n70084544)
print v(xbgr.mr_n70085760)
print v(xbgr.mr_n70085872)
print v(xbgr.mr_n70087024)
print v(xbgr.mr_n70087136)
print v(xbgr.mr_n70088288)
print v(xbgr.mr_n70088400)
print v(xbgr.mr_n70089552)
print v(xbgr.mr_n70089664)
print v(xbgr.mr_n70090816)
print v(xbgr.mr_n70090928)
print v(xbgr.mr_n70092080)
print v(xbgr.mr_n70092192)
print v(xbgr.mr_n70093344)
print v(xbgr.mr_n70093456)
print v(xbgr.mr_n70094336)
print v(xbgr.mr_n70095024)
print v(xbgr.mr_n70095712)
print v(xbgr.mr_n70096432)
print v(xbgr.mr_n70097376)
print v(xbgr.mr_n70098320)
print v(xbgr.mr_n70098912)
print v(xbgr.mr_n70099024)
print v(xbgr.mr_n70099136)
print v(xbgr.mr_n70099248)
print v(xbgr.mr_n70099360)
print v(xbgr.mr_n70100528)
print v(xbgr.mr_n70109168)
print v(xbgr.mr_n70110688)
print v(xbgr.mr_n70114768)
print v(xbgr.mr_n70121792)
print v(xbgr.mr_n70123408)
print v(xbgr.mr_n70124256)
print v(xbgr.mr_n70127392)
print v(xbgr.mr_n70129200)
print v(xbgr.mr_n70129776)
print v(xbgr.mr_n70130384)
print v(xbgr.mr_n70130880)
print v(xbgr.mr_n70131616)
print v(xbgr.mr_n70131728)
print v(xbgr.mr_n70132672)
print v(xbgr.mr_n70133824)
print v(xbgr.mr_n70133936)
print v(xbgr.mr_n70135184)
print v(xbgr.mr_n70135712)
print v(xbgr.mr_n70135824)
print v(xbgr.mr_n70136768)
print v(xbgr.mr_n70137920)
print v(xbgr.mr_n70138032)
print v(xbgr.mr_n70139280)
print v(xbgr.mr_n70139808)
print v(xbgr.mr_n70139920)
print v(xbgr.mr_n70140864)
print v(xbgr.mr_n70142016)
print v(xbgr.mr_n70142128)
print v(xbgr.mr_n70143904)
print v(xbgr.mr_n70144016)
print v(xbgr.mr_n70144960)
print v(xbgr.mr_n70146112)
print v(xbgr.mr_n70146224)
print v(xbgr.mr_n70147472)
print v(xbgr.mr_n70148000)
print v(xbgr.mr_n70148112)
print v(xbgr.mr_n70149056)
print v(xbgr.mr_n70150208)
print v(xbgr.mr_n70150320)
print v(xbgr.mr_n70152096)
print v(xbgr.mr_n70152208)
print v(xbgr.mr_n70153152)
print v(xbgr.mr_n70154240)
print v(xbgr.mr_n70154352)
print v(xbgr.mr_n70156192)
print v(xbgr.mr_n70156304)
print v(xbgr.mr_n70157248)
print v(xbgr.mr_n70158400)
print v(xbgr.mr_n70158512)
print v(xbgr.mr_n70160288)
print v(xbgr.mr_n70160400)
print v(xbgr.mr_n70161344)
print v(xbgr.mr_n70162496)
print v(xbgr.mr_n70162608)
print v(xbgr.mr_n70164384)
print v(xbgr.mr_n70164496)
print v(xbgr.mr_n70165808)
print v(xbgr.mr_n70166928)
print v(xbgr.mr_n70169024)
print v(xbgr.mr_n70170592)
print v(xbgr.mr_n70172160)
print v(xbgr.mr_n70173728)
print v(xbgr.mr_n70175296)
print v(xbgr.mr_n70176864)
print v(xbgr.mr_n70178432)
print v(xbgr.mr_n70180208)
print v(xbgr.mr_n70183488)
print v(xbgr.mr_n70184880)
print v(xbgr.mr_n70189952)
print v(xbgr.mr_n70191488)
print v(xbgr.mr_n70192704)
print v(xbgr.mr_n70196176)
print v(xbgr.mr_n70198032)
print v(xbgr.mr_n70198144)
print v(xbgr.mr_n70199088)
print v(xbgr.mr_n70199280)
print v(xbgr.mr_n70199472)
print v(xbgr.mr_n70199664)
print v(xbgr.mr_n70201920)
print v(xbgr.mr_n70202192)
print v(xbgr.mr_n70202384)
print v(xbgr.mr_n70202896)
print v(xbgr.mr_n70207024)
print v(xbgr.mr_n70207136)
print v(xbgr.mr_n70208880)
print v(xbgr.mr_n70209152)
print v(xbgr.mr_n70209344)
print v(xbgr.mr_n70209856)
print v(xbgr.mr_n70212000)
print v(xbgr.mr_n70212112)
print v(xbgr.mr_n70213856)
print v(xbgr.mr_n70214048)
print v(xbgr.mr_n70214240)
print v(xbgr.mr_n70214832)
print v(xbgr.mr_n70216976)
print v(xbgr.mr_n70217088)
print v(xbgr.mr_n70218832)
print v(xbgr.mr_n70219104)
print v(xbgr.mr_n70219296)
print v(xbgr.mr_n70219808)
print v(xbgr.mr_n70221952)
print v(xbgr.mr_n70222064)
print v(xbgr.mr_n70223808)
print v(xbgr.mr_n70224080)
print v(xbgr.mr_n70224272)
print v(xbgr.mr_n70224784)
print v(xbgr.mr_n70226928)
print v(xbgr.mr_n70227040)
print v(xbgr.mr_n70228784)
print v(xbgr.mr_n70229056)
print v(xbgr.mr_n70229248)
print v(xbgr.mr_n70229760)
print v(xbgr.mr_n70231904)
print v(xbgr.mr_n70232016)
print v(xbgr.mr_n70233760)
print v(xbgr.mr_n70234256)
print v(xbgr.mr_n70236096)
print v(xbgr.mr_n70236784)
print v(xbgr.mr_n70237888)
print v(xbgr.mr_n70238000)
print v(xbgr.mr_n70238112)
print v(xbgr.mr_n70238224)
print v(xbgr.mr_n70239968)
print v(xbgr.mr_n70240240)
print v(xbgr.mr_n70240432)
print v(xbgr.mr_n70240944)
print v(xbgr.mr_n70244976)
print v(xbgr.mr_n70245088)
print v(xbgr.mr_n70246832)
print v(xbgr.mr_n70247104)
print v(xbgr.mr_n70247296)
print v(xbgr.mr_n70247808)
print v(xbgr.mr_n70249952)
print v(xbgr.mr_n70250064)
print v(xbgr.mr_n70251808)
print v(xbgr.mr_n70252080)
print v(xbgr.mr_n70252272)
print v(xbgr.mr_n70252784)
print v(xbgr.mr_n70254928)
print v(xbgr.mr_n70255040)
print v(xbgr.mr_n70256784)
print v(xbgr.mr_n70257056)
print v(xbgr.mr_n70257248)
print v(xbgr.mr_n70257760)
print v(xbgr.mr_n70259904)
print v(xbgr.mr_n70260016)
print v(xbgr.mr_n70261760)
print v(xbgr.mr_n70262032)
print v(xbgr.mr_n70262224)
print v(xbgr.mr_n70262736)
print v(xbgr.mr_n70264880)
print v(xbgr.mr_n70265072)
print v(xbgr.mr_n70265264)
print v(xbgr.mr_n70267072)
print v(xbgr.mr_n70267264)
print v(xbgr.mr_n70267776)
print v(xbgr.mr_n70269856)
print v(xbgr.mr_n70269968)
print v(xbgr.mr_n70271712)
print v(xbgr.mr_n70271984)
print v(xbgr.mr_n70272176)
print v(xbgr.mr_n70272688)
print v(xbgr.mr_n70274832)
print v(xbgr.mr_n70274944)
print v(xbgr.mr_n70276688)
print v(xbgr.mr_n70276960)
print v(xbgr.mr_n70277152)
print v(xbgr.mr_n70277664)
print v(xbgr.mr_n70279808)
print v(xbgr.mr_n70279920)
print v(xbgr.mr_n70281664)
print v(xbgr.mr_n70281936)
print v(xbgr.mr_n70282128)
print v(xbgr.mr_n70282640)
print v(xbgr.mr_n70284048)
print v(xbgr.mr_n70284352)
print v(xbgr.mr_n70292720)
print v(xbgr.mr_n70293488)
print v(xbgr.mr_n70295360)
print v(xbgr.mr_n70298992)
print v(xbgr.mr_n70305872)
print v(xbgr.mr_n70314288)
print v(xbgr.mr_n70316032)
print v(xbgr.mr_n70320224)
print v(xbgr.mr_n70320336)
print v(xbgr.mr_n70321488)
print v(xbgr.mr_n70321600)
print v(xbgr.mr_n70322752)
print v(xbgr.mr_n70322864)
print v(xbgr.mr_n70324016)
print v(xbgr.mr_n70324128)
print v(xbgr.mr_n70325280)
print v(xbgr.mr_n70325392)
print v(xbgr.mr_n70326544)
print v(xbgr.mr_n70326656)
print v(xbgr.mr_n70327808)
print v(xbgr.mr_n70327920)
print v(xbgr.mr_n70329072)
print v(xbgr.mr_n70329184)
print v(xbgr.mr_n70330336)
print v(xbgr.mr_n70330448)
print v(xbgr.mr_n70331600)
print v(xbgr.mr_n70331712)
print v(xbgr.mr_n70332864)
print v(xbgr.mr_n70332976)
print v(xbgr.mr_n70334128)
print v(xbgr.mr_n70334240)
print v(xbgr.mr_n70335392)
print v(xbgr.mr_n70335504)
print v(xbgr.mr_n70336656)
print v(xbgr.mr_n70336768)
print v(xbgr.mr_n70337920)
print v(xbgr.mr_n70338032)
print v(xbgr.mr_n70341616)
print v(xbgr.mr_n70343712)
print v(xbgr.mr_n70345920)
print v(xbgr.mr_n70348192)
print v(xbgr.mr_n70348880)
print v(xbgr.mr_n70349568)
print v(xbgr.mr_n70350288)
print v(xbgr.mr_n70351232)
print v(xbgr.mr_n70352176)
print v(xbgr.mr_n70353120)
print v(xbgr.mr_n70354064)
print v(xbgr.mr_n70355008)
print v(xbgr.mr_n70355952)
print v(xbgr.mr_n70356896)
print v(xbgr.mr_n70357840)
print v(xbgr.mr_n70358784)
print v(xbgr.mr_n70359728)
print v(xbgr.mr_n70360672)
print v(xbgr.mr_n70361616)
print v(xbgr.mr_n70362560)
print v(xbgr.mr_n70363504)
print v(xbgr.mr_n70364448)
print v(xbgr.mr_n70365392)
print v(xbgr.mr_n70365504)
print v(xbgr.mr_n70366336)
print v(xbgr.mr_n70367280)
print v(xbgr.mr_n70368224)
print v(xbgr.mr_n70369776)
print v(xbgr.mr_n70381728)
print v(xbgr.mr_n70381872)
print v(xbgr.mr_n70382304)
print v(xbgr.mr_n70384656)
print v(xbgr.mr_n70385280)
print v(xbgr.mr_n70385488)
print v(xbgr.mr_n70385904)
print v(xbgr.mr_n70386336)
print v(xbgr.mr_n70387920)
print v(xbgr.mr_n70388208)
print v(xbgr.mr_n70390208)
print v(xbgr.mr_n70391904)
print v(xbgr.mr_n70392896)
print v(xbgr.mr_n70394368)
print v(xbgr.mr_n70394784)
print v(xbgr.mr_n70395200)
print v(xbgr.mr_n70395776)
print v(xbgr.mr_n70396128)
print v(xbgr.mr_n70396304)
print v(xbgr.mr_n70396896)
print v(xbgr.mr_n70397424)
print v(xbgr.mr_n70397776)
print v(xbgr.mr_n70398768)
print v(xbgr.mr_n70399008)
print v(xbgr.mr_n70399472)
print v(xbgr.mr_n70399648)
print v(xbgr.mr_n70400000)
print v(xbgr.mr_n70400240)
print v(xbgr.mr_n70400704)
print v(xbgr.mr_n70401760)
print v(xbgr.mr_n70402176)
print v(xbgr.mr_n70402816)
print v(xbgr.mr_n70403168)
print v(xbgr.mr_n70403344)
print v(xbgr.mr_n70403936)
print v(xbgr.mr_n70405104)
print v(xbgr.mr_n70406224)
print v(xbgr.mr_n70408448)
print v(xbgr.mr_n70408800)
print v(xbgr.mr_n70408976)
print v(xbgr.mr_n70409152)
print v(xbgr.mr_n70409328)
print v(xbgr.mr_n70409504)
print v(xbgr.mr_n70409680)
print v(xbgr.mr_n70409856)
print v(xbgr.mr_n70410032)
print v(xbgr.mr_n70410800)
print v(xbgr.mr_n70411808)
print v(xbgr.mr_n70411984)
print v(xbgr.mr_n70413680)
print v(xbgr.mr_n70414736)
print v(xbgr.mr_n70415936)
print v(xbgr.mr_n70416128)
print v(xbgr.mr_n70416480)
print v(xbgr.mr_n70417088)
print v(xbgr.mr_n70418032)
print v(xbgr.mr_n70418976)
print v(xbgr.mr_n70419920)
print v(xbgr.mr_n70420864)
print v(xbgr.mr_n70421808)
print v(xbgr.mr_n70422752)
print v(xbgr.mr_n70423696)
print v(xbgr.mr_n70424640)
print v(xbgr.mr_n70425584)
print v(xbgr.mr_n70426528)
print v(xbgr.mr_n70427472)
print v(xbgr.mr_n70428416)
print v(xbgr.mr_n70429360)
print v(xbgr.mr_n70430304)
print v(xbgr.mr_n70431248)
print v(xbgr.mr_n70432192)
print v(xbgr.mr_n70433136)
print v(xbgr.mr_n70434080)
print v(xbgr.mr_n70435024)
print v(xbgr.mr_n70435968)
print v(xbgr.mr_n70436912)
print v(xbgr.mr_n70437856)
print v(xbgr.mr_n70438800)
print v(xbgr.mr_n70439744)
print v(xbgr.mr_n70440688)
print v(xbgr.mr_n70441632)
print v(xbgr.mr_n70442576)
print v(xbgr.mr_n70443520)
print v(xbgr.mr_n70444464)
print v(xbgr.mr_n70445408)
print v(xbgr.mr_n70446352)
print v(xbgr.mr_n70447296)
print v(xbgr.mr_n70448240)
print v(xbgr.mr_n70449184)
print v(xbgr.mr_n70450128)
print v(xbgr.mr_n70451072)
print v(xbgr.mr_n70452016)
print v(xbgr.mr_n70452960)
print v(xbgr.mr_n70453904)
print v(xbgr.mr_n70454848)
print v(xbgr.mr_n70455792)
print v(xbgr.mr_n70456736)
print v(xbgr.mr_n70457680)
print v(xbgr.mr_n70458624)
print v(xbgr.mr_n70459568)
print v(xbgr.mr_n70460512)
print v(xbgr.mr_n70461456)
print v(xbgr.mr_n70462400)
print v(xbgr.mr_n70463344)
print v(xbgr.mr_n70464288)
print v(xbgr.mr_n70465232)
print v(xbgr.mr_n70466176)
print v(xbgr.mr_n70467120)
print v(xbgr.mr_n70468064)
print v(xbgr.mr_n70469008)
print v(xbgr.mr_n70469952)
print v(xbgr.mr_n70470896)
print v(xbgr.mr_n70471840)
print v(xbgr.mr_n70472784)
print v(xbgr.mr_n70473728)
print v(xbgr.mr_n70474672)
print v(xbgr.mr_n70475616)
print v(xbgr.mr_n70476560)
print v(xbgr.mr_n70477504)
print v(xbgr.mr_n70478448)
print v(xbgr.mr_n70479392)
print v(xbgr.mr_n70480336)
print v(xbgr.mr_n70481280)
print v(xbgr.mr_n70482224)
print v(xbgr.mr_n70483168)
print v(xbgr.mr_n70484112)
print v(xbgr.mr_n70485056)
print v(xbgr.mr_n70486000)
print v(xbgr.mr_n70486944)
print v(xbgr.mr_n70487888)
print v(xbgr.mr_n70488832)
print v(xbgr.mr_n70489776)
print v(xbgr.mr_n70490720)
print v(xbgr.mr_n70491664)
print v(xbgr.mr_n70492608)
print v(xbgr.mr_n70493552)
print v(xbgr.mr_n70494496)
print v(xbgr.mr_n70495440)
print v(xbgr.mr_n70496384)
print v(xbgr.mr_n70497328)
print v(xbgr.mr_n70498272)
print v(xbgr.mr_n70499216)
print v(xbgr.mr_n70500160)
print v(xbgr.mr_n70501104)
print v(xbgr.mr_n70502048)
print v(xbgr.mr_n70502992)
print v(xbgr.mr_n70503936)
print v(xbgr.mr_n70506656)
print v(xbgr.mr_n70506848)
print v(xbgr.mr_n70507488)
print v(xbgr.mr_n70511568)
print v(xbgr.mr_n70513088)
print v(xbgr.mr_n70513280)
print v(xbgr.mr_n70513472)
print v(xbgr.mr_n70515280)
print v(xbgr.mr_n70515472)
print v(xbgr.mr_n70515984)
print v(xbgr.mr_n70519104)
print v(xbgr.mr_n70519216)
print v(xbgr.mr_n70519328)
print v(xbgr.mr_n70519440)
print v(xbgr.mr_n70521184)
print v(xbgr.mr_n70521456)
print v(xbgr.mr_n70521648)
print v(xbgr.mr_n70522160)
print v(xbgr.mr_n70523392)
print v(xbgr.mr_n70523904)
print v(xbgr.mr_n70526752)
print v(xbgr.mr_n70526864)
print v(xbgr.mr_n70528608)
print v(xbgr.mr_n70528880)
print v(xbgr.mr_n70529072)
print v(xbgr.mr_n70529584)
print v(xbgr.mr_n70532768)
print v(xbgr.mr_n70532880)
print v(xbgr.mr_n70532992)
print v(xbgr.mr_n70533184)
print v(xbgr.mr_n70533376)
print v(xbgr.mr_n70535184)
print v(xbgr.mr_n70535376)
print v(xbgr.mr_n70535888)
print v(xbgr.mr_n70539008)
print v(xbgr.mr_n70539120)
print v(xbgr.mr_n70539232)
print v(xbgr.mr_n70539344)
print v(xbgr.mr_n70541088)
print v(xbgr.mr_n70541360)
print v(xbgr.mr_n70541552)
print v(xbgr.mr_n70542064)
print v(xbgr.mr_n70543296)
print v(xbgr.mr_n70543808)
print v(xbgr.mr_n70546176)
print v(xbgr.mr_n70546656)
print v(xbgr.mr_n70546768)
print v(xbgr.mr_n70548512)
print v(xbgr.mr_n70548784)
print v(xbgr.mr_n70548976)
print v(xbgr.mr_n70549488)
print v(xbgr.mr_n70552672)
print v(xbgr.mr_n70552784)
print v(xbgr.mr_n70552896)
print v(xbgr.mr_n70553008)
print v(xbgr.mr_n70554752)
print v(xbgr.mr_n70555024)
print v(xbgr.mr_n70555216)
print v(xbgr.mr_n70555728)
print v(xbgr.mr_n70557664)
print v(xbgr.mr_n70558912)
print v(xbgr.mr_n70559024)
print v(xbgr.mr_n70559136)
print v(xbgr.mr_n70559248)
print v(xbgr.mr_n70560992)
print v(xbgr.mr_n70561264)
print v(xbgr.mr_n70561456)
print v(xbgr.mr_n70561968)
print v(xbgr.mr_n70563200)
print v(xbgr.mr_n70563712)
print v(xbgr.mr_n70566560)
print v(xbgr.mr_n70566752)
print v(xbgr.mr_n70566944)
print v(xbgr.mr_n70568752)
print v(xbgr.mr_n70568944)
print v(xbgr.mr_n70569456)
print v(xbgr.mr_n70572576)
print v(xbgr.mr_n70572688)
print v(xbgr.mr_n70572800)
print v(xbgr.mr_n70572912)
print v(xbgr.mr_n70574656)
print v(xbgr.mr_n70574928)
print v(xbgr.mr_n70575120)
print v(xbgr.mr_n70575632)
print v(xbgr.mr_n70578816)
print v(xbgr.mr_n70578928)
print v(xbgr.mr_n70579040)
print v(xbgr.mr_n70579152)
print v(xbgr.mr_n70580896)
print v(xbgr.mr_n70581088)
print v(xbgr.mr_n70581280)
print v(xbgr.mr_n70581872)
print v(xbgr.mr_n70582240)
print v(xbgr.mr_n70583104)
print v(xbgr.mr_n70583616)
print v(xbgr.mr_n70586464)
print v(xbgr.mr_n70586576)
print v(xbgr.mr_n70588320)
print v(xbgr.mr_n70588592)
print v(xbgr.mr_n70588784)
print v(xbgr.mr_n70589296)
print v(xbgr.mr_n70591360)
print v(xbgr.mr_n70591472)
print v(xbgr.mr_n70591984)
print v(xbgr.mr_n70592096)
print v(xbgr.mr_n70592608)
print v(xbgr.mr_n70592720)
print v(xbgr.mr_n70593488)
print v(xbgr.mr_n70593600)
print v(xbgr.mr_n70594432)
print v(xbgr.mr_n70594544)
print v(xbgr.mr_n70595632)
print v(xbgr.mr_n70595744)
print v(xbgr.mr_n70596896)
print v(xbgr.mr_n70597008)
print v(xbgr.mr_n70598160)
print v(xbgr.mr_n70598272)
print v(xbgr.mr_n70599424)
print v(xbgr.mr_n70599536)
print v(xbgr.mr_n70600688)
print v(xbgr.mr_n70600800)
print v(xbgr.mr_n70601952)
print v(xbgr.mr_n70602064)
print v(xbgr.mr_n70603216)
print v(xbgr.mr_n70603328)
print v(xbgr.mr_n70604480)
print v(xbgr.mr_n70604592)
print v(xbgr.mr_n70605744)
print v(xbgr.mr_n70605856)
print v(xbgr.mr_n70606944)
print v(xbgr.mr_n70607056)
print v(xbgr.mr_n70608272)
print v(xbgr.mr_n70608384)
print v(xbgr.mr_n70617872)
print v(xbgr.mr_n70624192)
print v(xbgr.mr_n70634752)
print v(xbgr.mr_n70635632)
print v(xbgr.mr_n70635952)
print v(xbgr.mr_n70636144)
print v(xbgr.mr_n70638992)
print v(xbgr.mr_n70639104)
print v(xbgr.mr_n70640800)
print v(xbgr.mr_n70641296)
print v(xbgr.mr_n70642448)
print v(xbgr.mr_n70643152)
print v(xbgr.mr_n70644048)
print v(xbgr.mr_n70645136)
print v(xbgr.mr_n70650272)
print v(xbgr.mr_n70650384)
print v(xbgr.mr_n70650496)
print v(xbgr.mr_n70651488)
print v(xbgr.mr_n70657968)
print v(xbgr.mr_n70661680)
print v(xbgr.mr_n70662800)
print v(xbgr.mr_n70664096)
print v(xbgr.mr_n70665664)
print v(xbgr.mr_n70668096)
print v(xbgr.mr_n70669040)
print v(xbgr.mr_n70669984)
print v(xbgr.mr_n70670928)
print v(xbgr.mr_n70671872)
print v(xbgr.mr_n70672816)
print v(xbgr.mr_n70673760)
print v(xbgr.mr_n70674704)
print v(xbgr.mr_n70675648)
print v(xbgr.mr_n70676592)
print v(xbgr.mr_n70677536)
print v(xbgr.mr_n70678480)
print v(xbgr.mr_n70679424)
print v(xbgr.mr_n70680368)
print v(xbgr.mr_n70681312)
print v(xbgr.mr_n70682256)
print v(xbgr.mr_n70683200)
print v(xbgr.mr_n70684144)
print v(xbgr.mr_n70685088)
print v(xbgr.mr_n70686032)
print v(xbgr.mr_n70686976)
print v(xbgr.mr_n70687920)
print v(xbgr.mr_n70688864)
print v(xbgr.mr_n70689808)
print v(xbgr.mr_n70690752)
print v(xbgr.mr_n70691696)
print v(xbgr.mr_n70692640)
print v(xbgr.mr_n70693584)
print v(xbgr.mr_n70694528)
print v(xbgr.mr_n70695920)
print v(xbgr.mr_n70700464)
print v(xbgr.mr_n70701408)
print v(xbgr.mr_n70702352)
print v(xbgr.mr_n70708672)
print v(xbgr.mr_n70708864)
print v(xbgr.mr_n70709696)
print v(xbgr.mr_n70709808)
print v(xbgr.mr_n70709920)
print v(xbgr.mr_n70710032)
print v(xbgr.mr_n70710144)
print v(xbgr.mr_n70711888)
print v(xbgr.mr_n70712160)
print v(xbgr.mr_n70712352)
print v(xbgr.mr_n70712864)
print v(xbgr.mr_n70714800)
print v(xbgr.mr_n70716544)
print v(xbgr.mr_n70716816)
print v(xbgr.mr_n70717008)
print v(xbgr.mr_n70717520)
print v(xbgr.mr_n70719456)
print v(xbgr.mr_n70721200)
print v(xbgr.mr_n70721472)
print v(xbgr.mr_n70721664)
print v(xbgr.mr_n70722176)
print v(xbgr.mr_n70724352)
print v(xbgr.mr_n70724544)
print v(xbgr.mr_n70724736)
print v(xbgr.mr_n70724928)
print v(xbgr.mr_n70727152)
print v(xbgr.mr_n70728768)
print v(xbgr.mr_n70730512)
print v(xbgr.mr_n70730784)
print v(xbgr.mr_n70730976)
print v(xbgr.mr_n70731488)
print v(xbgr.mr_n70733424)
print v(xbgr.mr_n70735168)
print v(xbgr.mr_n70735440)
print v(xbgr.mr_n70735632)
print v(xbgr.mr_n70736144)
print v(xbgr.mr_n70738080)
print v(xbgr.mr_n70740096)
print v(xbgr.mr_n70740288)
print v(xbgr.mr_n70740800)
print v(xbgr.mr_n70742736)
print v(xbgr.mr_n70744480)
print v(xbgr.mr_n70744752)
print v(xbgr.mr_n70744944)
print v(xbgr.mr_n70745456)
print v(xbgr.mr_n70747392)
print v(xbgr.mr_n70749136)
print v(xbgr.mr_n70749408)
print v(xbgr.mr_n70749600)
print v(xbgr.mr_n70750112)
print v(xbgr.mr_n70752048)
print v(xbgr.mr_n70753792)
print v(xbgr.mr_n70754064)
print v(xbgr.mr_n70754256)
print v(xbgr.mr_n70754768)
print v(xbgr.mr_n70756704)
print v(xbgr.mr_n70758448)
print v(xbgr.mr_n70758720)
print v(xbgr.mr_n70758912)
print v(xbgr.mr_n70759424)
print v(xbgr.mr_n70761360)
print v(xbgr.mr_n70761552)
print v(xbgr.mr_n70763104)
print v(xbgr.mr_n70763376)
print v(xbgr.mr_n70763568)
print v(xbgr.mr_n70764080)
print v(xbgr.mr_n70766016)
print v(xbgr.mr_n70767760)
print v(xbgr.mr_n70768032)
print v(xbgr.mr_n70768224)
print v(xbgr.mr_n70768736)
print v(xbgr.mr_n70770672)
print v(xbgr.mr_n70772416)
print v(xbgr.mr_n70772688)
print v(xbgr.mr_n70772880)
print v(xbgr.mr_n70773392)
print v(xbgr.mr_n70775344)
print v(xbgr.mr_n70775456)
print v(xbgr.mr_n70775968)
print v(xbgr.mr_n70777968)
print v(xbgr.mr_n70782704)
print v(xbgr.mr_n70782896)
print v(xbgr.mr_n70784128)
print v(xbgr.mr_n70784704)
print v(xbgr.mr_n70788048)
print v(xbgr.mr_n70791968)
print v(xbgr.mr_n70792288)
print v(xbgr.mr_n70792576)
print v(xbgr.mr_n70794704)
print v(xbgr.mr_n70795840)
print v(xbgr.mr_n70797616)
print v(xbgr.mr_n70797952)
print v(xbgr.mr_n70798544)
print v(xbgr.mr_n70799168)
print v(xbgr.mr_n70800736)
print v(xbgr.mr_n70801328)
print v(xbgr.mr_n70807520)
print v(xbgr.mr_n70809456)
print v(xbgr.mr_n70810112)
print v(xbgr.mr_n70810416)
print v(xbgr.mr_n70811440)
print v(xbgr.mr_n70811552)
print v(xbgr.mr_n70813392)
print v(xbgr.mr_n70814416)
print v(xbgr.mr_n70815184)
print v(xbgr.mr_n70815552)
print v(xbgr.mr_n70816432)
print v(xbgr.mr_n70818192)
print v(xbgr.mr_n70821488)
print v(xbgr.mr_n70823472)
print v(xbgr.mr_n70823984)
print v(xbgr.mr_n70826448)
print v(xbgr.mr_n70826704)
print v(xbgr.mr_n70827472)
print v(xbgr.mr_n70830416)
print v(xbgr.mr_n70831472)
print v(xbgr.mr_n70832208)
print v(xbgr.mr_n70834480)
print v(xbgr.mr_n70836016)
print v(xbgr.mr_n70837984)
print v(xbgr.mr_n70839440)
print v(xbgr.mr_n70839840)
print v(xbgr.mr_n70839952)
print v(xbgr.mr_n70840064)
print v(xbgr.mr_n70840496)
print v(xbgr.mr_n70841008)
print v(xbgr.mr_n70841120)
print v(xbgr.mr_n70841552)
print v(xbgr.mr_n70842064)
print v(xbgr.mr_n70842176)
print v(xbgr.mr_n70842608)
print v(xbgr.mr_n70843120)
print v(xbgr.mr_n70843232)
print v(xbgr.mr_n70843664)
print v(xbgr.mr_n70844976)
print v(xbgr.mr_n70846768)
print v(xbgr.mr_n70847376)
print v(xbgr.mr_n70848288)
print v(xbgr.mr_n70848608)
print v(xbgr.mr_n70851488)
print v(xbgr.mr_n70851888)
print v(xbgr.mr_n70852080)
print v(xbgr.mr_n70852272)
print v(xbgr.mr_n70853952)
print v(xbgr.mr_n70855184)
print v(xbgr.mr_n70857296)
print v(xbgr.mr_n70859344)
print v(xbgr.mr_n70859536)
print v(xbgr.mr_n70859872)
print v(xbgr.mr_n70860336)
print v(xbgr.mr_n70861344)
print v(xbgr.mr_n70866016)
print v(xbgr.mr_n70867840)
print v(xbgr.mr_n70870464)
print v(xbgr.mr_n70870656)
print v(xbgr.mr_n70871664)
print v(xbgr.mr_n70871856)
print v(xbgr.mr_n70872272)
print v(xbgr.mr_n70872784)
print v(xbgr.mr_n70874592)
print v(xbgr.mr_n70877808)
print v(xbgr.mr_n70878544)
print v(xbgr.mr_n70879008)
print v(xbgr.mr_n70879472)
print v(xbgr.mr_n70879936)
print v(xbgr.mr_n70880880)
print v(xbgr.mr_n70881696)
print v(xbgr.mr_n70882032)
print v(xbgr.mr_n70884064)
print v(xbgr.mr_n70884464)
print v(xbgr.mr_n70884864)
print v(xbgr.mr_n70885264)
print v(xbgr.mr_n70885952)
print v(xbgr.mr_n70886352)
print v(xbgr.mr_n70886816)
print v(xbgr.mr_n70891264)
print v(xbgr.mr_n70892144)
print v(xbgr.mr_n70893968)
print v(xbgr.mr_n70894080)
print v(xbgr.mr_n70895040)
print v(xbgr.mr_n70895728)
print v(xbgr.mr_n70896416)
print v(xbgr.mr_n70897104)
print v(xbgr.mr_n70897792)
print v(xbgr.mr_n70898480)
print v(xbgr.mr_n70899168)
print v(xbgr.mr_n70899856)
print v(xbgr.mr_n70900544)
print v(xbgr.mr_n70901232)
print v(xbgr.mr_n70901920)
print v(xbgr.mr_n70902608)
print v(xbgr.mr_n70903296)
print v(xbgr.mr_n70903984)
print v(xbgr.mr_n70904672)
print v(xbgr.mr_n70905360)
print v(xbgr.mr_n70906048)
print v(xbgr.mr_n70906736)
print v(xbgr.mr_n70907424)
print v(xbgr.mr_n70908112)
print v(xbgr.mr_n70908800)
print v(xbgr.mr_n70909488)
print v(xbgr.mr_n70909920)
print v(xbgr.mr_n70910032)
print v(xbgr.mr_n70910144)
print v(xbgr.mr_n70910256)
print v(xbgr.mr_n70912048)
print v(xbgr.mr_n70912560)
print v(xbgr.mr_n70912672)
print v(xbgr.mr_n70913184)
print v(xbgr.mr_n70913296)
print v(xbgr.mr_n70913808)
print v(xbgr.mr_n70913920)
print v(xbgr.mr_n70914432)
print v(xbgr.mr_n70914544)
print v(xbgr.mr_n70915056)
print v(xbgr.mr_n70915168)
print v(xbgr.mr_n70915680)
print v(xbgr.mr_n70915792)
print v(xbgr.mr_n70916304)
print v(xbgr.mr_n70916416)
print v(xbgr.mr_n70916928)
print v(xbgr.mr_n70917040)
print v(xbgr.mr_n70917552)
print v(xbgr.mr_n70917664)
print v(xbgr.mr_n70918432)
print v(xbgr.mr_n70918544)
print v(xbgr.mr_n70919376)
print v(xbgr.mr_n70919488)
print v(xbgr.mr_n70920672)
print v(xbgr.mr_n70920784)
print v(xbgr.mr_n70923216)
print v(xbgr.mr_n70923328)
print v(xbgr.mr_n70924800)
print v(xbgr.mr_n70938672)
print v(xbgr.mr_n70941488)
print v(xbgr.mr_n70941936)
print v(xbgr.mr_n70942128)
print v(xbgr.mr_n70942320)
print v(xbgr.mr_n70942512)
print v(xbgr.mr_n70944832)
print v(xbgr.mr_n70945104)
print v(xbgr.mr_n70945296)
print v(xbgr.mr_n70945808)
print v(xbgr.mr_n70945920)
print v(xbgr.mr_n70946032)
print v(xbgr.mr_n70946144)
print v(xbgr.mr_n70946336)
print v(xbgr.mr_n70946528)
print v(xbgr.mr_n70946720)
print v(xbgr.mr_n70950288)
print v(xbgr.mr_n70969840)
print v(xbgr.mr_n70971456)
print v(xbgr.mr_n70973136)
print v(xbgr.mr_n70975392)
print v(xbgr.mr_n70977648)
print v(xbgr.mr_n70979904)
print v(xbgr.mr_n70982160)
print v(xbgr.mr_n70985024)
print v(xbgr.mr_n71003456)
print v(xbgr.mr_n71004032)
print v(xbgr.mr_n71004720)
print v(xbgr.mr_n71005296)
print v(xbgr.mr_n71005984)
print v(xbgr.mr_n71006560)
print v(xbgr.mr_n71007248)
print v(xbgr.mr_n71007680)
print v(xbgr.mr_n71008512)
print v(xbgr.mr_n71009088)
print v(xbgr.mr_n71009776)
print v(xbgr.mr_n71010208)
print v(xbgr.mr_n71011040)
print v(xbgr.mr_n71011616)
print v(xbgr.mr_n71012304)
print v(xbgr.mr_n71013568)
print v(xbgr.mr_n71025408)
print v(xbgr.mr_n71026512)
print v(xbgr.mr_n71038496)
print v(xbgr.mr_n71045056)
print v(xbgr.mr_n71046064)
print v(xbgr.mr_n71046528)
print v(xbgr.mr_n71048400)
print v(xbgr.mr_n71048512)
print v(xbgr.mr_n71048624)
print v(xbgr.mr_n71048736)
print v(xbgr.mr_n71048848)
print v(xbgr.mr_n71048960)
print v(xbgr.mr_n71049072)
print v(xbgr.mr_n71049184)
print v(xbgr.mr_n71049296)
print v(xbgr.mr_n71049408)
print v(xbgr.mr_n71049760)
print v(xbgr.mr_n71050384)
print v(xbgr.mr_n71050656)
print v(xbgr.mr_n71051088)
print v(xbgr.mr_n71052992)
print v(xbgr.mr_n71053184)
print v(xbgr.mr_n71053584)
print v(xbgr.mr_n71053776)
print v(xbgr.mr_n71054112)
print v(xbgr.mr_n71054928)
print v(xbgr.mr_n71055200)
print v(xbgr.mr_n71055952)
print v(xbgr.mr_n71058272)
print v(xbgr.mr_n71058704)
print v(xbgr.mr_n71058816)
print v(xbgr.mr_n71059328)
print v(xbgr.mr_n71059440)
print v(xbgr.mr_n71059952)
print v(xbgr.mr_n71060064)
print v(xbgr.mr_n71060576)
print v(xbgr.mr_n71060688)
print v(xbgr.mr_n71061200)
print v(xbgr.mr_n71061312)
print v(xbgr.mr_n71061824)
print v(xbgr.mr_n71061936)
print v(xbgr.mr_n71062448)
print v(xbgr.mr_n71062560)
print v(xbgr.mr_n71063072)
print v(xbgr.mr_n71063184)
print v(xbgr.mr_n71072256)
print v(xbgr.mr_n71074256)
print v(xbgr.mr_n71075264)
print v(xbgr.mr_n71076672)
print v(xbgr.mr_n71077360)
print v(xbgr.mr_n71078048)
print v(xbgr.mr_n71078736)
print v(xbgr.mr_n71079424)
print v(xbgr.mr_n71080112)
print v(xbgr.mr_n71080800)
print v(xbgr.mr_n71081488)
print v(xbgr.mr_n71082176)
print v(xbgr.mr_n71082864)
print v(xbgr.mr_n71083552)
print v(xbgr.mr_n71085456)
print v(xbgr.mr_n71086592)
print v(xbgr.mr_n71087536)
print v(xbgr.mr_n71088480)
print v(xbgr.mr_n71089424)
print v(xbgr.mr_n71090368)
print v(xbgr.mr_n71091312)
print v(xbgr.mr_n71099264)
print v(xbgr.mr_n71099648)
print v(xbgr.mr_n71101568)
print v(xbgr.mr_n71101952)
print v(xbgr.mr_n71103872)
print v(xbgr.mr_n71104256)
print v(xbgr.mr_n71104640)
print v(xbgr.mr_n71105408)
print v(xbgr.mr_n71106176)
print v(xbgr.mr_n71106560)
print v(xbgr.mr_n71107328)
print v(xbgr.mr_n71107712)
print v(xbgr.mr_n71108176)
print v(xbgr.mr_n71108560)
print v(xbgr.mr_n71109536)
print v(xbgr.mr_n71110304)
print v(xbgr.mr_n71111168)
print v(xbgr.mr_n71112624)
print v(xbgr.mr_n71113664)
print v(xbgr.mr_n71115776)
print v(xbgr.mr_n71117232)
print v(xbgr.mr_n71120128)
print v(xbgr.mr_n71120768)
print v(xbgr.mr_n71121552)
print v(xbgr.mr_n71121664)
print v(xbgr.mr_n71122784)
print v(xbgr.mr_n71122992)
print v(xbgr.mr_n71123456)
print v(xbgr.mr_n71131600)
print v(xbgr.mr_n71133168)
print v(xbgr.mr_n71134704)
print v(xbgr.mr_n71135248)
print v(xbgr.mr_n71136976)
print v(xbgr.mr_n71138032)
print v(xbgr.mr_n71139184)
print v(xbgr.mr_n71139296)
print v(xbgr.mr_n71139984)
print v(xbgr.mr_n71141264)
print v(xbgr.mr_n71142960)
print v(xbgr.mr_n71143216)
print v(xbgr.mr_n71143728)
print v(xbgr.mr_n71145792)
print v(xbgr.mr_n71147568)
print v(xbgr.mr_n71147680)
print v(xbgr.mr_n71148112)
print v(xbgr.mr_n71148624)
print v(xbgr.mr_n71148736)
print v(xbgr.mr_n71149168)
print v(xbgr.mr_n71149680)
print v(xbgr.mr_n71149792)
print v(xbgr.mr_n71150224)
print v(xbgr.mr_n71150736)
print v(xbgr.mr_n71150848)
print v(xbgr.mr_n71152560)
print v(xbgr.mr_n71152896)
print v(xbgr.mr_n71153760)
print v(xbgr.mr_n71154688)
print v(xbgr.mr_n71156560)
print v(xbgr.mr_n71157728)
print v(xbgr.mr_n71159264)
print v(xbgr.mr_n71161440)
print v(xbgr.mr_n71163008)
print v(xbgr.mr_n71163552)
print v(xbgr.mr_n71163744)
print v(xbgr.mr_n71164992)
print v(xbgr.mr_n71165504)
print v(xbgr.mr_n71168496)
print v(xbgr.mr_n71172160)
print v(xbgr.mr_n71175456)
print v(xbgr.mr_n71177120)
print v(xbgr.mr_n71180736)
print v(xbgr.mr_n71182992)
print v(xbgr.mr_n71187648)
print v(xbgr.mr_n71189184)
print v(xbgr.mr_n71190240)
print v(xbgr.mr_n71190400)
print v(xbgr.mr_n71193568)
print v(xbgr.mr_n71194048)
print v(xbgr.mr_n71194688)
print v(xbgr.mr_n71195072)
print v(xbgr.mr_n71196000)
print v(xbgr.mr_n71196192)
print v(xbgr.mr_n71197648)
print v(xbgr.mr_n71201296)
print v(xbgr.mr_n71201632)
print v(xbgr.mr_n71202096)
print v(xbgr.mr_n71202560)
print v(xbgr.mr_n71202752)
print v(xbgr.mr_n71203392)
print v(xbgr.mr_n71204064)
print v(xbgr.mr_n71204176)
print v(xbgr.mr_n71204640)
print v(xbgr.mr_n71205104)
print v(xbgr.mr_n71205568)
print v(xbgr.mr_n71206512)
print v(xbgr.mr_n71206848)
print v(xbgr.mr_n71207520)
print v(xbgr.mr_n71208144)
print v(xbgr.mr_n71214160)
print v(xbgr.mr_n71214624)
print v(xbgr.mr_n71215088)
print v(xbgr.mr_n71215280)
print v(xbgr.mr_n71215744)
print v(xbgr.mr_n71216208)
print v(xbgr.mr_n71216672)
print v(xbgr.mr_n71216864)
print v(xbgr.mr_n71217328)
print v(xbgr.mr_n71217792)
print v(xbgr.mr_n71218256)
print v(xbgr.mr_n71218448)
print v(xbgr.mr_n71218640)
print v(xbgr.mr_n71220208)
print v(xbgr.mr_n71220400)
print v(xbgr.mr_n71221216)
print v(xbgr.mr_n71222032)
print v(xbgr.mr_n71222256)
print v(xbgr.mr_n71222432)
print v(xbgr.mr_n71222720)
print v(xbgr.mr_n71223328)
print v(xbgr.mr_n71223664)
print v(xbgr.mr_n71232048)
print v(xbgr.mr_n71232560)
print v(xbgr.mr_n71232672)
print v(xbgr.mr_n71233104)
print v(xbgr.mr_n71233616)
print v(xbgr.mr_n71233728)
print v(xbgr.mr_n71234160)
print v(xbgr.mr_n71234672)
print v(xbgr.mr_n71234784)
print v(xbgr.mr_n71235216)
print v(xbgr.mr_n71235728)
print v(xbgr.mr_n71235840)
print v(xbgr.mr_n71236272)
print v(xbgr.mr_n71236784)
print v(xbgr.mr_n71236896)
print v(xbgr.mr_n71237328)
print v(xbgr.mr_n71237840)
print v(xbgr.mr_n71237952)
print v(xbgr.mr_n71238384)
print v(xbgr.mr_n71238896)
print v(xbgr.mr_n71239008)
print v(xbgr.mr_n71239440)
print v(xbgr.mr_n71240080)
print v(xbgr.mr_n71240192)
print v(xbgr.mr_n71240624)
print v(xbgr.mr_n71241712)
print v(xbgr.mr_n71241824)
print v(xbgr.mr_n71242704)
print v(xbgr.mr_n71243392)
print v(xbgr.mr_n71244080)
print v(xbgr.mr_n71244768)
print v(xbgr.mr_n71245456)
print v(xbgr.mr_n71246144)
print v(xbgr.mr_n71246832)
print v(xbgr.mr_n71247520)
print v(xbgr.mr_n71248208)
print v(xbgr.mr_n71248896)
print v(xbgr.mr_n71249584)
print v(xbgr.mr_n71250272)
print v(xbgr.mr_n71250960)
print v(xbgr.mr_n71251648)
print v(xbgr.mr_n71252336)
print v(xbgr.mr_n71253024)
print v(xbgr.mr_n71253712)
print v(xbgr.mr_n71254752)
print v(xbgr.mr_n71255984)
print v(xbgr.mr_n71256928)
print v(xbgr.mr_n71257872)
print v(xbgr.mr_n71258816)
print v(xbgr.mr_n71259760)
print v(xbgr.mr_n71260704)
print v(xbgr.mr_n71261648)
print v(xbgr.mr_n71262592)
print v(xbgr.mr_n71263536)
print v(xbgr.mr_n71264480)
print v(xbgr.mr_n71265424)
print v(xbgr.mr_n71266368)
print v(xbgr.mr_n71267312)
print v(xbgr.mr_n71268256)
print v(xbgr.mr_n71269200)
print v(xbgr.mr_n71270144)
print v(xbgr.mr_n71271088)
print v(xbgr.mr_n71272032)
print v(xbgr.mr_n71272976)
print v(xbgr.mr_n71273920)
print v(xbgr.mr_n71274864)
print v(xbgr.mr_n71275808)
print v(xbgr.mr_n71276752)
print v(xbgr.mr_n71277696)
print v(xbgr.mr_n71278640)
print v(xbgr.mr_n71279584)
print v(xbgr.mr_n71280528)
print v(xbgr.mr_n71281472)
print v(xbgr.mr_n71286272)
print v(xbgr.mr_n71286528)
print v(xbgr.mr_n71286784)
print v(xbgr.mr_n71287040)
print v(xbgr.mr_n71287296)
print v(xbgr.mr_n71287552)
print v(xbgr.mr_n71290352)
print v(xbgr.mr_n71290800)
print v(xbgr.mr_n71290992)
print v(xbgr.mr_n71291184)
print v(xbgr.mr_n71291376)
print v(xbgr.mr_n71291568)
print v(xbgr.mr_n71291760)
print v(xbgr.mr_n71292016)
print v(xbgr.mr_n71293040)
print v(xbgr.mr_n71297024)
print v(xbgr.mr_n71308496)
print v(xbgr.mr_n71312176)
print v(xbgr.mr_n71313968)
print v(xbgr.mr_n71314160)
print v(xbgr.mr_n71331824)
print v(xbgr.mr_n71332784)
print v(xbgr.mr_n71334544)
print v(xbgr.mr_n71334880)
print v(xbgr.mr_n71335280)
print v(xbgr.mr_n71335392)
print v(xbgr.mr_n71335648)
print v(xbgr.mr_n71336032)
print v(xbgr.mr_n71338672)
print v(xbgr.mr_n71621376)
print v(xbgr.mr_n71621568)
print v(xbgr.mr_n71621760)
print v(xbgr.mr_n71622192)
print v(xbgr.mr_n71636000)
print v(xbgr.mr_n71679248)
print v(xbgr.mr_n71725760)
print v(xbgr.mr_n71741104)
print v(xbgr.mr_n71741904)
print v(xbgr.mr_n71768256)
print v(xbgr.mr_n71768832)
print v(xbgr.mr_n71769024)
print v(xbgr.mr_n71769600)
print v(xbgr.mr_n71769824)
print v(xbgr.mr_n71786112)
print v(xbgr.mr_n71855632)
print v(xbgr.mr_n71856592)
print v(xbgr.mr_n71887200)
print v(xbgr.mr_n71888592)
print v(xbgr.mr_n71889264)
print v(xbgr.mr_n71889456)
print v(xbgr.mr_n71889712)
print v(xbgr.mr_n71904784)
print v(xbgr.mr_n71905840)
print v(xbgr.mr_n71906032)
print v(xbgr.mr_n71936080)
print v(xbgr.mr_n71956656)
print v(xbgr.mr_n72018304)
print v(xbgr.mr_n72019088)
print v(xbgr.mr_n72084016)
print v(xbgr.mr_n72103920)
print v(xbgr.mr_n72117360)
print v(xbgr.mr_n72117552)
print v(xbgr.mr_n72117824)
print v(xbgr.mr_n72145104)
print v(xbgr.mr_n72168512)
print v(xbgr.mr_n72171600)
print v(xbgr.mr_n72179680)
print v(xbgr.mr_n72179792)
print v(xbgr.mr_n72223248)
print v(xbgr.mr_n72223584)
print v(xbgr.mr_n72223952)
print v(xbgr.mr_n72268768)
print v(xbgr.mr_n72269504)
print v(xbgr.mr_n72270336)
print v(xbgr.mr_n72291248)
print v(xbgr.mr_n72292208)
print v(xbgr.mr_n72298784)
print v(xbgr.mr_n72298976)
print v(xbgr.mr_n72299168)
print v(xbgr.mr_n72299360)
print v(xbgr.mr_n72335376)
print v(xbgr.mr_n72335568)
print v(xbgr.mr_n72339088)
print v(xbgr.mr_n72339280)
print v(xbgr.mr_n72348832)
print v(xbgr.mr_n72358880)
print v(xbgr.mr_n72359072)
print v(xbgr.mr_n72382000)
print v(xbgr.mr_n72382192)
print v(xbgr.mr_n72388448)
print v(xbgr.mr_n72390384)
print v(xbgr.mr_n72402784)
print v(xbgr.mr_n72404384)
print v(xbgr.mr_n72410640)
print v(xbgr.mr_n72440336)
print v(xbgr.mr_n72440608)
print v(xbgr.mr_n72441120)
print v(xbgr.n1)
print v(xbgr.n_10)
print v(xbgr.n_11)
print v(xbgr.n_12)
print v(xbgr.n_13)
print v(xbgr.n_14)
print v(xbgr.n_15)
print v(xbgr.n_16)
print v(xbgr.n_17)
print v(xbgr.n_18)
print v(xbgr.n_19)
print v(xbgr.n_2)
print v(xbgr.n_21)
print v(xbgr.n_22)
print v(xbgr.n_23)
print v(xbgr.n_24)
print v(xbgr.n_25)
print v(xbgr.n_26)
print v(xbgr.n_27)
print v(xbgr.n_3)
print v(xbgr.n_30)
print v(xbgr.n_31)
print v(xbgr.n_33)
print v(xbgr.n_34)
print v(xbgr.n_36)
print v(xbgr.n_37)
print v(xbgr.n_4)
print v(xbgr.n_5)
print v(xbgr.n_6)
print v(xbgr.n_7)
print v(xbgr.n_8)
print v(xbgr.n_9)
print v(pbias)
print v(pcasc)
print v(r4)
print v(xbgr.r4n)
print v(xbgr.vb2)
print v(vbe)
print v(xbgr.vbe3)
print v(xbgr.vd1)
print v(xbgr.vd2)
print v(vdd)
print v(vref)
print v(vdd)-v(vdd)
echo METALLIC_ALL_NODE_VOLTAGES_END
quit
.endc
.end
